$ Spice netlist generated by v2lvs
$ v2022.3_33.19    Tue Sep 6 12:09:54 PDT 2022
.INCLUDE "core.spi"
.INCLUDE "umc18_io_lvs.spi"
*.BUSDELIMITER [

.SUBCKT SNPS_CLOCK_GATE_HIGH_cordic_rotation_1_0 EN ENCLK CLK
*.CONNECT net2428 EN
XFE_PHC1336_net2431 DELC $PINS O=net2431 I=FE_PHN1336_net2431
Xlatch QDBHN $PINS Q=FE_PHN1336_net2431 D=net2428 CKB=CLK
Xmain_gate AN2T $PINS O=ENCLK I1=net2431 I2=CLK
.ENDS

.SUBCKT SNPS_CLOCK_GATE_HIGH_cordic_rotation_1_4 EN ENCLK CLK
*.CONNECT net2428 EN
XFE_PHC1353_net2431 DELC $PINS O=FE_PHN1353_net2431 I=net2431
Xlatch QDBHN $PINS Q=net2431 D=net2428 CKB=CLK
Xmain_gate AN2T $PINS O=ENCLK I1=FE_PHN1353_net2431 I2=CLK
.ENDS

.SUBCKT SNPS_CLOCK_GATE_HIGH_cordic_rotation_1_3 EN ENCLK CLK
*.CONNECT net2428 EN
XFE_PHC1352_net2431 DELC $PINS O=FE_PHN1352_net2431 I=net2431
Xlatch QDBHN $PINS Q=net2431 D=net2428 CKB=CLK
Xmain_gate AN2T $PINS O=ENCLK I1=FE_PHN1352_net2431 I2=CLK
.ENDS

.SUBCKT SNPS_CLOCK_GATE_HIGH_cordic_rotation_1_2 CLK EN ENCLK CLK_clone1
*.CONNECT net2425 CLK
*.CONNECT net2428 EN
XFE_PHC2089_net2431 BUF1CK $PINS O=FE_PHN2089_net2431 I=net2431
XFE_PHC1465_net2431 DELC $PINS O=FE_PHN1465_net2431 I=FE_PHN2089_net2431
Xlatch QDBHN $PINS Q=net2431 D=net2428 CKB=CLK_clone1
Xmain_gate AN2T $PINS O=ENCLK I1=FE_PHN1465_net2431 I2=net2425
.ENDS

.SUBCKT SNPS_CLOCK_GATE_HIGH_cordic_rotation_1_1 EN ENCLK CLK
*.CONNECT ENCLK net2427
*.CONNECT net2428 EN
XFE_PHC1309_net2431 DELC $PINS O=FE_PHN1309_net2431 I=net2431
Xlatch QDBHN $PINS Q=net2431 D=net2428 CKB=CLK
Xmain_gate AN2 $PINS O=net2427 I1=FE_PHN1309_net2431 I2=CLK
.ENDS

.SUBCKT cordic_rotation_1_DW01_add_2_DW01_add_8 A[15] A[14] A[13] A[12] A[11]
+ A[10] A[9] A[8] A[7] A[6] A[5] A[4] A[3] A[2] A[1] A[0] B[15] B[14] B[13]
+ B[12] B[11] B[10] B[9] B[8] B[7] B[6] B[5] B[4] B[3] B[2] B[1] B[0] CI
+ SUM[15] SUM[14] SUM[13] SUM[12] SUM[11] SUM[10] SUM[9] SUM[8] SUM[7] SUM[6]
+ SUM[5] SUM[4] SUM[3] SUM[2] SUM[1] SUM[0] CO
XU1_12 FA1S $PINS S=SUM[12] CO=carry[13] A=A[12] B=B[12] CI=carry[12]
XU1_11 FA1S $PINS S=SUM[11] CO=carry[12] A=A[11] B=B[11] CI=carry[11]
XU1_5 FA1S $PINS S=SUM[5] CO=carry[6] A=A[5] B=B[5] CI=carry[5]
XU1_7 FA1S $PINS S=SUM[7] CO=carry[8] A=A[7] B=B[7] CI=carry[7]
XU1_6 FA1S $PINS S=SUM[6] CO=carry[7] A=A[6] B=B[6] CI=carry[6]
XU1_8 FA1S $PINS S=SUM[8] CO=carry[9] A=A[8] B=B[8] CI=carry[8]
XU1_9 FA1S $PINS S=SUM[9] CO=carry[10] A=A[9] B=B[9] CI=carry[9]
XU1_10 FA1S $PINS S=SUM[10] CO=carry[11] A=A[10] B=B[10] CI=carry[10]
XU1_4 FA1S $PINS S=SUM[4] CO=carry[5] A=A[4] B=B[4] CI=carry[4]
XU1_2 FA1S $PINS S=SUM[2] CO=carry[3] A=A[2] B=B[2] CI=carry[2]
XU1_3 FA1S $PINS S=SUM[3] CO=carry[4] A=A[3] B=B[3] CI=carry[3]
XU1_1 FA1S $PINS S=SUM[1] CO=carry[2] A=A[1] B=B[1] CI=n1
XU1_13 FA1S $PINS S=SUM[13] CO=carry[14] A=A[13] B=B[13] CI=carry[13]
XU1 AN2 $PINS O=n1 I1=B[0] I2=A[0]
XU2 XNR2HS $PINS O=SUM[15] I1=A[15] I2=n2
XU3 XOR2HS $PINS O=SUM[14] I1=A[14] I2=carry[14]
XU4 XOR2HS $PINS O=SUM[0] I1=B[0] I2=A[0]
XU5 ND2 $PINS O=n2 I1=A[14] I2=carry[14]
.ENDS

.SUBCKT cordic_rotation_1_DW01_sub_0_DW01_sub_34 A[17] A[16] A[15] A[14] A[13]
+ A[12] A[11] A[10] A[9] A[8] A[7] A[6] A[5] A[4] A[3] A[2] A[1] A[0] B[17]
+ B[16] B[15] B[14] B[13] B[12] B[11] B[10] B[9] B[8] B[7] B[6] B[5] B[4] B[3]
+ B[2] B[1] B[0] CI DIFF[17] DIFF[16] DIFF[15] DIFF[14] DIFF[13] DIFF[12]
+ DIFF[11] DIFF[10] DIFF[9] DIFF[8] DIFF[7] DIFF[6] DIFF[5] DIFF[4] DIFF[3]
+ DIFF[2] DIFF[1] DIFF[0] CO
XU2_2 FA1 $PINS S=DIFF[2] CO=carry[3] A=A[2] B=n12 CI=carry[2]
XU2_3 FA1 $PINS S=DIFF[3] CO=carry[4] A=A[3] B=n13 CI=carry[3]
XU2_1 FA1S $PINS S=DIFF[1] CO=carry[2] A=A[1] B=n11 CI=carry[1]
XU2_6 FA1 $PINS S=DIFF[6] CO=carry[7] A=A[6] B=n16 CI=carry[6]
XU2_14 FA1S $PINS S=DIFF[14] CO=carry[15] A=A[14] B=n6 CI=carry[14]
XU2_15 FA1S $PINS S=DIFF[15] CO=carry[16] A=A[15] B=n7 CI=carry[15]
XU2_16 FA1S $PINS S=DIFF[16] CO=carry[17] A=A[16] B=n8 CI=carry[16]
XU2_9 FA1 $PINS S=DIFF[9] CO=carry[10] A=A[9] B=n10 CI=carry[9]
XU2_7 FA1S $PINS S=DIFF[7] CO=carry[8] A=A[7] B=n17 CI=carry[7]
XU2_8 FA1S $PINS S=DIFF[8] CO=carry[9] A=A[8] B=n18 CI=carry[8]
XU2_5 FA1 $PINS S=DIFF[5] CO=carry[6] A=A[5] B=n15 CI=carry[5]
XU2_4 FA1 $PINS S=DIFF[4] CO=carry[5] A=A[4] B=n14 CI=carry[4]
XU2_11 FA1 $PINS S=DIFF[11] CO=carry[12] A=A[11] B=n4 CI=carry[11]
XU2_12 FA1 $PINS S=DIFF[12] CO=carry[13] A=A[12] B=n9 CI=carry[12]
XU2_10 FA1 $PINS S=DIFF[10] CO=carry[11] A=A[10] B=n3 CI=carry[10]
XU2_13 FA1S $PINS S=DIFF[13] CO=carry[14] A=A[13] B=n5 CI=carry[13]
XU2_17 XOR3S $PINS O=DIFF[17] I1=A[17] I2=n8 I3=carry[17]
XU1 INV1S $PINS O=n2 I=B[0]
XU2 INV1S $PINS O=n8 I=B[17]
XU3 INV1S $PINS O=n5 I=B[13]
XU4 INV1S $PINS O=n3 I=B[10]
XU5 INV1S $PINS O=n9 I=B[12]
XU6 INV1S $PINS O=n4 I=B[11]
XU7 INV1S $PINS O=n14 I=B[4]
XU8 INV1S $PINS O=n15 I=B[5]
XU9 INV1S $PINS O=n18 I=B[8]
XU10 INV1S $PINS O=n17 I=B[7]
XU11 INV1S $PINS O=n10 I=B[9]
XU12 INV1S $PINS O=n7 I=B[15]
XU13 INV1S $PINS O=n6 I=B[14]
XU14 INV1S $PINS O=n16 I=B[6]
XU15 INV1S $PINS O=n11 I=B[1]
XU16 INV1S $PINS O=n1 I=A[0]
XU17 INV1S $PINS O=n13 I=B[3]
XU18 INV1S $PINS O=n12 I=B[2]
XU19 XNR2HS $PINS O=DIFF[0] I1=n2 I2=A[0]
XU20 ND2 $PINS O=carry[1] I1=B[0] I2=n1
.ENDS

.SUBCKT cordic_rotation_1_DW01_add_3_DW01_add_9 A[17] A[16] A[15] A[14] A[13]
+ A[12] A[11] A[10] A[9] A[8] A[7] A[6] A[5] A[4] A[3] A[2] A[1] A[0] B[17]
+ B[16] B[15] B[14] B[13] B[12] B[11] B[10] B[9] B[8] B[7] B[6] B[5] B[4] B[3]
+ B[2] B[1] B[0] CI SUM[17] SUM[16] SUM[15] SUM[14] SUM[13] SUM[12] SUM[11]
+ SUM[10] SUM[9] SUM[8] SUM[7] SUM[6] SUM[5] SUM[4] SUM[3] SUM[2] SUM[1] SUM[0]
+ CO
XU1_14 FA1S $PINS S=SUM[14] CO=carry[15] A=A[14] B=B[14] CI=carry[14]
XU1_1 FA1 $PINS S=SUM[1] CO=carry[2] A=A[1] B=B[1] CI=n1
XU1_9 FA1 $PINS S=SUM[9] CO=carry[10] A=A[9] B=B[9] CI=carry[9]
XU1_6 FA1 $PINS S=SUM[6] CO=carry[7] A=A[6] B=B[6] CI=carry[6]
XU1_5 FA1 $PINS S=SUM[5] CO=carry[6] A=A[5] B=B[5] CI=carry[5]
XU1_4 FA1S $PINS S=SUM[4] CO=carry[5] A=A[4] B=B[4] CI=carry[4]
XU1_3 FA1 $PINS S=SUM[3] CO=carry[4] A=A[3] B=B[3] CI=carry[3]
XU1_7 FA1 $PINS S=SUM[7] CO=carry[8] A=A[7] B=B[7] CI=carry[7]
XU1_8 FA1 $PINS S=SUM[8] CO=carry[9] A=A[8] B=B[8] CI=carry[8]
XU1_2 FA1 $PINS S=SUM[2] CO=carry[3] A=A[2] B=B[2] CI=carry[2]
XU1_11 FA1S $PINS S=SUM[11] CO=carry[12] A=A[11] B=B[11] CI=carry[11]
XU1_12 FA1 $PINS S=SUM[12] CO=carry[13] A=A[12] B=B[12] CI=carry[12]
XU1_10 FA1 $PINS S=SUM[10] CO=carry[11] A=A[10] B=B[10] CI=carry[10]
XU1_13 FA1S $PINS S=SUM[13] CO=carry[14] A=A[13] B=B[13] CI=carry[13]
XU1_15 FA1S $PINS S=SUM[15] CO=carry[16] A=A[15] B=B[15] CI=carry[15]
XU1_16 FA1S $PINS S=SUM[16] CO=carry[17] A=A[16] B=B[16] CI=carry[16]
XU1_17 XOR3S $PINS O=SUM[17] I1=A[17] I2=B[17] I3=carry[17]
XU1 AN2 $PINS O=n1 I1=B[0] I2=A[0]
XU2 XOR2HS $PINS O=SUM[0] I1=B[0] I2=A[0]
.ENDS

.SUBCKT cordic_rotation_1_DW01_sub_1_DW01_sub_35 A[15] A[14] A[13] A[12] A[11]
+ A[10] A[9] A[8] A[7] A[6] A[5] A[4] A[3] A[2] A[1] A[0] B[15] B[14] B[13]
+ B[12] B[11] B[10] B[9] B[8] B[7] B[6] B[5] B[4] B[3] B[2] B[1] B[0] CI
+ DIFF[15] DIFF[14] DIFF[13] DIFF[12] DIFF[11] DIFF[10] DIFF[9] DIFF[8] DIFF[7]
+ DIFF[6] DIFF[5] DIFF[4] DIFF[3] DIFF[2] DIFF[1] DIFF[0] CO n72 n261
XU2_9 FA1S $PINS S=DIFF[9] CO=carry[10] A=A[9] B=n11 CI=carry[9]
XU2_12 FA1S $PINS S=DIFF[12] CO=carry[13] A=A[12] B=n72 CI=carry[12]
XU2_8 FA1S $PINS S=DIFF[8] CO=carry[9] A=A[8] B=n14 CI=carry[8]
XU2_11 FA1S $PINS S=DIFF[11] CO=carry[12] A=A[11] B=n2 CI=carry[11]
XU2_7 FA1S $PINS S=DIFF[7] CO=carry[8] A=A[7] B=n8 CI=carry[7]
XU2_10 FA1S $PINS S=DIFF[10] CO=carry[11] A=A[10] B=n261 CI=carry[10]
XU2_6 FA1S $PINS S=DIFF[6] CO=carry[7] A=A[6] B=n15 CI=carry[6]
XU2_5 FA1S $PINS S=DIFF[5] CO=carry[6] A=A[5] B=n9 CI=carry[5]
XU2_4 FA1S $PINS S=DIFF[4] CO=carry[5] A=A[4] B=n6 CI=carry[4]
XU2_3 FA1S $PINS S=DIFF[3] CO=carry[4] A=A[3] B=n12 CI=carry[3]
XU2_2 FA1S $PINS S=DIFF[2] CO=carry[3] A=A[2] B=n5 CI=carry[2]
XU2_1 FA1S $PINS S=DIFF[1] CO=carry[2] A=A[1] B=n7 CI=carry[1]
XU2_13 FA1S $PINS S=DIFF[13] CO=carry[14] A=A[13] B=B[13] CI=carry[13]
XU1 OR2 $PINS O=carry[15] I1=carry[14] I2=A[14]
XU2 INV1S $PINS O=n10 I=B[0]
XU4 XNR2HS $PINS O=DIFF[15] I1=A[15] I2=carry[15]
XU5 INV1S $PINS O=n7 I=B[1]
XU6 INV1S $PINS O=n1 I=A[0]
XU7 INV1S $PINS O=n5 I=B[2]
XU8 INV1S $PINS O=n12 I=B[3]
XU9 INV1S $PINS O=n6 I=B[4]
XU10 INV1S $PINS O=n9 I=B[5]
XU11 INV1S $PINS O=n15 I=B[6]
XU13 INV1S $PINS O=n8 I=B[7]
XU14 INV1S $PINS O=n2 I=B[11]
XU15 INV1S $PINS O=n14 I=B[8]
XU17 INV1S $PINS O=n11 I=B[9]
XU18 XNR2HS $PINS O=DIFF[14] I1=A[14] I2=carry[14]
XU19 XNR2HS $PINS O=DIFF[0] I1=n10 I2=A[0]
XU20 ND2 $PINS O=carry[1] I1=B[0] I2=n1
.ENDS

.SUBCKT cordic_rotation_1_DW01_add_4_DW01_add_10 A[17] A[16] A[15] A[14] A[13]
+ A[12] A[11] A[10] A[9] A[8] A[7] A[6] A[5] A[4] A[3] A[2] A[1] A[0] B[17]
+ B[16] B[15] B[14] B[13] B[12] B[11] B[10] B[9] B[8] B[7] B[6] B[5] B[4] B[3]
+ B[2] B[1] B[0] CI SUM[17] SUM[16] SUM[15] SUM[14] SUM[13] SUM[12] SUM[11]
+ SUM[10] SUM[9] SUM[8] SUM[7] SUM[6] SUM[5] SUM[4] SUM[3] SUM[2] SUM[1] SUM[0]
+ CO
XFE_PHC2239_y_reg_10 BUF1CK $PINS O=FE_PHN2239_y_reg_10 I=A[10]
XFE_PHC1997_N290 BUF1S $PINS O=SUM[2] I=FE_PHN1997_N290
XU1_14 FA1S $PINS S=SUM[14] CO=carry[15] A=A[14] B=B[14] CI=carry[14]
XU1_1 FA1 $PINS S=SUM[1] CO=carry[2] A=A[1] B=B[1] CI=n1
XU1_9 FA1S $PINS S=SUM[9] CO=carry[10] A=A[9] B=B[9] CI=carry[9]
XU1_6 FA1 $PINS S=SUM[6] CO=carry[7] A=A[6] B=B[6] CI=carry[6]
XU1_5 FA1 $PINS S=SUM[5] CO=carry[6] A=A[5] B=B[5] CI=carry[5]
XU1_4 FA1 $PINS S=SUM[4] CO=carry[5] A=A[4] B=B[4] CI=carry[4]
XU1_3 FA1 $PINS S=SUM[3] CO=carry[4] A=A[3] B=B[3] CI=carry[3]
XU1_7 FA1 $PINS S=SUM[7] CO=carry[8] A=A[7] B=B[7] CI=carry[7]
XU1_8 FA1 $PINS S=SUM[8] CO=carry[9] A=A[8] B=B[8] CI=carry[8]
XU1_2 FA1 $PINS S=FE_PHN1997_N290 CO=carry[3] A=A[2] B=B[2] CI=carry[2]
XU1_11 FA1 $PINS S=SUM[11] CO=carry[12] A=A[11] B=B[11] CI=carry[11]
XU1_12 FA1S $PINS S=SUM[12] CO=carry[13] A=A[12] B=B[12] CI=carry[12]
XU1_10 FA1 $PINS S=SUM[10] CO=carry[11] A=FE_PHN2239_y_reg_10 B=B[10]
+ CI=carry[10]
XU1_13 FA1S $PINS S=SUM[13] CO=carry[14] A=A[13] B=B[13] CI=carry[13]
XU1_15 FA1S $PINS S=SUM[15] CO=carry[16] A=A[15] B=B[15] CI=carry[15]
XU1_16 FA1S $PINS S=SUM[16] CO=carry[17] A=A[16] B=B[16] CI=carry[16]
XU1_17 XOR3S $PINS O=SUM[17] I1=A[17] I2=B[17] I3=carry[17]
XU1 AN2 $PINS O=n1 I1=B[0] I2=A[0]
XU2 XOR2HS $PINS O=SUM[0] I1=B[0] I2=A[0]
.ENDS

.SUBCKT cordic_rotation_1_DW01_sub_2_DW01_sub_36 A[17] A[16] A[15] A[14] A[13]
+ A[12] A[11] A[10] A[9] A[8] A[7] A[6] A[5] A[4] A[3] A[2] A[1] A[0] B[17]
+ B[16] B[15] B[14] B[13] B[12] B[11] B[10] B[9] B[8] B[7] B[6] B[5] B[4] B[3]
+ B[2] B[1] B[0] CI DIFF[17] DIFF[16] DIFF[15] DIFF[14] DIFF[13] DIFF[12]
+ DIFF[11] DIFF[10] DIFF[9] DIFF[8] DIFF[7] DIFF[6] DIFF[5] DIFF[4] DIFF[3]
+ DIFF[2] DIFF[1] DIFF[0] CO
XFE_PHC2174_x_reg_8 BUF1CK $PINS O=FE_PHN2174_x_reg_8 I=A[8]
XU2_2 FA1S $PINS S=DIFF[2] CO=carry[3] A=A[2] B=n12 CI=carry[2]
XU2_3 FA1 $PINS S=DIFF[3] CO=carry[4] A=A[3] B=n13 CI=carry[3]
XU2_1 FA1S $PINS S=DIFF[1] CO=carry[2] A=A[1] B=n11 CI=carry[1]
XU2_14 FA1 $PINS S=DIFF[14] CO=carry[15] A=A[14] B=n4 CI=carry[14]
XU2_6 FA1 $PINS S=DIFF[6] CO=carry[7] A=A[6] B=n16 CI=carry[6]
XU2_15 FA1S $PINS S=DIFF[15] CO=carry[16] A=A[15] B=n3 CI=carry[15]
XU2_16 FA1S $PINS S=DIFF[16] CO=carry[17] A=A[16] B=n2 CI=carry[16]
XU2_9 FA1S $PINS S=DIFF[9] CO=carry[10] A=A[9] B=n9 CI=carry[9]
XU2_7 FA1 $PINS S=DIFF[7] CO=carry[8] A=A[7] B=n17 CI=carry[7]
XU2_8 FA1 $PINS S=DIFF[8] CO=carry[9] A=FE_PHN2174_x_reg_8 B=n18 CI=carry[8]
XU2_5 FA1 $PINS S=DIFF[5] CO=carry[6] A=A[5] B=n15 CI=carry[5]
XU2_4 FA1S $PINS S=DIFF[4] CO=carry[5] A=A[4] B=n14 CI=carry[4]
XU2_11 FA1S $PINS S=DIFF[11] CO=carry[12] A=A[11] B=n7 CI=carry[11]
XU2_12 FA1 $PINS S=DIFF[12] CO=carry[13] A=A[12] B=n6 CI=carry[12]
XU2_10 FA1 $PINS S=DIFF[10] CO=carry[11] A=A[10] B=n8 CI=carry[10]
XU2_13 FA1 $PINS S=DIFF[13] CO=carry[14] A=A[13] B=n5 CI=carry[13]
XU2_17 XOR3S $PINS O=DIFF[17] I1=A[17] I2=n2 I3=carry[17]
XU1 INV1S $PINS O=n10 I=B[0]
XU2 INV1S $PINS O=n2 I=B[17]
XU3 INV1S $PINS O=n5 I=B[13]
XU4 INV1S $PINS O=n8 I=B[10]
XU5 INV1S $PINS O=n6 I=B[12]
XU6 INV1S $PINS O=n7 I=B[11]
XU7 INV1S $PINS O=n14 I=B[4]
XU8 INV1S $PINS O=n15 I=B[5]
XU9 INV1S $PINS O=n18 I=B[8]
XU10 INV1S $PINS O=n17 I=B[7]
XU11 INV1S $PINS O=n9 I=B[9]
XU12 INV1S $PINS O=n3 I=B[15]
XU13 INV1S $PINS O=n16 I=B[6]
XU14 INV1S $PINS O=n4 I=B[14]
XU15 INV1S $PINS O=n11 I=B[1]
XU16 INV1S $PINS O=n1 I=A[0]
XU17 INV1S $PINS O=n13 I=B[3]
XU18 INV1S $PINS O=n12 I=B[2]
XU19 XNR2HS $PINS O=DIFF[0] I1=n10 I2=A[0]
XU20 ND2 $PINS O=carry[1] I1=B[0] I2=n1
.ENDS

.SUBCKT cordic_rotation_1 rst_n valid_in valid_out x_in[16] x_in[15] x_in[14]
+ x_in[13] x_in[12] x_in[11] x_in[10] x_in[9] x_in[8] x_in[7] x_in[6] x_in[5]
+ x_in[4] x_in[3] x_in[2] x_in[1] x_in[0] y_in[16] y_in[15] y_in[14] y_in[13]
+ y_in[12] y_in[11] y_in[10] y_in[9] y_in[8] y_in[7] y_in[6] y_in[5] y_in[4]
+ y_in[3] y_in[2] y_in[1] y_in[0] phase_in[15] phase_in[14] phase_in[13]
+ phase_in[12] phase_in[11] phase_in[10] phase_in[9] phase_in[8] phase_in[7]
+ phase_in[6] phase_in[5] phase_in[4] phase_in[3] phase_in[2] phase_in[1]
+ phase_in[0] x_out[16] x_out[15] x_out[14] x_out[13] x_out[12] x_out[11]
+ x_out[10] x_out[9] x_out[8] x_out[7] x_out[6] x_out[5] x_out[4] x_out[3]
+ x_out[2] x_out[1] x_out[0] y_out[16] y_out[15] y_out[14] y_out[13] y_out[12]
+ y_out[11] y_out[10] y_out[9] y_out[8] y_out[7] y_out[6] y_out[5] y_out[4]
+ y_out[3] y_out[2] y_out[1] y_out[0] i_rst_n p1 FE_OFN50_i_rst_n
+ FE_OFN28_i_rst_n FE_OFN25_i_rst_n FE_OFN19_i_rst_n FE_OFN18_i_rst_n
+ FE_OFN12_i_rst_n FE_OFN5_i_rst_n FE_OFN4_i_rst_n FE_OFN3_i_rst_n clk_clone3
+ clk_clone2 clk clk_clone4 clk_clone1
*.CONNECT N130 x_in[0]
*.CONNECT N148 y_in[0]
*.CONNECT N177 phase_in[9]
*.CONNECT N178 phase_in[10]
*.CONNECT N179 phase_in[11]
*.CONNECT N180 phase_in[12]
*.CONNECT N181 phase_in[13]
*.CONNECT N182 phase_in[14]
XFE_PHC2219_c_in_r_0_0 BUF1CK $PINS O=FE_PHN2219_c_in_r_0_0
+ I=FE_PHN2088_c_in_r_0_0
XFE_PHC2216_n276 BUF1CK $PINS O=FE_PHN2216_n276 I=n276
XFE_PHC2215_n274 BUF1CK $PINS O=FE_PHN2215_n274 I=n274
XFE_PHC2214_N502 BUF1CK $PINS O=FE_PHN2214_N502 I=N502
XFE_PHC2213_n278 BUF1CK $PINS O=FE_PHN2213_n278 I=n278
XFE_PHC2212_n270 BUF1CK $PINS O=FE_PHN2212_n270 I=n270
XFE_PHC2211_n290 BUF1CK $PINS O=FE_PHN2211_n290 I=n290
XFE_PHC2208_n321 BUF1CK $PINS O=n321 I=FE_PHN2208_n321
XFE_PHC2195_y_reg_4 BUF1CK $PINS O=y_reg[4] I=FE_PHN2195_y_reg_4
XFE_PHC2192_x_reg_10 BUF1CK $PINS O=FE_PHN2192_x_reg_10 I=x_reg[10]
XFE_PHC2178_x_reg_6 BUF1CK $PINS O=FE_PHN2178_x_reg_6 I=x_reg[6]
XFE_PHC2158_c_in_r_0_16 BUF4CK $PINS O=FE_PHN2158_c_in_r_0_16 I=x_in[16]
XFE_PHC2088_c_in_r_0_0 BUF1S $PINS O=FE_PHN2088_c_in_r_0_0 I=x_in[0]
XFE_PHC2087_n380 BUF1CK $PINS O=n380 I=FE_PHN2087_n380
XFE_PHC2081_c_in_r_0_14 BUF1CK $PINS O=FE_PHN2081_c_in_r_0_14 I=x_in[14]
XFE_PHC2080_y_reg_17 BUF1CK $PINS O=FE_PHN2080_y_reg_17 I=y_reg[17]
XFE_PHC2075_N493 BUF1S $PINS O=FE_PHN2075_N493 I=N493
XFE_PHC2074_N501 BUF1S $PINS O=N501 I=FE_PHN2074_N501
XFE_PHC2073_N507 BUF1S $PINS O=N507 I=FE_PHN2073_N507
XFE_PHC2072_n288 BUF1S $PINS O=FE_PHN2072_n288 I=n288
XFE_PHC2071_N513 DELA $PINS O=FE_PHN2071_N513 I=N513
XFE_PHC2070_N514 DELA $PINS O=FE_PHN2070_N514 I=N514
XFE_PHC2069_N503 DELA $PINS O=FE_PHN2069_N503 I=N503
XFE_PHC2068_N505 DELA $PINS O=N505 I=FE_PHN2068_N505
XFE_PHC2067_N510 DELA $PINS O=FE_PHN2067_N510 I=N510
XFE_PHC2065_N506 DELA $PINS O=FE_PHN2065_N506 I=N506
XFE_PHC2062_N504 DELA $PINS O=FE_PHN2062_N504 I=N504
XFE_PHC2061_N480 DELB $PINS O=FE_PHN2061_N480 I=N480
XFE_PHC2060_N492 DELB $PINS O=FE_PHN2060_N492 I=N492
XFE_PHC2059_N494 DELB $PINS O=FE_PHN2059_N494 I=N494
XFE_PHC2058_N481 DELB $PINS O=FE_PHN2058_N481 I=N481
XFE_PHC2057_N490 DELB $PINS O=FE_PHN2057_N490 I=N490
XFE_PHC2056_N488 DELB $PINS O=FE_PHN2056_N488 I=N488
XFE_PHC2051_N459 DELC $PINS O=N459 I=FE_PHN2051_N459
XFE_PHC2050_N460 DELC $PINS O=FE_PHN2050_N460 I=N460
XFE_PHC2049_N461 DELC $PINS O=FE_PHN2049_N461 I=N461
XFE_PHC2020_n327 BUF1CK $PINS O=FE_PHN2020_n327 I=n327
XFE_PHC2014_N498 DELA $PINS O=FE_PHN2014_N498 I=N498
XFE_PHC2007_n293 BUF1CK $PINS O=n293 I=FE_PHN2007_n293
XFE_PHC2004_n332 DELB $PINS O=FE_PHN2004_n332 I=n332
XFE_PHC2000_n330 DELB $PINS O=FE_PHN2000_n330 I=n330
XFE_PHC1989_n346 DELB $PINS O=FE_PHN1989_n346 I=n346
XFE_PHC1988_n378 DELB $PINS O=n378 I=FE_PHN1988_n378
XFE_PHC1986_n381 DELB $PINS O=FE_PHN1986_n381 I=n381
XFE_PHC1979_n349 DELB $PINS O=FE_PHN1979_n349 I=n349
XFE_PHC1978_N482 DELB $PINS O=FE_PHN1978_N482 I=N482
XFE_PHC1977_n382 DELB $PINS O=n382 I=FE_PHN1977_n382
XFE_PHC1976_n379 DELB $PINS O=n379 I=FE_PHN1976_n379
XFE_PHC1974_n352 DELB $PINS O=n352 I=FE_PHN1974_n352
XFE_PHC1967_N450 DELB $PINS O=FE_PHN1967_N450 I=N450
XFE_PHC1965_N451 BUF1S $PINS O=FE_PHN1965_N451 I=N451
XFE_PHC1964_N449 DELB $PINS O=FE_PHN1964_N449 I=N449
XFE_PHC1956_N448 DELB $PINS O=FE_PHN1956_N448 I=N448
XFE_PHC1949_N447 DELB $PINS O=FE_PHN1949_N447 I=N447
XFE_PHC1943_N442 DELB $PINS O=FE_PHN1943_N442 I=N442
XFE_PHC1935_n343 DELB $PINS O=FE_PHN1935_n343 I=n343
XFE_PHC1932_N441 DELB $PINS O=FE_PHN1932_N441 I=N441
XFE_PHC1929_N446 DELB $PINS O=FE_PHN1929_N446 I=N446
XFE_PHC1926_N445 DELB $PINS O=FE_PHN1926_N445 I=N445
XFE_PHC1922_n338 DELB $PINS O=n338 I=FE_PHN1922_n338
XFE_PHC1916_N443 DELB $PINS O=FE_PHN1916_N443 I=N443
XFE_PHC1909_N444 DELB $PINS O=FE_PHN1909_N444 I=N444
XFE_PHC1898_N437 DELC $PINS O=N437 I=FE_PHN1898_N437
XFE_PHC1892_N436 DELB $PINS O=FE_PHN1892_N436 I=N436
XFE_PHC1885_N435 DELC $PINS O=FE_PHN1885_N435 I=N435
XFE_PHC1876_N434 DELC $PINS O=N434 I=FE_PHN1876_N434
XFE_PHC1873_N432 DELC $PINS O=FE_PHN1873_N432 I=N432
XFE_PHC1864_N433 DELC $PINS O=FE_PHN1864_N433 I=N433
XFE_PHC1832_N457 DELC $PINS O=N457 I=FE_PHN1832_N457
XFE_PHC1822_n368 DELC $PINS O=n368 I=FE_PHN1822_n368
XFE_PHC1789_y_reg_15 BUF1S $PINS O=y_reg[15] I=FE_PHN1789_y_reg_15
XFE_PHC1788_y_reg_14 BUF1S $PINS O=y_reg[14] I=FE_PHN1788_y_reg_14
XFE_PHC1778_x_reg_10 DELC $PINS O=FE_PHN1778_x_reg_10 I=FE_PHN2192_x_reg_10
XFE_PHC1775_x_reg_16 DELC $PINS O=FE_PHN1775_x_reg_16 I=x_reg[16]
XFE_PHC1774_x_reg_9 DELC $PINS O=FE_PHN1774_x_reg_9 I=x_reg[9]
XFE_PHC1771_y_reg_6 DELB $PINS O=FE_PHN1771_y_reg_6 I=y_reg[6]
XFE_PHC1770_y_reg_5 DELB $PINS O=FE_PHN1770_y_reg_5 I=y_reg[5]
XFE_PHC1769_x_reg_0 DELB $PINS O=FE_PHN1769_x_reg_0 I=x_reg[0]
XFE_PHC1764_x_reg_17 DELB $PINS O=x_reg[17] I=FE_PHN1764_x_reg_17
XFE_PHC1752_y_reg_0 DELB $PINS O=y_reg[0] I=FE_PHN1752_y_reg_0
XFE_PHC1747_x_reg_4 DELC $PINS O=x_reg[4] I=FE_PHN1747_x_reg_4
XFE_PHC1744_c_in_i_0_0 BUF1S $PINS O=FE_PHN1744_c_in_i_0_0 I=y_in[0]
XFE_PHC1738_is_computing DELC $PINS O=is_computing I=FE_PHN1738_is_computing
XFE_PHC1732_z_reg_3 BUF1S $PINS O=z_reg[3] I=FE_PHN1732_z_reg_3
XFE_PHC1731_y_reg_12 BUF1S $PINS O=FE_PHN1731_y_reg_12 I=y_reg[12]
XFE_PHC1729_z_reg_0 DELC $PINS O=FE_PHN1729_z_reg_0 I=z_reg[0]
XFE_PHC1723_y_reg_2 BUF1S $PINS O=FE_PHN1723_y_reg_2 I=y_reg[2]
XFE_PHC1717_c_in_i_0_14 DELB $PINS O=FE_PHN1717_c_in_i_0_14 I=y_in[14]
XFE_PHC1714_c_in_i_0_12 DELA $PINS O=FE_PHN1714_c_in_i_0_12 I=y_in[12]
XFE_PHC1708_c_in_i_0_11 DELA $PINS O=FE_PHN1708_c_in_i_0_11 I=y_in[11]
XFE_PHC1704_c_in_r_0_16 BUF1CK $PINS O=FE_PHN1704_c_in_r_0_16
+ I=FE_PHN2158_c_in_r_0_16
XFE_PHC1659_y_reg_4 DELB $PINS O=FE_PHN1659_y_reg_4 I=y_reg[4]
XFE_PHC1614_cor_x_out_0_14 BUF1CK $PINS O=x_out[14] I=FE_PHN1614_cor_x_out_0_14
XFE_PHC1603_cor_x_out_0_16 BUF1S $PINS O=x_out[16] I=FE_PHN1603_cor_x_out_0_16
XFE_PHC1601_cor_y_out_0_0 BUF1S $PINS O=y_out[0] I=FE_PHN1601_cor_y_out_0_0
XFE_PHC1600_x_reg_7 DELC $PINS O=FE_PHN1600_x_reg_7 I=x_reg[7]
XFE_PHC1594_z_reg_7 DELB $PINS O=FE_PHN1594_z_reg_7 I=z_reg[7]
XFE_PHC1593_cor_y_out_0_7 BUF1S $PINS O=y_out[7] I=FE_PHN1593_cor_y_out_0_7
XFE_PHC1590_x_reg_8 DELC $PINS O=FE_PHN1590_x_reg_8 I=x_reg[8]
XFE_PHC1586_z_reg_6 DELB $PINS O=z_reg[6] I=FE_PHN1586_z_reg_6
XFE_PHC1578_x_reg_6 DELB $PINS O=FE_PHN1578_x_reg_6 I=FE_PHN2178_x_reg_6
XFE_PHC1576_cor_y_out_0_10 BUF1S $PINS O=y_out[10] I=FE_PHN1576_cor_y_out_0_10
XFE_PHC1551_x_reg_5 DELC $PINS O=FE_PHN1551_x_reg_5 I=x_reg[5]
XFE_PHC1536_cor_y_out_0_14 DELA $PINS O=y_out[14] I=FE_PHN1536_cor_y_out_0_14
XFE_PHC1531_cor_x_out_0_15 DELA $PINS O=x_out[15] I=FE_PHN1531_cor_x_out_0_15
XFE_PHC1524_cor_y_out_0_3 DELA $PINS O=y_out[3] I=FE_PHN1524_cor_y_out_0_3
XFE_PHC1520_z_reg_10 DELB $PINS O=z_reg[10] I=FE_PHN1520_z_reg_10
XFE_PHC1517_z_reg_9 DELB $PINS O=z_reg[9] I=FE_PHN1517_z_reg_9
XFE_PHC1508_z_reg_8 DELB $PINS O=FE_PHN1508_z_reg_8 I=z_reg[8]
XFE_PHC1419_cor_x_out_0_13 BUF1S $PINS O=x_out[13] I=FE_PHN1419_cor_x_out_0_13
XFE_RC_226_0 AOI22S $PINS O=n263 A1=N305 A2=FE_OFN42_n1 B1=N357
+ B2=FE_OFN44_n259
XCTS_ccl_a_INV_CLK_G1_L12_17 INV3CK $PINS O=CTS_46 I=CTS_47
XCTS_ccl_a_INV_CLK_G1_L11_17 INV2CK $PINS O=CTS_47 I=CTS_48
XCTS_ccl_a_INV_CLK_G1_L10_6 INV6CK $PINS O=CTS_43 I=CTS_44
XCTS_ccl_a_INV_CLK_G1_L9_6 INV2CK $PINS O=CTS_44 I=CTS_45
XCTS_ccl_a_INV_CLK_G1_L10_5 INV6CK $PINS O=CTS_40 I=CTS_41
XCTS_ccl_a_INV_CLK_G1_L9_5 INV6CK $PINS O=CTS_41 I=CTS_42
XCTS_ccl_a_INV_CLK_G1_L10_4 INV3CK $PINS O=CTS_37 I=CTS_38
XCTS_ccl_a_INV_CLK_G1_L9_4 INV2CK $PINS O=CTS_38 I=CTS_39
XFE_RC_4024_0 ND3 $PINS O=n104 I1=n254 I2=step_cnt[3] I3=step_cnt[1]
XFE_RC_3866_0 ND3 $PINS O=n251 I1=n255 I2=n369 I3=step_cnt[2]
XFE_OFC575_n103 BUF1 $PINS O=FE_OFN351_n103 I=n103
XFE_OFC574_n103 BUF1 $PINS O=FE_OFN350_n103 I=n103
XFE_OFC573_n102 BUF1 $PINS O=FE_OFN349_n102 I=n102
XFE_OFC564_x_reg_4 INV1S $PINS O=FE_OFN344_x_reg_4 I=x_reg[4]
XFE_OFC513_y_reg_6 INV1S $PINS O=n111 I=FE_PHN1771_y_reg_6
XFE_OFC447_n261 INV1S $PINS O=FE_OFN300_n261 I=N108
XFE_OFC444_n261 INV1S $PINS O=N108 I=n261
XFE_OFC426_y_reg_7 INV1S $PINS O=n100 I=y_reg[7]
XFE_OFC423_x_reg_8 INV1S $PINS O=n187 I=x_reg[8]
XFE_OFC418_x_reg_6 INV1S $PINS O=n202 I=FE_PHN2178_x_reg_6
XFE_OFC407_y_reg_9 INV1S $PINS O=n88 I=y_reg[9]
XFE_OFC393_n158 INV1S $PINS O=FE_OFN286_n158 I=n79
XFE_OFC392_n158 INV2 $PINS O=n79 I=n158
XFE_OFC386_x_reg_12 INV1S $PINS O=n188 I=x_reg[12]
XFE_OFC384_n5 INV2 $PINS O=FE_OFN282_n5 I=n141
XFE_OFC383_n5 INV1S $PINS O=n141 I=n5
XFE_OFC382_x_reg_7 INV1S $PINS O=n195 I=x_reg[7]
XFE_OFC365_y_reg_12 INV1S $PINS O=n90 I=y_reg[12]
XFE_OFC347_n82 INV2 $PINS O=n91 I=n82
XFE_OFC346_x_reg_11 INV1S $PINS O=n196 I=x_reg[11]
XFE_OFC341_x_reg_9 INV1S $PINS O=n186 I=FE_PHN1774_x_reg_9
XFE_OFC340_y_reg_10 INV1S $PINS O=n73 I=y_reg[10]
XFE_OFC339_y_reg_11 INV1S $PINS O=n101 I=y_reg[11]
XFE_OFC333_x_reg_10 INV1S $PINS O=n176 I=FE_PHN1778_x_reg_10
XFE_OFC310_n2 INV2 $PINS O=FE_DBTN15_n2 I=n2
XFE_OFC265_n72 BUF2 $PINS O=FE_OFN43_n72 I=n72
XFE_OFC264_n72 INV2 $PINS O=n9 I=n72
XFE_OFC46_n265 BUF1 $PINS O=FE_OFN46_n265 I=n265
XFE_OFC45_n264 BUF1 $PINS O=FE_OFN45_n264 I=n264
XFE_OFC44_n259 BUF1 $PINS O=FE_OFN44_n259 I=n259
XFE_OFC42_n1 BUF1 $PINS O=FE_OFN42_n1 I=n1
XFE_OFC41_n1 BUF1 $PINS O=FE_OFN41_n1 I=n1
Xx_out_reg[5] QDFFRBN $PINS Q=x_out[5] D=N431 CK=CTS_46 RB=FE_OFN25_i_rst_n
Xx_out_reg[6] QDFFRBN $PINS Q=x_out[6] D=FE_PHN1873_N432 CK=CTS_46
+ RB=FE_OFN25_i_rst_n
Xx_out_reg[7] QDFFRBN $PINS Q=x_out[7] D=FE_PHN1864_N433 CK=CTS_46
+ RB=FE_OFN25_i_rst_n
Xx_out_reg[8] QDFFRBN $PINS Q=x_out[8] D=N434 CK=CTS_46 RB=FE_OFN25_i_rst_n
Xx_out_reg[9] QDFFRBN $PINS Q=x_out[9] D=FE_PHN1885_N435 CK=CTS_46
+ RB=FE_OFN4_i_rst_n
Xx_out_reg[0] QDFFRBN $PINS Q=x_out[0] D=N426 CK=CTS_46 RB=FE_OFN25_i_rst_n
Xx_out_reg[10] QDFFRBN $PINS Q=x_out[10] D=FE_PHN1892_N436 CK=CTS_46
+ RB=FE_OFN4_i_rst_n
Xx_out_reg[11] QDFFRBN $PINS Q=x_out[11] D=N437 CK=CTS_46 RB=FE_OFN4_i_rst_n
Xx_out_reg[12] QDFFRBN $PINS Q=x_out[12] D=N438 CK=CTS_46 RB=FE_OFN25_i_rst_n
Xx_out_reg[13] QDFFRBN $PINS Q=FE_PHN1419_cor_x_out_0_13 D=N438 CK=CTS_46
+ RB=FE_OFN25_i_rst_n
Xx_out_reg[14] QDFFRBN $PINS Q=FE_PHN1614_cor_x_out_0_14 D=N438 CK=CTS_46
+ RB=FE_OFN25_i_rst_n
Xx_out_reg[15] QDFFRBN $PINS Q=FE_PHN1531_cor_x_out_0_15 D=N438 CK=CTS_46
+ RB=FE_OFN25_i_rst_n
Xy_out_reg[0] QDFFRBN $PINS Q=FE_PHN1601_cor_y_out_0_0 D=N439 CK=CTS_37
+ RB=FE_OFN19_i_rst_n
Xy_out_reg[1] QDFFRBN $PINS Q=y_out[1] D=N440 CK=CTS_37 RB=FE_OFN19_i_rst_n
Xy_out_reg[2] QDFFRBN $PINS Q=y_out[2] D=FE_PHN1932_N441 CK=CTS_37
+ RB=FE_OFN19_i_rst_n
Xy_out_reg[3] QDFFRBN $PINS Q=FE_PHN1524_cor_y_out_0_3 D=FE_PHN1943_N442
+ CK=CTS_37 RB=FE_OFN19_i_rst_n
Xy_out_reg[4] QDFFRBN $PINS Q=y_out[4] D=FE_PHN1916_N443 CK=CTS_37
+ RB=FE_OFN19_i_rst_n
Xy_out_reg[5] QDFFRBN $PINS Q=y_out[5] D=FE_PHN1909_N444 CK=CTS_37
+ RB=FE_OFN5_i_rst_n
Xy_out_reg[6] QDFFRBN $PINS Q=y_out[6] D=FE_PHN1926_N445 CK=CTS_37
+ RB=FE_OFN19_i_rst_n
Xy_out_reg[7] QDFFRBN $PINS Q=FE_PHN1593_cor_y_out_0_7 D=FE_PHN1929_N446
+ CK=CTS_37 RB=FE_OFN19_i_rst_n
Xy_out_reg[8] QDFFRBN $PINS Q=y_out[8] D=FE_PHN1949_N447 CK=CTS_37
+ RB=FE_OFN19_i_rst_n
Xy_out_reg[9] QDFFRBN $PINS Q=y_out[9] D=FE_PHN1956_N448 CK=CTS_37
+ RB=FE_OFN5_i_rst_n
Xy_out_reg[10] QDFFRBN $PINS Q=FE_PHN1576_cor_y_out_0_10 D=FE_PHN1964_N449
+ CK=CTS_37 RB=FE_OFN19_i_rst_n
Xy_out_reg[11] QDFFRBN $PINS Q=y_out[11] D=FE_PHN1967_N450 CK=CTS_37
+ RB=FE_OFN19_i_rst_n
Xy_out_reg[12] QDFFRBN $PINS Q=y_out[12] D=FE_PHN1965_N451 CK=CTS_37
+ RB=FE_OFN28_i_rst_n
Xy_out_reg[13] QDFFRBN $PINS Q=y_out[13] D=FE_PHN1965_N451 CK=CTS_37
+ RB=FE_OFN19_i_rst_n
Xy_out_reg[14] QDFFRBN $PINS Q=FE_PHN1536_cor_y_out_0_14 D=FE_PHN1965_N451
+ CK=CTS_37 RB=FE_OFN19_i_rst_n
Xy_out_reg[15] QDFFRBN $PINS Q=y_out[15] D=FE_PHN1965_N451 CK=CTS_37
+ RB=FE_OFN28_i_rst_n
Xy_out_reg[16] QDFFRBN $PINS Q=y_out[16] D=FE_PHN1965_N451 CK=CTS_37
+ RB=FE_OFN28_i_rst_n
Xx_out_reg[1] QDFFRBN $PINS Q=x_out[1] D=N427 CK=CTS_46 RB=FE_OFN25_i_rst_n
Xx_out_reg[2] QDFFRBN $PINS Q=x_out[2] D=N428 CK=CTS_46 RB=FE_OFN25_i_rst_n
Xx_out_reg[3] QDFFRBN $PINS Q=x_out[3] D=N429 CK=CTS_46 RB=FE_OFN25_i_rst_n
Xx_out_reg[4] QDFFRBN $PINS Q=x_out[4] D=N430 CK=CTS_46 RB=FE_OFN25_i_rst_n
Xx_out_reg[16] QDFFRBN $PINS Q=FE_PHN1603_cor_x_out_0_16 D=N438 CK=CTS_46
+ RB=FE_OFN25_i_rst_n
Xz_reg_reg[14] QDFFRBN $PINS Q=z_reg[14] D=N477 CK=CTS_43 RB=FE_OFN5_i_rst_n
Xz_reg_reg[15] QDFFRBN $PINS Q=z_reg[15] D=N478 CK=CTS_43 RB=FE_OFN19_i_rst_n
Xz_reg_reg[13] QDFFRBN $PINS Q=z_reg[13] D=N476 CK=CTS_43 RB=FE_OFN5_i_rst_n
Xz_reg_reg[12] QDFFRBN $PINS Q=z_reg[12] D=N475 CK=CTS_43 RB=FE_OFN19_i_rst_n
Xz_reg_reg[11] QDFFRBN $PINS Q=z_reg[11] D=N474 CK=CTS_43 RB=FE_OFN19_i_rst_n
Xz_reg_reg[10] QDFFRBN $PINS Q=FE_PHN1520_z_reg_10 D=N473 CK=CTS_43
+ RB=FE_OFN19_i_rst_n
Xz_reg_reg[9] QDFFRBN $PINS Q=FE_PHN1517_z_reg_9 D=N472 CK=CTS_43
+ RB=FE_OFN19_i_rst_n
Xz_reg_reg[8] QDFFRBN $PINS Q=z_reg[8] D=n375 CK=CTS_43 RB=FE_OFN19_i_rst_n
Xz_reg_reg[7] QDFFRBN $PINS Q=z_reg[7] D=n376 CK=CTS_43 RB=FE_OFN19_i_rst_n
Xz_reg_reg[6] QDFFRBN $PINS Q=FE_PHN1586_z_reg_6 D=n377 CK=CTS_40
+ RB=FE_OFN19_i_rst_n
Xz_reg_reg[5] QDFFRBN $PINS Q=z_reg[5] D=n378 CK=CTS_40 RB=FE_OFN19_i_rst_n
Xz_reg_reg[4] QDFFRBN $PINS Q=z_reg[4] D=n379 CK=CTS_40 RB=FE_OFN19_i_rst_n
Xz_reg_reg[3] QDFFRBN $PINS Q=FE_PHN1732_z_reg_3 D=n380 CK=CTS_40
+ RB=FE_OFN3_i_rst_n
Xz_reg_reg[2] QDFFRBN $PINS Q=z_reg[2] D=FE_PHN1986_n381 CK=CTS_40
+ RB=FE_OFN19_i_rst_n
Xy_reg_reg[17] QDFFRBN $PINS Q=y_reg[17] D=FE_PHN2070_N514 CK=CTS_43
+ RB=FE_OFN50_i_rst_n
Xx_reg_reg[17] QDFFRBN $PINS Q=FE_PHN1764_x_reg_17 D=N496 CK=CTS_40
+ RB=FE_OFN12_i_rst_n
Xz_reg_reg[1] QDFFRBN $PINS Q=z_reg[1] D=n382 CK=CTS_40 RB=FE_OFN3_i_rst_n
Xx_reg_reg[16] QDFFRBN $PINS Q=x_reg[16] D=N495 CK=CTS_40 RB=FE_OFN12_i_rst_n
Xy_reg_reg[16] QDFFRBN $PINS Q=y_reg[16] D=FE_PHN2071_N513 CK=CTS_43
+ RB=FE_OFN50_i_rst_n
Xz_reg_reg[0] QDFFRBN $PINS Q=z_reg[0] D=n383 CK=CTS_40 RB=FE_OFN3_i_rst_n
Xx_reg_reg[15] QDFFRBN $PINS Q=x_reg[15] D=FE_PHN2059_N494 CK=CTS_40
+ RB=FE_OFN12_i_rst_n
Xy_reg_reg[15] QDFFRBN $PINS Q=FE_PHN1789_y_reg_15 D=N512 CK=CTS_43
+ RB=FE_OFN50_i_rst_n
Xx_reg_reg[14] QDFFRBN $PINS Q=x_reg[14] D=FE_PHN2075_N493 CK=CTS_40
+ RB=FE_OFN12_i_rst_n
Xy_reg_reg[14] QDFFRBN $PINS Q=FE_PHN1788_y_reg_14 D=N511 CK=CTS_43
+ RB=FE_OFN50_i_rst_n
Xy_reg_reg[13] QDFFRBN $PINS Q=y_reg[13] D=FE_PHN2067_N510 CK=CTS_43
+ RB=FE_OFN5_i_rst_n
Xx_reg_reg[13] QDFFRBN $PINS Q=x_reg[13] D=FE_PHN2060_N492 CK=CTS_40
+ RB=FE_OFN12_i_rst_n
Xy_reg_reg[12] QDFFRBN $PINS Q=y_reg[12] D=N509 CK=CTS_43 RB=FE_OFN5_i_rst_n
Xx_reg_reg[12] QDFFRBN $PINS Q=x_reg[12] D=N491 CK=CTS_40 RB=FE_OFN12_i_rst_n
Xis_computing_reg QDFFRBN $PINS Q=FE_PHN1738_is_computing D=N457 CK=CTS_40
+ RB=FE_OFN19_i_rst_n
Xy_reg_reg[11] QDFFRBN $PINS Q=y_reg[11] D=N508 CK=CTS_43 RB=FE_OFN5_i_rst_n
Xx_reg_reg[11] QDFFRBN $PINS Q=x_reg[11] D=FE_PHN2057_N490 CK=CTS_40
+ RB=FE_OFN12_i_rst_n
Xx_reg_reg[1] QDFFRBN $PINS Q=x_reg[1] D=FE_PHN2061_N480 CK=CTS_40
+ RB=FE_OFN18_i_rst_n
Xy_reg_reg[1] QDFFRBN $PINS Q=y_reg[1] D=FE_PHN2014_N498 CK=CTS_43
+ RB=FE_OFN18_i_rst_n
Xy_reg_reg[3] QDFFRBN $PINS Q=y_reg[3] D=N500 CK=CTS_43 RB=FE_OFN18_i_rst_n
Xx_reg_reg[3] QDFFRBN $PINS Q=x_reg[3] D=FE_PHN1978_N482 CK=CTS_40
+ RB=FE_OFN18_i_rst_n
Xy_reg_reg[10] QDFFRBN $PINS Q=y_reg[10] D=N507 CK=CTS_43 RB=FE_OFN5_i_rst_n
Xx_reg_reg[4] QDFFRBN $PINS Q=FE_PHN1747_x_reg_4 D=N483 CK=CTS_40
+ RB=FE_OFN18_i_rst_n
Xx_reg_reg[10] QDFFRBN $PINS Q=x_reg[10] D=N489 CK=CTS_40 RB=FE_OFN12_i_rst_n
Xy_reg_reg[4] QDFFRBN $PINS Q=FE_PHN2195_y_reg_4 D=N501 CK=CTS_43
+ RB=FE_OFN5_i_rst_n
Xy_reg_reg[2] QDFFRBN $PINS Q=y_reg[2] D=N499 CK=CTS_43 RB=FE_OFN18_i_rst_n
Xx_reg_reg[0] QDFFRBN $PINS Q=x_reg[0] D=N479 CK=CTS_40 RB=FE_OFN18_i_rst_n
Xx_reg_reg[2] QDFFRBN $PINS Q=x_reg[2] D=FE_PHN2058_N481 CK=CTS_40
+ RB=FE_OFN18_i_rst_n
Xy_reg_reg[0] QDFFRBN $PINS Q=FE_PHN1752_y_reg_0 D=N497 CK=CTS_43
+ RB=FE_OFN18_i_rst_n
Xy_reg_reg[7] QDFFRBN $PINS Q=y_reg[7] D=FE_PHN2062_N504 CK=CTS_43
+ RB=FE_OFN5_i_rst_n
Xx_reg_reg[7] QDFFRBN $PINS Q=x_reg[7] D=N486 CK=CTS_40 RB=FE_OFN18_i_rst_n
Xy_reg_reg[5] QDFFRBN $PINS Q=y_reg[5] D=FE_PHN2214_N502 CK=CTS_43
+ RB=FE_OFN19_i_rst_n
Xx_reg_reg[5] QDFFRBN $PINS Q=x_reg[5] D=N484 CK=CTS_40 RB=FE_OFN18_i_rst_n
Xy_reg_reg[8] QDFFRBN $PINS Q=y_reg[8] D=N505 CK=CTS_43 RB=FE_OFN5_i_rst_n
Xx_reg_reg[8] QDFFRBN $PINS Q=x_reg[8] D=N487 CK=CTS_40 RB=i_rst_n
Xy_reg_reg[6] QDFFRBN $PINS Q=y_reg[6] D=FE_PHN2069_N503 CK=CTS_43
+ RB=FE_OFN5_i_rst_n
Xx_reg_reg[6] QDFFRBN $PINS Q=x_reg[6] D=N485 CK=CTS_40 RB=FE_OFN18_i_rst_n
Xy_reg_reg[9] QDFFRBN $PINS Q=y_reg[9] D=FE_PHN2065_N506 CK=CTS_43
+ RB=FE_OFN5_i_rst_n
Xx_reg_reg[9] QDFFRBN $PINS Q=x_reg[9] D=FE_PHN2056_N488 CK=CTS_40 RB=i_rst_n
Xvalid_out_reg QDFFRBN $PINS Q=valid_out D=N515 CK=clk RB=FE_OFN28_i_rst_n
Xstep_cnt_reg[0] QDFFRBP $PINS Q=step_cnt[0] D=N458 CK=net2457
+ RB=FE_OFN19_i_rst_n
Xstep_cnt_reg[3] QDFFRBN $PINS Q=step_cnt[3] D=FE_PHN2049_N461 CK=net2457
+ RB=FE_OFN19_i_rst_n
Xstep_cnt_reg[1] QDFFRBP $PINS Q=step_cnt[1] D=N459 CK=net2457
+ RB=FE_OFN19_i_rst_n
XU3 OR2P $PINS O=n3 I1=n252 I2=step_cnt[3]
XU4 AN3 $PINS O=n29 I1=n254 I2=step_cnt[1] I3=n258
XU5 OAI112HS $PINS O=N114 A1=FE_OFN300_n261 B1=n371 C1=n258 C2=n369
XU6 INV1S $PINS O=n369 I=step_cnt[0]
XU7 NR2 $PINS O=N147 I1=FE_PHN2158_c_in_r_0_16 I2=sub_87/carry[16]
XU8 AN2B1 $PINS O=n257 I1=step_cnt[0] B1=step_cnt[1]
XU9 NR2 $PINS O=sub_87/carry[2] I1=N130 I2=x_in[1]
XU10 NR2 $PINS O=sub_88/carry[2] I1=N148 I2=y_in[1]
XU11 NR2 $PINS O=N165 I1=y_in[16] I2=sub_88/carry[16]
XU16 NR2 $PINS O=n1 I1=n260 I2=z_reg[15]
XU17 INV2 $PINS O=n258 I=step_cnt[3]
XU19 INV1S $PINS O=n255 I=step_cnt[1]
XU20 ND2S $PINS O=n253 I1=step_cnt[2] I2=n257
XU22 OA222S $PINS O=n166 A1=n103 A2=n129 B1=n73 B2=n104 C1=n88 C2=n105
XU23 OA222S $PINS O=n227 A1=n103 A2=FE_OFN344_x_reg_4 B1=n104 B2=n196 C1=n105
+ C2=n176
XU24 OA222S $PINS O=n228 A1=FE_OFN349_n102 A2=n186 B1=n79 B2=n202 C1=n3 C2=n195
XU25 OA222S $PINS O=n221 A1=n103 A2=n208 B1=n104 B2=n188 C1=n105 C2=n196
XU26 OA222S $PINS O=n222 A1=FE_OFN349_n102 A2=n176 B1=n79 B2=n195 C1=n3 C2=n187
XU27 OA222S $PINS O=n136 A1=n103 A2=n123 B1=n101 B2=n104 C1=n73 C2=n105
XU28 OA222S $PINS O=n137 A1=n88 A2=FE_OFN349_n102 B1=n79 B2=n111 C1=n3 C2=n100
XU29 OA222S $PINS O=n130 A1=FE_OFN351_n103 A2=n117 B1=n90 B2=n104 C1=n101
+ C2=n105
XU30 OA222S $PINS O=n131 A1=n73 A2=FE_OFN349_n102 B1=n79 B2=n100 C1=n3 C2=n89
XU31 OA222S $PINS O=n215 A1=n103 A2=n202 B1=n104 B2=n189 C1=n105 C2=n188
XU32 OA222S $PINS O=n216 A1=FE_OFN349_n102 A2=n196 B1=n79 B2=n187 C1=n3 C2=n186
XU33 OA222S $PINS O=n124 A1=FE_OFN351_n103 A2=n111 B1=n93 B2=n104 C1=n90
+ C2=n105
XU34 OA222S $PINS O=n125 A1=n101 A2=FE_OFN349_n102 B1=n79 B2=n89 C1=n3 C2=n88
XU35 OA222S $PINS O=n209 A1=n103 A2=n195 B1=n104 B2=n180 C1=n105 C2=n189
XU36 OA222S $PINS O=n210 A1=FE_OFN349_n102 A2=n188 B1=n79 B2=n186 C1=n3 C2=n176
XU37 OA222S $PINS O=n118 A1=FE_OFN351_n103 A2=n100 B1=n80 B2=n104 C1=n93
+ C2=n105
XU38 OA222S $PINS O=n119 A1=n90 A2=FE_OFN349_n102 B1=n79 B2=n88 C1=n3 C2=n73
XU39 OA222S $PINS O=n203 A1=n103 A2=n187 B1=n104 B2=n178 C1=n105 C2=n180
XU40 OA222S $PINS O=n204 A1=FE_OFN349_n102 A2=n189 B1=n79 B2=n176 C1=n3 C2=n196
XU41 OA222S $PINS O=n112 A1=FE_OFN351_n103 A2=n89 B1=n76 B2=n104 C1=n80 C2=n105
XU42 OA222S $PINS O=n113 A1=n93 A2=FE_OFN349_n102 B1=n79 B2=n73 C1=n3 C2=n101
XU43 OA222S $PINS O=n197 A1=n103 A2=n186 B1=n104 B2=n177 C1=n105 C2=n178
XU44 OA222S $PINS O=n198 A1=FE_OFN349_n102 A2=n180 B1=n79 B2=n196 C1=n3 C2=n188
XU45 OA222S $PINS O=n106 A1=FE_OFN351_n103 A2=n88 B1=n75 B2=n104 C1=n76 C2=n105
XU46 OA222S $PINS O=n107 A1=n80 A2=FE_OFN349_n102 B1=n79 B2=n101 C1=n3 C2=n90
XU47 OA222S $PINS O=n190 A1=n103 A2=n176 B1=n104 B2=n179 C1=n105 C2=n177
XU48 OA222S $PINS O=n191 A1=FE_OFN349_n102 A2=n178 B1=n79 B2=n188 C1=n3 C2=n189
XU49 OA222S $PINS O=n95 A1=FE_OFN351_n103 A2=n73 B1=n78 B2=n104 C1=n75 C2=n105
XU50 OA222S $PINS O=n96 A1=n76 A2=FE_OFN349_n102 B1=n79 B2=n90 C1=n3 C2=n93
XU51 ND3S $PINS O=N112 I1=n253 I2=n72 I3=n371
XU52 ND3S $PINS O=N113 I1=n153 I2=n72 I3=n372
XU53 OR2S $PINS O=n157 I1=n164 I2=n165
XU54 OA222S $PINS O=n236 A1=FE_OFN43_n72 A2=n189 B1=FE_DBTN15_n2 B2=n188
+ C1=n153 C2=n180
XU55 OA222S $PINS O=n237 A1=n91 A2=n177 B1=n152 B2=n179 C1=FE_OFN350_n103
+ C2=n178
XU56 OA222S $PINS O=n150 A1=n93 A2=FE_OFN43_n72 B1=n90 B2=FE_DBTN15_n2 C1=n80
+ C2=n153
XU57 OA222S $PINS O=n151 A1=n91 A2=n75 B1=n152 B2=n78 C1=n76 C2=FE_OFN350_n103
XU58 ND2S $PINS O=N109 I1=n251 I2=n72
XU60 ND3 $PINS O=n153 I1=n254 I2=n258 I3=step_cnt[1]
XU63 AO222S $PINS O=n249 A1=FE_PHN1769_x_reg_0 A2=n2 B1=x_reg[4] B2=n82
+ C1=x_reg[7] C2=n141
XU64 AO222S $PINS O=n169 A1=y_reg[0] A2=n2 B1=y_reg[4] B2=n82 C1=y_reg[7]
+ C2=n141
XU65 ND3S $PINS O=n261 I1=step_cnt[1] I2=n256 I3=step_cnt[0]
XU66 ND3 $PINS O=n105 I1=step_cnt[3] I2=n256 I3=n257
XU67 ND3S $PINS O=n252 I1=step_cnt[1] I2=n369 I3=step_cnt[2]
XU68 AO222S $PINS O=n230 A1=n2 A2=x_reg[1] B1=n82 B2=x_reg[5] C1=n141
+ C2=x_reg[8]
XU69 AO222S $PINS O=n139 A1=n2 A2=y_reg[1] B1=n82 B2=FE_PHN1770_y_reg_5 C1=n141
+ C2=y_reg[8]
XU70 ND3S $PINS O=n102 I1=n254 I2=n255 I3=step_cnt[3]
XU72 OA222S $PINS O=n182 A1=n3 A2=n180 B1=n92 B2=n179 C1=n79 C2=n189
XU73 OA222S $PINS O=n84 A1=n80 A2=n3 B1=n92 B2=n78 C1=n79 C2=n93
XU74 OA222S $PINS O=n172 A1=n3 A2=n178 B1=n77 B2=n179 C1=n79 C2=n180
XU75 OA222S $PINS O=n68 A1=n3 A2=n76 B1=n77 B2=n78 C1=n79 C2=n80
XU76 OA222S $PINS O=n240 A1=FE_OFN43_n72 A2=n188 B1=FE_DBTN15_n2 B2=n196
+ C1=n153 C2=n189
XU77 OA222S $PINS O=n156 A1=n90 A2=FE_OFN43_n72 B1=FE_DBTN15_n2 B2=n101 C1=n93
+ C2=n153
XU78 OA222S $PINS O=n235 A1=FE_DBTN15_n2 A2=n189 B1=n149 B2=n179
+ C1=FE_OFN350_n103 C2=n177
XU79 OA222S $PINS O=n148 A1=n93 A2=FE_DBTN15_n2 B1=n149 B2=n78
+ C1=FE_OFN350_n103 C2=n75
XU80 OA12S $PINS O=n365 A1=n367 B1=step_cnt[2] B2=n260
XU81 ND2S $PINS O=FE_PHN1822_n368 I1=is_computing I2=n369
XU82 OA12S $PINS O=n367 A1=n368 B1=step_cnt[1] B2=n260
XU102 ND2 $PINS O=n103 I1=N108 I2=n258
XU103 AN3 $PINS O=n2 I1=n255 I2=n258 I3=n254
XU104 INV1S $PINS O=n66 I=FE_PHN1744_c_in_i_0_0
XU105 INV1S $PINS O=n49 I=N130
XU106 INV1S $PINS O=n65 I=y_in[1]
XU107 INV1S $PINS O=n48 I=x_in[1]
XU108 INV1S $PINS O=n64 I=y_in[2]
XU109 INV1S $PINS O=n47 I=x_in[2]
XU110 INV1S $PINS O=n63 I=y_in[3]
XU111 INV1S $PINS O=n46 I=x_in[3]
XU112 INV1S $PINS O=n62 I=y_in[4]
XU113 INV1S $PINS O=n45 I=x_in[4]
XU114 INV1S $PINS O=n61 I=y_in[5]
XU115 INV1S $PINS O=n44 I=x_in[5]
XU116 INV1S $PINS O=n60 I=y_in[6]
XU117 INV1S $PINS O=n43 I=x_in[6]
XU118 INV1S $PINS O=n42 I=x_in[7]
XU119 INV1S $PINS O=n59 I=y_in[7]
XU120 INV1S $PINS O=n58 I=y_in[8]
XU121 INV1S $PINS O=n41 I=x_in[8]
XU122 INV1S $PINS O=n57 I=y_in[9]
XU123 INV1S $PINS O=n40 I=x_in[9]
XU124 INV1S $PINS O=n56 I=y_in[10]
XU125 INV1S $PINS O=n39 I=x_in[10]
XU126 INV1S $PINS O=n55 I=y_in[11]
XU127 INV1S $PINS O=n38 I=x_in[11]
XU128 INV1S $PINS O=n54 I=y_in[12]
XU129 INV1S $PINS O=n37 I=x_in[12]
XU130 INV1S $PINS O=n53 I=y_in[13]
XU131 INV1S $PINS O=n36 I=x_in[13]
XU132 INV1S $PINS O=n52 I=y_in[14]
XU133 INV1S $PINS O=n35 I=x_in[14]
XU134 INV1S $PINS O=n51 I=y_in[15]
XU135 INV1S $PINS O=n34 I=x_in[15]
XU136 INV1S $PINS O=n50 I=y_in[16]
XU137 INV1S $PINS O=n33 I=x_in[16]
XU141 NR2T $PINS O=n82 I1=n251 I2=step_cnt[3]
XU148 INV1S $PINS O=n189 I=x_reg[13]
XU149 INV1S $PINS O=n93 I=y_reg[13]
XU151 XOR2HS $PINS O=N438 I1=x_reg[17] I2=add_116/carry[17]
XU152 AN2 $PINS O=add_116/carry[17] I1=add_116/carry[16] I2=FE_PHN1775_x_reg_16
XU153 XOR2HS $PINS O=FE_PHN1898_N437 I1=FE_PHN1775_x_reg_16
+ I2=add_116/carry[16]
XU154 AN2 $PINS O=add_116/carry[16] I1=add_116/carry[15] I2=x_reg[15]
XU155 XOR2HS $PINS O=N436 I1=x_reg[15] I2=add_116/carry[15]
XU156 AN2 $PINS O=add_116/carry[15] I1=add_116/carry[14] I2=x_reg[14]
XU157 XOR2HS $PINS O=N435 I1=x_reg[14] I2=add_116/carry[14]
XU158 AN2 $PINS O=add_116/carry[14] I1=add_116/carry[13] I2=x_reg[13]
XU159 XOR2HS $PINS O=FE_PHN1876_N434 I1=x_reg[13] I2=add_116/carry[13]
XU160 AN2 $PINS O=add_116/carry[13] I1=add_116/carry[12] I2=x_reg[12]
XU161 XOR2HS $PINS O=N433 I1=x_reg[12] I2=add_116/carry[12]
XU162 AN2 $PINS O=add_116/carry[12] I1=add_116/carry[11] I2=x_reg[11]
XU163 XOR2HS $PINS O=N432 I1=x_reg[11] I2=add_116/carry[11]
XU164 AN2 $PINS O=add_116/carry[11] I1=add_116/carry[10] I2=FE_PHN1778_x_reg_10
XU165 XOR2HS $PINS O=N431 I1=FE_PHN1778_x_reg_10 I2=add_116/carry[10]
XU166 AN2 $PINS O=add_116/carry[10] I1=add_116/carry[9] I2=FE_PHN1774_x_reg_9
XU167 XOR2HS $PINS O=N430 I1=FE_PHN1774_x_reg_9 I2=add_116/carry[9]
XU168 AN2 $PINS O=add_116/carry[9] I1=add_116/carry[8] I2=FE_PHN1590_x_reg_8
XU169 XOR2HS $PINS O=N429 I1=FE_PHN1590_x_reg_8 I2=add_116/carry[8]
XU170 AN2 $PINS O=add_116/carry[8] I1=add_116/carry[7] I2=FE_PHN1600_x_reg_7
XU171 XOR2HS $PINS O=N428 I1=FE_PHN1600_x_reg_7 I2=add_116/carry[7]
XU172 AN2 $PINS O=add_116/carry[7] I1=add_116/carry[6] I2=FE_PHN1578_x_reg_6
XU173 XOR2HS $PINS O=N427 I1=FE_PHN1578_x_reg_6 I2=add_116/carry[6]
XU174 AN2 $PINS O=add_116/carry[6] I1=x_reg[4] I2=FE_PHN1551_x_reg_5
XU175 XOR2HS $PINS O=N426 I1=FE_PHN1551_x_reg_5 I2=x_reg[4]
XU176 XOR2HS $PINS O=N451 I1=FE_PHN2080_y_reg_17 I2=add_117/carry[17]
XU177 AN2 $PINS O=add_117/carry[17] I1=add_117/carry[16] I2=y_reg[16]
XU178 XOR2HS $PINS O=N450 I1=y_reg[16] I2=add_117/carry[16]
XU179 AN2 $PINS O=add_117/carry[16] I1=add_117/carry[15] I2=y_reg[15]
XU180 XOR2HS $PINS O=N449 I1=y_reg[15] I2=add_117/carry[15]
XU181 AN2 $PINS O=add_117/carry[15] I1=add_117/carry[14] I2=y_reg[14]
XU182 XOR2HS $PINS O=N448 I1=y_reg[14] I2=add_117/carry[14]
XU183 AN2 $PINS O=add_117/carry[14] I1=add_117/carry[13] I2=y_reg[13]
XU184 XOR2HS $PINS O=N447 I1=y_reg[13] I2=add_117/carry[13]
XU185 AN2 $PINS O=add_117/carry[13] I1=add_117/carry[12] I2=FE_PHN1731_y_reg_12
XU186 XOR2HS $PINS O=N446 I1=FE_PHN1731_y_reg_12 I2=add_117/carry[12]
XU187 AN2 $PINS O=add_117/carry[12] I1=add_117/carry[11] I2=y_reg[11]
XU188 XOR2HS $PINS O=N445 I1=y_reg[11] I2=add_117/carry[11]
XU189 AN2 $PINS O=add_117/carry[11] I1=add_117/carry[10] I2=y_reg[10]
XU190 XOR2HS $PINS O=N444 I1=y_reg[10] I2=add_117/carry[10]
XU191 AN2 $PINS O=add_117/carry[10] I1=add_117/carry[9] I2=y_reg[9]
XU192 XOR2HS $PINS O=N443 I1=y_reg[9] I2=add_117/carry[9]
XU193 AN2 $PINS O=add_117/carry[9] I1=add_117/carry[8] I2=y_reg[8]
XU194 XOR2HS $PINS O=N442 I1=y_reg[8] I2=add_117/carry[8]
XU195 AN2 $PINS O=add_117/carry[8] I1=add_117/carry[7] I2=y_reg[7]
XU196 XOR2HS $PINS O=N441 I1=y_reg[7] I2=add_117/carry[7]
XU197 AN2 $PINS O=add_117/carry[7] I1=add_117/carry[6] I2=FE_PHN1771_y_reg_6
XU198 XOR2HS $PINS O=N440 I1=FE_PHN1771_y_reg_6 I2=add_117/carry[6]
XU199 AN2 $PINS O=add_117/carry[6] I1=FE_PHN1659_y_reg_4 I2=FE_PHN1770_y_reg_5
XU200 XOR2HS $PINS O=N439 I1=FE_PHN1770_y_reg_5 I2=FE_PHN1659_y_reg_4
XU201 XOR2HS $PINS O=N146 I1=n33 I2=sub_87/carry[16]
XU202 AN2 $PINS O=sub_87/carry[16] I1=sub_87/carry[15] I2=n34
XU203 XOR2HS $PINS O=N145 I1=n34 I2=sub_87/carry[15]
XU204 AN2 $PINS O=sub_87/carry[15] I1=sub_87/carry[14] I2=n35
XU205 XOR2HS $PINS O=N144 I1=n35 I2=sub_87/carry[14]
XU206 AN2 $PINS O=sub_87/carry[14] I1=sub_87/carry[13] I2=n36
XU207 XOR2HS $PINS O=N143 I1=n36 I2=sub_87/carry[13]
XU208 AN2 $PINS O=sub_87/carry[13] I1=sub_87/carry[12] I2=n37
XU209 XOR2HS $PINS O=N142 I1=n37 I2=sub_87/carry[12]
XU210 AN2 $PINS O=sub_87/carry[12] I1=sub_87/carry[11] I2=n38
XU211 XOR2HS $PINS O=N141 I1=n38 I2=sub_87/carry[11]
XU212 AN2 $PINS O=sub_87/carry[11] I1=sub_87/carry[10] I2=n39
XU213 XOR2HS $PINS O=N140 I1=n39 I2=sub_87/carry[10]
XU214 AN2 $PINS O=sub_87/carry[10] I1=sub_87/carry[9] I2=n40
XU215 XOR2HS $PINS O=N139 I1=n40 I2=sub_87/carry[9]
XU216 AN2 $PINS O=sub_87/carry[9] I1=sub_87/carry[8] I2=n41
XU217 XOR2HS $PINS O=N138 I1=n41 I2=sub_87/carry[8]
XU218 AN2 $PINS O=sub_87/carry[8] I1=sub_87/carry[7] I2=n42
XU219 XOR2HS $PINS O=N137 I1=n42 I2=sub_87/carry[7]
XU220 AN2 $PINS O=sub_87/carry[7] I1=sub_87/carry[6] I2=n43
XU221 XOR2HS $PINS O=N136 I1=n43 I2=sub_87/carry[6]
XU222 AN2 $PINS O=sub_87/carry[6] I1=sub_87/carry[5] I2=n44
XU223 XOR2HS $PINS O=N135 I1=n44 I2=sub_87/carry[5]
XU224 AN2 $PINS O=sub_87/carry[5] I1=sub_87/carry[4] I2=n45
XU225 XOR2HS $PINS O=N134 I1=n45 I2=sub_87/carry[4]
XU226 AN2 $PINS O=sub_87/carry[4] I1=sub_87/carry[3] I2=n46
XU227 XOR2HS $PINS O=N133 I1=n46 I2=sub_87/carry[3]
XU228 AN2 $PINS O=sub_87/carry[3] I1=sub_87/carry[2] I2=n47
XU229 XOR2HS $PINS O=N132 I1=n47 I2=sub_87/carry[2]
XU230 XOR2HS $PINS O=N131 I1=n48 I2=n49
XU231 XOR2HS $PINS O=N164 I1=n50 I2=sub_88/carry[16]
XU232 AN2 $PINS O=sub_88/carry[16] I1=sub_88/carry[15] I2=n51
XU233 XOR2HS $PINS O=N163 I1=n51 I2=sub_88/carry[15]
XU234 AN2 $PINS O=sub_88/carry[15] I1=sub_88/carry[14] I2=n52
XU235 XOR2HS $PINS O=N162 I1=n52 I2=sub_88/carry[14]
XU236 AN2 $PINS O=sub_88/carry[14] I1=sub_88/carry[13] I2=n53
XU237 XOR2HS $PINS O=N161 I1=n53 I2=sub_88/carry[13]
XU238 AN2 $PINS O=sub_88/carry[13] I1=sub_88/carry[12] I2=n54
XU239 XOR2HS $PINS O=N160 I1=n54 I2=sub_88/carry[12]
XU240 AN2 $PINS O=sub_88/carry[12] I1=sub_88/carry[11] I2=n55
XU241 XOR2HS $PINS O=N159 I1=n55 I2=sub_88/carry[11]
XU242 AN2 $PINS O=sub_88/carry[11] I1=sub_88/carry[10] I2=n56
XU243 XOR2HS $PINS O=N158 I1=n56 I2=sub_88/carry[10]
XU244 AN2 $PINS O=sub_88/carry[10] I1=sub_88/carry[9] I2=n57
XU245 XOR2HS $PINS O=N157 I1=n57 I2=sub_88/carry[9]
XU246 AN2 $PINS O=sub_88/carry[9] I1=sub_88/carry[8] I2=n58
XU247 XOR2HS $PINS O=N156 I1=n58 I2=sub_88/carry[8]
XU248 AN2 $PINS O=sub_88/carry[8] I1=sub_88/carry[7] I2=n59
XU249 XOR2HS $PINS O=N155 I1=n59 I2=sub_88/carry[7]
XU250 AN2 $PINS O=sub_88/carry[7] I1=sub_88/carry[6] I2=n60
XU251 XOR2HS $PINS O=N154 I1=n60 I2=sub_88/carry[6]
XU252 AN2 $PINS O=sub_88/carry[6] I1=sub_88/carry[5] I2=n61
XU253 XOR2HS $PINS O=N153 I1=n61 I2=sub_88/carry[5]
XU254 AN2 $PINS O=sub_88/carry[5] I1=sub_88/carry[4] I2=n62
XU255 XOR2HS $PINS O=N152 I1=n62 I2=sub_88/carry[4]
XU256 AN2 $PINS O=sub_88/carry[4] I1=sub_88/carry[3] I2=n63
XU257 XOR2HS $PINS O=N151 I1=n63 I2=sub_88/carry[3]
XU258 AN2 $PINS O=sub_88/carry[3] I1=sub_88/carry[2] I2=n64
XU259 XOR2HS $PINS O=N150 I1=n64 I2=sub_88/carry[2]
XU260 XOR2HS $PINS O=N149 I1=n65 I2=n66
XU261 ND3 $PINS O=y_shift[9] I1=n67 I2=n68 I3=n69
XU262 NR2 $PINS O=n69 I1=n70 I2=n71
XU263 MOAI1S $PINS O=n71 A1=FE_OFN43_n72 A2=n73 B1=n29 B2=y_reg[11]
XU264 MOAI1S $PINS O=n70 A1=FE_OFN282_n5 A2=n75 B1=n2 B2=y_reg[9]
XU265 AOI22S $PINS O=n67 A1=y_reg[12] A2=n81 B1=y_reg[13] B2=n82
XU266 ND3 $PINS O=y_shift[8] I1=n83 I2=n84 I3=n85
XU267 NR2 $PINS O=n85 I1=n86 I2=n87
XU268 MOAI1S $PINS O=n87 A1=n88 A2=FE_OFN43_n72 B1=n29 B2=y_reg[10]
XU269 OAI222S $PINS O=n86 A1=FE_DBTN15_n2 A2=n89 B1=n90 B2=n91 C1=n76
+ C2=FE_OFN282_n5
XU270 AOI22S $PINS O=n83 A1=n94 A2=y_reg[16] B1=y_reg[11] B2=n81
XU271 ND3 $PINS O=y_shift[7] I1=n95 I2=n96 I3=n97
XU272 NR2 $PINS O=n97 I1=n98 I2=n99
XU273 MOAI1S $PINS O=n99 A1=FE_OFN43_n72 A2=n89 B1=y_reg[9] B2=n29
XU274 OAI222S $PINS O=n98 A1=FE_DBTN15_n2 A2=n100 B1=n91 B2=n101 C1=n80
+ C2=FE_OFN282_n5
XU275 ND3 $PINS O=y_shift[6] I1=n106 I2=n107 I3=n108
XU276 NR2 $PINS O=n108 I1=n109 I2=n110
XU277 MOAI1S $PINS O=n110 A1=FE_OFN43_n72 A2=n100 B1=n29 B2=y_reg[8]
XU278 OAI222S $PINS O=n109 A1=FE_DBTN15_n2 A2=n111 B1=n91 B2=n73 C1=n93
+ C2=FE_OFN282_n5
XU279 ND3 $PINS O=y_shift[5] I1=n112 I2=n113 I3=n114
XU280 NR2 $PINS O=n114 I1=n115 I2=n116
XU281 MOAI1S $PINS O=n116 A1=FE_OFN43_n72 A2=n111 B1=n29 B2=y_reg[7]
XU282 OAI222S $PINS O=n115 A1=FE_DBTN15_n2 A2=n117 B1=n91 B2=n88 C1=n90
+ C2=FE_OFN282_n5
XU283 ND3 $PINS O=y_shift[4] I1=n118 I2=n119 I3=n120
XU284 NR2 $PINS O=n120 I1=n121 I2=n122
XU285 MOAI1S $PINS O=n122 A1=FE_OFN43_n72 A2=n117 B1=n29 B2=FE_PHN1771_y_reg_6
XU286 OAI222S $PINS O=n121 A1=FE_DBTN15_n2 A2=n123 B1=n91 B2=n89
+ C1=FE_OFN282_n5 C2=n101
XU287 ND3 $PINS O=y_shift[3] I1=n124 I2=n125 I3=n126
XU288 NR2 $PINS O=n126 I1=n127 I2=n128
XU289 MOAI1S $PINS O=n128 A1=FE_OFN43_n72 A2=n123 B1=n29 B2=FE_PHN1770_y_reg_5
XU290 OAI222S $PINS O=n127 A1=FE_DBTN15_n2 A2=n129 B1=n91 B2=n100
+ C1=FE_OFN282_n5 C2=n73
XU291 ND3 $PINS O=y_shift[2] I1=n130 I2=n131 I3=n132
XU292 NR2 $PINS O=n132 I1=n133 I2=n134
XU293 MOAI1S $PINS O=n134 A1=FE_OFN43_n72 A2=n129 B1=n29 B2=y_reg[4]
XU294 OAI222S $PINS O=n133 A1=FE_DBTN15_n2 A2=n135 B1=n91 B2=n111 C1=n88
+ C2=FE_OFN282_n5
XU295 ND3 $PINS O=y_shift[1] I1=n136 I2=n137 I3=n138
XU296 NR2 $PINS O=n138 I1=n139 I2=n140
XU297 MOAI1S $PINS O=n140 A1=FE_OFN43_n72 A2=n135 B1=n29 B2=y_reg[3]
XU299 INV1S $PINS O=n123 I=y_reg[4]
XU300 MOAI1S $PINS O=y_shift[16] A1=FE_DBTN15_n2 A2=n75 B1=y_reg[17] B2=n142
XU301 OAI222S $PINS O=y_shift[15] A1=n76 A2=FE_DBTN15_n2 B1=n143 B2=n78 C1=n75
+ C2=FE_OFN43_n72
XU302 ND2 $PINS O=y_shift[14] I1=n144 I2=n145
XU303 AOI22S $PINS O=n145 A1=y_reg[17] A2=n146 B1=n2 B2=y_reg[14]
XU304 AOI22S $PINS O=n144 A1=n29 A2=y_reg[16] B1=n9 B2=y_reg[15]
XU305 ND2 $PINS O=y_shift[13] I1=n147 I2=n148
XU306 AOI22S $PINS O=n147 A1=n29 A2=y_reg[15] B1=n9 B2=y_reg[14]
XU307 ND2 $PINS O=y_shift[12] I1=n150 I2=n151
XU308 INV1S $PINS O=n76 I=y_reg[15]
XU309 INV1S $PINS O=n78 I=y_reg[17]
XU310 INV1S $PINS O=n75 I=y_reg[16]
XU311 INV1S $PINS O=n80 I=y_reg[14]
XU312 ND3 $PINS O=y_shift[11] I1=n154 I2=n155 I3=n156
XU313 AOI22S $PINS O=n155 A1=y_reg[17] A2=n157 B1=y_reg[16] B2=FE_OFN286_n158
XU314 AOI22S $PINS O=n154 A1=n81 A2=y_reg[14] B1=n82 B2=y_reg[15]
XU315 ND3 $PINS O=y_shift[10] I1=n159 I2=n160 I3=n161
XU316 NR2 $PINS O=n161 I1=n162 I2=n163
XU317 MOAI1S $PINS O=n163 A1=n101 A2=FE_OFN43_n72 B1=y_reg[12] B2=n29
XU318 MOAI1S $PINS O=n162 A1=FE_DBTN15_n2 A2=n73 B1=y_reg[14] B2=n82
XU319 AOI22S $PINS O=n160 A1=y_reg[17] A2=n164 B1=y_reg[15] B2=FE_OFN286_n158
XU320 AOI22S $PINS O=n159 A1=y_reg[16] A2=n165 B1=y_reg[13] B2=n81
XU321 ND3 $PINS O=y_shift[0] I1=n166 I2=n167 I3=n168
XU322 NR2 $PINS O=n168 I1=n169 I2=n170
XU323 MOAI1S $PINS O=n170 A1=n153 A2=n135 B1=n9 B2=y_reg[1]
XU324 INV1S $PINS O=n135 I=y_reg[2]
XU325 OA222 $PINS O=n167 A1=FE_OFN349_n102 A2=n89 B1=n79 B2=n117 C1=n3 C2=n111
XU327 INV1S $PINS O=n117 I=FE_PHN1770_y_reg_5
XU328 INV1S $PINS O=n89 I=y_reg[8]
XU330 INV1S $PINS O=n129 I=y_reg[3]
XU331 ND3 $PINS O=x_shift[9] I1=n171 I2=n172 I3=n173
XU332 NR2 $PINS O=n173 I1=n174 I2=n175
XU333 MOAI1S $PINS O=n175 A1=FE_OFN43_n72 A2=n176 B1=n29 B2=x_reg[11]
XU334 MOAI1S $PINS O=n174 A1=FE_OFN282_n5 A2=n177 B1=n2 B2=FE_PHN1774_x_reg_9
XU335 AOI22S $PINS O=n171 A1=x_reg[12] A2=n81 B1=x_reg[13] B2=n82
XU336 ND3 $PINS O=x_shift[8] I1=n181 I2=n182 I3=n183
XU337 NR2 $PINS O=n183 I1=n184 I2=n185
XU338 MOAI1S $PINS O=n185 A1=FE_OFN43_n72 A2=n186 B1=n29 B2=FE_PHN2192_x_reg_10
XU339 OAI222S $PINS O=n184 A1=FE_DBTN15_n2 A2=n187 B1=n91 B2=n188
+ C1=FE_OFN282_n5 C2=n178
XU340 AOI22S $PINS O=n181 A1=FE_PHN1775_x_reg_16 A2=n94 B1=x_reg[11] B2=n81
XU341 INV1S $PINS O=n94 I=FE_OFN349_n102
XU342 ND3 $PINS O=x_shift[7] I1=n190 I2=n191 I3=n192
XU343 NR2 $PINS O=n192 I1=n193 I2=n194
XU344 MOAI1S $PINS O=n194 A1=FE_OFN43_n72 A2=n187 B1=n29 B2=FE_PHN1774_x_reg_9
XU345 OAI222S $PINS O=n193 A1=FE_DBTN15_n2 A2=n195 B1=n91 B2=n196
+ C1=FE_OFN282_n5 C2=n180
XU346 ND3 $PINS O=x_shift[6] I1=n197 I2=n198 I3=n199
XU347 NR2 $PINS O=n199 I1=n200 I2=n201
XU348 MOAI1S $PINS O=n201 A1=FE_OFN43_n72 A2=n195 B1=n29 B2=x_reg[8]
XU349 OAI222S $PINS O=n200 A1=FE_DBTN15_n2 A2=n202 B1=n91 B2=n176
+ C1=FE_OFN282_n5 C2=n189
XU350 ND3 $PINS O=x_shift[5] I1=n203 I2=n204 I3=n205
XU351 NR2 $PINS O=n205 I1=n206 I2=n207
XU352 MOAI1S $PINS O=n207 A1=FE_OFN43_n72 A2=n202 B1=n29 B2=x_reg[7]
XU353 OAI222S $PINS O=n206 A1=FE_DBTN15_n2 A2=n208 B1=n91 B2=n186
+ C1=FE_OFN282_n5 C2=n188
XU354 ND3 $PINS O=x_shift[4] I1=n209 I2=n210 I3=n211
XU355 NR2 $PINS O=n211 I1=n212 I2=n213
XU356 MOAI1S $PINS O=n213 A1=FE_OFN43_n72 A2=n208 B1=n29 B2=FE_PHN2178_x_reg_6
XU357 OAI222S $PINS O=n212 A1=FE_DBTN15_n2 A2=FE_OFN344_x_reg_4 B1=n91 B2=n187
+ C1=FE_OFN282_n5 C2=n196
XU358 ND3 $PINS O=x_shift[3] I1=n215 I2=n216 I3=n217
XU359 NR2 $PINS O=n217 I1=n218 I2=n219
XU360 MOAI1S $PINS O=n219 A1=FE_OFN43_n72 A2=FE_OFN344_x_reg_4 B1=n29
+ B2=x_reg[5]
XU361 OAI222S $PINS O=n218 A1=FE_DBTN15_n2 A2=n220 B1=n91 B2=n195
+ C1=FE_OFN282_n5 C2=n176
XU362 ND3 $PINS O=x_shift[2] I1=n221 I2=n222 I3=n223
XU363 NR2 $PINS O=n223 I1=n224 I2=n225
XU364 MOAI1S $PINS O=n225 A1=FE_OFN43_n72 A2=n220 B1=n29 B2=x_reg[4]
XU365 OAI222S $PINS O=n224 A1=FE_DBTN15_n2 A2=n226 B1=n91 B2=n202
+ C1=FE_OFN282_n5 C2=n186
XU366 ND3 $PINS O=x_shift[1] I1=n227 I2=n228 I3=n229
XU367 NR2 $PINS O=n229 I1=n230 I2=n231
XU368 MOAI1S $PINS O=n231 A1=FE_OFN43_n72 A2=n226 B1=n29 B2=x_reg[3]
XU371 MOAI1S $PINS O=x_shift[16] A1=FE_DBTN15_n2 A2=n177 B1=x_reg[17] B2=n142
XU372 ND2 $PINS O=n142 I1=n143 I2=FE_OFN43_n72
XU373 OAI222S $PINS O=x_shift[15] A1=FE_DBTN15_n2 A2=n178 B1=n143 B2=n179
+ C1=FE_OFN43_n72 C2=n177
XU374 NR2 $PINS O=n143 I1=n146 I2=n29
XU375 ND2 $PINS O=x_shift[14] I1=n232 I2=n233
XU376 AOI22S $PINS O=n233 A1=x_reg[17] A2=n146 B1=x_reg[14] B2=n2
XU377 ND2 $PINS O=n146 I1=n149 I2=FE_OFN350_n103
XU378 AOI22S $PINS O=n232 A1=FE_PHN1775_x_reg_16 A2=n29 B1=x_reg[15] B2=n9
XU379 ND2 $PINS O=x_shift[13] I1=n234 I2=n235
XU380 AN2 $PINS O=n149 I1=n152 I2=n91
XU381 AOI22S $PINS O=n234 A1=x_reg[15] A2=n29 B1=x_reg[14] B2=n9
XU382 ND2 $PINS O=x_shift[12] I1=n236 I2=n237
XU383 INV1S $PINS O=n178 I=x_reg[15]
XU384 INV1S $PINS O=n179 I=x_reg[17]
XU385 NR2 $PINS O=n152 I1=n157 I2=FE_OFN286_n158
XU386 INV1S $PINS O=n177 I=FE_PHN1775_x_reg_16
XU387 INV1S $PINS O=n180 I=x_reg[14]
XU388 ND3 $PINS O=x_shift[11] I1=n238 I2=n239 I3=n240
XU389 AOI22S $PINS O=n239 A1=x_reg[17] A2=n157 B1=FE_PHN1775_x_reg_16
+ B2=FE_OFN286_n158
XU390 AOI22S $PINS O=n238 A1=x_reg[14] A2=n81 B1=x_reg[15] B2=n82
XU391 ND3 $PINS O=x_shift[10] I1=n241 I2=n242 I3=n243
XU392 NR2 $PINS O=n243 I1=n244 I2=n245
XU393 MOAI1S $PINS O=n245 A1=FE_OFN43_n72 A2=n196 B1=n29 B2=x_reg[12]
XU394 MOAI1S $PINS O=n244 A1=FE_DBTN15_n2 A2=n176 B1=n82 B2=x_reg[14]
XU395 AOI22S $PINS O=n242 A1=x_reg[17] A2=n164 B1=x_reg[15] B2=FE_OFN286_n158
XU396 ND2 $PINS O=n164 I1=n77 I2=FE_OFN282_n5
XU397 AN2 $PINS O=n77 I1=n92 I2=FE_OFN349_n102
XU398 AN2 $PINS O=n92 I1=n105 I2=n104
XU399 AOI22S $PINS O=n241 A1=FE_PHN1775_x_reg_16 A2=n165 B1=x_reg[13] B2=n81
XU400 INV1S $PINS O=n81 I=FE_OFN350_n103
XU401 ND3 $PINS O=x_shift[0] I1=n246 I2=n247 I3=n248
XU402 NR2 $PINS O=n248 I1=n249 I2=n250
XU403 MOAI1S $PINS O=n250 A1=n153 A2=n226 B1=n9 B2=x_reg[1]
XU404 INV1S $PINS O=n226 I=x_reg[2]
XU405 OA222 $PINS O=n247 A1=FE_OFN349_n102 A2=n187 B1=n79 B2=n208 C1=n3 C2=n202
XU407 NR2 $PINS O=n165 I1=n252 I2=step_cnt[3]
XU408 INV1S $PINS O=n208 I=x_reg[5]
XU409 NR2 $PINS O=n158 I1=n253 I2=step_cnt[3]
XU411 OA222 $PINS O=n246 A1=n103 A2=n220 B1=n104 B2=n176 C1=n105 C2=n186
XU413 INV1S $PINS O=n220 I=x_reg[3]
XU414 AO22 $PINS O=n375 A1=N314 A2=n1 B1=N366 B2=n259
XU415 AO22 $PINS O=n376 A1=N313 A2=n1 B1=N365 B2=n259
XU416 AO22 $PINS O=n377 A1=N312 A2=n1 B1=N364 B2=n259
XU417 AO22 $PINS O=FE_PHN1988_n378 A1=N311 A2=n1 B1=N363 B2=n259
XU418 AO22 $PINS O=FE_PHN1976_n379 A1=N310 A2=n1 B1=N362 B2=n259
XU419 AO22 $PINS O=FE_PHN2087_n380 A1=N309 A2=n1 B1=N361 B2=n259
XU420 AO22 $PINS O=n381 A1=N308 A2=n1 B1=N360 B2=n259
XU421 AO22 $PINS O=FE_PHN1977_n382 A1=N307 A2=n1 B1=N359 B2=n259
XU422 AO22 $PINS O=n383 A1=N306 A2=n1 B1=N358 B2=n259
XU423 NR3 $PINS O=N515 I1=n260 I2=n258 I3=FE_OFN300_n261
XU424 ND2 $PINS O=N514 I1=n262 I2=n263
XU426 AOI22S $PINS O=n262 A1=y_in[16] A2=FE_OFN45_n264 B1=N165 B2=n265
XU427 ND2 $PINS O=N513 I1=n266 I2=n267
XU428 AOI22S $PINS O=n267 A1=N356 A2=FE_OFN44_n259 B1=N304 B2=FE_OFN42_n1
XU429 AOI22S $PINS O=n266 A1=y_in[16] A2=FE_OFN45_n264 B1=N164 B2=n265
XU430 ND2 $PINS O=N512 I1=n268 I2=n269
XU431 AOI22S $PINS O=n269 A1=N355 A2=FE_OFN44_n259 B1=N303 B2=FE_OFN42_n1
XU432 AOI22S $PINS O=n268 A1=y_in[15] A2=n264 B1=N163 B2=n265
XU433 ND2 $PINS O=N511 I1=FE_PHN2212_n270 I2=n271
XU434 AOI22S $PINS O=n271 A1=N354 A2=FE_OFN44_n259 B1=N302 B2=FE_OFN42_n1
XU435 AOI22S $PINS O=n270 A1=FE_PHN1717_c_in_i_0_14 A2=n264 B1=N162 B2=n265
XU436 ND2 $PINS O=N510 I1=n272 I2=n273
XU437 AOI22S $PINS O=n273 A1=N353 A2=FE_OFN44_n259 B1=N301 B2=FE_OFN42_n1
XU438 AOI22S $PINS O=n272 A1=y_in[13] A2=n264 B1=N161 B2=n265
XU439 ND2 $PINS O=N509 I1=FE_PHN2215_n274 I2=n275
XU440 AOI22S $PINS O=n275 A1=N352 A2=FE_OFN44_n259 B1=N300 B2=FE_OFN42_n1
XU441 AOI22S $PINS O=n274 A1=FE_PHN1714_c_in_i_0_12 A2=n264 B1=N160
+ B2=FE_OFN46_n265
XU442 ND2 $PINS O=N508 I1=FE_PHN2216_n276 I2=n277
XU443 AOI22S $PINS O=n277 A1=N351 A2=FE_OFN44_n259 B1=N299 B2=FE_OFN42_n1
XU444 AOI22S $PINS O=n276 A1=FE_PHN1708_c_in_i_0_11 A2=n264 B1=N159
+ B2=FE_OFN46_n265
XU445 ND2 $PINS O=FE_PHN2073_N507 I1=FE_PHN2213_n278 I2=n279
XU446 AOI22S $PINS O=n279 A1=N350 A2=FE_OFN44_n259 B1=N298 B2=FE_OFN42_n1
XU447 AOI22S $PINS O=n278 A1=y_in[10] A2=n264 B1=N158 B2=FE_OFN46_n265
XU448 ND2 $PINS O=N506 I1=n280 I2=n281
XU449 AOI22S $PINS O=n281 A1=N349 A2=FE_OFN44_n259 B1=N297 B2=FE_OFN42_n1
XU450 AOI22S $PINS O=n280 A1=y_in[9] A2=n264 B1=N157 B2=FE_OFN46_n265
XU451 ND2 $PINS O=FE_PHN2068_N505 I1=n282 I2=n283
XU452 AOI22S $PINS O=n283 A1=N348 A2=n259 B1=N296 B2=FE_OFN42_n1
XU453 AOI22S $PINS O=n282 A1=y_in[8] A2=n264 B1=N156 B2=FE_OFN46_n265
XU454 ND2 $PINS O=N504 I1=n284 I2=n285
XU455 AOI22S $PINS O=n285 A1=N347 A2=n259 B1=N295 B2=FE_OFN41_n1
XU456 AOI22S $PINS O=n284 A1=y_in[7] A2=FE_OFN45_n264 B1=N155 B2=FE_OFN46_n265
XU457 ND2 $PINS O=N503 I1=n286 I2=n287
XU458 AOI22S $PINS O=n287 A1=N346 A2=n259 B1=N294 B2=FE_OFN41_n1
XU459 AOI22S $PINS O=n286 A1=y_in[6] A2=FE_OFN45_n264 B1=N154 B2=FE_OFN46_n265
XU460 ND2 $PINS O=N502 I1=FE_PHN2072_n288 I2=n289
XU461 AOI22S $PINS O=n289 A1=N345 A2=n259 B1=N293 B2=FE_OFN41_n1
XU462 AOI22S $PINS O=n288 A1=y_in[5] A2=FE_OFN45_n264 B1=N153 B2=FE_OFN46_n265
XU463 ND2 $PINS O=FE_PHN2074_N501 I1=FE_PHN2211_n290 I2=n291
XU464 AOI22S $PINS O=n291 A1=N344 A2=n259 B1=N292 B2=FE_OFN41_n1
XU465 AOI22S $PINS O=n290 A1=y_in[4] A2=FE_OFN45_n264 B1=N152 B2=FE_OFN46_n265
XU466 ND2 $PINS O=N500 I1=n292 I2=n293
XU467 AOI22S $PINS O=FE_PHN2007_n293 A1=N343 A2=n259 B1=N291 B2=FE_OFN41_n1
XU468 AOI22S $PINS O=n292 A1=y_in[3] A2=FE_OFN45_n264 B1=N151 B2=FE_OFN46_n265
XU469 ND2 $PINS O=N499 I1=n294 I2=n295
XU470 AOI22S $PINS O=n295 A1=N342 A2=n259 B1=N290 B2=FE_OFN41_n1
XU471 AOI22S $PINS O=n294 A1=y_in[2] A2=FE_OFN45_n264 B1=N150 B2=FE_OFN46_n265
XU472 ND2 $PINS O=N498 I1=n296 I2=n297
XU473 AOI22S $PINS O=n297 A1=N341 A2=n259 B1=N289 B2=FE_OFN41_n1
XU474 AOI22S $PINS O=n296 A1=y_in[1] A2=FE_OFN45_n264 B1=N149 B2=FE_OFN46_n265
XU475 ND2 $PINS O=N497 I1=n298 I2=n299
XU476 AOI22S $PINS O=n299 A1=N340 A2=n259 B1=N288 B2=FE_OFN41_n1
XU477 AOI22S $PINS O=n298 A1=FE_PHN1744_c_in_i_0_0 A2=FE_OFN45_n264
+ B1=FE_PHN1744_c_in_i_0_0 B2=FE_OFN46_n265
XU478 ND2 $PINS O=N496 I1=n300 I2=n301
XU479 AOI22S $PINS O=n301 A1=N339 A2=FE_OFN44_n259 B1=N287 B2=FE_OFN42_n1
XU480 AOI22S $PINS O=n300 A1=FE_PHN1704_c_in_r_0_16 A2=FE_OFN45_n264 B1=N147
+ B2=FE_OFN46_n265
XU481 ND2 $PINS O=N495 I1=n302 I2=n303
XU482 AOI22S $PINS O=n303 A1=N338 A2=FE_OFN44_n259 B1=N286 B2=FE_OFN42_n1
XU483 AOI22S $PINS O=n302 A1=FE_PHN1704_c_in_r_0_16 A2=FE_OFN45_n264 B1=N146
+ B2=FE_OFN46_n265
XU484 ND2 $PINS O=N494 I1=n304 I2=n305
XU485 AOI22S $PINS O=n305 A1=N337 A2=FE_OFN44_n259 B1=N285 B2=FE_OFN42_n1
XU486 AOI22S $PINS O=n304 A1=x_in[15] A2=FE_OFN45_n264 B1=N145 B2=FE_OFN46_n265
XU487 ND2 $PINS O=N493 I1=n306 I2=n307
XU488 AOI22S $PINS O=n307 A1=N336 A2=FE_OFN44_n259 B1=N284 B2=FE_OFN42_n1
XU489 AOI22S $PINS O=n306 A1=FE_PHN2081_c_in_r_0_14 A2=FE_OFN45_n264 B1=N144
+ B2=FE_OFN46_n265
XU490 ND2 $PINS O=N492 I1=n308 I2=n309
XU491 AOI22S $PINS O=n309 A1=N335 A2=FE_OFN44_n259 B1=N283 B2=FE_OFN42_n1
XU492 AOI22S $PINS O=n308 A1=x_in[13] A2=FE_OFN45_n264 B1=N143 B2=FE_OFN46_n265
XU493 ND2 $PINS O=N491 I1=n310 I2=n311
XU494 AOI22S $PINS O=n311 A1=N334 A2=FE_OFN44_n259 B1=N282 B2=FE_OFN42_n1
XU495 AOI22S $PINS O=n310 A1=x_in[12] A2=FE_OFN45_n264 B1=N142 B2=FE_OFN46_n265
XU496 ND2 $PINS O=N490 I1=n312 I2=n313
XU497 AOI22S $PINS O=n313 A1=N333 A2=FE_OFN44_n259 B1=N281 B2=FE_OFN42_n1
XU498 AOI22S $PINS O=n312 A1=x_in[11] A2=FE_OFN45_n264 B1=N141 B2=FE_OFN46_n265
XU499 ND2 $PINS O=N489 I1=n314 I2=n315
XU500 AOI22S $PINS O=n315 A1=N332 A2=FE_OFN44_n259 B1=N280 B2=FE_OFN42_n1
XU501 AOI22S $PINS O=n314 A1=x_in[10] A2=FE_OFN45_n264 B1=N140 B2=FE_OFN46_n265
XU502 ND2 $PINS O=N488 I1=n316 I2=n317
XU503 AOI22S $PINS O=n317 A1=N331 A2=FE_OFN44_n259 B1=N279 B2=FE_OFN41_n1
XU504 AOI22S $PINS O=n316 A1=x_in[9] A2=FE_OFN45_n264 B1=N139 B2=FE_OFN46_n265
XU505 ND2 $PINS O=N487 I1=n318 I2=n319
XU506 AOI22S $PINS O=n319 A1=N330 A2=FE_OFN44_n259 B1=N278 B2=FE_OFN41_n1
XU507 AOI22S $PINS O=n318 A1=x_in[8] A2=FE_OFN45_n264 B1=N138 B2=FE_OFN46_n265
XU508 ND2 $PINS O=N486 I1=n320 I2=n321
XU509 AOI22S $PINS O=FE_PHN2208_n321 A1=N329 A2=FE_OFN44_n259 B1=N277
+ B2=FE_OFN41_n1
XU510 AOI22S $PINS O=n320 A1=x_in[7] A2=FE_OFN45_n264 B1=N137 B2=FE_OFN46_n265
XU511 ND2 $PINS O=N485 I1=n322 I2=n323
XU512 AOI22S $PINS O=n323 A1=N328 A2=FE_OFN44_n259 B1=N276 B2=FE_OFN41_n1
XU513 AOI22S $PINS O=n322 A1=x_in[6] A2=FE_OFN45_n264 B1=N136 B2=FE_OFN46_n265
XU514 ND2 $PINS O=N484 I1=n324 I2=n325
XU515 AOI22S $PINS O=n325 A1=N327 A2=n259 B1=N275 B2=FE_OFN41_n1
XU516 AOI22S $PINS O=n324 A1=x_in[5] A2=FE_OFN45_n264 B1=N135 B2=FE_OFN46_n265
XU517 ND2 $PINS O=N483 I1=n326 I2=FE_PHN2020_n327
XU518 AOI22S $PINS O=n327 A1=N326 A2=n259 B1=N274 B2=FE_OFN41_n1
XU519 AOI22S $PINS O=n326 A1=x_in[4] A2=FE_OFN45_n264 B1=N134 B2=FE_OFN46_n265
XU520 ND2 $PINS O=N482 I1=n328 I2=n329
XU521 AOI22S $PINS O=n329 A1=N325 A2=n259 B1=N273 B2=FE_OFN41_n1
XU522 AOI22S $PINS O=n328 A1=x_in[3] A2=FE_OFN45_n264 B1=N133 B2=FE_OFN46_n265
XU523 ND2 $PINS O=N481 I1=FE_PHN2000_n330 I2=n331
XU524 AOI22S $PINS O=n331 A1=N324 A2=n259 B1=N272 B2=FE_OFN41_n1
XU525 AOI22S $PINS O=n330 A1=x_in[2] A2=FE_OFN45_n264 B1=N132 B2=FE_OFN46_n265
XU526 ND2 $PINS O=N480 I1=FE_PHN2004_n332 I2=n333
XU527 AOI22S $PINS O=n333 A1=N323 A2=n259 B1=N271 B2=FE_OFN41_n1
XU528 AOI22S $PINS O=n332 A1=x_in[1] A2=FE_OFN45_n264 B1=N131 B2=FE_OFN46_n265
XU529 ND2 $PINS O=N479 I1=n334 I2=n335
XU530 AOI22S $PINS O=n335 A1=N322 A2=n259 B1=N270 B2=FE_OFN41_n1
XU531 AOI22S $PINS O=n334 A1=FE_PHN2088_c_in_r_0_0 A2=FE_OFN45_n264
+ B1=FE_PHN2219_c_in_r_0_0 B2=FE_OFN46_n265
XU532 INV1S $PINS O=n264 I=n336
XU533 OAI112HS $PINS O=N478 A1=n338 B1=n339 C1=n337 C2=n336
XU534 AOI22S $PINS O=n339 A1=n337 A2=n340 B1=n337 B2=n341
XU535 AOI22S $PINS O=FE_PHN1922_n338 A1=N373 A2=n259 B1=N321 B2=n1
XU536 OAI112HS $PINS O=N477 A1=FE_PHN1935_n343 B1=n344 C1=n342 C2=n336
XU537 AOI22S $PINS O=n344 A1=N182 A2=n340 B1=N182 B2=n341
XU538 AOI22S $PINS O=n343 A1=N372 A2=n259 B1=N320 B2=FE_OFN42_n1
XU539 OAI112HS $PINS O=N476 A1=FE_PHN1989_n346 B1=n347 C1=n336 C2=n345
XU540 AOI22S $PINS O=n347 A1=N181 A2=n340 B1=N181 B2=n341
XU541 AOI22S $PINS O=n346 A1=N371 A2=n259 B1=N319 B2=n1
XU542 INV1S $PINS O=n345 I=N181
XU543 OAI112HS $PINS O=N475 A1=FE_PHN1979_n349 B1=n350 C1=n336 C2=n348
XU544 AOI22S $PINS O=n350 A1=N180 A2=n340 B1=N180 B2=n341
XU545 AOI22S $PINS O=n349 A1=N370 A2=n259 B1=N318 B2=n1
XU546 INV1S $PINS O=n348 I=N180
XU547 OAI112HS $PINS O=N474 A1=n352 B1=n353 C1=n336 C2=n351
XU548 AOI22S $PINS O=n353 A1=N179 A2=n340 B1=N179 B2=n341
XU549 AOI22S $PINS O=FE_PHN1974_n352 A1=N369 A2=n259 B1=N317 B2=n1
XU550 OAI112HS $PINS O=N473 A1=n355 B1=n356 C1=n336 C2=n354
XU551 AOI22S $PINS O=n356 A1=N178 A2=n340 B1=N178 B2=n341
XU552 AOI22S $PINS O=n355 A1=N368 A2=n259 B1=N316 B2=n1
XU553 OAI112HS $PINS O=N472 A1=n358 B1=n359 C1=n336 C2=p1
XU554 AOI22S $PINS O=n359 A1=N177 A2=n340 B1=N177 B2=n341
XU555 AN2 $PINS O=n341 I1=n265 I2=phase_in[15]
XU556 AN2 $PINS O=n340 I1=n265 I2=n337
XU557 AOI12HS $PINS O=n265 A1=n362 B1=n360 B2=n361
XU558 AOI22S $PINS O=n358 A1=N367 A2=n259 B1=N315 B2=n1
XU559 AN2 $PINS O=n259 I1=z_reg[15] I2=is_computing
XU561 OR3B2 $PINS O=n336 I1=n362 B1=n361 B2=n360
XU562 ND2 $PINS O=n360 I1=phase_in[15] I2=n342
XU563 INV1S $PINS O=n342 I=N182
XU564 ND3 $PINS O=n361 I1=n363 I2=n337 I3=N182
XU565 INV1S $PINS O=n337 I=phase_in[15]
XU566 ND3 $PINS O=n363 I1=n354 I2=n351 I3=n364
XU567 NR3 $PINS O=n364 I1=N180 I2=N177 I3=N181
XU568 INV1S $PINS O=n351 I=N179
XU569 INV1S $PINS O=n354 I=N178
XU570 ND2 $PINS O=N462 I1=n260 I2=n362
XU571 MOAI1S $PINS O=N461 A1=n365 A2=n258 B1=is_computing B2=n141
XU573 NR2 $PINS O=n366 I1=step_cnt[3] I2=n255
XU574 OAI22S $PINS O=N460 A1=n367 A2=n256 B1=n261 B2=n260
XU575 MOAI1S $PINS O=FE_PHN2051_N459 A1=n255 A2=n368 B1=n257 B2=is_computing
XU576 INV1S $PINS O=N458 I=n368
XU577 ND2 $PINS O=FE_PHN1832_N457 I1=n362 I2=n370
XU578 OAI12HS $PINS O=n370 A1=is_computing B1=n258 B2=FE_OFN300_n261
XU579 ND2 $PINS O=n362 I1=valid_in I2=n260
XU580 INV1S $PINS O=n260 I=is_computing
XU581 ND3 $PINS O=N118 I1=n371 I2=n372 I3=n373
XU582 AN2 $PINS O=n373 I1=FE_OFN300_n261 I2=n251
XU583 OAI112HS $PINS O=N117 A1=n253 B1=n374 C1=n255 C2=n258
XU584 AN3 $PINS O=n374 I1=n251 I2=n153 I3=n252
XU585 OAI112HS $PINS O=N116 A1=n253 B1=n72 C1=n258 C2=n369
XU586 OAI112HS $PINS O=N115 A1=n251 B1=n153 C1=n257 C2=n258
XU587 OA13S $PINS O=n372 A1=n252 B1=step_cnt[0] B2=step_cnt[1] B3=n258
XU588 AOI13HS $PINS O=n371 A1=n29 B1=step_cnt[0] B2=step_cnt[1] B3=step_cnt[2]
XU589 OR3B2 $PINS O=N111 I1=N109 B1=n153 B2=n252
XU590 ND3 $PINS O=N110 I1=n153 I2=FE_OFN300_n261 I3=n253
XU591 NR2 $PINS O=n254 I1=step_cnt[2] I2=step_cnt[0]
XU592 ND3 $PINS O=n72 I1=n256 I2=n258 I3=n257
Xstep_cnt_reg[2] DFFRBN $PINS Q=step_cnt[2] QB=n256 D=FE_PHN2050_N460
+ CK=net2457 RB=FE_OFN19_i_rst_n
XU13 OR3B2S $PINS O=n5 I1=n256 B1=step_cnt[0] B2=n366
Xclk_gate_y_reg_reg SNPS_CLOCK_GATE_HIGH_cordic_rotation_1_0 $PINS EN=N462
+ ENCLK=CTS_45 CLK=clk_clone4
Xclk_gate_z_reg_reg SNPS_CLOCK_GATE_HIGH_cordic_rotation_1_4 $PINS EN=N462
+ ENCLK=CTS_42 CLK=clk_clone4
Xclk_gate_y_out_reg SNPS_CLOCK_GATE_HIGH_cordic_rotation_1_3 $PINS EN=N515
+ ENCLK=CTS_39 CLK=clk_clone4
Xclk_gate_x_out_reg SNPS_CLOCK_GATE_HIGH_cordic_rotation_1_2 $PINS
+ CLK=clk_clone2 EN=N515 ENCLK=CTS_48 CLK_clone1=clk_clone3
Xclk_gate_step_cnt_reg SNPS_CLOCK_GATE_HIGH_cordic_rotation_1_1 $PINS EN=N457
+ ENCLK=net2457 CLK=clk_clone1
Xadd_105 cordic_rotation_1_DW01_add_2_DW01_add_8 $PINS A[15]=z_reg[15]
+ A[14]=z_reg[14] A[13]=z_reg[13] A[12]=z_reg[12] A[11]=z_reg[11] A[10]=z_reg[10]
+ A[9]=z_reg[9] A[8]=FE_PHN1508_z_reg_8 A[7]=FE_PHN1594_z_reg_7 A[6]=z_reg[6]
+ A[5]=z_reg[5] A[4]=z_reg[4] A[3]=z_reg[3] A[2]=z_reg[2] A[1]=z_reg[1]
+ A[0]=FE_PHN1729_z_reg_0 B[15]=n8 B[14]=n8 B[13]=n2 B[12]=n9 B[11]=n29
+ B[10]=N108 B[9]=N109 B[8]=N110 B[7]=N111 B[6]=N112 B[5]=N113 B[4]=N114
+ B[3]=N115 B[2]=N116 B[1]=N117 B[0]=N118 CI=n8 SUM[15]=N373 SUM[14]=N372
+ SUM[13]=N371 SUM[12]=N370 SUM[11]=N369 SUM[10]=N368 SUM[9]=N367 SUM[8]=N366
+ SUM[7]=N365 SUM[6]=N364 SUM[5]=N363 SUM[4]=N362 SUM[3]=N361 SUM[2]=N360
+ SUM[1]=N359 SUM[0]=N358
Xsub_104 cordic_rotation_1_DW01_sub_0_DW01_sub_34 $PINS A[17]=y_reg[17]
+ A[16]=y_reg[16] A[15]=y_reg[15] A[14]=y_reg[14] A[13]=y_reg[13]
+ A[12]=FE_PHN1731_y_reg_12 A[11]=y_reg[11] A[10]=y_reg[10] A[9]=y_reg[9]
+ A[8]=y_reg[8] A[7]=y_reg[7] A[6]=FE_PHN1771_y_reg_6 A[5]=FE_PHN1770_y_reg_5
+ A[4]=y_reg[4] A[3]=y_reg[3] A[2]=FE_PHN1723_y_reg_2 A[1]=y_reg[1] A[0]=y_reg[0]
+ B[17]=x_shift[16] B[16]=x_shift[16] B[15]=x_shift[15] B[14]=x_shift[14]
+ B[13]=x_shift[13] B[12]=x_shift[12] B[11]=x_shift[11] B[10]=x_shift[10]
+ B[9]=x_shift[9] B[8]=x_shift[8] B[7]=x_shift[7] B[6]=x_shift[6] B[5]=x_shift[5]
+ B[4]=x_shift[4] B[3]=x_shift[3] B[2]=x_shift[2] B[1]=x_shift[1] B[0]=x_shift[0]
+ CI=n8 DIFF[17]=N357 DIFF[16]=N356 DIFF[15]=N355 DIFF[14]=N354 DIFF[13]=N353
+ DIFF[12]=N352 DIFF[11]=N351 DIFF[10]=N350 DIFF[9]=N349 DIFF[8]=N348
+ DIFF[7]=N347 DIFF[6]=N346 DIFF[5]=N345 DIFF[4]=N344 DIFF[3]=N343 DIFF[2]=N342
+ DIFF[1]=N341 DIFF[0]=N340
Xadd_103 cordic_rotation_1_DW01_add_3_DW01_add_9 $PINS A[17]=x_reg[17]
+ A[16]=FE_PHN1775_x_reg_16 A[15]=x_reg[15] A[14]=x_reg[14] A[13]=x_reg[13]
+ A[12]=x_reg[12] A[11]=x_reg[11] A[10]=FE_PHN2192_x_reg_10
+ A[9]=FE_PHN1774_x_reg_9 A[8]=x_reg[8] A[7]=x_reg[7] A[6]=FE_PHN2178_x_reg_6
+ A[5]=x_reg[5] A[4]=x_reg[4] A[3]=x_reg[3] A[2]=x_reg[2] A[1]=x_reg[1]
+ A[0]=FE_PHN1769_x_reg_0 B[17]=y_shift[16] B[16]=y_shift[16] B[15]=y_shift[15]
+ B[14]=y_shift[14] B[13]=y_shift[13] B[12]=y_shift[12] B[11]=y_shift[11]
+ B[10]=y_shift[10] B[9]=y_shift[9] B[8]=y_shift[8] B[7]=y_shift[7]
+ B[6]=y_shift[6] B[5]=y_shift[5] B[4]=y_shift[4] B[3]=y_shift[3] B[2]=y_shift[2]
+ B[1]=y_shift[1] B[0]=y_shift[0] CI=n8 SUM[17]=N339 SUM[16]=N338 SUM[15]=N337
+ SUM[14]=N336 SUM[13]=N335 SUM[12]=N334 SUM[11]=N333 SUM[10]=N332 SUM[9]=N331
+ SUM[8]=N330 SUM[7]=N329 SUM[6]=N328 SUM[5]=N327 SUM[4]=N326 SUM[3]=N325
+ SUM[2]=N324 SUM[1]=N323 SUM[0]=N322
Xsub_101 cordic_rotation_1_DW01_sub_1_DW01_sub_35 $PINS A[15]=z_reg[15]
+ A[14]=z_reg[14] A[13]=z_reg[13] A[12]=z_reg[12] A[11]=z_reg[11] A[10]=z_reg[10]
+ A[9]=z_reg[9] A[8]=FE_PHN1508_z_reg_8 A[7]=FE_PHN1594_z_reg_7 A[6]=z_reg[6]
+ A[5]=z_reg[5] A[4]=z_reg[4] A[3]=z_reg[3] A[2]=z_reg[2] A[1]=z_reg[1]
+ A[0]=FE_PHN1729_z_reg_0 B[15]=n8 B[14]=n8 B[13]=FE_DBTN15_n2 B[12]=n9 B[11]=n29
+ B[10]=N108 B[9]=N109 B[8]=N110 B[7]=N111 B[6]=N112 B[5]=N113 B[4]=N114
+ B[3]=N115 B[2]=N116 B[1]=N117 B[0]=N118 CI=n8 DIFF[15]=N321 DIFF[14]=N320
+ DIFF[13]=N319 DIFF[12]=N318 DIFF[11]=N317 DIFF[10]=N316 DIFF[9]=N315
+ DIFF[8]=N314 DIFF[7]=N313 DIFF[6]=N312 DIFF[5]=N311 DIFF[4]=N310 DIFF[3]=N309
+ DIFF[2]=N308 DIFF[1]=N307 DIFF[0]=N306 n72=n72 n261=FE_OFN300_n261
Xadd_100 cordic_rotation_1_DW01_add_4_DW01_add_10 $PINS A[17]=y_reg[17]
+ A[16]=y_reg[16] A[15]=y_reg[15] A[14]=y_reg[14] A[13]=y_reg[13]
+ A[12]=FE_PHN1731_y_reg_12 A[11]=y_reg[11] A[10]=y_reg[10] A[9]=y_reg[9]
+ A[8]=y_reg[8] A[7]=y_reg[7] A[6]=FE_PHN1771_y_reg_6 A[5]=FE_PHN1770_y_reg_5
+ A[4]=y_reg[4] A[3]=y_reg[3] A[2]=FE_PHN1723_y_reg_2 A[1]=y_reg[1] A[0]=y_reg[0]
+ B[17]=x_shift[16] B[16]=x_shift[16] B[15]=x_shift[15] B[14]=x_shift[14]
+ B[13]=x_shift[13] B[12]=x_shift[12] B[11]=x_shift[11] B[10]=x_shift[10]
+ B[9]=x_shift[9] B[8]=x_shift[8] B[7]=x_shift[7] B[6]=x_shift[6] B[5]=x_shift[5]
+ B[4]=x_shift[4] B[3]=x_shift[3] B[2]=x_shift[2] B[1]=x_shift[1] B[0]=x_shift[0]
+ CI=n8 SUM[17]=N305 SUM[16]=N304 SUM[15]=N303 SUM[14]=N302 SUM[13]=N301
+ SUM[12]=N300 SUM[11]=N299 SUM[10]=N298 SUM[9]=N297 SUM[8]=N296 SUM[7]=N295
+ SUM[6]=N294 SUM[5]=N293 SUM[4]=N292 SUM[3]=N291 SUM[2]=N290 SUM[1]=N289
+ SUM[0]=N288
Xsub_99 cordic_rotation_1_DW01_sub_2_DW01_sub_36 $PINS A[17]=x_reg[17]
+ A[16]=FE_PHN1775_x_reg_16 A[15]=x_reg[15] A[14]=x_reg[14] A[13]=x_reg[13]
+ A[12]=x_reg[12] A[11]=x_reg[11] A[10]=FE_PHN2192_x_reg_10
+ A[9]=FE_PHN1774_x_reg_9 A[8]=x_reg[8] A[7]=x_reg[7] A[6]=FE_PHN2178_x_reg_6
+ A[5]=x_reg[5] A[4]=x_reg[4] A[3]=x_reg[3] A[2]=x_reg[2] A[1]=x_reg[1]
+ A[0]=FE_PHN1769_x_reg_0 B[17]=y_shift[16] B[16]=y_shift[16] B[15]=y_shift[15]
+ B[14]=y_shift[14] B[13]=y_shift[13] B[12]=y_shift[12] B[11]=y_shift[11]
+ B[10]=y_shift[10] B[9]=y_shift[9] B[8]=y_shift[8] B[7]=y_shift[7]
+ B[6]=y_shift[6] B[5]=y_shift[5] B[4]=y_shift[4] B[3]=y_shift[3] B[2]=y_shift[2]
+ B[1]=y_shift[1] B[0]=y_shift[0] CI=n8 DIFF[17]=N287 DIFF[16]=N286 DIFF[15]=N285
+ DIFF[14]=N284 DIFF[13]=N283 DIFF[12]=N282 DIFF[11]=N281 DIFF[10]=N280
+ DIFF[9]=N279 DIFF[8]=N278 DIFF[7]=N277 DIFF[6]=N276 DIFF[5]=N275 DIFF[4]=N274
+ DIFF[3]=N273 DIFF[2]=N272 DIFF[1]=N271 DIFF[0]=N270
.ENDS

.SUBCKT SNPS_CLOCK_GATE_HIGH_cordic_rotation_0_0 EN ENCLK CLK
*.CONNECT net2392 EN
XFE_PHC1321_net2395 DELC $PINS O=FE_PHN1321_net2395 I=net2395
Xlatch QDBHN $PINS Q=net2395 D=net2392 CKB=CLK
Xmain_gate AN2T $PINS O=ENCLK I1=FE_PHN1321_net2395 I2=CLK
.ENDS

.SUBCKT SNPS_CLOCK_GATE_HIGH_cordic_rotation_0_4 CLK EN ENCLK CLK_clone1
*.CONNECT net2389 CLK
*.CONNECT net2392 EN
XFE_PHC2104_net2395 BUF1CK $PINS O=net2395 I=FE_PHN2104_net2395
XFE_PHC1438_net2395 DELC $PINS O=FE_PHN1438_net2395 I=net2395
Xlatch QDBHN $PINS Q=FE_PHN2104_net2395 D=net2392 CKB=CLK_clone1
Xmain_gate AN2T $PINS O=ENCLK I1=FE_PHN1438_net2395 I2=net2389
.ENDS

.SUBCKT SNPS_CLOCK_GATE_HIGH_cordic_rotation_0_3 EN ENCLK CLK
*.CONNECT ENCLK net2391
*.CONNECT net2392 EN
XFE_PHC1337_net2395 DELC $PINS O=net2395 I=FE_PHN1337_net2395
Xlatch QDBHN $PINS Q=FE_PHN1337_net2395 D=net2392 CKB=CLK
Xmain_gate AN2T $PINS O=net2391 I1=net2395 I2=CLK
.ENDS

.SUBCKT SNPS_CLOCK_GATE_HIGH_cordic_rotation_0_2 EN ENCLK CLK
*.CONNECT net2392 EN
XFE_PHC1320_net2395 DELC $PINS O=net2395 I=FE_PHN1320_net2395
Xlatch QDBHN $PINS Q=FE_PHN1320_net2395 D=net2392 CKB=CLK
Xmain_gate AN2 $PINS O=ENCLK I1=net2395 I2=CLK
.ENDS

.SUBCKT SNPS_CLOCK_GATE_HIGH_cordic_rotation_0_1 EN ENCLK CLK
*.CONNECT ENCLK net2391
*.CONNECT net2392 EN
XFE_PHC1289_net2395 DELC $PINS O=net2395 I=FE_PHN1289_net2395
Xlatch QDBHN $PINS Q=FE_PHN1289_net2395 D=net2392 CKB=CLK
Xmain_gate AN2 $PINS O=net2391 I1=net2395 I2=CLK
.ENDS

.SUBCKT cordic_rotation_0_DW01_add_2 A[15] A[14] A[13] A[12] A[11] A[10] A[9]
+ A[8] A[7] A[6] A[5] A[4] A[3] A[2] A[1] A[0] B[15] B[14] B[13] B[12] B[11]
+ B[10] B[9] B[8] B[7] B[6] B[5] B[4] B[3] B[2] B[1] B[0] CI SUM[15] SUM[14]
+ SUM[13] SUM[12] SUM[11] SUM[10] SUM[9] SUM[8] SUM[7] SUM[6] SUM[5] SUM[4]
+ SUM[3] SUM[2] SUM[1] SUM[0] CO
XU1_12 FA1S $PINS S=SUM[12] CO=carry[13] A=A[12] B=B[12] CI=carry[12]
XU1_11 FA1S $PINS S=SUM[11] CO=carry[12] A=A[11] B=B[11] CI=carry[11]
XU1_5 FA1S $PINS S=SUM[5] CO=carry[6] A=A[5] B=B[5] CI=carry[5]
XU1_7 FA1S $PINS S=SUM[7] CO=carry[8] A=A[7] B=B[7] CI=carry[7]
XU1_6 FA1S $PINS S=SUM[6] CO=carry[7] A=A[6] B=B[6] CI=carry[6]
XU1_8 FA1S $PINS S=SUM[8] CO=carry[9] A=A[8] B=B[8] CI=carry[8]
XU1_9 FA1S $PINS S=SUM[9] CO=carry[10] A=A[9] B=B[9] CI=carry[9]
XU1_10 FA1S $PINS S=SUM[10] CO=carry[11] A=A[10] B=B[10] CI=carry[10]
XU1_4 FA1S $PINS S=SUM[4] CO=carry[5] A=A[4] B=B[4] CI=carry[4]
XU1_2 FA1S $PINS S=SUM[2] CO=carry[3] A=A[2] B=B[2] CI=carry[2]
XU1_3 FA1S $PINS S=SUM[3] CO=carry[4] A=A[3] B=B[3] CI=carry[3]
XU1_1 FA1S $PINS S=SUM[1] CO=carry[2] A=A[1] B=B[1] CI=n1
XU1_13 FA1S $PINS S=SUM[13] CO=carry[14] A=A[13] B=B[13] CI=carry[13]
XU1 AN2 $PINS O=n1 I1=B[0] I2=A[0]
XU2 XNR2HS $PINS O=SUM[15] I1=A[15] I2=n2
XU3 XOR2HS $PINS O=SUM[14] I1=A[14] I2=carry[14]
XU4 XOR2HS $PINS O=SUM[0] I1=B[0] I2=A[0]
XU5 ND2 $PINS O=n2 I1=A[14] I2=carry[14]
.ENDS

.SUBCKT cordic_rotation_0_DW01_sub_0_DW01_sub_28 A[17] A[16] A[15] A[14] A[13]
+ A[12] A[11] A[10] A[9] A[8] A[7] A[6] A[5] A[4] A[3] A[2] A[1] A[0] B[17]
+ B[16] B[15] B[14] B[13] B[12] B[11] B[10] B[9] B[8] B[7] B[6] B[5] B[4] B[3]
+ B[2] B[1] B[0] CI DIFF[17] DIFF[16] DIFF[15] DIFF[14] DIFF[13] DIFF[12]
+ DIFF[11] DIFF[10] DIFF[9] DIFF[8] DIFF[7] DIFF[6] DIFF[5] DIFF[4] DIFF[3]
+ DIFF[2] DIFF[1] DIFF[0] CO
XU2_2 FA1 $PINS S=DIFF[2] CO=carry[3] A=A[2] B=n12 CI=carry[2]
XU2_3 FA1 $PINS S=DIFF[3] CO=carry[4] A=A[3] B=n13 CI=carry[3]
XU2_1 FA1 $PINS S=DIFF[1] CO=carry[2] A=A[1] B=n11 CI=carry[1]
XU2_6 FA1 $PINS S=DIFF[6] CO=carry[7] A=A[6] B=n16 CI=carry[6]
XU2_14 FA1S $PINS S=DIFF[14] CO=carry[15] A=A[14] B=n6 CI=carry[14]
XU2_15 FA1S $PINS S=DIFF[15] CO=carry[16] A=A[15] B=n7 CI=carry[15]
XU2_16 FA1S $PINS S=DIFF[16] CO=carry[17] A=A[16] B=n8 CI=carry[16]
XU2_9 FA1S $PINS S=DIFF[9] CO=carry[10] A=A[9] B=n10 CI=carry[9]
XU2_7 FA1 $PINS S=DIFF[7] CO=carry[8] A=A[7] B=n17 CI=carry[7]
XU2_8 FA1 $PINS S=DIFF[8] CO=carry[9] A=A[8] B=n18 CI=carry[8]
XU2_5 FA1 $PINS S=DIFF[5] CO=carry[6] A=A[5] B=n15 CI=carry[5]
XU2_4 FA1S $PINS S=DIFF[4] CO=carry[5] A=A[4] B=n14 CI=carry[4]
XU2_11 FA1 $PINS S=DIFF[11] CO=carry[12] A=A[11] B=n4 CI=carry[11]
XU2_12 FA1S $PINS S=DIFF[12] CO=carry[13] A=A[12] B=n9 CI=carry[12]
XU2_10 FA1 $PINS S=DIFF[10] CO=carry[11] A=A[10] B=n3 CI=carry[10]
XU2_13 FA1S $PINS S=DIFF[13] CO=carry[14] A=A[13] B=n5 CI=carry[13]
XU2_17 XOR3S $PINS O=DIFF[17] I1=A[17] I2=n8 I3=carry[17]
XU1 INV1S $PINS O=n2 I=B[0]
XU2 INV1S $PINS O=n8 I=B[17]
XU3 INV1S $PINS O=n5 I=B[13]
XU4 INV1S $PINS O=n3 I=B[10]
XU5 INV1S $PINS O=n9 I=B[12]
XU6 INV1S $PINS O=n4 I=B[11]
XU7 INV1S $PINS O=n14 I=B[4]
XU8 INV1S $PINS O=n15 I=B[5]
XU9 INV1S $PINS O=n18 I=B[8]
XU10 INV1S $PINS O=n17 I=B[7]
XU11 INV1S $PINS O=n10 I=B[9]
XU12 INV1S $PINS O=n7 I=B[15]
XU13 INV1S $PINS O=n6 I=B[14]
XU14 INV1S $PINS O=n16 I=B[6]
XU15 INV1S $PINS O=n11 I=B[1]
XU16 INV1S $PINS O=n1 I=A[0]
XU17 INV1S $PINS O=n13 I=B[3]
XU18 INV1S $PINS O=n12 I=B[2]
XU19 XNR2HS $PINS O=DIFF[0] I1=n2 I2=A[0]
XU20 ND2 $PINS O=carry[1] I1=B[0] I2=n1
.ENDS

.SUBCKT cordic_rotation_0_DW01_add_3 A[17] A[16] A[15] A[14] A[13] A[12] A[11]
+ A[10] A[9] A[8] A[7] A[6] A[5] A[4] A[3] A[2] A[1] A[0] B[17] B[16] B[15]
+ B[14] B[13] B[12] B[11] B[10] B[9] B[8] B[7] B[6] B[5] B[4] B[3] B[2] B[1]
+ B[0] CI SUM[17] SUM[16] SUM[15] SUM[14] SUM[13] SUM[12] SUM[11] SUM[10]
+ SUM[9] SUM[8] SUM[7] SUM[6] SUM[5] SUM[4] SUM[3] SUM[2] SUM[1] SUM[0] CO
XU1_14 FA1S $PINS S=SUM[14] CO=carry[15] A=A[14] B=B[14] CI=carry[14]
XU1_1 FA1 $PINS S=SUM[1] CO=carry[2] A=A[1] B=B[1] CI=n1
XU1_9 FA1 $PINS S=SUM[9] CO=carry[10] A=A[9] B=B[9] CI=carry[9]
XU1_6 FA1 $PINS S=SUM[6] CO=carry[7] A=A[6] B=B[6] CI=carry[6]
XU1_5 FA1S $PINS S=SUM[5] CO=carry[6] A=A[5] B=B[5] CI=carry[5]
XU1_4 FA1 $PINS S=SUM[4] CO=carry[5] A=A[4] B=B[4] CI=carry[4]
XU1_3 FA1 $PINS S=SUM[3] CO=carry[4] A=A[3] B=B[3] CI=carry[3]
XU1_8 FA1S $PINS S=SUM[8] CO=carry[9] A=A[8] B=B[8] CI=carry[8]
XU1_7 FA1S $PINS S=SUM[7] CO=carry[8] A=A[7] B=B[7] CI=carry[7]
XU1_2 FA1 $PINS S=SUM[2] CO=carry[3] A=A[2] B=B[2] CI=carry[2]
XU1_11 FA1S $PINS S=SUM[11] CO=carry[12] A=A[11] B=B[11] CI=carry[11]
XU1_12 FA1 $PINS S=SUM[12] CO=carry[13] A=A[12] B=B[12] CI=carry[12]
XU1_10 FA1 $PINS S=SUM[10] CO=carry[11] A=A[10] B=B[10] CI=carry[10]
XU1_13 FA1 $PINS S=SUM[13] CO=carry[14] A=A[13] B=B[13] CI=carry[13]
XU1_15 FA1S $PINS S=SUM[15] CO=carry[16] A=A[15] B=B[15] CI=carry[15]
XU1_16 FA1S $PINS S=SUM[16] CO=carry[17] A=A[16] B=B[16] CI=carry[16]
XU1_17 XOR3S $PINS O=SUM[17] I1=A[17] I2=B[17] I3=carry[17]
XU1 AN2 $PINS O=n1 I1=B[0] I2=A[0]
XU2 XOR2HS $PINS O=SUM[0] I1=B[0] I2=A[0]
.ENDS

.SUBCKT cordic_rotation_0_DW01_sub_1_DW01_sub_29 A[15] A[14] A[13] A[12] A[11]
+ A[10] A[9] A[8] A[7] A[6] A[5] A[4] A[3] A[2] A[1] A[0] B[15] B[14] B[13]
+ B[12] B[11] B[10] B[9] B[8] B[7] B[6] B[5] B[4] B[3] B[2] B[1] B[0] CI
+ DIFF[15] DIFF[14] DIFF[13] DIFF[12] DIFF[11] DIFF[10] DIFF[9] DIFF[8] DIFF[7]
+ DIFF[6] DIFF[5] DIFF[4] DIFF[3] DIFF[2] DIFF[1] DIFF[0] CO n56 n244
+ FE_OFN303_n244
XU2_12 FA1S $PINS S=DIFF[12] CO=carry[13] A=A[12] B=n56 CI=carry[12]
XU2_11 FA1S $PINS S=DIFF[11] CO=carry[12] A=A[11] B=n2 CI=carry[11]
XU2_10 FA1S $PINS S=DIFF[10] CO=carry[11] A=A[10] B=FE_OFN303_n244 CI=carry[10]
XU2_9 FA1S $PINS S=DIFF[9] CO=carry[10] A=A[9] B=n11 CI=carry[9]
XU2_8 FA1S $PINS S=DIFF[8] CO=carry[9] A=A[8] B=n14 CI=carry[8]
XU2_7 FA1S $PINS S=DIFF[7] CO=carry[8] A=A[7] B=n8 CI=carry[7]
XU2_6 FA1S $PINS S=DIFF[6] CO=carry[7] A=A[6] B=n15 CI=carry[6]
XU2_5 FA1S $PINS S=DIFF[5] CO=carry[6] A=A[5] B=n9 CI=carry[5]
XU2_4 FA1S $PINS S=DIFF[4] CO=carry[5] A=A[4] B=n6 CI=carry[4]
XU2_3 FA1S $PINS S=DIFF[3] CO=carry[4] A=A[3] B=n12 CI=carry[3]
XU2_2 FA1S $PINS S=DIFF[2] CO=carry[3] A=A[2] B=n5 CI=carry[2]
XU2_1 FA1S $PINS S=DIFF[1] CO=carry[2] A=A[1] B=n7 CI=carry[1]
XU2_13 FA1S $PINS S=DIFF[13] CO=carry[14] A=A[13] B=B[13] CI=carry[13]
XU1 OR2 $PINS O=carry[15] I1=carry[14] I2=A[14]
XU2 INV1S $PINS O=n10 I=B[0]
XU4 XNR2HS $PINS O=DIFF[15] I1=A[15] I2=carry[15]
XU5 INV1S $PINS O=n7 I=B[1]
XU6 INV1S $PINS O=n1 I=A[0]
XU7 INV1S $PINS O=n5 I=B[2]
XU8 INV1S $PINS O=n12 I=B[3]
XU9 INV1S $PINS O=n6 I=B[4]
XU10 INV1S $PINS O=n9 I=B[5]
XU11 INV1S $PINS O=n15 I=B[6]
XU12 INV1S $PINS O=n8 I=B[7]
XU13 INV1S $PINS O=n14 I=B[8]
XU14 INV1S $PINS O=n11 I=B[9]
XU16 INV1S $PINS O=n2 I=B[11]
XU18 XNR2HS $PINS O=DIFF[14] I1=A[14] I2=carry[14]
XU19 XNR2HS $PINS O=DIFF[0] I1=n10 I2=A[0]
XU20 ND2 $PINS O=carry[1] I1=B[0] I2=n1
.ENDS

.SUBCKT cordic_rotation_0_DW01_add_4 A[17] A[16] A[15] A[14] A[13] A[12] A[11]
+ A[10] A[9] A[8] A[7] A[6] A[5] A[4] A[3] A[2] A[1] A[0] B[17] B[16] B[15]
+ B[14] B[13] B[12] B[11] B[10] B[9] B[8] B[7] B[6] B[5] B[4] B[3] B[2] B[1]
+ B[0] CI SUM[17] SUM[16] SUM[15] SUM[14] SUM[13] SUM[12] SUM[11] SUM[10]
+ SUM[9] SUM[8] SUM[7] SUM[6] SUM[5] SUM[4] SUM[3] SUM[2] SUM[1] SUM[0] CO
XFE_PHC2012_N290 BUF1CK $PINS O=SUM[2] I=FE_PHN2012_N290
XFE_RC_8_0 XNR2HS $PINS O=FE_RN_0_0 I1=B[8] I2=A[8]
XFE_RC_7_0 ND2S $PINS O=FE_RN_1_0 I1=A[8] I2=B[8]
XFE_RC_6_0 ND2S $PINS O=FE_RN_2_0 I1=FE_RN_5_0 I2=FE_RN_1_0
XFE_RC_5_0 ND2 $PINS O=FE_RN_3_0 I1=carry[8] I2=FE_RN_2_0
XFE_RC_4_0 OAI12HS $PINS O=SUM[8] A1=FE_RN_3_0 B1=carry[8] B2=FE_RN_0_0
XFE_RC_2_0 OR2 $PINS O=FE_RN_5_0 I1=B[8] I2=A[8]
XFE_RC_1_0 ND2 $PINS O=FE_RN_6_0 I1=FE_RN_5_0 I2=carry[8]
XFE_RC_0_0 ND2 $PINS O=carry[9] I1=FE_RN_6_0 I2=FE_RN_1_0
XU1_14 FA1S $PINS S=SUM[14] CO=carry[15] A=A[14] B=B[14] CI=carry[14]
XU1_1 FA1 $PINS S=SUM[1] CO=carry[2] A=A[1] B=B[1] CI=n1
XU1_9 FA1 $PINS S=SUM[9] CO=carry[10] A=A[9] B=B[9] CI=carry[9]
XU1_6 FA1 $PINS S=SUM[6] CO=carry[7] A=A[6] B=B[6] CI=carry[6]
XU1_5 FA1S $PINS S=SUM[5] CO=carry[6] A=A[5] B=B[5] CI=carry[5]
XU1_4 FA1 $PINS S=SUM[4] CO=carry[5] A=A[4] B=B[4] CI=carry[4]
XU1_3 FA1S $PINS S=SUM[3] CO=carry[4] A=A[3] B=B[3] CI=carry[3]
XU1_7 FA1S $PINS S=SUM[7] CO=carry[8] A=A[7] B=B[7] CI=carry[7]
XU1_2 FA1 $PINS S=FE_PHN2012_N290 CO=carry[3] A=A[2] B=B[2] CI=carry[2]
XU1_11 FA1 $PINS S=SUM[11] CO=carry[12] A=A[11] B=B[11] CI=carry[11]
XU1_12 FA1 $PINS S=SUM[12] CO=carry[13] A=A[12] B=B[12] CI=carry[12]
XU1_10 FA1 $PINS S=SUM[10] CO=carry[11] A=A[10] B=B[10] CI=carry[10]
XU1_13 FA1S $PINS S=SUM[13] CO=carry[14] A=A[13] B=B[13] CI=carry[13]
XU1_15 FA1 $PINS S=SUM[15] CO=carry[16] A=A[15] B=B[15] CI=carry[15]
XU1_16 FA1S $PINS S=SUM[16] CO=carry[17] A=A[16] B=B[16] CI=carry[16]
XU1_17 XOR3S $PINS O=SUM[17] I1=A[17] I2=B[17] I3=carry[17]
XU1 AN2 $PINS O=n1 I1=B[0] I2=A[0]
XU2 XOR2HS $PINS O=SUM[0] I1=B[0] I2=A[0]
.ENDS

.SUBCKT cordic_rotation_0_DW01_sub_2_DW01_sub_30 A[17] A[16] A[15] A[14] A[13]
+ A[12] A[11] A[10] A[9] A[8] A[7] A[6] A[5] A[4] A[3] A[2] A[1] A[0] B[17]
+ B[16] B[15] B[14] B[13] B[12] B[11] B[10] B[9] B[8] B[7] B[6] B[5] B[4] B[3]
+ B[2] B[1] B[0] CI DIFF[17] DIFF[16] DIFF[15] DIFF[14] DIFF[13] DIFF[12]
+ DIFF[11] DIFF[10] DIFF[9] DIFF[8] DIFF[7] DIFF[6] DIFF[5] DIFF[4] DIFF[3]
+ DIFF[2] DIFF[1] DIFF[0] CO
XU2_2 FA1 $PINS S=DIFF[2] CO=carry[3] A=A[2] B=n12 CI=carry[2]
XU2_3 FA1 $PINS S=DIFF[3] CO=carry[4] A=A[3] B=n13 CI=carry[3]
XU2_1 FA1S $PINS S=DIFF[1] CO=carry[2] A=A[1] B=n11 CI=carry[1]
XU2_14 FA1 $PINS S=DIFF[14] CO=carry[15] A=A[14] B=n4 CI=carry[14]
XU2_6 FA1S $PINS S=DIFF[6] CO=carry[7] A=A[6] B=n16 CI=carry[6]
XU2_15 FA1 $PINS S=DIFF[15] CO=carry[16] A=A[15] B=n3 CI=carry[15]
XU2_16 FA1S $PINS S=DIFF[16] CO=carry[17] A=A[16] B=n2 CI=carry[16]
XU2_9 FA1S $PINS S=DIFF[9] CO=carry[10] A=A[9] B=n9 CI=carry[9]
XU2_7 FA1S $PINS S=DIFF[7] CO=carry[8] A=A[7] B=n17 CI=carry[7]
XU2_8 FA1S $PINS S=DIFF[8] CO=carry[9] A=A[8] B=n18 CI=carry[8]
XU2_5 FA1 $PINS S=DIFF[5] CO=carry[6] A=A[5] B=n15 CI=carry[5]
XU2_4 FA1 $PINS S=DIFF[4] CO=carry[5] A=A[4] B=n14 CI=carry[4]
XU2_11 FA1S $PINS S=DIFF[11] CO=carry[12] A=A[11] B=n7 CI=carry[11]
XU2_12 FA1 $PINS S=DIFF[12] CO=carry[13] A=A[12] B=n6 CI=carry[12]
XU2_10 FA1 $PINS S=DIFF[10] CO=carry[11] A=A[10] B=n8 CI=carry[10]
XU2_13 FA1S $PINS S=DIFF[13] CO=carry[14] A=A[13] B=n5 CI=carry[13]
XU2_17 XOR3S $PINS O=DIFF[17] I1=A[17] I2=n2 I3=carry[17]
XU1 INV1S $PINS O=n10 I=B[0]
XU2 INV1S $PINS O=n2 I=B[17]
XU3 INV1S $PINS O=n5 I=B[13]
XU4 INV1S $PINS O=n8 I=B[10]
XU5 INV1S $PINS O=n6 I=B[12]
XU6 INV1S $PINS O=n7 I=B[11]
XU7 INV1S $PINS O=n14 I=B[4]
XU8 INV1S $PINS O=n15 I=B[5]
XU9 INV1S $PINS O=n18 I=B[8]
XU10 INV1S $PINS O=n17 I=B[7]
XU11 INV1S $PINS O=n9 I=B[9]
XU12 INV1S $PINS O=n3 I=B[15]
XU13 INV1S $PINS O=n16 I=B[6]
XU14 INV1S $PINS O=n4 I=B[14]
XU15 INV1S $PINS O=n11 I=B[1]
XU16 INV1S $PINS O=n1 I=A[0]
XU17 INV1S $PINS O=n13 I=B[3]
XU18 INV1S $PINS O=n12 I=B[2]
XU19 XNR2HS $PINS O=DIFF[0] I1=n10 I2=A[0]
XU20 ND2 $PINS O=carry[1] I1=B[0] I2=n1
.ENDS

.SUBCKT cordic_rotation_0 rst_n valid_in valid_out x_in[16] x_in[15] x_in[14]
+ x_in[13] x_in[12] x_in[11] x_in[10] x_in[9] x_in[8] x_in[7] x_in[6] x_in[5]
+ x_in[4] x_in[3] x_in[2] x_in[1] x_in[0] y_in[16] y_in[15] y_in[14] y_in[13]
+ y_in[12] y_in[11] y_in[10] y_in[9] y_in[8] y_in[7] y_in[6] y_in[5] y_in[4]
+ y_in[3] y_in[2] y_in[1] y_in[0] phase_in[15] phase_in[14] phase_in[13]
+ phase_in[12] phase_in[11] phase_in[10] phase_in[9] phase_in[8] phase_in[7]
+ phase_in[6] phase_in[5] phase_in[4] phase_in[3] phase_in[2] phase_in[1]
+ phase_in[0] x_out[16] x_out[15] x_out[14] x_out[13] x_out[12] x_out[11]
+ x_out[10] x_out[9] x_out[8] x_out[7] x_out[6] x_out[5] x_out[4] x_out[3]
+ x_out[2] x_out[1] x_out[0] y_out[16] y_out[15] y_out[14] y_out[13] y_out[12]
+ y_out[11] y_out[10] y_out[9] y_out[8] y_out[7] y_out[6] y_out[5] y_out[4]
+ y_out[3] y_out[2] y_out[1] y_out[0] p1 FE_OFN51_i_rst_n FE_OFN27_i_rst_n
+ FE_OFN26_i_rst_n FE_OFN21_i_rst_n FE_OFN7_i_rst_n clk_clone2 clk clk_clone4
+ clk_clone3 clk_clone1
*.CONNECT N130 x_in[0]
*.CONNECT N148 y_in[0]
*.CONNECT N176 phase_in[8]
*.CONNECT N177 phase_in[9]
*.CONNECT N178 phase_in[10]
*.CONNECT N179 phase_in[11]
*.CONNECT N180 phase_in[12]
*.CONNECT N181 phase_in[13]
*.CONNECT N182 phase_in[14]
XFE_PHC2209_N508 BUF1CK $PINS O=FE_PHN2209_N508 I=N508
XFE_PHC2206_N488 BUF1CK $PINS O=N488 I=FE_PHN2206_N488
XFE_PHC2205_N507 BUF1CK $PINS O=FE_PHN2205_N507 I=N507
XFE_PHC2190_y_reg_11 BUF1CK $PINS O=FE_PHN2190_y_reg_11 I=y_reg[11]
XFE_PHC2186_y_reg_10 BUF1CK $PINS O=FE_PHN2186_y_reg_10 I=y_reg[10]
XFE_PHC2180_n152 BUF1CK $PINS O=FE_PHN2180_n152 I=n152
XFE_PHC2151_z_reg_7 BUF1S $PINS O=FE_PHN2151_z_reg_7 I=FE_PHN1652_z_reg_7
XFE_PHC2135_z_reg_6 BUF1S $PINS O=FE_PHN2135_z_reg_6 I=z_reg[6]
XFE_PHC2122_N439 BUF1CK $PINS O=FE_PHN2122_N439 I=N439
XFE_PHC2119_N441 BUF1CK $PINS O=FE_PHN2119_N441 I=N441
XFE_PHC2107_y_reg_15 DELA $PINS O=FE_PHN2107_y_reg_15 I=y_reg[15]
XFE_PHC2086_c_in_i_1_10 BUF1CK $PINS O=FE_PHN2086_c_in_i_1_10
+ I=FE_PHN1703_c_in_i_1_10
XFE_PHC2085_c_in_r_1_12 BUF1CK $PINS O=FE_PHN2085_c_in_r_1_12 I=x_in[12]
XFE_PHC2083_c_in_r_1_11 BUF1CK $PINS O=FE_PHN2083_c_in_r_1_11 I=x_in[11]
XFE_PHC2079_N450 DELB $PINS O=FE_PHN2079_N450 I=N450
XFE_PHC2076_N451 DELC $PINS O=FE_PHN2076_N451 I=N451
XFE_PHC2066_N499 DELA $PINS O=N499 I=FE_PHN2066_N499
XFE_PHC2064_N500 DELA $PINS O=N500 I=FE_PHN2064_N500
XFE_PHC2055_add_117_carry_10 DELB $PINS O=add_117/carry[10]
+ I=FE_PHN2055_add_117_carry_10
XFE_PHC2054_N497 DELB $PINS O=FE_PHN2054_N497 I=N497
XFE_PHC2052_N442 DELC $PINS O=FE_PHN2052_N442 I=N442
XFE_PHC2047_N443 DELC $PINS O=FE_PHN2047_N443 I=N443
XFE_PHC2037_N488 BUF1S $PINS O=FE_PHN2037_N488 I=N488
XFE_PHC2033_N498 DELA $PINS O=FE_PHN2033_N498 I=N498
XFE_PHC2031_n362 BUF1S $PINS O=FE_PHN2031_n362 I=n362
XFE_PHC2028_N503 DELA $PINS O=FE_PHN2028_N503 I=N503
XFE_PHC2024_N501 DELA $PINS O=FE_PHN2024_N501 I=N501
XFE_PHC2010_n276 DELA $PINS O=FE_PHN2010_n276 I=n276
XFE_PHC2005_N506 DELA $PINS O=FE_PHN2005_N506 I=N506
XFE_PHC2003_n329 DELB $PINS O=FE_PHN2003_n329 I=n329
XFE_PHC2001_N504 DELB $PINS O=FE_PHN2001_N504 I=N504
XFE_PHC1998_N502 DELB $PINS O=FE_PHN1998_N502 I=N502
XFE_PHC1996_N505 DELB $PINS O=FE_PHN1996_N505 I=N505
XFE_PHC1993_n341 DELB $PINS O=FE_PHN1993_n341 I=n341
XFE_PHC1991_n338 DELB $PINS O=FE_PHN1991_n338 I=n338
XFE_PHC1990_n364 DELB $PINS O=n364 I=FE_PHN1990_n364
XFE_PHC1987_n363 DELB $PINS O=FE_PHN1987_n363 I=n363
XFE_PHC1985_n365 DELB $PINS O=n365 I=FE_PHN1985_n365
XFE_PHC1983_n332 DELB $PINS O=FE_PHN1983_n332 I=n332
XFE_PHC1982_n366 DELB $PINS O=FE_PHN1982_n366 I=n366
XFE_PHC1981_n335 DELB $PINS O=FE_PHN1981_n335 I=n335
XFE_PHC1980_n344 DELB $PINS O=FE_PHN1980_n344 I=n344
XFE_PHC1975_n367 DELB $PINS O=FE_PHN1975_n367 I=n367
XFE_PHC1971_N489 DELB $PINS O=FE_PHN1971_N489 I=N489
XFE_PHC1970_N487 DELB $PINS O=FE_PHN1970_N487 I=N487
XFE_PHC1966_N486 DELB $PINS O=FE_PHN1966_N486 I=N486
XFE_PHC1963_N437 DELB $PINS O=FE_PHN1963_N437 I=N437
XFE_PHC1957_N435 DELB $PINS O=FE_PHN1957_N435 I=N435
XFE_PHC1954_N483 DELB $PINS O=FE_PHN1954_N483 I=N483
XFE_PHC1950_n321 DELB $PINS O=FE_PHN1950_n321 I=n321
XFE_PHC1947_N485 DELB $PINS O=FE_PHN1947_N485 I=N485
XFE_PHC1944_N434 DELB $PINS O=FE_PHN1944_N434 I=N434
XFE_PHC1941_N484 DELB $PINS O=FE_PHN1941_N484 I=N484
XFE_PHC1938_N482 DELB $PINS O=FE_PHN1938_N482 I=N482
XFE_PHC1937_N432 DELB $PINS O=FE_PHN1937_N432 I=N432
XFE_PHC1928_n326 DELB $PINS O=FE_PHN1928_n326 I=n326
XFE_PHC1925_N459 DELB $PINS O=FE_PHN1925_N459 I=N459
XFE_PHC1918_N461 DELB $PINS O=FE_PHN1918_N461 I=N461
XFE_PHC1914_N481 DELB $PINS O=N481 I=FE_PHN1914_N481
XFE_PHC1910_n282 DELB $PINS O=FE_PHN1910_n282 I=n282
XFE_PHC1904_N431 DELB $PINS O=N431 I=FE_PHN1904_N431
XFE_PHC1887_N457 DELC $PINS O=FE_PHN1887_N457 I=N457
XFE_PHC1871_n368 DELC $PINS O=FE_PHN1871_n368 I=n368
XFE_PHC1840_N460 DELC $PINS O=FE_PHN1840_N460 I=N460
XFE_PHC1787_x_reg_14 DELB $PINS O=x_reg[14] I=FE_PHN1787_x_reg_14
XFE_PHC1786_x_reg_15 DELB $PINS O=x_reg[15] I=FE_PHN1786_x_reg_15
XFE_PHC1785_x_reg_13 BUF1S $PINS O=FE_PHN1785_x_reg_13 I=x_reg[13]
XFE_PHC1783_x_reg_16 BUF1S $PINS O=FE_PHN1783_x_reg_16 I=x_reg[16]
XFE_PHC1782_x_reg_12 DELB $PINS O=FE_PHN1782_x_reg_12 I=x_reg[12]
XFE_PHC1781_x_reg_11 DELB $PINS O=FE_PHN1781_x_reg_11 I=x_reg[11]
XFE_PHC1779_x_reg_10 DELB $PINS O=x_reg[10] I=FE_PHN1779_x_reg_10
XFE_PHC1776_y_reg_15 DELC $PINS O=FE_PHN1776_y_reg_15 I=y_reg[15]
XFE_PHC1772_x_reg_17 DELB $PINS O=FE_PHN1772_x_reg_17 I=x_reg[17]
XFE_PHC1768_x_reg_0 DELB $PINS O=x_reg[0] I=FE_PHN1768_x_reg_0
XFE_PHC1767_y_reg_12 DELC $PINS O=FE_PHN1767_y_reg_12 I=y_reg[12]
XFE_PHC1766_y_reg_6 DELC $PINS O=FE_PHN1766_y_reg_6 I=y_reg[6]
XFE_PHC1765_y_reg_13 DELC $PINS O=FE_PHN1765_y_reg_13 I=y_reg[13]
XFE_PHC1754_y_reg_5 DELB $PINS O=FE_PHN1754_y_reg_5 I=y_reg[5]
XFE_PHC1751_y_reg_7 DELB $PINS O=FE_PHN1751_y_reg_7 I=y_reg[7]
XFE_PHC1749_y_reg_17 DELC $PINS O=y_reg[17] I=FE_PHN1749_y_reg_17
XFE_PHC1748_z_reg_15 DELB $PINS O=z_reg[15] I=FE_PHN1748_z_reg_15
XFE_PHC1737_x_reg_1 DELA $PINS O=FE_PHN1737_x_reg_1 I=x_reg[1]
XFE_PHC1736_y_reg_4 DELC $PINS O=FE_PHN1736_y_reg_4 I=y_reg[4]
XFE_PHC1728_c_in_i_1_16 BUF6CK $PINS O=FE_PHN1728_c_in_i_1_16 I=y_in[16]
XFE_PHC1710_y_reg_14 DELC $PINS O=FE_PHN1710_y_reg_14 I=y_reg[14]
XFE_PHC1705_c_in_i_1_11 BUF2CK $PINS O=FE_PHN1705_c_in_i_1_11 I=y_in[11]
XFE_PHC1703_c_in_i_1_10 BUF1CK $PINS O=FE_PHN1703_c_in_i_1_10 I=y_in[10]
XFE_PHC1681_c_in_i_1_13 DELA $PINS O=FE_PHN1681_c_in_i_1_13 I=y_in[13]
XFE_PHC1663_c_in_i_1_14 DELA $PINS O=FE_PHN1663_c_in_i_1_14 I=y_in[14]
XFE_PHC1656_c_in_i_1_12 DELA $PINS O=FE_PHN1656_c_in_i_1_12 I=y_in[12]
XFE_PHC1652_z_reg_7 BUF1S $PINS O=FE_PHN1652_z_reg_7 I=z_reg[7]
XFE_PHC1572_cor_y_out_1_8 BUF1S $PINS O=y_out[8] I=FE_PHN1572_cor_y_out_1_8
XFE_PHC1566_N428 DELB $PINS O=FE_PHN1566_N428 I=N428
XFE_PHC1563_N427 DELB $PINS O=FE_PHN1563_N427 I=N427
XFE_PHC1560_N429 DELB $PINS O=FE_PHN1560_N429 I=N429
XFE_PHC1557_N430 DELB $PINS O=FE_PHN1557_N430 I=N430
XFE_PHC1555_N426 DELB $PINS O=FE_PHN1555_N426 I=N426
XFE_PHC1529_n354 DELB $PINS O=n354 I=FE_PHN1529_n354
XFE_PHC1518_cor_x_out_1_0 DELA $PINS O=x_out[0] I=FE_PHN1518_cor_x_out_1_0
XFE_PHC1515_y_reg_11 DELC $PINS O=FE_PHN1515_y_reg_11 I=FE_PHN2190_y_reg_11
XFE_PHC1512_cor_x_out_1_14 DELA $PINS O=x_out[14] I=FE_PHN1512_cor_x_out_1_14
XFE_PHC1474_y_reg_10 DELC $PINS O=FE_PHN1474_y_reg_10 I=FE_PHN2186_y_reg_10
XFE_PHC1442_cor_x_out_1_12 DELA $PINS O=x_out[12] I=FE_PHN1442_cor_x_out_1_12
XFE_PHC1315_cor_x_out_1_15 DELB $PINS O=x_out[15] I=FE_PHN1315_cor_x_out_1_15
XFE_PHC1310_cor_y_out_1_4 BUF1S $PINS O=y_out[4] I=FE_PHN1310_cor_y_out_1_4
XFE_RC_228_0 INV1S $PINS O=FE_RN_105_0 I=FE_RN_2592_0
XFE_RC_227_0 ND3P $PINS O=n56 I1=n240 I2=n241 I3=FE_RN_105_0
XFE_RC_125_0 AOI22S $PINS O=n246 A1=N305 A2=FE_OFN47_n1 B1=N357
+ B2=FE_OFN49_n242
XFE_OCPC0_FE_OFN50_n247 BUF2 $PINS O=FE_OCPN0_FE_OFN50_n247 I=n247
XCTS_ccl_a_INV_CLK_G1_L12_16 INV6CK $PINS O=CTS_34 I=CTS_35
XCTS_ccl_a_INV_CLK_G1_L11_16 INV8CK $PINS O=CTS_35 I=CTS_36
XCTS_ccl_a_INV_CLK_G1_L10_23 INV3CK $PINS O=CTS_31 I=CTS_32
XCTS_ccl_a_INV_CLK_G1_L9_23 INV1CK $PINS O=CTS_32 I=CTS_33
XCTS_ccl_a_INV_CLK_G1_L10_3 INV6CK $PINS O=CTS_28 I=CTS_29
XCTS_ccl_a_INV_CLK_G1_L9_3 INV3CK $PINS O=CTS_29 I=CTS_30
XFE_RC_4001_0 INV1S $PINS O=FE_RN_2592_0 I=n239
XFE_OFC578_n86 BUF1 $PINS O=FE_OFN354_n86 I=n86
XFE_OFC557_y_reg_5 INV1S $PINS O=n100 I=FE_PHN1754_y_reg_5
XFE_OFC551_n141 INV1S $PINS O=FE_OFN339_n141 I=n62
XFE_OFC550_n141 INV1S $PINS O=FE_OFN338_n141 I=n62
XFE_OFC549_n141 INV2 $PINS O=n62 I=n141
XFE_OFC531_y_reg_6 INV1S $PINS O=n94 I=FE_PHN1766_y_reg_6
XFE_OFC514_x_reg_6 INV1S $PINS O=n185 I=x_reg[6]
XFE_OFC510_y_reg_8 INV1S $PINS O=n72 I=y_reg[8]
XFE_OFC497_x_reg_9 INV1S $PINS O=n169 I=x_reg[9]
XFE_OFC461_y_reg_9 INV1S $PINS O=n71 I=y_reg[9]
XFE_OFC451_n244 INV1S $PINS O=FE_OFN303_n244 I=N108
XFE_OFC448_n244 INV1S $PINS O=N108 I=n244
XFE_OFC427_n2 INV2 $PINS O=FE_DBTN14_n2 I=n2
XFE_OFC425_y_reg_7 INV1S $PINS O=n83 I=FE_PHN1751_y_reg_7
XFE_OFC424_x_reg_7 INV1S $PINS O=n178 I=x_reg[7]
XFE_OFC385_x_reg_10 INV1S $PINS O=n159 I=x_reg[10]
XFE_OFC366_x_reg_11 INV1S $PINS O=n179 I=FE_PHN1781_x_reg_11
XFE_OFC348_y_reg_11 INV1S $PINS O=n84 I=FE_PHN2190_y_reg_11
XFE_OFC338_y_reg_10 INV1S $PINS O=n57 I=FE_PHN2186_y_reg_10
XFE_OFC334_n65 INV2 $PINS O=n74 I=n65
XFE_OFC294_n56 BUF2 $PINS O=FE_OFN48_n56 I=n56
XFE_OFC293_n56 INV2 $PINS O=n6 I=n56
XFE_OFC290_n4 INV2 $PINS O=FE_OFN257_n4 I=n124
XFE_OFC289_n4 INV1S $PINS O=n124 I=n4
XFE_OFC51_n248 BUF1 $PINS O=FE_OFN51_n248 I=n248
XFE_OFC49_n242 BUF1 $PINS O=FE_OFN49_n242 I=n242
XFE_OFC47_n1 BUF1 $PINS O=FE_OFN47_n1 I=n1
Xx_out_reg[5] QDFFRBN $PINS Q=x_out[5] D=N431 CK=CTS_31 RB=FE_OFN21_i_rst_n
Xx_out_reg[6] QDFFRBN $PINS Q=x_out[6] D=FE_PHN1937_N432 CK=CTS_31
+ RB=FE_OFN21_i_rst_n
Xx_out_reg[7] QDFFRBN $PINS Q=x_out[7] D=N433 CK=CTS_31 RB=FE_OFN21_i_rst_n
Xx_out_reg[8] QDFFRBN $PINS Q=x_out[8] D=FE_PHN1944_N434 CK=CTS_31
+ RB=FE_OFN21_i_rst_n
Xx_out_reg[9] QDFFRBN $PINS Q=x_out[9] D=FE_PHN1957_N435 CK=CTS_31
+ RB=FE_OFN26_i_rst_n
Xy_out_reg[0] QDFFRBN $PINS Q=y_out[0] D=FE_PHN2122_N439 CK=net2411
+ RB=FE_OFN27_i_rst_n
Xy_out_reg[1] QDFFRBN $PINS Q=y_out[1] D=N440 CK=net2411 RB=FE_OFN27_i_rst_n
Xy_out_reg[2] QDFFRBN $PINS Q=y_out[2] D=FE_PHN2119_N441 CK=net2411
+ RB=FE_OFN27_i_rst_n
Xy_out_reg[3] QDFFRBN $PINS Q=y_out[3] D=FE_PHN2052_N442 CK=net2411
+ RB=FE_OFN7_i_rst_n
Xy_out_reg[4] QDFFRBN $PINS Q=FE_PHN1310_cor_y_out_1_4 D=FE_PHN2047_N443
+ CK=net2411 RB=FE_OFN7_i_rst_n
Xy_out_reg[5] QDFFRBN $PINS Q=y_out[5] D=N444 CK=net2411 RB=FE_OFN27_i_rst_n
Xy_out_reg[6] QDFFRBN $PINS Q=y_out[6] D=N445 CK=net2411 RB=FE_OFN27_i_rst_n
Xy_out_reg[7] QDFFRBN $PINS Q=y_out[7] D=N446 CK=net2411 RB=FE_OFN27_i_rst_n
Xy_out_reg[8] QDFFRBN $PINS Q=FE_PHN1572_cor_y_out_1_8 D=N447 CK=net2411
+ RB=FE_OFN27_i_rst_n
Xy_out_reg[9] QDFFRBN $PINS Q=y_out[9] D=N448 CK=net2411 RB=FE_OFN27_i_rst_n
Xy_out_reg[10] QDFFRBN $PINS Q=y_out[10] D=N449 CK=net2411 RB=FE_OFN27_i_rst_n
Xy_out_reg[11] QDFFRBN $PINS Q=y_out[11] D=FE_PHN2079_N450 CK=net2411
+ RB=FE_OFN27_i_rst_n
Xy_out_reg[12] QDFFRBN $PINS Q=y_out[12] D=FE_PHN2076_N451 CK=net2411 RB=rst_n
Xy_out_reg[13] QDFFRBN $PINS Q=y_out[13] D=FE_PHN2076_N451 CK=net2411 RB=rst_n
Xy_out_reg[14] QDFFRBN $PINS Q=y_out[14] D=FE_PHN2076_N451 CK=net2411
+ RB=FE_OFN27_i_rst_n
Xy_out_reg[15] QDFFRBN $PINS Q=y_out[15] D=FE_PHN2076_N451 CK=net2411 RB=rst_n
Xy_out_reg[16] QDFFRBN $PINS Q=y_out[16] D=FE_PHN2076_N451 CK=net2411
+ RB=FE_OFN27_i_rst_n
Xx_out_reg[0] QDFFRBN $PINS Q=FE_PHN1518_cor_x_out_1_0 D=FE_PHN1555_N426
+ CK=CTS_31 RB=FE_OFN26_i_rst_n
Xx_out_reg[1] QDFFRBN $PINS Q=x_out[1] D=FE_PHN1563_N427 CK=CTS_31
+ RB=FE_OFN26_i_rst_n
Xx_out_reg[2] QDFFRBN $PINS Q=x_out[2] D=FE_PHN1566_N428 CK=CTS_31
+ RB=FE_OFN26_i_rst_n
Xx_out_reg[3] QDFFRBN $PINS Q=x_out[3] D=FE_PHN1560_N429 CK=CTS_31
+ RB=FE_OFN21_i_rst_n
Xx_out_reg[4] QDFFRBN $PINS Q=x_out[4] D=FE_PHN1557_N430 CK=CTS_31
+ RB=FE_OFN21_i_rst_n
Xx_out_reg[10] QDFFRBN $PINS Q=x_out[10] D=N436 CK=CTS_31 RB=FE_OFN26_i_rst_n
Xx_out_reg[11] QDFFRBN $PINS Q=x_out[11] D=FE_PHN1963_N437 CK=CTS_31
+ RB=FE_OFN26_i_rst_n
Xx_out_reg[12] QDFFRBN $PINS Q=FE_PHN1442_cor_x_out_1_12 D=N438 CK=CTS_31
+ RB=FE_OFN26_i_rst_n
Xx_out_reg[13] QDFFRBN $PINS Q=x_out[13] D=N438 CK=CTS_31 RB=FE_OFN26_i_rst_n
Xx_out_reg[14] QDFFRBN $PINS Q=FE_PHN1512_cor_x_out_1_14 D=N438 CK=CTS_31
+ RB=FE_OFN26_i_rst_n
Xx_out_reg[15] QDFFRBN $PINS Q=FE_PHN1315_cor_x_out_1_15 D=N438 CK=CTS_31
+ RB=FE_OFN26_i_rst_n
Xx_out_reg[16] QDFFRBN $PINS Q=x_out[16] D=N438 CK=CTS_31 RB=FE_OFN26_i_rst_n
Xz_reg_reg[14] QDFFRBN $PINS Q=z_reg[14] D=N477 CK=CTS_28 RB=FE_OFN27_i_rst_n
Xz_reg_reg[15] QDFFRBN $PINS Q=FE_PHN1748_z_reg_15 D=N478 CK=CTS_28
+ RB=FE_OFN27_i_rst_n
Xz_reg_reg[13] QDFFRBN $PINS Q=z_reg[13] D=N476 CK=CTS_28 RB=FE_OFN27_i_rst_n
Xz_reg_reg[12] QDFFRBN $PINS Q=z_reg[12] D=N475 CK=CTS_28 RB=FE_OFN27_i_rst_n
Xz_reg_reg[11] QDFFRBN $PINS Q=z_reg[11] D=N474 CK=CTS_28 RB=FE_OFN27_i_rst_n
Xz_reg_reg[10] QDFFRBN $PINS Q=z_reg[10] D=N473 CK=CTS_28 RB=FE_OFN27_i_rst_n
Xz_reg_reg[9] QDFFRBN $PINS Q=z_reg[9] D=N472 CK=CTS_28 RB=FE_OFN27_i_rst_n
Xz_reg_reg[8] QDFFRBN $PINS Q=z_reg[8] D=N471 CK=CTS_28 RB=FE_OFN27_i_rst_n
Xz_reg_reg[7] QDFFRBN $PINS Q=z_reg[7] D=n361 CK=CTS_28 RB=FE_OFN27_i_rst_n
Xz_reg_reg[6] QDFFRBN $PINS Q=z_reg[6] D=FE_PHN2031_n362 CK=CTS_34 RB=rst_n
Xz_reg_reg[5] QDFFRBN $PINS Q=z_reg[5] D=FE_PHN1987_n363 CK=CTS_34 RB=rst_n
Xz_reg_reg[4] QDFFRBN $PINS Q=z_reg[4] D=n364 CK=CTS_34 RB=rst_n
Xz_reg_reg[3] QDFFRBN $PINS Q=z_reg[3] D=n365 CK=CTS_34 RB=rst_n
Xz_reg_reg[2] QDFFRBN $PINS Q=z_reg[2] D=FE_PHN1982_n366 CK=CTS_34 RB=rst_n
Xy_reg_reg[17] QDFFRBN $PINS Q=FE_PHN1749_y_reg_17 D=N514 CK=CTS_28
+ RB=FE_OFN27_i_rst_n
Xx_reg_reg[17] QDFFRBN $PINS Q=x_reg[17] D=N496 CK=CTS_34 RB=FE_OFN26_i_rst_n
Xz_reg_reg[1] QDFFRBN $PINS Q=z_reg[1] D=FE_PHN1975_n367 CK=CTS_34
+ RB=FE_OFN26_i_rst_n
Xx_reg_reg[16] QDFFRBN $PINS Q=x_reg[16] D=N495 CK=CTS_34 RB=FE_OFN26_i_rst_n
Xy_reg_reg[16] QDFFRBN $PINS Q=y_reg[16] D=N513 CK=CTS_28 RB=FE_OFN27_i_rst_n
Xz_reg_reg[0] QDFFRBN $PINS Q=z_reg[0] D=FE_PHN1871_n368 CK=CTS_34
+ RB=FE_OFN26_i_rst_n
Xx_reg_reg[15] QDFFRBN $PINS Q=FE_PHN1786_x_reg_15 D=N494 CK=CTS_34
+ RB=FE_OFN26_i_rst_n
Xy_reg_reg[15] QDFFRBN $PINS Q=y_reg[15] D=N512 CK=CTS_28 RB=FE_OFN51_i_rst_n
Xx_reg_reg[14] QDFFRBN $PINS Q=FE_PHN1787_x_reg_14 D=N493 CK=CTS_34
+ RB=FE_OFN26_i_rst_n
Xy_reg_reg[14] QDFFRBN $PINS Q=y_reg[14] D=N511 CK=CTS_28 RB=FE_OFN51_i_rst_n
Xy_reg_reg[13] QDFFRBN $PINS Q=y_reg[13] D=N510 CK=CTS_28 RB=FE_OFN51_i_rst_n
Xx_reg_reg[13] QDFFRBN $PINS Q=x_reg[13] D=N492 CK=CTS_34 RB=rst_n
Xy_reg_reg[12] QDFFRBN $PINS Q=y_reg[12] D=N509 CK=CTS_28 RB=FE_OFN51_i_rst_n
Xx_reg_reg[12] QDFFRBN $PINS Q=x_reg[12] D=N491 CK=CTS_34 RB=rst_n
Xis_computing_reg QDFFRBN $PINS Q=is_computing D=FE_PHN1887_N457 CK=CTS_34
+ RB=rst_n
Xy_reg_reg[11] QDFFRBN $PINS Q=y_reg[11] D=FE_PHN2209_N508 CK=CTS_28
+ RB=FE_OFN51_i_rst_n
Xx_reg_reg[11] QDFFRBN $PINS Q=x_reg[11] D=N490 CK=CTS_34 RB=rst_n
Xx_reg_reg[1] QDFFRBN $PINS Q=x_reg[1] D=N480 CK=CTS_34 RB=FE_OFN21_i_rst_n
Xy_reg_reg[1] QDFFRBN $PINS Q=y_reg[1] D=FE_PHN2033_N498 CK=CTS_28
+ RB=FE_OFN51_i_rst_n
Xy_reg_reg[3] QDFFRBN $PINS Q=y_reg[3] D=N500 CK=CTS_28 RB=FE_OFN51_i_rst_n
Xx_reg_reg[3] QDFFRBN $PINS Q=x_reg[3] D=FE_PHN1938_N482 CK=CTS_34
+ RB=FE_OFN21_i_rst_n
Xy_reg_reg[10] QDFFRBN $PINS Q=y_reg[10] D=FE_PHN2205_N507 CK=CTS_28
+ RB=FE_OFN51_i_rst_n
Xx_reg_reg[4] QDFFRBN $PINS Q=x_reg[4] D=FE_PHN1954_N483 CK=CTS_34
+ RB=FE_OFN21_i_rst_n
Xx_reg_reg[10] QDFFRBN $PINS Q=FE_PHN1779_x_reg_10 D=FE_PHN1971_N489 CK=CTS_34
+ RB=rst_n
Xy_reg_reg[4] QDFFRBN $PINS Q=y_reg[4] D=FE_PHN2024_N501 CK=CTS_28
+ RB=FE_OFN51_i_rst_n
Xy_reg_reg[2] QDFFRBN $PINS Q=y_reg[2] D=N499 CK=CTS_28 RB=FE_OFN51_i_rst_n
Xx_reg_reg[0] QDFFRBN $PINS Q=FE_PHN1768_x_reg_0 D=N479 CK=CTS_34
+ RB=FE_OFN21_i_rst_n
Xx_reg_reg[2] QDFFRBN $PINS Q=x_reg[2] D=N481 CK=CTS_34 RB=FE_OFN21_i_rst_n
Xy_reg_reg[0] QDFFRBN $PINS Q=y_reg[0] D=FE_PHN2054_N497 CK=CTS_28
+ RB=FE_OFN51_i_rst_n
Xy_reg_reg[7] QDFFRBN $PINS Q=y_reg[7] D=FE_PHN2001_N504 CK=CTS_28
+ RB=FE_OFN51_i_rst_n
Xx_reg_reg[7] QDFFRBN $PINS Q=x_reg[7] D=FE_PHN1966_N486 CK=CTS_34
+ RB=FE_OFN21_i_rst_n
Xy_reg_reg[5] QDFFRBN $PINS Q=y_reg[5] D=FE_PHN1998_N502 CK=CTS_28
+ RB=FE_OFN51_i_rst_n
Xx_reg_reg[5] QDFFRBN $PINS Q=x_reg[5] D=FE_PHN1941_N484 CK=CTS_34
+ RB=FE_OFN21_i_rst_n
Xy_reg_reg[8] QDFFRBN $PINS Q=y_reg[8] D=FE_PHN1996_N505 CK=CTS_28
+ RB=FE_OFN51_i_rst_n
Xx_reg_reg[8] QDFFRBN $PINS Q=x_reg[8] D=FE_PHN1970_N487 CK=CTS_34
+ RB=FE_OFN21_i_rst_n
Xy_reg_reg[6] QDFFRBN $PINS Q=y_reg[6] D=FE_PHN2028_N503 CK=CTS_28
+ RB=FE_OFN51_i_rst_n
Xx_reg_reg[6] QDFFRBN $PINS Q=x_reg[6] D=FE_PHN1947_N485 CK=CTS_34
+ RB=FE_OFN21_i_rst_n
Xy_reg_reg[9] QDFFRBN $PINS Q=y_reg[9] D=FE_PHN2005_N506 CK=CTS_28
+ RB=FE_OFN51_i_rst_n
Xx_reg_reg[9] QDFFRBN $PINS Q=x_reg[9] D=FE_PHN2037_N488 CK=CTS_34 RB=rst_n
Xvalid_out_reg QDFFRBN $PINS Q=valid_out D=N515 CK=clk RB=FE_OFN27_i_rst_n
Xstep_cnt_reg[0] QDFFRBN $PINS Q=step_cnt[0] D=N458 CK=net2421 RB=rst_n
Xstep_cnt_reg[3] QDFFRBN $PINS Q=step_cnt[3] D=FE_PHN1918_N461 CK=net2421
+ RB=rst_n
Xstep_cnt_reg[1] QDFFRBN $PINS Q=step_cnt[1] D=FE_PHN1925_N459 CK=net2421
+ RB=rst_n
Xstep_cnt_reg[2] DFFRBN $PINS Q=step_cnt[2] QB=n239 D=FE_PHN1840_N460
+ CK=net2421 RB=rst_n
XU3 AN3 $PINS O=n14 I1=n237 I2=step_cnt[1] I3=n241
XU4 AN3 $PINS O=n2 I1=n237 I2=n238 I3=n241
XU5 INV2 $PINS O=n238 I=step_cnt[1]
XU6 ND3 $PINS O=n4 I1=step_cnt[2] I2=step_cnt[0] I3=n352
XU7 NR2 $PINS O=N147 I1=x_in[16] I2=sub_87/carry[16]
XU8 OR2P $PINS O=n3 I1=n235 I2=step_cnt[3]
XU9 NR2 $PINS O=sub_87/carry[2] I1=N130 I2=x_in[1]
XU10 NR2 $PINS O=sub_88/carry[2] I1=N148 I2=y_in[1]
XU11 NR2 $PINS O=N165 I1=FE_PHN1728_c_in_i_1_16 I2=sub_88/carry[16]
XU17 NR2P $PINS O=n1 I1=n243 I2=z_reg[15]
XU18 NR2P $PINS O=n240 I1=n355 I2=step_cnt[1]
XU19 INV2 $PINS O=n241 I=step_cnt[3]
XU21 ND2 $PINS O=n236 I1=step_cnt[2] I2=n240
XU22 INV2 $PINS O=n355 I=step_cnt[0]
XU23 OA222S $PINS O=n149 A1=FE_OFN354_n86 A2=n112 B1=n57 B2=n87 C1=n71 C2=n88
XU24 OA222S $PINS O=n210 A1=FE_OFN354_n86 A2=n197 B1=n87 B2=n179 C1=n88 C2=n159
XU25 OA222S $PINS O=n211 A1=n85 A2=n169 B1=n62 B2=n185 C1=n3 C2=n178
XU26 OA222S $PINS O=n204 A1=FE_OFN354_n86 A2=n191 B1=n87 B2=n171 C1=n88 C2=n179
XU27 OA222S $PINS O=n205 A1=n85 A2=n159 B1=n62 B2=n178 C1=n3 C2=n170
XU28 OA222S $PINS O=n119 A1=FE_OFN354_n86 A2=n106 B1=n84 B2=n87 C1=n57 C2=n88
XU29 OA222S $PINS O=n120 A1=n71 A2=n85 B1=n62 B2=n94 C1=n3 C2=n83
XU30 OA222S $PINS O=n113 A1=FE_OFN354_n86 A2=n100 B1=n73 B2=n87 C1=n84 C2=n88
XU31 OA222S $PINS O=n114 A1=n57 A2=n85 B1=n62 B2=n83 C1=n3 C2=n72
XU32 OA222S $PINS O=n198 A1=FE_OFN354_n86 A2=n185 B1=n87 B2=n172 C1=n88 C2=n171
XU33 OA222S $PINS O=n199 A1=n85 A2=n179 B1=n62 B2=n170 C1=n3 C2=n169
XU34 OA222S $PINS O=n107 A1=FE_OFN354_n86 A2=n94 B1=n76 B2=n87 C1=n73 C2=n88
XU35 OA222S $PINS O=n108 A1=n84 A2=n85 B1=n62 B2=n72 C1=n3 C2=n71
XU36 OA222S $PINS O=n192 A1=FE_OFN354_n86 A2=n178 B1=n87 B2=n163 C1=n88 C2=n172
XU37 OA222S $PINS O=n193 A1=n85 A2=n171 B1=n62 B2=n169 C1=n3 C2=n159
XU38 OA222S $PINS O=n101 A1=FE_OFN354_n86 A2=n83 B1=n63 B2=n87 C1=n76 C2=n88
XU39 OA222S $PINS O=n102 A1=n73 A2=n85 B1=n62 B2=n71 C1=n3 C2=n57
XU40 OA222S $PINS O=n186 A1=FE_OFN354_n86 A2=n170 B1=n87 B2=n161 C1=n88 C2=n163
XU41 OA222S $PINS O=n187 A1=n85 A2=n172 B1=n62 B2=n159 C1=n3 C2=n179
XU42 OA222S $PINS O=n95 A1=FE_OFN354_n86 A2=n72 B1=n59 B2=n87 C1=n63 C2=n88
XU43 OA222S $PINS O=n96 A1=n76 A2=n85 B1=n62 B2=n57 C1=n3 C2=n84
XU44 OA222S $PINS O=n180 A1=FE_OFN354_n86 A2=n169 B1=n87 B2=n160 C1=n88 C2=n161
XU45 OA222S $PINS O=n181 A1=n85 A2=n163 B1=n62 B2=n179 C1=n3 C2=n171
XU46 OA222S $PINS O=n89 A1=FE_OFN354_n86 A2=n71 B1=n58 B2=n87 C1=n59 C2=n88
XU47 OA222S $PINS O=n90 A1=n63 A2=n85 B1=n62 B2=n84 C1=n3 C2=n73
XU48 OA222S $PINS O=n173 A1=FE_OFN354_n86 A2=n159 B1=n87 B2=n162 C1=n88 C2=n160
XU49 OA222S $PINS O=n174 A1=n85 A2=n161 B1=n62 B2=n171 C1=n3 C2=n172
XU50 OA222S $PINS O=n78 A1=FE_OFN354_n86 A2=n57 B1=n61 B2=n87 C1=n58 C2=n88
XU51 OA222S $PINS O=n79 A1=n59 A2=n85 B1=n62 B2=n73 C1=n3 C2=n76
XU52 ND3S $PINS O=N112 I1=n236 I2=n56 I3=n357
XU53 ND3S $PINS O=N113 I1=n136 I2=n56 I3=n358
XU54 OR2S $PINS O=n140 I1=n147 I2=n148
XU55 OA222S $PINS O=n219 A1=FE_OFN48_n56 A2=n172 B1=FE_DBTN14_n2 B2=n171
+ C1=n136 C2=n163
XU56 OA222S $PINS O=n220 A1=n74 A2=n160 B1=n135 B2=n162 C1=FE_OFN354_n86
+ C2=n161
XU57 OA222S $PINS O=n133 A1=n76 A2=FE_OFN48_n56 B1=n73 B2=FE_DBTN14_n2 C1=n63
+ C2=n136
XU58 OA222S $PINS O=n134 A1=n74 A2=n58 B1=n135 B2=n61 C1=n59 C2=FE_OFN354_n86
XU59 ND2S $PINS O=N109 I1=n234 I2=n56
XU60 ND3 $PINS O=n234 I1=n355 I2=n238 I3=step_cnt[2]
XU61 ND3 $PINS O=n136 I1=n237 I2=n241 I3=step_cnt[1]
XU62 AO222S $PINS O=n232 A1=x_reg[0] A2=n2 B1=x_reg[4] B2=n65 C1=x_reg[7]
+ C2=n124
XU63 AO222S $PINS O=n152 A1=y_reg[0] A2=n2 B1=FE_PHN1736_y_reg_4 B2=n65
+ C1=y_reg[7] C2=n124
XU64 ND3S $PINS O=n244 I1=step_cnt[1] I2=n239 I3=step_cnt[0]
XU65 ND3 $PINS O=n88 I1=step_cnt[3] I2=n239 I3=n240
XU66 ND3S $PINS O=n235 I1=step_cnt[1] I2=n355 I3=step_cnt[2]
XU67 AO222S $PINS O=n213 A1=n2 A2=x_reg[1] B1=n65 B2=x_reg[5] C1=n124
+ C2=x_reg[8]
XU68 AO222S $PINS O=n122 A1=n2 A2=y_reg[1] B1=n65 B2=FE_PHN1754_y_reg_5 C1=n124
+ C2=y_reg[8]
XU69 ND3 $PINS O=n85 I1=n237 I2=n238 I3=step_cnt[3]
XU70 ND3 $PINS O=n87 I1=step_cnt[3] I2=n237 I3=step_cnt[1]
XU71 OA222S $PINS O=n165 A1=n3 A2=n163 B1=n75 B2=n162 C1=n62 C2=n172
XU72 OA222S $PINS O=n67 A1=n63 A2=n3 B1=n75 B2=n61 C1=n62 C2=n76
XU73 OA222S $PINS O=n155 A1=n3 A2=n161 B1=n60 B2=n162 C1=n62 C2=n163
XU74 OA222S $PINS O=n52 A1=n3 A2=n59 B1=n60 B2=n61 C1=n62 C2=n63
XU75 OA222S $PINS O=n223 A1=FE_OFN48_n56 A2=n171 B1=FE_DBTN14_n2 B2=n179
+ C1=n136 C2=n172
XU76 OA222S $PINS O=n139 A1=n73 A2=FE_OFN48_n56 B1=FE_DBTN14_n2 B2=n84 C1=n76
+ C2=n136
XU77 OA222S $PINS O=n218 A1=FE_DBTN14_n2 A2=n172 B1=n132 B2=n162
+ C1=FE_OFN354_n86 C2=n160
XU78 OA222S $PINS O=n131 A1=n76 A2=FE_DBTN14_n2 B1=n132 B2=n61 C1=FE_OFN354_n86
+ C2=n58
XU79 OA12S $PINS O=n351 A1=n353 B1=step_cnt[2] B2=n243
XU80 ND2S $PINS O=FE_PHN1529_n354 I1=is_computing I2=n355
XU81 OA12S $PINS O=n353 A1=n354 B1=step_cnt[1] B2=n243
XU88 ND2 $PINS O=n86 I1=N108 I2=n241
XU89 INV1S $PINS O=n50 I=N148
XU90 INV1S $PINS O=n33 I=N130
XU91 INV1S $PINS O=n49 I=y_in[1]
XU92 INV1S $PINS O=n32 I=x_in[1]
XU93 INV1S $PINS O=n48 I=y_in[2]
XU94 INV1S $PINS O=n31 I=x_in[2]
XU95 INV1S $PINS O=n47 I=y_in[3]
XU96 INV1S $PINS O=n30 I=x_in[3]
XU97 INV1S $PINS O=n46 I=y_in[4]
XU98 INV1S $PINS O=n29 I=x_in[4]
XU99 INV1S $PINS O=n45 I=y_in[5]
XU100 INV1S $PINS O=n28 I=x_in[5]
XU101 INV1S $PINS O=n44 I=y_in[6]
XU102 INV1S $PINS O=n27 I=x_in[6]
XU103 INV1S $PINS O=n43 I=y_in[7]
XU104 INV1S $PINS O=n26 I=x_in[7]
XU105 INV1S $PINS O=n42 I=y_in[8]
XU106 INV1S $PINS O=n25 I=x_in[8]
XU107 INV1S $PINS O=n24 I=x_in[9]
XU108 INV1S $PINS O=n41 I=y_in[9]
XU109 INV1S $PINS O=n40 I=y_in[10]
XU110 INV1S $PINS O=n23 I=x_in[10]
XU111 INV1S $PINS O=n39 I=y_in[11]
XU112 INV1S $PINS O=n22 I=x_in[11]
XU113 INV1S $PINS O=n38 I=y_in[12]
XU114 INV1S $PINS O=n21 I=x_in[12]
XU115 INV1S $PINS O=n37 I=y_in[13]
XU116 INV1S $PINS O=n20 I=x_in[13]
XU117 INV1S $PINS O=n36 I=y_in[14]
XU118 INV1S $PINS O=n19 I=x_in[14]
XU119 INV1S $PINS O=n35 I=y_in[15]
XU120 INV1S $PINS O=n18 I=x_in[15]
XU121 INV1S $PINS O=n34 I=y_in[16]
XU122 INV1S $PINS O=n17 I=x_in[16]
XU124 NR2P $PINS O=n65 I1=n234 I2=step_cnt[3]
XU129 INV1S $PINS O=n171 I=FE_PHN1782_x_reg_12
XU130 INV1S $PINS O=n73 I=FE_PHN1767_y_reg_12
XU131 INV1S $PINS O=n172 I=FE_PHN1785_x_reg_13
XU132 INV1S $PINS O=n76 I=FE_PHN1765_y_reg_13
XU134 XOR2HS $PINS O=N438 I1=FE_PHN1772_x_reg_17 I2=add_116/carry[17]
XU135 AN2 $PINS O=add_116/carry[17] I1=add_116/carry[16] I2=FE_PHN1783_x_reg_16
XU136 XOR2HS $PINS O=N437 I1=FE_PHN1783_x_reg_16 I2=add_116/carry[16]
XU137 AN2 $PINS O=add_116/carry[16] I1=add_116/carry[15] I2=x_reg[15]
XU138 XOR2HS $PINS O=N436 I1=x_reg[15] I2=add_116/carry[15]
XU139 AN2 $PINS O=add_116/carry[15] I1=add_116/carry[14] I2=x_reg[14]
XU140 XOR2HS $PINS O=N435 I1=x_reg[14] I2=add_116/carry[14]
XU141 AN2 $PINS O=add_116/carry[14] I1=add_116/carry[13] I2=FE_PHN1785_x_reg_13
XU142 XOR2HS $PINS O=N434 I1=FE_PHN1785_x_reg_13 I2=add_116/carry[13]
XU143 AN2 $PINS O=add_116/carry[13] I1=add_116/carry[12] I2=FE_PHN1782_x_reg_12
XU144 XOR2HS $PINS O=N433 I1=FE_PHN1782_x_reg_12 I2=add_116/carry[12]
XU145 AN2 $PINS O=add_116/carry[12] I1=add_116/carry[11] I2=FE_PHN1781_x_reg_11
XU146 XOR2HS $PINS O=N432 I1=FE_PHN1781_x_reg_11 I2=add_116/carry[11]
XU147 AN2 $PINS O=add_116/carry[11] I1=add_116/carry[10] I2=x_reg[10]
XU148 XOR2HS $PINS O=FE_PHN1904_N431 I1=x_reg[10] I2=add_116/carry[10]
XU149 AN2 $PINS O=add_116/carry[10] I1=add_116/carry[9] I2=x_reg[9]
XU150 XOR2HS $PINS O=N430 I1=x_reg[9] I2=add_116/carry[9]
XU151 AN2 $PINS O=add_116/carry[9] I1=add_116/carry[8] I2=x_reg[8]
XU152 XOR2HS $PINS O=N429 I1=x_reg[8] I2=add_116/carry[8]
XU153 AN2 $PINS O=add_116/carry[8] I1=add_116/carry[7] I2=x_reg[7]
XU154 XOR2HS $PINS O=N428 I1=x_reg[7] I2=add_116/carry[7]
XU155 AN2 $PINS O=add_116/carry[7] I1=add_116/carry[6] I2=x_reg[6]
XU156 XOR2HS $PINS O=N427 I1=x_reg[6] I2=add_116/carry[6]
XU157 AN2 $PINS O=add_116/carry[6] I1=x_reg[4] I2=x_reg[5]
XU158 XOR2HS $PINS O=N426 I1=x_reg[5] I2=x_reg[4]
XU159 XOR2HS $PINS O=N451 I1=y_reg[17] I2=add_117/carry[17]
XU160 AN2 $PINS O=add_117/carry[17] I1=add_117/carry[16] I2=y_reg[16]
XU161 XOR2HS $PINS O=N450 I1=y_reg[16] I2=add_117/carry[16]
XU162 AN2 $PINS O=add_117/carry[16] I1=add_117/carry[15] I2=FE_PHN1776_y_reg_15
XU163 XOR2HS $PINS O=N449 I1=FE_PHN1776_y_reg_15 I2=add_117/carry[15]
XU164 AN2 $PINS O=add_117/carry[15] I1=add_117/carry[14] I2=FE_PHN1710_y_reg_14
XU165 XOR2HS $PINS O=N448 I1=FE_PHN1710_y_reg_14 I2=add_117/carry[14]
XU166 AN2 $PINS O=add_117/carry[14] I1=add_117/carry[13] I2=FE_PHN1765_y_reg_13
XU167 XOR2HS $PINS O=N447 I1=FE_PHN1765_y_reg_13 I2=add_117/carry[13]
XU168 AN2 $PINS O=add_117/carry[13] I1=add_117/carry[12] I2=FE_PHN1767_y_reg_12
XU169 XOR2HS $PINS O=N446 I1=FE_PHN1767_y_reg_12 I2=add_117/carry[12]
XU170 AN2 $PINS O=add_117/carry[12] I1=add_117/carry[11] I2=FE_PHN1515_y_reg_11
XU171 XOR2HS $PINS O=N445 I1=FE_PHN1515_y_reg_11 I2=add_117/carry[11]
XU172 AN2 $PINS O=add_117/carry[11] I1=add_117/carry[10] I2=FE_PHN1474_y_reg_10
XU173 XOR2HS $PINS O=N444 I1=FE_PHN1474_y_reg_10 I2=add_117/carry[10]
XU174 AN2 $PINS O=FE_PHN2055_add_117_carry_10 I1=add_117/carry[9] I2=y_reg[9]
XU175 XOR2HS $PINS O=N443 I1=y_reg[9] I2=add_117/carry[9]
XU176 AN2 $PINS O=add_117/carry[9] I1=add_117/carry[8] I2=y_reg[8]
XU177 XOR2HS $PINS O=N442 I1=y_reg[8] I2=add_117/carry[8]
XU178 AN2 $PINS O=add_117/carry[8] I1=add_117/carry[7] I2=FE_PHN1751_y_reg_7
XU179 XOR2HS $PINS O=N441 I1=FE_PHN1751_y_reg_7 I2=add_117/carry[7]
XU180 AN2 $PINS O=add_117/carry[7] I1=add_117/carry[6] I2=FE_PHN1766_y_reg_6
XU181 XOR2HS $PINS O=N440 I1=FE_PHN1766_y_reg_6 I2=add_117/carry[6]
XU182 AN2 $PINS O=add_117/carry[6] I1=FE_PHN1736_y_reg_4 I2=FE_PHN1754_y_reg_5
XU183 XOR2HS $PINS O=N439 I1=FE_PHN1754_y_reg_5 I2=FE_PHN1736_y_reg_4
XU184 XOR2HS $PINS O=N146 I1=n17 I2=sub_87/carry[16]
XU185 AN2 $PINS O=sub_87/carry[16] I1=sub_87/carry[15] I2=n18
XU186 XOR2HS $PINS O=N145 I1=n18 I2=sub_87/carry[15]
XU187 AN2 $PINS O=sub_87/carry[15] I1=sub_87/carry[14] I2=n19
XU188 XOR2HS $PINS O=N144 I1=n19 I2=sub_87/carry[14]
XU189 AN2 $PINS O=sub_87/carry[14] I1=sub_87/carry[13] I2=n20
XU190 XOR2HS $PINS O=N143 I1=n20 I2=sub_87/carry[13]
XU191 AN2 $PINS O=sub_87/carry[13] I1=sub_87/carry[12] I2=n21
XU192 XOR2HS $PINS O=N142 I1=n21 I2=sub_87/carry[12]
XU193 AN2 $PINS O=sub_87/carry[12] I1=sub_87/carry[11] I2=n22
XU194 XOR2HS $PINS O=N141 I1=n22 I2=sub_87/carry[11]
XU195 AN2 $PINS O=sub_87/carry[11] I1=sub_87/carry[10] I2=n23
XU196 XOR2HS $PINS O=N140 I1=n23 I2=sub_87/carry[10]
XU197 AN2 $PINS O=sub_87/carry[10] I1=sub_87/carry[9] I2=n24
XU198 XOR2HS $PINS O=N139 I1=n24 I2=sub_87/carry[9]
XU199 AN2 $PINS O=sub_87/carry[9] I1=sub_87/carry[8] I2=n25
XU200 XOR2HS $PINS O=N138 I1=n25 I2=sub_87/carry[8]
XU201 AN2 $PINS O=sub_87/carry[8] I1=sub_87/carry[7] I2=n26
XU202 XOR2HS $PINS O=N137 I1=n26 I2=sub_87/carry[7]
XU203 AN2 $PINS O=sub_87/carry[7] I1=sub_87/carry[6] I2=n27
XU204 XOR2HS $PINS O=N136 I1=n27 I2=sub_87/carry[6]
XU205 AN2 $PINS O=sub_87/carry[6] I1=sub_87/carry[5] I2=n28
XU206 XOR2HS $PINS O=N135 I1=n28 I2=sub_87/carry[5]
XU207 AN2 $PINS O=sub_87/carry[5] I1=sub_87/carry[4] I2=n29
XU208 XOR2HS $PINS O=N134 I1=n29 I2=sub_87/carry[4]
XU209 AN2 $PINS O=sub_87/carry[4] I1=sub_87/carry[3] I2=n30
XU210 XOR2HS $PINS O=N133 I1=n30 I2=sub_87/carry[3]
XU211 AN2 $PINS O=sub_87/carry[3] I1=sub_87/carry[2] I2=n31
XU212 XOR2HS $PINS O=N132 I1=n31 I2=sub_87/carry[2]
XU213 XOR2HS $PINS O=N131 I1=n32 I2=n33
XU214 XOR2HS $PINS O=N164 I1=n34 I2=sub_88/carry[16]
XU215 AN2 $PINS O=sub_88/carry[16] I1=sub_88/carry[15] I2=n35
XU216 XOR2HS $PINS O=N163 I1=n35 I2=sub_88/carry[15]
XU217 AN2 $PINS O=sub_88/carry[15] I1=sub_88/carry[14] I2=n36
XU218 XOR2HS $PINS O=N162 I1=n36 I2=sub_88/carry[14]
XU219 AN2 $PINS O=sub_88/carry[14] I1=sub_88/carry[13] I2=n37
XU220 XOR2HS $PINS O=N161 I1=n37 I2=sub_88/carry[13]
XU221 AN2 $PINS O=sub_88/carry[13] I1=sub_88/carry[12] I2=n38
XU222 XOR2HS $PINS O=N160 I1=n38 I2=sub_88/carry[12]
XU223 AN2 $PINS O=sub_88/carry[12] I1=sub_88/carry[11] I2=n39
XU224 XOR2HS $PINS O=N159 I1=n39 I2=sub_88/carry[11]
XU225 AN2 $PINS O=sub_88/carry[11] I1=sub_88/carry[10] I2=n40
XU226 XOR2HS $PINS O=N158 I1=n40 I2=sub_88/carry[10]
XU227 AN2 $PINS O=sub_88/carry[10] I1=sub_88/carry[9] I2=n41
XU228 XOR2HS $PINS O=N157 I1=n41 I2=sub_88/carry[9]
XU229 AN2 $PINS O=sub_88/carry[9] I1=sub_88/carry[8] I2=n42
XU230 XOR2HS $PINS O=N156 I1=n42 I2=sub_88/carry[8]
XU231 AN2 $PINS O=sub_88/carry[8] I1=sub_88/carry[7] I2=n43
XU232 XOR2HS $PINS O=N155 I1=n43 I2=sub_88/carry[7]
XU233 AN2 $PINS O=sub_88/carry[7] I1=sub_88/carry[6] I2=n44
XU234 XOR2HS $PINS O=N154 I1=n44 I2=sub_88/carry[6]
XU235 AN2 $PINS O=sub_88/carry[6] I1=sub_88/carry[5] I2=n45
XU236 XOR2HS $PINS O=N153 I1=n45 I2=sub_88/carry[5]
XU237 AN2 $PINS O=sub_88/carry[5] I1=sub_88/carry[4] I2=n46
XU238 XOR2HS $PINS O=N152 I1=n46 I2=sub_88/carry[4]
XU239 AN2 $PINS O=sub_88/carry[4] I1=sub_88/carry[3] I2=n47
XU240 XOR2HS $PINS O=N151 I1=n47 I2=sub_88/carry[3]
XU241 AN2 $PINS O=sub_88/carry[3] I1=sub_88/carry[2] I2=n48
XU242 XOR2HS $PINS O=N150 I1=n48 I2=sub_88/carry[2]
XU243 XOR2HS $PINS O=N149 I1=n49 I2=n50
XU244 ND3 $PINS O=y_shift[9] I1=n51 I2=n52 I3=n53
XU245 NR2 $PINS O=n53 I1=n54 I2=n55
XU246 MOAI1S $PINS O=n55 A1=FE_OFN48_n56 A2=n57 B1=n14 B2=FE_PHN2190_y_reg_11
XU247 MOAI1S $PINS O=n54 A1=FE_OFN257_n4 A2=n58 B1=n2 B2=y_reg[9]
XU248 AOI22S $PINS O=n51 A1=FE_PHN1767_y_reg_12 A2=n64 B1=FE_PHN1765_y_reg_13
+ B2=n65
XU249 ND3 $PINS O=y_shift[8] I1=n66 I2=n67 I3=n68
XU250 NR2 $PINS O=n68 I1=n69 I2=n70
XU251 MOAI1S $PINS O=n70 A1=n71 A2=FE_OFN48_n56 B1=n14 B2=FE_PHN2186_y_reg_10
XU252 OAI222S $PINS O=n69 A1=FE_DBTN14_n2 A2=n72 B1=n73 B2=n74 C1=n59
+ C2=FE_OFN257_n4
XU253 AOI22S $PINS O=n66 A1=n77 A2=y_reg[16] B1=FE_PHN2190_y_reg_11 B2=n64
XU254 ND3 $PINS O=y_shift[7] I1=n78 I2=n79 I3=n80
XU255 NR2 $PINS O=n80 I1=n81 I2=n82
XU256 MOAI1S $PINS O=n82 A1=FE_OFN48_n56 A2=n72 B1=y_reg[9] B2=n14
XU257 OAI222S $PINS O=n81 A1=FE_DBTN14_n2 A2=n83 B1=n74 B2=n84 C1=n63
+ C2=FE_OFN257_n4
XU258 ND3 $PINS O=y_shift[6] I1=n89 I2=n90 I3=n91
XU259 NR2 $PINS O=n91 I1=n92 I2=n93
XU260 MOAI1S $PINS O=n93 A1=FE_OFN48_n56 A2=n83 B1=n14 B2=y_reg[8]
XU261 OAI222S $PINS O=n92 A1=FE_DBTN14_n2 A2=n94 B1=n74 B2=n57 C1=n76
+ C2=FE_OFN257_n4
XU262 ND3 $PINS O=y_shift[5] I1=n95 I2=n96 I3=n97
XU263 NR2 $PINS O=n97 I1=n98 I2=n99
XU264 MOAI1S $PINS O=n99 A1=FE_OFN48_n56 A2=n94 B1=n14 B2=FE_PHN1751_y_reg_7
XU265 OAI222S $PINS O=n98 A1=FE_DBTN14_n2 A2=n100 B1=n74 B2=n71 C1=n73
+ C2=FE_OFN257_n4
XU266 ND3 $PINS O=y_shift[4] I1=n101 I2=n102 I3=n103
XU267 NR2 $PINS O=n103 I1=n104 I2=n105
XU268 MOAI1S $PINS O=n105 A1=FE_OFN48_n56 A2=n100 B1=n14 B2=FE_PHN1766_y_reg_6
XU269 OAI222S $PINS O=n104 A1=FE_DBTN14_n2 A2=n106 B1=n74 B2=n72
+ C1=FE_OFN257_n4 C2=n84
XU270 ND3 $PINS O=y_shift[3] I1=n107 I2=n108 I3=n109
XU271 NR2 $PINS O=n109 I1=n110 I2=n111
XU272 MOAI1S $PINS O=n111 A1=FE_OFN48_n56 A2=n106 B1=n14 B2=FE_PHN1754_y_reg_5
XU273 OAI222S $PINS O=n110 A1=FE_DBTN14_n2 A2=n112 B1=n74 B2=n83
+ C1=FE_OFN257_n4 C2=n57
XU274 ND3 $PINS O=y_shift[2] I1=n113 I2=n114 I3=n115
XU275 NR2 $PINS O=n115 I1=n116 I2=n117
XU276 MOAI1S $PINS O=n117 A1=FE_OFN48_n56 A2=n112 B1=n14 B2=FE_PHN1736_y_reg_4
XU277 OAI222S $PINS O=n116 A1=FE_DBTN14_n2 A2=n118 B1=n74 B2=n94 C1=n71
+ C2=FE_OFN257_n4
XU278 ND3 $PINS O=y_shift[1] I1=n119 I2=n120 I3=n121
XU279 NR2 $PINS O=n121 I1=n122 I2=n123
XU280 MOAI1S $PINS O=n123 A1=FE_OFN48_n56 A2=n118 B1=n14 B2=y_reg[3]
XU282 INV1S $PINS O=n106 I=FE_PHN1736_y_reg_4
XU283 MOAI1S $PINS O=y_shift[16] A1=FE_DBTN14_n2 A2=n58 B1=y_reg[17] B2=n125
XU284 OAI222S $PINS O=y_shift[15] A1=n59 A2=FE_DBTN14_n2 B1=n126 B2=n61 C1=n58
+ C2=FE_OFN48_n56
XU285 ND2 $PINS O=y_shift[14] I1=n127 I2=n128
XU286 AOI22S $PINS O=n128 A1=y_reg[17] A2=n129 B1=n2 B2=FE_PHN1710_y_reg_14
XU287 AOI22S $PINS O=n127 A1=n14 A2=y_reg[16] B1=n6 B2=FE_PHN1776_y_reg_15
XU288 ND2 $PINS O=y_shift[13] I1=n130 I2=n131
XU289 AOI22S $PINS O=n130 A1=n14 A2=FE_PHN1776_y_reg_15 B1=n6
+ B2=FE_PHN1710_y_reg_14
XU290 ND2 $PINS O=y_shift[12] I1=n133 I2=n134
XU291 INV1S $PINS O=n59 I=FE_PHN1776_y_reg_15
XU292 INV1S $PINS O=n61 I=y_reg[17]
XU293 INV1S $PINS O=n58 I=y_reg[16]
XU294 INV1S $PINS O=n63 I=y_reg[14]
XU295 ND3 $PINS O=y_shift[11] I1=n137 I2=n138 I3=n139
XU296 AOI22S $PINS O=n138 A1=y_reg[17] A2=n140 B1=y_reg[16] B2=FE_OFN339_n141
XU297 AOI22S $PINS O=n137 A1=n64 A2=FE_PHN1710_y_reg_14 B1=n65
+ B2=FE_PHN2107_y_reg_15
XU298 ND3 $PINS O=y_shift[10] I1=n142 I2=n143 I3=n144
XU299 NR2 $PINS O=n144 I1=n145 I2=n146
XU300 MOAI1S $PINS O=n146 A1=n84 A2=FE_OFN48_n56 B1=FE_PHN1767_y_reg_12 B2=n14
XU301 MOAI1S $PINS O=n145 A1=FE_DBTN14_n2 A2=n57 B1=y_reg[14] B2=n65
XU302 AOI22S $PINS O=n143 A1=y_reg[17] A2=n147 B1=FE_PHN1776_y_reg_15
+ B2=FE_OFN339_n141
XU303 AOI22S $PINS O=n142 A1=y_reg[16] A2=n148 B1=FE_PHN1765_y_reg_13 B2=n64
XU304 ND3 $PINS O=y_shift[0] I1=n149 I2=n150 I3=n151
XU305 NR2 $PINS O=n151 I1=FE_PHN2180_n152 I2=n153
XU306 MOAI1S $PINS O=n153 A1=n136 A2=n118 B1=n6 B2=y_reg[1]
XU307 INV1S $PINS O=n118 I=y_reg[2]
XU308 OA222 $PINS O=n150 A1=n85 A2=n72 B1=n62 B2=n100 C1=n3 C2=n94
XU313 INV1S $PINS O=n112 I=y_reg[3]
XU314 ND3 $PINS O=x_shift[9] I1=n154 I2=n155 I3=n156
XU315 NR2 $PINS O=n156 I1=n157 I2=n158
XU316 MOAI1S $PINS O=n158 A1=FE_OFN48_n56 A2=n159 B1=n14 B2=FE_PHN1781_x_reg_11
XU317 MOAI1S $PINS O=n157 A1=FE_OFN257_n4 A2=n160 B1=n2 B2=x_reg[9]
XU318 AOI22S $PINS O=n154 A1=FE_PHN1782_x_reg_12 A2=n64 B1=FE_PHN1785_x_reg_13
+ B2=n65
XU319 ND3 $PINS O=x_shift[8] I1=n164 I2=n165 I3=n166
XU320 NR2 $PINS O=n166 I1=n167 I2=n168
XU321 MOAI1S $PINS O=n168 A1=FE_OFN48_n56 A2=n169 B1=n14 B2=x_reg[10]
XU322 OAI222S $PINS O=n167 A1=FE_DBTN14_n2 A2=n170 B1=n74 B2=n171
+ C1=FE_OFN257_n4 C2=n161
XU323 AOI22S $PINS O=n164 A1=FE_PHN1783_x_reg_16 A2=n77 B1=FE_PHN1781_x_reg_11
+ B2=n64
XU324 INV1S $PINS O=n77 I=n85
XU325 ND3 $PINS O=x_shift[7] I1=n173 I2=n174 I3=n175
XU326 NR2 $PINS O=n175 I1=n176 I2=n177
XU327 MOAI1S $PINS O=n177 A1=FE_OFN48_n56 A2=n170 B1=n14 B2=x_reg[9]
XU328 OAI222S $PINS O=n176 A1=FE_DBTN14_n2 A2=n178 B1=n74 B2=n179
+ C1=FE_OFN257_n4 C2=n163
XU329 ND3 $PINS O=x_shift[6] I1=n180 I2=n181 I3=n182
XU330 NR2 $PINS O=n182 I1=n183 I2=n184
XU331 MOAI1S $PINS O=n184 A1=FE_OFN48_n56 A2=n178 B1=n14 B2=x_reg[8]
XU332 OAI222S $PINS O=n183 A1=FE_DBTN14_n2 A2=n185 B1=n74 B2=n159
+ C1=FE_OFN257_n4 C2=n172
XU333 ND3 $PINS O=x_shift[5] I1=n186 I2=n187 I3=n188
XU334 NR2 $PINS O=n188 I1=n189 I2=n190
XU335 MOAI1S $PINS O=n190 A1=FE_OFN48_n56 A2=n185 B1=n14 B2=x_reg[7]
XU336 OAI222S $PINS O=n189 A1=FE_DBTN14_n2 A2=n191 B1=n74 B2=n169
+ C1=FE_OFN257_n4 C2=n171
XU337 ND3 $PINS O=x_shift[4] I1=n192 I2=n193 I3=n194
XU338 NR2 $PINS O=n194 I1=n195 I2=n196
XU339 MOAI1S $PINS O=n196 A1=FE_OFN48_n56 A2=n191 B1=n14 B2=x_reg[6]
XU340 OAI222S $PINS O=n195 A1=FE_DBTN14_n2 A2=n197 B1=n74 B2=n170
+ C1=FE_OFN257_n4 C2=n179
XU341 ND3 $PINS O=x_shift[3] I1=n198 I2=n199 I3=n200
XU342 NR2 $PINS O=n200 I1=n201 I2=n202
XU343 MOAI1S $PINS O=n202 A1=FE_OFN48_n56 A2=n197 B1=n14 B2=x_reg[5]
XU344 OAI222S $PINS O=n201 A1=FE_DBTN14_n2 A2=n203 B1=n74 B2=n178
+ C1=FE_OFN257_n4 C2=n159
XU345 ND3 $PINS O=x_shift[2] I1=n204 I2=n205 I3=n206
XU346 NR2 $PINS O=n206 I1=n207 I2=n208
XU347 MOAI1S $PINS O=n208 A1=FE_OFN48_n56 A2=n203 B1=n14 B2=x_reg[4]
XU348 OAI222S $PINS O=n207 A1=FE_DBTN14_n2 A2=n209 B1=n74 B2=n185
+ C1=FE_OFN257_n4 C2=n169
XU349 ND3 $PINS O=x_shift[1] I1=n210 I2=n211 I3=n212
XU350 NR2 $PINS O=n212 I1=n213 I2=n214
XU351 MOAI1S $PINS O=n214 A1=FE_OFN48_n56 A2=n209 B1=n14 B2=x_reg[3]
XU353 INV1S $PINS O=n197 I=x_reg[4]
XU354 MOAI1S $PINS O=x_shift[16] A1=FE_DBTN14_n2 A2=n160 B1=FE_PHN1772_x_reg_17
+ B2=n125
XU355 ND2 $PINS O=n125 I1=n126 I2=n56
XU356 OAI222S $PINS O=x_shift[15] A1=FE_DBTN14_n2 A2=n161 B1=n126 B2=n162
+ C1=n56 C2=n160
XU357 NR2 $PINS O=n126 I1=n129 I2=n14
XU358 ND2 $PINS O=x_shift[14] I1=n215 I2=n216
XU359 AOI22S $PINS O=n216 A1=FE_PHN1772_x_reg_17 A2=n129 B1=x_reg[14] B2=n2
XU360 ND2 $PINS O=n129 I1=n132 I2=FE_OFN354_n86
XU361 AOI22S $PINS O=n215 A1=FE_PHN1783_x_reg_16 A2=n14 B1=x_reg[15] B2=n6
XU362 ND2 $PINS O=x_shift[13] I1=n217 I2=n218
XU363 AN2 $PINS O=n132 I1=n135 I2=n74
XU364 AOI22S $PINS O=n217 A1=x_reg[15] A2=n14 B1=x_reg[14] B2=n6
XU365 ND2 $PINS O=x_shift[12] I1=n219 I2=n220
XU366 INV1S $PINS O=n161 I=x_reg[15]
XU367 INV1S $PINS O=n162 I=FE_PHN1772_x_reg_17
XU368 NR2 $PINS O=n135 I1=n140 I2=FE_OFN338_n141
XU369 INV1S $PINS O=n160 I=FE_PHN1783_x_reg_16
XU370 INV1S $PINS O=n163 I=x_reg[14]
XU371 ND3 $PINS O=x_shift[11] I1=n221 I2=n222 I3=n223
XU372 AOI22S $PINS O=n222 A1=FE_PHN1772_x_reg_17 A2=n140 B1=FE_PHN1783_x_reg_16
+ B2=FE_OFN338_n141
XU373 AOI22S $PINS O=n221 A1=x_reg[14] A2=n64 B1=x_reg[15] B2=n65
XU374 ND3 $PINS O=x_shift[10] I1=n224 I2=n225 I3=n226
XU375 NR2 $PINS O=n226 I1=n227 I2=n228
XU376 MOAI1S $PINS O=n228 A1=FE_OFN48_n56 A2=n179 B1=n14 B2=FE_PHN1782_x_reg_12
XU377 MOAI1S $PINS O=n227 A1=FE_DBTN14_n2 A2=n159 B1=n65 B2=x_reg[14]
XU378 AOI22S $PINS O=n225 A1=FE_PHN1772_x_reg_17 A2=n147 B1=x_reg[15]
+ B2=FE_OFN338_n141
XU379 ND2 $PINS O=n147 I1=n60 I2=FE_OFN257_n4
XU380 AN2 $PINS O=n60 I1=n75 I2=n85
XU381 AN2 $PINS O=n75 I1=n88 I2=n87
XU382 AOI22S $PINS O=n224 A1=FE_PHN1783_x_reg_16 A2=n148 B1=FE_PHN1785_x_reg_13
+ B2=n64
XU383 INV1S $PINS O=n64 I=FE_OFN354_n86
XU384 ND3P $PINS O=x_shift[0] I1=n229 I2=n230 I3=n231
XU385 NR2 $PINS O=n231 I1=n232 I2=n233
XU386 MOAI1S $PINS O=n233 A1=n136 A2=n209 B1=n6 B2=x_reg[1]
XU387 INV1S $PINS O=n209 I=x_reg[2]
XU388 OA222 $PINS O=n230 A1=n85 A2=n170 B1=n62 B2=n191 C1=n3 C2=n185
XU390 NR2 $PINS O=n148 I1=n235 I2=step_cnt[3]
XU391 INV1S $PINS O=n191 I=x_reg[5]
XU392 NR2 $PINS O=n141 I1=n236 I2=step_cnt[3]
XU393 INV1S $PINS O=n170 I=x_reg[8]
XU394 OA222 $PINS O=n229 A1=FE_OFN354_n86 A2=n203 B1=n87 B2=n159 C1=n88 C2=n169
XU396 INV1S $PINS O=n203 I=x_reg[3]
XU397 AO22 $PINS O=n361 A1=N313 A2=n1 B1=N365 B2=n242
XU398 AO22 $PINS O=n362 A1=N312 A2=n1 B1=N364 B2=n242
XU399 AO22 $PINS O=n363 A1=N311 A2=n1 B1=N363 B2=n242
XU400 AO22 $PINS O=FE_PHN1990_n364 A1=N310 A2=n1 B1=N362 B2=n242
XU401 AO22 $PINS O=FE_PHN1985_n365 A1=N309 A2=n1 B1=N361 B2=n242
XU402 AO22 $PINS O=n366 A1=N308 A2=n1 B1=N360 B2=n242
XU403 AO22 $PINS O=n367 A1=N307 A2=n1 B1=N359 B2=n242
XU404 AO22 $PINS O=n368 A1=N306 A2=n1 B1=N358 B2=n242
XU405 NR3 $PINS O=N515 I1=n243 I2=n241 I3=FE_OFN303_n244
XU406 ND2 $PINS O=N514 I1=n245 I2=n246
XU408 AOI22S $PINS O=n245 A1=FE_PHN1728_c_in_i_1_16 A2=n247 B1=N165 B2=n248
XU409 ND2 $PINS O=N513 I1=n249 I2=n250
XU410 AOI22S $PINS O=n250 A1=N356 A2=FE_OFN49_n242 B1=N304 B2=FE_OFN47_n1
XU411 AOI22S $PINS O=n249 A1=FE_PHN1728_c_in_i_1_16 A2=n247 B1=N164 B2=n248
XU412 ND2 $PINS O=N512 I1=n251 I2=n252
XU413 AOI22S $PINS O=n252 A1=N355 A2=FE_OFN49_n242 B1=N303 B2=FE_OFN47_n1
XU414 AOI22S $PINS O=n251 A1=y_in[15] A2=n247 B1=N163 B2=n248
XU415 ND2 $PINS O=N511 I1=n253 I2=n254
XU416 AOI22S $PINS O=n254 A1=N354 A2=FE_OFN49_n242 B1=N302 B2=FE_OFN47_n1
XU417 AOI22S $PINS O=n253 A1=FE_PHN1663_c_in_i_1_14 A2=n247 B1=N162 B2=n248
XU418 ND2 $PINS O=N510 I1=n255 I2=n256
XU419 AOI22S $PINS O=n256 A1=N353 A2=FE_OFN49_n242 B1=N301 B2=FE_OFN47_n1
XU420 AOI22S $PINS O=n255 A1=FE_PHN1681_c_in_i_1_13 A2=n247 B1=N161
+ B2=FE_OFN51_n248
XU421 ND2 $PINS O=N509 I1=n257 I2=n258
XU422 AOI22S $PINS O=n258 A1=N352 A2=FE_OFN49_n242 B1=N300 B2=FE_OFN47_n1
XU423 AOI22S $PINS O=n257 A1=FE_PHN1656_c_in_i_1_12 A2=FE_OCPN0_FE_OFN50_n247
+ B1=N160 B2=FE_OFN51_n248
XU424 ND2 $PINS O=N508 I1=n259 I2=n260
XU425 AOI22S $PINS O=n260 A1=N351 A2=FE_OFN49_n242 B1=N299 B2=FE_OFN47_n1
XU426 AOI22S $PINS O=n259 A1=FE_PHN1705_c_in_i_1_11 A2=FE_OCPN0_FE_OFN50_n247
+ B1=N159 B2=FE_OFN51_n248
XU427 ND2 $PINS O=N507 I1=n261 I2=n262
XU428 AOI22S $PINS O=n262 A1=N350 A2=FE_OFN49_n242 B1=N298 B2=FE_OFN47_n1
XU429 AOI22S $PINS O=n261 A1=FE_PHN2086_c_in_i_1_10 A2=FE_OCPN0_FE_OFN50_n247
+ B1=N158 B2=FE_OFN51_n248
XU430 ND2 $PINS O=N506 I1=n263 I2=n264
XU431 AOI22S $PINS O=n264 A1=N349 A2=FE_OFN49_n242 B1=N297 B2=FE_OFN47_n1
XU432 AOI22S $PINS O=n263 A1=y_in[9] A2=FE_OCPN0_FE_OFN50_n247 B1=N157
+ B2=FE_OFN51_n248
XU433 ND2 $PINS O=N505 I1=n265 I2=n266
XU434 AOI22S $PINS O=n266 A1=N348 A2=FE_OFN49_n242 B1=N296 B2=FE_OFN47_n1
XU435 AOI22S $PINS O=n265 A1=y_in[8] A2=FE_OCPN0_FE_OFN50_n247 B1=N156
+ B2=FE_OFN51_n248
XU436 ND2 $PINS O=N504 I1=n267 I2=n268
XU437 AOI22S $PINS O=n268 A1=N347 A2=FE_OFN49_n242 B1=N295 B2=FE_OFN47_n1
XU438 AOI22S $PINS O=n267 A1=y_in[7] A2=FE_OCPN0_FE_OFN50_n247 B1=N155
+ B2=FE_OFN51_n248
XU439 ND2 $PINS O=N503 I1=n269 I2=n270
XU440 AOI22S $PINS O=n270 A1=N346 A2=FE_OFN49_n242 B1=N294 B2=FE_OFN47_n1
XU441 AOI22S $PINS O=n269 A1=y_in[6] A2=FE_OCPN0_FE_OFN50_n247 B1=N154
+ B2=FE_OFN51_n248
XU442 ND2 $PINS O=N502 I1=n271 I2=n272
XU443 AOI22S $PINS O=n272 A1=N345 A2=FE_OFN49_n242 B1=N293 B2=FE_OFN47_n1
XU444 AOI22S $PINS O=n271 A1=y_in[5] A2=FE_OCPN0_FE_OFN50_n247 B1=N153
+ B2=FE_OFN51_n248
XU445 ND2 $PINS O=N501 I1=n273 I2=n274
XU446 AOI22S $PINS O=n274 A1=N344 A2=FE_OFN49_n242 B1=N292 B2=FE_OFN47_n1
XU447 AOI22S $PINS O=n273 A1=y_in[4] A2=FE_OCPN0_FE_OFN50_n247 B1=N152
+ B2=FE_OFN51_n248
XU448 ND2 $PINS O=FE_PHN2064_N500 I1=n275 I2=FE_PHN2010_n276
XU449 AOI22S $PINS O=n276 A1=N343 A2=FE_OFN49_n242 B1=N291 B2=FE_OFN47_n1
XU450 AOI22S $PINS O=n275 A1=y_in[3] A2=FE_OCPN0_FE_OFN50_n247 B1=N151
+ B2=FE_OFN51_n248
XU451 ND2 $PINS O=FE_PHN2066_N499 I1=n277 I2=n278
XU452 AOI22S $PINS O=n278 A1=N342 A2=FE_OFN49_n242 B1=N290 B2=FE_OFN47_n1
XU453 AOI22S $PINS O=n277 A1=y_in[2] A2=FE_OCPN0_FE_OFN50_n247 B1=N150
+ B2=FE_OFN51_n248
XU454 ND2 $PINS O=N498 I1=n279 I2=n280
XU455 AOI22S $PINS O=n280 A1=N341 A2=FE_OFN49_n242 B1=N289 B2=FE_OFN47_n1
XU456 AOI22S $PINS O=n279 A1=y_in[1] A2=FE_OCPN0_FE_OFN50_n247 B1=N149
+ B2=FE_OFN51_n248
XU457 ND2 $PINS O=N497 I1=n281 I2=FE_PHN1910_n282
XU458 AOI22S $PINS O=n282 A1=N340 A2=FE_OFN49_n242 B1=N288 B2=FE_OFN47_n1
XU459 AOI22S $PINS O=n281 A1=N148 A2=FE_OCPN0_FE_OFN50_n247 B1=N148
+ B2=FE_OFN51_n248
XU460 ND2 $PINS O=N496 I1=n283 I2=n284
XU461 AOI22S $PINS O=n284 A1=N339 A2=n242 B1=N287 B2=n1
XU462 AOI22S $PINS O=n283 A1=x_in[16] A2=FE_OCPN0_FE_OFN50_n247 B1=N147
+ B2=FE_OFN51_n248
XU463 ND2 $PINS O=N495 I1=n285 I2=n286
XU464 AOI22S $PINS O=n286 A1=N338 A2=n242 B1=N286 B2=n1
XU465 AOI22S $PINS O=n285 A1=x_in[16] A2=FE_OCPN0_FE_OFN50_n247 B1=N146
+ B2=FE_OFN51_n248
XU466 ND2 $PINS O=N494 I1=n287 I2=n288
XU467 AOI22S $PINS O=n288 A1=N337 A2=n242 B1=N285 B2=n1
XU468 AOI22S $PINS O=n287 A1=x_in[15] A2=FE_OCPN0_FE_OFN50_n247 B1=N145
+ B2=FE_OFN51_n248
XU469 ND2 $PINS O=N493 I1=n289 I2=n290
XU470 AOI22S $PINS O=n290 A1=N336 A2=n242 B1=N284 B2=n1
XU471 AOI22S $PINS O=n289 A1=x_in[14] A2=FE_OCPN0_FE_OFN50_n247 B1=N144
+ B2=FE_OFN51_n248
XU472 ND2 $PINS O=N492 I1=n291 I2=n292
XU473 AOI22S $PINS O=n292 A1=N335 A2=n242 B1=N283 B2=n1
XU474 AOI22S $PINS O=n291 A1=x_in[13] A2=FE_OCPN0_FE_OFN50_n247 B1=N143
+ B2=FE_OFN51_n248
XU475 ND2 $PINS O=N491 I1=n293 I2=n294
XU476 AOI22S $PINS O=n294 A1=N334 A2=n242 B1=N282 B2=n1
XU477 AOI22S $PINS O=n293 A1=FE_PHN2085_c_in_r_1_12 A2=FE_OCPN0_FE_OFN50_n247
+ B1=N142 B2=FE_OFN51_n248
XU478 ND2 $PINS O=N490 I1=n295 I2=n296
XU479 AOI22S $PINS O=n296 A1=N333 A2=n242 B1=N281 B2=n1
XU480 AOI22S $PINS O=n295 A1=FE_PHN2083_c_in_r_1_11 A2=FE_OCPN0_FE_OFN50_n247
+ B1=N141 B2=FE_OFN51_n248
XU481 ND2 $PINS O=N489 I1=n297 I2=n298
XU482 AOI22S $PINS O=n298 A1=N332 A2=n242 B1=N280 B2=n1
XU483 AOI22S $PINS O=n297 A1=x_in[10] A2=FE_OCPN0_FE_OFN50_n247 B1=N140
+ B2=FE_OFN51_n248
XU484 ND2 $PINS O=FE_PHN2206_N488 I1=n299 I2=n300
XU485 AOI22S $PINS O=n300 A1=N331 A2=n242 B1=N279 B2=n1
XU486 AOI22S $PINS O=n299 A1=x_in[9] A2=FE_OCPN0_FE_OFN50_n247 B1=N139
+ B2=FE_OFN51_n248
XU487 ND2 $PINS O=N487 I1=n301 I2=n302
XU488 AOI22S $PINS O=n302 A1=N330 A2=n242 B1=N278 B2=n1
XU489 AOI22S $PINS O=n301 A1=x_in[8] A2=FE_OCPN0_FE_OFN50_n247 B1=N138
+ B2=FE_OFN51_n248
XU490 ND2 $PINS O=N486 I1=n303 I2=n304
XU491 AOI22S $PINS O=n304 A1=N329 A2=n242 B1=N277 B2=n1
XU492 AOI22S $PINS O=n303 A1=x_in[7] A2=FE_OCPN0_FE_OFN50_n247 B1=N137
+ B2=FE_OFN51_n248
XU493 ND2 $PINS O=N485 I1=n305 I2=n306
XU494 AOI22S $PINS O=n306 A1=N328 A2=n242 B1=N276 B2=n1
XU495 AOI22S $PINS O=n305 A1=x_in[6] A2=FE_OCPN0_FE_OFN50_n247 B1=N136
+ B2=FE_OFN51_n248
XU496 ND2 $PINS O=N484 I1=n307 I2=n308
XU497 AOI22S $PINS O=n308 A1=N327 A2=n242 B1=N275 B2=n1
XU498 AOI22S $PINS O=n307 A1=x_in[5] A2=FE_OCPN0_FE_OFN50_n247 B1=N135
+ B2=FE_OFN51_n248
XU499 ND2 $PINS O=N483 I1=n309 I2=n310
XU500 AOI22S $PINS O=n310 A1=N326 A2=n242 B1=N274 B2=n1
XU501 AOI22S $PINS O=n309 A1=x_in[4] A2=FE_OCPN0_FE_OFN50_n247 B1=N134
+ B2=FE_OFN51_n248
XU502 ND2 $PINS O=N482 I1=n311 I2=n312
XU503 AOI22S $PINS O=n312 A1=N325 A2=n242 B1=N273 B2=n1
XU504 AOI22S $PINS O=n311 A1=x_in[3] A2=FE_OCPN0_FE_OFN50_n247 B1=N133
+ B2=FE_OFN51_n248
XU505 ND2 $PINS O=FE_PHN1914_N481 I1=n313 I2=n314
XU506 AOI22S $PINS O=n314 A1=N324 A2=FE_OFN49_n242 B1=N272 B2=FE_OFN47_n1
XU507 AOI22S $PINS O=n313 A1=x_in[2] A2=FE_OCPN0_FE_OFN50_n247 B1=N132
+ B2=FE_OFN51_n248
XU508 ND2 $PINS O=N480 I1=n315 I2=n316
XU509 AOI22S $PINS O=n316 A1=N323 A2=FE_OFN49_n242 B1=N271 B2=FE_OFN47_n1
XU510 AOI22S $PINS O=n315 A1=x_in[1] A2=FE_OCPN0_FE_OFN50_n247 B1=N131
+ B2=FE_OFN51_n248
XU511 ND2 $PINS O=N479 I1=n317 I2=n318
XU512 AOI22S $PINS O=n318 A1=N322 A2=FE_OFN49_n242 B1=N270 B2=FE_OFN47_n1
XU513 AOI22S $PINS O=n317 A1=N130 A2=FE_OCPN0_FE_OFN50_n247 B1=N130
+ B2=FE_OFN51_n248
XU514 INV1S $PINS O=n247 I=n319
XU515 OAI112HS $PINS O=N478 A1=FE_PHN1950_n321 B1=n322 C1=n320 C2=n319
XU516 AOI22S $PINS O=n322 A1=n320 A2=n323 B1=n320 B2=n324
XU517 AOI22S $PINS O=n321 A1=N373 A2=FE_OFN49_n242 B1=N321 B2=FE_OFN47_n1
XU518 OAI112HS $PINS O=N477 A1=FE_PHN1928_n326 B1=n327 C1=n325 C2=n319
XU519 AOI22S $PINS O=n327 A1=N182 A2=n323 B1=N182 B2=n324
XU520 AOI22S $PINS O=n326 A1=N372 A2=FE_OFN49_n242 B1=N320 B2=FE_OFN47_n1
XU521 OAI112HS $PINS O=N476 A1=FE_PHN2003_n329 B1=n330 C1=n319 C2=n328
XU522 AOI22S $PINS O=n330 A1=N181 A2=n323 B1=N181 B2=n324
XU523 AOI22S $PINS O=n329 A1=N371 A2=FE_OFN49_n242 B1=N319 B2=FE_OFN47_n1
XU524 OAI112HS $PINS O=N475 A1=FE_PHN1983_n332 B1=n333 C1=n319 C2=n331
XU525 AOI22S $PINS O=n333 A1=N180 A2=n323 B1=N180 B2=n324
XU526 AOI22S $PINS O=n332 A1=N370 A2=FE_OFN49_n242 B1=N318 B2=FE_OFN47_n1
XU527 OAI112HS $PINS O=N474 A1=FE_PHN1981_n335 B1=n336 C1=n319 C2=n334
XU528 AOI22S $PINS O=n336 A1=N179 A2=n323 B1=N179 B2=n324
XU529 AOI22S $PINS O=n335 A1=N369 A2=n242 B1=N317 B2=n1
XU530 OAI112HS $PINS O=N473 A1=FE_PHN1991_n338 B1=n339 C1=n319 C2=n337
XU531 AOI22S $PINS O=n339 A1=N178 A2=n323 B1=N178 B2=n324
XU532 AOI22S $PINS O=n338 A1=N368 A2=n242 B1=N316 B2=n1
XU533 OAI112HS $PINS O=N472 A1=FE_PHN1993_n341 B1=n342 C1=n319 C2=n340
XU534 AOI22S $PINS O=n342 A1=N177 A2=n323 B1=N177 B2=n324
XU535 AOI22S $PINS O=n341 A1=N367 A2=n242 B1=N315 B2=n1
XU536 OAI112HS $PINS O=N471 A1=FE_PHN1980_n344 B1=n345 C1=n319 C2=p1
XU537 AOI22S $PINS O=n345 A1=N176 A2=n323 B1=N176 B2=n324
XU538 AN2 $PINS O=n324 I1=n248 I2=phase_in[15]
XU539 AN2 $PINS O=n323 I1=n248 I2=n320
XU540 AOI12HS $PINS O=n248 A1=n348 B1=n346 B2=n347
XU541 AOI22S $PINS O=n344 A1=N366 A2=n242 B1=N314 B2=n1
XU542 AN2 $PINS O=n242 I1=z_reg[15] I2=is_computing
XU543 OR3B2 $PINS O=n319 I1=n348 B1=n347 B2=n346
XU544 ND2 $PINS O=n346 I1=phase_in[15] I2=n325
XU545 INV1S $PINS O=n325 I=N182
XU546 OAI112HS $PINS O=n347 A1=n320 B1=N182 C1=n349 C2=n350
XU547 INV1S $PINS O=n320 I=phase_in[15]
XU548 ND3 $PINS O=n350 I1=n334 I2=n331 I3=n337
XU549 INV1S $PINS O=n337 I=N178
XU550 INV1S $PINS O=n331 I=N180
XU551 INV1S $PINS O=n334 I=N179
XU552 ND3 $PINS O=n349 I1=p1 I2=n340 I3=n328
XU553 INV1S $PINS O=n328 I=N181
XU554 INV1S $PINS O=n340 I=N177
XU556 ND2 $PINS O=N462 I1=n243 I2=n348
XU557 MOAI1S $PINS O=N461 A1=n351 A2=n241 B1=is_computing B2=n124
XU559 NR2 $PINS O=n352 I1=step_cnt[3] I2=n238
XU560 OAI22S $PINS O=N460 A1=n353 A2=n239 B1=FE_OFN303_n244 B2=n243
XU561 MOAI1S $PINS O=N459 A1=n238 A2=n354 B1=n240 B2=is_computing
XU562 INV1S $PINS O=N458 I=n354
XU563 ND2 $PINS O=N457 I1=n348 I2=n356
XU564 OAI12HS $PINS O=n356 A1=is_computing B1=n241 B2=FE_OFN303_n244
XU565 ND2 $PINS O=n348 I1=valid_in I2=n243
XU566 INV1S $PINS O=n243 I=is_computing
XU567 ND3 $PINS O=N118 I1=n357 I2=n358 I3=n359
XU568 AN2 $PINS O=n359 I1=FE_OFN303_n244 I2=n234
XU569 OAI112HS $PINS O=N117 A1=n236 B1=n360 C1=n238 C2=n241
XU570 AN3 $PINS O=n360 I1=n234 I2=n136 I3=n235
XU571 OAI112HS $PINS O=N116 A1=n236 B1=n56 C1=n241 C2=n355
XU572 OAI112HS $PINS O=N115 A1=n234 B1=n136 C1=n240 C2=n241
XU573 OAI112HS $PINS O=N114 A1=FE_OFN303_n244 B1=n357 C1=n241 C2=n355
XU574 OA13S $PINS O=n358 A1=n235 B1=step_cnt[0] B2=step_cnt[1] B3=n241
XU575 AOI13HS $PINS O=n357 A1=n14 B1=step_cnt[0] B2=step_cnt[1] B3=step_cnt[2]
XU576 OR3B2 $PINS O=N111 I1=N109 B1=n136 B2=n235
XU577 ND3 $PINS O=N110 I1=n136 I2=FE_OFN303_n244 I3=n236
XU578 NR2 $PINS O=n237 I1=step_cnt[2] I2=step_cnt[0]
Xclk_gate_y_reg_reg SNPS_CLOCK_GATE_HIGH_cordic_rotation_0_0 $PINS EN=N462
+ ENCLK=CTS_30 CLK=clk_clone4
Xclk_gate_z_reg_reg SNPS_CLOCK_GATE_HIGH_cordic_rotation_0_4 $PINS
+ CLK=clk_clone2 EN=N462 ENCLK=CTS_36 CLK_clone1=clk_clone4
Xclk_gate_y_out_reg SNPS_CLOCK_GATE_HIGH_cordic_rotation_0_3 $PINS EN=N515
+ ENCLK=net2411 CLK=clk_clone1
Xclk_gate_x_out_reg SNPS_CLOCK_GATE_HIGH_cordic_rotation_0_2 $PINS EN=N515
+ ENCLK=CTS_33 CLK=clk_clone3
Xclk_gate_step_cnt_reg SNPS_CLOCK_GATE_HIGH_cordic_rotation_0_1 $PINS
+ EN=FE_PHN1887_N457 ENCLK=net2421 CLK=clk_clone1
Xadd_105 cordic_rotation_0_DW01_add_2 $PINS A[15]=z_reg[15] A[14]=z_reg[14]
+ A[13]=z_reg[13] A[12]=z_reg[12] A[11]=z_reg[11] A[10]=z_reg[10] A[9]=z_reg[9]
+ A[8]=z_reg[8] A[7]=FE_PHN2151_z_reg_7 A[6]=FE_PHN2135_z_reg_6 A[5]=z_reg[5]
+ A[4]=z_reg[4] A[3]=z_reg[3] A[2]=z_reg[2] A[1]=z_reg[1] A[0]=z_reg[0] B[15]=n8
+ B[14]=n8 B[13]=n2 B[12]=n6 B[11]=n14 B[10]=N108 B[9]=N109 B[8]=N110 B[7]=N111
+ B[6]=N112 B[5]=N113 B[4]=N114 B[3]=N115 B[2]=N116 B[1]=N117 B[0]=N118 CI=n8
+ SUM[15]=N373 SUM[14]=N372 SUM[13]=N371 SUM[12]=N370 SUM[11]=N369 SUM[10]=N368
+ SUM[9]=N367 SUM[8]=N366 SUM[7]=N365 SUM[6]=N364 SUM[5]=N363 SUM[4]=N362
+ SUM[3]=N361 SUM[2]=N360 SUM[1]=N359 SUM[0]=N358
Xsub_104 cordic_rotation_0_DW01_sub_0_DW01_sub_28 $PINS A[17]=y_reg[17]
+ A[16]=y_reg[16] A[15]=FE_PHN1776_y_reg_15 A[14]=FE_PHN1710_y_reg_14
+ A[13]=FE_PHN1765_y_reg_13 A[12]=FE_PHN1767_y_reg_12 A[11]=FE_PHN2190_y_reg_11
+ A[10]=FE_PHN2186_y_reg_10 A[9]=y_reg[9] A[8]=y_reg[8] A[7]=y_reg[7]
+ A[6]=y_reg[6] A[5]=y_reg[5] A[4]=FE_PHN1736_y_reg_4 A[3]=y_reg[3] A[2]=y_reg[2]
+ A[1]=y_reg[1] A[0]=y_reg[0] B[17]=x_shift[16] B[16]=x_shift[16]
+ B[15]=x_shift[15] B[14]=x_shift[14] B[13]=x_shift[13] B[12]=x_shift[12]
+ B[11]=x_shift[11] B[10]=x_shift[10] B[9]=x_shift[9] B[8]=x_shift[8]
+ B[7]=x_shift[7] B[6]=x_shift[6] B[5]=x_shift[5] B[4]=x_shift[4] B[3]=x_shift[3]
+ B[2]=x_shift[2] B[1]=x_shift[1] B[0]=x_shift[0] CI=n8 DIFF[17]=N357
+ DIFF[16]=N356 DIFF[15]=N355 DIFF[14]=N354 DIFF[13]=N353 DIFF[12]=N352
+ DIFF[11]=N351 DIFF[10]=N350 DIFF[9]=N349 DIFF[8]=N348 DIFF[7]=N347 DIFF[6]=N346
+ DIFF[5]=N345 DIFF[4]=N344 DIFF[3]=N343 DIFF[2]=N342 DIFF[1]=N341 DIFF[0]=N340
Xadd_103 cordic_rotation_0_DW01_add_3 $PINS A[17]=FE_PHN1772_x_reg_17
+ A[16]=FE_PHN1783_x_reg_16 A[15]=x_reg[15] A[14]=x_reg[14]
+ A[13]=FE_PHN1785_x_reg_13 A[12]=FE_PHN1782_x_reg_12 A[11]=FE_PHN1781_x_reg_11
+ A[10]=x_reg[10] A[9]=x_reg[9] A[8]=x_reg[8] A[7]=x_reg[7] A[6]=x_reg[6]
+ A[5]=x_reg[5] A[4]=x_reg[4] A[3]=x_reg[3] A[2]=x_reg[2] A[1]=FE_PHN1737_x_reg_1
+ A[0]=x_reg[0] B[17]=y_shift[16] B[16]=y_shift[16] B[15]=y_shift[15]
+ B[14]=y_shift[14] B[13]=y_shift[13] B[12]=y_shift[12] B[11]=y_shift[11]
+ B[10]=y_shift[10] B[9]=y_shift[9] B[8]=y_shift[8] B[7]=y_shift[7]
+ B[6]=y_shift[6] B[5]=y_shift[5] B[4]=y_shift[4] B[3]=y_shift[3] B[2]=y_shift[2]
+ B[1]=y_shift[1] B[0]=y_shift[0] CI=n8 SUM[17]=N339 SUM[16]=N338 SUM[15]=N337
+ SUM[14]=N336 SUM[13]=N335 SUM[12]=N334 SUM[11]=N333 SUM[10]=N332 SUM[9]=N331
+ SUM[8]=N330 SUM[7]=N329 SUM[6]=N328 SUM[5]=N327 SUM[4]=N326 SUM[3]=N325
+ SUM[2]=N324 SUM[1]=N323 SUM[0]=N322
Xsub_101 cordic_rotation_0_DW01_sub_1_DW01_sub_29 $PINS A[15]=z_reg[15]
+ A[14]=z_reg[14] A[13]=z_reg[13] A[12]=z_reg[12] A[11]=z_reg[11] A[10]=z_reg[10]
+ A[9]=z_reg[9] A[8]=z_reg[8] A[7]=FE_PHN2151_z_reg_7 A[6]=FE_PHN2135_z_reg_6
+ A[5]=z_reg[5] A[4]=z_reg[4] A[3]=z_reg[3] A[2]=z_reg[2] A[1]=z_reg[1]
+ A[0]=z_reg[0] B[15]=n8 B[14]=n8 B[13]=FE_DBTN14_n2 B[12]=n6 B[11]=n14
+ B[10]=N108 B[9]=N109 B[8]=N110 B[7]=N111 B[6]=N112 B[5]=N113 B[4]=N114
+ B[3]=N115 B[2]=N116 B[1]=N117 B[0]=N118 CI=n8 DIFF[15]=N321 DIFF[14]=N320
+ DIFF[13]=N319 DIFF[12]=N318 DIFF[11]=N317 DIFF[10]=N316 DIFF[9]=N315
+ DIFF[8]=N314 DIFF[7]=N313 DIFF[6]=N312 DIFF[5]=N311 DIFF[4]=N310 DIFF[3]=N309
+ DIFF[2]=N308 DIFF[1]=N307 DIFF[0]=N306 n56=n56 n244=N108
+ FE_OFN303_n244=FE_OFN303_n244
Xadd_100 cordic_rotation_0_DW01_add_4 $PINS A[17]=y_reg[17] A[16]=y_reg[16]
+ A[15]=FE_PHN1776_y_reg_15 A[14]=FE_PHN1710_y_reg_14 A[13]=FE_PHN1765_y_reg_13
+ A[12]=FE_PHN1767_y_reg_12 A[11]=FE_PHN2190_y_reg_11 A[10]=FE_PHN2186_y_reg_10
+ A[9]=y_reg[9] A[8]=y_reg[8] A[7]=FE_PHN1751_y_reg_7 A[6]=FE_PHN1766_y_reg_6
+ A[5]=FE_PHN1754_y_reg_5 A[4]=FE_PHN1736_y_reg_4 A[3]=y_reg[3] A[2]=y_reg[2]
+ A[1]=y_reg[1] A[0]=y_reg[0] B[17]=x_shift[16] B[16]=x_shift[16]
+ B[15]=x_shift[15] B[14]=x_shift[14] B[13]=x_shift[13] B[12]=x_shift[12]
+ B[11]=x_shift[11] B[10]=x_shift[10] B[9]=x_shift[9] B[8]=x_shift[8]
+ B[7]=x_shift[7] B[6]=x_shift[6] B[5]=x_shift[5] B[4]=x_shift[4] B[3]=x_shift[3]
+ B[2]=x_shift[2] B[1]=x_shift[1] B[0]=x_shift[0] CI=n8 SUM[17]=N305 SUM[16]=N304
+ SUM[15]=N303 SUM[14]=N302 SUM[13]=N301 SUM[12]=N300 SUM[11]=N299 SUM[10]=N298
+ SUM[9]=N297 SUM[8]=N296 SUM[7]=N295 SUM[6]=N294 SUM[5]=N293 SUM[4]=N292
+ SUM[3]=N291 SUM[2]=N290 SUM[1]=N289 SUM[0]=N288
Xsub_99 cordic_rotation_0_DW01_sub_2_DW01_sub_30 $PINS
+ A[17]=FE_PHN1772_x_reg_17 A[16]=FE_PHN1783_x_reg_16 A[15]=x_reg[15]
+ A[14]=x_reg[14] A[13]=FE_PHN1785_x_reg_13 A[12]=FE_PHN1782_x_reg_12
+ A[11]=FE_PHN1781_x_reg_11 A[10]=x_reg[10] A[9]=x_reg[9] A[8]=x_reg[8]
+ A[7]=x_reg[7] A[6]=x_reg[6] A[5]=x_reg[5] A[4]=x_reg[4] A[3]=x_reg[3]
+ A[2]=x_reg[2] A[1]=FE_PHN1737_x_reg_1 A[0]=x_reg[0] B[17]=y_shift[16]
+ B[16]=y_shift[16] B[15]=y_shift[15] B[14]=y_shift[14] B[13]=y_shift[13]
+ B[12]=y_shift[12] B[11]=y_shift[11] B[10]=y_shift[10] B[9]=y_shift[9]
+ B[8]=y_shift[8] B[7]=y_shift[7] B[6]=y_shift[6] B[5]=y_shift[5] B[4]=y_shift[4]
+ B[3]=y_shift[3] B[2]=y_shift[2] B[1]=y_shift[1] B[0]=y_shift[0] CI=n8
+ DIFF[17]=N287 DIFF[16]=N286 DIFF[15]=N285 DIFF[14]=N284 DIFF[13]=N283
+ DIFF[12]=N282 DIFF[11]=N281 DIFF[10]=N280 DIFF[9]=N279 DIFF[8]=N278
+ DIFF[7]=N277 DIFF[6]=N276 DIFF[5]=N275 DIFF[4]=N274 DIFF[3]=N273 DIFF[2]=N272
+ DIFF[1]=N271 DIFF[0]=N270
.ENDS

.SUBCKT CSD_ROM_Table_even_1 n_idx[4] n_idx[3] n_idx[2] n_idx[1] n_idx[0]
+ k_idx[4] k_idx[3] k_idx[2] k_idx[1] k_idx[0] sign1[1] sign1[0] shift1[3]
+ shift1[2] shift1[1] shift1[0] sign2[1] sign2[0] shift2[3] shift2[2] shift2[1]
+ shift2[0] sign3[1] sign3[0] shift3[3] shift3[2] shift3[1] shift3[0]
XFE_OFC364_fold_n_2 INV1S $PINS O=FE_OFN279_fold_n_2 I=n111
XFE_OFC363_fold_n_2 INV1S $PINS O=n111 I=n_idx[2]
XFE_OFC332_n242 INV1S $PINS O=FE_OFN271_n242 I=n26
XFE_OFC331_n242 INV1S $PINS O=n26 I=n242
XFE_OFC296_n253 INV1S $PINS O=FE_OFN258_n253 I=n62
XFE_OFC295_n253 INV1S $PINS O=n62 I=n253
XFE_OFC276_n217 INV1S $PINS O=n33 I=n217
XFE_OFC260_fold_n_0 INV1S $PINS O=FE_OFN248_fold_n_0 I=n_idx[0]
XFE_OFC259_fold_n_0 INV1S $PINS O=n113 I=n_idx[0]
XFE_OFC258_n1 INV2 $PINS O=n37 I=n1
XU776 OA222 $PINS O=n144 A1=n152 A2=n98 B1=n153 B2=n154 C1=n155 C2=n156
XU777 OR3B2 $PINS O=n164 I1=n165 B1=n166 B2=n167
XU778 ND2 $PINS O=n168 I1=n40 I2=FE_OFN248_fold_n_0
XU779 AO12 $PINS O=n179 A1=n182 B1=n110 B2=n181
XU780 AO112 $PINS O=n187 A1=n_idx[4] B1=n189 C1=n188 C2=n_idx[3]
XU782 OA222 $PINS O=n226 A1=n227 A2=n163 B1=n228 B2=n229 C1=n230 C2=n231
XU783 ND2 $PINS O=n233 I1=n235 I2=n236
XU784 ND2 $PINS O=n232 I1=n237 I2=n238
XU785 ND2 $PINS O=n240 I1=n241 I2=n89
XU787 AN3B2S $PINS O=n247 I1=n249 B1=n250 B2=n251
XU788 AN3 $PINS O=n258 I1=n259 I2=n260 I3=n220
XU789 OR3B2 $PINS O=n261 I1=n265 B1=n266 B2=n34
XU790 AN3 $PINS O=n268 I1=n271 I2=n272 I3=n273
XU791 AO12 $PINS O=sign2[1] A1=n276 B1=n274 B2=n275
XU792 AO222 $PINS O=n275 A1=n277 A2=n991 B1=n278 B2=n279 C1=n280 C2=n281
XU794 ND2 $PINS O=n307 I1=n311 I2=n174
XU795 AO12 $PINS O=n303 A1=n313 B1=n312 B2=n223
XU796 OA222 $PINS O=n316 A1=n317 A2=n216 B1=n318 B2=n319 C1=n320 C2=n154
XU797 ND2 $PINS O=n353 I1=n83 I2=n419
XU798 AO12 $PINS O=sign1[1] A1=n276 B1=n274 B2=n356
XU799 ND2 $PINS O=n180 I1=n_idx[4] I2=n97
XU800 AN3 $PINS O=n357 I1=n358 I2=FE_OFN248_fold_n_0 I3=n359
XU801 OR3 $PINS O=n358 I1=n282 I2=n40 I3=n_idx[1]
XU802 ND2 $PINS O=n365 I1=n134 I2=n282
XU803 ND2 $PINS O=n282 I1=n286 I2=k_idx[2]
XU804 OA222 $PINS O=n376 A1=n383 A2=n231 B1=n384 B2=n347 C1=n385 C2=n248
XU805 OA222 $PINS O=n375 A1=n389 A2=n172 B1=n390 B2=n391 C1=n392 C2=n393
XU806 OA222 $PINS O=n374 A1=n93 A2=n100 B1=n82 B2=n95 C1=n77 C2=n238
XU807 ND2 $PINS O=n270 I1=n413 I2=n414
XU810 OA112 $PINS O=n267 A1=n427 B1=n428 C1=n77 C2=n426
XU811 ND2 $PINS O=n431 I1=n176 I2=n401
XU812 ND2 $PINS O=n443 I1=n1 I2=n444
XU813 ND2 $PINS O=n447 I1=n450 I2=FE_OFN271_n242
XU814 AO12 $PINS O=n445 A1=n216 B1=n163 B2=n451
XU815 ND2 $PINS O=n455 I1=n62 I2=n132
XU816 OA222 $PINS O=n463 A1=n77 A2=n319 B1=n405 B2=n299 C1=n99 C2=n93
XU817 OA222 $PINS O=n462 A1=n468 A2=n147 B1=n469 B2=n212 C1=n470 C2=n216
XU818 AN3B2S $PINS O=n469 I1=n151 B1=n344 B2=n55
XU819 AN3B2S $PINS O=n486 I1=n498 B1=n499 B2=n500
XU820 AN3 $PINS O=n514 I1=n228 I2=n151 I3=n517
XU821 OA222 $PINS O=n511 A1=n93 A2=n518 B1=n519 B2=n311 C1=n520 C2=n319
XU822 OA222 $PINS O=n509 A1=n404 A2=n154 B1=n524 B2=n172 C1=n259 C2=n345
XU823 AN3B2S $PINS O=n531 I1=n484 B1=n532 B2=n37
XU824 OA112 $PINS O=n538 A1=n540 B1=n541 C1=n216 C2=n253
XU825 AN3 $PINS O=n555 I1=n563 I2=n564 I3=n427
XU826 ND2 $PINS O=n427 I1=n131 I2=n565
XU827 ND2 $PINS O=n567 I1=n263 I2=n221
XU828 ND2 $PINS O=n566 I1=n309 I2=n87
XU829 ND2 $PINS O=n571 I1=n54 I2=n444
XU830 OA222 $PINS O=n547 A1=n73 A2=n319 B1=n573 B2=n229 C1=n574 C2=n488
XU831 AN3B2S $PINS O=n573 I1=n575 B1=n576 B2=n485
XU833 ND2 $PINS O=n586 I1=n588 I2=n3
XU834 OA222 $PINS O=n606 A1=n610 A2=n335 B1=n611 B2=n229 C1=n612 C2=n488
XU835 ND2 $PINS O=n430 I1=n323 I2=n386
XU836 OA222 $PINS O=n605 A1=n615 A2=n214 B1=n560 B2=n616 C1=n617 C2=n216
XU837 OA222 $PINS O=n604 A1=n619 A2=n147 B1=n387 B2=n347 C1=n620 C2=n154
XU838 AN3B2S $PINS O=n601 I1=n536 B1=n627 B2=n552
XU839 AN3 $PINS O=n504 I1=n633 I2=n634 I3=n635
XU840 OA112 $PINS O=n634 A1=n564 B1=n645 C1=n644 C2=n238
XU841 AO12 $PINS O=n645 A1=n319 B1=n64 B2=n646
XU842 OA222 $PINS O=n633 A1=n392 A2=n214 B1=n647 B2=n299 C1=n235 C2=n64
XU843 OA112 $PINS O=n454 A1=n648 B1=n649 C1=n299 C2=n253
XU844 OA222 $PINS O=n649 A1=n156 A2=n28 B1=n650 B2=n7 C1=n595 C2=n238
XU845 OA222 $PINS O=n536 A1=n600 A2=n93 B1=n191 B2=n64 C1=n178 C2=n72
XU847 OA222 $PINS O=n655 A1=n661 A2=n488 B1=n662 B2=n154 C1=n663 C2=n424
XU848 OA222 $PINS O=n654 A1=n665 A2=n212 B1=n666 B2=n347 C1=n667 C2=n172
XU849 OA112 $PINS O=n652 A1=n669 B1=n670 C1=n299 C2=n176
XU850 OA222 $PINS O=n670 A1=n231 A2=n162 B1=n388 B2=n235 C1=n248 C2=n493
XU851 OR3B2 $PINS O=n671 I1=n352 B1=n245 B2=n562
XU852 OA222 $PINS O=n675 A1=n154 A2=n221 B1=n313 B2=n600 C1=n79 C2=n214
XU853 OA222 $PINS O=n681 A1=n594 A2=n67 B1=n432 B2=n77 C1=n182 C2=n3
XU854 ND2 $PINS O=n684 I1=n54 I2=n664
XU855 ND2 $PINS O=n683 I1=n162 I2=n621
XU856 AO12 $PINS O=n679 A1=n299 B1=n621 B2=n404
XU857 OA222 $PINS O=n677 A1=n82 A2=n223 B1=n218 B2=n345 C1=n630 C2=n319
XU858 OA112 $PINS O=n676 A1=n272 B1=n685 C1=n146 C2=n348
XU859 OA222 $PINS O=n687 A1=n313 A2=n688 B1=n689 B2=n79 C1=n690 C2=n231
XU860 OA112 $PINS O=n561 A1=n697 B1=n698 C1=n82 C2=n223
XU861 ND2 $PINS O=n698 I1=n61 I2=n133
XU862 OA222 $PINS O=n456 A1=n473 A2=n154 B1=n488 B2=n386 C1=n229 C2=n253
XU863 AO112 $PINS O=n702 A1=n704 B1=n705 C1=n703 C2=n417
XU864 AN3 $PINS O=n271 I1=n708 I2=n709 I3=n710
XU865 OA112 $PINS O=n710 A1=n669 B1=n711 C1=n473 C2=n301
XU866 OA222 $PINS O=n711 A1=n154 A2=n221 B1=n77 B2=n319 C1=n345 C2=n621
XU867 OA222 $PINS O=n669 A1=n77 A2=n238 B1=n191 B2=n67 C1=n235 C2=n72
XU868 OA222 $PINS O=n709 A1=n325 A2=n424 B1=n712 B2=n172 C1=n590 C2=n229
XU869 OA222 $PINS O=n708 A1=n178 A2=n3 B1=n328 B2=n313 C1=n411 C2=n488
XU870 AN3 $PINS O=n350 I1=n713 I2=n714 I3=n715
XU871 AN3B2S $PINS O=n715 I1=n716 B1=n717 B2=n718
XU872 ND2 $PINS O=n723 I1=n242 I2=n621
XU873 OA222 $PINS O=n726 A1=n172 A2=n162 B1=n346 B2=n391 C1=n154 C2=n621
XU874 OA222 $PINS O=n731 A1=n79 A2=n235 B1=n82 B2=n688 C1=n313 C2=n95
XU875 AO12 $PINS O=n730 A1=n93 B1=n329 B2=n96
XU876 AN3 $PINS O=n317 I1=n473 I2=n146 I3=n343
XU877 OA222 $PINS O=n761 A1=n197 A2=n81 B1=n762 B2=n248 C1=n90 C2=n172
XU879 ND2 $PINS O=n764 I1=n575 I2=n389
XU880 ND2 $PINS O=n339 I1=n176 I2=n323
XU881 AN3B2S $PINS O=n784 I1=n685 B1=n785 B2=n718
XU883 AO222 $PINS O=n785 A1=n234 A2=n130 B1=n69 B2=n127 C1=n419 C2=n92
XU884 OA222 $PINS O=n783 A1=n66 A2=n174 B1=n786 B2=n72 C1=n787 C2=n154
XU885 AO112 $PINS O=n798 A1=n553 B1=n502 C1=n572 C2=n125
XU886 ND2 $PINS O=n421 I1=n309 I2=n533
XU887 OA222 $PINS O=n806 A1=n807 A2=n231 B1=n808 B2=n348 C1=n809 C2=n248
XU888 OR3B2 $PINS O=n632 I1=n381 B1=n811 B2=n812
XU889 ND2 $PINS O=n763 I1=n252 I2=n533
XU890 ND2 $PINS O=n381 I1=n497 I2=n442
XU891 AN3 $PINS O=n215 I1=n740 I2=n28 I3=n254
XU892 ND2 $PINS O=n706 I1=n214 I2=n311
XU894 ND2 $PINS O=n828 I1=n393 I2=n238
XU895 ND2 $PINS O=n826 I1=n93 I2=n82
XU896 ND2 $PINS O=n564 I1=n62 I2=n123
XU897 ND2 $PINS O=n703 I1=n444 I2=n338
XU898 AN3 $PINS O=n776 I1=n838 I2=n411 I3=n39
XU899 ND2 $PINS O=n849 I1=n72 I2=n67
XU900 ND2 $PINS O=n848 I1=n95 I2=n223
XU901 ND2 $PINS O=n322 I1=n256 I2=n176
XU902 AN3B1 $PINS O=n329 I1=n157 I2=n688 B1=n834
XU903 ND2 $PINS O=n199 I1=n347 I2=n236
XU904 ND2 $PINS O=n833 I1=n346 I2=n7
XU905 ND2 $PINS O=n496 I1=FE_OFN258_n253 I2=n338
XU906 OR3B2 $PINS O=n872 I1=n382 B1=n87 B2=n484
XU908 ND2 $PINS O=n251 I1=n484 I2=n442
XU909 ND2 $PINS O=n491 I1=n338 I2=n533
XU911 AN3 $PINS O=n273 I1=n883 I2=n884 I3=n885
XU912 ND2 $PINS O=n697 I1=n279 I2=n186
XU913 OA222 $PINS O=n889 A1=n802 A2=n82 B1=n392 B2=n174 C1=n400 C2=n345
XU915 ND2 $PINS O=n757 I1=n688 I2=n100
XU916 ND2 $PINS O=n200 I1=n570 I2=n191
XU917 ND2 $PINS O=n907 I1=n789 I2=n319
XU919 ND2 $PINS O=n906 I1=n312 I2=n597
XU920 OA222 $PINS O=n911 A1=n238 A2=n64 B1=n440 B2=n176 C1=n39 C2=n488
XU923 OR3B2 $PINS O=n915 I1=n722 B1=n108 B2=n688
XU924 ND2 $PINS O=n722 I1=n312 I2=n802
XU925 ND2 $PINS O=n914 I1=n342 I2=n338
XU926 ND2 $PINS O=n728 I1=n318 I2=n67
XU927 ND2 $PINS O=n788 I1=n79 I2=n67
XU928 OA222 $PINS O=n922 A1=n84 A2=n248 B1=n923 B2=n3 C1=n924 C2=n216
XU929 ND2 $PINS O=n492 I1=n442 I2=n664
XU930 OA222 $PINS O=n637 A1=n415 A2=n82 B1=n256 B2=n345 C1=n93 C2=n312
XU931 OA112 $PINS O=n919 A1=n269 B1=n416 C1=n335 C2=n493
XU932 OA222 $PINS O=n926 A1=n77 A2=n222 B1=n311 B2=n64 C1=n82 C2=n600
XU933 ND2 $PINS O=shift1[0] I1=n927 I2=n928
XU934 ND2 $PINS O=n304 I1=n130 I2=n69
XU935 ND2 $PINS O=n236 I1=n908 I2=n360
XU936 AO12 $PINS O=n933 A1=n388 B1=n174 B2=n650
XU937 ND2 $PINS O=n391 I1=n935 I2=n913
XU939 OA222 $PINS O=n931 A1=n105 A2=n93 B1=n937 B2=n299 C1=n938 C2=n162
XU940 OA222 $PINS O=n930 A1=n404 A2=n229 B1=n197 B2=n64 C1=n524 C2=n488
XU941 OA222 $PINS O=n929 A1=n191 A2=n3 B1=n630 B2=n424 C1=n89 C2=n231
XU942 ND2 $PINS O=n767 I1=n252 I2=n493
XU943 AN3 $PINS O=n920 I1=n944 I2=n945 I3=n946
XU944 AO12 $PINS O=n720 A1=n7 B1=n191 B2=n178
XU945 ND2 $PINS O=n344 I1=n259 I2=n953
XU947 ND2 $PINS O=n957 I1=n150 I2=n252
XU948 ND2 $PINS O=n956 I1=n264 I2=n493
XU949 OA222 $PINS O=n948 A1=n594 A2=n81 B1=n960 B2=n231 C1=n498 C2=n335
XU950 ND2 $PINS O=n449 I1=n778 I2=n533
XU951 ND2 $PINS O=n301 I1=n360 I2=n936
XU954 ND2 $PINS O=n426 I1=n964 I2=n935
XU955 ND2 $PINS O=n673 I1=n966 I2=n967
XU956 OA222 $PINS O=n967 A1=n876 A2=n248 B1=n968 B2=n216 C1=n969 C2=n311
XU957 ND2 $PINS O=n311 I1=n908 I2=n913
XU958 OA222 $PINS O=n966 A1=n146 A2=n231 B1=n399 B2=n299 C1=n328 C2=n93
XU960 ND2 $PINS O=n222 I1=n912 I2=n964
XU961 AN3 $PINS O=n792 I1=n971 I2=n76 I3=n972
XU962 OA222 $PINS O=n972 A1=n646 A2=n424 B1=n594 B2=n72 C1=n7 C2=n347
XU968 ND2 $PINS O=n234 I1=n302 I2=n7
XU970 OA222 $PINS O=n942 A1=n335 A2=FE_OFN258_n253 B1=n975 B2=n172 C1=n147
+ C2=n28
XU971 ND2 $PINS O=n500 I1=FE_OFN258_n253 I2=n533
XU972 ND2 $PINS O=n444 I1=n976 I2=n958
XU973 ND2 $PINS O=n252 I1=n939 I2=n961
XU974 OA222 $PINS O=n941 A1=n156 A2=n79 B1=n977 B2=n82 C1=n978 C2=n313
XU976 AN3B2S $PINS O=n186 I1=n291 B1=k_idx[3] B2=k_idx[4]
XU977 ND2 $PINS O=n189 I1=n599 I2=n95
XU979 ND2 $PINS O=n979 I1=n328 I2=n97
XU983 ND2 $PINS O=n518 I1=n102 I2=n113
XU987 ND2 $PINS O=n415 I1=n175 I2=n113
XU990 OA222 $PINS O=n940 A1=n982 A2=n154 B1=n497 B2=n212 C1=n983 C2=n345
XU998 ND2 $PINS O=n309 I1=n976 I2=n280
XU3 AN4B1S $PINS O=n624 I1=n399 I2=n741 I3=n221 B1=n618
XU4 AOI13HS $PINS O=n685 A1=n553 B1=n194 B2=n160 B3=n120
XU5 AN4B1S $PINS O=n152 I1=n196 I2=n426 I3=n235 B1=n198
XU6 AN4S $PINS O=n738 I1=n259 I2=n309 I3=n317 I4=n404
XU8 NR2P $PINS O=n1 I1=n38 I2=n50
XU9 NR2P $PINS O=n217 I1=n45 I2=n35
XU10 ND2 $PINS O=n150 I1=n985 I2=FE_OFN248_fold_n_0
XU11 NR2 $PINS O=n280 I1=n_idx[4] I2=n_idx[3]
XU12 ND2 $PINS O=n221 I1=n989 I2=n_idx[0]
XU13 ND2S $PINS O=n203 I1=n_idx[3] I2=n_idx[2]
XU14 ND3 $PINS O=n815 I1=n323 I2=n166 I3=n814
XU15 INV1S $PINS O=n50 I=n166
XU16 ND2S $PINS O=n239 I1=n176 I2=FE_OFN271_n242
XU18 INV1S $PINS O=n112 I=n_idx[1]
XU19 ND2S $PINS O=n861 I1=n300 I2=n253
XU20 ND3 $PINS O=n796 I1=n804 I2=n805 I3=n806
XU21 ND2S $PINS O=n813 I1=n824 I2=n825
XU22 ND3S $PINS O=n609 I1=n478 I2=n87 I3=n881
XU23 ND3S $PINS O=shift3[2] I1=n458 I2=n459 I3=n460
XU24 ND3S $PINS O=n816 I1=n479 I2=n1 I3=n215
XU25 ND3S $PINS O=n618 I1=n217 I2=n150 I3=n400
XU26 OR2S $PINS O=n765 I1=n485 I2=n20
XU27 OR3B2S $PINS O=n587 I1=n322 B1=n472 B2=n399
XU28 ND3S $PINS O=n494 I1=n217 I2=n497 I3=n342
XU29 AO12S $PINS O=n718 A1=n522 B1=n35 B2=n419
XU30 ND2S $PINS O=n802 I1=n107 I2=n113
XU31 ND2S $PINS O=n223 I1=n103 I2=n113
XU32 AN2S $PINS O=n385 I1=n386 I2=n310
XU33 MAOI1S $PINS O=n805 A1=n115 A2=n813 B1=n154 B2=n814
XU34 ND3S $PINS O=n308 I1=n221 I2=n309 I3=n310
XU35 ND3S $PINS O=shift1[1] I1=n896 I2=n897 I3=n898
XU36 ND3S $PINS O=n476 I1=n478 I2=n479 I3=n480
XU37 ND3S $PINS O=n626 I1=n167 I2=n338 I3=n613
XU38 AN3S $PINS O=n982 I1=n516 I2=n151 I3=n405
XU39 NR2 $PINS O=n2 I1=n80 I2=n110
XU40 ND3S $PINS O=n219 I1=n220 I2=n166 I3=n221
XU41 OA222S $PINS O=n656 A1=n1 A2=n229 B1=n99 B2=n93 C1=n260 C2=n216
XU42 ND2S $PINS O=n495 I1=n150 I2=n442
XU43 ND3S $PINS O=n774 I1=n517 I2=n472 I3=n439
XU44 OA12S $PINS O=n523 A1=n115 B1=n38 B2=n322
XU45 ND3S $PINS O=n660 I1=FE_OFN271_n242 I2=n150 I3=n497
XU46 OA22S $PINS O=n909 A1=n227 A2=n217 B1=n174 B2=n588
XU47 ND2S $PINS O=n485 I1=n497 I2=n166
XU48 OA22S $PINS O=n354 A1=n299 A2=n166 B1=n266 B2=n348
XU49 ND3S $PINS O=n499 I1=n442 I2=n166 I3=n266
XU50 ND2S $PINS O=n157 I1=n109 I2=n113
XU51 ND2S $PINS O=n146 I1=n_idx[0] I2=n985
XU52 ND2S $PINS O=n382 I1=n406 I2=FE_OFN258_n253
XU53 ND2S $PINS O=n220 I1=n986 I2=n_idx[0]
XU54 ND3S $PINS O=n323 I1=n961 I2=FE_OFN248_fold_n_0 I3=n280
XU55 ND2S $PINS O=n242 I1=n989 I2=FE_OFN248_fold_n_0
XU56 ND2S $PINS O=n149 I1=n111 I2=n104
XU57 ND3S $PINS O=n176 I1=n280 I2=n961 I3=n_idx[0]
XU58 ND3S $PINS O=n534 I1=n493 I2=n778 I3=n1
XU59 ND2S $PINS O=n401 I1=n984 I2=n_idx[0]
XU60 ND2S $PINS O=n204 I1=n990 I2=n_idx[1]
XU61 ND3S $PINS O=n727 I1=n298 I2=n1 I3=n729
XU62 ND3S $PINS O=n631 I1=n150 I2=n162 I3=n338
XU63 ND2S $PINS O=n386 I1=n165 I2=FE_OFN248_fold_n_0
XU64 ND2S $PINS O=n402 I1=n988 I2=FE_OFN248_fold_n_0
XU65 ND2S $PINS O=n974 I1=n990 I2=n112
XU66 ND2S $PINS O=n953 I1=n986 I2=FE_OFN248_fold_n_0
XU67 ND2S $PINS O=n163 I1=n984 I2=FE_OFN248_fold_n_0
XU68 ND3S $PINS O=n338 I1=n_idx[1] I2=n111 I3=n939
XU69 ND2S $PINS O=n621 I1=n988 I2=n_idx[0]
XU70 ND3S $PINS O=n533 I1=n958 I2=n111 I3=n370
XU71 ND3S $PINS O=n442 I1=n112 I2=n111 I3=n939
XU72 ND2S $PINS O=n851 I1=n981 I2=n_idx[1]
XU73 ND3S $PINS O=n664 I1=n_idx[0] I2=n961 I3=n958
XU74 ND3S $PINS O=n614 I1=n150 I2=n162 I3=n177
XU75 ND2S $PINS O=n894 I1=n981 I2=n112
XU76 ND3S $PINS O=n745 I1=n146 I2=n162 I3=n338
XU77 ND2S $PINS O=n158 I1=n109 I2=n_idx[0]
XU78 ND2S $PINS O=n688 I1=n106 I2=n_idx[0]
XU79 OA12S $PINS O=n159 A1=n17 B1=n110 B2=n113
XU80 ND2S $PINS O=n312 I1=n103 I2=n_idx[0]
XU81 ND2S $PINS O=n597 I1=n102 I2=n_idx[0]
XU82 ND3S $PINS O=n289 I1=n134 I2=n890 I3=n160
XU83 ND2S $PINS O=n181 I1=n961 I2=n_idx[3]
XU84 ND3S $PINS O=n253 I1=n987 I2=FE_OFN248_fold_n_0 I3=n_idx[4]
XU85 ND3S $PINS O=n162 I1=n280 I2=n_idx[1] I3=n970
XU86 NR2 $PINS O=n279 I1=n97 I2=n_idx[4]
XU87 ND3S $PINS O=n493 I1=n958 I2=FE_OFN279_fold_n_2 I3=n370
XU88 ND3S $PINS O=n778 I1=n_idx[1] I2=FE_OFN279_fold_n_2 I3=n939
XU89 ND3S $PINS O=n283 I1=n112 I2=n111 I3=k_idx[0]
XU90 OR2S $PINS O=n188 I1=FE_OFN279_fold_n_2 I2=n370
XU91 AO12S $PINS O=n288 A1=k_idx[0] B1=FE_OFN248_fold_n_0 B2=k_idx[2]
XU93 INV1S $PINS O=n36 I=n478
XU94 NR2 $PINS O=n478 I1=n37 I2=n47
XU95 NR2 $PINS O=n390 I1=n69 I2=n234
XU96 INV1S $PINS O=n66 I=n788
XU97 INV1S $PINS O=n75 I=n682
XU98 AN2 $PINS O=n825 I1=n479 I2=n740
XU99 INV1S $PINS O=n20 I=n472
XU100 INV1S $PINS O=n19 I=n479
XU102 INV1S $PINS O=n31 I=n411
XU103 INV1S $PINS O=n71 I=n318
XU104 INV1S $PINS O=n59 I=n218
XU105 INV1S $PINS O=n69 I=n388
XU106 INV1S $PINS O=n34 I=n618
XU107 INV1S $PINS O=n41 I=n389
XU108 NR2 $PINS O=n254 I1=n43 I2=n47
XU109 INV1S $PINS O=n47 I=n497
XU111 INV1S $PINS O=n95 I=n642
XU112 ND3 $PINS O=n834 I1=n600 I2=n415 I3=n638
XU113 INV1S $PINS O=n49 I=n859
XU114 INV1S $PINS O=n18 I=n773
XU115 AN2 $PINS O=n384 I1=n387 I2=n388
XU116 INV1S $PINS O=n65 I=n520
XU117 NR2 $PINS O=n263 I1=n43 I2=n38
XU118 INV1S $PINS O=n96 I=n979
XU119 AN2 $PINS O=n328 I1=n802 I2=n223
XU120 INV1S $PINS O=n42 I=n535
XU121 NR2 $PINS O=n383 I1=n38 I2=n42
XU122 INV1S $PINS O=n22 I=n741
XU123 AN2 $PINS O=n625 I1=n801 I2=n318
XU124 INV1S $PINS O=n73 I=n701
XU125 INV1S $PINS O=n68 I=n630
XU126 INV1S $PINS O=n100 I=n721
XU127 ND3 $PINS O=n528 I1=n3 I2=n77 I3=n73
XU128 INV1S $PINS O=n44 I=n471
XU130 NR2 $PINS O=n527 I1=n572 I2=n788
XU131 NR2 $PINS O=n754 I1=n834 I2=n642
XU132 INV1S $PINS O=n30 I=n824
XU133 NR2 $PINS O=n682 I1=n7 I2=n237
XU134 NR2 $PINS O=n197 I1=n126 I2=n125
XU135 NR2 $PINS O=n237 I1=n126 I2=n122
XU136 NR2 $PINS O=n814 I1=n813 I2=n45
XU137 NR2 $PINS O=n300 I1=n26 I2=n61
XU138 AN2 $PINS O=n740 I1=n473 I2=n405
XU139 INV1S $PINS O=n55 I=n400
XU140 NR2 $PINS O=n484 I1=n92 I2=n94
XU141 NR2 $PINS O=n881 I1=n88 I2=n251
XU142 NR2 $PINS O=n613 I1=n251 I2=n33
XU143 NR2 $PINS O=n472 I1=n21 I2=n25
XU144 NR2 $PINS O=n479 I1=n20 I2=n23
XU145 NR2 $PINS O=n459 I1=n481 I2=n482
XU146 NR3 $PINS O=n458 I1=n501 I2=n502 I3=n503
XU147 AN4B1S $PINS O=n460 I1=n461 I2=n462 I3=n463 B1=n464
XU148 INV1S $PINS O=n85 I=n251
XU149 ND3 $PINS O=shift3[0] I1=n542 I2=n543 I3=n544
XU150 NR3 $PINS O=n542 I1=n591 I2=n592 I3=n593
XU151 AN4B1S $PINS O=n543 I1=n579 I2=n580 I3=n581 B1=n582
XU152 AN4B1S $PINS O=n544 I1=n545 I2=n546 I3=n547 B1=n548
XU153 NR2 $PINS O=n256 I1=n23 I2=n26
XU154 ND3 $PINS O=n695 I1=n350 I2=n271 I3=n27
XU155 NR2 $PINS O=n968 I1=n26 I2=n29
XU156 NR2 $PINS O=n405 I1=n56 I2=n60
XU157 NR2 $PINS O=n712 I1=n94 I2=n381
XU158 NR2 $PINS O=n497 I1=n53 I2=n48
XU159 NR3 $PINS O=n406 I1=n53 I2=n50 I3=n33
XU160 NR2 $PINS O=n647 I1=n35 I2=n26
XU161 NR2 $PINS O=n411 I1=n91 I2=n35
XU162 NR2 $PINS O=n809 I1=n336 I2=n703
XU163 ND3 $PINS O=n407 I1=n27 I2=n349 I3=n416
XU164 NR2 $PINS O=n707 I1=n35 I2=n55
XU165 AN2B1S $PINS O=n318 I1=n595 B1=n2
XU166 NR2 $PINS O=n646 I1=n71 I2=n306
XU167 AOI22S $PINS O=n580 A1=n128 A2=n586 B1=n337 B2=n587
XU168 OAI112HS $PINS O=n557 A1=n561 B1=n562 C1=n560 C2=n235
XU169 ND3 $PINS O=n539 I1=n554 I2=n555 I3=n556
XU170 NR2 $PINS O=n554 I1=n568 I2=n569
XU171 NR3 $PINS O=n556 I1=n557 I2=n558 I3=n559
XU172 NR2 $PINS O=n218 I1=n60 I2=n61
XU173 NR2 $PINS O=n575 I1=n59 I2=n58
XU174 AN2 $PINS O=n517 I1=n400 I2=n256
XU175 NR2 $PINS O=n388 I1=n565 I2=n668
XU176 AOI22S $PINS O=n243 A1=n417 A2=n261 B1=n418 B2=n262
XU177 ND3 $PINS O=n262 I1=n263 I2=n264 I3=n249
XU178 NR2 $PINS O=n151 I1=n33 I2=n48
XU179 NR2 $PINS O=n389 I1=n45 I2=n50
XU180 INV1S $PINS O=n101 I=n175
XU181 INV1S $PINS O=n77 I=n823
XU182 NR2 $PINS O=n404 I1=n38 I2=n56
XU183 AOI22S $PINS O=n971 A1=n26 A2=n132 B1=n125 B2=n234
XU184 NR2 $PINS O=n310 I1=n37 I2=n35
XU185 INV1S $PINS O=n38 I=n150
XU186 NR2 $PINS O=n590 I1=n45 I2=n25
XU187 NR2 $PINS O=n259 I1=n25 I2=n60
XU188 INV1S $PINS O=n46 I=n167
XU189 NR2 $PINS O=n343 I1=n46 I2=n23
XU190 NR2 $PINS O=n302 I1=n2 I2=n823
XU191 INV1S $PINS O=n87 I=n491
XU192 INV1S $PINS O=n67 I=n668
XU193 AOI13HS $PINS O=n395 A1=n212 B1=n256 B2=n405 B3=n406
XU194 INV1S $PINS O=n39 I=n495
XU195 INV1S $PINS O=n43 I=n450
XU196 NR2 $PINS O=n642 I1=n113 I2=n98
XU197 NR2 $PINS O=n325 I1=n823 I2=n585
XU198 NR2 $PINS O=n859 I1=n50 I2=n60
XU199 AOI22S $PINS O=n947 A1=n114 A2=n22 B1=n132 B2=n49
XU200 INV1S $PINS O=n79 I=n2
XU201 NR2 $PINS O=n773 I1=n21 I2=n35
XU202 AOI22S $PINS O=n716 A1=n133 A2=n58 B1=n116 B2=n306
XU203 INV1S $PINS O=n74 I=n519
XU204 NR2 $PINS O=n387 I1=n74 I2=n2
XU205 NR2 $PINS O=n399 I1=n58 I2=n61
XU206 NR2 $PINS O=n520 I1=n2 I2=n585
XU207 NR2 $PINS O=n824 I1=n38 I2=n35
XU208 AOI22S $PINS O=n428 A1=n2 A2=n122 B1=n48 B2=n137
XU209 NR2 $PINS O=n721 I1=n101 I2=n113
XU210 NR2 $PINS O=n638 I1=n721 I2=n577
XU211 NR2 $PINS O=n346 I1=n78 I2=n565
XU212 INV1S $PINS O=n78 I=n560
XU213 NR2 $PINS O=n801 I1=n78 I2=n306
XU214 INV1S $PINS O=n88 I=n252
XU215 NR2 $PINS O=n266 I1=n88 I2=n48
XU216 NR2 $PINS O=n475 I1=n48 I2=n56
XU217 NR2 $PINS O=n535 I1=n43 I2=n53
XU218 NR2 $PINS O=n741 I1=n48 I2=n23
XU219 MOAI1S $PINS O=n717 A1=n594 A2=n72 B1=n306 B2=n125
XU220 NR2 $PINS O=n665 I1=n21 I2=n26
XU221 OAI12HS $PINS O=n886 A1=n128 B1=n565 B2=n585
XU222 AOI22S $PINS O=n842 A1=n131 A2=n833 B1=n133 B2=n30
XU223 NR2 $PINS O=n451 I1=n35 I2=n56
XU224 NR2 $PINS O=n228 I1=n21 I2=n58
XU225 NR2 $PINS O=n584 I1=n21 I2=n60
XU226 NR2 $PINS O=n630 I1=n823 I2=n668
XU227 ND3 $PINS O=n701 I1=n81 I2=n79 I3=n392
XU228 NR2 $PINS O=n213 I1=n788 I2=n306
XU229 NR2 $PINS O=n474 I1=n43 I2=n50
XU230 MAOI1 $PINS O=n537 A1=n122 A2=n728 B1=n346 B2=n426
XU231 INV1S $PINS O=n54 I=n421
XU232 INV1S $PINS O=n99 I=n757
XU233 MOAI1S $PINS O=n569 A1=n570 A2=n3 B1=n68 B2=n120
XU234 MOAI1S $PINS O=n918 A1=n213 A2=n347 B1=n116 B2=n728
XU235 NR2 $PINS O=n787 I1=n60 I2=n35
XU236 INV1S $PINS O=n64 I=n585
XU237 INV1S $PINS O=n76 I=n888
XU238 NR2 $PINS O=n471 I1=n45 I2=n53
XU239 ND3 $PINS O=n572 I1=n392 I2=n3 I3=n325
XU240 AN2 $PINS O=n505 I1=n699 I2=n700
XU241 AOI22S $PINS O=n700 A1=n668 A2=n116 B1=n565 B2=n125
XU242 AOI22S $PINS O=n699 A1=n117 A2=n701 B1=n128 B2=n572
XU243 INV1S $PINS O=n51 I=n260
XU244 NR2 $PINS O=n324 I1=n491 I2=n50
XU245 AOI22S $PINS O=n416 A1=n137 A2=n23 B1=n133 B2=n60
XU246 NR2 $PINS O=n588 I1=n65 I2=n823
XU247 INV1S $PINS O=n108 I=n577
XU248 MOAI1S $PINS O=n592 A1=n594 A2=n595 B1=n49 B2=n136
XU249 ND2 $PINS O=n600 I1=n106 I2=n113
XU250 NR2 $PINS O=n719 I1=n721 I2=n722
XU251 INV1S $PINS O=n90 I=n763
XU252 NR2 $PINS O=n241 I1=n92 I2=n48
XU253 ND3 $PINS O=n758 I1=n600 I2=n157 I3=n108
XU254 MOAI1S $PINS O=n623 A1=n318 A2=n594 B1=n115 B2=n23
XU255 NR2 $PINS O=n524 I1=n50 I2=n86
XU256 NR2 $PINS O=n924 I1=n61 I2=n50
XU257 NR2 $PINS O=n439 I1=n38 I2=n61
XU258 INV1S $PINS O=n123 I=n301
XU259 INV1S $PINS O=n130 I=n236
XU260 INV1S $PINS O=n84 I=n492
XU261 NR2 $PINS O=n423 I1=n127 I2=n129
XU262 ND3 $PINS O=n198 I1=n423 I2=n424 I3=n425
XU263 NR2 $PINS O=n425 I1=n131 I2=n120
XU264 INV1S $PINS O=n122 I=n594
XU265 NR2 $PINS O=n570 I1=n119 I2=n124
XU266 NR3 $PINS O=n196 I1=n199 I2=n117 I3=n200
XU267 INV1S $PINS O=n118 I=n200
XU268 AOI22S $PINS O=n546 A1=n577 A2=n8 B1=n117 B2=n2
XU269 INV1S $PINS O=n126 I=n426
XU270 NR2 $PINS O=n182 I1=n126 I2=n127
XU271 INV1S $PINS O=n117 I=n222
XU272 INV1S $PINS O=n116 I=n424
XU273 INV1S $PINS O=n417 I=n348
XU274 NR2 $PINS O=n393 I1=n119 I2=n117
XU275 NR2 $PINS O=n650 I1=n127 I2=n125
XU276 NR2 $PINS O=n895 I1=n116 I2=n129
XU277 INV1S $PINS O=n128 I=n347
XU278 INV1S $PINS O=n125 I=n235
XU279 NR2 $PINS O=n432 I1=n125 I2=n131
XU280 INV1S $PINS O=n337 I=n212
XU281 NR2 $PINS O=n185 I1=n122 I2=n121
XU282 NR2 $PINS O=n786 I1=n129 I2=n125
XU283 NR2 $PINS O=n227 I1=n115 I2=n133
XU284 NR2 $PINS O=n789 I1=n127 I2=n131
XU285 NR2 $PINS O=n440 I1=n419 I2=n418
XU287 OAI222S $PINS O=n819 A1=n820 A2=n216 B1=n527 B2=n821 C1=n822 C2=n229
XU288 NR2 $PINS O=n821 I1=n128 I2=n706
XU289 NR2 $PINS O=n822 I1=n35 I2=n816
XU290 NR2 $PINS O=n820 I1=n51 I2=n815
XU291 NR2 $PINS O=n473 I1=n861 I2=n58
XU292 INV1S $PINS O=n110 I=n160
XU293 ND3 $PINS O=shift1[3] I1=n793 I2=n794 I3=n795
XU294 NR3 $PINS O=n793 I1=n830 I2=n831 I3=n832
XU295 NR3 $PINS O=n795 I1=n796 I2=n797 I3=n798
XU296 AN4B1S $PINS O=n794 I1=n817 I2=n564 I3=n818 B1=n819
XU297 AOI22S $PINS O=n804 A1=n337 A2=n815 B1=n132 B2=n816
XU298 AN4B1S $PINS O=n205 I1=n267 I2=n268 I3=n269 B1=n270
XU299 OAI222S $PINS O=n210 A1=n211 A2=n212 B1=n213 B2=n214 C1=n215 C2=n216
XU300 AN4B1S $PINS O=n211 I1=n167 I2=n217 I3=n218 B1=n219
XU301 AN4B1S $PINS O=n610 I1=n249 I2=n1 I3=n63 B1=n430
XU302 AN4B1S $PINS O=n612 I1=n63 I2=n497 I3=n613 B1=n614
XU303 AN4B1S $PINS O=n611 I1=n471 I2=n317 I3=n516 B1=n60
XU304 ND3 $PINS O=shift2[3] I1=n601 I2=n602 I3=n603
XU305 NR2 $PINS O=n602 I1=n622 I2=n623
XU306 AN4B1S $PINS O=n603 I1=n604 I2=n605 I3=n606 B1=n607
XU307 NR3 $PINS O=n294 I1=n295 I2=n296 I3=n297
XU308 OAI222S $PINS O=n297 A1=n298 A2=n299 B1=n300 B2=n301 C1=n302 C2=n236
XU309 ND3 $PINS O=n296 I1=n303 I2=n304 I3=n305
XU310 ND3 $PINS O=n295 I1=n314 I2=n315 I3=n316
XU311 NR3 $PINS O=n320 I1=n321 I2=n37 I3=n322
XU312 ND3 $PINS O=n321 I1=n221 I2=n323 I3=n218
XU313 INV1S $PINS O=n56 I=n220
XU314 NR2 $PINS O=n400 I1=n62 I2=n56
XU315 NR3 $PINS O=n808 I1=n477 I2=n38 I3=n86
XU316 INV1S $PINS O=n24 I=n632
XU317 INV1S $PINS O=n94 I=n386
XU318 INV1S $PINS O=n98 I=n987
XU319 AN4B1S $PINS O=n885 I1=n697 I2=n886 I3=n887 B1=n522
XU320 AOI22S $PINS O=n884 A1=n117 A2=n65 B1=n133 B2=n20
XU321 NR2 $PINS O=n883 I1=n888 I2=n457
XU322 OAI112HS $PINS O=n457 A1=n716 B1=n889 C1=n193 C2=n28
XU323 OAI222S $PINS O=n830 A1=n256 A2=n301 B1=n599 B2=n93 C1=n825 C2=n345
XU324 INV1S $PINS O=n21 I=n401
XU325 AN4B1S $PINS O=n468 I1=n474 I2=n475 I3=n257 B1=n59
XU326 AN4B1S $PINS O=n470 I1=n471 I2=n472 I3=n473 B1=n37
XU327 AN4B1S $PINS O=n574 I1=n85 I2=n89 I3=n411 B1=n485
XU328 ND3 $PINS O=n576 I1=n221 I2=n146 I3=n400
XU329 AN4B1S $PINS O=n619 I1=n474 I2=n400 I3=n257 B1=n23
XU330 AN4B1S $PINS O=n620 I1=n621 I2=n150 I3=n473 B1=n18
XU331 OAI22S $PINS O=n736 A1=n737 A2=n147 B1=n738 B2=n216
XU332 AN4B1S $PINS O=n737 I1=n218 I2=n34 I3=n665 B1=n47
XU333 ND3 $PINS O=shift2[1] I1=n691 I2=n692 I3=n693
XU334 AN4B1S $PINS O=n692 I1=n730 I2=n75 I3=n731 B1=n732
XU335 NR3 $PINS O=n693 I1=n694 I2=n695 I3=n696
XU336 NR3 $PINS O=n691 I1=n734 I2=n735 I3=n736
XU337 OAI222S $PINS O=n797 A1=n625 A2=n236 B1=n803 B2=n172 C1=n73 C2=n424
XU338 NR3 $PINS O=n803 I1=n626 I2=n421 I3=n37
XU339 AN4B1S $PINS O=n928 I1=n929 I2=n930 I3=n931 B1=n932
XU340 AN4B1S $PINS O=n927 I1=n940 I2=n941 I3=n942 B1=n943
XU341 AN4B1S $PINS O=n983 I1=n473 I2=n217 I3=n404 B1=n22
XU342 AN4B1S $PINS O=n635 I1=n636 I2=n540 I3=n637 B1=n355
XU343 ND3 $PINS O=n627 I1=n454 I2=n273 I3=n504
XU344 INV1S $PINS O=n25 I=n221
XU345 INV1S $PINS O=n97 I=n755
XU346 NR2 $PINS O=n969 I1=n565 I2=n2
XU347 INV1S $PINS O=n29 I=n257
XU348 NR2 $PINS O=n945 I1=n962 I2=n963
XU349 AN4B1S $PINS O=n946 I1=n947 I2=n948 I3=n949 B1=n950
XU350 AN4B1S $PINS O=n944 I1=n790 I2=n965 I3=n354 B1=n673
XU351 NR3 $PINS O=n897 I1=n916 I2=n917 I3=n918
XU352 NR3 $PINS O=n898 I1=n899 I2=n900 I3=n901
XU353 AN4B1S $PINS O=n896 I1=n919 I2=n637 I3=n920 B1=n672
XU354 OAI112HS $PINS O=n501 A1=n504 B1=n505 C1=n154 C2=n150
XU355 MOAI1S $PINS O=n856 A1=n857 A2=n299 B1=n136 B2=n858
XU356 AN4B1S $PINS O=n857 I1=n400 I2=n323 I3=n584 B1=n322
XU357 ND3 $PINS O=n858 I1=n343 I2=n473 I3=n859
XU358 ND3 $PINS O=shift1[2] I1=n839 I2=n840 I3=n841
XU359 AN4B1S $PINS O=n840 I1=n862 I2=n863 I3=n864 B1=n865
XU360 AN4B1S $PINS O=n839 I1=n537 I2=n648 I3=n791 B1=n878
XU361 AN4B1S $PINS O=n841 I1=n842 I2=n843 I3=n844 B1=n845
XU362 OAI112HS $PINS O=n878 A1=n273 B1=n879 C1=n624 C2=n147
XU363 AOI22S $PINS O=n879 A1=n419 A2=n880 B1=n418 B2=n609
XU364 ND3 $PINS O=n880 I1=n498 I2=n39 I3=n882
XU365 NR3 $PINS O=n882 I1=n46 I2=n94 I3=n88
XU366 MOAI1S $PINS O=n735 A1=n1 A2=n229 B1=n115 B2=n739
XU367 ND3 $PINS O=n739 I1=n740 I2=n401 I3=n741
XU368 ND3 $PINS O=shift3[3] I1=n433 I2=n434 I3=n435
XU369 NR2 $PINS O=n434 I1=n452 I2=n453
XU370 NR3 $PINS O=n435 I1=n436 I2=n437 I3=n438
XU371 AN4B1S $PINS O=n433 I1=n454 I2=n455 I3=n456 B1=n457
XU372 INV1S $PINS O=n61 I=n402
XU373 OAI222S $PINS O=n622 A1=n624 A2=n212 B1=n32 B2=n172 C1=n625 C2=n236
XU374 INV1S $PINS O=n32 I=n626
XU375 INV1S $PINS O=n53 I=n309
XU376 ND3 $PINS O=n696 I1=n505 I2=n456 I3=n561
XU377 AOI22S $PINS O=n461 A1=n137 A2=n476 B1=n417 B2=n477
XU378 NR3 $PINS O=n480 I1=n29 I2=n35 I3=n59
XU379 MOAI1S $PINS O=n607 A1=n608 A2=n248 B1=n609 B2=n138
XU380 AN4B1S $PINS O=n608 I1=n1 I2=n484 I3=n87 B1=n44
XU381 NR2 $PINS O=n616 I1=n129 I2=n126
XU382 NR2 $PINS O=n615 I1=n585 I2=n69
XU383 NR2 $PINS O=n617 I1=n618 I2=n19
XU384 OAI222S $PINS O=n377 A1=n378 A2=n229 B1=n379 B2=n216 C1=n380 C2=n335
XU385 NR2 $PINS O=n380 I1=n35 I2=n381
XU386 NR2 $PINS O=n378 I1=n52 I2=n18
XU387 NR2 $PINS O=n379 I1=n382 I2=n19
XU388 AN4B1S $PINS O=n373 I1=n374 I2=n375 I3=n376 B1=n377
XU389 INV1S $PINS O=n35 I=n146
XU390 INV1S $PINS O=n72 I=n422
XU391 NR2 $PINS O=n498 I1=n31 I2=n83
XU392 NR2 $PINS O=n960 I1=n47 I2=n449
XU393 MOAI1S $PINS O=n865 A1=n235 A2=n213 B1=n138 B2=n866
XU394 ND3 $PINS O=n866 I1=n85 I2=n450 I3=n867
XU395 NR2 $PINS O=n867 I1=n496 I2=n534
XU396 AOI22S $PINS O=n863 A1=n429 A2=n871 B1=n135 B2=n872
XU397 ND3 $PINS O=n871 I1=n484 I2=n249 I3=n873
XU398 NR3 $PINS O=n873 I1=n51 I2=n88 I3=n33
XU399 ND3 $PINS O=n336 I1=n776 I2=n389 I3=n837
XU400 NR3 $PINS O=n837 I1=n767 I2=n94 I3=n53
XU401 ND3 $PINS O=n548 I1=n549 I2=n550 I3=n551
XU402 AOI22S $PINS O=n549 A1=n116 A2=n78 B1=n56 B2=n133
XU403 AOI22S $PINS O=n550 A1=n125 A2=n71 B1=n129 B2=n572
XU404 NR3 $PINS O=n551 I1=n552 I2=n553 I3=n539
XU405 INV1S $PINS O=n60 I=n621
XU406 INV1S $PINS O=n27 I=n702
XU407 MOAI1S $PINS O=n705 A1=n28 A2=n193 B1=n2 B2=n706
XU408 OAI12HS $PINS O=n704 A1=n304 B1=n707 B2=n345
XU409 NR2 $PINS O=n595 I1=n422 I2=n565
XU410 NR2 $PINS O=n392 I1=n306 I2=n422
XU411 NR2 $PINS O=n838 I1=n46 I2=n449
XU412 OAI112HS $PINS O=n950 A1=n952 B1=n720 C1=n951 C2=n229
XU413 OAI12HS $PINS O=n952 A1=n337 B1=n43 B2=n344
XU414 NR2 $PINS O=n951 I1=n29 I2=n44
XU415 OA22 $PINS O=n887 A1=n67 A2=n391 B1=n311 B2=n392
XU416 ND3 $PINS O=shift3[1] I1=n506 I2=n507 I3=n508
XU417 AN4B1S $PINS O=n506 I1=n536 I2=n537 I3=n538 B1=n539
XU418 NR2 $PINS O=n507 I1=n525 I2=n526
XU419 AN4B1S $PINS O=n508 I1=n509 I2=n510 I3=n511 B1=n512
XU420 NR3 $PINS O=n510 I1=n521 I2=n522 I3=n523
XU421 AOI13HS $PINS O=n521 A1=n348 B1=n87 B2=n176 B3=n39
XU422 OAI222S $PINS O=n512 A1=n513 A2=n147 B1=n514 B2=n212 C1=n515 C2=n229
XU423 AN4B1S $PINS O=n513 I1=n404 I2=n256 I3=n472 B1=n42
XU424 AN4B1S $PINS O=n515 I1=n218 I2=n516 I3=n451 B1=n53
XU425 OR2 $PINS O=n3 I1=n80 I2=n204
XU426 INV1S $PINS O=n565 I=n3
XU427 NR2 $PINS O=n668 I1=n851 I2=n80
XU428 INV1S $PINS O=n23 I=n163
XU429 INV1S $PINS O=n58 I=n953
XU430 INV1S $PINS O=n92 I=n444
XU431 NR3 $PINS O=n349 I1=n4 I2=n5 I3=n6
XU432 OAI22S $PINS O=n4 A1=n64 A2=n432 B1=n81 B2=n238
XU433 AO22 $PINS O=n5 A1=n419 A2=n430 B1=n133 B2=n431
XU434 OAI112HS $PINS O=n6 A1=n267 B1=n420 C1=n257 C2=n229
XU435 ND3 $PINS O=n749 I1=n759 I2=n760 I3=n761
XU436 AOI22S $PINS O=n759 A1=n136 A2=n339 B1=n418 B2=n766
XU437 AOI22S $PINS O=n760 A1=n114 A2=n764 B1=n132 B2=n765
XU438 ND3 $PINS O=shift2[0] I1=n746 I2=n747 I3=n748
XU439 NR3 $PINS O=n746 I1=n779 I2=n503 I3=n780
XU440 NR3 $PINS O=n747 I1=n768 I2=n769 I3=n770
XU441 NR3 $PINS O=n748 I1=n749 I2=n750 I3=n751
XU442 NR2 $PINS O=n370 I1=FE_OFN248_fold_n_0 I2=n112
XU443 NR2 $PINS O=n823 I1=n80 I2=n101
XU444 NR2 $PINS O=n175 I1=n112 I2=n149
XU445 ND3 $PINS O=shift2[2] I1=n651 I2=n652 I3=n653
XU446 AN4B1S $PINS O=n653 I1=n654 I2=n655 I3=n656 B1=n657
XU447 NR3 $PINS O=n651 I1=n671 I2=n672 I3=n673
XU448 INV1S $PINS O=n45 I=n176
XU449 ND3 $PINS O=n352 I1=n676 I2=n677 I3=n678
XU450 AN4B1S $PINS O=n678 I1=n679 I2=n680 I3=n681 B1=n682
XU451 INV1S $PINS O=n48 I=n323
XU452 ND3 $PINS O=n779 I1=n790 I2=n791 I3=n792
XU453 MOAI1S $PINS O=n408 A1=n409 A2=n147 B1=n429 B2=n410
XU454 ND3 $PINS O=n410 I1=n411 I2=n177 I3=n412
XU456 OR2 $PINS O=n7 I1=n80 I2=n974
XU457 INV1S $PINS O=n306 I=n7
XU458 INV1S $PINS O=n89 I=n767
XU459 ND3 $PINS O=n208 I1=n224 I2=n225 I3=n226
XU460 AOI22S $PINS O=n224 A1=n136 A2=n239 B1=n429 B2=n240
XU461 AOI22S $PINS O=n225 A1=n232 A2=n69 B1=n233 B2=n234
XU462 AN2 $PINS O=n230 I1=n89 I2=n442
XU463 NR2 $PINS O=n167 I1=n52 I2=n48
XU464 ND3 $PINS O=n503 I1=n782 I2=n783 I3=n784
XU465 OA22 $PINS O=n782 A1=n77 A2=n789 B1=n64 B2=n424
XU466 AOI22S $PINS O=n563 A1=n566 A2=n135 B1=n114 B2=n567
XU467 MOAI1S $PINS O=n333 A1=n334 A2=n335 B1=n336 B2=n135
XU468 AN4B1S $PINS O=n334 I1=n1 I2=n338 I3=n177 B1=n339
XU469 AOI22S $PINS O=n244 A1=n132 A2=n255 B1=n58 B2=n115
XU470 ND3 $PINS O=n255 I1=n256 I2=n257 I3=n258
XU471 MOAI1S $PINS O=n769 A1=n174 A2=n7 B1=n133 B2=n774
XU472 ND3 $PINS O=n265 I1=n338 I2=n28 I3=n221
XU473 MOAI1S $PINS O=n559 A1=n217 A2=n154 B1=n71 B2=n116
XU474 OAI22S $PINS O=n396 A1=n397 A2=n154 B1=n398 B2=n299
XU475 AN4B1S $PINS O=n398 I1=n399 I2=n343 I3=n400 B1=n38
XU476 AN4B1S $PINS O=n397 I1=n401 I2=n28 I3=n402 B1=n403
XU477 ND3 $PINS O=n403 I1=n256 I2=n167 I3=n404
XU478 NR2 $PINS O=n450 I1=n45 I2=n52
XU479 AOI22S $PINS O=n545 A1=n135 A2=n33 B1=n115 B2=n578
XU480 ND3 $PINS O=n578 I1=n218 I2=n163 I3=n34
XU481 OA22 $PINS O=n862 A1=n874 A2=n348 B1=n875 B2=n229
XU482 NR3 $PINS O=n874 I1=n877 I2=n265 I3=n37
XU483 AN4B1S $PINS O=n875 I1=n876 I2=n472 I3=n647 B1=n49
XU484 ND3 $PINS O=n877 I1=n260 I2=FE_OFN271_n242 I3=n400
XU485 NR2 $PINS O=n522 I1=n313 I2=n415
XU486 AOI22S $PINS O=n713 A1=n137 A2=n723 B1=n126 B2=n585
XU487 OA12 $PINS O=n714 A1=n720 B1=n719 B2=n82
XU488 AN2 $PINS O=n272 I1=n686 I2=n687
XU489 AOI22S $PINS O=n686 A1=n117 A2=n306 B1=n56 B2=n137
XU490 NR2 $PINS O=n689 I1=n124 I2=n116
XU491 ND3 $PINS O=n932 I1=n933 I2=n304 I3=n934
XU492 OAI12HS $PINS O=n934 A1=n123 B1=n38 B2=n861
XU493 OAI222S $PINS O=n482 A1=n345 A2=n221 B1=n483 B2=n231 C1=n172 C2=n338
XU494 AN4B1S $PINS O=n483 I1=n484 I2=n146 I3=n90 B1=n485
XU495 NR2 $PINS O=n412 I1=n36 I2=n500
XU496 MOAI1S $PINS O=n780 A1=n388 A2=n311 B1=n337 B2=n781
XU497 ND3 $PINS O=n781 I1=n474 I2=n256 I3=n575
XU498 NR2 $PINS O=n177 I1=n767 I2=n83
XU499 OA22 $PINS O=n636 A1=n600 A2=n82 B1=n72 B2=n424
XU500 OAI112HS $PINS O=n502 A1=n799 B1=n800 C1=n646 C2=n594
XU501 OA22 $PINS O=n800 A1=n426 A2=n801 B1=n191 B2=n560
XU502 OA12 $PINS O=n799 A1=n697 B1=n318 B2=n178
XU503 NR2 $PINS O=n264 I1=n500 I2=n48
XU504 AN2 $PINS O=n562 I1=n674 I2=n675
XU505 AOI22S $PINS O=n674 A1=n23 A2=n123 B1=n83 B2=n135
XU506 ND3 $PINS O=n860 I1=n597 I2=n97 I3=n329
XU507 AN4B1S $PINS O=n762 I1=n442 I2=n411 I3=n533 B1=n48
XU508 OAI22S $PINS O=n888 A1=n191 A2=n77 B1=n178 B2=n79
XU509 NR2 $PINS O=n298 I1=n18 I2=n62
XU510 NR2 $PINS O=n519 I1=n422 I2=n823
XU511 NR2 $PINS O=n585 I1=n80 I2=n894
XU512 OA22 $PINS O=n579 A1=n589 A2=n147 B1=n426 B2=n81
XU513 AN4B1S $PINS O=n589 I1=n220 I2=n257 I3=n590 B1=n23
XU514 NR2 $PINS O=n876 I1=n46 I2=n62
XU515 NR2 $PINS O=n560 I1=n823 I2=n467
XU516 OAI222S $PINS O=n481 A1=n486 A2=n335 B1=n487 B2=n488 C1=n489 C2=n248
XU517 NR3 $PINS O=n487 I1=n494 I2=n495 I3=n496
XU518 NR3 $PINS O=n489 I1=n490 I2=n491 I3=n492
XU519 INV1S $PINS O=n107 I=n894
XU520 INV1S $PINS O=n103 I=n974
XU521 NR3 $PINS O=n977 I1=n980 I2=n201 I3=n979
XU522 AN4B1S $PINS O=n978 I1=n688 I2=n415 I3=n96 B1=n189
XU523 ND3 $PINS O=n980 I1=n600 I2=n415 I3=n100
XU524 NR2 $PINS O=n663 I1=n467 I2=n565
XU525 AN2 $PINS O=n661 I1=n664 I2=n524
XU526 AN2 $PINS O=n662 I1=n389 I2=n475
XU527 OAI22S $PINS O=n770 A1=n771 A2=n229 B1=n772 B2=n299
XU528 AN4B1S $PINS O=n772 I1=n584 I2=n741 I3=n400 B1=n37
XU529 AN4B1S $PINS O=n771 I1=n773 I2=n404 I3=n257 B1=n51
XU530 NR2 $PINS O=n666 I1=n668 I2=n306
XU531 NR2 $PINS O=n667 I1=n50 I2=n88
XU532 AN4B1S $PINS O=n351 I1=n76 I2=n353 I3=n354 B1=n355
XU533 MOAI1S $PINS O=n332 A1=n340 A2=n147 B1=n429 B2=n341
XU534 AN4B1S $PINS O=n340 I1=n217 I2=n343 I3=n1 B1=n344
XU535 ND3 $PINS O=n341 I1=n63 I2=n254 I3=n342
XU536 OAI222S $PINS O=n331 A1=n345 A2=n221 B1=n346 B2=n347 C1=n220 C2=n348
XU537 ND3 $PINS O=n436 I1=n445 I2=n304 I3=n446
XU538 AOI22S $PINS O=n446 A1=n137 A2=n447 B1=n429 B2=n448
XU539 OR2 $PINS O=n448 I1=n449 I2=n52
XU540 OAI22S $PINS O=n657 A1=n658 A2=n335 B1=n659 B2=n147
XU541 AN4B1S $PINS O=n658 I1=n230 I2=n260 I3=n217 B1=n86
XU542 NR3 $PINS O=n659 I1=n660 I2=n59 I3=n20
XU543 NR2 $PINS O=n690 I1=n83 I2=n45
XU544 OAI222S $PINS O=n750 A1=n256 A2=n301 B1=n67 B2=n319 C1=n594 C2=n3
XU545 AOI22S $PINS O=n305 A1=n306 A2=n307 B1=n337 B2=n308
XU546 INV1S $PINS O=n63 I=n500
XU547 OAI222S $PINS O=n962 A1=n178 A2=n67 B1=n595 B2=n426 C1=n630 C2=n319
XU548 OAI222S $PINS O=n901 A1=n902 A2=n147 B1=n903 B2=n154 C1=n904 C2=n348
XU549 NR2 $PINS O=n902 I1=n21 I2=n53
XU550 NR2 $PINS O=n903 I1=n18 I2=n36
XU551 AN2 $PINS O=n904 I1=n533 I2=n217
XU552 MOAI1S $PINS O=n832 A1=n754 A2=n313 B1=n127 B2=n833
XU553 NR3 $PINS O=n342 I1=n91 I2=n92 I3=n767
XU554 ND3 $PINS O=n899 I1=n909 I2=n910 I3=n911
XU555 AOI22S $PINS O=n910 A1=n419 A2=n914 B1=n8 B2=n915
XU556 OAI222S $PINS O=n209 A1=n222 A2=n3 B1=n87 B2=n172 C1=n93 C2=n223
XU557 INV1S $PINS O=n81 I=n467
XU558 MOAI1S $PINS O=n553 A1=n313 A2=n802 B1=n123 B2=n58
XU559 AOI22S $PINS O=n420 A1=n417 A2=n421 B1=n422 B2=n198
XU560 INV1S $PINS O=n102 I=n204
XU561 AN2 $PINS O=n599 I1=n312 I2=n518
XU562 OAI22S $PINS O=n170 A1=n171 A2=n172 B1=n173 B2=n174
XU563 NR2 $PINS O=n173 I1=n175 I2=n107
XU564 AN4B1S $PINS O=n171 I1=n176 I2=n150 I3=n177 B1=n62
XU565 MOAI1S $PINS O=n582 A1=n335 A2=n412 B1=n138 B2=n583
XU566 ND3 $PINS O=n583 I1=n254 I2=n533 I3=n39
XU567 OAI222S $PINS O=n591 A1=n82 A2=n100 B1=n520 B2=n238 C1=n596 C2=n93
XU568 AN4B1S $PINS O=n596 I1=n597 I2=n97 I3=n223 B1=n598
XU569 ND3 $PINS O=n598 I1=n599 I2=n600 I3=n99
XU570 OAI222S $PINS O=n526 A1=n527 A2=n347 B1=n70 B2=n222 C1=n248 C2=n386
XU571 INV1S $PINS O=n70 I=n528
XU572 NR2 $PINS O=n260 I1=n53 I2=n52
XU573 AOI22S $PINS O=n818 A1=n826 A2=n827 B1=n828 B2=n528
XU574 ND3 $PINS O=n827 I1=n96 I2=n688 I3=n754
XU575 MOAI1S $PINS O=n568 A1=n423 A2=n67 B1=n419 B2=n571
XU576 ND3 $PINS O=n766 I1=n177 I2=n664 I3=n535
XU577 INV1S $PINS O=n91 I=n664
XU578 INV1S $PINS O=n106 I=n851
XU579 ND3 $PINS O=n532 I1=n450 I2=n533 I3=n266
XU580 OAI222S $PINS O=n916 A1=n346 A2=n235 B1=n388 B2=n191 C1=n229 C2=n402
XU581 OAI112HS $PINS O=n464 A1=n466 B1=n427 C1=n465 C2=n236
XU582 OAI12HS $PINS O=n466 A1=n129 B1=n467 B2=n234
XU583 OA22 $PINS O=n315 A1=n231 A2=n324 B1=n222 B2=n325
XU584 OA22 $PINS O=n414 A1=n93 A2=n415 B1=n319 B2=n79
XU585 AOI22S $PINS O=n413 A1=n120 A2=n306 B1=n129 B2=n69
XU586 ND3 $PINS O=n201 I1=n597 I2=n157 I3=n599
XU587 OAI222S $PINS O=n394 A1=n7 A2=n214 B1=n174 B2=n72 C1=n1 C2=n348
XU588 OA22 $PINS O=n581 A1=n236 A2=n465 B1=n216 B2=n584
XU589 NR2 $PINS O=n577 I1=n894 I2=n113
XU590 OAI222S $PINS O=n751 A1=n752 A2=n93 B1=n753 B2=n82 C1=n313 C2=n600
XU591 NR3 $PINS O=n752 I1=n756 I2=n757 I3=n758
XU592 AN4B1S $PINS O=n753 I1=n518 I2=n754 I3=n223 B1=n755
XU593 ND3 $PINS O=n756 I1=n158 I2=n97 I3=n518
XU594 MOAI1S $PINS O=n593 A1=n519 A2=n214 B1=n31 B2=n419
XU595 MOAI1S $PINS O=n963 A1=n93 A2=n158 B1=n123 B2=n58
XU596 MOAI1S $PINS O=n355 A1=n638 A2=n313 B1=n124 B2=n565
XU597 OA22 $PINS O=n648 A1=n391 A2=n64 B1=n638 B2=n82
XU598 NR2 $PINS O=n249 I1=n83 I2=n91
XU599 MOAI1S $PINS O=n732 A1=n733 A2=n488 B1=n30 B2=n417
XU600 NR2 $PINS O=n733 I1=n51 I2=n491
XU601 OA22 $PINS O=n245 A1=n93 A2=n518 B1=n174 B2=n67
XU602 MOAI1S $PINS O=n558 A1=n313 A2=n100 B1=n306 B2=n130
XU603 NR2 $PINS O=n850 I1=n109 I2=n103
XU604 NR2 $PINS O=n644 I1=n467 I2=n306
XU605 AOI22S $PINS O=n790 A1=n132 A2=n52 B1=n306 B2=n117
XU606 INV1S $PINS O=n86 I=n338
XU607 ND3 $PINS O=n672 I1=n921 I2=n541 I3=n922
XU608 AOI22S $PINS O=n921 A1=n127 A2=n823 B1=n417 B2=n92
XU609 NR2 $PINS O=n923 I1=n121 I2=n117
XU610 NR2 $PINS O=n465 I1=n422 I2=n585
XU611 OA22 $PINS O=n541 A1=n93 A2=n597 B1=n82 B2=n688
XU612 OAI22S $PINS O=n438 A1=n439 A2=n212 B1=n386 B2=n440
XU613 MOAI1S $PINS O=n453 A1=n231 A2=n338 B1=n133 B2=n21
XU614 INV1S $PINS O=n991 I=n286
XU615 MOAI1S $PINS O=n437 A1=n441 A2=n442 B1=n135 B2=n443
XU616 NR2 $PINS O=n441 I1=n138 I2=n419
XU617 OR2 $PINS O=n965 I1=n348 I2=n442
XU618 MOAI1S $PINS O=n452 A1=n214 A2=n81 B1=n46 B2=n419
XU619 INV1S $PINS O=n129 I=n311
XU620 INV1S $PINS O=n127 I=n391
XU621 INV1S $PINS O=n124 I=n174
XU622 ND2 $PINS O=n594 I1=n936 I2=n964
XU623 INV1S $PINS O=n137 I=n229
XU624 INV1S $PINS O=n992 I=n954
XU625 MOAI1S $PINS O=n917 A1=n79 A2=n391 B1=n306 B2=n130
XU626 ND3 $PINS O=n829 I1=n850 I2=n851 I3=n852
XU627 NR2 $PINS O=n852 I1=n160 I2=n102
XU628 INV1S $PINS O=n133 I=n345
XU629 ND2 $PINS O=n235 I1=n360 I2=n935
XU630 INV1S $PINS O=n135 I=n248
XU631 ND2 $PINS O=n424 I1=n912 I2=n360
XU632 ND2 $PINS O=n348 I1=n291 I2=n954
XU633 INV1S $PINS O=n120 I=n238
XU634 INV1S $PINS O=n119 I=n319
XU635 INV1S $PINS O=n131 I=n214
XU636 ND2 $PINS O=n347 I1=n908 I2=n964
XU637 NR2 $PINS O=n367 I1=n149 I2=n991
XU638 ND2 $PINS O=n212 I1=n291 I2=n286
XU639 INV1S $PINS O=n419 I=n172
XU640 AOI22S $PINS O=n142 A1=n123 A2=n168 B1=n122 B2=n107
XU641 INV1S $PINS O=n429 I=n488
XU642 INV1S $PINS O=n114 I=n216
XU643 INV1S $PINS O=n121 I=n178
XU644 INV1S $PINS O=n115 I=n299
XU645 INV1S $PINS O=n132 I=n147
XU646 INV1S $PINS O=n418 I=n335
XU647 INV1S $PINS O=n136 I=n154
XU648 INV1S $PINS O=n138 I=n231
XU649 NR2 $PINS O=n160 I1=n112 I2=n203
XU650 NR2 $PINS O=n961 I1=n111 I2=n_idx[1]
XU651 NR2 $PINS O=n811 I1=n279 I2=n25
XU652 NR3 $PINS O=n812 I1=n763 I2=n55 I3=n41
XU653 ND3 $PINS O=n477 I1=n162 I2=n444 I3=n810
XU654 AN2 $PINS O=n810 I1=n647 I2=n24
XU655 NR2 $PINS O=n987 I1=n149 I2=n_idx[1]
XU656 AN4B1S $PINS O=n807 I1=n664 I2=n162 I3=n217 B1=n609
XU657 OAI222S $PINS O=n734 A1=n742 A2=n248 B1=n743 B2=n335 C1=n744 C2=n231
XU658 AN4B1S $PINS O=n742 I1=n85 I2=n177 I3=n478 B1=n745
XU659 AN4B1S $PINS O=n743 I1=n89 I2=n613 I3=n324 B1=n52
XU660 AN4B1S $PINS O=n744 I1=n664 I2=n493 I3=n613 B1=n496
XU662 NR2 $PINS O=n257 I1=n279 I2=n58
XU663 OAI112HS $PINS O=n943 A1=n792 B1=n920 C1=n248 C2=n778
XU664 NR2 $PINS O=n755 I1=n98 I2=n_idx[0]
XU665 AN2 $PINS O=n540 I1=n639 I2=n640
XU666 AOI22S $PINS O=n639 A1=n642 A2=n643 B1=n26 B2=n123
XU667 AOI22S $PINS O=n640 A1=n326 A2=n641 B1=n115 B2=n20
XU668 ND3 $PINS O=n641 I1=n415 I2=n95 I3=n108
XU669 AN4B1S $PINS O=n844 I1=n853 I2=n854 I3=n855 B1=n856
XU670 AOI22S $PINS O=n853 A1=n130 A2=n65 B1=n565 B2=n116
XU671 AOI22S $PINS O=n855 A1=n326 A2=n860 B1=n119 B2=n306
XU672 AOI22S $PINS O=n854 A1=n123 A2=n861 B1=n129 B2=n668
XU673 OAI22S $PINS O=n246 A1=n156 A2=n28 B1=n247 B2=n248
XU674 ND3 $PINS O=n250 I1=n252 I2=FE_OFN258_n253 I3=n254
XU675 NR3 $PINS O=n985 I1=n112 I2=n111 I3=n40
XU676 INV1S $PINS O=n40 I=n280
XU677 NR2 $PINS O=n422 I1=n80 I2=n181
XU678 OAI22S $PINS O=n552 A1=n628 A2=n348 B1=n629 B2=n222
XU679 NR2 $PINS O=n629 I1=n422 I2=n68
XU680 NR3 $PINS O=n628 I1=n631 I2=n26 I3=n632
XU681 NR2 $PINS O=n516 I1=n20 I2=n279
XU682 INV1S $PINS O=n80 I=n194
XU683 INV1S $PINS O=n28 I=n279
XU684 AN4B1S $PINS O=n975 I1=n252 I2=n444 I3=n406 B1=n500
XU685 OAI222S $PINS O=n525 A1=n529 A2=n335 B1=n530 B2=n488 C1=n531 C2=n231
XU686 NR3 $PINS O=n529 I1=n534 I2=n491 I3=n42
XU687 AN4B1S $PINS O=n530 I1=n493 I2=n444 I3=n442 B1=n382
XU688 AN2 $PINS O=n939 I1=n958 I2=FE_OFN248_fold_n_0
XU689 ND3 $PINS O=n166 I1=n280 I2=n111 I3=n370
XU690 NR3 $PINS O=n729 I1=n59 I2=n279 I3=n53
XU691 ND3 $PINS O=n694 I1=n724 I2=n725 I3=n726
XU692 AOI22S $PINS O=n724 A1=n120 A2=n71 B1=n131 B2=n78
XU693 AOI22S $PINS O=n725 A1=n337 A2=n727 B1=n124 B2=n728
XU694 OAI222S $PINS O=n768 A1=n775 A2=n488 B1=n24 B2=n348 C1=n776 C2=n231
XU695 NR3 $PINS O=n775 I1=n777 I2=n41 I3=n496
XU696 ND3 $PINS O=n777 I1=n493 I2=n778 I3=n241
XU697 OAI22S $PINS O=n831 A1=n835 A2=n335 B1=n836 B2=n488
XU698 NR2 $PINS O=n835 I1=n496 I2=n336
XU699 AN2 $PINS O=n836 I1=FE_OFN258_n253 I2=n809
XU700 AOI22S $PINS O=n864 A1=n337 A2=n868 B1=n114 B2=n869
XU701 ND3 $PINS O=n869 I1=n34 I2=n621 I3=n516
XU702 ND3 $PINS O=n868 I1=n439 I2=n517 I3=n870
XU703 NR3 $PINS O=n870 I1=n18 I2=n279 I3=n51
XU704 INV1S $PINS O=n52 I=n162
XU705 AOI22S $PINS O=n314 A1=n127 A2=n65 B1=n326 B2=n327
XU706 ND3 $PINS O=n327 I1=n328 I2=n329 I3=n330
XU707 AN2 $PINS O=n330 I1=n158 I2=n312
XU708 AN4B1S $PINS O=n155 I1=n157 I2=n158 I3=n159 B1=n160
XU709 NR3 $PINS O=n153 I1=n161 I2=n21 I3=n47
XU710 ND3 $PINS O=n161 I1=n162 I2=n28 I3=n163
XU711 ND3 $PINS O=sign3[1] I1=n139 I2=n140 I3=n141
XU712 NR2 $PINS O=n139 I1=n183 I2=n184
XU713 NR2 $PINS O=n140 I1=n169 I2=n170
XU714 AN4B1S $PINS O=n141 I1=n142 I2=n143 I3=n144 B1=n145
XU715 AOI22S $PINS O=n949 A1=n429 A2=n956 B1=n135 B2=n957
XU716 ND3 $PINS O=n490 I1=n493 I2=n386 I3=n254
XU717 INV1S $PINS O=n83 I=n778
XU718 ND3 $PINS O=n900 I1=n75 I2=n304 I3=n905
XU719 AOI22S $PINS O=n905 A1=n643 A2=n906 B1=n422 B2=n907
XU720 INV1S $PINS O=n109 I=n181
XU721 NR2 $PINS O=n938 I1=n114 I2=n418
XU722 INV1S $PINS O=n105 I=n758
XU723 AN2 $PINS O=n937 I1=n401 I2=n343
XU724 OA12 $PINS O=n467 A1=n194 B1=n106 B2=n107
XU725 AOI22S $PINS O=n680 A1=n337 A2=n683 B1=n419 B2=n684
XU726 AN2 $PINS O=n269 I1=n925 I2=n926
XU727 AOI22S $PINS O=n925 A1=n326 A2=n642 B1=n25 B2=n115
XU728 NR2 $PINS O=n278 I1=n890 I2=n991
XU729 OAI112HS $PINS O=n277 A1=n289 B1=n290 C1=k_idx[2] C2=n203
XU730 OA22 $PINS O=n791 A1=n891 A2=n80 B1=n99 B2=n313
XU731 NR2 $PINS O=n891 I1=n892 I2=n893
XU732 OAI222S $PINS O=n893 A1=n110 A2=n319 B1=n570 B2=n204 C1=n178 C2=n181
XU733 OAI222S $PINS O=n892 A1=n118 A2=n894 B1=n895 B2=n101 C1=n850 C2=n391
XU734 ND3 $PINS O=n845 I1=n846 I2=n720 I3=n847
XU735 ND3 $PINS O=n846 I1=n194 I2=n829 I3=n120
XU736 AOI22S $PINS O=n847 A1=n8 A2=n848 B1=n117 B2=n849
XU737 AOI22S $PINS O=n843 A1=n74 A2=n199 B1=n643 B2=n189
XU738 OAI222S $PINS O=n183 A1=n190 A2=n191 B1=n192 B2=n193 C1=n194 C2=n195
XU739 AN2 $PINS O=n190 I1=n203 I2=n204
XU740 AN2 $PINS O=n195 I1=n185 I2=n152
XU741 NR2 $PINS O=n192 I1=n201 I2=n202
XU742 AN2 $PINS O=n8 I1=n186 I2=n17
XU743 INV1S $PINS O=n313 I=n8
XU744 INV1S $PINS O=n82 I=n643
XU745 AOI22S $PINS O=n143 A1=n115 A2=n164 B1=n418 B2=n92
XU746 NR2 $PINS O=n286 I1=n16 I2=n15
XU747 NR2 $PINS O=n936 I1=n991 I2=n134
XU748 NR2 $PINS O=n360 I1=n890 I2=n14
XU749 OAI12HS $PINS O=n276 A1=n180 B1=n134 B2=n357
XU750 OA22 $PINS O=n359 A1=n17 A2=n360 B1=n98 B2=n286
XU751 ND3 $PINS O=n356 I1=n361 I2=n362 I3=n363
XU752 ND3 $PINS O=n361 I1=n188 I2=n991 I3=n368
XU753 ND3 $PINS O=n362 I1=n366 I2=n17 I3=n367
XU754 INV1S $PINS O=n93 I=n326
XU755 AN2 $PINS O=n291 I1=n287 I2=n890
XU756 ND2 $PINS O=n174 I1=n369 I2=n936
XU757 ND3 $PINS O=n193 I1=n15 I2=n16 I3=n955
XU758 ND3 $PINS O=n345 I1=n286 I2=n134 I3=n360
XU759 AN2 $PINS O=n908 I1=k_idx[3] I2=n973
XU760 NR2 $PINS O=n964 I1=n890 I2=k_idx[2]
XU761 AN2 $PINS O=n935 I1=n973 I2=n15
XU762 ND2 $PINS O=n229 I1=n954 I2=n955
XU763 OAI112HS $PINS O=n202 A1=n110 B1=n17 C1=n203 C2=n113
XU764 NR2 $PINS O=n954 I1=n16 I2=k_idx[3]
XU765 NR2 $PINS O=n912 I1=n992 I2=n134
XU766 ND3 $PINS O=n817 I1=n124 I2=n829 I3=n194
XU767 ND2 $PINS O=n178 I1=n936 I2=n913
XU768 ND3 $PINS O=n248 I1=k_idx[3] I2=n16 I3=n955
XU769 ND3 $PINS O=n231 I1=k_idx[3] I2=n16 I3=n291
XU770 ND2 $PINS O=n319 I1=n912 I2=n369
XU771 ND2 $PINS O=n238 I1=n912 I2=n913
XU772 ND2 $PINS O=n154 I1=n955 I2=n286
XU773 ND3 $PINS O=n156 I1=n913 I2=n15 I3=n959
XU774 ND2 $PINS O=n214 I1=n908 I2=n369
XU775 ND3 $PINS O=n172 I1=n360 I2=n15 I3=n959
XU781 ND3 $PINS O=n488 I1=n360 I2=k_idx[3] I3=n959
XU786 ND3 $PINS O=n216 I1=n360 I2=n134 I3=n954
XU793 ND2 $PINS O=n191 I1=n369 I2=n935
XU808 ND3 $PINS O=n299 I1=n913 I2=n134 I3=n286
XU809 ND3 $PINS O=n147 I1=n913 I2=n134 I3=n954
XU832 ND3 $PINS O=n335 I1=k_idx[3] I2=n913 I3=n959
XU846 NR2 $PINS O=n989 I1=n110 I2=n_idx[4]
XU878 ND3 $PINS O=sign3[0] I1=n205 I2=n206 I3=n207
XU882 AN4B1S $PINS O=n206 I1=n243 I2=n244 I3=n245 B1=n246
XU893 NR3 $PINS O=n207 I1=n208 I2=n209 I3=n210
XU910 ND3 $PINS O=sign2[0] I1=n292 I2=n293 I3=n294
XU914 NR3 $PINS O=n293 I1=n331 I2=n332 I3=n333
XU918 AN4B1S $PINS O=n292 I1=n349 I2=n350 I3=n351 B1=n352
XU921 NR2 $PINS O=n986 I1=n181 I2=n_idx[4]
XU922 NR2 $PINS O=n165 I1=n98 I2=n_idx[4]
XU938 INV1S $PINS O=n104 I=n_idx[3]
XU952 NR2 $PINS O=n984 I1=n204 I2=n_idx[4]
XU953 NR2 $PINS O=n990 I1=n104 I2=n_idx[2]
XU963 NR2 $PINS O=n988 I1=n974 I2=n_idx[4]
XU964 NR3 $PINS O=n976 I1=n_idx[1] I2=FE_OFN279_fold_n_2 I3=FE_OFN248_fold_n_0
XU965 ND3 $PINS O=sign1[0] I1=n371 I2=n372 I3=n373
XU966 NR3 $PINS O=n372 I1=n394 I2=n395 I3=n396
XU967 NR3 $PINS O=n371 I1=n407 I2=n270 I3=n408
XU969 NR2 $PINS O=n194 I1=n_idx[0] I2=n_idx[4]
XU975 NR2 $PINS O=n958 I1=n104 I2=n_idx[4]
XU978 NR2 $PINS O=n970 I1=FE_OFN279_fold_n_2 I2=n_idx[0]
XU980 NR2 $PINS O=n981 I1=n111 I2=n_idx[3]
XU981 MOAI1S $PINS O=n145 A1=n146 A2=n147 B1=n133 B2=n148
XU982 OAI112HS $PINS O=n148 A1=n150 B1=n151 C1=n_idx[4] C2=n149
XU984 MOAI1S $PINS O=n184 A1=n185 A2=n149 B1=n186 B2=n187
XU985 INV1S $PINS O=n17 I=n_idx[4]
XU986 NR2 $PINS O=n643 I1=n193 I2=n_idx[4]
XU988 OAI112HS $PINS O=n169 A1=n179 B1=n180 C1=n_idx[3] C2=n178
XU989 INV1S $PINS O=n16 I=k_idx[4]
XU991 INV1S $PINS O=n890 I=k_idx[1]
XU992 INV1S $PINS O=n15 I=k_idx[3]
XU993 NR2 $PINS O=n326 I1=n156 I2=n_idx[4]
XU994 NR2 $PINS O=n913 I1=n14 I2=k_idx[1]
XU995 NR2 $PINS O=n287 I1=k_idx[2] I2=k_idx[0]
XU996 AN2 $PINS O=n955 I1=n287 I2=k_idx[1]
XU997 AOI22S $PINS O=n363 A1=n364 A2=n991 B1=n165 B2=n365
XU999 MOAI1S $PINS O=n364 A1=k_idx[1] A2=n159 B1=n14 B2=n202
XU1000 INV1S $PINS O=n134 I=k_idx[0]
XU1001 NR2 $PINS O=n973 I1=n134 I2=k_idx[4]
XU1002 OAI112HS $PINS O=n281 A1=n283 B1=n284 C1=n282 C2=n188
XU1003 AOI13HS $PINS O=n284 A1=n123 B1=k_idx[1] B2=n285 B3=n286
XU1004 MOAI1S $PINS O=n285 A1=n_idx[2] A2=n287 B1=n288 B2=n112
XU1005 INV1S $PINS O=n14 I=k_idx[2]
XU1006 NR2 $PINS O=n959 I1=k_idx[4] I2=k_idx[0]
XU1007 NR2 $PINS O=n369 I1=k_idx[2] I2=k_idx[1]
XU1008 AOI13HS $PINS O=n290 A1=n_idx[4] B1=n_idx[1] B2=n_idx[3] B3=n291
XU1009 AN2 $PINS O=n368 I1=n_idx[3] I2=n369
XU1010 MOAI1S $PINS O=n366 A1=n287 A2=n890 B1=k_idx[0] B2=k_idx[2]
XU1011 OA12 $PINS O=n274 A1=n992 B1=k_idx[4] B2=n15
XU129 AN4S $PINS O=n409 I1=n220 I2=n401 I3=n406 I4=n399
.ENDS

.SUBCKT SNPS_CLOCK_GATE_HIGH_ROM_Wrapper_Even_1 EN ENCLK CLK
*.CONNECT net2376 EN
XFE_PHC1293_net2379 DELC $PINS O=FE_PHN1293_net2379 I=net2379
Xlatch QDBHN $PINS Q=net2379 D=net2376 CKB=CLK
Xmain_gate AN2 $PINS O=ENCLK I1=FE_PHN1293_net2379 I2=CLK
.ENDS

.SUBCKT ROM_Wrapper_Even_1 rst_n en n_in[4] n_in[3] n_in[2] n_in[1] n_in[0]
+ k_idx[4] k_idx[3] k_idx[2] k_idx[1] k_idx[0] reg_sign1[1] reg_sign1[0]
+ reg_sign2[1] reg_sign2[0] reg_sign3[1] reg_sign3[0] reg_shift1[3]
+ reg_shift1[2] reg_shift1[1] reg_shift1[0] reg_shift2[3] reg_shift2[2]
+ reg_shift2[1] reg_shift2[0] reg_shift3[3] reg_shift3[2] reg_shift3[1]
+ reg_shift3[0] i_rst_n FE_OFN14_i_rst_n clk
*.CONNECT N4 n_in[0]
XCTS_ccl_a_INV_CLK_G1_L10_42 INV3CK $PINS O=CTS_10 I=CTS_11
XCTS_ccl_a_INV_CLK_G1_L9_44 INV2CK $PINS O=CTS_11 I=CTS_12
XFE_RC_3949_0 NR2 $PINS O=FE_RN_2568_0 I1=n8 I2=N2
XFE_RC_3948_0 AO12 $PINS O=fold_n[0] A1=FE_RN_2568_0 B1=N2 B2=n_in[0]
XFE_OFC559_rom_n_idx_3__3 INV1S $PINS O=n6 I=n_in[3]
Xreg_sign1_reg[1] DFFSBN $PINS Q=reg_sign1[1] D=raw_s1[1] CK=CTS_10
+ SB=FE_OFN14_i_rst_n
Xreg_sign2_reg[1] DFFSBN $PINS Q=reg_sign2[1] D=raw_s2[1] CK=CTS_10
+ SB=FE_OFN14_i_rst_n
Xreg_sign3_reg[1] DFFSBN $PINS Q=reg_sign3[1] D=raw_s3[1] CK=CTS_10
+ SB=FE_OFN14_i_rst_n
Xreg_shift2_reg[1] QDFFRBN $PINS Q=reg_shift2[1] D=raw_h2[1] CK=CTS_10
+ RB=FE_OFN14_i_rst_n
Xreg_shift3_reg[1] QDFFRBN $PINS Q=reg_shift3[1] D=raw_h3[1] CK=CTS_10
+ RB=i_rst_n
Xreg_shift1_reg[1] QDFFRBN $PINS Q=reg_shift1[1] D=raw_h1[1] CK=CTS_10
+ RB=FE_OFN14_i_rst_n
Xreg_shift1_reg[2] QDFFRBN $PINS Q=reg_shift1[2] D=raw_h1[2] CK=CTS_10
+ RB=FE_OFN14_i_rst_n
Xreg_shift2_reg[0] QDFFRBN $PINS Q=reg_shift2[0] D=raw_h2[0] CK=CTS_10
+ RB=FE_OFN14_i_rst_n
Xreg_shift3_reg[0] QDFFRBN $PINS Q=reg_shift3[0] D=raw_h3[0] CK=CTS_10
+ RB=FE_OFN14_i_rst_n
Xreg_shift3_reg[2] QDFFRBN $PINS Q=reg_shift3[2] D=raw_h3[2] CK=CTS_10
+ RB=i_rst_n
Xreg_shift3_reg[3] QDFFRBN $PINS Q=reg_shift3[3] D=raw_h3[3] CK=CTS_10
+ RB=i_rst_n
Xreg_shift2_reg[2] QDFFRBN $PINS Q=reg_shift2[2] D=raw_h2[2] CK=CTS_10
+ RB=FE_OFN14_i_rst_n
Xreg_shift1_reg[3] QDFFRBN $PINS Q=reg_shift1[3] D=raw_h1[3] CK=CTS_10
+ RB=i_rst_n
Xreg_shift2_reg[3] QDFFRBN $PINS Q=reg_shift2[3] D=raw_h2[3] CK=CTS_10
+ RB=i_rst_n
Xreg_sign2_reg[0] QDFFRBP $PINS Q=reg_sign2[0] D=final_s2[0] CK=CTS_10
+ RB=FE_OFN14_i_rst_n
Xreg_sign1_reg[0] QDFFRBN $PINS Q=reg_sign1[0] D=final_s1[0] CK=CTS_10
+ RB=FE_OFN14_i_rst_n
Xreg_shift1_reg[0] QDFFRBN $PINS Q=reg_shift1[0] D=raw_h1[0] CK=CTS_10
+ RB=FE_OFN14_i_rst_n
Xreg_sign3_reg[0] QDFFRBN $PINS Q=reg_sign3[0] D=final_s3[0] CK=CTS_10
+ RB=FE_OFN14_i_rst_n
XU4 MOAI1 $PINS O=fold_n[4] A1=n7 A2=N2 B1=N8 B2=N2
XU5 AN2S $PINS O=sub_79/carry[2] I1=n8 I2=n4
XU6 AN2S $PINS O=sub_79/carry[3] I1=sub_79/carry[2] I2=n5
XU7 AN2S $PINS O=sub_79/carry[4] I1=sub_79/carry[3] I2=n6
XU8 ND3S $PINS O=n10 I1=N2 I2=n11 I3=k_idx[0]
XU9 XNR2HS $PINS O=final_s3[0] I1=raw_s3[0] I2=n10
XU10 MOAI1 $PINS O=fold_n[1] A1=n4 A2=N2 B1=N5 B2=N2
XU11 XNR2HS $PINS O=final_s2[0] I1=raw_s2[0] I2=n10
XU12 INV1S $PINS O=n8 I=N4
XU13 INV1S $PINS O=n4 I=n_in[1]
XU15 XNR2HS $PINS O=final_s1[0] I1=raw_s1[0] I2=n10
XU16 MOAI1S $PINS O=fold_n[2] A1=n5 A2=N2 B1=N6 B2=N2
XU17 OA13S $PINS O=N2 A1=n_in[4] B1=n_in[1] B2=N4 B3=n9
XU18 MOAI1 $PINS O=fold_n[3] A1=n6 A2=N2 B1=N7 B2=N2
XU19 INV1S $PINS O=n5 I=n_in[2]
XU21 INV1S $PINS O=n7 I=n_in[4]
XU24 ND3 $PINS O=n11 I1=k_idx[4] I2=k_idx[3] I3=n12
XU25 AN2 $PINS O=n12 I1=k_idx[2] I2=k_idx[1]
XU26 XOR2HS $PINS O=N8 I1=n7 I2=sub_79/carry[4]
XU27 XOR2HS $PINS O=N7 I1=n6 I2=sub_79/carry[3]
XU28 XOR2HS $PINS O=N6 I1=n5 I2=sub_79/carry[2]
XU29 XOR2HS $PINS O=N5 I1=n4 I2=n8
XU30 OR2 $PINS O=n9 I1=n_in[3] I2=n_in[2]
Xrom_inst CSD_ROM_Table_even_1 $PINS n_idx[4]=fold_n[4] n_idx[3]=fold_n[3]
+ n_idx[2]=fold_n[2] n_idx[1]=fold_n[1] n_idx[0]=fold_n[0] k_idx[4]=k_idx[4]
+ k_idx[3]=k_idx[3] k_idx[2]=k_idx[2] k_idx[1]=k_idx[1] k_idx[0]=k_idx[0]
+ sign1[1]=raw_s1[1] sign1[0]=raw_s1[0] shift1[3]=raw_h1[3] shift1[2]=raw_h1[2]
+ shift1[1]=raw_h1[1] shift1[0]=raw_h1[0] sign2[1]=raw_s2[1] sign2[0]=raw_s2[0]
+ shift2[3]=raw_h2[3] shift2[2]=raw_h2[2] shift2[1]=raw_h2[1] shift2[0]=raw_h2[0]
+ sign3[1]=raw_s3[1] sign3[0]=raw_s3[0] shift3[3]=raw_h3[3] shift3[2]=raw_h3[2]
+ shift3[1]=raw_h3[1] shift3[0]=raw_h3[0]
Xclk_gate_reg_shift1_reg SNPS_CLOCK_GATE_HIGH_ROM_Wrapper_Even_1 $PINS EN=en
+ ENCLK=CTS_12 CLK=clk
.ENDS

.SUBCKT CSD_ROM_Table_odd_1 n_idx[4] n_idx[3] n_idx[2] n_idx[1] n_idx[0]
+ k_idx[4] k_idx[3] k_idx[2] k_idx[1] k_idx[0] sign1[1] sign1[0] shift1[3]
+ shift1[2] shift1[1] shift1[0] sign2[1] sign2[0] shift2[3] shift2[2] shift2[1]
+ shift2[0] sign3[1] sign3[0] shift3[3] shift3[2] shift3[1] shift3[0]
+ FE_OFN137_rom_k_idx_3__2
XFE_OFC437_n325 INV1S $PINS O=n65 I=n325
XFE_OFC317_n144 INV1S $PINS O=FE_OFN264_n144 I=n91
XFE_OFC315_n144 INV1S $PINS O=n91 I=n144
XFE_OFC292_n253 INV2 $PINS O=n103 I=n253
XFE_OFC288_fold_n_0 INV1S $PINS O=n620 I=n_idx[0]
XFE_OFC287_n236 INV2 $PINS O=FE_OFN256_n236 I=n236
XFE_OFC274_n195 INV1S $PINS O=FE_OFN252_n195 I=n74
XFE_OFC273_n195 INV1S $PINS O=n74 I=n195
XFE_OFC124_fold_n_4 BUF1 $PINS O=FE_OFN124_fold_n_4 I=n_idx[4]
XU728 ND2 $PINS O=sign3[1] I1=n132 I2=n133
XU729 AO112 $PINS O=n140 A1=n103 B1=n142 C1=n141 C2=n87
XU730 OA222 $PINS O=n136 A1=n145 A2=n146 B1=n147 B2=n148 C1=n149 C2=n150
XU731 AN3B2S $PINS O=n153 I1=n155 B1=n126 B2=n130
XU732 OA222 $PINS O=n135 A1=n165 A2=n166 B1=n167 B2=n168 C1=n169 C2=n170
XU733 OA222 $PINS O=n134 A1=n172 A2=n173 B1=n174 B2=n175 C1=n176 C2=n177
XU736 ND2 $PINS O=n163 I1=n175 I2=n213
XU737 ND2 $PINS O=n247 I1=n248 I2=n234
XU738 ND2 $PINS O=n251 I1=n252 I2=n253
XU739 ND2 $PINS O=n250 I1=n139 I2=n254
XU740 ND2 $PINS O=n256 I1=n257 I2=n62
XU742 OA222 $PINS O=n229 A1=n261 A2=n262 B1=n263 B2=n264 C1=n265 C2=n266
XU743 OA222 $PINS O=n286 A1=n122 A2=n94 B1=n_idx[3] B2=n287 C1=n108 C2=n95
XU744 OA112 $PINS O=n293 A1=n304 B1=n305 C1=n303 C2=n34
XU747 OA222 $PINS O=n333 A1=n334 A2=n175 B1=n335 B2=n266 C1=n336 C2=n262
XU748 AO12 $PINS O=n351 A1=n240 B1=n44 B2=n42
XU749 ND2 $PINS O=n352 I1=n354 I2=n355
XU750 OA112 $PINS O=n343 A1=n364 B1=n365 C1=n173 C2=n28
XU751 AO12 $PINS O=n371 A1=n182 B1=n123 B2=n375
XU752 ND2 $PINS O=n383 I1=n108 I2=n18
XU753 OA222 $PINS O=n396 A1=n401 A2=n254 B1=n402 B2=n161 C1=n403 C2=n262
XU754 OA222 $PINS O=n395 A1=n405 A2=n202 B1=n406 B2=n213 C1=n407 C2=n266
XU755 OA222 $PINS O=n390 A1=n307 A2=n416 B1=n417 B2=n40 C1=n418 C2=n29
XU756 OA112 $PINS O=n434 A1=n435 B1=n436 C1=n188 C2=n41
XU757 ND2 $PINS O=n441 I1=n427 I2=n199
XU758 ND2 $PINS O=n439 I1=n56 I2=n101
XU760 AN3 $PINS O=n276 I1=n444 I2=n445 I3=n446
XU761 OA222 $PINS O=n445 A1=n451 A2=n188 B1=n88 B2=n45 C1=FE_OFN264_n144 C2=n44
XU763 ND2 $PINS O=n431 I1=n4 I2=n317
XU764 ND2 $PINS O=n455 I1=n21 I2=n34
XU765 OA222 $PINS O=n457 A1=n300 A2=n412 B1=n463 B2=n42 C1=n90 C2=n464
XU767 OA222 $PINS O=n456 A1=n199 A2=n45 B1=n466 B2=n271 C1=n47 C2=n259
XU768 OA222 $PINS O=n342 A1=n166 A2=n34 B1=n478 B2=n479 C1=n202 C2=n39
XU769 OA222 $PINS O=n488 A1=n156 A2=n88 B1=n493 B2=n262 C1=n494 C2=n495
XU770 OA222 $PINS O=n487 A1=n496 A2=n266 B1=n497 B2=n264 C1=n498 C2=n213
XU771 OA222 $PINS O=n468 A1=n36 A2=n503 B1=n504 B2=n37 C1=n505 C2=n29
XU772 OA222 $PINS O=n513 A1=n516 A2=n264 B1=n517 B2=n161 C1=n518 C2=n246
XU773 OA222 $PINS O=n511 A1=n44 A2=n237 B1=n199 B2=n49 C1=n47 C2=n236
XU774 OA222 $PINS O=n510 A1=n173 A2=n29 B1=n42 B2=n101 C1=n520 C2=n40
XU776 OR3B2 $PINS O=n529 I1=n532 B1=n533 B2=n534
XU777 AO222 $PINS O=n541 A1=n369 A2=n353 B1=n542 B2=n17 C1=n220 C2=n543
XU778 AO222 $PINS O=n542 A1=n109 A2=n545 B1=n118 B2=n546 C1=n117 C2=n547
XU780 AN3B2S $PINS O=n550 I1=n515 B1=n551 B2=n55
XU781 OA222 $PINS O=n539 A1=n329 A2=n37 B1=n552 B2=n44 C1=n60 C2=n40
XU783 ND2 $PINS O=n523 I1=n562 I2=n563
XU784 ND2 $PINS O=n565 I1=n258 I2=n237
XU785 ND2 $PINS O=n564 I1=n268 I2=n100
XU787 OA112 $PINS O=n341 A1=n569 B1=n570 C1=n478 C2=n355
XU788 AN3B2S $PINS O=n535 I1=n572 B1=n573 B2=n574
XU789 AO222 $PINS O=n588 A1=n118 A2=n589 B1=n113 B2=n96 C1=n117 C2=n590
XU791 OA222 $PINS O=n587 A1=n400 A2=n495 B1=n595 B2=n213 C1=n596 C2=n262
XU793 OA222 $PINS O=n582 A1=n200 A2=n32 B1=n601 B2=n602 C1=n603 C2=n33
XU794 OA222 $PINS O=n581 A1=n604 A2=n37 B1=n59 B2=n42 C1=n605 C2=n40
XU795 OA112 $PINS O=n578 A1=n274 B1=n609 C1=n41 C2=n495
XU797 ND2 $PINS O=n561 I1=n612 I2=n613
XU798 ND2 $PINS O=n615 I1=n224 I2=n188
XU799 OA112 $PINS O=n472 A1=n527 B1=n617 C1=n152 C2=n28
XU801 ND2 $PINS O=n571 I1=n623 I2=n624
XU802 OA222 $PINS O=n624 A1=n216 A2=n224 B1=n625 B2=n452 C1=n626 C2=n361
XU806 ND2 $PINS O=n639 I1=n42 I2=n464
XU807 AN3B2S $PINS O=n633 I1=n641 B1=n642 B2=n531
XU808 OA112 $PINS O=n645 A1=n556 B1=n646 C1=n152 C2=n29
XU810 OA222 $PINS O=n657 A1=n625 A2=n224 B1=n452 B2=n478 C1=n515 C2=n40
XU811 OA112 $PINS O=n686 A1=n688 B1=n689 C1=n687 C2=n51
XU812 ND2 $PINS O=n464 I1=n118 I2=n17
XU813 ND2 $PINS O=n690 I1=n37 I2=n300
XU814 ND2 $PINS O=n300 I1=n117 I2=n17
XU815 OA112 $PINS O=n533 A1=n693 B1=n694 C1=n152 C2=n35
XU816 AN3 $PINS O=n471 I1=n696 I2=n697 I3=n698
XU817 OA112 $PINS O=n698 A1=n43 B1=n699 C1=n566 C2=n271
XU818 OA222 $PINS O=n705 A1=FE_OFN124_fold_n_4 A2=n708 B1=n709 B2=n51 C1=n478
+ C2=n224
XU819 ND2 $PINS O=n478 I1=n147 I2=n710
XU820 OA222 $PINS O=n708 A1=n53 A2=n264 B1=n711 B2=n246 C1=n712 C2=n161
XU823 ND2 $PINS O=n519 I1=n248 I2=n237
XU824 AO222 $PINS O=n717 A1=n411 A2=n358 B1=n721 B2=n467 C1=n722 C2=n440
XU825 AN3B2S $PINS O=n700 I1=n534 B1=n726 B2=n727
XU826 OR3B2 $PINS O=n726 I1=n574 B1=n650 B2=n728
XU827 OA112 $PINS O=n735 A1=n736 B1=n737 C1=n152 C2=n26
XU828 ND2 $PINS O=n738 I1=n237 I2=n465
XU832 OA222 $PINS O=n729 A1=n648 A2=n26 B1=n199 B2=n45 C1=n610 C2=n503
XU835 ND2 $PINS O=n756 I1=n720 I2=n35
XU836 OA222 $PINS O=n752 A1=n408 A2=n48 B1=n759 B2=n36 C1=n501 C2=n46
XU837 ND2 $PINS O=n761 I1=n129 I2=n710
XU838 ND2 $PINS O=n760 I1=n308 I2=n762
XU839 OR3 $PINS O=n545 I1=n270 I2=n97 I3=n67
XU841 AO222 $PINS O=n767 A1=n114 A2=n770 B1=n115 B2=n771 C1=n116 C2=n772
XU842 AN3B2S $PINS O=n600 I1=n664 B1=n63 B2=n66
XU843 OA222 $PINS O=n765 A1=n664 A2=n177 B1=n773 B2=n774 C1=n775 C2=n254
XU845 AN3 $PINS O=n504 I1=n240 I2=n74 I3=n494
XU846 AO222 $PINS O=n780 A1=n779 A2=n483 B1=n782 B2=n297 C1=n783 C2=n424
XU847 OR3 $PINS O=n779 I1=n783 I2=n326 I3=n98
XU848 AN3B2S $PINS O=n605 I1=n724 B1=n670 B2=n76
XU850 OA222 $PINS O=n628 A1=n26 A2=n505 B1=n521 B2=n33 C1=n254 C2=n41
XU853 AO12 $PINS O=n795 A1=n40 B1=n553 B2=n325
XU854 OA222 $PINS O=n793 A1=n307 A2=n296 B1=n801 B2=n503 C1=FE_OFN124_fold_n_4
+ C2=n802
XU855 OA222 $PINS O=n802 A1=n803 A2=n264 B1=n804 B2=n246 C1=n805 C2=n161
XU858 OA222 $PINS O=n791 A1=n807 A2=n49 B1=n54 B2=n51 C1=n808 C2=n38
XU859 ND2 $PINS O=n419 I1=n408 I2=FE_OFN264_n144
XU860 ND2 $PINS O=n298 I1=n90 I2=n237
XU861 AN3 $PINS O=n728 I1=n821 I2=n822 I3=n823
XU862 OA112 $PINS O=n823 A1=n627 B1=n824 C1=n188 C2=n26
XU865 AN3 $PINS O=n673 I1=n825 I2=n826 I3=n827
XU866 OA222 $PINS O=n829 A1=n832 A2=n26 B1=n833 B2=n48 C1=n834 C2=n46
XU867 ND2 $PINS O=n421 I1=n521 I2=n835
XU868 ND2 $PINS O=n836 I1=n428 I2=n35
XU870 ND2 $PINS O=n840 I1=n218 I2=n3
XU871 ND2 $PINS O=n159 I1=n246 I2=n495
XU872 ND2 $PINS O=n862 I1=n485 I2=n252
XU874 OR3 $PINS O=n846 I1=n652 I2=n530 I3=n863
XU875 OA112 $PINS O=n866 A1=n274 B1=n692 C1=n166 C2=n26
XU876 OA13S $PINS O=n865 A1=n688 B1=n591 B2=FE_OFN124_fold_n_4 B3=n161
XU877 ND2 $PINS O=n503 I1=n867 I2=n384
XU878 OA222 $PINS O=n475 A1=n39 A2=n262 B1=n224 B2=n29 C1=n210 C2=n21
XU879 ND2 $PINS O=n210 I1=n873 I2=n874
XU881 OA222 $PINS O=n869 A1=n56 A2=n49 B1=n404 B2=n44 C1=n51 C2=n253
XU882 OA222 $PINS O=n868 A1=n237 A2=n40 B1=n47 B2=n88 C1=n356 C2=n42
XU883 OA222 $PINS O=n843 A1=n363 A2=n355 B1=n200 B2=n26 C1=n216 C2=n152
XU885 ND2 $PINS O=n139 I1=n385 I2=n888
XU889 ND2 $PINS O=n254 I1=n892 I2=n372
XU890 OA222 $PINS O=n883 A1=n893 A2=n45 B1=n894 B2=n46 C1=n47 C2=n253
XU891 ND2 $PINS O=n177 I1=n892 I2=n895
XU893 ND2 $PINS O=n175 I1=n385 I2=n895
XU894 OR3 $PINS O=n896 I1=n260 I2=n85 I3=n340
XU898 ND2 $PINS O=n495 I1=n875 I2=n385
XU899 OR3B2 $PINS O=n902 I1=n837 B1=n302 B2=n903
XU900 ND2 $PINS O=n878 I1=n194 I2=n904
XU901 ND2 $PINS O=n837 I1=n758 I2=n366
XU902 ND2 $PINS O=n366 I1=n194 I2=n61
XU905 ND2 $PINS O=n226 I1=n374 I2=n_idx[4]
XU907 ND2 $PINS O=n863 I1=n905 I2=n906
XU908 ND2 $PINS O=n611 I1=n384 I2=n888
XU909 ND2 $PINS O=n551 I1=n430 I2=n101
XU914 ND2 $PINS O=n916 I1=n724 I2=n253
XU920 OA222 $PINS O=n908 A1=n920 A2=n835 B1=n921 B2=n21 C1=n922 C2=n28
XU921 ND2 $PINS O=n189 I1=n891 I2=n384
XU922 ND2 $PINS O=n215 I1=n923 I2=n384
XU923 ND2 $PINS O=n835 I1=n895 I2=n874
XU924 ND2 $PINS O=n648 I1=n372 I2=n384
XU925 ND2 $PINS O=n479 I1=n875 I2=n384
XU927 ND2 $PINS O=n150 I1=n892 I2=n888
XU930 ND2 $PINS O=n452 I1=n867 I2=n874
XU934 ND2 $PINS O=n162 I1=n867 I2=n385
XU936 ND2 $PINS O=n930 I1=n147 I2=n762
XU937 AN3 $PINS O=n932 I1=n73 I2=n171 I3=n198
XU938 ND2 $PINS O=n355 I1=n874 I2=n888
XU939 ND2 $PINS O=n283 I1=k_idx[4] I2=k_idx[3]
XU948 ND2 $PINS O=n412 I1=n193 I2=n285
XU949 ND2 $PINS O=n266 I1=n873 I2=n892
XU950 ND2 $PINS O=n160 I1=n875 I2=n892
XU951 ND2 $PINS O=n376 I1=k_idx[4] I2=n19
XU952 ND2 $PINS O=n505 I1=n873 I2=n384
XU953 ND2 $PINS O=n173 I1=n384 I2=n895
XU3 AN4B1S $PINS O=n599 I1=n267 I2=n679 I3=n330 B1=n338
XU4 NR2P $PINS O=n15 I1=n36 I2=n171
XU5 OAI222S $PINS O=n8 A1=n44 A2=n629 B1=n49 B2=n631 C1=n707 C2=n188
XU6 AOI13HS $PINS O=n382 A1=n179 B1=n_idx[1] B2=n_idx[3] B3=n384
XU7 AN4B1S $PINS O=n336 I1=n591 I2=n408 I3=n316 B1=n593
XU8 AN4B1S $PINS O=n151 I1=n189 I2=n452 I3=n197 B1=n308
XU9 INV1S $PINS O=n106 I=n_idx[2]
XU10 NR2 $PINS O=n426 I1=n105 I2=n103
XU11 NR2 $PINS O=n526 I1=n74 I2=FE_OFN124_fold_n_4
XU12 NR2 $PINS O=n408 I1=n80 I2=FE_OFN256_n236
XU13 ND2 $PINS O=n253 I1=n918 I2=n897
XU14 NR2 $PINS O=n3 I1=n36 I2=n168
XU15 NR2 $PINS O=n147 I1=n620 I2=FE_OFN124_fold_n_4
XU16 NR2 $PINS O=n144 I1=n338 I2=n104
XU17 INV1S $PINS O=n105 I=n259
XU19 INV1S $PINS O=n107 I=n_idx[1]
XU20 NR2 $PINS O=n285 I1=n106 I2=n87
XU21 NR2 $PINS O=n179 I1=n78 I2=n107
XU22 NR2 $PINS O=n195 I1=n77 I2=n620
XU23 INV1S $PINS O=n17 I=FE_OFN124_fold_n_4
XU24 INV1S $PINS O=n58 I=n500
XU25 INV1S $PINS O=n64 I=n271
XU26 ND2S $PINS O=n180 I1=n258 I2=n465
XU27 ND2S $PINS O=n143 I1=n193 I2=n897
XU28 NR2 $PINS O=n608 I1=n36 I2=n92
XU29 NR2 $PINS O=n362 I1=n36 I2=n73
XU30 ND2S $PINS O=n798 I1=n800 I2=n272
XU31 ND2S $PINS O=n353 I1=n21 I2=n35
XU32 ND3S $PINS O=n522 I1=n476 I2=n527 I3=n528
XU33 ND2S $PINS O=n270 I1=n301 I2=n252
XU34 ND2S $PINS O=n670 I1=n325 I2=n90
XU35 ND2S $PINS O=n225 I1=n720 I2=n26
XU36 ND3S $PINS O=n606 I1=n713 I2=n500 I3=n607
XU37 ND2S $PINS O=n442 I1=n211 I2=n33
XU38 NR2 $PINS O=n1 I1=n36 I2=n77
XU39 ND2S $PINS O=n787 I1=n601 I2=n302
XU40 ND2S $PINS O=n640 I1=n28 I2=n29
XU41 ND3S $PINS O=n546 I1=n492 I2=n325 I3=n549
XU42 OA222S $PINS O=n540 A1=n45 A2=n90 B1=n312 B2=n38 C1=n550 C2=n49
XU43 OR3S $PINS O=n9 I1=n621 I2=n571 I3=n622
XU44 OA222S $PINS O=n739 A1=n50 A2=n56 B1=n45 B2=n100 C1=n139 C2=n41
XU45 AN3S $PINS O=n758 I1=n226 I2=n41 I3=n707
XU46 ND3S $PINS O=n757 I1=n451 I2=n39 I3=n758
XU47 OR2S $PINS O=n275 I1=n41 I2=n139
XU48 AN2S $PINS O=n364 I1=n453 I2=n454
XU49 ND2S $PINS O=n339 I1=n324 I2=n267
XU50 ND3S $PINS O=n409 I1=n629 I2=n713 I3=n714
XU51 OA22S $PINS O=n391 A1=n28 A2=n414 B1=n33 B2=n415
XU52 NR2 $PINS O=n2 I1=n36 I2=n94
XU53 OA22S $PINS O=n685 A1=n26 A2=n155 B1=n38 B2=n88
XU54 OA222S $PINS O=n792 A1=n155 A2=n34 B1=n806 B2=n45 C1=n414 C2=n29
XU55 OA22S $PINS O=n558 A1=n101 A2=n566 B1=n29 B2=n414
XU56 ND3S $PINS O=n817 I1=n100 I2=n412 I3=n426
XU57 ND3S $PINS O=n721 I1=n501 I2=n597 I3=n500
XU58 ND2S $PINS O=n304 I1=n608 I2=n308
XU59 ND2S $PINS O=n569 I1=n614 I2=n608
XU60 ND3S $PINS O=n890 I1=n240 I2=n412 I3=n548
XU61 ND3S $PINS O=n889 I1=n591 I2=n408 I3=n502
XU62 OA22S $PINS O=n347 A1=n50 A2=n273 B1=n48 B2=n356
XU63 ND3S $PINS O=n410 I1=n412 I2=n356 I3=n100
XU64 ND2S $PINS O=n799 I1=n235 I2=n356
XU65 ND3S $PINS O=shift3[2] I1=n468 I2=n469 I3=n470
XU66 OA112S $PINS O=n732 A1=n435 B1=n739 C1=n33 C2=n505
XU67 ND3S $PINS O=shift1[1] I1=n843 I2=n844 I3=n845
XU68 OA222S $PINS O=n675 A1=n361 A2=n33 B1=n101 B2=n40 C1=n41 C2=n246
XU69 OA22S $PINS O=n365 A1=n366 A2=n188 B1=n41 B2=n150
XU70 ND3S $PINS O=shift3[3] I1=n456 I2=n457 I3=n458
XU71 ND3S $PINS O=shift1[3] I1=n748 I2=n749 I3=n750
XU72 OA222S $PINS O=n586 A1=n598 A2=n161 B1=n599 B2=n266 C1=n600 C2=n202
XU73 OA222S $PINS O=n534 A1=n648 A2=n33 B1=n747 B2=n38 C1=n41 C2=n160
XU74 NR2 $PINS O=n4 I1=n36 I2=n170
XU75 OA222S $PINS O=n623 A1=n21 A2=n479 B1=n50 B2=n412 C1=n188 C2=n226
XU76 OA222S $PINS O=n444 A1=n28 A2=n361 B1=n50 B2=n56 C1=n452 C2=n33
XU77 OA222S $PINS O=n556 A1=n42 A2=n143 B1=n47 B2=n56 C1=n611 C2=n33
XU78 ND3S $PINS O=n589 I1=FE_OFN264_n144 I2=n259 I3=n594
XU79 ND3S $PINS O=n484 I1=n325 I2=n201 I3=n485
XU80 MAOI1S $PINS O=n294 A1=n131 A2=n299 B1=n300 B2=n301
XU81 ND3S $PINS O=n299 I1=n33 I2=n29 I3=n302
XU82 OA222S $PINS O=n609 A1=n307 A2=n479 B1=n610 B2=n503 C1=n525 C2=n611
XU83 ND3S $PINS O=n337 I1=n330 I2=n143 I3=n809
XU84 ND2S $PINS O=n465 I1=n141 I2=n285
XU85 OA112S $PINS O=n555 A1=n341 B1=n460 C1=n33 C2=n215
XU86 ND3S $PINS O=n238 I1=n239 I2=FE_OFN264_n144 I3=n240
XU87 OA222S $PINS O=n704 A1=n211 A2=n355 B1=n715 B2=n29 C1=n716 C2=n37
XU88 OA222S $PINS O=n703 A1=n38 A2=n143 B1=n306 B2=n21 C1=n301 C2=n40
XU89 OA222S $PINS O=n538 A1=n166 A2=n21 B1=n189 B2=n29 C1=n26 C2=n224
XU90 AO12S $PINS O=n305 A1=n307 B1=n173 B2=n306
XU91 MAOI1S $PINS O=n689 A1=n83 A2=n690 B1=n464 B2=n691
XU92 ND3S $PINS O=n328 I1=n329 I2=n74 I3=FE_OFN264_n144
XU93 ND3S $PINS O=n425 I1=n426 I2=n234 I3=n427
XU94 OA22S $PINS O=n872 A1=n49 A2=n806 B1=n44 B2=n356
XU95 OA222S $PINS O=n509 A1=n521 A2=n307 B1=n166 B2=n34 C1=n189 C2=n32
XU96 ND2S $PINS O=n260 I1=n56 I2=n259
XU97 ND3S $PINS O=n662 I1=n272 I2=n267 I3=n401
XU98 ND3S $PINS O=n814 I1=n259 I2=n465 I3=n500
XU99 NR2 $PINS O=n5 I1=n198 I2=n620
XU100 ND3S $PINS O=n249 I1=n56 I2=n143 I3=n408
XU101 NR2 $PINS O=n6 I1=n139 I2=FE_OFN124_fold_n_4
XU102 OA222S $PINS O=n183 A1=n199 A2=n162 B1=n200 B2=n77 C1=n201 C2=n202
XU103 ND2S $PINS O=n255 I1=n258 I2=n259
XU104 OA222S $PINS O=n649 A1=n37 A2=n90 B1=n38 B2=n412 C1=n202 C2=n39
XU105 ND2S $PINS O=n661 I1=n259 I2=n88
XU106 ND2S $PINS O=n861 I1=n259 I2=n101
XU107 ND2S $PINS O=n707 I1=n194 I2=n179
XU108 ND3S $PINS O=n710 I1=n170 I2=n92 I3=n171
XU109 ND2S $PINS O=n917 I1=n356 I2=n236
XU110 OA22S $PINS O=n856 A1=n329 A2=n162 B1=n356 B2=n213
XU111 ND2S $PINS O=n309 I1=n271 I2=n465
XU112 OA222S $PINS O=n184 A1=n196 A2=n94 B1=n197 B2=n78 C1=n155 C2=n198
XU113 OR2S $PINS O=n192 I1=n193 I2=n194
XU114 ND2 $PINS O=n236 I1=n193 I2=n919
XU115 ND3S $PINS O=n547 I1=n500 I2=n252 I3=n548
XU116 ND3S $PINS O=n543 I1=n143 I2=n356 I3=n544
XU117 ND2S $PINS O=n199 I1=n375 I2=n193
XU118 ND2S $PINS O=n168 I1=n_idx[1] I2=n919
XU119 ND2S $PINS O=n170 I1=n919 I2=n107
XU120 ND2S $PINS O=n198 I1=n897 I2=n_idx[1]
XU121 ND2S $PINS O=n171 I1=n897 I2=n107
XU122 ND2S $PINS O=n237 I1=n918 I2=n919
XU123 ND3S $PINS O=n142 I1=n95 I2=n17 I3=n143
XU124 ND2S $PINS O=n329 I1=n918 I2=n375
XU125 NR2 $PINS O=n874 I1=n630 I2=k_idx[0]
XU126 NR2 $PINS O=n610 I1=n30 I2=n23
XU127 INV1S $PINS O=n23 I=n720
XU128 NR2 $PINS O=n301 I1=n58 I2=n91
XU129 NR2 $PINS O=n272 I1=n76 I2=n96
XU130 NR2 $PINS O=n597 I1=n68 I2=n82
XU131 INV1S $PINS O=n82 I=n312
XU132 INV1S $PINS O=n34 I=n1
XU133 INV1S $PINS O=n84 I=n330
XU134 INV1S $PINS O=n30 I=n601
XU135 NR2 $PINS O=n800 I1=n71 I2=n58
XU136 NR2 $PINS O=n720 I1=n24 I2=n1
XU137 INV1S $PINS O=n29 I=n608
XU138 NR2 $PINS O=n596 I1=n96 I2=n63
XU139 NR2 $PINS O=n515 I1=n102 I2=n82
XU140 AN2 $PINS O=n598 I1=n491 I2=n235
XU141 INV1S $PINS O=n102 I=n426
XU142 INV1S $PINS O=n66 I=n679
XU143 NR2 $PINS O=n496 I1=n339 I2=n84
XU144 INV1S $PINS O=n68 I=n408
XU145 INV1S $PINS O=n67 I=n713
XU148 NR2 $PINS O=n494 I1=n65 I2=n80
XU149 INV1S $PINS O=n76 I=n201
XU150 INV1S $PINS O=n25 I=n367
XU151 NR2 $PINS O=n312 I1=n83 I2=n86
XU152 NR2 $PINS O=n594 I1=n606 I2=n83
XU153 AN2 $PINS O=n595 I1=n544 I2=n597
XU154 INV1S $PINS O=n53 I=n409
XU155 INV1S $PINS O=n57 I=n234
XU156 NR2 $PINS O=n330 I1=n96 I2=n86
XU157 INV1S $PINS O=n96 I=n747
XU158 INV1S $PINS O=n75 I=n671
XU159 NR2 $PINS O=n601 I1=n31 I2=n2
XU160 INV1S $PINS O=n31 I=n307
XU161 INV1S $PINS O=n97 I=n316
XU162 INV1S $PINS O=n63 I=n485
XU163 INV1S $PINS O=n24 I=n451
XU164 INV1S $PINS O=n21 I=n362
XU165 ND3 $PINS O=n315 I1=n101 I2=n74 I3=n316
XU166 NR2 $PINS O=n427 I1=n68 I2=n86
XU167 INV1S $PINS O=n85 I=n252
XU168 INV1S $PINS O=n71 I=n235
XU169 NR2 $PINS O=n501 I1=n89 I2=n102
XU170 INV1S $PINS O=n70 I=n492
XU171 AN2 $PINS O=n525 I1=n428 I2=n216
XU172 INV1S $PINS O=n79 I=n401
XU173 INV1S $PINS O=n22 I=n428
XU174 INV1S $PINS O=n35 I=n2
XU175 INV1S $PINS O=n43 I=n743
XU176 INV1S $PINS O=n81 I=n248
XU177 INV1S $PINS O=n27 I=n302
XU178 ND3 $PINS O=n573 I1=n528 I2=n575 I3=n576
XU179 ND3 $PINS O=n349 I1=n350 I2=n43 I3=n351
XU180 OAI112HS $PINS O=n754 A1=n304 B1=n43 C1=n601 C2=n755
XU181 NR2 $PINS O=n755 I1=n124 I2=n126
XU182 INV1S $PINS O=n130 I=n196
XU183 INV1S $PINS O=n126 I=n521
XU184 INV1S $PINS O=n124 I=n197
XU185 INV1S $PINS O=n128 I=n415
XU186 INV1S $PINS O=n219 I=n200
XU188 OAI112HS $PINS O=n621 A1=n627 B1=n628 C1=n50 C2=n356
XU189 INV1S $PINS O=n77 I=n179
XU190 NR3 $PINS O=n527 I1=n7 I2=n8 I3=n9
XU191 OAI222S $PINS O=n7 A1=n324 A2=n45 B1=n48 B2=n465 C1=n316 C2=n46
XU192 INV1S $PINS O=n41 I=n526
XU193 NR2 $PINS O=n500 I1=n326 I2=n64
XU194 NR3 $PINS O=n491 I1=n99 I2=n83 I3=n545
XU195 ND3 $PINS O=shift2[3] I1=n577 I2=n578 I3=n579
XU196 AN4B1S $PINS O=n577 I1=n472 I2=n459 I3=n572 B1=n561
XU197 AN4B1S $PINS O=n579 I1=n580 I2=n581 I3=n582 B1=n583
XU198 NR2 $PINS O=n325 I1=n66 I2=n104
XU199 AOI22S $PINS O=n764 A1=n112 A2=n778 B1=n118 B2=n779
XU200 ND3 $PINS O=n778 I1=n252 I2=n56 I3=n504
XU201 NR2 $PINS O=n679 I1=n102 I2=FE_OFN256_n236
XU202 ND3 $PINS O=shift2[0] I1=n700 I2=n701 I3=n702
XU203 NR2 $PINS O=n701 I1=n717 I2=n718
XU204 AN4B1S $PINS O=n702 I1=n703 I2=n704 I3=n705 B1=n706
XU205 AN4B1S $PINS O=n906 I1=n907 I2=n908 I3=n909 B1=n910
XU206 NR3 $PINS O=n905 I1=n924 I2=n925 I3=n926
XU207 OA22 $PINS O=n907 A1=n32 A2=n886 B1=n29 B2=n715
XU208 ND3 $PINS O=n924 I1=n641 I2=n675 I3=n927
XU209 AOI22S $PINS O=n927 A1=n2 A2=n420 B1=n109 B2=n526
XU210 AOI22S $PINS O=n828 A1=n413 A2=n836 B1=n111 B2=n837
XU211 NR2 $PINS O=n826 I1=n838 I2=n839
XU212 AN4B1S $PINS O=n825 I1=n454 I2=n840 I3=n841 B1=n616
XU213 AN4B1S $PINS O=n827 I1=n828 I2=n829 I3=n830 B1=n831
XU214 ND3 $PINS O=shift2[1] I1=n653 I2=n654 I3=n655
XU215 AN4B1S $PINS O=n655 I1=n656 I2=n657 I3=n658 B1=n659
XU216 NR2 $PINS O=n654 I1=n666 I2=n667
XU217 AN4B1S $PINS O=n653 I1=n672 I2=n673 I3=n651 B1=n462
XU218 ND3 $PINS O=shift3[1] I1=n506 I2=n507 I3=n508
XU219 AN4B1S $PINS O=n508 I1=n509 I2=n510 I3=n511 B1=n512
XU220 NR3 $PINS O=n506 I1=n529 I2=n530 I3=n531
XU221 NR3 $PINS O=n507 I1=n522 I2=n523 I3=n524
XU222 ND3 $PINS O=shift1[2] I1=n788 I2=n789 I3=n790
XU223 NR3 $PINS O=n789 I1=n810 I2=n811 I3=n812
XU224 AN4B1S $PINS O=n790 I1=n791 I2=n792 I3=n793 B1=n794
XU225 AN4B1S $PINS O=n788 I1=n673 I2=n818 I3=n728 B1=n819
XU226 NR2 $PINS O=n713 I1=n68 I2=FE_OFN252_n195
XU227 INV1S $PINS O=n80 I=n412
XU228 ND3 $PINS O=n771 I1=n599 I2=n88 I3=n776
XU229 NR2 $PINS O=n776 I1=n83 I2=n80
XU230 NR2 $PINS O=n591 I1=n58 I2=n104
XU231 NR3 $PINS O=n773 I1=n771 I2=FE_OFN252_n195 I3=n104
XU232 AN4B1S $PINS O=n388 I1=n389 I2=n390 I3=n391 B1=n392
XU233 AOI22S $PINS O=n389 A1=n6 A2=n419 B1=n2 B2=n421
XU234 INV1S $PINS O=n92 I=n191
XU235 ND3 $PINS O=shift1[0] I1=n879 I2=n880 I3=n881
XU236 AN4B1S $PINS O=n881 I1=n882 I2=n883 I3=n884 B1=n885
XU237 NR2 $PINS O=n880 I1=n900 I2=n901
XU238 AN4B1S $PINS O=n879 I1=n841 I2=n649 I3=n785 B1=n863
XU239 NR2 $PINS O=n201 I1=n82 I2=FE_OFN252_n195
XU240 NR2 $PINS O=n234 I1=n58 I2=n99
XU241 AN4B1S $PINS O=n230 I1=n241 I2=n242 I3=n243 B1=n244
XU242 AOI22S $PINS O=n243 A1=n72 A2=n250 B1=n119 B2=n251
XU243 AOI22S $PINS O=n242 A1=n110 A2=n255 B1=n120 B2=n256
XU244 AOI22S $PINS O=n241 A1=n112 A2=n260 B1=n99 B2=n159
XU245 NR2 $PINS O=n714 I1=n103 I2=n55
XU246 AN4B1S $PINS O=n804 I1=n331 I2=n301 I3=n356 B1=n72
XU247 INV1S $PINS O=n55 I=n499
XU248 AN4B1S $PINS O=n803 I1=n806 I2=n301 I3=n465 B1=n80
XU249 ND3 $PINS O=n367 I1=n432 I2=n433 I3=n434
XU250 MAOI1 $PINS O=n432 A1=n592 A2=n442 B1=n363 B2=n443
XU251 AOI22S $PINS O=n433 A1=n438 A2=n439 B1=n440 B2=n441
XU252 AOI12HS $PINS O=n459 A1=n616 B1=n15 B2=n420
XU253 AOI22S $PINS O=n454 A1=n308 A2=n437 B1=n526 B2=n121
XU254 AOI22S $PINS O=n453 A1=n413 A2=n455 B1=n6 B2=n81
XU255 INV1S $PINS O=n86 I=n465
XU256 INV1S $PINS O=n56 I=n326
XU257 NR2 $PINS O=n417 I1=n98 I2=n270
XU258 ND3 $PINS O=n411 I1=n499 I2=n273 I3=n725
XU259 NR2 $PINS O=n725 I1=n85 I2=n58
XU260 AOI22S $PINS O=n753 A1=n129 A2=n756 B1=n111 B2=n757
XU261 INV1S $PINS O=n59 I=n606
XU262 AN4B1S $PINS O=n604 I1=n607 I2=n494 I3=n74 B1=n64
XU263 ND3 $PINS O=n462 I1=n674 I2=n675 I3=n676
XU264 AOI22S $PINS O=n674 A1=n618 A2=n22 B1=n608 B2=n619
XU265 NR2 $PINS O=n676 I1=n677 I2=n678
XU266 MOAI1S $PINS O=n678 A1=n679 A2=n38 B1=FE_OFN256_n236 B2=n220
XU267 INV1S $PINS O=n39 I=n212
XU268 INV1S $PINS O=n83 I=n356
XU269 NR3 $PINS O=n322 I1=n327 I2=n80 I3=n72
XU270 NR2 $PINS O=n553 I1=n76 I2=n326
XU271 ND3 $PINS O=n327 I1=n273 I2=n553 I3=n554
XU272 NR2 $PINS O=n554 I1=n104 I2=n99
XU273 NR3 $PINS O=n544 I1=n55 I2=n96 I3=n260
XU274 ND3 $PINS O=shift2[2] I1=n632 I2=n633 I3=n634
XU275 AN4B1S $PINS O=n634 I1=n635 I2=n636 I3=n637 B1=n638
XU276 AN4B1S $PINS O=n632 I1=n649 I2=n650 I3=n651 B1=n652
XU277 NR2 $PINS O=n216 I1=n15 I2=n1
XU278 NR2 $PINS O=n493 I1=n338 I2=n326
XU279 NR2 $PINS O=n430 I1=n91 I2=n326
XU280 NR2 $PINS O=n625 I1=n4 I2=n1
XU281 AN4B1S $PINS O=n323 I1=n324 I2=n178 I3=n325 B1=n75
XU282 NR2 $PINS O=n400 I1=n68 I2=n64
XU283 NR2 $PINS O=n747 I1=n98 I2=n5
XU284 NR2 $PINS O=n671 I1=FE_OFN252_n195 I2=n98
XU285 OA12 $PINS O=n820 A1=n575 B1=n39 B2=n175
XU286 NR2 $PINS O=n307 I1=n15 I2=n608
XU287 NR2 $PINS O=n252 I1=n5 I2=n86
XU288 NR2 $PINS O=n724 I1=n99 I2=n5
XU289 AOI22S $PINS O=n460 A1=n119 A2=n526 B1=n96 B2=n358
XU290 AOI22S $PINS O=n824 A1=n104 A2=n6 B1=n614 B2=n30
XU291 AOI22S $PINS O=n821 A1=n438 A2=n82 B1=n326 B2=n568
XU292 AOI22S $PINS O=n822 A1=n357 A2=n661 B1=n125 B2=n640
XU293 AN4B1S $PINS O=n473 I1=n475 I2=n476 I3=n342 B1=n477
XU294 INV1S $PINS O=n100 I=n340
XU295 NR2 $PINS O=n316 I1=n105 I2=n98
XU296 AOI22S $PINS O=n737 A1=n340 A2=n357 B1=n568 B2=n102
XU297 INV1S $PINS O=n33 I=n3
XU298 NR3 $PINS O=n548 I1=n102 I2=FE_OFN252_n195 I3=n55
XU299 NR2 $PINS O=n485 I1=n338 I2=n64
XU300 NR2 $PINS O=n451 I1=n3 I2=n362
XU301 NR2 $PINS O=n664 I1=n96 I2=n340
XU302 INV1S $PINS O=n90 I=n338
XU303 NR2 $PINS O=n607 I1=n85 I2=n72
XU304 AOI22S $PINS O=n650 A1=n110 A2=n526 B1=n98 B2=n483
XU305 INV1S $PINS O=n26 I=n4
XU306 NR2 $PINS O=n258 I1=n326 I2=n80
XU307 OAI22S $PINS O=n811 A1=n815 A2=n44 B1=n816 B2=n47
XU308 NR3 $PINS O=n816 I1=n817 I2=n84 I3=n63
XU309 AN4B1S $PINS O=n815 I1=n234 I2=n101 I3=n713 B1=n298
XU310 OAI112HS $PINS O=n885 A1=n887 B1=n569 C1=n886 C2=n21
XU311 OAI12HS $PINS O=n887 A1=n6 B1=n670 B2=n180
XU312 AOI22S $PINS O=n736 A1=n619 A2=n3 B1=n111 B2=n362
XU313 NR2 $PINS O=n235 I1=n103 I2=n72
XU314 NR2 $PINS O=n404 I1=n71 I2=n104
XU315 NR2 $PINS O=n331 I1=n105 I2=n80
XU316 NR2 $PINS O=n629 I1=n326 I2=n86
XU317 MOAI1S $PINS O=n876 A1=n196 A2=n28 B1=n526 B2=n164
XU318 AOI22S $PINS O=n680 A1=n98 A2=n117 B1=n109 B2=n71
XU319 INV1S $PINS O=n36 I=n147
XU320 ND3 $PINS O=n722 I1=n723 I2=n331 I3=n724
XU321 NR3 $PINS O=n723 I1=n91 I2=n64 I3=n70
XU322 AOI22S $PINS O=n641 A1=n212 A2=n117 B1=n483 B2=n80
XU323 AOI22S $PINS O=n695 A1=n483 A2=n58 B1=n5 B2=n6
XU324 NR3 $PINS O=n518 I1=n519 I2=n105 I3=n249
XU325 ND3 $PINS O=n794 I1=n795 I2=n796 I3=n797
XU326 ND3 $PINS O=n796 I1=n147 I2=n762 I3=n618
XU327 AOI22S $PINS O=n797 A1=n424 A2=n798 B1=n6 B2=n799
XU328 NR2 $PINS O=n626 I1=n437 I2=n2
XU329 AOI22S $PINS O=n884 A1=n438 A2=n889 B1=n467 B2=n890
XU330 INV1S $PINS O=n89 I=n324
XU331 NR2 $PINS O=n268 I1=n338 I2=n103
XU332 NR2 $PINS O=n492 I1=n82 I2=n72
XU333 NR2 $PINS O=n775 I1=n326 I2=n70
XU334 AN4B1S $PINS O=n516 I1=n88 I2=n273 I3=n430 B1=n85
XU335 AOI22S $PINS O=n672 A1=n127 A2=n362 B1=n115 B2=n526
XU336 MOAI1S $PINS O=n910 A1=n26 A2=n354 B1=n424 B2=n249
XU337 MOAI1S $PINS O=n781 A1=n594 A2=n50 B1=n592 B2=n225
XU338 AOI22S $PINS O=n575 A1=n221 A2=n3 B1=n131 B2=n15
XU339 INV1S $PINS O=n62 I=n567
XU340 NR2 $PINS O=n832 I1=n130 I2=n421
XU341 NR2 $PINS O=n833 I1=n64 I2=n5
XU342 AN2 $PINS O=n834 I1=n62 I2=n549
XU343 INV1S $PINS O=n48 I=n438
XU344 OAI22S $PINS O=n742 A1=n745 A2=n28 B1=n746 B2=n37
XU345 NR2 $PINS O=n745 I1=n370 I2=n219
XU346 NR2 $PINS O=n746 I1=n81 I2=n79
XU347 NR2 $PINS O=n401 I1=n104 I2=n80
XU348 NR2 $PINS O=n248 I1=n83 I2=n5
XU349 INV1S $PINS O=n50 I=n6
XU350 AOI22S $PINS O=n830 A1=n568 A2=n97 B1=n131 B2=n24
XU351 INV1S $PINS O=n101 I=n5
XU352 AOI22S $PINS O=n627 A1=n420 A2=n3 B1=n413 B2=n15
XU353 INV1S $PINS O=n45 I=n568
XU354 NR2 $PINS O=n428 I1=n437 I2=n362
XU355 AOI22S $PINS O=n692 A1=n437 A2=n614 B1=n1 B2=n218
XU356 NR2 $PINS O=n257 I1=n103 I2=n340
XU357 NR2 $PINS O=n239 I1=n99 I2=n105
XU358 NR2 $PINS O=n363 I1=n3 I2=n2
XU359 INV1S $PINS O=n20 I=n571
XU360 NR2 $PINS O=n302 I1=n437 I2=n4
XU361 AOI22S $PINS O=n274 A1=n221 A2=n2 B1=n131 B2=n1
XU362 NR2 $PINS O=n403 I1=n104 I2=n97
XU363 NR2 $PINS O=n691 I1=n99 I2=n98
XU364 ND3 $PINS O=n474 I1=n557 I2=n558 I3=n559
XU365 AOI22S $PINS O=n557 A1=n567 A2=n568 B1=n1 B2=n308
XU366 NR3 $PINS O=n559 I1=n560 I2=n561 I3=n523
XU367 AOI22S $PINS O=n476 A1=n2 A2=n614 B1=n308 B2=n22
XU368 NR2 $PINS O=n602 I1=n619 I2=n614
XU369 MOAI1S $PINS O=n926 A1=n42 A2=n101 B1=n413 B2=n1
XU370 AOI22S $PINS O=n841 A1=n125 A2=n2 B1=n1 B2=n127
XU371 INV1S $PINS O=n32 I=n15
XU372 AOI22S $PINS O=n435 A1=n437 A2=n619 B1=n131 B2=n362
XU373 OR2 $PINS O=n350 I1=n707 I2=n188
XU374 NR2 $PINS O=n743 I1=n878 I2=n188
XU375 AOI22S $PINS O=n818 A1=n369 A2=n362 B1=n370 B2=n608
XU376 AOI22S $PINS O=n332 A1=n120 A2=n64 B1=n116 B2=n82
XU377 NR2 $PINS O=n273 I1=n103 I2=FE_OFN256_n236
XU378 AOI22S $PINS O=n580 A1=n608 A2=n126 B1=n592 B2=n23
XU379 INV1S $PINS O=n28 I=n437
XU380 AOI22S $PINS O=n871 A1=n218 A2=n15 B1=n4 B2=n111
XU381 AOI22S $PINS O=n528 A1=n212 A2=n115 B1=n15 B2=n129
XU382 AOI22S $PINS O=n292 A1=n6 A2=n309 B1=n22 B2=n219
XU383 AOI12HS $PINS O=n744 A1=n38 B1=n324 B2=n716
XU384 NR2 $PINS O=n716 I1=n326 I2=FE_OFN256_n236
XU385 OAI12HS $PINS O=n449 A1=n15 B1=n127 B2=n618
XU386 AOI22S $PINS O=n346 A1=n357 A2=n89 B1=n358 B2=n98
XU387 AOI22S $PINS O=n576 A1=n15 A2=n127 B1=n1 B2=n370
XU388 NR2 $PINS O=n211 I1=n4 I2=n15
XU389 AOI22S $PINS O=n699 A1=n72 A2=n438 B1=n103 B2=n357
XU390 AOI22S $PINS O=n684 A1=n567 A2=n568 B1=n317 B2=n27
XU391 NR2 $PINS O=n549 I1=n98 I2=n64
XU392 NR2 $PINS O=n240 I1=n83 I2=n64
XU393 NR2 $PINS O=n149 I1=n97 I2=n99
XU394 INV1S $PINS O=n46 I=n357
XU395 AOI22S $PINS O=n461 A1=n592 A2=n24 B1=n614 B2=n31
XU396 NR2 $PINS O=n631 I1=n105 I2=n104
XU397 AOI22S $PINS O=n206 A1=n127 A2=n1 B1=n370 B2=n15
XU398 OAI112HS $PINS O=n659 A1=n569 B1=n304 C1=n660 C2=n51
XU399 NR2 $PINS O=n660 I1=n86 I2=n661
XU400 NR2 $PINS O=n566 I1=n6 I2=n568
XU401 INV1S $PINS O=n40 I=n483
XU402 NR2 $PINS O=n502 I1=n81 I2=n103
XU403 AOI22S $PINS O=n185 A1=n110 A2=n195 B1=n131 B2=n191
XU404 AOI22S $PINS O=n882 A1=n440 A2=n898 B1=n297 B2=n71
XU405 ND3 $PINS O=n898 I1=n691 I2=n485 I3=n899
XU406 NR2 $PINS O=n899 I1=n82 I2=n71
XU407 AOI22S $PINS O=n436 A1=n437 A2=n128 B1=n2 B2=n308
XU408 INV1S $PINS O=n37 I=n424
XU409 AOI22S $PINS O=n857 A1=n118 A2=FE_OFN256_n236 B1=n338 B2=n112
XU410 INV1S $PINS O=n44 I=n440
XU411 INV1S $PINS O=n42 I=n297
XU412 ND3 $PINS O=n706 I1=n350 I2=n688 I3=n448
XU413 NR2 $PINS O=n196 I1=n370 I2=n131
XU414 AOI22S $PINS O=n693 A1=n357 A2=n5 B1=FE_OFN256_n236 B2=n438
XU415 INV1S $PINS O=n49 I=n467
XU416 MOAI1S $PINS O=n295 A1=n33 A2=n296 B1=n297 B2=n298
XU417 NR2 $PINS O=n521 I1=n127 I2=n218
XU418 INV1S $PINS O=n111 I=n188
XU419 AOI22S $PINS O=n207 A1=n4 A2=n128 B1=n220 B2=n96
XU420 INV1S $PINS O=n38 I=n647
XU421 AOI22S $PINS O=n635 A1=n221 A2=n640 B1=n338 B2=n220
XU422 MOAI1S $PINS O=n480 A1=n502 A2=n42 B1=n85 B2=n467
XU423 NR2 $PINS O=n156 I1=n120 I2=n116
XU424 INV1S $PINS O=n112 I=n495
XU425 INV1S $PINS O=n47 I=n358
XU426 NR3 $PINS O=n306 I1=n619 I2=n221 I3=n126
XU427 NR2 $PINS O=n197 I1=n125 I2=n614
XU428 NR2 $PINS O=n157 I1=n163 I2=n164
XU429 AOI22S $PINS O=n572 A1=n131 A2=n437 B1=n221 B2=n4
XU430 INV1S $PINS O=n51 I=n220
XU431 OA12 $PINS O=n877 A1=n111 B1=n3 B2=n437
XU432 NR2 $PINS O=n886 I1=n420 I2=n592
XU433 NR2 $PINS O=n603 I1=n130 I2=n413
XU434 AOI22S $PINS O=n636 A1=n420 A2=n608 B1=n15 B2=n370
XU435 NR2 $PINS O=n415 I1=n129 I2=n618
XU436 NR2 $PINS O=n200 I1=n221 I2=n369
XU437 NR2 $PINS O=n354 I1=n129 I2=n308
XU438 NR2 $PINS O=n418 I1=n221 I2=n154
XU439 NR2 $PINS O=n155 I1=n129 I2=n592
XU440 NR2 $PINS O=n774 I1=n117 I2=n110
XU441 INV1S $PINS O=n113 I=n175
XU442 NR2 $PINS O=n443 I1=n413 I2=n317
XU443 NR2 $PINS O=n715 I1=n129 I2=n131
XU444 NR2 $PINS O=n414 I1=n218 I2=n420
XU445 NR2 $PINS O=n296 I1=n127 I2=n619
XU446 AOI22S $PINS O=n637 A1=n86 A2=n467 B1=n105 B2=n440
XU447 NR2 $PINS O=n463 I1=FE_OFN256_n236 I2=n309
XU448 NR3 $PINS O=n466 I1=n467 I2=n440 I3=n358
XU449 NR2 $PINS O=n169 I1=n218 I2=n124
XU450 NR2 $PINS O=n167 I1=n370 I2=n614
XU451 NR2 $PINS O=n416 I1=n129 I2=n369
XU452 INV1S $PINS O=n78 I=n285
XU453 AOI22S $PINS O=n617 A1=n370 A2=n27 B1=n218 B2=n362
XU454 NR2 $PINS O=n469 I1=n480 I2=n481
XU455 AN4B1S $PINS O=n470 I1=n471 I2=n472 I3=n473 B1=n474
XU456 NR2 $PINS O=n326 I1=n620 I2=n168
XU457 MOAI1S $PINS O=n583 A1=FE_OFN124_fold_n_4 A2=n584 B1=n22 B2=n618
XU458 AN4B1S $PINS O=n584 I1=n585 I2=n586 I3=n587 B1=n588
XU459 AOI22S $PINS O=n585 A1=n593 A2=n120 B1=n83 B2=n121
XU460 ND3 $PINS O=n783 I1=n271 I2=n412 I3=n784
XU461 AN2 $PINS O=n784 I1=n237 I2=n605
XU462 AN4B1S $PINS O=n748 I1=n785 I2=n692 I3=n628 B1=n477
XU463 NR2 $PINS O=n749 I1=n780 I2=n781
XU464 AN4B1S $PINS O=n750 I1=n751 I2=n752 I3=n753 B1=n754
XU465 OAI22S $PINS O=n768 A1=n598 A2=n161 B1=n769 B2=n175
XU466 AN4B1S $PINS O=n769 I1=n664 I2=n501 I3=n271 B1=n567
XU467 ND3 $PINS O=n574 I1=n729 I2=n730 I3=n731
XU468 NR3 $PINS O=n730 I1=n742 I2=n743 I3=n744
XU469 AN4B1S $PINS O=n731 I1=n646 I2=n732 I3=n693 B1=n622
XU470 NR2 $PINS O=n267 I1=n58 I2=n269
XU471 NR3 $PINS O=n313 I1=n318 I2=n319 I3=n320
XU472 OAI222S $PINS O=n319 A1=n330 A2=n264 B1=n156 B2=n101 C1=n331 C2=n202
XU473 OAI222S $PINS O=n320 A1=n321 A2=n161 B1=n322 B2=n246 C1=n323 C2=n213
XU474 OAI112HS $PINS O=n318 A1=n332 B1=n333 C1=n254 C2=n271
XU475 NR3 $PINS O=n335 I1=n337 I2=n338 I3=n67
XU476 NR3 $PINS O=n334 I1=n339 I2=n340 I3=n97
XU477 NR2 $PINS O=n290 I1=n310 I2=n311
XU478 MOAI1S $PINS O=n311 A1=n312 A2=n37 B1=n413 B2=n15
XU479 OAI222S $PINS O=n310 A1=FE_OFN124_fold_n_4 A2=n313 B1=n151 B2=n26 C1=n314
+ C2=n40
XU480 NR3 $PINS O=n314 I1=n315 I2=n57 I3=n79
XU481 ND3 $PINS O=n782 I1=n594 I2=n143 I3=n253
XU482 INV1S $PINS O=n114 I=n262
XU483 ND3 $PINS O=n772 I1=n499 I2=n56 I3=n600
XU484 ND3 $PINS O=n770 I1=n631 I2=n236 I3=n496
XU485 NR3 $PINS O=n844 I1=n876 I2=n743 I3=n877
XU486 NR3 $PINS O=n845 I1=n846 I2=n847 I3=n848
XU488 ND3 $PINS O=shift3[0] I1=n535 I2=n536 I3=n537
XU489 AN4B1S $PINS O=n536 I1=n20 I2=n555 I3=n556 B1=n474
XU490 AN4B1S $PINS O=n537 I1=n538 I2=n539 I3=n540 B1=n541
XU491 NR2 $PINS O=n204 I1=n222 I2=n223
XU492 MOAI1S $PINS O=n223 A1=n21 A2=n224 B1=n592 B2=n225
XU493 OAI22S $PINS O=n222 A1=n188 A2=n226 B1=FE_OFN124_fold_n_4 B2=n227
XU494 AN4B1S $PINS O=n227 I1=n228 I2=n229 I3=n230 B1=n231
XU495 AN4B1S $PINS O=n261 I1=n271 I2=n236 I3=n272 B1=n89
XU496 AN4B1S $PINS O=n265 I1=n267 I2=n268 I3=n248 B1=n80
XU497 NR3 $PINS O=n263 I1=n102 I2=n269 I3=n270
XU498 OAI112HS $PINS O=n616 A1=n739 B1=n842 C1=n210 C2=n26
XU499 AOI22S $PINS O=n842 A1=n80 A2=n438 B1=n338 B2=n357
XU500 MOAI1S $PINS O=n392 A1=FE_OFN124_fold_n_4 A2=n393 B1=n24 B2=n370
XU501 AN4B1S $PINS O=n393 I1=n394 I2=n395 I3=n396 B1=n397
XU502 AOI22S $PINS O=n394 A1=n5 A2=n112 B1=n98 B2=n113
XU503 NR3 $PINS O=n405 I1=n410 I2=n75 I3=n411
XU504 NR3 $PINS O=n406 I1=n409 I2=n83 I3=n104
XU505 AN4B1S $PINS O=n407 I1=n408 I2=n201 I3=n267 B1=n97
XU506 NR2 $PINS O=n191 I1=n95 I2=n107
XU507 NR2P $PINS O=n338 I1=n92 I2=n620
XU508 OAI22S $PINS O=n489 A1=n490 A2=n246 B1=n161 B2=n491
XU509 AN4B1S $PINS O=n490 I1=n149 I2=n492 I3=n400 B1=n104
XU510 MOAI1S $PINS O=n481 A1=FE_OFN124_fold_n_4 A2=n482 B1=n483 B2=n484
XU511 AN4B1S $PINS O=n482 I1=n486 I2=n487 I3=n488 B1=n489
XU512 AOI22S $PINS O=n486 A1=FE_OFN256_n236 A2=n116 B1=n83 B2=n121
XU513 AN4B1S $PINS O=n498 I1=n331 I2=n499 I3=n500 B1=n84
XU514 AN4B1S $PINS O=n497 I1=n501 I2=n201 I3=n500 B1=n5
XU515 MOAI1S $PINS O=n244 A1=n245 A2=n246 B1=n109 B2=n247
XU516 NR2 $PINS O=n245 I1=n83 I2=n249
XU517 MOAI1S $PINS O=n901 A1=n648 A2=n33 B1=n111 B2=n902
XU518 OA12 $PINS O=n903 A1=n878 B1=FE_OFN124_fold_n_4 B2=n253
XU519 NR3 $PINS O=n801 I1=n353 I2=n1 I3=n608
XU520 AN4B1S $PINS O=n805 I1=n259 I2=n597 I3=n724 B1=n338
XU521 NR2 $PINS O=n499 I1=n269 I2=n593
XU522 NR2 $PINS O=n809 I1=n55 I2=n260
XU523 ND3 $PINS O=n277 I1=n343 I2=n344 I3=n345
XU524 NR2 $PINS O=n344 I1=n359 I2=n360
XU525 AN4B1S $PINS O=n345 I1=n346 I2=n347 I3=n348 B1=n349
XU526 AN4B1S $PINS O=n458 I1=n459 I2=n460 I3=n461 B1=n462
XU527 AN4B1S $PINS O=n712 I1=n301 I2=n248 I3=n329 B1=n68
XU528 NR2 $PINS O=n709 I1=n58 I2=n79
XU529 AN4B1S $PINS O=n711 I1=n199 I2=n426 I3=FE_OFN264_n144 B1=n519
XU530 OAI22S $PINS O=n231 A1=n232 A2=n162 B1=n233 B2=n160
XU531 AN4B1S $PINS O=n232 I1=n236 I2=n74 I3=n237 B1=n238
XU532 AN4B1S $PINS O=n233 I1=n234 I2=n74 I3=n235 B1=n96
XU533 AN4B1S $PINS O=n893 I1=n90 I2=n73 I3=n52 B1=n896
XU534 AN4B1S $PINS O=n894 I1=n62 I2=n101 I3=n100 B1=n339
XU535 MOAI1S $PINS O=n914 A1=n915 A2=n213 B1=n551 B2=n115
XU536 NR2 $PINS O=n915 I1=n68 I2=n63
XU537 OA22 $PINS O=n909 A1=FE_OFN124_fold_n_4 A2=n911 B1=n216 B2=n611
XU538 AN4B1S $PINS O=n911 I1=n912 I2=n680 I3=n913 B1=n914
XU539 AOI22S $PINS O=n912 A1=FE_OFN256_n236 A2=n116 B1=n109 B2=n98
XU540 AOI22S $PINS O=n913 A1=n118 A2=n916 B1=n117 B2=n917
XU541 ND3 $PINS O=n590 I1=n268 I2=n252 I3=n336
XU542 NR2 $PINS O=n212 I1=n52 I2=FE_OFN124_fold_n_4
XU543 INV1S $PINS O=n52 I=n269
XU544 NR2 $PINS O=n646 I1=n10 I2=n11
XU545 OAI222S $PINS O=n10 A1=n152 A2=n33 B1=n188 B2=n39 C1=n21 C2=n452
XU546 OAI222S $PINS O=n11 A1=n35 A2=n215 B1=n361 B2=n29 C1=n34 C2=n479
XU547 ND2 $PINS O=n356 I1=n918 I2=n285
XU548 ND3 $PINS O=n531 I1=n643 I2=n644 I3=n645
XU549 AOI22S $PINS O=n644 A1=n104 A2=n647 B1=n467 B2=FE_OFN256_n236
XU550 AOI22S $PINS O=n643 A1=n5 A2=n440 B1=n424 B2=n326
XU551 ND3 $PINS O=n652 I1=n868 I2=n869 I3=n870
XU552 AN4B1S $PINS O=n870 I1=n871 I2=n475 I3=n818 B1=n532
XU553 OAI22S $PINS O=n397 A1=n398 A2=n264 B1=n399 B2=n246
XU554 AN4B1S $PINS O=n399 I1=n400 I2=n201 I3=n199 B1=n91
XU555 AN4B1S $PINS O=n398 I1=n258 I2=n272 I3=n268 B1=n269
XU556 NR3 $PINS O=n651 I1=n681 I2=n682 I3=n683
XU557 ND3 $PINS O=n682 I1=n533 I2=n692 I3=n576
XU558 ND3 $PINS O=n683 I1=n684 I2=n685 I3=n686
XU559 OAI112HS $PINS O=n681 A1=n471 B1=n695 C1=n41 C2=n264
XU560 AN4B1S $PINS O=n520 I1=n234 I2=n90 I3=n426 B1=n70
XU561 INV1S $PINS O=n104 I=n143
XU563 OAI112HS $PINS O=n532 A1=n820 B1=n872 C1=n50 C2=n253
XU564 AN4B1S $PINS O=n133 I1=n134 I2=n135 I3=n136 B1=n137
XU565 AN4B1S $PINS O=n132 I1=n183 I2=n184 I3=n185 B1=n186
XU566 NR3 $PINS O=n321 I1=n328 I2=n81 I3=n71
XU567 INV1S $PINS O=n99 I=n329
XU568 OAI112HS $PINS O=n530 A1=n865 B1=n866 C1=n864 C2=n503
XU569 NR2 $PINS O=n864 I1=n15 I2=n3
XU570 NR2 $PINS O=n340 I1=n171 I2=n620
XU571 NR2 $PINS O=n851 I1=n859 I2=n860
XU572 MOAI1S $PINS O=n860 A1=n257 A2=n177 B1=n159 B2=n98
XU573 OAI22S $PINS O=n859 A1=n239 A2=n150 B1=n800 B2=n254
XU574 MOAI1S $PINS O=n848 A1=FE_OFN124_fold_n_4 A2=n849 B1=n120 B2=n212
XU575 AN4B1S $PINS O=n849 I1=n850 I2=n851 I3=n852 B1=n853
XU576 AOI22S $PINS O=n850 A1=n117 A2=n861 B1=n113 B2=n862
XU577 AN4B1S $PINS O=n852 I1=n856 I2=n332 I3=n857 B1=n858
XU578 AN4B1S $PINS O=n552 I1=n258 I2=n329 I3=n325 B1=n70
XU579 INV1S $PINS O=n60 I=n327
XU580 ND3 $PINS O=n622 I1=n733 I2=n734 I3=n735
XU581 OA22 $PINS O=n733 A1=n452 A2=n626 B1=n56 B2=n48
XU582 MAOI1 $PINS O=n734 A1=n6 A2=n738 B1=n361 B2=n625
XU583 INV1S $PINS O=n73 I=n904
XU584 NR2 $PINS O=n324 I1=n338 I2=n593
XU585 OAI22S $PINS O=n853 A1=n854 A2=n139 B1=n855 B2=n465
XU586 NR2 $PINS O=n855 I1=n115 I2=n159
XU587 AN2 $PINS O=n854 I1=n259 I2=n400
XU588 AN4B1S $PINS O=n807 I1=n747 I2=n253 I3=n240 B1=n419
XU589 INV1S $PINS O=n54 I=n337
XU590 AN4B1S $PINS O=n808 I1=n671 I2=n271 I3=n325 B1=n55
XU591 OAI222S $PINS O=n666 A1=n668 A2=n42 B1=n669 B2=n44 C1=n199 C2=n37
XU592 AN4B1S $PINS O=n668 I1=n408 I2=n90 I3=n553 B1=n71
XU593 NR3 $PINS O=n669 I1=n670 I2=n57 I3=n75
XU594 MOAI1S $PINS O=n423 A1=n34 A2=n224 B1=n424 B2=n425
XU595 INV1S $PINS O=n98 I=n199
XU596 INV1S $PINS O=n72 I=n237
XU597 AN2 $PINS O=n402 I1=n236 I2=n404
XU598 MOAI1S $PINS O=n477 A1=n786 A2=n648 B1=n787 B2=n221
XU599 NR2 $PINS O=n786 I1=n437 I2=n225
XU600 MOAI1S $PINS O=n524 A1=n525 A2=n355 B1=n526 B2=n112
XU601 OAI222S $PINS O=n512 A1=n273 A2=n37 B1=FE_OFN124_fold_n_4 B2=n513 C1=n514
+ C2=n51
XU602 AN4B1S $PINS O=n514 I1=n515 I2=n401 I3=n271 B1=n55
XU603 NR2 $PINS O=n517 I1=n80 I2=n338
XU604 NR2 $PINS O=n437 I1=n36 I2=n198
XU605 AOI22S $PINS O=n656 A1=n467 A2=n662 B1=n358 B2=n663
XU606 ND3 $PINS O=n663 I1=n664 I2=n501 I3=n665
XU607 NR2 $PINS O=n665 I1=n269 I2=n80
XU608 OAI222S $PINS O=n838 A1=n50 A2=n465 B1=n363 B2=n611 C1=n34 C2=n452
XU609 OAI222S $PINS O=n422 A1=n428 A2=n166 B1=n302 B2=n188 C1=n429 C2=n42
XU610 AN4B1S $PINS O=n429 I1=n252 I2=n236 I3=n430 B1=n75
XU611 NR2 $PINS O=n178 I1=n269 I2=n326
XU612 OAI222S $PINS O=n718 A1=n719 A2=n42 B1=n216 B2=n215 C1=n720 C2=n166
XU613 NR3 $PINS O=n719 I1=n519 I2=n64 I3=n65
XU614 INV1S $PINS O=n94 I=n182
XU615 MOAI1S $PINS O=n812 A1=n813 A2=n42 B1=n27 B2=n420
XU616 NR3 $PINS O=n813 I1=n814 I2=n67 I3=n298
XU617 NR2 $PINS O=n567 I1=n620 I2=n170
XU618 NR2 $PINS O=n438 I1=n254 I2=FE_OFN124_fold_n_4
XU619 NR2 $PINS O=n921 I1=n218 I2=n221
XU620 NR2 $PINS O=n922 I1=n592 I2=n126
XU621 NR2 $PINS O=n920 I1=n4 I2=n3
XU622 NR2 $PINS O=n568 I1=n175 I2=FE_OFN124_fold_n_4
XU623 OA22 $PINS O=n785 A1=n929 A2=n152 B1=n355 B2=n930
XU624 NR2 $PINS O=n929 I1=n3 I2=n787
XU625 NR2 $PINS O=n303 I1=n218 I2=n619
XU626 OAI222S $PINS O=n450 A1=n415 A2=n35 B1=n354 B2=n21 C1=n48 C2=n236
XU627 AN4B1S $PINS O=n446 I1=n447 I2=n448 I3=n449 B1=n450
XU628 OR2 $PINS O=n688 I1=n479 I2=n363
XU629 AOI22S $PINS O=n348 A1=n1 A2=n352 B1=n619 B2=n353
XU630 MOAI1S $PINS O=n359 A1=n363 A2=n152 B1=n22 B2=n317
XU631 INV1S $PINS O=n88 I=n593
XU632 OAI222S $PINS O=n925 A1=n363 A2=n505 B1=n485 B2=n40 C1=n302 C2=n173
XU633 OAI112HS $PINS O=n819 A1=n736 B1=n820 C1=n166 C2=n33
XU634 AOI22S $PINS O=n696 A1=n437 A2=n126 B1=n4 B2=n308
XU635 AOI22S $PINS O=n697 A1=n619 A2=n1 B1=n618 B2=n2
XU636 OA22 $PINS O=n208 A1=n214 A2=n215 B1=n216 B2=n217
XU637 NR2 $PINS O=n217 I1=n420 I2=n317
XU638 NR2 $PINS O=n214 I1=n15 I2=n24
XU639 OAI22S $PINS O=n858 A1=n316 A2=n160 B1=n331 B2=n262
XU640 NR2 $PINS O=n687 I1=n64 I2=n104
XU641 OR2 $PINS O=n448 I1=n478 I2=n611
XU642 AOI22S $PINS O=n613 A1=n3 A2=n615 B1=FE_OFN256_n236 B2=n6
XU643 AOI22S $PINS O=n612 A1=n127 A2=n2 B1=n125 B2=n31
XU644 AOI22S $PINS O=n562 A1=n2 A2=n619 B1=n15 B2=n308
XU645 AOI22S $PINS O=n563 A1=n358 A2=n564 B1=n297 B2=n565
XU646 AOI22S $PINS O=n570 A1=n424 A2=n102 B1=n297 B2=FE_OFN256_n236
XU647 NR2 $PINS O=n172 I1=n181 I2=n182
XU648 AN2 $PINS O=n176 I1=n78 I2=n178
XU649 NR2 $PINS O=n174 I1=n179 I2=n180
XU650 AN4B1S $PINS O=n759 I1=n760 I2=n452 I3=n761 B1=n154
XU651 NR2 $PINS O=n806 I1=n103 I2=n593
XU652 MOAI1S $PINS O=n209 A1=n210 A2=n211 B1=n212 B2=n163
XU653 OAI222S $PINS O=n831 A1=n155 A2=n428 B1=n626 B2=n210 C1=n200 C2=n28
XU654 NR2 $PINS O=n357 I1=n177 I2=FE_OFN124_fold_n_4
XU655 ND3 $PINS O=n762 I1=n931 I2=n168 I3=n932
XU656 NR2 $PINS O=n931 I1=n179 I2=n61
XU657 OAI22S $PINS O=n677 A1=FE_OFN124_fold_n_4 A2=n680 B1=n607 B2=n37
XU658 OA22 $PINS O=n228 A1=n175 A2=n268 B1=n202 B2=n273
XU659 AOI22S $PINS O=n694 A1=n647 A2=n83 B1=n424 B2=n99
XU660 INV1S $PINS O=n115 I=n266
XU661 INV1S $PINS O=n619 I=n210
XU662 INV1S $PINS O=n61 I=n170
XU663 MOAI1S $PINS O=n839 A1=n189 A2=n307 B1=n15 B2=n129
XU664 MOAI1S $PINS O=n667 A1=n215 A2=n307 B1=n110 B2=n212
XU665 AN4B1S $PINS O=n145 I1=n156 I2=n157 I3=n158 B1=n159
XU666 AN4B1S $PINS O=n148 I1=n151 I2=n152 I3=n153 B1=n154
XU667 AN4B1S $PINS O=n158 I1=n160 I2=n161 I3=n162 B1=n119
XU668 NR2 $PINS O=n483 I1=n162 I2=FE_OFN124_fold_n_4
XU669 MOAI1S $PINS O=n360 A1=n361 A2=n26 B1=n362 B2=n420
XU670 MOAI1S $PINS O=n560 A1=n210 A2=n32 B1=n413 B2=n362
XU671 NR2 $PINS O=n424 I1=n160 I2=FE_OFN124_fold_n_4
XU672 NR2 $PINS O=n440 I1=n495 I2=FE_OFN124_fold_n_4
XU673 OA22 $PINS O=n658 A1=n464 A2=n56 B1=n143 B2=n300
XU674 OAI222S $PINS O=n810 A1=n361 A2=n26 B1=n35 B2=n215 C1=n611 C2=n21
XU675 NR2 $PINS O=n297 I1=n150 I2=FE_OFN124_fold_n_4
XU676 INV1S $PINS O=n370 I=n355
XU677 NR2 $PINS O=n467 I1=n262 I2=FE_OFN124_fold_n_4
XU678 INV1S $PINS O=n117 I=n264
XU679 INV1S $PINS O=n218 I=n215
XU680 INV1S $PINS O=n120 I=n177
XU681 ND2 $PINS O=n188 I1=n385 I2=n372
XU682 ND2 $PINS O=n262 I1=n891 I2=n385
XU683 MOAI1S $PINS O=n727 A1=n189 A2=n307 B1=n437 B2=n127
XU684 INV1S $PINS O=n121 I=n254
XU685 INV1S $PINS O=n119 I=n150
XU686 OAI222S $PINS O=n900 A1=n611 A2=n35 B1=n361 B2=n29 C1=n189 C2=n32
XU687 NR2 $PINS O=n647 I1=n266 I2=FE_OFN124_fold_n_4
XU688 INV1S $PINS O=n420 I=n452
XU689 MOAI1S $PINS O=n847 A1=n503 A2=n302 B1=n125 B2=n15
XU690 INV1S $PINS O=n118 I=n246
XU691 MOAI1S $PINS O=n642 A1=n648 A2=n26 B1=n125 B2=n437
XU692 NR2 $PINS O=n358 I1=n202 I2=FE_OFN124_fold_n_4
XU693 INV1S $PINS O=n116 I=n202
XU694 MOAI1S $PINS O=n638 A1=n21 A2=n603 B1=n103 B2=n639
XU695 INV1S $PINS O=n109 I=n161
XU696 INV1S $PINS O=n614 I=n835
XU697 INV1S $PINS O=n127 I=n505
XU698 AN2 $PINS O=n165 I1=n171 I2=n95
XU699 INV1S $PINS O=n131 I=n648
XU700 NR2 $PINS O=n220 I1=n213 I2=FE_OFN124_fold_n_4
XU701 INV1S $PINS O=n221 I=n189
XU702 ND3 $PINS O=n164 I1=n266 I2=n262 I3=n264
XU703 INV1S $PINS O=n618 I=n224
XU704 INV1S $PINS O=n413 I=n361
XU705 NR2 $PINS O=n146 I1=n_idx[4] I2=n374
XU706 INV1S $PINS O=n592 I=n166
XU707 INV1S $PINS O=n308 I=n611
XU708 INV1S $PINS O=n110 I=n213
XU709 ND3 $PINS O=n154 I1=n224 I2=n210 I3=n443
XU710 INV1S $PINS O=n369 I=n152
XU711 INV1S $PINS O=n125 I=n173
XU712 INV1S $PINS O=n129 I=n479
XU713 INV1S $PINS O=n317 I=n503
XU714 INV1S $PINS O=n93 I=n374
XU715 AOI22S $PINS O=n379 A1=n141 A2=n372 B1=n111 B2=n107
XU716 INV1S $PINS O=n108 I=n385
XU717 NR2 $PINS O=n141 I1=n_idx[1] I2=n_idx[0]
XU718 ND2 $PINS O=n259 I1=n141 I2=n897
XU719 AOI22S $PINS O=n751 A1=n763 A2=n17 B1=n22 B2=n126
XU720 ND3 $PINS O=n763 I1=n764 I2=n765 I3=n766
XU721 NR2 $PINS O=n766 I1=n767 I2=n768
XU722 NR2 $PINS O=n918 I1=n107 I2=n_idx[0]
XU723 NR2 $PINS O=n193 I1=n620 I2=n_idx[1]
XU724 INV1S $PINS O=n95 I=n375
XU725 NR2 $PINS O=n269 I1=n168 I2=n_idx[0]
XU726 ND2 $PINS O=n271 I1=n141 I2=n919
XU727 NR2 $PINS O=n593 I1=n92 I2=n_idx[0]
XU734 OAI222S $PINS O=n186 A1=n187 A2=n188 B1=n73 B2=n189 C1=n171 C2=n152
XU735 AN4B1S $PINS O=n187 I1=n28 I2=n41 I3=n190 B1=n191
XU741 AOI22S $PINS O=n190 A1=n192 A2=n87 B1=FE_OFN124_fold_n_4 B2=n95
XU745 NR2 $PINS O=n904 I1=n78 I2=n_idx[1]
XU746 NR2 $PINS O=n182 I1=n95 I2=n_idx[1]
XU759 NR2 $PINS O=n374 I1=n94 I2=n_idx[0]
XU762 NR2 $PINS O=n385 I1=n122 I2=n630
XU775 OAI112HS $PINS O=n447 A1=n17 B1=n109 C1=n98 C2=n338
XU779 OAI12HS $PINS O=sign2[1] A1=n280 B1=n278 B2=n279
XU782 AOI22S $PINS O=n278 A1=n281 A2=n740 B1=n282 B2=n283
XU786 NR2 $PINS O=n281 I1=n_idx[4] I2=n286
XU790 MOAI1S $PINS O=n282 A1=FE_OFN137_rom_k_idx_3__2 A2=n284 B1=n630 B2=n195
XU792 NR2 $PINS O=n372 I1=n18 I2=n283
XU796 NR2 $PINS O=n194 I1=FE_OFN124_fold_n_4 I2=n_idx[0]
XU800 ND2 $PINS O=n264 I1=n892 I2=n923
XU803 MOAI1S $PINS O=n137 A1=n138 A2=n139 B1=n121 B2=n140
XU804 AN4B1S $PINS O=n138 I1=n95 I2=n17 I3=FE_OFN264_n144 B1=n105
XU805 NR2 $PINS O=n888 I1=n283 I2=k_idx[2]
XU809 ND2 $PINS O=n246 I1=n867 I2=n892
XU821 ND2 $PINS O=n202 I1=n891 I2=n892
XU822 ND2 $PINS O=n161 I1=n385 I2=n923
XU829 ND2 $PINS O=n224 I1=n875 I2=n874
XU830 AN2 $PINS O=n895 I1=n933 I2=n19
XU831 ND2 $PINS O=n213 I1=n873 I2=n385
XU833 ND2 $PINS O=n361 I1=n923 I2=n874
XU834 ND2 $PINS O=n166 I1=n372 I2=n874
XU840 ND2 $PINS O=n152 I1=n891 I2=n874
XU844 NR2 $PINS O=n867 I1=n376 I2=k_idx[2]
XU849 NR2 $PINS O=n875 I1=n376 I2=n18
XU851 AN2 $PINS O=n891 I1=n928 I2=n19
XU852 NR2 $PINS O=n181 I1=n107 I2=n87
XU856 AOI13HS $PINS O=n284 A1=n285 B1=n_idx[0] B2=n630 B3=n181
XU857 INV1S $PINS O=n123 I=n384
XU863 INV1S $PINS O=n740 I=n283
XU864 INV1S $PINS O=n87 I=n_idx[3]
XU869 NR2 $PINS O=n919 I1=n87 I2=n_idx[2]
XU880 NR2 $PINS O=n897 I1=n106 I2=n_idx[3]
XU884 ND3 $PINS O=sign2[0] I1=n289 I2=n290 I3=n291
XU886 AN4B1S $PINS O=n291 I1=n292 I2=n293 I3=n294 B1=n295
XU887 AN4B1S $PINS O=n289 I1=n25 I2=n341 I3=n342 B1=n277
XU888 ND3 $PINS O=sign3[0] I1=n203 I2=n204 I3=n205
XU892 AN4B1S $PINS O=n205 I1=n206 I2=n207 I3=n208 B1=n209
XU895 AN4B1S $PINS O=n203 I1=n274 I2=n275 I3=n276 B1=n277
XU896 ND3 $PINS O=sign1[0] I1=n386 I2=n387 I3=n388
XU897 NR2 $PINS O=n387 I1=n422 I2=n423
XU903 AN4B1S $PINS O=n386 I1=n364 I2=n431 I3=n276 B1=n367
XU904 NR2 $PINS O=n375 I1=n_idx[3] I2=n_idx[2]
XU906 NR2 $PINS O=n892 I1=n122 I2=k_idx[1]
XU910 INV1S $PINS O=n122 I=k_idx[0]
XU911 INV1S $PINS O=n630 I=k_idx[1]
XU912 NR2 $PINS O=n384 I1=k_idx[1] I2=k_idx[0]
XU913 OAI12HS $PINS O=sign1[1] A1=n280 B1=n368 B2=n279
XU915 AOI22S $PINS O=n368 A1=n377 A2=n283 B1=n378 B2=n17
XU916 OAI112HS $PINS O=n378 A1=n380 B1=n93 C1=n_idx[3] C2=n379
XU917 OAI222S $PINS O=n377 A1=k_idx[2] A2=n382 B1=n78 B2=n383 C1=n123 C2=n77
XU918 NR2 $PINS O=n933 I1=k_idx[4] I2=k_idx[2]
XU919 INV1S $PINS O=n18 I=FE_OFN137_rom_k_idx_3__2
XU926 AN2 $PINS O=n923 I1=n928 I2=k_idx[3]
XU928 NR2 $PINS O=n928 I1=n18 I2=k_idx[4]
XU929 INV1S $PINS O=n19 I=k_idx[3]
XU931 NR2 $PINS O=n280 I1=n12 I2=n13
XU932 OAI22S $PINS O=n12 A1=k_idx[0] A2=n_idx[0] B1=n146 B2=n740
XU933 AO13S $PINS O=n13 A1=n373 B1=n371 B2=n17 B3=n372
XU935 AOI13HS $PINS O=n373 A1=n17 B1=FE_OFN137_rom_k_idx_3__2 B2=k_idx[1]
+ B3=n374
XU940 AN2 $PINS O=n873 I1=n933 I2=k_idx[3]
XU941 AOI22S $PINS O=n287 A1=FE_OFN137_rom_k_idx_3__2 A2=n288 B1=n141
+ B2=k_idx[1]
XU942 MOAI1S $PINS O=n288 A1=n_idx[1] A2=n122 B1=n620 B2=k_idx[1]
XU943 ND3 $PINS O=n380 I1=k_idx[1] I2=n381 I3=n740
XU944 MOAI1S $PINS O=n381 A1=n122 A2=n94 B1=n620 B2=n375
XU945 OAI12HS $PINS O=n279 A1=n376 B1=k_idx[4] B2=n19
.ENDS

.SUBCKT SNPS_CLOCK_GATE_HIGH_ROM_Wrapper_Odd_1 EN ENCLK CLK
*.CONNECT net2361 EN
XFE_PHC1284_net2364 DELC $PINS O=FE_PHN1284_net2364 I=net2364
Xlatch QDBHN $PINS Q=net2364 D=net2361 CKB=CLK
Xmain_gate AN2 $PINS O=ENCLK I1=FE_PHN1284_net2364 I2=CLK
.ENDS

.SUBCKT ROM_Wrapper_Odd_1 rst_n en n_in[4] n_in[3] n_in[2] n_in[1] n_in[0]
+ k_idx[4] k_idx[3] k_idx[2] k_idx[1] k_idx[0] reg_sign1[1] reg_sign1[0]
+ reg_sign2[1] reg_sign2[0] reg_sign3[1] reg_sign3[0] reg_shift1[3]
+ reg_shift1[2] reg_shift1[1] reg_shift1[0] reg_shift2[3] reg_shift2[2]
+ reg_shift2[1] reg_shift2[0] reg_shift3[3] reg_shift3[2] reg_shift3[1]
+ reg_shift3[0] i_rst_n FE_OFN55_i_rst_n FE_OFN34_i_rst_n FE_OFN30_i_rst_n
+ FE_OFN136_rom_k_idx_3__2 FE_OFN147_rom_n_idx_3__3 clk
*.CONNECT N4 n_in[0]
XCTS_ccl_a_INV_CLK_G1_L10_41 INV4CK $PINS O=CTS_10 I=CTS_11
XCTS_ccl_a_INV_CLK_G1_L9_43 INV2CK $PINS O=CTS_11 I=CTS_12
XFE_OFC561_rom_n_idx_3__3 INV1S $PINS O=FE_OFN343_rom_n_idx_3__3
+ I=FE_OFN147_rom_n_idx_3__3
Xreg_sign1_reg[1] DFFSBN $PINS Q=reg_sign1[1] D=raw_s1[1] CK=CTS_10
+ SB=FE_OFN30_i_rst_n
Xreg_sign2_reg[1] DFFSBN $PINS Q=reg_sign2[1] D=raw_s2[1] CK=CTS_10
+ SB=FE_OFN30_i_rst_n
Xreg_sign3_reg[1] DFFSBN $PINS Q=reg_sign3[1] D=raw_s3[1] CK=CTS_10
+ SB=FE_OFN30_i_rst_n
Xreg_shift2_reg[1] QDFFRBN $PINS Q=reg_shift2[1] D=raw_h2[1] CK=CTS_10
+ RB=FE_OFN34_i_rst_n
Xreg_shift3_reg[1] QDFFRBN $PINS Q=reg_shift3[1] D=raw_h3[1] CK=CTS_10
+ RB=i_rst_n
Xreg_shift2_reg[2] QDFFRBN $PINS Q=reg_shift2[2] D=raw_h2[2] CK=CTS_10
+ RB=FE_OFN34_i_rst_n
Xreg_shift1_reg[1] QDFFRBN $PINS Q=reg_shift1[1] D=raw_h1[1] CK=CTS_10
+ RB=i_rst_n
Xreg_shift1_reg[2] QDFFRBN $PINS Q=reg_shift1[2] D=raw_h1[2] CK=CTS_10
+ RB=i_rst_n
Xreg_shift2_reg[0] QDFFRBN $PINS Q=reg_shift2[0] D=raw_h2[0] CK=CTS_10
+ RB=FE_OFN34_i_rst_n
Xreg_shift3_reg[0] QDFFRBP $PINS Q=reg_shift3[0] D=raw_h3[0] CK=CTS_10
+ RB=i_rst_n
Xreg_shift3_reg[2] QDFFRBN $PINS Q=reg_shift3[2] D=raw_h3[2] CK=CTS_10
+ RB=i_rst_n
Xreg_shift3_reg[3] QDFFRBN $PINS Q=reg_shift3[3] D=raw_h3[3] CK=CTS_10
+ RB=i_rst_n
Xreg_shift2_reg[3] QDFFRBN $PINS Q=reg_shift2[3] D=raw_h2[3] CK=CTS_10
+ RB=FE_OFN34_i_rst_n
Xreg_sign2_reg[0] QDFFRBN $PINS Q=reg_sign2[0] D=final_s2[0] CK=CTS_10
+ RB=FE_OFN34_i_rst_n
Xreg_sign3_reg[0] QDFFRBN $PINS Q=reg_sign3[0] D=final_s3[0] CK=CTS_10
+ RB=i_rst_n
Xreg_sign1_reg[0] QDFFRBN $PINS Q=reg_sign1[0] D=final_s1[0] CK=CTS_10
+ RB=FE_OFN30_i_rst_n
Xreg_shift1_reg[0] QDFFRBN $PINS Q=reg_shift1[0] D=raw_h1[0] CK=CTS_10
+ RB=FE_OFN30_i_rst_n
Xreg_shift1_reg[3] QDFFRBN $PINS Q=reg_shift1[3] D=raw_h1[3] CK=CTS_10
+ RB=FE_OFN55_i_rst_n
XU3 NR2 $PINS O=sub_17/carry[2] I1=N4 I2=n_in[1]
XU4 MUX2 $PINS O=fold_n[3] S=N2 A=FE_OFN147_rom_n_idx_3__3 B=N7
XU5 MOAI1 $PINS O=fold_n[1] A1=n3 A2=N2 B1=N5 B2=N2
XU7 AN2S $PINS O=sub_17/carry[3] I1=sub_17/carry[2] I2=n4
XU8 AN2S $PINS O=sub_17/carry[4] I1=sub_17/carry[3] I2=FE_OFN343_rom_n_idx_3__3
XU9 ND3S $PINS O=n10 I1=N2 I2=n11 I3=k_idx[0]
XU10 INV1S $PINS O=n7 I=N4
XU11 MOAI1 $PINS O=fold_n[0] A1=n7 A2=N2 B1=N4 B2=N2
XU12 XNR2HS $PINS O=final_s2[0] I1=raw_s2[0] I2=n10
XU13 XNR2HS $PINS O=final_s3[0] I1=raw_s3[0] I2=n10
XU14 INV1S $PINS O=n3 I=n_in[1]
XU15 XNR2HS $PINS O=final_s1[0] I1=raw_s1[0] I2=n10
XU16 OA13 $PINS O=N2 A1=n_in[4] B1=n_in[1] B2=N4 B3=n8
XU17 INV1S $PINS O=n4 I=n_in[2]
XU18 MOAI1S $PINS O=fold_n[2] A1=n4 A2=N2 B1=N6 B2=N2
XU20 MOAI1S $PINS O=fold_n[4] A1=n6 A2=N2 B1=N8 B2=N2
XU21 INV1S $PINS O=n6 I=n_in[4]
XU23 ND3 $PINS O=n11 I1=k_idx[4] I2=k_idx[3] I3=n12
XU24 AN2 $PINS O=n12 I1=FE_OFN136_rom_k_idx_3__2 I2=k_idx[1]
XU25 XOR2HS $PINS O=N8 I1=n6 I2=sub_17/carry[4]
XU26 XOR2HS $PINS O=N7 I1=FE_OFN343_rom_n_idx_3__3 I2=sub_17/carry[3]
XU27 XOR2HS $PINS O=N6 I1=n4 I2=sub_17/carry[2]
XU28 XOR2HS $PINS O=N5 I1=n3 I2=n7
XU29 OR2 $PINS O=n8 I1=n_in[3] I2=n_in[2]
Xrom_inst CSD_ROM_Table_odd_1 $PINS n_idx[4]=fold_n[4] n_idx[3]=fold_n[3]
+ n_idx[2]=fold_n[2] n_idx[1]=fold_n[1] n_idx[0]=fold_n[0] k_idx[4]=k_idx[4]
+ k_idx[3]=k_idx[3] k_idx[2]=k_idx[2] k_idx[1]=k_idx[1] k_idx[0]=k_idx[0]
+ sign1[1]=raw_s1[1] sign1[0]=raw_s1[0] shift1[3]=raw_h1[3] shift1[2]=raw_h1[2]
+ shift1[1]=raw_h1[1] shift1[0]=raw_h1[0] sign2[1]=raw_s2[1] sign2[0]=raw_s2[0]
+ shift2[3]=raw_h2[3] shift2[2]=raw_h2[2] shift2[1]=raw_h2[1] shift2[0]=raw_h2[0]
+ sign3[1]=raw_s3[1] sign3[0]=raw_s3[0] shift3[3]=raw_h3[3] shift3[2]=raw_h3[2]
+ shift3[1]=raw_h3[1] shift3[0]=raw_h3[0]
+ FE_OFN137_rom_k_idx_3__2=FE_OFN136_rom_k_idx_3__2
Xclk_gate_reg_shift1_reg SNPS_CLOCK_GATE_HIGH_ROM_Wrapper_Odd_1 $PINS EN=en
+ ENCLK=CTS_12 CLK=clk
.ENDS

.SUBCKT CSD_ROM_Table_even_0 n_idx[4] n_idx[3] n_idx[2] n_idx[1] n_idx[0]
+ k_idx[4] k_idx[3] k_idx[2] k_idx[1] k_idx[0] sign1[1] sign1[0] shift1[3]
+ shift1[2] shift1[1] shift1[0] sign2[1] sign2[0] shift2[3] shift2[2] shift2[1]
+ shift2[0] sign3[1] sign3[0] shift3[3] shift3[2] shift3[1] shift3[0]
XFE_OFC304_n1724 INV1S $PINS O=n62 I=n1724
XFE_OFC281_n1760 INV1S $PINS O=n33 I=n1760
XFE_OFC268_fold_n_0 BUF1 $PINS O=FE_OFN250_fold_n_0 I=n113
XFE_OFC267_fold_n_0 INV2 $PINS O=FE_OFN249_fold_n_0 I=n113
XFE_OFC266_fold_n_0 INV1S $PINS O=n113 I=n_idx[0]
XFE_OFC262_n1 INV2 $PINS O=n37 I=n1
XU776 OA222 $PINS O=n1833 A1=n1825 A2=n98 B1=n1824 B2=n1823 C1=n1822 C2=n1821
XU777 OR3B2 $PINS O=n1813 I1=n1812 B1=n1811 B2=n1810
XU778 ND2 $PINS O=n1809 I1=n40 I2=n113
XU779 AO12 $PINS O=n1798 A1=n1795 B1=n110 B2=n1796
XU780 AO112 $PINS O=n1790 A1=n_idx[4] B1=n1788 C1=n1789 C2=n_idx[3]
XU782 OA222 $PINS O=n1751 A1=n1750 A2=n1814 B1=n1749 B2=n1748 C1=n1747 C2=n1746
XU783 ND2 $PINS O=n1744 I1=n1742 I2=n1741
XU784 ND2 $PINS O=n1745 I1=n1740 I2=n1739
XU785 ND2 $PINS O=n1737 I1=n1736 I2=n89
XU787 AN3B2S $PINS O=n1730 I1=n1728 B1=n1727 B2=n1726
XU788 AN3 $PINS O=n1719 I1=n1718 I2=n1717 I3=n1757
XU789 OR3B2 $PINS O=n1716 I1=n1712 B1=n1711 B2=n34
XU790 AN3 $PINS O=n1709 I1=n1706 I2=n1705 I3=n1704
XU791 AO12 $PINS O=sign2[1] A1=n1701 B1=n1703 B2=n1702
XU792 AO222 $PINS O=n1702 A1=n1700 A2=n890 B1=n1699 B2=n1698 C1=n1697 C2=n1696
XU794 ND2 $PINS O=n1670 I1=n1666 I2=n1803
XU795 AO12 $PINS O=n1674 A1=n1664 B1=n1665 B2=n1754
XU796 OA222 $PINS O=n1661 A1=n1660 A2=n1761 B1=n1659 B2=n1658 C1=n1657 C2=n1823
XU797 ND2 $PINS O=n1625 I1=n83 I2=n419
XU798 AO12 $PINS O=sign1[1] A1=n1701 B1=n1703 B2=n1622
XU799 ND2 $PINS O=n1797 I1=n_idx[4] I2=n97
XU800 AN3 $PINS O=n1621 I1=n1620 I2=n113 I3=n1619
XU801 OR3 $PINS O=n1620 I1=n1695 I2=n40 I3=n_idx[1]
XU802 ND2 $PINS O=n1613 I1=n134 I2=n1695
XU803 ND2 $PINS O=n1695 I1=n1691 I2=k_idx[2]
XU804 OA222 $PINS O=n1602 A1=n1595 A2=n1746 B1=n1594 B2=n1631 C1=n1593 C2=n1729
XU805 OA222 $PINS O=n1603 A1=n1589 A2=n1805 B1=n1588 B2=n1587 C1=n1586 C2=n1585
XU806 OA222 $PINS O=n1604 A1=n93 A2=n100 B1=n82 B2=n95 C1=n77 C2=n1739
XU807 ND2 $PINS O=n1707 I1=n1565 I2=n1564
XU810 OA112 $PINS O=n1710 A1=n1554 B1=n1553 C1=n77 C2=n1555
XU811 ND2 $PINS O=n1551 I1=n1801 I2=n1577
XU812 ND2 $PINS O=n1539 I1=n1 I2=n1538
XU813 ND2 $PINS O=n1535 I1=n1532 I2=n1735
XU814 AO12 $PINS O=n1537 A1=n1761 B1=n1814 B2=n1531
XU815 ND2 $PINS O=n1527 I1=n62 I2=n132
XU816 OA222 $PINS O=n1519 A1=n77 A2=n1658 B1=n1573 B2=n1678 C1=n99 C2=n93
XU817 OA222 $PINS O=n1520 A1=n1514 A2=n1830 B1=n1513 B2=n1765 C1=n1512 C2=n1761
XU818 AN3B2S $PINS O=n1513 I1=n1826 B1=n1634 B2=n55
XU819 AN3B2S $PINS O=n1496 I1=n1484 B1=n1483 B2=n1482
XU820 AN3 $PINS O=n1468 I1=n1749 I2=n1826 I3=n1465
XU821 OA222 $PINS O=n1471 A1=n93 A2=n1464 B1=n1463 B2=n1666 C1=n1462 C2=n1658
XU822 OA222 $PINS O=n1473 A1=n1574 A2=n1823 B1=n1458 B2=n1805 C1=n1718 C2=n1633
XU823 AN3B2S $PINS O=n1451 I1=n1498 B1=n1450 B2=n37
XU824 OA112 $PINS O=n1444 A1=n1442 B1=n1441 C1=n1761 C2=n1724
XU825 AN3 $PINS O=n1427 I1=n1419 I2=n1418 I3=n1554
XU826 ND2 $PINS O=n1554 I1=n131 I2=n1417
XU827 ND2 $PINS O=n1415 I1=n1714 I2=n1756
XU828 ND2 $PINS O=n1416 I1=n1668 I2=n87
XU829 ND2 $PINS O=n1411 I1=n54 I2=n1538
XU830 OA222 $PINS O=n1435 A1=n73 A2=n1658 B1=n1409 B2=n1748 C1=n1408 C2=n1494
XU831 AN3B2S $PINS O=n1409 I1=n1407 B1=n1406 B2=n1497
XU833 ND2 $PINS O=n1396 I1=n1394 I2=n3
XU834 OA222 $PINS O=n1376 A1=n1372 A2=n1642 B1=n1371 B2=n1748 C1=n1370 C2=n1494
XU835 ND2 $PINS O=n1552 I1=n1654 I2=n1592
XU836 OA222 $PINS O=n1377 A1=n1367 A2=n1763 B1=n1422 B2=n1366 C1=n1365 C2=n1761
XU837 OA222 $PINS O=n1378 A1=n1363 A2=n1830 B1=n1591 B2=n1631 C1=n1362 C2=n1823
XU838 AN3B2S $PINS O=n1381 I1=n1446 B1=n1355 B2=n1430
XU839 AN3 $PINS O=n1478 I1=n1349 I2=n1348 I3=n1347
XU840 OA112 $PINS O=n1348 A1=n1418 B1=n1337 C1=n1338 C2=n1739
XU841 AO12 $PINS O=n1337 A1=n1658 B1=n64 B2=n1336
XU842 OA222 $PINS O=n1349 A1=n1586 A2=n1763 B1=n1335 B2=n1678 C1=n1742 C2=n64
XU843 OA112 $PINS O=n1528 A1=n1334 B1=n1333 C1=n1678 C2=n1724
XU844 OA222 $PINS O=n1333 A1=n1821 A2=n28 B1=n1332 B2=n7 C1=n1387 C2=n1739
XU845 OA222 $PINS O=n1446 A1=n1382 A2=n93 B1=n1786 B2=n64 C1=n1799 C2=n72
XU847 OA222 $PINS O=n1327 A1=n1321 A2=n1494 B1=n1320 B2=n1823 C1=n1319 C2=n1557
XU848 OA222 $PINS O=n1328 A1=n1317 A2=n1765 B1=n1316 B2=n1631 C1=n1315 C2=n1805
XU849 OA112 $PINS O=n1330 A1=n1313 B1=n1312 C1=n1678 C2=n1801
XU850 OA222 $PINS O=n1312 A1=n1746 A2=n1815 B1=n1590 B2=n1742 C1=n1729 C2=n1489
XU851 OR3B2 $PINS O=n1311 I1=n1626 B1=n1732 B2=n1420
XU852 OA222 $PINS O=n1307 A1=n1823 A2=n1756 B1=n1664 B2=n1382 C1=n79 C2=n1763
XU853 OA222 $PINS O=n1301 A1=n1388 A2=n67 B1=n1550 B2=n77 C1=n1795 C2=n3
XU854 ND2 $PINS O=n1298 I1=n54 I2=n1318
XU855 ND2 $PINS O=n1299 I1=n1815 I2=n1361
XU856 AO12 $PINS O=n1303 A1=n1678 B1=n1361 B2=n1574
XU857 OA222 $PINS O=n1305 A1=n82 A2=n1754 B1=n1759 B2=n1633 C1=n1352 C2=n1658
XU858 OA112 $PINS O=n1306 A1=n1705 B1=n1297 C1=n1831 C2=n1630
XU859 OA222 $PINS O=n1295 A1=n1664 A2=n1294 B1=n1293 B2=n79 C1=n1292 C2=n1746
XU860 OA112 $PINS O=n1421 A1=n1285 B1=n1284 C1=n82 C2=n1754
XU861 ND2 $PINS O=n1284 I1=n61 I2=n133
XU862 OA222 $PINS O=n1526 A1=n1509 A2=n1823 B1=n1494 B2=n1592 C1=n1748 C2=n1724
XU863 AO112 $PINS O=n1280 A1=n1278 B1=n1277 C1=n1279 C2=n417
XU864 AN3 $PINS O=n1706 I1=n1274 I2=n1273 I3=n1272
XU865 OA112 $PINS O=n1272 A1=n1313 B1=n1271 C1=n1509 C2=n1676
XU866 OA222 $PINS O=n1271 A1=n1823 A2=n1756 B1=n77 B2=n1658 C1=n1633 C2=n1361
XU867 OA222 $PINS O=n1313 A1=n77 A2=n1739 B1=n1786 B2=n67 C1=n1742 C2=n72
XU868 OA222 $PINS O=n1273 A1=n1652 A2=n1557 B1=n1270 B2=n1805 C1=n1392 C2=n1748
XU869 OA222 $PINS O=n1274 A1=n1799 A2=n3 B1=n1649 B2=n1664 C1=n1567 C2=n1494
XU870 AN3 $PINS O=n1628 I1=n1269 I2=n1268 I3=n1267
XU871 AN3B2S $PINS O=n1267 I1=n1266 B1=n1265 B2=n1264
XU872 ND2 $PINS O=n1259 I1=n1735 I2=n1361
XU873 OA222 $PINS O=n1256 A1=n1805 A2=n1815 B1=n1632 B2=n1587 C1=n1823 C2=n1361
XU874 OA222 $PINS O=n1251 A1=n79 A2=n1742 B1=n82 B2=n1294 C1=n1664 C2=n95
XU875 AO12 $PINS O=n1252 A1=n93 B1=n1648 B2=n96
XU876 AN3 $PINS O=n1660 I1=n1509 I2=n1831 I3=n1635
XU877 OA222 $PINS O=n1221 A1=n1780 A2=n81 B1=n1220 B2=n1729 C1=n90 C2=n1805
XU879 ND2 $PINS O=n1218 I1=n1407 I2=n1589
XU880 ND2 $PINS O=n1639 I1=n1801 I2=n1654
XU881 AN3B2S $PINS O=n1198 I1=n1297 B1=n1197 B2=n1264
XU883 AO222 $PINS O=n1197 A1=n1743 A2=n130 B1=n69 B2=n127 C1=n419 C2=n92
XU884 OA222 $PINS O=n1199 A1=n66 A2=n1803 B1=n1196 B2=n72 C1=n1195 C2=n1823
XU885 AO112 $PINS O=n1184 A1=n1429 B1=n1480 C1=n1410 C2=n125
XU886 ND2 $PINS O=n1560 I1=n1668 I2=n1449
XU887 OA222 $PINS O=n1176 A1=n1175 A2=n1746 B1=n1174 B2=n1630 C1=n1173 C2=n1729
XU888 OR3B2 $PINS O=n1350 I1=n1597 B1=n1171 B2=n1170
XU889 ND2 $PINS O=n1219 I1=n1725 I2=n1449
XU890 ND2 $PINS O=n1597 I1=n1485 I2=n1540
XU891 AN3 $PINS O=n1762 I1=n1242 I2=n28 I3=n1723
XU892 ND2 $PINS O=n1276 I1=n1763 I2=n1666
XU894 ND2 $PINS O=n1154 I1=n1585 I2=n1739
XU895 ND2 $PINS O=n1156 I1=n93 I2=n82
XU896 ND2 $PINS O=n1418 I1=n62 I2=n123
XU897 ND2 $PINS O=n1279 I1=n1538 I2=n1640
XU898 AN3 $PINS O=n1206 I1=n1144 I2=n1567 I3=n39
XU899 ND2 $PINS O=n1133 I1=n72 I2=n67
XU900 ND2 $PINS O=n1134 I1=n95 I2=n1754
XU901 ND2 $PINS O=n1655 I1=n1721 I2=n1801
XU902 AN3B1 $PINS O=n1648 I1=n1820 I2=n1294 B1=n1148
XU903 ND2 $PINS O=n1778 I1=n1631 I2=n1741
XU904 ND2 $PINS O=n1149 I1=n1632 I2=n7
XU905 ND2 $PINS O=n1486 I1=n1724 I2=n1640
XU906 OR3B2 $PINS O=n1110 I1=n1596 B1=n87 B2=n1498
XU908 ND2 $PINS O=n1726 I1=n1498 I2=n1540
XU909 ND2 $PINS O=n1491 I1=n1640 I2=n1449
XU911 AN3 $PINS O=n1704 I1=n1099 I2=n1098 I3=n1097
XU912 ND2 $PINS O=n1285 I1=n1698 I2=n1791
XU913 OA222 $PINS O=n1093 A1=n1180 A2=n82 B1=n1586 B2=n1803 C1=n1578 C2=n1633
XU915 ND2 $PINS O=n1225 I1=n1294 I2=n100
XU916 ND2 $PINS O=n1777 I1=n1412 I2=n1786
XU917 ND2 $PINS O=n1076 I1=n1193 I2=n1658
XU919 ND2 $PINS O=n1077 I1=n1665 I2=n1385
XU920 OA222 $PINS O=n1072 A1=n1739 A2=n64 B1=n1542 B2=n1801 C1=n39 C2=n1494
XU923 OR3B2 $PINS O=n1068 I1=n1260 B1=n108 B2=n1294
XU924 ND2 $PINS O=n1260 I1=n1665 I2=n1180
XU925 ND2 $PINS O=n1069 I1=n1636 I2=n1640
XU926 ND2 $PINS O=n1254 I1=n1659 I2=n67
XU927 ND2 $PINS O=n1194 I1=n79 I2=n67
XU928 OA222 $PINS O=n1061 A1=n84 A2=n1729 B1=n1060 B2=n3 C1=n1059 C2=n1761
XU929 ND2 $PINS O=n1490 I1=n1540 I2=n1318
XU930 OA222 $PINS O=n1345 A1=n1563 A2=n82 B1=n1721 B2=n1633 C1=n93 C2=n1665
XU931 OA112 $PINS O=n1064 A1=n1708 B1=n1562 C1=n1642 C2=n1489
XU932 OA222 $PINS O=n1057 A1=n77 A2=n1755 B1=n1666 B2=n64 C1=n82 C2=n1382
XU933 ND2 $PINS O=shift1[0] I1=n1056 I2=n1055
XU934 ND2 $PINS O=n1673 I1=n130 I2=n69
XU935 ND2 $PINS O=n1741 I1=n1075 I2=n1618
XU936 AO12 $PINS O=n1050 A1=n1590 B1=n1803 B2=n1332
XU937 ND2 $PINS O=n1587 I1=n1048 I2=n1070
XU939 OA222 $PINS O=n1052 A1=n105 A2=n93 B1=n1046 B2=n1678 C1=n1045 C2=n1815
XU940 OA222 $PINS O=n1053 A1=n1574 A2=n1748 B1=n1780 B2=n64 C1=n1458 C2=n1494
XU941 OA222 $PINS O=n1054 A1=n1786 A2=n3 B1=n1352 B2=n1557 C1=n89 C2=n1746
XU942 ND2 $PINS O=n1215 I1=n1725 I2=n1489
XU943 AN3 $PINS O=n1063 I1=n1039 I2=n1038 I3=n1037
XU944 AO12 $PINS O=n1262 A1=n7 B1=n1786 B2=n1799
XU945 ND2 $PINS O=n1634 I1=n1718 I2=n1030
XU947 ND2 $PINS O=n1026 I1=n1827 I2=n1725
XU948 ND2 $PINS O=n1027 I1=n1713 I2=n1489
XU949 OA222 $PINS O=n1035 A1=n1388 A2=n81 B1=n1023 B2=n1746 C1=n1484 C2=n1642
XU950 ND2 $PINS O=n1533 I1=n1204 I2=n1449
XU951 ND2 $PINS O=n1676 I1=n1618 I2=n1047
XU954 ND2 $PINS O=n1555 I1=n1019 I2=n1048
XU955 ND2 $PINS O=n1309 I1=n1017 I2=n1016
XU956 OA222 $PINS O=n1016 A1=n1106 A2=n1729 B1=n1015 B2=n1761 C1=n1014 C2=n1666
XU957 ND2 $PINS O=n1666 I1=n1075 I2=n1070
XU958 OA222 $PINS O=n1017 A1=n1831 A2=n1746 B1=n1579 B2=n1678 C1=n1649 C2=n93
XU960 ND2 $PINS O=n1755 I1=n1071 I2=n1019
XU961 AN3 $PINS O=n1190 I1=n1012 I2=n76 I3=n1011
XU962 OA222 $PINS O=n1011 A1=n1336 A2=n1557 B1=n1388 B2=n72 C1=n7 C2=n1631
XU968 ND2 $PINS O=n1743 I1=n1675 I2=n7
XU970 OA222 $PINS O=n1041 A1=n1642 A2=n1724 B1=n1008 B2=n1805 C1=n1830 C2=n28
XU971 ND2 $PINS O=n1482 I1=n1724 I2=n1449
XU972 ND2 $PINS O=n1538 I1=n1007 I2=n1025
XU973 ND2 $PINS O=n1725 I1=n1044 I2=n1022
XU974 OA222 $PINS O=n1042 A1=n1821 A2=n79 B1=n1006 B2=n82 C1=n1005 C2=n1664
XU976 AN3B2S $PINS O=n1791 I1=n1686 B1=k_idx[3] B2=k_idx[4]
XU977 ND2 $PINS O=n1788 I1=n1383 I2=n95
XU979 ND2 $PINS O=n1004 I1=n1649 I2=n97
XU983 ND2 $PINS O=n1464 I1=n102 I2=FE_OFN250_fold_n_0
XU987 ND2 $PINS O=n1563 I1=n1802 I2=FE_OFN250_fold_n_0
XU990 OA222 $PINS O=n1043 A1=n1001 A2=n1823 B1=n1485 B2=n1765 C1=n1000 C2=n1633
XU998 ND2 $PINS O=n1668 I1=n1007 I2=n1697
XU3 AN4B1S $PINS O=n1358 I1=n1579 I2=n1241 I3=n1756 B1=n1364
XU4 AOI13HS $PINS O=n1297 A1=n1429 B1=n1783 B2=n1817 B3=n120
XU5 AN4B1S $PINS O=n1825 I1=n1781 I2=n1555 I3=n1742 B1=n1779
XU6 AN4S $PINS O=n1244 I1=n1718 I2=n1668 I3=n1660 I4=n1574
XU8 NR2P $PINS O=n1760 I1=n45 I2=n35
XU9 NR2 $PINS O=n1 I1=n38 I2=n50
XU10 ND2 $PINS O=n1827 I1=n998 I2=n113
XU11 NR2 $PINS O=n1697 I1=n_idx[4] I2=n_idx[3]
XU12 ND2 $PINS O=n1756 I1=n994 I2=FE_OFN249_fold_n_0
XU13 ND2S $PINS O=n1774 I1=n_idx[3] I2=n_idx[2]
XU14 ND3 $PINS O=n1167 I1=n1654 I2=n1811 I3=n1168
XU15 INV1S $PINS O=n50 I=n1811
XU16 ND2S $PINS O=n1738 I1=n1801 I2=n1735
XU18 INV1S $PINS O=n112 I=n_idx[1]
XU19 ND2S $PINS O=n1121 I1=n1677 I2=n1724
XU20 ND3 $PINS O=n1186 I1=n1178 I2=n1177 I3=n1176
XU21 ND3 $PINS O=shift1[3] I1=n1189 I2=n1188 I3=n1187
XU22 ND2S $PINS O=n1169 I1=n1158 I2=n1157
XU23 ND3S $PINS O=n1373 I1=n1504 I2=n87 I3=n1101
XU24 ND3S $PINS O=n1166 I1=n1503 I2=n1 I3=n1762
XU25 ND3S $PINS O=n1364 I1=n1760 I2=n1827 I3=n1578
XU26 OR2S $PINS O=n1217 I1=n1497 I2=n20
XU27 OR3B2S $PINS O=n1395 I1=n1655 B1=n1510 B2=n1579
XU28 ND3S $PINS O=n1488 I1=n1760 I2=n1485 I3=n1636
XU29 AO12S $PINS O=n1264 A1=n1460 B1=n35 B2=n419
XU30 ND2S $PINS O=n1180 I1=n107 I2=FE_OFN250_fold_n_0
XU31 ND2S $PINS O=n1754 I1=n103 I2=FE_OFN250_fold_n_0
XU32 AN2S $PINS O=n1593 I1=n1592 I2=n1667
XU33 MAOI1S $PINS O=n1177 A1=n115 A2=n1169 B1=n1823 B2=n1168
XU34 ND3S $PINS O=n1669 I1=n1756 I2=n1668 I3=n1667
XU35 ND3S $PINS O=shift1[1] I1=n1087 I2=n1086 I3=n1085
XU36 ND3S $PINS O=n1506 I1=n1504 I2=n1503 I3=n1502
XU37 ND3S $PINS O=n1356 I1=n1810 I2=n1640 I3=n1369
XU38 AN3S $PINS O=n1001 I1=n1466 I2=n1826 I3=n1573
XU39 NR2 $PINS O=n2 I1=n80 I2=n110
XU40 ND3S $PINS O=n1758 I1=n1757 I2=n1811 I3=n1756
XU41 OA222S $PINS O=n1326 A1=n1 A2=n1748 B1=n99 B2=n93 C1=n1717 C2=n1761
XU42 ND2S $PINS O=n1487 I1=n1827 I2=n1540
XU43 ND3S $PINS O=n1208 I1=n1465 I2=n1510 I3=n1543
XU44 OA12S $PINS O=n1459 A1=n115 B1=n38 B2=n1655
XU45 ND3S $PINS O=n1322 I1=n1735 I2=n1827 I3=n1485
XU46 OA22S $PINS O=n1074 A1=n1750 A2=n1760 B1=n1803 B2=n1394
XU47 ND2S $PINS O=n1497 I1=n1485 I2=n1811
XU48 OA22S $PINS O=n1624 A1=n1678 A2=n1811 B1=n1711 B2=n1630
XU49 ND3S $PINS O=n1483 I1=n1540 I2=n1811 I3=n1711
XU50 ND2S $PINS O=n1820 I1=n109 I2=FE_OFN250_fold_n_0
XU51 ND2S $PINS O=n1831 I1=FE_OFN249_fold_n_0 I2=n998
XU52 ND2S $PINS O=n1596 I1=n1572 I2=n1724
XU53 ND2S $PINS O=n1757 I1=n997 I2=FE_OFN249_fold_n_0
XU54 ND3S $PINS O=n1654 I1=n1022 I2=n113 I3=n1697
XU55 ND2S $PINS O=n1735 I1=n994 I2=n113
XU56 ND2S $PINS O=n1828 I1=n111 I2=n104
XU57 ND3S $PINS O=n1801 I1=n1697 I2=n1022 I3=FE_OFN249_fold_n_0
XU58 ND3S $PINS O=n1448 I1=n1489 I2=n1204 I3=n1
XU59 ND2S $PINS O=n1577 I1=n999 I2=FE_OFN249_fold_n_0
XU60 ND2S $PINS O=n1773 I1=n993 I2=n_idx[1]
XU61 ND3S $PINS O=n1255 I1=n1679 I2=n1 I3=n1253
XU62 ND3S $PINS O=n1351 I1=n1827 I2=n1815 I3=n1640
XU63 ND2S $PINS O=n1592 I1=n1812 I2=n113
XU64 ND2S $PINS O=n1576 I1=n995 I2=FE_OFN250_fold_n_0
XU65 ND2S $PINS O=n1009 I1=n993 I2=n112
XU66 ND2S $PINS O=n1030 I1=n997 I2=n113
XU67 ND2S $PINS O=n1814 I1=n999 I2=n113
XU68 ND3S $PINS O=n1640 I1=n_idx[1] I2=n111 I3=n1044
XU69 ND2S $PINS O=n1361 I1=n995 I2=FE_OFN249_fold_n_0
XU70 ND3S $PINS O=n1449 I1=n1025 I2=n111 I3=n1608
XU71 ND3S $PINS O=n1540 I1=n112 I2=n111 I3=n1044
XU72 ND2S $PINS O=n1131 I1=n1002 I2=n_idx[1]
XU73 ND3S $PINS O=n1318 I1=FE_OFN249_fold_n_0 I2=n1022 I3=n1025
XU74 ND3S $PINS O=n1368 I1=n1827 I2=n1815 I3=n1800
XU75 ND2S $PINS O=n1089 I1=n1002 I2=n112
XU76 ND3S $PINS O=n1237 I1=n1831 I2=n1815 I3=n1640
XU77 ND2S $PINS O=n1819 I1=n109 I2=FE_OFN249_fold_n_0
XU78 ND2S $PINS O=n1294 I1=n106 I2=FE_OFN249_fold_n_0
XU79 OA12S $PINS O=n1818 A1=n17 B1=n110 B2=n113
XU80 ND2S $PINS O=n1665 I1=n103 I2=FE_OFN249_fold_n_0
XU81 ND2S $PINS O=n1385 I1=n102 I2=FE_OFN249_fold_n_0
XU82 ND3S $PINS O=n1688 I1=n134 I2=n992 I3=n1817
XU83 ND2S $PINS O=n1796 I1=n1022 I2=n_idx[3]
XU84 ND3 $PINS O=n1724 I1=n996 I2=n113 I3=n_idx[4]
XU85 ND3S $PINS O=n1815 I1=n1697 I2=n_idx[1] I3=n1013
XU86 NR2 $PINS O=n1698 I1=n97 I2=n_idx[4]
XU87 ND3S $PINS O=n1489 I1=n1025 I2=n_idx[2] I3=n1608
XU88 ND3S $PINS O=n1204 I1=n_idx[1] I2=n_idx[2] I3=n1044
XU89 NR2 $PINS O=n1070 I1=n14 I2=k_idx[1]
XU90 ND3S $PINS O=n1694 I1=n112 I2=n111 I3=k_idx[0]
XU91 OR2S $PINS O=n1789 I1=n_idx[2] I2=n1608
XU92 AO12S $PINS O=n1689 A1=k_idx[0] B1=n113 B2=k_idx[2]
XU94 INV1S $PINS O=n36 I=n1504
XU95 NR2 $PINS O=n1588 I1=n69 I2=n1743
XU96 NR2 $PINS O=n1504 I1=n37 I2=n47
XU97 INV1S $PINS O=n66 I=n1194
XU98 INV1S $PINS O=n75 I=n1300
XU99 AN2 $PINS O=n1157 I1=n1503 I2=n1242
XU100 INV1S $PINS O=n20 I=n1510
XU102 INV1S $PINS O=n19 I=n1503
XU103 INV1S $PINS O=n31 I=n1567
XU104 INV1S $PINS O=n71 I=n1659
XU105 INV1S $PINS O=n59 I=n1759
XU106 INV1S $PINS O=n69 I=n1590
XU107 INV1S $PINS O=n34 I=n1364
XU108 INV1S $PINS O=n41 I=n1589
XU109 NR2 $PINS O=n1723 I1=n43 I2=n47
XU110 INV1S $PINS O=n47 I=n1485
XU112 INV1S $PINS O=n95 I=n1340
XU113 ND3 $PINS O=n1148 I1=n1382 I2=n1563 I3=n1344
XU114 INV1S $PINS O=n49 I=n1123
XU115 INV1S $PINS O=n18 I=n1209
XU116 INV1S $PINS O=n65 I=n1462
XU117 AN2 $PINS O=n1594 I1=n1591 I2=n1590
XU118 NR2 $PINS O=n1714 I1=n43 I2=n38
XU119 INV1S $PINS O=n42 I=n1447
XU120 NR2 $PINS O=n1595 I1=n38 I2=n42
XU121 INV1S $PINS O=n96 I=n1004
XU122 AN2 $PINS O=n1649 I1=n1180 I2=n1754
XU123 INV1S $PINS O=n22 I=n1241
XU124 AN2 $PINS O=n1357 I1=n1181 I2=n1659
XU125 INV1S $PINS O=n73 I=n1281
XU126 INV1S $PINS O=n68 I=n1352
XU127 NR2 $PINS O=n1780 I1=n126 I2=n125
XU128 INV1S $PINS O=n100 I=n1261
XU129 ND3 $PINS O=n1454 I1=n3 I2=n77 I3=n73
XU130 INV1S $PINS O=n44 I=n1511
XU132 NR2 $PINS O=n1740 I1=n126 I2=n122
XU133 NR2 $PINS O=n1300 I1=n7 I2=n1740
XU134 NR2 $PINS O=n1455 I1=n1410 I2=n1194
XU135 NR2 $PINS O=n1228 I1=n1148 I2=n1340
XU136 INV1S $PINS O=n30 I=n1158
XU137 NR2 $PINS O=n1168 I1=n1169 I2=n45
XU138 NR2 $PINS O=n1677 I1=n26 I2=n61
XU139 AN2 $PINS O=n1242 I1=n1509 I2=n1573
XU140 INV1S $PINS O=n55 I=n1578
XU141 NR2 $PINS O=n1498 I1=n92 I2=n94
XU142 NR2 $PINS O=n1101 I1=n88 I2=n1726
XU143 NR2 $PINS O=n1369 I1=n1726 I2=n33
XU144 NR2 $PINS O=n1510 I1=n21 I2=n25
XU145 NR2 $PINS O=n1503 I1=n20 I2=n23
XU146 ND3 $PINS O=shift3[2] I1=n1524 I2=n1523 I3=n1522
XU147 NR2 $PINS O=n1523 I1=n1501 I2=n1500
XU148 NR3 $PINS O=n1524 I1=n1481 I2=n1480 I3=n1479
XU149 AN4B1S $PINS O=n1522 I1=n1521 I2=n1520 I3=n1519 B1=n1518
XU150 INV1S $PINS O=n85 I=n1726
XU151 ND3 $PINS O=shift3[0] I1=n1440 I2=n1439 I3=n1438
XU152 NR3 $PINS O=n1440 I1=n1391 I2=n1390 I3=n1389
XU153 AN4B1S $PINS O=n1439 I1=n1403 I2=n1402 I3=n1401 B1=n1400
XU154 AN4B1S $PINS O=n1438 I1=n1437 I2=n1436 I3=n1435 B1=n1434
XU155 NR2 $PINS O=n1721 I1=n23 I2=n26
XU156 ND3 $PINS O=n1287 I1=n1628 I2=n1706 I3=n27
XU157 NR2 $PINS O=n1015 I1=n26 I2=n29
XU158 NR2 $PINS O=n1573 I1=n56 I2=n60
XU159 NR2 $PINS O=n1270 I1=n94 I2=n1597
XU160 NR2 $PINS O=n1485 I1=n53 I2=n48
XU161 NR3 $PINS O=n1572 I1=n53 I2=n50 I3=n33
XU162 NR2 $PINS O=n1335 I1=n35 I2=n26
XU163 NR2 $PINS O=n1567 I1=n91 I2=n35
XU164 NR2 $PINS O=n1173 I1=n1641 I2=n1279
XU165 ND3 $PINS O=n1571 I1=n27 I2=n1629 I3=n1562
XU166 NR2 $PINS O=n1275 I1=n35 I2=n55
XU167 AN2B1S $PINS O=n1659 I1=n1387 B1=n2
XU168 NR2 $PINS O=n1336 I1=n71 I2=n1671
XU169 AOI22S $PINS O=n1402 A1=n128 A2=n1396 B1=n337 B2=n1395
XU170 OAI112HS $PINS O=n1425 A1=n1421 B1=n1420 C1=n1422 C2=n1742
XU171 ND3 $PINS O=n1443 I1=n1428 I2=n1427 I3=n1426
XU172 NR2 $PINS O=n1428 I1=n1414 I2=n1413
XU173 NR3 $PINS O=n1426 I1=n1425 I2=n1424 I3=n1423
XU174 NR2 $PINS O=n1759 I1=n60 I2=n61
XU175 NR2 $PINS O=n1407 I1=n59 I2=n58
XU176 NR2 $PINS O=n1590 I1=n1417 I2=n1314
XU177 AN2 $PINS O=n1465 I1=n1578 I2=n1721
XU178 NR2 $PINS O=n1826 I1=n33 I2=n48
XU179 AOI22S $PINS O=n1734 A1=n417 A2=n1716 B1=n418 B2=n1715
XU180 ND3 $PINS O=n1715 I1=n1714 I2=n1713 I3=n1728
XU181 NR2 $PINS O=n1589 I1=n45 I2=n50
XU182 INV1S $PINS O=n101 I=n1802
XU183 INV1S $PINS O=n77 I=n1159
XU184 NR2 $PINS O=n1574 I1=n38 I2=n56
XU185 AOI22S $PINS O=n1012 A1=n26 A2=n132 B1=n125 B2=n1743
XU186 NR2 $PINS O=n1667 I1=n37 I2=n35
XU187 INV1S $PINS O=n38 I=n1827
XU188 INV1S $PINS O=n46 I=n1810
XU189 NR2 $PINS O=n1635 I1=n46 I2=n23
XU190 NR2 $PINS O=n1718 I1=n25 I2=n60
XU191 NR2 $PINS O=n1392 I1=n45 I2=n25
XU192 INV1S $PINS O=n130 I=n1741
XU193 NR2 $PINS O=n1675 I1=n2 I2=n1159
XU194 INV1S $PINS O=n67 I=n1314
XU195 INV1S $PINS O=n87 I=n1491
XU196 AOI13HS $PINS O=n1583 A1=n1765 B1=n1721 B2=n1573 B3=n1572
XU197 INV1S $PINS O=n39 I=n1487
XU198 INV1S $PINS O=n43 I=n1532
XU199 NR2 $PINS O=n1558 I1=n127 I2=n129
XU200 ND3 $PINS O=n1779 I1=n1558 I2=n1557 I3=n1556
XU201 NR2 $PINS O=n1556 I1=n131 I2=n120
XU202 NR2 $PINS O=n1340 I1=FE_OFN250_fold_n_0 I2=n98
XU203 NR2 $PINS O=n1652 I1=n1159 I2=n1397
XU204 NR2 $PINS O=n1123 I1=n50 I2=n60
XU205 AOI22S $PINS O=n1036 A1=n114 A2=n22 B1=n132 B2=n49
XU206 INV1S $PINS O=n79 I=n2
XU207 NR2 $PINS O=n1209 I1=n21 I2=n35
XU208 NR2 $PINS O=n1462 I1=n2 I2=n1397
XU209 NR2 $PINS O=n1158 I1=n38 I2=n35
XU210 AOI22S $PINS O=n1266 A1=n133 A2=n58 B1=n116 B2=n1671
XU211 INV1S $PINS O=n74 I=n1463
XU212 NR2 $PINS O=n1591 I1=n74 I2=n2
XU213 NR2 $PINS O=n1579 I1=n58 I2=n61
XU214 AOI22S $PINS O=n1553 A1=n2 A2=n122 B1=n48 B2=n137
XU215 NR2 $PINS O=n1261 I1=n101 I2=FE_OFN250_fold_n_0
XU216 NR2 $PINS O=n1344 I1=n1261 I2=n1405
XU217 NR2 $PINS O=n1632 I1=n78 I2=n1417
XU218 INV1S $PINS O=n78 I=n1422
XU219 NR3 $PINS O=n1781 I1=n1778 I2=n117 I3=n1777
XU220 INV1S $PINS O=n126 I=n1555
XU221 NR2 $PINS O=n1795 I1=n126 I2=n127
XU222 NR2 $PINS O=n1447 I1=n43 I2=n53
XU223 NR2 $PINS O=n1181 I1=n78 I2=n1671
XU224 INV1S $PINS O=n88 I=n1725
XU225 NR2 $PINS O=n1711 I1=n88 I2=n48
XU226 NR2 $PINS O=n1507 I1=n48 I2=n56
XU227 INV1S $PINS O=n123 I=n1676
XU228 NR2 $PINS O=n1241 I1=n48 I2=n23
XU229 MOAI1S $PINS O=n1265 A1=n1388 A2=n72 B1=n1671 B2=n125
XU230 OAI12HS $PINS O=n1096 A1=n128 B1=n1417 B2=n1397
XU231 NR2 $PINS O=n1317 I1=n21 I2=n26
XU232 INV1S $PINS O=n117 I=n1755
XU233 AOI22S $PINS O=n1140 A1=n131 A2=n1149 B1=n133 B2=n30
XU234 NR2 $PINS O=n1531 I1=n35 I2=n56
XU235 NR2 $PINS O=n1749 I1=n21 I2=n58
XU236 NR2 $PINS O=n1398 I1=n21 I2=n60
XU237 NR2 $PINS O=n1352 I1=n1159 I2=n1314
XU238 INV1S $PINS O=n417 I=n1630
XU239 NR2 $PINS O=n1764 I1=n1194 I2=n1671
XU240 NR2 $PINS O=n1508 I1=n43 I2=n50
XU241 NR2 $PINS O=n1332 I1=n127 I2=n125
XU242 ND3 $PINS O=n1281 I1=n81 I2=n79 I3=n1586
XU243 INV1S $PINS O=n116 I=n1557
XU244 MAOI1 $PINS O=n1445 A1=n122 A2=n1254 B1=n1632 B2=n1555
XU245 NR2 $PINS O=n1195 I1=n60 I2=n35
XU246 MOAI1S $PINS O=n1413 A1=n1412 A2=n3 B1=n68 B2=n120
XU247 INV1S $PINS O=n54 I=n1560
XU248 INV1S $PINS O=n99 I=n1225
XU249 INV1S $PINS O=n64 I=n1397
XU250 MOAI1S $PINS O=n1065 A1=n1764 A2=n1631 B1=n116 B2=n1254
XU251 INV1S $PINS O=n76 I=n1094
XU252 NR2 $PINS O=n1585 I1=n119 I2=n117
XU253 NR2 $PINS O=n1511 I1=n45 I2=n53
XU254 INV1S $PINS O=n122 I=n1388
XU255 ND3 $PINS O=n1410 I1=n1586 I2=n3 I3=n1652
XU256 AN2 $PINS O=n1477 I1=n1283 I2=n1282
XU257 AOI22S $PINS O=n1282 A1=n1314 A2=n116 B1=n1417 B2=n125
XU258 AOI22S $PINS O=n1283 A1=n117 A2=n1281 B1=n128 B2=n1410
XU259 INV1S $PINS O=n51 I=n1717
XU260 INV1S $PINS O=n128 I=n1631
XU261 NR2 $PINS O=n1653 I1=n1491 I2=n50
XU262 AOI22S $PINS O=n1562 A1=n137 A2=n23 B1=n133 B2=n60
XU263 NR2 $PINS O=n1088 I1=n116 I2=n129
XU264 NR2 $PINS O=n1394 I1=n65 I2=n1159
XU265 INV1S $PINS O=n108 I=n1405
XU266 INV1S $PINS O=n125 I=n1742
XU267 NR2 $PINS O=n1550 I1=n125 I2=n131
XU268 MOAI1S $PINS O=n1390 A1=n1388 A2=n1387 B1=n49 B2=n136
XU269 INV1S $PINS O=n337 I=n1765
XU270 ND2 $PINS O=n1382 I1=n106 I2=FE_OFN250_fold_n_0
XU271 NR2 $PINS O=n1263 I1=n1261 I2=n1260
XU272 INV1S $PINS O=n90 I=n1219
XU273 NR2 $PINS O=n1060 I1=n121 I2=n117
XU274 NR2 $PINS O=n1196 I1=n129 I2=n125
XU275 NR2 $PINS O=n1736 I1=n92 I2=n48
XU276 NR2 $PINS O=n1750 I1=n115 I2=n133
XU277 NR2 $PINS O=n1193 I1=n127 I2=n131
XU278 ND3 $PINS O=n1224 I1=n1382 I2=n1820 I3=n108
XU279 NR2 $PINS O=n1412 I1=n119 I2=n124
XU280 AOI22S $PINS O=n1436 A1=n1405 A2=n8 B1=n117 B2=n2
XU281 MOAI1S $PINS O=n1359 A1=n1659 A2=n1388 B1=n115 B2=n23
XU282 INV1S $PINS O=n118 I=n1777
XU283 NR2 $PINS O=n1458 I1=n50 I2=n86
XU284 NR2 $PINS O=n1059 I1=n61 I2=n50
XU285 NR2 $PINS O=n1542 I1=n419 I2=n418
XU286 NR2 $PINS O=n1543 I1=n38 I2=n61
XU287 NR2 $PINS O=n1792 I1=n122 I2=n121
XU288 INV1S $PINS O=n26 I=n1735
XU289 OAI222S $PINS O=n1163 A1=n1162 A2=n1761 B1=n1455 B2=n1161 C1=n1160
+ C2=n1748
XU290 NR2 $PINS O=n1161 I1=n128 I2=n1276
XU291 NR2 $PINS O=n1160 I1=n35 I2=n1166
XU292 NR2 $PINS O=n1162 I1=n51 I2=n1167
XU293 NR2 $PINS O=n1509 I1=n1121 I2=n58
XU294 INV1S $PINS O=n110 I=n1817
XU295 NR3 $PINS O=n1189 I1=n1152 I2=n1151 I3=n1150
XU296 NR3 $PINS O=n1187 I1=n1186 I2=n1185 I3=n1184
XU297 AN4B1S $PINS O=n1188 I1=n1165 I2=n1418 I3=n1164 B1=n1163
XU298 AOI22S $PINS O=n1178 A1=n337 A2=n1167 B1=n132 B2=n1166
XU299 AN4B1S $PINS O=n1772 I1=n1710 I2=n1709 I3=n1708 B1=n1707
XU300 OAI222S $PINS O=n1767 A1=n1766 A2=n1765 B1=n1764 B2=n1763 C1=n1762
+ C2=n1761
XU301 AN4B1S $PINS O=n1766 I1=n1810 I2=n1760 I3=n1759 B1=n1758
XU302 AN4B1S $PINS O=n1372 I1=n1728 I2=n1 I3=n63 B1=n1552
XU303 AN4B1S $PINS O=n1370 I1=n63 I2=n1485 I3=n1369 B1=n1368
XU304 AN4B1S $PINS O=n1371 I1=n1511 I2=n1660 I3=n1466 B1=n60
XU305 ND3 $PINS O=shift2[3] I1=n1381 I2=n1380 I3=n1379
XU306 NR2 $PINS O=n1380 I1=n1360 I2=n1359
XU307 AN4B1S $PINS O=n1379 I1=n1378 I2=n1377 I3=n1376 B1=n1375
XU308 NR3 $PINS O=n1683 I1=n1682 I2=n1681 I3=n1680
XU309 OAI222S $PINS O=n1680 A1=n1679 A2=n1678 B1=n1677 B2=n1676 C1=n1675
+ C2=n1741
XU310 ND3 $PINS O=n1681 I1=n1674 I2=n1673 I3=n1672
XU311 ND3 $PINS O=n1682 I1=n1663 I2=n1662 I3=n1661
XU312 NR3 $PINS O=n1657 I1=n1656 I2=n37 I3=n1655
XU313 ND3 $PINS O=n1656 I1=n1756 I2=n1654 I3=n1759
XU314 INV1S $PINS O=n56 I=n1757
XU315 NR2 $PINS O=n1578 I1=n62 I2=n56
XU316 NR3 $PINS O=n1174 I1=n1505 I2=n38 I3=n86
XU317 INV1S $PINS O=n24 I=n1350
XU318 INV1S $PINS O=n94 I=n1592
XU319 INV1S $PINS O=n98 I=n996
XU320 OAI112HS $PINS O=n1525 A1=n1266 B1=n1093 C1=n1784 C2=n28
XU321 AN4B1S $PINS O=n1097 I1=n1285 I2=n1096 I3=n1095 B1=n1460
XU322 AOI22S $PINS O=n1098 A1=n117 A2=n65 B1=n133 B2=n20
XU323 NR2 $PINS O=n1099 I1=n1094 I2=n1525
XU324 OAI222S $PINS O=n1152 A1=n1721 A2=n1676 B1=n1383 B2=n93 C1=n1157 C2=n1633
XU325 INV1S $PINS O=n21 I=n1577
XU326 AN4B1S $PINS O=n1514 I1=n1508 I2=n1507 I3=n1720 B1=n59
XU327 AN4B1S $PINS O=n1512 I1=n1511 I2=n1510 I3=n1509 B1=n37
XU328 AN4B1S $PINS O=n1408 I1=n85 I2=n89 I3=n1567 B1=n1497
XU329 ND3 $PINS O=n1406 I1=n1756 I2=n1831 I3=n1578
XU330 AN4B1S $PINS O=n1363 I1=n1508 I2=n1578 I3=n1720 B1=n23
XU331 AN4B1S $PINS O=n1362 I1=n1361 I2=n1827 I3=n1509 B1=n18
XU332 OAI22S $PINS O=n1246 A1=n1245 A2=n1830 B1=n1244 B2=n1761
XU333 AN4B1S $PINS O=n1245 I1=n1759 I2=n34 I3=n1317 B1=n47
XU334 ND3 $PINS O=shift2[1] I1=n1291 I2=n1290 I3=n1289
XU335 AN4B1S $PINS O=n1290 I1=n1252 I2=n75 I3=n1251 B1=n1250
XU336 NR3 $PINS O=n1289 I1=n1288 I2=n1287 I3=n1286
XU337 NR3 $PINS O=n1291 I1=n1248 I2=n1247 I3=n1246
XU338 OAI222S $PINS O=n1185 A1=n1357 A2=n1741 B1=n1179 B2=n1805 C1=n73 C2=n1557
XU339 NR3 $PINS O=n1179 I1=n1356 I2=n1560 I3=n37
XU340 AN4B1S $PINS O=n1055 I1=n1054 I2=n1053 I3=n1052 B1=n1051
XU341 AN4B1S $PINS O=n1056 I1=n1043 I2=n1042 I3=n1041 B1=n1040
XU342 AN4B1S $PINS O=n1000 I1=n1509 I2=n1760 I3=n1574 B1=n22
XU343 AN4B1S $PINS O=n1347 I1=n1346 I2=n1442 I3=n1345 B1=n1623
XU344 ND3 $PINS O=n1355 I1=n1528 I2=n1704 I3=n1478
XU345 INV1S $PINS O=n25 I=n1756
XU346 INV1S $PINS O=n97 I=n1227
XU347 NR2 $PINS O=n1014 I1=n1417 I2=n2
XU348 INV1S $PINS O=n29 I=n1720
XU349 NR2 $PINS O=n1038 I1=n1021 I2=n1020
XU350 AN4B1S $PINS O=n1037 I1=n1036 I2=n1035 I3=n1034 B1=n1033
XU351 AN4B1S $PINS O=n1039 I1=n1192 I2=n1018 I3=n1624 B1=n1309
XU352 NR3 $PINS O=n1086 I1=n1067 I2=n1066 I3=n1065
XU353 NR3 $PINS O=n1085 I1=n1084 I2=n1083 I3=n1082
XU354 AN4B1S $PINS O=n1087 I1=n1064 I2=n1345 I3=n1063 B1=n1310
XU355 OAI112HS $PINS O=n1481 A1=n1478 B1=n1477 C1=n1823 C2=n1827
XU356 MOAI1S $PINS O=n1126 A1=n1125 A2=n1678 B1=n136 B2=n1124
XU357 AN4B1S $PINS O=n1125 I1=n1578 I2=n1654 I3=n1398 B1=n1655
XU358 ND3 $PINS O=n1124 I1=n1635 I2=n1509 I3=n1123
XU359 ND3 $PINS O=shift1[2] I1=n1143 I2=n1142 I3=n1141
XU360 AN4B1S $PINS O=n1142 I1=n1120 I2=n1119 I3=n1118 B1=n1117
XU361 AN4B1S $PINS O=n1143 I1=n1445 I2=n1334 I3=n1191 B1=n1104
XU362 AN4B1S $PINS O=n1141 I1=n1140 I2=n1139 I3=n1138 B1=n1137
XU363 OAI112HS $PINS O=n1104 A1=n1704 B1=n1103 C1=n1358 C2=n1830
XU364 AOI22S $PINS O=n1103 A1=n419 A2=n1102 B1=n418 B2=n1373
XU365 ND3 $PINS O=n1102 I1=n1484 I2=n39 I3=n1100
XU366 NR3 $PINS O=n1100 I1=n46 I2=n94 I3=n88
XU367 MOAI1S $PINS O=n1247 A1=n1 A2=n1748 B1=n115 B2=n1243
XU368 ND3 $PINS O=n1243 I1=n1242 I2=n1577 I3=n1241
XU369 ND3 $PINS O=shift3[3] I1=n1549 I2=n1548 I3=n1547
XU370 NR2 $PINS O=n1548 I1=n1530 I2=n1529
XU371 NR3 $PINS O=n1547 I1=n1546 I2=n1545 I3=n1544
XU372 AN4B1S $PINS O=n1549 I1=n1528 I2=n1527 I3=n1526 B1=n1525
XU373 INV1S $PINS O=n61 I=n1576
XU374 OAI222S $PINS O=n1360 A1=n1358 A2=n1765 B1=n32 B2=n1805 C1=n1357 C2=n1741
XU375 INV1S $PINS O=n32 I=n1356
XU376 INV1S $PINS O=n53 I=n1668
XU377 AOI22S $PINS O=n1521 A1=n137 A2=n1506 B1=n417 B2=n1505
XU378 NR3 $PINS O=n1502 I1=n29 I2=n35 I3=n59
XU379 ND3 $PINS O=n1286 I1=n1477 I2=n1526 I3=n1421
XU380 MOAI1S $PINS O=n1375 A1=n1374 A2=n1729 B1=n1373 B2=n138
XU381 AN4B1S $PINS O=n1374 I1=n1 I2=n1498 I3=n87 B1=n44
XU382 OAI222S $PINS O=n1601 A1=n1600 A2=n1748 B1=n1599 B2=n1761 C1=n1598
+ C2=n1642
XU383 NR2 $PINS O=n1598 I1=n35 I2=n1597
XU384 NR2 $PINS O=n1600 I1=n52 I2=n18
XU385 NR2 $PINS O=n1599 I1=n1596 I2=n19
XU386 AN4B1S $PINS O=n1605 I1=n1604 I2=n1603 I3=n1602 B1=n1601
XU387 INV1S $PINS O=n35 I=n1831
XU388 NR2 $PINS O=n1366 I1=n129 I2=n126
XU389 NR2 $PINS O=n1367 I1=n1397 I2=n69
XU390 NR2 $PINS O=n1365 I1=n1364 I2=n19
XU391 NR2 $PINS O=n1484 I1=n31 I2=n83
XU392 NR2 $PINS O=n1023 I1=n47 I2=n1533
XU393 AOI22S $PINS O=n1119 A1=n429 A2=n1111 B1=n135 B2=n1110
XU394 ND3 $PINS O=n1111 I1=n1498 I2=n1728 I3=n1109
XU395 NR3 $PINS O=n1109 I1=n51 I2=n88 I3=n33
XU396 INV1S $PINS O=n72 I=n1559
XU397 MOAI1S $PINS O=n1117 A1=n1742 A2=n1764 B1=n138 B2=n1116
XU398 ND3 $PINS O=n1116 I1=n85 I2=n1532 I3=n1115
XU399 NR2 $PINS O=n1115 I1=n1486 I2=n1448
XU400 ND3 $PINS O=n1434 I1=n1433 I2=n1432 I3=n1431
XU401 AOI22S $PINS O=n1433 A1=n116 A2=n78 B1=n56 B2=n133
XU402 AOI22S $PINS O=n1432 A1=n125 A2=n71 B1=n129 B2=n1410
XU403 NR3 $PINS O=n1431 I1=n1430 I2=n1429 I3=n1443
XU404 ND3 $PINS O=n1641 I1=n1206 I2=n1589 I3=n1145
XU405 NR3 $PINS O=n1145 I1=n1215 I2=n94 I3=n53
XU406 INV1S $PINS O=n60 I=n1361
XU407 INV1S $PINS O=n27 I=n1280
XU408 MOAI1S $PINS O=n1277 A1=n28 A2=n1784 B1=n2 B2=n1276
XU409 OAI12HS $PINS O=n1278 A1=n1673 B1=n1275 B2=n1633
XU410 NR2 $PINS O=n1387 I1=n1559 I2=n1417
XU411 NR2 $PINS O=n1144 I1=n46 I2=n1533
XU412 NR2 $PINS O=n1586 I1=n1671 I2=n1559
XU413 OA22 $PINS O=n1095 A1=n67 A2=n1587 B1=n1666 B2=n1586
XU414 OAI112HS $PINS O=n1033 A1=n1031 B1=n1262 C1=n1032 C2=n1748
XU415 OAI12HS $PINS O=n1031 A1=n337 B1=n43 B2=n1634
XU416 NR2 $PINS O=n1032 I1=n29 I2=n44
XU417 OR2 $PINS O=n3 I1=n80 I2=n1773
XU418 INV1S $PINS O=n1417 I=n3
XU419 NR2 $PINS O=n1314 I1=n1131 I2=n80
XU420 ND3 $PINS O=shift3[1] I1=n1476 I2=n1475 I3=n1474
XU421 AN4B1S $PINS O=n1476 I1=n1446 I2=n1445 I3=n1444 B1=n1443
XU422 NR2 $PINS O=n1475 I1=n1457 I2=n1456
XU423 AN4B1S $PINS O=n1474 I1=n1473 I2=n1472 I3=n1471 B1=n1470
XU424 NR3 $PINS O=n1472 I1=n1461 I2=n1460 I3=n1459
XU425 AOI13HS $PINS O=n1461 A1=n1630 B1=n87 B2=n1801 B3=n39
XU426 OAI222S $PINS O=n1470 A1=n1469 A2=n1830 B1=n1468 B2=n1765 C1=n1467
+ C2=n1748
XU427 AN4B1S $PINS O=n1469 I1=n1574 I2=n1721 I3=n1510 B1=n42
XU428 AN4B1S $PINS O=n1467 I1=n1759 I2=n1466 I3=n1531 B1=n53
XU429 INV1S $PINS O=n23 I=n1814
XU430 INV1S $PINS O=n58 I=n1030
XU431 INV1S $PINS O=n92 I=n1538
XU432 NR3 $PINS O=n1629 I1=n4 I2=n5 I3=n6
XU433 OAI22S $PINS O=n4 A1=n64 A2=n1550 B1=n81 B2=n1739
XU434 AO22 $PINS O=n5 A1=n419 A2=n1552 B1=n133 B2=n1551
XU435 OAI112HS $PINS O=n6 A1=n1710 B1=n1561 C1=n1720 C2=n1748
XU436 INV1S $PINS O=n45 I=n1801
XU437 ND3 $PINS O=n1233 I1=n1223 I2=n1222 I3=n1221
XU438 AOI22S $PINS O=n1223 A1=n136 A2=n1639 B1=n418 B2=n1216
XU439 AOI22S $PINS O=n1222 A1=n114 A2=n1218 B1=n132 B2=n1217
XU440 ND3 $PINS O=shift2[0] I1=n1236 I2=n1235 I3=n1234
XU441 NR3 $PINS O=n1236 I1=n1203 I2=n1479 I3=n1202
XU442 NR3 $PINS O=n1235 I1=n1214 I2=n1213 I3=n1212
XU443 NR3 $PINS O=n1234 I1=n1233 I2=n1232 I3=n1231
XU444 NR2 $PINS O=n1608 I1=n113 I2=n112
XU445 NR2 $PINS O=n1159 I1=n80 I2=n101
XU446 NR2 $PINS O=n1802 I1=n112 I2=n1828
XU447 ND3 $PINS O=shift2[2] I1=n1331 I2=n1330 I3=n1329
XU448 AN4B1S $PINS O=n1329 I1=n1328 I2=n1327 I3=n1326 B1=n1325
XU449 NR3 $PINS O=n1331 I1=n1311 I2=n1310 I3=n1309
XU450 ND3 $PINS O=n1626 I1=n1306 I2=n1305 I3=n1304
XU451 AN4B1S $PINS O=n1304 I1=n1303 I2=n1302 I3=n1301 B1=n1300
XU452 INV1S $PINS O=n48 I=n1654
XU453 MOAI1S $PINS O=n1570 A1=n1569 A2=n1830 B1=n429 B2=n1568
XU454 ND3 $PINS O=n1568 I1=n1567 I2=n1800 I3=n1566
XU456 OR2 $PINS O=n7 I1=n80 I2=n1009
XU457 INV1S $PINS O=n1671 I=n7
XU458 ND3 $PINS O=n1203 I1=n1192 I2=n1191 I3=n1190
XU459 INV1S $PINS O=n89 I=n1215
XU460 ND3 $PINS O=n1769 I1=n1753 I2=n1752 I3=n1751
XU461 AOI22S $PINS O=n1753 A1=n136 A2=n1738 B1=n429 B2=n1737
XU462 AOI22S $PINS O=n1752 A1=n1745 A2=n69 B1=n1744 B2=n1743
XU463 AN2 $PINS O=n1747 I1=n89 I2=n1540
XU464 NR2 $PINS O=n1810 I1=n52 I2=n48
XU465 ND3 $PINS O=n1479 I1=n1200 I2=n1199 I3=n1198
XU466 OA22 $PINS O=n1200 A1=n77 A2=n1193 B1=n64 B2=n1557
XU467 AN2 $PINS O=n1420 I1=n1308 I2=n1307
XU468 AOI22S $PINS O=n1308 A1=n23 A2=n123 B1=n83 B2=n135
XU469 AOI22S $PINS O=n1419 A1=n1416 A2=n135 B1=n114 B2=n1415
XU470 MOAI1S $PINS O=n1644 A1=n1643 A2=n1642 B1=n1641 B2=n135
XU471 AN4B1S $PINS O=n1643 I1=n1 I2=n1640 I3=n1800 B1=n1639
XU472 NR2 $PINS O=n1460 I1=n1664 I2=n1563
XU473 AOI22S $PINS O=n1269 A1=n137 A2=n1259 B1=n126 B2=n1397
XU474 OA12 $PINS O=n1268 A1=n1262 B1=n1263 B2=n82
XU475 AOI22S $PINS O=n1733 A1=n132 A2=n1722 B1=n58 B2=n115
XU476 ND3 $PINS O=n1722 I1=n1721 I2=n1720 I3=n1719
XU477 MOAI1S $PINS O=n1213 A1=n1803 A2=n7 B1=n133 B2=n1208
XU478 ND3 $PINS O=n1712 I1=n1640 I2=n28 I3=n1756
XU479 NR2 $PINS O=n1532 I1=n45 I2=n52
XU480 MOAI1S $PINS O=n1423 A1=n1760 A2=n1823 B1=n71 B2=n116
XU481 OAI22S $PINS O=n1582 A1=n1581 A2=n1823 B1=n1580 B2=n1678
XU482 AN4B1S $PINS O=n1580 I1=n1579 I2=n1635 I3=n1578 B1=n38
XU483 AN4B1S $PINS O=n1581 I1=n1577 I2=n28 I3=n1576 B1=n1575
XU484 ND3 $PINS O=n1575 I1=n1721 I2=n1810 I3=n1574
XU485 INV1S $PINS O=n129 I=n1666
XU486 AOI22S $PINS O=n1561 A1=n417 A2=n1560 B1=n1559 B2=n1779
XU487 AOI22S $PINS O=n1437 A1=n135 A2=n33 B1=n115 B2=n1404
XU488 ND3 $PINS O=n1404 I1=n1759 I2=n1814 I3=n34
XU489 OA22 $PINS O=n1120 A1=n1108 A2=n1630 B1=n1107 B2=n1748
XU490 NR3 $PINS O=n1108 I1=n1105 I2=n1712 I3=n37
XU491 AN4B1S $PINS O=n1107 I1=n1106 I2=n1510 I3=n1335 B1=n49
XU492 ND3 $PINS O=n1105 I1=n1717 I2=n1735 I3=n1578
XU493 AN2 $PINS O=n1705 I1=n1296 I2=n1295
XU494 AOI22S $PINS O=n1296 A1=n117 A2=n1671 B1=n56 B2=n137
XU495 NR2 $PINS O=n1293 I1=n124 I2=n116
XU496 NR2 $PINS O=n1566 I1=n36 I2=n1482
XU497 ND3 $PINS O=n1051 I1=n1050 I2=n1673 I3=n1049
XU498 OAI12HS $PINS O=n1049 A1=n123 B1=n38 B2=n1121
XU499 INV1S $PINS O=n127 I=n1587
XU500 MOAI1S $PINS O=n1202 A1=n1590 A2=n1666 B1=n337 B2=n1201
XU501 ND3 $PINS O=n1201 I1=n1508 I2=n1721 I3=n1407
XU502 OAI222S $PINS O=n1500 A1=n1633 A2=n1756 B1=n1499 B2=n1746 C1=n1805
+ C2=n1640
XU503 AN4B1S $PINS O=n1499 I1=n1498 I2=n1831 I3=n90 B1=n1497
XU504 NR2 $PINS O=n1800 I1=n1215 I2=n83
XU505 OA22 $PINS O=n1346 A1=n1382 A2=n82 B1=n72 B2=n1557
XU506 AN4B1S $PINS O=n1220 I1=n1540 I2=n1567 I3=n1449 B1=n48
XU507 OAI112HS $PINS O=n1480 A1=n1183 B1=n1182 C1=n1336 C2=n1388
XU508 OA22 $PINS O=n1182 A1=n1555 A2=n1181 B1=n1786 B2=n1422
XU509 OA12 $PINS O=n1183 A1=n1285 B1=n1659 B2=n1799
XU510 NR2 $PINS O=n1713 I1=n1482 I2=n48
XU511 ND3 $PINS O=n1122 I1=n1385 I2=n97 I3=n1648
XU512 OAI22S $PINS O=n1094 A1=n1786 A2=n77 B1=n1799 B2=n79
XU513 NR2 $PINS O=n1679 I1=n18 I2=n62
XU514 NR2 $PINS O=n1397 I1=n80 I2=n1089
XU515 NR2 $PINS O=n1106 I1=n46 I2=n62
XU516 NR2 $PINS O=n1463 I1=n1559 I2=n1159
XU517 OA22 $PINS O=n1403 A1=n1393 A2=n1830 B1=n1555 B2=n81
XU518 AN4B1S $PINS O=n1393 I1=n1757 I2=n1720 I3=n1392 B1=n23
XU519 NR2 $PINS O=n1422 I1=n1159 I2=n1515
XU520 OAI222S $PINS O=n1501 A1=n1496 A2=n1642 B1=n1495 B2=n1494 C1=n1493
+ C2=n1729
XU521 NR3 $PINS O=n1495 I1=n1488 I2=n1487 I3=n1486
XU522 NR3 $PINS O=n1493 I1=n1492 I2=n1491 I3=n1490
XU523 INV1S $PINS O=n107 I=n1089
XU524 INV1S $PINS O=n103 I=n1009
XU525 NR3 $PINS O=n1006 I1=n1003 I2=n1776 I3=n1004
XU526 AN4B1S $PINS O=n1005 I1=n1294 I2=n1563 I3=n96 B1=n1788
XU527 ND3 $PINS O=n1003 I1=n1382 I2=n1563 I3=n100
XU528 NR2 $PINS O=n1319 I1=n1515 I2=n1417
XU529 AN2 $PINS O=n1321 I1=n1318 I2=n1458
XU530 AN2 $PINS O=n1320 I1=n1589 I2=n1507
XU531 OAI22S $PINS O=n1212 A1=n1211 A2=n1748 B1=n1210 B2=n1678
XU532 AN4B1S $PINS O=n1210 I1=n1398 I2=n1241 I3=n1578 B1=n37
XU533 AN4B1S $PINS O=n1211 I1=n1209 I2=n1574 I3=n1720 B1=n51
XU534 MOAI1S $PINS O=n1645 A1=n1638 A2=n1830 B1=n429 B2=n1637
XU535 AN4B1S $PINS O=n1638 I1=n1760 I2=n1635 I3=n1 B1=n1634
XU536 ND3 $PINS O=n1637 I1=n63 I2=n1723 I3=n1636
XU537 ND3 $PINS O=n1546 I1=n1537 I2=n1673 I3=n1536
XU538 AOI22S $PINS O=n1536 A1=n137 A2=n1535 B1=n429 B2=n1534
XU539 OR2 $PINS O=n1534 I1=n1533 I2=n52
XU540 OAI222S $PINS O=n1646 A1=n1633 A2=n1756 B1=n1632 B2=n1631 C1=n1757
+ C2=n1630
XU541 NR2 $PINS O=n1316 I1=n1314 I2=n1671
XU542 NR2 $PINS O=n1315 I1=n50 I2=n88
XU543 AN4B1S $PINS O=n1627 I1=n76 I2=n1625 I3=n1624 B1=n1623
XU544 OAI22S $PINS O=n1325 A1=n1324 A2=n1642 B1=n1323 B2=n1830
XU545 AN4B1S $PINS O=n1324 I1=n1747 I2=n1717 I3=n1760 B1=n86
XU546 NR3 $PINS O=n1323 I1=n1322 I2=n59 I3=n20
XU547 MOAI1S $PINS O=n1429 A1=n1664 A2=n1180 B1=n123 B2=n58
XU548 NR2 $PINS O=n1292 I1=n83 I2=n45
XU549 AOI22S $PINS O=n1672 A1=n1671 A2=n1670 B1=n337 B2=n1669
XU550 OAI222S $PINS O=n1232 A1=n1721 A2=n1676 B1=n67 B2=n1658 C1=n1388 C2=n3
XU551 OAI222S $PINS O=n1082 A1=n1081 A2=n1830 B1=n1080 B2=n1823 C1=n1079
+ C2=n1630
XU552 NR2 $PINS O=n1081 I1=n21 I2=n53
XU553 NR2 $PINS O=n1080 I1=n18 I2=n36
XU554 AN2 $PINS O=n1079 I1=n1449 I2=n1760
XU555 INV1S $PINS O=n133 I=n1633
XU556 INV1S $PINS O=n63 I=n1482
XU557 OAI222S $PINS O=n1021 A1=n1799 A2=n67 B1=n1387 B2=n1555 C1=n1352 C2=n1658
XU558 MOAI1S $PINS O=n1150 A1=n1228 A2=n1664 B1=n127 B2=n1149
XU559 ND2 $PINS O=n1630 I1=n1686 I2=n1029
XU560 ND2 $PINS O=n1742 I1=n1618 I2=n1048
XU561 NR3 $PINS O=n1636 I1=n91 I2=n92 I3=n1215
XU562 ND3 $PINS O=n1084 I1=n1074 I2=n1073 I3=n1072
XU563 AOI22S $PINS O=n1073 A1=n419 A2=n1069 B1=n8 B2=n1068
XU564 OAI222S $PINS O=n1768 A1=n1755 A2=n3 B1=n87 B2=n1805 C1=n93 C2=n1754
XU565 ND2 $PINS O=n1557 I1=n1071 I2=n1618
XU566 INV1S $PINS O=n81 I=n1515
XU567 MOAI1S $PINS O=n1400 A1=n1642 A2=n1566 B1=n138 B2=n1399
XU568 ND3 $PINS O=n1399 I1=n1723 I2=n1449 I3=n39
XU569 INV1S $PINS O=n102 I=n1773
XU570 AN2 $PINS O=n1383 I1=n1665 I2=n1464
XU571 OAI22S $PINS O=n1807 A1=n1806 A2=n1805 B1=n1804 B2=n1803
XU572 NR2 $PINS O=n1804 I1=n1802 I2=n107
XU573 AN4B1S $PINS O=n1806 I1=n1801 I2=n1827 I3=n1800 B1=n62
XU574 OAI222S $PINS O=n1391 A1=n82 A2=n100 B1=n1462 B2=n1739 C1=n1386 C2=n93
XU575 AN4B1S $PINS O=n1386 I1=n1385 I2=n97 I3=n1754 B1=n1384
XU576 ND3 $PINS O=n1384 I1=n1383 I2=n1382 I3=n99
XU577 OAI222S $PINS O=n1456 A1=n1455 A2=n1631 B1=n70 B2=n1755 C1=n1729 C2=n1592
XU578 INV1S $PINS O=n70 I=n1454
XU579 MOAI1S $PINS O=n1424 A1=n1664 A2=n100 B1=n1671 B2=n130
XU580 MOAI1S $PINS O=n1623 A1=n1344 A2=n1664 B1=n124 B2=n1417
XU581 NR2 $PINS O=n1717 I1=n53 I2=n52
XU582 AOI22S $PINS O=n1164 A1=n1156 A2=n1155 B1=n1154 B2=n1454
XU583 ND3 $PINS O=n1155 I1=n96 I2=n1294 I3=n1228
XU584 MOAI1S $PINS O=n1414 A1=n1558 A2=n67 B1=n419 B2=n1411
XU585 ND3 $PINS O=n1216 I1=n1800 I2=n1318 I3=n1447
XU586 ND2 $PINS O=n1388 I1=n1047 I2=n1019
XU587 INV1S $PINS O=n91 I=n1318
XU588 INV1S $PINS O=n106 I=n1131
XU589 ND3 $PINS O=n1450 I1=n1532 I2=n1449 I3=n1711
XU590 OAI222S $PINS O=n1067 A1=n1632 A2=n1742 B1=n1590 B2=n1786 C1=n1748
+ C2=n1576
XU591 OA22 $PINS O=n1564 A1=n93 A2=n1563 B1=n1658 B2=n79
XU592 AOI22S $PINS O=n1565 A1=n120 A2=n1671 B1=n129 B2=n69
XU593 OAI112HS $PINS O=n1518 A1=n1516 B1=n1554 C1=n1517 C2=n1741
XU594 OAI12HS $PINS O=n1516 A1=n129 B1=n1515 B2=n1743
XU595 ND2 $PINS O=n1631 I1=n1075 I2=n1019
XU596 OA22 $PINS O=n1662 A1=n1746 A2=n1653 B1=n1755 B2=n1652
XU597 MOAI1S $PINS O=n1020 A1=n93 A2=n1819 B1=n123 B2=n58
XU598 INV1S $PINS O=n131 I=n1763
XU599 AOI22S $PINS O=n1192 A1=n132 A2=n52 B1=n1671 B2=n117
XU600 INV1S $PINS O=n120 I=n1739
XU601 ND3 $PINS O=n1776 I1=n1385 I2=n1820 I3=n1383
XU602 OAI222S $PINS O=n1584 A1=n7 A2=n1763 B1=n1803 B2=n72 C1=n1 C2=n1630
XU603 OA22 $PINS O=n1401 A1=n1741 A2=n1517 B1=n1761 B2=n1398
XU604 NR2 $PINS O=n1405 I1=n1089 I2=FE_OFN250_fold_n_0
XU605 MOAI1S $PINS O=n1389 A1=n1463 A2=n1763 B1=n31 B2=n419
XU606 OAI222S $PINS O=n1231 A1=n1230 A2=n93 B1=n1229 B2=n82 C1=n1664 C2=n1382
XU607 NR3 $PINS O=n1230 I1=n1226 I2=n1225 I3=n1224
XU608 AN4B1S $PINS O=n1229 I1=n1464 I2=n1228 I3=n1754 B1=n1227
XU609 ND3 $PINS O=n1226 I1=n1819 I2=n97 I3=n1464
XU610 ND2 $PINS O=n1765 I1=n1686 I2=n1691
XU611 INV1S $PINS O=n137 I=n1748
XU612 OA22 $PINS O=n1334 A1=n1587 A2=n64 B1=n1344 B2=n82
XU613 NR2 $PINS O=n1728 I1=n83 I2=n91
XU614 INV1S $PINS O=n419 I=n1805
XU615 ND3 $PINS O=n1310 I1=n1062 I2=n1441 I3=n1061
XU616 AOI22S $PINS O=n1062 A1=n127 A2=n1159 B1=n417 B2=n92
XU617 INV1S $PINS O=n84 I=n1490
XU618 MOAI1S $PINS O=n1250 A1=n1249 A2=n1494 B1=n30 B2=n417
XU619 NR2 $PINS O=n1249 I1=n51 I2=n1491
XU620 OA22 $PINS O=n1732 A1=n93 A2=n1464 B1=n1803 B2=n67
XU621 INV1S $PINS O=n429 I=n1494
XU622 INV1S $PINS O=n124 I=n1803
XU623 INV1S $PINS O=n114 I=n1761
XU624 NR2 $PINS O=n1338 I1=n1515 I2=n1671
XU625 NR2 $PINS O=n1132 I1=n109 I2=n103
XU626 INV1S $PINS O=n119 I=n1658
XU627 INV1S $PINS O=n135 I=n1729
XU628 INV1S $PINS O=n86 I=n1640
XU629 NR2 $PINS O=n1517 I1=n1559 I2=n1397
XU630 OA22 $PINS O=n1441 A1=n93 A2=n1385 B1=n82 B2=n1294
XU631 INV1S $PINS O=n115 I=n1678
XU632 OAI22S $PINS O=n1544 A1=n1543 A2=n1765 B1=n1592 B2=n1542
XU633 MOAI1S $PINS O=n1529 A1=n1746 A2=n1640 B1=n133 B2=n21
XU634 MOAI1S $PINS O=n1066 A1=n79 A2=n1587 B1=n1671 B2=n130
XU635 OR2 $PINS O=n1018 I1=n1630 I2=n1540
XU636 MOAI1S $PINS O=n1545 A1=n1541 A2=n1540 B1=n135 B2=n1539
XU637 NR2 $PINS O=n1541 I1=n138 I2=n419
XU638 AOI22S $PINS O=n1835 A1=n123 A2=n1809 B1=n122 B2=n107
XU639 INV1S $PINS O=n890 I=n1691
XU640 INV1S $PINS O=n132 I=n1830
XU641 MOAI1S $PINS O=n1530 A1=n1763 A2=n81 B1=n46 B2=n419
XU642 INV1S $PINS O=n418 I=n1642
XU643 INV1S $PINS O=n138 I=n1746
XU644 INV1S $PINS O=n991 I=n1029
XU645 ND3 $PINS O=n1153 I1=n1132 I2=n1131 I3=n1130
XU646 NR2 $PINS O=n1130 I1=n1817 I2=n102
XU647 INV1S $PINS O=n121 I=n1799
XU648 INV1S $PINS O=n136 I=n1823
XU649 NR2 $PINS O=n1611 I1=n1828 I2=n890
XU650 NR2 $PINS O=n1817 I1=n112 I2=n1774
XU651 NR2 $PINS O=n1022 I1=n111 I2=n_idx[1]
XU652 NR2 $PINS O=n1171 I1=n1698 I2=n25
XU653 NR3 $PINS O=n1170 I1=n1219 I2=n55 I3=n41
XU654 ND3 $PINS O=n1505 I1=n1815 I2=n1538 I3=n1172
XU655 AN2 $PINS O=n1172 I1=n1335 I2=n24
XU656 NR2 $PINS O=n996 I1=n1828 I2=n_idx[1]
XU657 AN4B1S $PINS O=n1175 I1=n1318 I2=n1815 I3=n1760 B1=n1373
XU658 OAI222S $PINS O=n1248 A1=n1240 A2=n1729 B1=n1239 B2=n1642 C1=n1238
+ C2=n1746
XU659 AN4B1S $PINS O=n1240 I1=n85 I2=n1800 I3=n1504 B1=n1237
XU660 AN4B1S $PINS O=n1239 I1=n89 I2=n1369 I3=n1653 B1=n52
XU661 AN4B1S $PINS O=n1238 I1=n1318 I2=n1489 I3=n1369 B1=n1486
XU663 NR2 $PINS O=n1720 I1=n1698 I2=n58
XU664 OAI112HS $PINS O=n1040 A1=n1190 B1=n1063 C1=n1729 C2=n1204
XU665 NR2 $PINS O=n1227 I1=n98 I2=FE_OFN249_fold_n_0
XU666 AN2 $PINS O=n1442 I1=n1343 I2=n1342
XU667 AOI22S $PINS O=n1343 A1=n1340 A2=n1339 B1=n26 B2=n123
XU668 AOI22S $PINS O=n1342 A1=n1651 A2=n1341 B1=n115 B2=n20
XU669 ND3 $PINS O=n1341 I1=n1563 I2=n95 I3=n108
XU670 AN4B1S $PINS O=n1138 I1=n1129 I2=n1128 I3=n1127 B1=n1126
XU671 AOI22S $PINS O=n1129 A1=n130 A2=n65 B1=n1417 B2=n116
XU672 AOI22S $PINS O=n1127 A1=n1651 A2=n1122 B1=n119 B2=n1671
XU673 AOI22S $PINS O=n1128 A1=n123 A2=n1121 B1=n129 B2=n1314
XU674 OAI22S $PINS O=n1731 A1=n1821 A2=n28 B1=n1730 B2=n1729
XU675 ND3 $PINS O=n1727 I1=n1725 I2=n1724 I3=n1723
XU676 NR3 $PINS O=n998 I1=n112 I2=n111 I3=n40
XU677 INV1S $PINS O=n40 I=n1697
XU678 NR2 $PINS O=n1559 I1=n80 I2=n1796
XU679 OAI22S $PINS O=n1430 A1=n1354 A2=n1630 B1=n1353 B2=n1755
XU680 NR2 $PINS O=n1353 I1=n1559 I2=n68
XU681 NR3 $PINS O=n1354 I1=n1351 I2=n26 I3=n1350
XU682 NR2 $PINS O=n1466 I1=n20 I2=n1698
XU683 INV1S $PINS O=n80 I=n1783
XU684 AN4B1S $PINS O=n1008 I1=n1725 I2=n1538 I3=n1572 B1=n1482
XU685 INV1S $PINS O=n28 I=n1698
XU686 OAI222S $PINS O=n1457 A1=n1453 A2=n1642 B1=n1452 B2=n1494 C1=n1451
+ C2=n1746
XU687 NR3 $PINS O=n1453 I1=n1448 I2=n1491 I3=n42
XU688 AN4B1S $PINS O=n1452 I1=n1489 I2=n1538 I3=n1540 B1=n1596
XU689 AN2 $PINS O=n1044 I1=n1025 I2=n113
XU690 NR3 $PINS O=n1253 I1=n59 I2=n1698 I3=n53
XU691 ND3 $PINS O=n1288 I1=n1258 I2=n1257 I3=n1256
XU692 AOI22S $PINS O=n1258 A1=n120 A2=n71 B1=n131 B2=n78
XU693 AOI22S $PINS O=n1257 A1=n337 A2=n1255 B1=n124 B2=n1254
XU694 ND3 $PINS O=n1811 I1=n1697 I2=n111 I3=n1608
XU695 OAI22S $PINS O=n1151 A1=n1147 A2=n1642 B1=n1146 B2=n1494
XU696 NR2 $PINS O=n1147 I1=n1486 I2=n1641
XU697 AN2 $PINS O=n1146 I1=n1724 I2=n1173
XU698 OAI222S $PINS O=n1214 A1=n1207 A2=n1494 B1=n24 B2=n1630 C1=n1206 C2=n1746
XU699 NR3 $PINS O=n1207 I1=n1205 I2=n41 I3=n1486
XU700 ND3 $PINS O=n1205 I1=n1489 I2=n1204 I3=n1736
XU701 AOI22S $PINS O=n1118 A1=n337 A2=n1114 B1=n114 B2=n1113
XU702 ND3 $PINS O=n1113 I1=n34 I2=n1361 I3=n1466
XU703 ND3 $PINS O=n1114 I1=n1543 I2=n1465 I3=n1112
XU704 NR3 $PINS O=n1112 I1=n18 I2=n1698 I3=n51
XU705 INV1S $PINS O=n52 I=n1815
XU706 NR2 $PINS O=n1618 I1=n992 I2=n14
XU707 AN2 $PINS O=n1686 I1=n1690 I2=n992
XU708 AN2 $PINS O=n8 I1=n1791 I2=n17
XU709 INV1S $PINS O=n1664 I=n8
XU710 AOI22S $PINS O=n1663 A1=n127 A2=n65 B1=n1651 B2=n1650
XU711 ND3 $PINS O=n1650 I1=n1649 I2=n1648 I3=n1647
XU712 AN2 $PINS O=n1647 I1=n1819 I2=n1665
XU713 AN4B1S $PINS O=n1822 I1=n1820 I2=n1819 I3=n1818 B1=n1817
XU714 NR3 $PINS O=n1824 I1=n1816 I2=n21 I3=n47
XU715 ND3 $PINS O=n1816 I1=n1815 I2=n28 I3=n1814
XU716 ND3 $PINS O=sign3[1] I1=n1838 I2=n1837 I3=n1836
XU717 NR2 $PINS O=n1837 I1=n1808 I2=n1807
XU718 NR2 $PINS O=n1838 I1=n1794 I2=n1793
XU719 AN4B1S $PINS O=n1836 I1=n1835 I2=n1834 I3=n1833 B1=n1832
XU720 AOI22S $PINS O=n1034 A1=n429 A2=n1027 B1=n135 B2=n1026
XU721 ND3 $PINS O=n1633 I1=n1691 I2=n134 I3=n1618
XU722 ND3 $PINS O=n1492 I1=n1489 I2=n1592 I3=n1723
XU723 OAI222S $PINS O=n1794 A1=n1787 A2=n1786 B1=n1785 B2=n1784 C1=n1783
+ C2=n1782
XU724 AN2 $PINS O=n1787 I1=n1774 I2=n1773
XU725 NR2 $PINS O=n1785 I1=n1776 I2=n1775
XU726 AN2 $PINS O=n1782 I1=n1792 I2=n1825
XU727 NR2 $PINS O=n1019 I1=n992 I2=k_idx[2]
XU728 ND3 $PINS O=n1083 I1=n75 I2=n1673 I3=n1078
XU729 AOI22S $PINS O=n1078 A1=n1339 A2=n1077 B1=n1559 B2=n1076
XU730 INV1S $PINS O=n83 I=n1204
XU731 INV1S $PINS O=n109 I=n1796
XU732 NR2 $PINS O=n1045 I1=n114 I2=n418
XU733 INV1S $PINS O=n105 I=n1224
XU734 AN2 $PINS O=n1046 I1=n1577 I2=n1635
XU735 OA12 $PINS O=n1515 A1=n1783 B1=n106 B2=n107
XU736 ND3 $PINS O=n1746 I1=k_idx[3] I2=n16 I3=n1686
XU737 AOI22S $PINS O=n1302 A1=n337 A2=n1299 B1=n419 B2=n1298
XU738 AN2 $PINS O=n1708 I1=n1058 I2=n1057
XU739 AOI22S $PINS O=n1058 A1=n1651 A2=n1340 B1=n25 B2=n115
XU740 NR2 $PINS O=n1699 I1=n992 I2=n890
XU741 OAI112HS $PINS O=n1700 A1=n1688 B1=n1687 C1=k_idx[2] C2=n1774
XU742 ND2 $PINS O=n1763 I1=n1075 I2=n1609
XU743 ND3 $PINS O=n1821 I1=n1070 I2=n15 I3=n1024
XU744 INV1S $PINS O=n93 I=n1651
XU745 ND3 $PINS O=n1784 I1=n15 I2=n16 I3=n1028
XU746 INV1S $PINS O=n82 I=n1339
XU747 OA22 $PINS O=n1191 A1=n1092 A2=n80 B1=n99 B2=n1664
XU748 NR2 $PINS O=n1092 I1=n1091 I2=n1090
XU749 OAI222S $PINS O=n1090 A1=n110 A2=n1658 B1=n1412 B2=n1773 C1=n1799
+ C2=n1796
XU750 OAI222S $PINS O=n1091 A1=n118 A2=n1089 B1=n1088 B2=n101 C1=n1132 C2=n1587
XU751 ND2 $PINS O=n1739 I1=n1071 I2=n1070
XU752 ND3 $PINS O=n1805 I1=n1618 I2=n15 I3=n1024
XU753 ND3 $PINS O=n1494 I1=n1618 I2=k_idx[3] I3=n1024
XU754 ND2 $PINS O=n1748 I1=n1029 I2=n1028
XU755 ND3 $PINS O=n1761 I1=n1618 I2=n134 I3=n1029
XU756 ND3 $PINS O=n1137 I1=n1136 I2=n1262 I3=n1135
XU757 ND3 $PINS O=n1136 I1=n1783 I2=n1153 I3=n120
XU758 AOI22S $PINS O=n1135 A1=n8 A2=n1134 B1=n117 B2=n1133
XU759 ND2 $PINS O=n1803 I1=n1609 I2=n1047
XU760 ND2 $PINS O=n1658 I1=n1071 I2=n1609
XU761 AOI22S $PINS O=n1139 A1=n74 A2=n1778 B1=n1339 B2=n1788
XU762 ND3 $PINS O=n1729 I1=k_idx[3] I2=n16 I3=n1028
XU763 ND2 $PINS O=n1786 I1=n1609 I2=n1048
XU764 ND3 $PINS O=n1678 I1=n1070 I2=n134 I3=n1691
XU765 ND2 $PINS O=n1823 I1=n1028 I2=n1691
XU766 ND2 $PINS O=n1799 I1=n1047 I2=n1070
XU767 AOI22S $PINS O=n1834 A1=n115 A2=n1813 B1=n418 B2=n92
XU768 NR2 $PINS O=n1691 I1=n16 I2=n15
XU769 NR2 $PINS O=n1047 I1=n890 I2=n134
XU770 ND3 $PINS O=n1830 I1=n1070 I2=n134 I3=n1029
XU771 OAI12HS $PINS O=n1701 A1=n1797 B1=n134 B2=n1621
XU772 OA22 $PINS O=n1619 A1=n17 A2=n1618 B1=n98 B2=n1691
XU773 ND3 $PINS O=n1622 I1=n1617 I2=n1616 I3=n1615
XU774 ND3 $PINS O=n1617 I1=n1789 I2=n890 I3=n1610
XU775 ND3 $PINS O=n1616 I1=n1612 I2=n17 I3=n1611
XU781 ND3 $PINS O=n1642 I1=k_idx[3] I2=n1070 I3=n1024
XU786 OAI112HS $PINS O=n1775 A1=n110 B1=n17 C1=n1774 C2=n113
XU793 NR2 $PINS O=n1029 I1=n16 I2=k_idx[3]
XU808 NR2 $PINS O=n1071 I1=n991 I2=n134
XU809 AN2 $PINS O=n1075 I1=k_idx[3] I2=n1010
XU832 AN2 $PINS O=n1048 I1=n1010 I2=n15
XU846 ND3 $PINS O=n1165 I1=n124 I2=n1153 I3=n1783
XU878 NR2 $PINS O=n994 I1=n110 I2=n_idx[4]
XU882 ND3 $PINS O=sign3[0] I1=n1772 I2=n1771 I3=n1770
XU893 AN4B1S $PINS O=n1771 I1=n1734 I2=n1733 I3=n1732 B1=n1731
XU907 NR3 $PINS O=n1770 I1=n1769 I2=n1768 I3=n1767
XU914 ND3 $PINS O=sign2[0] I1=n1685 I2=n1684 I3=n1683
XU918 NR3 $PINS O=n1684 I1=n1646 I2=n1645 I3=n1644
XU921 AN4B1S $PINS O=n1685 I1=n1629 I2=n1628 I3=n1627 B1=n1626
XU922 NR2 $PINS O=n997 I1=n1796 I2=n_idx[4]
XU938 NR2 $PINS O=n1812 I1=n98 I2=n_idx[4]
XU946 INV1S $PINS O=n104 I=n_idx[3]
XU952 INV1S $PINS O=n111 I=n_idx[2]
XU953 NR2 $PINS O=n999 I1=n1773 I2=n_idx[4]
XU959 NR2 $PINS O=n993 I1=n104 I2=n_idx[2]
XU964 NR2 $PINS O=n995 I1=n1009 I2=n_idx[4]
XU965 NR3 $PINS O=n1007 I1=n_idx[1] I2=n_idx[2] I3=n113
XU966 ND3 $PINS O=sign1[0] I1=n1607 I2=n1606 I3=n1605
XU967 NR3 $PINS O=n1606 I1=n1584 I2=n1583 I3=n1582
XU969 NR3 $PINS O=n1607 I1=n1571 I2=n1707 I3=n1570
XU975 NR2 $PINS O=n1783 I1=FE_OFN249_fold_n_0 I2=n_idx[4]
XU978 NR2 $PINS O=n1025 I1=n104 I2=n_idx[4]
XU980 NR2 $PINS O=n1013 I1=n_idx[2] I2=FE_OFN249_fold_n_0
XU981 INV1S $PINS O=n992 I=k_idx[1]
XU982 NR2 $PINS O=n1002 I1=n111 I2=n_idx[3]
XU984 MOAI1S $PINS O=n1832 A1=n1831 A2=n1830 B1=n133 B2=n1829
XU985 OAI112HS $PINS O=n1829 A1=n1827 B1=n1826 C1=n_idx[4] C2=n1828
XU986 NR2 $PINS O=n1609 I1=k_idx[2] I2=k_idx[1]
XU988 NR2 $PINS O=n1651 I1=n1821 I2=n_idx[4]
XU989 NR2 $PINS O=n1339 I1=n1784 I2=n_idx[4]
XU991 AN2 $PINS O=n1028 I1=n1690 I2=k_idx[1]
XU992 MOAI1S $PINS O=n1793 A1=n1792 A2=n1828 B1=n1791 B2=n1790
XU993 OAI112HS $PINS O=n1808 A1=n1798 B1=n1797 C1=n_idx[3] C2=n1799
XU994 OAI112HS $PINS O=n1696 A1=n1694 B1=n1693 C1=n1695 C2=n1789
XU995 AOI13HS $PINS O=n1693 A1=n123 B1=k_idx[1] B2=n1692 B3=n1691
XU996 MOAI1S $PINS O=n1692 A1=n_idx[2] A2=n1690 B1=n1689 B2=n112
XU997 INV1S $PINS O=n17 I=n_idx[4]
XU999 INV1S $PINS O=n16 I=k_idx[4]
XU1000 INV1S $PINS O=n15 I=k_idx[3]
XU1001 AOI13HS $PINS O=n1687 A1=n_idx[4] B1=n_idx[1] B2=n_idx[3] B3=n1686
XU1002 NR2 $PINS O=n1690 I1=k_idx[2] I2=k_idx[0]
XU1003 AOI22S $PINS O=n1615 A1=n1614 A2=n890 B1=n1812 B2=n1613
XU1004 MOAI1S $PINS O=n1614 A1=k_idx[1] A2=n1818 B1=n14 B2=n1775
XU1005 INV1S $PINS O=n14 I=k_idx[2]
XU1006 INV1S $PINS O=n134 I=k_idx[0]
XU1007 NR2 $PINS O=n1010 I1=n134 I2=k_idx[4]
XU1008 NR2 $PINS O=n1024 I1=k_idx[4] I2=k_idx[0]
XU1009 AN2 $PINS O=n1610 I1=n_idx[3] I2=n1609
XU1010 MOAI1S $PINS O=n1612 A1=n1690 A2=n992 B1=k_idx[0] B2=k_idx[2]
XU1011 OA12 $PINS O=n1703 A1=n991 B1=k_idx[4] B2=n15
XU131 AN4S $PINS O=n1569 I1=n1757 I2=n1577 I3=n1572 I4=n1579
.ENDS

.SUBCKT SNPS_CLOCK_GATE_HIGH_ROM_Wrapper_Even_0 EN ENCLK CLK
*.CONNECT net2346 EN
XFE_PHC1356_net2349 DELC $PINS O=FE_PHN1356_net2349 I=net2349
Xlatch QDBHN $PINS Q=net2349 D=net2346 CKB=CLK
Xmain_gate AN2T $PINS O=ENCLK I1=FE_PHN1356_net2349 I2=CLK
.ENDS

.SUBCKT ROM_Wrapper_Even_0 rst_n en n_in[4] n_in[3] n_in[2] n_in[1] n_in[0]
+ k_idx[4] k_idx[3] k_idx[2] k_idx[1] k_idx[0] reg_sign1[1] reg_sign1[0]
+ reg_sign2[1] reg_sign2[0] reg_sign3[1] reg_sign3[0] reg_shift1[3]
+ reg_shift1[2] reg_shift1[1] reg_shift1[0] reg_shift2[3] reg_shift2[2]
+ reg_shift2[1] reg_shift2[0] reg_shift3[3] reg_shift3[2] reg_shift3[1]
+ reg_shift3[0] i_rst_n FE_OFN1_i_rst_n FE_OFN148_rom_n_idx_3__3 clk
*.CONNECT N4 n_in[0]
XCTS_ccl_a_INV_CLK_G1_L10_2 INV3CK $PINS O=CTS_10 I=CTS_11
XCTS_ccl_a_INV_CLK_G1_L9_2 INV2CK $PINS O=CTS_11 I=CTS_12
Xreg_sign1_reg[1] DFFSBN $PINS Q=reg_sign1[1] D=raw_s1[1] CK=CTS_10
+ SB=FE_OFN1_i_rst_n
Xreg_sign2_reg[1] DFFSBN $PINS Q=reg_sign2[1] D=raw_s2[1] CK=CTS_10
+ SB=FE_OFN1_i_rst_n
Xreg_sign3_reg[1] DFFSBN $PINS Q=reg_sign3[1] D=raw_s3[1] CK=CTS_10
+ SB=FE_OFN1_i_rst_n
Xreg_shift1_reg[1] QDFFRBN $PINS Q=reg_shift1[1] D=raw_h1[1] CK=CTS_10
+ RB=FE_OFN1_i_rst_n
Xreg_shift3_reg[1] QDFFRBN $PINS Q=reg_shift3[1] D=raw_h3[1] CK=CTS_10
+ RB=i_rst_n
Xreg_shift2_reg[1] QDFFRBN $PINS Q=reg_shift2[1] D=raw_h2[1] CK=CTS_10
+ RB=FE_OFN1_i_rst_n
Xreg_shift1_reg[0] QDFFRBN $PINS Q=reg_shift1[0] D=raw_h1[0] CK=CTS_10
+ RB=FE_OFN1_i_rst_n
Xreg_shift1_reg[2] QDFFRBN $PINS Q=reg_shift1[2] D=raw_h1[2] CK=CTS_10
+ RB=i_rst_n
Xreg_shift1_reg[3] QDFFRBP $PINS Q=reg_shift1[3] D=raw_h1[3] CK=CTS_10
+ RB=i_rst_n
Xreg_shift2_reg[0] QDFFRBP $PINS Q=reg_shift2[0] D=raw_h2[0] CK=CTS_10
+ RB=FE_OFN1_i_rst_n
Xreg_shift3_reg[2] QDFFRBN $PINS Q=reg_shift3[2] D=raw_h3[2] CK=CTS_10
+ RB=i_rst_n
Xreg_shift2_reg[2] QDFFRBN $PINS Q=reg_shift2[2] D=raw_h2[2] CK=CTS_10
+ RB=FE_OFN1_i_rst_n
Xreg_shift2_reg[3] QDFFRBN $PINS Q=reg_shift2[3] D=raw_h2[3] CK=CTS_10
+ RB=i_rst_n
Xreg_sign2_reg[0] QDFFRBP $PINS Q=reg_sign2[0] D=final_s2[0] CK=CTS_10
+ RB=FE_OFN1_i_rst_n
Xreg_sign1_reg[0] QDFFRBN $PINS Q=reg_sign1[0] D=final_s1[0] CK=CTS_10
+ RB=FE_OFN1_i_rst_n
Xreg_shift3_reg[3] QDFFRBP $PINS Q=reg_shift3[3] D=raw_h3[3] CK=CTS_10
+ RB=FE_OFN1_i_rst_n
Xreg_shift3_reg[0] QDFFRBN $PINS Q=reg_shift3[0] D=raw_h3[0] CK=CTS_10
+ RB=FE_OFN1_i_rst_n
Xreg_sign3_reg[0] QDFFRBN $PINS Q=reg_sign3[0] D=final_s3[0] CK=CTS_10
+ RB=FE_OFN1_i_rst_n
XU3 MOAI1 $PINS O=fold_n[4] A1=n7 A2=N2 B1=N8 B2=N2
XU4 AN2S $PINS O=sub_79/carry[2] I1=n9 I2=n8
XU5 AN2S $PINS O=sub_79/carry[3] I1=sub_79/carry[2] I2=n5
XU6 AN2S $PINS O=sub_79/carry[4] I1=sub_79/carry[3] I2=n6
XU7 ND3S $PINS O=n10 I1=N2 I2=n11 I3=k_idx[0]
XU10 INV1S $PINS O=n8 I=n_in[1]
XU11 XNR2HS $PINS O=final_s3[0] I1=raw_s3[0] I2=n10
XU12 MOAI1 $PINS O=fold_n[1] A1=n8 A2=N2 B1=N5 B2=N2
XU13 XNR2HS $PINS O=final_s2[0] I1=raw_s2[0] I2=n10
XU14 INV1S $PINS O=n9 I=N4
XU15 MOAI1S $PINS O=fold_n[0] A1=n9 A2=N2 B1=N4 B2=N2
XU16 XNR2HS $PINS O=final_s1[0] I1=raw_s1[0] I2=n10
XU17 MOAI1 $PINS O=fold_n[2] A1=n5 A2=N2 B1=N6 B2=N2
XU18 OA13S $PINS O=N2 A1=n_in[4] B1=n_in[1] B2=N4 B3=n13
XU19 MOAI1 $PINS O=fold_n[3] A1=n6 A2=N2 B1=N7 B2=N2
XU20 INV1S $PINS O=n5 I=n_in[2]
XU21 INV1S $PINS O=n6 I=FE_OFN148_rom_n_idx_3__3
XU22 INV1S $PINS O=n7 I=n_in[4]
XU25 ND3 $PINS O=n11 I1=k_idx[4] I2=k_idx[3] I3=n12
XU26 AN2 $PINS O=n12 I1=k_idx[2] I2=k_idx[1]
XU27 XOR2HS $PINS O=N8 I1=n7 I2=sub_79/carry[4]
XU28 XOR2HS $PINS O=N7 I1=n6 I2=sub_79/carry[3]
XU29 XOR2HS $PINS O=N6 I1=n5 I2=sub_79/carry[2]
XU30 XOR2HS $PINS O=N5 I1=n8 I2=n9
XU31 OR2 $PINS O=n13 I1=n_in[3] I2=n_in[2]
Xrom_inst CSD_ROM_Table_even_0 $PINS n_idx[4]=fold_n[4] n_idx[3]=fold_n[3]
+ n_idx[2]=fold_n[2] n_idx[1]=fold_n[1] n_idx[0]=fold_n[0] k_idx[4]=k_idx[4]
+ k_idx[3]=k_idx[3] k_idx[2]=k_idx[2] k_idx[1]=k_idx[1] k_idx[0]=k_idx[0]
+ sign1[1]=raw_s1[1] sign1[0]=raw_s1[0] shift1[3]=raw_h1[3] shift1[2]=raw_h1[2]
+ shift1[1]=raw_h1[1] shift1[0]=raw_h1[0] sign2[1]=raw_s2[1] sign2[0]=raw_s2[0]
+ shift2[3]=raw_h2[3] shift2[2]=raw_h2[2] shift2[1]=raw_h2[1] shift2[0]=raw_h2[0]
+ sign3[1]=raw_s3[1] sign3[0]=raw_s3[0] shift3[3]=raw_h3[3] shift3[2]=raw_h3[2]
+ shift3[1]=raw_h3[1] shift3[0]=raw_h3[0]
Xclk_gate_reg_shift1_reg SNPS_CLOCK_GATE_HIGH_ROM_Wrapper_Even_0 $PINS EN=en
+ ENCLK=CTS_12 CLK=clk
.ENDS

.SUBCKT CSD_ROM_Table_odd_0 n_idx[4] n_idx[3] n_idx[2] n_idx[1] n_idx[0]
+ k_idx[4] k_idx[3] k_idx[2] k_idx[1] k_idx[0] sign1[1] sign1[0] shift1[3]
+ shift1[2] shift1[1] shift1[0] sign2[1] sign2[0] shift2[3] shift2[2] shift2[1]
+ shift2[0] sign3[1] sign3[0] shift3[3] shift3[2] shift3[1] shift3[0]
XFE_OCPC9_n1652 BUF1 $PINS O=FE_OCPN8_n1652 I=n1652
XFE_OCPC4_n1525 BUF1 $PINS O=FE_OCPN3_n1525 I=n1525
XFE_OFC496_n1526 INV1S $PINS O=n63 I=n1526
XFE_OFC314_fold_n_1 INV1S $PINS O=FE_OFN262_fold_n_1 I=n105
XFE_OFC313_fold_n_1 INV1S $PINS O=n105 I=n_idx[1]
XFE_OFC291_n1445 INV1S $PINS O=n66 I=n1445
XFE_OFC263_n1652 INV1S $PINS O=n72 I=n1652
XFE_OFC125_fold_n_4 BUF1 $PINS O=FE_OFN125_fold_n_4 I=n_idx[4]
XU728 ND2 $PINS O=sign3[1] I1=n1715 I2=n1714
XU729 AO112 $PINS O=n1707 A1=n101 B1=n1705 C1=n1706 C2=n85
XU730 OA222 $PINS O=n1711 A1=n1702 A2=n1701 B1=n1700 B2=n1699 C1=n1698 C2=n1697
XU731 AN3B2S $PINS O=n1694 I1=n1692 B1=n124 B2=n128
XU732 OA222 $PINS O=n1712 A1=n1682 A2=n1681 B1=n1680 B2=n1679 C1=n1678 C2=n1677
XU733 OA222 $PINS O=n1713 A1=n1675 A2=n1674 B1=n1673 B2=n1672 C1=n1671 C2=n1670
XU736 ND2 $PINS O=n1684 I1=n1672 I2=n1634
XU737 ND2 $PINS O=n1603 I1=n1602 I2=n1616
XU739 ND2 $PINS O=n1600 I1=n1708 I2=n1596
XU740 ND2 $PINS O=n1594 I1=n1593 I2=n60
XU742 OA222 $PINS O=n1621 A1=n1589 A2=n1588 B1=n1587 B2=n1586 C1=n1585 C2=n1584
XU743 OA222 $PINS O=n1564 A1=n120 A2=n92 B1=n_idx[3] B2=n1563 C1=n106 C2=n93
XU744 OA112 $PINS O=n1557 A1=n1546 B1=n1545 C1=n1547 C2=n34
XU745 AO12 $PINS O=n1545 A1=n1543 B1=n1674 B2=n1544
XU747 OA222 $PINS O=n1518 A1=n1517 A2=n1672 B1=n1516 B2=n1584 C1=n1515 C2=n1588
XU748 AO12 $PINS O=n1500 A1=n1610 B1=n43 B2=n41
XU749 ND2 $PINS O=n1499 I1=n1497 I2=n1496
XU750 OA112 $PINS O=n1508 A1=n1487 B1=n1486 C1=n1674 C2=n28
XU751 AO12 $PINS O=n1482 A1=n1665 B1=n121 B2=n1478
XU752 ND2 $PINS O=n1470 I1=n106 I2=n18
XU753 OA222 $PINS O=n1457 A1=n1452 A2=n1596 B1=n1451 B2=n1686 C1=n1450 C2=n1588
XU754 OA222 $PINS O=n1458 A1=n1448 A2=n1645 B1=n1447 B2=n1634 C1=n1446 C2=n1584
XU755 OA222 $PINS O=n1463 A1=n1543 A2=n1438 B1=n1437 B2=n39 C1=n1436 C2=n29
XU756 OA112 $PINS O=n1420 A1=n1419 B1=n1418 C1=n1659 C2=n40
XU757 ND2 $PINS O=n1413 I1=n1427 I2=n1648
XU758 ND2 $PINS O=n1415 I1=n54 I2=n99
XU759 ND2 $PINS O=n1412 I1=n1636 I2=n33
XU760 AN3 $PINS O=n1574 I1=n1410 I2=n1409 I3=n1408
XU762 OA222 $PINS O=n1410 A1=n28 A2=n1490 B1=n11 B2=n54 C1=n1402 C2=n33
XU763 ND2 $PINS O=n1423 I1=n2 I2=n221
XU764 ND2 $PINS O=n1399 I1=n21 I2=n34
XU765 OA222 $PINS O=n1397 A1=n1550 A2=n1441 B1=n1391 B2=n41 C1=n88 C2=n1390
XU767 OA222 $PINS O=n1398 A1=n1648 A2=n44 B1=n1388 B2=n1579 C1=n46 C2=n1591
XU768 OA222 $PINS O=n1509 A1=n1681 A2=n34 B1=n1376 B2=n1375 C1=n1645 C2=n38
XU769 OA222 $PINS O=n1366 A1=n1691 A2=n86 B1=n1361 B2=n1588 C1=n1360 C2=n1359
XU770 OA222 $PINS O=n1367 A1=n1358 A2=n1584 B1=n1357 B2=n1586 C1=n1356 C2=n1634
XU771 OA222 $PINS O=n1386 A1=n35 A2=n1351 B1=n1350 B2=n36 C1=n1349 C2=n29
XU772 OA222 $PINS O=n1341 A1=n1338 A2=n1586 B1=n1337 B2=n1686 C1=n1336 C2=n1604
XU773 OA222 $PINS O=n1343 A1=n43 A2=n1613 B1=n1648 B2=n48 C1=n46 C2=n1614
XU774 OA222 $PINS O=n1344 A1=n1674 A2=n29 B1=n41 B2=n99 C1=n1334 C2=n39
XU775 OA222 $PINS O=n1345 A1=n1333 A2=n1543 B1=n1681 B2=n34 C1=n1658 C2=n32
XU776 OR3B2 $PINS O=n1325 I1=n1322 B1=n1321 B2=n1320
XU777 AO222 $PINS O=n1313 A1=n317 A2=n1498 B1=n1312 B2=n17 C1=n1629 C2=n1311
XU778 AO222 $PINS O=n1312 A1=n107 A2=n1309 B1=n116 B2=n1308 C1=n115 C2=n1307
XU779 OA222 $PINS O=n1314 A1=n44 A2=n88 B1=n1538 B2=n37 C1=n1304 C2=n48
XU780 AN3B2S $PINS O=n1304 I1=n1339 B1=n1303 B2=n53
XU781 OA222 $PINS O=n1315 A1=n1522 A2=n36 B1=n1302 B2=n43 C1=n58 C2=n39
XU782 OA222 $PINS O=n1316 A1=n1681 A2=n21 B1=n1658 B2=n29 C1=n26 C2=n1626
XU783 ND2 $PINS O=n1331 I1=n1292 I2=n1291
XU784 ND2 $PINS O=n1289 I1=n1592 I2=n1613
XU785 ND2 $PINS O=n1290 I1=n1582 I2=n98
XU787 OA112 $PINS O=n1510 A1=n1285 B1=n1284 C1=n1376 C2=n1496
XU788 AN3B2S $PINS O=n1319 I1=n1282 B1=n1281 B2=n1280
XU789 AO222 $PINS O=n1266 A1=n116 A2=n1265 B1=n111 B2=n94 C1=n115 C2=n1264
XU791 OA222 $PINS O=n1267 A1=n1453 A2=n1359 B1=n1260 B2=n1634 C1=n1259 C2=n1588
XU793 OA222 $PINS O=n1272 A1=n1647 A2=n32 B1=n1254 B2=n1253 C1=n1252 C2=n33
XU794 OA222 $PINS O=n1273 A1=n1251 A2=n36 B1=n57 B2=n41 C1=n1250 C2=n39
XU795 OA112 $PINS O=n1276 A1=n1576 B1=n1246 C1=n40 C2=n1359
XU796 OA222 $PINS O=n1246 A1=n1543 A2=n1375 B1=n1245 B2=n1351 C1=n1329 C2=n1244
XU797 ND2 $PINS O=n1293 I1=n1243 I2=n1242
XU798 ND2 $PINS O=n1241 I1=n1626 I2=n1659
XU799 OA112 $PINS O=n1382 A1=n1327 B1=n1239 C1=n1695 C2=n28
XU801 ND2 $PINS O=n1283 I1=n1236 I2=n1235
XU802 OA222 $PINS O=n1235 A1=n1631 A2=n1626 B1=n1234 B2=n1402 C1=n1233 C2=n1490
XU803 OA222 $PINS O=n1236 A1=n21 A2=n1375 B1=n11 B2=n1441 C1=n1659 C2=n1624
XU806 ND2 $PINS O=n1221 I1=n41 I2=n1390
XU807 AN3B2S $PINS O=n1227 I1=n1219 B1=n1218 B2=n1323
XU808 OA112 $PINS O=n1215 A1=n1298 B1=n1214 C1=n1695 C2=n29
XU810 OA222 $PINS O=n1203 A1=n1234 A2=n1626 B1=n1402 B2=n1376 C1=n1339 C2=n39
XU811 OA112 $PINS O=n1174 A1=n1172 B1=n1171 C1=n1173 C2=n49
XU812 ND2 $PINS O=n1390 I1=n116 I2=n17
XU813 ND2 $PINS O=n1170 I1=n36 I2=n1550
XU814 ND2 $PINS O=n1550 I1=n115 I2=n17
XU815 OA112 $PINS O=n1321 A1=n1167 B1=n1166 C1=n1695 C2=n8
XU816 AN3 $PINS O=n1383 I1=n1164 I2=n1163 I3=n1162
XU817 OA112 $PINS O=n1162 A1=n42 B1=n1161 C1=n1288 C2=n1579
XU818 OA222 $PINS O=n1155 A1=FE_OFN125_fold_n_4 A2=n1152 B1=n1151 B2=n49
+ C1=n1376 C2=n1626
XU819 ND2 $PINS O=n1376 I1=n1700 I2=n1150
XU820 OA222 $PINS O=n1152 A1=n51 A2=n1586 B1=n1149 B2=n1604 C1=n1148 C2=n1686
XU821 OA222 $PINS O=n1156 A1=n1636 A2=n1496 B1=n1145 B2=n29 C1=n1144 C2=n36
XU823 ND2 $PINS O=n1335 I1=n1602 I2=n1613
XU824 AO222 $PINS O=n1143 A1=n1442 A2=n1493 B1=n1139 B2=n1387 C1=n1138 C2=n1414
XU825 AN3B2S $PINS O=n1160 I1=n1320 B1=n1134 B2=n1133
XU826 OR3B2 $PINS O=n1134 I1=n1280 B1=n1210 B2=n1132
XU827 OA112 $PINS O=n1125 A1=n1124 B1=n1123 C1=n1695 C2=n26
XU828 ND2 $PINS O=n1122 I1=n1613 I2=n1389
XU832 OA222 $PINS O=n1131 A1=n1212 A2=n26 B1=n1648 B2=n44 C1=n1245 C2=n1351
XU834 ND2 $PINS O=n1546 I1=n1247 I2=n219
XU835 ND2 $PINS O=n1106 I1=n1140 I2=n8
XU836 OA222 $PINS O=n1110 A1=n1445 A2=n47 B1=n1103 B2=n35 C1=n1353 C2=n45
XU837 ND2 $PINS O=n1101 I1=n127 I2=n1150
XU838 ND2 $PINS O=n1102 I1=n219 I2=n1100
XU839 OR3 $PINS O=n1309 I1=n1580 I2=n95 I3=n65
XU841 AO222 $PINS O=n1095 A1=n112 A2=n1092 B1=n113 B2=n1091 C1=n114 C2=n1090
XU842 AN3B2S $PINS O=n1255 I1=n1196 B1=n61 B2=n64
XU843 OA222 $PINS O=n1097 A1=n1196 A2=n1670 B1=n1089 B2=n1088 C1=n1087 C2=n1596
XU845 AN3 $PINS O=n1350 I1=n1610 I2=n72 I3=n1360
XU846 AO222 $PINS O=n1083 A1=n1084 A2=n1371 B1=n1081 B2=n1553 C1=n1080 C2=n1430
XU847 OR3 $PINS O=n1084 I1=n1080 I2=n1525 I3=n96
XU848 AN3B2S $PINS O=n1250 I1=n1136 B1=n1190 B2=n74
XU849 ND2 $PINS O=n1625 I1=n1140 I2=n26
XU850 OA222 $PINS O=n1231 A1=n26 A2=n1349 B1=n1333 B2=n33 C1=n1596 C2=n40
XU853 AO12 $PINS O=n1068 A1=n39 B1=n1301 B2=n1526
XU854 OA222 $PINS O=n1070 A1=n1543 A2=n1554 B1=n1062 B2=n1351
+ C1=FE_OFN125_fold_n_4 C2=n1061
XU855 OA222 $PINS O=n1061 A1=n1060 A2=n1586 B1=n1059 B2=n1604 C1=n1058 C2=n1686
XU856 ND2 $PINS O=n1498 I1=n21 I2=n8
XU857 OA222 $PINS O=n1071 A1=n1692 A2=n34 B1=n1057 B2=n44 C1=n1440 C2=n29
XU858 OA222 $PINS O=n1072 A1=n1056 A2=n48 B1=n52 B2=n49 C1=n1055 C2=n37
XU860 ND2 $PINS O=n1552 I1=n88 I2=n1613
XU861 AN3 $PINS O=n1132 I1=n1042 I2=n1041 I3=n1040
XU862 OA112 $PINS O=n1040 A1=n1232 B1=n1039 C1=n1659 C2=n26
XU863 ND2 $PINS O=n1220 I1=n28 I2=n29
XU864 ND2 $PINS O=n1199 I1=n1591 I2=n86
XU865 AN3 $PINS O=n1187 I1=n1038 I2=n1037 I3=n1036
XU866 OA222 $PINS O=n1034 A1=n1031 A2=n26 B1=n1030 B2=n47 C1=n1029 C2=n45
XU867 ND2 $PINS O=n1433 I1=n1333 I2=n1028
XU868 ND2 $PINS O=n1027 I1=n1426 I2=n8
XU870 ND2 $PINS O=n1023 I1=n130 I2=n1
XU871 ND2 $PINS O=n1688 I1=n1604 I2=n1359
XU872 ND2 $PINS O=n1001 I1=n1369 I2=n1598
XU873 ND2 $PINS O=n1002 I1=n1591 I2=n99
XU874 OR3 $PINS O=n1017 I1=n1208 I2=n1324 I3=n1000
XU875 OA112 $PINS O=n997 A1=n1576 B1=n1168 C1=n1681 C2=n26
XU876 OA13S $PINS O=n998 A1=n1172 B1=n1263 B2=FE_OFN125_fold_n_4 B3=n1686
XU877 ND2 $PINS O=n1351 I1=n996 I2=n1469
XU878 OA222 $PINS O=n1379 A1=n38 A2=n1588 B1=n1626 B2=n29 C1=n1637 C2=n21
XU879 ND2 $PINS O=n1637 I1=n990 I2=n989
XU881 OA222 $PINS O=n994 A1=n54 A2=n48 B1=n1449 B2=n43 C1=n49 C2=n1597
XU882 OA222 $PINS O=n995 A1=n1613 A2=n39 B1=n46 B2=n86 C1=n1495 C2=n41
XU883 OA222 $PINS O=n1020 A1=n1488 A2=n1496 B1=n1647 B2=n26 C1=n1631 C2=n1695
XU884 ND2 $PINS O=n1285 I1=n614 I2=n1247
XU885 ND2 $PINS O=n1708 I1=n1468 I2=n975
XU886 ND2 $PINS O=n1667 I1=n1592 I2=n1389
XU889 ND2 $PINS O=n1596 I1=n971 I2=n1481
XU890 OA222 $PINS O=n980 A1=n970 A2=n44 B1=n969 B2=n45 C1=n46 C2=n1597
XU891 ND2 $PINS O=n1670 I1=n971 I2=n968
XU893 ND2 $PINS O=n1672 I1=n1468 I2=n968
XU894 OR3 $PINS O=n967 I1=n1590 I2=n83 I3=n1511
XU895 ND2 $PINS O=n1590 I1=n54 I2=n1591
XU898 ND2 $PINS O=n1359 I1=n988 I2=n1468
XU899 OR3B2 $PINS O=n961 I1=n1026 B1=n1548 B2=n960
XU900 ND2 $PINS O=n985 I1=n1653 I2=n959
XU901 ND2 $PINS O=n1026 I1=n1104 I2=n1485
XU902 ND2 $PINS O=n1485 I1=n1653 I2=n59
XU905 ND2 $PINS O=n1624 I1=n1479 I2=FE_OFN125_fold_n_4
XU907 ND2 $PINS O=n1000 I1=n958 I2=n957
XU908 ND2 $PINS O=n1244 I1=n1469 I2=n975
XU909 ND2 $PINS O=n1303 I1=n1424 I2=n99
XU912 ND2 $PINS O=n946 I1=n1495 I2=n1614
XU920 OA222 $PINS O=n955 A1=n943 A2=n1028 B1=n942 B2=n21 C1=n941 C2=n28
XU921 ND2 $PINS O=n1658 I1=n972 I2=n1469
XU922 ND2 $PINS O=n1632 I1=n940 I2=n1469
XU923 ND2 $PINS O=n1028 I1=n968 I2=n989
XU924 ND2 $PINS O=n1212 I1=n1481 I2=n1469
XU925 ND2 $PINS O=n1375 I1=n988 I2=n1469
XU927 ND2 $PINS O=n1697 I1=n971 I2=n975
XU930 ND2 $PINS O=n1402 I1=n996 I2=n989
XU934 ND2 $PINS O=n1685 I1=n996 I2=n1468
XU936 ND2 $PINS O=n933 I1=n1700 I2=n1100
XU937 AN3 $PINS O=n777 I1=n71 I2=n1676 I3=n1649
XU938 ND2 $PINS O=n1496 I1=n989 I2=n975
XU939 ND2 $PINS O=n1567 I1=k_idx[4] I2=k_idx[3]
XU941 ND2 $PINS O=n1076 I1=n1254 I2=n1548
XU945 OA222 $PINS O=n1211 A1=n36 A2=n88 B1=n37 B2=n1441 C1=n1645 C2=n38
XU949 ND2 $PINS O=n1584 I1=n990 I2=n971
XU950 ND2 $PINS O=n1687 I1=n988 I2=n971
XU951 ND2 $PINS O=n1477 I1=k_idx[4] I2=n19
XU952 ND2 $PINS O=n1349 I1=n990 I2=n1469
XU953 ND2 $PINS O=n1674 I1=n1469 I2=n968
XU3 AN4B1S $PINS O=n1256 I1=n1583 I2=n1181 I3=n1521 B1=n1513
XU4 ND2 $PINS O=n8 I1=n1700 I2=n1665
XU5 OAI222S $PINS O=n6 A1=n43 A2=n1230 B1=n48 B2=n1229 C1=n1153 C2=n1659
XU6 AN4B1S $PINS O=n1515 I1=n1263 I2=n1445 I3=n1534 B1=n1262
XU7 NR2P $PINS O=n15 I1=n35 I2=n1676
XU8 AN4B1S $PINS O=n1696 I1=n1658 I2=n1402 I3=n1650 B1=n219
XU9 INV1S $PINS O=n620 I=n_idx[0]
XU11 INV1S $PINS O=n104 I=n_idx[2]
XU12 NR2 $PINS O=n1328 I1=n72 I2=FE_OFN125_fold_n_4
XU13 INV1S $PINS O=n85 I=n_idx[3]
XU14 NR2 $PINS O=n1652 I1=n75 I2=n620
XU15 NR2 $PINS O=n1 I1=n35 I2=n1679
XU16 NR2 $PINS O=n2 I1=n35 I2=n1677
XU17 INV1S $PINS O=n76 I=n1565
XU18 INV2 $PINS O=n102 I=n1704
XU19 ND2S $PINS O=n1065 I1=n1063 I2=n1578
XU20 ND2S $PINS O=n1512 I1=n1527 I2=n1583
XU21 ND2S $PINS O=n1064 I1=n1615 I2=n1495
XU22 OA112S $PINS O=n1299 A1=n1510 B1=n1394 C1=n33 C2=n1632
XU23 ND2S $PINS O=n1595 I1=n1592 I2=n1591
XU24 ND2S $PINS O=n1541 I1=n1579 I2=n1389
XU25 ND3S $PINS O=n1332 I1=n1378 I2=n1327 I3=n1326
XU26 ND2S $PINS O=n1580 I1=n1549 I2=n1598
XU27 ND2S $PINS O=n1190 I1=n1526 I2=n88
XU28 ND3S $PINS O=n1249 I1=n1147 I2=n1354 I3=n1248
XU29 NR2 $PINS O=n3 I1=n35 I2=n75
XU30 ND3S $PINS O=n1308 I1=n1362 I2=n1526 I3=n1305
XU31 ND2S $PINS O=n1435 I1=n1445 I2=n1703
XU32 OR3S $PINS O=n7 I1=n1238 I2=n1283 I3=n1237
XU33 OA222S $PINS O=n1121 A1=n11 A2=n54 B1=n44 B2=n98 C1=n1708 C2=n40
XU34 AN3S $PINS O=n1104 I1=n1624 I2=n40 I3=n1153
XU35 ND3S $PINS O=n1105 I1=n1403 I2=n38 I3=n1104
XU36 OR2S $PINS O=n1575 I1=n40 I2=n1708
XU37 ND3S $PINS O=n1444 I1=n1230 I2=n1147 I3=n1146
XU38 ND3S $PINS O=n1046 I1=n98 I2=n1441 I3=n1428
XU39 ND3S $PINS O=n974 I1=n1263 I2=n1445 I3=n1352
XU40 ND3S $PINS O=shift3[2] I1=n1386 I2=n1385 I3=n1384
XU41 OA112S $PINS O=n1128 A1=n1419 B1=n1121 C1=n33 C2=n1349
XU42 ND3S $PINS O=shift1[1] I1=n1020 I2=n1019 I3=n1018
XU43 OA222S $PINS O=n1185 A1=n1490 A2=n33 B1=n99 B2=n39 C1=n40 C2=n1604
XU44 OA22S $PINS O=n1486 A1=n1485 A2=n1659 B1=n40 B2=n1697
XU45 OA222S $PINS O=n1268 A1=n1257 A2=n1686 B1=n1256 B2=n1584 C1=n1255 C2=n1645
XU46 ND3S $PINS O=shift3[3] I1=n1398 I2=n1397 I3=n1396
XU47 OA12S $PINS O=n960 A1=n985 B1=FE_OFN125_fold_n_4 B2=n1597
XU48 ND3S $PINS O=n1081 I1=n1261 I2=n1704 I3=n1597
XU49 OA222S $PINS O=n1320 A1=n1212 A2=n33 B1=n1115 B2=n37 C1=n40 C2=n1687
XU50 ND3S $PINS O=n1265 I1=n1703 I2=n1591 I3=n1261
XU51 ND3S $PINS O=n1370 I1=n1526 I2=n1646 I3=n1369
XU52 ND2S $PINS O=n1441 I1=n1654 I2=n1565
XU53 ND2S $PINS O=n1495 I1=n945 I2=n1565
XU54 OA222S $PINS O=n1409 A1=n1403 A2=n1659 B1=n86 B2=n44 C1=n1703 C2=n43
XU55 OA222S $PINS O=n1298 A1=n41 A2=n1704 B1=n46 B2=n54 C1=n1244 C2=n33
XU56 ND3S $PINS O=n1514 I1=n1521 I2=n1704 I3=n1054
XU57 MAOI1S $PINS O=n1556 A1=n129 A2=n1551 B1=n1550 B2=n1549
XU58 ND2S $PINS O=n1389 I1=n1706 I2=n1565
XU59 ND3S $PINS O=n1612 I1=n1611 I2=n1703 I3=n1610
XU60 OA222S $PINS O=n1157 A1=n37 A2=n1704 B1=n1544 B2=n21 C1=n1549 C2=n39
XU61 ND3S $PINS O=n1523 I1=n1522 I2=n72 I3=n1703
XU62 ND3S $PINS O=n1601 I1=n54 I2=n1704 I3=n1445
XU63 ND3S $PINS O=n1429 I1=n1428 I2=n1616 I3=n1427
XU64 NR2 $PINS O=n4 I1=n1649 I2=n620
XU65 OA222S $PINS O=n1664 A1=n1648 A2=n1685 B1=n1647 B2=n75 C1=n1646 C2=n1645
XU66 ND2S $PINS O=n947 I1=n1136 I2=n1597
XU67 ND2S $PINS O=n1599 I1=n1598 I2=n1597
XU68 ND2S $PINS O=n1153 I1=n1653 I2=n1668
XU69 OA22S $PINS O=n1202 A1=n1390 A2=n54 B1=n1704 B2=n1550
XU70 OA222S $PINS O=n1663 A1=n1651 A2=n92 B1=n1650 B2=n76 C1=n1692 C2=n1649
XU71 ND2S $PINS O=n1614 I1=n1654 I2=n944
XU72 OR2S $PINS O=n1655 I1=n1654 I2=n1653
XU73 ND3S $PINS O=n1311 I1=n1704 I2=n1495 I3=n1310
XU74 ND2S $PINS O=n1648 I1=n1478 I2=n1654
XU75 ND2S $PINS O=n1679 I1=FE_OFN262_fold_n_1 I2=n944
XU76 ND2S $PINS O=n1649 I1=n966 I2=FE_OFN262_fold_n_1
XU77 ND2S $PINS O=n1676 I1=n966 I2=n105
XU78 ND2S $PINS O=n1677 I1=n944 I2=n105
XU79 ND2S $PINS O=n1613 I1=n945 I2=n944
XU80 ND2S $PINS O=n1522 I1=n945 I2=n1478
XU81 ND3S $PINS O=n1705 I1=n93 I2=n17 I3=n1704
XU82 NR2 $PINS O=n989 I1=n740 I2=k_idx[0]
XU83 NR2 $PINS O=n1245 I1=n30 I2=n23
XU84 INV1S $PINS O=n23 I=n1140
XU85 NR2 $PINS O=n1549 I1=n56 I2=n89
XU86 NR2 $PINS O=n1578 I1=n74 I2=n94
XU87 NR2 $PINS O=n1258 I1=n66 I2=n80
XU88 INV1S $PINS O=n80 I=n1538
XU89 INV1S $PINS O=n34 I=n3
XU90 INV1S $PINS O=n82 I=n1521
XU91 INV1S $PINS O=n30 I=n1254
XU92 NR2 $PINS O=n1063 I1=n69 I2=n56
XU93 NR2 $PINS O=n1140 I1=n24 I2=n3
XU94 INV1S $PINS O=n29 I=n1247
XU95 NR2 $PINS O=n1259 I1=n94 I2=n61
XU96 NR2 $PINS O=n1339 I1=n100 I2=n80
XU97 INV1S $PINS O=n56 I=n1354
XU98 AN2 $PINS O=n1257 I1=n1363 I2=n1615
XU99 INV1S $PINS O=n100 I=n1428
XU100 INV1S $PINS O=n64 I=n1181
XU101 NR2 $PINS O=n1358 I1=n1512 I2=n82
XU103 INV1S $PINS O=n65 I=n1147
XU104 INV1S $PINS O=n89 I=n1703
XU106 NR2 $PINS O=n1360 I1=n63 I2=n78
XU107 INV1S $PINS O=n74 I=n1646
XU108 INV1S $PINS O=n25 I=n1484
XU109 NR2 $PINS O=n1538 I1=n81 I2=n84
XU110 NR2 $PINS O=n1261 I1=n1249 I2=n81
XU111 AN2 $PINS O=n1260 I1=n1310 I2=n1258
XU112 INV1S $PINS O=n51 I=n1444
XU113 INV1S $PINS O=n55 I=n1616
XU114 NR2 $PINS O=n1521 I1=n94 I2=n84
XU115 INV1S $PINS O=n94 I=n1115
XU116 INV1S $PINS O=n73 I=n1189
XU117 NR2 $PINS O=n1254 I1=n31 I2=n1434
XU118 INV1S $PINS O=n31 I=n1543
XU119 INV1S $PINS O=n95 I=n1534
XU120 INV1S $PINS O=n61 I=n1369
XU121 INV1S $PINS O=n24 I=n1403
XU122 INV1S $PINS O=n21 I=n1489
XU123 ND3 $PINS O=n1535 I1=n99 I2=n72 I3=n1534
XU124 NR2 $PINS O=n1427 I1=n66 I2=n84
XU125 INV1S $PINS O=n83 I=n1598
XU126 INV1S $PINS O=n128 I=n1651
XU127 INV1S $PINS O=n69 I=n1615
XU128 NR2 $PINS O=n1247 I1=n35 I2=n90
XU129 NR2 $PINS O=n1353 I1=n87 I2=n100
XU130 INV1S $PINS O=n68 I=n1362
XU131 AN2 $PINS O=n1329 I1=n1426 I2=n1631
XU132 INV1S $PINS O=n77 I=n1452
XU133 INV1S $PINS O=n22 I=n1426
XU134 INV1S $PINS O=n124 I=n1333
XU135 INV1S $PINS O=n122 I=n1650
XU136 INV1S $PINS O=n42 I=n1119
XU137 ND3 $PINS O=n1502 I1=n1501 I2=n42 I3=n1500
XU138 INV1S $PINS O=n79 I=n1602
XU139 INV1S $PINS O=n27 I=n1548
XU140 ND3 $PINS O=n1281 I1=n1326 I2=n1279 I3=n1278
XU141 INV1S $PINS O=n126 I=n1439
XU142 INV1S $PINS O=n131 I=n1647
XU143 OAI112HS $PINS O=n1108 A1=n1546 B1=n42 C1=n1254 C2=n1107
XU144 NR2 $PINS O=n1107 I1=n122 I2=n124
XU146 OAI112HS $PINS O=n1238 A1=n1232 B1=n1231 C1=n11 C2=n1495
XU147 INV1S $PINS O=n75 I=n1668
XU148 NR3 $PINS O=n1327 I1=n5 I2=n6 I3=n7
XU149 OAI222S $PINS O=n5 A1=n1527 A2=n44 B1=n47 B2=n1389 C1=n1534 C2=n45
XU150 INV1S $PINS O=n40 I=n1328
XU151 NR2 $PINS O=n1354 I1=FE_OCPN3_n1525 I2=n62
XU152 NR3 $PINS O=n1363 I1=n97 I2=n81 I3=n1309
XU153 ND3 $PINS O=shift2[3] I1=n1277 I2=n1276 I3=n1275
XU154 AN4B1S $PINS O=n1277 I1=n1382 I2=n1395 I3=n1282 B1=n1293
XU155 AN4B1S $PINS O=n1275 I1=n1274 I2=n1273 I3=n1272 B1=n1271
XU156 NR2P $PINS O=n1526 I1=n64 I2=n102
XU157 NR2 $PINS O=n1428 I1=n103 I2=n101
XU158 AOI22S $PINS O=n1098 A1=n110 A2=n1085 B1=n116 B2=n1084
XU159 ND3 $PINS O=n1085 I1=n1598 I2=n54 I3=n1350
XU160 NR2 $PINS O=n1181 I1=n100 I2=n67
XU161 ND3 $PINS O=shift2[0] I1=n1160 I2=n1159 I3=n1158
XU162 NR2 $PINS O=n1159 I1=n1143 I2=n1142
XU163 AN4B1S $PINS O=n1158 I1=n1157 I2=n1156 I3=n1155 B1=n1154
XU164 AN4B1S $PINS O=n957 I1=n956 I2=n955 I3=n954 B1=n953
XU165 NR3 $PINS O=n958 I1=n939 I2=n938 I3=n937
XU166 OA22 $PINS O=n956 A1=n32 A2=n977 B1=n29 B2=n1145
XU167 ND3 $PINS O=n939 I1=n1219 I2=n1185 I3=n936
XU168 AOI22S $PINS O=n936 A1=n1434 A2=n413 B1=n107 B2=n1328
XU169 ND3 $PINS O=shift3[1] I1=n1348 I2=n1347 I3=n1346
XU170 AN4B1S $PINS O=n1346 I1=n1345 I2=n1344 I3=n1343 B1=n1342
XU171 NR3 $PINS O=n1348 I1=n1325 I2=n1324 I3=n1323
XU172 NR3 $PINS O=n1347 I1=n1332 I2=n1331 I3=n1330
XU173 AOI22S $PINS O=n1035 A1=n370 A2=n1027 B1=n109 B2=n1026
XU174 NR2 $PINS O=n1037 I1=n1025 I2=n1024
XU175 AN4B1S $PINS O=n1038 I1=n1400 I2=n1023 I3=n1022 B1=n1240
XU176 AN4B1S $PINS O=n1036 I1=n1035 I2=n1034 I3=n1033 B1=n1032
XU177 ND3 $PINS O=shift2[1] I1=n1207 I2=n1206 I3=n1205
XU178 AN4B1S $PINS O=n1205 I1=n1204 I2=n1203 I3=n1202 B1=n1201
XU179 NR2 $PINS O=n1206 I1=n1194 I2=n1193
XU180 AN4B1S $PINS O=n1207 I1=n1188 I2=n1187 I3=n1209 B1=n1392
XU181 ND3 $PINS O=shift1[2] I1=n1075 I2=n1074 I3=n1073
XU182 NR3 $PINS O=n1074 I1=n1053 I2=n1052 I3=n1051
XU183 AN4B1S $PINS O=n1073 I1=n1072 I2=n1071 I3=n1070 B1=n1069
XU184 AN4B1S $PINS O=n1075 I1=n1187 I2=n1045 I3=n1132 B1=n1044
XU185 NR2P $PINS O=n1445 I1=n78 I2=n67
XU186 NR2 $PINS O=n1147 I1=n66 I2=FE_OCPN8_n1652
XU187 INV1S $PINS O=n78 I=n1441
XU188 NR2 $PINS O=n1263 I1=n56 I2=n102
XU189 ND3 $PINS O=n1091 I1=n1256 I2=n86 I3=n1086
XU190 NR2 $PINS O=n1086 I1=n81 I2=n78
XU191 NR3 $PINS O=n1089 I1=n1091 I2=FE_OCPN8_n1652 I3=n102
XU192 AN4B1S $PINS O=n1465 I1=n1464 I2=n1463 I3=n1462 B1=n1461
XU193 OA22 $PINS O=n1462 A1=n28 A2=n1440 B1=n33 B2=n1439
XU194 AOI22S $PINS O=n1464 A1=n1542 A2=n1435 B1=n1434 B2=n1433
XU195 NR2 $PINS O=n1703 I1=n1513 I2=n102
XU196 INV1S $PINS O=n90 I=n1656
XU197 ND3 $PINS O=shift1[0] I1=n984 I2=n983 I3=n982
XU198 AN4B1S $PINS O=n982 I1=n981 I2=n980 I3=n979 B1=n978
XU199 NR2 $PINS O=n983 I1=n963 I2=n962
XU200 AN4B1S $PINS O=n984 I1=n1022 I2=n1211 I3=n1078 B1=n1000
XU201 NR2 $PINS O=n1646 I1=n80 I2=FE_OCPN8_n1652
XU202 NR2 $PINS O=n1616 I1=n56 I2=n97
XU203 AN4B1S $PINS O=n1620 I1=n1609 I2=n1608 I3=n1607 B1=n1606
XU204 AOI22S $PINS O=n1607 A1=n70 A2=n1600 B1=n117 B2=n1599
XU205 AOI22S $PINS O=n1608 A1=n108 A2=n1595 B1=n118 B2=n1594
XU206 AOI22S $PINS O=n1609 A1=n110 A2=n1590 B1=n97 B2=n1688
XU207 NR2 $PINS O=n1146 I1=n101 I2=n53
XU208 AN4B1S $PINS O=n1059 I1=n1520 I2=n1549 I3=n1495 B1=n70
XU209 INV1S $PINS O=n53 I=n1355
XU210 AN4B1S $PINS O=n1060 I1=n1057 I2=n1549 I3=n1389 B1=n78
XU211 ND3 $PINS O=n1484 I1=n1422 I2=n1421 I3=n1420
XU212 MAOI1 $PINS O=n1422 A1=n592 A2=n1412 B1=n1488 B2=n1411
XU213 AOI22S $PINS O=n1421 A1=n1416 A2=n1415 B1=n1414 B2=n1413
XU214 AOI12HS $PINS O=n1395 A1=n1240 B1=n15 B2=n413
XU215 AOI22S $PINS O=n1400 A1=n219 A2=n1417 B1=n1328 B2=n119
XU216 AN2 $PINS O=n1487 I1=n1401 I2=n1400
XU217 AOI22S $PINS O=n1401 A1=n370 A2=n1399 B1=n1542 B2=n79
XU218 INV1S $PINS O=n84 I=n1389
XU219 INV1S $PINS O=n54 I=FE_OCPN3_n1525
XU220 NR2 $PINS O=n1437 I1=n96 I2=n1580
XU221 ND3 $PINS O=n1442 I1=n1355 I2=n1577 I3=n1135
XU222 NR2 $PINS O=n1135 I1=n83 I2=n56
XU223 AOI22S $PINS O=n1109 A1=n127 A2=n1106 B1=n109 B2=n1105
XU224 INV1S $PINS O=n57 I=n1249
XU225 AN4B1S $PINS O=n1251 I1=n1248 I2=n1360 I3=n72 B1=n62
XU226 ND3 $PINS O=n1392 I1=n1186 I2=n1185 I3=n1184
XU227 AOI22S $PINS O=n1186 A1=n618 A2=n22 B1=n1247 B2=n619
XU228 NR2 $PINS O=n1184 I1=n1183 I2=n1182
XU229 MOAI1S $PINS O=n1182 A1=n1181 A2=n37 B1=n67 B2=n1629
XU230 INV1S $PINS O=n38 I=n1635
XU231 INV1S $PINS O=n81 I=n1495
XU232 NR3 $PINS O=n1529 I1=n1524 I2=n78 I3=n70
XU233 NR2 $PINS O=n1301 I1=n74 I2=FE_OCPN3_n1525
XU234 ND3 $PINS O=n1524 I1=n1577 I2=n1301 I3=n1300
XU235 NR2 $PINS O=n1300 I1=n102 I2=n97
XU236 NR3 $PINS O=n1310 I1=n53 I2=n94 I3=n1590
XU237 ND3 $PINS O=shift2[2] I1=n1228 I2=n1227 I3=n1226
XU238 AN4B1S $PINS O=n1226 I1=n1225 I2=n1224 I3=n1223 B1=n1222
XU239 AN4B1S $PINS O=n1228 I1=n1211 I2=n1210 I3=n1209 B1=n1208
XU240 NR2 $PINS O=n1631 I1=n15 I2=n3
XU241 NR2 $PINS O=n1361 I1=n1513 I2=n1525
XU242 NR2 $PINS O=n1424 I1=n89 I2=FE_OCPN3_n1525
XU243 NR2 $PINS O=n1234 I1=n2 I2=n3
XU244 AN4B1S $PINS O=n1528 I1=n1527 I2=n1669 I3=n1526 B1=n73
XU245 NR2 $PINS O=n1453 I1=n66 I2=n62
XU246 NR2 $PINS O=n1115 I1=n96 I2=n4
XU247 NR2 $PINS O=n1189 I1=FE_OCPN8_n1652 I2=n96
XU248 OA12 $PINS O=n1043 A1=n1279 B1=n38 B2=n1672
XU249 NR2 $PINS O=n1543 I1=n15 I2=n1247
XU250 NR2 $PINS O=n1598 I1=n4 I2=n84
XU251 NR2 $PINS O=n1136 I1=n97 I2=n4
XU252 AOI22S $PINS O=n1394 A1=n117 A2=n1328 B1=n94 B2=n1493
XU253 INV1S $PINS O=n44 I=n1286
XU254 AOI22S $PINS O=n1039 A1=n102 A2=n1542 B1=n614 B2=n30
XU255 AOI22S $PINS O=n1042 A1=n1416 A2=n80 B1=FE_OCPN3_n1525 B2=n1286
XU256 AOI22S $PINS O=n1041 A1=n1494 A2=n1199 B1=n123 B2=n1220
XU257 AN4B1S $PINS O=n1381 I1=n1379 I2=n1378 I3=n1509 B1=n1377
XU258 AOI22S $PINS O=n1124 A1=n619 A2=n1 B1=n109 B2=n1489
XU259 INV1S $PINS O=n98 I=n1511
XU260 NR2 $PINS O=n1534 I1=n103 I2=n96
XU261 AOI22S $PINS O=n1123 A1=n1511 A2=n1494 B1=n1286 B2=n100
XU262 INV1S $PINS O=n33 I=n1
XU263 NR3 $PINS O=n1306 I1=n100 I2=FE_OCPN8_n1652 I3=n53
XU264 NR2 $PINS O=n1369 I1=n1513 I2=n62
XU265 NR2 $PINS O=n1489 I1=n35 I2=n71
XU266 NR2 $PINS O=n1403 I1=n1 I2=n1489
XU267 NR2 $PINS O=n1196 I1=n94 I2=n1511
XU268 INV1S $PINS O=n88 I=n1513
XU269 NR2 $PINS O=n1248 I1=n83 I2=n70
XU270 AOI22S $PINS O=n1210 A1=n108 A2=n1328 B1=n96 B2=n1371
XU271 INV1S $PINS O=n26 I=n2
XU272 NR2 $PINS O=n1592 I1=n1525 I2=n78
XU273 OAI22S $PINS O=n1052 A1=n1048 A2=n43 B1=n1047 B2=n46
XU274 NR3 $PINS O=n1047 I1=n1046 I2=n82 I3=n61
XU275 AN4B1S $PINS O=n1048 I1=n1616 I2=n99 I3=n1147 B1=n1552
XU276 OAI112HS $PINS O=n978 A1=n976 B1=n1285 C1=n977 C2=n21
XU277 OAI12HS $PINS O=n976 A1=n1542 B1=n1190 B2=n1667
XU278 NR2 $PINS O=n1651 I1=n369 I2=n129
XU279 NR2 $PINS O=n1030 I1=n62 I2=n4
XU280 AN2 $PINS O=n1029 I1=n60 I2=n1305
XU281 NR2 $PINS O=n1031 I1=n128 I2=n1433
XU282 NR2 $PINS O=n1615 I1=n101 I2=n70
XU283 NR2 $PINS O=n1449 I1=n69 I2=n102
XU284 NR2 $PINS O=n1520 I1=n103 I2=n78
XU285 NR2 $PINS O=n1230 I1=FE_OCPN3_n1525 I2=n84
XU286 MOAI1S $PINS O=n987 A1=n1651 A2=n28 B1=n1328 B2=n1683
XU287 AOI22S $PINS O=n1180 A1=n96 A2=n115 B1=n107 B2=n69
XU288 INV1S $PINS O=n35 I=n1700
XU289 ND3 $PINS O=n1138 I1=n1137 I2=n1520 I3=n1136
XU290 ND3 $PINS O=n1139 I1=n1353 I2=n1258 I3=n1354
XU291 NR3 $PINS O=n1137 I1=n89 I2=n62 I3=n68
XU292 AOI22S $PINS O=n1165 A1=n1371 A2=n56 B1=n4 B2=n1542
XU293 AOI22S $PINS O=n1219 A1=n1635 A2=n115 B1=n1371 B2=n78
XU294 NR3 $PINS O=n1336 I1=n1335 I2=n103 I3=n1601
XU295 ND3 $PINS O=n1069 I1=n1068 I2=n1067 I3=n1066
XU296 ND3 $PINS O=n1067 I1=n1700 I2=n1100 I3=n618
XU297 AOI22S $PINS O=n1066 A1=n1430 A2=n1065 B1=n1542 B2=n1064
XU298 ND3 $PINS O=n1443 I1=n1441 I2=n1495 I3=n98
XU299 NR2 $PINS O=n1233 I1=n1417 I2=n1434
XU300 AOI22S $PINS O=n979 A1=n1416 A2=n974 B1=n1387 B2=n973
XU301 ND3 $PINS O=n973 I1=n1610 I2=n1441 I3=n1306
XU302 INV1S $PINS O=n87 I=n1527
XU303 NR2 $PINS O=n1582 I1=n1513 I2=n101
XU304 NR2 $PINS O=n1362 I1=n80 I2=n70
XU305 NR2 $PINS O=n1087 I1=n1525 I2=n68
XU306 AN4B1S $PINS O=n1338 I1=n86 I2=n1577 I3=n1424 B1=n83
XU307 AOI22S $PINS O=n1188 A1=n125 A2=n1489 B1=n113 B2=n1328
XU308 INV1S $PINS O=n1434 I=n8
XU309 INV1S $PINS O=n47 I=n1416
XU310 MOAI1S $PINS O=n953 A1=n26 A2=n1497 B1=n1430 B2=n1601
XU311 MOAI1S $PINS O=n1082 A1=n1261 A2=n11 B1=n592 B2=n1625
XU312 AOI22S $PINS O=n1232 A1=n413 A2=n1 B1=n370 B2=n15
XU313 AOI22S $PINS O=n1279 A1=n218 A2=n1 B1=n129 B2=n15
XU314 INV1S $PINS O=n60 I=n1287
XU315 NR3 $PINS O=n1544 I1=n619 I2=n218 I3=n124
XU316 AOI22S $PINS O=n1419 A1=n1417 A2=n619 B1=n129 B2=n1489
XU317 OAI22S $PINS O=n1120 A1=n1117 A2=n28 B1=n1116 B2=n36
XU318 NR2 $PINS O=n1117 I1=n369 I2=n131
XU319 NR2 $PINS O=n1116 I1=n79 I2=n77
XU320 NR2 $PINS O=n1452 I1=n102 I2=n78
XU321 NR2 $PINS O=n1602 I1=n81 I2=n4
XU322 AOI22S $PINS O=n1033 A1=n1286 A2=n95 B1=n129 B2=n24
XU323 NR2 $PINS O=n1288 I1=n1542 I2=n1286
XU324 INV1S $PINS O=n99 I=n4
XU325 INV1S $PINS O=n39 I=n1371
XU326 NR2 $PINS O=n1426 I1=n1417 I2=n1489
XU327 AOI22S $PINS O=n1168 A1=n1417 A2=n614 B1=n3 B2=n130
XU328 NR2 $PINS O=n1593 I1=n101 I2=n1511
XU329 NR2 $PINS O=n1611 I1=n97 I2=n103
XU330 NR2 $PINS O=n1488 I1=n1 I2=n1434
XU331 INV1S $PINS O=n20 I=n1283
XU332 NR2 $PINS O=n977 I1=n413 I2=n592
XU333 NR2 $PINS O=n1548 I1=n1417 I2=n2
XU334 NR2 $PINS O=n1252 I1=n128 I2=n370
XU335 NR2 $PINS O=n1253 I1=n619 I2=n614
XU336 NR2 $PINS O=n1450 I1=n102 I2=n95
XU337 AOI22S $PINS O=n1576 A1=n218 A2=n1434 B1=n129 B2=n3
XU338 INV1S $PINS O=n43 I=n1414
XU339 NR2 $PINS O=n1333 I1=n125 I2=n130
XU340 OA22 $PINS O=n1504 A1=n11 A2=n1577 B1=n47 B2=n1495
XU341 NR2 $PINS O=n1169 I1=n97 I2=n96
XU342 ND3 $PINS O=n1380 I1=n1297 I2=n1296 I3=n1295
XU343 AOI22S $PINS O=n1297 A1=n1287 A2=n1286 B1=n3 B2=n219
XU344 OA22 $PINS O=n1296 A1=n99 A2=n1288 B1=n29 B2=n1440
XU345 NR3 $PINS O=n1295 I1=n1294 I2=n1293 I3=n1331
XU346 AOI22S $PINS O=n1378 A1=n1434 A2=n614 B1=n219 B2=n22
XU347 MOAI1S $PINS O=n937 A1=n41 A2=n99 B1=n370 B2=n3
XU348 AOI22S $PINS O=n1022 A1=n123 A2=n1434 B1=n3 B2=n125
XU349 NR2 $PINS O=n1650 I1=n123 I2=n614
XU350 INV1S $PINS O=n32 I=n15
XU351 AOI22S $PINS O=n1161 A1=n70 A2=n1416 B1=n101 B2=n1494
XU352 AOI22S $PINS O=n1045 A1=n317 A2=n1489 B1=n369 B2=n1247
XU353 NR2 $PINS O=n1436 I1=n218 I2=n1693
XU354 OR2 $PINS O=n1501 I1=n1153 I2=n1659
XU355 NR2 $PINS O=n1119 I1=n985 I2=n1659
XU356 INV1S $PINS O=n109 I=n1659
XU357 INV1S $PINS O=n48 I=n1387
XU358 AOI22S $PINS O=n1519 A1=n118 A2=n62 B1=n114 B2=n80
XU359 NR2 $PINS O=n1577 I1=n101 I2=n67
XU360 AOI22S $PINS O=n1274 A1=n1247 A2=n124 B1=n592 B2=n23
XU361 INV1S $PINS O=n28 I=n1417
XU362 AOI22S $PINS O=n992 A1=n130 A2=n15 B1=n2 B2=n109
XU363 NR2 $PINS O=n1692 I1=n127 I2=n592
XU364 INV1S $PINS O=n110 I=n1359
XU365 AOI22S $PINS O=n1326 A1=n1635 A2=n113 B1=n15 B2=n127
XU366 AOI22S $PINS O=n1558 A1=n1542 A2=n1541 B1=n22 B2=n131
XU367 AOI12HS $PINS O=n1118 A1=n37 B1=n1527 B2=n1144
XU368 NR2 $PINS O=n1144 I1=FE_OCPN3_n1525 I2=n67
XU369 OAI12HS $PINS O=n1405 A1=n15 B1=n125 B2=n618
XU370 AOI22S $PINS O=n1505 A1=n1494 A2=n87 B1=n1493 B2=n96
XU371 AOI22S $PINS O=n1278 A1=n15 A2=n125 B1=n3 B2=n369
XU372 NR2 $PINS O=n1636 I1=n2 I2=n15
XU373 NR2 $PINS O=n1690 I1=n1684 I2=n1683
XU374 INV1S $PINS O=n45 I=n1494
XU375 NR2 $PINS O=n1411 I1=n370 I2=n221
XU376 NR2 $PINS O=n1440 I1=n130 I2=n413
XU377 NR2 $PINS O=n1554 I1=n125 I2=n619
XU378 INV1S $PINS O=n41 I=n1553
XU379 AOI22S $PINS O=n1176 A1=n1287 A2=n1286 B1=n221 B2=n27
XU380 NR2 $PINS O=n1610 I1=n81 I2=n62
XU381 NR2 $PINS O=n1305 I1=n96 I2=n62
XU382 AOI22S $PINS O=n1167 A1=n1494 A2=n4 B1=n67 B2=n1416
XU383 NR2 $PINS O=n1698 I1=n95 I2=n97
XU384 OA22 $PINS O=n1175 A1=n26 A2=n1692 B1=n37 B2=n86
XU385 NR2 $PINS O=n1439 I1=n127 I2=n618
XU386 AOI22S $PINS O=n1418 A1=n1417 A2=n126 B1=n1434 B2=n219
XU387 INV1S $PINS O=n36 I=n1430
XU388 AOI22S $PINS O=n1393 A1=n592 A2=n24 B1=n614 B2=n31
XU389 NR2 $PINS O=n1229 I1=n103 I2=n102
XU390 AOI22S $PINS O=n1641 A1=n125 A2=n3 B1=n369 B2=n15
XU391 NR2 $PINS O=n1647 I1=n218 I2=n317
XU392 MOAI1S $PINS O=n1555 A1=n33 A2=n1554 B1=n1553 B2=n1552
XU393 OAI112HS $PINS O=n1201 A1=n1285 B1=n1546 C1=n1200 C2=n49
XU394 NR2 $PINS O=n1200 I1=n84 I2=n1199
XU395 INV1S $PINS O=n49 I=n1629
XU396 NR2 $PINS O=n1352 I1=n79 I2=n101
XU397 AOI22S $PINS O=n1662 A1=n108 A2=n1652 B1=n129 B2=n1656
XU398 AOI22S $PINS O=n1006 A1=n116 A2=n67 B1=n1513 B2=n110
XU399 AOI22S $PINS O=n981 A1=n1414 A2=n965 B1=n1553 B2=n69
XU400 ND3 $PINS O=n965 I1=n1169 I2=n1369 I3=n964
XU401 NR2 $PINS O=n964 I1=n80 I2=n69
XU402 NR2 $PINS O=n1497 I1=n127 I2=n219
XU403 ND3 $PINS O=n1154 I1=n1501 I2=n1172 I3=n1406
XU404 INV1S $PINS O=n111 I=n1672
XU405 INV1S $PINS O=n37 I=n1213
XU406 INV1S $PINS O=n46 I=n1493
XU407 NR2 $PINS O=n1691 I1=n118 I2=n114
XU408 AOI22S $PINS O=n1640 A1=n2 A2=n126 B1=n1629 B2=n94
XU409 AOI22S $PINS O=n1225 A1=n218 A2=n1220 B1=n1513 B2=n1629
XU410 AOI22S $PINS O=n1224 A1=n413 A2=n1247 B1=n15 B2=n369
XU411 MOAI1S $PINS O=n1374 A1=n1352 A2=n41 B1=n83 B2=n1387
XU412 NR3 $PINS O=n1388 I1=n1387 I2=n1414 I3=n1493
XU413 NR2 $PINS O=n1145 I1=n127 I2=n129
XU414 NR2 $PINS O=n1088 I1=n115 I2=n108
XU415 NR2 $PINS O=n1438 I1=n127 I2=n317
XU416 AOI22S $PINS O=n1223 A1=n84 A2=n1387 B1=n103 B2=n1414
XU417 AOI22S $PINS O=n1282 A1=n129 A2=n1417 B1=n218 B2=n2
XU418 OA12 $PINS O=n986 A1=n109 B1=n1 B2=n1417
XU419 NR2 $PINS O=n1391 I1=n67 I2=n1541
XU420 NR2 $PINS O=n1668 I1=n76 I2=n105
XU421 AOI22S $PINS O=n1239 A1=n369 A2=n27 B1=n130 B2=n1489
XU422 NR2 $PINS O=n1385 I1=n1374 I2=n1373
XU423 AN4B1S $PINS O=n1384 I1=n1383 I2=n1382 I3=n1381 B1=n1380
XU424 NR2 $PINS O=n1525 I1=n620 I2=n1679
XU425 MOAI1S $PINS O=n1271 A1=FE_OFN125_fold_n_4 A2=n1270 B1=n22 B2=n618
XU426 AN4B1S $PINS O=n1270 I1=n1269 I2=n1268 I3=n1267 B1=n1266
XU427 AOI22S $PINS O=n1269 A1=n1262 A2=n118 B1=n81 B2=n119
XU428 INV1S $PINS O=n103 I=n1591
XU429 ND3 $PINS O=n1080 I1=n1579 I2=n1441 I3=n1079
XU430 AN2 $PINS O=n1079 I1=n1613 I2=n1250
XU431 ND3 $PINS O=shift1[3] I1=n1114 I2=n1113 I3=n1112
XU432 AN4B1S $PINS O=n1114 I1=n1078 I2=n1168 I3=n1231 B1=n1377
XU433 NR2 $PINS O=n1113 I1=n1083 I2=n1082
XU434 AN4B1S $PINS O=n1112 I1=n1111 I2=n1110 I3=n1109 B1=n1108
XU435 OAI22S $PINS O=n1094 A1=n1257 A2=n1686 B1=n1093 B2=n1672
XU436 AN4B1S $PINS O=n1093 I1=n1196 I2=n1353 I3=n1579 B1=n1287
XU437 ND3 $PINS O=n1280 I1=n1131 I2=n1130 I3=n1129
XU438 NR3 $PINS O=n1130 I1=n1120 I2=n1119 I3=n1118
XU439 AN4B1S $PINS O=n1129 I1=n1214 I2=n1128 I3=n1167 B1=n1237
XU440 NR2 $PINS O=n1560 I1=n1540 I2=n1539
XU441 MOAI1S $PINS O=n1539 A1=n1538 A2=n36 B1=n370 B2=n15
XU442 OAI222S $PINS O=n1540 A1=FE_OFN125_fold_n_4 A2=n1537 B1=n1696 B2=n26
+ C1=n1536 C2=n39
XU443 NR3 $PINS O=n1536 I1=n1535 I2=n55 I3=n77
XU444 NR2 $PINS O=n1583 I1=n56 I2=n1581
XU445 NR3 $PINS O=n1537 I1=n1533 I2=n1532 I3=n1531
XU446 OAI222S $PINS O=n1532 A1=n1521 A2=n1586 B1=n1691 B2=n99 C1=n1520 C2=n1645
XU447 OAI222S $PINS O=n1531 A1=n1530 A2=n1686 B1=n1529 B2=n1604 C1=n1528
+ C2=n1634
XU448 OAI112HS $PINS O=n1533 A1=n1519 B1=n1518 C1=n1596 C2=n1579
XU449 NR3 $PINS O=n1516 I1=n1514 I2=n1513 I3=n65
XU450 NR3 $PINS O=n1517 I1=n1512 I2=n1511 I3=n95
XU451 INV1S $PINS O=n112 I=n1588
XU452 ND3 $PINS O=n1090 I1=n1355 I2=n54 I3=n1255
XU453 ND3 $PINS O=n1092 I1=n1229 I2=n1614 I3=n1358
XU454 NR3 $PINS O=n1019 I1=n987 I2=n1119 I3=n986
XU455 NR3 $PINS O=n1018 I1=n1017 I2=n1016 I3=n1015
XU456 INV1S $PINS O=n101 I=n1597
XU457 ND3 $PINS O=shift3[0] I1=n1319 I2=n1318 I3=n1317
XU458 AN4B1S $PINS O=n1318 I1=n20 I2=n1299 I3=n1298 B1=n1380
XU459 AN4B1S $PINS O=n1317 I1=n1316 I2=n1315 I3=n1314 B1=n1313
XU460 NR2 $PINS O=n1643 I1=n1628 I2=n1627
XU461 MOAI1S $PINS O=n1627 A1=n21 A2=n1626 B1=n592 B2=n1625
XU462 OAI22S $PINS O=n1628 A1=n1659 A2=n1624 B1=FE_OFN125_fold_n_4 B2=n1623
XU463 AN4B1S $PINS O=n1623 I1=n1622 I2=n1621 I3=n1620 B1=n1619
XU464 AN4B1S $PINS O=n1589 I1=n1579 I2=n1614 I3=n1578 B1=n87
XU465 AN4B1S $PINS O=n1585 I1=n1583 I2=n1582 I3=n1602 B1=n78
XU466 NR3 $PINS O=n1587 I1=n100 I2=n1581 I3=n1580
XU467 OAI112HS $PINS O=n1240 A1=n1121 B1=n1021 C1=n1637 C2=n26
XU468 AOI22S $PINS O=n1021 A1=n78 A2=n1416 B1=n1513 B2=n1494
XU469 MOAI1S $PINS O=n1461 A1=FE_OFN125_fold_n_4 A2=n1460 B1=n24 B2=n369
XU470 AN4B1S $PINS O=n1460 I1=n1459 I2=n1458 I3=n1457 B1=n1456
XU471 AOI22S $PINS O=n1459 A1=n4 A2=n110 B1=n96 B2=n111
XU472 NR3 $PINS O=n1448 I1=n1443 I2=n73 I3=n1442
XU473 NR3 $PINS O=n1447 I1=n1444 I2=n81 I3=n102
XU474 AN4B1S $PINS O=n1446 I1=n1445 I2=n1646 I3=n1583 B1=n95
XU475 NR2 $PINS O=n1656 I1=n93 I2=n105
XU476 NR2P $PINS O=n1513 I1=n90 I2=n620
XU477 OAI22S $PINS O=n1365 A1=n1364 A2=n1604 B1=n1686 B2=n1363
XU478 AN4B1S $PINS O=n1364 I1=n1698 I2=n1362 I3=n1453 B1=n102
XU479 MOAI1S $PINS O=n1373 A1=FE_OFN125_fold_n_4 A2=n1372 B1=n1371 B2=n1370
XU480 AN4B1S $PINS O=n1372 I1=n1368 I2=n1367 I3=n1366 B1=n1365
XU481 AOI22S $PINS O=n1368 A1=n67 A2=n114 B1=n81 B2=n119
XU482 AN4B1S $PINS O=n1356 I1=n1520 I2=n1355 I3=n1354 B1=n82
XU483 AN4B1S $PINS O=n1357 I1=n1353 I2=n1646 I3=n1354 B1=n4
XU484 MOAI1S $PINS O=n1606 A1=n1605 A2=n1604 B1=n107 B2=n1603
XU485 NR2 $PINS O=n1605 I1=n81 I2=n1601
XU486 MOAI1S $PINS O=n962 A1=n1212 A2=n33 B1=n109 B2=n961
XU487 NR3 $PINS O=n1062 I1=n1498 I2=n3 I3=n1247
XU488 AN4B1S $PINS O=n1058 I1=n1591 I2=n1258 I3=n1136 B1=n1513
XU489 NR2 $PINS O=n1355 I1=n1581 I2=n1262
XU490 NR2 $PINS O=n1054 I1=n53 I2=n1590
XU491 ND3 $PINS O=n1573 I1=n1508 I2=n1507 I3=n1506
XU492 NR2 $PINS O=n1507 I1=n1492 I2=n1491
XU493 AN4B1S $PINS O=n1506 I1=n1505 I2=n1504 I3=n1503 B1=n1502
XU494 AN4B1S $PINS O=n1396 I1=n1395 I2=n1394 I3=n1393 B1=n1392
XU495 AN4B1S $PINS O=n1148 I1=n1549 I2=n1602 I3=n1522 B1=n66
XU496 NR2 $PINS O=n1151 I1=n56 I2=n77
XU497 AN4B1S $PINS O=n1149 I1=n1648 I2=n1428 I3=n1703 B1=n1335
XU498 INV2 $PINS O=n62 I=n1579
XU499 OAI22S $PINS O=n1619 A1=n1618 A2=n1685 B1=n1617 B2=n1687
XU500 AN4B1S $PINS O=n1618 I1=n1614 I2=n72 I3=n1613 B1=n1612
XU501 AN4B1S $PINS O=n1617 I1=n1616 I2=n72 I3=n1615 B1=n94
XU502 AN4B1S $PINS O=n970 I1=n88 I2=n71 I3=n50 B1=n967
XU503 AN4B1S $PINS O=n969 I1=n60 I2=n99 I3=n98 B1=n1512
XU504 MOAI1S $PINS O=n949 A1=n948 A2=n1634 B1=n1303 B2=n113
XU505 NR2 $PINS O=n948 I1=n66 I2=n61
XU506 OA22 $PINS O=n954 A1=FE_OFN125_fold_n_4 A2=n952 B1=n1631 B2=n1244
XU507 AN4B1S $PINS O=n952 I1=n951 I2=n1180 I3=n950 B1=n949
XU508 AOI22S $PINS O=n951 A1=n67 A2=n114 B1=n107 B2=n96
XU509 AOI22S $PINS O=n950 A1=n116 A2=n947 B1=n115 B2=n946
XU510 ND3 $PINS O=n1264 I1=n1582 I2=n1598 I3=n1515
XU511 NR2 $PINS O=n1635 I1=n50 I2=FE_OFN125_fold_n_4
XU512 INV1S $PINS O=n50 I=n1581
XU513 NR2 $PINS O=n1214 I1=n9 I2=n10
XU514 OAI222S $PINS O=n9 A1=n1695 A2=n33 B1=n1659 B2=n38 C1=n21 C2=n1402
XU515 OAI222S $PINS O=n10 A1=n8 A2=n1632 B1=n1490 B2=n29 C1=n34 C2=n1375
XU516 ND3 $PINS O=n1323 I1=n1217 I2=n1216 I3=n1215
XU517 AOI22S $PINS O=n1216 A1=n102 A2=n1213 B1=n1387 B2=n67
XU518 AOI22S $PINS O=n1217 A1=n4 A2=n1414 B1=n1430 B2=FE_OCPN3_n1525
XU519 ND3 $PINS O=n1208 I1=n995 I2=n994 I3=n993
XU520 AN4B1S $PINS O=n993 I1=n992 I2=n1379 I3=n1045 B1=n1322
XU521 OAI22S $PINS O=n1456 A1=n1455 A2=n1586 B1=n1454 B2=n1604
XU522 AN4B1S $PINS O=n1454 I1=n1453 I2=n1646 I3=n1648 B1=n89
XU523 AN4B1S $PINS O=n1455 I1=n1592 I2=n1578 I3=n1582 B1=n1581
XU524 NR3 $PINS O=n1209 I1=n1179 I2=n1178 I3=n1177
XU525 ND3 $PINS O=n1178 I1=n1321 I2=n1168 I3=n1278
XU526 ND3 $PINS O=n1177 I1=n1176 I2=n1175 I3=n1174
XU527 OAI112HS $PINS O=n1179 A1=n1383 B1=n1165 C1=n40 C2=n1586
XU528 AN4B1S $PINS O=n1334 I1=n1616 I2=n88 I3=n1428 B1=n68
XU529 INV2 $PINS O=n67 I=n1614
XU530 OAI112HS $PINS O=n1322 A1=n1043 B1=n991 C1=n11 C2=n1597
XU531 OA22 $PINS O=n991 A1=n48 A2=n1057 B1=n43 B2=n1495
XU532 AN4B1S $PINS O=n1714 I1=n1713 I2=n1712 I3=n1711 B1=n1710
XU533 AN4B1S $PINS O=n1715 I1=n1664 I2=n1663 I3=n1662 B1=n1661
XU534 MOAI1S $PINS O=n1710 A1=n1709 A2=n1708 B1=n119 B2=n1707
XU535 OR2 $PINS O=n11 I1=n1708 I2=FE_OFN125_fold_n_4
XU536 INV1S $PINS O=n1542 I=n11
XU537 NR3 $PINS O=n1530 I1=n1523 I2=n79 I3=n69
XU538 INV1S $PINS O=n97 I=n1522
XU539 NR2 $PINS O=n1286 I1=n1672 I2=FE_OFN125_fold_n_4
XU540 OAI112HS $PINS O=n1324 A1=n998 B1=n997 C1=n999 C2=n1351
XU541 NR2 $PINS O=n999 I1=n15 I2=n1
XU542 ND3 $PINS O=n1237 I1=n1127 I2=n1126 I3=n1125
XU543 OA22 $PINS O=n1127 A1=n1402 A2=n1233 B1=n54 B2=n47
XU544 MAOI1 $PINS O=n1126 A1=n1542 A2=n1122 B1=n1490 B2=n1234
XU545 INV1S $PINS O=n619 I=n1637
XU546 NR2 $PINS O=n1511 I1=n1676 I2=n620
XU547 MOAI1S $PINS O=n1015 A1=FE_OFN125_fold_n_4 A2=n1014 B1=n118 B2=n1635
XU548 AN4B1S $PINS O=n1014 I1=n1013 I2=n1012 I3=n1011 B1=n1010
XU549 AOI22S $PINS O=n1013 A1=n115 A2=n1002 B1=n111 B2=n1001
XU550 AN4B1S $PINS O=n1011 I1=n1007 I2=n1519 I3=n1006 B1=n1005
XU551 NR2 $PINS O=n1012 I1=n1004 I2=n1003
XU552 MOAI1S $PINS O=n1003 A1=n1593 A2=n1670 B1=n1688 B2=n96
XU553 OAI22S $PINS O=n1004 A1=n1611 A2=n1697 B1=n1063 B2=n1596
XU554 AN4B1S $PINS O=n1302 I1=n1592 I2=n1522 I3=n1526 B1=n68
XU555 INV1S $PINS O=n58 I=n1524
XU556 ND3 $PINS O=n1551 I1=n33 I2=n29 I3=n1548
XU557 INV1S $PINS O=n71 I=n959
XU558 NR2 $PINS O=n1527 I1=n1513 I2=n1262
XU559 OAI22S $PINS O=n1010 A1=n1009 A2=n1708 B1=n1008 B2=n1389
XU560 NR2 $PINS O=n1008 I1=n113 I2=n1688
XU561 AN2 $PINS O=n1009 I1=n1591 I2=n1453
XU562 AN4B1S $PINS O=n1056 I1=n1115 I2=n1597 I3=n1610 B1=n1435
XU563 INV1S $PINS O=n52 I=n1514
XU564 AN4B1S $PINS O=n1055 I1=n1189 I2=n1579 I3=n1526 B1=n53
XU565 OAI222S $PINS O=n1194 A1=n1192 A2=n41 B1=n1191 B2=n43 C1=n1648 C2=n36
XU566 AN4B1S $PINS O=n1192 I1=n1445 I2=n88 I3=n1301 B1=n69
XU567 NR3 $PINS O=n1191 I1=n1190 I2=n55 I3=n73
XU568 MOAI1S $PINS O=n1431 A1=n34 A2=n1626 B1=n1430 B2=n1429
XU569 INV1S $PINS O=n369 I=n1496
XU570 INV1S $PINS O=n96 I=n1648
XU571 INV1S $PINS O=n70 I=n1613
XU572 AN2 $PINS O=n1451 I1=n1614 I2=n1449
XU573 MOAI1S $PINS O=n1377 A1=n1077 A2=n1212 B1=n1076 B2=n218
XU574 NR2 $PINS O=n1077 I1=n1417 I2=n1625
XU575 NR2 $PINS O=n1700 I1=n620 I2=FE_OFN125_fold_n_4
XU576 AN4B1S $PINS O=n1702 I1=n1691 I2=n1690 I3=n1689 B1=n1688
XU577 AN4B1S $PINS O=n1699 I1=n1696 I2=n1695 I3=n1694 B1=n1693
XU578 AN4B1S $PINS O=n1689 I1=n1687 I2=n1686 I3=n1685 B1=n117
XU579 MOAI1S $PINS O=n1330 A1=n1329 A2=n1496 B1=n1328 B2=n110
XU580 OAI222S $PINS O=n1342 A1=n1577 A2=n36 B1=FE_OFN125_fold_n_4 B2=n1341
+ C1=n1340 C2=n49
XU581 AN4B1S $PINS O=n1340 I1=n1339 I2=n1452 I3=n1579 B1=n53
XU582 NR2 $PINS O=n1337 I1=n78 I2=n1513
XU583 NR2 $PINS O=n1417 I1=n35 I2=n1649
XU584 AOI22S $PINS O=n1204 A1=n1387 A2=n1198 B1=n1493 B2=n1197
XU585 ND3 $PINS O=n1197 I1=n1196 I2=n1353 I3=n1195
XU586 ND3 $PINS O=n1198 I1=n1578 I2=n1583 I3=n1452
XU587 NR2 $PINS O=n1195 I1=n1581 I2=n78
XU588 OAI222S $PINS O=n1025 A1=n11 A2=n1389 B1=n1488 B2=n1244 C1=n34 C2=n1402
XU589 OAI222S $PINS O=n1432 A1=n1426 A2=n1681 B1=n1548 B2=n1659 C1=n1425 C2=n41
XU590 AN4B1S $PINS O=n1425 I1=n1598 I2=n1614 I3=n1424 B1=n73
XU591 NR2 $PINS O=n1669 I1=n1581 I2=n1525
XU592 AN4B1S $PINS O=n1408 I1=n1407 I2=n1406 I3=n1405 B1=n1404
XU593 OAI222S $PINS O=n1142 A1=n1141 A2=n41 B1=n1631 B2=n1632 C1=n1140 C2=n1681
XU594 NR3 $PINS O=n1141 I1=n1335 I2=n62 I3=n63
XU595 INV1S $PINS O=n92 I=n1665
XU596 NR2 $PINS O=n1416 I1=n1596 I2=FE_OFN125_fold_n_4
XU597 MOAI1S $PINS O=n1051 A1=n1050 A2=n41 B1=n27 B2=n413
XU598 NR3 $PINS O=n1050 I1=n1049 I2=n65 I3=n1552
XU599 ND3 $PINS O=n1049 I1=n1591 I2=n1389 I3=n1354
XU600 INV1S $PINS O=n413 I=n1402
XU601 NR2 $PINS O=n1287 I1=n620 I2=n1677
XU602 NR2 $PINS O=n1547 I1=n130 I2=n619
XU603 NR2 $PINS O=n942 I1=n130 I2=n218
XU604 NR2 $PINS O=n941 I1=n592 I2=n124
XU605 NR2 $PINS O=n943 I1=n2 I2=n1
XU606 AOI22S $PINS O=n1164 A1=n1417 A2=n124 B1=n2 B2=n219
XU607 AOI22S $PINS O=n1163 A1=n619 A2=n3 B1=n618 B2=n1434
XU608 NR2 $PINS O=n1371 I1=n1685 I2=FE_OFN125_fold_n_4
XU609 OA22 $PINS O=n1078 A1=n934 A2=n1695 B1=n1496 B2=n933
XU610 NR2 $PINS O=n934 I1=n1 I2=n1076
XU611 OAI222S $PINS O=n1404 A1=n1439 A2=n8 B1=n1497 B2=n21 C1=n47 C2=n1614
XU612 OR2 $PINS O=n1172 I1=n1375 I2=n1488
XU613 AOI22S $PINS O=n1503 A1=n3 A2=n1499 B1=n619 B2=n1498
XU614 MOAI1S $PINS O=n1492 A1=n1488 A2=n1695 B1=n22 B2=n221
XU615 INV1S $PINS O=n86 I=n1262
XU616 OAI222S $PINS O=n938 A1=n1488 A2=n1349 B1=n1369 B2=n39 C1=n1548 C2=n1674
XU617 OAI112HS $PINS O=n1044 A1=n1124 B1=n1043 C1=n1681 C2=n33
XU618 NR2 $PINS O=n1414 I1=n1359 I2=FE_OFN125_fold_n_4
XU619 OA22 $PINS O=n1639 A1=n1633 A2=n1632 B1=n1631 B2=n1630
XU620 NR2 $PINS O=n1630 I1=n413 I2=n221
XU621 NR2 $PINS O=n1633 I1=n15 I2=n24
XU622 OAI22S $PINS O=n1005 A1=n1534 A2=n1687 B1=n1520 B2=n1588
XU623 INV1S $PINS O=n130 I=n1632
XU624 NR2 $PINS O=n1173 I1=n62 I2=n102
XU625 MAOI1 $PINS O=n1171 A1=n81 A2=n1170 B1=n1390 B2=n1169
XU626 ND3 $PINS O=n1150 I1=n1677 I2=n90 I3=n1676
XU627 OR2 $PINS O=n1406 I1=n1376 I2=n1244
XU628 AOI22S $PINS O=n1242 A1=n1 A2=n1241 B1=n67 B2=n1542
XU629 AOI22S $PINS O=n1243 A1=n125 A2=n1434 B1=n123 B2=n31
XU630 NR2 $PINS O=n1494 I1=n1670 I2=FE_OFN125_fold_n_4
XU631 INV1S $PINS O=n113 I=n1584
XU632 AOI22S $PINS O=n1292 A1=n1434 A2=n619 B1=n15 B2=n219
XU633 AOI22S $PINS O=n1291 A1=n1493 A2=n1290 B1=n1553 B2=n1289
XU634 INV1S $PINS O=n614 I=n1028
XU635 AOI22S $PINS O=n1284 A1=n1430 A2=n100 B1=n1553 B2=n67
XU636 NR2 $PINS O=n1675 I1=n1666 I2=n1665
XU637 AN2 $PINS O=n1671 I1=n76 I2=n1669
XU638 NR2 $PINS O=n1673 I1=n1668 I2=n1667
XU639 ND3 $PINS O=n1693 I1=n1626 I2=n1637 I3=n1411
XU640 AN4B1S $PINS O=n1103 I1=n1102 I2=n1402 I3=n1101 B1=n1693
XU641 ND2 $PINS O=n1659 I1=n1468 I2=n1481
XU642 NR2 $PINS O=n1057 I1=n101 I2=n1262
XU643 NR2 $PINS O=n1387 I1=n1588 I2=FE_OFN125_fold_n_4
XU644 ND2 $PINS O=n1588 I1=n972 I2=n1468
XU645 MOAI1S $PINS O=n1638 A1=n1637 A2=n1636 B1=n1635 B2=n1684
XU646 OAI222S $PINS O=n1032 A1=n1692 A2=n1426 B1=n1233 B2=n1637 C1=n1647 C2=n28
XU647 ND3 $PINS O=n1100 I1=n932 I2=n1679 I3=n777
XU648 NR2 $PINS O=n932 I1=n1668 I2=n59
XU649 INV1S $PINS O=n125 I=n1349
XU650 INV1S $PINS O=n592 I=n1681
XU651 OAI22S $PINS O=n1183 A1=FE_OFN125_fold_n_4 A2=n1180 B1=n1248 B2=n36
XU652 OA22 $PINS O=n1622 A1=n1672 A2=n1582 B1=n1645 B2=n1577
XU653 INV1S $PINS O=n107 I=n1686
XU654 AOI22S $PINS O=n1166 A1=n1213 A2=n81 B1=n1430 B2=n97
XU655 INV1S $PINS O=n370 I=n1490
XU656 NR2 $PINS O=n1553 I1=n1697 I2=FE_OFN125_fold_n_4
XU657 INV1S $PINS O=n218 I=n1658
XU658 INV1S $PINS O=n618 I=n1626
XU659 NR2 $PINS O=n1430 I1=n1687 I2=FE_OFN125_fold_n_4
XU660 INV1S $PINS O=n59 I=n1677
XU661 INV1S $PINS O=n119 I=n1596
XU662 INV1S $PINS O=n115 I=n1586
XU663 MOAI1S $PINS O=n1491 A1=n1490 A2=n26 B1=n1489 B2=n413
XU664 MOAI1S $PINS O=n1024 A1=n1658 A2=n1543 B1=n15 B2=n127
XU665 MOAI1S $PINS O=n1193 A1=n1632 A2=n1543 B1=n108 B2=n1635
XU666 MOAI1S $PINS O=n1222 A1=n21 A2=n1252 B1=n101 B2=n1221
XU667 OA22 $PINS O=n1007 A1=n1522 A2=n1685 B1=n1495 B2=n1634
XU668 AN2 $PINS O=n1682 I1=n1676 I2=n93
XU669 NR2 $PINS O=n1678 I1=n130 I2=n122
XU670 NR2 $PINS O=n1680 I1=n369 I2=n614
XU671 INV1S $PINS O=n129 I=n1212
XU672 NR2 $PINS O=n1629 I1=n1634 I2=FE_OFN125_fold_n_4
XU673 INV1S $PINS O=n317 I=n1695
XU674 MOAI1S $PINS O=n1294 A1=n1637 A2=n32 B1=n370 B2=n1489
XU675 INV1S $PINS O=n123 I=n1674
XU676 INV1S $PINS O=n116 I=n1604
XU677 INV1S $PINS O=n114 I=n1645
XU678 INV1S $PINS O=n108 I=n1634
XU679 OAI222S $PINS O=n1053 A1=n1490 A2=n26 B1=n8 B2=n1632 C1=n1244 C2=n21
XU680 INV1S $PINS O=n219 I=n1244
XU681 INV1S $PINS O=n118 I=n1670
XU682 NR2 $PINS O=n1213 I1=n1584 I2=FE_OFN125_fold_n_4
XU683 INV1S $PINS O=n127 I=n1375
XU684 INV1S $PINS O=n221 I=n1351
XU685 NR2 $PINS O=n1493 I1=n1645 I2=FE_OFN125_fold_n_4
XU686 INV1S $PINS O=n117 I=n1697
XU687 MOAI1S $PINS O=n1133 A1=n1658 A2=n1543 B1=n1417 B2=n125
XU688 OAI222S $PINS O=n963 A1=n1244 A2=n8 B1=n1490 B2=n29 C1=n1658 C2=n32
XU689 MOAI1S $PINS O=n1016 A1=n1351 A2=n1548 B1=n123 B2=n15
XU690 MOAI1S $PINS O=n1218 A1=n1212 A2=n26 B1=n123 B2=n1417
XU691 ND3 $PINS O=n1683 I1=n1584 I2=n1588 I3=n1586
XU692 NR2 $PINS O=n1701 I1=FE_OFN125_fold_n_4 I2=n1479
XU693 AOI22S $PINS O=n1474 A1=n1706 A2=n1481 B1=n109 B2=n105
XU694 INV1S $PINS O=n91 I=n1479
XU695 INV1S $PINS O=n106 I=n1468
XU696 NR2 $PINS O=n1565 I1=n104 I2=n85
XU697 NR2 $PINS O=n1706 I1=n_idx[1] I2=n_idx[0]
XU698 ND2 $PINS O=n1591 I1=n1706 I2=n966
XU699 AOI22S $PINS O=n1111 A1=n1099 A2=n17 B1=n22 B2=n124
XU700 ND3 $PINS O=n1099 I1=n1098 I2=n1097 I3=n1096
XU701 NR2 $PINS O=n1096 I1=n1095 I2=n1094
XU702 NR2 $PINS O=n945 I1=n105 I2=n_idx[0]
XU704 ND2 $PINS O=n1597 I1=n945 I2=n966
XU705 ND3 $PINS O=n1307 I1=n1354 I2=n1598 I3=n1306
XU706 NR2 $PINS O=n1654 I1=n620 I2=n_idx[1]
XU707 INV1S $PINS O=n93 I=n1478
XU708 NR2 $PINS O=n1581 I1=n1679 I2=n_idx[0]
XU709 ND2 $PINS O=n1579 I1=n1706 I2=n944
XU710 NR2 $PINS O=n1262 I1=n90 I2=n_idx[0]
XU711 ND2 $PINS O=n1704 I1=n1654 I2=n966
XU712 OAI222S $PINS O=n1661 A1=n1660 A2=n1659 B1=n71 B2=n1658 C1=n1676 C2=n1695
XU713 AN4B1S $PINS O=n1660 I1=n28 I2=n40 I3=n1657 B1=n1656
XU714 AOI22S $PINS O=n1657 A1=n1655 A2=n85 B1=FE_OFN125_fold_n_4 B2=n93
XU715 NR2 $PINS O=n1468 I1=n120 I2=n740
XU716 NR2 $PINS O=n959 I1=n76 I2=FE_OFN262_fold_n_1
XU717 NR2 $PINS O=n1665 I1=n93 I2=FE_OFN262_fold_n_1
XU718 NR2 $PINS O=n1479 I1=n92 I2=n_idx[0]
XU719 ND2 $PINS O=n1681 I1=n1481 I2=n989
XU720 ND2 $PINS O=n1490 I1=n940 I2=n989
XU721 ND2 $PINS O=n1686 I1=n1468 I2=n940
XU722 ND2 $PINS O=n1626 I1=n988 I2=n989
XU723 OAI112HS $PINS O=n1407 A1=n17 B1=n107 C1=n96 C2=n1513
XU724 ND2 $PINS O=n1586 I1=n971 I2=n940
XU725 ND2 $PINS O=n1695 I1=n972 I2=n989
XU726 ND2 $PINS O=n1634 I1=n990 I2=n1468
XU727 ND2 $PINS O=n1604 I1=n996 I2=n971
XU734 ND2 $PINS O=n1645 I1=n972 I2=n971
XU735 OAI12HS $PINS O=sign2[1] A1=n1570 B1=n1572 B2=n1571
XU738 AOI22S $PINS O=n1572 A1=n1569 A2=n630 B1=n1568 B2=n1567
XU741 NR2 $PINS O=n1569 I1=n_idx[4] I2=n1564
XU746 MOAI1S $PINS O=n1568 A1=k_idx[2] A2=n1566 B1=n740 B2=FE_OCPN8_n1652
XU761 NR2 $PINS O=n1481 I1=n18 I2=n1567
XU766 NR2 $PINS O=n1653 I1=FE_OFN125_fold_n_4 I2=n_idx[0]
XU786 AN4B1S $PINS O=n1709 I1=n93 I2=n17 I3=n1703 B1=n103
XU790 NR2 $PINS O=n975 I1=n1567 I2=k_idx[2]
XU792 AN2 $PINS O=n968 I1=n741 I2=n19
XU800 AOI12HS $PINS O=n1471 A1=n1668 B1=n1469 B2=n1666
XU804 NR2 $PINS O=n996 I1=n1477 I2=k_idx[2]
XU805 NR2 $PINS O=n988 I1=n1477 I2=n18
XU809 AN2 $PINS O=n972 I1=n935 I2=n19
XU822 NR2 $PINS O=n1666 I1=n105 I2=n85
XU829 AOI13HS $PINS O=n1566 A1=n1565 B1=n_idx[0] B2=n740 B3=n1666
XU830 INV1S $PINS O=n121 I=n1469
XU831 INV1S $PINS O=n630 I=n1567
XU833 NR2 $PINS O=n944 I1=n85 I2=n_idx[2]
XU844 ND3 $PINS O=sign2[0] I1=n1561 I2=n1560 I3=n1559
XU851 AN4B1S $PINS O=n1559 I1=n1558 I2=n1557 I3=n1556 B1=n1555
XU852 AN4B1S $PINS O=n1561 I1=n25 I2=n1510 I3=n1509 B1=n1573
XU859 NR2 $PINS O=n966 I1=n104 I2=n_idx[3]
XU869 ND3 $PINS O=sign3[0] I1=n1644 I2=n1643 I3=n1642
XU880 AN4B1S $PINS O=n1642 I1=n1641 I2=n1640 I3=n1639 B1=n1638
XU887 AN4B1S $PINS O=n1644 I1=n1576 I2=n1575 I3=n1574 B1=n1573
XU888 ND3 $PINS O=sign1[0] I1=n1467 I2=n1466 I3=n1465
XU892 NR2 $PINS O=n1466 I1=n1432 I2=n1431
XU896 AN4B1S $PINS O=n1467 I1=n1487 I2=n1423 I3=n1574 B1=n1484
XU897 NR2 $PINS O=n1478 I1=n_idx[3] I2=n_idx[2]
XU903 INV1S $PINS O=n740 I=k_idx[1]
XU904 NR2 $PINS O=n971 I1=n120 I2=k_idx[1]
XU906 INV1S $PINS O=n120 I=k_idx[0]
XU910 NR2 $PINS O=n1469 I1=k_idx[1] I2=k_idx[0]
XU911 OAI12HS $PINS O=sign1[1] A1=n1570 B1=n1483 B2=n1571
XU913 AOI22S $PINS O=n1483 A1=n1476 A2=n1567 B1=n1475 B2=n17
XU914 OAI112HS $PINS O=n1475 A1=n1473 B1=n91 C1=n_idx[3] C2=n1474
XU915 OAI222S $PINS O=n1476 A1=k_idx[2] A2=n1471 B1=n76 B2=n1470 C1=n121 C2=n75
XU916 NR2 $PINS O=n741 I1=k_idx[4] I2=k_idx[2]
XU917 INV1S $PINS O=n18 I=k_idx[2]
XU918 AN2 $PINS O=n940 I1=n935 I2=k_idx[3]
XU919 NR2 $PINS O=n935 I1=n18 I2=k_idx[4]
XU926 AOI13HS $PINS O=n1480 A1=n17 B1=k_idx[2] B2=k_idx[1] B3=n1479
XU928 NR2 $PINS O=n1570 I1=n12 I2=n13
XU929 OAI22S $PINS O=n12 A1=k_idx[0] A2=n_idx[0] B1=n1701 B2=n630
XU931 AO13S $PINS O=n13 A1=n1480 B1=n1482 B2=n17 B3=n1481
XU932 INV1S $PINS O=n19 I=k_idx[3]
XU933 AN2 $PINS O=n990 I1=n741 I2=k_idx[3]
XU935 AOI22S $PINS O=n1563 A1=k_idx[2] A2=n1562 B1=n1706 B2=k_idx[1]
XU940 MOAI1S $PINS O=n1562 A1=n_idx[1] A2=n120 B1=n620 B2=k_idx[1]
XU942 INV1S $PINS O=n17 I=n_idx[4]
XU943 ND3S $PINS O=n1473 I1=k_idx[1] I2=n1472 I3=n630
XU944 MOAI1S $PINS O=n1472 A1=n120 A2=n92 B1=n620 B2=n1478
XU946 OAI12HS $PINS O=n1571 A1=n1477 B1=k_idx[4] B2=n19
.ENDS

.SUBCKT SNPS_CLOCK_GATE_HIGH_ROM_Wrapper_Odd_0 EN ENCLK CLK
*.CONNECT net2331 EN
XFE_PHC1357_net2334 DELC $PINS O=FE_PHN1357_net2334 I=net2334
Xlatch QDBHN $PINS Q=net2334 D=net2331 CKB=CLK
Xmain_gate AN2T $PINS O=ENCLK I1=FE_PHN1357_net2334 I2=CLK
.ENDS

.SUBCKT ROM_Wrapper_Odd_0 rst_n en n_in[4] n_in[3] n_in[2] n_in[1] n_in[0]
+ k_idx[4] k_idx[3] k_idx[2] k_idx[1] k_idx[0] reg_sign1[1] reg_sign1[0]
+ reg_sign2[1] reg_sign2[0] reg_sign3[1] reg_sign3[0] reg_shift1[3]
+ reg_shift1[2] reg_shift1[1] reg_shift1[0] reg_shift2[3] reg_shift2[2]
+ reg_shift2[1] reg_shift2[0] reg_shift3[3] reg_shift3[2] reg_shift3[1]
+ reg_shift3[0] i_rst_n clk
*.CONNECT N4 n_in[0]
XCTS_ccl_a_INV_CLK_G1_L10_1 INV3CK $PINS O=CTS_10 I=CTS_11
XCTS_ccl_a_INV_CLK_G1_L9_1 INV2CK $PINS O=CTS_11 I=CTS_12
XFE_OFC562_rom_n_idx_3__3 INV1S $PINS O=n6 I=n_in[3]
Xreg_sign1_reg[1] DFFSBN $PINS Q=reg_sign1[1] D=raw_s1[1] CK=CTS_10 SB=i_rst_n
Xreg_sign2_reg[1] DFFSBN $PINS Q=reg_sign2[1] D=raw_s2[1] CK=CTS_10 SB=i_rst_n
Xreg_sign3_reg[1] DFFSBN $PINS Q=reg_sign3[1] D=raw_s3[1] CK=CTS_10 SB=i_rst_n
Xreg_shift1_reg[1] QDFFRBN $PINS Q=reg_shift1[1] D=raw_h1[1] CK=CTS_10
+ RB=i_rst_n
Xreg_shift2_reg[1] QDFFRBN $PINS Q=reg_shift2[1] D=raw_h2[1] CK=CTS_10
+ RB=i_rst_n
Xreg_shift3_reg[1] QDFFRBN $PINS Q=reg_shift3[1] D=raw_h3[1] CK=CTS_10
+ RB=i_rst_n
Xreg_shift2_reg[2] QDFFRBN $PINS Q=reg_shift2[2] D=raw_h2[2] CK=CTS_10
+ RB=i_rst_n
Xreg_shift2_reg[3] QDFFRBN $PINS Q=reg_shift2[3] D=raw_h2[3] CK=CTS_10
+ RB=i_rst_n
Xreg_shift1_reg[2] QDFFRBN $PINS Q=reg_shift1[2] D=raw_h1[2] CK=CTS_10
+ RB=i_rst_n
Xreg_shift1_reg[0] QDFFRBN $PINS Q=reg_shift1[0] D=raw_h1[0] CK=CTS_10
+ RB=i_rst_n
Xreg_shift2_reg[0] QDFFRBP $PINS Q=reg_shift2[0] D=raw_h2[0] CK=CTS_10
+ RB=i_rst_n
Xreg_shift1_reg[3] QDFFRBP $PINS Q=reg_shift1[3] D=raw_h1[3] CK=CTS_10
+ RB=i_rst_n
Xreg_sign3_reg[0] QDFFRBN $PINS Q=reg_sign3[0] D=final_s3[0] CK=CTS_10
+ RB=i_rst_n
Xreg_sign2_reg[0] QDFFRBN $PINS Q=reg_sign2[0] D=final_s2[0] CK=CTS_10
+ RB=i_rst_n
Xreg_shift3_reg[2] QDFFRBN $PINS Q=reg_shift3[2] D=raw_h3[2] CK=CTS_10
+ RB=i_rst_n
Xreg_shift3_reg[0] QDFFRBN $PINS Q=reg_shift3[0] D=raw_h3[0] CK=CTS_10
+ RB=i_rst_n
Xreg_sign1_reg[0] QDFFRBN $PINS Q=reg_sign1[0] D=final_s1[0] CK=CTS_10
+ RB=i_rst_n
Xreg_shift3_reg[3] QDFFRBN $PINS Q=reg_shift3[3] D=raw_h3[3] CK=CTS_10
+ RB=i_rst_n
XU3 NR2 $PINS O=sub_17/carry[2] I1=N4 I2=n_in[1]
XU4 MOAI1S $PINS O=fold_n[1] A1=n8 A2=N2 B1=N5 B2=N2
XU6 OA13 $PINS O=N2 A1=n_in[4] B1=n_in[1] B2=N4 B3=n13
XU7 ND3S $PINS O=n10 I1=N2 I2=n11 I3=k_idx[0]
XU10 INV1S $PINS O=n9 I=N4
XU11 MOAI1 $PINS O=fold_n[0] A1=n9 A2=N2 B1=N4 B2=N2
XU12 XNR2HS $PINS O=final_s2[0] I1=raw_s2[0] I2=n10
XU13 INV1S $PINS O=n8 I=n_in[1]
XU14 XNR2HS $PINS O=final_s3[0] I1=raw_s3[0] I2=n10
XU15 XNR2HS $PINS O=final_s1[0] I1=raw_s1[0] I2=n10
XU16 MOAI1 $PINS O=fold_n[3] A1=n6 A2=N2 B1=N7 B2=N2
XU17 INV1S $PINS O=n5 I=n_in[2]
XU18 MOAI1S $PINS O=fold_n[2] A1=n5 A2=N2 B1=N6 B2=N2
XU20 MOAI1S $PINS O=fold_n[4] A1=n7 A2=N2 B1=N8 B2=N2
XU21 INV1S $PINS O=n7 I=n_in[4]
XU23 ND3 $PINS O=n11 I1=k_idx[4] I2=k_idx[3] I3=n12
XU24 AN2 $PINS O=n12 I1=k_idx[2] I2=k_idx[1]
XU25 XOR2HS $PINS O=N8 I1=n7 I2=sub_17/carry[4]
XU26 AN2 $PINS O=sub_17/carry[4] I1=sub_17/carry[3] I2=n6
XU27 XOR2HS $PINS O=N7 I1=n6 I2=sub_17/carry[3]
XU28 AN2 $PINS O=sub_17/carry[3] I1=sub_17/carry[2] I2=n5
XU29 XOR2HS $PINS O=N6 I1=n5 I2=sub_17/carry[2]
XU30 XOR2HS $PINS O=N5 I1=n8 I2=n9
XU31 OR2 $PINS O=n13 I1=n_in[3] I2=n_in[2]
Xrom_inst CSD_ROM_Table_odd_0 $PINS n_idx[4]=fold_n[4] n_idx[3]=fold_n[3]
+ n_idx[2]=fold_n[2] n_idx[1]=fold_n[1] n_idx[0]=fold_n[0] k_idx[4]=k_idx[4]
+ k_idx[3]=k_idx[3] k_idx[2]=k_idx[2] k_idx[1]=k_idx[1] k_idx[0]=k_idx[0]
+ sign1[1]=raw_s1[1] sign1[0]=raw_s1[0] shift1[3]=raw_h1[3] shift1[2]=raw_h1[2]
+ shift1[1]=raw_h1[1] shift1[0]=raw_h1[0] sign2[1]=raw_s2[1] sign2[0]=raw_s2[0]
+ shift2[3]=raw_h2[3] shift2[2]=raw_h2[2] shift2[1]=raw_h2[1] shift2[0]=raw_h2[0]
+ sign3[1]=raw_s3[1] sign3[0]=raw_s3[0] shift3[3]=raw_h3[3] shift3[2]=raw_h3[2]
+ shift3[1]=raw_h3[1] shift3[0]=raw_h3[0]
Xclk_gate_reg_shift1_reg SNPS_CLOCK_GATE_HIGH_ROM_Wrapper_Odd_0 $PINS EN=en
+ ENCLK=CTS_12 CLK=clk
.ENDS

.SUBCKT SNPS_CLOCK_GATE_HIGH_PE_Shift_Add_7 EN ENCLK CLK
*.CONNECT net2316 EN
XFE_PHC1290_net2319 DELC $PINS O=FE_PHN1290_net2319 I=net2319
Xlatch QDBHN $PINS Q=net2319 D=net2316 CKB=CLK
Xmain_gate AN2 $PINS O=ENCLK I1=FE_PHN1290_net2319 I2=CLK
.ENDS

.SUBCKT PE_Shift_Add_7_DW01_sub_0_DW01_sub_21 A[26] A[25] A[24] A[23] A[22]
+ A[21] A[20] A[19] A[18] A[17] A[16] A[15] A[14] A[13] A[12] A[11] A[10] A[9]
+ A[8] A[7] A[6] A[5] A[4] A[3] A[2] A[1] A[0] B[26] B[25] B[24] B[23] B[22]
+ B[21] B[20] B[19] B[18] B[17] B[16] B[15] B[14] B[13] B[12] B[11] B[10] B[9]
+ B[8] B[7] B[6] B[5] B[4] B[3] B[2] B[1] B[0] CI DIFF[26] DIFF[25] DIFF[24]
+ DIFF[23] DIFF[22] DIFF[21] DIFF[20] DIFF[19] DIFF[18] DIFF[17] DIFF[16]
+ DIFF[15] DIFF[14] DIFF[13] DIFF[12] DIFF[11] DIFF[10] DIFF[9] DIFF[8] DIFF[7]
+ DIFF[6] DIFF[5] DIFF[4] DIFF[3] DIFF[2] DIFF[1] DIFF[0] CO
XFE_RC_192_0 INV1S $PINS O=FE_RN_88_0 I=n33
XFE_RC_191_0 MXL2HS $PINS OB=DIFF[19] S=n16 A=FE_RN_88_0 B=n33
XFE_RC_3830_0 INV1S $PINS O=FE_RN_2511_0 I=n32
XFE_RC_3829_0 MXL2HS $PINS OB=DIFF[20] S=n17 A=FE_RN_2511_0 B=n32
XFE_RC_3118_0 INV1S $PINS O=FE_RN_2009_0 I=n52
XFE_RC_3117_0 MXL2HS $PINS OB=DIFF[1] S=n51 A=FE_RN_2009_0 B=n52
XFE_OFC838_N124 INV2 $PINS O=n52 I=B[0]
XFE_OFC829_term3_shifted_6 INV1S $PINS O=n46 I=B[6]
XU2 INV1S $PINS O=n50 I=B[2]
XU4 INV2 $PINS O=n48 I=B[4]
XU6 XNR2HS $PINS O=DIFF[2] I1=B[2] I2=n3
XU8 INV1S $PINS O=n47 I=B[5]
XU9 INV1S $PINS O=n45 I=B[7]
XU11 INV1S $PINS O=n44 I=B[8]
XU12 INV1S $PINS O=n43 I=B[9]
XU13 AN2 $PINS O=n1 I1=n46 I2=n24
XU14 AN2 $PINS O=n2 I1=n45 I2=n1
XU15 INV1 $PINS O=n49 I=B[3]
XU16 ND2S $PINS O=n26 I1=n27 I2=n22
XU18 AN2 $PINS O=n4 I1=n50 I2=n3
XU19 AN2T $PINS O=n5 I1=n4 I2=n49
XU20 AN2 $PINS O=n6 I1=n44 I2=n2
XU21 AN2 $PINS O=n7 I1=n43 I2=n6
XU22 AN2 $PINS O=n8 I1=n42 I2=n7
XU23 AN2 $PINS O=n9 I1=n41 I2=n8
XU24 AN2 $PINS O=n10 I1=n40 I2=n9
XU25 AN2 $PINS O=n11 I1=n39 I2=n10
XU26 AN2 $PINS O=n12 I1=n38 I2=n11
XU27 AN2 $PINS O=n13 I1=n37 I2=n12
XU28 AN2 $PINS O=n14 I1=n36 I2=n13
XU29 AN2 $PINS O=n15 I1=n35 I2=n14
XU30 AN2 $PINS O=n16 I1=n34 I2=n15
XU31 AN2 $PINS O=n17 I1=n33 I2=n16
XU32 AN2 $PINS O=n18 I1=n32 I2=n17
XU33 AN2 $PINS O=n19 I1=n31 I2=n18
XU34 AN2 $PINS O=n20 I1=n30 I2=n19
XU35 AN2 $PINS O=n21 I1=n29 I2=n20
XU36 AN2 $PINS O=n22 I1=n28 I2=n21
XU37 AN2T $PINS O=n23 I1=n48 I2=n5
XU38 AN2 $PINS O=n24 I1=n47 I2=n23
XU39 INV1S $PINS O=n42 I=B[10]
XU40 INV1S $PINS O=n41 I=B[11]
XU41 INV1S $PINS O=n40 I=B[12]
XU42 INV1S $PINS O=n39 I=B[13]
XU43 INV1S $PINS O=n38 I=B[14]
XU44 INV1S $PINS O=n37 I=B[15]
XU45 INV1S $PINS O=n36 I=B[16]
XU46 INV1S $PINS O=n35 I=B[17]
XU47 INV1S $PINS O=n34 I=B[18]
XU48 INV1S $PINS O=n33 I=B[19]
XU49 INV1S $PINS O=n32 I=B[20]
XU50 INV1S $PINS O=n31 I=B[21]
XU51 INV1S $PINS O=n30 I=B[22]
XU52 INV1S $PINS O=n29 I=B[23]
XU53 INV1S $PINS O=n28 I=B[24]
XU54 INV1S $PINS O=n27 I=B[25]
XU55 XOR2HS $PINS O=DIFF[3] I1=n49 I2=n4
XU56 XOR2HS $PINS O=DIFF[5] I1=n47 I2=n23
XU57 XOR2HS $PINS O=DIFF[4] I1=n48 I2=n5
XU58 XOR2HS $PINS O=DIFF[7] I1=n45 I2=n1
XU59 XOR2HS $PINS O=DIFF[6] I1=n46 I2=n24
XU60 XOR2HS $PINS O=DIFF[9] I1=n43 I2=n6
XU61 XOR2HS $PINS O=DIFF[8] I1=n44 I2=n2
XU62 XOR2HS $PINS O=DIFF[11] I1=n41 I2=n8
XU63 XOR2HS $PINS O=DIFF[10] I1=n42 I2=n7
XU64 XOR2HS $PINS O=DIFF[12] I1=n40 I2=n9
XU65 XOR2HS $PINS O=DIFF[13] I1=n39 I2=n10
XU66 XOR2HS $PINS O=DIFF[14] I1=n38 I2=n11
XU67 XOR2HS $PINS O=DIFF[15] I1=n37 I2=n12
XU68 XOR2HS $PINS O=DIFF[16] I1=n36 I2=n13
XU69 XOR2HS $PINS O=DIFF[17] I1=n35 I2=n14
XU70 XOR2HS $PINS O=DIFF[18] I1=n34 I2=n15
XU73 XOR2HS $PINS O=DIFF[21] I1=n31 I2=n18
XU74 XOR2HS $PINS O=DIFF[22] I1=n30 I2=n19
XU75 XOR2HS $PINS O=DIFF[23] I1=n29 I2=n20
XU76 XOR2HS $PINS O=DIFF[24] I1=n28 I2=n21
XU77 XOR2HS $PINS O=DIFF[25] I1=n27 I2=n22
XU78 XOR2HS $PINS O=DIFF[26] I1=B[26] I2=n26
XU1 INV2 $PINS O=n51 I=B[1]
XU17 AN2B1T $PINS O=n3 I1=n51 B1=B[0]
.ENDS

.SUBCKT PE_Shift_Add_7_DW01_sub_1_DW01_sub_22 A[26] A[25] A[24] A[23] A[22]
+ A[21] A[20] A[19] A[18] A[17] A[16] A[15] A[14] A[13] A[12] A[11] A[10] A[9]
+ A[8] A[7] A[6] A[5] A[4] A[3] A[2] A[1] A[0] B[26] B[25] B[24] B[23] B[22]
+ B[21] B[20] B[19] B[18] B[17] B[16] B[15] B[14] B[13] B[12] B[11] B[10] B[9]
+ B[8] B[7] B[6] B[5] B[4] B[3] B[2] B[1] B[0] CI DIFF[26] DIFF[25] DIFF[24]
+ DIFF[23] DIFF[22] DIFF[21] DIFF[20] DIFF[19] DIFF[18] DIFF[17] DIFF[16]
+ DIFF[15] DIFF[14] DIFF[13] DIFF[12] DIFF[11] DIFF[10] DIFF[9] DIFF[8] DIFF[7]
+ DIFF[6] DIFF[5] DIFF[4] DIFF[3] DIFF[2] DIFF[1] DIFF[0] CO
*.CONNECT DIFF[0] B[0]
XFE_RC_3874_0 XOR2HS $PINS O=DIFF[3] I1=n51 I2=n4
XFE_RC_123_0 XOR2HS $PINS O=DIFF[1] I1=n54 I2=n53
XU6 INV1S $PINS O=n51 I=B[3]
XU7 INV2 $PINS O=n54 I=B[0]
XU8 INV1S $PINS O=n50 I=B[4]
XU10 XOR2HS $PINS O=DIFF[4] I1=n50 I2=n5
XU11 INV1S $PINS O=n48 I=B[6]
XU12 INV1S $PINS O=n49 I=B[5]
XU13 INV1S $PINS O=n46 I=B[8]
XU14 INV1S $PINS O=n45 I=B[9]
XU15 ND2S $PINS O=DIFF[2] I1=n1 I2=n2
XU16 ND2S $PINS O=n28 I1=n29 I2=n22
XU17 AN2T $PINS O=n3 I1=n53 I2=n54
XU18 AN2 $PINS O=n5 I1=n51 I2=n4
XU19 AN2 $PINS O=n6 I1=n46 I2=n26
XU20 AN2 $PINS O=n7 I1=n45 I2=n6
XU21 AN2 $PINS O=n8 I1=n44 I2=n7
XU22 AN2T $PINS O=n9 I1=n43 I2=n8
XU23 AN2T $PINS O=n10 I1=n42 I2=n9
XU24 AN2T $PINS O=n11 I1=n41 I2=n10
XU25 AN2 $PINS O=n12 I1=n40 I2=n11
XU26 AN2 $PINS O=n13 I1=n39 I2=n12
XU27 AN2 $PINS O=n14 I1=n38 I2=n13
XU28 AN2 $PINS O=n15 I1=n37 I2=n14
XU29 AN2 $PINS O=n16 I1=n36 I2=n15
XU30 AN2 $PINS O=n17 I1=n35 I2=n16
XU31 AN2 $PINS O=n18 I1=n34 I2=n17
XU32 AN2 $PINS O=n19 I1=n33 I2=n18
XU33 AN2 $PINS O=n20 I1=n32 I2=n19
XU34 AN2 $PINS O=n21 I1=n31 I2=n20
XU35 AN2 $PINS O=n22 I1=n30 I2=n21
XU36 AN2 $PINS O=n23 I1=n50 I2=n5
XU37 AN2 $PINS O=n24 I1=n49 I2=n23
XU38 AN2 $PINS O=n25 I1=n48 I2=n24
XU39 AN2 $PINS O=n26 I1=n47 I2=n25
XU40 INV1S $PINS O=n44 I=B[10]
XU41 INV1S $PINS O=n43 I=B[11]
XU42 INV1S $PINS O=n42 I=B[12]
XU43 INV1S $PINS O=n41 I=B[13]
XU44 INV1S $PINS O=n40 I=B[14]
XU45 INV1S $PINS O=n39 I=B[15]
XU46 INV1S $PINS O=n38 I=B[16]
XU47 INV1S $PINS O=n37 I=B[17]
XU48 INV1S $PINS O=n36 I=B[18]
XU49 INV1S $PINS O=n35 I=B[19]
XU50 INV1S $PINS O=n34 I=B[20]
XU51 INV1S $PINS O=n33 I=B[21]
XU52 INV1S $PINS O=n32 I=B[22]
XU53 INV1S $PINS O=n31 I=B[23]
XU54 INV1S $PINS O=n30 I=B[24]
XU55 INV1S $PINS O=n29 I=B[25]
XU56 INV1S $PINS O=n47 I=B[7]
XU57 XOR2HS $PINS O=DIFF[26] I1=B[26] I2=n28
XU58 XOR2HS $PINS O=DIFF[9] I1=n45 I2=n6
XU59 XOR2HS $PINS O=DIFF[10] I1=n44 I2=n7
XU60 XOR2HS $PINS O=DIFF[8] I1=n46 I2=n26
XU61 XOR2HS $PINS O=DIFF[7] I1=n47 I2=n25
XU62 XOR2HS $PINS O=DIFF[6] I1=n48 I2=n24
XU63 XOR2HS $PINS O=DIFF[5] I1=n49 I2=n23
XU65 XOR2HS $PINS O=DIFF[11] I1=n43 I2=n8
XU66 XOR2HS $PINS O=DIFF[12] I1=n42 I2=n9
XU67 XOR2HS $PINS O=DIFF[13] I1=n41 I2=n10
XU68 XOR2HS $PINS O=DIFF[14] I1=n40 I2=n11
XU69 XOR2HS $PINS O=DIFF[15] I1=n39 I2=n12
XU70 XOR2HS $PINS O=DIFF[16] I1=n38 I2=n13
XU71 XOR2HS $PINS O=DIFF[17] I1=n37 I2=n14
XU72 XOR2HS $PINS O=DIFF[18] I1=n36 I2=n15
XU73 XOR2HS $PINS O=DIFF[19] I1=n35 I2=n16
XU74 XOR2HS $PINS O=DIFF[20] I1=n34 I2=n17
XU75 XOR2HS $PINS O=DIFF[21] I1=n33 I2=n18
XU76 XOR2HS $PINS O=DIFF[22] I1=n32 I2=n19
XU77 XOR2HS $PINS O=DIFF[23] I1=n31 I2=n20
XU78 XOR2HS $PINS O=DIFF[24] I1=n30 I2=n21
XU79 XOR2HS $PINS O=DIFF[25] I1=n29 I2=n22
XU1 INV2 $PINS O=n53 I=B[1]
XU2 OR2B1S $PINS O=n55 I1=B[2] B1=n3
XU3 INV2 $PINS O=n4 I=n55
XU4 OR2S $PINS O=n1 I1=n3 I2=B[2]
XU5 ND2 $PINS O=n2 I1=n3 I2=B[2]
.ENDS

.SUBCKT PE_Shift_Add_7_DW01_sub_2_DW01_sub_23 A[26] A[25] A[24] A[23] A[22]
+ A[21] A[20] A[19] A[18] A[17] A[16] A[15] A[14] A[13] A[12] A[11] A[10] A[9]
+ A[8] A[7] A[6] A[5] A[4] A[3] A[2] A[1] A[0] B[26] B[25] B[24] B[23] B[22]
+ B[21] B[20] B[19] B[18] B[17] B[16] B[15] B[14] B[13] B[12] B[11] B[10] B[9]
+ B[8] B[7] B[6] B[5] B[4] B[3] B[2] B[1] B[0] CI DIFF[26] DIFF[25] DIFF[24]
+ DIFF[23] DIFF[22] DIFF[21] DIFF[20] DIFF[19] DIFF[18] DIFF[17] DIFF[16]
+ DIFF[15] DIFF[14] DIFF[13] DIFF[12] DIFF[11] DIFF[10] DIFF[9] DIFF[8] DIFF[7]
+ DIFF[6] DIFF[5] DIFF[4] DIFF[3] DIFF[2] DIFF[1] DIFF[0] CO
*.CONNECT DIFF[0] B[0]
XFE_RC_230_0 XOR2HS $PINS O=DIFF[4] I1=n4 I2=n49
XFE_RC_3934_0 INV1S $PINS O=FE_RN_2563_0 I=n34
XFE_RC_3933_0 MXL2HS $PINS OB=DIFF[19] S=n15 A=FE_RN_2563_0 B=n34
XFE_OFC841_term1_shifted_7 INV1S $PINS O=n46 I=B[7]
XFE_OFC747_term1_shifted_5 INV1S $PINS O=n48 I=B[5]
XU2 NR2 $PINS O=n2 I1=B[1] I2=B[0]
XU3 NR2 $PINS O=n22 I1=B[4] I2=n1
XU4 INV1S $PINS O=n1 I=n4
XU6 INV1S $PINS O=n49 I=B[4]
XU7 INV1S $PINS O=n45 I=B[8]
XU8 XNR2HS $PINS O=DIFF[2] I1=B[2] I2=n2
XU10 INV1S $PINS O=n47 I=B[6]
XU11 INV1S $PINS O=n44 I=B[9]
XU13 XOR2HS $PINS O=DIFF[1] I1=B[0] I2=B[1]
XU14 INV1S $PINS O=n51 I=B[2]
XU15 ND2S $PINS O=n27 I1=n28 I2=n21
XU16 XOR2HS $PINS O=DIFF[3] I1=n50 I2=n3
XU19 XOR2HS $PINS O=DIFF[8] I1=n45 I2=n25
XU20 XOR2HS $PINS O=DIFF[9] I1=n44 I2=n5
XU21 AN2 $PINS O=n5 I1=n45 I2=n25
XU22 XOR2HS $PINS O=DIFF[10] I1=n43 I2=n6
XU23 AN2 $PINS O=n6 I1=n44 I2=n5
XU24 XOR2HS $PINS O=DIFF[11] I1=n42 I2=n7
XU25 AN2 $PINS O=n7 I1=n43 I2=n6
XU26 XOR2HS $PINS O=DIFF[12] I1=n41 I2=n8
XU27 AN2 $PINS O=n8 I1=n42 I2=n7
XU28 XOR2HS $PINS O=DIFF[13] I1=n40 I2=n9
XU29 AN2 $PINS O=n9 I1=n41 I2=n8
XU30 XOR2HS $PINS O=DIFF[14] I1=n39 I2=n10
XU31 AN2 $PINS O=n10 I1=n40 I2=n9
XU32 XOR2HS $PINS O=DIFF[15] I1=n38 I2=n11
XU33 AN2 $PINS O=n11 I1=n39 I2=n10
XU34 XOR2HS $PINS O=DIFF[16] I1=n37 I2=n12
XU35 AN2 $PINS O=n12 I1=n38 I2=n11
XU36 XOR2HS $PINS O=DIFF[17] I1=n36 I2=n13
XU37 AN2 $PINS O=n13 I1=n37 I2=n12
XU38 XOR2HS $PINS O=DIFF[18] I1=n35 I2=n14
XU39 AN2 $PINS O=n14 I1=n36 I2=n13
XU41 AN2 $PINS O=n15 I1=n35 I2=n14
XU42 XOR2HS $PINS O=DIFF[20] I1=n33 I2=n16
XU43 AN2 $PINS O=n16 I1=n34 I2=n15
XU44 XOR2HS $PINS O=DIFF[21] I1=n32 I2=n17
XU45 AN2 $PINS O=n17 I1=n33 I2=n16
XU46 XOR2HS $PINS O=DIFF[22] I1=n31 I2=n18
XU47 AN2 $PINS O=n18 I1=n32 I2=n17
XU48 XOR2HS $PINS O=DIFF[23] I1=n30 I2=n19
XU49 AN2 $PINS O=n19 I1=n31 I2=n18
XU50 AN2 $PINS O=n20 I1=n30 I2=n19
XU51 AN2 $PINS O=n21 I1=n29 I2=n20
XU52 XOR2HS $PINS O=DIFF[24] I1=n29 I2=n20
XU53 XOR2HS $PINS O=DIFF[25] I1=n28 I2=n21
XU55 XOR2HS $PINS O=DIFF[5] I1=n48 I2=n22
XU56 XOR2HS $PINS O=DIFF[6] I1=n47 I2=n23
XU57 AN2 $PINS O=n23 I1=n48 I2=n22
XU58 XOR2HS $PINS O=DIFF[7] I1=n46 I2=n24
XU59 AN2 $PINS O=n24 I1=n47 I2=n23
XU60 AN2 $PINS O=n25 I1=n46 I2=n24
XU61 INV1S $PINS O=n43 I=B[10]
XU62 INV1S $PINS O=n42 I=B[11]
XU63 INV1S $PINS O=n41 I=B[12]
XU64 INV1S $PINS O=n40 I=B[13]
XU65 INV1S $PINS O=n39 I=B[14]
XU66 INV1S $PINS O=n38 I=B[15]
XU67 INV1S $PINS O=n37 I=B[16]
XU68 INV1S $PINS O=n36 I=B[17]
XU69 INV1S $PINS O=n35 I=B[18]
XU70 INV1S $PINS O=n34 I=B[19]
XU71 INV1S $PINS O=n33 I=B[20]
XU72 INV1S $PINS O=n32 I=B[21]
XU73 INV1S $PINS O=n31 I=B[22]
XU74 INV1S $PINS O=n30 I=B[23]
XU75 INV1S $PINS O=n29 I=B[24]
XU76 INV1S $PINS O=n28 I=B[25]
XU77 XOR2HS $PINS O=DIFF[26] I1=B[26] I2=n27
XU1 AN2 $PINS O=n3 I1=n51 I2=n2
XU17 NR2P $PINS O=n4 I1=B[3] I2=n52
XU18 INV1S $PINS O=n52 I=n3
XU78 INV1S $PINS O=n50 I=B[3]
.ENDS

.SUBCKT PE_Shift_Add_7_DW01_add_2_DW01_add_37 A[26] A[25] A[24] A[23] A[22]
+ A[21] A[20] A[19] A[18] A[17] A[16] A[15] A[14] A[13] A[12] A[11] A[10] A[9]
+ A[8] A[7] A[6] A[5] A[4] A[3] A[2] A[1] A[0] B[26] B[25] B[24] B[23] B[22]
+ B[21] B[20] B[19] B[18] B[17] B[16] B[15] B[14] B[13] B[12] B[11] B[10] B[9]
+ B[8] B[7] B[6] B[5] B[4] B[3] B[2] B[1] B[0] CI SUM[26] SUM[25] SUM[24]
+ SUM[23] SUM[22] SUM[21] SUM[20] SUM[19] SUM[18] SUM[17] SUM[16] SUM[15]
+ SUM[14] SUM[13] SUM[12] SUM[11] SUM[10] SUM[9] SUM[8] SUM[7] SUM[6] SUM[5]
+ SUM[4] SUM[3] SUM[2] SUM[1] SUM[0] CO
XFE_RC_283_0 XOR3 $PINS O=SUM[23] I1=A[23] I2=B[23] I3=carry[23]
XFE_RC_282_0 MAO222P $PINS O=carry[24] A1=A[23] B1=B[23] C1=carry[23]
XFE_OCPC7_N163 BUF1 $PINS O=FE_OCPN6_N163 I=B[12]
XFE_RC_165_0 XOR3 $PINS O=SUM[24] I1=A[24] I2=B[24] I3=carry[24]
XFE_RC_164_0 MAO222 $PINS O=carry[25] A1=A[24] B1=B[24] C1=carry[24]
XFE_OCPC1231_carry_11 BUF1S $PINS O=FE_OCPN1231_carry_11 I=carry[11]
XFE_OCPC1159_FE_RN_1 BUF1S $PINS O=FE_OCPN1159_FE_RN_1 I=FE_RN_1
XFE_OCPC1146_carry_19 BUF1S $PINS O=FE_OCPN1146_carry_19 I=carry[19]
XFE_OCPC1137_carry_5 BUF1S $PINS O=FE_OCPN1137_carry_5 I=carry[5]
XFE_RC_4036_0 XOR3 $PINS O=SUM[20] I1=A[20] I2=B[20] I3=carry[20]
XFE_RC_4035_0 MAO222P $PINS O=carry[21] A1=A[20] B1=B[20] C1=carry[20]
XFE_RC_3964_0 XOR3 $PINS O=SUM[21] I1=A[21] I2=B[21] I3=carry[21]
XFE_RC_3963_0 MAO222 $PINS O=carry[22] A1=A[21] B1=B[21] C1=carry[21]
XFE_RC_3923_0 XOR3 $PINS O=SUM[26] I1=A[26] I2=B[26] I3=carry[26]
XFE_RC_3896_0 ND3P $PINS O=carry[3] I1=n9 I2=n11 I3=n10
XFE_RC_3569_0 OR2 $PINS O=FE_RN_2331_0 I1=FE_RN_762_0 I2=FE_RN_761_0
XFE_RC_3568_0 ND2P $PINS O=carry[7] I1=FE_RN_764_0 I2=FE_RN_2331_0
XFE_RC_3194_0 OR2 $PINS O=FE_RN_2061_0 I1=A[8] I2=B[8]
XFE_RC_3193_0 ND2P $PINS O=FE_RN_239_0 I1=carry[8] I2=FE_RN_2061_0
XFE_RC_3056_0 INV1S $PINS O=FE_RN_1962_0 I=carry[22]
XFE_RC_3054_0 INV1S $PINS O=FE_RN_1964_0 I=A[22]
XFE_RC_3052_0 ND2 $PINS O=FE_RN_1966_0 I1=FE_RN_1964_0 I2=B[22]
XFE_RC_3051_0 OAI12HS $PINS O=FE_RN_1967_0 A1=FE_RN_1966_0 B1=FE_RN_1964_0
+ B2=B[22]
XFE_RC_3050_0 ND2 $PINS O=FE_RN_1968_0 I1=FE_RN_1967_0 I2=FE_RN_1962_0
XFE_RC_3049_0 OAI12H $PINS O=SUM[22] A1=FE_RN_1968_0 B1=FE_RN_1967_0
+ B2=FE_RN_1962_0
XFE_RC_3048_0 ND2 $PINS O=FE_RN_1969_0 I1=A[22] I2=B[22]
XFE_RC_3047_0 OAI12H $PINS O=FE_RN_1970_0 A1=carry[22] B1=A[22] B2=B[22]
XFE_RC_3046_0 ND2P $PINS O=carry[23] I1=FE_RN_1970_0 I2=FE_RN_1969_0
XFE_RC_3045_0 AOI22H $PINS O=FE_RN_1170_0 A1=B[13] A2=A[13] B1=carry[13]
+ B2=A[13]
XFE_RC_1969_0_dup ND2P $PINS O=FE_RN_1 I1=FE_RN_1170_0 I2=FE_RN_1169_0
XFE_RC_2878_0 OAI12H $PINS O=carry[20] A1=FE_RN_1636_0 B1=FE_RN_1632_0
+ B2=FE_RN_1624_0
XFE_RC_2596_0 INV1S $PINS O=FE_RN_1624_0 I=A[19]
XFE_RC_2595_0 NR2 $PINS O=FE_RN_1625_0 I1=B[19] I2=FE_RN_1624_0
XFE_RC_2594_0 AN2B1S $PINS O=FE_RN_1626_0 I1=B[19] B1=A[19]
XFE_RC_2593_0 INV1S $PINS O=FE_RN_1627_0 I=carry[19]
XFE_RC_2592_0 OAI12HS $PINS O=FE_RN_1628_0 A1=FE_RN_1627_0 B1=FE_RN_1626_0
+ B2=FE_RN_1625_0
XFE_RC_2591_0 ND2 $PINS O=FE_RN_1629_0 I1=A[19] I2=B[19]
XFE_RC_2590_0 ND2 $PINS O=FE_RN_1630_0 I1=FE_RN_1629_0 I2=FE_RN_1635_0
XFE_RC_2589_0 ND2 $PINS O=FE_RN_1631_0 I1=FE_RN_1630_0 I2=FE_OCPN1146_carry_19
XFE_RC_2588_0 ND2P $PINS O=SUM[19] I1=FE_RN_1631_0 I2=FE_RN_1628_0
XFE_RC_2587_0 INV1S $PINS O=FE_RN_1632_0 I=B[19]
XFE_RC_2585_0 INV1S $PINS O=FE_RN_1634_0 I=A[19]
XFE_RC_2584_0 OR2B1P $PINS O=FE_RN_1635_0 I1=B[19] B1=FE_RN_1634_0
XFE_RC_2583_0 ND2P $PINS O=FE_RN_1636_0 I1=FE_RN_1635_0 I2=carry[19]
XFE_RC_2172_0 ND2P $PINS O=FE_RN_1318_0 I1=carry[9] I2=B[9]
XFE_RC_2171_0 AOI22H $PINS O=FE_RN_1319_0 A1=B[9] A2=A[9] B1=carry[9] B2=A[9]
XFE_RC_2170_0 ND2P $PINS O=carry[10] I1=FE_RN_1319_0 I2=FE_RN_1318_0
XFE_RC_2169_0 ND2 $PINS O=FE_RN_1316_0 I1=carry[11] I2=B[11]
XFE_RC_2168_0 AOI22H $PINS O=FE_RN_1317_0 A1=B[11] A2=A[11] B1=carry[11]
+ B2=A[11]
XFE_RC_2167_0 ND2P $PINS O=carry[12] I1=FE_RN_1317_0 I2=FE_RN_1316_0
XFE_RC_2163_0 XOR2HS $PINS O=FE_RN_1309_0 I1=B[18] I2=A[18]
XFE_RC_2162_0 XOR2HS $PINS O=SUM[18] I1=carry[18] I2=FE_RN_1309_0
XFE_RC_2161_0 ND2 $PINS O=FE_RN_1310_0 I1=A[18] I2=B[18]
XFE_RC_2160_0 INV1S $PINS O=FE_RN_1311_0 I=A[18]
XFE_RC_2159_0 OR2B1S $PINS O=FE_RN_1312_0 I1=B[18] B1=FE_RN_1311_0
XFE_RC_2158_0 ND2 $PINS O=FE_RN_1313_0 I1=FE_RN_1312_0 I2=carry[18]
XFE_RC_2157_0 ND2P $PINS O=carry[19] I1=FE_RN_1313_0 I2=FE_RN_1310_0
XFE_RC_2155_0 ND3P $PINS O=carry[17] I1=n3 I2=n4 I3=n2
XFE_RC_1971_0 ND2 $PINS O=FE_RN_1169_0 I1=carry[13] I2=B[13]
XFE_RC_1968_0 ND3P $PINS O=carry[18] I1=n7 I2=n8 I3=n6
XFE_RC_1854_0 ND2 $PINS O=FE_RN_1083_0 I1=FE_RN_1 I2=B[14]
XFE_RC_1853_0 AOI22H $PINS O=FE_RN_1084_0 A1=B[14] A2=A[14] B1=FE_RN_1 B2=A[14]
XFE_RC_1852_0 ND2P $PINS O=carry[15] I1=FE_RN_1084_0 I2=FE_RN_1083_0
XFE_RC_1805_0 ND2 $PINS O=FE_RN_1043_0 I1=carry[15] I2=B[15]
XFE_RC_1804_0 AOI22H $PINS O=FE_RN_1044_0 A1=B[15] A2=A[15] B1=carry[15]
+ B2=A[15]
XFE_RC_1803_0 ND2P $PINS O=carry[16] I1=FE_RN_1044_0 I2=FE_RN_1043_0
XFE_RC_1802_0 ND2 $PINS O=FE_RN_1041_0 I1=carry[10] I2=B[10]
XFE_RC_1801_0 AOI22H $PINS O=FE_RN_1042_0 A1=B[10] A2=A[10] B1=carry[10]
+ B2=A[10]
XFE_RC_1800_0 ND2P $PINS O=carry[11] I1=FE_RN_1042_0 I2=FE_RN_1041_0
XFE_RC_1435_0 INV1S $PINS O=FE_RN_755_0 I=carry[6]
XFE_RC_1434_0 XOR2HS $PINS O=FE_RN_756_0 I1=B[6] I2=A[6]
XFE_RC_1433_0 ND2S $PINS O=FE_RN_757_0 I1=FE_RN_756_0 I2=FE_RN_755_0
XFE_RC_1432_0 ND2 $PINS O=FE_RN_758_0 I1=A[6] I2=B[6]
XFE_RC_1431_0 ND2 $PINS O=FE_RN_759_0 I1=FE_RN_758_0 I2=FE_RN_763_0
XFE_RC_1430_0 ND2 $PINS O=FE_RN_760_0 I1=FE_RN_759_0 I2=carry[6]
XFE_RC_1429_0 ND2P $PINS O=SUM[6] I1=FE_RN_760_0 I2=FE_RN_757_0
XFE_RC_1428_0 INV1S $PINS O=FE_RN_761_0 I=B[6]
XFE_RC_1427_0 INV1S $PINS O=FE_RN_762_0 I=A[6]
XFE_RC_1426_0 OR2 $PINS O=FE_RN_763_0 I1=B[6] I2=A[6]
XFE_RC_1425_0 ND2 $PINS O=FE_RN_764_0 I1=carry[6] I2=FE_RN_763_0
XFE_RC_1321_0 INV1S $PINS O=FE_RN_678_0 I=FE_RN_570_0
XFE_RC_1320_0 OR2B1S $PINS O=FE_RN_679_0 I1=FE_RN_569_0 B1=FE_RN_678_0
XFE_RC_1319_0 ND2P $PINS O=carry[8] I1=FE_RN_572_0 I2=FE_RN_679_0
XFE_RC_1185_0 INV1S $PINS O=FE_RN_563_0 I=carry[7]
XFE_RC_1184_0 XOR2HS $PINS O=FE_RN_564_0 I1=B[7] I2=A[7]
XFE_RC_1183_0 ND2 $PINS O=FE_RN_565_0 I1=FE_RN_564_0 I2=FE_RN_563_0
XFE_RC_1182_0 ND2 $PINS O=FE_RN_566_0 I1=A[7] I2=B[7]
XFE_RC_1181_0 ND2 $PINS O=FE_RN_567_0 I1=FE_RN_566_0 I2=FE_RN_571_0
XFE_RC_1180_0 ND2 $PINS O=FE_RN_568_0 I1=FE_RN_567_0 I2=carry[7]
XFE_RC_1179_0 ND2P $PINS O=SUM[7] I1=FE_RN_568_0 I2=FE_RN_565_0
XFE_RC_1178_0 INV1S $PINS O=FE_RN_569_0 I=B[7]
XFE_RC_1177_0 INV1S $PINS O=FE_RN_570_0 I=A[7]
XFE_RC_1176_0 OR2 $PINS O=FE_RN_571_0 I1=B[7] I2=A[7]
XFE_RC_1175_0 ND2 $PINS O=FE_RN_572_0 I1=carry[7] I2=FE_RN_571_0
XFE_RC_716_0 XOR2HS $PINS O=FE_RN_237_0 I1=B[8] I2=A[8]
XFE_RC_715_0 XOR2HS $PINS O=SUM[8] I1=carry[8] I2=FE_RN_237_0
XFE_RC_714_0 ND2S $PINS O=FE_RN_238_0 I1=A[8] I2=B[8]
XFE_RC_712_0 ND2P $PINS O=carry[9] I1=FE_RN_239_0 I2=FE_RN_238_0
XFE_RC_572_0 XOR3 $PINS O=SUM[9] I1=A[9] I2=B[9] I3=carry[9]
XFE_RC_569_0 XOR3 $PINS O=SUM[5] I1=A[5] I2=B[5] I3=FE_OCPN1137_carry_5
XFE_RC_568_0 MAO222 $PINS O=carry[6] A1=carry[5] B1=B[5] C1=A[5]
XFE_RC_494_0 XOR3 $PINS O=SUM[10] I1=A[10] I2=B[10] I3=carry[10]
XFE_RC_426_0 OR2 $PINS O=FE_RN_118_0 I1=FE_RN_54_0 I2=FE_RN_62_0
XFE_RC_425_0 ND2P $PINS O=carry[13] I1=FE_RN_66_0 I2=FE_RN_118_0
XFE_RC_322_0 INV1S $PINS O=FE_RN_53_0 I=carry[12]
XFE_RC_321_0 INV1S $PINS O=FE_RN_54_0 I=A[12]
XFE_RC_319_0 ND2S $PINS O=FE_RN_56_0 I1=FE_RN_54_0 I2=FE_OCPN6_N163
XFE_RC_318_0 OAI12HS $PINS O=FE_RN_57_0 A1=FE_RN_56_0 B1=FE_RN_54_0
+ B2=FE_OCPN6_N163
XFE_RC_317_0 ND2 $PINS O=FE_RN_58_0 I1=FE_RN_57_0 I2=FE_RN_53_0
XFE_RC_316_0 ND2 $PINS O=FE_RN_59_0 I1=A[12] I2=FE_OCPN6_N163
XFE_RC_315_0 ND2S $PINS O=FE_RN_60_0 I1=FE_RN_59_0 I2=FE_RN_65_0
XFE_RC_314_0 ND2 $PINS O=FE_RN_61_0 I1=FE_RN_60_0 I2=carry[12]
XFE_RC_313_0 ND2P $PINS O=SUM[12] I1=FE_RN_61_0 I2=FE_RN_58_0
XFE_RC_312_0 INV1S $PINS O=FE_RN_62_0 I=B[12]
XFE_RC_309_0 OR2B1S $PINS O=FE_RN_65_0 I1=B[12] B1=FE_RN_54_0
XFE_RC_308_0 ND2 $PINS O=FE_RN_66_0 I1=FE_RN_65_0 I2=carry[12]
XFE_RC_239_0 XOR3 $PINS O=SUM[11] I1=A[11] I2=B[11] I3=FE_OCPN1231_carry_11
XFE_RC_188_0 XOR3 $PINS O=SUM[13] I1=A[13] I2=B[13] I3=carry[13]
XFE_RC_184_0 ND3 $PINS O=carry[5] I1=n14 I2=n13 I3=n15
XFE_RC_104_0 XOR3 $PINS O=SUM[14] I1=A[14] I2=B[14] I3=FE_OCPN1159_FE_RN_1
XFE_RC_68_0 XOR3 $PINS O=SUM[15] I1=A[15] I2=B[15] I3=carry[15]
XU1_3 FA1 $PINS S=SUM[3] CO=carry[4] A=A[3] B=B[3] CI=carry[3]
XU1_25 FA1 $PINS S=SUM[25] CO=carry[26] A=A[25] B=B[25] CI=carry[25]
XU1_1 FA1 $PINS S=SUM[1] CO=carry[2] A=B[1] B=A[1] CI=n1
XU1 ND2 $PINS O=n15 I1=A[4] I2=B[4]
XU3 XOR3 $PINS O=SUM[4] I1=A[4] I2=B[4] I3=n12
XU5 AN2 $PINS O=n1 I1=B[0] I2=A[0]
XU6 XOR3 $PINS O=SUM[16] I1=A[16] I2=B[16] I3=carry[16]
XU7 ND2 $PINS O=n2 I1=A[16] I2=B[16]
XU8 ND2 $PINS O=n3 I1=carry[16] I2=A[16]
XU9 ND2 $PINS O=n4 I1=carry[16] I2=B[16]
XU11 XOR2HS $PINS O=n5 I1=A[17] I2=B[17]
XU12 XOR2HS $PINS O=SUM[17] I1=carry[17] I2=n5
XU13 ND2 $PINS O=n6 I1=A[17] I2=B[17]
XU14 ND2 $PINS O=n7 I1=carry[17] I2=A[17]
XU15 ND2 $PINS O=n8 I1=carry[17] I2=B[17]
XU17 ND2 $PINS O=n9 I1=B[2] I2=carry[2]
XU18 ND2 $PINS O=n10 I1=B[2] I2=A[2]
XU19 ND2 $PINS O=n11 I1=carry[2] I2=A[2]
XU20 ND2 $PINS O=n14 I1=carry[4] I2=B[4]
XU21 MAO222 $PINS O=n12 A1=carry[3] B1=B[3] C1=A[3]
XU23 ND2 $PINS O=n13 I1=n12 I2=A[4]
XU24 XOR2HS $PINS O=SUM[0] I1=B[0] I2=A[0]
XU4 XOR3 $PINS O=SUM[2] I1=carry[2] I2=A[2] I3=B[2]
.ENDS

.SUBCKT PE_Shift_Add_7_DW01_add_1_DW01_add_36 A[26] A[25] A[24] A[23] A[22]
+ A[21] A[20] A[19] A[18] A[17] A[16] A[15] A[14] A[13] A[12] A[11] A[10] A[9]
+ A[8] A[7] A[6] A[5] A[4] A[3] A[2] A[1] A[0] B[26] B[25] B[24] B[23] B[22]
+ B[21] B[20] B[19] B[18] B[17] B[16] B[15] B[14] B[13] B[12] B[11] B[10] B[9]
+ B[8] B[7] B[6] B[5] B[4] B[3] B[2] B[1] B[0] CI SUM[26] SUM[25] SUM[24]
+ SUM[23] SUM[22] SUM[21] SUM[20] SUM[19] SUM[18] SUM[17] SUM[16] SUM[15]
+ SUM[14] SUM[13] SUM[12] SUM[11] SUM[10] SUM[9] SUM[8] SUM[7] SUM[6] SUM[5]
+ SUM[4] SUM[3] SUM[2] SUM[1] SUM[0] CO
XFE_RC_267_0 ND3HT $PINS O=carry[11] I1=n10 I2=n9 I3=n11
XFE_RC_157_0 XOR3P $PINS O=SUM[22] I1=A[22] I2=B[22] I3=carry[22]
XFE_RC_156_0 MAO222P $PINS O=carry[23] A1=A[22] B1=B[22] C1=carry[22]
XFE_OCPC1151_carry_10 BUF1S $PINS O=FE_OCPN1151_carry_10 I=carry[10]
XFE_OCPC1147_FE_RN_1 BUF1S $PINS O=FE_OCPN1147_FE_RN_1 I=FE_RN_1
XFE_OCPC1107_carry_4 BUF1S $PINS O=FE_OCPN1107_carry_4 I=carry[4]
XFE_OCPC1105_carry_7 BUF1CK $PINS O=FE_OCPN1105_carry_7 I=carry[7]
XFE_OCPC1097_carry_6 BUF1CK $PINS O=FE_OCPN1097_carry_6 I=carry[6]
XFE_OCPC1095_carry_5 BUF1S $PINS O=FE_OCPN1095_carry_5 I=carry[5]
XFE_OCPC954_carry_24 BUF1S $PINS O=FE_OCPN954_carry_24 I=carry[24]
XFE_RC_4043_0 XOR3 $PINS O=SUM[23] I1=A[23] I2=B[23] I3=carry[23]
XFE_RC_4042_0 MAO222 $PINS O=carry[24] A1=A[23] B1=B[23] C1=carry[23]
XFE_RC_3940_0 ND3P $PINS O=carry[16] I1=n8 I2=n7 I3=n6
XFE_RC_3902_0 XOR3 $PINS O=SUM[24] I1=A[24] I2=B[24] I3=FE_OCPN954_carry_24
XFE_RC_3901_0 MAO222 $PINS O=carry[25] A1=A[24] B1=B[24] C1=carry[24]
XFE_RC_3835_0 INV2 $PINS O=SUM[8] I=FE_RN_2514_0
XFE_RC_3834_0 XNR3 $PINS O=FE_RN_2514_0 I1=A[8] I2=B[8] I3=carry[8]
XFE_RC_1394_0_dup ND2P $PINS O=FE_RN_1 I1=FE_RN_735_0 I2=FE_RN_734_0
XFE_RC_3354_0 INV1S $PINS O=FE_RN_2165_0 I=A[20]
XFE_RC_3353_0 NR2 $PINS O=FE_RN_2166_0 I1=B[20] I2=FE_RN_2165_0
XFE_RC_3352_0 AN2B1S $PINS O=FE_RN_2167_0 I1=B[20] B1=A[20]
XFE_RC_3351_0 INV1S $PINS O=FE_RN_2168_0 I=carry[20]
XFE_RC_3350_0 OAI12HS $PINS O=FE_RN_2169_0 A1=FE_RN_2168_0 B1=FE_RN_2167_0
+ B2=FE_RN_2166_0
XFE_RC_3349_0 ND2 $PINS O=FE_RN_2170_0 I1=A[20] I2=B[20]
XFE_RC_3348_0 ND2S $PINS O=FE_RN_2171_0 I1=FE_RN_2170_0 I2=FE_RN_2177_0
XFE_RC_3347_0 ND2 $PINS O=FE_RN_2172_0 I1=FE_RN_2171_0 I2=carry[20]
XFE_RC_3346_0 ND2 $PINS O=SUM[20] I1=FE_RN_2172_0 I2=FE_RN_2169_0
XFE_RC_3345_0 INV1S $PINS O=FE_RN_2173_0 I=B[20]
XFE_RC_3343_0 INV2 $PINS O=FE_RN_2175_0 I=B[20]
XFE_RC_3341_0 ND2P $PINS O=FE_RN_2177_0 I1=FE_RN_2175_0 I2=FE_RN_2165_0
XFE_RC_3340_0 ND2 $PINS O=FE_RN_2178_0 I1=FE_RN_2177_0 I2=carry[20]
XFE_RC_3339_0 OAI12HS $PINS O=carry[21] A1=FE_RN_2178_0 B1=FE_RN_2165_0
+ B2=FE_RN_2173_0
XFE_RC_3001_0 ND2 $PINS O=FE_RN_1929_0 I1=carry[11] I2=B[11]
XFE_RC_3000_0 AOI22H $PINS O=FE_RN_1930_0 A1=B[11] A2=A[11] B1=carry[11]
+ B2=A[11]
XFE_RC_2999_0 ND2P $PINS O=carry[12] I1=FE_RN_1930_0 I2=FE_RN_1929_0
XFE_RC_2851_0 ND2 $PINS O=FE_RN_1820_0 I1=carry[12] I2=B[12]
XFE_RC_2850_0 AOI22H $PINS O=FE_RN_1821_0 A1=B[12] A2=A[12] B1=carry[12]
+ B2=A[12]
XFE_RC_2849_0 ND2P $PINS O=carry[13] I1=FE_RN_1821_0 I2=FE_RN_1820_0
XFE_RC_2471_0 ND2 $PINS O=FE_RN_1543_0 I1=carry[13] I2=B[13]
XFE_RC_2470_0 AOI22H $PINS O=FE_RN_1544_0 A1=B[13] A2=A[13] B1=carry[13]
+ B2=A[13]
XFE_RC_2469_0 ND2P $PINS O=carry[14] I1=FE_RN_1544_0 I2=FE_RN_1543_0
XFE_RC_2145_0 INV1S $PINS O=FE_RN_1296_0 I=FE_RN_1301_0
XFE_RC_2144_0 AOI12HS $PINS O=FE_RN_1297_0 A1=FE_RN_1296_0 B1=A[19] B2=B[19]
XFE_RC_2143_0 XNR2HS $PINS O=FE_RN_1298_0 I1=B[19] I2=A[19]
XFE_RC_2142_0 MXL2HS $PINS OB=SUM[19] S=carry[19] A=FE_RN_1298_0 B=FE_RN_1297_0
XFE_RC_2141_0 ND2 $PINS O=FE_RN_1299_0 I1=A[19] I2=B[19]
XFE_RC_2140_0 INV1S $PINS O=FE_RN_1300_0 I=A[19]
XFE_RC_2139_0 OR2B1S $PINS O=FE_RN_1301_0 I1=B[19] B1=FE_RN_1300_0
XFE_RC_2138_0 ND2 $PINS O=FE_RN_1302_0 I1=FE_RN_1301_0 I2=carry[19]
XFE_RC_2137_0 ND2P $PINS O=carry[20] I1=FE_RN_1302_0 I2=FE_RN_1299_0
XFE_RC_1847_0 INV1S $PINS O=FE_RN_1069_0 I=A[18]
XFE_RC_1846_0 AN2B1S $PINS O=FE_RN_1070_0 I1=B[18] B1=FE_RN_1069_0
XFE_RC_1845_0 AN2B1S $PINS O=FE_RN_1071_0 I1=FE_RN_1079_0 B1=FE_RN_1070_0
XFE_RC_1842_0 NR2 $PINS O=FE_RN_1074_0 I1=B[18] I2=FE_RN_1069_0
XFE_RC_1841_0 AOI12HS $PINS O=FE_RN_1075_0 A1=FE_RN_1074_0 B1=FE_RN_1069_0
+ B2=B[18]
XFE_RC_1840_0 MXL2HS $PINS OB=SUM[18] S=carry[18] A=FE_RN_1075_0 B=FE_RN_1071_0
XFE_RC_1839_0 ND2 $PINS O=FE_RN_1076_0 I1=A[18] I2=B[18]
XFE_RC_1838_0 INV1S $PINS O=FE_RN_1077_0 I=B[18]
XFE_RC_1836_0 ND2 $PINS O=FE_RN_1079_0 I1=FE_RN_1069_0 I2=FE_RN_1077_0
XFE_RC_1835_0 ND2 $PINS O=FE_RN_1080_0 I1=carry[18] I2=FE_RN_1079_0
XFE_RC_1834_0 ND2P $PINS O=carry[19] I1=FE_RN_1080_0 I2=FE_RN_1076_0
XFE_RC_1396_0 ND2 $PINS O=FE_RN_734_0 I1=carry[8] I2=B[8]
XFE_RC_1395_0 AOI22H $PINS O=FE_RN_735_0 A1=B[8] A2=A[8] B1=carry[8] B2=A[8]
XFE_RC_1375_0 INV1S $PINS O=FE_RN_709_0 I=FE_RN_717_0
XFE_RC_1374_0 AOI12HS $PINS O=FE_RN_710_0 A1=FE_RN_709_0 B1=A[17] B2=B[17]
XFE_RC_1373_0 INV1S $PINS O=FE_RN_711_0 I=A[17]
XFE_RC_1371_0 NR2 $PINS O=FE_RN_713_0 I1=B[17] I2=FE_RN_711_0
XFE_RC_1370_0 AOI12HS $PINS O=FE_RN_714_0 A1=FE_RN_713_0 B1=FE_RN_711_0
+ B2=B[17]
XFE_RC_1369_0 MXL2HS $PINS OB=SUM[17] S=carry[17] A=FE_RN_714_0 B=FE_RN_710_0
XFE_RC_1368_0 ND2 $PINS O=FE_RN_715_0 I1=A[17] I2=B[17]
XFE_RC_1366_0 OR2B1 $PINS O=FE_RN_717_0 I1=B[17] B1=FE_RN_711_0
XFE_RC_1365_0 ND2P $PINS O=FE_RN_718_0 I1=carry[17] I2=FE_RN_717_0
XFE_RC_1364_0 ND2P $PINS O=carry[18] I1=FE_RN_718_0 I2=FE_RN_715_0
XFE_RC_1313_0 ND2 $PINS O=FE_RN_673_0 I1=carry[7] I2=B[7]
XFE_RC_1312_0 AOI22H $PINS O=FE_RN_674_0 A1=B[7] A2=A[7] B1=carry[7] B2=A[7]
XFE_RC_1311_0 ND2P $PINS O=carry[8] I1=FE_RN_674_0 I2=FE_RN_673_0
XFE_RC_1006_0 ND2 $PINS O=FE_RN_439_0 I1=FE_RN_1 I2=B[9]
XFE_RC_1005_0 AOI22H $PINS O=FE_RN_440_0 A1=B[9] A2=A[9] B1=FE_RN_1 B2=A[9]
XFE_RC_1004_0 ND2P $PINS O=carry[10] I1=FE_RN_440_0 I2=FE_RN_439_0
XFE_RC_999_0 AN2B1S $PINS O=FE_RN_427_0 I1=B[16] B1=FE_RN_430_0
XFE_RC_998_0 AN2B1S $PINS O=FE_RN_428_0 I1=FE_RN_435_0 B1=FE_RN_427_0
XFE_RC_997_0 INV1S $PINS O=FE_RN_429_0 I=B[16]
XFE_RC_996_0 INV1S $PINS O=FE_RN_430_0 I=A[16]
XFE_RC_995_0 AOI22S $PINS O=FE_RN_431_0 A1=FE_RN_430_0 A2=B[16] B1=A[16]
+ B2=FE_RN_429_0
XFE_RC_994_0 MXL2HS $PINS OB=SUM[16] S=carry[16] A=FE_RN_431_0 B=FE_RN_428_0
XFE_RC_993_0 ND2 $PINS O=FE_RN_432_0 I1=A[16] I2=B[16]
XFE_RC_990_0 ND2 $PINS O=FE_RN_435_0 I1=FE_RN_430_0 I2=FE_RN_429_0
XFE_RC_989_0 ND2 $PINS O=FE_RN_436_0 I1=carry[16] I2=FE_RN_435_0
XFE_RC_988_0 ND2P $PINS O=carry[17] I1=FE_RN_436_0 I2=FE_RN_432_0
XFE_RC_762_0 ND2P $PINS O=FE_RN_253_0 I1=carry[4] I2=B[4]
XFE_RC_761_0 AOI22H $PINS O=FE_RN_254_0 A1=B[4] A2=A[4] B1=carry[4] B2=A[4]
XFE_RC_760_0 ND2P $PINS O=carry[5] I1=FE_RN_254_0 I2=FE_RN_253_0
XFE_RC_759_0 ND2 $PINS O=FE_RN_251_0 I1=carry[6] I2=B[6]
XFE_RC_758_0 AOI22H $PINS O=FE_RN_252_0 A1=B[6] A2=A[6] B1=carry[6] B2=A[6]
XFE_RC_757_0 ND2P $PINS O=carry[7] I1=FE_RN_252_0 I2=FE_RN_251_0
XFE_RC_663_0 ND2P $PINS O=FE_RN_209_0 I1=carry[5] I2=B[5]
XFE_RC_662_0 AOI22H $PINS O=FE_RN_210_0 A1=B[5] A2=A[5] B1=carry[5] B2=A[5]
XFE_RC_661_0 ND2P $PINS O=carry[6] I1=FE_RN_210_0 I2=FE_RN_209_0
XFE_RC_639_0 XOR3 $PINS O=SUM[11] I1=A[11] I2=B[11] I3=carry[11]
XFE_RC_479_0 XOR3 $PINS O=SUM[12] I1=A[12] I2=B[12] I3=carry[12]
XFE_RC_474_0 XOR3 $PINS O=SUM[4] I1=A[4] I2=B[4] I3=FE_OCPN1107_carry_4
XFE_RC_415_0 XOR3 $PINS O=SUM[5] I1=A[5] I2=B[5] I3=FE_OCPN1095_carry_5
XFE_RC_283_0 XOR3 $PINS O=SUM[13] I1=A[13] I2=B[13] I3=carry[13]
XFE_RC_281_0 XOR3 $PINS O=SUM[6] I1=A[6] I2=B[6] I3=FE_OCPN1097_carry_6
XFE_RC_231_0 XOR3 $PINS O=SUM[7] I1=A[7] I2=B[7] I3=FE_OCPN1105_carry_7
XFE_RC_164_0 ND3P $PINS O=carry[15] I1=n3 I2=n4 I3=n2
XFE_RC_142_0 XOR3 $PINS O=SUM[9] I1=A[9] I2=B[9] I3=FE_OCPN1147_FE_RN_1
XU1_21 FA1 $PINS S=SUM[21] CO=carry[22] A=A[21] B=B[21] CI=carry[21]
XU1_2 FA1 $PINS S=SUM[2] CO=carry[3] A=A[2] B=n12 CI=B[2]
XU1_1 FA1 $PINS S=SUM[1] CO=carry[2] A=A[1] B=B[1] CI=n1
XU1_25 FA1 $PINS S=SUM[25] CO=carry[26] A=A[25] B=B[25] CI=carry[25]
XU1_26 XOR3 $PINS O=SUM[26] I1=A[26] I2=B[26] I3=carry[26]
XU2 XOR3 $PINS O=SUM[14] I1=A[14] I2=B[14] I3=carry[14]
XU3 ND2P $PINS O=n15 I1=carry[3] I2=A[3]
XU4 ND2P $PINS O=n14 I1=n13 I2=B[3]
XU5 ND2 $PINS O=n2 I1=A[14] I2=B[14]
XU7 AN2T $PINS O=n1 I1=B[0] I2=A[0]
XU8 ND2 $PINS O=n3 I1=carry[14] I2=A[14]
XU9 ND2 $PINS O=n4 I1=carry[14] I2=B[14]
XU11 XOR2HS $PINS O=n5 I1=A[15] I2=B[15]
XU12 XOR2HS $PINS O=SUM[15] I1=n5 I2=carry[15]
XU13 ND2 $PINS O=n6 I1=A[15] I2=B[15]
XU14 ND2 $PINS O=n7 I1=carry[15] I2=A[15]
XU15 ND2 $PINS O=n8 I1=carry[15] I2=B[15]
XU16 XOR3 $PINS O=SUM[10] I1=B[10] I2=A[10] I3=FE_OCPN1151_carry_10
XU17 ND2P $PINS O=n9 I1=carry[10] I2=B[10]
XU18 ND2P $PINS O=n10 I1=carry[10] I2=A[10]
XU19 ND2 $PINS O=n11 I1=B[10] I2=A[10]
XU20 XOR3 $PINS O=SUM[3] I1=B[3] I2=A[3] I3=n13
XU21 MAO222 $PINS O=n12 A1=B[1] B1=n1 C1=A[1]
XU22 MAO222 $PINS O=n13 A1=carry[2] B1=B[2] C1=A[2]
XU23 ND3HT $PINS O=carry[4] I1=n15 I2=n14 I3=n16
XU24 ND2 $PINS O=n16 I1=B[3] I2=A[3]
XU25 XOR2HS $PINS O=SUM[0] I1=B[0] I2=A[0]
.ENDS

.SUBCKT PE_Shift_Add_7_DW01_add_0_DW01_add_35 A[26] A[25] A[24] A[23] A[22]
+ A[21] A[20] A[19] A[18] A[17] A[16] A[15] A[14] A[13] A[12] A[11] A[10] A[9]
+ A[8] A[7] A[6] A[5] A[4] A[3] A[2] A[1] A[0] B[26] B[25] B[24] B[23] B[22]
+ B[21] B[20] B[19] B[18] B[17] B[16] B[15] B[14] B[13] B[12] B[11] B[10] B[9]
+ B[8] B[7] B[6] B[5] B[4] B[3] B[2] B[1] B[0] CI SUM[26] SUM[25] SUM[24]
+ SUM[23] SUM[22] SUM[21] SUM[20] SUM[19] SUM[18] SUM[17] SUM[16] SUM[15]
+ SUM[14] SUM[13] SUM[12] SUM[11] SUM[10] SUM[9] SUM[8] SUM[7] SUM[6] SUM[5]
+ SUM[4] SUM[3] SUM[2] SUM[1] SUM[0] CO
XFE_RC_268_0 ND3P $PINS O=carry[22] I1=FE_RN_83_0 I2=FE_RN_81_0 I3=FE_RN_82_0
XFE_RC_177_0 ND3HT $PINS O=carry[16] I1=n10 I2=n9 I3=n11
XFE_OCPC1210_N217 BUF1CK $PINS O=FE_OCPN1210_N217 I=B[12]
XFE_OCPC1175_N192 BUF1S $PINS O=FE_OCPN1175_N192 I=A[14]
XFE_OCPC1172_carry_8 BUF1S $PINS O=FE_OCPN1172_carry_8 I=carry[8]
XFE_OCPC1127_carry_9 BUF1S $PINS O=FE_OCPN1127_carry_9 I=carry[9]
XFE_OCPC1125_carry_12 BUF1S $PINS O=FE_OCPN1125_carry_12 I=carry[12]
XFE_OCPC1065_carry_18 BUF1S $PINS O=FE_OCPN1065_carry_18 I=carry[18]
XFE_OCPC1062_carry_22 BUF1S $PINS O=FE_OCPN1062_carry_22 I=carry[22]
XFE_OCPC1058_carry_10 BUF1S $PINS O=FE_OCPN1058_carry_10 I=carry[10]
XFE_OCPC1030_carry_16 BUF1S $PINS O=FE_OCPN1030_carry_16 I=carry[16]
XFE_OCPC1020_carry_23 BUF1S $PINS O=FE_OCPN1020_carry_23 I=carry[23]
XFE_OCPC1019_carry_13 BUF1S $PINS O=FE_OCPN1019_carry_13 I=carry[13]
XFE_OCPC1013_carry_11 BUF1S $PINS O=FE_OCPN1013_carry_11 I=carry[11]
XFE_RC_3900_0 ND3P $PINS O=carry[6] I1=n21 I2=n22 I3=n23
XFE_RC_3857_0 XOR2HS $PINS O=FE_RN_2531_0 I1=A[26] I2=B[26]
XFE_RC_3856_0 XOR2HS $PINS O=SUM[26] I1=FE_RN_2531_0 I2=carry[26]
XFE_RC_3530_0 ND2 $PINS O=FE_RN_2301_0 I1=carry[13] I2=B[13]
XFE_RC_3529_0 AOI22H $PINS O=FE_RN_2302_0 A1=A[13] A2=B[13] B1=carry[13]
+ B2=A[13]
XFE_RC_3528_0 ND2P $PINS O=carry[14] I1=FE_RN_2302_0 I2=FE_RN_2301_0
XFE_RC_3516_0 ND3P $PINS O=carry[23] I1=FE_RN_144_0 I2=FE_RN_142_0
+ I3=FE_RN_143_0
XFE_OCPC437_carry_14 BUF1S $PINS O=FE_OCPN437_carry_14 I=carry[14]
XFE_OCPC373_carry_15 BUF1S $PINS O=FE_OCPN373_carry_15 I=carry[15]
XFE_OCPC299_carry_19 BUF1S $PINS O=FE_OCPN299_carry_19 I=carry[19]
XFE_OCPC271_carry_20 BUF1S $PINS O=FE_OCPN271_carry_20 I=carry[20]
XFE_OCPC268_carry_21 BUF1S $PINS O=FE_OCPN268_carry_21 I=carry[21]
XFE_RC_635_0_dup ND2P $PINS O=FE_RN_2 I1=FE_RN_193_0 I2=FE_RN_192_0
XFE_RC_622_0_dup ND2P $PINS O=FE_RN_1 I1=FE_RN_186_0 I2=FE_RN_185_0
XFE_RC_3298_0 ND2 $PINS O=FE_RN_2136_0 I1=carry[4] I2=B[4]
XFE_RC_3297_0 AOI22S $PINS O=FE_RN_2137_0 A1=B[4] A2=A[4] B1=carry[4] B2=A[4]
XFE_RC_3296_0 ND2S $PINS O=n16 I1=FE_RN_2137_0 I2=FE_RN_2136_0
XFE_RC_3111_0 INV1S $PINS O=FE_RN_1993_0 I=A[1]
XFE_RC_3110_0 INV1S $PINS O=FE_RN_1994_0 I=B[1]
XFE_RC_3109_0 INV1S $PINS O=FE_RN_1995_0 I=n1
XFE_RC_3108_0 MXL2HS $PINS OB=FE_RN_1996_0 S=FE_RN_1995_0 A=B[1] B=FE_RN_1994_0
XFE_RC_3107_0 ND2 $PINS O=FE_RN_1997_0 I1=FE_RN_1996_0 I2=FE_RN_1993_0
XFE_RC_3104_0 OAI12HS $PINS O=FE_RN_2000_0 A1=FE_RN_2005_0 B1=FE_RN_1995_0
+ B2=FE_RN_1994_0
XFE_RC_3103_0 ND2 $PINS O=FE_RN_2001_0 I1=FE_RN_2000_0 I2=A[1]
XFE_RC_3102_0 ND2 $PINS O=SUM[1] I1=FE_RN_2001_0 I2=FE_RN_1997_0
XFE_RC_3101_0 ND2 $PINS O=FE_RN_2002_0 I1=n1 I2=B[1]
XFE_RC_3098_0 ND2S $PINS O=FE_RN_2005_0 I1=FE_RN_1995_0 I2=FE_RN_1994_0
XFE_RC_3097_0 ND2 $PINS O=FE_RN_2006_0 I1=FE_RN_2005_0 I2=A[1]
XFE_RC_3096_0 ND2P $PINS O=carry[2] I1=FE_RN_2006_0 I2=FE_RN_2002_0
XFE_RC_2752_0 OR2S $PINS O=FE_RN_1751_0 I1=FE_RN_1482_0 I2=FE_RN_1488_0
XFE_RC_2751_0 ND2P $PINS O=carry[7] I1=FE_RN_1751_0 I2=FE_RN_1492_0
XFE_RC_2405_0 INV1S $PINS O=FE_RN_1482_0 I=B[6]
XFE_RC_2404_0 ND2S $PINS O=FE_RN_1483_0 I1=A[6] I2=FE_RN_1482_0
XFE_RC_2402_0 XOR2HS $PINS O=FE_RN_1485_0 I1=carry[6] I2=A[6]
XFE_RC_2401_0 INV1S $PINS O=FE_RN_1486_0 I=carry[6]
XFE_RC_2400_0 OAI222S $PINS O=SUM[6] A1=FE_RN_1486_0 A2=FE_RN_1491_0
+ B1=FE_RN_1485_0 B2=FE_RN_1482_0 C1=carry[6] C2=FE_RN_1483_0
XFE_RC_2398_0 INV1S $PINS O=FE_RN_1488_0 I=A[6]
XFE_RC_2395_0 ND2S $PINS O=FE_RN_1491_0 I1=FE_RN_1488_0 I2=FE_RN_1482_0
XFE_RC_2394_0 ND2 $PINS O=FE_RN_1492_0 I1=carry[6] I2=FE_RN_1491_0
XFE_RC_1987_0 XNR2HS $PINS O=FE_RN_1175_0 I1=B[7] I2=A[7]
XFE_RC_1986_0 INV1S $PINS O=FE_RN_1176_0 I=B[7]
XFE_RC_1985_0 INV1S $PINS O=FE_RN_1177_0 I=A[7]
XFE_RC_1984_0 OAI12HS $PINS O=FE_RN_1178_0 A1=FE_RN_1181_0 B1=FE_RN_1177_0
+ B2=FE_RN_1176_0
XFE_RC_1983_0 ND2 $PINS O=FE_RN_1179_0 I1=FE_RN_1178_0 I2=carry[7]
XFE_RC_1982_0 OAI12HS $PINS O=SUM[7] A1=FE_RN_1179_0 B1=FE_RN_1175_0
+ B2=carry[7]
XFE_RC_1981_0 ND2 $PINS O=FE_RN_1180_0 I1=A[7] I2=B[7]
XFE_RC_1980_0 OR2 $PINS O=FE_RN_1181_0 I1=B[7] I2=A[7]
XFE_RC_1979_0 ND2 $PINS O=FE_RN_1182_0 I1=FE_RN_1181_0 I2=carry[7]
XFE_RC_1978_0 ND2P $PINS O=carry[8] I1=FE_RN_1182_0 I2=FE_RN_1180_0
XFE_RC_1833_0 INV2 $PINS O=FE_RN_1056_0 I=A[8]
XFE_RC_1831_0 NR2 $PINS O=FE_RN_1058_0 I1=B[8] I2=FE_RN_1056_0
XFE_RC_1830_0 AOI12HS $PINS O=FE_RN_1059_0 A1=FE_RN_1058_0 B1=FE_RN_1056_0
+ B2=B[8]
XFE_RC_1829_0 INV1S $PINS O=FE_RN_1060_0 I=B[8]
XFE_RC_1827_0 OAI12HS $PINS O=FE_RN_1062_0 A1=FE_RN_1067_0 B1=FE_RN_1056_0
+ B2=FE_RN_1060_0
XFE_RC_1826_0 ND2 $PINS O=FE_RN_1063_0 I1=FE_RN_1062_0 I2=FE_OCPN1172_carry_8
XFE_RC_1825_0 OAI12HS $PINS O=SUM[8] A1=FE_RN_1063_0 B1=FE_RN_1059_0
+ B2=FE_OCPN1172_carry_8
XFE_RC_1824_0 ND2 $PINS O=FE_RN_1064_0 I1=A[8] I2=B[8]
XFE_RC_1821_0 ND2S $PINS O=FE_RN_1067_0 I1=FE_RN_1056_0 I2=FE_RN_1060_0
XFE_RC_1820_0 ND2 $PINS O=FE_RN_1068_0 I1=FE_RN_1067_0 I2=carry[8]
XFE_RC_1819_0 ND2P $PINS O=carry[9] I1=FE_RN_1068_0 I2=FE_RN_1064_0
XFE_RC_1592_0 INV1S $PINS O=FE_RN_875_0 I=FE_OCPN1127_carry_9
XFE_RC_1591_0 INV1S $PINS O=FE_RN_876_0 I=B[9]
XFE_RC_1590_0 AOI22S $PINS O=FE_RN_877_0 A1=B[9] A2=FE_OCPN1127_carry_9
+ B1=FE_RN_876_0 B2=FE_RN_875_0
XFE_RC_1589_0 INV1S $PINS O=FE_RN_878_0 I=A[9]
XFE_RC_1587_0 OR2 $PINS O=FE_RN_880_0 I1=B[9] I2=A[9]
XFE_RC_1585_0 OAI222S $PINS O=SUM[9] A1=FE_RN_876_0 A2=FE_RN_883_0
+ B1=FE_RN_880_0 B2=FE_RN_875_0 C1=FE_RN_878_0 C2=FE_RN_877_0
XFE_RC_1584_0 ND2 $PINS O=FE_RN_882_0 I1=A[9] I2=carry[9]
XFE_RC_1583_0 OR2T $PINS O=FE_RN_883_0 I1=A[9] I2=carry[9]
XFE_RC_1582_0 ND2P $PINS O=FE_RN_884_0 I1=FE_RN_883_0 I2=B[9]
XFE_RC_1581_0 ND2P $PINS O=carry[10] I1=FE_RN_884_0 I2=FE_RN_882_0
XFE_RC_1512_0 ND2 $PINS O=FE_RN_821_0 I1=carry[11] I2=B[11]
XFE_RC_1511_0 AOI22H $PINS O=FE_RN_822_0 A1=A[11] A2=B[11] B1=carry[11]
+ B2=A[11]
XFE_RC_1510_0 ND2P $PINS O=carry[12] I1=FE_RN_822_0 I2=FE_RN_821_0
XFE_RC_1287_0 INV1S $PINS O=FE_RN_644_0 I=carry[10]
XFE_RC_1286_0 INV1S $PINS O=FE_RN_645_0 I=B[10]
XFE_RC_1285_0 OR2 $PINS O=FE_RN_646_0 I1=A[10] I2=FE_RN_645_0
XFE_RC_1282_0 MXL2HS $PINS OB=FE_RN_649_0 S=FE_RN_645_0 A=FE_OCPN1058_carry_10
+ B=FE_RN_644_0
XFE_RC_1281_0 INV1S $PINS O=FE_RN_650_0 I=A[10]
XFE_RC_1280_0 OAI222S $PINS O=SUM[10] A1=FE_RN_650_0 A2=FE_RN_649_0
+ B1=FE_RN_646_0 B2=FE_OCPN1058_carry_10 C1=FE_RN_644_0 C2=FE_RN_652_0
XFE_RC_1279_0 ND2 $PINS O=FE_RN_651_0 I1=B[10] I2=A[10]
XFE_RC_1278_0 OR2T $PINS O=FE_RN_652_0 I1=A[10] I2=B[10]
XFE_RC_1277_0 ND2P $PINS O=FE_RN_653_0 I1=FE_RN_652_0 I2=carry[10]
XFE_RC_1276_0 ND2P $PINS O=carry[11] I1=FE_RN_653_0 I2=FE_RN_651_0
XFE_RC_1113_0 XOR3 $PINS O=SUM[11] I1=A[11] I2=B[11] I3=FE_OCPN1013_carry_11
XFE_RC_974_0 INV1S $PINS O=FE_RN_405_0 I=A[12]
XFE_RC_972_0 NR2 $PINS O=FE_RN_407_0 I1=FE_OCPN1210_N217 I2=FE_RN_405_0
XFE_RC_971_0 AOI12HS $PINS O=FE_RN_408_0 A1=FE_RN_407_0 B1=FE_RN_405_0 B2=B[12]
XFE_RC_970_0 INV1S $PINS O=FE_RN_409_0 I=B[12]
XFE_RC_968_0 OAI12HS $PINS O=FE_RN_411_0 A1=FE_RN_414_0 B1=FE_RN_405_0
+ B2=FE_RN_409_0
XFE_RC_967_0 ND2 $PINS O=FE_RN_412_0 I1=FE_RN_411_0 I2=FE_OCPN1125_carry_12
XFE_RC_966_0 OAI12HS $PINS O=SUM[12] A1=FE_RN_412_0 B1=FE_RN_408_0
+ B2=FE_OCPN1125_carry_12
XFE_RC_965_0 ND2 $PINS O=FE_RN_413_0 I1=A[12] I2=FE_OCPN1210_N217
XFE_RC_964_0 OR2 $PINS O=FE_RN_414_0 I1=A[12] I2=B[12]
XFE_RC_963_0 ND2P $PINS O=FE_RN_415_0 I1=FE_RN_414_0 I2=carry[12]
XFE_RC_962_0 ND2P $PINS O=carry[13] I1=FE_RN_415_0 I2=FE_RN_413_0
XFE_RC_906_0 ND2 $PINS O=FE_RN_364_0 I1=FE_RN_1 I2=B[25]
XFE_RC_905_0 AOI22H $PINS O=FE_RN_365_0 A1=B[25] A2=A[25] B1=FE_RN_1 B2=A[25]
XFE_RC_904_0 ND2P $PINS O=carry[26] I1=FE_RN_365_0 I2=FE_RN_364_0
XFE_RC_722_0 XOR3 $PINS O=SUM[13] I1=A[13] I2=B[13] I3=FE_OCPN1019_carry_13
XFE_RC_718_0 XOR3 $PINS O=SUM[25] I1=A[25] I2=B[25] I3=FE_RN_1
XFE_RC_637_0 ND2P $PINS O=FE_RN_192_0 I1=carry[16] I2=B[16]
XFE_RC_636_0 AOI22HP $PINS O=FE_RN_193_0 A1=A[16] A2=B[16] B1=carry[16]
+ B2=A[16]
XFE_RC_635_0 ND2P $PINS O=carry[17] I1=FE_RN_193_0 I2=FE_RN_192_0
XFE_RC_624_0 ND2P $PINS O=FE_RN_185_0 I1=carry[24] I2=B[24]
XFE_RC_623_0 AOI22H $PINS O=FE_RN_186_0 A1=B[24] A2=A[24] B1=carry[24] B2=A[24]
XFE_RC_516_0 ND2P $PINS O=FE_RN_142_0 I1=carry[22] I2=A[22]
XFE_RC_515_0 ND2 $PINS O=FE_RN_143_0 I1=A[22] I2=B[22]
XFE_RC_514_0 ND2P $PINS O=FE_RN_144_0 I1=carry[22] I2=B[22]
XFE_RC_512_0 ND2P $PINS O=FE_RN_140_0 I1=carry[17] I2=B[17]
XFE_RC_511_0 AOI22H $PINS O=FE_RN_141_0 A1=A[17] A2=B[17] B1=FE_RN_2 B2=A[17]
XFE_RC_510_0 ND2P $PINS O=carry[18] I1=FE_RN_141_0 I2=FE_RN_140_0
XFE_RC_454_0 ND2 $PINS O=FE_RN_124_0 I1=carry[20] I2=B[20]
XFE_RC_453_0 AOI22H $PINS O=FE_RN_125_0 A1=A[20] A2=B[20] B1=carry[20] B2=A[20]
XFE_RC_452_0 ND2P $PINS O=carry[21] I1=FE_RN_125_0 I2=FE_RN_124_0
XFE_RC_434_0 ND2 $PINS O=FE_RN_119_0 I1=carry[23] I2=A[23]
XFE_RC_433_0 ND2 $PINS O=FE_RN_120_0 I1=A[23] I2=B[23]
XFE_RC_432_0 ND2 $PINS O=FE_RN_121_0 I1=carry[23] I2=B[23]
XFE_RC_431_0 ND3P $PINS O=carry[24] I1=FE_RN_121_0 I2=FE_RN_119_0
+ I3=FE_RN_120_0
XFE_RC_350_0 ND2P $PINS O=FE_RN_81_0 I1=carry[21] I2=A[21]
XFE_RC_349_0 ND2 $PINS O=FE_RN_82_0 I1=A[21] I2=B[21]
XFE_RC_348_0 ND2P $PINS O=FE_RN_83_0 I1=carry[21] I2=B[21]
XFE_RC_292_0 XOR3 $PINS O=SUM[20] I1=A[20] I2=B[20] I3=FE_OCPN271_carry_20
XFE_RC_233_0 XOR3 $PINS O=SUM[21] I1=A[21] I2=B[21] I3=FE_OCPN268_carry_21
XFE_RC_186_0 XOR3 $PINS O=SUM[22] I1=A[22] I2=B[22] I3=FE_OCPN1062_carry_22
XFE_RC_168_0 XOR3 $PINS O=SUM[23] I1=A[23] I2=B[23] I3=FE_OCPN1020_carry_23
XFE_RC_94_0 XOR3 $PINS O=SUM[24] I1=A[24] I2=B[24] I3=carry[24]
XFE_RC_92_0 XOR3 $PINS O=SUM[16] I1=A[16] I2=B[16] I3=FE_OCPN1030_carry_16
XFE_RC_38_0 ND3P $PINS O=carry[20] I1=n8 I2=n7 I3=n6
XFE_RC_35_0 XOR3 $PINS O=SUM[17] I1=A[17] I2=B[17] I3=carry[17]
XU1_3 FA1 $PINS S=SUM[3] CO=carry[4] A=A[3] B=B[3] CI=carry[3]
XU1_4 FA1S $PINS S=SUM[4] CO=carry[5] A=A[4] B=B[4] CI=n15
XU2 ND2 $PINS O=n22 I1=n16 I2=B[5]
XU3 XOR3 $PINS O=SUM[15] I1=B[15] I2=A[15] I3=FE_OCPN373_carry_15
XU4 ND3P $PINS O=carry[3] I1=n12 I2=n13 I3=n14
XU5 ND3P $PINS O=carry[15] I1=n18 I2=n19 I3=n20
XU6 ND2 $PINS O=n2 I1=A[18] I2=B[18]
XU7 XOR3 $PINS O=SUM[2] I1=A[2] I2=B[2] I3=carry[2]
XU8 XOR3 $PINS O=SUM[5] I1=A[5] I2=B[5] I3=carry[5]
XU10 XOR3 $PINS O=SUM[14] I1=FE_OCPN1175_N192 I2=B[14] I3=FE_OCPN437_carry_14
XU11 XOR3 $PINS O=SUM[18] I1=A[18] I2=B[18] I3=FE_OCPN1065_carry_18
XU12 AN2 $PINS O=n1 I1=B[0] I2=A[0]
XU13 ND2 $PINS O=n3 I1=carry[18] I2=A[18]
XU14 ND2 $PINS O=n4 I1=carry[18] I2=B[18]
XU15 ND3P $PINS O=carry[19] I1=n4 I2=n3 I3=n2
XU16 XOR2HS $PINS O=n5 I1=A[19] I2=B[19]
XU17 XOR2HS $PINS O=SUM[19] I1=n5 I2=FE_OCPN299_carry_19
XU18 ND2 $PINS O=n6 I1=A[19] I2=B[19]
XU19 ND2P $PINS O=n7 I1=carry[19] I2=A[19]
XU20 ND2 $PINS O=n8 I1=carry[19] I2=B[19]
XU21 ND2P $PINS O=n9 I1=carry[15] I2=B[15]
XU22 ND2P $PINS O=n10 I1=carry[15] I2=A[15]
XU23 ND2 $PINS O=n11 I1=B[15] I2=A[15]
XU25 ND2 $PINS O=n12 I1=carry[2] I2=A[2]
XU26 ND2 $PINS O=n13 I1=carry[2] I2=B[2]
XU27 ND2 $PINS O=n14 I1=A[2] I2=B[2]
XU28 MAO222 $PINS O=n15 A1=A[3] B1=B[3] C1=carry[3]
XU30 MAO222 $PINS O=n17 A1=A[4] B1=B[4] C1=n15
XU31 ND2 $PINS O=n18 I1=carry[14] I2=A[14]
XU32 ND2 $PINS O=n19 I1=carry[14] I2=B[14]
XU33 ND2 $PINS O=n20 I1=A[14] I2=B[14]
XU34 ND2 $PINS O=n21 I1=n17 I2=A[5]
XU35 ND2S $PINS O=n23 I1=A[5] I2=B[5]
XU36 XOR2HS $PINS O=SUM[0] I1=B[0] I2=A[0]
.ENDS

.SUBCKT PE_Shift_Add_7 rst_n en clear calc_done stage_sel x_in[16] x_in[15]
+ x_in[14] x_in[13] x_in[12] x_in[11] x_in[10] x_in[9] x_in[8] x_in[7] x_in[6]
+ x_in[5] x_in[4] x_in[3] x_in[2] x_in[1] x_in[0] sign1[1] sign1[0] sign2[1]
+ sign2[0] sign3[1] sign3[0] shf1[3] shf1[2] shf1[1] shf1[0] shf2[3] shf2[2]
+ shf2[1] shf2[0] shf3[3] shf3[2] shf3[1] shf3[0] y_out[16] y_out[15] y_out[14]
+ y_out[13] y_out[12] y_out[11] y_out[10] y_out[9] y_out[8] y_out[7] y_out[6]
+ y_out[5] y_out[4] y_out[3] y_out[2] y_out[1] y_out[0] i_rst_n
+ FE_OFN53_i_rst_n FE_OFN47_i_rst_n FE_OFN165_s03_0 FE_OFN163_s03_0
+ FE_OFN166_h03_1 clk_clone1 clk clk_clone2
XFE_PHC2187_pe_r0_7 BUF1CK $PINS O=y_out[7] I=FE_PHN2187_pe_r0_7
XFE_PHC2185_pe_r0_8 BUF1CK $PINS O=FE_PHN1759_pe_r0_8 I=FE_PHN2185_pe_r0_8
XFE_PHC2181_pe_r0_9 BUF1CK $PINS O=y_out[9] I=FE_PHN2181_pe_r0_9
XFE_PHC2082_N251 BUF3 $PINS O=FE_PHN2082_N251 I=N251
XFE_PHC1961_N235 DELC $PINS O=FE_PHN1961_N235 I=N235
XFE_PHC1955_N236 DELC $PINS O=FE_PHN1955_N236 I=N236
XFE_PHC1952_N239 DELC $PINS O=FE_PHN1952_N239 I=N239
XFE_PHC1946_N246 DELC $PINS O=FE_PHN1946_N246 I=N246
XFE_PHC1945_N237 DELC $PINS O=FE_PHN1945_N237 I=N237
XFE_PHC1936_N240 DELC $PINS O=N240 I=FE_PHN1936_N240
XFE_PHC1933_N243 DELB $PINS O=N243 I=FE_PHN1933_N243
XFE_PHC1921_N244 DELB $PINS O=N244 I=FE_PHN1921_N244
XFE_PHC1759_pe_r0_8 DELC $PINS O=y_out[8] I=FE_PHN1759_pe_r0_8
XFE_PHC1655_N251 DELC $PINS O=FE_PHN1655_N251 I=N251
XFE_PHC1575_next_acc_0 DELB $PINS O=FE_PHN1575_next_acc_0 I=next_acc[0]
XFE_PHC1568_N238 DELC $PINS O=FE_PHN1568_N238 I=N238
XFE_PHC1567_N242 DELB $PINS O=N242 I=FE_PHN1567_N242
XFE_PHC1507_acc_reg_14 DELB $PINS O=FE_PHN1507_acc_reg_14 I=acc_reg[14]
XFE_PHC1484_acc_reg_24 DELB $PINS O=FE_PHN1484_acc_reg_24 I=acc_reg[24]
XFE_PHC1450_acc_reg_15 DELB $PINS O=FE_PHN1450_acc_reg_15 I=acc_reg[15]
XFE_PHC1446_acc_reg_25 DELB $PINS O=FE_PHN1446_acc_reg_25 I=acc_reg[25]
XFE_PHC1424_acc_reg_20 DELB $PINS O=FE_PHN1424_acc_reg_20 I=acc_reg[20]
XFE_PHC1415_acc_reg_16 DELB $PINS O=FE_PHN1415_acc_reg_16 I=acc_reg[16]
XFE_PHC1395_acc_reg_22 DELC $PINS O=FE_PHN1395_acc_reg_22 I=acc_reg[22]
XFE_PHC1383_acc_reg_23 DELC $PINS O=FE_PHN1383_acc_reg_23 I=acc_reg[23]
XFE_RC_277_0 ND2 $PINS O=FE_RN_127_0 I1=term3_shifted[9] I2=FE_OFN416_s03_0
XFE_RC_276_0 ND2 $PINS O=FE_RN_128_0 I1=N133 I2=sign3[0]
XFE_RC_275_0 ND2P $PINS O=N160 I1=FE_RN_128_0 I2=FE_RN_127_0
XFE_RC_147_0 ND2 $PINS O=FE_RN_72_0 I1=term3_shifted[13] I2=n19
XFE_RC_146_0 ND2 $PINS O=FE_RN_73_0 I1=N137 I2=sign3[0]
XFE_RC_145_0 ND2P $PINS O=N164 I1=FE_RN_73_0 I2=FE_RN_72_0
XFE_RC_138_0 AO22 $PINS O=N49 A1=term1_shifted[8] A2=n44 B1=N22 B2=sign1[0]
XFE_RC_78_0 AO22 $PINS O=N113 A1=term2_shifted[17] A2=n32 B1=N86
+ B2=FE_OFN403_s02_0
XCTS_ccl_a_INV_CLK_G1_L10_40 INV3CK $PINS O=CTS_10 I=CTS_11
XCTS_ccl_a_INV_CLK_G1_L9_42 INV2CK $PINS O=CTS_11 I=CTS_12
XFE_OCPC1227_n59 BUF1S $PINS O=FE_OCPN1227_n59 I=n59
XFE_OCPC1219_sll_17_ML_int_1_1 BUF1S $PINS O=FE_OCPN1219_sll_17_ML_int_1_1
+ I=sll_17/ML_int[1][1]
XFE_OCPC1200_term3_shifted_1 BUF1S $PINS O=FE_OCPN1200_term3_shifted_1
+ I=term3_shifted[1]
XFE_OCPC1176_N194 BUF4CK $PINS O=FE_OCPN1176_N194 I=N194
XFE_OCPC1132_n6 BUF1S $PINS O=FE_OCPN1132_n6 I=n6
XFE_OFC890_FE_OFN57_h01_0 BUF2 $PINS O=FE_OFN494_FE_OFN57_h01_0 I=shf1[0]
XFE_OFC887_FE_OFN63_h02_0 BUF1 $PINS O=FE_OFN491_FE_OFN63_h02_0 I=shf2[0]
XFE_RC_3826_0 INV1S $PINS O=FE_RN_2508_0 I=FE_OFN305_h01_2
XFE_RC_3825_0 INV1S $PINS O=sll_16/ML_int[3][4] I=FE_RN_2509_0
XFE_RC_3824_0 AOI22S $PINS O=FE_RN_2509_0 A1=n53 A2=FE_OFN305_h01_2
+ B1=sll_16/ML_int[2][4] B2=FE_RN_2508_0
XFE_RC_3804_0 ND2 $PINS O=FE_RN_2491_0 I1=term3_shifted[8] I2=FE_OFN416_s03_0
XFE_RC_3803_0 ND2 $PINS O=FE_RN_2492_0 I1=N132 I2=sign3[0]
XFE_RC_3802_0 ND2P $PINS O=N159 I1=FE_RN_2492_0 I2=FE_RN_2491_0
XFE_RC_3795_0 ND2 $PINS O=FE_RN_2487_0 I1=term3_shifted[7] I2=FE_OFN416_s03_0
XFE_RC_3794_0 ND2 $PINS O=FE_RN_2488_0 I1=N131 I2=sign3[0]
XFE_RC_3793_0 ND2P $PINS O=N158 I1=FE_RN_2488_0 I2=FE_RN_2487_0
XFE_RC_3781_0 ND2 $PINS O=FE_RN_2480_0 I1=term3_shifted[18] I2=n19
XFE_RC_3780_0 ND2 $PINS O=FE_RN_2481_0 I1=N142 I2=FE_OFN418_s03_0
XFE_RC_3779_0 ND2P $PINS O=N169 I1=FE_RN_2481_0 I2=FE_RN_2480_0
XFE_RC_3767_0 ND2 $PINS O=FE_RN_2472_0 I1=term3_shifted[12] I2=FE_OFN416_s03_0
XFE_RC_3766_0 ND2 $PINS O=FE_RN_2473_0 I1=N136 I2=sign3[0]
XFE_RC_3765_0 ND2P $PINS O=N163 I1=FE_RN_2473_0 I2=FE_RN_2472_0
XFE_RC_3746_0 ND2 $PINS O=FE_RN_2460_0 I1=term3_shifted[19] I2=n19
XFE_RC_3745_0 ND2 $PINS O=FE_RN_2461_0 I1=N143 I2=FE_OFN418_s03_0
XFE_RC_3744_0 ND2P $PINS O=N170 I1=FE_RN_2461_0 I2=FE_RN_2460_0
XFE_RC_3715_0 ND2 $PINS O=FE_RN_2438_0 I1=term2_shifted[18] I2=n32
XFE_RC_3714_0 ND2 $PINS O=FE_RN_2439_0 I1=N87 I2=FE_OFN403_s02_0
XFE_RC_3713_0 ND2 $PINS O=N114 I1=FE_RN_2439_0 I2=FE_RN_2438_0
XFE_RC_3527_0 ND2 $PINS O=FE_RN_2299_0 I1=term2_shifted[19] I2=n32
XFE_RC_3526_0 ND2 $PINS O=FE_RN_2300_0 I1=N88 I2=FE_OFN403_s02_0
XFE_RC_3525_0 ND2P $PINS O=N115 I1=FE_RN_2300_0 I2=FE_RN_2299_0
XFE_RC_3378_0 INV1S $PINS O=FE_RN_2194_0 I=n12
XFE_RC_3377_0 INV2 $PINS O=sll_18/ML_int[2][2] I=FE_RN_2195_0
XFE_RC_3376_0 AOI22S $PINS O=FE_RN_2195_0 A1=sll_18/ML_int[1][0] A2=n12
+ B1=sll_18/ML_int[1][2] B2=FE_RN_2194_0
XFE_RC_3328_0 ND2 $PINS O=FE_RN_2159_0 I1=FE_OCPN1200_term3_shifted_1
+ I2=FE_OFN416_s03_0
XFE_RC_3327_0 ND2 $PINS O=FE_RN_2160_0 I1=N125 I2=sign3[0]
XFE_RC_3326_0 ND2 $PINS O=N152 I1=FE_RN_2160_0 I2=FE_RN_2159_0
XFE_RC_3292_0 ND2 $PINS O=FE_RN_2131_0 I1=term1_in[0]
+ I2=FE_OFN494_FE_OFN57_h01_0
XFE_RC_3291_0 INV1S $PINS O=FE_RN_2132_0 I=shf1[0]
XFE_RC_3290_0 ND2 $PINS O=FE_RN_2133_0 I1=term1_in[1] I2=FE_RN_2132_0
XFE_RC_3289_0 ND2P $PINS O=sll_16/ML_int[1][1] I1=FE_RN_2131_0 I2=FE_RN_2133_0
XFE_RC_3164_0 ND2 $PINS O=FE_RN_2040_0 I1=term1_shifted[13] I2=FE_OFN274_s01_0
XFE_RC_3163_0 ND2 $PINS O=FE_RN_2041_0 I1=N27 I2=FE_OFN273_s01_0
XFE_RC_3162_0 ND2 $PINS O=N54 I1=FE_RN_2041_0 I2=FE_RN_2040_0
XFE_RC_2888_0 ND2 $PINS O=FE_RN_1844_0 I1=term2_shifted[6] I2=FE_OFN59_s02_0
XFE_RC_2887_0 ND2 $PINS O=FE_RN_1845_0 I1=N75 I2=FE_OFN401_s02_0
XFE_RC_2886_0 ND2 $PINS O=N102 I1=FE_RN_1845_0 I2=FE_RN_1844_0
XFE_RC_2885_0 ND2P $PINS O=FE_RN_1841_0 I1=term3_in[0] I2=shf3[0]
XFE_RC_2884_0 INV1S $PINS O=FE_RN_1842_0 I=shf3[0]
XFE_RC_2883_0 ND2S $PINS O=FE_RN_1843_0 I1=term3_in[1] I2=FE_RN_1842_0
XFE_RC_2882_0 ND2 $PINS O=sll_18/ML_int[1][1] I1=FE_RN_1843_0 I2=FE_RN_1841_0
XFE_RC_2836_0 ND2 $PINS O=FE_RN_1808_0 I1=term2_shifted[5] I2=FE_OFN59_s02_0
XFE_RC_2835_0 ND2 $PINS O=FE_RN_1809_0 I1=N74 I2=sign2[0]
XFE_RC_2834_0 ND2 $PINS O=N101 I1=FE_RN_1809_0 I2=FE_RN_1808_0
XFE_RC_2787_0 ND2 $PINS O=FE_RN_1773_0 I1=term2_shifted[2] I2=FE_OFN59_s02_0
XFE_RC_2786_0 ND2 $PINS O=FE_RN_1774_0 I1=N71 I2=sign2[0]
XFE_RC_2785_0 ND2P $PINS O=N98 I1=FE_RN_1774_0 I2=FE_RN_1773_0
XFE_RC_2761_0 ND2 $PINS O=FE_RN_1755_0 I1=term2_shifted[8] I2=FE_OFN59_s02_0
XFE_RC_2760_0 ND2 $PINS O=FE_RN_1756_0 I1=N77 I2=FE_OFN401_s02_0
XFE_RC_2759_0 ND2 $PINS O=N104 I1=FE_RN_1756_0 I2=FE_RN_1755_0
XFE_RC_2577_0 ND2 $PINS O=FE_RN_1619_0 I1=term2_shifted[3] I2=FE_OFN59_s02_0
XFE_RC_2576_0 ND2S $PINS O=FE_RN_1620_0 I1=N72 I2=sign2[0]
XFE_RC_2575_0 ND2P $PINS O=N99 I1=FE_RN_1620_0 I2=FE_RN_1619_0
XFE_RC_2484_0 ND2 $PINS O=FE_RN_1550_0 I1=term2_shifted[4] I2=FE_OFN59_s02_0
XFE_RC_2483_0 ND2 $PINS O=FE_RN_1551_0 I1=N73 I2=sign2[0]
XFE_RC_2482_0 ND2P $PINS O=N100 I1=FE_RN_1551_0 I2=FE_RN_1550_0
XFE_RC_1275_0 INV1S $PINS O=FE_RN_641_0 I=shf2[0]
XFE_RC_1274_0 ND2S $PINS O=FE_RN_642_0 I1=term2_in[1] I2=FE_RN_641_0
XFE_RC_1273_0 ND2S $PINS O=FE_RN_643_0 I1=term2_in[0] I2=shf2[0]
XFE_RC_1272_0 ND2P $PINS O=sll_17/ML_int[1][1] I1=FE_RN_643_0 I2=FE_RN_642_0
XFE_RC_1218_0 ND2S $PINS O=FE_RN_595_0 I1=term2_shifted[1] I2=FE_OFN59_s02_0
XFE_RC_1217_0 ND2P $PINS O=FE_RN_596_0 I1=N70 I2=sign2[0]
XFE_RC_1216_0 ND2P $PINS O=N97 I1=FE_RN_596_0 I2=FE_RN_595_0
XFE_RC_13_0 OA12 $PINS O=N41 A1=N14 B1=sign1[0] B2=n44
XFE_RC_7_0 OA12 $PINS O=N96 A1=N69 B1=sign2[0] B2=FE_OFN59_s02_0
XFE_RC_0_0 OA12 $PINS O=N151 A1=term3_shifted[0] B1=sign3[0] B2=FE_OFN416_s03_0
XFE_OFC854_h01_1 BUF1 $PINS O=n36 I=shf1[1]
XFE_OFC844_n15 BUF1 $PINS O=FE_OFN454_n15 I=n15
XFE_OFC800_s01_0 INV1S $PINS O=n44 I=sign1[0]
XFE_OFC759_sll_18_ML_int_2__3 INV1S $PINS O=n72 I=sll_18/ML_int[2][3]
XFE_OFC728_h03_1 BUF1 $PINS O=n12 I=shf3[1]
XFE_OFC725_s03_0 INV1S $PINS O=FE_OFN418_s03_0 I=n19
XFE_OFC723_s03_0 INV1S $PINS O=FE_OFN416_s03_0 I=sign3[0]
XFE_OFC721_s03_0 INV1S $PINS O=n19 I=sign3[0]
XFE_OFC695_s02_0 INV1S $PINS O=FE_OFN403_s02_0 I=n32
XFE_OFC693_s02_0 BUF1 $PINS O=FE_OFN401_s02_0 I=sign2[0]
XFE_OFC692_s02_0 INV3 $PINS O=FE_OFN59_s02_0 I=sign2[0]
XFE_OFC690_s02_0 INV1S $PINS O=n32 I=sign2[0]
XFE_OFC663_s01_0 BUF1 $PINS O=FE_OFN273_s01_0 I=sign1[0]
XFE_OFC633_h03_3 INV1S $PINS O=n17 I=shf3[3]
XFE_OFC556_h01_1 INV1S $PINS O=FE_OFN341_h01_1 I=shf1[1]
XFE_OFC541_h01_0 INV1S $PINS O=n35 I=FE_OFN494_FE_OFN57_h01_0
XFE_OFC518_h02_1 INV2 $PINS O=n24 I=shf2[1]
XFE_OFC483_h01_3 INV1S $PINS O=FE_OFN315_h01_3 I=shf1[3]
XFE_OFC482_h01_3 INV1S $PINS O=n41 I=shf1[3]
XFE_OFC453_h01_2 BUF2 $PINS O=FE_OFN305_h01_2 I=shf1[2]
XFE_OFC381_pe_clear_d1 INV2 $PINS O=n101 I=clear
XFE_OFC353_s01_0 INV1S $PINS O=FE_OFN274_s01_0 I=FE_OFN273_s01_0
XFE_OFC280_h02_3 INV1S $PINS O=n28 I=shf2[3]
XFE_OFC272_h03_2 INV1S $PINS O=n15 I=shf3[2]
XU110 AO22 $PINS O=base_val[13] A1=acc_reg[13] A2=n101 B1=clear B2=stage_sel
XU115 AO22 $PINS O=N67 A1=FE_OFN273_s01_0 A2=N40 B1=term1_shifted[26]
+ B2=FE_OFN274_s01_0
XU116 AO22 $PINS O=N66 A1=N39 A2=FE_OFN273_s01_0 B1=term1_shifted[25]
+ B2=FE_OFN274_s01_0
XU117 AO22 $PINS O=N65 A1=N38 A2=FE_OFN273_s01_0 B1=term1_shifted[24]
+ B2=FE_OFN274_s01_0
XU118 AO22 $PINS O=N64 A1=N37 A2=FE_OFN273_s01_0 B1=term1_shifted[23]
+ B2=FE_OFN274_s01_0
XU119 AO22 $PINS O=N63 A1=N36 A2=FE_OFN273_s01_0 B1=term1_shifted[22]
+ B2=FE_OFN274_s01_0
XU120 AO22 $PINS O=N62 A1=N35 A2=FE_OFN273_s01_0 B1=term1_shifted[21]
+ B2=FE_OFN274_s01_0
XU121 AO22 $PINS O=N61 A1=N34 A2=FE_OFN273_s01_0 B1=term1_shifted[20]
+ B2=FE_OFN274_s01_0
XU122 AO22P $PINS O=N60 A1=N33 A2=FE_OFN273_s01_0 B1=term1_shifted[19]
+ B2=FE_OFN274_s01_0
XU132 AO22 $PINS O=N50 A1=N23 A2=FE_OFN273_s01_0 B1=term1_shifted[9] B2=n44
XU134 AO22 $PINS O=N48 A1=N21 A2=sign1[0] B1=term1_shifted[7] B2=n44
XU135 AO22 $PINS O=N47 A1=N20 A2=sign1[0] B1=term1_shifted[6] B2=n44
XU136 AO22 $PINS O=N46 A1=N19 A2=sign1[0] B1=term1_shifted[5] B2=n44
XU142 AO22 $PINS O=N177 A1=FE_OFN165_s03_0 A2=N150 B1=term3_shifted[26]
+ B2=FE_OFN163_s03_0
XU143 AO22 $PINS O=N176 A1=N149 A2=FE_OFN165_s03_0 B1=term3_shifted[25]
+ B2=FE_OFN163_s03_0
XU144 AO22 $PINS O=N175 A1=N148 A2=FE_OFN165_s03_0 B1=term3_shifted[24]
+ B2=FE_OFN163_s03_0
XU145 AO22 $PINS O=N174 A1=N147 A2=FE_OFN165_s03_0 B1=term3_shifted[23]
+ B2=FE_OFN163_s03_0
XU146 AO22 $PINS O=N173 A1=N146 A2=FE_OFN165_s03_0 B1=term3_shifted[22]
+ B2=FE_OFN163_s03_0
XU147 AO22 $PINS O=N172 A1=N145 A2=FE_OFN418_s03_0 B1=term3_shifted[21] B2=n19
XU148 AO22 $PINS O=N171 A1=N144 A2=FE_OFN418_s03_0 B1=term3_shifted[20] B2=n19
XU151 AO22 $PINS O=N168 A1=N141 A2=FE_OFN418_s03_0 B1=term3_shifted[17] B2=n19
XU152 AO22 $PINS O=N167 A1=N140 A2=FE_OFN418_s03_0 B1=term3_shifted[16] B2=n19
XU153 AO22 $PINS O=N166 A1=N139 A2=FE_OFN418_s03_0 B1=term3_shifted[15] B2=n19
XU154 AO22 $PINS O=N165 A1=N138 A2=FE_OFN418_s03_0 B1=term3_shifted[14] B2=n19
XU157 AO22 $PINS O=N162 A1=N135 A2=sign3[0] B1=term3_shifted[11]
+ B2=FE_OFN416_s03_0
XU158 AO22 $PINS O=N161 A1=N134 A2=sign3[0] B1=term3_shifted[10]
+ B2=FE_OFN416_s03_0
XU162 AO22P $PINS O=N157 A1=N130 A2=sign3[0] B1=term3_shifted[6]
+ B2=FE_OFN416_s03_0
XU163 AO22 $PINS O=N156 A1=N129 A2=sign3[0] B1=term3_shifted[5]
+ B2=FE_OFN416_s03_0
XU169 AO22 $PINS O=N122 A1=N95 A2=FE_OFN403_s02_0 B1=term2_shifted[26] B2=n32
XU170 AO22 $PINS O=N121 A1=N94 A2=FE_OFN403_s02_0 B1=term2_shifted[25] B2=n32
XU171 AO22 $PINS O=N120 A1=N93 A2=FE_OFN403_s02_0 B1=term2_shifted[24] B2=n32
XU172 AO22 $PINS O=N119 A1=N92 A2=FE_OFN403_s02_0 B1=term2_shifted[23] B2=n32
XU173 AO22 $PINS O=N118 A1=N91 A2=FE_OFN403_s02_0 B1=term2_shifted[22] B2=n32
XU174 AO22 $PINS O=N117 A1=N90 A2=FE_OFN403_s02_0 B1=term2_shifted[21] B2=n32
XU175 AO22P $PINS O=N116 A1=N89 A2=FE_OFN403_s02_0 B1=term2_shifted[20] B2=n32
XU179 AO22 $PINS O=N112 A1=N85 A2=FE_OFN403_s02_0 B1=term2_shifted[16] B2=n32
XU180 AO22 $PINS O=N111 A1=N84 A2=FE_OFN401_s02_0 B1=term2_shifted[15] B2=n32
XU181 AO22 $PINS O=N110 A1=N83 A2=FE_OFN401_s02_0 B1=term2_shifted[14] B2=n32
XU183 AO22 $PINS O=N108 A1=N81 A2=FE_OFN401_s02_0 B1=term2_shifted[12] B2=n32
XU184 AO22 $PINS O=N107 A1=N80 A2=FE_OFN401_s02_0 B1=term2_shifted[11] B2=n32
XU185 AO22 $PINS O=N106 A1=N79 A2=FE_OFN401_s02_0 B1=term2_shifted[10]
+ B2=FE_OFN59_s02_0
XU186 AO22 $PINS O=N105 A1=N78 A2=FE_OFN401_s02_0 B1=term2_shifted[9]
+ B2=FE_OFN59_s02_0
XU188 AO22 $PINS O=N103 A1=N76 A2=FE_OFN401_s02_0 B1=term2_shifted[7]
+ B2=FE_OFN59_s02_0
Xsll_18/M1_0_2 MUX2 $PINS O=sll_18/ML_int[1][2] S=shf3[0] A=term3_in[2]
+ B=term3_in[1]
Xsll_18/M1_0_4 MUX2 $PINS O=sll_18/ML_int[1][4] S=shf3[0] A=term3_in[4]
+ B=term3_in[3]
Xsll_18/M1_0_6 MUX2 $PINS O=sll_18/ML_int[1][6] S=shf3[0] A=term3_in[6]
+ B=term3_in[5]
Xsll_18/M1_0_7 MUX2 $PINS O=sll_18/ML_int[1][7] S=shf3[0] A=term3_in[7]
+ B=term3_in[6]
Xsll_18/M1_0_8 MUX2 $PINS O=sll_18/ML_int[1][8] S=shf3[0] A=term3_in[8]
+ B=term3_in[7]
Xsll_18/M1_0_9 MUX2 $PINS O=sll_18/ML_int[1][9] S=shf3[0] A=term3_in[9]
+ B=term3_in[8]
Xsll_18/M1_0_10 MUX2 $PINS O=sll_18/ML_int[1][10] S=shf3[0] A=term3_in[10]
+ B=term3_in[9]
Xsll_18/M1_1_3 MUX2 $PINS O=sll_18/ML_int[2][3] S=n12 A=sll_18/ML_int[1][3]
+ B=sll_18/ML_int[1][1]
Xsll_18/M1_1_4 MUX2 $PINS O=sll_18/ML_int[2][4] S=n12 A=sll_18/ML_int[1][4]
+ B=sll_18/ML_int[1][2]
Xsll_18/M1_1_5 MUX2 $PINS O=sll_18/ML_int[2][5] S=n12 A=sll_18/ML_int[1][5]
+ B=sll_18/ML_int[1][3]
Xsll_18/M1_1_6 MUX2 $PINS O=sll_18/ML_int[2][6] S=n12 A=sll_18/ML_int[1][6]
+ B=sll_18/ML_int[1][4]
Xsll_18/M1_1_7 MUX2 $PINS O=sll_18/ML_int[2][7] S=n12 A=sll_18/ML_int[1][7]
+ B=sll_18/ML_int[1][5]
Xsll_18/M1_1_8 MUX2 $PINS O=sll_18/ML_int[2][8] S=n12 A=sll_18/ML_int[1][8]
+ B=sll_18/ML_int[1][6]
Xsll_18/M1_1_9 MUX2 $PINS O=sll_18/ML_int[2][9] S=n12 A=sll_18/ML_int[1][9]
+ B=sll_18/ML_int[1][7]
Xsll_18/M1_1_10 MUX2 $PINS O=sll_18/ML_int[2][10] S=n12 A=sll_18/ML_int[1][10]
+ B=sll_18/ML_int[1][8]
Xsll_18/M1_1_11 MUX2 $PINS O=sll_18/ML_int[2][11] S=n12 A=sll_18/ML_int[1][11]
+ B=sll_18/ML_int[1][9]
Xsll_18/M1_2_4 MUX2 $PINS O=sll_18/ML_int[3][4] S=n15 A=sll_18/ML_int[2][4]
+ B=n74
Xsll_18/M1_2_5 MUX2 $PINS O=sll_18/ML_int[3][5] S=n15 A=sll_18/ML_int[2][5]
+ B=n75
Xsll_18/M1_2_7 MUX2 $PINS O=sll_18/ML_int[3][7] S=n15 A=sll_18/ML_int[2][7]
+ B=sll_18/ML_int[2][3]
Xsll_18/M1_2_8 MUX2 $PINS O=sll_18/ML_int[3][8] S=n15 A=sll_18/ML_int[2][8]
+ B=sll_18/ML_int[2][4]
Xsll_18/M1_2_9 MUX2 $PINS O=sll_18/ML_int[3][9] S=FE_OFN454_n15
+ A=sll_18/ML_int[2][9] B=sll_18/ML_int[2][5]
Xsll_18/M1_2_10 MUX2 $PINS O=sll_18/ML_int[3][10] S=n15 A=sll_18/ML_int[2][10]
+ B=sll_18/ML_int[2][6]
Xsll_18/M1_2_11 MUX2 $PINS O=sll_18/ML_int[3][11] S=FE_OFN454_n15
+ A=sll_18/ML_int[2][11] B=sll_18/ML_int[2][7]
Xsll_18/M1_2_12 MUX2 $PINS O=sll_18/ML_int[3][12] S=FE_OFN454_n15
+ A=sll_18/ML_int[2][12] B=sll_18/ML_int[2][8]
Xsll_18/M1_2_13 MUX2 $PINS O=sll_18/ML_int[3][13] S=FE_OFN454_n15
+ A=sll_18/ML_int[2][13] B=sll_18/ML_int[2][9]
Xsll_18/M1_3_8 MUX2 $PINS O=term3_shifted[8] S=n17 A=sll_18/ML_int[3][8]
+ B=sll_18/ML_int[3][0]
Xsll_18/M1_3_9 MUX2 $PINS O=term3_shifted[9] S=n17 A=sll_18/ML_int[3][9]
+ B=sll_18/ML_int[3][1]
Xsll_18/M1_3_10 MUX2 $PINS O=term3_shifted[10] S=n17 A=sll_18/ML_int[3][10]
+ B=sll_18/ML_int[3][2]
Xsll_18/M1_3_11 MUX2 $PINS O=term3_shifted[11] S=n17 A=sll_18/ML_int[3][11]
+ B=sll_18/ML_int[3][3]
Xsll_18/M1_3_12 MUX2 $PINS O=term3_shifted[12] S=n17 A=sll_18/ML_int[3][12]
+ B=sll_18/ML_int[3][4]
Xsll_18/M1_3_13 MUX2 $PINS O=term3_shifted[13] S=n17 A=sll_18/ML_int[3][13]
+ B=sll_18/ML_int[3][5]
Xsll_18/M1_3_14 MUX2 $PINS O=term3_shifted[14] S=n17 A=sll_18/ML_int[3][14]
+ B=sll_18/ML_int[3][6]
Xsll_18/M1_3_15 MUX2 $PINS O=term3_shifted[15] S=n17 A=sll_18/ML_int[3][15]
+ B=sll_18/ML_int[3][7]
Xsll_18/M1_3_16 MUX2 $PINS O=term3_shifted[16] S=n17 A=sll_18/ML_int[3][16]
+ B=sll_18/ML_int[3][8]
Xsll_18/M1_3_17 MUX2 $PINS O=term3_shifted[17] S=n17 A=sll_18/ML_int[3][17]
+ B=sll_18/ML_int[3][9]
Xsll_18/M1_3_22 MUX2 $PINS O=term3_shifted[22] S=n17 A=sll_18/ML_int[3][22]
+ B=sll_18/ML_int[3][14]
Xsll_18/M1_3_23 MUX2 $PINS O=term3_shifted[23] S=n17 A=term3_in[26]
+ B=sll_18/ML_int[3][15]
Xsll_17/M1_0_4 MUX2 $PINS O=sll_17/ML_int[1][4] S=shf2[0] A=term2_in[4]
+ B=term2_in[3]
Xsll_17/M1_0_6 MUX2 $PINS O=sll_17/ML_int[1][6] S=shf2[0] A=term2_in[6]
+ B=term2_in[5]
Xsll_17/M1_0_7 MUX2 $PINS O=sll_17/ML_int[1][7] S=shf2[0] A=term2_in[7]
+ B=term2_in[6]
Xsll_17/M1_0_8 MUX2 $PINS O=sll_17/ML_int[1][8] S=shf2[0] A=term2_in[8]
+ B=term2_in[7]
Xsll_17/M1_0_9 MUX2 $PINS O=sll_17/ML_int[1][9] S=shf2[0] A=term2_in[9]
+ B=term2_in[8]
Xsll_17/M1_0_10 MUX2 $PINS O=sll_17/ML_int[1][10] S=shf2[0] A=term2_in[10]
+ B=term2_in[9]
Xsll_17/M1_1_3 MUX2 $PINS O=sll_17/ML_int[2][3] S=shf2[1] A=sll_17/ML_int[1][3]
+ B=sll_17/ML_int[1][1]
Xsll_17/M1_1_5 MUX2 $PINS O=sll_17/ML_int[2][5] S=shf2[1] A=sll_17/ML_int[1][5]
+ B=sll_17/ML_int[1][3]
Xsll_17/M1_1_6 MUX2 $PINS O=sll_17/ML_int[2][6] S=shf2[1] A=sll_17/ML_int[1][6]
+ B=sll_17/ML_int[1][4]
Xsll_17/M1_1_7 MUX2 $PINS O=sll_17/ML_int[2][7] S=shf2[1] A=sll_17/ML_int[1][7]
+ B=sll_17/ML_int[1][5]
Xsll_17/M1_1_8 MUX2 $PINS O=sll_17/ML_int[2][8] S=shf2[1] A=sll_17/ML_int[1][8]
+ B=sll_17/ML_int[1][6]
Xsll_17/M1_1_9 MUX2 $PINS O=sll_17/ML_int[2][9] S=shf2[1] A=sll_17/ML_int[1][9]
+ B=sll_17/ML_int[1][7]
Xsll_17/M1_1_10 MUX2 $PINS O=sll_17/ML_int[2][10] S=shf2[1]
+ A=sll_17/ML_int[1][10] B=sll_17/ML_int[1][8]
Xsll_17/M1_1_11 MUX2 $PINS O=sll_17/ML_int[2][11] S=shf2[1]
+ A=sll_17/ML_int[1][11] B=sll_17/ML_int[1][9]
Xsll_17/M1_2_4 MUX2 $PINS O=sll_17/ML_int[3][4] S=shf2[2] A=sll_17/ML_int[2][4]
+ B=n64
Xsll_17/M1_2_5 MUX2 $PINS O=sll_17/ML_int[3][5] S=shf2[2] A=sll_17/ML_int[2][5]
+ B=n7
Xsll_17/M1_2_7 MUX2 $PINS O=sll_17/ML_int[3][7] S=shf2[2] A=sll_17/ML_int[2][7]
+ B=sll_17/ML_int[2][3]
Xsll_17/M1_2_8 MUX2 $PINS O=sll_17/ML_int[3][8] S=shf2[2] A=sll_17/ML_int[2][8]
+ B=sll_17/ML_int[2][4]
Xsll_17/M1_2_9 MUX2 $PINS O=sll_17/ML_int[3][9] S=shf2[2] A=sll_17/ML_int[2][9]
+ B=sll_17/ML_int[2][5]
Xsll_17/M1_2_10 MUX2 $PINS O=sll_17/ML_int[3][10] S=shf2[2]
+ A=sll_17/ML_int[2][10] B=sll_17/ML_int[2][6]
Xsll_17/M1_2_12 MUX2 $PINS O=sll_17/ML_int[3][12] S=shf2[2]
+ A=sll_17/ML_int[2][12] B=sll_17/ML_int[2][8]
Xsll_17/M1_2_13 MUX2 $PINS O=sll_17/ML_int[3][13] S=shf2[2]
+ A=sll_17/ML_int[2][13] B=sll_17/ML_int[2][9]
Xsll_17/M1_3_8 MUX2 $PINS O=term2_shifted[8] S=n28 A=sll_17/ML_int[3][8]
+ B=sll_17/ML_int[3][0]
Xsll_17/M1_3_9 MUX2 $PINS O=term2_shifted[9] S=n28 A=sll_17/ML_int[3][9]
+ B=sll_17/ML_int[3][1]
Xsll_17/M1_3_10 MUX2 $PINS O=term2_shifted[10] S=n28 A=sll_17/ML_int[3][10]
+ B=sll_17/ML_int[3][2]
Xsll_17/M1_3_11 MUX2 $PINS O=term2_shifted[11] S=n28 A=sll_17/ML_int[3][11]
+ B=sll_17/ML_int[3][3]
Xsll_17/M1_3_12 MUX2 $PINS O=term2_shifted[12] S=n28 A=sll_17/ML_int[3][12]
+ B=sll_17/ML_int[3][4]
Xsll_17/M1_3_13 MUX2 $PINS O=term2_shifted[13] S=n28 A=sll_17/ML_int[3][13]
+ B=sll_17/ML_int[3][5]
Xsll_17/M1_3_14 MUX2 $PINS O=term2_shifted[14] S=n28 A=sll_17/ML_int[3][14]
+ B=sll_17/ML_int[3][6]
Xsll_17/M1_3_16 MUX2 $PINS O=term2_shifted[16] S=n28 A=sll_17/ML_int[3][16]
+ B=sll_17/ML_int[3][8]
Xsll_17/M1_3_17 MUX2 $PINS O=term2_shifted[17] S=n28 A=sll_17/ML_int[3][17]
+ B=sll_17/ML_int[3][9]
Xsll_17/M1_3_22 MUX2 $PINS O=term2_shifted[22] S=n28 A=sll_17/ML_int[3][22]
+ B=sll_17/ML_int[3][14]
Xsll_17/M1_3_23 MUX2 $PINS O=term2_shifted[23] S=n28 A=term2_in[26]
+ B=sll_17/ML_int[3][15]
Xsll_16/M1_0_5 MUX2 $PINS O=sll_16/ML_int[1][5] S=FE_OFN494_FE_OFN57_h01_0
+ A=term1_in[5] B=term1_in[4]
Xsll_16/M1_0_6 MUX2 $PINS O=sll_16/ML_int[1][6] S=FE_OFN494_FE_OFN57_h01_0
+ A=term1_in[6] B=term1_in[5]
Xsll_16/M1_0_7 MUX2 $PINS O=sll_16/ML_int[1][7] S=FE_OFN494_FE_OFN57_h01_0
+ A=term1_in[7] B=term1_in[6]
Xsll_16/M1_0_8 MUX2 $PINS O=sll_16/ML_int[1][8] S=FE_OFN494_FE_OFN57_h01_0
+ A=term1_in[8] B=term1_in[7]
Xsll_16/M1_0_9 MUX2 $PINS O=sll_16/ML_int[1][9] S=FE_OFN494_FE_OFN57_h01_0
+ A=term1_in[9] B=term1_in[8]
Xsll_16/M1_0_10 MUX2 $PINS O=sll_16/ML_int[1][10] S=FE_OFN494_FE_OFN57_h01_0
+ A=term1_in[10] B=term1_in[9]
Xsll_16/M1_1_3 MUX2 $PINS O=sll_16/ML_int[2][3] S=shf1[1] A=sll_16/ML_int[1][3]
+ B=sll_16/ML_int[1][1]
Xsll_16/M1_1_4 MUX2 $PINS O=sll_16/ML_int[2][4] S=shf1[1] A=sll_16/ML_int[1][4]
+ B=sll_16/ML_int[1][2]
Xsll_16/M1_1_5 MUX2 $PINS O=sll_16/ML_int[2][5] S=shf1[1] A=sll_16/ML_int[1][5]
+ B=sll_16/ML_int[1][3]
Xsll_16/M1_1_6 MUX2 $PINS O=sll_16/ML_int[2][6] S=shf1[1] A=sll_16/ML_int[1][6]
+ B=sll_16/ML_int[1][4]
Xsll_16/M1_1_7 MUX2 $PINS O=sll_16/ML_int[2][7] S=shf1[1] A=sll_16/ML_int[1][7]
+ B=sll_16/ML_int[1][5]
Xsll_16/M1_1_8 MUX2 $PINS O=sll_16/ML_int[2][8] S=n36 A=sll_16/ML_int[1][8]
+ B=sll_16/ML_int[1][6]
Xsll_16/M1_1_9 MUX2 $PINS O=sll_16/ML_int[2][9] S=n36 A=sll_16/ML_int[1][9]
+ B=sll_16/ML_int[1][7]
Xsll_16/M1_1_10 MUX2 $PINS O=sll_16/ML_int[2][10] S=n36 A=sll_16/ML_int[1][10]
+ B=sll_16/ML_int[1][8]
Xsll_16/M1_1_11 MUX2 $PINS O=sll_16/ML_int[2][11] S=n36 A=sll_16/ML_int[1][11]
+ B=sll_16/ML_int[1][9]
Xsll_16/M1_2_5 MUX2 $PINS O=sll_16/ML_int[3][5] S=FE_OFN305_h01_2
+ A=sll_16/ML_int[2][5] B=n54
Xsll_16/M1_2_7 MUX2 $PINS O=sll_16/ML_int[3][7] S=FE_OFN305_h01_2
+ A=sll_16/ML_int[2][7] B=sll_16/ML_int[2][3]
Xsll_16/M1_2_8 MUX2 $PINS O=sll_16/ML_int[3][8] S=FE_OFN305_h01_2
+ A=sll_16/ML_int[2][8] B=sll_16/ML_int[2][4]
Xsll_16/M1_2_9 MUX2 $PINS O=sll_16/ML_int[3][9] S=FE_OFN305_h01_2
+ A=sll_16/ML_int[2][9] B=sll_16/ML_int[2][5]
Xsll_16/M1_2_10 MUX2 $PINS O=sll_16/ML_int[3][10] S=FE_OFN305_h01_2
+ A=sll_16/ML_int[2][10] B=sll_16/ML_int[2][6]
Xsll_16/M1_2_11 MUX2 $PINS O=sll_16/ML_int[3][11] S=FE_OFN305_h01_2
+ A=sll_16/ML_int[2][11] B=sll_16/ML_int[2][7]
Xsll_16/M1_2_12 MUX2 $PINS O=sll_16/ML_int[3][12] S=FE_OFN305_h01_2
+ A=sll_16/ML_int[2][12] B=sll_16/ML_int[2][8]
Xsll_16/M1_2_13 MUX2 $PINS O=sll_16/ML_int[3][13] S=FE_OFN305_h01_2
+ A=sll_16/ML_int[2][13] B=sll_16/ML_int[2][9]
Xsll_16/M1_3_8 MUX2 $PINS O=term1_shifted[8] S=FE_OFN315_h01_3
+ A=sll_16/ML_int[3][8] B=sll_16/ML_int[3][0]
Xsll_16/M1_3_9 MUX2 $PINS O=term1_shifted[9] S=FE_OFN315_h01_3
+ A=sll_16/ML_int[3][9] B=sll_16/ML_int[3][1]
Xsll_16/M1_3_10 MUX2 $PINS O=term1_shifted[10] S=FE_OFN315_h01_3
+ A=sll_16/ML_int[3][10] B=sll_16/ML_int[3][2]
Xsll_16/M1_3_11 MUX2 $PINS O=term1_shifted[11] S=FE_OFN315_h01_3
+ A=sll_16/ML_int[3][11] B=sll_16/ML_int[3][3]
Xsll_16/M1_3_12 MUX2 $PINS O=term1_shifted[12] S=FE_OFN315_h01_3
+ A=sll_16/ML_int[3][12] B=sll_16/ML_int[3][4]
Xsll_16/M1_3_13 MUX2 $PINS O=term1_shifted[13] S=FE_OFN315_h01_3
+ A=sll_16/ML_int[3][13] B=sll_16/ML_int[3][5]
Xsll_16/M1_3_14 MUX2 $PINS O=term1_shifted[14] S=FE_OFN315_h01_3
+ A=sll_16/ML_int[3][14] B=sll_16/ML_int[3][6]
Xsll_16/M1_3_15 MUX2 $PINS O=term1_shifted[15] S=FE_OFN315_h01_3
+ A=sll_16/ML_int[3][15] B=sll_16/ML_int[3][7]
Xsll_16/M1_3_16 MUX2 $PINS O=term1_shifted[16] S=FE_OFN315_h01_3
+ A=sll_16/ML_int[3][16] B=sll_16/ML_int[3][8]
Xsll_16/M1_3_17 MUX2 $PINS O=term1_shifted[17] S=n41 A=sll_16/ML_int[3][17]
+ B=sll_16/ML_int[3][9]
Xsll_16/M1_3_23 MUX2 $PINS O=term1_shifted[23] S=n41 A=term1_in[26]
+ B=sll_16/ML_int[3][15]
Xy_out_reg[9] QDFFRBN $PINS Q=FE_PHN2181_pe_r0_9 D=N244 CK=CTS_10
+ RB=FE_OFN53_i_rst_n
Xy_out_reg[8] QDFFRBN $PINS Q=FE_PHN2185_pe_r0_8 D=N243 CK=CTS_10
+ RB=FE_OFN53_i_rst_n
Xy_out_reg[7] QDFFRBN $PINS Q=FE_PHN2187_pe_r0_7 D=N242 CK=CTS_10
+ RB=FE_OFN53_i_rst_n
Xy_out_reg[6] QDFFRBN $PINS Q=y_out[6] D=N241 CK=CTS_10 RB=i_rst_n
Xy_out_reg[5] QDFFRBN $PINS Q=y_out[5] D=N240 CK=CTS_10 RB=i_rst_n
Xy_out_reg[4] QDFFRBN $PINS Q=y_out[4] D=FE_PHN1952_N239 CK=CTS_10 RB=i_rst_n
Xy_out_reg[3] QDFFRBN $PINS Q=y_out[3] D=FE_PHN1568_N238 CK=CTS_10
+ RB=FE_OFN53_i_rst_n
Xy_out_reg[2] QDFFRBN $PINS Q=y_out[2] D=FE_PHN1945_N237 CK=CTS_10
+ RB=FE_OFN53_i_rst_n
Xy_out_reg[1] QDFFRBN $PINS Q=y_out[1] D=FE_PHN1955_N236 CK=CTS_10
+ RB=FE_OFN53_i_rst_n
Xy_out_reg[0] QDFFRBN $PINS Q=y_out[0] D=FE_PHN1961_N235 CK=CTS_10
+ RB=FE_OFN53_i_rst_n
Xacc_reg_reg[25] QDFFRBN $PINS Q=acc_reg[25] D=next_acc[25] CK=clk RB=i_rst_n
Xy_out_reg[16] QDFFRBN $PINS Q=y_out[16] D=FE_PHN1655_N251 CK=CTS_10
+ RB=FE_OFN53_i_rst_n
Xy_out_reg[10] QDFFRBN $PINS Q=y_out[10] D=N245 CK=CTS_10 RB=FE_OFN53_i_rst_n
Xacc_reg_reg[24] QDFFRBN $PINS Q=acc_reg[24] D=next_acc[24] CK=clk RB=i_rst_n
Xy_out_reg[11] QDFFRBN $PINS Q=y_out[11] D=FE_PHN1946_N246 CK=CTS_10
+ RB=FE_OFN53_i_rst_n
Xy_out_reg[12] QDFFRBN $PINS Q=y_out[12] D=N247 CK=CTS_10 RB=FE_OFN53_i_rst_n
Xy_out_reg[14] QDFFRBN $PINS Q=y_out[14] D=N249 CK=CTS_10 RB=FE_OFN53_i_rst_n
Xy_out_reg[15] QDFFRBN $PINS Q=y_out[15] D=N250 CK=CTS_10 RB=FE_OFN53_i_rst_n
Xy_out_reg[13] QDFFRBN $PINS Q=y_out[13] D=N248 CK=CTS_10 RB=FE_OFN53_i_rst_n
Xacc_reg_reg[23] QDFFRBN $PINS Q=acc_reg[23] D=next_acc[23] CK=clk_clone1
+ RB=i_rst_n
Xacc_reg_reg[22] QDFFRBN $PINS Q=acc_reg[22] D=next_acc[22] CK=clk_clone1
+ RB=i_rst_n
Xacc_reg_reg[21] QDFFRBN $PINS Q=acc_reg[21] D=next_acc[21] CK=clk_clone1
+ RB=i_rst_n
Xacc_reg_reg[20] QDFFRBN $PINS Q=acc_reg[20] D=next_acc[20] CK=clk_clone1
+ RB=FE_OFN47_i_rst_n
Xacc_reg_reg[19] QDFFRBN $PINS Q=acc_reg[19] D=next_acc[19] CK=clk_clone1
+ RB=FE_OFN47_i_rst_n
Xacc_reg_reg[18] QDFFRBN $PINS Q=acc_reg[18] D=next_acc[18] CK=clk_clone1
+ RB=FE_OFN47_i_rst_n
Xacc_reg_reg[17] QDFFRBN $PINS Q=acc_reg[17] D=next_acc[17] CK=clk_clone1
+ RB=FE_OFN47_i_rst_n
Xacc_reg_reg[16] QDFFRBN $PINS Q=acc_reg[16] D=next_acc[16] CK=clk_clone1
+ RB=FE_OFN47_i_rst_n
Xacc_reg_reg[15] QDFFRBN $PINS Q=acc_reg[15] D=next_acc[15] CK=clk_clone1
+ RB=FE_OFN47_i_rst_n
Xacc_reg_reg[14] QDFFRBN $PINS Q=acc_reg[14] D=next_acc[14] CK=clk_clone1
+ RB=FE_OFN47_i_rst_n
Xacc_reg_reg[13] QDFFRBN $PINS Q=acc_reg[13] D=next_acc[13] CK=clk_clone1
+ RB=FE_OFN47_i_rst_n
Xacc_reg_reg[12] QDFFRBN $PINS Q=acc_reg[12] D=next_acc[12] CK=clk_clone1
+ RB=FE_OFN47_i_rst_n
Xacc_reg_reg[11] QDFFRBN $PINS Q=acc_reg[11] D=next_acc[11] CK=clk_clone1
+ RB=FE_OFN47_i_rst_n
Xacc_reg_reg[10] QDFFRBN $PINS Q=acc_reg[10] D=next_acc[10] CK=clk_clone1
+ RB=FE_OFN47_i_rst_n
Xacc_reg_reg[9] QDFFRBN $PINS Q=acc_reg[9] D=next_acc[9] CK=clk_clone1
+ RB=FE_OFN47_i_rst_n
Xacc_reg_reg[8] QDFFRBN $PINS Q=acc_reg[8] D=next_acc[8] CK=clk_clone1
+ RB=FE_OFN47_i_rst_n
Xacc_reg_reg[7] QDFFRBN $PINS Q=acc_reg[7] D=next_acc[7] CK=clk_clone1
+ RB=FE_OFN47_i_rst_n
Xacc_reg_reg[6] QDFFRBN $PINS Q=acc_reg[6] D=next_acc[6] CK=clk_clone1
+ RB=FE_OFN47_i_rst_n
Xacc_reg_reg[5] QDFFRBN $PINS Q=acc_reg[5] D=next_acc[5] CK=clk_clone1
+ RB=FE_OFN47_i_rst_n
Xacc_reg_reg[4] QDFFRBN $PINS Q=acc_reg[4] D=next_acc[4] CK=clk_clone1
+ RB=FE_OFN47_i_rst_n
Xacc_reg_reg[3] QDFFRBN $PINS Q=acc_reg[3] D=next_acc[3] CK=clk_clone1
+ RB=FE_OFN47_i_rst_n
Xacc_reg_reg[2] QDFFRBN $PINS Q=acc_reg[2] D=next_acc[2] CK=clk_clone1
+ RB=FE_OFN47_i_rst_n
Xacc_reg_reg[1] QDFFRBN $PINS Q=acc_reg[1] D=next_acc[1] CK=clk_clone1
+ RB=FE_OFN47_i_rst_n
Xacc_reg_reg[0] QDFFRBN $PINS Q=acc_reg[0] D=FE_PHN1575_next_acc_0
+ CK=clk_clone1 RB=FE_OFN47_i_rst_n
Xacc_reg_reg[26] QDFFRBS $PINS Q=N251 D=next_acc[26] CK=clk RB=i_rst_n
XU5 AO22 $PINS O=N42 A1=N15 A2=sign1[0] B1=term1_shifted[1] B2=n44
XU7 MUX2 $PINS O=sll_16/ML_int[1][2] S=FE_OFN494_FE_OFN57_h01_0 A=term1_in[2]
+ B=term1_in[1]
XU8 AO22 $PINS O=N153 A1=N126 A2=sign3[0] B1=term3_shifted[2]
+ B2=FE_OFN416_s03_0
XU14 AN2 $PINS O=sll_18/ML_int[1][0] I1=term3_in[0] I2=n10
XU17 AO22 $PINS O=N44 A1=N17 A2=sign1[0] B1=term1_shifted[3] B2=n44
XU19 NR2 $PINS O=term1_shifted[0] I1=n1 I2=n3
XU20 ND2P $PINS O=n1 I1=term1_in[0] I2=n35
XU22 AN2 $PINS O=term1_shifted[4] I1=sll_16/ML_int[3][4] I2=shf1[3]
XU23 ND2 $PINS O=n49 I1=sll_16/ML_int[1][0] I2=FE_OFN341_h01_1
XU24 NR2 $PINS O=sll_16/ML_int[3][2] I1=FE_OFN305_h01_2 I2=FE_OCPN1132_n6
XU28 INV1S $PINS O=n62 I=sll_17/ML_int[2][3]
XU29 MUX2S $PINS O=sll_18/ML_int[1][5] S=shf3[0] A=term3_in[5] B=term3_in[4]
XU30 MUX2 $PINS O=sll_16/ML_int[1][4] S=FE_OFN494_FE_OFN57_h01_0 A=term1_in[4]
+ B=term1_in[3]
XU35 INV2 $PINS O=n63 I=sll_17/ML_int[2][2]
XU38 NR2 $PINS O=term2_in[1] I1=sign2[1] I2=x_in[1]
XU39 NR2P $PINS O=term2_shifted[3] I1=n61 I2=n62
XU40 INV1S $PINS O=n52 I=sll_16/ML_int[2][3]
XU43 AO22 $PINS O=N154 A1=N127 A2=sign3[0] B1=term3_shifted[3]
+ B2=FE_OFN416_s03_0
XU45 INV1S $PINS O=n22 I=shf2[0]
XU47 NR2T $PINS O=term3_shifted[1] I1=n71 I2=n70
XU51 MUX2 $PINS O=sll_17/ML_int[1][2] S=shf2[0] A=term2_in[2] B=term2_in[1]
XU52 MUX2S $PINS O=sll_17/ML_int[1][5] S=shf2[0] A=term2_in[5] B=term2_in[4]
XU53 NR2 $PINS O=term3_in[2] I1=sign3[1] I2=x_in[2]
XU55 ND2P $PINS O=n70 I1=sll_18/ML_int[1][1] I2=FE_OFN166_h03_1
XU56 AN2T $PINS O=sll_17/ML_int[1][0] I1=term2_in[0] I2=n22
XU57 NR2T $PINS O=term2_in[0] I1=sign2[1] I2=n100
XU59 NR2T $PINS O=term3_in[0] I1=sign3[1] I2=n100
XU62 ND2 $PINS O=n71 I1=shf3[2] I2=shf3[3]
XU63 OR2 $PINS O=n3 I1=n51 I2=shf1[1]
XU64 ND2P $PINS O=n61 I1=n26 I2=shf2[3]
XU66 NR2 $PINS O=term3_in[3] I1=sign3[1] I2=x_in[3]
XU67 NR2 $PINS O=term2_in[4] I1=sign2[1] I2=x_in[4]
XU68 NR2 $PINS O=term3_in[4] I1=sign3[1] I2=x_in[4]
XU69 NR2T $PINS O=term1_in[4] I1=sign1[1] I2=x_in[4]
XU70 NR2 $PINS O=term1_in[1] I1=sign1[1] I2=x_in[1]
XU71 MUX2 $PINS O=sll_17/ML_int[2][2] S=shf2[1] A=sll_17/ML_int[1][2]
+ B=sll_17/ML_int[1][0]
XU72 MXL2HS $PINS OB=n6 S=shf1[1] A=sll_16/ML_int[1][2] B=sll_16/ML_int[1][0]
XU75 AO22 $PINS O=N155 A1=N128 A2=sign3[0] B1=term3_shifted[4]
+ B2=FE_OFN416_s03_0
XU76 AO22 $PINS O=N45 A1=N18 A2=sign1[0] B1=term1_shifted[4] B2=n44
XU81 NR2 $PINS O=term2_in[3] I1=sign2[1] I2=x_in[3]
XU83 AO22 $PINS O=N43 A1=N16 A2=sign1[0] B1=term1_shifted[2] B2=n44
XU84 MUX2S $PINS O=sll_18/ML_int[3][6] S=n15 A=sll_18/ML_int[2][6]
+ B=sll_18/ML_int[2][2]
XU85 INV1S $PINS O=sll_16/ML_int[2][2] I=FE_OCPN1132_n6
XU86 AO22 $PINS O=N51 A1=N24 A2=FE_OFN273_s01_0 B1=term1_shifted[10] B2=n44
XU87 AO22 $PINS O=N55 A1=N28 A2=FE_OFN273_s01_0 B1=term1_shifted[14]
+ B2=FE_OFN274_s01_0
XU88 MUX2S $PINS O=sll_17/ML_int[3][6] S=shf2[2] A=sll_17/ML_int[2][6]
+ B=sll_17/ML_int[2][2]
XU89 NR2 $PINS O=term2_shifted[2] I1=n61 I2=n63
XU91 MUX2 $PINS O=sll_16/ML_int[3][6] S=FE_OFN305_h01_2 A=sll_16/ML_int[2][6]
+ B=sll_16/ML_int[2][2]
XU92 AN2 $PINS O=n7 I1=FE_OCPN1219_sll_17_ML_int_1_1 I2=n24
XU95 MUX2 $PINS O=sll_16/ML_int[1][3] S=FE_OFN494_FE_OFN57_h01_0 A=term1_in[3]
+ B=term1_in[2]
XU97 MUX2S $PINS O=sll_18/ML_int[1][3] S=shf3[0] A=term3_in[3] B=term3_in[2]
XU101 AN2 $PINS O=base_val[4] I1=acc_reg[4] I2=n101
XU102 AN2 $PINS O=base_val[5] I1=acc_reg[5] I2=n101
XU103 AN2 $PINS O=base_val[0] I1=acc_reg[0] I2=n101
XU104 MUX2S $PINS O=sll_17/ML_int[3][11] S=shf2[2] A=sll_17/ML_int[2][11]
+ B=sll_17/ML_int[2][7]
XU105 MUX2S $PINS O=sll_16/ML_int[2][12] S=n36 A=sll_16/ML_int[1][12]
+ B=sll_16/ML_int[1][10]
XU106 MUX2S $PINS O=sll_18/ML_int[2][12] S=n12 A=sll_18/ML_int[1][12]
+ B=sll_18/ML_int[1][10]
XU107 MUX2S $PINS O=sll_17/ML_int[2][12] S=shf2[1] A=sll_17/ML_int[1][12]
+ B=sll_17/ML_int[1][10]
XU108 MUX2S $PINS O=sll_16/ML_int[1][11] S=FE_OFN494_FE_OFN57_h01_0
+ A=term1_in[11] B=term1_in[10]
XU109 MUX2S $PINS O=sll_16/ML_int[3][14] S=FE_OFN305_h01_2
+ A=sll_16/ML_int[2][14] B=sll_16/ML_int[2][10]
XU111 MUX2S $PINS O=sll_18/ML_int[1][11] S=shf3[0] A=term3_in[11]
+ B=term3_in[10]
XU112 MUX2S $PINS O=sll_16/ML_int[2][13] S=n36 A=sll_16/ML_int[1][13]
+ B=sll_16/ML_int[1][11]
XU113 MUX2S $PINS O=sll_16/ML_int[1][13] S=FE_OFN494_FE_OFN57_h01_0
+ A=term1_in[13] B=term1_in[12]
XU114 MUX2S $PINS O=sll_17/ML_int[1][11] S=shf2[0] A=term2_in[11]
+ B=term2_in[10]
XU123 MUX2S $PINS O=sll_18/ML_int[3][14] S=FE_OFN454_n15 A=sll_18/ML_int[2][14]
+ B=sll_18/ML_int[2][10]
XU124 MUX2S $PINS O=sll_17/ML_int[3][14] S=shf2[2] A=sll_17/ML_int[2][14]
+ B=sll_17/ML_int[2][10]
XU125 MUX2S $PINS O=sll_18/ML_int[2][13] S=n12 A=sll_18/ML_int[1][13]
+ B=sll_18/ML_int[1][11]
XU126 MUX2S $PINS O=sll_18/ML_int[1][13] S=shf3[0] A=term3_in[13]
+ B=term3_in[12]
XU127 MUX2S $PINS O=sll_17/ML_int[2][13] S=shf2[1] A=sll_17/ML_int[1][13]
+ B=sll_17/ML_int[1][11]
XU128 MUX2S $PINS O=sll_17/ML_int[1][13] S=shf2[0] A=term2_in[13]
+ B=term2_in[12]
XU129 MUX2S $PINS O=sll_16/ML_int[1][12] S=FE_OFN494_FE_OFN57_h01_0
+ A=term1_in[12] B=term1_in[11]
XU130 MUX2S $PINS O=sll_18/ML_int[1][12] S=shf3[0] A=term3_in[12]
+ B=term3_in[11]
XU131 MUX2S $PINS O=sll_16/ML_int[3][15] S=FE_OFN305_h01_2
+ A=sll_16/ML_int[2][15] B=sll_16/ML_int[2][11]
XU137 MUX2S $PINS O=sll_16/ML_int[2][14] S=n36 A=sll_16/ML_int[1][14]
+ B=sll_16/ML_int[1][12]
XU138 MUX2S $PINS O=sll_16/ML_int[1][14] S=FE_OFN494_FE_OFN57_h01_0
+ A=term1_in[14] B=term1_in[13]
XU139 MUX2S $PINS O=sll_17/ML_int[1][12] S=shf2[0] A=term2_in[12]
+ B=term2_in[11]
XU140 MUX2S $PINS O=sll_18/ML_int[3][15] S=FE_OFN454_n15 A=sll_18/ML_int[2][15]
+ B=sll_18/ML_int[2][11]
XU141 MUX2S $PINS O=term2_shifted[15] S=n28 A=sll_17/ML_int[3][15]
+ B=sll_17/ML_int[3][7]
XU164 MUX2S $PINS O=sll_17/ML_int[3][15] S=shf2[2] A=sll_17/ML_int[2][15]
+ B=sll_17/ML_int[2][11]
XU165 MUX2S $PINS O=sll_18/ML_int[2][14] S=n12 A=sll_18/ML_int[1][14]
+ B=sll_18/ML_int[1][12]
XU166 MUX2S $PINS O=sll_18/ML_int[1][14] S=shf3[0] A=term3_in[14]
+ B=term3_in[13]
XU167 MUX2S $PINS O=sll_17/ML_int[2][14] S=shf2[1] A=sll_17/ML_int[1][14]
+ B=sll_17/ML_int[1][12]
XU168 MUX2S $PINS O=sll_17/ML_int[1][14] S=shf2[0] A=term2_in[14]
+ B=term2_in[13]
XU182 MUX2S $PINS O=sll_16/ML_int[3][16] S=FE_OFN305_h01_2 A=n55
+ B=sll_16/ML_int[2][12]
XU192 MUX2S $PINS O=sll_18/ML_int[3][16] S=FE_OFN454_n15 A=n76
+ B=sll_18/ML_int[2][12]
XU193 MUX2S $PINS O=sll_17/ML_int[3][16] S=shf2[2] A=n65 B=sll_17/ML_int[2][12]
XU194 MUX2S $PINS O=n65 S=shf2[1] A=n68 B=sll_17/ML_int[1][14]
XU195 MUX2S $PINS O=sll_16/ML_int[2][15] S=n36 A=sll_16/ML_int[1][15]
+ B=sll_16/ML_int[1][13]
XU196 MUX2S $PINS O=sll_16/ML_int[1][15] S=FE_OFN494_FE_OFN57_h01_0
+ A=term1_in[15] B=term1_in[14]
XU197 MUX2S $PINS O=sll_18/ML_int[2][15] S=n12 A=sll_18/ML_int[1][15]
+ B=sll_18/ML_int[1][13]
XU198 MUX2S $PINS O=sll_18/ML_int[1][15] S=shf3[0] A=term3_in[15]
+ B=term3_in[14]
XU199 MUX2S $PINS O=sll_17/ML_int[2][15] S=shf2[1] A=sll_17/ML_int[1][15]
+ B=sll_17/ML_int[1][13]
XU200 MUX2S $PINS O=sll_17/ML_int[1][15] S=FE_OFN491_FE_OFN63_h02_0
+ A=term2_in[15] B=term2_in[14]
XU201 MUX2S $PINS O=sll_16/ML_int[3][17] S=FE_OFN305_h01_2 A=n56
+ B=sll_16/ML_int[2][13]
XU202 MUX2S $PINS O=term1_shifted[18] S=n41 A=sll_16/ML_int[3][18]
+ B=sll_16/ML_int[3][10]
XU203 MUX2S $PINS O=sll_18/ML_int[3][17] S=FE_OFN454_n15 A=n77
+ B=sll_18/ML_int[2][13]
XU204 MUX2S $PINS O=n66 S=shf2[1] A=term2_in[26] B=sll_17/ML_int[1][15]
XU205 MUX2S $PINS O=sll_17/ML_int[3][17] S=shf2[2] A=n66 B=sll_17/ML_int[2][13]
XU206 MUX2S $PINS O=sll_16/ML_int[3][18] S=FE_OFN305_h01_2 A=n57
+ B=sll_16/ML_int[2][14]
XU207 MUX2S $PINS O=term3_shifted[18] S=n17 A=sll_18/ML_int[3][18]
+ B=sll_18/ML_int[3][10]
XU208 MUX2S $PINS O=term2_shifted[18] S=n28 A=sll_17/ML_int[3][18]
+ B=sll_17/ML_int[3][10]
XU209 MUX2S $PINS O=sll_18/ML_int[3][18] S=FE_OFN454_n15 A=n78
+ B=sll_18/ML_int[2][14]
XU210 MUX2S $PINS O=sll_17/ML_int[3][18] S=shf2[2] A=n67 B=sll_17/ML_int[2][14]
XU211 MUX2S $PINS O=n67 S=shf2[1] A=term2_in[26] B=n68
XU212 MUX2S $PINS O=term1_shifted[19] S=n41 A=sll_16/ML_int[3][19]
+ B=sll_16/ML_int[3][11]
XU213 MUX2S $PINS O=sll_16/ML_int[3][19] S=FE_OFN305_h01_2 A=term1_in[26]
+ B=sll_16/ML_int[2][15]
XU214 MUX2S $PINS O=term3_shifted[19] S=n17 A=sll_18/ML_int[3][19]
+ B=sll_18/ML_int[3][11]
XU215 MUX2S $PINS O=sll_18/ML_int[3][19] S=FE_OFN454_n15 A=term3_in[26]
+ B=sll_18/ML_int[2][15]
XU216 MUX2S $PINS O=term2_shifted[19] S=n28 A=sll_17/ML_int[3][19]
+ B=sll_17/ML_int[3][11]
XU217 MUX2S $PINS O=sll_17/ML_int[3][19] S=shf2[2] A=term2_in[26]
+ B=sll_17/ML_int[2][15]
XU218 MUX2S $PINS O=term1_shifted[20] S=n41 A=sll_16/ML_int[3][20]
+ B=sll_16/ML_int[3][12]
XU219 MUX2S $PINS O=sll_16/ML_int[3][20] S=FE_OFN305_h01_2 A=term1_in[26] B=n55
XU220 MUX2S $PINS O=term3_shifted[20] S=n17 A=sll_18/ML_int[3][20]
+ B=sll_18/ML_int[3][12]
XU221 MUX2S $PINS O=sll_18/ML_int[3][20] S=FE_OFN454_n15 A=term3_in[26] B=n76
XU222 MUX2S $PINS O=term2_shifted[20] S=n28 A=sll_17/ML_int[3][20]
+ B=sll_17/ML_int[3][12]
XU223 MUX2S $PINS O=sll_17/ML_int[3][20] S=shf2[2] A=term2_in[26] B=n65
XU224 MUX2S $PINS O=term1_shifted[21] S=n41 A=sll_16/ML_int[3][21]
+ B=sll_16/ML_int[3][13]
XU225 MUX2S $PINS O=sll_16/ML_int[3][21] S=FE_OFN305_h01_2 A=term1_in[26] B=n56
XU226 MUX2S $PINS O=term3_shifted[21] S=n17 A=sll_18/ML_int[3][21]
+ B=sll_18/ML_int[3][13]
XU227 MUX2S $PINS O=sll_18/ML_int[3][21] S=FE_OFN454_n15 A=term3_in[26] B=n77
XU228 MUX2S $PINS O=term2_shifted[21] S=n28 A=sll_17/ML_int[3][21]
+ B=sll_17/ML_int[3][13]
XU229 MUX2S $PINS O=sll_17/ML_int[3][21] S=shf2[2] A=term2_in[26] B=n66
XU230 MUX2S $PINS O=term1_shifted[22] S=n41 A=sll_16/ML_int[3][22]
+ B=sll_16/ML_int[3][14]
XU231 MUX2S $PINS O=sll_16/ML_int[3][22] S=FE_OFN305_h01_2 A=term1_in[26] B=n57
XU232 MUX2S $PINS O=sll_18/ML_int[3][22] S=n15 A=term3_in[26] B=n78
XU233 MUX2S $PINS O=sll_17/ML_int[3][22] S=shf2[2] A=term2_in[26] B=n67
XU234 AO22 $PINS O=N52 A1=N25 A2=FE_OFN273_s01_0 B1=term1_shifted[11]
+ B2=FE_OFN274_s01_0
XU235 AO22 $PINS O=N53 A1=N26 A2=FE_OFN273_s01_0 B1=term1_shifted[12]
+ B2=FE_OFN274_s01_0
XU237 AO22S $PINS O=N56 A1=N29 A2=FE_OFN273_s01_0 B1=term1_shifted[15]
+ B2=FE_OFN274_s01_0
XU238 AO22 $PINS O=N57 A1=N30 A2=FE_OFN273_s01_0 B1=term1_shifted[16]
+ B2=FE_OFN274_s01_0
XU239 AO22 $PINS O=N58 A1=N31 A2=FE_OFN273_s01_0 B1=term1_shifted[17]
+ B2=FE_OFN274_s01_0
XU240 AO22 $PINS O=N59 A1=N32 A2=FE_OFN273_s01_0 B1=term1_shifted[18]
+ B2=FE_OFN274_s01_0
XU245 AN2S $PINS O=base_val[6] I1=acc_reg[6] I2=n101
XU246 AO22 $PINS O=N109 A1=N82 A2=FE_OFN401_s02_0 B1=term2_shifted[13] B2=n32
XU247 ND2S $PINS O=n102 I1=FE_PHN1655_N251 I2=stage_sel
XU248 MUX2S $PINS O=N235 S=stage_sel A=acc_reg[10] B=FE_PHN1507_acc_reg_14
XU249 MUX2S $PINS O=N236 S=stage_sel A=acc_reg[11] B=FE_PHN1450_acc_reg_15
XU250 MUX2S $PINS O=N237 S=stage_sel A=acc_reg[12] B=FE_PHN1415_acc_reg_16
XU251 MUX2S $PINS O=N238 S=stage_sel A=acc_reg[13] B=acc_reg[17]
XU252 MUX2S $PINS O=N239 S=stage_sel A=FE_PHN1507_acc_reg_14 B=acc_reg[18]
XU253 MUX2S $PINS O=FE_PHN1936_N240 S=stage_sel A=FE_PHN1450_acc_reg_15
+ B=acc_reg[19]
XU254 MUX2S $PINS O=FE_PHN1567_N242 S=stage_sel A=acc_reg[17] B=acc_reg[21]
XU255 MUX2S $PINS O=N245 S=stage_sel A=FE_PHN1424_acc_reg_20
+ B=FE_PHN1484_acc_reg_24
XU256 MUX2S $PINS O=N246 S=stage_sel A=acc_reg[21] B=FE_PHN1446_acc_reg_25
XU261 INV1S $PINS O=n53 I=n49
XU262 INV1S $PINS O=n74 I=n69
XU263 INV1S $PINS O=n64 I=FE_OCPN1227_n59
XU264 INV1S $PINS O=n54 I=n50
XU265 INV1S $PINS O=n75 I=n70
XU266 ND2P $PINS O=n60 I1=sll_17/ML_int[1][1] I2=n24
XU267 NR2 $PINS O=term1_in[5] I1=sign1[1] I2=x_in[5]
XU268 NR2 $PINS O=term3_in[5] I1=sign3[1] I2=x_in[5]
XU269 NR2 $PINS O=term2_in[5] I1=sign2[1] I2=x_in[5]
XU270 NR2 $PINS O=term1_in[8] I1=sign1[1] I2=x_in[8]
XU271 NR2 $PINS O=term3_in[8] I1=sign3[1] I2=x_in[8]
XU272 NR2 $PINS O=term1_in[6] I1=sign1[1] I2=x_in[6]
XU273 NR2 $PINS O=term2_in[8] I1=sign2[1] I2=x_in[8]
XU274 NR2 $PINS O=term3_in[6] I1=sign3[1] I2=x_in[6]
XU275 NR2 $PINS O=term2_in[6] I1=sign2[1] I2=x_in[6]
XU276 NR2 $PINS O=term1_in[9] I1=sign1[1] I2=x_in[9]
XU277 NR2 $PINS O=term3_in[9] I1=sign3[1] I2=x_in[9]
XU278 NR2 $PINS O=term1_in[7] I1=sign1[1] I2=x_in[7]
XU279 NR2 $PINS O=term3_in[7] I1=sign3[1] I2=x_in[7]
XU280 NR2 $PINS O=term2_in[9] I1=sign2[1] I2=x_in[9]
XU281 NR2 $PINS O=term2_in[7] I1=sign2[1] I2=x_in[7]
XU284 NR2 $PINS O=term1_in[10] I1=sign1[1] I2=x_in[10]
XU285 NR2 $PINS O=term3_in[10] I1=sign3[1] I2=x_in[10]
XU287 NR2 $PINS O=term2_in[10] I1=sign2[1] I2=x_in[10]
XU291 NR2 $PINS O=term1_in[11] I1=sign1[1] I2=x_in[11]
XU292 NR2 $PINS O=term3_in[11] I1=sign3[1] I2=x_in[11]
XU293 NR2 $PINS O=term2_in[11] I1=sign2[1] I2=x_in[11]
XU296 NR2 $PINS O=term1_in[12] I1=sign1[1] I2=x_in[12]
XU297 NR2 $PINS O=term3_in[12] I1=sign3[1] I2=x_in[12]
XU298 NR2 $PINS O=term2_in[12] I1=sign2[1] I2=x_in[12]
XU300 NR2 $PINS O=term1_in[13] I1=sign1[1] I2=x_in[13]
XU301 NR2 $PINS O=term3_in[13] I1=sign3[1] I2=x_in[13]
XU302 NR2 $PINS O=term2_in[13] I1=sign2[1] I2=x_in[13]
XU303 NR2 $PINS O=term1_in[14] I1=sign1[1] I2=x_in[14]
XU304 NR2 $PINS O=term3_in[14] I1=sign3[1] I2=x_in[14]
XU305 NR2 $PINS O=term2_in[14] I1=sign2[1] I2=x_in[14]
XU306 NR2 $PINS O=term1_in[15] I1=sign1[1] I2=n89
XU308 NR2 $PINS O=term3_in[15] I1=sign3[1] I2=n89
XU310 NR2 $PINS O=term1_in[26] I1=n90 I2=sign1[1]
XU311 NR2 $PINS O=term3_in[26] I1=n90 I2=sign3[1]
XU312 NR2 $PINS O=term2_in[15] I1=sign2[1] I2=n89
XU314 NR2 $PINS O=term2_in[26] I1=n90 I2=sign2[1]
XU319 INV1S $PINS O=n10 I=shf3[0]
XU321 INV1S $PINS O=n26 I=shf2[2]
XU333 INV1S $PINS O=n89 I=x_in[15]
XU334 INV1S $PINS O=n90 I=x_in[16]
XU335 AN2 $PINS O=base_val[26] I1=FE_PHN2082_N251 I2=n101
XU336 AN2 $PINS O=base_val[1] I1=acc_reg[1] I2=n101
XU337 MOAI1S $PINS O=base_val[9] A1=stage_sel A2=n101 B1=acc_reg[9] B2=n101
XU338 AN2 $PINS O=base_val[10] I1=acc_reg[10] I2=n101
XU340 AN2 $PINS O=base_val[7] I1=acc_reg[7] I2=n101
XU341 AN2 $PINS O=base_val[3] I1=acc_reg[3] I2=n101
XU342 AN2 $PINS O=base_val[2] I1=acc_reg[2] I2=n101
XU344 AN2 $PINS O=base_val[12] I1=acc_reg[12] I2=n101
XU345 AN2 $PINS O=base_val[14] I1=acc_reg[14] I2=n101
XU346 AN2 $PINS O=base_val[15] I1=acc_reg[15] I2=n101
XU347 AN2 $PINS O=base_val[16] I1=acc_reg[16] I2=n101
XU348 AN2 $PINS O=base_val[17] I1=acc_reg[17] I2=n101
XU349 AN2 $PINS O=base_val[18] I1=acc_reg[18] I2=n101
XU350 AN2 $PINS O=base_val[19] I1=acc_reg[19] I2=n101
XU351 AN2 $PINS O=base_val[20] I1=acc_reg[20] I2=n101
XU352 AN2 $PINS O=base_val[21] I1=acc_reg[21] I2=n101
XU353 AN2 $PINS O=base_val[22] I1=acc_reg[22] I2=n101
XU354 AN2 $PINS O=base_val[23] I1=acc_reg[23] I2=n101
XU355 AN2 $PINS O=base_val[24] I1=acc_reg[24] I2=n101
XU356 AN2 $PINS O=base_val[25] I1=acc_reg[25] I2=n101
XU358 AN2 $PINS O=N234 I1=en I2=calc_done
XU359 OAI12HS $PINS O=N247 A1=n102 B1=stage_sel B2=n83
XU360 INV1S $PINS O=n83 I=FE_PHN1395_acc_reg_22
XU361 OAI12HS $PINS O=N248 A1=n102 B1=stage_sel B2=n82
XU362 INV1S $PINS O=n82 I=FE_PHN1383_acc_reg_23
XU363 OAI12HS $PINS O=N249 A1=n102 B1=stage_sel B2=n81
XU364 INV1S $PINS O=n81 I=FE_PHN1484_acc_reg_24
XU365 OAI12HS $PINS O=N250 A1=n102 B1=stage_sel B2=n80
XU366 INV1S $PINS O=n80 I=FE_PHN1446_acc_reg_25
XU368 NR2 $PINS O=sll_16/ML_int[3][0] I1=FE_OFN305_h01_2 I2=n49
XU369 NR2 $PINS O=sll_16/ML_int[3][1] I1=FE_OFN305_h01_2 I2=n50
XU370 NR2 $PINS O=sll_16/ML_int[3][3] I1=FE_OFN305_h01_2 I2=n52
XU371 AN2 $PINS O=term1_shifted[5] I1=sll_16/ML_int[3][5] I2=shf1[3]
XU372 AN2 $PINS O=term1_shifted[6] I1=sll_16/ML_int[3][6] I2=shf1[3]
XU373 AN2 $PINS O=term1_shifted[7] I1=sll_16/ML_int[3][7] I2=shf1[3]
XU374 MUX2 $PINS O=term1_shifted[24] S=n41 A=term1_in[26]
+ B=sll_16/ML_int[3][16]
XU375 MUX2 $PINS O=n55 S=n36 A=n58 B=sll_16/ML_int[1][14]
XU376 MUX2 $PINS O=term1_shifted[25] S=n41 A=term1_in[26]
+ B=sll_16/ML_int[3][17]
XU377 MUX2 $PINS O=n56 S=n36 A=term1_in[26] B=sll_16/ML_int[1][15]
XU378 MUX2 $PINS O=term1_shifted[26] S=n41 A=term1_in[26]
+ B=sll_16/ML_int[3][18]
XU379 MUX2 $PINS O=n57 S=n36 A=term1_in[26] B=n58
XU380 MUX2 $PINS O=n58 S=FE_OFN494_FE_OFN57_h01_0 A=term1_in[26] B=term1_in[15]
XU381 NR2 $PINS O=sll_17/ML_int[3][0] I1=shf2[2] I2=FE_OCPN1227_n59
XU382 NR2 $PINS O=sll_17/ML_int[3][1] I1=shf2[2] I2=n60
XU383 NR2 $PINS O=sll_17/ML_int[3][2] I1=shf2[2] I2=n63
XU384 NR2 $PINS O=sll_17/ML_int[3][3] I1=shf2[2] I2=n62
XU385 AN2 $PINS O=term2_shifted[4] I1=sll_17/ML_int[3][4] I2=shf2[3]
XU386 AN2 $PINS O=term2_shifted[5] I1=sll_17/ML_int[3][5] I2=shf2[3]
XU387 AN2 $PINS O=term2_shifted[6] I1=sll_17/ML_int[3][6] I2=shf2[3]
XU388 AN2 $PINS O=term2_shifted[7] I1=sll_17/ML_int[3][7] I2=shf2[3]
XU389 MUX2 $PINS O=term2_shifted[24] S=n28 A=term2_in[26]
+ B=sll_17/ML_int[3][16]
XU390 MUX2 $PINS O=term2_shifted[25] S=n28 A=term2_in[26]
+ B=sll_17/ML_int[3][17]
XU391 MUX2 $PINS O=term2_shifted[26] S=n28 A=term2_in[26]
+ B=sll_17/ML_int[3][18]
XU392 MUX2 $PINS O=n68 S=FE_OFN491_FE_OFN63_h02_0 A=term2_in[26] B=term2_in[15]
XU393 NR2 $PINS O=sll_18/ML_int[3][0] I1=n15 I2=n69
XU394 NR2 $PINS O=sll_18/ML_int[3][1] I1=n15 I2=n70
XU397 AN2T $PINS O=term3_shifted[4] I1=sll_18/ML_int[3][4] I2=shf3[3]
XU398 AN2 $PINS O=term3_shifted[5] I1=sll_18/ML_int[3][5] I2=shf3[3]
XU399 AN2 $PINS O=term3_shifted[6] I1=sll_18/ML_int[3][6] I2=shf3[3]
XU400 AN2 $PINS O=term3_shifted[7] I1=sll_18/ML_int[3][7] I2=shf3[3]
XU401 MUX2 $PINS O=term3_shifted[24] S=n17 A=term3_in[26]
+ B=sll_18/ML_int[3][16]
XU402 MUX2 $PINS O=n76 S=n12 A=n79 B=sll_18/ML_int[1][14]
XU403 MUX2 $PINS O=term3_shifted[25] S=n17 A=term3_in[26]
+ B=sll_18/ML_int[3][17]
XU404 MUX2 $PINS O=n77 S=n12 A=term3_in[26] B=sll_18/ML_int[1][15]
XU405 MUX2 $PINS O=term3_shifted[26] S=n17 A=term3_in[26]
+ B=sll_18/ML_int[3][18]
XU406 MUX2 $PINS O=n78 S=n12 A=term3_in[26] B=n79
XU407 MUX2 $PINS O=n79 S=shf3[0] A=term3_in[26] B=term3_in[15]
XU408 MUX2 $PINS O=N241 S=stage_sel A=FE_PHN1415_acc_reg_16
+ B=FE_PHN1424_acc_reg_20
XU409 MUX2 $PINS O=FE_PHN1933_N243 S=stage_sel A=acc_reg[18]
+ B=FE_PHN1395_acc_reg_22
XU410 MUX2 $PINS O=FE_PHN1921_N244 S=stage_sel A=acc_reg[19]
+ B=FE_PHN1383_acc_reg_23
Xsll_17/M1_0_3 MUX2S $PINS O=sll_17/ML_int[1][3] S=shf2[0] A=term2_in[3]
+ B=term2_in[2]
XU3 NR2 $PINS O=term3_shifted[3] I1=n71 I2=n72
XU6 NR2P $PINS O=n4 I1=n61 I2=n63
XU11 NR2T $PINS O=term2_shifted[0] I1=n61 I2=n59
XU12 INV3 $PINS O=n100 I=x_in[0]
XU13 NR2T $PINS O=term1_shifted[1] I1=n51 I2=n50
XU16 ND2P $PINS O=n50 I1=sll_16/ML_int[1][1] I2=FE_OFN341_h01_1
XU18 NR2P $PINS O=term1_in[0] I1=sign1[1] I2=n100
XU25 NR2P $PINS O=term3_shifted[2] I1=n71 I2=n73
XU26 AN2 $PINS O=base_val[8] I1=acc_reg[8] I2=n101
XU27 MUX2 $PINS O=sll_17/ML_int[2][4] S=n24 A=sll_17/ML_int[1][2]
+ B=sll_17/ML_int[1][4]
XU33 OR2 $PINS O=n51 I1=FE_OFN305_h01_2 I2=FE_OFN315_h01_3
XU34 NR2P $PINS O=term3_shifted[0] I1=n71 I2=n69
XU36 NR2 $PINS O=sll_18/ML_int[3][2] I1=n15 I2=n73
XU37 INV2 $PINS O=n73 I=sll_18/ML_int[2][2]
XU46 AN2 $PINS O=base_val[11] I1=acc_reg[11] I2=n101
XU48 AN2B1T $PINS O=term1_shifted[3] I1=sll_16/ML_int[2][3] B1=n51
XU49 ND3 $PINS O=n69 I1=term3_in[0] I2=n10 I3=FE_OFN166_h03_1
XU54 NR2 $PINS O=sll_18/ML_int[3][3] I1=n15 I2=n72
XU61 INV1S $PINS O=sll_16/ML_int[1][0] I=n1
XU98 ND2T $PINS O=n59 I1=sll_17/ML_int[1][0] I2=n24
XU99 NR2P $PINS O=term2_shifted[1] I1=n61 I2=n60
XU100 NR2 $PINS O=term2_in[2] I1=sign2[1] I2=x_in[2]
XU327 NR2 $PINS O=term3_in[1] I1=sign3[1] I2=x_in[1]
XU339 NR2 $PINS O=term1_in[2] I1=sign1[1] I2=x_in[2]
XU343 NR2 $PINS O=term1_in[3] I1=sign1[1] I2=x_in[3]
XU395 NR2P $PINS O=term1_shifted[2] I1=n51 I2=n6
Xclk_gate_y_out_reg SNPS_CLOCK_GATE_HIGH_PE_Shift_Add_7 $PINS EN=N234
+ ENCLK=CTS_12 CLK=clk_clone2
Xsub_28_3 PE_Shift_Add_7_DW01_sub_0_DW01_sub_21 $PINS A[26]=net45637
+ A[25]=net45637 A[24]=net45637 A[23]=net45637 A[22]=net45637 A[21]=net45637
+ A[20]=net45637 A[19]=net45637 A[18]=net45637 A[17]=net45637 A[16]=net45637
+ A[15]=net45637 A[14]=net45637 A[13]=net45637 A[12]=net45637 A[11]=net45637
+ A[10]=net45637 A[9]=net45637 A[8]=net45637 A[7]=net45637 A[6]=net45637
+ A[5]=net45637 A[4]=net45637 A[3]=net45637 A[2]=net45637 A[1]=net45637
+ A[0]=net45637 B[26]=term3_shifted[26] B[25]=term3_shifted[25]
+ B[24]=term3_shifted[24] B[23]=term3_shifted[23] B[22]=term3_shifted[22]
+ B[21]=term3_shifted[21] B[20]=term3_shifted[20] B[19]=term3_shifted[19]
+ B[18]=term3_shifted[18] B[17]=term3_shifted[17] B[16]=term3_shifted[16]
+ B[15]=term3_shifted[15] B[14]=term3_shifted[14] B[13]=term3_shifted[13]
+ B[12]=term3_shifted[12] B[11]=term3_shifted[11] B[10]=term3_shifted[10]
+ B[9]=term3_shifted[9] B[8]=term3_shifted[8] B[7]=term3_shifted[7]
+ B[6]=term3_shifted[6] B[5]=term3_shifted[5] B[4]=term3_shifted[4]
+ B[3]=term3_shifted[3] B[2]=term3_shifted[2] B[1]=term3_shifted[1]
+ B[0]=term3_shifted[0] CI=net45637 DIFF[26]=N150 DIFF[25]=N149 DIFF[24]=N148
+ DIFF[23]=N147 DIFF[22]=N146 DIFF[21]=N145 DIFF[20]=N144 DIFF[19]=N143
+ DIFF[18]=N142 DIFF[17]=N141 DIFF[16]=N140 DIFF[15]=N139 DIFF[14]=N138
+ DIFF[13]=N137 DIFF[12]=N136 DIFF[11]=N135 DIFF[10]=N134 DIFF[9]=N133
+ DIFF[8]=N132 DIFF[7]=N131 DIFF[6]=N130 DIFF[5]=N129 DIFF[4]=N128 DIFF[3]=N127
+ DIFF[2]=N126 DIFF[1]=N125 DIFF[0]=N124
Xsub_28_2 PE_Shift_Add_7_DW01_sub_1_DW01_sub_22 $PINS A[26]=net45637
+ A[25]=net45637 A[24]=net45637 A[23]=net45637 A[22]=net45637 A[21]=net45637
+ A[20]=net45637 A[19]=net45637 A[18]=net45637 A[17]=net45637 A[16]=net45637
+ A[15]=net45637 A[14]=net45637 A[13]=net45637 A[12]=net45637 A[11]=net45637
+ A[10]=net45637 A[9]=net45637 A[8]=net45637 A[7]=net45637 A[6]=net45637
+ A[5]=net45637 A[4]=net45637 A[3]=net45637 A[2]=net45637 A[1]=net45637
+ A[0]=net45637 B[26]=term2_shifted[26] B[25]=term2_shifted[25]
+ B[24]=term2_shifted[24] B[23]=term2_shifted[23] B[22]=term2_shifted[22]
+ B[21]=term2_shifted[21] B[20]=term2_shifted[20] B[19]=term2_shifted[19]
+ B[18]=term2_shifted[18] B[17]=term2_shifted[17] B[16]=term2_shifted[16]
+ B[15]=term2_shifted[15] B[14]=term2_shifted[14] B[13]=term2_shifted[13]
+ B[12]=term2_shifted[12] B[11]=term2_shifted[11] B[10]=term2_shifted[10]
+ B[9]=term2_shifted[9] B[8]=term2_shifted[8] B[7]=term2_shifted[7]
+ B[6]=term2_shifted[6] B[5]=term2_shifted[5] B[4]=term2_shifted[4]
+ B[3]=term2_shifted[3] B[2]=n4 B[1]=term2_shifted[1] B[0]=term2_shifted[0]
+ CI=net45637 DIFF[26]=N95 DIFF[25]=N94 DIFF[24]=N93 DIFF[23]=N92 DIFF[22]=N91
+ DIFF[21]=N90 DIFF[20]=N89 DIFF[19]=N88 DIFF[18]=N87 DIFF[17]=N86 DIFF[16]=N85
+ DIFF[15]=N84 DIFF[14]=N83 DIFF[13]=N82 DIFF[12]=N81 DIFF[11]=N80 DIFF[10]=N79
+ DIFF[9]=N78 DIFF[8]=N77 DIFF[7]=N76 DIFF[6]=N75 DIFF[5]=N74 DIFF[4]=N73
+ DIFF[3]=N72 DIFF[2]=N71 DIFF[1]=N70 DIFF[0]=N69
Xsub_28 PE_Shift_Add_7_DW01_sub_2_DW01_sub_23 $PINS A[26]=net45637
+ A[25]=net45637 A[24]=net45637 A[23]=net45637 A[22]=net45637 A[21]=net45637
+ A[20]=net45637 A[19]=net45637 A[18]=net45637 A[17]=net45637 A[16]=net45637
+ A[15]=net45637 A[14]=net45637 A[13]=net45637 A[12]=net45637 A[11]=net45637
+ A[10]=net45637 A[9]=net45637 A[8]=net45637 A[7]=net45637 A[6]=net45637
+ A[5]=net45637 A[4]=net45637 A[3]=net45637 A[2]=net45637 A[1]=net45637
+ A[0]=net45637 B[26]=term1_shifted[26] B[25]=term1_shifted[25]
+ B[24]=term1_shifted[24] B[23]=term1_shifted[23] B[22]=term1_shifted[22]
+ B[21]=term1_shifted[21] B[20]=term1_shifted[20] B[19]=term1_shifted[19]
+ B[18]=term1_shifted[18] B[17]=term1_shifted[17] B[16]=term1_shifted[16]
+ B[15]=term1_shifted[15] B[14]=term1_shifted[14] B[13]=term1_shifted[13]
+ B[12]=term1_shifted[12] B[11]=term1_shifted[11] B[10]=term1_shifted[10]
+ B[9]=term1_shifted[9] B[8]=term1_shifted[8] B[7]=term1_shifted[7]
+ B[6]=term1_shifted[6] B[5]=term1_shifted[5] B[4]=term1_shifted[4]
+ B[3]=term1_shifted[3] B[2]=term1_shifted[2] B[1]=term1_shifted[1]
+ B[0]=term1_shifted[0] CI=net45637 DIFF[26]=N40 DIFF[25]=N39 DIFF[24]=N38
+ DIFF[23]=N37 DIFF[22]=N36 DIFF[21]=N35 DIFF[20]=N34 DIFF[19]=N33 DIFF[18]=N32
+ DIFF[17]=N31 DIFF[16]=N30 DIFF[15]=N29 DIFF[14]=N28 DIFF[13]=N27 DIFF[12]=N26
+ DIFF[11]=N25 DIFF[10]=N24 DIFF[9]=N23 DIFF[8]=N22 DIFF[7]=N21 DIFF[6]=N20
+ DIFF[5]=N19 DIFF[4]=N18 DIFF[3]=N17 DIFF[2]=N16 DIFF[1]=N15 DIFF[0]=N14
Xadd_1_root_add_0_root_add_28_3 PE_Shift_Add_7_DW01_add_2_DW01_add_37 $PINS
+ A[26]=N67 A[25]=N66 A[24]=N65 A[23]=N64 A[22]=N63 A[21]=N62 A[20]=N61 A[19]=N60
+ A[18]=N59 A[17]=N58 A[16]=N57 A[15]=N56 A[14]=N55 A[13]=N54 A[12]=N53 A[11]=N52
+ A[10]=N51 A[9]=N50 A[8]=N49 A[7]=N48 A[6]=N47 A[5]=N46 A[4]=N45 A[3]=N44
+ A[2]=N43 A[1]=N42 A[0]=N41 B[26]=N177 B[25]=N176 B[24]=N175 B[23]=N174
+ B[22]=N173 B[21]=N172 B[20]=N171 B[19]=N170 B[18]=N169 B[17]=N168 B[16]=N167
+ B[15]=N166 B[14]=N165 B[13]=N164 B[12]=N163 B[11]=N162 B[10]=N161 B[9]=N160
+ B[8]=N159 B[7]=N158 B[6]=N157 B[5]=N156 B[4]=N155 B[3]=N154 B[2]=N153 B[1]=N152
+ B[0]=N151 CI=net45637 SUM[26]=N204 SUM[25]=N203 SUM[24]=N202 SUM[23]=N201
+ SUM[22]=N200 SUM[21]=N199 SUM[20]=N198 SUM[19]=N197 SUM[18]=N196 SUM[17]=N195
+ SUM[16]=N194 SUM[15]=N193 SUM[14]=N192 SUM[13]=N191 SUM[12]=N190 SUM[11]=N189
+ SUM[10]=N188 SUM[9]=N187 SUM[8]=N186 SUM[7]=N185 SUM[6]=N184 SUM[5]=N183
+ SUM[4]=N182 SUM[3]=N181 SUM[2]=N180 SUM[1]=N179 SUM[0]=N178
Xadd_2_root_add_0_root_add_28_3 PE_Shift_Add_7_DW01_add_1_DW01_add_36 $PINS
+ A[26]=base_val[26] A[25]=base_val[25] A[24]=base_val[24] A[23]=base_val[23]
+ A[22]=base_val[22] A[21]=base_val[21] A[20]=base_val[20] A[19]=base_val[19]
+ A[18]=base_val[18] A[17]=base_val[17] A[16]=base_val[16] A[15]=base_val[15]
+ A[14]=base_val[14] A[13]=base_val[13] A[12]=base_val[12] A[11]=base_val[11]
+ A[10]=base_val[10] A[9]=base_val[9] A[8]=base_val[8] A[7]=base_val[7]
+ A[6]=base_val[6] A[5]=base_val[5] A[4]=base_val[4] A[3]=base_val[3]
+ A[2]=base_val[2] A[1]=base_val[1] A[0]=base_val[0] B[26]=N122 B[25]=N121
+ B[24]=N120 B[23]=N119 B[22]=N118 B[21]=N117 B[20]=N116 B[19]=N115 B[18]=N114
+ B[17]=N113 B[16]=N112 B[15]=N111 B[14]=N110 B[13]=N109 B[12]=N108 B[11]=N107
+ B[10]=N106 B[9]=N105 B[8]=N104 B[7]=N103 B[6]=N102 B[5]=N101 B[4]=N100 B[3]=N99
+ B[2]=N98 B[1]=N97 B[0]=N96 CI=net45637 SUM[26]=N231 SUM[25]=N230 SUM[24]=N229
+ SUM[23]=N228 SUM[22]=N227 SUM[21]=N226 SUM[20]=N225 SUM[19]=N224 SUM[18]=N223
+ SUM[17]=N222 SUM[16]=N221 SUM[15]=N220 SUM[14]=N219 SUM[13]=N218 SUM[12]=N217
+ SUM[11]=N216 SUM[10]=N215 SUM[9]=N214 SUM[8]=N213 SUM[7]=N212 SUM[6]=N211
+ SUM[5]=N210 SUM[4]=N209 SUM[3]=N208 SUM[2]=N207 SUM[1]=N206 SUM[0]=N205
Xadd_0_root_add_0_root_add_28_3 PE_Shift_Add_7_DW01_add_0_DW01_add_35 $PINS
+ A[26]=N204 A[25]=N203 A[24]=N202 A[23]=N201 A[22]=N200 A[21]=N199 A[20]=N198
+ A[19]=N197 A[18]=N196 A[17]=N195 A[16]=FE_OCPN1176_N194 A[15]=N193 A[14]=N192
+ A[13]=N191 A[12]=N190 A[11]=N189 A[10]=N188 A[9]=N187 A[8]=N186 A[7]=N185
+ A[6]=N184 A[5]=N183 A[4]=N182 A[3]=N181 A[2]=N180 A[1]=N179 A[0]=N178
+ B[26]=N231 B[25]=N230 B[24]=N229 B[23]=N228 B[22]=N227 B[21]=N226 B[20]=N225
+ B[19]=N224 B[18]=N223 B[17]=N222 B[16]=N221 B[15]=N220 B[14]=N219 B[13]=N218
+ B[12]=N217 B[11]=N216 B[10]=N215 B[9]=N214 B[8]=N213 B[7]=N212 B[6]=N211
+ B[5]=N210 B[4]=N209 B[3]=N208 B[2]=N207 B[1]=N206 B[0]=N205 CI=net45637
+ SUM[26]=next_acc[26] SUM[25]=next_acc[25] SUM[24]=next_acc[24]
+ SUM[23]=next_acc[23] SUM[22]=next_acc[22] SUM[21]=next_acc[21]
+ SUM[20]=next_acc[20] SUM[19]=next_acc[19] SUM[18]=next_acc[18]
+ SUM[17]=next_acc[17] SUM[16]=next_acc[16] SUM[15]=next_acc[15]
+ SUM[14]=next_acc[14] SUM[13]=next_acc[13] SUM[12]=next_acc[12]
+ SUM[11]=next_acc[11] SUM[10]=next_acc[10] SUM[9]=next_acc[9] SUM[8]=next_acc[8]
+ SUM[7]=next_acc[7] SUM[6]=next_acc[6] SUM[5]=next_acc[5] SUM[4]=next_acc[4]
+ SUM[3]=next_acc[3] SUM[2]=next_acc[2] SUM[1]=next_acc[1] SUM[0]=next_acc[0]
.ENDS

.SUBCKT SNPS_CLOCK_GATE_HIGH_PE_Shift_Add_6 EN ENCLK CLK
*.CONNECT ENCLK net2300
*.CONNECT net2301 EN
XFE_PHC1316_net2304 DELC $PINS O=FE_PHN1316_net2304 I=net2304
Xlatch QDBHN $PINS Q=net2304 D=net2301 CKB=CLK
Xmain_gate AN2T $PINS O=net2300 I1=FE_PHN1316_net2304 I2=CLK
.ENDS

.SUBCKT PE_Shift_Add_6_DW01_sub_0_DW01_sub_18 A[26] A[25] A[24] A[23] A[22]
+ A[21] A[20] A[19] A[18] A[17] A[16] A[15] A[14] A[13] A[12] A[11] A[10] A[9]
+ A[8] A[7] A[6] A[5] A[4] A[3] A[2] A[1] A[0] B[26] B[25] B[24] B[23] B[22]
+ B[21] B[20] B[19] B[18] B[17] B[16] B[15] B[14] B[13] B[12] B[11] B[10] B[9]
+ B[8] B[7] B[6] B[5] B[4] B[3] B[2] B[1] B[0] CI DIFF[26] DIFF[25] DIFF[24]
+ DIFF[23] DIFF[22] DIFF[21] DIFF[20] DIFF[19] DIFF[18] DIFF[17] DIFF[16]
+ DIFF[15] DIFF[14] DIFF[13] DIFF[12] DIFF[11] DIFF[10] DIFF[9] DIFF[8] DIFF[7]
+ DIFF[6] DIFF[5] DIFF[4] DIFF[3] DIFF[2] DIFF[1] DIFF[0] CO p1
*.CONNECT DIFF[0] B[0]
XFE_RC_190_0 INV1S $PINS O=FE_RN_87_0 I=n33
XFE_RC_189_0 MXL2HS $PINS OB=DIFF[19] S=n14 A=FE_RN_87_0 B=n33
XFE_RC_3875_0 XOR2HS $PINS O=DIFF[2] I1=n1 I2=n50
XFE_RC_3761_0 INV1S $PINS O=FE_RN_2471_0 I=n44
XFE_RC_3760_0 MXL2HS $PINS OB=DIFF[8] S=n24 A=FE_RN_2471_0 B=n44
XFE_OFC758_term3_shifted_2 INV2 $PINS O=n50 I=B[2]
XU3 NR2 $PINS O=n1 I1=p1 I2=B[0]
XU4 INV2 $PINS O=n51 I=B[0]
XU5 INV1S $PINS O=n47 I=B[5]
XU8 INV2 $PINS O=n48 I=B[4]
XU9 XNR2HS $PINS O=DIFF[1] I1=n51 I2=B[1]
XU10 AN2 $PINS O=n2 I1=n50 I2=n1
XU11 AN2 $PINS O=n3 I1=n49 I2=n2
XU12 AN2 $PINS O=n4 I1=n44 I2=n24
XU13 AN2 $PINS O=n5 I1=n43 I2=n4
XU14 AN2 $PINS O=n6 I1=n42 I2=n5
XU15 AN2 $PINS O=n7 I1=n41 I2=n6
XU16 AN2 $PINS O=n8 I1=n40 I2=n7
XU17 AN2 $PINS O=n9 I1=n39 I2=n8
XU18 AN2 $PINS O=n10 I1=n38 I2=n9
XU19 AN2 $PINS O=n11 I1=n37 I2=n10
XU20 AN2 $PINS O=n12 I1=n36 I2=n11
XU21 AN2 $PINS O=n13 I1=n35 I2=n12
XU22 AN2 $PINS O=n14 I1=n34 I2=n13
XU23 AN2 $PINS O=n15 I1=n33 I2=n14
XU24 AN2 $PINS O=n16 I1=n32 I2=n15
XU25 AN2 $PINS O=n17 I1=n31 I2=n16
XU26 AN2 $PINS O=n18 I1=n30 I2=n17
XU27 AN2 $PINS O=n19 I1=n29 I2=n18
XU28 AN2 $PINS O=n20 I1=n28 I2=n19
XU29 AN2T $PINS O=n21 I1=n48 I2=n3
XU30 AN2T $PINS O=n22 I1=n47 I2=n21
XU31 AN2 $PINS O=n23 I1=n46 I2=n22
XU32 AN2 $PINS O=n24 I1=n45 I2=n23
XU33 INV1S $PINS O=n44 I=B[8]
XU34 INV1S $PINS O=n43 I=B[9]
XU35 INV1S $PINS O=n42 I=B[10]
XU36 INV1S $PINS O=n41 I=B[11]
XU37 XOR2HS $PINS O=DIFF[26] I1=B[26] I2=n26
XU38 INV1S $PINS O=n40 I=B[12]
XU39 INV1S $PINS O=n39 I=B[13]
XU40 INV1S $PINS O=n38 I=B[14]
XU41 INV1S $PINS O=n37 I=B[15]
XU42 INV1S $PINS O=n36 I=B[16]
XU43 INV1S $PINS O=n35 I=B[17]
XU44 INV1S $PINS O=n34 I=B[18]
XU45 INV1S $PINS O=n33 I=B[19]
XU46 INV1S $PINS O=n32 I=B[20]
XU47 INV1S $PINS O=n31 I=B[21]
XU48 INV1S $PINS O=n30 I=B[22]
XU49 INV1S $PINS O=n29 I=B[23]
XU50 INV1S $PINS O=n28 I=B[24]
XU51 INV1S $PINS O=n27 I=B[25]
XU52 INV1S $PINS O=n46 I=B[6]
XU53 INV1S $PINS O=n45 I=B[7]
XU54 XOR2HS $PINS O=DIFF[12] I1=n40 I2=n7
XU55 XOR2HS $PINS O=DIFF[13] I1=n39 I2=n8
XU56 XOR2HS $PINS O=DIFF[14] I1=n38 I2=n9
XU57 XOR2HS $PINS O=DIFF[15] I1=n37 I2=n10
XU58 XOR2HS $PINS O=DIFF[16] I1=n36 I2=n11
XU59 XOR2HS $PINS O=DIFF[11] I1=n41 I2=n6
XU60 XOR2HS $PINS O=DIFF[17] I1=n35 I2=n12
XU61 XOR2HS $PINS O=DIFF[18] I1=n34 I2=n13
XU63 XOR2HS $PINS O=DIFF[20] I1=n32 I2=n15
XU64 XOR2HS $PINS O=DIFF[21] I1=n31 I2=n16
XU65 XOR2HS $PINS O=DIFF[10] I1=n42 I2=n5
XU66 XOR2HS $PINS O=DIFF[22] I1=n30 I2=n17
XU67 XOR2HS $PINS O=DIFF[23] I1=n29 I2=n18
XU68 XOR2HS $PINS O=DIFF[9] I1=n43 I2=n4
XU69 XOR2HS $PINS O=DIFF[7] I1=n45 I2=n23
XU71 XOR2HS $PINS O=DIFF[24] I1=n28 I2=n19
XU72 XOR2HS $PINS O=DIFF[6] I1=n46 I2=n22
XU73 XOR2HS $PINS O=DIFF[3] I1=n49 I2=n2
XU74 XOR2HS $PINS O=DIFF[4] I1=n3 I2=n48
XU75 XOR2HS $PINS O=DIFF[5] I1=n47 I2=n21
XU76 XOR2HS $PINS O=DIFF[25] I1=n27 I2=n20
XU77 ND2 $PINS O=n26 I1=n27 I2=n20
XU7 INV2 $PINS O=n49 I=B[3]
.ENDS

.SUBCKT PE_Shift_Add_6_DW01_sub_1_DW01_sub_19 A[26] A[25] A[24] A[23] A[22]
+ A[21] A[20] A[19] A[18] A[17] A[16] A[15] A[14] A[13] A[12] A[11] A[10] A[9]
+ A[8] A[7] A[6] A[5] A[4] A[3] A[2] A[1] A[0] B[26] B[25] B[24] B[23] B[22]
+ B[21] B[20] B[19] B[18] B[17] B[16] B[15] B[14] B[13] B[12] B[11] B[10] B[9]
+ B[8] B[7] B[6] B[5] B[4] B[3] B[2] B[1] B[0] CI DIFF[26] DIFF[25] DIFF[24]
+ DIFF[23] DIFF[22] DIFF[21] DIFF[20] DIFF[19] DIFF[18] DIFF[17] DIFF[16]
+ DIFF[15] DIFF[14] DIFF[13] DIFF[12] DIFF[11] DIFF[10] DIFF[9] DIFF[8] DIFF[7]
+ DIFF[6] DIFF[5] DIFF[4] DIFF[3] DIFF[2] DIFF[1] DIFF[0] CO
XFE_RC_34_0 XOR2HS $PINS O=DIFF[4] I1=n4 I2=n49
XFE_RC_422_0 INV1S $PINS O=FE_RN_117_0 I=n53
XFE_RC_421_0 MXL2HS $PINS OB=DIFF[1] S=n52 A=FE_RN_117_0 B=n53
XFE_OFC621_term2_shifted_0 INV1S $PINS O=n53 I=B[0]
XU3 NR2 $PINS O=n9 I1=B[1] I2=B[0]
XU4 NR2P $PINS O=n4 I1=B[3] I2=n1
XU5 INV1S $PINS O=n1 I=n3
XU6 XOR2HS $PINS O=DIFF[2] I1=n9 I2=B[2]
XU9 INV1S $PINS O=n50 I=B[3]
XU10 INV2 $PINS O=n49 I=B[4]
XU11 AN2 $PINS O=n2 I1=n48 I2=n6
XU13 INV1S $PINS O=n47 I=B[6]
XU14 INV1S $PINS O=n48 I=B[5]
XU16 AN2 $PINS O=n3 I1=B[2] I2=n9
XU17 AN2 $PINS O=n5 I1=n47 I2=n2
XU18 AN2 $PINS O=n6 I1=n49 I2=n4
XU19 AN2 $PINS O=n7 I1=n46 I2=n5
XU20 AN2 $PINS O=n10 I1=n45 I2=n7
XU21 AN2 $PINS O=n11 I1=n44 I2=n10
XU22 AN2 $PINS O=n12 I1=n43 I2=n11
XU23 AN2 $PINS O=n13 I1=n42 I2=n12
XU24 AN2 $PINS O=n14 I1=n41 I2=n13
XU25 AN2 $PINS O=n15 I1=n40 I2=n14
XU26 AN2 $PINS O=n16 I1=n39 I2=n15
XU27 AN2 $PINS O=n17 I1=n38 I2=n16
XU28 AN2 $PINS O=n18 I1=n37 I2=n17
XU29 AN2 $PINS O=n19 I1=n36 I2=n18
XU30 AN2T $PINS O=n20 I1=n35 I2=n19
XU31 AN2T $PINS O=n21 I1=n34 I2=n20
XU32 AN2 $PINS O=n22 I1=n33 I2=n21
XU33 AN2 $PINS O=n23 I1=n32 I2=n22
XU34 AN2 $PINS O=n24 I1=n31 I2=n23
XU35 AN2 $PINS O=n25 I1=n30 I2=n24
XU36 AN2 $PINS O=n26 I1=n29 I2=n25
XU37 INV1S $PINS O=n45 I=B[8]
XU38 INV1S $PINS O=n44 I=B[9]
XU39 INV1S $PINS O=n43 I=B[10]
XU40 INV1S $PINS O=n42 I=B[11]
XU41 INV1S $PINS O=n41 I=B[12]
XU42 INV1S $PINS O=n40 I=B[13]
XU43 INV1S $PINS O=n39 I=B[14]
XU44 INV1S $PINS O=n38 I=B[15]
XU45 INV1S $PINS O=n37 I=B[16]
XU46 INV1S $PINS O=n36 I=B[17]
XU47 INV1S $PINS O=n35 I=B[18]
XU48 INV1S $PINS O=n34 I=B[19]
XU49 INV1S $PINS O=n33 I=B[20]
XU50 INV1S $PINS O=n32 I=B[21]
XU51 INV1S $PINS O=n31 I=B[22]
XU52 INV1S $PINS O=n30 I=B[23]
XU53 INV1S $PINS O=n29 I=B[24]
XU54 INV1S $PINS O=n28 I=B[25]
XU55 INV1S $PINS O=n46 I=B[7]
XU56 XOR2HS $PINS O=DIFF[26] I1=B[26] I2=n27
XU57 XOR2HS $PINS O=DIFF[9] I1=n44 I2=n10
XU58 XOR2HS $PINS O=DIFF[10] I1=n43 I2=n11
XU59 XOR2HS $PINS O=DIFF[12] I1=n41 I2=n13
XU60 XOR2HS $PINS O=DIFF[13] I1=n40 I2=n14
XU61 XOR2HS $PINS O=DIFF[14] I1=n39 I2=n15
XU62 XOR2HS $PINS O=DIFF[15] I1=n38 I2=n16
XU63 XOR2HS $PINS O=DIFF[11] I1=n42 I2=n12
XU64 XOR2HS $PINS O=DIFF[16] I1=n37 I2=n17
XU65 XOR2HS $PINS O=DIFF[17] I1=n36 I2=n18
XU66 XOR2HS $PINS O=DIFF[18] I1=n35 I2=n19
XU67 XOR2HS $PINS O=DIFF[8] I1=n45 I2=n7
XU68 XOR2HS $PINS O=DIFF[7] I1=n46 I2=n5
XU69 XOR2HS $PINS O=DIFF[19] I1=n34 I2=n20
XU70 XOR2HS $PINS O=DIFF[20] I1=n33 I2=n21
XU71 XOR2HS $PINS O=DIFF[6] I1=n47 I2=n2
XU72 XOR2HS $PINS O=DIFF[21] I1=n32 I2=n22
XU73 XOR2HS $PINS O=DIFF[5] I1=n48 I2=n6
XU74 XOR2HS $PINS O=DIFF[22] I1=n31 I2=n23
XU75 XOR2HS $PINS O=DIFF[23] I1=n30 I2=n24
XU76 XOR2HS $PINS O=DIFF[24] I1=n29 I2=n25
XU77 XOR2HS $PINS O=DIFF[3] I1=n50 I2=n3
XU78 XOR2HS $PINS O=DIFF[25] I1=n28 I2=n26
XU79 ND2 $PINS O=n27 I1=n28 I2=n26
XU1 INV1S $PINS O=n52 I=B[1]
.ENDS

.SUBCKT PE_Shift_Add_6_DW01_sub_2_DW01_sub_20 A[26] A[25] A[24] A[23] A[22]
+ A[21] A[20] A[19] A[18] A[17] A[16] A[15] A[14] A[13] A[12] A[11] A[10] A[9]
+ A[8] A[7] A[6] A[5] A[4] A[3] A[2] A[1] A[0] B[26] B[25] B[24] B[23] B[22]
+ B[21] B[20] B[19] B[18] B[17] B[16] B[15] B[14] B[13] B[12] B[11] B[10] B[9]
+ B[8] B[7] B[6] B[5] B[4] B[3] B[2] B[1] B[0] CI DIFF[26] DIFF[25] DIFF[24]
+ DIFF[23] DIFF[22] DIFF[21] DIFF[20] DIFF[19] DIFF[18] DIFF[17] DIFF[16]
+ DIFF[15] DIFF[14] DIFF[13] DIFF[12] DIFF[11] DIFF[10] DIFF[9] DIFF[8] DIFF[7]
+ DIFF[6] DIFF[5] DIFF[4] DIFF[3] DIFF[2] DIFF[1] DIFF[0] CO
XFE_RC_3947_0 INV1S $PINS O=FE_RN_2567_0 I=n33
XFE_RC_3946_0 MXL2HS $PINS OB=DIFF[20] S=n16 A=FE_RN_2567_0 B=n33
XFE_RC_3703_0 INV1S $PINS O=FE_RN_2433_0 I=n38
XFE_RC_3702_0 MXL2HS $PINS OB=DIFF[15] S=n11 A=FE_RN_2433_0 B=n38
XFE_RC_3079_0 XOR2HS $PINS O=DIFF[1] I1=DIFF[0] I2=n52
XFE_OFC788_term1_shifted_10 INV1S $PINS O=n43 I=B[10]
XFE_OFC753_term1_shifted_8 INV1S $PINS O=n45 I=B[8]
XFE_DBTC18_N14 INV1S $PINS O=DIFF[0] I=B[0]
XU1 OR2B1S $PINS O=n1 I1=B[3] B1=n3
XU2 INV2 $PINS O=n4 I=n1
XU3 NR2 $PINS O=n2 I1=B[1] I2=B[0]
XU4 XOR2HS $PINS O=DIFF[2] I1=n51 I2=n2
XU5 INV2 $PINS O=n52 I=B[1]
XU6 INV1S $PINS O=n50 I=B[3]
XU8 INV2 $PINS O=n51 I=B[2]
XU9 INV1S $PINS O=n48 I=B[5]
XU12 INV1S $PINS O=n49 I=B[4]
XU13 INV1S $PINS O=n47 I=B[6]
XU14 INV1S $PINS O=n46 I=B[7]
XU15 XOR2HS $PINS O=DIFF[3] I1=n50 I2=n3
XU16 AN2 $PINS O=n3 I1=n51 I2=n2
XU17 XOR2HS $PINS O=DIFF[8] I1=n45 I2=n25
XU18 XOR2HS $PINS O=DIFF[9] I1=n44 I2=n5
XU19 AN2 $PINS O=n5 I1=n45 I2=n25
XU20 XOR2HS $PINS O=DIFF[10] I1=n43 I2=n6
XU21 AN2 $PINS O=n6 I1=n44 I2=n5
XU22 XOR2HS $PINS O=DIFF[11] I1=n42 I2=n7
XU23 AN2 $PINS O=n7 I1=n43 I2=n6
XU24 XOR2HS $PINS O=DIFF[12] I1=n41 I2=n8
XU25 AN2 $PINS O=n8 I1=n42 I2=n7
XU26 XOR2HS $PINS O=DIFF[13] I1=n40 I2=n9
XU27 AN2 $PINS O=n9 I1=n41 I2=n8
XU28 XOR2HS $PINS O=DIFF[14] I1=n39 I2=n10
XU29 AN2 $PINS O=n10 I1=n40 I2=n9
XU31 AN2 $PINS O=n11 I1=n39 I2=n10
XU32 XOR2HS $PINS O=DIFF[16] I1=n37 I2=n12
XU33 AN2 $PINS O=n12 I1=n38 I2=n11
XU34 XOR2HS $PINS O=DIFF[17] I1=n36 I2=n13
XU35 AN2 $PINS O=n13 I1=n37 I2=n12
XU36 XOR2HS $PINS O=DIFF[18] I1=n35 I2=n14
XU37 AN2 $PINS O=n14 I1=n36 I2=n13
XU38 XOR2HS $PINS O=DIFF[19] I1=n34 I2=n15
XU39 AN2 $PINS O=n15 I1=n35 I2=n14
XU41 AN2 $PINS O=n16 I1=n34 I2=n15
XU42 XOR2HS $PINS O=DIFF[21] I1=n32 I2=n17
XU43 AN2 $PINS O=n17 I1=n33 I2=n16
XU44 XOR2HS $PINS O=DIFF[22] I1=n31 I2=n18
XU45 AN2 $PINS O=n18 I1=n32 I2=n17
XU46 XOR2HS $PINS O=DIFF[23] I1=n30 I2=n19
XU47 AN2 $PINS O=n19 I1=n31 I2=n18
XU48 XOR2HS $PINS O=DIFF[24] I1=n29 I2=n20
XU49 AN2 $PINS O=n20 I1=n30 I2=n19
XU50 AN2 $PINS O=n21 I1=n29 I2=n20
XU51 XOR2HS $PINS O=DIFF[25] I1=n28 I2=n21
XU52 XOR2HS $PINS O=DIFF[4] I1=n49 I2=n4
XU53 XOR2HS $PINS O=DIFF[5] I1=n48 I2=n22
XU54 AN2T $PINS O=n22 I1=n49 I2=n4
XU55 XOR2HS $PINS O=DIFF[6] I1=n47 I2=n23
XU56 AN2T $PINS O=n23 I1=n48 I2=n22
XU57 XOR2HS $PINS O=DIFF[7] I1=n46 I2=n24
XU58 AN2T $PINS O=n24 I1=n47 I2=n23
XU59 AN2T $PINS O=n25 I1=n46 I2=n24
XU61 INV1S $PINS O=n44 I=B[9]
XU63 INV1S $PINS O=n42 I=B[11]
XU64 INV1S $PINS O=n41 I=B[12]
XU65 INV1S $PINS O=n40 I=B[13]
XU66 INV1S $PINS O=n39 I=B[14]
XU67 INV1S $PINS O=n38 I=B[15]
XU68 INV1S $PINS O=n37 I=B[16]
XU69 INV1S $PINS O=n36 I=B[17]
XU70 INV1S $PINS O=n35 I=B[18]
XU71 INV1S $PINS O=n34 I=B[19]
XU72 INV1S $PINS O=n33 I=B[20]
XU73 INV1S $PINS O=n32 I=B[21]
XU74 INV1S $PINS O=n31 I=B[22]
XU75 INV1S $PINS O=n30 I=B[23]
XU76 INV1S $PINS O=n29 I=B[24]
XU77 INV1S $PINS O=n28 I=B[25]
XU78 XOR2HS $PINS O=DIFF[26] I1=B[26] I2=n27
XU79 ND2 $PINS O=n27 I1=n28 I2=n21
.ENDS

.SUBCKT PE_Shift_Add_6_DW01_add_2_DW01_add_25 A[26] A[25] A[24] A[23] A[22]
+ A[21] A[20] A[19] A[18] A[17] A[16] A[15] A[14] A[13] A[12] A[11] A[10] A[9]
+ A[8] A[7] A[6] A[5] A[4] A[3] A[2] A[1] A[0] B[26] B[25] B[24] B[23] B[22]
+ B[21] B[20] B[19] B[18] B[17] B[16] B[15] B[14] B[13] B[12] B[11] B[10] B[9]
+ B[8] B[7] B[6] B[5] B[4] B[3] B[2] B[1] B[0] CI SUM[26] SUM[25] SUM[24]
+ SUM[23] SUM[22] SUM[21] SUM[20] SUM[19] SUM[18] SUM[17] SUM[16] SUM[15]
+ SUM[14] SUM[13] SUM[12] SUM[11] SUM[10] SUM[9] SUM[8] SUM[7] SUM[6] SUM[5]
+ SUM[4] SUM[3] SUM[2] SUM[1] SUM[0] CO
XFE_RC_265_0 XOR3 $PINS O=SUM[1] I1=B[1] I2=A[1] I3=carry[1]
XFE_RC_264_0 MAO222 $PINS O=carry[2] A1=B[1] B1=A[1] C1=carry[1]
XFE_RC_120_0 ND3P $PINS O=carry[6] I1=n12 I2=n11 I3=n13
XFE_RC_68_0 MOAI1H $PINS O=carry[20] A1=FE_RN_1291_0 A2=FE_RN_1293_0 B1=B[19]
+ B2=A[19]
XFE_OCPC1230_carry_17 BUF2 $PINS O=FE_OCPN1230_carry_17 I=carry[17]
XFE_OCPC1225_carry_5 BUF1S $PINS O=FE_OCPN1225_carry_5 I=carry[5]
XFE_OCPC1205_carry_11 BUF1CK $PINS O=FE_OCPN1205_carry_11 I=carry[11]
XFE_OCPC1195_carry_14 BUF1 $PINS O=FE_OCPN1195_carry_14 I=carry[14]
XFE_OCPC1126_carry_16 BUF1 $PINS O=FE_OCPN1126_carry_16 I=carry[16]
XFE_OCPC1074_carry_20 BUF1 $PINS O=FE_OCPN1074_carry_20 I=carry[20]
XFE_OCPC1008_carry_6 BUF1S $PINS O=FE_OCPN1008_carry_6 I=carry[6]
XFE_RC_3945_0 XOR3 $PINS O=SUM[23] I1=A[23] I2=B[23] I3=carry[23]
XFE_RC_3944_0 MAO222P $PINS O=carry[24] A1=A[23] B1=B[23] C1=carry[23]
XFE_RC_3941_0 ND3P $PINS O=carry[25] I1=n7 I2=n6 I3=n8
XFE_RC_3764_0 ND3P $PINS O=carry[3] I1=FE_RN_2359_0 I2=FE_RN_2358_0
+ I3=FE_RN_2357_0
XFE_RC_3610_0 ND2 $PINS O=FE_RN_2357_0 I1=B[2] I2=A[2]
XFE_RC_3609_0 ND2 $PINS O=FE_RN_2358_0 I1=carry[2] I2=A[2]
XFE_RC_3608_0 ND2 $PINS O=FE_RN_2359_0 I1=carry[2] I2=B[2]
XFE_RC_3553_0 OAI12H $PINS O=carry[21] A1=FE_RN_2148_0 B1=FE_RN_2145_0
+ B2=FE_RN_2146_0
XFE_RC_3519_0 XOR2H $PINS O=SUM[16] I1=FE_RN_778_0 I2=FE_OCPN1126_carry_16
XFE_RC_3515_0 OR2 $PINS O=FE_RN_2296_0 I1=FE_RN_360_0 I2=FE_RN_359_0
XFE_RC_3514_0 ND2P $PINS O=carry[15] I1=FE_RN_363_0 I2=FE_RN_2296_0
XFE_RC_3454_0 OR2 $PINS O=FE_RN_2253_0 I1=A[18] I2=B[18]
XFE_RC_3453_0 ND2 $PINS O=FE_RN_1461_0 I1=carry[18] I2=FE_RN_2253_0
XFE_RC_3312_0 ND2 $PINS O=FE_RN_2140_0 I1=A[20] I2=B[20]
XFE_RC_3311_0 ND2 $PINS O=FE_RN_2141_0 I1=FE_RN_2140_0 I2=FE_RN_2147_0
XFE_RC_3310_0 ND2 $PINS O=FE_RN_2142_0 I1=FE_RN_2141_0 I2=FE_OCPN1074_carry_20
XFE_RC_3309_0 XOR2HS $PINS O=FE_RN_2143_0 I1=B[20] I2=A[20]
XFE_RC_3308_0 OR2B1S $PINS O=FE_RN_2144_0 I1=FE_OCPN1074_carry_20
+ B1=FE_RN_2143_0
XFE_RC_3307_0 ND2 $PINS O=SUM[20] I1=FE_RN_2144_0 I2=FE_RN_2142_0
XFE_RC_3306_0 INV1S $PINS O=FE_RN_2145_0 I=B[20]
XFE_RC_3305_0 INV1S $PINS O=FE_RN_2146_0 I=A[20]
XFE_RC_3304_0 OR2T $PINS O=FE_RN_2147_0 I1=B[20] I2=A[20]
XFE_RC_3303_0 ND2P $PINS O=FE_RN_2148_0 I1=FE_RN_2147_0 I2=carry[20]
XFE_RC_3082_0 ND2 $PINS O=FE_RN_1985_0 I1=carry[11] I2=B[11]
XFE_RC_3081_0 AOI22H $PINS O=FE_RN_1986_0 A1=B[11] A2=A[11] B1=carry[11]
+ B2=A[11]
XFE_RC_3080_0 ND2P $PINS O=carry[12] I1=FE_RN_1986_0 I2=FE_RN_1985_0
XFE_RC_2874_0 INV1S $PINS O=FE_RN_1835_0 I=FE_RN_1155_0
XFE_RC_2873_0 OR2B1 $PINS O=FE_RN_1836_0 I1=FE_RN_1154_0 B1=FE_RN_1835_0
XFE_RC_2872_0 ND2P $PINS O=carry[18] I1=FE_RN_1158_0 I2=FE_RN_1836_0
XFE_RC_2364_0 XOR2HS $PINS O=FE_RN_1459_0 I1=B[18] I2=A[18]
XFE_RC_2363_0 XOR2HS $PINS O=SUM[18] I1=carry[18] I2=FE_RN_1459_0
XFE_RC_2362_0 ND2 $PINS O=FE_RN_1460_0 I1=A[18] I2=B[18]
XFE_RC_2360_0 ND2P $PINS O=carry[19] I1=FE_RN_1461_0 I2=FE_RN_1460_0
XFE_RC_2133_0 INV1S $PINS O=FE_RN_1288_0 I=FE_RN_1292_0
XFE_RC_2132_0 AOI12HS $PINS O=FE_RN_1289_0 A1=FE_RN_1288_0 B1=A[19] B2=B[19]
XFE_RC_2131_0 XNR2HS $PINS O=FE_RN_1290_0 I1=B[19] I2=A[19]
XFE_RC_2130_0 MXL2HS $PINS OB=SUM[19] S=carry[19] A=FE_RN_1290_0 B=FE_RN_1289_0
XFE_RC_2129_0 INV2CK $PINS O=FE_RN_1291_0 I=carry[19]
XFE_RC_2128_0 OR2T $PINS O=FE_RN_1292_0 I1=A[19] I2=B[19]
XFE_RC_2127_0 INV2 $PINS O=FE_RN_1293_0 I=FE_RN_1292_0
XFE_RC_2012_0 ND2 $PINS O=FE_RN_1199_0 I1=carry[10] I2=B[10]
XFE_RC_2011_0 AOI22H $PINS O=FE_RN_1200_0 A1=B[10] A2=A[10] B1=carry[10]
+ B2=A[10]
XFE_RC_2010_0 ND2P $PINS O=carry[11] I1=FE_RN_1200_0 I2=FE_RN_1199_0
XFE_RC_1952_0 XOR2HS $PINS O=FE_RN_1153_0 I1=B[17] I2=A[17]
XFE_RC_1951_0 XOR2HS $PINS O=SUM[17] I1=FE_OCPN1230_carry_17 I2=FE_RN_1153_0
XFE_RC_1950_0 INV1S $PINS O=FE_RN_1154_0 I=B[17]
XFE_RC_1949_0 INV1S $PINS O=FE_RN_1155_0 I=A[17]
XFE_RC_1947_0 OR2B1S $PINS O=FE_RN_1157_0 I1=B[17] B1=FE_RN_1155_0
XFE_RC_1946_0 ND2P $PINS O=FE_RN_1158_0 I1=carry[17] I2=FE_RN_1157_0
XFE_RC_1879_0 OAI12H $PINS O=FE_RN_780_0 A1=carry[16] B1=B[16] B2=A[16]
XFE_RC_1476_0 INV1S $PINS O=FE_RN_794_0 I=FE_RN_621_0
XFE_RC_1475_0 OR2B1 $PINS O=FE_RN_795_0 I1=FE_RN_620_0 B1=FE_RN_794_0
XFE_RC_1474_0 ND2P $PINS O=carry[13] I1=FE_RN_624_0 I2=FE_RN_795_0
XFE_RC_1457_0 XOR2HS $PINS O=FE_RN_778_0 I1=B[16] I2=A[16]
XFE_RC_1455_0 ND2 $PINS O=FE_RN_779_0 I1=A[16] I2=B[16]
XFE_RC_1453_0 ND2P $PINS O=carry[17] I1=FE_RN_780_0 I2=FE_RN_779_0
XFE_RC_1252_0 INV1S $PINS O=FE_RN_614_0 I=carry[12]
XFE_RC_1251_0 XOR2HS $PINS O=FE_RN_615_0 I1=B[12] I2=A[12]
XFE_RC_1250_0 ND2 $PINS O=FE_RN_616_0 I1=FE_RN_615_0 I2=FE_RN_614_0
XFE_RC_1249_0 ND2 $PINS O=FE_RN_617_0 I1=A[12] I2=B[12]
XFE_RC_1248_0 ND2S $PINS O=FE_RN_618_0 I1=FE_RN_617_0 I2=FE_RN_623_0
XFE_RC_1247_0 ND2 $PINS O=FE_RN_619_0 I1=FE_RN_618_0 I2=carry[12]
XFE_RC_1246_0 ND2 $PINS O=SUM[12] I1=FE_RN_619_0 I2=FE_RN_616_0
XFE_RC_1245_0 INV1S $PINS O=FE_RN_620_0 I=B[12]
XFE_RC_1244_0 INV1S $PINS O=FE_RN_621_0 I=A[12]
XFE_RC_1242_0 OR2B1S $PINS O=FE_RN_623_0 I1=B[12] B1=FE_RN_621_0
XFE_RC_1241_0 ND2 $PINS O=FE_RN_624_0 I1=FE_RN_623_0 I2=carry[12]
XFE_RC_1156_0 INV1S $PINS O=FE_RN_547_0 I=FE_RN_491_0
XFE_RC_1155_0 OR2B1S $PINS O=FE_RN_548_0 I1=FE_RN_490_0 B1=FE_RN_547_0
XFE_RC_1154_0 ND2P $PINS O=carry[14] I1=FE_RN_494_0 I2=FE_RN_548_0
XFE_RC_1075_0 INV1S $PINS O=FE_RN_484_0 I=carry[13]
XFE_RC_1074_0 XOR2HS $PINS O=FE_RN_485_0 I1=B[13] I2=A[13]
XFE_RC_1073_0 ND2S $PINS O=FE_RN_486_0 I1=FE_RN_485_0 I2=FE_RN_484_0
XFE_RC_1072_0 ND2 $PINS O=FE_RN_487_0 I1=A[13] I2=B[13]
XFE_RC_1071_0 ND2S $PINS O=FE_RN_488_0 I1=FE_RN_487_0 I2=FE_RN_493_0
XFE_RC_1070_0 ND2 $PINS O=FE_RN_489_0 I1=FE_RN_488_0 I2=carry[13]
XFE_RC_1069_0 ND2P $PINS O=SUM[13] I1=FE_RN_489_0 I2=FE_RN_486_0
XFE_RC_1068_0 INV1S $PINS O=FE_RN_490_0 I=B[13]
XFE_RC_1067_0 INV1S $PINS O=FE_RN_491_0 I=A[13]
XFE_RC_1065_0 OR2B1S $PINS O=FE_RN_493_0 I1=B[13] B1=FE_RN_491_0
XFE_RC_1064_0 ND2 $PINS O=FE_RN_494_0 I1=FE_RN_493_0 I2=carry[13]
XFE_RC_903_0 INV1S $PINS O=FE_RN_353_0 I=carry[14]
XFE_RC_902_0 XOR2HS $PINS O=FE_RN_354_0 I1=B[14] I2=A[14]
XFE_RC_901_0 ND2 $PINS O=FE_RN_355_0 I1=FE_RN_354_0 I2=FE_RN_353_0
XFE_RC_900_0 ND2 $PINS O=FE_RN_356_0 I1=A[14] I2=B[14]
XFE_RC_899_0 ND2S $PINS O=FE_RN_357_0 I1=FE_RN_356_0 I2=FE_RN_362_0
XFE_RC_898_0 ND2 $PINS O=FE_RN_358_0 I1=FE_RN_357_0 I2=FE_OCPN1195_carry_14
XFE_RC_897_0 ND2T $PINS O=SUM[14] I1=FE_RN_358_0 I2=FE_RN_355_0
XFE_RC_896_0 INV1S $PINS O=FE_RN_359_0 I=B[14]
XFE_RC_895_0 INV1S $PINS O=FE_RN_360_0 I=A[14]
XFE_RC_893_0 OR2B1S $PINS O=FE_RN_362_0 I1=B[14] B1=FE_RN_360_0
XFE_RC_892_0 ND2 $PINS O=FE_RN_363_0 I1=FE_RN_362_0 I2=carry[14]
XFE_RC_739_0 XOR3 $PINS O=SUM[11] I1=A[11] I2=B[11] I3=FE_OCPN1205_carry_11
XFE_RC_683_0 XOR3 $PINS O=SUM[2] I1=A[2] I2=B[2] I3=carry[2]
XFE_RC_596_0 ND2 $PINS O=FE_RN_176_0 I1=carry[6] I2=B[6]
XFE_RC_595_0 AOI22H $PINS O=FE_RN_177_0 A1=B[6] A2=A[6] B1=carry[6] B2=A[6]
XFE_RC_594_0 ND2P $PINS O=carry[7] I1=FE_RN_177_0 I2=FE_RN_176_0
XFE_RC_591_0 XOR3 $PINS O=SUM[10] I1=A[10] I2=B[10] I3=carry[10]
XFE_RC_456_0 XOR3 $PINS O=SUM[3] I1=A[3] I2=B[3] I3=carry[3]
XFE_RC_455_0 MAO222 $PINS O=carry[4] A1=A[3] B1=B[3] C1=carry[3]
XFE_RC_448_0 XOR3 $PINS O=SUM[6] I1=A[6] I2=B[6] I3=FE_OCPN1008_carry_6
XFE_RC_358_0 XOR3 $PINS O=SUM[4] I1=A[4] I2=B[4] I3=carry[4]
XFE_RC_357_0 MAO222P $PINS O=carry[5] A1=carry[4] B1=B[4] C1=A[4]
XU1_26 XOR3 $PINS O=SUM[26] I1=A[26] I2=B[26] I3=carry[26]
XU1_22 FA1 $PINS S=SUM[22] CO=carry[23] A=A[22] B=B[22] CI=carry[22]
XU1_8 FA1 $PINS S=SUM[8] CO=carry[9] A=A[8] B=B[8] CI=carry[8]
XU1_15 FA1 $PINS S=SUM[15] CO=carry[16] A=A[15] B=B[15] CI=carry[15]
XU1_21 FA1 $PINS S=SUM[21] CO=carry[22] A=A[21] B=B[21] CI=carry[21]
XU1 ND2P $PINS O=n6 I1=carry[24] I2=A[24]
XU2 ND2P $PINS O=n14 I1=carry[7] I2=A[7]
XU3 XNR2HS $PINS O=SUM[24] I1=carry[24] I2=n1
XU4 XNR2HS $PINS O=n1 I1=A[24] I2=B[24]
XU5 ND2 $PINS O=n20 I1=B[0] I2=A[0]
XU6 ND2 $PINS O=n18 I1=carry[9] I2=B[9]
XU7 XOR3 $PINS O=SUM[9] I1=A[9] I2=B[9] I3=n9
XU8 ND2P $PINS O=n15 I1=carry[7] I2=B[7]
XU9 ND2S $PINS O=n13 I1=A[5] I2=B[5]
XU10 XOR2HS $PINS O=n2 I1=A[25] I2=B[25]
XU11 XOR2HS $PINS O=SUM[25] I1=carry[25] I2=n2
XU12 ND2 $PINS O=n3 I1=carry[25] I2=A[25]
XU13 ND2 $PINS O=n4 I1=carry[25] I2=B[25]
XU14 ND2S $PINS O=n5 I1=A[25] I2=B[25]
XU15 ND3 $PINS O=carry[26] I1=n3 I2=n4 I3=n5
XU16 ND2P $PINS O=n7 I1=carry[24] I2=B[24]
XU17 ND2S $PINS O=n8 I1=A[24] I2=B[24]
XU19 INV1S $PINS O=carry[1] I=n20
XU20 MAO222 $PINS O=n9 A1=A[8] B1=B[8] C1=carry[8]
XU21 ND3HT $PINS O=carry[8] I1=n14 I2=n15 I3=n16
XU22 ND3P $PINS O=carry[10] I1=n18 I2=n17 I3=n19
XU23 XOR2HS $PINS O=n10 I1=A[5] I2=B[5]
XU24 XOR2HS $PINS O=SUM[5] I1=FE_OCPN1225_carry_5 I2=n10
XU25 ND2P $PINS O=n11 I1=carry[5] I2=A[5]
XU26 ND2P $PINS O=n12 I1=carry[5] I2=B[5]
XU28 XOR3 $PINS O=SUM[7] I1=A[7] I2=B[7] I3=carry[7]
XU29 ND2 $PINS O=n16 I1=A[7] I2=B[7]
XU30 ND2P $PINS O=n17 I1=n9 I2=A[9]
XU31 ND2 $PINS O=n19 I1=A[9] I2=B[9]
XU32 XOR2HS $PINS O=SUM[0] I1=B[0] I2=A[0]
.ENDS

.SUBCKT PE_Shift_Add_6_DW01_add_1_DW01_add_24 A[26] A[25] A[24] A[23] A[22]
+ A[21] A[20] A[19] A[18] A[17] A[16] A[15] A[14] A[13] A[12] A[11] A[10] A[9]
+ A[8] A[7] A[6] A[5] A[4] A[3] A[2] A[1] A[0] B[26] B[25] B[24] B[23] B[22]
+ B[21] B[20] B[19] B[18] B[17] B[16] B[15] B[14] B[13] B[12] B[11] B[10] B[9]
+ B[8] B[7] B[6] B[5] B[4] B[3] B[2] B[1] B[0] CI SUM[26] SUM[25] SUM[24]
+ SUM[23] SUM[22] SUM[21] SUM[20] SUM[19] SUM[18] SUM[17] SUM[16] SUM[15]
+ SUM[14] SUM[13] SUM[12] SUM[11] SUM[10] SUM[9] SUM[8] SUM[7] SUM[6] SUM[5]
+ SUM[4] SUM[3] SUM[2] SUM[1] SUM[0] CO
XFE_RC_56_0 ND3P $PINS O=carry[11] I1=n5 I2=n6 I3=n7
XFE_RC_36_0 INV2CK $PINS O=SUM[14] I=FE_RN_20_0
XFE_RC_35_0 XNR3 $PINS O=FE_RN_20_0 I1=A[14] I2=B[14] I3=carry[14]
XFE_RC_29_0 OR2 $PINS O=FE_RN_17_0 I1=FE_RN_2374_0 I2=FE_RN_2373_0
XFE_RC_28_0 ND2P $PINS O=carry[24] I1=FE_RN_2378_0 I2=FE_RN_17_0
XFE_OCPC1196_carry_11 BUF1S $PINS O=FE_OCPN1196_carry_11 I=carry[11]
XFE_OCPC1139_carry_6 BUF1S $PINS O=FE_OCPN1139_carry_6 I=carry[6]
XFE_RC_3905_0 OR2 $PINS O=FE_RN_2552_0 I1=FE_RN_2042_0 I2=FE_RN_2050_0
XFE_RC_3904_0 ND2P $PINS O=carry[18] I1=FE_RN_2055_0 I2=FE_RN_2552_0
XFE_RC_3862_0 XNR2HS $PINS O=FE_RN_2534_0 I1=B[10] I2=A[10]
XFE_RC_3861_0 INV1S $PINS O=FE_RN_2533_0 I=FE_RN_2534_0
XFE_RC_3860_0 XOR2HS $PINS O=SUM[10] I1=FE_RN_2533_0 I2=carry[10]
XFE_RC_3742_0 OAI12HS $PINS O=SUM[12] A1=FE_RN_558_0 B1=carry[12]
+ B2=FE_RN_555_0
XFE_RC_3634_0 INV1S $PINS O=FE_RN_2367_0 I=carry[23]
XFE_RC_3633_0 XOR2HS $PINS O=FE_RN_2368_0 I1=B[23] I2=A[23]
XFE_RC_3632_0 ND2S $PINS O=FE_RN_2369_0 I1=FE_RN_2368_0 I2=FE_RN_2367_0
XFE_RC_3631_0 ND2 $PINS O=FE_RN_2370_0 I1=A[23] I2=B[23]
XFE_RC_3630_0 ND2S $PINS O=FE_RN_2371_0 I1=FE_RN_2370_0 I2=FE_RN_2377_0
XFE_RC_3629_0 ND2 $PINS O=FE_RN_2372_0 I1=FE_RN_2371_0 I2=carry[23]
XFE_RC_3628_0 ND2 $PINS O=SUM[23] I1=FE_RN_2372_0 I2=FE_RN_2369_0
XFE_RC_3627_0 INV1S $PINS O=FE_RN_2373_0 I=B[23]
XFE_RC_3626_0 INV1S $PINS O=FE_RN_2374_0 I=A[23]
XFE_RC_3623_0 ND2 $PINS O=FE_RN_2377_0 I1=FE_RN_2374_0 I2=FE_RN_2373_0
XFE_RC_3622_0 ND2 $PINS O=FE_RN_2378_0 I1=FE_RN_2377_0 I2=carry[23]
XFE_RC_3545_0 INV1S $PINS O=FE_RN_2303_0 I=B[1]
XFE_RC_3544_0 INV1S $PINS O=FE_RN_2304_0 I=A[1]
XFE_RC_3542_0 ND2 $PINS O=FE_RN_2306_0 I1=FE_RN_2304_0 I2=carry[1]
XFE_RC_3541_0 OAI12HS $PINS O=FE_RN_2307_0 A1=FE_RN_2306_0 B1=FE_RN_2304_0
+ B2=carry[1]
XFE_RC_3540_0 ND2 $PINS O=FE_RN_2308_0 I1=FE_RN_2307_0 I2=FE_RN_2303_0
XFE_RC_3539_0 ND2 $PINS O=FE_RN_2309_0 I1=A[1] I2=carry[1]
XFE_RC_3538_0 ND2 $PINS O=FE_RN_2310_0 I1=FE_RN_2309_0 I2=FE_RN_2314_0
XFE_RC_3537_0 ND2 $PINS O=FE_RN_2311_0 I1=FE_RN_2310_0 I2=B[1]
XFE_RC_3536_0 ND2 $PINS O=SUM[1] I1=FE_RN_2311_0 I2=FE_RN_2308_0
XFE_RC_3533_0 OR2B1S $PINS O=FE_RN_2314_0 I1=carry[1] B1=FE_RN_2304_0
XFE_RC_3532_0 ND2 $PINS O=FE_RN_2315_0 I1=FE_RN_2314_0 I2=B[1]
XFE_RC_3531_0 ND2P $PINS O=carry[2] I1=FE_RN_2315_0 I2=FE_RN_2309_0
XFE_RC_3491_0 INV1S $PINS O=FE_RN_2272_0 I=carry[21]
XFE_RC_3490_0 INV1S $PINS O=FE_RN_2273_0 I=A[21]
XFE_RC_3488_0 ND2 $PINS O=FE_RN_2275_0 I1=FE_RN_2273_0 I2=B[21]
XFE_RC_3487_0 OAI12HS $PINS O=FE_RN_2276_0 A1=FE_RN_2275_0 B1=FE_RN_2273_0
+ B2=B[21]
XFE_RC_3486_0 MXL2HS $PINS OB=SUM[21] S=FE_RN_2276_0 A=FE_RN_2272_0 B=carry[21]
XFE_RC_3485_0 ND2 $PINS O=FE_RN_2277_0 I1=B[21] I2=A[21]
XFE_RC_3483_0 OR2B1S $PINS O=FE_RN_2279_0 I1=B[21] B1=FE_RN_2273_0
XFE_RC_3482_0 ND2 $PINS O=FE_RN_2280_0 I1=FE_RN_2279_0 I2=carry[21]
XFE_RC_3481_0 ND2P $PINS O=carry[22] I1=FE_RN_2280_0 I2=FE_RN_2277_0
XFE_RC_3301_0 ND2 $PINS O=FE_RN_2138_0 I1=carry[6] I2=B[6]
XFE_RC_3300_0 AOI22H $PINS O=FE_RN_2139_0 A1=B[6] A2=A[6] B1=carry[6] B2=A[6]
XFE_RC_3299_0 ND2P $PINS O=carry[7] I1=FE_RN_2139_0 I2=FE_RN_2138_0
XFE_RC_3288_0 ND2 $PINS O=FE_RN_2129_0 I1=B[3] I2=carry[3]
XFE_RC_3287_0 AOI22H $PINS O=FE_RN_2130_0 A1=B[3] A2=A[3] B1=carry[3] B2=A[3]
XFE_RC_3286_0 ND2P $PINS O=carry[4] I1=FE_RN_2130_0 I2=FE_RN_2129_0
XFE_RC_3224_0 ND2 $PINS O=FE_RN_2081_0 I1=carry[7] I2=B[7]
XFE_RC_3223_0 AOI22H $PINS O=FE_RN_2082_0 A1=B[7] A2=A[7] B1=carry[7] B2=A[7]
XFE_RC_3222_0 ND2P $PINS O=carry[8] I1=FE_RN_2082_0 I2=FE_RN_2081_0
XFE_RC_3181_0 OAI12H $PINS O=FE_RN_1438_0 A1=carry[19] B1=B[19] B2=A[19]
XFE_RC_3180_0 INV1S $PINS O=FE_RN_2042_0 I=A[17]
XFE_RC_3178_0 ND2 $PINS O=FE_RN_2044_0 I1=FE_RN_2042_0 I2=B[17]
XFE_RC_3177_0 OAI12HS $PINS O=FE_RN_2045_0 A1=FE_RN_2044_0 B1=FE_RN_2042_0
+ B2=B[17]
XFE_RC_3176_0 OR2B1S $PINS O=FE_RN_2046_0 I1=carry[17] B1=FE_RN_2045_0
XFE_RC_3175_0 ND2 $PINS O=FE_RN_2047_0 I1=A[17] I2=B[17]
XFE_RC_3174_0 ND2S $PINS O=FE_RN_2048_0 I1=FE_RN_2047_0 I2=FE_RN_2054_0
XFE_RC_3173_0 ND2 $PINS O=FE_RN_2049_0 I1=FE_RN_2048_0 I2=carry[17]
XFE_RC_3172_0 ND2 $PINS O=SUM[17] I1=FE_RN_2046_0 I2=FE_RN_2049_0
XFE_RC_3171_0 INV1S $PINS O=FE_RN_2050_0 I=B[17]
XFE_RC_3167_0 ND2 $PINS O=FE_RN_2054_0 I1=FE_RN_2042_0 I2=FE_RN_2050_0
XFE_RC_3166_0 ND2 $PINS O=FE_RN_2055_0 I1=FE_RN_2054_0 I2=carry[17]
XFE_RC_2833_0 INV1S $PINS O=FE_RN_1798_0 I=FE_RN_1806_0
XFE_RC_2832_0 AOI12HS $PINS O=FE_RN_1799_0 A1=FE_RN_1798_0 B1=A[18] B2=B[18]
XFE_RC_2831_0 INV1S $PINS O=FE_RN_1800_0 I=A[18]
XFE_RC_2829_0 NR2 $PINS O=FE_RN_1802_0 I1=B[18] I2=FE_RN_1800_0
XFE_RC_2828_0 AOI12HS $PINS O=FE_RN_1803_0 A1=FE_RN_1802_0 B1=FE_RN_1800_0
+ B2=B[18]
XFE_RC_2827_0 MXL2HS $PINS OB=SUM[18] S=carry[18] A=FE_RN_1803_0 B=FE_RN_1799_0
XFE_RC_2826_0 ND2 $PINS O=FE_RN_1804_0 I1=A[18] I2=B[18]
XFE_RC_2824_0 OR2B1S $PINS O=FE_RN_1806_0 I1=B[18] B1=FE_RN_1800_0
XFE_RC_2823_0 ND2 $PINS O=FE_RN_1807_0 I1=FE_RN_1806_0 I2=carry[18]
XFE_RC_2822_0 ND2P $PINS O=carry[19] I1=FE_RN_1807_0 I2=FE_RN_1804_0
XFE_RC_2334_0 INV1S $PINS O=FE_RN_1433_0 I=A[19]
XFE_RC_2332_0 ND2S $PINS O=FE_RN_1435_0 I1=FE_RN_1433_0 I2=B[19]
XFE_RC_2331_0 OAI12HS $PINS O=FE_RN_1436_0 A1=FE_RN_1435_0 B1=FE_RN_1433_0
+ B2=B[19]
XFE_RC_2330_0 XOR2HS $PINS O=SUM[19] I1=carry[19] I2=FE_RN_1436_0
XFE_RC_2329_0 ND2S $PINS O=FE_RN_1437_0 I1=A[19] I2=B[19]
XFE_RC_2327_0 ND2P $PINS O=carry[20] I1=FE_RN_1438_0 I2=FE_RN_1437_0
XFE_RC_1920_0 INV1S $PINS O=FE_RN_1125_0 I=A[20]
XFE_RC_1919_0 AN2B1S $PINS O=FE_RN_1126_0 I1=B[20] B1=FE_RN_1125_0
XFE_RC_1918_0 AN2B1S $PINS O=FE_RN_1127_0 I1=FE_RN_1133_0 B1=FE_RN_1126_0
XFE_RC_1915_0 MAOI1 $PINS O=FE_RN_1130_0 A1=FE_RN_1125_0 A2=B[20] B1=B[20]
+ B2=FE_RN_1125_0
XFE_RC_1914_0 MXL2HS $PINS OB=SUM[20] S=carry[20] A=FE_RN_1130_0 B=FE_RN_1127_0
XFE_RC_1913_0 ND2S $PINS O=FE_RN_1131_0 I1=A[20] I2=B[20]
XFE_RC_1911_0 OR2B1S $PINS O=FE_RN_1133_0 I1=B[20] B1=FE_RN_1125_0
XFE_RC_1910_0 ND2 $PINS O=FE_RN_1134_0 I1=FE_RN_1133_0 I2=carry[20]
XFE_RC_1909_0 ND2P $PINS O=carry[21] I1=FE_RN_1134_0 I2=FE_RN_1131_0
XFE_RC_1527_0 INV1S $PINS O=FE_RN_823_0 I=A[11]
XFE_RC_1526_0 NR2 $PINS O=FE_RN_824_0 I1=B[11] I2=FE_RN_823_0
XFE_RC_1525_0 AN2B1S $PINS O=FE_RN_825_0 I1=B[11] B1=A[11]
XFE_RC_1524_0 INV1S $PINS O=FE_RN_826_0 I=carry[11]
XFE_RC_1523_0 OAI12HS $PINS O=FE_RN_827_0 A1=FE_RN_826_0 B1=FE_RN_825_0
+ B2=FE_RN_824_0
XFE_RC_1522_0 ND2 $PINS O=FE_RN_828_0 I1=A[11] I2=B[11]
XFE_RC_1521_0 ND2S $PINS O=FE_RN_829_0 I1=FE_RN_828_0 I2=FE_RN_834_0
XFE_RC_1520_0 ND2 $PINS O=FE_RN_830_0 I1=FE_RN_829_0 I2=FE_OCPN1196_carry_11
XFE_RC_1519_0 ND2P $PINS O=SUM[11] I1=FE_RN_830_0 I2=FE_RN_827_0
XFE_RC_1517_0 INV1S $PINS O=FE_RN_832_0 I=B[11]
XFE_RC_1515_0 ND2 $PINS O=FE_RN_834_0 I1=FE_RN_823_0 I2=FE_RN_832_0
XFE_RC_1514_0 ND2 $PINS O=FE_RN_835_0 I1=carry[11] I2=FE_RN_834_0
XFE_RC_1513_0 ND2P $PINS O=carry[12] I1=FE_RN_835_0 I2=FE_RN_828_0
XFE_RC_1173_0 INV1S $PINS O=FE_RN_553_0 I=A[12]
XFE_RC_1171_0 MAOI1 $PINS O=FE_RN_555_0 A1=FE_RN_553_0 A2=B[12] B1=B[12]
+ B2=FE_RN_553_0
XFE_RC_1170_0 ND2S $PINS O=FE_RN_556_0 I1=A[12] I2=B[12]
XFE_RC_1169_0 ND2 $PINS O=FE_RN_557_0 I1=FE_RN_561_0 I2=FE_RN_556_0
XFE_RC_1168_0 ND2 $PINS O=FE_RN_558_0 I1=carry[12] I2=FE_RN_557_0
XFE_RC_1164_0 OR2B1 $PINS O=FE_RN_561_0 I1=B[12] B1=FE_RN_553_0
XFE_RC_1163_0 ND2 $PINS O=FE_RN_562_0 I1=carry[12] I2=FE_RN_561_0
XFE_RC_1162_0 ND2P $PINS O=carry[13] I1=FE_RN_562_0 I2=FE_RN_556_0
XFE_RC_1016_0 INV1S $PINS O=FE_RN_444_0 I=FE_RN_334_0
XFE_RC_1015_0 OR2B1S $PINS O=FE_RN_445_0 I1=FE_RN_342_0 B1=FE_RN_444_0
XFE_RC_1014_0 ND2P $PINS O=carry[14] I1=FE_RN_346_0 I2=FE_RN_445_0
XFE_RC_882_0 INV1S $PINS O=FE_RN_333_0 I=carry[13]
XFE_RC_881_0 INV1S $PINS O=FE_RN_334_0 I=A[13]
XFE_RC_879_0 ND2S $PINS O=FE_RN_336_0 I1=FE_RN_334_0 I2=B[13]
XFE_RC_878_0 OAI12HS $PINS O=FE_RN_337_0 A1=FE_RN_336_0 B1=FE_RN_334_0 B2=B[13]
XFE_RC_877_0 ND2S $PINS O=FE_RN_338_0 I1=FE_RN_337_0 I2=FE_RN_333_0
XFE_RC_876_0 ND2S $PINS O=FE_RN_339_0 I1=A[13] I2=B[13]
XFE_RC_875_0 ND2 $PINS O=FE_RN_340_0 I1=FE_RN_339_0 I2=FE_RN_345_0
XFE_RC_874_0 ND2 $PINS O=FE_RN_341_0 I1=FE_RN_340_0 I2=carry[13]
XFE_RC_873_0 ND2P $PINS O=SUM[13] I1=FE_RN_338_0 I2=FE_RN_341_0
XFE_RC_872_0 INV1S $PINS O=FE_RN_342_0 I=B[13]
XFE_RC_869_0 OR2B1 $PINS O=FE_RN_345_0 I1=B[13] B1=FE_RN_334_0
XFE_RC_868_0 ND2 $PINS O=FE_RN_346_0 I1=FE_RN_345_0 I2=carry[13]
XFE_RC_719_0 MAO222 $PINS O=carry[15] A1=A[14] B1=B[14] C1=carry[14]
XFE_RC_613_0 XOR3 $PINS O=SUM[15] I1=A[15] I2=B[15] I3=carry[15]
XFE_RC_612_0 MAO222 $PINS O=carry[16] A1=A[15] B1=B[15] C1=carry[15]
XFE_RC_403_0 INV1S $PINS O=FE_RN_99_0 I=A[16]
XFE_RC_402_0 AN2B1S $PINS O=FE_RN_100_0 I1=B[16] B1=FE_RN_99_0
XFE_RC_401_0 AN2B1S $PINS O=FE_RN_101_0 I1=FE_RN_107_0 B1=FE_RN_100_0
XFE_RC_398_0 MAOI1 $PINS O=FE_RN_104_0 A1=FE_RN_99_0 A2=B[16] B1=B[16]
+ B2=FE_RN_99_0
XFE_RC_397_0 MXL2HS $PINS OB=SUM[16] S=carry[16] A=FE_RN_104_0 B=FE_RN_101_0
XFE_RC_396_0 ND2 $PINS O=FE_RN_105_0 I1=A[16] I2=B[16]
XFE_RC_394_0 OR2B1S $PINS O=FE_RN_107_0 I1=B[16] B1=FE_RN_99_0
XFE_RC_393_0 ND2 $PINS O=FE_RN_108_0 I1=FE_RN_107_0 I2=carry[16]
XFE_RC_392_0 ND2P $PINS O=carry[17] I1=FE_RN_108_0 I2=FE_RN_105_0
XFE_RC_269_0 XOR3 $PINS O=SUM[2] I1=A[2] I2=B[2] I3=carry[2]
XFE_RC_268_0 MAO222P $PINS O=carry[3] A1=A[2] B1=B[2] C1=carry[2]
XFE_RC_267_0 ND3P $PINS O=carry[6] I1=n3 I2=n2 I3=n4
XFE_RC_98_0 XOR3 $PINS O=SUM[3] I1=A[3] I2=B[3] I3=carry[3]
XFE_RC_96_0 XOR3 $PINS O=SUM[6] I1=A[6] I2=B[6] I3=FE_OCPN1139_carry_6
XFE_RC_66_0 ND3P $PINS O=carry[10] I1=n10 I2=n11 I3=n12
XFE_RC_64_0 XOR3 $PINS O=SUM[7] I1=A[7] I2=B[7] I3=carry[7]
XU1_22 FA1 $PINS S=SUM[22] CO=carry[23] A=A[22] B=B[22] CI=carry[22]
XU1_8 FA1 $PINS S=SUM[8] CO=carry[9] A=A[8] B=B[8] CI=carry[8]
XU1_4 FA1 $PINS S=SUM[4] CO=carry[5] A=A[4] B=B[4] CI=carry[4]
XU1_24 FA1 $PINS S=SUM[24] CO=carry[25] A=A[24] B=B[24] CI=carry[24]
XU1_25 FA1 $PINS S=SUM[25] CO=carry[26] A=A[25] B=B[25] CI=carry[25]
XU1_26 XOR3 $PINS O=SUM[26] I1=A[26] I2=B[26] I3=carry[26]
XU1 MAO222 $PINS O=n1 A1=A[4] B1=B[4] C1=carry[4]
XU3 ND2 $PINS O=n13 I1=B[0] I2=A[0]
XU6 ND2 $PINS O=n10 I1=carry[9] I2=B[9]
XU7 ND2 $PINS O=n2 I1=n1 I2=B[5]
XU8 ND2 $PINS O=n3 I1=carry[5] I2=A[5]
XU9 ND2 $PINS O=n4 I1=B[5] I2=A[5]
XU11 ND2 $PINS O=n5 I1=carry[10] I2=B[10]
XU12 ND2 $PINS O=n6 I1=carry[10] I2=A[10]
XU13 ND2 $PINS O=n7 I1=B[10] I2=A[10]
XU14 INV2 $PINS O=carry[1] I=n13
XU15 ND2S $PINS O=n12 I1=B[9] I2=A[9]
XU16 MAO222 $PINS O=n8 A1=carry[8] B1=B[8] C1=A[8]
XU17 XOR2HS $PINS O=n9 I1=B[9] I2=A[9]
XU18 XOR2HS $PINS O=SUM[9] I1=n8 I2=n9
XU19 ND2P $PINS O=n11 I1=n8 I2=A[9]
XU21 XOR2HS $PINS O=SUM[0] I1=B[0] I2=A[0]
XU5 XOR3 $PINS O=SUM[5] I1=B[5] I2=A[5] I3=n1
.ENDS

.SUBCKT PE_Shift_Add_6_DW01_add_0_DW01_add_23 A[26] A[25] A[24] A[23] A[22]
+ A[21] A[20] A[19] A[18] A[17] A[16] A[15] A[14] A[13] A[12] A[11] A[10] A[9]
+ A[8] A[7] A[6] A[5] A[4] A[3] A[2] A[1] A[0] B[26] B[25] B[24] B[23] B[22]
+ B[21] B[20] B[19] B[18] B[17] B[16] B[15] B[14] B[13] B[12] B[11] B[10] B[9]
+ B[8] B[7] B[6] B[5] B[4] B[3] B[2] B[1] B[0] CI SUM[26] SUM[25] SUM[24]
+ SUM[23] SUM[22] SUM[21] SUM[20] SUM[19] SUM[18] SUM[17] SUM[16] SUM[15]
+ SUM[14] SUM[13] SUM[12] SUM[11] SUM[10] SUM[9] SUM[8] SUM[7] SUM[6] SUM[5]
+ SUM[4] SUM[3] SUM[2] SUM[1] SUM[0] CO
XFE_RC_313_0 XOR2HS $PINS O=FE_RN_1038_0 I1=A[12] I2=B[12]
XFE_RC_119_0 AOI22H $PINS O=FE_RN_1321_0 A1=A[14] A2=B[14] B1=carry[14]
+ B2=A[14]
XFE_RC_117_0 AOI22H $PINS O=FE_RN_2135_0 A1=B[24] A2=A[24] B1=carry[24]
+ B2=B[24]
XFE_RC_115_0 ND3P $PINS O=carry[19] I1=FE_RN_248_0 I2=FE_RN_250_0
+ I3=FE_RN_249_0
XFE_OCPC1238_N195 BUF1S $PINS O=FE_OCPN1238_N195 I=A[17]
XFE_OCPC1209_carry_8 BUF1S $PINS O=FE_OCPN1209_carry_8 I=carry[8]
XFE_OCPC1133_carry_11 BUF1S $PINS O=FE_OCPN1133_carry_11 I=carry[11]
XFE_OCPC1130_carry_10 BUF1S $PINS O=FE_OCPN1130_carry_10 I=carry[10]
XFE_OCPC1026_carry_13 BUF1S $PINS O=FE_OCPN1026_carry_13 I=carry[13]
XFE_OCPC1018_carry_17 BUF1S $PINS O=FE_OCPN1018_carry_17 I=carry[17]
XFE_OCPC1002_carry_15 BUF1S $PINS O=FE_OCPN1002_carry_15 I=carry[15]
XFE_OCPC1001_carry_12 BUF1S $PINS O=FE_OCPN1001_carry_12 I=carry[12]
XFE_OCPC992_carry_14 BUF1S $PINS O=FE_OCPN992_carry_14 I=carry[14]
XFE_OCPC989_carry_20 BUF1S $PINS O=FE_OCPN989_carry_20 I=carry[20]
XFE_OCPC987_carry_21 BUF1S $PINS O=FE_OCPN987_carry_21 I=carry[21]
XFE_OCPC986_carry_16 BUF1S $PINS O=FE_OCPN986_carry_16 I=carry[16]
XFE_RC_4049_0 ND3P $PINS O=carry[20] I1=FE_RN_173_0 I2=FE_RN_175_0
+ I3=FE_RN_174_0
XFE_RC_3988_0 XOR2HS $PINS O=FE_RN_2578_0 I1=A[25] I2=B[25]
XFE_RC_3987_0 OR2B1S $PINS O=FE_RN_2579_0 I1=carry[25] B1=FE_RN_2578_0
XFE_RC_3986_0 ND2 $PINS O=FE_RN_2580_0 I1=B[25] I2=A[25]
XFE_RC_3985_0 ND2 $PINS O=FE_RN_2581_0 I1=FE_RN_2585_0 I2=FE_RN_2580_0
XFE_RC_3984_0 ND2 $PINS O=FE_RN_2582_0 I1=FE_RN_2581_0 I2=carry[25]
XFE_RC_3983_0 ND2 $PINS O=SUM[25] I1=FE_RN_2582_0 I2=FE_RN_2579_0
XFE_RC_3981_0 INV1S $PINS O=FE_RN_2584_0 I=B[25]
XFE_RC_3980_0 OR2B1S $PINS O=FE_RN_2585_0 I1=A[25] B1=FE_RN_2584_0
XFE_RC_3979_0 ND2 $PINS O=FE_RN_2586_0 I1=FE_RN_2585_0 I2=carry[25]
XFE_RC_3978_0 ND2P $PINS O=carry[26] I1=FE_RN_2586_0 I2=FE_RN_2580_0
XFE_RC_3859_0 XNR2HS $PINS O=FE_RN_2532_0 I1=A[26] I2=B[26]
XFE_RC_3858_0 XNR2HS $PINS O=SUM[26] I1=FE_RN_2532_0 I2=carry[26]
XFE_RC_3517_0 OAI12H $PINS O=FE_RN_1040_0 A1=carry[12] B1=B[12] B2=A[12]
XFE_OCPC352_carry_24 BUF1S $PINS O=FE_OCPN352_carry_24 I=carry[24]
XFE_OCPC282_carry_18 BUF1S $PINS O=FE_OCPN282_carry_18 I=carry[18]
XFE_OCPC276_carry_19 BUF1S $PINS O=FE_OCPN276_carry_19 I=carry[19]
XFE_OCPC240_carry_22 BUF1S $PINS O=FE_OCPN240_carry_22 I=carry[22]
XFE_OCPC228_carry_23 BUF1S $PINS O=FE_OCPN228_carry_23 I=carry[23]
XFE_RC_3295_0 ND2 $PINS O=FE_RN_2134_0 I1=carry[24] I2=A[24]
XFE_RC_3293_0 ND2 $PINS O=carry[25] I1=FE_RN_2135_0 I2=FE_RN_2134_0
XFE_RC_3218_0 ND3P $PINS O=carry[23] I1=FE_RN_2057_0 I2=FE_RN_2058_0
+ I3=FE_RN_2056_0
XFE_RC_3185_0 ND2 $PINS O=FE_RN_2056_0 I1=A[22] I2=B[22]
XFE_RC_3184_0 ND2 $PINS O=FE_RN_2057_0 I1=carry[22] I2=A[22]
XFE_RC_3183_0 ND2P $PINS O=FE_RN_2058_0 I1=carry[22] I2=B[22]
XFE_RC_3092_0 ND3 $PINS O=carry[7] I1=n18 I2=n19 I3=n20
XFE_RC_3066_0 ND2 $PINS O=FE_RN_1974_0 I1=carry[21] I2=B[21]
XFE_RC_3065_0 AOI22H $PINS O=FE_RN_1975_0 A1=A[21] A2=B[21] B1=carry[21]
+ B2=A[21]
XFE_RC_3064_0 ND2P $PINS O=carry[22] I1=FE_RN_1975_0 I2=FE_RN_1974_0
XFE_RC_2689_0 INV1S $PINS O=FE_RN_1691_0 I=B[7]
XFE_RC_2688_0 INV1S $PINS O=FE_RN_1692_0 I=A[7]
XFE_RC_2687_0 AOI22S $PINS O=FE_RN_1693_0 A1=FE_RN_1692_0 A2=B[7] B1=A[7]
+ B2=FE_RN_1691_0
XFE_RC_2684_0 OAI12HS $PINS O=FE_RN_1696_0 A1=FE_RN_1701_0 B1=FE_RN_1692_0
+ B2=FE_RN_1691_0
XFE_RC_2683_0 ND2 $PINS O=FE_RN_1697_0 I1=FE_RN_1696_0 I2=carry[7]
XFE_RC_2682_0 OAI12HS $PINS O=SUM[7] A1=FE_RN_1697_0 B1=FE_RN_1693_0
+ B2=carry[7]
XFE_RC_2681_0 ND2 $PINS O=FE_RN_1698_0 I1=A[7] I2=B[7]
XFE_RC_2679_0 INV2 $PINS O=FE_RN_1700_0 I=A[7]
XFE_RC_2678_0 ND2S $PINS O=FE_RN_1701_0 I1=FE_RN_1691_0 I2=FE_RN_1700_0
XFE_RC_2677_0 ND2 $PINS O=FE_RN_1702_0 I1=FE_RN_1701_0 I2=carry[7]
XFE_RC_2676_0 ND2P $PINS O=carry[8] I1=FE_RN_1702_0 I2=FE_RN_1698_0
XFE_RC_2645_0 ND3P $PINS O=carry[21] I1=FE_RN_1526_0 I2=FE_RN_1528_0
+ I3=FE_RN_1527_0
XFE_RC_2452_0 ND2 $PINS O=FE_RN_1526_0 I1=carry[20] I2=A[20]
XFE_RC_2451_0 ND2 $PINS O=FE_RN_1527_0 I1=A[20] I2=B[20]
XFE_RC_2450_0 ND2 $PINS O=FE_RN_1528_0 I1=carry[20] I2=B[20]
XFE_RC_2447_0 INV1S $PINS O=FE_RN_1515_0 I=B[8]
XFE_RC_2445_0 NR2 $PINS O=FE_RN_1517_0 I1=A[8] I2=FE_RN_1515_0
XFE_RC_2444_0 AOI12HS $PINS O=FE_RN_1518_0 A1=FE_RN_1517_0 B1=FE_RN_1515_0
+ B2=A[8]
XFE_RC_2443_0 INV1S $PINS O=FE_RN_1519_0 I=A[8]
XFE_RC_2441_0 OAI12HS $PINS O=FE_RN_1521_0 A1=FE_RN_1524_0 B1=FE_RN_1515_0
+ B2=FE_RN_1519_0
XFE_RC_2440_0 ND2 $PINS O=FE_RN_1522_0 I1=FE_RN_1521_0 I2=FE_OCPN1209_carry_8
XFE_RC_2439_0 OAI12HS $PINS O=SUM[8] A1=FE_RN_1522_0 B1=FE_RN_1518_0
+ B2=FE_OCPN1209_carry_8
XFE_RC_2438_0 ND2 $PINS O=FE_RN_1523_0 I1=B[8] I2=A[8]
XFE_RC_2437_0 OR2 $PINS O=FE_RN_1524_0 I1=B[8] I2=A[8]
XFE_RC_2436_0 ND2P $PINS O=FE_RN_1525_0 I1=FE_RN_1524_0 I2=carry[8]
XFE_RC_2435_0 ND2P $PINS O=carry[9] I1=FE_RN_1525_0 I2=FE_RN_1523_0
XFE_RC_2228_0 AOI22H $PINS O=FE_RN_389_0 A1=B[17] A2=A[17] B1=carry[17]
+ B2=A[17]
XFE_RC_2176_0 ND2P $PINS O=FE_RN_1320_0 I1=carry[14] I2=B[14]
XFE_RC_2174_0 ND2P $PINS O=carry[15] I1=FE_RN_1321_0 I2=FE_RN_1320_0
XFE_RC_2173_0 ND3P $PINS O=carry[12] I1=n26 I2=n27 I3=n25
XFE_RC_1796_0 XOR2HS $PINS O=SUM[12] I1=FE_OCPN1001_carry_12 I2=FE_RN_1038_0
XFE_RC_1795_0 ND2 $PINS O=FE_RN_1039_0 I1=A[12] I2=B[12]
XFE_RC_1793_0 ND2P $PINS O=carry[13] I1=FE_RN_1040_0 I2=FE_RN_1039_0
XFE_RC_1625_0 OAI12H $PINS O=FE_RN_524_0 A1=carry[13] B1=A[13] B2=B[13]
XFE_RC_1613_0 ND2 $PINS O=FE_RN_896_0 I1=carry[15] I2=B[15]
XFE_RC_1612_0 AOI22H $PINS O=FE_RN_897_0 A1=B[15] A2=A[15] B1=carry[15]
+ B2=A[15]
XFE_RC_1611_0 ND2P $PINS O=carry[16] I1=FE_RN_897_0 I2=FE_RN_896_0
XFE_RC_1153_0 ND2P $PINS O=FE_RN_545_0 I1=carry[16] I2=B[16]
XFE_RC_1152_0 AOI22H $PINS O=FE_RN_546_0 A1=A[16] A2=B[16] B1=carry[16]
+ B2=A[16]
XFE_RC_1151_0 ND2P $PINS O=carry[17] I1=FE_RN_546_0 I2=FE_RN_545_0
XFE_RC_1123_0 INV1S $PINS O=FE_RN_519_0 I=FE_OCPN1026_carry_13
XFE_RC_1121_0 XOR2HS $PINS O=FE_RN_521_0 I1=B[13] I2=A[13]
XFE_RC_1120_0 ND2 $PINS O=FE_RN_522_0 I1=FE_RN_521_0 I2=FE_RN_519_0
XFE_RC_1119_0 OAI12HS $PINS O=SUM[13] A1=FE_RN_522_0 B1=FE_RN_521_0
+ B2=FE_RN_519_0
XFE_RC_1118_0 ND2 $PINS O=FE_RN_523_0 I1=A[13] I2=B[13]
XFE_RC_1116_0 ND2T $PINS O=carry[14] I1=FE_RN_524_0 I2=FE_RN_523_0
XFE_RC_943_0 ND2 $PINS O=FE_RN_388_0 I1=carry[17] I2=B[17]
XFE_RC_941_0 ND2P $PINS O=carry[18] I1=FE_RN_389_0 I2=FE_RN_388_0
XFE_RC_913_0 XOR3 $PINS O=SUM[14] I1=A[14] I2=B[14] I3=FE_OCPN992_carry_14
XFE_RC_780_0 XOR3 $PINS O=SUM[15] I1=A[15] I2=B[15] I3=FE_OCPN1002_carry_15
XFE_RC_756_0 ND2P $PINS O=FE_RN_248_0 I1=carry[18] I2=A[18]
XFE_RC_755_0 ND2 $PINS O=FE_RN_249_0 I1=A[18] I2=B[18]
XFE_RC_754_0 ND2P $PINS O=FE_RN_250_0 I1=carry[18] I2=B[18]
XFE_RC_588_0 ND2 $PINS O=FE_RN_173_0 I1=carry[19] I2=A[19]
XFE_RC_587_0 ND2 $PINS O=FE_RN_174_0 I1=A[19] I2=B[19]
XFE_RC_586_0 ND2 $PINS O=FE_RN_175_0 I1=carry[19] I2=B[19]
XFE_RC_576_0 XOR3 $PINS O=SUM[16] I1=A[16] I2=B[16] I3=FE_OCPN986_carry_16
XFE_RC_354_0 XOR3 $PINS O=SUM[24] I1=B[24] I2=A[24] I3=FE_OCPN352_carry_24
XFE_RC_346_0 XOR3 $PINS O=SUM[17] I1=FE_OCPN1238_N195 I2=B[17]
+ I3=FE_OCPN1018_carry_17
XFE_RC_304_0 XOR3 $PINS O=SUM[18] I1=A[18] I2=B[18] I3=FE_OCPN282_carry_18
XFE_RC_211_0 XOR3 $PINS O=SUM[19] I1=A[19] I2=B[19] I3=FE_OCPN276_carry_19
XFE_RC_197_0 ND3P $PINS O=carry[10] I1=n16 I2=n15 I3=n17
XFE_RC_194_0 XOR3 $PINS O=SUM[20] I1=A[20] I2=B[20] I3=FE_OCPN989_carry_20
XFE_RC_40_0 XOR3 $PINS O=SUM[21] I1=A[21] I2=B[21] I3=FE_OCPN987_carry_21
XFE_RC_29_0 XOR3 $PINS O=SUM[22] I1=A[22] I2=B[22] I3=FE_OCPN240_carry_22
XU1_1 FA1 $PINS S=SUM[1] CO=carry[2] A=n1 B=B[1] CI=A[1]
XU1_5 FA1 $PINS S=SUM[5] CO=carry[6] A=A[5] B=B[5] CI=carry[5]
XU2 XOR3 $PINS O=SUM[3] I1=A[3] I2=B[3] I3=carry[3]
XU4 ND3P $PINS O=carry[24] I1=n2 I2=n3 I3=n4
XU6 ND2P $PINS O=n26 I1=carry[11] I2=A[11]
XU7 ND2P $PINS O=n27 I1=carry[11] I2=B[11]
XU8 ND3P $PINS O=carry[4] I1=n5 I2=n6 I3=n7
XU9 ND2 $PINS O=n5 I1=A[3] I2=B[3]
XU10 ND2 $PINS O=n21 I1=B[10] I2=A[10]
XU12 XOR3 $PINS O=SUM[9] I1=A[9] I2=B[9] I3=carry[9]
XU13 ND3 $PINS O=carry[3] I1=n12 I2=n13 I3=n14
XU14 AN2 $PINS O=n1 I1=B[0] I2=A[0]
XU15 XOR3 $PINS O=SUM[23] I1=A[23] I2=B[23] I3=FE_OCPN228_carry_23
XU16 ND2 $PINS O=n2 I1=carry[23] I2=A[23]
XU17 ND2 $PINS O=n3 I1=carry[23] I2=B[23]
XU18 ND2 $PINS O=n4 I1=A[23] I2=B[23]
XU19 ND2 $PINS O=n6 I1=A[3] I2=carry[3]
XU20 ND2 $PINS O=n7 I1=B[3] I2=carry[3]
XU21 XOR2HS $PINS O=n8 I1=A[4] I2=B[4]
XU22 XOR2HS $PINS O=SUM[4] I1=carry[4] I2=n8
XU23 ND2 $PINS O=n9 I1=A[4] I2=B[4]
XU24 ND2 $PINS O=n10 I1=carry[4] I2=A[4]
XU25 ND2 $PINS O=n11 I1=B[4] I2=carry[4]
XU26 XOR3S $PINS O=SUM[2] I1=A[2] I2=B[2] I3=carry[2]
XU27 ND2 $PINS O=n12 I1=carry[2] I2=A[2]
XU28 ND2 $PINS O=n13 I1=carry[2] I2=B[2]
XU29 ND2 $PINS O=n14 I1=A[2] I2=B[2]
XU30 ND2 $PINS O=n15 I1=carry[9] I2=A[9]
XU31 ND2 $PINS O=n16 I1=carry[9] I2=B[9]
XU32 ND2 $PINS O=n17 I1=A[9] I2=B[9]
XU35 XOR3 $PINS O=SUM[6] I1=B[6] I2=A[6] I3=carry[6]
XU36 ND2 $PINS O=n18 I1=carry[6] I2=B[6]
XU37 ND2 $PINS O=n19 I1=carry[6] I2=A[6]
XU38 ND2 $PINS O=n20 I1=B[6] I2=A[6]
XU39 ND2 $PINS O=n22 I1=carry[10] I2=A[10]
XU40 ND2 $PINS O=n23 I1=B[10] I2=carry[10]
XU41 XOR2HS $PINS O=n24 I1=A[11] I2=B[11]
XU42 XOR2HS $PINS O=SUM[11] I1=n24 I2=FE_OCPN1133_carry_11
XU43 ND2P $PINS O=n25 I1=A[11] I2=B[11]
XU44 XOR2HS $PINS O=SUM[0] I1=B[0] I2=A[0]
XU1 XOR3 $PINS O=SUM[10] I1=A[10] I2=B[10] I3=FE_OCPN1130_carry_10
XU3 ND3P $PINS O=carry[11] I1=n21 I2=n23 I3=n22
XU5 ND3 $PINS O=carry[5] I1=n11 I2=n10 I3=n9
.ENDS

.SUBCKT PE_Shift_Add_6 rst_n en clear calc_done stage_sel x_in[16] x_in[15]
+ x_in[14] x_in[13] x_in[12] x_in[11] x_in[10] x_in[9] x_in[8] x_in[7] x_in[6]
+ x_in[5] x_in[4] x_in[3] x_in[2] x_in[1] x_in[0] sign1[1] sign1[0] sign2[1]
+ sign2[0] sign3[1] sign3[0] shf1[3] shf1[2] shf1[1] shf1[0] shf2[3] shf2[2]
+ shf2[1] shf2[0] shf3[3] shf3[2] shf3[1] shf3[0] y_out[16] y_out[15] y_out[14]
+ y_out[13] y_out[12] y_out[11] y_out[10] y_out[9] y_out[8] y_out[7] y_out[6]
+ y_out[5] y_out[4] y_out[3] y_out[2] y_out[1] y_out[0] i_rst_n
+ FE_OFN52_i_rst_n FE_OFN31_i_rst_n FE_OFN15_i_rst_n FE_OFN60_FE_DBTN9_n336
+ FE_OFN64_s01_1 FE_OFN65_s01_0 FE_OFN66_h01_3 FE_OFN67_h01_2 FE_OFN68_h01_1
+ FE_OFN69_h01_0 FE_OFN70_s02_1 FE_OFN71_h02_3 FE_OFN72_h02_2 FE_OFN73_h02_1
+ FE_OFN74_h02_0 FE_OFN75_s03_1 FE_OFN76_s03_0 FE_OFN77_h03_3 FE_OFN78_h03_2
+ FE_OFN79_h03_1 FE_OFN80_h03_0 FE_OFN144_s02_0 FE_OFN164_s03_0 clk clk_clone1
XFE_PHC2163_N251 BUF1CK $PINS O=N251 I=FE_PHN2163_N251
XFE_PHC2125_acc_reg_11 BUF1CK $PINS O=FE_PHN2125_acc_reg_11 I=acc_reg[11]
XFE_PHC1931_N235 DELC $PINS O=N235 I=FE_PHN1931_N235
XFE_PHC1902_N238 DELB $PINS O=FE_PHN1902_N238 I=N238
XFE_PHC1897_N239 DELC $PINS O=FE_PHN1897_N239 I=N239
XFE_PHC1879_N249 DELB $PINS O=FE_PHN1879_N249 I=N249
XFE_PHC1877_N250 DELB $PINS O=FE_PHN1877_N250 I=N250
XFE_PHC1874_N247 DELC $PINS O=FE_PHN1874_N247 I=N247
XFE_PHC1869_N248 DELC $PINS O=FE_PHN1869_N248 I=N248
XFE_PHC1589_N236 DELB $PINS O=FE_PHN1589_N236 I=N236
XFE_PHC1574_next_acc_0 DELB $PINS O=FE_PHN1574_next_acc_0 I=next_acc[0]
XFE_PHC1539_N240 DELB $PINS O=FE_PHN1539_N240 I=N240
XFE_PHC1537_N237 DELB $PINS O=FE_PHN1537_N237 I=N237
XFE_PHC1535_N246 DELB $PINS O=FE_PHN1535_N246 I=N246
XFE_PHC1532_N245 DELB $PINS O=FE_PHN1532_N245 I=N245
XFE_PHC1528_acc_reg_13 DELB $PINS O=FE_PHN1528_acc_reg_13 I=acc_reg[13]
XFE_PHC1525_N242 DELC $PINS O=FE_PHN1525_N242 I=N242
XFE_PHC1493_N244 DELC $PINS O=FE_PHN1493_N244 I=N244
XFE_PHC1492_N243 DELC $PINS O=FE_PHN1492_N243 I=N243
XFE_PHC1488_N241 DELC $PINS O=FE_PHN1488_N241 I=N241
XFE_PHC1422_N251 DELC $PINS O=FE_PHN1422_N251 I=N251
XFE_PHC1409_acc_reg_14 DELB $PINS O=FE_PHN1409_acc_reg_14 I=acc_reg[14]
XFE_RC_310_0 MUX2 $PINS O=N153 S=FE_OFN76_s03_0 A=N126 B=term3_shifted[2]
XFE_RC_272_0 AO22 $PINS O=N112 A1=term2_shifted[16] A2=FE_OFN297_s02_0 B1=N85
+ B2=FE_RN_6
XFE_RC_243_0 ND2 $PINS O=FE_RN_110_0 I1=term3_shifted[19] I2=FE_DBTN24_s03_0
XFE_RC_242_0 ND2 $PINS O=FE_RN_111_0 I1=N143 I2=FE_OFN414_s03_0
XFE_RC_241_0 ND2P $PINS O=N170 I1=FE_RN_111_0 I2=FE_RN_110_0
XFE_RC_208_0 OR2 $PINS O=FE_RN_97_0 I1=FE_OFN400_s02_0 I2=n9
XFE_RC_207_0 ND2 $PINS O=FE_RN_98_0 I1=N70 I2=FE_OFN400_s02_0
XFE_RC_206_0 ND2P $PINS O=N97 I1=FE_RN_98_0 I2=FE_RN_97_0
XFE_RC_202_0 ND2 $PINS O=FE_RN_93_0 I1=term3_shifted[13] I2=FE_OFN415_s03_0
XFE_RC_201_0 ND2 $PINS O=FE_RN_94_0 I1=N137 I2=FE_OFN414_s03_0
XFE_RC_200_0 ND2 $PINS O=N164 I1=FE_RN_94_0 I2=FE_RN_93_0
XFE_OCPC8_FE_OFN237_mac_in_imag_6 BUF3 $PINS O=FE_OCPN7_FE_OFN237_mac_in_imag_6
+ I=x_in[6]
XFE_RC_135_0 AO22 $PINS O=N109 A1=term2_shifted[13] A2=FE_OFN297_s02_0 B1=N82
+ B2=FE_OFN296_s02_0
XFE_RC_74_0 INV1S $PINS O=FE_RN_44_0 I=n43
XFE_RC_73_0 OR3B2 $PINS O=n57 I1=FE_RN_44_0 B1=term1_in[0] B2=n45
XFE_RC_64_0 AO22 $PINS O=N99 A1=term2_shifted[3] A2=FE_OFN399_s02_0 B1=N72
+ B2=FE_OFN400_s02_0
XFE_RC_11_0 ND2 $PINS O=FE_RN_7_0 I1=term3_shifted[5] I2=FE_OFN76_s03_0
XFE_RC_10_0 ND2 $PINS O=FE_RN_8_0 I1=N129 I2=FE_OFN164_s03_0
XFE_RC_9_0 ND2P $PINS O=N156 I1=FE_RN_8_0 I2=FE_RN_7_0
XFE_OFC889_FE_OFN57_h01_0 BUF1 $PINS O=FE_OFN493_FE_OFN57_h01_0
+ I=FE_OFN69_h01_0
XFE_OFC888_FE_OFN57_h01_0 BUF1 $PINS O=FE_OFN492_FE_OFN57_h01_0
+ I=FE_OFN69_h01_0
XFE_RC_4033_0 ND2 $PINS O=FE_RN_2597_0 I1=term3_shifted[18] I2=FE_DBTN24_s03_0
XFE_RC_4032_0 ND2 $PINS O=FE_RN_2598_0 I1=N142 I2=FE_OFN414_s03_0
XFE_RC_4031_0 ND2 $PINS O=N169 I1=FE_RN_2598_0 I2=FE_RN_2597_0
XFE_RC_4030_0 AO22 $PINS O=N114 A1=term2_shifted[18] A2=FE_OFN297_s02_0 B1=N87
+ B2=FE_RN_6
XFE_RC_3958_0 ND2 $PINS O=FE_RN_2571_0 I1=term2_shifted[20] I2=FE_OFN402_s02_0
XFE_RC_3957_0 ND2 $PINS O=FE_RN_2572_0 I1=N89 I2=FE_RN_6
XFE_RC_3956_0 ND2 $PINS O=N116 I1=FE_RN_2572_0 I2=FE_RN_2571_0
XFE_RC_3888_0 ND2 $PINS O=FE_RN_2544_0 I1=term2_shifted[21] I2=FE_OFN402_s02_0
XFE_RC_3887_0 ND2 $PINS O=FE_RN_2545_0 I1=N90 I2=FE_RN_6
XFE_RC_3886_0 ND2 $PINS O=N117 I1=FE_RN_2545_0 I2=FE_RN_2544_0
XFE_RC_3881_0 AOI22S $PINS O=n105 A1=term1_in[0] A2=FE_RN_44_0 B1=term1_in[1]
+ B2=n43
XFE_RC_3880_0 AO22 $PINS O=N60 A1=term1_shifted[19] A2=FE_DBTN25_s01_0 B1=N33
+ B2=FE_OFN390_s01_0
XFE_RC_3619_0 INV1S $PINS O=FE_RN_2363_0 I=shf1[1]
XFE_RC_3618_0 INV1S $PINS O=FE_RN_2364_0 I=sll_16/ML_int[1][2]
XFE_RC_3617_0 INV1S $PINS O=FE_RN_2365_0 I=shf1[1]
XFE_RC_3616_0 ND2P $PINS O=FE_RN_2366_0 I1=sll_16/ML_int[1][4] I2=FE_RN_2365_0
XFE_RC_3615_0 OAI12H $PINS O=sll_16/ML_int[2][4] A1=FE_RN_2366_0
+ B1=FE_RN_2364_0 B2=FE_RN_2363_0
XFE_RC_3583_0 ND2S $PINS O=FE_RN_2339_0 I1=term3_shifted[20] I2=FE_DBTN24_s03_0
XFE_RC_3582_0 ND2 $PINS O=FE_RN_2340_0 I1=N144 I2=FE_OFN414_s03_0
XFE_RC_3581_0 ND2P $PINS O=N171 I1=FE_RN_2340_0 I2=FE_RN_2339_0
XFE_RC_3452_0 INV1S $PINS O=FE_RN_2249_0 I=FE_RN_3
XFE_RC_3451_0 INV1S $PINS O=FE_RN_2250_0 I=n62
XFE_RC_3450_0 INV1S $PINS O=FE_RN_2251_0 I=FE_RN_3
XFE_RC_3449_0 ND2P $PINS O=FE_RN_2252_0 I1=sll_16/ML_int[2][4] I2=FE_RN_2251_0
XFE_RC_3448_0 OAI12H $PINS O=sll_16/ML_int[3][4] A1=FE_RN_2252_0
+ B1=FE_RN_2250_0 B2=FE_RN_2249_0
XFE_RC_8_0 OA12 $PINS O=N151 A1=N124 B1=sign3[0] B2=FE_OFN415_s03_0
XFE_RC_1_0 OA12 $PINS O=N96 A1=term2_shifted[0] B1=FE_OFN144_s02_0
+ B2=FE_OFN399_s02_0
XFE_OFC853_h01_1 INV1S $PINS O=n45 I=shf1[1]
XFE_OFC799_s01_0 INV1S $PINS O=FE_OFN389_s01_0 I=sign1[0]
XFE_OFC727_h03_1 BUF1 $PINS O=n22 I=FE_OFN79_h03_1
XFE_OFC720_s03_0 INV1S $PINS O=FE_OFN415_s03_0 I=sign3[0]
XFE_OFC719_s03_0 INV1S $PINS O=FE_DBTN24_s03_0 I=sign3[0]
XFE_OFC718_s03_0 BUF1 $PINS O=FE_OFN414_s03_0 I=sign3[0]
XFE_OFC717_sll_16_ML_int_2__3 INV2 $PINS O=n60 I=sll_16/ML_int[2][3]
XFE_OFC694_s02_0 INV1S $PINS O=FE_OFN402_s02_0 I=FE_RN_6
XFE_OFC691_s02_0 BUF1 $PINS O=FE_OFN400_s02_0 I=FE_OFN144_s02_0
XFE_OFC689_s02_0 INV1S $PINS O=FE_OFN399_s02_0 I=FE_OFN144_s02_0
XFE_OFC688_s02_0 INV1S $PINS O=FE_OFN297_s02_0 I=FE_OFN144_s02_0
XFE_OFC687_s02_0 BUF1 $PINS O=FE_OFN296_s02_0 I=FE_OFN144_s02_0
XFE_OFC686_s02_0 BUF1 $PINS O=FE_RN_6 I=FE_OFN144_s02_0
XFE_OFC666_s01_0 INV1S $PINS O=FE_OFN391_s01_0 I=FE_OFN388_s01_0
XFE_OFC665_s01_0 INV1S $PINS O=FE_OFN390_s01_0 I=FE_DBTN25_s01_0
XFE_OFC661_s01_0 INV1S $PINS O=FE_OFN388_s01_0 I=sign1[0]
XFE_OFC660_s01_0 INV1S $PINS O=FE_DBTN25_s01_0 I=sign1[0]
XFE_OFC632_h03_3 INV1S $PINS O=FE_OFN375_h03_3 I=FE_OFN77_h03_3
XFE_OFC631_h03_3 INV1S $PINS O=FE_RN_5 I=FE_OFN77_h03_3
XFE_OFC630_h03_3 INV1S $PINS O=n26 I=FE_OFN77_h03_3
XFE_OFC582_h01_1 BUF1 $PINS O=FE_OFN358_h01_1 I=shf1[1]
XFE_OFC577_h02_2 BUF1 $PINS O=FE_OFN353_h02_2 I=shf2[2]
XFE_OFC540_h01_0 INV1S $PINS O=n43 I=FE_OFN69_h01_0
XFE_OFC517_h02_1 INV1S $PINS O=n32 I=FE_OFN73_h02_1
XFE_OFC481_h01_3 INV1S $PINS O=n48 I=FE_OFN66_h01_3
XFE_OFC480_h01_3 INV1S $PINS O=FE_RN_4 I=FE_OFN66_h01_3
XFE_OFC454_h01_2 BUF1 $PINS O=FE_RN_3 I=FE_OFN67_h01_2
XFE_OFC380_pe_clear_d1 INV2 $PINS O=n104 I=clear
XFE_OFC279_h02_3 INV1S $PINS O=n36 I=FE_OFN71_h02_3
XFE_OFC278_h02_3 INV1S $PINS O=FE_RN_2 I=FE_OFN71_h02_3
XFE_OFC271_h03_2 INV1S $PINS O=FE_RN_1 I=FE_OFN78_h03_2
XFE_DBTC17_term2_shifted_2 INV2 $PINS O=FE_DBTN17_term2_shifted_2
+ I=term2_shifted[2]
XU110 AO22 $PINS O=base_val[13] A1=acc_reg[13] A2=n104 B1=clear
+ B2=FE_OFN60_FE_DBTN9_n336
XU115 AO22 $PINS O=N67 A1=FE_OFN390_s01_0 A2=N40 B1=term1_shifted[26]
+ B2=FE_DBTN25_s01_0
XU117 AO22 $PINS O=N65 A1=N38 A2=FE_OFN390_s01_0 B1=term1_shifted[24]
+ B2=FE_DBTN25_s01_0
XU118 AO22 $PINS O=N64 A1=N37 A2=FE_OFN390_s01_0 B1=term1_shifted[23]
+ B2=FE_DBTN25_s01_0
XU119 AO22 $PINS O=N63 A1=N36 A2=FE_OFN390_s01_0 B1=term1_shifted[22]
+ B2=FE_DBTN25_s01_0
XU120 AO22 $PINS O=N62 A1=N35 A2=FE_OFN390_s01_0 B1=term1_shifted[21]
+ B2=FE_DBTN25_s01_0
XU121 AO22P $PINS O=N61 A1=N34 A2=FE_OFN390_s01_0 B1=term1_shifted[20]
+ B2=FE_DBTN25_s01_0
XU123 AO22 $PINS O=N59 A1=N32 A2=FE_OFN391_s01_0 B1=term1_shifted[18]
+ B2=FE_DBTN25_s01_0
XU124 AO22 $PINS O=N58 A1=N31 A2=FE_OFN391_s01_0 B1=term1_shifted[17]
+ B2=FE_DBTN25_s01_0
XU125 AO22 $PINS O=N57 A1=N30 A2=FE_OFN391_s01_0 B1=term1_shifted[16]
+ B2=FE_DBTN25_s01_0
XU126 AO22 $PINS O=N56 A1=N29 A2=FE_OFN391_s01_0 B1=term1_shifted[15]
+ B2=FE_OFN388_s01_0
XU127 AO22 $PINS O=N55 A1=N28 A2=FE_OFN391_s01_0 B1=term1_shifted[14]
+ B2=FE_OFN388_s01_0
XU128 AO22 $PINS O=N54 A1=N27 A2=FE_OFN391_s01_0 B1=term1_shifted[13]
+ B2=FE_OFN388_s01_0
XU129 AO22 $PINS O=N53 A1=N26 A2=FE_OFN391_s01_0 B1=term1_shifted[12]
+ B2=FE_OFN388_s01_0
XU130 AO22 $PINS O=N52 A1=N25 A2=FE_OFN391_s01_0 B1=term1_shifted[11]
+ B2=FE_OFN388_s01_0
XU131 AO22 $PINS O=N51 A1=N24 A2=sign1[0] B1=term1_shifted[10]
+ B2=FE_OFN388_s01_0
XU133 AO22 $PINS O=N49 A1=N22 A2=sign1[0] B1=term1_shifted[8]
+ B2=FE_OFN389_s01_0
XU135 AO22 $PINS O=N47 A1=N20 A2=sign1[0] B1=term1_shifted[6]
+ B2=FE_OFN389_s01_0
XU137 AO22 $PINS O=N45 A1=sign1[0] A2=N18 B1=term1_shifted[4]
+ B2=FE_OFN389_s01_0
XU142 AO22 $PINS O=N177 A1=FE_OFN414_s03_0 A2=N150 B1=term3_shifted[26]
+ B2=FE_DBTN24_s03_0
XU144 AO22 $PINS O=N175 A1=N148 A2=FE_OFN414_s03_0 B1=term3_shifted[24]
+ B2=FE_DBTN24_s03_0
XU145 AO22 $PINS O=N174 A1=N147 A2=FE_OFN414_s03_0 B1=term3_shifted[23]
+ B2=FE_DBTN24_s03_0
XU146 AO22 $PINS O=N173 A1=N146 A2=FE_OFN414_s03_0 B1=term3_shifted[22]
+ B2=FE_DBTN24_s03_0
XU147 AO22 $PINS O=N172 A1=N145 A2=FE_OFN414_s03_0 B1=term3_shifted[21]
+ B2=FE_DBTN24_s03_0
XU151 AO22 $PINS O=N168 A1=N141 A2=FE_OFN414_s03_0 B1=term3_shifted[17]
+ B2=FE_DBTN24_s03_0
XU152 AO22 $PINS O=N167 A1=N140 A2=FE_OFN414_s03_0 B1=term3_shifted[16]
+ B2=FE_DBTN24_s03_0
XU153 AO22 $PINS O=N166 A1=N139 A2=FE_OFN414_s03_0 B1=term3_shifted[15]
+ B2=FE_OFN415_s03_0
XU154 AO22 $PINS O=N165 A1=N138 A2=FE_OFN414_s03_0 B1=term3_shifted[14]
+ B2=FE_OFN415_s03_0
XU156 AO22 $PINS O=N163 A1=N136 A2=FE_OFN414_s03_0 B1=term3_shifted[12]
+ B2=FE_OFN415_s03_0
XU157 AO22 $PINS O=N162 A1=N135 A2=FE_OFN164_s03_0 B1=term3_shifted[11]
+ B2=FE_OFN415_s03_0
XU160 AO22 $PINS O=N159 A1=N132 A2=FE_OFN164_s03_0 B1=term3_shifted[8]
+ B2=FE_OFN76_s03_0
XU162 AO22 $PINS O=N157 A1=N130 A2=FE_OFN164_s03_0 B1=term3_shifted[6]
+ B2=FE_OFN76_s03_0
XU164 AO22 $PINS O=N155 A1=N128 A2=FE_OFN164_s03_0 B1=term3_shifted[4]
+ B2=FE_OFN76_s03_0
XU169 AO22 $PINS O=N122 A1=N95 A2=FE_RN_6 B1=term2_shifted[26]
+ B2=FE_OFN402_s02_0
XU170 AO22 $PINS O=N121 A1=N94 A2=FE_RN_6 B1=term2_shifted[25]
+ B2=FE_OFN402_s02_0
XU171 AO22 $PINS O=N120 A1=N93 A2=FE_RN_6 B1=term2_shifted[24]
+ B2=FE_OFN402_s02_0
XU172 AO22 $PINS O=N119 A1=N92 A2=FE_RN_6 B1=term2_shifted[23]
+ B2=FE_OFN402_s02_0
XU173 AO22 $PINS O=N118 A1=N91 A2=FE_RN_6 B1=term2_shifted[22]
+ B2=FE_OFN402_s02_0
XU176 AO22 $PINS O=N115 A1=N88 A2=FE_RN_6 B1=term2_shifted[19]
+ B2=FE_OFN402_s02_0
XU178 AO22 $PINS O=N113 A1=N86 A2=FE_RN_6 B1=term2_shifted[17]
+ B2=FE_OFN297_s02_0
XU180 AO22 $PINS O=N111 A1=N84 A2=FE_OFN296_s02_0 B1=term2_shifted[15]
+ B2=FE_OFN297_s02_0
XU181 AO22 $PINS O=N110 A1=N83 A2=FE_OFN296_s02_0 B1=term2_shifted[14]
+ B2=FE_OFN297_s02_0
XU183 AO22 $PINS O=N108 A1=N81 A2=FE_OFN296_s02_0 B1=term2_shifted[12]
+ B2=FE_OFN297_s02_0
XU184 AO22 $PINS O=N107 A1=N80 A2=FE_OFN296_s02_0 B1=term2_shifted[11]
+ B2=FE_OFN297_s02_0
XU185 AO22 $PINS O=N106 A1=N79 A2=FE_OFN296_s02_0 B1=term2_shifted[10]
+ B2=FE_OFN297_s02_0
XU187 AO22 $PINS O=N104 A1=N77 A2=FE_OFN296_s02_0 B1=term2_shifted[8]
+ B2=FE_OFN399_s02_0
XU188 AO22 $PINS O=N103 A1=N76 A2=FE_OFN296_s02_0 B1=term2_shifted[7]
+ B2=FE_OFN399_s02_0
XU189 AO22 $PINS O=N102 A1=N75 A2=FE_OFN296_s02_0 B1=term2_shifted[6]
+ B2=FE_OFN399_s02_0
XU190 AO22 $PINS O=N101 A1=N74 A2=FE_OFN400_s02_0 B1=term2_shifted[5]
+ B2=FE_OFN399_s02_0
Xsll_18/M1_0_2 MUX2 $PINS O=sll_18/ML_int[1][2] S=FE_OFN80_h03_0 A=term3_in[2]
+ B=term3_in[1]
Xsll_18/M1_0_3 MUX2 $PINS O=sll_18/ML_int[1][3] S=FE_OFN80_h03_0 A=term3_in[3]
+ B=term3_in[2]
Xsll_18/M1_0_5 MUX2 $PINS O=sll_18/ML_int[1][5] S=FE_OFN80_h03_0 A=term3_in[5]
+ B=term3_in[4]
Xsll_18/M1_0_6 MUX2 $PINS O=sll_18/ML_int[1][6] S=FE_OFN80_h03_0 A=term3_in[6]
+ B=term3_in[5]
Xsll_18/M1_0_7 MUX2 $PINS O=sll_18/ML_int[1][7] S=FE_OFN80_h03_0 A=term3_in[7]
+ B=term3_in[6]
Xsll_18/M1_1_2 MUX2 $PINS O=sll_18/ML_int[2][2] S=FE_OFN79_h03_1
+ A=sll_18/ML_int[1][2] B=sll_18/ML_int[1][0]
Xsll_18/M1_1_3 MUX2 $PINS O=sll_18/ML_int[2][3] S=FE_OFN79_h03_1
+ A=sll_18/ML_int[1][3] B=sll_18/ML_int[1][1]
Xsll_18/M1_1_4 MUX2 $PINS O=sll_18/ML_int[2][4] S=FE_OFN79_h03_1
+ A=sll_18/ML_int[1][4] B=sll_18/ML_int[1][2]
Xsll_18/M1_1_5 MUX2 $PINS O=sll_18/ML_int[2][5] S=FE_OFN79_h03_1
+ A=sll_18/ML_int[1][5] B=sll_18/ML_int[1][3]
Xsll_18/M1_1_6 MUX2 $PINS O=sll_18/ML_int[2][6] S=FE_OFN79_h03_1
+ A=sll_18/ML_int[1][6] B=sll_18/ML_int[1][4]
Xsll_18/M1_1_7 MUX2 $PINS O=sll_18/ML_int[2][7] S=n22 A=sll_18/ML_int[1][7]
+ B=sll_18/ML_int[1][5]
Xsll_18/M1_1_8 MUX2 $PINS O=sll_18/ML_int[2][8] S=n22 A=sll_18/ML_int[1][8]
+ B=sll_18/ML_int[1][6]
Xsll_18/M1_2_4 MUX2 $PINS O=sll_18/ML_int[3][4] S=FE_RN_1 A=sll_18/ML_int[2][4]
+ B=n7
Xsll_18/M1_2_5 MUX2 $PINS O=sll_18/ML_int[3][5] S=FE_RN_1 A=sll_18/ML_int[2][5]
+ B=n82
Xsll_18/M1_2_6 MUX2 $PINS O=sll_18/ML_int[3][6] S=FE_RN_1 A=sll_18/ML_int[2][6]
+ B=sll_18/ML_int[2][2]
Xsll_18/M1_2_7 MUX2 $PINS O=sll_18/ML_int[3][7] S=FE_RN_1 A=sll_18/ML_int[2][7]
+ B=sll_18/ML_int[2][3]
Xsll_18/M1_2_8 MUX2 $PINS O=sll_18/ML_int[3][8] S=FE_RN_1 A=sll_18/ML_int[2][8]
+ B=sll_18/ML_int[2][4]
Xsll_18/M1_2_9 MUX2 $PINS O=sll_18/ML_int[3][9] S=FE_RN_1 A=sll_18/ML_int[2][9]
+ B=sll_18/ML_int[2][5]
Xsll_18/M1_2_10 MUX2 $PINS O=sll_18/ML_int[3][10] S=FE_RN_1
+ A=sll_18/ML_int[2][10] B=sll_18/ML_int[2][6]
Xsll_18/M1_3_8 MUX2 $PINS O=term3_shifted[8] S=FE_RN_5 A=sll_18/ML_int[3][8]
+ B=sll_18/ML_int[3][0]
Xsll_18/M1_3_9 MUX2 $PINS O=term3_shifted[9] S=FE_RN_5 A=sll_18/ML_int[3][9]
+ B=sll_18/ML_int[3][1]
Xsll_18/M1_3_10 MUX2 $PINS O=term3_shifted[10] S=FE_RN_5 A=sll_18/ML_int[3][10]
+ B=sll_18/ML_int[3][2]
Xsll_18/M1_3_11 MUX2 $PINS O=term3_shifted[11] S=FE_RN_5 A=sll_18/ML_int[3][11]
+ B=sll_18/ML_int[3][3]
Xsll_18/M1_3_12 MUX2 $PINS O=term3_shifted[12] S=FE_RN_5 A=sll_18/ML_int[3][12]
+ B=sll_18/ML_int[3][4]
Xsll_18/M1_3_13 MUX2 $PINS O=term3_shifted[13] S=FE_RN_5 A=sll_18/ML_int[3][13]
+ B=sll_18/ML_int[3][5]
Xsll_18/M1_3_14 MUX2 $PINS O=term3_shifted[14] S=FE_RN_5 A=sll_18/ML_int[3][14]
+ B=sll_18/ML_int[3][6]
Xsll_18/M1_3_23 MUX2 $PINS O=term3_shifted[23] S=n26 A=term3_in[26]
+ B=sll_18/ML_int[3][15]
Xsll_17/M1_0_3 MUX2 $PINS O=sll_17/ML_int[1][3] S=FE_OFN74_h02_0 A=term2_in[3]
+ B=term2_in[2]
Xsll_17/M1_0_4 MUX2 $PINS O=sll_17/ML_int[1][4] S=FE_OFN74_h02_0 A=term2_in[4]
+ B=term2_in[3]
Xsll_17/M1_0_5 MUX2 $PINS O=sll_17/ML_int[1][5] S=FE_OFN74_h02_0 A=term2_in[5]
+ B=term2_in[4]
Xsll_17/M1_0_6 MUX2 $PINS O=sll_17/ML_int[1][6] S=FE_OFN74_h02_0 A=term2_in[6]
+ B=term2_in[5]
Xsll_17/M1_0_7 MUX2 $PINS O=sll_17/ML_int[1][7] S=FE_OFN74_h02_0 A=term2_in[7]
+ B=term2_in[6]
Xsll_17/M1_1_2 MUX2 $PINS O=sll_17/ML_int[2][2] S=FE_OFN73_h02_1
+ A=sll_17/ML_int[1][2] B=sll_17/ML_int[1][0]
Xsll_17/M1_1_3 MUX2 $PINS O=sll_17/ML_int[2][3] S=FE_OFN73_h02_1
+ A=sll_17/ML_int[1][3] B=sll_17/ML_int[1][1]
Xsll_17/M1_1_4 MUX2 $PINS O=sll_17/ML_int[2][4] S=FE_OFN73_h02_1
+ A=sll_17/ML_int[1][4] B=sll_17/ML_int[1][2]
Xsll_17/M1_1_5 MUX2 $PINS O=sll_17/ML_int[2][5] S=FE_OFN73_h02_1
+ A=sll_17/ML_int[1][5] B=sll_17/ML_int[1][3]
Xsll_17/M1_1_6 MUX2 $PINS O=sll_17/ML_int[2][6] S=FE_OFN73_h02_1
+ A=sll_17/ML_int[1][6] B=sll_17/ML_int[1][4]
Xsll_17/M1_1_7 MUX2 $PINS O=sll_17/ML_int[2][7] S=FE_OFN73_h02_1
+ A=sll_17/ML_int[1][7] B=sll_17/ML_int[1][5]
Xsll_17/M1_1_8 MUX2 $PINS O=sll_17/ML_int[2][8] S=FE_OFN73_h02_1
+ A=sll_17/ML_int[1][8] B=sll_17/ML_int[1][6]
Xsll_17/M1_2_4 MUX2 $PINS O=sll_17/ML_int[3][4] S=FE_OFN72_h02_2
+ A=sll_17/ML_int[2][4] B=n14
Xsll_17/M1_2_5 MUX2 $PINS O=sll_17/ML_int[3][5] S=FE_OFN72_h02_2
+ A=sll_17/ML_int[2][5] B=n73
Xsll_17/M1_2_7 MUX2 $PINS O=sll_17/ML_int[3][7] S=shf2[2] A=sll_17/ML_int[2][7]
+ B=sll_17/ML_int[2][3]
Xsll_17/M1_2_8 MUX2 $PINS O=sll_17/ML_int[3][8] S=shf2[2] A=sll_17/ML_int[2][8]
+ B=sll_17/ML_int[2][4]
Xsll_17/M1_2_9 MUX2 $PINS O=sll_17/ML_int[3][9] S=shf2[2] A=sll_17/ML_int[2][9]
+ B=sll_17/ML_int[2][5]
Xsll_17/M1_2_10 MUX2 $PINS O=sll_17/ML_int[3][10] S=shf2[2]
+ A=sll_17/ML_int[2][10] B=sll_17/ML_int[2][6]
Xsll_17/M1_3_8 MUX2 $PINS O=term2_shifted[8] S=n36 A=sll_17/ML_int[3][8]
+ B=sll_17/ML_int[3][0]
Xsll_17/M1_3_9 MUX2 $PINS O=term2_shifted[9] S=n36 A=sll_17/ML_int[3][9]
+ B=sll_17/ML_int[3][1]
Xsll_17/M1_3_10 MUX2 $PINS O=term2_shifted[10] S=n36 A=sll_17/ML_int[3][10]
+ B=sll_17/ML_int[3][2]
Xsll_17/M1_3_11 MUX2 $PINS O=term2_shifted[11] S=n36 A=sll_17/ML_int[3][11]
+ B=sll_17/ML_int[3][3]
Xsll_17/M1_3_12 MUX2 $PINS O=term2_shifted[12] S=n36 A=sll_17/ML_int[3][12]
+ B=sll_17/ML_int[3][4]
Xsll_17/M1_3_13 MUX2 $PINS O=term2_shifted[13] S=n36 A=sll_17/ML_int[3][13]
+ B=sll_17/ML_int[3][5]
Xsll_17/M1_3_14 MUX2 $PINS O=term2_shifted[14] S=n36 A=sll_17/ML_int[3][14]
+ B=sll_17/ML_int[3][6]
Xsll_17/M1_3_23 MUX2 $PINS O=term2_shifted[23] S=FE_RN_2 A=term2_in[26]
+ B=sll_17/ML_int[3][15]
Xsll_16/M1_0_2 MUX2 $PINS O=sll_16/ML_int[1][2] S=FE_OFN69_h01_0 A=term1_in[2]
+ B=term1_in[1]
Xsll_16/M1_0_3 MUX2 $PINS O=sll_16/ML_int[1][3] S=FE_OFN493_FE_OFN57_h01_0
+ A=term1_in[3] B=term1_in[2]
Xsll_16/M1_0_4 MUX2 $PINS O=sll_16/ML_int[1][4] S=FE_OFN493_FE_OFN57_h01_0
+ A=term1_in[4] B=term1_in[3]
Xsll_16/M1_0_6 MUX2 $PINS O=sll_16/ML_int[1][6] S=FE_OFN69_h01_0 A=term1_in[6]
+ B=term1_in[5]
Xsll_16/M1_0_7 MUX2 $PINS O=sll_16/ML_int[1][7] S=FE_OFN69_h01_0 A=term1_in[7]
+ B=term1_in[6]
Xsll_16/M1_0_8 MUX2 $PINS O=sll_16/ML_int[1][8] S=FE_OFN69_h01_0 A=term1_in[8]
+ B=term1_in[7]
Xsll_16/M1_1_5 MUX2 $PINS O=sll_16/ML_int[2][5] S=shf1[1] A=sll_16/ML_int[1][5]
+ B=sll_16/ML_int[1][3]
Xsll_16/M1_1_6 MUX2 $PINS O=sll_16/ML_int[2][6] S=shf1[1] A=sll_16/ML_int[1][6]
+ B=sll_16/ML_int[1][4]
Xsll_16/M1_1_7 MUX2 $PINS O=sll_16/ML_int[2][7] S=shf1[1] A=sll_16/ML_int[1][7]
+ B=sll_16/ML_int[1][5]
Xsll_16/M1_1_8 MUX2 $PINS O=sll_16/ML_int[2][8] S=shf1[1] A=sll_16/ML_int[1][8]
+ B=sll_16/ML_int[1][6]
Xsll_16/M1_1_9 MUX2 $PINS O=sll_16/ML_int[2][9] S=FE_OFN358_h01_1
+ A=sll_16/ML_int[1][9] B=sll_16/ML_int[1][7]
Xsll_16/M1_2_5 MUX2 $PINS O=sll_16/ML_int[3][5] S=FE_RN_3 A=sll_16/ML_int[2][5]
+ B=n63
Xsll_16/M1_2_8 MUX2 $PINS O=sll_16/ML_int[3][8] S=FE_RN_3 A=sll_16/ML_int[2][8]
+ B=sll_16/ML_int[2][4]
Xsll_16/M1_2_9 MUX2 $PINS O=sll_16/ML_int[3][9] S=FE_RN_3 A=sll_16/ML_int[2][9]
+ B=sll_16/ML_int[2][5]
Xsll_16/M1_2_10 MUX2 $PINS O=sll_16/ML_int[3][10] S=FE_RN_3
+ A=sll_16/ML_int[2][10] B=sll_16/ML_int[2][6]
Xsll_16/M1_2_11 MUX2 $PINS O=sll_16/ML_int[3][11] S=FE_RN_3
+ A=sll_16/ML_int[2][11] B=sll_16/ML_int[2][7]
Xsll_16/M1_3_13 MUX2 $PINS O=term1_shifted[13] S=n48 A=sll_16/ML_int[3][13]
+ B=sll_16/ML_int[3][5]
Xsll_16/M1_3_14 MUX2 $PINS O=term1_shifted[14] S=n48 A=sll_16/ML_int[3][14]
+ B=sll_16/ML_int[3][6]
Xsll_16/M1_3_15 MUX2 $PINS O=term1_shifted[15] S=n48 A=sll_16/ML_int[3][15]
+ B=sll_16/ML_int[3][7]
Xsll_16/M1_3_23 MUX2 $PINS O=term1_shifted[23] S=FE_RN_4 A=term1_in[26]
+ B=sll_16/ML_int[3][15]
Xy_out_reg[9] QDFFRBN $PINS Q=y_out[9] D=FE_PHN1493_N244 CK=net2310
+ RB=FE_OFN31_i_rst_n
Xy_out_reg[8] QDFFRBN $PINS Q=y_out[8] D=FE_PHN1492_N243 CK=net2310
+ RB=FE_OFN52_i_rst_n
Xy_out_reg[7] QDFFRBN $PINS Q=y_out[7] D=FE_PHN1525_N242 CK=net2310
+ RB=FE_OFN52_i_rst_n
Xy_out_reg[6] QDFFRBN $PINS Q=y_out[6] D=FE_PHN1488_N241 CK=net2310
+ RB=FE_OFN52_i_rst_n
Xy_out_reg[5] QDFFRBN $PINS Q=y_out[5] D=FE_PHN1539_N240 CK=net2310
+ RB=FE_OFN52_i_rst_n
Xy_out_reg[4] QDFFRBN $PINS Q=y_out[4] D=FE_PHN1897_N239 CK=net2310
+ RB=FE_OFN52_i_rst_n
Xy_out_reg[3] QDFFRBN $PINS Q=y_out[3] D=FE_PHN1902_N238 CK=net2310
+ RB=FE_OFN31_i_rst_n
Xy_out_reg[2] QDFFRBN $PINS Q=y_out[2] D=FE_PHN1537_N237 CK=net2310
+ RB=FE_OFN31_i_rst_n
Xy_out_reg[1] QDFFRBN $PINS Q=y_out[1] D=FE_PHN1589_N236 CK=net2310
+ RB=FE_OFN31_i_rst_n
Xy_out_reg[0] QDFFRBN $PINS Q=y_out[0] D=N235 CK=net2310 RB=FE_OFN31_i_rst_n
Xacc_reg_reg[25] QDFFRBN $PINS Q=acc_reg[25] D=next_acc[25] CK=clk
+ RB=FE_OFN15_i_rst_n
Xy_out_reg[16] QDFFRBN $PINS Q=y_out[16] D=FE_PHN1422_N251 CK=net2310
+ RB=FE_OFN31_i_rst_n
Xacc_reg_reg[24] QDFFRBN $PINS Q=acc_reg[24] D=next_acc[24] CK=clk
+ RB=FE_OFN15_i_rst_n
Xy_out_reg[10] QDFFRBN $PINS Q=y_out[10] D=FE_PHN1532_N245 CK=net2310
+ RB=FE_OFN31_i_rst_n
Xy_out_reg[11] QDFFRBN $PINS Q=y_out[11] D=FE_PHN1535_N246 CK=net2310
+ RB=FE_OFN31_i_rst_n
Xy_out_reg[12] QDFFRBN $PINS Q=y_out[12] D=FE_PHN1874_N247 CK=net2310
+ RB=FE_OFN31_i_rst_n
Xy_out_reg[14] QDFFRBN $PINS Q=y_out[14] D=FE_PHN1879_N249 CK=net2310
+ RB=FE_OFN31_i_rst_n
Xy_out_reg[15] QDFFRBN $PINS Q=y_out[15] D=FE_PHN1877_N250 CK=net2310
+ RB=FE_OFN31_i_rst_n
Xy_out_reg[13] QDFFRBN $PINS Q=y_out[13] D=FE_PHN1869_N248 CK=net2310
+ RB=FE_OFN31_i_rst_n
Xacc_reg_reg[23] QDFFRBN $PINS Q=acc_reg[23] D=next_acc[23] CK=clk
+ RB=FE_OFN15_i_rst_n
Xacc_reg_reg[22] QDFFRBN $PINS Q=acc_reg[22] D=next_acc[22] CK=clk
+ RB=FE_OFN15_i_rst_n
Xacc_reg_reg[21] QDFFRBN $PINS Q=acc_reg[21] D=next_acc[21] CK=clk
+ RB=FE_OFN52_i_rst_n
Xacc_reg_reg[20] QDFFRBN $PINS Q=acc_reg[20] D=next_acc[20] CK=clk
+ RB=FE_OFN52_i_rst_n
Xacc_reg_reg[19] QDFFRBN $PINS Q=acc_reg[19] D=next_acc[19] CK=clk
+ RB=FE_OFN52_i_rst_n
Xacc_reg_reg[18] QDFFRBN $PINS Q=acc_reg[18] D=next_acc[18] CK=clk
+ RB=FE_OFN52_i_rst_n
Xacc_reg_reg[17] QDFFRBN $PINS Q=acc_reg[17] D=next_acc[17] CK=clk
+ RB=FE_OFN52_i_rst_n
Xacc_reg_reg[16] QDFFRBN $PINS Q=acc_reg[16] D=next_acc[16] CK=clk
+ RB=FE_OFN52_i_rst_n
Xacc_reg_reg[15] QDFFRBN $PINS Q=acc_reg[15] D=next_acc[15] CK=clk
+ RB=FE_OFN52_i_rst_n
Xacc_reg_reg[14] QDFFRBN $PINS Q=acc_reg[14] D=next_acc[14] CK=clk
+ RB=FE_OFN52_i_rst_n
Xacc_reg_reg[13] QDFFRBN $PINS Q=acc_reg[13] D=next_acc[13] CK=clk RB=i_rst_n
Xacc_reg_reg[12] QDFFRBN $PINS Q=acc_reg[12] D=next_acc[12] CK=clk RB=i_rst_n
Xacc_reg_reg[11] QDFFRBN $PINS Q=acc_reg[11] D=next_acc[11] CK=clk RB=i_rst_n
Xacc_reg_reg[10] QDFFRBN $PINS Q=acc_reg[10] D=next_acc[10] CK=clk RB=i_rst_n
Xacc_reg_reg[9] QDFFRBN $PINS Q=acc_reg[9] D=next_acc[9] CK=clk RB=i_rst_n
Xacc_reg_reg[8] QDFFRBN $PINS Q=acc_reg[8] D=next_acc[8] CK=clk RB=i_rst_n
Xacc_reg_reg[7] QDFFRBN $PINS Q=acc_reg[7] D=next_acc[7] CK=clk RB=i_rst_n
Xacc_reg_reg[6] QDFFRBN $PINS Q=acc_reg[6] D=next_acc[6] CK=clk RB=i_rst_n
Xacc_reg_reg[5] QDFFRBN $PINS Q=acc_reg[5] D=next_acc[5] CK=clk RB=i_rst_n
Xacc_reg_reg[4] QDFFRBN $PINS Q=acc_reg[4] D=next_acc[4] CK=clk RB=i_rst_n
Xacc_reg_reg[3] QDFFRBN $PINS Q=acc_reg[3] D=next_acc[3] CK=clk RB=i_rst_n
Xacc_reg_reg[2] QDFFRBN $PINS Q=acc_reg[2] D=next_acc[2] CK=clk RB=i_rst_n
Xacc_reg_reg[1] QDFFRBN $PINS Q=acc_reg[1] D=next_acc[1] CK=clk RB=i_rst_n
Xacc_reg_reg[0] QDFFRBS $PINS Q=acc_reg[0] D=FE_PHN1574_next_acc_0 CK=clk
+ RB=i_rst_n
Xacc_reg_reg[26] QDFFRBT $PINS Q=FE_PHN2163_N251 D=next_acc[26] CK=clk
+ RB=FE_OFN15_i_rst_n
XU3 MOAI1 $PINS O=N98 A1=FE_DBTN17_term2_shifted_2 A2=FE_OFN400_s02_0 B1=N71
+ B2=FE_OFN400_s02_0
XU4 ND2 $PINS O=n16 I1=term3_in[1] I2=n21
XU6 NR2P $PINS O=term2_shifted[1] I1=n70 I2=n69
XU8 ND2 $PINS O=n70 I1=n34 I2=FE_OFN71_h02_3
XU13 OR2 $PINS O=n59 I1=FE_RN_3 I2=n48
XU14 NR2 $PINS O=term3_in[3] I1=FE_OFN75_s03_1 I2=x_in[3]
XU15 AN2B1S $PINS O=n15 I1=shf3[1] B1=n79
XU16 MUX2 $PINS O=N248 S=stage_sel A=acc_reg[23] B=FE_PHN1422_N251
XU17 NR2P $PINS O=term1_in[2] I1=FE_OFN64_s01_1 I2=x_in[2]
XU18 NR2 $PINS O=term2_in[0] I1=FE_OFN70_s02_1 I2=x_in[0]
XU19 NR2P $PINS O=term2_shifted[0] I1=n13 I2=n1
XU20 NR2P $PINS O=term3_shifted[0] I1=n5 I2=n6
XU22 NR2 $PINS O=sll_18/ML_int[3][2] I1=FE_RN_1 I2=n81
XU23 INV2 $PINS O=n81 I=sll_18/ML_int[2][2]
XU24 MUX2 $PINS O=N250 S=stage_sel A=acc_reg[25] B=FE_PHN1422_N251
XU25 NR2 $PINS O=term2_in[2] I1=FE_OFN70_s02_1 I2=x_in[2]
XU27 NR2P $PINS O=term2_shifted[3] I1=n70 I2=n71
XU28 AN2B1T $PINS O=term3_shifted[3] I1=sll_18/ML_int[2][3] B1=n79
XU29 NR2 $PINS O=sll_16/ML_int[3][2] I1=FE_RN_3 I2=n61
XU30 INV2 $PINS O=n61 I=sll_16/ML_int[2][2]
XU31 MUX2 $PINS O=N249 S=stage_sel A=acc_reg[24] B=FE_PHN1422_N251
XU32 NR2 $PINS O=term1_in[1] I1=sign1[1] I2=x_in[1]
XU33 ND2 $PINS O=n1 I1=term2_in[0] I2=n31
XU35 AN2 $PINS O=sll_18/ML_int[3][0] I1=FE_OFN78_h03_2 I2=n7
XU36 MUX2 $PINS O=N247 S=stage_sel A=acc_reg[22] B=FE_PHN1422_N251
XU38 AO22 $PINS O=N152 A1=N125 A2=sign3[0] B1=term3_shifted[1]
+ B2=FE_OFN76_s03_0
XU39 INV2 $PINS O=n72 I=sll_17/ML_int[2][2]
XU40 OR2S $PINS O=n9 I1=n70 I2=n69
XU41 NR2P $PINS O=term3_shifted[2] I1=n79 I2=n81
XU45 INV2 $PINS O=n71 I=sll_17/ML_int[2][3]
XU49 NR2 $PINS O=term2_in[3] I1=FE_OFN70_s02_1 I2=x_in[3]
XU51 NR2P $PINS O=term1_in[0] I1=sign1[1] I2=x_in[0]
XU54 AO22 $PINS O=N154 A1=N127 A2=sign3[0] B1=term3_shifted[3]
+ B2=FE_OFN76_s03_0
XU55 AO22 $PINS O=N44 A1=N17 A2=sign1[0] B1=term1_shifted[3] B2=FE_OFN389_s01_0
XU60 MUX2 $PINS O=sll_16/ML_int[2][3] S=shf1[1] A=sll_16/ML_int[1][3]
+ B=sll_16/ML_int[1][1]
XU62 NR2P $PINS O=term3_in[0] I1=sign3[1] I2=x_in[0]
XU64 AN2 $PINS O=sll_18/ML_int[1][0] I1=term3_in[0] I2=n21
XU66 MOAI1H $PINS O=N42 A1=n11 A2=sign1[0] B1=N15 B2=sign1[0]
XU67 MUX2 $PINS O=sll_18/ML_int[1][4] S=FE_OFN80_h03_0 A=term3_in[4]
+ B=term3_in[3]
XU68 MUX2 $PINS O=term1_shifted[8] S=n48 A=sll_16/ML_int[3][8]
+ B=sll_16/ML_int[3][0]
XU69 MUX2S $PINS O=term1_shifted[9] S=n48 A=sll_16/ML_int[3][9]
+ B=sll_16/ML_int[3][1]
XU70 MUX2 $PINS O=term1_shifted[10] S=n48 A=sll_16/ML_int[3][10]
+ B=sll_16/ML_int[3][2]
XU71 MUX2S $PINS O=term1_shifted[11] S=n48 A=sll_16/ML_int[3][11]
+ B=sll_16/ML_int[3][3]
XU74 NR2 $PINS O=n14 I1=n1 I2=FE_OFN73_h02_1
XU75 AN2T $PINS O=term2_shifted[4] I1=sll_17/ML_int[3][4] I2=FE_OFN71_h02_3
XU80 AN2 $PINS O=sll_16/ML_int[1][0] I1=term1_in[0] I2=n43
XU83 MUX2 $PINS O=sll_16/ML_int[2][2] S=shf1[1] A=sll_16/ML_int[1][2]
+ B=sll_16/ML_int[1][0]
XU84 ND2 $PINS O=n79 I1=FE_OFN78_h03_2 I2=FE_OFN77_h03_3
XU85 INV1S $PINS O=n68 I=n14
XU87 NR2P $PINS O=term1_shifted[2] I1=n59 I2=n61
XU88 NR2P $PINS O=term2_shifted[2] I1=n70 I2=n72
XU89 AN2 $PINS O=term1_shifted[4] I1=sll_16/ML_int[3][4] I2=FE_OFN66_h01_3
XU90 AO22 $PINS O=N100 A1=N73 A2=FE_OFN400_s02_0 B1=term2_shifted[4]
+ B2=FE_OFN399_s02_0
XU91 AO22 $PINS O=N66 A1=N39 A2=FE_OFN390_s01_0 B1=term1_shifted[25]
+ B2=FE_DBTN25_s01_0
XU92 AO22 $PINS O=N176 A1=N149 A2=FE_OFN414_s03_0 B1=term3_shifted[25]
+ B2=FE_DBTN24_s03_0
XU98 NR2 $PINS O=term1_in[4] I1=FE_OFN64_s01_1 I2=x_in[4]
XU100 MUX2 $PINS O=sll_17/ML_int[1][1] S=n31 A=term2_in[0] B=term2_in[1]
XU105 MOAI1S $PINS O=N41 A1=N14 A2=FE_OFN389_s01_0 B1=term1_shifted[0]
+ B2=FE_OFN389_s01_0
XU107 AO22 $PINS O=N43 A1=term1_shifted[2] A2=FE_OFN389_s01_0 B1=N16
+ B2=sign1[0]
XU108 MUX2S $PINS O=sll_16/ML_int[3][6] S=FE_RN_3 A=sll_16/ML_int[2][6]
+ B=sll_16/ML_int[2][2]
XU111 OR2 $PINS O=n6 I1=n79 I2=FE_OFN79_h03_1
XU112 NR2 $PINS O=n7 I1=n5 I2=FE_OFN79_h03_1
XU113 MUX2S $PINS O=sll_17/ML_int[3][6] S=FE_OFN72_h02_2 A=sll_17/ML_int[2][6]
+ B=sll_17/ML_int[2][2]
XU116 MUX2S $PINS O=term1_shifted[12] S=n48 A=sll_16/ML_int[3][12]
+ B=sll_16/ML_int[3][4]
XU132 MUX2S $PINS O=sll_16/ML_int[3][7] S=FE_RN_3 A=sll_16/ML_int[2][7]
+ B=sll_16/ML_int[2][3]
XU134 OR2S $PINS O=n11 I1=n59 I2=n58
XU136 MUX2S $PINS O=sll_16/ML_int[1][5] S=FE_OFN69_h01_0 A=term1_in[5]
+ B=term1_in[4]
XU139 AO22 $PINS O=N46 A1=N19 A2=sign1[0] B1=term1_shifted[5]
+ B2=FE_OFN389_s01_0
XU140 AO22 $PINS O=N105 A1=N78 A2=FE_OFN296_s02_0 B1=term2_shifted[9]
+ B2=FE_OFN399_s02_0
XU141 AO22 $PINS O=N48 A1=N21 A2=sign1[0] B1=term1_shifted[7]
+ B2=FE_OFN389_s01_0
XU143 AO22 $PINS O=N158 A1=N131 A2=FE_OFN164_s03_0 B1=term3_shifted[7]
+ B2=FE_OFN76_s03_0
XU158 AO22 $PINS O=N50 A1=N23 A2=sign1[0] B1=term1_shifted[9]
+ B2=FE_OFN388_s01_0
XU159 AO22 $PINS O=N160 A1=N133 A2=FE_OFN164_s03_0 B1=term3_shifted[9]
+ B2=FE_OFN415_s03_0
XU163 OR2 $PINS O=n13 I1=n70 I2=FE_OFN73_h02_1
XU165 AN2 $PINS O=term3_shifted[1] I1=sll_18/ML_int[1][1] I2=n15
XU166 AN2 $PINS O=base_val[0] I1=acc_reg[0] I2=n104
XU167 MUX2S $PINS O=sll_17/ML_int[1][8] S=FE_OFN74_h02_0 A=term2_in[8]
+ B=term2_in[7]
XU182 MUX2S $PINS O=sll_18/ML_int[1][8] S=FE_OFN80_h03_0 A=term3_in[8]
+ B=term3_in[7]
XU186 MUX2S $PINS O=sll_17/ML_int[2][9] S=FE_OFN73_h02_1 A=sll_17/ML_int[1][9]
+ B=sll_17/ML_int[1][7]
XU191 MUX2S $PINS O=sll_17/ML_int[1][9] S=FE_OFN74_h02_0 A=term2_in[9]
+ B=term2_in[8]
XU192 MUX2S $PINS O=sll_18/ML_int[2][9] S=n22 A=sll_18/ML_int[1][9]
+ B=sll_18/ML_int[1][7]
XU193 MUX2S $PINS O=sll_18/ML_int[1][9] S=FE_OFN80_h03_0 A=term3_in[9]
+ B=term3_in[8]
XU194 MUX2S $PINS O=sll_16/ML_int[1][9] S=FE_OFN492_FE_OFN57_h01_0
+ A=term1_in[9] B=term1_in[8]
XU195 MUX2S $PINS O=sll_16/ML_int[2][10] S=FE_OFN358_h01_1
+ A=sll_16/ML_int[1][10] B=sll_16/ML_int[1][8]
XU196 MUX2S $PINS O=sll_16/ML_int[1][10] S=FE_OFN69_h01_0 A=term1_in[10]
+ B=term1_in[9]
XU197 MUX2S $PINS O=sll_18/ML_int[2][10] S=n22 A=sll_18/ML_int[1][10]
+ B=sll_18/ML_int[1][8]
XU198 MUX2S $PINS O=sll_18/ML_int[1][10] S=FE_OFN80_h03_0 A=term3_in[10]
+ B=term3_in[9]
XU199 MUX2S $PINS O=sll_17/ML_int[2][10] S=FE_OFN73_h02_1
+ A=sll_17/ML_int[1][10] B=sll_17/ML_int[1][8]
XU200 MUX2S $PINS O=sll_17/ML_int[1][10] S=FE_OFN74_h02_0 A=term2_in[10]
+ B=term2_in[9]
XU201 MUX2S $PINS O=sll_16/ML_int[2][11] S=FE_OFN358_h01_1
+ A=sll_16/ML_int[1][11] B=sll_16/ML_int[1][9]
XU202 MUX2S $PINS O=sll_16/ML_int[1][11] S=FE_OFN492_FE_OFN57_h01_0
+ A=term1_in[11] B=term1_in[10]
XU203 MUX2S $PINS O=sll_18/ML_int[3][11] S=FE_RN_1 A=sll_18/ML_int[2][11]
+ B=sll_18/ML_int[2][7]
XU204 MUX2S $PINS O=sll_18/ML_int[2][11] S=n22 A=sll_18/ML_int[1][11]
+ B=sll_18/ML_int[1][9]
XU205 MUX2S $PINS O=sll_18/ML_int[1][11] S=FE_OFN80_h03_0 A=term3_in[11]
+ B=term3_in[10]
XU206 MUX2S $PINS O=sll_17/ML_int[3][11] S=shf2[2] A=sll_17/ML_int[2][11]
+ B=sll_17/ML_int[2][7]
XU207 MUX2S $PINS O=sll_17/ML_int[2][11] S=FE_OFN73_h02_1
+ A=sll_17/ML_int[1][11] B=sll_17/ML_int[1][9]
XU208 MUX2S $PINS O=sll_17/ML_int[1][11] S=FE_OFN74_h02_0 A=term2_in[11]
+ B=term2_in[10]
XU209 MUX2S $PINS O=sll_16/ML_int[3][12] S=FE_RN_3 A=sll_16/ML_int[2][12]
+ B=sll_16/ML_int[2][8]
XU210 MUX2S $PINS O=sll_16/ML_int[2][12] S=FE_OFN358_h01_1
+ A=sll_16/ML_int[1][12] B=sll_16/ML_int[1][10]
XU211 MUX2 $PINS O=sll_16/ML_int[1][12] S=FE_OFN69_h01_0 A=term1_in[12]
+ B=term1_in[11]
XU212 MUX2S $PINS O=sll_18/ML_int[3][12] S=FE_RN_1 A=sll_18/ML_int[2][12]
+ B=sll_18/ML_int[2][8]
XU213 MUX2S $PINS O=sll_18/ML_int[2][12] S=n22 A=sll_18/ML_int[1][12]
+ B=sll_18/ML_int[1][10]
XU214 MUX2S $PINS O=sll_18/ML_int[1][12] S=FE_OFN80_h03_0 A=term3_in[12]
+ B=term3_in[11]
XU215 MUX2S $PINS O=sll_17/ML_int[3][12] S=FE_OFN353_h02_2
+ A=sll_17/ML_int[2][12] B=sll_17/ML_int[2][8]
XU216 MUX2S $PINS O=sll_17/ML_int[2][12] S=FE_OFN73_h02_1
+ A=sll_17/ML_int[1][12] B=sll_17/ML_int[1][10]
XU217 MUX2S $PINS O=sll_17/ML_int[1][12] S=FE_OFN74_h02_0 A=term2_in[12]
+ B=term2_in[11]
XU218 MUX2S $PINS O=sll_16/ML_int[3][13] S=FE_OFN67_h01_2
+ A=sll_16/ML_int[2][13] B=sll_16/ML_int[2][9]
XU219 MUX2S $PINS O=sll_16/ML_int[2][13] S=FE_OFN358_h01_1
+ A=sll_16/ML_int[1][13] B=sll_16/ML_int[1][11]
XU220 MUX2S $PINS O=sll_16/ML_int[1][13] S=FE_OFN69_h01_0 A=term1_in[13]
+ B=term1_in[12]
XU221 MUX2S $PINS O=sll_18/ML_int[3][13] S=FE_RN_1 A=sll_18/ML_int[2][13]
+ B=sll_18/ML_int[2][9]
XU222 MUX2S $PINS O=sll_18/ML_int[2][13] S=n22 A=sll_18/ML_int[1][13]
+ B=sll_18/ML_int[1][11]
XU223 MUX2S $PINS O=sll_18/ML_int[1][13] S=shf3[0] A=term3_in[13]
+ B=term3_in[12]
XU224 MUX2S $PINS O=sll_17/ML_int[3][13] S=FE_OFN353_h02_2
+ A=sll_17/ML_int[2][13] B=sll_17/ML_int[2][9]
XU225 MUX2S $PINS O=sll_17/ML_int[2][13] S=shf2[1] A=sll_17/ML_int[1][13]
+ B=sll_17/ML_int[1][11]
XU226 MUX2S $PINS O=sll_17/ML_int[1][13] S=FE_OFN74_h02_0 A=term2_in[13]
+ B=term2_in[12]
XU227 MUX2S $PINS O=sll_16/ML_int[3][14] S=FE_OFN67_h01_2
+ A=sll_16/ML_int[2][14] B=sll_16/ML_int[2][10]
XU228 MUX2S $PINS O=sll_16/ML_int[2][14] S=FE_OFN358_h01_1
+ A=sll_16/ML_int[1][14] B=sll_16/ML_int[1][12]
XU229 MUX2S $PINS O=sll_16/ML_int[1][14] S=FE_OFN69_h01_0 A=term1_in[14]
+ B=term1_in[13]
XU230 MUX2S $PINS O=sll_18/ML_int[3][14] S=FE_RN_1 A=sll_18/ML_int[2][14]
+ B=sll_18/ML_int[2][10]
XU231 MUX2S $PINS O=sll_18/ML_int[2][14] S=n22 A=sll_18/ML_int[1][14]
+ B=sll_18/ML_int[1][12]
XU232 MUX2S $PINS O=sll_18/ML_int[1][14] S=FE_OFN80_h03_0 A=term3_in[14]
+ B=term3_in[13]
XU233 MUX2S $PINS O=sll_17/ML_int[3][14] S=FE_OFN353_h02_2
+ A=sll_17/ML_int[2][14] B=sll_17/ML_int[2][10]
XU234 MUX2S $PINS O=sll_17/ML_int[2][14] S=FE_OFN73_h02_1
+ A=sll_17/ML_int[1][14] B=sll_17/ML_int[1][12]
XU235 MUX2S $PINS O=sll_17/ML_int[1][14] S=FE_OFN74_h02_0 A=term2_in[14]
+ B=term2_in[13]
XU236 MUX2S $PINS O=term1_shifted[16] S=FE_RN_4 A=sll_16/ML_int[3][16]
+ B=sll_16/ML_int[3][8]
XU237 MUX2S $PINS O=sll_16/ML_int[3][16] S=FE_OFN67_h01_2 A=n64
+ B=sll_16/ML_int[2][12]
XU238 MUX2S $PINS O=n64 S=FE_OFN358_h01_1 A=n67 B=sll_16/ML_int[1][14]
XU239 MUX2S $PINS O=term3_shifted[16] S=FE_OFN375_h03_3 A=sll_18/ML_int[3][16]
+ B=sll_18/ML_int[3][8]
XU240 MUX2S $PINS O=sll_18/ML_int[3][16] S=FE_RN_1 A=n83 B=sll_18/ML_int[2][12]
XU241 MUX2S $PINS O=n83 S=n22 A=n86 B=sll_18/ML_int[1][14]
XU242 MUX2S $PINS O=term2_shifted[16] S=n36 A=sll_17/ML_int[3][16]
+ B=sll_17/ML_int[3][8]
XU243 MUX2S $PINS O=sll_17/ML_int[3][16] S=FE_OFN353_h02_2 A=n74
+ B=sll_17/ML_int[2][12]
XU244 MUX2S $PINS O=n74 S=shf2[1] A=n77 B=sll_17/ML_int[1][14]
XU245 MUX2S $PINS O=sll_16/ML_int[3][15] S=FE_OFN67_h01_2
+ A=sll_16/ML_int[2][15] B=sll_16/ML_int[2][11]
XU246 MUX2S $PINS O=sll_16/ML_int[2][15] S=FE_OFN358_h01_1
+ A=sll_16/ML_int[1][15] B=sll_16/ML_int[1][13]
XU247 MUX2S $PINS O=sll_16/ML_int[1][15] S=shf1[0] A=term1_in[15]
+ B=term1_in[14]
XU248 MUX2S $PINS O=term3_shifted[15] S=FE_RN_5 A=sll_18/ML_int[3][15]
+ B=sll_18/ML_int[3][7]
XU249 MUX2S $PINS O=sll_18/ML_int[3][15] S=FE_RN_1 A=sll_18/ML_int[2][15]
+ B=sll_18/ML_int[2][11]
XU250 MUX2S $PINS O=sll_18/ML_int[2][15] S=n22 A=sll_18/ML_int[1][15]
+ B=sll_18/ML_int[1][13]
XU251 MUX2S $PINS O=sll_18/ML_int[1][15] S=shf3[0] A=term3_in[15]
+ B=term3_in[14]
XU252 MUX2S $PINS O=term2_shifted[15] S=n36 A=sll_17/ML_int[3][15]
+ B=sll_17/ML_int[3][7]
XU253 MUX2S $PINS O=sll_17/ML_int[3][15] S=FE_OFN353_h02_2
+ A=sll_17/ML_int[2][15] B=sll_17/ML_int[2][11]
XU254 MUX2S $PINS O=sll_17/ML_int[2][15] S=shf2[1] A=sll_17/ML_int[1][15]
+ B=sll_17/ML_int[1][13]
XU255 MUX2S $PINS O=sll_17/ML_int[1][15] S=shf2[0] A=term2_in[15]
+ B=term2_in[14]
XU256 MUX2S $PINS O=term1_shifted[17] S=FE_RN_4 A=sll_16/ML_int[3][17]
+ B=sll_16/ML_int[3][9]
XU257 MUX2S $PINS O=sll_16/ML_int[3][17] S=FE_OFN67_h01_2 A=n65
+ B=sll_16/ML_int[2][13]
XU258 MUX2S $PINS O=term3_shifted[17] S=FE_OFN375_h03_3 A=sll_18/ML_int[3][17]
+ B=sll_18/ML_int[3][9]
XU259 MUX2S $PINS O=sll_18/ML_int[3][17] S=FE_RN_1 A=n84 B=sll_18/ML_int[2][13]
XU260 MUX2S $PINS O=term2_shifted[17] S=FE_RN_2 A=sll_17/ML_int[3][17]
+ B=sll_17/ML_int[3][9]
XU261 MUX2S $PINS O=sll_17/ML_int[3][17] S=FE_OFN353_h02_2 A=n75
+ B=sll_17/ML_int[2][13]
XU262 MUX2S $PINS O=term1_shifted[18] S=FE_RN_4 A=sll_16/ML_int[3][18]
+ B=sll_16/ML_int[3][10]
XU263 MUX2S $PINS O=sll_16/ML_int[3][18] S=FE_OFN67_h01_2 A=n66
+ B=sll_16/ML_int[2][14]
XU264 MUX2S $PINS O=term3_shifted[18] S=FE_OFN375_h03_3 A=sll_18/ML_int[3][18]
+ B=sll_18/ML_int[3][10]
XU265 MUX2S $PINS O=sll_18/ML_int[3][18] S=FE_RN_1 A=n85 B=sll_18/ML_int[2][14]
XU266 MUX2S $PINS O=term2_shifted[18] S=FE_RN_2 A=sll_17/ML_int[3][18]
+ B=sll_17/ML_int[3][10]
XU267 MUX2S $PINS O=sll_17/ML_int[3][18] S=FE_OFN353_h02_2 A=n76
+ B=sll_17/ML_int[2][14]
XU268 MUX2S $PINS O=term1_shifted[20] S=FE_RN_4 A=sll_16/ML_int[3][20]
+ B=sll_16/ML_int[3][12]
XU269 MUX2S $PINS O=sll_16/ML_int[3][20] S=FE_OFN67_h01_2 A=term1_in[26] B=n64
XU270 MUX2S $PINS O=term1_shifted[19] S=FE_RN_4 A=sll_16/ML_int[3][19]
+ B=sll_16/ML_int[3][11]
XU271 MUX2S $PINS O=sll_16/ML_int[3][19] S=FE_OFN67_h01_2 A=term1_in[26]
+ B=sll_16/ML_int[2][15]
XU272 MUX2S $PINS O=term3_shifted[20] S=FE_OFN375_h03_3 A=sll_18/ML_int[3][20]
+ B=sll_18/ML_int[3][12]
XU273 MUX2S $PINS O=sll_18/ML_int[3][20] S=FE_RN_1 A=term3_in[26] B=n83
XU274 MUX2S $PINS O=term3_shifted[19] S=FE_OFN375_h03_3 A=sll_18/ML_int[3][19]
+ B=sll_18/ML_int[3][11]
XU275 MUX2S $PINS O=sll_18/ML_int[3][19] S=FE_RN_1 A=term3_in[26]
+ B=sll_18/ML_int[2][15]
XU276 MUX2S $PINS O=term2_shifted[20] S=FE_RN_2 A=sll_17/ML_int[3][20]
+ B=sll_17/ML_int[3][12]
XU277 MUX2S $PINS O=sll_17/ML_int[3][20] S=FE_OFN353_h02_2 A=term2_in[26] B=n74
XU278 MUX2S $PINS O=term2_shifted[19] S=FE_RN_2 A=sll_17/ML_int[3][19]
+ B=sll_17/ML_int[3][11]
XU279 MUX2S $PINS O=sll_17/ML_int[3][19] S=FE_OFN353_h02_2 A=term2_in[26]
+ B=sll_17/ML_int[2][15]
XU280 MUX2S $PINS O=term1_shifted[21] S=FE_RN_4 A=sll_16/ML_int[3][21]
+ B=sll_16/ML_int[3][13]
XU281 MUX2S $PINS O=sll_16/ML_int[3][21] S=FE_OFN67_h01_2 A=term1_in[26] B=n65
XU282 MUX2S $PINS O=term3_shifted[21] S=FE_OFN375_h03_3 A=sll_18/ML_int[3][21]
+ B=sll_18/ML_int[3][13]
XU283 MUX2S $PINS O=sll_18/ML_int[3][21] S=FE_RN_1 A=term3_in[26] B=n84
XU284 MUX2S $PINS O=term2_shifted[21] S=FE_RN_2 A=sll_17/ML_int[3][21]
+ B=sll_17/ML_int[3][13]
XU285 MUX2S $PINS O=sll_17/ML_int[3][21] S=FE_OFN353_h02_2 A=term2_in[26] B=n75
XU286 MUX2S $PINS O=term1_shifted[22] S=FE_RN_4 A=sll_16/ML_int[3][22]
+ B=sll_16/ML_int[3][14]
XU287 MUX2S $PINS O=sll_16/ML_int[3][22] S=FE_OFN67_h01_2 A=term1_in[26] B=n66
XU288 MUX2S $PINS O=term3_shifted[22] S=FE_OFN375_h03_3 A=sll_18/ML_int[3][22]
+ B=sll_18/ML_int[3][14]
XU289 MUX2S $PINS O=sll_18/ML_int[3][22] S=FE_RN_1 A=term3_in[26] B=n85
XU290 MUX2S $PINS O=term2_shifted[22] S=FE_RN_2 A=sll_17/ML_int[3][22]
+ B=sll_17/ML_int[3][14]
XU291 MUX2S $PINS O=sll_17/ML_int[3][22] S=FE_OFN353_h02_2 A=term2_in[26] B=n76
XU292 MUX2S $PINS O=term1_shifted[24] S=FE_RN_4 A=term1_in[26]
+ B=sll_16/ML_int[3][16]
XU293 MUX2S $PINS O=term3_shifted[24] S=n26 A=term3_in[26]
+ B=sll_18/ML_int[3][16]
XU294 MUX2S $PINS O=term2_shifted[24] S=FE_RN_2 A=term2_in[26]
+ B=sll_17/ML_int[3][16]
XU295 MUX2S $PINS O=term1_shifted[25] S=FE_RN_4 A=term1_in[26]
+ B=sll_16/ML_int[3][17]
XU296 MUX2S $PINS O=term3_shifted[25] S=n26 A=term3_in[26]
+ B=sll_18/ML_int[3][17]
XU297 MUX2S $PINS O=term2_shifted[25] S=FE_RN_2 A=term2_in[26]
+ B=sll_17/ML_int[3][17]
XU298 MUX2S $PINS O=term1_shifted[26] S=FE_RN_4 A=term1_in[26]
+ B=sll_16/ML_int[3][18]
XU299 MUX2S $PINS O=term3_shifted[26] S=n26 A=term3_in[26]
+ B=sll_18/ML_int[3][18]
XU300 MUX2S $PINS O=term2_shifted[26] S=FE_RN_2 A=term2_in[26]
+ B=sll_17/ML_int[3][18]
XU305 MUX2S $PINS O=FE_PHN1931_N235 S=FE_OFN60_FE_DBTN9_n336 A=acc_reg[10]
+ B=FE_PHN1409_acc_reg_14
XU306 MUX2S $PINS O=N236 S=FE_OFN60_FE_DBTN9_n336 A=FE_PHN2125_acc_reg_11
+ B=acc_reg[15]
XU307 MUX2S $PINS O=N237 S=FE_OFN60_FE_DBTN9_n336 A=acc_reg[12] B=acc_reg[16]
XU308 MUX2S $PINS O=N238 S=FE_OFN60_FE_DBTN9_n336 A=FE_PHN1528_acc_reg_13
+ B=acc_reg[17]
XU309 MUX2S $PINS O=N239 S=FE_OFN60_FE_DBTN9_n336 A=FE_PHN1409_acc_reg_14
+ B=acc_reg[18]
XU310 MUX2S $PINS O=N240 S=FE_OFN60_FE_DBTN9_n336 A=acc_reg[15] B=acc_reg[19]
XU311 MUX2S $PINS O=N242 S=FE_OFN60_FE_DBTN9_n336 A=acc_reg[17] B=acc_reg[21]
XU312 MUX2S $PINS O=N245 S=stage_sel A=acc_reg[20] B=acc_reg[24]
XU313 MUX2S $PINS O=N246 S=stage_sel A=acc_reg[21] B=acc_reg[25]
XU316 INV1S $PINS O=n62 I=n57
XU317 INV1S $PINS O=n82 I=n78
XU318 AO22 $PINS O=N161 A1=N134 A2=FE_OFN164_s03_0 B1=term3_shifted[10]
+ B2=FE_OFN415_s03_0
XU319 NR2 $PINS O=term1_in[5] I1=FE_OFN64_s01_1 I2=x_in[5]
XU320 NR2P $PINS O=term3_in[2] I1=FE_OFN75_s03_1 I2=x_in[2]
XU321 NR2 $PINS O=term2_in[5] I1=FE_OFN70_s02_1 I2=x_in[5]
XU322 NR2 $PINS O=term3_in[5] I1=FE_OFN75_s03_1 I2=x_in[5]
XU323 NR2 $PINS O=term2_in[4] I1=FE_OFN70_s02_1 I2=x_in[4]
XU324 NR2P $PINS O=term3_in[4] I1=FE_OFN75_s03_1 I2=x_in[4]
XU325 NR2 $PINS O=term1_in[6] I1=FE_OFN64_s01_1
+ I2=FE_OCPN7_FE_OFN237_mac_in_imag_6
XU326 NR2 $PINS O=term2_in[6] I1=FE_OFN70_s02_1
+ I2=FE_OCPN7_FE_OFN237_mac_in_imag_6
XU327 NR2 $PINS O=term3_in[6] I1=FE_OFN75_s03_1
+ I2=FE_OCPN7_FE_OFN237_mac_in_imag_6
XU328 NR2 $PINS O=term1_in[7] I1=FE_OFN64_s01_1 I2=x_in[7]
XU329 NR2 $PINS O=term2_in[7] I1=FE_OFN70_s02_1 I2=x_in[7]
XU330 NR2 $PINS O=term3_in[7] I1=FE_OFN75_s03_1 I2=x_in[7]
XU331 NR2 $PINS O=term1_in[8] I1=FE_OFN64_s01_1 I2=x_in[8]
XU332 NR2 $PINS O=term2_in[8] I1=FE_OFN70_s02_1 I2=x_in[8]
XU333 NR2 $PINS O=term3_in[8] I1=FE_OFN75_s03_1 I2=x_in[8]
XU334 NR2 $PINS O=term1_in[9] I1=FE_OFN64_s01_1 I2=x_in[9]
XU335 NR2 $PINS O=term2_in[9] I1=FE_OFN70_s02_1 I2=x_in[9]
XU336 NR2 $PINS O=term3_in[9] I1=FE_OFN75_s03_1 I2=x_in[9]
XU337 NR2 $PINS O=term1_in[10] I1=FE_OFN64_s01_1 I2=x_in[10]
XU338 NR2 $PINS O=term2_in[10] I1=FE_OFN70_s02_1 I2=x_in[10]
XU339 NR2 $PINS O=term3_in[10] I1=FE_OFN75_s03_1 I2=x_in[10]
XU344 NR2 $PINS O=term1_in[11] I1=FE_OFN64_s01_1 I2=x_in[11]
XU345 NR2 $PINS O=term2_in[11] I1=FE_OFN70_s02_1 I2=x_in[11]
XU346 NR2 $PINS O=term3_in[11] I1=FE_OFN75_s03_1 I2=x_in[11]
XU347 NR2 $PINS O=term1_in[12] I1=FE_OFN64_s01_1 I2=x_in[12]
XU348 NR2 $PINS O=term2_in[12] I1=FE_OFN70_s02_1 I2=x_in[12]
XU349 NR2 $PINS O=term3_in[12] I1=FE_OFN75_s03_1 I2=x_in[12]
XU350 NR2 $PINS O=term1_in[13] I1=FE_OFN64_s01_1 I2=x_in[13]
XU351 NR2 $PINS O=term2_in[13] I1=FE_OFN70_s02_1 I2=x_in[13]
XU352 NR2 $PINS O=term3_in[13] I1=FE_OFN75_s03_1 I2=x_in[13]
XU353 NR2 $PINS O=term1_in[14] I1=FE_OFN64_s01_1 I2=x_in[14]
XU354 NR2 $PINS O=term2_in[14] I1=FE_OFN70_s02_1 I2=x_in[14]
XU355 NR2 $PINS O=term3_in[14] I1=FE_OFN75_s03_1 I2=x_in[14]
XU356 NR2 $PINS O=term1_in[15] I1=FE_OFN64_s01_1 I2=x_in[15]
XU357 NR2 $PINS O=term1_in[26] I1=x_in[16] I2=FE_OFN64_s01_1
XU358 NR2 $PINS O=term2_in[15] I1=sign2[1] I2=x_in[15]
XU359 NR2 $PINS O=term3_in[15] I1=FE_OFN75_s03_1 I2=x_in[15]
XU360 NR2 $PINS O=term2_in[26] I1=x_in[16] I2=sign2[1]
XU361 NR2 $PINS O=term3_in[26] I1=x_in[16] I2=FE_OFN75_s03_1
XU365 INV1S $PINS O=n31 I=FE_OFN74_h02_0
XU368 INV1S $PINS O=n21 I=FE_OFN80_h03_0
XU371 INV1S $PINS O=n34 I=FE_OFN72_h02_2
XU387 AN2 $PINS O=base_val[1] I1=acc_reg[1] I2=n104
XU388 AN2 $PINS O=base_val[2] I1=acc_reg[2] I2=n104
XU389 MOAI1S $PINS O=base_val[9] A1=FE_OFN60_FE_DBTN9_n336 A2=n104
+ B1=acc_reg[9] B2=n104
XU390 AN2 $PINS O=base_val[10] I1=acc_reg[10] I2=n104
XU391 AN2 $PINS O=base_val[12] I1=acc_reg[12] I2=n104
XU392 AN2 $PINS O=base_val[14] I1=acc_reg[14] I2=n104
XU393 AN2 $PINS O=base_val[15] I1=acc_reg[15] I2=n104
XU394 AN2 $PINS O=base_val[11] I1=acc_reg[11] I2=n104
XU395 AN2 $PINS O=base_val[16] I1=acc_reg[16] I2=n104
XU396 AN2 $PINS O=base_val[17] I1=acc_reg[17] I2=n104
XU397 AN2 $PINS O=base_val[18] I1=acc_reg[18] I2=n104
XU398 AN2 $PINS O=base_val[8] I1=acc_reg[8] I2=n104
XU399 AN2 $PINS O=base_val[7] I1=acc_reg[7] I2=n104
XU400 AN2 $PINS O=base_val[19] I1=acc_reg[19] I2=n104
XU401 AN2 $PINS O=base_val[20] I1=acc_reg[20] I2=n104
XU402 AN2 $PINS O=base_val[6] I1=acc_reg[6] I2=n104
XU403 AN2 $PINS O=base_val[21] I1=acc_reg[21] I2=n104
XU404 AN2 $PINS O=base_val[5] I1=acc_reg[5] I2=n104
XU405 AN2 $PINS O=base_val[22] I1=acc_reg[22] I2=n104
XU406 AN2 $PINS O=base_val[23] I1=acc_reg[23] I2=n104
XU407 AN2 $PINS O=base_val[24] I1=acc_reg[24] I2=n104
XU408 AN2 $PINS O=base_val[4] I1=acc_reg[4] I2=n104
XU409 AN2 $PINS O=base_val[3] I1=acc_reg[3] I2=n104
XU410 AN2 $PINS O=base_val[25] I1=acc_reg[25] I2=n104
XU412 AN2 $PINS O=N234 I1=en I2=calc_done
XU413 AN2 $PINS O=base_val[26] I1=N251 I2=n104
XU415 INV1S $PINS O=n63 I=n58
XU416 INV1S $PINS O=n73 I=n69
XU417 NR2 $PINS O=sll_16/ML_int[3][0] I1=FE_RN_3 I2=n57
XU418 NR2 $PINS O=sll_16/ML_int[3][1] I1=FE_RN_3 I2=n58
XU419 NR2 $PINS O=sll_16/ML_int[3][3] I1=FE_RN_3 I2=n60
XU420 AN2 $PINS O=term1_shifted[5] I1=sll_16/ML_int[3][5] I2=FE_OFN66_h01_3
XU421 AN2 $PINS O=term1_shifted[6] I1=sll_16/ML_int[3][6] I2=FE_OFN66_h01_3
XU422 AN2 $PINS O=term1_shifted[7] I1=sll_16/ML_int[3][7] I2=FE_OFN66_h01_3
XU423 MUX2 $PINS O=n65 S=FE_OFN358_h01_1 A=term1_in[26] B=sll_16/ML_int[1][15]
XU424 MUX2 $PINS O=n66 S=FE_OFN358_h01_1 A=term1_in[26] B=n67
XU425 MUX2 $PINS O=n67 S=FE_OFN69_h01_0 A=term1_in[26] B=term1_in[15]
XU426 NR2 $PINS O=sll_17/ML_int[3][0] I1=FE_OFN72_h02_2 I2=n68
XU427 NR2 $PINS O=sll_17/ML_int[3][1] I1=FE_OFN72_h02_2 I2=n69
XU428 NR2 $PINS O=sll_17/ML_int[3][2] I1=FE_OFN72_h02_2 I2=n72
XU429 NR2 $PINS O=sll_17/ML_int[3][3] I1=FE_OFN72_h02_2 I2=n71
XU430 AN2 $PINS O=term2_shifted[5] I1=sll_17/ML_int[3][5] I2=FE_OFN71_h02_3
XU431 AN2 $PINS O=term2_shifted[6] I1=sll_17/ML_int[3][6] I2=FE_OFN71_h02_3
XU432 AN2 $PINS O=term2_shifted[7] I1=sll_17/ML_int[3][7] I2=FE_OFN71_h02_3
XU433 MUX2 $PINS O=n75 S=shf2[1] A=term2_in[26] B=sll_17/ML_int[1][15]
XU434 MUX2 $PINS O=n76 S=shf2[1] A=term2_in[26] B=n77
XU435 MUX2 $PINS O=n77 S=FE_OFN74_h02_0 A=term2_in[26] B=term2_in[15]
XU436 NR2 $PINS O=sll_18/ML_int[3][1] I1=FE_RN_1 I2=n78
XU438 AN2T $PINS O=term3_shifted[4] I1=sll_18/ML_int[3][4] I2=FE_OFN77_h03_3
XU439 AN2 $PINS O=term3_shifted[5] I1=sll_18/ML_int[3][5] I2=FE_OFN77_h03_3
XU440 AN2 $PINS O=term3_shifted[6] I1=sll_18/ML_int[3][6] I2=FE_OFN77_h03_3
XU441 AN2 $PINS O=term3_shifted[7] I1=sll_18/ML_int[3][7] I2=FE_OFN77_h03_3
XU442 MUX2 $PINS O=n84 S=n22 A=term3_in[26] B=sll_18/ML_int[1][15]
XU443 MUX2 $PINS O=n85 S=n22 A=term3_in[26] B=n86
XU444 MUX2 $PINS O=n86 S=shf3[0] A=term3_in[26] B=term3_in[15]
XU445 MUX2 $PINS O=N241 S=FE_OFN60_FE_DBTN9_n336 A=acc_reg[16] B=acc_reg[20]
XU446 MUX2 $PINS O=N243 S=FE_OFN60_FE_DBTN9_n336 A=acc_reg[18] B=acc_reg[22]
XU447 MUX2 $PINS O=N244 S=FE_OFN60_FE_DBTN9_n336 A=acc_reg[19] B=acc_reg[23]
Xsll_17/M1_0_2 MUX2 $PINS O=sll_17/ML_int[1][2] S=FE_OFN74_h02_0 A=term2_in[2]
+ B=term2_in[1]
XU5 NR2 $PINS O=term1_shifted[3] I1=n59 I2=n60
XU7 NR2 $PINS O=term1_in[3] I1=FE_OFN64_s01_1 I2=x_in[3]
XU9 NR2P $PINS O=term3_in[1] I1=sign3[1] I2=x_in[1]
XU26 INV1S $PINS O=sll_16/ML_int[1][1] I=n105
XU34 NR2P $PINS O=term1_shifted[0] I1=n59 I2=n57
XU37 AN2 $PINS O=sll_18/ML_int[3][3] I1=FE_OFN78_h03_2 I2=sll_18/ML_int[2][3]
XU42 INV1S $PINS O=sll_17/ML_int[1][0] I=n1
XU46 ND2S $PINS O=n78 I1=sll_18/ML_int[1][1] I2=shf3[1]
XU47 ND2P $PINS O=n69 I1=sll_17/ML_int[1][1] I2=n32
XU50 INV1S $PINS O=n5 I=sll_18/ML_int[1][0]
XU57 ND2 $PINS O=n17 I1=term3_in[0] I2=FE_OFN80_h03_0
XU59 ND2 $PINS O=n58 I1=sll_16/ML_int[1][1] I2=n45
XU61 NR2 $PINS O=term2_in[1] I1=FE_OFN70_s02_1 I2=x_in[1]
XU65 ND2 $PINS O=sll_18/ML_int[1][1] I1=n17 I2=n16
XU73 NR2P $PINS O=term1_shifted[1] I1=n59 I2=n58
Xclk_gate_y_out_reg SNPS_CLOCK_GATE_HIGH_PE_Shift_Add_6 $PINS EN=N234
+ ENCLK=net2310 CLK=clk_clone1
Xsub_28_3 PE_Shift_Add_6_DW01_sub_0_DW01_sub_18 $PINS A[26]=net45585
+ A[25]=net45585 A[24]=net45585 A[23]=net45585 A[22]=net45585 A[21]=net45585
+ A[20]=net45585 A[19]=net45585 A[18]=net45585 A[17]=net45585 A[16]=net45585
+ A[15]=net45585 A[14]=net45585 A[13]=net45585 A[12]=net45585 A[11]=net45585
+ A[10]=net45585 A[9]=net45585 A[8]=net45585 A[7]=net45585 A[6]=net45585
+ A[5]=net45585 A[4]=net45585 A[3]=net45585 A[2]=net45585 A[1]=net45585
+ A[0]=net45585 B[26]=term3_shifted[26] B[25]=term3_shifted[25]
+ B[24]=term3_shifted[24] B[23]=term3_shifted[23] B[22]=term3_shifted[22]
+ B[21]=term3_shifted[21] B[20]=term3_shifted[20] B[19]=term3_shifted[19]
+ B[18]=term3_shifted[18] B[17]=term3_shifted[17] B[16]=term3_shifted[16]
+ B[15]=term3_shifted[15] B[14]=term3_shifted[14] B[13]=term3_shifted[13]
+ B[12]=term3_shifted[12] B[11]=term3_shifted[11] B[10]=term3_shifted[10]
+ B[9]=term3_shifted[9] B[8]=term3_shifted[8] B[7]=term3_shifted[7]
+ B[6]=term3_shifted[6] B[5]=term3_shifted[5] B[4]=term3_shifted[4]
+ B[3]=term3_shifted[3] B[2]=term3_shifted[2] B[1]=term3_shifted[1]
+ B[0]=term3_shifted[0] CI=net45585 DIFF[26]=N150 DIFF[25]=N149 DIFF[24]=N148
+ DIFF[23]=N147 DIFF[22]=N146 DIFF[21]=N145 DIFF[20]=N144 DIFF[19]=N143
+ DIFF[18]=N142 DIFF[17]=N141 DIFF[16]=N140 DIFF[15]=N139 DIFF[14]=N138
+ DIFF[13]=N137 DIFF[12]=N136 DIFF[11]=N135 DIFF[10]=N134 DIFF[9]=N133
+ DIFF[8]=N132 DIFF[7]=N131 DIFF[6]=N130 DIFF[5]=N129 DIFF[4]=N128 DIFF[3]=N127
+ DIFF[2]=N126 DIFF[1]=N125 DIFF[0]=N124 p1=term3_shifted[1]
Xsub_28_2 PE_Shift_Add_6_DW01_sub_1_DW01_sub_19 $PINS A[26]=net45585
+ A[25]=net45585 A[24]=net45585 A[23]=net45585 A[22]=net45585 A[21]=net45585
+ A[20]=net45585 A[19]=net45585 A[18]=net45585 A[17]=net45585 A[16]=net45585
+ A[15]=net45585 A[14]=net45585 A[13]=net45585 A[12]=net45585 A[11]=net45585
+ A[10]=net45585 A[9]=net45585 A[8]=net45585 A[7]=net45585 A[6]=net45585
+ A[5]=net45585 A[4]=net45585 A[3]=net45585 A[2]=net45585 A[1]=net45585
+ A[0]=net45585 B[26]=term2_shifted[26] B[25]=term2_shifted[25]
+ B[24]=term2_shifted[24] B[23]=term2_shifted[23] B[22]=term2_shifted[22]
+ B[21]=term2_shifted[21] B[20]=term2_shifted[20] B[19]=term2_shifted[19]
+ B[18]=term2_shifted[18] B[17]=term2_shifted[17] B[16]=term2_shifted[16]
+ B[15]=term2_shifted[15] B[14]=term2_shifted[14] B[13]=term2_shifted[13]
+ B[12]=term2_shifted[12] B[11]=term2_shifted[11] B[10]=term2_shifted[10]
+ B[9]=term2_shifted[9] B[8]=term2_shifted[8] B[7]=term2_shifted[7]
+ B[6]=term2_shifted[6] B[5]=term2_shifted[5] B[4]=term2_shifted[4]
+ B[3]=term2_shifted[3] B[2]=FE_DBTN17_term2_shifted_2 B[1]=term2_shifted[1]
+ B[0]=term2_shifted[0] CI=net45585 DIFF[26]=N95 DIFF[25]=N94 DIFF[24]=N93
+ DIFF[23]=N92 DIFF[22]=N91 DIFF[21]=N90 DIFF[20]=N89 DIFF[19]=N88 DIFF[18]=N87
+ DIFF[17]=N86 DIFF[16]=N85 DIFF[15]=N84 DIFF[14]=N83 DIFF[13]=N82 DIFF[12]=N81
+ DIFF[11]=N80 DIFF[10]=N79 DIFF[9]=N78 DIFF[8]=N77 DIFF[7]=N76 DIFF[6]=N75
+ DIFF[5]=N74 DIFF[4]=N73 DIFF[3]=N72 DIFF[2]=N71 DIFF[1]=N70 DIFF[0]=N69
Xsub_28 PE_Shift_Add_6_DW01_sub_2_DW01_sub_20 $PINS A[26]=net45585
+ A[25]=net45585 A[24]=net45585 A[23]=net45585 A[22]=net45585 A[21]=net45585
+ A[20]=net45585 A[19]=net45585 A[18]=net45585 A[17]=net45585 A[16]=net45585
+ A[15]=net45585 A[14]=net45585 A[13]=net45585 A[12]=net45585 A[11]=net45585
+ A[10]=net45585 A[9]=net45585 A[8]=net45585 A[7]=net45585 A[6]=net45585
+ A[5]=net45585 A[4]=net45585 A[3]=net45585 A[2]=net45585 A[1]=net45585
+ A[0]=net45585 B[26]=term1_shifted[26] B[25]=term1_shifted[25]
+ B[24]=term1_shifted[24] B[23]=term1_shifted[23] B[22]=term1_shifted[22]
+ B[21]=term1_shifted[21] B[20]=term1_shifted[20] B[19]=term1_shifted[19]
+ B[18]=term1_shifted[18] B[17]=term1_shifted[17] B[16]=term1_shifted[16]
+ B[15]=term1_shifted[15] B[14]=term1_shifted[14] B[13]=term1_shifted[13]
+ B[12]=term1_shifted[12] B[11]=term1_shifted[11] B[10]=term1_shifted[10]
+ B[9]=term1_shifted[9] B[8]=term1_shifted[8] B[7]=term1_shifted[7]
+ B[6]=term1_shifted[6] B[5]=term1_shifted[5] B[4]=term1_shifted[4]
+ B[3]=term1_shifted[3] B[2]=term1_shifted[2] B[1]=term1_shifted[1]
+ B[0]=term1_shifted[0] CI=net45585 DIFF[26]=N40 DIFF[25]=N39 DIFF[24]=N38
+ DIFF[23]=N37 DIFF[22]=N36 DIFF[21]=N35 DIFF[20]=N34 DIFF[19]=N33 DIFF[18]=N32
+ DIFF[17]=N31 DIFF[16]=N30 DIFF[15]=N29 DIFF[14]=N28 DIFF[13]=N27 DIFF[12]=N26
+ DIFF[11]=N25 DIFF[10]=N24 DIFF[9]=N23 DIFF[8]=N22 DIFF[7]=N21 DIFF[6]=N20
+ DIFF[5]=N19 DIFF[4]=N18 DIFF[3]=N17 DIFF[2]=N16 DIFF[1]=N15 DIFF[0]=N14
Xadd_1_root_add_0_root_add_28_3 PE_Shift_Add_6_DW01_add_2_DW01_add_25 $PINS
+ A[26]=N67 A[25]=N66 A[24]=N65 A[23]=N64 A[22]=N63 A[21]=N62 A[20]=N61 A[19]=N60
+ A[18]=N59 A[17]=N58 A[16]=N57 A[15]=N56 A[14]=N55 A[13]=N54 A[12]=N53 A[11]=N52
+ A[10]=N51 A[9]=N50 A[8]=N49 A[7]=N48 A[6]=N47 A[5]=N46 A[4]=N45 A[3]=N44
+ A[2]=N43 A[1]=N42 A[0]=N41 B[26]=N177 B[25]=N176 B[24]=N175 B[23]=N174
+ B[22]=N173 B[21]=N172 B[20]=N171 B[19]=N170 B[18]=N169 B[17]=N168 B[16]=N167
+ B[15]=N166 B[14]=N165 B[13]=N164 B[12]=N163 B[11]=N162 B[10]=N161 B[9]=N160
+ B[8]=N159 B[7]=N158 B[6]=N157 B[5]=N156 B[4]=N155 B[3]=N154 B[2]=N153 B[1]=N152
+ B[0]=N151 CI=net45585 SUM[26]=N204 SUM[25]=N203 SUM[24]=N202 SUM[23]=N201
+ SUM[22]=N200 SUM[21]=N199 SUM[20]=N198 SUM[19]=N197 SUM[18]=N196 SUM[17]=N195
+ SUM[16]=N194 SUM[15]=N193 SUM[14]=N192 SUM[13]=N191 SUM[12]=N190 SUM[11]=N189
+ SUM[10]=N188 SUM[9]=N187 SUM[8]=N186 SUM[7]=N185 SUM[6]=N184 SUM[5]=N183
+ SUM[4]=N182 SUM[3]=N181 SUM[2]=N180 SUM[1]=N179 SUM[0]=N178
Xadd_2_root_add_0_root_add_28_3 PE_Shift_Add_6_DW01_add_1_DW01_add_24 $PINS
+ A[26]=base_val[26] A[25]=base_val[25] A[24]=base_val[24] A[23]=base_val[23]
+ A[22]=base_val[22] A[21]=base_val[21] A[20]=base_val[20] A[19]=base_val[19]
+ A[18]=base_val[18] A[17]=base_val[17] A[16]=base_val[16] A[15]=base_val[15]
+ A[14]=base_val[14] A[13]=base_val[13] A[12]=base_val[12] A[11]=base_val[11]
+ A[10]=base_val[10] A[9]=base_val[9] A[8]=base_val[8] A[7]=base_val[7]
+ A[6]=base_val[6] A[5]=base_val[5] A[4]=base_val[4] A[3]=base_val[3]
+ A[2]=base_val[2] A[1]=base_val[1] A[0]=base_val[0] B[26]=N122 B[25]=N121
+ B[24]=N120 B[23]=N119 B[22]=N118 B[21]=N117 B[20]=N116 B[19]=N115 B[18]=N114
+ B[17]=N113 B[16]=N112 B[15]=N111 B[14]=N110 B[13]=N109 B[12]=N108 B[11]=N107
+ B[10]=N106 B[9]=N105 B[8]=N104 B[7]=N103 B[6]=N102 B[5]=N101 B[4]=N100 B[3]=N99
+ B[2]=N98 B[1]=N97 B[0]=N96 CI=net45585 SUM[26]=N231 SUM[25]=N230 SUM[24]=N229
+ SUM[23]=N228 SUM[22]=N227 SUM[21]=N226 SUM[20]=N225 SUM[19]=N224 SUM[18]=N223
+ SUM[17]=N222 SUM[16]=N221 SUM[15]=N220 SUM[14]=N219 SUM[13]=N218 SUM[12]=N217
+ SUM[11]=N216 SUM[10]=N215 SUM[9]=N214 SUM[8]=N213 SUM[7]=N212 SUM[6]=N211
+ SUM[5]=N210 SUM[4]=N209 SUM[3]=N208 SUM[2]=N207 SUM[1]=N206 SUM[0]=N205
Xadd_0_root_add_0_root_add_28_3 PE_Shift_Add_6_DW01_add_0_DW01_add_23 $PINS
+ A[26]=N204 A[25]=N203 A[24]=N202 A[23]=N201 A[22]=N200 A[21]=N199 A[20]=N198
+ A[19]=N197 A[18]=N196 A[17]=N195 A[16]=N194 A[15]=N193 A[14]=N192 A[13]=N191
+ A[12]=N190 A[11]=N189 A[10]=N188 A[9]=N187 A[8]=N186 A[7]=N185 A[6]=N184
+ A[5]=N183 A[4]=N182 A[3]=N181 A[2]=N180 A[1]=N179 A[0]=N178 B[26]=N231
+ B[25]=N230 B[24]=N229 B[23]=N228 B[22]=N227 B[21]=N226 B[20]=N225 B[19]=N224
+ B[18]=N223 B[17]=N222 B[16]=N221 B[15]=N220 B[14]=N219 B[13]=N218 B[12]=N217
+ B[11]=N216 B[10]=N215 B[9]=N214 B[8]=N213 B[7]=N212 B[6]=N211 B[5]=N210
+ B[4]=N209 B[3]=N208 B[2]=N207 B[1]=N206 B[0]=N205 CI=net45585
+ SUM[26]=next_acc[26] SUM[25]=next_acc[25] SUM[24]=next_acc[24]
+ SUM[23]=next_acc[23] SUM[22]=next_acc[22] SUM[21]=next_acc[21]
+ SUM[20]=next_acc[20] SUM[19]=next_acc[19] SUM[18]=next_acc[18]
+ SUM[17]=next_acc[17] SUM[16]=next_acc[16] SUM[15]=next_acc[15]
+ SUM[14]=next_acc[14] SUM[13]=next_acc[13] SUM[12]=next_acc[12]
+ SUM[11]=next_acc[11] SUM[10]=next_acc[10] SUM[9]=next_acc[9] SUM[8]=next_acc[8]
+ SUM[7]=next_acc[7] SUM[6]=next_acc[6] SUM[5]=next_acc[5] SUM[4]=next_acc[4]
+ SUM[3]=next_acc[3] SUM[2]=next_acc[2] SUM[1]=next_acc[1] SUM[0]=next_acc[0]
.ENDS

.SUBCKT SNPS_CLOCK_GATE_HIGH_PE_Shift_Add_5 EN ENCLK CLK
*.CONNECT ENCLK net2285
*.CONNECT net2286 EN
XFE_PHC1282_net2289 DELC $PINS O=net2289 I=FE_PHN1282_net2289
Xlatch QDBHN $PINS Q=FE_PHN1282_net2289 D=net2286 CKB=CLK
Xmain_gate AN2T $PINS O=net2285 I1=net2289 I2=CLK
.ENDS

.SUBCKT PE_Shift_Add_5_DW01_sub_0_DW01_sub_15 A[26] A[25] A[24] A[23] A[22]
+ A[21] A[20] A[19] A[18] A[17] A[16] A[15] A[14] A[13] A[12] A[11] A[10] A[9]
+ A[8] A[7] A[6] A[5] A[4] A[3] A[2] A[1] A[0] B[26] B[25] B[24] B[23] B[22]
+ B[21] B[20] B[19] B[18] B[17] B[16] B[15] B[14] B[13] B[12] B[11] B[10] B[9]
+ B[8] B[7] B[6] B[5] B[4] B[3] B[2] B[1] B[0] CI DIFF[26] DIFF[25] DIFF[24]
+ DIFF[23] DIFF[22] DIFF[21] DIFF[20] DIFF[19] DIFF[18] DIFF[17] DIFF[16]
+ DIFF[15] DIFF[14] DIFF[13] DIFF[12] DIFF[11] DIFF[10] DIFF[9] DIFF[8] DIFF[7]
+ DIFF[6] DIFF[5] DIFF[4] DIFF[3] DIFF[2] DIFF[1] DIFF[0] CO FE_RN_1960_0
+ FE_RN_1944_0 FE_RN_1922_0
*.CONNECT DIFF[0] B[0]
XFE_RC_309_0 XOR2HS $PINS O=DIFF[1] I1=n52 I2=n51
XFE_RC_2646_0 XOR2HS $PINS O=DIFF[2] I1=n3 I2=n50
XFE_OFC823_term3_shifted_6 INV1S $PINS O=n46 I=B[6]
XU3 INV2 $PINS O=n51 I=B[1]
XU4 INV2 $PINS O=n52 I=B[0]
XU6 INV1S $PINS O=n45 I=B[7]
XU7 INV1S $PINS O=n44 I=B[8]
XU8 INV1S $PINS O=n43 I=B[9]
XU13 AN2 $PINS O=n1 I1=n46 I2=n24
XU14 AN2 $PINS O=n2 I1=n45 I2=n1
XU15 ND2S $PINS O=n26 I1=n27 I2=n22
XU16 AN2 $PINS O=n3 I1=n52 I2=n51
XU17 AN2T $PINS O=n4 I1=n50 I2=n3
XU18 AN2T $PINS O=n5 I1=FE_RN_1922_0 I2=n4
XU19 AN2 $PINS O=n6 I1=n44 I2=n2
XU20 AN2 $PINS O=n7 I1=n43 I2=n6
XU21 AN2 $PINS O=n8 I1=n42 I2=n7
XU22 AN2 $PINS O=n9 I1=n41 I2=n8
XU23 AN2 $PINS O=n10 I1=n40 I2=n9
XU24 AN2 $PINS O=n11 I1=n39 I2=n10
XU25 AN2 $PINS O=n12 I1=n38 I2=n11
XU26 AN2 $PINS O=n13 I1=n37 I2=n12
XU27 AN2 $PINS O=n14 I1=n36 I2=n13
XU28 AN2 $PINS O=n15 I1=n35 I2=n14
XU29 AN2 $PINS O=n16 I1=n34 I2=n15
XU30 AN2 $PINS O=n17 I1=n33 I2=n16
XU31 AN2 $PINS O=n18 I1=n32 I2=n17
XU32 AN2 $PINS O=n19 I1=n31 I2=n18
XU33 AN2 $PINS O=n20 I1=n30 I2=n19
XU34 AN2 $PINS O=n21 I1=n29 I2=n20
XU35 AN2 $PINS O=n22 I1=n28 I2=n21
XU36 AN2T $PINS O=n23 I1=FE_RN_1960_0 I2=n5
XU37 AN2 $PINS O=n24 I1=FE_RN_1944_0 I2=n23
XU38 INV1S $PINS O=n42 I=B[10]
XU39 INV1S $PINS O=n41 I=B[11]
XU40 INV1S $PINS O=n40 I=B[12]
XU41 INV1S $PINS O=n39 I=B[13]
XU42 INV1S $PINS O=n38 I=B[14]
XU43 INV1S $PINS O=n37 I=B[15]
XU44 INV1S $PINS O=n36 I=B[16]
XU45 INV1S $PINS O=n35 I=B[17]
XU46 INV1S $PINS O=n34 I=B[18]
XU47 INV1S $PINS O=n33 I=B[19]
XU48 INV1S $PINS O=n32 I=B[20]
XU49 INV1S $PINS O=n31 I=B[21]
XU50 INV1S $PINS O=n30 I=B[22]
XU51 INV1S $PINS O=n29 I=B[23]
XU52 INV1S $PINS O=n28 I=B[24]
XU53 INV1S $PINS O=n27 I=B[25]
XU54 XOR2HS $PINS O=DIFF[3] I1=FE_RN_1922_0 I2=n4
XU55 XOR2HS $PINS O=DIFF[5] I1=FE_RN_1944_0 I2=n23
XU56 XOR2HS $PINS O=DIFF[4] I1=FE_RN_1960_0 I2=n5
XU57 XOR2HS $PINS O=DIFF[7] I1=n45 I2=n1
XU58 XOR2HS $PINS O=DIFF[6] I1=n46 I2=n24
XU59 XOR2HS $PINS O=DIFF[9] I1=n43 I2=n6
XU60 XOR2HS $PINS O=DIFF[8] I1=n44 I2=n2
XU61 XOR2HS $PINS O=DIFF[11] I1=n41 I2=n8
XU62 XOR2HS $PINS O=DIFF[10] I1=n42 I2=n7
XU63 XOR2HS $PINS O=DIFF[12] I1=n40 I2=n9
XU64 XOR2HS $PINS O=DIFF[13] I1=n39 I2=n10
XU65 XOR2HS $PINS O=DIFF[14] I1=n38 I2=n11
XU66 XOR2HS $PINS O=DIFF[15] I1=n37 I2=n12
XU67 XOR2HS $PINS O=DIFF[16] I1=n36 I2=n13
XU68 XOR2HS $PINS O=DIFF[17] I1=n35 I2=n14
XU69 XOR2HS $PINS O=DIFF[18] I1=n34 I2=n15
XU70 XOR2HS $PINS O=DIFF[19] I1=n33 I2=n16
XU71 XOR2HS $PINS O=DIFF[20] I1=n32 I2=n17
XU72 XOR2HS $PINS O=DIFF[21] I1=n31 I2=n18
XU73 XOR2HS $PINS O=DIFF[22] I1=n30 I2=n19
XU74 XOR2HS $PINS O=DIFF[23] I1=n29 I2=n20
XU75 XOR2HS $PINS O=DIFF[24] I1=n28 I2=n21
XU76 XOR2HS $PINS O=DIFF[25] I1=n27 I2=n22
XU77 XOR2HS $PINS O=DIFF[26] I1=B[26] I2=n26
XU9 INV2 $PINS O=n50 I=B[2]
.ENDS

.SUBCKT PE_Shift_Add_5_DW01_sub_1_DW01_sub_16 A[26] A[25] A[24] A[23] A[22]
+ A[21] A[20] A[19] A[18] A[17] A[16] A[15] A[14] A[13] A[12] A[11] A[10] A[9]
+ A[8] A[7] A[6] A[5] A[4] A[3] A[2] A[1] A[0] B[26] B[25] B[24] B[23] B[22]
+ B[21] B[20] B[19] B[18] B[17] B[16] B[15] B[14] B[13] B[12] B[11] B[10] B[9]
+ B[8] B[7] B[6] B[5] B[4] B[3] B[2] B[1] B[0] CI DIFF[26] DIFF[25] DIFF[24]
+ DIFF[23] DIFF[22] DIFF[21] DIFF[20] DIFF[19] DIFF[18] DIFF[17] DIFF[16]
+ DIFF[15] DIFF[14] DIFF[13] DIFF[12] DIFF[11] DIFF[10] DIFF[9] DIFF[8] DIFF[7]
+ DIFF[6] DIFF[5] DIFF[4] DIFF[3] DIFF[2] DIFF[1] DIFF[0] CO
XFE_RC_180_0 INV1S $PINS O=FE_RN_83_0 I=n49
XFE_RC_179_0 MXL2HS $PINS OB=DIFF[6] S=n25 A=FE_RN_83_0 B=n49
XFE_RC_3932_0 INV1S $PINS O=FE_RN_2562_0 I=n38
XFE_RC_3931_0 MXL2HS $PINS OB=DIFF[17] S=n15 A=FE_RN_2562_0 B=n38
XFE_OFC816_term2_shifted_7 INV1S $PINS O=n48 I=B[7]
XFE_OFC739_N69 INV2 $PINS O=n55 I=B[0]
XU3 OAI12HS $PINS O=DIFF[2] A1=n1 B1=B[2] B2=n4
XU4 ND2 $PINS O=n2 I1=n54 I2=B[0]
XU5 INV1S $PINS O=n52 I=B[3]
XU6 INV2 $PINS O=n54 I=B[1]
XU7 ND2S $PINS O=n3 I1=B[1] I2=n55
XU8 ND2S $PINS O=DIFF[1] I1=n2 I2=n3
XU9 INV1S $PINS O=n51 I=B[4]
XU10 INV1S $PINS O=n47 I=B[8]
XU11 INV1S $PINS O=n46 I=B[9]
XU12 INV1S $PINS O=n50 I=B[5]
XU13 INV1S $PINS O=n49 I=B[6]
XU16 ND2S $PINS O=n29 I1=n30 I2=n23
XU17 AN2 $PINS O=n4 I1=n54 I2=n55
XU18 AN2 $PINS O=n6 I1=n52 I2=n5
XU19 AN2T $PINS O=n7 I1=n47 I2=n27
XU20 AN2T $PINS O=n8 I1=n46 I2=n7
XU21 AN2 $PINS O=n9 I1=n45 I2=n8
XU22 AN2 $PINS O=n10 I1=n44 I2=n9
XU23 AN2 $PINS O=n11 I1=n43 I2=n10
XU24 AN2 $PINS O=n12 I1=n42 I2=n11
XU25 AN2 $PINS O=n13 I1=n41 I2=n12
XU26 AN2 $PINS O=n14 I1=n40 I2=n13
XU27 AN2 $PINS O=n15 I1=n39 I2=n14
XU28 AN2 $PINS O=n16 I1=n38 I2=n15
XU29 AN2 $PINS O=n17 I1=n37 I2=n16
XU30 AN2 $PINS O=n18 I1=n36 I2=n17
XU31 AN2 $PINS O=n19 I1=n35 I2=n18
XU32 AN2 $PINS O=n20 I1=n34 I2=n19
XU33 AN2 $PINS O=n21 I1=n33 I2=n20
XU34 AN2 $PINS O=n22 I1=n32 I2=n21
XU35 AN2 $PINS O=n23 I1=n31 I2=n22
XU36 AN2 $PINS O=n24 I1=n51 I2=n6
XU37 AN2 $PINS O=n25 I1=n50 I2=n24
XU38 AN2 $PINS O=n26 I1=n49 I2=n25
XU39 AN2 $PINS O=n27 I1=n26 I2=n48
XU40 INV1S $PINS O=n45 I=B[10]
XU41 INV1S $PINS O=n44 I=B[11]
XU42 INV1S $PINS O=n43 I=B[12]
XU43 INV1S $PINS O=n42 I=B[13]
XU44 INV1S $PINS O=n41 I=B[14]
XU45 INV1S $PINS O=n40 I=B[15]
XU46 INV1S $PINS O=n39 I=B[16]
XU47 INV1S $PINS O=n38 I=B[17]
XU48 INV1S $PINS O=n37 I=B[18]
XU49 INV1S $PINS O=n36 I=B[19]
XU50 INV1S $PINS O=n35 I=B[20]
XU51 INV1S $PINS O=n34 I=B[21]
XU52 INV1S $PINS O=n33 I=B[22]
XU53 INV1S $PINS O=n32 I=B[23]
XU54 INV1S $PINS O=n31 I=B[24]
XU55 INV1S $PINS O=n30 I=B[25]
XU57 XOR2HS $PINS O=DIFF[26] I1=B[26] I2=n29
XU58 XOR2HS $PINS O=DIFF[9] I1=n46 I2=n7
XU59 XOR2HS $PINS O=DIFF[10] I1=n45 I2=n8
XU60 XOR2HS $PINS O=DIFF[8] I1=n47 I2=n27
XU61 XOR2HS $PINS O=DIFF[7] I1=n48 I2=n26
XU63 XOR2HS $PINS O=DIFF[5] I1=n50 I2=n24
XU64 XOR2HS $PINS O=DIFF[4] I1=n51 I2=n6
XU65 XOR2HS $PINS O=DIFF[3] I1=n52 I2=n5
XU66 XOR2HS $PINS O=DIFF[11] I1=n44 I2=n9
XU67 XOR2HS $PINS O=DIFF[12] I1=n43 I2=n10
XU68 XOR2HS $PINS O=DIFF[13] I1=n42 I2=n11
XU69 XOR2HS $PINS O=DIFF[14] I1=n41 I2=n12
XU70 XOR2HS $PINS O=DIFF[15] I1=n40 I2=n13
XU71 XOR2HS $PINS O=DIFF[16] I1=n39 I2=n14
XU73 XOR2HS $PINS O=DIFF[18] I1=n37 I2=n16
XU74 XOR2HS $PINS O=DIFF[19] I1=n36 I2=n17
XU75 XOR2HS $PINS O=DIFF[20] I1=n35 I2=n18
XU76 XOR2HS $PINS O=DIFF[21] I1=n34 I2=n19
XU77 XOR2HS $PINS O=DIFF[22] I1=n33 I2=n20
XU78 XOR2HS $PINS O=DIFF[23] I1=n32 I2=n21
XU79 XOR2HS $PINS O=DIFF[24] I1=n31 I2=n22
XU80 XOR2HS $PINS O=DIFF[25] I1=n30 I2=n23
XU1 ND2 $PINS O=n1 I1=B[2] I2=n4
XU2 NR2 $PINS O=n5 I1=B[2] I2=n56
XU15 INV1S $PINS O=n56 I=n4
.ENDS

.SUBCKT PE_Shift_Add_5_DW01_sub_2_DW01_sub_17 A[26] A[25] A[24] A[23] A[22]
+ A[21] A[20] A[19] A[18] A[17] A[16] A[15] A[14] A[13] A[12] A[11] A[10] A[9]
+ A[8] A[7] A[6] A[5] A[4] A[3] A[2] A[1] A[0] B[26] B[25] B[24] B[23] B[22]
+ B[21] B[20] B[19] B[18] B[17] B[16] B[15] B[14] B[13] B[12] B[11] B[10] B[9]
+ B[8] B[7] B[6] B[5] B[4] B[3] B[2] B[1] B[0] CI DIFF[26] DIFF[25] DIFF[24]
+ DIFF[23] DIFF[22] DIFF[21] DIFF[20] DIFF[19] DIFF[18] DIFF[17] DIFF[16]
+ DIFF[15] DIFF[14] DIFF[13] DIFF[12] DIFF[11] DIFF[10] DIFF[9] DIFF[8] DIFF[7]
+ DIFF[6] DIFF[5] DIFF[4] DIFF[3] DIFF[2] DIFF[1] DIFF[0] CO FE_RN_1957_0
*.CONNECT DIFF[0] B[0]
XFE_RC_186_0 INV1S $PINS O=FE_RN_85_0 I=n45
XFE_RC_185_0 MXL2HS $PINS OB=DIFF[9] S=n6 A=FE_RN_85_0 B=n45
XFE_RC_3187_0 ND2 $PINS O=FE_RN_2059_0 I1=B[1] I2=n53
XFE_RC_3186_0 OAI12HS $PINS O=DIFF[1] A1=FE_RN_2059_0 B1=B[1] B2=n53
XFE_RC_2781_0 INV1S $PINS O=FE_RN_1770_0 I=FE_RN_1957_0
XFE_RC_2780_0 MXL2HS $PINS OB=DIFF[5] S=n23 A=FE_RN_1770_0 B=FE_RN_1957_0
XFE_OFC812_term1_shifted_3 INV2 $PINS O=n51 I=B[3]
XU1 ND2 $PINS O=n2 I1=B[2] I2=n3
XU3 NR2 $PINS O=n4 I1=B[2] I2=n1
XU4 INV1S $PINS O=n1 I=n3
XU5 OAI12HS $PINS O=DIFF[2] A1=n2 B1=B[2] B2=n3
XU9 XOR2HS $PINS O=DIFF[3] I1=n51 I2=n4
XU11 INV1S $PINS O=n47 I=B[7]
XU12 INV1S $PINS O=n48 I=B[6]
XU13 INV1S $PINS O=n46 I=B[8]
XU14 INV1S $PINS O=n45 I=B[9]
XU15 ND2S $PINS O=n28 I1=n29 I2=n22
XU17 AN2 $PINS O=n5 I1=n51 I2=n4
XU18 XOR2HS $PINS O=DIFF[8] I1=n46 I2=n26
XU20 AN2 $PINS O=n6 I1=n46 I2=n26
XU21 XOR2HS $PINS O=DIFF[10] I1=n44 I2=n7
XU22 AN2 $PINS O=n7 I1=n45 I2=n6
XU23 XOR2HS $PINS O=DIFF[11] I1=n43 I2=n8
XU24 AN2 $PINS O=n8 I1=n44 I2=n7
XU25 XOR2HS $PINS O=DIFF[12] I1=n42 I2=n9
XU26 AN2 $PINS O=n9 I1=n43 I2=n8
XU27 XOR2HS $PINS O=DIFF[13] I1=n41 I2=n10
XU28 AN2 $PINS O=n10 I1=n42 I2=n9
XU29 XOR2HS $PINS O=DIFF[14] I1=n40 I2=n11
XU30 AN2 $PINS O=n11 I1=n41 I2=n10
XU31 XOR2HS $PINS O=DIFF[15] I1=n39 I2=n12
XU32 AN2 $PINS O=n12 I1=n40 I2=n11
XU33 XOR2HS $PINS O=DIFF[16] I1=n38 I2=n13
XU34 AN2 $PINS O=n13 I1=n39 I2=n12
XU35 XOR2HS $PINS O=DIFF[17] I1=n37 I2=n14
XU36 AN2 $PINS O=n14 I1=n38 I2=n13
XU37 XOR2HS $PINS O=DIFF[18] I1=n36 I2=n15
XU38 AN2 $PINS O=n15 I1=n37 I2=n14
XU39 XOR2HS $PINS O=DIFF[19] I1=n35 I2=n16
XU40 AN2 $PINS O=n16 I1=n36 I2=n15
XU41 XOR2HS $PINS O=DIFF[20] I1=n34 I2=n17
XU42 AN2 $PINS O=n17 I1=n35 I2=n16
XU43 XOR2HS $PINS O=DIFF[21] I1=n33 I2=n18
XU44 AN2 $PINS O=n18 I1=n34 I2=n17
XU45 XOR2HS $PINS O=DIFF[22] I1=n32 I2=n19
XU46 AN2 $PINS O=n19 I1=n33 I2=n18
XU47 XOR2HS $PINS O=DIFF[23] I1=n31 I2=n20
XU48 AN2 $PINS O=n20 I1=n32 I2=n19
XU49 AN2 $PINS O=n21 I1=n31 I2=n20
XU50 AN2 $PINS O=n22 I1=n30 I2=n21
XU51 XOR2HS $PINS O=DIFF[24] I1=n30 I2=n21
XU52 XOR2HS $PINS O=DIFF[25] I1=n29 I2=n22
XU53 XOR2HS $PINS O=DIFF[4] I1=n50 I2=n5
XU55 AN2T $PINS O=n23 I1=n50 I2=n5
XU56 XOR2HS $PINS O=DIFF[6] I1=n48 I2=n24
XU57 AN2T $PINS O=n24 I1=FE_RN_1957_0 I2=n23
XU58 XOR2HS $PINS O=DIFF[7] I1=n47 I2=n25
XU59 AN2 $PINS O=n25 I1=n48 I2=n24
XU60 AN2 $PINS O=n26 I1=n47 I2=n25
XU61 INV1S $PINS O=n44 I=B[10]
XU62 INV1S $PINS O=n43 I=B[11]
XU63 INV1S $PINS O=n42 I=B[12]
XU64 INV1S $PINS O=n41 I=B[13]
XU65 INV1S $PINS O=n40 I=B[14]
XU66 INV1S $PINS O=n39 I=B[15]
XU67 INV1S $PINS O=n38 I=B[16]
XU68 INV1S $PINS O=n37 I=B[17]
XU69 INV1S $PINS O=n36 I=B[18]
XU70 INV1S $PINS O=n35 I=B[19]
XU71 INV1S $PINS O=n34 I=B[20]
XU72 INV1S $PINS O=n33 I=B[21]
XU73 INV1S $PINS O=n32 I=B[22]
XU74 INV1S $PINS O=n31 I=B[23]
XU75 INV1S $PINS O=n30 I=B[24]
XU76 INV1S $PINS O=n29 I=B[25]
XU78 XOR2HS $PINS O=DIFF[26] I1=B[26] I2=n28
XU2 INV2 $PINS O=n53 I=B[0]
XU7 NR2P $PINS O=n3 I1=DIFF[0] I2=B[1]
XU16 INV2 $PINS O=n50 I=B[4]
.ENDS

.SUBCKT PE_Shift_Add_5_DW01_add_2_DW01_add_34 A[26] A[25] A[24] A[23] A[22]
+ A[21] A[20] A[19] A[18] A[17] A[16] A[15] A[14] A[13] A[12] A[11] A[10] A[9]
+ A[8] A[7] A[6] A[5] A[4] A[3] A[2] A[1] A[0] B[26] B[25] B[24] B[23] B[22]
+ B[21] B[20] B[19] B[18] B[17] B[16] B[15] B[14] B[13] B[12] B[11] B[10] B[9]
+ B[8] B[7] B[6] B[5] B[4] B[3] B[2] B[1] B[0] CI SUM[26] SUM[25] SUM[24]
+ SUM[23] SUM[22] SUM[21] SUM[20] SUM[19] SUM[18] SUM[17] SUM[16] SUM[15]
+ SUM[14] SUM[13] SUM[12] SUM[11] SUM[10] SUM[9] SUM[8] SUM[7] SUM[6] SUM[5]
+ SUM[4] SUM[3] SUM[2] SUM[1] SUM[0] CO
XFE_RC_240_0 XOR3 $PINS O=SUM[19] I1=A[19] I2=B[19] I3=carry[19]
XFE_RC_239_0 MAO222P $PINS O=carry[20] A1=A[19] B1=B[19] C1=carry[19]
XFE_OCPC1180_carry_7 BUF1S $PINS O=FE_OCPN1180_carry_7 I=carry[7]
XFE_OCPC1115_N159 BUF1S $PINS O=FE_OCPN1115_N159 I=B[8]
XFE_OCPC1088_carry_3 BUF1S $PINS O=FE_OCPN1088_carry_3 I=carry[3]
XFE_OCPC1085_carry_22 BUF1S $PINS O=FE_OCPN1085_carry_22 I=carry[22]
XFE_OCPC1080_carry_5 BUF1S $PINS O=FE_OCPN1080_carry_5 I=carry[5]
XFE_OCPC1047_carry_3 BUF1CK $PINS O=FE_OCPN1047_carry_3 I=carry[3]
XFE_OCPC874_carry_9 BUF1 $PINS O=FE_OCPN478_carry_9 I=carry[9]
XFE_RC_3960_0 INV2 $PINS O=SUM[15] I=FE_RN_2573_0
XFE_RC_3959_0 XNR3 $PINS O=FE_RN_2573_0 I1=B[15] I2=A[15] I3=carry[15]
XFE_RC_3884_0 INV2 $PINS O=SUM[12] I=FE_RN_2543_0
XFE_RC_3883_0 XNR3 $PINS O=FE_RN_2543_0 I1=B[12] I2=A[12] I3=carry[12]
XFE_OCPC340_carry_21 BUF1CK $PINS O=FE_OCPN340_carry_21 I=carry[21]
XFE_RC_3333_0 XOR3 $PINS O=SUM[1] I1=A[1] I2=B[1] I3=n1
XFE_RC_3332_0 MAO222P $PINS O=carry[2] A1=A[1] B1=n1 C1=B[1]
XFE_RC_3160_0 ND2 $PINS O=FE_RN_2037_0 I1=B[5] I2=A[5]
XFE_RC_3159_0 ND2 $PINS O=FE_RN_2038_0 I1=carry[5] I2=A[5]
XFE_RC_3158_0 ND2 $PINS O=FE_RN_2039_0 I1=carry[5] I2=B[5]
XFE_RC_3157_0 ND3 $PINS O=n10 I1=FE_RN_2039_0 I2=FE_RN_2038_0 I3=FE_RN_2037_0
XFE_RC_2987_0 INV1S $PINS O=FE_RN_1915_0 I=FE_RN_1919_0
XFE_RC_2986_0 AOI12HS $PINS O=FE_RN_1916_0 A1=FE_RN_1915_0 B1=B[22] B2=A[22]
XFE_RC_2985_0 XNR2HS $PINS O=FE_RN_1917_0 I1=A[22] I2=B[22]
XFE_RC_2984_0 MXL2HS $PINS OB=SUM[22] S=FE_OCPN1085_carry_22 A=FE_RN_1917_0
+ B=FE_RN_1916_0
XFE_RC_2983_0 ND2 $PINS O=FE_RN_1918_0 I1=B[22] I2=A[22]
XFE_RC_2982_0 OR2P $PINS O=FE_RN_1919_0 I1=A[22] I2=B[22]
XFE_RC_2981_0 ND2P $PINS O=FE_RN_1920_0 I1=carry[22] I2=FE_RN_1919_0
XFE_RC_2980_0 ND2P $PINS O=carry[23] I1=FE_RN_1920_0 I2=FE_RN_1918_0
XFE_RC_2863_0 ND3P $PINS O=carry[7] I1=n14 I2=n15 I3=n16
XFE_RC_2821_0 INV1S $PINS O=FE_RN_1788_0 I=FE_RN_1792_0
XFE_RC_2820_0 ND2 $PINS O=FE_RN_1789_0 I1=FE_RN_1790_0 I2=carry[5]
XFE_RC_2819_0 ND2 $PINS O=carry[6] I1=FE_RN_1789_0 I2=FE_RN_1788_0
XFE_RC_2818_0 OR2 $PINS O=FE_RN_1790_0 I1=A[5] I2=B[5]
XFE_RC_2817_0 AN2B1S $PINS O=FE_RN_1791_0 I1=FE_RN_1790_0 B1=FE_RN_1792_0
XFE_RC_2816_0 AN2 $PINS O=FE_RN_1792_0 I1=B[5] I2=A[5]
XFE_RC_2814_0 INV1S $PINS O=FE_RN_1794_0 I=A[5]
XFE_RC_2813_0 INV1S $PINS O=FE_RN_1795_0 I=B[5]
XFE_RC_2812_0 ND2 $PINS O=FE_RN_1796_0 I1=FE_RN_1795_0 I2=FE_RN_1794_0
XFE_RC_2811_0 ND2S $PINS O=FE_RN_1797_0 I1=FE_RN_1796_0 I2=FE_RN_1788_0
XFE_RC_2810_0 MXL2HS $PINS OB=SUM[5] S=FE_OCPN1080_carry_5 A=FE_RN_1797_0
+ B=FE_RN_1791_0
XFE_RC_2753_0 NR3H $PINS O=FE_RN_1607_0 I1=carry[3] I2=B[3] I3=FE_RN_1602_0
XFE_RC_2705_0 ND3P $PINS O=carry[3] I1=n5 I2=n7 I3=n6
XFE_RC_2606_0 INV1S $PINS O=FE_RN_1637_0 I=B[21]
XFE_RC_2605_0 AN2B1S $PINS O=FE_RN_1638_0 I1=A[21] B1=FE_RN_1637_0
XFE_RC_2604_0 AN2B1S $PINS O=FE_RN_1639_0 I1=FE_RN_1643_0 B1=FE_RN_1638_0
XFE_RC_2603_0 XNR2HS $PINS O=FE_RN_1640_0 I1=A[21] I2=B[21]
XFE_RC_2602_0 MXL2H $PINS OB=SUM[21] S=FE_OCPN340_carry_21 A=FE_RN_1640_0
+ B=FE_RN_1639_0
XFE_RC_2601_0 ND2 $PINS O=FE_RN_1641_0 I1=B[21] I2=A[21]
XFE_RC_2599_0 OR2B1S $PINS O=FE_RN_1643_0 I1=A[21] B1=FE_RN_1637_0
XFE_RC_2598_0 ND2 $PINS O=FE_RN_1644_0 I1=carry[21] I2=FE_RN_1643_0
XFE_RC_2597_0 ND2P $PINS O=carry[22] I1=FE_RN_1644_0 I2=FE_RN_1641_0
XFE_RC_2559_0 INV1S $PINS O=FE_RN_1602_0 I=A[3]
XFE_RC_2558_0 OR3B2 $PINS O=FE_RN_1603_0 I1=B[3] B1=FE_RN_1602_0
+ B2=FE_OCPN1088_carry_3
XFE_RC_2556_0 OR3B2 $PINS O=FE_RN_1605_0 I1=FE_OCPN1047_carry_3 B1=B[3]
+ B2=FE_RN_1602_0
XFE_RC_2553_0 AOI13HS $PINS O=FE_RN_1608_0 A1=FE_RN_1607_0
+ B1=FE_OCPN1047_carry_3 B2=A[3] B3=B[3]
XFE_RC_2552_0 ND3P $PINS O=SUM[3] I1=FE_RN_1608_0 I2=FE_RN_1605_0
+ I3=FE_RN_1603_0
XFE_RC_2359_0 INV1S $PINS O=FE_RN_1446_0 I=carry[20]
XFE_RC_2358_0 INV1S $PINS O=FE_RN_1447_0 I=B[20]
XFE_RC_2356_0 ND2 $PINS O=FE_RN_1449_0 I1=FE_RN_1447_0 I2=A[20]
XFE_RC_2355_0 OAI12HS $PINS O=FE_RN_1450_0 A1=FE_RN_1449_0 B1=FE_RN_1447_0
+ B2=A[20]
XFE_RC_2354_0 ND2 $PINS O=FE_RN_1451_0 I1=FE_RN_1450_0 I2=FE_RN_1446_0
XFE_RC_2353_0 ND2 $PINS O=FE_RN_1452_0 I1=B[20] I2=A[20]
XFE_RC_2352_0 ND2S $PINS O=FE_RN_1453_0 I1=FE_RN_1452_0 I2=FE_RN_1457_0
XFE_RC_2351_0 ND2 $PINS O=FE_RN_1454_0 I1=FE_RN_1453_0 I2=carry[20]
XFE_RC_2350_0 ND2P $PINS O=SUM[20] I1=FE_RN_1454_0 I2=FE_RN_1451_0
XFE_RC_2347_0 OR2B1S $PINS O=FE_RN_1457_0 I1=A[20] B1=FE_RN_1447_0
XFE_RC_2346_0 ND2 $PINS O=FE_RN_1458_0 I1=carry[20] I2=FE_RN_1457_0
XFE_RC_2345_0 ND2P $PINS O=carry[21] I1=FE_RN_1458_0 I2=FE_RN_1452_0
XFE_RC_2208_0 ND2 $PINS O=FE_RN_1343_0 I1=carry[17] I2=B[17]
XFE_RC_2207_0 AOI22H $PINS O=FE_RN_1344_0 A1=A[17] A2=B[17] B1=carry[17]
+ B2=A[17]
XFE_RC_2206_0 ND2P $PINS O=carry[18] I1=FE_RN_1344_0 I2=FE_RN_1343_0
XFE_RC_2112_0 ND2 $PINS O=FE_RN_1276_0 I1=carry[16] I2=B[16]
XFE_RC_2111_0 AOI22H $PINS O=FE_RN_1277_0 A1=A[16] A2=B[16] B1=carry[16]
+ B2=A[16]
XFE_RC_2110_0 ND2P $PINS O=carry[17] I1=FE_RN_1277_0 I2=FE_RN_1276_0
XFE_RC_1990_0 ND2 $PINS O=FE_RN_1183_0 I1=carry[13] I2=B[13]
XFE_RC_1989_0 AOI22H $PINS O=FE_RN_1184_0 A1=A[13] A2=B[13] B1=carry[13]
+ B2=A[13]
XFE_RC_1988_0 ND2P $PINS O=carry[14] I1=FE_RN_1184_0 I2=FE_RN_1183_0
XFE_RC_1977_0 ND2 $PINS O=FE_RN_1173_0 I1=carry[15] I2=B[15]
XFE_RC_1976_0 AOI22H $PINS O=FE_RN_1174_0 A1=A[15] A2=B[15] B1=carry[15]
+ B2=A[15]
XFE_RC_1975_0 ND2P $PINS O=carry[16] I1=FE_RN_1174_0 I2=FE_RN_1173_0
XFE_RC_1860_0 ND2 $PINS O=FE_RN_1087_0 I1=carry[14] I2=B[14]
XFE_RC_1859_0 AOI22H $PINS O=FE_RN_1088_0 A1=A[14] A2=B[14] B1=carry[14]
+ B2=A[14]
XFE_RC_1858_0 ND2P $PINS O=carry[15] I1=FE_RN_1088_0 I2=FE_RN_1087_0
XFE_RC_1739_0 ND2 $PINS O=FE_RN_991_0 I1=carry[10] I2=B[10]
XFE_RC_1738_0 AOI22H $PINS O=FE_RN_992_0 A1=A[10] A2=B[10] B1=carry[10]
+ B2=A[10]
XFE_RC_1737_0 ND2P $PINS O=carry[11] I1=FE_RN_992_0 I2=FE_RN_991_0
XFE_RC_1724_0 ND2 $PINS O=FE_RN_979_0 I1=carry[12] I2=B[12]
XFE_RC_1723_0 AOI22S $PINS O=FE_RN_980_0 A1=A[12] A2=B[12] B1=carry[12]
+ B2=A[12]
XFE_RC_1722_0 ND2P $PINS O=carry[13] I1=FE_RN_980_0 I2=FE_RN_979_0
XFE_RC_1616_0 ND2 $PINS O=FE_RN_898_0 I1=carry[11] I2=B[11]
XFE_RC_1615_0 AOI22H $PINS O=FE_RN_899_0 A1=A[11] A2=B[11] B1=carry[11]
+ B2=A[11]
XFE_RC_1614_0 ND2P $PINS O=carry[12] I1=FE_RN_899_0 I2=FE_RN_898_0
XFE_RC_1538_0 INV1S $PINS O=FE_RN_836_0 I=carry[7]
XFE_RC_1537_0 XOR2HS $PINS O=FE_RN_837_0 I1=A[7] I2=B[7]
XFE_RC_1536_0 ND2S $PINS O=FE_RN_838_0 I1=FE_RN_837_0 I2=FE_RN_836_0
XFE_RC_1535_0 ND2 $PINS O=FE_RN_839_0 I1=B[7] I2=A[7]
XFE_RC_1534_0 ND2 $PINS O=FE_RN_840_0 I1=FE_RN_839_0 I2=FE_RN_843_0
XFE_RC_1533_0 ND2 $PINS O=FE_RN_841_0 I1=FE_RN_840_0 I2=FE_OCPN1180_carry_7
XFE_RC_1532_0 ND2 $PINS O=SUM[7] I1=FE_RN_841_0 I2=FE_RN_838_0
XFE_RC_1530_0 OR2 $PINS O=FE_RN_843_0 I1=B[7] I2=A[7]
XFE_RC_1529_0 ND2P $PINS O=FE_RN_844_0 I1=FE_RN_843_0 I2=carry[7]
XFE_RC_1528_0 ND2P $PINS O=carry[8] I1=FE_RN_844_0 I2=FE_RN_839_0
XFE_RC_1317_0 INV1S $PINS O=FE_RN_675_0 I=FE_RN_452_0
XFE_RC_1316_0 OR2B1S $PINS O=FE_RN_676_0 I1=FE_RN_451_0 B1=FE_RN_675_0
XFE_RC_1315_0 ND2 $PINS O=FE_RN_677_0 I1=carry[8] I2=FE_RN_455_0
XFE_RC_1314_0 ND2 $PINS O=carry[9] I1=FE_RN_677_0 I2=FE_RN_676_0
XFE_RC_1031_0 INV1S $PINS O=FE_RN_448_0 I=carry[8]
XFE_RC_1030_0 XOR2HS $PINS O=FE_RN_449_0 I1=A[8] I2=FE_OCPN1115_N159
XFE_RC_1029_0 ND2S $PINS O=FE_RN_450_0 I1=FE_RN_449_0 I2=FE_RN_448_0
XFE_RC_1028_0 INV1S $PINS O=FE_RN_451_0 I=A[8]
XFE_RC_1027_0 INV2 $PINS O=FE_RN_452_0 I=B[8]
XFE_RC_1026_0 OAI12HS $PINS O=FE_RN_453_0 A1=FE_RN_455_0 B1=FE_RN_452_0
+ B2=FE_RN_451_0
XFE_RC_1025_0 ND2 $PINS O=FE_RN_454_0 I1=FE_RN_453_0 I2=carry[8]
XFE_RC_1024_0 ND2P $PINS O=SUM[8] I1=FE_RN_454_0 I2=FE_RN_450_0
XFE_RC_1023_0 OR2 $PINS O=FE_RN_455_0 I1=A[8] I2=B[8]
XFE_RC_890_0 ND2 $PINS O=FE_RN_347_0 I1=B[9] I2=A[9]
XFE_RC_889_0 ND2 $PINS O=FE_RN_348_0 I1=FE_RN_347_0 I2=FE_RN_351_0
XFE_RC_888_0 XNR2HS $PINS O=FE_RN_349_0 I1=A[9] I2=B[9]
XFE_RC_887_0 MOAI1 $PINS O=SUM[9] A1=FE_RN_349_0 A2=FE_OCPN478_carry_9
+ B1=FE_RN_348_0 B2=FE_OCPN478_carry_9
XFE_RC_885_0 OR2 $PINS O=FE_RN_351_0 I1=A[9] I2=B[9]
XFE_RC_884_0 ND2 $PINS O=FE_RN_352_0 I1=FE_RN_351_0 I2=carry[9]
XFE_RC_883_0 ND2P $PINS O=carry[10] I1=FE_RN_352_0 I2=FE_RN_347_0
XFE_RC_724_0 XOR3 $PINS O=SUM[10] I1=B[10] I2=A[10] I3=carry[10]
XFE_RC_665_0 XOR3 $PINS O=SUM[11] I1=A[11] I2=B[11] I3=carry[11]
XFE_RC_496_0 XOR3 $PINS O=SUM[16] I1=A[16] I2=B[16] I3=carry[16]
XFE_RC_436_0 XOR3 $PINS O=SUM[13] I1=A[13] I2=B[13] I3=carry[13]
XFE_RC_302_0 XOR3 $PINS O=SUM[14] I1=A[14] I2=B[14] I3=carry[14]
XFE_RC_300_0 XOR3 $PINS O=SUM[17] I1=A[17] I2=B[17] I3=carry[17]
XFE_RC_174_0 MAO222 $PINS O=carry[4] A1=A[3] B1=B[3] C1=carry[3]
XU1_24 FA1 $PINS S=SUM[24] CO=carry[25] A=A[24] B=B[24] CI=carry[24]
XU1_25 FA1 $PINS S=SUM[25] CO=carry[26] A=A[25] B=B[25] CI=carry[25]
XU1_23 FA1 $PINS S=SUM[23] CO=carry[24] A=A[23] B=B[23] CI=carry[23]
XU1 ND2 $PINS O=n13 I1=B[4] I2=A[4]
XU2 ND3P $PINS O=carry[5] I1=n11 I2=n12 I3=n13
XU3 XOR3 $PINS O=SUM[2] I1=carry[2] I2=B[2] I3=A[2]
XU4 INV1S $PINS O=n9 I=B[26]
XU5 INV1S $PINS O=n8 I=A[26]
XU7 AN2T $PINS O=n1 I1=B[0] I2=A[0]
XU8 XOR3 $PINS O=SUM[18] I1=A[18] I2=B[18] I3=carry[18]
XU9 ND2 $PINS O=n2 I1=carry[18] I2=A[18]
XU10 ND2P $PINS O=n3 I1=carry[18] I2=B[18]
XU11 ND2 $PINS O=n4 I1=A[18] I2=B[18]
XU12 ND3P $PINS O=carry[19] I1=n2 I2=n3 I3=n4
XU13 ND2 $PINS O=n5 I1=A[2] I2=carry[2]
XU14 ND2 $PINS O=n6 I1=A[2] I2=B[2]
XU15 ND2P $PINS O=n7 I1=carry[2] I2=B[2]
XU16 XOR3 $PINS O=SUM[6] I1=B[6] I2=A[6] I3=n10
XU17 XOR3 $PINS O=SUM[26] I1=n8 I2=n9 I3=carry[26]
XU19 ND2 $PINS O=n15 I1=carry[6] I2=A[6]
XU21 XOR3 $PINS O=SUM[4] I1=B[4] I2=A[4] I3=carry[4]
XU22 ND2 $PINS O=n11 I1=carry[4] I2=B[4]
XU23 ND2 $PINS O=n12 I1=carry[4] I2=A[4]
XU24 ND2 $PINS O=n14 I1=n10 I2=B[6]
XU25 ND2 $PINS O=n16 I1=B[6] I2=A[6]
XU26 XOR2HS $PINS O=SUM[0] I1=B[0] I2=A[0]
.ENDS

.SUBCKT PE_Shift_Add_5_DW01_add_1_DW01_add_33 A[26] A[25] A[24] A[23] A[22]
+ A[21] A[20] A[19] A[18] A[17] A[16] A[15] A[14] A[13] A[12] A[11] A[10] A[9]
+ A[8] A[7] A[6] A[5] A[4] A[3] A[2] A[1] A[0] B[26] B[25] B[24] B[23] B[22]
+ B[21] B[20] B[19] B[18] B[17] B[16] B[15] B[14] B[13] B[12] B[11] B[10] B[9]
+ B[8] B[7] B[6] B[5] B[4] B[3] B[2] B[1] B[0] CI SUM[26] SUM[25] SUM[24]
+ SUM[23] SUM[22] SUM[21] SUM[20] SUM[19] SUM[18] SUM[17] SUM[16] SUM[15]
+ SUM[14] SUM[13] SUM[12] SUM[11] SUM[10] SUM[9] SUM[8] SUM[7] SUM[6] SUM[5]
+ SUM[4] SUM[3] SUM[2] SUM[1] SUM[0] CO
XFE_RC_312_0 XNR2HS $PINS O=FE_RN_27_0 I1=A[19] I2=B[19]
XFE_RC_151_0 XOR3 $PINS O=SUM[2] I1=A[2] I2=B[2] I3=carry[2]
XFE_RC_150_0 MAO222 $PINS O=carry[3] A1=A[2] B1=B[2] C1=carry[2]
XFE_RC_52_0 INV1S $PINS O=FE_RN_28_0 I=B[19]
XFE_RC_51_0 INV1S $PINS O=FE_RN_29_0 I=A[19]
XFE_RC_50_0 OAI12HS $PINS O=FE_RN_30_0 A1=FE_RN_35_0 B1=FE_RN_29_0
+ B2=FE_RN_28_0
XFE_RC_49_0 ND2 $PINS O=FE_RN_31_0 I1=FE_RN_30_0 I2=carry[19]
XFE_RC_48_0 OAI12H $PINS O=SUM[19] A1=FE_RN_31_0 B1=FE_RN_27_0 B2=carry[19]
XFE_RC_47_0 ND2 $PINS O=FE_RN_32_0 I1=A[19] I2=B[19]
XFE_RC_44_0 ND2S $PINS O=FE_RN_35_0 I1=FE_RN_29_0 I2=FE_RN_28_0
XFE_RC_43_0 ND2 $PINS O=FE_RN_36_0 I1=FE_RN_35_0 I2=carry[19]
XFE_RC_42_0 ND2P $PINS O=carry[20] I1=FE_RN_36_0 I2=FE_RN_32_0
XFE_RC_26_0 INV2 $PINS O=SUM[13] I=FE_RN_16_0
XFE_RC_25_0 XNR3 $PINS O=FE_RN_16_0 I1=A[13] I2=B[13] I3=carry[13]
XFE_RC_21_0 INV2 $PINS O=SUM[12] I=FE_RN_14_0
XFE_RC_20_0 XNR3 $PINS O=FE_RN_14_0 I1=A[12] I2=B[12] I3=carry[12]
XFE_RC_4048_0 XOR3 $PINS O=SUM[24] I1=A[24] I2=B[24] I3=carry[24]
XFE_RC_4047_0 MAO222 $PINS O=carry[25] A1=A[24] B1=B[24] C1=carry[24]
XFE_RC_3865_0 OR2 $PINS O=FE_RN_2535_0 I1=FE_RN_2232_0 I2=FE_RN_2240_0
XFE_RC_3864_0 ND2 $PINS O=FE_RN_2536_0 I1=carry[20] I2=FE_RN_2239_0
XFE_RC_3863_0 ND2P $PINS O=carry[21] I1=FE_RN_2536_0 I2=FE_RN_2535_0
XFE_RC_3437_0 INV1S $PINS O=FE_RN_2232_0 I=A[20]
XFE_RC_3435_0 MAOI1 $PINS O=FE_RN_2234_0 A1=FE_RN_2232_0 A2=B[20] B1=B[20]
+ B2=FE_RN_2232_0
XFE_RC_3434_0 ND2S $PINS O=FE_RN_2235_0 I1=A[20] I2=B[20]
XFE_RC_3433_0 ND2 $PINS O=FE_RN_2236_0 I1=FE_RN_2235_0 I2=FE_RN_2239_0
XFE_RC_3432_0 ND2 $PINS O=FE_RN_2237_0 I1=FE_RN_2236_0 I2=carry[20]
XFE_RC_3431_0 OAI12HS $PINS O=SUM[20] A1=FE_RN_2237_0 B1=FE_RN_2234_0
+ B2=carry[20]
XFE_RC_3429_0 OR2B1 $PINS O=FE_RN_2239_0 I1=B[20] B1=FE_RN_2232_0
XFE_RC_3428_0 INV1S $PINS O=FE_RN_2240_0 I=B[20]
XFE_RC_3323_0 ND2S $PINS O=FE_RN_2149_0 I1=A[21] I2=B[21]
XFE_RC_3322_0 ND2 $PINS O=FE_RN_2150_0 I1=FE_RN_2149_0 I2=FE_RN_2156_0
XFE_RC_3321_0 INV1S $PINS O=FE_RN_2151_0 I=A[21]
XFE_RC_3319_0 MAOI1 $PINS O=FE_RN_2153_0 A1=FE_RN_2151_0 A2=B[21] B1=B[21]
+ B2=FE_RN_2151_0
XFE_RC_3318_0 MOAI1 $PINS O=SUM[21] A1=FE_RN_2153_0 A2=carry[21]
+ B1=FE_RN_2150_0 B2=carry[21]
XFE_RC_3315_0 OR2B1 $PINS O=FE_RN_2156_0 I1=B[21] B1=FE_RN_2151_0
XFE_RC_3314_0 ND2P $PINS O=FE_RN_2157_0 I1=carry[21] I2=FE_RN_2156_0
XFE_RC_3313_0 ND2P $PINS O=carry[22] I1=FE_RN_2157_0 I2=FE_RN_2149_0
XFE_RC_3161_0 ND3 $PINS O=carry[4] I1=n17 I2=n16 I3=n18
XFE_RC_2730_0 INV1S $PINS O=FE_RN_1723_0 I=A[17]
XFE_RC_2729_0 NR2 $PINS O=FE_RN_1724_0 I1=B[17] I2=FE_RN_1723_0
XFE_RC_2728_0 AN2B1S $PINS O=FE_RN_1725_0 I1=B[17] B1=A[17]
XFE_RC_2727_0 INV1S $PINS O=FE_RN_1726_0 I=carry[17]
XFE_RC_2726_0 OAI12HS $PINS O=FE_RN_1727_0 A1=FE_RN_1726_0 B1=FE_RN_1725_0
+ B2=FE_RN_1724_0
XFE_RC_2725_0 ND2 $PINS O=FE_RN_1728_0 I1=A[17] I2=B[17]
XFE_RC_2724_0 ND2 $PINS O=FE_RN_1729_0 I1=FE_RN_1728_0 I2=FE_RN_1733_0
XFE_RC_2723_0 ND2 $PINS O=FE_RN_1730_0 I1=FE_RN_1729_0 I2=carry[17]
XFE_RC_2722_0 ND2 $PINS O=SUM[17] I1=FE_RN_1730_0 I2=FE_RN_1727_0
XFE_RC_2719_0 OR2B1 $PINS O=FE_RN_1733_0 I1=B[17] B1=FE_RN_1723_0
XFE_RC_2718_0 ND2 $PINS O=FE_RN_1734_0 I1=FE_RN_1733_0 I2=carry[17]
XFE_RC_2717_0 ND2P $PINS O=carry[18] I1=FE_RN_1734_0 I2=FE_RN_1728_0
XFE_RC_2644_0 XOR3 $PINS O=SUM[5] I1=A[5] I2=B[5] I3=carry[5]
XFE_RC_2536_0 ND2 $PINS O=FE_RN_1590_0 I1=carry[5] I2=B[5]
XFE_RC_2535_0 AOI22H $PINS O=FE_RN_1591_0 A1=B[5] A2=A[5] B1=carry[5] B2=A[5]
XFE_RC_2534_0 ND2P $PINS O=carry[6] I1=FE_RN_1591_0 I2=FE_RN_1590_0
XFE_RC_2494_0 ND3 $PINS O=carry[2] I1=n13 I2=n15 I3=n14
XFE_RC_2490_0 INV1S $PINS O=FE_RN_1554_0 I=FE_RN_1017_0
XFE_RC_2489_0 OR2B1S $PINS O=FE_RN_1555_0 I1=FE_RN_1025_0 B1=FE_RN_1554_0
XFE_RC_2488_0 ND2P $PINS O=carry[16] I1=FE_RN_1030_0 I2=FE_RN_1555_0
XFE_RC_2125_0 XNR2HS $PINS O=FE_RN_1280_0 I1=B[16] I2=A[16]
XFE_RC_2124_0 ND2 $PINS O=FE_RN_1281_0 I1=A[16] I2=B[16]
XFE_RC_2123_0 ND2 $PINS O=FE_RN_1282_0 I1=FE_RN_1281_0 I2=FE_RN_1286_0
XFE_RC_2122_0 ND2 $PINS O=FE_RN_1283_0 I1=FE_RN_1282_0 I2=carry[16]
XFE_RC_2121_0 OAI12HS $PINS O=SUM[16] A1=FE_RN_1283_0 B1=FE_RN_1280_0
+ B2=carry[16]
XFE_RC_2119_0 INV1S $PINS O=FE_RN_1285_0 I=A[16]
XFE_RC_2118_0 OR2B1S $PINS O=FE_RN_1286_0 I1=B[16] B1=FE_RN_1285_0
XFE_RC_2117_0 ND2 $PINS O=FE_RN_1287_0 I1=FE_RN_1286_0 I2=carry[16]
XFE_RC_2116_0 ND2P $PINS O=carry[17] I1=FE_RN_1287_0 I2=FE_RN_1281_0
XFE_RC_1786_0 ND2 $PINS O=FE_RN_1031_0 I1=carry[13] I2=B[13]
XFE_RC_1785_0 AOI22H $PINS O=FE_RN_1032_0 A1=B[13] A2=A[13] B1=carry[13]
+ B2=A[13]
XFE_RC_1784_0 ND2P $PINS O=carry[14] I1=FE_RN_1032_0 I2=FE_RN_1031_0
XFE_RC_1783_0 INV1S $PINS O=FE_RN_1017_0 I=A[15]
XFE_RC_1782_0 NR2 $PINS O=FE_RN_1018_0 I1=B[15] I2=FE_RN_1017_0
XFE_RC_1781_0 AN2B1S $PINS O=FE_RN_1019_0 I1=B[15] B1=A[15]
XFE_RC_1780_0 INV1S $PINS O=FE_RN_1020_0 I=carry[15]
XFE_RC_1779_0 OAI12HS $PINS O=FE_RN_1021_0 A1=FE_RN_1020_0 B1=FE_RN_1019_0
+ B2=FE_RN_1018_0
XFE_RC_1778_0 ND2 $PINS O=FE_RN_1022_0 I1=A[15] I2=B[15]
XFE_RC_1777_0 ND2S $PINS O=FE_RN_1023_0 I1=FE_RN_1022_0 I2=FE_RN_1029_0
XFE_RC_1776_0 ND2 $PINS O=FE_RN_1024_0 I1=FE_RN_1023_0 I2=carry[15]
XFE_RC_1775_0 ND2P $PINS O=SUM[15] I1=FE_RN_1024_0 I2=FE_RN_1021_0
XFE_RC_1774_0 INV1S $PINS O=FE_RN_1025_0 I=B[15]
XFE_RC_1770_0 ND2 $PINS O=FE_RN_1029_0 I1=FE_RN_1017_0 I2=FE_RN_1025_0
XFE_RC_1769_0 ND2 $PINS O=FE_RN_1030_0 I1=carry[15] I2=FE_RN_1029_0
XFE_RC_1691_0 ND2 $PINS O=FE_RN_955_0 I1=carry[9] I2=B[9]
XFE_RC_1690_0 AOI22S $PINS O=FE_RN_956_0 A1=B[9] A2=A[9] B1=carry[9] B2=A[9]
XFE_RC_1689_0 ND2P $PINS O=carry[10] I1=FE_RN_956_0 I2=FE_RN_955_0
XFE_RC_1665_0 ND2 $PINS O=FE_RN_935_0 I1=carry[12] I2=B[12]
XFE_RC_1664_0 AOI22H $PINS O=FE_RN_936_0 A1=B[12] A2=A[12] B1=carry[12]
+ B2=A[12]
XFE_RC_1663_0 ND2P $PINS O=carry[13] I1=FE_RN_936_0 I2=FE_RN_935_0
XFE_RC_1494_0 ND2 $PINS O=FE_RN_808_0 I1=carry[7] I2=B[7]
XFE_RC_1493_0 AOI22S $PINS O=FE_RN_809_0 A1=B[7] A2=A[7] B1=carry[7] B2=A[7]
XFE_RC_1492_0 ND2P $PINS O=carry[8] I1=FE_RN_809_0 I2=FE_RN_808_0
XFE_RC_1419_0 INV1S $PINS O=FE_RN_751_0 I=FE_RN_397_0
XFE_RC_1418_0 OR2B1S $PINS O=FE_RN_752_0 I1=FE_RN_396_0 B1=FE_RN_751_0
XFE_RC_1417_0 ND2P $PINS O=carry[11] I1=FE_RN_401_0 I2=FE_RN_752_0
XFE_RC_957_0 INV1S $PINS O=FE_RN_390_0 I=carry[10]
XFE_RC_956_0 XOR2HS $PINS O=FE_RN_391_0 I1=B[10] I2=A[10]
XFE_RC_955_0 ND2S $PINS O=FE_RN_392_0 I1=FE_RN_391_0 I2=FE_RN_390_0
XFE_RC_954_0 ND2 $PINS O=FE_RN_393_0 I1=A[10] I2=B[10]
XFE_RC_953_0 ND2S $PINS O=FE_RN_394_0 I1=FE_RN_393_0 I2=FE_RN_400_0
XFE_RC_952_0 ND2 $PINS O=FE_RN_395_0 I1=FE_RN_394_0 I2=carry[10]
XFE_RC_951_0 ND2P $PINS O=SUM[10] I1=FE_RN_395_0 I2=FE_RN_392_0
XFE_RC_950_0 INV1S $PINS O=FE_RN_396_0 I=B[10]
XFE_RC_949_0 INV1S $PINS O=FE_RN_397_0 I=A[10]
XFE_RC_946_0 ND2 $PINS O=FE_RN_400_0 I1=FE_RN_397_0 I2=FE_RN_396_0
XFE_RC_945_0 ND2 $PINS O=FE_RN_401_0 I1=carry[10] I2=FE_RN_400_0
XFE_RC_838_0 ND2S $PINS O=FE_RN_302_0 I1=A[11] I2=B[11]
XFE_RC_837_0 ND2 $PINS O=FE_RN_303_0 I1=FE_RN_302_0 I2=FE_RN_309_0
XFE_RC_836_0 INV1S $PINS O=FE_RN_304_0 I=A[11]
XFE_RC_835_0 AN2B1S $PINS O=FE_RN_305_0 I1=A[11] B1=B[11]
XFE_RC_834_0 AOI12HS $PINS O=FE_RN_306_0 A1=FE_RN_305_0 B1=FE_RN_304_0 B2=B[11]
XFE_RC_833_0 MOAI1 $PINS O=SUM[11] A1=FE_RN_306_0 A2=carry[11] B1=FE_RN_303_0
+ B2=carry[11]
XFE_RC_830_0 OR2B1S $PINS O=FE_RN_309_0 I1=B[11] B1=FE_RN_304_0
XFE_RC_829_0 ND2 $PINS O=FE_RN_310_0 I1=FE_RN_309_0 I2=carry[11]
XFE_RC_828_0 ND2P $PINS O=carry[12] I1=FE_RN_310_0 I2=FE_RN_302_0
XFE_RC_685_0 XOR3 $PINS O=SUM[9] I1=A[9] I2=B[9] I3=carry[9]
XFE_RC_584_0 XOR3 $PINS O=SUM[4] I1=A[4] I2=B[4] I3=carry[4]
XFE_RC_583_0 MAO222P $PINS O=carry[5] A1=carry[4] B1=B[4] C1=A[4]
XFE_RC_451_0 INV1S $PINS O=FE_RN_122_0 I=FE_RN_68_0
XFE_RC_450_0 OR2B1 $PINS O=FE_RN_123_0 I1=FE_RN_76_0 B1=FE_RN_122_0
XFE_RC_449_0 ND2P $PINS O=carry[7] I1=FE_RN_80_0 I2=FE_RN_123_0
XFE_RC_340_0 INV1S $PINS O=FE_RN_67_0 I=carry[6]
XFE_RC_339_0 INV1S $PINS O=FE_RN_68_0 I=A[6]
XFE_RC_337_0 ND2 $PINS O=FE_RN_70_0 I1=FE_RN_68_0 I2=B[6]
XFE_RC_336_0 OAI12HS $PINS O=FE_RN_71_0 A1=FE_RN_70_0 B1=FE_RN_68_0 B2=B[6]
XFE_RC_335_0 ND2S $PINS O=FE_RN_72_0 I1=FE_RN_71_0 I2=FE_RN_67_0
XFE_RC_334_0 ND2 $PINS O=FE_RN_73_0 I1=A[6] I2=B[6]
XFE_RC_333_0 ND2 $PINS O=FE_RN_74_0 I1=FE_RN_73_0 I2=FE_RN_79_0
XFE_RC_332_0 ND2 $PINS O=FE_RN_75_0 I1=FE_RN_74_0 I2=carry[6]
XFE_RC_331_0 ND2 $PINS O=SUM[6] I1=FE_RN_75_0 I2=FE_RN_72_0
XFE_RC_330_0 INV1S $PINS O=FE_RN_76_0 I=B[6]
XFE_RC_327_0 OR2B1 $PINS O=FE_RN_79_0 I1=B[6] B1=FE_RN_68_0
XFE_RC_326_0 ND2 $PINS O=FE_RN_80_0 I1=FE_RN_79_0 I2=carry[6]
XFE_RC_229_0 XOR3 $PINS O=SUM[7] I1=A[7] I2=B[7] I3=carry[7]
XU1_18 FA1 $PINS S=SUM[18] CO=carry[19] A=A[18] B=B[18] CI=carry[18]
XU1_23 FA1 $PINS S=SUM[23] CO=carry[24] A=A[23] B=B[23] CI=carry[23]
XU1_25 FA1 $PINS S=SUM[25] CO=carry[26] A=A[25] B=B[25] CI=carry[25]
XU2 ND3P $PINS O=carry[9] I1=n9 I2=n10 I3=n11
XU3 ND2S $PINS O=n18 I1=B[3] I2=A[3]
XU4 ND3P $PINS O=carry[15] I1=n2 I2=n3 I3=n4
XU5 ND3P $PINS O=carry[23] I1=n6 I2=n7 I3=n8
XU6 AN2 $PINS O=n1 I1=B[0] I2=A[0]
XU7 XOR3 $PINS O=SUM[14] I1=B[14] I2=A[14] I3=carry[14]
XU8 ND2 $PINS O=n2 I1=carry[14] I2=B[14]
XU9 ND2 $PINS O=n3 I1=carry[14] I2=A[14]
XU10 ND2 $PINS O=n4 I1=B[14] I2=A[14]
XU11 XOR2HS $PINS O=n5 I1=B[22] I2=A[22]
XU12 XOR2HS $PINS O=SUM[22] I1=carry[22] I2=n5
XU13 ND2 $PINS O=n6 I1=carry[22] I2=B[22]
XU14 ND2 $PINS O=n7 I1=carry[22] I2=A[22]
XU15 ND2S $PINS O=n8 I1=B[22] I2=A[22]
XU16 XOR3 $PINS O=SUM[8] I1=B[8] I2=A[8] I3=carry[8]
XU17 ND2 $PINS O=n9 I1=carry[8] I2=B[8]
XU18 ND2 $PINS O=n10 I1=carry[8] I2=A[8]
XU19 ND2 $PINS O=n11 I1=B[8] I2=A[8]
XU21 XOR3S $PINS O=SUM[26] I1=A[26] I2=B[26] I3=carry[26]
XU22 ND2 $PINS O=n13 I1=n1 I2=B[1]
XU23 ND2 $PINS O=n15 I1=B[1] I2=A[1]
XU24 XOR2HS $PINS O=n12 I1=B[1] I2=A[1]
XU25 XOR2HS $PINS O=SUM[1] I1=n1 I2=n12
XU26 ND2 $PINS O=n14 I1=n1 I2=A[1]
XU27 XOR3 $PINS O=SUM[3] I1=A[3] I2=B[3] I3=carry[3]
XU28 ND2 $PINS O=n16 I1=carry[3] I2=B[3]
XU29 ND2 $PINS O=n17 I1=carry[3] I2=A[3]
XU30 XOR2HS $PINS O=SUM[0] I1=B[0] I2=A[0]
.ENDS

.SUBCKT PE_Shift_Add_5_DW01_add_0_DW01_add_32 A[26] A[25] A[24] A[23] A[22]
+ A[21] A[20] A[19] A[18] A[17] A[16] A[15] A[14] A[13] A[12] A[11] A[10] A[9]
+ A[8] A[7] A[6] A[5] A[4] A[3] A[2] A[1] A[0] B[26] B[25] B[24] B[23] B[22]
+ B[21] B[20] B[19] B[18] B[17] B[16] B[15] B[14] B[13] B[12] B[11] B[10] B[9]
+ B[8] B[7] B[6] B[5] B[4] B[3] B[2] B[1] B[0] CI SUM[26] SUM[25] SUM[24]
+ SUM[23] SUM[22] SUM[21] SUM[20] SUM[19] SUM[18] SUM[17] SUM[16] SUM[15]
+ SUM[14] SUM[13] SUM[12] SUM[11] SUM[10] SUM[9] SUM[8] SUM[7] SUM[6] SUM[5]
+ SUM[4] SUM[3] SUM[2] SUM[1] SUM[0] CO
XFE_PHC1777_N207 BUF1CK $PINS O=FE_PHN1777_N207 I=B[2]
XFE_PHC1726_FE_RN_968_0 BUF1CK $PINS O=FE_RN_968_0 I=FE_PHN1726_FE_RN_968_0
XFE_RC_182_0 ND3P $PINS O=carry[24] I1=FE_RN_128_0 I2=FE_RN_126_0
+ I3=FE_RN_127_0
XFE_RC_181_0 ND3P $PINS O=carry[20] I1=n11 I2=n10 I3=n9
XFE_RC_178_0 ND3P $PINS O=FE_RN_2 I1=FE_RN_295_0 I2=FE_RN_297_0 I3=FE_RN_296_0
XFE_OCPC5_N182 BUF1CK $PINS O=FE_OCPN4_N182 I=A[4]
XFE_RC_30_0 ND3P $PINS O=carry[8] I1=n3 I2=n2 I3=n4
XFE_OCPC1211_n17 BUF1S $PINS O=FE_OCPN1211_n17 I=n17
XFE_OCPC1173_N181 BUF1S $PINS O=FE_OCPN1173_N181 I=A[3]
XFE_OCPC1119_carry_20 BUF1S $PINS O=FE_OCPN1119_carry_20 I=carry[20]
XFE_OCPC1102_carry_15 BUF1S $PINS O=FE_OCPN1102_carry_15 I=carry[15]
XFE_OCPC1068_carry_9 BUF1S $PINS O=FE_OCPN1068_carry_9 I=carry[9]
XFE_OCPC1017_carry_17 BUF1S $PINS O=FE_OCPN1017_carry_17 I=carry[17]
XFE_OCPC1010_FE_RN_3 BUF1S $PINS O=FE_OCPN1010_FE_RN_3 I=FE_RN_3
XFE_OCPC917_FE_RN_2 BUF1S $PINS O=FE_OCPN917_FE_RN_2 I=FE_RN_2
XFE_OCPC877_carry_8 BUF1S $PINS O=FE_OCPN877_carry_8 I=carry[8]
XFE_RC_3509_0 XOR3 $PINS O=SUM[9] I1=A[9] I2=B[9] I3=FE_OCPN1068_carry_9
XFE_RC_3508_0 MAO222P $PINS O=carry[10] A1=carry[9] B1=B[9] C1=A[9]
XFE_OCPC342_carry_22 BUF1S $PINS O=FE_OCPN342_carry_22 I=FE_RN_1
XFE_RC_3493_0 ND3HT $PINS O=carry[23] I1=FE_RN_88_0 I2=FE_RN_86_0 I3=FE_RN_87_0
XFE_OCPC250_carry_21 BUF1S $PINS O=FE_OCPN250_carry_21 I=carry[21]
XFE_OCPC248_carry_19 BUF1S $PINS O=FE_OCPN248_carry_19 I=carry[19]
XFE_OCPC247_carry_23 BUF1S $PINS O=FE_OCPN247_carry_23 I=carry[23]
XFE_OCPC231_carry_24 BUF1S $PINS O=FE_OCPN231_carry_24 I=carry[24]
XFE_RC_3335_0 XOR3 $PINS O=SUM[5] I1=A[5] I2=B[5] I3=carry[5]
XFE_RC_3334_0 MAO222P $PINS O=carry[6] A1=carry[5] B1=B[5] C1=A[5]
XFE_RC_1489_0_dup ND2P $PINS O=FE_RN_3 I1=FE_RN_807_0 I2=FE_RN_806_0
XFE_RC_486_0_dup ND2F $PINS O=FE_RN_1 I1=FE_RN_136_0 I2=FE_RN_135_0
XFE_RC_2899_0 ND2 $PINS O=FE_RN_1851_0 I1=carry[13] I2=B[13]
XFE_RC_2898_0 AOI22H $PINS O=FE_RN_1852_0 A1=A[13] A2=B[13] B1=carry[13]
+ B2=A[13]
XFE_RC_2897_0 ND2P $PINS O=n22 I1=FE_RN_1852_0 I2=FE_RN_1851_0
XFE_RC_2519_0 INV1S $PINS O=FE_RN_1568_0 I=n18
XFE_RC_2518_0 XOR2HS $PINS O=FE_RN_1569_0 I1=A[12] I2=B[12]
XFE_RC_2517_0 ND2 $PINS O=FE_RN_1570_0 I1=FE_RN_1569_0 I2=FE_RN_1568_0
XFE_RC_2516_0 INV1S $PINS O=FE_RN_1571_0 I=A[12]
XFE_RC_2515_0 INV1S $PINS O=FE_RN_1572_0 I=B[12]
XFE_RC_2514_0 OAI12HS $PINS O=FE_RN_1573_0 A1=FE_RN_1576_0 B1=FE_RN_1572_0
+ B2=FE_RN_1571_0
XFE_RC_2513_0 ND2 $PINS O=FE_RN_1574_0 I1=FE_RN_1573_0 I2=n18
XFE_RC_2512_0 ND2 $PINS O=SUM[12] I1=FE_RN_1574_0 I2=FE_RN_1570_0
XFE_RC_2511_0 ND2 $PINS O=FE_RN_1575_0 I1=B[12] I2=A[12]
XFE_RC_2510_0 OR2P $PINS O=FE_RN_1576_0 I1=A[12] I2=B[12]
XFE_RC_2509_0 ND2 $PINS O=FE_RN_1577_0 I1=FE_RN_1576_0 I2=n18
XFE_RC_2508_0 ND2P $PINS O=carry[13] I1=FE_RN_1577_0 I2=FE_RN_1575_0
XFE_RC_2310_0 ND2 $PINS O=FE_RN_1421_0 I1=n20 I2=B[13]
XFE_RC_2309_0 AOI22H $PINS O=FE_RN_1422_0 A1=A[13] A2=B[13] B1=n20 B2=A[13]
XFE_RC_2308_0 ND2P $PINS O=n23 I1=FE_RN_1422_0 I2=FE_RN_1421_0
XFE_RC_2151_0 ND2 $PINS O=FE_RN_1305_0 I1=n19 I2=B[12]
XFE_RC_2150_0 AOI22H $PINS O=FE_RN_1306_0 A1=A[12] A2=B[12] B1=n19 B2=A[12]
XFE_RC_2149_0 ND2P $PINS O=n20 I1=FE_RN_1306_0 I2=FE_RN_1305_0
XFE_RC_2136_0 ND2 $PINS O=FE_RN_1294_0 I1=carry[10] I2=B[10]
XFE_RC_2135_0 AOI22H $PINS O=FE_RN_1295_0 A1=A[10] A2=B[10] B1=carry[10]
+ B2=A[10]
XFE_RC_2134_0 ND2P $PINS O=n17 I1=FE_RN_1295_0 I2=FE_RN_1294_0
XFE_RC_2071_0 ND2 $PINS O=FE_RN_1245_0 I1=n17 I2=B[11]
XFE_RC_2070_0 AOI22H $PINS O=FE_RN_1246_0 A1=A[11] A2=B[11] B1=n17 B2=A[11]
XFE_RC_2069_0 ND2P $PINS O=n19 I1=FE_RN_1246_0 I2=FE_RN_1245_0
XFE_RC_2054_0 INV1S $PINS O=FE_RN_1221_0 I=A[10]
XFE_RC_2053_0 INV1S $PINS O=FE_RN_1222_0 I=n16
XFE_RC_2052_0 MXL2HS $PINS OB=FE_RN_1223_0 S=B[10] A=FE_RN_1222_0 B=n16
XFE_RC_2051_0 INV1S $PINS O=FE_RN_1224_0 I=FE_RN_1231_0
XFE_RC_2050_0 ND2S $PINS O=FE_RN_1225_0 I1=FE_RN_1224_0 I2=n16
XFE_RC_2048_0 INV1S $PINS O=FE_RN_1227_0 I=B[10]
XFE_RC_2047_0 NR2 $PINS O=FE_RN_1228_0 I1=A[10] I2=FE_RN_1227_0
XFE_RC_2046_0 ND2 $PINS O=FE_RN_1229_0 I1=FE_RN_1228_0 I2=FE_RN_1222_0
XFE_RC_2045_0 OAI112HS $PINS O=SUM[10] A1=FE_RN_1229_0 B1=FE_RN_1225_0
+ C1=FE_RN_1223_0 C2=FE_RN_1221_0
XFE_RC_2044_0 ND2 $PINS O=FE_RN_1230_0 I1=B[10] I2=A[10]
XFE_RC_2043_0 OR2 $PINS O=FE_RN_1231_0 I1=A[10] I2=B[10]
XFE_RC_2042_0 ND2 $PINS O=FE_RN_1232_0 I1=FE_RN_1231_0 I2=n16
XFE_RC_2041_0 ND2P $PINS O=carry[11] I1=FE_RN_1232_0 I2=FE_RN_1230_0
XFE_RC_1993_0 ND2 $PINS O=FE_RN_1185_0 I1=carry[11] I2=B[11]
XFE_RC_1992_0 AOI22H $PINS O=FE_RN_1186_0 A1=B[11] A2=A[11] B1=carry[11]
+ B2=A[11]
XFE_RC_1991_0 ND2P $PINS O=n18 I1=FE_RN_1186_0 I2=FE_RN_1185_0
XFE_RC_1935_0 INV1S $PINS O=FE_RN_1135_0 I=B[3]
XFE_RC_1933_0 NR2 $PINS O=FE_RN_1137_0 I1=FE_OCPN1173_N181 I2=FE_RN_1135_0
XFE_RC_1932_0 AOI12HS $PINS O=FE_RN_1138_0 A1=FE_RN_1137_0 B1=FE_RN_1135_0
+ B2=FE_OCPN1173_N181
XFE_RC_1931_0 INV1S $PINS O=FE_RN_1139_0 I=A[3]
XFE_RC_1929_0 OAI12HS $PINS O=FE_RN_1141_0 A1=FE_RN_1144_0 B1=FE_RN_1135_0
+ B2=FE_RN_1139_0
XFE_RC_1928_0 ND2 $PINS O=FE_RN_1142_0 I1=FE_RN_1141_0 I2=carry[3]
XFE_RC_1927_0 OAI12HS $PINS O=SUM[3] A1=FE_RN_1142_0 B1=FE_RN_1138_0
+ B2=carry[3]
XFE_RC_1926_0 ND2 $PINS O=FE_RN_1143_0 I1=B[3] I2=A[3]
XFE_RC_1925_0 OR2P $PINS O=FE_RN_1144_0 I1=A[3] I2=B[3]
XFE_RC_1924_0 ND2P $PINS O=FE_RN_1145_0 I1=FE_RN_1144_0 I2=carry[3]
XFE_RC_1923_0 ND2P $PINS O=carry[4] I1=FE_RN_1145_0 I2=FE_RN_1143_0
XFE_RC_1751_0 INV1S $PINS O=FE_RN_993_0 I=carry[4]
XFE_RC_1750_0 XOR2HS $PINS O=FE_RN_994_0 I1=B[4] I2=FE_OCPN4_N182
XFE_RC_1749_0 ND2 $PINS O=FE_RN_995_0 I1=FE_RN_994_0 I2=FE_RN_993_0
XFE_RC_1748_0 INV1S $PINS O=FE_RN_996_0 I=B[4]
XFE_RC_1747_0 INV1S $PINS O=FE_RN_997_0 I=FE_OCPN4_N182
XFE_RC_1746_0 OAI12HS $PINS O=FE_RN_998_0 A1=FE_RN_1001_0 B1=FE_RN_997_0
+ B2=FE_RN_996_0
XFE_RC_1745_0 ND2 $PINS O=FE_RN_999_0 I1=FE_RN_998_0 I2=carry[4]
XFE_RC_1744_0 ND2 $PINS O=SUM[4] I1=FE_RN_999_0 I2=FE_RN_995_0
XFE_RC_1743_0 ND2 $PINS O=FE_RN_1000_0 I1=FE_OCPN4_N182 I2=B[4]
XFE_RC_1742_0 OR2 $PINS O=FE_RN_1001_0 I1=B[4] I2=A[4]
XFE_RC_1741_0 ND2 $PINS O=FE_RN_1002_0 I1=FE_RN_1001_0 I2=carry[4]
XFE_RC_1740_0 ND2P $PINS O=carry[5] I1=FE_RN_1002_0 I2=FE_RN_1000_0
XFE_RC_1718_0 INV1S $PINS O=FE_RN_967_0 I=A[1]
XFE_RC_1717_0 XOR2HS $PINS O=FE_PHN1726_FE_RN_968_0 I1=B[1] I2=n1
XFE_RC_1716_0 ND2S $PINS O=FE_RN_969_0 I1=FE_RN_968_0 I2=FE_RN_967_0
XFE_RC_1715_0 ND2 $PINS O=FE_RN_970_0 I1=n1 I2=B[1]
XFE_RC_1714_0 ND2 $PINS O=FE_RN_971_0 I1=FE_RN_970_0 I2=FE_RN_975_0
XFE_RC_1713_0 ND2 $PINS O=FE_RN_972_0 I1=FE_RN_971_0 I2=A[1]
XFE_RC_1712_0 ND2 $PINS O=SUM[1] I1=FE_RN_972_0 I2=FE_RN_969_0
XFE_RC_1710_0 INV1S $PINS O=FE_RN_974_0 I=n1
XFE_RC_1709_0 OR2B1S $PINS O=FE_RN_975_0 I1=B[1] B1=FE_RN_974_0
XFE_RC_1708_0 ND2 $PINS O=FE_RN_976_0 I1=FE_RN_975_0 I2=A[1]
XFE_RC_1707_0 ND2 $PINS O=carry[2] I1=FE_RN_976_0 I2=FE_RN_970_0
XFE_RC_1491_0 ND2 $PINS O=FE_RN_806_0 I1=carry[15] I2=B[15]
XFE_RC_1490_0 AOI22HP $PINS O=FE_RN_807_0 A1=A[15] A2=B[15] B1=carry[15]
+ B2=A[15]
XFE_RC_1488_0 INV1S $PINS O=FE_RN_796_0 I=A[2]
XFE_RC_1487_0 INV1S $PINS O=FE_RN_797_0 I=B[2]
XFE_RC_1486_0 AOI22S $PINS O=FE_RN_798_0 A1=FE_RN_797_0 A2=A[2]
+ B1=FE_PHN1777_N207 B2=FE_RN_796_0
XFE_RC_1483_0 OAI12HS $PINS O=FE_RN_801_0 A1=FE_RN_804_0 B1=FE_RN_797_0
+ B2=FE_RN_796_0
XFE_RC_1482_0 ND2 $PINS O=FE_RN_802_0 I1=FE_RN_801_0 I2=carry[2]
XFE_RC_1481_0 OAI12HS $PINS O=SUM[2] A1=FE_RN_802_0 B1=FE_RN_798_0 B2=carry[2]
XFE_RC_1480_0 ND2 $PINS O=FE_RN_803_0 I1=B[2] I2=A[2]
XFE_RC_1479_0 OR2 $PINS O=FE_RN_804_0 I1=A[2] I2=B[2]
XFE_RC_1478_0 ND2 $PINS O=FE_RN_805_0 I1=FE_RN_804_0 I2=carry[2]
XFE_RC_1477_0 ND2P $PINS O=carry[3] I1=FE_RN_805_0 I2=FE_RN_803_0
XFE_RC_1330_0 ND2P $PINS O=FE_RN_682_0 I1=carry[25] I2=B[25]
XFE_RC_1329_0 AOI22H $PINS O=FE_RN_683_0 A1=A[25] A2=B[25] B1=carry[25]
+ B2=A[25]
XFE_RC_1328_0 ND2P $PINS O=carry[26] I1=FE_RN_683_0 I2=FE_RN_682_0
XFE_RC_1322_0 ND3HT $PINS O=carry[17] I1=FE_RN_402_0 I2=FE_RN_404_0
+ I3=FE_RN_403_0
XFE_RC_1094_0 INV1S $PINS O=FE_RN_499_0 I=carry[6]
XFE_RC_1093_0 XOR2HS $PINS O=FE_RN_500_0 I1=A[6] I2=B[6]
XFE_RC_1092_0 ND2 $PINS O=FE_RN_501_0 I1=FE_RN_500_0 I2=FE_RN_499_0
XFE_RC_1091_0 ND2 $PINS O=FE_RN_502_0 I1=B[6] I2=A[6]
XFE_RC_1090_0 ND2 $PINS O=FE_RN_503_0 I1=FE_RN_502_0 I2=FE_RN_506_0
XFE_RC_1089_0 ND2 $PINS O=FE_RN_504_0 I1=FE_RN_503_0 I2=carry[6]
XFE_RC_1088_0 ND2 $PINS O=SUM[6] I1=FE_RN_504_0 I2=FE_RN_501_0
XFE_RC_1086_0 OR2P $PINS O=FE_RN_506_0 I1=A[6] I2=B[6]
XFE_RC_1085_0 ND2T $PINS O=FE_RN_507_0 I1=FE_RN_506_0 I2=carry[6]
XFE_RC_1084_0 ND2T $PINS O=carry[7] I1=FE_RN_507_0 I2=FE_RN_502_0
XFE_RC_961_0 ND2P $PINS O=FE_RN_402_0 I1=A[16] I2=FE_RN_3
XFE_RC_960_0 ND2 $PINS O=FE_RN_403_0 I1=A[16] I2=B[16]
XFE_RC_959_0 ND2P $PINS O=FE_RN_404_0 I1=FE_RN_3 I2=B[16]
XFE_RC_917_0 ND2 $PINS O=FE_RN_369_0 I1=carry[24] I2=A[24]
XFE_RC_916_0 ND2 $PINS O=FE_RN_370_0 I1=A[24] I2=B[24]
XFE_RC_915_0 ND2 $PINS O=FE_RN_371_0 I1=carry[24] I2=B[24]
XFE_RC_914_0 ND3HT $PINS O=carry[25] I1=FE_RN_371_0 I2=FE_RN_369_0
+ I3=FE_RN_370_0
XFE_RC_821_0 ND2P $PINS O=FE_RN_295_0 I1=carry[17] I2=A[17]
XFE_RC_820_0 ND2 $PINS O=FE_RN_296_0 I1=A[17] I2=B[17]
XFE_RC_819_0 ND2P $PINS O=FE_RN_297_0 I1=carry[17] I2=B[17]
XFE_RC_782_0 XOR3 $PINS O=SUM[25] I1=A[25] I2=B[25] I3=carry[25]
XFE_RC_711_0 ND3P $PINS O=carry[19] I1=FE_RN_188_0 I2=FE_RN_189_0
+ I3=FE_RN_187_0
XFE_RC_628_0 ND2 $PINS O=FE_RN_187_0 I1=A[18] I2=B[18]
XFE_RC_627_0 ND2 $PINS O=FE_RN_188_0 I1=A[18] I2=FE_RN_2
XFE_RC_626_0 ND2 $PINS O=FE_RN_189_0 I1=FE_RN_2 I2=B[18]
XFE_RC_603_0 ND3HT $PINS O=carry[15] I1=n24 I2=n25 I3=n26
XFE_RC_537_0 XOR3 $PINS O=SUM[15] I1=A[15] I2=B[15] I3=FE_OCPN1102_carry_15
XFE_RC_488_0 ND2P $PINS O=FE_RN_135_0 I1=carry[21] I2=B[21]
XFE_RC_487_0 AOI22HP $PINS O=FE_RN_136_0 A1=B[21] A2=A[21] B1=carry[21]
+ B2=A[21]
XFE_RC_472_0 ND2P $PINS O=FE_RN_126_0 I1=carry[23] I2=A[23]
XFE_RC_471_0 ND2 $PINS O=FE_RN_127_0 I1=A[23] I2=B[23]
XFE_RC_470_0 ND2P $PINS O=FE_RN_128_0 I1=carry[23] I2=B[23]
XFE_RC_367_0 ND2T $PINS O=FE_RN_86_0 I1=FE_RN_1 I2=A[22]
XFE_RC_366_0 ND2 $PINS O=FE_RN_87_0 I1=A[22] I2=B[22]
XFE_RC_365_0 ND2P $PINS O=FE_RN_88_0 I1=FE_RN_1 I2=B[22]
XFE_RC_352_0 XOR3 $PINS O=SUM[16] I1=A[16] I2=B[16] I3=FE_OCPN1010_FE_RN_3
XFE_RC_296_0 XOR3 $PINS O=SUM[22] I1=A[22] I2=B[22] I3=FE_OCPN342_carry_22
XFE_RC_217_0 XOR3 $PINS O=SUM[17] I1=A[17] I2=B[17] I3=FE_OCPN1017_carry_17
XFE_RC_213_0 XOR3 $PINS O=SUM[23] I1=A[23] I2=B[23] I3=FE_OCPN247_carry_23
XFE_RC_118_0 XOR3 $PINS O=SUM[24] I1=A[24] I2=B[24] I3=FE_OCPN231_carry_24
XFE_RC_108_0 XOR3 $PINS O=SUM[21] I1=A[21] I2=B[21] I3=FE_OCPN250_carry_21
XFE_RC_65_0 ND3HT $PINS O=carry[21] I1=n15 I2=n14 I3=n13
XFE_RC_58_0 XOR3 $PINS O=SUM[18] I1=A[18] I2=B[18] I3=FE_OCPN917_FE_RN_2
XU1_26 XOR3 $PINS O=SUM[26] I1=B[26] I2=A[26] I3=carry[26]
XU1_13 FA1S $PINS S=SUM[13] CO=carry[14] A=A[13] B=B[13] CI=n21
XU1_11 FA1S $PINS S=SUM[11] CO=carry[12] A=A[11] B=B[11] CI=FE_OCPN1211_n17
XU2 XOR2HS $PINS O=SUM[20] I1=n12 I2=FE_OCPN1119_carry_20
XU3 ND2 $PINS O=n2 I1=A[7] I2=B[7]
XU4 ND2 $PINS O=n9 I1=A[19] I2=B[19]
XU5 XOR3 $PINS O=SUM[7] I1=A[7] I2=B[7] I3=carry[7]
XU6 XOR3 $PINS O=SUM[19] I1=A[19] I2=B[19] I3=FE_OCPN248_carry_19
XU7 XOR3 $PINS O=SUM[14] I1=A[14] I2=B[14] I3=carry[14]
XU8 ND2P $PINS O=n25 I1=n22 I2=B[14]
XU9 ND2 $PINS O=n26 I1=A[14] I2=B[14]
XU10 AN2 $PINS O=n1 I1=B[0] I2=A[0]
XU11 ND2 $PINS O=n3 I1=A[7] I2=carry[7]
XU12 ND2P $PINS O=n4 I1=B[7] I2=carry[7]
XU14 XOR2HS $PINS O=n5 I1=A[8] I2=B[8]
XU15 XOR2HS $PINS O=SUM[8] I1=n5 I2=FE_OCPN877_carry_8
XU16 ND2 $PINS O=n6 I1=A[8] I2=B[8]
XU17 ND2 $PINS O=n7 I1=carry[8] I2=A[8]
XU18 ND2 $PINS O=n8 I1=B[8] I2=carry[8]
XU19 ND3P $PINS O=carry[9] I1=n8 I2=n7 I3=n6
XU20 ND2 $PINS O=n10 I1=carry[19] I2=A[19]
XU21 ND2 $PINS O=n11 I1=carry[19] I2=B[19]
XU23 XOR2HS $PINS O=n12 I1=A[20] I2=B[20]
XU24 ND2 $PINS O=n13 I1=A[20] I2=B[20]
XU25 ND2 $PINS O=n14 I1=carry[20] I2=A[20]
XU26 ND2 $PINS O=n15 I1=carry[20] I2=B[20]
XU28 MAO222 $PINS O=n16 A1=A[9] B1=B[9] C1=carry[9]
XU33 MAO222S $PINS O=n21 A1=A[12] B1=B[12] C1=carry[12]
XU36 ND2P $PINS O=n24 I1=n23 I2=A[14]
XU37 XOR2HS $PINS O=SUM[0] I1=B[0] I2=A[0]
.ENDS

.SUBCKT PE_Shift_Add_5 rst_n en clear calc_done stage_sel x_in[16] x_in[15]
+ x_in[14] x_in[13] x_in[12] x_in[11] x_in[10] x_in[9] x_in[8] x_in[7] x_in[6]
+ x_in[5] x_in[4] x_in[3] x_in[2] x_in[1] x_in[0] sign1[1] sign1[0] sign2[1]
+ sign2[0] sign3[1] sign3[0] shf1[3] shf1[2] shf1[1] shf1[0] shf2[3] shf2[2]
+ shf2[1] shf2[0] shf3[3] shf3[2] shf3[1] shf3[0] y_out[16] y_out[15] y_out[14]
+ y_out[13] y_out[12] y_out[11] y_out[10] y_out[9] y_out[8] y_out[7] y_out[6]
+ y_out[5] y_out[4] y_out[3] y_out[2] y_out[1] y_out[0] i_rst_n
+ FE_OFN48_i_rst_n FE_OFN36_i_rst_n FE_OFN83_s11_0 FE_OFN149_h12_1
+ FE_OFN152_s13_0 FE_OFN156_s12_0 FE_OFN154_s12_0 FE_OFN169_h11_1
+ FE_OFN173_h13_1 FE_OFN174_h11_3 clk_clone1 clk_clone2 clk
XFE_PHC2046_next_acc_8 BUF1CK $PINS O=FE_PHN2046_next_acc_8 I=next_acc[8]
XFE_PHC1891_N235 DELC $PINS O=FE_PHN1891_N235 I=N235
XFE_PHC1889_N239 DELC $PINS O=N239 I=FE_PHN1889_N239
XFE_PHC1878_N250 DELC $PINS O=N250 I=FE_PHN1878_N250
XFE_PHC1872_N248 DELC $PINS O=N248 I=FE_PHN1872_N248
XFE_PHC1861_N249 DELC $PINS O=N249 I=FE_PHN1861_N249
XFE_PHC1854_N247 DELC $PINS O=N247 I=FE_PHN1854_N247
XFE_PHC1612_pe_r1_1 DELC $PINS O=y_out[1] I=FE_PHN1612_pe_r1_1
XFE_PHC1565_next_acc_0 DELB $PINS O=FE_PHN1565_next_acc_0 I=next_acc[0]
XFE_PHC1527_N246 DELC $PINS O=N246 I=FE_PHN1527_N246
XFE_PHC1516_N240 DELC $PINS O=N240 I=FE_PHN1516_N240
XFE_PHC1510_N242 DELC $PINS O=N242 I=FE_PHN1510_N242
XFE_PHC1505_N236 DELC $PINS O=FE_PHN1505_N236 I=N236
XFE_PHC1503_N245 DELC $PINS O=FE_PHN1503_N245 I=N245
XFE_PHC1500_N237 DELC $PINS O=N237 I=FE_PHN1500_N237
XFE_PHC1496_N238 DELC $PINS O=FE_PHN1496_N238 I=N238
XFE_PHC1491_N241 DELC $PINS O=N241 I=FE_PHN1491_N241
XFE_PHC1482_N244 DELC $PINS O=N244 I=FE_PHN1482_N244
XFE_PHC1429_N243 DELC $PINS O=FE_PHN1429_N243 I=N243
XFE_PHC1382_acc_reg_14 DELB $PINS O=FE_PHN1382_acc_reg_14 I=acc_reg[14]
XFE_PHC1330_N251 DELC $PINS O=FE_PHN1330_N251 I=N251
XFE_RC_311_0 MUX2 $PINS O=N99 S=FE_OFN449_n A=N72 B=term2_shifted[3]
XFE_RC_229_0 AO22 $PINS O=N117 A1=term2_shifted[21] A2=FE_OFN156_s12_0 B1=N90
+ B2=FE_OFN154_s12_0
XFE_RC_161_0 OR2 $PINS O=FE_RN_77_0 I1=FE_RN_1959_0 I2=FE_RN_1944_0
XFE_RC_160_0 ND2 $PINS O=N156 I1=FE_RN_1945_0 I2=FE_RN_77_0
XFE_OCPC1190_term3_shifted_2 BUF1S $PINS O=FE_OCPN1190_term3_shifted_2
+ I=term3_shifted[2]
XFE_OCPC1043_n70 BUF1S $PINS O=FE_OCPN1043_n70 I=n70
XFE_OFC882_FE_OFN81_h12_0 BUF4 $PINS O=FE_OFN486_FE_OFN81_h12_0 I=shf2[0]
XFE_OFC879_FE_OFN75_h11_0 BUF1 $PINS O=FE_OFN483_FE_OFN75_h11_0 I=shf1[0]
XFE_OCPC896_N191 BUF3 $PINS O=FE_OCPN896_N191 I=N191
XFE_RC_4028_0 AO22 $PINS O=N63 A1=term1_shifted[22] A2=n39 B1=N36
+ B2=FE_OFN83_s11_0
XFE_RC_3974_0 OR2 $PINS O=FE_RN_2576_0 I1=FE_RN_1959_0 I2=FE_RN_1960_0
XFE_RC_3973_0 ND2 $PINS O=N155 I1=FE_RN_1961_0 I2=FE_RN_2576_0
XFE_RC_3638_0 ND2 $PINS O=FE_RN_2379_0 I1=term1_in[1]
+ I2=FE_OFN483_FE_OFN75_h11_0
XFE_RC_3637_0 INV1S $PINS O=FE_RN_2380_0 I=shf1[0]
XFE_RC_3636_0 ND2 $PINS O=FE_RN_2381_0 I1=term1_in[2] I2=FE_RN_2380_0
XFE_RC_3635_0 ND2 $PINS O=sll_16/ML_int[1][2] I1=FE_RN_2381_0 I2=FE_RN_2379_0
XFE_RC_3425_0 ND2 $PINS O=FE_RN_2230_0 I1=FE_OCPN1190_term3_shifted_2
+ I2=FE_OFN270_s13_0
XFE_RC_3424_0 ND2 $PINS O=FE_RN_2231_0 I1=N126 I2=FE_OFN379_s13_0
XFE_RC_3423_0 ND2 $PINS O=N153 I1=FE_RN_2231_0 I2=FE_RN_2230_0
XFE_RC_3143_0 INV2 $PINS O=N43 I=FE_RN_2025_0
XFE_RC_3142_0 AOI22S $PINS O=FE_RN_2025_0 A1=term1_shifted[2]
+ A2=FE_OFN284_s11_0 B1=N16 B2=FE_OFN83_s11_0
XFE_RC_3125_0 ND2P $PINS O=FE_RN_2012_0 I1=term3_in[0] I2=shf3[0]
XFE_RC_3124_0 INV1S $PINS O=FE_RN_2013_0 I=shf3[0]
XFE_RC_3123_0 ND2 $PINS O=FE_RN_2014_0 I1=n5 I2=FE_RN_2013_0
XFE_RC_3122_0 ND2P $PINS O=sll_18/ML_int[1][1] I1=FE_RN_2014_0 I2=FE_RN_2012_0
XFE_RC_3042_0 INV1S $PINS O=FE_RN_1959_0 I=FE_OFN270_s13_0
XFE_RC_3041_0 INV2 $PINS O=FE_RN_1960_0 I=term3_shifted[4]
XFE_RC_3040_0 ND2S $PINS O=FE_RN_1961_0 I1=N128 I2=FE_OFN379_s13_0
XFE_RC_3038_0 INV1S $PINS O=FE_RN_1956_0 I=n39
XFE_RC_3037_0 INV1S $PINS O=FE_RN_1957_0 I=term1_shifted[5]
XFE_RC_3036_0 ND2 $PINS O=FE_RN_1958_0 I1=N19 I2=FE_OFN83_s11_0
XFE_RC_3035_0 OAI12HS $PINS O=N46 A1=FE_RN_1958_0 B1=FE_RN_1957_0
+ B2=FE_RN_1956_0
XFE_RC_3021_0 INV1S $PINS O=FE_RN_1944_0 I=term3_shifted[5]
XFE_RC_3020_0 ND2 $PINS O=FE_RN_1945_0 I1=N129 I2=FE_OFN379_s13_0
XFE_RC_3005_0 ND2 $PINS O=FE_RN_1931_0 I1=term1_shifted[8] I2=n39
XFE_RC_3004_0 ND2S $PINS O=FE_RN_1932_0 I1=N22 I2=FE_OFN83_s11_0
XFE_RC_3003_0 ND2P $PINS O=N49 I1=FE_RN_1932_0 I2=FE_RN_1931_0
XFE_RC_2993_0 INV1S $PINS O=FE_RN_1923_0 I=FE_OFN443_h13_1
XFE_RC_2992_0 INV2 $PINS O=sll_18/ML_int[2][2] I=FE_RN_1924_0
XFE_RC_2991_0 AOI22H $PINS O=FE_RN_1924_0 A1=sll_18/ML_int[1][0]
+ A2=FE_OFN443_h13_1 B1=sll_18/ML_int[1][2] B2=FE_RN_1923_0
XFE_RC_2989_0 INV2 $PINS O=FE_RN_1922_0 I=term3_shifted[3]
XFE_RC_2988_0 MOAI1H $PINS O=N154 A1=FE_RN_1922_0 A2=FE_RN_1959_0 B1=N127
+ B2=FE_OFN379_s13_0
XFE_RC_2866_0 ND2 $PINS O=FE_RN_1831_0 I1=term3_shifted[1] I2=FE_OFN270_s13_0
XFE_RC_2865_0 ND2 $PINS O=FE_RN_1832_0 I1=N125 I2=FE_OFN379_s13_0
XFE_RC_2864_0 ND2 $PINS O=N152 I1=FE_RN_1832_0 I2=FE_RN_1831_0
XFE_RC_2805_0 ND2 $PINS O=FE_RN_1784_0 I1=n54 I2=shf1[2]
XFE_RC_2804_0 INV1S $PINS O=FE_RN_1785_0 I=shf1[2]
XFE_RC_2803_0 ND2 $PINS O=FE_RN_1786_0 I1=sll_16/ML_int[2][5] I2=FE_RN_1785_0
XFE_RC_2802_0 ND2 $PINS O=sll_16/ML_int[3][5] I1=FE_RN_1786_0 I2=FE_RN_1784_0
XFE_RC_2779_0 INV1S $PINS O=FE_RN_1766_0 I=n33
XFE_RC_2778_0 INV1S $PINS O=FE_RN_1767_0 I=sll_16/ML_int[1][1]
XFE_RC_2777_0 INV1S $PINS O=FE_RN_1768_0 I=n33
XFE_RC_2776_0 ND2S $PINS O=FE_RN_1769_0 I1=sll_16/ML_int[1][3] I2=FE_RN_1768_0
XFE_RC_2775_0 OAI12H $PINS O=sll_16/ML_int[2][3] A1=FE_RN_1769_0
+ B1=FE_RN_1767_0 B2=FE_RN_1766_0
XFE_RC_2716_0 ND2 $PINS O=FE_RN_1720_0 I1=term2_in[1]
+ I2=FE_OFN486_FE_OFN81_h12_0
XFE_RC_2715_0 INV1S $PINS O=FE_RN_1721_0 I=shf2[0]
XFE_RC_2714_0 ND2S $PINS O=FE_RN_1722_0 I1=term2_in[2] I2=FE_RN_1721_0
XFE_RC_2713_0 ND2 $PINS O=sll_17/ML_int[1][2] I1=FE_RN_1722_0 I2=FE_RN_1720_0
XFE_RC_2649_0 ND2 $PINS O=FE_RN_1673_0 I1=term1_shifted[1] I2=FE_OFN284_s11_0
XFE_RC_2648_0 ND2 $PINS O=FE_RN_1674_0 I1=N15 I2=FE_OFN83_s11_0
XFE_RC_2647_0 ND2 $PINS O=N42 I1=FE_RN_1674_0 I2=FE_RN_1673_0
XFE_RC_2543_0 INV1S $PINS O=FE_RN_1594_0 I=shf2[0]
XFE_RC_2542_0 ND2S $PINS O=FE_RN_1595_0 I1=term2_in[1] I2=FE_RN_1594_0
XFE_RC_2541_0 ND2P $PINS O=FE_RN_1596_0 I1=term2_in[0]
+ I2=FE_OFN486_FE_OFN81_h12_0
XFE_RC_2540_0 ND2 $PINS O=sll_17/ML_int[1][1] I1=FE_RN_1596_0 I2=FE_RN_1595_0
XFE_RC_2487_0 ND2 $PINS O=FE_RN_1552_0 I1=term1_shifted[4] I2=n39
XFE_RC_2486_0 ND2 $PINS O=FE_RN_1553_0 I1=N18 I2=FE_OFN83_s11_0
XFE_RC_2485_0 ND2 $PINS O=N45 I1=FE_RN_1553_0 I2=FE_RN_1552_0
XFE_RC_2307_0 INV1S $PINS O=FE_RN_1417_0 I=n25
XFE_RC_2306_0 INV1S $PINS O=FE_RN_1418_0 I=sll_17/ML_int[1][1]
XFE_RC_2305_0 INV1S $PINS O=FE_RN_1419_0 I=n25
XFE_RC_2304_0 ND2S $PINS O=FE_RN_1420_0 I1=sll_17/ML_int[1][3] I2=FE_RN_1419_0
XFE_RC_2303_0 OAI12HS $PINS O=sll_17/ML_int[2][3] A1=FE_RN_1420_0
+ B1=FE_RN_1418_0 B2=FE_RN_1417_0
XFE_RC_2281_0 ND2 $PINS O=FE_RN_1398_0 I1=term2_shifted[4] I2=FE_OFN449_n
XFE_RC_2280_0 ND2 $PINS O=FE_RN_1399_0 I1=N73 I2=FE_OFN396_s12_0
XFE_RC_2279_0 ND2 $PINS O=N100 I1=FE_RN_1399_0 I2=FE_RN_1398_0
XFE_RC_1694_0 INV1S $PINS O=FE_RN_957_0 I=n72
XFE_RC_1693_0 INV2 $PINS O=term3_shifted[1] I=FE_RN_958_0
XFE_RC_1692_0 ND3P $PINS O=FE_RN_958_0 I1=sll_18/ML_int[1][1] I2=FE_RN_957_0
+ I3=FE_OFN173_h13_1
XFE_RC_15_0 OA12 $PINS O=N151 A1=N124 B1=FE_OFN379_s13_0 B2=FE_OFN270_s13_0
XFE_RC_9_0 OA12P $PINS O=N41 A1=N14 B1=FE_OFN83_s11_0 B2=FE_OFN284_s11_0
XFE_RC_2_0 OA12 $PINS O=N96 A1=term2_shifted[0] B1=FE_OFN396_s12_0
+ B2=FE_OFN449_n
XFE_OFC866_h13_0 BUF1 $PINS O=FE_OFN469_h13_0 I=shf3[0]
XFE_OFC857_h11_2 BUF1 $PINS O=FE_OFN463_h11_2 I=shf1[2]
XFE_OFC834_s12_0 INV2 $PINS O=FE_OFN449_n I=FE_OFN396_s12_0
XFE_OFC833_s12_0 INV1S $PINS O=FE_OFN396_s12_0 I=sign2[0]
XFE_OFC824_sll_17_ML_int_2__3 INV1S $PINS O=n62 I=sll_17/ML_int[2][3]
XFE_OFC815_s13_1 BUF1 $PINS O=FE_OFN445_s13_1 I=sign3[1]
XFE_OFC805_h13_1 BUF1 $PINS O=FE_OFN443_h13_1 I=shf3[1]
XFE_OFC801_h12_1 BUF1 $PINS O=n25 I=shf2[1]
XFE_OFC781_s13_0 INV2 $PINS O=FE_OFN379_s13_0 I=FE_OFN270_s13_0
XFE_OFC760_sll_18_ML_int_2__3 INV1S $PINS O=n73 I=sll_18/ML_int[2][3]
XFE_OFC743_h11_1 BUF1 $PINS O=n33 I=shf1[1]
XFE_OFC680_s12_0 INV1S $PINS O=FE_OFN395_s12_0 I=FE_OFN396_s12_0
XFE_OFC635_s13_0 INV1S $PINS O=FE_OFN270_s13_0 I=sign3[0]
XFE_OFC608_h12_3 INV1S $PINS O=n27 I=shf2[3]
XFE_OFC607_h12_3 INV1S $PINS O=FE_OFN259_h12_3 I=shf2[3]
XFE_OFC595_h13_3 INV1S $PINS O=FE_OFN363_h13_3 I=shf3[3]
XFE_OFC594_h13_3 INV1S $PINS O=n15 I=shf3[3]
XFE_OFC534_h13_2 INV1S $PINS O=n13 I=shf3[2]
XFE_OFC429_h11_2 INV1S $PINS O=n35 I=shf1[2]
XFE_OFC401_h11_3 INV1S $PINS O=n36 I=shf1[3]
XFE_OFC390_s11_0 INV1S $PINS O=FE_OFN284_s11_0 I=FE_OFN83_s11_0
XFE_OFC389_s11_0 INV1S $PINS O=n39 I=FE_OFN83_s11_0
XFE_OFC377_pe_clear_d1 INV2 $PINS O=n98 I=clear
XFE_OFC329_s13_0 INV1S $PINS O=n18 I=FE_OFN379_s13_0
XFE_OFC302_h12_2 BUF2 $PINS O=FE_OFN260_h12_2 I=shf2[2]
XFE_OFC17_i_rst_n BUF1 $PINS O=FE_OFN17_i_rst_n I=i_rst_n
XU110 AO22 $PINS O=base_val[13] A1=acc_reg[13] A2=n98 B1=clear B2=stage_sel
XU120 AO22 $PINS O=N62 A1=N35 A2=FE_OFN83_s11_0 B1=term1_shifted[21] B2=n39
XU121 AO22 $PINS O=N61 A1=N34 A2=FE_OFN83_s11_0 B1=term1_shifted[20] B2=n39
XU122 AO22 $PINS O=N60 A1=N33 A2=FE_OFN83_s11_0 B1=term1_shifted[19] B2=n39
XU132 AO22P $PINS O=N50 A1=N23 A2=FE_OFN83_s11_0 B1=term1_shifted[9] B2=n39
XU134 AO22 $PINS O=N48 A1=N21 A2=FE_OFN83_s11_0 B1=term1_shifted[7] B2=n39
XU138 AO22P $PINS O=N44 A1=N17 A2=FE_OFN83_s11_0 B1=term1_shifted[3]
+ B2=FE_OFN284_s11_0
XU142 AO22 $PINS O=N177 A1=FE_OFN152_s13_0 A2=N150 B1=term3_shifted[26] B2=n18
XU143 AO22 $PINS O=N176 A1=N149 A2=FE_OFN152_s13_0 B1=term3_shifted[25] B2=n18
XU144 AO22 $PINS O=N175 A1=N148 A2=FE_OFN152_s13_0 B1=term3_shifted[24] B2=n18
XU145 AO22 $PINS O=N174 A1=N147 A2=FE_OFN152_s13_0 B1=term3_shifted[23] B2=n18
XU146 AO22 $PINS O=N173 A1=N146 A2=FE_OFN152_s13_0 B1=term3_shifted[22] B2=n18
XU147 AO22 $PINS O=N172 A1=N145 A2=FE_OFN152_s13_0 B1=term3_shifted[21] B2=n18
XU148 AO22 $PINS O=N171 A1=N144 A2=FE_OFN152_s13_0 B1=term3_shifted[20] B2=n18
XU149 AO22 $PINS O=N170 A1=N143 A2=FE_OFN379_s13_0 B1=term3_shifted[19] B2=n18
XU150 AO22 $PINS O=N169 A1=N142 A2=FE_OFN379_s13_0 B1=term3_shifted[18] B2=n18
XU151 AO22 $PINS O=N168 A1=N141 A2=FE_OFN379_s13_0 B1=term3_shifted[17] B2=n18
XU152 AO22 $PINS O=N167 A1=N140 A2=FE_OFN379_s13_0 B1=term3_shifted[16] B2=n18
XU153 AO22 $PINS O=N166 A1=N139 A2=FE_OFN379_s13_0 B1=term3_shifted[15] B2=n18
XU154 AO22 $PINS O=N165 A1=N138 A2=FE_OFN379_s13_0 B1=term3_shifted[14] B2=n18
XU155 AO22 $PINS O=N164 A1=N137 A2=FE_OFN379_s13_0 B1=term3_shifted[13] B2=n18
XU156 AO22 $PINS O=N163 A1=N136 A2=FE_OFN379_s13_0 B1=term3_shifted[12] B2=n18
XU157 AO22 $PINS O=N162 A1=N135 A2=FE_OFN379_s13_0 B1=term3_shifted[11] B2=n18
XU158 AO22 $PINS O=N161 A1=N134 A2=FE_OFN379_s13_0 B1=term3_shifted[10]
+ B2=FE_OFN270_s13_0
XU159 AO22P $PINS O=N160 A1=N133 A2=FE_OFN379_s13_0 B1=term3_shifted[9]
+ B2=FE_OFN270_s13_0
XU160 AO22 $PINS O=N159 A1=N132 A2=FE_OFN379_s13_0 B1=term3_shifted[8]
+ B2=FE_OFN270_s13_0
XU161 AO22 $PINS O=N158 A1=N131 A2=FE_OFN379_s13_0 B1=term3_shifted[7]
+ B2=FE_OFN270_s13_0
XU169 AO22 $PINS O=N122 A1=N95 A2=FE_OFN154_s12_0 B1=term2_shifted[26]
+ B2=FE_OFN156_s12_0
XU171 AO22 $PINS O=N120 A1=N93 A2=FE_OFN154_s12_0 B1=term2_shifted[24]
+ B2=FE_OFN156_s12_0
XU172 AO22 $PINS O=N119 A1=N92 A2=FE_OFN154_s12_0 B1=term2_shifted[23]
+ B2=FE_OFN156_s12_0
XU173 AO22 $PINS O=N118 A1=N91 A2=FE_OFN154_s12_0 B1=term2_shifted[22]
+ B2=FE_OFN156_s12_0
XU175 AO22 $PINS O=N116 A1=N89 A2=FE_OFN154_s12_0 B1=term2_shifted[20]
+ B2=FE_OFN395_s12_0
XU176 AO22 $PINS O=N115 A1=N88 A2=FE_OFN396_s12_0 B1=term2_shifted[19]
+ B2=FE_OFN395_s12_0
XU177 AO22 $PINS O=N114 A1=N87 A2=FE_OFN396_s12_0 B1=term2_shifted[18]
+ B2=FE_OFN395_s12_0
XU178 AO22P $PINS O=N113 A1=N86 A2=FE_OFN396_s12_0 B1=term2_shifted[17]
+ B2=FE_OFN395_s12_0
XU179 AO22 $PINS O=N112 A1=N85 A2=FE_OFN396_s12_0 B1=term2_shifted[16]
+ B2=FE_OFN395_s12_0
XU180 AO22 $PINS O=N111 A1=N84 A2=FE_OFN396_s12_0 B1=term2_shifted[15]
+ B2=FE_OFN395_s12_0
XU181 AO22 $PINS O=N110 A1=N83 A2=FE_OFN396_s12_0 B1=term2_shifted[14]
+ B2=FE_OFN395_s12_0
XU183 AO22 $PINS O=N108 A1=N81 A2=FE_OFN396_s12_0 B1=term2_shifted[12]
+ B2=FE_OFN395_s12_0
XU184 AO22 $PINS O=N107 A1=N80 A2=FE_OFN396_s12_0 B1=term2_shifted[11]
+ B2=FE_OFN395_s12_0
XU185 AO22 $PINS O=N106 A1=N79 A2=FE_OFN396_s12_0 B1=term2_shifted[10]
+ B2=FE_OFN449_n
XU186 AO22 $PINS O=N105 A1=N78 A2=FE_OFN396_s12_0 B1=term2_shifted[9]
+ B2=FE_OFN449_n
XU187 AO22 $PINS O=N104 A1=N77 A2=FE_OFN396_s12_0 B1=term2_shifted[8]
+ B2=FE_OFN449_n
XU188 AO22 $PINS O=N103 A1=N76 A2=FE_OFN396_s12_0 B1=term2_shifted[7]
+ B2=FE_OFN449_n
XU189 AO22P $PINS O=N102 A1=N75 A2=FE_OFN396_s12_0 B1=term2_shifted[6]
+ B2=FE_OFN449_n
XU190 AO22 $PINS O=N101 A1=N74 A2=FE_OFN396_s12_0 B1=term2_shifted[5]
+ B2=FE_OFN449_n
Xsll_18/M1_0_2 MUX2 $PINS O=sll_18/ML_int[1][2] S=shf3[0] A=term3_in[2]
+ B=term3_in[1]
Xsll_18/M1_0_4 MUX2 $PINS O=sll_18/ML_int[1][4] S=shf3[0] A=term3_in[4]
+ B=term3_in[3]
Xsll_18/M1_0_5 MUX2 $PINS O=sll_18/ML_int[1][5] S=shf3[0] A=term3_in[5]
+ B=term3_in[4]
Xsll_18/M1_0_6 MUX2 $PINS O=sll_18/ML_int[1][6] S=shf3[0] A=term3_in[6]
+ B=term3_in[5]
Xsll_18/M1_0_7 MUX2 $PINS O=sll_18/ML_int[1][7] S=FE_OFN469_h13_0 A=term3_in[7]
+ B=term3_in[6]
Xsll_18/M1_0_8 MUX2 $PINS O=sll_18/ML_int[1][8] S=FE_OFN469_h13_0 A=term3_in[8]
+ B=term3_in[7]
Xsll_18/M1_0_9 MUX2 $PINS O=sll_18/ML_int[1][9] S=FE_OFN469_h13_0 A=term3_in[9]
+ B=term3_in[8]
Xsll_18/M1_0_10 MUX2 $PINS O=sll_18/ML_int[1][10] S=FE_OFN469_h13_0
+ A=term3_in[10] B=term3_in[9]
Xsll_18/M1_1_3 MUX2 $PINS O=sll_18/ML_int[2][3] S=FE_OFN443_h13_1
+ A=sll_18/ML_int[1][3] B=sll_18/ML_int[1][1]
Xsll_18/M1_1_4 MUX2 $PINS O=sll_18/ML_int[2][4] S=FE_OFN443_h13_1
+ A=sll_18/ML_int[1][4] B=sll_18/ML_int[1][2]
Xsll_18/M1_1_5 MUX2 $PINS O=sll_18/ML_int[2][5] S=FE_OFN443_h13_1
+ A=sll_18/ML_int[1][5] B=sll_18/ML_int[1][3]
Xsll_18/M1_1_6 MUX2 $PINS O=sll_18/ML_int[2][6] S=FE_OFN443_h13_1
+ A=sll_18/ML_int[1][6] B=sll_18/ML_int[1][4]
Xsll_18/M1_1_7 MUX2 $PINS O=sll_18/ML_int[2][7] S=FE_OFN443_h13_1
+ A=sll_18/ML_int[1][7] B=sll_18/ML_int[1][5]
Xsll_18/M1_1_8 MUX2 $PINS O=sll_18/ML_int[2][8] S=FE_OFN443_h13_1
+ A=sll_18/ML_int[1][8] B=sll_18/ML_int[1][6]
Xsll_18/M1_1_9 MUX2 $PINS O=sll_18/ML_int[2][9] S=FE_OFN443_h13_1
+ A=sll_18/ML_int[1][9] B=sll_18/ML_int[1][7]
Xsll_18/M1_1_10 MUX2 $PINS O=sll_18/ML_int[2][10] S=FE_OFN443_h13_1
+ A=sll_18/ML_int[1][10] B=sll_18/ML_int[1][8]
Xsll_18/M1_1_11 MUX2 $PINS O=sll_18/ML_int[2][11] S=FE_OFN443_h13_1
+ A=sll_18/ML_int[1][11] B=sll_18/ML_int[1][9]
Xsll_18/M1_2_4 MUX2 $PINS O=sll_18/ML_int[3][4] S=shf3[2] A=sll_18/ML_int[2][4]
+ B=n75
Xsll_18/M1_2_5 MUX2 $PINS O=sll_18/ML_int[3][5] S=shf3[2] A=sll_18/ML_int[2][5]
+ B=n76
Xsll_18/M1_2_6 MUX2 $PINS O=sll_18/ML_int[3][6] S=shf3[2] A=sll_18/ML_int[2][6]
+ B=sll_18/ML_int[2][2]
Xsll_18/M1_2_7 MUX2 $PINS O=sll_18/ML_int[3][7] S=shf3[2] A=sll_18/ML_int[2][7]
+ B=sll_18/ML_int[2][3]
Xsll_18/M1_3_8 MUX2 $PINS O=term3_shifted[8] S=FE_OFN363_h13_3
+ A=sll_18/ML_int[3][8] B=sll_18/ML_int[3][0]
Xsll_18/M1_3_9 MUX2 $PINS O=term3_shifted[9] S=FE_OFN363_h13_3
+ A=sll_18/ML_int[3][9] B=sll_18/ML_int[3][1]
Xsll_18/M1_3_10 MUX2 $PINS O=term3_shifted[10] S=FE_OFN363_h13_3
+ A=sll_18/ML_int[3][10] B=sll_18/ML_int[3][2]
Xsll_18/M1_3_11 MUX2 $PINS O=term3_shifted[11] S=FE_OFN363_h13_3
+ A=sll_18/ML_int[3][11] B=sll_18/ML_int[3][3]
Xsll_18/M1_3_12 MUX2 $PINS O=term3_shifted[12] S=FE_OFN363_h13_3
+ A=sll_18/ML_int[3][12] B=sll_18/ML_int[3][4]
Xsll_18/M1_3_13 MUX2 $PINS O=term3_shifted[13] S=FE_OFN363_h13_3
+ A=sll_18/ML_int[3][13] B=sll_18/ML_int[3][5]
Xsll_18/M1_3_14 MUX2 $PINS O=term3_shifted[14] S=FE_OFN363_h13_3
+ A=sll_18/ML_int[3][14] B=sll_18/ML_int[3][6]
Xsll_18/M1_3_15 MUX2 $PINS O=term3_shifted[15] S=FE_OFN363_h13_3
+ A=sll_18/ML_int[3][15] B=sll_18/ML_int[3][7]
Xsll_18/M1_3_16 MUX2 $PINS O=term3_shifted[16] S=FE_OFN363_h13_3
+ A=sll_18/ML_int[3][16] B=sll_18/ML_int[3][8]
Xsll_18/M1_3_17 MUX2 $PINS O=term3_shifted[17] S=FE_OFN363_h13_3
+ A=sll_18/ML_int[3][17] B=sll_18/ML_int[3][9]
Xsll_18/M1_3_22 MUX2 $PINS O=term3_shifted[22] S=n15 A=sll_18/ML_int[3][22]
+ B=sll_18/ML_int[3][14]
Xsll_18/M1_3_23 MUX2 $PINS O=term3_shifted[23] S=n15 A=term3_in[26]
+ B=sll_18/ML_int[3][15]
Xsll_17/M1_0_3 MUX2 $PINS O=sll_17/ML_int[1][3] S=FE_OFN486_FE_OFN81_h12_0
+ A=term2_in[3] B=term2_in[2]
Xsll_17/M1_0_4 MUX2 $PINS O=sll_17/ML_int[1][4] S=FE_OFN486_FE_OFN81_h12_0
+ A=term2_in[4] B=term2_in[3]
Xsll_17/M1_0_6 MUX2 $PINS O=sll_17/ML_int[1][6] S=FE_OFN486_FE_OFN81_h12_0
+ A=term2_in[6] B=term2_in[5]
Xsll_17/M1_0_7 MUX2 $PINS O=sll_17/ML_int[1][7] S=FE_OFN486_FE_OFN81_h12_0
+ A=term2_in[7] B=term2_in[6]
Xsll_17/M1_0_8 MUX2 $PINS O=sll_17/ML_int[1][8] S=FE_OFN486_FE_OFN81_h12_0
+ A=term2_in[8] B=term2_in[7]
Xsll_17/M1_0_9 MUX2 $PINS O=sll_17/ML_int[1][9] S=FE_OFN486_FE_OFN81_h12_0
+ A=term2_in[9] B=term2_in[8]
Xsll_17/M1_0_10 MUX2 $PINS O=sll_17/ML_int[1][10] S=FE_OFN486_FE_OFN81_h12_0
+ A=term2_in[10] B=term2_in[9]
Xsll_17/M1_1_5 MUX2 $PINS O=sll_17/ML_int[2][5] S=n25 A=sll_17/ML_int[1][5]
+ B=sll_17/ML_int[1][3]
Xsll_17/M1_1_6 MUX2 $PINS O=sll_17/ML_int[2][6] S=n25 A=sll_17/ML_int[1][6]
+ B=sll_17/ML_int[1][4]
Xsll_17/M1_1_7 MUX2 $PINS O=sll_17/ML_int[2][7] S=n25 A=sll_17/ML_int[1][7]
+ B=sll_17/ML_int[1][5]
Xsll_17/M1_1_8 MUX2 $PINS O=sll_17/ML_int[2][8] S=n25 A=sll_17/ML_int[1][8]
+ B=sll_17/ML_int[1][6]
Xsll_17/M1_1_9 MUX2 $PINS O=sll_17/ML_int[2][9] S=n25 A=sll_17/ML_int[1][9]
+ B=sll_17/ML_int[1][7]
Xsll_17/M1_1_10 MUX2 $PINS O=sll_17/ML_int[2][10] S=n25 A=sll_17/ML_int[1][10]
+ B=sll_17/ML_int[1][8]
Xsll_17/M1_1_11 MUX2 $PINS O=sll_17/ML_int[2][11] S=n25 A=sll_17/ML_int[1][11]
+ B=sll_17/ML_int[1][9]
Xsll_17/M1_2_4 MUX2 $PINS O=sll_17/ML_int[3][4] S=FE_OFN260_h12_2
+ A=sll_17/ML_int[2][4] B=n64
Xsll_17/M1_2_5 MUX2 $PINS O=sll_17/ML_int[3][5] S=FE_OFN260_h12_2
+ A=sll_17/ML_int[2][5] B=n65
Xsll_17/M1_2_7 MUX2 $PINS O=sll_17/ML_int[3][7] S=FE_OFN260_h12_2
+ A=sll_17/ML_int[2][7] B=sll_17/ML_int[2][3]
Xsll_17/M1_2_8 MUX2 $PINS O=sll_17/ML_int[3][8] S=FE_OFN260_h12_2
+ A=sll_17/ML_int[2][8] B=sll_17/ML_int[2][4]
Xsll_17/M1_2_9 MUX2 $PINS O=sll_17/ML_int[3][9] S=FE_OFN260_h12_2
+ A=sll_17/ML_int[2][9] B=sll_17/ML_int[2][5]
Xsll_17/M1_2_10 MUX2 $PINS O=sll_17/ML_int[3][10] S=FE_OFN260_h12_2
+ A=sll_17/ML_int[2][10] B=sll_17/ML_int[2][6]
Xsll_17/M1_2_12 MUX2 $PINS O=sll_17/ML_int[3][12] S=FE_OFN260_h12_2
+ A=sll_17/ML_int[2][12] B=sll_17/ML_int[2][8]
Xsll_17/M1_2_13 MUX2 $PINS O=sll_17/ML_int[3][13] S=FE_OFN260_h12_2
+ A=sll_17/ML_int[2][13] B=sll_17/ML_int[2][9]
Xsll_17/M1_3_8 MUX2 $PINS O=term2_shifted[8] S=n27 A=sll_17/ML_int[3][8]
+ B=sll_17/ML_int[3][0]
Xsll_17/M1_3_9 MUX2 $PINS O=term2_shifted[9] S=n27 A=sll_17/ML_int[3][9]
+ B=sll_17/ML_int[3][1]
Xsll_17/M1_3_10 MUX2 $PINS O=term2_shifted[10] S=n27 A=sll_17/ML_int[3][10]
+ B=sll_17/ML_int[3][2]
Xsll_17/M1_3_11 MUX2 $PINS O=term2_shifted[11] S=n27 A=sll_17/ML_int[3][11]
+ B=sll_17/ML_int[3][3]
Xsll_17/M1_3_12 MUX2 $PINS O=term2_shifted[12] S=n27 A=sll_17/ML_int[3][12]
+ B=sll_17/ML_int[3][4]
Xsll_17/M1_3_13 MUX2 $PINS O=term2_shifted[13] S=n27 A=sll_17/ML_int[3][13]
+ B=sll_17/ML_int[3][5]
Xsll_17/M1_3_14 MUX2 $PINS O=term2_shifted[14] S=n27 A=sll_17/ML_int[3][14]
+ B=sll_17/ML_int[3][6]
Xsll_17/M1_3_16 MUX2 $PINS O=term2_shifted[16] S=n27 A=sll_17/ML_int[3][16]
+ B=sll_17/ML_int[3][8]
Xsll_17/M1_3_17 MUX2 $PINS O=term2_shifted[17] S=FE_OFN259_h12_3
+ A=sll_17/ML_int[3][17] B=sll_17/ML_int[3][9]
Xsll_17/M1_3_22 MUX2 $PINS O=term2_shifted[22] S=FE_OFN259_h12_3
+ A=sll_17/ML_int[3][22] B=sll_17/ML_int[3][14]
Xsll_17/M1_3_23 MUX2 $PINS O=term2_shifted[23] S=FE_OFN259_h12_3 A=term2_in[26]
+ B=sll_17/ML_int[3][15]
Xsll_16/M1_0_1 MUX2 $PINS O=sll_16/ML_int[1][1] S=FE_OFN483_FE_OFN75_h11_0
+ A=term1_in[1] B=term1_in[0]
Xsll_16/M1_0_4 MUX2 $PINS O=sll_16/ML_int[1][4] S=FE_OFN483_FE_OFN75_h11_0
+ A=term1_in[4] B=term1_in[3]
Xsll_16/M1_0_5 MUX2 $PINS O=sll_16/ML_int[1][5] S=FE_OFN483_FE_OFN75_h11_0
+ A=term1_in[5] B=term1_in[4]
Xsll_16/M1_0_6 MUX2 $PINS O=sll_16/ML_int[1][6] S=FE_OFN483_FE_OFN75_h11_0
+ A=term1_in[6] B=term1_in[5]
Xsll_16/M1_0_7 MUX2 $PINS O=sll_16/ML_int[1][7] S=FE_OFN483_FE_OFN75_h11_0
+ A=term1_in[7] B=term1_in[6]
Xsll_16/M1_0_8 MUX2 $PINS O=sll_16/ML_int[1][8] S=FE_OFN483_FE_OFN75_h11_0
+ A=term1_in[8] B=term1_in[7]
Xsll_16/M1_0_9 MUX2 $PINS O=sll_16/ML_int[1][9] S=FE_OFN483_FE_OFN75_h11_0
+ A=term1_in[9] B=term1_in[8]
Xsll_16/M1_0_10 MUX2 $PINS O=sll_16/ML_int[1][10] S=FE_OFN483_FE_OFN75_h11_0
+ A=term1_in[10] B=term1_in[9]
Xsll_16/M1_1_5 MUX2 $PINS O=sll_16/ML_int[2][5] S=n33 A=sll_16/ML_int[1][5]
+ B=sll_16/ML_int[1][3]
Xsll_16/M1_1_6 MUX2 $PINS O=sll_16/ML_int[2][6] S=n33 A=sll_16/ML_int[1][6]
+ B=sll_16/ML_int[1][4]
Xsll_16/M1_1_7 MUX2 $PINS O=sll_16/ML_int[2][7] S=n33 A=sll_16/ML_int[1][7]
+ B=sll_16/ML_int[1][5]
Xsll_16/M1_1_8 MUX2 $PINS O=sll_16/ML_int[2][8] S=n33 A=sll_16/ML_int[1][8]
+ B=sll_16/ML_int[1][6]
Xsll_16/M1_1_9 MUX2 $PINS O=sll_16/ML_int[2][9] S=n33 A=sll_16/ML_int[1][9]
+ B=sll_16/ML_int[1][7]
Xsll_16/M1_1_10 MUX2 $PINS O=sll_16/ML_int[2][10] S=n33 A=sll_16/ML_int[1][10]
+ B=sll_16/ML_int[1][8]
Xsll_16/M1_1_11 MUX2 $PINS O=sll_16/ML_int[2][11] S=n33 A=sll_16/ML_int[1][11]
+ B=sll_16/ML_int[1][9]
Xsll_16/M1_2_4 MUX2 $PINS O=sll_16/ML_int[3][4] S=shf1[2] A=sll_16/ML_int[2][4]
+ B=n53
Xsll_16/M1_2_7 MUX2 $PINS O=sll_16/ML_int[3][7] S=shf1[2] A=sll_16/ML_int[2][7]
+ B=sll_16/ML_int[2][3]
Xsll_16/M1_2_9 MUX2 $PINS O=sll_16/ML_int[3][9] S=shf1[2] A=sll_16/ML_int[2][9]
+ B=sll_16/ML_int[2][5]
Xsll_16/M1_2_10 MUX2 $PINS O=sll_16/ML_int[3][10] S=FE_OFN463_h11_2
+ A=sll_16/ML_int[2][10] B=sll_16/ML_int[2][6]
Xsll_16/M1_2_11 MUX2 $PINS O=sll_16/ML_int[3][11] S=FE_OFN463_h11_2
+ A=sll_16/ML_int[2][11] B=sll_16/ML_int[2][7]
Xsll_16/M1_2_12 MUX2 $PINS O=sll_16/ML_int[3][12] S=FE_OFN463_h11_2
+ A=sll_16/ML_int[2][12] B=sll_16/ML_int[2][8]
Xsll_16/M1_2_13 MUX2 $PINS O=sll_16/ML_int[3][13] S=FE_OFN463_h11_2
+ A=sll_16/ML_int[2][13] B=sll_16/ML_int[2][9]
Xsll_16/M1_3_8 MUX2 $PINS O=term1_shifted[8] S=shf1[3] A=sll_16/ML_int[3][8]
+ B=sll_16/ML_int[3][0]
Xsll_16/M1_3_9 MUX2 $PINS O=term1_shifted[9] S=shf1[3] A=sll_16/ML_int[3][9]
+ B=sll_16/ML_int[3][1]
Xsll_16/M1_3_10 MUX2 $PINS O=term1_shifted[10] S=shf1[3] A=sll_16/ML_int[3][10]
+ B=sll_16/ML_int[3][2]
Xsll_16/M1_3_11 MUX2 $PINS O=term1_shifted[11] S=shf1[3] A=sll_16/ML_int[3][11]
+ B=sll_16/ML_int[3][3]
Xsll_16/M1_3_12 MUX2 $PINS O=term1_shifted[12] S=shf1[3] A=sll_16/ML_int[3][12]
+ B=sll_16/ML_int[3][4]
Xsll_16/M1_3_13 MUX2 $PINS O=term1_shifted[13] S=shf1[3] A=sll_16/ML_int[3][13]
+ B=sll_16/ML_int[3][5]
Xsll_16/M1_3_14 MUX2 $PINS O=term1_shifted[14] S=shf1[3] A=sll_16/ML_int[3][14]
+ B=sll_16/ML_int[3][6]
Xsll_16/M1_3_15 MUX2 $PINS O=term1_shifted[15] S=shf1[3] A=sll_16/ML_int[3][15]
+ B=sll_16/ML_int[3][7]
Xsll_16/M1_3_16 MUX2 $PINS O=term1_shifted[16] S=shf1[3] A=sll_16/ML_int[3][16]
+ B=sll_16/ML_int[3][8]
Xsll_16/M1_3_17 MUX2 $PINS O=term1_shifted[17] S=shf1[3] A=sll_16/ML_int[3][17]
+ B=sll_16/ML_int[3][9]
Xsll_16/M1_3_23 MUX2 $PINS O=term1_shifted[23] S=FE_OFN174_h11_3 A=term1_in[26]
+ B=sll_16/ML_int[3][15]
Xy_out_reg[9] QDFFRBN $PINS Q=y_out[9] D=N244 CK=net2295 RB=i_rst_n
Xy_out_reg[8] QDFFRBN $PINS Q=y_out[8] D=FE_PHN1429_N243 CK=net2295
+ RB=FE_OFN17_i_rst_n
Xy_out_reg[7] QDFFRBN $PINS Q=y_out[7] D=N242 CK=net2295 RB=FE_OFN17_i_rst_n
Xy_out_reg[6] QDFFRBN $PINS Q=y_out[6] D=N241 CK=net2295 RB=FE_OFN17_i_rst_n
Xy_out_reg[5] QDFFRBN $PINS Q=y_out[5] D=N240 CK=net2295 RB=FE_OFN17_i_rst_n
Xy_out_reg[4] QDFFRBN $PINS Q=y_out[4] D=N239 CK=net2295 RB=FE_OFN17_i_rst_n
Xy_out_reg[3] QDFFRBN $PINS Q=y_out[3] D=FE_PHN1496_N238 CK=net2295
+ RB=FE_OFN17_i_rst_n
Xy_out_reg[2] QDFFRBN $PINS Q=y_out[2] D=N237 CK=net2295 RB=FE_OFN17_i_rst_n
Xy_out_reg[1] QDFFRBN $PINS Q=FE_PHN1612_pe_r1_1 D=FE_PHN1505_N236 CK=net2295
+ RB=FE_OFN17_i_rst_n
Xy_out_reg[0] QDFFRBN $PINS Q=y_out[0] D=FE_PHN1891_N235 CK=net2295
+ RB=FE_OFN17_i_rst_n
Xacc_reg_reg[25] QDFFRBN $PINS Q=acc_reg[25] D=next_acc[25] CK=clk_clone1
+ RB=i_rst_n
Xacc_reg_reg[24] QDFFRBN $PINS Q=acc_reg[24] D=next_acc[24] CK=clk_clone1
+ RB=i_rst_n
Xy_out_reg[16] QDFFRBN $PINS Q=y_out[16] D=FE_PHN1330_N251 CK=net2295
+ RB=FE_OFN36_i_rst_n
Xy_out_reg[11] QDFFRBN $PINS Q=y_out[11] D=N246 CK=net2295 RB=FE_OFN36_i_rst_n
Xy_out_reg[12] QDFFRBN $PINS Q=y_out[12] D=N247 CK=net2295 RB=FE_OFN36_i_rst_n
Xy_out_reg[10] QDFFRBN $PINS Q=y_out[10] D=FE_PHN1503_N245 CK=net2295
+ RB=i_rst_n
Xacc_reg_reg[23] QDFFRBN $PINS Q=acc_reg[23] D=next_acc[23] CK=clk_clone2
+ RB=i_rst_n
Xy_out_reg[14] QDFFRBN $PINS Q=y_out[14] D=N249 CK=net2295 RB=FE_OFN36_i_rst_n
Xy_out_reg[15] QDFFRBN $PINS Q=y_out[15] D=N250 CK=net2295 RB=FE_OFN36_i_rst_n
Xy_out_reg[13] QDFFRBN $PINS Q=y_out[13] D=N248 CK=net2295 RB=FE_OFN36_i_rst_n
Xacc_reg_reg[22] QDFFRBN $PINS Q=acc_reg[22] D=next_acc[22] CK=clk_clone1
+ RB=i_rst_n
Xacc_reg_reg[21] QDFFRBN $PINS Q=acc_reg[21] D=next_acc[21] CK=clk_clone2
+ RB=FE_OFN17_i_rst_n
Xacc_reg_reg[20] QDFFRBN $PINS Q=acc_reg[20] D=next_acc[20] CK=clk_clone2
+ RB=FE_OFN17_i_rst_n
Xacc_reg_reg[19] QDFFRBN $PINS Q=acc_reg[19] D=next_acc[19] CK=clk_clone2
+ RB=FE_OFN17_i_rst_n
Xacc_reg_reg[18] QDFFRBN $PINS Q=acc_reg[18] D=next_acc[18] CK=clk_clone2
+ RB=FE_OFN17_i_rst_n
Xacc_reg_reg[17] QDFFRBN $PINS Q=acc_reg[17] D=next_acc[17] CK=clk_clone2
+ RB=FE_OFN17_i_rst_n
Xacc_reg_reg[16] QDFFRBN $PINS Q=acc_reg[16] D=next_acc[16] CK=clk_clone2
+ RB=FE_OFN17_i_rst_n
Xacc_reg_reg[15] QDFFRBN $PINS Q=acc_reg[15] D=next_acc[15] CK=clk_clone2
+ RB=FE_OFN17_i_rst_n
Xacc_reg_reg[14] QDFFRBN $PINS Q=acc_reg[14] D=next_acc[14] CK=clk_clone2
+ RB=FE_OFN17_i_rst_n
Xacc_reg_reg[13] QDFFRBN $PINS Q=acc_reg[13] D=next_acc[13] CK=clk_clone2
+ RB=FE_OFN17_i_rst_n
Xacc_reg_reg[12] QDFFRBN $PINS Q=acc_reg[12] D=next_acc[12] CK=clk_clone2
+ RB=FE_OFN17_i_rst_n
Xacc_reg_reg[11] QDFFRBN $PINS Q=acc_reg[11] D=next_acc[11] CK=clk_clone2
+ RB=FE_OFN17_i_rst_n
Xacc_reg_reg[10] QDFFRBN $PINS Q=acc_reg[10] D=next_acc[10] CK=clk_clone2
+ RB=FE_OFN17_i_rst_n
Xacc_reg_reg[9] QDFFRBN $PINS Q=acc_reg[9] D=next_acc[9] CK=clk_clone2
+ RB=FE_OFN17_i_rst_n
Xacc_reg_reg[8] QDFFRBN $PINS Q=acc_reg[8] D=FE_PHN2046_next_acc_8
+ CK=clk_clone2 RB=FE_OFN17_i_rst_n
Xacc_reg_reg[7] QDFFRBN $PINS Q=acc_reg[7] D=next_acc[7] CK=clk_clone2
+ RB=FE_OFN17_i_rst_n
Xacc_reg_reg[6] QDFFRBN $PINS Q=acc_reg[6] D=next_acc[6] CK=clk_clone2
+ RB=FE_OFN17_i_rst_n
Xacc_reg_reg[5] QDFFRBN $PINS Q=acc_reg[5] D=next_acc[5] CK=clk_clone2
+ RB=FE_OFN17_i_rst_n
Xacc_reg_reg[4] QDFFRBN $PINS Q=acc_reg[4] D=next_acc[4] CK=clk_clone2
+ RB=FE_OFN17_i_rst_n
Xacc_reg_reg[3] QDFFRBN $PINS Q=acc_reg[3] D=next_acc[3] CK=clk_clone2
+ RB=FE_OFN48_i_rst_n
Xacc_reg_reg[2] QDFFRBN $PINS Q=acc_reg[2] D=next_acc[2] CK=clk_clone2
+ RB=FE_OFN48_i_rst_n
Xacc_reg_reg[1] QDFFRBN $PINS Q=acc_reg[1] D=next_acc[1] CK=clk_clone2
+ RB=FE_OFN48_i_rst_n
Xacc_reg_reg[0] QDFFRBS $PINS Q=acc_reg[0] D=FE_PHN1565_next_acc_0
+ CK=clk_clone2 RB=FE_OFN48_i_rst_n
Xacc_reg_reg[26] QDFFRBS $PINS Q=N251 D=next_acc[26] CK=clk_clone1 RB=i_rst_n
XU13 MUX2S $PINS O=sll_16/ML_int[3][8] S=shf1[2] A=sll_16/ML_int[2][8]
+ B=sll_16/ML_int[2][4]
XU16 INV1S $PINS O=n10 I=shf3[0]
XU17 AN2 $PINS O=sll_17/ML_int[1][0] I1=term2_in[0] I2=n22
XU20 ND2P $PINS O=n70 I1=sll_18/ML_int[1][0] I2=FE_OFN173_h13_1
XU24 ND2 $PINS O=N98 I1=n1 I2=n2
XU25 MUX2 $PINS O=FE_PHN1872_N248 S=stage_sel A=acc_reg[23] B=FE_PHN1330_N251
XU26 MUX2 $PINS O=FE_PHN1878_N250 S=stage_sel A=acc_reg[25] B=FE_PHN1330_N251
XU27 MUX2 $PINS O=FE_PHN1861_N249 S=stage_sel A=acc_reg[24] B=FE_PHN1330_N251
XU28 MUX2 $PINS O=FE_PHN1854_N247 S=stage_sel A=acc_reg[22] B=FE_PHN1330_N251
XU29 OR2 $PINS O=n61 I1=FE_OFN260_h12_2 I2=n27
XU30 ND2P $PINS O=n60 I1=sll_17/ML_int[1][1] I2=FE_OFN149_h12_1
XU31 AN2B1T $PINS O=term1_shifted[3] I1=sll_16/ML_int[2][3] B1=n50
XU33 NR2T $PINS O=term1_shifted[0] I1=n50 I2=n48
XU35 NR2 $PINS O=term3_shifted[3] I1=n73 I2=n72
XU37 NR2 $PINS O=term1_in[2] I1=sign1[1] I2=x_in[2]
XU39 ND2S $PINS O=n3 I1=sll_18/ML_int[1][1] I2=FE_OFN173_h13_1
XU40 NR2P $PINS O=term2_shifted[1] I1=n61 I2=n60
XU45 ND2P $PINS O=n49 I1=sll_16/ML_int[1][1] I2=FE_OFN169_h11_1
XU46 NR2T $PINS O=term1_shifted[1] I1=n50 I2=n49
XU47 ND2P $PINS O=n50 I1=n35 I2=n36
XU49 NR2P $PINS O=term2_in[2] I1=sign2[1] I2=x_in[2]
XU50 NR2T $PINS O=term3_in[0] I1=sign3[1] I2=n97
XU51 ND2P $PINS O=n48 I1=sll_16/ML_int[1][0] I2=FE_OFN169_h11_1
XU53 ND2 $PINS O=n1 I1=N71 I2=FE_OFN396_s12_0
XU54 AO22 $PINS O=N97 A1=N70 A2=FE_OFN396_s12_0 B1=term2_shifted[1]
+ B2=FE_OFN449_n
XU55 MUX2S $PINS O=sll_18/ML_int[3][13] S=shf3[2] A=sll_18/ML_int[2][13]
+ B=sll_18/ML_int[2][9]
XU56 MUX2S $PINS O=sll_18/ML_int[3][12] S=shf3[2] A=sll_18/ML_int[2][12]
+ B=sll_18/ML_int[2][8]
XU57 MUX2S $PINS O=sll_18/ML_int[3][11] S=shf3[2] A=sll_18/ML_int[2][11]
+ B=sll_18/ML_int[2][7]
XU58 MUX2S $PINS O=sll_18/ML_int[3][10] S=shf3[2] A=sll_18/ML_int[2][10]
+ B=sll_18/ML_int[2][6]
XU59 MUX2S $PINS O=sll_18/ML_int[3][9] S=shf3[2] A=sll_18/ML_int[2][9]
+ B=sll_18/ML_int[2][5]
XU60 MUX2S $PINS O=sll_18/ML_int[3][8] S=shf3[2] A=sll_18/ML_int[2][8]
+ B=sll_18/ML_int[2][4]
XU62 MUX2S $PINS O=sll_17/ML_int[1][5] S=FE_OFN486_FE_OFN81_h12_0 A=term2_in[5]
+ B=term2_in[4]
XU65 MUX2 $PINS O=sll_16/ML_int[2][4] S=n33 A=sll_16/ML_int[1][4]
+ B=sll_16/ML_int[1][2]
XU67 NR2P $PINS O=term2_in[1] I1=sign2[1] I2=x_in[1]
XU69 INV1S $PINS O=n51 I=sll_16/ML_int[2][3]
XU70 NR2 $PINS O=term1_in[4] I1=sign1[1] I2=x_in[4]
XU71 NR2 $PINS O=term1_in[1] I1=sign1[1] I2=x_in[1]
XU74 AN2T $PINS O=sll_18/ML_int[1][0] I1=term3_in[0] I2=n10
XU75 MUX2 $PINS O=sll_17/ML_int[2][2] S=n25 A=sll_17/ML_int[1][2]
+ B=sll_17/ML_int[1][0]
XU76 MUX2 $PINS O=sll_16/ML_int[2][2] S=n33 A=sll_16/ML_int[1][2]
+ B=sll_16/ML_int[1][0]
XU82 MUX2 $PINS O=sll_17/ML_int[2][4] S=n25 A=sll_17/ML_int[1][4]
+ B=sll_17/ML_int[1][2]
XU85 MUX2S $PINS O=sll_17/ML_int[3][6] S=FE_OFN260_h12_2 A=sll_17/ML_int[2][6]
+ B=sll_17/ML_int[2][2]
XU89 MUX2S $PINS O=sll_16/ML_int[3][6] S=shf1[2] A=sll_16/ML_int[2][6]
+ B=sll_16/ML_int[2][2]
XU90 ND2S $PINS O=n2 I1=term2_shifted[2] I2=FE_OFN449_n
XU91 AO22 $PINS O=N109 A1=N82 A2=FE_OFN396_s12_0 B1=term2_shifted[13]
+ B2=FE_OFN395_s12_0
XU95 AO22S $PINS O=N121 A1=N94 A2=FE_OFN154_s12_0 B1=term2_shifted[25]
+ B2=FE_OFN156_s12_0
XU96 NR2 $PINS O=n5 I1=sign3[1] I2=x_in[1]
XU97 MUX2 $PINS O=sll_18/ML_int[1][3] S=shf3[0] A=term3_in[3] B=term3_in[2]
XU102 AO22 $PINS O=N47 A1=N20 A2=FE_OFN83_s11_0 B1=term1_shifted[6] B2=n39
XU103 AO22 $PINS O=N157 A1=N130 A2=FE_OFN379_s13_0 B1=term3_shifted[6]
+ B2=FE_OFN270_s13_0
XU104 MUX2S $PINS O=sll_16/ML_int[1][3] S=FE_OFN483_FE_OFN75_h11_0
+ A=term1_in[3] B=term1_in[2]
XU106 AN2 $PINS O=base_val[4] I1=acc_reg[4] I2=n98
XU107 AN2 $PINS O=base_val[5] I1=acc_reg[5] I2=n98
XU108 AN2 $PINS O=base_val[0] I1=acc_reg[0] I2=n98
XU109 MUX2S $PINS O=sll_17/ML_int[3][11] S=FE_OFN260_h12_2
+ A=sll_17/ML_int[2][11] B=sll_17/ML_int[2][7]
XU111 MUX2S $PINS O=sll_16/ML_int[2][12] S=n33 A=sll_16/ML_int[1][12]
+ B=sll_16/ML_int[1][10]
XU112 MUX2S $PINS O=sll_18/ML_int[2][12] S=FE_OFN443_h13_1
+ A=sll_18/ML_int[1][12] B=sll_18/ML_int[1][10]
XU113 MUX2S $PINS O=sll_17/ML_int[2][12] S=n25 A=sll_17/ML_int[1][12]
+ B=sll_17/ML_int[1][10]
XU123 MUX2S $PINS O=sll_16/ML_int[1][11] S=FE_OFN483_FE_OFN75_h11_0
+ A=term1_in[11] B=term1_in[10]
XU124 MUX2S $PINS O=sll_16/ML_int[3][14] S=FE_OFN463_h11_2
+ A=sll_16/ML_int[2][14] B=sll_16/ML_int[2][10]
XU125 MUX2S $PINS O=sll_18/ML_int[1][11] S=FE_OFN469_h13_0 A=term3_in[11]
+ B=term3_in[10]
XU126 MUX2S $PINS O=sll_16/ML_int[2][13] S=n33 A=sll_16/ML_int[1][13]
+ B=sll_16/ML_int[1][11]
XU127 MUX2S $PINS O=sll_16/ML_int[1][13] S=shf1[0] A=term1_in[13]
+ B=term1_in[12]
XU128 MUX2S $PINS O=sll_17/ML_int[1][11] S=FE_OFN486_FE_OFN81_h12_0
+ A=term2_in[11] B=term2_in[10]
XU129 MUX2S $PINS O=sll_18/ML_int[3][14] S=shf3[2] A=sll_18/ML_int[2][14]
+ B=sll_18/ML_int[2][10]
XU130 MUX2S $PINS O=sll_17/ML_int[3][14] S=FE_OFN260_h12_2
+ A=sll_17/ML_int[2][14] B=sll_17/ML_int[2][10]
XU131 MUX2S $PINS O=sll_18/ML_int[2][13] S=FE_OFN443_h13_1
+ A=sll_18/ML_int[1][13] B=sll_18/ML_int[1][11]
XU135 MUX2S $PINS O=sll_18/ML_int[1][13] S=FE_OFN469_h13_0 A=term3_in[13]
+ B=term3_in[12]
XU137 MUX2S $PINS O=sll_17/ML_int[2][13] S=n25 A=sll_17/ML_int[1][13]
+ B=sll_17/ML_int[1][11]
XU139 MUX2S $PINS O=sll_17/ML_int[1][13] S=FE_OFN486_FE_OFN81_h12_0
+ A=term2_in[13] B=term2_in[12]
XU140 MUX2S $PINS O=sll_16/ML_int[1][12] S=FE_OFN483_FE_OFN75_h11_0
+ A=term1_in[12] B=term1_in[11]
XU162 MUX2S $PINS O=sll_18/ML_int[1][12] S=FE_OFN469_h13_0 A=term3_in[12]
+ B=term3_in[11]
XU164 MUX2S $PINS O=sll_16/ML_int[3][15] S=FE_OFN463_h11_2
+ A=sll_16/ML_int[2][15] B=sll_16/ML_int[2][11]
XU167 MUX2S $PINS O=sll_16/ML_int[2][14] S=n33 A=sll_16/ML_int[1][14]
+ B=sll_16/ML_int[1][12]
XU170 MUX2S $PINS O=sll_16/ML_int[1][14] S=shf1[0] A=term1_in[14]
+ B=term1_in[13]
XU182 MUX2S $PINS O=sll_17/ML_int[1][12] S=FE_OFN486_FE_OFN81_h12_0
+ A=term2_in[12] B=term2_in[11]
XU192 MUX2S $PINS O=sll_18/ML_int[3][15] S=shf3[2] A=sll_18/ML_int[2][15]
+ B=sll_18/ML_int[2][11]
XU193 MUX2S $PINS O=term2_shifted[15] S=n27 A=sll_17/ML_int[3][15]
+ B=sll_17/ML_int[3][7]
XU194 MUX2S $PINS O=sll_17/ML_int[3][15] S=FE_OFN260_h12_2
+ A=sll_17/ML_int[2][15] B=sll_17/ML_int[2][11]
XU195 MUX2S $PINS O=sll_18/ML_int[2][14] S=FE_OFN443_h13_1
+ A=sll_18/ML_int[1][14] B=sll_18/ML_int[1][12]
XU196 MUX2S $PINS O=sll_18/ML_int[1][14] S=FE_OFN469_h13_0 A=term3_in[14]
+ B=term3_in[13]
XU197 MUX2S $PINS O=sll_17/ML_int[2][14] S=n25 A=sll_17/ML_int[1][14]
+ B=sll_17/ML_int[1][12]
XU198 MUX2S $PINS O=sll_17/ML_int[1][14] S=FE_OFN486_FE_OFN81_h12_0
+ A=term2_in[14] B=term2_in[13]
XU199 MUX2S $PINS O=sll_16/ML_int[3][16] S=FE_OFN463_h11_2 A=n55
+ B=sll_16/ML_int[2][12]
XU200 MUX2S $PINS O=sll_18/ML_int[3][16] S=shf3[2] A=n77 B=sll_18/ML_int[2][12]
XU201 MUX2S $PINS O=sll_17/ML_int[3][16] S=FE_OFN260_h12_2 A=n66
+ B=sll_17/ML_int[2][12]
XU202 MUX2S $PINS O=n66 S=n25 A=n69 B=sll_17/ML_int[1][14]
XU203 MUX2S $PINS O=sll_16/ML_int[2][15] S=n33 A=sll_16/ML_int[1][15]
+ B=sll_16/ML_int[1][13]
XU204 MUX2S $PINS O=sll_16/ML_int[1][15] S=shf1[0] A=term1_in[15]
+ B=term1_in[14]
XU205 MUX2S $PINS O=sll_18/ML_int[2][15] S=FE_OFN443_h13_1
+ A=sll_18/ML_int[1][15] B=sll_18/ML_int[1][13]
XU206 MUX2S $PINS O=sll_18/ML_int[1][15] S=FE_OFN469_h13_0 A=term3_in[15]
+ B=term3_in[14]
XU207 MUX2S $PINS O=sll_17/ML_int[2][15] S=n25 A=sll_17/ML_int[1][15]
+ B=sll_17/ML_int[1][13]
XU208 MUX2S $PINS O=sll_17/ML_int[1][15] S=FE_OFN486_FE_OFN81_h12_0
+ A=term2_in[15] B=term2_in[14]
XU209 MUX2S $PINS O=sll_16/ML_int[3][17] S=FE_OFN463_h11_2 A=n56
+ B=sll_16/ML_int[2][13]
XU210 MUX2S $PINS O=term1_shifted[18] S=shf1[3] A=sll_16/ML_int[3][18]
+ B=sll_16/ML_int[3][10]
XU211 MUX2S $PINS O=sll_18/ML_int[3][17] S=shf3[2] A=n78 B=sll_18/ML_int[2][13]
XU212 MUX2S $PINS O=n67 S=n25 A=term2_in[26] B=sll_17/ML_int[1][15]
XU213 MUX2S $PINS O=sll_17/ML_int[3][17] S=FE_OFN260_h12_2 A=n67
+ B=sll_17/ML_int[2][13]
XU214 MUX2S $PINS O=sll_16/ML_int[3][18] S=FE_OFN463_h11_2 A=n57
+ B=sll_16/ML_int[2][14]
XU215 MUX2S $PINS O=term3_shifted[18] S=FE_OFN363_h13_3 A=sll_18/ML_int[3][18]
+ B=sll_18/ML_int[3][10]
XU216 MUX2S $PINS O=term2_shifted[18] S=FE_OFN259_h12_3 A=sll_17/ML_int[3][18]
+ B=sll_17/ML_int[3][10]
XU217 MUX2S $PINS O=sll_18/ML_int[3][18] S=shf3[2] A=n79 B=sll_18/ML_int[2][14]
XU218 MUX2S $PINS O=sll_17/ML_int[3][18] S=FE_OFN260_h12_2 A=n68
+ B=sll_17/ML_int[2][14]
XU219 MUX2S $PINS O=n68 S=n25 A=term2_in[26] B=n69
XU220 MUX2S $PINS O=term1_shifted[19] S=FE_OFN174_h11_3 A=sll_16/ML_int[3][19]
+ B=sll_16/ML_int[3][11]
XU221 MUX2S $PINS O=sll_16/ML_int[3][19] S=FE_OFN463_h11_2 A=term1_in[26]
+ B=sll_16/ML_int[2][15]
XU222 MUX2S $PINS O=term3_shifted[19] S=n15 A=sll_18/ML_int[3][19]
+ B=sll_18/ML_int[3][11]
XU223 MUX2S $PINS O=sll_18/ML_int[3][19] S=shf3[2] A=term3_in[26]
+ B=sll_18/ML_int[2][15]
XU224 MUX2S $PINS O=term2_shifted[19] S=FE_OFN259_h12_3 A=sll_17/ML_int[3][19]
+ B=sll_17/ML_int[3][11]
XU225 MUX2S $PINS O=sll_17/ML_int[3][19] S=FE_OFN260_h12_2 A=term2_in[26]
+ B=sll_17/ML_int[2][15]
XU226 MUX2S $PINS O=term1_shifted[20] S=FE_OFN174_h11_3 A=sll_16/ML_int[3][20]
+ B=sll_16/ML_int[3][12]
XU227 MUX2S $PINS O=sll_16/ML_int[3][20] S=FE_OFN463_h11_2 A=term1_in[26] B=n55
XU228 MUX2S $PINS O=term3_shifted[20] S=n15 A=sll_18/ML_int[3][20]
+ B=sll_18/ML_int[3][12]
XU229 MUX2S $PINS O=sll_18/ML_int[3][20] S=shf3[2] A=term3_in[26] B=n77
XU230 MUX2S $PINS O=term2_shifted[20] S=FE_OFN259_h12_3 A=sll_17/ML_int[3][20]
+ B=sll_17/ML_int[3][12]
XU231 MUX2S $PINS O=sll_17/ML_int[3][20] S=FE_OFN260_h12_2 A=term2_in[26] B=n66
XU232 MUX2S $PINS O=term1_shifted[21] S=FE_OFN174_h11_3 A=sll_16/ML_int[3][21]
+ B=sll_16/ML_int[3][13]
XU233 MUX2S $PINS O=sll_16/ML_int[3][21] S=FE_OFN463_h11_2 A=term1_in[26] B=n56
XU234 MUX2S $PINS O=term3_shifted[21] S=n15 A=sll_18/ML_int[3][21]
+ B=sll_18/ML_int[3][13]
XU235 MUX2S $PINS O=sll_18/ML_int[3][21] S=shf3[2] A=term3_in[26] B=n78
XU236 MUX2S $PINS O=term2_shifted[21] S=FE_OFN259_h12_3 A=sll_17/ML_int[3][21]
+ B=sll_17/ML_int[3][13]
XU237 MUX2S $PINS O=sll_17/ML_int[3][21] S=FE_OFN260_h12_2 A=term2_in[26] B=n67
XU238 MUX2S $PINS O=term1_shifted[22] S=FE_OFN174_h11_3 A=sll_16/ML_int[3][22]
+ B=sll_16/ML_int[3][14]
XU239 MUX2S $PINS O=sll_16/ML_int[3][22] S=shf1[2] A=term1_in[26] B=n57
XU240 MUX2S $PINS O=sll_18/ML_int[3][22] S=shf3[2] A=term3_in[26] B=n79
XU241 MUX2S $PINS O=sll_17/ML_int[3][22] S=FE_OFN260_h12_2 A=term2_in[26] B=n68
XU242 AO22 $PINS O=N51 A1=N24 A2=FE_OFN83_s11_0 B1=term1_shifted[10]
+ B2=FE_OFN284_s11_0
XU243 AO22 $PINS O=N52 A1=N25 A2=FE_OFN83_s11_0 B1=term1_shifted[11]
+ B2=FE_OFN284_s11_0
XU244 AO22 $PINS O=N53 A1=N26 A2=FE_OFN83_s11_0 B1=term1_shifted[12]
+ B2=FE_OFN284_s11_0
XU245 AO22 $PINS O=N54 A1=N27 A2=FE_OFN83_s11_0 B1=term1_shifted[13]
+ B2=FE_OFN284_s11_0
XU246 AO22 $PINS O=N55 A1=N28 A2=FE_OFN83_s11_0 B1=term1_shifted[14]
+ B2=FE_OFN284_s11_0
XU247 AO22 $PINS O=N56 A1=N29 A2=FE_OFN83_s11_0 B1=term1_shifted[15]
+ B2=FE_OFN284_s11_0
XU248 AO22 $PINS O=N57 A1=N30 A2=FE_OFN83_s11_0 B1=term1_shifted[16] B2=n39
XU249 AO22 $PINS O=N58 A1=N31 A2=FE_OFN83_s11_0 B1=term1_shifted[17] B2=n39
XU250 AO22 $PINS O=N59 A1=N32 A2=FE_OFN83_s11_0 B1=term1_shifted[18] B2=n39
XU255 AN2S $PINS O=base_val[6] I1=acc_reg[6] I2=n98
XU256 MUX2S $PINS O=N235 S=stage_sel A=acc_reg[10] B=FE_PHN1382_acc_reg_14
XU257 MUX2S $PINS O=N236 S=stage_sel A=acc_reg[11] B=acc_reg[15]
XU258 MUX2S $PINS O=FE_PHN1500_N237 S=stage_sel A=acc_reg[12] B=acc_reg[16]
XU259 MUX2S $PINS O=N238 S=stage_sel A=acc_reg[13] B=acc_reg[17]
XU260 MUX2S $PINS O=FE_PHN1889_N239 S=stage_sel A=FE_PHN1382_acc_reg_14
+ B=acc_reg[18]
XU261 MUX2S $PINS O=FE_PHN1516_N240 S=stage_sel A=acc_reg[15] B=acc_reg[19]
XU262 MUX2S $PINS O=FE_PHN1510_N242 S=stage_sel A=acc_reg[17] B=acc_reg[21]
XU263 MUX2S $PINS O=N245 S=stage_sel A=acc_reg[20] B=acc_reg[24]
XU264 MUX2S $PINS O=FE_PHN1527_N246 S=stage_sel A=acc_reg[21] B=acc_reg[25]
XU270 INV1S $PINS O=n53 I=n48
XU271 INV1S $PINS O=n75 I=FE_OCPN1043_n70
XU272 INV1S $PINS O=n64 I=n59
XU273 INV1S $PINS O=n54 I=n49
XU274 INV1S $PINS O=n76 I=n3
XU275 INV1S $PINS O=n65 I=n60
XU276 NR2 $PINS O=term1_in[3] I1=sign1[1] I2=x_in[3]
XU277 NR2 $PINS O=term2_in[3] I1=sign2[1] I2=x_in[3]
XU278 NR2 $PINS O=term3_in[1] I1=sign3[1] I2=x_in[1]
XU279 NR2 $PINS O=term1_in[5] I1=sign1[1] I2=x_in[5]
XU280 NR2 $PINS O=term3_in[5] I1=sign3[1] I2=x_in[5]
XU281 NR2 $PINS O=term2_in[5] I1=sign2[1] I2=x_in[5]
XU282 NR2 $PINS O=term1_in[8] I1=sign1[1] I2=x_in[8]
XU283 NR2 $PINS O=term3_in[8] I1=FE_OFN445_s13_1 I2=x_in[8]
XU284 NR2 $PINS O=term1_in[6] I1=sign1[1] I2=x_in[6]
XU285 NR2 $PINS O=term2_in[8] I1=sign2[1] I2=x_in[8]
XU286 NR2 $PINS O=term3_in[6] I1=sign3[1] I2=x_in[6]
XU287 NR2 $PINS O=term2_in[6] I1=sign2[1] I2=x_in[6]
XU288 NR2 $PINS O=term1_in[9] I1=sign1[1] I2=x_in[9]
XU289 NR2 $PINS O=term3_in[9] I1=FE_OFN445_s13_1 I2=x_in[9]
XU290 NR2 $PINS O=term1_in[7] I1=sign1[1] I2=x_in[7]
XU291 NR2 $PINS O=term3_in[7] I1=sign3[1] I2=x_in[7]
XU292 NR2 $PINS O=term2_in[9] I1=sign2[1] I2=x_in[9]
XU293 NR2 $PINS O=term2_in[7] I1=sign2[1] I2=x_in[7]
XU294 NR2 $PINS O=term1_in[10] I1=sign1[1] I2=x_in[10]
XU295 NR2 $PINS O=term3_in[10] I1=FE_OFN445_s13_1 I2=x_in[10]
XU297 NR2 $PINS O=term2_in[10] I1=sign2[1] I2=x_in[10]
XU300 NR2 $PINS O=term1_in[11] I1=sign1[1] I2=x_in[11]
XU301 NR2 $PINS O=term3_in[11] I1=FE_OFN445_s13_1 I2=x_in[11]
XU302 NR2 $PINS O=term2_in[11] I1=sign2[1] I2=x_in[11]
XU303 NR2 $PINS O=term1_in[12] I1=sign1[1] I2=x_in[12]
XU304 NR2 $PINS O=term3_in[12] I1=FE_OFN445_s13_1 I2=x_in[12]
XU305 NR2 $PINS O=term2_in[12] I1=sign2[1] I2=x_in[12]
XU307 NR2 $PINS O=term1_in[13] I1=sign1[1] I2=x_in[13]
XU308 NR2 $PINS O=term3_in[13] I1=FE_OFN445_s13_1 I2=x_in[13]
XU309 NR2 $PINS O=term2_in[13] I1=sign2[1] I2=x_in[13]
XU310 NR2 $PINS O=term1_in[14] I1=sign1[1] I2=x_in[14]
XU311 NR2 $PINS O=term3_in[14] I1=FE_OFN445_s13_1 I2=x_in[14]
XU312 NR2 $PINS O=term2_in[14] I1=sign2[1] I2=x_in[14]
XU313 NR2 $PINS O=term1_in[15] I1=sign1[1] I2=n86
XU314 NR2 $PINS O=term3_in[15] I1=FE_OFN445_s13_1 I2=n86
XU316 NR2 $PINS O=term1_in[26] I1=n87 I2=sign1[1]
XU317 NR2 $PINS O=term3_in[26] I1=n87 I2=FE_OFN445_s13_1
XU318 NR2 $PINS O=term2_in[15] I1=sign2[1] I2=n86
XU320 NR2 $PINS O=term2_in[26] I1=n87 I2=sign2[1]
XU323 INV1S $PINS O=n32 I=FE_OFN483_FE_OFN75_h11_0
XU325 INV1S $PINS O=n22 I=FE_OFN486_FE_OFN81_h12_0
XU339 INV1S $PINS O=n86 I=x_in[15]
XU340 INV1S $PINS O=n87 I=x_in[16]
XU341 AN2 $PINS O=base_val[26] I1=N251 I2=n98
XU342 AN2 $PINS O=base_val[1] I1=acc_reg[1] I2=n98
XU343 MOAI1S $PINS O=base_val[9] A1=stage_sel A2=n98 B1=acc_reg[9] B2=n98
XU344 AN2 $PINS O=base_val[10] I1=acc_reg[10] I2=n98
XU345 AN2 $PINS O=base_val[8] I1=acc_reg[8] I2=n98
XU346 AN2 $PINS O=base_val[7] I1=acc_reg[7] I2=n98
XU347 AN2 $PINS O=base_val[3] I1=acc_reg[3] I2=n98
XU348 AN2 $PINS O=base_val[2] I1=acc_reg[2] I2=n98
XU349 AN2 $PINS O=base_val[11] I1=acc_reg[11] I2=n98
XU350 AN2 $PINS O=base_val[12] I1=acc_reg[12] I2=n98
XU351 AN2 $PINS O=base_val[14] I1=acc_reg[14] I2=n98
XU352 AN2 $PINS O=base_val[15] I1=acc_reg[15] I2=n98
XU353 AN2 $PINS O=base_val[16] I1=acc_reg[16] I2=n98
XU354 AN2 $PINS O=base_val[17] I1=acc_reg[17] I2=n98
XU355 AN2 $PINS O=base_val[18] I1=acc_reg[18] I2=n98
XU356 AN2 $PINS O=base_val[19] I1=acc_reg[19] I2=n98
XU357 AN2 $PINS O=base_val[20] I1=acc_reg[20] I2=n98
XU358 AN2 $PINS O=base_val[21] I1=acc_reg[21] I2=n98
XU359 AN2 $PINS O=base_val[22] I1=acc_reg[22] I2=n98
XU360 AN2 $PINS O=base_val[23] I1=acc_reg[23] I2=n98
XU361 AN2 $PINS O=base_val[24] I1=acc_reg[24] I2=n98
XU362 AN2 $PINS O=base_val[25] I1=acc_reg[25] I2=n98
XU364 AN2 $PINS O=N234 I1=en I2=calc_done
XU366 NR2 $PINS O=sll_16/ML_int[3][0] I1=shf1[2] I2=n48
XU367 NR2 $PINS O=sll_16/ML_int[3][1] I1=shf1[2] I2=n49
XU368 NR2 $PINS O=sll_16/ML_int[3][2] I1=shf1[2] I2=n52
XU369 NR2 $PINS O=sll_16/ML_int[3][3] I1=shf1[2] I2=n51
XU370 AN2T $PINS O=term1_shifted[4] I1=sll_16/ML_int[3][4] I2=n36
XU371 AN2 $PINS O=term1_shifted[5] I1=sll_16/ML_int[3][5] I2=n36
XU372 AN2 $PINS O=term1_shifted[6] I1=sll_16/ML_int[3][6] I2=n36
XU373 AN2 $PINS O=term1_shifted[7] I1=sll_16/ML_int[3][7] I2=n36
XU374 MUX2 $PINS O=term1_shifted[24] S=FE_OFN174_h11_3 A=term1_in[26]
+ B=sll_16/ML_int[3][16]
XU375 MUX2 $PINS O=n55 S=n33 A=n58 B=sll_16/ML_int[1][14]
XU376 MUX2 $PINS O=term1_shifted[25] S=FE_OFN174_h11_3 A=term1_in[26]
+ B=sll_16/ML_int[3][17]
XU377 MUX2 $PINS O=n56 S=n33 A=term1_in[26] B=sll_16/ML_int[1][15]
XU378 MUX2 $PINS O=term1_shifted[26] S=FE_OFN174_h11_3 A=term1_in[26]
+ B=sll_16/ML_int[3][18]
XU379 MUX2 $PINS O=n57 S=n33 A=term1_in[26] B=n58
XU380 MUX2 $PINS O=n58 S=shf1[0] A=term1_in[26] B=term1_in[15]
XU381 NR2 $PINS O=sll_17/ML_int[3][0] I1=FE_OFN260_h12_2 I2=n59
XU382 NR2 $PINS O=sll_17/ML_int[3][1] I1=FE_OFN260_h12_2 I2=n60
XU383 NR2 $PINS O=sll_17/ML_int[3][2] I1=FE_OFN260_h12_2 I2=n63
XU384 NR2 $PINS O=sll_17/ML_int[3][3] I1=FE_OFN260_h12_2 I2=n62
XU385 NR2 $PINS O=term2_shifted[3] I1=n61 I2=n62
XU386 AN2 $PINS O=term2_shifted[4] I1=sll_17/ML_int[3][4] I2=shf2[3]
XU387 AN2 $PINS O=term2_shifted[5] I1=sll_17/ML_int[3][5] I2=shf2[3]
XU388 AN2 $PINS O=term2_shifted[6] I1=sll_17/ML_int[3][6] I2=shf2[3]
XU389 AN2 $PINS O=term2_shifted[7] I1=sll_17/ML_int[3][7] I2=shf2[3]
XU390 MUX2 $PINS O=term2_shifted[24] S=FE_OFN259_h12_3 A=term2_in[26]
+ B=sll_17/ML_int[3][16]
XU391 MUX2 $PINS O=term2_shifted[25] S=FE_OFN259_h12_3 A=term2_in[26]
+ B=sll_17/ML_int[3][17]
XU392 MUX2 $PINS O=term2_shifted[26] S=FE_OFN259_h12_3 A=term2_in[26]
+ B=sll_17/ML_int[3][18]
XU393 MUX2 $PINS O=n69 S=FE_OFN486_FE_OFN81_h12_0 A=term2_in[26] B=term2_in[15]
XU394 NR2 $PINS O=sll_18/ML_int[3][0] I1=shf3[2] I2=FE_OCPN1043_n70
XU395 NR2 $PINS O=sll_18/ML_int[3][1] I1=shf3[2] I2=n3
XU396 NR2 $PINS O=sll_18/ML_int[3][2] I1=shf3[2] I2=n74
XU397 NR2 $PINS O=sll_18/ML_int[3][3] I1=shf3[2] I2=n73
XU398 ND2P $PINS O=n72 I1=n13 I2=shf3[3]
XU399 AN2T $PINS O=term3_shifted[4] I1=sll_18/ML_int[3][4] I2=shf3[3]
XU400 AN2 $PINS O=term3_shifted[5] I1=sll_18/ML_int[3][5] I2=shf3[3]
XU401 AN2 $PINS O=term3_shifted[6] I1=sll_18/ML_int[3][6] I2=shf3[3]
XU402 AN2 $PINS O=term3_shifted[7] I1=sll_18/ML_int[3][7] I2=shf3[3]
XU403 MUX2 $PINS O=term3_shifted[24] S=n15 A=term3_in[26]
+ B=sll_18/ML_int[3][16]
XU404 MUX2 $PINS O=n77 S=FE_OFN443_h13_1 A=n80 B=sll_18/ML_int[1][14]
XU405 MUX2 $PINS O=term3_shifted[25] S=n15 A=term3_in[26]
+ B=sll_18/ML_int[3][17]
XU406 MUX2 $PINS O=n78 S=FE_OFN443_h13_1 A=term3_in[26] B=sll_18/ML_int[1][15]
XU407 MUX2 $PINS O=term3_shifted[26] S=n15 A=term3_in[26]
+ B=sll_18/ML_int[3][18]
XU408 MUX2 $PINS O=n79 S=FE_OFN443_h13_1 A=term3_in[26] B=n80
XU409 MUX2 $PINS O=n80 S=FE_OFN469_h13_0 A=term3_in[26] B=term3_in[15]
XU410 MUX2 $PINS O=FE_PHN1491_N241 S=stage_sel A=acc_reg[16] B=acc_reg[20]
XU411 MUX2 $PINS O=N243 S=stage_sel A=acc_reg[18] B=acc_reg[22]
XU412 MUX2 $PINS O=FE_PHN1482_N244 S=stage_sel A=acc_reg[19] B=acc_reg[23]
XU3 NR2T $PINS O=term2_in[0] I1=sign2[1] I2=n97
XU7 NR2P $PINS O=term1_in[0] I1=sign1[1] I2=n97
XU8 INV6 $PINS O=n97 I=x_in[0]
XU9 AN2 $PINS O=sll_16/ML_int[1][0] I1=term1_in[0] I2=n32
XU10 NR2 $PINS O=term2_in[4] I1=sign2[1] I2=x_in[4]
XU11 NR2P $PINS O=term3_shifted[2] I1=n72 I2=n74
XU21 INV2 $PINS O=n74 I=sll_18/ML_int[2][2]
XU22 INV1S $PINS O=n63 I=sll_17/ML_int[2][2]
XU23 ND3 $PINS O=n59 I1=term2_in[0] I2=n22 I3=FE_OFN149_h12_1
XU34 NR2T $PINS O=term1_shifted[2] I1=n52 I2=n50
XU41 INV2 $PINS O=n52 I=sll_16/ML_int[2][2]
XU43 NR2P $PINS O=term2_shifted[2] I1=n61 I2=n63
XU44 AO22S $PINS O=N67 A1=sign1[0] A2=N40 B1=term1_shifted[26] B2=n39
XU48 AO22S $PINS O=N66 A1=N39 A2=FE_OFN83_s11_0 B1=term1_shifted[25] B2=n39
XU61 AO22S $PINS O=N65 A1=N38 A2=FE_OFN83_s11_0 B1=term1_shifted[24] B2=n39
XU63 AO22S $PINS O=N64 A1=N37 A2=FE_OFN83_s11_0 B1=term1_shifted[23] B2=n39
XU68 NR2T $PINS O=term3_shifted[0] I1=n72 I2=n70
XU78 NR2 $PINS O=term3_in[2] I1=sign3[1] I2=x_in[2]
XU79 NR2 $PINS O=term3_in[3] I1=sign3[1] I2=x_in[3]
XU94 NR2 $PINS O=term3_in[4] I1=sign3[1] I2=x_in[4]
XU116 NR2P $PINS O=term2_shifted[0] I1=n61 I2=n59
Xclk_gate_y_out_reg SNPS_CLOCK_GATE_HIGH_PE_Shift_Add_5 $PINS EN=N234
+ ENCLK=net2295 CLK=clk
Xsub_28_3 PE_Shift_Add_5_DW01_sub_0_DW01_sub_15 $PINS A[26]=net45624
+ A[25]=net45624 A[24]=net45624 A[23]=net45624 A[22]=net45624 A[21]=net45624
+ A[20]=net45624 A[19]=net45624 A[18]=net45624 A[17]=net45624 A[16]=net45624
+ A[15]=net45624 A[14]=net45624 A[13]=net45624 A[12]=net45624 A[11]=net45624
+ A[10]=net45624 A[9]=net45624 A[8]=net45624 A[7]=net45624 A[6]=net45624
+ A[5]=net45624 A[4]=net45624 A[3]=net45624 A[2]=net45624 A[1]=net45624
+ A[0]=net45624 B[26]=term3_shifted[26] B[25]=term3_shifted[25]
+ B[24]=term3_shifted[24] B[23]=term3_shifted[23] B[22]=term3_shifted[22]
+ B[21]=term3_shifted[21] B[20]=term3_shifted[20] B[19]=term3_shifted[19]
+ B[18]=term3_shifted[18] B[17]=term3_shifted[17] B[16]=term3_shifted[16]
+ B[15]=term3_shifted[15] B[14]=term3_shifted[14] B[13]=term3_shifted[13]
+ B[12]=term3_shifted[12] B[11]=term3_shifted[11] B[10]=term3_shifted[10]
+ B[9]=term3_shifted[9] B[8]=term3_shifted[8] B[7]=term3_shifted[7]
+ B[6]=term3_shifted[6] B[5]=term3_shifted[5] B[4]=term3_shifted[4]
+ B[3]=term3_shifted[3] B[2]=term3_shifted[2] B[1]=term3_shifted[1]
+ B[0]=term3_shifted[0] CI=net45624 DIFF[26]=N150 DIFF[25]=N149 DIFF[24]=N148
+ DIFF[23]=N147 DIFF[22]=N146 DIFF[21]=N145 DIFF[20]=N144 DIFF[19]=N143
+ DIFF[18]=N142 DIFF[17]=N141 DIFF[16]=N140 DIFF[15]=N139 DIFF[14]=N138
+ DIFF[13]=N137 DIFF[12]=N136 DIFF[11]=N135 DIFF[10]=N134 DIFF[9]=N133
+ DIFF[8]=N132 DIFF[7]=N131 DIFF[6]=N130 DIFF[5]=N129 DIFF[4]=N128 DIFF[3]=N127
+ DIFF[2]=N126 DIFF[1]=N125 DIFF[0]=N124 FE_RN_1960_0=FE_RN_1960_0
+ FE_RN_1944_0=FE_RN_1944_0 FE_RN_1922_0=FE_RN_1922_0
Xsub_28_2 PE_Shift_Add_5_DW01_sub_1_DW01_sub_16 $PINS A[26]=net45624
+ A[25]=net45624 A[24]=net45624 A[23]=net45624 A[22]=net45624 A[21]=net45624
+ A[20]=net45624 A[19]=net45624 A[18]=net45624 A[17]=net45624 A[16]=net45624
+ A[15]=net45624 A[14]=net45624 A[13]=net45624 A[12]=net45624 A[11]=net45624
+ A[10]=net45624 A[9]=net45624 A[8]=net45624 A[7]=net45624 A[6]=net45624
+ A[5]=net45624 A[4]=net45624 A[3]=net45624 A[2]=net45624 A[1]=net45624
+ A[0]=net45624 B[26]=term2_shifted[26] B[25]=term2_shifted[25]
+ B[24]=term2_shifted[24] B[23]=term2_shifted[23] B[22]=term2_shifted[22]
+ B[21]=term2_shifted[21] B[20]=term2_shifted[20] B[19]=term2_shifted[19]
+ B[18]=term2_shifted[18] B[17]=term2_shifted[17] B[16]=term2_shifted[16]
+ B[15]=term2_shifted[15] B[14]=term2_shifted[14] B[13]=term2_shifted[13]
+ B[12]=term2_shifted[12] B[11]=term2_shifted[11] B[10]=term2_shifted[10]
+ B[9]=term2_shifted[9] B[8]=term2_shifted[8] B[7]=term2_shifted[7]
+ B[6]=term2_shifted[6] B[5]=term2_shifted[5] B[4]=term2_shifted[4]
+ B[3]=term2_shifted[3] B[2]=term2_shifted[2] B[1]=term2_shifted[1]
+ B[0]=term2_shifted[0] CI=net45624 DIFF[26]=N95 DIFF[25]=N94 DIFF[24]=N93
+ DIFF[23]=N92 DIFF[22]=N91 DIFF[21]=N90 DIFF[20]=N89 DIFF[19]=N88 DIFF[18]=N87
+ DIFF[17]=N86 DIFF[16]=N85 DIFF[15]=N84 DIFF[14]=N83 DIFF[13]=N82 DIFF[12]=N81
+ DIFF[11]=N80 DIFF[10]=N79 DIFF[9]=N78 DIFF[8]=N77 DIFF[7]=N76 DIFF[6]=N75
+ DIFF[5]=N74 DIFF[4]=N73 DIFF[3]=N72 DIFF[2]=N71 DIFF[1]=N70 DIFF[0]=N69
Xsub_28 PE_Shift_Add_5_DW01_sub_2_DW01_sub_17 $PINS A[26]=net45624
+ A[25]=net45624 A[24]=net45624 A[23]=net45624 A[22]=net45624 A[21]=net45624
+ A[20]=net45624 A[19]=net45624 A[18]=net45624 A[17]=net45624 A[16]=net45624
+ A[15]=net45624 A[14]=net45624 A[13]=net45624 A[12]=net45624 A[11]=net45624
+ A[10]=net45624 A[9]=net45624 A[8]=net45624 A[7]=net45624 A[6]=net45624
+ A[5]=net45624 A[4]=net45624 A[3]=net45624 A[2]=net45624 A[1]=net45624
+ A[0]=net45624 B[26]=term1_shifted[26] B[25]=term1_shifted[25]
+ B[24]=term1_shifted[24] B[23]=term1_shifted[23] B[22]=term1_shifted[22]
+ B[21]=term1_shifted[21] B[20]=term1_shifted[20] B[19]=term1_shifted[19]
+ B[18]=term1_shifted[18] B[17]=term1_shifted[17] B[16]=term1_shifted[16]
+ B[15]=term1_shifted[15] B[14]=term1_shifted[14] B[13]=term1_shifted[13]
+ B[12]=term1_shifted[12] B[11]=term1_shifted[11] B[10]=term1_shifted[10]
+ B[9]=term1_shifted[9] B[8]=term1_shifted[8] B[7]=term1_shifted[7]
+ B[6]=term1_shifted[6] B[5]=term1_shifted[5] B[4]=term1_shifted[4]
+ B[3]=term1_shifted[3] B[2]=term1_shifted[2] B[1]=term1_shifted[1]
+ B[0]=term1_shifted[0] CI=net45624 DIFF[26]=N40 DIFF[25]=N39 DIFF[24]=N38
+ DIFF[23]=N37 DIFF[22]=N36 DIFF[21]=N35 DIFF[20]=N34 DIFF[19]=N33 DIFF[18]=N32
+ DIFF[17]=N31 DIFF[16]=N30 DIFF[15]=N29 DIFF[14]=N28 DIFF[13]=N27 DIFF[12]=N26
+ DIFF[11]=N25 DIFF[10]=N24 DIFF[9]=N23 DIFF[8]=N22 DIFF[7]=N21 DIFF[6]=N20
+ DIFF[5]=N19 DIFF[4]=N18 DIFF[3]=N17 DIFF[2]=N16 DIFF[1]=N15 DIFF[0]=N14
+ FE_RN_1957_0=FE_RN_1957_0
Xadd_1_root_add_0_root_add_28_3 PE_Shift_Add_5_DW01_add_2_DW01_add_34 $PINS
+ A[26]=N67 A[25]=N66 A[24]=N65 A[23]=N64 A[22]=N63 A[21]=N62 A[20]=N61 A[19]=N60
+ A[18]=N59 A[17]=N58 A[16]=N57 A[15]=N56 A[14]=N55 A[13]=N54 A[12]=N53 A[11]=N52
+ A[10]=N51 A[9]=N50 A[8]=N49 A[7]=N48 A[6]=N47 A[5]=N46 A[4]=N45 A[3]=N44
+ A[2]=N43 A[1]=N42 A[0]=N41 B[26]=N177 B[25]=N176 B[24]=N175 B[23]=N174
+ B[22]=N173 B[21]=N172 B[20]=N171 B[19]=N170 B[18]=N169 B[17]=N168 B[16]=N167
+ B[15]=N166 B[14]=N165 B[13]=N164 B[12]=N163 B[11]=N162 B[10]=N161 B[9]=N160
+ B[8]=N159 B[7]=N158 B[6]=N157 B[5]=N156 B[4]=N155 B[3]=N154 B[2]=N153 B[1]=N152
+ B[0]=N151 CI=net45624 SUM[26]=N204 SUM[25]=N203 SUM[24]=N202 SUM[23]=N201
+ SUM[22]=N200 SUM[21]=N199 SUM[20]=N198 SUM[19]=N197 SUM[18]=N196 SUM[17]=N195
+ SUM[16]=N194 SUM[15]=N193 SUM[14]=N192 SUM[13]=N191 SUM[12]=N190 SUM[11]=N189
+ SUM[10]=N188 SUM[9]=N187 SUM[8]=N186 SUM[7]=N185 SUM[6]=N184 SUM[5]=N183
+ SUM[4]=N182 SUM[3]=N181 SUM[2]=N180 SUM[1]=N179 SUM[0]=N178
Xadd_2_root_add_0_root_add_28_3 PE_Shift_Add_5_DW01_add_1_DW01_add_33 $PINS
+ A[26]=base_val[26] A[25]=base_val[25] A[24]=base_val[24] A[23]=base_val[23]
+ A[22]=base_val[22] A[21]=base_val[21] A[20]=base_val[20] A[19]=base_val[19]
+ A[18]=base_val[18] A[17]=base_val[17] A[16]=base_val[16] A[15]=base_val[15]
+ A[14]=base_val[14] A[13]=base_val[13] A[12]=base_val[12] A[11]=base_val[11]
+ A[10]=base_val[10] A[9]=base_val[9] A[8]=base_val[8] A[7]=base_val[7]
+ A[6]=base_val[6] A[5]=base_val[5] A[4]=base_val[4] A[3]=base_val[3]
+ A[2]=base_val[2] A[1]=base_val[1] A[0]=base_val[0] B[26]=N122 B[25]=N121
+ B[24]=N120 B[23]=N119 B[22]=N118 B[21]=N117 B[20]=N116 B[19]=N115 B[18]=N114
+ B[17]=N113 B[16]=N112 B[15]=N111 B[14]=N110 B[13]=N109 B[12]=N108 B[11]=N107
+ B[10]=N106 B[9]=N105 B[8]=N104 B[7]=N103 B[6]=N102 B[5]=N101 B[4]=N100 B[3]=N99
+ B[2]=N98 B[1]=N97 B[0]=N96 CI=net45624 SUM[26]=N231 SUM[25]=N230 SUM[24]=N229
+ SUM[23]=N228 SUM[22]=N227 SUM[21]=N226 SUM[20]=N225 SUM[19]=N224 SUM[18]=N223
+ SUM[17]=N222 SUM[16]=N221 SUM[15]=N220 SUM[14]=N219 SUM[13]=N218 SUM[12]=N217
+ SUM[11]=N216 SUM[10]=N215 SUM[9]=N214 SUM[8]=N213 SUM[7]=N212 SUM[6]=N211
+ SUM[5]=N210 SUM[4]=N209 SUM[3]=N208 SUM[2]=N207 SUM[1]=N206 SUM[0]=N205
Xadd_0_root_add_0_root_add_28_3 PE_Shift_Add_5_DW01_add_0_DW01_add_32 $PINS
+ A[26]=N204 A[25]=N203 A[24]=N202 A[23]=N201 A[22]=N200 A[21]=N199 A[20]=N198
+ A[19]=N197 A[18]=N196 A[17]=N195 A[16]=N194 A[15]=N193 A[14]=N192
+ A[13]=FE_OCPN896_N191 A[12]=N190 A[11]=N189 A[10]=N188 A[9]=N187 A[8]=N186
+ A[7]=N185 A[6]=N184 A[5]=N183 A[4]=N182 A[3]=N181 A[2]=N180 A[1]=N179 A[0]=N178
+ B[26]=N231 B[25]=N230 B[24]=N229 B[23]=N228 B[22]=N227 B[21]=N226 B[20]=N225
+ B[19]=N224 B[18]=N223 B[17]=N222 B[16]=N221 B[15]=N220 B[14]=N219 B[13]=N218
+ B[12]=N217 B[11]=N216 B[10]=N215 B[9]=N214 B[8]=N213 B[7]=N212 B[6]=N211
+ B[5]=N210 B[4]=N209 B[3]=N208 B[2]=N207 B[1]=N206 B[0]=N205 CI=net45624
+ SUM[26]=next_acc[26] SUM[25]=next_acc[25] SUM[24]=next_acc[24]
+ SUM[23]=next_acc[23] SUM[22]=next_acc[22] SUM[21]=next_acc[21]
+ SUM[20]=next_acc[20] SUM[19]=next_acc[19] SUM[18]=next_acc[18]
+ SUM[17]=next_acc[17] SUM[16]=next_acc[16] SUM[15]=next_acc[15]
+ SUM[14]=next_acc[14] SUM[13]=next_acc[13] SUM[12]=next_acc[12]
+ SUM[11]=next_acc[11] SUM[10]=next_acc[10] SUM[9]=next_acc[9] SUM[8]=next_acc[8]
+ SUM[7]=next_acc[7] SUM[6]=next_acc[6] SUM[5]=next_acc[5] SUM[4]=next_acc[4]
+ SUM[3]=next_acc[3] SUM[2]=next_acc[2] SUM[1]=next_acc[1] SUM[0]=next_acc[0]
.ENDS

.SUBCKT SNPS_CLOCK_GATE_HIGH_PE_Shift_Add_4 EN ENCLK CLK
*.CONNECT net2271 EN
XFE_PHC1294_net2274 DELC $PINS O=FE_PHN1294_net2274 I=net2274
Xlatch QDBHN $PINS Q=net2274 D=net2271 CKB=CLK
Xmain_gate AN2 $PINS O=ENCLK I1=FE_PHN1294_net2274 I2=CLK
.ENDS

.SUBCKT PE_Shift_Add_4_DW01_sub_0_DW01_sub_12 A[26] A[25] A[24] A[23] A[22]
+ A[21] A[20] A[19] A[18] A[17] A[16] A[15] A[14] A[13] A[12] A[11] A[10] A[9]
+ A[8] A[7] A[6] A[5] A[4] A[3] A[2] A[1] A[0] B[26] B[25] B[24] B[23] B[22]
+ B[21] B[20] B[19] B[18] B[17] B[16] B[15] B[14] B[13] B[12] B[11] B[10] B[9]
+ B[8] B[7] B[6] B[5] B[4] B[3] B[2] B[1] B[0] CI DIFF[26] DIFF[25] DIFF[24]
+ DIFF[23] DIFF[22] DIFF[21] DIFF[20] DIFF[19] DIFF[18] DIFF[17] DIFF[16]
+ DIFF[15] DIFF[14] DIFF[13] DIFF[12] DIFF[11] DIFF[10] DIFF[9] DIFF[8] DIFF[7]
+ DIFF[6] DIFF[5] DIFF[4] DIFF[3] DIFF[2] DIFF[1] DIFF[0] CO
*.CONNECT DIFF[0] B[0]
XFE_RC_199_0 INV2 $PINS O=FE_RN_92_0 I=n52
XFE_RC_198_0 MXL2HS $PINS OB=DIFF[1] S=n51 A=FE_RN_92_0 B=n52
XFE_RC_3943_0 INV1S $PINS O=FE_RN_2566_0 I=n32
XFE_RC_3942_0 MXL2HS $PINS OB=DIFF[20] S=n15 A=FE_RN_2566_0 B=n32
XFE_RC_3395_0 XOR2HS $PINS O=DIFF[4] I1=n3 I2=n48
XFE_RC_2870_0 XOR2HS $PINS O=DIFF[3] I1=n2 I2=n49
XFE_RC_2754_0 XOR2HS $PINS O=DIFF[2] I1=n1 I2=n50
XFE_OFC837_term3_shifted_2 INV2 $PINS O=n50 I=B[2]
XFE_OFC755_term3_shifted_3 INV2 $PINS O=n49 I=B[3]
XU3 INV2 $PINS O=n52 I=B[0]
XU4 INV2 $PINS O=n47 I=B[5]
XU8 INV2 $PINS O=n48 I=B[4]
XU10 AN2 $PINS O=n2 I1=n50 I2=n1
XU11 AN2T $PINS O=n3 I1=n49 I2=n2
XU12 AN2 $PINS O=n4 I1=n44 I2=n24
XU13 AN2 $PINS O=n5 I1=n43 I2=n4
XU14 AN2 $PINS O=n6 I1=n42 I2=n5
XU15 AN2 $PINS O=n7 I1=n41 I2=n6
XU16 AN2 $PINS O=n8 I1=n40 I2=n7
XU17 AN2 $PINS O=n9 I1=n39 I2=n8
XU18 AN2 $PINS O=n10 I1=n38 I2=n9
XU19 AN2 $PINS O=n11 I1=n37 I2=n10
XU20 AN2 $PINS O=n12 I1=n36 I2=n11
XU21 AN2 $PINS O=n13 I1=n35 I2=n12
XU22 AN2 $PINS O=n14 I1=n34 I2=n13
XU23 AN2 $PINS O=n15 I1=n33 I2=n14
XU24 AN2 $PINS O=n16 I1=n32 I2=n15
XU25 AN2 $PINS O=n17 I1=n31 I2=n16
XU26 AN2 $PINS O=n18 I1=n30 I2=n17
XU27 AN2 $PINS O=n19 I1=n29 I2=n18
XU28 AN2 $PINS O=n20 I1=n28 I2=n19
XU29 AN2T $PINS O=n21 I1=n48 I2=n3
XU30 AN2T $PINS O=n22 I1=n47 I2=n21
XU31 AN2 $PINS O=n23 I1=n46 I2=n22
XU32 AN2 $PINS O=n24 I1=n45 I2=n23
XU33 INV1S $PINS O=n44 I=B[8]
XU34 INV1S $PINS O=n43 I=B[9]
XU35 INV1S $PINS O=n42 I=B[10]
XU36 INV1S $PINS O=n41 I=B[11]
XU37 XOR2HS $PINS O=DIFF[26] I1=B[26] I2=n26
XU38 INV1S $PINS O=n40 I=B[12]
XU39 INV1S $PINS O=n39 I=B[13]
XU40 INV1S $PINS O=n38 I=B[14]
XU41 INV1S $PINS O=n37 I=B[15]
XU42 INV1S $PINS O=n36 I=B[16]
XU43 INV1S $PINS O=n35 I=B[17]
XU44 INV1S $PINS O=n34 I=B[18]
XU45 INV1S $PINS O=n33 I=B[19]
XU46 INV1S $PINS O=n32 I=B[20]
XU47 INV1S $PINS O=n31 I=B[21]
XU48 INV1S $PINS O=n30 I=B[22]
XU49 INV1S $PINS O=n29 I=B[23]
XU50 INV1S $PINS O=n28 I=B[24]
XU51 INV1S $PINS O=n27 I=B[25]
XU52 INV1S $PINS O=n46 I=B[6]
XU53 INV1S $PINS O=n45 I=B[7]
XU55 XOR2HS $PINS O=DIFF[12] I1=n40 I2=n7
XU56 XOR2HS $PINS O=DIFF[13] I1=n39 I2=n8
XU57 XOR2HS $PINS O=DIFF[14] I1=n38 I2=n9
XU58 XOR2HS $PINS O=DIFF[15] I1=n37 I2=n10
XU59 XOR2HS $PINS O=DIFF[16] I1=n36 I2=n11
XU60 XOR2HS $PINS O=DIFF[11] I1=n41 I2=n6
XU61 XOR2HS $PINS O=DIFF[17] I1=n35 I2=n12
XU62 XOR2HS $PINS O=DIFF[18] I1=n34 I2=n13
XU63 XOR2HS $PINS O=DIFF[19] I1=n33 I2=n14
XU65 XOR2HS $PINS O=DIFF[21] I1=n31 I2=n16
XU66 XOR2HS $PINS O=DIFF[10] I1=n42 I2=n5
XU67 XOR2HS $PINS O=DIFF[22] I1=n30 I2=n17
XU68 XOR2HS $PINS O=DIFF[23] I1=n29 I2=n18
XU69 XOR2HS $PINS O=DIFF[9] I1=n43 I2=n4
XU70 XOR2HS $PINS O=DIFF[7] I1=n45 I2=n23
XU71 XOR2HS $PINS O=DIFF[8] I1=n44 I2=n24
XU72 XOR2HS $PINS O=DIFF[24] I1=n28 I2=n19
XU73 XOR2HS $PINS O=DIFF[6] I1=n46 I2=n22
XU75 XOR2HS $PINS O=DIFF[5] I1=n21 I2=n47
XU76 XOR2HS $PINS O=DIFF[25] I1=n27 I2=n20
XU78 ND2 $PINS O=n26 I1=n27 I2=n20
XU2 INV2 $PINS O=n51 I=B[1]
XU7 NR2 $PINS O=n1 I1=B[1] I2=B[0]
.ENDS

.SUBCKT PE_Shift_Add_4_DW01_sub_1_DW01_sub_13 A[26] A[25] A[24] A[23] A[22]
+ A[21] A[20] A[19] A[18] A[17] A[16] A[15] A[14] A[13] A[12] A[11] A[10] A[9]
+ A[8] A[7] A[6] A[5] A[4] A[3] A[2] A[1] A[0] B[26] B[25] B[24] B[23] B[22]
+ B[21] B[20] B[19] B[18] B[17] B[16] B[15] B[14] B[13] B[12] B[11] B[10] B[9]
+ B[8] B[7] B[6] B[5] B[4] B[3] B[2] B[1] B[0] CI DIFF[26] DIFF[25] DIFF[24]
+ DIFF[23] DIFF[22] DIFF[21] DIFF[20] DIFF[19] DIFF[18] DIFF[17] DIFF[16]
+ DIFF[15] DIFF[14] DIFF[13] DIFF[12] DIFF[11] DIFF[10] DIFF[9] DIFF[8] DIFF[7]
+ DIFF[6] DIFF[5] DIFF[4] DIFF[3] DIFF[2] DIFF[1] DIFF[0] CO
*.CONNECT DIFF[0] B[0]
XFE_RC_128_0 AN2 $PINS O=FE_RN_66_0 I1=n45 I2=n46
XFE_RC_127_0 AN2T $PINS O=n5 I1=FE_RN_66_0 I2=n2
XFE_RC_4034_0 XOR2HS $PINS O=DIFF[3] I1=n7 I2=n49
XFE_RC_3996_0 AN2 $PINS O=FE_RN_2591_0 I1=n10 I2=n40
XFE_RC_3995_0 AN2 $PINS O=n12 I1=FE_RN_2591_0 I2=n41
XFE_RC_2806_0 XOR2HS $PINS O=DIFF[2] I1=n6 I2=n50
XU3 INV2 $PINS O=n48 I=B[4]
XU4 INV2 $PINS O=n50 I=B[2]
XU7 XOR2HS $PINS O=DIFF[5] I1=n47 I2=n1
XU8 XOR2HS $PINS O=DIFF[1] I1=n51 I2=B[0]
XU9 INV1S $PINS O=n47 I=B[5]
XU10 INV1S $PINS O=n46 I=B[6]
XU11 AN2T $PINS O=n1 I1=n3 I2=n48
XU12 AN2 $PINS O=n2 I1=n47 I2=n1
XU13 AN2 $PINS O=n3 I1=n49 I2=n7
XU14 AN2 $PINS O=n4 I1=n46 I2=n2
XU17 AN2T $PINS O=n6 I1=n51 I2=B[0]
XU18 AN2 $PINS O=n7 I1=n50 I2=n6
XU19 AN2 $PINS O=n8 I1=n44 I2=n5
XU20 AN2 $PINS O=n9 I1=n43 I2=n8
XU21 AN2 $PINS O=n10 I1=n42 I2=n9
XU22 AN2 $PINS O=n11 I1=n41 I2=n10
XU24 AN2 $PINS O=n13 I1=n39 I2=n12
XU25 AN2 $PINS O=n14 I1=n38 I2=n13
XU26 AN2 $PINS O=n15 I1=n37 I2=n14
XU27 AN2 $PINS O=n16 I1=n36 I2=n15
XU28 AN2 $PINS O=n17 I1=n35 I2=n16
XU29 AN2 $PINS O=n18 I1=n34 I2=n17
XU30 AN2 $PINS O=n19 I1=n33 I2=n18
XU31 AN2 $PINS O=n20 I1=n32 I2=n19
XU32 AN2 $PINS O=n21 I1=n31 I2=n20
XU33 AN2 $PINS O=n22 I1=n30 I2=n21
XU34 AN2 $PINS O=n23 I1=n29 I2=n22
XU35 AN2 $PINS O=n24 I1=n28 I2=n23
XU36 INV1S $PINS O=n44 I=B[8]
XU37 INV1S $PINS O=n43 I=B[9]
XU38 INV1S $PINS O=n42 I=B[10]
XU39 INV1S $PINS O=n41 I=B[11]
XU40 INV1S $PINS O=n40 I=B[12]
XU41 INV1S $PINS O=n39 I=B[13]
XU42 INV1S $PINS O=n38 I=B[14]
XU43 INV1S $PINS O=n37 I=B[15]
XU44 INV1S $PINS O=n36 I=B[16]
XU45 INV1S $PINS O=n35 I=B[17]
XU46 INV1S $PINS O=n34 I=B[18]
XU47 INV1S $PINS O=n33 I=B[19]
XU48 INV1S $PINS O=n32 I=B[20]
XU49 INV1S $PINS O=n31 I=B[21]
XU50 INV1S $PINS O=n30 I=B[22]
XU51 INV1S $PINS O=n29 I=B[23]
XU52 INV1S $PINS O=n28 I=B[24]
XU53 INV1S $PINS O=n27 I=B[25]
XU54 INV1S $PINS O=n45 I=B[7]
XU55 XOR2HS $PINS O=DIFF[26] I1=B[26] I2=n26
XU56 XOR2HS $PINS O=DIFF[9] I1=n43 I2=n8
XU57 XOR2HS $PINS O=DIFF[10] I1=n42 I2=n9
XU58 XOR2HS $PINS O=DIFF[12] I1=n40 I2=n11
XU59 XOR2HS $PINS O=DIFF[13] I1=n39 I2=n12
XU60 XOR2HS $PINS O=DIFF[14] I1=n38 I2=n13
XU61 XOR2HS $PINS O=DIFF[15] I1=n37 I2=n14
XU62 XOR2HS $PINS O=DIFF[16] I1=n36 I2=n15
XU63 XOR2HS $PINS O=DIFF[11] I1=n41 I2=n10
XU64 XOR2HS $PINS O=DIFF[17] I1=n35 I2=n16
XU65 XOR2HS $PINS O=DIFF[18] I1=n34 I2=n17
XU66 XOR2HS $PINS O=DIFF[19] I1=n33 I2=n18
XU67 XOR2HS $PINS O=DIFF[20] I1=n32 I2=n19
XU68 XOR2HS $PINS O=DIFF[8] I1=n44 I2=n5
XU69 XOR2HS $PINS O=DIFF[7] I1=n45 I2=n4
XU70 XOR2HS $PINS O=DIFF[21] I1=n31 I2=n20
XU71 XOR2HS $PINS O=DIFF[6] I1=n46 I2=n2
XU72 XOR2HS $PINS O=DIFF[22] I1=n30 I2=n21
XU73 XOR2HS $PINS O=DIFF[23] I1=n29 I2=n22
XU74 XOR2HS $PINS O=DIFF[24] I1=n28 I2=n23
XU75 XOR2HS $PINS O=DIFF[4] I1=n48 I2=n3
XU77 XOR2HS $PINS O=DIFF[25] I1=n27 I2=n24
XU78 ND2 $PINS O=n26 I1=n27 I2=n24
XU1 INV2 $PINS O=n49 I=B[3]
XU2 INV2 $PINS O=n51 I=B[1]
.ENDS

.SUBCKT PE_Shift_Add_4_DW01_sub_2_DW01_sub_14 A[26] A[25] A[24] A[23] A[22]
+ A[21] A[20] A[19] A[18] A[17] A[16] A[15] A[14] A[13] A[12] A[11] A[10] A[9]
+ A[8] A[7] A[6] A[5] A[4] A[3] A[2] A[1] A[0] B[26] B[25] B[24] B[23] B[22]
+ B[21] B[20] B[19] B[18] B[17] B[16] B[15] B[14] B[13] B[12] B[11] B[10] B[9]
+ B[8] B[7] B[6] B[5] B[4] B[3] B[2] B[1] B[0] CI DIFF[26] DIFF[25] DIFF[24]
+ DIFF[23] DIFF[22] DIFF[21] DIFF[20] DIFF[19] DIFF[18] DIFF[17] DIFF[16]
+ DIFF[15] DIFF[14] DIFF[13] DIFF[12] DIFF[11] DIFF[10] DIFF[9] DIFF[8] DIFF[7]
+ DIFF[6] DIFF[5] DIFF[4] DIFF[3] DIFF[2] DIFF[1] DIFF[0] CO
*.CONNECT DIFF[0] B[0]
XFE_RC_3199_0 XOR2HS $PINS O=DIFF[3] I1=n3 I2=n50
XFE_RC_2809_0 INV1S $PINS O=FE_RN_1787_0 I=n53
XFE_RC_2808_0 MXL2HS $PINS OB=DIFF[1] S=n52 A=FE_RN_1787_0 B=n53
XFE_RC_264_0 XOR2HS $PINS O=DIFF[2] I1=n2 I2=n51
XU4 INV2 $PINS O=n53 I=B[0]
XU6 NR2 $PINS O=n2 I1=B[1] I2=B[0]
XU8 NR2P $PINS O=n4 I1=B[3] I2=n1
XU9 INV1S $PINS O=n1 I=n3
XU10 INV2 $PINS O=n49 I=B[4]
XU11 XOR2HS $PINS O=DIFF[4] I1=n49 I2=n4
XU12 INV1S $PINS O=n47 I=B[6]
XU13 INV1S $PINS O=n48 I=B[5]
XU14 INV1S $PINS O=n46 I=B[7]
XU16 AN2 $PINS O=n3 I1=n51 I2=n2
XU17 XOR2HS $PINS O=DIFF[8] I1=n45 I2=n25
XU18 XOR2HS $PINS O=DIFF[9] I1=n44 I2=n5
XU19 AN2 $PINS O=n5 I1=n45 I2=n25
XU20 XOR2HS $PINS O=DIFF[10] I1=n43 I2=n6
XU21 AN2 $PINS O=n6 I1=n44 I2=n5
XU22 XOR2HS $PINS O=DIFF[11] I1=n42 I2=n7
XU23 AN2 $PINS O=n7 I1=n43 I2=n6
XU24 XOR2HS $PINS O=DIFF[12] I1=n41 I2=n8
XU25 AN2 $PINS O=n8 I1=n42 I2=n7
XU26 XOR2HS $PINS O=DIFF[13] I1=n40 I2=n9
XU27 AN2 $PINS O=n9 I1=n41 I2=n8
XU28 XOR2HS $PINS O=DIFF[14] I1=n39 I2=n10
XU29 AN2 $PINS O=n10 I1=n40 I2=n9
XU30 XOR2HS $PINS O=DIFF[15] I1=n38 I2=n11
XU31 AN2 $PINS O=n11 I1=n39 I2=n10
XU32 XOR2HS $PINS O=DIFF[16] I1=n37 I2=n12
XU33 AN2 $PINS O=n12 I1=n38 I2=n11
XU34 XOR2HS $PINS O=DIFF[17] I1=n36 I2=n13
XU35 AN2 $PINS O=n13 I1=n37 I2=n12
XU36 XOR2HS $PINS O=DIFF[18] I1=n35 I2=n14
XU37 AN2 $PINS O=n14 I1=n36 I2=n13
XU38 XOR2HS $PINS O=DIFF[19] I1=n34 I2=n15
XU39 AN2 $PINS O=n15 I1=n35 I2=n14
XU40 XOR2HS $PINS O=DIFF[20] I1=n33 I2=n16
XU41 AN2 $PINS O=n16 I1=n34 I2=n15
XU42 XOR2HS $PINS O=DIFF[21] I1=n32 I2=n17
XU43 AN2 $PINS O=n17 I1=n33 I2=n16
XU44 XOR2HS $PINS O=DIFF[22] I1=n31 I2=n18
XU45 AN2 $PINS O=n18 I1=n32 I2=n17
XU46 XOR2HS $PINS O=DIFF[23] I1=n30 I2=n19
XU47 AN2 $PINS O=n19 I1=n31 I2=n18
XU48 XOR2HS $PINS O=DIFF[24] I1=n29 I2=n20
XU49 AN2 $PINS O=n20 I1=n30 I2=n19
XU50 AN2 $PINS O=n21 I1=n29 I2=n20
XU51 XOR2HS $PINS O=DIFF[25] I1=n28 I2=n21
XU52 XOR2HS $PINS O=DIFF[5] I1=n48 I2=n22
XU53 AN2 $PINS O=n22 I1=n49 I2=n4
XU54 XOR2HS $PINS O=DIFF[6] I1=n47 I2=n23
XU55 AN2T $PINS O=n23 I1=n22 I2=n48
XU56 XOR2HS $PINS O=DIFF[7] I1=n46 I2=n24
XU57 AN2T $PINS O=n24 I1=n47 I2=n23
XU58 AN2 $PINS O=n25 I1=n46 I2=n24
XU59 INV1S $PINS O=n45 I=B[8]
XU60 INV1S $PINS O=n44 I=B[9]
XU61 INV1S $PINS O=n43 I=B[10]
XU62 INV1S $PINS O=n42 I=B[11]
XU63 INV1S $PINS O=n41 I=B[12]
XU64 INV1S $PINS O=n40 I=B[13]
XU65 INV1S $PINS O=n39 I=B[14]
XU66 INV1S $PINS O=n38 I=B[15]
XU67 INV1S $PINS O=n37 I=B[16]
XU68 INV1S $PINS O=n36 I=B[17]
XU69 INV1S $PINS O=n35 I=B[18]
XU70 INV1S $PINS O=n34 I=B[19]
XU71 INV1S $PINS O=n33 I=B[20]
XU72 INV1S $PINS O=n32 I=B[21]
XU73 INV1S $PINS O=n31 I=B[22]
XU74 INV1S $PINS O=n30 I=B[23]
XU75 INV1S $PINS O=n29 I=B[24]
XU76 INV1S $PINS O=n28 I=B[25]
XU77 XOR2HS $PINS O=DIFF[26] I1=B[26] I2=n27
XU79 ND2 $PINS O=n27 I1=n28 I2=n21
XU1 INV1S $PINS O=n50 I=B[3]
XU3 INV2 $PINS O=n51 I=B[2]
XU5 INV2 $PINS O=n52 I=B[1]
.ENDS

.SUBCKT PE_Shift_Add_4_DW01_add_2_DW01_add_22 A[26] A[25] A[24] A[23] A[22]
+ A[21] A[20] A[19] A[18] A[17] A[16] A[15] A[14] A[13] A[12] A[11] A[10] A[9]
+ A[8] A[7] A[6] A[5] A[4] A[3] A[2] A[1] A[0] B[26] B[25] B[24] B[23] B[22]
+ B[21] B[20] B[19] B[18] B[17] B[16] B[15] B[14] B[13] B[12] B[11] B[10] B[9]
+ B[8] B[7] B[6] B[5] B[4] B[3] B[2] B[1] B[0] CI SUM[26] SUM[25] SUM[24]
+ SUM[23] SUM[22] SUM[21] SUM[20] SUM[19] SUM[18] SUM[17] SUM[16] SUM[15]
+ SUM[14] SUM[13] SUM[12] SUM[11] SUM[10] SUM[9] SUM[8] SUM[7] SUM[6] SUM[5]
+ SUM[4] SUM[3] SUM[2] SUM[1] SUM[0] CO
XFE_RC_306_0 XOR3 $PINS O=SUM[21] I1=A[21] I2=B[21] I3=carry[21]
XFE_RC_305_0 ND2P $PINS O=FE_RN_145_0 I1=B[21] I2=carry[21]
XFE_RC_304_0 ND2P $PINS O=FE_RN_146_0 I1=A[21] I2=carry[21]
XFE_RC_303_0 ND2 $PINS O=FE_RN_147_0 I1=A[21] I2=B[21]
XFE_RC_302_0 ND3P $PINS O=carry[22] I1=FE_RN_147_0 I2=FE_RN_146_0
+ I3=FE_RN_145_0
XFE_RC_274_0 XOR2HS $PINS O=FE_RN_286_0 I1=B[7] I2=FE_OCPN1217_N48
XFE_RC_193_0 AOI22H $PINS O=FE_RN_697_0 A1=B[8] A2=A[8] B1=carry[8] B2=A[8]
XFE_RC_159_0 XOR3 $PINS O=SUM[22] I1=A[22] I2=B[22] I3=carry[22]
XFE_RC_158_0 MAO222P $PINS O=carry[23] A1=A[22] B1=B[22] C1=carry[22]
XFE_RC_149_0 INV2 $PINS O=SUM[13] I=FE_RN_74_0
XFE_RC_148_0 XNR3 $PINS O=FE_RN_74_0 I1=B[13] I2=A[13] I3=carry[13]
XFE_RC_132_0 AOI22H $PINS O=FE_RN_640_0 A1=B[6] A2=A[6] B1=carry[6] B2=A[6]
XFE_OCPC1217_N48 BUF1 $PINS O=FE_OCPN1217_N48 I=A[7]
XFE_OCPC1184_carry_23 BUF1S $PINS O=FE_OCPN1184_carry_23 I=carry[23]
XFE_OCPC1181_carry_19 BUF1 $PINS O=FE_OCPN1181_carry_19 I=carry[19]
XFE_OCPC1117_carry_17 BUF1 $PINS O=FE_OCPN1117_carry_17 I=carry[17]
XFE_OCPC1111_carry_20 BUF1S $PINS O=FE_OCPN1111_carry_20 I=carry[20]
XFE_OCPC1060_carry_18 BUF1S $PINS O=FE_OCPN1060_carry_18 I=carry[18]
XFE_OCPC1016_carry_5 BUF1S $PINS O=FE_OCPN1016_carry_5 I=carry[5]
XFE_RC_4008_0 XOR3 $PINS O=SUM[23] I1=A[23] I2=B[23] I3=FE_OCPN1184_carry_23
XFE_RC_4007_0 MAO222 $PINS O=carry[24] A1=A[23] B1=B[23] C1=carry[23]
XFE_RC_3998_0 MAO222P $PINS O=carry[4] A1=carry[3] B1=B[3] C1=A[3]
XFE_RC_3971_0 XOR3 $PINS O=SUM[24] I1=A[24] I2=B[24] I3=carry[24]
XFE_RC_3970_0 MAO222 $PINS O=carry[25] A1=A[24] B1=B[24] C1=carry[24]
XFE_RC_3918_0 XOR3 $PINS O=SUM[2] I1=A[2] I2=B[2] I3=carry[2]
XFE_RC_3917_0 MAO222 $PINS O=carry[3] A1=A[2] B1=B[2] C1=carry[2]
XFE_RC_3885_0 XOR2H $PINS O=SUM[5] I1=FE_OCPN1016_carry_5 I2=n5
XFE_RC_3785_0 XOR3 $PINS O=SUM[3] I1=A[3] I2=B[3] I3=carry[3]
XFE_RC_1349_0_dup ND2P $PINS O=FE_RN_1 I1=FE_RN_699_0 I2=FE_RN_698_0
XFE_RC_2504_0 XNR2HS $PINS O=FE_RN_1558_0 I1=A[20] I2=B[20]
XFE_RC_2503_0 ND2 $PINS O=FE_RN_1559_0 I1=B[20] I2=A[20]
XFE_RC_2502_0 ND2 $PINS O=FE_RN_1560_0 I1=FE_RN_1559_0 I2=FE_RN_1564_0
XFE_RC_2501_0 ND2 $PINS O=FE_RN_1561_0 I1=FE_RN_1560_0 I2=FE_OCPN1111_carry_20
XFE_RC_2500_0 OAI12HS $PINS O=SUM[20] A1=FE_RN_1561_0 B1=FE_RN_1558_0
+ B2=FE_OCPN1111_carry_20
XFE_RC_2498_0 INV1S $PINS O=FE_RN_1563_0 I=B[20]
XFE_RC_2497_0 OR2B1S $PINS O=FE_RN_1564_0 I1=A[20] B1=FE_RN_1563_0
XFE_RC_2496_0 ND2 $PINS O=FE_RN_1565_0 I1=carry[20] I2=FE_RN_1564_0
XFE_RC_2495_0 ND2P $PINS O=carry[21] I1=FE_RN_1565_0 I2=FE_RN_1559_0
XFE_RC_2423_0 ND3 $PINS O=carry[2] I1=n18 I2=n19 I3=n20
XFE_RC_2205_0 ND3P $PINS O=carry[5] I1=n3 I2=n4 I3=n2
XFE_RC_2189_0 XOR2HS $PINS O=FE_RN_1326_0 I1=A[19] I2=B[19]
XFE_RC_2188_0 XOR2HS $PINS O=SUM[19] I1=FE_OCPN1181_carry_19 I2=FE_RN_1326_0
XFE_RC_2187_0 ND2 $PINS O=FE_RN_1327_0 I1=B[19] I2=A[19]
XFE_RC_2186_0 INV1S $PINS O=FE_RN_1328_0 I=B[19]
XFE_RC_2185_0 OR2B1S $PINS O=FE_RN_1329_0 I1=A[19] B1=FE_RN_1328_0
XFE_RC_2184_0 ND2 $PINS O=FE_RN_1330_0 I1=carry[19] I2=FE_RN_1329_0
XFE_RC_2183_0 ND2P $PINS O=carry[20] I1=FE_RN_1330_0 I2=FE_RN_1327_0
XFE_RC_1996_0 ND2 $PINS O=FE_RN_1187_0 I1=carry[13] I2=B[13]
XFE_RC_1995_0 AOI22H $PINS O=FE_RN_1188_0 A1=A[13] A2=B[13] B1=carry[13]
+ B2=A[13]
XFE_RC_1994_0 ND2P $PINS O=carry[14] I1=FE_RN_1188_0 I2=FE_RN_1187_0
XFE_RC_1974_0 ND2 $PINS O=FE_RN_1171_0 I1=carry[16] I2=B[16]
XFE_RC_1973_0 AOI22H $PINS O=FE_RN_1172_0 A1=A[16] A2=B[16] B1=carry[16]
+ B2=A[16]
XFE_RC_1972_0 ND2P $PINS O=carry[17] I1=FE_RN_1172_0 I2=FE_RN_1171_0
XFE_RC_1658_0 ND2 $PINS O=FE_RN_930_0 I1=FE_RN_1 I2=B[11]
XFE_RC_1657_0 AOI22S $PINS O=FE_RN_931_0 A1=A[11] A2=B[11] B1=FE_RN_1 B2=A[11]
XFE_RC_1656_0 ND2P $PINS O=carry[12] I1=FE_RN_931_0 I2=FE_RN_930_0
XFE_RC_1652_0 INV1S $PINS O=FE_RN_919_0 I=FE_RN_926_0
XFE_RC_1651_0 AOI12HS $PINS O=FE_RN_920_0 A1=FE_RN_919_0 B1=B[18] B2=A[18]
XFE_RC_1650_0 INV1S $PINS O=FE_RN_921_0 I=B[18]
XFE_RC_1648_0 NR2 $PINS O=FE_RN_923_0 I1=A[18] I2=FE_RN_921_0
XFE_RC_1647_0 AOI12HS $PINS O=FE_RN_924_0 A1=FE_RN_923_0 B1=FE_RN_921_0
+ B2=A[18]
XFE_RC_1646_0 MXL2HS $PINS OB=SUM[18] S=FE_OCPN1060_carry_18 A=FE_RN_924_0
+ B=FE_RN_920_0
XFE_RC_1645_0 ND2 $PINS O=FE_RN_925_0 I1=B[18] I2=A[18]
XFE_RC_1644_0 OR2 $PINS O=FE_RN_926_0 I1=A[18] I2=B[18]
XFE_RC_1643_0 ND2P $PINS O=FE_RN_927_0 I1=carry[18] I2=FE_RN_926_0
XFE_RC_1642_0 ND2P $PINS O=carry[19] I1=FE_RN_927_0 I2=FE_RN_925_0
XFE_RC_1550_0 ND2 $PINS O=FE_RN_850_0 I1=carry[12] I2=B[12]
XFE_RC_1549_0 AOI22H $PINS O=FE_RN_851_0 A1=A[12] A2=B[12] B1=carry[12]
+ B2=A[12]
XFE_RC_1548_0 ND2P $PINS O=carry[13] I1=FE_RN_851_0 I2=FE_RN_850_0
XFE_RC_1351_0 ND2 $PINS O=FE_RN_698_0 I1=carry[10] I2=B[10]
XFE_RC_1350_0 AOI22H $PINS O=FE_RN_699_0 A1=A[10] A2=B[10] B1=carry[10]
+ B2=A[10]
XFE_RC_1348_0 ND2 $PINS O=FE_RN_696_0 I1=carry[8] I2=B[8]
XFE_RC_1346_0 ND2P $PINS O=carry[9] I1=FE_RN_697_0 I2=FE_RN_696_0
XFE_RC_1271_0 ND2 $PINS O=FE_RN_639_0 I1=carry[6] I2=B[6]
XFE_RC_1269_0 ND2P $PINS O=carry[7] I1=FE_RN_640_0 I2=FE_RN_639_0
XFE_RC_1221_0 ND2 $PINS O=FE_RN_597_0 I1=carry[9] I2=B[9]
XFE_RC_1220_0 AOI22H $PINS O=FE_RN_598_0 A1=A[9] A2=B[9] B1=carry[9] B2=A[9]
XFE_RC_1219_0 ND2P $PINS O=carry[10] I1=FE_RN_598_0 I2=FE_RN_597_0
XFE_RC_817_0 INV1S $PINS O=FE_RN_285_0 I=carry[7]
XFE_RC_815_0 ND2 $PINS O=FE_RN_287_0 I1=FE_RN_286_0 I2=FE_RN_285_0
XFE_RC_814_0 INV1S $PINS O=FE_RN_288_0 I=A[7]
XFE_RC_813_0 INV1S $PINS O=FE_RN_289_0 I=B[7]
XFE_RC_812_0 OAI12HS $PINS O=FE_RN_290_0 A1=FE_RN_293_0 B1=FE_RN_289_0
+ B2=FE_RN_288_0
XFE_RC_811_0 ND2 $PINS O=FE_RN_291_0 I1=FE_RN_290_0 I2=carry[7]
XFE_RC_810_0 ND2P $PINS O=SUM[7] I1=FE_RN_291_0 I2=FE_RN_287_0
XFE_RC_809_0 ND2 $PINS O=FE_RN_292_0 I1=B[7] I2=A[7]
XFE_RC_808_0 OR2T $PINS O=FE_RN_293_0 I1=A[7] I2=B[7]
XFE_RC_807_0 ND2P $PINS O=FE_RN_294_0 I1=carry[7] I2=FE_RN_293_0
XFE_RC_806_0 ND2P $PINS O=carry[8] I1=FE_RN_294_0 I2=FE_RN_292_0
XFE_RC_727_0 XOR3 $PINS O=SUM[6] I1=A[6] I2=B[6] I3=carry[6]
XFE_RC_617_0 XOR3 $PINS O=SUM[8] I1=A[8] I2=B[8] I3=carry[8]
XFE_RC_541_0 XOR3 $PINS O=SUM[9] I1=A[9] I2=B[9] I3=carry[9]
XFE_RC_466_0 XOR3 $PINS O=SUM[10] I1=A[10] I2=B[10] I3=carry[10]
XFE_RC_440_0 XOR3 $PINS O=SUM[11] I1=A[11] I2=B[11] I3=FE_RN_1
XFE_RC_290_0 XOR3 $PINS O=SUM[12] I1=A[12] I2=B[12] I3=carry[12]
XFE_RC_173_0 ND3P $PINS O=carry[16] I1=n12 I2=n11 I3=n13
XFE_RC_100_0 XOR3 $PINS O=SUM[16] I1=A[16] I2=B[16] I3=carry[16]
XU1_14 FA1 $PINS S=SUM[14] CO=carry[15] A=A[14] B=B[14] CI=carry[14]
XU1_25 FA1 $PINS S=SUM[25] CO=carry[26] A=A[25] B=B[25] CI=carry[25]
XU1_26 XOR3 $PINS O=SUM[26] I1=A[26] I2=B[26] I3=carry[26]
XU1 XOR3 $PINS O=SUM[4] I1=B[4] I2=A[4] I3=carry[4]
XU3 ND3P $PINS O=carry[6] I1=n8 I2=n7 I3=n6
XU4 XOR3 $PINS O=SUM[1] I1=carry[1] I2=A[1] I3=B[1]
XU6 ND2 $PINS O=n2 I1=B[4] I2=A[4]
XU8 ND2 $PINS O=n18 I1=A[1] I2=carry[1]
XU9 ND2 $PINS O=n19 I1=A[1] I2=B[1]
XU10 ND2 $PINS O=n20 I1=carry[1] I2=B[1]
XU12 ND2 $PINS O=n3 I1=B[4] I2=carry[4]
XU13 ND2 $PINS O=n4 I1=carry[4] I2=A[4]
XU14 XOR2HS $PINS O=n5 I1=A[5] I2=B[5]
XU15 ND2P $PINS O=n6 I1=A[5] I2=B[5]
XU16 ND2 $PINS O=n7 I1=carry[5] I2=A[5]
XU17 ND2 $PINS O=n8 I1=carry[5] I2=B[5]
XU18 ND2 $PINS O=n13 I1=A[15] I2=B[15]
XU19 ND2 $PINS O=n21 I1=A[0] I2=B[0]
XU21 MAO222 $PINS O=n9 A1=carry[14] B1=B[14] C1=A[14]
XU22 XOR2HS $PINS O=n10 I1=A[15] I2=B[15]
XU23 XOR2HS $PINS O=SUM[15] I1=n9 I2=n10
XU24 ND2P $PINS O=n11 I1=n9 I2=A[15]
XU26 XOR2HS $PINS O=n14 I1=A[17] I2=B[17]
XU27 XOR2H $PINS O=SUM[17] I1=FE_OCPN1117_carry_17 I2=n14
XU28 ND2P $PINS O=n15 I1=carry[17] I2=A[17]
XU29 ND2 $PINS O=n16 I1=carry[17] I2=B[17]
XU30 ND2 $PINS O=n17 I1=A[17] I2=B[17]
XU32 INV2 $PINS O=carry[1] I=n21
XU33 XOR2HS $PINS O=SUM[0] I1=A[0] I2=B[0]
XU20 ND3P $PINS O=carry[18] I1=n16 I2=n15 I3=n17
XU31 ND2 $PINS O=n12 I1=carry[15] I2=B[15]
.ENDS

.SUBCKT PE_Shift_Add_4_DW01_add_1_DW01_add_21 A[26] A[25] A[24] A[23] A[22]
+ A[21] A[20] A[19] A[18] A[17] A[16] A[15] A[14] A[13] A[12] A[11] A[10] A[9]
+ A[8] A[7] A[6] A[5] A[4] A[3] A[2] A[1] A[0] B[26] B[25] B[24] B[23] B[22]
+ B[21] B[20] B[19] B[18] B[17] B[16] B[15] B[14] B[13] B[12] B[11] B[10] B[9]
+ B[8] B[7] B[6] B[5] B[4] B[3] B[2] B[1] B[0] CI SUM[26] SUM[25] SUM[24]
+ SUM[23] SUM[22] SUM[21] SUM[20] SUM[19] SUM[18] SUM[17] SUM[16] SUM[15]
+ SUM[14] SUM[13] SUM[12] SUM[11] SUM[10] SUM[9] SUM[8] SUM[7] SUM[6] SUM[5]
+ SUM[4] SUM[3] SUM[2] SUM[1] SUM[0] CO
XFE_RC_263_0 INV1S $PINS O=FE_RN_115_0 I=B[22]
XFE_RC_262_0 INV1S $PINS O=FE_RN_116_0 I=A[22]
XFE_RC_261_0 AOI22S $PINS O=FE_RN_117_0 A1=FE_RN_116_0 A2=B[22] B1=A[22]
+ B2=FE_RN_115_0
XFE_RC_258_0 OAI12HS $PINS O=FE_RN_120_0 A1=FE_RN_125_0 B1=FE_RN_116_0
+ B2=FE_RN_115_0
XFE_RC_257_0 ND2S $PINS O=FE_RN_121_0 I1=FE_RN_120_0 I2=carry[22]
XFE_RC_256_0 OAI12H $PINS O=SUM[22] A1=FE_RN_121_0 B1=FE_RN_117_0 B2=carry[22]
XFE_RC_255_0 ND2 $PINS O=FE_RN_122_0 I1=A[22] I2=B[22]
XFE_RC_252_0 ND2S $PINS O=FE_RN_125_0 I1=FE_RN_116_0 I2=FE_RN_115_0
XFE_RC_251_0 ND2 $PINS O=FE_RN_126_0 I1=FE_RN_125_0 I2=carry[22]
XFE_RC_250_0 ND2P $PINS O=carry[23] I1=FE_RN_126_0 I2=FE_RN_122_0
XFE_RC_133_0 OAI12H $PINS O=carry[2] A1=FE_RN_1464_0 B1=FE_RN_1462_0
+ B2=FE_RN_1463_0
XFE_RC_94_0 OR2 $PINS O=FE_RN_53_0 I1=FE_RN_2288_0 I2=FE_RN_2287_0
XFE_RC_93_0 ND2 $PINS O=carry[21] I1=FE_RN_2292_0 I2=FE_RN_53_0
XFE_RC_88_0 ND3P $PINS O=carry[25] I1=n5 I2=n4 I3=n6
XFE_OCPC1202_FE_RN_732_0 BUF1 $PINS O=FE_OCPN1202_FE_RN_732_0 I=FE_RN_732_0
XFE_RC_4016_0 XOR3 $PINS O=SUM[23] I1=A[23] I2=B[23] I3=carry[23]
XFE_RC_4015_0 MAO222 $PINS O=carry[24] A1=A[23] B1=B[23] C1=carry[23]
XFE_RC_3911_0 INV1S $PINS O=FE_RN_2555_0 I=FE_RN_2074_0
XFE_RC_3910_0 OR2B1S $PINS O=FE_RN_2556_0 I1=FE_RN_2073_0 B1=FE_RN_2555_0
XFE_RC_3909_0 ND2P $PINS O=carry[20] I1=FE_RN_2078_0 I2=FE_RN_2556_0
XFE_RC_3507_0 INV1S $PINS O=FE_RN_2281_0 I=carry[20]
XFE_RC_3506_0 XOR2HS $PINS O=FE_RN_2282_0 I1=B[20] I2=A[20]
XFE_RC_3505_0 ND2 $PINS O=FE_RN_2283_0 I1=FE_RN_2282_0 I2=FE_RN_2281_0
XFE_RC_3504_0 ND2 $PINS O=FE_RN_2284_0 I1=A[20] I2=B[20]
XFE_RC_3503_0 ND2S $PINS O=FE_RN_2285_0 I1=FE_RN_2284_0 I2=FE_RN_2291_0
XFE_RC_3502_0 ND2 $PINS O=FE_RN_2286_0 I1=FE_RN_2285_0 I2=carry[20]
XFE_RC_3501_0 ND2 $PINS O=SUM[20] I1=FE_RN_2286_0 I2=FE_RN_2283_0
XFE_RC_3500_0 INV1S $PINS O=FE_RN_2287_0 I=B[20]
XFE_RC_3499_0 INV1S $PINS O=FE_RN_2288_0 I=A[20]
XFE_RC_3496_0 ND2 $PINS O=FE_RN_2291_0 I1=FE_RN_2287_0 I2=FE_RN_2288_0
XFE_RC_3495_0 ND2 $PINS O=FE_RN_2292_0 I1=FE_RN_2291_0 I2=carry[20]
XFE_RC_3444_0 INV1S $PINS O=FE_RN_2245_0 I=FE_RN_1585_0
XFE_RC_3443_0 OR2B1S $PINS O=FE_RN_2246_0 I1=FE_RN_1584_0 B1=FE_RN_2245_0
XFE_RC_3442_0 ND2P $PINS O=carry[19] I1=FE_RN_1589_0 I2=FE_RN_2246_0
XFE_RC_3217_0 INV1S $PINS O=FE_RN_2067_0 I=carry[19]
XFE_RC_3216_0 XOR2HS $PINS O=FE_RN_2068_0 I1=B[19] I2=A[19]
XFE_RC_3215_0 ND2 $PINS O=FE_RN_2069_0 I1=FE_RN_2068_0 I2=FE_RN_2067_0
XFE_RC_3214_0 ND2 $PINS O=FE_RN_2070_0 I1=A[19] I2=B[19]
XFE_RC_3213_0 ND2S $PINS O=FE_RN_2071_0 I1=FE_RN_2070_0 I2=FE_RN_2077_0
XFE_RC_3212_0 ND2 $PINS O=FE_RN_2072_0 I1=FE_RN_2071_0 I2=carry[19]
XFE_RC_3211_0 ND2 $PINS O=SUM[19] I1=FE_RN_2072_0 I2=FE_RN_2069_0
XFE_RC_3210_0 INV1S $PINS O=FE_RN_2073_0 I=B[19]
XFE_RC_3209_0 INV1S $PINS O=FE_RN_2074_0 I=A[19]
XFE_RC_3206_0 ND2 $PINS O=FE_RN_2077_0 I1=FE_RN_2073_0 I2=FE_RN_2074_0
XFE_RC_3205_0 ND2 $PINS O=FE_RN_2078_0 I1=FE_RN_2077_0 I2=carry[19]
XFE_RC_3141_0 ND2 $PINS O=FE_RN_2023_0 I1=carry[3] I2=A[3]
XFE_RC_3140_0 AOI22H $PINS O=FE_RN_2024_0 A1=B[3] A2=A[3] B1=carry[3] B2=B[3]
XFE_RC_3139_0 ND2P $PINS O=carry[4] I1=FE_RN_2024_0 I2=FE_RN_2023_0
XFE_RC_3135_0 INV1S $PINS O=FE_RN_2019_0 I=FE_RN_1371_0
XFE_RC_3134_0 OR2B1S $PINS O=FE_RN_2020_0 I1=FE_RN_1379_0 B1=FE_RN_2019_0
XFE_RC_3133_0 ND2P $PINS O=carry[18] I1=FE_RN_1384_0 I2=FE_RN_2020_0
XFE_RC_3089_0 ND2P $PINS O=FE_RN_1989_0 I1=carry[4] I2=A[4]
XFE_RC_3088_0 AOI22H $PINS O=FE_RN_1990_0 A1=B[4] A2=A[4] B1=carry[4] B2=B[4]
XFE_RC_3087_0 ND2P $PINS O=carry[5] I1=FE_RN_1990_0 I2=FE_RN_1989_0
XFE_RC_2546_0 ND2 $PINS O=FE_RN_1597_0 I1=carry[14] I2=B[14]
XFE_RC_2545_0 AOI22S $PINS O=FE_RN_1598_0 A1=B[14] A2=A[14] B1=carry[14]
+ B2=A[14]
XFE_RC_2544_0 ND2P $PINS O=carry[15] I1=FE_RN_1598_0 I2=FE_RN_1597_0
XFE_RC_2533_0 INV1S $PINS O=FE_RN_1578_0 I=carry[18]
XFE_RC_2532_0 XOR2HS $PINS O=FE_RN_1579_0 I1=B[18] I2=A[18]
XFE_RC_2531_0 ND2 $PINS O=FE_RN_1580_0 I1=FE_RN_1579_0 I2=FE_RN_1578_0
XFE_RC_2530_0 ND2 $PINS O=FE_RN_1581_0 I1=A[18] I2=B[18]
XFE_RC_2529_0 ND2S $PINS O=FE_RN_1582_0 I1=FE_RN_1581_0 I2=FE_RN_1588_0
XFE_RC_2528_0 ND2 $PINS O=FE_RN_1583_0 I1=FE_RN_1582_0 I2=carry[18]
XFE_RC_2527_0 ND2 $PINS O=SUM[18] I1=FE_RN_1583_0 I2=FE_RN_1580_0
XFE_RC_2526_0 INV1S $PINS O=FE_RN_1584_0 I=B[18]
XFE_RC_2525_0 INV1S $PINS O=FE_RN_1585_0 I=A[18]
XFE_RC_2522_0 ND2 $PINS O=FE_RN_1588_0 I1=FE_RN_1585_0 I2=FE_RN_1584_0
XFE_RC_2521_0 ND2 $PINS O=FE_RN_1589_0 I1=FE_RN_1588_0 I2=carry[18]
XFE_RC_2370_0 INV1S $PINS O=FE_RN_1462_0 I=n3
XFE_RC_2369_0 INV1S $PINS O=FE_RN_1463_0 I=A[1]
XFE_RC_2368_0 OAI12HS $PINS O=FE_RN_1464_0 A1=B[1] B1=n3 B2=A[1]
XFE_RC_2366_0 XOR2HS $PINS O=FE_RN_1465_0 I1=n3 I2=A[1]
XFE_RC_2365_0 XOR2HS $PINS O=SUM[1] I1=B[1] I2=FE_RN_1465_0
XFE_RC_2320_0 XOR3 $PINS O=SUM[4] I1=A[4] I2=B[4] I3=carry[4]
XFE_RC_2259_0 INV1S $PINS O=FE_RN_1371_0 I=A[17]
XFE_RC_2258_0 NR2 $PINS O=FE_RN_1372_0 I1=B[17] I2=FE_RN_1371_0
XFE_RC_2257_0 AN2B1S $PINS O=FE_RN_1373_0 I1=B[17] B1=A[17]
XFE_RC_2256_0 INV1S $PINS O=FE_RN_1374_0 I=carry[17]
XFE_RC_2255_0 OAI12HS $PINS O=FE_RN_1375_0 A1=FE_RN_1374_0 B1=FE_RN_1373_0
+ B2=FE_RN_1372_0
XFE_RC_2254_0 ND2 $PINS O=FE_RN_1376_0 I1=A[17] I2=B[17]
XFE_RC_2253_0 ND2S $PINS O=FE_RN_1377_0 I1=FE_RN_1376_0 I2=FE_RN_1383_0
XFE_RC_2252_0 ND2 $PINS O=FE_RN_1378_0 I1=FE_RN_1377_0 I2=carry[17]
XFE_RC_2251_0 ND2 $PINS O=SUM[17] I1=FE_RN_1378_0 I2=FE_RN_1375_0
XFE_RC_2250_0 INV1S $PINS O=FE_RN_1379_0 I=B[17]
XFE_RC_2246_0 ND2 $PINS O=FE_RN_1383_0 I1=FE_RN_1371_0 I2=FE_RN_1379_0
XFE_RC_2245_0 ND2 $PINS O=FE_RN_1384_0 I1=FE_RN_1383_0 I2=carry[17]
XFE_RC_2215_0 ND3P $PINS O=carry[17] I1=n12 I2=n11 I3=n13
XFE_RC_2214_0 ND2 $PINS O=FE_RN_1347_0 I1=carry[5] I2=A[5]
XFE_RC_2213_0 AOI22H $PINS O=FE_RN_1348_0 A1=B[5] A2=A[5] B1=carry[5] B2=B[5]
XFE_RC_2212_0 ND2P $PINS O=carry[6] I1=FE_RN_1348_0 I2=FE_RN_1347_0
XFE_RC_2040_0 INV1S $PINS O=FE_RN_1219_0 I=FE_RN_1003_0
XFE_RC_2039_0 OR2B1S $PINS O=FE_RN_1220_0 I1=FE_RN_1011_0 B1=FE_RN_1219_0
XFE_RC_2038_0 ND2P $PINS O=carry[10] I1=FE_RN_1016_0 I2=FE_RN_1220_0
XFE_RC_1767_0 INV1S $PINS O=FE_RN_1003_0 I=A[9]
XFE_RC_1766_0 NR2 $PINS O=FE_RN_1004_0 I1=B[9] I2=FE_RN_1003_0
XFE_RC_1765_0 AN2B1S $PINS O=FE_RN_1005_0 I1=B[9] B1=A[9]
XFE_RC_1764_0 INV1S $PINS O=FE_RN_1006_0 I=carry[9]
XFE_RC_1763_0 OAI12HS $PINS O=FE_RN_1007_0 A1=FE_RN_1006_0 B1=FE_RN_1005_0
+ B2=FE_RN_1004_0
XFE_RC_1762_0 ND2 $PINS O=FE_RN_1008_0 I1=A[9] I2=B[9]
XFE_RC_1761_0 ND2S $PINS O=FE_RN_1009_0 I1=FE_RN_1008_0 I2=FE_RN_1015_0
XFE_RC_1760_0 ND2 $PINS O=FE_RN_1010_0 I1=FE_RN_1009_0 I2=carry[9]
XFE_RC_1759_0 ND2P $PINS O=SUM[9] I1=FE_RN_1010_0 I2=FE_RN_1007_0
XFE_RC_1758_0 INV1S $PINS O=FE_RN_1011_0 I=B[9]
XFE_RC_1754_0 ND2 $PINS O=FE_RN_1015_0 I1=FE_RN_1003_0 I2=FE_RN_1011_0
XFE_RC_1753_0 ND2 $PINS O=FE_RN_1016_0 I1=FE_RN_1015_0 I2=carry[9]
XFE_RC_1603_0 INV1S $PINS O=FE_RN_890_0 I=FE_RN_721_0
XFE_RC_1602_0 OR2B1S $PINS O=FE_RN_891_0 I1=FE_RN_729_0 B1=FE_RN_890_0
XFE_RC_1601_0 ND2P $PINS O=carry[11] I1=FE_RN_733_0 I2=FE_RN_891_0
XFE_RC_1393_0 INV1S $PINS O=FE_RN_720_0 I=carry[10]
XFE_RC_1392_0 INV1S $PINS O=FE_RN_721_0 I=A[10]
XFE_RC_1390_0 ND2S $PINS O=FE_RN_723_0 I1=FE_RN_721_0 I2=B[10]
XFE_RC_1389_0 OAI12HS $PINS O=FE_RN_724_0 A1=FE_RN_723_0 B1=FE_RN_721_0
+ B2=B[10]
XFE_RC_1388_0 ND2 $PINS O=FE_RN_725_0 I1=FE_RN_724_0 I2=FE_RN_720_0
XFE_RC_1387_0 ND2S $PINS O=FE_RN_726_0 I1=A[10] I2=B[10]
XFE_RC_1386_0 ND2 $PINS O=FE_RN_727_0 I1=FE_RN_726_0 I2=FE_OCPN1202_FE_RN_732_0
XFE_RC_1385_0 ND2 $PINS O=FE_RN_728_0 I1=FE_RN_727_0 I2=carry[10]
XFE_RC_1384_0 ND2 $PINS O=SUM[10] I1=FE_RN_728_0 I2=FE_RN_725_0
XFE_RC_1383_0 INV1S $PINS O=FE_RN_729_0 I=B[10]
XFE_RC_1380_0 OR2B1S $PINS O=FE_RN_732_0 I1=B[10] B1=FE_RN_721_0
XFE_RC_1379_0 ND2 $PINS O=FE_RN_733_0 I1=carry[10] I2=FE_RN_732_0
XFE_RC_1061_0 INV1S $PINS O=FE_RN_471_0 I=carry[11]
XFE_RC_1060_0 INV1S $PINS O=FE_RN_472_0 I=A[11]
XFE_RC_1058_0 ND2 $PINS O=FE_RN_474_0 I1=FE_RN_472_0 I2=B[11]
XFE_RC_1057_0 OAI12HS $PINS O=FE_RN_475_0 A1=FE_RN_474_0 B1=FE_RN_472_0
+ B2=B[11]
XFE_RC_1056_0 ND2S $PINS O=FE_RN_476_0 I1=FE_RN_475_0 I2=FE_RN_471_0
XFE_RC_1055_0 ND2 $PINS O=FE_RN_477_0 I1=A[11] I2=B[11]
XFE_RC_1054_0 ND2 $PINS O=FE_RN_478_0 I1=FE_RN_477_0 I2=FE_RN_482_0
XFE_RC_1053_0 ND2 $PINS O=FE_RN_479_0 I1=FE_RN_478_0 I2=carry[11]
XFE_RC_1052_0 ND2 $PINS O=SUM[11] I1=FE_RN_479_0 I2=FE_RN_476_0
XFE_RC_1049_0 OR2B1 $PINS O=FE_RN_482_0 I1=B[11] B1=FE_RN_472_0
XFE_RC_1048_0 ND2 $PINS O=FE_RN_483_0 I1=FE_RN_482_0 I2=carry[11]
XFE_RC_1047_0 ND2P $PINS O=carry[12] I1=FE_RN_483_0 I2=FE_RN_477_0
XFE_RC_706_0 INV1S $PINS O=FE_RN_224_0 I=carry[12]
XFE_RC_705_0 INV1S $PINS O=FE_RN_225_0 I=A[12]
XFE_RC_703_0 ND2S $PINS O=FE_RN_227_0 I1=FE_RN_225_0 I2=B[12]
XFE_RC_702_0 OAI12HS $PINS O=FE_RN_228_0 A1=FE_RN_227_0 B1=FE_RN_225_0 B2=B[12]
XFE_RC_701_0 ND2S $PINS O=FE_RN_229_0 I1=FE_RN_228_0 I2=FE_RN_224_0
XFE_RC_700_0 ND2S $PINS O=FE_RN_230_0 I1=A[12] I2=B[12]
XFE_RC_699_0 ND2 $PINS O=FE_RN_231_0 I1=FE_RN_230_0 I2=FE_RN_235_0
XFE_RC_698_0 ND2 $PINS O=FE_RN_232_0 I1=FE_RN_231_0 I2=carry[12]
XFE_RC_697_0 ND2 $PINS O=SUM[12] I1=FE_RN_232_0 I2=FE_RN_229_0
XFE_RC_694_0 OR2B1 $PINS O=FE_RN_235_0 I1=B[12] B1=FE_RN_225_0
XFE_RC_693_0 ND2 $PINS O=FE_RN_236_0 I1=FE_RN_235_0 I2=carry[12]
XFE_RC_692_0 ND2P $PINS O=carry[13] I1=FE_RN_236_0 I2=FE_RN_230_0
XFE_RC_593_0 XOR3 $PINS O=SUM[3] I1=B[3] I2=A[3] I3=carry[3]
XFE_RC_521_0 ND3P $PINS O=carry[9] I1=n20 I2=n19 I3=n18
XFE_RC_458_0 XOR3 $PINS O=SUM[5] I1=B[5] I2=A[5] I3=carry[5]
XFE_RC_368_0 ND3P $PINS O=carry[14] I1=n7 I2=n8 I3=n9
XFE_RC_363_0 XOR3 $PINS O=SUM[6] I1=A[6] I2=B[6] I3=carry[6]
XFE_RC_362_0 MAO222P $PINS O=carry[7] A1=carry[6] B1=B[6] C1=A[6]
XFE_RC_248_0 ND3P $PINS O=carry[8] I1=n16 I2=n15 I3=n14
XFE_RC_247_0 XOR3 $PINS O=SUM[14] I1=A[14] I2=B[14] I3=carry[14]
XU1_15 FA1 $PINS S=SUM[15] CO=carry[16] A=A[15] B=B[15] CI=carry[15]
XU1_2 FA1 $PINS S=SUM[2] CO=carry[3] A=A[2] B=B[2] CI=carry[2]
XU1_21 FA1 $PINS S=SUM[21] CO=carry[22] A=A[21] B=B[21] CI=carry[21]
XU1_25 FA1 $PINS S=SUM[25] CO=carry[26] A=A[25] B=B[25] CI=carry[25]
XU3 ND2 $PINS O=n12 I1=carry[16] I2=A[16]
XU4 XOR2HS $PINS O=SUM[8] I1=n17 I2=carry[8]
XU5 MAO222 $PINS O=n1 A1=A[15] B1=B[15] C1=carry[15]
XU10 ND2 $PINS O=n14 I1=A[7] I2=B[7]
XU11 AN2T $PINS O=n3 I1=B[0] I2=A[0]
XU12 XOR3 $PINS O=SUM[24] I1=B[24] I2=A[24] I3=carry[24]
XU13 ND2 $PINS O=n4 I1=carry[24] I2=B[24]
XU14 ND2 $PINS O=n5 I1=carry[24] I2=A[24]
XU15 ND2 $PINS O=n6 I1=B[24] I2=A[24]
XU17 XOR3 $PINS O=SUM[13] I1=B[13] I2=A[13] I3=carry[13]
XU18 ND2 $PINS O=n7 I1=carry[13] I2=B[13]
XU19 ND2 $PINS O=n8 I1=carry[13] I2=A[13]
XU20 ND2 $PINS O=n9 I1=B[13] I2=A[13]
XU21 XOR2HS $PINS O=n10 I1=B[16] I2=A[16]
XU22 XOR2HS $PINS O=SUM[16] I1=n1 I2=n10
XU23 ND2 $PINS O=n11 I1=n1 I2=B[16]
XU24 ND2 $PINS O=n13 I1=B[16] I2=A[16]
XU25 ND2 $PINS O=n15 I1=carry[7] I2=A[7]
XU26 ND2 $PINS O=n16 I1=carry[7] I2=B[7]
XU28 XOR2HS $PINS O=n17 I1=A[8] I2=B[8]
XU29 ND2 $PINS O=n18 I1=A[8] I2=B[8]
XU31 XOR3S $PINS O=SUM[26] I1=A[26] I2=B[26] I3=carry[26]
XU32 XOR2HS $PINS O=SUM[0] I1=B[0] I2=A[0]
XU1 ND2 $PINS O=n20 I1=carry[8] I2=B[8]
XU6 ND2 $PINS O=n19 I1=carry[8] I2=A[8]
XU9 XOR3 $PINS O=SUM[7] I1=A[7] I2=B[7] I3=carry[7]
.ENDS

.SUBCKT PE_Shift_Add_4_DW01_add_0_DW01_add_20 A[26] A[25] A[24] A[23] A[22]
+ A[21] A[20] A[19] A[18] A[17] A[16] A[15] A[14] A[13] A[12] A[11] A[10] A[9]
+ A[8] A[7] A[6] A[5] A[4] A[3] A[2] A[1] A[0] B[26] B[25] B[24] B[23] B[22]
+ B[21] B[20] B[19] B[18] B[17] B[16] B[15] B[14] B[13] B[12] B[11] B[10] B[9]
+ B[8] B[7] B[6] B[5] B[4] B[3] B[2] B[1] B[0] CI SUM[26] SUM[25] SUM[24]
+ SUM[23] SUM[22] SUM[21] SUM[20] SUM[19] SUM[18] SUM[17] SUM[16] SUM[15]
+ SUM[14] SUM[13] SUM[12] SUM[11] SUM[10] SUM[9] SUM[8] SUM[7] SUM[6] SUM[5]
+ SUM[4] SUM[3] SUM[2] SUM[1] SUM[0] CO
XFE_PHC1753_FE_RN_917_0 BUF1CK $PINS O=FE_PHN1753_FE_RN_917_0 I=FE_RN_917_0
XFE_RC_232_0 XOR3 $PINS O=SUM[2] I1=A[2] I2=B[2] I3=carry[2]
XFE_RC_231_0 MAO222 $PINS O=carry[3] A1=A[2] B1=B[2] C1=carry[2]
XFE_RC_152_0 ND3HT $PINS O=carry[24] I1=FE_RN_51_0 I2=FE_RN_52_0 I3=FE_RN_50_0
XFE_RC_107_0 XOR3 $PINS O=SUM[3] I1=A[3] I2=B[3] I3=carry[3]
XFE_RC_106_0 MAO222 $PINS O=carry[4] A1=A[3] B1=B[3] C1=carry[3]
XFE_RC_101_0 ND2 $PINS O=FE_RN_54_0 I1=B[22] I2=A[22]
XFE_RC_100_0 ND2P $PINS O=FE_RN_55_0 I1=carry[22] I2=A[22]
XFE_RC_99_0 ND2P $PINS O=FE_RN_56_0 I1=carry[22] I2=B[22]
XFE_RC_98_0 ND3HT $PINS O=carry[23] I1=FE_RN_56_0 I2=FE_RN_55_0 I3=FE_RN_54_0
XFE_RC_95_0 ND3HT $PINS O=carry[17] I1=n19 I2=n20 I3=n18
XFE_RC_92_0 ND2 $PINS O=FE_RN_50_0 I1=A[23] I2=B[23]
XFE_RC_91_0 ND2P $PINS O=FE_RN_51_0 I1=carry[23] I2=A[23]
XFE_RC_90_0 ND2P $PINS O=FE_RN_52_0 I1=carry[23] I2=B[23]
XFE_RC_87_0 AOI22H $PINS O=FE_RN_846_0 A1=B[7] A2=A[7] B1=carry[7] B2=A[7]
XFE_OCPC1233_carry_13 BUF1S $PINS O=FE_OCPN1233_carry_13 I=carry[13]
XFE_OCPC1216_N194 BUF1S $PINS O=FE_OCPN1216_N194 I=A[16]
XFE_OCPC1212_n15 BUF1S $PINS O=FE_OCPN1212_n15 I=n15
XFE_OCPC1191_N196 BUF1S $PINS O=FE_OCPN1191_N196 I=A[18]
XFE_OCPC1189_N184 BUF1S $PINS O=FE_OCPN1189_N184 I=A[6]
XFE_OCPC1174_carry_4 BUF1S $PINS O=FE_OCPN1174_carry_4 I=carry[4]
XFE_OCPC1169_carry_9 BUF1S $PINS O=FE_OCPN1169_carry_9 I=carry[9]
XFE_OCPC1136_N206 BUF1CK $PINS O=FE_OCPN1136_N206 I=B[1]
XFE_OCPC1106_FE_RN_1 BUF1S $PINS O=FE_OCPN1106_FE_RN_1 I=FE_RN_1
XFE_OCPC1103_carry_23 BUF1S $PINS O=FE_OCPN1103_carry_23 I=carry[23]
XFE_OCPC1072_carry_10 BUF1S $PINS O=FE_OCPN1072_carry_10 I=carry[10]
XFE_OCPC1071_carry_12 BUF1S $PINS O=FE_OCPN1071_carry_12 I=carry[12]
XFE_OCPC1000_carry_11 BUF1S $PINS O=FE_OCPN1000_carry_11 I=carry[11]
XFE_OCPC960_carry_7 BUF1S $PINS O=FE_OCPN960_carry_7 I=carry[7]
XFE_OCPC928_carry_25 BUF1 $PINS O=FE_OCPN928_carry_25 I=carry[25]
XFE_RC_3922_0 ND2 $PINS O=FE_RN_2558_0 I1=B[24] I2=A[24]
XFE_RC_3921_0 ND2P $PINS O=FE_RN_2559_0 I1=carry[24] I2=A[24]
XFE_RC_3920_0 ND2P $PINS O=FE_RN_2560_0 I1=carry[24] I2=B[24]
XFE_RC_3919_0 ND3P $PINS O=carry[25] I1=FE_RN_2560_0 I2=FE_RN_2559_0
+ I3=FE_RN_2558_0
XFE_RC_3914_0 XOR3 $PINS O=SUM[4] I1=A[4] I2=B[4] I3=FE_OCPN1174_carry_4
XFE_RC_3913_0 MAO222 $PINS O=carry[5] A1=A[4] B1=B[4] C1=carry[4]
XFE_OCPC439_carry_24 BUF1S $PINS O=FE_OCPN439_carry_24 I=carry[24]
XFE_OCPC285_carry_19 BUF1S $PINS O=FE_OCPN285_carry_19 I=carry[19]
XFE_OCPC273_carry_20 BUF1S $PINS O=FE_OCPN273_carry_20 I=carry[20]
XFE_OCPC266_carry_17 BUF1S $PINS O=FE_OCPN266_carry_17 I=carry[17]
XFE_OCPC238_carry_21 BUF1S $PINS O=FE_OCPN238_carry_21 I=carry[21]
XFE_OCPC229_carry_22 BUF1S $PINS O=FE_OCPN229_carry_22 I=carry[22]
XFE_OCPC873_carry_6 BUF1 $PINS O=FE_OCPN477_carry_6 I=carry[6]
XFE_RC_3268_0 ND3P $PINS O=carry[12] I1=n9 I2=n8 I3=n7
XFE_RC_3083_0 ND3HT $PINS O=carry[19] I1=n21 I2=n22 I3=n23
XFE_RC_1539_0_dup ND2P $PINS O=FE_RN_1 I1=FE_RN_846_0 I2=FE_RN_845_0
XFE_RC_2434_0 ND2 $PINS O=FE_RN_1513_0 I1=n15 I2=B[15]
XFE_RC_2433_0 AOI22H $PINS O=FE_RN_1514_0 A1=A[15] A2=B[15] B1=n15 B2=A[15]
XFE_RC_2432_0 ND2P $PINS O=n17 I1=FE_RN_1514_0 I2=FE_RN_1513_0
XFE_RC_2302_0 INV1S $PINS O=FE_RN_1404_0 I=n2
XFE_RC_2300_0 ND2 $PINS O=FE_RN_1406_0 I1=FE_RN_1404_0 I2=B[1]
XFE_RC_2299_0 OAI12HS $PINS O=FE_RN_1407_0 A1=FE_RN_1406_0 B1=FE_RN_1404_0
+ B2=FE_OCPN1136_N206
XFE_RC_2298_0 OR2B1S $PINS O=FE_RN_1408_0 I1=A[1] B1=FE_RN_1407_0
XFE_RC_2297_0 ND2 $PINS O=FE_RN_1409_0 I1=n2 I2=FE_OCPN1136_N206
XFE_RC_2296_0 ND2 $PINS O=FE_RN_1410_0 I1=FE_RN_1409_0 I2=FE_RN_1415_0
XFE_RC_2295_0 ND2 $PINS O=FE_RN_1411_0 I1=FE_RN_1410_0 I2=A[1]
XFE_RC_2294_0 ND2 $PINS O=SUM[1] I1=FE_RN_1411_0 I2=FE_RN_1408_0
XFE_RC_2292_0 INV1S $PINS O=FE_RN_1413_0 I=B[1]
XFE_RC_2290_0 ND2 $PINS O=FE_RN_1415_0 I1=FE_RN_1404_0 I2=FE_RN_1413_0
XFE_RC_2289_0 ND2 $PINS O=FE_RN_1416_0 I1=FE_RN_1415_0 I2=A[1]
XFE_RC_2288_0 ND2 $PINS O=carry[2] I1=FE_RN_1416_0 I2=FE_RN_1409_0
XFE_RC_1866_0 ND2 $PINS O=FE_RN_1091_0 I1=FE_RN_1 I2=B[8]
XFE_RC_1865_0 AOI22HP $PINS O=FE_RN_1092_0 A1=A[8] A2=B[8] B1=FE_RN_1 B2=A[8]
XFE_RC_1864_0 ND2P $PINS O=carry[9] I1=FE_RN_1092_0 I2=FE_RN_1091_0
XFE_RC_1863_0 ND2 $PINS O=FE_RN_1089_0 I1=carry[15] I2=B[15]
XFE_RC_1862_0 AOI22H $PINS O=FE_RN_1090_0 A1=A[15] A2=B[15] B1=carry[15]
+ B2=A[15]
XFE_RC_1861_0 ND2P $PINS O=n16 I1=FE_RN_1090_0 I2=FE_RN_1089_0
XFE_RC_1851_0 ND2 $PINS O=FE_RN_1081_0 I1=carry[25] I2=B[25]
XFE_RC_1850_0 AOI22H $PINS O=FE_RN_1082_0 A1=B[25] A2=A[25] B1=carry[25]
+ B2=A[25]
XFE_RC_1849_0 ND2P $PINS O=carry[26] I1=FE_RN_1082_0 I2=FE_RN_1081_0
XFE_RC_1641_0 INV1S $PINS O=FE_RN_908_0 I=B[6]
XFE_RC_1640_0 OR2 $PINS O=FE_RN_909_0 I1=A[6] I2=FE_RN_908_0
XFE_RC_1639_0 INV1S $PINS O=FE_RN_910_0 I=FE_OCPN477_carry_6
XFE_RC_1636_0 ND2 $PINS O=FE_RN_913_0 I1=FE_RN_908_0 I2=FE_OCPN477_carry_6
XFE_RC_1635_0 OAI12HS $PINS O=FE_RN_914_0 A1=FE_RN_913_0 B1=FE_RN_908_0
+ B2=FE_OCPN477_carry_6
XFE_RC_1634_0 INV1S $PINS O=FE_RN_915_0 I=FE_OCPN1189_N184
XFE_RC_1633_0 OAI222S $PINS O=SUM[6] A1=FE_RN_915_0 A2=FE_RN_914_0
+ B1=FE_PHN1753_FE_RN_917_0 B2=FE_RN_910_0 C1=FE_OCPN477_carry_6 C2=FE_RN_909_0
XFE_RC_1632_0 ND2 $PINS O=FE_RN_916_0 I1=B[6] I2=A[6]
XFE_RC_1631_0 OR2T $PINS O=FE_RN_917_0 I1=A[6] I2=B[6]
XFE_RC_1630_0 ND2P $PINS O=FE_RN_918_0 I1=FE_RN_917_0 I2=carry[6]
XFE_RC_1629_0 ND2P $PINS O=carry[7] I1=FE_RN_918_0 I2=FE_RN_916_0
XFE_RC_1541_0 ND2 $PINS O=FE_RN_845_0 I1=carry[7] I2=B[7]
XFE_RC_1362_0 INV1S $PINS O=FE_RN_700_0 I=carry[5]
XFE_RC_1361_0 INV1S $PINS O=FE_RN_701_0 I=B[5]
XFE_RC_1360_0 ND2S $PINS O=FE_RN_702_0 I1=A[5] I2=FE_RN_701_0
XFE_RC_1358_0 MXL2HS $PINS OB=FE_RN_704_0 S=A[5] A=FE_RN_700_0 B=carry[5]
XFE_RC_1356_0 OAI222S $PINS O=SUM[5] A1=FE_RN_701_0 A2=FE_RN_704_0
+ B1=FE_RN_702_0 B2=carry[5] C1=FE_RN_700_0 C2=FE_RN_707_0
XFE_RC_1355_0 ND2 $PINS O=FE_RN_706_0 I1=A[5] I2=B[5]
XFE_RC_1354_0 OR2T $PINS O=FE_RN_707_0 I1=B[5] I2=A[5]
XFE_RC_1353_0 ND2P $PINS O=FE_RN_708_0 I1=carry[5] I2=FE_RN_707_0
XFE_RC_1352_0 ND2P $PINS O=carry[6] I1=FE_RN_708_0 I2=FE_RN_706_0
XFE_RC_1318_0 ND3HT $PINS O=carry[14] I1=FE_RN_543_0 I2=FE_RN_544_0
+ I3=FE_RN_542_0
XFE_RC_1150_0 ND2P $PINS O=FE_RN_542_0 I1=A[13] I2=B[13]
XFE_RC_1149_0 ND2P $PINS O=FE_RN_543_0 I1=carry[13] I2=A[13]
XFE_RC_1148_0 ND2T $PINS O=FE_RN_544_0 I1=carry[13] I2=B[13]
XFE_RC_1115_0 XOR3 $PINS O=SUM[7] I1=A[7] I2=B[7] I3=FE_OCPN960_carry_7
XFE_RC_1013_0 XOR3 $PINS O=SUM[8] I1=A[8] I2=B[8] I3=FE_OCPN1106_FE_RN_1
XFE_RC_866_0 ND2 $PINS O=FE_RN_331_0 I1=carry[19] I2=B[19]
XFE_RC_865_0 AOI22H $PINS O=FE_RN_332_0 A1=B[19] A2=A[19] B1=carry[19] B2=A[19]
XFE_RC_864_0 ND2P $PINS O=carry[20] I1=FE_RN_332_0 I2=FE_RN_331_0
XFE_RC_853_0 ND2 $PINS O=FE_RN_321_0 I1=carry[21] I2=B[21]
XFE_RC_852_0 AOI22H $PINS O=FE_RN_322_0 A1=B[21] A2=A[21] B1=carry[21] B2=A[21]
XFE_RC_851_0 ND2P $PINS O=carry[22] I1=FE_RN_322_0 I2=FE_RN_321_0
XFE_RC_765_0 ND3P $PINS O=carry[21] I1=FE_RN_182_0 I2=FE_RN_180_0
+ I3=FE_RN_181_0
XFE_RC_611_0 ND2 $PINS O=FE_RN_180_0 I1=carry[20] I2=A[20]
XFE_RC_610_0 ND2 $PINS O=FE_RN_181_0 I1=B[20] I2=A[20]
XFE_RC_609_0 ND2 $PINS O=FE_RN_182_0 I1=B[20] I2=carry[20]
XFE_RC_574_0 XOR3 $PINS O=SUM[12] I1=A[12] I2=B[12] I3=FE_OCPN1071_carry_12
XFE_RC_573_0 MAO222P $PINS O=carry[13] A1=carry[12] B1=B[12] C1=A[12]
XFE_RC_430_0 XOR3 $PINS O=SUM[19] I1=A[19] I2=B[19] I3=FE_OCPN285_carry_19
XFE_RC_344_0 XOR3 $PINS O=SUM[20] I1=A[20] I2=B[20] I3=FE_OCPN273_carry_20
XFE_RC_237_0 XOR3 $PINS O=SUM[24] I1=A[24] I2=B[24] I3=FE_OCPN439_carry_24
XFE_RC_209_0 XOR3 $PINS O=SUM[21] I1=A[21] I2=B[21] I3=FE_OCPN238_carry_21
XFE_RC_177_0 XOR3 $PINS O=SUM[25] I1=A[25] I2=B[25] I3=FE_OCPN928_carry_25
XFE_RC_112_0 XOR3 $PINS O=SUM[22] I1=A[22] I2=B[22] I3=FE_OCPN229_carry_22
XFE_RC_78_0 XOR3 $PINS O=SUM[23] I1=A[23] I2=B[23] I3=FE_OCPN1103_carry_23
XFE_RC_48_0 XOR3 $PINS O=SUM[13] I1=A[13] I2=B[13] I3=FE_OCPN1233_carry_13
XU1_26 XOR3 $PINS O=SUM[26] I1=A[26] I2=B[26] I3=carry[26]
XU1_14 FA1 $PINS S=SUM[14] CO=carry[15] A=A[14] B=B[14] CI=carry[14]
XU1_15 FA1S $PINS S=SUM[15] CO=carry[16] A=A[15] B=B[15] CI=FE_OCPN1212_n15
XU1_17 FA1S $PINS S=SUM[17] CO=carry[18] A=A[17] B=B[17] CI=FE_OCPN266_carry_17
XU4 ND2P $PINS O=n22 I1=n13 I2=B[18]
XU5 ND3P $PINS O=carry[11] I1=n5 I2=n4 I3=n3
XU6 ND2 $PINS O=n3 I1=A[10] I2=B[10]
XU7 XOR3 $PINS O=SUM[16] I1=FE_OCPN1216_N194 I2=B[16] I3=carry[16]
XU8 XOR3 $PINS O=SUM[18] I1=FE_OCPN1191_N196 I2=B[18] I3=carry[18]
XU10 AN2 $PINS O=n2 I1=B[0] I2=A[0]
XU11 ND2 $PINS O=n12 I1=A[9] I2=B[9]
XU12 ND2 $PINS O=n4 I1=carry[10] I2=A[10]
XU13 ND2 $PINS O=n5 I1=B[10] I2=carry[10]
XU14 XOR2HS $PINS O=n6 I1=A[11] I2=B[11]
XU15 XOR2HS $PINS O=SUM[11] I1=n6 I2=FE_OCPN1000_carry_11
XU16 ND2 $PINS O=n7 I1=A[11] I2=B[11]
XU17 ND2 $PINS O=n8 I1=A[11] I2=carry[11]
XU18 ND2 $PINS O=n9 I1=B[11] I2=carry[11]
XU19 XOR3 $PINS O=SUM[9] I1=A[9] I2=B[9] I3=FE_OCPN1169_carry_9
XU20 ND2 $PINS O=n10 I1=carry[9] I2=A[9]
XU21 ND2 $PINS O=n11 I1=carry[9] I2=B[9]
XU22 ND3P $PINS O=carry[10] I1=n10 I2=n11 I3=n12
XU24 ND2P $PINS O=n19 I1=n16 I2=B[16]
XU25 MAO222 $PINS O=n13 A1=A[17] B1=B[17] C1=carry[17]
XU26 MAO222 $PINS O=n14 A1=A[17] B1=B[17] C1=carry[17]
XU28 MAO222 $PINS O=n15 A1=A[14] B1=B[14] C1=carry[14]
XU31 ND2 $PINS O=n20 I1=A[16] I2=B[16]
XU32 ND2P $PINS O=n21 I1=n14 I2=A[18]
XU33 ND2 $PINS O=n23 I1=A[18] I2=B[18]
XU34 XOR2HS $PINS O=SUM[0] I1=B[0] I2=A[0]
XU3 XOR3 $PINS O=SUM[10] I1=A[10] I2=B[10] I3=FE_OCPN1072_carry_10
XU27 ND2P $PINS O=n18 I1=n17 I2=A[16]
.ENDS

.SUBCKT PE_Shift_Add_4 rst_n en clear calc_done stage_sel x_in[16] x_in[15]
+ x_in[14] x_in[13] x_in[12] x_in[11] x_in[10] x_in[9] x_in[8] x_in[7] x_in[6]
+ x_in[5] x_in[4] x_in[3] x_in[2] x_in[1] x_in[0] sign1[1] sign1[0] sign2[1]
+ sign2[0] sign3[1] sign3[0] shf1[3] shf1[2] shf1[1] shf1[0] shf2[3] shf2[2]
+ shf2[1] shf2[0] shf3[3] shf3[2] shf3[1] shf3[0] y_out[16] y_out[15] y_out[14]
+ y_out[13] y_out[12] y_out[11] y_out[10] y_out[9] y_out[8] y_out[7] y_out[6]
+ y_out[5] y_out[4] y_out[3] y_out[2] y_out[1] y_out[0] i_rst_n
+ FE_OFN40_i_rst_n FE_OFN37_i_rst_n FE_OFN35_i_rst_n FE_OFN61_FE_DBTN9_n336
+ FE_OFN81_s11_1 FE_OFN82_s11_0 FE_OFN84_h11_3 FE_OFN85_h11_2 FE_OFN86_h11_1
+ FE_OFN87_h11_0 FE_OFN88_s12_1 FE_OFN89_s12_0 FE_OFN90_h12_3 FE_OFN91_h12_2
+ FE_OFN92_h12_1 FE_OFN93_h12_0 FE_OFN94_s13_1 FE_OFN95_s13_0 FE_OFN96_h13_3
+ FE_OFN97_h13_2 FE_OFN98_h13_1 FE_OFN99_h13_0 FE_OFN140_s11_0 FE_OFN139_s11_0
+ FE_OFN151_s13_0 FE_OFN157_s12_0 FE_OFN155_s12_0 clk_clone1 clk
XFE_PHC2202_pe_i1_16 BUF1CK $PINS O=y_out[16] I=FE_PHN2202_pe_i1_16
XFE_PHC1860_N250 DELC $PINS O=N250 I=FE_PHN1860_N250
XFE_PHC1859_N249 DELC $PINS O=FE_PHN1859_N249 I=N249
XFE_PHC1858_N245 DELC $PINS O=FE_PHN1858_N245 I=N245
XFE_PHC1855_N248 DELC $PINS O=FE_PHN1855_N248 I=N248
XFE_PHC1852_N241 DELC $PINS O=N241 I=FE_PHN1852_N241
XFE_PHC1842_N243 DELC $PINS O=FE_PHN1842_N243 I=N243
XFE_PHC1780_acc_reg_22 DELC $PINS O=acc_reg[22] I=FE_PHN1780_acc_reg_22
XFE_PHC1690_pe_i1_5 DELC $PINS O=y_out[5] I=FE_PHN1690_pe_i1_5
XFE_PHC1689_pe_i1_3 DELC $PINS O=y_out[3] I=FE_PHN1689_pe_i1_3
XFE_PHC1684_pe_i1_4 DELC $PINS O=y_out[4] I=FE_PHN1684_pe_i1_4
XFE_PHC1654_pe_i1_8 DELC $PINS O=y_out[8] I=FE_PHN1654_pe_i1_8
XFE_PHC1651_pe_i1_6 DELC $PINS O=y_out[6] I=FE_PHN1651_pe_i1_6
XFE_PHC1641_pe_i1_2 DELC $PINS O=y_out[2] I=FE_PHN1641_pe_i1_2
XFE_PHC1636_pe_i1_1 DELC $PINS O=y_out[1] I=FE_PHN1636_pe_i1_1
XFE_PHC1622_pe_i1_0 DELC $PINS O=y_out[0] I=FE_PHN1622_pe_i1_0
XFE_PHC1571_next_acc_0 DELB $PINS O=FE_PHN1571_next_acc_0 I=next_acc[0]
XFE_PHC1441_N237 DELC $PINS O=N237 I=FE_PHN1441_N237
XFE_PHC1437_N244 DELC $PINS O=FE_PHN1437_N244 I=N244
XFE_PHC1436_N240 DELC $PINS O=N240 I=FE_PHN1436_N240
XFE_PHC1435_N242 DELC $PINS O=FE_PHN1435_N242 I=N242
XFE_PHC1434_N238 DELC $PINS O=N238 I=FE_PHN1434_N238
XFE_PHC1433_N239 DELC $PINS O=FE_PHN1433_N239 I=N239
XFE_PHC1431_N246 DELC $PINS O=FE_PHN1431_N246 I=N246
XFE_PHC1427_N236 DELC $PINS O=FE_PHN1427_N236 I=N236
XFE_PHC1423_N235 DELC $PINS O=N235 I=FE_PHN1423_N235
XFE_PHC1366_N251 DELC $PINS O=FE_PHN1366_N251 I=N251
XFE_PHC1283_acc_reg_20 DELC $PINS O=FE_PHN1283_acc_reg_20 I=acc_reg[20]
XFE_RC_166_0 MOAI1H $PINS O=sll_16/ML_int[1][4] A1=FE_RN_2595_0
+ A2=FE_OFN87_h11_0 B1=term1_in[3] B2=FE_OFN87_h11_0
XFE_RC_110_0 ND2S $PINS O=FE_RN_58_0 I1=term3_shifted[20] I2=n26
XFE_RC_109_0 ND2 $PINS O=FE_RN_59_0 I1=N144 I2=FE_OFN377_s13_0
XFE_RC_108_0 ND2 $PINS O=N171 I1=FE_RN_59_0 I2=FE_RN_58_0
XFE_RC_41_0 INV1S $PINS O=FE_RN_21_0 I=FE_OFN92_h12_1
XFE_RC_39_0 INV1S $PINS O=FE_RN_23_0 I=FE_OFN92_h12_1
XFE_RC_38_0 ND2 $PINS O=FE_RN_24_0 I1=sll_17/ML_int[1][2] I2=FE_RN_23_0
XFE_RC_37_0 OAI12HS $PINS O=sll_17/ML_int[2][2] A1=FE_RN_24_0 B1=n13
+ B2=FE_RN_21_0
XFE_RC_16_1 ND2 $PINS O=FE_RN_10_0 I1=term1_shifted[8] I2=FE_OFN139_s11_0
XFE_RC_15_0 ND2 $PINS O=FE_RN_11_0 I1=N22 I2=FE_OFN82_s11_0
XFE_RC_14_0 ND2P $PINS O=N49 I1=FE_RN_11_0 I2=FE_RN_10_0
XCTS_ccl_a_INV_CLK_G1_L10_54 INV3CK $PINS O=CTS_10 I=CTS_11
XCTS_ccl_a_INV_CLK_G1_L9_56 INV2CK $PINS O=CTS_11 I=CTS_12
XFE_OCPC1192_term1_shifted_2 BUF1S $PINS O=FE_OCPN1192_term1_shifted_2
+ I=term1_shifted[2]
XFE_OCPC1186_sll_17_ML_int_1_1 BUF1S $PINS O=FE_OCPN1186_sll_17_ML_int_1_1
+ I=sll_17/ML_int[1][1]
XFE_OCPC1141_N186 BUF3 $PINS O=FE_OCPN1141_N186 I=N186
XFE_OCPC1021_sll_16_ML_int_1_4 BUF1S $PINS O=FE_OCPN1021_sll_16_ML_int_1_4
+ I=sll_16/ML_int[1][4]
XFE_RC_4013_0 AO22P $PINS O=N46 A1=term1_shifted[5] A2=FE_OFN139_s11_0 B1=N19
+ B2=FE_OFN140_s11_0
XFE_RC_4006_0 INV2 $PINS O=FE_RN_2595_0 I=term1_in[4]
XFE_RC_3879_0 ND2 $PINS O=FE_RN_2540_0 I1=term1_shifted[20] I2=FE_OFN425_n
XFE_RC_3878_0 ND2 $PINS O=FE_RN_2541_0 I1=N34 I2=sign1[0]
XFE_RC_3877_0 ND2P $PINS O=N61 I1=FE_RN_2541_0 I2=FE_RN_2540_0
XFE_RC_3872_0 ND2 $PINS O=FE_RN_2538_0 I1=N124 I2=sign3[0]
XFE_RC_3871_0 ND2 $PINS O=FE_RN_2539_0 I1=N124 I2=FE_OFN380_s13_0
XFE_RC_3870_0 ND2 $PINS O=N151 I1=FE_RN_2539_0 I2=FE_RN_2538_0
XFE_RC_3759_0 ND2 $PINS O=FE_RN_2468_0 I1=sll_18/ML_int[1][1] I2=FE_OFN98_h13_1
XFE_RC_3758_0 INV1S $PINS O=FE_RN_2469_0 I=FE_OFN98_h13_1
XFE_RC_3757_0 ND2 $PINS O=FE_RN_2470_0 I1=sll_18/ML_int[1][3] I2=FE_RN_2469_0
XFE_RC_3756_0 ND2P $PINS O=sll_18/ML_int[2][3] I1=FE_RN_2470_0 I2=FE_RN_2468_0
XFE_RC_3726_0 ND2 $PINS O=FE_RN_2445_0 I1=sll_18/ML_int[1][2] I2=FE_OFN98_h13_1
XFE_RC_3725_0 INV1S $PINS O=FE_RN_2446_0 I=FE_OFN98_h13_1
XFE_RC_3724_0 ND2S $PINS O=FE_RN_2447_0 I1=sll_18/ML_int[1][4] I2=FE_RN_2446_0
XFE_RC_3723_0 ND2 $PINS O=sll_18/ML_int[2][4] I1=FE_RN_2447_0 I2=FE_RN_2445_0
XFE_RC_3662_0 INV1S $PINS O=FE_RN_2397_0 I=shf2[2]
XFE_RC_3661_0 INV1S $PINS O=FE_RN_2398_0 I=n70
XFE_RC_3660_0 INV1S $PINS O=FE_RN_2399_0 I=shf2[2]
XFE_RC_3659_0 ND2 $PINS O=FE_RN_2400_0 I1=sll_17/ML_int[2][4] I2=FE_RN_2399_0
XFE_RC_3658_0 OAI12H $PINS O=sll_17/ML_int[3][4] A1=FE_RN_2400_0
+ B1=FE_RN_2398_0 B2=FE_RN_2397_0
XFE_RC_3513_0 INV1S $PINS O=FE_RN_2293_0 I=FE_OFN99_h13_0
XFE_RC_3512_0 ND2 $PINS O=FE_RN_2294_0 I1=term3_in[2] I2=FE_RN_2293_0
XFE_RC_3511_0 ND2S $PINS O=FE_RN_2295_0 I1=term3_in[1] I2=FE_OFN99_h13_0
XFE_RC_3510_0 ND2 $PINS O=sll_18/ML_int[1][2] I1=FE_RN_2295_0 I2=FE_RN_2294_0
XFE_RC_3415_0 ND2 $PINS O=FE_RN_2222_0 I1=term1_in[2] I2=FE_OFN87_h11_0
XFE_RC_3414_0 INV1S $PINS O=FE_RN_2223_0 I=FE_OFN87_h11_0
XFE_RC_3413_0 ND2S $PINS O=FE_RN_2224_0 I1=term1_in[3] I2=FE_RN_2223_0
XFE_RC_3412_0 ND2 $PINS O=sll_16/ML_int[1][3] I1=FE_RN_2224_0 I2=FE_RN_2222_0
XFE_RC_3203_0 ND2S $PINS O=FE_RN_2064_0 I1=term2_in[1] I2=FE_OFN93_h12_0
XFE_RC_3202_0 INV1S $PINS O=FE_RN_2065_0 I=FE_OFN93_h12_0
XFE_RC_3201_0 ND2 $PINS O=FE_RN_2066_0 I1=term2_in[2] I2=FE_RN_2065_0
XFE_RC_3200_0 ND2 $PINS O=sll_17/ML_int[1][2] I1=FE_RN_2066_0 I2=FE_RN_2064_0
XFE_RC_3095_0 ND2 $PINS O=FE_RN_1991_0 I1=term2_shifted[4] I2=FE_OFN157_s12_0
XFE_RC_3094_0 ND2 $PINS O=FE_RN_1992_0 I1=N73 I2=FE_OFN155_s12_0
XFE_RC_3093_0 ND2 $PINS O=N100 I1=FE_RN_1992_0 I2=FE_RN_1991_0
XFE_RC_3067_0 MOAI1H $PINS O=N96 A1=N69 A2=FE_OFN448_n B1=term2_shifted[0]
+ B2=FE_OFN448_n
XFE_RC_2958_0 ND2 $PINS O=FE_RN_1897_0 I1=sll_18/ML_int[1][0] I2=FE_OFN98_h13_1
XFE_RC_2957_0 INV1S $PINS O=FE_RN_1898_0 I=FE_OFN98_h13_1
XFE_RC_2956_0 ND2 $PINS O=FE_RN_1899_0 I1=sll_18/ML_int[1][2] I2=FE_RN_1898_0
XFE_RC_2955_0 ND2 $PINS O=sll_18/ML_int[2][2] I1=FE_RN_1899_0 I2=FE_RN_1897_0
XFE_RC_2894_0 ND2 $PINS O=FE_RN_1848_0 I1=term1_shifted[6] I2=FE_OFN139_s11_0
XFE_RC_2893_0 ND2 $PINS O=FE_RN_1849_0 I1=N20 I2=FE_OFN82_s11_0
XFE_RC_2892_0 ND2P $PINS O=N47 I1=FE_RN_1849_0 I2=FE_RN_1848_0
XFE_RC_2794_0 ND2S $PINS O=FE_RN_1777_0 I1=term1_in[0] I2=FE_OFN87_h11_0
XFE_RC_2793_0 INV1S $PINS O=FE_RN_1778_0 I=FE_OFN87_h11_0
XFE_RC_2792_0 ND2S $PINS O=FE_RN_1779_0 I1=term1_in[1] I2=FE_RN_1778_0
XFE_RC_2791_0 ND2 $PINS O=sll_16/ML_int[1][1] I1=FE_RN_1779_0 I2=FE_RN_1777_0
XFE_RC_2790_0 INV1S $PINS O=FE_RN_1775_0 I=n67
XFE_RC_2789_0 INV2 $PINS O=n107 I=FE_RN_1776_0
XFE_RC_2788_0 ND3P $PINS O=FE_RN_1776_0 I1=sll_17/ML_int[1][1] I2=FE_RN_1775_0
+ I3=shf2[1]
XFE_RC_2771_0 ND2 $PINS O=FE_RN_1761_0 I1=term3_in[3] I2=FE_OFN99_h13_0
XFE_RC_2770_0 INV1S $PINS O=FE_RN_1762_0 I=FE_OFN99_h13_0
XFE_RC_2769_0 ND2S $PINS O=FE_RN_1763_0 I1=term3_in[4] I2=FE_RN_1762_0
XFE_RC_2768_0 ND2 $PINS O=sll_18/ML_int[1][4] I1=FE_RN_1763_0 I2=FE_RN_1761_0
XFE_RC_2767_0 ND2 $PINS O=FE_RN_1759_0 I1=term1_shifted[3] I2=FE_OFN139_s11_0
XFE_RC_2766_0 ND2 $PINS O=FE_RN_1760_0 I1=N17 I2=FE_OFN140_s11_0
XFE_RC_2765_0 ND2P $PINS O=N44 I1=FE_RN_1760_0 I2=FE_RN_1759_0
XFE_RC_2758_0 ND2 $PINS O=FE_RN_1752_0 I1=sll_17/ML_int[1][2] I2=FE_OFN92_h12_1
XFE_RC_2757_0 INV1S $PINS O=FE_RN_1753_0 I=FE_OFN92_h12_1
XFE_RC_2756_0 ND2S $PINS O=FE_RN_1754_0 I1=sll_17/ML_int[1][4] I2=FE_RN_1753_0
XFE_RC_2755_0 ND2 $PINS O=sll_17/ML_int[2][4] I1=FE_RN_1754_0 I2=FE_RN_1752_0
XFE_RC_2750_0 INV1S $PINS O=FE_RN_1749_0 I=FE_OFN87_h11_0
XFE_RC_2749_0 INV2 $PINS O=sll_16/ML_int[1][2] I=FE_RN_1750_0
XFE_RC_2748_0 AOI22H $PINS O=FE_RN_1750_0 A1=term1_in[1] A2=FE_OFN87_h11_0
+ B1=term1_in[2] B2=FE_RN_1749_0
XFE_RC_2675_0 ND2 $PINS O=FE_RN_1689_0 I1=term3_shifted[3] I2=sign3[0]
XFE_RC_2674_0 ND2 $PINS O=FE_RN_1690_0 I1=N127 I2=FE_OFN380_s13_0
XFE_RC_2673_0 ND2 $PINS O=N154 I1=FE_RN_1690_0 I2=FE_RN_1689_0
XFE_RC_2672_0 ND2S $PINS O=FE_RN_1686_0 I1=n60 I2=FE_OFN85_h11_2
XFE_RC_2671_0 INV2 $PINS O=FE_RN_1687_0 I=FE_OFN85_h11_2
XFE_RC_2670_0 ND2 $PINS O=FE_RN_1688_0 I1=sll_16/ML_int[2][4] I2=FE_RN_1687_0
XFE_RC_2669_0 ND2 $PINS O=sll_16/ML_int[3][4] I1=FE_RN_1688_0 I2=FE_RN_1686_0
XFE_RC_2667_0 INV2 $PINS O=N99 I=FE_RN_1685_0
XFE_RC_2666_0 AOI22S $PINS O=FE_RN_1685_0 A1=term2_shifted[3] A2=FE_OFN448_n
+ B1=N72 B2=FE_OFN155_s12_0
XFE_RC_2616_0 ND2 $PINS O=FE_RN_1650_0 I1=term3_shifted[1] I2=sign3[0]
XFE_RC_2615_0 ND2P $PINS O=FE_RN_1651_0 I1=N125 I2=FE_OFN380_s13_0
XFE_RC_2614_0 ND2P $PINS O=N152 I1=FE_RN_1651_0 I2=FE_RN_1650_0
XFE_RC_2613_0 ND2S $PINS O=FE_RN_1647_0 I1=term3_in[0] I2=FE_OFN99_h13_0
XFE_RC_2612_0 INV1S $PINS O=FE_RN_1648_0 I=FE_OFN99_h13_0
XFE_RC_2611_0 ND2 $PINS O=FE_RN_1649_0 I1=term3_in[1] I2=FE_RN_1648_0
XFE_RC_2610_0 ND2 $PINS O=sll_18/ML_int[1][1] I1=FE_RN_1649_0 I2=FE_RN_1647_0
XFE_RC_2609_0 INV1S $PINS O=FE_RN_1645_0 I=FE_OFN86_h11_1
XFE_RC_2608_0 INV2 $PINS O=sll_16/ML_int[2][4] I=FE_RN_1646_0
XFE_RC_2607_0 AOI22H $PINS O=FE_RN_1646_0 A1=sll_16/ML_int[1][2]
+ A2=FE_OFN86_h11_1 B1=sll_16/ML_int[1][4] B2=FE_RN_1645_0
XFE_RC_2568_0 ND2 $PINS O=FE_RN_1613_0 I1=term1_shifted[1] I2=FE_OFN139_s11_0
XFE_RC_2567_0 ND2P $PINS O=FE_RN_1614_0 I1=N15 I2=FE_OFN140_s11_0
XFE_RC_2566_0 ND2P $PINS O=N42 I1=FE_RN_1614_0 I2=FE_RN_1613_0
XFE_RC_2428_0 INV1S $PINS O=FE_RN_1507_0 I=FE_OFN155_s12_0
XFE_RC_2427_0 INV1S $PINS O=FE_RN_1508_0 I=n4
XFE_RC_2426_0 ND2S $PINS O=FE_RN_1509_0 I1=FE_RN_1508_0 I2=FE_RN_1507_0
XFE_RC_2425_0 ND2 $PINS O=FE_RN_1510_0 I1=N71 I2=FE_OFN155_s12_0
XFE_RC_2424_0 ND2 $PINS O=N98 I1=FE_RN_1510_0 I2=FE_RN_1509_0
XFE_RC_2422_0 INV1S $PINS O=FE_RN_1505_0 I=FE_OFN86_h11_1
XFE_RC_2421_0 INV2 $PINS O=sll_16/ML_int[2][2] I=FE_RN_1506_0
XFE_RC_2420_0 AOI22H $PINS O=FE_RN_1506_0 A1=sll_16/ML_int[1][0]
+ A2=FE_OFN86_h11_1 B1=sll_16/ML_int[1][2] B2=FE_RN_1505_0
XFE_RC_2088_0 ND2 $PINS O=FE_RN_1258_0 I1=FE_OCPN1192_term1_shifted_2
+ I2=FE_OFN139_s11_0
XFE_RC_2087_0 ND2 $PINS O=FE_RN_1259_0 I1=N16 I2=FE_OFN140_s11_0
XFE_RC_2086_0 ND2 $PINS O=N43 I1=FE_RN_1259_0 I2=FE_RN_1258_0
XFE_RC_1959_0 ND2 $PINS O=FE_RN_1162_0 I1=term1_shifted[4] I2=FE_OFN139_s11_0
XFE_RC_1958_0 ND2 $PINS O=FE_RN_1163_0 I1=N18 I2=FE_OFN140_s11_0
XFE_RC_1957_0 ND2 $PINS O=N45 I1=FE_RN_1163_0 I2=FE_RN_1162_0
XFE_RC_16_0 OA12 $PINS O=N41 A1=N14 B1=sign1[0] B2=FE_OFN139_s11_0
XFE_OFC865_h13_0 BUF1 $PINS O=FE_RN_4 I=FE_OFN99_h13_0
XFE_OFC858_h11_3 BUF1 $PINS O=FE_OFN465_h11_3 I=FE_OFN84_h11_3
XFE_OFC856_h11_2 BUF1 $PINS O=FE_RN_3 I=FE_OFN85_h11_2
XFE_OFC850_n105 BUF1 $PINS O=FE_OFN460_n105 I=FE_OFN459_n105
XFE_OFC849_n105 BUF1 $PINS O=FE_OFN459_n105 I=n105
XFE_OFC831_s12_0 BUF2 $PINS O=FE_OFN448_n I=sign2[0]
XFE_OFC814_s13_1 BUF1 $PINS O=FE_RN_2 I=FE_OFN94_s13_1
XFE_OFC803_h13_1 BUF1 $PINS O=n19 I=FE_OFN98_h13_1
XFE_OFC751_s11_0 BUF1 $PINS O=FE_OFN425_n I=FE_OFN139_s11_0
XFE_OFC742_h11_1 BUF1 $PINS O=n41 I=FE_OFN86_h11_1
XFE_OFC677_s12_0 INV1S $PINS O=FE_DBTN23_s12_0 I=FE_OFN448_n
XFE_OFC640_s13_0 INV2 $PINS O=FE_OFN380_s13_0 I=sign3[0]
XFE_OFC637_s13_0 INV1S $PINS O=FE_OFN377_s13_0 I=n26
XFE_OFC634_s13_0 INV1S $PINS O=n26 I=FE_OFN95_s13_0
XFE_OFC612_h12_1 BUF1 $PINS O=n31 I=FE_OFN92_h12_1
XFE_OFC606_h12_3 INV1S $PINS O=FE_OFN369_h12_3 I=shf2[3]
XFE_OFC605_h12_3 INV1S $PINS O=n35 I=shf2[3]
XFE_OFC593_h13_3 INV1S $PINS O=n23 I=FE_OFN96_h13_3
XFE_OFC592_h13_3 INV1S $PINS O=FE_RN_1 I=FE_OFN96_h13_3
XFE_OFC585_h13_2 BUF1 $PINS O=FE_OFN361_h13_2 I=shf3[2]
XFE_OFC576_h12_2 BUF1 $PINS O=FE_OFN352_h12_2 I=shf2[2]
XFE_OFC533_h13_2 INV1S $PINS O=n21 I=FE_OFN97_h13_2
XFE_OFC400_h11_3 INV1S $PINS O=n45 I=shf1[3]
XFE_OFC375_pe_clear_d1 INV1S $PINS O=n105 I=clear
XFE_OFC303_h12_2 INV1S $PINS O=n33 I=shf2[2]
XFE_DBTC16_N69 INV2 $PINS O=N691 I=term2_shifted[0]
XU110 AO22 $PINS O=base_val[13] A1=acc_reg[13] A2=FE_OFN459_n105 B1=clear
+ B2=FE_OFN61_FE_DBTN9_n336
XU115 AO22 $PINS O=N67 A1=sign1[0] A2=N40 B1=term1_shifted[26] B2=FE_OFN425_n
XU116 AO22 $PINS O=N66 A1=N39 A2=sign1[0] B1=term1_shifted[25] B2=FE_OFN425_n
XU117 AO22 $PINS O=N65 A1=N38 A2=sign1[0] B1=term1_shifted[24] B2=FE_OFN425_n
XU118 AO22 $PINS O=N64 A1=N37 A2=sign1[0] B1=term1_shifted[23] B2=FE_OFN425_n
XU119 AO22 $PINS O=N63 A1=N36 A2=sign1[0] B1=term1_shifted[22] B2=FE_OFN425_n
XU120 AO22 $PINS O=N62 A1=N35 A2=sign1[0] B1=term1_shifted[21] B2=FE_OFN425_n
XU122 AO22 $PINS O=N60 A1=N33 A2=sign1[0] B1=term1_shifted[19] B2=FE_OFN425_n
XU123 AO22 $PINS O=N59 A1=N32 A2=sign1[0] B1=term1_shifted[18] B2=FE_OFN425_n
XU125 AO22 $PINS O=N57 A1=N30 A2=sign1[0] B1=term1_shifted[16] B2=FE_OFN425_n
XU127 AO22 $PINS O=N55 A1=N28 A2=sign1[0] B1=term1_shifted[14] B2=FE_OFN425_n
XU128 AO22 $PINS O=N54 A1=N27 A2=sign1[0] B1=term1_shifted[13] B2=FE_OFN425_n
XU129 AO22 $PINS O=N53 A1=N26 A2=sign1[0] B1=term1_shifted[12] B2=FE_OFN425_n
XU130 AO22 $PINS O=N52 A1=N25 A2=sign1[0] B1=term1_shifted[11] B2=FE_OFN425_n
XU131 AO22 $PINS O=N51 A1=N24 A2=sign1[0] B1=term1_shifted[10] B2=FE_OFN425_n
XU132 AO22 $PINS O=N50 A1=N23 A2=sign1[0] B1=term1_shifted[9]
+ B2=FE_OFN139_s11_0
XU134 AO22P $PINS O=N48 A1=N21 A2=FE_OFN82_s11_0 B1=term1_shifted[7]
+ B2=FE_OFN139_s11_0
XU142 AO22 $PINS O=N177 A1=FE_OFN377_s13_0 A2=N150 B1=term3_shifted[26] B2=n26
XU143 AO22 $PINS O=N176 A1=N149 A2=FE_OFN377_s13_0 B1=term3_shifted[25] B2=n26
XU144 AO22 $PINS O=N175 A1=N148 A2=FE_OFN377_s13_0 B1=term3_shifted[24] B2=n26
XU145 AO22 $PINS O=N174 A1=N147 A2=FE_OFN377_s13_0 B1=term3_shifted[23] B2=n26
XU146 AO22 $PINS O=N173 A1=N146 A2=FE_OFN377_s13_0 B1=term3_shifted[22] B2=n26
XU147 AO22 $PINS O=N172 A1=N145 A2=FE_OFN377_s13_0 B1=term3_shifted[21] B2=n26
XU149 AO22 $PINS O=N170 A1=N143 A2=FE_OFN377_s13_0 B1=term3_shifted[19] B2=n26
XU150 AO22 $PINS O=N169 A1=N142 A2=FE_OFN377_s13_0 B1=term3_shifted[18] B2=n26
XU152 AO22 $PINS O=N167 A1=N140 A2=FE_OFN377_s13_0 B1=term3_shifted[16]
+ B2=sign3[0]
XU155 AO22 $PINS O=N164 A1=N137 A2=FE_OFN380_s13_0 B1=term3_shifted[13]
+ B2=sign3[0]
XU156 AO22 $PINS O=N163 A1=N136 A2=FE_OFN380_s13_0 B1=term3_shifted[12]
+ B2=sign3[0]
XU157 AO22 $PINS O=N162 A1=N135 A2=FE_OFN380_s13_0 B1=term3_shifted[11]
+ B2=sign3[0]
XU158 AO22 $PINS O=N161 A1=N134 A2=FE_OFN380_s13_0 B1=term3_shifted[10]
+ B2=sign3[0]
XU159 AO22 $PINS O=N160 A1=N133 A2=FE_OFN380_s13_0 B1=term3_shifted[9]
+ B2=sign3[0]
XU160 AO22 $PINS O=N159 A1=N132 A2=FE_OFN380_s13_0 B1=term3_shifted[8]
+ B2=sign3[0]
XU161 AO22P $PINS O=N158 A1=N131 A2=FE_OFN151_s13_0 B1=term3_shifted[7]
+ B2=sign3[0]
XU162 AO22 $PINS O=N157 A1=N130 A2=FE_OFN151_s13_0 B1=term3_shifted[6]
+ B2=sign3[0]
XU163 AO22P $PINS O=N156 A1=N129 A2=FE_OFN151_s13_0 B1=term3_shifted[5]
+ B2=sign3[0]
XU164 AO22P $PINS O=N155 A1=FE_OFN380_s13_0 A2=N128 B1=term3_shifted[4]
+ B2=sign3[0]
XU169 AO22 $PINS O=N122 A1=N95 A2=FE_DBTN23_s12_0 B1=term2_shifted[26]
+ B2=FE_OFN448_n
XU170 AO22 $PINS O=N121 A1=N94 A2=FE_DBTN23_s12_0 B1=term2_shifted[25]
+ B2=FE_OFN448_n
XU171 AO22 $PINS O=N120 A1=N93 A2=FE_DBTN23_s12_0 B1=term2_shifted[24]
+ B2=FE_OFN448_n
XU172 AO22 $PINS O=N119 A1=N92 A2=FE_DBTN23_s12_0 B1=term2_shifted[23]
+ B2=FE_OFN448_n
XU173 AO22 $PINS O=N118 A1=N91 A2=FE_DBTN23_s12_0 B1=term2_shifted[22]
+ B2=FE_OFN448_n
XU174 AO22 $PINS O=N117 A1=N90 A2=FE_DBTN23_s12_0 B1=term2_shifted[21]
+ B2=FE_OFN448_n
XU175 AO22 $PINS O=N116 A1=N89 A2=FE_DBTN23_s12_0 B1=term2_shifted[20]
+ B2=FE_OFN448_n
XU176 AO22 $PINS O=N115 A1=N88 A2=FE_DBTN23_s12_0 B1=term2_shifted[19]
+ B2=FE_OFN448_n
XU177 AO22 $PINS O=N114 A1=N87 A2=FE_DBTN23_s12_0 B1=term2_shifted[18]
+ B2=FE_OFN448_n
XU178 AO22 $PINS O=N113 A1=N86 A2=FE_DBTN23_s12_0 B1=term2_shifted[17]
+ B2=FE_OFN448_n
XU180 AO22 $PINS O=N111 A1=N84 A2=FE_OFN155_s12_0 B1=term2_shifted[15]
+ B2=FE_OFN448_n
XU181 AO22 $PINS O=N110 A1=N83 A2=FE_OFN155_s12_0 B1=term2_shifted[14]
+ B2=FE_OFN448_n
XU183 AO22 $PINS O=N108 A1=N81 A2=FE_OFN155_s12_0 B1=term2_shifted[12]
+ B2=FE_OFN448_n
XU184 AO22 $PINS O=N107 A1=N80 A2=FE_OFN155_s12_0 B1=term2_shifted[11]
+ B2=FE_OFN448_n
XU185 AO22 $PINS O=N106 A1=N79 A2=FE_OFN155_s12_0 B1=term2_shifted[10]
+ B2=FE_OFN448_n
XU186 AO22 $PINS O=N105 A1=N78 A2=FE_OFN155_s12_0 B1=term2_shifted[9]
+ B2=FE_OFN157_s12_0
XU187 AO22 $PINS O=N104 A1=N77 A2=FE_OFN155_s12_0 B1=term2_shifted[8]
+ B2=FE_OFN157_s12_0
XU188 AO22 $PINS O=N103 A1=N76 A2=FE_OFN155_s12_0 B1=term2_shifted[7]
+ B2=FE_OFN157_s12_0
XU189 AO22 $PINS O=N102 A1=N75 A2=FE_OFN155_s12_0 B1=term2_shifted[6]
+ B2=FE_OFN157_s12_0
XU190 AO22T $PINS O=N101 A1=N74 A2=FE_OFN155_s12_0 B1=term2_shifted[5]
+ B2=FE_OFN157_s12_0
Xsll_18/M1_0_6 MUX2 $PINS O=sll_18/ML_int[1][6] S=FE_OFN99_h13_0 A=term3_in[6]
+ B=term3_in[5]
Xsll_18/M1_0_7 MUX2 $PINS O=sll_18/ML_int[1][7] S=FE_OFN99_h13_0 A=term3_in[7]
+ B=term3_in[6]
Xsll_18/M1_1_5 MUX2 $PINS O=sll_18/ML_int[2][5] S=FE_OFN98_h13_1
+ A=sll_18/ML_int[1][5] B=sll_18/ML_int[1][3]
Xsll_18/M1_1_6 MUX2 $PINS O=sll_18/ML_int[2][6] S=FE_OFN98_h13_1
+ A=sll_18/ML_int[1][6] B=sll_18/ML_int[1][4]
Xsll_18/M1_1_7 MUX2 $PINS O=sll_18/ML_int[2][7] S=FE_OFN98_h13_1
+ A=sll_18/ML_int[1][7] B=sll_18/ML_int[1][5]
Xsll_18/M1_1_8 MUX2 $PINS O=sll_18/ML_int[2][8] S=FE_OFN98_h13_1
+ A=sll_18/ML_int[1][8] B=sll_18/ML_int[1][6]
Xsll_18/M1_2_4 MUX2 $PINS O=sll_18/ML_int[3][4] S=FE_OFN97_h13_2
+ A=sll_18/ML_int[2][4] B=n81
Xsll_18/M1_2_5 MUX2 $PINS O=sll_18/ML_int[3][5] S=FE_OFN97_h13_2
+ A=sll_18/ML_int[2][5] B=n82
Xsll_18/M1_2_6 MUX2 $PINS O=sll_18/ML_int[3][6] S=FE_OFN97_h13_2
+ A=sll_18/ML_int[2][6] B=sll_18/ML_int[2][2]
Xsll_18/M1_2_8 MUX2 $PINS O=sll_18/ML_int[3][8] S=FE_OFN97_h13_2
+ A=sll_18/ML_int[2][8] B=sll_18/ML_int[2][4]
Xsll_18/M1_2_9 MUX2 $PINS O=sll_18/ML_int[3][9] S=shf3[2] A=sll_18/ML_int[2][9]
+ B=sll_18/ML_int[2][5]
Xsll_18/M1_2_10 MUX2 $PINS O=sll_18/ML_int[3][10] S=shf3[2]
+ A=sll_18/ML_int[2][10] B=sll_18/ML_int[2][6]
Xsll_18/M1_3_8 MUX2 $PINS O=term3_shifted[8] S=n23 A=sll_18/ML_int[3][8]
+ B=sll_18/ML_int[3][0]
Xsll_18/M1_3_9 MUX2 $PINS O=term3_shifted[9] S=n23 A=sll_18/ML_int[3][9]
+ B=sll_18/ML_int[3][1]
Xsll_18/M1_3_10 MUX2 $PINS O=term3_shifted[10] S=n23 A=sll_18/ML_int[3][10]
+ B=sll_18/ML_int[3][2]
Xsll_18/M1_3_11 MUX2 $PINS O=term3_shifted[11] S=n23 A=sll_18/ML_int[3][11]
+ B=sll_18/ML_int[3][3]
Xsll_18/M1_3_12 MUX2 $PINS O=term3_shifted[12] S=n23 A=sll_18/ML_int[3][12]
+ B=sll_18/ML_int[3][4]
Xsll_18/M1_3_13 MUX2 $PINS O=term3_shifted[13] S=n23 A=sll_18/ML_int[3][13]
+ B=sll_18/ML_int[3][5]
Xsll_18/M1_3_14 MUX2 $PINS O=term3_shifted[14] S=n23 A=sll_18/ML_int[3][14]
+ B=sll_18/ML_int[3][6]
Xsll_18/M1_3_15 MUX2 $PINS O=term3_shifted[15] S=n23 A=sll_18/ML_int[3][15]
+ B=sll_18/ML_int[3][7]
Xsll_18/M1_3_23 MUX2 $PINS O=term3_shifted[23] S=FE_RN_1 A=term3_in[26]
+ B=sll_18/ML_int[3][15]
Xsll_17/M1_0_3 MUX2 $PINS O=sll_17/ML_int[1][3] S=FE_OFN93_h12_0 A=term2_in[3]
+ B=term2_in[2]
Xsll_17/M1_0_5 MUX2 $PINS O=sll_17/ML_int[1][5] S=FE_OFN93_h12_0 A=term2_in[5]
+ B=term2_in[4]
Xsll_17/M1_0_6 MUX2 $PINS O=sll_17/ML_int[1][6] S=FE_OFN93_h12_0 A=term2_in[6]
+ B=term2_in[5]
Xsll_17/M1_0_7 MUX2 $PINS O=sll_17/ML_int[1][7] S=FE_OFN93_h12_0 A=term2_in[7]
+ B=term2_in[6]
Xsll_17/M1_1_5 MUX2 $PINS O=sll_17/ML_int[2][5] S=FE_OFN92_h12_1
+ A=sll_17/ML_int[1][5] B=sll_17/ML_int[1][3]
Xsll_17/M1_1_6 MUX2 $PINS O=sll_17/ML_int[2][6] S=FE_OFN92_h12_1
+ A=sll_17/ML_int[1][6] B=sll_17/ML_int[1][4]
Xsll_17/M1_1_7 MUX2 $PINS O=sll_17/ML_int[2][7] S=FE_OFN92_h12_1
+ A=sll_17/ML_int[1][7] B=sll_17/ML_int[1][5]
Xsll_17/M1_1_8 MUX2 $PINS O=sll_17/ML_int[2][8] S=FE_OFN92_h12_1
+ A=sll_17/ML_int[1][8] B=sll_17/ML_int[1][6]
Xsll_17/M1_2_5 MUX2 $PINS O=sll_17/ML_int[3][5] S=shf2[2] A=sll_17/ML_int[2][5]
+ B=n71
Xsll_17/M1_2_8 MUX2 $PINS O=sll_17/ML_int[3][8] S=shf2[2] A=sll_17/ML_int[2][8]
+ B=sll_17/ML_int[2][4]
Xsll_17/M1_2_9 MUX2 $PINS O=sll_17/ML_int[3][9] S=shf2[2] A=sll_17/ML_int[2][9]
+ B=sll_17/ML_int[2][5]
Xsll_17/M1_2_10 MUX2 $PINS O=sll_17/ML_int[3][10] S=FE_OFN352_h12_2
+ A=sll_17/ML_int[2][10] B=sll_17/ML_int[2][6]
Xsll_17/M1_3_8 MUX2 $PINS O=term2_shifted[8] S=FE_OFN369_h12_3
+ A=sll_17/ML_int[3][8] B=sll_17/ML_int[3][0]
Xsll_17/M1_3_9 MUX2 $PINS O=term2_shifted[9] S=FE_OFN369_h12_3
+ A=sll_17/ML_int[3][9] B=sll_17/ML_int[3][1]
Xsll_17/M1_3_10 MUX2 $PINS O=term2_shifted[10] S=FE_OFN369_h12_3
+ A=sll_17/ML_int[3][10] B=sll_17/ML_int[3][2]
Xsll_17/M1_3_11 MUX2 $PINS O=term2_shifted[11] S=FE_OFN369_h12_3
+ A=sll_17/ML_int[3][11] B=sll_17/ML_int[3][3]
Xsll_17/M1_3_12 MUX2 $PINS O=term2_shifted[12] S=FE_OFN369_h12_3
+ A=sll_17/ML_int[3][12] B=sll_17/ML_int[3][4]
Xsll_17/M1_3_13 MUX2 $PINS O=term2_shifted[13] S=FE_OFN369_h12_3
+ A=sll_17/ML_int[3][13] B=sll_17/ML_int[3][5]
Xsll_17/M1_3_14 MUX2 $PINS O=term2_shifted[14] S=FE_OFN369_h12_3
+ A=sll_17/ML_int[3][14] B=sll_17/ML_int[3][6]
Xsll_17/M1_3_23 MUX2 $PINS O=term2_shifted[23] S=n35 A=term2_in[26]
+ B=sll_17/ML_int[3][15]
Xsll_16/M1_0_6 MUX2 $PINS O=sll_16/ML_int[1][6] S=FE_OFN87_h11_0 A=term1_in[6]
+ B=term1_in[5]
Xsll_16/M1_0_7 MUX2 $PINS O=sll_16/ML_int[1][7] S=FE_OFN87_h11_0 A=term1_in[7]
+ B=term1_in[6]
Xsll_16/M1_0_8 MUX2 $PINS O=sll_16/ML_int[1][8] S=FE_OFN87_h11_0 A=term1_in[8]
+ B=term1_in[7]
Xsll_16/M1_1_3 MUX2 $PINS O=sll_16/ML_int[2][3] S=FE_OFN86_h11_1
+ A=sll_16/ML_int[1][3] B=sll_16/ML_int[1][1]
Xsll_16/M1_1_5 MUX2 $PINS O=sll_16/ML_int[2][5] S=FE_OFN86_h11_1
+ A=sll_16/ML_int[1][5] B=sll_16/ML_int[1][3]
Xsll_16/M1_1_6 MUX2 $PINS O=sll_16/ML_int[2][6] S=FE_OFN86_h11_1
+ A=sll_16/ML_int[1][6] B=FE_OCPN1021_sll_16_ML_int_1_4
Xsll_16/M1_1_7 MUX2 $PINS O=sll_16/ML_int[2][7] S=FE_OFN86_h11_1
+ A=sll_16/ML_int[1][7] B=sll_16/ML_int[1][5]
Xsll_16/M1_1_8 MUX2 $PINS O=sll_16/ML_int[2][8] S=FE_OFN86_h11_1
+ A=sll_16/ML_int[1][8] B=sll_16/ML_int[1][6]
Xsll_16/M1_1_9 MUX2 $PINS O=sll_16/ML_int[2][9] S=FE_OFN86_h11_1
+ A=sll_16/ML_int[1][9] B=sll_16/ML_int[1][7]
Xsll_16/M1_2_5 MUX2 $PINS O=sll_16/ML_int[3][5] S=FE_OFN85_h11_2
+ A=sll_16/ML_int[2][5] B=n61
Xsll_16/M1_2_6 MUX2 $PINS O=sll_16/ML_int[3][6] S=FE_OFN85_h11_2
+ A=sll_16/ML_int[2][6] B=sll_16/ML_int[2][2]
Xsll_16/M1_2_7 MUX2 $PINS O=sll_16/ML_int[3][7] S=FE_OFN85_h11_2
+ A=sll_16/ML_int[2][7] B=sll_16/ML_int[2][3]
Xsll_16/M1_2_8 MUX2 $PINS O=sll_16/ML_int[3][8] S=FE_OFN85_h11_2
+ A=sll_16/ML_int[2][8] B=sll_16/ML_int[2][4]
Xsll_16/M1_2_9 MUX2 $PINS O=sll_16/ML_int[3][9] S=FE_OFN85_h11_2
+ A=sll_16/ML_int[2][9] B=sll_16/ML_int[2][5]
Xsll_16/M1_2_10 MUX2 $PINS O=sll_16/ML_int[3][10] S=FE_OFN85_h11_2
+ A=sll_16/ML_int[2][10] B=sll_16/ML_int[2][6]
Xsll_16/M1_2_11 MUX2 $PINS O=sll_16/ML_int[3][11] S=FE_OFN85_h11_2
+ A=sll_16/ML_int[2][11] B=sll_16/ML_int[2][7]
Xsll_16/M1_3_8 MUX2 $PINS O=term1_shifted[8] S=FE_OFN84_h11_3
+ A=sll_16/ML_int[3][8] B=sll_16/ML_int[3][0]
Xsll_16/M1_3_9 MUX2 $PINS O=term1_shifted[9] S=FE_OFN84_h11_3
+ A=sll_16/ML_int[3][9] B=sll_16/ML_int[3][1]
Xsll_16/M1_3_10 MUX2 $PINS O=term1_shifted[10] S=FE_OFN84_h11_3
+ A=sll_16/ML_int[3][10] B=sll_16/ML_int[3][2]
Xsll_16/M1_3_11 MUX2 $PINS O=term1_shifted[11] S=FE_OFN84_h11_3
+ A=sll_16/ML_int[3][11] B=sll_16/ML_int[3][3]
Xsll_16/M1_3_12 MUX2 $PINS O=term1_shifted[12] S=FE_OFN84_h11_3
+ A=sll_16/ML_int[3][12] B=sll_16/ML_int[3][4]
Xsll_16/M1_3_13 MUX2 $PINS O=term1_shifted[13] S=FE_OFN84_h11_3
+ A=sll_16/ML_int[3][13] B=sll_16/ML_int[3][5]
Xsll_16/M1_3_14 MUX2 $PINS O=term1_shifted[14] S=FE_OFN84_h11_3
+ A=sll_16/ML_int[3][14] B=sll_16/ML_int[3][6]
Xsll_16/M1_3_15 MUX2 $PINS O=term1_shifted[15] S=FE_OFN84_h11_3
+ A=sll_16/ML_int[3][15] B=sll_16/ML_int[3][7]
Xsll_16/M1_3_23 MUX2 $PINS O=term1_shifted[23] S=FE_OFN465_h11_3 A=term1_in[26]
+ B=sll_16/ML_int[3][15]
Xy_out_reg[9] QDFFRBN $PINS Q=y_out[9] D=FE_PHN1437_N244 CK=CTS_10
+ RB=FE_OFN40_i_rst_n
Xy_out_reg[8] QDFFRBN $PINS Q=FE_PHN1654_pe_i1_8 D=FE_PHN1842_N243 CK=CTS_10
+ RB=FE_OFN40_i_rst_n
Xy_out_reg[7] QDFFRBN $PINS Q=y_out[7] D=FE_PHN1435_N242 CK=CTS_10
+ RB=FE_OFN40_i_rst_n
Xy_out_reg[6] QDFFRBN $PINS Q=FE_PHN1651_pe_i1_6 D=N241 CK=CTS_10
+ RB=FE_OFN40_i_rst_n
Xy_out_reg[5] QDFFRBN $PINS Q=FE_PHN1690_pe_i1_5 D=N240 CK=CTS_10
+ RB=FE_OFN40_i_rst_n
Xy_out_reg[4] QDFFRBN $PINS Q=FE_PHN1684_pe_i1_4 D=FE_PHN1433_N239 CK=CTS_10
+ RB=FE_OFN37_i_rst_n
Xy_out_reg[3] QDFFRBN $PINS Q=FE_PHN1689_pe_i1_3 D=N238 CK=CTS_10
+ RB=FE_OFN37_i_rst_n
Xy_out_reg[2] QDFFRBN $PINS Q=FE_PHN1641_pe_i1_2 D=N237 CK=CTS_10
+ RB=FE_OFN37_i_rst_n
Xy_out_reg[1] QDFFRBN $PINS Q=FE_PHN1636_pe_i1_1 D=FE_PHN1427_N236 CK=CTS_10
+ RB=FE_OFN37_i_rst_n
Xy_out_reg[0] QDFFRBN $PINS Q=FE_PHN1622_pe_i1_0 D=N235 CK=CTS_10
+ RB=FE_OFN37_i_rst_n
Xacc_reg_reg[25] QDFFRBN $PINS Q=acc_reg[25] D=next_acc[25] CK=clk_clone1
+ RB=FE_OFN35_i_rst_n
Xacc_reg_reg[24] QDFFRBN $PINS Q=acc_reg[24] D=next_acc[24] CK=clk_clone1
+ RB=FE_OFN35_i_rst_n
Xy_out_reg[16] QDFFRBN $PINS Q=FE_PHN2202_pe_i1_16 D=FE_PHN1366_N251 CK=CTS_10
+ RB=FE_OFN40_i_rst_n
Xy_out_reg[11] QDFFRBN $PINS Q=y_out[11] D=FE_PHN1431_N246 CK=CTS_10
+ RB=FE_OFN40_i_rst_n
Xy_out_reg[12] QDFFRBN $PINS Q=y_out[12] D=N247 CK=CTS_10 RB=FE_OFN40_i_rst_n
Xy_out_reg[10] QDFFRBN $PINS Q=y_out[10] D=FE_PHN1858_N245 CK=CTS_10
+ RB=FE_OFN40_i_rst_n
Xacc_reg_reg[23] QDFFRBN $PINS Q=acc_reg[23] D=next_acc[23] CK=clk_clone1
+ RB=FE_OFN40_i_rst_n
Xy_out_reg[14] QDFFRBN $PINS Q=y_out[14] D=FE_PHN1859_N249 CK=CTS_10
+ RB=FE_OFN40_i_rst_n
Xy_out_reg[15] QDFFRBN $PINS Q=y_out[15] D=N250 CK=CTS_10 RB=FE_OFN40_i_rst_n
Xy_out_reg[13] QDFFRBN $PINS Q=y_out[13] D=FE_PHN1855_N248 CK=CTS_10
+ RB=FE_OFN40_i_rst_n
Xacc_reg_reg[22] QDFFRBN $PINS Q=FE_PHN1780_acc_reg_22 D=next_acc[22]
+ CK=clk_clone1 RB=FE_OFN40_i_rst_n
Xacc_reg_reg[21] QDFFRBN $PINS Q=acc_reg[21] D=next_acc[21] CK=clk_clone1
+ RB=FE_OFN40_i_rst_n
Xacc_reg_reg[20] QDFFRBN $PINS Q=acc_reg[20] D=next_acc[20] CK=clk_clone1
+ RB=FE_OFN40_i_rst_n
Xacc_reg_reg[19] QDFFRBN $PINS Q=acc_reg[19] D=next_acc[19] CK=clk_clone1
+ RB=FE_OFN40_i_rst_n
Xacc_reg_reg[18] QDFFRBN $PINS Q=acc_reg[18] D=next_acc[18] CK=clk_clone1
+ RB=FE_OFN40_i_rst_n
Xacc_reg_reg[17] QDFFRBN $PINS Q=acc_reg[17] D=next_acc[17] CK=clk_clone1
+ RB=FE_OFN40_i_rst_n
Xacc_reg_reg[16] QDFFRBN $PINS Q=acc_reg[16] D=next_acc[16] CK=clk_clone1
+ RB=FE_OFN37_i_rst_n
Xacc_reg_reg[15] QDFFRBN $PINS Q=acc_reg[15] D=next_acc[15] CK=clk_clone1
+ RB=FE_OFN37_i_rst_n
Xacc_reg_reg[14] QDFFRBN $PINS Q=acc_reg[14] D=next_acc[14] CK=clk_clone1
+ RB=FE_OFN37_i_rst_n
Xacc_reg_reg[13] QDFFRBN $PINS Q=acc_reg[13] D=next_acc[13] CK=clk_clone1
+ RB=FE_OFN37_i_rst_n
Xacc_reg_reg[12] QDFFRBN $PINS Q=acc_reg[12] D=next_acc[12] CK=clk_clone1
+ RB=FE_OFN37_i_rst_n
Xacc_reg_reg[11] QDFFRBN $PINS Q=acc_reg[11] D=next_acc[11] CK=clk_clone1
+ RB=FE_OFN37_i_rst_n
Xacc_reg_reg[10] QDFFRBN $PINS Q=acc_reg[10] D=next_acc[10] CK=clk_clone1
+ RB=FE_OFN37_i_rst_n
Xacc_reg_reg[9] QDFFRBN $PINS Q=acc_reg[9] D=next_acc[9] CK=clk_clone1
+ RB=i_rst_n
Xacc_reg_reg[8] QDFFRBN $PINS Q=acc_reg[8] D=next_acc[8] CK=clk_clone1
+ RB=i_rst_n
Xacc_reg_reg[7] QDFFRBN $PINS Q=acc_reg[7] D=next_acc[7] CK=clk_clone1
+ RB=i_rst_n
Xacc_reg_reg[6] QDFFRBN $PINS Q=acc_reg[6] D=next_acc[6] CK=clk_clone1
+ RB=i_rst_n
Xacc_reg_reg[5] QDFFRBN $PINS Q=acc_reg[5] D=next_acc[5] CK=clk_clone1
+ RB=i_rst_n
Xacc_reg_reg[4] QDFFRBN $PINS Q=acc_reg[4] D=next_acc[4] CK=clk_clone1
+ RB=i_rst_n
Xacc_reg_reg[3] QDFFRBN $PINS Q=acc_reg[3] D=next_acc[3] CK=clk_clone1
+ RB=i_rst_n
Xacc_reg_reg[2] QDFFRBN $PINS Q=acc_reg[2] D=next_acc[2] CK=clk_clone1
+ RB=i_rst_n
Xacc_reg_reg[1] QDFFRBN $PINS Q=acc_reg[1] D=next_acc[1] CK=clk_clone1
+ RB=i_rst_n
Xacc_reg_reg[0] QDFFRBS $PINS Q=acc_reg[0] D=FE_PHN1571_next_acc_0
+ CK=clk_clone1 RB=i_rst_n
Xacc_reg_reg[26] QDFFRBS $PINS Q=N251 D=next_acc[26] CK=clk_clone1
+ RB=FE_OFN35_i_rst_n
XU6 NR2P $PINS O=term1_shifted[3] I1=n57 I2=n58
XU11 NR2 $PINS O=term3_in[3] I1=FE_OFN94_s13_1 I2=x_in[3]
XU12 ND2 $PINS O=n11 I1=N126 I2=FE_OFN380_s13_0
XU14 MUX2 $PINS O=FE_PHN1860_N250 S=stage_sel A=acc_reg[25] B=FE_PHN1366_N251
XU15 MUX2 $PINS O=N249 S=stage_sel A=acc_reg[24] B=FE_PHN1366_N251
XU16 MUX2 $PINS O=N247 S=stage_sel A=acc_reg[22] B=FE_PHN1366_N251
XU18 NR2 $PINS O=sll_16/ML_int[3][2] I1=FE_OFN85_h11_2 I2=n59
XU19 INV2 $PINS O=n59 I=sll_16/ML_int[2][2]
XU20 MUX2S $PINS O=sll_18/ML_int[3][7] S=n21 A=sll_18/ML_int[2][3]
+ B=sll_18/ML_int[2][7]
XU25 AN2B1T $PINS O=term3_shifted[3] I1=sll_18/ML_int[2][3] B1=n78
XU26 NR2 $PINS O=sll_16/ML_int[3][3] I1=FE_OFN85_h11_2 I2=n58
XU28 AN2 $PINS O=base_val[1] I1=acc_reg[1] I2=n105
XU29 OR2 $PINS O=n76 I1=n6 I2=FE_OFN98_h13_1
XU30 ND2 $PINS O=n5 I1=FE_OCPN1186_sll_17_ML_int_1_1 I2=shf2[1]
XU31 ND2 $PINS O=n67 I1=n33 I2=shf2[3]
XU32 ND2 $PINS O=N153 I1=n11 I2=n12
XU45 INV2 $PINS O=n13 I=sll_17/ML_int[1][0]
XU46 INV2CK $PINS O=n9 I=N70
XU50 MUX2 $PINS O=sll_17/ML_int[1][4] S=FE_OFN93_h12_0 A=term2_in[4]
+ B=term2_in[3]
XU51 MUX2S $PINS O=sll_17/ML_int[3][7] S=shf2[2] A=sll_17/ML_int[2][7]
+ B=sll_17/ML_int[2][3]
XU52 MUX2 $PINS O=sll_17/ML_int[2][3] S=FE_OFN92_h12_1 A=sll_17/ML_int[1][3]
+ B=sll_17/ML_int[1][1]
XU59 INV2 $PINS O=n69 I=sll_17/ML_int[2][2]
XU62 NR2P $PINS O=term2_shifted[2] I1=n67 I2=n69
XU65 NR2P $PINS O=term1_in[2] I1=FE_OFN81_s11_1 I2=x_in[2]
XU66 NR2 $PINS O=term3_in[2] I1=FE_OFN94_s13_1 I2=x_in[2]
XU67 NR2T $PINS O=term1_in[4] I1=FE_OFN81_s11_1 I2=x_in[4]
XU69 NR2 $PINS O=term3_in[4] I1=FE_OFN94_s13_1 I2=x_in[4]
XU74 AO22 $PINS O=N166 A1=N139 A2=FE_OFN380_s13_0 B1=term3_shifted[15]
+ B2=sign3[0]
XU75 AO22 $PINS O=N112 A1=N85 A2=FE_DBTN23_s12_0 B1=term2_shifted[16]
+ B2=FE_OFN448_n
XU76 AN2 $PINS O=base_val[16] I1=acc_reg[16] I2=FE_OFN459_n105
XU78 NR2 $PINS O=n3 I1=FE_OFN88_s12_1 I2=x_in[1]
XU81 NR2 $PINS O=term2_in[2] I1=FE_OFN88_s12_1 I2=x_in[2]
XU82 NR2 $PINS O=term2_in[1] I1=FE_OFN88_s12_1 I2=x_in[1]
XU83 NR2 $PINS O=term2_in[4] I1=FE_OFN88_s12_1 I2=x_in[4]
XU92 OR2S $PINS O=n4 I1=n67 I2=n69
XU94 MUX2 $PINS O=sll_17/ML_int[1][1] S=n29 A=term2_in[0] B=n3
XU95 OR2 $PINS O=n7 I1=n78 I2=FE_OFN98_h13_1
XU96 MUX2S $PINS O=sll_17/ML_int[3][6] S=shf2[2] A=sll_17/ML_int[2][6]
+ B=sll_17/ML_int[2][2]
XU97 AO22 $PINS O=N165 A1=N138 A2=FE_OFN380_s13_0 B1=term3_shifted[14]
+ B2=sign3[0]
XU99 MUX2S $PINS O=sll_18/ML_int[1][5] S=FE_OFN99_h13_0 A=term3_in[5]
+ B=term3_in[4]
XU101 MOAI1 $PINS O=N97 A1=n9 A2=FE_OFN448_n B1=n107 B2=FE_OFN448_n
XU102 MUX2 $PINS O=sll_16/ML_int[1][5] S=FE_OFN87_h11_0 A=term1_in[5]
+ B=term1_in[4]
XU106 AO22 $PINS O=N56 A1=N29 A2=sign1[0] B1=term1_shifted[15] B2=FE_OFN425_n
XU107 ND2S $PINS O=n12 I1=term3_shifted[2] I2=sign3[0]
XU109 AO22S $PINS O=N58 A1=N31 A2=sign1[0] B1=term1_shifted[17] B2=FE_OFN425_n
XU111 AO22S $PINS O=N168 A1=N141 A2=FE_OFN377_s13_0 B1=term3_shifted[17] B2=n26
XU112 MUX2 $PINS O=sll_18/ML_int[1][3] S=FE_OFN99_h13_0 A=term3_in[3]
+ B=term3_in[2]
XU126 OR2S $PINS O=n66 I1=n13 I2=FE_OFN92_h12_1
XU137 OR2 $PINS O=n14 I1=n67 I2=FE_OFN92_h12_1
XU138 INV2 $PINS O=n80 I=sll_18/ML_int[2][2]
XU139 INV1S $PINS O=n81 I=n76
XU140 AN2 $PINS O=term3_shifted[7] I1=sll_18/ML_int[3][7] I2=FE_OFN96_h13_3
XU154 AN2 $PINS O=base_val[0] I1=acc_reg[0] I2=n105
XU165 MUX2S $PINS O=sll_17/ML_int[1][8] S=FE_OFN93_h12_0 A=term2_in[8]
+ B=term2_in[7]
XU166 MUX2S $PINS O=sll_18/ML_int[1][8] S=FE_RN_4 A=term3_in[8] B=term3_in[7]
XU167 MUX2S $PINS O=sll_17/ML_int[2][9] S=n31 A=sll_17/ML_int[1][9]
+ B=sll_17/ML_int[1][7]
XU168 MUX2S $PINS O=sll_18/ML_int[2][9] S=FE_OFN98_h13_1 A=sll_18/ML_int[1][9]
+ B=sll_18/ML_int[1][7]
XU179 MUX2S $PINS O=sll_17/ML_int[1][9] S=FE_OFN93_h12_0 A=term2_in[9]
+ B=term2_in[8]
XU182 MUX2S $PINS O=sll_18/ML_int[1][9] S=FE_RN_4 A=term3_in[9] B=term3_in[8]
XU192 MUX2S $PINS O=sll_16/ML_int[1][9] S=FE_OFN87_h11_0 A=term1_in[9]
+ B=term1_in[8]
XU193 MUX2S $PINS O=sll_16/ML_int[2][10] S=n41 A=sll_16/ML_int[1][10]
+ B=sll_16/ML_int[1][8]
XU194 MUX2S $PINS O=sll_16/ML_int[1][10] S=FE_OFN87_h11_0 A=term1_in[10]
+ B=term1_in[9]
XU195 MUX2S $PINS O=sll_18/ML_int[2][10] S=n19 A=sll_18/ML_int[1][10]
+ B=sll_18/ML_int[1][8]
XU196 MUX2S $PINS O=sll_18/ML_int[1][10] S=FE_RN_4 A=term3_in[10] B=term3_in[9]
XU197 MUX2S $PINS O=sll_17/ML_int[2][10] S=n31 A=sll_17/ML_int[1][10]
+ B=sll_17/ML_int[1][8]
XU198 MUX2S $PINS O=sll_17/ML_int[1][10] S=FE_OFN93_h12_0 A=term2_in[10]
+ B=term2_in[9]
XU199 MUX2S $PINS O=sll_16/ML_int[2][11] S=n41 A=sll_16/ML_int[1][11]
+ B=sll_16/ML_int[1][9]
XU200 MUX2S $PINS O=sll_16/ML_int[1][11] S=FE_OFN87_h11_0 A=term1_in[11]
+ B=term1_in[10]
XU201 MUX2S $PINS O=sll_18/ML_int[3][11] S=shf3[2] A=sll_18/ML_int[2][11]
+ B=sll_18/ML_int[2][7]
XU202 MUX2S $PINS O=sll_18/ML_int[2][11] S=n19 A=sll_18/ML_int[1][11]
+ B=sll_18/ML_int[1][9]
XU203 MUX2S $PINS O=sll_18/ML_int[1][11] S=FE_RN_4 A=term3_in[11]
+ B=term3_in[10]
XU204 MUX2S $PINS O=sll_17/ML_int[3][11] S=FE_OFN352_h12_2
+ A=sll_17/ML_int[2][11] B=sll_17/ML_int[2][7]
XU205 MUX2S $PINS O=sll_17/ML_int[2][11] S=n31 A=sll_17/ML_int[1][11]
+ B=sll_17/ML_int[1][9]
XU206 MUX2S $PINS O=sll_17/ML_int[1][11] S=FE_OFN93_h12_0 A=term2_in[11]
+ B=term2_in[10]
XU207 MUX2S $PINS O=sll_16/ML_int[3][12] S=FE_RN_3 A=sll_16/ML_int[2][12]
+ B=sll_16/ML_int[2][8]
XU208 MUX2S $PINS O=sll_16/ML_int[2][12] S=n41 A=sll_16/ML_int[1][12]
+ B=sll_16/ML_int[1][10]
XU209 MUX2S $PINS O=sll_16/ML_int[1][12] S=FE_OFN87_h11_0 A=term1_in[12]
+ B=term1_in[11]
XU210 MUX2S $PINS O=sll_18/ML_int[3][12] S=FE_OFN361_h13_2
+ A=sll_18/ML_int[2][12] B=sll_18/ML_int[2][8]
XU211 MUX2S $PINS O=sll_18/ML_int[2][12] S=n19 A=sll_18/ML_int[1][12]
+ B=sll_18/ML_int[1][10]
XU212 MUX2S $PINS O=sll_18/ML_int[1][12] S=FE_RN_4 A=term3_in[12]
+ B=term3_in[11]
XU213 MUX2S $PINS O=sll_17/ML_int[3][12] S=FE_OFN352_h12_2
+ A=sll_17/ML_int[2][12] B=sll_17/ML_int[2][8]
XU214 MUX2S $PINS O=sll_17/ML_int[2][12] S=n31 A=sll_17/ML_int[1][12]
+ B=sll_17/ML_int[1][10]
XU215 MUX2S $PINS O=sll_17/ML_int[1][12] S=FE_OFN93_h12_0 A=term2_in[12]
+ B=term2_in[11]
XU216 MUX2S $PINS O=sll_16/ML_int[3][13] S=FE_RN_3 A=sll_16/ML_int[2][13]
+ B=sll_16/ML_int[2][9]
XU217 MUX2S $PINS O=sll_16/ML_int[2][13] S=n41 A=sll_16/ML_int[1][13]
+ B=sll_16/ML_int[1][11]
XU218 MUX2S $PINS O=sll_16/ML_int[1][13] S=FE_OFN87_h11_0 A=term1_in[13]
+ B=term1_in[12]
XU219 MUX2S $PINS O=sll_18/ML_int[3][13] S=FE_OFN361_h13_2
+ A=sll_18/ML_int[2][13] B=sll_18/ML_int[2][9]
XU220 MUX2S $PINS O=sll_18/ML_int[2][13] S=n19 A=sll_18/ML_int[1][13]
+ B=sll_18/ML_int[1][11]
XU221 MUX2S $PINS O=sll_18/ML_int[1][13] S=FE_RN_4 A=term3_in[13]
+ B=term3_in[12]
XU222 MUX2S $PINS O=sll_17/ML_int[3][13] S=FE_OFN352_h12_2
+ A=sll_17/ML_int[2][13] B=sll_17/ML_int[2][9]
XU223 MUX2S $PINS O=sll_17/ML_int[2][13] S=n31 A=sll_17/ML_int[1][13]
+ B=sll_17/ML_int[1][11]
XU224 MUX2S $PINS O=sll_17/ML_int[1][13] S=FE_OFN93_h12_0 A=term2_in[13]
+ B=term2_in[12]
XU225 MUX2S $PINS O=sll_16/ML_int[3][14] S=FE_RN_3 A=sll_16/ML_int[2][14]
+ B=sll_16/ML_int[2][10]
XU226 MUX2S $PINS O=sll_16/ML_int[2][14] S=n41 A=sll_16/ML_int[1][14]
+ B=sll_16/ML_int[1][12]
XU227 MUX2S $PINS O=sll_16/ML_int[1][14] S=FE_OFN87_h11_0 A=term1_in[14]
+ B=term1_in[13]
XU228 MUX2S $PINS O=sll_18/ML_int[3][14] S=FE_OFN361_h13_2
+ A=sll_18/ML_int[2][14] B=sll_18/ML_int[2][10]
XU229 MUX2S $PINS O=sll_18/ML_int[2][14] S=n19 A=sll_18/ML_int[1][14]
+ B=sll_18/ML_int[1][12]
XU230 MUX2S $PINS O=sll_18/ML_int[1][14] S=FE_RN_4 A=term3_in[14]
+ B=term3_in[13]
XU231 MUX2S $PINS O=sll_17/ML_int[3][14] S=FE_OFN352_h12_2
+ A=sll_17/ML_int[2][14] B=sll_17/ML_int[2][10]
XU232 MUX2S $PINS O=sll_17/ML_int[2][14] S=n31 A=sll_17/ML_int[1][14]
+ B=sll_17/ML_int[1][12]
XU233 MUX2S $PINS O=sll_17/ML_int[1][14] S=FE_OFN93_h12_0 A=term2_in[14]
+ B=term2_in[13]
XU234 MUX2S $PINS O=n62 S=n41 A=n65 B=sll_16/ML_int[1][14]
XU235 MUX2S $PINS O=term1_shifted[16] S=FE_OFN84_h11_3 A=sll_16/ML_int[3][16]
+ B=sll_16/ML_int[3][8]
XU236 MUX2S $PINS O=sll_16/ML_int[3][16] S=FE_RN_3 A=n62 B=sll_16/ML_int[2][12]
XU237 MUX2S $PINS O=term3_shifted[16] S=n23 A=sll_18/ML_int[3][16]
+ B=sll_18/ML_int[3][8]
XU238 MUX2S $PINS O=sll_18/ML_int[3][16] S=FE_OFN361_h13_2 A=n83
+ B=sll_18/ML_int[2][12]
XU239 MUX2S $PINS O=n83 S=n19 A=n86 B=sll_18/ML_int[1][14]
XU240 MUX2S $PINS O=term2_shifted[16] S=n35 A=sll_17/ML_int[3][16]
+ B=sll_17/ML_int[3][8]
XU241 MUX2S $PINS O=sll_17/ML_int[3][16] S=FE_OFN352_h12_2 A=n72
+ B=sll_17/ML_int[2][12]
XU242 MUX2S $PINS O=n72 S=n31 A=n75 B=sll_17/ML_int[1][14]
XU243 MUX2S $PINS O=sll_16/ML_int[3][15] S=FE_RN_3 A=sll_16/ML_int[2][15]
+ B=sll_16/ML_int[2][11]
XU244 MUX2S $PINS O=sll_16/ML_int[2][15] S=n41 A=sll_16/ML_int[1][15]
+ B=sll_16/ML_int[1][13]
XU245 MUX2S $PINS O=sll_16/ML_int[1][15] S=shf1[0] A=term1_in[15]
+ B=term1_in[14]
XU246 MUX2S $PINS O=sll_18/ML_int[3][15] S=FE_OFN361_h13_2
+ A=sll_18/ML_int[2][15] B=sll_18/ML_int[2][11]
XU247 MUX2S $PINS O=sll_18/ML_int[2][15] S=n19 A=sll_18/ML_int[1][15]
+ B=sll_18/ML_int[1][13]
XU248 MUX2S $PINS O=sll_18/ML_int[1][15] S=FE_RN_4 A=term3_in[15]
+ B=term3_in[14]
XU249 MUX2S $PINS O=term2_shifted[15] S=FE_OFN369_h12_3 A=sll_17/ML_int[3][15]
+ B=sll_17/ML_int[3][7]
XU250 MUX2S $PINS O=sll_17/ML_int[3][15] S=FE_OFN352_h12_2
+ A=sll_17/ML_int[2][15] B=sll_17/ML_int[2][11]
XU251 MUX2S $PINS O=sll_17/ML_int[2][15] S=n31 A=sll_17/ML_int[1][15]
+ B=sll_17/ML_int[1][13]
XU252 MUX2S $PINS O=sll_17/ML_int[1][15] S=shf2[0] A=term2_in[15]
+ B=term2_in[14]
XU253 MUX2S $PINS O=term1_shifted[17] S=FE_OFN465_h11_3 A=sll_16/ML_int[3][17]
+ B=sll_16/ML_int[3][9]
XU254 MUX2S $PINS O=sll_16/ML_int[3][17] S=FE_RN_3 A=n63 B=sll_16/ML_int[2][13]
XU255 MUX2S $PINS O=term3_shifted[17] S=FE_RN_1 A=sll_18/ML_int[3][17]
+ B=sll_18/ML_int[3][9]
XU256 MUX2S $PINS O=sll_18/ML_int[3][17] S=FE_OFN361_h13_2 A=n84
+ B=sll_18/ML_int[2][13]
XU257 MUX2S $PINS O=term2_shifted[17] S=n35 A=sll_17/ML_int[3][17]
+ B=sll_17/ML_int[3][9]
XU258 MUX2S $PINS O=sll_17/ML_int[3][17] S=FE_OFN352_h12_2 A=n73
+ B=sll_17/ML_int[2][13]
XU259 MUX2S $PINS O=term1_shifted[18] S=FE_OFN465_h11_3 A=sll_16/ML_int[3][18]
+ B=sll_16/ML_int[3][10]
XU260 MUX2S $PINS O=sll_16/ML_int[3][18] S=FE_RN_3 A=n64 B=sll_16/ML_int[2][14]
XU261 MUX2S $PINS O=term3_shifted[18] S=FE_RN_1 A=sll_18/ML_int[3][18]
+ B=sll_18/ML_int[3][10]
XU262 MUX2S $PINS O=sll_18/ML_int[3][18] S=shf3[2] A=n85 B=sll_18/ML_int[2][14]
XU263 MUX2S $PINS O=term2_shifted[18] S=n35 A=sll_17/ML_int[3][18]
+ B=sll_17/ML_int[3][10]
XU264 MUX2S $PINS O=sll_17/ML_int[3][18] S=FE_OFN352_h12_2 A=n74
+ B=sll_17/ML_int[2][14]
XU265 MUX2S $PINS O=term1_shifted[20] S=FE_OFN465_h11_3 A=sll_16/ML_int[3][20]
+ B=sll_16/ML_int[3][12]
XU266 MUX2S $PINS O=sll_16/ML_int[3][20] S=FE_RN_3 A=term1_in[26] B=n62
XU267 MUX2S $PINS O=term1_shifted[19] S=FE_OFN465_h11_3 A=sll_16/ML_int[3][19]
+ B=sll_16/ML_int[3][11]
XU268 MUX2S $PINS O=sll_16/ML_int[3][19] S=FE_RN_3 A=term1_in[26]
+ B=sll_16/ML_int[2][15]
XU269 MUX2S $PINS O=term3_shifted[20] S=FE_RN_1 A=sll_18/ML_int[3][20]
+ B=sll_18/ML_int[3][12]
XU270 MUX2S $PINS O=sll_18/ML_int[3][20] S=FE_OFN361_h13_2 A=term3_in[26] B=n83
XU271 MUX2S $PINS O=term3_shifted[19] S=FE_RN_1 A=sll_18/ML_int[3][19]
+ B=sll_18/ML_int[3][11]
XU272 MUX2S $PINS O=sll_18/ML_int[3][19] S=FE_OFN361_h13_2 A=term3_in[26]
+ B=sll_18/ML_int[2][15]
XU273 MUX2S $PINS O=term2_shifted[20] S=n35 A=sll_17/ML_int[3][20]
+ B=sll_17/ML_int[3][12]
XU274 MUX2S $PINS O=sll_17/ML_int[3][20] S=FE_OFN352_h12_2 A=term2_in[26] B=n72
XU275 MUX2S $PINS O=term2_shifted[19] S=n35 A=sll_17/ML_int[3][19]
+ B=sll_17/ML_int[3][11]
XU276 MUX2S $PINS O=sll_17/ML_int[3][19] S=FE_OFN352_h12_2 A=term2_in[26]
+ B=sll_17/ML_int[2][15]
XU277 MUX2S $PINS O=term1_shifted[21] S=FE_OFN465_h11_3 A=sll_16/ML_int[3][21]
+ B=sll_16/ML_int[3][13]
XU278 MUX2S $PINS O=sll_16/ML_int[3][21] S=FE_RN_3 A=term1_in[26] B=n63
XU279 MUX2S $PINS O=term3_shifted[21] S=FE_RN_1 A=sll_18/ML_int[3][21]
+ B=sll_18/ML_int[3][13]
XU280 MUX2S $PINS O=sll_18/ML_int[3][21] S=FE_OFN361_h13_2 A=term3_in[26] B=n84
XU281 MUX2S $PINS O=term2_shifted[21] S=n35 A=sll_17/ML_int[3][21]
+ B=sll_17/ML_int[3][13]
XU282 MUX2S $PINS O=sll_17/ML_int[3][21] S=FE_OFN352_h12_2 A=term2_in[26] B=n73
XU283 MUX2S $PINS O=term1_shifted[22] S=FE_OFN465_h11_3 A=sll_16/ML_int[3][22]
+ B=sll_16/ML_int[3][14]
XU284 MUX2S $PINS O=sll_16/ML_int[3][22] S=FE_RN_3 A=term1_in[26] B=n64
XU285 MUX2S $PINS O=term3_shifted[22] S=FE_RN_1 A=sll_18/ML_int[3][22]
+ B=sll_18/ML_int[3][14]
XU286 MUX2S $PINS O=sll_18/ML_int[3][22] S=shf3[2] A=term3_in[26] B=n85
XU287 MUX2S $PINS O=term2_shifted[22] S=n35 A=sll_17/ML_int[3][22]
+ B=sll_17/ML_int[3][14]
XU288 MUX2S $PINS O=sll_17/ML_int[3][22] S=FE_OFN352_h12_2 A=term2_in[26] B=n74
XU289 MUX2S $PINS O=term1_shifted[24] S=FE_OFN465_h11_3 A=term1_in[26]
+ B=sll_16/ML_int[3][16]
XU290 MUX2S $PINS O=term3_shifted[24] S=FE_RN_1 A=term3_in[26]
+ B=sll_18/ML_int[3][16]
XU291 MUX2S $PINS O=term2_shifted[24] S=n35 A=term2_in[26]
+ B=sll_17/ML_int[3][16]
XU292 MUX2S $PINS O=term1_shifted[25] S=FE_OFN465_h11_3 A=term1_in[26]
+ B=sll_16/ML_int[3][17]
XU293 MUX2S $PINS O=term3_shifted[25] S=FE_RN_1 A=term3_in[26]
+ B=sll_18/ML_int[3][17]
XU294 MUX2S $PINS O=term2_shifted[25] S=n35 A=term2_in[26]
+ B=sll_17/ML_int[3][17]
XU295 MUX2S $PINS O=term1_shifted[26] S=FE_OFN465_h11_3 A=term1_in[26]
+ B=sll_16/ML_int[3][18]
XU296 MUX2S $PINS O=term3_shifted[26] S=FE_RN_1 A=term3_in[26]
+ B=sll_18/ML_int[3][18]
XU297 MUX2S $PINS O=term2_shifted[26] S=n35 A=term2_in[26]
+ B=sll_17/ML_int[3][18]
XU299 AO22 $PINS O=N109 A1=N82 A2=FE_OFN155_s12_0 B1=term2_shifted[13]
+ B2=FE_OFN448_n
XU301 MUX2S $PINS O=FE_PHN1423_N235 S=FE_OFN61_FE_DBTN9_n336 A=acc_reg[10]
+ B=acc_reg[14]
XU302 MUX2S $PINS O=N236 S=FE_OFN61_FE_DBTN9_n336 A=acc_reg[11] B=acc_reg[15]
XU303 MUX2S $PINS O=FE_PHN1441_N237 S=FE_OFN61_FE_DBTN9_n336 A=acc_reg[12]
+ B=acc_reg[16]
XU304 MUX2S $PINS O=FE_PHN1434_N238 S=FE_OFN61_FE_DBTN9_n336 A=acc_reg[13]
+ B=acc_reg[17]
XU305 MUX2S $PINS O=N239 S=FE_OFN61_FE_DBTN9_n336 A=acc_reg[14] B=acc_reg[18]
XU306 MUX2S $PINS O=FE_PHN1436_N240 S=FE_OFN61_FE_DBTN9_n336 A=acc_reg[15]
+ B=acc_reg[19]
XU307 MUX2S $PINS O=N242 S=FE_OFN61_FE_DBTN9_n336 A=acc_reg[17] B=acc_reg[21]
XU308 MUX2S $PINS O=N245 S=FE_OFN61_FE_DBTN9_n336 A=FE_PHN1283_acc_reg_20
+ B=acc_reg[24]
XU309 MUX2S $PINS O=N246 S=FE_OFN61_FE_DBTN9_n336 A=acc_reg[21] B=acc_reg[25]
XU314 INV1S $PINS O=n60 I=n55
XU315 INV1S $PINS O=n70 I=n66
XU317 NR2 $PINS O=term1_in[5] I1=FE_OFN81_s11_1 I2=x_in[5]
XU318 NR2P $PINS O=term2_in[5] I1=FE_OFN88_s12_1 I2=x_in[5]
XU319 NR2 $PINS O=term3_in[5] I1=FE_OFN94_s13_1 I2=x_in[5]
XU320 NR2 $PINS O=term1_in[6] I1=FE_OFN81_s11_1 I2=x_in[6]
XU321 NR2 $PINS O=term2_in[6] I1=FE_OFN88_s12_1 I2=x_in[6]
XU322 NR2 $PINS O=term3_in[6] I1=FE_OFN94_s13_1 I2=x_in[6]
XU323 NR2 $PINS O=term1_in[7] I1=FE_OFN81_s11_1 I2=x_in[7]
XU324 NR2 $PINS O=term2_in[7] I1=FE_OFN88_s12_1 I2=x_in[7]
XU325 NR2 $PINS O=term3_in[7] I1=FE_OFN94_s13_1 I2=x_in[7]
XU326 NR2 $PINS O=term1_in[8] I1=FE_OFN81_s11_1 I2=x_in[8]
XU327 NR2 $PINS O=term2_in[8] I1=FE_OFN88_s12_1 I2=x_in[8]
XU328 NR2 $PINS O=term3_in[8] I1=FE_OFN94_s13_1 I2=x_in[8]
XU329 NR2 $PINS O=term1_in[9] I1=FE_OFN81_s11_1 I2=x_in[9]
XU330 NR2 $PINS O=term2_in[9] I1=FE_OFN88_s12_1 I2=x_in[9]
XU331 NR2 $PINS O=term3_in[9] I1=FE_OFN94_s13_1 I2=x_in[9]
XU332 NR2 $PINS O=term1_in[10] I1=FE_OFN81_s11_1 I2=x_in[10]
XU333 NR2 $PINS O=term2_in[10] I1=FE_OFN88_s12_1 I2=x_in[10]
XU334 NR2 $PINS O=term3_in[10] I1=FE_RN_2 I2=x_in[10]
XU339 NR2 $PINS O=term1_in[11] I1=FE_OFN81_s11_1 I2=x_in[11]
XU340 NR2 $PINS O=term2_in[11] I1=FE_OFN88_s12_1 I2=x_in[11]
XU341 NR2 $PINS O=term3_in[11] I1=FE_RN_2 I2=x_in[11]
XU342 NR2 $PINS O=term1_in[12] I1=FE_OFN81_s11_1 I2=x_in[12]
XU343 NR2 $PINS O=term2_in[12] I1=FE_OFN88_s12_1 I2=x_in[12]
XU344 NR2 $PINS O=term3_in[12] I1=FE_RN_2 I2=x_in[12]
XU345 NR2 $PINS O=term1_in[13] I1=FE_OFN81_s11_1 I2=x_in[13]
XU346 NR2 $PINS O=term2_in[13] I1=FE_OFN88_s12_1 I2=x_in[13]
XU347 NR2 $PINS O=term3_in[13] I1=FE_RN_2 I2=x_in[13]
XU348 NR2 $PINS O=term1_in[14] I1=FE_OFN81_s11_1 I2=x_in[14]
XU349 NR2 $PINS O=term2_in[14] I1=sign2[1] I2=x_in[14]
XU350 NR2 $PINS O=term3_in[14] I1=FE_RN_2 I2=x_in[14]
XU351 NR2 $PINS O=term1_in[15] I1=sign1[1] I2=x_in[15]
XU352 NR2 $PINS O=term1_in[26] I1=x_in[16] I2=sign1[1]
XU354 NR2 $PINS O=term2_in[15] I1=sign2[1] I2=x_in[15]
XU355 NR2 $PINS O=term3_in[15] I1=FE_RN_2 I2=x_in[15]
XU356 NR2 $PINS O=term2_in[26] I1=x_in[16] I2=sign2[1]
XU357 NR2 $PINS O=term3_in[26] I1=x_in[16] I2=FE_RN_2
XU363 INV1S $PINS O=n29 I=FE_OFN93_h12_0
XU386 AN2 $PINS O=base_val[2] I1=acc_reg[2] I2=n105
XU387 MOAI1S $PINS O=base_val[9] A1=FE_OFN61_FE_DBTN9_n336 A2=n105
+ B1=acc_reg[9] B2=n105
XU388 AN2 $PINS O=base_val[10] I1=acc_reg[10] I2=FE_OFN459_n105
XU389 AN2 $PINS O=base_val[12] I1=acc_reg[12] I2=FE_OFN459_n105
XU390 AN2 $PINS O=base_val[14] I1=acc_reg[14] I2=FE_OFN459_n105
XU391 AN2 $PINS O=base_val[15] I1=acc_reg[15] I2=FE_OFN459_n105
XU392 AN2 $PINS O=base_val[11] I1=acc_reg[11] I2=FE_OFN459_n105
XU393 AN2 $PINS O=base_val[17] I1=acc_reg[17] I2=FE_OFN459_n105
XU394 AN2 $PINS O=base_val[18] I1=acc_reg[18] I2=FE_OFN459_n105
XU395 AN2 $PINS O=base_val[19] I1=acc_reg[19] I2=FE_OFN459_n105
XU396 AN2 $PINS O=base_val[20] I1=acc_reg[20] I2=FE_OFN460_n105
XU397 AN2 $PINS O=base_val[8] I1=acc_reg[8] I2=n105
XU398 AN2 $PINS O=base_val[7] I1=acc_reg[7] I2=n105
XU399 AN2 $PINS O=base_val[21] I1=acc_reg[21] I2=FE_OFN460_n105
XU400 AN2 $PINS O=base_val[6] I1=acc_reg[6] I2=n105
XU401 AN2 $PINS O=base_val[22] I1=acc_reg[22] I2=FE_OFN460_n105
XU402 AN2 $PINS O=base_val[5] I1=acc_reg[5] I2=n105
XU403 AN2 $PINS O=base_val[23] I1=acc_reg[23] I2=FE_OFN460_n105
XU404 AN2 $PINS O=base_val[24] I1=acc_reg[24] I2=FE_OFN460_n105
XU405 AN2 $PINS O=base_val[4] I1=acc_reg[4] I2=n105
XU406 AN2 $PINS O=base_val[3] I1=acc_reg[3] I2=n105
XU407 AN2 $PINS O=base_val[25] I1=acc_reg[25] I2=FE_OFN460_n105
XU409 AN2 $PINS O=N234 I1=en I2=calc_done
XU412 AN2 $PINS O=base_val[26] I1=N251 I2=FE_OFN460_n105
XU414 INV1S $PINS O=n71 I=n5
XU415 INV1S $PINS O=n61 I=n56
XU416 INV1S $PINS O=n82 I=n77
XU417 NR2 $PINS O=sll_16/ML_int[3][0] I1=FE_OFN85_h11_2 I2=n55
XU418 NR2 $PINS O=sll_16/ML_int[3][1] I1=FE_OFN85_h11_2 I2=n56
XU419 AN2 $PINS O=term1_shifted[4] I1=sll_16/ML_int[3][4] I2=n45
XU420 AN2 $PINS O=term1_shifted[5] I1=sll_16/ML_int[3][5] I2=n45
XU421 AN2 $PINS O=term1_shifted[6] I1=sll_16/ML_int[3][6] I2=n45
XU422 AN2 $PINS O=term1_shifted[7] I1=sll_16/ML_int[3][7] I2=n45
XU423 MUX2 $PINS O=n63 S=n41 A=term1_in[26] B=sll_16/ML_int[1][15]
XU424 MUX2 $PINS O=n64 S=n41 A=term1_in[26] B=n65
XU425 MUX2 $PINS O=n65 S=shf1[0] A=term1_in[26] B=term1_in[15]
XU426 NR2 $PINS O=sll_17/ML_int[3][0] I1=shf2[2] I2=n66
XU427 NR2 $PINS O=sll_17/ML_int[3][1] I1=shf2[2] I2=n5
XU428 NR2 $PINS O=sll_17/ML_int[3][2] I1=shf2[2] I2=n69
XU429 NR2 $PINS O=sll_17/ML_int[3][3] I1=shf2[2] I2=n68
XU430 AN2T $PINS O=term2_shifted[4] I1=sll_17/ML_int[3][4] I2=shf2[3]
XU431 AN2 $PINS O=term2_shifted[5] I1=sll_17/ML_int[3][5] I2=shf2[3]
XU432 AN2 $PINS O=term2_shifted[6] I1=sll_17/ML_int[3][6] I2=shf2[3]
XU433 AN2 $PINS O=term2_shifted[7] I1=sll_17/ML_int[3][7] I2=shf2[3]
XU434 MUX2 $PINS O=n73 S=n31 A=term2_in[26] B=sll_17/ML_int[1][15]
XU435 MUX2 $PINS O=n74 S=n31 A=term2_in[26] B=n75
XU436 MUX2 $PINS O=n75 S=FE_OFN93_h12_0 A=term2_in[26] B=term2_in[15]
XU437 NR2 $PINS O=sll_18/ML_int[3][0] I1=FE_OFN97_h13_2 I2=n76
XU438 NR2 $PINS O=sll_18/ML_int[3][1] I1=FE_OFN97_h13_2 I2=n77
XU439 NR2 $PINS O=sll_18/ML_int[3][2] I1=FE_OFN97_h13_2 I2=n80
XU441 AN2T $PINS O=term3_shifted[4] I1=sll_18/ML_int[3][4] I2=FE_OFN96_h13_3
XU442 AN2T $PINS O=term3_shifted[5] I1=sll_18/ML_int[3][5] I2=FE_OFN96_h13_3
XU443 AN2 $PINS O=term3_shifted[6] I1=sll_18/ML_int[3][6] I2=FE_OFN96_h13_3
XU444 MUX2 $PINS O=n84 S=n19 A=term3_in[26] B=sll_18/ML_int[1][15]
XU445 MUX2 $PINS O=n85 S=n19 A=term3_in[26] B=n86
XU446 MUX2 $PINS O=n86 S=FE_RN_4 A=term3_in[26] B=term3_in[15]
XU447 MUX2 $PINS O=FE_PHN1852_N241 S=FE_OFN61_FE_DBTN9_n336 A=acc_reg[16]
+ B=FE_PHN1283_acc_reg_20
XU448 MUX2 $PINS O=N243 S=FE_OFN61_FE_DBTN9_n336 A=acc_reg[18] B=acc_reg[22]
XU449 MUX2 $PINS O=N244 S=FE_OFN61_FE_DBTN9_n336 A=acc_reg[19] B=acc_reg[23]
XU3 NR2T $PINS O=term3_shifted[1] I1=n78 I2=n77
XU4 ND2 $PINS O=n78 I1=n21 I2=FE_OFN96_h13_3
XU5 AN2B1T $PINS O=sll_16/ML_int[1][0] I1=term1_in[0] B1=FE_OFN87_h11_0
XU7 INV2 $PINS O=n6 I=sll_18/ML_int[1][0]
XU8 AN2B1 $PINS O=sll_18/ML_int[1][0] I1=term3_in[0] B1=FE_OFN99_h13_0
XU9 NR2P $PINS O=term1_in[3] I1=FE_OFN81_s11_1 I2=x_in[3]
XU17 NR2 $PINS O=term2_shifted[3] I1=n67 I2=n68
XU21 ND2P $PINS O=n77 I1=sll_18/ML_int[1][1] I2=shf3[1]
XU22 NR2T $PINS O=term2_in[3] I1=FE_OFN88_s12_1 I2=x_in[3]
XU23 NR2P $PINS O=term2_shifted[0] I1=n13 I2=n14
XU24 NR2T $PINS O=term1_shifted[2] I1=n57 I2=n59
XU27 INV1S $PINS O=n58 I=sll_16/ML_int[2][3]
XU34 OR2 $PINS O=n57 I1=FE_OFN85_h11_2 I2=FE_OFN84_h11_3
XU35 ND2P $PINS O=n55 I1=sll_16/ML_int[1][0] I2=shf1[1]
XU36 NR2T $PINS O=term3_shifted[2] I1=n78 I2=n80
XU37 NR2P $PINS O=term1_shifted[1] I1=n57 I2=n56
XU38 NR2T $PINS O=term1_shifted[0] I1=n57 I2=n55
XU40 AN2 $PINS O=sll_18/ML_int[3][3] I1=n21 I2=sll_18/ML_int[2][3]
XU43 MUX2 $PINS O=N248 S=stage_sel A=acc_reg[23] B=FE_PHN1366_N251
XU47 AN2T $PINS O=sll_17/ML_int[1][0] I1=term2_in[0] I2=n29
XU53 ND2P $PINS O=n56 I1=sll_16/ML_int[1][1] I2=shf1[1]
XU55 NR2T $PINS O=term1_in[1] I1=FE_OFN81_s11_1 I2=x_in[1]
XU70 NR2P $PINS O=term3_in[1] I1=FE_OFN94_s13_1 I2=x_in[1]
XU73 NR2P $PINS O=term2_in[0] I1=FE_OFN88_s12_1 I2=x_in[0]
XU91 NR2P $PINS O=term1_in[0] I1=FE_OFN81_s11_1 I2=x_in[0]
XU98 NR2P $PINS O=term3_in[0] I1=FE_OFN94_s13_1 I2=x_in[0]
XU108 NR2T $PINS O=term3_shifted[0] I1=n6 I2=n7
XU113 INV2 $PINS O=n68 I=sll_17/ML_int[2][3]
Xclk_gate_y_out_reg SNPS_CLOCK_GATE_HIGH_PE_Shift_Add_4 $PINS EN=N234
+ ENCLK=CTS_12 CLK=clk
Xsub_28_3 PE_Shift_Add_4_DW01_sub_0_DW01_sub_12 $PINS A[26]=net45572
+ A[25]=net45572 A[24]=net45572 A[23]=net45572 A[22]=net45572 A[21]=net45572
+ A[20]=net45572 A[19]=net45572 A[18]=net45572 A[17]=net45572 A[16]=net45572
+ A[15]=net45572 A[14]=net45572 A[13]=net45572 A[12]=net45572 A[11]=net45572
+ A[10]=net45572 A[9]=net45572 A[8]=net45572 A[7]=net45572 A[6]=net45572
+ A[5]=net45572 A[4]=net45572 A[3]=net45572 A[2]=net45572 A[1]=net45572
+ A[0]=net45572 B[26]=term3_shifted[26] B[25]=term3_shifted[25]
+ B[24]=term3_shifted[24] B[23]=term3_shifted[23] B[22]=term3_shifted[22]
+ B[21]=term3_shifted[21] B[20]=term3_shifted[20] B[19]=term3_shifted[19]
+ B[18]=term3_shifted[18] B[17]=term3_shifted[17] B[16]=term3_shifted[16]
+ B[15]=term3_shifted[15] B[14]=term3_shifted[14] B[13]=term3_shifted[13]
+ B[12]=term3_shifted[12] B[11]=term3_shifted[11] B[10]=term3_shifted[10]
+ B[9]=term3_shifted[9] B[8]=term3_shifted[8] B[7]=term3_shifted[7]
+ B[6]=term3_shifted[6] B[5]=term3_shifted[5] B[4]=term3_shifted[4]
+ B[3]=term3_shifted[3] B[2]=term3_shifted[2] B[1]=term3_shifted[1]
+ B[0]=term3_shifted[0] CI=net45572 DIFF[26]=N150 DIFF[25]=N149 DIFF[24]=N148
+ DIFF[23]=N147 DIFF[22]=N146 DIFF[21]=N145 DIFF[20]=N144 DIFF[19]=N143
+ DIFF[18]=N142 DIFF[17]=N141 DIFF[16]=N140 DIFF[15]=N139 DIFF[14]=N138
+ DIFF[13]=N137 DIFF[12]=N136 DIFF[11]=N135 DIFF[10]=N134 DIFF[9]=N133
+ DIFF[8]=N132 DIFF[7]=N131 DIFF[6]=N130 DIFF[5]=N129 DIFF[4]=N128 DIFF[3]=N127
+ DIFF[2]=N126 DIFF[1]=N125 DIFF[0]=N124
Xsub_28_2 PE_Shift_Add_4_DW01_sub_1_DW01_sub_13 $PINS A[26]=net45572
+ A[25]=net45572 A[24]=net45572 A[23]=net45572 A[22]=net45572 A[21]=net45572
+ A[20]=net45572 A[19]=net45572 A[18]=net45572 A[17]=net45572 A[16]=net45572
+ A[15]=net45572 A[14]=net45572 A[13]=net45572 A[12]=net45572 A[11]=net45572
+ A[10]=net45572 A[9]=net45572 A[8]=net45572 A[7]=net45572 A[6]=net45572
+ A[5]=net45572 A[4]=net45572 A[3]=net45572 A[2]=net45572 A[1]=net45572
+ A[0]=net45572 B[26]=term2_shifted[26] B[25]=term2_shifted[25]
+ B[24]=term2_shifted[24] B[23]=term2_shifted[23] B[22]=term2_shifted[22]
+ B[21]=term2_shifted[21] B[20]=term2_shifted[20] B[19]=term2_shifted[19]
+ B[18]=term2_shifted[18] B[17]=term2_shifted[17] B[16]=term2_shifted[16]
+ B[15]=term2_shifted[15] B[14]=term2_shifted[14] B[13]=term2_shifted[13]
+ B[12]=term2_shifted[12] B[11]=term2_shifted[11] B[10]=term2_shifted[10]
+ B[9]=term2_shifted[9] B[8]=term2_shifted[8] B[7]=term2_shifted[7]
+ B[6]=term2_shifted[6] B[5]=term2_shifted[5] B[4]=term2_shifted[4]
+ B[3]=term2_shifted[3] B[2]=term2_shifted[2] B[1]=n107 B[0]=N691 CI=net45572
+ DIFF[26]=N95 DIFF[25]=N94 DIFF[24]=N93 DIFF[23]=N92 DIFF[22]=N91 DIFF[21]=N90
+ DIFF[20]=N89 DIFF[19]=N88 DIFF[18]=N87 DIFF[17]=N86 DIFF[16]=N85 DIFF[15]=N84
+ DIFF[14]=N83 DIFF[13]=N82 DIFF[12]=N81 DIFF[11]=N80 DIFF[10]=N79 DIFF[9]=N78
+ DIFF[8]=N77 DIFF[7]=N76 DIFF[6]=N75 DIFF[5]=N74 DIFF[4]=N73 DIFF[3]=N72
+ DIFF[2]=N71 DIFF[1]=N70 DIFF[0]=N69
Xsub_28 PE_Shift_Add_4_DW01_sub_2_DW01_sub_14 $PINS A[26]=net45572
+ A[25]=net45572 A[24]=net45572 A[23]=net45572 A[22]=net45572 A[21]=net45572
+ A[20]=net45572 A[19]=net45572 A[18]=net45572 A[17]=net45572 A[16]=net45572
+ A[15]=net45572 A[14]=net45572 A[13]=net45572 A[12]=net45572 A[11]=net45572
+ A[10]=net45572 A[9]=net45572 A[8]=net45572 A[7]=net45572 A[6]=net45572
+ A[5]=net45572 A[4]=net45572 A[3]=net45572 A[2]=net45572 A[1]=net45572
+ A[0]=net45572 B[26]=term1_shifted[26] B[25]=term1_shifted[25]
+ B[24]=term1_shifted[24] B[23]=term1_shifted[23] B[22]=term1_shifted[22]
+ B[21]=term1_shifted[21] B[20]=term1_shifted[20] B[19]=term1_shifted[19]
+ B[18]=term1_shifted[18] B[17]=term1_shifted[17] B[16]=term1_shifted[16]
+ B[15]=term1_shifted[15] B[14]=term1_shifted[14] B[13]=term1_shifted[13]
+ B[12]=term1_shifted[12] B[11]=term1_shifted[11] B[10]=term1_shifted[10]
+ B[9]=term1_shifted[9] B[8]=term1_shifted[8] B[7]=term1_shifted[7]
+ B[6]=term1_shifted[6] B[5]=term1_shifted[5] B[4]=term1_shifted[4]
+ B[3]=term1_shifted[3] B[2]=term1_shifted[2] B[1]=term1_shifted[1]
+ B[0]=term1_shifted[0] CI=net45572 DIFF[26]=N40 DIFF[25]=N39 DIFF[24]=N38
+ DIFF[23]=N37 DIFF[22]=N36 DIFF[21]=N35 DIFF[20]=N34 DIFF[19]=N33 DIFF[18]=N32
+ DIFF[17]=N31 DIFF[16]=N30 DIFF[15]=N29 DIFF[14]=N28 DIFF[13]=N27 DIFF[12]=N26
+ DIFF[11]=N25 DIFF[10]=N24 DIFF[9]=N23 DIFF[8]=N22 DIFF[7]=N21 DIFF[6]=N20
+ DIFF[5]=N19 DIFF[4]=N18 DIFF[3]=N17 DIFF[2]=N16 DIFF[1]=N15 DIFF[0]=N14
Xadd_1_root_add_0_root_add_28_3 PE_Shift_Add_4_DW01_add_2_DW01_add_22 $PINS
+ A[26]=N67 A[25]=N66 A[24]=N65 A[23]=N64 A[22]=N63 A[21]=N62 A[20]=N61 A[19]=N60
+ A[18]=N59 A[17]=N58 A[16]=N57 A[15]=N56 A[14]=N55 A[13]=N54 A[12]=N53 A[11]=N52
+ A[10]=N51 A[9]=N50 A[8]=N49 A[7]=N48 A[6]=N47 A[5]=N46 A[4]=N45 A[3]=N44
+ A[2]=N43 A[1]=N42 A[0]=N41 B[26]=N177 B[25]=N176 B[24]=N175 B[23]=N174
+ B[22]=N173 B[21]=N172 B[20]=N171 B[19]=N170 B[18]=N169 B[17]=N168 B[16]=N167
+ B[15]=N166 B[14]=N165 B[13]=N164 B[12]=N163 B[11]=N162 B[10]=N161 B[9]=N160
+ B[8]=N159 B[7]=N158 B[6]=N157 B[5]=N156 B[4]=N155 B[3]=N154 B[2]=N153 B[1]=N152
+ B[0]=N151 CI=net45572 SUM[26]=N204 SUM[25]=N203 SUM[24]=N202 SUM[23]=N201
+ SUM[22]=N200 SUM[21]=N199 SUM[20]=N198 SUM[19]=N197 SUM[18]=N196 SUM[17]=N195
+ SUM[16]=N194 SUM[15]=N193 SUM[14]=N192 SUM[13]=N191 SUM[12]=N190 SUM[11]=N189
+ SUM[10]=N188 SUM[9]=N187 SUM[8]=N186 SUM[7]=N185 SUM[6]=N184 SUM[5]=N183
+ SUM[4]=N182 SUM[3]=N181 SUM[2]=N180 SUM[1]=N179 SUM[0]=N178
Xadd_2_root_add_0_root_add_28_3 PE_Shift_Add_4_DW01_add_1_DW01_add_21 $PINS
+ A[26]=base_val[26] A[25]=base_val[25] A[24]=base_val[24] A[23]=base_val[23]
+ A[22]=base_val[22] A[21]=base_val[21] A[20]=base_val[20] A[19]=base_val[19]
+ A[18]=base_val[18] A[17]=base_val[17] A[16]=base_val[16] A[15]=base_val[15]
+ A[14]=base_val[14] A[13]=base_val[13] A[12]=base_val[12] A[11]=base_val[11]
+ A[10]=base_val[10] A[9]=base_val[9] A[8]=base_val[8] A[7]=base_val[7]
+ A[6]=base_val[6] A[5]=base_val[5] A[4]=base_val[4] A[3]=base_val[3]
+ A[2]=base_val[2] A[1]=base_val[1] A[0]=base_val[0] B[26]=N122 B[25]=N121
+ B[24]=N120 B[23]=N119 B[22]=N118 B[21]=N117 B[20]=N116 B[19]=N115 B[18]=N114
+ B[17]=N113 B[16]=N112 B[15]=N111 B[14]=N110 B[13]=N109 B[12]=N108 B[11]=N107
+ B[10]=N106 B[9]=N105 B[8]=N104 B[7]=N103 B[6]=N102 B[5]=N101 B[4]=N100 B[3]=N99
+ B[2]=N98 B[1]=N97 B[0]=N96 CI=net45572 SUM[26]=N231 SUM[25]=N230 SUM[24]=N229
+ SUM[23]=N228 SUM[22]=N227 SUM[21]=N226 SUM[20]=N225 SUM[19]=N224 SUM[18]=N223
+ SUM[17]=N222 SUM[16]=N221 SUM[15]=N220 SUM[14]=N219 SUM[13]=N218 SUM[12]=N217
+ SUM[11]=N216 SUM[10]=N215 SUM[9]=N214 SUM[8]=N213 SUM[7]=N212 SUM[6]=N211
+ SUM[5]=N210 SUM[4]=N209 SUM[3]=N208 SUM[2]=N207 SUM[1]=N206 SUM[0]=N205
Xadd_0_root_add_0_root_add_28_3 PE_Shift_Add_4_DW01_add_0_DW01_add_20 $PINS
+ A[26]=N204 A[25]=N203 A[24]=N202 A[23]=N201 A[22]=N200 A[21]=N199 A[20]=N198
+ A[19]=N197 A[18]=N196 A[17]=N195 A[16]=N194 A[15]=N193 A[14]=N192 A[13]=N191
+ A[12]=N190 A[11]=N189 A[10]=N188 A[9]=N187 A[8]=FE_OCPN1141_N186 A[7]=N185
+ A[6]=N184 A[5]=N183 A[4]=N182 A[3]=N181 A[2]=N180 A[1]=N179 A[0]=N178
+ B[26]=N231 B[25]=N230 B[24]=N229 B[23]=N228 B[22]=N227 B[21]=N226 B[20]=N225
+ B[19]=N224 B[18]=N223 B[17]=N222 B[16]=N221 B[15]=N220 B[14]=N219 B[13]=N218
+ B[12]=N217 B[11]=N216 B[10]=N215 B[9]=N214 B[8]=N213 B[7]=N212 B[6]=N211
+ B[5]=N210 B[4]=N209 B[3]=N208 B[2]=N207 B[1]=N206 B[0]=N205 CI=net45572
+ SUM[26]=next_acc[26] SUM[25]=next_acc[25] SUM[24]=next_acc[24]
+ SUM[23]=next_acc[23] SUM[22]=next_acc[22] SUM[21]=next_acc[21]
+ SUM[20]=next_acc[20] SUM[19]=next_acc[19] SUM[18]=next_acc[18]
+ SUM[17]=next_acc[17] SUM[16]=next_acc[16] SUM[15]=next_acc[15]
+ SUM[14]=next_acc[14] SUM[13]=next_acc[13] SUM[12]=next_acc[12]
+ SUM[11]=next_acc[11] SUM[10]=next_acc[10] SUM[9]=next_acc[9] SUM[8]=next_acc[8]
+ SUM[7]=next_acc[7] SUM[6]=next_acc[6] SUM[5]=next_acc[5] SUM[4]=next_acc[4]
+ SUM[3]=next_acc[3] SUM[2]=next_acc[2] SUM[1]=next_acc[1] SUM[0]=next_acc[0]
.ENDS

.SUBCKT SNPS_CLOCK_GATE_HIGH_PE_Shift_Add_3 EN ENCLK CLK
*.CONNECT ENCLK net2255
*.CONNECT net2256 EN
XFE_PHC1312_net2259 DELC $PINS O=FE_PHN1312_net2259 I=net2259
Xlatch QDBHN $PINS Q=net2259 D=net2256 CKB=CLK
Xmain_gate AN2T $PINS O=net2255 I1=FE_PHN1312_net2259 I2=CLK
.ENDS

.SUBCKT PE_Shift_Add_3_DW01_sub_0_DW01_sub_9 A[26] A[25] A[24] A[23] A[22]
+ A[21] A[20] A[19] A[18] A[17] A[16] A[15] A[14] A[13] A[12] A[11] A[10] A[9]
+ A[8] A[7] A[6] A[5] A[4] A[3] A[2] A[1] A[0] B[26] B[25] B[24] B[23] B[22]
+ B[21] B[20] B[19] B[18] B[17] B[16] B[15] B[14] B[13] B[12] B[11] B[10] B[9]
+ B[8] B[7] B[6] B[5] B[4] B[3] B[2] B[1] B[0] CI DIFF[26] DIFF[25] DIFF[24]
+ DIFF[23] DIFF[22] DIFF[21] DIFF[20] DIFF[19] DIFF[18] DIFF[17] DIFF[16]
+ DIFF[15] DIFF[14] DIFF[13] DIFF[12] DIFF[11] DIFF[10] DIFF[9] DIFF[8] DIFF[7]
+ DIFF[6] DIFF[5] DIFF[4] DIFF[3] DIFF[2] DIFF[1] DIFF[0] CO
*.CONNECT DIFF[0] B[0]
XFE_RC_77_0 XOR2HS $PINS O=DIFF[1] I1=n54 I2=n53
XFE_RC_3977_0 OAI12HS $PINS O=DIFF[4] A1=n2 B1=n5 B2=B[4]
XFE_RC_3937_0 INV1S $PINS O=FE_RN_2564_0 I=n38
XFE_RC_3936_0 MXL2HS $PINS OB=DIFF[16] S=n13 A=FE_RN_2564_0 B=n38
XFE_RC_3701_0 INV1S $PINS O=FE_RN_2432_0 I=n52
XFE_RC_3700_0 MXL2HS $PINS OB=DIFF[2] S=n3 A=FE_RN_2432_0 B=n52
XFE_RC_3479_0 INV1S $PINS O=FE_RN_2271_0 I=n36
XFE_RC_3478_0 MXL2HS $PINS OB=DIFF[18] S=n15 A=FE_RN_2271_0 B=n36
XFE_OFC817_term3_shifted_8 INV1S $PINS O=n46 I=B[8]
XFE_OFC734_term3_shifted_5 INV1S $PINS O=n49 I=B[5]
XU1 INV2 $PINS O=n52 I=B[2]
XU2 NR2P $PINS O=n4 I1=B[2] I2=n1
XU3 INV2 $PINS O=n1 I=n3
XU5 INV1S $PINS O=n51 I=B[3]
XU6 AN2T $PINS O=n5 I1=n4 I2=n51
XU7 ND2 $PINS O=n2 I1=B[4] I2=n5
XU8 INV2 $PINS O=n53 I=B[1]
XU9 INV1S $PINS O=n45 I=B[9]
XU11 INV2 $PINS O=n54 I=B[0]
XU13 AN2T $PINS O=n3 I1=n53 I2=n54
XU14 AN2T $PINS O=n6 I1=n46 I2=n26
XU15 AN2 $PINS O=n7 I1=n45 I2=n6
XU16 AN2T $PINS O=n8 I1=n44 I2=n7
XU17 AN2T $PINS O=n9 I1=n43 I2=n8
XU18 AN2 $PINS O=n10 I1=n42 I2=n9
XU19 AN2T $PINS O=n11 I1=n41 I2=n10
XU20 AN2 $PINS O=n12 I1=n40 I2=n11
XU21 AN2 $PINS O=n13 I1=n39 I2=n12
XU22 AN2T $PINS O=n14 I1=n38 I2=n13
XU23 AN2 $PINS O=n15 I1=n37 I2=n14
XU24 AN2 $PINS O=n16 I1=n36 I2=n15
XU25 AN2 $PINS O=n17 I1=n35 I2=n16
XU26 AN2 $PINS O=n18 I1=n34 I2=n17
XU27 AN2 $PINS O=n19 I1=n33 I2=n18
XU28 AN2 $PINS O=n20 I1=n32 I2=n19
XU29 AN2 $PINS O=n21 I1=n31 I2=n20
XU30 AN2 $PINS O=n22 I1=n30 I2=n21
XU32 AN2T $PINS O=n24 I1=n49 I2=n23
XU33 AN2T $PINS O=n25 I1=n48 I2=n24
XU35 AN2T $PINS O=n26 I1=n47 I2=n25
XU36 INV1S $PINS O=n44 I=B[10]
XU37 INV1S $PINS O=n43 I=B[11]
XU38 INV1S $PINS O=n42 I=B[12]
XU39 XOR2HS $PINS O=DIFF[26] I1=B[26] I2=n28
XU40 INV1S $PINS O=n41 I=B[13]
XU41 INV1S $PINS O=n40 I=B[14]
XU42 INV1S $PINS O=n39 I=B[15]
XU43 INV1S $PINS O=n38 I=B[16]
XU44 INV1S $PINS O=n37 I=B[17]
XU45 INV1S $PINS O=n36 I=B[18]
XU46 INV1S $PINS O=n35 I=B[19]
XU47 INV1S $PINS O=n34 I=B[20]
XU48 INV1S $PINS O=n33 I=B[21]
XU49 INV1S $PINS O=n32 I=B[22]
XU50 INV1S $PINS O=n31 I=B[23]
XU51 INV1S $PINS O=n30 I=B[24]
XU52 INV1S $PINS O=n29 I=B[25]
XU55 INV1S $PINS O=n48 I=B[6]
XU56 INV1S $PINS O=n47 I=B[7]
XU57 XOR2HS $PINS O=DIFF[3] I1=n51 I2=n4
XU58 XOR2HS $PINS O=DIFF[5] I1=n49 I2=n23
XU59 XOR2HS $PINS O=DIFF[6] I1=n48 I2=n24
XU60 XOR2HS $PINS O=DIFF[7] I1=n47 I2=n25
XU61 XOR2HS $PINS O=DIFF[8] I1=n46 I2=n26
XU62 XOR2HS $PINS O=DIFF[10] I1=n44 I2=n7
XU63 XOR2HS $PINS O=DIFF[9] I1=n45 I2=n6
XU64 XOR2HS $PINS O=DIFF[12] I1=n42 I2=n9
XU65 XOR2HS $PINS O=DIFF[11] I1=n43 I2=n8
XU66 XOR2HS $PINS O=DIFF[13] I1=n41 I2=n10
XU67 XOR2HS $PINS O=DIFF[14] I1=n40 I2=n11
XU68 XOR2HS $PINS O=DIFF[15] I1=n39 I2=n12
XU70 XOR2HS $PINS O=DIFF[17] I1=n37 I2=n14
XU72 XOR2HS $PINS O=DIFF[19] I1=n35 I2=n16
XU73 XOR2HS $PINS O=DIFF[20] I1=n34 I2=n17
XU74 XOR2HS $PINS O=DIFF[21] I1=n33 I2=n18
XU75 XOR2HS $PINS O=DIFF[22] I1=n32 I2=n19
XU76 XOR2HS $PINS O=DIFF[23] I1=n31 I2=n20
XU77 XOR2HS $PINS O=DIFF[24] I1=n30 I2=n21
XU78 XOR2HS $PINS O=DIFF[25] I1=n29 I2=n22
XU80 ND2 $PINS O=n28 I1=n29 I2=n22
XU10 NR2 $PINS O=n23 I1=B[4] I2=n55
XU31 INV1S $PINS O=n55 I=n5
.ENDS

.SUBCKT PE_Shift_Add_3_DW01_sub_1_DW01_sub_10 A[26] A[25] A[24] A[23] A[22]
+ A[21] A[20] A[19] A[18] A[17] A[16] A[15] A[14] A[13] A[12] A[11] A[10] A[9]
+ A[8] A[7] A[6] A[5] A[4] A[3] A[2] A[1] A[0] B[26] B[25] B[24] B[23] B[22]
+ B[21] B[20] B[19] B[18] B[17] B[16] B[15] B[14] B[13] B[12] B[11] B[10] B[9]
+ B[8] B[7] B[6] B[5] B[4] B[3] B[2] B[1] B[0] CI DIFF[26] DIFF[25] DIFF[24]
+ DIFF[23] DIFF[22] DIFF[21] DIFF[20] DIFF[19] DIFF[18] DIFF[17] DIFF[16]
+ DIFF[15] DIFF[14] DIFF[13] DIFF[12] DIFF[11] DIFF[10] DIFF[9] DIFF[8] DIFF[7]
+ DIFF[6] DIFF[5] DIFF[4] DIFF[3] DIFF[2] DIFF[1] DIFF[0] CO
*.CONNECT DIFF[0] B[0]
XFE_RC_316_0 XOR2HS $PINS O=DIFF[3] I1=n2 I2=n49
XFE_RC_176_0 INV1S $PINS O=FE_RN_82_0 I=n46
XFE_RC_175_0 MXL2HS $PINS OB=DIFF[6] S=n22 A=FE_RN_82_0 B=n46
XFE_RC_3898_0 AN2 $PINS O=FE_RN_2550_0 I1=n38 I2=n39
XFE_RC_3897_0 AN2 $PINS O=n10 I1=FE_RN_2550_0 I2=n8
XFE_RC_3570_0 XOR2HS $PINS O=DIFF[1] I1=n51 I2=n52
XFE_RC_975_0 XOR2HS $PINS O=DIFF[4] I1=n3 I2=n48
XFE_RC_404_0 XOR2HS $PINS O=DIFF[2] I1=n1 I2=n50
XFE_OFC822_term2_shifted_6 INV1S $PINS O=n46 I=B[6]
XFE_OFC741_n1 INV2 $PINS O=n53 I=n1
XU1 INV2 $PINS O=n52 I=B[0]
XU2 INV2 $PINS O=n50 I=B[2]
XU6 INV1S $PINS O=n43 I=B[9]
XU8 INV1S $PINS O=n48 I=B[4]
XU9 AN2 $PINS O=n1 I1=n52 I2=n51
XU10 ND2S $PINS O=n26 I1=n27 I2=n20
XU12 AN2 $PINS O=n3 I1=n2 I2=n49
XU13 AN2 $PINS O=n4 I1=n44 I2=n24
XU14 AN2 $PINS O=n5 I1=n43 I2=n4
XU15 AN2 $PINS O=n6 I1=n42 I2=n5
XU16 AN2 $PINS O=n7 I1=n41 I2=n6
XU17 AN2 $PINS O=n8 I1=n40 I2=n7
XU18 AN2 $PINS O=n9 I1=n39 I2=n8
XU20 AN2 $PINS O=n11 I1=n37 I2=n10
XU21 AN2 $PINS O=n12 I1=n36 I2=n11
XU22 AN2 $PINS O=n13 I1=n35 I2=n12
XU23 AN2 $PINS O=n14 I1=n34 I2=n13
XU24 AN2 $PINS O=n15 I1=n33 I2=n14
XU25 AN2 $PINS O=n16 I1=n32 I2=n15
XU26 AN2 $PINS O=n17 I1=n31 I2=n16
XU27 AN2 $PINS O=n18 I1=n30 I2=n17
XU28 AN2 $PINS O=n19 I1=n29 I2=n18
XU29 AN2 $PINS O=n20 I1=n28 I2=n19
XU30 AN2 $PINS O=n21 I1=n48 I2=n3
XU31 AN2 $PINS O=n22 I1=n47 I2=n21
XU32 AN2 $PINS O=n23 I1=n46 I2=n22
XU33 INV1S $PINS O=n44 I=B[8]
XU34 AN2 $PINS O=n24 I1=n45 I2=n23
XU35 INV1S $PINS O=n42 I=B[10]
XU36 INV1S $PINS O=n41 I=B[11]
XU37 INV1S $PINS O=n40 I=B[12]
XU38 INV1S $PINS O=n39 I=B[13]
XU39 INV1S $PINS O=n38 I=B[14]
XU40 INV1S $PINS O=n37 I=B[15]
XU41 INV1S $PINS O=n36 I=B[16]
XU42 INV1S $PINS O=n35 I=B[17]
XU43 INV1S $PINS O=n34 I=B[18]
XU44 INV1S $PINS O=n33 I=B[19]
XU45 INV1S $PINS O=n32 I=B[20]
XU46 INV1S $PINS O=n31 I=B[21]
XU47 INV1S $PINS O=n30 I=B[22]
XU48 INV1S $PINS O=n29 I=B[23]
XU49 INV1S $PINS O=n28 I=B[24]
XU50 INV1S $PINS O=n27 I=B[25]
XU51 INV1S $PINS O=n47 I=B[5]
XU53 INV1S $PINS O=n45 I=B[7]
XU54 XOR2HS $PINS O=DIFF[26] I1=B[26] I2=n26
XU55 XOR2HS $PINS O=DIFF[9] I1=n43 I2=n4
XU56 XOR2HS $PINS O=DIFF[10] I1=n42 I2=n5
XU57 XOR2HS $PINS O=DIFF[8] I1=n44 I2=n24
XU59 XOR2HS $PINS O=DIFF[7] I1=n45 I2=n23
XU60 XOR2HS $PINS O=DIFF[5] I1=n47 I2=n21
XU63 XOR2HS $PINS O=DIFF[11] I1=n41 I2=n6
XU64 XOR2HS $PINS O=DIFF[12] I1=n40 I2=n7
XU65 XOR2HS $PINS O=DIFF[13] I1=n39 I2=n8
XU66 XOR2HS $PINS O=DIFF[14] I1=n38 I2=n9
XU67 XOR2HS $PINS O=DIFF[15] I1=n37 I2=n10
XU68 XOR2HS $PINS O=DIFF[16] I1=n36 I2=n11
XU69 XOR2HS $PINS O=DIFF[17] I1=n35 I2=n12
XU70 XOR2HS $PINS O=DIFF[18] I1=n34 I2=n13
XU71 XOR2HS $PINS O=DIFF[19] I1=n33 I2=n14
XU72 XOR2HS $PINS O=DIFF[20] I1=n32 I2=n15
XU73 XOR2HS $PINS O=DIFF[21] I1=n31 I2=n16
XU74 XOR2HS $PINS O=DIFF[22] I1=n30 I2=n17
XU75 XOR2HS $PINS O=DIFF[23] I1=n29 I2=n18
XU76 XOR2HS $PINS O=DIFF[24] I1=n28 I2=n19
XU77 XOR2HS $PINS O=DIFF[25] I1=n27 I2=n20
XU3 INV2 $PINS O=n49 I=B[3]
XU5 NR2P $PINS O=n2 I1=B[2] I2=n53
XU79 INV2 $PINS O=n51 I=B[1]
.ENDS

.SUBCKT PE_Shift_Add_3_DW01_sub_2_DW01_sub_11 A[26] A[25] A[24] A[23] A[22]
+ A[21] A[20] A[19] A[18] A[17] A[16] A[15] A[14] A[13] A[12] A[11] A[10] A[9]
+ A[8] A[7] A[6] A[5] A[4] A[3] A[2] A[1] A[0] B[26] B[25] B[24] B[23] B[22]
+ B[21] B[20] B[19] B[18] B[17] B[16] B[15] B[14] B[13] B[12] B[11] B[10] B[9]
+ B[8] B[7] B[6] B[5] B[4] B[3] B[2] B[1] B[0] CI DIFF[26] DIFF[25] DIFF[24]
+ DIFF[23] DIFF[22] DIFF[21] DIFF[20] DIFF[19] DIFF[18] DIFF[17] DIFF[16]
+ DIFF[15] DIFF[14] DIFF[13] DIFF[12] DIFF[11] DIFF[10] DIFF[9] DIFF[8] DIFF[7]
+ DIFF[6] DIFF[5] DIFF[4] DIFF[3] DIFF[2] DIFF[1] DIFF[0] CO p1
*.CONNECT DIFF[0] B[0]
XFE_RC_4010_0 AN2 $PINS O=FE_RN_2596_0 I1=n13 I2=n41
XFE_RC_4009_0 AN2 $PINS O=n15 I1=FE_RN_2596_0 I2=n42
XFE_RC_1610_0 XOR2HS $PINS O=DIFF[3] I1=n5 I2=n53
XFE_RC_1542_0 XOR2HS $PINS O=DIFF[2] I1=n7 I2=n54
XFE_RC_1080_0 XOR2HS $PINS O=DIFF[5] I1=n25 I2=n51
XFE_OFC839_term1_shifted_6 INV1S $PINS O=n50 I=B[6]
XU1 INV1S $PINS O=n54 I=p1
XU3 OR2B1S $PINS O=n1 I1=B[1] B1=n55
XU4 INV1S $PINS O=n7 I=n1
XU7 INV2 $PINS O=n53 I=B[3]
XU9 INV1S $PINS O=n47 I=B[9]
XU10 ND2 $PINS O=n4 I1=B[4] I2=n6
XU16 ND2S $PINS O=n30 I1=n31 I2=n24
XU18 XOR2HS $PINS O=DIFF[8] I1=n48 I2=n28
XU19 XOR2HS $PINS O=DIFF[9] I1=n47 I2=n8
XU20 AN2 $PINS O=n8 I1=n48 I2=n28
XU21 XOR2HS $PINS O=DIFF[10] I1=n46 I2=n9
XU22 AN2 $PINS O=n9 I1=n47 I2=n8
XU23 XOR2HS $PINS O=DIFF[11] I1=n45 I2=n10
XU24 AN2 $PINS O=n10 I1=n46 I2=n9
XU25 XOR2HS $PINS O=DIFF[12] I1=n44 I2=n11
XU26 AN2 $PINS O=n11 I1=n45 I2=n10
XU27 XOR2HS $PINS O=DIFF[13] I1=n43 I2=n12
XU28 AN2 $PINS O=n12 I1=n44 I2=n11
XU29 XOR2HS $PINS O=DIFF[14] I1=n42 I2=n13
XU30 AN2T $PINS O=n13 I1=n43 I2=n12
XU31 XOR2HS $PINS O=DIFF[15] I1=n41 I2=n14
XU32 AN2 $PINS O=n14 I1=n42 I2=n13
XU33 XOR2HS $PINS O=DIFF[16] I1=n40 I2=n15
XU35 XOR2HS $PINS O=DIFF[17] I1=n39 I2=n16
XU36 AN2 $PINS O=n16 I1=n40 I2=n15
XU37 XOR2HS $PINS O=DIFF[18] I1=n38 I2=n17
XU38 AN2 $PINS O=n17 I1=n39 I2=n16
XU39 XOR2HS $PINS O=DIFF[19] I1=n37 I2=n18
XU40 AN2 $PINS O=n18 I1=n38 I2=n17
XU41 XOR2HS $PINS O=DIFF[20] I1=n36 I2=n19
XU42 AN2 $PINS O=n19 I1=n37 I2=n18
XU43 XOR2HS $PINS O=DIFF[21] I1=n35 I2=n20
XU44 AN2 $PINS O=n20 I1=n36 I2=n19
XU45 XOR2HS $PINS O=DIFF[22] I1=n34 I2=n21
XU46 AN2 $PINS O=n21 I1=n35 I2=n20
XU47 XOR2HS $PINS O=DIFF[23] I1=n33 I2=n22
XU48 AN2 $PINS O=n22 I1=n34 I2=n21
XU49 AN2 $PINS O=n23 I1=n33 I2=n22
XU50 AN2 $PINS O=n24 I1=n32 I2=n23
XU51 XOR2HS $PINS O=DIFF[24] I1=n32 I2=n23
XU52 XOR2HS $PINS O=DIFF[25] I1=n31 I2=n24
XU55 XOR2HS $PINS O=DIFF[6] I1=n50 I2=n26
XU56 AN2T $PINS O=n26 I1=n51 I2=n25
XU57 XOR2HS $PINS O=DIFF[7] I1=n49 I2=n27
XU58 AN2T $PINS O=n27 I1=n50 I2=n26
XU59 INV1S $PINS O=n48 I=B[8]
XU60 AN2 $PINS O=n28 I1=n49 I2=n27
XU61 INV1S $PINS O=n46 I=B[10]
XU62 INV1S $PINS O=n45 I=B[11]
XU63 INV1S $PINS O=n44 I=B[12]
XU64 INV1S $PINS O=n43 I=B[13]
XU65 INV1S $PINS O=n42 I=B[14]
XU66 INV1S $PINS O=n41 I=B[15]
XU67 INV1S $PINS O=n40 I=B[16]
XU68 INV1S $PINS O=n39 I=B[17]
XU69 INV1S $PINS O=n38 I=B[18]
XU70 INV1S $PINS O=n37 I=B[19]
XU71 INV1S $PINS O=n36 I=B[20]
XU72 INV1S $PINS O=n35 I=B[21]
XU73 INV1S $PINS O=n34 I=B[22]
XU74 INV1S $PINS O=n33 I=B[23]
XU75 INV1S $PINS O=n32 I=B[24]
XU76 INV1S $PINS O=n31 I=B[25]
XU78 INV1S $PINS O=n51 I=B[5]
XU80 INV1S $PINS O=n49 I=B[7]
XU81 XOR2HS $PINS O=DIFF[26] I1=B[26] I2=n30
XU5 NR2 $PINS O=n5 I1=n1 I2=B[2]
XU6 AN2T $PINS O=n6 I1=n53 I2=n5
XU8 NR2 $PINS O=n25 I1=B[4] I2=n56
XU11 INV1S $PINS O=n56 I=n6
XU12 OAI12HS $PINS O=DIFF[4] A1=n4 B1=B[4] B2=n6
XU13 INV2 $PINS O=n55 I=B[0]
XU14 XNR2HS $PINS O=DIFF[1] I1=B[1] I2=n55
.ENDS

.SUBCKT PE_Shift_Add_3_DW01_add_2_DW01_add_31 A[26] A[25] A[24] A[23] A[22]
+ A[21] A[20] A[19] A[18] A[17] A[16] A[15] A[14] A[13] A[12] A[11] A[10] A[9]
+ A[8] A[7] A[6] A[5] A[4] A[3] A[2] A[1] A[0] B[26] B[25] B[24] B[23] B[22]
+ B[21] B[20] B[19] B[18] B[17] B[16] B[15] B[14] B[13] B[12] B[11] B[10] B[9]
+ B[8] B[7] B[6] B[5] B[4] B[3] B[2] B[1] B[0] CI SUM[26] SUM[25] SUM[24]
+ SUM[23] SUM[22] SUM[21] SUM[20] SUM[19] SUM[18] SUM[17] SUM[16] SUM[15]
+ SUM[14] SUM[13] SUM[12] SUM[11] SUM[10] SUM[9] SUM[8] SUM[7] SUM[6] SUM[5]
+ SUM[4] SUM[3] SUM[2] SUM[1] SUM[0] CO
XFE_RC_218_0 XOR3T $PINS O=SUM[20] I1=A[20] I2=B[20] I3=carry[20]
XFE_RC_217_0 MAO222P $PINS O=carry[21] A1=A[20] B1=B[20] C1=carry[20]
XFE_OCPC1161_carry_18 BUF1 $PINS O=FE_OCPN1161_carry_18 I=carry[18]
XFE_OCPC1156_carry_12 BUF1S $PINS O=FE_OCPN1156_carry_12 I=carry[12]
XFE_OCPC1145_carry_5 BUF1S $PINS O=FE_OCPN1145_carry_5 I=carry[5]
XFE_OCPC1134_carry_9 BUF1S $PINS O=FE_OCPN1134_carry_9 I=carry[9]
XFE_OCPC1075_carry_8 BUF1S $PINS O=FE_OCPN1075_carry_8 I=carry[8]
XFE_OCPC1067_carry_2 BUF1S $PINS O=FE_OCPN1067_carry_2 I=carry[2]
XFE_OCPC1066_carry_10 BUF1S $PINS O=FE_OCPN1066_carry_10 I=carry[10]
XFE_OCPC1046_carry_3 BUF1S $PINS O=FE_OCPN1046_carry_3 I=carry[3]
XFE_OCPC1022_carry_7 BUF1S $PINS O=FE_OCPN1022_carry_7 I=carry[7]
XFE_OCPC942_carry_21 BUF1S $PINS O=FE_OCPN942_carry_21 I=carry[21]
XFE_RC_4046_0 XOR3 $PINS O=SUM[21] I1=A[21] I2=B[21] I3=FE_OCPN942_carry_21
XFE_RC_4045_0 MAO222 $PINS O=carry[22] A1=A[21] B1=B[21] C1=carry[21]
XFE_RC_4018_0 XOR3 $PINS O=SUM[19] I1=A[19] I2=B[19] I3=carry[19]
XFE_RC_4017_0 MAO222P $PINS O=carry[20] A1=A[19] B1=B[19] C1=carry[19]
XFE_RC_3928_0 ND3P $PINS O=carry[14] I1=n3 I2=n2 I3=n4
XFE_RC_3572_0 OR2 $PINS O=FE_RN_2332_0 I1=FE_RN_2196_0 I2=FE_RN_2204_0
XFE_RC_3571_0 ND2P $PINS O=carry[12] I1=FE_RN_2332_0 I2=FE_RN_2207_0
XFE_RC_3523_0 ND3 $PINS O=carry[3] I1=n20 I2=n21 I3=n19
XFE_OCPC494_carry_11 BUF1S $PINS O=FE_OCPN494_carry_11 I=carry[11]
XFE_RC_3392_0 INV1S $PINS O=FE_RN_2196_0 I=A[11]
XFE_RC_3391_0 NR2 $PINS O=FE_RN_2197_0 I1=B[11] I2=FE_RN_2196_0
XFE_RC_3390_0 AN2B1S $PINS O=FE_RN_2198_0 I1=B[11] B1=A[11]
XFE_RC_3389_0 INV1S $PINS O=FE_RN_2199_0 I=carry[11]
XFE_RC_3388_0 OAI12HS $PINS O=FE_RN_2200_0 A1=FE_RN_2199_0 B1=FE_RN_2198_0
+ B2=FE_RN_2197_0
XFE_RC_3387_0 ND2 $PINS O=FE_RN_2201_0 I1=A[11] I2=B[11]
XFE_RC_3386_0 ND2 $PINS O=FE_RN_2202_0 I1=FE_RN_2201_0 I2=FE_RN_2206_0
XFE_RC_3385_0 ND2 $PINS O=FE_RN_2203_0 I1=FE_RN_2202_0 I2=FE_OCPN494_carry_11
XFE_RC_3384_0 ND2 $PINS O=SUM[11] I1=FE_RN_2203_0 I2=FE_RN_2200_0
XFE_RC_3383_0 INV1S $PINS O=FE_RN_2204_0 I=B[11]
XFE_RC_3381_0 OR2 $PINS O=FE_RN_2206_0 I1=B[11] I2=A[11]
XFE_RC_3380_0 ND2P $PINS O=FE_RN_2207_0 I1=FE_RN_2206_0 I2=carry[11]
XFE_RC_3121_0 INV1S $PINS O=FE_RN_2010_0 I=FE_RN_1828_0
XFE_RC_3120_0 OR2B1S $PINS O=FE_RN_2011_0 I1=FE_RN_1827_0 B1=FE_RN_2010_0
XFE_RC_3119_0 ND2P $PINS O=carry[15] I1=FE_RN_1830_0 I2=FE_RN_2011_0
XFE_RC_2862_0 XOR2HS $PINS O=FE_RN_1822_0 I1=B[14] I2=A[14]
XFE_RC_2861_0 OR2B1S $PINS O=FE_RN_1823_0 I1=carry[14] B1=FE_RN_1822_0
XFE_RC_2860_0 ND2 $PINS O=FE_RN_1824_0 I1=A[14] I2=B[14]
XFE_RC_2859_0 ND2 $PINS O=FE_RN_1825_0 I1=FE_RN_1824_0 I2=FE_RN_1829_0
XFE_RC_2858_0 ND2 $PINS O=FE_RN_1826_0 I1=FE_RN_1825_0 I2=carry[14]
XFE_RC_2857_0 ND2 $PINS O=SUM[14] I1=FE_RN_1826_0 I2=FE_RN_1823_0
XFE_RC_2856_0 INV1S $PINS O=FE_RN_1827_0 I=B[14]
XFE_RC_2855_0 INV1S $PINS O=FE_RN_1828_0 I=A[14]
XFE_RC_2854_0 OR2 $PINS O=FE_RN_1829_0 I1=B[14] I2=A[14]
XFE_RC_2853_0 ND2 $PINS O=FE_RN_1830_0 I1=FE_RN_1829_0 I2=carry[14]
XFE_RC_2643_0 INV1S $PINS O=FE_RN_1666_0 I=B[15]
XFE_RC_2642_0 INV1S $PINS O=FE_RN_1667_0 I=A[15]
XFE_RC_2641_0 OAI12HS $PINS O=FE_RN_1668_0 A1=FE_RN_1671_0 B1=FE_RN_1667_0
+ B2=FE_RN_1666_0
XFE_RC_2640_0 XNR2HS $PINS O=FE_RN_1669_0 I1=B[15] I2=A[15]
XFE_RC_2639_0 MOAI1 $PINS O=SUM[15] A1=FE_RN_1669_0 A2=carry[15]
+ B1=FE_RN_1668_0 B2=carry[15]
XFE_RC_2638_0 ND2 $PINS O=FE_RN_1670_0 I1=A[15] I2=B[15]
XFE_RC_2637_0 OR2 $PINS O=FE_RN_1671_0 I1=B[15] I2=A[15]
XFE_RC_2636_0 ND2P $PINS O=FE_RN_1672_0 I1=FE_RN_1671_0 I2=carry[15]
XFE_RC_2635_0 ND2P $PINS O=carry[16] I1=FE_RN_1672_0 I2=FE_RN_1670_0
XFE_RC_2319_0 XNR2HS $PINS O=FE_RN_1423_0 I1=B[16] I2=A[16]
XFE_RC_2318_0 ND2 $PINS O=FE_RN_1424_0 I1=A[16] I2=B[16]
XFE_RC_2317_0 ND2 $PINS O=FE_RN_1425_0 I1=FE_RN_1424_0 I2=FE_RN_1428_0
XFE_RC_2316_0 ND2 $PINS O=FE_RN_1426_0 I1=FE_RN_1425_0 I2=carry[16]
XFE_RC_2315_0 OAI12HS $PINS O=SUM[16] A1=FE_RN_1426_0 B1=FE_RN_1423_0
+ B2=carry[16]
XFE_RC_2313_0 OR2 $PINS O=FE_RN_1428_0 I1=B[16] I2=A[16]
XFE_RC_2312_0 ND2P $PINS O=FE_RN_1429_0 I1=FE_RN_1428_0 I2=carry[16]
XFE_RC_2311_0 ND2P $PINS O=carry[17] I1=FE_RN_1429_0 I2=FE_RN_1424_0
XFE_RC_1944_0 INV1S $PINS O=FE_RN_1146_0 I=carry[17]
XFE_RC_1943_0 INV1S $PINS O=FE_RN_1147_0 I=FE_RN_1151_0
XFE_RC_1942_0 AOI12HS $PINS O=FE_RN_1148_0 A1=FE_RN_1147_0 B1=A[17] B2=B[17]
XFE_RC_1941_0 XNR2HS $PINS O=FE_RN_1149_0 I1=B[17] I2=A[17]
XFE_RC_1940_0 OAI22S $PINS O=SUM[17] A1=carry[17] A2=FE_RN_1149_0
+ B1=FE_RN_1148_0 B2=FE_RN_1146_0
XFE_RC_1939_0 ND2S $PINS O=FE_RN_1150_0 I1=A[17] I2=B[17]
XFE_RC_1938_0 OR2 $PINS O=FE_RN_1151_0 I1=B[17] I2=A[17]
XFE_RC_1937_0 ND2 $PINS O=FE_RN_1152_0 I1=FE_RN_1151_0 I2=carry[17]
XFE_RC_1936_0 ND2P $PINS O=carry[18] I1=FE_RN_1152_0 I2=FE_RN_1150_0
XFE_RC_1688_0 XNR2HS $PINS O=FE_RN_948_0 I1=B[18] I2=A[18]
XFE_RC_1687_0 ND2S $PINS O=FE_RN_949_0 I1=A[18] I2=B[18]
XFE_RC_1686_0 ND2 $PINS O=FE_RN_950_0 I1=FE_RN_953_0 I2=FE_RN_949_0
XFE_RC_1685_0 ND2 $PINS O=FE_RN_951_0 I1=FE_RN_950_0 I2=carry[18]
XFE_RC_1684_0 OAI12HS $PINS O=SUM[18] A1=FE_RN_951_0 B1=FE_RN_948_0
+ B2=FE_OCPN1161_carry_18
XFE_RC_1682_0 OR2T $PINS O=FE_RN_953_0 I1=B[18] I2=A[18]
XFE_RC_1681_0 ND2P $PINS O=FE_RN_954_0 I1=FE_RN_953_0 I2=carry[18]
XFE_RC_1680_0 ND2P $PINS O=carry[19] I1=FE_RN_954_0 I2=FE_RN_949_0
XFE_RC_1600_0 ND2 $PINS O=FE_RN_887_0 I1=n1 I2=A[1]
XFE_RC_1599_0 ND2 $PINS O=FE_RN_888_0 I1=B[1] I2=A[1]
XFE_RC_1598_0 ND2 $PINS O=FE_RN_889_0 I1=B[1] I2=n1
XFE_RC_1597_0 ND3 $PINS O=carry[2] I1=FE_RN_889_0 I2=FE_RN_888_0 I3=FE_RN_887_0
XFE_RC_1377_0 OR2 $PINS O=FE_RN_719_0 I1=FE_RN_582_0 I2=FE_RN_583_0
XFE_RC_1376_0 ND2P $PINS O=carry[13] I1=FE_RN_719_0 I2=FE_RN_587_0
XFE_RC_1203_0 INV1S $PINS O=FE_RN_576_0 I=carry[12]
XFE_RC_1202_0 XOR2HS $PINS O=FE_RN_577_0 I1=A[12] I2=B[12]
XFE_RC_1201_0 ND2S $PINS O=FE_RN_578_0 I1=FE_RN_577_0 I2=FE_RN_576_0
XFE_RC_1200_0 ND2 $PINS O=FE_RN_579_0 I1=B[12] I2=A[12]
XFE_RC_1199_0 ND2S $PINS O=FE_RN_580_0 I1=FE_RN_579_0 I2=FE_RN_586_0
XFE_RC_1198_0 ND2 $PINS O=FE_RN_581_0 I1=FE_RN_580_0 I2=FE_OCPN1156_carry_12
XFE_RC_1197_0 ND2 $PINS O=SUM[12] I1=FE_RN_581_0 I2=FE_RN_578_0
XFE_RC_1196_0 INV1S $PINS O=FE_RN_582_0 I=A[12]
XFE_RC_1195_0 INV1S $PINS O=FE_RN_583_0 I=B[12]
XFE_RC_1192_0 ND2S $PINS O=FE_RN_586_0 I1=FE_RN_583_0 I2=FE_RN_582_0
XFE_RC_1191_0 ND2P $PINS O=FE_RN_587_0 I1=FE_RN_586_0 I2=carry[12]
XFE_RC_1062_0 ND3P $PINS O=carry[9] I1=n6 I2=n5 I3=n7
XFE_RC_752_0 XOR3 $PINS O=SUM[9] I1=A[9] I2=B[9] I3=FE_OCPN1134_carry_9
XFE_RC_751_0 MAO222 $PINS O=carry[10] A1=carry[9] B1=B[9] C1=A[9]
XFE_RC_747_0 ND2 $PINS O=FE_RN_244_0 I1=carry[7] I2=B[7]
XFE_RC_746_0 AOI22H $PINS O=FE_RN_245_0 A1=A[7] A2=B[7] B1=carry[7] B2=A[7]
XFE_RC_745_0 ND2P $PINS O=carry[8] I1=FE_RN_245_0 I2=FE_RN_244_0
XFE_RC_744_0 XOR3 $PINS O=SUM[1] I1=A[1] I2=B[1] I3=n1
XFE_RC_732_0 OAI12H $PINS O=FE_RN_114_0 A1=carry[4] B1=A[4] B2=B[4]
XFE_RC_708_0 XOR3 $PINS O=SUM[3] I1=A[3] I2=B[3] I3=FE_OCPN1046_carry_3
XFE_RC_707_0 MAO222P $PINS O=carry[4] A1=carry[3] B1=B[3] C1=A[3]
XFE_RC_691_0 ND2P $PINS O=FE_RN_221_0 I1=A[5] I2=B[5]
XFE_RC_690_0 ND2 $PINS O=FE_RN_222_0 I1=carry[5] I2=A[5]
XFE_RC_689_0 ND2 $PINS O=FE_RN_223_0 I1=carry[5] I2=B[5]
XFE_RC_688_0 ND3P $PINS O=carry[6] I1=FE_RN_223_0 I2=FE_RN_222_0 I3=FE_RN_221_0
XFE_RC_412_0 INV1S $PINS O=FE_RN_109_0 I=carry[4]
XFE_RC_410_0 XOR2HS $PINS O=FE_RN_111_0 I1=A[4] I2=B[4]
XFE_RC_409_0 ND2 $PINS O=FE_RN_112_0 I1=FE_RN_111_0 I2=FE_RN_109_0
XFE_RC_408_0 OAI12H $PINS O=SUM[4] A1=FE_RN_112_0 B1=FE_RN_111_0 B2=FE_RN_109_0
XFE_RC_407_0 ND2 $PINS O=FE_RN_113_0 I1=B[4] I2=A[4]
XFE_RC_405_0 ND2P $PINS O=carry[5] I1=FE_RN_114_0 I2=FE_RN_113_0
XFE_RC_279_0 XOR3 $PINS O=SUM[7] I1=A[7] I2=B[7] I3=FE_OCPN1022_carry_7
XFE_RC_277_0 XOR3 $PINS O=SUM[5] I1=A[5] I2=B[5] I3=FE_OCPN1145_carry_5
XU1_22 FA1 $PINS S=SUM[22] CO=carry[23] A=A[22] B=B[22] CI=carry[22]
XU1_23 FA1 $PINS S=SUM[23] CO=carry[24] A=A[23] B=B[23] CI=carry[23]
XU1_24 FA1 $PINS S=SUM[24] CO=carry[25] A=A[24] B=B[24] CI=carry[24]
XU1_25 FA1 $PINS S=SUM[25] CO=carry[26] A=A[25] B=B[25] CI=carry[25]
XU2 XOR2HS $PINS O=n18 I1=A[2] I2=B[2]
XU3 ND3P $PINS O=carry[11] I1=n15 I2=n16 I3=n17
XU4 INV1S $PINS O=n9 I=B[26]
XU5 INV1S $PINS O=n8 I=A[26]
XU6 AN2 $PINS O=n1 I1=A[0] I2=B[0]
XU7 XOR3 $PINS O=SUM[13] I1=A[13] I2=B[13] I3=carry[13]
XU8 ND2 $PINS O=n2 I1=carry[13] I2=A[13]
XU9 ND2 $PINS O=n3 I1=carry[13] I2=B[13]
XU10 ND2 $PINS O=n4 I1=A[13] I2=B[13]
XU12 XOR3 $PINS O=SUM[8] I1=A[8] I2=B[8] I3=FE_OCPN1075_carry_8
XU13 ND2 $PINS O=n5 I1=carry[8] I2=A[8]
XU14 ND2 $PINS O=n6 I1=carry[8] I2=B[8]
XU15 ND2 $PINS O=n7 I1=A[8] I2=B[8]
XU17 XOR3 $PINS O=SUM[26] I1=n8 I2=n9 I3=carry[26]
XU18 ND2 $PINS O=n21 I1=A[2] I2=B[2]
XU19 ND2 $PINS O=n13 I1=A[6] I2=B[6]
XU20 XOR2HS $PINS O=SUM[10] I1=FE_OCPN1066_carry_10 I2=n14
XU21 XOR2HS $PINS O=SUM[6] I1=carry[6] I2=n10
XU22 XOR2HS $PINS O=n10 I1=A[6] I2=B[6]
XU23 ND2 $PINS O=n11 I1=carry[6] I2=A[6]
XU24 ND2 $PINS O=n12 I1=carry[6] I2=B[6]
XU25 ND3P $PINS O=carry[7] I1=n11 I2=n12 I3=n13
XU26 XOR2HS $PINS O=n14 I1=A[10] I2=B[10]
XU27 ND2 $PINS O=n15 I1=carry[10] I2=A[10]
XU28 ND2 $PINS O=n16 I1=carry[10] I2=B[10]
XU29 ND2S $PINS O=n17 I1=A[10] I2=B[10]
XU30 XOR2HS $PINS O=SUM[2] I1=FE_OCPN1067_carry_2 I2=n18
XU31 ND2 $PINS O=n19 I1=carry[2] I2=A[2]
XU32 ND2 $PINS O=n20 I1=carry[2] I2=B[2]
XU33 XOR2HS $PINS O=SUM[0] I1=B[0] I2=A[0]
.ENDS

.SUBCKT PE_Shift_Add_3_DW01_add_1_DW01_add_30 A[26] A[25] A[24] A[23] A[22]
+ A[21] A[20] A[19] A[18] A[17] A[16] A[15] A[14] A[13] A[12] A[11] A[10] A[9]
+ A[8] A[7] A[6] A[5] A[4] A[3] A[2] A[1] A[0] B[26] B[25] B[24] B[23] B[22]
+ B[21] B[20] B[19] B[18] B[17] B[16] B[15] B[14] B[13] B[12] B[11] B[10] B[9]
+ B[8] B[7] B[6] B[5] B[4] B[3] B[2] B[1] B[0] CI SUM[26] SUM[25] SUM[24]
+ SUM[23] SUM[22] SUM[21] SUM[20] SUM[19] SUM[18] SUM[17] SUM[16] SUM[15]
+ SUM[14] SUM[13] SUM[12] SUM[11] SUM[10] SUM[9] SUM[8] SUM[7] SUM[6] SUM[5]
+ SUM[4] SUM[3] SUM[2] SUM[1] SUM[0] CO
XFE_PHC1805_N205 DELB $PINS O=SUM[0] I=FE_PHN1805_N205
XFE_RC_317_0 OAI12H $PINS O=FE_RN_37_0 A1=A[2] B1=B[2] B2=carry[2]
XFE_RC_315_0 OAI12H $PINS O=FE_RN_2248_0 A1=A[1] B1=B[1] B2=n1
XFE_RC_172_0 OAI12HS $PINS O=SUM[14] A1=FE_RN_513_0 B1=carry[14] B2=FE_RN_510_0
XFE_RC_76_0 ND2S $PINS O=FE_RN_45_0 I1=carry[15] I2=FE_RN_739_0
XFE_RC_75_0 OAI12HS $PINS O=SUM[15] A1=FE_RN_45_0 B1=carry[15] B2=FE_RN_743_0
XFE_OCPC1171_carry_7 BUF1S $PINS O=FE_OCPN1171_carry_7 I=carry[7]
XFE_OCPC1114_carry_8 BUF1S $PINS O=FE_OCPN1114_carry_8 I=carry[8]
XFE_OCPC1083_carry_10 BUF1S $PINS O=FE_OCPN1083_carry_10 I=carry[10]
XFE_OCPC1078_carry_9 BUF1S $PINS O=FE_OCPN1078_carry_9 I=carry[9]
XFE_RC_3549_0 ND3P $PINS O=carry[4] I1=n3 I2=n2 I3=n4
XFE_RC_3447_0 ND2 $PINS O=FE_RN_2247_0 I1=n1 I2=B[1]
XFE_RC_3445_0 ND2P $PINS O=carry[2] I1=FE_RN_2248_0 I2=FE_RN_2247_0
XFE_RC_3034_0 ND2 $PINS O=FE_RN_1946_0 I1=A[20] I2=B[20]
XFE_RC_3033_0 ND2 $PINS O=FE_RN_1947_0 I1=FE_RN_1946_0 I2=FE_RN_1954_0
XFE_RC_3032_0 INV1S $PINS O=FE_RN_1948_0 I=A[20]
XFE_RC_3030_0 NR2 $PINS O=FE_RN_1950_0 I1=B[20] I2=FE_RN_1948_0
XFE_RC_3029_0 AOI12HS $PINS O=FE_RN_1951_0 A1=FE_RN_1950_0 B1=FE_RN_1948_0
+ B2=B[20]
XFE_RC_3028_0 MOAI1 $PINS O=SUM[20] A1=FE_RN_1951_0 A2=carry[20]
+ B1=FE_RN_1947_0 B2=carry[20]
XFE_RC_3025_0 OR2B1S $PINS O=FE_RN_1954_0 I1=B[20] B1=FE_RN_1948_0
XFE_RC_3024_0 ND2 $PINS O=FE_RN_1955_0 I1=FE_RN_1954_0 I2=carry[20]
XFE_RC_3023_0 ND2P $PINS O=carry[21] I1=FE_RN_1955_0 I2=FE_RN_1946_0
XFE_RC_2634_0 INV1S $PINS O=FE_RN_1656_0 I=FE_RN_1664_0
XFE_RC_2633_0 AOI12HS $PINS O=FE_RN_1657_0 A1=FE_RN_1656_0 B1=A[16] B2=B[16]
XFE_RC_2632_0 INV1S $PINS O=FE_RN_1658_0 I=A[16]
XFE_RC_2630_0 NR2 $PINS O=FE_RN_1660_0 I1=B[16] I2=FE_RN_1658_0
XFE_RC_2629_0 AOI12HS $PINS O=FE_RN_1661_0 A1=FE_RN_1660_0 B1=FE_RN_1658_0
+ B2=B[16]
XFE_RC_2628_0 MXL2HS $PINS OB=SUM[16] S=carry[16] A=FE_RN_1661_0 B=FE_RN_1657_0
XFE_RC_2627_0 ND2 $PINS O=FE_RN_1662_0 I1=A[16] I2=B[16]
XFE_RC_2625_0 OR2B1S $PINS O=FE_RN_1664_0 I1=B[16] B1=FE_RN_1658_0
XFE_RC_2624_0 ND2P $PINS O=FE_RN_1665_0 I1=carry[16] I2=FE_RN_1664_0
XFE_RC_2623_0 ND2P $PINS O=carry[17] I1=FE_RN_1665_0 I2=FE_RN_1662_0
XFE_RC_2227_0 INV1S $PINS O=FE_RN_1349_0 I=A[17]
XFE_RC_2225_0 MAOI1 $PINS O=FE_RN_1351_0 A1=FE_RN_1349_0 A2=B[17] B1=B[17]
+ B2=FE_RN_1349_0
XFE_RC_2224_0 ND2S $PINS O=FE_RN_1352_0 I1=A[17] I2=B[17]
XFE_RC_2223_0 ND2 $PINS O=FE_RN_1353_0 I1=FE_RN_1352_0 I2=FE_RN_1357_0
XFE_RC_2222_0 ND2 $PINS O=FE_RN_1354_0 I1=FE_RN_1353_0 I2=carry[17]
XFE_RC_2221_0 OAI12HS $PINS O=SUM[17] A1=FE_RN_1354_0 B1=FE_RN_1351_0
+ B2=carry[17]
XFE_RC_2218_0 OR2B1S $PINS O=FE_RN_1357_0 I1=B[17] B1=FE_RN_1349_0
XFE_RC_2217_0 ND2P $PINS O=FE_RN_1358_0 I1=carry[17] I2=FE_RN_1357_0
XFE_RC_2216_0 ND2P $PINS O=carry[18] I1=FE_RN_1358_0 I2=FE_RN_1352_0
XFE_RC_1894_0 ND2S $PINS O=FE_RN_1102_0 I1=A[18] I2=B[18]
XFE_RC_1893_0 ND2 $PINS O=FE_RN_1103_0 I1=FE_RN_1102_0 I2=FE_RN_1113_0
XFE_RC_1892_0 ND2 $PINS O=FE_RN_1104_0 I1=FE_RN_1103_0 I2=carry[18]
XFE_RC_1891_0 INV1S $PINS O=FE_RN_1105_0 I=carry[18]
XFE_RC_1890_0 INV1S $PINS O=FE_RN_1106_0 I=A[18]
XFE_RC_1888_0 ND2S $PINS O=FE_RN_1108_0 I1=FE_RN_1106_0 I2=B[18]
XFE_RC_1887_0 OAI12HS $PINS O=FE_RN_1109_0 A1=FE_RN_1108_0 B1=FE_RN_1106_0
+ B2=B[18]
XFE_RC_1886_0 ND2S $PINS O=FE_RN_1110_0 I1=FE_RN_1109_0 I2=FE_RN_1105_0
XFE_RC_1885_0 ND2 $PINS O=SUM[18] I1=FE_RN_1110_0 I2=FE_RN_1104_0
XFE_RC_1882_0 OR2B1 $PINS O=FE_RN_1113_0 I1=B[18] B1=FE_RN_1106_0
XFE_RC_1881_0 ND2 $PINS O=FE_RN_1114_0 I1=carry[18] I2=FE_RN_1113_0
XFE_RC_1880_0 ND2P $PINS O=carry[19] I1=FE_RN_1114_0 I2=FE_RN_1102_0
XFE_RC_1595_0 ND2 $PINS O=FE_RN_885_0 I1=carry[12] I2=B[12]
XFE_RC_1594_0 AOI22H $PINS O=FE_RN_886_0 A1=B[12] A2=A[12] B1=carry[12]
+ B2=A[12]
XFE_RC_1593_0 ND2P $PINS O=carry[13] I1=FE_RN_886_0 I2=FE_RN_885_0
XFE_RC_1580_0 INV1S $PINS O=FE_RN_865_0 I=A[19]
XFE_RC_1578_0 MAOI1 $PINS O=FE_RN_867_0 A1=FE_RN_865_0 A2=B[19] B1=B[19]
+ B2=FE_RN_865_0
XFE_RC_1577_0 ND2S $PINS O=FE_RN_868_0 I1=A[19] I2=B[19]
XFE_RC_1576_0 ND2 $PINS O=FE_RN_869_0 I1=FE_RN_868_0 I2=FE_RN_873_0
XFE_RC_1575_0 ND2 $PINS O=FE_RN_870_0 I1=FE_RN_869_0 I2=carry[19]
XFE_RC_1574_0 OAI12HS $PINS O=SUM[19] A1=FE_RN_870_0 B1=FE_RN_867_0
+ B2=carry[19]
XFE_RC_1571_0 OR2B1S $PINS O=FE_RN_873_0 I1=B[19] B1=FE_RN_865_0
XFE_RC_1570_0 ND2 $PINS O=FE_RN_874_0 I1=FE_RN_873_0 I2=carry[19]
XFE_RC_1569_0 ND2P $PINS O=carry[20] I1=FE_RN_874_0 I2=FE_RN_868_0
XFE_RC_1416_0 ND2 $PINS O=FE_RN_749_0 I1=carry[9] I2=B[9]
XFE_RC_1415_0 AOI22H $PINS O=FE_RN_750_0 A1=B[9] A2=A[9] B1=carry[9] B2=A[9]
XFE_RC_1414_0 ND2P $PINS O=carry[10] I1=FE_RN_750_0 I2=FE_RN_749_0
XFE_RC_1411_0 ND2 $PINS O=FE_RN_738_0 I1=A[15] I2=B[15]
XFE_RC_1410_0 ND2 $PINS O=FE_RN_739_0 I1=FE_RN_738_0 I2=FE_RN_746_0
XFE_RC_1409_0 INV1S $PINS O=FE_RN_740_0 I=A[15]
XFE_RC_1407_0 NR2 $PINS O=FE_RN_742_0 I1=B[15] I2=FE_RN_740_0
XFE_RC_1406_0 AOI12HS $PINS O=FE_RN_743_0 A1=FE_RN_742_0 B1=FE_RN_740_0
+ B2=B[15]
XFE_RC_1402_0 OR2B1S $PINS O=FE_RN_746_0 I1=B[15] B1=FE_RN_740_0
XFE_RC_1401_0 ND2 $PINS O=FE_RN_747_0 I1=FE_RN_746_0 I2=carry[15]
XFE_RC_1400_0 ND2P $PINS O=carry[16] I1=FE_RN_747_0 I2=FE_RN_738_0
XFE_RC_1399_0 ND2 $PINS O=FE_RN_736_0 I1=carry[13] I2=B[13]
XFE_RC_1398_0 AOI22H $PINS O=FE_RN_737_0 A1=B[13] A2=A[13] B1=carry[13]
+ B2=A[13]
XFE_RC_1397_0 ND2P $PINS O=carry[14] I1=FE_RN_737_0 I2=FE_RN_736_0
XFE_RC_1107_0 INV1S $PINS O=FE_RN_508_0 I=A[14]
XFE_RC_1105_0 MAOI1 $PINS O=FE_RN_510_0 A1=FE_RN_508_0 A2=B[14] B1=B[14]
+ B2=FE_RN_508_0
XFE_RC_1104_0 ND2S $PINS O=FE_RN_511_0 I1=A[14] I2=B[14]
XFE_RC_1103_0 ND2 $PINS O=FE_RN_512_0 I1=FE_RN_511_0 I2=FE_RN_516_0
XFE_RC_1102_0 ND2 $PINS O=FE_RN_513_0 I1=FE_RN_512_0 I2=carry[14]
XFE_RC_1098_0 OR2B1 $PINS O=FE_RN_516_0 I1=B[14] B1=FE_RN_508_0
XFE_RC_1097_0 ND2 $PINS O=FE_RN_517_0 I1=carry[14] I2=FE_RN_516_0
XFE_RC_1096_0 ND2P $PINS O=carry[15] I1=FE_RN_517_0 I2=FE_RN_511_0
XFE_RC_1009_0 ND2 $PINS O=FE_RN_441_0 I1=carry[10] I2=B[10]
XFE_RC_1008_0 AOI22H $PINS O=FE_RN_442_0 A1=B[10] A2=A[10] B1=carry[10]
+ B2=A[10]
XFE_RC_1007_0 ND2P $PINS O=carry[11] I1=FE_RN_442_0 I2=FE_RN_441_0
XFE_RC_827_0 ND2P $PINS O=FE_RN_300_0 I1=carry[11] I2=B[11]
XFE_RC_826_0 AOI22H $PINS O=FE_RN_301_0 A1=B[11] A2=A[11] B1=carry[11] B2=A[11]
XFE_RC_825_0 ND2P $PINS O=carry[12] I1=FE_RN_301_0 I2=FE_RN_300_0
XFE_RC_687_0 XOR3 $PINS O=SUM[11] I1=A[11] I2=B[11] I3=carry[11]
XFE_RC_660_0 XOR3 $PINS O=SUM[10] I1=A[10] I2=B[10] I3=FE_OCPN1083_carry_10
XFE_RC_528_0 XOR3 $PINS O=SUM[9] I1=A[9] I2=B[9] I3=FE_OCPN1078_carry_9
XFE_RC_526_0 XOR3 $PINS O=SUM[12] I1=A[12] I2=B[12] I3=carry[12]
XFE_RC_504_0 XOR3 $PINS O=SUM[1] I1=A[1] I2=B[1] I3=n1
XFE_RC_420_0 ND2 $PINS O=FE_RN_115_0 I1=carry[7] I2=B[7]
XFE_RC_419_0 AOI22H $PINS O=FE_RN_116_0 A1=B[7] A2=A[7] B1=carry[7] B2=A[7]
XFE_RC_418_0 ND2P $PINS O=carry[8] I1=FE_RN_116_0 I2=FE_RN_115_0
XFE_RC_417_0 XOR3 $PINS O=SUM[13] I1=A[13] I2=B[13] I3=carry[13]
XFE_RC_324_0 XOR3 $PINS O=SUM[7] I1=A[7] I2=B[7] I3=FE_OCPN1171_carry_7
XFE_RC_284_0 ND3P $PINS O=carry[7] I1=n12 I2=n11 I3=n13
XFE_RC_204_0 ND3P $PINS O=carry[5] I1=n7 I2=n8 I3=n6
XFE_RC_203_0 ND2 $PINS O=FE_RN_36_0 I1=B[2] I2=carry[2]
XFE_RC_201_0 ND2P $PINS O=carry[3] I1=FE_RN_37_0 I2=FE_RN_36_0
XFE_RC_125_0 XOR3 $PINS O=SUM[2] I1=A[2] I2=carry[2] I3=B[2]
XU1_22 FA1 $PINS S=SUM[22] CO=carry[23] A=A[22] B=B[22] CI=carry[22]
XU1_5 FA1 $PINS S=SUM[5] CO=carry[6] A=A[5] B=B[5] CI=carry[5]
XU1_24 FA1 $PINS S=SUM[24] CO=carry[25] A=A[24] B=B[24] CI=carry[24]
XU1_23 FA1 $PINS S=SUM[23] CO=carry[24] A=A[23] B=B[23] CI=carry[23]
XU1_21 FA1 $PINS S=SUM[21] CO=carry[22] A=A[21] B=B[21] CI=carry[21]
XU1_25 FA1 $PINS S=SUM[25] CO=carry[26] A=A[25] B=B[25] CI=carry[25]
XU1_26 XOR3S $PINS O=SUM[26] I1=A[26] I2=B[26] I3=carry[26]
XU1 ND2 $PINS O=n12 I1=carry[6] I2=A[6]
XU2 ND2 $PINS O=n2 I1=A[3] I2=B[3]
XU3 AN2T $PINS O=n1 I1=B[0] I2=A[0]
XU4 XOR3 $PINS O=SUM[3] I1=A[3] I2=B[3] I3=carry[3]
XU5 ND2 $PINS O=n3 I1=A[3] I2=carry[3]
XU6 ND2 $PINS O=n4 I1=carry[3] I2=B[3]
XU8 XOR2HS $PINS O=n5 I1=A[4] I2=B[4]
XU9 XOR2HS $PINS O=SUM[4] I1=carry[4] I2=n5
XU10 ND2 $PINS O=n6 I1=A[4] I2=B[4]
XU11 ND2 $PINS O=n7 I1=carry[4] I2=A[4]
XU12 ND2 $PINS O=n8 I1=carry[4] I2=B[4]
XU14 MAO222P $PINS O=n9 A1=carry[5] B1=B[5] C1=A[5]
XU15 ND3P $PINS O=carry[9] I1=n14 I2=n15 I3=n16
XU16 XOR2HS $PINS O=n10 I1=B[6] I2=A[6]
XU17 XOR2HS $PINS O=SUM[6] I1=n9 I2=n10
XU18 ND2P $PINS O=n11 I1=n9 I2=B[6]
XU19 ND2 $PINS O=n13 I1=B[6] I2=A[6]
XU21 XOR3 $PINS O=SUM[8] I1=B[8] I2=A[8] I3=FE_OCPN1114_carry_8
XU22 ND2 $PINS O=n14 I1=carry[8] I2=B[8]
XU23 ND2P $PINS O=n15 I1=carry[8] I2=A[8]
XU24 ND2 $PINS O=n16 I1=B[8] I2=A[8]
XU25 XOR2HS $PINS O=FE_PHN1805_N205 I1=B[0] I2=A[0]
.ENDS

.SUBCKT PE_Shift_Add_3_DW01_add_0_DW01_add_29 A[26] A[25] A[24] A[23] A[22]
+ A[21] A[20] A[19] A[18] A[17] A[16] A[15] A[14] A[13] A[12] A[11] A[10] A[9]
+ A[8] A[7] A[6] A[5] A[4] A[3] A[2] A[1] A[0] B[26] B[25] B[24] B[23] B[22]
+ B[21] B[20] B[19] B[18] B[17] B[16] B[15] B[14] B[13] B[12] B[11] B[10] B[9]
+ B[8] B[7] B[6] B[5] B[4] B[3] B[2] B[1] B[0] CI SUM[26] SUM[25] SUM[24]
+ SUM[23] SUM[22] SUM[21] SUM[20] SUM[19] SUM[18] SUM[17] SUM[16] SUM[15]
+ SUM[14] SUM[13] SUM[12] SUM[11] SUM[10] SUM[9] SUM[8] SUM[7] SUM[6] SUM[5]
+ SUM[4] SUM[3] SUM[2] SUM[1] SUM[0] CO
XFE_PHC2045_FE_RN_1859_0 BUF1CK $PINS O=FE_RN_1859_0 I=FE_PHN2045_FE_RN_1859_0
XFE_RC_301_0 INV1S $PINS O=FE_RN_134_0 I=B[13]
XFE_RC_300_0 INV1S $PINS O=FE_RN_135_0 I=A[13]
XFE_RC_299_0 AOI22S $PINS O=FE_RN_136_0 A1=FE_RN_135_0 A2=B[13] B1=A[13]
+ B2=FE_RN_134_0
XFE_RC_298_0 ND2 $PINS O=FE_RN_137_0 I1=A[13] I2=B[13]
XFE_RC_297_0 ND2 $PINS O=FE_RN_138_0 I1=FE_RN_137_0 I2=FE_RN_143_0
XFE_RC_296_0 ND2 $PINS O=FE_RN_139_0 I1=FE_RN_138_0 I2=carry[13]
XFE_RC_295_0 OAI12HS $PINS O=SUM[13] A1=FE_RN_139_0 B1=FE_RN_136_0 B2=carry[13]
XFE_RC_293_0 INV1S $PINS O=FE_RN_141_0 I=B[13]
XFE_RC_292_0 INV1S $PINS O=FE_RN_142_0 I=A[13]
XFE_RC_291_0 ND2 $PINS O=FE_RN_143_0 I1=FE_RN_142_0 I2=FE_RN_141_0
XFE_RC_290_0 ND2 $PINS O=FE_RN_144_0 I1=FE_RN_143_0 I2=carry[13]
XFE_RC_289_0 ND2 $PINS O=carry[14] I1=FE_RN_144_0 I2=FE_RN_137_0
XFE_OCPC6_N193 BUF2 $PINS O=FE_OCPN5_N193 I=A[15]
XFE_OCPC1234_N182 BUF1S $PINS O=FE_OCPN1234_N182 I=A[4]
XFE_OCPC1100_carry_8 BUF1S $PINS O=FE_OCPN1100_carry_8 I=carry[8]
XFE_OCPC1094_N220 BUF1S $PINS O=FE_OCPN1094_N220 I=B[15]
XFE_OCPC1077_carry_14 BUF1S $PINS O=FE_OCPN1077_carry_14 I=carry[14]
XFE_OCPC1073_carry_6 BUF1S $PINS O=FE_OCPN1073_carry_6 I=carry[6]
XFE_OCPC1064_N219 BUF1S $PINS O=FE_OCPN1064_N219 I=B[14]
XFE_OCPC1035_carry_21 BUF1S $PINS O=FE_OCPN1035_carry_21 I=carry[21]
XFE_OCPC898_carry_24 BUF1S $PINS O=FE_OCPN898_carry_24 I=carry[24]
XFE_OCPC600_carry_11 BUF1S $PINS O=FE_OCPN600_carry_11 I=carry[11]
XFE_OCPC597_carry_9 BUF1S $PINS O=FE_OCPN597_carry_9 I=carry[9]
XFE_OCPC532_carry_10 BUF1S $PINS O=FE_OCPN532_carry_10 I=carry[10]
XFE_OCPC432_carry_19 BUF1S $PINS O=FE_OCPN432_carry_19 I=carry[19]
XFE_OCPC429_carry_15 BUF1S $PINS O=FE_OCPN429_carry_15 I=carry[15]
XFE_OCPC427_carry_25 BUF1S $PINS O=FE_OCPN427_carry_25 I=carry[25]
XFE_OCPC341_carry_22 BUF1S $PINS O=FE_OCPN341_carry_22 I=carry[22]
XFE_OCPC334_carry_12 BUF1S $PINS O=FE_OCPN334_carry_12 I=carry[12]
XFE_OCPC270_carry_23 BUF1S $PINS O=FE_OCPN270_carry_23 I=carry[23]
XFE_OCPC267_carry_17 BUF1S $PINS O=FE_OCPN267_carry_17 I=carry[17]
XFE_OCPC264_carry_20 BUF1S $PINS O=FE_OCPN264_carry_20 I=carry[20]
XFE_OCPC262_carry_18 BUF1S $PINS O=FE_OCPN262_carry_18 I=carry[18]
XFE_RC_3338_0 ND2 $PINS O=FE_RN_2163_0 I1=carry[22] I2=B[22]
XFE_RC_3337_0 AOI22H $PINS O=FE_RN_2164_0 A1=B[22] A2=A[22] B1=carry[22]
+ B2=A[22]
XFE_RC_3336_0 ND2P $PINS O=carry[23] I1=FE_RN_2164_0 I2=FE_RN_2163_0
XFE_RC_3331_0 ND2 $PINS O=FE_RN_2161_0 I1=carry[9] I2=B[9]
XFE_RC_3330_0 AOI22H $PINS O=FE_RN_2162_0 A1=B[9] A2=A[9] B1=carry[9] B2=A[9]
XFE_RC_3329_0 ND2P $PINS O=carry[10] I1=FE_RN_2162_0 I2=FE_RN_2161_0
XFE_RC_3228_0 INV1S $PINS O=FE_RN_2083_0 I=FE_RN_1865_0
XFE_RC_3227_0 OR2B1S $PINS O=FE_RN_2084_0 I1=FE_RN_1864_0 B1=FE_RN_2083_0
XFE_RC_3226_0 ND2 $PINS O=carry[5] I1=FE_RN_2084_0 I2=FE_RN_1867_0
XFE_RC_3128_0 ND2 $PINS O=FE_RN_2015_0 I1=carry[23] I2=B[23]
XFE_RC_3127_0 AOI22H $PINS O=FE_RN_2016_0 A1=A[23] A2=B[23] B1=carry[23]
+ B2=A[23]
XFE_RC_3126_0 ND2P $PINS O=carry[24] I1=FE_RN_2016_0 I2=FE_RN_2015_0
XFE_RC_3058_0 ND3 $PINS O=carry[4] I1=n22 I2=n23 I3=n24
XFE_RC_2918_0 INV1S $PINS O=FE_RN_1858_0 I=carry[4]
XFE_RC_2917_0 XOR2HS $PINS O=FE_PHN2045_FE_RN_1859_0 I1=FE_OCPN1234_N182
+ I2=B[4]
XFE_RC_2916_0 ND2 $PINS O=FE_RN_1860_0 I1=FE_RN_1859_0 I2=FE_RN_1858_0
XFE_RC_2915_0 ND2 $PINS O=FE_RN_1861_0 I1=B[4] I2=FE_OCPN1234_N182
XFE_RC_2914_0 ND2 $PINS O=FE_RN_1862_0 I1=FE_RN_1861_0 I2=FE_RN_1866_0
XFE_RC_2913_0 ND2 $PINS O=FE_RN_1863_0 I1=FE_RN_1862_0 I2=carry[4]
XFE_RC_2912_0 ND2 $PINS O=SUM[4] I1=FE_RN_1863_0 I2=FE_RN_1860_0
XFE_RC_2911_0 INV1S $PINS O=FE_RN_1864_0 I=A[4]
XFE_RC_2910_0 INV1S $PINS O=FE_RN_1865_0 I=B[4]
XFE_RC_2909_0 OR2 $PINS O=FE_RN_1866_0 I1=A[4] I2=B[4]
XFE_RC_2908_0 ND2 $PINS O=FE_RN_1867_0 I1=FE_RN_1866_0 I2=carry[4]
XFE_RC_2877_0 ND2 $PINS O=FE_RN_1837_0 I1=carry[20] I2=B[20]
XFE_RC_2876_0 AOI22H $PINS O=FE_RN_1838_0 A1=B[20] A2=A[20] B1=carry[20]
+ B2=A[20]
XFE_RC_2875_0 ND2P $PINS O=carry[21] I1=FE_RN_1838_0 I2=FE_RN_1837_0
XFE_RC_2662_0 ND2 $PINS O=FE_RN_1681_0 I1=carry[17] I2=B[17]
XFE_RC_2661_0 AOI22H $PINS O=FE_RN_1682_0 A1=A[17] A2=B[17] B1=carry[17]
+ B2=A[17]
XFE_RC_2660_0 ND2P $PINS O=carry[18] I1=FE_RN_1682_0 I2=FE_RN_1681_0
XFE_RC_2655_0 ND2 $PINS O=FE_RN_1677_0 I1=carry[21] I2=B[21]
XFE_RC_2654_0 AOI22H $PINS O=FE_RN_1678_0 A1=A[21] A2=B[21] B1=carry[21]
+ B2=A[21]
XFE_RC_2653_0 ND2P $PINS O=carry[22] I1=FE_RN_1678_0 I2=FE_RN_1677_0
XFE_RC_2562_0 ND2 $PINS O=FE_RN_1609_0 I1=carry[16] I2=B[16]
XFE_RC_2561_0 AOI22H $PINS O=FE_RN_1610_0 A1=B[16] A2=A[16] B1=carry[16]
+ B2=A[16]
XFE_RC_2560_0 ND2P $PINS O=carry[17] I1=FE_RN_1610_0 I2=FE_RN_1609_0
XFE_RC_2084_0 INV1S $PINS O=FE_RN_1247_0 I=carry[18]
XFE_RC_2083_0 XOR2HS $PINS O=FE_RN_1248_0 I1=B[18] I2=A[18]
XFE_RC_2082_0 ND2S $PINS O=FE_RN_1249_0 I1=FE_RN_1248_0 I2=FE_RN_1247_0
XFE_RC_2081_0 ND2 $PINS O=FE_RN_1250_0 I1=A[18] I2=B[18]
XFE_RC_2080_0 ND2 $PINS O=FE_RN_1251_0 I1=FE_RN_1250_0 I2=FE_RN_1256_0
XFE_RC_2079_0 ND2 $PINS O=FE_RN_1252_0 I1=FE_RN_1251_0 I2=FE_OCPN262_carry_18
XFE_RC_2078_0 ND2 $PINS O=SUM[18] I1=FE_RN_1252_0 I2=FE_RN_1249_0
XFE_RC_2076_0 INV1S $PINS O=FE_RN_1254_0 I=B[18]
XFE_RC_2075_0 INV1S $PINS O=FE_RN_1255_0 I=A[18]
XFE_RC_2074_0 ND2 $PINS O=FE_RN_1256_0 I1=FE_RN_1255_0 I2=FE_RN_1254_0
XFE_RC_2073_0 ND2P $PINS O=FE_RN_1257_0 I1=carry[18] I2=FE_RN_1256_0
XFE_RC_2072_0 ND2P $PINS O=carry[19] I1=FE_RN_1257_0 I2=FE_RN_1250_0
XFE_RC_1962_0 ND2 $PINS O=FE_RN_1164_0 I1=carry[19] I2=B[19]
XFE_RC_1961_0 AOI22H $PINS O=FE_RN_1165_0 A1=A[19] A2=B[19] B1=carry[19]
+ B2=A[19]
XFE_RC_1960_0 ND2P $PINS O=carry[20] I1=FE_RN_1165_0 I2=FE_RN_1164_0
XFE_RC_1509_0 INV1S $PINS O=FE_RN_813_0 I=A[11]
XFE_RC_1508_0 OR2 $PINS O=FE_RN_814_0 I1=B[11] I2=FE_RN_813_0
XFE_RC_1507_0 INV1S $PINS O=FE_RN_815_0 I=B[11]
XFE_RC_1506_0 XOR2HS $PINS O=FE_RN_816_0 I1=FE_OCPN600_carry_11 I2=A[11]
XFE_RC_1505_0 INV1S $PINS O=FE_RN_817_0 I=FE_OCPN600_carry_11
XFE_RC_1504_0 OAI222S $PINS O=SUM[11] A1=FE_RN_817_0 A2=FE_RN_819_0
+ B1=FE_RN_816_0 B2=FE_RN_815_0 C1=FE_OCPN600_carry_11 C2=FE_RN_814_0
XFE_RC_1503_0 ND2 $PINS O=FE_RN_818_0 I1=A[11] I2=B[11]
XFE_RC_1502_0 OR2 $PINS O=FE_RN_819_0 I1=B[11] I2=A[11]
XFE_RC_1501_0 ND2 $PINS O=FE_RN_820_0 I1=FE_RN_819_0 I2=carry[11]
XFE_RC_1500_0 ND2 $PINS O=carry[12] I1=FE_RN_820_0 I2=FE_RN_818_0
XFE_RC_1342_0 INV1S $PINS O=FE_RN_684_0 I=carry[12]
XFE_RC_1341_0 INV1S $PINS O=FE_RN_685_0 I=A[12]
XFE_RC_1340_0 OR2 $PINS O=FE_RN_686_0 I1=B[12] I2=FE_RN_685_0
XFE_RC_1337_0 MXL2HS $PINS OB=FE_RN_689_0 S=FE_RN_685_0 A=FE_OCPN334_carry_12
+ B=FE_RN_684_0
XFE_RC_1336_0 INV1S $PINS O=FE_RN_690_0 I=B[12]
XFE_RC_1335_0 OAI222S $PINS O=SUM[12] A1=FE_RN_690_0 A2=FE_RN_689_0
+ B1=FE_RN_686_0 B2=FE_OCPN334_carry_12 C1=FE_RN_684_0 C2=FE_RN_692_0
XFE_RC_1334_0 ND2 $PINS O=FE_RN_691_0 I1=A[12] I2=B[12]
XFE_RC_1333_0 OR2 $PINS O=FE_RN_692_0 I1=B[12] I2=A[12]
XFE_RC_1332_0 ND2 $PINS O=FE_RN_693_0 I1=FE_RN_692_0 I2=carry[12]
XFE_RC_1331_0 ND2P $PINS O=carry[13] I1=FE_RN_693_0 I2=FE_RN_691_0
XFE_RC_1323_0 ND3 $PINS O=carry[26] I1=n10 I2=n11 I3=n9
XFE_RC_1205_0 OR2 $PINS O=FE_RN_588_0 I1=FE_RN_262_0 I2=FE_RN_263_0
XFE_RC_1204_0 ND2 $PINS O=carry[15] I1=FE_RN_266_0 I2=FE_RN_588_0
XFE_RC_778_0 INV1S $PINS O=FE_RN_256_0 I=FE_OCPN1077_carry_14
XFE_RC_777_0 XOR2HS $PINS O=FE_RN_257_0 I1=FE_OCPN1064_N219 I2=A[14]
XFE_RC_776_0 ND2 $PINS O=FE_RN_258_0 I1=FE_RN_257_0 I2=FE_RN_256_0
XFE_RC_775_0 ND2 $PINS O=FE_RN_259_0 I1=A[14] I2=FE_OCPN1064_N219
XFE_RC_774_0 ND2 $PINS O=FE_RN_260_0 I1=FE_RN_259_0 I2=FE_RN_265_0
XFE_RC_773_0 ND2S $PINS O=FE_RN_261_0 I1=FE_RN_260_0 I2=FE_OCPN1077_carry_14
XFE_RC_772_0 ND2 $PINS O=SUM[14] I1=FE_RN_261_0 I2=FE_RN_258_0
XFE_RC_771_0 INV1S $PINS O=FE_RN_262_0 I=B[14]
XFE_RC_770_0 INV1S $PINS O=FE_RN_263_0 I=A[14]
XFE_RC_768_0 OR2B1S $PINS O=FE_RN_265_0 I1=A[14] B1=FE_RN_262_0
XFE_RC_767_0 ND2 $PINS O=FE_RN_266_0 I1=carry[14] I2=FE_RN_265_0
XFE_RC_677_0 INV1S $PINS O=FE_RN_211_0 I=FE_OCPN429_carry_15
XFE_RC_676_0 XOR2HS $PINS O=FE_RN_212_0 I1=FE_OCPN5_N193 I2=FE_OCPN1094_N220
XFE_RC_675_0 ND2 $PINS O=FE_RN_213_0 I1=FE_RN_212_0 I2=FE_RN_211_0
XFE_RC_674_0 INV1S $PINS O=FE_RN_214_0 I=FE_OCPN5_N193
XFE_RC_673_0 INV1S $PINS O=FE_RN_215_0 I=FE_OCPN1094_N220
XFE_RC_672_0 OAI12HS $PINS O=FE_RN_216_0 A1=FE_RN_219_0 B1=FE_RN_215_0
+ B2=FE_RN_214_0
XFE_RC_671_0 ND2 $PINS O=FE_RN_217_0 I1=FE_RN_216_0 I2=FE_OCPN429_carry_15
XFE_RC_670_0 ND2 $PINS O=SUM[15] I1=FE_RN_217_0 I2=FE_RN_213_0
XFE_RC_669_0 ND2 $PINS O=FE_RN_218_0 I1=B[15] I2=FE_OCPN5_N193
XFE_RC_668_0 OR2 $PINS O=FE_RN_219_0 I1=A[15] I2=B[15]
XFE_RC_667_0 ND2P $PINS O=FE_RN_220_0 I1=carry[15] I2=FE_RN_219_0
XFE_RC_666_0 ND2P $PINS O=carry[16] I1=FE_RN_220_0 I2=FE_RN_218_0
XFE_RC_567_0 XOR3 $PINS O=SUM[16] I1=A[16] I2=B[16] I3=carry[16]
XFE_RC_462_0 XOR3 $PINS O=SUM[8] I1=A[8] I2=B[8] I3=FE_OCPN1100_carry_8
XFE_RC_461_0 MAO222 $PINS O=carry[9] A1=A[8] B1=B[8] C1=carry[8]
XFE_RC_460_0 XOR3 $PINS O=SUM[17] I1=A[17] I2=B[17] I3=FE_OCPN267_carry_17
XFE_RC_387_0 ND3P $PINS O=carry[7] I1=n18 I2=n17 I3=n16
XFE_RC_384_0 XOR3 $PINS O=SUM[9] I1=A[9] I2=B[9] I3=FE_OCPN597_carry_9
XFE_RC_235_0 XOR3 $PINS O=SUM[10] I1=A[10] I2=B[10] I3=FE_OCPN532_carry_10
XFE_RC_234_0 MAO222 $PINS O=carry[11] A1=carry[10] B1=B[10] C1=A[10]
XFE_RC_170_0 XOR3 $PINS O=SUM[19] I1=A[19] I2=B[19] I3=FE_OCPN432_carry_19
XFE_RC_166_0 XOR3 $PINS O=SUM[22] I1=A[22] I2=B[22] I3=FE_OCPN341_carry_22
XFE_RC_72_0 XOR3 $PINS O=SUM[20] I1=A[20] I2=B[20] I3=FE_OCPN264_carry_20
XFE_RC_70_0 XOR3 $PINS O=SUM[23] I1=A[23] I2=B[23] I3=FE_OCPN270_carry_23
XFE_RC_43_0 XOR3 $PINS O=SUM[21] I1=A[21] I2=B[21] I3=FE_OCPN1035_carry_21
XU1_1 FA1 $PINS S=SUM[1] CO=carry[2] A=A[1] B=B[1] CI=n4
XU1_26 XOR3 $PINS O=SUM[26] I1=A[26] I2=B[26] I3=carry[26]
XU1 ND2 $PINS O=n25 I1=carry[7] I2=B[7]
XU4 XOR3 $PINS O=SUM[5] I1=A[5] I2=B[5] I3=carry[5]
XU5 XOR3 $PINS O=SUM[24] I1=A[24] I2=B[24] I3=FE_OCPN898_carry_24
XU7 ND2 $PINS O=n12 I1=A[5] I2=B[5]
XU8 ND2 $PINS O=n5 I1=A[24] I2=B[24]
XU9 AN2 $PINS O=n4 I1=B[0] I2=A[0]
XU10 ND2 $PINS O=n6 I1=A[24] I2=carry[24]
XU11 ND2P $PINS O=n7 I1=B[24] I2=carry[24]
XU12 ND3P $PINS O=carry[25] I1=n6 I2=n7 I3=n5
XU13 XOR2HS $PINS O=n8 I1=A[25] I2=B[25]
XU14 XOR2HS $PINS O=SUM[25] I1=n8 I2=FE_OCPN427_carry_25
XU15 ND2 $PINS O=n9 I1=A[25] I2=B[25]
XU16 ND2 $PINS O=n10 I1=A[25] I2=carry[25]
XU17 ND2 $PINS O=n11 I1=B[25] I2=carry[25]
XU19 ND2 $PINS O=n27 I1=carry[7] I2=A[7]
XU20 ND3 $PINS O=carry[8] I1=n25 I2=n26 I3=n27
XU21 XOR3S $PINS O=SUM[7] I1=carry[7] I2=A[7] I3=B[7]
XU22 ND2 $PINS O=n13 I1=A[5] I2=carry[5]
XU23 ND2 $PINS O=n14 I1=B[5] I2=carry[5]
XU24 ND3P $PINS O=carry[6] I1=n12 I2=n13 I3=n14
XU25 XOR2HS $PINS O=n15 I1=A[6] I2=B[6]
XU26 XOR2HS $PINS O=SUM[6] I1=n15 I2=FE_OCPN1073_carry_6
XU27 ND2S $PINS O=n16 I1=A[6] I2=B[6]
XU28 ND2 $PINS O=n17 I1=A[6] I2=carry[6]
XU29 ND2 $PINS O=n18 I1=B[6] I2=carry[6]
XU31 XOR3P $PINS O=SUM[2] I1=carry[2] I2=A[2] I3=B[2]
XU32 ND2 $PINS O=n19 I1=B[2] I2=carry[2]
XU33 ND2 $PINS O=n20 I1=B[2] I2=A[2]
XU34 ND2 $PINS O=n21 I1=carry[2] I2=A[2]
XU35 ND3 $PINS O=carry[3] I1=n19 I2=n20 I3=n21
XU36 XOR3S $PINS O=SUM[3] I1=A[3] I2=B[3] I3=carry[3]
XU37 ND2 $PINS O=n22 I1=carry[3] I2=A[3]
XU38 ND2 $PINS O=n23 I1=carry[3] I2=B[3]
XU39 ND2 $PINS O=n24 I1=A[3] I2=B[3]
XU41 ND2 $PINS O=n26 I1=B[7] I2=A[7]
XU42 XOR2HS $PINS O=SUM[0] I1=B[0] I2=A[0]
.ENDS

.SUBCKT PE_Shift_Add_3 rst_n en clear calc_done stage_sel x_in[16] x_in[15]
+ x_in[14] x_in[13] x_in[12] x_in[11] x_in[10] x_in[9] x_in[8] x_in[7] x_in[6]
+ x_in[5] x_in[4] x_in[3] x_in[2] x_in[1] x_in[0] sign1[1] sign1[0] sign2[1]
+ sign2[0] sign3[1] sign3[0] shf1[3] shf1[2] shf1[1] shf1[0] shf2[3] shf2[2]
+ shf2[1] shf2[0] shf3[3] shf3[2] shf3[1] shf3[0] y_out[16] y_out[15] y_out[14]
+ y_out[13] y_out[12] y_out[11] y_out[10] y_out[9] y_out[8] y_out[7] y_out[6]
+ y_out[5] y_out[4] y_out[3] y_out[2] y_out[1] y_out[0] i_rst_n
+ FE_OFN54_i_rst_n FE_OFN29_i_rst_n FE_OFN13_i_rst_n FE_OFN9_i_rst_n
+ FE_OFN108_h22_3 FE_OFN115_h23_2 FE_OFN116_h23_1 FE_OFN117_h23_0
+ FE_OFN143_h23_3 FE_OFN141_h23_3 FE_OFN146_s21_0 FE_OFN153_h21_2
+ FE_OFN160_s23_0 FE_OFN158_s23_0 FE_OFN167_s21_1 FE_OFN168_s23_1
+ FE_OFN393_mac_in_real_1 FE_OFN411_mac_in_real_4 FE_OFN334_mac_in_real_3
+ FE_OFN370_mac_in_real_2 clk clk_clone1 clk_clone2
XFE_PHC2241_pe_r2_10 BUF1CK $PINS O=FE_PHN2241_pe_r2_10 I=FE_PHN1643_pe_r2_10
XFE_PHC2194_pe_r2_11 BUF1CK $PINS O=y_out[11] I=FE_PHN2194_pe_r2_11
XFE_PHC2182_pe_r2_16 BUF1CK $PINS O=FE_PHN1599_pe_r2_16 I=FE_PHN2182_pe_r2_16
XFE_PHC2177_pe_r2_4 BUF3 $PINS O=FE_PHN1408_pe_r2_4 I=FE_PHN2177_pe_r2_4
XFE_PHC2169_pe_r2_13 BUF1CK $PINS O=y_out[13] I=FE_PHN2169_pe_r2_13
XFE_PHC2168_pe_r2_15 BUF1CK $PINS O=y_out[15] I=FE_PHN2168_pe_r2_15
XFE_PHC2160_pe_r2_0 BUF2CK $PINS O=y_out[0] I=FE_PHN2160_pe_r2_0
XFE_PHC2145_pe_r2_3 BUF1CK $PINS O=FE_PHN1406_pe_r2_3 I=FE_PHN2145_pe_r2_3
XFE_PHC2140_N251 BUF1CK $PINS O=FE_PHN2140_N251 I=N251
XFE_PHC2043_next_acc_6 BUF1CK $PINS O=FE_PHN2043_next_acc_6 I=next_acc[6]
XFE_PHC1968_next_acc_0 DELB $PINS O=FE_PHN1968_next_acc_0 I=next_acc[0]
XFE_PHC1866_N248 DELC $PINS O=N248 I=FE_PHN1866_N248
XFE_PHC1865_N246 DELC $PINS O=FE_PHN1865_N246 I=N246
XFE_PHC1863_N247 DELB $PINS O=FE_PHN1863_N247 I=N247
XFE_PHC1862_N249 DELC $PINS O=N249 I=FE_PHN1862_N249
XFE_PHC1715_pe_r2_12 DELC $PINS O=y_out[12] I=FE_PHN1715_pe_r2_12
XFE_PHC1711_pe_r2_14 DELC $PINS O=y_out[14] I=FE_PHN1711_pe_r2_14
XFE_PHC1643_pe_r2_10 DELC $PINS O=y_out[10] I=FE_PHN2241_pe_r2_10
XFE_PHC1599_pe_r2_16 DELC $PINS O=y_out[16] I=FE_PHN1599_pe_r2_16
XFE_PHC1583_acc_reg_25 DELC $PINS O=acc_reg[25] I=FE_PHN1583_acc_reg_25
XFE_PHC1549_N236 DELB $PINS O=FE_PHN1549_N236 I=N236
XFE_PHC1547_N237 DELB $PINS O=FE_PHN1547_N237 I=N237
XFE_PHC1542_N239 DELB $PINS O=FE_PHN1542_N239 I=N239
XFE_PHC1541_N235 DELB $PINS O=FE_PHN1541_N235 I=N235
XFE_PHC1540_N240 DELB $PINS O=FE_PHN1540_N240 I=N240
XFE_PHC1533_N242 DELC $PINS O=FE_PHN1533_N242 I=N242
XFE_PHC1530_N251 DELC $PINS O=N251 I=FE_PHN1530_N251
XFE_PHC1523_N238 DELC $PINS O=FE_PHN1523_N238 I=N238
XFE_PHC1509_N244 DELB $PINS O=FE_PHN1509_N244 I=N244
XFE_PHC1506_N245 DELC $PINS O=FE_PHN1506_N245 I=N245
XFE_PHC1501_N243 DELB $PINS O=FE_PHN1501_N243 I=N243
XFE_PHC1498_N241 DELB $PINS O=FE_PHN1498_N241 I=N241
XFE_PHC1408_pe_r2_4 DELC $PINS O=y_out[4] I=FE_PHN1408_pe_r2_4
XFE_PHC1406_pe_r2_3 DELC $PINS O=y_out[3] I=FE_PHN1406_pe_r2_3
XFE_PHC1397_pe_r2_5 DELC $PINS O=y_out[5] I=FE_PHN1397_pe_r2_5
XFE_RC_314_0 OA12P $PINS O=N96 A1=N69 B1=sign2[0] B2=FE_OFN289_s22_0
XFE_RC_307_0 OA12 $PINS O=N41 A1=N14 B1=FE_OFN314_s21_0 B2=sign1[0]
XFE_RC_280_0 ND2 $PINS O=FE_RN_129_0 I1=term2_shifted[14] I2=FE_OFN290_s22_0
XFE_RC_279_0 ND2 $PINS O=FE_RN_130_0 I1=N83 I2=n34
XFE_RC_278_0 ND2 $PINS O=N110 I1=FE_RN_130_0 I2=FE_RN_129_0
XFE_RC_238_0 ND2 $PINS O=FE_RN_108_0 I1=term2_shifted[19] I2=FE_OFN290_s22_0
XFE_RC_237_0 ND2 $PINS O=FE_RN_109_0 I1=N88 I2=n34
XFE_RC_236_0 ND2 $PINS O=N115 I1=FE_RN_109_0 I2=FE_RN_108_0
XFE_RC_205_0 ND2 $PINS O=FE_RN_95_0 I1=term2_shifted[6] I2=FE_OFN289_s22_0
XFE_RC_204_0 ND2 $PINS O=FE_RN_96_0 I1=N75 I2=FE_OFN383_s22_0
XFE_RC_203_0 ND2P $PINS O=N102 I1=FE_RN_96_0 I2=FE_RN_95_0
XFE_RC_197_0 INV1S $PINS O=FE_RN_89_0 I=FE_RN_2404_0
XFE_RC_196_0 INV1S $PINS O=FE_RN_90_0 I=FE_RN_2405_0
XFE_RC_195_0 ND2S $PINS O=FE_RN_91_0 I1=FE_RN_90_0 I2=FE_RN_89_0
XFE_RC_194_0 ND2S $PINS O=sll_16/ML_int[3][4] I1=FE_RN_2407_0 I2=FE_RN_91_0
XFE_RC_144_0 ND2 $PINS O=FE_RN_70_0 I1=term2_shifted[20] I2=FE_OFN290_s22_0
XFE_RC_143_0 ND2 $PINS O=FE_RN_71_0 I1=N89 I2=n34
XFE_RC_142_0 ND2P $PINS O=N116 I1=FE_RN_71_0 I2=FE_RN_70_0
XFE_RC_141_0 ND2 $PINS O=FE_RN_68_0 I1=term3_shifted[11] I2=FE_OFN407_s23_0
XFE_RC_140_0 ND2 $PINS O=FE_RN_69_0 I1=N135 I2=FE_OFN158_s23_0
XFE_RC_139_0 ND2 $PINS O=N162 I1=FE_RN_69_0 I2=FE_RN_68_0
XFE_RC_137_0 AO22 $PINS O=N46 A1=term1_shifted[5] A2=sign1[0] B1=N19
+ B2=FE_OFN314_s21_0
XFE_RC_136_0 AO22 $PINS O=N58 A1=term1_shifted[17] A2=FE_OFN313_s21_0 B1=N31
+ B2=FE_OFN146_s21_0
XFE_RC_85_0 ND2 $PINS O=FE_RN_48_0 I1=term3_shifted[6] I2=FE_OFN292_s23_0
XFE_RC_84_0 ND2 $PINS O=FE_RN_49_0 I1=N130 I2=sign3[0]
XFE_RC_83_0 ND2 $PINS O=N157 I1=FE_RN_49_0 I2=FE_RN_48_0
XFE_OCPC1157_n65 BUF1S $PINS O=FE_OCPN1157_n65 I=n65
XFE_OFC886_FE_OFN99_h22_0 BUF1 $PINS O=FE_OFN490_FE_OFN99_h22_0 I=shf2[0]
XFE_OFC880_h23_0 BUF1 $PINS O=FE_RN_2 I=FE_OFN117_h23_0
XFE_OFC878_FE_OFN93_h21_0 BUF2CK $PINS O=FE_OFN482_FE_OFN93_h21_0 I=shf1[0]
XFE_RC_4004_0 ND2 $PINS O=FE_RN_2593_0 I1=term3_shifted[15] I2=FE_OFN407_s23_0
XFE_RC_4003_0 ND2 $PINS O=FE_RN_2594_0 I1=N139 I2=FE_OFN158_s23_0
XFE_RC_4002_0 ND2 $PINS O=N166 I1=FE_RN_2594_0 I2=FE_RN_2593_0
XFE_RC_3951_0 AO22 $PINS O=N57 A1=term1_shifted[16] A2=FE_OFN313_s21_0 B1=N30
+ B2=FE_OFN312_s21_0
XFE_RC_3894_0 ND2 $PINS O=FE_RN_2548_0 I1=term1_shifted[18] I2=FE_OFN313_s21_0
XFE_RC_3893_0 ND2 $PINS O=FE_RN_2549_0 I1=N32 I2=FE_OFN146_s21_0
XFE_RC_3892_0 ND2 $PINS O=N59 I1=FE_RN_2549_0 I2=FE_RN_2548_0
XFE_RC_3772_0 ND2S $PINS O=FE_RN_2474_0 I1=term1_in[3] I2=shf1[0]
XFE_RC_3771_0 INV1S $PINS O=FE_RN_2475_0 I=shf1[0]
XFE_RC_3770_0 ND2S $PINS O=FE_RN_2476_0 I1=term1_in[4] I2=FE_RN_2475_0
XFE_RC_3769_0 ND2 $PINS O=sll_16/ML_int[1][4] I1=FE_RN_2476_0 I2=FE_RN_2474_0
XFE_RC_3671_0 INV1S $PINS O=FE_RN_2404_0 I=FE_OFN382_h21_2
XFE_RC_3670_0 INV1S $PINS O=FE_RN_2405_0 I=n58
XFE_RC_3669_0 INV1S $PINS O=FE_RN_2406_0 I=FE_OFN382_h21_2
XFE_RC_3668_0 ND2S $PINS O=FE_RN_2407_0 I1=sll_16/ML_int[2][4] I2=FE_RN_2406_0
XFE_RC_3657_0 INV1S $PINS O=FE_RN_2394_0 I=FE_OFN346_h23_1
XFE_RC_3656_0 ND2S $PINS O=FE_RN_2395_0 I1=sll_18/ML_int[1][3] I2=FE_RN_2394_0
XFE_RC_3655_0 ND2 $PINS O=FE_RN_2396_0 I1=sll_18/ML_int[1][1]
+ I2=FE_OFN346_h23_1
XFE_RC_3654_0 ND2 $PINS O=sll_18/ML_int[2][3] I1=FE_RN_2396_0 I2=FE_RN_2395_0
XFE_RC_3586_0 ND2 $PINS O=FE_RN_2341_0 I1=term3_shifted[12] I2=FE_OFN407_s23_0
XFE_RC_3585_0 ND2 $PINS O=FE_RN_2342_0 I1=N136 I2=FE_OFN158_s23_0
XFE_RC_3584_0 ND2 $PINS O=N163 I1=FE_RN_2342_0 I2=FE_RN_2341_0
XFE_RC_3576_0 INV1S $PINS O=FE_RN_2333_0 I=shf1[0]
XFE_RC_3575_0 ND2 $PINS O=FE_RN_2334_0 I1=term1_in[1] I2=FE_RN_2333_0
XFE_RC_3574_0 ND2 $PINS O=FE_RN_2335_0 I1=term1_in[0] I2=shf1[0]
XFE_RC_3573_0 ND2 $PINS O=sll_16/ML_int[1][1] I1=FE_RN_2335_0 I2=FE_RN_2334_0
XFE_RC_3238_0 ND2S $PINS O=FE_RN_2088_0 I1=term2_in[0]
+ I2=FE_OFN490_FE_OFN99_h22_0
XFE_RC_3237_0 INV2 $PINS O=FE_RN_2089_0 I=shf2[0]
XFE_RC_3236_0 ND2S $PINS O=FE_RN_2090_0 I1=term2_in[1] I2=FE_RN_2089_0
XFE_RC_3235_0 ND2 $PINS O=sll_17/ML_int[1][1] I1=FE_RN_2090_0 I2=FE_RN_2088_0
XFE_RC_3221_0 ND2 $PINS O=FE_RN_2079_0 I1=term2_shifted[1] I2=FE_OFN289_s22_0
XFE_RC_3220_0 ND2P $PINS O=FE_RN_2080_0 I1=N70 I2=sign2[0]
XFE_RC_3219_0 ND2P $PINS O=N97 I1=FE_RN_2080_0 I2=FE_RN_2079_0
XFE_RC_2971_0 ND2 $PINS O=FE_RN_1907_0 I1=term2_shifted[4] I2=FE_OFN289_s22_0
XFE_RC_2970_0 ND2 $PINS O=FE_RN_1908_0 I1=N73 I2=FE_OFN383_s22_0
XFE_RC_2969_0 ND2 $PINS O=N100 I1=FE_RN_1908_0 I2=FE_RN_1907_0
XFE_RC_1661_0 ND2S $PINS O=FE_RN_933_0 I1=sll_18/ML_int[1][2] I2=FE_RN_2394_0
XFE_RC_1660_0 ND2 $PINS O=FE_RN_934_0 I1=sll_18/ML_int[1][0] I2=FE_OFN346_h23_1
XFE_RC_1659_0 ND2 $PINS O=sll_18/ML_int[2][2] I1=FE_RN_934_0 I2=FE_RN_933_0
XFE_RC_1628_0 ND2 $PINS O=FE_RN_906_0 I1=term3_shifted[3] I2=FE_OFN292_s23_0
XFE_RC_1627_0 ND2 $PINS O=FE_RN_907_0 I1=N127 I2=sign3[0]
XFE_RC_1626_0 ND2 $PINS O=N154 I1=FE_RN_907_0 I2=FE_RN_906_0
XFE_RC_1609_0 ND2 $PINS O=FE_RN_894_0 I1=term3_shifted[7] I2=FE_OFN292_s23_0
XFE_RC_1608_0 ND2 $PINS O=FE_RN_895_0 I1=N131 I2=sign3[0]
XFE_RC_1607_0 ND2P $PINS O=N158 I1=FE_RN_895_0 I2=FE_RN_894_0
XFE_RC_1606_0 ND2 $PINS O=FE_RN_892_0 I1=term1_shifted[4] I2=sign1[0]
XFE_RC_1605_0 ND2 $PINS O=FE_RN_893_0 I1=N18 I2=FE_OFN314_s21_0
XFE_RC_1604_0 ND2P $PINS O=N45 I1=FE_RN_893_0 I2=FE_RN_892_0
XFE_RC_1565_0 ND2 $PINS O=FE_RN_861_0 I1=term3_shifted[5] I2=FE_OFN292_s23_0
XFE_RC_1564_0 ND2 $PINS O=FE_RN_862_0 I1=N129 I2=sign3[0]
XFE_RC_1563_0 ND2P $PINS O=N156 I1=FE_RN_862_0 I2=FE_RN_861_0
XFE_RC_1562_0 ND2S $PINS O=FE_RN_858_0 I1=term1_in[4]
+ I2=FE_OFN482_FE_OFN93_h21_0
XFE_RC_1561_0 INV1S $PINS O=FE_RN_859_0 I=shf1[0]
XFE_RC_1560_0 ND2 $PINS O=FE_RN_860_0 I1=term1_in[5] I2=FE_RN_859_0
XFE_RC_1559_0 ND2 $PINS O=sll_16/ML_int[1][5] I1=FE_RN_860_0 I2=FE_RN_858_0
XFE_RC_1161_0 INV1S $PINS O=FE_RN_549_0 I=FE_OFN117_h23_0
XFE_RC_1160_0 INV1S $PINS O=FE_RN_550_0 I=term3_in[1]
XFE_RC_1159_0 INV1S $PINS O=FE_RN_551_0 I=FE_OFN117_h23_0
XFE_RC_1158_0 ND2 $PINS O=FE_RN_552_0 I1=term3_in[2] I2=FE_RN_551_0
XFE_RC_1157_0 OAI12HS $PINS O=sll_18/ML_int[1][2] A1=FE_RN_552_0 B1=FE_RN_550_0
+ B2=FE_RN_549_0
XFE_RC_1083_0 ND2 $PINS O=FE_RN_497_0 I1=term2_shifted[2] I2=FE_OFN289_s22_0
XFE_RC_1082_0 ND2P $PINS O=FE_RN_498_0 I1=N71 I2=sign2[0]
XFE_RC_1081_0 ND2P $PINS O=N98 I1=FE_RN_498_0 I2=FE_RN_497_0
XFE_RC_1019_0 ND2 $PINS O=FE_RN_446_0 I1=term1_shifted[7] I2=sign1[0]
XFE_RC_1018_0 ND2 $PINS O=FE_RN_447_0 I1=N21 I2=FE_OFN314_s21_0
XFE_RC_1017_0 ND2 $PINS O=N48 I1=FE_RN_447_0 I2=FE_RN_446_0
XFE_RC_621_0 ND2 $PINS O=FE_RN_183_0 I1=term3_shifted[4] I2=FE_OFN292_s23_0
XFE_RC_620_0 ND2 $PINS O=FE_RN_184_0 I1=N128 I2=sign3[0]
XFE_RC_619_0 ND2P $PINS O=N155 I1=FE_RN_184_0 I2=FE_RN_183_0
XFE_RC_482_0 ND2 $PINS O=FE_RN_131_0 I1=term2_shifted[5] I2=FE_OFN289_s22_0
XFE_RC_481_0 ND2 $PINS O=FE_RN_132_0 I1=N74 I2=FE_OFN383_s22_0
XFE_RC_480_0 ND2 $PINS O=N101 I1=FE_RN_132_0 I2=FE_RN_131_0
XFE_RC_245_0 ND2 $PINS O=FE_RN_40_0 I1=term1_shifted[1] I2=sign1[0]
XFE_RC_244_0 ND2 $PINS O=FE_RN_41_0 I1=N15 I2=FE_OFN314_s21_0
XFE_RC_243_0 ND2 $PINS O=N42 I1=FE_RN_41_0 I2=FE_RN_40_0
XFE_RC_10_0 OA12 $PINS O=N151 A1=N124 B1=sign3[0] B2=FE_OFN292_s23_0
XFE_OFC864_h22_1 BUF1 $PINS O=FE_OFN467_h22_1 I=shf2[1]
XFE_OFC848_n29 BUF1 $PINS O=FE_OFN458_n29 I=n29
XFE_OFC752_sll_17_ML_int_2__3 INV1S $PINS O=n67 I=sll_17/ML_int[2][3]
XFE_OFC737_s23_1 BUF1 $PINS O=FE_OFN422_s23_1 I=sign3[1]
XFE_OFC716_s22_1 INV1S $PINS O=n1 I=sign2[1]
XFE_OFC701_s23_0 INV1S $PINS O=FE_OFN407_s23_0 I=FE_OFN158_s23_0
XFE_OFC699_s23_0 INV1S $PINS O=FE_OFN292_s23_0 I=sign3[0]
XFE_OFC671_s21_0 INV2 $PINS O=FE_OFN314_s21_0 I=sign1[0]
XFE_OFC670_s21_0 INV1S $PINS O=FE_OFN312_s21_0 I=sign1[0]
XFE_OFC650_s22_0 BUF1 $PINS O=FE_OFN383_s22_0 I=sign2[0]
XFE_OFC649_s22_0 INV1S $PINS O=FE_OFN289_s22_0 I=sign2[0]
XFE_OFC648_s22_0 BUF1 $PINS O=n34 I=sign2[0]
XFE_OFC645_h21_2 INV1S $PINS O=FE_OFN382_h21_2 I=shf1[2]
XFE_OFC626_h22_3 INV1S $PINS O=FE_RN_1 I=FE_OFN108_h22_3
XFE_OFC620_h22_2 INV1S $PINS O=n29 I=shf2[2]
XFE_OFC568_h23_1 INV1S $PINS O=FE_OFN346_h23_1 I=FE_OFN116_h23_1
XFE_OFC547_h21_1 INV1S $PINS O=n39 I=shf1[1]
XFE_OFC475_h21_3 INV1S $PINS O=n43 I=shf1[3]
XFE_OFC468_s21_0 INV1S $PINS O=FE_OFN313_s21_0 I=FE_OFN312_s21_0
XFE_OFC406_s22_0 INV1S $PINS O=FE_OFN290_s22_0 I=FE_OFN383_s22_0
XFE_OFC379_pe_clear_d1 INV1S $PINS O=n103 I=clear
XFE_OFC355_h23_2 BUF1 $PINS O=FE_OFN275_h23_2 I=FE_OFN115_h23_2
XU110 AO22 $PINS O=base_val[13] A1=acc_reg[13] A2=n103 B1=clear B2=stage_sel
XU111 AO22P $PINS O=N99 A1=sign2[0] A2=N72 B1=term2_shifted[3]
+ B2=FE_OFN289_s22_0
XU115 AO22 $PINS O=N67 A1=FE_OFN146_s21_0 A2=N40 B1=term1_shifted[26]
+ B2=FE_OFN313_s21_0
XU116 AO22 $PINS O=N66 A1=N39 A2=FE_OFN146_s21_0 B1=term1_shifted[25]
+ B2=FE_OFN313_s21_0
XU117 AO22 $PINS O=N65 A1=N38 A2=FE_OFN146_s21_0 B1=term1_shifted[24]
+ B2=FE_OFN313_s21_0
XU118 AO22 $PINS O=N64 A1=N37 A2=FE_OFN146_s21_0 B1=term1_shifted[23]
+ B2=FE_OFN313_s21_0
XU119 AO22 $PINS O=N63 A1=N36 A2=FE_OFN146_s21_0 B1=term1_shifted[22]
+ B2=FE_OFN313_s21_0
XU120 AO22 $PINS O=N62 A1=N35 A2=FE_OFN146_s21_0 B1=term1_shifted[21]
+ B2=FE_OFN313_s21_0
XU121 AO22 $PINS O=N61 A1=N34 A2=FE_OFN146_s21_0 B1=term1_shifted[20]
+ B2=FE_OFN313_s21_0
XU122 AO22 $PINS O=N60 A1=N33 A2=FE_OFN146_s21_0 B1=term1_shifted[19]
+ B2=FE_OFN313_s21_0
XU126 AO22 $PINS O=N56 A1=N29 A2=FE_OFN312_s21_0 B1=term1_shifted[15]
+ B2=FE_OFN313_s21_0
XU127 AO22 $PINS O=N55 A1=N28 A2=FE_OFN312_s21_0 B1=term1_shifted[14]
+ B2=FE_OFN313_s21_0
XU128 AO22 $PINS O=N54 A1=N27 A2=FE_OFN312_s21_0 B1=term1_shifted[13]
+ B2=FE_OFN313_s21_0
XU129 AO22 $PINS O=N53 A1=N26 A2=FE_OFN312_s21_0 B1=term1_shifted[12]
+ B2=FE_OFN313_s21_0
XU132 AO22 $PINS O=N50 A1=N23 A2=FE_OFN314_s21_0 B1=term1_shifted[9]
+ B2=sign1[0]
XU133 AO22 $PINS O=N49 A1=N22 A2=FE_OFN314_s21_0 B1=term1_shifted[8]
+ B2=sign1[0]
XU135 AO22 $PINS O=N47 A1=N20 A2=FE_OFN314_s21_0 B1=term1_shifted[6]
+ B2=sign1[0]
XU142 AO22 $PINS O=N177 A1=FE_OFN158_s23_0 A2=N150 B1=term3_shifted[26]
+ B2=FE_OFN160_s23_0
XU143 AO22 $PINS O=N176 A1=N149 A2=FE_OFN158_s23_0 B1=term3_shifted[25]
+ B2=FE_OFN160_s23_0
XU144 AO22 $PINS O=N175 A1=N148 A2=FE_OFN158_s23_0 B1=term3_shifted[24]
+ B2=FE_OFN160_s23_0
XU145 AO22 $PINS O=N174 A1=N147 A2=FE_OFN158_s23_0 B1=term3_shifted[23]
+ B2=FE_OFN160_s23_0
XU146 AO22 $PINS O=N173 A1=N146 A2=FE_OFN158_s23_0 B1=term3_shifted[22]
+ B2=FE_OFN160_s23_0
XU147 AO22 $PINS O=N172 A1=N145 A2=FE_OFN158_s23_0 B1=term3_shifted[21]
+ B2=FE_OFN160_s23_0
XU148 AO22 $PINS O=N171 A1=N144 A2=FE_OFN158_s23_0 B1=term3_shifted[20]
+ B2=FE_OFN160_s23_0
XU149 AO22 $PINS O=N170 A1=N143 A2=FE_OFN158_s23_0 B1=term3_shifted[19]
+ B2=FE_OFN160_s23_0
XU150 AO22P $PINS O=N169 A1=N142 A2=FE_OFN158_s23_0 B1=term3_shifted[18]
+ B2=FE_OFN160_s23_0
XU151 AO22P $PINS O=N168 A1=N141 A2=FE_OFN158_s23_0 B1=term3_shifted[17]
+ B2=FE_OFN160_s23_0
XU152 AO22P $PINS O=N167 A1=N140 A2=FE_OFN158_s23_0 B1=term3_shifted[16]
+ B2=FE_OFN407_s23_0
XU154 AO22 $PINS O=N165 A1=N138 A2=FE_OFN158_s23_0 B1=term3_shifted[14]
+ B2=FE_OFN407_s23_0
XU155 AO22 $PINS O=N164 A1=N137 A2=FE_OFN158_s23_0 B1=term3_shifted[13]
+ B2=FE_OFN407_s23_0
XU159 AO22 $PINS O=N160 A1=N133 A2=sign3[0] B1=term3_shifted[9]
+ B2=FE_OFN292_s23_0
XU160 AO22 $PINS O=N159 A1=N132 A2=sign3[0] B1=term3_shifted[8]
+ B2=FE_OFN292_s23_0
XU169 AO22 $PINS O=N122 A1=N95 A2=n34 B1=term2_shifted[26] B2=FE_OFN290_s22_0
XU170 AO22 $PINS O=N121 A1=N94 A2=n34 B1=term2_shifted[25] B2=FE_OFN290_s22_0
XU171 AO22 $PINS O=N120 A1=N93 A2=n34 B1=term2_shifted[24] B2=FE_OFN290_s22_0
XU172 AO22 $PINS O=N119 A1=N92 A2=n34 B1=term2_shifted[23] B2=FE_OFN290_s22_0
XU173 AO22 $PINS O=N118 A1=N91 A2=n34 B1=term2_shifted[22] B2=FE_OFN290_s22_0
XU174 AO22 $PINS O=N117 A1=N90 A2=n34 B1=term2_shifted[21] B2=FE_OFN290_s22_0
XU177 AO22 $PINS O=N114 A1=N87 A2=n34 B1=term2_shifted[18] B2=FE_OFN290_s22_0
XU178 AO22 $PINS O=N113 A1=N86 A2=n34 B1=term2_shifted[17] B2=FE_OFN290_s22_0
XU179 AO22 $PINS O=N112 A1=N85 A2=n34 B1=term2_shifted[16] B2=FE_OFN290_s22_0
XU180 AO22 $PINS O=N111 A1=N84 A2=n34 B1=term2_shifted[15] B2=FE_OFN290_s22_0
XU183 AO22 $PINS O=N108 A1=N81 A2=n34 B1=term2_shifted[12] B2=FE_OFN290_s22_0
XU184 AO22 $PINS O=N107 A1=N80 A2=n34 B1=term2_shifted[11] B2=FE_OFN290_s22_0
XU185 AO22 $PINS O=N106 A1=N79 A2=FE_OFN383_s22_0 B1=term2_shifted[10]
+ B2=FE_OFN290_s22_0
XU186 AO22 $PINS O=N105 A1=N78 A2=FE_OFN383_s22_0 B1=term2_shifted[9]
+ B2=FE_OFN289_s22_0
XU188 AO22 $PINS O=N103 A1=N76 A2=FE_OFN383_s22_0 B1=term2_shifted[7]
+ B2=FE_OFN289_s22_0
Xsll_18/M1_0_4 MUX2 $PINS O=sll_18/ML_int[1][4] S=FE_OFN117_h23_0 A=term3_in[4]
+ B=term3_in[3]
Xsll_18/M1_0_6 MUX2 $PINS O=sll_18/ML_int[1][6] S=FE_OFN117_h23_0 A=term3_in[6]
+ B=term3_in[5]
Xsll_18/M1_0_7 MUX2 $PINS O=sll_18/ML_int[1][7] S=FE_RN_2 A=term3_in[7]
+ B=term3_in[6]
Xsll_18/M1_0_8 MUX2 $PINS O=sll_18/ML_int[1][8] S=FE_RN_2 A=term3_in[8]
+ B=term3_in[7]
Xsll_18/M1_0_9 MUX2 $PINS O=sll_18/ML_int[1][9] S=FE_RN_2 A=term3_in[9]
+ B=term3_in[8]
Xsll_18/M1_0_10 MUX2 $PINS O=sll_18/ML_int[1][10] S=FE_RN_2 A=term3_in[10]
+ B=term3_in[9]
Xsll_18/M1_1_4 MUX2 $PINS O=sll_18/ML_int[2][4] S=FE_OFN346_h23_1
+ A=sll_18/ML_int[1][4] B=sll_18/ML_int[1][2]
Xsll_18/M1_1_5 MUX2 $PINS O=sll_18/ML_int[2][5] S=shf3[1] A=sll_18/ML_int[1][5]
+ B=sll_18/ML_int[1][3]
Xsll_18/M1_1_6 MUX2 $PINS O=sll_18/ML_int[2][6] S=shf3[1] A=sll_18/ML_int[1][6]
+ B=sll_18/ML_int[1][4]
Xsll_18/M1_1_7 MUX2 $PINS O=sll_18/ML_int[2][7] S=shf3[1] A=sll_18/ML_int[1][7]
+ B=sll_18/ML_int[1][5]
Xsll_18/M1_1_8 MUX2 $PINS O=sll_18/ML_int[2][8] S=shf3[1] A=sll_18/ML_int[1][8]
+ B=sll_18/ML_int[1][6]
Xsll_18/M1_1_9 MUX2 $PINS O=sll_18/ML_int[2][9] S=shf3[1] A=sll_18/ML_int[1][9]
+ B=sll_18/ML_int[1][7]
Xsll_18/M1_1_10 MUX2 $PINS O=sll_18/ML_int[2][10] S=shf3[1]
+ A=sll_18/ML_int[1][10] B=sll_18/ML_int[1][8]
Xsll_18/M1_1_11 MUX2 $PINS O=sll_18/ML_int[2][11] S=shf3[1]
+ A=sll_18/ML_int[1][11] B=sll_18/ML_int[1][9]
Xsll_18/M1_2_4 MUX2 $PINS O=sll_18/ML_int[3][4] S=FE_OFN115_h23_2
+ A=sll_18/ML_int[2][4] B=n80
Xsll_18/M1_2_5 MUX2 $PINS O=sll_18/ML_int[3][5] S=FE_OFN115_h23_2
+ A=sll_18/ML_int[2][5] B=n81
Xsll_18/M1_2_7 MUX2 $PINS O=sll_18/ML_int[3][7] S=FE_OFN115_h23_2
+ A=sll_18/ML_int[2][7] B=sll_18/ML_int[2][3]
Xsll_18/M1_2_8 MUX2 $PINS O=sll_18/ML_int[3][8] S=FE_OFN115_h23_2
+ A=sll_18/ML_int[2][8] B=sll_18/ML_int[2][4]
Xsll_18/M1_2_9 MUX2 $PINS O=sll_18/ML_int[3][9] S=FE_OFN275_h23_2
+ A=sll_18/ML_int[2][9] B=sll_18/ML_int[2][5]
Xsll_18/M1_2_10 MUX2 $PINS O=sll_18/ML_int[3][10] S=FE_OFN275_h23_2
+ A=sll_18/ML_int[2][10] B=sll_18/ML_int[2][6]
Xsll_18/M1_2_11 MUX2 $PINS O=sll_18/ML_int[3][11] S=FE_OFN275_h23_2
+ A=sll_18/ML_int[2][11] B=sll_18/ML_int[2][7]
Xsll_18/M1_2_12 MUX2 $PINS O=sll_18/ML_int[3][12] S=FE_OFN275_h23_2
+ A=sll_18/ML_int[2][12] B=sll_18/ML_int[2][8]
Xsll_18/M1_2_13 MUX2 $PINS O=sll_18/ML_int[3][13] S=FE_OFN275_h23_2
+ A=sll_18/ML_int[2][13] B=sll_18/ML_int[2][9]
Xsll_18/M1_3_8 MUX2 $PINS O=term3_shifted[8] S=shf3[3] A=sll_18/ML_int[3][8]
+ B=sll_18/ML_int[3][0]
Xsll_18/M1_3_9 MUX2 $PINS O=term3_shifted[9] S=shf3[3] A=sll_18/ML_int[3][9]
+ B=sll_18/ML_int[3][1]
Xsll_18/M1_3_10 MUX2 $PINS O=term3_shifted[10] S=shf3[3] A=sll_18/ML_int[3][10]
+ B=sll_18/ML_int[3][2]
Xsll_18/M1_3_11 MUX2 $PINS O=term3_shifted[11] S=shf3[3] A=sll_18/ML_int[3][11]
+ B=sll_18/ML_int[3][3]
Xsll_18/M1_3_12 MUX2 $PINS O=term3_shifted[12] S=shf3[3] A=sll_18/ML_int[3][12]
+ B=sll_18/ML_int[3][4]
Xsll_18/M1_3_13 MUX2 $PINS O=term3_shifted[13] S=shf3[3] A=sll_18/ML_int[3][13]
+ B=sll_18/ML_int[3][5]
Xsll_18/M1_3_14 MUX2 $PINS O=term3_shifted[14] S=shf3[3] A=sll_18/ML_int[3][14]
+ B=sll_18/ML_int[3][6]
Xsll_18/M1_3_15 MUX2 $PINS O=term3_shifted[15] S=shf3[3] A=sll_18/ML_int[3][15]
+ B=sll_18/ML_int[3][7]
Xsll_18/M1_3_16 MUX2 $PINS O=term3_shifted[16] S=shf3[3] A=sll_18/ML_int[3][16]
+ B=sll_18/ML_int[3][8]
Xsll_18/M1_3_17 MUX2 $PINS O=term3_shifted[17] S=shf3[3] A=sll_18/ML_int[3][17]
+ B=sll_18/ML_int[3][9]
Xsll_18/M1_3_23 MUX2 $PINS O=term3_shifted[23] S=FE_OFN143_h23_3 A=term3_in[26]
+ B=sll_18/ML_int[3][15]
Xsll_17/M1_0_2 MUX2 $PINS O=sll_17/ML_int[1][2] S=shf2[0] A=term2_in[2]
+ B=term2_in[1]
Xsll_17/M1_0_3 MUX2 $PINS O=sll_17/ML_int[1][3] S=shf2[0] A=term2_in[3]
+ B=term2_in[2]
Xsll_17/M1_0_4 MUX2 $PINS O=sll_17/ML_int[1][4] S=shf2[0] A=term2_in[4]
+ B=term2_in[3]
Xsll_17/M1_0_5 MUX2 $PINS O=sll_17/ML_int[1][5] S=shf2[0] A=term2_in[5]
+ B=term2_in[4]
Xsll_17/M1_0_6 MUX2 $PINS O=sll_17/ML_int[1][6] S=shf2[0] A=term2_in[6]
+ B=term2_in[5]
Xsll_17/M1_0_7 MUX2 $PINS O=sll_17/ML_int[1][7] S=shf2[0] A=term2_in[7]
+ B=term2_in[6]
Xsll_17/M1_0_8 MUX2 $PINS O=sll_17/ML_int[1][8] S=shf2[0] A=term2_in[8]
+ B=term2_in[7]
Xsll_17/M1_0_9 MUX2 $PINS O=sll_17/ML_int[1][9] S=shf2[0] A=term2_in[9]
+ B=term2_in[8]
Xsll_17/M1_0_10 MUX2 $PINS O=sll_17/ML_int[1][10] S=shf2[0] A=term2_in[10]
+ B=term2_in[9]
Xsll_17/M1_1_2 MUX2 $PINS O=sll_17/ML_int[2][2] S=shf2[1] A=sll_17/ML_int[1][2]
+ B=sll_17/ML_int[1][0]
Xsll_17/M1_1_5 MUX2 $PINS O=sll_17/ML_int[2][5] S=shf2[1] A=sll_17/ML_int[1][5]
+ B=sll_17/ML_int[1][3]
Xsll_17/M1_1_6 MUX2 $PINS O=sll_17/ML_int[2][6] S=shf2[1] A=sll_17/ML_int[1][6]
+ B=sll_17/ML_int[1][4]
Xsll_17/M1_1_7 MUX2 $PINS O=sll_17/ML_int[2][7] S=shf2[1] A=sll_17/ML_int[1][7]
+ B=sll_17/ML_int[1][5]
Xsll_17/M1_1_8 MUX2 $PINS O=sll_17/ML_int[2][8] S=FE_OFN467_h22_1
+ A=sll_17/ML_int[1][8] B=sll_17/ML_int[1][6]
Xsll_17/M1_1_9 MUX2 $PINS O=sll_17/ML_int[2][9] S=FE_OFN467_h22_1
+ A=sll_17/ML_int[1][9] B=sll_17/ML_int[1][7]
Xsll_17/M1_1_10 MUX2 $PINS O=sll_17/ML_int[2][10] S=FE_OFN467_h22_1
+ A=sll_17/ML_int[1][10] B=sll_17/ML_int[1][8]
Xsll_17/M1_1_11 MUX2 $PINS O=sll_17/ML_int[2][11] S=FE_OFN467_h22_1
+ A=sll_17/ML_int[1][11] B=sll_17/ML_int[1][9]
Xsll_17/M1_2_4 MUX2 $PINS O=sll_17/ML_int[3][4] S=n29 A=sll_17/ML_int[2][4]
+ B=n69
Xsll_17/M1_2_5 MUX2 $PINS O=sll_17/ML_int[3][5] S=n29 A=sll_17/ML_int[2][5]
+ B=n70
Xsll_17/M1_2_8 MUX2 $PINS O=sll_17/ML_int[3][8] S=n29 A=sll_17/ML_int[2][8]
+ B=sll_17/ML_int[2][4]
Xsll_17/M1_2_9 MUX2 $PINS O=sll_17/ML_int[3][9] S=n29 A=sll_17/ML_int[2][9]
+ B=sll_17/ML_int[2][5]
Xsll_17/M1_2_10 MUX2 $PINS O=sll_17/ML_int[3][10] S=n29 A=sll_17/ML_int[2][10]
+ B=sll_17/ML_int[2][6]
Xsll_17/M1_2_12 MUX2 $PINS O=sll_17/ML_int[3][12] S=FE_OFN458_n29
+ A=sll_17/ML_int[2][12] B=sll_17/ML_int[2][8]
Xsll_17/M1_2_13 MUX2 $PINS O=sll_17/ML_int[3][13] S=FE_OFN458_n29
+ A=sll_17/ML_int[2][13] B=sll_17/ML_int[2][9]
Xsll_17/M1_3_8 MUX2 $PINS O=term2_shifted[8] S=FE_RN_1 A=sll_17/ML_int[3][8]
+ B=sll_17/ML_int[3][0]
Xsll_17/M1_3_9 MUX2 $PINS O=term2_shifted[9] S=FE_RN_1 A=sll_17/ML_int[3][9]
+ B=sll_17/ML_int[3][1]
Xsll_17/M1_3_10 MUX2 $PINS O=term2_shifted[10] S=FE_RN_1 A=sll_17/ML_int[3][10]
+ B=sll_17/ML_int[3][2]
Xsll_17/M1_3_11 MUX2 $PINS O=term2_shifted[11] S=FE_RN_1 A=sll_17/ML_int[3][11]
+ B=sll_17/ML_int[3][3]
Xsll_17/M1_3_12 MUX2 $PINS O=term2_shifted[12] S=FE_RN_1 A=sll_17/ML_int[3][12]
+ B=sll_17/ML_int[3][4]
Xsll_17/M1_3_13 MUX2 $PINS O=term2_shifted[13] S=FE_RN_1 A=sll_17/ML_int[3][13]
+ B=sll_17/ML_int[3][5]
Xsll_17/M1_3_14 MUX2 $PINS O=term2_shifted[14] S=FE_RN_1 A=sll_17/ML_int[3][14]
+ B=sll_17/ML_int[3][6]
Xsll_17/M1_3_16 MUX2 $PINS O=term2_shifted[16] S=FE_RN_1 A=sll_17/ML_int[3][16]
+ B=sll_17/ML_int[3][8]
Xsll_17/M1_3_17 MUX2 $PINS O=term2_shifted[17] S=FE_RN_1 A=sll_17/ML_int[3][17]
+ B=sll_17/ML_int[3][9]
Xsll_17/M1_3_23 MUX2 $PINS O=term2_shifted[23] S=FE_RN_1 A=term2_in[26]
+ B=sll_17/ML_int[3][15]
Xsll_16/M1_0_6 MUX2 $PINS O=sll_16/ML_int[1][6] S=shf1[0] A=term1_in[6]
+ B=term1_in[5]
Xsll_16/M1_0_7 MUX2 $PINS O=sll_16/ML_int[1][7] S=FE_OFN482_FE_OFN93_h21_0
+ A=term1_in[7] B=term1_in[6]
Xsll_16/M1_0_8 MUX2 $PINS O=sll_16/ML_int[1][8] S=shf1[0] A=term1_in[8]
+ B=term1_in[7]
Xsll_16/M1_0_9 MUX2 $PINS O=sll_16/ML_int[1][9] S=FE_OFN482_FE_OFN93_h21_0
+ A=term1_in[9] B=term1_in[8]
Xsll_16/M1_0_10 MUX2 $PINS O=sll_16/ML_int[1][10] S=FE_OFN482_FE_OFN93_h21_0
+ A=term1_in[10] B=term1_in[9]
Xsll_16/M1_1_2 MUX2 $PINS O=sll_16/ML_int[2][2] S=shf1[1] A=sll_16/ML_int[1][2]
+ B=sll_16/ML_int[1][0]
Xsll_16/M1_1_3 MUX2 $PINS O=sll_16/ML_int[2][3] S=shf1[1] A=sll_16/ML_int[1][3]
+ B=sll_16/ML_int[1][1]
Xsll_16/M1_1_5 MUX2 $PINS O=sll_16/ML_int[2][5] S=shf1[1] A=sll_16/ML_int[1][5]
+ B=sll_16/ML_int[1][3]
Xsll_16/M1_1_6 MUX2 $PINS O=sll_16/ML_int[2][6] S=shf1[1] A=sll_16/ML_int[1][6]
+ B=sll_16/ML_int[1][4]
Xsll_16/M1_1_7 MUX2 $PINS O=sll_16/ML_int[2][7] S=shf1[1] A=sll_16/ML_int[1][7]
+ B=sll_16/ML_int[1][5]
Xsll_16/M1_1_8 MUX2 $PINS O=sll_16/ML_int[2][8] S=shf1[1] A=sll_16/ML_int[1][8]
+ B=sll_16/ML_int[1][6]
Xsll_16/M1_1_9 MUX2 $PINS O=sll_16/ML_int[2][9] S=shf1[1] A=sll_16/ML_int[1][9]
+ B=sll_16/ML_int[1][7]
Xsll_16/M1_1_10 MUX2 $PINS O=sll_16/ML_int[2][10] S=shf1[1]
+ A=sll_16/ML_int[1][10] B=sll_16/ML_int[1][8]
Xsll_16/M1_1_11 MUX2 $PINS O=sll_16/ML_int[2][11] S=shf1[1]
+ A=sll_16/ML_int[1][11] B=sll_16/ML_int[1][9]
Xsll_16/M1_2_5 MUX2 $PINS O=sll_16/ML_int[3][5] S=FE_OFN382_h21_2
+ A=sll_16/ML_int[2][5] B=n59
Xsll_16/M1_2_7 MUX2 $PINS O=sll_16/ML_int[3][7] S=FE_OFN382_h21_2
+ A=sll_16/ML_int[2][7] B=sll_16/ML_int[2][3]
Xsll_16/M1_2_9 MUX2 $PINS O=sll_16/ML_int[3][9] S=FE_OFN382_h21_2
+ A=sll_16/ML_int[2][9] B=sll_16/ML_int[2][5]
Xsll_16/M1_2_10 MUX2 $PINS O=sll_16/ML_int[3][10] S=FE_OFN382_h21_2
+ A=sll_16/ML_int[2][10] B=sll_16/ML_int[2][6]
Xsll_16/M1_2_11 MUX2 $PINS O=sll_16/ML_int[3][11] S=FE_OFN382_h21_2
+ A=sll_16/ML_int[2][11] B=sll_16/ML_int[2][7]
Xsll_16/M1_2_12 MUX2 $PINS O=sll_16/ML_int[3][12] S=FE_OFN382_h21_2
+ A=sll_16/ML_int[2][12] B=sll_16/ML_int[2][8]
Xsll_16/M1_2_13 MUX2 $PINS O=sll_16/ML_int[3][13] S=FE_OFN382_h21_2
+ A=sll_16/ML_int[2][13] B=sll_16/ML_int[2][9]
Xsll_16/M1_3_8 MUX2 $PINS O=term1_shifted[8] S=shf1[3] A=sll_16/ML_int[3][8]
+ B=sll_16/ML_int[3][0]
Xsll_16/M1_3_9 MUX2 $PINS O=term1_shifted[9] S=shf1[3] A=sll_16/ML_int[3][9]
+ B=sll_16/ML_int[3][1]
Xsll_16/M1_3_10 MUX2 $PINS O=term1_shifted[10] S=shf1[3] A=sll_16/ML_int[3][10]
+ B=sll_16/ML_int[3][2]
Xsll_16/M1_3_11 MUX2 $PINS O=term1_shifted[11] S=shf1[3] A=sll_16/ML_int[3][11]
+ B=sll_16/ML_int[3][3]
Xsll_16/M1_3_12 MUX2 $PINS O=term1_shifted[12] S=shf1[3] A=sll_16/ML_int[3][12]
+ B=sll_16/ML_int[3][4]
Xsll_16/M1_3_13 MUX2 $PINS O=term1_shifted[13] S=shf1[3] A=sll_16/ML_int[3][13]
+ B=sll_16/ML_int[3][5]
Xsll_16/M1_3_14 MUX2 $PINS O=term1_shifted[14] S=shf1[3] A=sll_16/ML_int[3][14]
+ B=sll_16/ML_int[3][6]
Xsll_16/M1_3_15 MUX2 $PINS O=term1_shifted[15] S=shf1[3] A=sll_16/ML_int[3][15]
+ B=sll_16/ML_int[3][7]
Xsll_16/M1_3_16 MUX2 $PINS O=term1_shifted[16] S=shf1[3] A=sll_16/ML_int[3][16]
+ B=sll_16/ML_int[3][8]
Xsll_16/M1_3_17 MUX2 $PINS O=term1_shifted[17] S=shf1[3] A=sll_16/ML_int[3][17]
+ B=sll_16/ML_int[3][9]
Xy_out_reg[9] QDFFRBN $PINS Q=y_out[9] D=FE_PHN1509_N244 CK=net2265
+ RB=FE_OFN29_i_rst_n
Xy_out_reg[8] QDFFRBN $PINS Q=y_out[8] D=FE_PHN1501_N243 CK=net2265
+ RB=FE_OFN29_i_rst_n
Xy_out_reg[7] QDFFRBN $PINS Q=y_out[7] D=FE_PHN1533_N242 CK=net2265
+ RB=FE_OFN29_i_rst_n
Xy_out_reg[6] QDFFRBN $PINS Q=y_out[6] D=FE_PHN1498_N241 CK=net2265
+ RB=FE_OFN29_i_rst_n
Xy_out_reg[5] QDFFRBN $PINS Q=FE_PHN1397_pe_r2_5 D=FE_PHN1540_N240 CK=net2265
+ RB=FE_OFN29_i_rst_n
Xy_out_reg[4] QDFFRBN $PINS Q=FE_PHN2177_pe_r2_4 D=FE_PHN1542_N239 CK=net2265
+ RB=FE_OFN29_i_rst_n
Xy_out_reg[3] QDFFRBN $PINS Q=FE_PHN2145_pe_r2_3 D=FE_PHN1523_N238 CK=net2265
+ RB=FE_OFN29_i_rst_n
Xy_out_reg[2] QDFFRBN $PINS Q=y_out[2] D=FE_PHN1547_N237 CK=net2265
+ RB=FE_OFN29_i_rst_n
Xy_out_reg[1] QDFFRBN $PINS Q=y_out[1] D=FE_PHN1549_N236 CK=net2265
+ RB=FE_OFN29_i_rst_n
Xy_out_reg[0] QDFFRBN $PINS Q=FE_PHN2160_pe_r2_0 D=FE_PHN1541_N235 CK=net2265
+ RB=FE_OFN29_i_rst_n
Xy_out_reg[16] QDFFRBN $PINS Q=FE_PHN2182_pe_r2_16 D=FE_PHN2140_N251 CK=net2265
+ RB=FE_OFN29_i_rst_n
Xy_out_reg[10] QDFFRBN $PINS Q=FE_PHN1643_pe_r2_10 D=FE_PHN1506_N245 CK=net2265
+ RB=FE_OFN29_i_rst_n
Xy_out_reg[11] QDFFRBN $PINS Q=FE_PHN2194_pe_r2_11 D=FE_PHN1865_N246 CK=net2265
+ RB=FE_OFN29_i_rst_n
Xy_out_reg[12] QDFFRBN $PINS Q=FE_PHN1715_pe_r2_12 D=FE_PHN1863_N247 CK=net2265
+ RB=FE_OFN29_i_rst_n
Xacc_reg_reg[26] QDFFRBS $PINS Q=FE_PHN1530_N251 D=next_acc[26] CK=clk
+ RB=FE_OFN9_i_rst_n
Xy_out_reg[14] QDFFRBN $PINS Q=FE_PHN1711_pe_r2_14 D=N249 CK=net2265
+ RB=FE_OFN9_i_rst_n
Xy_out_reg[15] QDFFRBN $PINS Q=FE_PHN2168_pe_r2_15 D=N250 CK=net2265
+ RB=FE_OFN29_i_rst_n
Xy_out_reg[13] QDFFRBN $PINS Q=FE_PHN2169_pe_r2_13 D=N248 CK=net2265
+ RB=FE_OFN9_i_rst_n
Xacc_reg_reg[25] QDFFRBN $PINS Q=FE_PHN1583_acc_reg_25 D=next_acc[25] CK=clk
+ RB=FE_OFN9_i_rst_n
Xacc_reg_reg[24] QDFFRBN $PINS Q=acc_reg[24] D=next_acc[24] CK=clk_clone1
+ RB=FE_OFN9_i_rst_n
Xacc_reg_reg[23] QDFFRBN $PINS Q=acc_reg[23] D=next_acc[23] CK=clk_clone1
+ RB=FE_OFN54_i_rst_n
Xacc_reg_reg[22] QDFFRBN $PINS Q=acc_reg[22] D=next_acc[22] CK=clk_clone1
+ RB=FE_OFN54_i_rst_n
Xacc_reg_reg[21] QDFFRBN $PINS Q=acc_reg[21] D=next_acc[21] CK=clk_clone1
+ RB=FE_OFN54_i_rst_n
Xacc_reg_reg[20] QDFFRBN $PINS Q=acc_reg[20] D=next_acc[20] CK=clk_clone1
+ RB=FE_OFN54_i_rst_n
Xacc_reg_reg[19] QDFFRBN $PINS Q=acc_reg[19] D=next_acc[19] CK=clk_clone1
+ RB=FE_OFN13_i_rst_n
Xacc_reg_reg[18] QDFFRBN $PINS Q=acc_reg[18] D=next_acc[18] CK=clk_clone1
+ RB=FE_OFN13_i_rst_n
Xacc_reg_reg[17] QDFFRBN $PINS Q=acc_reg[17] D=next_acc[17] CK=clk_clone1
+ RB=FE_OFN13_i_rst_n
Xacc_reg_reg[16] QDFFRBN $PINS Q=acc_reg[16] D=next_acc[16] CK=clk_clone1
+ RB=FE_OFN13_i_rst_n
Xacc_reg_reg[15] QDFFRBN $PINS Q=acc_reg[15] D=next_acc[15] CK=clk_clone1
+ RB=FE_OFN13_i_rst_n
Xacc_reg_reg[14] QDFFRBN $PINS Q=acc_reg[14] D=next_acc[14] CK=clk_clone1
+ RB=FE_OFN13_i_rst_n
Xacc_reg_reg[13] QDFFRBN $PINS Q=acc_reg[13] D=next_acc[13] CK=clk_clone1
+ RB=FE_OFN13_i_rst_n
Xacc_reg_reg[12] QDFFRBN $PINS Q=acc_reg[12] D=next_acc[12] CK=clk_clone1
+ RB=FE_OFN13_i_rst_n
Xacc_reg_reg[11] QDFFRBN $PINS Q=acc_reg[11] D=next_acc[11] CK=clk_clone1
+ RB=FE_OFN13_i_rst_n
Xacc_reg_reg[10] QDFFRBN $PINS Q=acc_reg[10] D=next_acc[10] CK=clk_clone1
+ RB=FE_OFN13_i_rst_n
Xacc_reg_reg[9] QDFFRBN $PINS Q=acc_reg[9] D=next_acc[9] CK=clk_clone1
+ RB=FE_OFN13_i_rst_n
Xacc_reg_reg[8] QDFFRBN $PINS Q=acc_reg[8] D=next_acc[8] CK=clk_clone1
+ RB=FE_OFN13_i_rst_n
Xacc_reg_reg[7] QDFFRBN $PINS Q=acc_reg[7] D=next_acc[7] CK=clk_clone1
+ RB=FE_OFN13_i_rst_n
Xacc_reg_reg[6] QDFFRBN $PINS Q=acc_reg[6] D=FE_PHN2043_next_acc_6
+ CK=clk_clone1 RB=i_rst_n
Xacc_reg_reg[5] QDFFRBN $PINS Q=acc_reg[5] D=next_acc[5] CK=clk_clone1
+ RB=i_rst_n
Xacc_reg_reg[4] QDFFRBN $PINS Q=acc_reg[4] D=next_acc[4] CK=clk_clone1
+ RB=i_rst_n
Xacc_reg_reg[3] QDFFRBN $PINS Q=acc_reg[3] D=next_acc[3] CK=clk_clone1
+ RB=i_rst_n
Xacc_reg_reg[2] QDFFRBN $PINS Q=acc_reg[2] D=next_acc[2] CK=clk_clone1
+ RB=i_rst_n
Xacc_reg_reg[1] QDFFRBN $PINS Q=acc_reg[1] D=next_acc[1] CK=clk_clone1
+ RB=i_rst_n
Xacc_reg_reg[0] QDFFRBN $PINS Q=acc_reg[0] D=FE_PHN1968_next_acc_0
+ CK=clk_clone1 RB=i_rst_n
XU6 ND2T $PINS O=n64 I1=sll_17/ML_int[1][0] I2=n27
XU12 MUX2 $PINS O=sll_17/ML_int[2][3] S=shf2[1] A=sll_17/ML_int[1][3]
+ B=sll_17/ML_int[1][1]
XU13 MUX2 $PINS O=sll_18/ML_int[1][1] S=FE_OFN117_h23_0 A=term3_in[1]
+ B=term3_in[0]
XU21 INV1S $PINS O=n27 I=shf2[1]
XU26 INV2 $PINS O=n79 I=sll_18/ML_int[2][2]
XU27 AN2 $PINS O=term2_in[3] I1=n1 I2=x_in[3]
XU29 MUX2 $PINS O=FE_PHN1866_N248 S=stage_sel A=acc_reg[23] B=N251
XU30 NR2 $PINS O=term1_in[3] I1=sign1[1] I2=FE_OFN334_mac_in_real_3
XU31 OR2 $PINS O=n77 I1=FE_OFN115_h23_2 I2=shf3[3]
XU32 MUX2 $PINS O=N250 S=stage_sel A=acc_reg[25] B=N251
XU33 NR2 $PINS O=term1_in[4] I1=sign1[1] I2=FE_OFN411_mac_in_real_4
XU34 MUX2S $PINS O=sll_17/ML_int[3][7] S=shf2[2] A=sll_17/ML_int[2][3]
+ B=sll_17/ML_int[2][7]
XU35 AN2 $PINS O=base_val[2] I1=acc_reg[2] I2=n103
XU36 MUX2 $PINS O=FE_PHN1862_N249 S=stage_sel A=acc_reg[24] B=N251
XU37 ND2P $PINS O=n65 I1=sll_17/ML_int[1][1] I2=n27
XU38 NR2 $PINS O=sll_16/ML_int[3][2] I1=FE_OFN382_h21_2 I2=n57
XU39 INV2 $PINS O=n57 I=sll_16/ML_int[2][2]
XU40 NR2 $PINS O=sll_17/ML_int[3][3] I1=FE_OFN458_n29 I2=n67
XU41 MUX2 $PINS O=N247 S=stage_sel A=acc_reg[22] B=FE_PHN2140_N251
XU43 AN2T $PINS O=sll_16/ML_int[1][0] I1=term1_in[0] I2=n37
XU44 MUX2S $PINS O=sll_16/ML_int[3][8] S=FE_OFN382_h21_2 A=sll_16/ML_int[2][8]
+ B=sll_16/ML_int[2][4]
XU45 MUX2 $PINS O=sll_16/ML_int[2][4] S=shf1[1] A=sll_16/ML_int[1][4]
+ B=sll_16/ML_int[1][2]
XU47 MUX2S $PINS O=sll_18/ML_int[1][3] S=FE_OFN117_h23_0 A=term3_in[3]
+ B=term3_in[2]
XU48 NR2P $PINS O=term3_shifted[3] I1=n77 I2=n78
XU49 INV2 $PINS O=n78 I=sll_18/ML_int[2][3]
XU56 MUX2 $PINS O=sll_16/ML_int[1][3] S=shf1[0] A=term1_in[3] B=term1_in[2]
XU58 MUX2S $PINS O=n73 S=FE_OFN467_h22_1 A=term2_in[26] B=n74
XU59 MUX2S $PINS O=n72 S=FE_OFN467_h22_1 A=term2_in[26] B=sll_17/ML_int[1][15]
XU60 MUX2S $PINS O=n71 S=FE_OFN467_h22_1 A=n74 B=sll_17/ML_int[1][14]
XU61 MUX2 $PINS O=sll_17/ML_int[2][4] S=shf2[1] A=sll_17/ML_int[1][4]
+ B=sll_17/ML_int[1][2]
XU62 AN2T $PINS O=sll_17/ML_int[1][0] I1=term2_in[0] I2=n25
XU64 NR2T $PINS O=n2 I1=n66 I2=n65
XU65 AO22 $PINS O=N44 A1=N17 A2=FE_OFN314_s21_0 B1=term1_shifted[3] B2=sign1[0]
XU67 ND2 $PINS O=n66 I1=shf2[2] I2=FE_OFN108_h22_3
XU69 NR2F $PINS O=term2_shifted[0] I1=n66 I2=n64
XU70 ND2 $PINS O=n55 I1=shf1[2] I2=n43
XU71 ND2 $PINS O=n4 I1=N126 I2=sign3[0]
XU72 AO22 $PINS O=N51 A1=N24 A2=FE_OFN312_s21_0 B1=term1_shifted[10]
+ B2=sign1[0]
XU73 AO22 $PINS O=N161 A1=N134 A2=FE_OFN158_s23_0 B1=term3_shifted[10]
+ B2=FE_OFN407_s23_0
XU76 NR2 $PINS O=term1_in[8] I1=sign1[1] I2=x_in[8]
XU77 NR2P $PINS O=term2_in[0] I1=sign2[1] I2=n102
XU78 NR2P $PINS O=term1_in[0] I1=sign1[1] I2=n102
XU79 NR2T $PINS O=term3_shifted[1] I1=n77 I2=n76
XU81 INV1S $PINS O=n56 I=sll_16/ML_int[2][3]
XU83 AN2T $PINS O=term3_shifted[4] I1=sll_18/ML_int[3][4] I2=FE_OFN141_h23_3
XU86 AO22 $PINS O=N104 A1=N77 A2=FE_OFN383_s22_0 B1=term2_shifted[8]
+ B2=FE_OFN289_s22_0
XU89 MUX2 $PINS O=sll_16/ML_int[3][6] S=FE_OFN382_h21_2 A=sll_16/ML_int[2][6]
+ B=sll_16/ML_int[2][2]
XU91 MUX2 $PINS O=sll_18/ML_int[3][6] S=FE_OFN115_h23_2 A=sll_18/ML_int[2][6]
+ B=sll_18/ML_int[2][2]
XU92 MUX2S $PINS O=sll_17/ML_int[3][6] S=n29 A=sll_17/ML_int[2][6]
+ B=sll_17/ML_int[2][2]
XU94 NR2 $PINS O=term2_shifted[1] I1=n66 I2=n65
XU101 MUX2S $PINS O=sll_18/ML_int[1][5] S=FE_OFN117_h23_0 A=term3_in[5]
+ B=term3_in[4]
XU103 ND2S $PINS O=n5 I1=term3_shifted[2] I2=FE_OFN292_s23_0
XU104 ND2P $PINS O=N153 I1=n4 I2=n5
XU106 NR2P $PINS O=term3_in[1] I1=sign3[1] I2=FE_OFN393_mac_in_real_1
XU108 NR2 $PINS O=term2_in[1] I1=sign2[1] I2=FE_OFN393_mac_in_real_1
XU113 ND2S $PINS O=n10 I1=term3_shifted[1] I2=FE_OFN292_s23_0
XU139 MUX2S $PINS O=sll_17/ML_int[3][11] S=n29 A=sll_17/ML_int[2][11]
+ B=sll_17/ML_int[2][7]
XU141 MUX2S $PINS O=sll_16/ML_int[2][12] S=shf1[1] A=sll_16/ML_int[1][12]
+ B=sll_16/ML_int[1][10]
XU158 MUX2S $PINS O=sll_18/ML_int[2][12] S=shf3[1] A=sll_18/ML_int[1][12]
+ B=sll_18/ML_int[1][10]
XU162 MUX2 $PINS O=sll_17/ML_int[2][12] S=FE_OFN467_h22_1
+ A=sll_17/ML_int[1][12] B=sll_17/ML_int[1][10]
XU164 MUX2S $PINS O=sll_16/ML_int[1][11] S=FE_OFN482_FE_OFN93_h21_0
+ A=term1_in[11] B=term1_in[10]
XU166 MUX2S $PINS O=sll_18/ML_int[1][11] S=FE_RN_2 A=term3_in[11]
+ B=term3_in[10]
XU167 MUX2S $PINS O=sll_16/ML_int[3][14] S=FE_OFN382_h21_2
+ A=sll_16/ML_int[2][14] B=sll_16/ML_int[2][10]
XU168 MUX2S $PINS O=sll_17/ML_int[1][11] S=shf2[0] A=term2_in[11]
+ B=term2_in[10]
XU182 MUX2S $PINS O=sll_18/ML_int[3][14] S=FE_OFN275_h23_2
+ A=sll_18/ML_int[2][14] B=sll_18/ML_int[2][10]
XU187 MUX2S $PINS O=sll_18/ML_int[2][13] S=shf3[1] A=sll_18/ML_int[1][13]
+ B=sll_18/ML_int[1][11]
XU189 MUX2S $PINS O=sll_18/ML_int[1][13] S=FE_RN_2 A=term3_in[13]
+ B=term3_in[12]
XU190 MUX2S $PINS O=sll_17/ML_int[3][14] S=FE_OFN458_n29 A=sll_17/ML_int[2][14]
+ B=sll_17/ML_int[2][10]
XU191 MUX2S $PINS O=sll_16/ML_int[2][13] S=shf1[1] A=sll_16/ML_int[1][13]
+ B=sll_16/ML_int[1][11]
XU192 MUX2S $PINS O=sll_16/ML_int[1][13] S=FE_OFN482_FE_OFN93_h21_0
+ A=term1_in[13] B=term1_in[12]
XU193 MUX2S $PINS O=sll_17/ML_int[2][13] S=FE_OFN467_h22_1
+ A=sll_17/ML_int[1][13] B=sll_17/ML_int[1][11]
XU194 MUX2S $PINS O=sll_17/ML_int[1][13] S=shf2[0] A=term2_in[13]
+ B=term2_in[12]
XU195 MUX2S $PINS O=sll_16/ML_int[1][12] S=FE_OFN482_FE_OFN93_h21_0
+ A=term1_in[12] B=term1_in[11]
XU196 MUX2S $PINS O=sll_18/ML_int[1][12] S=FE_RN_2 A=term3_in[12]
+ B=term3_in[11]
XU197 MUX2S $PINS O=sll_16/ML_int[3][15] S=FE_OFN382_h21_2
+ A=sll_16/ML_int[2][15] B=sll_16/ML_int[2][11]
XU198 MUX2S $PINS O=sll_17/ML_int[1][12] S=shf2[0] A=term2_in[12]
+ B=term2_in[11]
XU199 MUX2S $PINS O=sll_18/ML_int[3][15] S=FE_OFN275_h23_2
+ A=sll_18/ML_int[2][15] B=sll_18/ML_int[2][11]
XU200 MUX2S $PINS O=sll_18/ML_int[2][14] S=shf3[1] A=sll_18/ML_int[1][14]
+ B=sll_18/ML_int[1][12]
XU201 MUX2S $PINS O=sll_18/ML_int[1][14] S=FE_RN_2 A=term3_in[14]
+ B=term3_in[13]
XU202 MUX2S $PINS O=term2_shifted[15] S=FE_RN_1 A=sll_17/ML_int[3][15]
+ B=sll_17/ML_int[3][7]
XU203 MUX2S $PINS O=sll_17/ML_int[3][15] S=FE_OFN458_n29 A=sll_17/ML_int[2][15]
+ B=sll_17/ML_int[2][11]
XU204 MUX2S $PINS O=sll_16/ML_int[2][14] S=shf1[1] A=sll_16/ML_int[1][14]
+ B=sll_16/ML_int[1][12]
XU205 MUX2S $PINS O=sll_16/ML_int[1][14] S=FE_OFN482_FE_OFN93_h21_0
+ A=term1_in[14] B=term1_in[13]
XU206 MUX2S $PINS O=sll_17/ML_int[2][14] S=FE_OFN467_h22_1
+ A=sll_17/ML_int[1][14] B=sll_17/ML_int[1][12]
XU207 MUX2S $PINS O=sll_17/ML_int[1][14] S=shf2[0] A=term2_in[14]
+ B=term2_in[13]
XU208 MUX2S $PINS O=sll_16/ML_int[3][16] S=FE_OFN382_h21_2 A=n60
+ B=sll_16/ML_int[2][12]
XU209 MUX2S $PINS O=sll_18/ML_int[3][16] S=FE_OFN275_h23_2 A=n82
+ B=sll_18/ML_int[2][12]
XU210 MUX2S $PINS O=sll_18/ML_int[2][15] S=shf3[1] A=sll_18/ML_int[1][15]
+ B=sll_18/ML_int[1][13]
XU211 MUX2S $PINS O=sll_18/ML_int[1][15] S=FE_RN_2 A=term3_in[15]
+ B=term3_in[14]
XU212 MUX2S $PINS O=sll_16/ML_int[2][15] S=shf1[1] A=sll_16/ML_int[1][15]
+ B=sll_16/ML_int[1][13]
XU213 MUX2S $PINS O=sll_17/ML_int[3][16] S=FE_OFN458_n29 A=n71
+ B=sll_17/ML_int[2][12]
XU214 MUX2S $PINS O=sll_16/ML_int[1][15] S=FE_OFN482_FE_OFN93_h21_0
+ A=term1_in[15] B=term1_in[14]
XU215 MUX2S $PINS O=sll_17/ML_int[2][15] S=FE_OFN467_h22_1
+ A=sll_17/ML_int[1][15] B=sll_17/ML_int[1][13]
XU216 MUX2S $PINS O=sll_17/ML_int[1][15] S=shf2[0] A=term2_in[15]
+ B=term2_in[14]
XU217 MUX2S $PINS O=sll_16/ML_int[3][17] S=FE_OFN153_h21_2 A=n61
+ B=sll_16/ML_int[2][13]
XU218 MUX2S $PINS O=sll_18/ML_int[3][17] S=FE_OFN275_h23_2 A=n83
+ B=sll_18/ML_int[2][13]
XU219 MUX2S $PINS O=sll_17/ML_int[3][17] S=FE_OFN458_n29 A=n72
+ B=sll_17/ML_int[2][13]
XU220 MUX2S $PINS O=term1_shifted[18] S=shf1[3] A=sll_16/ML_int[3][18]
+ B=sll_16/ML_int[3][10]
XU221 MUX2S $PINS O=term3_shifted[18] S=FE_OFN143_h23_3 A=sll_18/ML_int[3][18]
+ B=sll_18/ML_int[3][10]
XU222 MUX2S $PINS O=sll_16/ML_int[3][18] S=FE_OFN153_h21_2 A=n62
+ B=sll_16/ML_int[2][14]
XU223 MUX2S $PINS O=term2_shifted[18] S=FE_RN_1 A=sll_17/ML_int[3][18]
+ B=sll_17/ML_int[3][10]
XU224 MUX2S $PINS O=sll_18/ML_int[3][18] S=FE_OFN275_h23_2 A=n84
+ B=sll_18/ML_int[2][14]
XU225 MUX2S $PINS O=sll_17/ML_int[3][18] S=FE_OFN458_n29 A=n73
+ B=sll_17/ML_int[2][14]
XU226 MUX2S $PINS O=term1_shifted[19] S=shf1[3] A=sll_16/ML_int[3][19]
+ B=sll_16/ML_int[3][11]
XU227 MUX2S $PINS O=sll_16/ML_int[3][19] S=FE_OFN382_h21_2 A=term1_in[26]
+ B=sll_16/ML_int[2][15]
XU228 MUX2S $PINS O=term3_shifted[19] S=shf3[3] A=sll_18/ML_int[3][19]
+ B=sll_18/ML_int[3][11]
XU229 MUX2S $PINS O=sll_18/ML_int[3][19] S=FE_OFN275_h23_2 A=term3_in[26]
+ B=sll_18/ML_int[2][15]
XU230 MUX2S $PINS O=term2_shifted[19] S=FE_RN_1 A=sll_17/ML_int[3][19]
+ B=sll_17/ML_int[3][11]
XU231 MUX2S $PINS O=sll_17/ML_int[3][19] S=FE_OFN458_n29 A=term2_in[26]
+ B=sll_17/ML_int[2][15]
XU232 MUX2S $PINS O=term1_shifted[20] S=shf1[3] A=sll_16/ML_int[3][20]
+ B=sll_16/ML_int[3][12]
XU233 MUX2S $PINS O=sll_16/ML_int[3][20] S=FE_OFN153_h21_2 A=term1_in[26] B=n60
XU234 MUX2S $PINS O=term3_shifted[20] S=shf3[3] A=sll_18/ML_int[3][20]
+ B=sll_18/ML_int[3][12]
XU235 MUX2S $PINS O=sll_18/ML_int[3][20] S=FE_OFN275_h23_2 A=term3_in[26] B=n82
XU236 MUX2S $PINS O=term2_shifted[20] S=FE_RN_1 A=sll_17/ML_int[3][20]
+ B=sll_17/ML_int[3][12]
XU237 MUX2S $PINS O=sll_17/ML_int[3][20] S=FE_OFN458_n29 A=term2_in[26] B=n71
XU238 MUX2S $PINS O=term1_shifted[21] S=shf1[3] A=sll_16/ML_int[3][21]
+ B=sll_16/ML_int[3][13]
XU239 MUX2S $PINS O=sll_16/ML_int[3][21] S=FE_OFN153_h21_2 A=term1_in[26] B=n61
XU240 MUX2S $PINS O=term3_shifted[21] S=FE_OFN143_h23_3 A=sll_18/ML_int[3][21]
+ B=sll_18/ML_int[3][13]
XU241 MUX2S $PINS O=sll_18/ML_int[3][21] S=FE_OFN275_h23_2 A=term3_in[26] B=n83
XU242 MUX2S $PINS O=term2_shifted[21] S=FE_RN_1 A=sll_17/ML_int[3][21]
+ B=sll_17/ML_int[3][13]
XU243 MUX2S $PINS O=sll_17/ML_int[3][21] S=FE_OFN458_n29 A=term2_in[26] B=n72
XU244 MUX2S $PINS O=term1_shifted[22] S=shf1[3] A=sll_16/ML_int[3][22]
+ B=sll_16/ML_int[3][14]
XU245 MUX2S $PINS O=sll_16/ML_int[3][22] S=FE_OFN153_h21_2 A=term1_in[26] B=n62
XU246 MUX2S $PINS O=term3_shifted[22] S=FE_OFN143_h23_3 A=sll_18/ML_int[3][22]
+ B=sll_18/ML_int[3][14]
XU247 MUX2S $PINS O=sll_18/ML_int[3][22] S=shf3[2] A=term3_in[26] B=n84
XU248 MUX2S $PINS O=term2_shifted[22] S=FE_RN_1 A=sll_17/ML_int[3][22]
+ B=sll_17/ML_int[3][14]
XU249 MUX2S $PINS O=sll_17/ML_int[3][22] S=FE_OFN458_n29 A=term2_in[26] B=n73
XU250 MUX2S $PINS O=term1_shifted[23] S=shf1[3] A=term1_in[26]
+ B=sll_16/ML_int[3][15]
XU251 MUX2S $PINS O=term1_shifted[24] S=shf1[3] A=term1_in[26]
+ B=sll_16/ML_int[3][16]
XU252 MUX2S $PINS O=term3_shifted[24] S=FE_OFN143_h23_3 A=term3_in[26]
+ B=sll_18/ML_int[3][16]
XU253 MUX2S $PINS O=term2_shifted[24] S=FE_RN_1 A=term2_in[26]
+ B=sll_17/ML_int[3][16]
XU254 MUX2S $PINS O=term1_shifted[25] S=shf1[3] A=term1_in[26]
+ B=sll_16/ML_int[3][17]
XU255 MUX2S $PINS O=term3_shifted[25] S=FE_OFN143_h23_3 A=term3_in[26]
+ B=sll_18/ML_int[3][17]
XU256 MUX2S $PINS O=term2_shifted[25] S=FE_RN_1 A=term2_in[26]
+ B=sll_17/ML_int[3][17]
XU257 MUX2S $PINS O=term1_shifted[26] S=shf1[3] A=term1_in[26]
+ B=sll_16/ML_int[3][18]
XU258 MUX2S $PINS O=term3_shifted[26] S=FE_OFN143_h23_3 A=term3_in[26]
+ B=sll_18/ML_int[3][18]
XU259 MUX2S $PINS O=term2_shifted[26] S=FE_RN_1 A=term2_in[26]
+ B=sll_17/ML_int[3][18]
XU260 AO22 $PINS O=N52 A1=N25 A2=FE_OFN312_s21_0 B1=term1_shifted[11]
+ B2=FE_OFN313_s21_0
XU263 AO22 $PINS O=N109 A1=N82 A2=n34 B1=term2_shifted[13] B2=FE_OFN290_s22_0
XU264 AN2 $PINS O=base_val[1] I1=acc_reg[1] I2=n103
XU265 AN2S $PINS O=base_val[0] I1=acc_reg[0] I2=n103
XU266 MUX2S $PINS O=N235 S=stage_sel A=acc_reg[10] B=acc_reg[14]
XU267 MUX2S $PINS O=N236 S=stage_sel A=acc_reg[11] B=acc_reg[15]
XU268 MUX2S $PINS O=N237 S=stage_sel A=acc_reg[12] B=acc_reg[16]
XU269 MUX2S $PINS O=N238 S=stage_sel A=acc_reg[13] B=acc_reg[17]
XU270 MUX2S $PINS O=N239 S=stage_sel A=acc_reg[14] B=acc_reg[18]
XU271 MUX2S $PINS O=N240 S=stage_sel A=acc_reg[15] B=acc_reg[19]
XU272 MUX2S $PINS O=N242 S=stage_sel A=acc_reg[17] B=acc_reg[21]
XU273 MUX2S $PINS O=N245 S=stage_sel A=acc_reg[20] B=acc_reg[24]
XU274 MUX2S $PINS O=N246 S=stage_sel A=acc_reg[21] B=acc_reg[25]
XU275 INV1S $PINS O=n58 I=n53
XU276 INV1S $PINS O=n80 I=n75
XU277 INV1S $PINS O=n69 I=n64
XU278 INV1S $PINS O=n59 I=n54
XU279 INV1S $PINS O=n81 I=n76
XU280 INV1S $PINS O=n70 I=n65
XU281 NR2 $PINS O=term3_in[3] I1=sign3[1] I2=FE_OFN334_mac_in_real_3
XU282 NR2 $PINS O=term3_in[4] I1=sign3[1] I2=FE_OFN411_mac_in_real_4
XU283 NR2P $PINS O=term2_in[4] I1=sign2[1] I2=FE_OFN411_mac_in_real_4
XU284 NR2 $PINS O=term1_in[5] I1=sign1[1] I2=x_in[5]
XU285 NR2P $PINS O=term3_in[5] I1=sign3[1] I2=x_in[5]
XU286 NR2 $PINS O=term2_in[5] I1=sign2[1] I2=x_in[5]
XU287 NR2 $PINS O=term3_in[8] I1=sign3[1] I2=x_in[8]
XU288 NR2 $PINS O=term1_in[6] I1=sign1[1] I2=x_in[6]
XU289 NR2 $PINS O=term2_in[8] I1=sign2[1] I2=x_in[8]
XU290 NR2 $PINS O=term3_in[6] I1=sign3[1] I2=x_in[6]
XU291 NR2 $PINS O=term2_in[6] I1=sign2[1] I2=x_in[6]
XU292 NR2 $PINS O=term1_in[9] I1=sign1[1] I2=x_in[9]
XU293 NR2 $PINS O=term3_in[9] I1=FE_OFN422_s23_1 I2=x_in[9]
XU294 NR2 $PINS O=term1_in[7] I1=sign1[1] I2=x_in[7]
XU295 NR2 $PINS O=term3_in[7] I1=sign3[1] I2=x_in[7]
XU296 NR2 $PINS O=term2_in[9] I1=sign2[1] I2=x_in[9]
XU297 NR2 $PINS O=term2_in[7] I1=sign2[1] I2=x_in[7]
XU298 NR2 $PINS O=term1_in[10] I1=sign1[1] I2=x_in[10]
XU299 NR2 $PINS O=term3_in[10] I1=FE_OFN422_s23_1 I2=x_in[10]
XU301 NR2 $PINS O=term2_in[10] I1=sign2[1] I2=x_in[10]
XU306 NR2 $PINS O=term1_in[11] I1=FE_OFN167_s21_1 I2=x_in[11]
XU307 NR2 $PINS O=term3_in[11] I1=FE_OFN422_s23_1 I2=x_in[11]
XU308 NR2 $PINS O=term2_in[11] I1=sign2[1] I2=x_in[11]
XU309 NR2 $PINS O=term1_in[12] I1=FE_OFN167_s21_1 I2=x_in[12]
XU310 NR2 $PINS O=term3_in[12] I1=FE_OFN422_s23_1 I2=x_in[12]
XU311 NR2 $PINS O=term2_in[12] I1=sign2[1] I2=x_in[12]
XU313 NR2 $PINS O=term1_in[13] I1=FE_OFN167_s21_1 I2=x_in[13]
XU314 NR2 $PINS O=term3_in[13] I1=FE_OFN168_s23_1 I2=x_in[13]
XU315 NR2 $PINS O=term2_in[13] I1=sign2[1] I2=x_in[13]
XU316 NR2 $PINS O=term1_in[14] I1=FE_OFN167_s21_1 I2=x_in[14]
XU317 NR2 $PINS O=term3_in[14] I1=FE_OFN168_s23_1 I2=x_in[14]
XU318 NR2 $PINS O=term2_in[14] I1=sign2[1] I2=x_in[14]
XU319 NR2 $PINS O=term1_in[15] I1=FE_OFN167_s21_1 I2=n91
XU321 NR2 $PINS O=term3_in[15] I1=FE_OFN168_s23_1 I2=n91
XU323 NR2 $PINS O=term1_in[26] I1=n92 I2=FE_OFN167_s21_1
XU324 NR2 $PINS O=term3_in[26] I1=n92 I2=FE_OFN168_s23_1
XU325 NR2 $PINS O=term2_in[15] I1=sign2[1] I2=n91
XU327 NR2 $PINS O=term2_in[26] I1=n92 I2=sign2[1]
XU332 INV1S $PINS O=n25 I=FE_OFN490_FE_OFN99_h22_0
XU337 INV1S $PINS O=n37 I=shf1[0]
XU351 INV1S $PINS O=n91 I=x_in[15]
XU352 INV1S $PINS O=n92 I=x_in[16]
XU353 MOAI1S $PINS O=base_val[9] A1=stage_sel A2=n103 B1=acc_reg[9] B2=n103
XU354 AN2 $PINS O=base_val[10] I1=acc_reg[10] I2=n103
XU355 AN2 $PINS O=base_val[8] I1=acc_reg[8] I2=n103
XU356 AN2 $PINS O=base_val[6] I1=acc_reg[6] I2=n103
XU357 AN2 $PINS O=base_val[7] I1=acc_reg[7] I2=n103
XU358 AN2 $PINS O=base_val[5] I1=acc_reg[5] I2=n103
XU359 AN2 $PINS O=base_val[4] I1=acc_reg[4] I2=n103
XU360 AN2 $PINS O=base_val[3] I1=acc_reg[3] I2=n103
XU361 AN2 $PINS O=base_val[11] I1=acc_reg[11] I2=n103
XU362 AN2 $PINS O=base_val[12] I1=acc_reg[12] I2=n103
XU363 AN2 $PINS O=base_val[14] I1=acc_reg[14] I2=n103
XU364 AN2 $PINS O=base_val[15] I1=acc_reg[15] I2=n103
XU365 AN2 $PINS O=base_val[16] I1=acc_reg[16] I2=n103
XU366 AN2 $PINS O=base_val[17] I1=acc_reg[17] I2=n103
XU367 AN2 $PINS O=base_val[18] I1=acc_reg[18] I2=n103
XU368 AN2 $PINS O=base_val[19] I1=acc_reg[19] I2=n103
XU369 AN2 $PINS O=base_val[20] I1=acc_reg[20] I2=n103
XU370 AN2 $PINS O=base_val[21] I1=acc_reg[21] I2=n103
XU371 AN2 $PINS O=base_val[22] I1=acc_reg[22] I2=n103
XU372 AN2 $PINS O=base_val[23] I1=acc_reg[23] I2=n103
XU373 AN2 $PINS O=base_val[24] I1=acc_reg[24] I2=n103
XU374 AN2 $PINS O=base_val[25] I1=acc_reg[25] I2=n103
XU376 AN2 $PINS O=N234 I1=en I2=calc_done
XU377 AN2 $PINS O=base_val[26] I1=N251 I2=n103
XU379 ND2 $PINS O=n9 I1=N125 I2=sign3[0]
XU380 ND2P $PINS O=N152 I1=n9 I2=n10
XU381 ND2 $PINS O=n11 I1=N16 I2=FE_OFN314_s21_0
XU382 ND2S $PINS O=n12 I1=term1_shifted[2] I2=sign1[0]
XU383 ND2P $PINS O=n76 I1=sll_18/ML_int[1][1] I2=FE_OFN116_h23_1
XU384 NR2 $PINS O=sll_16/ML_int[3][0] I1=FE_OFN382_h21_2 I2=n53
XU385 NR2 $PINS O=sll_16/ML_int[3][1] I1=FE_OFN382_h21_2 I2=n54
XU386 NR2 $PINS O=sll_16/ML_int[3][3] I1=FE_OFN382_h21_2 I2=n56
XU387 AN2 $PINS O=term1_shifted[4] I1=sll_16/ML_int[3][4] I2=n43
XU388 AN2 $PINS O=term1_shifted[5] I1=sll_16/ML_int[3][5] I2=n43
XU389 AN2 $PINS O=term1_shifted[6] I1=sll_16/ML_int[3][6] I2=n43
XU390 AN2 $PINS O=term1_shifted[7] I1=sll_16/ML_int[3][7] I2=n43
XU391 MUX2 $PINS O=n60 S=shf1[1] A=n63 B=sll_16/ML_int[1][14]
XU392 MUX2 $PINS O=n61 S=shf1[1] A=term1_in[26] B=sll_16/ML_int[1][15]
XU393 MUX2 $PINS O=n62 S=shf1[1] A=term1_in[26] B=n63
XU394 MUX2 $PINS O=n63 S=FE_OFN482_FE_OFN93_h21_0 A=term1_in[26] B=term1_in[15]
XU395 NR2 $PINS O=sll_17/ML_int[3][0] I1=FE_OFN458_n29 I2=n64
XU396 NR2 $PINS O=sll_17/ML_int[3][1] I1=FE_OFN458_n29 I2=FE_OCPN1157_n65
XU398 NR2P $PINS O=term2_shifted[3] I1=n66 I2=n67
XU399 AN2 $PINS O=term2_shifted[4] I1=sll_17/ML_int[3][4] I2=FE_OFN108_h22_3
XU400 AN2 $PINS O=term2_shifted[5] I1=sll_17/ML_int[3][5] I2=FE_OFN108_h22_3
XU401 AN2 $PINS O=term2_shifted[6] I1=sll_17/ML_int[3][6] I2=FE_OFN108_h22_3
XU402 AN2 $PINS O=term2_shifted[7] I1=sll_17/ML_int[3][7] I2=FE_OFN108_h22_3
XU403 MUX2 $PINS O=n74 S=shf2[0] A=term2_in[26] B=term2_in[15]
XU404 NR2 $PINS O=sll_18/ML_int[3][0] I1=FE_OFN115_h23_2 I2=n75
XU405 NR2 $PINS O=sll_18/ML_int[3][1] I1=FE_OFN115_h23_2 I2=n76
XU406 NR2 $PINS O=sll_18/ML_int[3][2] I1=FE_OFN115_h23_2 I2=n79
XU407 NR2 $PINS O=sll_18/ML_int[3][3] I1=FE_OFN115_h23_2 I2=n78
XU408 AN2 $PINS O=term3_shifted[5] I1=sll_18/ML_int[3][5] I2=FE_OFN141_h23_3
XU409 AN2 $PINS O=term3_shifted[6] I1=sll_18/ML_int[3][6] I2=FE_OFN141_h23_3
XU410 AN2 $PINS O=term3_shifted[7] I1=sll_18/ML_int[3][7] I2=FE_OFN141_h23_3
XU411 MUX2 $PINS O=n82 S=shf3[1] A=n85 B=sll_18/ML_int[1][14]
XU412 MUX2 $PINS O=n83 S=shf3[1] A=term3_in[26] B=sll_18/ML_int[1][15]
XU413 MUX2 $PINS O=n84 S=shf3[1] A=term3_in[26] B=n85
XU414 MUX2 $PINS O=n85 S=FE_RN_2 A=term3_in[26] B=term3_in[15]
XU415 MUX2 $PINS O=N241 S=stage_sel A=acc_reg[16] B=acc_reg[20]
XU416 MUX2 $PINS O=N243 S=stage_sel A=acc_reg[18] B=acc_reg[22]
XU417 MUX2 $PINS O=N244 S=stage_sel A=acc_reg[19] B=acc_reg[23]
XU57 MUX2 $PINS O=sll_16/ML_int[1][2] S=shf1[0] A=term1_in[2] B=term1_in[1]
XU5 NR2P $PINS O=term1_shifted[1] I1=n55 I2=n54
XU8 NR2P $PINS O=term1_shifted[2] I1=n55 I2=n57
XU10 INV4 $PINS O=n102 I=x_in[0]
XU11 ND2P $PINS O=n54 I1=sll_16/ML_int[1][1] I2=n39
XU14 NR2T $PINS O=term2_shifted[2] I1=n66 I2=n68
XU15 INV2 $PINS O=n68 I=sll_17/ML_int[2][2]
XU16 NR2 $PINS O=term1_in[1] I1=sign1[1] I2=FE_OFN393_mac_in_real_1
XU18 NR2T $PINS O=term3_shifted[2] I1=n79 I2=n77
XU19 AN2B1T $PINS O=term1_shifted[3] I1=sll_16/ML_int[2][3] B1=n55
XU20 NR2 $PINS O=sll_17/ML_int[3][2] I1=FE_OFN458_n29 I2=n68
XU42 ND2P $PINS O=n53 I1=sll_16/ML_int[1][0] I2=n39
XU46 NR2T $PINS O=term1_shifted[0] I1=n55 I2=n53
XU50 NR2T $PINS O=term3_shifted[0] I1=n77 I2=n75
XU52 ND2P $PINS O=N43 I1=n11 I2=n12
XU63 NR2P $PINS O=term3_in[0] I1=sign3[1] I2=n102
XU66 NR2 $PINS O=term3_in[2] I1=sign3[1] I2=FE_OFN370_mac_in_real_2
XU100 NR2 $PINS O=term2_in[2] I1=sign2[1] I2=FE_OFN370_mac_in_real_2
XU105 ND2P $PINS O=n75 I1=sll_18/ML_int[1][0] I2=FE_OFN116_h23_1
XU107 AN2B1T $PINS O=sll_18/ML_int[1][0] I1=term3_in[0] B1=FE_OFN117_h23_0
XU109 NR2T $PINS O=term1_in[2] I1=sign1[1] I2=FE_OFN370_mac_in_real_2
Xclk_gate_y_out_reg SNPS_CLOCK_GATE_HIGH_PE_Shift_Add_3 $PINS EN=N234
+ ENCLK=net2265 CLK=clk_clone2
Xsub_28_3 PE_Shift_Add_3_DW01_sub_0_DW01_sub_9 $PINS A[26]=net45611
+ A[25]=net45611 A[24]=net45611 A[23]=net45611 A[22]=net45611 A[21]=net45611
+ A[20]=net45611 A[19]=net45611 A[18]=net45611 A[17]=net45611 A[16]=net45611
+ A[15]=net45611 A[14]=net45611 A[13]=net45611 A[12]=net45611 A[11]=net45611
+ A[10]=net45611 A[9]=net45611 A[8]=net45611 A[7]=net45611 A[6]=net45611
+ A[5]=net45611 A[4]=net45611 A[3]=net45611 A[2]=net45611 A[1]=net45611
+ A[0]=net45611 B[26]=term3_shifted[26] B[25]=term3_shifted[25]
+ B[24]=term3_shifted[24] B[23]=term3_shifted[23] B[22]=term3_shifted[22]
+ B[21]=term3_shifted[21] B[20]=term3_shifted[20] B[19]=term3_shifted[19]
+ B[18]=term3_shifted[18] B[17]=term3_shifted[17] B[16]=term3_shifted[16]
+ B[15]=term3_shifted[15] B[14]=term3_shifted[14] B[13]=term3_shifted[13]
+ B[12]=term3_shifted[12] B[11]=term3_shifted[11] B[10]=term3_shifted[10]
+ B[9]=term3_shifted[9] B[8]=term3_shifted[8] B[7]=term3_shifted[7]
+ B[6]=term3_shifted[6] B[5]=term3_shifted[5] B[4]=term3_shifted[4]
+ B[3]=term3_shifted[3] B[2]=term3_shifted[2] B[1]=term3_shifted[1]
+ B[0]=term3_shifted[0] CI=net45611 DIFF[26]=N150 DIFF[25]=N149 DIFF[24]=N148
+ DIFF[23]=N147 DIFF[22]=N146 DIFF[21]=N145 DIFF[20]=N144 DIFF[19]=N143
+ DIFF[18]=N142 DIFF[17]=N141 DIFF[16]=N140 DIFF[15]=N139 DIFF[14]=N138
+ DIFF[13]=N137 DIFF[12]=N136 DIFF[11]=N135 DIFF[10]=N134 DIFF[9]=N133
+ DIFF[8]=N132 DIFF[7]=N131 DIFF[6]=N130 DIFF[5]=N129 DIFF[4]=N128 DIFF[3]=N127
+ DIFF[2]=N126 DIFF[1]=N125 DIFF[0]=N124
Xsub_28_2 PE_Shift_Add_3_DW01_sub_1_DW01_sub_10 $PINS A[26]=net45611
+ A[25]=net45611 A[24]=net45611 A[23]=net45611 A[22]=net45611 A[21]=net45611
+ A[20]=net45611 A[19]=net45611 A[18]=net45611 A[17]=net45611 A[16]=net45611
+ A[15]=net45611 A[14]=net45611 A[13]=net45611 A[12]=net45611 A[11]=net45611
+ A[10]=net45611 A[9]=net45611 A[8]=net45611 A[7]=net45611 A[6]=net45611
+ A[5]=net45611 A[4]=net45611 A[3]=net45611 A[2]=net45611 A[1]=net45611
+ A[0]=net45611 B[26]=term2_shifted[26] B[25]=term2_shifted[25]
+ B[24]=term2_shifted[24] B[23]=term2_shifted[23] B[22]=term2_shifted[22]
+ B[21]=term2_shifted[21] B[20]=term2_shifted[20] B[19]=term2_shifted[19]
+ B[18]=term2_shifted[18] B[17]=term2_shifted[17] B[16]=term2_shifted[16]
+ B[15]=term2_shifted[15] B[14]=term2_shifted[14] B[13]=term2_shifted[13]
+ B[12]=term2_shifted[12] B[11]=term2_shifted[11] B[10]=term2_shifted[10]
+ B[9]=term2_shifted[9] B[8]=term2_shifted[8] B[7]=term2_shifted[7]
+ B[6]=term2_shifted[6] B[5]=term2_shifted[5] B[4]=term2_shifted[4]
+ B[3]=term2_shifted[3] B[2]=term2_shifted[2] B[1]=n2 B[0]=term2_shifted[0]
+ CI=net45611 DIFF[26]=N95 DIFF[25]=N94 DIFF[24]=N93 DIFF[23]=N92 DIFF[22]=N91
+ DIFF[21]=N90 DIFF[20]=N89 DIFF[19]=N88 DIFF[18]=N87 DIFF[17]=N86 DIFF[16]=N85
+ DIFF[15]=N84 DIFF[14]=N83 DIFF[13]=N82 DIFF[12]=N81 DIFF[11]=N80 DIFF[10]=N79
+ DIFF[9]=N78 DIFF[8]=N77 DIFF[7]=N76 DIFF[6]=N75 DIFF[5]=N74 DIFF[4]=N73
+ DIFF[3]=N72 DIFF[2]=N71 DIFF[1]=N70 DIFF[0]=N69
Xsub_28 PE_Shift_Add_3_DW01_sub_2_DW01_sub_11 $PINS A[26]=net45611
+ A[25]=net45611 A[24]=net45611 A[23]=net45611 A[22]=net45611 A[21]=net45611
+ A[20]=net45611 A[19]=net45611 A[18]=net45611 A[17]=net45611 A[16]=net45611
+ A[15]=net45611 A[14]=net45611 A[13]=net45611 A[12]=net45611 A[11]=net45611
+ A[10]=net45611 A[9]=net45611 A[8]=net45611 A[7]=net45611 A[6]=net45611
+ A[5]=net45611 A[4]=net45611 A[3]=net45611 A[2]=net45611 A[1]=net45611
+ A[0]=net45611 B[26]=term1_shifted[26] B[25]=term1_shifted[25]
+ B[24]=term1_shifted[24] B[23]=term1_shifted[23] B[22]=term1_shifted[22]
+ B[21]=term1_shifted[21] B[20]=term1_shifted[20] B[19]=term1_shifted[19]
+ B[18]=term1_shifted[18] B[17]=term1_shifted[17] B[16]=term1_shifted[16]
+ B[15]=term1_shifted[15] B[14]=term1_shifted[14] B[13]=term1_shifted[13]
+ B[12]=term1_shifted[12] B[11]=term1_shifted[11] B[10]=term1_shifted[10]
+ B[9]=term1_shifted[9] B[8]=term1_shifted[8] B[7]=term1_shifted[7]
+ B[6]=term1_shifted[6] B[5]=term1_shifted[5] B[4]=term1_shifted[4]
+ B[3]=term1_shifted[3] B[2]=term1_shifted[2] B[1]=term1_shifted[1]
+ B[0]=term1_shifted[0] CI=net45611 DIFF[26]=N40 DIFF[25]=N39 DIFF[24]=N38
+ DIFF[23]=N37 DIFF[22]=N36 DIFF[21]=N35 DIFF[20]=N34 DIFF[19]=N33 DIFF[18]=N32
+ DIFF[17]=N31 DIFF[16]=N30 DIFF[15]=N29 DIFF[14]=N28 DIFF[13]=N27 DIFF[12]=N26
+ DIFF[11]=N25 DIFF[10]=N24 DIFF[9]=N23 DIFF[8]=N22 DIFF[7]=N21 DIFF[6]=N20
+ DIFF[5]=N19 DIFF[4]=N18 DIFF[3]=N17 DIFF[2]=N16 DIFF[1]=N15 DIFF[0]=N14
+ p1=term1_shifted[2]
Xadd_1_root_add_0_root_add_28_3 PE_Shift_Add_3_DW01_add_2_DW01_add_31 $PINS
+ A[26]=N67 A[25]=N66 A[24]=N65 A[23]=N64 A[22]=N63 A[21]=N62 A[20]=N61 A[19]=N60
+ A[18]=N59 A[17]=N58 A[16]=N57 A[15]=N56 A[14]=N55 A[13]=N54 A[12]=N53 A[11]=N52
+ A[10]=N51 A[9]=N50 A[8]=N49 A[7]=N48 A[6]=N47 A[5]=N46 A[4]=N45 A[3]=N44
+ A[2]=N43 A[1]=N42 A[0]=N41 B[26]=N177 B[25]=N176 B[24]=N175 B[23]=N174
+ B[22]=N173 B[21]=N172 B[20]=N171 B[19]=N170 B[18]=N169 B[17]=N168 B[16]=N167
+ B[15]=N166 B[14]=N165 B[13]=N164 B[12]=N163 B[11]=N162 B[10]=N161 B[9]=N160
+ B[8]=N159 B[7]=N158 B[6]=N157 B[5]=N156 B[4]=N155 B[3]=N154 B[2]=N153 B[1]=N152
+ B[0]=N151 CI=net45611 SUM[26]=N204 SUM[25]=N203 SUM[24]=N202 SUM[23]=N201
+ SUM[22]=N200 SUM[21]=N199 SUM[20]=N198 SUM[19]=N197 SUM[18]=N196 SUM[17]=N195
+ SUM[16]=N194 SUM[15]=N193 SUM[14]=N192 SUM[13]=N191 SUM[12]=N190 SUM[11]=N189
+ SUM[10]=N188 SUM[9]=N187 SUM[8]=N186 SUM[7]=N185 SUM[6]=N184 SUM[5]=N183
+ SUM[4]=N182 SUM[3]=N181 SUM[2]=N180 SUM[1]=N179 SUM[0]=N178
Xadd_2_root_add_0_root_add_28_3 PE_Shift_Add_3_DW01_add_1_DW01_add_30 $PINS
+ A[26]=base_val[26] A[25]=base_val[25] A[24]=base_val[24] A[23]=base_val[23]
+ A[22]=base_val[22] A[21]=base_val[21] A[20]=base_val[20] A[19]=base_val[19]
+ A[18]=base_val[18] A[17]=base_val[17] A[16]=base_val[16] A[15]=base_val[15]
+ A[14]=base_val[14] A[13]=base_val[13] A[12]=base_val[12] A[11]=base_val[11]
+ A[10]=base_val[10] A[9]=base_val[9] A[8]=base_val[8] A[7]=base_val[7]
+ A[6]=base_val[6] A[5]=base_val[5] A[4]=base_val[4] A[3]=base_val[3]
+ A[2]=base_val[2] A[1]=base_val[1] A[0]=base_val[0] B[26]=N122 B[25]=N121
+ B[24]=N120 B[23]=N119 B[22]=N118 B[21]=N117 B[20]=N116 B[19]=N115 B[18]=N114
+ B[17]=N113 B[16]=N112 B[15]=N111 B[14]=N110 B[13]=N109 B[12]=N108 B[11]=N107
+ B[10]=N106 B[9]=N105 B[8]=N104 B[7]=N103 B[6]=N102 B[5]=N101 B[4]=N100 B[3]=N99
+ B[2]=N98 B[1]=N97 B[0]=N96 CI=net45611 SUM[26]=N231 SUM[25]=N230 SUM[24]=N229
+ SUM[23]=N228 SUM[22]=N227 SUM[21]=N226 SUM[20]=N225 SUM[19]=N224 SUM[18]=N223
+ SUM[17]=N222 SUM[16]=N221 SUM[15]=N220 SUM[14]=N219 SUM[13]=N218 SUM[12]=N217
+ SUM[11]=N216 SUM[10]=N215 SUM[9]=N214 SUM[8]=N213 SUM[7]=N212 SUM[6]=N211
+ SUM[5]=N210 SUM[4]=N209 SUM[3]=N208 SUM[2]=N207 SUM[1]=N206 SUM[0]=N205
Xadd_0_root_add_0_root_add_28_3 PE_Shift_Add_3_DW01_add_0_DW01_add_29 $PINS
+ A[26]=N204 A[25]=N203 A[24]=N202 A[23]=N201 A[22]=N200 A[21]=N199 A[20]=N198
+ A[19]=N197 A[18]=N196 A[17]=N195 A[16]=N194 A[15]=N193 A[14]=N192 A[13]=N191
+ A[12]=N190 A[11]=N189 A[10]=N188 A[9]=N187 A[8]=N186 A[7]=N185 A[6]=N184
+ A[5]=N183 A[4]=N182 A[3]=N181 A[2]=N180 A[1]=N179 A[0]=N178 B[26]=N231
+ B[25]=N230 B[24]=N229 B[23]=N228 B[22]=N227 B[21]=N226 B[20]=N225 B[19]=N224
+ B[18]=N223 B[17]=N222 B[16]=N221 B[15]=N220 B[14]=N219 B[13]=N218 B[12]=N217
+ B[11]=N216 B[10]=N215 B[9]=N214 B[8]=N213 B[7]=N212 B[6]=N211 B[5]=N210
+ B[4]=N209 B[3]=N208 B[2]=N207 B[1]=N206 B[0]=N205 CI=net45611
+ SUM[26]=next_acc[26] SUM[25]=next_acc[25] SUM[24]=next_acc[24]
+ SUM[23]=next_acc[23] SUM[22]=next_acc[22] SUM[21]=next_acc[21]
+ SUM[20]=next_acc[20] SUM[19]=next_acc[19] SUM[18]=next_acc[18]
+ SUM[17]=next_acc[17] SUM[16]=next_acc[16] SUM[15]=next_acc[15]
+ SUM[14]=next_acc[14] SUM[13]=next_acc[13] SUM[12]=next_acc[12]
+ SUM[11]=next_acc[11] SUM[10]=next_acc[10] SUM[9]=next_acc[9] SUM[8]=next_acc[8]
+ SUM[7]=next_acc[7] SUM[6]=next_acc[6] SUM[5]=next_acc[5] SUM[4]=next_acc[4]
+ SUM[3]=next_acc[3] SUM[2]=next_acc[2] SUM[1]=next_acc[1] SUM[0]=next_acc[0]
.ENDS

.SUBCKT SNPS_CLOCK_GATE_HIGH_PE_Shift_Add_2 EN ENCLK CLK
*.CONNECT ENCLK net2240
*.CONNECT net2241 EN
XFE_PHC1314_net2244 DELC $PINS O=FE_PHN1314_net2244 I=net2244
Xlatch QDBHN $PINS Q=net2244 D=net2241 CKB=CLK
Xmain_gate AN2T $PINS O=net2240 I1=FE_PHN1314_net2244 I2=CLK
.ENDS

.SUBCKT PE_Shift_Add_2_DW01_sub_0_DW01_sub_6 A[26] A[25] A[24] A[23] A[22]
+ A[21] A[20] A[19] A[18] A[17] A[16] A[15] A[14] A[13] A[12] A[11] A[10] A[9]
+ A[8] A[7] A[6] A[5] A[4] A[3] A[2] A[1] A[0] B[26] B[25] B[24] B[23] B[22]
+ B[21] B[20] B[19] B[18] B[17] B[16] B[15] B[14] B[13] B[12] B[11] B[10] B[9]
+ B[8] B[7] B[6] B[5] B[4] B[3] B[2] B[1] B[0] CI DIFF[26] DIFF[25] DIFF[24]
+ DIFF[23] DIFF[22] DIFF[21] DIFF[20] DIFF[19] DIFF[18] DIFF[17] DIFF[16]
+ DIFF[15] DIFF[14] DIFF[13] DIFF[12] DIFF[11] DIFF[10] DIFF[9] DIFF[8] DIFF[7]
+ DIFF[6] DIFF[5] DIFF[4] DIFF[3] DIFF[2] DIFF[1] DIFF[0] CO
XFE_RC_4025_0 XOR2HS $PINS O=DIFF[3] I1=n1 I2=n49
XFE_RC_2547_0 XOR2HS $PINS O=DIFF[2] I1=n2 I2=n50
XFE_RC_2478_0 XOR2HS $PINS O=DIFF[4] I1=n3 I2=n48
XFE_RC_2477_0 XOR2HS $PINS O=DIFF[1] I1=n52 I2=n51
XFE_OFC798_N124 INV2 $PINS O=n52 I=B[0]
XU2 INV2 $PINS O=n51 I=B[1]
XU8 INV2 $PINS O=n48 I=B[4]
XU9 INV1S $PINS O=n47 I=B[5]
XU10 AN2T $PINS O=n1 I1=n50 I2=n2
XU11 AN2T $PINS O=n2 I1=n51 I2=n52
XU12 AN2 $PINS O=n3 I1=n49 I2=n1
XU13 AN2 $PINS O=n4 I1=n44 I2=n24
XU14 AN2T $PINS O=n5 I1=n43 I2=n4
XU15 AN2 $PINS O=n6 I1=n42 I2=n5
XU16 AN2 $PINS O=n7 I1=n41 I2=n6
XU17 AN2 $PINS O=n8 I1=n40 I2=n7
XU18 AN2 $PINS O=n9 I1=n39 I2=n8
XU19 AN2 $PINS O=n10 I1=n38 I2=n9
XU20 AN2 $PINS O=n11 I1=n10 I2=n37
XU21 AN2 $PINS O=n12 I1=n11 I2=n36
XU22 AN2 $PINS O=n13 I1=n35 I2=n12
XU23 AN2T $PINS O=n14 I1=n34 I2=n13
XU24 AN2 $PINS O=n15 I1=n33 I2=n14
XU25 AN2 $PINS O=n16 I1=n32 I2=n15
XU26 AN2 $PINS O=n17 I1=n31 I2=n16
XU27 AN2 $PINS O=n18 I1=n30 I2=n17
XU28 AN2 $PINS O=n19 I1=n29 I2=n18
XU29 AN2 $PINS O=n20 I1=n28 I2=n19
XU30 AN2T $PINS O=n21 I1=n48 I2=n3
XU31 AN2T $PINS O=n22 I1=n47 I2=n21
XU32 AN2T $PINS O=n23 I1=n46 I2=n22
XU33 AN2 $PINS O=n24 I1=n45 I2=n23
XU34 INV1S $PINS O=n44 I=B[8]
XU35 INV1S $PINS O=n43 I=B[9]
XU36 INV1S $PINS O=n42 I=B[10]
XU37 INV1S $PINS O=n41 I=B[11]
XU38 XOR2HS $PINS O=DIFF[26] I1=B[26] I2=n26
XU39 INV1S $PINS O=n40 I=B[12]
XU40 INV1S $PINS O=n39 I=B[13]
XU41 INV1S $PINS O=n38 I=B[14]
XU42 INV1S $PINS O=n37 I=B[15]
XU43 INV1S $PINS O=n36 I=B[16]
XU44 INV1S $PINS O=n35 I=B[17]
XU45 INV1S $PINS O=n34 I=B[18]
XU46 INV1S $PINS O=n33 I=B[19]
XU47 INV1S $PINS O=n32 I=B[20]
XU48 INV1S $PINS O=n31 I=B[21]
XU49 INV1S $PINS O=n30 I=B[22]
XU50 INV1S $PINS O=n29 I=B[23]
XU51 INV1S $PINS O=n28 I=B[24]
XU52 INV1S $PINS O=n27 I=B[25]
XU53 INV1S $PINS O=n46 I=B[6]
XU54 INV1S $PINS O=n45 I=B[7]
XU55 XOR2HS $PINS O=DIFF[12] I1=n40 I2=n7
XU56 XOR2HS $PINS O=DIFF[13] I1=n39 I2=n8
XU57 XOR2HS $PINS O=DIFF[14] I1=n38 I2=n9
XU58 XOR2HS $PINS O=DIFF[15] I1=n37 I2=n10
XU59 XOR2HS $PINS O=DIFF[16] I1=n36 I2=n11
XU60 XOR2HS $PINS O=DIFF[11] I1=n41 I2=n6
XU61 XOR2HS $PINS O=DIFF[17] I1=n35 I2=n12
XU62 XOR2HS $PINS O=DIFF[18] I1=n34 I2=n13
XU63 XOR2HS $PINS O=DIFF[19] I1=n33 I2=n14
XU64 XOR2HS $PINS O=DIFF[20] I1=n32 I2=n15
XU65 XOR2HS $PINS O=DIFF[21] I1=n31 I2=n16
XU66 XOR2HS $PINS O=DIFF[10] I1=n42 I2=n5
XU67 XOR2HS $PINS O=DIFF[22] I1=n30 I2=n17
XU68 XOR2HS $PINS O=DIFF[23] I1=n29 I2=n18
XU69 XOR2HS $PINS O=DIFF[9] I1=n43 I2=n4
XU70 XOR2HS $PINS O=DIFF[7] I1=n45 I2=n23
XU71 XOR2HS $PINS O=DIFF[8] I1=n44 I2=n24
XU72 XOR2HS $PINS O=DIFF[24] I1=n28 I2=n19
XU73 XOR2HS $PINS O=DIFF[6] I1=n46 I2=n22
XU76 XOR2HS $PINS O=DIFF[5] I1=n47 I2=n21
XU77 XOR2HS $PINS O=DIFF[25] I1=n27 I2=n20
XU78 ND2 $PINS O=n26 I1=n27 I2=n20
XU5 INV2 $PINS O=n50 I=B[2]
XU7 INV2 $PINS O=n49 I=B[3]
.ENDS

.SUBCKT PE_Shift_Add_2_DW01_sub_1_DW01_sub_7 A[26] A[25] A[24] A[23] A[22]
+ A[21] A[20] A[19] A[18] A[17] A[16] A[15] A[14] A[13] A[12] A[11] A[10] A[9]
+ A[8] A[7] A[6] A[5] A[4] A[3] A[2] A[1] A[0] B[26] B[25] B[24] B[23] B[22]
+ B[21] B[20] B[19] B[18] B[17] B[16] B[15] B[14] B[13] B[12] B[11] B[10] B[9]
+ B[8] B[7] B[6] B[5] B[4] B[3] B[2] B[1] B[0] CI DIFF[26] DIFF[25] DIFF[24]
+ DIFF[23] DIFF[22] DIFF[21] DIFF[20] DIFF[19] DIFF[18] DIFF[17] DIFF[16]
+ DIFF[15] DIFF[14] DIFF[13] DIFF[12] DIFF[11] DIFF[10] DIFF[9] DIFF[8] DIFF[7]
+ DIFF[6] DIFF[5] DIFF[4] DIFF[3] DIFF[2] DIFF[1] DIFF[0] CO
XFE_RC_3939_0 INV1S $PINS O=FE_RN_2565_0 I=n52
XFE_RC_3938_0 MXL2HS $PINS OB=DIFF[1] S=n51 A=FE_RN_2565_0 B=n52
XFE_RC_3777_0 XOR2HS $PINS O=DIFF[3] I1=n49 I2=n2
XFE_RC_3518_0 XOR2HS $PINS O=DIFF[4] I1=n3 I2=n48
XFE_RC_2265_0 XOR2HS $PINS O=DIFF[2] I1=n8 I2=n50
XFE_OFC245_term2_shifted_0 INV2 $PINS O=n52 I=B[0]
XU2 INV1S $PINS O=n49 I=B[3]
XU4 INV1S $PINS O=n47 I=B[5]
XU6 INV1S $PINS O=n46 I=B[6]
XU7 INV2 $PINS O=n48 I=B[4]
XU9 AN2 $PINS O=n1 I1=n47 I2=n4
XU10 AN2T $PINS O=n2 I1=n50 I2=n8
XU12 AN2 $PINS O=n3 I1=n49 I2=n2
XU13 AN2T $PINS O=n4 I1=n48 I2=n3
XU14 AN2T $PINS O=n5 I1=n46 I2=n1
XU15 AN2T $PINS O=n6 I1=n45 I2=n5
XU17 AN2 $PINS O=n8 I1=n51 I2=n52
XU18 AN2T $PINS O=n9 I1=n44 I2=n6
XU19 AN2 $PINS O=n10 I1=n43 I2=n9
XU20 AN2 $PINS O=n11 I1=n42 I2=n10
XU21 AN2 $PINS O=n12 I1=n41 I2=n11
XU22 AN2 $PINS O=n13 I1=n40 I2=n12
XU23 AN2 $PINS O=n14 I1=n13 I2=n39
XU24 AN2T $PINS O=n15 I1=n38 I2=n14
XU25 AN2T $PINS O=n16 I1=n37 I2=n15
XU26 AN2 $PINS O=n17 I1=n36 I2=n16
XU27 AN2 $PINS O=n18 I1=n35 I2=n17
XU28 AN2 $PINS O=n19 I1=n34 I2=n18
XU29 AN2 $PINS O=n20 I1=n33 I2=n19
XU30 AN2 $PINS O=n21 I1=n32 I2=n20
XU31 AN2 $PINS O=n22 I1=n31 I2=n21
XU32 AN2 $PINS O=n23 I1=n30 I2=n22
XU33 AN2 $PINS O=n24 I1=n29 I2=n23
XU34 AN2 $PINS O=n25 I1=n28 I2=n24
XU35 INV1S $PINS O=n44 I=B[8]
XU36 INV1S $PINS O=n43 I=B[9]
XU37 INV1S $PINS O=n42 I=B[10]
XU38 INV1S $PINS O=n41 I=B[11]
XU39 INV1S $PINS O=n40 I=B[12]
XU40 INV1S $PINS O=n39 I=B[13]
XU41 INV1S $PINS O=n38 I=B[14]
XU42 INV1S $PINS O=n37 I=B[15]
XU43 INV1S $PINS O=n36 I=B[16]
XU44 INV1S $PINS O=n35 I=B[17]
XU45 INV1S $PINS O=n34 I=B[18]
XU46 INV1S $PINS O=n33 I=B[19]
XU47 INV1S $PINS O=n32 I=B[20]
XU48 INV1S $PINS O=n31 I=B[21]
XU49 INV1S $PINS O=n30 I=B[22]
XU50 INV1S $PINS O=n29 I=B[23]
XU51 INV1S $PINS O=n28 I=B[24]
XU52 INV1S $PINS O=n27 I=B[25]
XU53 INV1S $PINS O=n45 I=B[7]
XU54 XOR2HS $PINS O=DIFF[26] I1=B[26] I2=n26
XU55 XOR2HS $PINS O=DIFF[9] I1=n43 I2=n9
XU56 XOR2HS $PINS O=DIFF[10] I1=n42 I2=n10
XU57 XOR2HS $PINS O=DIFF[12] I1=n40 I2=n12
XU58 XOR2HS $PINS O=DIFF[13] I1=n39 I2=n13
XU59 XOR2HS $PINS O=DIFF[14] I1=n38 I2=n14
XU60 XOR2HS $PINS O=DIFF[15] I1=n37 I2=n15
XU61 XOR2HS $PINS O=DIFF[11] I1=n41 I2=n11
XU62 XOR2HS $PINS O=DIFF[16] I1=n36 I2=n16
XU63 XOR2HS $PINS O=DIFF[17] I1=n35 I2=n17
XU64 XOR2HS $PINS O=DIFF[18] I1=n34 I2=n18
XU65 XOR2HS $PINS O=DIFF[8] I1=n44 I2=n6
XU66 XOR2HS $PINS O=DIFF[7] I1=n45 I2=n5
XU67 XOR2HS $PINS O=DIFF[19] I1=n33 I2=n19
XU68 XOR2HS $PINS O=DIFF[20] I1=n32 I2=n20
XU69 XOR2HS $PINS O=DIFF[6] I1=n46 I2=n1
XU70 XOR2HS $PINS O=DIFF[21] I1=n31 I2=n21
XU71 XOR2HS $PINS O=DIFF[5] I1=n47 I2=n4
XU72 XOR2HS $PINS O=DIFF[22] I1=n30 I2=n22
XU73 XOR2HS $PINS O=DIFF[23] I1=n29 I2=n23
XU74 XOR2HS $PINS O=DIFF[24] I1=n28 I2=n24
XU77 XOR2HS $PINS O=DIFF[25] I1=n27 I2=n25
XU78 ND2 $PINS O=n26 I1=n27 I2=n25
XU1 INV2 $PINS O=n51 I=B[1]
XU5 INV2 $PINS O=n50 I=B[2]
.ENDS

.SUBCKT PE_Shift_Add_2_DW01_sub_2_DW01_sub_8 A[26] A[25] A[24] A[23] A[22]
+ A[21] A[20] A[19] A[18] A[17] A[16] A[15] A[14] A[13] A[12] A[11] A[10] A[9]
+ A[8] A[7] A[6] A[5] A[4] A[3] A[2] A[1] A[0] B[26] B[25] B[24] B[23] B[22]
+ B[21] B[20] B[19] B[18] B[17] B[16] B[15] B[14] B[13] B[12] B[11] B[10] B[9]
+ B[8] B[7] B[6] B[5] B[4] B[3] B[2] B[1] B[0] CI DIFF[26] DIFF[25] DIFF[24]
+ DIFF[23] DIFF[22] DIFF[21] DIFF[20] DIFF[19] DIFF[18] DIFF[17] DIFF[16]
+ DIFF[15] DIFF[14] DIFF[13] DIFF[12] DIFF[11] DIFF[10] DIFF[9] DIFF[8] DIFF[7]
+ DIFF[6] DIFF[5] DIFF[4] DIFF[3] DIFF[2] DIFF[1] DIFF[0] CO FE_RN_1600_0
+ FE_RN_1546_0
*.CONNECT DIFF[0] B[0]
XFE_RC_184_0 INV1S $PINS O=FE_RN_84_0 I=n33
XFE_RC_183_0 MXL2HS $PINS OB=DIFF[19] S=n14 A=FE_RN_84_0 B=n33
XFE_RC_3192_0 INV1S $PINS O=FE_RN_2060_0 I=n52
XFE_RC_3191_0 MXL2HS $PINS OB=DIFF[1] S=n51 A=FE_RN_2060_0 B=n52
XFE_RC_2871_0 XOR2HS $PINS O=DIFF[3] I1=n2 I2=FE_RN_1546_0
XFE_RC_2085_0 XOR2HS $PINS O=DIFF[4] I1=n3 I2=n48
XFE_RC_1420_0 XOR2HS $PINS O=DIFF[2] I1=n1 I2=n50
XU3 INV2 $PINS O=n48 I=B[4]
XU6 INV2 $PINS O=n47 I=B[5]
XU8 INV1S $PINS O=n45 I=B[7]
XU9 INV1S $PINS O=n46 I=B[6]
XU10 INV1S $PINS O=n52 I=B[0]
XU14 AN2 $PINS O=n2 I1=n50 I2=n1
XU15 AN2 $PINS O=n3 I1=n2 I2=FE_RN_1546_0
XU16 XOR2HS $PINS O=DIFF[8] I1=n44 I2=n24
XU17 XOR2HS $PINS O=DIFF[9] I1=FE_RN_1600_0 I2=n4
XU18 AN2T $PINS O=n4 I1=n44 I2=n24
XU19 XOR2HS $PINS O=DIFF[10] I1=n42 I2=n5
XU20 AN2T $PINS O=n5 I1=FE_RN_1600_0 I2=n4
XU21 XOR2HS $PINS O=DIFF[11] I1=n41 I2=n6
XU22 AN2 $PINS O=n6 I1=n42 I2=n5
XU23 XOR2HS $PINS O=DIFF[12] I1=n40 I2=n7
XU24 AN2 $PINS O=n7 I1=n41 I2=n6
XU25 XOR2HS $PINS O=DIFF[13] I1=n39 I2=n8
XU26 AN2 $PINS O=n8 I1=n40 I2=n7
XU27 XOR2HS $PINS O=DIFF[14] I1=n38 I2=n9
XU28 AN2 $PINS O=n9 I1=n39 I2=n8
XU29 XOR2HS $PINS O=DIFF[15] I1=n37 I2=n10
XU30 AN2 $PINS O=n10 I1=n38 I2=n9
XU31 XOR2HS $PINS O=DIFF[16] I1=n36 I2=n11
XU32 AN2 $PINS O=n11 I1=n37 I2=n10
XU33 XOR2HS $PINS O=DIFF[17] I1=n35 I2=n12
XU34 AN2 $PINS O=n12 I1=n36 I2=n11
XU35 XOR2HS $PINS O=DIFF[18] I1=n34 I2=n13
XU36 AN2 $PINS O=n13 I1=n12 I2=n35
XU38 AN2 $PINS O=n14 I1=n34 I2=n13
XU39 XOR2HS $PINS O=DIFF[20] I1=n32 I2=n15
XU40 AN2 $PINS O=n15 I1=n33 I2=n14
XU41 XOR2HS $PINS O=DIFF[21] I1=n31 I2=n16
XU42 AN2 $PINS O=n16 I1=n32 I2=n15
XU43 XOR2HS $PINS O=DIFF[22] I1=n30 I2=n17
XU44 AN2 $PINS O=n17 I1=n31 I2=n16
XU45 XOR2HS $PINS O=DIFF[23] I1=n29 I2=n18
XU46 AN2 $PINS O=n18 I1=n30 I2=n17
XU47 XOR2HS $PINS O=DIFF[24] I1=n28 I2=n19
XU48 AN2 $PINS O=n19 I1=n29 I2=n18
XU49 AN2 $PINS O=n20 I1=n28 I2=n19
XU50 XOR2HS $PINS O=DIFF[25] I1=n27 I2=n20
XU51 XOR2HS $PINS O=DIFF[5] I1=n47 I2=n21
XU52 AN2T $PINS O=n21 I1=n48 I2=n3
XU53 XOR2HS $PINS O=DIFF[6] I1=n46 I2=n22
XU54 AN2T $PINS O=n22 I1=n47 I2=n21
XU55 XOR2HS $PINS O=DIFF[7] I1=n45 I2=n23
XU56 AN2T $PINS O=n23 I1=n46 I2=n22
XU57 AN2T $PINS O=n24 I1=n23 I2=n45
XU58 INV1S $PINS O=n44 I=B[8]
XU60 INV1S $PINS O=n42 I=B[10]
XU61 INV1S $PINS O=n41 I=B[11]
XU62 INV1S $PINS O=n40 I=B[12]
XU63 INV1S $PINS O=n39 I=B[13]
XU64 INV1S $PINS O=n38 I=B[14]
XU65 INV1S $PINS O=n37 I=B[15]
XU66 INV1S $PINS O=n36 I=B[16]
XU67 INV1S $PINS O=n35 I=B[17]
XU68 INV1S $PINS O=n34 I=B[18]
XU69 INV1S $PINS O=n33 I=B[19]
XU70 INV1S $PINS O=n32 I=B[20]
XU71 INV1S $PINS O=n31 I=B[21]
XU72 INV1S $PINS O=n30 I=B[22]
XU73 INV1S $PINS O=n29 I=B[23]
XU74 INV1S $PINS O=n28 I=B[24]
XU75 INV1S $PINS O=n27 I=B[25]
XU76 XOR2HS $PINS O=DIFF[26] I1=B[26] I2=n26
XU78 ND2 $PINS O=n26 I1=n27 I2=n20
XU1 INV2 $PINS O=n51 I=B[1]
XU4 INV2 $PINS O=n50 I=B[2]
XU5 NR2P $PINS O=n1 I1=B[1] I2=B[0]
.ENDS

.SUBCKT PE_Shift_Add_2_DW01_add_2_DW01_add_19 A[26] A[25] A[24] A[23] A[22]
+ A[21] A[20] A[19] A[18] A[17] A[16] A[15] A[14] A[13] A[12] A[11] A[10] A[9]
+ A[8] A[7] A[6] A[5] A[4] A[3] A[2] A[1] A[0] B[26] B[25] B[24] B[23] B[22]
+ B[21] B[20] B[19] B[18] B[17] B[16] B[15] B[14] B[13] B[12] B[11] B[10] B[9]
+ B[8] B[7] B[6] B[5] B[4] B[3] B[2] B[1] B[0] CI SUM[26] SUM[25] SUM[24]
+ SUM[23] SUM[22] SUM[21] SUM[20] SUM[19] SUM[18] SUM[17] SUM[16] SUM[15]
+ SUM[14] SUM[13] SUM[12] SUM[11] SUM[10] SUM[9] SUM[8] SUM[7] SUM[6] SUM[5]
+ SUM[4] SUM[3] SUM[2] SUM[1] SUM[0] CO
XFE_RC_249_0 INV2 $PINS O=SUM[9] I=FE_RN_114_0
XFE_RC_248_0 XNR3 $PINS O=FE_RN_114_0 I1=A[9] I2=B[9] I3=carry[9]
XFE_RC_216_0 XOR3P $PINS O=SUM[24] I1=A[24] I2=B[24] I3=carry[24]
XFE_RC_215_0 MAO222 $PINS O=carry[25] A1=A[24] B1=B[24] C1=carry[24]
XFE_OCPC1168_carry_4 BUF1 $PINS O=FE_OCPN1168_carry_4 I=carry[4]
XFE_OCPC1148_carry_8 BUF1S $PINS O=FE_OCPN1148_carry_8 I=carry[8]
XFE_OCPC1090_carry_6 BUF1S $PINS O=FE_OCPN1090_carry_6 I=carry[6]
XFE_OCPC1087_carry_5 BUF1S $PINS O=FE_OCPN1087_carry_5 I=carry[5]
XFE_OCPC886_carry_19 BUF1S $PINS O=FE_OCPN886_carry_19 I=carry[19]
XFE_RC_4023_0 MOAI1 $PINS O=carry[19] A1=FE_RN_1432_0 A2=FE_RN_1431_0 B1=B[18]
+ B2=A[18]
XFE_RC_3712_0 ND3P $PINS O=carry[2] I1=n13 I2=n15 I3=n14
XFE_RC_3666_0 ND2 $PINS O=FE_RN_2401_0 I1=B[4] I2=A[4]
XFE_RC_3665_0 ND2 $PINS O=FE_RN_2402_0 I1=carry[4] I2=A[4]
XFE_RC_3664_0 ND2 $PINS O=FE_RN_2403_0 I1=carry[4] I2=B[4]
XFE_RC_3663_0 ND3P $PINS O=carry[5] I1=FE_RN_2403_0 I2=FE_RN_2402_0
+ I3=FE_RN_2401_0
XFE_OCPC474_carry_20 BUF1S $PINS O=FE_OCPN474_carry_20 I=carry[20]
XFE_RC_3465_0 XOR2HS $PINS O=FE_RN_2254_0 I1=B[20] I2=A[20]
XFE_RC_3464_0 OR2B1S $PINS O=FE_RN_2255_0 I1=FE_OCPN474_carry_20
+ B1=FE_RN_2254_0
XFE_RC_3463_0 ND2 $PINS O=FE_RN_2256_0 I1=A[20] I2=B[20]
XFE_RC_3462_0 ND2 $PINS O=FE_RN_2257_0 I1=FE_RN_2256_0 I2=FE_RN_2261_0
XFE_RC_3461_0 ND2 $PINS O=FE_RN_2258_0 I1=FE_RN_2257_0 I2=FE_OCPN474_carry_20
XFE_RC_3460_0 ND2 $PINS O=SUM[20] I1=FE_RN_2258_0 I2=FE_RN_2255_0
XFE_RC_3459_0 INV1S $PINS O=FE_RN_2259_0 I=B[20]
XFE_RC_3458_0 INV1S $PINS O=FE_RN_2260_0 I=A[20]
XFE_RC_3457_0 OR2 $PINS O=FE_RN_2261_0 I1=B[20] I2=A[20]
XFE_RC_3456_0 ND2 $PINS O=FE_RN_2262_0 I1=FE_RN_2261_0 I2=carry[20]
XFE_RC_3455_0 OAI12HS $PINS O=carry[21] A1=FE_RN_2262_0 B1=FE_RN_2260_0
+ B2=FE_RN_2259_0
XFE_RC_3355_0 OAI12H $PINS O=FE_RN_849_0 A1=carry[17] B1=B[17] B2=A[17]
XFE_RC_2325_0 INV1S $PINS O=FE_RN_1431_0 I=FE_RN_1264_0
XFE_RC_2324_0 INV1S $PINS O=FE_RN_1432_0 I=carry[18]
XFE_RC_2096_0 XOR2HS $PINS O=FE_RN_1262_0 I1=A[18] I2=B[18]
XFE_RC_2095_0 XOR2HS $PINS O=SUM[18] I1=carry[18] I2=FE_RN_1262_0
XFE_RC_2094_0 INV1S $PINS O=FE_RN_1263_0 I=B[18]
XFE_RC_2093_0 OR2B1S $PINS O=FE_RN_1264_0 I1=A[18] B1=FE_RN_1263_0
XFE_RC_1736_0 INV2CK $PINS O=FE_RN_981_0 I=B[19]
XFE_RC_1735_0 AN2B1S $PINS O=FE_RN_982_0 I1=A[19] B1=FE_RN_981_0
XFE_RC_1734_0 AN2B1S $PINS O=FE_RN_983_0 I1=FE_RN_989_0 B1=FE_RN_982_0
XFE_RC_1731_0 MAOI1 $PINS O=FE_RN_986_0 A1=FE_RN_981_0 A2=A[19] B1=A[19]
+ B2=FE_RN_981_0
XFE_RC_1730_0 MXL2HS $PINS OB=SUM[19] S=FE_OCPN886_carry_19 A=FE_RN_986_0
+ B=FE_RN_983_0
XFE_RC_1729_0 INV1S $PINS O=FE_RN_987_0 I=carry[19]
XFE_RC_1727_0 OR2B1S $PINS O=FE_RN_989_0 I1=A[19] B1=FE_RN_981_0
XFE_RC_1726_0 INV1S $PINS O=FE_RN_990_0 I=FE_RN_989_0
XFE_RC_1725_0 MOAI1 $PINS O=carry[20] A1=FE_RN_987_0 A2=FE_RN_990_0 B1=B[19]
+ B2=A[19]
XFE_RC_1706_0 ND3P $PINS O=carry[17] I1=n9 I2=n10 I3=n11
XFE_RC_1547_0 XOR2HS $PINS O=FE_RN_847_0 I1=A[17] I2=B[17]
XFE_RC_1546_0 XOR2HS $PINS O=SUM[17] I1=carry[17] I2=FE_RN_847_0
XFE_RC_1545_0 ND2 $PINS O=FE_RN_848_0 I1=B[17] I2=A[17]
XFE_RC_1543_0 ND2P $PINS O=carry[18] I1=FE_RN_849_0 I2=FE_RN_848_0
XFE_RC_1449_0 ND3P $PINS O=carry[14] I1=n7 I2=n6 I3=n8
XFE_RC_1310_0 ND2 $PINS O=FE_RN_664_0 I1=B[14] I2=A[14]
XFE_RC_1309_0 ND2 $PINS O=FE_RN_665_0 I1=FE_RN_664_0 I2=FE_RN_671_0
XFE_RC_1308_0 INV1S $PINS O=FE_RN_666_0 I=B[14]
XFE_RC_1306_0 NR2 $PINS O=FE_RN_668_0 I1=A[14] I2=FE_RN_666_0
XFE_RC_1305_0 AOI12HS $PINS O=FE_RN_669_0 A1=FE_RN_668_0 B1=FE_RN_666_0
+ B2=A[14]
XFE_RC_1304_0 MOAI1 $PINS O=SUM[14] A1=FE_RN_669_0 A2=carry[14] B1=FE_RN_665_0
+ B2=carry[14]
XFE_RC_1302_0 OR2 $PINS O=FE_RN_671_0 I1=A[14] I2=B[14]
XFE_RC_1301_0 ND2P $PINS O=FE_RN_672_0 I1=carry[14] I2=FE_RN_671_0
XFE_RC_1300_0 ND2P $PINS O=carry[15] I1=FE_RN_672_0 I2=FE_RN_664_0
XFE_RC_1046_0 INV1S $PINS O=FE_RN_458_0 I=carry[15]
XFE_RC_1045_0 INV1S $PINS O=FE_RN_459_0 I=B[15]
XFE_RC_1043_0 ND2 $PINS O=FE_RN_461_0 I1=FE_RN_459_0 I2=A[15]
XFE_RC_1042_0 OAI12HS $PINS O=FE_RN_462_0 A1=FE_RN_461_0 B1=FE_RN_459_0
+ B2=A[15]
XFE_RC_1041_0 ND2S $PINS O=FE_RN_463_0 I1=FE_RN_462_0 I2=FE_RN_458_0
XFE_RC_1040_0 ND2 $PINS O=FE_RN_464_0 I1=B[15] I2=A[15]
XFE_RC_1039_0 ND2S $PINS O=FE_RN_465_0 I1=FE_RN_464_0 I2=FE_RN_469_0
XFE_RC_1038_0 ND2 $PINS O=FE_RN_466_0 I1=FE_RN_465_0 I2=carry[15]
XFE_RC_1037_0 ND2P $PINS O=SUM[15] I1=FE_RN_466_0 I2=FE_RN_463_0
XFE_RC_1034_0 OR2B1S $PINS O=FE_RN_469_0 I1=A[15] B1=FE_RN_459_0
XFE_RC_1033_0 ND2 $PINS O=FE_RN_470_0 I1=carry[15] I2=FE_RN_469_0
XFE_RC_1032_0 ND2P $PINS O=carry[16] I1=FE_RN_470_0 I2=FE_RN_464_0
XFE_RC_921_0 ND2 $PINS O=FE_RN_372_0 I1=carry[2] I2=B[2]
XFE_RC_920_0 AOI22H $PINS O=FE_RN_373_0 A1=A[2] A2=B[2] B1=carry[2] B2=A[2]
XFE_RC_919_0 ND2P $PINS O=carry[3] I1=FE_RN_373_0 I2=FE_RN_372_0
XFE_RC_735_0 ND2 $PINS O=FE_RN_240_0 I1=carry[3] I2=B[3]
XFE_RC_734_0 AOI22H $PINS O=FE_RN_241_0 A1=A[3] A2=B[3] B1=carry[3] B2=A[3]
XFE_RC_733_0 ND2P $PINS O=carry[4] I1=FE_RN_241_0 I2=FE_RN_240_0
XFE_RC_655_0 ND2 $PINS O=FE_RN_205_0 I1=carry[8] I2=B[8]
XFE_RC_654_0 AOI22H $PINS O=FE_RN_206_0 A1=A[8] A2=B[8] B1=carry[8] B2=A[8]
XFE_RC_653_0 ND2T $PINS O=carry[9] I1=FE_RN_205_0 I2=FE_RN_206_0
XFE_RC_634_0 ND2 $PINS O=FE_RN_190_0 I1=carry[5] I2=B[5]
XFE_RC_633_0 AOI22H $PINS O=FE_RN_191_0 A1=A[5] A2=B[5] B1=carry[5] B2=A[5]
XFE_RC_632_0 ND2P $PINS O=carry[6] I1=FE_RN_191_0 I2=FE_RN_190_0
XFE_RC_570_0 ND3P $PINS O=carry[10] I1=FE_RN_147_0 I2=FE_RN_148_0
+ I3=FE_RN_149_0
XFE_RC_532_0 ND2P $PINS O=FE_RN_147_0 I1=carry[9] I2=B[9]
XFE_RC_531_0 ND2P $PINS O=FE_RN_148_0 I1=carry[9] I2=A[9]
XFE_RC_530_0 ND2 $PINS O=FE_RN_149_0 I1=A[9] I2=B[9]
XFE_RC_524_0 ND2P $PINS O=FE_RN_145_0 I1=carry[6] I2=B[6]
XFE_RC_523_0 AOI22H $PINS O=FE_RN_146_0 A1=A[6] A2=B[6] B1=carry[6] B2=A[6]
XFE_RC_522_0 ND2P $PINS O=carry[7] I1=FE_RN_146_0 I2=FE_RN_145_0
XFE_RC_477_0 ND2 $PINS O=FE_RN_129_0 I1=carry[7] I2=B[7]
XFE_RC_476_0 AOI22H $PINS O=FE_RN_130_0 A1=A[7] A2=B[7] B1=carry[7] B2=A[7]
XFE_RC_475_0 ND2P $PINS O=carry[8] I1=FE_RN_130_0 I2=FE_RN_129_0
XFE_RC_389_0 XOR3 $PINS O=SUM[8] I1=A[8] I2=B[8] I3=FE_OCPN1148_carry_8
XFE_RC_286_0 XOR3 $PINS O=SUM[2] I1=A[2] I2=B[2] I3=carry[2]
XFE_RC_271_0 XOR3 $PINS O=SUM[7] I1=A[7] I2=B[7] I3=carry[7]
XFE_RC_120_0 XOR3 $PINS O=SUM[6] I1=A[6] I2=B[6] I3=FE_OCPN1090_carry_6
XFE_RC_116_0 XOR3 $PINS O=SUM[3] I1=A[3] I2=B[3] I3=carry[3]
XFE_RC_84_0 XOR3 $PINS O=SUM[5] I1=A[5] I2=B[5] I3=FE_OCPN1087_carry_5
XFE_RC_54_0 XOR3 $PINS O=SUM[4] I1=A[4] I2=B[4] I3=FE_OCPN1168_carry_4
XU1_26 XOR3 $PINS O=SUM[26] I1=A[26] I2=B[26] I3=carry[26]
XU1_22 FA1 $PINS S=SUM[22] CO=carry[23] A=A[22] B=B[22] CI=carry[22]
XU1_12 FA1 $PINS S=SUM[12] CO=carry[13] A=A[12] B=B[12] CI=carry[12]
XU1_10 FA1 $PINS S=SUM[10] CO=carry[11] A=A[10] B=B[10] CI=carry[10]
XU1_23 FA1 $PINS S=SUM[23] CO=carry[24] A=A[23] B=B[23] CI=carry[23]
XU1_21 FA1 $PINS S=SUM[21] CO=carry[22] A=A[21] B=B[21] CI=carry[21]
XU1_25 FA1 $PINS S=SUM[25] CO=carry[26] A=A[25] B=B[25] CI=carry[25]
XU1 ND2 $PINS O=n8 I1=A[13] I2=B[13]
XU3 ND2P $PINS O=n3 I1=n1 I2=A[11]
XU4 ND2 $PINS O=n15 I1=A[1] I2=B[1]
XU5 ND2P $PINS O=n14 I1=carry[1] I2=B[1]
XU6 XOR3 $PINS O=SUM[11] I1=A[11] I2=B[11] I3=n1
XU8 ND2 $PINS O=n4 I1=carry[11] I2=B[11]
XU9 ND2 $PINS O=n9 I1=carry[16] I2=A[16]
XU10 XOR3 $PINS O=SUM[13] I1=A[13] I2=B[13] I3=n2
XU11 MAO222 $PINS O=n1 A1=carry[10] B1=B[10] C1=A[10]
XU12 ND2 $PINS O=n7 I1=carry[13] I2=B[13]
XU13 ND2S $PINS O=n5 I1=A[11] I2=B[11]
XU14 MAO222 $PINS O=n2 A1=carry[12] B1=B[12] C1=A[12]
XU15 ND2 $PINS O=n16 I1=B[0] I2=A[0]
XU16 ND2 $PINS O=n13 I1=A[1] I2=carry[1]
XU17 XOR2HS $PINS O=SUM[1] I1=carry[1] I2=n12
XU20 ND2 $PINS O=n6 I1=n2 I2=A[13]
XU21 XOR3 $PINS O=SUM[16] I1=A[16] I2=B[16] I3=carry[16]
XU22 ND2P $PINS O=n10 I1=carry[16] I2=B[16]
XU23 ND2 $PINS O=n11 I1=A[16] I2=B[16]
XU24 XOR2HS $PINS O=n12 I1=A[1] I2=B[1]
XU26 XOR2HS $PINS O=SUM[0] I1=A[0] I2=B[0]
XU2 ND3P $PINS O=carry[12] I1=n4 I2=n3 I3=n5
XU25 INV2 $PINS O=carry[1] I=n16
.ENDS

.SUBCKT PE_Shift_Add_2_DW01_add_1_DW01_add_18 A[26] A[25] A[24] A[23] A[22]
+ A[21] A[20] A[19] A[18] A[17] A[16] A[15] A[14] A[13] A[12] A[11] A[10] A[9]
+ A[8] A[7] A[6] A[5] A[4] A[3] A[2] A[1] A[0] B[26] B[25] B[24] B[23] B[22]
+ B[21] B[20] B[19] B[18] B[17] B[16] B[15] B[14] B[13] B[12] B[11] B[10] B[9]
+ B[8] B[7] B[6] B[5] B[4] B[3] B[2] B[1] B[0] CI SUM[26] SUM[25] SUM[24]
+ SUM[23] SUM[22] SUM[21] SUM[20] SUM[19] SUM[18] SUM[17] SUM[16] SUM[15]
+ SUM[14] SUM[13] SUM[12] SUM[11] SUM[10] SUM[9] SUM[8] SUM[7] SUM[6] SUM[5]
+ SUM[4] SUM[3] SUM[2] SUM[1] SUM[0] CO
XFE_RC_105_0 XOR2HS $PINS O=SUM[2] I1=FE_RN_1912_0 I2=FE_OCPN1197_carry_2
XFE_RC_103_0 OR2T $PINS O=FE_RN_57_0 I1=FE_RN_1470_0 I2=B[1]
XFE_RC_102_0 ND2P $PINS O=FE_RN_1473_0 I1=FE_RN_1472_0 I2=FE_RN_57_0
XFE_OCPC1218_N100 BUF1S $PINS O=FE_OCPN1218_N100 I=B[4]
XFE_OCPC1199_carry_4 BUF1S $PINS O=FE_OCPN1199_carry_4 I=carry[4]
XFE_OCPC1197_carry_2 BUF1S $PINS O=FE_OCPN1197_carry_2 I=carry[2]
XFE_OCPC1187_carry_3 BUF1S $PINS O=FE_OCPN1187_carry_3 I=carry[3]
XFE_OCPC1116_carry_8 BUF1S $PINS O=FE_OCPN1116_carry_8 I=carry[8]
XFE_OCPC1113_carry_5 BUF1S $PINS O=FE_OCPN1113_carry_5 I=carry[5]
XFE_RC_4054_0 ND3P $PINS O=carry[6] I1=n9 I2=n8 I3=n10
XFE_RC_4044_0 OAI12HS $PINS O=FE_RN_1467_0 A1=carry[1] B1=B[1] B2=A[1]
XFE_RC_3976_0 INV2CK $PINS O=SUM[10] I=FE_RN_2577_0
XFE_RC_3975_0 XNR3 $PINS O=FE_RN_2577_0 I1=A[10] I2=B[10] I3=carry[10]
XFE_RC_740_0_dup ND2P $PINS O=FE_RN_1 I1=FE_RN_243_0 I2=FE_RN_242_0
XFE_RC_3602_0 OAI12H $PINS O=FE_RN_1914_0 A1=carry[2] B1=B[2] B2=A[2]
XFE_RC_3375_0 XOR2HS $PINS O=FE_RN_2183_0 I1=B[20] I2=A[20]
XFE_RC_3374_0 OR2B1S $PINS O=FE_RN_2184_0 I1=carry[20] B1=FE_RN_2183_0
XFE_RC_3373_0 ND2 $PINS O=FE_RN_2185_0 I1=A[20] I2=B[20]
XFE_RC_3372_0 ND2S $PINS O=FE_RN_2186_0 I1=FE_RN_2185_0 I2=FE_RN_2192_0
XFE_RC_3371_0 ND2 $PINS O=FE_RN_2187_0 I1=FE_RN_2186_0 I2=carry[20]
XFE_RC_3370_0 ND2 $PINS O=SUM[20] I1=FE_RN_2187_0 I2=FE_RN_2184_0
XFE_RC_3369_0 INV1S $PINS O=FE_RN_2188_0 I=B[20]
XFE_RC_3368_0 INV1S $PINS O=FE_RN_2189_0 I=A[20]
XFE_RC_3365_0 ND2 $PINS O=FE_RN_2192_0 I1=FE_RN_2189_0 I2=FE_RN_2188_0
XFE_RC_3364_0 ND2 $PINS O=FE_RN_2193_0 I1=FE_RN_2192_0 I2=carry[20]
XFE_RC_3363_0 OAI12HS $PINS O=carry[21] A1=FE_RN_2193_0 B1=FE_RN_2189_0
+ B2=FE_RN_2188_0
XFE_RC_2979_0 INV1S $PINS O=FE_RN_1909_0 I=A[2]
XFE_RC_2977_0 ND2 $PINS O=FE_RN_1911_0 I1=FE_RN_1909_0 I2=B[2]
XFE_RC_2976_0 OAI12HS $PINS O=FE_RN_1912_0 A1=FE_RN_1911_0 B1=FE_RN_1909_0
+ B2=B[2]
XFE_RC_2974_0 ND2 $PINS O=FE_RN_1913_0 I1=A[2] I2=B[2]
XFE_RC_2972_0 ND2P $PINS O=carry[3] I1=FE_RN_1914_0 I2=FE_RN_1913_0
XFE_RC_2381_0 ND2S $PINS O=FE_RN_1466_0 I1=A[1] I2=B[1]
XFE_RC_2379_0 ND2 $PINS O=carry[2] I1=FE_RN_1467_0 I2=FE_RN_1466_0
XFE_RC_2378_0 INV1S $PINS O=FE_RN_1468_0 I=carry[1]
XFE_RC_2376_0 INV1S $PINS O=FE_RN_1470_0 I=A[1]
XFE_RC_2374_0 ND2 $PINS O=FE_RN_1472_0 I1=FE_RN_1470_0 I2=B[1]
XFE_RC_2372_0 ND2P $PINS O=FE_RN_1474_0 I1=FE_RN_1473_0 I2=FE_RN_1468_0
XFE_RC_2371_0 OAI12H $PINS O=SUM[1] A1=FE_RN_1474_0 B1=FE_RN_1473_0
+ B2=FE_RN_1468_0
XFE_RC_2243_0 ND2 $PINS O=FE_RN_1369_0 I1=carry[3] I2=B[3]
XFE_RC_2242_0 AOI22H $PINS O=FE_RN_1370_0 A1=B[3] A2=A[3] B1=carry[3] B2=A[3]
XFE_RC_2241_0 ND2P $PINS O=carry[4] I1=FE_RN_1370_0 I2=FE_RN_1369_0
XFE_RC_2240_0 INV1S $PINS O=FE_RN_1359_0 I=FE_RN_1367_0
XFE_RC_2239_0 AOI12HS $PINS O=FE_RN_1360_0 A1=FE_RN_1359_0 B1=A[19] B2=B[19]
XFE_RC_2238_0 INV1S $PINS O=FE_RN_1361_0 I=A[19]
XFE_RC_2236_0 NR2 $PINS O=FE_RN_1363_0 I1=B[19] I2=FE_RN_1361_0
XFE_RC_2235_0 AOI12HS $PINS O=FE_RN_1364_0 A1=FE_RN_1363_0 B1=FE_RN_1361_0
+ B2=B[19]
XFE_RC_2234_0 MXL2HS $PINS OB=SUM[19] S=carry[19] A=FE_RN_1364_0 B=FE_RN_1360_0
XFE_RC_2233_0 ND2 $PINS O=FE_RN_1365_0 I1=A[19] I2=B[19]
XFE_RC_2231_0 OR2B1S $PINS O=FE_RN_1367_0 I1=B[19] B1=FE_RN_1361_0
XFE_RC_2230_0 ND2 $PINS O=FE_RN_1368_0 I1=FE_RN_1367_0 I2=carry[19]
XFE_RC_2229_0 ND2P $PINS O=carry[20] I1=FE_RN_1368_0 I2=FE_RN_1365_0
XFE_RC_2068_0 INV1S $PINS O=FE_RN_1233_0 I=A[18]
XFE_RC_2066_0 NR2 $PINS O=FE_RN_1235_0 I1=B[18] I2=FE_RN_1233_0
XFE_RC_2065_0 AOI12HS $PINS O=FE_RN_1236_0 A1=FE_RN_1235_0 B1=FE_RN_1233_0
+ B2=B[18]
XFE_RC_2064_0 ND2 $PINS O=FE_RN_1237_0 I1=A[18] I2=B[18]
XFE_RC_2063_0 ND2S $PINS O=FE_RN_1238_0 I1=FE_RN_1237_0 I2=FE_RN_1243_0
XFE_RC_2062_0 ND2 $PINS O=FE_RN_1239_0 I1=FE_RN_1238_0 I2=carry[18]
XFE_RC_2061_0 OAI12HS $PINS O=SUM[18] A1=FE_RN_1239_0 B1=FE_RN_1236_0
+ B2=carry[18]
XFE_RC_2059_0 INV1S $PINS O=FE_RN_1241_0 I=B[18]
XFE_RC_2057_0 ND2 $PINS O=FE_RN_1243_0 I1=FE_RN_1233_0 I2=FE_RN_1241_0
XFE_RC_2056_0 ND2 $PINS O=FE_RN_1244_0 I1=FE_RN_1243_0 I2=carry[18]
XFE_RC_2055_0 ND2P $PINS O=carry[19] I1=FE_RN_1244_0 I2=FE_RN_1237_0
XFE_RC_1878_0 INV1S $PINS O=FE_RN_1095_0 I=FE_RN_1100_0
XFE_RC_1877_0 AOI12HS $PINS O=FE_RN_1096_0 A1=FE_RN_1095_0 B1=A[17] B2=B[17]
XFE_RC_1876_0 XNR2HS $PINS O=FE_RN_1097_0 I1=B[17] I2=A[17]
XFE_RC_1875_0 MXL2HS $PINS OB=SUM[17] S=carry[17] A=FE_RN_1097_0 B=FE_RN_1096_0
XFE_RC_1874_0 ND2 $PINS O=FE_RN_1098_0 I1=A[17] I2=B[17]
XFE_RC_1873_0 INV1S $PINS O=FE_RN_1099_0 I=A[17]
XFE_RC_1872_0 OR2B1S $PINS O=FE_RN_1100_0 I1=B[17] B1=FE_RN_1099_0
XFE_RC_1871_0 ND2 $PINS O=FE_RN_1101_0 I1=carry[17] I2=FE_RN_1100_0
XFE_RC_1870_0 ND2P $PINS O=carry[18] I1=FE_RN_1101_0 I2=FE_RN_1098_0
XFE_RC_1679_0 ND2 $PINS O=FE_RN_939_0 I1=A[16] I2=B[16]
XFE_RC_1678_0 ND2 $PINS O=FE_RN_940_0 I1=FE_RN_939_0 I2=FE_RN_946_0
XFE_RC_1677_0 INV1S $PINS O=FE_RN_941_0 I=A[16]
XFE_RC_1676_0 AN2B1S $PINS O=FE_RN_942_0 I1=A[16] B1=B[16]
XFE_RC_1675_0 AOI12HS $PINS O=FE_RN_943_0 A1=FE_RN_942_0 B1=FE_RN_941_0
+ B2=B[16]
XFE_RC_1674_0 MOAI1 $PINS O=SUM[16] A1=FE_RN_943_0 A2=carry[16] B1=FE_RN_940_0
+ B2=carry[16]
XFE_RC_1671_0 OR2B1S $PINS O=FE_RN_946_0 I1=B[16] B1=FE_RN_941_0
XFE_RC_1670_0 ND2 $PINS O=FE_RN_947_0 I1=carry[16] I2=FE_RN_946_0
XFE_RC_1669_0 ND2P $PINS O=carry[17] I1=FE_RN_947_0 I2=FE_RN_939_0
XFE_RC_1668_0 ND2 $PINS O=FE_RN_937_0 I1=carry[13] I2=B[13]
XFE_RC_1667_0 AOI22H $PINS O=FE_RN_938_0 A1=B[13] A2=A[13] B1=carry[13]
+ B2=A[13]
XFE_RC_1666_0 ND2P $PINS O=carry[14] I1=FE_RN_938_0 I2=FE_RN_937_0
XFE_RC_1655_0 ND2 $PINS O=FE_RN_928_0 I1=FE_RN_1 I2=B[11]
XFE_RC_1654_0 AOI22H $PINS O=FE_RN_929_0 A1=B[11] A2=A[11] B1=FE_RN_1 B2=A[11]
XFE_RC_1653_0 ND2P $PINS O=carry[12] I1=FE_RN_929_0 I2=FE_RN_928_0
XFE_RC_1596_0 OAI12H $PINS O=FE_RN_368_0 A1=carry[15] B1=B[15] B2=A[15]
XFE_RC_1345_0 ND2 $PINS O=FE_RN_694_0 I1=carry[14] I2=B[14]
XFE_RC_1344_0 AOI22H $PINS O=FE_RN_695_0 A1=B[14] A2=A[14] B1=carry[14]
+ B2=A[14]
XFE_RC_1343_0 ND2P $PINS O=carry[15] I1=FE_RN_695_0 I2=FE_RN_694_0
XFE_RC_1003_0 ND2 $PINS O=FE_RN_437_0 I1=carry[6] I2=B[6]
XFE_RC_1002_0 AOI22H $PINS O=FE_RN_438_0 A1=B[6] A2=A[6] B1=carry[6] B2=A[6]
XFE_RC_1001_0 ND2P $PINS O=carry[7] I1=FE_RN_438_0 I2=FE_RN_437_0
XFE_RC_911_0 XOR2HS $PINS O=FE_RN_366_0 I1=B[15] I2=A[15]
XFE_RC_910_0 XOR2HS $PINS O=SUM[15] I1=carry[15] I2=FE_RN_366_0
XFE_RC_909_0 ND2S $PINS O=FE_RN_367_0 I1=A[15] I2=B[15]
XFE_RC_907_0 ND2P $PINS O=carry[16] I1=FE_RN_368_0 I2=FE_RN_367_0
XFE_RC_750_0 ND2P $PINS O=FE_RN_246_0 I1=carry[7] I2=B[7]
XFE_RC_749_0 AOI22H $PINS O=FE_RN_247_0 A1=B[7] A2=A[7] B1=carry[7] B2=A[7]
XFE_RC_748_0 ND2P $PINS O=carry[8] I1=FE_RN_247_0 I2=FE_RN_246_0
XFE_RC_742_0 ND2 $PINS O=FE_RN_242_0 I1=carry[10] I2=B[10]
XFE_RC_741_0 AOI22H $PINS O=FE_RN_243_0 A1=B[10] A2=A[10] B1=carry[10] B2=A[10]
XFE_RC_658_0 ND2 $PINS O=FE_RN_207_0 I1=carry[8] I2=B[8]
XFE_RC_657_0 AOI22H $PINS O=FE_RN_208_0 A1=B[8] A2=A[8] B1=carry[8] B2=A[8]
XFE_RC_656_0 ND2P $PINS O=carry[9] I1=FE_RN_208_0 I2=FE_RN_207_0
XFE_RC_629_0 ND3P $PINS O=carry[13] I1=n5 I2=n4 I3=n6
XFE_RC_615_0 XOR3 $PINS O=SUM[3] I1=A[3] I2=B[3] I3=FE_OCPN1187_carry_3
XFE_RC_539_0 XOR3 $PINS O=SUM[13] I1=A[13] I2=B[13] I3=carry[13]
XFE_RC_485_0 ND2 $PINS O=FE_RN_133_0 I1=carry[9] I2=B[9]
XFE_RC_484_0 AOI22H $PINS O=FE_RN_134_0 A1=B[9] A2=A[9] B1=carry[9] B2=A[9]
XFE_RC_483_0 ND2P $PINS O=carry[10] I1=FE_RN_134_0 I2=FE_RN_133_0
XFE_RC_468_0 XOR3 $PINS O=SUM[14] I1=A[14] I2=B[14] I3=carry[14]
XFE_RC_391_0 XOR3 $PINS O=SUM[6] I1=A[6] I2=B[6] I3=carry[6]
XFE_RC_356_0 XOR3 $PINS O=SUM[7] I1=A[7] I2=B[7] I3=carry[7]
XFE_RC_273_0 XOR3 $PINS O=SUM[8] I1=A[8] I2=B[8] I3=FE_OCPN1116_carry_8
XFE_RC_114_0 XOR3 $PINS O=SUM[9] I1=A[9] I2=B[9] I3=carry[9]
XFE_RC_30_0 ND3P $PINS O=carry[5] I1=n13 I2=n12 I3=n14
XFE_RC_27_0 XOR3 $PINS O=SUM[11] I1=A[11] I2=B[11] I3=FE_RN_1
XU1_22 FA1 $PINS S=SUM[22] CO=carry[23] A=A[22] B=B[22] CI=carry[22]
XU1_21 FA1 $PINS S=SUM[21] CO=carry[22] A=A[21] B=B[21] CI=carry[21]
XU1_24 FA1 $PINS S=SUM[24] CO=carry[25] A=A[24] B=B[24] CI=carry[24]
XU1_23 FA1 $PINS S=SUM[23] CO=carry[24] A=A[23] B=B[23] CI=carry[23]
XU1_25 FA1 $PINS S=SUM[25] CO=carry[26] A=A[25] B=B[25] CI=carry[25]
XU2 ND2 $PINS O=n15 I1=B[0] I2=A[0]
XU8 XOR2HS $PINS O=n3 I1=B[12] I2=A[12]
XU9 XOR2HS $PINS O=SUM[12] I1=carry[12] I2=n3
XU10 ND2P $PINS O=n4 I1=carry[12] I2=B[12]
XU11 ND2P $PINS O=n5 I1=carry[12] I2=A[12]
XU12 ND2S $PINS O=n6 I1=B[12] I2=A[12]
XU14 XOR2HS $PINS O=n7 I1=B[5] I2=A[5]
XU15 XOR2HS $PINS O=SUM[5] I1=FE_OCPN1113_carry_5 I2=n7
XU17 ND2 $PINS O=n10 I1=B[5] I2=A[5]
XU19 XOR2HS $PINS O=n11 I1=FE_OCPN1218_N100 I2=A[4]
XU20 ND2P $PINS O=n12 I1=carry[4] I2=B[4]
XU21 ND2 $PINS O=n13 I1=carry[4] I2=A[4]
XU22 XOR3 $PINS O=SUM[26] I1=A[26] I2=B[26] I3=carry[26]
XU23 INV1S $PINS O=carry[1] I=n15
XU24 XOR2HS $PINS O=SUM[0] I1=B[0] I2=A[0]
XU1 ND2 $PINS O=n14 I1=B[4] I2=A[4]
XU3 XOR2HS $PINS O=SUM[4] I1=FE_OCPN1199_carry_4 I2=n11
XU4 ND2 $PINS O=n9 I1=carry[5] I2=A[5]
XU7 ND2 $PINS O=n8 I1=carry[5] I2=B[5]
.ENDS

.SUBCKT PE_Shift_Add_2_DW01_add_0_DW01_add_17 A[26] A[25] A[24] A[23] A[22]
+ A[21] A[20] A[19] A[18] A[17] A[16] A[15] A[14] A[13] A[12] A[11] A[10] A[9]
+ A[8] A[7] A[6] A[5] A[4] A[3] A[2] A[1] A[0] B[26] B[25] B[24] B[23] B[22]
+ B[21] B[20] B[19] B[18] B[17] B[16] B[15] B[14] B[13] B[12] B[11] B[10] B[9]
+ B[8] B[7] B[6] B[5] B[4] B[3] B[2] B[1] B[0] CI SUM[26] SUM[25] SUM[24]
+ SUM[23] SUM[22] SUM[21] SUM[20] SUM[19] SUM[18] SUM[17] SUM[16] SUM[15]
+ SUM[14] SUM[13] SUM[12] SUM[11] SUM[10] SUM[9] SUM[8] SUM[7] SUM[6] SUM[5]
+ SUM[4] SUM[3] SUM[2] SUM[1] SUM[0] CO
XFE_RC_219_0 ND3P $PINS O=n16 I1=FE_RN_1160_0 I2=FE_RN_1161_0 I3=FE_RN_1159_0
XFE_RC_124_0 ND2S $PINS O=FE_RN_63_0 I1=B[22] I2=A[22]
XFE_RC_123_0 ND2P $PINS O=FE_RN_64_0 I1=carry[22] I2=A[22]
XFE_RC_122_0 ND2P $PINS O=FE_RN_65_0 I1=carry[22] I2=B[22]
XFE_RC_121_0 ND3P $PINS O=carry[23] I1=FE_RN_65_0 I2=FE_RN_64_0 I3=FE_RN_63_0
XFE_RC_118_0 ND3HT $PINS O=carry[15] I1=n20 I2=n21 I3=n19
XFE_RC_114_0 ND2 $PINS O=FE_RN_60_0 I1=B[24] I2=A[24]
XFE_RC_113_0 ND2 $PINS O=FE_RN_61_0 I1=carry[24] I2=A[24]
XFE_RC_112_0 ND2 $PINS O=FE_RN_62_0 I1=carry[24] I2=B[24]
XFE_RC_111_0 ND3P $PINS O=FE_RN_2 I1=FE_RN_62_0 I2=FE_RN_61_0 I3=FE_RN_60_0
XFE_OCPC1215_N215 BUF2 $PINS O=FE_OCPN1215_N215 I=B[10]
XFE_OCPC1198_N218 BUF1S $PINS O=FE_OCPN1198_N218 I=B[13]
XFE_OCPC1128_carry_9 BUF1S $PINS O=FE_OCPN1128_carry_9 I=carry[9]
XFE_OCPC1082_carry_10 BUF1S $PINS O=FE_OCPN1082_carry_10 I=carry[10]
XFE_OCPC1063_carry_7 BUF1S $PINS O=FE_OCPN1063_carry_7 I=carry[7]
XFE_OCPC1050_N191 BUF1S $PINS O=FE_OCPN1050_N191 I=A[13]
XFE_OCPC1042_carry_17 BUF1S $PINS O=FE_OCPN1042_carry_17 I=carry[17]
XFE_OCPC1032_N206 BUF1S $PINS O=FE_OCPN1032_N206 I=B[1]
XFE_OCPC1004_n16 BUF1S $PINS O=FE_OCPN1004_n16 I=n16
XFE_OCPC994_carry_16 BUF1S $PINS O=FE_OCPN994_carry_16 I=carry[16]
XFE_OCPC895_FE_RN_1 BUF1S $PINS O=FE_OCPN895_FE_RN_1 I=FE_RN_1
XFE_RC_3992_0 ND2 $PINS O=FE_RN_2587_0 I1=A[23] I2=B[23]
XFE_RC_3991_0 ND2 $PINS O=FE_RN_2588_0 I1=carry[23] I2=A[23]
XFE_RC_3990_0 ND2 $PINS O=FE_RN_2589_0 I1=carry[23] I2=B[23]
XFE_RC_3989_0 ND3P $PINS O=carry[24] I1=FE_RN_2589_0 I2=FE_RN_2588_0
+ I3=FE_RN_2587_0
XFE_RC_3912_0 ND3P $PINS O=carry[22] I1=FE_RN_537_0 I2=FE_RN_539_0
+ I3=FE_RN_538_0
XFE_RC_3855_0 XOR2HS $PINS O=FE_RN_2530_0 I1=A[26] I2=B[26]
XFE_RC_3854_0 XOR2HS $PINS O=SUM[26] I1=carry[26] I2=FE_RN_2530_0
XFE_RC_3567_0 INV1S $PINS O=FE_RN_2319_0 I=FE_OCPN1063_carry_7
XFE_RC_3566_0 XOR2HS $PINS O=FE_RN_2320_0 I1=A[7] I2=B[7]
XFE_RC_3565_0 ND2 $PINS O=FE_RN_2321_0 I1=FE_RN_2320_0 I2=FE_RN_2319_0
XFE_RC_3564_0 INV1S $PINS O=FE_RN_2322_0 I=A[7]
XFE_RC_3563_0 INV1S $PINS O=FE_RN_2323_0 I=B[7]
XFE_RC_3562_0 OAI12HS $PINS O=FE_RN_2324_0 A1=FE_RN_2329_0 B1=FE_RN_2323_0
+ B2=FE_RN_2322_0
XFE_RC_3561_0 ND2 $PINS O=FE_RN_2325_0 I1=FE_RN_2324_0 I2=FE_OCPN1063_carry_7
XFE_RC_3560_0 ND2 $PINS O=SUM[7] I1=FE_RN_2325_0 I2=FE_RN_2321_0
XFE_RC_3559_0 ND2 $PINS O=FE_RN_2326_0 I1=B[7] I2=A[7]
XFE_RC_3556_0 ND2S $PINS O=FE_RN_2329_0 I1=FE_RN_2323_0 I2=FE_RN_2322_0
XFE_RC_3555_0 ND2 $PINS O=FE_RN_2330_0 I1=carry[7] I2=FE_RN_2329_0
XFE_RC_3554_0 ND2P $PINS O=carry[8] I1=FE_RN_2330_0 I2=FE_RN_2326_0
XFE_OCPC394_carry_24 BUF1S $PINS O=FE_OCPN394_carry_24 I=carry[24]
XFE_OCPC312_carry_23 BUF1S $PINS O=FE_OCPN312_carry_23 I=carry[23]
XFE_OCPC263_carry_15 BUF1S $PINS O=FE_OCPN263_carry_15 I=carry[15]
XFE_RC_3492_0 ND3P $PINS O=carry[21] I1=FE_RN_137_0 I2=FE_RN_139_0
+ I3=FE_RN_138_0
XFE_OCPC235_carry_20 BUF1S $PINS O=FE_OCPN235_carry_20 I=carry[20]
XFE_OCPC234_carry_21 BUF1S $PINS O=FE_OCPN234_carry_21 I=carry[21]
XFE_OCPC233_carry_19 BUF1S $PINS O=FE_OCPN233_carry_19 I=carry[19]
XFE_OCPC230_carry_22 BUF1S $PINS O=FE_OCPN230_carry_22 I=carry[22]
XFE_RC_3267_0 INV1S $PINS O=FE_RN_2104_0 I=n1
XFE_RC_3265_0 NR2 $PINS O=FE_RN_2106_0 I1=FE_OCPN1032_N206 I2=FE_RN_2104_0
XFE_RC_3264_0 AOI12HS $PINS O=FE_RN_2107_0 A1=FE_RN_2106_0 B1=FE_RN_2104_0
+ B2=B[1]
XFE_RC_3263_0 INV1S $PINS O=FE_RN_2108_0 I=B[1]
XFE_RC_3261_0 OAI12HS $PINS O=FE_RN_2110_0 A1=FE_RN_2113_0 B1=FE_RN_2104_0
+ B2=FE_RN_2108_0
XFE_RC_3260_0 ND2 $PINS O=FE_RN_2111_0 I1=FE_RN_2110_0 I2=A[1]
XFE_RC_3259_0 OAI12HS $PINS O=SUM[1] A1=FE_RN_2111_0 B1=FE_RN_2107_0 B2=A[1]
XFE_RC_3258_0 ND2 $PINS O=FE_RN_2112_0 I1=n1 I2=B[1]
XFE_RC_3257_0 OR2T $PINS O=FE_RN_2113_0 I1=B[1] I2=n1
XFE_RC_3256_0 ND2P $PINS O=FE_RN_2114_0 I1=FE_RN_2113_0 I2=A[1]
XFE_RC_3255_0 ND2P $PINS O=carry[2] I1=FE_RN_2114_0 I2=FE_RN_2112_0
XFE_RC_3132_0 AOI22HP $PINS O=FE_RN_681_0 A1=A[16] A2=B[16] B1=carry[16]
+ B2=A[16]
XFE_RC_3044_0 AOI22HP $PINS O=FE_RN_777_0 A1=B[17] A2=A[17] B1=carry[17]
+ B2=A[17]
XFE_RC_1450_0_dup ND2P $PINS O=FE_RN_1 I1=FE_RN_777_0 I2=FE_RN_776_0
XFE_RC_2201_0 INV1S $PINS O=FE_RN_1331_0 I=n15
XFE_RC_2200_0 XOR2HS $PINS O=FE_RN_1332_0 I1=A[12] I2=B[12]
XFE_RC_2199_0 ND2 $PINS O=FE_RN_1333_0 I1=FE_RN_1332_0 I2=FE_RN_1331_0
XFE_RC_2198_0 INV1S $PINS O=FE_RN_1334_0 I=A[12]
XFE_RC_2197_0 INV1S $PINS O=FE_RN_1335_0 I=B[12]
XFE_RC_2196_0 OAI12HS $PINS O=FE_RN_1336_0 A1=FE_RN_1339_0 B1=FE_RN_1335_0
+ B2=FE_RN_1334_0
XFE_RC_2195_0 ND2 $PINS O=FE_RN_1337_0 I1=FE_RN_1336_0 I2=n15
XFE_RC_2194_0 ND2 $PINS O=SUM[12] I1=FE_RN_1337_0 I2=FE_RN_1333_0
XFE_RC_2193_0 ND2 $PINS O=FE_RN_1338_0 I1=B[12] I2=A[12]
XFE_RC_2192_0 OR2T $PINS O=FE_RN_1339_0 I1=A[12] I2=B[12]
XFE_RC_2191_0 ND2 $PINS O=FE_RN_1340_0 I1=FE_RN_1339_0 I2=n15
XFE_RC_2190_0 ND2 $PINS O=carry[13] I1=FE_RN_1340_0 I2=FE_RN_1338_0
XFE_RC_2182_0 ND2 $PINS O=FE_RN_1324_0 I1=FE_RN_1 I2=B[18]
XFE_RC_2181_0 AOI22H $PINS O=FE_RN_1325_0 A1=A[18] A2=B[18] B1=FE_RN_1 B2=A[18]
XFE_RC_2180_0 ND2P $PINS O=carry[19] I1=FE_RN_1325_0 I2=FE_RN_1324_0
XFE_RC_2148_0 ND2 $PINS O=FE_RN_1303_0 I1=n16 I2=B[13]
XFE_RC_2147_0 AOI22H $PINS O=FE_RN_1304_0 A1=B[13] A2=A[13] B1=n16 B2=A[13]
XFE_RC_2146_0 ND2P $PINS O=n18 I1=FE_RN_1304_0 I2=FE_RN_1303_0
XFE_RC_2008_0 XNR2HS $PINS O=FE_RN_1189_0 I1=B[2] I2=carry[2]
XFE_RC_2007_0 OR2 $PINS O=FE_RN_1190_0 I1=A[2] I2=FE_RN_1189_0
XFE_RC_2006_0 ND2 $PINS O=FE_RN_1191_0 I1=carry[2] I2=B[2]
XFE_RC_2005_0 ND2 $PINS O=FE_RN_1192_0 I1=FE_RN_1191_0 I2=FE_RN_1197_0
XFE_RC_2004_0 ND2 $PINS O=FE_RN_1193_0 I1=FE_RN_1192_0 I2=A[2]
XFE_RC_2003_0 ND2 $PINS O=SUM[2] I1=FE_RN_1193_0 I2=FE_RN_1190_0
XFE_RC_2001_0 INV1S $PINS O=FE_RN_1195_0 I=B[2]
XFE_RC_2000_0 INV2 $PINS O=FE_RN_1196_0 I=carry[2]
XFE_RC_1999_0 ND2P $PINS O=FE_RN_1197_0 I1=FE_RN_1196_0 I2=FE_RN_1195_0
XFE_RC_1998_0 ND2P $PINS O=FE_RN_1198_0 I1=FE_RN_1197_0 I2=A[2]
XFE_RC_1997_0 ND2P $PINS O=carry[3] I1=FE_RN_1198_0 I2=FE_RN_1191_0
XFE_RC_1956_0 ND2 $PINS O=FE_RN_1159_0 I1=A[12] I2=B[12]
XFE_RC_1955_0 ND2 $PINS O=FE_RN_1160_0 I1=carry[12] I2=A[12]
XFE_RC_1954_0 ND2 $PINS O=FE_RN_1161_0 I1=carry[12] I2=B[12]
XFE_RC_1922_0 ND3P $PINS O=carry[4] I1=n3 I2=n2 I3=n4
XFE_RC_1869_0 ND2 $PINS O=FE_RN_1093_0 I1=carry[13] I2=B[13]
XFE_RC_1868_0 AOI22S $PINS O=FE_RN_1094_0 A1=B[13] A2=A[13] B1=carry[13]
+ B2=A[13]
XFE_RC_1867_0 ND2S $PINS O=n17 I1=FE_RN_1094_0 I2=FE_RN_1093_0
XFE_RC_1848_0 ND3P $PINS O=carry[6] I1=n10 I2=n9 I3=n8
XFE_RC_1799_0 ND3P $PINS O=carry[7] I1=n13 I2=n14 I3=n12
XFE_RC_1452_0 ND2P $PINS O=FE_RN_776_0 I1=carry[17] I2=B[17]
XFE_RC_1423_0 ND2 $PINS O=FE_RN_753_0 I1=FE_RN_2 I2=B[25]
XFE_RC_1422_0 AOI22H $PINS O=FE_RN_754_0 A1=B[25] A2=A[25] B1=FE_RN_2 B2=A[25]
XFE_RC_1421_0 ND2P $PINS O=carry[26] I1=FE_RN_754_0 I2=FE_RN_753_0
XFE_RC_1327_0 ND2 $PINS O=FE_RN_680_0 I1=carry[16] I2=B[16]
XFE_RC_1325_0 ND2T $PINS O=carry[17] I1=FE_RN_680_0 I2=FE_RN_681_0
XFE_RC_1146_0 ND3P $PINS O=carry[9] I1=n5 I2=n6 I3=n7
XFE_RC_1141_0 ND2 $PINS O=FE_RN_537_0 I1=carry[21] I2=A[21]
XFE_RC_1140_0 ND2 $PINS O=FE_RN_538_0 I1=A[21] I2=B[21]
XFE_RC_1139_0 ND2P $PINS O=FE_RN_539_0 I1=carry[21] I2=B[21]
XFE_RC_1111_0 XOR3 $PINS O=SUM[25] I1=A[25] I2=B[25] I3=FE_RN_2
XFE_RC_805_0 XNR2HS $PINS O=FE_RN_277_0 I1=A[9] I2=B[9]
XFE_RC_804_0 INV1S $PINS O=FE_RN_278_0 I=A[9]
XFE_RC_803_0 INV1S $PINS O=FE_RN_279_0 I=B[9]
XFE_RC_802_0 OAI12HS $PINS O=FE_RN_280_0 A1=FE_RN_283_0 B1=FE_RN_279_0
+ B2=FE_RN_278_0
XFE_RC_801_0 ND2 $PINS O=FE_RN_281_0 I1=FE_RN_280_0 I2=FE_OCPN1128_carry_9
XFE_RC_800_0 OAI12HS $PINS O=SUM[9] A1=FE_RN_281_0 B1=FE_RN_277_0
+ B2=FE_OCPN1128_carry_9
XFE_RC_799_0 ND2 $PINS O=FE_RN_282_0 I1=B[9] I2=A[9]
XFE_RC_798_0 OR2P $PINS O=FE_RN_283_0 I1=A[9] I2=B[9]
XFE_RC_797_0 ND2 $PINS O=FE_RN_284_0 I1=FE_RN_283_0 I2=carry[9]
XFE_RC_796_0 ND2P $PINS O=carry[10] I1=FE_RN_284_0 I2=FE_RN_282_0
XFE_RC_652_0 INV1S $PINS O=FE_RN_194_0 I=A[10]
XFE_RC_650_0 NR2 $PINS O=FE_RN_196_0 I1=FE_OCPN1215_N215 I2=FE_RN_194_0
XFE_RC_649_0 AOI12HS $PINS O=FE_RN_197_0 A1=FE_RN_196_0 B1=FE_RN_194_0
+ B2=FE_OCPN1215_N215
XFE_RC_648_0 INV1S $PINS O=FE_RN_198_0 I=B[10]
XFE_RC_646_0 OAI12HS $PINS O=FE_RN_200_0 A1=FE_RN_203_0 B1=FE_RN_194_0
+ B2=FE_RN_198_0
XFE_RC_645_0 ND2 $PINS O=FE_RN_201_0 I1=FE_RN_200_0 I2=carry[10]
XFE_RC_644_0 OAI12HS $PINS O=SUM[10] A1=FE_RN_201_0 B1=FE_RN_197_0
+ B2=FE_OCPN1082_carry_10
XFE_RC_643_0 ND2P $PINS O=FE_RN_202_0 I1=A[10] I2=FE_OCPN1215_N215
XFE_RC_642_0 OR2 $PINS O=FE_RN_203_0 I1=B[10] I2=A[10]
XFE_RC_641_0 ND2P $PINS O=FE_RN_204_0 I1=FE_RN_203_0 I2=carry[10]
XFE_RC_640_0 ND2P $PINS O=carry[11] I1=FE_RN_204_0 I2=FE_RN_202_0
XFE_RC_580_0 ND2P $PINS O=FE_RN_170_0 I1=carry[19] I2=A[19]
XFE_RC_579_0 ND2 $PINS O=FE_RN_171_0 I1=A[19] I2=B[19]
XFE_RC_578_0 ND2 $PINS O=FE_RN_172_0 I1=carry[19] I2=B[19]
XFE_RC_577_0 ND3P $PINS O=carry[20] I1=FE_RN_172_0 I2=FE_RN_170_0
+ I3=FE_RN_171_0
XFE_RC_505_0 ND3HT $PINS O=carry[16] I1=n25 I2=n24 I3=n23
XFE_RC_502_0 ND2 $PINS O=FE_RN_137_0 I1=A[20] I2=carry[20]
XFE_RC_501_0 ND2 $PINS O=FE_RN_138_0 I1=A[20] I2=B[20]
XFE_RC_500_0 ND2 $PINS O=FE_RN_139_0 I1=B[20] I2=carry[20]
XFE_RC_428_0 XOR3 $PINS O=SUM[24] I1=A[24] I2=B[24] I3=FE_OCPN394_carry_24
XFE_RC_382_0 XOR3 $PINS O=SUM[23] I1=A[23] I2=B[23] I3=FE_OCPN312_carry_23
XFE_RC_294_0 XOR3 $PINS O=SUM[19] I1=A[19] I2=B[19] I3=FE_OCPN233_carry_19
XFE_RC_207_0 XOR3 $PINS O=SUM[16] I1=A[16] I2=B[16] I3=FE_OCPN994_carry_16
XFE_RC_76_0 XOR3 $PINS O=SUM[17] I1=A[17] I2=B[17] I3=FE_OCPN1042_carry_17
XFE_RC_74_0 XOR3 $PINS O=SUM[20] I1=A[20] I2=B[20] I3=FE_OCPN235_carry_20
XFE_RC_37_0 XOR3 $PINS O=SUM[21] I1=A[21] I2=B[21] I3=FE_OCPN234_carry_21
XFE_RC_23_0 XOR3 $PINS O=SUM[22] I1=A[22] I2=B[22] I3=FE_OCPN230_carry_22
XFE_RC_21_0 XOR3 $PINS O=SUM[18] I1=A[18] I2=B[18] I3=FE_OCPN895_FE_RN_1
XU1_11 FA1 $PINS S=SUM[11] CO=carry[12] A=A[11] B=B[11] CI=carry[11]
XU1_4 FA1 $PINS S=SUM[4] CO=carry[5] A=A[4] B=B[4] CI=carry[4]
XU1_13 FA1S $PINS S=SUM[13] CO=carry[14] A=FE_OCPN1050_N191 B=FE_OCPN1198_N218
+ CI=FE_OCPN1004_n16
XU2 ND2 $PINS O=n21 I1=B[14] I2=n17
XU5 ND2 $PINS O=n8 I1=A[5] I2=B[5]
XU6 ND2 $PINS O=n19 I1=A[14] I2=B[14]
XU7 ND2P $PINS O=n20 I1=A[14] I2=n18
XU8 XOR3 $PINS O=SUM[5] I1=A[5] I2=B[5] I3=carry[5]
XU9 XOR3 $PINS O=SUM[14] I1=A[14] I2=B[14] I3=carry[14]
XU10 AN2 $PINS O=n1 I1=B[0] I2=A[0]
XU11 XOR3 $PINS O=SUM[3] I1=A[3] I2=B[3] I3=carry[3]
XU12 ND2P $PINS O=n2 I1=carry[3] I2=A[3]
XU13 ND2 $PINS O=n3 I1=carry[3] I2=B[3]
XU14 ND2 $PINS O=n4 I1=A[3] I2=B[3]
XU16 XOR3 $PINS O=SUM[8] I1=A[8] I2=B[8] I3=carry[8]
XU17 ND2P $PINS O=n5 I1=carry[8] I2=A[8]
XU18 ND2P $PINS O=n6 I1=carry[8] I2=B[8]
XU19 ND2 $PINS O=n7 I1=A[8] I2=B[8]
XU20 ND2 $PINS O=n9 I1=A[5] I2=carry[5]
XU21 ND2 $PINS O=n10 I1=B[5] I2=carry[5]
XU23 XOR2HS $PINS O=n11 I1=A[6] I2=B[6]
XU24 XOR2HS $PINS O=SUM[6] I1=carry[6] I2=n11
XU25 ND2 $PINS O=n12 I1=A[6] I2=B[6]
XU26 ND2 $PINS O=n13 I1=A[6] I2=carry[6]
XU27 ND2 $PINS O=n14 I1=carry[6] I2=B[6]
XU28 MAO222 $PINS O=n15 A1=A[11] B1=B[11] C1=carry[11]
XU29 ND2P $PINS O=n25 I1=carry[15] I2=B[15]
XU30 ND2P $PINS O=n24 I1=carry[15] I2=A[15]
XU35 XOR2HS $PINS O=n22 I1=A[15] I2=B[15]
XU36 XOR2HS $PINS O=SUM[15] I1=n22 I2=FE_OCPN263_carry_15
XU37 ND2 $PINS O=n23 I1=A[15] I2=B[15]
XU38 XOR2HS $PINS O=SUM[0] I1=B[0] I2=A[0]
.ENDS

.SUBCKT PE_Shift_Add_2 rst_n en clear calc_done stage_sel x_in[16] x_in[15]
+ x_in[14] x_in[13] x_in[12] x_in[11] x_in[10] x_in[9] x_in[8] x_in[7] x_in[6]
+ x_in[5] x_in[4] x_in[3] x_in[2] x_in[1] x_in[0] sign1[1] sign1[0] sign2[1]
+ sign2[0] sign3[1] sign3[0] shf1[3] shf1[2] shf1[1] shf1[0] shf2[3] shf2[2]
+ shf2[1] shf2[0] shf3[3] shf3[2] shf3[1] shf3[0] y_out[16] y_out[15] y_out[14]
+ y_out[13] y_out[12] y_out[11] y_out[10] y_out[9] y_out[8] y_out[7] y_out[6]
+ y_out[5] y_out[4] y_out[3] y_out[2] y_out[1] y_out[0] i_rst_n
+ FE_OFN33_i_rst_n FE_OFN17_i_rst_n FE_OFN10_i_rst_n FE_OFN59_FE_DBTN9_n336
+ FE_OFN57_FE_DBTN9_n336 FE_OFN100_s21_1 FE_OFN101_s21_0 FE_OFN102_h21_3
+ FE_OFN103_h21_2 FE_OFN104_h21_1 FE_OFN105_h21_0 FE_OFN106_s22_1
+ FE_OFN107_s22_0 FE_OFN109_h22_2 FE_OFN110_h22_1 FE_OFN111_h22_0
+ FE_OFN112_s23_1 FE_OFN113_s23_0 FE_OFN114_h23_3 FE_OFN138_h23_2
+ FE_OFN142_h23_3 FE_OFN145_s21_0 FE_OFN159_s23_0 clk_clone1 clk
XFE_PHC2240_pe_i2_0 BUF1CK $PINS O=FE_PHN1244_pe_i2_0 I=FE_PHN2240_pe_i2_0
XFE_PHC2171_pe_i2_4 BUF1CK $PINS O=y_out[4] I=FE_PHN2171_pe_i2_4
XFE_PHC2084_N251 BUF1CK $PINS O=FE_PHN2084_N251 I=N251
XFE_PHC1849_N248 DELC $PINS O=FE_PHN1849_N248 I=N248
XFE_PHC1845_N250 DELC $PINS O=FE_PHN1845_N250 I=N250
XFE_PHC1843_N249 DELC $PINS O=N249 I=FE_PHN1843_N249
XFE_PHC1835_N247 DELC $PINS O=N247 I=FE_PHN1835_N247
XFE_PHC1807_N205 DELB $PINS O=FE_PHN1807_N205 I=N205
XFE_PHC1716_pe_i2_15 DELC $PINS O=y_out[15] I=FE_PHN1716_pe_i2_15
XFE_PHC1713_pe_i2_12 DELC $PINS O=y_out[12] I=FE_PHN1713_pe_i2_12
XFE_PHC1707_pe_i2_13 DELC $PINS O=y_out[13] I=FE_PHN1707_pe_i2_13
XFE_PHC1702_pe_i2_11 DELC $PINS O=y_out[11] I=FE_PHN1702_pe_i2_11
XFE_PHC1635_pe_i2_10 DELC $PINS O=y_out[10] I=FE_PHN1635_pe_i2_10
XFE_PHC1502_N238 DELC $PINS O=N238 I=FE_PHN1502_N238
XFE_PHC1499_N245 DELC $PINS O=FE_PHN1499_N245 I=N245
XFE_PHC1497_N235 DELC $PINS O=N235 I=FE_PHN1497_N235
XFE_PHC1486_N240 DELC $PINS O=FE_PHN1486_N240 I=N240
XFE_PHC1481_N239 DELC $PINS O=FE_PHN1481_N239 I=N239
XFE_PHC1480_N237 DELC $PINS O=FE_PHN1480_N237 I=N237
XFE_PHC1479_N251 DELC $PINS O=FE_PHN1479_N251 I=N251
XFE_PHC1472_N236 DELC $PINS O=FE_PHN1472_N236 I=N236
XFE_PHC1462_N242 DELC $PINS O=FE_PHN1462_N242 I=N242
XFE_PHC1443_N246 DELC $PINS O=FE_PHN1443_N246 I=N246
XFE_PHC1428_N241 DELC $PINS O=FE_PHN1428_N241 I=N241
XFE_PHC1414_N244 DELC $PINS O=N244 I=FE_PHN1414_N244
XFE_PHC1412_N243 DELC $PINS O=FE_PHN1412_N243 I=N243
XFE_PHC1248_pe_i2_2 DELC $PINS O=y_out[2] I=FE_PHN1248_pe_i2_2
XFE_PHC1246_pe_i2_1 DELC $PINS O=y_out[1] I=FE_PHN1246_pe_i2_1
XFE_PHC1244_pe_i2_0 DELC $PINS O=y_out[0] I=FE_PHN1244_pe_i2_0
XFE_RC_308_0 OA12 $PINS O=N96 A1=term2_shifted[0] B1=FE_OFN107_s22_0
+ B2=FE_DBTN22_s22_0
XFE_RC_273_0 AO22P $PINS O=N113 A1=term2_shifted[17] A2=FE_RN_3 B1=N86
+ B2=FE_OFN385_s22_0
XFE_RC_212_0 ND2 $PINS O=FE_RN_99_0 I1=term3_in[1] I2=shf3[0]
XFE_RC_211_0 INV2 $PINS O=FE_RN_100_0 I=shf3[0]
XFE_RC_210_0 ND2 $PINS O=FE_RN_101_0 I1=term3_in[2] I2=FE_RN_100_0
XFE_RC_209_0 ND2 $PINS O=sll_18/ML_int[1][2] I1=FE_RN_101_0 I2=FE_RN_99_0
XFE_RC_174_0 OR2 $PINS O=FE_RN_81_0 I1=FE_RN_1893_0 I2=FE_RN_1894_0
XFE_RC_173_0 ND2P $PINS O=sll_16/ML_int[3][4] I1=FE_RN_1896_0 I2=FE_RN_81_0
XFE_RC_72_0 ND2 $PINS O=FE_RN_41_0 I1=term3_in[0] I2=shf3[0]
XFE_RC_71_0 INV2 $PINS O=FE_RN_42_0 I=shf3[0]
XFE_RC_70_0 ND2 $PINS O=FE_RN_43_0 I1=term3_in[1] I2=FE_RN_42_0
XFE_RC_69_0 ND2 $PINS O=sll_18/ML_int[1][1] I1=FE_RN_43_0 I2=FE_RN_41_0
XFE_RC_57_0 AO22 $PINS O=N48 A1=term1_shifted[7] A2=n43 B1=N21
+ B2=FE_OFN310_s21_0
XFE_RC_27_0 ND3 $PINS O=n48 I1=term1_in[0] I2=n36 I3=n34
XFE_OCPC1223_n48 BUF1S $PINS O=FE_OCPN1223_n48 I=n48
XFE_OCPC1222_n49 BUF1S $PINS O=FE_OCPN1222_n49 I=n49
XFE_OCPC1208_sll_17_ML_int_2_2 BUF1S $PINS O=FE_OCPN1208_sll_17_ML_int_2_2
+ I=sll_17/ML_int[2][2]
XFE_OCPC1207_term2_shifted_2 BUF1CK $PINS O=FE_OCPN1207_term2_shifted_2
+ I=term2_shifted[2]
XFE_OCPC1140_n69 BUF1S $PINS O=FE_OCPN1140_n69 I=n69
XFE_OFC884_FE_OFN347_h23_1 BUF2 $PINS O=FE_OFN488_FE_OFN347_h23_1 I=shf3[1]
XFE_OFC883_FE_OFN347_h23_1 BUF1 $PINS O=FE_OFN487_FE_OFN347_h23_1 I=shf3[1]
XFE_OFC881_h23_0 BUF1 $PINS O=FE_OFN484_h23_0 I=shf3[0]
XFE_RC_4052_0 OAI12HS $PINS O=sll_18/ML_int[2][4] A1=FE_RN_1928_0
+ B1=FE_RN_1926_0 B2=FE_RN_1925_0
XFE_RC_4039_0 ND2 $PINS O=FE_RN_2599_0 I1=term1_shifted[20] I2=FE_OFN392_n
XFE_RC_4038_0 ND2 $PINS O=FE_RN_2600_0 I1=N34 I2=sign1[0]
XFE_RC_4037_0 ND2P $PINS O=N61 I1=FE_RN_2600_0 I2=FE_RN_2599_0
XFE_RC_3966_0 OR2 $PINS O=FE_RN_2575_0 I1=FE_RN_2263_0 I2=n59
XFE_RC_3965_0 ND2S $PINS O=sll_17/ML_int[3][4] I1=FE_RN_2266_0 I2=FE_RN_2575_0
XFE_RC_3955_0 INV1S $PINS O=FE_RN_2569_0 I=FE_OFN385_s22_0
XFE_RC_3954_0 INV1S $PINS O=FE_RN_2570_0 I=N89
XFE_RC_3953_0 MOAI1 $PINS O=N116 A1=FE_RN_2570_0 A2=FE_RN_2569_0
+ B1=term2_shifted[20] B2=FE_RN_3
XFE_RC_3916_0 OR2 $PINS O=FE_RN_2557_0 I1=FE_RN_1545_0 I2=FE_RN_1546_0
XFE_RC_3915_0 ND2P $PINS O=N44 I1=FE_RN_1547_0 I2=FE_RN_2557_0
XFE_RC_3891_0 ND2 $PINS O=FE_RN_2546_0 I1=term3_shifted[20] I2=n21
XFE_RC_3890_0 ND2 $PINS O=FE_RN_2547_0 I1=N144 I2=FE_OFN409_s23_0
XFE_RC_3889_0 ND2P $PINS O=N171 I1=FE_RN_2547_0 I2=FE_RN_2546_0
XFE_RC_3876_0 AO22P $PINS O=N115 A1=term2_shifted[19] A2=FE_RN_3 B1=N88
+ B2=FE_OFN385_s22_0
XFE_RC_3763_0 AO22 $PINS O=N46 A1=term1_shifted[5] A2=n43 B1=N19
+ B2=FE_OFN310_s21_0
XFE_RC_3730_0 ND2S $PINS O=FE_RN_2448_0 I1=term3_in[3] I2=FE_OFN484_h23_0
XFE_RC_3729_0 INV1S $PINS O=FE_RN_2449_0 I=shf3[0]
XFE_RC_3728_0 ND2S $PINS O=FE_RN_2450_0 I1=n9 I2=FE_RN_2449_0
XFE_RC_3727_0 ND2 $PINS O=sll_18/ML_int[1][4] I1=FE_RN_2450_0 I2=FE_RN_2448_0
XFE_RC_3722_0 ND2 $PINS O=FE_RN_2442_0 I1=sll_17/ML_int[1][1]
+ I2=FE_OFN110_h22_1
XFE_RC_3721_0 INV2 $PINS O=FE_RN_2443_0 I=FE_OFN110_h22_1
XFE_RC_3720_0 ND2 $PINS O=FE_RN_2444_0 I1=sll_17/ML_int[1][3] I2=FE_RN_2443_0
XFE_RC_3719_0 ND2 $PINS O=sll_17/ML_int[2][3] I1=FE_RN_2444_0 I2=FE_RN_2442_0
XFE_RC_3470_0 INV1S $PINS O=FE_RN_2263_0 I=FE_RN_2
XFE_RC_3468_0 INV1S $PINS O=FE_RN_2265_0 I=FE_RN_2
XFE_RC_3467_0 ND2 $PINS O=FE_RN_2266_0 I1=sll_17/ML_int[2][4] I2=FE_RN_2265_0
XFE_RC_3441_0 INV1S $PINS O=FE_RN_2242_0 I=n34
XFE_RC_3440_0 ND2 $PINS O=FE_RN_2243_0 I1=term1_in[0] I2=FE_RN_2242_0
XFE_RC_3439_0 ND2 $PINS O=FE_RN_2244_0 I1=term1_in[1] I2=n34
XFE_RC_3438_0 ND2 $PINS O=sll_16/ML_int[1][1] I1=FE_RN_2244_0 I2=FE_RN_2243_0
XFE_RC_3131_0 ND2 $PINS O=FE_RN_2017_0 I1=term2_shifted[7] I2=FE_DBTN22_s22_0
XFE_RC_3130_0 ND2 $PINS O=FE_RN_2018_0 I1=N76 I2=FE_OFN384_s22_0
XFE_RC_3129_0 ND2 $PINS O=N103 I1=FE_RN_2018_0 I2=FE_RN_2017_0
XFE_RC_2998_0 INV1S $PINS O=FE_RN_1925_0 I=shf3[1]
XFE_RC_2997_0 INV1S $PINS O=FE_RN_1926_0 I=sll_18/ML_int[1][2]
XFE_RC_2996_0 INV1S $PINS O=FE_RN_1927_0 I=shf3[1]
XFE_RC_2995_0 ND2S $PINS O=FE_RN_1928_0 I1=sll_18/ML_int[1][4] I2=FE_RN_1927_0
XFE_RC_2968_0 ND2 $PINS O=FE_RN_1904_0 I1=term1_in[1] I2=FE_OFN105_h21_0
XFE_RC_2967_0 INV1S $PINS O=FE_RN_1905_0 I=FE_OFN105_h21_0
XFE_RC_2966_0 ND2S $PINS O=FE_RN_1906_0 I1=term1_in[2] I2=FE_RN_1905_0
XFE_RC_2965_0 ND2 $PINS O=sll_16/ML_int[1][2] I1=FE_RN_1906_0 I2=FE_RN_1904_0
XFE_RC_2964_0 ND2 $PINS O=FE_RN_1902_0 I1=term3_shifted[9] I2=FE_OFN405_s23_0
XFE_RC_2963_0 ND2 $PINS O=FE_RN_1903_0 I1=N133 I2=FE_OFN406_s23_0
XFE_RC_2962_0 ND2 $PINS O=N160 I1=FE_RN_1903_0 I2=FE_RN_1902_0
XFE_RC_2954_0 INV1S $PINS O=FE_RN_1893_0 I=FE_OFN103_h21_2
XFE_RC_2953_0 INV1S $PINS O=FE_RN_1894_0 I=n53
XFE_RC_2952_0 INV1S $PINS O=FE_RN_1895_0 I=FE_OFN103_h21_2
XFE_RC_2951_0 ND2P $PINS O=FE_RN_1896_0 I1=sll_16/ML_int[2][4] I2=FE_RN_1895_0
XFE_RC_2934_0 MOAI1H $PINS O=N97 A1=n3 A2=FE_DBTN22_s22_0 B1=term2_shifted[1]
+ B2=FE_DBTN22_s22_0
XFE_RC_2903_0 ND2 $PINS O=FE_RN_1853_0 I1=term1_in[2] I2=FE_OFN105_h21_0
XFE_RC_2902_0 INV1S $PINS O=FE_RN_1854_0 I=FE_OFN105_h21_0
XFE_RC_2901_0 ND2S $PINS O=FE_RN_1855_0 I1=term1_in[3] I2=FE_RN_1854_0
XFE_RC_2900_0 ND2 $PINS O=sll_16/ML_int[1][3] I1=FE_RN_1855_0 I2=FE_RN_1853_0
XFE_RC_2891_0 ND2 $PINS O=FE_RN_1846_0 I1=term3_shifted[6] I2=FE_OFN405_s23_0
XFE_RC_2890_0 ND2 $PINS O=FE_RN_1847_0 I1=N130 I2=FE_OFN406_s23_0
XFE_RC_2889_0 ND2 $PINS O=N157 I1=FE_RN_1847_0 I2=FE_RN_1846_0
XFE_RC_2800_0 ND2 $PINS O=FE_RN_1782_0 I1=term3_shifted[5] I2=FE_OFN405_s23_0
XFE_RC_2799_0 ND2 $PINS O=FE_RN_1783_0 I1=N129 I2=FE_OFN406_s23_0
XFE_RC_2798_0 ND2P $PINS O=N156 I1=FE_RN_1783_0 I2=FE_RN_1782_0
XFE_RC_2797_0 ND2 $PINS O=FE_RN_1780_0 I1=term2_shifted[6] I2=FE_DBTN22_s22_0
XFE_RC_2796_0 ND2 $PINS O=FE_RN_1781_0 I1=N75 I2=FE_OFN107_s22_0
XFE_RC_2795_0 ND2P $PINS O=N102 I1=FE_RN_1781_0 I2=FE_RN_1780_0
XFE_RC_2774_0 ND2 $PINS O=FE_RN_1764_0 I1=term3_shifted[4] I2=FE_OFN405_s23_0
XFE_RC_2773_0 ND2P $PINS O=FE_RN_1765_0 I1=N128 I2=FE_OFN406_s23_0
XFE_RC_2772_0 ND2P $PINS O=N155 I1=FE_RN_1765_0 I2=FE_RN_1764_0
XFE_RC_2764_0 ND2 $PINS O=FE_RN_1757_0 I1=term2_shifted[5] I2=FE_DBTN22_s22_0
XFE_RC_2763_0 ND2P $PINS O=FE_RN_1758_0 I1=N74 I2=FE_OFN107_s22_0
XFE_RC_2762_0 ND2P $PINS O=N101 I1=FE_RN_1758_0 I2=FE_RN_1757_0
XFE_RC_2712_0 ND2 $PINS O=FE_RN_1717_0 I1=sll_17/ML_int[1][0]
+ I2=FE_OFN110_h22_1
XFE_RC_2711_0 INV2 $PINS O=FE_RN_1718_0 I=FE_OFN110_h22_1
XFE_RC_2710_0 ND2 $PINS O=FE_RN_1719_0 I1=sll_17/ML_int[1][2] I2=FE_RN_1718_0
XFE_RC_2709_0 ND2 $PINS O=sll_17/ML_int[2][2] I1=FE_RN_1719_0 I2=FE_RN_1717_0
XFE_RC_2658_0 ND2 $PINS O=FE_RN_1679_0 I1=term1_shifted[2] I2=n43
XFE_RC_2657_0 ND2 $PINS O=FE_RN_1680_0 I1=N16 I2=FE_OFN310_s21_0
XFE_RC_2656_0 ND2P $PINS O=N43 I1=FE_RN_1679_0 I2=FE_RN_1680_0
XFE_RC_2652_0 ND2 $PINS O=FE_RN_1675_0 I1=term3_shifted[1] I2=FE_OFN405_s23_0
XFE_RC_2651_0 ND2P $PINS O=FE_RN_1676_0 I1=N125 I2=FE_OFN406_s23_0
XFE_RC_2650_0 ND2P $PINS O=N152 I1=FE_RN_1676_0 I2=FE_RN_1675_0
XFE_RC_2622_0 INV1S $PINS O=FE_RN_1654_0 I=shf3[1]
XFE_RC_2621_0 INV2 $PINS O=sll_18/ML_int[2][2] I=FE_RN_1655_0
XFE_RC_2620_0 AOI22S $PINS O=FE_RN_1655_0 A1=sll_18/ML_int[1][0]
+ A2=FE_OFN488_FE_OFN347_h23_1 B1=sll_18/ML_int[1][2] B2=FE_RN_1654_0
XFE_RC_2619_0 ND2 $PINS O=FE_RN_1652_0 I1=term3_shifted[3] I2=FE_OFN405_s23_0
XFE_RC_2618_0 ND2P $PINS O=FE_RN_1653_0 I1=N127 I2=FE_OFN406_s23_0
XFE_RC_2617_0 ND2P $PINS O=N154 I1=FE_RN_1653_0 I2=FE_RN_1652_0
XFE_RC_2581_0 ND2 $PINS O=FE_RN_1621_0 I1=term1_in[3] I2=FE_OFN105_h21_0
XFE_RC_2580_0 INV1S $PINS O=FE_RN_1622_0 I=FE_OFN105_h21_0
XFE_RC_2579_0 ND2S $PINS O=FE_RN_1623_0 I1=term1_in[4] I2=FE_RN_1622_0
XFE_RC_2578_0 ND2 $PINS O=sll_16/ML_int[1][4] I1=FE_RN_1623_0 I2=FE_RN_1621_0
XFE_RC_2565_0 ND2 $PINS O=FE_RN_1611_0 I1=term3_shifted[2] I2=FE_OFN405_s23_0
XFE_RC_2564_0 ND2P $PINS O=FE_RN_1612_0 I1=N126 I2=FE_OFN406_s23_0
XFE_RC_2563_0 ND2P $PINS O=N153 I1=FE_RN_1612_0 I2=FE_RN_1611_0
XFE_RC_2551_0 INV1S $PINS O=FE_RN_1599_0 I=n43
XFE_RC_2550_0 INV1S $PINS O=FE_RN_1600_0 I=term1_shifted[9]
XFE_RC_2549_0 ND2 $PINS O=FE_RN_1601_0 I1=N23 I2=FE_OFN310_s21_0
XFE_RC_2548_0 OAI12HS $PINS O=N50 A1=FE_RN_1601_0 B1=FE_RN_1600_0
+ B2=FE_RN_1599_0
XFE_RC_2481_0 ND2 $PINS O=FE_RN_1548_0 I1=term1_shifted[1] I2=n43
XFE_RC_2480_0 ND2P $PINS O=FE_RN_1549_0 I1=N15 I2=FE_OFN310_s21_0
XFE_RC_2479_0 ND2P $PINS O=N42 I1=FE_RN_1549_0 I2=FE_RN_1548_0
XFE_RC_2475_0 INV1S $PINS O=FE_RN_1545_0 I=n43
XFE_RC_2474_0 INV2 $PINS O=FE_RN_1546_0 I=term1_shifted[3]
XFE_RC_2473_0 ND2 $PINS O=FE_RN_1547_0 I1=N17 I2=FE_OFN310_s21_0
XFE_RC_2431_0 ND2 $PINS O=FE_RN_1511_0 I1=FE_OCPN1207_term2_shifted_2
+ I2=FE_DBTN22_s22_0
XFE_RC_2430_0 ND2P $PINS O=FE_RN_1512_0 I1=N71 I2=FE_OFN107_s22_0
XFE_RC_2429_0 ND2P $PINS O=N98 I1=FE_RN_1512_0 I2=FE_RN_1511_0
XFE_RC_2392_0 ND2 $PINS O=FE_RN_1480_0 I1=term1_shifted[4] I2=n43
XFE_RC_2391_0 ND2 $PINS O=FE_RN_1481_0 I1=N18 I2=FE_OFN310_s21_0
XFE_RC_2390_0 ND2P $PINS O=N45 I1=FE_RN_1481_0 I2=FE_RN_1480_0
XFE_RC_2388_0 ND2 $PINS O=FE_RN_1477_0 I1=sll_16/ML_int[1][0] I2=FE_RN_1
XFE_RC_2387_0 INV1S $PINS O=FE_RN_1478_0 I=FE_RN_1
XFE_RC_2386_0 ND2S $PINS O=FE_RN_1479_0 I1=sll_16/ML_int[1][2] I2=FE_RN_1478_0
XFE_RC_2385_0 ND2 $PINS O=sll_16/ML_int[2][2] I1=FE_RN_1479_0 I2=FE_RN_1477_0
XFE_RC_2383_0 INV2 $PINS O=sll_17/ML_int[1][1] I=FE_RN_1476_0
XFE_RC_2382_0 AOI22H $PINS O=FE_RN_1476_0 A1=term2_in[0] A2=shf2[0]
+ B1=term2_in[1] B2=n24
XFE_RC_2154_0 ND2 $PINS O=FE_RN_1307_0 I1=term2_shifted[3] I2=FE_DBTN22_s22_0
XFE_RC_2153_0 ND2 $PINS O=FE_RN_1308_0 I1=N72 I2=FE_OFN107_s22_0
XFE_RC_2152_0 ND2P $PINS O=N99 I1=FE_RN_1308_0 I2=FE_RN_1307_0
XFE_RC_1499_0 ND2 $PINS O=FE_RN_811_0 I1=term2_shifted[4] I2=FE_DBTN22_s22_0
XFE_RC_1498_0 ND2P $PINS O=FE_RN_812_0 I1=N73 I2=FE_OFN107_s22_0
XFE_RC_1497_0 ND2P $PINS O=N100 I1=FE_RN_812_0 I2=FE_RN_811_0
XFE_RC_17_0 OA12 $PINS O=N151 A1=term3_shifted[0] B1=FE_OFN113_s23_0
+ B2=FE_OFN405_s23_0
XFE_RC_3_0 OA12 $PINS O=N41 A1=N14 B1=FE_OFN310_s21_0 B2=n43
XFE_OFC863_h22_1 BUF1 $PINS O=FE_RN_5 I=FE_OFN110_h22_1
XFE_OFC821_sll_17_ML_int_2__2 INV2 $PINS O=n63 I=sll_17/ML_int[2][2]
XFE_OFC774_sll_17_ML_int_1__1 INV2 $PINS O=n6 I=sll_17/ML_int[1][1]
XFE_OFC715_s22_1 BUF1 $PINS O=FE_RN_4 I=FE_OFN106_s22_1
XFE_OFC703_s23_0 INV1S $PINS O=FE_OFN409_s23_0 I=n21
XFE_OFC700_s23_0 BUF1 $PINS O=FE_OFN406_s23_0 I=FE_OFN113_s23_0
XFE_OFC698_s23_0 INV1S $PINS O=FE_OFN405_s23_0 I=FE_OFN113_s23_0
XFE_OFC697_s23_0 INV1S $PINS O=n21 I=FE_OFN113_s23_0
XFE_OFC672_s21_0 INV1S $PINS O=FE_OFN392_n I=sign1[0]
XFE_OFC669_s21_0 INV2 $PINS O=FE_OFN310_s21_0 I=FE_OFN101_s21_0
XFE_OFC667_s21_0 BUF1 $PINS O=n43 I=FE_OFN101_s21_0
XFE_OFC652_s22_0 INV1S $PINS O=FE_OFN385_s22_0 I=FE_RN_3
XFE_OFC651_s22_0 BUF1 $PINS O=FE_OFN384_s22_0 I=FE_OFN107_s22_0
XFE_OFC647_s22_0 INV1S $PINS O=FE_DBTN22_s22_0 I=FE_OFN107_s22_0
XFE_OFC646_s22_0 INV1S $PINS O=FE_RN_3 I=FE_OFN107_s22_0
XFE_OFC625_h22_3 INV1S $PINS O=n28 I=shf2[3]
XFE_OFC619_h22_2 INV1S $PINS O=FE_RN_2 I=FE_OFN109_h22_2
XFE_OFC570_h23_1 INV1S $PINS O=n14 I=FE_OFN488_FE_OFN347_h23_1
XFE_OFC546_h21_1 BUF1 $PINS O=FE_OFN336_h21_1 I=shf1[1]
XFE_OFC545_h21_1 BUF1 $PINS O=FE_OFN335_h21_1 I=shf1[1]
XFE_OFC544_h21_1 INV1S $PINS O=n36 I=shf1[1]
XFE_OFC543_h21_1 BUF1CK $PINS O=FE_RN_1 I=shf1[1]
XFE_OFC473_h21_3 INV1S $PINS O=n40 I=shf1[3]
XFE_OFC408_h23_3 BUF1 $PINS O=n18 I=FE_OFN114_h23_3
XFE_OFC378_pe_clear_d1 INV1S $PINS O=n96 I=clear
XFE_OFC357_h23_2 INV1S $PINS O=FE_OFN277_h23_2 I=shf3[2]
XU110 AO22 $PINS O=base_val[13] A1=acc_reg[13] A2=n96 B1=clear
+ B2=FE_OFN57_FE_DBTN9_n336
XU115 AO22 $PINS O=N67 A1=FE_OFN145_s21_0 A2=N40 B1=term1_shifted[26]
+ B2=FE_OFN392_n
XU116 AO22 $PINS O=N66 A1=N39 A2=FE_OFN145_s21_0 B1=term1_shifted[25]
+ B2=FE_OFN392_n
XU117 AO22 $PINS O=N65 A1=N38 A2=FE_OFN145_s21_0 B1=term1_shifted[24]
+ B2=FE_OFN392_n
XU118 AO22 $PINS O=N64 A1=N37 A2=sign1[0] B1=term1_shifted[23] B2=FE_OFN392_n
XU119 AO22 $PINS O=N63 A1=N36 A2=sign1[0] B1=term1_shifted[22] B2=FE_OFN392_n
XU120 AO22 $PINS O=N62 A1=N35 A2=sign1[0] B1=term1_shifted[21] B2=FE_OFN392_n
XU122 AO22P $PINS O=N60 A1=N33 A2=sign1[0] B1=term1_shifted[19] B2=FE_OFN392_n
XU123 AO22 $PINS O=N59 A1=N32 A2=sign1[0] B1=term1_shifted[18] B2=FE_OFN392_n
XU124 AO22 $PINS O=N58 A1=N31 A2=sign1[0] B1=term1_shifted[17] B2=FE_OFN392_n
XU126 AO22 $PINS O=N56 A1=N29 A2=sign1[0] B1=term1_shifted[15] B2=FE_OFN392_n
XU127 AO22 $PINS O=N55 A1=N28 A2=sign1[0] B1=term1_shifted[14] B2=n43
XU129 AO22 $PINS O=N53 A1=N26 A2=FE_OFN310_s21_0 B1=term1_shifted[12] B2=n43
XU131 AO22 $PINS O=N51 A1=N24 A2=FE_OFN310_s21_0 B1=term1_shifted[10] B2=n43
XU133 AO22 $PINS O=N49 A1=N22 A2=FE_OFN310_s21_0 B1=term1_shifted[8] B2=n43
XU135 AO22 $PINS O=N47 A1=N20 A2=FE_OFN310_s21_0 B1=term1_shifted[6] B2=n43
XU142 AO22 $PINS O=N177 A1=sign3[0] A2=N150 B1=term3_shifted[26]
+ B2=FE_OFN159_s23_0
XU143 AO22 $PINS O=N176 A1=N149 A2=sign3[0] B1=term3_shifted[25]
+ B2=FE_OFN159_s23_0
XU144 AO22 $PINS O=N175 A1=N148 A2=sign3[0] B1=term3_shifted[24]
+ B2=FE_OFN159_s23_0
XU145 AO22 $PINS O=N174 A1=N147 A2=sign3[0] B1=term3_shifted[23]
+ B2=FE_OFN159_s23_0
XU146 AO22 $PINS O=N173 A1=N146 A2=sign3[0] B1=term3_shifted[22]
+ B2=FE_OFN159_s23_0
XU147 AO22 $PINS O=N172 A1=N145 A2=FE_OFN409_s23_0 B1=term3_shifted[21] B2=n21
XU149 AO22 $PINS O=N170 A1=N143 A2=FE_OFN409_s23_0 B1=term3_shifted[19] B2=n21
XU150 AO22 $PINS O=N169 A1=N142 A2=FE_OFN409_s23_0 B1=term3_shifted[18] B2=n21
XU151 AO22 $PINS O=N168 A1=N141 A2=FE_OFN409_s23_0 B1=term3_shifted[17] B2=n21
XU153 AO22 $PINS O=N166 A1=N139 A2=FE_OFN409_s23_0 B1=term3_shifted[15] B2=n21
XU154 AO22 $PINS O=N165 A1=N138 A2=FE_OFN409_s23_0 B1=term3_shifted[14] B2=n21
XU156 AO22 $PINS O=N163 A1=N136 A2=FE_OFN406_s23_0 B1=term3_shifted[12]
+ B2=FE_OFN405_s23_0
XU158 AO22 $PINS O=N161 A1=N134 A2=FE_OFN406_s23_0 B1=term3_shifted[10]
+ B2=FE_OFN405_s23_0
XU161 AO22 $PINS O=N158 A1=N131 A2=FE_OFN406_s23_0 B1=term3_shifted[7]
+ B2=FE_OFN405_s23_0
XU169 AO22 $PINS O=N122 A1=N95 A2=FE_OFN385_s22_0 B1=term2_shifted[26]
+ B2=FE_RN_3
XU171 AO22 $PINS O=N120 A1=N93 A2=FE_OFN385_s22_0 B1=term2_shifted[24]
+ B2=FE_RN_3
XU172 AO22 $PINS O=N119 A1=N92 A2=FE_OFN385_s22_0 B1=term2_shifted[23]
+ B2=FE_RN_3
XU173 AO22 $PINS O=N118 A1=N91 A2=FE_OFN385_s22_0 B1=term2_shifted[22]
+ B2=FE_RN_3
XU174 AO22 $PINS O=N117 A1=N90 A2=FE_OFN385_s22_0 B1=term2_shifted[21]
+ B2=FE_RN_3
XU177 AO22 $PINS O=N114 A1=N87 A2=FE_OFN385_s22_0 B1=term2_shifted[18]
+ B2=FE_RN_3
XU179 AO22 $PINS O=N112 A1=N85 A2=FE_OFN385_s22_0 B1=term2_shifted[16]
+ B2=FE_RN_3
XU180 AO22 $PINS O=N111 A1=N84 A2=FE_OFN385_s22_0 B1=term2_shifted[15]
+ B2=FE_RN_3
XU181 AO22 $PINS O=N110 A1=N83 A2=FE_OFN384_s22_0 B1=term2_shifted[14]
+ B2=FE_RN_3
XU184 AO22 $PINS O=N107 A1=N80 A2=FE_OFN384_s22_0 B1=term2_shifted[11]
+ B2=FE_DBTN22_s22_0
XU185 AO22 $PINS O=N106 A1=N79 A2=FE_OFN384_s22_0 B1=term2_shifted[10]
+ B2=FE_DBTN22_s22_0
XU186 AO22 $PINS O=N105 A1=N78 A2=FE_OFN384_s22_0 B1=term2_shifted[9]
+ B2=FE_DBTN22_s22_0
XU187 AO22 $PINS O=N104 A1=N77 A2=FE_OFN384_s22_0 B1=term2_shifted[8]
+ B2=FE_DBTN22_s22_0
Xsll_18/M1_0_5 MUX2 $PINS O=sll_18/ML_int[1][5] S=FE_OFN484_h23_0 A=term3_in[5]
+ B=term3_in[4]
Xsll_18/M1_0_6 MUX2 $PINS O=sll_18/ML_int[1][6] S=FE_OFN484_h23_0 A=term3_in[6]
+ B=term3_in[5]
Xsll_18/M1_0_7 MUX2 $PINS O=sll_18/ML_int[1][7] S=FE_OFN484_h23_0 A=term3_in[7]
+ B=term3_in[6]
Xsll_18/M1_1_3 MUX2 $PINS O=sll_18/ML_int[2][3] S=FE_OFN488_FE_OFN347_h23_1
+ A=sll_18/ML_int[1][3] B=sll_18/ML_int[1][1]
Xsll_18/M1_1_5 MUX2 $PINS O=sll_18/ML_int[2][5] S=FE_OFN488_FE_OFN347_h23_1
+ A=sll_18/ML_int[1][5] B=sll_18/ML_int[1][3]
Xsll_18/M1_1_6 MUX2 $PINS O=sll_18/ML_int[2][6] S=FE_OFN488_FE_OFN347_h23_1
+ A=sll_18/ML_int[1][6] B=sll_18/ML_int[1][4]
Xsll_18/M1_1_7 MUX2 $PINS O=sll_18/ML_int[2][7] S=FE_OFN488_FE_OFN347_h23_1
+ A=sll_18/ML_int[1][7] B=sll_18/ML_int[1][5]
Xsll_18/M1_1_8 MUX2 $PINS O=sll_18/ML_int[2][8] S=FE_OFN488_FE_OFN347_h23_1
+ A=sll_18/ML_int[1][8] B=sll_18/ML_int[1][6]
Xsll_18/M1_2_4 MUX2 $PINS O=sll_18/ML_int[3][4] S=FE_OFN277_h23_2
+ A=sll_18/ML_int[2][4] B=n73
Xsll_18/M1_2_5 MUX2 $PINS O=sll_18/ML_int[3][5] S=FE_OFN277_h23_2
+ A=sll_18/ML_int[2][5] B=n74
Xsll_18/M1_2_7 MUX2 $PINS O=sll_18/ML_int[3][7] S=FE_OFN277_h23_2
+ A=sll_18/ML_int[2][7] B=sll_18/ML_int[2][3]
Xsll_18/M1_2_8 MUX2 $PINS O=sll_18/ML_int[3][8] S=FE_OFN277_h23_2
+ A=sll_18/ML_int[2][8] B=sll_18/ML_int[2][4]
Xsll_18/M1_2_9 MUX2 $PINS O=sll_18/ML_int[3][9] S=FE_OFN277_h23_2
+ A=sll_18/ML_int[2][9] B=sll_18/ML_int[2][5]
Xsll_18/M1_2_10 MUX2 $PINS O=sll_18/ML_int[3][10] S=FE_OFN277_h23_2
+ A=sll_18/ML_int[2][10] B=sll_18/ML_int[2][6]
Xsll_18/M1_3_8 MUX2 $PINS O=term3_shifted[8] S=n18 A=sll_18/ML_int[3][8]
+ B=sll_18/ML_int[3][0]
Xsll_18/M1_3_9 MUX2 $PINS O=term3_shifted[9] S=n18 A=sll_18/ML_int[3][9]
+ B=sll_18/ML_int[3][1]
Xsll_18/M1_3_10 MUX2 $PINS O=term3_shifted[10] S=n18 A=sll_18/ML_int[3][10]
+ B=sll_18/ML_int[3][2]
Xsll_18/M1_3_11 MUX2 $PINS O=term3_shifted[11] S=n18 A=sll_18/ML_int[3][11]
+ B=sll_18/ML_int[3][3]
Xsll_18/M1_3_12 MUX2 $PINS O=term3_shifted[12] S=n18 A=sll_18/ML_int[3][12]
+ B=sll_18/ML_int[3][4]
Xsll_18/M1_3_13 MUX2 $PINS O=term3_shifted[13] S=n18 A=sll_18/ML_int[3][13]
+ B=sll_18/ML_int[3][5]
Xsll_18/M1_3_14 MUX2 $PINS O=term3_shifted[14] S=n18 A=sll_18/ML_int[3][14]
+ B=sll_18/ML_int[3][6]
Xsll_18/M1_3_23 MUX2 $PINS O=term3_shifted[23] S=FE_OFN142_h23_3 A=term3_in[26]
+ B=sll_18/ML_int[3][15]
Xsll_17/M1_0_2 MUX2 $PINS O=sll_17/ML_int[1][2] S=FE_OFN111_h22_0 A=term2_in[2]
+ B=term2_in[1]
Xsll_17/M1_0_4 MUX2 $PINS O=sll_17/ML_int[1][4] S=FE_OFN111_h22_0 A=term2_in[4]
+ B=term2_in[3]
Xsll_17/M1_0_5 MUX2 $PINS O=sll_17/ML_int[1][5] S=FE_OFN111_h22_0 A=term2_in[5]
+ B=term2_in[4]
Xsll_17/M1_0_6 MUX2 $PINS O=sll_17/ML_int[1][6] S=FE_OFN111_h22_0 A=term2_in[6]
+ B=term2_in[5]
Xsll_17/M1_0_7 MUX2 $PINS O=sll_17/ML_int[1][7] S=FE_OFN111_h22_0 A=term2_in[7]
+ B=term2_in[6]
Xsll_17/M1_1_4 MUX2 $PINS O=sll_17/ML_int[2][4] S=FE_OFN110_h22_1
+ A=sll_17/ML_int[1][4] B=sll_17/ML_int[1][2]
Xsll_17/M1_2_5 MUX2 $PINS O=sll_17/ML_int[3][5] S=FE_RN_2 A=sll_17/ML_int[2][5]
+ B=n8
Xsll_17/M1_2_6 MUX2 $PINS O=sll_17/ML_int[3][6] S=FE_RN_2 A=sll_17/ML_int[2][6]
+ B=FE_OCPN1208_sll_17_ML_int_2_2
Xsll_17/M1_2_7 MUX2 $PINS O=sll_17/ML_int[3][7] S=FE_RN_2 A=sll_17/ML_int[2][7]
+ B=sll_17/ML_int[2][3]
Xsll_17/M1_2_8 MUX2 $PINS O=sll_17/ML_int[3][8] S=FE_RN_2 A=sll_17/ML_int[2][8]
+ B=sll_17/ML_int[2][4]
Xsll_17/M1_2_9 MUX2 $PINS O=sll_17/ML_int[3][9] S=FE_RN_2 A=sll_17/ML_int[2][9]
+ B=sll_17/ML_int[2][5]
Xsll_17/M1_2_10 MUX2 $PINS O=sll_17/ML_int[3][10] S=FE_RN_2
+ A=sll_17/ML_int[2][10] B=sll_17/ML_int[2][6]
Xsll_17/M1_3_8 MUX2 $PINS O=term2_shifted[8] S=n28 A=sll_17/ML_int[3][8]
+ B=sll_17/ML_int[3][0]
Xsll_17/M1_3_9 MUX2 $PINS O=term2_shifted[9] S=n28 A=sll_17/ML_int[3][9]
+ B=sll_17/ML_int[3][1]
Xsll_17/M1_3_10 MUX2 $PINS O=term2_shifted[10] S=n28 A=sll_17/ML_int[3][10]
+ B=sll_17/ML_int[3][2]
Xsll_17/M1_3_11 MUX2 $PINS O=term2_shifted[11] S=n28 A=sll_17/ML_int[3][11]
+ B=sll_17/ML_int[3][3]
Xsll_17/M1_3_12 MUX2 $PINS O=term2_shifted[12] S=n28 A=sll_17/ML_int[3][12]
+ B=sll_17/ML_int[3][4]
Xsll_17/M1_3_13 MUX2 $PINS O=term2_shifted[13] S=n28 A=sll_17/ML_int[3][13]
+ B=sll_17/ML_int[3][5]
Xsll_17/M1_3_14 MUX2 $PINS O=term2_shifted[14] S=n28 A=sll_17/ML_int[3][14]
+ B=sll_17/ML_int[3][6]
Xsll_17/M1_3_23 MUX2 $PINS O=term2_shifted[23] S=n28 A=term2_in[26]
+ B=sll_17/ML_int[3][15]
Xsll_16/M1_0_6 MUX2 $PINS O=sll_16/ML_int[1][6] S=FE_OFN105_h21_0 A=term1_in[6]
+ B=term1_in[5]
Xsll_16/M1_0_7 MUX2 $PINS O=sll_16/ML_int[1][7] S=FE_OFN105_h21_0 A=term1_in[7]
+ B=term1_in[6]
Xsll_16/M1_0_8 MUX2 $PINS O=sll_16/ML_int[1][8] S=FE_OFN105_h21_0 A=term1_in[8]
+ B=term1_in[7]
Xsll_16/M1_1_3 MUX2 $PINS O=sll_16/ML_int[2][3] S=shf1[1] A=sll_16/ML_int[1][3]
+ B=sll_16/ML_int[1][1]
Xsll_16/M1_1_4 MUX2 $PINS O=sll_16/ML_int[2][4] S=shf1[1] A=sll_16/ML_int[1][4]
+ B=sll_16/ML_int[1][2]
Xsll_16/M1_1_5 MUX2 $PINS O=sll_16/ML_int[2][5] S=shf1[1] A=sll_16/ML_int[1][5]
+ B=sll_16/ML_int[1][3]
Xsll_16/M1_1_6 MUX2 $PINS O=sll_16/ML_int[2][6] S=shf1[1] A=sll_16/ML_int[1][6]
+ B=sll_16/ML_int[1][4]
Xsll_16/M1_1_7 MUX2 $PINS O=sll_16/ML_int[2][7] S=shf1[1] A=sll_16/ML_int[1][7]
+ B=sll_16/ML_int[1][5]
Xsll_16/M1_1_8 MUX2 $PINS O=sll_16/ML_int[2][8] S=shf1[1] A=sll_16/ML_int[1][8]
+ B=sll_16/ML_int[1][6]
Xsll_16/M1_1_9 MUX2 $PINS O=sll_16/ML_int[2][9] S=shf1[1] A=sll_16/ML_int[1][9]
+ B=sll_16/ML_int[1][7]
Xsll_16/M1_2_5 MUX2 $PINS O=sll_16/ML_int[3][5] S=FE_OFN103_h21_2
+ A=sll_16/ML_int[2][5] B=n54
Xsll_16/M1_2_6 MUX2 $PINS O=sll_16/ML_int[3][6] S=FE_OFN103_h21_2
+ A=sll_16/ML_int[2][6] B=sll_16/ML_int[2][2]
Xsll_16/M1_2_7 MUX2 $PINS O=sll_16/ML_int[3][7] S=FE_OFN103_h21_2
+ A=sll_16/ML_int[2][7] B=sll_16/ML_int[2][3]
Xsll_16/M1_2_8 MUX2 $PINS O=sll_16/ML_int[3][8] S=FE_OFN103_h21_2
+ A=sll_16/ML_int[2][8] B=sll_16/ML_int[2][4]
Xsll_16/M1_2_9 MUX2 $PINS O=sll_16/ML_int[3][9] S=FE_OFN103_h21_2
+ A=sll_16/ML_int[2][9] B=sll_16/ML_int[2][5]
Xsll_16/M1_2_10 MUX2 $PINS O=sll_16/ML_int[3][10] S=FE_OFN103_h21_2
+ A=sll_16/ML_int[2][10] B=sll_16/ML_int[2][6]
Xsll_16/M1_2_11 MUX2 $PINS O=sll_16/ML_int[3][11] S=FE_OFN103_h21_2
+ A=sll_16/ML_int[2][11] B=sll_16/ML_int[2][7]
Xsll_16/M1_3_8 MUX2 $PINS O=term1_shifted[8] S=shf1[3] A=sll_16/ML_int[3][8]
+ B=sll_16/ML_int[3][0]
Xsll_16/M1_3_9 MUX2 $PINS O=term1_shifted[9] S=shf1[3] A=sll_16/ML_int[3][9]
+ B=sll_16/ML_int[3][1]
Xsll_16/M1_3_10 MUX2 $PINS O=term1_shifted[10] S=shf1[3] A=sll_16/ML_int[3][10]
+ B=sll_16/ML_int[3][2]
Xsll_16/M1_3_11 MUX2 $PINS O=term1_shifted[11] S=shf1[3] A=sll_16/ML_int[3][11]
+ B=sll_16/ML_int[3][3]
Xsll_16/M1_3_12 MUX2 $PINS O=term1_shifted[12] S=shf1[3] A=sll_16/ML_int[3][12]
+ B=sll_16/ML_int[3][4]
Xsll_16/M1_3_13 MUX2 $PINS O=term1_shifted[13] S=shf1[3] A=sll_16/ML_int[3][13]
+ B=sll_16/ML_int[3][5]
Xsll_16/M1_3_14 MUX2 $PINS O=term1_shifted[14] S=shf1[3] A=sll_16/ML_int[3][14]
+ B=sll_16/ML_int[3][6]
Xsll_16/M1_3_15 MUX2 $PINS O=term1_shifted[15] S=shf1[3] A=sll_16/ML_int[3][15]
+ B=sll_16/ML_int[3][7]
Xsll_16/M1_3_23 MUX2 $PINS O=term1_shifted[23] S=FE_OFN102_h21_3 A=term1_in[26]
+ B=sll_16/ML_int[3][15]
Xy_out_reg[9] QDFFRBN $PINS Q=y_out[9] D=N244 CK=net2250 RB=FE_OFN33_i_rst_n
Xy_out_reg[8] QDFFRBN $PINS Q=y_out[8] D=FE_PHN1412_N243 CK=net2250
+ RB=FE_OFN33_i_rst_n
Xy_out_reg[7] QDFFRBN $PINS Q=y_out[7] D=FE_PHN1462_N242 CK=net2250
+ RB=FE_OFN33_i_rst_n
Xy_out_reg[6] QDFFRBN $PINS Q=y_out[6] D=FE_PHN1428_N241 CK=net2250
+ RB=FE_OFN33_i_rst_n
Xy_out_reg[5] QDFFRBN $PINS Q=y_out[5] D=FE_PHN1486_N240 CK=net2250
+ RB=FE_OFN33_i_rst_n
Xy_out_reg[4] QDFFRBN $PINS Q=FE_PHN2171_pe_i2_4 D=FE_PHN1481_N239 CK=net2250
+ RB=FE_OFN33_i_rst_n
Xy_out_reg[3] QDFFRBN $PINS Q=y_out[3] D=N238 CK=net2250 RB=FE_OFN33_i_rst_n
Xy_out_reg[2] QDFFRBN $PINS Q=FE_PHN1248_pe_i2_2 D=FE_PHN1480_N237 CK=net2250
+ RB=FE_OFN17_i_rst_n
Xy_out_reg[1] QDFFRBN $PINS Q=FE_PHN1246_pe_i2_1 D=FE_PHN1472_N236 CK=net2250
+ RB=FE_OFN17_i_rst_n
Xy_out_reg[0] QDFFRBN $PINS Q=FE_PHN2240_pe_i2_0 D=N235 CK=net2250
+ RB=FE_OFN33_i_rst_n
Xy_out_reg[16] QDFFRBN $PINS Q=y_out[16] D=FE_PHN1479_N251 CK=net2250
+ RB=FE_OFN33_i_rst_n
Xy_out_reg[10] QDFFRBN $PINS Q=FE_PHN1635_pe_i2_10 D=FE_PHN1499_N245 CK=net2250
+ RB=FE_OFN33_i_rst_n
Xy_out_reg[11] QDFFRBN $PINS Q=FE_PHN1702_pe_i2_11 D=FE_PHN1443_N246 CK=net2250
+ RB=FE_OFN33_i_rst_n
Xy_out_reg[12] QDFFRBN $PINS Q=FE_PHN1713_pe_i2_12 D=N247 CK=net2250
+ RB=FE_OFN33_i_rst_n
Xy_out_reg[14] QDFFRBN $PINS Q=y_out[14] D=N249 CK=net2250 RB=FE_OFN33_i_rst_n
Xy_out_reg[15] QDFFRBN $PINS Q=FE_PHN1716_pe_i2_15 D=FE_PHN1845_N250 CK=net2250
+ RB=FE_OFN33_i_rst_n
Xy_out_reg[13] QDFFRBN $PINS Q=FE_PHN1707_pe_i2_13 D=FE_PHN1849_N248 CK=net2250
+ RB=FE_OFN33_i_rst_n
Xacc_reg_reg[25] QDFFRBN $PINS Q=acc_reg[25] D=next_acc[25] CK=clk_clone1
+ RB=FE_OFN33_i_rst_n
Xacc_reg_reg[24] QDFFRBN $PINS Q=acc_reg[24] D=next_acc[24] CK=clk_clone1
+ RB=FE_OFN33_i_rst_n
Xacc_reg_reg[23] QDFFRBN $PINS Q=acc_reg[23] D=next_acc[23] CK=clk_clone1
+ RB=FE_OFN33_i_rst_n
Xacc_reg_reg[22] QDFFRBN $PINS Q=acc_reg[22] D=next_acc[22] CK=clk_clone1
+ RB=FE_OFN33_i_rst_n
Xacc_reg_reg[21] QDFFRBN $PINS Q=acc_reg[21] D=next_acc[21] CK=clk_clone1
+ RB=FE_OFN17_i_rst_n
Xacc_reg_reg[20] QDFFRBN $PINS Q=acc_reg[20] D=next_acc[20] CK=clk_clone1
+ RB=FE_OFN17_i_rst_n
Xacc_reg_reg[19] QDFFRBN $PINS Q=acc_reg[19] D=next_acc[19] CK=clk_clone1
+ RB=FE_OFN17_i_rst_n
Xacc_reg_reg[18] QDFFRBN $PINS Q=acc_reg[18] D=next_acc[18] CK=clk_clone1
+ RB=FE_OFN17_i_rst_n
Xacc_reg_reg[17] QDFFRBN $PINS Q=acc_reg[17] D=next_acc[17] CK=clk_clone1
+ RB=FE_OFN17_i_rst_n
Xacc_reg_reg[16] QDFFRBN $PINS Q=acc_reg[16] D=next_acc[16] CK=clk_clone1
+ RB=FE_OFN17_i_rst_n
Xacc_reg_reg[15] QDFFRBN $PINS Q=acc_reg[15] D=next_acc[15] CK=clk_clone1
+ RB=FE_OFN17_i_rst_n
Xacc_reg_reg[14] QDFFRBN $PINS Q=acc_reg[14] D=next_acc[14] CK=clk_clone1
+ RB=FE_OFN17_i_rst_n
Xacc_reg_reg[13] QDFFRBN $PINS Q=acc_reg[13] D=next_acc[13] CK=clk_clone1
+ RB=FE_OFN17_i_rst_n
Xacc_reg_reg[12] QDFFRBN $PINS Q=acc_reg[12] D=next_acc[12] CK=clk_clone1
+ RB=FE_OFN17_i_rst_n
Xacc_reg_reg[11] QDFFRBN $PINS Q=acc_reg[11] D=next_acc[11] CK=clk_clone1
+ RB=FE_OFN17_i_rst_n
Xacc_reg_reg[10] QDFFRBN $PINS Q=acc_reg[10] D=next_acc[10] CK=clk_clone1
+ RB=FE_OFN17_i_rst_n
Xacc_reg_reg[9] QDFFRBN $PINS Q=acc_reg[9] D=next_acc[9] CK=clk_clone1
+ RB=FE_OFN17_i_rst_n
Xacc_reg_reg[8] QDFFRBN $PINS Q=acc_reg[8] D=next_acc[8] CK=clk_clone1
+ RB=FE_OFN17_i_rst_n
Xacc_reg_reg[7] QDFFRBN $PINS Q=acc_reg[7] D=next_acc[7] CK=clk_clone1
+ RB=FE_OFN17_i_rst_n
Xacc_reg_reg[6] QDFFRBN $PINS Q=acc_reg[6] D=next_acc[6] CK=clk_clone1
+ RB=FE_OFN17_i_rst_n
Xacc_reg_reg[5] QDFFRBN $PINS Q=acc_reg[5] D=next_acc[5] CK=clk_clone1
+ RB=i_rst_n
Xacc_reg_reg[4] QDFFRBN $PINS Q=acc_reg[4] D=next_acc[4] CK=clk_clone1
+ RB=i_rst_n
Xacc_reg_reg[3] QDFFRBN $PINS Q=acc_reg[3] D=next_acc[3] CK=clk_clone1
+ RB=i_rst_n
Xacc_reg_reg[2] QDFFRBN $PINS Q=acc_reg[2] D=next_acc[2] CK=clk_clone1
+ RB=i_rst_n
Xacc_reg_reg[1] QDFFRBN $PINS Q=acc_reg[1] D=next_acc[1] CK=clk_clone1
+ RB=FE_OFN17_i_rst_n
Xacc_reg_reg[0] QDFFRBS $PINS Q=acc_reg[0] D=next_acc[0] CK=clk_clone1
+ RB=FE_OFN17_i_rst_n
Xacc_reg_reg[26] QDFFRBS $PINS Q=N251 D=next_acc[26] CK=clk_clone1
+ RB=FE_OFN10_i_rst_n
XU3 NR2 $PINS O=term2_shifted[0] I1=n4 I2=n2
XU6 INV2 $PINS O=n72 I=sll_18/ML_int[2][2]
XU9 NR2F $PINS O=term1_shifted[1] I1=n50 I2=n49
XU10 ND2P $PINS O=n49 I1=sll_16/ML_int[1][1] I2=n36
XU14 NR2P $PINS O=term1_in[3] I1=sign1[1] I2=x_in[3]
XU20 NR2P $PINS O=term3_shifted[2] I1=n70 I2=n72
XU21 MUX2 $PINS O=N248 S=FE_OFN57_FE_DBTN9_n336 A=acc_reg[23] B=FE_PHN1479_N251
XU22 MUX2 $PINS O=N250 S=stage_sel A=acc_reg[25] B=FE_PHN1479_N251
XU23 MUX2 $PINS O=FE_PHN1843_N249 S=FE_OFN59_FE_DBTN9_n336 A=acc_reg[24]
+ B=FE_PHN1479_N251
XU24 NR2T $PINS O=term2_in[0] I1=FE_OFN106_s22_1 I2=x_in[0]
XU25 MUX2 $PINS O=FE_PHN1835_N247 S=stage_sel A=acc_reg[22] B=FE_PHN1479_N251
XU26 AN2 $PINS O=sll_16/ML_int[1][0] I1=term1_in[0] I2=n34
XU28 ND2P $PINS O=n68 I1=sll_18/ML_int[1][0] I2=n14
XU29 NR2P $PINS O=term1_shifted[0] I1=n50 I2=n48
XU30 NR2T $PINS O=term3_shifted[1] I1=n70 I2=n69
XU31 AN2 $PINS O=base_val[5] I1=acc_reg[5] I2=n96
XU32 NR2 $PINS O=term2_in[2] I1=FE_OFN106_s22_1 I2=x_in[2]
XU34 ND2P $PINS O=n69 I1=sll_18/ML_int[1][1] I2=n14
XU35 MUX2S $PINS O=sll_18/ML_int[3][6] S=FE_OFN277_h23_2 A=sll_18/ML_int[2][6]
+ B=sll_18/ML_int[2][2]
XU37 MUX2 $PINS O=sll_16/ML_int[1][5] S=FE_OFN105_h21_0 A=term1_in[5]
+ B=term1_in[4]
XU38 INV2 $PINS O=n62 I=sll_17/ML_int[2][3]
XU39 INV2 $PINS O=n51 I=sll_16/ML_int[2][3]
XU50 NR2 $PINS O=term2_in[5] I1=FE_OFN106_s22_1 I2=x_in[5]
XU51 NR2P $PINS O=term1_in[0] I1=sign1[1] I2=x_in[0]
XU57 NR2 $PINS O=term1_shifted[3] I1=n50 I2=n51
XU58 NR2P $PINS O=term2_shifted[3] I1=n61 I2=n62
XU60 MUX2S $PINS O=sll_17/ML_int[2][8] S=FE_RN_5 A=sll_17/ML_int[1][8]
+ B=sll_17/ML_int[1][6]
XU61 MUX2S $PINS O=sll_17/ML_int[2][7] S=FE_OFN110_h22_1 A=sll_17/ML_int[1][7]
+ B=sll_17/ML_int[1][5]
XU62 MUX2S $PINS O=sll_17/ML_int[2][6] S=FE_OFN110_h22_1 A=sll_17/ML_int[1][6]
+ B=sll_17/ML_int[1][4]
XU63 MUX2S $PINS O=sll_17/ML_int[2][5] S=FE_OFN110_h22_1 A=sll_17/ML_int[1][5]
+ B=sll_17/ML_int[1][3]
XU64 OR2S $PINS O=n7 I1=n61 I2=FE_OFN110_h22_1
XU65 OR2S $PINS O=n4 I1=n61 I2=FE_OFN110_h22_1
XU67 NR2P $PINS O=term3_shifted[0] I1=n70 I2=n68
XU69 AN2 $PINS O=sll_17/ML_int[1][0] I1=term2_in[0] I2=n24
XU70 NR2 $PINS O=term1_in[2] I1=sign1[1] I2=x_in[2]
XU71 NR2P $PINS O=term2_in[4] I1=FE_OFN106_s22_1 I2=x_in[4]
XU72 AN2T $PINS O=sll_18/ML_int[1][0] I1=term3_in[0] I2=n13
XU74 INV1S $PINS O=n60 I=n8
XU75 AO22 $PINS O=N108 A1=N81 A2=FE_OFN384_s22_0 B1=term2_shifted[12]
+ B2=FE_DBTN22_s22_0
XU76 AN2 $PINS O=base_val[12] I1=acc_reg[12] I2=n96
XU77 AO22 $PINS O=N162 A1=N135 A2=FE_OFN406_s23_0 B1=term3_shifted[11]
+ B2=FE_OFN405_s23_0
XU78 AO22 $PINS O=N164 A1=N137 A2=FE_OFN409_s23_0 B1=term3_shifted[13]
+ B2=FE_OFN405_s23_0
XU89 INV1S $PINS O=n13 I=shf3[0]
XU90 ND2 $PINS O=n2 I1=term2_in[0] I2=n24
XU92 NR2P $PINS O=term2_in[1] I1=FE_OFN106_s22_1 I2=x_in[1]
XU95 INV1S $PINS O=n59 I=n5
XU96 NR2 $PINS O=n5 I1=FE_OFN110_h22_1 I2=n2
XU98 NR2 $PINS O=n8 I1=n6 I2=FE_OFN110_h22_1
XU99 AO22S $PINS O=N121 A1=N94 A2=FE_OFN385_s22_0 B1=term2_shifted[25]
+ B2=FE_RN_3
XU100 AO22 $PINS O=N52 A1=N25 A2=FE_OFN310_s21_0 B1=term1_shifted[11] B2=n43
XU101 AO22 $PINS O=N54 A1=N27 A2=FE_OFN310_s21_0 B1=term1_shifted[13] B2=n43
XU102 AO22 $PINS O=N57 A1=N30 A2=sign1[0] B1=term1_shifted[16] B2=FE_OFN392_n
XU103 AO22S $PINS O=N167 A1=N140 A2=FE_OFN409_s23_0 B1=term3_shifted[16] B2=n21
XU105 MUX2 $PINS O=sll_17/ML_int[1][3] S=FE_OFN111_h22_0 A=term2_in[3]
+ B=term2_in[2]
XU107 MUX2 $PINS O=sll_18/ML_int[1][3] S=shf3[0] A=term3_in[3] B=term3_in[2]
XU109 NR2 $PINS O=n9 I1=FE_OFN112_s23_1 I2=x_in[4]
XU111 INV1S $PINS O=n73 I=n68
XU112 INV1S $PINS O=n74 I=FE_OCPN1140_n69
XU113 AN2 $PINS O=base_val[0] I1=acc_reg[0] I2=n96
XU114 MUX2S $PINS O=sll_17/ML_int[1][8] S=FE_OFN111_h22_0 A=term2_in[8]
+ B=term2_in[7]
XU125 MUX2S $PINS O=sll_18/ML_int[1][8] S=FE_OFN484_h23_0 A=term3_in[8]
+ B=term3_in[7]
XU128 MUX2S $PINS O=sll_17/ML_int[2][9] S=FE_RN_5 A=sll_17/ML_int[1][9]
+ B=sll_17/ML_int[1][7]
XU130 MUX2S $PINS O=sll_18/ML_int[2][9] S=FE_OFN488_FE_OFN347_h23_1
+ A=sll_18/ML_int[1][9] B=sll_18/ML_int[1][7]
XU139 MUX2S $PINS O=sll_17/ML_int[1][9] S=FE_OFN111_h22_0 A=term2_in[9]
+ B=term2_in[8]
XU140 MUX2S $PINS O=sll_18/ML_int[1][9] S=FE_OFN484_h23_0 A=term3_in[9]
+ B=term3_in[8]
XU141 MUX2S $PINS O=sll_16/ML_int[1][9] S=FE_OFN105_h21_0 A=term1_in[9]
+ B=term1_in[8]
XU152 MUX2S $PINS O=sll_16/ML_int[2][10] S=FE_OFN335_h21_1
+ A=sll_16/ML_int[1][10] B=sll_16/ML_int[1][8]
XU155 MUX2S $PINS O=sll_16/ML_int[1][10] S=FE_OFN105_h21_0 A=term1_in[10]
+ B=term1_in[9]
XU157 MUX2S $PINS O=sll_18/ML_int[2][10] S=FE_OFN488_FE_OFN347_h23_1
+ A=sll_18/ML_int[1][10] B=sll_18/ML_int[1][8]
XU159 MUX2S $PINS O=sll_18/ML_int[1][10] S=FE_OFN484_h23_0 A=term3_in[10]
+ B=term3_in[9]
XU160 MUX2S $PINS O=sll_17/ML_int[2][10] S=FE_RN_5 A=sll_17/ML_int[1][10]
+ B=sll_17/ML_int[1][8]
XU165 MUX2S $PINS O=sll_17/ML_int[1][10] S=FE_OFN111_h22_0 A=term2_in[10]
+ B=term2_in[9]
XU166 MUX2S $PINS O=sll_16/ML_int[2][11] S=FE_OFN336_h21_1
+ A=sll_16/ML_int[1][11] B=sll_16/ML_int[1][9]
XU167 MUX2S $PINS O=sll_16/ML_int[1][11] S=FE_OFN105_h21_0 A=term1_in[11]
+ B=term1_in[10]
XU168 MUX2S $PINS O=sll_18/ML_int[3][11] S=FE_OFN277_h23_2
+ A=sll_18/ML_int[2][11] B=sll_18/ML_int[2][7]
XU170 MUX2 $PINS O=sll_18/ML_int[2][11] S=FE_OFN488_FE_OFN347_h23_1
+ A=sll_18/ML_int[1][11] B=sll_18/ML_int[1][9]
XU182 MUX2 $PINS O=sll_18/ML_int[1][11] S=FE_OFN484_h23_0 A=term3_in[11]
+ B=term3_in[10]
XU183 MUX2S $PINS O=sll_17/ML_int[3][11] S=FE_RN_2 A=sll_17/ML_int[2][11]
+ B=sll_17/ML_int[2][7]
XU191 MUX2S $PINS O=sll_17/ML_int[2][11] S=FE_RN_5 A=sll_17/ML_int[1][11]
+ B=sll_17/ML_int[1][9]
XU192 MUX2S $PINS O=sll_17/ML_int[1][11] S=FE_OFN111_h22_0 A=term2_in[11]
+ B=term2_in[10]
XU193 MUX2S $PINS O=sll_16/ML_int[3][12] S=FE_OFN103_h21_2
+ A=sll_16/ML_int[2][12] B=sll_16/ML_int[2][8]
XU194 MUX2S $PINS O=sll_16/ML_int[2][12] S=FE_OFN335_h21_1
+ A=sll_16/ML_int[1][12] B=sll_16/ML_int[1][10]
XU195 MUX2S $PINS O=sll_16/ML_int[1][12] S=FE_OFN105_h21_0 A=term1_in[12]
+ B=term1_in[11]
XU196 MUX2S $PINS O=sll_18/ML_int[3][12] S=FE_OFN138_h23_2
+ A=sll_18/ML_int[2][12] B=sll_18/ML_int[2][8]
XU197 MUX2S $PINS O=sll_18/ML_int[2][12] S=shf3[1] A=sll_18/ML_int[1][12]
+ B=sll_18/ML_int[1][10]
XU198 MUX2S $PINS O=sll_18/ML_int[1][12] S=FE_OFN484_h23_0 A=term3_in[12]
+ B=term3_in[11]
XU199 MUX2S $PINS O=sll_17/ML_int[3][12] S=FE_RN_2 A=sll_17/ML_int[2][12]
+ B=sll_17/ML_int[2][8]
XU200 MUX2S $PINS O=sll_17/ML_int[2][12] S=FE_RN_5 A=sll_17/ML_int[1][12]
+ B=sll_17/ML_int[1][10]
XU201 MUX2S $PINS O=sll_17/ML_int[1][12] S=FE_OFN111_h22_0 A=term2_in[12]
+ B=term2_in[11]
XU202 MUX2S $PINS O=sll_16/ML_int[3][13] S=FE_OFN103_h21_2
+ A=sll_16/ML_int[2][13] B=sll_16/ML_int[2][9]
XU203 MUX2S $PINS O=sll_16/ML_int[2][13] S=FE_OFN335_h21_1
+ A=sll_16/ML_int[1][13] B=sll_16/ML_int[1][11]
XU204 MUX2S $PINS O=sll_16/ML_int[1][13] S=FE_OFN105_h21_0 A=term1_in[13]
+ B=term1_in[12]
XU205 MUX2S $PINS O=sll_18/ML_int[3][13] S=FE_OFN138_h23_2
+ A=sll_18/ML_int[2][13] B=sll_18/ML_int[2][9]
XU206 MUX2S $PINS O=sll_18/ML_int[2][13] S=shf3[1] A=sll_18/ML_int[1][13]
+ B=sll_18/ML_int[1][11]
XU207 MUX2S $PINS O=sll_18/ML_int[1][13] S=FE_OFN484_h23_0 A=term3_in[13]
+ B=term3_in[12]
XU208 MUX2S $PINS O=sll_17/ML_int[3][13] S=FE_RN_2 A=sll_17/ML_int[2][13]
+ B=sll_17/ML_int[2][9]
XU209 MUX2S $PINS O=sll_17/ML_int[2][13] S=FE_RN_5 A=sll_17/ML_int[1][13]
+ B=sll_17/ML_int[1][11]
XU210 MUX2S $PINS O=sll_17/ML_int[1][13] S=FE_OFN111_h22_0 A=term2_in[13]
+ B=term2_in[12]
XU211 MUX2S $PINS O=sll_16/ML_int[2][14] S=shf1[1] A=sll_16/ML_int[1][14]
+ B=sll_16/ML_int[1][12]
XU212 MUX2S $PINS O=sll_16/ML_int[1][14] S=FE_OFN105_h21_0 A=term1_in[14]
+ B=term1_in[13]
XU213 MUX2S $PINS O=sll_16/ML_int[3][14] S=FE_OFN103_h21_2
+ A=sll_16/ML_int[2][14] B=sll_16/ML_int[2][10]
XU214 MUX2S $PINS O=sll_18/ML_int[3][14] S=FE_OFN138_h23_2
+ A=sll_18/ML_int[2][14] B=sll_18/ML_int[2][10]
XU215 MUX2S $PINS O=sll_18/ML_int[2][14] S=FE_OFN487_FE_OFN347_h23_1
+ A=sll_18/ML_int[1][14] B=sll_18/ML_int[1][12]
XU216 MUX2S $PINS O=sll_18/ML_int[1][14] S=FE_OFN484_h23_0 A=term3_in[14]
+ B=term3_in[13]
XU217 MUX2S $PINS O=sll_17/ML_int[3][14] S=FE_RN_2 A=sll_17/ML_int[2][14]
+ B=sll_17/ML_int[2][10]
XU218 MUX2S $PINS O=sll_17/ML_int[2][14] S=FE_RN_5 A=sll_17/ML_int[1][14]
+ B=sll_17/ML_int[1][12]
XU219 MUX2S $PINS O=sll_17/ML_int[1][14] S=FE_OFN111_h22_0 A=term2_in[14]
+ B=term2_in[13]
XU220 MUX2S $PINS O=term1_shifted[16] S=shf1[3] A=sll_16/ML_int[3][16]
+ B=sll_16/ML_int[3][8]
XU221 MUX2S $PINS O=sll_16/ML_int[3][16] S=FE_OFN103_h21_2 A=n55
+ B=sll_16/ML_int[2][12]
XU222 MUX2S $PINS O=n55 S=shf1[1] A=n58 B=sll_16/ML_int[1][14]
XU223 MUX2S $PINS O=term3_shifted[16] S=n18 A=sll_18/ML_int[3][16]
+ B=sll_18/ML_int[3][8]
XU224 MUX2S $PINS O=sll_18/ML_int[3][16] S=FE_OFN138_h23_2 A=n75
+ B=sll_18/ML_int[2][12]
XU225 MUX2S $PINS O=n75 S=FE_OFN487_FE_OFN347_h23_1 A=n78
+ B=sll_18/ML_int[1][14]
XU226 MUX2S $PINS O=term2_shifted[16] S=n28 A=sll_17/ML_int[3][16]
+ B=sll_17/ML_int[3][8]
XU227 MUX2S $PINS O=sll_17/ML_int[3][16] S=FE_RN_2 A=n64 B=sll_17/ML_int[2][12]
XU228 MUX2S $PINS O=n64 S=FE_RN_5 A=n67 B=sll_17/ML_int[1][14]
XU229 MUX2S $PINS O=sll_16/ML_int[3][15] S=FE_OFN103_h21_2
+ A=sll_16/ML_int[2][15] B=sll_16/ML_int[2][11]
XU230 MUX2S $PINS O=sll_16/ML_int[2][15] S=shf1[1] A=sll_16/ML_int[1][15]
+ B=sll_16/ML_int[1][13]
XU231 MUX2S $PINS O=sll_16/ML_int[1][15] S=FE_OFN105_h21_0 A=term1_in[15]
+ B=term1_in[14]
XU232 MUX2S $PINS O=term3_shifted[15] S=n18 A=sll_18/ML_int[3][15]
+ B=sll_18/ML_int[3][7]
XU233 MUX2S $PINS O=sll_18/ML_int[3][15] S=FE_OFN138_h23_2
+ A=sll_18/ML_int[2][15] B=sll_18/ML_int[2][11]
XU234 MUX2S $PINS O=sll_18/ML_int[2][15] S=FE_OFN487_FE_OFN347_h23_1
+ A=sll_18/ML_int[1][15] B=sll_18/ML_int[1][13]
XU235 MUX2S $PINS O=sll_18/ML_int[1][15] S=FE_OFN484_h23_0 A=term3_in[15]
+ B=term3_in[14]
XU236 MUX2S $PINS O=term2_shifted[15] S=n28 A=sll_17/ML_int[3][15]
+ B=sll_17/ML_int[3][7]
XU237 MUX2S $PINS O=sll_17/ML_int[3][15] S=FE_RN_2 A=sll_17/ML_int[2][15]
+ B=sll_17/ML_int[2][11]
XU238 MUX2S $PINS O=sll_17/ML_int[2][15] S=FE_RN_5 A=sll_17/ML_int[1][15]
+ B=sll_17/ML_int[1][13]
XU239 MUX2S $PINS O=sll_17/ML_int[1][15] S=FE_OFN111_h22_0 A=term2_in[15]
+ B=term2_in[14]
XU240 MUX2S $PINS O=term1_shifted[17] S=shf1[3] A=sll_16/ML_int[3][17]
+ B=sll_16/ML_int[3][9]
XU241 MUX2S $PINS O=sll_16/ML_int[3][17] S=FE_OFN103_h21_2 A=n56
+ B=sll_16/ML_int[2][13]
XU242 MUX2S $PINS O=term3_shifted[17] S=n18 A=sll_18/ML_int[3][17]
+ B=sll_18/ML_int[3][9]
XU243 MUX2S $PINS O=sll_18/ML_int[3][17] S=FE_OFN138_h23_2 A=n76
+ B=sll_18/ML_int[2][13]
XU244 MUX2S $PINS O=term2_shifted[17] S=n28 A=sll_17/ML_int[3][17]
+ B=sll_17/ML_int[3][9]
XU245 MUX2S $PINS O=sll_17/ML_int[3][17] S=FE_RN_2 A=n65 B=sll_17/ML_int[2][13]
XU246 MUX2S $PINS O=term1_shifted[18] S=shf1[3] A=sll_16/ML_int[3][18]
+ B=sll_16/ML_int[3][10]
XU247 MUX2S $PINS O=sll_16/ML_int[3][18] S=FE_OFN103_h21_2 A=n57
+ B=sll_16/ML_int[2][14]
XU248 MUX2S $PINS O=term3_shifted[18] S=n18 A=sll_18/ML_int[3][18]
+ B=sll_18/ML_int[3][10]
XU249 MUX2S $PINS O=sll_18/ML_int[3][18] S=FE_OFN138_h23_2 A=n77
+ B=sll_18/ML_int[2][14]
XU250 MUX2S $PINS O=term2_shifted[18] S=n28 A=sll_17/ML_int[3][18]
+ B=sll_17/ML_int[3][10]
XU251 MUX2S $PINS O=sll_17/ML_int[3][18] S=FE_RN_2 A=n66 B=sll_17/ML_int[2][14]
XU252 MUX2S $PINS O=term1_shifted[20] S=shf1[3] A=sll_16/ML_int[3][20]
+ B=sll_16/ML_int[3][12]
XU253 MUX2S $PINS O=sll_16/ML_int[3][20] S=FE_OFN103_h21_2 A=term1_in[26] B=n55
XU254 MUX2S $PINS O=term1_shifted[19] S=shf1[3] A=sll_16/ML_int[3][19]
+ B=sll_16/ML_int[3][11]
XU255 MUX2S $PINS O=sll_16/ML_int[3][19] S=FE_OFN103_h21_2 A=term1_in[26]
+ B=sll_16/ML_int[2][15]
XU256 MUX2S $PINS O=term3_shifted[20] S=FE_OFN142_h23_3 A=sll_18/ML_int[3][20]
+ B=sll_18/ML_int[3][12]
XU257 MUX2S $PINS O=sll_18/ML_int[3][20] S=FE_OFN138_h23_2 A=term3_in[26] B=n75
XU258 MUX2S $PINS O=term3_shifted[19] S=FE_OFN142_h23_3 A=sll_18/ML_int[3][19]
+ B=sll_18/ML_int[3][11]
XU259 MUX2S $PINS O=sll_18/ML_int[3][19] S=FE_OFN138_h23_2 A=term3_in[26]
+ B=sll_18/ML_int[2][15]
XU260 MUX2S $PINS O=term2_shifted[20] S=n28 A=sll_17/ML_int[3][20]
+ B=sll_17/ML_int[3][12]
XU261 MUX2S $PINS O=sll_17/ML_int[3][20] S=FE_RN_2 A=term2_in[26] B=n64
XU262 MUX2S $PINS O=term2_shifted[19] S=n28 A=sll_17/ML_int[3][19]
+ B=sll_17/ML_int[3][11]
XU263 MUX2S $PINS O=sll_17/ML_int[3][19] S=FE_RN_2 A=term2_in[26]
+ B=sll_17/ML_int[2][15]
XU264 MUX2S $PINS O=term1_shifted[21] S=shf1[3] A=sll_16/ML_int[3][21]
+ B=sll_16/ML_int[3][13]
XU265 MUX2S $PINS O=sll_16/ML_int[3][21] S=FE_OFN103_h21_2 A=term1_in[26] B=n56
XU266 MUX2S $PINS O=term3_shifted[21] S=FE_OFN142_h23_3 A=sll_18/ML_int[3][21]
+ B=sll_18/ML_int[3][13]
XU267 MUX2S $PINS O=sll_18/ML_int[3][21] S=FE_OFN138_h23_2 A=term3_in[26] B=n76
XU268 MUX2S $PINS O=term2_shifted[21] S=n28 A=sll_17/ML_int[3][21]
+ B=sll_17/ML_int[3][13]
XU269 MUX2S $PINS O=sll_17/ML_int[3][21] S=FE_RN_2 A=term2_in[26] B=n65
XU270 MUX2S $PINS O=term1_shifted[22] S=FE_OFN102_h21_3 A=sll_16/ML_int[3][22]
+ B=sll_16/ML_int[3][14]
XU271 MUX2S $PINS O=sll_16/ML_int[3][22] S=FE_OFN103_h21_2 A=term1_in[26] B=n57
XU272 MUX2S $PINS O=term3_shifted[22] S=FE_OFN142_h23_3 A=sll_18/ML_int[3][22]
+ B=sll_18/ML_int[3][14]
XU273 MUX2S $PINS O=sll_18/ML_int[3][22] S=FE_OFN138_h23_2 A=term3_in[26] B=n77
XU274 MUX2S $PINS O=term2_shifted[22] S=n28 A=sll_17/ML_int[3][22]
+ B=sll_17/ML_int[3][14]
XU275 MUX2S $PINS O=sll_17/ML_int[3][22] S=FE_RN_2 A=term2_in[26] B=n66
XU276 MUX2S $PINS O=term1_shifted[24] S=FE_OFN102_h21_3 A=term1_in[26]
+ B=sll_16/ML_int[3][16]
XU277 MUX2S $PINS O=term3_shifted[24] S=FE_OFN142_h23_3 A=term3_in[26]
+ B=sll_18/ML_int[3][16]
XU278 MUX2S $PINS O=term2_shifted[24] S=n28 A=term2_in[26]
+ B=sll_17/ML_int[3][16]
XU279 MUX2S $PINS O=term1_shifted[25] S=FE_OFN102_h21_3 A=term1_in[26]
+ B=sll_16/ML_int[3][17]
XU280 MUX2S $PINS O=term3_shifted[25] S=FE_OFN142_h23_3 A=term3_in[26]
+ B=sll_18/ML_int[3][17]
XU281 MUX2S $PINS O=term2_shifted[25] S=n28 A=term2_in[26]
+ B=sll_17/ML_int[3][17]
XU282 MUX2S $PINS O=term1_shifted[26] S=FE_OFN102_h21_3 A=term1_in[26]
+ B=sll_16/ML_int[3][18]
XU283 MUX2S $PINS O=term3_shifted[26] S=FE_OFN142_h23_3 A=term3_in[26]
+ B=sll_18/ML_int[3][18]
XU284 MUX2S $PINS O=term2_shifted[26] S=n28 A=term2_in[26]
+ B=sll_17/ML_int[3][18]
XU288 AO22S $PINS O=N109 A1=N82 A2=FE_OFN384_s22_0 B1=term2_shifted[13]
+ B2=FE_DBTN22_s22_0
XU289 MUX2S $PINS O=FE_PHN1497_N235 S=stage_sel A=acc_reg[10] B=acc_reg[14]
XU290 MUX2S $PINS O=N236 S=stage_sel A=acc_reg[11] B=acc_reg[15]
XU291 MUX2S $PINS O=N237 S=stage_sel A=acc_reg[12] B=acc_reg[16]
XU292 MUX2S $PINS O=FE_PHN1502_N238 S=FE_OFN57_FE_DBTN9_n336 A=acc_reg[13]
+ B=acc_reg[17]
XU293 MUX2S $PINS O=N239 S=stage_sel A=acc_reg[14] B=acc_reg[18]
XU294 MUX2S $PINS O=N240 S=stage_sel A=acc_reg[15] B=acc_reg[19]
XU295 MUX2S $PINS O=N242 S=FE_OFN57_FE_DBTN9_n336 A=acc_reg[17] B=acc_reg[21]
XU296 MUX2S $PINS O=N245 S=FE_OFN57_FE_DBTN9_n336 A=acc_reg[20] B=acc_reg[24]
XU297 MUX2S $PINS O=N246 S=stage_sel A=acc_reg[21] B=acc_reg[25]
XU300 INV1S $PINS O=n53 I=FE_OCPN1223_n48
XU303 AO22 $PINS O=N159 A1=N132 A2=FE_OFN406_s23_0 B1=term3_shifted[8]
+ B2=FE_OFN405_s23_0
XU304 NR2 $PINS O=term1_in[5] I1=sign1[1] I2=x_in[5]
XU305 NR2 $PINS O=term3_in[5] I1=FE_OFN112_s23_1 I2=x_in[5]
XU306 NR2 $PINS O=term3_in[4] I1=FE_OFN112_s23_1 I2=x_in[4]
XU307 NR2 $PINS O=term1_in[6] I1=sign1[1] I2=x_in[6]
XU308 NR2 $PINS O=term2_in[6] I1=FE_OFN106_s22_1 I2=x_in[6]
XU309 NR2 $PINS O=term3_in[6] I1=FE_OFN112_s23_1 I2=x_in[6]
XU311 NR2 $PINS O=term1_in[7] I1=sign1[1] I2=x_in[7]
XU312 NR2 $PINS O=term2_in[7] I1=FE_OFN106_s22_1 I2=x_in[7]
XU313 NR2 $PINS O=term3_in[7] I1=FE_OFN112_s23_1 I2=x_in[7]
XU314 NR2 $PINS O=term1_in[8] I1=sign1[1] I2=x_in[8]
XU315 NR2 $PINS O=term2_in[8] I1=FE_RN_4 I2=x_in[8]
XU316 NR2 $PINS O=term3_in[8] I1=FE_OFN112_s23_1 I2=x_in[8]
XU317 NR2 $PINS O=term1_in[9] I1=sign1[1] I2=x_in[9]
XU318 NR2 $PINS O=term2_in[9] I1=FE_RN_4 I2=x_in[9]
XU319 NR2 $PINS O=term3_in[9] I1=FE_OFN112_s23_1 I2=x_in[9]
XU320 NR2 $PINS O=term1_in[10] I1=sign1[1] I2=x_in[10]
XU321 NR2 $PINS O=term2_in[10] I1=FE_RN_4 I2=x_in[10]
XU322 NR2 $PINS O=term3_in[10] I1=FE_OFN112_s23_1 I2=x_in[10]
XU326 NR2 $PINS O=term1_in[11] I1=sign1[1] I2=x_in[11]
XU327 NR2 $PINS O=term2_in[11] I1=FE_RN_4 I2=x_in[11]
XU328 NR2 $PINS O=term3_in[11] I1=FE_OFN112_s23_1 I2=x_in[11]
XU329 NR2 $PINS O=term1_in[12] I1=FE_OFN100_s21_1 I2=x_in[12]
XU330 NR2 $PINS O=term2_in[12] I1=FE_RN_4 I2=x_in[12]
XU331 NR2 $PINS O=term3_in[12] I1=sign3[1] I2=x_in[12]
XU332 NR2 $PINS O=term1_in[13] I1=FE_OFN100_s21_1 I2=x_in[13]
XU333 NR2 $PINS O=term2_in[13] I1=FE_RN_4 I2=x_in[13]
XU334 NR2 $PINS O=term3_in[13] I1=sign3[1] I2=x_in[13]
XU335 NR2 $PINS O=term1_in[14] I1=FE_OFN100_s21_1 I2=x_in[14]
XU336 NR2 $PINS O=term2_in[14] I1=FE_RN_4 I2=x_in[14]
XU337 NR2 $PINS O=term3_in[14] I1=sign3[1] I2=x_in[14]
XU338 NR2 $PINS O=term1_in[15] I1=FE_OFN100_s21_1 I2=x_in[15]
XU339 NR2 $PINS O=term1_in[26] I1=x_in[16] I2=FE_OFN100_s21_1
XU341 NR2 $PINS O=term2_in[15] I1=FE_RN_4 I2=x_in[15]
XU342 NR2 $PINS O=term3_in[15] I1=sign3[1] I2=x_in[15]
XU343 NR2 $PINS O=term2_in[26] I1=x_in[16] I2=FE_RN_4
XU344 NR2 $PINS O=term3_in[26] I1=x_in[16] I2=sign3[1]
XU349 INV1S $PINS O=n24 I=shf2[0]
XU350 INV1S $PINS O=n34 I=shf1[0]
XU372 AN2 $PINS O=base_val[1] I1=acc_reg[1] I2=n96
XU373 AN2 $PINS O=base_val[2] I1=acc_reg[2] I2=n96
XU374 MOAI1S $PINS O=base_val[9] A1=stage_sel A2=n96 B1=acc_reg[9] B2=n96
XU375 AN2 $PINS O=base_val[10] I1=acc_reg[10] I2=n96
XU376 AN2 $PINS O=base_val[14] I1=acc_reg[14] I2=n96
XU377 AN2 $PINS O=base_val[15] I1=acc_reg[15] I2=n96
XU378 AN2 $PINS O=base_val[11] I1=acc_reg[11] I2=n96
XU379 AN2 $PINS O=base_val[16] I1=acc_reg[16] I2=n96
XU380 AN2 $PINS O=base_val[17] I1=acc_reg[17] I2=n96
XU381 AN2 $PINS O=base_val[18] I1=acc_reg[18] I2=n96
XU382 AN2 $PINS O=base_val[8] I1=acc_reg[8] I2=n96
XU383 AN2 $PINS O=base_val[7] I1=acc_reg[7] I2=n96
XU384 AN2 $PINS O=base_val[19] I1=acc_reg[19] I2=n96
XU385 AN2 $PINS O=base_val[20] I1=acc_reg[20] I2=n96
XU386 AN2 $PINS O=base_val[6] I1=acc_reg[6] I2=n96
XU387 AN2 $PINS O=base_val[21] I1=acc_reg[21] I2=n96
XU388 AN2 $PINS O=base_val[22] I1=acc_reg[22] I2=n96
XU389 AN2 $PINS O=base_val[23] I1=acc_reg[23] I2=n96
XU390 AN2 $PINS O=base_val[24] I1=acc_reg[24] I2=n96
XU391 AN2 $PINS O=base_val[4] I1=acc_reg[4] I2=n96
XU392 AN2 $PINS O=base_val[3] I1=acc_reg[3] I2=n96
XU395 AN2 $PINS O=N234 I1=en I2=calc_done
XU396 AN2 $PINS O=base_val[26] I1=FE_PHN2084_N251 I2=n96
XU398 INV1S $PINS O=n54 I=n49
XU399 NR2 $PINS O=sll_16/ML_int[3][0] I1=FE_OFN103_h21_2 I2=FE_OCPN1223_n48
XU400 NR2 $PINS O=sll_16/ML_int[3][1] I1=FE_OFN103_h21_2 I2=FE_OCPN1222_n49
XU401 NR2 $PINS O=sll_16/ML_int[3][2] I1=FE_OFN103_h21_2 I2=n52
XU402 NR2 $PINS O=sll_16/ML_int[3][3] I1=FE_OFN103_h21_2 I2=n51
XU403 ND2 $PINS O=n50 I1=shf1[2] I2=n40
XU404 AN2T $PINS O=term1_shifted[4] I1=sll_16/ML_int[3][4] I2=n40
XU405 AN2T $PINS O=term1_shifted[5] I1=sll_16/ML_int[3][5] I2=n40
XU406 AN2 $PINS O=term1_shifted[6] I1=sll_16/ML_int[3][6] I2=n40
XU407 AN2 $PINS O=term1_shifted[7] I1=sll_16/ML_int[3][7] I2=n40
XU408 MUX2 $PINS O=n56 S=FE_OFN336_h21_1 A=term1_in[26] B=sll_16/ML_int[1][15]
XU409 MUX2 $PINS O=n57 S=FE_OFN336_h21_1 A=term1_in[26] B=n58
XU410 MUX2 $PINS O=n58 S=FE_OFN105_h21_0 A=term1_in[26] B=term1_in[15]
XU411 NR2 $PINS O=sll_17/ML_int[3][0] I1=FE_RN_2 I2=n59
XU412 NR2 $PINS O=sll_17/ML_int[3][1] I1=FE_RN_2 I2=n60
XU413 NR2 $PINS O=sll_17/ML_int[3][2] I1=FE_RN_2 I2=n63
XU414 NR2 $PINS O=sll_17/ML_int[3][3] I1=FE_RN_2 I2=n62
XU415 ND2 $PINS O=n61 I1=FE_OFN109_h22_2 I2=shf2[3]
XU416 AN2T $PINS O=term2_shifted[4] I1=sll_17/ML_int[3][4] I2=shf2[3]
XU417 AN2 $PINS O=term2_shifted[5] I1=sll_17/ML_int[3][5] I2=shf2[3]
XU418 AN2 $PINS O=term2_shifted[6] I1=sll_17/ML_int[3][6] I2=shf2[3]
XU419 AN2 $PINS O=term2_shifted[7] I1=sll_17/ML_int[3][7] I2=shf2[3]
XU420 MUX2 $PINS O=n65 S=FE_RN_5 A=term2_in[26] B=sll_17/ML_int[1][15]
XU421 MUX2 $PINS O=n66 S=FE_RN_5 A=term2_in[26] B=n67
XU422 MUX2 $PINS O=n67 S=FE_OFN111_h22_0 A=term2_in[26] B=term2_in[15]
XU423 NR2 $PINS O=sll_18/ML_int[3][0] I1=FE_OFN277_h23_2 I2=n68
XU424 NR2 $PINS O=sll_18/ML_int[3][1] I1=FE_OFN277_h23_2 I2=FE_OCPN1140_n69
XU425 NR2 $PINS O=sll_18/ML_int[3][2] I1=FE_OFN277_h23_2 I2=n72
XU426 NR2 $PINS O=sll_18/ML_int[3][3] I1=FE_OFN277_h23_2 I2=n71
XU427 ND2P $PINS O=n70 I1=shf3[2] I2=shf3[3]
XU428 AN2 $PINS O=term3_shifted[4] I1=sll_18/ML_int[3][4] I2=shf3[3]
XU429 AN2 $PINS O=term3_shifted[5] I1=sll_18/ML_int[3][5] I2=shf3[3]
XU430 AN2 $PINS O=term3_shifted[6] I1=sll_18/ML_int[3][6] I2=shf3[3]
XU431 AN2 $PINS O=term3_shifted[7] I1=sll_18/ML_int[3][7] I2=shf3[3]
XU432 MUX2 $PINS O=n76 S=FE_OFN487_FE_OFN347_h23_1 A=term3_in[26]
+ B=sll_18/ML_int[1][15]
XU433 MUX2 $PINS O=n77 S=FE_OFN487_FE_OFN347_h23_1 A=term3_in[26] B=n78
XU434 MUX2 $PINS O=n78 S=FE_OFN484_h23_0 A=term3_in[26] B=term3_in[15]
XU435 MUX2 $PINS O=N241 S=stage_sel A=acc_reg[16] B=acc_reg[20]
XU436 MUX2 $PINS O=N243 S=stage_sel A=acc_reg[18] B=acc_reg[22]
XU437 MUX2 $PINS O=FE_PHN1414_N244 S=FE_OFN57_FE_DBTN9_n336 A=acc_reg[19]
+ B=acc_reg[23]
XU5 NR2P $PINS O=term2_shifted[1] I1=n7 I2=n6
XU11 NR2P $PINS O=term1_in[1] I1=sign1[1] I2=x_in[1]
XU12 INV2 $PINS O=n3 I=N70
XU13 NR2P $PINS O=term3_in[0] I1=FE_OFN112_s23_1 I2=x_in[0]
XU19 AN2 $PINS O=base_val[25] I1=acc_reg[25] I2=n96
XU41 INV2 $PINS O=n52 I=sll_16/ML_int[2][2]
XU42 NR2P $PINS O=term3_shifted[3] I1=n70 I2=n71
XU43 INV2 $PINS O=n71 I=sll_18/ML_int[2][3]
XU44 NR2T $PINS O=term2_shifted[2] I1=n61 I2=n63
XU54 NR2P $PINS O=term3_in[2] I1=FE_OFN112_s23_1 I2=x_in[2]
XU73 NR2T $PINS O=term2_in[3] I1=FE_OFN106_s22_1 I2=x_in[3]
XU88 NR2P $PINS O=term3_in[3] I1=FE_OFN112_s23_1 I2=x_in[3]
XU106 NR2 $PINS O=term1_in[4] I1=sign1[1] I2=x_in[4]
XU310 NR2P $PINS O=term3_in[1] I1=FE_OFN112_s23_1 I2=x_in[1]
XU393 NR2T $PINS O=term1_shifted[2] I1=n50 I2=n52
Xclk_gate_y_out_reg SNPS_CLOCK_GATE_HIGH_PE_Shift_Add_2 $PINS EN=N234
+ ENCLK=net2250 CLK=clk
Xsub_28_3 PE_Shift_Add_2_DW01_sub_0_DW01_sub_6 $PINS A[26]=net45559
+ A[25]=net45559 A[24]=net45559 A[23]=net45559 A[22]=net45559 A[21]=net45559
+ A[20]=net45559 A[19]=net45559 A[18]=net45559 A[17]=net45559 A[16]=net45559
+ A[15]=net45559 A[14]=net45559 A[13]=net45559 A[12]=net45559 A[11]=net45559
+ A[10]=net45559 A[9]=net45559 A[8]=net45559 A[7]=net45559 A[6]=net45559
+ A[5]=net45559 A[4]=net45559 A[3]=net45559 A[2]=net45559 A[1]=net45559
+ A[0]=net45559 B[26]=term3_shifted[26] B[25]=term3_shifted[25]
+ B[24]=term3_shifted[24] B[23]=term3_shifted[23] B[22]=term3_shifted[22]
+ B[21]=term3_shifted[21] B[20]=term3_shifted[20] B[19]=term3_shifted[19]
+ B[18]=term3_shifted[18] B[17]=term3_shifted[17] B[16]=term3_shifted[16]
+ B[15]=term3_shifted[15] B[14]=term3_shifted[14] B[13]=term3_shifted[13]
+ B[12]=term3_shifted[12] B[11]=term3_shifted[11] B[10]=term3_shifted[10]
+ B[9]=term3_shifted[9] B[8]=term3_shifted[8] B[7]=term3_shifted[7]
+ B[6]=term3_shifted[6] B[5]=term3_shifted[5] B[4]=term3_shifted[4]
+ B[3]=term3_shifted[3] B[2]=term3_shifted[2] B[1]=term3_shifted[1]
+ B[0]=term3_shifted[0] CI=net45559 DIFF[26]=N150 DIFF[25]=N149 DIFF[24]=N148
+ DIFF[23]=N147 DIFF[22]=N146 DIFF[21]=N145 DIFF[20]=N144 DIFF[19]=N143
+ DIFF[18]=N142 DIFF[17]=N141 DIFF[16]=N140 DIFF[15]=N139 DIFF[14]=N138
+ DIFF[13]=N137 DIFF[12]=N136 DIFF[11]=N135 DIFF[10]=N134 DIFF[9]=N133
+ DIFF[8]=N132 DIFF[7]=N131 DIFF[6]=N130 DIFF[5]=N129 DIFF[4]=N128 DIFF[3]=N127
+ DIFF[2]=N126 DIFF[1]=N125 DIFF[0]=N124
Xsub_28_2 PE_Shift_Add_2_DW01_sub_1_DW01_sub_7 $PINS A[26]=net45559
+ A[25]=net45559 A[24]=net45559 A[23]=net45559 A[22]=net45559 A[21]=net45559
+ A[20]=net45559 A[19]=net45559 A[18]=net45559 A[17]=net45559 A[16]=net45559
+ A[15]=net45559 A[14]=net45559 A[13]=net45559 A[12]=net45559 A[11]=net45559
+ A[10]=net45559 A[9]=net45559 A[8]=net45559 A[7]=net45559 A[6]=net45559
+ A[5]=net45559 A[4]=net45559 A[3]=net45559 A[2]=net45559 A[1]=net45559
+ A[0]=net45559 B[26]=term2_shifted[26] B[25]=term2_shifted[25]
+ B[24]=term2_shifted[24] B[23]=term2_shifted[23] B[22]=term2_shifted[22]
+ B[21]=term2_shifted[21] B[20]=term2_shifted[20] B[19]=term2_shifted[19]
+ B[18]=term2_shifted[18] B[17]=term2_shifted[17] B[16]=term2_shifted[16]
+ B[15]=term2_shifted[15] B[14]=term2_shifted[14] B[13]=term2_shifted[13]
+ B[12]=term2_shifted[12] B[11]=term2_shifted[11] B[10]=term2_shifted[10]
+ B[9]=term2_shifted[9] B[8]=term2_shifted[8] B[7]=term2_shifted[7]
+ B[6]=term2_shifted[6] B[5]=term2_shifted[5] B[4]=term2_shifted[4]
+ B[3]=term2_shifted[3] B[2]=term2_shifted[2] B[1]=term2_shifted[1]
+ B[0]=term2_shifted[0] CI=net45559 DIFF[26]=N95 DIFF[25]=N94 DIFF[24]=N93
+ DIFF[23]=N92 DIFF[22]=N91 DIFF[21]=N90 DIFF[20]=N89 DIFF[19]=N88 DIFF[18]=N87
+ DIFF[17]=N86 DIFF[16]=N85 DIFF[15]=N84 DIFF[14]=N83 DIFF[13]=N82 DIFF[12]=N81
+ DIFF[11]=N80 DIFF[10]=N79 DIFF[9]=N78 DIFF[8]=N77 DIFF[7]=N76 DIFF[6]=N75
+ DIFF[5]=N74 DIFF[4]=N73 DIFF[3]=N72 DIFF[2]=N71 DIFF[1]=N70 DIFF[0]=N69
Xsub_28 PE_Shift_Add_2_DW01_sub_2_DW01_sub_8 $PINS A[26]=net45559
+ A[25]=net45559 A[24]=net45559 A[23]=net45559 A[22]=net45559 A[21]=net45559
+ A[20]=net45559 A[19]=net45559 A[18]=net45559 A[17]=net45559 A[16]=net45559
+ A[15]=net45559 A[14]=net45559 A[13]=net45559 A[12]=net45559 A[11]=net45559
+ A[10]=net45559 A[9]=net45559 A[8]=net45559 A[7]=net45559 A[6]=net45559
+ A[5]=net45559 A[4]=net45559 A[3]=net45559 A[2]=net45559 A[1]=net45559
+ A[0]=net45559 B[26]=term1_shifted[26] B[25]=term1_shifted[25]
+ B[24]=term1_shifted[24] B[23]=term1_shifted[23] B[22]=term1_shifted[22]
+ B[21]=term1_shifted[21] B[20]=term1_shifted[20] B[19]=term1_shifted[19]
+ B[18]=term1_shifted[18] B[17]=term1_shifted[17] B[16]=term1_shifted[16]
+ B[15]=term1_shifted[15] B[14]=term1_shifted[14] B[13]=term1_shifted[13]
+ B[12]=term1_shifted[12] B[11]=term1_shifted[11] B[10]=term1_shifted[10]
+ B[9]=term1_shifted[9] B[8]=term1_shifted[8] B[7]=term1_shifted[7]
+ B[6]=term1_shifted[6] B[5]=term1_shifted[5] B[4]=term1_shifted[4]
+ B[3]=term1_shifted[3] B[2]=term1_shifted[2] B[1]=term1_shifted[1]
+ B[0]=term1_shifted[0] CI=net45559 DIFF[26]=N40 DIFF[25]=N39 DIFF[24]=N38
+ DIFF[23]=N37 DIFF[22]=N36 DIFF[21]=N35 DIFF[20]=N34 DIFF[19]=N33 DIFF[18]=N32
+ DIFF[17]=N31 DIFF[16]=N30 DIFF[15]=N29 DIFF[14]=N28 DIFF[13]=N27 DIFF[12]=N26
+ DIFF[11]=N25 DIFF[10]=N24 DIFF[9]=N23 DIFF[8]=N22 DIFF[7]=N21 DIFF[6]=N20
+ DIFF[5]=N19 DIFF[4]=N18 DIFF[3]=N17 DIFF[2]=N16 DIFF[1]=N15 DIFF[0]=N14
+ FE_RN_1600_0=FE_RN_1600_0 FE_RN_1546_0=FE_RN_1546_0
Xadd_1_root_add_0_root_add_28_3 PE_Shift_Add_2_DW01_add_2_DW01_add_19 $PINS
+ A[26]=N67 A[25]=N66 A[24]=N65 A[23]=N64 A[22]=N63 A[21]=N62 A[20]=N61 A[19]=N60
+ A[18]=N59 A[17]=N58 A[16]=N57 A[15]=N56 A[14]=N55 A[13]=N54 A[12]=N53 A[11]=N52
+ A[10]=N51 A[9]=N50 A[8]=N49 A[7]=N48 A[6]=N47 A[5]=N46 A[4]=N45 A[3]=N44
+ A[2]=N43 A[1]=N42 A[0]=N41 B[26]=N177 B[25]=N176 B[24]=N175 B[23]=N174
+ B[22]=N173 B[21]=N172 B[20]=N171 B[19]=N170 B[18]=N169 B[17]=N168 B[16]=N167
+ B[15]=N166 B[14]=N165 B[13]=N164 B[12]=N163 B[11]=N162 B[10]=N161 B[9]=N160
+ B[8]=N159 B[7]=N158 B[6]=N157 B[5]=N156 B[4]=N155 B[3]=N154 B[2]=N153 B[1]=N152
+ B[0]=N151 CI=net45559 SUM[26]=N204 SUM[25]=N203 SUM[24]=N202 SUM[23]=N201
+ SUM[22]=N200 SUM[21]=N199 SUM[20]=N198 SUM[19]=N197 SUM[18]=N196 SUM[17]=N195
+ SUM[16]=N194 SUM[15]=N193 SUM[14]=N192 SUM[13]=N191 SUM[12]=N190 SUM[11]=N189
+ SUM[10]=N188 SUM[9]=N187 SUM[8]=N186 SUM[7]=N185 SUM[6]=N184 SUM[5]=N183
+ SUM[4]=N182 SUM[3]=N181 SUM[2]=N180 SUM[1]=N179 SUM[0]=N178
Xadd_2_root_add_0_root_add_28_3 PE_Shift_Add_2_DW01_add_1_DW01_add_18 $PINS
+ A[26]=base_val[26] A[25]=base_val[25] A[24]=base_val[24] A[23]=base_val[23]
+ A[22]=base_val[22] A[21]=base_val[21] A[20]=base_val[20] A[19]=base_val[19]
+ A[18]=base_val[18] A[17]=base_val[17] A[16]=base_val[16] A[15]=base_val[15]
+ A[14]=base_val[14] A[13]=base_val[13] A[12]=base_val[12] A[11]=base_val[11]
+ A[10]=base_val[10] A[9]=base_val[9] A[8]=base_val[8] A[7]=base_val[7]
+ A[6]=base_val[6] A[5]=base_val[5] A[4]=base_val[4] A[3]=base_val[3]
+ A[2]=base_val[2] A[1]=base_val[1] A[0]=base_val[0] B[26]=N122 B[25]=N121
+ B[24]=N120 B[23]=N119 B[22]=N118 B[21]=N117 B[20]=N116 B[19]=N115 B[18]=N114
+ B[17]=N113 B[16]=N112 B[15]=N111 B[14]=N110 B[13]=N109 B[12]=N108 B[11]=N107
+ B[10]=N106 B[9]=N105 B[8]=N104 B[7]=N103 B[6]=N102 B[5]=N101 B[4]=N100 B[3]=N99
+ B[2]=N98 B[1]=N97 B[0]=N96 CI=net45559 SUM[26]=N231 SUM[25]=N230 SUM[24]=N229
+ SUM[23]=N228 SUM[22]=N227 SUM[21]=N226 SUM[20]=N225 SUM[19]=N224 SUM[18]=N223
+ SUM[17]=N222 SUM[16]=N221 SUM[15]=N220 SUM[14]=N219 SUM[13]=N218 SUM[12]=N217
+ SUM[11]=N216 SUM[10]=N215 SUM[9]=N214 SUM[8]=N213 SUM[7]=N212 SUM[6]=N211
+ SUM[5]=N210 SUM[4]=N209 SUM[3]=N208 SUM[2]=N207 SUM[1]=N206 SUM[0]=N205
Xadd_0_root_add_0_root_add_28_3 PE_Shift_Add_2_DW01_add_0_DW01_add_17 $PINS
+ A[26]=N204 A[25]=N203 A[24]=N202 A[23]=N201 A[22]=N200 A[21]=N199 A[20]=N198
+ A[19]=N197 A[18]=N196 A[17]=N195 A[16]=N194 A[15]=N193 A[14]=N192 A[13]=N191
+ A[12]=N190 A[11]=N189 A[10]=N188 A[9]=N187 A[8]=N186 A[7]=N185 A[6]=N184
+ A[5]=N183 A[4]=N182 A[3]=N181 A[2]=N180 A[1]=N179 A[0]=N178 B[26]=N231
+ B[25]=N230 B[24]=N229 B[23]=N228 B[22]=N227 B[21]=N226 B[20]=N225 B[19]=N224
+ B[18]=N223 B[17]=N222 B[16]=N221 B[15]=N220 B[14]=N219 B[13]=N218 B[12]=N217
+ B[11]=N216 B[10]=N215 B[9]=N214 B[8]=N213 B[7]=N212 B[6]=N211 B[5]=N210
+ B[4]=N209 B[3]=N208 B[2]=N207 B[1]=N206 B[0]=FE_PHN1807_N205 CI=net45559
+ SUM[26]=next_acc[26] SUM[25]=next_acc[25] SUM[24]=next_acc[24]
+ SUM[23]=next_acc[23] SUM[22]=next_acc[22] SUM[21]=next_acc[21]
+ SUM[20]=next_acc[20] SUM[19]=next_acc[19] SUM[18]=next_acc[18]
+ SUM[17]=next_acc[17] SUM[16]=next_acc[16] SUM[15]=next_acc[15]
+ SUM[14]=next_acc[14] SUM[13]=next_acc[13] SUM[12]=next_acc[12]
+ SUM[11]=next_acc[11] SUM[10]=next_acc[10] SUM[9]=next_acc[9] SUM[8]=next_acc[8]
+ SUM[7]=next_acc[7] SUM[6]=next_acc[6] SUM[5]=next_acc[5] SUM[4]=next_acc[4]
+ SUM[3]=next_acc[3] SUM[2]=next_acc[2] SUM[1]=next_acc[1] SUM[0]=next_acc[0]
.ENDS

.SUBCKT SNPS_CLOCK_GATE_HIGH_PE_Shift_Add_1 EN ENCLK CLK
*.CONNECT net2226 EN
XFE_PHC1296_net2229 DELC $PINS O=FE_PHN1296_net2229 I=net2229
Xlatch QDBHN $PINS Q=net2229 D=net2226 CKB=CLK
Xmain_gate AN2 $PINS O=ENCLK I1=FE_PHN1296_net2229 I2=CLK
.ENDS

.SUBCKT PE_Shift_Add_1_DW01_sub_0_DW01_sub_3 A[26] A[25] A[24] A[23] A[22]
+ A[21] A[20] A[19] A[18] A[17] A[16] A[15] A[14] A[13] A[12] A[11] A[10] A[9]
+ A[8] A[7] A[6] A[5] A[4] A[3] A[2] A[1] A[0] B[26] B[25] B[24] B[23] B[22]
+ B[21] B[20] B[19] B[18] B[17] B[16] B[15] B[14] B[13] B[12] B[11] B[10] B[9]
+ B[8] B[7] B[6] B[5] B[4] B[3] B[2] B[1] B[0] CI DIFF[26] DIFF[25] DIFF[24]
+ DIFF[23] DIFF[22] DIFF[21] DIFF[20] DIFF[19] DIFF[18] DIFF[17] DIFF[16]
+ DIFF[15] DIFF[14] DIFF[13] DIFF[12] DIFF[11] DIFF[10] DIFF[9] DIFF[8] DIFF[7]
+ DIFF[6] DIFF[5] DIFF[4] DIFF[3] DIFF[2] DIFF[1] DIFF[0] CO
*.CONNECT DIFF[0] B[0]
XFE_RC_82_0 XOR2HS $PINS O=DIFF[4] I1=n5 I2=n50
XFE_RC_22_0 XOR2H $PINS O=DIFF[2] I1=B[2] I2=n2
XFE_RC_3962_0 AN2S $PINS O=FE_RN_2574_0 I1=n48 I2=n49
XFE_RC_3961_0 AN2 $PINS O=n25 I1=FE_RN_2574_0 I2=n23
XFE_RC_3926_0 INV1S $PINS O=FE_RN_2561_0 I=n47
XFE_RC_3925_0 MXL2HS $PINS OB=DIFF[7] S=n25 A=FE_RN_2561_0 B=n47
XFE_RC_205_0 XOR2HS $PINS O=DIFF[1] I1=n53 I2=n52
XFE_OFC757_term3_shifted_3 INV1S $PINS O=n51 I=B[3]
XU4 NR2 $PINS O=n4 I1=B[2] I2=n2
XU7 AN2T $PINS O=n3 I1=n52 I2=n53
XU8 INV3 $PINS O=n2 I=n3
XU9 INV1S $PINS O=n45 I=B[9]
XU12 ND2S $PINS O=n28 I1=n29 I2=n22
XU13 AN2 $PINS O=n5 I1=n51 I2=n4
XU14 AN2T $PINS O=n6 I1=n46 I2=n26
XU15 AN2 $PINS O=n7 I1=n45 I2=n6
XU16 AN2 $PINS O=n8 I1=n44 I2=n7
XU17 AN2 $PINS O=n9 I1=n43 I2=n8
XU18 AN2 $PINS O=n10 I1=n42 I2=n9
XU19 AN2 $PINS O=n11 I1=n41 I2=n10
XU20 AN2 $PINS O=n12 I1=n40 I2=n11
XU21 AN2 $PINS O=n13 I1=n39 I2=n12
XU22 AN2 $PINS O=n14 I1=n38 I2=n13
XU23 AN2 $PINS O=n15 I1=n37 I2=n14
XU24 AN2 $PINS O=n16 I1=n36 I2=n15
XU25 AN2 $PINS O=n17 I1=n35 I2=n16
XU26 AN2 $PINS O=n18 I1=n34 I2=n17
XU27 AN2 $PINS O=n19 I1=n33 I2=n18
XU28 AN2 $PINS O=n20 I1=n32 I2=n19
XU29 AN2 $PINS O=n21 I1=n31 I2=n20
XU30 AN2 $PINS O=n22 I1=n30 I2=n21
XU31 AN2 $PINS O=n23 I1=n50 I2=n5
XU32 AN2 $PINS O=n24 I1=n49 I2=n23
XU34 INV1S $PINS O=n46 I=B[8]
XU35 AN2T $PINS O=n26 I1=n47 I2=n25
XU36 INV1S $PINS O=n44 I=B[10]
XU37 INV1S $PINS O=n43 I=B[11]
XU38 INV1S $PINS O=n42 I=B[12]
XU39 INV1S $PINS O=n41 I=B[13]
XU40 INV1S $PINS O=n40 I=B[14]
XU41 INV1S $PINS O=n39 I=B[15]
XU42 INV1S $PINS O=n38 I=B[16]
XU43 INV1S $PINS O=n37 I=B[17]
XU44 INV1S $PINS O=n36 I=B[18]
XU45 INV1S $PINS O=n35 I=B[19]
XU46 INV1S $PINS O=n34 I=B[20]
XU47 INV1S $PINS O=n33 I=B[21]
XU48 INV1S $PINS O=n32 I=B[22]
XU49 INV1S $PINS O=n31 I=B[23]
XU50 INV1S $PINS O=n30 I=B[24]
XU51 INV1S $PINS O=n29 I=B[25]
XU52 INV1S $PINS O=n50 I=B[4]
XU53 INV1S $PINS O=n49 I=B[5]
XU54 INV1S $PINS O=n48 I=B[6]
XU55 INV1S $PINS O=n47 I=B[7]
XU56 XOR2HS $PINS O=DIFF[3] I1=n51 I2=n4
XU58 XOR2HS $PINS O=DIFF[5] I1=n49 I2=n23
XU59 XOR2HS $PINS O=DIFF[6] I1=n48 I2=n24
XU61 XOR2HS $PINS O=DIFF[9] I1=n45 I2=n6
XU62 XOR2HS $PINS O=DIFF[8] I1=n46 I2=n26
XU63 XOR2HS $PINS O=DIFF[11] I1=n43 I2=n8
XU64 XOR2HS $PINS O=DIFF[10] I1=n44 I2=n7
XU65 XOR2HS $PINS O=DIFF[12] I1=n42 I2=n9
XU66 XOR2HS $PINS O=DIFF[13] I1=n41 I2=n10
XU67 XOR2HS $PINS O=DIFF[14] I1=n40 I2=n11
XU68 XOR2HS $PINS O=DIFF[15] I1=n39 I2=n12
XU69 XOR2HS $PINS O=DIFF[16] I1=n38 I2=n13
XU70 XOR2HS $PINS O=DIFF[17] I1=n37 I2=n14
XU71 XOR2HS $PINS O=DIFF[18] I1=n36 I2=n15
XU72 XOR2HS $PINS O=DIFF[19] I1=n35 I2=n16
XU73 XOR2HS $PINS O=DIFF[20] I1=n34 I2=n17
XU74 XOR2HS $PINS O=DIFF[21] I1=n33 I2=n18
XU75 XOR2HS $PINS O=DIFF[22] I1=n32 I2=n19
XU76 XOR2HS $PINS O=DIFF[23] I1=n31 I2=n20
XU77 XOR2HS $PINS O=DIFF[24] I1=n30 I2=n21
XU78 XOR2HS $PINS O=DIFF[25] I1=n29 I2=n22
XU79 XOR2HS $PINS O=DIFF[26] I1=B[26] I2=n28
XU1 INV2 $PINS O=n52 I=B[1]
XU2 INV2 $PINS O=n53 I=B[0]
.ENDS

.SUBCKT PE_Shift_Add_1_DW01_sub_1_DW01_sub_4 A[26] A[25] A[24] A[23] A[22]
+ A[21] A[20] A[19] A[18] A[17] A[16] A[15] A[14] A[13] A[12] A[11] A[10] A[9]
+ A[8] A[7] A[6] A[5] A[4] A[3] A[2] A[1] A[0] B[26] B[25] B[24] B[23] B[22]
+ B[21] B[20] B[19] B[18] B[17] B[16] B[15] B[14] B[13] B[12] B[11] B[10] B[9]
+ B[8] B[7] B[6] B[5] B[4] B[3] B[2] B[1] B[0] CI DIFF[26] DIFF[25] DIFF[24]
+ DIFF[23] DIFF[22] DIFF[21] DIFF[20] DIFF[19] DIFF[18] DIFF[17] DIFF[16]
+ DIFF[15] DIFF[14] DIFF[13] DIFF[12] DIFF[11] DIFF[10] DIFF[9] DIFF[8] DIFF[7]
+ DIFF[6] DIFF[5] DIFF[4] DIFF[3] DIFF[2] DIFF[1] DIFF[0] CO
XFE_RC_4014_0 XOR2HS $PINS O=DIFF[4] I1=n3 I2=n48
XFE_OFC818_term2_shifted_7 INV1S $PINS O=n45 I=B[7]
XFE_OFC794_term2_shifted_3 INV1S $PINS O=n49 I=B[3]
XFE_OFC740_term2_shifted_2 INV1S $PINS O=n50 I=B[2]
XFE_OFC730_N69 INV1S $PINS O=n52 I=B[0]
XU4 INV1S $PINS O=n43 I=B[9]
XU7 INV1S $PINS O=n48 I=B[4]
XU8 ND2S $PINS O=n26 I1=n27 I2=n20
XU10 AN2 $PINS O=n2 I1=n50 I2=n1
XU11 AN2 $PINS O=n3 I1=n49 I2=n2
XU12 AN2 $PINS O=n4 I1=n44 I2=n24
XU13 AN2 $PINS O=n5 I1=n43 I2=n4
XU14 AN2 $PINS O=n6 I1=n42 I2=n5
XU15 AN2 $PINS O=n7 I1=n41 I2=n6
XU16 AN2 $PINS O=n8 I1=n40 I2=n7
XU17 AN2 $PINS O=n9 I1=n39 I2=n8
XU18 AN2 $PINS O=n10 I1=n38 I2=n9
XU19 AN2 $PINS O=n11 I1=n37 I2=n10
XU20 AN2 $PINS O=n12 I1=n36 I2=n11
XU21 AN2 $PINS O=n13 I1=n35 I2=n12
XU22 AN2 $PINS O=n14 I1=n34 I2=n13
XU23 AN2 $PINS O=n15 I1=n33 I2=n14
XU24 AN2 $PINS O=n16 I1=n32 I2=n15
XU25 AN2 $PINS O=n17 I1=n31 I2=n16
XU26 AN2 $PINS O=n18 I1=n30 I2=n17
XU27 AN2 $PINS O=n19 I1=n29 I2=n18
XU28 AN2 $PINS O=n20 I1=n28 I2=n19
XU30 AN2 $PINS O=n21 I1=n48 I2=n3
XU31 AN2 $PINS O=n22 I1=n47 I2=n21
XU32 AN2 $PINS O=n23 I1=n46 I2=n22
XU33 INV1S $PINS O=n44 I=B[8]
XU34 AN2 $PINS O=n24 I1=n45 I2=n23
XU35 INV1S $PINS O=n42 I=B[10]
XU36 INV1S $PINS O=n41 I=B[11]
XU37 INV1S $PINS O=n40 I=B[12]
XU38 INV1S $PINS O=n39 I=B[13]
XU39 INV1S $PINS O=n38 I=B[14]
XU40 INV1S $PINS O=n37 I=B[15]
XU41 INV1S $PINS O=n36 I=B[16]
XU42 INV1S $PINS O=n35 I=B[17]
XU43 INV1S $PINS O=n34 I=B[18]
XU44 INV1S $PINS O=n33 I=B[19]
XU45 INV1S $PINS O=n32 I=B[20]
XU46 INV1S $PINS O=n31 I=B[21]
XU47 INV1S $PINS O=n30 I=B[22]
XU48 INV1S $PINS O=n29 I=B[23]
XU49 INV1S $PINS O=n28 I=B[24]
XU50 INV1S $PINS O=n27 I=B[25]
XU51 INV1S $PINS O=n47 I=B[5]
XU52 INV1S $PINS O=n46 I=B[6]
XU54 XOR2HS $PINS O=DIFF[26] I1=B[26] I2=n26
XU55 XOR2HS $PINS O=DIFF[9] I1=n43 I2=n4
XU56 XOR2HS $PINS O=DIFF[10] I1=n42 I2=n5
XU57 XOR2HS $PINS O=DIFF[8] I1=n44 I2=n24
XU58 XOR2HS $PINS O=DIFF[6] I1=n46 I2=n22
XU59 XOR2HS $PINS O=DIFF[7] I1=n45 I2=n23
XU60 XOR2HS $PINS O=DIFF[5] I1=n47 I2=n21
XU62 XOR2HS $PINS O=DIFF[3] I1=n49 I2=n2
XU63 XOR2HS $PINS O=DIFF[2] I1=n50 I2=n1
XU64 XOR2HS $PINS O=DIFF[11] I1=n41 I2=n6
XU65 XOR2HS $PINS O=DIFF[12] I1=n40 I2=n7
XU66 XOR2HS $PINS O=DIFF[13] I1=n39 I2=n8
XU67 XOR2HS $PINS O=DIFF[14] I1=n38 I2=n9
XU68 XOR2HS $PINS O=DIFF[15] I1=n37 I2=n10
XU69 XOR2HS $PINS O=DIFF[16] I1=n36 I2=n11
XU70 XOR2HS $PINS O=DIFF[17] I1=n35 I2=n12
XU71 XOR2HS $PINS O=DIFF[18] I1=n34 I2=n13
XU72 XOR2HS $PINS O=DIFF[19] I1=n33 I2=n14
XU73 XOR2HS $PINS O=DIFF[20] I1=n32 I2=n15
XU74 XOR2HS $PINS O=DIFF[21] I1=n31 I2=n16
XU75 XOR2HS $PINS O=DIFF[22] I1=n30 I2=n17
XU76 XOR2HS $PINS O=DIFF[23] I1=n29 I2=n18
XU77 XOR2HS $PINS O=DIFF[24] I1=n28 I2=n19
XU78 XOR2HS $PINS O=DIFF[25] I1=n27 I2=n20
XU5 NR2 $PINS O=n1 I1=B[1] I2=B[0]
XU6 XNR2HS $PINS O=DIFF[1] I1=n52 I2=B[1]
.ENDS

.SUBCKT PE_Shift_Add_1_DW01_sub_2_DW01_sub_5 A[26] A[25] A[24] A[23] A[22]
+ A[21] A[20] A[19] A[18] A[17] A[16] A[15] A[14] A[13] A[12] A[11] A[10] A[9]
+ A[8] A[7] A[6] A[5] A[4] A[3] A[2] A[1] A[0] B[26] B[25] B[24] B[23] B[22]
+ B[21] B[20] B[19] B[18] B[17] B[16] B[15] B[14] B[13] B[12] B[11] B[10] B[9]
+ B[8] B[7] B[6] B[5] B[4] B[3] B[2] B[1] B[0] CI DIFF[26] DIFF[25] DIFF[24]
+ DIFF[23] DIFF[22] DIFF[21] DIFF[20] DIFF[19] DIFF[18] DIFF[17] DIFF[16]
+ DIFF[15] DIFF[14] DIFF[13] DIFF[12] DIFF[11] DIFF[10] DIFF[9] DIFF[8] DIFF[7]
+ DIFF[6] DIFF[5] DIFF[4] DIFF[3] DIFF[2] DIFF[1] DIFF[0] CO
*.CONNECT DIFF[0] B[0]
XFE_RC_3994_0 INV1S $PINS O=FE_RN_2590_0 I=n47
XFE_RC_3993_0 MXL2HS $PINS OB=DIFF[7] S=n25 A=FE_RN_2590_0 B=n47
XFE_OFC825_term1_shifted_6 INV1S $PINS O=n48 I=B[6]
XU4 NR2 $PINS O=n4 I1=B[2] I2=n53
XU6 XNR2HS $PINS O=DIFF[1] I1=B[1] I2=n52
XU9 INV1S $PINS O=n45 I=B[9]
XU10 XOR2HS $PINS O=DIFF[4] I1=n50 I2=n3
XU11 ND2S $PINS O=n28 I1=n29 I2=n22
XU12 INV1S $PINS O=n52 I=B[0]
XU13 XOR2HS $PINS O=DIFF[3] I1=n51 I2=n4
XU14 AN2 $PINS O=n3 I1=n51 I2=n4
XU15 XOR2HS $PINS O=DIFF[8] I1=n46 I2=n26
XU16 XOR2HS $PINS O=DIFF[9] I1=n45 I2=n6
XU17 AN2 $PINS O=n6 I1=n46 I2=n26
XU18 XOR2HS $PINS O=DIFF[10] I1=n44 I2=n7
XU19 AN2 $PINS O=n7 I1=n45 I2=n6
XU20 XOR2HS $PINS O=DIFF[11] I1=n43 I2=n8
XU21 AN2 $PINS O=n8 I1=n44 I2=n7
XU22 XOR2HS $PINS O=DIFF[12] I1=n42 I2=n9
XU23 AN2T $PINS O=n9 I1=n43 I2=n8
XU24 XOR2HS $PINS O=DIFF[13] I1=n41 I2=n10
XU25 AN2T $PINS O=n10 I1=n42 I2=n9
XU26 XOR2HS $PINS O=DIFF[14] I1=n40 I2=n11
XU27 AN2T $PINS O=n11 I1=n41 I2=n10
XU28 XOR2HS $PINS O=DIFF[15] I1=n39 I2=n12
XU29 AN2 $PINS O=n12 I1=n40 I2=n11
XU30 XOR2HS $PINS O=DIFF[16] I1=n38 I2=n13
XU31 AN2 $PINS O=n13 I1=n39 I2=n12
XU32 XOR2HS $PINS O=DIFF[17] I1=n37 I2=n14
XU33 AN2 $PINS O=n14 I1=n38 I2=n13
XU34 XOR2HS $PINS O=DIFF[18] I1=n36 I2=n15
XU35 AN2 $PINS O=n15 I1=n37 I2=n14
XU36 XOR2HS $PINS O=DIFF[19] I1=n35 I2=n16
XU37 AN2 $PINS O=n16 I1=n36 I2=n15
XU38 XOR2HS $PINS O=DIFF[20] I1=n34 I2=n17
XU39 AN2 $PINS O=n17 I1=n35 I2=n16
XU40 XOR2HS $PINS O=DIFF[21] I1=n33 I2=n18
XU41 AN2 $PINS O=n18 I1=n34 I2=n17
XU42 XOR2HS $PINS O=DIFF[22] I1=n32 I2=n19
XU43 AN2 $PINS O=n19 I1=n33 I2=n18
XU44 XOR2HS $PINS O=DIFF[23] I1=n31 I2=n20
XU45 AN2 $PINS O=n20 I1=n32 I2=n19
XU46 AN2 $PINS O=n21 I1=n31 I2=n20
XU47 AN2 $PINS O=n22 I1=n30 I2=n21
XU48 XOR2HS $PINS O=DIFF[24] I1=n30 I2=n21
XU49 XOR2HS $PINS O=DIFF[25] I1=n29 I2=n22
XU50 XOR2HS $PINS O=DIFF[5] I1=n49 I2=n23
XU51 AN2 $PINS O=n23 I1=n50 I2=n3
XU52 XOR2HS $PINS O=DIFF[6] I1=n48 I2=n24
XU53 AN2T $PINS O=n24 I1=n49 I2=n23
XU55 AN2 $PINS O=n25 I1=n48 I2=n24
XU56 INV1S $PINS O=n46 I=B[8]
XU57 AN2 $PINS O=n26 I1=n47 I2=n25
XU58 INV1S $PINS O=n44 I=B[10]
XU59 INV1S $PINS O=n43 I=B[11]
XU60 INV1S $PINS O=n42 I=B[12]
XU61 INV1S $PINS O=n41 I=B[13]
XU62 INV1S $PINS O=n40 I=B[14]
XU63 INV1S $PINS O=n39 I=B[15]
XU64 INV1S $PINS O=n38 I=B[16]
XU65 INV1S $PINS O=n37 I=B[17]
XU66 INV1S $PINS O=n36 I=B[18]
XU67 INV1S $PINS O=n35 I=B[19]
XU68 INV1S $PINS O=n34 I=B[20]
XU69 INV1S $PINS O=n33 I=B[21]
XU70 INV1S $PINS O=n32 I=B[22]
XU71 INV1S $PINS O=n31 I=B[23]
XU72 INV1S $PINS O=n30 I=B[24]
XU73 INV1S $PINS O=n29 I=B[25]
XU74 INV1S $PINS O=n49 I=B[5]
XU76 INV1S $PINS O=n47 I=B[7]
XU77 XOR2HS $PINS O=DIFF[26] I1=B[26] I2=n28
XU1 XOR2H $PINS O=DIFF[2] I1=B[2] I2=n53
XU2 INV1S $PINS O=n51 I=B[3]
XU3 OR2 $PINS O=n53 I1=B[1] I2=B[0]
XU5 INV1S $PINS O=n50 I=B[4]
.ENDS

.SUBCKT PE_Shift_Add_1_DW01_add_2_DW01_add_28 A[26] A[25] A[24] A[23] A[22]
+ A[21] A[20] A[19] A[18] A[17] A[16] A[15] A[14] A[13] A[12] A[11] A[10] A[9]
+ A[8] A[7] A[6] A[5] A[4] A[3] A[2] A[1] A[0] B[26] B[25] B[24] B[23] B[22]
+ B[21] B[20] B[19] B[18] B[17] B[16] B[15] B[14] B[13] B[12] B[11] B[10] B[9]
+ B[8] B[7] B[6] B[5] B[4] B[3] B[2] B[1] B[0] CI SUM[26] SUM[25] SUM[24]
+ SUM[23] SUM[22] SUM[21] SUM[20] SUM[19] SUM[18] SUM[17] SUM[16] SUM[15]
+ SUM[14] SUM[13] SUM[12] SUM[11] SUM[10] SUM[9] SUM[8] SUM[7] SUM[6] SUM[5]
+ SUM[4] SUM[3] SUM[2] SUM[1] SUM[0] CO
XFE_RC_24_0 OR2 $PINS O=FE_RN_15_0 I1=FE_RN_1538_0 I2=FE_RN_1530_0
XFE_RC_23_0 ND2P $PINS O=carry[20] I1=FE_RN_1542_0 I2=FE_RN_15_0
XFE_OCPC1224_carry_14 BUF1CK $PINS O=FE_OCPN1224_carry_14 I=carry[14]
XFE_OCPC1160_carry_21 BUF1S $PINS O=FE_OCPN1160_carry_21 I=carry[21]
XFE_OCPC1149_carry_19 BUF1S $PINS O=FE_OCPN1149_carry_19 I=carry[19]
XFE_OCPC1091_N153 BUF2 $PINS O=FE_OCPN1091_N153 I=B[2]
XFE_OCPC1089_carry_3 BUF1 $PINS O=FE_OCPN1089_carry_3 I=carry[3]
XFE_OCPC1044_carry_7 BUF1 $PINS O=FE_OCPN1044_carry_7 I=carry[7]
XFE_OCPC916_carry_4 BUF1S $PINS O=FE_OCPN916_carry_4 I=carry[4]
XFE_RC_4022_0 XOR3 $PINS O=SUM[20] I1=A[20] I2=B[20] I3=carry[20]
XFE_RC_4021_0 MAO222 $PINS O=carry[21] A1=A[20] B1=B[20] C1=carry[20]
XFE_RC_4020_0 XOR3 $PINS O=SUM[1] I1=A[1] I2=B[1] I3=carry[1]
XFE_RC_4019_0 MAO222 $PINS O=carry[2] A1=A[1] B1=B[1] C1=carry[1]
XFE_RC_3895_0 MOAI1 $PINS O=SUM[15] A1=carry[15] A2=FE_RN_1117_0
+ B1=FE_RN_1116_0 B2=carry[15]
XFE_RC_3797_0 OR2 $PINS O=FE_RN_2489_0 I1=FE_RN_2428_0 I2=FE_RN_2427_0
XFE_RC_3796_0 ND2P $PINS O=carry[22] I1=FE_RN_2431_0 I2=FE_RN_2489_0
XFE_RC_3699_0 INV1S $PINS O=FE_RN_2421_0 I=carry[21]
XFE_RC_3698_0 XOR2HS $PINS O=FE_RN_2422_0 I1=A[21] I2=B[21]
XFE_RC_3697_0 ND2S $PINS O=FE_RN_2423_0 I1=FE_RN_2422_0 I2=FE_RN_2421_0
XFE_RC_3696_0 ND2 $PINS O=FE_RN_2424_0 I1=B[21] I2=A[21]
XFE_RC_3695_0 ND2S $PINS O=FE_RN_2425_0 I1=FE_RN_2424_0 I2=FE_RN_2430_0
XFE_RC_3694_0 ND2 $PINS O=FE_RN_2426_0 I1=FE_RN_2425_0 I2=FE_OCPN1160_carry_21
XFE_RC_3693_0 ND2 $PINS O=SUM[21] I1=FE_RN_2426_0 I2=FE_RN_2423_0
XFE_RC_3692_0 INV1S $PINS O=FE_RN_2427_0 I=A[21]
XFE_RC_3691_0 INV1S $PINS O=FE_RN_2428_0 I=B[21]
XFE_RC_3689_0 OR2B1S $PINS O=FE_RN_2430_0 I1=A[21] B1=FE_RN_2428_0
XFE_RC_3688_0 ND2 $PINS O=FE_RN_2431_0 I1=FE_RN_2430_0 I2=carry[21]
XFE_RC_3548_0 ND3P $PINS O=carry[14] I1=n15 I2=n14 I3=n16
XFE_RC_3480_0 AOI22S $PINS O=FE_RN_2226_0 A1=B[4] A2=A[4] B1=carry[4] B2=A[4]
XFE_RC_3418_0 ND2 $PINS O=FE_RN_2225_0 I1=carry[4] I2=B[4]
XFE_RC_3416_0 ND2P $PINS O=carry[5] I1=FE_RN_2226_0 I2=FE_RN_2225_0
XFE_RC_3138_0 INV1S $PINS O=FE_RN_2021_0 I=FE_RN_1738_0
XFE_RC_3137_0 OR2B1S $PINS O=FE_RN_2022_0 I1=FE_RN_1742_0 B1=FE_RN_2021_0
XFE_RC_3136_0 ND2P $PINS O=carry[19] I1=FE_RN_2022_0 I2=FE_RN_1746_0
XFE_RC_3086_0 INV1S $PINS O=FE_RN_1987_0 I=FE_RN_626_0
XFE_RC_3085_0 OR2B1S $PINS O=FE_RN_1988_0 I1=FE_RN_634_0 B1=FE_RN_1987_0
XFE_RC_3084_0 ND2P $PINS O=carry[18] I1=FE_RN_638_0 I2=FE_RN_1988_0
XFE_RC_2744_0 ND2 $PINS O=FE_RN_1735_0 I1=B[18] I2=A[18]
XFE_RC_2743_0 ND2 $PINS O=FE_RN_1736_0 I1=FE_RN_1735_0 I2=FE_RN_1745_0
XFE_RC_2742_0 INV1S $PINS O=FE_RN_1737_0 I=carry[18]
XFE_RC_2741_0 INV1S $PINS O=FE_RN_1738_0 I=B[18]
XFE_RC_2739_0 ND2 $PINS O=FE_RN_1740_0 I1=FE_RN_1738_0 I2=A[18]
XFE_RC_2738_0 OAI12HS $PINS O=FE_RN_1741_0 A1=FE_RN_1740_0 B1=FE_RN_1738_0
+ B2=A[18]
XFE_RC_2737_0 AO22 $PINS O=SUM[18] A1=FE_RN_1741_0 A2=FE_RN_1737_0
+ B1=FE_RN_1736_0 B2=carry[18]
XFE_RC_2736_0 INV1S $PINS O=FE_RN_1742_0 I=A[18]
XFE_RC_2733_0 OR2B1S $PINS O=FE_RN_1745_0 I1=A[18] B1=FE_RN_1738_0
XFE_RC_2732_0 ND2 $PINS O=FE_RN_1746_0 I1=FE_RN_1745_0 I2=carry[18]
XFE_RC_2468_0 INV1S $PINS O=FE_RN_1529_0 I=carry[19]
XFE_RC_2467_0 INV1S $PINS O=FE_RN_1530_0 I=B[19]
XFE_RC_2465_0 ND2 $PINS O=FE_RN_1532_0 I1=FE_RN_1530_0 I2=A[19]
XFE_RC_2464_0 OAI12HS $PINS O=FE_RN_1533_0 A1=FE_RN_1532_0 B1=FE_RN_1530_0
+ B2=A[19]
XFE_RC_2463_0 ND2S $PINS O=FE_RN_1534_0 I1=FE_RN_1533_0 I2=FE_RN_1529_0
XFE_RC_2462_0 ND2 $PINS O=FE_RN_1535_0 I1=B[19] I2=A[19]
XFE_RC_2461_0 ND2S $PINS O=FE_RN_1536_0 I1=FE_RN_1535_0 I2=FE_RN_1541_0
XFE_RC_2460_0 ND2 $PINS O=FE_RN_1537_0 I1=FE_RN_1536_0 I2=FE_OCPN1149_carry_19
XFE_RC_2459_0 ND2 $PINS O=SUM[19] I1=FE_RN_1537_0 I2=FE_RN_1534_0
XFE_RC_2458_0 INV1S $PINS O=FE_RN_1538_0 I=A[19]
XFE_RC_2455_0 OR2B1S $PINS O=FE_RN_1541_0 I1=A[19] B1=FE_RN_1530_0
XFE_RC_2454_0 ND2 $PINS O=FE_RN_1542_0 I1=FE_RN_1541_0 I2=carry[19]
XFE_RC_2263_0 INV1S $PINS O=FE_RN_1385_0 I=FE_RN_1216_0
XFE_RC_2262_0 OR2B1S $PINS O=FE_RN_1386_0 I1=FE_RN_1215_0 B1=FE_RN_1385_0
XFE_RC_2261_0 ND2 $PINS O=FE_RN_1387_0 I1=carry[14] I2=FE_RN_1214_0
XFE_RC_2260_0 ND2P $PINS O=carry[15] I1=FE_RN_1387_0 I2=FE_RN_1386_0
XFE_RC_2033_0 ND2 $PINS O=FE_RN_1211_0 I1=B[14] I2=A[14]
XFE_RC_2032_0 ND2 $PINS O=FE_RN_1212_0 I1=FE_RN_1211_0 I2=FE_RN_1214_0
XFE_RC_2031_0 XNR2HS $PINS O=FE_RN_1213_0 I1=A[14] I2=B[14]
XFE_RC_2030_0 MOAI1 $PINS O=SUM[14] A1=FE_RN_1213_0 A2=FE_OCPN1224_carry_14
+ B1=FE_RN_1212_0 B2=carry[14]
XFE_RC_2029_0 OR2 $PINS O=FE_RN_1214_0 I1=A[14] I2=B[14]
XFE_RC_2028_0 INV1S $PINS O=FE_RN_1215_0 I=A[14]
XFE_RC_2027_0 INV1S $PINS O=FE_RN_1216_0 I=B[14]
XFE_RC_1902_0 ND2 $PINS O=FE_RN_1115_0 I1=B[15] I2=A[15]
XFE_RC_1901_0 ND2 $PINS O=FE_RN_1116_0 I1=FE_RN_1119_0 I2=FE_RN_1115_0
XFE_RC_1900_0 XNR2HS $PINS O=FE_RN_1117_0 I1=A[15] I2=B[15]
XFE_RC_1897_0 OR2 $PINS O=FE_RN_1119_0 I1=A[15] I2=B[15]
XFE_RC_1896_0 ND2 $PINS O=FE_RN_1120_0 I1=FE_RN_1119_0 I2=carry[15]
XFE_RC_1895_0 ND2P $PINS O=carry[16] I1=FE_RN_1120_0 I2=FE_RN_1115_0
XFE_RC_1568_0 ND2 $PINS O=FE_RN_863_0 I1=carry[5] I2=B[5]
XFE_RC_1567_0 AOI22H $PINS O=FE_RN_864_0 A1=B[5] A2=A[5] B1=carry[5] B2=A[5]
XFE_RC_1566_0 ND2P $PINS O=carry[6] I1=FE_RN_864_0 I2=FE_RN_863_0
XFE_RC_1558_0 INV1S $PINS O=FE_RN_852_0 I=FE_RN_856_0
XFE_RC_1557_0 AOI12HS $PINS O=FE_RN_853_0 A1=FE_RN_852_0 B1=B[16] B2=A[16]
XFE_RC_1556_0 XNR2HS $PINS O=FE_RN_854_0 I1=A[16] I2=B[16]
XFE_RC_1555_0 MXL2HS $PINS OB=SUM[16] S=carry[16] A=FE_RN_854_0 B=FE_RN_853_0
XFE_RC_1554_0 ND2S $PINS O=FE_RN_855_0 I1=B[16] I2=A[16]
XFE_RC_1553_0 OR2 $PINS O=FE_RN_856_0 I1=A[16] I2=B[16]
XFE_RC_1552_0 ND2 $PINS O=FE_RN_857_0 I1=FE_RN_856_0 I2=carry[16]
XFE_RC_1551_0 ND2P $PINS O=carry[17] I1=FE_RN_857_0 I2=FE_RN_855_0
XFE_RC_1268_0 INV1S $PINS O=FE_RN_625_0 I=carry[17]
XFE_RC_1267_0 INV1S $PINS O=FE_RN_626_0 I=B[17]
XFE_RC_1265_0 ND2S $PINS O=FE_RN_628_0 I1=FE_RN_626_0 I2=A[17]
XFE_RC_1264_0 OAI12HS $PINS O=FE_RN_629_0 A1=FE_RN_628_0 B1=FE_RN_626_0
+ B2=A[17]
XFE_RC_1263_0 ND2S $PINS O=FE_RN_630_0 I1=FE_RN_629_0 I2=FE_RN_625_0
XFE_RC_1262_0 ND2S $PINS O=FE_RN_631_0 I1=B[17] I2=A[17]
XFE_RC_1261_0 ND2S $PINS O=FE_RN_632_0 I1=FE_RN_637_0 I2=FE_RN_631_0
XFE_RC_1260_0 ND2 $PINS O=FE_RN_633_0 I1=FE_RN_632_0 I2=carry[17]
XFE_RC_1259_0 ND2 $PINS O=SUM[17] I1=FE_RN_633_0 I2=FE_RN_630_0
XFE_RC_1258_0 INV1S $PINS O=FE_RN_634_0 I=A[17]
XFE_RC_1255_0 OR2B1S $PINS O=FE_RN_637_0 I1=A[17] B1=FE_RN_626_0
XFE_RC_1254_0 ND2 $PINS O=FE_RN_638_0 I1=FE_RN_637_0 I2=carry[17]
XFE_RC_1207_0 ND3P $PINS O=carry[4] I1=FE_RN_574_0 I2=FE_RN_573_0
+ I3=FE_RN_575_0
XFE_RC_1189_0 ND2 $PINS O=FE_RN_573_0 I1=A[3] I2=B[3]
XFE_RC_1188_0 ND2 $PINS O=FE_RN_574_0 I1=carry[3] I2=A[3]
XFE_RC_1187_0 ND2P $PINS O=FE_RN_575_0 I1=carry[3] I2=B[3]
XFE_RC_1011_0 OR2 $PINS O=FE_RN_443_0 I1=FE_RN_318_0 I2=FE_RN_317_0
XFE_RC_1010_0 ND2P $PINS O=carry[3] I1=FE_RN_443_0 I2=FE_RN_320_0
XFE_RC_850_0 INV1S $PINS O=FE_RN_311_0 I=carry[2]
XFE_RC_849_0 XOR2HS $PINS O=FE_RN_312_0 I1=A[2] I2=FE_OCPN1091_N153
XFE_RC_848_0 ND2S $PINS O=FE_RN_313_0 I1=FE_RN_312_0 I2=FE_RN_311_0
XFE_RC_847_0 ND2 $PINS O=FE_RN_314_0 I1=B[2] I2=A[2]
XFE_RC_846_0 ND2 $PINS O=FE_RN_315_0 I1=FE_RN_314_0 I2=FE_RN_319_0
XFE_RC_845_0 ND2 $PINS O=FE_RN_316_0 I1=FE_RN_315_0 I2=carry[2]
XFE_RC_844_0 ND2P $PINS O=SUM[2] I1=FE_RN_316_0 I2=FE_RN_313_0
XFE_RC_843_0 INV1S $PINS O=FE_RN_317_0 I=A[2]
XFE_RC_842_0 INV1S $PINS O=FE_RN_318_0 I=B[2]
XFE_RC_841_0 OR2T $PINS O=FE_RN_319_0 I1=A[2] I2=B[2]
XFE_RC_840_0 ND2P $PINS O=FE_RN_320_0 I1=carry[2] I2=FE_RN_319_0
XFE_RC_824_0 ND2 $PINS O=FE_RN_298_0 I1=carry[6] I2=B[6]
XFE_RC_823_0 AOI22H $PINS O=FE_RN_299_0 A1=B[6] A2=A[6] B1=carry[6] B2=A[6]
XFE_RC_822_0 ND2P $PINS O=carry[7] I1=FE_RN_299_0 I2=FE_RN_298_0
XFE_RC_679_0 XOR3 $PINS O=SUM[4] I1=A[4] I2=B[4] I3=FE_OCPN916_carry_4
XFE_RC_631_0 XOR3 $PINS O=SUM[3] I1=A[3] I2=B[3] I3=FE_OCPN1089_carry_3
XFE_RC_518_0 XOR3 $PINS O=SUM[5] I1=A[5] I2=B[5] I3=carry[5]
XFE_RC_446_0 XOR3 $PINS O=SUM[6] I1=A[6] I2=B[6] I3=carry[6]
XFE_RC_361_0 INV1S $PINS O=FE_RN_84_0 I=FE_RN_50_0
XFE_RC_360_0 OR2B1S $PINS O=FE_RN_85_0 I1=FE_RN_49_0 B1=FE_RN_84_0
XFE_RC_359_0 ND2P $PINS O=carry[8] I1=FE_RN_85_0 I2=FE_RN_52_0
XFE_RC_263_0 ND3P $PINS O=carry[10] I1=n6 I2=n7 I3=n8
XFE_RC_262_0 INV1S $PINS O=FE_RN_43_0 I=carry[7]
XFE_RC_261_0 XOR2HS $PINS O=FE_RN_44_0 I1=A[7] I2=B[7]
XFE_RC_260_0 ND2S $PINS O=FE_RN_45_0 I1=FE_RN_44_0 I2=FE_RN_43_0
XFE_RC_259_0 ND2 $PINS O=FE_RN_46_0 I1=B[7] I2=A[7]
XFE_RC_258_0 ND2 $PINS O=FE_RN_47_0 I1=FE_RN_46_0 I2=FE_RN_51_0
XFE_RC_257_0 ND2 $PINS O=FE_RN_48_0 I1=FE_RN_47_0 I2=FE_OCPN1044_carry_7
XFE_RC_256_0 ND2P $PINS O=SUM[7] I1=FE_RN_48_0 I2=FE_RN_45_0
XFE_RC_255_0 INV1S $PINS O=FE_RN_49_0 I=A[7]
XFE_RC_254_0 INV1S $PINS O=FE_RN_50_0 I=B[7]
XFE_RC_253_0 OR2 $PINS O=FE_RN_51_0 I1=A[7] I2=B[7]
XFE_RC_252_0 ND2P $PINS O=FE_RN_52_0 I1=FE_RN_51_0 I2=carry[7]
XFE_RC_198_0 ND3P $PINS O=carry[12] I1=n12 I2=n11 I3=n13
XFE_RC_196_0 XOR3 $PINS O=SUM[8] I1=A[8] I2=B[8] I3=carry[8]
XFE_RC_195_0 MAO222P $PINS O=carry[9] A1=carry[8] B1=B[8] C1=A[8]
XU1_26 XOR3 $PINS O=SUM[26] I1=A[26] I2=B[26] I3=carry[26]
XU1_24 FA1 $PINS S=SUM[24] CO=carry[25] A=A[24] B=B[24] CI=carry[24]
XU1_22 FA1 $PINS S=SUM[22] CO=carry[23] A=A[22] B=B[22] CI=carry[22]
XU1_12 FA1 $PINS S=SUM[12] CO=carry[13] A=A[12] B=B[12] CI=carry[12]
XU1_10 FA1 $PINS S=SUM[10] CO=carry[11] A=A[10] B=B[10] CI=carry[10]
XU1_25 FA1 $PINS S=SUM[25] CO=carry[26] A=A[25] B=B[25] CI=carry[25]
XU1 ND2 $PINS O=n3 I1=carry[23] I2=B[23]
XU2 ND2 $PINS O=n15 I1=carry[13] I2=B[13]
XU3 XOR3 $PINS O=SUM[13] I1=A[13] I2=B[13] I3=n10
XU4 MAO222 $PINS O=n1 A1=A[22] B1=B[22] C1=carry[22]
XU5 ND3P $PINS O=carry[24] I1=n3 I2=n2 I3=n4
XU7 XOR3 $PINS O=SUM[11] I1=A[11] I2=B[11] I3=n9
XU8 XOR3 $PINS O=SUM[23] I1=A[23] I2=B[23] I3=n1
XU9 ND2 $PINS O=n2 I1=n1 I2=A[23]
XU10 ND2 $PINS O=n4 I1=A[23] I2=B[23]
XU11 XOR2HS $PINS O=n5 I1=A[9] I2=B[9]
XU12 XOR2HS $PINS O=SUM[9] I1=carry[9] I2=n5
XU13 ND2 $PINS O=n6 I1=carry[9] I2=A[9]
XU14 ND2 $PINS O=n7 I1=carry[9] I2=B[9]
XU15 ND2S $PINS O=n8 I1=A[9] I2=B[9]
XU17 ND2 $PINS O=n12 I1=carry[11] I2=B[11]
XU18 MAO222 $PINS O=n9 A1=carry[10] B1=B[10] C1=A[10]
XU19 ND2 $PINS O=n16 I1=A[13] I2=B[13]
XU20 MAO222 $PINS O=n10 A1=carry[12] B1=B[12] C1=A[12]
XU22 ND2 $PINS O=n11 I1=n9 I2=A[11]
XU23 ND2 $PINS O=n13 I1=A[11] I2=B[11]
XU24 ND2 $PINS O=n14 I1=n10 I2=A[13]
XU25 XOR2HS $PINS O=SUM[0] I1=B[0] I2=A[0]
XU26 INV1S $PINS O=carry[1] I=n17
XU27 ND2 $PINS O=n17 I1=B[0] I2=A[0]
.ENDS

.SUBCKT PE_Shift_Add_1_DW01_add_1_DW01_add_27 A[26] A[25] A[24] A[23] A[22]
+ A[21] A[20] A[19] A[18] A[17] A[16] A[15] A[14] A[13] A[12] A[11] A[10] A[9]
+ A[8] A[7] A[6] A[5] A[4] A[3] A[2] A[1] A[0] B[26] B[25] B[24] B[23] B[22]
+ B[21] B[20] B[19] B[18] B[17] B[16] B[15] B[14] B[13] B[12] B[11] B[10] B[9]
+ B[8] B[7] B[6] B[5] B[4] B[3] B[2] B[1] B[0] CI SUM[26] SUM[25] SUM[24]
+ SUM[23] SUM[22] SUM[21] SUM[20] SUM[19] SUM[18] SUM[17] SUM[16] SUM[15]
+ SUM[14] SUM[13] SUM[12] SUM[11] SUM[10] SUM[9] SUM[8] SUM[7] SUM[6] SUM[5]
+ SUM[4] SUM[3] SUM[2] SUM[1] SUM[0] CO
XFE_RC_281_0 ND3P $PINS O=carry[2] I1=n14 I2=n13 I3=n15
XFE_OCPC1167_carry_4 BUF1S $PINS O=FE_OCPN1167_carry_4 I=carry[4]
XFE_OCPC1162_carry_5 BUF1S $PINS O=FE_OCPN1162_carry_5 I=carry[5]
XFE_OCPC1158_carry_3 BUF1S $PINS O=FE_OCPN1158_carry_3 I=carry[3]
XFE_OCPC1150_carry_6 BUF1S $PINS O=FE_OCPN1150_carry_6 I=carry[6]
XFE_OCPC1076_carry_9 BUF1S $PINS O=FE_OCPN1076_carry_9 I=carry[9]
XFE_OCPC1070_carry_8 BUF1S $PINS O=FE_OCPN1070_carry_8 I=carry[8]
XFE_OCPC1061_carry_22 BUF1S $PINS O=FE_OCPN1061_carry_22 I=carry[22]
XFE_OCPC1059_carry_23 BUF1S $PINS O=FE_OCPN1059_carry_23 I=carry[23]
XFE_OCPC1027_carry_10 BUF1CK $PINS O=FE_OCPN1027_carry_10 I=carry[10]
XFE_OCPC1012_carry_19 BUF1S $PINS O=FE_OCPN1012_carry_19 I=carry[19]
XFE_OCPC991_carry_19 BUF1S $PINS O=FE_OCPN991_carry_19 I=carry[19]
XFE_RC_3968_0 MAO222 $PINS O=carry[26] A1=A[25] B1=B[25] C1=carry[25]
XFE_RC_3967_0 XOR3 $PINS O=SUM[25] I1=A[25] I2=B[25] I3=carry[25]
XFE_RC_3849_0 INV1S $PINS O=FE_RN_2515_0 I=A[23]
XFE_RC_3848_0 NR2 $PINS O=FE_RN_2516_0 I1=B[23] I2=FE_RN_2515_0
XFE_RC_3847_0 AN2B1S $PINS O=FE_RN_2517_0 I1=B[23] B1=A[23]
XFE_RC_3846_0 INV1S $PINS O=FE_RN_2518_0 I=carry[23]
XFE_RC_3845_0 OAI12HS $PINS O=FE_RN_2519_0 A1=FE_RN_2518_0 B1=FE_RN_2517_0
+ B2=FE_RN_2516_0
XFE_RC_3844_0 ND2 $PINS O=FE_RN_2520_0 I1=A[23] I2=B[23]
XFE_RC_3843_0 ND2 $PINS O=FE_RN_2521_0 I1=FE_RN_2520_0 I2=FE_RN_2525_0
XFE_RC_3842_0 ND2 $PINS O=FE_RN_2522_0 I1=FE_RN_2521_0 I2=FE_OCPN1059_carry_23
XFE_RC_3841_0 ND2 $PINS O=SUM[23] I1=FE_RN_2522_0 I2=FE_RN_2519_0
XFE_RC_3838_0 OR2B1 $PINS O=FE_RN_2525_0 I1=B[23] B1=FE_RN_2515_0
XFE_RC_3837_0 ND2 $PINS O=FE_RN_2526_0 I1=FE_RN_2525_0 I2=carry[23]
XFE_RC_3836_0 ND2 $PINS O=carry[24] I1=FE_RN_2526_0 I2=FE_RN_2520_0
XFE_RC_3823_0 INV1S $PINS O=FE_RN_2496_0 I=A[21]
XFE_RC_3821_0 ND2 $PINS O=FE_RN_2498_0 I1=FE_RN_2496_0 I2=B[21]
XFE_RC_3820_0 OAI12HS $PINS O=FE_RN_2499_0 A1=FE_RN_2498_0 B1=FE_RN_2496_0
+ B2=B[21]
XFE_RC_3819_0 OR2B1S $PINS O=FE_RN_2500_0 I1=carry[21] B1=FE_RN_2499_0
XFE_RC_3818_0 ND2 $PINS O=FE_RN_2501_0 I1=A[21] I2=B[21]
XFE_RC_3817_0 ND2 $PINS O=FE_RN_2502_0 I1=FE_RN_2501_0 I2=FE_RN_2506_0
XFE_RC_3816_0 ND2 $PINS O=FE_RN_2503_0 I1=FE_RN_2502_0 I2=carry[21]
XFE_RC_3815_0 ND2 $PINS O=SUM[21] I1=FE_RN_2503_0 I2=FE_RN_2500_0
XFE_RC_3812_0 OR2B1 $PINS O=FE_RN_2506_0 I1=B[21] B1=FE_RN_2496_0
XFE_RC_3811_0 ND2 $PINS O=FE_RN_2507_0 I1=FE_RN_2506_0 I2=carry[21]
XFE_RC_3810_0 ND2 $PINS O=carry[22] I1=FE_RN_2507_0 I2=FE_RN_2501_0
XFE_RC_3711_0 ND3P $PINS O=carry[9] I1=n11 I2=n12 I3=n10
XFE_RC_3599_0 INV1S $PINS O=FE_RN_2343_0 I=B[22]
XFE_RC_3598_0 INV1S $PINS O=FE_RN_2344_0 I=A[22]
XFE_RC_3597_0 AOI22S $PINS O=FE_RN_2345_0 A1=FE_RN_2344_0 A2=B[22] B1=A[22]
+ B2=FE_RN_2343_0
XFE_RC_3596_0 ND2 $PINS O=FE_RN_2346_0 I1=A[22] I2=B[22]
XFE_RC_3595_0 ND2 $PINS O=FE_RN_2347_0 I1=FE_RN_2346_0 I2=FE_RN_2352_0
XFE_RC_3594_0 ND2 $PINS O=FE_RN_2348_0 I1=FE_RN_2347_0 I2=carry[22]
XFE_RC_3593_0 OAI12HS $PINS O=SUM[22] A1=FE_RN_2348_0 B1=FE_RN_2345_0
+ B2=FE_OCPN1061_carry_22
XFE_RC_3589_0 ND2 $PINS O=FE_RN_2352_0 I1=FE_RN_2344_0 I2=FE_RN_2343_0
XFE_RC_3588_0 ND2 $PINS O=FE_RN_2353_0 I1=FE_RN_2352_0 I2=carry[22]
XFE_RC_3587_0 ND2 $PINS O=carry[23] I1=FE_RN_2353_0 I2=FE_RN_2346_0
XFE_RC_3552_0 ND2 $PINS O=FE_RN_2317_0 I1=carry[16] I2=B[16]
XFE_RC_3551_0 AOI22S $PINS O=FE_RN_2318_0 A1=B[16] A2=A[16] B1=carry[16]
+ B2=A[16]
XFE_RC_3550_0 ND2P $PINS O=carry[17] I1=FE_RN_2318_0 I2=FE_RN_2317_0
XFE_RC_3524_0 ND3P $PINS O=carry[8] I1=n7 I2=n8 I3=n6
XFE_RC_3475_0 INV1S $PINS O=FE_RN_2268_0 I=FE_RN_1880_0
XFE_RC_3474_0 OR2B1S $PINS O=FE_RN_2269_0 I1=FE_RN_1887_0 B1=FE_RN_2268_0
XFE_RC_3473_0 ND2P $PINS O=carry[20] I1=FE_RN_1892_0 I2=FE_RN_2269_0
XFE_RC_3251_0 INV1S $PINS O=FE_RN_2091_0 I=B[20]
XFE_RC_3250_0 INV1S $PINS O=FE_RN_2092_0 I=A[20]
XFE_RC_3249_0 AOI22S $PINS O=FE_RN_2093_0 A1=FE_RN_2092_0 A2=B[20] B1=A[20]
+ B2=FE_RN_2091_0
XFE_RC_3248_0 ND2 $PINS O=FE_RN_2094_0 I1=A[20] I2=B[20]
XFE_RC_3247_0 ND2S $PINS O=FE_RN_2095_0 I1=FE_RN_2094_0 I2=FE_RN_2100_0
XFE_RC_3246_0 ND2 $PINS O=FE_RN_2096_0 I1=FE_RN_2095_0 I2=carry[20]
XFE_RC_3245_0 OAI12HS $PINS O=SUM[20] A1=FE_RN_2096_0 B1=FE_RN_2093_0
+ B2=carry[20]
XFE_RC_3241_0 ND2S $PINS O=FE_RN_2100_0 I1=FE_RN_2092_0 I2=FE_RN_2091_0
XFE_RC_3240_0 ND2 $PINS O=FE_RN_2101_0 I1=FE_RN_2100_0 I2=carry[20]
XFE_RC_3239_0 ND2 $PINS O=carry[21] I1=FE_RN_2101_0 I2=FE_RN_2094_0
XFE_RC_3116_0 ND2 $PINS O=FE_RN_2007_0 I1=carry[4] I2=B[4]
XFE_RC_3115_0 AOI22H $PINS O=FE_RN_2008_0 A1=B[4] A2=A[4] B1=carry[4] B2=A[4]
XFE_RC_3114_0 ND2P $PINS O=carry[5] I1=FE_RN_2008_0 I2=FE_RN_2007_0
XFE_RC_3112_0 MOAI1 $PINS O=carry[19] A1=FE_RN_592_0 A2=FE_RN_594_0 B1=B[18]
+ B2=A[18]
XFE_RC_2949_0 INV1S $PINS O=FE_RN_1880_0 I=A[19]
XFE_RC_2947_0 NR2 $PINS O=FE_RN_1882_0 I1=B[19] I2=FE_RN_1880_0
XFE_RC_2946_0 AOI12HS $PINS O=FE_RN_1883_0 A1=FE_RN_1882_0 B1=FE_RN_1880_0
+ B2=B[19]
XFE_RC_2945_0 ND2 $PINS O=FE_RN_1884_0 I1=A[19] I2=B[19]
XFE_RC_2944_0 ND2S $PINS O=FE_RN_1885_0 I1=FE_RN_1884_0 I2=FE_RN_1891_0
XFE_RC_2943_0 ND2 $PINS O=FE_RN_1886_0 I1=FE_RN_1885_0 I2=FE_OCPN1012_carry_19
XFE_RC_2942_0 OAI12HS $PINS O=SUM[19] A1=FE_RN_1886_0 B1=FE_RN_1883_0
+ B2=FE_OCPN991_carry_19
XFE_RC_2941_0 INV1S $PINS O=FE_RN_1887_0 I=B[19]
XFE_RC_2937_0 ND2 $PINS O=FE_RN_1891_0 I1=FE_RN_1880_0 I2=FE_RN_1887_0
XFE_RC_2936_0 ND2 $PINS O=FE_RN_1892_0 I1=FE_RN_1891_0 I2=carry[19]
XFE_RC_2906_0 ND2 $PINS O=FE_RN_1856_0 I1=carry[3] I2=B[3]
XFE_RC_2905_0 AOI22H $PINS O=FE_RN_1857_0 A1=B[3] A2=A[3] B1=carry[3] B2=A[3]
XFE_RC_2904_0 ND2P $PINS O=carry[4] I1=FE_RN_1857_0 I2=FE_RN_1856_0
XFE_RC_2747_0 ND2 $PINS O=FE_RN_1747_0 I1=carry[13] I2=B[13]
XFE_RC_2746_0 AOI22H $PINS O=FE_RN_1748_0 A1=B[13] A2=A[13] B1=carry[13]
+ B2=A[13]
XFE_RC_2745_0 ND2P $PINS O=carry[14] I1=FE_RN_1748_0 I2=FE_RN_1747_0
XFE_RC_2708_0 ND2 $PINS O=FE_RN_1715_0 I1=carry[5] I2=B[5]
XFE_RC_2707_0 AOI22H $PINS O=FE_RN_1716_0 A1=B[5] A2=A[5] B1=carry[5] B2=A[5]
XFE_RC_2706_0 ND2P $PINS O=carry[6] I1=FE_RN_1716_0 I2=FE_RN_1715_0
XFE_RC_2539_0 ND2 $PINS O=FE_RN_1592_0 I1=carry[10] I2=B[10]
XFE_RC_2538_0 AOI22H $PINS O=FE_RN_1593_0 A1=B[10] A2=A[10] B1=carry[10]
+ B2=A[10]
XFE_RC_2537_0 ND2P $PINS O=carry[11] I1=FE_RN_1593_0 I2=FE_RN_1592_0
XFE_RC_2507_0 ND2 $PINS O=FE_RN_1566_0 I1=carry[6] I2=B[6]
XFE_RC_2506_0 AOI22S $PINS O=FE_RN_1567_0 A1=B[6] A2=A[6] B1=carry[6] B2=A[6]
XFE_RC_2505_0 ND2P $PINS O=carry[7] I1=FE_RN_1567_0 I2=FE_RN_1566_0
XFE_RC_2287_0 ND2P $PINS O=FE_RN_1402_0 I1=carry[11] I2=B[11]
XFE_RC_2286_0 AOI22H $PINS O=FE_RN_1403_0 A1=B[11] A2=A[11] B1=carry[11]
+ B2=A[11]
XFE_RC_2285_0 ND2P $PINS O=carry[12] I1=FE_RN_1403_0 I2=FE_RN_1402_0
XFE_RC_2284_0 ND2 $PINS O=FE_RN_1400_0 I1=carry[14] I2=B[14]
XFE_RC_2283_0 AOI22S $PINS O=FE_RN_1401_0 A1=B[14] A2=A[14] B1=carry[14]
+ B2=A[14]
XFE_RC_2282_0 ND2P $PINS O=carry[15] I1=FE_RN_1401_0 I2=FE_RN_1400_0
XFE_RC_2115_0 ND2 $PINS O=FE_RN_1278_0 I1=carry[12] I2=B[12]
XFE_RC_2114_0 AOI22H $PINS O=FE_RN_1279_0 A1=B[12] A2=A[12] B1=carry[12]
+ B2=A[12]
XFE_RC_2113_0 ND2P $PINS O=carry[13] I1=FE_RN_1279_0 I2=FE_RN_1278_0
XFE_RC_1702_0 AN2 $PINS O=FE_RN_959_0 I1=A[17] I2=B[17]
XFE_RC_1701_0 AN2B1S $PINS O=FE_RN_960_0 I1=FE_RN_963_0 B1=FE_RN_959_0
XFE_RC_1700_0 XNR2HS $PINS O=FE_RN_961_0 I1=B[17] I2=A[17]
XFE_RC_1699_0 MXL2HS $PINS OB=SUM[17] S=carry[17] A=FE_RN_961_0 B=FE_RN_960_0
XFE_RC_1698_0 ND2 $PINS O=FE_RN_962_0 I1=A[17] I2=B[17]
XFE_RC_1697_0 OR2 $PINS O=FE_RN_963_0 I1=B[17] I2=A[17]
XFE_RC_1696_0 ND2 $PINS O=FE_RN_964_0 I1=FE_RN_963_0 I2=carry[17]
XFE_RC_1695_0 ND2 $PINS O=carry[18] I1=FE_RN_964_0 I2=FE_RN_962_0
XFE_RC_1215_0 AN2 $PINS O=FE_RN_589_0 I1=A[18] I2=B[18]
XFE_RC_1214_0 AN2B1S $PINS O=FE_RN_590_0 I1=FE_RN_593_0 B1=FE_RN_589_0
XFE_RC_1213_0 XNR2HS $PINS O=FE_RN_591_0 I1=B[18] I2=A[18]
XFE_RC_1212_0 MXL2HS $PINS OB=SUM[18] S=carry[18] A=FE_RN_591_0 B=FE_RN_590_0
XFE_RC_1211_0 INV1S $PINS O=FE_RN_592_0 I=carry[18]
XFE_RC_1210_0 OR2 $PINS O=FE_RN_593_0 I1=B[18] I2=A[18]
XFE_RC_1209_0 INV1S $PINS O=FE_RN_594_0 I=FE_RN_593_0
XFE_RC_1206_0 OAI12H $PINS O=FE_RN_377_0 A1=B[2] B1=carry[2] B2=A[2]
XFE_RC_927_0 INV1S $PINS O=FE_RN_374_0 I=B[2]
XFE_RC_926_0 XOR2HS $PINS O=FE_RN_375_0 I1=carry[2] I2=A[2]
XFE_RC_925_0 MXL2HS $PINS OB=SUM[2] S=FE_RN_375_0 A=FE_RN_374_0 B=B[2]
XFE_RC_924_0 ND2 $PINS O=FE_RN_376_0 I1=A[2] I2=carry[2]
XFE_RC_922_0 ND2P $PINS O=carry[3] I1=FE_RN_377_0 I2=FE_RN_376_0
XFE_RC_918_0 ND3P $PINS O=carry[16] I1=n3 I2=n4 I3=n5
XFE_RC_737_0 XOR3 $PINS O=SUM[16] I1=A[16] I2=B[16] I3=carry[16]
XFE_RC_729_0 XOR3 $PINS O=SUM[3] I1=A[3] I2=B[3] I3=FE_OCPN1158_carry_3
XFE_RC_589_0 ND3P $PINS O=carry[10] I1=n18 I2=n17 I3=n19
XFE_RC_582_0 XOR3 $PINS O=SUM[4] I1=A[4] I2=B[4] I3=FE_OCPN1167_carry_4
XFE_RC_507_0 XOR3 $PINS O=SUM[10] I1=A[10] I2=B[10] I3=FE_OCPN1027_carry_10
XFE_RC_444_0 XOR3 $PINS O=SUM[11] I1=A[11] I2=B[11] I3=carry[11]
XFE_RC_442_0 XOR3 $PINS O=SUM[5] I1=A[5] I2=B[5] I3=FE_OCPN1162_carry_5
XFE_RC_306_0 XOR3 $PINS O=SUM[12] I1=A[12] I2=B[12] I3=carry[12]
XFE_RC_222_0 XOR3 $PINS O=SUM[13] I1=A[13] I2=B[13] I3=carry[13]
XFE_RC_219_0 XOR3 $PINS O=SUM[6] I1=A[6] I2=B[6] I3=FE_OCPN1150_carry_6
XFE_RC_122_0 XOR3 $PINS O=SUM[14] I1=A[14] I2=B[14] I3=carry[14]
XU1_26 XOR3 $PINS O=SUM[26] I1=A[26] I2=B[26] I3=carry[26]
XU1_24 FA1 $PINS S=SUM[24] CO=carry[25] A=A[24] B=B[24] CI=carry[24]
XU1 ND2 $PINS O=n6 I1=A[7] I2=B[7]
XU4 AN2 $PINS O=n1 I1=B[0] I2=A[0]
XU5 XOR2HS $PINS O=n2 I1=B[15] I2=A[15]
XU6 XOR2HS $PINS O=SUM[15] I1=carry[15] I2=n2
XU7 ND2 $PINS O=n3 I1=carry[15] I2=B[15]
XU8 ND2 $PINS O=n4 I1=carry[15] I2=A[15]
XU9 ND2S $PINS O=n5 I1=B[15] I2=A[15]
XU10 XOR3 $PINS O=SUM[7] I1=A[7] I2=B[7] I3=carry[7]
XU11 ND2 $PINS O=n7 I1=A[7] I2=carry[7]
XU12 ND2 $PINS O=n8 I1=carry[7] I2=B[7]
XU14 XOR2HS $PINS O=n9 I1=A[8] I2=B[8]
XU15 XOR2HS $PINS O=SUM[8] I1=n9 I2=FE_OCPN1070_carry_8
XU16 ND2 $PINS O=n10 I1=A[8] I2=B[8]
XU17 ND2 $PINS O=n11 I1=carry[8] I2=A[8]
XU18 ND2 $PINS O=n12 I1=carry[8] I2=B[8]
XU20 XOR3 $PINS O=SUM[1] I1=n1 I2=A[1] I3=B[1]
XU21 ND2 $PINS O=n13 I1=B[1] I2=n1
XU22 ND2 $PINS O=n14 I1=B[1] I2=A[1]
XU23 ND2S $PINS O=n15 I1=n1 I2=A[1]
XU25 ND2S $PINS O=n19 I1=B[9] I2=A[9]
XU26 XOR2HS $PINS O=n16 I1=B[9] I2=A[9]
XU27 XOR2HS $PINS O=SUM[9] I1=FE_OCPN1076_carry_9 I2=n16
XU28 ND2 $PINS O=n17 I1=carry[9] I2=B[9]
XU29 ND2 $PINS O=n18 I1=carry[9] I2=A[9]
XU30 XOR2HS $PINS O=SUM[0] I1=B[0] I2=A[0]
.ENDS

.SUBCKT PE_Shift_Add_1_DW01_add_0_DW01_add_26 A[26] A[25] A[24] A[23] A[22]
+ A[21] A[20] A[19] A[18] A[17] A[16] A[15] A[14] A[13] A[12] A[11] A[10] A[9]
+ A[8] A[7] A[6] A[5] A[4] A[3] A[2] A[1] A[0] B[26] B[25] B[24] B[23] B[22]
+ B[21] B[20] B[19] B[18] B[17] B[16] B[15] B[14] B[13] B[12] B[11] B[10] B[9]
+ B[8] B[7] B[6] B[5] B[4] B[3] B[2] B[1] B[0] CI SUM[26] SUM[25] SUM[24]
+ SUM[23] SUM[22] SUM[21] SUM[20] SUM[19] SUM[18] SUM[17] SUM[16] SUM[15]
+ SUM[14] SUM[13] SUM[12] SUM[11] SUM[10] SUM[9] SUM[8] SUM[7] SUM[6] SUM[5]
+ SUM[4] SUM[3] SUM[2] SUM[1] SUM[0] CO
XFE_PHC1784_FE_RN_1704_0 BUF1CK $PINS O=FE_RN_1704_0 I=FE_PHN1784_FE_RN_1704_0
XFE_RC_61_0 ND3 $PINS O=carry[24] I1=n14 I2=n13 I3=n12
XFE_OCPC1214_FE_RN_275_0 BUF1S $PINS O=FE_OCPN1214_FE_RN_275_0 I=FE_RN_275_0
XFE_OCPC1178_N180 BUF1S $PINS O=FE_OCPN1178_N180 I=A[2]
XFE_OCPC1165_carry_6 BUF1S $PINS O=FE_OCPN1165_carry_6 I=carry[6]
XFE_OCPC1164_N213 BUF1S $PINS O=FE_OCPN1164_N213 I=B[8]
XFE_OCPC1138_N191 BUF1S $PINS O=FE_OCPN1138_N191 I=A[13]
XFE_OCPC1120_N186 BUF1 $PINS O=FE_OCPN1120_N186 I=A[8]
XFE_OCPC1110_N202 BUF1CK $PINS O=FE_OCPN1110_N202 I=A[24]
XFE_OCPC1084_carry_5 BUF1S $PINS O=FE_OCPN1084_carry_5 I=carry[5]
XFE_OCPC1051_carry_4 BUF1S $PINS O=FE_OCPN1051_carry_4 I=carry[4]
XFE_OCPC1025_carry_17 BUF1S $PINS O=FE_OCPN1025_carry_17 I=carry[17]
XFE_OCPC1024_carry_7 BUF1S $PINS O=FE_OCPN1024_carry_7 I=carry[7]
XFE_OCPC1015_carry_22 BUF1S $PINS O=FE_OCPN1015_carry_22 I=carry[22]
XFE_OCPC998_carry_8 BUF1S $PINS O=FE_OCPN998_carry_8 I=carry[8]
XFE_OCPC932_carry_11 BUF1S $PINS O=FE_OCPN932_carry_11 I=carry[11]
XFE_OCPC931_N186 BUF1S $PINS O=FE_OCPN931_N186 I=A[8]
XFE_RC_3930_0 AOI22H $PINS O=FE_RN_1901_0 A1=A[11] A2=B[11] B1=carry[11]
+ B2=A[11]
XFE_RC_3929_0 ND3P $PINS O=carry[13] I1=n17 I2=n16 I3=n18
XFE_RC_3903_0 ND3P $PINS O=carry[4] I1=n2 I2=n3 I3=n4
XFE_RC_3755_0 INV1S $PINS O=FE_RN_2466_0 I=FE_RN_2115_0
XFE_RC_3754_0 OR2B1S $PINS O=FE_RN_2467_0 I1=FE_RN_2123_0 B1=FE_RN_2466_0
XFE_RC_3753_0 ND2S $PINS O=carry[2] I1=FE_RN_2467_0 I2=FE_RN_2128_0
XFE_OCPC492_carry_9 BUF1S $PINS O=FE_OCPN492_carry_9 I=carry[9]
XFE_OCPC491_carry_24 BUF1S $PINS O=FE_OCPN491_carry_24 I=carry[24]
XFE_OCPC484_carry_10 BUF1S $PINS O=FE_OCPN484_carry_10 I=carry[10]
XFE_OCPC386_carry_20 BUF1S $PINS O=FE_OCPN386_carry_20 I=carry[20]
XFE_OCPC383_carry_12 BUF1S $PINS O=FE_OCPN383_carry_12 I=carry[12]
XFE_OCPC381_carry_15 BUF1S $PINS O=FE_OCPN381_carry_15 I=carry[15]
XFE_OCPC303_carry_23 BUF1S $PINS O=FE_OCPN303_carry_23 I=carry[23]
XFE_OCPC281_carry_18 BUF1S $PINS O=FE_OCPN281_carry_18 I=carry[18]
XFE_OCPC280_carry_16 BUF1S $PINS O=FE_OCPN280_carry_16 I=carry[16]
XFE_OCPC265_carry_13 BUF1S $PINS O=FE_OCPN265_carry_13 I=carry[13]
XFE_OCPC246_carry_19 BUF1S $PINS O=FE_OCPN246_carry_19 I=carry[19]
XFE_OCPC244_carry_21 BUF1S $PINS O=FE_OCPN244_carry_21 I=carry[21]
XFE_RC_3285_0 INV1S $PINS O=FE_RN_2115_0 I=n1
XFE_RC_3283_0 ND2 $PINS O=FE_RN_2117_0 I1=FE_RN_2115_0 I2=B[1]
XFE_RC_3282_0 OAI12HS $PINS O=FE_RN_2118_0 A1=FE_RN_2117_0 B1=FE_RN_2115_0
+ B2=B[1]
XFE_RC_3281_0 OR2B1S $PINS O=FE_RN_2119_0 I1=A[1] B1=FE_RN_2118_0
XFE_RC_3280_0 ND2 $PINS O=FE_RN_2120_0 I1=n1 I2=B[1]
XFE_RC_3279_0 ND2 $PINS O=FE_RN_2121_0 I1=FE_RN_2120_0 I2=FE_RN_2127_0
XFE_RC_3278_0 ND2 $PINS O=FE_RN_2122_0 I1=FE_RN_2121_0 I2=A[1]
XFE_RC_3277_0 ND2 $PINS O=SUM[1] I1=FE_RN_2122_0 I2=FE_RN_2119_0
XFE_RC_3276_0 INV1S $PINS O=FE_RN_2123_0 I=B[1]
XFE_RC_3272_0 ND2 $PINS O=FE_RN_2127_0 I1=FE_RN_2115_0 I2=FE_RN_2123_0
XFE_RC_3271_0 ND2 $PINS O=FE_RN_2128_0 I1=FE_RN_2127_0 I2=A[1]
XFE_RC_3198_0 ND2 $PINS O=FE_RN_2062_0 I1=carry[10] I2=B[10]
XFE_RC_3197_0 AOI22H $PINS O=FE_RN_2063_0 A1=B[10] A2=A[10] B1=carry[10]
+ B2=A[10]
XFE_RC_3196_0 ND2P $PINS O=carry[11] I1=FE_RN_2063_0 I2=FE_RN_2062_0
XFE_RC_3060_0 OR2 $PINS O=FE_RN_1971_0 I1=FE_RN_1710_0 I2=FE_RN_1709_0
XFE_RC_3059_0 ND2P $PINS O=carry[3] I1=FE_RN_1712_0 I2=FE_RN_1971_0
XFE_RC_2961_0 ND2 $PINS O=FE_RN_1900_0 I1=carry[11] I2=B[11]
XFE_RC_2959_0 ND2P $PINS O=carry[12] I1=FE_RN_1901_0 I2=FE_RN_1900_0
XFE_RC_2704_0 ND2 $PINS O=FE_RN_1713_0 I1=carry[21] I2=B[21]
XFE_RC_2703_0 AOI22H $PINS O=FE_RN_1714_0 A1=A[21] A2=B[21] B1=carry[21]
+ B2=A[21]
XFE_RC_2702_0 ND2P $PINS O=carry[22] I1=FE_RN_1714_0 I2=FE_RN_1713_0
XFE_RC_2701_0 INV1S $PINS O=FE_RN_1703_0 I=carry[2]
XFE_RC_2700_0 XOR2HS $PINS O=FE_PHN1784_FE_RN_1704_0 I1=FE_OCPN1178_N180
+ I2=B[2]
XFE_RC_2699_0 ND2S $PINS O=FE_RN_1705_0 I1=FE_RN_1704_0 I2=FE_RN_1703_0
XFE_RC_2698_0 ND2 $PINS O=FE_RN_1706_0 I1=B[2] I2=FE_OCPN1178_N180
XFE_RC_2697_0 ND2 $PINS O=FE_RN_1707_0 I1=FE_RN_1706_0 I2=FE_RN_1711_0
XFE_RC_2696_0 ND2 $PINS O=FE_RN_1708_0 I1=FE_RN_1707_0 I2=carry[2]
XFE_RC_2695_0 ND2S $PINS O=SUM[2] I1=FE_RN_1708_0 I2=FE_RN_1705_0
XFE_RC_2694_0 INV1S $PINS O=FE_RN_1709_0 I=A[2]
XFE_RC_2693_0 INV1S $PINS O=FE_RN_1710_0 I=B[2]
XFE_RC_2692_0 OR2P $PINS O=FE_RN_1711_0 I1=A[2] I2=B[2]
XFE_RC_2691_0 ND2P $PINS O=FE_RN_1712_0 I1=FE_RN_1711_0 I2=carry[2]
XFE_RC_2665_0 ND2 $PINS O=FE_RN_1683_0 I1=carry[9] I2=B[9]
XFE_RC_2664_0 AOI22H $PINS O=FE_RN_1684_0 A1=A[9] A2=B[9] B1=carry[9] B2=A[9]
XFE_RC_2663_0 ND2P $PINS O=carry[10] I1=FE_RN_1684_0 I2=FE_RN_1683_0
XFE_RC_2493_0 ND2 $PINS O=FE_RN_1556_0 I1=carry[13] I2=B[13]
XFE_RC_2492_0 AOI22H $PINS O=FE_RN_1557_0 A1=B[13] A2=A[13] B1=carry[13]
+ B2=A[13]
XFE_RC_2491_0 ND2P $PINS O=n15 I1=FE_RN_1557_0 I2=FE_RN_1556_0
XFE_RC_2476_0 ND3HT $PINS O=carry[21] I1=FE_RN_1444_0 I2=FE_RN_1445_0
+ I3=FE_RN_1443_0
XFE_RC_2344_0 ND2 $PINS O=FE_RN_1443_0 I1=A[20] I2=B[20]
XFE_RC_2343_0 ND2P $PINS O=FE_RN_1444_0 I1=carry[20] I2=A[20]
XFE_RC_2342_0 ND2P $PINS O=FE_RN_1445_0 I1=carry[20] I2=B[20]
XFE_RC_2211_0 ND2 $PINS O=FE_RN_1345_0 I1=carry[16] I2=B[16]
XFE_RC_2210_0 AOI22H $PINS O=FE_RN_1346_0 A1=B[16] A2=A[16] B1=carry[16]
+ B2=A[16]
XFE_RC_2209_0 ND2P $PINS O=carry[17] I1=FE_RN_1346_0 I2=FE_RN_1345_0
XFE_RC_2204_0 ND2P $PINS O=FE_RN_1341_0 I1=carry[5] I2=B[5]
XFE_RC_2203_0 AOI22H $PINS O=FE_RN_1342_0 A1=A[5] A2=B[5] B1=carry[5] B2=A[5]
XFE_RC_2202_0 ND2P $PINS O=carry[6] I1=FE_RN_1342_0 I2=FE_RN_1341_0
XFE_RC_2179_0 ND2P $PINS O=FE_RN_1322_0 I1=carry[18] I2=B[18]
XFE_RC_2178_0 AOI22H $PINS O=FE_RN_1323_0 A1=A[18] A2=B[18] B1=carry[18]
+ B2=A[18]
XFE_RC_2177_0 ND2P $PINS O=carry[19] I1=FE_RN_1323_0 I2=FE_RN_1322_0
XFE_RC_2034_0 OAI12H $PINS O=FE_RN_1124_0 A1=A[4] B1=carry[4] B2=B[4]
XFE_RC_2009_0 AOI22H $PINS O=FE_RN_1086_0 A1=B[17] A2=A[17] B1=carry[17]
+ B2=A[17]
XFE_RC_1908_0 INV1S $PINS O=FE_RN_1121_0 I=A[4]
XFE_RC_1907_0 XOR2HS $PINS O=FE_RN_1122_0 I1=FE_OCPN1051_carry_4 I2=B[4]
XFE_RC_1906_0 MXL2HS $PINS OB=SUM[4] S=FE_RN_1122_0 A=FE_RN_1121_0 B=A[4]
XFE_RC_1905_0 ND2 $PINS O=FE_RN_1123_0 I1=B[4] I2=carry[4]
XFE_RC_1903_0 ND2P $PINS O=carry[5] I1=FE_RN_1124_0 I2=FE_RN_1123_0
XFE_RC_1857_0 ND2 $PINS O=FE_RN_1085_0 I1=carry[17] I2=B[17]
XFE_RC_1855_0 ND2P $PINS O=carry[18] I1=FE_RN_1086_0 I2=FE_RN_1085_0
XFE_RC_1721_0 ND2 $PINS O=FE_RN_977_0 I1=carry[6] I2=B[6]
XFE_RC_1720_0 AOI22H $PINS O=FE_RN_978_0 A1=B[6] A2=A[6] B1=carry[6] B2=A[6]
XFE_RC_1719_0 ND2P $PINS O=carry[7] I1=FE_RN_978_0 I2=FE_RN_977_0
XFE_RC_1705_0 ND2 $PINS O=FE_RN_965_0 I1=carry[19] I2=B[19]
XFE_RC_1704_0 AOI22H $PINS O=FE_RN_966_0 A1=B[19] A2=A[19] B1=carry[19]
+ B2=A[19]
XFE_RC_1703_0 ND2P $PINS O=carry[20] I1=FE_RN_966_0 I2=FE_RN_965_0
XFE_RC_1239_0 INV1S $PINS O=FE_RN_601_0 I=FE_OCPN491_carry_24
XFE_RC_1238_0 INV2CK $PINS O=FE_RN_602_0 I=B[24]
XFE_RC_1237_0 MXL2HS $PINS OB=FE_RN_603_0 S=FE_OCPN1110_N202 A=FE_RN_602_0
+ B=B[24]
XFE_RC_1236_0 ND2 $PINS O=FE_RN_604_0 I1=FE_RN_603_0 I2=FE_RN_601_0
XFE_RC_1234_0 INV2CK $PINS O=FE_RN_606_0 I=A[24]
XFE_RC_1233_0 OAI12HS $PINS O=FE_RN_607_0 A1=FE_RN_612_0 B1=FE_RN_606_0
+ B2=FE_RN_602_0
XFE_RC_1232_0 ND2 $PINS O=FE_RN_608_0 I1=FE_RN_607_0 I2=FE_OCPN491_carry_24
XFE_RC_1231_0 ND2 $PINS O=SUM[24] I1=FE_RN_608_0 I2=FE_RN_604_0
XFE_RC_1230_0 ND2 $PINS O=FE_RN_609_0 I1=FE_OCPN1110_N202 I2=B[24]
XFE_RC_1227_0 ND2 $PINS O=FE_RN_612_0 I1=FE_RN_606_0 I2=FE_RN_602_0
XFE_RC_1226_0 ND2 $PINS O=FE_RN_613_0 I1=carry[24] I2=FE_RN_612_0
XFE_RC_1225_0 ND2P $PINS O=carry[25] I1=FE_RN_613_0 I2=FE_RN_609_0
XFE_RC_1224_0 ND2P $PINS O=FE_RN_599_0 I1=carry[7] I2=B[7]
XFE_RC_1223_0 AOI22HP $PINS O=FE_RN_600_0 A1=A[7] A2=B[7] B1=carry[7] B2=A[7]
XFE_RC_1222_0 ND2P $PINS O=carry[8] I1=FE_RN_600_0 I2=FE_RN_599_0
XFE_RC_795_0 OR2B1S $PINS O=FE_RN_267_0 I1=A[8] B1=FE_OCPN1164_N213
XFE_RC_794_0 INV1S $PINS O=FE_RN_268_0 I=FE_OCPN931_N186
XFE_RC_793_0 INV1S $PINS O=FE_RN_269_0 I=B[8]
XFE_RC_791_0 ND2 $PINS O=FE_RN_271_0 I1=FE_RN_269_0 I2=FE_OCPN998_carry_8
XFE_RC_790_0 OAI12HS $PINS O=FE_RN_272_0 A1=FE_RN_271_0 B1=FE_RN_269_0
+ B2=FE_OCPN998_carry_8
XFE_RC_789_0 INV1S $PINS O=FE_RN_273_0 I=FE_OCPN998_carry_8
XFE_RC_788_0 OAI222S $PINS O=SUM[8] A1=FE_RN_273_0 A2=FE_OCPN1214_FE_RN_275_0
+ B1=FE_RN_272_0 B2=FE_RN_268_0 C1=FE_OCPN998_carry_8 C2=FE_RN_267_0
XFE_RC_787_0 ND2 $PINS O=FE_RN_274_0 I1=B[8] I2=FE_OCPN1120_N186
XFE_RC_786_0 OR2 $PINS O=FE_RN_275_0 I1=A[8] I2=B[8]
XFE_RC_785_0 ND2P $PINS O=FE_RN_276_0 I1=carry[8] I2=FE_RN_275_0
XFE_RC_784_0 ND2P $PINS O=carry[9] I1=FE_RN_276_0 I2=FE_RN_274_0
XFE_RC_607_0 XOR3 $PINS O=SUM[9] I1=A[9] I2=B[9] I3=FE_OCPN492_carry_9
XFE_RC_602_0 XOR3 $PINS O=SUM[5] I1=A[5] I2=B[5] I3=FE_OCPN1084_carry_5
XFE_RC_535_0 XOR3 $PINS O=SUM[6] I1=A[6] I2=B[6] I3=FE_OCPN1165_carry_6
XFE_RC_464_0 XOR3 $PINS O=SUM[7] I1=A[7] I2=B[7] I3=FE_OCPN1024_carry_7
XFE_RC_386_0 XOR3 $PINS O=SUM[10] I1=A[10] I2=B[10] I3=FE_OCPN484_carry_10
XFE_RC_298_0 XOR3 $PINS O=SUM[16] I1=A[16] I2=B[16] I3=FE_OCPN280_carry_16
XFE_RC_241_0 XOR3 $PINS O=SUM[17] I1=A[17] I2=B[17] I3=FE_OCPN1025_carry_17
XFE_RC_192_0 XOR3 $PINS O=SUM[11] I1=A[11] I2=B[11] I3=FE_OCPN932_carry_11
XFE_RC_190_0 XOR3 $PINS O=SUM[18] I1=A[18] I2=B[18] I3=FE_OCPN281_carry_18
XFE_RC_106_0 XOR3 $PINS O=SUM[19] I1=A[19] I2=B[19] I3=FE_OCPN246_carry_19
XFE_RC_82_0 XOR3 $PINS O=SUM[20] I1=A[20] I2=B[20] I3=FE_OCPN386_carry_20
XFE_RC_51_0 XOR3 $PINS O=SUM[21] I1=A[21] I2=B[21] I3=FE_OCPN244_carry_21
XU1_26 XOR3 $PINS O=SUM[26] I1=A[26] I2=B[26] I3=carry[26]
XU1_25 FA1 $PINS S=SUM[25] CO=carry[26] A=A[25] B=B[25] CI=carry[25]
XU1_13 FA1S $PINS S=SUM[13] CO=carry[14] A=FE_OCPN1138_N191 B=B[13]
+ CI=FE_OCPN265_carry_13
XU2 ND2 $PINS O=n20 I1=n15 I2=B[14]
XU3 ND2 $PINS O=n8 I1=A[22] I2=B[22]
XU4 XOR3 $PINS O=SUM[12] I1=A[12] I2=B[12] I3=FE_OCPN383_carry_12
XU5 XOR3 $PINS O=SUM[14] I1=A[14] I2=B[14] I3=carry[14]
XU6 XOR3 $PINS O=SUM[22] I1=A[22] I2=B[22] I3=FE_OCPN1015_carry_22
XU7 AN2 $PINS O=n1 I1=B[0] I2=A[0]
XU8 XOR3 $PINS O=SUM[3] I1=A[3] I2=B[3] I3=carry[3]
XU9 ND2 $PINS O=n2 I1=carry[3] I2=A[3]
XU10 ND2 $PINS O=n3 I1=carry[3] I2=B[3]
XU11 ND2 $PINS O=n4 I1=A[3] I2=B[3]
XU16 ND2 $PINS O=n7 I1=A[15] I2=B[15]
XU18 ND2 $PINS O=n9 I1=carry[22] I2=A[22]
XU19 ND2 $PINS O=n10 I1=carry[22] I2=B[22]
XU21 XOR2HS $PINS O=n11 I1=A[23] I2=B[23]
XU22 XOR2HS $PINS O=SUM[23] I1=n11 I2=FE_OCPN303_carry_23
XU23 ND2 $PINS O=n12 I1=A[23] I2=B[23]
XU24 ND2 $PINS O=n13 I1=carry[23] I2=A[23]
XU26 ND2 $PINS O=n18 I1=A[12] I2=B[12]
XU29 ND2 $PINS O=n16 I1=carry[12] I2=A[12]
XU30 ND2 $PINS O=n17 I1=carry[12] I2=B[12]
XU31 ND2 $PINS O=n19 I1=n15 I2=A[14]
XU32 ND2 $PINS O=n21 I1=A[14] I2=B[14]
XU33 ND3 $PINS O=carry[15] I1=n19 I2=n20 I3=n21
XU34 XOR2HS $PINS O=SUM[0] I1=B[0] I2=A[0]
XU13 ND2 $PINS O=n14 I1=carry[23] I2=B[23]
XU14 ND3P $PINS O=carry[23] I1=n10 I2=n9 I3=n8
XU15 XOR3 $PINS O=SUM[15] I1=A[15] I2=B[15] I3=FE_OCPN381_carry_15
XU17 ND2 $PINS O=n6 I1=carry[15] I2=B[15]
XU20 ND2 $PINS O=n5 I1=carry[15] I2=A[15]
XU25 ND3P $PINS O=carry[16] I1=n5 I2=n6 I3=n7
.ENDS

.SUBCKT PE_Shift_Add_1 rst_n en clear calc_done stage_sel x_in[16] x_in[15]
+ x_in[14] x_in[13] x_in[12] x_in[11] x_in[10] x_in[9] x_in[8] x_in[7] x_in[6]
+ x_in[5] x_in[4] x_in[3] x_in[2] x_in[1] x_in[0] sign1[1] sign1[0] sign2[1]
+ sign2[0] sign3[1] sign3[0] shf1[3] shf1[2] shf1[1] shf1[0] shf2[3] shf2[2]
+ shf2[1] shf2[0] shf3[3] shf3[2] shf3[1] shf3[0] y_out[16] y_out[15] y_out[14]
+ y_out[13] y_out[12] y_out[11] y_out[10] y_out[9] y_out[8] y_out[7] y_out[6]
+ y_out[5] y_out[4] y_out[3] y_out[2] y_out[1] y_out[0] i_rst_n
+ FE_OFN46_i_rst_n FE_OFN44_i_rst_n FE_OFN150_h31_3 FE_OFN162_h32_1 FE_OFN171_n
+ FE_OFN393_mac_in_real_1 FE_OFN411_mac_in_real_4 FE_OFN334_mac_in_real_3
+ FE_OFN370_mac_in_real_2 clk_clone1 clk
XFE_PHC2091_N251 BUF1CK $PINS O=FE_PHN2091_N251 I=N251
XFE_PHC1851_N246 DELC $PINS O=FE_PHN1851_N246 I=N246
XFE_PHC1847_N249 DELC $PINS O=FE_PHN1847_N249 I=N249
XFE_PHC1844_N248 DELC $PINS O=FE_PHN1844_N248 I=N248
XFE_PHC1836_N241 DELC $PINS O=N241 I=FE_PHN1836_N241
XFE_PHC1830_N247 DELC $PINS O=N247 I=FE_PHN1830_N247
XFE_PHC1808_N205 DELB $PINS O=FE_PHN1808_N205 I=N205
XFE_PHC1798_acc_reg_16 DELC $PINS O=acc_reg[16] I=FE_PHN1798_acc_reg_16
XFE_PHC1683_pe_r3_12 DELC $PINS O=y_out[12] I=FE_PHN1683_pe_r3_12
XFE_PHC1676_pe_r3_15 DELC $PINS O=y_out[15] I=FE_PHN1676_pe_r3_15
XFE_PHC1671_pe_r3_14 DELC $PINS O=y_out[14] I=FE_PHN1671_pe_r3_14
XFE_PHC1670_pe_r3_13 DELC $PINS O=y_out[13] I=FE_PHN1670_pe_r3_13
XFE_PHC1657_pe_r3_11 DELC $PINS O=y_out[11] I=FE_PHN1657_pe_r3_11
XFE_PHC1653_pe_r3_10 DELC $PINS O=y_out[10] I=FE_PHN1653_pe_r3_10
XFE_PHC1545_pe_r3_16 DELC $PINS O=y_out[16] I=FE_PHN1545_pe_r3_16
XFE_PHC1511_N251 DELC $PINS O=FE_PHN1511_N251 I=N251
XFE_PHC1487_N239 DELC $PINS O=FE_PHN1487_N239 I=N239
XFE_PHC1475_N236 DELC $PINS O=FE_PHN1475_N236 I=N236
XFE_PHC1449_N238 DELC $PINS O=N238 I=FE_PHN1449_N238
XFE_PHC1445_N242 DELC $PINS O=FE_PHN1445_N242 I=N242
XFE_PHC1444_acc_reg_12 DELC $PINS O=FE_PHN1444_acc_reg_12 I=acc_reg[12]
XFE_PHC1439_N240 DELC $PINS O=N240 I=FE_PHN1439_N240
XFE_PHC1430_N235 DELC $PINS O=FE_PHN1430_N235 I=N235
XFE_PHC1417_N245 DELC $PINS O=FE_PHN1417_N245 I=N245
XFE_PHC1416_N244 DELC $PINS O=FE_PHN1416_N244 I=N244
XFE_PHC1411_N243 DELC $PINS O=FE_PHN1411_N243 I=N243
XFE_PHC1291_acc_reg_25 DELC $PINS O=FE_PHN1291_acc_reg_25 I=acc_reg[25]
XFE_PHC1254_pe_r3_2 DELC $PINS O=y_out[2] I=FE_PHN1254_pe_r3_2
XFE_PHC1253_pe_r3_6 DELC $PINS O=y_out[6] I=FE_PHN1253_pe_r3_6
XFE_PHC1252_pe_r3_3 DELC $PINS O=y_out[3] I=FE_PHN1252_pe_r3_3
XFE_PHC1251_pe_r3_4 DELC $PINS O=y_out[4] I=FE_PHN1251_pe_r3_4
XFE_PHC1250_pe_r3_0 DELC $PINS O=y_out[0] I=FE_PHN1250_pe_r3_0
XFE_PHC1249_pe_r3_5 DELC $PINS O=y_out[5] I=FE_PHN1249_pe_r3_5
XFE_PHC1247_pe_r3_7 DELC $PINS O=y_out[7] I=FE_PHN1247_pe_r3_7
XFE_RC_271_0 AO22 $PINS O=N49 A1=term1_shifted[8] A2=n42 B1=N22 B2=sign1[0]
XFE_RC_270_0 AO22 $PINS O=N155 A1=term3_shifted[4] A2=sign3[0] B1=N128 B2=n19
XFE_RC_246_0 ND2 $PINS O=FE_RN_112_0 I1=term1_shifted[7] I2=n42
XFE_RC_245_0 ND2S $PINS O=FE_RN_113_0 I1=N21 I2=sign1[0]
XFE_RC_244_0 ND2P $PINS O=N48 I1=FE_RN_113_0 I2=FE_RN_112_0
XFE_RC_235_0 ND2S $PINS O=FE_RN_106_0 I1=term1_shifted[21] I2=FE_OFN437_n
XFE_RC_234_0 ND2 $PINS O=FE_RN_107_0 I1=N35 I2=FE_OFN452_n
XFE_RC_233_0 ND2 $PINS O=N62 I1=FE_RN_107_0 I2=FE_RN_106_0
XFE_RC_65_0 AO22 $PINS O=N98 A1=term2_shifted[2] A2=sign2[0] B1=N71
+ B2=FE_OFN366_s32_0
XCTS_ccl_a_INV_CLK_G1_L10_71 INV3CK $PINS O=CTS_10 I=CTS_11
XCTS_ccl_a_INV_CLK_G1_L9_73 INV2CK $PINS O=CTS_11 I=CTS_12
XFE_OCPC1166_n71 BUF1S $PINS O=FE_OCPN1166_n71 I=n71
XFE_OCPC1144_n70 BUF1S $PINS O=FE_OCPN1144_n70 I=n70
XFE_RC_4029_0 AO22 $PINS O=N101 A1=term2_shifted[5] A2=sign2[0] B1=N74
+ B2=FE_OFN366_s32_0
XFE_RC_3999_0 AO22 $PINS O=N51 A1=term1_shifted[10] A2=n42 B1=N24 B2=sign1[0]
XFE_RC_3997_0 AO22 $PINS O=N99 A1=term2_shifted[3] A2=sign2[0] B1=N72
+ B2=FE_OFN366_s32_0
XFE_RC_3805_0 AO22 $PINS O=N100 A1=term2_shifted[4] A2=sign2[0] B1=N73
+ B2=FE_OFN366_s32_0
XFE_RC_3707_0 ND2 $PINS O=FE_RN_2434_0 I1=term2_shifted[1] I2=sign2[0]
XFE_RC_3706_0 ND2P $PINS O=FE_RN_2435_0 I1=N70 I2=FE_OFN366_s32_0
XFE_RC_3705_0 ND2P $PINS O=N97 I1=FE_RN_2435_0 I2=FE_RN_2434_0
XFE_RC_3522_0 ND2 $PINS O=FE_RN_2297_0 I1=term1_shifted[19] I2=FE_OFN261_s31_0
XFE_RC_3521_0 ND2 $PINS O=FE_RN_2298_0 I1=N33 I2=FE_OFN452_n
XFE_RC_3520_0 ND2P $PINS O=N60 I1=FE_RN_2298_0 I2=FE_RN_2297_0
XFE_RC_3422_0 ND2S $PINS O=FE_RN_2227_0 I1=sll_16/ML_int[1][0] I2=shf1[1]
XFE_RC_3421_0 INV2 $PINS O=FE_RN_2228_0 I=shf1[1]
XFE_RC_3420_0 ND2 $PINS O=FE_RN_2229_0 I1=sll_16/ML_int[1][2] I2=FE_RN_2228_0
XFE_RC_3419_0 ND2 $PINS O=sll_16/ML_int[2][2] I1=FE_RN_2229_0 I2=FE_RN_2227_0
XFE_RC_2933_0 ND2 $PINS O=FE_RN_1877_0 I1=term1_in[2] I2=shf1[0]
XFE_RC_2932_0 INV1S $PINS O=FE_RN_1878_0 I=shf1[0]
XFE_RC_2931_0 ND2S $PINS O=FE_RN_1879_0 I1=term1_in[3] I2=FE_RN_1878_0
XFE_RC_2930_0 ND2 $PINS O=sll_16/ML_int[1][3] I1=FE_RN_1879_0 I2=FE_RN_1877_0
XFE_RC_1145_0 ND2 $PINS O=FE_RN_540_0 I1=term3_shifted[2] I2=sign3[0]
XFE_RC_1144_0 ND2T $PINS O=FE_RN_541_0 I1=N126 I2=n19
XFE_RC_1143_0 ND2T $PINS O=N153 I1=FE_RN_541_0 I2=FE_RN_540_0
XFE_RC_1079_0 ND2 $PINS O=FE_RN_495_0 I1=term1_shifted[2] I2=n42
XFE_RC_1078_0 ND2P $PINS O=FE_RN_496_0 I1=N16 I2=sign1[0]
XFE_RC_1077_0 ND2P $PINS O=N43 I1=FE_RN_496_0 I2=FE_RN_495_0
XFE_RC_11_0 OA12 $PINS O=N151 A1=N124 B1=n19 B2=sign3[0]
XFE_RC_5_0 OA12 $PINS O=N96 A1=term2_shifted[0] B1=FE_OFN366_s32_0 B2=sign2[0]
XFE_RC_4_0 OA12 $PINS O=N41 A1=N14 B1=sign1[0] B2=n42
XFE_OFC852_h31_1 BUF1 $PINS O=FE_OFN461_h31_1 I=shf1[1]
XFE_OFC842_n BUF1 $PINS O=FE_OFN452_n I=FE_OFN171_n
XFE_OFC828_h33_0 INV1S $PINS O=n10 I=shf3[0]
XFE_OFC797_s33_1 BUF2 $PINS O=FE_OFN441_s33_1 I=sign3[1]
XFE_OFC793_s32_0 INV1S $PINS O=FE_OFN366_s32_0 I=sign2[0]
XFE_OFC792_s32_0 INV1S $PINS O=FE_OFN267_s32_0 I=sign2[0]
XFE_OFC787_h33_3 INV1S $PINS O=n15 I=shf3[3]
XFE_OFC780_s31_0 INV1S $PINS O=FE_OFN437_n I=FE_OFN452_n
XFE_OFC778_s31_0 INV1S $PINS O=n42 I=sign1[0]
XFE_OFC777_s31_0 INV1S $PINS O=FE_OFN261_s31_0 I=sign1[0]
XFE_OFC772_s33_0 INV1S $PINS O=FE_OFN434_s33_0 I=FE_OFN265_s33_0
XFE_OFC771_s33_0 INV1S $PINS O=FE_OFN433_s33_0 I=FE_OFN265_s33_0
XFE_OFC770_s33_0 INV1S $PINS O=n19 I=sign3[0]
XFE_OFC769_s33_0 INV1S $PINS O=FE_OFN265_s33_0 I=sign3[0]
XFE_OFC754_sll_16_ML_int_2__3 INV2 $PINS O=n52 I=sll_16/ML_int[2][3]
XFE_OFC628_n12 INV1S $PINS O=FE_OFN329_h33_1 I=n12
XFE_OFC598_s32_0 INV1S $PINS O=n29 I=sign2[0]
XFE_OFC590_h32_3 INV1S $PINS O=n26 I=shf2[3]
XFE_OFC588_h32_3 INV1S $PINS O=FE_OFN323_h32_3 I=shf2[3]
XFE_OFC520_h33_1 INV2 $PINS O=n12 I=shf3[1]
XFE_OFC509_h31_0 INV1S $PINS O=n32 I=shf1[0]
XFE_OFC495_h33_3 INV1S $PINS O=FE_OFN322_h33_3 I=n15
XFE_OFC421_h31_2 BUF1 $PINS O=FE_OFN293_h31_2 I=shf1[2]
XFE_OFC398_h33_2 INV1S $PINS O=FE_OFN287_h33_2 I=shf3[2]
XFE_OFC397_h33_2 BUF1 $PINS O=n14 I=shf3[2]
XFE_OFC376_pe_clear_d1 INV2 $PINS O=n99 I=clear
XFE_OFC326_s32_0 INV1S $PINS O=FE_OFN268_s32_0 I=FE_OFN267_s32_0
XFE_OFC284_h32_2 INV1S $PINS O=n24 I=shf2[2]
XFE_OFC251_FE_DBTN9_n336 BUF1 $PINS O=FE_OFN243_FE_DBTN9_n336 I=stage_sel
XFE_OFC23_i_rst_n BUF1 $PINS O=FE_OFN23_i_rst_n I=i_rst_n
XFE_OFC19_i_rst_n BUF1 $PINS O=FE_OFN19_i_rst_n I=i_rst_n
XU110 AO22 $PINS O=base_val[13] A1=acc_reg[13] A2=n99 B1=clear
+ B2=FE_OFN243_FE_DBTN9_n336
XU129 AO22 $PINS O=N53 A1=N26 A2=sign1[0] B1=term1_shifted[12]
+ B2=FE_OFN261_s31_0
XU135 AO22 $PINS O=N47 A1=N20 A2=sign1[0] B1=term1_shifted[6] B2=n42
XU136 AO22 $PINS O=N46 A1=N19 A2=sign1[0] B1=term1_shifted[5] B2=n42
XU149 AO22 $PINS O=N170 A1=N143 A2=FE_OFN265_s33_0 B1=term3_shifted[19]
+ B2=FE_OFN433_s33_0
XU150 AO22 $PINS O=N169 A1=N142 A2=FE_OFN265_s33_0 B1=term3_shifted[18]
+ B2=FE_OFN434_s33_0
XU151 AO22 $PINS O=N168 A1=N141 A2=FE_OFN265_s33_0 B1=term3_shifted[17]
+ B2=FE_OFN434_s33_0
XU152 AO22 $PINS O=N167 A1=N140 A2=FE_OFN265_s33_0 B1=term3_shifted[16]
+ B2=FE_OFN434_s33_0
XU153 AO22 $PINS O=N166 A1=N139 A2=FE_OFN265_s33_0 B1=term3_shifted[15]
+ B2=FE_OFN434_s33_0
XU154 AO22 $PINS O=N165 A1=N138 A2=FE_OFN265_s33_0 B1=term3_shifted[14]
+ B2=FE_OFN434_s33_0
XU156 AO22 $PINS O=N163 A1=N136 A2=FE_OFN265_s33_0 B1=term3_shifted[12]
+ B2=FE_OFN434_s33_0
XU160 AO22 $PINS O=N159 A1=N132 A2=n19 B1=term3_shifted[8] B2=sign3[0]
XU161 AO22 $PINS O=N158 A1=N131 A2=n19 B1=term3_shifted[7] B2=sign3[0]
XU162 AO22 $PINS O=N157 A1=N130 A2=n19 B1=term3_shifted[6] B2=sign3[0]
XU163 AO22 $PINS O=N156 A1=N129 A2=n19 B1=term3_shifted[5] B2=sign3[0]
XU165 AO22 $PINS O=N154 A1=N127 A2=n19 B1=term3_shifted[3] B2=sign3[0]
XU169 AO22 $PINS O=N122 A1=N95 A2=n29 B1=term2_shifted[26] B2=FE_OFN268_s32_0
XU170 AO22 $PINS O=N121 A1=N94 A2=n29 B1=term2_shifted[25] B2=FE_OFN268_s32_0
XU172 AO22 $PINS O=N119 A1=N92 A2=n29 B1=term2_shifted[23] B2=FE_OFN268_s32_0
XU173 AO22 $PINS O=N118 A1=N91 A2=n29 B1=term2_shifted[22] B2=FE_OFN268_s32_0
XU174 AO22 $PINS O=N117 A1=N90 A2=n29 B1=term2_shifted[21] B2=FE_OFN268_s32_0
XU175 AO22 $PINS O=N116 A1=N89 A2=n29 B1=term2_shifted[20] B2=FE_OFN268_s32_0
XU176 AO22 $PINS O=N115 A1=N88 A2=n29 B1=term2_shifted[19] B2=FE_OFN268_s32_0
XU177 AO22 $PINS O=N114 A1=N87 A2=n29 B1=term2_shifted[18] B2=FE_OFN268_s32_0
XU178 AO22 $PINS O=N113 A1=N86 A2=n29 B1=term2_shifted[17] B2=FE_OFN268_s32_0
XU179 AO22 $PINS O=N112 A1=N85 A2=FE_OFN267_s32_0 B1=term2_shifted[16]
+ B2=FE_OFN268_s32_0
XU181 AO22 $PINS O=N110 A1=N83 A2=FE_OFN267_s32_0 B1=term2_shifted[14]
+ B2=FE_OFN268_s32_0
XU183 AO22 $PINS O=N108 A1=N81 A2=FE_OFN366_s32_0 B1=term2_shifted[12]
+ B2=sign2[0]
XU184 AO22 $PINS O=N107 A1=N80 A2=FE_OFN366_s32_0 B1=term2_shifted[11]
+ B2=sign2[0]
XU185 AO22 $PINS O=N106 A1=N79 A2=FE_OFN366_s32_0 B1=term2_shifted[10]
+ B2=sign2[0]
XU188 AO22 $PINS O=N103 A1=N76 A2=FE_OFN366_s32_0 B1=term2_shifted[7]
+ B2=sign2[0]
XU189 AO22 $PINS O=N102 A1=N75 A2=FE_OFN366_s32_0 B1=term2_shifted[6]
+ B2=sign2[0]
Xsll_18/M1_0_1 MUX2 $PINS O=sll_18/ML_int[1][1] S=shf3[0] A=term3_in[1]
+ B=term3_in[0]
Xsll_18/M1_0_2 MUX2 $PINS O=sll_18/ML_int[1][2] S=shf3[0] A=term3_in[2]
+ B=term3_in[1]
Xsll_18/M1_0_3 MUX2 $PINS O=sll_18/ML_int[1][3] S=shf3[0] A=term3_in[3]
+ B=term3_in[2]
Xsll_18/M1_0_4 MUX2 $PINS O=sll_18/ML_int[1][4] S=shf3[0] A=term3_in[4]
+ B=term3_in[3]
Xsll_18/M1_0_5 MUX2 $PINS O=sll_18/ML_int[1][5] S=shf3[0] A=term3_in[5]
+ B=term3_in[4]
Xsll_18/M1_0_6 MUX2 $PINS O=sll_18/ML_int[1][6] S=shf3[0] A=term3_in[6]
+ B=term3_in[5]
Xsll_18/M1_0_7 MUX2 $PINS O=sll_18/ML_int[1][7] S=shf3[0] A=term3_in[7]
+ B=term3_in[6]
Xsll_18/M1_0_8 MUX2 $PINS O=sll_18/ML_int[1][8] S=shf3[0] A=term3_in[8]
+ B=term3_in[7]
Xsll_18/M1_0_9 MUX2 $PINS O=sll_18/ML_int[1][9] S=shf3[0] A=term3_in[9]
+ B=term3_in[8]
Xsll_18/M1_0_10 MUX2 $PINS O=sll_18/ML_int[1][10] S=shf3[0] A=term3_in[10]
+ B=term3_in[9]
Xsll_18/M1_1_2 MUX2 $PINS O=sll_18/ML_int[2][2] S=FE_OFN329_h33_1
+ A=sll_18/ML_int[1][2] B=sll_18/ML_int[1][0]
Xsll_18/M1_1_5 MUX2 $PINS O=sll_18/ML_int[2][5] S=FE_OFN329_h33_1
+ A=sll_18/ML_int[1][5] B=sll_18/ML_int[1][3]
Xsll_18/M1_1_6 MUX2 $PINS O=sll_18/ML_int[2][6] S=FE_OFN329_h33_1
+ A=sll_18/ML_int[1][6] B=sll_18/ML_int[1][4]
Xsll_18/M1_1_7 MUX2 $PINS O=sll_18/ML_int[2][7] S=FE_OFN329_h33_1
+ A=sll_18/ML_int[1][7] B=sll_18/ML_int[1][5]
Xsll_18/M1_1_8 MUX2 $PINS O=sll_18/ML_int[2][8] S=FE_OFN329_h33_1
+ A=sll_18/ML_int[1][8] B=sll_18/ML_int[1][6]
Xsll_18/M1_1_9 MUX2 $PINS O=sll_18/ML_int[2][9] S=FE_OFN329_h33_1
+ A=sll_18/ML_int[1][9] B=sll_18/ML_int[1][7]
Xsll_18/M1_1_10 MUX2 $PINS O=sll_18/ML_int[2][10] S=shf3[1]
+ A=sll_18/ML_int[1][10] B=sll_18/ML_int[1][8]
Xsll_18/M1_1_11 MUX2 $PINS O=sll_18/ML_int[2][11] S=FE_OFN329_h33_1
+ A=sll_18/ML_int[1][11] B=sll_18/ML_int[1][9]
Xsll_18/M1_2_4 MUX2 $PINS O=sll_18/ML_int[3][4] S=shf3[2] A=sll_18/ML_int[2][4]
+ B=n75
Xsll_18/M1_2_5 MUX2 $PINS O=sll_18/ML_int[3][5] S=shf3[2] A=sll_18/ML_int[2][5]
+ B=n76
Xsll_18/M1_2_7 MUX2 $PINS O=sll_18/ML_int[3][7] S=shf3[2] A=sll_18/ML_int[2][7]
+ B=sll_18/ML_int[2][3]
Xsll_18/M1_2_9 MUX2 $PINS O=sll_18/ML_int[3][9] S=shf3[2] A=sll_18/ML_int[2][9]
+ B=sll_18/ML_int[2][5]
Xsll_18/M1_2_10 MUX2 $PINS O=sll_18/ML_int[3][10] S=shf3[2]
+ A=sll_18/ML_int[2][10] B=sll_18/ML_int[2][6]
Xsll_18/M1_2_11 MUX2 $PINS O=sll_18/ML_int[3][11] S=n14 A=sll_18/ML_int[2][11]
+ B=sll_18/ML_int[2][7]
Xsll_18/M1_2_12 MUX2 $PINS O=sll_18/ML_int[3][12] S=n14 A=sll_18/ML_int[2][12]
+ B=sll_18/ML_int[2][8]
Xsll_18/M1_2_13 MUX2 $PINS O=sll_18/ML_int[3][13] S=n14 A=sll_18/ML_int[2][13]
+ B=sll_18/ML_int[2][9]
Xsll_18/M1_3_8 MUX2 $PINS O=term3_shifted[8] S=FE_OFN322_h33_3
+ A=sll_18/ML_int[3][8] B=sll_18/ML_int[3][0]
Xsll_18/M1_3_9 MUX2 $PINS O=term3_shifted[9] S=FE_OFN322_h33_3
+ A=sll_18/ML_int[3][9] B=sll_18/ML_int[3][1]
Xsll_18/M1_3_10 MUX2 $PINS O=term3_shifted[10] S=FE_OFN322_h33_3
+ A=sll_18/ML_int[3][10] B=sll_18/ML_int[3][2]
Xsll_18/M1_3_11 MUX2 $PINS O=term3_shifted[11] S=FE_OFN322_h33_3
+ A=sll_18/ML_int[3][11] B=sll_18/ML_int[3][3]
Xsll_18/M1_3_12 MUX2 $PINS O=term3_shifted[12] S=FE_OFN322_h33_3
+ A=sll_18/ML_int[3][12] B=sll_18/ML_int[3][4]
Xsll_18/M1_3_13 MUX2 $PINS O=term3_shifted[13] S=FE_OFN322_h33_3
+ A=sll_18/ML_int[3][13] B=sll_18/ML_int[3][5]
Xsll_18/M1_3_14 MUX2 $PINS O=term3_shifted[14] S=FE_OFN322_h33_3
+ A=sll_18/ML_int[3][14] B=sll_18/ML_int[3][6]
Xsll_18/M1_3_15 MUX2 $PINS O=term3_shifted[15] S=FE_OFN322_h33_3
+ A=sll_18/ML_int[3][15] B=sll_18/ML_int[3][7]
Xsll_18/M1_3_16 MUX2 $PINS O=term3_shifted[16] S=FE_OFN322_h33_3
+ A=sll_18/ML_int[3][16] B=sll_18/ML_int[3][8]
Xsll_18/M1_3_17 MUX2 $PINS O=term3_shifted[17] S=FE_OFN322_h33_3
+ A=sll_18/ML_int[3][17] B=sll_18/ML_int[3][9]
Xsll_18/M1_3_23 MUX2 $PINS O=term3_shifted[23] S=shf3[3] A=term3_in[26]
+ B=sll_18/ML_int[3][15]
Xsll_17/M1_0_2 MUX2 $PINS O=sll_17/ML_int[1][2] S=shf2[0] A=term2_in[2]
+ B=term2_in[1]
Xsll_17/M1_0_3 MUX2 $PINS O=sll_17/ML_int[1][3] S=shf2[0] A=term2_in[3]
+ B=term2_in[2]
Xsll_17/M1_0_4 MUX2 $PINS O=sll_17/ML_int[1][4] S=shf2[0] A=term2_in[4]
+ B=term2_in[3]
Xsll_17/M1_0_5 MUX2 $PINS O=sll_17/ML_int[1][5] S=shf2[0] A=term2_in[5]
+ B=term2_in[4]
Xsll_17/M1_0_6 MUX2 $PINS O=sll_17/ML_int[1][6] S=shf2[0] A=term2_in[6]
+ B=term2_in[5]
Xsll_17/M1_0_7 MUX2 $PINS O=sll_17/ML_int[1][7] S=shf2[0] A=term2_in[7]
+ B=term2_in[6]
Xsll_17/M1_0_8 MUX2 $PINS O=sll_17/ML_int[1][8] S=shf2[0] A=term2_in[8]
+ B=term2_in[7]
Xsll_17/M1_0_9 MUX2 $PINS O=sll_17/ML_int[1][9] S=shf2[0] A=term2_in[9]
+ B=term2_in[8]
Xsll_17/M1_0_10 MUX2 $PINS O=sll_17/ML_int[1][10] S=shf2[0] A=term2_in[10]
+ B=term2_in[9]
Xsll_17/M1_1_3 MUX2 $PINS O=sll_17/ML_int[2][3] S=shf2[1] A=sll_17/ML_int[1][3]
+ B=sll_17/ML_int[1][1]
Xsll_17/M1_1_4 MUX2 $PINS O=sll_17/ML_int[2][4] S=shf2[1] A=sll_17/ML_int[1][4]
+ B=sll_17/ML_int[1][2]
Xsll_17/M1_1_5 MUX2 $PINS O=sll_17/ML_int[2][5] S=shf2[1] A=sll_17/ML_int[1][5]
+ B=sll_17/ML_int[1][3]
Xsll_17/M1_1_6 MUX2 $PINS O=sll_17/ML_int[2][6] S=shf2[1] A=sll_17/ML_int[1][6]
+ B=sll_17/ML_int[1][4]
Xsll_17/M1_1_7 MUX2 $PINS O=sll_17/ML_int[2][7] S=shf2[1] A=sll_17/ML_int[1][7]
+ B=sll_17/ML_int[1][5]
Xsll_17/M1_1_8 MUX2 $PINS O=sll_17/ML_int[2][8] S=shf2[1] A=sll_17/ML_int[1][8]
+ B=sll_17/ML_int[1][6]
Xsll_17/M1_1_9 MUX2 $PINS O=sll_17/ML_int[2][9] S=shf2[1] A=sll_17/ML_int[1][9]
+ B=sll_17/ML_int[1][7]
Xsll_17/M1_1_10 MUX2 $PINS O=sll_17/ML_int[2][10] S=shf2[1]
+ A=sll_17/ML_int[1][10] B=sll_17/ML_int[1][8]
Xsll_17/M1_1_11 MUX2 $PINS O=sll_17/ML_int[2][11] S=shf2[1]
+ A=sll_17/ML_int[1][11] B=sll_17/ML_int[1][9]
Xsll_17/M1_2_4 MUX2 $PINS O=sll_17/ML_int[3][4] S=n24 A=sll_17/ML_int[2][4]
+ B=n64
Xsll_17/M1_2_5 MUX2 $PINS O=sll_17/ML_int[3][5] S=n24 A=sll_17/ML_int[2][5]
+ B=n65
Xsll_17/M1_2_7 MUX2 $PINS O=sll_17/ML_int[3][7] S=n24 A=sll_17/ML_int[2][7]
+ B=sll_17/ML_int[2][3]
Xsll_17/M1_2_8 MUX2 $PINS O=sll_17/ML_int[3][8] S=n24 A=sll_17/ML_int[2][8]
+ B=sll_17/ML_int[2][4]
Xsll_17/M1_2_9 MUX2 $PINS O=sll_17/ML_int[3][9] S=n24 A=sll_17/ML_int[2][9]
+ B=sll_17/ML_int[2][5]
Xsll_17/M1_2_10 MUX2 $PINS O=sll_17/ML_int[3][10] S=n24 A=sll_17/ML_int[2][10]
+ B=sll_17/ML_int[2][6]
Xsll_17/M1_2_12 MUX2 $PINS O=sll_17/ML_int[3][12] S=n24 A=sll_17/ML_int[2][12]
+ B=sll_17/ML_int[2][8]
Xsll_17/M1_2_13 MUX2 $PINS O=sll_17/ML_int[3][13] S=n24 A=sll_17/ML_int[2][13]
+ B=sll_17/ML_int[2][9]
Xsll_17/M1_3_8 MUX2 $PINS O=term2_shifted[8] S=n26 A=sll_17/ML_int[3][8]
+ B=sll_17/ML_int[3][0]
Xsll_17/M1_3_9 MUX2 $PINS O=term2_shifted[9] S=n26 A=sll_17/ML_int[3][9]
+ B=sll_17/ML_int[3][1]
Xsll_17/M1_3_10 MUX2 $PINS O=term2_shifted[10] S=n26 A=sll_17/ML_int[3][10]
+ B=sll_17/ML_int[3][2]
Xsll_17/M1_3_11 MUX2 $PINS O=term2_shifted[11] S=n26 A=sll_17/ML_int[3][11]
+ B=sll_17/ML_int[3][3]
Xsll_17/M1_3_12 MUX2 $PINS O=term2_shifted[12] S=n26 A=sll_17/ML_int[3][12]
+ B=sll_17/ML_int[3][4]
Xsll_17/M1_3_13 MUX2 $PINS O=term2_shifted[13] S=n26 A=sll_17/ML_int[3][13]
+ B=sll_17/ML_int[3][5]
Xsll_17/M1_3_14 MUX2 $PINS O=term2_shifted[14] S=n26 A=sll_17/ML_int[3][14]
+ B=sll_17/ML_int[3][6]
Xsll_17/M1_3_16 MUX2 $PINS O=term2_shifted[16] S=n26 A=sll_17/ML_int[3][16]
+ B=sll_17/ML_int[3][8]
Xsll_17/M1_3_17 MUX2 $PINS O=term2_shifted[17] S=n26 A=sll_17/ML_int[3][17]
+ B=sll_17/ML_int[3][9]
Xsll_17/M1_3_23 MUX2 $PINS O=term2_shifted[23] S=FE_OFN323_h32_3 A=term2_in[26]
+ B=sll_17/ML_int[3][15]
Xsll_16/M1_0_2 MUX2 $PINS O=sll_16/ML_int[1][2] S=shf1[0] A=term1_in[2]
+ B=term1_in[1]
Xsll_16/M1_0_4 MUX2 $PINS O=sll_16/ML_int[1][4] S=shf1[0] A=term1_in[4]
+ B=term1_in[3]
Xsll_16/M1_0_6 MUX2 $PINS O=sll_16/ML_int[1][6] S=shf1[0] A=term1_in[6]
+ B=term1_in[5]
Xsll_16/M1_0_7 MUX2 $PINS O=sll_16/ML_int[1][7] S=shf1[0] A=term1_in[7]
+ B=term1_in[6]
Xsll_16/M1_0_8 MUX2 $PINS O=sll_16/ML_int[1][8] S=shf1[0] A=term1_in[8]
+ B=term1_in[7]
Xsll_16/M1_0_9 MUX2 $PINS O=sll_16/ML_int[1][9] S=shf1[0] A=term1_in[9]
+ B=term1_in[8]
Xsll_16/M1_0_10 MUX2 $PINS O=sll_16/ML_int[1][10] S=shf1[0] A=term1_in[10]
+ B=term1_in[9]
Xsll_16/M1_1_3 MUX2 $PINS O=sll_16/ML_int[2][3] S=shf1[1] A=sll_16/ML_int[1][3]
+ B=sll_16/ML_int[1][1]
Xsll_16/M1_1_4 MUX2 $PINS O=sll_16/ML_int[2][4] S=shf1[1] A=sll_16/ML_int[1][4]
+ B=sll_16/ML_int[1][2]
Xsll_16/M1_1_5 MUX2 $PINS O=sll_16/ML_int[2][5] S=shf1[1] A=sll_16/ML_int[1][5]
+ B=sll_16/ML_int[1][3]
Xsll_16/M1_1_6 MUX2 $PINS O=sll_16/ML_int[2][6] S=shf1[1] A=sll_16/ML_int[1][6]
+ B=sll_16/ML_int[1][4]
Xsll_16/M1_1_7 MUX2 $PINS O=sll_16/ML_int[2][7] S=shf1[1] A=sll_16/ML_int[1][7]
+ B=sll_16/ML_int[1][5]
Xsll_16/M1_1_8 MUX2 $PINS O=sll_16/ML_int[2][8] S=shf1[1] A=sll_16/ML_int[1][8]
+ B=sll_16/ML_int[1][6]
Xsll_16/M1_1_9 MUX2 $PINS O=sll_16/ML_int[2][9] S=FE_OFN461_h31_1
+ A=sll_16/ML_int[1][9] B=sll_16/ML_int[1][7]
Xsll_16/M1_1_10 MUX2 $PINS O=sll_16/ML_int[2][10] S=FE_OFN461_h31_1
+ A=sll_16/ML_int[1][10] B=sll_16/ML_int[1][8]
Xsll_16/M1_1_11 MUX2 $PINS O=sll_16/ML_int[2][11] S=FE_OFN461_h31_1
+ A=sll_16/ML_int[1][11] B=sll_16/ML_int[1][9]
Xsll_16/M1_2_4 MUX2 $PINS O=sll_16/ML_int[3][4] S=shf1[2] A=sll_16/ML_int[2][4]
+ B=n54
Xsll_16/M1_2_5 MUX2 $PINS O=sll_16/ML_int[3][5] S=shf1[2] A=sll_16/ML_int[2][5]
+ B=n55
Xsll_16/M1_2_7 MUX2 $PINS O=sll_16/ML_int[3][7] S=shf1[2] A=sll_16/ML_int[2][7]
+ B=sll_16/ML_int[2][3]
Xsll_16/M1_2_8 MUX2 $PINS O=sll_16/ML_int[3][8] S=shf1[2] A=sll_16/ML_int[2][8]
+ B=sll_16/ML_int[2][4]
Xsll_16/M1_2_9 MUX2 $PINS O=sll_16/ML_int[3][9] S=shf1[2] A=sll_16/ML_int[2][9]
+ B=sll_16/ML_int[2][5]
Xsll_16/M1_2_10 MUX2 $PINS O=sll_16/ML_int[3][10] S=shf1[2]
+ A=sll_16/ML_int[2][10] B=sll_16/ML_int[2][6]
Xsll_16/M1_2_11 MUX2 $PINS O=sll_16/ML_int[3][11] S=FE_OFN293_h31_2
+ A=sll_16/ML_int[2][11] B=sll_16/ML_int[2][7]
Xsll_16/M1_2_12 MUX2 $PINS O=sll_16/ML_int[3][12] S=FE_OFN293_h31_2
+ A=sll_16/ML_int[2][12] B=sll_16/ML_int[2][8]
Xsll_16/M1_2_13 MUX2 $PINS O=sll_16/ML_int[3][13] S=FE_OFN293_h31_2
+ A=sll_16/ML_int[2][13] B=sll_16/ML_int[2][9]
Xsll_16/M1_3_8 MUX2 $PINS O=term1_shifted[8] S=shf1[3] A=sll_16/ML_int[3][8]
+ B=sll_16/ML_int[3][0]
Xsll_16/M1_3_9 MUX2 $PINS O=term1_shifted[9] S=shf1[3] A=sll_16/ML_int[3][9]
+ B=sll_16/ML_int[3][1]
Xsll_16/M1_3_10 MUX2 $PINS O=term1_shifted[10] S=shf1[3] A=sll_16/ML_int[3][10]
+ B=sll_16/ML_int[3][2]
Xsll_16/M1_3_11 MUX2 $PINS O=term1_shifted[11] S=shf1[3] A=sll_16/ML_int[3][11]
+ B=sll_16/ML_int[3][3]
Xsll_16/M1_3_12 MUX2 $PINS O=term1_shifted[12] S=shf1[3] A=sll_16/ML_int[3][12]
+ B=sll_16/ML_int[3][4]
Xsll_16/M1_3_13 MUX2 $PINS O=term1_shifted[13] S=shf1[3] A=sll_16/ML_int[3][13]
+ B=sll_16/ML_int[3][5]
Xsll_16/M1_3_14 MUX2 $PINS O=term1_shifted[14] S=shf1[3] A=sll_16/ML_int[3][14]
+ B=sll_16/ML_int[3][6]
Xsll_16/M1_3_15 MUX2 $PINS O=term1_shifted[15] S=shf1[3] A=sll_16/ML_int[3][15]
+ B=sll_16/ML_int[3][7]
Xsll_16/M1_3_16 MUX2 $PINS O=term1_shifted[16] S=shf1[3] A=sll_16/ML_int[3][16]
+ B=sll_16/ML_int[3][8]
Xsll_16/M1_3_17 MUX2 $PINS O=term1_shifted[17] S=shf1[3] A=sll_16/ML_int[3][17]
+ B=sll_16/ML_int[3][9]
Xy_out_reg[9] QDFFRBN $PINS Q=y_out[9] D=FE_PHN1416_N244 CK=CTS_10
+ RB=FE_OFN46_i_rst_n
Xy_out_reg[8] QDFFRBN $PINS Q=y_out[8] D=FE_PHN1411_N243 CK=CTS_10
+ RB=FE_OFN23_i_rst_n
Xy_out_reg[7] QDFFRBN $PINS Q=FE_PHN1247_pe_r3_7 D=FE_PHN1445_N242 CK=CTS_10
+ RB=FE_OFN23_i_rst_n
Xy_out_reg[6] QDFFRBN $PINS Q=FE_PHN1253_pe_r3_6 D=N241 CK=CTS_10
+ RB=FE_OFN23_i_rst_n
Xy_out_reg[5] QDFFRBN $PINS Q=FE_PHN1249_pe_r3_5 D=N240 CK=CTS_10
+ RB=FE_OFN23_i_rst_n
Xy_out_reg[4] QDFFRBN $PINS Q=FE_PHN1251_pe_r3_4 D=FE_PHN1487_N239 CK=CTS_10
+ RB=FE_OFN23_i_rst_n
Xy_out_reg[3] QDFFRBN $PINS Q=FE_PHN1252_pe_r3_3 D=N238 CK=CTS_10
+ RB=FE_OFN23_i_rst_n
Xy_out_reg[2] QDFFRBN $PINS Q=FE_PHN1254_pe_r3_2 D=N237 CK=CTS_10
+ RB=FE_OFN19_i_rst_n
Xy_out_reg[1] QDFFRBN $PINS Q=y_out[1] D=FE_PHN1475_N236 CK=CTS_10
+ RB=FE_OFN19_i_rst_n
Xy_out_reg[0] QDFFRBN $PINS Q=FE_PHN1250_pe_r3_0 D=FE_PHN1430_N235 CK=CTS_10
+ RB=FE_OFN19_i_rst_n
Xy_out_reg[16] QDFFRBN $PINS Q=FE_PHN1545_pe_r3_16 D=FE_PHN1511_N251 CK=CTS_10
+ RB=FE_OFN46_i_rst_n
Xy_out_reg[10] QDFFRBN $PINS Q=FE_PHN1653_pe_r3_10 D=FE_PHN1417_N245 CK=CTS_10
+ RB=FE_OFN23_i_rst_n
Xy_out_reg[11] QDFFRBN $PINS Q=FE_PHN1657_pe_r3_11 D=FE_PHN1851_N246 CK=CTS_10
+ RB=FE_OFN46_i_rst_n
Xy_out_reg[12] QDFFRBN $PINS Q=FE_PHN1683_pe_r3_12 D=N247 CK=CTS_10
+ RB=FE_OFN23_i_rst_n
Xy_out_reg[14] QDFFRBN $PINS Q=FE_PHN1671_pe_r3_14 D=FE_PHN1847_N249 CK=CTS_10
+ RB=i_rst_n
Xy_out_reg[15] QDFFRBN $PINS Q=FE_PHN1676_pe_r3_15 D=N250 CK=CTS_10 RB=i_rst_n
Xy_out_reg[13] QDFFRBN $PINS Q=FE_PHN1670_pe_r3_13 D=FE_PHN1844_N248 CK=CTS_10
+ RB=i_rst_n
Xacc_reg_reg[25] QDFFRBN $PINS Q=acc_reg[25] D=next_acc[25] CK=clk_clone1
+ RB=FE_OFN44_i_rst_n
Xacc_reg_reg[24] QDFFRBN $PINS Q=acc_reg[24] D=next_acc[24] CK=clk_clone1
+ RB=FE_OFN44_i_rst_n
Xacc_reg_reg[23] QDFFRBN $PINS Q=acc_reg[23] D=next_acc[23] CK=clk_clone1
+ RB=FE_OFN44_i_rst_n
Xacc_reg_reg[22] QDFFRBN $PINS Q=acc_reg[22] D=next_acc[22] CK=clk_clone1
+ RB=FE_OFN23_i_rst_n
Xacc_reg_reg[21] QDFFRBN $PINS Q=acc_reg[21] D=next_acc[21] CK=clk_clone1
+ RB=FE_OFN23_i_rst_n
Xacc_reg_reg[20] QDFFRBN $PINS Q=acc_reg[20] D=next_acc[20] CK=clk_clone1
+ RB=FE_OFN23_i_rst_n
Xacc_reg_reg[19] QDFFRBN $PINS Q=acc_reg[19] D=next_acc[19] CK=clk_clone1
+ RB=FE_OFN19_i_rst_n
Xacc_reg_reg[18] QDFFRBN $PINS Q=acc_reg[18] D=next_acc[18] CK=clk_clone1
+ RB=FE_OFN19_i_rst_n
Xacc_reg_reg[17] QDFFRBN $PINS Q=acc_reg[17] D=next_acc[17] CK=clk_clone1
+ RB=FE_OFN19_i_rst_n
Xacc_reg_reg[16] QDFFRBN $PINS Q=FE_PHN1798_acc_reg_16 D=next_acc[16]
+ CK=clk_clone1 RB=FE_OFN19_i_rst_n
Xacc_reg_reg[15] QDFFRBN $PINS Q=acc_reg[15] D=next_acc[15] CK=clk_clone1
+ RB=FE_OFN19_i_rst_n
Xacc_reg_reg[14] QDFFRBN $PINS Q=acc_reg[14] D=next_acc[14] CK=clk_clone1
+ RB=FE_OFN19_i_rst_n
Xacc_reg_reg[13] QDFFRBN $PINS Q=acc_reg[13] D=next_acc[13] CK=clk_clone1
+ RB=FE_OFN19_i_rst_n
Xacc_reg_reg[12] QDFFRBN $PINS Q=acc_reg[12] D=next_acc[12] CK=clk_clone1
+ RB=FE_OFN19_i_rst_n
Xacc_reg_reg[11] QDFFRBN $PINS Q=acc_reg[11] D=next_acc[11] CK=clk_clone1
+ RB=FE_OFN19_i_rst_n
Xacc_reg_reg[10] QDFFRBN $PINS Q=acc_reg[10] D=next_acc[10] CK=clk_clone1
+ RB=FE_OFN19_i_rst_n
Xacc_reg_reg[9] QDFFRBN $PINS Q=acc_reg[9] D=next_acc[9] CK=clk_clone1
+ RB=FE_OFN19_i_rst_n
Xacc_reg_reg[8] QDFFRBN $PINS Q=acc_reg[8] D=next_acc[8] CK=clk_clone1
+ RB=FE_OFN19_i_rst_n
Xacc_reg_reg[7] QDFFRBN $PINS Q=acc_reg[7] D=next_acc[7] CK=clk_clone1
+ RB=FE_OFN19_i_rst_n
Xacc_reg_reg[6] QDFFRBN $PINS Q=acc_reg[6] D=next_acc[6] CK=clk_clone1
+ RB=FE_OFN19_i_rst_n
Xacc_reg_reg[5] QDFFRBN $PINS Q=acc_reg[5] D=next_acc[5] CK=clk_clone1
+ RB=FE_OFN19_i_rst_n
Xacc_reg_reg[4] QDFFRBN $PINS Q=acc_reg[4] D=next_acc[4] CK=clk_clone1
+ RB=FE_OFN19_i_rst_n
Xacc_reg_reg[3] QDFFRBN $PINS Q=acc_reg[3] D=next_acc[3] CK=clk_clone1
+ RB=FE_OFN19_i_rst_n
Xacc_reg_reg[2] QDFFRBN $PINS Q=acc_reg[2] D=next_acc[2] CK=clk_clone1
+ RB=FE_OFN19_i_rst_n
Xacc_reg_reg[1] QDFFRBN $PINS Q=acc_reg[1] D=next_acc[1] CK=clk_clone1
+ RB=FE_OFN19_i_rst_n
Xacc_reg_reg[0] QDFFRBN $PINS Q=acc_reg[0] D=next_acc[0] CK=clk_clone1
+ RB=FE_OFN19_i_rst_n
Xacc_reg_reg[26] QDFFRBS $PINS Q=N251 D=next_acc[26] CK=clk_clone1
+ RB=FE_OFN19_i_rst_n
XU6 MUX2 $PINS O=sll_18/ML_int[2][3] S=FE_OFN329_h33_1 A=sll_18/ML_int[1][3]
+ B=sll_18/ML_int[1][1]
XU7 MUX2 $PINS O=sll_18/ML_int[2][4] S=FE_OFN329_h33_1 A=sll_18/ML_int[1][4]
+ B=sll_18/ML_int[1][2]
XU14 NR2P $PINS O=term1_in[0] I1=sign1[1] I2=n98
XU19 MUX2 $PINS O=sll_17/ML_int[1][1] S=shf2[0] A=term2_in[1] B=term2_in[0]
XU20 MUX2 $PINS O=N250 S=FE_OFN243_FE_DBTN9_n336 A=FE_PHN1291_acc_reg_25
+ B=FE_PHN1511_N251
XU21 MUX2 $PINS O=N249 S=FE_OFN243_FE_DBTN9_n336 A=acc_reg[24]
+ B=FE_PHN1511_N251
XU22 MUX2 $PINS O=FE_PHN1830_N247 S=FE_OFN243_FE_DBTN9_n336 A=acc_reg[22]
+ B=FE_PHN1511_N251
XU23 NR2 $PINS O=term1_shifted[0] I1=n51 I2=n49
XU24 NR2P $PINS O=term2_in[0] I1=sign2[1] I2=n98
XU25 OR2 $PINS O=n50 I1=n5 I2=shf1[1]
XU26 NR3HP $PINS O=sll_17/ML_int[1][0] I1=shf2[0] I2=sign2[1] I3=n98
XU27 OR2 $PINS O=n51 I1=shf1[2] I2=shf1[3]
XU28 OR2S $PINS O=n60 I1=n2 I2=shf2[1]
XU29 ND3 $PINS O=n49 I1=term1_in[0] I2=n32 I3=n34
XU33 NR2T $PINS O=term3_shifted[1] I1=n72 I2=n71
XU34 ND2P $PINS O=n71 I1=sll_18/ML_int[1][1] I2=n12
XU37 NR2P $PINS O=term3_shifted[2] I1=n72 I2=n74
XU41 NR2P $PINS O=term2_shifted[0] I1=n2 I2=n3
XU45 NR2 $PINS O=term1_in[1] I1=sign1[1] I2=FE_OFN393_mac_in_real_1
XU46 NR2P $PINS O=term2_in[2] I1=sign2[1] I2=FE_OFN370_mac_in_real_2
XU47 AN2 $PINS O=sll_16/ML_int[1][0] I1=term1_in[0] I2=n32
XU50 AO22P $PINS O=N152 A1=n19 A2=N125 B1=term3_shifted[1] B2=sign3[0]
XU54 NR2 $PINS O=term3_in[1] I1=FE_OFN441_s33_1 I2=FE_OFN393_mac_in_real_1
XU55 AO22S $PINS O=N177 A1=FE_OFN265_s33_0 A2=N150 B1=term3_shifted[26]
+ B2=FE_OFN433_s33_0
XU56 AO22S $PINS O=N176 A1=N149 A2=FE_OFN265_s33_0 B1=term3_shifted[25]
+ B2=FE_OFN433_s33_0
XU57 AO22S $PINS O=N175 A1=N148 A2=FE_OFN265_s33_0 B1=term3_shifted[24]
+ B2=FE_OFN433_s33_0
XU58 AO22S $PINS O=N174 A1=N147 A2=FE_OFN265_s33_0 B1=term3_shifted[23]
+ B2=FE_OFN433_s33_0
XU59 AO22S $PINS O=N173 A1=N146 A2=FE_OFN265_s33_0 B1=term3_shifted[22]
+ B2=FE_OFN433_s33_0
XU60 AO22 $PINS O=N172 A1=N145 A2=FE_OFN265_s33_0 B1=term3_shifted[21]
+ B2=FE_OFN433_s33_0
XU61 AO22S $PINS O=N171 A1=N144 A2=FE_OFN265_s33_0 B1=term3_shifted[20]
+ B2=FE_OFN433_s33_0
XU62 MUX2 $PINS O=sll_16/ML_int[1][5] S=shf1[0] A=term1_in[5] B=term1_in[4]
XU64 AO22 $PINS O=N44 A1=N17 A2=sign1[0] B1=term1_shifted[3] B2=n42
XU65 AO22S $PINS O=N67 A1=FE_OFN452_n A2=N40 B1=term1_shifted[26]
+ B2=FE_OFN437_n
XU66 AO22S $PINS O=N66 A1=N39 A2=FE_OFN452_n B1=term1_shifted[25]
+ B2=FE_OFN437_n
XU67 AO22 $PINS O=N65 A1=N38 A2=FE_OFN452_n B1=term1_shifted[24] B2=FE_OFN437_n
XU68 AO22S $PINS O=N64 A1=N37 A2=FE_OFN452_n B1=term1_shifted[23]
+ B2=FE_OFN437_n
XU69 AO22S $PINS O=N63 A1=N36 A2=FE_OFN452_n B1=term1_shifted[22]
+ B2=FE_OFN437_n
XU71 AO22S $PINS O=N61 A1=N34 A2=FE_OFN452_n B1=term1_shifted[20]
+ B2=FE_OFN437_n
XU73 AO22P $PINS O=N59 A1=N32 A2=FE_OFN452_n B1=term1_shifted[18]
+ B2=FE_OFN261_s31_0
XU74 AO22 $PINS O=N58 A1=N31 A2=FE_OFN452_n B1=term1_shifted[17]
+ B2=FE_OFN261_s31_0
XU75 AO22 $PINS O=N57 A1=N30 A2=FE_OFN452_n B1=term1_shifted[16]
+ B2=FE_OFN261_s31_0
XU76 AO22 $PINS O=N56 A1=N29 A2=FE_OFN452_n B1=term1_shifted[15]
+ B2=FE_OFN261_s31_0
XU77 AO22 $PINS O=N55 A1=N28 A2=FE_OFN452_n B1=term1_shifted[14]
+ B2=FE_OFN261_s31_0
XU78 MUX2 $PINS O=sll_16/ML_int[1][1] S=shf1[0] A=term1_in[1] B=term1_in[0]
XU79 NR2 $PINS O=term2_in[3] I1=sign2[1] I2=FE_OFN334_mac_in_real_3
XU82 NR2 $PINS O=term3_in[2] I1=FE_OFN441_s33_1 I2=FE_OFN370_mac_in_real_2
XU86 AO22 $PINS O=N111 A1=N84 A2=FE_OFN267_s32_0 B1=term2_shifted[15]
+ B2=FE_OFN268_s32_0
XU92 NR2 $PINS O=term1_in[3] I1=sign1[1] I2=FE_OFN334_mac_in_real_3
XU93 NR2 $PINS O=term2_in[4] I1=sign2[1] I2=FE_OFN411_mac_in_real_4
XU97 OR2 $PINS O=n3 I1=n62 I2=shf2[1]
XU98 INV2 $PINS O=n73 I=sll_18/ML_int[2][3]
XU100 INV2 $PINS O=n63 I=sll_17/ML_int[2][3]
XU103 AN2 $PINS O=base_val[15] I1=acc_reg[15] I2=n99
XU104 AN2 $PINS O=base_val[1] I1=acc_reg[1] I2=n99
XU107 AO22 $PINS O=N162 A1=N135 A2=FE_OFN265_s33_0 B1=term3_shifted[11]
+ B2=FE_OFN434_s33_0
XU108 AO22 $PINS O=N52 A1=N25 A2=sign1[0] B1=term1_shifted[11] B2=n42
XU112 OR2 $PINS O=n6 I1=n51 I2=shf1[1]
XU113 NR2P $PINS O=term1_shifted[3] I1=n51 I2=n52
XU118 MUX2S $PINS O=sll_18/ML_int[3][6] S=shf3[2] A=sll_18/ML_int[2][6]
+ B=sll_18/ML_int[2][2]
XU120 AO22 $PINS O=N120 A1=N93 A2=n29 B1=term2_shifted[24] B2=FE_OFN268_s32_0
XU121 AO22 $PINS O=N104 A1=N77 A2=FE_OFN366_s32_0 B1=term2_shifted[8]
+ B2=sign2[0]
XU122 AO22 $PINS O=N50 A1=N23 A2=sign1[0] B1=term1_shifted[9] B2=n42
XU123 AO22 $PINS O=N160 A1=N133 A2=n19 B1=term3_shifted[9] B2=sign3[0]
XU124 MUX2S $PINS O=sll_16/ML_int[3][6] S=shf1[2] A=sll_16/ML_int[2][6]
+ B=sll_16/ML_int[2][2]
XU125 MUX2 $PINS O=sll_17/ML_int[3][6] S=n24 A=sll_17/ML_int[2][6]
+ B=sll_17/ML_int[2][2]
XU126 AO22 $PINS O=N161 A1=N134 A2=n19 B1=term3_shifted[10] B2=sign3[0]
XU127 AO22 $PINS O=N105 A1=N78 A2=FE_OFN366_s32_0 B1=term2_shifted[9]
+ B2=sign2[0]
XU132 AO22 $PINS O=N45 A1=N18 A2=sign1[0] B1=term1_shifted[4] B2=n42
XU137 AO22 $PINS O=N54 A1=N27 A2=sign1[0] B1=term1_shifted[13]
+ B2=FE_OFN261_s31_0
XU138 AO22 $PINS O=N164 A1=N137 A2=FE_OFN265_s33_0 B1=term3_shifted[13]
+ B2=FE_OFN434_s33_0
XU139 AN2 $PINS O=base_val[0] I1=acc_reg[0] I2=n99
XU142 MUX2S $PINS O=sll_17/ML_int[3][11] S=n24 A=sll_17/ML_int[2][11]
+ B=sll_17/ML_int[2][7]
XU143 MUX2S $PINS O=sll_16/ML_int[2][12] S=FE_OFN461_h31_1
+ A=sll_16/ML_int[1][12] B=sll_16/ML_int[1][10]
XU144 MUX2S $PINS O=sll_18/ML_int[2][12] S=FE_OFN329_h33_1
+ A=sll_18/ML_int[1][12] B=sll_18/ML_int[1][10]
XU145 MUX2S $PINS O=sll_17/ML_int[2][12] S=shf2[1] A=sll_17/ML_int[1][12]
+ B=sll_17/ML_int[1][10]
XU146 MUX2S $PINS O=sll_16/ML_int[1][11] S=shf1[0] A=term1_in[11]
+ B=term1_in[10]
XU147 MUX2S $PINS O=sll_18/ML_int[1][11] S=shf3[0] A=term3_in[11]
+ B=term3_in[10]
XU148 MUX2S $PINS O=sll_16/ML_int[3][14] S=FE_OFN293_h31_2
+ A=sll_16/ML_int[2][14] B=sll_16/ML_int[2][10]
XU155 MUX2S $PINS O=sll_17/ML_int[1][11] S=shf2[0] A=term2_in[11]
+ B=term2_in[10]
XU157 MUX2S $PINS O=sll_18/ML_int[3][14] S=n14 A=sll_18/ML_int[2][14]
+ B=sll_18/ML_int[2][10]
XU158 MUX2S $PINS O=sll_17/ML_int[3][14] S=n24 A=sll_17/ML_int[2][14]
+ B=sll_17/ML_int[2][10]
XU159 MUX2S $PINS O=sll_16/ML_int[2][13] S=FE_OFN461_h31_1
+ A=sll_16/ML_int[1][13] B=sll_16/ML_int[1][11]
XU166 MUX2S $PINS O=sll_16/ML_int[1][13] S=shf1[0] A=term1_in[13]
+ B=term1_in[12]
XU167 MUX2S $PINS O=sll_18/ML_int[2][13] S=shf3[1] A=sll_18/ML_int[1][13]
+ B=sll_18/ML_int[1][11]
XU168 MUX2S $PINS O=sll_18/ML_int[1][13] S=shf3[0] A=term3_in[13]
+ B=term3_in[12]
XU171 MUX2S $PINS O=sll_17/ML_int[2][13] S=shf2[1] A=sll_17/ML_int[1][13]
+ B=sll_17/ML_int[1][11]
XU180 MUX2S $PINS O=sll_17/ML_int[1][13] S=shf2[0] A=term2_in[13]
+ B=term2_in[12]
XU182 MUX2S $PINS O=sll_16/ML_int[1][12] S=shf1[0] A=term1_in[12]
+ B=term1_in[11]
XU186 MUX2S $PINS O=sll_18/ML_int[1][12] S=shf3[0] A=term3_in[12]
+ B=term3_in[11]
XU187 MUX2S $PINS O=sll_16/ML_int[3][15] S=FE_OFN293_h31_2
+ A=sll_16/ML_int[2][15] B=sll_16/ML_int[2][11]
XU191 MUX2S $PINS O=sll_17/ML_int[1][12] S=shf2[0] A=term2_in[12]
+ B=term2_in[11]
XU192 MUX2S $PINS O=sll_18/ML_int[3][15] S=n14 A=sll_18/ML_int[2][15]
+ B=sll_18/ML_int[2][11]
XU193 MUX2S $PINS O=term2_shifted[15] S=n26 A=sll_17/ML_int[3][15]
+ B=sll_17/ML_int[3][7]
XU194 MUX2S $PINS O=sll_17/ML_int[3][15] S=n24 A=sll_17/ML_int[2][15]
+ B=sll_17/ML_int[2][11]
XU195 MUX2S $PINS O=sll_16/ML_int[2][14] S=FE_OFN461_h31_1
+ A=sll_16/ML_int[1][14] B=sll_16/ML_int[1][12]
XU196 MUX2S $PINS O=sll_16/ML_int[1][14] S=shf1[0] A=term1_in[14]
+ B=term1_in[13]
XU197 MUX2S $PINS O=sll_18/ML_int[2][14] S=shf3[1] A=sll_18/ML_int[1][14]
+ B=sll_18/ML_int[1][12]
XU198 MUX2S $PINS O=sll_18/ML_int[1][14] S=shf3[0] A=term3_in[14]
+ B=term3_in[13]
XU199 MUX2S $PINS O=sll_17/ML_int[2][14] S=shf2[1] A=sll_17/ML_int[1][14]
+ B=sll_17/ML_int[1][12]
XU200 MUX2S $PINS O=sll_17/ML_int[1][14] S=shf2[0] A=term2_in[14]
+ B=term2_in[13]
XU201 MUX2S $PINS O=sll_16/ML_int[3][16] S=FE_OFN293_h31_2 A=n56
+ B=sll_16/ML_int[2][12]
XU202 MUX2S $PINS O=sll_18/ML_int[3][16] S=n14 A=n77 B=sll_18/ML_int[2][12]
XU203 MUX2S $PINS O=sll_16/ML_int[2][15] S=FE_OFN461_h31_1
+ A=sll_16/ML_int[1][15] B=sll_16/ML_int[1][13]
XU204 MUX2S $PINS O=sll_17/ML_int[3][16] S=n24 A=n66 B=sll_17/ML_int[2][12]
XU205 MUX2S $PINS O=sll_16/ML_int[1][15] S=shf1[0] A=term1_in[15]
+ B=term1_in[14]
XU206 MUX2S $PINS O=sll_18/ML_int[2][15] S=shf3[1] A=sll_18/ML_int[1][15]
+ B=sll_18/ML_int[1][13]
XU207 MUX2S $PINS O=sll_18/ML_int[1][15] S=shf3[0] A=term3_in[15]
+ B=term3_in[14]
XU208 MUX2S $PINS O=sll_17/ML_int[2][15] S=shf2[1] A=sll_17/ML_int[1][15]
+ B=sll_17/ML_int[1][13]
XU209 MUX2S $PINS O=sll_17/ML_int[1][15] S=shf2[0] A=term2_in[15]
+ B=term2_in[14]
XU210 MUX2S $PINS O=sll_16/ML_int[3][17] S=FE_OFN293_h31_2 A=n57
+ B=sll_16/ML_int[2][13]
XU211 MUX2S $PINS O=sll_18/ML_int[3][17] S=n14 A=n78 B=sll_18/ML_int[2][13]
XU212 MUX2S $PINS O=sll_17/ML_int[3][17] S=n24 A=n67 B=sll_17/ML_int[2][13]
XU213 MUX2S $PINS O=term1_shifted[18] S=shf1[3] A=sll_16/ML_int[3][18]
+ B=sll_16/ML_int[3][10]
XU214 MUX2S $PINS O=term3_shifted[18] S=FE_OFN322_h33_3 A=sll_18/ML_int[3][18]
+ B=sll_18/ML_int[3][10]
XU215 MUX2S $PINS O=sll_16/ML_int[3][18] S=FE_OFN293_h31_2 A=n58
+ B=sll_16/ML_int[2][14]
XU216 MUX2S $PINS O=term2_shifted[18] S=FE_OFN323_h32_3 A=sll_17/ML_int[3][18]
+ B=sll_17/ML_int[3][10]
XU217 MUX2S $PINS O=sll_18/ML_int[3][18] S=n14 A=n79 B=sll_18/ML_int[2][14]
XU218 MUX2S $PINS O=sll_17/ML_int[3][18] S=n24 A=n68 B=sll_17/ML_int[2][14]
XU219 MUX2S $PINS O=term1_shifted[19] S=shf1[3] A=sll_16/ML_int[3][19]
+ B=sll_16/ML_int[3][11]
XU220 MUX2S $PINS O=sll_16/ML_int[3][19] S=FE_OFN293_h31_2 A=term1_in[26]
+ B=sll_16/ML_int[2][15]
XU221 MUX2S $PINS O=term3_shifted[19] S=shf3[3] A=sll_18/ML_int[3][19]
+ B=sll_18/ML_int[3][11]
XU222 MUX2S $PINS O=sll_18/ML_int[3][19] S=n14 A=term3_in[26]
+ B=sll_18/ML_int[2][15]
XU223 MUX2S $PINS O=term2_shifted[19] S=FE_OFN323_h32_3 A=sll_17/ML_int[3][19]
+ B=sll_17/ML_int[3][11]
XU224 MUX2S $PINS O=sll_17/ML_int[3][19] S=n24 A=term2_in[26]
+ B=sll_17/ML_int[2][15]
XU225 MUX2S $PINS O=term1_shifted[20] S=shf1[3] A=sll_16/ML_int[3][20]
+ B=sll_16/ML_int[3][12]
XU226 MUX2S $PINS O=sll_16/ML_int[3][20] S=FE_OFN293_h31_2 A=term1_in[26] B=n56
XU227 MUX2S $PINS O=term3_shifted[20] S=shf3[3] A=sll_18/ML_int[3][20]
+ B=sll_18/ML_int[3][12]
XU228 MUX2S $PINS O=sll_18/ML_int[3][20] S=n14 A=term3_in[26] B=n77
XU229 MUX2S $PINS O=term2_shifted[20] S=FE_OFN323_h32_3 A=sll_17/ML_int[3][20]
+ B=sll_17/ML_int[3][12]
XU230 MUX2S $PINS O=sll_17/ML_int[3][20] S=n24 A=term2_in[26] B=n66
XU231 MUX2S $PINS O=term1_shifted[21] S=shf1[3] A=sll_16/ML_int[3][21]
+ B=sll_16/ML_int[3][13]
XU232 MUX2S $PINS O=sll_16/ML_int[3][21] S=FE_OFN293_h31_2 A=term1_in[26] B=n57
XU233 MUX2S $PINS O=term3_shifted[21] S=shf3[3] A=sll_18/ML_int[3][21]
+ B=sll_18/ML_int[3][13]
XU234 MUX2S $PINS O=sll_18/ML_int[3][21] S=n14 A=term3_in[26] B=n78
XU235 MUX2S $PINS O=term2_shifted[21] S=FE_OFN323_h32_3 A=sll_17/ML_int[3][21]
+ B=sll_17/ML_int[3][13]
XU236 MUX2S $PINS O=sll_17/ML_int[3][21] S=n24 A=term2_in[26] B=n67
XU237 MUX2S $PINS O=term1_shifted[22] S=shf1[3] A=sll_16/ML_int[3][22]
+ B=sll_16/ML_int[3][14]
XU238 MUX2S $PINS O=sll_16/ML_int[3][22] S=FE_OFN293_h31_2 A=term1_in[26] B=n58
XU239 MUX2S $PINS O=term3_shifted[22] S=shf3[3] A=sll_18/ML_int[3][22]
+ B=sll_18/ML_int[3][14]
XU240 MUX2S $PINS O=sll_18/ML_int[3][22] S=n14 A=term3_in[26] B=n79
XU241 MUX2S $PINS O=term2_shifted[22] S=FE_OFN323_h32_3 A=sll_17/ML_int[3][22]
+ B=sll_17/ML_int[3][14]
XU242 MUX2S $PINS O=sll_17/ML_int[3][22] S=n24 A=term2_in[26] B=n68
XU243 MUX2S $PINS O=term1_shifted[23] S=shf1[3] A=term1_in[26]
+ B=sll_16/ML_int[3][15]
XU244 MUX2S $PINS O=term1_shifted[24] S=shf1[3] A=term1_in[26]
+ B=sll_16/ML_int[3][16]
XU245 MUX2S $PINS O=term2_shifted[24] S=FE_OFN323_h32_3 A=term2_in[26]
+ B=sll_17/ML_int[3][16]
XU246 MUX2S $PINS O=term1_shifted[25] S=shf1[3] A=term1_in[26]
+ B=sll_16/ML_int[3][17]
XU247 MUX2S $PINS O=term2_shifted[25] S=FE_OFN323_h32_3 A=term2_in[26]
+ B=sll_17/ML_int[3][17]
XU248 MUX2S $PINS O=term1_shifted[26] S=shf1[3] A=term1_in[26]
+ B=sll_16/ML_int[3][18]
XU249 MUX2S $PINS O=term2_shifted[26] S=FE_OFN323_h32_3 A=term2_in[26]
+ B=sll_17/ML_int[3][18]
XU252 AO22S $PINS O=N109 A1=N82 A2=FE_OFN267_s32_0 B1=term2_shifted[13]
+ B2=FE_OFN268_s32_0
XU254 MUX2S $PINS O=N235 S=FE_OFN243_FE_DBTN9_n336 A=acc_reg[10] B=acc_reg[14]
XU255 MUX2S $PINS O=N236 S=FE_OFN243_FE_DBTN9_n336 A=acc_reg[11] B=acc_reg[15]
XU256 MUX2S $PINS O=N237 S=FE_OFN243_FE_DBTN9_n336 A=FE_PHN1444_acc_reg_12
+ B=acc_reg[16]
XU257 MUX2S $PINS O=FE_PHN1449_N238 S=FE_OFN243_FE_DBTN9_n336 A=acc_reg[13]
+ B=acc_reg[17]
XU258 MUX2S $PINS O=N239 S=FE_OFN243_FE_DBTN9_n336 A=acc_reg[14] B=acc_reg[18]
XU259 MUX2S $PINS O=FE_PHN1439_N240 S=FE_OFN243_FE_DBTN9_n336 A=acc_reg[15]
+ B=acc_reg[19]
XU260 MUX2S $PINS O=N242 S=FE_OFN243_FE_DBTN9_n336 A=acc_reg[17] B=acc_reg[21]
XU261 MUX2S $PINS O=N245 S=FE_OFN243_FE_DBTN9_n336 A=acc_reg[20] B=acc_reg[24]
XU262 MUX2S $PINS O=N246 S=FE_OFN243_FE_DBTN9_n336 A=acc_reg[21]
+ B=FE_PHN1291_acc_reg_25
XU263 INV1S $PINS O=n54 I=n49
XU264 INV1S $PINS O=n75 I=FE_OCPN1144_n70
XU265 INV1S $PINS O=n64 I=n60
XU266 INV1S $PINS O=n55 I=n50
XU267 INV1S $PINS O=n76 I=n71
XU268 INV1S $PINS O=n65 I=n61
XU269 NR2 $PINS O=term3_in[3] I1=FE_OFN441_s33_1 I2=FE_OFN334_mac_in_real_3
XU270 NR2 $PINS O=term3_in[4] I1=FE_OFN441_s33_1 I2=FE_OFN411_mac_in_real_4
XU271 NR2 $PINS O=term1_in[5] I1=sign1[1] I2=x_in[5]
XU272 NR2 $PINS O=term3_in[5] I1=FE_OFN441_s33_1 I2=x_in[5]
XU273 NR2 $PINS O=term2_in[5] I1=sign2[1] I2=x_in[5]
XU274 NR2 $PINS O=term1_in[8] I1=sign1[1] I2=x_in[8]
XU275 NR2 $PINS O=term3_in[8] I1=FE_OFN441_s33_1 I2=x_in[8]
XU276 NR2 $PINS O=term1_in[6] I1=sign1[1] I2=x_in[6]
XU277 NR2 $PINS O=term2_in[8] I1=sign2[1] I2=x_in[8]
XU278 NR2 $PINS O=term3_in[6] I1=FE_OFN441_s33_1 I2=x_in[6]
XU279 NR2 $PINS O=term2_in[6] I1=sign2[1] I2=x_in[6]
XU280 NR2 $PINS O=term1_in[9] I1=sign1[1] I2=x_in[9]
XU281 NR2 $PINS O=term3_in[9] I1=FE_OFN441_s33_1 I2=x_in[9]
XU282 NR2 $PINS O=term1_in[7] I1=sign1[1] I2=x_in[7]
XU283 NR2 $PINS O=term3_in[7] I1=FE_OFN441_s33_1 I2=x_in[7]
XU284 NR2 $PINS O=term2_in[9] I1=sign2[1] I2=x_in[9]
XU285 NR2 $PINS O=term2_in[7] I1=sign2[1] I2=x_in[7]
XU287 NR2 $PINS O=term1_in[10] I1=sign1[1] I2=x_in[10]
XU288 NR2 $PINS O=term3_in[10] I1=FE_OFN441_s33_1 I2=x_in[10]
XU289 NR2 $PINS O=term2_in[10] I1=sign2[1] I2=x_in[10]
XU294 NR2 $PINS O=term1_in[11] I1=sign1[1] I2=x_in[11]
XU295 NR2 $PINS O=term3_in[11] I1=FE_OFN441_s33_1 I2=x_in[11]
XU296 NR2 $PINS O=term2_in[11] I1=sign2[1] I2=x_in[11]
XU297 NR2 $PINS O=term1_in[12] I1=sign1[1] I2=x_in[12]
XU298 NR2 $PINS O=term3_in[12] I1=FE_OFN441_s33_1 I2=x_in[12]
XU299 NR2 $PINS O=term2_in[12] I1=sign2[1] I2=x_in[12]
XU301 NR2 $PINS O=term1_in[13] I1=sign1[1] I2=x_in[13]
XU302 NR2 $PINS O=term3_in[13] I1=FE_OFN441_s33_1 I2=x_in[13]
XU303 NR2 $PINS O=term2_in[13] I1=sign2[1] I2=x_in[13]
XU304 NR2 $PINS O=term1_in[14] I1=sign1[1] I2=x_in[14]
XU305 NR2 $PINS O=term3_in[14] I1=FE_OFN441_s33_1 I2=x_in[14]
XU306 NR2 $PINS O=term2_in[14] I1=sign2[1] I2=x_in[14]
XU307 NR2 $PINS O=term1_in[15] I1=sign1[1] I2=n87
XU309 NR2 $PINS O=term3_in[15] I1=FE_OFN441_s33_1 I2=n87
XU310 NR2 $PINS O=term1_in[26] I1=n88 I2=sign1[1]
XU311 NR2 $PINS O=term3_in[26] I1=n88 I2=FE_OFN441_s33_1
XU312 NR2 $PINS O=term2_in[15] I1=sign2[1] I2=n87
XU314 NR2 $PINS O=term2_in[26] I1=n88 I2=sign2[1]
XU323 INV1S $PINS O=n34 I=shf1[1]
XU334 INV1S $PINS O=n87 I=x_in[15]
XU335 INV1S $PINS O=n88 I=x_in[16]
XU336 AN2 $PINS O=base_val[26] I1=FE_PHN2091_N251 I2=n99
XU337 MOAI1S $PINS O=base_val[9] A1=FE_OFN243_FE_DBTN9_n336 A2=n99
+ B1=acc_reg[9] B2=n99
XU338 AN2 $PINS O=base_val[10] I1=acc_reg[10] I2=n99
XU339 AN2 $PINS O=base_val[8] I1=acc_reg[8] I2=n99
XU340 AN2 $PINS O=base_val[6] I1=acc_reg[6] I2=n99
XU341 AN2 $PINS O=base_val[7] I1=acc_reg[7] I2=n99
XU342 AN2 $PINS O=base_val[5] I1=acc_reg[5] I2=n99
XU343 AN2 $PINS O=base_val[4] I1=acc_reg[4] I2=n99
XU344 AN2 $PINS O=base_val[3] I1=acc_reg[3] I2=n99
XU345 AN2 $PINS O=base_val[2] I1=acc_reg[2] I2=n99
XU346 AN2 $PINS O=base_val[11] I1=acc_reg[11] I2=n99
XU347 AN2 $PINS O=base_val[12] I1=acc_reg[12] I2=n99
XU348 AN2 $PINS O=base_val[14] I1=acc_reg[14] I2=n99
XU349 AN2 $PINS O=base_val[16] I1=acc_reg[16] I2=n99
XU350 AN2 $PINS O=base_val[17] I1=acc_reg[17] I2=n99
XU351 AN2 $PINS O=base_val[18] I1=acc_reg[18] I2=n99
XU352 AN2 $PINS O=base_val[19] I1=acc_reg[19] I2=n99
XU353 AN2 $PINS O=base_val[20] I1=acc_reg[20] I2=n99
XU354 AN2 $PINS O=base_val[21] I1=acc_reg[21] I2=n99
XU355 AN2 $PINS O=base_val[22] I1=acc_reg[22] I2=n99
XU356 AN2 $PINS O=base_val[23] I1=acc_reg[23] I2=n99
XU357 AN2 $PINS O=base_val[24] I1=acc_reg[24] I2=n99
XU358 AN2 $PINS O=base_val[25] I1=acc_reg[25] I2=n99
XU360 AN2 $PINS O=N234 I1=en I2=calc_done
XU364 NR2 $PINS O=sll_16/ML_int[3][0] I1=shf1[2] I2=n49
XU365 NR2 $PINS O=sll_16/ML_int[3][1] I1=shf1[2] I2=n50
XU366 NR2 $PINS O=sll_16/ML_int[3][2] I1=shf1[2] I2=n53
XU367 NR2 $PINS O=sll_16/ML_int[3][3] I1=shf1[2] I2=n52
XU368 AN2 $PINS O=term1_shifted[4] I1=sll_16/ML_int[3][4] I2=FE_OFN150_h31_3
XU369 AN2 $PINS O=term1_shifted[5] I1=sll_16/ML_int[3][5] I2=FE_OFN150_h31_3
XU370 AN2 $PINS O=term1_shifted[6] I1=sll_16/ML_int[3][6] I2=FE_OFN150_h31_3
XU371 AN2 $PINS O=term1_shifted[7] I1=sll_16/ML_int[3][7] I2=FE_OFN150_h31_3
XU372 MUX2 $PINS O=n56 S=FE_OFN461_h31_1 A=n59 B=sll_16/ML_int[1][14]
XU373 MUX2 $PINS O=n57 S=FE_OFN461_h31_1 A=term1_in[26] B=sll_16/ML_int[1][15]
XU374 MUX2 $PINS O=n58 S=FE_OFN461_h31_1 A=term1_in[26] B=n59
XU375 MUX2 $PINS O=n59 S=shf1[0] A=term1_in[26] B=term1_in[15]
XU376 NR2 $PINS O=sll_17/ML_int[3][0] I1=n24 I2=n60
XU377 NR2 $PINS O=sll_17/ML_int[3][1] I1=n24 I2=n61
XU378 NR2 $PINS O=sll_17/ML_int[3][2] I1=n24 I2=n1
XU379 NR2 $PINS O=sll_17/ML_int[3][3] I1=n24 I2=n63
XU380 ND2 $PINS O=n62 I1=shf2[2] I2=shf2[3]
XU381 NR2P $PINS O=term2_shifted[3] I1=n62 I2=n63
XU382 AN2 $PINS O=term2_shifted[4] I1=sll_17/ML_int[3][4] I2=shf2[3]
XU383 AN2 $PINS O=term2_shifted[5] I1=sll_17/ML_int[3][5] I2=shf2[3]
XU384 AN2 $PINS O=term2_shifted[6] I1=sll_17/ML_int[3][6] I2=shf2[3]
XU385 AN2 $PINS O=term2_shifted[7] I1=sll_17/ML_int[3][7] I2=shf2[3]
XU386 MUX2 $PINS O=n66 S=shf2[1] A=n69 B=sll_17/ML_int[1][14]
XU387 MUX2 $PINS O=n67 S=shf2[1] A=term2_in[26] B=sll_17/ML_int[1][15]
XU388 MUX2 $PINS O=n68 S=shf2[1] A=term2_in[26] B=n69
XU389 MUX2 $PINS O=n69 S=shf2[0] A=term2_in[26] B=term2_in[15]
XU390 NR2 $PINS O=sll_18/ML_int[3][0] I1=shf3[2] I2=FE_OCPN1144_n70
XU391 NR2 $PINS O=sll_18/ML_int[3][1] I1=shf3[2] I2=FE_OCPN1166_n71
XU392 NR2 $PINS O=sll_18/ML_int[3][2] I1=shf3[2] I2=n74
XU393 NR2 $PINS O=sll_18/ML_int[3][3] I1=shf3[2] I2=n73
XU394 ND2P $PINS O=n72 I1=FE_OFN287_h33_2 I2=n15
XU395 NR2 $PINS O=term3_shifted[3] I1=n72 I2=n73
XU396 AN2 $PINS O=term3_shifted[4] I1=sll_18/ML_int[3][4] I2=n15
XU397 AN2 $PINS O=term3_shifted[5] I1=sll_18/ML_int[3][5] I2=n15
XU398 AN2 $PINS O=term3_shifted[6] I1=sll_18/ML_int[3][6] I2=n15
XU399 AN2 $PINS O=term3_shifted[7] I1=sll_18/ML_int[3][7] I2=n15
XU400 MUX2 $PINS O=term3_shifted[24] S=shf3[3] A=term3_in[26]
+ B=sll_18/ML_int[3][16]
XU401 MUX2 $PINS O=n77 S=shf3[1] A=n80 B=sll_18/ML_int[1][14]
XU402 MUX2 $PINS O=term3_shifted[25] S=shf3[3] A=term3_in[26]
+ B=sll_18/ML_int[3][17]
XU403 MUX2 $PINS O=n78 S=shf3[1] A=term3_in[26] B=sll_18/ML_int[1][15]
XU404 MUX2 $PINS O=term3_shifted[26] S=shf3[3] A=term3_in[26]
+ B=sll_18/ML_int[3][18]
XU405 MUX2 $PINS O=n79 S=shf3[1] A=term3_in[26] B=n80
XU406 MUX2 $PINS O=n80 S=shf3[0] A=term3_in[26] B=term3_in[15]
XU407 MUX2 $PINS O=FE_PHN1836_N241 S=FE_OFN243_FE_DBTN9_n336 A=acc_reg[16]
+ B=acc_reg[20]
XU408 MUX2 $PINS O=N243 S=FE_OFN243_FE_DBTN9_n336 A=acc_reg[18] B=acc_reg[22]
XU409 MUX2 $PINS O=N244 S=FE_OFN243_FE_DBTN9_n336 A=acc_reg[19] B=acc_reg[23]
Xsll_18/M1_2_8 MUX2S $PINS O=sll_18/ML_int[3][8] S=shf3[2]
+ A=sll_18/ML_int[2][8] B=sll_18/ML_int[2][4]
Xsll_17/M1_1_2 MUX2S $PINS O=sll_17/ML_int[2][2] S=shf2[1]
+ A=sll_17/ML_int[1][2] B=sll_17/ML_int[1][0]
XU4 INV2 $PINS O=n5 I=sll_16/ML_int[1][1]
XU5 INV2 $PINS O=n2 I=sll_17/ML_int[1][0]
XU9 ND2P $PINS O=n61 I1=sll_17/ML_int[1][1] I2=FE_OFN162_h32_1
XU10 ND2P $PINS O=n70 I1=sll_18/ML_int[1][0] I2=n12
XU12 NR2 $PINS O=term2_shifted[2] I1=n62 I2=n1
XU13 INV4 $PINS O=n98 I=x_in[0]
XU16 INV2 $PINS O=n74 I=sll_18/ML_int[2][2]
XU18 AO22 $PINS O=N42 A1=N15 A2=sign1[0] B1=term1_shifted[1] B2=n42
XU30 NR2 $PINS O=term3_in[0] I1=FE_OFN441_s33_1 I2=n98
XU36 NR2 $PINS O=term2_in[1] I1=sign2[1] I2=FE_OFN393_mac_in_real_1
XU38 MUX2 $PINS O=N248 S=FE_OFN243_FE_DBTN9_n336 A=acc_reg[23]
+ B=FE_PHN1511_N251
XU39 NR2P $PINS O=term1_shifted[1] I1=n5 I2=n6
XU42 NR2P $PINS O=term1_shifted[2] I1=n51 I2=n53
XU44 AN2 $PINS O=sll_18/ML_int[1][0] I1=term3_in[0] I2=n10
XU48 NR2T $PINS O=term1_in[4] I1=sign1[1] I2=FE_OFN411_mac_in_real_4
XU81 INV2 $PINS O=n53 I=sll_16/ML_int[2][2]
XU84 NR2 $PINS O=term1_in[2] I1=sign1[1] I2=FE_OFN370_mac_in_real_2
XU85 NR2T $PINS O=term3_shifted[0] I1=n72 I2=n70
XU94 MXL2HS $PINS OB=n1 S=shf2[1] A=sll_17/ML_int[1][2] B=sll_17/ML_int[1][0]
XU95 NR2T $PINS O=term2_shifted[1] I1=n62 I2=n61
Xclk_gate_y_out_reg SNPS_CLOCK_GATE_HIGH_PE_Shift_Add_1 $PINS EN=N234
+ ENCLK=CTS_12 CLK=clk
Xsub_28_3 PE_Shift_Add_1_DW01_sub_0_DW01_sub_3 $PINS A[26]=net45598
+ A[25]=net45598 A[24]=net45598 A[23]=net45598 A[22]=net45598 A[21]=net45598
+ A[20]=net45598 A[19]=net45598 A[18]=net45598 A[17]=net45598 A[16]=net45598
+ A[15]=net45598 A[14]=net45598 A[13]=net45598 A[12]=net45598 A[11]=net45598
+ A[10]=net45598 A[9]=net45598 A[8]=net45598 A[7]=net45598 A[6]=net45598
+ A[5]=net45598 A[4]=net45598 A[3]=net45598 A[2]=net45598 A[1]=net45598
+ A[0]=net45598 B[26]=term3_shifted[26] B[25]=term3_shifted[25]
+ B[24]=term3_shifted[24] B[23]=term3_shifted[23] B[22]=term3_shifted[22]
+ B[21]=term3_shifted[21] B[20]=term3_shifted[20] B[19]=term3_shifted[19]
+ B[18]=term3_shifted[18] B[17]=term3_shifted[17] B[16]=term3_shifted[16]
+ B[15]=term3_shifted[15] B[14]=term3_shifted[14] B[13]=term3_shifted[13]
+ B[12]=term3_shifted[12] B[11]=term3_shifted[11] B[10]=term3_shifted[10]
+ B[9]=term3_shifted[9] B[8]=term3_shifted[8] B[7]=term3_shifted[7]
+ B[6]=term3_shifted[6] B[5]=term3_shifted[5] B[4]=term3_shifted[4]
+ B[3]=term3_shifted[3] B[2]=term3_shifted[2] B[1]=term3_shifted[1]
+ B[0]=term3_shifted[0] CI=net45598 DIFF[26]=N150 DIFF[25]=N149 DIFF[24]=N148
+ DIFF[23]=N147 DIFF[22]=N146 DIFF[21]=N145 DIFF[20]=N144 DIFF[19]=N143
+ DIFF[18]=N142 DIFF[17]=N141 DIFF[16]=N140 DIFF[15]=N139 DIFF[14]=N138
+ DIFF[13]=N137 DIFF[12]=N136 DIFF[11]=N135 DIFF[10]=N134 DIFF[9]=N133
+ DIFF[8]=N132 DIFF[7]=N131 DIFF[6]=N130 DIFF[5]=N129 DIFF[4]=N128 DIFF[3]=N127
+ DIFF[2]=N126 DIFF[1]=N125 DIFF[0]=N124
Xsub_28_2 PE_Shift_Add_1_DW01_sub_1_DW01_sub_4 $PINS A[26]=net45598
+ A[25]=net45598 A[24]=net45598 A[23]=net45598 A[22]=net45598 A[21]=net45598
+ A[20]=net45598 A[19]=net45598 A[18]=net45598 A[17]=net45598 A[16]=net45598
+ A[15]=net45598 A[14]=net45598 A[13]=net45598 A[12]=net45598 A[11]=net45598
+ A[10]=net45598 A[9]=net45598 A[8]=net45598 A[7]=net45598 A[6]=net45598
+ A[5]=net45598 A[4]=net45598 A[3]=net45598 A[2]=net45598 A[1]=net45598
+ A[0]=net45598 B[26]=term2_shifted[26] B[25]=term2_shifted[25]
+ B[24]=term2_shifted[24] B[23]=term2_shifted[23] B[22]=term2_shifted[22]
+ B[21]=term2_shifted[21] B[20]=term2_shifted[20] B[19]=term2_shifted[19]
+ B[18]=term2_shifted[18] B[17]=term2_shifted[17] B[16]=term2_shifted[16]
+ B[15]=term2_shifted[15] B[14]=term2_shifted[14] B[13]=term2_shifted[13]
+ B[12]=term2_shifted[12] B[11]=term2_shifted[11] B[10]=term2_shifted[10]
+ B[9]=term2_shifted[9] B[8]=term2_shifted[8] B[7]=term2_shifted[7]
+ B[6]=term2_shifted[6] B[5]=term2_shifted[5] B[4]=term2_shifted[4]
+ B[3]=term2_shifted[3] B[2]=term2_shifted[2] B[1]=term2_shifted[1]
+ B[0]=term2_shifted[0] CI=net45598 DIFF[26]=N95 DIFF[25]=N94 DIFF[24]=N93
+ DIFF[23]=N92 DIFF[22]=N91 DIFF[21]=N90 DIFF[20]=N89 DIFF[19]=N88 DIFF[18]=N87
+ DIFF[17]=N86 DIFF[16]=N85 DIFF[15]=N84 DIFF[14]=N83 DIFF[13]=N82 DIFF[12]=N81
+ DIFF[11]=N80 DIFF[10]=N79 DIFF[9]=N78 DIFF[8]=N77 DIFF[7]=N76 DIFF[6]=N75
+ DIFF[5]=N74 DIFF[4]=N73 DIFF[3]=N72 DIFF[2]=N71 DIFF[1]=N70 DIFF[0]=N69
Xsub_28 PE_Shift_Add_1_DW01_sub_2_DW01_sub_5 $PINS A[26]=net45598
+ A[25]=net45598 A[24]=net45598 A[23]=net45598 A[22]=net45598 A[21]=net45598
+ A[20]=net45598 A[19]=net45598 A[18]=net45598 A[17]=net45598 A[16]=net45598
+ A[15]=net45598 A[14]=net45598 A[13]=net45598 A[12]=net45598 A[11]=net45598
+ A[10]=net45598 A[9]=net45598 A[8]=net45598 A[7]=net45598 A[6]=net45598
+ A[5]=net45598 A[4]=net45598 A[3]=net45598 A[2]=net45598 A[1]=net45598
+ A[0]=net45598 B[26]=term1_shifted[26] B[25]=term1_shifted[25]
+ B[24]=term1_shifted[24] B[23]=term1_shifted[23] B[22]=term1_shifted[22]
+ B[21]=term1_shifted[21] B[20]=term1_shifted[20] B[19]=term1_shifted[19]
+ B[18]=term1_shifted[18] B[17]=term1_shifted[17] B[16]=term1_shifted[16]
+ B[15]=term1_shifted[15] B[14]=term1_shifted[14] B[13]=term1_shifted[13]
+ B[12]=term1_shifted[12] B[11]=term1_shifted[11] B[10]=term1_shifted[10]
+ B[9]=term1_shifted[9] B[8]=term1_shifted[8] B[7]=term1_shifted[7]
+ B[6]=term1_shifted[6] B[5]=term1_shifted[5] B[4]=term1_shifted[4]
+ B[3]=term1_shifted[3] B[2]=term1_shifted[2] B[1]=term1_shifted[1]
+ B[0]=term1_shifted[0] CI=net45598 DIFF[26]=N40 DIFF[25]=N39 DIFF[24]=N38
+ DIFF[23]=N37 DIFF[22]=N36 DIFF[21]=N35 DIFF[20]=N34 DIFF[19]=N33 DIFF[18]=N32
+ DIFF[17]=N31 DIFF[16]=N30 DIFF[15]=N29 DIFF[14]=N28 DIFF[13]=N27 DIFF[12]=N26
+ DIFF[11]=N25 DIFF[10]=N24 DIFF[9]=N23 DIFF[8]=N22 DIFF[7]=N21 DIFF[6]=N20
+ DIFF[5]=N19 DIFF[4]=N18 DIFF[3]=N17 DIFF[2]=N16 DIFF[1]=N15 DIFF[0]=N14
Xadd_1_root_add_0_root_add_28_3 PE_Shift_Add_1_DW01_add_2_DW01_add_28 $PINS
+ A[26]=N67 A[25]=N66 A[24]=N65 A[23]=N64 A[22]=N63 A[21]=N62 A[20]=N61 A[19]=N60
+ A[18]=N59 A[17]=N58 A[16]=N57 A[15]=N56 A[14]=N55 A[13]=N54 A[12]=N53 A[11]=N52
+ A[10]=N51 A[9]=N50 A[8]=N49 A[7]=N48 A[6]=N47 A[5]=N46 A[4]=N45 A[3]=N44
+ A[2]=N43 A[1]=N42 A[0]=N41 B[26]=N177 B[25]=N176 B[24]=N175 B[23]=N174
+ B[22]=N173 B[21]=N172 B[20]=N171 B[19]=N170 B[18]=N169 B[17]=N168 B[16]=N167
+ B[15]=N166 B[14]=N165 B[13]=N164 B[12]=N163 B[11]=N162 B[10]=N161 B[9]=N160
+ B[8]=N159 B[7]=N158 B[6]=N157 B[5]=N156 B[4]=N155 B[3]=N154 B[2]=N153 B[1]=N152
+ B[0]=N151 CI=net45598 SUM[26]=N204 SUM[25]=N203 SUM[24]=N202 SUM[23]=N201
+ SUM[22]=N200 SUM[21]=N199 SUM[20]=N198 SUM[19]=N197 SUM[18]=N196 SUM[17]=N195
+ SUM[16]=N194 SUM[15]=N193 SUM[14]=N192 SUM[13]=N191 SUM[12]=N190 SUM[11]=N189
+ SUM[10]=N188 SUM[9]=N187 SUM[8]=N186 SUM[7]=N185 SUM[6]=N184 SUM[5]=N183
+ SUM[4]=N182 SUM[3]=N181 SUM[2]=N180 SUM[1]=N179 SUM[0]=N178
Xadd_2_root_add_0_root_add_28_3 PE_Shift_Add_1_DW01_add_1_DW01_add_27 $PINS
+ A[26]=base_val[26] A[25]=base_val[25] A[24]=base_val[24] A[23]=base_val[23]
+ A[22]=base_val[22] A[21]=base_val[21] A[20]=base_val[20] A[19]=base_val[19]
+ A[18]=base_val[18] A[17]=base_val[17] A[16]=base_val[16] A[15]=base_val[15]
+ A[14]=base_val[14] A[13]=base_val[13] A[12]=base_val[12] A[11]=base_val[11]
+ A[10]=base_val[10] A[9]=base_val[9] A[8]=base_val[8] A[7]=base_val[7]
+ A[6]=base_val[6] A[5]=base_val[5] A[4]=base_val[4] A[3]=base_val[3]
+ A[2]=base_val[2] A[1]=base_val[1] A[0]=base_val[0] B[26]=N122 B[25]=N121
+ B[24]=N120 B[23]=N119 B[22]=N118 B[21]=N117 B[20]=N116 B[19]=N115 B[18]=N114
+ B[17]=N113 B[16]=N112 B[15]=N111 B[14]=N110 B[13]=N109 B[12]=N108 B[11]=N107
+ B[10]=N106 B[9]=N105 B[8]=N104 B[7]=N103 B[6]=N102 B[5]=N101 B[4]=N100 B[3]=N99
+ B[2]=N98 B[1]=N97 B[0]=N96 CI=net45598 SUM[26]=N231 SUM[25]=N230 SUM[24]=N229
+ SUM[23]=N228 SUM[22]=N227 SUM[21]=N226 SUM[20]=N225 SUM[19]=N224 SUM[18]=N223
+ SUM[17]=N222 SUM[16]=N221 SUM[15]=N220 SUM[14]=N219 SUM[13]=N218 SUM[12]=N217
+ SUM[11]=N216 SUM[10]=N215 SUM[9]=N214 SUM[8]=N213 SUM[7]=N212 SUM[6]=N211
+ SUM[5]=N210 SUM[4]=N209 SUM[3]=N208 SUM[2]=N207 SUM[1]=N206 SUM[0]=N205
Xadd_0_root_add_0_root_add_28_3 PE_Shift_Add_1_DW01_add_0_DW01_add_26 $PINS
+ A[26]=N204 A[25]=N203 A[24]=N202 A[23]=N201 A[22]=N200 A[21]=N199 A[20]=N198
+ A[19]=N197 A[18]=N196 A[17]=N195 A[16]=N194 A[15]=N193 A[14]=N192 A[13]=N191
+ A[12]=N190 A[11]=N189 A[10]=N188 A[9]=N187 A[8]=N186 A[7]=N185 A[6]=N184
+ A[5]=N183 A[4]=N182 A[3]=N181 A[2]=N180 A[1]=N179 A[0]=N178 B[26]=N231
+ B[25]=N230 B[24]=N229 B[23]=N228 B[22]=N227 B[21]=N226 B[20]=N225 B[19]=N224
+ B[18]=N223 B[17]=N222 B[16]=N221 B[15]=N220 B[14]=N219 B[13]=N218 B[12]=N217
+ B[11]=N216 B[10]=N215 B[9]=N214 B[8]=N213 B[7]=N212 B[6]=N211 B[5]=N210
+ B[4]=N209 B[3]=N208 B[2]=N207 B[1]=N206 B[0]=FE_PHN1808_N205 CI=net45598
+ SUM[26]=next_acc[26] SUM[25]=next_acc[25] SUM[24]=next_acc[24]
+ SUM[23]=next_acc[23] SUM[22]=next_acc[22] SUM[21]=next_acc[21]
+ SUM[20]=next_acc[20] SUM[19]=next_acc[19] SUM[18]=next_acc[18]
+ SUM[17]=next_acc[17] SUM[16]=next_acc[16] SUM[15]=next_acc[15]
+ SUM[14]=next_acc[14] SUM[13]=next_acc[13] SUM[12]=next_acc[12]
+ SUM[11]=next_acc[11] SUM[10]=next_acc[10] SUM[9]=next_acc[9] SUM[8]=next_acc[8]
+ SUM[7]=next_acc[7] SUM[6]=next_acc[6] SUM[5]=next_acc[5] SUM[4]=next_acc[4]
+ SUM[3]=next_acc[3] SUM[2]=next_acc[2] SUM[1]=next_acc[1] SUM[0]=next_acc[0]
.ENDS

.SUBCKT SNPS_CLOCK_GATE_HIGH_PE_Shift_Add_0 EN ENCLK CLK
*.CONNECT net2211 EN
XFE_PHC1306_net2214 DELC $PINS O=net2214 I=FE_PHN1306_net2214
Xlatch QDBHN $PINS Q=FE_PHN1306_net2214 D=net2211 CKB=CLK
Xmain_gate AN2 $PINS O=ENCLK I1=net2214 I2=CLK
.ENDS

.SUBCKT PE_Shift_Add_0_DW01_sub_0 A[26] A[25] A[24] A[23] A[22] A[21] A[20]
+ A[19] A[18] A[17] A[16] A[15] A[14] A[13] A[12] A[11] A[10] A[9] A[8] A[7]
+ A[6] A[5] A[4] A[3] A[2] A[1] A[0] B[26] B[25] B[24] B[23] B[22] B[21] B[20]
+ B[19] B[18] B[17] B[16] B[15] B[14] B[13] B[12] B[11] B[10] B[9] B[8] B[7]
+ B[6] B[5] B[4] B[3] B[2] B[1] B[0] CI DIFF[26] DIFF[25] DIFF[24] DIFF[23]
+ DIFF[22] DIFF[21] DIFF[20] DIFF[19] DIFF[18] DIFF[17] DIFF[16] DIFF[15]
+ DIFF[14] DIFF[13] DIFF[12] DIFF[11] DIFF[10] DIFF[9] DIFF[8] DIFF[7] DIFF[6]
+ DIFF[5] DIFF[4] DIFF[3] DIFF[2] DIFF[1] DIFF[0] CO FE_RN_2478_0
*.CONNECT DIFF[0] B[0]
XFE_RC_223_0 INV1S $PINS O=FE_RN_103_0 I=n34
XFE_RC_222_0 MXL2HS $PINS OB=DIFF[19] S=n15 A=FE_RN_103_0 B=n34
XFE_RC_221_0 INV1S $PINS O=FE_RN_102_0 I=n32
XFE_RC_220_0 MXL2HS $PINS OB=DIFF[21] S=n17 A=FE_RN_102_0 B=n32
XFE_RC_4051_0 INV1S $PINS O=FE_RN_2601_0 I=n36
XFE_RC_4050_0 MXL2HS $PINS OB=DIFF[17] S=n13 A=FE_RN_2601_0 B=n36
XFE_RC_3801_0 XOR2HS $PINS O=DIFF[2] I1=n2 I2=n51
XFE_RC_3799_0 INV1S $PINS O=FE_RN_2490_0 I=FE_RN_2478_0
XFE_RC_3798_0 MXL2HS $PINS OB=DIFF[9] S=n5 A=FE_RN_2490_0 B=FE_RN_2478_0
XFE_RC_163_0 ND2 $PINS O=FE_RN_32_0 I1=B[1] I2=n53
XFE_RC_162_0 OAI12HS $PINS O=DIFF[1] A1=FE_RN_32_0 B1=B[1] B2=n53
XFE_OFC807_term3_shifted_2 INV1S $PINS O=n51 I=B[2]
XU5 NR2 $PINS O=n3 I1=B[2] I2=n1
XU6 INV1S $PINS O=n1 I=n2
XU8 INV2 $PINS O=n50 I=B[3]
XU10 AN2 $PINS O=n4 I1=n50 I2=n3
XU12 INV1S $PINS O=n48 I=B[5]
XU13 INV1S $PINS O=n47 I=B[6]
XU14 AN2 $PINS O=n2 I1=n52 I2=n53
XU15 XOR2HS $PINS O=DIFF[3] I1=n50 I2=n3
XU16 XOR2HS $PINS O=DIFF[8] I1=n45 I2=n25
XU18 AN2 $PINS O=n5 I1=n45 I2=n25
XU19 XOR2HS $PINS O=DIFF[10] I1=n43 I2=n6
XU20 AN2 $PINS O=n6 I1=FE_RN_2478_0 I2=n5
XU21 XOR2HS $PINS O=DIFF[11] I1=n42 I2=n7
XU22 AN2 $PINS O=n7 I1=n43 I2=n6
XU23 XOR2HS $PINS O=DIFF[12] I1=n41 I2=n8
XU24 AN2 $PINS O=n8 I1=n42 I2=n7
XU25 XOR2HS $PINS O=DIFF[13] I1=n40 I2=n9
XU26 AN2 $PINS O=n9 I1=n41 I2=n8
XU27 XOR2HS $PINS O=DIFF[14] I1=n39 I2=n10
XU28 AN2 $PINS O=n10 I1=n40 I2=n9
XU29 XOR2HS $PINS O=DIFF[15] I1=n38 I2=n11
XU30 AN2 $PINS O=n11 I1=n39 I2=n10
XU31 XOR2HS $PINS O=DIFF[16] I1=n37 I2=n12
XU32 AN2 $PINS O=n12 I1=n38 I2=n11
XU34 AN2 $PINS O=n13 I1=n37 I2=n12
XU35 XOR2HS $PINS O=DIFF[18] I1=n35 I2=n14
XU36 AN2 $PINS O=n14 I1=n36 I2=n13
XU38 AN2 $PINS O=n15 I1=n35 I2=n14
XU39 XOR2HS $PINS O=DIFF[20] I1=n33 I2=n16
XU40 AN2 $PINS O=n16 I1=n34 I2=n15
XU42 AN2 $PINS O=n17 I1=n33 I2=n16
XU43 XOR2HS $PINS O=DIFF[22] I1=n31 I2=n18
XU44 AN2 $PINS O=n18 I1=n32 I2=n17
XU45 XOR2HS $PINS O=DIFF[23] I1=n30 I2=n19
XU46 AN2 $PINS O=n19 I1=n31 I2=n18
XU47 XOR2HS $PINS O=DIFF[24] I1=n29 I2=n20
XU48 AN2 $PINS O=n20 I1=n30 I2=n19
XU49 AN2 $PINS O=n21 I1=n29 I2=n20
XU50 XOR2HS $PINS O=DIFF[25] I1=n28 I2=n21
XU51 XOR2HS $PINS O=DIFF[4] I1=n49 I2=n4
XU52 XOR2HS $PINS O=DIFF[5] I1=n48 I2=n22
XU53 AN2 $PINS O=n22 I1=n49 I2=n4
XU54 XOR2HS $PINS O=DIFF[6] I1=n47 I2=n23
XU55 AN2 $PINS O=n23 I1=n48 I2=n22
XU56 XOR2HS $PINS O=DIFF[7] I1=n46 I2=n24
XU57 AN2 $PINS O=n24 I1=n47 I2=n23
XU58 AN2 $PINS O=n25 I1=n46 I2=n24
XU59 INV1S $PINS O=n45 I=B[8]
XU61 INV1S $PINS O=n43 I=B[10]
XU62 INV1S $PINS O=n42 I=B[11]
XU63 INV1S $PINS O=n41 I=B[12]
XU64 INV1S $PINS O=n40 I=B[13]
XU65 INV1S $PINS O=n39 I=B[14]
XU66 INV1S $PINS O=n38 I=B[15]
XU67 INV1S $PINS O=n37 I=B[16]
XU68 INV1S $PINS O=n36 I=B[17]
XU69 INV1S $PINS O=n35 I=B[18]
XU70 INV1S $PINS O=n34 I=B[19]
XU71 INV1S $PINS O=n33 I=B[20]
XU72 INV1S $PINS O=n32 I=B[21]
XU73 INV1S $PINS O=n31 I=B[22]
XU74 INV1S $PINS O=n30 I=B[23]
XU75 INV1S $PINS O=n29 I=B[24]
XU76 INV1S $PINS O=n28 I=B[25]
XU77 INV1S $PINS O=n46 I=B[7]
XU78 XOR2HS $PINS O=DIFF[26] I1=B[26] I2=n27
XU79 ND2 $PINS O=n27 I1=n28 I2=n21
XU1 INV1S $PINS O=n53 I=B[0]
XU2 INV1S $PINS O=n52 I=B[1]
XU9 INV2 $PINS O=n49 I=B[4]
.ENDS

.SUBCKT PE_Shift_Add_0_DW01_sub_1 A[26] A[25] A[24] A[23] A[22] A[21] A[20]
+ A[19] A[18] A[17] A[16] A[15] A[14] A[13] A[12] A[11] A[10] A[9] A[8] A[7]
+ A[6] A[5] A[4] A[3] A[2] A[1] A[0] B[26] B[25] B[24] B[23] B[22] B[21] B[20]
+ B[19] B[18] B[17] B[16] B[15] B[14] B[13] B[12] B[11] B[10] B[9] B[8] B[7]
+ B[6] B[5] B[4] B[3] B[2] B[1] B[0] CI DIFF[26] DIFF[25] DIFF[24] DIFF[23]
+ DIFF[22] DIFF[21] DIFF[20] DIFF[19] DIFF[18] DIFF[17] DIFF[16] DIFF[15]
+ DIFF[14] DIFF[13] DIFF[12] DIFF[11] DIFF[10] DIFF[9] DIFF[8] DIFF[7] DIFF[6]
+ DIFF[5] DIFF[4] DIFF[3] DIFF[2] DIFF[1] DIFF[0] CO
*.CONNECT DIFF[0] B[0]
XFE_RC_3762_0 XOR2HS $PINS O=DIFF[2] I1=n7 I2=n50
XFE_RC_3393_0 XOR2HS $PINS O=DIFF[4] I1=n3 I2=n48
XFE_RC_89_0 INV1S $PINS O=FE_RN_4_0 I=DIFF[0]
XFE_RC_88_0 MXL2HS $PINS OB=DIFF[1] S=B[1] A=FE_RN_4_0 B=DIFF[0]
XFE_OFC806_term2_shifted_2 INV3 $PINS O=n50 I=B[2]
XU3 NR2 $PINS O=n7 I1=B[1] I2=B[0]
XU4 XOR2HS $PINS O=DIFF[3] I1=n49 I2=n2
XU7 INV2 $PINS O=n48 I=B[4]
XU8 INV1S $PINS O=n47 I=B[5]
XU9 INV1S $PINS O=n46 I=B[6]
XU10 AN2 $PINS O=n1 I1=n46 I2=n6
XU11 AN2T $PINS O=n2 I1=n50 I2=n7
XU12 AN2 $PINS O=n3 I1=n49 I2=n2
XU13 AN2 $PINS O=n4 I1=n48 I2=n3
XU14 AN2T $PINS O=n5 I1=n45 I2=n1
XU15 AN2 $PINS O=n6 I1=n47 I2=n4
XU16 AN2 $PINS O=n8 I1=n44 I2=n5
XU17 AN2 $PINS O=n9 I1=n43 I2=n8
XU18 AN2 $PINS O=n10 I1=n42 I2=n9
XU19 AN2 $PINS O=n11 I1=n41 I2=n10
XU20 AN2 $PINS O=n12 I1=n40 I2=n11
XU21 AN2 $PINS O=n13 I1=n39 I2=n12
XU22 AN2 $PINS O=n14 I1=n38 I2=n13
XU23 AN2 $PINS O=n15 I1=n37 I2=n14
XU24 AN2 $PINS O=n16 I1=n36 I2=n15
XU25 AN2 $PINS O=n17 I1=n35 I2=n16
XU26 AN2 $PINS O=n18 I1=n34 I2=n17
XU27 AN2 $PINS O=n19 I1=n33 I2=n18
XU28 AN2 $PINS O=n20 I1=n32 I2=n19
XU29 AN2 $PINS O=n21 I1=n31 I2=n20
XU30 AN2 $PINS O=n22 I1=n30 I2=n21
XU31 AN2 $PINS O=n23 I1=n29 I2=n22
XU32 AN2 $PINS O=n24 I1=n28 I2=n23
XU33 INV1S $PINS O=n44 I=B[8]
XU34 INV1S $PINS O=n43 I=B[9]
XU35 INV1S $PINS O=n42 I=B[10]
XU36 INV1S $PINS O=n41 I=B[11]
XU37 INV1S $PINS O=n40 I=B[12]
XU38 INV1S $PINS O=n39 I=B[13]
XU39 INV1S $PINS O=n38 I=B[14]
XU40 INV1S $PINS O=n37 I=B[15]
XU41 INV1S $PINS O=n36 I=B[16]
XU42 INV1S $PINS O=n35 I=B[17]
XU43 INV1S $PINS O=n34 I=B[18]
XU44 INV1S $PINS O=n33 I=B[19]
XU45 INV1S $PINS O=n32 I=B[20]
XU46 INV1S $PINS O=n31 I=B[21]
XU47 INV1S $PINS O=n30 I=B[22]
XU48 INV1S $PINS O=n29 I=B[23]
XU49 INV1S $PINS O=n28 I=B[24]
XU50 INV1S $PINS O=n27 I=B[25]
XU51 INV1S $PINS O=n45 I=B[7]
XU52 XOR2HS $PINS O=DIFF[26] I1=B[26] I2=n26
XU54 XOR2HS $PINS O=DIFF[9] I1=n43 I2=n8
XU55 XOR2HS $PINS O=DIFF[10] I1=n42 I2=n9
XU56 XOR2HS $PINS O=DIFF[11] I1=n41 I2=n10
XU57 XOR2HS $PINS O=DIFF[12] I1=n40 I2=n11
XU58 XOR2HS $PINS O=DIFF[13] I1=n39 I2=n12
XU59 XOR2HS $PINS O=DIFF[14] I1=n38 I2=n13
XU60 XOR2HS $PINS O=DIFF[15] I1=n37 I2=n14
XU61 XOR2HS $PINS O=DIFF[16] I1=n36 I2=n15
XU62 XOR2HS $PINS O=DIFF[17] I1=n35 I2=n16
XU63 XOR2HS $PINS O=DIFF[18] I1=n34 I2=n17
XU64 XOR2HS $PINS O=DIFF[19] I1=n33 I2=n18
XU65 XOR2HS $PINS O=DIFF[20] I1=n32 I2=n19
XU66 XOR2HS $PINS O=DIFF[21] I1=n31 I2=n20
XU67 XOR2HS $PINS O=DIFF[22] I1=n30 I2=n21
XU68 XOR2HS $PINS O=DIFF[23] I1=n29 I2=n22
XU69 XOR2HS $PINS O=DIFF[24] I1=n28 I2=n23
XU70 XOR2HS $PINS O=DIFF[25] I1=n27 I2=n24
XU71 XOR2HS $PINS O=DIFF[8] I1=n44 I2=n5
XU72 XOR2HS $PINS O=DIFF[7] I1=n45 I2=n1
XU73 XOR2HS $PINS O=DIFF[6] I1=n46 I2=n6
XU74 XOR2HS $PINS O=DIFF[5] I1=n47 I2=n4
XU76 ND2 $PINS O=n26 I1=n27 I2=n24
XU1 INV2 $PINS O=n49 I=B[3]
.ENDS

.SUBCKT PE_Shift_Add_0_DW01_sub_2 A[26] A[25] A[24] A[23] A[22] A[21] A[20]
+ A[19] A[18] A[17] A[16] A[15] A[14] A[13] A[12] A[11] A[10] A[9] A[8] A[7]
+ A[6] A[5] A[4] A[3] A[2] A[1] A[0] B[26] B[25] B[24] B[23] B[22] B[21] B[20]
+ B[19] B[18] B[17] B[16] B[15] B[14] B[13] B[12] B[11] B[10] B[9] B[8] B[7]
+ B[6] B[5] B[4] B[3] B[2] B[1] B[0] CI DIFF[26] DIFF[25] DIFF[24] DIFF[23]
+ DIFF[22] DIFF[21] DIFF[20] DIFF[19] DIFF[18] DIFF[17] DIFF[16] DIFF[15]
+ DIFF[14] DIFF[13] DIFF[12] DIFF[11] DIFF[10] DIFF[9] DIFF[8] DIFF[7] DIFF[6]
+ DIFF[5] DIFF[4] DIFF[3] DIFF[2] DIFF[1] DIFF[0] CO
XFE_RC_188_0 INV1S $PINS O=FE_RN_86_0 I=n27
XFE_RC_187_0 MXL2HS $PINS OB=DIFF[25] S=n24 A=FE_RN_86_0 B=n27
XFE_RC_3789_0 INV1S $PINS O=FE_RN_2484_0 I=n43
XFE_RC_3788_0 MXL2HS $PINS OB=DIFF[9] S=n8 A=FE_RN_2484_0 B=n43
XFE_OFC840_term1_shifted_8 INV1S $PINS O=n44 I=B[8]
XFE_OFC756_N14 INV1S $PINS O=n52 I=B[0]
XU5 XOR2HS $PINS O=DIFF[1] I1=n52 I2=n51
XU6 XOR2HS $PINS O=DIFF[2] I1=n50 I2=n5
XU7 INV2 $PINS O=n49 I=B[3]
XU8 INV2 $PINS O=n50 I=B[2]
XU9 INV1S $PINS O=n46 I=B[6]
XU11 INV1S $PINS O=n45 I=B[7]
XU12 INV1S $PINS O=n47 I=B[5]
XU13 AN2 $PINS O=n1 I1=n46 I2=n3
XU15 AN2 $PINS O=n3 I1=n47 I2=n2
XU16 AN2 $PINS O=n4 I1=n45 I2=n1
XU18 AN2 $PINS O=n5 I1=n51 I2=n52
XU19 AN2 $PINS O=n8 I1=n44 I2=n4
XU20 AN2 $PINS O=n9 I1=n43 I2=n8
XU21 AN2 $PINS O=n10 I1=n42 I2=n9
XU22 AN2 $PINS O=n11 I1=n41 I2=n10
XU23 AN2 $PINS O=n12 I1=n40 I2=n11
XU24 AN2 $PINS O=n13 I1=n39 I2=n12
XU25 AN2 $PINS O=n14 I1=n38 I2=n13
XU26 AN2 $PINS O=n15 I1=n37 I2=n14
XU27 AN2 $PINS O=n16 I1=n36 I2=n15
XU28 AN2 $PINS O=n17 I1=n35 I2=n16
XU29 AN2 $PINS O=n18 I1=n34 I2=n17
XU30 AN2 $PINS O=n19 I1=n33 I2=n18
XU31 AN2 $PINS O=n20 I1=n32 I2=n19
XU32 AN2 $PINS O=n21 I1=n31 I2=n20
XU33 AN2 $PINS O=n22 I1=n30 I2=n21
XU34 AN2 $PINS O=n23 I1=n29 I2=n22
XU35 AN2 $PINS O=n24 I1=n28 I2=n23
XU37 INV1S $PINS O=n43 I=B[9]
XU38 INV1S $PINS O=n42 I=B[10]
XU39 INV1S $PINS O=n41 I=B[11]
XU40 INV1S $PINS O=n40 I=B[12]
XU41 INV1S $PINS O=n39 I=B[13]
XU42 INV1S $PINS O=n38 I=B[14]
XU43 INV1S $PINS O=n37 I=B[15]
XU44 INV1S $PINS O=n36 I=B[16]
XU45 INV1S $PINS O=n35 I=B[17]
XU46 INV1S $PINS O=n34 I=B[18]
XU47 INV1S $PINS O=n33 I=B[19]
XU48 INV1S $PINS O=n32 I=B[20]
XU49 INV1S $PINS O=n31 I=B[21]
XU50 INV1S $PINS O=n30 I=B[22]
XU51 INV1S $PINS O=n29 I=B[23]
XU52 INV1S $PINS O=n28 I=B[24]
XU53 INV1S $PINS O=n27 I=B[25]
XU54 XOR2HS $PINS O=DIFF[12] I1=n40 I2=n11
XU55 XOR2HS $PINS O=DIFF[13] I1=n39 I2=n12
XU56 XOR2HS $PINS O=DIFF[14] I1=n38 I2=n13
XU57 XOR2HS $PINS O=DIFF[15] I1=n37 I2=n14
XU58 XOR2HS $PINS O=DIFF[16] I1=n36 I2=n15
XU59 XOR2HS $PINS O=DIFF[17] I1=n35 I2=n16
XU60 XOR2HS $PINS O=DIFF[18] I1=n34 I2=n17
XU61 XOR2HS $PINS O=DIFF[19] I1=n33 I2=n18
XU62 XOR2HS $PINS O=DIFF[20] I1=n32 I2=n19
XU63 XOR2HS $PINS O=DIFF[21] I1=n31 I2=n20
XU64 XOR2HS $PINS O=DIFF[22] I1=n30 I2=n21
XU65 XOR2HS $PINS O=DIFF[23] I1=n29 I2=n22
XU66 XOR2HS $PINS O=DIFF[24] I1=n28 I2=n23
XU68 XOR2HS $PINS O=DIFF[11] I1=n41 I2=n10
XU69 XOR2HS $PINS O=DIFF[10] I1=n42 I2=n9
XU71 XOR2HS $PINS O=DIFF[8] I1=n44 I2=n4
XU72 XOR2HS $PINS O=DIFF[7] I1=n45 I2=n1
XU73 XOR2HS $PINS O=DIFF[6] I1=n46 I2=n3
XU74 XOR2HS $PINS O=DIFF[5] I1=n47 I2=n2
XU76 XOR2HS $PINS O=DIFF[3] I1=n49 I2=n6
XU77 XOR2HS $PINS O=DIFF[26] I1=B[26] I2=n26
XU78 ND2 $PINS O=n26 I1=n27 I2=n24
XU1 INV2 $PINS O=n51 I=B[1]
XU2 NR2 $PINS O=n2 I1=B[4] I2=n53
XU3 INV1S $PINS O=n53 I=n7
XU10 AN2T $PINS O=n7 I1=n49 I2=n6
XU14 XNR2HS $PINS O=DIFF[4] I1=B[4] I2=n7
XU75 AN2 $PINS O=n6 I1=n50 I2=n5
.ENDS

.SUBCKT PE_Shift_Add_0_DW01_add_2_DW01_add_16 A[26] A[25] A[24] A[23] A[22]
+ A[21] A[20] A[19] A[18] A[17] A[16] A[15] A[14] A[13] A[12] A[11] A[10] A[9]
+ A[8] A[7] A[6] A[5] A[4] A[3] A[2] A[1] A[0] B[26] B[25] B[24] B[23] B[22]
+ B[21] B[20] B[19] B[18] B[17] B[16] B[15] B[14] B[13] B[12] B[11] B[10] B[9]
+ B[8] B[7] B[6] B[5] B[4] B[3] B[2] B[1] B[0] CI SUM[26] SUM[25] SUM[24]
+ SUM[23] SUM[22] SUM[21] SUM[20] SUM[19] SUM[18] SUM[17] SUM[16] SUM[15]
+ SUM[14] SUM[13] SUM[12] SUM[11] SUM[10] SUM[9] SUM[8] SUM[7] SUM[6] SUM[5]
+ SUM[4] SUM[3] SUM[2] SUM[1] SUM[0] CO
XFE_RC_214_0 XOR3 $PINS O=SUM[23] I1=A[23] I2=B[23] I3=carry[23]
XFE_RC_213_0 MAO222 $PINS O=carry[24] A1=A[23] B1=B[23] C1=carry[23]
XFE_RC_131_0 INV2 $PINS O=SUM[14] I=FE_RN_67_0
XFE_RC_130_0 XNR3 $PINS O=FE_RN_67_0 I1=B[14] I2=A[14] I3=carry[14]
XFE_RC_129_0 OAI12H $PINS O=carry[9] A1=FE_RN_1210_0 B1=FE_RN_1207_0
+ B2=FE_RN_1208_0
XFE_RC_67_0 OR2 $PINS O=FE_RN_40_0 I1=carry[17] I2=FE_RN_1268_0
XFE_RC_66_0 ND2P $PINS O=SUM[17] I1=FE_RN_40_0 I2=FE_RN_1271_0
XFE_OCPC1131_N160 BUF1 $PINS O=FE_OCPN1131_N160 I=B[9]
XFE_RC_4041_0 XOR3 $PINS O=SUM[24] I1=A[24] I2=B[24] I3=carry[24]
XFE_RC_4040_0 MAO222 $PINS O=carry[25] A1=A[24] B1=B[24] C1=carry[24]
XFE_RC_3908_0 INV1S $PINS O=FE_RN_2553_0 I=FE_RN_2217_0
XFE_RC_3907_0 OR2B1S $PINS O=FE_RN_2554_0 I1=FE_RN_2209_0 B1=FE_RN_2553_0
XFE_RC_3906_0 ND2P $PINS O=carry[20] I1=FE_RN_2221_0 I2=FE_RN_2554_0
XFE_RC_3867_0 OAI12HS $PINS O=FE_RN_2419_0 A1=FE_RN_2418_0 B1=FE_RN_2411_0
+ B2=FE_RN_2415_0
XFE_RC_3768_0 OAI12H $PINS O=carry[19] A1=FE_RN_2459_0 B1=FE_RN_2456_0
+ B2=FE_RN_2457_0
XFE_RC_3741_0 XOR2HS $PINS O=FE_RN_2451_0 I1=A[18] I2=B[18]
XFE_RC_3740_0 OR2B1S $PINS O=FE_RN_2452_0 I1=carry[18] B1=FE_RN_2451_0
XFE_RC_3739_0 ND2 $PINS O=FE_RN_2453_0 I1=B[18] I2=A[18]
XFE_RC_3738_0 ND2 $PINS O=FE_RN_2454_0 I1=FE_RN_2453_0 I2=FE_RN_2458_0
XFE_RC_3737_0 ND2 $PINS O=FE_RN_2455_0 I1=FE_RN_2454_0 I2=carry[18]
XFE_RC_3736_0 ND2P $PINS O=SUM[18] I1=FE_RN_2455_0 I2=FE_RN_2452_0
XFE_RC_3735_0 INV1S $PINS O=FE_RN_2456_0 I=A[18]
XFE_RC_3734_0 INV1S $PINS O=FE_RN_2457_0 I=B[18]
XFE_RC_3733_0 OR2 $PINS O=FE_RN_2458_0 I1=A[18] I2=B[18]
XFE_RC_3732_0 ND2P $PINS O=FE_RN_2459_0 I1=FE_RN_2458_0 I2=carry[18]
XFE_RC_3686_0 ND2 $PINS O=FE_RN_2408_0 I1=A[2] I2=B[2]
XFE_RC_3685_0 ND2 $PINS O=FE_RN_2409_0 I1=FE_RN_2418_0 I2=n8
XFE_RC_3684_0 ND2 $PINS O=carry[3] I1=FE_RN_2409_0 I2=FE_RN_2408_0
XFE_RC_3683_0 INV1S $PINS O=FE_RN_2410_0 I=n8
XFE_RC_3682_0 INV2 $PINS O=FE_RN_2411_0 I=B[2]
XFE_RC_3681_0 MXL2HS $PINS OB=FE_RN_2412_0 S=A[2] A=FE_RN_2411_0 B=B[2]
XFE_RC_3680_0 ND2S $PINS O=FE_RN_2413_0 I1=FE_RN_2412_0 I2=FE_RN_2410_0
XFE_RC_3678_0 INV1S $PINS O=FE_RN_2415_0 I=A[2]
XFE_RC_3675_0 ND2 $PINS O=FE_RN_2418_0 I1=FE_RN_2415_0 I2=FE_RN_2411_0
XFE_RC_3673_0 ND2 $PINS O=FE_RN_2420_0 I1=FE_RN_2419_0 I2=n8
XFE_RC_3672_0 ND2P $PINS O=SUM[2] I1=FE_RN_2420_0 I2=FE_RN_2413_0
XFE_RC_3601_0 OR2 $PINS O=FE_RN_2354_0 I1=FE_RN_2033_0 I2=FE_RN_2032_0
XFE_RC_3600_0 ND2P $PINS O=carry[21] I1=FE_RN_2036_0 I2=FE_RN_2354_0
XFE_RC_3411_0 INV1S $PINS O=FE_RN_2208_0 I=carry[19]
XFE_RC_3410_0 INV1S $PINS O=FE_RN_2209_0 I=B[19]
XFE_RC_3408_0 ND2S $PINS O=FE_RN_2211_0 I1=FE_RN_2209_0 I2=A[19]
XFE_RC_3407_0 OAI12HS $PINS O=FE_RN_2212_0 A1=FE_RN_2211_0 B1=FE_RN_2209_0
+ B2=A[19]
XFE_RC_3406_0 ND2 $PINS O=FE_RN_2213_0 I1=FE_RN_2212_0 I2=FE_RN_2208_0
XFE_RC_3405_0 ND2 $PINS O=FE_RN_2214_0 I1=B[19] I2=A[19]
XFE_RC_3404_0 ND2S $PINS O=FE_RN_2215_0 I1=FE_RN_2214_0 I2=FE_RN_2220_0
XFE_RC_3403_0 ND2 $PINS O=FE_RN_2216_0 I1=FE_RN_2215_0 I2=carry[19]
XFE_RC_3402_0 ND2 $PINS O=SUM[19] I1=FE_RN_2216_0 I2=FE_RN_2213_0
XFE_RC_3401_0 INV1S $PINS O=FE_RN_2217_0 I=A[19]
XFE_RC_3398_0 OR2B1S $PINS O=FE_RN_2220_0 I1=A[19] B1=FE_RN_2209_0
XFE_RC_3397_0 ND2 $PINS O=FE_RN_2221_0 I1=carry[19] I2=FE_RN_2220_0
XFE_RC_3156_0 INV1S $PINS O=FE_RN_2026_0 I=carry[20]
XFE_RC_3155_0 XOR2HS $PINS O=FE_RN_2027_0 I1=A[20] I2=B[20]
XFE_RC_3154_0 ND2S $PINS O=FE_RN_2028_0 I1=FE_RN_2027_0 I2=FE_RN_2026_0
XFE_RC_3153_0 ND2 $PINS O=FE_RN_2029_0 I1=B[20] I2=A[20]
XFE_RC_3152_0 ND2S $PINS O=FE_RN_2030_0 I1=FE_RN_2035_0 I2=FE_RN_2029_0
XFE_RC_3151_0 ND2 $PINS O=FE_RN_2031_0 I1=FE_RN_2030_0 I2=carry[20]
XFE_RC_3150_0 ND2P $PINS O=SUM[20] I1=FE_RN_2031_0 I2=FE_RN_2028_0
XFE_RC_3149_0 INV1S $PINS O=FE_RN_2032_0 I=A[20]
XFE_RC_3148_0 INV1S $PINS O=FE_RN_2033_0 I=B[20]
XFE_RC_3146_0 OR2B1S $PINS O=FE_RN_2035_0 I1=A[20] B1=FE_RN_2033_0
XFE_RC_3145_0 ND2 $PINS O=FE_RN_2036_0 I1=FE_RN_2035_0 I2=carry[20]
XFE_RC_3078_0 XOR2HS $PINS O=FE_RN_1976_0 I1=A[21] I2=B[21]
XFE_RC_3077_0 INV1S $PINS O=FE_RN_1977_0 I=carry[21]
XFE_RC_3076_0 ND2 $PINS O=FE_RN_1978_0 I1=FE_RN_1977_0 I2=FE_RN_1976_0
XFE_RC_3075_0 ND2 $PINS O=FE_RN_1979_0 I1=B[21] I2=A[21]
XFE_RC_3074_0 ND2 $PINS O=FE_RN_1980_0 I1=FE_RN_1983_0 I2=FE_RN_1979_0
XFE_RC_3073_0 ND2 $PINS O=FE_RN_1981_0 I1=FE_RN_1980_0 I2=carry[21]
XFE_RC_3072_0 ND2 $PINS O=SUM[21] I1=FE_RN_1981_0 I2=FE_RN_1978_0
XFE_RC_3070_0 OR2 $PINS O=FE_RN_1983_0 I1=A[21] I2=B[21]
XFE_RC_3069_0 ND2 $PINS O=FE_RN_1984_0 I1=FE_RN_1983_0 I2=carry[21]
XFE_RC_3068_0 ND2P $PINS O=carry[22] I1=FE_RN_1984_0 I2=FE_RN_1979_0
XFE_RC_3063_0 INV1S $PINS O=FE_RN_1972_0 I=FE_RN_1873_0
XFE_RC_3062_0 OR2B1S $PINS O=FE_RN_1973_0 I1=FE_RN_1874_0 B1=FE_RN_1972_0
XFE_RC_3061_0 ND2 $PINS O=carry[16] I1=FE_RN_1876_0 I2=FE_RN_1973_0
XFE_RC_2929_0 XOR2HS $PINS O=FE_RN_1868_0 I1=B[15] I2=A[15]
XFE_RC_2928_0 OR2B1S $PINS O=FE_RN_1869_0 I1=carry[15] B1=FE_RN_1868_0
XFE_RC_2927_0 ND2 $PINS O=FE_RN_1870_0 I1=A[15] I2=B[15]
XFE_RC_2926_0 ND2 $PINS O=FE_RN_1871_0 I1=FE_RN_1870_0 I2=FE_RN_1875_0
XFE_RC_2925_0 ND2 $PINS O=FE_RN_1872_0 I1=FE_RN_1871_0 I2=carry[15]
XFE_RC_2924_0 ND2P $PINS O=SUM[15] I1=FE_RN_1872_0 I2=FE_RN_1869_0
XFE_RC_2923_0 INV1S $PINS O=FE_RN_1873_0 I=B[15]
XFE_RC_2922_0 INV1S $PINS O=FE_RN_1874_0 I=A[15]
XFE_RC_2921_0 OR2 $PINS O=FE_RN_1875_0 I1=B[15] I2=A[15]
XFE_RC_2920_0 ND2 $PINS O=FE_RN_1876_0 I1=FE_RN_1875_0 I2=carry[15]
XFE_RC_2419_0 INV1S $PINS O=FE_RN_1493_0 I=carry[16]
XFE_RC_2418_0 INV2 $PINS O=FE_RN_1494_0 I=B[16]
XFE_RC_2417_0 MXL2HS $PINS OB=FE_RN_1495_0 S=A[16] A=FE_RN_1494_0 B=B[16]
XFE_RC_2416_0 ND2S $PINS O=FE_RN_1496_0 I1=FE_RN_1495_0 I2=FE_RN_1493_0
XFE_RC_2414_0 INV1S $PINS O=FE_RN_1498_0 I=A[16]
XFE_RC_2413_0 OAI12HS $PINS O=FE_RN_1499_0 A1=FE_RN_1503_0 B1=FE_RN_1498_0
+ B2=FE_RN_1494_0
XFE_RC_2412_0 ND2 $PINS O=FE_RN_1500_0 I1=FE_RN_1499_0 I2=carry[16]
XFE_RC_2411_0 ND2P $PINS O=SUM[16] I1=FE_RN_1500_0 I2=FE_RN_1496_0
XFE_RC_2410_0 ND2 $PINS O=FE_RN_1501_0 I1=A[16] I2=B[16]
XFE_RC_2408_0 OR2B1S $PINS O=FE_RN_1503_0 I1=A[16] B1=FE_RN_1494_0
XFE_RC_2407_0 ND2S $PINS O=FE_RN_1504_0 I1=FE_RN_1503_0 I2=carry[16]
XFE_RC_2406_0 ND2S $PINS O=carry[17] I1=FE_RN_1504_0 I2=FE_RN_1501_0
XFE_RC_2109_0 INV1S $PINS O=FE_RN_1265_0 I=B[17]
XFE_RC_2107_0 NR2 $PINS O=FE_RN_1267_0 I1=A[17] I2=FE_RN_1265_0
XFE_RC_2106_0 AOI12HS $PINS O=FE_RN_1268_0 A1=FE_RN_1267_0 B1=FE_RN_1265_0
+ B2=A[17]
XFE_RC_2105_0 ND2 $PINS O=FE_RN_1269_0 I1=B[17] I2=A[17]
XFE_RC_2104_0 ND2 $PINS O=FE_RN_1270_0 I1=FE_RN_1274_0 I2=FE_RN_1269_0
XFE_RC_2103_0 ND2 $PINS O=FE_RN_1271_0 I1=FE_RN_1270_0 I2=carry[17]
XFE_RC_2099_0 OR2B1S $PINS O=FE_RN_1274_0 I1=A[17] B1=FE_RN_1265_0
XFE_RC_2098_0 ND2 $PINS O=FE_RN_1275_0 I1=FE_RN_1274_0 I2=carry[17]
XFE_RC_2097_0 ND2P $PINS O=carry[18] I1=FE_RN_1275_0 I2=FE_RN_1269_0
XFE_RC_2024_0 INV1S $PINS O=FE_RN_1201_0 I=carry[8]
XFE_RC_2023_0 XOR2HS $PINS O=FE_RN_1202_0 I1=A[8] I2=B[8]
XFE_RC_2022_0 ND2 $PINS O=FE_RN_1203_0 I1=FE_RN_1202_0 I2=FE_RN_1201_0
XFE_RC_2021_0 ND2 $PINS O=FE_RN_1204_0 I1=B[8] I2=A[8]
XFE_RC_2020_0 ND2S $PINS O=FE_RN_1205_0 I1=FE_RN_1209_0 I2=FE_RN_1204_0
XFE_RC_2019_0 ND2 $PINS O=FE_RN_1206_0 I1=FE_RN_1205_0 I2=carry[8]
XFE_RC_2018_0 ND2P $PINS O=SUM[8] I1=FE_RN_1206_0 I2=FE_RN_1203_0
XFE_RC_2017_0 INV1S $PINS O=FE_RN_1207_0 I=A[8]
XFE_RC_2016_0 INV1S $PINS O=FE_RN_1208_0 I=B[8]
XFE_RC_2015_0 OR2 $PINS O=FE_RN_1209_0 I1=A[8] I2=B[8]
XFE_RC_2014_0 ND2 $PINS O=FE_RN_1210_0 I1=carry[8] I2=FE_RN_1209_0
XFE_RC_1624_0 INV2 $PINS O=FE_RN_900_0 I=FE_RN_904_0
XFE_RC_1623_0 AOI12H $PINS O=FE_RN_901_0 A1=FE_RN_900_0 B1=FE_OCPN1131_N160
+ B2=A[9]
XFE_RC_1622_0 XNR2HS $PINS O=FE_RN_902_0 I1=A[9] I2=FE_OCPN1131_N160
XFE_RC_1621_0 MXL2H $PINS OB=SUM[9] S=carry[9] A=FE_RN_902_0 B=FE_RN_901_0
XFE_RC_1620_0 ND2S $PINS O=FE_RN_903_0 I1=B[9] I2=A[9]
XFE_RC_1619_0 OR2 $PINS O=FE_RN_904_0 I1=A[9] I2=B[9]
XFE_RC_1618_0 ND2 $PINS O=FE_RN_905_0 I1=FE_RN_904_0 I2=carry[9]
XFE_RC_1617_0 ND2 $PINS O=carry[10] I1=FE_RN_905_0 I2=FE_RN_903_0
XFE_RC_1496_0 OR2 $PINS O=FE_RN_810_0 I1=FE_RN_661_0 I2=FE_RN_660_0
XFE_RC_1495_0 ND2 $PINS O=carry[11] I1=FE_RN_810_0 I2=FE_RN_663_0
XFE_RC_1299_0 INV1S $PINS O=FE_RN_654_0 I=carry[10]
XFE_RC_1298_0 XOR2HS $PINS O=FE_RN_655_0 I1=B[10] I2=A[10]
XFE_RC_1297_0 ND2S $PINS O=FE_RN_656_0 I1=FE_RN_655_0 I2=FE_RN_654_0
XFE_RC_1296_0 ND2 $PINS O=FE_RN_657_0 I1=A[10] I2=B[10]
XFE_RC_1295_0 ND2 $PINS O=FE_RN_658_0 I1=FE_RN_662_0 I2=FE_RN_657_0
XFE_RC_1294_0 ND2 $PINS O=FE_RN_659_0 I1=FE_RN_658_0 I2=carry[10]
XFE_RC_1293_0 ND2P $PINS O=SUM[10] I1=FE_RN_659_0 I2=FE_RN_656_0
XFE_RC_1292_0 INV1S $PINS O=FE_RN_660_0 I=B[10]
XFE_RC_1291_0 INV1S $PINS O=FE_RN_661_0 I=A[10]
XFE_RC_1290_0 OR2 $PINS O=FE_RN_662_0 I1=B[10] I2=A[10]
XFE_RC_1289_0 ND2S $PINS O=FE_RN_663_0 I1=FE_RN_662_0 I2=carry[10]
XFE_RC_1109_0 OR2 $PINS O=FE_RN_518_0 I1=FE_RN_423_0 I2=FE_RN_422_0
XFE_RC_1108_0 ND2 $PINS O=carry[12] I1=FE_RN_425_0 I2=FE_RN_518_0
XFE_RC_987_0 INV1S $PINS O=FE_RN_416_0 I=carry[11]
XFE_RC_986_0 XOR2HS $PINS O=FE_RN_417_0 I1=B[11] I2=A[11]
XFE_RC_985_0 ND2 $PINS O=FE_RN_418_0 I1=FE_RN_417_0 I2=FE_RN_416_0
XFE_RC_984_0 ND2S $PINS O=FE_RN_419_0 I1=A[11] I2=B[11]
XFE_RC_983_0 ND2 $PINS O=FE_RN_420_0 I1=FE_RN_424_0 I2=FE_RN_419_0
XFE_RC_982_0 ND2 $PINS O=FE_RN_421_0 I1=FE_RN_420_0 I2=carry[11]
XFE_RC_981_0 ND2P $PINS O=SUM[11] I1=FE_RN_421_0 I2=FE_RN_418_0
XFE_RC_980_0 INV1S $PINS O=FE_RN_422_0 I=B[11]
XFE_RC_979_0 INV1S $PINS O=FE_RN_423_0 I=A[11]
XFE_RC_978_0 OR2 $PINS O=FE_RN_424_0 I1=B[11] I2=A[11]
XFE_RC_977_0 ND2S $PINS O=FE_RN_425_0 I1=FE_RN_424_0 I2=carry[11]
XFE_RC_764_0 OR2 $PINS O=FE_RN_255_0 I1=FE_RN_95_0 I2=FE_RN_96_0
XFE_RC_763_0 ND2P $PINS O=carry[7] I1=FE_RN_98_0 I2=FE_RN_255_0
XFE_RC_731_0 XOR3 $PINS O=SUM[7] I1=A[7] I2=B[7] I3=carry[7]
XFE_RC_730_0 MAO222P $PINS O=carry[8] A1=carry[7] B1=B[7] C1=A[7]
XFE_RC_598_0 OR2 $PINS O=FE_RN_178_0 I1=FE_RN_167_0 I2=FE_RN_166_0
XFE_RC_597_0 ND2P $PINS O=carry[13] I1=FE_RN_169_0 I2=FE_RN_178_0
XFE_RC_565_0 INV1S $PINS O=FE_RN_160_0 I=carry[12]
XFE_RC_564_0 XOR2HS $PINS O=FE_RN_161_0 I1=B[12] I2=A[12]
XFE_RC_563_0 ND2 $PINS O=FE_RN_162_0 I1=FE_RN_161_0 I2=FE_RN_160_0
XFE_RC_562_0 ND2S $PINS O=FE_RN_163_0 I1=A[12] I2=B[12]
XFE_RC_561_0 ND2S $PINS O=FE_RN_164_0 I1=FE_RN_163_0 I2=FE_RN_168_0
XFE_RC_560_0 ND2 $PINS O=FE_RN_165_0 I1=FE_RN_164_0 I2=carry[12]
XFE_RC_559_0 ND2P $PINS O=SUM[12] I1=FE_RN_165_0 I2=FE_RN_162_0
XFE_RC_558_0 INV1S $PINS O=FE_RN_166_0 I=B[12]
XFE_RC_557_0 INV1S $PINS O=FE_RN_167_0 I=A[12]
XFE_RC_556_0 OR2 $PINS O=FE_RN_168_0 I1=B[12] I2=A[12]
XFE_RC_555_0 ND2 $PINS O=FE_RN_169_0 I1=FE_RN_168_0 I2=carry[12]
XFE_RC_380_0 INV1S $PINS O=FE_RN_89_0 I=carry[6]
XFE_RC_379_0 XOR2HS $PINS O=FE_RN_90_0 I1=A[6] I2=B[6]
XFE_RC_378_0 ND2S $PINS O=FE_RN_91_0 I1=FE_RN_90_0 I2=FE_RN_89_0
XFE_RC_377_0 ND2 $PINS O=FE_RN_92_0 I1=B[6] I2=A[6]
XFE_RC_376_0 ND2 $PINS O=FE_RN_93_0 I1=FE_RN_92_0 I2=FE_RN_97_0
XFE_RC_375_0 ND2 $PINS O=FE_RN_94_0 I1=FE_RN_93_0 I2=carry[6]
XFE_RC_374_0 ND2P $PINS O=SUM[6] I1=FE_RN_94_0 I2=FE_RN_91_0
XFE_RC_373_0 INV2 $PINS O=FE_RN_95_0 I=A[6]
XFE_RC_372_0 INV1S $PINS O=FE_RN_96_0 I=B[6]
XFE_RC_371_0 OR2 $PINS O=FE_RN_97_0 I1=A[6] I2=B[6]
XFE_RC_370_0 ND2 $PINS O=FE_RN_98_0 I1=FE_RN_97_0 I2=carry[6]
XFE_RC_275_0 XOR3 $PINS O=SUM[5] I1=A[5] I2=B[5] I3=carry[5]
XFE_RC_274_0 MAO222 $PINS O=carry[6] A1=carry[5] B1=A[5] C1=B[5]
XFE_RC_227_0 INV1S $PINS O=FE_RN_38_0 I=FE_RN_19_0
XFE_RC_226_0 OR2B1S $PINS O=FE_RN_39_0 I1=FE_RN_27_0 B1=FE_RN_38_0
XFE_RC_225_0 ND2P $PINS O=carry[14] I1=FE_RN_31_0 I2=FE_RN_39_0
XFE_RC_161_0 INV1S $PINS O=FE_RN_18_0 I=carry[13]
XFE_RC_160_0 INV1S $PINS O=FE_RN_19_0 I=B[13]
XFE_RC_158_0 ND2 $PINS O=FE_RN_21_0 I1=FE_RN_19_0 I2=A[13]
XFE_RC_157_0 OAI12HS $PINS O=FE_RN_22_0 A1=FE_RN_21_0 B1=FE_RN_19_0 B2=A[13]
XFE_RC_156_0 ND2S $PINS O=FE_RN_23_0 I1=FE_RN_22_0 I2=FE_RN_18_0
XFE_RC_155_0 ND2S $PINS O=FE_RN_24_0 I1=B[13] I2=A[13]
XFE_RC_154_0 ND2S $PINS O=FE_RN_25_0 I1=FE_RN_24_0 I2=FE_RN_30_0
XFE_RC_153_0 ND2 $PINS O=FE_RN_26_0 I1=FE_RN_25_0 I2=carry[13]
XFE_RC_152_0 ND2P $PINS O=SUM[13] I1=FE_RN_26_0 I2=FE_RN_23_0
XFE_RC_151_0 INV1S $PINS O=FE_RN_27_0 I=A[13]
XFE_RC_148_0 OR2B1S $PINS O=FE_RN_30_0 I1=A[13] B1=FE_RN_19_0
XFE_RC_147_0 ND2 $PINS O=FE_RN_31_0 I1=FE_RN_30_0 I2=carry[13]
XU1_25 FA1 $PINS S=SUM[25] CO=carry[26] A=A[25] B=B[25] CI=carry[25]
XU1_4 FA1 $PINS S=SUM[4] CO=carry[5] A=B[4] B=A[4] CI=carry[4]
XU1_1 FA1 $PINS S=SUM[1] CO=carry[2] A=B[1] B=A[1] CI=carry[1]
XU1 ND2 $PINS O=n14 I1=B[0] I2=A[0]
XU2 ND3 $PINS O=carry[15] I1=n1 I2=n2 I3=n3
XU3 XOR2HS $PINS O=SUM[3] I1=carry[3] I2=n10
XU4 MAO222S $PINS O=n8 A1=B[1] B1=A[1] C1=carry[1]
XU6 ND2 $PINS O=n1 I1=carry[14] I2=B[14]
XU7 ND2 $PINS O=n2 I1=carry[14] I2=A[14]
XU8 ND2 $PINS O=n3 I1=B[14] I2=A[14]
XU9 XOR2HS $PINS O=n4 I1=B[22] I2=A[22]
XU10 XOR2HS $PINS O=SUM[22] I1=carry[22] I2=n4
XU11 ND2 $PINS O=n5 I1=carry[22] I2=B[22]
XU12 ND2 $PINS O=n6 I1=carry[22] I2=A[22]
XU13 ND2S $PINS O=n7 I1=B[22] I2=A[22]
XU14 ND3P $PINS O=carry[23] I1=n5 I2=n6 I3=n7
XU15 XOR3 $PINS O=SUM[26] I1=A[26] I2=B[26] I3=carry[26]
XU16 INV1S $PINS O=carry[1] I=n14
XU17 MAO222 $PINS O=n9 A1=A[2] B1=B[2] C1=carry[2]
XU18 ND3P $PINS O=carry[4] I1=n11 I2=n12 I3=n13
XU19 XOR2HS $PINS O=n10 I1=B[3] I2=A[3]
XU20 ND2 $PINS O=n11 I1=n9 I2=A[3]
XU21 ND2 $PINS O=n12 I1=n9 I2=B[3]
XU22 ND2 $PINS O=n13 I1=A[3] I2=B[3]
XU23 XOR2HS $PINS O=SUM[0] I1=A[0] I2=B[0]
.ENDS

.SUBCKT PE_Shift_Add_0_DW01_add_1_DW01_add_15 A[26] A[25] A[24] A[23] A[22]
+ A[21] A[20] A[19] A[18] A[17] A[16] A[15] A[14] A[13] A[12] A[11] A[10] A[9]
+ A[8] A[7] A[6] A[5] A[4] A[3] A[2] A[1] A[0] B[26] B[25] B[24] B[23] B[22]
+ B[21] B[20] B[19] B[18] B[17] B[16] B[15] B[14] B[13] B[12] B[11] B[10] B[9]
+ B[8] B[7] B[6] B[5] B[4] B[3] B[2] B[1] B[0] CI SUM[26] SUM[25] SUM[24]
+ SUM[23] SUM[22] SUM[21] SUM[20] SUM[19] SUM[18] SUM[17] SUM[16] SUM[15]
+ SUM[14] SUM[13] SUM[12] SUM[11] SUM[10] SUM[9] SUM[8] SUM[7] SUM[6] SUM[5]
+ SUM[4] SUM[3] SUM[2] SUM[1] SUM[0] CO
XFE_RC_318_0 XOR2HS $PINS O=SUM[21] I1=FE_RN_2180_0 I2=FE_OCPN883_carry_21
XFE_RC_171_0 INV1S $PINS O=FE_RN_78_0 I=FE_RN_1048_0
XFE_RC_170_0 INV1S $PINS O=FE_RN_79_0 I=carry[10]
XFE_RC_169_0 ND2 $PINS O=FE_RN_80_0 I1=FE_RN_79_0 I2=FE_RN_78_0
XFE_RC_168_0 ND2P $PINS O=SUM[10] I1=FE_RN_80_0 I2=FE_RN_1051_0
XFE_RC_167_0 ND3P $PINS O=carry[3] I1=n14 I2=n15 I3=n13
XFE_RC_4057_0 XNR2H $PINS O=FE_RN_2603_0 I1=B[9] I2=A[9]
XFE_RC_4056_0 INV2 $PINS O=FE_RN_2602_0 I=FE_RN_2603_0
XFE_RC_4055_0 XOR2HS $PINS O=SUM[9] I1=FE_RN_2602_0 I2=carry[9]
XFE_OCPC1109_N102 BUF1 $PINS O=FE_OCPN1109_N102 I=B[6]
XFE_OCPC883_carry_21 BUF1 $PINS O=FE_OCPN883_carry_21 I=carry[21]
XFE_RC_3972_0 ND3P $PINS O=carry[10] I1=n10 I2=n9 I3=n11
XFE_RC_3787_0 INV1S $PINS O=FE_RN_2483_0 I=carry[11]
XFE_RC_3786_0 AOI22H $PINS O=SUM[11] A1=FE_RN_787_0 A2=FE_RN_2483_0
+ B1=FE_RN_783_0 B2=carry[11]
XFE_RC_3651_0 INV1S $PINS O=FE_RN_2382_0 I=carry[23]
XFE_RC_3650_0 XOR2HS $PINS O=FE_RN_2383_0 I1=B[23] I2=A[23]
XFE_RC_3649_0 ND2S $PINS O=FE_RN_2384_0 I1=FE_RN_2383_0 I2=FE_RN_2382_0
XFE_RC_3648_0 INV1S $PINS O=FE_RN_2385_0 I=B[23]
XFE_RC_3647_0 INV1S $PINS O=FE_RN_2386_0 I=A[23]
XFE_RC_3646_0 OAI12HS $PINS O=FE_RN_2387_0 A1=FE_RN_2391_0 B1=FE_RN_2386_0
+ B2=FE_RN_2385_0
XFE_RC_3645_0 ND2 $PINS O=FE_RN_2388_0 I1=FE_RN_2387_0 I2=carry[23]
XFE_RC_3644_0 ND2P $PINS O=SUM[23] I1=FE_RN_2388_0 I2=FE_RN_2384_0
XFE_RC_3643_0 ND2 $PINS O=FE_RN_2389_0 I1=A[23] I2=B[23]
XFE_RC_3641_0 OR2B1S $PINS O=FE_RN_2391_0 I1=B[23] B1=FE_RN_2386_0
XFE_RC_3640_0 ND2 $PINS O=FE_RN_2392_0 I1=FE_RN_2391_0 I2=carry[23]
XFE_RC_3639_0 ND2P $PINS O=carry[24] I1=FE_RN_2392_0 I2=FE_RN_2389_0
XFE_OCPC487_carry_18 BUF1S $PINS O=FE_OCPN487_carry_18 I=carry[18]
XFE_RC_3360_0 XOR2HS $PINS O=FE_RN_2180_0 I1=B[21] I2=A[21]
XFE_RC_3358_0 ND2 $PINS O=FE_RN_2181_0 I1=A[21] I2=B[21]
XFE_RC_3357_0 OAI12HS $PINS O=FE_RN_2182_0 A1=carry[21] B1=A[21] B2=B[21]
XFE_RC_3356_0 ND2P $PINS O=carry[22] I1=FE_RN_2182_0 I2=FE_RN_2181_0
XFE_RC_3254_0 ND2 $PINS O=FE_RN_2102_0 I1=carry[7] I2=B[7]
XFE_RC_3253_0 AOI22H $PINS O=FE_RN_2103_0 A1=B[7] A2=A[7] B1=carry[7] B2=A[7]
XFE_RC_3252_0 ND2P $PINS O=carry[8] I1=FE_RN_2103_0 I2=FE_RN_2102_0
XFE_RC_3232_0 ND3P $PINS O=carry[15] I1=n7 I2=n6 I3=n8
XFE_RC_3018_0 ND2 $PINS O=FE_RN_1933_0 I1=A[15] I2=B[15]
XFE_RC_3017_0 ND2 $PINS O=FE_RN_1934_0 I1=FE_RN_1933_0 I2=FE_RN_1941_0
XFE_RC_3016_0 INV1S $PINS O=FE_RN_1935_0 I=A[15]
XFE_RC_3014_0 NR2 $PINS O=FE_RN_1937_0 I1=B[15] I2=FE_RN_1935_0
XFE_RC_3013_0 AOI12HS $PINS O=FE_RN_1938_0 A1=FE_RN_1937_0 B1=FE_RN_1935_0
+ B2=B[15]
XFE_RC_3012_0 MOAI1 $PINS O=SUM[15] A1=FE_RN_1938_0 A2=carry[15]
+ B1=FE_RN_1934_0 B2=carry[15]
XFE_RC_3009_0 OR2B1S $PINS O=FE_RN_1941_0 I1=B[15] B1=FE_RN_1935_0
XFE_RC_3008_0 ND2 $PINS O=FE_RN_1942_0 I1=FE_RN_1941_0 I2=carry[15]
XFE_RC_3007_0 ND2P $PINS O=carry[16] I1=FE_RN_1942_0 I2=FE_RN_1933_0
XFE_RC_2848_0 ND2 $PINS O=FE_RN_1810_0 I1=A[16] I2=B[16]
XFE_RC_2847_0 ND2 $PINS O=FE_RN_1811_0 I1=FE_RN_1810_0 I2=FE_RN_1818_0
XFE_RC_2846_0 INV1S $PINS O=FE_RN_1812_0 I=A[16]
XFE_RC_2844_0 NR2 $PINS O=FE_RN_1814_0 I1=B[16] I2=FE_RN_1812_0
XFE_RC_2843_0 AOI12HS $PINS O=FE_RN_1815_0 A1=FE_RN_1814_0 B1=FE_RN_1812_0
+ B2=B[16]
XFE_RC_2842_0 MOAI1 $PINS O=SUM[16] A1=FE_RN_1815_0 A2=carry[16]
+ B1=FE_RN_1811_0 B2=carry[16]
XFE_RC_2839_0 OR2B1S $PINS O=FE_RN_1818_0 I1=B[16] B1=FE_RN_1812_0
XFE_RC_2838_0 ND2 $PINS O=FE_RN_1819_0 I1=FE_RN_1818_0 I2=carry[16]
XFE_RC_2837_0 ND2P $PINS O=carry[17] I1=FE_RN_1819_0 I2=FE_RN_1810_0
XFE_RC_2278_0 INV1S $PINS O=FE_RN_1388_0 I=A[17]
XFE_RC_2277_0 AN2B1S $PINS O=FE_RN_1389_0 I1=B[17] B1=FE_RN_1388_0
XFE_RC_2276_0 AN2B1S $PINS O=FE_RN_1390_0 I1=FE_RN_1396_0 B1=FE_RN_1389_0
XFE_RC_2273_0 MAOI1 $PINS O=FE_RN_1393_0 A1=FE_RN_1388_0 A2=B[17] B1=B[17]
+ B2=FE_RN_1388_0
XFE_RC_2272_0 MXL2HS $PINS OB=SUM[17] S=carry[17] A=FE_RN_1393_0 B=FE_RN_1390_0
XFE_RC_2271_0 ND2S $PINS O=FE_RN_1394_0 I1=A[17] I2=B[17]
XFE_RC_2269_0 OR2B1S $PINS O=FE_RN_1396_0 I1=B[17] B1=FE_RN_1388_0
XFE_RC_2268_0 ND2 $PINS O=FE_RN_1397_0 I1=FE_RN_1396_0 I2=carry[17]
XFE_RC_2267_0 ND2S $PINS O=carry[18] I1=FE_RN_1397_0 I2=FE_RN_1394_0
XFE_RC_1818_0 INV1S $PINS O=FE_RN_1045_0 I=A[10]
XFE_RC_1816_0 NR2 $PINS O=FE_RN_1047_0 I1=B[10] I2=FE_RN_1045_0
XFE_RC_1815_0 AOI12HS $PINS O=FE_RN_1048_0 A1=FE_RN_1047_0 B1=FE_RN_1045_0
+ B2=B[10]
XFE_RC_1814_0 ND2 $PINS O=FE_RN_1049_0 I1=A[10] I2=B[10]
XFE_RC_1813_0 ND2 $PINS O=FE_RN_1050_0 I1=FE_RN_1049_0 I2=FE_RN_1054_0
XFE_RC_1812_0 ND2 $PINS O=FE_RN_1051_0 I1=FE_RN_1050_0 I2=carry[10]
XFE_RC_1808_0 OR2B1S $PINS O=FE_RN_1054_0 I1=B[10] B1=FE_RN_1045_0
XFE_RC_1807_0 ND2 $PINS O=FE_RN_1055_0 I1=FE_RN_1054_0 I2=carry[10]
XFE_RC_1806_0 ND2P $PINS O=carry[11] I1=FE_RN_1055_0 I2=FE_RN_1049_0
XFE_RC_1473_0 ND2 $PINS O=FE_RN_792_0 I1=carry[5] I2=B[5]
XFE_RC_1472_0 AOI22H $PINS O=FE_RN_793_0 A1=B[5] A2=A[5] B1=carry[5] B2=A[5]
XFE_RC_1471_0 ND2P $PINS O=carry[6] I1=FE_RN_793_0 I2=FE_RN_792_0
XFE_RC_1470_0 INV1S $PINS O=FE_RN_781_0 I=A[11]
XFE_RC_1469_0 AN2B1S $PINS O=FE_RN_782_0 I1=B[11] B1=FE_RN_781_0
XFE_RC_1468_0 AN2B1S $PINS O=FE_RN_783_0 I1=FE_RN_790_0 B1=FE_RN_782_0
XFE_RC_1465_0 NR2 $PINS O=FE_RN_786_0 I1=B[11] I2=FE_RN_781_0
XFE_RC_1464_0 AOI12HS $PINS O=FE_RN_787_0 A1=FE_RN_786_0 B1=FE_RN_781_0
+ B2=B[11]
XFE_RC_1462_0 ND2S $PINS O=FE_RN_788_0 I1=A[11] I2=B[11]
XFE_RC_1460_0 OR2B1S $PINS O=FE_RN_790_0 I1=B[11] B1=FE_RN_781_0
XFE_RC_1459_0 ND2 $PINS O=FE_RN_791_0 I1=FE_RN_790_0 I2=carry[11]
XFE_RC_1458_0 ND2 $PINS O=carry[12] I1=FE_RN_791_0 I2=FE_RN_788_0
XFE_RC_940_0 INV1S $PINS O=FE_RN_378_0 I=A[18]
XFE_RC_939_0 AN2B1S $PINS O=FE_RN_379_0 I1=B[18] B1=FE_RN_378_0
XFE_RC_938_0 AN2B1S $PINS O=FE_RN_380_0 I1=FE_RN_386_0 B1=FE_RN_379_0
XFE_RC_935_0 MAOI1 $PINS O=FE_RN_383_0 A1=FE_RN_378_0 A2=B[18] B1=B[18]
+ B2=FE_RN_378_0
XFE_RC_934_0 MXL2HS $PINS OB=SUM[18] S=FE_OCPN487_carry_18 A=FE_RN_383_0
+ B=FE_RN_380_0
XFE_RC_933_0 ND2 $PINS O=FE_RN_384_0 I1=A[18] I2=B[18]
XFE_RC_931_0 OR2B1S $PINS O=FE_RN_386_0 I1=B[18] B1=FE_RN_378_0
XFE_RC_930_0 ND2 $PINS O=FE_RN_387_0 I1=FE_RN_386_0 I2=carry[18]
XFE_RC_929_0 ND2P $PINS O=carry[19] I1=FE_RN_387_0 I2=FE_RN_384_0
XFE_RC_928_0 ND3P $PINS O=carry[21] I1=n4 I2=n3 I3=n5
XFE_RC_553_0 INV1S $PINS O=FE_RN_150_0 I=A[12]
XFE_RC_552_0 AN2B1S $PINS O=FE_RN_151_0 I1=B[12] B1=FE_RN_150_0
XFE_RC_551_0 AN2B1S $PINS O=FE_RN_152_0 I1=FE_RN_158_0 B1=FE_RN_151_0
XFE_RC_548_0 MAOI1 $PINS O=FE_RN_155_0 A1=FE_RN_150_0 A2=B[12] B1=B[12]
+ B2=FE_RN_150_0
XFE_RC_547_0 MXL2HS $PINS OB=SUM[12] S=carry[12] A=FE_RN_155_0 B=FE_RN_152_0
XFE_RC_546_0 ND2S $PINS O=FE_RN_156_0 I1=A[12] I2=B[12]
XFE_RC_544_0 OR2B1S $PINS O=FE_RN_158_0 I1=B[12] B1=FE_RN_150_0
XFE_RC_543_0 ND2 $PINS O=FE_RN_159_0 I1=FE_RN_158_0 I2=carry[12]
XFE_RC_542_0 ND2P $PINS O=carry[13] I1=FE_RN_159_0 I2=FE_RN_156_0
XFE_RC_438_0 XOR3 $PINS O=SUM[5] I1=A[5] I2=B[5] I3=carry[5]
XFE_RC_140_0 ND2S $PINS O=FE_RN_5_0 I1=A[6] I2=FE_OCPN1109_N102
XFE_RC_139_0 ND2 $PINS O=FE_RN_6_0 I1=FE_RN_5_0 I2=FE_RN_16_0
XFE_RC_138_0 ND2 $PINS O=FE_RN_7_0 I1=FE_RN_6_0 I2=carry[6]
XFE_RC_137_0 INV1S $PINS O=FE_RN_8_0 I=carry[6]
XFE_RC_136_0 INV1S $PINS O=FE_RN_9_0 I=A[6]
XFE_RC_134_0 ND2S $PINS O=FE_RN_11_0 I1=FE_RN_9_0 I2=FE_OCPN1109_N102
XFE_RC_133_0 OAI12HS $PINS O=FE_RN_12_0 A1=FE_RN_11_0 B1=FE_RN_9_0
+ B2=FE_OCPN1109_N102
XFE_RC_132_0 ND2S $PINS O=FE_RN_13_0 I1=FE_RN_12_0 I2=FE_RN_8_0
XFE_RC_131_0 ND2 $PINS O=SUM[6] I1=FE_RN_13_0 I2=FE_RN_7_0
XFE_RC_128_0 OR2B1S $PINS O=FE_RN_16_0 I1=B[6] B1=FE_RN_9_0
XFE_RC_127_0 ND2P $PINS O=FE_RN_17_0 I1=carry[6] I2=FE_RN_16_0
XFE_RC_126_0 ND2P $PINS O=carry[7] I1=FE_RN_17_0 I2=FE_RN_5_0
XFE_RC_86_0 XOR3 $PINS O=SUM[7] I1=A[7] I2=B[7] I3=carry[7]
XFE_RC_56_0 XOR3 $PINS O=SUM[8] I1=A[8] I2=B[8] I3=carry[8]
XFE_RC_55_0 MAO222P $PINS O=carry[9] A1=carry[8] B1=B[8] C1=A[8]
XU1_25 FA1 $PINS S=SUM[25] CO=carry[26] A=A[25] B=B[25] CI=carry[25]
XU1_24 FA1 $PINS S=SUM[24] CO=carry[25] A=A[24] B=B[24] CI=carry[24]
XU1_22 FA1 $PINS S=SUM[22] CO=carry[23] A=A[22] B=B[22] CI=carry[22]
XU1_19 FA1 $PINS S=SUM[19] CO=carry[20] A=A[19] B=B[19] CI=carry[19]
XU1_13 FA1 $PINS S=SUM[13] CO=carry[14] A=A[13] B=B[13] CI=carry[13]
XU1_4 FA1 $PINS S=SUM[4] CO=carry[5] A=A[4] B=B[4] CI=carry[4]
XU1_1 FA1 $PINS S=SUM[1] CO=carry[2] A=A[1] B=B[1] CI=carry[1]
XU1_3 FA1 $PINS S=SUM[3] CO=carry[4] A=B[3] B=A[3] CI=carry[3]
XU1 MAO222 $PINS O=n1 A1=A[19] B1=B[19] C1=carry[19]
XU3 XOR3 $PINS O=SUM[2] I1=n12 I2=A[2] I3=B[2]
XU4 XOR3 $PINS O=SUM[14] I1=B[14] I2=A[14] I3=n2
XU5 MAO222 $PINS O=n2 A1=carry[13] B1=B[13] C1=A[13]
XU8 ND2 $PINS O=n15 I1=B[2] I2=A[2]
XU9 INV2 $PINS O=carry[1] I=n16
XU10 ND2 $PINS O=n16 I1=B[0] I2=A[0]
XU12 ND2 $PINS O=n14 I1=carry[2] I2=A[2]
XU13 XOR3 $PINS O=SUM[20] I1=B[20] I2=A[20] I3=n1
XU14 ND2 $PINS O=n3 I1=n1 I2=B[20]
XU15 ND2 $PINS O=n4 I1=carry[20] I2=A[20]
XU16 ND2 $PINS O=n5 I1=B[20] I2=A[20]
XU17 ND2 $PINS O=n6 I1=n2 I2=B[14]
XU18 ND2 $PINS O=n7 I1=carry[14] I2=A[14]
XU19 ND2S $PINS O=n8 I1=B[14] I2=A[14]
XU20 ND2 $PINS O=n9 I1=carry[9] I2=B[9]
XU21 ND2 $PINS O=n10 I1=carry[9] I2=A[9]
XU22 ND2S $PINS O=n11 I1=B[9] I2=A[9]
XU23 XOR3 $PINS O=SUM[26] I1=A[26] I2=B[26] I3=carry[26]
XU24 MAO222 $PINS O=n12 A1=B[1] B1=A[1] C1=carry[1]
XU25 ND2 $PINS O=n13 I1=B[2] I2=n12
XU27 XOR2HS $PINS O=SUM[0] I1=B[0] I2=A[0]
.ENDS

.SUBCKT PE_Shift_Add_0_DW01_add_0_DW01_add_14 A[26] A[25] A[24] A[23] A[22]
+ A[21] A[20] A[19] A[18] A[17] A[16] A[15] A[14] A[13] A[12] A[11] A[10] A[9]
+ A[8] A[7] A[6] A[5] A[4] A[3] A[2] A[1] A[0] B[26] B[25] B[24] B[23] B[22]
+ B[21] B[20] B[19] B[18] B[17] B[16] B[15] B[14] B[13] B[12] B[11] B[10] B[9]
+ B[8] B[7] B[6] B[5] B[4] B[3] B[2] B[1] B[0] CI SUM[26] SUM[25] SUM[24]
+ SUM[23] SUM[22] SUM[21] SUM[20] SUM[19] SUM[18] SUM[17] SUM[16] SUM[15]
+ SUM[14] SUM[13] SUM[12] SUM[11] SUM[10] SUM[9] SUM[8] SUM[7] SUM[6] SUM[5]
+ SUM[4] SUM[3] SUM[2] SUM[1] SUM[0] CO
XFE_RC_163_0 XOR3T $PINS O=SUM[25] I1=A[25] I2=B[25] I3=carry[25]
XFE_RC_162_0 MAO222P $PINS O=carry[26] A1=A[25] B1=B[25] C1=carry[25]
XFE_RC_13_0 OR2 $PINS O=FE_RN_9_0 I1=FE_RN_1035_0 I2=FE_RN_1036_0
XFE_RC_12_0 ND2P $PINS O=carry[7] I1=FE_RN_2355_0 I2=FE_RN_9_0
XFE_OCPC1236_N214 BUF1S $PINS O=FE_OCPN1236_N214 I=B[9]
XFE_OCPC1235_N213 BUF1S $PINS O=FE_OCPN1235_N213 I=B[8]
XFE_OCPC1221_N194 BUF1S $PINS O=FE_OCPN1221_N194 I=A[16]
XFE_OCPC1220_FE_RN_774_0 BUF1S $PINS O=FE_OCPN1220_FE_RN_774_0 I=FE_RN_774_0
XFE_OCPC1213_carry_4 BUF1S $PINS O=FE_OCPN1213_carry_4 I=carry[4]
XFE_OCPC1204_N185 BUF1S $PINS O=FE_OCPN1204_N185 I=A[7]
XFE_OCPC1201_N219 BUF1S $PINS O=FE_OCPN1201_N219 I=B[14]
XFE_OCPC1182_N215 BUF3CK $PINS O=FE_OCPN1182_N215 I=B[10]
XFE_OCPC1153_N187 BUF1S $PINS O=FE_OCPN1153_N187 I=A[9]
XFE_OCPC1142_carry_6 BUF1S $PINS O=FE_OCPN1142_carry_6 I=carry[6]
XFE_OCPC1129_carry_5 BUF1S $PINS O=FE_OCPN1129_carry_5 I=carry[5]
XFE_OCPC1121_FE_RN_535_0 BUF1S $PINS O=FE_OCPN1121_FE_RN_535_0 I=FE_RN_535_0
XFE_OCPC1069_carry_7 BUF1S $PINS O=FE_OCPN1069_carry_7 I=carry[7]
XFE_OCPC1037_carry_24 BUF1S $PINS O=FE_OCPN1037_carry_24 I=carry[24]
XFE_OCPC1033_carry_21 BUF1S $PINS O=FE_OCPN1033_carry_21 I=carry[21]
XFE_OCPC1023_carry_15 BUF1S $PINS O=FE_OCPN1023_carry_15 I=carry[15]
XFE_OCPC950_FE_RN_329_0 BUF1S $PINS O=FE_OCPN950_FE_RN_329_0 I=FE_RN_329_0
XFE_OCPC903_carry_10 BUF1S $PINS O=FE_OCPN903_carry_10 I=carry[10]
XFE_RC_3704_0 ND3P $PINS O=carry[5] I1=n4 I2=n5 I3=n3
XFE_RC_3604_0 ND2P $PINS O=FE_RN_2355_0 I1=carry[6] I2=FE_RN_1034_0
XFE_OCPC447_carry_18 BUF1S $PINS O=FE_OCPN447_carry_18 I=carry[18]
XFE_OCPC426_carry_8 BUF1S $PINS O=FE_OCPN426_carry_8 I=carry[8]
XFE_OCPC388_carry_22 BUF1S $PINS O=FE_OCPN388_carry_22 I=carry[22]
XFE_OCPC311_carry_11 BUF1S $PINS O=FE_OCPN311_carry_11 I=carry[11]
XFE_OCPC310_carry_13 BUF1S $PINS O=FE_OCPN310_carry_13 I=carry[13]
XFE_OCPC309_carry_14 BUF1S $PINS O=FE_OCPN309_carry_14 I=carry[14]
XFE_OCPC308_carry_16 BUF1S $PINS O=FE_OCPN308_carry_16 I=carry[16]
XFE_OCPC300_carry_19 BUF1S $PINS O=FE_OCPN300_carry_19 I=carry[19]
XFE_OCPC298_carry_9 BUF1S $PINS O=FE_OCPN298_carry_9 I=carry[9]
XFE_OCPC243_carry_12 BUF1S $PINS O=FE_OCPN243_carry_12 I=carry[12]
XFE_OCPC241_carry_23 BUF1S $PINS O=FE_OCPN241_carry_23 I=carry[23]
XFE_OCPC237_carry_17 BUF1S $PINS O=FE_OCPN237_carry_17 I=carry[17]
XFE_RC_3231_0 ND2 $PINS O=FE_RN_2085_0 I1=carry[22] I2=B[22]
XFE_RC_3230_0 AOI22H $PINS O=FE_RN_2086_0 A1=A[22] A2=B[22] B1=carry[22]
+ B2=A[22]
XFE_RC_3229_0 ND2P $PINS O=carry[23] I1=FE_RN_2086_0 I2=FE_RN_2085_0
XFE_RC_3195_0 ND3HT $PINS O=carry[21] I1=n20 I2=n19 I3=n21
XFE_RC_3113_0 AOI22H $PINS O=FE_RN_1616_0 A1=B[12] A2=A[12] B1=carry[12]
+ B2=A[12]
XFE_RC_3091_0 ND3HT $PINS O=carry[24] I1=FE_RN_1167_0 I2=FE_RN_1166_0
+ I3=FE_RN_1168_0
XFE_RC_2881_0 ND2P $PINS O=FE_RN_1839_0 I1=carry[11] I2=B[11]
XFE_RC_2880_0 AOI22H $PINS O=FE_RN_1840_0 A1=A[11] A2=B[11] B1=carry[11]
+ B2=A[11]
XFE_RC_2879_0 ND2P $PINS O=carry[12] I1=FE_RN_1840_0 I2=FE_RN_1839_0
XFE_RC_2869_0 ND2 $PINS O=FE_RN_1833_0 I1=carry[24] I2=B[24]
XFE_RC_2868_0 AOI22H $PINS O=FE_RN_1834_0 A1=A[24] A2=B[24] B1=carry[24]
+ B2=A[24]
XFE_RC_2867_0 ND2P $PINS O=carry[25] I1=FE_RN_1834_0 I2=FE_RN_1833_0
XFE_RC_2807_0 AOI22H $PINS O=FE_RN_1442_0 A1=B[13] A2=A[13] B1=carry[13]
+ B2=A[13]
XFE_RC_2801_0 AOI22H $PINS O=FE_RN_1618_0 A1=B[16] A2=A[16] B1=carry[16]
+ B2=A[16]
XFE_RC_2784_0 ND2P $PINS O=FE_RN_1771_0 I1=carry[10] I2=FE_OCPN1182_N215
XFE_RC_2783_0 AOI22H $PINS O=FE_RN_1772_0 A1=A[10] A2=B[10] B1=carry[10]
+ B2=A[10]
XFE_RC_2782_0 ND2P $PINS O=carry[11] I1=FE_RN_1772_0 I2=FE_RN_1771_0
XFE_RC_2574_0 ND2 $PINS O=FE_RN_1617_0 I1=carry[16] I2=B[16]
XFE_RC_2572_0 ND2P $PINS O=carry[17] I1=FE_RN_1618_0 I2=FE_RN_1617_0
XFE_RC_2571_0 ND2P $PINS O=FE_RN_1615_0 I1=carry[12] I2=B[12]
XFE_RC_2569_0 ND2P $PINS O=carry[13] I1=FE_RN_1616_0 I2=FE_RN_1615_0
XFE_RC_2340_0 ND2 $PINS O=FE_RN_1441_0 I1=carry[13] I2=B[13]
XFE_RC_2338_0 ND2P $PINS O=carry[14] I1=FE_RN_1442_0 I2=FE_RN_1441_0
XFE_RC_2337_0 ND2 $PINS O=FE_RN_1439_0 I1=carry[17] I2=B[17]
XFE_RC_2336_0 AOI22H $PINS O=FE_RN_1440_0 A1=A[17] A2=B[17] B1=carry[17]
+ B2=A[17]
XFE_RC_2335_0 ND2P $PINS O=carry[18] I1=FE_RN_1440_0 I2=FE_RN_1439_0
XFE_RC_2166_0 ND2P $PINS O=FE_RN_1314_0 I1=carry[14] I2=B[14]
XFE_RC_2165_0 AOI22H $PINS O=FE_RN_1315_0 A1=A[14] A2=B[14] B1=carry[14]
+ B2=A[14]
XFE_RC_2164_0 ND2P $PINS O=carry[15] I1=FE_RN_1315_0 I2=FE_RN_1314_0
XFE_RC_2091_0 ND2 $PINS O=FE_RN_1260_0 I1=carry[15] I2=B[15]
XFE_RC_2090_0 AOI22H $PINS O=FE_RN_1261_0 A1=A[15] A2=B[15] B1=carry[15]
+ B2=A[15]
XFE_RC_2089_0 ND2P $PINS O=carry[16] I1=FE_RN_1261_0 I2=FE_RN_1260_0
XFE_RC_2037_0 ND2 $PINS O=FE_RN_1217_0 I1=carry[21] I2=B[21]
XFE_RC_2036_0 AOI22H $PINS O=FE_RN_1218_0 A1=A[21] A2=B[21] B1=carry[21]
+ B2=A[21]
XFE_RC_2035_0 ND2P $PINS O=carry[22] I1=FE_RN_1218_0 I2=FE_RN_1217_0
XFE_RC_1967_0 ND2P $PINS O=FE_RN_1166_0 I1=carry[23] I2=B[23]
XFE_RC_1966_0 ND2P $PINS O=FE_RN_1167_0 I1=carry[23] I2=A[23]
XFE_RC_1965_0 ND2 $PINS O=FE_RN_1168_0 I1=A[23] I2=B[23]
XFE_RC_1792_0 XOR2HS $PINS O=FE_RN_1033_0 I1=B[6] I2=A[6]
XFE_RC_1791_0 XOR2HS $PINS O=SUM[6] I1=FE_OCPN1142_carry_6 I2=FE_RN_1033_0
XFE_RC_1790_0 OR2 $PINS O=FE_RN_1034_0 I1=A[6] I2=B[6]
XFE_RC_1789_0 INV1S $PINS O=FE_RN_1035_0 I=B[6]
XFE_RC_1788_0 INV1S $PINS O=FE_RN_1036_0 I=A[6]
XFE_RC_1448_0 INV1S $PINS O=FE_RN_765_0 I=B[7]
XFE_RC_1446_0 NR2 $PINS O=FE_RN_767_0 I1=A[7] I2=FE_RN_765_0
XFE_RC_1445_0 AOI12HS $PINS O=FE_RN_768_0 A1=FE_RN_767_0 B1=FE_RN_765_0
+ B2=FE_OCPN1204_N185
XFE_RC_1444_0 INV1S $PINS O=FE_RN_769_0 I=FE_OCPN1204_N185
XFE_RC_1442_0 OAI12HS $PINS O=FE_RN_771_0 A1=FE_OCPN1220_FE_RN_774_0
+ B1=FE_RN_765_0 B2=FE_RN_769_0
XFE_RC_1441_0 ND2 $PINS O=FE_RN_772_0 I1=FE_RN_771_0 I2=FE_OCPN1069_carry_7
XFE_RC_1440_0 OAI12HS $PINS O=SUM[7] A1=FE_RN_772_0 B1=FE_RN_768_0
+ B2=FE_OCPN1069_carry_7
XFE_RC_1439_0 ND2 $PINS O=FE_RN_773_0 I1=B[7] I2=A[7]
XFE_RC_1438_0 OR2P $PINS O=FE_RN_774_0 I1=A[7] I2=B[7]
XFE_RC_1437_0 ND2P $PINS O=FE_RN_775_0 I1=FE_RN_774_0 I2=carry[7]
XFE_RC_1436_0 ND2P $PINS O=carry[8] I1=FE_RN_775_0 I2=FE_RN_773_0
XFE_RC_1137_0 INV1S $PINS O=FE_RN_525_0 I=FE_OCPN1235_N213
XFE_RC_1136_0 INV2CK $PINS O=FE_RN_526_0 I=A[8]
XFE_RC_1135_0 AOI22S $PINS O=FE_RN_527_0 A1=FE_RN_526_0 A2=FE_OCPN1235_N213
+ B1=A[8] B2=FE_RN_525_0
XFE_RC_1132_0 OAI12HS $PINS O=FE_RN_530_0 A1=FE_OCPN1121_FE_RN_535_0
+ B1=FE_RN_526_0 B2=FE_RN_525_0
XFE_RC_1131_0 ND2 $PINS O=FE_RN_531_0 I1=FE_RN_530_0 I2=FE_OCPN426_carry_8
XFE_RC_1130_0 OAI12HS $PINS O=SUM[8] A1=FE_RN_531_0 B1=FE_RN_527_0
+ B2=FE_OCPN426_carry_8
XFE_RC_1129_0 ND2 $PINS O=FE_RN_532_0 I1=A[8] I2=B[8]
XFE_RC_1128_0 INV1S $PINS O=FE_RN_533_0 I=B[8]
XFE_RC_1126_0 ND2P $PINS O=FE_RN_535_0 I1=FE_RN_533_0 I2=FE_RN_526_0
XFE_RC_1125_0 ND2P $PINS O=FE_RN_536_0 I1=carry[8] I2=FE_RN_535_0
XFE_RC_1124_0 ND2P $PINS O=carry[9] I1=FE_RN_536_0 I2=FE_RN_532_0
XFE_RC_863_0 XNR2HS $PINS O=FE_RN_323_0 I1=A[9] I2=FE_OCPN1236_N214
XFE_RC_862_0 INV1S $PINS O=FE_RN_324_0 I=FE_OCPN1153_N187
XFE_RC_861_0 INV1S $PINS O=FE_RN_325_0 I=FE_OCPN1236_N214
XFE_RC_860_0 OAI12HS $PINS O=FE_RN_326_0 A1=FE_OCPN950_FE_RN_329_0
+ B1=FE_RN_325_0 B2=FE_RN_324_0
XFE_RC_859_0 ND2 $PINS O=FE_RN_327_0 I1=FE_RN_326_0 I2=FE_OCPN298_carry_9
XFE_RC_858_0 OAI12HS $PINS O=SUM[9] A1=FE_RN_327_0 B1=FE_RN_323_0
+ B2=FE_OCPN298_carry_9
XFE_RC_857_0 ND2 $PINS O=FE_RN_328_0 I1=B[9] I2=A[9]
XFE_RC_856_0 OR2T $PINS O=FE_RN_329_0 I1=A[9] I2=B[9]
XFE_RC_855_0 ND2P $PINS O=FE_RN_330_0 I1=FE_RN_329_0 I2=carry[9]
XFE_RC_854_0 ND2P $PINS O=carry[10] I1=FE_RN_330_0 I2=FE_RN_328_0
XFE_RC_710_0 XOR3 $PINS O=SUM[11] I1=A[11] I2=B[11] I3=FE_OCPN311_carry_11
XFE_RC_600_0 XOR3 $PINS O=SUM[12] I1=A[12] I2=B[12] I3=FE_OCPN243_carry_12
XFE_RC_492_0 XOR3 $PINS O=SUM[10] I1=A[10] I2=FE_OCPN1182_N215
+ I3=FE_OCPN903_carry_10
XFE_RC_490_0 XOR3 $PINS O=SUM[13] I1=A[13] I2=B[13] I3=FE_OCPN310_carry_13
XFE_RC_424_0 XOR3 $PINS O=SUM[21] I1=A[21] I2=B[21] I3=FE_OCPN1033_carry_21
XFE_RC_342_0 XOR3 $PINS O=SUM[14] I1=A[14] I2=FE_OCPN1201_N219
+ I3=FE_OCPN309_carry_14
XFE_RC_266_0 XOR3 $PINS O=SUM[15] I1=A[15] I2=B[15] I3=FE_OCPN1023_carry_15
XFE_RC_110_0 XOR3 $PINS O=SUM[22] I1=A[22] I2=B[22] I3=FE_OCPN388_carry_22
XFE_RC_102_0 XOR3 $PINS O=SUM[16] I1=FE_OCPN1221_N194 I2=B[16]
+ I3=FE_OCPN308_carry_16
XFE_RC_62_0 XOR3 $PINS O=SUM[23] I1=A[23] I2=B[23] I3=FE_OCPN241_carry_23
XFE_RC_60_0 XOR3 $PINS O=SUM[17] I1=A[17] I2=B[17] I3=FE_OCPN237_carry_17
XFE_RC_25_0 XOR3 $PINS O=SUM[24] I1=A[24] I2=B[24] I3=FE_OCPN1037_carry_24
XU1_26 XOR3 $PINS O=SUM[26] I1=B[26] I2=A[26] I3=carry[26]
XU1_1 FA1 $PINS S=SUM[1] CO=carry[2] A=A[1] B=B[1] CI=n2
XU1_2 FA1 $PINS S=SUM[2] CO=carry[3] A=A[2] B=B[2] CI=carry[2]
XU1_19 FA1S $PINS S=SUM[19] CO=carry[20] A=A[19] B=B[19] CI=FE_OCPN300_carry_19
XU1 ND2 $PINS O=n5 I1=carry[4] I2=B[4]
XU2 ND2 $PINS O=n4 I1=carry[4] I2=A[4]
XU5 ND2 $PINS O=n12 I1=B[3] I2=A[3]
XU6 XOR3 $PINS O=SUM[3] I1=B[3] I2=A[3] I3=carry[3]
XU7 XOR3 $PINS O=SUM[18] I1=A[18] I2=B[18] I3=FE_OCPN447_carry_18
XU9 ND2 $PINS O=n3 I1=A[4] I2=B[4]
XU10 XOR3 $PINS O=SUM[20] I1=A[20] I2=B[20] I3=carry[20]
XU11 ND2 $PINS O=n21 I1=B[20] I2=A[20]
XU12 AN2 $PINS O=n2 I1=B[0] I2=A[0]
XU13 ND3P $PINS O=carry[6] I1=n9 I2=n8 I3=n7
XU15 XOR2HS $PINS O=n6 I1=A[5] I2=B[5]
XU16 XOR2HS $PINS O=SUM[5] I1=n6 I2=FE_OCPN1129_carry_5
XU17 ND2 $PINS O=n7 I1=A[5] I2=B[5]
XU18 ND2 $PINS O=n8 I1=carry[5] I2=A[5]
XU19 ND2 $PINS O=n9 I1=carry[5] I2=B[5]
XU20 ND2 $PINS O=n10 I1=carry[3] I2=B[3]
XU21 ND2 $PINS O=n11 I1=carry[3] I2=A[3]
XU22 ND2P $PINS O=n20 I1=n14 I2=B[20]
XU24 MAO222 $PINS O=n14 A1=carry[19] B1=B[19] C1=A[19]
XU25 MAO222 $PINS O=n15 A1=carry[19] B1=B[19] C1=A[19]
XU27 ND2P $PINS O=n16 I1=carry[18] I2=A[18]
XU28 ND2 $PINS O=n17 I1=carry[18] I2=B[18]
XU29 ND2 $PINS O=n18 I1=A[18] I2=B[18]
XU30 ND3P $PINS O=carry[19] I1=n17 I2=n16 I3=n18
XU31 ND2P $PINS O=n19 I1=n15 I2=A[20]
XU32 XOR2HS $PINS O=SUM[0] I1=B[0] I2=A[0]
XU3 XNR3 $PINS O=SUM[4] I1=A[4] I2=B[4] I3=n22
XU4 INV1S $PINS O=n22 I=FE_OCPN1213_carry_4
XU33 ND3P $PINS O=carry[4] I1=n10 I2=n11 I3=n12
.ENDS

.SUBCKT PE_Shift_Add_0 rst_n en clear calc_done stage_sel x_in[16] x_in[15]
+ x_in[14] x_in[13] x_in[12] x_in[11] x_in[10] x_in[9] x_in[8] x_in[7] x_in[6]
+ x_in[5] x_in[4] x_in[3] x_in[2] x_in[1] x_in[0] sign1[1] sign1[0] sign2[1]
+ sign2[0] sign3[1] sign3[0] shf1[3] shf1[2] shf1[1] shf1[0] shf2[3] shf2[2]
+ shf2[1] shf2[0] shf3[3] shf3[2] shf3[1] shf3[0] y_out[16] y_out[15] y_out[14]
+ y_out[13] y_out[12] y_out[11] y_out[10] y_out[9] y_out[8] y_out[7] y_out[6]
+ y_out[5] y_out[4] y_out[3] y_out[2] y_out[1] y_out[0] i_rst_n
+ FE_OFN43_i_rst_n FE_OFN42_i_rst_n FE_OFN38_i_rst_n FE_OFN24_i_rst_n
+ FE_OFN63_FE_DBTN9_n336 FE_OFN118_s31_1 FE_OFN119_s31_0 FE_OFN120_h31_3
+ FE_OFN121_h31_2 FE_OFN122_h31_1 FE_OFN123_h31_0 FE_OFN124_s32_1
+ FE_OFN125_s32_0 FE_OFN126_h32_3 FE_OFN127_h32_2 FE_OFN128_h32_1
+ FE_OFN129_h32_0 FE_OFN130_s33_1 FE_OFN131_s33_0 FE_OFN132_h33_3
+ FE_OFN133_h33_2 FE_OFN134_h33_1 FE_OFN135_h33_0 FE_OFN161_h32_1 FE_OFN172_n
+ FE_OFN170_n FE_OFN247_mac_in_imag_0 FE_OFN227_mac_in_imag_10 clk_clone3
+ clk_clone2 clk_clone1 clk
XFE_PHC1870_N246 DELC $PINS O=N246 I=FE_PHN1870_N246
XFE_PHC1867_N247 DELC $PINS O=FE_PHN1867_N247 I=N247
XFE_PHC1857_N248 DELC $PINS O=FE_PHN1857_N248 I=N248
XFE_PHC1827_N249 DELC $PINS O=N249 I=FE_PHN1827_N249
XFE_PHC1806_N205 DELB $PINS O=FE_PHN1806_N205 I=N205
XFE_PHC1693_pe_i3_14 DELC $PINS O=y_out[14] I=FE_PHN1693_pe_i3_14
XFE_PHC1680_pe_i3_11 DELC $PINS O=y_out[11] I=FE_PHN1680_pe_i3_11
XFE_PHC1661_pe_i3_15 DELC $PINS O=y_out[15] I=FE_PHN1661_pe_i3_15
XFE_PHC1597_pe_i3_10 DELC $PINS O=y_out[10] I=FE_PHN1597_pe_i3_10
XFE_PHC1577_acc_reg_25 DELC $PINS O=FE_PHN1577_acc_reg_25 I=acc_reg[25]
XFE_PHC1519_N236 DELC $PINS O=FE_PHN1519_N236 I=N236
XFE_PHC1495_N240 DELC $PINS O=FE_PHN1495_N240 I=N240
XFE_PHC1494_N235 DELC $PINS O=FE_PHN1494_N235 I=N235
XFE_PHC1485_N242 DELC $PINS O=FE_PHN1485_N242 I=N242
XFE_PHC1483_N238 DELC $PINS O=N238 I=FE_PHN1483_N238
XFE_PHC1478_N245 DELC $PINS O=FE_PHN1478_N245 I=N245
XFE_PHC1464_N239 DELC $PINS O=FE_PHN1464_N239 I=N239
XFE_PHC1454_N237 DELC $PINS O=N237 I=FE_PHN1454_N237
XFE_PHC1432_N241 DELC $PINS O=FE_PHN1432_N241 I=N241
XFE_PHC1425_N244 DELC $PINS O=N244 I=FE_PHN1425_N244
XFE_PHC1421_N243 DELC $PINS O=N243 I=FE_PHN1421_N243
XFE_PHC1393_pe_i3_2 DELC $PINS O=y_out[2] I=FE_PHN1393_pe_i3_2
XFE_PHC1392_pe_i3_3 DELC $PINS O=y_out[3] I=FE_PHN1392_pe_i3_3
XFE_PHC1391_pe_i3_5 DELC $PINS O=y_out[5] I=FE_PHN1391_pe_i3_5
XFE_PHC1390_pe_i3_9 DELC $PINS O=y_out[9] I=FE_PHN1390_pe_i3_9
XFE_PHC1389_pe_i3_8 DELC $PINS O=y_out[8] I=FE_PHN1389_pe_i3_8
XFE_PHC1388_pe_i3_1 DELC $PINS O=y_out[1] I=FE_PHN1388_pe_i3_1
XFE_PHC1387_pe_i3_4 DELC $PINS O=y_out[4] I=FE_PHN1387_pe_i3_4
XFE_PHC1386_pe_i3_6 DELC $PINS O=y_out[6] I=FE_PHN1386_pe_i3_6
XFE_PHC1384_pe_i3_7 DELC $PINS O=y_out[7] I=FE_PHN1384_pe_i3_7
XFE_PHC1280_N251 DELC $PINS O=N251 I=FE_PHN1280_N251
XFE_OFC13_FE_OFN116_h32_1 BUF1 $PINS O=FE_OFN12_FE_OFN116_h32_1
+ I=FE_OFN128_h32_1
XFE_RC_288_0 INV1S $PINS O=FE_RN_133_0 I=sll_16/ML_int[1][3]
XFE_RC_287_0 MOAI1 $PINS O=sll_16/ML_int[2][3] A1=FE_RN_133_0
+ A2=FE_OFN122_h31_1 B1=FE_OFN122_h31_1 B2=sll_16/ML_int[1][1]
XFE_RC_286_0 ND2S $PINS O=FE_RN_131_0 I1=term2_shifted[18] I2=FE_OFN368_s32_0
XFE_RC_285_0 ND2 $PINS O=FE_RN_132_0 I1=N87 I2=FE_RN_3
XFE_RC_284_0 ND2P $PINS O=N114 I1=FE_RN_132_0 I2=FE_RN_131_0
XFE_RC_155_0 ND2 $PINS O=FE_RN_75_0 I1=term3_shifted[6] I2=FE_OFN429_FE_RN_2
XFE_RC_154_0 ND2 $PINS O=FE_RN_76_0 I1=N130 I2=FE_OFN432_s33_0
XFE_RC_153_0 ND2 $PINS O=N157 I1=FE_RN_76_0 I2=FE_RN_75_0
XFE_RC_134_0 AO22 $PINS O=N51 A1=term1_shifted[10] A2=FE_OFN430_FE_DBTN21_s31_0
+ B1=N24 B2=sign1[0]
XFE_RC_81_0 ND2S $PINS O=FE_RN_46_0 I1=term1_shifted[20]
+ I2=FE_OFN431_FE_DBTN21_s31_0
XFE_RC_80_0 ND2 $PINS O=FE_RN_47_0 I1=N34 I2=FE_DBTN21_s31_0
XFE_RC_79_0 ND2 $PINS O=N61 I1=FE_RN_47_0 I2=FE_RN_46_0
XFE_RC_60_0 ND2S $PINS O=FE_RN_37_0 I1=term1_shifted[19]
+ I2=FE_OFN430_FE_DBTN21_s31_0
XFE_RC_59_0 ND2 $PINS O=FE_RN_38_0 I1=N33 I2=FE_DBTN21_s31_0
XFE_RC_58_0 ND2P $PINS O=N60 I1=FE_RN_38_0 I2=FE_RN_37_0
XFE_RC_33_0 ND2S $PINS O=FE_RN_18_0 I1=sll_17/ML_int[1][0] I2=FE_OFN128_h32_1
XFE_RC_32_0 OR2B1S $PINS O=FE_RN_19_0 I1=FE_OFN128_h32_1 B1=sll_17/ML_int[1][2]
XFE_RC_31_0 ND2 $PINS O=sll_17/ML_int[2][2] I1=FE_RN_19_0 I2=FE_RN_18_0
XFE_RC_19_0 ND2 $PINS O=FE_RN_12_0 I1=term1_shifted[21]
+ I2=FE_OFN431_FE_DBTN21_s31_0
XFE_RC_18_0 ND2 $PINS O=FE_RN_13_0 I1=N35 I2=FE_DBTN21_s31_0
XFE_RC_17_0 ND2 $PINS O=N62 I1=FE_RN_13_0 I2=FE_RN_12_0
XCTS_ccl_a_INV_CLK_G1_L10_53 INV3CK $PINS O=CTS_10 I=CTS_11
XCTS_ccl_a_INV_CLK_G1_L9_55 INV2CK $PINS O=CTS_11 I=CTS_12
XFE_OCPC1237_n56 BUF1S $PINS O=FE_OCPN1237_n56 I=n56
XFE_OCPC1177_n66 BUF1S $PINS O=FE_OCPN1177_n66 I=n66
XFE_OCPC1154_n2 BUF1S $PINS O=FE_OCPN1154_n2 I=n2
XFE_OCPC1049_sll_17_ML_int_2_2 BUF1S $PINS O=FE_OCPN1049_sll_17_ML_int_2_2
+ I=sll_17/ML_int[2][2]
XFE_OFC885_FE_OFN123_h33_0 BUF1 $PINS O=FE_OFN489_FE_OFN123_h33_0 I=shf3[0]
XFE_RC_4027_0 AO22 $PINS O=N53 A1=term1_shifted[12]
+ A2=FE_OFN430_FE_DBTN21_s31_0 B1=N26 B2=sign1[0]
XFE_RC_4026_0 AO22 $PINS O=N119 A1=term2_shifted[23] A2=FE_OFN368_s32_0 B1=N92
+ B2=FE_RN_3
XFE_RC_4012_0 AO22 $PINS O=N63 A1=term1_shifted[22]
+ A2=FE_OFN431_FE_DBTN21_s31_0 B1=N36 B2=FE_DBTN21_s31_0
XFE_RC_3853_0 ND2 $PINS O=FE_RN_2527_0 I1=sll_17/ML_int[1][1]
+ I2=FE_OFN128_h32_1
XFE_RC_3852_0 INV2 $PINS O=FE_RN_2528_0 I=FE_OFN128_h32_1
XFE_RC_3851_0 ND2 $PINS O=FE_RN_2529_0 I1=sll_17/ML_int[1][3] I2=FE_RN_2528_0
XFE_RC_3850_0 ND2 $PINS O=sll_17/ML_int[2][3] I1=FE_RN_2529_0 I2=FE_RN_2527_0
XFE_RC_3833_0 ND2 $PINS O=FE_RN_2512_0 I1=term2_shifted[6] I2=FE_OFN365_s32_0
XFE_RC_3832_0 ND2 $PINS O=FE_RN_2513_0 I1=N75 I2=FE_OFN440_s32_0
XFE_RC_3831_0 ND2 $PINS O=N102 I1=FE_RN_2513_0 I2=FE_RN_2512_0
XFE_RC_3828_0 INV1S $PINS O=FE_RN_2510_0 I=term3_in[4]
XFE_RC_3827_0 MOAI1 $PINS O=sll_18/ML_int[1][4] A1=FE_RN_2510_0
+ A2=FE_OFN489_FE_OFN123_h33_0 B1=term3_in[3] B2=shf3[0]
XFE_RC_3809_0 ND2S $PINS O=FE_RN_2493_0 I1=n70 I2=FE_RN_1
XFE_RC_3808_0 INV1S $PINS O=FE_RN_2494_0 I=FE_RN_1
XFE_RC_3807_0 ND2S $PINS O=FE_RN_2495_0 I1=sll_17/ML_int[2][4] I2=FE_RN_2494_0
XFE_RC_3806_0 ND2 $PINS O=sll_17/ML_int[3][4] I1=FE_RN_2495_0 I2=FE_RN_2493_0
XFE_RC_3792_0 INV1S $PINS O=FE_RN_2485_0 I=FE_OFN133_h33_2
XFE_RC_3791_0 INV2CK $PINS O=n5 I=FE_RN_2486_0
XFE_RC_3790_0 AOI22S $PINS O=FE_RN_2486_0 A1=n17 A2=FE_OFN133_h33_2
+ B1=sll_18/ML_int[2][4] B2=FE_RN_2485_0
XFE_RC_3776_0 INV1S $PINS O=FE_RN_2477_0 I=FE_OFN429_FE_RN_2
XFE_RC_3775_0 INV1S $PINS O=FE_RN_2478_0 I=term3_shifted[9]
XFE_RC_3774_0 ND2 $PINS O=FE_RN_2479_0 I1=N133 I2=FE_OFN432_s33_0
XFE_RC_3773_0 OAI12HS $PINS O=N160 A1=FE_RN_2479_0 B1=FE_RN_2478_0
+ B2=FE_RN_2477_0
XFE_RC_3752_0 ND2 $PINS O=FE_RN_2464_0 I1=term2_shifted[1] I2=sign2[0]
XFE_RC_3751_0 ND2 $PINS O=FE_RN_2465_0 I1=N70 I2=FE_OFN440_s32_0
XFE_RC_3750_0 ND2P $PINS O=N97 I1=FE_RN_2465_0 I2=FE_RN_2464_0
XFE_RC_3749_0 ND2S $PINS O=FE_RN_2462_0 I1=term1_in[0] I2=shf1[0]
XFE_RC_3748_0 ND2S $PINS O=FE_RN_2463_0 I1=term1_in[1] I2=FE_RN_2393_0
XFE_RC_3747_0 ND2 $PINS O=sll_16/ML_int[1][1] I1=FE_RN_2463_0 I2=FE_RN_2462_0
XFE_RC_3743_0 AO22 $PINS O=N43 A1=term1_shifted[2] A2=FE_OFN170_n B1=N16
+ B2=sign1[0]
XFE_RC_3718_0 ND2 $PINS O=FE_RN_2440_0 I1=term2_in[0] I2=FE_OFN129_h32_0
XFE_RC_3717_0 OR2B1S $PINS O=FE_RN_2441_0 I1=FE_OFN129_h32_0 B1=term2_in[1]
XFE_RC_3716_0 ND2P $PINS O=sll_17/ML_int[1][1] I1=FE_RN_2441_0 I2=FE_RN_2440_0
XFE_RC_3710_0 ND2 $PINS O=FE_RN_2436_0 I1=term3_shifted[2] I2=sign3[0]
XFE_RC_3709_0 ND2 $PINS O=FE_RN_2437_0 I1=N126 I2=FE_OFN432_s33_0
XFE_RC_3708_0 ND2P $PINS O=N153 I1=FE_RN_2437_0 I2=FE_RN_2436_0
XFE_RC_3653_0 INV2 $PINS O=FE_RN_2393_0 I=shf1[0]
XFE_RC_3614_0 ND2 $PINS O=FE_RN_2360_0 I1=term3_in[0] I2=shf3[0]
XFE_RC_3613_0 INV1S $PINS O=FE_RN_2361_0 I=shf3[0]
XFE_RC_3612_0 ND2S $PINS O=FE_RN_2362_0 I1=term3_in[1] I2=FE_RN_2361_0
XFE_RC_3611_0 ND2 $PINS O=sll_18/ML_int[1][1] I1=FE_RN_2362_0 I2=FE_RN_2360_0
XFE_RC_3580_0 ND2S $PINS O=FE_RN_2336_0 I1=n60 I2=FE_OFN121_h31_2
XFE_RC_3579_0 INV1S $PINS O=FE_RN_2337_0 I=FE_OFN121_h31_2
XFE_RC_3578_0 ND2 $PINS O=FE_RN_2338_0 I1=sll_16/ML_int[2][4] I2=FE_RN_2337_0
XFE_RC_3577_0 ND2P $PINS O=n4 I1=FE_RN_2338_0 I2=FE_RN_2336_0
XFE_RC_3477_0 INV2 $PINS O=FE_RN_2270_0 I=sll_16/ML_int[1][2]
XFE_RC_3476_0 MOAI1H $PINS O=sll_16/ML_int[2][2] A1=FE_RN_2270_0
+ A2=FE_OFN122_h31_1 B1=sll_16/ML_int[1][0] B2=FE_OFN122_h31_1
XFE_RC_14_0 OA12 $PINS O=N41 A1=term1_shifted[0] B1=sign1[0] B2=FE_OFN170_n
XFE_RC_12_0 OA12 $PINS O=N96 A1=N69 B1=FE_OFN440_s32_0 B2=sign2[0]
XFE_RC_6_0 OA12 $PINS O=N151 A1=N124 B1=FE_OFN432_s33_0 B2=sign3[0]
XFE_OFC862_h31_0 BUF1 $PINS O=FE_RN_11 I=shf1[0]
XFE_OFC851_h31_1 BUF1 $PINS O=FE_RN_10 I=FE_OFN122_h31_1
XFE_OFC846_n106 BUF1 $PINS O=FE_OFN456_n106 I=n106
XFE_OFC827_h33_0 INV1S $PINS O=n22 I=shf3[0]
XFE_OFC796_s33_1 INV1S $PINS O=n1 I=sign3[1]
XFE_OFC791_s32_0 INV1S $PINS O=FE_OFN440_s32_0 I=sign2[0]
XFE_OFC790_s32_0 BUF1 $PINS O=FE_OFN365_s32_0 I=sign2[0]
XFE_OFC786_h33_3 INV1S $PINS O=n24 I=shf3[3]
XFE_OFC775_s31_0 BUF1 $PINS O=FE_DBTN21_s31_0 I=sign1[0]
XFE_OFC768_s33_0 INV2 $PINS O=FE_OFN432_s33_0 I=sign3[0]
XFE_OFC767_s33_0 INV1S $PINS O=FE_RN_2 I=sign3[0]
XFE_OFC765_FE_DBTN21_s31_0 BUF1 $PINS O=FE_OFN431_FE_DBTN21_s31_0
+ I=FE_OFN430_FE_DBTN21_s31_0
XFE_OFC764_FE_DBTN21_s31_0 BUF1 $PINS O=FE_OFN430_FE_DBTN21_s31_0 I=FE_OFN170_n
XFE_OFC763_FE_RN_2 BUF1 $PINS O=FE_OFN429_FE_RN_2 I=sign3[0]
XFE_OFC711_h32_1 INV1S $PINS O=n32 I=FE_OFN12_FE_OFN116_h32_1
XFE_OFC705_s31_1 BUF1 $PINS O=FE_RN_9 I=FE_OFN118_s31_1
XFE_OFC685_s32_1 BUF1 $PINS O=FE_RN_8 I=FE_OFN124_s32_1
XFE_OFC623_h32_0 INV1S $PINS O=n31 I=FE_OFN129_h32_0
XFE_OFC622_h32_0 BUF1 $PINS O=FE_RN_7 I=FE_OFN129_h32_0
XFE_OFC617_h31_3 INV1S $PINS O=FE_OFN371_h31_3 I=shf1[3]
XFE_OFC615_h31_3 BUF1 $PINS O=n45 I=FE_OFN120_h31_3
XFE_OFC603_s32_0 INV1S $PINS O=FE_OFN368_s32_0 I=FE_RN_3
XFE_OFC597_s32_0 INV1S $PINS O=FE_RN_3 I=FE_OFN365_s32_0
XFE_OFC589_h32_3 INV1S $PINS O=FE_OFN362_h32_3 I=shf2[3]
XFE_OFC587_h32_3 INV1S $PINS O=n36 I=shf2[3]
XFE_OFC508_h31_0 INV1S $PINS O=n41 I=shf1[0]
XFE_OFC422_h31_2 INV1S $PINS O=FE_RN_6 I=FE_OFN121_h31_2
XFE_OFC420_h31_2 BUF1 $PINS O=n44 I=FE_OFN121_h31_2
XFE_OFC396_h33_2 BUF1 $PINS O=FE_RN_5 I=FE_OFN133_h33_2
XFE_OFC374_pe_clear_d1 INV1S $PINS O=n106 I=clear
XFE_OFC360_h32_1 INV1S $PINS O=FE_RN_4 I=n32
XFE_OFC285_h32_2 INV1S $PINS O=FE_RN_1 I=FE_OFN127_h32_2
XU110 AO22 $PINS O=base_val[13] A1=acc_reg[13] A2=FE_OFN456_n106 B1=clear
+ B2=stage_sel
XU169 AO22 $PINS O=N122 A1=N95 A2=FE_RN_3 B1=term2_shifted[26]
+ B2=FE_OFN368_s32_0
XU170 AO22 $PINS O=N121 A1=N94 A2=FE_RN_3 B1=term2_shifted[25]
+ B2=FE_OFN368_s32_0
XU171 AO22 $PINS O=N120 A1=N93 A2=FE_RN_3 B1=term2_shifted[24]
+ B2=FE_OFN368_s32_0
XU173 AO22 $PINS O=N118 A1=N91 A2=FE_RN_3 B1=term2_shifted[22]
+ B2=FE_OFN368_s32_0
XU174 AO22 $PINS O=N117 A1=N90 A2=FE_RN_3 B1=term2_shifted[21]
+ B2=FE_OFN368_s32_0
XU176 AO22 $PINS O=N115 A1=N88 A2=FE_RN_3 B1=term2_shifted[19]
+ B2=FE_OFN368_s32_0
XU178 AO22 $PINS O=N113 A1=N86 A2=FE_RN_3 B1=term2_shifted[17]
+ B2=FE_OFN368_s32_0
XU179 AO22 $PINS O=N112 A1=N85 A2=FE_RN_3 B1=term2_shifted[16]
+ B2=FE_OFN368_s32_0
XU180 AO22 $PINS O=N111 A1=N84 A2=FE_RN_3 B1=term2_shifted[15]
+ B2=FE_OFN365_s32_0
XU183 AO22 $PINS O=N108 A1=N81 A2=FE_OFN440_s32_0 B1=term2_shifted[12]
+ B2=FE_OFN365_s32_0
XU184 AO22 $PINS O=N107 A1=N80 A2=FE_OFN440_s32_0 B1=term2_shifted[11]
+ B2=FE_OFN365_s32_0
XU185 AO22 $PINS O=N106 A1=N79 A2=FE_OFN440_s32_0 B1=term2_shifted[10]
+ B2=FE_OFN365_s32_0
XU187 AO22 $PINS O=N104 A1=N77 A2=FE_OFN440_s32_0 B1=term2_shifted[8]
+ B2=FE_OFN365_s32_0
XU188 AO22 $PINS O=N103 A1=N76 A2=FE_OFN440_s32_0 B1=term2_shifted[7]
+ B2=FE_OFN365_s32_0
XU190 AO22 $PINS O=N101 A1=N74 A2=FE_OFN440_s32_0 B1=term2_shifted[5]
+ B2=sign2[0]
XU191 AO22 $PINS O=N100 A1=N73 A2=FE_OFN440_s32_0 B1=term2_shifted[4]
+ B2=sign2[0]
Xsll_18/M1_0_2 MUX2 $PINS O=sll_18/ML_int[1][2] S=shf3[0] A=term3_in[2]
+ B=term3_in[1]
Xsll_18/M1_0_6 MUX2 $PINS O=sll_18/ML_int[1][6] S=FE_OFN489_FE_OFN123_h33_0
+ A=term3_in[6] B=term3_in[5]
Xsll_18/M1_0_7 MUX2 $PINS O=sll_18/ML_int[1][7] S=shf3[0] A=term3_in[7]
+ B=term3_in[6]
Xsll_18/M1_1_2 MUX2 $PINS O=sll_18/ML_int[2][2] S=shf3[1] A=sll_18/ML_int[1][2]
+ B=sll_18/ML_int[1][0]
Xsll_18/M1_1_3 MUX2 $PINS O=sll_18/ML_int[2][3] S=shf3[1] A=sll_18/ML_int[1][3]
+ B=sll_18/ML_int[1][1]
Xsll_18/M1_1_4 MUX2 $PINS O=sll_18/ML_int[2][4] S=shf3[1] A=sll_18/ML_int[1][4]
+ B=sll_18/ML_int[1][2]
Xsll_18/M1_1_5 MUX2 $PINS O=sll_18/ML_int[2][5] S=shf3[1] A=sll_18/ML_int[1][5]
+ B=sll_18/ML_int[1][3]
Xsll_18/M1_1_6 MUX2 $PINS O=sll_18/ML_int[2][6] S=shf3[1] A=sll_18/ML_int[1][6]
+ B=sll_18/ML_int[1][4]
Xsll_18/M1_1_7 MUX2 $PINS O=sll_18/ML_int[2][7] S=shf3[1] A=sll_18/ML_int[1][7]
+ B=sll_18/ML_int[1][5]
Xsll_18/M1_1_8 MUX2 $PINS O=sll_18/ML_int[2][8] S=shf3[1] A=sll_18/ML_int[1][8]
+ B=sll_18/ML_int[1][6]
Xsll_18/M1_2_5 MUX2 $PINS O=sll_18/ML_int[3][5] S=FE_OFN133_h33_2
+ A=sll_18/ML_int[2][5] B=n80
Xsll_18/M1_2_6 MUX2 $PINS O=sll_18/ML_int[3][6] S=FE_OFN133_h33_2
+ A=sll_18/ML_int[2][6] B=sll_18/ML_int[2][2]
Xsll_18/M1_2_7 MUX2 $PINS O=sll_18/ML_int[3][7] S=FE_OFN133_h33_2
+ A=sll_18/ML_int[2][7] B=sll_18/ML_int[2][3]
Xsll_18/M1_2_8 MUX2 $PINS O=sll_18/ML_int[3][8] S=FE_OFN133_h33_2
+ A=sll_18/ML_int[2][8] B=sll_18/ML_int[2][4]
Xsll_18/M1_2_9 MUX2 $PINS O=sll_18/ML_int[3][9] S=FE_RN_5 A=sll_18/ML_int[2][9]
+ B=sll_18/ML_int[2][5]
Xsll_18/M1_2_10 MUX2 $PINS O=sll_18/ML_int[3][10] S=FE_RN_5
+ A=sll_18/ML_int[2][10] B=sll_18/ML_int[2][6]
Xsll_18/M1_3_8 MUX2 $PINS O=term3_shifted[8] S=shf3[3] A=sll_18/ML_int[3][8]
+ B=sll_18/ML_int[3][0]
Xsll_18/M1_3_9 MUX2 $PINS O=term3_shifted[9] S=shf3[3] A=sll_18/ML_int[3][9]
+ B=sll_18/ML_int[3][1]
Xsll_18/M1_3_10 MUX2 $PINS O=term3_shifted[10] S=shf3[3] A=sll_18/ML_int[3][10]
+ B=sll_18/ML_int[3][2]
Xsll_18/M1_3_11 MUX2 $PINS O=term3_shifted[11] S=shf3[3] A=sll_18/ML_int[3][11]
+ B=sll_18/ML_int[3][3]
Xsll_18/M1_3_13 MUX2 $PINS O=term3_shifted[13] S=shf3[3] A=sll_18/ML_int[3][13]
+ B=sll_18/ML_int[3][5]
Xsll_18/M1_3_14 MUX2 $PINS O=term3_shifted[14] S=shf3[3] A=sll_18/ML_int[3][14]
+ B=sll_18/ML_int[3][6]
Xsll_18/M1_3_21 MUX2 $PINS O=term3_shifted[21] S=shf3[3] A=sll_18/ML_int[3][21]
+ B=sll_18/ML_int[3][13]
Xsll_18/M1_3_22 MUX2 $PINS O=term3_shifted[22] S=shf3[3] A=sll_18/ML_int[3][22]
+ B=sll_18/ML_int[3][14]
Xsll_18/M1_3_23 MUX2 $PINS O=term3_shifted[23] S=shf3[3] A=term3_in[26]
+ B=sll_18/ML_int[3][15]
Xsll_17/M1_0_3 MUX2 $PINS O=sll_17/ML_int[1][3] S=FE_OFN129_h32_0 A=term2_in[3]
+ B=term2_in[2]
Xsll_17/M1_0_4 MUX2 $PINS O=sll_17/ML_int[1][4] S=FE_OFN129_h32_0 A=term2_in[4]
+ B=term2_in[3]
Xsll_17/M1_0_5 MUX2 $PINS O=sll_17/ML_int[1][5] S=FE_OFN129_h32_0 A=term2_in[5]
+ B=term2_in[4]
Xsll_17/M1_0_6 MUX2 $PINS O=sll_17/ML_int[1][6] S=FE_OFN129_h32_0 A=term2_in[6]
+ B=term2_in[5]
Xsll_17/M1_0_7 MUX2 $PINS O=sll_17/ML_int[1][7] S=FE_OFN129_h32_0 A=term2_in[7]
+ B=term2_in[6]
Xsll_17/M1_1_4 MUX2 $PINS O=sll_17/ML_int[2][4] S=FE_OFN128_h32_1
+ A=sll_17/ML_int[1][4] B=sll_17/ML_int[1][2]
Xsll_17/M1_1_5 MUX2 $PINS O=sll_17/ML_int[2][5] S=FE_OFN128_h32_1
+ A=sll_17/ML_int[1][5] B=sll_17/ML_int[1][3]
Xsll_17/M1_1_6 MUX2 $PINS O=sll_17/ML_int[2][6] S=FE_OFN12_FE_OFN116_h32_1
+ A=sll_17/ML_int[1][6] B=sll_17/ML_int[1][4]
Xsll_17/M1_1_7 MUX2 $PINS O=sll_17/ML_int[2][7] S=FE_OFN128_h32_1
+ A=sll_17/ML_int[1][7] B=sll_17/ML_int[1][5]
Xsll_17/M1_1_8 MUX2 $PINS O=sll_17/ML_int[2][8] S=FE_OFN12_FE_OFN116_h32_1
+ A=sll_17/ML_int[1][8] B=sll_17/ML_int[1][6]
Xsll_17/M1_2_5 MUX2 $PINS O=sll_17/ML_int[3][5] S=FE_RN_1 A=sll_17/ML_int[2][5]
+ B=n10
Xsll_17/M1_2_6 MUX2 $PINS O=sll_17/ML_int[3][6] S=FE_RN_1 A=sll_17/ML_int[2][6]
+ B=FE_OCPN1049_sll_17_ML_int_2_2
Xsll_17/M1_2_8 MUX2 $PINS O=sll_17/ML_int[3][8] S=FE_RN_1 A=sll_17/ML_int[2][8]
+ B=sll_17/ML_int[2][4]
Xsll_17/M1_2_9 MUX2 $PINS O=sll_17/ML_int[3][9] S=FE_RN_1 A=sll_17/ML_int[2][9]
+ B=sll_17/ML_int[2][5]
Xsll_17/M1_2_10 MUX2 $PINS O=sll_17/ML_int[3][10] S=FE_RN_1
+ A=sll_17/ML_int[2][10] B=sll_17/ML_int[2][6]
Xsll_17/M1_3_8 MUX2 $PINS O=term2_shifted[8] S=FE_OFN362_h32_3
+ A=sll_17/ML_int[3][8] B=sll_17/ML_int[3][0]
Xsll_17/M1_3_9 MUX2 $PINS O=term2_shifted[9] S=FE_OFN362_h32_3
+ A=sll_17/ML_int[3][9] B=sll_17/ML_int[3][1]
Xsll_17/M1_3_10 MUX2 $PINS O=term2_shifted[10] S=FE_OFN362_h32_3
+ A=sll_17/ML_int[3][10] B=sll_17/ML_int[3][2]
Xsll_17/M1_3_11 MUX2 $PINS O=term2_shifted[11] S=FE_OFN362_h32_3
+ A=sll_17/ML_int[3][11] B=sll_17/ML_int[3][3]
Xsll_17/M1_3_12 MUX2 $PINS O=term2_shifted[12] S=FE_OFN362_h32_3
+ A=sll_17/ML_int[3][12] B=sll_17/ML_int[3][4]
Xsll_17/M1_3_13 MUX2 $PINS O=term2_shifted[13] S=FE_OFN362_h32_3
+ A=sll_17/ML_int[3][13] B=sll_17/ML_int[3][5]
Xsll_17/M1_3_14 MUX2 $PINS O=term2_shifted[14] S=FE_OFN362_h32_3
+ A=sll_17/ML_int[3][14] B=sll_17/ML_int[3][6]
Xsll_17/M1_3_21 MUX2 $PINS O=term2_shifted[21] S=n36 A=sll_17/ML_int[3][21]
+ B=sll_17/ML_int[3][13]
Xsll_17/M1_3_22 MUX2 $PINS O=term2_shifted[22] S=n36 A=sll_17/ML_int[3][22]
+ B=sll_17/ML_int[3][14]
Xsll_17/M1_3_23 MUX2 $PINS O=term2_shifted[23] S=n36 A=term2_in[26]
+ B=sll_17/ML_int[3][15]
Xsll_16/M1_0_2 MUX2 $PINS O=sll_16/ML_int[1][2] S=shf1[0] A=term1_in[2]
+ B=term1_in[1]
Xsll_16/M1_0_4 MUX2 $PINS O=sll_16/ML_int[1][4] S=shf1[0] A=term1_in[4]
+ B=term1_in[3]
Xsll_16/M1_0_6 MUX2 $PINS O=sll_16/ML_int[1][6] S=shf1[0] A=term1_in[6]
+ B=term1_in[5]
Xsll_16/M1_0_7 MUX2 $PINS O=sll_16/ML_int[1][7] S=shf1[0] A=term1_in[7]
+ B=term1_in[6]
Xsll_16/M1_0_8 MUX2 $PINS O=sll_16/ML_int[1][8] S=shf1[0] A=term1_in[8]
+ B=term1_in[7]
Xsll_16/M1_1_5 MUX2 $PINS O=sll_16/ML_int[2][5] S=FE_OFN122_h31_1
+ A=sll_16/ML_int[1][5] B=sll_16/ML_int[1][3]
Xsll_16/M1_1_6 MUX2 $PINS O=sll_16/ML_int[2][6] S=FE_OFN122_h31_1
+ A=sll_16/ML_int[1][6] B=sll_16/ML_int[1][4]
Xsll_16/M1_1_7 MUX2 $PINS O=sll_16/ML_int[2][7] S=FE_OFN122_h31_1
+ A=sll_16/ML_int[1][7] B=sll_16/ML_int[1][5]
Xsll_16/M1_1_8 MUX2 $PINS O=sll_16/ML_int[2][8] S=FE_OFN122_h31_1
+ A=sll_16/ML_int[1][8] B=sll_16/ML_int[1][6]
Xsll_16/M1_1_9 MUX2 $PINS O=sll_16/ML_int[2][9] S=FE_RN_10
+ A=sll_16/ML_int[1][9] B=sll_16/ML_int[1][7]
Xsll_16/M1_2_5 MUX2 $PINS O=sll_16/ML_int[3][5] S=FE_OFN121_h31_2
+ A=sll_16/ML_int[2][5] B=n61
Xsll_16/M1_2_6 MUX2 $PINS O=sll_16/ML_int[3][6] S=FE_OFN121_h31_2
+ A=sll_16/ML_int[2][6] B=sll_16/ML_int[2][2]
Xsll_16/M1_2_7 MUX2 $PINS O=sll_16/ML_int[3][7] S=FE_OFN121_h31_2
+ A=sll_16/ML_int[2][7] B=sll_16/ML_int[2][3]
Xsll_16/M1_2_9 MUX2 $PINS O=sll_16/ML_int[3][9] S=FE_OFN121_h31_2
+ A=sll_16/ML_int[2][9] B=sll_16/ML_int[2][5]
Xsll_16/M1_2_10 MUX2 $PINS O=sll_16/ML_int[3][10] S=FE_OFN121_h31_2
+ A=sll_16/ML_int[2][10] B=sll_16/ML_int[2][6]
Xsll_16/M1_2_11 MUX2 $PINS O=sll_16/ML_int[3][11] S=n44 A=sll_16/ML_int[2][11]
+ B=sll_16/ML_int[2][7]
Xsll_16/M1_3_8 MUX2 $PINS O=term1_shifted[8] S=FE_OFN371_h31_3
+ A=sll_16/ML_int[3][8] B=sll_16/ML_int[3][0]
Xsll_16/M1_3_9 MUX2 $PINS O=term1_shifted[9] S=FE_OFN371_h31_3
+ A=sll_16/ML_int[3][9] B=sll_16/ML_int[3][1]
Xsll_16/M1_3_10 MUX2 $PINS O=term1_shifted[10] S=FE_OFN371_h31_3
+ A=sll_16/ML_int[3][10] B=sll_16/ML_int[3][2]
Xsll_16/M1_3_11 MUX2 $PINS O=term1_shifted[11] S=FE_OFN371_h31_3
+ A=sll_16/ML_int[3][11] B=sll_16/ML_int[3][3]
Xsll_16/M1_3_13 MUX2 $PINS O=term1_shifted[13] S=FE_OFN371_h31_3
+ A=sll_16/ML_int[3][13] B=sll_16/ML_int[3][5]
Xsll_16/M1_3_14 MUX2 $PINS O=term1_shifted[14] S=n45 A=sll_16/ML_int[3][14]
+ B=sll_16/ML_int[3][6]
Xsll_16/M1_3_15 MUX2 $PINS O=term1_shifted[15] S=n45 A=sll_16/ML_int[3][15]
+ B=sll_16/ML_int[3][7]
Xsll_16/M1_3_22 MUX2 $PINS O=term1_shifted[22] S=n45 A=sll_16/ML_int[3][22]
+ B=sll_16/ML_int[3][14]
Xsll_16/M1_3_23 MUX2 $PINS O=term1_shifted[23] S=n45 A=term1_in[26]
+ B=sll_16/ML_int[3][15]
Xy_out_reg[9] QDFFRBN $PINS Q=FE_PHN1390_pe_i3_9 D=N244 CK=CTS_10
+ RB=FE_OFN42_i_rst_n
Xy_out_reg[8] QDFFRBN $PINS Q=FE_PHN1389_pe_i3_8 D=N243 CK=CTS_10
+ RB=FE_OFN42_i_rst_n
Xy_out_reg[7] QDFFRBN $PINS Q=FE_PHN1384_pe_i3_7 D=FE_PHN1485_N242 CK=CTS_10
+ RB=FE_OFN42_i_rst_n
Xy_out_reg[6] QDFFRBN $PINS Q=FE_PHN1386_pe_i3_6 D=FE_PHN1432_N241 CK=CTS_10
+ RB=FE_OFN42_i_rst_n
Xy_out_reg[5] QDFFRBN $PINS Q=FE_PHN1391_pe_i3_5 D=FE_PHN1495_N240 CK=CTS_10
+ RB=FE_OFN42_i_rst_n
Xy_out_reg[4] QDFFRBN $PINS Q=FE_PHN1387_pe_i3_4 D=FE_PHN1464_N239 CK=CTS_10
+ RB=FE_OFN42_i_rst_n
Xy_out_reg[3] QDFFRBN $PINS Q=FE_PHN1392_pe_i3_3 D=N238 CK=CTS_10
+ RB=FE_OFN42_i_rst_n
Xy_out_reg[2] QDFFRBN $PINS Q=FE_PHN1393_pe_i3_2 D=N237 CK=CTS_10
+ RB=FE_OFN42_i_rst_n
Xy_out_reg[1] QDFFRBN $PINS Q=FE_PHN1388_pe_i3_1 D=FE_PHN1519_N236 CK=CTS_10
+ RB=FE_OFN38_i_rst_n
Xy_out_reg[0] QDFFRBN $PINS Q=y_out[0] D=FE_PHN1494_N235 CK=CTS_10
+ RB=FE_OFN42_i_rst_n
Xy_out_reg[16] QDFFRBN $PINS Q=y_out[16] D=N251 CK=CTS_10 RB=FE_OFN42_i_rst_n
Xy_out_reg[10] QDFFRBN $PINS Q=FE_PHN1597_pe_i3_10 D=FE_PHN1478_N245 CK=CTS_10
+ RB=FE_OFN42_i_rst_n
Xy_out_reg[11] QDFFRBN $PINS Q=FE_PHN1680_pe_i3_11 D=N246 CK=CTS_10
+ RB=FE_OFN42_i_rst_n
Xy_out_reg[12] QDFFRBN $PINS Q=y_out[12] D=FE_PHN1867_N247 CK=CTS_10
+ RB=FE_OFN42_i_rst_n
Xy_out_reg[14] QDFFRBN $PINS Q=FE_PHN1693_pe_i3_14 D=N249 CK=CTS_10
+ RB=FE_OFN42_i_rst_n
Xy_out_reg[15] QDFFRBN $PINS Q=FE_PHN1661_pe_i3_15 D=N250 CK=CTS_10
+ RB=FE_OFN42_i_rst_n
Xy_out_reg[13] QDFFRBN $PINS Q=y_out[13] D=FE_PHN1857_N248 CK=CTS_10
+ RB=FE_OFN42_i_rst_n
Xacc_reg_reg[25] QDFFRBN $PINS Q=acc_reg[25] D=next_acc[25] CK=clk_clone3
+ RB=FE_OFN42_i_rst_n
Xacc_reg_reg[24] QDFFRBN $PINS Q=acc_reg[24] D=next_acc[24] CK=clk_clone3
+ RB=FE_OFN42_i_rst_n
Xacc_reg_reg[23] QDFFRBN $PINS Q=acc_reg[23] D=next_acc[23] CK=clk_clone3
+ RB=FE_OFN42_i_rst_n
Xacc_reg_reg[22] QDFFRBN $PINS Q=acc_reg[22] D=next_acc[22] CK=clk_clone3
+ RB=FE_OFN42_i_rst_n
Xacc_reg_reg[21] QDFFRBN $PINS Q=acc_reg[21] D=next_acc[21] CK=clk_clone3
+ RB=FE_OFN42_i_rst_n
Xacc_reg_reg[20] QDFFRBN $PINS Q=acc_reg[20] D=next_acc[20] CK=clk_clone3
+ RB=FE_OFN42_i_rst_n
Xacc_reg_reg[19] QDFFRBN $PINS Q=acc_reg[19] D=next_acc[19] CK=clk_clone3
+ RB=FE_OFN42_i_rst_n
Xacc_reg_reg[18] QDFFRBN $PINS Q=acc_reg[18] D=next_acc[18] CK=clk_clone3
+ RB=FE_OFN42_i_rst_n
Xacc_reg_reg[17] QDFFRBN $PINS Q=acc_reg[17] D=next_acc[17] CK=clk_clone3
+ RB=i_rst_n
Xacc_reg_reg[16] QDFFRBN $PINS Q=acc_reg[16] D=next_acc[16] CK=clk_clone3
+ RB=FE_OFN42_i_rst_n
Xacc_reg_reg[15] QDFFRBN $PINS Q=acc_reg[15] D=next_acc[15] CK=clk_clone3
+ RB=i_rst_n
Xacc_reg_reg[14] QDFFRBN $PINS Q=acc_reg[14] D=next_acc[14] CK=clk_clone3
+ RB=i_rst_n
Xacc_reg_reg[13] QDFFRBN $PINS Q=acc_reg[13] D=next_acc[13] CK=clk_clone3
+ RB=i_rst_n
Xacc_reg_reg[12] QDFFRBN $PINS Q=acc_reg[12] D=next_acc[12] CK=clk_clone3
+ RB=i_rst_n
Xacc_reg_reg[11] QDFFRBN $PINS Q=acc_reg[11] D=next_acc[11] CK=clk_clone3
+ RB=i_rst_n
Xacc_reg_reg[10] QDFFRBN $PINS Q=acc_reg[10] D=next_acc[10] CK=clk_clone3
+ RB=i_rst_n
Xacc_reg_reg[9] QDFFRBN $PINS Q=acc_reg[9] D=next_acc[9] CK=clk_clone2
+ RB=i_rst_n
Xacc_reg_reg[8] QDFFRBN $PINS Q=acc_reg[8] D=next_acc[8] CK=clk_clone2
+ RB=i_rst_n
Xacc_reg_reg[7] QDFFRBN $PINS Q=acc_reg[7] D=next_acc[7] CK=clk_clone2
+ RB=i_rst_n
Xacc_reg_reg[6] QDFFRBN $PINS Q=acc_reg[6] D=next_acc[6] CK=clk_clone2
+ RB=i_rst_n
Xacc_reg_reg[5] QDFFRBN $PINS Q=acc_reg[5] D=next_acc[5] CK=clk_clone2
+ RB=FE_OFN43_i_rst_n
Xacc_reg_reg[4] QDFFRBN $PINS Q=acc_reg[4] D=next_acc[4] CK=clk_clone2
+ RB=FE_OFN43_i_rst_n
Xacc_reg_reg[3] QDFFRBN $PINS Q=acc_reg[3] D=next_acc[3] CK=clk_clone2
+ RB=FE_OFN43_i_rst_n
Xacc_reg_reg[2] QDFFRBN $PINS Q=acc_reg[2] D=next_acc[2] CK=clk_clone2
+ RB=FE_OFN43_i_rst_n
Xacc_reg_reg[1] QDFFRBN $PINS Q=acc_reg[1] D=next_acc[1] CK=clk_clone1
+ RB=FE_OFN24_i_rst_n
Xacc_reg_reg[0] QDFFRBS $PINS Q=acc_reg[0] D=next_acc[0] CK=clk_clone1
+ RB=FE_OFN24_i_rst_n
Xacc_reg_reg[26] QDFFRBS $PINS Q=FE_PHN1280_N251 D=next_acc[26] CK=clk_clone3
+ RB=FE_OFN42_i_rst_n
XU3 AN2B1 $PINS O=term3_in[0] I1=n1 B1=FE_OFN247_mac_in_imag_0
XU11 NR2P $PINS O=term2_shifted[0] I1=n67 I2=n66
XU15 AO22 $PINS O=N154 A1=N127 A2=FE_OFN432_s33_0 B1=term3_shifted[3]
+ B2=sign3[0]
XU17 AO22S $PINS O=N177 A1=FE_RN_2 A2=N150 B1=term3_shifted[26]
+ B2=FE_OFN429_FE_RN_2
XU18 AO22 $PINS O=N158 A1=N131 A2=FE_OFN432_s33_0 B1=term3_shifted[7]
+ B2=FE_OFN429_FE_RN_2
XU20 AO22S $PINS O=N156 A1=N129 A2=FE_OFN432_s33_0 B1=term3_shifted[5]
+ B2=sign3[0]
XU21 AO22S $PINS O=N155 A1=N128 A2=FE_OFN432_s33_0 B1=term3_shifted[4]
+ B2=sign3[0]
XU29 MOAI1 $PINS O=N98 A1=n11 A2=sign2[0] B1=term2_shifted[2] B2=sign2[0]
XU32 NR2 $PINS O=term3_in[2] I1=sign3[1] I2=x_in[2]
XU33 NR2 $PINS O=term2_in[3] I1=FE_OFN124_s32_1 I2=x_in[3]
XU34 NR2 $PINS O=term1_in[3] I1=FE_OFN118_s31_1 I2=x_in[3]
XU35 NR2 $PINS O=term1_in[0] I1=FE_OFN118_s31_1 I2=FE_OFN247_mac_in_imag_0
XU37 NR2T $PINS O=term3_shifted[1] I1=n19 I2=n18
XU38 INV1S $PINS O=n69 I=FE_OCPN1049_sll_17_ML_int_2_2
XU39 INV1S $PINS O=n7 I=N72
XU40 ND2 $PINS O=n2 I1=n41 I2=term1_in[0]
XU41 INV1S $PINS O=sll_16/ML_int[1][0] I=n2
XU42 OR2 $PINS O=n77 I1=FE_OFN133_h33_2 I2=shf3[3]
XU43 NR2T $PINS O=term1_shifted[2] I1=n59 I2=n57
XU44 INV3 $PINS O=n59 I=sll_16/ML_int[2][2]
XU46 INV2 $PINS O=sll_17/ML_int[1][0] I=n3
XU47 OR2 $PINS O=n55 I1=FE_OCPN1154_n2 I2=FE_OFN122_h31_1
XU48 OR2 $PINS O=n76 I1=n18 I2=shf3[1]
XU49 AN2 $PINS O=sll_17/ML_int[3][1] I1=FE_OFN127_h32_2 I2=n10
XU50 MUX2 $PINS O=sll_16/ML_int[1][5] S=shf1[0] A=term1_in[5] B=term1_in[4]
XU52 MUX2 $PINS O=sll_17/ML_int[1][2] S=FE_OFN129_h32_0 A=term2_in[2]
+ B=term2_in[1]
XU53 INV2 $PINS O=n68 I=sll_17/ML_int[2][3]
XU57 NR2P $PINS O=term3_shifted[3] I1=n77 I2=n78
XU58 MOAI1 $PINS O=N152 A1=n6 A2=sign3[0] B1=term3_shifted[1] B2=sign3[0]
XU60 INV2 $PINS O=n18 I=sll_18/ML_int[1][1]
XU62 NR2 $PINS O=term2_in[1] I1=FE_OFN124_s32_1 I2=x_in[1]
XU66 AN2 $PINS O=term1_shifted[4] I1=n4 I2=shf1[3]
XU69 NR2P $PINS O=term1_shifted[3] I1=n57 I2=n58
XU71 INV2 $PINS O=n78 I=sll_18/ML_int[2][3]
XU72 NR2 $PINS O=term2_in[2] I1=FE_OFN124_s32_1 I2=x_in[2]
XU74 OR2 $PINS O=n16 I1=n77 I2=shf3[1]
XU75 NR2 $PINS O=n17 I1=n15 I2=shf3[1]
XU78 MOAI1S $PINS O=base_val[9] A1=stage_sel A2=n106 B1=acc_reg[9] B2=n106
XU80 NR2 $PINS O=term3_in[1] I1=sign3[1] I2=x_in[1]
XU81 NR2 $PINS O=term1_in[2] I1=FE_OFN118_s31_1 I2=x_in[2]
XU84 OR2 $PINS O=n13 I1=n57 I2=FE_OFN122_h31_1
XU85 OR2 $PINS O=n19 I1=n77 I2=shf3[1]
XU86 ND2 $PINS O=n67 I1=FE_OFN127_h32_2 I2=shf2[3]
XU87 INV2 $PINS O=n79 I=sll_18/ML_int[2][2]
XU88 INV2 $PINS O=n58 I=sll_16/ML_int[2][3]
XU90 AN2T $PINS O=term3_shifted[4] I1=n5 I2=n24
XU91 AN2T $PINS O=term2_shifted[4] I1=sll_17/ML_int[3][4] I2=shf2[3]
XU92 INV1S $PINS O=n75 I=n17
XU93 AN2 $PINS O=base_val[14] I1=acc_reg[14] I2=FE_OFN456_n106
XU94 AO22S $PINS O=N67 A1=FE_DBTN21_s31_0 A2=N40 B1=term1_shifted[26]
+ B2=FE_OFN431_FE_DBTN21_s31_0
XU95 AO22S $PINS O=N66 A1=N39 A2=FE_DBTN21_s31_0 B1=term1_shifted[25]
+ B2=FE_OFN431_FE_DBTN21_s31_0
XU96 AO22S $PINS O=N65 A1=N38 A2=FE_DBTN21_s31_0 B1=term1_shifted[24]
+ B2=FE_OFN431_FE_DBTN21_s31_0
XU97 AO22 $PINS O=N64 A1=N37 A2=FE_DBTN21_s31_0 B1=term1_shifted[23]
+ B2=FE_OFN431_FE_DBTN21_s31_0
XU102 AO22 $PINS O=N59 A1=N32 A2=FE_DBTN21_s31_0 B1=term1_shifted[18]
+ B2=FE_OFN430_FE_DBTN21_s31_0
XU103 AO22 $PINS O=N58 A1=N31 A2=FE_DBTN21_s31_0 B1=term1_shifted[17]
+ B2=FE_OFN430_FE_DBTN21_s31_0
XU104 AO22 $PINS O=N57 A1=N30 A2=FE_DBTN21_s31_0 B1=term1_shifted[16]
+ B2=FE_OFN430_FE_DBTN21_s31_0
XU105 AO22 $PINS O=N56 A1=N29 A2=FE_DBTN21_s31_0 B1=term1_shifted[15]
+ B2=FE_OFN430_FE_DBTN21_s31_0
XU106 AO22S $PINS O=N55 A1=N28 A2=sign1[0] B1=term1_shifted[14]
+ B2=FE_OFN430_FE_DBTN21_s31_0
XU107 AO22 $PINS O=N54 A1=N27 A2=sign1[0] B1=term1_shifted[13]
+ B2=FE_OFN430_FE_DBTN21_s31_0
XU109 AO22 $PINS O=N52 A1=N25 A2=sign1[0] B1=term1_shifted[11]
+ B2=FE_OFN430_FE_DBTN21_s31_0
XU112 AO22T $PINS O=N50 A1=N23 A2=sign1[0] B1=term1_shifted[9]
+ B2=FE_OFN430_FE_DBTN21_s31_0
XU113 AO22 $PINS O=N49 A1=N22 A2=sign1[0] B1=term1_shifted[8]
+ B2=FE_OFN430_FE_DBTN21_s31_0
XU114 AO22 $PINS O=N48 A1=N21 A2=sign1[0] B1=term1_shifted[7]
+ B2=FE_OFN430_FE_DBTN21_s31_0
XU115 AO22P $PINS O=N47 A1=N20 A2=FE_OFN172_n B1=term1_shifted[6]
+ B2=FE_OFN430_FE_DBTN21_s31_0
XU116 AO22 $PINS O=N46 A1=N19 A2=FE_OFN172_n B1=term1_shifted[5] B2=FE_OFN170_n
XU120 INV2 $PINS O=n14 I=N15
XU122 INV2 $PINS O=n6 I=N125
XU123 MUX2 $PINS O=sll_16/ML_int[2][4] S=FE_OFN122_h31_1 A=sll_16/ML_int[1][4]
+ B=sll_16/ML_int[1][2]
XU124 AO22 $PINS O=N110 A1=N83 A2=FE_RN_3 B1=term2_shifted[14]
+ B2=FE_OFN365_s32_0
XU125 AO22 $PINS O=N105 A1=N78 A2=FE_OFN440_s32_0 B1=term2_shifted[9]
+ B2=FE_OFN365_s32_0
XU127 OR2 $PINS O=n9 I1=n67 I2=FE_OFN128_h32_1
XU128 NR2 $PINS O=term2_in[4] I1=FE_OFN124_s32_1 I2=x_in[4]
XU129 NR2P $PINS O=term3_in[4] I1=sign3[1] I2=x_in[4]
XU130 NR2 $PINS O=term1_in[4] I1=FE_OFN118_s31_1 I2=x_in[4]
XU131 AO22S $PINS O=N116 A1=N89 A2=FE_RN_3 B1=term2_shifted[20]
+ B2=FE_OFN368_s32_0
XU133 NR2 $PINS O=n10 I1=n8 I2=FE_OFN128_h32_1
XU135 MUX2S $PINS O=term1_shifted[12] S=FE_OFN371_h31_3 A=sll_16/ML_int[3][12]
+ B=n4
XU136 MUX2S $PINS O=term3_shifted[12] S=shf3[3] A=sll_18/ML_int[3][12] B=n5
XU137 MOAI1 $PINS O=N42 A1=n14 A2=FE_OFN170_n B1=term1_shifted[1]
+ B2=FE_OFN170_n
XU138 MUX2S $PINS O=sll_18/ML_int[1][5] S=shf3[0] A=term3_in[5] B=term3_in[4]
XU140 NR2 $PINS O=term1_in[1] I1=FE_OFN118_s31_1 I2=x_in[1]
XU141 AN2 $PINS O=base_val[3] I1=acc_reg[3] I2=n106
XU142 AN2 $PINS O=base_val[4] I1=acc_reg[4] I2=n106
XU143 AN2 $PINS O=base_val[5] I1=acc_reg[5] I2=n106
XU145 MUX2S $PINS O=sll_18/ML_int[1][8] S=shf3[0] A=term3_in[8] B=term3_in[7]
XU146 MUX2S $PINS O=sll_17/ML_int[1][8] S=FE_OFN129_h32_0 A=term2_in[8]
+ B=term2_in[7]
XU147 MUX2S $PINS O=sll_16/ML_int[1][9] S=FE_RN_11 A=term1_in[9] B=term1_in[8]
XU148 MUX2S $PINS O=sll_18/ML_int[2][9] S=shf3[1] A=sll_18/ML_int[1][9]
+ B=sll_18/ML_int[1][7]
XU149 MUX2S $PINS O=sll_18/ML_int[1][9] S=shf3[0] A=term3_in[9] B=term3_in[8]
XU150 MUX2S $PINS O=sll_17/ML_int[2][9] S=FE_RN_4 A=sll_17/ML_int[1][9]
+ B=sll_17/ML_int[1][7]
XU151 MUX2S $PINS O=sll_17/ML_int[1][9] S=FE_RN_7 A=term2_in[9] B=term2_in[8]
XU152 MUX2S $PINS O=sll_16/ML_int[2][10] S=FE_RN_10 A=sll_16/ML_int[1][10]
+ B=sll_16/ML_int[1][8]
XU153 MUX2S $PINS O=sll_16/ML_int[1][10] S=FE_RN_11 A=term1_in[10]
+ B=term1_in[9]
XU154 MUX2S $PINS O=sll_18/ML_int[2][10] S=shf3[1] A=sll_18/ML_int[1][10]
+ B=sll_18/ML_int[1][8]
XU155 MUX2S $PINS O=sll_18/ML_int[1][10] S=shf3[0] A=term3_in[10] B=term3_in[9]
XU156 MUX2S $PINS O=sll_17/ML_int[2][10] S=FE_RN_4 A=sll_17/ML_int[1][10]
+ B=sll_17/ML_int[1][8]
XU157 MUX2S $PINS O=sll_17/ML_int[1][10] S=FE_RN_7 A=term2_in[10] B=term2_in[9]
XU158 MUX2S $PINS O=sll_16/ML_int[2][11] S=FE_RN_10 A=sll_16/ML_int[1][11]
+ B=sll_16/ML_int[1][9]
XU159 MUX2S $PINS O=sll_16/ML_int[1][11] S=FE_RN_11 A=term1_in[11]
+ B=term1_in[10]
XU160 MUX2S $PINS O=sll_18/ML_int[3][11] S=FE_RN_5 A=sll_18/ML_int[2][11]
+ B=sll_18/ML_int[2][7]
XU161 MUX2 $PINS O=sll_18/ML_int[2][11] S=shf3[1] A=sll_18/ML_int[1][11]
+ B=sll_18/ML_int[1][9]
XU162 MUX2S $PINS O=sll_18/ML_int[1][11] S=shf3[0] A=term3_in[11]
+ B=term3_in[10]
XU163 MUX2S $PINS O=sll_17/ML_int[3][11] S=FE_RN_1 A=sll_17/ML_int[2][11]
+ B=sll_17/ML_int[2][7]
XU164 MUX2S $PINS O=sll_17/ML_int[2][11] S=FE_RN_4 A=sll_17/ML_int[1][11]
+ B=sll_17/ML_int[1][9]
XU165 MUX2S $PINS O=sll_17/ML_int[1][11] S=FE_RN_7 A=term2_in[11]
+ B=term2_in[10]
XU166 MUX2S $PINS O=sll_16/ML_int[3][12] S=FE_OFN121_h31_2
+ A=sll_16/ML_int[2][12] B=sll_16/ML_int[2][8]
XU167 MUX2S $PINS O=sll_16/ML_int[2][12] S=FE_RN_10 A=sll_16/ML_int[1][12]
+ B=sll_16/ML_int[1][10]
XU168 MUX2S $PINS O=sll_16/ML_int[1][12] S=FE_RN_11 A=term1_in[12]
+ B=term1_in[11]
XU175 MUX2S $PINS O=sll_18/ML_int[3][12] S=FE_RN_5 A=sll_18/ML_int[2][12]
+ B=sll_18/ML_int[2][8]
XU181 MUX2S $PINS O=sll_18/ML_int[2][12] S=shf3[1] A=sll_18/ML_int[1][12]
+ B=sll_18/ML_int[1][10]
XU182 MUX2S $PINS O=sll_18/ML_int[1][12] S=shf3[0] A=term3_in[12]
+ B=term3_in[11]
XU186 MUX2S $PINS O=sll_17/ML_int[3][12] S=FE_RN_1 A=sll_17/ML_int[2][12]
+ B=sll_17/ML_int[2][8]
XU192 MUX2S $PINS O=sll_17/ML_int[2][12] S=FE_RN_4 A=sll_17/ML_int[1][12]
+ B=sll_17/ML_int[1][10]
XU193 MUX2S $PINS O=sll_17/ML_int[1][12] S=FE_RN_7 A=term2_in[12]
+ B=term2_in[11]
XU194 MUX2S $PINS O=sll_16/ML_int[3][13] S=n44 A=sll_16/ML_int[2][13]
+ B=sll_16/ML_int[2][9]
XU195 MUX2S $PINS O=sll_16/ML_int[2][13] S=FE_RN_10 A=sll_16/ML_int[1][13]
+ B=sll_16/ML_int[1][11]
XU196 MUX2S $PINS O=sll_16/ML_int[1][13] S=FE_RN_11 A=term1_in[13]
+ B=term1_in[12]
XU197 MUX2S $PINS O=sll_18/ML_int[3][13] S=FE_RN_5 A=sll_18/ML_int[2][13]
+ B=sll_18/ML_int[2][9]
XU198 MUX2S $PINS O=sll_18/ML_int[2][13] S=shf3[1] A=sll_18/ML_int[1][13]
+ B=sll_18/ML_int[1][11]
XU199 MUX2S $PINS O=sll_18/ML_int[1][13] S=shf3[0] A=term3_in[13]
+ B=term3_in[12]
XU200 MUX2S $PINS O=sll_17/ML_int[3][13] S=FE_RN_1 A=sll_17/ML_int[2][13]
+ B=sll_17/ML_int[2][9]
XU201 MUX2S $PINS O=sll_17/ML_int[2][13] S=FE_RN_4 A=sll_17/ML_int[1][13]
+ B=sll_17/ML_int[1][11]
XU202 MUX2S $PINS O=sll_17/ML_int[1][13] S=FE_RN_7 A=term2_in[13]
+ B=term2_in[12]
XU203 MUX2S $PINS O=sll_16/ML_int[3][14] S=n44 A=sll_16/ML_int[2][14]
+ B=sll_16/ML_int[2][10]
XU204 MUX2S $PINS O=sll_16/ML_int[2][14] S=FE_RN_10 A=sll_16/ML_int[1][14]
+ B=sll_16/ML_int[1][12]
XU205 MUX2S $PINS O=sll_16/ML_int[1][14] S=FE_RN_11 A=term1_in[14]
+ B=term1_in[13]
XU206 MUX2S $PINS O=sll_18/ML_int[3][14] S=FE_RN_5 A=sll_18/ML_int[2][14]
+ B=sll_18/ML_int[2][10]
XU207 MUX2S $PINS O=sll_18/ML_int[2][14] S=shf3[1] A=sll_18/ML_int[1][14]
+ B=sll_18/ML_int[1][12]
XU208 MUX2S $PINS O=sll_18/ML_int[1][14] S=shf3[0] A=term3_in[14]
+ B=term3_in[13]
XU209 MUX2S $PINS O=sll_17/ML_int[3][14] S=FE_RN_1 A=sll_17/ML_int[2][14]
+ B=sll_17/ML_int[2][10]
XU210 MUX2S $PINS O=sll_17/ML_int[2][14] S=FE_RN_4 A=sll_17/ML_int[1][14]
+ B=sll_17/ML_int[1][12]
XU211 MUX2S $PINS O=sll_17/ML_int[1][14] S=FE_RN_7 A=term2_in[14]
+ B=term2_in[13]
XU212 MUX2S $PINS O=term1_shifted[16] S=n45 A=sll_16/ML_int[3][16]
+ B=sll_16/ML_int[3][8]
XU213 MUX2S $PINS O=sll_16/ML_int[3][16] S=n44 A=n62 B=sll_16/ML_int[2][12]
XU214 MUX2S $PINS O=term3_shifted[16] S=shf3[3] A=sll_18/ML_int[3][16]
+ B=sll_18/ML_int[3][8]
XU215 MUX2S $PINS O=sll_18/ML_int[3][16] S=FE_RN_5 A=n81 B=sll_18/ML_int[2][12]
XU216 MUX2S $PINS O=term2_shifted[16] S=n36 A=sll_17/ML_int[3][16]
+ B=sll_17/ML_int[3][8]
XU217 MUX2S $PINS O=sll_17/ML_int[3][16] S=FE_RN_1 A=n71 B=sll_17/ML_int[2][12]
XU218 MUX2S $PINS O=sll_16/ML_int[3][15] S=n44 A=sll_16/ML_int[2][15]
+ B=sll_16/ML_int[2][11]
XU219 MUX2S $PINS O=sll_16/ML_int[2][15] S=FE_RN_10 A=sll_16/ML_int[1][15]
+ B=sll_16/ML_int[1][13]
XU220 MUX2S $PINS O=sll_16/ML_int[1][15] S=FE_RN_11 A=term1_in[15]
+ B=term1_in[14]
XU221 MUX2S $PINS O=term3_shifted[15] S=shf3[3] A=sll_18/ML_int[3][15]
+ B=sll_18/ML_int[3][7]
XU222 MUX2S $PINS O=sll_18/ML_int[3][15] S=FE_RN_5 A=sll_18/ML_int[2][15]
+ B=sll_18/ML_int[2][11]
XU223 MUX2S $PINS O=sll_18/ML_int[2][15] S=shf3[1] A=sll_18/ML_int[1][15]
+ B=sll_18/ML_int[1][13]
XU224 MUX2S $PINS O=sll_18/ML_int[1][15] S=FE_OFN135_h33_0 A=term3_in[15]
+ B=term3_in[14]
XU225 MUX2S $PINS O=term2_shifted[15] S=n36 A=sll_17/ML_int[3][15]
+ B=sll_17/ML_int[3][7]
XU226 MUX2S $PINS O=sll_17/ML_int[3][15] S=FE_RN_1 A=sll_17/ML_int[2][15]
+ B=sll_17/ML_int[2][11]
XU227 MUX2S $PINS O=sll_17/ML_int[2][15] S=FE_RN_4 A=sll_17/ML_int[1][15]
+ B=sll_17/ML_int[1][13]
XU228 MUX2S $PINS O=sll_17/ML_int[1][15] S=FE_RN_7 A=term2_in[15]
+ B=term2_in[14]
XU229 MUX2S $PINS O=term1_shifted[17] S=n45 A=sll_16/ML_int[3][17]
+ B=sll_16/ML_int[3][9]
XU230 MUX2S $PINS O=sll_16/ML_int[3][17] S=n44 A=n63 B=sll_16/ML_int[2][13]
XU231 MUX2S $PINS O=term3_shifted[17] S=shf3[3] A=sll_18/ML_int[3][17]
+ B=sll_18/ML_int[3][9]
XU232 MUX2S $PINS O=sll_18/ML_int[3][17] S=FE_RN_5 A=n82 B=sll_18/ML_int[2][13]
XU233 MUX2S $PINS O=term2_shifted[17] S=n36 A=sll_17/ML_int[3][17]
+ B=sll_17/ML_int[3][9]
XU234 MUX2S $PINS O=sll_17/ML_int[3][17] S=FE_RN_1 A=n72 B=sll_17/ML_int[2][13]
XU235 MUX2S $PINS O=term1_shifted[18] S=n45 A=sll_16/ML_int[3][18]
+ B=sll_16/ML_int[3][10]
XU236 MUX2S $PINS O=sll_16/ML_int[3][18] S=n44 A=n64 B=sll_16/ML_int[2][14]
XU237 MUX2S $PINS O=term3_shifted[18] S=shf3[3] A=sll_18/ML_int[3][18]
+ B=sll_18/ML_int[3][10]
XU238 MUX2S $PINS O=sll_18/ML_int[3][18] S=FE_RN_5 A=n83 B=sll_18/ML_int[2][14]
XU239 MUX2S $PINS O=term2_shifted[18] S=n36 A=sll_17/ML_int[3][18]
+ B=sll_17/ML_int[3][10]
XU240 MUX2S $PINS O=sll_17/ML_int[3][18] S=FE_RN_1 A=n73 B=sll_17/ML_int[2][14]
XU241 MUX2S $PINS O=term1_shifted[20] S=n45 A=sll_16/ML_int[3][20]
+ B=sll_16/ML_int[3][12]
XU242 MUX2S $PINS O=sll_16/ML_int[3][20] S=n44 A=term1_in[26] B=n62
XU243 MUX2S $PINS O=term1_shifted[19] S=n45 A=sll_16/ML_int[3][19]
+ B=sll_16/ML_int[3][11]
XU244 MUX2S $PINS O=sll_16/ML_int[3][19] S=n44 A=term1_in[26]
+ B=sll_16/ML_int[2][15]
XU245 MUX2S $PINS O=term3_shifted[20] S=shf3[3] A=sll_18/ML_int[3][20]
+ B=sll_18/ML_int[3][12]
XU246 MUX2S $PINS O=sll_18/ML_int[3][20] S=FE_RN_5 A=term3_in[26] B=n81
XU247 MUX2S $PINS O=term3_shifted[19] S=shf3[3] A=sll_18/ML_int[3][19]
+ B=sll_18/ML_int[3][11]
XU248 MUX2S $PINS O=sll_18/ML_int[3][19] S=FE_RN_5 A=term3_in[26]
+ B=sll_18/ML_int[2][15]
XU249 MUX2S $PINS O=term2_shifted[20] S=n36 A=sll_17/ML_int[3][20]
+ B=sll_17/ML_int[3][12]
XU250 MUX2S $PINS O=sll_17/ML_int[3][20] S=FE_RN_1 A=term2_in[26] B=n71
XU251 MUX2S $PINS O=term2_shifted[19] S=n36 A=sll_17/ML_int[3][19]
+ B=sll_17/ML_int[3][11]
XU252 MUX2S $PINS O=sll_17/ML_int[3][19] S=FE_RN_1 A=term2_in[26]
+ B=sll_17/ML_int[2][15]
XU253 MUX2S $PINS O=term1_shifted[21] S=n45 A=sll_16/ML_int[3][21]
+ B=sll_16/ML_int[3][13]
XU254 MUX2S $PINS O=sll_16/ML_int[3][21] S=n44 A=term1_in[26] B=n63
XU255 MUX2S $PINS O=sll_17/ML_int[3][21] S=FE_RN_1 A=term2_in[26] B=n72
XU256 MUX2S $PINS O=sll_18/ML_int[3][21] S=FE_RN_5 A=term3_in[26] B=n82
XU257 MUX2S $PINS O=sll_16/ML_int[3][22] S=n44 A=term1_in[26] B=n64
XU258 MUX2S $PINS O=sll_17/ML_int[3][22] S=FE_RN_1 A=term2_in[26] B=n73
XU259 MUX2S $PINS O=sll_18/ML_int[3][22] S=FE_RN_5 A=term3_in[26] B=n83
XU260 AO22 $PINS O=N159 A1=N132 A2=FE_OFN432_s33_0 B1=term3_shifted[8]
+ B2=FE_OFN429_FE_RN_2
XU262 AO22 $PINS O=N161 A1=N134 A2=FE_OFN432_s33_0 B1=term3_shifted[10]
+ B2=FE_OFN429_FE_RN_2
XU263 AO22 $PINS O=N162 A1=N135 A2=FE_OFN432_s33_0 B1=term3_shifted[11]
+ B2=FE_OFN429_FE_RN_2
XU264 AO22 $PINS O=N163 A1=N136 A2=FE_OFN432_s33_0 B1=term3_shifted[12]
+ B2=FE_OFN429_FE_RN_2
XU265 AO22 $PINS O=N164 A1=N137 A2=FE_OFN432_s33_0 B1=term3_shifted[13]
+ B2=FE_OFN429_FE_RN_2
XU266 AO22 $PINS O=N165 A1=N138 A2=FE_RN_2 B1=term3_shifted[14]
+ B2=FE_OFN429_FE_RN_2
XU267 AO22 $PINS O=N166 A1=N139 A2=FE_RN_2 B1=term3_shifted[15]
+ B2=FE_OFN429_FE_RN_2
XU268 AO22 $PINS O=N167 A1=N140 A2=FE_RN_2 B1=term3_shifted[16]
+ B2=FE_OFN429_FE_RN_2
XU269 AO22S $PINS O=N168 A1=N141 A2=FE_RN_2 B1=term3_shifted[17]
+ B2=FE_OFN429_FE_RN_2
XU270 AO22 $PINS O=N169 A1=N142 A2=FE_RN_2 B1=term3_shifted[18]
+ B2=FE_OFN429_FE_RN_2
XU271 AO22 $PINS O=N170 A1=N143 A2=FE_RN_2 B1=term3_shifted[19]
+ B2=FE_OFN429_FE_RN_2
XU272 AO22 $PINS O=N171 A1=N144 A2=FE_RN_2 B1=term3_shifted[20]
+ B2=FE_OFN429_FE_RN_2
XU273 AO22 $PINS O=N172 A1=N145 A2=FE_RN_2 B1=term3_shifted[21]
+ B2=FE_OFN429_FE_RN_2
XU274 AO22S $PINS O=N173 A1=N146 A2=FE_RN_2 B1=term3_shifted[22]
+ B2=FE_OFN429_FE_RN_2
XU275 AO22S $PINS O=N174 A1=N147 A2=FE_RN_2 B1=term3_shifted[23]
+ B2=FE_OFN429_FE_RN_2
XU276 AO22S $PINS O=N175 A1=N148 A2=FE_RN_2 B1=term3_shifted[24]
+ B2=FE_OFN429_FE_RN_2
XU277 AO22S $PINS O=N176 A1=N149 A2=FE_RN_2 B1=term3_shifted[25]
+ B2=FE_OFN429_FE_RN_2
XU281 AN2S $PINS O=base_val[6] I1=acc_reg[6] I2=n106
XU283 AO22 $PINS O=N109 A1=N82 A2=FE_OFN440_s32_0 B1=term2_shifted[13]
+ B2=FE_OFN365_s32_0
XU284 ND2S $PINS O=n107 I1=N251 I2=stage_sel
XU285 MUX2S $PINS O=N235 S=stage_sel A=acc_reg[10] B=acc_reg[14]
XU286 MUX2S $PINS O=N236 S=stage_sel A=acc_reg[11] B=acc_reg[15]
XU287 MUX2S $PINS O=FE_PHN1454_N237 S=stage_sel A=acc_reg[12] B=acc_reg[16]
XU288 MUX2S $PINS O=FE_PHN1483_N238 S=stage_sel A=acc_reg[13] B=acc_reg[17]
XU289 MUX2S $PINS O=N239 S=stage_sel A=acc_reg[14] B=acc_reg[18]
XU290 MUX2S $PINS O=N240 S=stage_sel A=acc_reg[15] B=acc_reg[19]
XU291 MUX2S $PINS O=N242 S=stage_sel A=acc_reg[17] B=acc_reg[21]
XU292 MUX2S $PINS O=N245 S=stage_sel A=acc_reg[20] B=acc_reg[24]
XU293 MUX2S $PINS O=FE_PHN1870_N246 S=stage_sel A=acc_reg[21]
+ B=FE_PHN1577_acc_reg_25
XU295 INV1S $PINS O=n60 I=n55
XU296 INV1S $PINS O=n70 I=FE_OCPN1177_n66
XU297 INV1S $PINS O=n80 I=n76
XU299 NR2 $PINS O=term1_in[5] I1=FE_OFN118_s31_1 I2=x_in[5]
XU300 NR2 $PINS O=term2_in[5] I1=FE_OFN124_s32_1 I2=x_in[5]
XU301 NR2 $PINS O=term3_in[5] I1=sign3[1] I2=x_in[5]
XU302 NR2 $PINS O=term1_in[6] I1=FE_OFN118_s31_1 I2=x_in[6]
XU303 NR2 $PINS O=term2_in[6] I1=FE_OFN124_s32_1 I2=x_in[6]
XU304 NR2 $PINS O=term3_in[6] I1=sign3[1] I2=x_in[6]
XU305 NR2 $PINS O=term1_in[7] I1=FE_OFN118_s31_1 I2=x_in[7]
XU306 NR2 $PINS O=term2_in[7] I1=FE_OFN124_s32_1 I2=x_in[7]
XU307 NR2 $PINS O=term3_in[7] I1=sign3[1] I2=x_in[7]
XU308 NR2 $PINS O=term1_in[8] I1=FE_OFN118_s31_1 I2=x_in[8]
XU309 NR2 $PINS O=term2_in[8] I1=FE_RN_8 I2=x_in[8]
XU310 NR2 $PINS O=term3_in[8] I1=sign3[1] I2=x_in[8]
XU311 NR2 $PINS O=term1_in[9] I1=FE_OFN118_s31_1 I2=x_in[9]
XU312 NR2 $PINS O=term2_in[9] I1=FE_RN_8 I2=x_in[9]
XU313 NR2 $PINS O=term3_in[9] I1=sign3[1] I2=x_in[9]
XU314 NR2 $PINS O=term1_in[10] I1=FE_RN_9 I2=FE_OFN227_mac_in_imag_10
XU315 NR2 $PINS O=term2_in[10] I1=FE_RN_8 I2=FE_OFN227_mac_in_imag_10
XU316 NR2 $PINS O=term3_in[10] I1=sign3[1] I2=FE_OFN227_mac_in_imag_10
XU320 NR2 $PINS O=term1_in[11] I1=FE_RN_9 I2=x_in[11]
XU321 NR2 $PINS O=term2_in[11] I1=FE_RN_8 I2=x_in[11]
XU322 NR2 $PINS O=term3_in[11] I1=sign3[1] I2=x_in[11]
XU323 NR2 $PINS O=term1_in[12] I1=FE_RN_9 I2=x_in[12]
XU324 NR2 $PINS O=term2_in[12] I1=FE_RN_8 I2=x_in[12]
XU325 NR2 $PINS O=term3_in[12] I1=sign3[1] I2=x_in[12]
XU326 NR2 $PINS O=term1_in[13] I1=FE_RN_9 I2=x_in[13]
XU327 NR2 $PINS O=term2_in[13] I1=FE_RN_8 I2=x_in[13]
XU328 NR2 $PINS O=term3_in[13] I1=sign3[1] I2=x_in[13]
XU329 NR2 $PINS O=term1_in[14] I1=FE_RN_9 I2=x_in[14]
XU330 NR2 $PINS O=term2_in[14] I1=FE_RN_8 I2=x_in[14]
XU331 NR2 $PINS O=term3_in[14] I1=sign3[1] I2=x_in[14]
XU332 NR2 $PINS O=term1_in[15] I1=FE_RN_9 I2=x_in[15]
XU333 NR2 $PINS O=term1_in[26] I1=x_in[16] I2=FE_RN_9
XU334 NR2 $PINS O=term2_in[15] I1=FE_RN_8 I2=x_in[15]
XU335 NR2 $PINS O=term3_in[15] I1=sign3[1] I2=x_in[15]
XU336 NR2 $PINS O=term2_in[26] I1=x_in[16] I2=FE_RN_8
XU337 NR2 $PINS O=term3_in[26] I1=x_in[16] I2=sign3[1]
XU348 INV1S $PINS O=n42 I=FE_OFN122_h31_1
XU365 AN2 $PINS O=base_val[26] I1=N251 I2=FE_OFN456_n106
XU366 AN2 $PINS O=base_val[1] I1=acc_reg[1] I2=n106
XU368 AN2 $PINS O=base_val[10] I1=acc_reg[10] I2=FE_OFN456_n106
XU369 AN2 $PINS O=base_val[11] I1=acc_reg[11] I2=FE_OFN456_n106
XU370 AN2 $PINS O=base_val[12] I1=acc_reg[12] I2=FE_OFN456_n106
XU371 AN2 $PINS O=base_val[15] I1=acc_reg[15] I2=FE_OFN456_n106
XU372 AN2 $PINS O=base_val[16] I1=acc_reg[16] I2=FE_OFN456_n106
XU373 AN2 $PINS O=base_val[17] I1=acc_reg[17] I2=FE_OFN456_n106
XU374 AN2 $PINS O=base_val[18] I1=acc_reg[18] I2=FE_OFN456_n106
XU375 AN2 $PINS O=base_val[19] I1=acc_reg[19] I2=FE_OFN456_n106
XU376 AN2 $PINS O=base_val[20] I1=acc_reg[20] I2=FE_OFN456_n106
XU377 AN2 $PINS O=base_val[21] I1=acc_reg[21] I2=FE_OFN456_n106
XU378 AN2 $PINS O=base_val[22] I1=acc_reg[22] I2=FE_OFN456_n106
XU379 AN2 $PINS O=base_val[23] I1=acc_reg[23] I2=FE_OFN456_n106
XU380 AN2 $PINS O=base_val[24] I1=acc_reg[24] I2=FE_OFN456_n106
XU381 AN2 $PINS O=base_val[25] I1=FE_PHN1577_acc_reg_25 I2=FE_OFN456_n106
XU382 AN2 $PINS O=base_val[8] I1=acc_reg[8] I2=n106
XU383 AN2 $PINS O=base_val[7] I1=acc_reg[7] I2=n106
XU385 AN2 $PINS O=N234 I1=en I2=calc_done
XU390 OAI12HS $PINS O=FE_PHN1827_N249 A1=n107 B1=stage_sel B2=n86
XU391 INV1S $PINS O=n86 I=acc_reg[24]
XU395 INV1S $PINS O=n61 I=n56
XU396 NR2 $PINS O=sll_16/ML_int[3][0] I1=FE_OFN121_h31_2 I2=n55
XU397 NR2 $PINS O=sll_16/ML_int[3][1] I1=FE_OFN121_h31_2 I2=FE_OCPN1237_n56
XU398 NR2 $PINS O=sll_16/ML_int[3][2] I1=FE_OFN121_h31_2 I2=n59
XU399 NR2 $PINS O=sll_16/ML_int[3][3] I1=FE_OFN121_h31_2 I2=n58
XU400 ND2P $PINS O=n57 I1=FE_RN_6 I2=shf1[3]
XU401 AN2 $PINS O=term1_shifted[5] I1=sll_16/ML_int[3][5] I2=shf1[3]
XU402 AN2 $PINS O=term1_shifted[6] I1=sll_16/ML_int[3][6] I2=shf1[3]
XU403 AN2 $PINS O=term1_shifted[7] I1=sll_16/ML_int[3][7] I2=shf1[3]
XU404 MUX2 $PINS O=term1_shifted[24] S=n45 A=term1_in[26]
+ B=sll_16/ML_int[3][16]
XU405 MUX2 $PINS O=n62 S=FE_RN_10 A=n65 B=sll_16/ML_int[1][14]
XU406 MUX2 $PINS O=term1_shifted[25] S=n45 A=term1_in[26]
+ B=sll_16/ML_int[3][17]
XU407 MUX2 $PINS O=n63 S=FE_RN_10 A=term1_in[26] B=sll_16/ML_int[1][15]
XU408 MUX2 $PINS O=term1_shifted[26] S=n45 A=term1_in[26]
+ B=sll_16/ML_int[3][18]
XU409 MUX2 $PINS O=n64 S=FE_RN_10 A=term1_in[26] B=n65
XU410 MUX2 $PINS O=n65 S=FE_RN_11 A=term1_in[26] B=term1_in[15]
XU411 NR2 $PINS O=sll_17/ML_int[3][0] I1=FE_RN_1 I2=FE_OCPN1177_n66
XU412 NR2 $PINS O=sll_17/ML_int[3][2] I1=FE_RN_1 I2=n69
XU413 NR2 $PINS O=sll_17/ML_int[3][3] I1=FE_RN_1 I2=n68
XU414 AN2 $PINS O=term2_shifted[5] I1=sll_17/ML_int[3][5] I2=shf2[3]
XU415 AN2 $PINS O=term2_shifted[6] I1=sll_17/ML_int[3][6] I2=shf2[3]
XU416 AN2 $PINS O=term2_shifted[7] I1=sll_17/ML_int[3][7] I2=shf2[3]
XU417 MUX2 $PINS O=term2_shifted[24] S=n36 A=term2_in[26]
+ B=sll_17/ML_int[3][16]
XU418 MUX2 $PINS O=n71 S=FE_RN_4 A=n74 B=sll_17/ML_int[1][14]
XU419 MUX2 $PINS O=term2_shifted[25] S=n36 A=term2_in[26]
+ B=sll_17/ML_int[3][17]
XU420 MUX2 $PINS O=n72 S=FE_RN_4 A=term2_in[26] B=sll_17/ML_int[1][15]
XU421 MUX2 $PINS O=term2_shifted[26] S=n36 A=term2_in[26]
+ B=sll_17/ML_int[3][18]
XU422 MUX2 $PINS O=n73 S=FE_RN_4 A=term2_in[26] B=n74
XU423 MUX2 $PINS O=n74 S=FE_RN_7 A=term2_in[26] B=term2_in[15]
XU424 NR2 $PINS O=sll_18/ML_int[3][0] I1=FE_OFN133_h33_2 I2=n75
XU425 NR2 $PINS O=sll_18/ML_int[3][1] I1=FE_OFN133_h33_2 I2=n76
XU426 NR2 $PINS O=sll_18/ML_int[3][2] I1=FE_OFN133_h33_2 I2=n79
XU427 NR2 $PINS O=sll_18/ML_int[3][3] I1=FE_OFN133_h33_2 I2=n78
XU428 AN2 $PINS O=term3_shifted[5] I1=sll_18/ML_int[3][5] I2=n24
XU429 AN2 $PINS O=term3_shifted[6] I1=sll_18/ML_int[3][6] I2=n24
XU430 AN2 $PINS O=term3_shifted[7] I1=sll_18/ML_int[3][7] I2=n24
XU431 MUX2 $PINS O=term3_shifted[24] S=shf3[3] A=term3_in[26]
+ B=sll_18/ML_int[3][16]
XU432 MUX2 $PINS O=n81 S=shf3[1] A=n84 B=sll_18/ML_int[1][14]
XU433 MUX2 $PINS O=term3_shifted[25] S=shf3[3] A=term3_in[26]
+ B=sll_18/ML_int[3][17]
XU434 MUX2 $PINS O=n82 S=shf3[1] A=term3_in[26] B=sll_18/ML_int[1][15]
XU435 MUX2 $PINS O=term3_shifted[26] S=shf3[3] A=term3_in[26]
+ B=sll_18/ML_int[3][18]
XU436 MUX2 $PINS O=n83 S=shf3[1] A=term3_in[26] B=n84
XU437 MUX2 $PINS O=n84 S=FE_OFN135_h33_0 A=term3_in[26] B=term3_in[15]
XU438 MUX2 $PINS O=N241 S=stage_sel A=acc_reg[16] B=acc_reg[20]
XU439 MUX2 $PINS O=FE_PHN1421_N243 S=stage_sel A=acc_reg[18] B=acc_reg[22]
XU440 MUX2 $PINS O=FE_PHN1425_N244 S=stage_sel A=acc_reg[19] B=acc_reg[23]
Xsll_16/M1_2_8 MUX2S $PINS O=sll_16/ML_int[3][8] S=FE_OFN121_h31_2
+ A=sll_16/ML_int[2][8] B=sll_16/ML_int[2][4]
Xsll_16/M1_0_3 MUX2 $PINS O=sll_16/ML_int[1][3] S=shf1[0] A=term1_in[3]
+ B=term1_in[2]
XU12 MUX2 $PINS O=sll_18/ML_int[1][3] S=FE_OFN489_FE_OFN123_h33_0 A=term3_in[3]
+ B=term3_in[2]
XU6 NR2P $PINS O=term1_shifted[1] I1=n57 I2=n56
XU8 NR2P $PINS O=term3_shifted[0] I1=n15 I2=n16
XU13 INV2CK $PINS O=n8 I=sll_17/ML_int[1][1]
XU22 INV2 $PINS O=n11 I=N71
XU23 AO22 $PINS O=N45 A1=N18 A2=FE_OFN172_n B1=term1_shifted[4] B2=FE_OFN170_n
XU24 MUX2 $PINS O=N248 S=stage_sel A=acc_reg[23] B=N251
XU25 AN2 $PINS O=base_val[0] I1=acc_reg[0] I2=n106
XU26 AN2B1T $PINS O=term2_shifted[2] I1=sll_17/ML_int[2][2] B1=n67
XU27 MUX2 $PINS O=N250 S=stage_sel A=FE_PHN1577_acc_reg_25 B=N251
XU36 AN2 $PINS O=base_val[2] I1=acc_reg[2] I2=n106
XU45 MUX2 $PINS O=N247 S=stage_sel A=acc_reg[22] B=N251
XU51 AN2 $PINS O=sll_18/ML_int[1][0] I1=term3_in[0] I2=n22
XU54 MUX2S $PINS O=sll_17/ML_int[3][7] S=FE_OFN127_h32_2 A=sll_17/ML_int[2][3]
+ B=sll_17/ML_int[2][7]
XU55 ND2 $PINS O=n15 I1=term3_in[0] I2=n22
XU56 NR2P $PINS O=term2_shifted[3] I1=n67 I2=n68
XU59 AO22 $PINS O=N44 A1=N17 A2=FE_OFN172_n B1=term1_shifted[3] B2=FE_OFN170_n
XU65 NR2P $PINS O=term2_in[0] I1=FE_OFN124_s32_1 I2=FE_OFN247_mac_in_imag_0
XU70 ND2P $PINS O=n56 I1=sll_16/ML_int[1][1] I2=n42
XU77 ND2 $PINS O=n66 I1=sll_17/ML_int[1][0] I2=FE_OFN161_h32_1
XU126 NR2P $PINS O=term1_shifted[0] I1=n2 I2=n13
XU134 MOAI1 $PINS O=N99 A1=sign2[0] A2=n7 B1=term2_shifted[3] B2=sign2[0]
XU282 ND2 $PINS O=n3 I1=term2_in[0] I2=n31
XU318 NR2T $PINS O=term2_shifted[1] I1=n9 I2=n8
XU367 NR2P $PINS O=term3_shifted[2] I1=n77 I2=n79
XU387 NR2 $PINS O=term3_in[3] I1=sign3[1] I2=x_in[3]
Xclk_gate_y_out_reg SNPS_CLOCK_GATE_HIGH_PE_Shift_Add_0 $PINS EN=N234
+ ENCLK=CTS_12 CLK=clk
Xsub_28_3 PE_Shift_Add_0_DW01_sub_0 $PINS A[26]=net45546 A[25]=net45546
+ A[24]=net45546 A[23]=net45546 A[22]=net45546 A[21]=net45546 A[20]=net45546
+ A[19]=net45546 A[18]=net45546 A[17]=net45546 A[16]=net45546 A[15]=net45546
+ A[14]=net45546 A[13]=net45546 A[12]=net45546 A[11]=net45546 A[10]=net45546
+ A[9]=net45546 A[8]=net45546 A[7]=net45546 A[6]=net45546 A[5]=net45546
+ A[4]=net45546 A[3]=net45546 A[2]=net45546 A[1]=net45546 A[0]=net45546
+ B[26]=term3_shifted[26] B[25]=term3_shifted[25] B[24]=term3_shifted[24]
+ B[23]=term3_shifted[23] B[22]=term3_shifted[22] B[21]=term3_shifted[21]
+ B[20]=term3_shifted[20] B[19]=term3_shifted[19] B[18]=term3_shifted[18]
+ B[17]=term3_shifted[17] B[16]=term3_shifted[16] B[15]=term3_shifted[15]
+ B[14]=term3_shifted[14] B[13]=term3_shifted[13] B[12]=term3_shifted[12]
+ B[11]=term3_shifted[11] B[10]=term3_shifted[10] B[9]=term3_shifted[9]
+ B[8]=term3_shifted[8] B[7]=term3_shifted[7] B[6]=term3_shifted[6]
+ B[5]=term3_shifted[5] B[4]=term3_shifted[4] B[3]=term3_shifted[3]
+ B[2]=term3_shifted[2] B[1]=term3_shifted[1] B[0]=term3_shifted[0] CI=net45546
+ DIFF[26]=N150 DIFF[25]=N149 DIFF[24]=N148 DIFF[23]=N147 DIFF[22]=N146
+ DIFF[21]=N145 DIFF[20]=N144 DIFF[19]=N143 DIFF[18]=N142 DIFF[17]=N141
+ DIFF[16]=N140 DIFF[15]=N139 DIFF[14]=N138 DIFF[13]=N137 DIFF[12]=N136
+ DIFF[11]=N135 DIFF[10]=N134 DIFF[9]=N133 DIFF[8]=N132 DIFF[7]=N131 DIFF[6]=N130
+ DIFF[5]=N129 DIFF[4]=N128 DIFF[3]=N127 DIFF[2]=N126 DIFF[1]=N125 DIFF[0]=N124
+ FE_RN_2478_0=FE_RN_2478_0
Xsub_28_2 PE_Shift_Add_0_DW01_sub_1 $PINS A[26]=net45546 A[25]=net45546
+ A[24]=net45546 A[23]=net45546 A[22]=net45546 A[21]=net45546 A[20]=net45546
+ A[19]=net45546 A[18]=net45546 A[17]=net45546 A[16]=net45546 A[15]=net45546
+ A[14]=net45546 A[13]=net45546 A[12]=net45546 A[11]=net45546 A[10]=net45546
+ A[9]=net45546 A[8]=net45546 A[7]=net45546 A[6]=net45546 A[5]=net45546
+ A[4]=net45546 A[3]=net45546 A[2]=net45546 A[1]=net45546 A[0]=net45546
+ B[26]=term2_shifted[26] B[25]=term2_shifted[25] B[24]=term2_shifted[24]
+ B[23]=term2_shifted[23] B[22]=term2_shifted[22] B[21]=term2_shifted[21]
+ B[20]=term2_shifted[20] B[19]=term2_shifted[19] B[18]=term2_shifted[18]
+ B[17]=term2_shifted[17] B[16]=term2_shifted[16] B[15]=term2_shifted[15]
+ B[14]=term2_shifted[14] B[13]=term2_shifted[13] B[12]=term2_shifted[12]
+ B[11]=term2_shifted[11] B[10]=term2_shifted[10] B[9]=term2_shifted[9]
+ B[8]=term2_shifted[8] B[7]=term2_shifted[7] B[6]=term2_shifted[6]
+ B[5]=term2_shifted[5] B[4]=term2_shifted[4] B[3]=term2_shifted[3]
+ B[2]=term2_shifted[2] B[1]=term2_shifted[1] B[0]=term2_shifted[0] CI=net45546
+ DIFF[26]=N95 DIFF[25]=N94 DIFF[24]=N93 DIFF[23]=N92 DIFF[22]=N91 DIFF[21]=N90
+ DIFF[20]=N89 DIFF[19]=N88 DIFF[18]=N87 DIFF[17]=N86 DIFF[16]=N85 DIFF[15]=N84
+ DIFF[14]=N83 DIFF[13]=N82 DIFF[12]=N81 DIFF[11]=N80 DIFF[10]=N79 DIFF[9]=N78
+ DIFF[8]=N77 DIFF[7]=N76 DIFF[6]=N75 DIFF[5]=N74 DIFF[4]=N73 DIFF[3]=N72
+ DIFF[2]=N71 DIFF[1]=N70 DIFF[0]=N69
Xsub_28 PE_Shift_Add_0_DW01_sub_2 $PINS A[26]=net45546 A[25]=net45546
+ A[24]=net45546 A[23]=net45546 A[22]=net45546 A[21]=net45546 A[20]=net45546
+ A[19]=net45546 A[18]=net45546 A[17]=net45546 A[16]=net45546 A[15]=net45546
+ A[14]=net45546 A[13]=net45546 A[12]=net45546 A[11]=net45546 A[10]=net45546
+ A[9]=net45546 A[8]=net45546 A[7]=net45546 A[6]=net45546 A[5]=net45546
+ A[4]=net45546 A[3]=net45546 A[2]=net45546 A[1]=net45546 A[0]=net45546
+ B[26]=term1_shifted[26] B[25]=term1_shifted[25] B[24]=term1_shifted[24]
+ B[23]=term1_shifted[23] B[22]=term1_shifted[22] B[21]=term1_shifted[21]
+ B[20]=term1_shifted[20] B[19]=term1_shifted[19] B[18]=term1_shifted[18]
+ B[17]=term1_shifted[17] B[16]=term1_shifted[16] B[15]=term1_shifted[15]
+ B[14]=term1_shifted[14] B[13]=term1_shifted[13] B[12]=term1_shifted[12]
+ B[11]=term1_shifted[11] B[10]=term1_shifted[10] B[9]=term1_shifted[9]
+ B[8]=term1_shifted[8] B[7]=term1_shifted[7] B[6]=term1_shifted[6]
+ B[5]=term1_shifted[5] B[4]=term1_shifted[4] B[3]=term1_shifted[3]
+ B[2]=term1_shifted[2] B[1]=term1_shifted[1] B[0]=term1_shifted[0] CI=net45546
+ DIFF[26]=N40 DIFF[25]=N39 DIFF[24]=N38 DIFF[23]=N37 DIFF[22]=N36 DIFF[21]=N35
+ DIFF[20]=N34 DIFF[19]=N33 DIFF[18]=N32 DIFF[17]=N31 DIFF[16]=N30 DIFF[15]=N29
+ DIFF[14]=N28 DIFF[13]=N27 DIFF[12]=N26 DIFF[11]=N25 DIFF[10]=N24 DIFF[9]=N23
+ DIFF[8]=N22 DIFF[7]=N21 DIFF[6]=N20 DIFF[5]=N19 DIFF[4]=N18 DIFF[3]=N17
+ DIFF[2]=N16 DIFF[1]=N15 DIFF[0]=N14
Xadd_1_root_add_0_root_add_28_3 PE_Shift_Add_0_DW01_add_2_DW01_add_16 $PINS
+ A[26]=N67 A[25]=N66 A[24]=N65 A[23]=N64 A[22]=N63 A[21]=N62 A[20]=N61 A[19]=N60
+ A[18]=N59 A[17]=N58 A[16]=N57 A[15]=N56 A[14]=N55 A[13]=N54 A[12]=N53 A[11]=N52
+ A[10]=N51 A[9]=N50 A[8]=N49 A[7]=N48 A[6]=N47 A[5]=N46 A[4]=N45 A[3]=N44
+ A[2]=N43 A[1]=N42 A[0]=N41 B[26]=N177 B[25]=N176 B[24]=N175 B[23]=N174
+ B[22]=N173 B[21]=N172 B[20]=N171 B[19]=N170 B[18]=N169 B[17]=N168 B[16]=N167
+ B[15]=N166 B[14]=N165 B[13]=N164 B[12]=N163 B[11]=N162 B[10]=N161 B[9]=N160
+ B[8]=N159 B[7]=N158 B[6]=N157 B[5]=N156 B[4]=N155 B[3]=N154 B[2]=N153 B[1]=N152
+ B[0]=N151 CI=net45546 SUM[26]=N204 SUM[25]=N203 SUM[24]=N202 SUM[23]=N201
+ SUM[22]=N200 SUM[21]=N199 SUM[20]=N198 SUM[19]=N197 SUM[18]=N196 SUM[17]=N195
+ SUM[16]=N194 SUM[15]=N193 SUM[14]=N192 SUM[13]=N191 SUM[12]=N190 SUM[11]=N189
+ SUM[10]=N188 SUM[9]=N187 SUM[8]=N186 SUM[7]=N185 SUM[6]=N184 SUM[5]=N183
+ SUM[4]=N182 SUM[3]=N181 SUM[2]=N180 SUM[1]=N179 SUM[0]=N178
Xadd_2_root_add_0_root_add_28_3 PE_Shift_Add_0_DW01_add_1_DW01_add_15 $PINS
+ A[26]=base_val[26] A[25]=base_val[25] A[24]=base_val[24] A[23]=base_val[23]
+ A[22]=base_val[22] A[21]=base_val[21] A[20]=base_val[20] A[19]=base_val[19]
+ A[18]=base_val[18] A[17]=base_val[17] A[16]=base_val[16] A[15]=base_val[15]
+ A[14]=base_val[14] A[13]=base_val[13] A[12]=base_val[12] A[11]=base_val[11]
+ A[10]=base_val[10] A[9]=base_val[9] A[8]=base_val[8] A[7]=base_val[7]
+ A[6]=base_val[6] A[5]=base_val[5] A[4]=base_val[4] A[3]=base_val[3]
+ A[2]=base_val[2] A[1]=base_val[1] A[0]=base_val[0] B[26]=N122 B[25]=N121
+ B[24]=N120 B[23]=N119 B[22]=N118 B[21]=N117 B[20]=N116 B[19]=N115 B[18]=N114
+ B[17]=N113 B[16]=N112 B[15]=N111 B[14]=N110 B[13]=N109 B[12]=N108 B[11]=N107
+ B[10]=N106 B[9]=N105 B[8]=N104 B[7]=N103 B[6]=N102 B[5]=N101 B[4]=N100 B[3]=N99
+ B[2]=N98 B[1]=N97 B[0]=N96 CI=net45546 SUM[26]=N231 SUM[25]=N230 SUM[24]=N229
+ SUM[23]=N228 SUM[22]=N227 SUM[21]=N226 SUM[20]=N225 SUM[19]=N224 SUM[18]=N223
+ SUM[17]=N222 SUM[16]=N221 SUM[15]=N220 SUM[14]=N219 SUM[13]=N218 SUM[12]=N217
+ SUM[11]=N216 SUM[10]=N215 SUM[9]=N214 SUM[8]=N213 SUM[7]=N212 SUM[6]=N211
+ SUM[5]=N210 SUM[4]=N209 SUM[3]=N208 SUM[2]=N207 SUM[1]=N206 SUM[0]=N205
Xadd_0_root_add_0_root_add_28_3 PE_Shift_Add_0_DW01_add_0_DW01_add_14 $PINS
+ A[26]=N204 A[25]=N203 A[24]=N202 A[23]=N201 A[22]=N200 A[21]=N199 A[20]=N198
+ A[19]=N197 A[18]=N196 A[17]=N195 A[16]=N194 A[15]=N193 A[14]=N192 A[13]=N191
+ A[12]=N190 A[11]=N189 A[10]=N188 A[9]=N187 A[8]=N186 A[7]=N185 A[6]=N184
+ A[5]=N183 A[4]=N182 A[3]=N181 A[2]=N180 A[1]=N179 A[0]=N178 B[26]=N231
+ B[25]=N230 B[24]=N229 B[23]=N228 B[22]=N227 B[21]=N226 B[20]=N225 B[19]=N224
+ B[18]=N223 B[17]=N222 B[16]=N221 B[15]=N220 B[14]=N219 B[13]=N218 B[12]=N217
+ B[11]=N216 B[10]=N215 B[9]=N214 B[8]=N213 B[7]=N212 B[6]=N211 B[5]=N210
+ B[4]=N209 B[3]=N208 B[2]=N207 B[1]=N206 B[0]=FE_PHN1806_N205 CI=net45546
+ SUM[26]=next_acc[26] SUM[25]=next_acc[25] SUM[24]=next_acc[24]
+ SUM[23]=next_acc[23] SUM[22]=next_acc[22] SUM[21]=next_acc[21]
+ SUM[20]=next_acc[20] SUM[19]=next_acc[19] SUM[18]=next_acc[18]
+ SUM[17]=next_acc[17] SUM[16]=next_acc[16] SUM[15]=next_acc[15]
+ SUM[14]=next_acc[14] SUM[13]=next_acc[13] SUM[12]=next_acc[12]
+ SUM[11]=next_acc[11] SUM[10]=next_acc[10] SUM[9]=next_acc[9] SUM[8]=next_acc[8]
+ SUM[7]=next_acc[7] SUM[6]=next_acc[6] SUM[5]=next_acc[5] SUM[4]=next_acc[4]
+ SUM[3]=next_acc[3] SUM[2]=next_acc[2] SUM[1]=next_acc[1] SUM[0]=next_acc[0]
.ENDS

.SUBCKT DFrFT_MAC rst_n en pe_clear pe_done g_cnt[2] g_cnt[1] g_cnt[0] n_cnt[5]
+ n_cnt[4] n_cnt[3] n_cnt[2] n_cnt[1] n_cnt[0] data_in_r[16] data_in_r[15]
+ data_in_r[14] data_in_r[13] data_in_r[12] data_in_r[11] data_in_r[10]
+ data_in_r[9] data_in_r[8] data_in_r[7] data_in_r[6] data_in_r[5] data_in_r[4]
+ data_in_r[3] data_in_r[2] data_in_r[1] data_in_r[0] data_in_i[16]
+ data_in_i[15] data_in_i[14] data_in_i[13] data_in_i[12] data_in_i[11]
+ data_in_i[10] data_in_i[9] data_in_i[8] data_in_i[7] data_in_i[6]
+ data_in_i[5] data_in_i[4] data_in_i[3] data_in_i[2] data_in_i[1] data_in_i[0]
+ y_out_0_r[16] y_out_0_r[15] y_out_0_r[14] y_out_0_r[13] y_out_0_r[12]
+ y_out_0_r[11] y_out_0_r[10] y_out_0_r[9] y_out_0_r[8] y_out_0_r[7]
+ y_out_0_r[6] y_out_0_r[5] y_out_0_r[4] y_out_0_r[3] y_out_0_r[2] y_out_0_r[1]
+ y_out_0_r[0] y_out_0_i[16] y_out_0_i[15] y_out_0_i[14] y_out_0_i[13]
+ y_out_0_i[12] y_out_0_i[11] y_out_0_i[10] y_out_0_i[9] y_out_0_i[8]
+ y_out_0_i[7] y_out_0_i[6] y_out_0_i[5] y_out_0_i[4] y_out_0_i[3] y_out_0_i[2]
+ y_out_0_i[1] y_out_0_i[0] y_out_1_r[16] y_out_1_r[15] y_out_1_r[14]
+ y_out_1_r[13] y_out_1_r[12] y_out_1_r[11] y_out_1_r[10] y_out_1_r[9]
+ y_out_1_r[8] y_out_1_r[7] y_out_1_r[6] y_out_1_r[5] y_out_1_r[4] y_out_1_r[3]
+ y_out_1_r[2] y_out_1_r[1] y_out_1_r[0] y_out_1_i[16] y_out_1_i[15]
+ y_out_1_i[14] y_out_1_i[13] y_out_1_i[12] y_out_1_i[11] y_out_1_i[10]
+ y_out_1_i[9] y_out_1_i[8] y_out_1_i[7] y_out_1_i[6] y_out_1_i[5] y_out_1_i[4]
+ y_out_1_i[3] y_out_1_i[2] y_out_1_i[1] y_out_1_i[0] y_out_2_r[16]
+ y_out_2_r[15] y_out_2_r[14] y_out_2_r[13] y_out_2_r[12] y_out_2_r[11]
+ y_out_2_r[10] y_out_2_r[9] y_out_2_r[8] y_out_2_r[7] y_out_2_r[6]
+ y_out_2_r[5] y_out_2_r[4] y_out_2_r[3] y_out_2_r[2] y_out_2_r[1] y_out_2_r[0]
+ y_out_2_i[16] y_out_2_i[15] y_out_2_i[14] y_out_2_i[13] y_out_2_i[12]
+ y_out_2_i[11] y_out_2_i[10] y_out_2_i[9] y_out_2_i[8] y_out_2_i[7]
+ y_out_2_i[6] y_out_2_i[5] y_out_2_i[4] y_out_2_i[3] y_out_2_i[2] y_out_2_i[1]
+ y_out_2_i[0] y_out_3_r[16] y_out_3_r[15] y_out_3_r[14] y_out_3_r[13]
+ y_out_3_r[12] y_out_3_r[11] y_out_3_r[10] y_out_3_r[9] y_out_3_r[8]
+ y_out_3_r[7] y_out_3_r[6] y_out_3_r[5] y_out_3_r[4] y_out_3_r[3] y_out_3_r[2]
+ y_out_3_r[1] y_out_3_r[0] y_out_3_i[16] y_out_3_i[15] y_out_3_i[14]
+ y_out_3_i[13] y_out_3_i[12] y_out_3_i[11] y_out_3_i[10] y_out_3_i[9]
+ y_out_3_i[8] y_out_3_i[7] y_out_3_i[6] y_out_3_i[5] y_out_3_i[4] y_out_3_i[3]
+ y_out_3_i[2] y_out_3_i[1] y_out_3_i[0] stage_sel_BAR i_rst_n p1
+ FE_OFN45_i_rst_n FE_OFN41_i_rst_n FE_OFN39_i_rst_n FE_OFN32_i_rst_n
+ FE_OFN23_i_rst_n FE_OFN16_i_rst_n FE_OFN11_i_rst_n FE_OFN8_i_rst_n
+ FE_OFN2_i_rst_n FE_OFN0_i_rst_n FE_OFN62_FE_DBTN9_n336 FE_OFN58_FE_DBTN9_n336
+ FE_OFN56_FE_DBTN9_n336 clk_clone9 clk_clone6 clk_clone5 clk_clone7 clk_clone4
+ clk_clone3 clk_clone2 clk_clone8 clk_clone1 clk
XFE_PHC1809_s23_0 BUF1S $PINS O=FE_PHN1809_s23_0 I=s23[0]
XFE_RC_269_0 MOAI1 $PINS O=rom_n_idx[3][2] A1=stage_sel_BAR A2=g_cnt[0]
+ B1=stage_sel_BAR B2=n_cnt[2]
XCTS_ccl_a_INV_CLK_G0_L11_38 INV12CK $PINS O=CTS_14 I=CTS_15
XCTS_ccl_a_INV_CLK_G0_L11_37 INV12CK $PINS O=CTS_13 I=CTS_15
XCTS_ccl_a_INV_CLK_G0_L10_44 INV6CK $PINS O=CTS_15 I=clk_clone7
XFE_RC_3869_0 NR2 $PINS O=FE_RN_2537_0 I1=g_cnt[2] I2=FE_OCPN679_n336
XFE_RC_3868_0 AO12 $PINS O=rom_n_idx[3][4] A1=FE_RN_2537_0 B1=FE_OCPN679_n336
+ B2=n_cnt[4]
XFE_OCPC679_n336 BUF2 $PINS O=FE_OCPN679_n336 I=stage_sel_BAR
XFE_OFC861_h31_0 BUF12CK $PINS O=FE_OFN111_h31_0 I=h31[0]
XFE_OFC860_h13_2 BUF4 $PINS O=FE_OFN85_h13_2 I=h13[2]
XFE_OFC859_h11_3 BUF1 $PINS O=FE_OFN72_h11_3 I=h11[3]
XFE_OFC855_mac_in_imag_5 INV12 $PINS O=n6 I=data_in_i[5]
XFE_OFC843_mac_in_real_6 BUF6 $PINS O=FE_OFN453_n I=FE_OFN223_mac_in_real_6
XFE_OFC836_s03_1 BUF3 $PINS O=FE_OFN64_s03_1 I=s03[1]
XFE_OFC830_s12_0 INV2 $PINS O=FE_OFN394_s12_0 I=FE_OFN77_s12_0
XFE_OFC826_h33_0 BUF2 $PINS O=FE_OFN123_h33_0 I=h33[0]
XFE_OFC819_mac_in_imag_8 INV2 $PINS O=FE_OFN226_mac_in_imag_8 I=data_in_i[8]
XFE_OFC813_s13_1 BUF2 $PINS O=FE_OFN82_s13_1 I=s13[1]
XFE_OFC811_mac_in_real_12 INV2 $PINS O=FE_OFN241_mac_in_real_12 I=data_in_r[12]
XFE_OFC804_h13_1 INV1S $PINS O=FE_OFN86_h13_1 I=h13[1]
XFE_OFC802_h12_1 INV2 $PINS O=FE_OFN80_h12_1 I=h12[1]
XFE_OFC795_s33_1 BUF2 $PINS O=FE_OFN118_s33_1 I=s33[1]
XFE_OFC789_s32_0 INV3 $PINS O=FE_OFN113_s32_0 I=s32[0]
XFE_OFC785_h33_3 BUF2 $PINS O=FE_OFN120_h33_3 I=h33[3]
XFE_OFC784_mac_in_imag_10 INV2 $PINS O=FE_OFN227_mac_in_imag_10 I=data_in_i[10]
XFE_OFC779_s31_0 INV1S $PINS O=FE_OFN436_n I=FE_OFN435_n
XFE_OFC776_s31_0 INV1S $PINS O=FE_OFN435_n I=FE_OFN107_s31_0
XFE_OFC773_mac_in_imag_3 INV12 $PINS O=FE_OFN238_mac_in_imag_3 I=data_in_i[3]
XFE_OFC766_s33_0 INV2 $PINS O=FE_OFN119_s33_0 I=s33[0]
XFE_OFC761_mac_in_real_5 BUF12CK $PINS O=FE_OFN427_n I=FE_OFN224_mac_in_real_5
XFE_OFC750_s11_0 INV1S $PINS O=FE_OFN285_s11_0 I=FE_OFN283_s11_0
XFE_OFC748_mac_in_imag_7 INV4 $PINS O=FE_OFN225_mac_in_imag_7 I=data_in_i[7]
XFE_OFC744_h11_1 INV6 $PINS O=FE_OFN74_h11_1 I=h11[1]
XFE_OFC736_s23_1 BUF1 $PINS O=FE_OFN421_s23_1 I=FE_OFN100_s23_1
XFE_OFC735_s23_1 BUF3 $PINS O=FE_OFN100_s23_1 I=s23[1]
XFE_OFC733_s21_1 BUF1 $PINS O=FE_OFN420_s21_1 I=FE_OFN88_s21_1
XFE_OFC732_s21_1 BUF3 $PINS O=FE_OFN88_s21_1 I=s21[1]
XFE_OFC729_h03_1 INV1S $PINS O=FE_OFN68_h03_1 I=h03[1]
XFE_OFC724_s03_0 BUF1 $PINS O=FE_OFN417_s03_0 I=s03[0]
XFE_OFC722_s03_0 INV1S $PINS O=FE_OFN65_s03_0 I=s03[0]
XFE_OFC714_s22_1 BUF4 $PINS O=FE_OFN94_s22_1 I=s22[1]
XFE_OFC713_mac_in_imag_9 INV2 $PINS O=FE_OFN228_mac_in_imag_9 I=data_in_i[9]
XFE_OFC712_h32_1 INV2 $PINS O=FE_OFN412_h32_1 I=FE_OFN116_h32_1
XFE_OFC710_h32_1 BUF2 $PINS O=FE_OFN116_h32_1 I=h32[1]
XFE_OFC709_mac_in_imag_2 INV12 $PINS O=FE_OFN231_mac_in_imag_2 I=data_in_i[2]
XFE_OFC708_mac_in_real_4 INV12 $PINS O=FE_OFN411_mac_in_real_4 I=data_in_r[4]
XFE_OFC704_s31_1 BUF6 $PINS O=FE_OFN106_s31_1 I=s31[1]
XFE_OFC702_s23_0 INV1S $PINS O=FE_OFN408_s23_0 I=FE_OFN101_s23_0
XFE_OFC696_s23_0 BUF1 $PINS O=FE_OFN101_s23_0 I=FE_PHN1809_s23_0
XFE_OFC684_s32_1 BUF4 $PINS O=FE_OFN112_s32_1 I=s32[1]
XFE_OFC682_s12_0 INV1S $PINS O=FE_OFN397_s12_0 I=FE_OFN394_s12_0
XFE_OFC676_s12_0 INV2 $PINS O=FE_OFN77_s12_0 I=s12[0]
XFE_OFC675_mac_in_real_1 INV12 $PINS O=FE_OFN393_mac_in_real_1 I=data_in_r[1]
XFE_OFC668_s21_0 INV1S $PINS O=FE_OFN309_s21_0 I=FE_OFN89_s21_0
XFE_OFC659_s01_0 BUF2 $PINS O=FE_OFN53_s01_0 I=s01[0]
XFE_OFC654_mac_in_imag_4 INV12 $PINS O=FE_OFN253_mac_in_imag_4 I=data_in_i[4]
XFE_OFC644_h21_2 INV1S $PINS O=FE_OFN381_h21_2 I=FE_OFN91_h21_2
XFE_OFC643_h21_2 INV2 $PINS O=FE_OFN91_h21_2 I=h21[2]
XFE_OFC641_s13_0 INV1S $PINS O=FE_OFN355_s13_0 I=FE_OFN83_s13_0
XFE_OFC636_s13_0 INV1S $PINS O=FE_OFN83_s13_0 I=s13[0]
XFE_OFC629_h03_3 INV1S $PINS O=FE_OFN66_h03_3 I=h03[3]
XFE_OFC627_mac_in_imag_1 INV12 $PINS O=FE_OFN246_mac_in_imag_1 I=data_in_i[1]
XFE_OFC624_h22_3 INV2 $PINS O=FE_OFN96_h22_3 I=h22[3]
XFE_OFC618_h22_2 INV2 $PINS O=FE_OFN360_h22_2 I=h22[2]
XFE_OFC616_h31_3 INV2 $PINS O=FE_OFN108_h31_3 I=h31[3]
XFE_OFC610_mac_in_real_2 INV12 $PINS O=FE_OFN370_mac_in_real_2 I=data_in_r[2]
XFE_OFC604_h12_3 INV2 $PINS O=FE_OFN359_h12_3 I=h12[3]
XFE_OFC591_h13_3 INV2 $PINS O=FE_OFN84_h13_3 I=h13[3]
XFE_OFC586_h32_3 INV2 $PINS O=FE_OFN357_h32_3 I=h32[3]
XFE_OFC569_h23_1 INV3 $PINS O=FE_OFN347_h23_1 I=FE_OFN104_h23_1
XFE_OFC565_h23_1 INV3 $PINS O=FE_OFN104_h23_1 I=h23[1]
XFE_OFC552_s01_1 BUF3 $PINS O=FE_OFN52_s01_1 I=s01[1]
XFE_OFC542_h21_1 BUF2 $PINS O=FE_OFN92_h21_1 I=h21[1]
XFE_OFC539_h01_0 BUF2 $PINS O=FE_OFN57_h01_0 I=h01[0]
XFE_OFC538_mac_in_real_3 INV12 $PINS O=FE_OFN334_mac_in_real_3 I=data_in_r[3]
XFE_OFC519_h33_1 BUF2 $PINS O=FE_OFN122_h33_1 I=h33[1]
XFE_OFC516_h02_1 BUF6 $PINS O=FE_OFN62_h02_1 I=h02[1]
XFE_OFC479_h01_3 INV3 $PINS O=FE_OFN54_h01_3 I=h01[3]
XFE_OFC474_h21_3 BUF2 $PINS O=FE_OFN90_h21_3 I=h21[3]
XFE_OFC466_s21_0 BUF1 $PINS O=FE_OFN311_s21_0 I=FE_OFN309_s21_0
XFE_OFC462_s21_0 INV2 $PINS O=FE_OFN89_s21_0 I=s21[0]
XFE_OFC458_mac_in_real_9 INV2 $PINS O=FE_OFN147_mac_in_real_9 I=data_in_r[9]
XFE_OFC455_mac_in_real_8 INV3 $PINS O=FE_OFN148_mac_in_real_8 I=data_in_r[8]
XFE_OFC419_h31_2 BUF2 $PINS O=FE_OFN109_h31_2 I=h31[2]
XFE_OFC411_mac_in_real_7 INV3 $PINS O=FE_OFN222_mac_in_real_7 I=data_in_r[7]
XFE_OFC410_h23_3 BUF1 $PINS O=FE_OFN291_h23_3 I=h23[3]
XFE_OFC409_h23_3 INV1S $PINS O=FE_OFN102_h23_3 I=h23[3]
XFE_OFC395_h33_2 BUF2 $PINS O=FE_OFN121_h33_2 I=h33[2]
XFE_OFC388_s11_0 INV1S $PINS O=FE_OFN283_s11_0 I=s11[0]
XFE_OFC387_s11_0 BUF2 $PINS O=FE_OFN71_s11_0 I=s11[0]
XFE_OFC372_pe_clear_d1 BUF2 $PINS O=FE_OFN280_pe_clear_d1 I=pe_clear
XFE_OFC356_h23_2 INV1S $PINS O=FE_OFN276_h23_2 I=FE_OFN103_h23_2
XFE_OFC354_h23_2 INV1S $PINS O=FE_OFN103_h23_2 I=h23[2]
XFE_OFC306_s31_0 BUF3 $PINS O=FE_OFN107_s31_0 I=s31[0]
XFE_OFC282_h32_2 INV2 $PINS O=FE_OFN115_h32_2 I=h32[2]
XFE_OFC277_h02_3 INV2 $PINS O=FE_OFN60_h02_3 I=h02[3]
XFE_OFC269_h03_2 INV1S $PINS O=FE_OFN67_h03_2 I=h03[2]
XFE_OFC257_mac_in_imag_0 INV12 $PINS O=FE_OFN247_mac_in_imag_0 I=data_in_i[0]
XFE_OFC255_mac_in_real_6 INV1S $PINS O=FE_OFN223_mac_in_real_6 I=data_in_r[6]
XFE_OFC250_FE_DBTN9_n336 BUF1 $PINS O=FE_OFN32_FE_DBTN9_n336
+ I=FE_OFN58_FE_DBTN9_n336
XFE_OFC249_FE_DBTN9_n336 BUF1 $PINS O=FE_RN_1 I=FE_RN_2
XFE_OFC247_FE_DBTN9_n336 BUF1 $PINS O=FE_RN_2 I=p1
XFE_OFC246_mac_in_real_5 INV2 $PINS O=FE_OFN224_mac_in_real_5 I=data_in_r[5]
XFE_OFC244_mac_in_real_11 INV2 $PINS O=FE_OFN242_mac_in_real_11 I=data_in_r[11]
XFE_OFC242_mac_in_real_13 INV2 $PINS O=FE_OFN240_mac_in_real_13 I=data_in_r[13]
XFE_OFC241_mac_in_real_14 INV2 $PINS O=FE_OFN239_mac_in_real_14 I=data_in_r[14]
XFE_OFC239_mac_in_imag_6 INV8 $PINS O=FE_OFN237_mac_in_imag_6 I=data_in_i[6]
XFE_OFC238_mac_in_real_10 INV2 $PINS O=FE_OFN236_mac_in_real_10 I=data_in_r[10]
XFE_OFC237_mac_in_imag_15 INV1CK $PINS O=FE_OFN235_mac_in_imag_15
+ I=data_in_i[15]
XFE_OFC236_mac_in_imag_16 INV2 $PINS O=FE_OFN234_mac_in_imag_16 I=data_in_i[16]
XFE_OFC235_mac_in_imag_14 INV2 $PINS O=FE_OFN233_mac_in_imag_14 I=data_in_i[14]
XFE_OFC234_mac_in_imag_13 INV2 $PINS O=FE_OFN232_mac_in_imag_13 I=data_in_i[13]
XFE_OFC232_mac_in_imag_12 INV2 $PINS O=FE_OFN230_mac_in_imag_12 I=data_in_i[12]
XFE_OFC231_mac_in_imag_11 INV2 $PINS O=FE_OFN229_mac_in_imag_11 I=data_in_i[11]
XFE_OFC151_rom_k_idx_3__2 BUF1 $PINS O=FE_OFN151_rom_k_idx_3__2
+ I=rom_k_idx[3][2]
XFE_OFC150_rom_k_idx_3__3 BUF1 $PINS O=FE_OFN150_rom_k_idx_3__3
+ I=rom_k_idx[3][3]
XFE_OFC149_rom_k_idx_3__4 BUF1 $PINS O=FE_OFN149_rom_k_idx_3__4
+ I=rom_k_idx[3][4]
XFE_OFC99_h22_0 BUF2 $PINS O=FE_OFN99_h22_0 I=h22[0]
XFE_OFC93_h21_0 BUF2 $PINS O=FE_OFN93_h21_0 I=h21[0]
XFE_OFC81_h12_0 BUF2 $PINS O=FE_OFN81_h12_0 I=h12[0]
XFE_OFC76_s12_1 BUF4 $PINS O=FE_OFN76_s12_1 I=s12[1]
XFE_OFC75_h11_0 BUF3 $PINS O=FE_OFN75_h11_0 I=h11[0]
XFE_OFC70_s11_1 BUF6 $PINS O=FE_OFN70_s11_1 I=s11[1]
XFE_OFC69_h03_0 BUF2 $PINS O=FE_OFN69_h03_0 I=h03[0]
XFE_OFC63_h02_0 BUF6 $PINS O=FE_OFN63_h02_0 I=h02[0]
XFE_OFC61_h02_2 BUF4 $PINS O=FE_OFN61_h02_2 I=h02[2]
XFE_OFC58_s02_1 BUF6 $PINS O=FE_OFN58_s02_1 I=s02[1]
XFE_OFC27_i_rst_n BUF2CK $PINS O=FE_OFN27_i_rst_n I=FE_OFN9_i_rst_n
XFE_OFC25_i_rst_n BUF1 $PINS O=FE_OFN25_i_rst_n I=FE_OFN7_i_rst_n
XFE_OFC22_i_rst_n BUF1 $PINS O=FE_OFN22_i_rst_n I=FE_OFN11_i_rst_n
XFE_OFC18_i_rst_n BUF1 $PINS O=FE_OFN18_i_rst_n I=FE_OFN5_i_rst_n
XFE_OFC15_i_rst_n BUF1 $PINS O=FE_OFN15_i_rst_n I=FE_OFN8_i_rst_n
XFE_OFC9_i_rst_n BUF1 $PINS O=FE_OFN9_i_rst_n I=i_rst_n
XFE_OFC7_i_rst_n BUF1 $PINS O=FE_OFN7_i_rst_n I=i_rst_n
XFE_OFC5_i_rst_n BUF1 $PINS O=FE_OFN5_i_rst_n I=i_rst_n
XU20 ND2 $PINS O=rom_n_idx[3][0] I1=FE_OCPN679_n336 I2=n_cnt[0]
XU21 ND2 $PINS O=rom_k_idx[3][1] I1=p1 I2=n_cnt[1]
XU61 MOAI1H $PINS O=rom_n_idx[3][3] A1=g_cnt[1] A2=FE_OCPN679_n336
+ B1=stage_sel_BAR B2=n_cnt[3]
XU66 NR2 $PINS O=rom_n_idx[1][1] I1=n_cnt[1] I2=p1
XU78 ND2S $PINS O=rom_n_idx[3][1] I1=FE_OCPN679_n336 I2=n_cnt[1]
XU79 ND2S $PINS O=rom_k_idx[3][0] I1=p1 I2=n_cnt[0]
XU91 NR2 $PINS O=rom_n_idx[2][0] I1=n_cnt[0] I2=p1
XU92 NR2 $PINS O=rom_k_idx[1][1] I1=n_cnt[1] I2=FE_OCPN679_n336
XU93 NR2 $PINS O=rom_k_idx[2][0] I1=n_cnt[0] I2=FE_OCPN679_n336
XU101 MOAI1S $PINS O=rom_k_idx[3][4] A1=p1 A2=g_cnt[2] B1=n_cnt[4] B2=p1
XU103 MOAI1S $PINS O=rom_k_idx[3][3] A1=p1 A2=g_cnt[1] B1=n_cnt[3] B2=p1
XU104 MOAI1 $PINS O=rom_k_idx[3][2] A1=p1 A2=g_cnt[0] B1=n_cnt[2] B2=p1
Xrom0 ROM_Wrapper_Even_1 $PINS rst_n=rst_n en=en n_in[4]=rom_n_idx[3][4]
+ n_in[3]=rom_n_idx[3][3] n_in[2]=rom_n_idx[3][2] n_in[1]=rom_n_idx[1][1]
+ n_in[0]=rom_n_idx[2][0] k_idx[4]=FE_OFN149_rom_k_idx_3__4
+ k_idx[3]=FE_OFN150_rom_k_idx_3__3 k_idx[2]=FE_OFN151_rom_k_idx_3__2
+ k_idx[1]=rom_k_idx[1][1] k_idx[0]=rom_k_idx[2][0] reg_sign1[1]=s01[1]
+ reg_sign1[0]=s01[0] reg_sign2[1]=s02[1] reg_sign2[0]=s02[0] reg_sign3[1]=s03[1]
+ reg_sign3[0]=s03[0] reg_shift1[3]=h01[3] reg_shift1[2]=h01[2]
+ reg_shift1[1]=h01[1] reg_shift1[0]=h01[0] reg_shift2[3]=h02[3]
+ reg_shift2[2]=h02[2] reg_shift2[1]=h02[1] reg_shift2[0]=h02[0]
+ reg_shift3[3]=h03[3] reg_shift3[2]=h03[2] reg_shift3[1]=h03[1]
+ reg_shift3[0]=h03[0] i_rst_n=i_rst_n FE_OFN14_i_rst_n=FE_OFN9_i_rst_n
+ clk=clk_clone8
Xrom1 ROM_Wrapper_Odd_1 $PINS rst_n=rst_n en=en n_in[4]=rom_n_idx[3][4]
+ n_in[3]=rom_n_idx[3][3] n_in[2]=rom_n_idx[3][2] n_in[1]=rom_n_idx[1][1]
+ n_in[0]=rom_n_idx[3][0] k_idx[4]=FE_OFN149_rom_k_idx_3__4
+ k_idx[3]=FE_OFN150_rom_k_idx_3__3 k_idx[2]=rom_k_idx[3][2]
+ k_idx[1]=rom_k_idx[1][1] k_idx[0]=rom_k_idx[3][0] reg_sign1[1]=s11[1]
+ reg_sign1[0]=s11[0] reg_sign2[1]=s12[1] reg_sign2[0]=s12[0] reg_sign3[1]=s13[1]
+ reg_sign3[0]=s13[0] reg_shift1[3]=h11[3] reg_shift1[2]=h11[2]
+ reg_shift1[1]=h11[1] reg_shift1[0]=h11[0] reg_shift2[3]=h12[3]
+ reg_shift2[2]=h12[2] reg_shift2[1]=h12[1] reg_shift2[0]=h12[0]
+ reg_shift3[3]=h13[3] reg_shift3[2]=h13[2] reg_shift3[1]=h13[1]
+ reg_shift3[0]=h13[0] i_rst_n=FE_OFN8_i_rst_n FE_OFN55_i_rst_n=FE_OFN27_i_rst_n
+ FE_OFN34_i_rst_n=FE_OFN32_i_rst_n FE_OFN30_i_rst_n=FE_OFN15_i_rst_n
+ FE_OFN136_rom_k_idx_3__2=FE_OFN151_rom_k_idx_3__2
+ FE_OFN147_rom_n_idx_3__3=rom_n_idx[3][3] clk=clk_clone8
Xrom2 ROM_Wrapper_Even_0 $PINS rst_n=rst_n en=en n_in[4]=rom_n_idx[3][4]
+ n_in[3]=rom_n_idx[3][3] n_in[2]=rom_n_idx[3][2] n_in[1]=rom_n_idx[3][1]
+ n_in[0]=rom_n_idx[2][0] k_idx[4]=FE_OFN149_rom_k_idx_3__4
+ k_idx[3]=FE_OFN150_rom_k_idx_3__3 k_idx[2]=FE_OFN151_rom_k_idx_3__2
+ k_idx[1]=rom_k_idx[3][1] k_idx[0]=rom_k_idx[2][0] reg_sign1[1]=s21[1]
+ reg_sign1[0]=s21[0] reg_sign2[1]=s22[1] reg_sign2[0]=s22[0] reg_sign3[1]=s23[1]
+ reg_sign3[0]=s23[0] reg_shift1[3]=h21[3] reg_shift1[2]=h21[2]
+ reg_shift1[1]=h21[1] reg_shift1[0]=h21[0] reg_shift2[3]=h22[3]
+ reg_shift2[2]=h22[2] reg_shift2[1]=h22[1] reg_shift2[0]=h22[0]
+ reg_shift3[3]=h23[3] reg_shift3[2]=h23[2] reg_shift3[1]=h23[1]
+ reg_shift3[0]=h23[0] i_rst_n=i_rst_n FE_OFN1_i_rst_n=FE_OFN0_i_rst_n
+ FE_OFN148_rom_n_idx_3__3=rom_n_idx[3][3] clk=clk_clone9
Xrom3 ROM_Wrapper_Odd_0 $PINS rst_n=rst_n en=en n_in[4]=rom_n_idx[3][4]
+ n_in[3]=rom_n_idx[3][3] n_in[2]=rom_n_idx[3][2] n_in[1]=rom_n_idx[3][1]
+ n_in[0]=rom_n_idx[3][0] k_idx[4]=FE_OFN149_rom_k_idx_3__4
+ k_idx[3]=FE_OFN150_rom_k_idx_3__3 k_idx[2]=FE_OFN151_rom_k_idx_3__2
+ k_idx[1]=rom_k_idx[3][1] k_idx[0]=rom_k_idx[3][0] reg_sign1[1]=s31[1]
+ reg_sign1[0]=s31[0] reg_sign2[1]=s32[1] reg_sign2[0]=s32[0] reg_sign3[1]=s33[1]
+ reg_sign3[0]=s33[0] reg_shift1[3]=h31[3] reg_shift1[2]=h31[2]
+ reg_shift1[1]=h31[1] reg_shift1[0]=h31[0] reg_shift2[3]=h32[3]
+ reg_shift2[2]=h32[2] reg_shift2[1]=h32[1] reg_shift2[0]=h32[0]
+ reg_shift3[3]=h33[3] reg_shift3[2]=h33[2] reg_shift3[1]=h33[1]
+ reg_shift3[0]=h33[0] i_rst_n=FE_OFN2_i_rst_n clk=clk_clone9
Xpe0_r PE_Shift_Add_7 $PINS rst_n=rst_n en=en clear=pe_clear calc_done=pe_done
+ stage_sel=FE_RN_1 x_in[16]=data_in_r[16] x_in[15]=data_in_r[15]
+ x_in[14]=FE_OFN239_mac_in_real_14 x_in[13]=FE_OFN240_mac_in_real_13
+ x_in[12]=FE_OFN241_mac_in_real_12 x_in[11]=FE_OFN242_mac_in_real_11
+ x_in[10]=FE_OFN236_mac_in_real_10 x_in[9]=FE_OFN147_mac_in_real_9
+ x_in[8]=FE_OFN148_mac_in_real_8 x_in[7]=FE_OFN222_mac_in_real_7
+ x_in[6]=FE_OFN453_n x_in[5]=FE_OFN427_n x_in[4]=FE_OFN411_mac_in_real_4
+ x_in[3]=FE_OFN334_mac_in_real_3 x_in[2]=FE_OFN370_mac_in_real_2
+ x_in[1]=FE_OFN393_mac_in_real_1 x_in[0]=data_in_r[0] sign1[1]=FE_OFN52_s01_1
+ sign1[0]=FE_OFN53_s01_0 sign2[1]=FE_OFN58_s02_1 sign2[0]=s02[0]
+ sign3[1]=FE_OFN64_s03_1 sign3[0]=s03[0] shf1[3]=FE_OFN54_h01_3 shf1[2]=h01[2]
+ shf1[1]=h01[1] shf1[0]=FE_OFN57_h01_0 shf2[3]=FE_OFN60_h02_3
+ shf2[2]=FE_OFN61_h02_2 shf2[1]=FE_OFN62_h02_1 shf2[0]=FE_OFN63_h02_0
+ shf3[3]=FE_OFN66_h03_3 shf3[2]=FE_OFN67_h03_2 shf3[1]=h03[1]
+ shf3[0]=FE_OFN69_h03_0 y_out[16]=y_out_0_r[16] y_out[15]=y_out_0_r[15]
+ y_out[14]=y_out_0_r[14] y_out[13]=y_out_0_r[13] y_out[12]=y_out_0_r[12]
+ y_out[11]=y_out_0_r[11] y_out[10]=y_out_0_r[10] y_out[9]=y_out_0_r[9]
+ y_out[8]=y_out_0_r[8] y_out[7]=y_out_0_r[7] y_out[6]=y_out_0_r[6]
+ y_out[5]=y_out_0_r[5] y_out[4]=y_out_0_r[4] y_out[3]=y_out_0_r[3]
+ y_out[2]=y_out_0_r[2] y_out[1]=y_out_0_r[1] y_out[0]=y_out_0_r[0]
+ i_rst_n=FE_OFN7_i_rst_n FE_OFN53_i_rst_n=FE_OFN27_i_rst_n
+ FE_OFN47_i_rst_n=FE_OFN25_i_rst_n FE_OFN165_s03_0=FE_OFN417_s03_0
+ FE_OFN163_s03_0=FE_OFN65_s03_0 FE_OFN166_h03_1=FE_OFN68_h03_1 clk_clone1=CTS_13
+ clk=CTS_14 clk_clone2=clk_clone8
Xpe0_i PE_Shift_Add_6 $PINS rst_n=rst_n en=en clear=pe_clear calc_done=pe_done
+ stage_sel=FE_RN_2 x_in[16]=FE_OFN234_mac_in_imag_16
+ x_in[15]=FE_OFN235_mac_in_imag_15 x_in[14]=FE_OFN233_mac_in_imag_14
+ x_in[13]=FE_OFN232_mac_in_imag_13 x_in[12]=FE_OFN230_mac_in_imag_12
+ x_in[11]=FE_OFN229_mac_in_imag_11 x_in[10]=FE_OFN227_mac_in_imag_10
+ x_in[9]=FE_OFN228_mac_in_imag_9 x_in[8]=FE_OFN226_mac_in_imag_8
+ x_in[7]=FE_OFN225_mac_in_imag_7 x_in[6]=FE_OFN237_mac_in_imag_6 x_in[5]=n6
+ x_in[4]=FE_OFN253_mac_in_imag_4 x_in[3]=FE_OFN238_mac_in_imag_3
+ x_in[2]=FE_OFN231_mac_in_imag_2 x_in[1]=FE_OFN246_mac_in_imag_1
+ x_in[0]=FE_OFN247_mac_in_imag_0 sign1[1]=s01[1] sign1[0]=FE_OFN53_s01_0
+ sign2[1]=s02[1] sign2[0]=s02[0] sign3[1]=s03[1] sign3[0]=s03[0] shf1[3]=h01[3]
+ shf1[2]=h01[2] shf1[1]=h01[1] shf1[0]=h01[0] shf2[3]=h02[3] shf2[2]=h02[2]
+ shf2[1]=h02[1] shf2[0]=h02[0] shf3[3]=h03[3] shf3[2]=h03[2]
+ shf3[1]=FE_OFN68_h03_1 shf3[0]=h03[0] y_out[16]=y_out_0_i[16]
+ y_out[15]=y_out_0_i[15] y_out[14]=y_out_0_i[14] y_out[13]=y_out_0_i[13]
+ y_out[12]=y_out_0_i[12] y_out[11]=y_out_0_i[11] y_out[10]=y_out_0_i[10]
+ y_out[9]=y_out_0_i[9] y_out[8]=y_out_0_i[8] y_out[7]=y_out_0_i[7]
+ y_out[6]=y_out_0_i[6] y_out[5]=y_out_0_i[5] y_out[4]=y_out_0_i[4]
+ y_out[3]=y_out_0_i[3] y_out[2]=y_out_0_i[2] y_out[1]=y_out_0_i[1]
+ y_out[0]=y_out_0_i[0] i_rst_n=FE_OFN7_i_rst_n FE_OFN52_i_rst_n=FE_OFN27_i_rst_n
+ FE_OFN31_i_rst_n=FE_OFN15_i_rst_n FE_OFN15_i_rst_n=FE_OFN9_i_rst_n
+ FE_OFN60_FE_DBTN9_n336=FE_RN_1 FE_OFN64_s01_1=FE_OFN52_s01_1
+ FE_OFN65_s01_0=FE_OFN53_s01_0 FE_OFN66_h01_3=FE_OFN54_h01_3
+ FE_OFN67_h01_2=h01[2] FE_OFN68_h01_1=FE_OFN56_h01_1
+ FE_OFN69_h01_0=FE_OFN57_h01_0 FE_OFN70_s02_1=FE_OFN58_s02_1
+ FE_OFN71_h02_3=FE_OFN60_h02_3 FE_OFN72_h02_2=FE_OFN61_h02_2
+ FE_OFN73_h02_1=FE_OFN62_h02_1 FE_OFN74_h02_0=FE_OFN63_h02_0
+ FE_OFN75_s03_1=FE_OFN64_s03_1 FE_OFN76_s03_0=FE_OFN65_s03_0
+ FE_OFN77_h03_3=FE_OFN66_h03_3 FE_OFN78_h03_2=FE_OFN67_h03_2
+ FE_OFN79_h03_1=h03[1] FE_OFN80_h03_0=FE_OFN69_h03_0 FE_OFN144_s02_0=s02[0]
+ FE_OFN164_s03_0=FE_OFN417_s03_0 clk=CTS_14 clk_clone1=clk_clone7
Xpe1_r PE_Shift_Add_5 $PINS rst_n=rst_n en=en clear=FE_OFN280_pe_clear_d1
+ calc_done=pe_done stage_sel=FE_OFN32_FE_DBTN9_n336 x_in[16]=data_in_r[16]
+ x_in[15]=data_in_r[15] x_in[14]=FE_OFN239_mac_in_real_14
+ x_in[13]=FE_OFN240_mac_in_real_13 x_in[12]=FE_OFN241_mac_in_real_12
+ x_in[11]=FE_OFN242_mac_in_real_11 x_in[10]=FE_OFN236_mac_in_real_10
+ x_in[9]=FE_OFN147_mac_in_real_9 x_in[8]=FE_OFN148_mac_in_real_8
+ x_in[7]=FE_OFN222_mac_in_real_7 x_in[6]=FE_OFN453_n x_in[5]=FE_OFN427_n
+ x_in[4]=FE_OFN411_mac_in_real_4 x_in[3]=FE_OFN334_mac_in_real_3
+ x_in[2]=FE_OFN370_mac_in_real_2 x_in[1]=FE_OFN393_mac_in_real_1
+ x_in[0]=data_in_r[0] sign1[1]=FE_OFN70_s11_1 sign1[0]=FE_OFN285_s11_0
+ sign2[1]=FE_OFN76_s12_1 sign2[0]=FE_OFN77_s12_0 sign3[1]=FE_OFN82_s13_1
+ sign3[0]=s13[0] shf1[3]=h11[3] shf1[2]=h11[2] shf1[1]=h11[1]
+ shf1[0]=FE_OFN75_h11_0 shf2[3]=FE_OFN359_h12_3 shf2[2]=h12[2] shf2[1]=h12[1]
+ shf2[0]=FE_OFN81_h12_0 shf3[3]=FE_OFN84_h13_3 shf3[2]=FE_OFN85_h13_2
+ shf3[1]=h13[1] shf3[0]=h13[0] y_out[16]=y_out_1_r[16] y_out[15]=y_out_1_r[15]
+ y_out[14]=y_out_1_r[14] y_out[13]=y_out_1_r[13] y_out[12]=y_out_1_r[12]
+ y_out[11]=y_out_1_r[11] y_out[10]=y_out_1_r[10] y_out[9]=y_out_1_r[9]
+ y_out[8]=y_out_1_r[8] y_out[7]=y_out_1_r[7] y_out[6]=y_out_1_r[6]
+ y_out[5]=y_out_1_r[5] y_out[4]=y_out_1_r[4] y_out[3]=y_out_1_r[3]
+ y_out[2]=y_out_1_r[2] y_out[1]=y_out_1_r[1] y_out[0]=y_out_1_r[0]
+ i_rst_n=FE_OFN5_i_rst_n FE_OFN48_i_rst_n=FE_OFN25_i_rst_n
+ FE_OFN36_i_rst_n=FE_OFN18_i_rst_n FE_OFN83_s11_0=FE_OFN71_s11_0
+ FE_OFN149_h12_1=FE_OFN80_h12_1 FE_OFN152_s13_0=FE_OFN355_s13_0
+ FE_OFN156_s12_0=FE_OFN397_s12_0 FE_OFN154_s12_0=FE_OFN394_s12_0
+ FE_OFN169_h11_1=FE_OFN74_h11_1 FE_OFN173_h13_1=FE_OFN86_h13_1
+ FE_OFN174_h11_3=FE_OFN72_h11_3 clk_clone1=clk_clone6 clk_clone2=CTS_13
+ clk=clk_clone2
Xpe1_i PE_Shift_Add_4 $PINS rst_n=rst_n en=en clear=FE_OFN280_pe_clear_d1
+ calc_done=pe_done stage_sel=FE_OFN58_FE_DBTN9_n336
+ x_in[16]=FE_OFN234_mac_in_imag_16 x_in[15]=FE_OFN235_mac_in_imag_15
+ x_in[14]=FE_OFN233_mac_in_imag_14 x_in[13]=FE_OFN232_mac_in_imag_13
+ x_in[12]=FE_OFN230_mac_in_imag_12 x_in[11]=FE_OFN229_mac_in_imag_11
+ x_in[10]=FE_OFN227_mac_in_imag_10 x_in[9]=FE_OFN228_mac_in_imag_9
+ x_in[8]=FE_OFN226_mac_in_imag_8 x_in[7]=FE_OFN225_mac_in_imag_7
+ x_in[6]=FE_OFN237_mac_in_imag_6 x_in[5]=n6 x_in[4]=FE_OFN253_mac_in_imag_4
+ x_in[3]=FE_OFN238_mac_in_imag_3 x_in[2]=FE_OFN231_mac_in_imag_2
+ x_in[1]=FE_OFN246_mac_in_imag_1 x_in[0]=FE_OFN247_mac_in_imag_0 sign1[1]=s11[1]
+ sign1[0]=s11[0] sign2[1]=s12[1] sign2[0]=FE_OFN77_s12_0 sign3[1]=s13[1]
+ sign3[0]=FE_OFN83_s13_0 shf1[3]=FE_OFN72_h11_3 shf1[2]=h11[2]
+ shf1[1]=FE_OFN74_h11_1 shf1[0]=h11[0] shf2[3]=FE_OFN359_h12_3 shf2[2]=h12[2]
+ shf2[1]=FE_OFN80_h12_1 shf2[0]=h12[0] shf3[3]=h13[3] shf3[2]=h13[2]
+ shf3[1]=FE_OFN86_h13_1 shf3[0]=h13[0] y_out[16]=y_out_1_i[16]
+ y_out[15]=y_out_1_i[15] y_out[14]=y_out_1_i[14] y_out[13]=y_out_1_i[13]
+ y_out[12]=y_out_1_i[12] y_out[11]=y_out_1_i[11] y_out[10]=y_out_1_i[10]
+ y_out[9]=y_out_1_i[9] y_out[8]=y_out_1_i[8] y_out[7]=y_out_1_i[7]
+ y_out[6]=y_out_1_i[6] y_out[5]=y_out_1_i[5] y_out[4]=y_out_1_i[4]
+ y_out[3]=y_out_1_i[3] y_out[2]=y_out_1_i[2] y_out[1]=y_out_1_i[1]
+ y_out[0]=y_out_1_i[0] i_rst_n=FE_OFN5_i_rst_n FE_OFN40_i_rst_n=FE_OFN39_i_rst_n
+ FE_OFN37_i_rst_n=FE_OFN18_i_rst_n FE_OFN35_i_rst_n=FE_OFN32_i_rst_n
+ FE_OFN61_FE_DBTN9_n336=FE_OFN32_FE_DBTN9_n336 FE_OFN81_s11_1=FE_OFN70_s11_1
+ FE_OFN82_s11_0=FE_OFN71_s11_0 FE_OFN84_h11_3=h11[3] FE_OFN85_h11_2=h11[2]
+ FE_OFN86_h11_1=h11[1] FE_OFN87_h11_0=FE_OFN75_h11_0
+ FE_OFN88_s12_1=FE_OFN76_s12_1 FE_OFN89_s12_0=FE_OFN77_s12_0
+ FE_OFN90_h12_3=FE_OFN78_h12_3 FE_OFN91_h12_2=FE_OFN79_h12_2
+ FE_OFN92_h12_1=h12[1] FE_OFN93_h12_0=FE_OFN81_h12_0
+ FE_OFN94_s13_1=FE_OFN82_s13_1 FE_OFN95_s13_0=s13[0]
+ FE_OFN96_h13_3=FE_OFN84_h13_3 FE_OFN97_h13_2=FE_OFN85_h13_2
+ FE_OFN98_h13_1=h13[1] FE_OFN99_h13_0=h13[0] FE_OFN140_s11_0=FE_OFN285_s11_0
+ FE_OFN139_s11_0=FE_OFN283_s11_0 FE_OFN151_s13_0=FE_OFN355_s13_0
+ FE_OFN157_s12_0=FE_OFN397_s12_0 FE_OFN155_s12_0=FE_OFN394_s12_0
+ clk_clone1=clk_clone6 clk=clk_clone1
Xpe2_r PE_Shift_Add_3 $PINS rst_n=rst_n en=en clear=pe_clear calc_done=pe_done
+ stage_sel=FE_RN_2 x_in[16]=data_in_r[16] x_in[15]=data_in_r[15]
+ x_in[14]=FE_OFN239_mac_in_real_14 x_in[13]=FE_OFN240_mac_in_real_13
+ x_in[12]=FE_OFN241_mac_in_real_12 x_in[11]=FE_OFN242_mac_in_real_11
+ x_in[10]=FE_OFN236_mac_in_real_10 x_in[9]=FE_OFN147_mac_in_real_9
+ x_in[8]=FE_OFN148_mac_in_real_8 x_in[7]=FE_OFN222_mac_in_real_7
+ x_in[6]=FE_OFN453_n x_in[5]=FE_OFN427_n x_in[4]=data_in_r[4]
+ x_in[3]=data_in_r[3] x_in[2]=data_in_r[2] x_in[1]=data_in_r[1]
+ x_in[0]=data_in_r[0] sign1[1]=FE_OFN88_s21_1 sign1[0]=FE_OFN89_s21_0
+ sign2[1]=FE_OFN94_s22_1 sign2[0]=s22[0] sign3[1]=FE_OFN100_s23_1
+ sign3[0]=FE_PHN1809_s23_0 shf1[3]=FE_OFN90_h21_3 shf1[2]=FE_OFN91_h21_2
+ shf1[1]=FE_OFN92_h21_1 shf1[0]=FE_OFN93_h21_0 shf2[3]=h22[3]
+ shf2[2]=FE_OFN360_h22_2 shf2[1]=h22[1] shf2[0]=FE_OFN99_h22_0 shf3[3]=h23[3]
+ shf3[2]=FE_OFN276_h23_2 shf3[1]=FE_OFN347_h23_1 shf3[0]=h23[0]
+ y_out[16]=y_out_2_r[16] y_out[15]=y_out_2_r[15] y_out[14]=y_out_2_r[14]
+ y_out[13]=y_out_2_r[13] y_out[12]=y_out_2_r[12] y_out[11]=y_out_2_r[11]
+ y_out[10]=y_out_2_r[10] y_out[9]=y_out_2_r[9] y_out[8]=y_out_2_r[8]
+ y_out[7]=y_out_2_r[7] y_out[6]=y_out_2_r[6] y_out[5]=y_out_2_r[5]
+ y_out[4]=y_out_2_r[4] y_out[3]=y_out_2_r[3] y_out[2]=y_out_2_r[2]
+ y_out[1]=y_out_2_r[1] y_out[0]=y_out_2_r[0] i_rst_n=i_rst_n
+ FE_OFN54_i_rst_n=FE_OFN27_i_rst_n FE_OFN29_i_rst_n=FE_OFN15_i_rst_n
+ FE_OFN13_i_rst_n=FE_OFN9_i_rst_n FE_OFN9_i_rst_n=FE_OFN8_i_rst_n
+ FE_OFN108_h22_3=FE_OFN96_h22_3 FE_OFN115_h23_2=h23[2]
+ FE_OFN116_h23_1=FE_OFN104_h23_1 FE_OFN117_h23_0=h23[0]
+ FE_OFN143_h23_3=FE_OFN291_h23_3 FE_OFN141_h23_3=FE_OFN102_h23_3
+ FE_OFN146_s21_0=FE_OFN311_s21_0 FE_OFN153_h21_2=FE_OFN381_h21_2
+ FE_OFN160_s23_0=FE_OFN408_s23_0 FE_OFN158_s23_0=FE_OFN101_s23_0
+ FE_OFN167_s21_1=FE_OFN420_s21_1 FE_OFN168_s23_1=FE_OFN421_s23_1
+ FE_OFN393_mac_in_real_1=FE_OFN393_mac_in_real_1
+ FE_OFN411_mac_in_real_4=FE_OFN411_mac_in_real_4
+ FE_OFN334_mac_in_real_3=FE_OFN334_mac_in_real_3
+ FE_OFN370_mac_in_real_2=FE_OFN370_mac_in_real_2 clk=clk_clone5
+ clk_clone1=CTS_14 clk_clone2=clk_clone7
Xpe2_i PE_Shift_Add_2 $PINS rst_n=rst_n en=en clear=pe_clear calc_done=pe_done
+ stage_sel=p1 x_in[16]=FE_OFN234_mac_in_imag_16
+ x_in[15]=FE_OFN235_mac_in_imag_15 x_in[14]=FE_OFN233_mac_in_imag_14
+ x_in[13]=FE_OFN232_mac_in_imag_13 x_in[12]=FE_OFN230_mac_in_imag_12
+ x_in[11]=FE_OFN229_mac_in_imag_11 x_in[10]=FE_OFN227_mac_in_imag_10
+ x_in[9]=FE_OFN228_mac_in_imag_9 x_in[8]=FE_OFN226_mac_in_imag_8
+ x_in[7]=FE_OFN225_mac_in_imag_7 x_in[6]=FE_OFN237_mac_in_imag_6 x_in[5]=n6
+ x_in[4]=FE_OFN253_mac_in_imag_4 x_in[3]=FE_OFN238_mac_in_imag_3
+ x_in[2]=FE_OFN231_mac_in_imag_2 x_in[1]=FE_OFN246_mac_in_imag_1
+ x_in[0]=FE_OFN247_mac_in_imag_0 sign1[1]=FE_OFN88_s21_1
+ sign1[0]=FE_OFN309_s21_0 sign2[1]=s22[1] sign2[0]=s22[0]
+ sign3[1]=FE_OFN421_s23_1 sign3[0]=FE_OFN101_s23_0 shf1[3]=h21[3]
+ shf1[2]=FE_OFN91_h21_2 shf1[1]=FE_OFN92_h21_1 shf1[0]=h21[0]
+ shf2[3]=FE_OFN96_h22_3 shf2[2]=FE_OFN360_h22_2 shf2[1]=h22[1] shf2[0]=h22[0]
+ shf3[3]=FE_OFN102_h23_3 shf3[2]=FE_OFN103_h23_2 shf3[1]=FE_OFN347_h23_1
+ shf3[0]=h23[0] y_out[16]=y_out_2_i[16] y_out[15]=y_out_2_i[15]
+ y_out[14]=y_out_2_i[14] y_out[13]=y_out_2_i[13] y_out[12]=y_out_2_i[12]
+ y_out[11]=y_out_2_i[11] y_out[10]=y_out_2_i[10] y_out[9]=y_out_2_i[9]
+ y_out[8]=y_out_2_i[8] y_out[7]=y_out_2_i[7] y_out[6]=y_out_2_i[6]
+ y_out[5]=y_out_2_i[5] y_out[4]=y_out_2_i[4] y_out[3]=y_out_2_i[3]
+ y_out[2]=y_out_2_i[2] y_out[1]=y_out_2_i[1] y_out[0]=y_out_2_i[0]
+ i_rst_n=FE_OFN0_i_rst_n FE_OFN33_i_rst_n=FE_OFN32_i_rst_n
+ FE_OFN17_i_rst_n=FE_OFN16_i_rst_n FE_OFN10_i_rst_n=FE_OFN8_i_rst_n
+ FE_OFN59_FE_DBTN9_n336=FE_OFN58_FE_DBTN9_n336 FE_OFN57_FE_DBTN9_n336=FE_RN_2
+ FE_OFN100_s21_1=FE_OFN420_s21_1 FE_OFN101_s21_0=FE_OFN89_s21_0
+ FE_OFN102_h21_3=FE_OFN90_h21_3 FE_OFN103_h21_2=FE_OFN381_h21_2
+ FE_OFN104_h21_1=FE_OFN92_h21_1 FE_OFN105_h21_0=FE_OFN93_h21_0
+ FE_OFN106_s22_1=FE_OFN94_s22_1 FE_OFN107_s22_0=s22[0]
+ FE_OFN109_h22_2=FE_OFN360_h22_2 FE_OFN110_h22_1=h22[1]
+ FE_OFN111_h22_0=FE_OFN99_h22_0 FE_OFN112_s23_1=FE_OFN100_s23_1
+ FE_OFN113_s23_0=FE_PHN1809_s23_0 FE_OFN114_h23_3=h23[3]
+ FE_OFN138_h23_2=FE_OFN276_h23_2 FE_OFN142_h23_3=FE_OFN291_h23_3
+ FE_OFN145_s21_0=FE_OFN311_s21_0 FE_OFN159_s23_0=FE_OFN408_s23_0
+ clk_clone1=clk_clone5 clk=clk_clone2
Xpe3_r PE_Shift_Add_1 $PINS rst_n=rst_n en=en clear=FE_OFN280_pe_clear_d1
+ calc_done=pe_done stage_sel=FE_OFN58_FE_DBTN9_n336 x_in[16]=data_in_r[16]
+ x_in[15]=data_in_r[15] x_in[14]=FE_OFN239_mac_in_real_14
+ x_in[13]=FE_OFN240_mac_in_real_13 x_in[12]=FE_OFN241_mac_in_real_12
+ x_in[11]=FE_OFN242_mac_in_real_11 x_in[10]=FE_OFN236_mac_in_real_10
+ x_in[9]=FE_OFN147_mac_in_real_9 x_in[8]=FE_OFN148_mac_in_real_8
+ x_in[7]=FE_OFN222_mac_in_real_7 x_in[6]=FE_OFN453_n x_in[5]=FE_OFN427_n
+ x_in[4]=data_in_r[4] x_in[3]=data_in_r[3] x_in[2]=data_in_r[2]
+ x_in[1]=data_in_r[1] x_in[0]=data_in_r[0] sign1[1]=FE_OFN106_s31_1
+ sign1[0]=FE_OFN107_s31_0 sign2[1]=FE_OFN112_s32_1 sign2[0]=FE_OFN113_s32_0
+ sign3[1]=FE_OFN118_s33_1 sign3[0]=FE_OFN119_s33_0 shf1[3]=h31[3]
+ shf1[2]=FE_OFN109_h31_2 shf1[1]=h31[1] shf1[0]=FE_OFN111_h31_0
+ shf2[3]=FE_OFN357_h32_3 shf2[2]=FE_OFN115_h32_2 shf2[1]=FE_OFN116_h32_1
+ shf2[0]=h32[0] shf3[3]=FE_OFN120_h33_3 shf3[2]=FE_OFN121_h33_2
+ shf3[1]=FE_OFN122_h33_1 shf3[0]=FE_OFN123_h33_0 y_out[16]=y_out_3_r[16]
+ y_out[15]=y_out_3_r[15] y_out[14]=y_out_3_r[14] y_out[13]=y_out_3_r[13]
+ y_out[12]=y_out_3_r[12] y_out[11]=y_out_3_r[11] y_out[10]=y_out_3_r[10]
+ y_out[9]=y_out_3_r[9] y_out[8]=y_out_3_r[8] y_out[7]=y_out_3_r[7]
+ y_out[6]=y_out_3_r[6] y_out[5]=y_out_3_r[5] y_out[4]=y_out_3_r[4]
+ y_out[3]=y_out_3_r[3] y_out[2]=y_out_3_r[2] y_out[1]=y_out_3_r[1]
+ y_out[0]=y_out_3_r[0] i_rst_n=FE_OFN11_i_rst_n
+ FE_OFN46_i_rst_n=FE_OFN45_i_rst_n FE_OFN44_i_rst_n=FE_OFN22_i_rst_n
+ FE_OFN150_h31_3=FE_OFN108_h31_3 FE_OFN162_h32_1=FE_OFN412_h32_1
+ FE_OFN171_n=FE_OFN436_n FE_OFN393_mac_in_real_1=FE_OFN393_mac_in_real_1
+ FE_OFN411_mac_in_real_4=FE_OFN411_mac_in_real_4
+ FE_OFN334_mac_in_real_3=FE_OFN334_mac_in_real_3
+ FE_OFN370_mac_in_real_2=FE_OFN370_mac_in_real_2 clk_clone1=clk_clone4 clk=clk
Xpe3_i PE_Shift_Add_0 $PINS rst_n=rst_n en=en clear=FE_OFN280_pe_clear_d1
+ calc_done=pe_done stage_sel=FE_OFN58_FE_DBTN9_n336
+ x_in[16]=FE_OFN234_mac_in_imag_16 x_in[15]=FE_OFN235_mac_in_imag_15
+ x_in[14]=FE_OFN233_mac_in_imag_14 x_in[13]=FE_OFN232_mac_in_imag_13
+ x_in[12]=FE_OFN230_mac_in_imag_12 x_in[11]=FE_OFN229_mac_in_imag_11
+ x_in[10]=data_in_i[10] x_in[9]=FE_OFN228_mac_in_imag_9
+ x_in[8]=FE_OFN226_mac_in_imag_8 x_in[7]=FE_OFN225_mac_in_imag_7
+ x_in[6]=FE_OFN237_mac_in_imag_6 x_in[5]=n6 x_in[4]=FE_OFN253_mac_in_imag_4
+ x_in[3]=FE_OFN238_mac_in_imag_3 x_in[2]=FE_OFN231_mac_in_imag_2
+ x_in[1]=FE_OFN246_mac_in_imag_1 x_in[0]=data_in_i[0] sign1[1]=s31[1]
+ sign1[0]=FE_OFN107_s31_0 sign2[1]=s32[1] sign2[0]=FE_OFN113_s32_0
+ sign3[1]=FE_OFN118_s33_1 sign3[0]=FE_OFN119_s33_0 shf1[3]=FE_OFN108_h31_3
+ shf1[2]=h31[2] shf1[1]=h31[1] shf1[0]=FE_OFN111_h31_0 shf2[3]=FE_OFN357_h32_3
+ shf2[2]=h32[2] shf2[1]=h32[1] shf2[0]=h32[0] shf3[3]=FE_OFN120_h33_3
+ shf3[2]=h33[2] shf3[1]=FE_OFN122_h33_1 shf3[0]=FE_OFN123_h33_0
+ y_out[16]=y_out_3_i[16] y_out[15]=y_out_3_i[15] y_out[14]=y_out_3_i[14]
+ y_out[13]=y_out_3_i[13] y_out[12]=y_out_3_i[12] y_out[11]=y_out_3_i[11]
+ y_out[10]=y_out_3_i[10] y_out[9]=y_out_3_i[9] y_out[8]=y_out_3_i[8]
+ y_out[7]=y_out_3_i[7] y_out[6]=y_out_3_i[6] y_out[5]=y_out_3_i[5]
+ y_out[4]=y_out_3_i[4] y_out[3]=y_out_3_i[3] y_out[2]=y_out_3_i[2]
+ y_out[1]=y_out_3_i[1] y_out[0]=y_out_3_i[0] i_rst_n=FE_OFN11_i_rst_n
+ FE_OFN43_i_rst_n=FE_OFN22_i_rst_n FE_OFN42_i_rst_n=FE_OFN41_i_rst_n
+ FE_OFN38_i_rst_n=FE_OFN18_i_rst_n FE_OFN24_i_rst_n=FE_OFN23_i_rst_n
+ FE_OFN63_FE_DBTN9_n336=FE_RN_2 FE_OFN118_s31_1=FE_OFN106_s31_1
+ FE_OFN119_s31_0=FE_OFN107_s31_0 FE_OFN120_h31_3=h31[3]
+ FE_OFN121_h31_2=FE_OFN109_h31_2 FE_OFN122_h31_1=h31[1] FE_OFN123_h31_0=h31[0]
+ FE_OFN124_s32_1=FE_OFN112_s32_1 FE_OFN125_s32_0=FE_OFN113_s32_0
+ FE_OFN126_h32_3=FE_OFN114_h32_3 FE_OFN127_h32_2=FE_OFN115_h32_2
+ FE_OFN128_h32_1=FE_OFN116_h32_1 FE_OFN129_h32_0=h32[0]
+ FE_OFN130_s33_1=FE_OFN118_s33_1 FE_OFN131_s33_0=FE_OFN119_s33_0
+ FE_OFN132_h33_3=FE_OFN120_h33_3 FE_OFN133_h33_2=FE_OFN121_h33_2
+ FE_OFN134_h33_1=FE_OFN122_h33_1 FE_OFN135_h33_0=h33[0]
+ FE_OFN161_h32_1=FE_OFN412_h32_1 FE_OFN172_n=FE_OFN436_n FE_OFN170_n=FE_OFN435_n
+ FE_OFN247_mac_in_imag_0=FE_OFN247_mac_in_imag_0
+ FE_OFN227_mac_in_imag_10=FE_OFN227_mac_in_imag_10 clk_clone3=clk_clone6
+ clk_clone2=clk_clone4 clk_clone1=clk_clone3 clk=clk_clone1
.ENDS

.SUBCKT SNPS_CLOCK_GATE_HIGH_RegFileDual_DATA_WIDTH34_0 EN ENCLK CLK
*.CONNECT net1881 EN
XFE_PHC1322_net1884 DELC $PINS O=FE_PHN1322_net1884 I=net1884
Xlatch QDBHN $PINS Q=net1884 D=net1881 CKB=CLK
Xmain_gate AN2T $PINS O=ENCLK I1=FE_PHN1322_net1884 I2=CLK
.ENDS

.SUBCKT SNPS_CLOCK_GATE_HIGH_RegFileDual_DATA_WIDTH34_63 EN ENCLK CLK
*.CONNECT net1881 EN
XFE_PHC1363_net1884 DELC $PINS O=net1884 I=FE_PHN1363_net1884
Xlatch QDBHN $PINS Q=FE_PHN1363_net1884 D=net1881 CKB=CLK
Xmain_gate AN2T $PINS O=ENCLK I1=net1884 I2=CLK
.ENDS

.SUBCKT SNPS_CLOCK_GATE_HIGH_RegFileDual_DATA_WIDTH34_62 EN ENCLK CLK
*.CONNECT net1881 EN
XFE_PHC1360_net1884 DELC $PINS O=FE_PHN1360_net1884 I=net1884
Xlatch QDBHN $PINS Q=net1884 D=net1881 CKB=CLK
Xmain_gate AN2T $PINS O=ENCLK I1=FE_PHN1360_net1884 I2=CLK
.ENDS

.SUBCKT SNPS_CLOCK_GATE_HIGH_RegFileDual_DATA_WIDTH34_61 EN ENCLK CLK
*.CONNECT net1881 EN
XFE_PHC1334_net1884 DELC $PINS O=net1884 I=FE_PHN1334_net1884
Xlatch QDBHN $PINS Q=FE_PHN1334_net1884 D=net1881 CKB=CLK
Xmain_gate AN2T $PINS O=ENCLK I1=net1884 I2=CLK
.ENDS

.SUBCKT SNPS_CLOCK_GATE_HIGH_RegFileDual_DATA_WIDTH34_60 EN ENCLK CLK
*.CONNECT net1881 EN
XFE_PHC1338_net1884 DELC $PINS O=net1884 I=FE_PHN1338_net1884
Xlatch QDBHN $PINS Q=FE_PHN1338_net1884 D=net1881 CKB=CLK
Xmain_gate AN2T $PINS O=ENCLK I1=net1884 I2=CLK
.ENDS

.SUBCKT SNPS_CLOCK_GATE_HIGH_RegFileDual_DATA_WIDTH34_59 EN ENCLK CLK
*.CONNECT net1881 EN
XFE_PHC1359_net1884 DELC $PINS O=FE_PHN1359_net1884 I=net1884
Xlatch QDBHN $PINS Q=net1884 D=net1881 CKB=CLK
Xmain_gate AN2T $PINS O=ENCLK I1=FE_PHN1359_net1884 I2=CLK
.ENDS

.SUBCKT SNPS_CLOCK_GATE_HIGH_RegFileDual_DATA_WIDTH34_58 EN ENCLK CLK
*.CONNECT net1881 EN
XFE_PHC1345_net1884 DELC $PINS O=FE_PHN1345_net1884 I=net1884
Xlatch QDBHN $PINS Q=net1884 D=net1881 CKB=CLK
Xmain_gate AN2T $PINS O=ENCLK I1=FE_PHN1345_net1884 I2=CLK
.ENDS

.SUBCKT SNPS_CLOCK_GATE_HIGH_RegFileDual_DATA_WIDTH34_57 EN ENCLK CLK
*.CONNECT net1881 EN
XFE_PHC1358_net1884 DELC $PINS O=FE_PHN1358_net1884 I=net1884
Xlatch QDBHN $PINS Q=net1884 D=net1881 CKB=CLK
Xmain_gate AN2T $PINS O=ENCLK I1=FE_PHN1358_net1884 I2=CLK
.ENDS

.SUBCKT SNPS_CLOCK_GATE_HIGH_RegFileDual_DATA_WIDTH34_56 EN ENCLK CLK
*.CONNECT net1881 EN
XFE_PHC1347_net1884 DELC $PINS O=FE_PHN1347_net1884 I=net1884
Xlatch QDBHN $PINS Q=net1884 D=net1881 CKB=CLK
Xmain_gate AN2T $PINS O=ENCLK I1=FE_PHN1347_net1884 I2=CLK
.ENDS

.SUBCKT SNPS_CLOCK_GATE_HIGH_RegFileDual_DATA_WIDTH34_55 EN ENCLK CLK
*.CONNECT net1881 EN
XFE_PHC1323_net1884 DELC $PINS O=net1884 I=FE_PHN1323_net1884
Xlatch QDBHN $PINS Q=FE_PHN1323_net1884 D=net1881 CKB=CLK
Xmain_gate AN2T $PINS O=ENCLK I1=net1884 I2=CLK
.ENDS

.SUBCKT SNPS_CLOCK_GATE_HIGH_RegFileDual_DATA_WIDTH34_54 EN ENCLK CLK
*.CONNECT net1881 EN
XFE_PHC1339_net1884 DELC $PINS O=FE_PHN1339_net1884 I=net1884
Xlatch QDBHN $PINS Q=net1884 D=net1881 CKB=CLK
Xmain_gate AN2T $PINS O=ENCLK I1=FE_PHN1339_net1884 I2=CLK
.ENDS

.SUBCKT SNPS_CLOCK_GATE_HIGH_RegFileDual_DATA_WIDTH34_53 EN ENCLK CLK
*.CONNECT net1881 EN
XFE_PHC1349_net1884 DELC $PINS O=FE_PHN1349_net1884 I=net1884
Xlatch QDBHN $PINS Q=net1884 D=net1881 CKB=CLK
Xmain_gate AN2T $PINS O=ENCLK I1=FE_PHN1349_net1884 I2=CLK
.ENDS

.SUBCKT SNPS_CLOCK_GATE_HIGH_RegFileDual_DATA_WIDTH34_52 CLK EN ENCLK
+ CLK_clone1
*.CONNECT net1878 CLK
*.CONNECT net1881 EN
XFE_PHC1305_net1884 DELC $PINS O=FE_PHN1305_net1884 I=net1884
Xlatch QDBHN $PINS Q=net1884 D=net1881 CKB=CLK_clone1
Xmain_gate AN2T $PINS O=ENCLK I1=FE_PHN1305_net1884 I2=net1878
.ENDS

.SUBCKT SNPS_CLOCK_GATE_HIGH_RegFileDual_DATA_WIDTH34_51 EN ENCLK CLK
*.CONNECT net1881 EN
XFE_PHC1341_net1884 DELC $PINS O=FE_PHN1341_net1884 I=net1884
Xlatch QDBHN $PINS Q=net1884 D=net1881 CKB=CLK
Xmain_gate AN2T $PINS O=ENCLK I1=FE_PHN1341_net1884 I2=CLK
.ENDS

.SUBCKT SNPS_CLOCK_GATE_HIGH_RegFileDual_DATA_WIDTH34_50 CLK EN ENCLK
+ CLK_clone1
*.CONNECT net1878 CLK
*.CONNECT net1881 EN
XFE_PHC1362_net1884 DELC $PINS O=FE_PHN1362_net1884 I=net1884
Xlatch QDBHN $PINS Q=net1884 D=net1881 CKB=net1878
Xmain_gate AN2T $PINS O=ENCLK I1=FE_PHN1362_net1884 I2=CLK_clone1
.ENDS

.SUBCKT SNPS_CLOCK_GATE_HIGH_RegFileDual_DATA_WIDTH34_49 EN ENCLK CLK
*.CONNECT net1881 EN
XFE_PHC1329_net1884 DELC $PINS O=FE_PHN1329_net1884 I=net1884
Xlatch QDBHN $PINS Q=net1884 D=net1881 CKB=CLK
Xmain_gate AN2T $PINS O=ENCLK I1=FE_PHN1329_net1884 I2=CLK
.ENDS

.SUBCKT SNPS_CLOCK_GATE_HIGH_RegFileDual_DATA_WIDTH34_48 EN ENCLK CLK
*.CONNECT net1881 EN
XFE_PHC1327_net1884 DELC $PINS O=FE_PHN1327_net1884 I=net1884
Xlatch QDBHN $PINS Q=net1884 D=net1881 CKB=CLK
Xmain_gate AN2T $PINS O=ENCLK I1=FE_PHN1327_net1884 I2=CLK
.ENDS

.SUBCKT SNPS_CLOCK_GATE_HIGH_RegFileDual_DATA_WIDTH34_47 EN ENCLK CLK
*.CONNECT net1881 EN
XFE_PHC1308_net1884 DELC $PINS O=net1884 I=FE_PHN1308_net1884
Xlatch QDBHN $PINS Q=FE_PHN1308_net1884 D=net1881 CKB=CLK
Xmain_gate AN2T $PINS O=ENCLK I1=net1884 I2=CLK
.ENDS

.SUBCKT SNPS_CLOCK_GATE_HIGH_RegFileDual_DATA_WIDTH34_46 EN ENCLK CLK
*.CONNECT net1881 EN
XFE_PHC1335_net1884 DELC $PINS O=FE_PHN1335_net1884 I=net1884
Xlatch QDBHN $PINS Q=net1884 D=net1881 CKB=CLK
Xmain_gate AN2T $PINS O=ENCLK I1=FE_PHN1335_net1884 I2=CLK
.ENDS

.SUBCKT SNPS_CLOCK_GATE_HIGH_RegFileDual_DATA_WIDTH34_45 EN ENCLK CLK
*.CONNECT net1881 EN
XFE_PHC1348_net1884 DELC $PINS O=FE_PHN1348_net1884 I=net1884
Xlatch QDBHN $PINS Q=net1884 D=net1881 CKB=CLK
Xmain_gate AN2T $PINS O=ENCLK I1=FE_PHN1348_net1884 I2=CLK
.ENDS

.SUBCKT SNPS_CLOCK_GATE_HIGH_RegFileDual_DATA_WIDTH34_44 EN ENCLK CLK
*.CONNECT net1881 EN
XFE_PHC1343_net1884 DELC $PINS O=FE_PHN1343_net1884 I=net1884
Xlatch QDBHN $PINS Q=net1884 D=net1881 CKB=CLK
Xmain_gate AN2T $PINS O=ENCLK I1=FE_PHN1343_net1884 I2=CLK
.ENDS

.SUBCKT SNPS_CLOCK_GATE_HIGH_RegFileDual_DATA_WIDTH34_43 EN ENCLK CLK
*.CONNECT net1881 EN
XFE_PHC1351_net1884 DELC $PINS O=FE_PHN1351_net1884 I=net1884
Xlatch QDBHN $PINS Q=net1884 D=net1881 CKB=CLK
Xmain_gate AN2T $PINS O=ENCLK I1=FE_PHN1351_net1884 I2=CLK
.ENDS

.SUBCKT SNPS_CLOCK_GATE_HIGH_RegFileDual_DATA_WIDTH34_42 EN ENCLK CLK
*.CONNECT net1881 EN
XFE_PHC1328_net1884 DELC $PINS O=FE_PHN1328_net1884 I=net1884
Xlatch QDBHN $PINS Q=net1884 D=net1881 CKB=CLK
Xmain_gate AN2T $PINS O=ENCLK I1=FE_PHN1328_net1884 I2=CLK
.ENDS

.SUBCKT SNPS_CLOCK_GATE_HIGH_RegFileDual_DATA_WIDTH34_41 EN ENCLK CLK
*.CONNECT net1881 EN
XFE_PHC1331_net1884 DELC $PINS O=FE_PHN1331_net1884 I=net1884
Xlatch QDBHN $PINS Q=net1884 D=net1881 CKB=CLK
Xmain_gate AN2T $PINS O=ENCLK I1=FE_PHN1331_net1884 I2=CLK
.ENDS

.SUBCKT SNPS_CLOCK_GATE_HIGH_RegFileDual_DATA_WIDTH34_40 EN ENCLK CLK
*.CONNECT net1881 EN
XFE_PHC1342_net1884 DELC $PINS O=FE_PHN1342_net1884 I=net1884
Xlatch QDBHN $PINS Q=net1884 D=net1881 CKB=CLK
Xmain_gate AN2T $PINS O=ENCLK I1=FE_PHN1342_net1884 I2=CLK
.ENDS

.SUBCKT SNPS_CLOCK_GATE_HIGH_RegFileDual_DATA_WIDTH34_39 EN ENCLK CLK
*.CONNECT net1881 EN
XFE_PHC1367_net1884 DELC $PINS O=FE_PHN1367_net1884 I=net1884
Xlatch QDBHN $PINS Q=net1884 D=net1881 CKB=CLK
Xmain_gate AN2T $PINS O=ENCLK I1=FE_PHN1367_net1884 I2=CLK
.ENDS

.SUBCKT SNPS_CLOCK_GATE_HIGH_RegFileDual_DATA_WIDTH34_38 EN ENCLK CLK
*.CONNECT net1881 EN
XFE_PHC1346_net1884 DELC $PINS O=FE_PHN1346_net1884 I=net1884
Xlatch QDBHN $PINS Q=net1884 D=net1881 CKB=CLK
Xmain_gate AN2T $PINS O=ENCLK I1=FE_PHN1346_net1884 I2=CLK
.ENDS

.SUBCKT SNPS_CLOCK_GATE_HIGH_RegFileDual_DATA_WIDTH34_37 EN ENCLK CLK
*.CONNECT net1881 EN
XFE_PHC1361_net1884 DELC $PINS O=FE_PHN1361_net1884 I=net1884
Xlatch QDBHN $PINS Q=net1884 D=net1881 CKB=CLK
Xmain_gate AN2T $PINS O=ENCLK I1=FE_PHN1361_net1884 I2=CLK
.ENDS

.SUBCKT SNPS_CLOCK_GATE_HIGH_RegFileDual_DATA_WIDTH34_36 EN ENCLK CLK
*.CONNECT net1881 EN
XFE_PHC1324_net1884 DELC $PINS O=net1884 I=FE_PHN1324_net1884
Xlatch QDBHN $PINS Q=FE_PHN1324_net1884 D=net1881 CKB=CLK
Xmain_gate AN2T $PINS O=ENCLK I1=net1884 I2=CLK
.ENDS

.SUBCKT SNPS_CLOCK_GATE_HIGH_RegFileDual_DATA_WIDTH34_35 EN ENCLK CLK
*.CONNECT net1881 EN
XFE_PHC1325_net1884 DELC $PINS O=FE_PHN1325_net1884 I=net1884
Xlatch QDBHN $PINS Q=net1884 D=net1881 CKB=CLK
Xmain_gate AN2T $PINS O=ENCLK I1=FE_PHN1325_net1884 I2=CLK
.ENDS

.SUBCKT SNPS_CLOCK_GATE_HIGH_RegFileDual_DATA_WIDTH34_34 EN ENCLK CLK
*.CONNECT net1881 EN
XFE_PHC1333_net1884 DELC $PINS O=net1884 I=FE_PHN1333_net1884
Xlatch QDBHN $PINS Q=FE_PHN1333_net1884 D=net1881 CKB=CLK
Xmain_gate AN2T $PINS O=ENCLK I1=net1884 I2=CLK
.ENDS

.SUBCKT SNPS_CLOCK_GATE_HIGH_RegFileDual_DATA_WIDTH34_33 EN ENCLK CLK
*.CONNECT net1881 EN
XFE_PHC1372_net1884 DELC $PINS O=FE_PHN1372_net1884 I=net1884
Xlatch QDBHN $PINS Q=net1884 D=net1881 CKB=CLK
Xmain_gate AN2T $PINS O=ENCLK I1=FE_PHN1372_net1884 I2=CLK
.ENDS

.SUBCKT SNPS_CLOCK_GATE_HIGH_RegFileDual_DATA_WIDTH34_32 EN ENCLK CLK
*.CONNECT net1881 EN
XFE_PHC1375_net1884 DELC $PINS O=FE_PHN1375_net1884 I=net1884
Xlatch QDBHN $PINS Q=net1884 D=net1881 CKB=CLK
Xmain_gate AN2T $PINS O=ENCLK I1=FE_PHN1375_net1884 I2=CLK
.ENDS

.SUBCKT SNPS_CLOCK_GATE_HIGH_RegFileDual_DATA_WIDTH34_31 EN ENCLK CLK
*.CONNECT net1881 EN
XFE_PHC1303_net1884 DELC $PINS O=net1884 I=FE_PHN1303_net1884
Xlatch QDBHN $PINS Q=FE_PHN1303_net1884 D=net1881 CKB=CLK
Xmain_gate AN2 $PINS O=ENCLK I1=net1884 I2=CLK
.ENDS

.SUBCKT SNPS_CLOCK_GATE_HIGH_RegFileDual_DATA_WIDTH34_30 EN ENCLK CLK
*.CONNECT net1881 EN
XFE_PHC1376_net1884 DELC $PINS O=FE_PHN1376_net1884 I=net1884
Xlatch QDBHN $PINS Q=net1884 D=net1881 CKB=CLK
Xmain_gate AN2T $PINS O=ENCLK I1=FE_PHN1376_net1884 I2=CLK
.ENDS

.SUBCKT SNPS_CLOCK_GATE_HIGH_RegFileDual_DATA_WIDTH34_29 EN ENCLK CLK
*.CONNECT net1881 EN
XFE_PHC1298_net1884 DELC $PINS O=net1884 I=FE_PHN1298_net1884
Xlatch QDBHN $PINS Q=FE_PHN1298_net1884 D=net1881 CKB=CLK
Xmain_gate AN2 $PINS O=ENCLK I1=net1884 I2=CLK
.ENDS

.SUBCKT SNPS_CLOCK_GATE_HIGH_RegFileDual_DATA_WIDTH34_28 EN ENCLK CLK
*.CONNECT net1881 EN
XFE_PHC1373_net1884 DELC $PINS O=FE_PHN1373_net1884 I=net1884
Xlatch QDBHN $PINS Q=net1884 D=net1881 CKB=CLK
Xmain_gate AN2T $PINS O=ENCLK I1=FE_PHN1373_net1884 I2=CLK
.ENDS

.SUBCKT SNPS_CLOCK_GATE_HIGH_RegFileDual_DATA_WIDTH34_27 EN ENCLK CLK
*.CONNECT net1881 EN
XFE_PHC1300_net1884 DELC $PINS O=FE_PHN1300_net1884 I=net1884
Xlatch QDBHN $PINS Q=net1884 D=net1881 CKB=CLK
Xmain_gate AN2 $PINS O=ENCLK I1=FE_PHN1300_net1884 I2=CLK
.ENDS

.SUBCKT SNPS_CLOCK_GATE_HIGH_RegFileDual_DATA_WIDTH34_26 EN ENCLK CLK
*.CONNECT net1881 EN
XFE_PHC1368_net1884 DELC $PINS O=FE_PHN1368_net1884 I=net1884
Xlatch QDBHN $PINS Q=net1884 D=net1881 CKB=CLK
Xmain_gate AN2T $PINS O=ENCLK I1=FE_PHN1368_net1884 I2=CLK
.ENDS

.SUBCKT SNPS_CLOCK_GATE_HIGH_RegFileDual_DATA_WIDTH34_25 EN ENCLK CLK
*.CONNECT net1881 EN
XFE_PHC1332_net1884 DELC $PINS O=net1884 I=FE_PHN1332_net1884
Xlatch QDBHN $PINS Q=FE_PHN1332_net1884 D=net1881 CKB=CLK
Xmain_gate AN2T $PINS O=ENCLK I1=net1884 I2=CLK
.ENDS

.SUBCKT SNPS_CLOCK_GATE_HIGH_RegFileDual_DATA_WIDTH34_24 EN ENCLK CLK
*.CONNECT net1881 EN
XFE_PHC1374_net1884 DELC $PINS O=FE_PHN1374_net1884 I=net1884
Xlatch QDBHN $PINS Q=net1884 D=net1881 CKB=CLK
Xmain_gate AN2T $PINS O=ENCLK I1=FE_PHN1374_net1884 I2=CLK
.ENDS

.SUBCKT SNPS_CLOCK_GATE_HIGH_RegFileDual_DATA_WIDTH34_23 EN ENCLK CLK
*.CONNECT net1881 EN
XFE_PHC1307_net1884 DELC $PINS O=net1884 I=FE_PHN1307_net1884
Xlatch QDBHN $PINS Q=FE_PHN1307_net1884 D=net1881 CKB=CLK
Xmain_gate AN2 $PINS O=ENCLK I1=net1884 I2=CLK
.ENDS

.SUBCKT SNPS_CLOCK_GATE_HIGH_RegFileDual_DATA_WIDTH34_22 EN ENCLK CLK
*.CONNECT net1881 EN
XFE_PHC1378_net1884 DELC $PINS O=FE_PHN1378_net1884 I=net1884
Xlatch QDBHN $PINS Q=net1884 D=net1881 CKB=CLK
Xmain_gate AN2T $PINS O=ENCLK I1=FE_PHN1378_net1884 I2=CLK
.ENDS

.SUBCKT SNPS_CLOCK_GATE_HIGH_RegFileDual_DATA_WIDTH34_21 EN ENCLK CLK
*.CONNECT net1881 EN
XFE_PHC1313_net1884 DELC $PINS O=FE_PHN1313_net1884 I=net1884
Xlatch QDBHN $PINS Q=net1884 D=net1881 CKB=CLK
Xmain_gate AN2 $PINS O=ENCLK I1=FE_PHN1313_net1884 I2=CLK
.ENDS

.SUBCKT SNPS_CLOCK_GATE_HIGH_RegFileDual_DATA_WIDTH34_20 EN ENCLK CLK
*.CONNECT net1881 EN
XFE_PHC1379_net1884 DELC $PINS O=FE_PHN1379_net1884 I=net1884
Xlatch QDBHN $PINS Q=net1884 D=net1881 CKB=CLK
Xmain_gate AN2T $PINS O=ENCLK I1=FE_PHN1379_net1884 I2=CLK
.ENDS

.SUBCKT SNPS_CLOCK_GATE_HIGH_RegFileDual_DATA_WIDTH34_19 EN ENCLK CLK
*.CONNECT net1881 EN
XFE_PHC1301_net1884 DELC $PINS O=FE_PHN1301_net1884 I=net1884
Xlatch QDBHN $PINS Q=net1884 D=net1881 CKB=CLK
Xmain_gate AN2 $PINS O=ENCLK I1=FE_PHN1301_net1884 I2=CLK
.ENDS

.SUBCKT SNPS_CLOCK_GATE_HIGH_RegFileDual_DATA_WIDTH34_18 EN ENCLK CLK
*.CONNECT net1881 EN
XFE_PHC1380_net1884 DELC $PINS O=FE_PHN1380_net1884 I=net1884
Xlatch QDBHN $PINS Q=net1884 D=net1881 CKB=CLK
Xmain_gate AN2T $PINS O=ENCLK I1=FE_PHN1380_net1884 I2=CLK
.ENDS

.SUBCKT SNPS_CLOCK_GATE_HIGH_RegFileDual_DATA_WIDTH34_17 EN ENCLK CLK
*.CONNECT net1881 EN
XFE_PHC1299_net1884 DELC $PINS O=FE_PHN1299_net1884 I=net1884
Xlatch QDBHN $PINS Q=net1884 D=net1881 CKB=CLK
Xmain_gate AN2 $PINS O=ENCLK I1=FE_PHN1299_net1884 I2=CLK
.ENDS

.SUBCKT SNPS_CLOCK_GATE_HIGH_RegFileDual_DATA_WIDTH34_16 EN ENCLK CLK
*.CONNECT net1881 EN
XFE_PHC1370_net1884 DELC $PINS O=FE_PHN1370_net1884 I=net1884
Xlatch QDBHN $PINS Q=net1884 D=net1881 CKB=CLK
Xmain_gate AN2T $PINS O=ENCLK I1=FE_PHN1370_net1884 I2=CLK
.ENDS

.SUBCKT SNPS_CLOCK_GATE_HIGH_RegFileDual_DATA_WIDTH34_15 EN ENCLK CLK
*.CONNECT net1881 EN
XFE_PHC1304_net1884 DELC $PINS O=net1884 I=FE_PHN1304_net1884
Xlatch QDBHN $PINS Q=FE_PHN1304_net1884 D=net1881 CKB=CLK
Xmain_gate AN2 $PINS O=ENCLK I1=net1884 I2=CLK
.ENDS

.SUBCKT SNPS_CLOCK_GATE_HIGH_RegFileDual_DATA_WIDTH34_14 EN ENCLK CLK
*.CONNECT net1881 EN
XFE_PHC1371_net1884 DELC $PINS O=FE_PHN1371_net1884 I=net1884
Xlatch QDBHN $PINS Q=net1884 D=net1881 CKB=CLK
Xmain_gate AN2T $PINS O=ENCLK I1=FE_PHN1371_net1884 I2=CLK
.ENDS

.SUBCKT SNPS_CLOCK_GATE_HIGH_RegFileDual_DATA_WIDTH34_13 EN ENCLK CLK
*.CONNECT net1881 EN
XFE_PHC1288_net1884 DELC $PINS O=FE_PHN1288_net1884 I=net1884
Xlatch QDBHN $PINS Q=net1884 D=net1881 CKB=CLK
Xmain_gate AN2 $PINS O=ENCLK I1=FE_PHN1288_net1884 I2=CLK
.ENDS

.SUBCKT SNPS_CLOCK_GATE_HIGH_RegFileDual_DATA_WIDTH34_12 EN ENCLK CLK
*.CONNECT net1881 EN
XFE_PHC1365_net1884 DELC $PINS O=FE_PHN1365_net1884 I=net1884
Xlatch QDBHN $PINS Q=net1884 D=net1881 CKB=CLK
Xmain_gate AN2T $PINS O=ENCLK I1=FE_PHN1365_net1884 I2=CLK
.ENDS

.SUBCKT SNPS_CLOCK_GATE_HIGH_RegFileDual_DATA_WIDTH34_11 EN ENCLK CLK
*.CONNECT net1881 EN
XFE_PHC1297_net1884 DELC $PINS O=FE_PHN1297_net1884 I=net1884
Xlatch QDBHN $PINS Q=net1884 D=net1881 CKB=CLK
Xmain_gate AN2 $PINS O=ENCLK I1=FE_PHN1297_net1884 I2=CLK
.ENDS

.SUBCKT SNPS_CLOCK_GATE_HIGH_RegFileDual_DATA_WIDTH34_10 EN ENCLK CLK
*.CONNECT net1881 EN
XFE_PHC1369_net1884 DELC $PINS O=net1884 I=FE_PHN1369_net1884
Xlatch QDBHN $PINS Q=FE_PHN1369_net1884 D=net1881 CKB=CLK
Xmain_gate AN2T $PINS O=ENCLK I1=net1884 I2=CLK
.ENDS

.SUBCKT SNPS_CLOCK_GATE_HIGH_RegFileDual_DATA_WIDTH34_9 EN ENCLK CLK
*.CONNECT net1881 EN
XFE_PHC1295_net1884 DELC $PINS O=net1884 I=FE_PHN1295_net1884
Xlatch QDBHN $PINS Q=FE_PHN1295_net1884 D=net1881 CKB=CLK
Xmain_gate AN2 $PINS O=ENCLK I1=net1884 I2=CLK
.ENDS

.SUBCKT SNPS_CLOCK_GATE_HIGH_RegFileDual_DATA_WIDTH34_8 EN ENCLK CLK
*.CONNECT net1881 EN
XFE_PHC1344_net1884 DELC $PINS O=FE_PHN1344_net1884 I=net1884
Xlatch QDBHN $PINS Q=net1884 D=net1881 CKB=CLK
Xmain_gate AN2T $PINS O=ENCLK I1=FE_PHN1344_net1884 I2=CLK
.ENDS

.SUBCKT SNPS_CLOCK_GATE_HIGH_RegFileDual_DATA_WIDTH34_7 EN ENCLK CLK
*.CONNECT net1881 EN
XFE_PHC1287_net1884 DELC $PINS O=net1884 I=FE_PHN1287_net1884
Xlatch QDBHN $PINS Q=FE_PHN1287_net1884 D=net1881 CKB=CLK
Xmain_gate AN2 $PINS O=ENCLK I1=net1884 I2=CLK
.ENDS

.SUBCKT SNPS_CLOCK_GATE_HIGH_RegFileDual_DATA_WIDTH34_6 EN ENCLK CLK
*.CONNECT net1881 EN
XFE_PHC1355_net1884 DELC $PINS O=FE_PHN1355_net1884 I=net1884
Xlatch QDBHN $PINS Q=net1884 D=net1881 CKB=CLK
Xmain_gate AN2T $PINS O=ENCLK I1=FE_PHN1355_net1884 I2=CLK
.ENDS

.SUBCKT SNPS_CLOCK_GATE_HIGH_RegFileDual_DATA_WIDTH34_5 EN ENCLK CLK
*.CONNECT net1881 EN
XFE_PHC1292_net1884 DELC $PINS O=net1884 I=FE_PHN1292_net1884
Xlatch QDBHN $PINS Q=FE_PHN1292_net1884 D=net1881 CKB=CLK
Xmain_gate AN2 $PINS O=ENCLK I1=net1884 I2=CLK
.ENDS

.SUBCKT SNPS_CLOCK_GATE_HIGH_RegFileDual_DATA_WIDTH34_4 EN ENCLK CLK
*.CONNECT net1881 EN
XFE_PHC1364_net1884 DELC $PINS O=FE_PHN1364_net1884 I=net1884
Xlatch QDBHN $PINS Q=net1884 D=net1881 CKB=CLK
Xmain_gate AN2T $PINS O=ENCLK I1=FE_PHN1364_net1884 I2=CLK
.ENDS

.SUBCKT SNPS_CLOCK_GATE_HIGH_RegFileDual_DATA_WIDTH34_3 EN ENCLK CLK
*.CONNECT net1881 EN
XFE_PHC1286_net1884 DELC $PINS O=net1884 I=FE_PHN1286_net1884
Xlatch QDBHN $PINS Q=FE_PHN1286_net1884 D=net1881 CKB=CLK
Xmain_gate AN2 $PINS O=ENCLK I1=net1884 I2=CLK
.ENDS

.SUBCKT SNPS_CLOCK_GATE_HIGH_RegFileDual_DATA_WIDTH34_2 EN ENCLK CLK
*.CONNECT net1881 EN
XFE_PHC1377_net1884 DELC $PINS O=FE_PHN1377_net1884 I=net1884
Xlatch QDBHN $PINS Q=net1884 D=net1881 CKB=CLK
Xmain_gate AN2T $PINS O=ENCLK I1=FE_PHN1377_net1884 I2=CLK
.ENDS

.SUBCKT SNPS_CLOCK_GATE_HIGH_RegFileDual_DATA_WIDTH34_1 EN ENCLK CLK
*.CONNECT net1881 EN
XFE_PHC1302_net1884 DELC $PINS O=FE_PHN1302_net1884 I=net1884
Xlatch QDBHN $PINS Q=net1884 D=net1881 CKB=CLK
Xmain_gate AN2 $PINS O=ENCLK I1=FE_PHN1302_net1884 I2=CLK
.ENDS

.SUBCKT RegFileDual_DATA_WIDTH34 rst_n read_addr_1[4] read_addr_1[3]
+ read_addr_1[2] read_addr_1[1] read_addr_1[0] read_data_1[33] read_data_1[32]
+ read_data_1[31] read_data_1[30] read_data_1[29] read_data_1[28]
+ read_data_1[27] read_data_1[26] read_data_1[25] read_data_1[24]
+ read_data_1[23] read_data_1[22] read_data_1[21] read_data_1[20]
+ read_data_1[19] read_data_1[18] read_data_1[17] read_data_1[16]
+ read_data_1[15] read_data_1[14] read_data_1[13] read_data_1[12]
+ read_data_1[11] read_data_1[10] read_data_1[9] read_data_1[8] read_data_1[7]
+ read_data_1[6] read_data_1[5] read_data_1[4] read_data_1[3] read_data_1[2]
+ read_data_1[1] read_data_1[0] wen1 wen2 write_addr_1[4] write_addr_1[3]
+ write_addr_1[2] write_addr_1[1] write_addr_1[0] write_addr_2[4]
+ write_addr_2[3] write_addr_2[2] write_addr_2[1] write_addr_2[0]
+ write_data_1[33] write_data_1[32] write_data_1[31] write_data_1[30]
+ write_data_1[29] write_data_1[28] write_data_1[27] write_data_1[26]
+ write_data_1[25] write_data_1[24] write_data_1[23] write_data_1[22]
+ write_data_1[21] write_data_1[20] write_data_1[19] write_data_1[18]
+ write_data_1[17] write_data_1[16] write_data_1[15] write_data_1[14]
+ write_data_1[13] write_data_1[12] write_data_1[11] write_data_1[10]
+ write_data_1[9] write_data_1[8] write_data_1[7] write_data_1[6]
+ write_data_1[5] write_data_1[4] write_data_1[3] write_data_1[2]
+ write_data_1[1] write_data_1[0] write_data_2[33] write_data_2[32]
+ write_data_2[31] write_data_2[30] write_data_2[29] write_data_2[28]
+ write_data_2[27] write_data_2[26] write_data_2[25] write_data_2[24]
+ write_data_2[23] write_data_2[22] write_data_2[21] write_data_2[20]
+ write_data_2[19] write_data_2[18] write_data_2[17] write_data_2[16]
+ write_data_2[15] write_data_2[14] write_data_2[13] write_data_2[12]
+ write_data_2[11] write_data_2[10] write_data_2[9] write_data_2[8]
+ write_data_2[7] write_data_2[6] write_data_2[5] write_data_2[4]
+ write_data_2[3] write_data_2[2] write_data_2[1] write_data_2[0] p_1 i_rst_n
+ p1 p2 p3 FE_OFN49_i_rst_n FE_OFN22_i_rst_n FE_OFN20_i_rst_n FE_OFN6_i_rst_n
+ clk_clone4 clk_clone2 clk_clone1 clk clk_clone3
XFE_PHC2197_bank_wdata_0_14 BUF3 $PINS O=FE_PHN2197_bank_wdata_0_14
+ I=bank_wdata[0][14]
XFE_PHC2196_FE_OFN209_bank_wdata_1__14 BUF3 $PINS
+ O=FE_PHN2196_FE_OFN209_bank_wdata_1__14 I=FE_OFN209_bank_wdata_1__14
XFE_PHC2179_bank_mem_1_2_27 BUF1CK $PINS O=FE_PHN2179_bank_mem_1_2_27
+ I=bank_mem_1[2][27]
XFE_PHC2173_FE_OFN194_bank_wdata_1__32 BUF12CK $PINS
+ O=FE_PHN2173_FE_OFN194_bank_wdata_1__32 I=FE_PHN1880_FE_OFN194_bank_wdata_1__32
XFE_PHC2165_bank_mem_1_4_25 BUF1CK $PINS O=bank_mem_1[4][25]
+ I=FE_PHN2165_bank_mem_1_4_25
XFE_PHC2154_n178 BUF1CK $PINS O=n178 I=FE_PHN2154_n178
XFE_PHC2144_n41 BUF1CK $PINS O=n41 I=FE_PHN2144_n41
XFE_PHC2138_bank_wdata_0_4 DELC $PINS O=FE_PHN2138_bank_wdata_0_4
+ I=bank_wdata[0][4]
XFE_PHC2136_bank_wdata_1_16 BUF2CK $PINS O=FE_PHN2136_bank_wdata_1_16
+ I=bank_wdata[1][16]
XFE_PHC2099_bank_rdata_1_31 BUF1CK $PINS O=FE_PHN2099_bank_rdata_1_31
+ I=bank_rdata[1][31]
XFE_PHC2097_n200 BUF1CK $PINS O=n200 I=FE_PHN2097_n200
XFE_PHC2042_FE_OFN188_bank_wdata_0__18 DELB $PINS
+ O=FE_PHN2042_FE_OFN188_bank_wdata_0__18 I=FE_OFN188_bank_wdata_0__18
XFE_PHC2041_bank_wdata_0_11 DELC $PINS O=FE_PHN2041_bank_wdata_0_11
+ I=bank_wdata[0][11]
XFE_PHC2040_N123 BUF2CK $PINS O=FE_PHN2040_N123 I=N123
XFE_PHC2038_bank_wdata_0_9 DELC $PINS O=FE_PHN2038_bank_wdata_0_9
+ I=bank_wdata[0][9]
XFE_PHC2036_bank_wdata_0_10 DELC $PINS O=FE_PHN2036_bank_wdata_0_10
+ I=bank_wdata[0][10]
XFE_PHC2035_bank_wdata_0_2 DELC $PINS O=FE_PHN2035_bank_wdata_0_2
+ I=bank_wdata[0][2]
XFE_PHC2034_bank_wdata_0_12 DELC $PINS O=FE_PHN2034_bank_wdata_0_12
+ I=bank_wdata[0][12]
XFE_PHC2032_N105 BUF1S $PINS O=FE_PHN2032_N105 I=N105
XFE_PHC2030_N124 DELA $PINS O=FE_PHN2030_N124 I=N124
XFE_PHC2029_N120 DELA $PINS O=FE_PHN2029_N120 I=N120
XFE_PHC2027_bank_rdata_1_28 DELA $PINS O=bank_rdata[1][28]
+ I=FE_PHN2027_bank_rdata_1_28
XFE_PHC2026_N109 BUF1S $PINS O=N109 I=FE_PHN2026_N109
XFE_PHC2025_N134 BUF1S $PINS O=FE_PHN2025_N134 I=N134
XFE_PHC2023_N111 BUF1S $PINS O=N111 I=FE_PHN2023_N111
XFE_PHC2022_bank_rdata_1_30 DELA $PINS O=bank_rdata[1][30]
+ I=FE_PHN2022_bank_rdata_1_30
XFE_PHC2021_bank_wdata_0_7 DELC $PINS O=FE_PHN2021_bank_wdata_0_7
+ I=bank_wdata[0][7]
XFE_PHC2019_N121 DELA $PINS O=FE_PHN2019_N121 I=N121
XFE_PHC2018_N125 BUF1S $PINS O=FE_PHN2018_N125 I=N125
XFE_PHC2017_N103 DELA $PINS O=N103 I=FE_PHN2017_N103
XFE_PHC2016_N118 DELA $PINS O=FE_PHN2016_N118 I=N118
XFE_PHC2013_N117 DELA $PINS O=FE_PHN2013_N117 I=N117
XFE_PHC2011_N127 DELA $PINS O=FE_PHN2011_N127 I=N127
XFE_PHC1999_N119 DELB $PINS O=FE_PHN1999_N119 I=N119
XFE_PHC1995_FE_OFN218_bank_wdata_1__3 DELB $PINS
+ O=FE_PHN1995_FE_OFN218_bank_wdata_1__3 I=FE_OFN218_bank_wdata_1__3
XFE_PHC1994_N122 BUF1S $PINS O=FE_PHN1994_N122 I=N122
XFE_PHC1992_FE_OFN215_bank_wdata_1__6 DELB $PINS O=FE_OFN215_bank_wdata_1__6
+ I=FE_PHN1992_FE_OFN215_bank_wdata_1__6
XFE_PHC1984_FE_OFN216_bank_wdata_1__5 DELB $PINS O=FE_OFN216_bank_wdata_1__5
+ I=FE_PHN1984_FE_OFN216_bank_wdata_1__5
XFE_PHC1973_N136 DELB $PINS O=FE_PHN1973_N136 I=N136
XFE_PHC1972_N129 DELB $PINS O=N129 I=FE_PHN1972_N129
XFE_PHC1969_N126 BUF1S $PINS O=FE_PHN1969_N126 I=N126
XFE_PHC1962_N128 DELB $PINS O=FE_PHN1962_N128 I=N128
XFE_PHC1960_N133 DELB $PINS O=FE_PHN1960_N133 I=N133
XFE_PHC1958_N104 BUF1S $PINS O=N104 I=FE_PHN1958_N104
XFE_PHC1953_N132 DELB $PINS O=FE_PHN1953_N132 I=N132
XFE_PHC1948_N130 DELB $PINS O=N130 I=FE_PHN1948_N130
XFE_PHC1942_FE_OFN195_bank_wdata_1__31 DELB $PINS
+ O=FE_PHN1942_FE_OFN195_bank_wdata_1__31 I=FE_OFN195_bank_wdata_1__31
XFE_PHC1939_N131 DELB $PINS O=FE_PHN1939_N131 I=N131
XFE_PHC1930_FE_OFN221_bank_wdata_1__0 DELB $PINS
+ O=FE_PHN1930_FE_OFN221_bank_wdata_1__0 I=FE_OFN221_bank_wdata_1__0
XFE_PHC1919_FE_OFN174_bank_wdata_0__32 BUF1S $PINS
+ O=FE_PHN1919_FE_OFN174_bank_wdata_0__32 I=FE_OFN174_bank_wdata_0__32
XFE_PHC1915_bank_wdata_1_17 DELA $PINS O=FE_PHN1915_bank_wdata_1_17
+ I=bank_wdata[1][17]
XFE_PHC1906_N135 BUF1S $PINS O=FE_PHN1906_N135 I=N135
XFE_PHC1900_FE_OFN176_bank_wdata_0__30 BUF1S $PINS
+ O=FE_PHN1900_FE_OFN176_bank_wdata_0__30 I=FE_OFN176_bank_wdata_0__30
XFE_PHC1896_FE_OFN193_bank_wdata_1__33 DELB $PINS
+ O=FE_PHN1896_FE_OFN193_bank_wdata_1__33 I=FE_OFN193_bank_wdata_1__33
XFE_PHC1880_FE_OFN194_bank_wdata_1__32 BUF1S $PINS
+ O=FE_PHN1880_FE_OFN194_bank_wdata_1__32 I=FE_OFN194_bank_wdata_1__32
XFE_PHC1868_FE_OFN10_bank_wdata_1__12 BUF1S $PINS
+ O=FE_PHN1868_FE_OFN10_bank_wdata_1__12 I=FE_OFN10_bank_wdata_1__12
XFE_PHC1846_FE_OFN11_bank_wdata_0__0 BUF1S $PINS
+ O=FE_PHN1846_FE_OFN11_bank_wdata_0__0 I=FE_OFN11_bank_wdata_0__0
XFE_PHC1825_FE_OFN214_bank_wdata_1__7 BUF1S $PINS
+ O=FE_PHN1825_FE_OFN214_bank_wdata_1__7 I=FE_OFN214_bank_wdata_1__7
XFE_PHC1823_FE_OFN213_bank_wdata_1__8 BUF1S $PINS
+ O=FE_PHN1823_FE_OFN213_bank_wdata_1__8 I=FE_OFN213_bank_wdata_1__8
XFE_PHC1820_FE_OFN200_bank_wdata_1__25 BUF1S $PINS O=FE_OFN200_bank_wdata_1__25
+ I=FE_PHN1820_FE_OFN200_bank_wdata_1__25
XFE_PHC1819_FE_OFN198_bank_wdata_1__28 BUF1S $PINS
+ O=FE_PHN1819_FE_OFN198_bank_wdata_1__28 I=FE_OFN198_bank_wdata_1__28
XFE_PHC1818_FE_OFN212_bank_wdata_1__9 BUF1S $PINS
+ O=FE_PHN1818_FE_OFN212_bank_wdata_1__9 I=FE_OFN212_bank_wdata_1__9
XFE_PHC1817_FE_OFN201_bank_wdata_1__24 BUF1S $PINS
+ O=FE_PHN1817_FE_OFN201_bank_wdata_1__24 I=FE_OFN201_bank_wdata_1__24
XFE_PHC1816_FE_OFN211_bank_wdata_1__10 BUF1S $PINS
+ O=FE_PHN1816_FE_OFN211_bank_wdata_1__10 I=FE_OFN211_bank_wdata_1__10
XFE_PHC1815_FE_OFN219_bank_wdata_1__2 BUF1S $PINS
+ O=FE_PHN1815_FE_OFN219_bank_wdata_1__2 I=FE_OFN219_bank_wdata_1__2
XFE_PHC1814_FE_OFN206_bank_wdata_1__18 BUF1S $PINS
+ O=FE_PHN1814_FE_OFN206_bank_wdata_1__18 I=FE_OFN206_bank_wdata_1__18
XFE_PHC1813_FE_OFN210_bank_wdata_1__11 BUF1S $PINS
+ O=FE_PHN1813_FE_OFN210_bank_wdata_1__11 I=FE_OFN210_bank_wdata_1__11
XFE_PHC1812_FE_OFN196_bank_wdata_1__30 BUF1S $PINS O=FE_OFN196_bank_wdata_1__30
+ I=FE_PHN1812_FE_OFN196_bank_wdata_1__30
XFE_PHC1811_FE_OFN197_bank_wdata_1__29 BUF1S $PINS
+ O=FE_PHN1811_FE_OFN197_bank_wdata_1__29 I=FE_OFN197_bank_wdata_1__29
XFE_PHC1810_FE_OFN199_bank_wdata_1__27 BUF1S $PINS
+ O=FE_PHN1810_FE_OFN199_bank_wdata_1__27 I=FE_OFN199_bank_wdata_1__27
XFE_PHC1735_n321 BUF1CK $PINS O=FE_PHN1735_n321 I=n321
XFE_PHC1725_n277 BUF1CK $PINS O=FE_PHN1725_n277 I=n277
XFE_PHC1698_n715 DELA $PINS O=FE_PHN1698_n715 I=n715
XFE_PHC1696_n737 DELA $PINS O=n737 I=FE_PHN1696_n737
XFE_PHC1692_n693 BUF1S $PINS O=n693 I=FE_PHN1692_n693
XFE_PHC1686_n288 BUF1S $PINS O=FE_PHN1686_n288 I=n288
XFE_PHC1677_n792 DELA $PINS O=n792 I=FE_PHN1677_n792
XFE_PHC1662_n726 BUF1S $PINS O=n726 I=FE_PHN1662_n726
XFE_PHC1660_bank_mem_1_7_27 BUF1CK $PINS O=bank_mem_1[7][27]
+ I=FE_PHN1660_bank_mem_1_7_27
XFE_PHC1650_n704 BUF1S $PINS O=n704 I=FE_PHN1650_n704
XFE_PHC1649_bank_mem_1_7_30 BUF1CK $PINS O=FE_PHN1649_bank_mem_1_7_30
+ I=bank_mem_1[7][30]
XFE_PHC1646_n299 BUF2CK $PINS O=FE_PHN1646_n299 I=n299
XFE_PHC1642_n332 BUF2CK $PINS O=FE_PHN1642_n332 I=n332
XFE_PHC1633_bank_mem_1_7_28 BUF1CK $PINS O=FE_PHN1633_bank_mem_1_7_28
+ I=bank_mem_1[7][28]
XFE_PHC1625_n759 DELB $PINS O=n759 I=FE_PHN1625_n759
XFE_PHC1620_n310 BUF2CK $PINS O=FE_PHN1620_n310 I=n310
XFE_PHC1618_bank_mem_1_7_19 BUF1CK $PINS O=bank_mem_1[7][19]
+ I=FE_PHN1618_bank_mem_1_7_19
XFE_PHC1615_n962 DELA $PINS O=FE_PHN1615_n962 I=n962
XFE_PHC1613_bank_mem_0_7_15 BUF1CK $PINS O=bank_mem_0[7][15]
+ I=FE_PHN1613_bank_mem_0_7_15
XFE_PHC1611_n343 DELB $PINS O=n343 I=FE_PHN1611_n343
XFE_PHC1610_bank_mem_1_7_31 BUF1CK $PINS O=FE_PHN1610_bank_mem_1_7_31
+ I=bank_mem_1[7][31]
XFE_PHC1607_cor_x_out_1_7 BUF1S $PINS O=FE_PHN1607_cor_x_out_1_7
+ I=write_data_2[7]
XFE_PHC1606_cor_x_out_1_4 BUF1S $PINS O=FE_PHN1606_cor_x_out_1_4
+ I=write_data_2[4]
XFE_PHC1602_bank_mem_1_7_33 BUF1S $PINS O=FE_PHN1602_bank_mem_1_7_33
+ I=bank_mem_1[7][33]
XFE_PHC1585_cor_y_out_1_7 BUF1S $PINS O=FE_PHN1585_cor_y_out_1_7
+ I=write_data_2[24]
XFE_PHC1580_n131 DELB $PINS O=FE_PHN1580_n131 I=n131
XFE_PHC1573_cor_y_out_1_10 DELA $PINS O=FE_PHN1573_cor_y_out_1_10
+ I=write_data_2[27]
XFE_PHC1570_cor_y_out_0_2 DELA $PINS O=FE_PHN1570_cor_y_out_0_2
+ I=write_data_1[19]
XFE_PHC1556_cor_y_out_0_8 DELA $PINS O=FE_PHN1556_cor_y_out_0_8
+ I=write_data_1[25]
XFE_PHC1554_cor_y_out_0_5 DELA $PINS O=FE_PHN1554_cor_y_out_0_5
+ I=write_data_1[22]
XFE_PHC1553_cor_x_out_1_9 DELA $PINS O=FE_PHN1553_cor_x_out_1_9
+ I=write_data_2[9]
XFE_PHC1552_cor_y_out_1_3 DELA $PINS O=FE_PHN1552_cor_y_out_1_3
+ I=write_data_2[20]
XFE_PHC1550_cor_x_out_0_1 BUF1CK $PINS O=FE_PHN1550_cor_x_out_0_1
+ I=write_data_1[1]
XFE_PHC1548_cor_y_out_1_9 DELA $PINS O=FE_PHN1548_cor_y_out_1_9
+ I=write_data_2[26]
XFE_PHC1526_cor_x_out_0_4 BUF1CK $PINS O=FE_PHN1526_cor_x_out_0_4
+ I=write_data_1[4]
XFE_PHC1522_cor_y_out_0_12 DELA $PINS O=FE_PHN1522_cor_y_out_0_12
+ I=write_data_1[29]
XFE_PHC1521_cor_y_out_0_9 DELA $PINS O=FE_PHN1521_cor_y_out_0_9
+ I=write_data_1[26]
XFE_PHC1426_cor_x_out_1_16 DELB $PINS O=FE_PHN1426_cor_x_out_1_16
+ I=write_data_2[16]
XFE_OFC15_bank_wdata_1__15 BUF2CK $PINS O=FE_OFN14_bank_wdata_1__15
+ I=bank_wdata[1][15]
XFE_OFC14_bank_wdata_1__13 BUF1 $PINS O=FE_OFN13_bank_wdata_1__13
+ I=bank_wdata[1][13]
XFE_OFC12_bank_wdata_0__0 BUF1 $PINS O=FE_OFN11_bank_wdata_0__0
+ I=bank_wdata[0][0]
XFE_OFC11_bank_wdata_1__12 BUF1 $PINS O=FE_OFN10_bank_wdata_1__12
+ I=bank_wdata[1][12]
XFE_OFC10_bank_wdata_1__26 BUF1 $PINS O=FE_OFN9_bank_wdata_1__26
+ I=bank_wdata[1][26]
XCTS_cpc_drv_INV_CLK_G0_L9_25 INV12CK $PINS O=CTS_784 I=CTS_785
XCTS_cpc_drv_INV_CLK_G0_L8_2 INV12CK $PINS O=CTS_785 I=CTS_733
XCTS_ccl_a_INV_CLK_G1_L10_39 INV6CK $PINS O=CTS_779 I=CTS_780
XCTS_ccl_a_INV_CLK_G1_L9_41 INV3CK $PINS O=CTS_780 I=CTS_781
XCTS_ccl_a_INV_CLK_G1_L10_38 INV6CK $PINS O=CTS_776 I=CTS_777
XCTS_ccl_a_INV_CLK_G1_L9_40 INV3CK $PINS O=CTS_777 I=CTS_778
XCTS_ccl_a_INV_CLK_G1_L10_37 INV6CK $PINS O=CTS_773 I=CTS_774
XCTS_ccl_a_INV_CLK_G1_L9_39 INV3CK $PINS O=CTS_774 I=CTS_775
XCTS_ccl_a_INV_CLK_G1_L10_36 INV6CK $PINS O=CTS_770 I=CTS_771
XCTS_ccl_a_INV_CLK_G1_L9_38 INV3CK $PINS O=CTS_771 I=CTS_772
XCTS_ccl_a_INV_CLK_G1_L10_35 INV6CK $PINS O=CTS_767 I=CTS_768
XCTS_ccl_a_INV_CLK_G1_L9_37 INV3CK $PINS O=CTS_768 I=CTS_769
XCTS_ccl_a_INV_CLK_G1_L10_34 INV4CK $PINS O=CTS_764 I=CTS_765
XCTS_ccl_a_INV_CLK_G1_L9_36 INV3CK $PINS O=CTS_765 I=CTS_766
XCTS_ccl_a_INV_CLK_G1_L10_33 INV6CK $PINS O=CTS_761 I=CTS_762
XCTS_ccl_a_INV_CLK_G1_L9_35 INV3CK $PINS O=CTS_762 I=CTS_763
XCTS_ccl_a_INV_CLK_G1_L10_32 INV6CK $PINS O=CTS_758 I=CTS_759
XCTS_ccl_a_INV_CLK_G1_L9_34 INV3CK $PINS O=CTS_759 I=CTS_760
XCTS_ccl_a_INV_CLK_G1_L10_31 INV6CK $PINS O=CTS_755 I=CTS_756
XCTS_ccl_a_INV_CLK_G1_L9_33 INV3CK $PINS O=CTS_756 I=CTS_757
XCTS_ccl_a_INV_CLK_G1_L10_30 INV4CK $PINS O=CTS_752 I=CTS_753
XCTS_ccl_a_INV_CLK_G1_L9_32 INV3CK $PINS O=CTS_753 I=CTS_754
XCTS_ccl_a_INV_CLK_G1_L10_29 INV4CK $PINS O=CTS_749 I=CTS_750
XCTS_ccl_a_INV_CLK_G1_L9_31 INV2CK $PINS O=CTS_750 I=CTS_751
XCTS_ccl_a_INV_CLK_G1_L10_28 INV4CK $PINS O=CTS_746 I=CTS_747
XCTS_ccl_a_INV_CLK_G1_L9_30 INV3CK $PINS O=CTS_747 I=CTS_748
XCTS_ccl_a_INV_CLK_G1_L10_27 INV4CK $PINS O=CTS_743 I=CTS_744
XCTS_ccl_a_INV_CLK_G1_L9_29 INV3CK $PINS O=CTS_744 I=CTS_745
XCTS_ccl_a_INV_CLK_G1_L10_26 INV4CK $PINS O=CTS_740 I=CTS_741
XCTS_ccl_a_INV_CLK_G1_L9_28 INV3CK $PINS O=CTS_741 I=CTS_742
XCTS_ccl_a_INV_CLK_G1_L10_25 INV4CK $PINS O=CTS_737 I=CTS_738
XCTS_ccl_a_INV_CLK_G1_L9_27 INV2CK $PINS O=CTS_738 I=CTS_739
XCTS_ccl_a_INV_CLK_G1_L10_24 INV4CK $PINS O=CTS_734 I=CTS_735
XCTS_ccl_a_INV_CLK_G1_L9_26 INV3CK $PINS O=CTS_735 I=CTS_736
XCTS_ccl_a_INV_CLK_G0_L7_5 INV8CK $PINS O=CTS_782 I=CTS_783
XCTS_ccl_a_INV_CLK_G1_L12_34 INV6CK $PINS O=CTS_730 I=CTS_731
XCTS_ccl_a_INV_CLK_G1_L11_34 INV3CK $PINS O=CTS_731 I=CTS_732
XCTS_ccl_a_INV_CLK_G1_L12_33 INV4CK $PINS O=CTS_727 I=CTS_728
XCTS_ccl_a_INV_CLK_G1_L11_33 INV6CK $PINS O=CTS_728 I=CTS_729
XCTS_ccl_a_INV_CLK_G1_L12_32 INV6CK $PINS O=CTS_724 I=CTS_725
XCTS_ccl_a_INV_CLK_G1_L11_32 INV8CK $PINS O=CTS_725 I=CTS_726
XCTS_ccl_a_INV_CLK_G1_L12_31 INV4CK $PINS O=CTS_721 I=CTS_722
XCTS_ccl_a_INV_CLK_G1_L11_31 INV2CK $PINS O=CTS_722 I=CTS_723
XCTS_ccl_a_INV_CLK_G1_L12_30 INV6CK $PINS O=CTS_718 I=CTS_719
XCTS_ccl_a_INV_CLK_G1_L11_30 INV3CK $PINS O=CTS_719 I=CTS_720
XCTS_ccl_a_INV_CLK_G1_L12_29 INV12CK $PINS O=CTS_715 I=CTS_716
XCTS_ccl_a_INV_CLK_G1_L11_29 INV8CK $PINS O=CTS_716 I=CTS_717
XCTS_ccl_a_INV_CLK_G1_L12_28 INV6CK $PINS O=CTS_712 I=CTS_713
XCTS_ccl_a_INV_CLK_G1_L11_28 INV3CK $PINS O=CTS_713 I=CTS_714
XCTS_ccl_a_INV_CLK_G1_L12_27 INV4CK $PINS O=CTS_709 I=CTS_710
XCTS_ccl_a_INV_CLK_G1_L11_27 INV3CK $PINS O=CTS_710 I=CTS_711
XCTS_ccl_a_INV_CLK_G1_L12_26 INV6CK $PINS O=CTS_706 I=CTS_707
XCTS_ccl_a_INV_CLK_G1_L11_26 INV4CK $PINS O=CTS_707 I=CTS_708
XCTS_ccl_a_INV_CLK_G1_L12_25 INV4CK $PINS O=CTS_703 I=CTS_704
XCTS_ccl_a_INV_CLK_G1_L11_25 INV8CK $PINS O=CTS_704 I=CTS_705
XCTS_ccl_a_INV_CLK_G1_L12_24 INV6CK $PINS O=CTS_700 I=CTS_701
XCTS_ccl_a_INV_CLK_G1_L11_24 INV8CK $PINS O=CTS_701 I=CTS_702
XCTS_ccl_a_INV_CLK_G1_L12_23 INV4CK $PINS O=CTS_697 I=CTS_698
XCTS_ccl_a_INV_CLK_G1_L11_23 INV8CK $PINS O=CTS_698 I=CTS_699
XCTS_ccl_a_INV_CLK_G1_L12_22 INV6CK $PINS O=CTS_694 I=CTS_695
XCTS_ccl_a_INV_CLK_G1_L11_22 INV4CK $PINS O=CTS_695 I=CTS_696
XCTS_ccl_a_INV_CLK_G1_L12_21 INV8CK $PINS O=CTS_691 I=CTS_692
XCTS_ccl_a_INV_CLK_G1_L11_21 INV3CK $PINS O=CTS_692 I=CTS_693
XCTS_ccl_a_INV_CLK_G1_L12_20 INV4CK $PINS O=CTS_688 I=CTS_689
XCTS_ccl_a_INV_CLK_G1_L11_20 INV6CK $PINS O=CTS_689 I=CTS_690
XCTS_ccl_a_INV_CLK_G1_L12_19 INV4CK $PINS O=CTS_685 I=CTS_686
XCTS_ccl_a_INV_CLK_G1_L11_19 INV3CK $PINS O=CTS_686 I=CTS_687
XCTS_ccl_a_INV_CLK_G1_L12_18 INV8CK $PINS O=CTS_682 I=CTS_683
XCTS_ccl_a_INV_CLK_G1_L11_18 INV8CK $PINS O=CTS_683 I=CTS_684
XCTS_ccl_a_INV_CLK_G0_L7_4 INV8CK $PINS O=CTS_733 I=CTS_783
XCTS_ccl_a_INV_CLK_G0_L6_2 INV6CK $PINS O=CTS_783 I=clk_clone2
XCTS_ccl_a_INV_CLK_G1_L12_15 INV4CK $PINS O=CTS_679 I=CTS_680
XCTS_ccl_a_INV_CLK_G1_L11_15 INV2CK $PINS O=CTS_680 I=CTS_681
XCTS_ccl_a_INV_CLK_G1_L12_14 INV6CK $PINS O=CTS_676 I=CTS_677
XCTS_ccl_a_INV_CLK_G1_L11_14 INV2CK $PINS O=CTS_677 I=CTS_678
XCTS_ccl_a_INV_CLK_G1_L12_13 INV4CK $PINS O=CTS_673 I=CTS_674
XCTS_ccl_a_INV_CLK_G1_L11_13 INV8CK $PINS O=CTS_674 I=CTS_675
XCTS_ccl_a_INV_CLK_G1_L12_12 INV6CK $PINS O=CTS_670 I=CTS_671
XCTS_ccl_a_INV_CLK_G1_L11_12 INV2CK $PINS O=CTS_671 I=CTS_672
XCTS_ccl_a_INV_CLK_G1_L12_11 INV6CK $PINS O=CTS_667 I=CTS_668
XCTS_ccl_a_INV_CLK_G1_L11_11 INV8CK $PINS O=CTS_668 I=CTS_669
XCTS_ccl_a_INV_CLK_G1_L12_10 INV4CK $PINS O=CTS_664 I=CTS_665
XCTS_ccl_a_INV_CLK_G1_L11_10 INV2CK $PINS O=CTS_665 I=CTS_666
XCTS_ccl_a_INV_CLK_G1_L12_9 INV4CK $PINS O=CTS_661 I=CTS_662
XCTS_ccl_a_INV_CLK_G1_L11_9 INV2CK $PINS O=CTS_662 I=CTS_663
XCTS_ccl_a_INV_CLK_G1_L12_8 INV6CK $PINS O=CTS_658 I=CTS_659
XCTS_ccl_a_INV_CLK_G1_L11_8 INV2CK $PINS O=CTS_659 I=CTS_660
XCTS_ccl_a_INV_CLK_G1_L12_7 INV4CK $PINS O=CTS_655 I=CTS_656
XCTS_ccl_a_INV_CLK_G1_L11_7 INV2CK $PINS O=CTS_656 I=CTS_657
XCTS_ccl_a_INV_CLK_G1_L12_6 INV4CK $PINS O=CTS_652 I=CTS_653
XCTS_ccl_a_INV_CLK_G1_L11_6 INV2CK $PINS O=CTS_653 I=CTS_654
XCTS_ccl_a_INV_CLK_G1_L12_5 INV6CK $PINS O=CTS_649 I=CTS_650
XCTS_ccl_a_INV_CLK_G1_L11_5 INV8CK $PINS O=CTS_650 I=CTS_651
XCTS_ccl_a_INV_CLK_G1_L12_4 INV4CK $PINS O=CTS_646 I=CTS_647
XCTS_ccl_a_INV_CLK_G1_L11_4 INV2CK $PINS O=CTS_647 I=CTS_648
XCTS_ccl_a_INV_CLK_G1_L12_3 INV4CK $PINS O=CTS_643 I=CTS_644
XCTS_ccl_a_INV_CLK_G1_L11_3 INV2CK $PINS O=CTS_644 I=CTS_645
XCTS_ccl_a_INV_CLK_G1_L12_2 INV4CK $PINS O=CTS_640 I=CTS_641
XCTS_ccl_a_INV_CLK_G1_L11_2 INV2CK $PINS O=CTS_641 I=CTS_642
XCTS_ccl_a_INV_CLK_G1_L12_1 INV3CK $PINS O=CTS_637 I=CTS_638
XCTS_ccl_a_INV_CLK_G1_L11_1 INV2CK $PINS O=CTS_638 I=CTS_639
XCTS_ccl_a_INV_CLK_G1_L10_22 INV6CK $PINS O=CTS_634 I=CTS_635
XCTS_ccl_a_INV_CLK_G1_L9_22 INV2CK $PINS O=CTS_635 I=CTS_636
XCTS_ccl_a_INV_CLK_G1_L10_21 INV6CK $PINS O=CTS_631 I=CTS_632
XCTS_ccl_a_INV_CLK_G1_L9_21 INV2CK $PINS O=CTS_632 I=CTS_633
XCTS_ccl_a_INV_CLK_G1_L10_20 INV6CK $PINS O=CTS_628 I=CTS_629
XCTS_ccl_a_INV_CLK_G1_L9_20 INV2CK $PINS O=CTS_629 I=CTS_630
XCTS_ccl_a_INV_CLK_G1_L10_19 INV4CK $PINS O=CTS_625 I=CTS_626
XCTS_ccl_a_INV_CLK_G1_L9_19 INV2CK $PINS O=CTS_626 I=CTS_627
XCTS_ccl_a_INV_CLK_G1_L10_18 INV6CK $PINS O=CTS_622 I=CTS_623
XCTS_ccl_a_INV_CLK_G1_L9_18 INV2CK $PINS O=CTS_623 I=CTS_624
XCTS_ccl_a_INV_CLK_G1_L10_17 INV4CK $PINS O=CTS_619 I=CTS_620
XCTS_ccl_a_INV_CLK_G1_L9_17 INV2CK $PINS O=CTS_620 I=CTS_621
XCTS_ccl_a_INV_CLK_G1_L10_16 INV4CK $PINS O=CTS_616 I=CTS_617
XCTS_ccl_a_INV_CLK_G1_L9_16 INV2CK $PINS O=CTS_617 I=CTS_618
XCTS_ccl_a_INV_CLK_G1_L10_15 INV4CK $PINS O=CTS_613 I=CTS_614
XCTS_ccl_a_INV_CLK_G1_L9_15 INV2CK $PINS O=CTS_614 I=CTS_615
XCTS_ccl_a_INV_CLK_G1_L10_14 INV4CK $PINS O=CTS_610 I=CTS_611
XCTS_ccl_a_INV_CLK_G1_L9_14 INV2CK $PINS O=CTS_611 I=CTS_612
XCTS_ccl_a_INV_CLK_G1_L10_13 INV4CK $PINS O=CTS_607 I=CTS_608
XCTS_ccl_a_INV_CLK_G1_L9_13 INV2CK $PINS O=CTS_608 I=CTS_609
XCTS_ccl_a_INV_CLK_G1_L10_12 INV4CK $PINS O=CTS_604 I=CTS_605
XCTS_ccl_a_INV_CLK_G1_L9_12 INV2CK $PINS O=CTS_605 I=CTS_606
XCTS_ccl_a_INV_CLK_G1_L10_11 INV4CK $PINS O=CTS_601 I=CTS_602
XCTS_ccl_a_INV_CLK_G1_L9_11 INV2CK $PINS O=CTS_602 I=CTS_603
XCTS_ccl_a_INV_CLK_G1_L10_10 INV4CK $PINS O=CTS_598 I=CTS_599
XCTS_ccl_a_INV_CLK_G1_L9_10 INV2CK $PINS O=CTS_599 I=CTS_600
XCTS_ccl_a_INV_CLK_G1_L10_9 INV4CK $PINS O=CTS_595 I=CTS_596
XCTS_ccl_a_INV_CLK_G1_L9_9 INV2CK $PINS O=CTS_596 I=CTS_597
XCTS_ccl_a_INV_CLK_G1_L10_8 INV4CK $PINS O=CTS_592 I=CTS_593
XCTS_ccl_a_INV_CLK_G1_L9_8 INV2CK $PINS O=CTS_593 I=CTS_594
XCTS_ccl_a_INV_CLK_G1_L10_7 INV4CK $PINS O=CTS_589 I=CTS_590
XCTS_ccl_a_INV_CLK_G1_L9_7 INV2CK $PINS O=CTS_590 I=CTS_591
XFE_OFC877_bank_wdata_1__23 BUF1S $PINS O=FE_OFN481_bank_wdata_1__23
+ I=bank_wdata[1][23]
XFE_OFC876_bank_wdata_0__8 BUF1S $PINS O=FE_OFN480_bank_wdata_0__8
+ I=bank_wdata[0][8]
XFE_OFC221_bank_wdata_1__0 BUF1 $PINS O=FE_OFN221_bank_wdata_1__0
+ I=bank_wdata[1][0]
XFE_OFC220_bank_wdata_1__1 BUF1 $PINS O=FE_OFN220_bank_wdata_1__1
+ I=bank_wdata[1][1]
XFE_OFC219_bank_wdata_1__2 BUF1 $PINS O=FE_OFN219_bank_wdata_1__2
+ I=bank_wdata[1][2]
XFE_OFC218_bank_wdata_1__3 BUF1 $PINS O=FE_OFN218_bank_wdata_1__3
+ I=bank_wdata[1][3]
XFE_OFC217_bank_wdata_1__4 BUF1S $PINS O=FE_OFN217_bank_wdata_1__4
+ I=bank_wdata[1][4]
XFE_OFC216_bank_wdata_1__5 BUF1 $PINS O=FE_PHN1984_FE_OFN216_bank_wdata_1__5
+ I=bank_wdata[1][5]
XFE_OFC215_bank_wdata_1__6 BUF1 $PINS O=FE_PHN1992_FE_OFN215_bank_wdata_1__6
+ I=bank_wdata[1][6]
XFE_OFC214_bank_wdata_1__7 BUF1 $PINS O=FE_OFN214_bank_wdata_1__7
+ I=bank_wdata[1][7]
XFE_OFC213_bank_wdata_1__8 BUF1 $PINS O=FE_OFN213_bank_wdata_1__8
+ I=bank_wdata[1][8]
XFE_OFC212_bank_wdata_1__9 BUF1 $PINS O=FE_OFN212_bank_wdata_1__9
+ I=bank_wdata[1][9]
XFE_OFC211_bank_wdata_1__10 BUF1 $PINS O=FE_OFN211_bank_wdata_1__10
+ I=bank_wdata[1][10]
XFE_OFC210_bank_wdata_1__11 BUF1 $PINS O=FE_OFN210_bank_wdata_1__11
+ I=bank_wdata[1][11]
XFE_OFC209_bank_wdata_1__14 BUF1 $PINS O=FE_OFN209_bank_wdata_1__14
+ I=bank_wdata[1][14]
XFE_OFC208_bank_wdata_1__16 BUF1 $PINS O=FE_OFN208_bank_wdata_1__16
+ I=FE_PHN2136_bank_wdata_1_16
XFE_OFC207_bank_wdata_1__17 BUF1 $PINS O=FE_OFN207_bank_wdata_1__17
+ I=FE_PHN1915_bank_wdata_1_17
XFE_OFC206_bank_wdata_1__18 BUF1 $PINS O=FE_OFN206_bank_wdata_1__18
+ I=bank_wdata[1][18]
XFE_OFC205_bank_wdata_1__19 BUF1 $PINS O=FE_OFN205_bank_wdata_1__19
+ I=bank_wdata[1][19]
XFE_OFC204_bank_wdata_1__20 BUF1 $PINS O=FE_OFN204_bank_wdata_1__20
+ I=bank_wdata[1][20]
XFE_OFC203_bank_wdata_1__21 BUF1 $PINS O=FE_OFN203_bank_wdata_1__21
+ I=bank_wdata[1][21]
XFE_OFC202_bank_wdata_1__22 BUF1 $PINS O=FE_OFN202_bank_wdata_1__22
+ I=bank_wdata[1][22]
XFE_OFC201_bank_wdata_1__24 BUF1 $PINS O=FE_OFN201_bank_wdata_1__24
+ I=bank_wdata[1][24]
XFE_OFC200_bank_wdata_1__25 BUF1 $PINS O=FE_PHN1820_FE_OFN200_bank_wdata_1__25
+ I=bank_wdata[1][25]
XFE_OFC199_bank_wdata_1__27 BUF1 $PINS O=FE_OFN199_bank_wdata_1__27
+ I=bank_wdata[1][27]
XFE_OFC198_bank_wdata_1__28 BUF1 $PINS O=FE_OFN198_bank_wdata_1__28
+ I=bank_wdata[1][28]
XFE_OFC197_bank_wdata_1__29 BUF1 $PINS O=FE_OFN197_bank_wdata_1__29
+ I=bank_wdata[1][29]
XFE_OFC196_bank_wdata_1__30 BUF1 $PINS O=FE_PHN1812_FE_OFN196_bank_wdata_1__30
+ I=bank_wdata[1][30]
XFE_OFC195_bank_wdata_1__31 BUF1 $PINS O=FE_OFN195_bank_wdata_1__31
+ I=bank_wdata[1][31]
XFE_OFC194_bank_wdata_1__32 BUF1 $PINS O=FE_OFN194_bank_wdata_1__32
+ I=bank_wdata[1][32]
XFE_OFC193_bank_wdata_1__33 BUF1 $PINS O=FE_OFN193_bank_wdata_1__33
+ I=bank_wdata[1][33]
XFE_OFC192_bank_wdata_0__3 BUF1S $PINS O=FE_OFN192_bank_wdata_0__3
+ I=bank_wdata[0][3]
XFE_OFC191_bank_wdata_0__5 BUF1 $PINS O=FE_OFN191_bank_wdata_0__5
+ I=bank_wdata[0][5]
XFE_OFC190_bank_wdata_0__6 BUF1S $PINS O=FE_OFN190_bank_wdata_0__6
+ I=bank_wdata[0][6]
XFE_OFC189_bank_wdata_0__17 BUF1 $PINS O=FE_OFN189_bank_wdata_0__17
+ I=bank_wdata[0][17]
XFE_OFC188_bank_wdata_0__18 BUF1 $PINS O=FE_OFN188_bank_wdata_0__18
+ I=bank_wdata[0][18]
XFE_OFC187_bank_wdata_0__19 BUF1 $PINS O=FE_OFN187_bank_wdata_0__19
+ I=bank_wdata[0][19]
XFE_OFC186_bank_wdata_0__20 BUF1 $PINS O=FE_OFN186_bank_wdata_0__20
+ I=bank_wdata[0][20]
XFE_OFC185_bank_wdata_0__21 BUF1 $PINS O=FE_OFN185_bank_wdata_0__21
+ I=bank_wdata[0][21]
XFE_OFC184_bank_wdata_0__22 BUF1 $PINS O=FE_OFN184_bank_wdata_0__22
+ I=bank_wdata[0][22]
XFE_OFC183_bank_wdata_0__23 BUF1 $PINS O=FE_OFN183_bank_wdata_0__23
+ I=bank_wdata[0][23]
XFE_OFC182_bank_wdata_0__24 BUF1 $PINS O=FE_OFN182_bank_wdata_0__24
+ I=bank_wdata[0][24]
XFE_OFC181_bank_wdata_0__25 BUF1 $PINS O=FE_OFN181_bank_wdata_0__25
+ I=bank_wdata[0][25]
XFE_OFC180_bank_wdata_0__26 BUF1 $PINS O=FE_OFN180_bank_wdata_0__26
+ I=bank_wdata[0][26]
XFE_OFC179_bank_wdata_0__27 BUF1 $PINS O=FE_OFN179_bank_wdata_0__27
+ I=bank_wdata[0][27]
XFE_OFC178_bank_wdata_0__28 BUF1 $PINS O=FE_OFN178_bank_wdata_0__28
+ I=bank_wdata[0][28]
XFE_OFC177_bank_wdata_0__29 BUF1 $PINS O=FE_OFN177_bank_wdata_0__29
+ I=bank_wdata[0][29]
XFE_OFC176_bank_wdata_0__30 BUF1 $PINS O=FE_OFN176_bank_wdata_0__30
+ I=bank_wdata[0][30]
XFE_OFC175_bank_wdata_0__31 BUF1 $PINS O=FE_OFN175_bank_wdata_0__31
+ I=bank_wdata[0][31]
XFE_OFC174_bank_wdata_0__32 BUF1 $PINS O=FE_OFN174_bank_wdata_0__32
+ I=bank_wdata[0][32]
XFE_OFC173_n88 BUF1 $PINS O=FE_OFN173_n88 I=n88
XFE_OFC172_n86 BUF1 $PINS O=FE_OFN172_n86 I=n86
XFE_OFC170_n944 BUF1 $PINS O=FE_OFN170_n944 I=n944
XFE_OFC169_n847 BUF1 $PINS O=FE_OFN169_n847 I=n847
XFE_OFC168_n846 BUF1 $PINS O=FE_OFN168_n846 I=n846
XFE_OFC167_n845 BUF1 $PINS O=FE_OFN167_n845 I=n845
XFE_OFC166_n844 BUF1 $PINS O=FE_OFN166_n844 I=n844
XFE_OFC165_n843 BUF1 $PINS O=FE_OFN165_n843 I=n843
XFE_OFC164_n842 BUF1 $PINS O=FE_OFN164_n842 I=n842
XFE_OFC163_n841 BUF1 $PINS O=FE_OFN163_n841 I=n841
XFE_OFC162_n840 BUF1 $PINS O=FE_OFN162_n840 I=n840
XFE_OFC161_n431 BUF1 $PINS O=FE_OFN161_n431 I=n431
XFE_OFC160_n430 BUF1 $PINS O=FE_OFN160_n430 I=n430
XFE_OFC159_n429 BUF1 $PINS O=FE_OFN159_n429 I=n429
XFE_OFC158_n428 BUF1 $PINS O=FE_OFN158_n428 I=n428
XFE_OFC157_n427 BUF1 $PINS O=FE_OFN157_n427 I=n427
XFE_OFC156_n426 BUF1 $PINS O=FE_OFN156_n426 I=n426
XFE_OFC155_n425 BUF1 $PINS O=FE_OFN155_n425 I=n425
XFE_OFC154_n424 BUF1 $PINS O=FE_OFN154_n424 I=n424
XFE_OFC153_n87 BUF1 $PINS O=FE_OFN153_n87 I=n87
XFE_OFC152_n85 BUF1 $PINS O=FE_OFN152_n85 I=n85
XFE_OFC144_n833 BUF1 $PINS O=FE_OFN144_n833 I=n833
XFE_OFC143_n832 BUF1 $PINS O=FE_OFN143_n832 I=n832
XFE_OFC142_n831 BUF1 $PINS O=FE_OFN142_n831 I=n831
XFE_OFC141_n830 BUF1 $PINS O=FE_OFN141_n830 I=n830
XFE_OFC140_n829 BUF1 $PINS O=FE_OFN140_n829 I=n829
XFE_OFC139_n828 BUF1 $PINS O=FE_OFN139_n828 I=n828
XFE_OFC138_n827 BUF1 $PINS O=FE_OFN138_n827 I=n827
XFE_OFC137_n826 BUF1 $PINS O=FE_OFN137_n826 I=n826
XFE_OFC136_n417 BUF1 $PINS O=FE_OFN136_n417 I=n417
XFE_OFC135_n416 BUF1 $PINS O=FE_OFN135_n416 I=n416
XFE_OFC134_n415 BUF1 $PINS O=FE_OFN134_n415 I=n415
XFE_OFC133_n414 BUF1 $PINS O=FE_OFN133_n414 I=n414
XFE_OFC132_n413 BUF1 $PINS O=FE_OFN132_n413 I=n413
XFE_OFC131_n412 BUF1 $PINS O=FE_OFN131_n412 I=n412
XFE_OFC130_n411 BUF1 $PINS O=FE_OFN130_n411 I=n411
XFE_OFC129_n410 BUF1 $PINS O=FE_OFN129_n410 I=n410
XFE_OFC128_n122 BUF1 $PINS O=FE_OFN128_n122 I=n122
XFE_OFC127_N34 BUF1 $PINS O=FE_OFN127_N34 I=N34
XFE_OFC126_N30 BUF1 $PINS O=FE_OFN126_N30 I=N30
Xbank_raddr_reg[0][3] QDLHN $PINS Q=N30 D=read_addr_1[4] CK=FE_OFN128_n122
Xbank_raddr_reg[0][2] QDLHN $PINS Q=N29 D=read_addr_1[3] CK=FE_OFN128_n122
Xbank_raddr_reg[0][1] QDLHN $PINS Q=N28 D=read_addr_1[2] CK=FE_OFN128_n122
Xbank_raddr_reg[0][0] QDLHN $PINS Q=N27 D=read_addr_1[1] CK=FE_OFN128_n122
Xbank_raddr_reg[1][3] QDBHN $PINS Q=N34 D=read_addr_1[4] CKB=FE_OFN128_n122
Xbank_raddr_reg[1][2] QDBHN $PINS Q=N33 D=read_addr_1[3] CKB=FE_OFN128_n122
Xbank_raddr_reg[1][1] QDBHN $PINS Q=N32 D=read_addr_1[2] CKB=FE_OFN128_n122
Xbank_raddr_reg[1][0] QDBHN $PINS Q=N31 D=read_addr_1[1] CKB=FE_OFN128_n122
XU202 ND2 $PINS O=n89 I1=n95 I2=n96
XU204 ND2 $PINS O=n93 I1=n955 I2=n100
XU205 ND2 $PINS O=n97 I1=n956 I2=n101
XU206 ND2 $PINS O=n98 I1=n101 I2=n96
XU209 ND2 $PINS O=n104 I1=n108 I2=n109
XU210 ND2 $PINS O=n110 I1=n112 I2=wen1
XU211 ND2 $PINS O=n103 I1=n952 I2=n951
XU214 ND2 $PINS O=n113 I1=n953 I2=n111
XU215 ND2 $PINS O=n114 I1=n111 I2=n109
XU217 OR2B1S $PINS O=n87 I1=n117 B1=wen2
XU220 AO22 $PINS O=N134 A1=bank_rdata[0][2] A2=FE_OFN128_n122
+ B1=bank_rdata[1][2] B2=FE_OFN170_n944
XU227 AO22 $PINS O=N127 A1=bank_rdata[0][9] A2=FE_OFN128_n122
+ B1=bank_rdata[1][9] B2=FE_OFN170_n944
XU228 AO22 $PINS O=N126 A1=bank_rdata[0][10] A2=FE_OFN128_n122
+ B1=bank_rdata[1][10] B2=FE_OFN170_n944
XU229 AO22 $PINS O=N125 A1=bank_rdata[0][11] A2=FE_OFN128_n122
+ B1=bank_rdata[1][11] B2=FE_OFN170_n944
XU230 AO22 $PINS O=N124 A1=bank_rdata[0][12] A2=FE_OFN128_n122
+ B1=bank_rdata[1][12] B2=FE_OFN170_n944
XU231 AO22 $PINS O=N123 A1=bank_rdata[0][13] A2=FE_OFN128_n122
+ B1=bank_rdata[1][13] B2=FE_OFN170_n944
XU232 AO22 $PINS O=N122 A1=bank_rdata[0][14] A2=FE_OFN128_n122
+ B1=bank_rdata[1][14] B2=FE_OFN170_n944
XU233 AO22 $PINS O=N121 A1=bank_rdata[0][15] A2=FE_OFN128_n122
+ B1=bank_rdata[1][15] B2=FE_OFN170_n944
XU234 AO22 $PINS O=N120 A1=bank_rdata[0][16] A2=FE_OFN128_n122
+ B1=bank_rdata[1][16] B2=FE_OFN170_n944
XU236 AO22 $PINS O=N118 A1=bank_rdata[0][18] A2=n122 B1=bank_rdata[1][18]
+ B2=n944
XU237 AO22 $PINS O=N117 A1=bank_rdata[0][19] A2=n122 B1=bank_rdata[1][19]
+ B2=n944
XU238 AO22 $PINS O=N116 A1=bank_rdata[0][20] A2=FE_OFN128_n122
+ B1=bank_rdata[1][20] B2=n944
XU239 AO22 $PINS O=N115 A1=bank_rdata[0][21] A2=FE_OFN128_n122
+ B1=bank_rdata[1][21] B2=n944
XU240 AO22 $PINS O=N114 A1=bank_rdata[0][22] A2=FE_OFN128_n122
+ B1=bank_rdata[1][22] B2=n944
XU241 AO22 $PINS O=N113 A1=bank_rdata[0][23] A2=FE_OFN128_n122
+ B1=bank_rdata[1][23] B2=n944
XU242 AO22 $PINS O=N112 A1=bank_rdata[0][24] A2=FE_OFN128_n122
+ B1=bank_rdata[1][24] B2=n944
XU243 AO22 $PINS O=FE_PHN2023_N111 A1=bank_rdata[0][25] A2=FE_OFN128_n122
+ B1=bank_rdata[1][25] B2=n944
XU245 AO22 $PINS O=FE_PHN2026_N109 A1=bank_rdata[0][27] A2=FE_OFN128_n122
+ B1=bank_rdata[1][27] B2=n944
XU246 AO22 $PINS O=N108 A1=bank_rdata[0][28] A2=FE_OFN128_n122
+ B1=bank_rdata[1][28] B2=n944
XU247 AO22 $PINS O=N107 A1=bank_rdata[0][29] A2=FE_OFN128_n122
+ B1=bank_rdata[1][29] B2=n944
XU248 AO22 $PINS O=N106 A1=bank_rdata[0][30] A2=FE_OFN128_n122
+ B1=bank_rdata[1][30] B2=n944
XU249 AO22 $PINS O=N105 A1=bank_rdata[0][31] A2=FE_OFN128_n122
+ B1=FE_PHN2099_bank_rdata_1_31 B2=n944
XU250 AO22 $PINS O=FE_PHN1958_N104 A1=bank_rdata[0][32] A2=FE_OFN128_n122
+ B1=bank_rdata[1][32] B2=n944
XU251 AO22 $PINS O=FE_PHN2017_N103 A1=bank_rdata[0][33] A2=FE_OFN128_n122
+ B1=bank_rdata[1][33] B2=n944
XU252 XOR4 $PINS O=n122 I1=read_addr_1[1] I2=read_addr_1[0] I3=n118
+ I4=read_addr_1[2]
XU253 ND2 $PINS O=n91 I1=n956 I2=n95
XU254 ND2 $PINS O=n119 I1=wen1 I2=n1026
XU255 ND2 $PINS O=n90 I1=n954 I2=n955
Xbank_mem_1_reg[4][33] QDFFN $PINS Q=bank_mem_1[4][33]
+ D=FE_PHN1896_FE_OFN193_bank_wdata_1__33 CK=CTS_655
Xbank_mem_1_reg[4][32] QDFFN $PINS Q=bank_mem_1[4][32]
+ D=FE_PHN1880_FE_OFN194_bank_wdata_1__32 CK=CTS_655
Xbank_mem_1_reg[4][31] QDFFN $PINS Q=bank_mem_1[4][31]
+ D=FE_PHN1942_FE_OFN195_bank_wdata_1__31 CK=CTS_655
Xbank_mem_1_reg[4][30] QDFFN $PINS Q=bank_mem_1[4][30]
+ D=FE_OFN196_bank_wdata_1__30 CK=CTS_655
Xbank_mem_1_reg[4][29] QDFFN $PINS Q=bank_mem_1[4][29]
+ D=FE_PHN1811_FE_OFN197_bank_wdata_1__29 CK=CTS_655
Xbank_mem_1_reg[4][28] QDFFN $PINS Q=bank_mem_1[4][28]
+ D=FE_PHN1819_FE_OFN198_bank_wdata_1__28 CK=CTS_655
Xbank_mem_1_reg[4][27] QDFFN $PINS Q=bank_mem_1[4][27]
+ D=FE_PHN1810_FE_OFN199_bank_wdata_1__27 CK=CTS_655
Xbank_mem_1_reg[4][26] QDFFN $PINS Q=bank_mem_1[4][26]
+ D=FE_OFN9_bank_wdata_1__26 CK=CTS_655
Xbank_mem_1_reg[4][25] QDFFN $PINS Q=FE_PHN2165_bank_mem_1_4_25
+ D=FE_OFN200_bank_wdata_1__25 CK=CTS_655
Xbank_mem_1_reg[4][24] QDFFN $PINS Q=bank_mem_1[4][24]
+ D=FE_PHN1817_FE_OFN201_bank_wdata_1__24 CK=CTS_655
Xbank_mem_1_reg[4][23] QDFFN $PINS Q=bank_mem_1[4][23]
+ D=FE_OFN481_bank_wdata_1__23 CK=CTS_655
Xbank_mem_1_reg[4][22] QDFFN $PINS Q=bank_mem_1[4][22]
+ D=FE_OFN202_bank_wdata_1__22 CK=CTS_655
Xbank_mem_1_reg[4][21] QDFFN $PINS Q=bank_mem_1[4][21]
+ D=FE_OFN203_bank_wdata_1__21 CK=CTS_655
Xbank_mem_1_reg[4][20] QDFFN $PINS Q=bank_mem_1[4][20]
+ D=FE_OFN204_bank_wdata_1__20 CK=CTS_655
Xbank_mem_1_reg[4][19] QDFFN $PINS Q=bank_mem_1[4][19]
+ D=FE_OFN205_bank_wdata_1__19 CK=CTS_655
Xbank_mem_1_reg[4][18] QDFFN $PINS Q=bank_mem_1[4][18]
+ D=FE_PHN1814_FE_OFN206_bank_wdata_1__18 CK=CTS_655
Xbank_mem_1_reg[4][17] QDFFN $PINS Q=bank_mem_1[4][17]
+ D=FE_OFN207_bank_wdata_1__17 CK=CTS_655
Xbank_mem_1_reg[4][16] QDFFN $PINS Q=bank_mem_1[4][16]
+ D=FE_OFN208_bank_wdata_1__16 CK=CTS_652
Xbank_mem_1_reg[4][15] QDFFN $PINS Q=bank_mem_1[4][15]
+ D=FE_OFN14_bank_wdata_1__15 CK=CTS_652
Xbank_mem_1_reg[4][14] QDFFN $PINS Q=bank_mem_1[4][14]
+ D=FE_OFN209_bank_wdata_1__14 CK=CTS_652
Xbank_mem_1_reg[4][13] QDFFN $PINS Q=bank_mem_1[4][13]
+ D=FE_OFN13_bank_wdata_1__13 CK=CTS_652
Xbank_mem_1_reg[4][12] QDFFN $PINS Q=bank_mem_1[4][12]
+ D=FE_PHN1868_FE_OFN10_bank_wdata_1__12 CK=CTS_652
Xbank_mem_1_reg[4][11] QDFFN $PINS Q=bank_mem_1[4][11]
+ D=FE_PHN1813_FE_OFN210_bank_wdata_1__11 CK=CTS_652
Xbank_mem_1_reg[4][10] QDFFN $PINS Q=bank_mem_1[4][10]
+ D=FE_PHN1816_FE_OFN211_bank_wdata_1__10 CK=CTS_652
Xbank_mem_1_reg[4][9] QDFFN $PINS Q=bank_mem_1[4][9]
+ D=FE_PHN1818_FE_OFN212_bank_wdata_1__9 CK=CTS_652
Xbank_mem_1_reg[4][8] QDFFN $PINS Q=bank_mem_1[4][8]
+ D=FE_PHN1823_FE_OFN213_bank_wdata_1__8 CK=CTS_652
Xbank_mem_1_reg[4][7] QDFFN $PINS Q=bank_mem_1[4][7]
+ D=FE_PHN1825_FE_OFN214_bank_wdata_1__7 CK=CTS_652
Xbank_mem_1_reg[4][6] QDFFN $PINS Q=bank_mem_1[4][6]
+ D=FE_OFN215_bank_wdata_1__6 CK=CTS_652
Xbank_mem_1_reg[4][5] QDFFN $PINS Q=bank_mem_1[4][5]
+ D=FE_OFN216_bank_wdata_1__5 CK=CTS_652
Xbank_mem_1_reg[4][4] QDFFN $PINS Q=bank_mem_1[4][4]
+ D=FE_OFN217_bank_wdata_1__4 CK=CTS_652
Xbank_mem_1_reg[4][3] QDFFN $PINS Q=bank_mem_1[4][3]
+ D=FE_PHN1995_FE_OFN218_bank_wdata_1__3 CK=CTS_652
Xbank_mem_1_reg[4][2] QDFFN $PINS Q=bank_mem_1[4][2]
+ D=FE_PHN1815_FE_OFN219_bank_wdata_1__2 CK=CTS_652
Xbank_mem_1_reg[4][1] QDFFN $PINS Q=bank_mem_1[4][1]
+ D=FE_OFN220_bank_wdata_1__1 CK=CTS_652
Xbank_mem_1_reg[4][0] QDFFN $PINS Q=bank_mem_1[4][0]
+ D=FE_PHN1930_FE_OFN221_bank_wdata_1__0 CK=CTS_652
Xbank_mem_1_reg[6][33] QDFFN $PINS Q=bank_mem_1[6][33]
+ D=FE_PHN1896_FE_OFN193_bank_wdata_1__33 CK=CTS_730
Xbank_mem_1_reg[6][32] QDFFN $PINS Q=bank_mem_1[6][32]
+ D=FE_PHN1880_FE_OFN194_bank_wdata_1__32 CK=CTS_730
Xbank_mem_1_reg[6][31] QDFFN $PINS Q=bank_mem_1[6][31]
+ D=FE_PHN1942_FE_OFN195_bank_wdata_1__31 CK=CTS_730
Xbank_mem_1_reg[6][30] QDFFN $PINS Q=bank_mem_1[6][30]
+ D=FE_OFN196_bank_wdata_1__30 CK=CTS_730
Xbank_mem_1_reg[6][29] QDFFN $PINS Q=bank_mem_1[6][29]
+ D=FE_PHN1811_FE_OFN197_bank_wdata_1__29 CK=CTS_730
Xbank_mem_1_reg[6][28] QDFFN $PINS Q=bank_mem_1[6][28]
+ D=FE_PHN1819_FE_OFN198_bank_wdata_1__28 CK=CTS_730
Xbank_mem_1_reg[6][27] QDFFN $PINS Q=bank_mem_1[6][27]
+ D=FE_PHN1810_FE_OFN199_bank_wdata_1__27 CK=CTS_730
Xbank_mem_1_reg[6][26] QDFFN $PINS Q=bank_mem_1[6][26]
+ D=FE_OFN9_bank_wdata_1__26 CK=CTS_730
Xbank_mem_1_reg[6][25] QDFFN $PINS Q=bank_mem_1[6][25]
+ D=FE_OFN200_bank_wdata_1__25 CK=CTS_730
Xbank_mem_1_reg[6][24] QDFFN $PINS Q=bank_mem_1[6][24]
+ D=FE_PHN1817_FE_OFN201_bank_wdata_1__24 CK=CTS_730
Xbank_mem_1_reg[6][23] QDFFN $PINS Q=bank_mem_1[6][23]
+ D=FE_OFN481_bank_wdata_1__23 CK=CTS_730
Xbank_mem_1_reg[6][22] QDFFN $PINS Q=bank_mem_1[6][22]
+ D=FE_OFN202_bank_wdata_1__22 CK=CTS_730
Xbank_mem_1_reg[6][21] QDFFN $PINS Q=bank_mem_1[6][21]
+ D=FE_OFN203_bank_wdata_1__21 CK=CTS_730
Xbank_mem_1_reg[6][20] QDFFN $PINS Q=bank_mem_1[6][20]
+ D=FE_OFN204_bank_wdata_1__20 CK=CTS_730
Xbank_mem_1_reg[6][19] QDFFN $PINS Q=bank_mem_1[6][19]
+ D=FE_OFN205_bank_wdata_1__19 CK=CTS_730
Xbank_mem_1_reg[6][18] QDFFN $PINS Q=bank_mem_1[6][18]
+ D=FE_PHN1814_FE_OFN206_bank_wdata_1__18 CK=CTS_730
Xbank_mem_1_reg[6][17] QDFFN $PINS Q=bank_mem_1[6][17]
+ D=FE_OFN207_bank_wdata_1__17 CK=CTS_730
Xbank_mem_1_reg[6][16] QDFFN $PINS Q=bank_mem_1[6][16]
+ D=FE_OFN208_bank_wdata_1__16 CK=CTS_643
Xbank_mem_1_reg[6][15] QDFFN $PINS Q=bank_mem_1[6][15]
+ D=FE_OFN14_bank_wdata_1__15 CK=CTS_643
Xbank_mem_1_reg[6][14] QDFFN $PINS Q=bank_mem_1[6][14]
+ D=FE_OFN209_bank_wdata_1__14 CK=CTS_643
Xbank_mem_1_reg[6][13] QDFFN $PINS Q=bank_mem_1[6][13]
+ D=FE_OFN13_bank_wdata_1__13 CK=CTS_643
Xbank_mem_1_reg[6][12] QDFFN $PINS Q=bank_mem_1[6][12]
+ D=FE_PHN1868_FE_OFN10_bank_wdata_1__12 CK=CTS_643
Xbank_mem_1_reg[6][11] QDFFN $PINS Q=bank_mem_1[6][11]
+ D=FE_PHN1813_FE_OFN210_bank_wdata_1__11 CK=CTS_643
Xbank_mem_1_reg[6][10] QDFFN $PINS Q=bank_mem_1[6][10]
+ D=FE_PHN1816_FE_OFN211_bank_wdata_1__10 CK=CTS_643
Xbank_mem_1_reg[6][9] QDFFN $PINS Q=bank_mem_1[6][9]
+ D=FE_PHN1818_FE_OFN212_bank_wdata_1__9 CK=CTS_643
Xbank_mem_1_reg[6][8] QDFFN $PINS Q=bank_mem_1[6][8]
+ D=FE_PHN1823_FE_OFN213_bank_wdata_1__8 CK=CTS_643
Xbank_mem_1_reg[6][7] QDFFN $PINS Q=bank_mem_1[6][7]
+ D=FE_PHN1825_FE_OFN214_bank_wdata_1__7 CK=CTS_643
Xbank_mem_1_reg[6][6] QDFFN $PINS Q=bank_mem_1[6][6]
+ D=FE_OFN215_bank_wdata_1__6 CK=CTS_643
Xbank_mem_1_reg[6][5] QDFFN $PINS Q=bank_mem_1[6][5]
+ D=FE_OFN216_bank_wdata_1__5 CK=CTS_643
Xbank_mem_1_reg[6][4] QDFFN $PINS Q=bank_mem_1[6][4]
+ D=FE_OFN217_bank_wdata_1__4 CK=CTS_643
Xbank_mem_1_reg[6][3] QDFFN $PINS Q=bank_mem_1[6][3]
+ D=FE_PHN1995_FE_OFN218_bank_wdata_1__3 CK=CTS_643
Xbank_mem_1_reg[6][2] QDFFN $PINS Q=bank_mem_1[6][2]
+ D=FE_PHN1815_FE_OFN219_bank_wdata_1__2 CK=CTS_643
Xbank_mem_1_reg[6][1] QDFFN $PINS Q=bank_mem_1[6][1]
+ D=FE_OFN220_bank_wdata_1__1 CK=CTS_643
Xbank_mem_1_reg[6][0] QDFFN $PINS Q=bank_mem_1[6][0]
+ D=FE_PHN1930_FE_OFN221_bank_wdata_1__0 CK=CTS_643
Xbank_mem_1_reg[2][33] QDFFN $PINS Q=bank_mem_1[2][33]
+ D=FE_PHN1896_FE_OFN193_bank_wdata_1__33 CK=CTS_667
Xbank_mem_1_reg[2][32] QDFFN $PINS Q=bank_mem_1[2][32]
+ D=FE_PHN1880_FE_OFN194_bank_wdata_1__32 CK=CTS_667
Xbank_mem_1_reg[2][31] QDFFN $PINS Q=bank_mem_1[2][31]
+ D=FE_PHN1942_FE_OFN195_bank_wdata_1__31 CK=CTS_667
Xbank_mem_1_reg[2][30] QDFFN $PINS Q=bank_mem_1[2][30]
+ D=FE_OFN196_bank_wdata_1__30 CK=CTS_667
Xbank_mem_1_reg[2][29] QDFFN $PINS Q=bank_mem_1[2][29]
+ D=FE_PHN1811_FE_OFN197_bank_wdata_1__29 CK=CTS_667
Xbank_mem_1_reg[2][28] QDFFN $PINS Q=bank_mem_1[2][28]
+ D=FE_PHN1819_FE_OFN198_bank_wdata_1__28 CK=CTS_667
Xbank_mem_1_reg[2][27] QDFFN $PINS Q=bank_mem_1[2][27]
+ D=FE_PHN1810_FE_OFN199_bank_wdata_1__27 CK=CTS_667
Xbank_mem_1_reg[2][26] QDFFN $PINS Q=bank_mem_1[2][26]
+ D=FE_OFN9_bank_wdata_1__26 CK=CTS_667
Xbank_mem_1_reg[2][25] QDFFN $PINS Q=bank_mem_1[2][25]
+ D=FE_OFN200_bank_wdata_1__25 CK=CTS_667
Xbank_mem_1_reg[2][24] QDFFN $PINS Q=bank_mem_1[2][24]
+ D=FE_PHN1817_FE_OFN201_bank_wdata_1__24 CK=CTS_667
Xbank_mem_1_reg[2][23] QDFFN $PINS Q=bank_mem_1[2][23]
+ D=FE_OFN481_bank_wdata_1__23 CK=CTS_667
Xbank_mem_1_reg[2][22] QDFFN $PINS Q=bank_mem_1[2][22]
+ D=FE_OFN202_bank_wdata_1__22 CK=CTS_667
Xbank_mem_1_reg[2][21] QDFFN $PINS Q=bank_mem_1[2][21]
+ D=FE_OFN203_bank_wdata_1__21 CK=CTS_667
Xbank_mem_1_reg[2][20] QDFFN $PINS Q=bank_mem_1[2][20]
+ D=FE_OFN204_bank_wdata_1__20 CK=CTS_667
Xbank_mem_1_reg[2][19] QDFFN $PINS Q=bank_mem_1[2][19]
+ D=FE_OFN205_bank_wdata_1__19 CK=CTS_667
Xbank_mem_1_reg[2][18] QDFFN $PINS Q=bank_mem_1[2][18]
+ D=FE_PHN1814_FE_OFN206_bank_wdata_1__18 CK=CTS_667
Xbank_mem_1_reg[2][17] QDFFN $PINS Q=bank_mem_1[2][17]
+ D=FE_OFN207_bank_wdata_1__17 CK=CTS_667
Xbank_mem_1_reg[2][16] QDFFN $PINS Q=bank_mem_1[2][16]
+ D=FE_OFN208_bank_wdata_1__16 CK=CTS_664
Xbank_mem_1_reg[2][15] QDFFN $PINS Q=bank_mem_1[2][15]
+ D=FE_OFN14_bank_wdata_1__15 CK=CTS_664
Xbank_mem_1_reg[2][14] QDFFN $PINS Q=bank_mem_1[2][14]
+ D=FE_OFN209_bank_wdata_1__14 CK=CTS_664
Xbank_mem_1_reg[2][13] QDFFN $PINS Q=bank_mem_1[2][13]
+ D=FE_OFN13_bank_wdata_1__13 CK=CTS_664
Xbank_mem_1_reg[2][12] QDFFN $PINS Q=bank_mem_1[2][12]
+ D=FE_PHN1868_FE_OFN10_bank_wdata_1__12 CK=CTS_664
Xbank_mem_1_reg[2][11] QDFFN $PINS Q=bank_mem_1[2][11]
+ D=FE_PHN1813_FE_OFN210_bank_wdata_1__11 CK=CTS_664
Xbank_mem_1_reg[2][10] QDFFN $PINS Q=bank_mem_1[2][10]
+ D=FE_PHN1816_FE_OFN211_bank_wdata_1__10 CK=CTS_664
Xbank_mem_1_reg[2][9] QDFFN $PINS Q=bank_mem_1[2][9]
+ D=FE_PHN1818_FE_OFN212_bank_wdata_1__9 CK=CTS_664
Xbank_mem_1_reg[2][8] QDFFN $PINS Q=bank_mem_1[2][8]
+ D=FE_PHN1823_FE_OFN213_bank_wdata_1__8 CK=CTS_664
Xbank_mem_1_reg[2][7] QDFFN $PINS Q=bank_mem_1[2][7]
+ D=FE_PHN1825_FE_OFN214_bank_wdata_1__7 CK=CTS_664
Xbank_mem_1_reg[2][6] QDFFN $PINS Q=bank_mem_1[2][6]
+ D=FE_OFN215_bank_wdata_1__6 CK=CTS_664
Xbank_mem_1_reg[2][5] QDFFN $PINS Q=bank_mem_1[2][5]
+ D=FE_OFN216_bank_wdata_1__5 CK=CTS_664
Xbank_mem_1_reg[2][4] QDFFN $PINS Q=bank_mem_1[2][4]
+ D=FE_OFN217_bank_wdata_1__4 CK=CTS_664
Xbank_mem_1_reg[2][3] QDFFN $PINS Q=bank_mem_1[2][3]
+ D=FE_PHN1995_FE_OFN218_bank_wdata_1__3 CK=CTS_664
Xbank_mem_1_reg[2][2] QDFFN $PINS Q=bank_mem_1[2][2]
+ D=FE_PHN1815_FE_OFN219_bank_wdata_1__2 CK=CTS_664
Xbank_mem_1_reg[2][1] QDFFN $PINS Q=bank_mem_1[2][1]
+ D=FE_OFN220_bank_wdata_1__1 CK=CTS_664
Xbank_mem_1_reg[2][0] QDFFN $PINS Q=bank_mem_1[2][0]
+ D=FE_PHN1930_FE_OFN221_bank_wdata_1__0 CK=CTS_664
Xbank_mem_1_reg[7][32] QDFFN $PINS Q=bank_mem_1[7][32]
+ D=FE_PHN1880_FE_OFN194_bank_wdata_1__32 CK=CTS_640
Xbank_mem_1_reg[7][31] QDFFN $PINS Q=bank_mem_1[7][31]
+ D=FE_PHN1942_FE_OFN195_bank_wdata_1__31 CK=CTS_640
Xbank_mem_1_reg[7][30] QDFFN $PINS Q=bank_mem_1[7][30]
+ D=FE_OFN196_bank_wdata_1__30 CK=CTS_640
Xbank_mem_1_reg[7][29] QDFFN $PINS Q=bank_mem_1[7][29]
+ D=FE_PHN1811_FE_OFN197_bank_wdata_1__29 CK=CTS_640
Xbank_mem_1_reg[7][28] QDFFN $PINS Q=bank_mem_1[7][28]
+ D=FE_PHN1819_FE_OFN198_bank_wdata_1__28 CK=CTS_640
Xbank_mem_1_reg[7][27] QDFFN $PINS Q=FE_PHN1660_bank_mem_1_7_27
+ D=FE_PHN1810_FE_OFN199_bank_wdata_1__27 CK=CTS_640
Xbank_mem_1_reg[7][26] QDFFN $PINS Q=bank_mem_1[7][26]
+ D=FE_OFN9_bank_wdata_1__26 CK=CTS_640
Xbank_mem_1_reg[7][25] QDFFN $PINS Q=bank_mem_1[7][25]
+ D=FE_OFN200_bank_wdata_1__25 CK=CTS_640
Xbank_mem_1_reg[7][24] QDFFN $PINS Q=bank_mem_1[7][24]
+ D=FE_PHN1817_FE_OFN201_bank_wdata_1__24 CK=CTS_640
Xbank_mem_1_reg[7][23] QDFFN $PINS Q=bank_mem_1[7][23]
+ D=FE_OFN481_bank_wdata_1__23 CK=CTS_640
Xbank_mem_1_reg[7][22] QDFFN $PINS Q=bank_mem_1[7][22]
+ D=FE_OFN202_bank_wdata_1__22 CK=CTS_640
Xbank_mem_1_reg[7][21] QDFFN $PINS Q=bank_mem_1[7][21]
+ D=FE_OFN203_bank_wdata_1__21 CK=CTS_640
Xbank_mem_1_reg[7][20] QDFFN $PINS Q=bank_mem_1[7][20]
+ D=FE_OFN204_bank_wdata_1__20 CK=CTS_640
Xbank_mem_1_reg[7][19] QDFFN $PINS Q=FE_PHN1618_bank_mem_1_7_19
+ D=FE_OFN205_bank_wdata_1__19 CK=CTS_640
Xbank_mem_1_reg[7][18] QDFFN $PINS Q=bank_mem_1[7][18]
+ D=FE_PHN1814_FE_OFN206_bank_wdata_1__18 CK=CTS_640
Xbank_mem_1_reg[7][17] QDFFN $PINS Q=bank_mem_1[7][17]
+ D=FE_OFN207_bank_wdata_1__17 CK=CTS_640
Xbank_mem_1_reg[7][16] QDFFN $PINS Q=bank_mem_1[7][16]
+ D=FE_OFN208_bank_wdata_1__16 CK=CTS_637
Xbank_mem_1_reg[7][15] QDFFN $PINS Q=bank_mem_1[7][15]
+ D=FE_OFN14_bank_wdata_1__15 CK=CTS_637
Xbank_mem_1_reg[7][14] QDFFN $PINS Q=bank_mem_1[7][14]
+ D=FE_OFN209_bank_wdata_1__14 CK=CTS_637
Xbank_mem_1_reg[7][13] QDFFN $PINS Q=bank_mem_1[7][13]
+ D=FE_OFN13_bank_wdata_1__13 CK=CTS_637
Xbank_mem_1_reg[7][12] QDFFN $PINS Q=bank_mem_1[7][12]
+ D=FE_PHN1868_FE_OFN10_bank_wdata_1__12 CK=CTS_637
Xbank_mem_1_reg[7][11] QDFFN $PINS Q=bank_mem_1[7][11]
+ D=FE_PHN1813_FE_OFN210_bank_wdata_1__11 CK=CTS_637
Xbank_mem_1_reg[7][10] QDFFN $PINS Q=bank_mem_1[7][10]
+ D=FE_PHN1816_FE_OFN211_bank_wdata_1__10 CK=CTS_637
Xbank_mem_1_reg[7][9] QDFFN $PINS Q=bank_mem_1[7][9]
+ D=FE_PHN1818_FE_OFN212_bank_wdata_1__9 CK=CTS_637
Xbank_mem_1_reg[7][8] QDFFN $PINS Q=bank_mem_1[7][8]
+ D=FE_PHN1823_FE_OFN213_bank_wdata_1__8 CK=CTS_637
Xbank_mem_1_reg[7][7] QDFFN $PINS Q=bank_mem_1[7][7]
+ D=FE_PHN1825_FE_OFN214_bank_wdata_1__7 CK=CTS_637
Xbank_mem_1_reg[7][6] QDFFN $PINS Q=bank_mem_1[7][6]
+ D=FE_OFN215_bank_wdata_1__6 CK=CTS_637
Xbank_mem_1_reg[7][5] QDFFN $PINS Q=bank_mem_1[7][5]
+ D=FE_OFN216_bank_wdata_1__5 CK=CTS_637
Xbank_mem_1_reg[7][4] QDFFN $PINS Q=bank_mem_1[7][4]
+ D=FE_OFN217_bank_wdata_1__4 CK=CTS_637
Xbank_mem_1_reg[7][3] QDFFN $PINS Q=bank_mem_1[7][3]
+ D=FE_PHN1995_FE_OFN218_bank_wdata_1__3 CK=CTS_637
Xbank_mem_1_reg[7][2] QDFFN $PINS Q=bank_mem_1[7][2]
+ D=FE_PHN1815_FE_OFN219_bank_wdata_1__2 CK=CTS_637
Xbank_mem_1_reg[7][1] QDFFN $PINS Q=bank_mem_1[7][1]
+ D=FE_OFN220_bank_wdata_1__1 CK=CTS_637
Xbank_mem_1_reg[7][0] QDFFN $PINS Q=bank_mem_1[7][0]
+ D=FE_PHN1930_FE_OFN221_bank_wdata_1__0 CK=CTS_637
Xbank_mem_1_reg[7][33] QDFFN $PINS Q=bank_mem_1[7][33]
+ D=FE_PHN1896_FE_OFN193_bank_wdata_1__33 CK=CTS_640
Xbank_mem_1_reg[3][33] QDFFN $PINS Q=bank_mem_1[3][33]
+ D=FE_PHN1896_FE_OFN193_bank_wdata_1__33 CK=CTS_661
Xbank_mem_1_reg[3][32] QDFFN $PINS Q=bank_mem_1[3][32]
+ D=FE_PHN1880_FE_OFN194_bank_wdata_1__32 CK=CTS_661
Xbank_mem_1_reg[3][31] QDFFN $PINS Q=bank_mem_1[3][31]
+ D=FE_PHN1942_FE_OFN195_bank_wdata_1__31 CK=CTS_661
Xbank_mem_1_reg[3][30] QDFFN $PINS Q=bank_mem_1[3][30]
+ D=FE_OFN196_bank_wdata_1__30 CK=CTS_661
Xbank_mem_1_reg[3][29] QDFFN $PINS Q=bank_mem_1[3][29]
+ D=FE_PHN1811_FE_OFN197_bank_wdata_1__29 CK=CTS_661
Xbank_mem_1_reg[3][28] QDFFN $PINS Q=bank_mem_1[3][28]
+ D=FE_PHN1819_FE_OFN198_bank_wdata_1__28 CK=CTS_661
Xbank_mem_1_reg[3][27] QDFFN $PINS Q=bank_mem_1[3][27]
+ D=FE_PHN1810_FE_OFN199_bank_wdata_1__27 CK=CTS_661
Xbank_mem_1_reg[3][26] QDFFN $PINS Q=bank_mem_1[3][26]
+ D=FE_OFN9_bank_wdata_1__26 CK=CTS_661
Xbank_mem_1_reg[3][25] QDFFN $PINS Q=bank_mem_1[3][25]
+ D=FE_OFN200_bank_wdata_1__25 CK=CTS_661
Xbank_mem_1_reg[3][24] QDFFN $PINS Q=bank_mem_1[3][24]
+ D=FE_PHN1817_FE_OFN201_bank_wdata_1__24 CK=CTS_661
Xbank_mem_1_reg[3][23] QDFFN $PINS Q=bank_mem_1[3][23]
+ D=FE_OFN481_bank_wdata_1__23 CK=CTS_661
Xbank_mem_1_reg[3][22] QDFFN $PINS Q=bank_mem_1[3][22]
+ D=FE_OFN202_bank_wdata_1__22 CK=CTS_661
Xbank_mem_1_reg[3][21] QDFFN $PINS Q=bank_mem_1[3][21]
+ D=FE_OFN203_bank_wdata_1__21 CK=CTS_661
Xbank_mem_1_reg[3][20] QDFFN $PINS Q=bank_mem_1[3][20]
+ D=FE_OFN204_bank_wdata_1__20 CK=CTS_661
Xbank_mem_1_reg[3][19] QDFFN $PINS Q=bank_mem_1[3][19]
+ D=FE_OFN205_bank_wdata_1__19 CK=CTS_661
Xbank_mem_1_reg[3][18] QDFFN $PINS Q=bank_mem_1[3][18]
+ D=FE_PHN1814_FE_OFN206_bank_wdata_1__18 CK=CTS_661
Xbank_mem_1_reg[3][17] QDFFN $PINS Q=bank_mem_1[3][17]
+ D=FE_OFN207_bank_wdata_1__17 CK=CTS_661
Xbank_mem_1_reg[3][16] QDFFN $PINS Q=bank_mem_1[3][16]
+ D=FE_OFN208_bank_wdata_1__16 CK=CTS_658
Xbank_mem_1_reg[3][15] QDFFN $PINS Q=bank_mem_1[3][15]
+ D=FE_OFN14_bank_wdata_1__15 CK=CTS_658
Xbank_mem_1_reg[3][14] QDFFN $PINS Q=bank_mem_1[3][14]
+ D=FE_PHN2196_FE_OFN209_bank_wdata_1__14 CK=CTS_658
Xbank_mem_1_reg[3][13] QDFFN $PINS Q=bank_mem_1[3][13]
+ D=FE_OFN13_bank_wdata_1__13 CK=CTS_658
Xbank_mem_1_reg[3][12] QDFFN $PINS Q=bank_mem_1[3][12]
+ D=FE_PHN1868_FE_OFN10_bank_wdata_1__12 CK=CTS_658
Xbank_mem_1_reg[3][11] QDFFN $PINS Q=bank_mem_1[3][11]
+ D=FE_PHN1813_FE_OFN210_bank_wdata_1__11 CK=CTS_658
Xbank_mem_1_reg[3][10] QDFFN $PINS Q=bank_mem_1[3][10]
+ D=FE_PHN1816_FE_OFN211_bank_wdata_1__10 CK=CTS_658
Xbank_mem_1_reg[3][9] QDFFN $PINS Q=bank_mem_1[3][9]
+ D=FE_PHN1818_FE_OFN212_bank_wdata_1__9 CK=CTS_658
Xbank_mem_1_reg[3][8] QDFFN $PINS Q=bank_mem_1[3][8]
+ D=FE_PHN1823_FE_OFN213_bank_wdata_1__8 CK=CTS_658
Xbank_mem_1_reg[3][7] QDFFN $PINS Q=bank_mem_1[3][7]
+ D=FE_PHN1825_FE_OFN214_bank_wdata_1__7 CK=CTS_658
Xbank_mem_1_reg[3][6] QDFFN $PINS Q=bank_mem_1[3][6]
+ D=FE_OFN215_bank_wdata_1__6 CK=CTS_658
Xbank_mem_1_reg[3][5] QDFFN $PINS Q=bank_mem_1[3][5]
+ D=FE_OFN216_bank_wdata_1__5 CK=CTS_658
Xbank_mem_1_reg[3][4] QDFFN $PINS Q=bank_mem_1[3][4]
+ D=FE_OFN217_bank_wdata_1__4 CK=CTS_658
Xbank_mem_1_reg[3][3] QDFFN $PINS Q=bank_mem_1[3][3]
+ D=FE_PHN1995_FE_OFN218_bank_wdata_1__3 CK=CTS_658
Xbank_mem_1_reg[3][2] QDFFN $PINS Q=bank_mem_1[3][2]
+ D=FE_PHN1815_FE_OFN219_bank_wdata_1__2 CK=CTS_658
Xbank_mem_1_reg[3][1] QDFFN $PINS Q=bank_mem_1[3][1]
+ D=FE_OFN220_bank_wdata_1__1 CK=CTS_658
Xbank_mem_1_reg[3][0] QDFFN $PINS Q=bank_mem_1[3][0]
+ D=FE_PHN1930_FE_OFN221_bank_wdata_1__0 CK=CTS_658
Xbank_mem_1_reg[5][33] QDFFN $PINS Q=bank_mem_1[5][33]
+ D=FE_PHN1896_FE_OFN193_bank_wdata_1__33 CK=CTS_649
Xbank_mem_1_reg[5][32] QDFFN $PINS Q=bank_mem_1[5][32]
+ D=FE_PHN1880_FE_OFN194_bank_wdata_1__32 CK=CTS_649
Xbank_mem_1_reg[5][31] QDFFN $PINS Q=bank_mem_1[5][31]
+ D=FE_PHN1942_FE_OFN195_bank_wdata_1__31 CK=CTS_649
Xbank_mem_1_reg[5][30] QDFFN $PINS Q=bank_mem_1[5][30]
+ D=FE_OFN196_bank_wdata_1__30 CK=CTS_649
Xbank_mem_1_reg[5][29] QDFFN $PINS Q=bank_mem_1[5][29]
+ D=FE_PHN1811_FE_OFN197_bank_wdata_1__29 CK=CTS_649
Xbank_mem_1_reg[5][28] QDFFN $PINS Q=bank_mem_1[5][28]
+ D=FE_PHN1819_FE_OFN198_bank_wdata_1__28 CK=CTS_649
Xbank_mem_1_reg[5][27] QDFFN $PINS Q=bank_mem_1[5][27]
+ D=FE_PHN1810_FE_OFN199_bank_wdata_1__27 CK=CTS_649
Xbank_mem_1_reg[5][26] QDFFN $PINS Q=bank_mem_1[5][26]
+ D=FE_OFN9_bank_wdata_1__26 CK=CTS_649
Xbank_mem_1_reg[5][25] QDFFN $PINS Q=bank_mem_1[5][25]
+ D=FE_OFN200_bank_wdata_1__25 CK=CTS_649
Xbank_mem_1_reg[5][24] QDFFN $PINS Q=bank_mem_1[5][24]
+ D=FE_PHN1817_FE_OFN201_bank_wdata_1__24 CK=CTS_649
Xbank_mem_1_reg[5][23] QDFFN $PINS Q=bank_mem_1[5][23]
+ D=FE_OFN481_bank_wdata_1__23 CK=CTS_649
Xbank_mem_1_reg[5][22] QDFFN $PINS Q=bank_mem_1[5][22]
+ D=FE_OFN202_bank_wdata_1__22 CK=CTS_649
Xbank_mem_1_reg[5][21] QDFFN $PINS Q=bank_mem_1[5][21]
+ D=FE_OFN203_bank_wdata_1__21 CK=CTS_649
Xbank_mem_1_reg[5][20] QDFFN $PINS Q=bank_mem_1[5][20]
+ D=FE_OFN204_bank_wdata_1__20 CK=CTS_649
Xbank_mem_1_reg[5][19] QDFFN $PINS Q=bank_mem_1[5][19]
+ D=FE_OFN205_bank_wdata_1__19 CK=CTS_649
Xbank_mem_1_reg[5][18] QDFFN $PINS Q=bank_mem_1[5][18]
+ D=FE_PHN1814_FE_OFN206_bank_wdata_1__18 CK=CTS_649
Xbank_mem_1_reg[5][17] QDFFN $PINS Q=bank_mem_1[5][17]
+ D=FE_OFN207_bank_wdata_1__17 CK=CTS_649
Xbank_mem_1_reg[5][16] QDFFN $PINS Q=bank_mem_1[5][16]
+ D=FE_OFN208_bank_wdata_1__16 CK=CTS_646
Xbank_mem_1_reg[5][15] QDFFN $PINS Q=bank_mem_1[5][15]
+ D=FE_OFN14_bank_wdata_1__15 CK=CTS_646
Xbank_mem_1_reg[5][14] QDFFN $PINS Q=bank_mem_1[5][14]
+ D=FE_OFN209_bank_wdata_1__14 CK=CTS_646
Xbank_mem_1_reg[5][13] QDFFN $PINS Q=bank_mem_1[5][13]
+ D=FE_OFN13_bank_wdata_1__13 CK=CTS_646
Xbank_mem_1_reg[5][12] QDFFN $PINS Q=bank_mem_1[5][12]
+ D=FE_PHN1868_FE_OFN10_bank_wdata_1__12 CK=CTS_646
Xbank_mem_1_reg[5][11] QDFFN $PINS Q=bank_mem_1[5][11]
+ D=FE_PHN1813_FE_OFN210_bank_wdata_1__11 CK=CTS_646
Xbank_mem_1_reg[5][10] QDFFN $PINS Q=bank_mem_1[5][10]
+ D=FE_PHN1816_FE_OFN211_bank_wdata_1__10 CK=CTS_646
Xbank_mem_1_reg[5][9] QDFFN $PINS Q=bank_mem_1[5][9]
+ D=FE_PHN1818_FE_OFN212_bank_wdata_1__9 CK=CTS_646
Xbank_mem_1_reg[5][8] QDFFN $PINS Q=bank_mem_1[5][8]
+ D=FE_PHN1823_FE_OFN213_bank_wdata_1__8 CK=CTS_646
Xbank_mem_1_reg[5][7] QDFFN $PINS Q=bank_mem_1[5][7]
+ D=FE_PHN1825_FE_OFN214_bank_wdata_1__7 CK=CTS_646
Xbank_mem_1_reg[5][6] QDFFN $PINS Q=bank_mem_1[5][6]
+ D=FE_OFN215_bank_wdata_1__6 CK=CTS_646
Xbank_mem_1_reg[5][5] QDFFN $PINS Q=bank_mem_1[5][5]
+ D=FE_OFN216_bank_wdata_1__5 CK=CTS_646
Xbank_mem_1_reg[5][4] QDFFN $PINS Q=bank_mem_1[5][4]
+ D=FE_OFN217_bank_wdata_1__4 CK=CTS_646
Xbank_mem_1_reg[5][3] QDFFN $PINS Q=bank_mem_1[5][3]
+ D=FE_PHN1995_FE_OFN218_bank_wdata_1__3 CK=CTS_646
Xbank_mem_1_reg[5][2] QDFFN $PINS Q=bank_mem_1[5][2]
+ D=FE_PHN1815_FE_OFN219_bank_wdata_1__2 CK=CTS_646
Xbank_mem_1_reg[5][1] QDFFN $PINS Q=bank_mem_1[5][1]
+ D=FE_OFN220_bank_wdata_1__1 CK=CTS_646
Xbank_mem_1_reg[5][0] QDFFN $PINS Q=bank_mem_1[5][0]
+ D=FE_PHN1930_FE_OFN221_bank_wdata_1__0 CK=CTS_646
Xbank_mem_0_reg[4][33] QDFFN $PINS Q=bank_mem_0[4][33] D=n900 CK=CTS_767
Xbank_mem_0_reg[4][32] QDFFN $PINS Q=bank_mem_0[4][32]
+ D=FE_PHN1919_FE_OFN174_bank_wdata_0__32 CK=CTS_767
Xbank_mem_0_reg[4][31] QDFFN $PINS Q=bank_mem_0[4][31]
+ D=FE_OFN175_bank_wdata_0__31 CK=CTS_767
Xbank_mem_0_reg[4][30] QDFFN $PINS Q=bank_mem_0[4][30]
+ D=FE_PHN1900_FE_OFN176_bank_wdata_0__30 CK=CTS_767
Xbank_mem_0_reg[4][29] QDFFN $PINS Q=bank_mem_0[4][29]
+ D=FE_OFN177_bank_wdata_0__29 CK=CTS_767
Xbank_mem_0_reg[4][28] QDFFN $PINS Q=bank_mem_0[4][28]
+ D=FE_OFN178_bank_wdata_0__28 CK=CTS_767
Xbank_mem_0_reg[4][27] QDFFN $PINS Q=bank_mem_0[4][27]
+ D=FE_OFN179_bank_wdata_0__27 CK=CTS_767
Xbank_mem_0_reg[4][26] QDFFN $PINS Q=bank_mem_0[4][26]
+ D=FE_OFN180_bank_wdata_0__26 CK=CTS_767
Xbank_mem_0_reg[4][25] QDFFN $PINS Q=bank_mem_0[4][25]
+ D=FE_OFN181_bank_wdata_0__25 CK=CTS_767
Xbank_mem_0_reg[4][24] QDFFN $PINS Q=bank_mem_0[4][24]
+ D=FE_OFN182_bank_wdata_0__24 CK=CTS_767
Xbank_mem_0_reg[4][23] QDFFN $PINS Q=bank_mem_0[4][23]
+ D=FE_OFN183_bank_wdata_0__23 CK=CTS_767
Xbank_mem_0_reg[4][22] QDFFN $PINS Q=bank_mem_0[4][22]
+ D=FE_OFN184_bank_wdata_0__22 CK=CTS_767
Xbank_mem_0_reg[4][21] QDFFN $PINS Q=bank_mem_0[4][21]
+ D=FE_OFN185_bank_wdata_0__21 CK=CTS_767
Xbank_mem_0_reg[4][20] QDFFN $PINS Q=bank_mem_0[4][20]
+ D=FE_OFN186_bank_wdata_0__20 CK=CTS_767
Xbank_mem_0_reg[4][19] QDFFN $PINS Q=bank_mem_0[4][19]
+ D=FE_OFN187_bank_wdata_0__19 CK=CTS_767
Xbank_mem_0_reg[4][18] QDFFN $PINS Q=bank_mem_0[4][18]
+ D=FE_PHN2042_FE_OFN188_bank_wdata_0__18 CK=CTS_767
Xbank_mem_0_reg[4][17] QDFFN $PINS Q=bank_mem_0[4][17]
+ D=FE_OFN189_bank_wdata_0__17 CK=CTS_767
Xbank_mem_0_reg[4][16] QDFFN $PINS Q=bank_mem_0[4][16] D=bank_wdata[0][16]
+ CK=CTS_622
Xbank_mem_0_reg[4][15] QDFFN $PINS Q=bank_mem_0[4][15] D=bank_wdata[0][15]
+ CK=CTS_622
Xbank_mem_0_reg[4][14] QDFFN $PINS Q=bank_mem_0[4][14] D=bank_wdata[0][14]
+ CK=CTS_622
Xbank_mem_0_reg[4][13] QDFFN $PINS Q=bank_mem_0[4][13] D=bank_wdata[0][13]
+ CK=CTS_622
Xbank_mem_0_reg[4][12] QDFFN $PINS Q=bank_mem_0[4][12]
+ D=FE_PHN2034_bank_wdata_0_12 CK=CTS_622
Xbank_mem_0_reg[4][11] QDFFN $PINS Q=bank_mem_0[4][11]
+ D=FE_PHN2041_bank_wdata_0_11 CK=CTS_622
Xbank_mem_0_reg[4][10] QDFFN $PINS Q=bank_mem_0[4][10]
+ D=FE_PHN2036_bank_wdata_0_10 CK=CTS_622
Xbank_mem_0_reg[4][9] QDFFN $PINS Q=bank_mem_0[4][9]
+ D=FE_PHN2038_bank_wdata_0_9 CK=CTS_622
Xbank_mem_0_reg[4][8] QDFFN $PINS Q=bank_mem_0[4][8]
+ D=FE_OFN480_bank_wdata_0__8 CK=CTS_622
Xbank_mem_0_reg[4][7] QDFFN $PINS Q=bank_mem_0[4][7]
+ D=FE_PHN2021_bank_wdata_0_7 CK=CTS_622
Xbank_mem_0_reg[4][6] QDFFN $PINS Q=bank_mem_0[4][6]
+ D=FE_OFN190_bank_wdata_0__6 CK=CTS_622
Xbank_mem_0_reg[4][5] QDFFN $PINS Q=bank_mem_0[4][5]
+ D=FE_OFN191_bank_wdata_0__5 CK=CTS_622
Xbank_mem_0_reg[4][4] QDFFN $PINS Q=bank_mem_0[4][4]
+ D=FE_PHN2138_bank_wdata_0_4 CK=CTS_622
Xbank_mem_0_reg[4][3] QDFFN $PINS Q=bank_mem_0[4][3]
+ D=FE_OFN192_bank_wdata_0__3 CK=CTS_622
Xbank_mem_0_reg[4][2] QDFFN $PINS Q=bank_mem_0[4][2]
+ D=FE_PHN2035_bank_wdata_0_2 CK=CTS_622
Xbank_mem_0_reg[4][1] QDFFN $PINS Q=bank_mem_0[4][1] D=bank_wdata[0][1]
+ CK=CTS_622
Xbank_mem_0_reg[4][0] QDFFN $PINS Q=bank_mem_0[4][0]
+ D=FE_PHN1846_FE_OFN11_bank_wdata_0__0 CK=CTS_622
Xbank_mem_0_reg[6][33] QDFFN $PINS Q=bank_mem_0[6][33] D=n900 CK=CTS_761
Xbank_mem_0_reg[6][32] QDFFN $PINS Q=bank_mem_0[6][32]
+ D=FE_PHN1919_FE_OFN174_bank_wdata_0__32 CK=CTS_761
Xbank_mem_0_reg[6][31] QDFFN $PINS Q=bank_mem_0[6][31]
+ D=FE_OFN175_bank_wdata_0__31 CK=CTS_761
Xbank_mem_0_reg[6][30] QDFFN $PINS Q=bank_mem_0[6][30]
+ D=FE_PHN1900_FE_OFN176_bank_wdata_0__30 CK=CTS_761
Xbank_mem_0_reg[6][29] QDFFN $PINS Q=bank_mem_0[6][29]
+ D=FE_OFN177_bank_wdata_0__29 CK=CTS_761
Xbank_mem_0_reg[6][28] QDFFN $PINS Q=bank_mem_0[6][28]
+ D=FE_OFN178_bank_wdata_0__28 CK=CTS_761
Xbank_mem_0_reg[6][27] QDFFN $PINS Q=bank_mem_0[6][27]
+ D=FE_OFN179_bank_wdata_0__27 CK=CTS_761
Xbank_mem_0_reg[6][26] QDFFN $PINS Q=bank_mem_0[6][26]
+ D=FE_OFN180_bank_wdata_0__26 CK=CTS_761
Xbank_mem_0_reg[6][25] QDFFN $PINS Q=bank_mem_0[6][25]
+ D=FE_OFN181_bank_wdata_0__25 CK=CTS_761
Xbank_mem_0_reg[6][24] QDFFN $PINS Q=bank_mem_0[6][24]
+ D=FE_OFN182_bank_wdata_0__24 CK=CTS_761
Xbank_mem_0_reg[6][23] QDFFN $PINS Q=bank_mem_0[6][23]
+ D=FE_OFN183_bank_wdata_0__23 CK=CTS_761
Xbank_mem_0_reg[6][22] QDFFN $PINS Q=bank_mem_0[6][22]
+ D=FE_OFN184_bank_wdata_0__22 CK=CTS_761
Xbank_mem_0_reg[6][21] QDFFN $PINS Q=bank_mem_0[6][21]
+ D=FE_OFN185_bank_wdata_0__21 CK=CTS_761
Xbank_mem_0_reg[6][20] QDFFN $PINS Q=bank_mem_0[6][20]
+ D=FE_OFN186_bank_wdata_0__20 CK=CTS_761
Xbank_mem_0_reg[6][19] QDFFN $PINS Q=bank_mem_0[6][19]
+ D=FE_OFN187_bank_wdata_0__19 CK=CTS_761
Xbank_mem_0_reg[6][18] QDFFN $PINS Q=bank_mem_0[6][18]
+ D=FE_PHN2042_FE_OFN188_bank_wdata_0__18 CK=CTS_761
Xbank_mem_0_reg[6][17] QDFFN $PINS Q=bank_mem_0[6][17]
+ D=FE_OFN189_bank_wdata_0__17 CK=CTS_761
Xbank_mem_0_reg[6][16] QDFFN $PINS Q=bank_mem_0[6][16] D=bank_wdata[0][16]
+ CK=CTS_616
Xbank_mem_0_reg[6][15] QDFFN $PINS Q=bank_mem_0[6][15] D=bank_wdata[0][15]
+ CK=CTS_616
Xbank_mem_0_reg[6][14] QDFFN $PINS Q=bank_mem_0[6][14] D=bank_wdata[0][14]
+ CK=CTS_616
Xbank_mem_0_reg[6][13] QDFFN $PINS Q=bank_mem_0[6][13] D=bank_wdata[0][13]
+ CK=CTS_616
Xbank_mem_0_reg[6][12] QDFFN $PINS Q=bank_mem_0[6][12]
+ D=FE_PHN2034_bank_wdata_0_12 CK=CTS_616
Xbank_mem_0_reg[6][11] QDFFN $PINS Q=bank_mem_0[6][11]
+ D=FE_PHN2041_bank_wdata_0_11 CK=CTS_616
Xbank_mem_0_reg[6][10] QDFFN $PINS Q=bank_mem_0[6][10]
+ D=FE_PHN2036_bank_wdata_0_10 CK=CTS_616
Xbank_mem_0_reg[6][9] QDFFN $PINS Q=bank_mem_0[6][9]
+ D=FE_PHN2038_bank_wdata_0_9 CK=CTS_616
Xbank_mem_0_reg[6][8] QDFFN $PINS Q=bank_mem_0[6][8]
+ D=FE_OFN480_bank_wdata_0__8 CK=CTS_616
Xbank_mem_0_reg[6][7] QDFFN $PINS Q=bank_mem_0[6][7]
+ D=FE_PHN2021_bank_wdata_0_7 CK=CTS_616
Xbank_mem_0_reg[6][6] QDFFN $PINS Q=bank_mem_0[6][6]
+ D=FE_OFN190_bank_wdata_0__6 CK=CTS_616
Xbank_mem_0_reg[6][5] QDFFN $PINS Q=bank_mem_0[6][5]
+ D=FE_OFN191_bank_wdata_0__5 CK=CTS_616
Xbank_mem_0_reg[6][4] QDFFN $PINS Q=bank_mem_0[6][4]
+ D=FE_PHN2138_bank_wdata_0_4 CK=CTS_616
Xbank_mem_0_reg[6][3] QDFFN $PINS Q=bank_mem_0[6][3]
+ D=FE_OFN192_bank_wdata_0__3 CK=CTS_616
Xbank_mem_0_reg[6][2] QDFFN $PINS Q=bank_mem_0[6][2]
+ D=FE_PHN2035_bank_wdata_0_2 CK=CTS_616
Xbank_mem_0_reg[6][1] QDFFN $PINS Q=bank_mem_0[6][1] D=bank_wdata[0][1]
+ CK=CTS_616
Xbank_mem_0_reg[6][0] QDFFN $PINS Q=bank_mem_0[6][0]
+ D=FE_PHN1846_FE_OFN11_bank_wdata_0__0 CK=CTS_616
Xbank_mem_0_reg[2][33] QDFFN $PINS Q=bank_mem_0[2][33] D=n900 CK=CTS_773
Xbank_mem_0_reg[2][32] QDFFN $PINS Q=bank_mem_0[2][32]
+ D=FE_PHN1919_FE_OFN174_bank_wdata_0__32 CK=CTS_773
Xbank_mem_0_reg[2][31] QDFFN $PINS Q=bank_mem_0[2][31]
+ D=FE_OFN175_bank_wdata_0__31 CK=CTS_773
Xbank_mem_0_reg[2][30] QDFFN $PINS Q=bank_mem_0[2][30]
+ D=FE_PHN1900_FE_OFN176_bank_wdata_0__30 CK=CTS_773
Xbank_mem_0_reg[2][29] QDFFN $PINS Q=bank_mem_0[2][29]
+ D=FE_OFN177_bank_wdata_0__29 CK=CTS_773
Xbank_mem_0_reg[2][28] QDFFN $PINS Q=bank_mem_0[2][28]
+ D=FE_OFN178_bank_wdata_0__28 CK=CTS_773
Xbank_mem_0_reg[2][27] QDFFN $PINS Q=bank_mem_0[2][27]
+ D=FE_OFN179_bank_wdata_0__27 CK=CTS_773
Xbank_mem_0_reg[2][26] QDFFN $PINS Q=bank_mem_0[2][26]
+ D=FE_OFN180_bank_wdata_0__26 CK=CTS_773
Xbank_mem_0_reg[2][25] QDFFN $PINS Q=bank_mem_0[2][25]
+ D=FE_OFN181_bank_wdata_0__25 CK=CTS_773
Xbank_mem_0_reg[2][24] QDFFN $PINS Q=bank_mem_0[2][24]
+ D=FE_OFN182_bank_wdata_0__24 CK=CTS_773
Xbank_mem_0_reg[2][23] QDFFN $PINS Q=bank_mem_0[2][23]
+ D=FE_OFN183_bank_wdata_0__23 CK=CTS_773
Xbank_mem_0_reg[2][22] QDFFN $PINS Q=bank_mem_0[2][22]
+ D=FE_OFN184_bank_wdata_0__22 CK=CTS_773
Xbank_mem_0_reg[2][21] QDFFN $PINS Q=bank_mem_0[2][21]
+ D=FE_OFN185_bank_wdata_0__21 CK=CTS_773
Xbank_mem_0_reg[2][20] QDFFN $PINS Q=bank_mem_0[2][20]
+ D=FE_OFN186_bank_wdata_0__20 CK=CTS_773
Xbank_mem_0_reg[2][19] QDFFN $PINS Q=bank_mem_0[2][19]
+ D=FE_OFN187_bank_wdata_0__19 CK=CTS_773
Xbank_mem_0_reg[2][18] QDFFN $PINS Q=bank_mem_0[2][18]
+ D=FE_PHN2042_FE_OFN188_bank_wdata_0__18 CK=CTS_773
Xbank_mem_0_reg[2][17] QDFFN $PINS Q=bank_mem_0[2][17]
+ D=FE_OFN189_bank_wdata_0__17 CK=CTS_773
Xbank_mem_0_reg[2][16] QDFFN $PINS Q=bank_mem_0[2][16] D=bank_wdata[0][16]
+ CK=CTS_628
Xbank_mem_0_reg[2][15] QDFFN $PINS Q=bank_mem_0[2][15] D=bank_wdata[0][15]
+ CK=CTS_628
Xbank_mem_0_reg[2][14] QDFFN $PINS Q=bank_mem_0[2][14] D=bank_wdata[0][14]
+ CK=CTS_628
Xbank_mem_0_reg[2][13] QDFFN $PINS Q=bank_mem_0[2][13] D=bank_wdata[0][13]
+ CK=CTS_628
Xbank_mem_0_reg[2][12] QDFFN $PINS Q=bank_mem_0[2][12]
+ D=FE_PHN2034_bank_wdata_0_12 CK=CTS_628
Xbank_mem_0_reg[2][11] QDFFN $PINS Q=bank_mem_0[2][11]
+ D=FE_PHN2041_bank_wdata_0_11 CK=CTS_628
Xbank_mem_0_reg[2][10] QDFFN $PINS Q=bank_mem_0[2][10]
+ D=FE_PHN2036_bank_wdata_0_10 CK=CTS_628
Xbank_mem_0_reg[2][9] QDFFN $PINS Q=bank_mem_0[2][9]
+ D=FE_PHN2038_bank_wdata_0_9 CK=CTS_628
Xbank_mem_0_reg[2][8] QDFFN $PINS Q=bank_mem_0[2][8]
+ D=FE_OFN480_bank_wdata_0__8 CK=CTS_628
Xbank_mem_0_reg[2][7] QDFFN $PINS Q=bank_mem_0[2][7]
+ D=FE_PHN2021_bank_wdata_0_7 CK=CTS_628
Xbank_mem_0_reg[2][6] QDFFN $PINS Q=bank_mem_0[2][6]
+ D=FE_OFN190_bank_wdata_0__6 CK=CTS_628
Xbank_mem_0_reg[2][5] QDFFN $PINS Q=bank_mem_0[2][5]
+ D=FE_OFN191_bank_wdata_0__5 CK=CTS_628
Xbank_mem_0_reg[2][4] QDFFN $PINS Q=bank_mem_0[2][4]
+ D=FE_PHN2138_bank_wdata_0_4 CK=CTS_628
Xbank_mem_0_reg[2][3] QDFFN $PINS Q=bank_mem_0[2][3]
+ D=FE_OFN192_bank_wdata_0__3 CK=CTS_628
Xbank_mem_0_reg[2][2] QDFFN $PINS Q=bank_mem_0[2][2]
+ D=FE_PHN2035_bank_wdata_0_2 CK=CTS_628
Xbank_mem_0_reg[2][1] QDFFN $PINS Q=bank_mem_0[2][1] D=bank_wdata[0][1]
+ CK=CTS_628
Xbank_mem_0_reg[2][0] QDFFN $PINS Q=bank_mem_0[2][0]
+ D=FE_PHN1846_FE_OFN11_bank_wdata_0__0 CK=CTS_628
Xbank_mem_0_reg[7][32] QDFFN $PINS Q=bank_mem_0[7][32]
+ D=FE_PHN1919_FE_OFN174_bank_wdata_0__32 CK=CTS_758
Xbank_mem_0_reg[7][31] QDFFN $PINS Q=bank_mem_0[7][31]
+ D=FE_OFN175_bank_wdata_0__31 CK=CTS_758
Xbank_mem_0_reg[7][30] QDFFN $PINS Q=bank_mem_0[7][30]
+ D=FE_PHN1900_FE_OFN176_bank_wdata_0__30 CK=CTS_758
Xbank_mem_0_reg[7][29] QDFFN $PINS Q=bank_mem_0[7][29]
+ D=FE_OFN177_bank_wdata_0__29 CK=CTS_758
Xbank_mem_0_reg[7][28] QDFFN $PINS Q=bank_mem_0[7][28]
+ D=FE_OFN178_bank_wdata_0__28 CK=CTS_758
Xbank_mem_0_reg[7][27] QDFFN $PINS Q=bank_mem_0[7][27]
+ D=FE_OFN179_bank_wdata_0__27 CK=CTS_758
Xbank_mem_0_reg[7][26] QDFFN $PINS Q=bank_mem_0[7][26]
+ D=FE_OFN180_bank_wdata_0__26 CK=CTS_758
Xbank_mem_0_reg[7][25] QDFFN $PINS Q=bank_mem_0[7][25]
+ D=FE_OFN181_bank_wdata_0__25 CK=CTS_758
Xbank_mem_0_reg[7][24] QDFFN $PINS Q=bank_mem_0[7][24]
+ D=FE_OFN182_bank_wdata_0__24 CK=CTS_758
Xbank_mem_0_reg[7][23] QDFFN $PINS Q=bank_mem_0[7][23]
+ D=FE_OFN183_bank_wdata_0__23 CK=CTS_758
Xbank_mem_0_reg[7][22] QDFFN $PINS Q=bank_mem_0[7][22]
+ D=FE_OFN184_bank_wdata_0__22 CK=CTS_758
Xbank_mem_0_reg[7][21] QDFFN $PINS Q=bank_mem_0[7][21]
+ D=FE_OFN185_bank_wdata_0__21 CK=CTS_758
Xbank_mem_0_reg[7][20] QDFFN $PINS Q=bank_mem_0[7][20]
+ D=FE_OFN186_bank_wdata_0__20 CK=CTS_758
Xbank_mem_0_reg[7][19] QDFFN $PINS Q=bank_mem_0[7][19]
+ D=FE_OFN187_bank_wdata_0__19 CK=CTS_758
Xbank_mem_0_reg[7][18] QDFFN $PINS Q=bank_mem_0[7][18]
+ D=FE_PHN2042_FE_OFN188_bank_wdata_0__18 CK=CTS_758
Xbank_mem_0_reg[7][17] QDFFN $PINS Q=bank_mem_0[7][17]
+ D=FE_OFN189_bank_wdata_0__17 CK=CTS_758
Xbank_mem_0_reg[7][16] QDFFN $PINS Q=bank_mem_0[7][16] D=bank_wdata[0][16]
+ CK=CTS_613
Xbank_mem_0_reg[7][15] QDFFN $PINS Q=FE_PHN1613_bank_mem_0_7_15
+ D=bank_wdata[0][15] CK=CTS_613
Xbank_mem_0_reg[7][14] QDFFN $PINS Q=bank_mem_0[7][14] D=bank_wdata[0][14]
+ CK=CTS_613
Xbank_mem_0_reg[7][13] QDFFN $PINS Q=bank_mem_0[7][13] D=bank_wdata[0][13]
+ CK=CTS_613
Xbank_mem_0_reg[7][12] QDFFN $PINS Q=bank_mem_0[7][12]
+ D=FE_PHN2034_bank_wdata_0_12 CK=CTS_613
Xbank_mem_0_reg[7][11] QDFFN $PINS Q=bank_mem_0[7][11]
+ D=FE_PHN2041_bank_wdata_0_11 CK=CTS_613
Xbank_mem_0_reg[7][10] QDFFN $PINS Q=bank_mem_0[7][10]
+ D=FE_PHN2036_bank_wdata_0_10 CK=CTS_613
Xbank_mem_0_reg[7][9] QDFFN $PINS Q=bank_mem_0[7][9]
+ D=FE_PHN2038_bank_wdata_0_9 CK=CTS_613
Xbank_mem_0_reg[7][8] QDFFN $PINS Q=bank_mem_0[7][8]
+ D=FE_OFN480_bank_wdata_0__8 CK=CTS_613
Xbank_mem_0_reg[7][7] QDFFN $PINS Q=bank_mem_0[7][7]
+ D=FE_PHN2021_bank_wdata_0_7 CK=CTS_613
Xbank_mem_0_reg[7][6] QDFFN $PINS Q=bank_mem_0[7][6]
+ D=FE_OFN190_bank_wdata_0__6 CK=CTS_613
Xbank_mem_0_reg[7][5] QDFFN $PINS Q=bank_mem_0[7][5]
+ D=FE_OFN191_bank_wdata_0__5 CK=CTS_613
Xbank_mem_0_reg[7][4] QDFFN $PINS Q=bank_mem_0[7][4]
+ D=FE_PHN2138_bank_wdata_0_4 CK=CTS_613
Xbank_mem_0_reg[7][3] QDFFN $PINS Q=bank_mem_0[7][3]
+ D=FE_OFN192_bank_wdata_0__3 CK=CTS_613
Xbank_mem_0_reg[7][2] QDFFN $PINS Q=bank_mem_0[7][2]
+ D=FE_PHN2035_bank_wdata_0_2 CK=CTS_613
Xbank_mem_0_reg[7][1] QDFFN $PINS Q=bank_mem_0[7][1] D=bank_wdata[0][1]
+ CK=CTS_613
Xbank_mem_0_reg[7][0] QDFFN $PINS Q=bank_mem_0[7][0]
+ D=FE_PHN1846_FE_OFN11_bank_wdata_0__0 CK=CTS_613
Xbank_mem_0_reg[7][33] QDFFN $PINS Q=bank_mem_0[7][33] D=n900 CK=CTS_758
Xbank_mem_0_reg[3][33] QDFFN $PINS Q=bank_mem_0[3][33] D=n900 CK=CTS_770
Xbank_mem_0_reg[3][32] QDFFN $PINS Q=bank_mem_0[3][32]
+ D=FE_PHN1919_FE_OFN174_bank_wdata_0__32 CK=CTS_770
Xbank_mem_0_reg[3][31] QDFFN $PINS Q=bank_mem_0[3][31]
+ D=FE_OFN175_bank_wdata_0__31 CK=CTS_770
Xbank_mem_0_reg[3][30] QDFFN $PINS Q=bank_mem_0[3][30]
+ D=FE_PHN1900_FE_OFN176_bank_wdata_0__30 CK=CTS_770
Xbank_mem_0_reg[3][29] QDFFN $PINS Q=bank_mem_0[3][29]
+ D=FE_OFN177_bank_wdata_0__29 CK=CTS_770
Xbank_mem_0_reg[3][28] QDFFN $PINS Q=bank_mem_0[3][28]
+ D=FE_OFN178_bank_wdata_0__28 CK=CTS_770
Xbank_mem_0_reg[3][27] QDFFN $PINS Q=bank_mem_0[3][27]
+ D=FE_OFN179_bank_wdata_0__27 CK=CTS_770
Xbank_mem_0_reg[3][26] QDFFN $PINS Q=bank_mem_0[3][26]
+ D=FE_OFN180_bank_wdata_0__26 CK=CTS_770
Xbank_mem_0_reg[3][25] QDFFN $PINS Q=bank_mem_0[3][25]
+ D=FE_OFN181_bank_wdata_0__25 CK=CTS_770
Xbank_mem_0_reg[3][24] QDFFN $PINS Q=bank_mem_0[3][24]
+ D=FE_OFN182_bank_wdata_0__24 CK=CTS_770
Xbank_mem_0_reg[3][23] QDFFN $PINS Q=bank_mem_0[3][23]
+ D=FE_OFN183_bank_wdata_0__23 CK=CTS_770
Xbank_mem_0_reg[3][22] QDFFN $PINS Q=bank_mem_0[3][22]
+ D=FE_OFN184_bank_wdata_0__22 CK=CTS_770
Xbank_mem_0_reg[3][21] QDFFN $PINS Q=bank_mem_0[3][21]
+ D=FE_OFN185_bank_wdata_0__21 CK=CTS_770
Xbank_mem_0_reg[3][20] QDFFN $PINS Q=bank_mem_0[3][20]
+ D=FE_OFN186_bank_wdata_0__20 CK=CTS_770
Xbank_mem_0_reg[3][19] QDFFN $PINS Q=bank_mem_0[3][19]
+ D=FE_OFN187_bank_wdata_0__19 CK=CTS_770
Xbank_mem_0_reg[3][18] QDFFN $PINS Q=bank_mem_0[3][18]
+ D=FE_PHN2042_FE_OFN188_bank_wdata_0__18 CK=CTS_770
Xbank_mem_0_reg[3][17] QDFFN $PINS Q=bank_mem_0[3][17]
+ D=FE_OFN189_bank_wdata_0__17 CK=CTS_770
Xbank_mem_0_reg[3][16] QDFFN $PINS Q=bank_mem_0[3][16] D=bank_wdata[0][16]
+ CK=CTS_625
Xbank_mem_0_reg[3][15] QDFFN $PINS Q=bank_mem_0[3][15] D=bank_wdata[0][15]
+ CK=CTS_625
Xbank_mem_0_reg[3][14] QDFFN $PINS Q=bank_mem_0[3][14] D=bank_wdata[0][14]
+ CK=CTS_625
Xbank_mem_0_reg[3][13] QDFFN $PINS Q=bank_mem_0[3][13] D=bank_wdata[0][13]
+ CK=CTS_625
Xbank_mem_0_reg[3][12] QDFFN $PINS Q=bank_mem_0[3][12]
+ D=FE_PHN2034_bank_wdata_0_12 CK=CTS_625
Xbank_mem_0_reg[3][11] QDFFN $PINS Q=bank_mem_0[3][11]
+ D=FE_PHN2041_bank_wdata_0_11 CK=CTS_625
Xbank_mem_0_reg[3][10] QDFFN $PINS Q=bank_mem_0[3][10]
+ D=FE_PHN2036_bank_wdata_0_10 CK=CTS_625
Xbank_mem_0_reg[3][9] QDFFN $PINS Q=bank_mem_0[3][9]
+ D=FE_PHN2038_bank_wdata_0_9 CK=CTS_625
Xbank_mem_0_reg[3][8] QDFFN $PINS Q=bank_mem_0[3][8]
+ D=FE_OFN480_bank_wdata_0__8 CK=CTS_625
Xbank_mem_0_reg[3][7] QDFFN $PINS Q=bank_mem_0[3][7]
+ D=FE_PHN2021_bank_wdata_0_7 CK=CTS_625
Xbank_mem_0_reg[3][6] QDFFN $PINS Q=bank_mem_0[3][6]
+ D=FE_OFN190_bank_wdata_0__6 CK=CTS_625
Xbank_mem_0_reg[3][5] QDFFN $PINS Q=bank_mem_0[3][5]
+ D=FE_OFN191_bank_wdata_0__5 CK=CTS_625
Xbank_mem_0_reg[3][4] QDFFN $PINS Q=bank_mem_0[3][4]
+ D=FE_PHN2138_bank_wdata_0_4 CK=CTS_625
Xbank_mem_0_reg[3][3] QDFFN $PINS Q=bank_mem_0[3][3]
+ D=FE_OFN192_bank_wdata_0__3 CK=CTS_625
Xbank_mem_0_reg[3][2] QDFFN $PINS Q=bank_mem_0[3][2]
+ D=FE_PHN2035_bank_wdata_0_2 CK=CTS_625
Xbank_mem_0_reg[3][1] QDFFN $PINS Q=bank_mem_0[3][1] D=bank_wdata[0][1]
+ CK=CTS_625
Xbank_mem_0_reg[3][0] QDFFN $PINS Q=bank_mem_0[3][0]
+ D=FE_PHN1846_FE_OFN11_bank_wdata_0__0 CK=CTS_625
Xbank_mem_0_reg[5][33] QDFFN $PINS Q=bank_mem_0[5][33] D=n900 CK=CTS_764
Xbank_mem_0_reg[5][32] QDFFN $PINS Q=bank_mem_0[5][32]
+ D=FE_PHN1919_FE_OFN174_bank_wdata_0__32 CK=CTS_764
Xbank_mem_0_reg[5][31] QDFFN $PINS Q=bank_mem_0[5][31]
+ D=FE_OFN175_bank_wdata_0__31 CK=CTS_764
Xbank_mem_0_reg[5][30] QDFFN $PINS Q=bank_mem_0[5][30]
+ D=FE_PHN1900_FE_OFN176_bank_wdata_0__30 CK=CTS_764
Xbank_mem_0_reg[5][29] QDFFN $PINS Q=bank_mem_0[5][29]
+ D=FE_OFN177_bank_wdata_0__29 CK=CTS_764
Xbank_mem_0_reg[5][28] QDFFN $PINS Q=bank_mem_0[5][28]
+ D=FE_OFN178_bank_wdata_0__28 CK=CTS_764
Xbank_mem_0_reg[5][27] QDFFN $PINS Q=bank_mem_0[5][27]
+ D=FE_OFN179_bank_wdata_0__27 CK=CTS_764
Xbank_mem_0_reg[5][26] QDFFN $PINS Q=bank_mem_0[5][26]
+ D=FE_OFN180_bank_wdata_0__26 CK=CTS_764
Xbank_mem_0_reg[5][25] QDFFN $PINS Q=bank_mem_0[5][25]
+ D=FE_OFN181_bank_wdata_0__25 CK=CTS_764
Xbank_mem_0_reg[5][24] QDFFN $PINS Q=bank_mem_0[5][24]
+ D=FE_OFN182_bank_wdata_0__24 CK=CTS_764
Xbank_mem_0_reg[5][23] QDFFN $PINS Q=bank_mem_0[5][23]
+ D=FE_OFN183_bank_wdata_0__23 CK=CTS_764
Xbank_mem_0_reg[5][22] QDFFN $PINS Q=bank_mem_0[5][22]
+ D=FE_OFN184_bank_wdata_0__22 CK=CTS_764
Xbank_mem_0_reg[5][21] QDFFN $PINS Q=bank_mem_0[5][21]
+ D=FE_OFN185_bank_wdata_0__21 CK=CTS_764
Xbank_mem_0_reg[5][20] QDFFN $PINS Q=bank_mem_0[5][20]
+ D=FE_OFN186_bank_wdata_0__20 CK=CTS_764
Xbank_mem_0_reg[5][19] QDFFN $PINS Q=bank_mem_0[5][19]
+ D=FE_OFN187_bank_wdata_0__19 CK=CTS_764
Xbank_mem_0_reg[5][18] QDFFN $PINS Q=bank_mem_0[5][18]
+ D=FE_PHN2042_FE_OFN188_bank_wdata_0__18 CK=CTS_764
Xbank_mem_0_reg[5][17] QDFFN $PINS Q=bank_mem_0[5][17]
+ D=FE_OFN189_bank_wdata_0__17 CK=CTS_764
Xbank_mem_0_reg[5][16] QDFFN $PINS Q=bank_mem_0[5][16] D=bank_wdata[0][16]
+ CK=CTS_619
Xbank_mem_0_reg[5][15] QDFFN $PINS Q=bank_mem_0[5][15] D=bank_wdata[0][15]
+ CK=CTS_619
Xbank_mem_0_reg[5][14] QDFFN $PINS Q=bank_mem_0[5][14] D=bank_wdata[0][14]
+ CK=CTS_619
Xbank_mem_0_reg[5][13] QDFFN $PINS Q=bank_mem_0[5][13] D=bank_wdata[0][13]
+ CK=CTS_619
Xbank_mem_0_reg[5][12] QDFFN $PINS Q=bank_mem_0[5][12]
+ D=FE_PHN2034_bank_wdata_0_12 CK=CTS_619
Xbank_mem_0_reg[5][11] QDFFN $PINS Q=bank_mem_0[5][11]
+ D=FE_PHN2041_bank_wdata_0_11 CK=CTS_619
Xbank_mem_0_reg[5][10] QDFFN $PINS Q=bank_mem_0[5][10]
+ D=FE_PHN2036_bank_wdata_0_10 CK=CTS_619
Xbank_mem_0_reg[5][9] QDFFN $PINS Q=bank_mem_0[5][9]
+ D=FE_PHN2038_bank_wdata_0_9 CK=CTS_619
Xbank_mem_0_reg[5][8] QDFFN $PINS Q=bank_mem_0[5][8]
+ D=FE_OFN480_bank_wdata_0__8 CK=CTS_619
Xbank_mem_0_reg[5][7] QDFFN $PINS Q=bank_mem_0[5][7]
+ D=FE_PHN2021_bank_wdata_0_7 CK=CTS_619
Xbank_mem_0_reg[5][6] QDFFN $PINS Q=bank_mem_0[5][6]
+ D=FE_OFN190_bank_wdata_0__6 CK=CTS_619
Xbank_mem_0_reg[5][5] QDFFN $PINS Q=bank_mem_0[5][5]
+ D=FE_OFN191_bank_wdata_0__5 CK=CTS_619
Xbank_mem_0_reg[5][4] QDFFN $PINS Q=bank_mem_0[5][4]
+ D=FE_PHN2138_bank_wdata_0_4 CK=CTS_619
Xbank_mem_0_reg[5][3] QDFFN $PINS Q=bank_mem_0[5][3]
+ D=FE_OFN192_bank_wdata_0__3 CK=CTS_619
Xbank_mem_0_reg[5][2] QDFFN $PINS Q=bank_mem_0[5][2]
+ D=FE_PHN2035_bank_wdata_0_2 CK=CTS_619
Xbank_mem_0_reg[5][1] QDFFN $PINS Q=bank_mem_0[5][1] D=bank_wdata[0][1]
+ CK=CTS_619
Xbank_mem_0_reg[5][0] QDFFN $PINS Q=bank_mem_0[5][0]
+ D=FE_PHN1846_FE_OFN11_bank_wdata_0__0 CK=CTS_619
Xbank_mem_1_reg[0][33] QDFFN $PINS Q=bank_mem_1[0][33]
+ D=FE_PHN1896_FE_OFN193_bank_wdata_1__33 CK=CTS_679
Xbank_mem_1_reg[0][32] QDFFN $PINS Q=bank_mem_1[0][32]
+ D=FE_PHN1880_FE_OFN194_bank_wdata_1__32 CK=CTS_679
Xbank_mem_1_reg[0][31] QDFFN $PINS Q=bank_mem_1[0][31]
+ D=FE_PHN1942_FE_OFN195_bank_wdata_1__31 CK=CTS_679
Xbank_mem_1_reg[0][30] QDFFN $PINS Q=bank_mem_1[0][30]
+ D=FE_OFN196_bank_wdata_1__30 CK=CTS_679
Xbank_mem_1_reg[0][29] QDFFN $PINS Q=bank_mem_1[0][29]
+ D=FE_PHN1811_FE_OFN197_bank_wdata_1__29 CK=CTS_679
Xbank_mem_1_reg[0][28] QDFFN $PINS Q=bank_mem_1[0][28]
+ D=FE_PHN1819_FE_OFN198_bank_wdata_1__28 CK=CTS_679
Xbank_mem_1_reg[0][27] QDFFN $PINS Q=bank_mem_1[0][27]
+ D=FE_PHN1810_FE_OFN199_bank_wdata_1__27 CK=CTS_679
Xbank_mem_1_reg[0][26] QDFFN $PINS Q=bank_mem_1[0][26]
+ D=FE_OFN9_bank_wdata_1__26 CK=CTS_679
Xbank_mem_1_reg[0][25] QDFFN $PINS Q=bank_mem_1[0][25]
+ D=FE_OFN200_bank_wdata_1__25 CK=CTS_679
Xbank_mem_1_reg[0][24] QDFFN $PINS Q=bank_mem_1[0][24]
+ D=FE_PHN1817_FE_OFN201_bank_wdata_1__24 CK=CTS_679
Xbank_mem_1_reg[0][23] QDFFN $PINS Q=bank_mem_1[0][23]
+ D=FE_OFN481_bank_wdata_1__23 CK=CTS_679
Xbank_mem_1_reg[0][22] QDFFN $PINS Q=bank_mem_1[0][22]
+ D=FE_OFN202_bank_wdata_1__22 CK=CTS_679
Xbank_mem_1_reg[0][21] QDFFN $PINS Q=bank_mem_1[0][21]
+ D=FE_OFN203_bank_wdata_1__21 CK=CTS_679
Xbank_mem_1_reg[0][20] QDFFN $PINS Q=bank_mem_1[0][20]
+ D=FE_OFN204_bank_wdata_1__20 CK=CTS_679
Xbank_mem_1_reg[0][19] QDFFN $PINS Q=bank_mem_1[0][19]
+ D=FE_OFN205_bank_wdata_1__19 CK=CTS_679
Xbank_mem_1_reg[0][18] QDFFN $PINS Q=bank_mem_1[0][18]
+ D=FE_PHN1814_FE_OFN206_bank_wdata_1__18 CK=CTS_679
Xbank_mem_1_reg[0][17] QDFFN $PINS Q=bank_mem_1[0][17]
+ D=FE_OFN207_bank_wdata_1__17 CK=CTS_679
Xbank_mem_1_reg[0][16] QDFFN $PINS Q=bank_mem_1[0][16]
+ D=FE_OFN208_bank_wdata_1__16 CK=CTS_676
Xbank_mem_1_reg[0][15] QDFFN $PINS Q=bank_mem_1[0][15]
+ D=FE_OFN14_bank_wdata_1__15 CK=CTS_676
Xbank_mem_1_reg[0][14] QDFFN $PINS Q=bank_mem_1[0][14]
+ D=FE_OFN209_bank_wdata_1__14 CK=CTS_676
Xbank_mem_1_reg[0][13] QDFFN $PINS Q=bank_mem_1[0][13]
+ D=FE_OFN13_bank_wdata_1__13 CK=CTS_676
Xbank_mem_1_reg[0][12] QDFFN $PINS Q=bank_mem_1[0][12]
+ D=FE_PHN1868_FE_OFN10_bank_wdata_1__12 CK=CTS_676
Xbank_mem_1_reg[0][11] QDFFN $PINS Q=bank_mem_1[0][11]
+ D=FE_PHN1813_FE_OFN210_bank_wdata_1__11 CK=CTS_676
Xbank_mem_1_reg[0][10] QDFFN $PINS Q=bank_mem_1[0][10]
+ D=FE_PHN1816_FE_OFN211_bank_wdata_1__10 CK=CTS_676
Xbank_mem_1_reg[0][9] QDFFN $PINS Q=bank_mem_1[0][9]
+ D=FE_PHN1818_FE_OFN212_bank_wdata_1__9 CK=CTS_676
Xbank_mem_1_reg[0][8] QDFFN $PINS Q=bank_mem_1[0][8]
+ D=FE_PHN1823_FE_OFN213_bank_wdata_1__8 CK=CTS_676
Xbank_mem_1_reg[0][7] QDFFN $PINS Q=bank_mem_1[0][7]
+ D=FE_PHN1825_FE_OFN214_bank_wdata_1__7 CK=CTS_676
Xbank_mem_1_reg[0][6] QDFFN $PINS Q=bank_mem_1[0][6]
+ D=FE_OFN215_bank_wdata_1__6 CK=CTS_676
Xbank_mem_1_reg[0][5] QDFFN $PINS Q=bank_mem_1[0][5]
+ D=FE_OFN216_bank_wdata_1__5 CK=CTS_676
Xbank_mem_1_reg[0][4] QDFFN $PINS Q=bank_mem_1[0][4]
+ D=FE_OFN217_bank_wdata_1__4 CK=CTS_676
Xbank_mem_1_reg[0][3] QDFFN $PINS Q=bank_mem_1[0][3]
+ D=FE_PHN1995_FE_OFN218_bank_wdata_1__3 CK=CTS_676
Xbank_mem_1_reg[0][2] QDFFN $PINS Q=bank_mem_1[0][2]
+ D=FE_PHN1815_FE_OFN219_bank_wdata_1__2 CK=CTS_676
Xbank_mem_1_reg[0][1] QDFFN $PINS Q=bank_mem_1[0][1]
+ D=FE_OFN220_bank_wdata_1__1 CK=CTS_676
Xbank_mem_1_reg[0][0] QDFFN $PINS Q=bank_mem_1[0][0]
+ D=FE_PHN1930_FE_OFN221_bank_wdata_1__0 CK=CTS_676
Xbank_mem_1_reg[1][33] QDFFN $PINS Q=bank_mem_1[1][33]
+ D=FE_PHN1896_FE_OFN193_bank_wdata_1__33 CK=CTS_673
Xbank_mem_1_reg[1][32] QDFFN $PINS Q=bank_mem_1[1][32]
+ D=FE_PHN1880_FE_OFN194_bank_wdata_1__32 CK=CTS_673
Xbank_mem_1_reg[1][31] QDFFN $PINS Q=bank_mem_1[1][31]
+ D=FE_PHN1942_FE_OFN195_bank_wdata_1__31 CK=CTS_673
Xbank_mem_1_reg[1][30] QDFFN $PINS Q=bank_mem_1[1][30]
+ D=FE_OFN196_bank_wdata_1__30 CK=CTS_673
Xbank_mem_1_reg[1][29] QDFFN $PINS Q=bank_mem_1[1][29]
+ D=FE_PHN1811_FE_OFN197_bank_wdata_1__29 CK=CTS_673
Xbank_mem_1_reg[1][28] QDFFN $PINS Q=bank_mem_1[1][28]
+ D=FE_PHN1819_FE_OFN198_bank_wdata_1__28 CK=CTS_673
Xbank_mem_1_reg[1][27] QDFFN $PINS Q=bank_mem_1[1][27]
+ D=FE_PHN1810_FE_OFN199_bank_wdata_1__27 CK=CTS_673
Xbank_mem_1_reg[1][26] QDFFN $PINS Q=bank_mem_1[1][26]
+ D=FE_OFN9_bank_wdata_1__26 CK=CTS_673
Xbank_mem_1_reg[1][25] QDFFN $PINS Q=bank_mem_1[1][25]
+ D=FE_OFN200_bank_wdata_1__25 CK=CTS_673
Xbank_mem_1_reg[1][24] QDFFN $PINS Q=bank_mem_1[1][24]
+ D=FE_PHN1817_FE_OFN201_bank_wdata_1__24 CK=CTS_673
Xbank_mem_1_reg[1][23] QDFFN $PINS Q=bank_mem_1[1][23]
+ D=FE_OFN481_bank_wdata_1__23 CK=CTS_673
Xbank_mem_1_reg[1][22] QDFFN $PINS Q=bank_mem_1[1][22]
+ D=FE_OFN202_bank_wdata_1__22 CK=CTS_673
Xbank_mem_1_reg[1][21] QDFFN $PINS Q=bank_mem_1[1][21]
+ D=FE_OFN203_bank_wdata_1__21 CK=CTS_673
Xbank_mem_1_reg[1][20] QDFFN $PINS Q=bank_mem_1[1][20]
+ D=FE_OFN204_bank_wdata_1__20 CK=CTS_673
Xbank_mem_1_reg[1][19] QDFFN $PINS Q=bank_mem_1[1][19]
+ D=FE_OFN205_bank_wdata_1__19 CK=CTS_673
Xbank_mem_1_reg[1][18] QDFFN $PINS Q=bank_mem_1[1][18]
+ D=FE_PHN1814_FE_OFN206_bank_wdata_1__18 CK=CTS_673
Xbank_mem_1_reg[1][17] QDFFN $PINS Q=bank_mem_1[1][17]
+ D=FE_OFN207_bank_wdata_1__17 CK=CTS_673
Xbank_mem_1_reg[1][16] QDFFN $PINS Q=bank_mem_1[1][16]
+ D=FE_OFN208_bank_wdata_1__16 CK=CTS_670
Xbank_mem_1_reg[1][15] QDFFN $PINS Q=bank_mem_1[1][15]
+ D=FE_OFN14_bank_wdata_1__15 CK=CTS_670
Xbank_mem_1_reg[1][14] QDFFN $PINS Q=bank_mem_1[1][14]
+ D=FE_OFN209_bank_wdata_1__14 CK=CTS_670
Xbank_mem_1_reg[1][13] QDFFN $PINS Q=bank_mem_1[1][13]
+ D=FE_OFN13_bank_wdata_1__13 CK=CTS_670
Xbank_mem_1_reg[1][12] QDFFN $PINS Q=bank_mem_1[1][12]
+ D=FE_PHN1868_FE_OFN10_bank_wdata_1__12 CK=CTS_670
Xbank_mem_1_reg[1][11] QDFFN $PINS Q=bank_mem_1[1][11]
+ D=FE_PHN1813_FE_OFN210_bank_wdata_1__11 CK=CTS_670
Xbank_mem_1_reg[1][10] QDFFN $PINS Q=bank_mem_1[1][10]
+ D=FE_PHN1816_FE_OFN211_bank_wdata_1__10 CK=CTS_670
Xbank_mem_1_reg[1][9] QDFFN $PINS Q=bank_mem_1[1][9]
+ D=FE_PHN1818_FE_OFN212_bank_wdata_1__9 CK=CTS_670
Xbank_mem_1_reg[1][8] QDFFN $PINS Q=bank_mem_1[1][8]
+ D=FE_PHN1823_FE_OFN213_bank_wdata_1__8 CK=CTS_670
Xbank_mem_1_reg[1][7] QDFFN $PINS Q=bank_mem_1[1][7]
+ D=FE_PHN1825_FE_OFN214_bank_wdata_1__7 CK=CTS_670
Xbank_mem_1_reg[1][6] QDFFN $PINS Q=bank_mem_1[1][6]
+ D=FE_OFN215_bank_wdata_1__6 CK=CTS_670
Xbank_mem_1_reg[1][5] QDFFN $PINS Q=bank_mem_1[1][5]
+ D=FE_OFN216_bank_wdata_1__5 CK=CTS_670
Xbank_mem_1_reg[1][4] QDFFN $PINS Q=bank_mem_1[1][4]
+ D=FE_OFN217_bank_wdata_1__4 CK=CTS_670
Xbank_mem_1_reg[1][3] QDFFN $PINS Q=bank_mem_1[1][3]
+ D=FE_PHN1995_FE_OFN218_bank_wdata_1__3 CK=CTS_670
Xbank_mem_1_reg[1][2] QDFFN $PINS Q=bank_mem_1[1][2]
+ D=FE_PHN1815_FE_OFN219_bank_wdata_1__2 CK=CTS_670
Xbank_mem_1_reg[1][1] QDFFN $PINS Q=bank_mem_1[1][1]
+ D=FE_OFN220_bank_wdata_1__1 CK=CTS_670
Xbank_mem_1_reg[1][0] QDFFN $PINS Q=bank_mem_1[1][0]
+ D=FE_PHN1930_FE_OFN221_bank_wdata_1__0 CK=CTS_670
Xbank_mem_0_reg[0][33] QDFFN $PINS Q=bank_mem_0[0][33] D=n900 CK=CTS_779
Xbank_mem_0_reg[0][32] QDFFN $PINS Q=bank_mem_0[0][32]
+ D=FE_PHN1919_FE_OFN174_bank_wdata_0__32 CK=CTS_779
Xbank_mem_0_reg[0][31] QDFFN $PINS Q=bank_mem_0[0][31]
+ D=FE_OFN175_bank_wdata_0__31 CK=CTS_779
Xbank_mem_0_reg[0][30] QDFFN $PINS Q=bank_mem_0[0][30]
+ D=FE_PHN1900_FE_OFN176_bank_wdata_0__30 CK=CTS_779
Xbank_mem_0_reg[0][29] QDFFN $PINS Q=bank_mem_0[0][29]
+ D=FE_OFN177_bank_wdata_0__29 CK=CTS_779
Xbank_mem_0_reg[0][28] QDFFN $PINS Q=bank_mem_0[0][28]
+ D=FE_OFN178_bank_wdata_0__28 CK=CTS_779
Xbank_mem_0_reg[0][27] QDFFN $PINS Q=bank_mem_0[0][27]
+ D=FE_OFN179_bank_wdata_0__27 CK=CTS_779
Xbank_mem_0_reg[0][26] QDFFN $PINS Q=bank_mem_0[0][26]
+ D=FE_OFN180_bank_wdata_0__26 CK=CTS_779
Xbank_mem_0_reg[0][25] QDFFN $PINS Q=bank_mem_0[0][25]
+ D=FE_OFN181_bank_wdata_0__25 CK=CTS_779
Xbank_mem_0_reg[0][24] QDFFN $PINS Q=bank_mem_0[0][24]
+ D=FE_OFN182_bank_wdata_0__24 CK=CTS_779
Xbank_mem_0_reg[0][23] QDFFN $PINS Q=bank_mem_0[0][23]
+ D=FE_OFN183_bank_wdata_0__23 CK=CTS_779
Xbank_mem_0_reg[0][22] QDFFN $PINS Q=bank_mem_0[0][22]
+ D=FE_OFN184_bank_wdata_0__22 CK=CTS_779
Xbank_mem_0_reg[0][21] QDFFN $PINS Q=bank_mem_0[0][21]
+ D=FE_OFN185_bank_wdata_0__21 CK=CTS_779
Xbank_mem_0_reg[0][20] QDFFN $PINS Q=bank_mem_0[0][20]
+ D=FE_OFN186_bank_wdata_0__20 CK=CTS_779
Xbank_mem_0_reg[0][19] QDFFN $PINS Q=bank_mem_0[0][19]
+ D=FE_OFN187_bank_wdata_0__19 CK=CTS_779
Xbank_mem_0_reg[0][18] QDFFN $PINS Q=bank_mem_0[0][18]
+ D=FE_PHN2042_FE_OFN188_bank_wdata_0__18 CK=CTS_779
Xbank_mem_0_reg[0][17] QDFFN $PINS Q=bank_mem_0[0][17]
+ D=FE_OFN189_bank_wdata_0__17 CK=CTS_779
Xbank_mem_0_reg[0][16] QDFFN $PINS Q=bank_mem_0[0][16] D=bank_wdata[0][16]
+ CK=CTS_634
Xbank_mem_0_reg[0][15] QDFFN $PINS Q=bank_mem_0[0][15] D=bank_wdata[0][15]
+ CK=CTS_634
Xbank_mem_0_reg[0][14] QDFFN $PINS Q=bank_mem_0[0][14] D=bank_wdata[0][14]
+ CK=CTS_634
Xbank_mem_0_reg[0][13] QDFFN $PINS Q=bank_mem_0[0][13] D=bank_wdata[0][13]
+ CK=CTS_634
Xbank_mem_0_reg[0][12] QDFFN $PINS Q=bank_mem_0[0][12]
+ D=FE_PHN2034_bank_wdata_0_12 CK=CTS_634
Xbank_mem_0_reg[0][11] QDFFN $PINS Q=bank_mem_0[0][11]
+ D=FE_PHN2041_bank_wdata_0_11 CK=CTS_634
Xbank_mem_0_reg[0][10] QDFFN $PINS Q=bank_mem_0[0][10]
+ D=FE_PHN2036_bank_wdata_0_10 CK=CTS_634
Xbank_mem_0_reg[0][9] QDFFN $PINS Q=bank_mem_0[0][9]
+ D=FE_PHN2038_bank_wdata_0_9 CK=CTS_634
Xbank_mem_0_reg[0][8] QDFFN $PINS Q=bank_mem_0[0][8]
+ D=FE_OFN480_bank_wdata_0__8 CK=CTS_634
Xbank_mem_0_reg[0][7] QDFFN $PINS Q=bank_mem_0[0][7]
+ D=FE_PHN2021_bank_wdata_0_7 CK=CTS_634
Xbank_mem_0_reg[0][6] QDFFN $PINS Q=bank_mem_0[0][6]
+ D=FE_OFN190_bank_wdata_0__6 CK=CTS_634
Xbank_mem_0_reg[0][5] QDFFN $PINS Q=bank_mem_0[0][5]
+ D=FE_OFN191_bank_wdata_0__5 CK=CTS_634
Xbank_mem_0_reg[0][4] QDFFN $PINS Q=bank_mem_0[0][4]
+ D=FE_PHN2138_bank_wdata_0_4 CK=CTS_634
Xbank_mem_0_reg[0][3] QDFFN $PINS Q=bank_mem_0[0][3]
+ D=FE_OFN192_bank_wdata_0__3 CK=CTS_634
Xbank_mem_0_reg[0][2] QDFFN $PINS Q=bank_mem_0[0][2]
+ D=FE_PHN2035_bank_wdata_0_2 CK=CTS_634
Xbank_mem_0_reg[0][1] QDFFN $PINS Q=bank_mem_0[0][1] D=bank_wdata[0][1]
+ CK=CTS_634
Xbank_mem_0_reg[0][0] QDFFN $PINS Q=bank_mem_0[0][0]
+ D=FE_PHN1846_FE_OFN11_bank_wdata_0__0 CK=CTS_634
Xbank_mem_0_reg[1][33] QDFFN $PINS Q=bank_mem_0[1][33] D=n900 CK=CTS_776
Xbank_mem_0_reg[1][32] QDFFN $PINS Q=bank_mem_0[1][32]
+ D=FE_PHN1919_FE_OFN174_bank_wdata_0__32 CK=CTS_776
Xbank_mem_0_reg[1][31] QDFFN $PINS Q=bank_mem_0[1][31]
+ D=FE_OFN175_bank_wdata_0__31 CK=CTS_776
Xbank_mem_0_reg[1][30] QDFFN $PINS Q=bank_mem_0[1][30]
+ D=FE_PHN1900_FE_OFN176_bank_wdata_0__30 CK=CTS_776
Xbank_mem_0_reg[1][29] QDFFN $PINS Q=bank_mem_0[1][29]
+ D=FE_OFN177_bank_wdata_0__29 CK=CTS_776
Xbank_mem_0_reg[1][28] QDFFN $PINS Q=bank_mem_0[1][28]
+ D=FE_OFN178_bank_wdata_0__28 CK=CTS_776
Xbank_mem_0_reg[1][27] QDFFN $PINS Q=bank_mem_0[1][27]
+ D=FE_OFN179_bank_wdata_0__27 CK=CTS_776
Xbank_mem_0_reg[1][26] QDFFN $PINS Q=bank_mem_0[1][26]
+ D=FE_OFN180_bank_wdata_0__26 CK=CTS_776
Xbank_mem_0_reg[1][25] QDFFN $PINS Q=bank_mem_0[1][25]
+ D=FE_OFN181_bank_wdata_0__25 CK=CTS_776
Xbank_mem_0_reg[1][24] QDFFN $PINS Q=bank_mem_0[1][24]
+ D=FE_OFN182_bank_wdata_0__24 CK=CTS_776
Xbank_mem_0_reg[1][23] QDFFN $PINS Q=bank_mem_0[1][23]
+ D=FE_OFN183_bank_wdata_0__23 CK=CTS_776
Xbank_mem_0_reg[1][22] QDFFN $PINS Q=bank_mem_0[1][22]
+ D=FE_OFN184_bank_wdata_0__22 CK=CTS_776
Xbank_mem_0_reg[1][21] QDFFN $PINS Q=bank_mem_0[1][21]
+ D=FE_OFN185_bank_wdata_0__21 CK=CTS_776
Xbank_mem_0_reg[1][20] QDFFN $PINS Q=bank_mem_0[1][20]
+ D=FE_OFN186_bank_wdata_0__20 CK=CTS_776
Xbank_mem_0_reg[1][19] QDFFN $PINS Q=bank_mem_0[1][19]
+ D=FE_OFN187_bank_wdata_0__19 CK=CTS_776
Xbank_mem_0_reg[1][18] QDFFN $PINS Q=bank_mem_0[1][18]
+ D=FE_PHN2042_FE_OFN188_bank_wdata_0__18 CK=CTS_776
Xbank_mem_0_reg[1][17] QDFFN $PINS Q=bank_mem_0[1][17]
+ D=FE_OFN189_bank_wdata_0__17 CK=CTS_776
Xbank_mem_0_reg[1][16] QDFFN $PINS Q=bank_mem_0[1][16] D=bank_wdata[0][16]
+ CK=CTS_631
Xbank_mem_0_reg[1][15] QDFFN $PINS Q=bank_mem_0[1][15] D=bank_wdata[0][15]
+ CK=CTS_631
Xbank_mem_0_reg[1][14] QDFFN $PINS Q=bank_mem_0[1][14] D=bank_wdata[0][14]
+ CK=CTS_631
Xbank_mem_0_reg[1][13] QDFFN $PINS Q=bank_mem_0[1][13] D=bank_wdata[0][13]
+ CK=CTS_631
Xbank_mem_0_reg[1][12] QDFFN $PINS Q=bank_mem_0[1][12]
+ D=FE_PHN2034_bank_wdata_0_12 CK=CTS_631
Xbank_mem_0_reg[1][11] QDFFN $PINS Q=bank_mem_0[1][11]
+ D=FE_PHN2041_bank_wdata_0_11 CK=CTS_631
Xbank_mem_0_reg[1][10] QDFFN $PINS Q=bank_mem_0[1][10]
+ D=FE_PHN2036_bank_wdata_0_10 CK=CTS_631
Xbank_mem_0_reg[1][9] QDFFN $PINS Q=bank_mem_0[1][9]
+ D=FE_PHN2038_bank_wdata_0_9 CK=CTS_631
Xbank_mem_0_reg[1][8] QDFFN $PINS Q=bank_mem_0[1][8]
+ D=FE_OFN480_bank_wdata_0__8 CK=CTS_631
Xbank_mem_0_reg[1][7] QDFFN $PINS Q=bank_mem_0[1][7]
+ D=FE_PHN2021_bank_wdata_0_7 CK=CTS_631
Xbank_mem_0_reg[1][6] QDFFN $PINS Q=bank_mem_0[1][6]
+ D=FE_OFN190_bank_wdata_0__6 CK=CTS_631
Xbank_mem_0_reg[1][5] QDFFN $PINS Q=bank_mem_0[1][5]
+ D=FE_OFN191_bank_wdata_0__5 CK=CTS_631
Xbank_mem_0_reg[1][4] QDFFN $PINS Q=bank_mem_0[1][4]
+ D=FE_PHN2138_bank_wdata_0_4 CK=CTS_631
Xbank_mem_0_reg[1][3] QDFFN $PINS Q=bank_mem_0[1][3]
+ D=FE_OFN192_bank_wdata_0__3 CK=CTS_631
Xbank_mem_0_reg[1][2] QDFFN $PINS Q=bank_mem_0[1][2]
+ D=FE_PHN2035_bank_wdata_0_2 CK=CTS_631
Xbank_mem_0_reg[1][1] QDFFN $PINS Q=bank_mem_0[1][1] D=bank_wdata[0][1]
+ CK=CTS_631
Xbank_mem_0_reg[1][0] QDFFN $PINS Q=bank_mem_0[1][0]
+ D=FE_PHN1846_FE_OFN11_bank_wdata_0__0 CK=CTS_631
Xbank_mem_1_reg[15][32] QDFFN $PINS Q=bank_mem_1[15][32]
+ D=FE_PHN1880_FE_OFN194_bank_wdata_1__32 CK=CTS_685
Xbank_mem_1_reg[15][31] QDFFN $PINS Q=bank_mem_1[15][31]
+ D=FE_PHN1942_FE_OFN195_bank_wdata_1__31 CK=CTS_685
Xbank_mem_1_reg[15][30] QDFFN $PINS Q=bank_mem_1[15][30]
+ D=FE_OFN196_bank_wdata_1__30 CK=CTS_685
Xbank_mem_1_reg[15][29] QDFFN $PINS Q=bank_mem_1[15][29]
+ D=FE_PHN1811_FE_OFN197_bank_wdata_1__29 CK=CTS_685
Xbank_mem_1_reg[15][28] QDFFN $PINS Q=bank_mem_1[15][28]
+ D=FE_PHN1819_FE_OFN198_bank_wdata_1__28 CK=CTS_685
Xbank_mem_1_reg[15][27] QDFFN $PINS Q=bank_mem_1[15][27]
+ D=FE_PHN1810_FE_OFN199_bank_wdata_1__27 CK=CTS_685
Xbank_mem_1_reg[15][26] QDFFN $PINS Q=bank_mem_1[15][26]
+ D=FE_OFN9_bank_wdata_1__26 CK=CTS_685
Xbank_mem_1_reg[15][25] QDFFN $PINS Q=bank_mem_1[15][25]
+ D=FE_OFN200_bank_wdata_1__25 CK=CTS_685
Xbank_mem_1_reg[15][24] QDFFN $PINS Q=bank_mem_1[15][24]
+ D=FE_PHN1817_FE_OFN201_bank_wdata_1__24 CK=CTS_685
Xbank_mem_1_reg[15][23] QDFFN $PINS Q=bank_mem_1[15][23]
+ D=FE_OFN481_bank_wdata_1__23 CK=CTS_685
Xbank_mem_1_reg[15][22] QDFFN $PINS Q=bank_mem_1[15][22]
+ D=FE_OFN202_bank_wdata_1__22 CK=CTS_685
Xbank_mem_1_reg[15][21] QDFFN $PINS Q=bank_mem_1[15][21]
+ D=FE_OFN203_bank_wdata_1__21 CK=CTS_685
Xbank_mem_1_reg[15][20] QDFFN $PINS Q=bank_mem_1[15][20]
+ D=FE_OFN204_bank_wdata_1__20 CK=CTS_685
Xbank_mem_1_reg[15][19] QDFFN $PINS Q=bank_mem_1[15][19]
+ D=FE_OFN205_bank_wdata_1__19 CK=CTS_685
Xbank_mem_1_reg[15][18] QDFFN $PINS Q=bank_mem_1[15][18]
+ D=FE_PHN1814_FE_OFN206_bank_wdata_1__18 CK=CTS_685
Xbank_mem_1_reg[15][17] QDFFN $PINS Q=bank_mem_1[15][17]
+ D=FE_OFN207_bank_wdata_1__17 CK=CTS_685
Xbank_mem_1_reg[15][16] QDFFN $PINS Q=bank_mem_1[15][16]
+ D=FE_OFN208_bank_wdata_1__16 CK=CTS_682
Xbank_mem_1_reg[15][15] QDFFN $PINS Q=bank_mem_1[15][15]
+ D=FE_OFN14_bank_wdata_1__15 CK=CTS_682
Xbank_mem_1_reg[15][14] QDFFN $PINS Q=bank_mem_1[15][14]
+ D=FE_OFN209_bank_wdata_1__14 CK=CTS_682
Xbank_mem_1_reg[15][13] QDFFN $PINS Q=bank_mem_1[15][13]
+ D=FE_OFN13_bank_wdata_1__13 CK=CTS_682
Xbank_mem_1_reg[15][12] QDFFN $PINS Q=bank_mem_1[15][12]
+ D=FE_PHN1868_FE_OFN10_bank_wdata_1__12 CK=CTS_682
Xbank_mem_1_reg[15][11] QDFFN $PINS Q=bank_mem_1[15][11]
+ D=FE_PHN1813_FE_OFN210_bank_wdata_1__11 CK=CTS_682
Xbank_mem_1_reg[15][10] QDFFN $PINS Q=bank_mem_1[15][10]
+ D=FE_PHN1816_FE_OFN211_bank_wdata_1__10 CK=CTS_682
Xbank_mem_1_reg[15][9] QDFFN $PINS Q=bank_mem_1[15][9]
+ D=FE_PHN1818_FE_OFN212_bank_wdata_1__9 CK=CTS_682
Xbank_mem_1_reg[15][8] QDFFN $PINS Q=bank_mem_1[15][8]
+ D=FE_PHN1823_FE_OFN213_bank_wdata_1__8 CK=CTS_682
Xbank_mem_1_reg[15][7] QDFFN $PINS Q=bank_mem_1[15][7]
+ D=FE_PHN1825_FE_OFN214_bank_wdata_1__7 CK=CTS_682
Xbank_mem_1_reg[15][6] QDFFN $PINS Q=bank_mem_1[15][6]
+ D=FE_OFN215_bank_wdata_1__6 CK=CTS_682
Xbank_mem_1_reg[15][5] QDFFN $PINS Q=bank_mem_1[15][5]
+ D=FE_OFN216_bank_wdata_1__5 CK=CTS_682
Xbank_mem_1_reg[15][4] QDFFN $PINS Q=bank_mem_1[15][4]
+ D=FE_OFN217_bank_wdata_1__4 CK=CTS_682
Xbank_mem_1_reg[15][3] QDFFN $PINS Q=bank_mem_1[15][3]
+ D=FE_PHN1995_FE_OFN218_bank_wdata_1__3 CK=CTS_682
Xbank_mem_1_reg[15][2] QDFFN $PINS Q=bank_mem_1[15][2]
+ D=FE_PHN1815_FE_OFN219_bank_wdata_1__2 CK=CTS_682
Xbank_mem_1_reg[15][1] QDFFN $PINS Q=bank_mem_1[15][1]
+ D=FE_OFN220_bank_wdata_1__1 CK=CTS_682
Xbank_mem_1_reg[15][0] QDFFN $PINS Q=bank_mem_1[15][0]
+ D=FE_PHN1930_FE_OFN221_bank_wdata_1__0 CK=CTS_682
Xbank_mem_1_reg[13][32] QDFFN $PINS Q=bank_mem_1[13][32]
+ D=FE_PHN1880_FE_OFN194_bank_wdata_1__32 CK=CTS_697
Xbank_mem_1_reg[13][31] QDFFN $PINS Q=bank_mem_1[13][31]
+ D=FE_PHN1942_FE_OFN195_bank_wdata_1__31 CK=CTS_697
Xbank_mem_1_reg[13][30] QDFFN $PINS Q=bank_mem_1[13][30]
+ D=FE_OFN196_bank_wdata_1__30 CK=CTS_697
Xbank_mem_1_reg[13][29] QDFFN $PINS Q=bank_mem_1[13][29]
+ D=FE_PHN1811_FE_OFN197_bank_wdata_1__29 CK=CTS_697
Xbank_mem_1_reg[13][28] QDFFN $PINS Q=bank_mem_1[13][28]
+ D=FE_PHN1819_FE_OFN198_bank_wdata_1__28 CK=CTS_697
Xbank_mem_1_reg[13][27] QDFFN $PINS Q=bank_mem_1[13][27]
+ D=FE_PHN1810_FE_OFN199_bank_wdata_1__27 CK=CTS_697
Xbank_mem_1_reg[13][26] QDFFN $PINS Q=bank_mem_1[13][26]
+ D=FE_OFN9_bank_wdata_1__26 CK=CTS_697
Xbank_mem_1_reg[13][25] QDFFN $PINS Q=bank_mem_1[13][25]
+ D=FE_OFN200_bank_wdata_1__25 CK=CTS_697
Xbank_mem_1_reg[13][24] QDFFN $PINS Q=bank_mem_1[13][24]
+ D=FE_PHN1817_FE_OFN201_bank_wdata_1__24 CK=CTS_697
Xbank_mem_1_reg[13][23] QDFFN $PINS Q=bank_mem_1[13][23]
+ D=FE_OFN481_bank_wdata_1__23 CK=CTS_697
Xbank_mem_1_reg[13][22] QDFFN $PINS Q=bank_mem_1[13][22]
+ D=FE_OFN202_bank_wdata_1__22 CK=CTS_697
Xbank_mem_1_reg[13][21] QDFFN $PINS Q=bank_mem_1[13][21]
+ D=FE_OFN203_bank_wdata_1__21 CK=CTS_697
Xbank_mem_1_reg[13][20] QDFFN $PINS Q=bank_mem_1[13][20]
+ D=FE_OFN204_bank_wdata_1__20 CK=CTS_697
Xbank_mem_1_reg[13][19] QDFFN $PINS Q=bank_mem_1[13][19]
+ D=FE_OFN205_bank_wdata_1__19 CK=CTS_697
Xbank_mem_1_reg[13][18] QDFFN $PINS Q=bank_mem_1[13][18]
+ D=FE_PHN1814_FE_OFN206_bank_wdata_1__18 CK=CTS_697
Xbank_mem_1_reg[13][17] QDFFN $PINS Q=bank_mem_1[13][17]
+ D=FE_OFN207_bank_wdata_1__17 CK=CTS_697
Xbank_mem_1_reg[13][16] QDFFN $PINS Q=bank_mem_1[13][16]
+ D=FE_OFN208_bank_wdata_1__16 CK=CTS_694
Xbank_mem_1_reg[13][15] QDFFN $PINS Q=bank_mem_1[13][15]
+ D=FE_OFN14_bank_wdata_1__15 CK=CTS_694
Xbank_mem_1_reg[13][14] QDFFN $PINS Q=bank_mem_1[13][14]
+ D=FE_OFN209_bank_wdata_1__14 CK=CTS_694
Xbank_mem_1_reg[13][13] QDFFN $PINS Q=bank_mem_1[13][13]
+ D=FE_OFN13_bank_wdata_1__13 CK=CTS_694
Xbank_mem_1_reg[13][12] QDFFN $PINS Q=bank_mem_1[13][12]
+ D=FE_PHN1868_FE_OFN10_bank_wdata_1__12 CK=CTS_694
Xbank_mem_1_reg[13][11] QDFFN $PINS Q=bank_mem_1[13][11]
+ D=FE_PHN1813_FE_OFN210_bank_wdata_1__11 CK=CTS_694
Xbank_mem_1_reg[13][10] QDFFN $PINS Q=bank_mem_1[13][10]
+ D=FE_PHN1816_FE_OFN211_bank_wdata_1__10 CK=CTS_694
Xbank_mem_1_reg[13][9] QDFFN $PINS Q=bank_mem_1[13][9]
+ D=FE_PHN1818_FE_OFN212_bank_wdata_1__9 CK=CTS_694
Xbank_mem_1_reg[13][8] QDFFN $PINS Q=bank_mem_1[13][8]
+ D=FE_PHN1823_FE_OFN213_bank_wdata_1__8 CK=CTS_694
Xbank_mem_1_reg[13][7] QDFFN $PINS Q=bank_mem_1[13][7]
+ D=FE_PHN1825_FE_OFN214_bank_wdata_1__7 CK=CTS_694
Xbank_mem_1_reg[13][6] QDFFN $PINS Q=bank_mem_1[13][6]
+ D=FE_OFN215_bank_wdata_1__6 CK=CTS_694
Xbank_mem_1_reg[13][5] QDFFN $PINS Q=bank_mem_1[13][5]
+ D=FE_OFN216_bank_wdata_1__5 CK=CTS_694
Xbank_mem_1_reg[13][4] QDFFN $PINS Q=bank_mem_1[13][4]
+ D=FE_OFN217_bank_wdata_1__4 CK=CTS_694
Xbank_mem_1_reg[13][3] QDFFN $PINS Q=bank_mem_1[13][3]
+ D=FE_PHN1995_FE_OFN218_bank_wdata_1__3 CK=CTS_694
Xbank_mem_1_reg[13][2] QDFFN $PINS Q=bank_mem_1[13][2]
+ D=FE_PHN1815_FE_OFN219_bank_wdata_1__2 CK=CTS_694
Xbank_mem_1_reg[13][1] QDFFN $PINS Q=bank_mem_1[13][1]
+ D=FE_OFN220_bank_wdata_1__1 CK=CTS_694
Xbank_mem_1_reg[13][0] QDFFN $PINS Q=bank_mem_1[13][0]
+ D=FE_PHN1930_FE_OFN221_bank_wdata_1__0 CK=CTS_694
Xbank_mem_1_reg[14][32] QDFFN $PINS Q=bank_mem_1[14][32]
+ D=FE_PHN1880_FE_OFN194_bank_wdata_1__32 CK=CTS_691
Xbank_mem_1_reg[14][31] QDFFN $PINS Q=bank_mem_1[14][31]
+ D=FE_PHN1942_FE_OFN195_bank_wdata_1__31 CK=CTS_691
Xbank_mem_1_reg[14][30] QDFFN $PINS Q=bank_mem_1[14][30]
+ D=FE_OFN196_bank_wdata_1__30 CK=CTS_691
Xbank_mem_1_reg[14][29] QDFFN $PINS Q=bank_mem_1[14][29]
+ D=FE_PHN1811_FE_OFN197_bank_wdata_1__29 CK=CTS_691
Xbank_mem_1_reg[14][28] QDFFN $PINS Q=bank_mem_1[14][28]
+ D=FE_PHN1819_FE_OFN198_bank_wdata_1__28 CK=CTS_691
Xbank_mem_1_reg[14][27] QDFFN $PINS Q=bank_mem_1[14][27]
+ D=FE_PHN1810_FE_OFN199_bank_wdata_1__27 CK=CTS_691
Xbank_mem_1_reg[14][26] QDFFN $PINS Q=bank_mem_1[14][26]
+ D=FE_OFN9_bank_wdata_1__26 CK=CTS_691
Xbank_mem_1_reg[14][25] QDFFN $PINS Q=bank_mem_1[14][25]
+ D=FE_OFN200_bank_wdata_1__25 CK=CTS_691
Xbank_mem_1_reg[14][24] QDFFN $PINS Q=bank_mem_1[14][24]
+ D=FE_PHN1817_FE_OFN201_bank_wdata_1__24 CK=CTS_691
Xbank_mem_1_reg[14][23] QDFFN $PINS Q=bank_mem_1[14][23]
+ D=FE_OFN481_bank_wdata_1__23 CK=CTS_691
Xbank_mem_1_reg[14][22] QDFFN $PINS Q=bank_mem_1[14][22]
+ D=FE_OFN202_bank_wdata_1__22 CK=CTS_691
Xbank_mem_1_reg[14][21] QDFFN $PINS Q=bank_mem_1[14][21]
+ D=FE_OFN203_bank_wdata_1__21 CK=CTS_691
Xbank_mem_1_reg[14][20] QDFFN $PINS Q=bank_mem_1[14][20]
+ D=FE_OFN204_bank_wdata_1__20 CK=CTS_691
Xbank_mem_1_reg[14][19] QDFFN $PINS Q=bank_mem_1[14][19]
+ D=FE_OFN205_bank_wdata_1__19 CK=CTS_691
Xbank_mem_1_reg[14][18] QDFFN $PINS Q=bank_mem_1[14][18]
+ D=FE_PHN1814_FE_OFN206_bank_wdata_1__18 CK=CTS_691
Xbank_mem_1_reg[14][17] QDFFN $PINS Q=bank_mem_1[14][17]
+ D=FE_OFN207_bank_wdata_1__17 CK=CTS_691
Xbank_mem_1_reg[14][16] QDFFN $PINS Q=bank_mem_1[14][16]
+ D=FE_OFN208_bank_wdata_1__16 CK=CTS_688
Xbank_mem_1_reg[14][15] QDFFN $PINS Q=bank_mem_1[14][15]
+ D=FE_OFN14_bank_wdata_1__15 CK=CTS_688
Xbank_mem_1_reg[14][14] QDFFN $PINS Q=bank_mem_1[14][14]
+ D=FE_OFN209_bank_wdata_1__14 CK=CTS_688
Xbank_mem_1_reg[14][13] QDFFN $PINS Q=bank_mem_1[14][13]
+ D=FE_OFN13_bank_wdata_1__13 CK=CTS_688
Xbank_mem_1_reg[14][12] QDFFN $PINS Q=bank_mem_1[14][12]
+ D=FE_PHN1868_FE_OFN10_bank_wdata_1__12 CK=CTS_688
Xbank_mem_1_reg[14][11] QDFFN $PINS Q=bank_mem_1[14][11]
+ D=FE_PHN1813_FE_OFN210_bank_wdata_1__11 CK=CTS_688
Xbank_mem_1_reg[14][10] QDFFN $PINS Q=bank_mem_1[14][10]
+ D=FE_PHN1816_FE_OFN211_bank_wdata_1__10 CK=CTS_688
Xbank_mem_1_reg[14][9] QDFFN $PINS Q=bank_mem_1[14][9]
+ D=FE_PHN1818_FE_OFN212_bank_wdata_1__9 CK=CTS_688
Xbank_mem_1_reg[14][8] QDFFN $PINS Q=bank_mem_1[14][8]
+ D=FE_PHN1823_FE_OFN213_bank_wdata_1__8 CK=CTS_688
Xbank_mem_1_reg[14][7] QDFFN $PINS Q=bank_mem_1[14][7]
+ D=FE_PHN1825_FE_OFN214_bank_wdata_1__7 CK=CTS_688
Xbank_mem_1_reg[14][6] QDFFN $PINS Q=bank_mem_1[14][6]
+ D=FE_OFN215_bank_wdata_1__6 CK=CTS_688
Xbank_mem_1_reg[14][5] QDFFN $PINS Q=bank_mem_1[14][5]
+ D=FE_OFN216_bank_wdata_1__5 CK=CTS_688
Xbank_mem_1_reg[14][4] QDFFN $PINS Q=bank_mem_1[14][4]
+ D=FE_OFN217_bank_wdata_1__4 CK=CTS_688
Xbank_mem_1_reg[14][3] QDFFN $PINS Q=bank_mem_1[14][3]
+ D=FE_PHN1995_FE_OFN218_bank_wdata_1__3 CK=CTS_688
Xbank_mem_1_reg[14][2] QDFFN $PINS Q=bank_mem_1[14][2]
+ D=FE_PHN1815_FE_OFN219_bank_wdata_1__2 CK=CTS_688
Xbank_mem_1_reg[14][1] QDFFN $PINS Q=bank_mem_1[14][1]
+ D=FE_OFN220_bank_wdata_1__1 CK=CTS_688
Xbank_mem_1_reg[14][0] QDFFN $PINS Q=bank_mem_1[14][0]
+ D=FE_PHN1930_FE_OFN221_bank_wdata_1__0 CK=CTS_688
Xbank_mem_1_reg[15][33] QDFFN $PINS Q=bank_mem_1[15][33]
+ D=FE_PHN1896_FE_OFN193_bank_wdata_1__33 CK=CTS_685
Xbank_mem_1_reg[12][32] QDFFN $PINS Q=bank_mem_1[12][32]
+ D=FE_PHN1880_FE_OFN194_bank_wdata_1__32 CK=CTS_703
Xbank_mem_1_reg[12][31] QDFFN $PINS Q=bank_mem_1[12][31]
+ D=FE_PHN1942_FE_OFN195_bank_wdata_1__31 CK=CTS_703
Xbank_mem_1_reg[12][30] QDFFN $PINS Q=bank_mem_1[12][30]
+ D=FE_OFN196_bank_wdata_1__30 CK=CTS_703
Xbank_mem_1_reg[12][29] QDFFN $PINS Q=bank_mem_1[12][29]
+ D=FE_PHN1811_FE_OFN197_bank_wdata_1__29 CK=CTS_703
Xbank_mem_1_reg[12][28] QDFFN $PINS Q=bank_mem_1[12][28]
+ D=FE_PHN1819_FE_OFN198_bank_wdata_1__28 CK=CTS_703
Xbank_mem_1_reg[12][27] QDFFN $PINS Q=bank_mem_1[12][27]
+ D=FE_PHN1810_FE_OFN199_bank_wdata_1__27 CK=CTS_703
Xbank_mem_1_reg[12][26] QDFFN $PINS Q=bank_mem_1[12][26]
+ D=FE_OFN9_bank_wdata_1__26 CK=CTS_703
Xbank_mem_1_reg[12][25] QDFFN $PINS Q=bank_mem_1[12][25]
+ D=FE_OFN200_bank_wdata_1__25 CK=CTS_703
Xbank_mem_1_reg[12][24] QDFFN $PINS Q=bank_mem_1[12][24]
+ D=FE_PHN1817_FE_OFN201_bank_wdata_1__24 CK=CTS_703
Xbank_mem_1_reg[12][23] QDFFN $PINS Q=bank_mem_1[12][23]
+ D=FE_OFN481_bank_wdata_1__23 CK=CTS_703
Xbank_mem_1_reg[12][22] QDFFN $PINS Q=bank_mem_1[12][22]
+ D=FE_OFN202_bank_wdata_1__22 CK=CTS_703
Xbank_mem_1_reg[12][21] QDFFN $PINS Q=bank_mem_1[12][21]
+ D=FE_OFN203_bank_wdata_1__21 CK=CTS_703
Xbank_mem_1_reg[12][20] QDFFN $PINS Q=bank_mem_1[12][20]
+ D=FE_OFN204_bank_wdata_1__20 CK=CTS_703
Xbank_mem_1_reg[12][19] QDFFN $PINS Q=bank_mem_1[12][19]
+ D=FE_OFN205_bank_wdata_1__19 CK=CTS_703
Xbank_mem_1_reg[12][18] QDFFN $PINS Q=bank_mem_1[12][18]
+ D=FE_PHN1814_FE_OFN206_bank_wdata_1__18 CK=CTS_703
Xbank_mem_1_reg[12][17] QDFFN $PINS Q=bank_mem_1[12][17]
+ D=FE_OFN207_bank_wdata_1__17 CK=CTS_703
Xbank_mem_1_reg[12][16] QDFFN $PINS Q=bank_mem_1[12][16]
+ D=FE_OFN208_bank_wdata_1__16 CK=CTS_700
Xbank_mem_1_reg[12][15] QDFFN $PINS Q=bank_mem_1[12][15]
+ D=FE_OFN14_bank_wdata_1__15 CK=CTS_700
Xbank_mem_1_reg[12][14] QDFFN $PINS Q=bank_mem_1[12][14]
+ D=FE_OFN209_bank_wdata_1__14 CK=CTS_700
Xbank_mem_1_reg[12][13] QDFFN $PINS Q=bank_mem_1[12][13]
+ D=FE_OFN13_bank_wdata_1__13 CK=CTS_700
Xbank_mem_1_reg[12][12] QDFFN $PINS Q=bank_mem_1[12][12]
+ D=FE_PHN1868_FE_OFN10_bank_wdata_1__12 CK=CTS_700
Xbank_mem_1_reg[12][11] QDFFN $PINS Q=bank_mem_1[12][11]
+ D=FE_PHN1813_FE_OFN210_bank_wdata_1__11 CK=CTS_700
Xbank_mem_1_reg[12][10] QDFFN $PINS Q=bank_mem_1[12][10]
+ D=FE_PHN1816_FE_OFN211_bank_wdata_1__10 CK=CTS_700
Xbank_mem_1_reg[12][9] QDFFN $PINS Q=bank_mem_1[12][9]
+ D=FE_PHN1818_FE_OFN212_bank_wdata_1__9 CK=CTS_700
Xbank_mem_1_reg[12][8] QDFFN $PINS Q=bank_mem_1[12][8]
+ D=FE_PHN1823_FE_OFN213_bank_wdata_1__8 CK=CTS_700
Xbank_mem_1_reg[12][7] QDFFN $PINS Q=bank_mem_1[12][7]
+ D=FE_PHN1825_FE_OFN214_bank_wdata_1__7 CK=CTS_700
Xbank_mem_1_reg[12][6] QDFFN $PINS Q=bank_mem_1[12][6]
+ D=FE_OFN215_bank_wdata_1__6 CK=CTS_700
Xbank_mem_1_reg[12][5] QDFFN $PINS Q=bank_mem_1[12][5]
+ D=FE_OFN216_bank_wdata_1__5 CK=CTS_700
Xbank_mem_1_reg[12][4] QDFFN $PINS Q=bank_mem_1[12][4]
+ D=FE_OFN217_bank_wdata_1__4 CK=CTS_700
Xbank_mem_1_reg[12][3] QDFFN $PINS Q=bank_mem_1[12][3]
+ D=FE_PHN1995_FE_OFN218_bank_wdata_1__3 CK=CTS_700
Xbank_mem_1_reg[12][2] QDFFN $PINS Q=bank_mem_1[12][2]
+ D=FE_PHN1815_FE_OFN219_bank_wdata_1__2 CK=CTS_700
Xbank_mem_1_reg[12][1] QDFFN $PINS Q=bank_mem_1[12][1]
+ D=FE_OFN220_bank_wdata_1__1 CK=CTS_700
Xbank_mem_1_reg[12][0] QDFFN $PINS Q=bank_mem_1[12][0]
+ D=FE_PHN1930_FE_OFN221_bank_wdata_1__0 CK=CTS_700
Xbank_mem_1_reg[13][33] QDFFN $PINS Q=bank_mem_1[13][33]
+ D=FE_PHN1896_FE_OFN193_bank_wdata_1__33 CK=CTS_697
Xbank_mem_0_reg[15][32] QDFFN $PINS Q=bank_mem_0[15][32]
+ D=FE_PHN1919_FE_OFN174_bank_wdata_0__32 CK=CTS_734
Xbank_mem_0_reg[15][31] QDFFN $PINS Q=bank_mem_0[15][31]
+ D=FE_OFN175_bank_wdata_0__31 CK=CTS_734
Xbank_mem_0_reg[15][30] QDFFN $PINS Q=bank_mem_0[15][30]
+ D=FE_PHN1900_FE_OFN176_bank_wdata_0__30 CK=CTS_734
Xbank_mem_0_reg[15][29] QDFFN $PINS Q=bank_mem_0[15][29]
+ D=FE_OFN177_bank_wdata_0__29 CK=CTS_734
Xbank_mem_0_reg[15][28] QDFFN $PINS Q=bank_mem_0[15][28]
+ D=FE_OFN178_bank_wdata_0__28 CK=CTS_734
Xbank_mem_0_reg[15][27] QDFFN $PINS Q=bank_mem_0[15][27]
+ D=FE_OFN179_bank_wdata_0__27 CK=CTS_734
Xbank_mem_0_reg[15][26] QDFFN $PINS Q=bank_mem_0[15][26]
+ D=FE_OFN180_bank_wdata_0__26 CK=CTS_734
Xbank_mem_0_reg[15][25] QDFFN $PINS Q=bank_mem_0[15][25]
+ D=FE_OFN181_bank_wdata_0__25 CK=CTS_734
Xbank_mem_0_reg[15][24] QDFFN $PINS Q=bank_mem_0[15][24]
+ D=FE_OFN182_bank_wdata_0__24 CK=CTS_734
Xbank_mem_0_reg[15][23] QDFFN $PINS Q=bank_mem_0[15][23]
+ D=FE_OFN183_bank_wdata_0__23 CK=CTS_734
Xbank_mem_0_reg[15][22] QDFFN $PINS Q=bank_mem_0[15][22]
+ D=FE_OFN184_bank_wdata_0__22 CK=CTS_734
Xbank_mem_0_reg[15][21] QDFFN $PINS Q=bank_mem_0[15][21]
+ D=FE_OFN185_bank_wdata_0__21 CK=CTS_734
Xbank_mem_0_reg[15][20] QDFFN $PINS Q=bank_mem_0[15][20]
+ D=FE_OFN186_bank_wdata_0__20 CK=CTS_734
Xbank_mem_0_reg[15][19] QDFFN $PINS Q=bank_mem_0[15][19]
+ D=FE_OFN187_bank_wdata_0__19 CK=CTS_734
Xbank_mem_0_reg[15][18] QDFFN $PINS Q=bank_mem_0[15][18]
+ D=FE_PHN2042_FE_OFN188_bank_wdata_0__18 CK=CTS_734
Xbank_mem_0_reg[15][17] QDFFN $PINS Q=bank_mem_0[15][17]
+ D=FE_OFN189_bank_wdata_0__17 CK=CTS_734
Xbank_mem_0_reg[15][16] QDFFN $PINS Q=bank_mem_0[15][16] D=bank_wdata[0][16]
+ CK=CTS_589
Xbank_mem_0_reg[15][15] QDFFN $PINS Q=bank_mem_0[15][15] D=bank_wdata[0][15]
+ CK=CTS_589
Xbank_mem_0_reg[15][14] QDFFN $PINS Q=bank_mem_0[15][14]
+ D=FE_PHN2197_bank_wdata_0_14 CK=CTS_589
Xbank_mem_0_reg[15][13] QDFFN $PINS Q=bank_mem_0[15][13] D=bank_wdata[0][13]
+ CK=CTS_589
Xbank_mem_0_reg[15][12] QDFFN $PINS Q=bank_mem_0[15][12]
+ D=FE_PHN2034_bank_wdata_0_12 CK=CTS_589
Xbank_mem_0_reg[15][11] QDFFN $PINS Q=bank_mem_0[15][11]
+ D=FE_PHN2041_bank_wdata_0_11 CK=CTS_589
Xbank_mem_0_reg[15][10] QDFFN $PINS Q=bank_mem_0[15][10]
+ D=FE_PHN2036_bank_wdata_0_10 CK=CTS_589
Xbank_mem_0_reg[15][9] QDFFN $PINS Q=bank_mem_0[15][9]
+ D=FE_PHN2038_bank_wdata_0_9 CK=CTS_589
Xbank_mem_0_reg[15][8] QDFFN $PINS Q=bank_mem_0[15][8]
+ D=FE_OFN480_bank_wdata_0__8 CK=CTS_589
Xbank_mem_0_reg[15][7] QDFFN $PINS Q=bank_mem_0[15][7]
+ D=FE_PHN2021_bank_wdata_0_7 CK=CTS_589
Xbank_mem_0_reg[15][6] QDFFN $PINS Q=bank_mem_0[15][6]
+ D=FE_OFN190_bank_wdata_0__6 CK=CTS_589
Xbank_mem_0_reg[15][5] QDFFN $PINS Q=bank_mem_0[15][5]
+ D=FE_OFN191_bank_wdata_0__5 CK=CTS_589
Xbank_mem_0_reg[15][4] QDFFN $PINS Q=bank_mem_0[15][4]
+ D=FE_PHN2138_bank_wdata_0_4 CK=CTS_589
Xbank_mem_0_reg[15][3] QDFFN $PINS Q=bank_mem_0[15][3]
+ D=FE_OFN192_bank_wdata_0__3 CK=CTS_589
Xbank_mem_0_reg[15][2] QDFFN $PINS Q=bank_mem_0[15][2]
+ D=FE_PHN2035_bank_wdata_0_2 CK=CTS_589
Xbank_mem_0_reg[15][1] QDFFN $PINS Q=bank_mem_0[15][1] D=bank_wdata[0][1]
+ CK=CTS_589
Xbank_mem_0_reg[15][0] QDFFN $PINS Q=bank_mem_0[15][0]
+ D=FE_PHN1846_FE_OFN11_bank_wdata_0__0 CK=CTS_589
Xbank_mem_0_reg[13][32] QDFFN $PINS Q=bank_mem_0[13][32]
+ D=FE_PHN1919_FE_OFN174_bank_wdata_0__32 CK=CTS_740
Xbank_mem_0_reg[13][31] QDFFN $PINS Q=bank_mem_0[13][31]
+ D=FE_OFN175_bank_wdata_0__31 CK=CTS_740
Xbank_mem_0_reg[13][30] QDFFN $PINS Q=bank_mem_0[13][30]
+ D=FE_PHN1900_FE_OFN176_bank_wdata_0__30 CK=CTS_740
Xbank_mem_0_reg[13][29] QDFFN $PINS Q=bank_mem_0[13][29]
+ D=FE_OFN177_bank_wdata_0__29 CK=CTS_740
Xbank_mem_0_reg[13][28] QDFFN $PINS Q=bank_mem_0[13][28]
+ D=FE_OFN178_bank_wdata_0__28 CK=CTS_740
Xbank_mem_0_reg[13][27] QDFFN $PINS Q=bank_mem_0[13][27]
+ D=FE_OFN179_bank_wdata_0__27 CK=CTS_740
Xbank_mem_0_reg[13][26] QDFFN $PINS Q=bank_mem_0[13][26]
+ D=FE_OFN180_bank_wdata_0__26 CK=CTS_740
Xbank_mem_0_reg[13][25] QDFFN $PINS Q=bank_mem_0[13][25]
+ D=FE_OFN181_bank_wdata_0__25 CK=CTS_740
Xbank_mem_0_reg[13][24] QDFFN $PINS Q=bank_mem_0[13][24]
+ D=FE_OFN182_bank_wdata_0__24 CK=CTS_740
Xbank_mem_0_reg[13][23] QDFFN $PINS Q=bank_mem_0[13][23]
+ D=FE_OFN183_bank_wdata_0__23 CK=CTS_740
Xbank_mem_0_reg[13][22] QDFFN $PINS Q=bank_mem_0[13][22]
+ D=FE_OFN184_bank_wdata_0__22 CK=CTS_740
Xbank_mem_0_reg[13][21] QDFFN $PINS Q=bank_mem_0[13][21]
+ D=FE_OFN185_bank_wdata_0__21 CK=CTS_740
Xbank_mem_0_reg[13][20] QDFFN $PINS Q=bank_mem_0[13][20]
+ D=FE_OFN186_bank_wdata_0__20 CK=CTS_740
Xbank_mem_0_reg[13][19] QDFFN $PINS Q=bank_mem_0[13][19]
+ D=FE_OFN187_bank_wdata_0__19 CK=CTS_740
Xbank_mem_0_reg[13][18] QDFFN $PINS Q=bank_mem_0[13][18]
+ D=FE_PHN2042_FE_OFN188_bank_wdata_0__18 CK=CTS_740
Xbank_mem_0_reg[13][17] QDFFN $PINS Q=bank_mem_0[13][17]
+ D=FE_OFN189_bank_wdata_0__17 CK=CTS_740
Xbank_mem_0_reg[13][16] QDFFN $PINS Q=bank_mem_0[13][16] D=bank_wdata[0][16]
+ CK=CTS_595
Xbank_mem_0_reg[13][15] QDFFN $PINS Q=bank_mem_0[13][15] D=bank_wdata[0][15]
+ CK=CTS_595
Xbank_mem_0_reg[13][14] QDFFN $PINS Q=bank_mem_0[13][14] D=bank_wdata[0][14]
+ CK=CTS_595
Xbank_mem_0_reg[13][13] QDFFN $PINS Q=bank_mem_0[13][13] D=bank_wdata[0][13]
+ CK=CTS_595
Xbank_mem_0_reg[13][12] QDFFN $PINS Q=bank_mem_0[13][12]
+ D=FE_PHN2034_bank_wdata_0_12 CK=CTS_595
Xbank_mem_0_reg[13][11] QDFFN $PINS Q=bank_mem_0[13][11]
+ D=FE_PHN2041_bank_wdata_0_11 CK=CTS_595
Xbank_mem_0_reg[13][10] QDFFN $PINS Q=bank_mem_0[13][10]
+ D=FE_PHN2036_bank_wdata_0_10 CK=CTS_595
Xbank_mem_0_reg[13][9] QDFFN $PINS Q=bank_mem_0[13][9]
+ D=FE_PHN2038_bank_wdata_0_9 CK=CTS_595
Xbank_mem_0_reg[13][8] QDFFN $PINS Q=bank_mem_0[13][8]
+ D=FE_OFN480_bank_wdata_0__8 CK=CTS_595
Xbank_mem_0_reg[13][7] QDFFN $PINS Q=bank_mem_0[13][7]
+ D=FE_PHN2021_bank_wdata_0_7 CK=CTS_595
Xbank_mem_0_reg[13][6] QDFFN $PINS Q=bank_mem_0[13][6]
+ D=FE_OFN190_bank_wdata_0__6 CK=CTS_595
Xbank_mem_0_reg[13][5] QDFFN $PINS Q=bank_mem_0[13][5]
+ D=FE_OFN191_bank_wdata_0__5 CK=CTS_595
Xbank_mem_0_reg[13][4] QDFFN $PINS Q=bank_mem_0[13][4]
+ D=FE_PHN2138_bank_wdata_0_4 CK=CTS_595
Xbank_mem_0_reg[13][3] QDFFN $PINS Q=bank_mem_0[13][3]
+ D=FE_OFN192_bank_wdata_0__3 CK=CTS_595
Xbank_mem_0_reg[13][2] QDFFN $PINS Q=bank_mem_0[13][2]
+ D=FE_PHN2035_bank_wdata_0_2 CK=CTS_595
Xbank_mem_0_reg[13][1] QDFFN $PINS Q=bank_mem_0[13][1] D=bank_wdata[0][1]
+ CK=CTS_595
Xbank_mem_0_reg[13][0] QDFFN $PINS Q=bank_mem_0[13][0]
+ D=FE_PHN1846_FE_OFN11_bank_wdata_0__0 CK=CTS_595
Xbank_mem_1_reg[14][33] QDFFN $PINS Q=bank_mem_1[14][33]
+ D=FE_PHN1896_FE_OFN193_bank_wdata_1__33 CK=CTS_691
Xbank_mem_1_reg[12][33] QDFFN $PINS Q=bank_mem_1[12][33]
+ D=FE_PHN1896_FE_OFN193_bank_wdata_1__33 CK=CTS_703
Xbank_mem_0_reg[14][32] QDFFN $PINS Q=bank_mem_0[14][32]
+ D=FE_PHN1919_FE_OFN174_bank_wdata_0__32 CK=CTS_737
Xbank_mem_0_reg[14][31] QDFFN $PINS Q=bank_mem_0[14][31]
+ D=FE_OFN175_bank_wdata_0__31 CK=CTS_737
Xbank_mem_0_reg[14][30] QDFFN $PINS Q=bank_mem_0[14][30]
+ D=FE_PHN1900_FE_OFN176_bank_wdata_0__30 CK=CTS_737
Xbank_mem_0_reg[14][29] QDFFN $PINS Q=bank_mem_0[14][29]
+ D=FE_OFN177_bank_wdata_0__29 CK=CTS_737
Xbank_mem_0_reg[14][28] QDFFN $PINS Q=bank_mem_0[14][28]
+ D=FE_OFN178_bank_wdata_0__28 CK=CTS_737
Xbank_mem_0_reg[14][27] QDFFN $PINS Q=bank_mem_0[14][27]
+ D=FE_OFN179_bank_wdata_0__27 CK=CTS_737
Xbank_mem_0_reg[14][26] QDFFN $PINS Q=bank_mem_0[14][26]
+ D=FE_OFN180_bank_wdata_0__26 CK=CTS_737
Xbank_mem_0_reg[14][25] QDFFN $PINS Q=bank_mem_0[14][25]
+ D=FE_OFN181_bank_wdata_0__25 CK=CTS_737
Xbank_mem_0_reg[14][24] QDFFN $PINS Q=bank_mem_0[14][24]
+ D=FE_OFN182_bank_wdata_0__24 CK=CTS_737
Xbank_mem_0_reg[14][23] QDFFN $PINS Q=bank_mem_0[14][23]
+ D=FE_OFN183_bank_wdata_0__23 CK=CTS_737
Xbank_mem_0_reg[14][22] QDFFN $PINS Q=bank_mem_0[14][22]
+ D=FE_OFN184_bank_wdata_0__22 CK=CTS_737
Xbank_mem_0_reg[14][21] QDFFN $PINS Q=bank_mem_0[14][21]
+ D=FE_OFN185_bank_wdata_0__21 CK=CTS_737
Xbank_mem_0_reg[14][20] QDFFN $PINS Q=bank_mem_0[14][20]
+ D=FE_OFN186_bank_wdata_0__20 CK=CTS_737
Xbank_mem_0_reg[14][19] QDFFN $PINS Q=bank_mem_0[14][19]
+ D=FE_OFN187_bank_wdata_0__19 CK=CTS_737
Xbank_mem_0_reg[14][18] QDFFN $PINS Q=bank_mem_0[14][18]
+ D=FE_PHN2042_FE_OFN188_bank_wdata_0__18 CK=CTS_737
Xbank_mem_0_reg[14][17] QDFFN $PINS Q=bank_mem_0[14][17]
+ D=FE_OFN189_bank_wdata_0__17 CK=CTS_737
Xbank_mem_0_reg[14][16] QDFFN $PINS Q=bank_mem_0[14][16] D=bank_wdata[0][16]
+ CK=CTS_592
Xbank_mem_0_reg[14][15] QDFFN $PINS Q=bank_mem_0[14][15] D=bank_wdata[0][15]
+ CK=CTS_592
Xbank_mem_0_reg[14][14] QDFFN $PINS Q=bank_mem_0[14][14] D=bank_wdata[0][14]
+ CK=CTS_592
Xbank_mem_0_reg[14][13] QDFFN $PINS Q=bank_mem_0[14][13] D=bank_wdata[0][13]
+ CK=CTS_592
Xbank_mem_0_reg[14][12] QDFFN $PINS Q=bank_mem_0[14][12]
+ D=FE_PHN2034_bank_wdata_0_12 CK=CTS_592
Xbank_mem_0_reg[14][11] QDFFN $PINS Q=bank_mem_0[14][11]
+ D=FE_PHN2041_bank_wdata_0_11 CK=CTS_592
Xbank_mem_0_reg[14][10] QDFFN $PINS Q=bank_mem_0[14][10]
+ D=FE_PHN2036_bank_wdata_0_10 CK=CTS_592
Xbank_mem_0_reg[14][9] QDFFN $PINS Q=bank_mem_0[14][9]
+ D=FE_PHN2038_bank_wdata_0_9 CK=CTS_592
Xbank_mem_0_reg[14][8] QDFFN $PINS Q=bank_mem_0[14][8]
+ D=FE_OFN480_bank_wdata_0__8 CK=CTS_592
Xbank_mem_0_reg[14][7] QDFFN $PINS Q=bank_mem_0[14][7]
+ D=FE_PHN2021_bank_wdata_0_7 CK=CTS_592
Xbank_mem_0_reg[14][6] QDFFN $PINS Q=bank_mem_0[14][6]
+ D=FE_OFN190_bank_wdata_0__6 CK=CTS_592
Xbank_mem_0_reg[14][5] QDFFN $PINS Q=bank_mem_0[14][5]
+ D=FE_OFN191_bank_wdata_0__5 CK=CTS_592
Xbank_mem_0_reg[14][4] QDFFN $PINS Q=bank_mem_0[14][4]
+ D=FE_PHN2138_bank_wdata_0_4 CK=CTS_592
Xbank_mem_0_reg[14][3] QDFFN $PINS Q=bank_mem_0[14][3]
+ D=FE_OFN192_bank_wdata_0__3 CK=CTS_592
Xbank_mem_0_reg[14][2] QDFFN $PINS Q=bank_mem_0[14][2]
+ D=FE_PHN2035_bank_wdata_0_2 CK=CTS_592
Xbank_mem_0_reg[14][1] QDFFN $PINS Q=bank_mem_0[14][1] D=bank_wdata[0][1]
+ CK=CTS_592
Xbank_mem_0_reg[14][0] QDFFN $PINS Q=bank_mem_0[14][0]
+ D=FE_PHN1846_FE_OFN11_bank_wdata_0__0 CK=CTS_592
Xbank_mem_0_reg[15][33] QDFFN $PINS Q=bank_mem_0[15][33] D=n900 CK=CTS_734
Xbank_mem_0_reg[12][32] QDFFN $PINS Q=bank_mem_0[12][32]
+ D=FE_PHN1919_FE_OFN174_bank_wdata_0__32 CK=CTS_743
Xbank_mem_0_reg[12][31] QDFFN $PINS Q=bank_mem_0[12][31]
+ D=FE_OFN175_bank_wdata_0__31 CK=CTS_743
Xbank_mem_0_reg[12][30] QDFFN $PINS Q=bank_mem_0[12][30]
+ D=FE_PHN1900_FE_OFN176_bank_wdata_0__30 CK=CTS_743
Xbank_mem_0_reg[12][29] QDFFN $PINS Q=bank_mem_0[12][29]
+ D=FE_OFN177_bank_wdata_0__29 CK=CTS_743
Xbank_mem_0_reg[12][28] QDFFN $PINS Q=bank_mem_0[12][28]
+ D=FE_OFN178_bank_wdata_0__28 CK=CTS_743
Xbank_mem_0_reg[12][27] QDFFN $PINS Q=bank_mem_0[12][27]
+ D=FE_OFN179_bank_wdata_0__27 CK=CTS_743
Xbank_mem_0_reg[12][26] QDFFN $PINS Q=bank_mem_0[12][26]
+ D=FE_OFN180_bank_wdata_0__26 CK=CTS_743
Xbank_mem_0_reg[12][25] QDFFN $PINS Q=bank_mem_0[12][25]
+ D=FE_OFN181_bank_wdata_0__25 CK=CTS_743
Xbank_mem_0_reg[12][24] QDFFN $PINS Q=bank_mem_0[12][24]
+ D=FE_OFN182_bank_wdata_0__24 CK=CTS_743
Xbank_mem_0_reg[12][23] QDFFN $PINS Q=bank_mem_0[12][23]
+ D=FE_OFN183_bank_wdata_0__23 CK=CTS_743
Xbank_mem_0_reg[12][22] QDFFN $PINS Q=bank_mem_0[12][22]
+ D=FE_OFN184_bank_wdata_0__22 CK=CTS_743
Xbank_mem_0_reg[12][21] QDFFN $PINS Q=bank_mem_0[12][21]
+ D=FE_OFN185_bank_wdata_0__21 CK=CTS_743
Xbank_mem_0_reg[12][20] QDFFN $PINS Q=bank_mem_0[12][20]
+ D=FE_OFN186_bank_wdata_0__20 CK=CTS_743
Xbank_mem_0_reg[12][19] QDFFN $PINS Q=bank_mem_0[12][19]
+ D=FE_OFN187_bank_wdata_0__19 CK=CTS_743
Xbank_mem_0_reg[12][18] QDFFN $PINS Q=bank_mem_0[12][18]
+ D=FE_PHN2042_FE_OFN188_bank_wdata_0__18 CK=CTS_743
Xbank_mem_0_reg[12][17] QDFFN $PINS Q=bank_mem_0[12][17]
+ D=FE_OFN189_bank_wdata_0__17 CK=CTS_743
Xbank_mem_0_reg[12][16] QDFFN $PINS Q=bank_mem_0[12][16] D=bank_wdata[0][16]
+ CK=CTS_598
Xbank_mem_0_reg[12][15] QDFFN $PINS Q=bank_mem_0[12][15] D=bank_wdata[0][15]
+ CK=CTS_598
Xbank_mem_0_reg[12][14] QDFFN $PINS Q=bank_mem_0[12][14] D=bank_wdata[0][14]
+ CK=CTS_598
Xbank_mem_0_reg[12][13] QDFFN $PINS Q=bank_mem_0[12][13] D=bank_wdata[0][13]
+ CK=CTS_598
Xbank_mem_0_reg[12][12] QDFFN $PINS Q=bank_mem_0[12][12]
+ D=FE_PHN2034_bank_wdata_0_12 CK=CTS_598
Xbank_mem_0_reg[12][11] QDFFN $PINS Q=bank_mem_0[12][11]
+ D=FE_PHN2041_bank_wdata_0_11 CK=CTS_598
Xbank_mem_0_reg[12][10] QDFFN $PINS Q=bank_mem_0[12][10]
+ D=FE_PHN2036_bank_wdata_0_10 CK=CTS_598
Xbank_mem_0_reg[12][9] QDFFN $PINS Q=bank_mem_0[12][9]
+ D=FE_PHN2038_bank_wdata_0_9 CK=CTS_598
Xbank_mem_0_reg[12][8] QDFFN $PINS Q=bank_mem_0[12][8]
+ D=FE_OFN480_bank_wdata_0__8 CK=CTS_598
Xbank_mem_0_reg[12][7] QDFFN $PINS Q=bank_mem_0[12][7]
+ D=FE_PHN2021_bank_wdata_0_7 CK=CTS_598
Xbank_mem_0_reg[12][6] QDFFN $PINS Q=bank_mem_0[12][6]
+ D=FE_OFN190_bank_wdata_0__6 CK=CTS_598
Xbank_mem_0_reg[12][5] QDFFN $PINS Q=bank_mem_0[12][5]
+ D=FE_OFN191_bank_wdata_0__5 CK=CTS_598
Xbank_mem_0_reg[12][4] QDFFN $PINS Q=bank_mem_0[12][4]
+ D=FE_PHN2138_bank_wdata_0_4 CK=CTS_598
Xbank_mem_0_reg[12][3] QDFFN $PINS Q=bank_mem_0[12][3]
+ D=FE_OFN192_bank_wdata_0__3 CK=CTS_598
Xbank_mem_0_reg[12][2] QDFFN $PINS Q=bank_mem_0[12][2]
+ D=FE_PHN2035_bank_wdata_0_2 CK=CTS_598
Xbank_mem_0_reg[12][1] QDFFN $PINS Q=bank_mem_0[12][1] D=bank_wdata[0][1]
+ CK=CTS_598
Xbank_mem_0_reg[12][0] QDFFN $PINS Q=bank_mem_0[12][0]
+ D=FE_PHN1846_FE_OFN11_bank_wdata_0__0 CK=CTS_598
Xbank_mem_0_reg[13][33] QDFFN $PINS Q=bank_mem_0[13][33] D=n900 CK=CTS_740
Xbank_mem_0_reg[14][33] QDFFN $PINS Q=bank_mem_0[14][33] D=n900 CK=CTS_737
Xbank_mem_0_reg[12][33] QDFFN $PINS Q=bank_mem_0[12][33] D=n900 CK=CTS_743
Xbank_mem_1_reg[9][32] QDFFN $PINS Q=bank_mem_1[9][32]
+ D=FE_PHN2173_FE_OFN194_bank_wdata_1__32 CK=CTS_721
Xbank_mem_1_reg[9][31] QDFFN $PINS Q=bank_mem_1[9][31]
+ D=FE_PHN1942_FE_OFN195_bank_wdata_1__31 CK=CTS_721
Xbank_mem_1_reg[9][30] QDFFN $PINS Q=bank_mem_1[9][30]
+ D=FE_OFN196_bank_wdata_1__30 CK=CTS_721
Xbank_mem_1_reg[9][29] QDFFN $PINS Q=bank_mem_1[9][29]
+ D=FE_PHN1811_FE_OFN197_bank_wdata_1__29 CK=CTS_721
Xbank_mem_1_reg[9][28] QDFFN $PINS Q=bank_mem_1[9][28]
+ D=FE_PHN1819_FE_OFN198_bank_wdata_1__28 CK=CTS_721
Xbank_mem_1_reg[9][27] QDFFN $PINS Q=bank_mem_1[9][27]
+ D=FE_PHN1810_FE_OFN199_bank_wdata_1__27 CK=CTS_721
Xbank_mem_1_reg[9][26] QDFFN $PINS Q=bank_mem_1[9][26]
+ D=FE_OFN9_bank_wdata_1__26 CK=CTS_721
Xbank_mem_1_reg[9][25] QDFFN $PINS Q=bank_mem_1[9][25]
+ D=FE_OFN200_bank_wdata_1__25 CK=CTS_721
Xbank_mem_1_reg[9][24] QDFFN $PINS Q=bank_mem_1[9][24]
+ D=FE_PHN1817_FE_OFN201_bank_wdata_1__24 CK=CTS_721
Xbank_mem_1_reg[9][23] QDFFN $PINS Q=bank_mem_1[9][23]
+ D=FE_OFN481_bank_wdata_1__23 CK=CTS_721
Xbank_mem_1_reg[9][22] QDFFN $PINS Q=bank_mem_1[9][22]
+ D=FE_OFN202_bank_wdata_1__22 CK=CTS_721
Xbank_mem_1_reg[9][21] QDFFN $PINS Q=bank_mem_1[9][21]
+ D=FE_OFN203_bank_wdata_1__21 CK=CTS_721
Xbank_mem_1_reg[9][20] QDFFN $PINS Q=bank_mem_1[9][20]
+ D=FE_OFN204_bank_wdata_1__20 CK=CTS_721
Xbank_mem_1_reg[9][19] QDFFN $PINS Q=bank_mem_1[9][19]
+ D=FE_OFN205_bank_wdata_1__19 CK=CTS_721
Xbank_mem_1_reg[9][18] QDFFN $PINS Q=bank_mem_1[9][18]
+ D=FE_PHN1814_FE_OFN206_bank_wdata_1__18 CK=CTS_721
Xbank_mem_1_reg[9][17] QDFFN $PINS Q=bank_mem_1[9][17]
+ D=FE_OFN207_bank_wdata_1__17 CK=CTS_721
Xbank_mem_1_reg[9][16] QDFFN $PINS Q=bank_mem_1[9][16]
+ D=FE_OFN208_bank_wdata_1__16 CK=CTS_718
Xbank_mem_1_reg[9][15] QDFFN $PINS Q=bank_mem_1[9][15]
+ D=FE_OFN14_bank_wdata_1__15 CK=CTS_718
Xbank_mem_1_reg[9][14] QDFFN $PINS Q=bank_mem_1[9][14]
+ D=FE_OFN209_bank_wdata_1__14 CK=CTS_718
Xbank_mem_1_reg[9][13] QDFFN $PINS Q=bank_mem_1[9][13]
+ D=FE_OFN13_bank_wdata_1__13 CK=CTS_718
Xbank_mem_1_reg[9][12] QDFFN $PINS Q=bank_mem_1[9][12]
+ D=FE_PHN1868_FE_OFN10_bank_wdata_1__12 CK=CTS_718
Xbank_mem_1_reg[9][11] QDFFN $PINS Q=bank_mem_1[9][11]
+ D=FE_PHN1813_FE_OFN210_bank_wdata_1__11 CK=CTS_718
Xbank_mem_1_reg[9][10] QDFFN $PINS Q=bank_mem_1[9][10]
+ D=FE_PHN1816_FE_OFN211_bank_wdata_1__10 CK=CTS_718
Xbank_mem_1_reg[9][9] QDFFN $PINS Q=bank_mem_1[9][9]
+ D=FE_PHN1818_FE_OFN212_bank_wdata_1__9 CK=CTS_718
Xbank_mem_1_reg[9][8] QDFFN $PINS Q=bank_mem_1[9][8]
+ D=FE_PHN1823_FE_OFN213_bank_wdata_1__8 CK=CTS_718
Xbank_mem_1_reg[9][7] QDFFN $PINS Q=bank_mem_1[9][7]
+ D=FE_PHN1825_FE_OFN214_bank_wdata_1__7 CK=CTS_718
Xbank_mem_1_reg[9][6] QDFFN $PINS Q=bank_mem_1[9][6]
+ D=FE_OFN215_bank_wdata_1__6 CK=CTS_718
Xbank_mem_1_reg[9][5] QDFFN $PINS Q=bank_mem_1[9][5]
+ D=FE_OFN216_bank_wdata_1__5 CK=CTS_718
Xbank_mem_1_reg[9][4] QDFFN $PINS Q=bank_mem_1[9][4]
+ D=FE_OFN217_bank_wdata_1__4 CK=CTS_718
Xbank_mem_1_reg[9][3] QDFFN $PINS Q=bank_mem_1[9][3]
+ D=FE_PHN1995_FE_OFN218_bank_wdata_1__3 CK=CTS_718
Xbank_mem_1_reg[9][2] QDFFN $PINS Q=bank_mem_1[9][2]
+ D=FE_PHN1815_FE_OFN219_bank_wdata_1__2 CK=CTS_718
Xbank_mem_1_reg[9][1] QDFFN $PINS Q=bank_mem_1[9][1]
+ D=FE_OFN220_bank_wdata_1__1 CK=CTS_718
Xbank_mem_1_reg[9][0] QDFFN $PINS Q=bank_mem_1[9][0]
+ D=FE_PHN1930_FE_OFN221_bank_wdata_1__0 CK=CTS_718
Xbank_mem_1_reg[11][32] QDFFN $PINS Q=bank_mem_1[11][32]
+ D=FE_PHN2173_FE_OFN194_bank_wdata_1__32 CK=CTS_709
Xbank_mem_1_reg[11][31] QDFFN $PINS Q=bank_mem_1[11][31]
+ D=FE_PHN1942_FE_OFN195_bank_wdata_1__31 CK=CTS_709
Xbank_mem_1_reg[11][30] QDFFN $PINS Q=bank_mem_1[11][30]
+ D=FE_OFN196_bank_wdata_1__30 CK=CTS_709
Xbank_mem_1_reg[11][29] QDFFN $PINS Q=bank_mem_1[11][29]
+ D=FE_PHN1811_FE_OFN197_bank_wdata_1__29 CK=CTS_709
Xbank_mem_1_reg[11][28] QDFFN $PINS Q=bank_mem_1[11][28]
+ D=FE_PHN1819_FE_OFN198_bank_wdata_1__28 CK=CTS_709
Xbank_mem_1_reg[11][27] QDFFN $PINS Q=bank_mem_1[11][27]
+ D=FE_PHN1810_FE_OFN199_bank_wdata_1__27 CK=CTS_709
Xbank_mem_1_reg[11][26] QDFFN $PINS Q=bank_mem_1[11][26]
+ D=FE_OFN9_bank_wdata_1__26 CK=CTS_709
Xbank_mem_1_reg[11][25] QDFFN $PINS Q=bank_mem_1[11][25]
+ D=FE_OFN200_bank_wdata_1__25 CK=CTS_709
Xbank_mem_1_reg[11][24] QDFFN $PINS Q=bank_mem_1[11][24]
+ D=FE_PHN1817_FE_OFN201_bank_wdata_1__24 CK=CTS_709
Xbank_mem_1_reg[11][23] QDFFN $PINS Q=bank_mem_1[11][23]
+ D=FE_OFN481_bank_wdata_1__23 CK=CTS_709
Xbank_mem_1_reg[11][22] QDFFN $PINS Q=bank_mem_1[11][22]
+ D=FE_OFN202_bank_wdata_1__22 CK=CTS_709
Xbank_mem_1_reg[11][21] QDFFN $PINS Q=bank_mem_1[11][21]
+ D=FE_OFN203_bank_wdata_1__21 CK=CTS_709
Xbank_mem_1_reg[11][20] QDFFN $PINS Q=bank_mem_1[11][20]
+ D=FE_OFN204_bank_wdata_1__20 CK=CTS_709
Xbank_mem_1_reg[11][19] QDFFN $PINS Q=bank_mem_1[11][19]
+ D=FE_OFN205_bank_wdata_1__19 CK=CTS_709
Xbank_mem_1_reg[11][18] QDFFN $PINS Q=bank_mem_1[11][18]
+ D=FE_PHN1814_FE_OFN206_bank_wdata_1__18 CK=CTS_709
Xbank_mem_1_reg[11][17] QDFFN $PINS Q=bank_mem_1[11][17]
+ D=FE_OFN207_bank_wdata_1__17 CK=CTS_709
Xbank_mem_1_reg[11][16] QDFFN $PINS Q=bank_mem_1[11][16]
+ D=FE_OFN208_bank_wdata_1__16 CK=CTS_706
Xbank_mem_1_reg[11][15] QDFFN $PINS Q=bank_mem_1[11][15]
+ D=FE_OFN14_bank_wdata_1__15 CK=CTS_706
Xbank_mem_1_reg[11][14] QDFFN $PINS Q=bank_mem_1[11][14]
+ D=FE_OFN209_bank_wdata_1__14 CK=CTS_706
Xbank_mem_1_reg[11][13] QDFFN $PINS Q=bank_mem_1[11][13]
+ D=FE_OFN13_bank_wdata_1__13 CK=CTS_706
Xbank_mem_1_reg[11][12] QDFFN $PINS Q=bank_mem_1[11][12]
+ D=FE_PHN1868_FE_OFN10_bank_wdata_1__12 CK=CTS_706
Xbank_mem_1_reg[11][11] QDFFN $PINS Q=bank_mem_1[11][11]
+ D=FE_PHN1813_FE_OFN210_bank_wdata_1__11 CK=CTS_706
Xbank_mem_1_reg[11][10] QDFFN $PINS Q=bank_mem_1[11][10]
+ D=FE_PHN1816_FE_OFN211_bank_wdata_1__10 CK=CTS_706
Xbank_mem_1_reg[11][9] QDFFN $PINS Q=bank_mem_1[11][9]
+ D=FE_PHN1818_FE_OFN212_bank_wdata_1__9 CK=CTS_706
Xbank_mem_1_reg[11][8] QDFFN $PINS Q=bank_mem_1[11][8]
+ D=FE_PHN1823_FE_OFN213_bank_wdata_1__8 CK=CTS_706
Xbank_mem_1_reg[11][7] QDFFN $PINS Q=bank_mem_1[11][7]
+ D=FE_PHN1825_FE_OFN214_bank_wdata_1__7 CK=CTS_706
Xbank_mem_1_reg[11][6] QDFFN $PINS Q=bank_mem_1[11][6]
+ D=FE_OFN215_bank_wdata_1__6 CK=CTS_706
Xbank_mem_1_reg[11][5] QDFFN $PINS Q=bank_mem_1[11][5]
+ D=FE_OFN216_bank_wdata_1__5 CK=CTS_706
Xbank_mem_1_reg[11][4] QDFFN $PINS Q=bank_mem_1[11][4]
+ D=FE_OFN217_bank_wdata_1__4 CK=CTS_706
Xbank_mem_1_reg[11][3] QDFFN $PINS Q=bank_mem_1[11][3]
+ D=FE_PHN1995_FE_OFN218_bank_wdata_1__3 CK=CTS_706
Xbank_mem_1_reg[11][2] QDFFN $PINS Q=bank_mem_1[11][2]
+ D=FE_PHN1815_FE_OFN219_bank_wdata_1__2 CK=CTS_706
Xbank_mem_1_reg[11][1] QDFFN $PINS Q=bank_mem_1[11][1]
+ D=FE_OFN220_bank_wdata_1__1 CK=CTS_706
Xbank_mem_1_reg[11][0] QDFFN $PINS Q=bank_mem_1[11][0]
+ D=FE_PHN1930_FE_OFN221_bank_wdata_1__0 CK=CTS_706
Xbank_mem_1_reg[8][32] QDFFN $PINS Q=bank_mem_1[8][32]
+ D=FE_PHN2173_FE_OFN194_bank_wdata_1__32 CK=CTS_727
Xbank_mem_1_reg[8][31] QDFFN $PINS Q=bank_mem_1[8][31]
+ D=FE_PHN1942_FE_OFN195_bank_wdata_1__31 CK=CTS_727
Xbank_mem_1_reg[8][30] QDFFN $PINS Q=bank_mem_1[8][30]
+ D=FE_OFN196_bank_wdata_1__30 CK=CTS_727
Xbank_mem_1_reg[8][29] QDFFN $PINS Q=bank_mem_1[8][29]
+ D=FE_PHN1811_FE_OFN197_bank_wdata_1__29 CK=CTS_727
Xbank_mem_1_reg[8][28] QDFFN $PINS Q=bank_mem_1[8][28]
+ D=FE_PHN1819_FE_OFN198_bank_wdata_1__28 CK=CTS_727
Xbank_mem_1_reg[8][27] QDFFN $PINS Q=bank_mem_1[8][27]
+ D=FE_PHN1810_FE_OFN199_bank_wdata_1__27 CK=CTS_727
Xbank_mem_1_reg[8][26] QDFFN $PINS Q=bank_mem_1[8][26]
+ D=FE_OFN9_bank_wdata_1__26 CK=CTS_727
Xbank_mem_1_reg[8][25] QDFFN $PINS Q=bank_mem_1[8][25]
+ D=FE_OFN200_bank_wdata_1__25 CK=CTS_727
Xbank_mem_1_reg[8][24] QDFFN $PINS Q=bank_mem_1[8][24]
+ D=FE_PHN1817_FE_OFN201_bank_wdata_1__24 CK=CTS_727
Xbank_mem_1_reg[8][23] QDFFN $PINS Q=bank_mem_1[8][23]
+ D=FE_OFN481_bank_wdata_1__23 CK=CTS_727
Xbank_mem_1_reg[8][22] QDFFN $PINS Q=bank_mem_1[8][22]
+ D=FE_OFN202_bank_wdata_1__22 CK=CTS_727
Xbank_mem_1_reg[8][21] QDFFN $PINS Q=bank_mem_1[8][21]
+ D=FE_OFN203_bank_wdata_1__21 CK=CTS_727
Xbank_mem_1_reg[8][20] QDFFN $PINS Q=bank_mem_1[8][20]
+ D=FE_OFN204_bank_wdata_1__20 CK=CTS_727
Xbank_mem_1_reg[8][19] QDFFN $PINS Q=bank_mem_1[8][19]
+ D=FE_OFN205_bank_wdata_1__19 CK=CTS_727
Xbank_mem_1_reg[8][18] QDFFN $PINS Q=bank_mem_1[8][18]
+ D=FE_PHN1814_FE_OFN206_bank_wdata_1__18 CK=CTS_727
Xbank_mem_1_reg[8][17] QDFFN $PINS Q=bank_mem_1[8][17]
+ D=FE_OFN207_bank_wdata_1__17 CK=CTS_727
Xbank_mem_1_reg[8][16] QDFFN $PINS Q=bank_mem_1[8][16]
+ D=FE_OFN208_bank_wdata_1__16 CK=CTS_724
Xbank_mem_1_reg[8][15] QDFFN $PINS Q=bank_mem_1[8][15]
+ D=FE_OFN14_bank_wdata_1__15 CK=CTS_724
Xbank_mem_1_reg[8][14] QDFFN $PINS Q=bank_mem_1[8][14]
+ D=FE_OFN209_bank_wdata_1__14 CK=CTS_724
Xbank_mem_1_reg[8][13] QDFFN $PINS Q=bank_mem_1[8][13]
+ D=FE_OFN13_bank_wdata_1__13 CK=CTS_724
Xbank_mem_1_reg[8][12] QDFFN $PINS Q=bank_mem_1[8][12]
+ D=FE_PHN1868_FE_OFN10_bank_wdata_1__12 CK=CTS_724
Xbank_mem_1_reg[8][11] QDFFN $PINS Q=bank_mem_1[8][11]
+ D=FE_PHN1813_FE_OFN210_bank_wdata_1__11 CK=CTS_724
Xbank_mem_1_reg[8][10] QDFFN $PINS Q=bank_mem_1[8][10]
+ D=FE_PHN1816_FE_OFN211_bank_wdata_1__10 CK=CTS_724
Xbank_mem_1_reg[8][9] QDFFN $PINS Q=bank_mem_1[8][9]
+ D=FE_PHN1818_FE_OFN212_bank_wdata_1__9 CK=CTS_724
Xbank_mem_1_reg[8][8] QDFFN $PINS Q=bank_mem_1[8][8]
+ D=FE_PHN1823_FE_OFN213_bank_wdata_1__8 CK=CTS_724
Xbank_mem_1_reg[8][7] QDFFN $PINS Q=bank_mem_1[8][7]
+ D=FE_PHN1825_FE_OFN214_bank_wdata_1__7 CK=CTS_724
Xbank_mem_1_reg[8][6] QDFFN $PINS Q=bank_mem_1[8][6]
+ D=FE_OFN215_bank_wdata_1__6 CK=CTS_724
Xbank_mem_1_reg[8][5] QDFFN $PINS Q=bank_mem_1[8][5]
+ D=FE_OFN216_bank_wdata_1__5 CK=CTS_724
Xbank_mem_1_reg[8][4] QDFFN $PINS Q=bank_mem_1[8][4]
+ D=FE_OFN217_bank_wdata_1__4 CK=CTS_724
Xbank_mem_1_reg[8][3] QDFFN $PINS Q=bank_mem_1[8][3]
+ D=FE_PHN1995_FE_OFN218_bank_wdata_1__3 CK=CTS_724
Xbank_mem_1_reg[8][2] QDFFN $PINS Q=bank_mem_1[8][2]
+ D=FE_PHN1815_FE_OFN219_bank_wdata_1__2 CK=CTS_724
Xbank_mem_1_reg[8][1] QDFFN $PINS Q=bank_mem_1[8][1]
+ D=FE_OFN220_bank_wdata_1__1 CK=CTS_724
Xbank_mem_1_reg[8][0] QDFFN $PINS Q=bank_mem_1[8][0]
+ D=FE_PHN1930_FE_OFN221_bank_wdata_1__0 CK=CTS_724
Xbank_mem_1_reg[9][33] QDFFN $PINS Q=bank_mem_1[9][33]
+ D=FE_PHN1896_FE_OFN193_bank_wdata_1__33 CK=CTS_721
Xbank_mem_1_reg[10][32] QDFFN $PINS Q=bank_mem_1[10][32]
+ D=FE_PHN1880_FE_OFN194_bank_wdata_1__32 CK=CTS_715
Xbank_mem_1_reg[10][31] QDFFN $PINS Q=bank_mem_1[10][31]
+ D=FE_PHN1942_FE_OFN195_bank_wdata_1__31 CK=CTS_715
Xbank_mem_1_reg[10][30] QDFFN $PINS Q=bank_mem_1[10][30]
+ D=FE_OFN196_bank_wdata_1__30 CK=CTS_715
Xbank_mem_1_reg[10][29] QDFFN $PINS Q=bank_mem_1[10][29]
+ D=FE_PHN1811_FE_OFN197_bank_wdata_1__29 CK=CTS_715
Xbank_mem_1_reg[10][28] QDFFN $PINS Q=bank_mem_1[10][28]
+ D=FE_PHN1819_FE_OFN198_bank_wdata_1__28 CK=CTS_715
Xbank_mem_1_reg[10][27] QDFFN $PINS Q=bank_mem_1[10][27]
+ D=FE_PHN1810_FE_OFN199_bank_wdata_1__27 CK=CTS_715
Xbank_mem_1_reg[10][26] QDFFN $PINS Q=bank_mem_1[10][26]
+ D=FE_OFN9_bank_wdata_1__26 CK=CTS_715
Xbank_mem_1_reg[10][25] QDFFN $PINS Q=bank_mem_1[10][25]
+ D=FE_OFN200_bank_wdata_1__25 CK=CTS_715
Xbank_mem_1_reg[10][24] QDFFN $PINS Q=bank_mem_1[10][24]
+ D=FE_PHN1817_FE_OFN201_bank_wdata_1__24 CK=CTS_715
Xbank_mem_1_reg[10][23] QDFFN $PINS Q=bank_mem_1[10][23]
+ D=FE_OFN481_bank_wdata_1__23 CK=CTS_715
Xbank_mem_1_reg[10][22] QDFFN $PINS Q=bank_mem_1[10][22]
+ D=FE_OFN202_bank_wdata_1__22 CK=CTS_715
Xbank_mem_1_reg[10][21] QDFFN $PINS Q=bank_mem_1[10][21]
+ D=FE_OFN203_bank_wdata_1__21 CK=CTS_715
Xbank_mem_1_reg[10][20] QDFFN $PINS Q=bank_mem_1[10][20]
+ D=FE_OFN204_bank_wdata_1__20 CK=CTS_715
Xbank_mem_1_reg[10][19] QDFFN $PINS Q=bank_mem_1[10][19]
+ D=FE_OFN205_bank_wdata_1__19 CK=CTS_715
Xbank_mem_1_reg[10][18] QDFFN $PINS Q=bank_mem_1[10][18]
+ D=FE_PHN1814_FE_OFN206_bank_wdata_1__18 CK=CTS_715
Xbank_mem_1_reg[10][17] QDFFN $PINS Q=bank_mem_1[10][17]
+ D=FE_OFN207_bank_wdata_1__17 CK=CTS_715
Xbank_mem_1_reg[10][16] QDFFN $PINS Q=bank_mem_1[10][16]
+ D=FE_OFN208_bank_wdata_1__16 CK=CTS_712
Xbank_mem_1_reg[10][15] QDFFN $PINS Q=bank_mem_1[10][15]
+ D=FE_OFN14_bank_wdata_1__15 CK=CTS_712
Xbank_mem_1_reg[10][14] QDFFN $PINS Q=bank_mem_1[10][14]
+ D=FE_OFN209_bank_wdata_1__14 CK=CTS_712
Xbank_mem_1_reg[10][13] QDFFN $PINS Q=bank_mem_1[10][13]
+ D=FE_OFN13_bank_wdata_1__13 CK=CTS_712
Xbank_mem_1_reg[10][12] QDFFN $PINS Q=bank_mem_1[10][12]
+ D=FE_PHN1868_FE_OFN10_bank_wdata_1__12 CK=CTS_712
Xbank_mem_1_reg[10][11] QDFFN $PINS Q=bank_mem_1[10][11]
+ D=FE_PHN1813_FE_OFN210_bank_wdata_1__11 CK=CTS_712
Xbank_mem_1_reg[10][10] QDFFN $PINS Q=bank_mem_1[10][10]
+ D=FE_PHN1816_FE_OFN211_bank_wdata_1__10 CK=CTS_712
Xbank_mem_1_reg[10][9] QDFFN $PINS Q=bank_mem_1[10][9]
+ D=FE_PHN1818_FE_OFN212_bank_wdata_1__9 CK=CTS_712
Xbank_mem_1_reg[10][8] QDFFN $PINS Q=bank_mem_1[10][8]
+ D=FE_PHN1823_FE_OFN213_bank_wdata_1__8 CK=CTS_712
Xbank_mem_1_reg[10][7] QDFFN $PINS Q=bank_mem_1[10][7]
+ D=FE_PHN1825_FE_OFN214_bank_wdata_1__7 CK=CTS_712
Xbank_mem_1_reg[10][6] QDFFN $PINS Q=bank_mem_1[10][6]
+ D=FE_OFN215_bank_wdata_1__6 CK=CTS_712
Xbank_mem_1_reg[10][5] QDFFN $PINS Q=bank_mem_1[10][5]
+ D=FE_OFN216_bank_wdata_1__5 CK=CTS_712
Xbank_mem_1_reg[10][4] QDFFN $PINS Q=bank_mem_1[10][4]
+ D=FE_OFN217_bank_wdata_1__4 CK=CTS_712
Xbank_mem_1_reg[10][3] QDFFN $PINS Q=bank_mem_1[10][3]
+ D=FE_PHN1995_FE_OFN218_bank_wdata_1__3 CK=CTS_712
Xbank_mem_1_reg[10][2] QDFFN $PINS Q=bank_mem_1[10][2]
+ D=FE_PHN1815_FE_OFN219_bank_wdata_1__2 CK=CTS_712
Xbank_mem_1_reg[10][1] QDFFN $PINS Q=bank_mem_1[10][1]
+ D=FE_OFN220_bank_wdata_1__1 CK=CTS_712
Xbank_mem_1_reg[10][0] QDFFN $PINS Q=bank_mem_1[10][0]
+ D=FE_PHN1930_FE_OFN221_bank_wdata_1__0 CK=CTS_712
Xbank_mem_1_reg[11][33] QDFFN $PINS Q=bank_mem_1[11][33]
+ D=FE_PHN1896_FE_OFN193_bank_wdata_1__33 CK=CTS_709
Xbank_mem_0_reg[9][32] QDFFN $PINS Q=bank_mem_0[9][32]
+ D=FE_PHN1919_FE_OFN174_bank_wdata_0__32 CK=CTS_752
Xbank_mem_0_reg[9][31] QDFFN $PINS Q=bank_mem_0[9][31]
+ D=FE_OFN175_bank_wdata_0__31 CK=CTS_752
Xbank_mem_0_reg[9][30] QDFFN $PINS Q=bank_mem_0[9][30]
+ D=FE_PHN1900_FE_OFN176_bank_wdata_0__30 CK=CTS_752
Xbank_mem_0_reg[9][29] QDFFN $PINS Q=bank_mem_0[9][29]
+ D=FE_OFN177_bank_wdata_0__29 CK=CTS_752
Xbank_mem_0_reg[9][28] QDFFN $PINS Q=bank_mem_0[9][28]
+ D=FE_OFN178_bank_wdata_0__28 CK=CTS_752
Xbank_mem_0_reg[9][27] QDFFN $PINS Q=bank_mem_0[9][27]
+ D=FE_OFN179_bank_wdata_0__27 CK=CTS_752
Xbank_mem_0_reg[9][26] QDFFN $PINS Q=bank_mem_0[9][26]
+ D=FE_OFN180_bank_wdata_0__26 CK=CTS_752
Xbank_mem_0_reg[9][25] QDFFN $PINS Q=bank_mem_0[9][25]
+ D=FE_OFN181_bank_wdata_0__25 CK=CTS_752
Xbank_mem_0_reg[9][24] QDFFN $PINS Q=bank_mem_0[9][24]
+ D=FE_OFN182_bank_wdata_0__24 CK=CTS_752
Xbank_mem_0_reg[9][23] QDFFN $PINS Q=bank_mem_0[9][23]
+ D=FE_OFN183_bank_wdata_0__23 CK=CTS_752
Xbank_mem_0_reg[9][22] QDFFN $PINS Q=bank_mem_0[9][22]
+ D=FE_OFN184_bank_wdata_0__22 CK=CTS_752
Xbank_mem_0_reg[9][21] QDFFN $PINS Q=bank_mem_0[9][21]
+ D=FE_OFN185_bank_wdata_0__21 CK=CTS_752
Xbank_mem_0_reg[9][20] QDFFN $PINS Q=bank_mem_0[9][20]
+ D=FE_OFN186_bank_wdata_0__20 CK=CTS_752
Xbank_mem_0_reg[9][19] QDFFN $PINS Q=bank_mem_0[9][19]
+ D=FE_OFN187_bank_wdata_0__19 CK=CTS_752
Xbank_mem_0_reg[9][18] QDFFN $PINS Q=bank_mem_0[9][18]
+ D=FE_PHN2042_FE_OFN188_bank_wdata_0__18 CK=CTS_752
Xbank_mem_0_reg[9][17] QDFFN $PINS Q=bank_mem_0[9][17]
+ D=FE_OFN189_bank_wdata_0__17 CK=CTS_752
Xbank_mem_0_reg[9][16] QDFFN $PINS Q=bank_mem_0[9][16] D=bank_wdata[0][16]
+ CK=CTS_607
Xbank_mem_0_reg[9][15] QDFFN $PINS Q=bank_mem_0[9][15] D=bank_wdata[0][15]
+ CK=CTS_607
Xbank_mem_0_reg[9][14] QDFFN $PINS Q=bank_mem_0[9][14] D=bank_wdata[0][14]
+ CK=CTS_607
Xbank_mem_0_reg[9][13] QDFFN $PINS Q=bank_mem_0[9][13] D=bank_wdata[0][13]
+ CK=CTS_607
Xbank_mem_0_reg[9][12] QDFFN $PINS Q=bank_mem_0[9][12]
+ D=FE_PHN2034_bank_wdata_0_12 CK=CTS_607
Xbank_mem_0_reg[9][11] QDFFN $PINS Q=bank_mem_0[9][11]
+ D=FE_PHN2041_bank_wdata_0_11 CK=CTS_607
Xbank_mem_0_reg[9][10] QDFFN $PINS Q=bank_mem_0[9][10]
+ D=FE_PHN2036_bank_wdata_0_10 CK=CTS_607
Xbank_mem_0_reg[9][9] QDFFN $PINS Q=bank_mem_0[9][9]
+ D=FE_PHN2038_bank_wdata_0_9 CK=CTS_607
Xbank_mem_0_reg[9][8] QDFFN $PINS Q=bank_mem_0[9][8]
+ D=FE_OFN480_bank_wdata_0__8 CK=CTS_607
Xbank_mem_0_reg[9][7] QDFFN $PINS Q=bank_mem_0[9][7]
+ D=FE_PHN2021_bank_wdata_0_7 CK=CTS_607
Xbank_mem_0_reg[9][6] QDFFN $PINS Q=bank_mem_0[9][6]
+ D=FE_OFN190_bank_wdata_0__6 CK=CTS_607
Xbank_mem_0_reg[9][5] QDFFN $PINS Q=bank_mem_0[9][5]
+ D=FE_OFN191_bank_wdata_0__5 CK=CTS_607
Xbank_mem_0_reg[9][4] QDFFN $PINS Q=bank_mem_0[9][4]
+ D=FE_PHN2138_bank_wdata_0_4 CK=CTS_607
Xbank_mem_0_reg[9][3] QDFFN $PINS Q=bank_mem_0[9][3]
+ D=FE_OFN192_bank_wdata_0__3 CK=CTS_607
Xbank_mem_0_reg[9][2] QDFFN $PINS Q=bank_mem_0[9][2]
+ D=FE_PHN2035_bank_wdata_0_2 CK=CTS_607
Xbank_mem_0_reg[9][1] QDFFN $PINS Q=bank_mem_0[9][1] D=bank_wdata[0][1]
+ CK=CTS_607
Xbank_mem_0_reg[9][0] QDFFN $PINS Q=bank_mem_0[9][0]
+ D=FE_PHN1846_FE_OFN11_bank_wdata_0__0 CK=CTS_607
Xbank_mem_0_reg[11][32] QDFFN $PINS Q=bank_mem_0[11][32]
+ D=FE_PHN1919_FE_OFN174_bank_wdata_0__32 CK=CTS_746
Xbank_mem_0_reg[11][31] QDFFN $PINS Q=bank_mem_0[11][31]
+ D=FE_OFN175_bank_wdata_0__31 CK=CTS_746
Xbank_mem_0_reg[11][30] QDFFN $PINS Q=bank_mem_0[11][30]
+ D=FE_PHN1900_FE_OFN176_bank_wdata_0__30 CK=CTS_746
Xbank_mem_0_reg[11][29] QDFFN $PINS Q=bank_mem_0[11][29]
+ D=FE_OFN177_bank_wdata_0__29 CK=CTS_746
Xbank_mem_0_reg[11][28] QDFFN $PINS Q=bank_mem_0[11][28]
+ D=FE_OFN178_bank_wdata_0__28 CK=CTS_746
Xbank_mem_0_reg[11][27] QDFFN $PINS Q=bank_mem_0[11][27]
+ D=FE_OFN179_bank_wdata_0__27 CK=CTS_746
Xbank_mem_0_reg[11][26] QDFFN $PINS Q=bank_mem_0[11][26]
+ D=FE_OFN180_bank_wdata_0__26 CK=CTS_746
Xbank_mem_0_reg[11][25] QDFFN $PINS Q=bank_mem_0[11][25]
+ D=FE_OFN181_bank_wdata_0__25 CK=CTS_746
Xbank_mem_0_reg[11][24] QDFFN $PINS Q=bank_mem_0[11][24]
+ D=FE_OFN182_bank_wdata_0__24 CK=CTS_746
Xbank_mem_0_reg[11][23] QDFFN $PINS Q=bank_mem_0[11][23]
+ D=FE_OFN183_bank_wdata_0__23 CK=CTS_746
Xbank_mem_0_reg[11][22] QDFFN $PINS Q=bank_mem_0[11][22]
+ D=FE_OFN184_bank_wdata_0__22 CK=CTS_746
Xbank_mem_0_reg[11][21] QDFFN $PINS Q=bank_mem_0[11][21]
+ D=FE_OFN185_bank_wdata_0__21 CK=CTS_746
Xbank_mem_0_reg[11][20] QDFFN $PINS Q=bank_mem_0[11][20]
+ D=FE_OFN186_bank_wdata_0__20 CK=CTS_746
Xbank_mem_0_reg[11][19] QDFFN $PINS Q=bank_mem_0[11][19]
+ D=FE_OFN187_bank_wdata_0__19 CK=CTS_746
Xbank_mem_0_reg[11][18] QDFFN $PINS Q=bank_mem_0[11][18]
+ D=FE_PHN2042_FE_OFN188_bank_wdata_0__18 CK=CTS_746
Xbank_mem_0_reg[11][17] QDFFN $PINS Q=bank_mem_0[11][17]
+ D=FE_OFN189_bank_wdata_0__17 CK=CTS_746
Xbank_mem_0_reg[11][16] QDFFN $PINS Q=bank_mem_0[11][16] D=bank_wdata[0][16]
+ CK=CTS_601
Xbank_mem_0_reg[11][15] QDFFN $PINS Q=bank_mem_0[11][15] D=bank_wdata[0][15]
+ CK=CTS_601
Xbank_mem_0_reg[11][14] QDFFN $PINS Q=bank_mem_0[11][14] D=bank_wdata[0][14]
+ CK=CTS_601
Xbank_mem_0_reg[11][13] QDFFN $PINS Q=bank_mem_0[11][13] D=bank_wdata[0][13]
+ CK=CTS_601
Xbank_mem_0_reg[11][12] QDFFN $PINS Q=bank_mem_0[11][12]
+ D=FE_PHN2034_bank_wdata_0_12 CK=CTS_601
Xbank_mem_0_reg[11][11] QDFFN $PINS Q=bank_mem_0[11][11]
+ D=FE_PHN2041_bank_wdata_0_11 CK=CTS_601
Xbank_mem_0_reg[11][10] QDFFN $PINS Q=bank_mem_0[11][10]
+ D=FE_PHN2036_bank_wdata_0_10 CK=CTS_601
Xbank_mem_0_reg[11][9] QDFFN $PINS Q=bank_mem_0[11][9]
+ D=FE_PHN2038_bank_wdata_0_9 CK=CTS_601
Xbank_mem_0_reg[11][8] QDFFN $PINS Q=bank_mem_0[11][8]
+ D=FE_OFN480_bank_wdata_0__8 CK=CTS_601
Xbank_mem_0_reg[11][7] QDFFN $PINS Q=bank_mem_0[11][7]
+ D=FE_PHN2021_bank_wdata_0_7 CK=CTS_601
Xbank_mem_0_reg[11][6] QDFFN $PINS Q=bank_mem_0[11][6]
+ D=FE_OFN190_bank_wdata_0__6 CK=CTS_601
Xbank_mem_0_reg[11][5] QDFFN $PINS Q=bank_mem_0[11][5]
+ D=FE_OFN191_bank_wdata_0__5 CK=CTS_601
Xbank_mem_0_reg[11][4] QDFFN $PINS Q=bank_mem_0[11][4]
+ D=FE_PHN2138_bank_wdata_0_4 CK=CTS_601
Xbank_mem_0_reg[11][3] QDFFN $PINS Q=bank_mem_0[11][3]
+ D=FE_OFN192_bank_wdata_0__3 CK=CTS_601
Xbank_mem_0_reg[11][2] QDFFN $PINS Q=bank_mem_0[11][2]
+ D=FE_PHN2035_bank_wdata_0_2 CK=CTS_601
Xbank_mem_0_reg[11][1] QDFFN $PINS Q=bank_mem_0[11][1] D=bank_wdata[0][1]
+ CK=CTS_601
Xbank_mem_0_reg[11][0] QDFFN $PINS Q=bank_mem_0[11][0]
+ D=FE_PHN1846_FE_OFN11_bank_wdata_0__0 CK=CTS_601
Xbank_mem_1_reg[8][33] QDFFN $PINS Q=bank_mem_1[8][33]
+ D=FE_PHN1896_FE_OFN193_bank_wdata_1__33 CK=CTS_727
Xbank_mem_1_reg[10][33] QDFFN $PINS Q=bank_mem_1[10][33]
+ D=FE_PHN1896_FE_OFN193_bank_wdata_1__33 CK=CTS_715
Xbank_mem_0_reg[8][32] QDFFN $PINS Q=bank_mem_0[8][32]
+ D=FE_PHN1919_FE_OFN174_bank_wdata_0__32 CK=CTS_755
Xbank_mem_0_reg[8][31] QDFFN $PINS Q=bank_mem_0[8][31]
+ D=FE_OFN175_bank_wdata_0__31 CK=CTS_755
Xbank_mem_0_reg[8][30] QDFFN $PINS Q=bank_mem_0[8][30]
+ D=FE_PHN1900_FE_OFN176_bank_wdata_0__30 CK=CTS_755
Xbank_mem_0_reg[8][29] QDFFN $PINS Q=bank_mem_0[8][29]
+ D=FE_OFN177_bank_wdata_0__29 CK=CTS_755
Xbank_mem_0_reg[8][28] QDFFN $PINS Q=bank_mem_0[8][28]
+ D=FE_OFN178_bank_wdata_0__28 CK=CTS_755
Xbank_mem_0_reg[8][27] QDFFN $PINS Q=bank_mem_0[8][27]
+ D=FE_OFN179_bank_wdata_0__27 CK=CTS_755
Xbank_mem_0_reg[8][26] QDFFN $PINS Q=bank_mem_0[8][26]
+ D=FE_OFN180_bank_wdata_0__26 CK=CTS_755
Xbank_mem_0_reg[8][25] QDFFN $PINS Q=bank_mem_0[8][25]
+ D=FE_OFN181_bank_wdata_0__25 CK=CTS_755
Xbank_mem_0_reg[8][24] QDFFN $PINS Q=bank_mem_0[8][24]
+ D=FE_OFN182_bank_wdata_0__24 CK=CTS_755
Xbank_mem_0_reg[8][23] QDFFN $PINS Q=bank_mem_0[8][23]
+ D=FE_OFN183_bank_wdata_0__23 CK=CTS_755
Xbank_mem_0_reg[8][22] QDFFN $PINS Q=bank_mem_0[8][22]
+ D=FE_OFN184_bank_wdata_0__22 CK=CTS_755
Xbank_mem_0_reg[8][21] QDFFN $PINS Q=bank_mem_0[8][21]
+ D=FE_OFN185_bank_wdata_0__21 CK=CTS_755
Xbank_mem_0_reg[8][20] QDFFN $PINS Q=bank_mem_0[8][20]
+ D=FE_OFN186_bank_wdata_0__20 CK=CTS_755
Xbank_mem_0_reg[8][19] QDFFN $PINS Q=bank_mem_0[8][19]
+ D=FE_OFN187_bank_wdata_0__19 CK=CTS_755
Xbank_mem_0_reg[8][18] QDFFN $PINS Q=bank_mem_0[8][18]
+ D=FE_PHN2042_FE_OFN188_bank_wdata_0__18 CK=CTS_755
Xbank_mem_0_reg[8][17] QDFFN $PINS Q=bank_mem_0[8][17]
+ D=FE_OFN189_bank_wdata_0__17 CK=CTS_755
Xbank_mem_0_reg[8][16] QDFFN $PINS Q=bank_mem_0[8][16] D=bank_wdata[0][16]
+ CK=CTS_610
Xbank_mem_0_reg[8][15] QDFFN $PINS Q=bank_mem_0[8][15] D=bank_wdata[0][15]
+ CK=CTS_610
Xbank_mem_0_reg[8][14] QDFFN $PINS Q=bank_mem_0[8][14] D=bank_wdata[0][14]
+ CK=CTS_610
Xbank_mem_0_reg[8][13] QDFFN $PINS Q=bank_mem_0[8][13] D=bank_wdata[0][13]
+ CK=CTS_610
Xbank_mem_0_reg[8][12] QDFFN $PINS Q=bank_mem_0[8][12]
+ D=FE_PHN2034_bank_wdata_0_12 CK=CTS_610
Xbank_mem_0_reg[8][11] QDFFN $PINS Q=bank_mem_0[8][11]
+ D=FE_PHN2041_bank_wdata_0_11 CK=CTS_610
Xbank_mem_0_reg[8][10] QDFFN $PINS Q=bank_mem_0[8][10]
+ D=FE_PHN2036_bank_wdata_0_10 CK=CTS_610
Xbank_mem_0_reg[8][9] QDFFN $PINS Q=bank_mem_0[8][9]
+ D=FE_PHN2038_bank_wdata_0_9 CK=CTS_610
Xbank_mem_0_reg[8][8] QDFFN $PINS Q=bank_mem_0[8][8]
+ D=FE_OFN480_bank_wdata_0__8 CK=CTS_610
Xbank_mem_0_reg[8][7] QDFFN $PINS Q=bank_mem_0[8][7]
+ D=FE_PHN2021_bank_wdata_0_7 CK=CTS_610
Xbank_mem_0_reg[8][6] QDFFN $PINS Q=bank_mem_0[8][6]
+ D=FE_OFN190_bank_wdata_0__6 CK=CTS_610
Xbank_mem_0_reg[8][5] QDFFN $PINS Q=bank_mem_0[8][5]
+ D=FE_OFN191_bank_wdata_0__5 CK=CTS_610
Xbank_mem_0_reg[8][4] QDFFN $PINS Q=bank_mem_0[8][4]
+ D=FE_PHN2138_bank_wdata_0_4 CK=CTS_610
Xbank_mem_0_reg[8][3] QDFFN $PINS Q=bank_mem_0[8][3]
+ D=FE_OFN192_bank_wdata_0__3 CK=CTS_610
Xbank_mem_0_reg[8][2] QDFFN $PINS Q=bank_mem_0[8][2]
+ D=FE_PHN2035_bank_wdata_0_2 CK=CTS_610
Xbank_mem_0_reg[8][1] QDFFN $PINS Q=bank_mem_0[8][1] D=bank_wdata[0][1]
+ CK=CTS_610
Xbank_mem_0_reg[8][0] QDFFN $PINS Q=bank_mem_0[8][0]
+ D=FE_PHN1846_FE_OFN11_bank_wdata_0__0 CK=CTS_610
Xbank_mem_0_reg[9][33] QDFFN $PINS Q=bank_mem_0[9][33] D=n900 CK=CTS_752
Xbank_mem_0_reg[10][32] QDFFN $PINS Q=bank_mem_0[10][32]
+ D=FE_PHN1919_FE_OFN174_bank_wdata_0__32 CK=CTS_749
Xbank_mem_0_reg[10][31] QDFFN $PINS Q=bank_mem_0[10][31]
+ D=FE_OFN175_bank_wdata_0__31 CK=CTS_749
Xbank_mem_0_reg[10][30] QDFFN $PINS Q=bank_mem_0[10][30]
+ D=FE_PHN1900_FE_OFN176_bank_wdata_0__30 CK=CTS_749
Xbank_mem_0_reg[10][29] QDFFN $PINS Q=bank_mem_0[10][29]
+ D=FE_OFN177_bank_wdata_0__29 CK=CTS_749
Xbank_mem_0_reg[10][28] QDFFN $PINS Q=bank_mem_0[10][28]
+ D=FE_OFN178_bank_wdata_0__28 CK=CTS_749
Xbank_mem_0_reg[10][27] QDFFN $PINS Q=bank_mem_0[10][27]
+ D=FE_OFN179_bank_wdata_0__27 CK=CTS_749
Xbank_mem_0_reg[10][26] QDFFN $PINS Q=bank_mem_0[10][26]
+ D=FE_OFN180_bank_wdata_0__26 CK=CTS_749
Xbank_mem_0_reg[10][25] QDFFN $PINS Q=bank_mem_0[10][25]
+ D=FE_OFN181_bank_wdata_0__25 CK=CTS_749
Xbank_mem_0_reg[10][24] QDFFN $PINS Q=bank_mem_0[10][24]
+ D=FE_OFN182_bank_wdata_0__24 CK=CTS_749
Xbank_mem_0_reg[10][23] QDFFN $PINS Q=bank_mem_0[10][23]
+ D=FE_OFN183_bank_wdata_0__23 CK=CTS_749
Xbank_mem_0_reg[10][22] QDFFN $PINS Q=bank_mem_0[10][22]
+ D=FE_OFN184_bank_wdata_0__22 CK=CTS_749
Xbank_mem_0_reg[10][21] QDFFN $PINS Q=bank_mem_0[10][21]
+ D=FE_OFN185_bank_wdata_0__21 CK=CTS_749
Xbank_mem_0_reg[10][20] QDFFN $PINS Q=bank_mem_0[10][20]
+ D=FE_OFN186_bank_wdata_0__20 CK=CTS_749
Xbank_mem_0_reg[10][19] QDFFN $PINS Q=bank_mem_0[10][19]
+ D=FE_OFN187_bank_wdata_0__19 CK=CTS_749
Xbank_mem_0_reg[10][18] QDFFN $PINS Q=bank_mem_0[10][18]
+ D=FE_PHN2042_FE_OFN188_bank_wdata_0__18 CK=CTS_749
Xbank_mem_0_reg[10][17] QDFFN $PINS Q=bank_mem_0[10][17]
+ D=FE_OFN189_bank_wdata_0__17 CK=CTS_749
Xbank_mem_0_reg[10][16] QDFFN $PINS Q=bank_mem_0[10][16] D=bank_wdata[0][16]
+ CK=CTS_604
Xbank_mem_0_reg[10][15] QDFFN $PINS Q=bank_mem_0[10][15] D=bank_wdata[0][15]
+ CK=CTS_604
Xbank_mem_0_reg[10][14] QDFFN $PINS Q=bank_mem_0[10][14] D=bank_wdata[0][14]
+ CK=CTS_604
Xbank_mem_0_reg[10][13] QDFFN $PINS Q=bank_mem_0[10][13] D=bank_wdata[0][13]
+ CK=CTS_604
Xbank_mem_0_reg[10][12] QDFFN $PINS Q=bank_mem_0[10][12]
+ D=FE_PHN2034_bank_wdata_0_12 CK=CTS_604
Xbank_mem_0_reg[10][11] QDFFN $PINS Q=bank_mem_0[10][11]
+ D=FE_PHN2041_bank_wdata_0_11 CK=CTS_604
Xbank_mem_0_reg[10][10] QDFFN $PINS Q=bank_mem_0[10][10]
+ D=FE_PHN2036_bank_wdata_0_10 CK=CTS_604
Xbank_mem_0_reg[10][9] QDFFN $PINS Q=bank_mem_0[10][9]
+ D=FE_PHN2038_bank_wdata_0_9 CK=CTS_604
Xbank_mem_0_reg[10][8] QDFFN $PINS Q=bank_mem_0[10][8]
+ D=FE_OFN480_bank_wdata_0__8 CK=CTS_604
Xbank_mem_0_reg[10][7] QDFFN $PINS Q=bank_mem_0[10][7]
+ D=FE_PHN2021_bank_wdata_0_7 CK=CTS_604
Xbank_mem_0_reg[10][6] QDFFN $PINS Q=bank_mem_0[10][6]
+ D=FE_OFN190_bank_wdata_0__6 CK=CTS_604
Xbank_mem_0_reg[10][5] QDFFN $PINS Q=bank_mem_0[10][5]
+ D=FE_OFN191_bank_wdata_0__5 CK=CTS_604
Xbank_mem_0_reg[10][4] QDFFN $PINS Q=bank_mem_0[10][4]
+ D=FE_PHN2138_bank_wdata_0_4 CK=CTS_604
Xbank_mem_0_reg[10][3] QDFFN $PINS Q=bank_mem_0[10][3]
+ D=FE_OFN192_bank_wdata_0__3 CK=CTS_604
Xbank_mem_0_reg[10][2] QDFFN $PINS Q=bank_mem_0[10][2]
+ D=FE_PHN2035_bank_wdata_0_2 CK=CTS_604
Xbank_mem_0_reg[10][1] QDFFN $PINS Q=bank_mem_0[10][1] D=bank_wdata[0][1]
+ CK=CTS_604
Xbank_mem_0_reg[10][0] QDFFN $PINS Q=bank_mem_0[10][0]
+ D=FE_PHN1846_FE_OFN11_bank_wdata_0__0 CK=CTS_604
Xbank_mem_0_reg[11][33] QDFFN $PINS Q=bank_mem_0[11][33] D=n900 CK=CTS_746
Xbank_mem_0_reg[8][33] QDFFN $PINS Q=bank_mem_0[8][33] D=n900 CK=CTS_755
Xbank_mem_0_reg[10][33] QDFFN $PINS Q=bank_mem_0[10][33] D=n900 CK=CTS_749
Xread_data_1_reg[33] QDFFRBN $PINS Q=read_data_1[33] D=N103 CK=clk
+ RB=FE_OFN20_i_rst_n
Xread_data_1_reg[16] QDFFRBN $PINS Q=read_data_1[16] D=FE_PHN2029_N120 CK=clk
+ RB=FE_OFN22_i_rst_n
Xread_data_1_reg[32] QDFFRBN $PINS Q=read_data_1[32] D=N104 CK=clk
+ RB=FE_OFN20_i_rst_n
Xread_data_1_reg[15] QDFFRBN $PINS Q=read_data_1[15] D=FE_PHN2019_N121 CK=clk
+ RB=FE_OFN22_i_rst_n
Xread_data_1_reg[31] QDFFRBN $PINS Q=read_data_1[31] D=FE_PHN2032_N105 CK=clk
+ RB=FE_OFN6_i_rst_n
Xread_data_1_reg[14] QDFFRBN $PINS Q=read_data_1[14] D=FE_PHN1994_N122 CK=clk
+ RB=FE_OFN22_i_rst_n
Xread_data_1_reg[30] QDFFRBN $PINS Q=read_data_1[30] D=N106 CK=clk
+ RB=FE_OFN6_i_rst_n
Xread_data_1_reg[13] QDFFRBN $PINS Q=read_data_1[13] D=FE_PHN2040_N123 CK=clk
+ RB=FE_OFN22_i_rst_n
Xread_data_1_reg[29] QDFFRBN $PINS Q=read_data_1[29] D=N107 CK=clk
+ RB=FE_OFN6_i_rst_n
Xread_data_1_reg[12] QDFFRBN $PINS Q=read_data_1[12] D=FE_PHN2030_N124 CK=clk
+ RB=FE_OFN22_i_rst_n
Xread_data_1_reg[28] QDFFRBN $PINS Q=read_data_1[28] D=N108 CK=clk
+ RB=FE_OFN6_i_rst_n
Xread_data_1_reg[11] QDFFRBN $PINS Q=read_data_1[11] D=FE_PHN2018_N125 CK=clk
+ RB=FE_OFN22_i_rst_n
Xread_data_1_reg[27] QDFFRBN $PINS Q=read_data_1[27] D=N109 CK=clk
+ RB=FE_OFN6_i_rst_n
Xread_data_1_reg[10] QDFFRBN $PINS Q=read_data_1[10] D=FE_PHN1969_N126 CK=clk
+ RB=FE_OFN22_i_rst_n
Xread_data_1_reg[9] QDFFRBN $PINS Q=read_data_1[9] D=FE_PHN2011_N127 CK=clk
+ RB=FE_OFN22_i_rst_n
Xread_data_1_reg[8] QDFFRBN $PINS Q=read_data_1[8] D=FE_PHN1962_N128 CK=clk
+ RB=FE_OFN22_i_rst_n
Xread_data_1_reg[6] QDFFRBN $PINS Q=read_data_1[6] D=N130 CK=clk
+ RB=FE_OFN22_i_rst_n
Xread_data_1_reg[5] QDFFRBN $PINS Q=read_data_1[5] D=FE_PHN1939_N131 CK=clk
+ RB=FE_OFN22_i_rst_n
Xread_data_1_reg[21] QDFFRBN $PINS Q=read_data_1[21] D=N115 CK=clk RB=i_rst_n
Xread_data_1_reg[20] QDFFRBN $PINS Q=read_data_1[20] D=N116 CK=clk RB=i_rst_n
Xread_data_1_reg[4] QDFFRBN $PINS Q=read_data_1[4] D=FE_PHN1953_N132 CK=clk
+ RB=FE_OFN22_i_rst_n
Xread_data_1_reg[3] QDFFRBN $PINS Q=read_data_1[3] D=FE_PHN1960_N133 CK=clk
+ RB=FE_OFN22_i_rst_n
Xread_data_1_reg[1] QDFFRBN $PINS Q=read_data_1[1] D=FE_PHN1906_N135
+ CK=clk_clone1 RB=FE_OFN49_i_rst_n
Xread_data_1_reg[19] QDFFRBN $PINS Q=read_data_1[19] D=FE_PHN2013_N117 CK=clk
+ RB=FE_OFN6_i_rst_n
Xread_data_1_reg[18] QDFFRBP $PINS Q=read_data_1[18] D=FE_PHN2016_N118 CK=clk
+ RB=FE_OFN20_i_rst_n
Xread_data_1_reg[26] QDFFRBN $PINS Q=read_data_1[26] D=N110 CK=clk RB=i_rst_n
Xread_data_1_reg[25] QDFFRBN $PINS Q=read_data_1[25] D=N111 CK=clk RB=i_rst_n
Xread_data_1_reg[24] QDFFRBN $PINS Q=read_data_1[24] D=N112 CK=clk RB=i_rst_n
Xread_data_1_reg[7] QDFFRBN $PINS Q=read_data_1[7] D=N129 CK=clk
+ RB=FE_OFN22_i_rst_n
Xread_data_1_reg[23] QDFFRBN $PINS Q=read_data_1[23] D=N113 CK=clk RB=i_rst_n
Xread_data_1_reg[22] QDFFRBN $PINS Q=read_data_1[22] D=N114 CK=clk RB=i_rst_n
Xread_data_1_reg[17] QDFFRBN $PINS Q=read_data_1[17] D=FE_PHN1999_N119 CK=clk
+ RB=FE_OFN6_i_rst_n
Xread_data_1_reg[0] QDFFRBN $PINS Q=read_data_1[0] D=FE_PHN1973_N136
+ CK=clk_clone1 RB=FE_OFN49_i_rst_n
Xread_data_1_reg[2] QDFFRBN $PINS Q=read_data_1[2] D=FE_PHN2025_N134 CK=clk
+ RB=FE_OFN22_i_rst_n
XU4 OAI22S $PINS O=N136 A1=FE_OFN170_n944 A2=n19 B1=FE_OFN128_n122 B2=n473
XU5 MXL2HS $PINS OB=N119 S=n944 A=n244 B=n660
XU6 MXL2HS $PINS OB=FE_PHN1972_N129 S=FE_OFN170_n944 A=n134 B=n550
XU7 MXL2HS $PINS OB=N110 S=n944 A=n343 B=n759
XU8 MXL2HS $PINS OB=N135 S=FE_OFN170_n944 A=n30 B=n484
XU9 MXL2HS $PINS OB=N133 S=FE_OFN170_n944 A=n52 B=n506
XU10 MXL2HS $PINS OB=N132 S=FE_OFN170_n944 A=n63 B=n517
XU11 MXL2HS $PINS OB=N131 S=FE_OFN170_n944 A=n74 B=n528
XU12 MXL2HS $PINS OB=FE_PHN1948_N130 S=FE_OFN170_n944 A=n123 B=n539
XU13 ND2S $PINS O=n102 I1=n953 I2=n108
XU14 MXL2HS $PINS OB=N128 S=FE_OFN170_n944 A=n145 B=n561
XU15 OA22 $PINS O=n1 A1=n973 A2=n87 B1=n1007 B2=n88
XU16 INV1S $PINS O=n900 I=n1
XU18 ND2 $PINS O=n107 I1=n115 I2=n116
XU19 ND2S $PINS O=n105 I1=n952 I2=n115
XU20 ND2S $PINS O=n92 I1=n954 I2=n99
XU21 ND2S $PINS O=n94 I1=n99 I2=n100
XU24 ND2 $PINS O=n85 I1=wen2 I2=n117
XU25 XNR2HS $PINS O=n112 I1=p_1 I2=n2
XU26 XNR2HS $PINS O=n2 I1=n120 I2=write_addr_1[2]
XU29 INV1S $PINS O=n953 I=n109
XU30 NR2 $PINS O=N58 I1=n103 I2=n114
XU31 NR2 $PINS O=N59 I1=n103 I2=n113
XU32 NR2 $PINS O=N54 I1=n106 I2=n114
XU33 NR2 $PINS O=N55 I1=n106 I2=n113
XU34 NR2 $PINS O=N56 I1=n105 I2=n114
XU35 NR2 $PINS O=N57 I1=n105 I2=n113
XU36 NR2 $PINS O=N53 I1=n107 I2=n113
XU37 NR2 $PINS O=N52 I1=n107 I2=n114
XU38 NR2 $PINS O=N91 I1=n90 I2=n98
XU39 NR2 $PINS O=N92 I1=n90 I2=n97
XU40 INV1S $PINS O=n956 I=n96
XU41 NR2 $PINS O=N87 I1=n93 I2=n98
XU42 NR2 $PINS O=N88 I1=n93 I2=n97
XU43 NR2 $PINS O=N89 I1=n92 I2=n98
XU44 NR2 $PINS O=N90 I1=n92 I2=n97
XU45 NR2 $PINS O=N86 I1=n94 I2=n97
XU46 NR2 $PINS O=N85 I1=n94 I2=n98
XU53 OAI22S $PINS O=n109 A1=p_1 A2=FE_OFN153_n87 B1=p_1 B2=FE_OFN173_n88
XU54 NR2 $PINS O=N61 I1=n102 I2=n107
XU55 NR2 $PINS O=N65 I1=n102 I2=n105
XU56 NR2 $PINS O=N63 I1=n102 I2=n106
XU57 NR2 $PINS O=N67 I1=n102 I2=n103
XU58 NR2 $PINS O=N66 I1=n103 I2=n104
XU59 INV1S $PINS O=n951 I=n115
XU60 INV1S $PINS O=n952 I=n116
XU61 NR2 $PINS O=N60 I1=n104 I2=n107
XU62 NR2 $PINS O=N64 I1=n104 I2=n105
XU63 NR2 $PINS O=N62 I1=n104 I2=n106
XU64 NR2 $PINS O=N100 I1=n90 I2=n91
XU65 INV1S $PINS O=n955 I=n99
XU66 NR2 $PINS O=N93 I1=n89 I2=n94
XU67 NR2 $PINS O=N97 I1=n89 I2=n92
XU68 NR2 $PINS O=N95 I1=n89 I2=n93
XU69 NR2 $PINS O=N99 I1=n89 I2=n90
XU70 INV1S $PINS O=n954 I=n100
XU71 OAI22S $PINS O=n96 A1=p_1 A2=FE_OFN152_n85 B1=p_1 B2=FE_OFN172_n86
XU72 NR2 $PINS O=N94 I1=n91 I2=n94
XU73 NR2 $PINS O=N98 I1=n91 I2=n92
XU74 NR2 $PINS O=N96 I1=n91 I2=n93
XU75 INV1S $PINS O=n944 I=FE_OFN128_n122
XU100 OAI22S $PINS O=n115 A1=p1 A2=FE_OFN153_n87 B1=p1 B2=FE_OFN173_n88
XU101 OAI22S $PINS O=n116 A1=p2 A2=FE_OFN153_n87 B1=p2 B2=FE_OFN173_n88
XU102 OAI22S $PINS O=n111 A1=p3 A2=FE_OFN153_n87 B1=p3 B2=FE_OFN173_n88
XU103 OAI22S $PINS O=n99 A1=p1 A2=FE_OFN152_n85 B1=p1 B2=FE_OFN172_n86
XU104 OAI22S $PINS O=n101 A1=p3 A2=FE_OFN152_n85 B1=p3 B2=FE_OFN172_n86
XU105 OAI22S $PINS O=n100 A1=p2 A2=FE_OFN152_n85 B1=p2 B2=FE_OFN172_n86
XU106 INV1S $PINS O=n1026 I=n112
XU108 OAI22S $PINS O=bank_wdata[0][1] A1=n975 A2=FE_OFN153_n87 B1=n1009
+ B2=FE_OFN173_n88
XU110 OAI22S $PINS O=bank_wdata[0][2] A1=n976 A2=FE_OFN153_n87 B1=n1010
+ B2=FE_OFN173_n88
XU112 OAI22S $PINS O=bank_wdata[0][3] A1=n977 A2=FE_OFN153_n87 B1=n1011
+ B2=FE_OFN173_n88
XU114 OAI22S $PINS O=bank_wdata[0][4] A1=n978 A2=FE_OFN153_n87 B1=n1012
+ B2=FE_OFN173_n88
XU116 OAI22S $PINS O=bank_wdata[0][16] A1=n990 A2=FE_OFN153_n87 B1=n1024
+ B2=FE_OFN173_n88
XU118 OAI22S $PINS O=bank_wdata[0][17] A1=n957 A2=n87 B1=n991 B2=n88
XU120 OAI22S $PINS O=bank_wdata[0][18] A1=n958 A2=n87 B1=n992 B2=n88
XU122 OAI22S $PINS O=bank_wdata[0][19] A1=n959 A2=n87 B1=n993 B2=n88
XU124 OAI22S $PINS O=bank_wdata[0][20] A1=n960 A2=n87 B1=n994 B2=n88
XU126 OAI22S $PINS O=bank_wdata[0][21] A1=n961 A2=n87 B1=n995 B2=n88
XU128 OAI22S $PINS O=bank_wdata[0][22] A1=FE_PHN1615_n962 A2=n87 B1=n996 B2=n88
XU130 OAI22S $PINS O=bank_wdata[0][23] A1=n963 A2=n87 B1=n997 B2=n88
XU132 OAI22S $PINS O=bank_wdata[0][24] A1=n964 A2=n87 B1=n998 B2=n88
XU134 OAI22S $PINS O=bank_wdata[0][25] A1=n965 A2=n87 B1=n999 B2=n88
XU136 OAI22S $PINS O=bank_wdata[0][26] A1=n966 A2=n87 B1=n1000 B2=n88
XU138 OAI22S $PINS O=bank_wdata[0][27] A1=n967 A2=n87 B1=n1001 B2=n88
XU140 OAI22S $PINS O=bank_wdata[0][28] A1=n968 A2=n87 B1=n1002 B2=n88
XU142 OAI22S $PINS O=bank_wdata[0][29] A1=n969 A2=n87 B1=n1003 B2=n88
XU144 OAI22S $PINS O=bank_wdata[0][30] A1=n970 A2=n87 B1=n1004 B2=n88
XU146 OAI22S $PINS O=bank_wdata[0][31] A1=n971 A2=n87 B1=n1005 B2=n88
XU148 OAI22S $PINS O=bank_wdata[0][32] A1=n972 A2=n87 B1=n1006 B2=n88
XU150 OAI22S $PINS O=bank_wdata[0][0] A1=n974 A2=FE_OFN153_n87 B1=n1008
+ B2=FE_OFN173_n88
XU152 OAI22S $PINS O=bank_wdata[0][10] A1=n984 A2=FE_OFN153_n87 B1=n1018
+ B2=FE_OFN173_n88
XU154 OAI22S $PINS O=bank_wdata[0][11] A1=n985 A2=FE_OFN153_n87 B1=n1019
+ B2=FE_OFN173_n88
XU156 OAI22S $PINS O=bank_wdata[0][12] A1=n986 A2=FE_OFN153_n87 B1=n1020
+ B2=FE_OFN173_n88
XU158 OAI22S $PINS O=bank_wdata[0][13] A1=n987 A2=FE_OFN153_n87 B1=n1021
+ B2=FE_OFN173_n88
XU160 OAI22S $PINS O=bank_wdata[0][14] A1=n988 A2=FE_OFN153_n87 B1=n1022
+ B2=FE_OFN173_n88
XU162 OAI22S $PINS O=bank_wdata[0][15] A1=n989 A2=FE_OFN153_n87 B1=n1023
+ B2=FE_OFN173_n88
XU164 OAI22S $PINS O=bank_wdata[0][5] A1=n979 A2=FE_OFN153_n87 B1=n1013
+ B2=FE_OFN173_n88
XU166 OAI22S $PINS O=bank_wdata[0][6] A1=n980 A2=FE_OFN153_n87 B1=n1014
+ B2=FE_OFN173_n88
XU168 OAI22S $PINS O=bank_wdata[0][7] A1=n981 A2=FE_OFN153_n87 B1=n1015
+ B2=FE_OFN173_n88
XU170 OAI22S $PINS O=bank_wdata[0][8] A1=n982 A2=FE_OFN153_n87 B1=n1016
+ B2=FE_OFN173_n88
XU172 OAI22S $PINS O=bank_wdata[0][9] A1=n983 A2=FE_OFN153_n87 B1=n1017
+ B2=FE_OFN173_n88
XU174 OAI22S $PINS O=bank_wdata[1][1] A1=n85 A2=n975 B1=FE_OFN172_n86 B2=n1009
XU176 OAI22S $PINS O=bank_wdata[1][2] A1=n85 A2=n976 B1=FE_OFN172_n86 B2=n1010
XU178 OAI22S $PINS O=bank_wdata[1][3] A1=n85 A2=n977 B1=FE_OFN172_n86 B2=n1011
XU180 OAI22S $PINS O=bank_wdata[1][4] A1=n85 A2=n978 B1=FE_OFN172_n86 B2=n1012
XU182 OAI22S $PINS O=bank_wdata[1][5] A1=n85 A2=n979 B1=FE_OFN172_n86 B2=n1013
XU184 OAI22S $PINS O=bank_wdata[1][6] A1=n85 A2=n980 B1=FE_OFN172_n86 B2=n1014
XU186 OAI22S $PINS O=bank_wdata[1][16] A1=n85 A2=n990 B1=FE_OFN172_n86 B2=n1024
XU188 OAI22S $PINS O=bank_wdata[1][17] A1=FE_OFN152_n85 A2=n957 B1=n86 B2=n991
XU190 OAI22S $PINS O=bank_wdata[1][18] A1=FE_OFN152_n85 A2=n958 B1=n86 B2=n992
XU192 OAI22S $PINS O=bank_wdata[1][19] A1=FE_OFN152_n85 A2=n959 B1=n86 B2=n993
XU194 OAI22S $PINS O=bank_wdata[1][20] A1=FE_OFN152_n85 A2=n960 B1=n86 B2=n994
XU196 OAI22S $PINS O=bank_wdata[1][21] A1=FE_OFN152_n85 A2=n961 B1=n86 B2=n995
XU198 OAI22S $PINS O=bank_wdata[1][22] A1=FE_OFN152_n85 A2=FE_PHN1615_n962
+ B1=n86 B2=n996
XU200 OAI22S $PINS O=bank_wdata[1][23] A1=FE_OFN152_n85 A2=n963 B1=n86 B2=n997
XU203 OAI22S $PINS O=bank_wdata[1][24] A1=FE_OFN152_n85 A2=n964 B1=n86 B2=n998
XU208 OAI22S $PINS O=bank_wdata[1][25] A1=FE_OFN152_n85 A2=n965 B1=n86 B2=n999
XU213 OAI22S $PINS O=bank_wdata[1][26] A1=FE_OFN152_n85 A2=n966 B1=n86 B2=n1000
XU218 OAI22S $PINS O=bank_wdata[1][27] A1=FE_OFN152_n85 A2=n967 B1=n86 B2=n1001
XU221 OAI22S $PINS O=bank_wdata[1][28] A1=FE_OFN152_n85 A2=n968 B1=n86 B2=n1002
XU223 OAI22S $PINS O=bank_wdata[1][29] A1=FE_OFN152_n85 A2=n969 B1=n86 B2=n1003
XU225 OAI22S $PINS O=bank_wdata[1][30] A1=FE_OFN152_n85 A2=n970 B1=n86 B2=n1004
XU235 OAI22S $PINS O=bank_wdata[1][31] A1=FE_OFN152_n85 A2=n971 B1=n86 B2=n1005
XU256 OAI22S $PINS O=bank_wdata[1][32] A1=FE_OFN152_n85 A2=n972 B1=n86 B2=n1006
XU258 OAI22S $PINS O=bank_wdata[1][33] A1=FE_OFN152_n85 A2=n973 B1=n86 B2=n1007
XU260 OAI22S $PINS O=bank_wdata[1][0] A1=n85 A2=n974 B1=FE_OFN172_n86 B2=n1008
XU262 OAI22S $PINS O=bank_wdata[1][10] A1=n85 A2=n984 B1=FE_OFN172_n86 B2=n1018
XU264 OAI22S $PINS O=bank_wdata[1][11] A1=n85 A2=n985 B1=FE_OFN172_n86 B2=n1019
XU266 OAI22S $PINS O=bank_wdata[1][12] A1=n85 A2=n986 B1=FE_OFN172_n86 B2=n1020
XU268 OAI22S $PINS O=bank_wdata[1][13] A1=n85 A2=n987 B1=FE_OFN172_n86 B2=n1021
XU270 OAI22S $PINS O=bank_wdata[1][14] A1=n85 A2=n988 B1=FE_OFN172_n86 B2=n1022
XU272 OAI22S $PINS O=bank_wdata[1][15] A1=n85 A2=n989 B1=FE_OFN172_n86 B2=n1023
XU274 OAI22S $PINS O=bank_wdata[1][7] A1=n85 A2=n981 B1=FE_OFN172_n86 B2=n1015
XU276 OAI22S $PINS O=bank_wdata[1][8] A1=n85 A2=n982 B1=FE_OFN172_n86 B2=n1016
XU278 OAI22S $PINS O=bank_wdata[1][9] A1=n85 A2=n983 B1=FE_OFN172_n86 B2=n1017
XU279 XNR2HS $PINS O=n118 I1=read_addr_1[4] I2=read_addr_1[3]
XU288 ND3 $PINS O=n88 I1=wen1 I2=FE_OFN153_n87 I3=n112
XU289 XNR2HS $PINS O=n117 I1=p_1 I2=n1029
XU290 XOR2HS $PINS O=n1029 I1=n120 I2=p1
XU292 AOI12HS $PINS O=n108 A1=n111 B1=FE_OFN153_n87 B2=n110
XU293 ND3 $PINS O=n86 I1=n1026 I2=FE_OFN152_n85 I3=wen1
XU294 AOI12HS $PINS O=n95 A1=n101 B1=FE_OFN152_n85 B2=n119
XU296 XOR2HS $PINS O=n120 I1=write_addr_1[4] I2=write_addr_1[3]
XU299 INV1S $PINS O=n1009 I=FE_PHN1550_cor_x_out_0_1
XU300 INV1S $PINS O=n1010 I=write_data_1[2]
XU301 INV1S $PINS O=n1011 I=write_data_1[3]
XU302 INV1S $PINS O=n1012 I=FE_PHN1526_cor_x_out_0_4
XU303 INV1S $PINS O=n1024 I=write_data_1[16]
XU304 INV1S $PINS O=n991 I=write_data_1[17]
XU305 INV1S $PINS O=n992 I=write_data_1[18]
XU306 INV1S $PINS O=n993 I=FE_PHN1570_cor_y_out_0_2
XU307 INV1S $PINS O=n994 I=write_data_1[20]
XU308 INV1S $PINS O=n995 I=write_data_1[21]
XU309 INV1S $PINS O=n996 I=FE_PHN1554_cor_y_out_0_5
XU310 INV1S $PINS O=n997 I=write_data_1[23]
XU311 INV1S $PINS O=n998 I=write_data_1[24]
XU312 INV1S $PINS O=n999 I=FE_PHN1556_cor_y_out_0_8
XU313 INV1S $PINS O=n1000 I=FE_PHN1521_cor_y_out_0_9
XU314 INV1S $PINS O=n1001 I=write_data_1[27]
XU315 INV1S $PINS O=n1002 I=write_data_1[28]
XU316 INV1S $PINS O=n1003 I=FE_PHN1522_cor_y_out_0_12
XU317 INV1S $PINS O=n1004 I=write_data_1[30]
XU318 INV1S $PINS O=n1005 I=write_data_1[31]
XU319 INV1S $PINS O=n1006 I=write_data_1[32]
XU320 INV1S $PINS O=n1007 I=write_data_1[33]
XU321 INV1S $PINS O=n1008 I=write_data_1[0]
XU322 INV1S $PINS O=n1018 I=write_data_1[10]
XU323 INV1S $PINS O=n1019 I=write_data_1[11]
XU324 INV1S $PINS O=n1020 I=write_data_1[12]
XU325 INV1S $PINS O=n1021 I=write_data_1[13]
XU326 INV1S $PINS O=n1022 I=write_data_1[14]
XU327 INV1S $PINS O=n1023 I=write_data_1[15]
XU328 INV1S $PINS O=n1013 I=write_data_1[5]
XU329 INV1S $PINS O=n1014 I=write_data_1[6]
XU330 INV1S $PINS O=n1015 I=write_data_1[7]
XU331 INV1S $PINS O=n1016 I=write_data_1[8]
XU332 INV1S $PINS O=n1017 I=write_data_1[9]
XU333 INV1S $PINS O=n974 I=write_data_2[0]
XU334 INV1S $PINS O=n975 I=write_data_2[1]
XU335 INV1S $PINS O=n976 I=write_data_2[2]
XU336 INV1S $PINS O=n977 I=write_data_2[3]
XU337 INV1S $PINS O=n978 I=FE_PHN1606_cor_x_out_1_4
XU338 INV1S $PINS O=n984 I=write_data_2[10]
XU339 INV1S $PINS O=n985 I=write_data_2[11]
XU340 INV1S $PINS O=n986 I=write_data_2[12]
XU341 INV1S $PINS O=n987 I=write_data_2[13]
XU342 INV1S $PINS O=n988 I=write_data_2[14]
XU343 INV1S $PINS O=n989 I=write_data_2[15]
XU344 INV1S $PINS O=n990 I=FE_PHN1426_cor_x_out_1_16
XU345 INV1S $PINS O=n957 I=write_data_2[17]
XU346 INV1S $PINS O=n958 I=write_data_2[18]
XU347 INV1S $PINS O=n959 I=write_data_2[19]
XU348 INV1S $PINS O=n960 I=FE_PHN1552_cor_y_out_1_3
XU349 INV1S $PINS O=n961 I=write_data_2[21]
XU350 INV1S $PINS O=n962 I=write_data_2[22]
XU351 INV1S $PINS O=n963 I=write_data_2[23]
XU352 INV1S $PINS O=n964 I=FE_PHN1585_cor_y_out_1_7
XU353 INV1S $PINS O=n965 I=write_data_2[25]
XU354 INV1S $PINS O=n966 I=FE_PHN1548_cor_y_out_1_9
XU355 INV1S $PINS O=n967 I=FE_PHN1573_cor_y_out_1_10
XU356 INV1S $PINS O=n968 I=write_data_2[28]
XU357 INV1S $PINS O=n969 I=write_data_2[29]
XU358 INV1S $PINS O=n970 I=write_data_2[30]
XU359 INV1S $PINS O=n971 I=write_data_2[31]
XU360 INV1S $PINS O=n972 I=write_data_2[32]
XU361 INV1S $PINS O=n973 I=write_data_2[33]
XU362 INV1S $PINS O=n979 I=write_data_2[5]
XU363 INV1S $PINS O=n980 I=write_data_2[6]
XU364 INV1S $PINS O=n981 I=FE_PHN1607_cor_x_out_1_7
XU365 INV1S $PINS O=n982 I=write_data_2[8]
XU366 INV1S $PINS O=n983 I=FE_PHN1553_cor_x_out_1_9
XU367 INV1S $PINS O=n855 I=N33
XU368 INV1S $PINS O=n439 I=N29
XU369 INV1S $PINS O=n854 I=N32
XU370 INV1S $PINS O=n438 I=N28
XU371 INV1S $PINS O=n853 I=N31
XU372 INV1S $PINS O=n437 I=N27
XU373 NR2 $PINS O=n10 I1=n439 I2=FE_OFN126_N30
XU374 NR2 $PINS O=n9 I1=n438 I2=n437
XU375 AN2 $PINS O=n424 I1=n10 I2=n9
XU376 NR2 $PINS O=n13 I1=n438 I2=N27
XU377 AN2 $PINS O=n411 I1=n13 I2=N29
XU378 AN2 $PINS O=n410 I1=N29 I2=n9
XU379 AOI22S $PINS O=n7 A1=bank_mem_0[14][0] A2=FE_OFN130_n411
+ B1=bank_mem_0[15][0] B2=FE_OFN129_n410
XU380 NR2 $PINS O=n12 I1=N27 I2=N28
XU381 AN2 $PINS O=n413 I1=n12 I2=N29
XU382 NR2 $PINS O=n11 I1=n437 I2=N28
XU383 AN2 $PINS O=n412 I1=n11 I2=N29
XU384 AOI22S $PINS O=n6 A1=bank_mem_0[12][0] A2=n413 B1=bank_mem_0[13][0]
+ B2=FE_OFN131_n412
XU385 AN2 $PINS O=n415 I1=n13 I2=n439
XU386 AN2 $PINS O=n414 I1=n9 I2=n439
XU387 AOI22S $PINS O=n4 A1=bank_mem_0[10][0] A2=n415 B1=bank_mem_0[11][0]
+ B2=FE_OFN133_n414
XU388 AN2 $PINS O=n417 I1=n12 I2=n439
XU389 AN2 $PINS O=n416 I1=n11 I2=n439
XU390 AOI22S $PINS O=n3 A1=bank_mem_0[8][0] A2=n417 B1=bank_mem_0[9][0]
+ B2=FE_OFN135_n416
XU391 AN2 $PINS O=n5 I1=n4 I2=n3
XU392 ND3 $PINS O=n8 I1=n7 I2=n6 I3=n5
XU393 AOI22S $PINS O=n18 A1=bank_mem_0[7][0] A2=FE_OFN154_n424 B1=n8 B2=N30
XU394 AN2 $PINS O=n426 I1=n10 I2=n11
XU395 AN2 $PINS O=n425 I1=n10 I2=n13
XU396 AOI22S $PINS O=n17 A1=bank_mem_0[5][0] A2=FE_OFN156_n426
+ B1=bank_mem_0[6][0] B2=FE_OFN155_n425
XU397 NR2 $PINS O=n14 I1=N29 I2=FE_OFN126_N30
XU398 AN2 $PINS O=n428 I1=n14 I2=n9
XU399 AN2 $PINS O=n427 I1=n10 I2=n12
XU400 AOI22S $PINS O=n16 A1=bank_mem_0[3][0] A2=n428 B1=bank_mem_0[4][0]
+ B2=n427
XU401 AN2 $PINS O=n431 I1=n14 I2=n11
XU402 AN2 $PINS O=n430 I1=n14 I2=n12
XU403 AN2 $PINS O=n429 I1=n14 I2=n13
XU404 AO222 $PINS O=n15 A1=bank_mem_0[1][0] A2=n431 B1=bank_mem_0[0][0] B2=n430
+ C1=bank_mem_0[2][0] C2=n429
XU405 AN4B1S $PINS O=n19 I1=n18 I2=n17 I3=n16 B1=n15
XU406 AOI22S $PINS O=n24 A1=bank_mem_0[14][1] A2=FE_OFN130_n411
+ B1=bank_mem_0[15][1] B2=FE_OFN129_n410
XU407 AOI22S $PINS O=n23 A1=bank_mem_0[12][1] A2=n413 B1=bank_mem_0[13][1]
+ B2=FE_OFN131_n412
XU408 AOI22S $PINS O=n21 A1=bank_mem_0[10][1] A2=n415 B1=bank_mem_0[11][1]
+ B2=FE_OFN133_n414
XU409 AOI22S $PINS O=n20 A1=bank_mem_0[8][1] A2=n417 B1=bank_mem_0[9][1]
+ B2=FE_OFN135_n416
XU410 AN2 $PINS O=n22 I1=n21 I2=n20
XU411 ND3 $PINS O=n25 I1=n24 I2=n23 I3=n22
XU412 AOI22S $PINS O=n29 A1=bank_mem_0[7][1] A2=FE_OFN154_n424 B1=n25 B2=N30
XU413 AOI22S $PINS O=n28 A1=bank_mem_0[5][1] A2=FE_OFN156_n426
+ B1=bank_mem_0[6][1] B2=FE_OFN155_n425
XU414 AOI22S $PINS O=n27 A1=bank_mem_0[3][1] A2=n428 B1=bank_mem_0[4][1]
+ B2=n427
XU415 AO222 $PINS O=n26 A1=bank_mem_0[1][1] A2=n431 B1=bank_mem_0[0][1] B2=n430
+ C1=bank_mem_0[2][1] C2=n429
XU416 AN4B1S $PINS O=n30 I1=n29 I2=n28 I3=n27 B1=n26
XU417 AOI22S $PINS O=n35 A1=bank_mem_0[14][2] A2=FE_OFN130_n411
+ B1=bank_mem_0[15][2] B2=FE_OFN129_n410
XU418 AOI22S $PINS O=n34 A1=bank_mem_0[12][2] A2=n413 B1=bank_mem_0[13][2]
+ B2=FE_OFN131_n412
XU419 AOI22S $PINS O=n32 A1=bank_mem_0[10][2] A2=n415 B1=bank_mem_0[11][2]
+ B2=FE_OFN133_n414
XU420 AOI22S $PINS O=n31 A1=bank_mem_0[8][2] A2=n417 B1=bank_mem_0[9][2]
+ B2=FE_OFN135_n416
XU421 AN2 $PINS O=n33 I1=n32 I2=n31
XU422 ND3 $PINS O=n36 I1=n35 I2=n34 I3=n33
XU423 AOI22S $PINS O=n40 A1=bank_mem_0[7][2] A2=FE_OFN154_n424 B1=n36 B2=N30
XU424 AOI22S $PINS O=n39 A1=bank_mem_0[5][2] A2=FE_OFN156_n426
+ B1=bank_mem_0[6][2] B2=FE_OFN155_n425
XU425 AOI22S $PINS O=n38 A1=bank_mem_0[3][2] A2=n428 B1=bank_mem_0[4][2]
+ B2=n427
XU426 AO222 $PINS O=n37 A1=bank_mem_0[1][2] A2=n431 B1=bank_mem_0[0][2] B2=n430
+ C1=bank_mem_0[2][2] C2=n429
XU427 AN4B1S $PINS O=FE_PHN2144_n41 I1=n40 I2=n39 I3=n38 B1=n37
XU428 INV1S $PINS O=bank_rdata[0][2] I=n41
XU429 AOI22S $PINS O=n46 A1=bank_mem_0[14][3] A2=FE_OFN130_n411
+ B1=bank_mem_0[15][3] B2=FE_OFN129_n410
XU430 AOI22S $PINS O=n45 A1=bank_mem_0[12][3] A2=n413 B1=bank_mem_0[13][3]
+ B2=FE_OFN131_n412
XU431 AOI22S $PINS O=n43 A1=bank_mem_0[10][3] A2=n415 B1=bank_mem_0[11][3]
+ B2=FE_OFN133_n414
XU432 AOI22S $PINS O=n42 A1=bank_mem_0[8][3] A2=n417 B1=bank_mem_0[9][3]
+ B2=FE_OFN135_n416
XU433 AN2 $PINS O=n44 I1=n43 I2=n42
XU434 ND3 $PINS O=n47 I1=n46 I2=n45 I3=n44
XU435 AOI22S $PINS O=n51 A1=bank_mem_0[7][3] A2=FE_OFN154_n424 B1=n47 B2=N30
XU436 AOI22S $PINS O=n50 A1=bank_mem_0[5][3] A2=FE_OFN156_n426
+ B1=bank_mem_0[6][3] B2=FE_OFN155_n425
XU437 AOI22S $PINS O=n49 A1=bank_mem_0[3][3] A2=n428 B1=bank_mem_0[4][3]
+ B2=n427
XU438 AO222 $PINS O=n48 A1=bank_mem_0[1][3] A2=n431 B1=bank_mem_0[0][3] B2=n430
+ C1=bank_mem_0[2][3] C2=n429
XU439 AN4B1S $PINS O=n52 I1=n51 I2=n50 I3=n49 B1=n48
XU440 AOI22S $PINS O=n57 A1=bank_mem_0[14][4] A2=FE_OFN130_n411
+ B1=bank_mem_0[15][4] B2=FE_OFN129_n410
XU441 AOI22S $PINS O=n56 A1=bank_mem_0[12][4] A2=n413 B1=bank_mem_0[13][4]
+ B2=FE_OFN131_n412
XU442 AOI22S $PINS O=n54 A1=bank_mem_0[10][4] A2=n415 B1=bank_mem_0[11][4]
+ B2=FE_OFN133_n414
XU443 AOI22S $PINS O=n53 A1=bank_mem_0[8][4] A2=n417 B1=bank_mem_0[9][4]
+ B2=FE_OFN135_n416
XU444 AN2 $PINS O=n55 I1=n54 I2=n53
XU445 ND3 $PINS O=n58 I1=n57 I2=n56 I3=n55
XU446 AOI22S $PINS O=n62 A1=bank_mem_0[7][4] A2=FE_OFN154_n424 B1=n58 B2=N30
XU447 AOI22S $PINS O=n61 A1=bank_mem_0[5][4] A2=FE_OFN156_n426
+ B1=bank_mem_0[6][4] B2=FE_OFN155_n425
XU448 AOI22S $PINS O=n60 A1=bank_mem_0[3][4] A2=n428 B1=bank_mem_0[4][4]
+ B2=n427
XU449 AO222 $PINS O=n59 A1=bank_mem_0[1][4] A2=n431 B1=bank_mem_0[0][4] B2=n430
+ C1=bank_mem_0[2][4] C2=n429
XU450 AN4B1S $PINS O=n63 I1=n62 I2=n61 I3=n60 B1=n59
XU451 AOI22S $PINS O=n68 A1=bank_mem_0[14][5] A2=FE_OFN130_n411
+ B1=bank_mem_0[15][5] B2=FE_OFN129_n410
XU452 AOI22S $PINS O=n67 A1=bank_mem_0[12][5] A2=n413 B1=bank_mem_0[13][5]
+ B2=FE_OFN131_n412
XU453 AOI22S $PINS O=n65 A1=bank_mem_0[10][5] A2=n415 B1=bank_mem_0[11][5]
+ B2=FE_OFN133_n414
XU454 AOI22S $PINS O=n64 A1=bank_mem_0[8][5] A2=n417 B1=bank_mem_0[9][5]
+ B2=FE_OFN135_n416
XU455 AN2 $PINS O=n66 I1=n65 I2=n64
XU456 ND3 $PINS O=n69 I1=n68 I2=n67 I3=n66
XU457 AOI22S $PINS O=n73 A1=bank_mem_0[7][5] A2=FE_OFN154_n424 B1=n69 B2=N30
XU458 AOI22S $PINS O=n72 A1=bank_mem_0[5][5] A2=FE_OFN156_n426
+ B1=bank_mem_0[6][5] B2=FE_OFN155_n425
XU459 AOI22S $PINS O=n71 A1=bank_mem_0[3][5] A2=n428 B1=bank_mem_0[4][5]
+ B2=n427
XU460 AO222 $PINS O=n70 A1=bank_mem_0[1][5] A2=n431 B1=bank_mem_0[0][5] B2=n430
+ C1=bank_mem_0[2][5] C2=n429
XU461 AN4B1S $PINS O=n74 I1=n73 I2=n72 I3=n71 B1=n70
XU462 AOI22S $PINS O=n79 A1=bank_mem_0[14][6] A2=FE_OFN130_n411
+ B1=bank_mem_0[15][6] B2=FE_OFN129_n410
XU463 AOI22S $PINS O=n78 A1=bank_mem_0[12][6] A2=n413 B1=bank_mem_0[13][6]
+ B2=FE_OFN131_n412
XU464 AOI22S $PINS O=n76 A1=bank_mem_0[10][6] A2=n415 B1=bank_mem_0[11][6]
+ B2=FE_OFN133_n414
XU465 AOI22S $PINS O=n75 A1=bank_mem_0[8][6] A2=n417 B1=bank_mem_0[9][6]
+ B2=FE_OFN135_n416
XU466 AN2 $PINS O=n77 I1=n76 I2=n75
XU467 ND3 $PINS O=n80 I1=n79 I2=n78 I3=n77
XU468 AOI22S $PINS O=n84 A1=bank_mem_0[7][6] A2=FE_OFN154_n424 B1=n80 B2=N30
XU469 AOI22S $PINS O=n83 A1=bank_mem_0[5][6] A2=FE_OFN156_n426
+ B1=bank_mem_0[6][6] B2=FE_OFN155_n425
XU470 AOI22S $PINS O=n82 A1=bank_mem_0[3][6] A2=n428 B1=bank_mem_0[4][6]
+ B2=n427
XU471 AO222 $PINS O=n81 A1=bank_mem_0[1][6] A2=n431 B1=bank_mem_0[0][6] B2=n430
+ C1=bank_mem_0[2][6] C2=n429
XU472 AN4B1S $PINS O=n123 I1=n84 I2=n83 I3=n82 B1=n81
XU473 AOI22S $PINS O=n128 A1=bank_mem_0[14][7] A2=FE_OFN130_n411
+ B1=bank_mem_0[15][7] B2=FE_OFN129_n410
XU474 AOI22S $PINS O=n127 A1=bank_mem_0[12][7] A2=n413 B1=bank_mem_0[13][7]
+ B2=FE_OFN131_n412
XU475 AOI22S $PINS O=n125 A1=bank_mem_0[10][7] A2=n415 B1=bank_mem_0[11][7]
+ B2=FE_OFN133_n414
XU476 AOI22S $PINS O=n124 A1=bank_mem_0[8][7] A2=n417 B1=bank_mem_0[9][7]
+ B2=FE_OFN135_n416
XU477 AN2 $PINS O=n126 I1=n125 I2=n124
XU478 ND3 $PINS O=n129 I1=n128 I2=n127 I3=n126
XU479 AOI22S $PINS O=n133 A1=bank_mem_0[7][7] A2=FE_OFN154_n424 B1=n129 B2=N30
XU480 AOI22S $PINS O=n132 A1=bank_mem_0[5][7] A2=FE_OFN156_n426
+ B1=bank_mem_0[6][7] B2=FE_OFN155_n425
XU481 AOI22S $PINS O=n131 A1=bank_mem_0[3][7] A2=n428 B1=bank_mem_0[4][7]
+ B2=n427
XU482 AO222 $PINS O=n130 A1=bank_mem_0[1][7] A2=n431 B1=bank_mem_0[0][7]
+ B2=n430 C1=bank_mem_0[2][7] C2=n429
XU483 AN4B1S $PINS O=n134 I1=n133 I2=n132 I3=FE_PHN1580_n131 B1=n130
XU484 AOI22S $PINS O=n139 A1=bank_mem_0[14][8] A2=FE_OFN130_n411
+ B1=bank_mem_0[15][8] B2=FE_OFN129_n410
XU485 AOI22S $PINS O=n138 A1=bank_mem_0[12][8] A2=n413 B1=bank_mem_0[13][8]
+ B2=FE_OFN131_n412
XU486 AOI22S $PINS O=n136 A1=bank_mem_0[10][8] A2=n415 B1=bank_mem_0[11][8]
+ B2=FE_OFN133_n414
XU487 AOI22S $PINS O=n135 A1=bank_mem_0[8][8] A2=n417 B1=bank_mem_0[9][8]
+ B2=FE_OFN135_n416
XU488 AN2 $PINS O=n137 I1=n136 I2=n135
XU489 ND3 $PINS O=n140 I1=n139 I2=n138 I3=n137
XU490 AOI22S $PINS O=n144 A1=bank_mem_0[7][8] A2=FE_OFN154_n424 B1=n140 B2=N30
XU491 AOI22S $PINS O=n143 A1=bank_mem_0[5][8] A2=FE_OFN156_n426
+ B1=bank_mem_0[6][8] B2=FE_OFN155_n425
XU492 AOI22S $PINS O=n142 A1=bank_mem_0[3][8] A2=n428 B1=bank_mem_0[4][8]
+ B2=n427
XU493 AO222 $PINS O=n141 A1=bank_mem_0[1][8] A2=n431 B1=bank_mem_0[0][8]
+ B2=n430 C1=bank_mem_0[2][8] C2=n429
XU494 AN4B1S $PINS O=n145 I1=n144 I2=n143 I3=n142 B1=n141
XU495 AOI22S $PINS O=n150 A1=bank_mem_0[14][9] A2=FE_OFN130_n411
+ B1=bank_mem_0[15][9] B2=FE_OFN129_n410
XU496 AOI22S $PINS O=n149 A1=bank_mem_0[12][9] A2=n413 B1=bank_mem_0[13][9]
+ B2=FE_OFN131_n412
XU497 AOI22S $PINS O=n147 A1=bank_mem_0[10][9] A2=n415 B1=bank_mem_0[11][9]
+ B2=FE_OFN133_n414
XU498 AOI22S $PINS O=n146 A1=bank_mem_0[8][9] A2=n417 B1=bank_mem_0[9][9]
+ B2=FE_OFN135_n416
XU499 AN2 $PINS O=n148 I1=n147 I2=n146
XU500 ND3 $PINS O=n151 I1=n150 I2=n149 I3=n148
XU501 AOI22S $PINS O=n155 A1=bank_mem_0[7][9] A2=FE_OFN154_n424 B1=n151 B2=N30
XU502 AOI22S $PINS O=n154 A1=bank_mem_0[5][9] A2=FE_OFN156_n426
+ B1=bank_mem_0[6][9] B2=FE_OFN155_n425
XU503 AOI22S $PINS O=n153 A1=bank_mem_0[3][9] A2=n428 B1=bank_mem_0[4][9]
+ B2=n427
XU504 AO222 $PINS O=n152 A1=bank_mem_0[1][9] A2=n431 B1=bank_mem_0[0][9]
+ B2=n430 C1=bank_mem_0[2][9] C2=n429
XU505 AN4B1S $PINS O=n156 I1=n155 I2=n154 I3=n153 B1=n152
XU506 INV1S $PINS O=bank_rdata[0][9] I=n156
XU507 AOI22S $PINS O=n161 A1=bank_mem_0[14][10] A2=FE_OFN130_n411
+ B1=bank_mem_0[15][10] B2=FE_OFN129_n410
XU508 AOI22S $PINS O=n160 A1=bank_mem_0[12][10] A2=n413 B1=bank_mem_0[13][10]
+ B2=FE_OFN131_n412
XU509 AOI22S $PINS O=n158 A1=bank_mem_0[10][10] A2=n415 B1=bank_mem_0[11][10]
+ B2=FE_OFN133_n414
XU510 AOI22S $PINS O=n157 A1=bank_mem_0[8][10] A2=n417 B1=bank_mem_0[9][10]
+ B2=FE_OFN135_n416
XU511 AN2 $PINS O=n159 I1=n158 I2=n157
XU512 ND3 $PINS O=n162 I1=n161 I2=n160 I3=n159
XU513 AOI22S $PINS O=n166 A1=bank_mem_0[7][10] A2=FE_OFN154_n424 B1=n162 B2=N30
XU514 AOI22S $PINS O=n165 A1=bank_mem_0[5][10] A2=FE_OFN156_n426
+ B1=bank_mem_0[6][10] B2=FE_OFN155_n425
XU515 AOI22S $PINS O=n164 A1=bank_mem_0[3][10] A2=n428 B1=bank_mem_0[4][10]
+ B2=n427
XU516 AO222 $PINS O=n163 A1=bank_mem_0[1][10] A2=n431 B1=bank_mem_0[0][10]
+ B2=n430 C1=bank_mem_0[2][10] C2=n429
XU517 AN4B1S $PINS O=n167 I1=n166 I2=n165 I3=n164 B1=n163
XU518 INV1S $PINS O=bank_rdata[0][10] I=n167
XU519 AOI22S $PINS O=n172 A1=bank_mem_0[14][11] A2=FE_OFN130_n411
+ B1=bank_mem_0[15][11] B2=FE_OFN129_n410
XU520 AOI22S $PINS O=n171 A1=bank_mem_0[12][11] A2=n413 B1=bank_mem_0[13][11]
+ B2=FE_OFN131_n412
XU521 AOI22S $PINS O=n169 A1=bank_mem_0[10][11] A2=n415 B1=bank_mem_0[11][11]
+ B2=FE_OFN133_n414
XU522 AOI22S $PINS O=n168 A1=bank_mem_0[8][11] A2=n417 B1=bank_mem_0[9][11]
+ B2=FE_OFN135_n416
XU523 AN2 $PINS O=n170 I1=n169 I2=n168
XU524 ND3 $PINS O=n173 I1=n172 I2=n171 I3=n170
XU525 AOI22S $PINS O=n177 A1=bank_mem_0[7][11] A2=FE_OFN154_n424 B1=n173 B2=N30
XU526 AOI22S $PINS O=n176 A1=bank_mem_0[5][11] A2=FE_OFN156_n426
+ B1=bank_mem_0[6][11] B2=FE_OFN155_n425
XU527 AOI22S $PINS O=n175 A1=bank_mem_0[3][11] A2=n428 B1=bank_mem_0[4][11]
+ B2=n427
XU528 AO222 $PINS O=n174 A1=bank_mem_0[1][11] A2=n431 B1=bank_mem_0[0][11]
+ B2=n430 C1=bank_mem_0[2][11] C2=n429
XU529 AN4B1S $PINS O=FE_PHN2154_n178 I1=n177 I2=n176 I3=n175 B1=n174
XU530 INV1S $PINS O=bank_rdata[0][11] I=n178
XU531 AOI22S $PINS O=n183 A1=bank_mem_0[14][12] A2=FE_OFN130_n411
+ B1=bank_mem_0[15][12] B2=FE_OFN129_n410
XU532 AOI22S $PINS O=n182 A1=bank_mem_0[12][12] A2=n413 B1=bank_mem_0[13][12]
+ B2=FE_OFN131_n412
XU533 AOI22S $PINS O=n180 A1=bank_mem_0[10][12] A2=n415 B1=bank_mem_0[11][12]
+ B2=FE_OFN133_n414
XU534 AOI22S $PINS O=n179 A1=bank_mem_0[8][12] A2=n417 B1=bank_mem_0[9][12]
+ B2=FE_OFN135_n416
XU535 AN2 $PINS O=n181 I1=n180 I2=n179
XU536 ND3 $PINS O=n184 I1=n183 I2=n182 I3=n181
XU537 AOI22S $PINS O=n188 A1=bank_mem_0[7][12] A2=FE_OFN154_n424 B1=n184 B2=N30
XU538 AOI22S $PINS O=n187 A1=bank_mem_0[5][12] A2=FE_OFN156_n426
+ B1=bank_mem_0[6][12] B2=FE_OFN155_n425
XU539 AOI22S $PINS O=n186 A1=bank_mem_0[3][12] A2=n428 B1=bank_mem_0[4][12]
+ B2=n427
XU540 AO222 $PINS O=n185 A1=bank_mem_0[1][12] A2=n431 B1=bank_mem_0[0][12]
+ B2=n430 C1=bank_mem_0[2][12] C2=n429
XU541 AN4B1S $PINS O=n189 I1=n188 I2=n187 I3=n186 B1=n185
XU542 INV1S $PINS O=bank_rdata[0][12] I=n189
XU543 AOI22S $PINS O=n194 A1=bank_mem_0[14][13] A2=FE_OFN130_n411
+ B1=bank_mem_0[15][13] B2=FE_OFN129_n410
XU544 AOI22S $PINS O=n193 A1=bank_mem_0[12][13] A2=n413 B1=bank_mem_0[13][13]
+ B2=FE_OFN131_n412
XU545 AOI22S $PINS O=n191 A1=bank_mem_0[10][13] A2=n415 B1=bank_mem_0[11][13]
+ B2=FE_OFN133_n414
XU546 AOI22S $PINS O=n190 A1=bank_mem_0[8][13] A2=n417 B1=bank_mem_0[9][13]
+ B2=FE_OFN135_n416
XU547 AN2 $PINS O=n192 I1=n191 I2=n190
XU548 ND3 $PINS O=n195 I1=n194 I2=n193 I3=n192
XU549 AOI22S $PINS O=n199 A1=bank_mem_0[7][13] A2=FE_OFN154_n424 B1=n195 B2=N30
XU550 AOI22S $PINS O=n198 A1=bank_mem_0[5][13] A2=FE_OFN156_n426
+ B1=bank_mem_0[6][13] B2=FE_OFN155_n425
XU551 AOI22S $PINS O=n197 A1=bank_mem_0[3][13] A2=n428 B1=bank_mem_0[4][13]
+ B2=n427
XU552 AO222 $PINS O=n196 A1=bank_mem_0[1][13] A2=n431 B1=bank_mem_0[0][13]
+ B2=n430 C1=bank_mem_0[2][13] C2=n429
XU553 AN4B1S $PINS O=FE_PHN2097_n200 I1=n199 I2=n198 I3=n197 B1=n196
XU554 INV1S $PINS O=bank_rdata[0][13] I=n200
XU555 AOI22S $PINS O=n205 A1=bank_mem_0[14][14] A2=FE_OFN130_n411
+ B1=bank_mem_0[15][14] B2=FE_OFN129_n410
XU556 AOI22S $PINS O=n204 A1=bank_mem_0[12][14] A2=n413 B1=bank_mem_0[13][14]
+ B2=FE_OFN131_n412
XU557 AOI22S $PINS O=n202 A1=bank_mem_0[10][14] A2=n415 B1=bank_mem_0[11][14]
+ B2=FE_OFN133_n414
XU558 AOI22S $PINS O=n201 A1=bank_mem_0[8][14] A2=n417 B1=bank_mem_0[9][14]
+ B2=FE_OFN135_n416
XU559 AN2 $PINS O=n203 I1=n202 I2=n201
XU560 ND3 $PINS O=n206 I1=n205 I2=n204 I3=n203
XU561 AOI22S $PINS O=n210 A1=bank_mem_0[7][14] A2=FE_OFN154_n424 B1=n206 B2=N30
XU562 AOI22S $PINS O=n209 A1=bank_mem_0[5][14] A2=FE_OFN156_n426
+ B1=bank_mem_0[6][14] B2=FE_OFN155_n425
XU563 AOI22S $PINS O=n208 A1=bank_mem_0[3][14] A2=n428 B1=bank_mem_0[4][14]
+ B2=n427
XU564 AO222 $PINS O=n207 A1=bank_mem_0[1][14] A2=n431 B1=bank_mem_0[0][14]
+ B2=n430 C1=bank_mem_0[2][14] C2=n429
XU565 AN4B1S $PINS O=n211 I1=n210 I2=n209 I3=n208 B1=n207
XU566 INV1S $PINS O=bank_rdata[0][14] I=n211
XU567 AOI22S $PINS O=n216 A1=bank_mem_0[14][15] A2=FE_OFN130_n411
+ B1=bank_mem_0[15][15] B2=FE_OFN129_n410
XU568 AOI22S $PINS O=n215 A1=bank_mem_0[12][15] A2=n413 B1=bank_mem_0[13][15]
+ B2=FE_OFN131_n412
XU569 AOI22S $PINS O=n213 A1=bank_mem_0[10][15] A2=n415 B1=bank_mem_0[11][15]
+ B2=FE_OFN133_n414
XU570 AOI22S $PINS O=n212 A1=bank_mem_0[8][15] A2=n417 B1=bank_mem_0[9][15]
+ B2=FE_OFN135_n416
XU571 AN2 $PINS O=n214 I1=n213 I2=n212
XU572 ND3 $PINS O=n217 I1=n216 I2=n215 I3=n214
XU573 AOI22S $PINS O=n221 A1=bank_mem_0[7][15] A2=FE_OFN154_n424 B1=n217 B2=N30
XU574 AOI22S $PINS O=n220 A1=bank_mem_0[5][15] A2=FE_OFN156_n426
+ B1=bank_mem_0[6][15] B2=FE_OFN155_n425
XU575 AOI22S $PINS O=n219 A1=bank_mem_0[3][15] A2=n428 B1=bank_mem_0[4][15]
+ B2=n427
XU576 AO222 $PINS O=n218 A1=bank_mem_0[1][15] A2=n431 B1=bank_mem_0[0][15]
+ B2=n430 C1=bank_mem_0[2][15] C2=n429
XU577 AN4B1S $PINS O=n222 I1=n221 I2=n220 I3=n219 B1=n218
XU578 INV1S $PINS O=bank_rdata[0][15] I=n222
XU579 AOI22S $PINS O=n227 A1=bank_mem_0[14][16] A2=FE_OFN130_n411
+ B1=bank_mem_0[15][16] B2=FE_OFN129_n410
XU580 AOI22S $PINS O=n226 A1=bank_mem_0[12][16] A2=n413 B1=bank_mem_0[13][16]
+ B2=FE_OFN131_n412
XU581 AOI22S $PINS O=n224 A1=bank_mem_0[10][16] A2=n415 B1=bank_mem_0[11][16]
+ B2=FE_OFN133_n414
XU582 AOI22S $PINS O=n223 A1=bank_mem_0[8][16] A2=n417 B1=bank_mem_0[9][16]
+ B2=FE_OFN135_n416
XU583 AN2 $PINS O=n225 I1=n224 I2=n223
XU584 ND3 $PINS O=n228 I1=n227 I2=n226 I3=n225
XU585 AOI22S $PINS O=n232 A1=bank_mem_0[7][16] A2=FE_OFN154_n424 B1=n228 B2=N30
XU586 AOI22S $PINS O=n231 A1=bank_mem_0[5][16] A2=FE_OFN156_n426
+ B1=bank_mem_0[6][16] B2=FE_OFN155_n425
XU587 AOI22S $PINS O=n230 A1=bank_mem_0[3][16] A2=n428 B1=bank_mem_0[4][16]
+ B2=n427
XU588 AO222 $PINS O=n229 A1=bank_mem_0[1][16] A2=n431 B1=bank_mem_0[0][16]
+ B2=n430 C1=bank_mem_0[2][16] C2=n429
XU589 AN4B1S $PINS O=n233 I1=n232 I2=n231 I3=n230 B1=n229
XU590 INV1S $PINS O=bank_rdata[0][16] I=n233
XU591 AOI22S $PINS O=n238 A1=bank_mem_0[14][17] A2=n411 B1=bank_mem_0[15][17]
+ B2=n410
XU592 AOI22S $PINS O=n237 A1=bank_mem_0[12][17] A2=FE_OFN132_n413
+ B1=bank_mem_0[13][17] B2=n412
XU593 AOI22S $PINS O=n235 A1=bank_mem_0[10][17] A2=FE_OFN134_n415
+ B1=bank_mem_0[11][17] B2=n414
XU594 AOI22S $PINS O=n234 A1=bank_mem_0[8][17] A2=FE_OFN136_n417
+ B1=bank_mem_0[9][17] B2=n416
XU595 AN2 $PINS O=n236 I1=n235 I2=n234
XU596 ND3 $PINS O=n239 I1=n238 I2=n237 I3=n236
XU597 AOI22S $PINS O=n243 A1=bank_mem_0[7][17] A2=n424 B1=n239 B2=FE_OFN126_N30
XU598 AOI22S $PINS O=n242 A1=bank_mem_0[5][17] A2=n426 B1=bank_mem_0[6][17]
+ B2=n425
XU599 AOI22S $PINS O=n241 A1=bank_mem_0[3][17] A2=FE_OFN158_n428
+ B1=bank_mem_0[4][17] B2=FE_OFN157_n427
XU600 AO222 $PINS O=n240 A1=bank_mem_0[1][17] A2=FE_OFN161_n431
+ B1=bank_mem_0[0][17] B2=FE_OFN160_n430 C1=bank_mem_0[2][17] C2=FE_OFN159_n429
XU601 AN4B1S $PINS O=n244 I1=n243 I2=n242 I3=n241 B1=n240
XU602 AOI22S $PINS O=n249 A1=bank_mem_0[14][18] A2=n411 B1=bank_mem_0[15][18]
+ B2=n410
XU603 AOI22S $PINS O=n248 A1=bank_mem_0[12][18] A2=FE_OFN132_n413
+ B1=bank_mem_0[13][18] B2=n412
XU604 AOI22S $PINS O=n246 A1=bank_mem_0[10][18] A2=FE_OFN134_n415
+ B1=bank_mem_0[11][18] B2=n414
XU605 AOI22S $PINS O=n245 A1=bank_mem_0[8][18] A2=FE_OFN136_n417
+ B1=bank_mem_0[9][18] B2=n416
XU606 AN2 $PINS O=n247 I1=n246 I2=n245
XU607 ND3 $PINS O=n250 I1=n249 I2=n248 I3=n247
XU608 AOI22S $PINS O=n254 A1=bank_mem_0[7][18] A2=n424 B1=n250 B2=FE_OFN126_N30
XU609 AOI22S $PINS O=n253 A1=bank_mem_0[5][18] A2=n426 B1=bank_mem_0[6][18]
+ B2=n425
XU610 AOI22S $PINS O=n252 A1=bank_mem_0[3][18] A2=FE_OFN158_n428
+ B1=bank_mem_0[4][18] B2=FE_OFN157_n427
XU611 AO222 $PINS O=n251 A1=bank_mem_0[1][18] A2=FE_OFN161_n431
+ B1=bank_mem_0[0][18] B2=FE_OFN160_n430 C1=bank_mem_0[2][18] C2=FE_OFN159_n429
XU612 AN4B1S $PINS O=n255 I1=n254 I2=n253 I3=n252 B1=n251
XU613 INV1S $PINS O=bank_rdata[0][18] I=n255
XU614 AOI22S $PINS O=n260 A1=bank_mem_0[14][19] A2=n411 B1=bank_mem_0[15][19]
+ B2=n410
XU615 AOI22S $PINS O=n259 A1=bank_mem_0[12][19] A2=FE_OFN132_n413
+ B1=bank_mem_0[13][19] B2=n412
XU616 AOI22S $PINS O=n257 A1=bank_mem_0[10][19] A2=FE_OFN134_n415
+ B1=bank_mem_0[11][19] B2=n414
XU617 AOI22S $PINS O=n256 A1=bank_mem_0[8][19] A2=FE_OFN136_n417
+ B1=bank_mem_0[9][19] B2=n416
XU618 AN2 $PINS O=n258 I1=n257 I2=n256
XU619 ND3 $PINS O=n261 I1=n260 I2=n259 I3=n258
XU620 AOI22S $PINS O=n265 A1=bank_mem_0[7][19] A2=n424 B1=n261 B2=FE_OFN126_N30
XU621 AOI22S $PINS O=n264 A1=bank_mem_0[5][19] A2=n426 B1=bank_mem_0[6][19]
+ B2=n425
XU622 AOI22S $PINS O=n263 A1=bank_mem_0[3][19] A2=FE_OFN158_n428
+ B1=bank_mem_0[4][19] B2=FE_OFN157_n427
XU623 AO222 $PINS O=n262 A1=bank_mem_0[1][19] A2=FE_OFN161_n431
+ B1=bank_mem_0[0][19] B2=FE_OFN160_n430 C1=bank_mem_0[2][19] C2=FE_OFN159_n429
XU624 AN4B1S $PINS O=n266 I1=n265 I2=n264 I3=n263 B1=n262
XU625 INV1S $PINS O=bank_rdata[0][19] I=n266
XU626 AOI22S $PINS O=n271 A1=bank_mem_0[14][20] A2=n411 B1=bank_mem_0[15][20]
+ B2=n410
XU627 AOI22S $PINS O=n270 A1=bank_mem_0[12][20] A2=FE_OFN132_n413
+ B1=bank_mem_0[13][20] B2=n412
XU628 AOI22S $PINS O=n268 A1=bank_mem_0[10][20] A2=FE_OFN134_n415
+ B1=bank_mem_0[11][20] B2=n414
XU629 AOI22S $PINS O=n267 A1=bank_mem_0[8][20] A2=FE_OFN136_n417
+ B1=bank_mem_0[9][20] B2=n416
XU630 AN2 $PINS O=n269 I1=n268 I2=n267
XU631 ND3 $PINS O=n272 I1=n271 I2=n270 I3=n269
XU632 AOI22S $PINS O=n276 A1=bank_mem_0[7][20] A2=n424 B1=n272 B2=FE_OFN126_N30
XU633 AOI22S $PINS O=n275 A1=bank_mem_0[5][20] A2=n426 B1=bank_mem_0[6][20]
+ B2=n425
XU634 AOI22S $PINS O=n274 A1=bank_mem_0[3][20] A2=FE_OFN158_n428
+ B1=bank_mem_0[4][20] B2=FE_OFN157_n427
XU635 AO222 $PINS O=n273 A1=bank_mem_0[1][20] A2=FE_OFN161_n431
+ B1=bank_mem_0[0][20] B2=FE_OFN160_n430 C1=bank_mem_0[2][20] C2=FE_OFN159_n429
XU636 AN4B1S $PINS O=n277 I1=n276 I2=n275 I3=n274 B1=n273
XU637 INV1S $PINS O=bank_rdata[0][20] I=FE_PHN1725_n277
XU638 AOI22S $PINS O=n282 A1=bank_mem_0[14][21] A2=n411 B1=bank_mem_0[15][21]
+ B2=n410
XU639 AOI22S $PINS O=n281 A1=bank_mem_0[12][21] A2=FE_OFN132_n413
+ B1=bank_mem_0[13][21] B2=n412
XU640 AOI22S $PINS O=n279 A1=bank_mem_0[10][21] A2=FE_OFN134_n415
+ B1=bank_mem_0[11][21] B2=n414
XU641 AOI22S $PINS O=n278 A1=bank_mem_0[8][21] A2=FE_OFN136_n417
+ B1=bank_mem_0[9][21] B2=n416
XU642 AN2 $PINS O=n280 I1=n279 I2=n278
XU643 ND3 $PINS O=n283 I1=n282 I2=n281 I3=n280
XU644 AOI22S $PINS O=n287 A1=bank_mem_0[7][21] A2=n424 B1=n283 B2=FE_OFN126_N30
XU645 AOI22S $PINS O=n286 A1=bank_mem_0[5][21] A2=n426 B1=bank_mem_0[6][21]
+ B2=n425
XU646 AOI22S $PINS O=n285 A1=bank_mem_0[3][21] A2=FE_OFN158_n428
+ B1=bank_mem_0[4][21] B2=FE_OFN157_n427
XU647 AO222 $PINS O=n284 A1=bank_mem_0[1][21] A2=FE_OFN161_n431
+ B1=bank_mem_0[0][21] B2=FE_OFN160_n430 C1=bank_mem_0[2][21] C2=FE_OFN159_n429
XU648 AN4B1S $PINS O=n288 I1=n287 I2=n286 I3=n285 B1=n284
XU649 INV1S $PINS O=bank_rdata[0][21] I=FE_PHN1686_n288
XU650 AOI22S $PINS O=n293 A1=bank_mem_0[14][22] A2=n411 B1=bank_mem_0[15][22]
+ B2=n410
XU651 AOI22S $PINS O=n292 A1=bank_mem_0[12][22] A2=FE_OFN132_n413
+ B1=bank_mem_0[13][22] B2=n412
XU652 AOI22S $PINS O=n290 A1=bank_mem_0[10][22] A2=FE_OFN134_n415
+ B1=bank_mem_0[11][22] B2=n414
XU653 AOI22S $PINS O=n289 A1=bank_mem_0[8][22] A2=FE_OFN136_n417
+ B1=bank_mem_0[9][22] B2=n416
XU654 AN2 $PINS O=n291 I1=n290 I2=n289
XU655 ND3 $PINS O=n294 I1=n293 I2=n292 I3=n291
XU656 AOI22S $PINS O=n298 A1=bank_mem_0[7][22] A2=n424 B1=n294 B2=FE_OFN126_N30
XU657 AOI22S $PINS O=n297 A1=bank_mem_0[5][22] A2=n426 B1=bank_mem_0[6][22]
+ B2=n425
XU658 AOI22S $PINS O=n296 A1=bank_mem_0[3][22] A2=FE_OFN158_n428
+ B1=bank_mem_0[4][22] B2=FE_OFN157_n427
XU659 AO222 $PINS O=n295 A1=bank_mem_0[1][22] A2=FE_OFN161_n431
+ B1=bank_mem_0[0][22] B2=FE_OFN160_n430 C1=bank_mem_0[2][22] C2=FE_OFN159_n429
XU660 AN4B1S $PINS O=n299 I1=n298 I2=n297 I3=n296 B1=n295
XU661 INV1S $PINS O=bank_rdata[0][22] I=FE_PHN1646_n299
XU662 AOI22S $PINS O=n304 A1=bank_mem_0[14][23] A2=n411 B1=bank_mem_0[15][23]
+ B2=n410
XU663 AOI22S $PINS O=n303 A1=bank_mem_0[12][23] A2=FE_OFN132_n413
+ B1=bank_mem_0[13][23] B2=n412
XU664 AOI22S $PINS O=n301 A1=bank_mem_0[10][23] A2=FE_OFN134_n415
+ B1=bank_mem_0[11][23] B2=n414
XU665 AOI22S $PINS O=n300 A1=bank_mem_0[8][23] A2=FE_OFN136_n417
+ B1=bank_mem_0[9][23] B2=n416
XU666 AN2 $PINS O=n302 I1=n301 I2=n300
XU667 ND3 $PINS O=n305 I1=n304 I2=n303 I3=n302
XU668 AOI22S $PINS O=n309 A1=bank_mem_0[7][23] A2=n424 B1=n305 B2=FE_OFN126_N30
XU669 AOI22S $PINS O=n308 A1=bank_mem_0[5][23] A2=n426 B1=bank_mem_0[6][23]
+ B2=n425
XU670 AOI22S $PINS O=n307 A1=bank_mem_0[3][23] A2=FE_OFN158_n428
+ B1=bank_mem_0[4][23] B2=FE_OFN157_n427
XU671 AO222 $PINS O=n306 A1=bank_mem_0[1][23] A2=FE_OFN161_n431
+ B1=bank_mem_0[0][23] B2=FE_OFN160_n430 C1=bank_mem_0[2][23] C2=FE_OFN159_n429
XU672 AN4B1S $PINS O=n310 I1=n309 I2=n308 I3=n307 B1=n306
XU673 INV1S $PINS O=bank_rdata[0][23] I=FE_PHN1620_n310
XU674 AOI22S $PINS O=n315 A1=bank_mem_0[14][24] A2=n411 B1=bank_mem_0[15][24]
+ B2=n410
XU675 AOI22S $PINS O=n314 A1=bank_mem_0[12][24] A2=FE_OFN132_n413
+ B1=bank_mem_0[13][24] B2=n412
XU676 AOI22S $PINS O=n312 A1=bank_mem_0[10][24] A2=FE_OFN134_n415
+ B1=bank_mem_0[11][24] B2=n414
XU677 AOI22S $PINS O=n311 A1=bank_mem_0[8][24] A2=FE_OFN136_n417
+ B1=bank_mem_0[9][24] B2=n416
XU678 AN2 $PINS O=n313 I1=n312 I2=n311
XU679 ND3 $PINS O=n316 I1=n315 I2=n314 I3=n313
XU680 AOI22S $PINS O=n320 A1=bank_mem_0[7][24] A2=n424 B1=n316 B2=FE_OFN126_N30
XU681 AOI22S $PINS O=n319 A1=bank_mem_0[5][24] A2=n426 B1=bank_mem_0[6][24]
+ B2=n425
XU682 AOI22S $PINS O=n318 A1=bank_mem_0[3][24] A2=FE_OFN158_n428
+ B1=bank_mem_0[4][24] B2=FE_OFN157_n427
XU683 AO222 $PINS O=n317 A1=bank_mem_0[1][24] A2=FE_OFN161_n431
+ B1=bank_mem_0[0][24] B2=FE_OFN160_n430 C1=bank_mem_0[2][24] C2=FE_OFN159_n429
XU684 AN4B1S $PINS O=n321 I1=n320 I2=n319 I3=n318 B1=n317
XU685 INV1S $PINS O=bank_rdata[0][24] I=FE_PHN1735_n321
XU686 AOI22S $PINS O=n326 A1=bank_mem_0[14][25] A2=n411 B1=bank_mem_0[15][25]
+ B2=n410
XU687 AOI22S $PINS O=n325 A1=bank_mem_0[12][25] A2=FE_OFN132_n413
+ B1=bank_mem_0[13][25] B2=n412
XU688 AOI22S $PINS O=n323 A1=bank_mem_0[10][25] A2=FE_OFN134_n415
+ B1=bank_mem_0[11][25] B2=n414
XU689 AOI22S $PINS O=n322 A1=bank_mem_0[8][25] A2=FE_OFN136_n417
+ B1=bank_mem_0[9][25] B2=n416
XU690 AN2 $PINS O=n324 I1=n323 I2=n322
XU691 ND3 $PINS O=n327 I1=n326 I2=n325 I3=n324
XU692 AOI22S $PINS O=n331 A1=bank_mem_0[7][25] A2=n424 B1=n327 B2=FE_OFN126_N30
XU693 AOI22S $PINS O=n330 A1=bank_mem_0[5][25] A2=n426 B1=bank_mem_0[6][25]
+ B2=n425
XU694 AOI22S $PINS O=n329 A1=bank_mem_0[3][25] A2=FE_OFN158_n428
+ B1=bank_mem_0[4][25] B2=FE_OFN157_n427
XU695 AO222 $PINS O=n328 A1=bank_mem_0[1][25] A2=FE_OFN161_n431
+ B1=bank_mem_0[0][25] B2=FE_OFN160_n430 C1=bank_mem_0[2][25] C2=FE_OFN159_n429
XU696 AN4B1S $PINS O=n332 I1=n331 I2=n330 I3=n329 B1=n328
XU697 INV1S $PINS O=bank_rdata[0][25] I=FE_PHN1642_n332
XU698 AOI22S $PINS O=n337 A1=bank_mem_0[14][26] A2=n411 B1=bank_mem_0[15][26]
+ B2=n410
XU699 AOI22S $PINS O=n336 A1=bank_mem_0[12][26] A2=FE_OFN132_n413
+ B1=bank_mem_0[13][26] B2=n412
XU700 AOI22S $PINS O=n334 A1=bank_mem_0[10][26] A2=FE_OFN134_n415
+ B1=bank_mem_0[11][26] B2=n414
XU701 AOI22S $PINS O=n333 A1=bank_mem_0[8][26] A2=FE_OFN136_n417
+ B1=bank_mem_0[9][26] B2=n416
XU702 AN2 $PINS O=n335 I1=n334 I2=n333
XU703 ND3 $PINS O=n338 I1=n337 I2=n336 I3=n335
XU704 AOI22S $PINS O=n342 A1=bank_mem_0[7][26] A2=n424 B1=n338 B2=FE_OFN126_N30
XU705 AOI22S $PINS O=n341 A1=bank_mem_0[5][26] A2=n426 B1=bank_mem_0[6][26]
+ B2=n425
XU706 AOI22S $PINS O=n340 A1=bank_mem_0[3][26] A2=FE_OFN158_n428
+ B1=bank_mem_0[4][26] B2=FE_OFN157_n427
XU707 AO222 $PINS O=n339 A1=bank_mem_0[1][26] A2=FE_OFN161_n431
+ B1=bank_mem_0[0][26] B2=FE_OFN160_n430 C1=bank_mem_0[2][26] C2=FE_OFN159_n429
XU708 AN4B1S $PINS O=FE_PHN1611_n343 I1=n342 I2=n341 I3=n340 B1=n339
XU709 AOI22S $PINS O=n348 A1=bank_mem_0[14][27] A2=n411 B1=bank_mem_0[15][27]
+ B2=n410
XU710 AOI22S $PINS O=n347 A1=bank_mem_0[12][27] A2=FE_OFN132_n413
+ B1=bank_mem_0[13][27] B2=n412
XU711 AOI22S $PINS O=n345 A1=bank_mem_0[10][27] A2=FE_OFN134_n415
+ B1=bank_mem_0[11][27] B2=n414
XU712 AOI22S $PINS O=n344 A1=bank_mem_0[8][27] A2=FE_OFN136_n417
+ B1=bank_mem_0[9][27] B2=n416
XU713 AN2 $PINS O=n346 I1=n345 I2=n344
XU714 ND3 $PINS O=n349 I1=n348 I2=n347 I3=n346
XU715 AOI22S $PINS O=n353 A1=bank_mem_0[7][27] A2=n424 B1=n349 B2=FE_OFN126_N30
XU716 AOI22S $PINS O=n352 A1=bank_mem_0[5][27] A2=n426 B1=bank_mem_0[6][27]
+ B2=n425
XU717 AOI22S $PINS O=n351 A1=bank_mem_0[3][27] A2=FE_OFN158_n428
+ B1=bank_mem_0[4][27] B2=FE_OFN157_n427
XU718 AO222 $PINS O=n350 A1=bank_mem_0[1][27] A2=FE_OFN161_n431
+ B1=bank_mem_0[0][27] B2=FE_OFN160_n430 C1=bank_mem_0[2][27] C2=FE_OFN159_n429
XU719 AN4B1S $PINS O=n354 I1=n353 I2=n352 I3=n351 B1=n350
XU720 INV1S $PINS O=bank_rdata[0][27] I=n354
XU721 AOI22S $PINS O=n359 A1=bank_mem_0[14][28] A2=n411 B1=bank_mem_0[15][28]
+ B2=n410
XU722 AOI22S $PINS O=n358 A1=bank_mem_0[12][28] A2=FE_OFN132_n413
+ B1=bank_mem_0[13][28] B2=n412
XU723 AOI22S $PINS O=n356 A1=bank_mem_0[10][28] A2=FE_OFN134_n415
+ B1=bank_mem_0[11][28] B2=n414
XU724 AOI22S $PINS O=n355 A1=bank_mem_0[8][28] A2=FE_OFN136_n417
+ B1=bank_mem_0[9][28] B2=n416
XU725 AN2 $PINS O=n357 I1=n356 I2=n355
XU726 ND3 $PINS O=n360 I1=n359 I2=n358 I3=n357
XU727 AOI22S $PINS O=n364 A1=bank_mem_0[7][28] A2=n424 B1=n360 B2=FE_OFN126_N30
XU728 AOI22S $PINS O=n363 A1=bank_mem_0[5][28] A2=n426 B1=bank_mem_0[6][28]
+ B2=n425
XU729 AOI22S $PINS O=n362 A1=bank_mem_0[3][28] A2=FE_OFN158_n428
+ B1=bank_mem_0[4][28] B2=FE_OFN157_n427
XU730 AO222 $PINS O=n361 A1=bank_mem_0[1][28] A2=FE_OFN161_n431
+ B1=bank_mem_0[0][28] B2=FE_OFN160_n430 C1=bank_mem_0[2][28] C2=FE_OFN159_n429
XU731 AN4B1S $PINS O=n365 I1=n364 I2=n363 I3=n362 B1=n361
XU732 INV1S $PINS O=bank_rdata[0][28] I=n365
XU733 AOI22S $PINS O=n370 A1=bank_mem_0[14][29] A2=n411 B1=bank_mem_0[15][29]
+ B2=n410
XU734 AOI22S $PINS O=n369 A1=bank_mem_0[12][29] A2=FE_OFN132_n413
+ B1=bank_mem_0[13][29] B2=n412
XU735 AOI22S $PINS O=n367 A1=bank_mem_0[10][29] A2=FE_OFN134_n415
+ B1=bank_mem_0[11][29] B2=n414
XU736 AOI22S $PINS O=n366 A1=bank_mem_0[8][29] A2=FE_OFN136_n417
+ B1=bank_mem_0[9][29] B2=n416
XU737 AN2 $PINS O=n368 I1=n367 I2=n366
XU738 ND3 $PINS O=n371 I1=n370 I2=n369 I3=n368
XU739 AOI22S $PINS O=n375 A1=bank_mem_0[7][29] A2=n424 B1=n371 B2=FE_OFN126_N30
XU740 AOI22S $PINS O=n374 A1=bank_mem_0[5][29] A2=n426 B1=bank_mem_0[6][29]
+ B2=n425
XU741 AOI22S $PINS O=n373 A1=bank_mem_0[3][29] A2=FE_OFN158_n428
+ B1=bank_mem_0[4][29] B2=FE_OFN157_n427
XU742 AO222 $PINS O=n372 A1=bank_mem_0[1][29] A2=FE_OFN161_n431
+ B1=bank_mem_0[0][29] B2=FE_OFN160_n430 C1=bank_mem_0[2][29] C2=FE_OFN159_n429
XU743 AN4B1S $PINS O=n376 I1=n375 I2=n374 I3=n373 B1=n372
XU744 INV1S $PINS O=bank_rdata[0][29] I=n376
XU745 AOI22S $PINS O=n381 A1=bank_mem_0[14][30] A2=n411 B1=bank_mem_0[15][30]
+ B2=n410
XU746 AOI22S $PINS O=n380 A1=bank_mem_0[12][30] A2=FE_OFN132_n413
+ B1=bank_mem_0[13][30] B2=n412
XU747 AOI22S $PINS O=n378 A1=bank_mem_0[10][30] A2=FE_OFN134_n415
+ B1=bank_mem_0[11][30] B2=n414
XU748 AOI22S $PINS O=n377 A1=bank_mem_0[8][30] A2=FE_OFN136_n417
+ B1=bank_mem_0[9][30] B2=n416
XU749 AN2 $PINS O=n379 I1=n378 I2=n377
XU750 ND3 $PINS O=n382 I1=n381 I2=n380 I3=n379
XU751 AOI22S $PINS O=n386 A1=bank_mem_0[7][30] A2=n424 B1=n382 B2=FE_OFN126_N30
XU752 AOI22S $PINS O=n385 A1=bank_mem_0[5][30] A2=n426 B1=bank_mem_0[6][30]
+ B2=n425
XU753 AOI22S $PINS O=n384 A1=bank_mem_0[3][30] A2=FE_OFN158_n428
+ B1=bank_mem_0[4][30] B2=FE_OFN157_n427
XU754 AO222 $PINS O=n383 A1=bank_mem_0[1][30] A2=FE_OFN161_n431
+ B1=bank_mem_0[0][30] B2=FE_OFN160_n430 C1=bank_mem_0[2][30] C2=FE_OFN159_n429
XU755 AN4B1S $PINS O=n387 I1=n386 I2=n385 I3=n384 B1=n383
XU756 INV1S $PINS O=bank_rdata[0][30] I=n387
XU757 AOI22S $PINS O=n392 A1=bank_mem_0[14][31] A2=n411 B1=bank_mem_0[15][31]
+ B2=n410
XU758 AOI22S $PINS O=n391 A1=bank_mem_0[12][31] A2=FE_OFN132_n413
+ B1=bank_mem_0[13][31] B2=n412
XU759 AOI22S $PINS O=n389 A1=bank_mem_0[10][31] A2=FE_OFN134_n415
+ B1=bank_mem_0[11][31] B2=n414
XU760 AOI22S $PINS O=n388 A1=bank_mem_0[8][31] A2=FE_OFN136_n417
+ B1=bank_mem_0[9][31] B2=n416
XU761 AN2 $PINS O=n390 I1=n389 I2=n388
XU762 ND3 $PINS O=n393 I1=n392 I2=n391 I3=n390
XU763 AOI22S $PINS O=n397 A1=bank_mem_0[7][31] A2=n424 B1=n393 B2=FE_OFN126_N30
XU764 AOI22S $PINS O=n396 A1=bank_mem_0[5][31] A2=n426 B1=bank_mem_0[6][31]
+ B2=n425
XU765 AOI22S $PINS O=n395 A1=bank_mem_0[3][31] A2=FE_OFN158_n428
+ B1=bank_mem_0[4][31] B2=FE_OFN157_n427
XU766 AO222 $PINS O=n394 A1=bank_mem_0[1][31] A2=FE_OFN161_n431
+ B1=bank_mem_0[0][31] B2=FE_OFN160_n430 C1=bank_mem_0[2][31] C2=FE_OFN159_n429
XU767 AN4B1S $PINS O=n398 I1=n397 I2=n396 I3=n395 B1=n394
XU768 INV1S $PINS O=bank_rdata[0][31] I=n398
XU769 AOI22S $PINS O=n403 A1=bank_mem_0[14][32] A2=n411 B1=bank_mem_0[15][32]
+ B2=n410
XU770 AOI22S $PINS O=n402 A1=bank_mem_0[12][32] A2=FE_OFN132_n413
+ B1=bank_mem_0[13][32] B2=n412
XU771 AOI22S $PINS O=n400 A1=bank_mem_0[10][32] A2=FE_OFN134_n415
+ B1=bank_mem_0[11][32] B2=n414
XU772 AOI22S $PINS O=n399 A1=bank_mem_0[8][32] A2=FE_OFN136_n417
+ B1=bank_mem_0[9][32] B2=n416
XU773 AN2 $PINS O=n401 I1=n400 I2=n399
XU774 ND3 $PINS O=n404 I1=n403 I2=n402 I3=n401
XU775 AOI22S $PINS O=n408 A1=bank_mem_0[7][32] A2=n424 B1=n404 B2=FE_OFN126_N30
XU776 AOI22S $PINS O=n407 A1=bank_mem_0[5][32] A2=n426 B1=bank_mem_0[6][32]
+ B2=n425
XU777 AOI22S $PINS O=n406 A1=bank_mem_0[3][32] A2=FE_OFN158_n428
+ B1=bank_mem_0[4][32] B2=FE_OFN157_n427
XU778 AO222 $PINS O=n405 A1=bank_mem_0[1][32] A2=FE_OFN161_n431
+ B1=bank_mem_0[0][32] B2=FE_OFN160_n430 C1=bank_mem_0[2][32] C2=FE_OFN159_n429
XU779 AN4B1S $PINS O=n409 I1=n408 I2=n407 I3=n406 B1=n405
XU780 INV1S $PINS O=bank_rdata[0][32] I=n409
XU781 AOI22S $PINS O=n422 A1=bank_mem_0[14][33] A2=n411 B1=bank_mem_0[15][33]
+ B2=n410
XU782 AOI22S $PINS O=n421 A1=bank_mem_0[12][33] A2=FE_OFN132_n413
+ B1=bank_mem_0[13][33] B2=n412
XU783 AOI22S $PINS O=n419 A1=bank_mem_0[10][33] A2=FE_OFN134_n415
+ B1=bank_mem_0[11][33] B2=n414
XU784 AOI22S $PINS O=n418 A1=bank_mem_0[8][33] A2=FE_OFN136_n417
+ B1=bank_mem_0[9][33] B2=n416
XU785 AN2 $PINS O=n420 I1=n419 I2=n418
XU786 ND3 $PINS O=n423 I1=n422 I2=n421 I3=n420
XU787 AOI22S $PINS O=n435 A1=bank_mem_0[7][33] A2=n424 B1=FE_OFN126_N30 B2=n423
XU788 AOI22S $PINS O=n434 A1=bank_mem_0[5][33] A2=n426 B1=bank_mem_0[6][33]
+ B2=n425
XU789 AOI22S $PINS O=n433 A1=bank_mem_0[3][33] A2=FE_OFN158_n428
+ B1=bank_mem_0[4][33] B2=FE_OFN157_n427
XU790 AO222 $PINS O=n432 A1=bank_mem_0[1][33] A2=FE_OFN161_n431
+ B1=bank_mem_0[0][33] B2=FE_OFN160_n430 C1=bank_mem_0[2][33] C2=FE_OFN159_n429
XU791 AN4B1S $PINS O=n436 I1=n435 I2=n434 I3=n433 B1=n432
XU792 INV1S $PINS O=bank_rdata[0][33] I=n436
XU793 NR2 $PINS O=n464 I1=n855 I2=FE_OFN127_N34
XU794 NR2 $PINS O=n463 I1=n854 I2=n853
XU795 AN2 $PINS O=n840 I1=n464 I2=n463
XU796 NR2 $PINS O=n467 I1=n854 I2=N31
XU797 AN2 $PINS O=n827 I1=n467 I2=N33
XU798 AN2 $PINS O=n826 I1=N33 I2=n463
XU799 AOI22S $PINS O=n461 A1=bank_mem_1[14][0] A2=FE_OFN138_n827
+ B1=bank_mem_1[15][0] B2=FE_OFN137_n826
XU800 NR2 $PINS O=n466 I1=N31 I2=N32
XU801 AN2 $PINS O=n829 I1=n466 I2=N33
XU802 NR2 $PINS O=n465 I1=n853 I2=N32
XU803 AN2 $PINS O=n828 I1=n465 I2=N33
XU804 AOI22S $PINS O=n460 A1=bank_mem_1[12][0] A2=FE_OFN140_n829
+ B1=bank_mem_1[13][0] B2=FE_OFN139_n828
XU805 AN2 $PINS O=n831 I1=n467 I2=n855
XU806 AN2 $PINS O=n830 I1=n463 I2=n855
XU807 AOI22S $PINS O=n458 A1=bank_mem_1[10][0] A2=FE_OFN142_n831
+ B1=bank_mem_1[11][0] B2=FE_OFN141_n830
XU808 AN2 $PINS O=n833 I1=n466 I2=n855
XU809 AN2 $PINS O=n832 I1=n465 I2=n855
XU810 AOI22S $PINS O=n457 A1=bank_mem_1[8][0] A2=n833 B1=bank_mem_1[9][0]
+ B2=FE_OFN143_n832
XU811 AN2 $PINS O=n459 I1=n458 I2=n457
XU812 ND3 $PINS O=n462 I1=n461 I2=n460 I3=n459
XU813 AOI22S $PINS O=n472 A1=bank_mem_1[7][0] A2=n840 B1=n462 B2=N34
XU814 AN2 $PINS O=n842 I1=n464 I2=n465
XU815 AN2 $PINS O=n841 I1=n464 I2=n467
XU816 AOI22S $PINS O=n471 A1=bank_mem_1[5][0] A2=FE_OFN164_n842
+ B1=bank_mem_1[6][0] B2=FE_OFN163_n841
XU817 NR2 $PINS O=n468 I1=N33 I2=FE_OFN127_N34
XU818 AN2 $PINS O=n844 I1=n468 I2=n463
XU819 AN2 $PINS O=n843 I1=n464 I2=n466
XU820 AOI22S $PINS O=n470 A1=bank_mem_1[3][0] A2=FE_OFN166_n844
+ B1=bank_mem_1[4][0] B2=FE_OFN165_n843
XU821 AN2 $PINS O=n847 I1=n468 I2=n465
XU822 AN2 $PINS O=n846 I1=n468 I2=n466
XU823 AN2 $PINS O=n845 I1=n468 I2=n467
XU824 AO222 $PINS O=n469 A1=bank_mem_1[1][0] A2=FE_OFN169_n847
+ B1=bank_mem_1[0][0] B2=FE_OFN168_n846 C1=bank_mem_1[2][0] C2=FE_OFN167_n845
XU825 AN4B1S $PINS O=n473 I1=n472 I2=n471 I3=n470 B1=n469
XU826 AOI22S $PINS O=n478 A1=bank_mem_1[14][1] A2=n827 B1=bank_mem_1[15][1]
+ B2=n826
XU827 AOI22S $PINS O=n477 A1=bank_mem_1[12][1] A2=FE_OFN140_n829
+ B1=bank_mem_1[13][1] B2=FE_OFN139_n828
XU828 AOI22S $PINS O=n475 A1=bank_mem_1[10][1] A2=n831 B1=bank_mem_1[11][1]
+ B2=n830
XU829 AOI22S $PINS O=n474 A1=bank_mem_1[8][1] A2=n833 B1=bank_mem_1[9][1]
+ B2=FE_OFN143_n832
XU830 AN2 $PINS O=n476 I1=n475 I2=n474
XU831 ND3 $PINS O=n479 I1=n478 I2=n477 I3=n476
XU832 AOI22S $PINS O=n483 A1=bank_mem_1[7][1] A2=n840 B1=n479 B2=N34
XU833 AOI22S $PINS O=n482 A1=bank_mem_1[5][1] A2=FE_OFN164_n842
+ B1=bank_mem_1[6][1] B2=FE_OFN163_n841
XU834 AOI22S $PINS O=n481 A1=bank_mem_1[3][1] A2=FE_OFN166_n844
+ B1=bank_mem_1[4][1] B2=FE_OFN165_n843
XU835 AO222 $PINS O=n480 A1=bank_mem_1[1][1] A2=FE_OFN169_n847
+ B1=bank_mem_1[0][1] B2=FE_OFN168_n846 C1=bank_mem_1[2][1] C2=FE_OFN167_n845
XU836 AN4B1S $PINS O=n484 I1=n483 I2=n482 I3=n481 B1=n480
XU837 AOI22S $PINS O=n489 A1=bank_mem_1[14][2] A2=FE_OFN138_n827
+ B1=bank_mem_1[15][2] B2=FE_OFN137_n826
XU838 AOI22S $PINS O=n488 A1=bank_mem_1[12][2] A2=FE_OFN140_n829
+ B1=bank_mem_1[13][2] B2=FE_OFN139_n828
XU839 AOI22S $PINS O=n486 A1=bank_mem_1[10][2] A2=FE_OFN142_n831
+ B1=bank_mem_1[11][2] B2=FE_OFN141_n830
XU840 AOI22S $PINS O=n485 A1=bank_mem_1[8][2] A2=n833 B1=bank_mem_1[9][2]
+ B2=FE_OFN143_n832
XU841 AN2 $PINS O=n487 I1=n486 I2=n485
XU842 ND3 $PINS O=n490 I1=n489 I2=n488 I3=n487
XU843 AOI22S $PINS O=n494 A1=bank_mem_1[7][2] A2=n840 B1=n490 B2=N34
XU844 AOI22S $PINS O=n493 A1=bank_mem_1[5][2] A2=FE_OFN164_n842
+ B1=bank_mem_1[6][2] B2=FE_OFN163_n841
XU845 AOI22S $PINS O=n492 A1=bank_mem_1[3][2] A2=FE_OFN166_n844
+ B1=bank_mem_1[4][2] B2=FE_OFN165_n843
XU846 AO222 $PINS O=n491 A1=bank_mem_1[1][2] A2=FE_OFN169_n847
+ B1=bank_mem_1[0][2] B2=FE_OFN168_n846 C1=bank_mem_1[2][2] C2=FE_OFN167_n845
XU847 AN4B1S $PINS O=n495 I1=n494 I2=n493 I3=n492 B1=n491
XU848 INV1S $PINS O=bank_rdata[1][2] I=n495
XU849 AOI22S $PINS O=n500 A1=bank_mem_1[14][3] A2=FE_OFN138_n827
+ B1=bank_mem_1[15][3] B2=FE_OFN137_n826
XU850 AOI22S $PINS O=n499 A1=bank_mem_1[12][3] A2=FE_OFN140_n829
+ B1=bank_mem_1[13][3] B2=FE_OFN139_n828
XU851 AOI22S $PINS O=n497 A1=bank_mem_1[10][3] A2=FE_OFN142_n831
+ B1=bank_mem_1[11][3] B2=n830
XU852 AOI22S $PINS O=n496 A1=bank_mem_1[8][3] A2=n833 B1=bank_mem_1[9][3]
+ B2=FE_OFN143_n832
XU853 AN2 $PINS O=n498 I1=n497 I2=n496
XU854 ND3 $PINS O=n501 I1=n500 I2=n499 I3=n498
XU855 AOI22S $PINS O=n505 A1=bank_mem_1[7][3] A2=n840 B1=n501 B2=N34
XU856 AOI22S $PINS O=n504 A1=bank_mem_1[5][3] A2=FE_OFN164_n842
+ B1=bank_mem_1[6][3] B2=FE_OFN163_n841
XU857 AOI22S $PINS O=n503 A1=bank_mem_1[3][3] A2=FE_OFN166_n844
+ B1=bank_mem_1[4][3] B2=FE_OFN165_n843
XU858 AO222 $PINS O=n502 A1=bank_mem_1[1][3] A2=FE_OFN169_n847
+ B1=bank_mem_1[0][3] B2=FE_OFN168_n846 C1=bank_mem_1[2][3] C2=FE_OFN167_n845
XU859 AN4B1S $PINS O=n506 I1=n505 I2=n504 I3=n503 B1=n502
XU860 AOI22S $PINS O=n511 A1=bank_mem_1[14][4] A2=FE_OFN138_n827
+ B1=bank_mem_1[15][4] B2=FE_OFN137_n826
XU861 AOI22S $PINS O=n510 A1=bank_mem_1[12][4] A2=FE_OFN140_n829
+ B1=bank_mem_1[13][4] B2=FE_OFN139_n828
XU862 AOI22S $PINS O=n508 A1=bank_mem_1[10][4] A2=FE_OFN142_n831
+ B1=bank_mem_1[11][4] B2=FE_OFN141_n830
XU863 AOI22S $PINS O=n507 A1=bank_mem_1[8][4] A2=n833 B1=bank_mem_1[9][4]
+ B2=FE_OFN143_n832
XU864 AN2 $PINS O=n509 I1=n508 I2=n507
XU865 ND3 $PINS O=n512 I1=n511 I2=n510 I3=n509
XU866 AOI22S $PINS O=n516 A1=bank_mem_1[7][4] A2=n840 B1=n512 B2=N34
XU867 AOI22S $PINS O=n515 A1=bank_mem_1[5][4] A2=FE_OFN164_n842
+ B1=bank_mem_1[6][4] B2=FE_OFN163_n841
XU868 AOI22S $PINS O=n514 A1=bank_mem_1[3][4] A2=FE_OFN166_n844
+ B1=bank_mem_1[4][4] B2=FE_OFN165_n843
XU869 AO222 $PINS O=n513 A1=bank_mem_1[1][4] A2=FE_OFN169_n847
+ B1=bank_mem_1[0][4] B2=FE_OFN168_n846 C1=bank_mem_1[2][4] C2=FE_OFN167_n845
XU870 AN4B1S $PINS O=n517 I1=n516 I2=n515 I3=n514 B1=n513
XU871 AOI22S $PINS O=n522 A1=bank_mem_1[14][5] A2=FE_OFN138_n827
+ B1=bank_mem_1[15][5] B2=FE_OFN137_n826
XU872 AOI22S $PINS O=n521 A1=bank_mem_1[12][5] A2=FE_OFN140_n829
+ B1=bank_mem_1[13][5] B2=FE_OFN139_n828
XU873 AOI22S $PINS O=n519 A1=bank_mem_1[10][5] A2=FE_OFN142_n831
+ B1=bank_mem_1[11][5] B2=n830
XU874 AOI22S $PINS O=n518 A1=bank_mem_1[8][5] A2=n833 B1=bank_mem_1[9][5]
+ B2=FE_OFN143_n832
XU875 AN2 $PINS O=n520 I1=n519 I2=n518
XU876 ND3 $PINS O=n523 I1=n522 I2=n521 I3=n520
XU877 AOI22S $PINS O=n527 A1=bank_mem_1[7][5] A2=n840 B1=n523 B2=N34
XU878 AOI22S $PINS O=n526 A1=bank_mem_1[5][5] A2=FE_OFN164_n842
+ B1=bank_mem_1[6][5] B2=FE_OFN163_n841
XU879 AOI22S $PINS O=n525 A1=bank_mem_1[3][5] A2=FE_OFN166_n844
+ B1=bank_mem_1[4][5] B2=FE_OFN165_n843
XU880 AO222 $PINS O=n524 A1=bank_mem_1[1][5] A2=FE_OFN169_n847
+ B1=bank_mem_1[0][5] B2=FE_OFN168_n846 C1=bank_mem_1[2][5] C2=FE_OFN167_n845
XU881 AN4B1S $PINS O=n528 I1=n527 I2=n526 I3=n525 B1=n524
XU882 AOI22S $PINS O=n533 A1=bank_mem_1[14][6] A2=FE_OFN138_n827
+ B1=bank_mem_1[15][6] B2=FE_OFN137_n826
XU883 AOI22S $PINS O=n532 A1=bank_mem_1[12][6] A2=FE_OFN140_n829
+ B1=bank_mem_1[13][6] B2=FE_OFN139_n828
XU884 AOI22S $PINS O=n530 A1=bank_mem_1[10][6] A2=FE_OFN142_n831
+ B1=bank_mem_1[11][6] B2=n830
XU885 AOI22S $PINS O=n529 A1=bank_mem_1[8][6] A2=n833 B1=bank_mem_1[9][6]
+ B2=FE_OFN143_n832
XU886 AN2 $PINS O=n531 I1=n530 I2=n529
XU887 ND3 $PINS O=n534 I1=n533 I2=n532 I3=n531
XU888 AOI22S $PINS O=n538 A1=bank_mem_1[7][6] A2=n840 B1=n534 B2=N34
XU889 AOI22S $PINS O=n537 A1=bank_mem_1[5][6] A2=FE_OFN164_n842
+ B1=bank_mem_1[6][6] B2=FE_OFN163_n841
XU890 AOI22S $PINS O=n536 A1=bank_mem_1[3][6] A2=FE_OFN166_n844
+ B1=bank_mem_1[4][6] B2=FE_OFN165_n843
XU891 AO222 $PINS O=n535 A1=bank_mem_1[1][6] A2=FE_OFN169_n847
+ B1=bank_mem_1[0][6] B2=FE_OFN168_n846 C1=bank_mem_1[2][6] C2=FE_OFN167_n845
XU892 AN4B1S $PINS O=n539 I1=n538 I2=n537 I3=n536 B1=n535
XU893 AOI22S $PINS O=n544 A1=bank_mem_1[14][7] A2=FE_OFN138_n827
+ B1=bank_mem_1[15][7] B2=FE_OFN137_n826
XU894 AOI22S $PINS O=n543 A1=bank_mem_1[12][7] A2=FE_OFN140_n829
+ B1=bank_mem_1[13][7] B2=FE_OFN139_n828
XU895 AOI22S $PINS O=n541 A1=bank_mem_1[10][7] A2=FE_OFN142_n831
+ B1=bank_mem_1[11][7] B2=FE_OFN141_n830
XU896 AOI22S $PINS O=n540 A1=bank_mem_1[8][7] A2=n833 B1=bank_mem_1[9][7]
+ B2=FE_OFN143_n832
XU897 AN2 $PINS O=n542 I1=n541 I2=n540
XU898 ND3 $PINS O=n545 I1=n544 I2=n543 I3=n542
XU899 AOI22S $PINS O=n549 A1=bank_mem_1[7][7] A2=n840 B1=n545 B2=N34
XU900 AOI22S $PINS O=n548 A1=bank_mem_1[5][7] A2=FE_OFN164_n842
+ B1=bank_mem_1[6][7] B2=FE_OFN163_n841
XU901 AOI22S $PINS O=n547 A1=bank_mem_1[3][7] A2=FE_OFN166_n844
+ B1=bank_mem_1[4][7] B2=FE_OFN165_n843
XU902 AO222 $PINS O=n546 A1=bank_mem_1[1][7] A2=FE_OFN169_n847
+ B1=bank_mem_1[0][7] B2=FE_OFN168_n846 C1=bank_mem_1[2][7] C2=FE_OFN167_n845
XU903 AN4B1S $PINS O=n550 I1=n549 I2=n548 I3=n547 B1=n546
XU904 AOI22S $PINS O=n555 A1=bank_mem_1[14][8] A2=FE_OFN138_n827
+ B1=bank_mem_1[15][8] B2=FE_OFN137_n826
XU905 AOI22S $PINS O=n554 A1=bank_mem_1[12][8] A2=FE_OFN140_n829
+ B1=bank_mem_1[13][8] B2=FE_OFN139_n828
XU906 AOI22S $PINS O=n552 A1=bank_mem_1[10][8] A2=FE_OFN142_n831
+ B1=bank_mem_1[11][8] B2=n830
XU907 AOI22S $PINS O=n551 A1=bank_mem_1[8][8] A2=n833 B1=bank_mem_1[9][8]
+ B2=FE_OFN143_n832
XU908 AN2 $PINS O=n553 I1=n552 I2=n551
XU909 ND3 $PINS O=n556 I1=n555 I2=n554 I3=n553
XU910 AOI22S $PINS O=n560 A1=bank_mem_1[7][8] A2=n840 B1=n556 B2=N34
XU911 AOI22S $PINS O=n559 A1=bank_mem_1[5][8] A2=FE_OFN164_n842
+ B1=bank_mem_1[6][8] B2=FE_OFN163_n841
XU912 AOI22S $PINS O=n558 A1=bank_mem_1[3][8] A2=FE_OFN166_n844
+ B1=bank_mem_1[4][8] B2=FE_OFN165_n843
XU913 AO222 $PINS O=n557 A1=bank_mem_1[1][8] A2=FE_OFN169_n847
+ B1=bank_mem_1[0][8] B2=FE_OFN168_n846 C1=bank_mem_1[2][8] C2=FE_OFN167_n845
XU914 AN4B1S $PINS O=n561 I1=n560 I2=n559 I3=n558 B1=n557
XU915 AOI22S $PINS O=n566 A1=bank_mem_1[14][9] A2=FE_OFN138_n827
+ B1=bank_mem_1[15][9] B2=FE_OFN137_n826
XU916 AOI22S $PINS O=n565 A1=bank_mem_1[12][9] A2=FE_OFN140_n829
+ B1=bank_mem_1[13][9] B2=FE_OFN139_n828
XU917 AOI22S $PINS O=n563 A1=bank_mem_1[10][9] A2=FE_OFN142_n831
+ B1=bank_mem_1[11][9] B2=FE_OFN141_n830
XU918 AOI22S $PINS O=n562 A1=bank_mem_1[8][9] A2=n833 B1=bank_mem_1[9][9]
+ B2=FE_OFN143_n832
XU919 AN2 $PINS O=n564 I1=n563 I2=n562
XU920 ND3 $PINS O=n567 I1=n566 I2=n565 I3=n564
XU921 AOI22S $PINS O=n571 A1=bank_mem_1[7][9] A2=n840 B1=n567 B2=N34
XU922 AOI22S $PINS O=n570 A1=bank_mem_1[5][9] A2=FE_OFN164_n842
+ B1=bank_mem_1[6][9] B2=FE_OFN163_n841
XU923 AOI22S $PINS O=n569 A1=bank_mem_1[3][9] A2=FE_OFN166_n844
+ B1=bank_mem_1[4][9] B2=FE_OFN165_n843
XU924 AO222 $PINS O=n568 A1=bank_mem_1[1][9] A2=FE_OFN169_n847
+ B1=bank_mem_1[0][9] B2=FE_OFN168_n846 C1=bank_mem_1[2][9] C2=FE_OFN167_n845
XU925 AN4B1S $PINS O=n572 I1=n571 I2=n570 I3=n569 B1=n568
XU926 INV1S $PINS O=bank_rdata[1][9] I=n572
XU927 AOI22S $PINS O=n577 A1=bank_mem_1[14][10] A2=FE_OFN138_n827
+ B1=bank_mem_1[15][10] B2=n826
XU928 AOI22S $PINS O=n576 A1=bank_mem_1[12][10] A2=FE_OFN140_n829
+ B1=bank_mem_1[13][10] B2=FE_OFN139_n828
XU929 AOI22S $PINS O=n574 A1=bank_mem_1[10][10] A2=FE_OFN142_n831
+ B1=bank_mem_1[11][10] B2=FE_OFN141_n830
XU930 AOI22S $PINS O=n573 A1=bank_mem_1[8][10] A2=n833 B1=bank_mem_1[9][10]
+ B2=FE_OFN143_n832
XU931 AN2 $PINS O=n575 I1=n574 I2=n573
XU932 ND3 $PINS O=n578 I1=n577 I2=n576 I3=n575
XU933 AOI22S $PINS O=n582 A1=bank_mem_1[7][10] A2=n840 B1=n578 B2=N34
XU934 AOI22S $PINS O=n581 A1=bank_mem_1[5][10] A2=FE_OFN164_n842
+ B1=bank_mem_1[6][10] B2=FE_OFN163_n841
XU935 AOI22S $PINS O=n580 A1=bank_mem_1[3][10] A2=FE_OFN166_n844
+ B1=bank_mem_1[4][10] B2=FE_OFN165_n843
XU936 AO222 $PINS O=n579 A1=bank_mem_1[1][10] A2=FE_OFN169_n847
+ B1=bank_mem_1[0][10] B2=FE_OFN168_n846 C1=bank_mem_1[2][10] C2=FE_OFN167_n845
XU937 AN4B1S $PINS O=n583 I1=n582 I2=n581 I3=n580 B1=n579
XU938 INV1S $PINS O=bank_rdata[1][10] I=n583
XU939 AOI22S $PINS O=n588 A1=bank_mem_1[14][11] A2=FE_OFN138_n827
+ B1=bank_mem_1[15][11] B2=FE_OFN137_n826
XU940 AOI22S $PINS O=n587 A1=bank_mem_1[12][11] A2=FE_OFN140_n829
+ B1=bank_mem_1[13][11] B2=FE_OFN139_n828
XU941 AOI22S $PINS O=n585 A1=bank_mem_1[10][11] A2=FE_OFN142_n831
+ B1=bank_mem_1[11][11] B2=FE_OFN141_n830
XU942 AOI22S $PINS O=n584 A1=bank_mem_1[8][11] A2=n833 B1=bank_mem_1[9][11]
+ B2=FE_OFN143_n832
XU943 AN2 $PINS O=n586 I1=n585 I2=n584
XU944 ND3 $PINS O=n589 I1=n588 I2=n587 I3=n586
XU945 AOI22S $PINS O=n593 A1=bank_mem_1[7][11] A2=n840 B1=n589 B2=N34
XU946 AOI22S $PINS O=n592 A1=bank_mem_1[5][11] A2=FE_OFN164_n842
+ B1=bank_mem_1[6][11] B2=FE_OFN163_n841
XU947 AOI22S $PINS O=n591 A1=bank_mem_1[3][11] A2=FE_OFN166_n844
+ B1=bank_mem_1[4][11] B2=FE_OFN165_n843
XU948 AO222 $PINS O=n590 A1=bank_mem_1[1][11] A2=FE_OFN169_n847
+ B1=bank_mem_1[0][11] B2=FE_OFN168_n846 C1=bank_mem_1[2][11] C2=FE_OFN167_n845
XU949 AN4B1S $PINS O=n594 I1=n593 I2=n592 I3=n591 B1=n590
XU950 INV1S $PINS O=bank_rdata[1][11] I=n594
XU951 AOI22S $PINS O=n599 A1=bank_mem_1[14][12] A2=n827 B1=bank_mem_1[15][12]
+ B2=n826
XU952 AOI22S $PINS O=n598 A1=bank_mem_1[12][12] A2=FE_OFN140_n829
+ B1=bank_mem_1[13][12] B2=FE_OFN139_n828
XU953 AOI22S $PINS O=n596 A1=bank_mem_1[10][12] A2=n831 B1=bank_mem_1[11][12]
+ B2=n830
XU954 AOI22S $PINS O=n595 A1=bank_mem_1[8][12] A2=n833 B1=bank_mem_1[9][12]
+ B2=n832
XU955 AN2 $PINS O=n597 I1=n596 I2=n595
XU956 ND3 $PINS O=n600 I1=n599 I2=n598 I3=n597
XU957 AOI22S $PINS O=n604 A1=bank_mem_1[7][12] A2=n840 B1=n600 B2=N34
XU958 AOI22S $PINS O=n603 A1=bank_mem_1[5][12] A2=FE_OFN164_n842
+ B1=bank_mem_1[6][12] B2=FE_OFN163_n841
XU959 AOI22S $PINS O=n602 A1=bank_mem_1[3][12] A2=FE_OFN166_n844
+ B1=bank_mem_1[4][12] B2=FE_OFN165_n843
XU960 AO222 $PINS O=n601 A1=bank_mem_1[1][12] A2=FE_OFN169_n847
+ B1=bank_mem_1[0][12] B2=FE_OFN168_n846 C1=bank_mem_1[2][12] C2=FE_OFN167_n845
XU961 AN4B1S $PINS O=n605 I1=n604 I2=n603 I3=n602 B1=n601
XU962 INV1S $PINS O=bank_rdata[1][12] I=n605
XU963 AOI22S $PINS O=n610 A1=bank_mem_1[14][13] A2=n827 B1=bank_mem_1[15][13]
+ B2=n826
XU964 AOI22S $PINS O=n609 A1=bank_mem_1[12][13] A2=FE_OFN140_n829
+ B1=bank_mem_1[13][13] B2=FE_OFN139_n828
XU965 AOI22S $PINS O=n607 A1=bank_mem_1[10][13] A2=n831 B1=bank_mem_1[11][13]
+ B2=n830
XU966 AOI22S $PINS O=n606 A1=bank_mem_1[8][13] A2=n833 B1=bank_mem_1[9][13]
+ B2=n832
XU967 AN2 $PINS O=n608 I1=n607 I2=n606
XU968 ND3 $PINS O=n611 I1=n610 I2=n609 I3=n608
XU969 AOI22S $PINS O=n615 A1=bank_mem_1[7][13] A2=n840 B1=n611 B2=N34
XU970 AOI22S $PINS O=n614 A1=bank_mem_1[5][13] A2=FE_OFN164_n842
+ B1=bank_mem_1[6][13] B2=FE_OFN163_n841
XU971 AOI22S $PINS O=n613 A1=bank_mem_1[3][13] A2=FE_OFN166_n844
+ B1=bank_mem_1[4][13] B2=FE_OFN165_n843
XU972 AO222 $PINS O=n612 A1=bank_mem_1[1][13] A2=FE_OFN169_n847
+ B1=bank_mem_1[0][13] B2=FE_OFN168_n846 C1=bank_mem_1[2][13] C2=FE_OFN167_n845
XU973 AN4B1S $PINS O=n616 I1=n615 I2=n614 I3=n613 B1=n612
XU974 INV1S $PINS O=bank_rdata[1][13] I=n616
XU975 AOI22S $PINS O=n621 A1=bank_mem_1[14][14] A2=n827 B1=bank_mem_1[15][14]
+ B2=n826
XU976 AOI22S $PINS O=n620 A1=bank_mem_1[12][14] A2=FE_OFN140_n829
+ B1=bank_mem_1[13][14] B2=FE_OFN139_n828
XU977 AOI22S $PINS O=n618 A1=bank_mem_1[10][14] A2=n831 B1=bank_mem_1[11][14]
+ B2=n830
XU978 AOI22S $PINS O=n617 A1=bank_mem_1[8][14] A2=n833 B1=bank_mem_1[9][14]
+ B2=n832
XU979 AN2 $PINS O=n619 I1=n618 I2=n617
XU980 ND3 $PINS O=n622 I1=n621 I2=n620 I3=n619
XU981 AOI22S $PINS O=n626 A1=bank_mem_1[7][14] A2=n840 B1=n622 B2=N34
XU982 AOI22S $PINS O=n625 A1=bank_mem_1[5][14] A2=FE_OFN164_n842
+ B1=bank_mem_1[6][14] B2=FE_OFN163_n841
XU983 AOI22S $PINS O=n624 A1=bank_mem_1[3][14] A2=FE_OFN166_n844
+ B1=bank_mem_1[4][14] B2=FE_OFN165_n843
XU984 AO222 $PINS O=n623 A1=bank_mem_1[1][14] A2=FE_OFN169_n847
+ B1=bank_mem_1[0][14] B2=FE_OFN168_n846 C1=bank_mem_1[2][14] C2=FE_OFN167_n845
XU985 AN4B1S $PINS O=n627 I1=n626 I2=n625 I3=n624 B1=n623
XU986 INV1S $PINS O=bank_rdata[1][14] I=n627
XU987 AOI22S $PINS O=n632 A1=bank_mem_1[14][15] A2=n827 B1=bank_mem_1[15][15]
+ B2=n826
XU988 AOI22S $PINS O=n631 A1=bank_mem_1[12][15] A2=FE_OFN140_n829
+ B1=bank_mem_1[13][15] B2=FE_OFN139_n828
XU989 AOI22S $PINS O=n629 A1=bank_mem_1[10][15] A2=n831 B1=bank_mem_1[11][15]
+ B2=n830
XU990 AOI22S $PINS O=n628 A1=bank_mem_1[8][15] A2=n833 B1=bank_mem_1[9][15]
+ B2=n832
XU991 AN2 $PINS O=n630 I1=n629 I2=n628
XU992 ND3 $PINS O=n633 I1=n632 I2=n631 I3=n630
XU993 AOI22S $PINS O=n637 A1=bank_mem_1[7][15] A2=n840 B1=n633 B2=N34
XU994 AOI22S $PINS O=n636 A1=bank_mem_1[5][15] A2=FE_OFN164_n842
+ B1=bank_mem_1[6][15] B2=FE_OFN163_n841
XU995 AOI22S $PINS O=n635 A1=bank_mem_1[3][15] A2=FE_OFN166_n844
+ B1=bank_mem_1[4][15] B2=FE_OFN165_n843
XU996 AO222 $PINS O=n634 A1=bank_mem_1[1][15] A2=FE_OFN169_n847
+ B1=bank_mem_1[0][15] B2=FE_OFN168_n846 C1=bank_mem_1[2][15] C2=FE_OFN167_n845
XU997 AN4B1S $PINS O=n638 I1=n637 I2=n636 I3=n635 B1=n634
XU998 INV1S $PINS O=bank_rdata[1][15] I=n638
XU999 AOI22S $PINS O=n643 A1=bank_mem_1[14][16] A2=n827 B1=bank_mem_1[15][16]
+ B2=n826
XU1000 AOI22S $PINS O=n642 A1=bank_mem_1[12][16] A2=FE_OFN140_n829
+ B1=bank_mem_1[13][16] B2=FE_OFN139_n828
XU1001 AOI22S $PINS O=n640 A1=bank_mem_1[10][16] A2=n831 B1=bank_mem_1[11][16]
+ B2=n830
XU1002 AOI22S $PINS O=n639 A1=bank_mem_1[8][16] A2=n833 B1=bank_mem_1[9][16]
+ B2=n832
XU1003 AN2 $PINS O=n641 I1=n640 I2=n639
XU1004 ND3 $PINS O=n644 I1=n643 I2=n642 I3=n641
XU1005 AOI22S $PINS O=n648 A1=bank_mem_1[7][16] A2=n840 B1=n644 B2=N34
XU1006 AOI22S $PINS O=n647 A1=bank_mem_1[5][16] A2=FE_OFN164_n842
+ B1=bank_mem_1[6][16] B2=FE_OFN163_n841
XU1007 AOI22S $PINS O=n646 A1=bank_mem_1[3][16] A2=FE_OFN166_n844
+ B1=bank_mem_1[4][16] B2=FE_OFN165_n843
XU1008 AO222 $PINS O=n645 A1=bank_mem_1[1][16] A2=FE_OFN169_n847
+ B1=bank_mem_1[0][16] B2=FE_OFN168_n846 C1=bank_mem_1[2][16] C2=FE_OFN167_n845
XU1009 AN4B1S $PINS O=n649 I1=n648 I2=n647 I3=n646 B1=n645
XU1010 INV1S $PINS O=bank_rdata[1][16] I=n649
XU1011 AOI22S $PINS O=n654 A1=bank_mem_1[14][17] A2=FE_OFN138_n827
+ B1=bank_mem_1[15][17] B2=FE_OFN137_n826
XU1012 AOI22S $PINS O=n653 A1=bank_mem_1[12][17] A2=n829 B1=bank_mem_1[13][17]
+ B2=n828
XU1013 AOI22S $PINS O=n651 A1=bank_mem_1[10][17] A2=FE_OFN142_n831
+ B1=bank_mem_1[11][17] B2=FE_OFN141_n830
XU1014 AOI22S $PINS O=n650 A1=bank_mem_1[8][17] A2=FE_OFN144_n833
+ B1=bank_mem_1[9][17] B2=FE_OFN143_n832
XU1015 AN2 $PINS O=n652 I1=n651 I2=n650
XU1016 ND3 $PINS O=n655 I1=n654 I2=n653 I3=n652
XU1017 AOI22S $PINS O=n659 A1=bank_mem_1[7][17] A2=FE_OFN162_n840 B1=n655
+ B2=FE_OFN127_N34
XU1018 AOI22S $PINS O=n658 A1=bank_mem_1[5][17] A2=n842 B1=bank_mem_1[6][17]
+ B2=n841
XU1019 AOI22S $PINS O=n657 A1=bank_mem_1[3][17] A2=n844 B1=bank_mem_1[4][17]
+ B2=n843
XU1020 AO222 $PINS O=n656 A1=bank_mem_1[1][17] A2=n847 B1=bank_mem_1[0][17]
+ B2=n846 C1=bank_mem_1[2][17] C2=n845
XU1021 AN4B1S $PINS O=n660 I1=n659 I2=n658 I3=n657 B1=n656
XU1022 AOI22S $PINS O=n665 A1=bank_mem_1[14][18] A2=FE_OFN138_n827
+ B1=bank_mem_1[15][18] B2=FE_OFN137_n826
XU1023 AOI22S $PINS O=n664 A1=bank_mem_1[12][18] A2=n829 B1=bank_mem_1[13][18]
+ B2=n828
XU1024 AOI22S $PINS O=n662 A1=bank_mem_1[10][18] A2=FE_OFN142_n831
+ B1=bank_mem_1[11][18] B2=FE_OFN141_n830
XU1025 AOI22S $PINS O=n661 A1=bank_mem_1[8][18] A2=FE_OFN144_n833
+ B1=bank_mem_1[9][18] B2=FE_OFN143_n832
XU1026 AN2 $PINS O=n663 I1=n662 I2=n661
XU1027 ND3 $PINS O=n666 I1=n665 I2=n664 I3=n663
XU1028 AOI22S $PINS O=n670 A1=bank_mem_1[7][18] A2=FE_OFN162_n840 B1=n666
+ B2=FE_OFN127_N34
XU1029 AOI22S $PINS O=n669 A1=bank_mem_1[5][18] A2=n842 B1=bank_mem_1[6][18]
+ B2=n841
XU1030 AOI22S $PINS O=n668 A1=bank_mem_1[3][18] A2=n844 B1=bank_mem_1[4][18]
+ B2=n843
XU1031 AO222 $PINS O=n667 A1=bank_mem_1[1][18] A2=n847 B1=bank_mem_1[0][18]
+ B2=n846 C1=bank_mem_1[2][18] C2=n845
XU1032 AN4B1S $PINS O=n671 I1=n670 I2=n669 I3=n668 B1=n667
XU1033 INV1S $PINS O=bank_rdata[1][18] I=n671
XU1034 AOI22S $PINS O=n676 A1=bank_mem_1[14][19] A2=FE_OFN138_n827
+ B1=bank_mem_1[15][19] B2=FE_OFN137_n826
XU1035 AOI22S $PINS O=n675 A1=bank_mem_1[12][19] A2=n829 B1=bank_mem_1[13][19]
+ B2=n828
XU1036 AOI22S $PINS O=n673 A1=bank_mem_1[10][19] A2=FE_OFN142_n831
+ B1=bank_mem_1[11][19] B2=FE_OFN141_n830
XU1037 AOI22S $PINS O=n672 A1=bank_mem_1[8][19] A2=FE_OFN144_n833
+ B1=bank_mem_1[9][19] B2=FE_OFN143_n832
XU1038 AN2 $PINS O=n674 I1=n673 I2=n672
XU1039 ND3 $PINS O=n677 I1=n676 I2=n675 I3=n674
XU1040 AOI22S $PINS O=n681 A1=bank_mem_1[7][19] A2=FE_OFN162_n840 B1=n677
+ B2=FE_OFN127_N34
XU1041 AOI22S $PINS O=n680 A1=bank_mem_1[5][19] A2=n842 B1=bank_mem_1[6][19]
+ B2=n841
XU1042 AOI22S $PINS O=n679 A1=bank_mem_1[3][19] A2=n844 B1=bank_mem_1[4][19]
+ B2=n843
XU1043 AO222 $PINS O=n678 A1=bank_mem_1[1][19] A2=n847 B1=bank_mem_1[0][19]
+ B2=n846 C1=bank_mem_1[2][19] C2=n845
XU1044 AN4B1S $PINS O=n682 I1=n681 I2=n680 I3=n679 B1=n678
XU1045 INV1S $PINS O=bank_rdata[1][19] I=n682
XU1046 AOI22S $PINS O=n687 A1=bank_mem_1[14][20] A2=FE_OFN138_n827
+ B1=bank_mem_1[15][20] B2=FE_OFN137_n826
XU1047 AOI22S $PINS O=n686 A1=bank_mem_1[12][20] A2=n829 B1=bank_mem_1[13][20]
+ B2=n828
XU1048 AOI22S $PINS O=n684 A1=bank_mem_1[10][20] A2=FE_OFN142_n831
+ B1=bank_mem_1[11][20] B2=FE_OFN141_n830
XU1049 AOI22S $PINS O=n683 A1=bank_mem_1[8][20] A2=FE_OFN144_n833
+ B1=bank_mem_1[9][20] B2=FE_OFN143_n832
XU1050 AN2 $PINS O=n685 I1=n684 I2=n683
XU1051 ND3 $PINS O=n688 I1=n687 I2=n686 I3=n685
XU1052 AOI22S $PINS O=n692 A1=bank_mem_1[7][20] A2=FE_OFN162_n840 B1=n688
+ B2=FE_OFN127_N34
XU1053 AOI22S $PINS O=n691 A1=bank_mem_1[5][20] A2=n842 B1=bank_mem_1[6][20]
+ B2=n841
XU1054 AOI22S $PINS O=n690 A1=bank_mem_1[3][20] A2=n844 B1=bank_mem_1[4][20]
+ B2=n843
XU1055 AO222 $PINS O=n689 A1=bank_mem_1[1][20] A2=n847 B1=bank_mem_1[0][20]
+ B2=n846 C1=bank_mem_1[2][20] C2=n845
XU1056 AN4B1S $PINS O=FE_PHN1692_n693 I1=n692 I2=n691 I3=n690 B1=n689
XU1057 INV1S $PINS O=bank_rdata[1][20] I=n693
XU1058 AOI22S $PINS O=n698 A1=bank_mem_1[14][21] A2=FE_OFN138_n827
+ B1=bank_mem_1[15][21] B2=FE_OFN137_n826
XU1059 AOI22S $PINS O=n697 A1=bank_mem_1[12][21] A2=n829 B1=bank_mem_1[13][21]
+ B2=n828
XU1060 AOI22S $PINS O=n695 A1=bank_mem_1[10][21] A2=FE_OFN142_n831
+ B1=bank_mem_1[11][21] B2=FE_OFN141_n830
XU1061 AOI22S $PINS O=n694 A1=bank_mem_1[8][21] A2=FE_OFN144_n833
+ B1=bank_mem_1[9][21] B2=FE_OFN143_n832
XU1062 AN2 $PINS O=n696 I1=n695 I2=n694
XU1063 ND3 $PINS O=n699 I1=n698 I2=n697 I3=n696
XU1064 AOI22S $PINS O=n703 A1=bank_mem_1[7][21] A2=FE_OFN162_n840 B1=n699
+ B2=FE_OFN127_N34
XU1065 AOI22S $PINS O=n702 A1=bank_mem_1[5][21] A2=n842 B1=bank_mem_1[6][21]
+ B2=n841
XU1066 AOI22S $PINS O=n701 A1=bank_mem_1[3][21] A2=n844 B1=bank_mem_1[4][21]
+ B2=n843
XU1067 AO222 $PINS O=n700 A1=bank_mem_1[1][21] A2=n847 B1=bank_mem_1[0][21]
+ B2=n846 C1=bank_mem_1[2][21] C2=n845
XU1068 AN4B1S $PINS O=FE_PHN1650_n704 I1=n703 I2=n702 I3=n701 B1=n700
XU1069 INV1S $PINS O=bank_rdata[1][21] I=n704
XU1070 AOI22S $PINS O=n709 A1=bank_mem_1[14][22] A2=FE_OFN138_n827
+ B1=bank_mem_1[15][22] B2=FE_OFN137_n826
XU1071 AOI22S $PINS O=n708 A1=bank_mem_1[12][22] A2=n829 B1=bank_mem_1[13][22]
+ B2=n828
XU1072 AOI22S $PINS O=n706 A1=bank_mem_1[10][22] A2=FE_OFN142_n831
+ B1=bank_mem_1[11][22] B2=FE_OFN141_n830
XU1073 AOI22S $PINS O=n705 A1=bank_mem_1[8][22] A2=FE_OFN144_n833
+ B1=bank_mem_1[9][22] B2=FE_OFN143_n832
XU1074 AN2 $PINS O=n707 I1=n706 I2=n705
XU1075 ND3 $PINS O=n710 I1=n709 I2=n708 I3=n707
XU1076 AOI22S $PINS O=n714 A1=bank_mem_1[7][22] A2=FE_OFN162_n840 B1=n710
+ B2=FE_OFN127_N34
XU1077 AOI22S $PINS O=n713 A1=bank_mem_1[5][22] A2=n842 B1=bank_mem_1[6][22]
+ B2=n841
XU1078 AOI22S $PINS O=n712 A1=bank_mem_1[3][22] A2=n844 B1=bank_mem_1[4][22]
+ B2=n843
XU1079 AO222 $PINS O=n711 A1=bank_mem_1[1][22] A2=n847 B1=bank_mem_1[0][22]
+ B2=n846 C1=bank_mem_1[2][22] C2=n845
XU1080 AN4B1S $PINS O=n715 I1=n714 I2=n713 I3=n712 B1=n711
XU1081 INV1S $PINS O=bank_rdata[1][22] I=FE_PHN1698_n715
XU1082 AOI22S $PINS O=n720 A1=bank_mem_1[14][23] A2=FE_OFN138_n827
+ B1=bank_mem_1[15][23] B2=FE_OFN137_n826
XU1083 AOI22S $PINS O=n719 A1=bank_mem_1[12][23] A2=n829 B1=bank_mem_1[13][23]
+ B2=n828
XU1084 AOI22S $PINS O=n717 A1=bank_mem_1[10][23] A2=FE_OFN142_n831
+ B1=bank_mem_1[11][23] B2=FE_OFN141_n830
XU1085 AOI22S $PINS O=n716 A1=bank_mem_1[8][23] A2=FE_OFN144_n833
+ B1=bank_mem_1[9][23] B2=FE_OFN143_n832
XU1086 AN2 $PINS O=n718 I1=n717 I2=n716
XU1087 ND3 $PINS O=n721 I1=n720 I2=n719 I3=n718
XU1088 AOI22S $PINS O=n725 A1=bank_mem_1[7][23] A2=FE_OFN162_n840 B1=n721
+ B2=FE_OFN127_N34
XU1089 AOI22S $PINS O=n724 A1=bank_mem_1[5][23] A2=n842 B1=bank_mem_1[6][23]
+ B2=n841
XU1090 AOI22S $PINS O=n723 A1=bank_mem_1[3][23] A2=n844 B1=bank_mem_1[4][23]
+ B2=n843
XU1091 AO222 $PINS O=n722 A1=bank_mem_1[1][23] A2=n847 B1=bank_mem_1[0][23]
+ B2=n846 C1=bank_mem_1[2][23] C2=n845
XU1092 AN4B1S $PINS O=FE_PHN1662_n726 I1=n725 I2=n724 I3=n723 B1=n722
XU1093 INV1S $PINS O=bank_rdata[1][23] I=n726
XU1094 AOI22S $PINS O=n731 A1=bank_mem_1[14][24] A2=FE_OFN138_n827
+ B1=bank_mem_1[15][24] B2=FE_OFN137_n826
XU1095 AOI22S $PINS O=n730 A1=bank_mem_1[12][24] A2=n829 B1=bank_mem_1[13][24]
+ B2=n828
XU1096 AOI22S $PINS O=n728 A1=bank_mem_1[10][24] A2=FE_OFN142_n831
+ B1=bank_mem_1[11][24] B2=FE_OFN141_n830
XU1097 AOI22S $PINS O=n727 A1=bank_mem_1[8][24] A2=FE_OFN144_n833
+ B1=bank_mem_1[9][24] B2=FE_OFN143_n832
XU1098 AN2 $PINS O=n729 I1=n728 I2=n727
XU1099 ND3 $PINS O=n732 I1=n731 I2=n730 I3=n729
XU1100 AOI22S $PINS O=n736 A1=bank_mem_1[7][24] A2=FE_OFN162_n840 B1=n732
+ B2=FE_OFN127_N34
XU1101 AOI22S $PINS O=n735 A1=bank_mem_1[5][24] A2=n842 B1=bank_mem_1[6][24]
+ B2=n841
XU1102 AOI22S $PINS O=n734 A1=bank_mem_1[3][24] A2=n844 B1=bank_mem_1[4][24]
+ B2=n843
XU1103 AO222 $PINS O=n733 A1=bank_mem_1[1][24] A2=n847 B1=bank_mem_1[0][24]
+ B2=n846 C1=bank_mem_1[2][24] C2=n845
XU1104 AN4B1S $PINS O=FE_PHN1696_n737 I1=n736 I2=n735 I3=n734 B1=n733
XU1105 INV1S $PINS O=bank_rdata[1][24] I=n737
XU1106 AOI22S $PINS O=n742 A1=bank_mem_1[14][25] A2=FE_OFN138_n827
+ B1=bank_mem_1[15][25] B2=FE_OFN137_n826
XU1107 AOI22S $PINS O=n741 A1=bank_mem_1[12][25] A2=n829 B1=bank_mem_1[13][25]
+ B2=n828
XU1108 AOI22S $PINS O=n739 A1=bank_mem_1[10][25] A2=FE_OFN142_n831
+ B1=bank_mem_1[11][25] B2=FE_OFN141_n830
XU1109 AOI22S $PINS O=n738 A1=bank_mem_1[8][25] A2=FE_OFN144_n833
+ B1=bank_mem_1[9][25] B2=FE_OFN143_n832
XU1110 AN2 $PINS O=n740 I1=n739 I2=n738
XU1111 ND3 $PINS O=n743 I1=n742 I2=n741 I3=n740
XU1112 AOI22S $PINS O=n747 A1=bank_mem_1[7][25] A2=FE_OFN162_n840 B1=n743
+ B2=FE_OFN127_N34
XU1113 AOI22S $PINS O=n746 A1=bank_mem_1[5][25] A2=n842 B1=bank_mem_1[6][25]
+ B2=n841
XU1114 AOI22S $PINS O=n745 A1=bank_mem_1[3][25] A2=n844 B1=bank_mem_1[4][25]
+ B2=n843
XU1115 AO222 $PINS O=n744 A1=bank_mem_1[1][25] A2=n847 B1=bank_mem_1[0][25]
+ B2=n846 C1=bank_mem_1[2][25] C2=n845
XU1116 AN4B1S $PINS O=n748 I1=n747 I2=n746 I3=n745 B1=n744
XU1117 INV1S $PINS O=bank_rdata[1][25] I=n748
XU1118 AOI22S $PINS O=n753 A1=bank_mem_1[14][26] A2=FE_OFN138_n827
+ B1=bank_mem_1[15][26] B2=FE_OFN137_n826
XU1119 AOI22S $PINS O=n752 A1=bank_mem_1[12][26] A2=n829 B1=bank_mem_1[13][26]
+ B2=n828
XU1120 AOI22S $PINS O=n750 A1=bank_mem_1[10][26] A2=FE_OFN142_n831
+ B1=bank_mem_1[11][26] B2=FE_OFN141_n830
XU1121 AOI22S $PINS O=n749 A1=bank_mem_1[8][26] A2=FE_OFN144_n833
+ B1=bank_mem_1[9][26] B2=FE_OFN143_n832
XU1122 AN2 $PINS O=n751 I1=n750 I2=n749
XU1123 ND3 $PINS O=n754 I1=n753 I2=n752 I3=n751
XU1124 AOI22S $PINS O=n758 A1=bank_mem_1[7][26] A2=FE_OFN162_n840 B1=n754
+ B2=FE_OFN127_N34
XU1125 AOI22S $PINS O=n757 A1=bank_mem_1[5][26] A2=n842 B1=bank_mem_1[6][26]
+ B2=n841
XU1126 AOI22S $PINS O=n756 A1=bank_mem_1[3][26] A2=n844 B1=bank_mem_1[4][26]
+ B2=n843
XU1127 AO222 $PINS O=n755 A1=bank_mem_1[1][26] A2=n847 B1=bank_mem_1[0][26]
+ B2=n846 C1=bank_mem_1[2][26] C2=n845
XU1128 AN4B1S $PINS O=FE_PHN1625_n759 I1=n758 I2=n757 I3=n756 B1=n755
XU1129 AOI22S $PINS O=n764 A1=bank_mem_1[14][27] A2=FE_OFN138_n827
+ B1=bank_mem_1[15][27] B2=FE_OFN137_n826
XU1130 AOI22S $PINS O=n763 A1=bank_mem_1[12][27] A2=n829 B1=bank_mem_1[13][27]
+ B2=n828
XU1131 AOI22S $PINS O=n761 A1=bank_mem_1[10][27] A2=FE_OFN142_n831
+ B1=bank_mem_1[11][27] B2=FE_OFN141_n830
XU1132 AOI22S $PINS O=n760 A1=bank_mem_1[8][27] A2=FE_OFN144_n833
+ B1=bank_mem_1[9][27] B2=FE_OFN143_n832
XU1133 AN2 $PINS O=n762 I1=n761 I2=n760
XU1134 ND3 $PINS O=n765 I1=n764 I2=n763 I3=n762
XU1135 AOI22S $PINS O=n769 A1=bank_mem_1[7][27] A2=FE_OFN162_n840 B1=n765
+ B2=FE_OFN127_N34
XU1136 AOI22S $PINS O=n768 A1=bank_mem_1[5][27] A2=n842 B1=bank_mem_1[6][27]
+ B2=n841
XU1137 AOI22S $PINS O=n767 A1=bank_mem_1[3][27] A2=n844 B1=bank_mem_1[4][27]
+ B2=n843
XU1138 AO222 $PINS O=n766 A1=bank_mem_1[1][27] A2=n847 B1=bank_mem_1[0][27]
+ B2=n846 C1=FE_PHN2179_bank_mem_1_2_27 C2=n845
XU1139 AN4B1S $PINS O=n770 I1=n769 I2=n768 I3=n767 B1=n766
XU1140 INV1S $PINS O=bank_rdata[1][27] I=n770
XU1141 AOI22S $PINS O=n775 A1=bank_mem_1[14][28] A2=FE_OFN138_n827
+ B1=bank_mem_1[15][28] B2=FE_OFN137_n826
XU1142 AOI22S $PINS O=n774 A1=bank_mem_1[12][28] A2=n829 B1=bank_mem_1[13][28]
+ B2=n828
XU1143 AOI22S $PINS O=n772 A1=bank_mem_1[10][28] A2=FE_OFN142_n831
+ B1=bank_mem_1[11][28] B2=FE_OFN141_n830
XU1144 AOI22S $PINS O=n771 A1=bank_mem_1[8][28] A2=FE_OFN144_n833
+ B1=bank_mem_1[9][28] B2=FE_OFN143_n832
XU1145 AN2 $PINS O=n773 I1=n772 I2=n771
XU1146 ND3 $PINS O=n776 I1=n775 I2=n774 I3=n773
XU1147 AOI22S $PINS O=n780 A1=FE_PHN1633_bank_mem_1_7_28 A2=FE_OFN162_n840
+ B1=n776 B2=FE_OFN127_N34
XU1148 AOI22S $PINS O=n779 A1=bank_mem_1[5][28] A2=n842 B1=bank_mem_1[6][28]
+ B2=n841
XU1149 AOI22S $PINS O=n778 A1=bank_mem_1[3][28] A2=n844 B1=bank_mem_1[4][28]
+ B2=n843
XU1150 AO222 $PINS O=n777 A1=bank_mem_1[1][28] A2=n847 B1=bank_mem_1[0][28]
+ B2=n846 C1=bank_mem_1[2][28] C2=n845
XU1151 AN4B1S $PINS O=n781 I1=n780 I2=n779 I3=n778 B1=n777
XU1152 INV1S $PINS O=FE_PHN2027_bank_rdata_1_28 I=n781
XU1153 AOI22S $PINS O=n786 A1=bank_mem_1[14][29] A2=FE_OFN138_n827
+ B1=bank_mem_1[15][29] B2=FE_OFN137_n826
XU1154 AOI22S $PINS O=n785 A1=bank_mem_1[12][29] A2=n829 B1=bank_mem_1[13][29]
+ B2=n828
XU1155 AOI22S $PINS O=n783 A1=bank_mem_1[10][29] A2=FE_OFN142_n831
+ B1=bank_mem_1[11][29] B2=FE_OFN141_n830
XU1156 AOI22S $PINS O=n782 A1=bank_mem_1[8][29] A2=FE_OFN144_n833
+ B1=bank_mem_1[9][29] B2=FE_OFN143_n832
XU1157 AN2 $PINS O=n784 I1=n783 I2=n782
XU1158 ND3 $PINS O=n787 I1=n786 I2=n785 I3=n784
XU1159 AOI22S $PINS O=n791 A1=bank_mem_1[7][29] A2=FE_OFN162_n840 B1=n787
+ B2=FE_OFN127_N34
XU1160 AOI22S $PINS O=n790 A1=bank_mem_1[5][29] A2=n842 B1=bank_mem_1[6][29]
+ B2=n841
XU1161 AOI22S $PINS O=n789 A1=bank_mem_1[3][29] A2=n844 B1=bank_mem_1[4][29]
+ B2=n843
XU1162 AO222 $PINS O=n788 A1=bank_mem_1[1][29] A2=n847 B1=bank_mem_1[0][29]
+ B2=n846 C1=bank_mem_1[2][29] C2=n845
XU1163 AN4B1S $PINS O=FE_PHN1677_n792 I1=n791 I2=n790 I3=n789 B1=n788
XU1164 INV1S $PINS O=bank_rdata[1][29] I=n792
XU1165 AOI22S $PINS O=n797 A1=bank_mem_1[14][30] A2=FE_OFN138_n827
+ B1=bank_mem_1[15][30] B2=FE_OFN137_n826
XU1166 AOI22S $PINS O=n796 A1=bank_mem_1[12][30] A2=n829 B1=bank_mem_1[13][30]
+ B2=n828
XU1167 AOI22S $PINS O=n794 A1=bank_mem_1[10][30] A2=FE_OFN142_n831
+ B1=bank_mem_1[11][30] B2=FE_OFN141_n830
XU1168 AOI22S $PINS O=n793 A1=bank_mem_1[8][30] A2=FE_OFN144_n833
+ B1=bank_mem_1[9][30] B2=FE_OFN143_n832
XU1169 AN2 $PINS O=n795 I1=n794 I2=n793
XU1170 ND3 $PINS O=n798 I1=n797 I2=n796 I3=n795
XU1171 AOI22S $PINS O=n802 A1=FE_PHN1649_bank_mem_1_7_30 A2=FE_OFN162_n840
+ B1=n798 B2=FE_OFN127_N34
XU1172 AOI22S $PINS O=n801 A1=bank_mem_1[5][30] A2=n842 B1=bank_mem_1[6][30]
+ B2=n841
XU1173 AOI22S $PINS O=n800 A1=bank_mem_1[3][30] A2=n844 B1=bank_mem_1[4][30]
+ B2=n843
XU1174 AO222 $PINS O=n799 A1=bank_mem_1[1][30] A2=n847 B1=bank_mem_1[0][30]
+ B2=n846 C1=bank_mem_1[2][30] C2=n845
XU1175 AN4B1S $PINS O=n803 I1=n802 I2=n801 I3=n800 B1=n799
XU1176 INV1S $PINS O=FE_PHN2022_bank_rdata_1_30 I=n803
XU1177 AOI22S $PINS O=n808 A1=bank_mem_1[14][31] A2=FE_OFN138_n827
+ B1=bank_mem_1[15][31] B2=FE_OFN137_n826
XU1178 AOI22S $PINS O=n807 A1=bank_mem_1[12][31] A2=n829 B1=bank_mem_1[13][31]
+ B2=n828
XU1179 AOI22S $PINS O=n805 A1=bank_mem_1[10][31] A2=FE_OFN142_n831
+ B1=bank_mem_1[11][31] B2=FE_OFN141_n830
XU1180 AOI22S $PINS O=n804 A1=bank_mem_1[8][31] A2=FE_OFN144_n833
+ B1=bank_mem_1[9][31] B2=FE_OFN143_n832
XU1181 AN2 $PINS O=n806 I1=n805 I2=n804
XU1182 ND3 $PINS O=n809 I1=n808 I2=n807 I3=n806
XU1183 AOI22S $PINS O=n813 A1=FE_PHN1610_bank_mem_1_7_31 A2=FE_OFN162_n840
+ B1=n809 B2=FE_OFN127_N34
XU1184 AOI22S $PINS O=n812 A1=bank_mem_1[5][31] A2=n842 B1=bank_mem_1[6][31]
+ B2=n841
XU1185 AOI22S $PINS O=n811 A1=bank_mem_1[3][31] A2=n844 B1=bank_mem_1[4][31]
+ B2=n843
XU1186 AO222 $PINS O=n810 A1=bank_mem_1[1][31] A2=n847 B1=bank_mem_1[0][31]
+ B2=n846 C1=bank_mem_1[2][31] C2=n845
XU1187 AN4B1S $PINS O=n814 I1=n813 I2=n812 I3=n811 B1=n810
XU1188 INV1S $PINS O=bank_rdata[1][31] I=n814
XU1189 AOI22S $PINS O=n819 A1=bank_mem_1[14][32] A2=FE_OFN138_n827
+ B1=bank_mem_1[15][32] B2=FE_OFN137_n826
XU1190 AOI22S $PINS O=n818 A1=bank_mem_1[12][32] A2=n829 B1=bank_mem_1[13][32]
+ B2=n828
XU1191 AOI22S $PINS O=n816 A1=bank_mem_1[10][32] A2=FE_OFN142_n831
+ B1=bank_mem_1[11][32] B2=FE_OFN141_n830
XU1192 AOI22S $PINS O=n815 A1=bank_mem_1[8][32] A2=FE_OFN144_n833
+ B1=bank_mem_1[9][32] B2=FE_OFN143_n832
XU1193 AN2 $PINS O=n817 I1=n816 I2=n815
XU1194 ND3 $PINS O=n820 I1=n819 I2=n818 I3=n817
XU1195 AOI22S $PINS O=n824 A1=bank_mem_1[7][32] A2=FE_OFN162_n840 B1=n820
+ B2=FE_OFN127_N34
XU1196 AOI22S $PINS O=n823 A1=bank_mem_1[5][32] A2=n842 B1=bank_mem_1[6][32]
+ B2=n841
XU1197 AOI22S $PINS O=n822 A1=bank_mem_1[3][32] A2=n844 B1=bank_mem_1[4][32]
+ B2=n843
XU1198 AO222 $PINS O=n821 A1=bank_mem_1[1][32] A2=n847 B1=bank_mem_1[0][32]
+ B2=n846 C1=bank_mem_1[2][32] C2=n845
XU1199 AN4B1S $PINS O=n825 I1=n824 I2=n823 I3=n822 B1=n821
XU1200 INV1S $PINS O=bank_rdata[1][32] I=n825
XU1201 AOI22S $PINS O=n838 A1=bank_mem_1[14][33] A2=FE_OFN138_n827
+ B1=bank_mem_1[15][33] B2=FE_OFN137_n826
XU1202 AOI22S $PINS O=n837 A1=bank_mem_1[12][33] A2=n829 B1=bank_mem_1[13][33]
+ B2=n828
XU1203 AOI22S $PINS O=n835 A1=bank_mem_1[10][33] A2=FE_OFN142_n831
+ B1=bank_mem_1[11][33] B2=FE_OFN141_n830
XU1204 AOI22S $PINS O=n834 A1=bank_mem_1[8][33] A2=FE_OFN144_n833
+ B1=bank_mem_1[9][33] B2=FE_OFN143_n832
XU1205 AN2 $PINS O=n836 I1=n835 I2=n834
XU1206 ND3 $PINS O=n839 I1=n838 I2=n837 I3=n836
XU1207 AOI22S $PINS O=n851 A1=FE_PHN1602_bank_mem_1_7_33 A2=FE_OFN162_n840
+ B1=FE_OFN127_N34 B2=n839
XU1208 AOI22S $PINS O=n850 A1=bank_mem_1[5][33] A2=n842 B1=bank_mem_1[6][33]
+ B2=n841
XU1209 AOI22S $PINS O=n849 A1=bank_mem_1[3][33] A2=n844 B1=bank_mem_1[4][33]
+ B2=n843
XU1210 AO222 $PINS O=n848 A1=bank_mem_1[1][33] A2=n847 B1=bank_mem_1[0][33]
+ B2=n846 C1=bank_mem_1[2][33] C2=n845
XU1211 AN4B1S $PINS O=n852 I1=n851 I2=n850 I3=n849 B1=n848
XU1212 INV1S $PINS O=bank_rdata[1][33] I=n852
XU3 ND2S $PINS O=n106 I1=n951 I2=n116
Xclk_gate_bank_mem_1_reg[0] SNPS_CLOCK_GATE_HIGH_RegFileDual_DATA_WIDTH34_0
+ $PINS EN=N100 ENCLK=CTS_681 CLK=clk_clone3
Xclk_gate_bank_mem_1_reg[0]_0 SNPS_CLOCK_GATE_HIGH_RegFileDual_DATA_WIDTH34_63
+ $PINS EN=N100 ENCLK=CTS_678 CLK=clk_clone3
Xclk_gate_bank_mem_1_reg[1] SNPS_CLOCK_GATE_HIGH_RegFileDual_DATA_WIDTH34_62
+ $PINS EN=N99 ENCLK=CTS_675 CLK=clk_clone3
Xclk_gate_bank_mem_1_reg[1]_0 SNPS_CLOCK_GATE_HIGH_RegFileDual_DATA_WIDTH34_61
+ $PINS EN=N99 ENCLK=CTS_672 CLK=clk_clone3
Xclk_gate_bank_mem_1_reg[2] SNPS_CLOCK_GATE_HIGH_RegFileDual_DATA_WIDTH34_60
+ $PINS EN=N98 ENCLK=CTS_669 CLK=clk_clone3
Xclk_gate_bank_mem_1_reg[2]_0 SNPS_CLOCK_GATE_HIGH_RegFileDual_DATA_WIDTH34_59
+ $PINS EN=N98 ENCLK=CTS_666 CLK=clk_clone3
Xclk_gate_bank_mem_1_reg[3] SNPS_CLOCK_GATE_HIGH_RegFileDual_DATA_WIDTH34_58
+ $PINS EN=N97 ENCLK=CTS_663 CLK=clk_clone3
Xclk_gate_bank_mem_1_reg[3]_0 SNPS_CLOCK_GATE_HIGH_RegFileDual_DATA_WIDTH34_57
+ $PINS EN=N97 ENCLK=CTS_660 CLK=clk_clone3
Xclk_gate_bank_mem_1_reg[4] SNPS_CLOCK_GATE_HIGH_RegFileDual_DATA_WIDTH34_56
+ $PINS EN=N96 ENCLK=CTS_657 CLK=clk_clone3
Xclk_gate_bank_mem_1_reg[4]_0 SNPS_CLOCK_GATE_HIGH_RegFileDual_DATA_WIDTH34_55
+ $PINS EN=N96 ENCLK=CTS_654 CLK=clk_clone3
Xclk_gate_bank_mem_1_reg[5] SNPS_CLOCK_GATE_HIGH_RegFileDual_DATA_WIDTH34_54
+ $PINS EN=N95 ENCLK=CTS_651 CLK=clk_clone3
Xclk_gate_bank_mem_1_reg[5]_0 SNPS_CLOCK_GATE_HIGH_RegFileDual_DATA_WIDTH34_53
+ $PINS EN=N95 ENCLK=CTS_648 CLK=clk_clone3
Xclk_gate_bank_mem_1_reg[6] SNPS_CLOCK_GATE_HIGH_RegFileDual_DATA_WIDTH34_52
+ $PINS CLK=CTS_784 EN=N94 ENCLK=CTS_732 CLK_clone1=clk_clone3
Xclk_gate_bank_mem_1_reg[6]_0 SNPS_CLOCK_GATE_HIGH_RegFileDual_DATA_WIDTH34_51
+ $PINS EN=N94 ENCLK=CTS_645 CLK=clk_clone3
Xclk_gate_bank_mem_1_reg[7] SNPS_CLOCK_GATE_HIGH_RegFileDual_DATA_WIDTH34_50
+ $PINS CLK=CTS_784 EN=N93 ENCLK=CTS_642 CLK_clone1=clk_clone3
Xclk_gate_bank_mem_1_reg[7]_0 SNPS_CLOCK_GATE_HIGH_RegFileDual_DATA_WIDTH34_49
+ $PINS EN=N93 ENCLK=CTS_639 CLK=clk_clone3
Xclk_gate_bank_mem_1_reg[8] SNPS_CLOCK_GATE_HIGH_RegFileDual_DATA_WIDTH34_48
+ $PINS EN=N92 ENCLK=CTS_729 CLK=CTS_784
Xclk_gate_bank_mem_1_reg[8]_0 SNPS_CLOCK_GATE_HIGH_RegFileDual_DATA_WIDTH34_47
+ $PINS EN=N92 ENCLK=CTS_726 CLK=CTS_784
Xclk_gate_bank_mem_1_reg[9] SNPS_CLOCK_GATE_HIGH_RegFileDual_DATA_WIDTH34_46
+ $PINS EN=N91 ENCLK=CTS_723 CLK=CTS_784
Xclk_gate_bank_mem_1_reg[9]_0 SNPS_CLOCK_GATE_HIGH_RegFileDual_DATA_WIDTH34_45
+ $PINS EN=N91 ENCLK=CTS_720 CLK=CTS_784
Xclk_gate_bank_mem_1_reg[10] SNPS_CLOCK_GATE_HIGH_RegFileDual_DATA_WIDTH34_44
+ $PINS EN=N90 ENCLK=CTS_717 CLK=CTS_784
Xclk_gate_bank_mem_1_reg[10]_0 SNPS_CLOCK_GATE_HIGH_RegFileDual_DATA_WIDTH34_43
+ $PINS EN=N90 ENCLK=CTS_714 CLK=CTS_784
Xclk_gate_bank_mem_1_reg[11] SNPS_CLOCK_GATE_HIGH_RegFileDual_DATA_WIDTH34_42
+ $PINS EN=N89 ENCLK=CTS_711 CLK=CTS_784
Xclk_gate_bank_mem_1_reg[11]_0 SNPS_CLOCK_GATE_HIGH_RegFileDual_DATA_WIDTH34_41
+ $PINS EN=N89 ENCLK=CTS_708 CLK=CTS_784
Xclk_gate_bank_mem_1_reg[12] SNPS_CLOCK_GATE_HIGH_RegFileDual_DATA_WIDTH34_40
+ $PINS EN=N88 ENCLK=CTS_705 CLK=CTS_784
Xclk_gate_bank_mem_1_reg[12]_0 SNPS_CLOCK_GATE_HIGH_RegFileDual_DATA_WIDTH34_39
+ $PINS EN=N88 ENCLK=CTS_702 CLK=CTS_784
Xclk_gate_bank_mem_1_reg[13] SNPS_CLOCK_GATE_HIGH_RegFileDual_DATA_WIDTH34_38
+ $PINS EN=N87 ENCLK=CTS_699 CLK=CTS_784
Xclk_gate_bank_mem_1_reg[13]_0 SNPS_CLOCK_GATE_HIGH_RegFileDual_DATA_WIDTH34_37
+ $PINS EN=N87 ENCLK=CTS_696 CLK=CTS_784
Xclk_gate_bank_mem_1_reg[14] SNPS_CLOCK_GATE_HIGH_RegFileDual_DATA_WIDTH34_36
+ $PINS EN=N86 ENCLK=CTS_693 CLK=CTS_784
Xclk_gate_bank_mem_1_reg[14]_0 SNPS_CLOCK_GATE_HIGH_RegFileDual_DATA_WIDTH34_35
+ $PINS EN=N86 ENCLK=CTS_690 CLK=CTS_784
Xclk_gate_bank_mem_1_reg[15] SNPS_CLOCK_GATE_HIGH_RegFileDual_DATA_WIDTH34_34
+ $PINS EN=N85 ENCLK=CTS_687 CLK=CTS_784
Xclk_gate_bank_mem_1_reg[15]_0 SNPS_CLOCK_GATE_HIGH_RegFileDual_DATA_WIDTH34_33
+ $PINS EN=N85 ENCLK=CTS_684 CLK=CTS_784
Xclk_gate_bank_mem_0_reg[0] SNPS_CLOCK_GATE_HIGH_RegFileDual_DATA_WIDTH34_32
+ $PINS EN=N67 ENCLK=CTS_781 CLK=CTS_782
Xclk_gate_bank_mem_0_reg[0]_0 SNPS_CLOCK_GATE_HIGH_RegFileDual_DATA_WIDTH34_31
+ $PINS EN=N67 ENCLK=CTS_636 CLK=clk_clone4
Xclk_gate_bank_mem_0_reg[1] SNPS_CLOCK_GATE_HIGH_RegFileDual_DATA_WIDTH34_30
+ $PINS EN=N66 ENCLK=CTS_778 CLK=CTS_782
Xclk_gate_bank_mem_0_reg[1]_0 SNPS_CLOCK_GATE_HIGH_RegFileDual_DATA_WIDTH34_29
+ $PINS EN=N66 ENCLK=CTS_633 CLK=clk_clone4
Xclk_gate_bank_mem_0_reg[2] SNPS_CLOCK_GATE_HIGH_RegFileDual_DATA_WIDTH34_28
+ $PINS EN=N65 ENCLK=CTS_775 CLK=CTS_782
Xclk_gate_bank_mem_0_reg[2]_0 SNPS_CLOCK_GATE_HIGH_RegFileDual_DATA_WIDTH34_27
+ $PINS EN=N65 ENCLK=CTS_630 CLK=clk_clone4
Xclk_gate_bank_mem_0_reg[3] SNPS_CLOCK_GATE_HIGH_RegFileDual_DATA_WIDTH34_26
+ $PINS EN=N64 ENCLK=CTS_772 CLK=CTS_782
Xclk_gate_bank_mem_0_reg[3]_0 SNPS_CLOCK_GATE_HIGH_RegFileDual_DATA_WIDTH34_25
+ $PINS EN=N64 ENCLK=CTS_627 CLK=clk_clone4
Xclk_gate_bank_mem_0_reg[4] SNPS_CLOCK_GATE_HIGH_RegFileDual_DATA_WIDTH34_24
+ $PINS EN=N63 ENCLK=CTS_769 CLK=CTS_782
Xclk_gate_bank_mem_0_reg[4]_0 SNPS_CLOCK_GATE_HIGH_RegFileDual_DATA_WIDTH34_23
+ $PINS EN=N63 ENCLK=CTS_624 CLK=clk_clone4
Xclk_gate_bank_mem_0_reg[5] SNPS_CLOCK_GATE_HIGH_RegFileDual_DATA_WIDTH34_22
+ $PINS EN=N62 ENCLK=CTS_766 CLK=CTS_782
Xclk_gate_bank_mem_0_reg[5]_0 SNPS_CLOCK_GATE_HIGH_RegFileDual_DATA_WIDTH34_21
+ $PINS EN=N62 ENCLK=CTS_621 CLK=clk_clone4
Xclk_gate_bank_mem_0_reg[6] SNPS_CLOCK_GATE_HIGH_RegFileDual_DATA_WIDTH34_20
+ $PINS EN=N61 ENCLK=CTS_763 CLK=CTS_782
Xclk_gate_bank_mem_0_reg[6]_0 SNPS_CLOCK_GATE_HIGH_RegFileDual_DATA_WIDTH34_19
+ $PINS EN=N61 ENCLK=CTS_618 CLK=clk_clone4
Xclk_gate_bank_mem_0_reg[7] SNPS_CLOCK_GATE_HIGH_RegFileDual_DATA_WIDTH34_18
+ $PINS EN=N60 ENCLK=CTS_760 CLK=CTS_782
Xclk_gate_bank_mem_0_reg[7]_0 SNPS_CLOCK_GATE_HIGH_RegFileDual_DATA_WIDTH34_17
+ $PINS EN=N60 ENCLK=CTS_615 CLK=clk_clone4
Xclk_gate_bank_mem_0_reg[8] SNPS_CLOCK_GATE_HIGH_RegFileDual_DATA_WIDTH34_16
+ $PINS EN=N59 ENCLK=CTS_757 CLK=CTS_782
Xclk_gate_bank_mem_0_reg[8]_0 SNPS_CLOCK_GATE_HIGH_RegFileDual_DATA_WIDTH34_15
+ $PINS EN=N59 ENCLK=CTS_612 CLK=clk_clone4
Xclk_gate_bank_mem_0_reg[9] SNPS_CLOCK_GATE_HIGH_RegFileDual_DATA_WIDTH34_14
+ $PINS EN=N58 ENCLK=CTS_754 CLK=CTS_782
Xclk_gate_bank_mem_0_reg[9]_0 SNPS_CLOCK_GATE_HIGH_RegFileDual_DATA_WIDTH34_13
+ $PINS EN=N58 ENCLK=CTS_609 CLK=clk_clone4
Xclk_gate_bank_mem_0_reg[10] SNPS_CLOCK_GATE_HIGH_RegFileDual_DATA_WIDTH34_12
+ $PINS EN=N57 ENCLK=CTS_751 CLK=CTS_782
Xclk_gate_bank_mem_0_reg[10]_0 SNPS_CLOCK_GATE_HIGH_RegFileDual_DATA_WIDTH34_11
+ $PINS EN=N57 ENCLK=CTS_606 CLK=clk_clone4
Xclk_gate_bank_mem_0_reg[11] SNPS_CLOCK_GATE_HIGH_RegFileDual_DATA_WIDTH34_10
+ $PINS EN=N56 ENCLK=CTS_748 CLK=CTS_782
Xclk_gate_bank_mem_0_reg[11]_0 SNPS_CLOCK_GATE_HIGH_RegFileDual_DATA_WIDTH34_9
+ $PINS EN=N56 ENCLK=CTS_603 CLK=clk_clone4
Xclk_gate_bank_mem_0_reg[12] SNPS_CLOCK_GATE_HIGH_RegFileDual_DATA_WIDTH34_8
+ $PINS EN=N55 ENCLK=CTS_745 CLK=CTS_782
Xclk_gate_bank_mem_0_reg[12]_0 SNPS_CLOCK_GATE_HIGH_RegFileDual_DATA_WIDTH34_7
+ $PINS EN=N55 ENCLK=CTS_600 CLK=clk_clone4
Xclk_gate_bank_mem_0_reg[13] SNPS_CLOCK_GATE_HIGH_RegFileDual_DATA_WIDTH34_6
+ $PINS EN=N54 ENCLK=CTS_742 CLK=CTS_782
Xclk_gate_bank_mem_0_reg[13]_0 SNPS_CLOCK_GATE_HIGH_RegFileDual_DATA_WIDTH34_5
+ $PINS EN=N54 ENCLK=CTS_597 CLK=clk_clone4
Xclk_gate_bank_mem_0_reg[14] SNPS_CLOCK_GATE_HIGH_RegFileDual_DATA_WIDTH34_4
+ $PINS EN=N53 ENCLK=CTS_739 CLK=CTS_782
Xclk_gate_bank_mem_0_reg[14]_0 SNPS_CLOCK_GATE_HIGH_RegFileDual_DATA_WIDTH34_3
+ $PINS EN=N53 ENCLK=CTS_594 CLK=clk_clone4
Xclk_gate_bank_mem_0_reg[15] SNPS_CLOCK_GATE_HIGH_RegFileDual_DATA_WIDTH34_2
+ $PINS EN=N52 ENCLK=CTS_736 CLK=CTS_782
Xclk_gate_bank_mem_0_reg[15]_0 SNPS_CLOCK_GATE_HIGH_RegFileDual_DATA_WIDTH34_1
+ $PINS EN=N52 ENCLK=CTS_591 CLK=clk_clone4
.ENDS

.SUBCKT SNPS_CLOCK_GATE_HIGH_RegFileDual_DATA_WIDTH22_0 EN ENCLK CLK
*.CONNECT net1711 EN
XFE_PHC2143_net1714 DELA $PINS O=FE_PHN1667_net1714 I=FE_PHN2143_net1714
XFE_PHC1667_net1714 DELB $PINS O=net1714 I=FE_PHN1667_net1714
Xlatch QDBHN $PINS Q=FE_PHN2143_net1714 D=net1711 CKB=CLK
Xmain_gate AN2T $PINS O=ENCLK I1=net1714 I2=CLK
.ENDS

.SUBCKT SNPS_CLOCK_GATE_HIGH_RegFileDual_DATA_WIDTH22_31 EN ENCLK CLK
*.CONNECT net1711 EN
XFE_PHC2233_net1714 BUF1CK $PINS O=FE_PHN2233_net1714 I=FE_PHN2152_net1714
XFE_PHC2152_net1714 BUF1CK $PINS O=FE_PHN2152_net1714 I=net1714
XFE_PHC1678_net1714 DELB $PINS O=FE_PHN1678_net1714 I=FE_PHN2233_net1714
Xlatch QDBHN $PINS Q=net1714 D=net1711 CKB=CLK
Xmain_gate AN2T $PINS O=ENCLK I1=FE_PHN1678_net1714 I2=CLK
.ENDS

.SUBCKT SNPS_CLOCK_GATE_HIGH_RegFileDual_DATA_WIDTH22_30 EN ENCLK CLK
*.CONNECT net1711 EN
XFE_PHC2155_net1714 DELA $PINS O=FE_PHN1687_net1714 I=FE_PHN2155_net1714
XFE_PHC1687_net1714 DELB $PINS O=net1714 I=FE_PHN1687_net1714
Xlatch QDBHN $PINS Q=FE_PHN2155_net1714 D=net1711 CKB=CLK
Xmain_gate AN2T $PINS O=ENCLK I1=net1714 I2=CLK
.ENDS

.SUBCKT SNPS_CLOCK_GATE_HIGH_RegFileDual_DATA_WIDTH22_29 EN ENCLK CLK
*.CONNECT net1711 EN
XFE_PHC2137_net1714 DELA $PINS O=FE_PHN1665_net1714 I=FE_PHN2137_net1714
XFE_PHC1665_net1714 DELB $PINS O=net1714 I=FE_PHN1665_net1714
Xlatch QDBHN $PINS Q=FE_PHN2137_net1714 D=net1711 CKB=CLK
Xmain_gate AN2T $PINS O=ENCLK I1=net1714 I2=CLK
.ENDS

.SUBCKT SNPS_CLOCK_GATE_HIGH_RegFileDual_DATA_WIDTH22_28 EN ENCLK CLK
*.CONNECT net1711 EN
XFE_PHC2232_net1714 BUF1CK $PINS O=FE_PHN2232_net1714 I=FE_PHN2156_net1714
XFE_PHC2156_net1714 BUF1CK $PINS O=FE_PHN2156_net1714 I=net1714
XFE_PHC1688_net1714 DELB $PINS O=FE_PHN1688_net1714 I=FE_PHN2232_net1714
Xlatch QDBHN $PINS Q=net1714 D=net1711 CKB=CLK
Xmain_gate AN2T $PINS O=ENCLK I1=FE_PHN1688_net1714 I2=CLK
.ENDS

.SUBCKT SNPS_CLOCK_GATE_HIGH_RegFileDual_DATA_WIDTH22_27 EN ENCLK CLK
*.CONNECT net1711 EN
XFE_PHC2235_net1714 BUF1CK $PINS O=FE_PHN2157_net1714 I=FE_PHN2235_net1714
XFE_PHC2157_net1714 BUF1CK $PINS O=net1714 I=FE_PHN2157_net1714
XFE_PHC1682_net1714 DELB $PINS O=FE_PHN1682_net1714 I=net1714
Xlatch QDBHN $PINS Q=FE_PHN2235_net1714 D=net1711 CKB=CLK
Xmain_gate AN2T $PINS O=ENCLK I1=FE_PHN1682_net1714 I2=CLK
.ENDS

.SUBCKT SNPS_CLOCK_GATE_HIGH_RegFileDual_DATA_WIDTH22_26 EN ENCLK CLK
*.CONNECT net1711 EN
XFE_PHC2237_net1714 BUF1CK $PINS O=FE_PHN2237_net1714 I=net1714
XFE_PHC2162_net1714 BUF1CK $PINS O=net1714 I=FE_PHN2162_net1714
XFE_PHC1694_net1714 DELB $PINS O=FE_PHN1694_net1714 I=FE_PHN2237_net1714
Xlatch QDBHN $PINS Q=FE_PHN2162_net1714 D=net1711 CKB=CLK
Xmain_gate AN2T $PINS O=ENCLK I1=FE_PHN1694_net1714 I2=CLK
.ENDS

.SUBCKT SNPS_CLOCK_GATE_HIGH_RegFileDual_DATA_WIDTH22_25 EN ENCLK CLK
*.CONNECT net1711 EN
XFE_PHC2147_net1714 DELA $PINS O=FE_PHN2147_net1714 I=net1714
XFE_PHC1674_net1714 DELB $PINS O=FE_PHN1674_net1714 I=FE_PHN2147_net1714
Xlatch QDBHN $PINS Q=net1714 D=net1711 CKB=CLK
Xmain_gate AN2T $PINS O=ENCLK I1=FE_PHN1674_net1714 I2=CLK
.ENDS

.SUBCKT SNPS_CLOCK_GATE_HIGH_RegFileDual_DATA_WIDTH22_24 EN ENCLK CLK
*.CONNECT net1711 EN
XFE_PHC2231_net1714 BUF1CK $PINS O=FE_PHN2231_net1714 I=net1714
XFE_PHC2142_net1714 BUF1CK $PINS O=FE_PHN2142_net1714 I=FE_PHN2231_net1714
XFE_PHC1664_net1714 DELB $PINS O=FE_PHN1664_net1714 I=FE_PHN2142_net1714
Xlatch QDBHN $PINS Q=net1714 D=net1711 CKB=CLK
Xmain_gate AN2T $PINS O=ENCLK I1=FE_PHN1664_net1714 I2=CLK
.ENDS

.SUBCKT SNPS_CLOCK_GATE_HIGH_RegFileDual_DATA_WIDTH22_23 EN ENCLK CLK
*.CONNECT net1711 EN
XFE_PHC2236_net1714 BUF1CK $PINS O=FE_PHN2236_net1714 I=FE_PHN2159_net1714
XFE_PHC2159_net1714 BUF1CK $PINS O=FE_PHN2159_net1714 I=FE_PHN1679_net1714
XFE_PHC1679_net1714 DELB $PINS O=FE_PHN1679_net1714 I=net1714
Xlatch QDBHN $PINS Q=net1714 D=net1711 CKB=CLK
Xmain_gate AN2T $PINS O=ENCLK I1=FE_PHN2236_net1714 I2=CLK
.ENDS

.SUBCKT SNPS_CLOCK_GATE_HIGH_RegFileDual_DATA_WIDTH22_22 EN ENCLK CLK
*.CONNECT net1711 EN
XFE_PHC2234_net1714 BUF1CK $PINS O=FE_PHN2150_net1714 I=FE_PHN2234_net1714
XFE_PHC2150_net1714 BUF2CK $PINS O=FE_PHN1669_net1714 I=FE_PHN2150_net1714
XFE_PHC1669_net1714 DELB $PINS O=net1714 I=FE_PHN1669_net1714
Xlatch QDBHN $PINS Q=FE_PHN2234_net1714 D=net1711 CKB=CLK
Xmain_gate AN2T $PINS O=ENCLK I1=net1714 I2=CLK
.ENDS

.SUBCKT SNPS_CLOCK_GATE_HIGH_RegFileDual_DATA_WIDTH22_21 EN ENCLK CLK
*.CONNECT net1711 EN
XFE_PHC2133_net1714 DELA $PINS O=FE_PHN1658_net1714 I=FE_PHN2133_net1714
XFE_PHC1658_net1714 DELB $PINS O=net1714 I=FE_PHN1658_net1714
Xlatch QDBHN $PINS Q=FE_PHN2133_net1714 D=net1711 CKB=CLK
Xmain_gate AN2T $PINS O=ENCLK I1=net1714 I2=CLK
.ENDS

.SUBCKT SNPS_CLOCK_GATE_HIGH_RegFileDual_DATA_WIDTH22_20 EN ENCLK CLK
*.CONNECT net1711 EN
XFE_PHC2230_net1714 BUF1CK $PINS O=FE_PHN2148_net1714 I=FE_PHN2230_net1714
XFE_PHC2148_net1714 BUF1CK $PINS O=net1714 I=FE_PHN2148_net1714
XFE_PHC1673_net1714 DELB $PINS O=FE_PHN1673_net1714 I=net1714
Xlatch QDBHN $PINS Q=FE_PHN2230_net1714 D=net1711 CKB=CLK
Xmain_gate AN2T $PINS O=ENCLK I1=FE_PHN1673_net1714 I2=CLK
.ENDS

.SUBCKT SNPS_CLOCK_GATE_HIGH_RegFileDual_DATA_WIDTH22_19 EN ENCLK CLK
*.CONNECT net1711 EN
XFE_PHC2238_net1714 BUF1CK $PINS O=FE_PHN2238_net1714 I=FE_PHN2161_net1714
XFE_PHC2161_net1714 BUF1CK $PINS O=FE_PHN2161_net1714 I=FE_PHN1685_net1714
XFE_PHC1685_net1714 DELB $PINS O=FE_PHN1685_net1714 I=net1714
Xlatch QDBHN $PINS Q=net1714 D=net1711 CKB=CLK
Xmain_gate AN2T $PINS O=ENCLK I1=FE_PHN2238_net1714 I2=CLK
.ENDS

.SUBCKT SNPS_CLOCK_GATE_HIGH_RegFileDual_DATA_WIDTH22_18 EN ENCLK CLK
*.CONNECT net1711 EN
XFE_PHC2229_net1714 BUF1CK $PINS O=FE_PHN2229_net1714 I=net1714
XFE_PHC2141_net1714 BUF1CK $PINS O=net1714 I=FE_PHN2141_net1714
XFE_PHC1666_net1714 DELB $PINS O=FE_PHN1666_net1714 I=FE_PHN2229_net1714
Xlatch QDBHN $PINS Q=FE_PHN2141_net1714 D=net1711 CKB=CLK
Xmain_gate AN2T $PINS O=ENCLK I1=FE_PHN1666_net1714 I2=CLK
.ENDS

.SUBCKT SNPS_CLOCK_GATE_HIGH_RegFileDual_DATA_WIDTH22_17 EN ENCLK CLK
*.CONNECT net1711 EN
XFE_PHC2121_net1714 DELA $PINS O=FE_PHN2121_net1714 I=net1714
XFE_PHC1645_net1714 DELB $PINS O=FE_PHN1645_net1714 I=FE_PHN2121_net1714
Xlatch QDBHN $PINS Q=net1714 D=net1711 CKB=CLK
Xmain_gate AN2T $PINS O=ENCLK I1=FE_PHN1645_net1714 I2=CLK
.ENDS

.SUBCKT SNPS_CLOCK_GATE_HIGH_RegFileDual_DATA_WIDTH22_16 EN ENCLK CLK
*.CONNECT net1711 EN
XFE_PHC2223_net1714 BUF2 $PINS O=FE_PHN2223_net1714 I=FE_PHN2113_net1714
XFE_PHC2113_net1714 BUF1CK $PINS O=FE_PHN2113_net1714 I=net1714
XFE_PHC1626_net1714 DELB $PINS O=FE_PHN1626_net1714 I=FE_PHN2223_net1714
Xlatch QDBHN $PINS Q=net1714 D=net1711 CKB=CLK
Xmain_gate AN2T $PINS O=ENCLK I1=FE_PHN1626_net1714 I2=CLK
.ENDS

.SUBCKT SNPS_CLOCK_GATE_HIGH_RegFileDual_DATA_WIDTH22_15 EN ENCLK CLK
*.CONNECT net1711 EN
XFE_PHC2224_net1714 BUF2 $PINS O=FE_PHN2224_net1714 I=net1714
XFE_PHC2103_net1714 BUF1CK $PINS O=FE_PHN2103_net1714 I=FE_PHN2224_net1714
XFE_PHC1624_net1714 DELB $PINS O=FE_PHN1624_net1714 I=FE_PHN2103_net1714
Xlatch QDBHN $PINS Q=net1714 D=net1711 CKB=CLK
Xmain_gate AN2T $PINS O=ENCLK I1=FE_PHN1624_net1714 I2=CLK
.ENDS

.SUBCKT SNPS_CLOCK_GATE_HIGH_RegFileDual_DATA_WIDTH22_14 EN ENCLK CLK
*.CONNECT net1711 EN
XFE_PHC2225_net1714 BUF1 $PINS O=FE_PHN2225_net1714 I=FE_PHN1627_net1714
XFE_PHC2117_net1714 BUF2CK $PINS O=FE_PHN2117_net1714 I=net1714
XFE_PHC1627_net1714 DELB $PINS O=FE_PHN1627_net1714 I=FE_PHN2117_net1714
Xlatch QDBHN $PINS Q=net1714 D=net1711 CKB=CLK
Xmain_gate AN2T $PINS O=ENCLK I1=FE_PHN2225_net1714 I2=CLK
.ENDS

.SUBCKT SNPS_CLOCK_GATE_HIGH_RegFileDual_DATA_WIDTH22_13 EN ENCLK CLK
*.CONNECT net1711 EN
XFE_PHC2116_net1714 DELA $PINS O=FE_PHN2116_net1714 I=net1714
XFE_PHC1631_net1714 DELB $PINS O=FE_PHN1631_net1714 I=FE_PHN2116_net1714
Xlatch QDBHN $PINS Q=net1714 D=net1711 CKB=CLK
Xmain_gate AN2T $PINS O=ENCLK I1=FE_PHN1631_net1714 I2=CLK
.ENDS

.SUBCKT SNPS_CLOCK_GATE_HIGH_RegFileDual_DATA_WIDTH22_12 EN ENCLK CLK
*.CONNECT net1711 EN
XFE_PHC2228_net1714 BUF1CK $PINS O=FE_PHN2228_net1714 I=net1714
XFE_PHC2114_net1714 BUF1S $PINS O=FE_PHN2114_net1714 I=FE_PHN2228_net1714
XFE_PHC1628_net1714 DELB $PINS O=FE_PHN1628_net1714 I=FE_PHN2114_net1714
Xlatch QDBHN $PINS Q=net1714 D=net1711 CKB=CLK
Xmain_gate AN2T $PINS O=ENCLK I1=FE_PHN1628_net1714 I2=CLK
.ENDS

.SUBCKT SNPS_CLOCK_GATE_HIGH_RegFileDual_DATA_WIDTH22_11 EN ENCLK CLK
*.CONNECT net1711 EN
XFE_PHC2226_net1714 BUF1 $PINS O=FE_PHN2226_net1714 I=FE_PHN2115_net1714
XFE_PHC2115_net1714 BUF1CK $PINS O=FE_PHN2115_net1714 I=FE_PHN1637_net1714
XFE_PHC1637_net1714 DELB $PINS O=FE_PHN1637_net1714 I=net1714
Xlatch QDBHN $PINS Q=net1714 D=net1711 CKB=CLK
Xmain_gate AN2T $PINS O=ENCLK I1=FE_PHN2226_net1714 I2=CLK
.ENDS

.SUBCKT SNPS_CLOCK_GATE_HIGH_RegFileDual_DATA_WIDTH22_10 EN ENCLK CLK
*.CONNECT net1711 EN
XFE_PHC2221_net1714 BUF1CK $PINS O=FE_PHN2221_net1714 I=FE_PHN2109_net1714
XFE_PHC2109_net1714 BUF1CK $PINS O=FE_PHN2109_net1714 I=net1714
XFE_PHC1630_net1714 DELB $PINS O=FE_PHN1630_net1714 I=FE_PHN2221_net1714
Xlatch QDBHN $PINS Q=net1714 D=net1711 CKB=CLK
Xmain_gate AN2T $PINS O=ENCLK I1=FE_PHN1630_net1714 I2=CLK
.ENDS

.SUBCKT SNPS_CLOCK_GATE_HIGH_RegFileDual_DATA_WIDTH22_9 EN ENCLK CLK
*.CONNECT net1711 EN
XFE_PHC2098_net1714 DELA $PINS O=FE_PHN2098_net1714 I=FE_PHN1629_net1714
XFE_PHC1629_net1714 DELB $PINS O=FE_PHN1629_net1714 I=net1714
Xlatch QDBHN $PINS Q=net1714 D=net1711 CKB=CLK
Xmain_gate AN2T $PINS O=ENCLK I1=FE_PHN2098_net1714 I2=CLK
.ENDS

.SUBCKT SNPS_CLOCK_GATE_HIGH_RegFileDual_DATA_WIDTH22_8 EN ENCLK CLK
*.CONNECT net1711 EN
XFE_PHC2220_net1714 BUF1CK $PINS O=FE_PHN2220_net1714 I=net1714
XFE_PHC2102_net1714 BUF1CK $PINS O=net1714 I=FE_PHN2102_net1714
XFE_PHC1623_net1714 DELB $PINS O=FE_PHN1623_net1714 I=FE_PHN2220_net1714
Xlatch QDBHN $PINS Q=FE_PHN2102_net1714 D=net1711 CKB=CLK
Xmain_gate AN2T $PINS O=ENCLK I1=FE_PHN1623_net1714 I2=CLK
.ENDS

.SUBCKT SNPS_CLOCK_GATE_HIGH_RegFileDual_DATA_WIDTH22_7 EN ENCLK CLK
*.CONNECT net1711 EN
XFE_PHC2218_net1714 BUF1CK $PINS O=FE_PHN2218_net1714 I=FE_PHN2096_net1714
XFE_PHC2096_net1714 BUF1CK $PINS O=FE_PHN2096_net1714 I=net1714
XFE_PHC1621_net1714 DELB $PINS O=FE_PHN1621_net1714 I=FE_PHN2218_net1714
Xlatch QDBHN $PINS Q=net1714 D=net1711 CKB=CLK
Xmain_gate AN2T $PINS O=ENCLK I1=FE_PHN1621_net1714 I2=CLK
.ENDS

.SUBCKT SNPS_CLOCK_GATE_HIGH_RegFileDual_DATA_WIDTH22_6 EN ENCLK CLK
*.CONNECT net1711 EN
XFE_PHC2111_net1714 DELA $PINS O=net1714 I=FE_PHN2111_net1714
XFE_PHC1639_net1714 DELB $PINS O=FE_PHN1639_net1714 I=net1714
Xlatch QDBHN $PINS Q=FE_PHN2111_net1714 D=net1711 CKB=CLK
Xmain_gate AN2T $PINS O=ENCLK I1=FE_PHN1639_net1714 I2=CLK
.ENDS

.SUBCKT SNPS_CLOCK_GATE_HIGH_RegFileDual_DATA_WIDTH22_5 EN ENCLK CLK
*.CONNECT net1711 EN
XFE_PHC1616_net1714 DELC $PINS O=FE_PHN1616_net1714 I=net1714
Xlatch QDBHN $PINS Q=net1714 D=net1711 CKB=CLK
Xmain_gate AN2T $PINS O=ENCLK I1=FE_PHN1616_net1714 I2=CLK
.ENDS

.SUBCKT SNPS_CLOCK_GATE_HIGH_RegFileDual_DATA_WIDTH22_4 EN ENCLK CLK
*.CONNECT net1711 EN
XFE_PHC2217_net1714 BUF1CK $PINS O=FE_PHN2217_net1714 I=net1714
XFE_PHC2100_net1714 BUF1CK $PINS O=net1714 I=FE_PHN2100_net1714
XFE_PHC1632_net1714 DELB $PINS O=FE_PHN1632_net1714 I=FE_PHN2217_net1714
Xlatch QDBHN $PINS Q=FE_PHN2100_net1714 D=net1711 CKB=CLK
Xmain_gate AN2T $PINS O=ENCLK I1=FE_PHN1632_net1714 I2=CLK
.ENDS

.SUBCKT SNPS_CLOCK_GATE_HIGH_RegFileDual_DATA_WIDTH22_3 EN ENCLK CLK
*.CONNECT net1711 EN
XFE_PHC2222_net1714 BUF1CK $PINS O=FE_PHN2222_net1714 I=FE_PHN2092_net1714
XFE_PHC2092_net1714 BUF1CK $PINS O=FE_PHN2092_net1714 I=FE_PHN1619_net1714
XFE_PHC1619_net1714 DELB $PINS O=FE_PHN1619_net1714 I=net1714
Xlatch QDBHN $PINS Q=net1714 D=net1711 CKB=CLK
Xmain_gate AN2T $PINS O=ENCLK I1=FE_PHN2222_net1714 I2=CLK
.ENDS

.SUBCKT SNPS_CLOCK_GATE_HIGH_RegFileDual_DATA_WIDTH22_2 EN ENCLK CLK
*.CONNECT net1711 EN
XFE_PHC2227_net1714 BUF1CK $PINS O=FE_PHN2227_net1714 I=FE_PHN2110_net1714
XFE_PHC2110_net1714 BUF1CK $PINS O=FE_PHN2110_net1714 I=FE_PHN1634_net1714
XFE_PHC1634_net1714 DELB $PINS O=FE_PHN1634_net1714 I=net1714
Xlatch QDBHN $PINS Q=net1714 D=net1711 CKB=CLK
Xmain_gate AN2T $PINS O=ENCLK I1=FE_PHN2227_net1714 I2=CLK
.ENDS

.SUBCKT SNPS_CLOCK_GATE_HIGH_RegFileDual_DATA_WIDTH22_1 EN ENCLK CLK
*.CONNECT net1711 EN
XFE_PHC1598_net1714 DELC $PINS O=FE_PHN1598_net1714 I=net1714
Xlatch QDBHN $PINS Q=net1714 D=net1711 CKB=CLK
Xmain_gate AN2T $PINS O=ENCLK I1=FE_PHN1598_net1714 I2=CLK
.ENDS

.SUBCKT RegFileDual_DATA_WIDTH22 rst_n read_addr_1[4] read_addr_1[3]
+ read_addr_1[2] read_addr_1[1] read_addr_1[0] read_data_1[21] read_data_1[20]
+ read_data_1[19] read_data_1[18] read_data_1[17] read_data_1[16]
+ read_data_1[15] read_data_1[14] read_data_1[13] read_data_1[12]
+ read_data_1[11] read_data_1[10] read_data_1[9] read_data_1[8] read_data_1[7]
+ read_data_1[6] read_data_1[5] read_data_1[4] read_data_1[3] read_data_1[2]
+ read_data_1[1] read_data_1[0] wen1 wen2 write_addr_1[4] write_addr_1[3]
+ write_addr_1[2] write_addr_1[1] write_addr_1[0] write_addr_2[4]
+ write_addr_2[3] write_addr_2[2] write_addr_2[1] write_addr_2[0]
+ write_data_1[21] write_data_1[20] write_data_1[19] write_data_1[18]
+ write_data_1[17] write_data_1[16] write_data_1[15] write_data_1[14]
+ write_data_1[13] write_data_1[12] write_data_1[11] write_data_1[10]
+ write_data_1[9] write_data_1[8] write_data_1[7] write_data_1[6]
+ write_data_1[5] write_data_1[4] write_data_1[3] write_data_1[2]
+ write_data_1[1] write_data_1[0] write_data_2[21] write_data_2[20]
+ write_data_2[19] write_data_2[18] write_data_2[17] write_data_2[16]
+ write_data_2[15] write_data_2[14] write_data_2[13] write_data_2[12]
+ write_data_2[11] write_data_2[10] write_data_2[9] write_data_2[8]
+ write_data_2[7] write_data_2[6] write_data_2[5] write_data_2[4]
+ write_data_2[3] write_data_2[2] write_data_2[1] write_data_2[0] p_1 i_rst_n
+ clk_clone2 clk_clone1 clk
XFE_PHC2242_bank_wdata_0_9 BUF3 $PINS O=FE_PHN2242_bank_wdata_0_9
+ I=bank_wdata[0][9]
XFE_PHC2210_n618 BUF3CK $PINS O=FE_PHN2210_n618 I=n618
XFE_PHC2207_n616 BUF1CK $PINS O=FE_PHN2207_n616 I=n616
XFE_PHC2204_n612 BUF1CK $PINS O=FE_PHN2204_n612 I=n612
XFE_PHC2053_bank_wdata_0_7 BUF1S $PINS O=FE_PHN2053_bank_wdata_0_7
+ I=bank_wdata[0][7]
XFE_PHC2048_bank_wdata_0_3 BUF1S $PINS O=FE_PHN2048_bank_wdata_0_3
+ I=bank_wdata[0][3]
XFE_PHC2039_bank_wdata_0_16 BUF1S $PINS O=FE_PHN2039_bank_wdata_0_16
+ I=bank_wdata[0][16]
XFE_PHC2015_bank_wdata_1_4 DELB $PINS O=FE_PHN2015_bank_wdata_1_4
+ I=bank_wdata[1][4]
XFE_PHC2009_bank_wdata_1_8 DELB $PINS O=FE_PHN2009_bank_wdata_1_8
+ I=bank_wdata[1][8]
XFE_PHC2008_rf_io_wdata_2_3 BUF1S $PINS O=FE_PHN2008_rf_io_wdata_2_3
+ I=write_data_2[3]
XFE_PHC2006_rf_io_wdata_2_5 BUF2CK $PINS O=FE_PHN2006_rf_io_wdata_2_5
+ I=write_data_2[5]
XFE_PHC2002_rf_io_wdata_2_7 BUF1S $PINS O=FE_PHN2002_rf_io_wdata_2_7
+ I=write_data_2[7]
XFE_PHC1959_N124 DELB $PINS O=FE_PHN1959_N124 I=N124
XFE_PHC1951_N104 DELB $PINS O=FE_PHN1951_N104 I=N104
XFE_PHC1940_N116 DELB $PINS O=N116 I=FE_PHN1940_N116
XFE_PHC1934_N106 DELB $PINS O=N106 I=FE_PHN1934_N106
XFE_PHC1927_N114 DELB $PINS O=N114 I=FE_PHN1927_N114
XFE_PHC1923_N112 DELB $PINS O=FE_PHN1923_N112 I=N112
XFE_PHC1920_N121 DELB $PINS O=N121 I=FE_PHN1920_N121
XFE_PHC1917_N115 DELB $PINS O=N115 I=FE_PHN1917_N115
XFE_PHC1913_N108 DELB $PINS O=FE_PHN1913_N108 I=N108
XFE_PHC1912_N117 DELB $PINS O=FE_PHN1912_N117 I=N117
XFE_PHC1911_N110 DELB $PINS O=FE_PHN1911_N110 I=N110
XFE_PHC1908_N120 DELB $PINS O=N120 I=FE_PHN1908_N120
XFE_PHC1907_N111 DELB $PINS O=FE_PHN1907_N111 I=N111
XFE_PHC1905_N123 DELB $PINS O=FE_PHN1905_N123 I=N123
XFE_PHC1901_N118 DELB $PINS O=FE_PHN1901_N118 I=N118
XFE_PHC1899_N109 DELB $PINS O=FE_PHN1899_N109 I=N109
XFE_PHC1895_bank_wdata_1_2 BUF1S $PINS O=FE_PHN1895_bank_wdata_1_2
+ I=bank_wdata[1][2]
XFE_PHC1894_bank_wdata_1_10 BUF1S $PINS O=FE_PHN1894_bank_wdata_1_10
+ I=bank_wdata[1][10]
XFE_PHC1893_N119 DELB $PINS O=N119 I=FE_PHN1893_N119
XFE_PHC1890_bank_wdata_1_18 BUF1S $PINS O=FE_PHN1890_bank_wdata_1_18
+ I=bank_wdata[1][18]
XFE_PHC1888_N122 DELB $PINS O=N122 I=FE_PHN1888_N122
XFE_PHC1882_N105 DELB $PINS O=FE_PHN1882_N105 I=N105
XFE_PHC1875_N107 DELB $PINS O=FE_PHN1875_N107 I=N107
XFE_PHC1856_bank_wdata_1_21 BUF1S $PINS O=FE_PHN1856_bank_wdata_1_21
+ I=bank_wdata[1][21]
XFE_PHC1853_bank_wdata_1_19 BUF1S $PINS O=FE_PHN1853_bank_wdata_1_19
+ I=bank_wdata[1][19]
XFE_PHC1841_bank_wdata_1_17 BUF1S $PINS O=FE_PHN1841_bank_wdata_1_17
+ I=bank_wdata[1][17]
XFE_PHC1837_bank_wdata_1_0 BUF1S $PINS O=FE_PHN1837_bank_wdata_1_0
+ I=bank_wdata[1][0]
XFE_PHC1829_bank_wdata_0_11 BUF1S $PINS O=FE_PHN1829_bank_wdata_0_11
+ I=bank_wdata[0][11]
XFE_PHC1828_bank_wdata_1_13 BUF1S $PINS O=FE_PHN1828_bank_wdata_1_13
+ I=bank_wdata[1][13]
XFE_PHC1824_bank_wdata_1_12 BUF1S $PINS O=FE_PHN1824_bank_wdata_1_12
+ I=bank_wdata[1][12]
XFE_PHC1821_bank_wdata_1_11 BUF1S $PINS O=FE_PHN1821_bank_wdata_1_11
+ I=bank_wdata[1][11]
XFE_PHC1562_bank_rdata_1_20 DELB $PINS O=FE_PHN1562_bank_rdata_1_20
+ I=bank_rdata[1][20]
XFE_PHC1561_bank_rdata_0_11 DELB $PINS O=FE_PHN1561_bank_rdata_0_11
+ I=bank_rdata[0][11]
XFE_PHC1559_bank_rdata_1_8 DELB $PINS O=FE_PHN1559_bank_rdata_1_8
+ I=bank_rdata[1][8]
XFE_PHC1558_bank_rdata_0_21 DELB $PINS O=FE_PHN1558_bank_rdata_0_21
+ I=bank_rdata[0][21]
XFE_PHC1544_bank_rdata_0_3 DELB $PINS O=FE_PHN1544_bank_rdata_0_3
+ I=bank_rdata[0][3]
XFE_PHC1538_bank_rdata_1_21 DELB $PINS O=bank_rdata[1][21]
+ I=FE_PHN1538_bank_rdata_1_21
XFE_PHC1534_bank_rdata_0_13 DELB $PINS O=bank_rdata[0][13]
+ I=FE_PHN1534_bank_rdata_0_13
XFE_PHC1514_bank_rdata_1_11 DELB $PINS O=bank_rdata[1][11]
+ I=FE_PHN1514_bank_rdata_1_11
XFE_PHC1513_bank_rdata_1_19 DELB $PINS O=bank_rdata[1][19]
+ I=FE_PHN1513_bank_rdata_1_19
XFE_RC_225_0 ND2 $PINS O=FE_RN_104_0 I1=n63 I2=wen1
XFE_RC_224_0 OR2B1P $PINS O=n64 I1=FE_RN_104_0 B1=n88
XCTS_ccl_a_INV_CLK_G1_L10_87 INV6CK $PINS O=CTS_388 I=CTS_389
XCTS_ccl_a_INV_CLK_G1_L9_89 INV4CK $PINS O=CTS_389 I=CTS_390
XCTS_ccl_a_INV_CLK_G1_L10_86 INV6CK $PINS O=CTS_385 I=CTS_386
XCTS_ccl_a_INV_CLK_G1_L9_88 INV4CK $PINS O=CTS_386 I=CTS_387
XCTS_ccl_a_INV_CLK_G1_L10_85 INV6CK $PINS O=CTS_382 I=CTS_383
XCTS_ccl_a_INV_CLK_G1_L9_87 INV3CK $PINS O=CTS_383 I=CTS_384
XCTS_ccl_a_INV_CLK_G1_L10_84 INV8CK $PINS O=CTS_379 I=CTS_380
XCTS_ccl_a_INV_CLK_G1_L9_86 INV4CK $PINS O=CTS_380 I=CTS_381
XCTS_ccl_a_INV_CLK_G1_L10_83 INV6CK $PINS O=CTS_376 I=CTS_377
XCTS_ccl_a_INV_CLK_G1_L9_85 INV3CK $PINS O=CTS_377 I=CTS_378
XCTS_ccl_a_INV_CLK_G1_L10_82 INV6CK $PINS O=CTS_373 I=CTS_374
XCTS_ccl_a_INV_CLK_G1_L9_84 INV3CK $PINS O=CTS_374 I=CTS_375
XCTS_ccl_a_INV_CLK_G1_L10_81 INV6CK $PINS O=CTS_370 I=CTS_371
XCTS_ccl_a_INV_CLK_G1_L9_83 INV4CK $PINS O=CTS_371 I=CTS_372
XCTS_ccl_a_INV_CLK_G1_L10_80 INV6CK $PINS O=CTS_367 I=CTS_368
XCTS_ccl_a_INV_CLK_G1_L9_82 INV3CK $PINS O=CTS_368 I=CTS_369
XCTS_ccl_a_INV_CLK_G1_L10_79 INV6CK $PINS O=CTS_364 I=CTS_365
XCTS_ccl_a_INV_CLK_G1_L9_81 INV3CK $PINS O=CTS_365 I=CTS_366
XCTS_ccl_a_INV_CLK_G1_L10_78 INV6CK $PINS O=CTS_361 I=CTS_362
XCTS_ccl_a_INV_CLK_G1_L9_80 INV3CK $PINS O=CTS_362 I=CTS_363
XCTS_ccl_a_INV_CLK_G1_L10_77 INV6CK $PINS O=CTS_358 I=CTS_359
XCTS_ccl_a_INV_CLK_G1_L9_79 INV4CK $PINS O=CTS_359 I=CTS_360
XCTS_ccl_a_INV_CLK_G1_L10_76 INV6CK $PINS O=CTS_355 I=CTS_356
XCTS_ccl_a_INV_CLK_G1_L9_78 INV3CK $PINS O=CTS_356 I=CTS_357
XCTS_ccl_a_INV_CLK_G1_L10_75 INV6CK $PINS O=CTS_352 I=CTS_353
XCTS_ccl_a_INV_CLK_G1_L9_77 INV3CK $PINS O=CTS_353 I=CTS_354
XCTS_ccl_a_INV_CLK_G1_L10_74 INV6CK $PINS O=CTS_349 I=CTS_350
XCTS_ccl_a_INV_CLK_G1_L9_76 INV3CK $PINS O=CTS_350 I=CTS_351
XCTS_ccl_a_INV_CLK_G1_L10_73 INV6CK $PINS O=CTS_346 I=CTS_347
XCTS_ccl_a_INV_CLK_G1_L9_75 INV4CK $PINS O=CTS_347 I=CTS_348
XCTS_ccl_a_INV_CLK_G1_L10_72 INV6CK $PINS O=CTS_343 I=CTS_344
XCTS_ccl_a_INV_CLK_G1_L9_74 INV3CK $PINS O=CTS_344 I=CTS_345
XCTS_ccl_a_INV_CLK_G0_L7_9 INV8CK $PINS O=CTS_391 I=clk
XCTS_ccl_a_INV_CLK_G1_L10_70 INV6CK $PINS O=CTS_340 I=CTS_341
XCTS_ccl_a_INV_CLK_G1_L9_72 INV3CK $PINS O=CTS_341 I=CTS_342
XCTS_ccl_a_INV_CLK_G1_L10_69 INV6CK $PINS O=CTS_337 I=CTS_338
XCTS_ccl_a_INV_CLK_G1_L9_71 INV3CK $PINS O=CTS_338 I=CTS_339
XCTS_ccl_a_INV_CLK_G1_L10_68 INV6CK $PINS O=CTS_334 I=CTS_335
XCTS_ccl_a_INV_CLK_G1_L9_70 INV3CK $PINS O=CTS_335 I=CTS_336
XCTS_ccl_a_INV_CLK_G1_L10_67 INV6CK $PINS O=CTS_331 I=CTS_332
XCTS_ccl_a_INV_CLK_G1_L9_69 INV3CK $PINS O=CTS_332 I=CTS_333
XCTS_ccl_a_INV_CLK_G1_L10_66 INV6CK $PINS O=CTS_328 I=CTS_329
XCTS_ccl_a_INV_CLK_G1_L9_68 INV3CK $PINS O=CTS_329 I=CTS_330
XCTS_ccl_a_INV_CLK_G1_L10_65 INV6CK $PINS O=CTS_325 I=CTS_326
XCTS_ccl_a_INV_CLK_G1_L9_67 INV2CK $PINS O=CTS_326 I=CTS_327
XCTS_ccl_a_INV_CLK_G1_L10_64 INV6CK $PINS O=CTS_322 I=CTS_323
XCTS_ccl_a_INV_CLK_G1_L9_66 INV2CK $PINS O=CTS_323 I=CTS_324
XCTS_ccl_a_INV_CLK_G1_L10_63 INV4CK $PINS O=CTS_319 I=CTS_320
XCTS_ccl_a_INV_CLK_G1_L9_65 INV3CK $PINS O=CTS_320 I=CTS_321
XCTS_ccl_a_INV_CLK_G1_L10_62 INV6CK $PINS O=CTS_316 I=CTS_317
XCTS_ccl_a_INV_CLK_G1_L9_64 INV2CK $PINS O=CTS_317 I=CTS_318
XCTS_ccl_a_INV_CLK_G1_L10_61 INV6CK $PINS O=CTS_313 I=CTS_314
XCTS_ccl_a_INV_CLK_G1_L9_63 INV3CK $PINS O=CTS_314 I=CTS_315
XCTS_ccl_a_INV_CLK_G1_L10_60 INV6CK $PINS O=CTS_310 I=CTS_311
XCTS_ccl_a_INV_CLK_G1_L9_62 INV3CK $PINS O=CTS_311 I=CTS_312
XCTS_ccl_a_INV_CLK_G1_L10_59 INV6CK $PINS O=CTS_307 I=CTS_308
XCTS_ccl_a_INV_CLK_G1_L9_61 INV3CK $PINS O=CTS_308 I=CTS_309
XCTS_ccl_a_INV_CLK_G1_L10_58 INV6CK $PINS O=CTS_304 I=CTS_305
XCTS_ccl_a_INV_CLK_G1_L9_60 INV3CK $PINS O=CTS_305 I=CTS_306
XCTS_ccl_a_INV_CLK_G1_L10_57 INV6CK $PINS O=CTS_301 I=CTS_302
XCTS_ccl_a_INV_CLK_G1_L9_59 INV2CK $PINS O=CTS_302 I=CTS_303
XCTS_ccl_a_INV_CLK_G1_L10_56 INV6CK $PINS O=CTS_298 I=CTS_299
XCTS_ccl_a_INV_CLK_G1_L9_58 INV2CK $PINS O=CTS_299 I=CTS_300
XCTS_ccl_a_INV_CLK_G1_L10_55 INV6CK $PINS O=CTS_295 I=CTS_296
XCTS_ccl_a_INV_CLK_G1_L9_57 INV3CK $PINS O=CTS_296 I=CTS_297
Xbank_raddr_reg[0][3] QDLHN $PINS Q=N30 D=read_addr_1[4] CK=n98
Xbank_raddr_reg[0][2] QDLHN $PINS Q=N29 D=read_addr_1[3] CK=n98
Xbank_raddr_reg[0][1] QDLHN $PINS Q=N28 D=read_addr_1[2] CK=n98
Xbank_raddr_reg[0][0] QDLHN $PINS Q=N27 D=read_addr_1[1] CK=n98
Xbank_raddr_reg[1][3] QDBHN $PINS Q=N34 D=read_addr_1[4] CKB=n98
Xbank_raddr_reg[1][2] QDBHN $PINS Q=N33 D=read_addr_1[3] CKB=n98
Xbank_raddr_reg[1][1] QDBHN $PINS Q=N32 D=read_addr_1[2] CKB=n98
Xbank_raddr_reg[1][0] QDBHN $PINS Q=N31 D=read_addr_1[1] CKB=n98
XU154 ND2 $PINS O=n65 I1=n71 I2=n72
XU155 ND2 $PINS O=n68 I1=n641 I2=n75
XU156 ND2 $PINS O=n69 I1=n642 I2=n76
XU157 ND2 $PINS O=n73 I1=n643 I2=n77
XU158 ND2 $PINS O=n74 I1=n77 I2=n72
XU159 ND2 $PINS O=n70 I1=n75 I2=n76
XU160 ND2 $PINS O=n78 I1=n84 I2=n647
XU161 ND2 $PINS O=n80 I1=n84 I2=n85
XU162 ND2 $PINS O=n86 I1=n88 I2=wen1
XU163 ND2 $PINS O=n79 I1=n646 I2=n645
XU164 ND2 $PINS O=n81 I1=n646 I2=n91
XU165 ND2 $PINS O=n82 I1=n645 I2=n92
XU167 ND2 $PINS O=n90 I1=n87 I2=n85
XU168 ND2 $PINS O=n83 I1=n91 I2=n92
XU169 OR2B1P $PINS O=n63 I1=n93 B1=wen2
XU170 AO22 $PINS O=N124 A1=bank_rdata[0][0] A2=n98 B1=bank_rdata[1][0] B2=n589
XU171 AO22 $PINS O=N123 A1=bank_rdata[0][1] A2=n98 B1=bank_rdata[1][1] B2=n589
XU172 AO22 $PINS O=FE_PHN1888_N122 A1=bank_rdata[0][2] A2=n98
+ B1=bank_rdata[1][2] B2=n589
XU173 AO22 $PINS O=FE_PHN1920_N121 A1=FE_PHN1544_bank_rdata_0_3 A2=n98
+ B1=bank_rdata[1][3] B2=n589
XU174 AO22 $PINS O=FE_PHN1908_N120 A1=bank_rdata[0][4] A2=n98
+ B1=bank_rdata[1][4] B2=n589
XU175 AO22 $PINS O=FE_PHN1893_N119 A1=bank_rdata[0][5] A2=n98
+ B1=bank_rdata[1][5] B2=n589
XU176 AO22 $PINS O=N118 A1=bank_rdata[0][6] A2=n98 B1=bank_rdata[1][6] B2=n589
XU177 AO22 $PINS O=N117 A1=bank_rdata[0][7] A2=n98 B1=bank_rdata[1][7] B2=n589
XU178 AO22 $PINS O=FE_PHN1940_N116 A1=bank_rdata[0][8] A2=n98
+ B1=FE_PHN1559_bank_rdata_1_8 B2=n589
XU179 AO22 $PINS O=FE_PHN1917_N115 A1=bank_rdata[0][9] A2=n98
+ B1=bank_rdata[1][9] B2=n589
XU180 AO22 $PINS O=FE_PHN1927_N114 A1=bank_rdata[0][10] A2=n98
+ B1=bank_rdata[1][10] B2=n589
XU181 AO22 $PINS O=N113 A1=FE_PHN1561_bank_rdata_0_11 A2=n98
+ B1=bank_rdata[1][11] B2=n589
XU182 AO22 $PINS O=N112 A1=bank_rdata[0][12] A2=n98 B1=bank_rdata[1][12]
+ B2=n589
XU183 AO22 $PINS O=N111 A1=bank_rdata[0][13] A2=n98 B1=bank_rdata[1][13]
+ B2=n589
XU184 AO22 $PINS O=N110 A1=bank_rdata[0][14] A2=n98 B1=bank_rdata[1][14]
+ B2=n589
XU185 AO22 $PINS O=N109 A1=bank_rdata[0][15] A2=n98 B1=bank_rdata[1][15]
+ B2=n589
XU186 AO22 $PINS O=N108 A1=bank_rdata[0][16] A2=n98 B1=bank_rdata[1][16]
+ B2=n589
XU187 AO22 $PINS O=N107 A1=bank_rdata[0][17] A2=n98 B1=bank_rdata[1][17]
+ B2=n589
XU188 AO22 $PINS O=FE_PHN1934_N106 A1=bank_rdata[0][18] A2=n98
+ B1=bank_rdata[1][18] B2=n589
XU189 AO22 $PINS O=N105 A1=bank_rdata[0][19] A2=n98 B1=bank_rdata[1][19]
+ B2=n589
XU190 AO22 $PINS O=N104 A1=bank_rdata[0][20] A2=n98
+ B1=FE_PHN1562_bank_rdata_1_20 B2=n589
XU191 AO22 $PINS O=N103 A1=FE_PHN1558_bank_rdata_0_21 A2=n98
+ B1=bank_rdata[1][21] B2=n589
XU192 XOR4 $PINS O=n98 I1=read_addr_1[1] I2=read_addr_1[0] I3=n94
+ I4=read_addr_1[2]
XU193 ND2 $PINS O=n67 I1=n643 I2=n71
XU194 ND2 $PINS O=n95 I1=wen1 I2=n644
XU195 ND2 $PINS O=n66 I1=n641 I2=n642
XU196 XOR4 $PINS O=n88 I1=write_addr_1[2] I2=n96 I3=n648 I4=write_addr_1[0]
XU198 XOR4 $PINS O=n93 I1=n653 I2=n97 I3=p_1 I4=write_addr_2[0]
Xbank_mem_1_reg[6][21] QDFFN $PINS Q=bank_mem_1[6][21]
+ D=FE_PHN1856_bank_wdata_1_21 CK=CTS_370
Xbank_mem_1_reg[6][20] QDFFN $PINS Q=bank_mem_1[6][20] D=bank_wdata[1][20]
+ CK=CTS_370
Xbank_mem_1_reg[6][19] QDFFN $PINS Q=bank_mem_1[6][19]
+ D=FE_PHN1853_bank_wdata_1_19 CK=CTS_370
Xbank_mem_1_reg[6][18] QDFFN $PINS Q=bank_mem_1[6][18]
+ D=FE_PHN1890_bank_wdata_1_18 CK=CTS_370
Xbank_mem_1_reg[6][17] QDFFN $PINS Q=bank_mem_1[6][17]
+ D=FE_PHN1841_bank_wdata_1_17 CK=CTS_370
Xbank_mem_1_reg[6][16] QDFFN $PINS Q=bank_mem_1[6][16] D=bank_wdata[1][16]
+ CK=CTS_370
Xbank_mem_1_reg[6][15] QDFFN $PINS Q=bank_mem_1[6][15] D=bank_wdata[1][15]
+ CK=CTS_370
Xbank_mem_1_reg[6][14] QDFFN $PINS Q=bank_mem_1[6][14] D=bank_wdata[1][14]
+ CK=CTS_370
Xbank_mem_1_reg[6][13] QDFFN $PINS Q=bank_mem_1[6][13]
+ D=FE_PHN1828_bank_wdata_1_13 CK=CTS_370
Xbank_mem_1_reg[6][12] QDFFN $PINS Q=bank_mem_1[6][12]
+ D=FE_PHN1824_bank_wdata_1_12 CK=CTS_370
Xbank_mem_1_reg[6][11] QDFFN $PINS Q=bank_mem_1[6][11]
+ D=FE_PHN1821_bank_wdata_1_11 CK=CTS_370
Xbank_mem_1_reg[6][10] QDFFN $PINS Q=bank_mem_1[6][10]
+ D=FE_PHN1894_bank_wdata_1_10 CK=CTS_370
Xbank_mem_1_reg[6][9] QDFFN $PINS Q=bank_mem_1[6][9] D=bank_wdata[1][9]
+ CK=CTS_370
Xbank_mem_1_reg[6][8] QDFFN $PINS Q=bank_mem_1[6][8]
+ D=FE_PHN2009_bank_wdata_1_8 CK=CTS_370
Xbank_mem_1_reg[6][7] QDFFN $PINS Q=bank_mem_1[6][7] D=bank_wdata[1][7]
+ CK=CTS_370
Xbank_mem_1_reg[6][6] QDFFN $PINS Q=bank_mem_1[6][6] D=bank_wdata[1][6]
+ CK=CTS_370
Xbank_mem_1_reg[6][5] QDFFN $PINS Q=bank_mem_1[6][5] D=bank_wdata[1][5]
+ CK=CTS_370
Xbank_mem_1_reg[6][4] QDFFN $PINS Q=bank_mem_1[6][4]
+ D=FE_PHN2015_bank_wdata_1_4 CK=CTS_370
Xbank_mem_1_reg[6][3] QDFFN $PINS Q=bank_mem_1[6][3] D=bank_wdata[1][3]
+ CK=CTS_370
Xbank_mem_1_reg[6][2] QDFFN $PINS Q=bank_mem_1[6][2]
+ D=FE_PHN1895_bank_wdata_1_2 CK=CTS_370
Xbank_mem_1_reg[6][1] QDFFN $PINS Q=bank_mem_1[6][1] D=bank_wdata[1][1]
+ CK=CTS_370
Xbank_mem_1_reg[6][0] QDFFN $PINS Q=bank_mem_1[6][0]
+ D=FE_PHN1837_bank_wdata_1_0 CK=CTS_370
Xbank_mem_1_reg[7][20] QDFFN $PINS Q=bank_mem_1[7][20] D=bank_wdata[1][20]
+ CK=CTS_367
Xbank_mem_1_reg[7][19] QDFFN $PINS Q=bank_mem_1[7][19]
+ D=FE_PHN1853_bank_wdata_1_19 CK=CTS_367
Xbank_mem_1_reg[7][18] QDFFN $PINS Q=bank_mem_1[7][18]
+ D=FE_PHN1890_bank_wdata_1_18 CK=CTS_367
Xbank_mem_1_reg[7][17] QDFFN $PINS Q=bank_mem_1[7][17]
+ D=FE_PHN1841_bank_wdata_1_17 CK=CTS_367
Xbank_mem_1_reg[7][16] QDFFN $PINS Q=bank_mem_1[7][16] D=bank_wdata[1][16]
+ CK=CTS_367
Xbank_mem_1_reg[7][15] QDFFN $PINS Q=bank_mem_1[7][15] D=bank_wdata[1][15]
+ CK=CTS_367
Xbank_mem_1_reg[7][14] QDFFN $PINS Q=bank_mem_1[7][14] D=bank_wdata[1][14]
+ CK=CTS_367
Xbank_mem_1_reg[7][13] QDFFN $PINS Q=bank_mem_1[7][13]
+ D=FE_PHN1828_bank_wdata_1_13 CK=CTS_367
Xbank_mem_1_reg[7][12] QDFFN $PINS Q=bank_mem_1[7][12]
+ D=FE_PHN1824_bank_wdata_1_12 CK=CTS_367
Xbank_mem_1_reg[7][11] QDFFN $PINS Q=bank_mem_1[7][11]
+ D=FE_PHN1821_bank_wdata_1_11 CK=CTS_367
Xbank_mem_1_reg[7][10] QDFFN $PINS Q=bank_mem_1[7][10]
+ D=FE_PHN1894_bank_wdata_1_10 CK=CTS_367
Xbank_mem_1_reg[7][9] QDFFN $PINS Q=bank_mem_1[7][9] D=bank_wdata[1][9]
+ CK=CTS_367
Xbank_mem_1_reg[7][8] QDFFN $PINS Q=bank_mem_1[7][8]
+ D=FE_PHN2009_bank_wdata_1_8 CK=CTS_367
Xbank_mem_1_reg[7][7] QDFFN $PINS Q=bank_mem_1[7][7] D=bank_wdata[1][7]
+ CK=CTS_367
Xbank_mem_1_reg[7][6] QDFFN $PINS Q=bank_mem_1[7][6] D=bank_wdata[1][6]
+ CK=CTS_367
Xbank_mem_1_reg[7][5] QDFFN $PINS Q=bank_mem_1[7][5] D=bank_wdata[1][5]
+ CK=CTS_367
Xbank_mem_1_reg[7][4] QDFFN $PINS Q=bank_mem_1[7][4]
+ D=FE_PHN2015_bank_wdata_1_4 CK=CTS_367
Xbank_mem_1_reg[7][3] QDFFN $PINS Q=bank_mem_1[7][3] D=bank_wdata[1][3]
+ CK=CTS_367
Xbank_mem_1_reg[7][2] QDFFN $PINS Q=bank_mem_1[7][2]
+ D=FE_PHN1895_bank_wdata_1_2 CK=CTS_367
Xbank_mem_1_reg[7][1] QDFFN $PINS Q=bank_mem_1[7][1] D=bank_wdata[1][1]
+ CK=CTS_367
Xbank_mem_1_reg[7][0] QDFFN $PINS Q=bank_mem_1[7][0]
+ D=FE_PHN1837_bank_wdata_1_0 CK=CTS_367
Xbank_mem_1_reg[7][21] QDFFN $PINS Q=bank_mem_1[7][21]
+ D=FE_PHN1856_bank_wdata_1_21 CK=CTS_367
Xbank_mem_1_reg[5][21] QDFFN $PINS Q=bank_mem_1[5][21]
+ D=FE_PHN1856_bank_wdata_1_21 CK=CTS_373
Xbank_mem_1_reg[5][20] QDFFN $PINS Q=bank_mem_1[5][20] D=bank_wdata[1][20]
+ CK=CTS_373
Xbank_mem_1_reg[5][19] QDFFN $PINS Q=bank_mem_1[5][19]
+ D=FE_PHN1853_bank_wdata_1_19 CK=CTS_373
Xbank_mem_1_reg[5][18] QDFFN $PINS Q=bank_mem_1[5][18]
+ D=FE_PHN1890_bank_wdata_1_18 CK=CTS_373
Xbank_mem_1_reg[5][17] QDFFN $PINS Q=bank_mem_1[5][17]
+ D=FE_PHN1841_bank_wdata_1_17 CK=CTS_373
Xbank_mem_1_reg[5][16] QDFFN $PINS Q=bank_mem_1[5][16] D=bank_wdata[1][16]
+ CK=CTS_373
Xbank_mem_1_reg[5][15] QDFFN $PINS Q=bank_mem_1[5][15] D=bank_wdata[1][15]
+ CK=CTS_373
Xbank_mem_1_reg[5][14] QDFFN $PINS Q=bank_mem_1[5][14] D=bank_wdata[1][14]
+ CK=CTS_373
Xbank_mem_1_reg[5][13] QDFFN $PINS Q=bank_mem_1[5][13]
+ D=FE_PHN1828_bank_wdata_1_13 CK=CTS_373
Xbank_mem_1_reg[5][12] QDFFN $PINS Q=bank_mem_1[5][12]
+ D=FE_PHN1824_bank_wdata_1_12 CK=CTS_373
Xbank_mem_1_reg[5][11] QDFFN $PINS Q=bank_mem_1[5][11]
+ D=FE_PHN1821_bank_wdata_1_11 CK=CTS_373
Xbank_mem_1_reg[5][10] QDFFN $PINS Q=bank_mem_1[5][10]
+ D=FE_PHN1894_bank_wdata_1_10 CK=CTS_373
Xbank_mem_1_reg[5][9] QDFFN $PINS Q=bank_mem_1[5][9] D=bank_wdata[1][9]
+ CK=CTS_373
Xbank_mem_1_reg[5][8] QDFFN $PINS Q=bank_mem_1[5][8]
+ D=FE_PHN2009_bank_wdata_1_8 CK=CTS_373
Xbank_mem_1_reg[5][7] QDFFN $PINS Q=bank_mem_1[5][7] D=bank_wdata[1][7]
+ CK=CTS_373
Xbank_mem_1_reg[5][6] QDFFN $PINS Q=bank_mem_1[5][6] D=bank_wdata[1][6]
+ CK=CTS_373
Xbank_mem_1_reg[5][5] QDFFN $PINS Q=bank_mem_1[5][5] D=bank_wdata[1][5]
+ CK=CTS_373
Xbank_mem_1_reg[5][4] QDFFN $PINS Q=bank_mem_1[5][4]
+ D=FE_PHN2015_bank_wdata_1_4 CK=CTS_373
Xbank_mem_1_reg[5][3] QDFFN $PINS Q=bank_mem_1[5][3] D=bank_wdata[1][3]
+ CK=CTS_373
Xbank_mem_1_reg[5][2] QDFFN $PINS Q=bank_mem_1[5][2]
+ D=FE_PHN1895_bank_wdata_1_2 CK=CTS_373
Xbank_mem_1_reg[5][1] QDFFN $PINS Q=bank_mem_1[5][1] D=bank_wdata[1][1]
+ CK=CTS_373
Xbank_mem_1_reg[5][0] QDFFN $PINS Q=bank_mem_1[5][0]
+ D=FE_PHN1837_bank_wdata_1_0 CK=CTS_373
Xbank_mem_0_reg[6][21] QDFFN $PINS Q=bank_mem_0[6][21] D=bank_wdata[0][21]
+ CK=CTS_322
Xbank_mem_0_reg[6][20] QDFFN $PINS Q=bank_mem_0[6][20] D=bank_wdata[0][20]
+ CK=CTS_322
Xbank_mem_0_reg[6][19] QDFFN $PINS Q=bank_mem_0[6][19] D=bank_wdata[0][19]
+ CK=CTS_322
Xbank_mem_0_reg[6][18] QDFFN $PINS Q=bank_mem_0[6][18] D=bank_wdata[0][18]
+ CK=CTS_322
Xbank_mem_0_reg[6][17] QDFFN $PINS Q=bank_mem_0[6][17] D=bank_wdata[0][17]
+ CK=CTS_322
Xbank_mem_0_reg[6][16] QDFFN $PINS Q=bank_mem_0[6][16]
+ D=FE_PHN2039_bank_wdata_0_16 CK=CTS_322
Xbank_mem_0_reg[6][15] QDFFN $PINS Q=bank_mem_0[6][15] D=bank_wdata[0][15]
+ CK=CTS_322
Xbank_mem_0_reg[6][14] QDFFN $PINS Q=bank_mem_0[6][14] D=bank_wdata[0][14]
+ CK=CTS_322
Xbank_mem_0_reg[6][13] QDFFN $PINS Q=bank_mem_0[6][13] D=bank_wdata[0][13]
+ CK=CTS_322
Xbank_mem_0_reg[6][12] QDFFN $PINS Q=bank_mem_0[6][12] D=bank_wdata[0][12]
+ CK=CTS_322
Xbank_mem_0_reg[6][11] QDFFN $PINS Q=bank_mem_0[6][11]
+ D=FE_PHN1829_bank_wdata_0_11 CK=CTS_322
Xbank_mem_0_reg[6][10] QDFFN $PINS Q=bank_mem_0[6][10] D=bank_wdata[0][10]
+ CK=CTS_322
Xbank_mem_0_reg[6][9] QDFFN $PINS Q=bank_mem_0[6][9] D=bank_wdata[0][9]
+ CK=CTS_322
Xbank_mem_0_reg[6][8] QDFFN $PINS Q=bank_mem_0[6][8] D=bank_wdata[0][8]
+ CK=CTS_322
Xbank_mem_0_reg[6][7] QDFFN $PINS Q=bank_mem_0[6][7]
+ D=FE_PHN2053_bank_wdata_0_7 CK=CTS_322
Xbank_mem_0_reg[6][6] QDFFN $PINS Q=bank_mem_0[6][6] D=bank_wdata[0][6]
+ CK=CTS_322
Xbank_mem_0_reg[6][5] QDFFN $PINS Q=bank_mem_0[6][5] D=bank_wdata[0][5]
+ CK=CTS_322
Xbank_mem_0_reg[6][4] QDFFN $PINS Q=bank_mem_0[6][4] D=bank_wdata[0][4]
+ CK=CTS_322
Xbank_mem_0_reg[6][3] QDFFN $PINS Q=bank_mem_0[6][3]
+ D=FE_PHN2048_bank_wdata_0_3 CK=CTS_322
Xbank_mem_0_reg[6][2] QDFFN $PINS Q=bank_mem_0[6][2] D=bank_wdata[0][2]
+ CK=CTS_322
Xbank_mem_0_reg[6][1] QDFFN $PINS Q=bank_mem_0[6][1] D=bank_wdata[0][1]
+ CK=CTS_322
Xbank_mem_0_reg[6][0] QDFFN $PINS Q=bank_mem_0[6][0] D=bank_wdata[0][0]
+ CK=CTS_322
Xbank_mem_0_reg[7][20] QDFFN $PINS Q=bank_mem_0[7][20] D=bank_wdata[0][20]
+ CK=CTS_319
Xbank_mem_0_reg[7][19] QDFFN $PINS Q=bank_mem_0[7][19] D=bank_wdata[0][19]
+ CK=CTS_319
Xbank_mem_0_reg[7][18] QDFFN $PINS Q=bank_mem_0[7][18] D=bank_wdata[0][18]
+ CK=CTS_319
Xbank_mem_0_reg[7][17] QDFFN $PINS Q=bank_mem_0[7][17] D=bank_wdata[0][17]
+ CK=CTS_319
Xbank_mem_0_reg[7][16] QDFFN $PINS Q=bank_mem_0[7][16]
+ D=FE_PHN2039_bank_wdata_0_16 CK=CTS_319
Xbank_mem_0_reg[7][15] QDFFN $PINS Q=bank_mem_0[7][15] D=bank_wdata[0][15]
+ CK=CTS_319
Xbank_mem_0_reg[7][14] QDFFN $PINS Q=bank_mem_0[7][14] D=bank_wdata[0][14]
+ CK=CTS_319
Xbank_mem_0_reg[7][13] QDFFN $PINS Q=bank_mem_0[7][13] D=bank_wdata[0][13]
+ CK=CTS_319
Xbank_mem_0_reg[7][12] QDFFN $PINS Q=bank_mem_0[7][12] D=bank_wdata[0][12]
+ CK=CTS_319
Xbank_mem_0_reg[7][11] QDFFN $PINS Q=bank_mem_0[7][11]
+ D=FE_PHN1829_bank_wdata_0_11 CK=CTS_319
Xbank_mem_0_reg[7][10] QDFFN $PINS Q=bank_mem_0[7][10] D=bank_wdata[0][10]
+ CK=CTS_319
Xbank_mem_0_reg[7][9] QDFFN $PINS Q=bank_mem_0[7][9] D=bank_wdata[0][9]
+ CK=CTS_319
Xbank_mem_0_reg[7][8] QDFFN $PINS Q=bank_mem_0[7][8] D=bank_wdata[0][8]
+ CK=CTS_319
Xbank_mem_0_reg[7][7] QDFFN $PINS Q=bank_mem_0[7][7]
+ D=FE_PHN2053_bank_wdata_0_7 CK=CTS_319
Xbank_mem_0_reg[7][6] QDFFN $PINS Q=bank_mem_0[7][6] D=bank_wdata[0][6]
+ CK=CTS_319
Xbank_mem_0_reg[7][5] QDFFN $PINS Q=bank_mem_0[7][5] D=bank_wdata[0][5]
+ CK=CTS_319
Xbank_mem_0_reg[7][4] QDFFN $PINS Q=bank_mem_0[7][4] D=bank_wdata[0][4]
+ CK=CTS_319
Xbank_mem_0_reg[7][3] QDFFN $PINS Q=bank_mem_0[7][3]
+ D=FE_PHN2048_bank_wdata_0_3 CK=CTS_319
Xbank_mem_0_reg[7][2] QDFFN $PINS Q=bank_mem_0[7][2] D=bank_wdata[0][2]
+ CK=CTS_319
Xbank_mem_0_reg[7][1] QDFFN $PINS Q=bank_mem_0[7][1] D=bank_wdata[0][1]
+ CK=CTS_319
Xbank_mem_0_reg[7][0] QDFFN $PINS Q=bank_mem_0[7][0] D=bank_wdata[0][0]
+ CK=CTS_319
Xbank_mem_0_reg[7][21] QDFFN $PINS Q=bank_mem_0[7][21] D=bank_wdata[0][21]
+ CK=CTS_319
Xbank_mem_0_reg[5][21] QDFFN $PINS Q=bank_mem_0[5][21] D=bank_wdata[0][21]
+ CK=CTS_325
Xbank_mem_0_reg[5][20] QDFFN $PINS Q=bank_mem_0[5][20] D=bank_wdata[0][20]
+ CK=CTS_325
Xbank_mem_0_reg[5][19] QDFFN $PINS Q=bank_mem_0[5][19] D=bank_wdata[0][19]
+ CK=CTS_325
Xbank_mem_0_reg[5][18] QDFFN $PINS Q=bank_mem_0[5][18] D=bank_wdata[0][18]
+ CK=CTS_325
Xbank_mem_0_reg[5][17] QDFFN $PINS Q=bank_mem_0[5][17] D=bank_wdata[0][17]
+ CK=CTS_325
Xbank_mem_0_reg[5][16] QDFFN $PINS Q=bank_mem_0[5][16]
+ D=FE_PHN2039_bank_wdata_0_16 CK=CTS_325
Xbank_mem_0_reg[5][15] QDFFN $PINS Q=bank_mem_0[5][15] D=bank_wdata[0][15]
+ CK=CTS_325
Xbank_mem_0_reg[5][14] QDFFN $PINS Q=bank_mem_0[5][14] D=bank_wdata[0][14]
+ CK=CTS_325
Xbank_mem_0_reg[5][13] QDFFN $PINS Q=bank_mem_0[5][13] D=bank_wdata[0][13]
+ CK=CTS_325
Xbank_mem_0_reg[5][12] QDFFN $PINS Q=bank_mem_0[5][12] D=bank_wdata[0][12]
+ CK=CTS_325
Xbank_mem_0_reg[5][11] QDFFN $PINS Q=bank_mem_0[5][11]
+ D=FE_PHN1829_bank_wdata_0_11 CK=CTS_325
Xbank_mem_0_reg[5][10] QDFFN $PINS Q=bank_mem_0[5][10] D=bank_wdata[0][10]
+ CK=CTS_325
Xbank_mem_0_reg[5][9] QDFFN $PINS Q=bank_mem_0[5][9] D=bank_wdata[0][9]
+ CK=CTS_325
Xbank_mem_0_reg[5][8] QDFFN $PINS Q=bank_mem_0[5][8] D=bank_wdata[0][8]
+ CK=CTS_325
Xbank_mem_0_reg[5][7] QDFFN $PINS Q=bank_mem_0[5][7]
+ D=FE_PHN2053_bank_wdata_0_7 CK=CTS_325
Xbank_mem_0_reg[5][6] QDFFN $PINS Q=bank_mem_0[5][6] D=bank_wdata[0][6]
+ CK=CTS_325
Xbank_mem_0_reg[5][5] QDFFN $PINS Q=bank_mem_0[5][5] D=bank_wdata[0][5]
+ CK=CTS_325
Xbank_mem_0_reg[5][4] QDFFN $PINS Q=bank_mem_0[5][4] D=bank_wdata[0][4]
+ CK=CTS_325
Xbank_mem_0_reg[5][3] QDFFN $PINS Q=bank_mem_0[5][3]
+ D=FE_PHN2048_bank_wdata_0_3 CK=CTS_325
Xbank_mem_0_reg[5][2] QDFFN $PINS Q=bank_mem_0[5][2] D=bank_wdata[0][2]
+ CK=CTS_325
Xbank_mem_0_reg[5][1] QDFFN $PINS Q=bank_mem_0[5][1] D=bank_wdata[0][1]
+ CK=CTS_325
Xbank_mem_0_reg[5][0] QDFFN $PINS Q=bank_mem_0[5][0] D=bank_wdata[0][0]
+ CK=CTS_325
Xbank_mem_1_reg[3][21] QDFFN $PINS Q=bank_mem_1[3][21]
+ D=FE_PHN1856_bank_wdata_1_21 CK=CTS_379
Xbank_mem_1_reg[3][20] QDFFN $PINS Q=bank_mem_1[3][20] D=bank_wdata[1][20]
+ CK=CTS_379
Xbank_mem_1_reg[3][19] QDFFN $PINS Q=bank_mem_1[3][19]
+ D=FE_PHN1853_bank_wdata_1_19 CK=CTS_379
Xbank_mem_1_reg[3][18] QDFFN $PINS Q=bank_mem_1[3][18]
+ D=FE_PHN1890_bank_wdata_1_18 CK=CTS_379
Xbank_mem_1_reg[3][17] QDFFN $PINS Q=bank_mem_1[3][17]
+ D=FE_PHN1841_bank_wdata_1_17 CK=CTS_379
Xbank_mem_1_reg[3][16] QDFFN $PINS Q=bank_mem_1[3][16] D=bank_wdata[1][16]
+ CK=CTS_379
Xbank_mem_1_reg[3][15] QDFFN $PINS Q=bank_mem_1[3][15] D=bank_wdata[1][15]
+ CK=CTS_379
Xbank_mem_1_reg[3][14] QDFFN $PINS Q=bank_mem_1[3][14] D=bank_wdata[1][14]
+ CK=CTS_379
Xbank_mem_1_reg[3][13] QDFFN $PINS Q=bank_mem_1[3][13]
+ D=FE_PHN1828_bank_wdata_1_13 CK=CTS_379
Xbank_mem_1_reg[3][12] QDFFN $PINS Q=bank_mem_1[3][12]
+ D=FE_PHN1824_bank_wdata_1_12 CK=CTS_379
Xbank_mem_1_reg[3][11] QDFFN $PINS Q=bank_mem_1[3][11]
+ D=FE_PHN1821_bank_wdata_1_11 CK=CTS_379
Xbank_mem_1_reg[3][10] QDFFN $PINS Q=bank_mem_1[3][10]
+ D=FE_PHN1894_bank_wdata_1_10 CK=CTS_379
Xbank_mem_1_reg[3][9] QDFFN $PINS Q=bank_mem_1[3][9] D=bank_wdata[1][9]
+ CK=CTS_379
Xbank_mem_1_reg[3][8] QDFFN $PINS Q=bank_mem_1[3][8]
+ D=FE_PHN2009_bank_wdata_1_8 CK=CTS_379
Xbank_mem_1_reg[3][7] QDFFN $PINS Q=bank_mem_1[3][7] D=bank_wdata[1][7]
+ CK=CTS_379
Xbank_mem_1_reg[3][6] QDFFN $PINS Q=bank_mem_1[3][6] D=bank_wdata[1][6]
+ CK=CTS_379
Xbank_mem_1_reg[3][5] QDFFN $PINS Q=bank_mem_1[3][5] D=bank_wdata[1][5]
+ CK=CTS_379
Xbank_mem_1_reg[3][4] QDFFN $PINS Q=bank_mem_1[3][4]
+ D=FE_PHN2015_bank_wdata_1_4 CK=CTS_379
Xbank_mem_1_reg[3][3] QDFFN $PINS Q=bank_mem_1[3][3] D=bank_wdata[1][3]
+ CK=CTS_379
Xbank_mem_1_reg[3][2] QDFFN $PINS Q=bank_mem_1[3][2]
+ D=FE_PHN1895_bank_wdata_1_2 CK=CTS_379
Xbank_mem_1_reg[3][1] QDFFN $PINS Q=bank_mem_1[3][1] D=bank_wdata[1][1]
+ CK=CTS_379
Xbank_mem_1_reg[3][0] QDFFN $PINS Q=bank_mem_1[3][0]
+ D=FE_PHN1837_bank_wdata_1_0 CK=CTS_379
Xbank_mem_0_reg[3][21] QDFFN $PINS Q=bank_mem_0[3][21] D=bank_wdata[0][21]
+ CK=CTS_331
Xbank_mem_0_reg[3][20] QDFFN $PINS Q=bank_mem_0[3][20] D=bank_wdata[0][20]
+ CK=CTS_331
Xbank_mem_0_reg[3][19] QDFFN $PINS Q=bank_mem_0[3][19] D=bank_wdata[0][19]
+ CK=CTS_331
Xbank_mem_0_reg[3][18] QDFFN $PINS Q=bank_mem_0[3][18] D=bank_wdata[0][18]
+ CK=CTS_331
Xbank_mem_0_reg[3][17] QDFFN $PINS Q=bank_mem_0[3][17] D=bank_wdata[0][17]
+ CK=CTS_331
Xbank_mem_0_reg[3][16] QDFFN $PINS Q=bank_mem_0[3][16]
+ D=FE_PHN2039_bank_wdata_0_16 CK=CTS_331
Xbank_mem_0_reg[3][15] QDFFN $PINS Q=bank_mem_0[3][15] D=bank_wdata[0][15]
+ CK=CTS_331
Xbank_mem_0_reg[3][14] QDFFN $PINS Q=bank_mem_0[3][14] D=bank_wdata[0][14]
+ CK=CTS_331
Xbank_mem_0_reg[3][13] QDFFN $PINS Q=bank_mem_0[3][13] D=bank_wdata[0][13]
+ CK=CTS_331
Xbank_mem_0_reg[3][12] QDFFN $PINS Q=bank_mem_0[3][12] D=bank_wdata[0][12]
+ CK=CTS_331
Xbank_mem_0_reg[3][11] QDFFN $PINS Q=bank_mem_0[3][11]
+ D=FE_PHN1829_bank_wdata_0_11 CK=CTS_331
Xbank_mem_0_reg[3][10] QDFFN $PINS Q=bank_mem_0[3][10] D=bank_wdata[0][10]
+ CK=CTS_331
Xbank_mem_0_reg[3][9] QDFFN $PINS Q=bank_mem_0[3][9] D=bank_wdata[0][9]
+ CK=CTS_331
Xbank_mem_0_reg[3][8] QDFFN $PINS Q=bank_mem_0[3][8] D=bank_wdata[0][8]
+ CK=CTS_331
Xbank_mem_0_reg[3][7] QDFFN $PINS Q=bank_mem_0[3][7]
+ D=FE_PHN2053_bank_wdata_0_7 CK=CTS_331
Xbank_mem_0_reg[3][6] QDFFN $PINS Q=bank_mem_0[3][6] D=bank_wdata[0][6]
+ CK=CTS_331
Xbank_mem_0_reg[3][5] QDFFN $PINS Q=bank_mem_0[3][5] D=bank_wdata[0][5]
+ CK=CTS_331
Xbank_mem_0_reg[3][4] QDFFN $PINS Q=bank_mem_0[3][4] D=bank_wdata[0][4]
+ CK=CTS_331
Xbank_mem_0_reg[3][3] QDFFN $PINS Q=bank_mem_0[3][3]
+ D=FE_PHN2048_bank_wdata_0_3 CK=CTS_331
Xbank_mem_0_reg[3][2] QDFFN $PINS Q=bank_mem_0[3][2] D=bank_wdata[0][2]
+ CK=CTS_331
Xbank_mem_0_reg[3][1] QDFFN $PINS Q=bank_mem_0[3][1] D=bank_wdata[0][1]
+ CK=CTS_331
Xbank_mem_0_reg[3][0] QDFFN $PINS Q=bank_mem_0[3][0] D=bank_wdata[0][0]
+ CK=CTS_331
Xbank_mem_1_reg[4][21] QDFFN $PINS Q=bank_mem_1[4][21]
+ D=FE_PHN1856_bank_wdata_1_21 CK=CTS_376
Xbank_mem_1_reg[4][20] QDFFN $PINS Q=bank_mem_1[4][20] D=bank_wdata[1][20]
+ CK=CTS_376
Xbank_mem_1_reg[4][19] QDFFN $PINS Q=bank_mem_1[4][19]
+ D=FE_PHN1853_bank_wdata_1_19 CK=CTS_376
Xbank_mem_1_reg[4][18] QDFFN $PINS Q=bank_mem_1[4][18]
+ D=FE_PHN1890_bank_wdata_1_18 CK=CTS_376
Xbank_mem_1_reg[4][17] QDFFN $PINS Q=bank_mem_1[4][17]
+ D=FE_PHN1841_bank_wdata_1_17 CK=CTS_376
Xbank_mem_1_reg[4][16] QDFFN $PINS Q=bank_mem_1[4][16] D=bank_wdata[1][16]
+ CK=CTS_376
Xbank_mem_1_reg[4][15] QDFFN $PINS Q=bank_mem_1[4][15] D=bank_wdata[1][15]
+ CK=CTS_376
Xbank_mem_1_reg[4][14] QDFFN $PINS Q=bank_mem_1[4][14] D=bank_wdata[1][14]
+ CK=CTS_376
Xbank_mem_1_reg[4][13] QDFFN $PINS Q=bank_mem_1[4][13]
+ D=FE_PHN1828_bank_wdata_1_13 CK=CTS_376
Xbank_mem_1_reg[4][12] QDFFN $PINS Q=bank_mem_1[4][12]
+ D=FE_PHN1824_bank_wdata_1_12 CK=CTS_376
Xbank_mem_1_reg[4][11] QDFFN $PINS Q=bank_mem_1[4][11]
+ D=FE_PHN1821_bank_wdata_1_11 CK=CTS_376
Xbank_mem_1_reg[4][10] QDFFN $PINS Q=bank_mem_1[4][10]
+ D=FE_PHN1894_bank_wdata_1_10 CK=CTS_376
Xbank_mem_1_reg[4][9] QDFFN $PINS Q=bank_mem_1[4][9] D=bank_wdata[1][9]
+ CK=CTS_376
Xbank_mem_1_reg[4][8] QDFFN $PINS Q=bank_mem_1[4][8]
+ D=FE_PHN2009_bank_wdata_1_8 CK=CTS_376
Xbank_mem_1_reg[4][7] QDFFN $PINS Q=bank_mem_1[4][7] D=bank_wdata[1][7]
+ CK=CTS_376
Xbank_mem_1_reg[4][6] QDFFN $PINS Q=bank_mem_1[4][6] D=bank_wdata[1][6]
+ CK=CTS_376
Xbank_mem_1_reg[4][5] QDFFN $PINS Q=bank_mem_1[4][5] D=bank_wdata[1][5]
+ CK=CTS_376
Xbank_mem_1_reg[4][4] QDFFN $PINS Q=bank_mem_1[4][4]
+ D=FE_PHN2015_bank_wdata_1_4 CK=CTS_376
Xbank_mem_1_reg[4][3] QDFFN $PINS Q=bank_mem_1[4][3] D=bank_wdata[1][3]
+ CK=CTS_376
Xbank_mem_1_reg[4][2] QDFFN $PINS Q=bank_mem_1[4][2]
+ D=FE_PHN1895_bank_wdata_1_2 CK=CTS_376
Xbank_mem_1_reg[4][1] QDFFN $PINS Q=bank_mem_1[4][1] D=bank_wdata[1][1]
+ CK=CTS_376
Xbank_mem_1_reg[4][0] QDFFN $PINS Q=bank_mem_1[4][0]
+ D=FE_PHN1837_bank_wdata_1_0 CK=CTS_376
Xbank_mem_1_reg[2][21] QDFFN $PINS Q=bank_mem_1[2][21]
+ D=FE_PHN1856_bank_wdata_1_21 CK=CTS_382
Xbank_mem_1_reg[2][20] QDFFN $PINS Q=bank_mem_1[2][20] D=bank_wdata[1][20]
+ CK=CTS_382
Xbank_mem_1_reg[2][19] QDFFN $PINS Q=bank_mem_1[2][19]
+ D=FE_PHN1853_bank_wdata_1_19 CK=CTS_382
Xbank_mem_1_reg[2][18] QDFFN $PINS Q=bank_mem_1[2][18]
+ D=FE_PHN1890_bank_wdata_1_18 CK=CTS_382
Xbank_mem_1_reg[2][17] QDFFN $PINS Q=bank_mem_1[2][17]
+ D=FE_PHN1841_bank_wdata_1_17 CK=CTS_382
Xbank_mem_1_reg[2][16] QDFFN $PINS Q=bank_mem_1[2][16] D=bank_wdata[1][16]
+ CK=CTS_382
Xbank_mem_1_reg[2][15] QDFFN $PINS Q=bank_mem_1[2][15] D=bank_wdata[1][15]
+ CK=CTS_382
Xbank_mem_1_reg[2][14] QDFFN $PINS Q=bank_mem_1[2][14] D=bank_wdata[1][14]
+ CK=CTS_382
Xbank_mem_1_reg[2][13] QDFFN $PINS Q=bank_mem_1[2][13]
+ D=FE_PHN1828_bank_wdata_1_13 CK=CTS_382
Xbank_mem_1_reg[2][12] QDFFN $PINS Q=bank_mem_1[2][12]
+ D=FE_PHN1824_bank_wdata_1_12 CK=CTS_382
Xbank_mem_1_reg[2][11] QDFFN $PINS Q=bank_mem_1[2][11]
+ D=FE_PHN1821_bank_wdata_1_11 CK=CTS_382
Xbank_mem_1_reg[2][10] QDFFN $PINS Q=bank_mem_1[2][10]
+ D=FE_PHN1894_bank_wdata_1_10 CK=CTS_382
Xbank_mem_1_reg[2][9] QDFFN $PINS Q=bank_mem_1[2][9] D=bank_wdata[1][9]
+ CK=CTS_382
Xbank_mem_1_reg[2][8] QDFFN $PINS Q=bank_mem_1[2][8]
+ D=FE_PHN2009_bank_wdata_1_8 CK=CTS_382
Xbank_mem_1_reg[2][7] QDFFN $PINS Q=bank_mem_1[2][7] D=bank_wdata[1][7]
+ CK=CTS_382
Xbank_mem_1_reg[2][6] QDFFN $PINS Q=bank_mem_1[2][6] D=bank_wdata[1][6]
+ CK=CTS_382
Xbank_mem_1_reg[2][5] QDFFN $PINS Q=bank_mem_1[2][5] D=bank_wdata[1][5]
+ CK=CTS_382
Xbank_mem_1_reg[2][4] QDFFN $PINS Q=bank_mem_1[2][4]
+ D=FE_PHN2015_bank_wdata_1_4 CK=CTS_382
Xbank_mem_1_reg[2][3] QDFFN $PINS Q=bank_mem_1[2][3] D=bank_wdata[1][3]
+ CK=CTS_382
Xbank_mem_1_reg[2][2] QDFFN $PINS Q=bank_mem_1[2][2]
+ D=FE_PHN1895_bank_wdata_1_2 CK=CTS_382
Xbank_mem_1_reg[2][1] QDFFN $PINS Q=bank_mem_1[2][1] D=bank_wdata[1][1]
+ CK=CTS_382
Xbank_mem_1_reg[2][0] QDFFN $PINS Q=bank_mem_1[2][0]
+ D=FE_PHN1837_bank_wdata_1_0 CK=CTS_382
Xbank_mem_0_reg[4][21] QDFFN $PINS Q=bank_mem_0[4][21] D=bank_wdata[0][21]
+ CK=CTS_328
Xbank_mem_0_reg[4][20] QDFFN $PINS Q=bank_mem_0[4][20] D=bank_wdata[0][20]
+ CK=CTS_328
Xbank_mem_0_reg[4][19] QDFFN $PINS Q=bank_mem_0[4][19] D=bank_wdata[0][19]
+ CK=CTS_328
Xbank_mem_0_reg[4][18] QDFFN $PINS Q=bank_mem_0[4][18] D=bank_wdata[0][18]
+ CK=CTS_328
Xbank_mem_0_reg[4][17] QDFFN $PINS Q=bank_mem_0[4][17] D=bank_wdata[0][17]
+ CK=CTS_328
Xbank_mem_0_reg[4][16] QDFFN $PINS Q=bank_mem_0[4][16]
+ D=FE_PHN2039_bank_wdata_0_16 CK=CTS_328
Xbank_mem_0_reg[4][15] QDFFN $PINS Q=bank_mem_0[4][15] D=bank_wdata[0][15]
+ CK=CTS_328
Xbank_mem_0_reg[4][14] QDFFN $PINS Q=bank_mem_0[4][14] D=bank_wdata[0][14]
+ CK=CTS_328
Xbank_mem_0_reg[4][13] QDFFN $PINS Q=bank_mem_0[4][13] D=bank_wdata[0][13]
+ CK=CTS_328
Xbank_mem_0_reg[4][12] QDFFN $PINS Q=bank_mem_0[4][12] D=bank_wdata[0][12]
+ CK=CTS_328
Xbank_mem_0_reg[4][11] QDFFN $PINS Q=bank_mem_0[4][11]
+ D=FE_PHN1829_bank_wdata_0_11 CK=CTS_328
Xbank_mem_0_reg[4][10] QDFFN $PINS Q=bank_mem_0[4][10] D=bank_wdata[0][10]
+ CK=CTS_328
Xbank_mem_0_reg[4][9] QDFFN $PINS Q=bank_mem_0[4][9] D=bank_wdata[0][9]
+ CK=CTS_328
Xbank_mem_0_reg[4][8] QDFFN $PINS Q=bank_mem_0[4][8] D=bank_wdata[0][8]
+ CK=CTS_328
Xbank_mem_0_reg[4][7] QDFFN $PINS Q=bank_mem_0[4][7]
+ D=FE_PHN2053_bank_wdata_0_7 CK=CTS_328
Xbank_mem_0_reg[4][6] QDFFN $PINS Q=bank_mem_0[4][6] D=bank_wdata[0][6]
+ CK=CTS_328
Xbank_mem_0_reg[4][5] QDFFN $PINS Q=bank_mem_0[4][5] D=bank_wdata[0][5]
+ CK=CTS_328
Xbank_mem_0_reg[4][4] QDFFN $PINS Q=bank_mem_0[4][4] D=bank_wdata[0][4]
+ CK=CTS_328
Xbank_mem_0_reg[4][3] QDFFN $PINS Q=bank_mem_0[4][3]
+ D=FE_PHN2048_bank_wdata_0_3 CK=CTS_328
Xbank_mem_0_reg[4][2] QDFFN $PINS Q=bank_mem_0[4][2] D=bank_wdata[0][2]
+ CK=CTS_328
Xbank_mem_0_reg[4][1] QDFFN $PINS Q=bank_mem_0[4][1] D=bank_wdata[0][1]
+ CK=CTS_328
Xbank_mem_0_reg[4][0] QDFFN $PINS Q=bank_mem_0[4][0] D=bank_wdata[0][0]
+ CK=CTS_328
Xbank_mem_1_reg[15][20] QDFFN $PINS Q=bank_mem_1[15][20] D=bank_wdata[1][20]
+ CK=CTS_343
Xbank_mem_1_reg[15][19] QDFFN $PINS Q=bank_mem_1[15][19]
+ D=FE_PHN1853_bank_wdata_1_19 CK=CTS_343
Xbank_mem_1_reg[15][18] QDFFN $PINS Q=bank_mem_1[15][18]
+ D=FE_PHN1890_bank_wdata_1_18 CK=CTS_343
Xbank_mem_1_reg[15][17] QDFFN $PINS Q=bank_mem_1[15][17]
+ D=FE_PHN1841_bank_wdata_1_17 CK=CTS_343
Xbank_mem_1_reg[15][16] QDFFN $PINS Q=bank_mem_1[15][16] D=bank_wdata[1][16]
+ CK=CTS_343
Xbank_mem_1_reg[15][15] QDFFN $PINS Q=bank_mem_1[15][15] D=bank_wdata[1][15]
+ CK=CTS_343
Xbank_mem_1_reg[15][14] QDFFN $PINS Q=bank_mem_1[15][14] D=bank_wdata[1][14]
+ CK=CTS_343
Xbank_mem_1_reg[15][13] QDFFN $PINS Q=bank_mem_1[15][13]
+ D=FE_PHN1828_bank_wdata_1_13 CK=CTS_343
Xbank_mem_1_reg[15][12] QDFFN $PINS Q=bank_mem_1[15][12]
+ D=FE_PHN1824_bank_wdata_1_12 CK=CTS_343
Xbank_mem_1_reg[15][11] QDFFN $PINS Q=bank_mem_1[15][11]
+ D=FE_PHN1821_bank_wdata_1_11 CK=CTS_343
Xbank_mem_1_reg[15][10] QDFFN $PINS Q=bank_mem_1[15][10]
+ D=FE_PHN1894_bank_wdata_1_10 CK=CTS_343
Xbank_mem_1_reg[15][9] QDFFN $PINS Q=bank_mem_1[15][9] D=bank_wdata[1][9]
+ CK=CTS_343
Xbank_mem_1_reg[15][8] QDFFN $PINS Q=bank_mem_1[15][8]
+ D=FE_PHN2009_bank_wdata_1_8 CK=CTS_343
Xbank_mem_1_reg[15][7] QDFFN $PINS Q=bank_mem_1[15][7] D=bank_wdata[1][7]
+ CK=CTS_343
Xbank_mem_1_reg[15][6] QDFFN $PINS Q=bank_mem_1[15][6] D=bank_wdata[1][6]
+ CK=CTS_343
Xbank_mem_1_reg[15][5] QDFFN $PINS Q=bank_mem_1[15][5] D=bank_wdata[1][5]
+ CK=CTS_343
Xbank_mem_1_reg[15][4] QDFFN $PINS Q=bank_mem_1[15][4]
+ D=FE_PHN2015_bank_wdata_1_4 CK=CTS_343
Xbank_mem_1_reg[15][3] QDFFN $PINS Q=bank_mem_1[15][3] D=bank_wdata[1][3]
+ CK=CTS_343
Xbank_mem_1_reg[15][2] QDFFN $PINS Q=bank_mem_1[15][2]
+ D=FE_PHN1895_bank_wdata_1_2 CK=CTS_343
Xbank_mem_1_reg[15][1] QDFFN $PINS Q=bank_mem_1[15][1] D=bank_wdata[1][1]
+ CK=CTS_343
Xbank_mem_1_reg[15][0] QDFFN $PINS Q=bank_mem_1[15][0]
+ D=FE_PHN1837_bank_wdata_1_0 CK=CTS_343
Xbank_mem_1_reg[13][20] QDFFN $PINS Q=bank_mem_1[13][20] D=bank_wdata[1][20]
+ CK=CTS_349
Xbank_mem_1_reg[13][19] QDFFN $PINS Q=bank_mem_1[13][19]
+ D=FE_PHN1853_bank_wdata_1_19 CK=CTS_349
Xbank_mem_1_reg[13][18] QDFFN $PINS Q=bank_mem_1[13][18]
+ D=FE_PHN1890_bank_wdata_1_18 CK=CTS_349
Xbank_mem_1_reg[13][17] QDFFN $PINS Q=bank_mem_1[13][17]
+ D=FE_PHN1841_bank_wdata_1_17 CK=CTS_349
Xbank_mem_1_reg[13][16] QDFFN $PINS Q=bank_mem_1[13][16] D=bank_wdata[1][16]
+ CK=CTS_349
Xbank_mem_1_reg[13][15] QDFFN $PINS Q=bank_mem_1[13][15] D=bank_wdata[1][15]
+ CK=CTS_349
Xbank_mem_1_reg[13][14] QDFFN $PINS Q=bank_mem_1[13][14] D=bank_wdata[1][14]
+ CK=CTS_349
Xbank_mem_1_reg[13][13] QDFFN $PINS Q=bank_mem_1[13][13]
+ D=FE_PHN1828_bank_wdata_1_13 CK=CTS_349
Xbank_mem_1_reg[13][12] QDFFN $PINS Q=bank_mem_1[13][12]
+ D=FE_PHN1824_bank_wdata_1_12 CK=CTS_349
Xbank_mem_1_reg[13][11] QDFFN $PINS Q=bank_mem_1[13][11]
+ D=FE_PHN1821_bank_wdata_1_11 CK=CTS_349
Xbank_mem_1_reg[13][10] QDFFN $PINS Q=bank_mem_1[13][10]
+ D=FE_PHN1894_bank_wdata_1_10 CK=CTS_349
Xbank_mem_1_reg[13][9] QDFFN $PINS Q=bank_mem_1[13][9] D=bank_wdata[1][9]
+ CK=CTS_349
Xbank_mem_1_reg[13][8] QDFFN $PINS Q=bank_mem_1[13][8]
+ D=FE_PHN2009_bank_wdata_1_8 CK=CTS_349
Xbank_mem_1_reg[13][7] QDFFN $PINS Q=bank_mem_1[13][7] D=bank_wdata[1][7]
+ CK=CTS_349
Xbank_mem_1_reg[13][6] QDFFN $PINS Q=bank_mem_1[13][6] D=bank_wdata[1][6]
+ CK=CTS_349
Xbank_mem_1_reg[13][5] QDFFN $PINS Q=bank_mem_1[13][5] D=bank_wdata[1][5]
+ CK=CTS_349
Xbank_mem_1_reg[13][4] QDFFN $PINS Q=bank_mem_1[13][4]
+ D=FE_PHN2015_bank_wdata_1_4 CK=CTS_349
Xbank_mem_1_reg[13][3] QDFFN $PINS Q=bank_mem_1[13][3] D=bank_wdata[1][3]
+ CK=CTS_349
Xbank_mem_1_reg[13][2] QDFFN $PINS Q=bank_mem_1[13][2]
+ D=FE_PHN1895_bank_wdata_1_2 CK=CTS_349
Xbank_mem_1_reg[13][1] QDFFN $PINS Q=bank_mem_1[13][1] D=bank_wdata[1][1]
+ CK=CTS_349
Xbank_mem_1_reg[13][0] QDFFN $PINS Q=bank_mem_1[13][0]
+ D=FE_PHN1837_bank_wdata_1_0 CK=CTS_349
Xbank_mem_0_reg[2][21] QDFFN $PINS Q=bank_mem_0[2][21] D=bank_wdata[0][21]
+ CK=CTS_334
Xbank_mem_0_reg[2][20] QDFFN $PINS Q=bank_mem_0[2][20] D=bank_wdata[0][20]
+ CK=CTS_334
Xbank_mem_0_reg[2][19] QDFFN $PINS Q=bank_mem_0[2][19] D=bank_wdata[0][19]
+ CK=CTS_334
Xbank_mem_0_reg[2][18] QDFFN $PINS Q=bank_mem_0[2][18] D=bank_wdata[0][18]
+ CK=CTS_334
Xbank_mem_0_reg[2][17] QDFFN $PINS Q=bank_mem_0[2][17] D=bank_wdata[0][17]
+ CK=CTS_334
Xbank_mem_0_reg[2][16] QDFFN $PINS Q=bank_mem_0[2][16]
+ D=FE_PHN2039_bank_wdata_0_16 CK=CTS_334
Xbank_mem_0_reg[2][15] QDFFN $PINS Q=bank_mem_0[2][15] D=bank_wdata[0][15]
+ CK=CTS_334
Xbank_mem_0_reg[2][14] QDFFN $PINS Q=bank_mem_0[2][14] D=bank_wdata[0][14]
+ CK=CTS_334
Xbank_mem_0_reg[2][13] QDFFN $PINS Q=bank_mem_0[2][13] D=bank_wdata[0][13]
+ CK=CTS_334
Xbank_mem_0_reg[2][12] QDFFN $PINS Q=bank_mem_0[2][12] D=bank_wdata[0][12]
+ CK=CTS_334
Xbank_mem_0_reg[2][11] QDFFN $PINS Q=bank_mem_0[2][11]
+ D=FE_PHN1829_bank_wdata_0_11 CK=CTS_334
Xbank_mem_0_reg[2][10] QDFFN $PINS Q=bank_mem_0[2][10] D=bank_wdata[0][10]
+ CK=CTS_334
Xbank_mem_0_reg[2][9] QDFFN $PINS Q=bank_mem_0[2][9] D=bank_wdata[0][9]
+ CK=CTS_334
Xbank_mem_0_reg[2][8] QDFFN $PINS Q=bank_mem_0[2][8] D=bank_wdata[0][8]
+ CK=CTS_334
Xbank_mem_0_reg[2][7] QDFFN $PINS Q=bank_mem_0[2][7]
+ D=FE_PHN2053_bank_wdata_0_7 CK=CTS_334
Xbank_mem_0_reg[2][6] QDFFN $PINS Q=bank_mem_0[2][6] D=bank_wdata[0][6]
+ CK=CTS_334
Xbank_mem_0_reg[2][5] QDFFN $PINS Q=bank_mem_0[2][5] D=bank_wdata[0][5]
+ CK=CTS_334
Xbank_mem_0_reg[2][4] QDFFN $PINS Q=bank_mem_0[2][4] D=bank_wdata[0][4]
+ CK=CTS_334
Xbank_mem_0_reg[2][3] QDFFN $PINS Q=bank_mem_0[2][3]
+ D=FE_PHN2048_bank_wdata_0_3 CK=CTS_334
Xbank_mem_0_reg[2][2] QDFFN $PINS Q=bank_mem_0[2][2] D=bank_wdata[0][2]
+ CK=CTS_334
Xbank_mem_0_reg[2][1] QDFFN $PINS Q=bank_mem_0[2][1] D=bank_wdata[0][1]
+ CK=CTS_334
Xbank_mem_0_reg[2][0] QDFFN $PINS Q=bank_mem_0[2][0] D=bank_wdata[0][0]
+ CK=CTS_334
Xbank_mem_1_reg[14][20] QDFFN $PINS Q=bank_mem_1[14][20] D=bank_wdata[1][20]
+ CK=CTS_346
Xbank_mem_1_reg[14][19] QDFFN $PINS Q=bank_mem_1[14][19]
+ D=FE_PHN1853_bank_wdata_1_19 CK=CTS_346
Xbank_mem_1_reg[14][18] QDFFN $PINS Q=bank_mem_1[14][18]
+ D=FE_PHN1890_bank_wdata_1_18 CK=CTS_346
Xbank_mem_1_reg[14][17] QDFFN $PINS Q=bank_mem_1[14][17]
+ D=FE_PHN1841_bank_wdata_1_17 CK=CTS_346
Xbank_mem_1_reg[14][16] QDFFN $PINS Q=bank_mem_1[14][16] D=bank_wdata[1][16]
+ CK=CTS_346
Xbank_mem_1_reg[14][15] QDFFN $PINS Q=bank_mem_1[14][15] D=bank_wdata[1][15]
+ CK=CTS_346
Xbank_mem_1_reg[14][14] QDFFN $PINS Q=bank_mem_1[14][14] D=bank_wdata[1][14]
+ CK=CTS_346
Xbank_mem_1_reg[14][13] QDFFN $PINS Q=bank_mem_1[14][13]
+ D=FE_PHN1828_bank_wdata_1_13 CK=CTS_346
Xbank_mem_1_reg[14][12] QDFFN $PINS Q=bank_mem_1[14][12]
+ D=FE_PHN1824_bank_wdata_1_12 CK=CTS_346
Xbank_mem_1_reg[14][11] QDFFN $PINS Q=bank_mem_1[14][11]
+ D=FE_PHN1821_bank_wdata_1_11 CK=CTS_346
Xbank_mem_1_reg[14][10] QDFFN $PINS Q=bank_mem_1[14][10]
+ D=FE_PHN1894_bank_wdata_1_10 CK=CTS_346
Xbank_mem_1_reg[14][9] QDFFN $PINS Q=bank_mem_1[14][9] D=bank_wdata[1][9]
+ CK=CTS_346
Xbank_mem_1_reg[14][8] QDFFN $PINS Q=bank_mem_1[14][8]
+ D=FE_PHN2009_bank_wdata_1_8 CK=CTS_346
Xbank_mem_1_reg[14][7] QDFFN $PINS Q=bank_mem_1[14][7] D=bank_wdata[1][7]
+ CK=CTS_346
Xbank_mem_1_reg[14][6] QDFFN $PINS Q=bank_mem_1[14][6] D=bank_wdata[1][6]
+ CK=CTS_346
Xbank_mem_1_reg[14][5] QDFFN $PINS Q=bank_mem_1[14][5] D=bank_wdata[1][5]
+ CK=CTS_346
Xbank_mem_1_reg[14][4] QDFFN $PINS Q=bank_mem_1[14][4]
+ D=FE_PHN2015_bank_wdata_1_4 CK=CTS_346
Xbank_mem_1_reg[14][3] QDFFN $PINS Q=bank_mem_1[14][3] D=bank_wdata[1][3]
+ CK=CTS_346
Xbank_mem_1_reg[14][2] QDFFN $PINS Q=bank_mem_1[14][2]
+ D=FE_PHN1895_bank_wdata_1_2 CK=CTS_346
Xbank_mem_1_reg[14][1] QDFFN $PINS Q=bank_mem_1[14][1] D=bank_wdata[1][1]
+ CK=CTS_346
Xbank_mem_1_reg[14][0] QDFFN $PINS Q=bank_mem_1[14][0]
+ D=FE_PHN1837_bank_wdata_1_0 CK=CTS_346
Xbank_mem_1_reg[15][21] QDFFN $PINS Q=bank_mem_1[15][21]
+ D=FE_PHN1856_bank_wdata_1_21 CK=CTS_343
Xbank_mem_1_reg[12][20] QDFFN $PINS Q=bank_mem_1[12][20] D=bank_wdata[1][20]
+ CK=CTS_352
Xbank_mem_1_reg[12][19] QDFFN $PINS Q=bank_mem_1[12][19]
+ D=FE_PHN1853_bank_wdata_1_19 CK=CTS_352
Xbank_mem_1_reg[12][18] QDFFN $PINS Q=bank_mem_1[12][18]
+ D=FE_PHN1890_bank_wdata_1_18 CK=CTS_352
Xbank_mem_1_reg[12][17] QDFFN $PINS Q=bank_mem_1[12][17]
+ D=FE_PHN1841_bank_wdata_1_17 CK=CTS_352
Xbank_mem_1_reg[12][16] QDFFN $PINS Q=bank_mem_1[12][16] D=bank_wdata[1][16]
+ CK=CTS_352
Xbank_mem_1_reg[12][15] QDFFN $PINS Q=bank_mem_1[12][15] D=bank_wdata[1][15]
+ CK=CTS_352
Xbank_mem_1_reg[12][14] QDFFN $PINS Q=bank_mem_1[12][14] D=bank_wdata[1][14]
+ CK=CTS_352
Xbank_mem_1_reg[12][13] QDFFN $PINS Q=bank_mem_1[12][13]
+ D=FE_PHN1828_bank_wdata_1_13 CK=CTS_352
Xbank_mem_1_reg[12][12] QDFFN $PINS Q=bank_mem_1[12][12]
+ D=FE_PHN1824_bank_wdata_1_12 CK=CTS_352
Xbank_mem_1_reg[12][11] QDFFN $PINS Q=bank_mem_1[12][11]
+ D=FE_PHN1821_bank_wdata_1_11 CK=CTS_352
Xbank_mem_1_reg[12][10] QDFFN $PINS Q=bank_mem_1[12][10]
+ D=FE_PHN1894_bank_wdata_1_10 CK=CTS_352
Xbank_mem_1_reg[12][9] QDFFN $PINS Q=bank_mem_1[12][9] D=bank_wdata[1][9]
+ CK=CTS_352
Xbank_mem_1_reg[12][8] QDFFN $PINS Q=bank_mem_1[12][8]
+ D=FE_PHN2009_bank_wdata_1_8 CK=CTS_352
Xbank_mem_1_reg[12][7] QDFFN $PINS Q=bank_mem_1[12][7] D=bank_wdata[1][7]
+ CK=CTS_352
Xbank_mem_1_reg[12][6] QDFFN $PINS Q=bank_mem_1[12][6] D=bank_wdata[1][6]
+ CK=CTS_352
Xbank_mem_1_reg[12][5] QDFFN $PINS Q=bank_mem_1[12][5] D=bank_wdata[1][5]
+ CK=CTS_352
Xbank_mem_1_reg[12][4] QDFFN $PINS Q=bank_mem_1[12][4]
+ D=FE_PHN2015_bank_wdata_1_4 CK=CTS_352
Xbank_mem_1_reg[12][3] QDFFN $PINS Q=bank_mem_1[12][3] D=bank_wdata[1][3]
+ CK=CTS_352
Xbank_mem_1_reg[12][2] QDFFN $PINS Q=bank_mem_1[12][2]
+ D=FE_PHN1895_bank_wdata_1_2 CK=CTS_352
Xbank_mem_1_reg[12][1] QDFFN $PINS Q=bank_mem_1[12][1] D=bank_wdata[1][1]
+ CK=CTS_352
Xbank_mem_1_reg[12][0] QDFFN $PINS Q=bank_mem_1[12][0]
+ D=FE_PHN1837_bank_wdata_1_0 CK=CTS_352
Xbank_mem_1_reg[13][21] QDFFN $PINS Q=bank_mem_1[13][21]
+ D=FE_PHN1856_bank_wdata_1_21 CK=CTS_349
Xbank_mem_0_reg[15][20] QDFFN $PINS Q=bank_mem_0[15][20] D=bank_wdata[0][20]
+ CK=CTS_295
Xbank_mem_0_reg[15][19] QDFFN $PINS Q=bank_mem_0[15][19] D=bank_wdata[0][19]
+ CK=CTS_295
Xbank_mem_0_reg[15][18] QDFFN $PINS Q=bank_mem_0[15][18] D=bank_wdata[0][18]
+ CK=CTS_295
Xbank_mem_0_reg[15][17] QDFFN $PINS Q=bank_mem_0[15][17] D=bank_wdata[0][17]
+ CK=CTS_295
Xbank_mem_0_reg[15][16] QDFFN $PINS Q=bank_mem_0[15][16]
+ D=FE_PHN2039_bank_wdata_0_16 CK=CTS_295
Xbank_mem_0_reg[15][15] QDFFN $PINS Q=bank_mem_0[15][15] D=bank_wdata[0][15]
+ CK=CTS_295
Xbank_mem_0_reg[15][14] QDFFN $PINS Q=bank_mem_0[15][14] D=bank_wdata[0][14]
+ CK=CTS_295
Xbank_mem_0_reg[15][13] QDFFN $PINS Q=bank_mem_0[15][13] D=bank_wdata[0][13]
+ CK=CTS_295
Xbank_mem_0_reg[15][12] QDFFN $PINS Q=bank_mem_0[15][12] D=bank_wdata[0][12]
+ CK=CTS_295
Xbank_mem_0_reg[15][11] QDFFN $PINS Q=bank_mem_0[15][11]
+ D=FE_PHN1829_bank_wdata_0_11 CK=CTS_295
Xbank_mem_0_reg[15][10] QDFFN $PINS Q=bank_mem_0[15][10] D=bank_wdata[0][10]
+ CK=CTS_295
Xbank_mem_0_reg[15][9] QDFFN $PINS Q=bank_mem_0[15][9] D=bank_wdata[0][9]
+ CK=CTS_295
Xbank_mem_0_reg[15][8] QDFFN $PINS Q=bank_mem_0[15][8] D=bank_wdata[0][8]
+ CK=CTS_295
Xbank_mem_0_reg[15][7] QDFFN $PINS Q=bank_mem_0[15][7]
+ D=FE_PHN2053_bank_wdata_0_7 CK=CTS_295
Xbank_mem_0_reg[15][6] QDFFN $PINS Q=bank_mem_0[15][6] D=bank_wdata[0][6]
+ CK=CTS_295
Xbank_mem_0_reg[15][5] QDFFN $PINS Q=bank_mem_0[15][5] D=bank_wdata[0][5]
+ CK=CTS_295
Xbank_mem_0_reg[15][4] QDFFN $PINS Q=bank_mem_0[15][4] D=bank_wdata[0][4]
+ CK=CTS_295
Xbank_mem_0_reg[15][3] QDFFN $PINS Q=bank_mem_0[15][3]
+ D=FE_PHN2048_bank_wdata_0_3 CK=CTS_295
Xbank_mem_0_reg[15][2] QDFFN $PINS Q=bank_mem_0[15][2] D=bank_wdata[0][2]
+ CK=CTS_295
Xbank_mem_0_reg[15][1] QDFFN $PINS Q=bank_mem_0[15][1] D=bank_wdata[0][1]
+ CK=CTS_295
Xbank_mem_0_reg[15][0] QDFFN $PINS Q=bank_mem_0[15][0] D=bank_wdata[0][0]
+ CK=CTS_295
Xbank_mem_0_reg[13][20] QDFFN $PINS Q=bank_mem_0[13][20] D=bank_wdata[0][20]
+ CK=CTS_301
Xbank_mem_0_reg[13][19] QDFFN $PINS Q=bank_mem_0[13][19] D=bank_wdata[0][19]
+ CK=CTS_301
Xbank_mem_0_reg[13][18] QDFFN $PINS Q=bank_mem_0[13][18] D=bank_wdata[0][18]
+ CK=CTS_301
Xbank_mem_0_reg[13][17] QDFFN $PINS Q=bank_mem_0[13][17] D=bank_wdata[0][17]
+ CK=CTS_301
Xbank_mem_0_reg[13][16] QDFFN $PINS Q=bank_mem_0[13][16]
+ D=FE_PHN2039_bank_wdata_0_16 CK=CTS_301
Xbank_mem_0_reg[13][15] QDFFN $PINS Q=bank_mem_0[13][15] D=bank_wdata[0][15]
+ CK=CTS_301
Xbank_mem_0_reg[13][14] QDFFN $PINS Q=bank_mem_0[13][14] D=bank_wdata[0][14]
+ CK=CTS_301
Xbank_mem_0_reg[13][13] QDFFN $PINS Q=bank_mem_0[13][13] D=bank_wdata[0][13]
+ CK=CTS_301
Xbank_mem_0_reg[13][12] QDFFN $PINS Q=bank_mem_0[13][12] D=bank_wdata[0][12]
+ CK=CTS_301
Xbank_mem_0_reg[13][11] QDFFN $PINS Q=bank_mem_0[13][11]
+ D=FE_PHN1829_bank_wdata_0_11 CK=CTS_301
Xbank_mem_0_reg[13][10] QDFFN $PINS Q=bank_mem_0[13][10] D=bank_wdata[0][10]
+ CK=CTS_301
Xbank_mem_0_reg[13][9] QDFFN $PINS Q=bank_mem_0[13][9]
+ D=FE_PHN2242_bank_wdata_0_9 CK=CTS_301
Xbank_mem_0_reg[13][8] QDFFN $PINS Q=bank_mem_0[13][8] D=bank_wdata[0][8]
+ CK=CTS_301
Xbank_mem_0_reg[13][7] QDFFN $PINS Q=bank_mem_0[13][7]
+ D=FE_PHN2053_bank_wdata_0_7 CK=CTS_301
Xbank_mem_0_reg[13][6] QDFFN $PINS Q=bank_mem_0[13][6] D=bank_wdata[0][6]
+ CK=CTS_301
Xbank_mem_0_reg[13][5] QDFFN $PINS Q=bank_mem_0[13][5] D=bank_wdata[0][5]
+ CK=CTS_301
Xbank_mem_0_reg[13][4] QDFFN $PINS Q=bank_mem_0[13][4] D=bank_wdata[0][4]
+ CK=CTS_301
Xbank_mem_0_reg[13][3] QDFFN $PINS Q=bank_mem_0[13][3]
+ D=FE_PHN2048_bank_wdata_0_3 CK=CTS_301
Xbank_mem_0_reg[13][2] QDFFN $PINS Q=bank_mem_0[13][2] D=bank_wdata[0][2]
+ CK=CTS_301
Xbank_mem_0_reg[13][1] QDFFN $PINS Q=bank_mem_0[13][1] D=bank_wdata[0][1]
+ CK=CTS_301
Xbank_mem_0_reg[13][0] QDFFN $PINS Q=bank_mem_0[13][0] D=bank_wdata[0][0]
+ CK=CTS_301
Xbank_mem_1_reg[14][21] QDFFN $PINS Q=bank_mem_1[14][21]
+ D=FE_PHN1856_bank_wdata_1_21 CK=CTS_346
Xbank_mem_1_reg[12][21] QDFFN $PINS Q=bank_mem_1[12][21]
+ D=FE_PHN1856_bank_wdata_1_21 CK=CTS_352
Xbank_mem_1_reg[0][21] QDFFN $PINS Q=bank_mem_1[0][21]
+ D=FE_PHN1856_bank_wdata_1_21 CK=CTS_388
Xbank_mem_1_reg[0][20] QDFFN $PINS Q=bank_mem_1[0][20] D=bank_wdata[1][20]
+ CK=CTS_388
Xbank_mem_1_reg[0][19] QDFFN $PINS Q=bank_mem_1[0][19]
+ D=FE_PHN1853_bank_wdata_1_19 CK=CTS_388
Xbank_mem_1_reg[0][18] QDFFN $PINS Q=bank_mem_1[0][18]
+ D=FE_PHN1890_bank_wdata_1_18 CK=CTS_388
Xbank_mem_1_reg[0][17] QDFFN $PINS Q=bank_mem_1[0][17]
+ D=FE_PHN1841_bank_wdata_1_17 CK=CTS_388
Xbank_mem_1_reg[0][16] QDFFN $PINS Q=bank_mem_1[0][16] D=bank_wdata[1][16]
+ CK=CTS_388
Xbank_mem_1_reg[0][15] QDFFN $PINS Q=bank_mem_1[0][15] D=bank_wdata[1][15]
+ CK=CTS_388
Xbank_mem_1_reg[0][14] QDFFN $PINS Q=bank_mem_1[0][14] D=bank_wdata[1][14]
+ CK=CTS_388
Xbank_mem_1_reg[0][13] QDFFN $PINS Q=bank_mem_1[0][13]
+ D=FE_PHN1828_bank_wdata_1_13 CK=CTS_388
Xbank_mem_1_reg[0][12] QDFFN $PINS Q=bank_mem_1[0][12]
+ D=FE_PHN1824_bank_wdata_1_12 CK=CTS_388
Xbank_mem_1_reg[0][11] QDFFN $PINS Q=bank_mem_1[0][11]
+ D=FE_PHN1821_bank_wdata_1_11 CK=CTS_388
Xbank_mem_1_reg[0][10] QDFFN $PINS Q=bank_mem_1[0][10]
+ D=FE_PHN1894_bank_wdata_1_10 CK=CTS_388
Xbank_mem_1_reg[0][9] QDFFN $PINS Q=bank_mem_1[0][9] D=bank_wdata[1][9]
+ CK=CTS_388
Xbank_mem_1_reg[0][8] QDFFN $PINS Q=bank_mem_1[0][8]
+ D=FE_PHN2009_bank_wdata_1_8 CK=CTS_388
Xbank_mem_1_reg[0][7] QDFFN $PINS Q=bank_mem_1[0][7] D=bank_wdata[1][7]
+ CK=CTS_388
Xbank_mem_1_reg[0][6] QDFFN $PINS Q=bank_mem_1[0][6] D=bank_wdata[1][6]
+ CK=CTS_388
Xbank_mem_1_reg[0][5] QDFFN $PINS Q=bank_mem_1[0][5] D=bank_wdata[1][5]
+ CK=CTS_388
Xbank_mem_1_reg[0][4] QDFFN $PINS Q=bank_mem_1[0][4]
+ D=FE_PHN2015_bank_wdata_1_4 CK=CTS_388
Xbank_mem_1_reg[0][3] QDFFN $PINS Q=bank_mem_1[0][3] D=bank_wdata[1][3]
+ CK=CTS_388
Xbank_mem_1_reg[0][2] QDFFN $PINS Q=bank_mem_1[0][2]
+ D=FE_PHN1895_bank_wdata_1_2 CK=CTS_388
Xbank_mem_1_reg[0][1] QDFFN $PINS Q=bank_mem_1[0][1] D=bank_wdata[1][1]
+ CK=CTS_388
Xbank_mem_1_reg[0][0] QDFFN $PINS Q=bank_mem_1[0][0]
+ D=FE_PHN1837_bank_wdata_1_0 CK=CTS_388
Xbank_mem_0_reg[14][20] QDFFN $PINS Q=bank_mem_0[14][20] D=bank_wdata[0][20]
+ CK=CTS_298
Xbank_mem_0_reg[14][19] QDFFN $PINS Q=bank_mem_0[14][19] D=bank_wdata[0][19]
+ CK=CTS_298
Xbank_mem_0_reg[14][18] QDFFN $PINS Q=bank_mem_0[14][18] D=bank_wdata[0][18]
+ CK=CTS_298
Xbank_mem_0_reg[14][17] QDFFN $PINS Q=bank_mem_0[14][17] D=bank_wdata[0][17]
+ CK=CTS_298
Xbank_mem_0_reg[14][16] QDFFN $PINS Q=bank_mem_0[14][16]
+ D=FE_PHN2039_bank_wdata_0_16 CK=CTS_298
Xbank_mem_0_reg[14][15] QDFFN $PINS Q=bank_mem_0[14][15] D=bank_wdata[0][15]
+ CK=CTS_298
Xbank_mem_0_reg[14][14] QDFFN $PINS Q=bank_mem_0[14][14] D=bank_wdata[0][14]
+ CK=CTS_298
Xbank_mem_0_reg[14][13] QDFFN $PINS Q=bank_mem_0[14][13] D=bank_wdata[0][13]
+ CK=CTS_298
Xbank_mem_0_reg[14][12] QDFFN $PINS Q=bank_mem_0[14][12] D=bank_wdata[0][12]
+ CK=CTS_298
Xbank_mem_0_reg[14][11] QDFFN $PINS Q=bank_mem_0[14][11]
+ D=FE_PHN1829_bank_wdata_0_11 CK=CTS_298
Xbank_mem_0_reg[14][10] QDFFN $PINS Q=bank_mem_0[14][10] D=bank_wdata[0][10]
+ CK=CTS_298
Xbank_mem_0_reg[14][9] QDFFN $PINS Q=bank_mem_0[14][9] D=bank_wdata[0][9]
+ CK=CTS_298
Xbank_mem_0_reg[14][8] QDFFN $PINS Q=bank_mem_0[14][8] D=bank_wdata[0][8]
+ CK=CTS_298
Xbank_mem_0_reg[14][7] QDFFN $PINS Q=bank_mem_0[14][7]
+ D=FE_PHN2053_bank_wdata_0_7 CK=CTS_298
Xbank_mem_0_reg[14][6] QDFFN $PINS Q=bank_mem_0[14][6] D=bank_wdata[0][6]
+ CK=CTS_298
Xbank_mem_0_reg[14][5] QDFFN $PINS Q=bank_mem_0[14][5] D=bank_wdata[0][5]
+ CK=CTS_298
Xbank_mem_0_reg[14][4] QDFFN $PINS Q=bank_mem_0[14][4] D=bank_wdata[0][4]
+ CK=CTS_298
Xbank_mem_0_reg[14][3] QDFFN $PINS Q=bank_mem_0[14][3]
+ D=FE_PHN2048_bank_wdata_0_3 CK=CTS_298
Xbank_mem_0_reg[14][2] QDFFN $PINS Q=bank_mem_0[14][2] D=bank_wdata[0][2]
+ CK=CTS_298
Xbank_mem_0_reg[14][1] QDFFN $PINS Q=bank_mem_0[14][1] D=bank_wdata[0][1]
+ CK=CTS_298
Xbank_mem_0_reg[14][0] QDFFN $PINS Q=bank_mem_0[14][0] D=bank_wdata[0][0]
+ CK=CTS_298
Xbank_mem_0_reg[15][21] QDFFN $PINS Q=bank_mem_0[15][21] D=bank_wdata[0][21]
+ CK=CTS_295
Xbank_mem_0_reg[12][20] QDFFN $PINS Q=bank_mem_0[12][20] D=bank_wdata[0][20]
+ CK=CTS_304
Xbank_mem_0_reg[12][19] QDFFN $PINS Q=bank_mem_0[12][19] D=bank_wdata[0][19]
+ CK=CTS_304
Xbank_mem_0_reg[12][18] QDFFN $PINS Q=bank_mem_0[12][18] D=bank_wdata[0][18]
+ CK=CTS_304
Xbank_mem_0_reg[12][17] QDFFN $PINS Q=bank_mem_0[12][17] D=bank_wdata[0][17]
+ CK=CTS_304
Xbank_mem_0_reg[12][16] QDFFN $PINS Q=bank_mem_0[12][16]
+ D=FE_PHN2039_bank_wdata_0_16 CK=CTS_304
Xbank_mem_0_reg[12][15] QDFFN $PINS Q=bank_mem_0[12][15] D=bank_wdata[0][15]
+ CK=CTS_304
Xbank_mem_0_reg[12][14] QDFFN $PINS Q=bank_mem_0[12][14] D=bank_wdata[0][14]
+ CK=CTS_304
Xbank_mem_0_reg[12][13] QDFFN $PINS Q=bank_mem_0[12][13] D=bank_wdata[0][13]
+ CK=CTS_304
Xbank_mem_0_reg[12][12] QDFFN $PINS Q=bank_mem_0[12][12] D=bank_wdata[0][12]
+ CK=CTS_304
Xbank_mem_0_reg[12][11] QDFFN $PINS Q=bank_mem_0[12][11]
+ D=FE_PHN1829_bank_wdata_0_11 CK=CTS_304
Xbank_mem_0_reg[12][10] QDFFN $PINS Q=bank_mem_0[12][10] D=bank_wdata[0][10]
+ CK=CTS_304
Xbank_mem_0_reg[12][9] QDFFN $PINS Q=bank_mem_0[12][9] D=bank_wdata[0][9]
+ CK=CTS_304
Xbank_mem_0_reg[12][8] QDFFN $PINS Q=bank_mem_0[12][8] D=bank_wdata[0][8]
+ CK=CTS_304
Xbank_mem_0_reg[12][7] QDFFN $PINS Q=bank_mem_0[12][7]
+ D=FE_PHN2053_bank_wdata_0_7 CK=CTS_304
Xbank_mem_0_reg[12][6] QDFFN $PINS Q=bank_mem_0[12][6] D=bank_wdata[0][6]
+ CK=CTS_304
Xbank_mem_0_reg[12][5] QDFFN $PINS Q=bank_mem_0[12][5] D=bank_wdata[0][5]
+ CK=CTS_304
Xbank_mem_0_reg[12][4] QDFFN $PINS Q=bank_mem_0[12][4] D=bank_wdata[0][4]
+ CK=CTS_304
Xbank_mem_0_reg[12][3] QDFFN $PINS Q=bank_mem_0[12][3]
+ D=FE_PHN2048_bank_wdata_0_3 CK=CTS_304
Xbank_mem_0_reg[12][2] QDFFN $PINS Q=bank_mem_0[12][2] D=bank_wdata[0][2]
+ CK=CTS_304
Xbank_mem_0_reg[12][1] QDFFN $PINS Q=bank_mem_0[12][1] D=bank_wdata[0][1]
+ CK=CTS_304
Xbank_mem_0_reg[12][0] QDFFN $PINS Q=bank_mem_0[12][0] D=bank_wdata[0][0]
+ CK=CTS_304
Xbank_mem_0_reg[13][21] QDFFN $PINS Q=bank_mem_0[13][21] D=bank_wdata[0][21]
+ CK=CTS_301
Xbank_mem_1_reg[1][21] QDFFN $PINS Q=bank_mem_1[1][21]
+ D=FE_PHN1856_bank_wdata_1_21 CK=CTS_385
Xbank_mem_1_reg[1][20] QDFFN $PINS Q=bank_mem_1[1][20] D=bank_wdata[1][20]
+ CK=CTS_385
Xbank_mem_1_reg[1][19] QDFFN $PINS Q=bank_mem_1[1][19]
+ D=FE_PHN1853_bank_wdata_1_19 CK=CTS_385
Xbank_mem_1_reg[1][18] QDFFN $PINS Q=bank_mem_1[1][18]
+ D=FE_PHN1890_bank_wdata_1_18 CK=CTS_385
Xbank_mem_1_reg[1][17] QDFFN $PINS Q=bank_mem_1[1][17]
+ D=FE_PHN1841_bank_wdata_1_17 CK=CTS_385
Xbank_mem_1_reg[1][16] QDFFN $PINS Q=bank_mem_1[1][16] D=bank_wdata[1][16]
+ CK=CTS_385
Xbank_mem_1_reg[1][15] QDFFN $PINS Q=bank_mem_1[1][15] D=bank_wdata[1][15]
+ CK=CTS_385
Xbank_mem_1_reg[1][14] QDFFN $PINS Q=bank_mem_1[1][14] D=bank_wdata[1][14]
+ CK=CTS_385
Xbank_mem_1_reg[1][13] QDFFN $PINS Q=bank_mem_1[1][13]
+ D=FE_PHN1828_bank_wdata_1_13 CK=CTS_385
Xbank_mem_1_reg[1][12] QDFFN $PINS Q=bank_mem_1[1][12]
+ D=FE_PHN1824_bank_wdata_1_12 CK=CTS_385
Xbank_mem_1_reg[1][11] QDFFN $PINS Q=bank_mem_1[1][11]
+ D=FE_PHN1821_bank_wdata_1_11 CK=CTS_385
Xbank_mem_1_reg[1][10] QDFFN $PINS Q=bank_mem_1[1][10]
+ D=FE_PHN1894_bank_wdata_1_10 CK=CTS_385
Xbank_mem_1_reg[1][9] QDFFN $PINS Q=bank_mem_1[1][9] D=bank_wdata[1][9]
+ CK=CTS_385
Xbank_mem_1_reg[1][8] QDFFN $PINS Q=bank_mem_1[1][8]
+ D=FE_PHN2009_bank_wdata_1_8 CK=CTS_385
Xbank_mem_1_reg[1][7] QDFFN $PINS Q=bank_mem_1[1][7] D=bank_wdata[1][7]
+ CK=CTS_385
Xbank_mem_1_reg[1][6] QDFFN $PINS Q=bank_mem_1[1][6] D=bank_wdata[1][6]
+ CK=CTS_385
Xbank_mem_1_reg[1][5] QDFFN $PINS Q=bank_mem_1[1][5] D=bank_wdata[1][5]
+ CK=CTS_385
Xbank_mem_1_reg[1][4] QDFFN $PINS Q=bank_mem_1[1][4]
+ D=FE_PHN2015_bank_wdata_1_4 CK=CTS_385
Xbank_mem_1_reg[1][3] QDFFN $PINS Q=bank_mem_1[1][3] D=bank_wdata[1][3]
+ CK=CTS_385
Xbank_mem_1_reg[1][2] QDFFN $PINS Q=bank_mem_1[1][2]
+ D=FE_PHN1895_bank_wdata_1_2 CK=CTS_385
Xbank_mem_1_reg[1][1] QDFFN $PINS Q=bank_mem_1[1][1] D=bank_wdata[1][1]
+ CK=CTS_385
Xbank_mem_1_reg[1][0] QDFFN $PINS Q=bank_mem_1[1][0]
+ D=FE_PHN1837_bank_wdata_1_0 CK=CTS_385
Xbank_mem_0_reg[14][21] QDFFN $PINS Q=bank_mem_0[14][21] D=bank_wdata[0][21]
+ CK=CTS_298
Xbank_mem_0_reg[12][21] QDFFN $PINS Q=bank_mem_0[12][21] D=bank_wdata[0][21]
+ CK=CTS_304
Xbank_mem_0_reg[0][21] QDFFN $PINS Q=bank_mem_0[0][21] D=bank_wdata[0][21]
+ CK=CTS_340
Xbank_mem_0_reg[0][20] QDFFN $PINS Q=bank_mem_0[0][20] D=bank_wdata[0][20]
+ CK=CTS_340
Xbank_mem_0_reg[0][19] QDFFN $PINS Q=bank_mem_0[0][19] D=bank_wdata[0][19]
+ CK=CTS_340
Xbank_mem_0_reg[0][18] QDFFN $PINS Q=bank_mem_0[0][18] D=bank_wdata[0][18]
+ CK=CTS_340
Xbank_mem_0_reg[0][17] QDFFN $PINS Q=bank_mem_0[0][17] D=bank_wdata[0][17]
+ CK=CTS_340
Xbank_mem_0_reg[0][16] QDFFN $PINS Q=bank_mem_0[0][16]
+ D=FE_PHN2039_bank_wdata_0_16 CK=CTS_340
Xbank_mem_0_reg[0][15] QDFFN $PINS Q=bank_mem_0[0][15] D=bank_wdata[0][15]
+ CK=CTS_340
Xbank_mem_0_reg[0][14] QDFFN $PINS Q=bank_mem_0[0][14] D=bank_wdata[0][14]
+ CK=CTS_340
Xbank_mem_0_reg[0][13] QDFFN $PINS Q=bank_mem_0[0][13] D=bank_wdata[0][13]
+ CK=CTS_340
Xbank_mem_0_reg[0][12] QDFFN $PINS Q=bank_mem_0[0][12] D=bank_wdata[0][12]
+ CK=CTS_340
Xbank_mem_0_reg[0][11] QDFFN $PINS Q=bank_mem_0[0][11]
+ D=FE_PHN1829_bank_wdata_0_11 CK=CTS_340
Xbank_mem_0_reg[0][10] QDFFN $PINS Q=bank_mem_0[0][10] D=bank_wdata[0][10]
+ CK=CTS_340
Xbank_mem_0_reg[0][9] QDFFN $PINS Q=bank_mem_0[0][9] D=bank_wdata[0][9]
+ CK=CTS_340
Xbank_mem_0_reg[0][8] QDFFN $PINS Q=bank_mem_0[0][8] D=bank_wdata[0][8]
+ CK=CTS_340
Xbank_mem_0_reg[0][7] QDFFN $PINS Q=bank_mem_0[0][7]
+ D=FE_PHN2053_bank_wdata_0_7 CK=CTS_340
Xbank_mem_0_reg[0][6] QDFFN $PINS Q=bank_mem_0[0][6] D=bank_wdata[0][6]
+ CK=CTS_340
Xbank_mem_0_reg[0][5] QDFFN $PINS Q=bank_mem_0[0][5] D=bank_wdata[0][5]
+ CK=CTS_340
Xbank_mem_0_reg[0][4] QDFFN $PINS Q=bank_mem_0[0][4] D=bank_wdata[0][4]
+ CK=CTS_340
Xbank_mem_0_reg[0][3] QDFFN $PINS Q=bank_mem_0[0][3]
+ D=FE_PHN2048_bank_wdata_0_3 CK=CTS_340
Xbank_mem_0_reg[0][2] QDFFN $PINS Q=bank_mem_0[0][2] D=bank_wdata[0][2]
+ CK=CTS_340
Xbank_mem_0_reg[0][1] QDFFN $PINS Q=bank_mem_0[0][1] D=bank_wdata[0][1]
+ CK=CTS_340
Xbank_mem_0_reg[0][0] QDFFN $PINS Q=bank_mem_0[0][0] D=bank_wdata[0][0]
+ CK=CTS_340
Xbank_mem_0_reg[1][21] QDFFN $PINS Q=bank_mem_0[1][21] D=bank_wdata[0][21]
+ CK=CTS_337
Xbank_mem_0_reg[1][20] QDFFN $PINS Q=bank_mem_0[1][20] D=bank_wdata[0][20]
+ CK=CTS_337
Xbank_mem_0_reg[1][19] QDFFN $PINS Q=bank_mem_0[1][19] D=bank_wdata[0][19]
+ CK=CTS_337
Xbank_mem_0_reg[1][18] QDFFN $PINS Q=bank_mem_0[1][18] D=bank_wdata[0][18]
+ CK=CTS_337
Xbank_mem_0_reg[1][17] QDFFN $PINS Q=bank_mem_0[1][17] D=bank_wdata[0][17]
+ CK=CTS_337
Xbank_mem_0_reg[1][16] QDFFN $PINS Q=bank_mem_0[1][16]
+ D=FE_PHN2039_bank_wdata_0_16 CK=CTS_337
Xbank_mem_0_reg[1][15] QDFFN $PINS Q=bank_mem_0[1][15] D=bank_wdata[0][15]
+ CK=CTS_337
Xbank_mem_0_reg[1][14] QDFFN $PINS Q=bank_mem_0[1][14] D=bank_wdata[0][14]
+ CK=CTS_337
Xbank_mem_0_reg[1][13] QDFFN $PINS Q=bank_mem_0[1][13] D=bank_wdata[0][13]
+ CK=CTS_337
Xbank_mem_0_reg[1][12] QDFFN $PINS Q=bank_mem_0[1][12] D=bank_wdata[0][12]
+ CK=CTS_337
Xbank_mem_0_reg[1][11] QDFFN $PINS Q=bank_mem_0[1][11]
+ D=FE_PHN1829_bank_wdata_0_11 CK=CTS_337
Xbank_mem_0_reg[1][10] QDFFN $PINS Q=bank_mem_0[1][10] D=bank_wdata[0][10]
+ CK=CTS_337
Xbank_mem_0_reg[1][9] QDFFN $PINS Q=bank_mem_0[1][9] D=bank_wdata[0][9]
+ CK=CTS_337
Xbank_mem_0_reg[1][8] QDFFN $PINS Q=bank_mem_0[1][8] D=bank_wdata[0][8]
+ CK=CTS_337
Xbank_mem_0_reg[1][7] QDFFN $PINS Q=bank_mem_0[1][7]
+ D=FE_PHN2053_bank_wdata_0_7 CK=CTS_337
Xbank_mem_0_reg[1][6] QDFFN $PINS Q=bank_mem_0[1][6] D=bank_wdata[0][6]
+ CK=CTS_337
Xbank_mem_0_reg[1][5] QDFFN $PINS Q=bank_mem_0[1][5] D=bank_wdata[0][5]
+ CK=CTS_337
Xbank_mem_0_reg[1][4] QDFFN $PINS Q=bank_mem_0[1][4] D=bank_wdata[0][4]
+ CK=CTS_337
Xbank_mem_0_reg[1][3] QDFFN $PINS Q=bank_mem_0[1][3]
+ D=FE_PHN2048_bank_wdata_0_3 CK=CTS_337
Xbank_mem_0_reg[1][2] QDFFN $PINS Q=bank_mem_0[1][2] D=bank_wdata[0][2]
+ CK=CTS_337
Xbank_mem_0_reg[1][1] QDFFN $PINS Q=bank_mem_0[1][1] D=bank_wdata[0][1]
+ CK=CTS_337
Xbank_mem_0_reg[1][0] QDFFN $PINS Q=bank_mem_0[1][0] D=bank_wdata[0][0]
+ CK=CTS_337
Xbank_mem_1_reg[9][20] QDFFN $PINS Q=bank_mem_1[9][20] D=bank_wdata[1][20]
+ CK=CTS_361
Xbank_mem_1_reg[9][19] QDFFN $PINS Q=bank_mem_1[9][19]
+ D=FE_PHN1853_bank_wdata_1_19 CK=CTS_361
Xbank_mem_1_reg[9][18] QDFFN $PINS Q=bank_mem_1[9][18]
+ D=FE_PHN1890_bank_wdata_1_18 CK=CTS_361
Xbank_mem_1_reg[9][17] QDFFN $PINS Q=bank_mem_1[9][17]
+ D=FE_PHN1841_bank_wdata_1_17 CK=CTS_361
Xbank_mem_1_reg[9][16] QDFFN $PINS Q=bank_mem_1[9][16] D=bank_wdata[1][16]
+ CK=CTS_361
Xbank_mem_1_reg[9][15] QDFFN $PINS Q=bank_mem_1[9][15] D=bank_wdata[1][15]
+ CK=CTS_361
Xbank_mem_1_reg[9][14] QDFFN $PINS Q=bank_mem_1[9][14] D=bank_wdata[1][14]
+ CK=CTS_361
Xbank_mem_1_reg[9][13] QDFFN $PINS Q=bank_mem_1[9][13]
+ D=FE_PHN1828_bank_wdata_1_13 CK=CTS_361
Xbank_mem_1_reg[9][12] QDFFN $PINS Q=bank_mem_1[9][12]
+ D=FE_PHN1824_bank_wdata_1_12 CK=CTS_361
Xbank_mem_1_reg[9][11] QDFFN $PINS Q=bank_mem_1[9][11]
+ D=FE_PHN1821_bank_wdata_1_11 CK=CTS_361
Xbank_mem_1_reg[9][10] QDFFN $PINS Q=bank_mem_1[9][10]
+ D=FE_PHN1894_bank_wdata_1_10 CK=CTS_361
Xbank_mem_1_reg[9][9] QDFFN $PINS Q=bank_mem_1[9][9] D=bank_wdata[1][9]
+ CK=CTS_361
Xbank_mem_1_reg[9][8] QDFFN $PINS Q=bank_mem_1[9][8]
+ D=FE_PHN2009_bank_wdata_1_8 CK=CTS_361
Xbank_mem_1_reg[9][7] QDFFN $PINS Q=bank_mem_1[9][7] D=bank_wdata[1][7]
+ CK=CTS_361
Xbank_mem_1_reg[9][6] QDFFN $PINS Q=bank_mem_1[9][6] D=bank_wdata[1][6]
+ CK=CTS_361
Xbank_mem_1_reg[9][5] QDFFN $PINS Q=bank_mem_1[9][5] D=bank_wdata[1][5]
+ CK=CTS_361
Xbank_mem_1_reg[9][4] QDFFN $PINS Q=bank_mem_1[9][4]
+ D=FE_PHN2015_bank_wdata_1_4 CK=CTS_361
Xbank_mem_1_reg[9][3] QDFFN $PINS Q=bank_mem_1[9][3] D=bank_wdata[1][3]
+ CK=CTS_361
Xbank_mem_1_reg[9][2] QDFFN $PINS Q=bank_mem_1[9][2]
+ D=FE_PHN1895_bank_wdata_1_2 CK=CTS_361
Xbank_mem_1_reg[9][1] QDFFN $PINS Q=bank_mem_1[9][1] D=bank_wdata[1][1]
+ CK=CTS_361
Xbank_mem_1_reg[9][0] QDFFN $PINS Q=bank_mem_1[9][0]
+ D=FE_PHN1837_bank_wdata_1_0 CK=CTS_361
Xbank_mem_1_reg[11][20] QDFFN $PINS Q=bank_mem_1[11][20] D=bank_wdata[1][20]
+ CK=CTS_355
Xbank_mem_1_reg[11][19] QDFFN $PINS Q=bank_mem_1[11][19]
+ D=FE_PHN1853_bank_wdata_1_19 CK=CTS_355
Xbank_mem_1_reg[11][18] QDFFN $PINS Q=bank_mem_1[11][18]
+ D=FE_PHN1890_bank_wdata_1_18 CK=CTS_355
Xbank_mem_1_reg[11][17] QDFFN $PINS Q=bank_mem_1[11][17]
+ D=FE_PHN1841_bank_wdata_1_17 CK=CTS_355
Xbank_mem_1_reg[11][16] QDFFN $PINS Q=bank_mem_1[11][16] D=bank_wdata[1][16]
+ CK=CTS_355
Xbank_mem_1_reg[11][15] QDFFN $PINS Q=bank_mem_1[11][15] D=bank_wdata[1][15]
+ CK=CTS_355
Xbank_mem_1_reg[11][14] QDFFN $PINS Q=bank_mem_1[11][14] D=bank_wdata[1][14]
+ CK=CTS_355
Xbank_mem_1_reg[11][13] QDFFN $PINS Q=bank_mem_1[11][13]
+ D=FE_PHN1828_bank_wdata_1_13 CK=CTS_355
Xbank_mem_1_reg[11][12] QDFFN $PINS Q=bank_mem_1[11][12]
+ D=FE_PHN1824_bank_wdata_1_12 CK=CTS_355
Xbank_mem_1_reg[11][11] QDFFN $PINS Q=bank_mem_1[11][11]
+ D=FE_PHN1821_bank_wdata_1_11 CK=CTS_355
Xbank_mem_1_reg[11][10] QDFFN $PINS Q=bank_mem_1[11][10]
+ D=FE_PHN1894_bank_wdata_1_10 CK=CTS_355
Xbank_mem_1_reg[11][9] QDFFN $PINS Q=bank_mem_1[11][9] D=bank_wdata[1][9]
+ CK=CTS_355
Xbank_mem_1_reg[11][8] QDFFN $PINS Q=bank_mem_1[11][8]
+ D=FE_PHN2009_bank_wdata_1_8 CK=CTS_355
Xbank_mem_1_reg[11][7] QDFFN $PINS Q=bank_mem_1[11][7] D=bank_wdata[1][7]
+ CK=CTS_355
Xbank_mem_1_reg[11][6] QDFFN $PINS Q=bank_mem_1[11][6] D=bank_wdata[1][6]
+ CK=CTS_355
Xbank_mem_1_reg[11][5] QDFFN $PINS Q=bank_mem_1[11][5] D=bank_wdata[1][5]
+ CK=CTS_355
Xbank_mem_1_reg[11][4] QDFFN $PINS Q=bank_mem_1[11][4]
+ D=FE_PHN2015_bank_wdata_1_4 CK=CTS_355
Xbank_mem_1_reg[11][3] QDFFN $PINS Q=bank_mem_1[11][3] D=bank_wdata[1][3]
+ CK=CTS_355
Xbank_mem_1_reg[11][2] QDFFN $PINS Q=bank_mem_1[11][2]
+ D=FE_PHN1895_bank_wdata_1_2 CK=CTS_355
Xbank_mem_1_reg[11][1] QDFFN $PINS Q=bank_mem_1[11][1] D=bank_wdata[1][1]
+ CK=CTS_355
Xbank_mem_1_reg[11][0] QDFFN $PINS Q=bank_mem_1[11][0]
+ D=FE_PHN1837_bank_wdata_1_0 CK=CTS_355
Xbank_mem_1_reg[8][20] QDFFN $PINS Q=bank_mem_1[8][20] D=bank_wdata[1][20]
+ CK=CTS_364
Xbank_mem_1_reg[8][19] QDFFN $PINS Q=bank_mem_1[8][19]
+ D=FE_PHN1853_bank_wdata_1_19 CK=CTS_364
Xbank_mem_1_reg[8][18] QDFFN $PINS Q=bank_mem_1[8][18]
+ D=FE_PHN1890_bank_wdata_1_18 CK=CTS_364
Xbank_mem_1_reg[8][17] QDFFN $PINS Q=bank_mem_1[8][17]
+ D=FE_PHN1841_bank_wdata_1_17 CK=CTS_364
Xbank_mem_1_reg[8][16] QDFFN $PINS Q=bank_mem_1[8][16] D=bank_wdata[1][16]
+ CK=CTS_364
Xbank_mem_1_reg[8][15] QDFFN $PINS Q=bank_mem_1[8][15] D=bank_wdata[1][15]
+ CK=CTS_364
Xbank_mem_1_reg[8][14] QDFFN $PINS Q=bank_mem_1[8][14] D=bank_wdata[1][14]
+ CK=CTS_364
Xbank_mem_1_reg[8][13] QDFFN $PINS Q=bank_mem_1[8][13]
+ D=FE_PHN1828_bank_wdata_1_13 CK=CTS_364
Xbank_mem_1_reg[8][12] QDFFN $PINS Q=bank_mem_1[8][12]
+ D=FE_PHN1824_bank_wdata_1_12 CK=CTS_364
Xbank_mem_1_reg[8][11] QDFFN $PINS Q=bank_mem_1[8][11]
+ D=FE_PHN1821_bank_wdata_1_11 CK=CTS_364
Xbank_mem_1_reg[8][10] QDFFN $PINS Q=bank_mem_1[8][10]
+ D=FE_PHN1894_bank_wdata_1_10 CK=CTS_364
Xbank_mem_1_reg[8][9] QDFFN $PINS Q=bank_mem_1[8][9] D=bank_wdata[1][9]
+ CK=CTS_364
Xbank_mem_1_reg[8][8] QDFFN $PINS Q=bank_mem_1[8][8]
+ D=FE_PHN2009_bank_wdata_1_8 CK=CTS_364
Xbank_mem_1_reg[8][7] QDFFN $PINS Q=bank_mem_1[8][7] D=bank_wdata[1][7]
+ CK=CTS_364
Xbank_mem_1_reg[8][6] QDFFN $PINS Q=bank_mem_1[8][6] D=bank_wdata[1][6]
+ CK=CTS_364
Xbank_mem_1_reg[8][5] QDFFN $PINS Q=bank_mem_1[8][5] D=bank_wdata[1][5]
+ CK=CTS_364
Xbank_mem_1_reg[8][4] QDFFN $PINS Q=bank_mem_1[8][4]
+ D=FE_PHN2015_bank_wdata_1_4 CK=CTS_364
Xbank_mem_1_reg[8][3] QDFFN $PINS Q=bank_mem_1[8][3] D=bank_wdata[1][3]
+ CK=CTS_364
Xbank_mem_1_reg[8][2] QDFFN $PINS Q=bank_mem_1[8][2]
+ D=FE_PHN1895_bank_wdata_1_2 CK=CTS_364
Xbank_mem_1_reg[8][1] QDFFN $PINS Q=bank_mem_1[8][1] D=bank_wdata[1][1]
+ CK=CTS_364
Xbank_mem_1_reg[8][0] QDFFN $PINS Q=bank_mem_1[8][0]
+ D=FE_PHN1837_bank_wdata_1_0 CK=CTS_364
Xbank_mem_1_reg[9][21] QDFFN $PINS Q=bank_mem_1[9][21]
+ D=FE_PHN1856_bank_wdata_1_21 CK=CTS_361
Xbank_mem_1_reg[10][20] QDFFN $PINS Q=bank_mem_1[10][20] D=bank_wdata[1][20]
+ CK=CTS_358
Xbank_mem_1_reg[10][19] QDFFN $PINS Q=bank_mem_1[10][19]
+ D=FE_PHN1853_bank_wdata_1_19 CK=CTS_358
Xbank_mem_1_reg[10][18] QDFFN $PINS Q=bank_mem_1[10][18]
+ D=FE_PHN1890_bank_wdata_1_18 CK=CTS_358
Xbank_mem_1_reg[10][17] QDFFN $PINS Q=bank_mem_1[10][17]
+ D=FE_PHN1841_bank_wdata_1_17 CK=CTS_358
Xbank_mem_1_reg[10][16] QDFFN $PINS Q=bank_mem_1[10][16] D=bank_wdata[1][16]
+ CK=CTS_358
Xbank_mem_1_reg[10][15] QDFFN $PINS Q=bank_mem_1[10][15] D=bank_wdata[1][15]
+ CK=CTS_358
Xbank_mem_1_reg[10][14] QDFFN $PINS Q=bank_mem_1[10][14] D=bank_wdata[1][14]
+ CK=CTS_358
Xbank_mem_1_reg[10][13] QDFFN $PINS Q=bank_mem_1[10][13]
+ D=FE_PHN1828_bank_wdata_1_13 CK=CTS_358
Xbank_mem_1_reg[10][12] QDFFN $PINS Q=bank_mem_1[10][12]
+ D=FE_PHN1824_bank_wdata_1_12 CK=CTS_358
Xbank_mem_1_reg[10][11] QDFFN $PINS Q=bank_mem_1[10][11]
+ D=FE_PHN1821_bank_wdata_1_11 CK=CTS_358
Xbank_mem_1_reg[10][10] QDFFN $PINS Q=bank_mem_1[10][10]
+ D=FE_PHN1894_bank_wdata_1_10 CK=CTS_358
Xbank_mem_1_reg[10][9] QDFFN $PINS Q=bank_mem_1[10][9] D=bank_wdata[1][9]
+ CK=CTS_358
Xbank_mem_1_reg[10][8] QDFFN $PINS Q=bank_mem_1[10][8]
+ D=FE_PHN2009_bank_wdata_1_8 CK=CTS_358
Xbank_mem_1_reg[10][7] QDFFN $PINS Q=bank_mem_1[10][7] D=bank_wdata[1][7]
+ CK=CTS_358
Xbank_mem_1_reg[10][6] QDFFN $PINS Q=bank_mem_1[10][6] D=bank_wdata[1][6]
+ CK=CTS_358
Xbank_mem_1_reg[10][5] QDFFN $PINS Q=bank_mem_1[10][5] D=bank_wdata[1][5]
+ CK=CTS_358
Xbank_mem_1_reg[10][4] QDFFN $PINS Q=bank_mem_1[10][4]
+ D=FE_PHN2015_bank_wdata_1_4 CK=CTS_358
Xbank_mem_1_reg[10][3] QDFFN $PINS Q=bank_mem_1[10][3] D=bank_wdata[1][3]
+ CK=CTS_358
Xbank_mem_1_reg[10][2] QDFFN $PINS Q=bank_mem_1[10][2]
+ D=FE_PHN1895_bank_wdata_1_2 CK=CTS_358
Xbank_mem_1_reg[10][1] QDFFN $PINS Q=bank_mem_1[10][1] D=bank_wdata[1][1]
+ CK=CTS_358
Xbank_mem_1_reg[10][0] QDFFN $PINS Q=bank_mem_1[10][0]
+ D=FE_PHN1837_bank_wdata_1_0 CK=CTS_358
Xbank_mem_1_reg[11][21] QDFFN $PINS Q=bank_mem_1[11][21]
+ D=FE_PHN1856_bank_wdata_1_21 CK=CTS_355
Xbank_mem_0_reg[9][20] QDFFN $PINS Q=bank_mem_0[9][20] D=bank_wdata[0][20]
+ CK=CTS_313
Xbank_mem_0_reg[9][19] QDFFN $PINS Q=bank_mem_0[9][19] D=bank_wdata[0][19]
+ CK=CTS_313
Xbank_mem_0_reg[9][18] QDFFN $PINS Q=bank_mem_0[9][18] D=bank_wdata[0][18]
+ CK=CTS_313
Xbank_mem_0_reg[9][17] QDFFN $PINS Q=bank_mem_0[9][17] D=bank_wdata[0][17]
+ CK=CTS_313
Xbank_mem_0_reg[9][16] QDFFN $PINS Q=bank_mem_0[9][16]
+ D=FE_PHN2039_bank_wdata_0_16 CK=CTS_313
Xbank_mem_0_reg[9][15] QDFFN $PINS Q=bank_mem_0[9][15] D=bank_wdata[0][15]
+ CK=CTS_313
Xbank_mem_0_reg[9][14] QDFFN $PINS Q=bank_mem_0[9][14] D=bank_wdata[0][14]
+ CK=CTS_313
Xbank_mem_0_reg[9][13] QDFFN $PINS Q=bank_mem_0[9][13] D=bank_wdata[0][13]
+ CK=CTS_313
Xbank_mem_0_reg[9][12] QDFFN $PINS Q=bank_mem_0[9][12] D=bank_wdata[0][12]
+ CK=CTS_313
Xbank_mem_0_reg[9][11] QDFFN $PINS Q=bank_mem_0[9][11]
+ D=FE_PHN1829_bank_wdata_0_11 CK=CTS_313
Xbank_mem_0_reg[9][10] QDFFN $PINS Q=bank_mem_0[9][10] D=bank_wdata[0][10]
+ CK=CTS_313
Xbank_mem_0_reg[9][9] QDFFN $PINS Q=bank_mem_0[9][9] D=bank_wdata[0][9]
+ CK=CTS_313
Xbank_mem_0_reg[9][8] QDFFN $PINS Q=bank_mem_0[9][8] D=bank_wdata[0][8]
+ CK=CTS_313
Xbank_mem_0_reg[9][7] QDFFN $PINS Q=bank_mem_0[9][7]
+ D=FE_PHN2053_bank_wdata_0_7 CK=CTS_313
Xbank_mem_0_reg[9][6] QDFFN $PINS Q=bank_mem_0[9][6] D=bank_wdata[0][6]
+ CK=CTS_313
Xbank_mem_0_reg[9][5] QDFFN $PINS Q=bank_mem_0[9][5] D=bank_wdata[0][5]
+ CK=CTS_313
Xbank_mem_0_reg[9][4] QDFFN $PINS Q=bank_mem_0[9][4] D=bank_wdata[0][4]
+ CK=CTS_313
Xbank_mem_0_reg[9][3] QDFFN $PINS Q=bank_mem_0[9][3]
+ D=FE_PHN2048_bank_wdata_0_3 CK=CTS_313
Xbank_mem_0_reg[9][2] QDFFN $PINS Q=bank_mem_0[9][2] D=bank_wdata[0][2]
+ CK=CTS_313
Xbank_mem_0_reg[9][1] QDFFN $PINS Q=bank_mem_0[9][1] D=bank_wdata[0][1]
+ CK=CTS_313
Xbank_mem_0_reg[9][0] QDFFN $PINS Q=bank_mem_0[9][0] D=bank_wdata[0][0]
+ CK=CTS_313
Xbank_mem_0_reg[11][20] QDFFN $PINS Q=bank_mem_0[11][20] D=bank_wdata[0][20]
+ CK=CTS_307
Xbank_mem_0_reg[11][19] QDFFN $PINS Q=bank_mem_0[11][19] D=bank_wdata[0][19]
+ CK=CTS_307
Xbank_mem_0_reg[11][18] QDFFN $PINS Q=bank_mem_0[11][18] D=bank_wdata[0][18]
+ CK=CTS_307
Xbank_mem_0_reg[11][17] QDFFN $PINS Q=bank_mem_0[11][17] D=bank_wdata[0][17]
+ CK=CTS_307
Xbank_mem_0_reg[11][16] QDFFN $PINS Q=bank_mem_0[11][16]
+ D=FE_PHN2039_bank_wdata_0_16 CK=CTS_307
Xbank_mem_0_reg[11][15] QDFFN $PINS Q=bank_mem_0[11][15] D=bank_wdata[0][15]
+ CK=CTS_307
Xbank_mem_0_reg[11][14] QDFFN $PINS Q=bank_mem_0[11][14] D=bank_wdata[0][14]
+ CK=CTS_307
Xbank_mem_0_reg[11][13] QDFFN $PINS Q=bank_mem_0[11][13] D=bank_wdata[0][13]
+ CK=CTS_307
Xbank_mem_0_reg[11][12] QDFFN $PINS Q=bank_mem_0[11][12] D=bank_wdata[0][12]
+ CK=CTS_307
Xbank_mem_0_reg[11][11] QDFFN $PINS Q=bank_mem_0[11][11]
+ D=FE_PHN1829_bank_wdata_0_11 CK=CTS_307
Xbank_mem_0_reg[11][10] QDFFN $PINS Q=bank_mem_0[11][10] D=bank_wdata[0][10]
+ CK=CTS_307
Xbank_mem_0_reg[11][9] QDFFN $PINS Q=bank_mem_0[11][9] D=bank_wdata[0][9]
+ CK=CTS_307
Xbank_mem_0_reg[11][8] QDFFN $PINS Q=bank_mem_0[11][8] D=bank_wdata[0][8]
+ CK=CTS_307
Xbank_mem_0_reg[11][7] QDFFN $PINS Q=bank_mem_0[11][7]
+ D=FE_PHN2053_bank_wdata_0_7 CK=CTS_307
Xbank_mem_0_reg[11][6] QDFFN $PINS Q=bank_mem_0[11][6] D=bank_wdata[0][6]
+ CK=CTS_307
Xbank_mem_0_reg[11][5] QDFFN $PINS Q=bank_mem_0[11][5] D=bank_wdata[0][5]
+ CK=CTS_307
Xbank_mem_0_reg[11][4] QDFFN $PINS Q=bank_mem_0[11][4] D=bank_wdata[0][4]
+ CK=CTS_307
Xbank_mem_0_reg[11][3] QDFFN $PINS Q=bank_mem_0[11][3]
+ D=FE_PHN2048_bank_wdata_0_3 CK=CTS_307
Xbank_mem_0_reg[11][2] QDFFN $PINS Q=bank_mem_0[11][2] D=bank_wdata[0][2]
+ CK=CTS_307
Xbank_mem_0_reg[11][1] QDFFN $PINS Q=bank_mem_0[11][1] D=bank_wdata[0][1]
+ CK=CTS_307
Xbank_mem_0_reg[11][0] QDFFN $PINS Q=bank_mem_0[11][0] D=bank_wdata[0][0]
+ CK=CTS_307
Xbank_mem_1_reg[8][21] QDFFN $PINS Q=bank_mem_1[8][21]
+ D=FE_PHN1856_bank_wdata_1_21 CK=CTS_364
Xbank_mem_1_reg[10][21] QDFFN $PINS Q=bank_mem_1[10][21]
+ D=FE_PHN1856_bank_wdata_1_21 CK=CTS_358
Xbank_mem_0_reg[8][20] QDFFN $PINS Q=bank_mem_0[8][20] D=bank_wdata[0][20]
+ CK=CTS_316
Xbank_mem_0_reg[8][19] QDFFN $PINS Q=bank_mem_0[8][19] D=bank_wdata[0][19]
+ CK=CTS_316
Xbank_mem_0_reg[8][18] QDFFN $PINS Q=bank_mem_0[8][18] D=bank_wdata[0][18]
+ CK=CTS_316
Xbank_mem_0_reg[8][17] QDFFN $PINS Q=bank_mem_0[8][17] D=bank_wdata[0][17]
+ CK=CTS_316
Xbank_mem_0_reg[8][16] QDFFN $PINS Q=bank_mem_0[8][16]
+ D=FE_PHN2039_bank_wdata_0_16 CK=CTS_316
Xbank_mem_0_reg[8][15] QDFFN $PINS Q=bank_mem_0[8][15] D=bank_wdata[0][15]
+ CK=CTS_316
Xbank_mem_0_reg[8][14] QDFFN $PINS Q=bank_mem_0[8][14] D=bank_wdata[0][14]
+ CK=CTS_316
Xbank_mem_0_reg[8][13] QDFFN $PINS Q=bank_mem_0[8][13] D=bank_wdata[0][13]
+ CK=CTS_316
Xbank_mem_0_reg[8][12] QDFFN $PINS Q=bank_mem_0[8][12] D=bank_wdata[0][12]
+ CK=CTS_316
Xbank_mem_0_reg[8][11] QDFFN $PINS Q=bank_mem_0[8][11]
+ D=FE_PHN1829_bank_wdata_0_11 CK=CTS_316
Xbank_mem_0_reg[8][10] QDFFN $PINS Q=bank_mem_0[8][10] D=bank_wdata[0][10]
+ CK=CTS_316
Xbank_mem_0_reg[8][9] QDFFN $PINS Q=bank_mem_0[8][9] D=bank_wdata[0][9]
+ CK=CTS_316
Xbank_mem_0_reg[8][8] QDFFN $PINS Q=bank_mem_0[8][8] D=bank_wdata[0][8]
+ CK=CTS_316
Xbank_mem_0_reg[8][7] QDFFN $PINS Q=bank_mem_0[8][7]
+ D=FE_PHN2053_bank_wdata_0_7 CK=CTS_316
Xbank_mem_0_reg[8][6] QDFFN $PINS Q=bank_mem_0[8][6] D=bank_wdata[0][6]
+ CK=CTS_316
Xbank_mem_0_reg[8][5] QDFFN $PINS Q=bank_mem_0[8][5] D=bank_wdata[0][5]
+ CK=CTS_316
Xbank_mem_0_reg[8][4] QDFFN $PINS Q=bank_mem_0[8][4] D=bank_wdata[0][4]
+ CK=CTS_316
Xbank_mem_0_reg[8][3] QDFFN $PINS Q=bank_mem_0[8][3]
+ D=FE_PHN2048_bank_wdata_0_3 CK=CTS_316
Xbank_mem_0_reg[8][2] QDFFN $PINS Q=bank_mem_0[8][2] D=bank_wdata[0][2]
+ CK=CTS_316
Xbank_mem_0_reg[8][1] QDFFN $PINS Q=bank_mem_0[8][1] D=bank_wdata[0][1]
+ CK=CTS_316
Xbank_mem_0_reg[8][0] QDFFN $PINS Q=bank_mem_0[8][0] D=bank_wdata[0][0]
+ CK=CTS_316
Xbank_mem_0_reg[9][21] QDFFN $PINS Q=bank_mem_0[9][21] D=bank_wdata[0][21]
+ CK=CTS_313
Xbank_mem_0_reg[10][20] QDFFN $PINS Q=bank_mem_0[10][20] D=bank_wdata[0][20]
+ CK=CTS_310
Xbank_mem_0_reg[10][19] QDFFN $PINS Q=bank_mem_0[10][19] D=bank_wdata[0][19]
+ CK=CTS_310
Xbank_mem_0_reg[10][18] QDFFN $PINS Q=bank_mem_0[10][18] D=bank_wdata[0][18]
+ CK=CTS_310
Xbank_mem_0_reg[10][17] QDFFN $PINS Q=bank_mem_0[10][17] D=bank_wdata[0][17]
+ CK=CTS_310
Xbank_mem_0_reg[10][16] QDFFN $PINS Q=bank_mem_0[10][16]
+ D=FE_PHN2039_bank_wdata_0_16 CK=CTS_310
Xbank_mem_0_reg[10][15] QDFFN $PINS Q=bank_mem_0[10][15] D=bank_wdata[0][15]
+ CK=CTS_310
Xbank_mem_0_reg[10][14] QDFFN $PINS Q=bank_mem_0[10][14] D=bank_wdata[0][14]
+ CK=CTS_310
Xbank_mem_0_reg[10][13] QDFFN $PINS Q=bank_mem_0[10][13] D=bank_wdata[0][13]
+ CK=CTS_310
Xbank_mem_0_reg[10][12] QDFFN $PINS Q=bank_mem_0[10][12] D=bank_wdata[0][12]
+ CK=CTS_310
Xbank_mem_0_reg[10][11] QDFFN $PINS Q=bank_mem_0[10][11]
+ D=FE_PHN1829_bank_wdata_0_11 CK=CTS_310
Xbank_mem_0_reg[10][10] QDFFN $PINS Q=bank_mem_0[10][10] D=bank_wdata[0][10]
+ CK=CTS_310
Xbank_mem_0_reg[10][9] QDFFN $PINS Q=bank_mem_0[10][9] D=bank_wdata[0][9]
+ CK=CTS_310
Xbank_mem_0_reg[10][8] QDFFN $PINS Q=bank_mem_0[10][8] D=bank_wdata[0][8]
+ CK=CTS_310
Xbank_mem_0_reg[10][7] QDFFN $PINS Q=bank_mem_0[10][7]
+ D=FE_PHN2053_bank_wdata_0_7 CK=CTS_310
Xbank_mem_0_reg[10][6] QDFFN $PINS Q=bank_mem_0[10][6] D=bank_wdata[0][6]
+ CK=CTS_310
Xbank_mem_0_reg[10][5] QDFFN $PINS Q=bank_mem_0[10][5] D=bank_wdata[0][5]
+ CK=CTS_310
Xbank_mem_0_reg[10][4] QDFFN $PINS Q=bank_mem_0[10][4] D=bank_wdata[0][4]
+ CK=CTS_310
Xbank_mem_0_reg[10][3] QDFFN $PINS Q=bank_mem_0[10][3]
+ D=FE_PHN2048_bank_wdata_0_3 CK=CTS_310
Xbank_mem_0_reg[10][2] QDFFN $PINS Q=bank_mem_0[10][2] D=bank_wdata[0][2]
+ CK=CTS_310
Xbank_mem_0_reg[10][1] QDFFN $PINS Q=bank_mem_0[10][1] D=bank_wdata[0][1]
+ CK=CTS_310
Xbank_mem_0_reg[10][0] QDFFN $PINS Q=bank_mem_0[10][0] D=bank_wdata[0][0]
+ CK=CTS_310
Xbank_mem_0_reg[11][21] QDFFN $PINS Q=bank_mem_0[11][21] D=bank_wdata[0][21]
+ CK=CTS_307
Xbank_mem_0_reg[8][21] QDFFN $PINS Q=bank_mem_0[8][21] D=bank_wdata[0][21]
+ CK=CTS_316
Xbank_mem_0_reg[10][21] QDFFN $PINS Q=bank_mem_0[10][21] D=bank_wdata[0][21]
+ CK=CTS_310
Xread_data_1_reg[21] QDFFRBN $PINS Q=read_data_1[21] D=N103 CK=clk_clone2
+ RB=i_rst_n
Xread_data_1_reg[20] QDFFRBN $PINS Q=read_data_1[20] D=FE_PHN1951_N104
+ CK=clk_clone2 RB=i_rst_n
Xread_data_1_reg[10] QDFFRBN $PINS Q=read_data_1[10] D=N114 CK=clk_clone2
+ RB=i_rst_n
Xread_data_1_reg[19] QDFFRBN $PINS Q=read_data_1[19] D=FE_PHN1882_N105
+ CK=clk_clone2 RB=i_rst_n
Xread_data_1_reg[7] QDFFRBN $PINS Q=read_data_1[7] D=FE_PHN1912_N117
+ CK=clk_clone2 RB=i_rst_n
Xread_data_1_reg[18] QDFFRBN $PINS Q=read_data_1[18] D=N106 CK=clk_clone2
+ RB=i_rst_n
Xread_data_1_reg[9] QDFFRBN $PINS Q=read_data_1[9] D=N115 CK=clk_clone2
+ RB=i_rst_n
Xread_data_1_reg[6] QDFFRBN $PINS Q=read_data_1[6] D=FE_PHN1901_N118
+ CK=clk_clone2 RB=i_rst_n
Xread_data_1_reg[17] QDFFRBN $PINS Q=read_data_1[17] D=FE_PHN1875_N107
+ CK=clk_clone2 RB=i_rst_n
Xread_data_1_reg[8] QDFFRBN $PINS Q=read_data_1[8] D=N116 CK=clk_clone2
+ RB=i_rst_n
Xread_data_1_reg[5] QDFFRBN $PINS Q=read_data_1[5] D=N119 CK=clk_clone2
+ RB=i_rst_n
Xread_data_1_reg[15] QDFFRBN $PINS Q=read_data_1[15] D=FE_PHN1899_N109
+ CK=clk_clone2 RB=i_rst_n
Xread_data_1_reg[14] QDFFRBN $PINS Q=read_data_1[14] D=FE_PHN1911_N110
+ CK=clk_clone2 RB=i_rst_n
Xread_data_1_reg[16] QDFFRBN $PINS Q=read_data_1[16] D=FE_PHN1913_N108
+ CK=clk_clone2 RB=i_rst_n
Xread_data_1_reg[4] QDFFRBN $PINS Q=read_data_1[4] D=N120 CK=clk_clone2
+ RB=i_rst_n
Xread_data_1_reg[13] QDFFRBP $PINS Q=read_data_1[13] D=FE_PHN1907_N111
+ CK=clk_clone2 RB=i_rst_n
Xread_data_1_reg[12] QDFFRBN $PINS Q=read_data_1[12] D=FE_PHN1923_N112
+ CK=clk_clone2 RB=i_rst_n
Xread_data_1_reg[1] QDFFRBN $PINS Q=read_data_1[1] D=FE_PHN1905_N123
+ CK=clk_clone2 RB=i_rst_n
Xread_data_1_reg[11] QDFFRBP $PINS Q=read_data_1[11] D=N113 CK=clk_clone2
+ RB=i_rst_n
Xread_data_1_reg[0] QDFFRBN $PINS Q=read_data_1[0] D=FE_PHN1959_N124
+ CK=clk_clone2 RB=i_rst_n
Xread_data_1_reg[3] QDFFRBN $PINS Q=read_data_1[3] D=N121 CK=clk_clone2
+ RB=i_rst_n
Xread_data_1_reg[2] QDFFRBN $PINS Q=read_data_1[2] D=N122 CK=clk_clone2
+ RB=i_rst_n
XU3 AN2 $PINS O=n1 I1=n18 I2=n309
XU4 AN2 $PINS O=n2 I1=n326 I2=n580
XU5 AN2 $PINS O=n3 I1=n17 I2=n309
XU6 AN2 $PINS O=n4 I1=n325 I2=n580
XU7 AN2 $PINS O=n5 I1=n19 I2=n20
XU8 AN2 $PINS O=n6 I1=n19 I2=n16
XU9 AN2 $PINS O=n7 I1=n327 I2=n328
XU10 AN2 $PINS O=n8 I1=n327 I2=n324
XU11 ND2S $PINS O=n89 I1=n647 I2=n87
XU14 ND2P $PINS O=n9 I1=wen2 I2=n93
XU15 NR2 $PINS O=N98 I1=n67 I2=n68
XU16 NR2 $PINS O=N96 I1=n67 I2=n69
XU17 NR2 $PINS O=N94 I1=n67 I2=n70
XU18 NR2 $PINS O=N92 I1=n66 I2=n73
XU19 NR2 $PINS O=N59 I1=n79 I2=n89
XU20 NR2 $PINS O=N100 I1=n66 I2=n67
XU21 NR2 $PINS O=N90 I1=n68 I2=n73
XU22 NR2 $PINS O=N57 I1=n81 I2=n89
XU23 NR2 $PINS O=N88 I1=n69 I2=n73
XU24 NR2 $PINS O=N86 I1=n70 I2=n73
XU25 NR2 $PINS O=N55 I1=n82 I2=n89
XU26 NR2 $PINS O=N53 I1=n83 I2=n89
XU27 NR2 $PINS O=N99 I1=n65 I2=n66
XU28 NR2 $PINS O=N97 I1=n65 I2=n68
XU29 NR2 $PINS O=N95 I1=n65 I2=n69
XU30 NR2 $PINS O=N93 I1=n65 I2=n70
XU31 NR2 $PINS O=N67 I1=n78 I2=n79
XU32 NR2 $PINS O=N65 I1=n78 I2=n81
XU33 NR2 $PINS O=N63 I1=n78 I2=n82
XU34 NR2 $PINS O=N61 I1=n78 I2=n83
XU35 NR2 $PINS O=N64 I1=n80 I2=n81
XU36 NR2 $PINS O=N62 I1=n80 I2=n82
XU37 NR2 $PINS O=N60 I1=n80 I2=n83
XU38 NR2 $PINS O=N91 I1=n66 I2=n74
XU39 NR2 $PINS O=N66 I1=n79 I2=n80
XU40 NR2 $PINS O=N58 I1=n79 I2=n90
XU41 NR2 $PINS O=N89 I1=n68 I2=n74
XU42 NR2 $PINS O=N56 I1=n81 I2=n90
XU43 NR2 $PINS O=N87 I1=n69 I2=n74
XU44 NR2 $PINS O=N85 I1=n70 I2=n74
XU45 NR2 $PINS O=N54 I1=n82 I2=n90
XU46 NR2 $PINS O=N52 I1=n83 I2=n90
XU47 INV1S $PINS O=n642 I=n75
XU48 INV1S $PINS O=n645 I=n91
XU49 INV1S $PINS O=n646 I=n92
XU50 INV1S $PINS O=n641 I=n76
XU53 OAI22S $PINS O=n87 A1=n654 A2=n63 B1=n651 B2=n64
XU54 OAI22S $PINS O=n77 A1=n654 A2=n9 B1=n651 B2=n62
XU55 OAI22S $PINS O=n92 A1=n652 A2=n63 B1=n650 B2=n64
XU56 OAI22S $PINS O=n76 A1=n652 A2=n9 B1=n650 B2=n62
XU57 OAI22S $PINS O=n75 A1=n653 A2=n9 B1=n649 B2=n62
XU58 OAI22S $PINS O=n91 A1=n653 A2=n63 B1=n649 B2=n64
XU59 ND3P $PINS O=n62 I1=n644 I2=n9 I3=wen1
XU60 AOI12HS $PINS O=n71 A1=n77 B1=n9 B2=n95
XU61 INV1S $PINS O=n647 I=n85
XU62 INV1S $PINS O=n643 I=n72
XU67 OAI22S $PINS O=n85 A1=p_1 A2=n63 B1=n648 B2=n64
XU68 OAI22S $PINS O=n72 A1=p_1 A2=n9 B1=n648 B2=n62
XU70 AOI12HS $PINS O=n84 A1=n87 B1=n63 B2=n86
XU71 INV1S $PINS O=n644 I=n88
XU72 INV1S $PINS O=n650 I=write_addr_1[3]
XU73 INV1S $PINS O=n651 I=write_addr_1[4]
XU74 INV1S $PINS O=n649 I=write_addr_1[2]
XU75 XOR2HS $PINS O=n97 I1=write_addr_2[4] I2=write_addr_2[3]
XU76 INV1S $PINS O=n653 I=write_addr_2[2]
XU77 INV1S $PINS O=n652 I=write_addr_2[3]
XU78 INV1S $PINS O=n654 I=write_addr_2[4]
XU79 OAI22H $PINS O=bank_wdata[1][1] A1=n9 A2=n610 B1=n62 B2=n632
XU80 OAI22H $PINS O=bank_wdata[1][2] A1=n9 A2=n611 B1=n62 B2=n633
XU81 OAI22H $PINS O=bank_wdata[1][3] A1=n9 A2=FE_PHN2204_n612 B1=n62 B2=n634
XU82 OAI22H $PINS O=bank_wdata[1][4] A1=n9 A2=n613 B1=n62 B2=n635
XU83 OAI22H $PINS O=bank_wdata[1][5] A1=n9 A2=n614 B1=n62 B2=n636
XU84 OAI22S $PINS O=bank_wdata[1][6] A1=n9 A2=n615 B1=n62 B2=n637
XU85 OAI22S $PINS O=bank_wdata[1][16] A1=n9 A2=n602 B1=n62 B2=n624
XU86 OAI22H $PINS O=bank_wdata[1][17] A1=n9 A2=n603 B1=n62 B2=n625
XU87 OAI22H $PINS O=bank_wdata[1][18] A1=n9 A2=n604 B1=n62 B2=n626
XU88 OAI22H $PINS O=bank_wdata[1][19] A1=n9 A2=n605 B1=n62 B2=n627
XU89 OAI22S $PINS O=bank_wdata[1][20] A1=n9 A2=n606 B1=n62 B2=n628
XU90 OAI22H $PINS O=bank_wdata[1][21] A1=n9 A2=n607 B1=n62 B2=n629
XU91 OAI22H $PINS O=bank_wdata[1][0] A1=n9 A2=n608 B1=n62 B2=n630
XU92 OAI22H $PINS O=bank_wdata[1][10] A1=n9 A2=n609 B1=n62 B2=n631
XU93 OAI22H $PINS O=bank_wdata[1][11] A1=n9 A2=n597 B1=n62 B2=n619
XU94 OAI22H $PINS O=bank_wdata[1][12] A1=n9 A2=n598 B1=n62 B2=n620
XU95 OAI22H $PINS O=bank_wdata[1][13] A1=n9 A2=n599 B1=n62 B2=n621
XU96 OAI22S $PINS O=bank_wdata[1][14] A1=n9 A2=n600 B1=n62 B2=n622
XU97 OAI22S $PINS O=bank_wdata[1][15] A1=n9 A2=n601 B1=n62 B2=n623
XU98 OAI22S $PINS O=bank_wdata[0][0] A1=n608 A2=n63 B1=n630 B2=n64
XU99 OAI22H $PINS O=bank_wdata[0][1] A1=n610 A2=n63 B1=n632 B2=n64
XU100 OAI22S $PINS O=bank_wdata[0][2] A1=n611 A2=n63 B1=n633 B2=n64
XU101 OAI22H $PINS O=bank_wdata[0][3] A1=n612 A2=n63 B1=n634 B2=n64
XU102 OAI22S $PINS O=bank_wdata[0][4] A1=n613 A2=n63 B1=n635 B2=n64
XU103 OAI22H $PINS O=bank_wdata[0][5] A1=n614 A2=n63 B1=n636 B2=n64
XU104 OAI22S $PINS O=bank_wdata[0][6] A1=n615 A2=n63 B1=n637 B2=n64
XU105 OAI22H $PINS O=bank_wdata[0][7] A1=n616 A2=n63 B1=n638 B2=n64
XU106 OAI22S $PINS O=bank_wdata[0][8] A1=n617 A2=n63 B1=n639 B2=n64
XU107 OAI22H $PINS O=bank_wdata[0][9] A1=n618 A2=n63 B1=n640 B2=n64
XU108 OAI22S $PINS O=bank_wdata[0][10] A1=n609 A2=n63 B1=n631 B2=n64
XU109 OAI22H $PINS O=bank_wdata[0][11] A1=n597 A2=n63 B1=n619 B2=n64
XU110 OAI22S $PINS O=bank_wdata[0][12] A1=n598 A2=n63 B1=n620 B2=n64
XU111 OAI22S $PINS O=bank_wdata[0][13] A1=n599 A2=n63 B1=n621 B2=n64
XU112 OAI22S $PINS O=bank_wdata[0][14] A1=n600 A2=n63 B1=n622 B2=n64
XU113 OAI22S $PINS O=bank_wdata[0][15] A1=n601 A2=n63 B1=n623 B2=n64
XU114 OAI22H $PINS O=bank_wdata[0][16] A1=n602 A2=n63 B1=n624 B2=n64
XU115 OAI22S $PINS O=bank_wdata[0][17] A1=n603 A2=n63 B1=n625 B2=n64
XU116 OAI22S $PINS O=bank_wdata[0][18] A1=n604 A2=n63 B1=n626 B2=n64
XU117 OAI22S $PINS O=bank_wdata[0][19] A1=n605 A2=n63 B1=n627 B2=n64
XU118 OAI22S $PINS O=bank_wdata[0][20] A1=n606 A2=n63 B1=n628 B2=n64
XU119 OAI22S $PINS O=bank_wdata[0][21] A1=n607 A2=n63 B1=n629 B2=n64
XU120 OAI22H $PINS O=bank_wdata[1][7] A1=n9 A2=FE_PHN2207_n616 B1=n62 B2=n638
XU121 OAI22H $PINS O=bank_wdata[1][8] A1=n9 A2=n617 B1=n62 B2=n639
XU122 OAI22H $PINS O=bank_wdata[1][9] A1=n9 A2=FE_PHN2210_n618 B1=n62 B2=n640
XU123 INV1S $PINS O=n589 I=n98
XU124 XNR2HS $PINS O=n94 I1=read_addr_1[4] I2=read_addr_1[3]
XU127 AN2 $PINS O=n298 I1=n21 I2=n18
XU128 AN2 $PINS O=n569 I1=n329 I2=n326
XU131 AN2 $PINS O=n301 I1=n19 I2=n18
XU132 AN2 $PINS O=n572 I1=n327 I2=n326
XU135 AN2 $PINS O=n297 I1=n21 I2=n17
XU136 AN2 $PINS O=n568 I1=n329 I2=n325
XU138 AN2 $PINS O=n571 I1=n329 I2=n328
XU140 AN2 $PINS O=n300 I1=n21 I2=n20
XU141 AN2 $PINS O=n288 I1=n20 I2=n309
XU142 AN2 $PINS O=n559 I1=n328 I2=n580
XU143 AN2 $PINS O=n296 I1=n19 I2=n17
XU144 AN2 $PINS O=n567 I1=n327 I2=n325
XU145 AN2 $PINS O=n289 I1=n16 I2=n309
XU146 AN2 $PINS O=n560 I1=n324 I2=n580
XU147 AN2 $PINS O=n299 I1=n21 I2=n16
XU148 AN2 $PINS O=n570 I1=n329 I2=n324
XU149 XOR2HS $PINS O=n96 I1=write_addr_1[4] I2=write_addr_1[3]
XU150 INV1S $PINS O=n648 I=write_addr_1[1]
XU151 INV1S $PINS O=n631 I=write_data_1[10]
XU152 INV1S $PINS O=n629 I=write_data_1[21]
XU153 INV1S $PINS O=n630 I=write_data_1[0]
XU166 INV1S $PINS O=n632 I=write_data_1[1]
XU197 INV1S $PINS O=n633 I=write_data_1[2]
XU199 INV1S $PINS O=n634 I=write_data_1[3]
XU200 INV1S $PINS O=n635 I=write_data_1[4]
XU201 INV1S $PINS O=n636 I=write_data_1[5]
XU202 INV1S $PINS O=n637 I=write_data_1[6]
XU203 INV1S $PINS O=n638 I=write_data_1[7]
XU204 INV1S $PINS O=n639 I=write_data_1[8]
XU205 INV1S $PINS O=n640 I=write_data_1[9]
XU206 INV1S $PINS O=n619 I=write_data_1[11]
XU207 INV1S $PINS O=n620 I=write_data_1[12]
XU208 INV1S $PINS O=n621 I=write_data_1[13]
XU209 INV1S $PINS O=n622 I=write_data_1[14]
XU210 INV1S $PINS O=n623 I=write_data_1[15]
XU211 INV1S $PINS O=n624 I=write_data_1[16]
XU212 INV1S $PINS O=n625 I=write_data_1[17]
XU213 INV1S $PINS O=n626 I=write_data_1[18]
XU214 INV1S $PINS O=n627 I=write_data_1[19]
XU215 INV1S $PINS O=n628 I=write_data_1[20]
XU216 INV1S $PINS O=n609 I=write_data_2[10]
XU217 INV1S $PINS O=n607 I=write_data_2[21]
XU218 INV1S $PINS O=n610 I=write_data_2[1]
XU219 INV1S $PINS O=n611 I=write_data_2[2]
XU220 INV1S $PINS O=n612 I=FE_PHN2008_rf_io_wdata_2_3
XU221 INV1S $PINS O=n613 I=write_data_2[4]
XU222 INV1S $PINS O=n614 I=FE_PHN2006_rf_io_wdata_2_5
XU223 INV1S $PINS O=n615 I=write_data_2[6]
XU224 INV1S $PINS O=n616 I=FE_PHN2002_rf_io_wdata_2_7
XU225 INV1S $PINS O=n617 I=write_data_2[8]
XU226 INV1S $PINS O=n618 I=write_data_2[9]
XU227 INV1S $PINS O=n602 I=write_data_2[16]
XU228 INV1S $PINS O=n603 I=write_data_2[17]
XU229 INV1S $PINS O=n604 I=write_data_2[18]
XU230 INV1S $PINS O=n605 I=write_data_2[19]
XU231 INV1S $PINS O=n606 I=write_data_2[20]
XU232 INV1S $PINS O=n608 I=write_data_2[0]
XU233 INV1S $PINS O=n597 I=write_data_2[11]
XU234 INV1S $PINS O=n598 I=write_data_2[12]
XU235 INV1S $PINS O=n599 I=write_data_2[13]
XU236 INV1S $PINS O=n600 I=write_data_2[14]
XU237 INV1S $PINS O=n601 I=write_data_2[15]
XU240 AN2 $PINS O=n287 I1=n18 I2=N29
XU241 AN2 $PINS O=n558 I1=n326 I2=N33
XU243 AN2 $PINS O=n556 I1=n325 I2=N33
XU245 AN2 $PINS O=n285 I1=n17 I2=N29
XU248 AN2 $PINS O=n284 I1=N29 I2=n20
XU249 AN2 $PINS O=n555 I1=N33 I2=n328
XU252 AN2 $PINS O=n286 I1=n16 I2=N29
XU253 AN2 $PINS O=n557 I1=n324 I2=N33
XU254 INV1S $PINS O=n580 I=N33
XU255 INV1S $PINS O=n309 I=N29
XU256 INV1S $PINS O=n579 I=N32
XU257 INV1S $PINS O=n308 I=N28
XU258 INV1S $PINS O=n578 I=N31
XU259 INV1S $PINS O=n307 I=N27
XU260 NR2 $PINS O=n19 I1=n309 I2=N30
XU261 NR2 $PINS O=n20 I1=n308 I2=n307
XU262 NR2 $PINS O=n17 I1=n308 I2=N27
XU263 AOI22S $PINS O=n14 A1=bank_mem_0[14][0] A2=n285 B1=bank_mem_0[15][0]
+ B2=n284
XU264 NR2 $PINS O=n18 I1=N27 I2=N28
XU265 NR2 $PINS O=n16 I1=n307 I2=N28
XU266 AOI22S $PINS O=n13 A1=bank_mem_0[12][0] A2=n287 B1=bank_mem_0[13][0]
+ B2=n286
XU267 AOI22S $PINS O=n11 A1=bank_mem_0[10][0] A2=n3 B1=bank_mem_0[11][0]
+ B2=n288
XU268 AOI22S $PINS O=n10 A1=bank_mem_0[8][0] A2=n1 B1=bank_mem_0[9][0] B2=n289
XU269 AN2 $PINS O=n12 I1=n11 I2=n10
XU270 ND3 $PINS O=n15 I1=n14 I2=n13 I3=n12
XU271 AOI22S $PINS O=n26 A1=bank_mem_0[7][0] A2=n5 B1=n15 B2=N30
XU272 AOI22S $PINS O=n25 A1=bank_mem_0[5][0] A2=n6 B1=bank_mem_0[6][0] B2=n296
XU273 NR2 $PINS O=n21 I1=N29 I2=N30
XU274 AO222 $PINS O=n23 A1=bank_mem_0[1][0] A2=n299 B1=bank_mem_0[0][0] B2=n298
+ C1=bank_mem_0[2][0] C2=n297
XU275 AO22 $PINS O=n22 A1=bank_mem_0[4][0] A2=n301 B1=bank_mem_0[3][0] B2=n300
XU276 NR2 $PINS O=n24 I1=n23 I2=n22
XU277 ND3 $PINS O=bank_rdata[0][0] I1=n26 I2=n25 I3=n24
XU278 AOI22S $PINS O=n31 A1=bank_mem_0[14][1] A2=n285 B1=bank_mem_0[15][1]
+ B2=n284
XU279 AOI22S $PINS O=n30 A1=bank_mem_0[12][1] A2=n287 B1=bank_mem_0[13][1]
+ B2=n286
XU280 AOI22S $PINS O=n28 A1=bank_mem_0[10][1] A2=n3 B1=bank_mem_0[11][1]
+ B2=n288
XU281 AOI22S $PINS O=n27 A1=bank_mem_0[8][1] A2=n1 B1=bank_mem_0[9][1] B2=n289
XU282 AN2 $PINS O=n29 I1=n28 I2=n27
XU283 ND3 $PINS O=n32 I1=n31 I2=n30 I3=n29
XU284 AOI22S $PINS O=n37 A1=bank_mem_0[7][1] A2=n5 B1=n32 B2=N30
XU285 AOI22S $PINS O=n36 A1=bank_mem_0[5][1] A2=n6 B1=bank_mem_0[6][1] B2=n296
XU286 AO222 $PINS O=n34 A1=bank_mem_0[1][1] A2=n299 B1=bank_mem_0[0][1] B2=n298
+ C1=bank_mem_0[2][1] C2=n297
XU287 AO22 $PINS O=n33 A1=bank_mem_0[4][1] A2=n301 B1=bank_mem_0[3][1] B2=n300
XU288 NR2 $PINS O=n35 I1=n34 I2=n33
XU289 ND3 $PINS O=bank_rdata[0][1] I1=n37 I2=n36 I3=n35
XU290 AOI22S $PINS O=n42 A1=bank_mem_0[14][2] A2=n285 B1=bank_mem_0[15][2]
+ B2=n284
XU291 AOI22S $PINS O=n41 A1=bank_mem_0[12][2] A2=n287 B1=bank_mem_0[13][2]
+ B2=n286
XU292 AOI22S $PINS O=n39 A1=bank_mem_0[10][2] A2=n3 B1=bank_mem_0[11][2]
+ B2=n288
XU293 AOI22S $PINS O=n38 A1=bank_mem_0[8][2] A2=n1 B1=bank_mem_0[9][2] B2=n289
XU294 AN2 $PINS O=n40 I1=n39 I2=n38
XU295 ND3 $PINS O=n43 I1=n42 I2=n41 I3=n40
XU296 AOI22S $PINS O=n48 A1=bank_mem_0[7][2] A2=n5 B1=n43 B2=N30
XU297 AOI22S $PINS O=n47 A1=bank_mem_0[5][2] A2=n6 B1=bank_mem_0[6][2] B2=n296
XU298 AO222 $PINS O=n45 A1=bank_mem_0[1][2] A2=n299 B1=bank_mem_0[0][2] B2=n298
+ C1=bank_mem_0[2][2] C2=n297
XU299 AO22 $PINS O=n44 A1=bank_mem_0[4][2] A2=n301 B1=bank_mem_0[3][2] B2=n300
XU300 NR2 $PINS O=n46 I1=n45 I2=n44
XU301 ND3 $PINS O=bank_rdata[0][2] I1=n48 I2=n47 I3=n46
XU302 AOI22S $PINS O=n53 A1=bank_mem_0[14][3] A2=n285 B1=bank_mem_0[15][3]
+ B2=n284
XU303 AOI22S $PINS O=n52 A1=bank_mem_0[12][3] A2=n287 B1=bank_mem_0[13][3]
+ B2=n286
XU304 AOI22S $PINS O=n50 A1=bank_mem_0[10][3] A2=n3 B1=bank_mem_0[11][3]
+ B2=n288
XU305 AOI22S $PINS O=n49 A1=bank_mem_0[8][3] A2=n1 B1=bank_mem_0[9][3] B2=n289
XU306 AN2 $PINS O=n51 I1=n50 I2=n49
XU307 ND3 $PINS O=n54 I1=n53 I2=n52 I3=n51
XU308 AOI22S $PINS O=n59 A1=bank_mem_0[7][3] A2=n5 B1=n54 B2=N30
XU309 AOI22S $PINS O=n58 A1=bank_mem_0[5][3] A2=n6 B1=bank_mem_0[6][3] B2=n296
XU310 AO222 $PINS O=n56 A1=bank_mem_0[1][3] A2=n299 B1=bank_mem_0[0][3] B2=n298
+ C1=bank_mem_0[2][3] C2=n297
XU311 AO22 $PINS O=n55 A1=bank_mem_0[4][3] A2=n301 B1=bank_mem_0[3][3] B2=n300
XU312 NR2 $PINS O=n57 I1=n56 I2=n55
XU313 ND3 $PINS O=bank_rdata[0][3] I1=n59 I2=n58 I3=n57
XU314 AOI22S $PINS O=n101 A1=bank_mem_0[14][4] A2=n285 B1=bank_mem_0[15][4]
+ B2=n284
XU315 AOI22S $PINS O=n100 A1=bank_mem_0[12][4] A2=n287 B1=bank_mem_0[13][4]
+ B2=n286
XU316 AOI22S $PINS O=n61 A1=bank_mem_0[10][4] A2=n3 B1=bank_mem_0[11][4]
+ B2=n288
XU317 AOI22S $PINS O=n60 A1=bank_mem_0[8][4] A2=n1 B1=bank_mem_0[9][4] B2=n289
XU318 AN2 $PINS O=n99 I1=n61 I2=n60
XU319 ND3 $PINS O=n102 I1=n101 I2=n100 I3=n99
XU320 AOI22S $PINS O=n107 A1=bank_mem_0[7][4] A2=n5 B1=n102 B2=N30
XU321 AOI22S $PINS O=n106 A1=bank_mem_0[5][4] A2=n6 B1=bank_mem_0[6][4] B2=n296
XU322 AO222 $PINS O=n104 A1=bank_mem_0[1][4] A2=n299 B1=bank_mem_0[0][4]
+ B2=n298 C1=bank_mem_0[2][4] C2=n297
XU323 AO22 $PINS O=n103 A1=bank_mem_0[4][4] A2=n301 B1=bank_mem_0[3][4] B2=n300
XU324 NR2 $PINS O=n105 I1=n104 I2=n103
XU325 ND3 $PINS O=bank_rdata[0][4] I1=n107 I2=n106 I3=n105
XU326 AOI22S $PINS O=n112 A1=bank_mem_0[14][5] A2=n285 B1=bank_mem_0[15][5]
+ B2=n284
XU327 AOI22S $PINS O=n111 A1=bank_mem_0[12][5] A2=n287 B1=bank_mem_0[13][5]
+ B2=n286
XU328 AOI22S $PINS O=n109 A1=bank_mem_0[10][5] A2=n3 B1=bank_mem_0[11][5]
+ B2=n288
XU329 AOI22S $PINS O=n108 A1=bank_mem_0[8][5] A2=n1 B1=bank_mem_0[9][5] B2=n289
XU330 AN2 $PINS O=n110 I1=n109 I2=n108
XU331 ND3 $PINS O=n113 I1=n112 I2=n111 I3=n110
XU332 AOI22S $PINS O=n118 A1=bank_mem_0[7][5] A2=n5 B1=n113 B2=N30
XU333 AOI22S $PINS O=n117 A1=bank_mem_0[5][5] A2=n6 B1=bank_mem_0[6][5] B2=n296
XU334 AO222 $PINS O=n115 A1=bank_mem_0[1][5] A2=n299 B1=bank_mem_0[0][5]
+ B2=n298 C1=bank_mem_0[2][5] C2=n297
XU335 AO22 $PINS O=n114 A1=bank_mem_0[4][5] A2=n301 B1=bank_mem_0[3][5] B2=n300
XU336 NR2 $PINS O=n116 I1=n115 I2=n114
XU337 ND3 $PINS O=bank_rdata[0][5] I1=n118 I2=n117 I3=n116
XU338 AOI22S $PINS O=n123 A1=bank_mem_0[14][6] A2=n285 B1=bank_mem_0[15][6]
+ B2=n284
XU339 AOI22S $PINS O=n122 A1=bank_mem_0[12][6] A2=n287 B1=bank_mem_0[13][6]
+ B2=n286
XU340 AOI22S $PINS O=n120 A1=bank_mem_0[10][6] A2=n3 B1=bank_mem_0[11][6]
+ B2=n288
XU341 AOI22S $PINS O=n119 A1=bank_mem_0[8][6] A2=n1 B1=bank_mem_0[9][6] B2=n289
XU342 AN2 $PINS O=n121 I1=n120 I2=n119
XU343 ND3 $PINS O=n124 I1=n123 I2=n122 I3=n121
XU344 AOI22S $PINS O=n129 A1=bank_mem_0[7][6] A2=n5 B1=n124 B2=N30
XU345 AOI22S $PINS O=n128 A1=bank_mem_0[5][6] A2=n6 B1=bank_mem_0[6][6] B2=n296
XU346 AO222 $PINS O=n126 A1=bank_mem_0[1][6] A2=n299 B1=bank_mem_0[0][6]
+ B2=n298 C1=bank_mem_0[2][6] C2=n297
XU347 AO22 $PINS O=n125 A1=bank_mem_0[4][6] A2=n301 B1=bank_mem_0[3][6] B2=n300
XU348 NR2 $PINS O=n127 I1=n126 I2=n125
XU349 ND3 $PINS O=bank_rdata[0][6] I1=n129 I2=n128 I3=n127
XU350 AOI22S $PINS O=n134 A1=bank_mem_0[14][7] A2=n285 B1=bank_mem_0[15][7]
+ B2=n284
XU351 AOI22S $PINS O=n133 A1=bank_mem_0[12][7] A2=n287 B1=bank_mem_0[13][7]
+ B2=n286
XU352 AOI22S $PINS O=n131 A1=bank_mem_0[10][7] A2=n3 B1=bank_mem_0[11][7]
+ B2=n288
XU353 AOI22S $PINS O=n130 A1=bank_mem_0[8][7] A2=n1 B1=bank_mem_0[9][7] B2=n289
XU354 AN2 $PINS O=n132 I1=n131 I2=n130
XU355 ND3 $PINS O=n135 I1=n134 I2=n133 I3=n132
XU356 AOI22S $PINS O=n140 A1=bank_mem_0[7][7] A2=n5 B1=n135 B2=N30
XU357 AOI22S $PINS O=n139 A1=bank_mem_0[5][7] A2=n6 B1=bank_mem_0[6][7] B2=n296
XU358 AO222 $PINS O=n137 A1=bank_mem_0[1][7] A2=n299 B1=bank_mem_0[0][7]
+ B2=n298 C1=bank_mem_0[2][7] C2=n297
XU359 AO22 $PINS O=n136 A1=bank_mem_0[4][7] A2=n301 B1=bank_mem_0[3][7] B2=n300
XU360 NR2 $PINS O=n138 I1=n137 I2=n136
XU361 ND3 $PINS O=bank_rdata[0][7] I1=n140 I2=n139 I3=n138
XU362 AOI22S $PINS O=n145 A1=bank_mem_0[14][8] A2=n285 B1=bank_mem_0[15][8]
+ B2=n284
XU363 AOI22S $PINS O=n144 A1=bank_mem_0[12][8] A2=n287 B1=bank_mem_0[13][8]
+ B2=n286
XU364 AOI22S $PINS O=n142 A1=bank_mem_0[10][8] A2=n3 B1=bank_mem_0[11][8]
+ B2=n288
XU365 AOI22S $PINS O=n141 A1=bank_mem_0[8][8] A2=n1 B1=bank_mem_0[9][8] B2=n289
XU366 AN2 $PINS O=n143 I1=n142 I2=n141
XU367 ND3 $PINS O=n146 I1=n145 I2=n144 I3=n143
XU368 AOI22S $PINS O=n151 A1=bank_mem_0[7][8] A2=n5 B1=n146 B2=N30
XU369 AOI22S $PINS O=n150 A1=bank_mem_0[5][8] A2=n6 B1=bank_mem_0[6][8] B2=n296
XU370 AO222 $PINS O=n148 A1=bank_mem_0[1][8] A2=n299 B1=bank_mem_0[0][8]
+ B2=n298 C1=bank_mem_0[2][8] C2=n297
XU371 AO22 $PINS O=n147 A1=bank_mem_0[4][8] A2=n301 B1=bank_mem_0[3][8] B2=n300
XU372 NR2 $PINS O=n149 I1=n148 I2=n147
XU373 ND3 $PINS O=bank_rdata[0][8] I1=n151 I2=n150 I3=n149
XU374 AOI22S $PINS O=n156 A1=bank_mem_0[14][9] A2=n285 B1=bank_mem_0[15][9]
+ B2=n284
XU375 AOI22S $PINS O=n155 A1=bank_mem_0[12][9] A2=n287 B1=bank_mem_0[13][9]
+ B2=n286
XU376 AOI22S $PINS O=n153 A1=bank_mem_0[10][9] A2=n3 B1=bank_mem_0[11][9]
+ B2=n288
XU377 AOI22S $PINS O=n152 A1=bank_mem_0[8][9] A2=n1 B1=bank_mem_0[9][9] B2=n289
XU378 AN2 $PINS O=n154 I1=n153 I2=n152
XU379 ND3 $PINS O=n157 I1=n156 I2=n155 I3=n154
XU380 AOI22S $PINS O=n162 A1=bank_mem_0[7][9] A2=n5 B1=n157 B2=N30
XU381 AOI22S $PINS O=n161 A1=bank_mem_0[5][9] A2=n6 B1=bank_mem_0[6][9] B2=n296
XU382 AO222 $PINS O=n159 A1=bank_mem_0[1][9] A2=n299 B1=bank_mem_0[0][9]
+ B2=n298 C1=bank_mem_0[2][9] C2=n297
XU383 AO22 $PINS O=n158 A1=bank_mem_0[4][9] A2=n301 B1=bank_mem_0[3][9] B2=n300
XU384 NR2 $PINS O=n160 I1=n159 I2=n158
XU385 ND3 $PINS O=bank_rdata[0][9] I1=n162 I2=n161 I3=n160
XU386 AOI22S $PINS O=n167 A1=bank_mem_0[14][10] A2=n285 B1=bank_mem_0[15][10]
+ B2=n284
XU387 AOI22S $PINS O=n166 A1=bank_mem_0[12][10] A2=n287 B1=bank_mem_0[13][10]
+ B2=n286
XU388 AOI22S $PINS O=n164 A1=bank_mem_0[10][10] A2=n3 B1=bank_mem_0[11][10]
+ B2=n288
XU389 AOI22S $PINS O=n163 A1=bank_mem_0[8][10] A2=n1 B1=bank_mem_0[9][10]
+ B2=n289
XU390 AN2 $PINS O=n165 I1=n164 I2=n163
XU391 ND3 $PINS O=n168 I1=n167 I2=n166 I3=n165
XU392 AOI22S $PINS O=n173 A1=bank_mem_0[7][10] A2=n5 B1=n168 B2=N30
XU393 AOI22S $PINS O=n172 A1=bank_mem_0[5][10] A2=n6 B1=bank_mem_0[6][10]
+ B2=n296
XU394 AO222 $PINS O=n170 A1=bank_mem_0[1][10] A2=n299 B1=bank_mem_0[0][10]
+ B2=n298 C1=bank_mem_0[2][10] C2=n297
XU395 AO22 $PINS O=n169 A1=bank_mem_0[4][10] A2=n301 B1=bank_mem_0[3][10]
+ B2=n300
XU396 NR2 $PINS O=n171 I1=n170 I2=n169
XU397 ND3 $PINS O=bank_rdata[0][10] I1=n173 I2=n172 I3=n171
XU398 AOI22S $PINS O=n178 A1=bank_mem_0[14][11] A2=n285 B1=bank_mem_0[15][11]
+ B2=n284
XU399 AOI22S $PINS O=n177 A1=bank_mem_0[12][11] A2=n287 B1=bank_mem_0[13][11]
+ B2=n286
XU400 AOI22S $PINS O=n175 A1=bank_mem_0[10][11] A2=n3 B1=bank_mem_0[11][11]
+ B2=n288
XU401 AOI22S $PINS O=n174 A1=bank_mem_0[8][11] A2=n1 B1=bank_mem_0[9][11]
+ B2=n289
XU402 AN2 $PINS O=n176 I1=n175 I2=n174
XU403 ND3 $PINS O=n179 I1=n178 I2=n177 I3=n176
XU404 AOI22S $PINS O=n184 A1=bank_mem_0[7][11] A2=n5 B1=n179 B2=N30
XU405 AOI22S $PINS O=n183 A1=bank_mem_0[5][11] A2=n6 B1=bank_mem_0[6][11]
+ B2=n296
XU406 AO222 $PINS O=n181 A1=bank_mem_0[1][11] A2=n299 B1=bank_mem_0[0][11]
+ B2=n298 C1=bank_mem_0[2][11] C2=n297
XU407 AO22 $PINS O=n180 A1=bank_mem_0[4][11] A2=n301 B1=bank_mem_0[3][11]
+ B2=n300
XU408 NR2 $PINS O=n182 I1=n181 I2=n180
XU409 ND3 $PINS O=bank_rdata[0][11] I1=n184 I2=n183 I3=n182
XU410 AOI22S $PINS O=n189 A1=bank_mem_0[14][12] A2=n285 B1=bank_mem_0[15][12]
+ B2=n284
XU411 AOI22S $PINS O=n188 A1=bank_mem_0[12][12] A2=n287 B1=bank_mem_0[13][12]
+ B2=n286
XU412 AOI22S $PINS O=n186 A1=bank_mem_0[10][12] A2=n3 B1=bank_mem_0[11][12]
+ B2=n288
XU413 AOI22S $PINS O=n185 A1=bank_mem_0[8][12] A2=n1 B1=bank_mem_0[9][12]
+ B2=n289
XU414 AN2 $PINS O=n187 I1=n186 I2=n185
XU415 ND3 $PINS O=n190 I1=n189 I2=n188 I3=n187
XU416 AOI22S $PINS O=n195 A1=bank_mem_0[7][12] A2=n5 B1=n190 B2=N30
XU417 AOI22S $PINS O=n194 A1=bank_mem_0[5][12] A2=n6 B1=bank_mem_0[6][12]
+ B2=n296
XU418 AO222 $PINS O=n192 A1=bank_mem_0[1][12] A2=n299 B1=bank_mem_0[0][12]
+ B2=n298 C1=bank_mem_0[2][12] C2=n297
XU419 AO22 $PINS O=n191 A1=bank_mem_0[4][12] A2=n301 B1=bank_mem_0[3][12]
+ B2=n300
XU420 NR2 $PINS O=n193 I1=n192 I2=n191
XU421 ND3 $PINS O=bank_rdata[0][12] I1=n195 I2=n194 I3=n193
XU422 AOI22S $PINS O=n200 A1=bank_mem_0[14][13] A2=n285 B1=bank_mem_0[15][13]
+ B2=n284
XU423 AOI22S $PINS O=n199 A1=bank_mem_0[12][13] A2=n287 B1=bank_mem_0[13][13]
+ B2=n286
XU424 AOI22S $PINS O=n197 A1=bank_mem_0[10][13] A2=n3 B1=bank_mem_0[11][13]
+ B2=n288
XU425 AOI22S $PINS O=n196 A1=bank_mem_0[8][13] A2=n1 B1=bank_mem_0[9][13]
+ B2=n289
XU426 AN2 $PINS O=n198 I1=n197 I2=n196
XU427 ND3 $PINS O=n201 I1=n200 I2=n199 I3=n198
XU428 AOI22S $PINS O=n206 A1=bank_mem_0[7][13] A2=n5 B1=n201 B2=N30
XU429 AOI22S $PINS O=n205 A1=bank_mem_0[5][13] A2=n6 B1=bank_mem_0[6][13]
+ B2=n296
XU430 AO222 $PINS O=n203 A1=bank_mem_0[1][13] A2=n299 B1=bank_mem_0[0][13]
+ B2=n298 C1=bank_mem_0[2][13] C2=n297
XU431 AO22 $PINS O=n202 A1=bank_mem_0[4][13] A2=n301 B1=bank_mem_0[3][13]
+ B2=n300
XU432 NR2 $PINS O=n204 I1=n203 I2=n202
XU433 ND3 $PINS O=FE_PHN1534_bank_rdata_0_13 I1=n206 I2=n205 I3=n204
XU434 AOI22S $PINS O=n211 A1=bank_mem_0[14][14] A2=n285 B1=bank_mem_0[15][14]
+ B2=n284
XU435 AOI22S $PINS O=n210 A1=bank_mem_0[12][14] A2=n287 B1=bank_mem_0[13][14]
+ B2=n286
XU436 AOI22S $PINS O=n208 A1=bank_mem_0[10][14] A2=n3 B1=bank_mem_0[11][14]
+ B2=n288
XU437 AOI22S $PINS O=n207 A1=bank_mem_0[8][14] A2=n1 B1=bank_mem_0[9][14]
+ B2=n289
XU438 AN2 $PINS O=n209 I1=n208 I2=n207
XU439 ND3 $PINS O=n212 I1=n211 I2=n210 I3=n209
XU440 AOI22S $PINS O=n217 A1=bank_mem_0[7][14] A2=n5 B1=n212 B2=N30
XU441 AOI22S $PINS O=n216 A1=bank_mem_0[5][14] A2=n6 B1=bank_mem_0[6][14]
+ B2=n296
XU442 AO222 $PINS O=n214 A1=bank_mem_0[1][14] A2=n299 B1=bank_mem_0[0][14]
+ B2=n298 C1=bank_mem_0[2][14] C2=n297
XU443 AO22 $PINS O=n213 A1=bank_mem_0[4][14] A2=n301 B1=bank_mem_0[3][14]
+ B2=n300
XU444 NR2 $PINS O=n215 I1=n214 I2=n213
XU445 ND3 $PINS O=bank_rdata[0][14] I1=n217 I2=n216 I3=n215
XU446 AOI22S $PINS O=n222 A1=bank_mem_0[14][15] A2=n285 B1=bank_mem_0[15][15]
+ B2=n284
XU447 AOI22S $PINS O=n221 A1=bank_mem_0[12][15] A2=n287 B1=bank_mem_0[13][15]
+ B2=n286
XU448 AOI22S $PINS O=n219 A1=bank_mem_0[10][15] A2=n3 B1=bank_mem_0[11][15]
+ B2=n288
XU449 AOI22S $PINS O=n218 A1=bank_mem_0[8][15] A2=n1 B1=bank_mem_0[9][15]
+ B2=n289
XU450 AN2 $PINS O=n220 I1=n219 I2=n218
XU451 ND3 $PINS O=n223 I1=n222 I2=n221 I3=n220
XU452 AOI22S $PINS O=n228 A1=bank_mem_0[7][15] A2=n5 B1=n223 B2=N30
XU453 AOI22S $PINS O=n227 A1=bank_mem_0[5][15] A2=n6 B1=bank_mem_0[6][15]
+ B2=n296
XU454 AO222 $PINS O=n225 A1=bank_mem_0[1][15] A2=n299 B1=bank_mem_0[0][15]
+ B2=n298 C1=bank_mem_0[2][15] C2=n297
XU455 AO22 $PINS O=n224 A1=bank_mem_0[4][15] A2=n301 B1=bank_mem_0[3][15]
+ B2=n300
XU456 NR2 $PINS O=n226 I1=n225 I2=n224
XU457 ND3 $PINS O=bank_rdata[0][15] I1=n228 I2=n227 I3=n226
XU458 AOI22S $PINS O=n233 A1=bank_mem_0[14][16] A2=n285 B1=bank_mem_0[15][16]
+ B2=n284
XU459 AOI22S $PINS O=n232 A1=bank_mem_0[12][16] A2=n287 B1=bank_mem_0[13][16]
+ B2=n286
XU460 AOI22S $PINS O=n230 A1=bank_mem_0[10][16] A2=n3 B1=bank_mem_0[11][16]
+ B2=n288
XU461 AOI22S $PINS O=n229 A1=bank_mem_0[8][16] A2=n1 B1=bank_mem_0[9][16]
+ B2=n289
XU462 AN2 $PINS O=n231 I1=n230 I2=n229
XU463 ND3 $PINS O=n234 I1=n233 I2=n232 I3=n231
XU464 AOI22S $PINS O=n239 A1=bank_mem_0[7][16] A2=n5 B1=n234 B2=N30
XU465 AOI22S $PINS O=n238 A1=bank_mem_0[5][16] A2=n6 B1=bank_mem_0[6][16]
+ B2=n296
XU466 AO222 $PINS O=n236 A1=bank_mem_0[1][16] A2=n299 B1=bank_mem_0[0][16]
+ B2=n298 C1=bank_mem_0[2][16] C2=n297
XU467 AO22 $PINS O=n235 A1=bank_mem_0[4][16] A2=n301 B1=bank_mem_0[3][16]
+ B2=n300
XU468 NR2 $PINS O=n237 I1=n236 I2=n235
XU469 ND3 $PINS O=bank_rdata[0][16] I1=n239 I2=n238 I3=n237
XU470 AOI22S $PINS O=n244 A1=bank_mem_0[14][17] A2=n285 B1=bank_mem_0[15][17]
+ B2=n284
XU471 AOI22S $PINS O=n243 A1=bank_mem_0[12][17] A2=n287 B1=bank_mem_0[13][17]
+ B2=n286
XU472 AOI22S $PINS O=n241 A1=bank_mem_0[10][17] A2=n3 B1=bank_mem_0[11][17]
+ B2=n288
XU473 AOI22S $PINS O=n240 A1=bank_mem_0[8][17] A2=n1 B1=bank_mem_0[9][17]
+ B2=n289
XU474 AN2 $PINS O=n242 I1=n241 I2=n240
XU475 ND3 $PINS O=n245 I1=n244 I2=n243 I3=n242
XU476 AOI22S $PINS O=n250 A1=bank_mem_0[7][17] A2=n5 B1=n245 B2=N30
XU477 AOI22S $PINS O=n249 A1=bank_mem_0[5][17] A2=n6 B1=bank_mem_0[6][17]
+ B2=n296
XU478 AO222 $PINS O=n247 A1=bank_mem_0[1][17] A2=n299 B1=bank_mem_0[0][17]
+ B2=n298 C1=bank_mem_0[2][17] C2=n297
XU479 AO22 $PINS O=n246 A1=bank_mem_0[4][17] A2=n301 B1=bank_mem_0[3][17]
+ B2=n300
XU480 NR2 $PINS O=n248 I1=n247 I2=n246
XU481 ND3 $PINS O=bank_rdata[0][17] I1=n250 I2=n249 I3=n248
XU482 AOI22S $PINS O=n255 A1=bank_mem_0[14][18] A2=n285 B1=bank_mem_0[15][18]
+ B2=n284
XU483 AOI22S $PINS O=n254 A1=bank_mem_0[12][18] A2=n287 B1=bank_mem_0[13][18]
+ B2=n286
XU484 AOI22S $PINS O=n252 A1=bank_mem_0[10][18] A2=n3 B1=bank_mem_0[11][18]
+ B2=n288
XU485 AOI22S $PINS O=n251 A1=bank_mem_0[8][18] A2=n1 B1=bank_mem_0[9][18]
+ B2=n289
XU486 AN2 $PINS O=n253 I1=n252 I2=n251
XU487 ND3 $PINS O=n256 I1=n255 I2=n254 I3=n253
XU488 AOI22S $PINS O=n261 A1=bank_mem_0[7][18] A2=n5 B1=n256 B2=N30
XU489 AOI22S $PINS O=n260 A1=bank_mem_0[5][18] A2=n6 B1=bank_mem_0[6][18]
+ B2=n296
XU490 AO222 $PINS O=n258 A1=bank_mem_0[1][18] A2=n299 B1=bank_mem_0[0][18]
+ B2=n298 C1=bank_mem_0[2][18] C2=n297
XU491 AO22 $PINS O=n257 A1=bank_mem_0[4][18] A2=n301 B1=bank_mem_0[3][18]
+ B2=n300
XU492 NR2 $PINS O=n259 I1=n258 I2=n257
XU493 ND3 $PINS O=bank_rdata[0][18] I1=n261 I2=n260 I3=n259
XU494 AOI22S $PINS O=n266 A1=bank_mem_0[14][19] A2=n285 B1=bank_mem_0[15][19]
+ B2=n284
XU495 AOI22S $PINS O=n265 A1=bank_mem_0[12][19] A2=n287 B1=bank_mem_0[13][19]
+ B2=n286
XU496 AOI22S $PINS O=n263 A1=bank_mem_0[10][19] A2=n3 B1=bank_mem_0[11][19]
+ B2=n288
XU497 AOI22S $PINS O=n262 A1=bank_mem_0[8][19] A2=n1 B1=bank_mem_0[9][19]
+ B2=n289
XU498 AN2 $PINS O=n264 I1=n263 I2=n262
XU499 ND3 $PINS O=n267 I1=n266 I2=n265 I3=n264
XU500 AOI22S $PINS O=n272 A1=bank_mem_0[7][19] A2=n5 B1=n267 B2=N30
XU501 AOI22S $PINS O=n271 A1=bank_mem_0[5][19] A2=n6 B1=bank_mem_0[6][19]
+ B2=n296
XU502 AO222 $PINS O=n269 A1=bank_mem_0[1][19] A2=n299 B1=bank_mem_0[0][19]
+ B2=n298 C1=bank_mem_0[2][19] C2=n297
XU503 AO22 $PINS O=n268 A1=bank_mem_0[4][19] A2=n301 B1=bank_mem_0[3][19]
+ B2=n300
XU504 NR2 $PINS O=n270 I1=n269 I2=n268
XU505 ND3 $PINS O=bank_rdata[0][19] I1=n272 I2=n271 I3=n270
XU506 AOI22S $PINS O=n277 A1=bank_mem_0[14][20] A2=n285 B1=bank_mem_0[15][20]
+ B2=n284
XU507 AOI22S $PINS O=n276 A1=bank_mem_0[12][20] A2=n287 B1=bank_mem_0[13][20]
+ B2=n286
XU508 AOI22S $PINS O=n274 A1=bank_mem_0[10][20] A2=n3 B1=bank_mem_0[11][20]
+ B2=n288
XU509 AOI22S $PINS O=n273 A1=bank_mem_0[8][20] A2=n1 B1=bank_mem_0[9][20]
+ B2=n289
XU510 AN2 $PINS O=n275 I1=n274 I2=n273
XU511 ND3 $PINS O=n278 I1=n277 I2=n276 I3=n275
XU512 AOI22S $PINS O=n283 A1=bank_mem_0[7][20] A2=n5 B1=n278 B2=N30
XU513 AOI22S $PINS O=n282 A1=bank_mem_0[5][20] A2=n6 B1=bank_mem_0[6][20]
+ B2=n296
XU514 AO222 $PINS O=n280 A1=bank_mem_0[1][20] A2=n299 B1=bank_mem_0[0][20]
+ B2=n298 C1=bank_mem_0[2][20] C2=n297
XU515 AO22 $PINS O=n279 A1=bank_mem_0[4][20] A2=n301 B1=bank_mem_0[3][20]
+ B2=n300
XU516 NR2 $PINS O=n281 I1=n280 I2=n279
XU517 ND3 $PINS O=bank_rdata[0][20] I1=n283 I2=n282 I3=n281
XU518 AOI22S $PINS O=n294 A1=bank_mem_0[14][21] A2=n285 B1=bank_mem_0[15][21]
+ B2=n284
XU519 AOI22S $PINS O=n293 A1=bank_mem_0[12][21] A2=n287 B1=bank_mem_0[13][21]
+ B2=n286
XU520 AOI22S $PINS O=n291 A1=bank_mem_0[10][21] A2=n3 B1=bank_mem_0[11][21]
+ B2=n288
XU521 AOI22S $PINS O=n290 A1=bank_mem_0[8][21] A2=n1 B1=bank_mem_0[9][21]
+ B2=n289
XU522 AN2 $PINS O=n292 I1=n291 I2=n290
XU523 ND3 $PINS O=n295 I1=n294 I2=n293 I3=n292
XU524 AOI22S $PINS O=n306 A1=bank_mem_0[7][21] A2=n5 B1=N30 B2=n295
XU525 AOI22S $PINS O=n305 A1=bank_mem_0[5][21] A2=n6 B1=bank_mem_0[6][21]
+ B2=n296
XU526 AO222 $PINS O=n303 A1=bank_mem_0[1][21] A2=n299 B1=bank_mem_0[0][21]
+ B2=n298 C1=bank_mem_0[2][21] C2=n297
XU527 AO22 $PINS O=n302 A1=bank_mem_0[4][21] A2=n301 B1=bank_mem_0[3][21]
+ B2=n300
XU528 NR2 $PINS O=n304 I1=n303 I2=n302
XU529 ND3 $PINS O=bank_rdata[0][21] I1=n306 I2=n305 I3=n304
XU530 NR2 $PINS O=n327 I1=n580 I2=N34
XU531 NR2 $PINS O=n328 I1=n579 I2=n578
XU532 NR2 $PINS O=n325 I1=n579 I2=N31
XU533 AOI22S $PINS O=n322 A1=bank_mem_1[14][0] A2=n556 B1=bank_mem_1[15][0]
+ B2=n555
XU534 NR2 $PINS O=n326 I1=N31 I2=N32
XU535 NR2 $PINS O=n324 I1=n578 I2=N32
XU536 AOI22S $PINS O=n321 A1=bank_mem_1[12][0] A2=n558 B1=bank_mem_1[13][0]
+ B2=n557
XU537 AOI22S $PINS O=n319 A1=bank_mem_1[10][0] A2=n4 B1=bank_mem_1[11][0]
+ B2=n559
XU538 AOI22S $PINS O=n318 A1=bank_mem_1[8][0] A2=n2 B1=bank_mem_1[9][0] B2=n560
XU539 AN2 $PINS O=n320 I1=n319 I2=n318
XU540 ND3 $PINS O=n323 I1=n322 I2=n321 I3=n320
XU541 AOI22S $PINS O=n334 A1=bank_mem_1[7][0] A2=n7 B1=n323 B2=N34
XU542 AOI22S $PINS O=n333 A1=bank_mem_1[5][0] A2=n8 B1=bank_mem_1[6][0] B2=n567
XU543 NR2 $PINS O=n329 I1=N33 I2=N34
XU544 AO222 $PINS O=n331 A1=bank_mem_1[1][0] A2=n570 B1=bank_mem_1[0][0]
+ B2=n569 C1=bank_mem_1[2][0] C2=n568
XU545 AO22 $PINS O=n330 A1=bank_mem_1[4][0] A2=n572 B1=bank_mem_1[3][0] B2=n571
XU546 NR2 $PINS O=n332 I1=n331 I2=n330
XU547 ND3 $PINS O=bank_rdata[1][0] I1=n334 I2=n333 I3=n332
XU548 AOI22S $PINS O=n339 A1=bank_mem_1[14][1] A2=n556 B1=bank_mem_1[15][1]
+ B2=n555
XU549 AOI22S $PINS O=n338 A1=bank_mem_1[12][1] A2=n558 B1=bank_mem_1[13][1]
+ B2=n557
XU550 AOI22S $PINS O=n336 A1=bank_mem_1[10][1] A2=n4 B1=bank_mem_1[11][1]
+ B2=n559
XU551 AOI22S $PINS O=n335 A1=bank_mem_1[8][1] A2=n2 B1=bank_mem_1[9][1] B2=n560
XU552 AN2 $PINS O=n337 I1=n336 I2=n335
XU553 ND3 $PINS O=n340 I1=n339 I2=n338 I3=n337
XU554 AOI22S $PINS O=n345 A1=bank_mem_1[7][1] A2=n7 B1=n340 B2=N34
XU555 AOI22S $PINS O=n344 A1=bank_mem_1[5][1] A2=n8 B1=bank_mem_1[6][1] B2=n567
XU556 AO222 $PINS O=n342 A1=bank_mem_1[1][1] A2=n570 B1=bank_mem_1[0][1]
+ B2=n569 C1=bank_mem_1[2][1] C2=n568
XU557 AO22 $PINS O=n341 A1=bank_mem_1[4][1] A2=n572 B1=bank_mem_1[3][1] B2=n571
XU558 NR2 $PINS O=n343 I1=n342 I2=n341
XU559 ND3 $PINS O=bank_rdata[1][1] I1=n345 I2=n344 I3=n343
XU560 AOI22S $PINS O=n350 A1=bank_mem_1[14][2] A2=n556 B1=bank_mem_1[15][2]
+ B2=n555
XU561 AOI22S $PINS O=n349 A1=bank_mem_1[12][2] A2=n558 B1=bank_mem_1[13][2]
+ B2=n557
XU562 AOI22S $PINS O=n347 A1=bank_mem_1[10][2] A2=n4 B1=bank_mem_1[11][2]
+ B2=n559
XU563 AOI22S $PINS O=n346 A1=bank_mem_1[8][2] A2=n2 B1=bank_mem_1[9][2] B2=n560
XU564 AN2 $PINS O=n348 I1=n347 I2=n346
XU565 ND3 $PINS O=n351 I1=n350 I2=n349 I3=n348
XU566 AOI22S $PINS O=n356 A1=bank_mem_1[7][2] A2=n7 B1=n351 B2=N34
XU567 AOI22S $PINS O=n355 A1=bank_mem_1[5][2] A2=n8 B1=bank_mem_1[6][2] B2=n567
XU568 AO222 $PINS O=n353 A1=bank_mem_1[1][2] A2=n570 B1=bank_mem_1[0][2]
+ B2=n569 C1=bank_mem_1[2][2] C2=n568
XU569 AO22 $PINS O=n352 A1=bank_mem_1[4][2] A2=n572 B1=bank_mem_1[3][2] B2=n571
XU570 NR2 $PINS O=n354 I1=n353 I2=n352
XU571 ND3 $PINS O=bank_rdata[1][2] I1=n356 I2=n355 I3=n354
XU572 AOI22S $PINS O=n361 A1=bank_mem_1[14][3] A2=n556 B1=bank_mem_1[15][3]
+ B2=n555
XU573 AOI22S $PINS O=n360 A1=bank_mem_1[12][3] A2=n558 B1=bank_mem_1[13][3]
+ B2=n557
XU574 AOI22S $PINS O=n358 A1=bank_mem_1[10][3] A2=n4 B1=bank_mem_1[11][3]
+ B2=n559
XU575 AOI22S $PINS O=n357 A1=bank_mem_1[8][3] A2=n2 B1=bank_mem_1[9][3] B2=n560
XU576 AN2 $PINS O=n359 I1=n358 I2=n357
XU577 ND3 $PINS O=n362 I1=n361 I2=n360 I3=n359
XU578 AOI22S $PINS O=n367 A1=bank_mem_1[7][3] A2=n7 B1=n362 B2=N34
XU579 AOI22S $PINS O=n366 A1=bank_mem_1[5][3] A2=n8 B1=bank_mem_1[6][3] B2=n567
XU580 AO222 $PINS O=n364 A1=bank_mem_1[1][3] A2=n570 B1=bank_mem_1[0][3]
+ B2=n569 C1=bank_mem_1[2][3] C2=n568
XU581 AO22 $PINS O=n363 A1=bank_mem_1[4][3] A2=n572 B1=bank_mem_1[3][3] B2=n571
XU582 NR2 $PINS O=n365 I1=n364 I2=n363
XU583 ND3 $PINS O=bank_rdata[1][3] I1=n367 I2=n366 I3=n365
XU584 AOI22S $PINS O=n372 A1=bank_mem_1[14][4] A2=n556 B1=bank_mem_1[15][4]
+ B2=n555
XU585 AOI22S $PINS O=n371 A1=bank_mem_1[12][4] A2=n558 B1=bank_mem_1[13][4]
+ B2=n557
XU586 AOI22S $PINS O=n369 A1=bank_mem_1[10][4] A2=n4 B1=bank_mem_1[11][4]
+ B2=n559
XU587 AOI22S $PINS O=n368 A1=bank_mem_1[8][4] A2=n2 B1=bank_mem_1[9][4] B2=n560
XU588 AN2 $PINS O=n370 I1=n369 I2=n368
XU589 ND3 $PINS O=n373 I1=n372 I2=n371 I3=n370
XU590 AOI22S $PINS O=n378 A1=bank_mem_1[7][4] A2=n7 B1=n373 B2=N34
XU591 AOI22S $PINS O=n377 A1=bank_mem_1[5][4] A2=n8 B1=bank_mem_1[6][4] B2=n567
XU592 AO222 $PINS O=n375 A1=bank_mem_1[1][4] A2=n570 B1=bank_mem_1[0][4]
+ B2=n569 C1=bank_mem_1[2][4] C2=n568
XU593 AO22 $PINS O=n374 A1=bank_mem_1[4][4] A2=n572 B1=bank_mem_1[3][4] B2=n571
XU594 NR2 $PINS O=n376 I1=n375 I2=n374
XU595 ND3 $PINS O=bank_rdata[1][4] I1=n378 I2=n377 I3=n376
XU596 AOI22S $PINS O=n383 A1=bank_mem_1[14][5] A2=n556 B1=bank_mem_1[15][5]
+ B2=n555
XU597 AOI22S $PINS O=n382 A1=bank_mem_1[12][5] A2=n558 B1=bank_mem_1[13][5]
+ B2=n557
XU598 AOI22S $PINS O=n380 A1=bank_mem_1[10][5] A2=n4 B1=bank_mem_1[11][5]
+ B2=n559
XU599 AOI22S $PINS O=n379 A1=bank_mem_1[8][5] A2=n2 B1=bank_mem_1[9][5] B2=n560
XU600 AN2 $PINS O=n381 I1=n380 I2=n379
XU601 ND3 $PINS O=n384 I1=n383 I2=n382 I3=n381
XU602 AOI22S $PINS O=n389 A1=bank_mem_1[7][5] A2=n7 B1=n384 B2=N34
XU603 AOI22S $PINS O=n388 A1=bank_mem_1[5][5] A2=n8 B1=bank_mem_1[6][5] B2=n567
XU604 AO222 $PINS O=n386 A1=bank_mem_1[1][5] A2=n570 B1=bank_mem_1[0][5]
+ B2=n569 C1=bank_mem_1[2][5] C2=n568
XU605 AO22 $PINS O=n385 A1=bank_mem_1[4][5] A2=n572 B1=bank_mem_1[3][5] B2=n571
XU606 NR2 $PINS O=n387 I1=n386 I2=n385
XU607 ND3 $PINS O=bank_rdata[1][5] I1=n389 I2=n388 I3=n387
XU608 AOI22S $PINS O=n394 A1=bank_mem_1[14][6] A2=n556 B1=bank_mem_1[15][6]
+ B2=n555
XU609 AOI22S $PINS O=n393 A1=bank_mem_1[12][6] A2=n558 B1=bank_mem_1[13][6]
+ B2=n557
XU610 AOI22S $PINS O=n391 A1=bank_mem_1[10][6] A2=n4 B1=bank_mem_1[11][6]
+ B2=n559
XU611 AOI22S $PINS O=n390 A1=bank_mem_1[8][6] A2=n2 B1=bank_mem_1[9][6] B2=n560
XU612 AN2 $PINS O=n392 I1=n391 I2=n390
XU613 ND3 $PINS O=n395 I1=n394 I2=n393 I3=n392
XU614 AOI22S $PINS O=n400 A1=bank_mem_1[7][6] A2=n7 B1=n395 B2=N34
XU615 AOI22S $PINS O=n399 A1=bank_mem_1[5][6] A2=n8 B1=bank_mem_1[6][6] B2=n567
XU616 AO222 $PINS O=n397 A1=bank_mem_1[1][6] A2=n570 B1=bank_mem_1[0][6]
+ B2=n569 C1=bank_mem_1[2][6] C2=n568
XU617 AO22 $PINS O=n396 A1=bank_mem_1[4][6] A2=n572 B1=bank_mem_1[3][6] B2=n571
XU618 NR2 $PINS O=n398 I1=n397 I2=n396
XU619 ND3 $PINS O=bank_rdata[1][6] I1=n400 I2=n399 I3=n398
XU620 AOI22S $PINS O=n405 A1=bank_mem_1[14][7] A2=n556 B1=bank_mem_1[15][7]
+ B2=n555
XU621 AOI22S $PINS O=n404 A1=bank_mem_1[12][7] A2=n558 B1=bank_mem_1[13][7]
+ B2=n557
XU622 AOI22S $PINS O=n402 A1=bank_mem_1[10][7] A2=n4 B1=bank_mem_1[11][7]
+ B2=n559
XU623 AOI22S $PINS O=n401 A1=bank_mem_1[8][7] A2=n2 B1=bank_mem_1[9][7] B2=n560
XU624 AN2 $PINS O=n403 I1=n402 I2=n401
XU625 ND3 $PINS O=n406 I1=n405 I2=n404 I3=n403
XU626 AOI22S $PINS O=n411 A1=bank_mem_1[7][7] A2=n7 B1=n406 B2=N34
XU627 AOI22S $PINS O=n410 A1=bank_mem_1[5][7] A2=n8 B1=bank_mem_1[6][7] B2=n567
XU628 AO222 $PINS O=n408 A1=bank_mem_1[1][7] A2=n570 B1=bank_mem_1[0][7]
+ B2=n569 C1=bank_mem_1[2][7] C2=n568
XU629 AO22 $PINS O=n407 A1=bank_mem_1[4][7] A2=n572 B1=bank_mem_1[3][7] B2=n571
XU630 NR2 $PINS O=n409 I1=n408 I2=n407
XU631 ND3 $PINS O=bank_rdata[1][7] I1=n411 I2=n410 I3=n409
XU632 AOI22S $PINS O=n416 A1=bank_mem_1[14][8] A2=n556 B1=bank_mem_1[15][8]
+ B2=n555
XU633 AOI22S $PINS O=n415 A1=bank_mem_1[12][8] A2=n558 B1=bank_mem_1[13][8]
+ B2=n557
XU634 AOI22S $PINS O=n413 A1=bank_mem_1[10][8] A2=n4 B1=bank_mem_1[11][8]
+ B2=n559
XU635 AOI22S $PINS O=n412 A1=bank_mem_1[8][8] A2=n2 B1=bank_mem_1[9][8] B2=n560
XU636 AN2 $PINS O=n414 I1=n413 I2=n412
XU637 ND3 $PINS O=n417 I1=n416 I2=n415 I3=n414
XU638 AOI22S $PINS O=n422 A1=bank_mem_1[7][8] A2=n7 B1=n417 B2=N34
XU639 AOI22S $PINS O=n421 A1=bank_mem_1[5][8] A2=n8 B1=bank_mem_1[6][8] B2=n567
XU640 AO222 $PINS O=n419 A1=bank_mem_1[1][8] A2=n570 B1=bank_mem_1[0][8]
+ B2=n569 C1=bank_mem_1[2][8] C2=n568
XU641 AO22 $PINS O=n418 A1=bank_mem_1[4][8] A2=n572 B1=bank_mem_1[3][8] B2=n571
XU642 NR2 $PINS O=n420 I1=n419 I2=n418
XU643 ND3 $PINS O=bank_rdata[1][8] I1=n422 I2=n421 I3=n420
XU644 AOI22S $PINS O=n427 A1=bank_mem_1[14][9] A2=n556 B1=bank_mem_1[15][9]
+ B2=n555
XU645 AOI22S $PINS O=n426 A1=bank_mem_1[12][9] A2=n558 B1=bank_mem_1[13][9]
+ B2=n557
XU646 AOI22S $PINS O=n424 A1=bank_mem_1[10][9] A2=n4 B1=bank_mem_1[11][9]
+ B2=n559
XU647 AOI22S $PINS O=n423 A1=bank_mem_1[8][9] A2=n2 B1=bank_mem_1[9][9] B2=n560
XU648 AN2 $PINS O=n425 I1=n424 I2=n423
XU649 ND3 $PINS O=n428 I1=n427 I2=n426 I3=n425
XU650 AOI22S $PINS O=n433 A1=bank_mem_1[7][9] A2=n7 B1=n428 B2=N34
XU651 AOI22S $PINS O=n432 A1=bank_mem_1[5][9] A2=n8 B1=bank_mem_1[6][9] B2=n567
XU652 AO222 $PINS O=n430 A1=bank_mem_1[1][9] A2=n570 B1=bank_mem_1[0][9]
+ B2=n569 C1=bank_mem_1[2][9] C2=n568
XU653 AO22 $PINS O=n429 A1=bank_mem_1[4][9] A2=n572 B1=bank_mem_1[3][9] B2=n571
XU654 NR2 $PINS O=n431 I1=n430 I2=n429
XU655 ND3 $PINS O=bank_rdata[1][9] I1=n433 I2=n432 I3=n431
XU656 AOI22S $PINS O=n438 A1=bank_mem_1[14][10] A2=n556 B1=bank_mem_1[15][10]
+ B2=n555
XU657 AOI22S $PINS O=n437 A1=bank_mem_1[12][10] A2=n558 B1=bank_mem_1[13][10]
+ B2=n557
XU658 AOI22S $PINS O=n435 A1=bank_mem_1[10][10] A2=n4 B1=bank_mem_1[11][10]
+ B2=n559
XU659 AOI22S $PINS O=n434 A1=bank_mem_1[8][10] A2=n2 B1=bank_mem_1[9][10]
+ B2=n560
XU660 AN2 $PINS O=n436 I1=n435 I2=n434
XU661 ND3 $PINS O=n439 I1=n438 I2=n437 I3=n436
XU662 AOI22S $PINS O=n444 A1=bank_mem_1[7][10] A2=n7 B1=n439 B2=N34
XU663 AOI22S $PINS O=n443 A1=bank_mem_1[5][10] A2=n8 B1=bank_mem_1[6][10]
+ B2=n567
XU664 AO222 $PINS O=n441 A1=bank_mem_1[1][10] A2=n570 B1=bank_mem_1[0][10]
+ B2=n569 C1=bank_mem_1[2][10] C2=n568
XU665 AO22 $PINS O=n440 A1=bank_mem_1[4][10] A2=n572 B1=bank_mem_1[3][10]
+ B2=n571
XU666 NR2 $PINS O=n442 I1=n441 I2=n440
XU667 ND3 $PINS O=bank_rdata[1][10] I1=n444 I2=n443 I3=n442
XU668 AOI22S $PINS O=n449 A1=bank_mem_1[14][11] A2=n556 B1=bank_mem_1[15][11]
+ B2=n555
XU669 AOI22S $PINS O=n448 A1=bank_mem_1[12][11] A2=n558 B1=bank_mem_1[13][11]
+ B2=n557
XU670 AOI22S $PINS O=n446 A1=bank_mem_1[10][11] A2=n4 B1=bank_mem_1[11][11]
+ B2=n559
XU671 AOI22S $PINS O=n445 A1=bank_mem_1[8][11] A2=n2 B1=bank_mem_1[9][11]
+ B2=n560
XU672 AN2 $PINS O=n447 I1=n446 I2=n445
XU673 ND3 $PINS O=n450 I1=n449 I2=n448 I3=n447
XU674 AOI22S $PINS O=n455 A1=bank_mem_1[7][11] A2=n7 B1=n450 B2=N34
XU675 AOI22S $PINS O=n454 A1=bank_mem_1[5][11] A2=n8 B1=bank_mem_1[6][11]
+ B2=n567
XU676 AO222 $PINS O=n452 A1=bank_mem_1[1][11] A2=n570 B1=bank_mem_1[0][11]
+ B2=n569 C1=bank_mem_1[2][11] C2=n568
XU677 AO22 $PINS O=n451 A1=bank_mem_1[4][11] A2=n572 B1=bank_mem_1[3][11]
+ B2=n571
XU678 NR2 $PINS O=n453 I1=n452 I2=n451
XU679 ND3 $PINS O=FE_PHN1514_bank_rdata_1_11 I1=n455 I2=n454 I3=n453
XU680 AOI22S $PINS O=n460 A1=bank_mem_1[14][12] A2=n556 B1=bank_mem_1[15][12]
+ B2=n555
XU681 AOI22S $PINS O=n459 A1=bank_mem_1[12][12] A2=n558 B1=bank_mem_1[13][12]
+ B2=n557
XU682 AOI22S $PINS O=n457 A1=bank_mem_1[10][12] A2=n4 B1=bank_mem_1[11][12]
+ B2=n559
XU683 AOI22S $PINS O=n456 A1=bank_mem_1[8][12] A2=n2 B1=bank_mem_1[9][12]
+ B2=n560
XU684 AN2 $PINS O=n458 I1=n457 I2=n456
XU685 ND3 $PINS O=n461 I1=n460 I2=n459 I3=n458
XU686 AOI22S $PINS O=n466 A1=bank_mem_1[7][12] A2=n7 B1=n461 B2=N34
XU687 AOI22S $PINS O=n465 A1=bank_mem_1[5][12] A2=n8 B1=bank_mem_1[6][12]
+ B2=n567
XU688 AO222 $PINS O=n463 A1=bank_mem_1[1][12] A2=n570 B1=bank_mem_1[0][12]
+ B2=n569 C1=bank_mem_1[2][12] C2=n568
XU689 AO22 $PINS O=n462 A1=bank_mem_1[4][12] A2=n572 B1=bank_mem_1[3][12]
+ B2=n571
XU690 NR2 $PINS O=n464 I1=n463 I2=n462
XU691 ND3 $PINS O=bank_rdata[1][12] I1=n466 I2=n465 I3=n464
XU692 AOI22S $PINS O=n471 A1=bank_mem_1[14][13] A2=n556 B1=bank_mem_1[15][13]
+ B2=n555
XU693 AOI22S $PINS O=n470 A1=bank_mem_1[12][13] A2=n558 B1=bank_mem_1[13][13]
+ B2=n557
XU694 AOI22S $PINS O=n468 A1=bank_mem_1[10][13] A2=n4 B1=bank_mem_1[11][13]
+ B2=n559
XU695 AOI22S $PINS O=n467 A1=bank_mem_1[8][13] A2=n2 B1=bank_mem_1[9][13]
+ B2=n560
XU696 AN2 $PINS O=n469 I1=n468 I2=n467
XU697 ND3 $PINS O=n472 I1=n471 I2=n470 I3=n469
XU698 AOI22S $PINS O=n477 A1=bank_mem_1[7][13] A2=n7 B1=n472 B2=N34
XU699 AOI22S $PINS O=n476 A1=bank_mem_1[5][13] A2=n8 B1=bank_mem_1[6][13]
+ B2=n567
XU700 AO222 $PINS O=n474 A1=bank_mem_1[1][13] A2=n570 B1=bank_mem_1[0][13]
+ B2=n569 C1=bank_mem_1[2][13] C2=n568
XU701 AO22 $PINS O=n473 A1=bank_mem_1[4][13] A2=n572 B1=bank_mem_1[3][13]
+ B2=n571
XU702 NR2 $PINS O=n475 I1=n474 I2=n473
XU703 ND3 $PINS O=bank_rdata[1][13] I1=n477 I2=n476 I3=n475
XU704 AOI22S $PINS O=n482 A1=bank_mem_1[14][14] A2=n556 B1=bank_mem_1[15][14]
+ B2=n555
XU705 AOI22S $PINS O=n481 A1=bank_mem_1[12][14] A2=n558 B1=bank_mem_1[13][14]
+ B2=n557
XU706 AOI22S $PINS O=n479 A1=bank_mem_1[10][14] A2=n4 B1=bank_mem_1[11][14]
+ B2=n559
XU707 AOI22S $PINS O=n478 A1=bank_mem_1[8][14] A2=n2 B1=bank_mem_1[9][14]
+ B2=n560
XU708 AN2 $PINS O=n480 I1=n479 I2=n478
XU709 ND3 $PINS O=n483 I1=n482 I2=n481 I3=n480
XU710 AOI22S $PINS O=n488 A1=bank_mem_1[7][14] A2=n7 B1=n483 B2=N34
XU711 AOI22S $PINS O=n487 A1=bank_mem_1[5][14] A2=n8 B1=bank_mem_1[6][14]
+ B2=n567
XU712 AO222 $PINS O=n485 A1=bank_mem_1[1][14] A2=n570 B1=bank_mem_1[0][14]
+ B2=n569 C1=bank_mem_1[2][14] C2=n568
XU713 AO22 $PINS O=n484 A1=bank_mem_1[4][14] A2=n572 B1=bank_mem_1[3][14]
+ B2=n571
XU714 NR2 $PINS O=n486 I1=n485 I2=n484
XU715 ND3 $PINS O=bank_rdata[1][14] I1=n488 I2=n487 I3=n486
XU716 AOI22S $PINS O=n493 A1=bank_mem_1[14][15] A2=n556 B1=bank_mem_1[15][15]
+ B2=n555
XU717 AOI22S $PINS O=n492 A1=bank_mem_1[12][15] A2=n558 B1=bank_mem_1[13][15]
+ B2=n557
XU718 AOI22S $PINS O=n490 A1=bank_mem_1[10][15] A2=n4 B1=bank_mem_1[11][15]
+ B2=n559
XU719 AOI22S $PINS O=n489 A1=bank_mem_1[8][15] A2=n2 B1=bank_mem_1[9][15]
+ B2=n560
XU720 AN2 $PINS O=n491 I1=n490 I2=n489
XU721 ND3 $PINS O=n494 I1=n493 I2=n492 I3=n491
XU722 AOI22S $PINS O=n499 A1=bank_mem_1[7][15] A2=n7 B1=n494 B2=N34
XU723 AOI22S $PINS O=n498 A1=bank_mem_1[5][15] A2=n8 B1=bank_mem_1[6][15]
+ B2=n567
XU724 AO222 $PINS O=n496 A1=bank_mem_1[1][15] A2=n570 B1=bank_mem_1[0][15]
+ B2=n569 C1=bank_mem_1[2][15] C2=n568
XU725 AO22 $PINS O=n495 A1=bank_mem_1[4][15] A2=n572 B1=bank_mem_1[3][15]
+ B2=n571
XU726 NR2 $PINS O=n497 I1=n496 I2=n495
XU727 ND3 $PINS O=bank_rdata[1][15] I1=n499 I2=n498 I3=n497
XU728 AOI22S $PINS O=n504 A1=bank_mem_1[14][16] A2=n556 B1=bank_mem_1[15][16]
+ B2=n555
XU729 AOI22S $PINS O=n503 A1=bank_mem_1[12][16] A2=n558 B1=bank_mem_1[13][16]
+ B2=n557
XU730 AOI22S $PINS O=n501 A1=bank_mem_1[10][16] A2=n4 B1=bank_mem_1[11][16]
+ B2=n559
XU731 AOI22S $PINS O=n500 A1=bank_mem_1[8][16] A2=n2 B1=bank_mem_1[9][16]
+ B2=n560
XU732 AN2 $PINS O=n502 I1=n501 I2=n500
XU733 ND3 $PINS O=n505 I1=n504 I2=n503 I3=n502
XU734 AOI22S $PINS O=n510 A1=bank_mem_1[7][16] A2=n7 B1=n505 B2=N34
XU735 AOI22S $PINS O=n509 A1=bank_mem_1[5][16] A2=n8 B1=bank_mem_1[6][16]
+ B2=n567
XU736 AO222 $PINS O=n507 A1=bank_mem_1[1][16] A2=n570 B1=bank_mem_1[0][16]
+ B2=n569 C1=bank_mem_1[2][16] C2=n568
XU737 AO22 $PINS O=n506 A1=bank_mem_1[4][16] A2=n572 B1=bank_mem_1[3][16]
+ B2=n571
XU738 NR2 $PINS O=n508 I1=n507 I2=n506
XU739 ND3 $PINS O=bank_rdata[1][16] I1=n510 I2=n509 I3=n508
XU740 AOI22S $PINS O=n515 A1=bank_mem_1[14][17] A2=n556 B1=bank_mem_1[15][17]
+ B2=n555
XU741 AOI22S $PINS O=n514 A1=bank_mem_1[12][17] A2=n558 B1=bank_mem_1[13][17]
+ B2=n557
XU742 AOI22S $PINS O=n512 A1=bank_mem_1[10][17] A2=n4 B1=bank_mem_1[11][17]
+ B2=n559
XU743 AOI22S $PINS O=n511 A1=bank_mem_1[8][17] A2=n2 B1=bank_mem_1[9][17]
+ B2=n560
XU744 AN2 $PINS O=n513 I1=n512 I2=n511
XU745 ND3 $PINS O=n516 I1=n515 I2=n514 I3=n513
XU746 AOI22S $PINS O=n521 A1=bank_mem_1[7][17] A2=n7 B1=n516 B2=N34
XU747 AOI22S $PINS O=n520 A1=bank_mem_1[5][17] A2=n8 B1=bank_mem_1[6][17]
+ B2=n567
XU748 AO222 $PINS O=n518 A1=bank_mem_1[1][17] A2=n570 B1=bank_mem_1[0][17]
+ B2=n569 C1=bank_mem_1[2][17] C2=n568
XU749 AO22 $PINS O=n517 A1=bank_mem_1[4][17] A2=n572 B1=bank_mem_1[3][17]
+ B2=n571
XU750 NR2 $PINS O=n519 I1=n518 I2=n517
XU751 ND3 $PINS O=bank_rdata[1][17] I1=n521 I2=n520 I3=n519
XU752 AOI22S $PINS O=n526 A1=bank_mem_1[14][18] A2=n556 B1=bank_mem_1[15][18]
+ B2=n555
XU753 AOI22S $PINS O=n525 A1=bank_mem_1[12][18] A2=n558 B1=bank_mem_1[13][18]
+ B2=n557
XU754 AOI22S $PINS O=n523 A1=bank_mem_1[10][18] A2=n4 B1=bank_mem_1[11][18]
+ B2=n559
XU755 AOI22S $PINS O=n522 A1=bank_mem_1[8][18] A2=n2 B1=bank_mem_1[9][18]
+ B2=n560
XU756 AN2 $PINS O=n524 I1=n523 I2=n522
XU757 ND3 $PINS O=n527 I1=n526 I2=n525 I3=n524
XU758 AOI22S $PINS O=n532 A1=bank_mem_1[7][18] A2=n7 B1=n527 B2=N34
XU759 AOI22S $PINS O=n531 A1=bank_mem_1[5][18] A2=n8 B1=bank_mem_1[6][18]
+ B2=n567
XU760 AO222 $PINS O=n529 A1=bank_mem_1[1][18] A2=n570 B1=bank_mem_1[0][18]
+ B2=n569 C1=bank_mem_1[2][18] C2=n568
XU761 AO22 $PINS O=n528 A1=bank_mem_1[4][18] A2=n572 B1=bank_mem_1[3][18]
+ B2=n571
XU762 NR2 $PINS O=n530 I1=n529 I2=n528
XU763 ND3 $PINS O=bank_rdata[1][18] I1=n532 I2=n531 I3=n530
XU764 AOI22S $PINS O=n537 A1=bank_mem_1[14][19] A2=n556 B1=bank_mem_1[15][19]
+ B2=n555
XU765 AOI22S $PINS O=n536 A1=bank_mem_1[12][19] A2=n558 B1=bank_mem_1[13][19]
+ B2=n557
XU766 AOI22S $PINS O=n534 A1=bank_mem_1[10][19] A2=n4 B1=bank_mem_1[11][19]
+ B2=n559
XU767 AOI22S $PINS O=n533 A1=bank_mem_1[8][19] A2=n2 B1=bank_mem_1[9][19]
+ B2=n560
XU768 AN2 $PINS O=n535 I1=n534 I2=n533
XU769 ND3 $PINS O=n538 I1=n537 I2=n536 I3=n535
XU770 AOI22S $PINS O=n543 A1=bank_mem_1[7][19] A2=n7 B1=n538 B2=N34
XU771 AOI22S $PINS O=n542 A1=bank_mem_1[5][19] A2=n8 B1=bank_mem_1[6][19]
+ B2=n567
XU772 AO222 $PINS O=n540 A1=bank_mem_1[1][19] A2=n570 B1=bank_mem_1[0][19]
+ B2=n569 C1=bank_mem_1[2][19] C2=n568
XU773 AO22 $PINS O=n539 A1=bank_mem_1[4][19] A2=n572 B1=bank_mem_1[3][19]
+ B2=n571
XU774 NR2 $PINS O=n541 I1=n540 I2=n539
XU775 ND3 $PINS O=FE_PHN1513_bank_rdata_1_19 I1=n543 I2=n542 I3=n541
XU776 AOI22S $PINS O=n548 A1=bank_mem_1[14][20] A2=n556 B1=bank_mem_1[15][20]
+ B2=n555
XU777 AOI22S $PINS O=n547 A1=bank_mem_1[12][20] A2=n558 B1=bank_mem_1[13][20]
+ B2=n557
XU778 AOI22S $PINS O=n545 A1=bank_mem_1[10][20] A2=n4 B1=bank_mem_1[11][20]
+ B2=n559
XU779 AOI22S $PINS O=n544 A1=bank_mem_1[8][20] A2=n2 B1=bank_mem_1[9][20]
+ B2=n560
XU780 AN2 $PINS O=n546 I1=n545 I2=n544
XU781 ND3 $PINS O=n549 I1=n548 I2=n547 I3=n546
XU782 AOI22S $PINS O=n554 A1=bank_mem_1[7][20] A2=n7 B1=n549 B2=N34
XU783 AOI22S $PINS O=n553 A1=bank_mem_1[5][20] A2=n8 B1=bank_mem_1[6][20]
+ B2=n567
XU784 AO222 $PINS O=n551 A1=bank_mem_1[1][20] A2=n570 B1=bank_mem_1[0][20]
+ B2=n569 C1=bank_mem_1[2][20] C2=n568
XU785 AO22 $PINS O=n550 A1=bank_mem_1[4][20] A2=n572 B1=bank_mem_1[3][20]
+ B2=n571
XU786 NR2 $PINS O=n552 I1=n551 I2=n550
XU787 ND3 $PINS O=bank_rdata[1][20] I1=n554 I2=n553 I3=n552
XU788 AOI22S $PINS O=n565 A1=bank_mem_1[14][21] A2=n556 B1=bank_mem_1[15][21]
+ B2=n555
XU789 AOI22S $PINS O=n564 A1=bank_mem_1[12][21] A2=n558 B1=bank_mem_1[13][21]
+ B2=n557
XU790 AOI22S $PINS O=n562 A1=bank_mem_1[10][21] A2=n4 B1=bank_mem_1[11][21]
+ B2=n559
XU791 AOI22S $PINS O=n561 A1=bank_mem_1[8][21] A2=n2 B1=bank_mem_1[9][21]
+ B2=n560
XU792 AN2 $PINS O=n563 I1=n562 I2=n561
XU793 ND3 $PINS O=n566 I1=n565 I2=n564 I3=n563
XU794 AOI22S $PINS O=n577 A1=bank_mem_1[7][21] A2=n7 B1=N34 B2=n566
XU795 AOI22S $PINS O=n576 A1=bank_mem_1[5][21] A2=n8 B1=bank_mem_1[6][21]
+ B2=n567
XU796 AO222 $PINS O=n574 A1=bank_mem_1[1][21] A2=n570 B1=bank_mem_1[0][21]
+ B2=n569 C1=bank_mem_1[2][21] C2=n568
XU797 AO22 $PINS O=n573 A1=bank_mem_1[4][21] A2=n572 B1=bank_mem_1[3][21]
+ B2=n571
XU798 NR2 $PINS O=n575 I1=n574 I2=n573
XU799 ND3 $PINS O=FE_PHN1538_bank_rdata_1_21 I1=n577 I2=n576 I3=n575
Xclk_gate_bank_mem_1_reg[0] SNPS_CLOCK_GATE_HIGH_RegFileDual_DATA_WIDTH22_0
+ $PINS EN=N100 ENCLK=CTS_390 CLK=CTS_391
Xclk_gate_bank_mem_1_reg[1] SNPS_CLOCK_GATE_HIGH_RegFileDual_DATA_WIDTH22_31
+ $PINS EN=N99 ENCLK=CTS_387 CLK=CTS_391
Xclk_gate_bank_mem_1_reg[2] SNPS_CLOCK_GATE_HIGH_RegFileDual_DATA_WIDTH22_30
+ $PINS EN=N98 ENCLK=CTS_384 CLK=CTS_391
Xclk_gate_bank_mem_1_reg[3] SNPS_CLOCK_GATE_HIGH_RegFileDual_DATA_WIDTH22_29
+ $PINS EN=N97 ENCLK=CTS_381 CLK=CTS_391
Xclk_gate_bank_mem_1_reg[4] SNPS_CLOCK_GATE_HIGH_RegFileDual_DATA_WIDTH22_28
+ $PINS EN=N96 ENCLK=CTS_378 CLK=CTS_391
Xclk_gate_bank_mem_1_reg[5] SNPS_CLOCK_GATE_HIGH_RegFileDual_DATA_WIDTH22_27
+ $PINS EN=N95 ENCLK=CTS_375 CLK=CTS_391
Xclk_gate_bank_mem_1_reg[6] SNPS_CLOCK_GATE_HIGH_RegFileDual_DATA_WIDTH22_26
+ $PINS EN=N94 ENCLK=CTS_372 CLK=CTS_391
Xclk_gate_bank_mem_1_reg[7] SNPS_CLOCK_GATE_HIGH_RegFileDual_DATA_WIDTH22_25
+ $PINS EN=N93 ENCLK=CTS_369 CLK=CTS_391
Xclk_gate_bank_mem_1_reg[8] SNPS_CLOCK_GATE_HIGH_RegFileDual_DATA_WIDTH22_24
+ $PINS EN=N92 ENCLK=CTS_366 CLK=CTS_391
Xclk_gate_bank_mem_1_reg[9] SNPS_CLOCK_GATE_HIGH_RegFileDual_DATA_WIDTH22_23
+ $PINS EN=N91 ENCLK=CTS_363 CLK=CTS_391
Xclk_gate_bank_mem_1_reg[10] SNPS_CLOCK_GATE_HIGH_RegFileDual_DATA_WIDTH22_22
+ $PINS EN=N90 ENCLK=CTS_360 CLK=CTS_391
Xclk_gate_bank_mem_1_reg[11] SNPS_CLOCK_GATE_HIGH_RegFileDual_DATA_WIDTH22_21
+ $PINS EN=N89 ENCLK=CTS_357 CLK=CTS_391
Xclk_gate_bank_mem_1_reg[12] SNPS_CLOCK_GATE_HIGH_RegFileDual_DATA_WIDTH22_20
+ $PINS EN=N88 ENCLK=CTS_354 CLK=CTS_391
Xclk_gate_bank_mem_1_reg[13] SNPS_CLOCK_GATE_HIGH_RegFileDual_DATA_WIDTH22_19
+ $PINS EN=N87 ENCLK=CTS_351 CLK=CTS_391
Xclk_gate_bank_mem_1_reg[14] SNPS_CLOCK_GATE_HIGH_RegFileDual_DATA_WIDTH22_18
+ $PINS EN=N86 ENCLK=CTS_348 CLK=CTS_391
Xclk_gate_bank_mem_1_reg[15] SNPS_CLOCK_GATE_HIGH_RegFileDual_DATA_WIDTH22_17
+ $PINS EN=N85 ENCLK=CTS_345 CLK=CTS_391
Xclk_gate_bank_mem_0_reg[0] SNPS_CLOCK_GATE_HIGH_RegFileDual_DATA_WIDTH22_16
+ $PINS EN=N67 ENCLK=CTS_342 CLK=clk_clone1
Xclk_gate_bank_mem_0_reg[1] SNPS_CLOCK_GATE_HIGH_RegFileDual_DATA_WIDTH22_15
+ $PINS EN=N66 ENCLK=CTS_339 CLK=clk_clone1
Xclk_gate_bank_mem_0_reg[2] SNPS_CLOCK_GATE_HIGH_RegFileDual_DATA_WIDTH22_14
+ $PINS EN=N65 ENCLK=CTS_336 CLK=clk_clone1
Xclk_gate_bank_mem_0_reg[3] SNPS_CLOCK_GATE_HIGH_RegFileDual_DATA_WIDTH22_13
+ $PINS EN=N64 ENCLK=CTS_333 CLK=clk_clone1
Xclk_gate_bank_mem_0_reg[4] SNPS_CLOCK_GATE_HIGH_RegFileDual_DATA_WIDTH22_12
+ $PINS EN=N63 ENCLK=CTS_330 CLK=clk_clone1
Xclk_gate_bank_mem_0_reg[5] SNPS_CLOCK_GATE_HIGH_RegFileDual_DATA_WIDTH22_11
+ $PINS EN=N62 ENCLK=CTS_327 CLK=clk_clone1
Xclk_gate_bank_mem_0_reg[6] SNPS_CLOCK_GATE_HIGH_RegFileDual_DATA_WIDTH22_10
+ $PINS EN=N61 ENCLK=CTS_324 CLK=clk_clone1
Xclk_gate_bank_mem_0_reg[7] SNPS_CLOCK_GATE_HIGH_RegFileDual_DATA_WIDTH22_9
+ $PINS EN=N60 ENCLK=CTS_321 CLK=clk_clone1
Xclk_gate_bank_mem_0_reg[8] SNPS_CLOCK_GATE_HIGH_RegFileDual_DATA_WIDTH22_8
+ $PINS EN=N59 ENCLK=CTS_318 CLK=clk_clone1
Xclk_gate_bank_mem_0_reg[9] SNPS_CLOCK_GATE_HIGH_RegFileDual_DATA_WIDTH22_7
+ $PINS EN=N58 ENCLK=CTS_315 CLK=clk_clone1
Xclk_gate_bank_mem_0_reg[10] SNPS_CLOCK_GATE_HIGH_RegFileDual_DATA_WIDTH22_6
+ $PINS EN=N57 ENCLK=CTS_312 CLK=clk_clone1
Xclk_gate_bank_mem_0_reg[11] SNPS_CLOCK_GATE_HIGH_RegFileDual_DATA_WIDTH22_5
+ $PINS EN=N56 ENCLK=CTS_309 CLK=clk_clone1
Xclk_gate_bank_mem_0_reg[12] SNPS_CLOCK_GATE_HIGH_RegFileDual_DATA_WIDTH22_4
+ $PINS EN=N55 ENCLK=CTS_306 CLK=clk_clone1
Xclk_gate_bank_mem_0_reg[13] SNPS_CLOCK_GATE_HIGH_RegFileDual_DATA_WIDTH22_3
+ $PINS EN=N54 ENCLK=CTS_303 CLK=clk_clone1
Xclk_gate_bank_mem_0_reg[14] SNPS_CLOCK_GATE_HIGH_RegFileDual_DATA_WIDTH22_2
+ $PINS EN=N53 ENCLK=CTS_300 CLK=clk_clone1
Xclk_gate_bank_mem_0_reg[15] SNPS_CLOCK_GATE_HIGH_RegFileDual_DATA_WIDTH22_1
+ $PINS EN=N52 ENCLK=CTS_297 CLK=clk_clone1
.ENDS

.SUBCKT SNPS_CLOCK_GATE_HIGH_CHIP_0 EN ENCLK CLK
*.CONNECT ENCLK net1640
*.CONNECT net1641 EN
XFE_PHC1285_net1644 DELC $PINS O=FE_PHN1285_net1644 I=net1644
Xlatch QDBHN $PINS Q=net1644 D=net1641 CKB=CLK
Xmain_gate AN2P $PINS O=net1640 I1=FE_PHN1285_net1644 I2=CLK
.ENDS

.SUBCKT SNPS_CLOCK_GATE_HIGH_CHIP_11 EN ENCLK CLK
*.CONNECT net1641 EN
XFE_PHC1317_net1644 DELC $PINS O=FE_PHN1317_net1644 I=net1644
Xlatch QDBHN $PINS Q=net1644 D=net1641 CKB=CLK
Xmain_gate AN2T $PINS O=ENCLK I1=FE_PHN1317_net1644 I2=CLK
.ENDS

.SUBCKT SNPS_CLOCK_GATE_HIGH_CHIP_10 EN ENCLK CLK
*.CONNECT net1641 EN
XFE_PHC1340_net1644 DELC $PINS O=FE_PHN1340_net1644 I=net1644
Xlatch QDBHN $PINS Q=net1644 D=net1641 CKB=CLK
Xmain_gate AN2T $PINS O=ENCLK I1=FE_PHN1340_net1644 I2=CLK
.ENDS

.SUBCKT SNPS_CLOCK_GATE_HIGH_CHIP_9 EN ENCLK CLK
*.CONNECT net1641 EN
XFE_PHC1326_net1644 DELC $PINS O=net1644 I=FE_PHN1326_net1644
Xlatch QDBHN $PINS Q=FE_PHN1326_net1644 D=net1641 CKB=CLK
Xmain_gate AN2T $PINS O=ENCLK I1=net1644 I2=CLK
.ENDS

.SUBCKT SNPS_CLOCK_GATE_HIGH_CHIP_8 EN ENCLK CLK
*.CONNECT net1641 EN
XFE_PHC1319_net1644 DELC $PINS O=FE_PHN1319_net1644 I=net1644
Xlatch QDBHN $PINS Q=net1644 D=net1641 CKB=CLK
Xmain_gate AN2T $PINS O=ENCLK I1=FE_PHN1319_net1644 I2=CLK
.ENDS

.SUBCKT SNPS_CLOCK_GATE_HIGH_CHIP_7 EN ENCLK CLK
*.CONNECT net1641 EN
XFE_PHC1350_net1644 DELC $PINS O=net1644 I=FE_PHN1350_net1644
Xlatch QDBHN $PINS Q=FE_PHN1350_net1644 D=net1641 CKB=CLK
Xmain_gate AN2T $PINS O=ENCLK I1=net1644 I2=CLK
.ENDS

.SUBCKT SNPS_CLOCK_GATE_HIGH_CHIP_6 EN ENCLK CLK
*.CONNECT net1641 EN
XFE_PHC1311_net1644 DELC $PINS O=net1644 I=FE_PHN1311_net1644
Xlatch QDBHN $PINS Q=FE_PHN1311_net1644 D=net1641 CKB=CLK
Xmain_gate AN2 $PINS O=ENCLK I1=net1644 I2=CLK
.ENDS

.SUBCKT SNPS_CLOCK_GATE_HIGH_CHIP_5 EN ENCLK CLK
*.CONNECT net1641 EN
XFE_PHC1354_net1644 DELC $PINS O=FE_PHN1354_net1644 I=net1644
Xlatch QDBHN $PINS Q=net1644 D=net1641 CKB=CLK
Xmain_gate AN2T $PINS O=ENCLK I1=FE_PHN1354_net1644 I2=CLK
.ENDS

.SUBCKT SNPS_CLOCK_GATE_HIGH_CHIP_4 EN ENCLK CLK
*.CONNECT ENCLK net1640
*.CONNECT net1641 EN
XFE_PHC1279_net1644 DELC $PINS O=FE_PHN1279_net1644 I=net1644
Xlatch QDBHN $PINS Q=net1644 D=net1641 CKB=CLK
Xmain_gate AN2P $PINS O=net1640 I1=FE_PHN1279_net1644 I2=CLK
.ENDS

.SUBCKT SNPS_CLOCK_GATE_HIGH_CHIP_3 EN ENCLK CLK
*.CONNECT ENCLK net1640
*.CONNECT net1641 EN
XFE_PHC1278_net1644 DELC $PINS O=FE_PHN1278_net1644 I=net1644
Xlatch QDBHN $PINS Q=net1644 D=net1641 CKB=CLK
Xmain_gate AN2P $PINS O=net1640 I1=FE_PHN1278_net1644 I2=CLK
.ENDS

.SUBCKT SNPS_CLOCK_GATE_HIGH_CHIP_2 EN ENCLK CLK
*.CONNECT ENCLK net1640
*.CONNECT net1641 EN
XFE_PHC1281_net1644 DELC $PINS O=FE_PHN1281_net1644 I=net1644
Xlatch QDBHN $PINS Q=net1644 D=net1641 CKB=CLK
Xmain_gate AN2T $PINS O=net1640 I1=FE_PHN1281_net1644 I2=CLK
.ENDS

.SUBCKT SNPS_CLOCK_GATE_HIGH_CHIP_1 EN ENCLK CLK
*.CONNECT ENCLK net1640
*.CONNECT net1641 EN
XFE_PHC1318_net1644 DELC $PINS O=FE_PHN1318_net1644 I=net1644
Xlatch QDBHN $PINS Q=net1644 D=net1641 CKB=CLK
Xmain_gate AN2T $PINS O=net1640 I1=FE_PHN1318_net1644 I2=CLK
.ENDS

.SUBCKT CHIP_DW01_inc_1_DW01_inc_3 A[8] A[7] A[6] A[5] A[4] A[3] A[2] A[1] A[0]
+ SUM[8] SUM[7] SUM[6] SUM[5] SUM[4] SUM[3] SUM[2] SUM[1] SUM[0]
XU1_1_7 HA1 $PINS S=SUM[7] C=carry[8] A=A[7] B=carry[7]
XU1_1_6 HA1 $PINS S=SUM[6] C=carry[7] A=A[6] B=carry[6]
XU1_1_5 HA1 $PINS S=SUM[5] C=carry[6] A=A[5] B=carry[5]
XU1_1_4 HA1 $PINS S=SUM[4] C=carry[5] A=A[4] B=carry[4]
XU1_1_3 HA1 $PINS S=SUM[3] C=carry[4] A=A[3] B=carry[3]
XU1_1_2 HA1 $PINS S=SUM[2] C=carry[3] A=A[2] B=carry[2]
XU1_1_1 HA1 $PINS S=SUM[1] C=carry[2] A=A[1] B=A[0]
XU1 XOR2HS $PINS O=SUM[8] I1=carry[8] I2=A[8]
.ENDS

.SUBCKT CHIP_DW02_mult_1 A[5] A[4] A[3] A[2] A[1] A[0] B[7] B[6] B[5] B[4] B[3]
+ B[2] B[1] B[0] TC PRODUCT[13] PRODUCT[12] PRODUCT[11] PRODUCT[10] PRODUCT[9]
+ PRODUCT[8] PRODUCT[7] PRODUCT[6] PRODUCT[5] PRODUCT[4] PRODUCT[3] PRODUCT[2]
+ PRODUCT[1] PRODUCT[0]
XS2_2_5 XOR3 $PINS O=SUMB[2][5] I1=ab[2][5] I2=n8 I3=SUMB[1][6]
XS2_3_4 XOR3 $PINS O=SUMB[3][4] I1=ab[3][4] I2=CARRYB[2][4] I3=SUMB[2][5]
XS2_2_4 FA1S $PINS S=SUMB[2][4] CO=CARRYB[2][4] A=ab[2][4] B=n2 CI=SUMB[1][5]
XS1_2_0 FA1S $PINS S=PRODUCT[2] CO=CARRYB[2][0] A=ab[2][0] B=n6 CI=SUMB[1][1]
XS2_3_3 FA1S $PINS S=SUMB[3][3] CO=CARRYB[3][3] A=ab[3][3] B=CARRYB[2][3]
+ CI=SUMB[2][4]
XS2_2_3 FA1S $PINS S=SUMB[2][3] CO=CARRYB[2][3] A=ab[2][3] B=n3 CI=SUMB[1][4]
XS2_4_2 FA1S $PINS S=SUMB[4][2] CO=CARRYB[4][2] A=ab[4][2] B=CARRYB[3][2]
+ CI=SUMB[3][3]
XS2_3_2 FA1S $PINS S=SUMB[3][2] CO=CARRYB[3][2] A=ab[3][2] B=CARRYB[2][2]
+ CI=SUMB[2][3]
XS2_4_3 XOR3 $PINS O=SUMB[4][3] I1=ab[4][3] I2=CARRYB[3][3] I3=SUMB[3][4]
XS4_2 XOR3 $PINS O=SUMB[5][2] I1=ab[5][2] I2=CARRYB[4][2] I3=SUMB[4][3]
XS2_2_2 FA1S $PINS S=SUMB[2][2] CO=CARRYB[2][2] A=ab[2][2] B=n4 CI=SUMB[1][3]
XS2_4_1 FA1S $PINS S=SUMB[4][1] CO=CARRYB[4][1] A=ab[4][1] B=CARRYB[3][1]
+ CI=SUMB[3][2]
XS2_3_1 FA1S $PINS S=SUMB[3][1] CO=CARRYB[3][1] A=ab[3][1] B=CARRYB[2][1]
+ CI=SUMB[2][2]
XS4_1 FA1S $PINS S=SUMB[5][1] CO=CARRYB[5][1] A=ab[5][1] B=CARRYB[4][1]
+ CI=SUMB[4][2]
XS2_2_1 FA1S $PINS S=SUMB[2][1] CO=CARRYB[2][1] A=ab[2][1] B=n5 CI=SUMB[1][2]
XS1_4_0 FA1S $PINS S=PRODUCT[4] CO=CARRYB[4][0] A=ab[4][0] B=CARRYB[3][0]
+ CI=SUMB[3][1]
XS1_3_0 FA1S $PINS S=PRODUCT[3] CO=CARRYB[3][0] A=ab[3][0] B=CARRYB[2][0]
+ CI=SUMB[2][1]
XS4_0 FA1S $PINS S=PRODUCT[5] CO=CARRYB[5][0] A=ab[5][0] B=CARRYB[4][0]
+ CI=SUMB[4][1]
XU2 XOR3 $PINS O=PRODUCT[7] I1=CARRYB[5][1] I2=SUMB[5][2] I3=n7
XU3 AN2 $PINS O=n2 I1=ab[0][5] I2=ab[1][4]
XU4 AN2 $PINS O=n3 I1=ab[0][4] I2=ab[1][3]
XU5 AN2 $PINS O=n4 I1=ab[0][3] I2=ab[1][2]
XU6 AN2 $PINS O=n5 I1=ab[0][2] I2=ab[1][1]
XU7 AN2 $PINS O=n6 I1=ab[0][1] I2=ab[1][0]
XU8 INV1S $PINS O=n20 I=A[1]
XU9 AN2 $PINS O=n7 I1=SUMB[5][1] I2=CARRYB[5][0]
XU10 XOR2HS $PINS O=PRODUCT[6] I1=CARRYB[5][0] I2=SUMB[5][1]
XU11 AN2 $PINS O=n8 I1=ab[0][6] I2=ab[1][5]
XU12 XOR2HS $PINS O=PRODUCT[1] I1=ab[1][0] I2=ab[0][1]
XU13 XOR2HS $PINS O=SUMB[1][2] I1=ab[1][2] I2=ab[0][3]
XU14 XOR2HS $PINS O=SUMB[1][3] I1=ab[1][3] I2=ab[0][4]
XU15 XOR2HS $PINS O=SUMB[1][4] I1=ab[1][4] I2=ab[0][5]
XU16 XOR2HS $PINS O=SUMB[1][1] I1=ab[1][1] I2=ab[0][2]
XU17 XOR2HS $PINS O=SUMB[1][5] I1=ab[1][5] I2=ab[0][6]
XU18 INV1S $PINS O=n19 I=A[2]
XU19 XOR2HS $PINS O=SUMB[1][6] I1=ab[1][6] I2=ab[0][7]
XU20 INV1S $PINS O=n18 I=A[3]
XU21 INV1S $PINS O=n17 I=A[4]
XU22 INV1S $PINS O=n9 I=B[7]
XU23 INV1S $PINS O=n14 I=B[2]
XU24 INV1S $PINS O=n15 I=B[1]
XU25 INV1S $PINS O=n13 I=B[3]
XU26 INV1S $PINS O=n12 I=B[4]
XU27 INV1S $PINS O=n11 I=B[5]
XU28 INV1S $PINS O=n16 I=B[0]
XU29 INV1S $PINS O=n10 I=B[6]
XU30 NR2 $PINS O=ab[5][2] I1=A[0] I2=n14
XU31 NR2 $PINS O=ab[5][1] I1=A[0] I2=n15
XU32 NR2 $PINS O=ab[5][0] I1=A[0] I2=n16
XU33 NR2 $PINS O=ab[4][3] I1=n13 I2=n17
XU34 NR2 $PINS O=ab[4][2] I1=n14 I2=n17
XU35 NR2 $PINS O=ab[4][1] I1=n15 I2=n17
XU36 NR2 $PINS O=ab[4][0] I1=n16 I2=n17
XU37 NR2 $PINS O=ab[3][4] I1=n12 I2=n18
XU38 NR2 $PINS O=ab[3][3] I1=n13 I2=n18
XU39 NR2 $PINS O=ab[3][2] I1=n14 I2=n18
XU40 NR2 $PINS O=ab[3][1] I1=n15 I2=n18
XU41 NR2 $PINS O=ab[3][0] I1=n16 I2=n18
XU42 NR2 $PINS O=ab[2][5] I1=n11 I2=n19
XU43 NR2 $PINS O=ab[2][4] I1=n12 I2=n19
XU44 NR2 $PINS O=ab[2][3] I1=n13 I2=n19
XU45 NR2 $PINS O=ab[2][2] I1=n14 I2=n19
XU46 NR2 $PINS O=ab[2][1] I1=n15 I2=n19
XU47 NR2 $PINS O=ab[2][0] I1=n16 I2=n19
XU48 NR2 $PINS O=ab[1][6] I1=n10 I2=n20
XU49 NR2 $PINS O=ab[1][5] I1=n11 I2=n20
XU50 NR2 $PINS O=ab[1][4] I1=n12 I2=n20
XU51 NR2 $PINS O=ab[1][3] I1=n13 I2=n20
XU52 NR2 $PINS O=ab[1][2] I1=n14 I2=n20
XU53 NR2 $PINS O=ab[1][1] I1=n15 I2=n20
XU54 NR2 $PINS O=ab[1][0] I1=n16 I2=n20
XU55 NR2 $PINS O=ab[0][7] I1=A[5] I2=n9
XU56 NR2 $PINS O=ab[0][6] I1=A[5] I2=n10
XU57 NR2 $PINS O=ab[0][5] I1=A[5] I2=n11
XU58 NR2 $PINS O=ab[0][4] I1=A[5] I2=n12
XU59 NR2 $PINS O=ab[0][3] I1=A[5] I2=n13
XU60 NR2 $PINS O=ab[0][2] I1=A[5] I2=n14
XU61 NR2 $PINS O=ab[0][1] I1=A[5] I2=n15
XU62 NR2 $PINS O=PRODUCT[0] I1=A[5] I2=n16
.ENDS

.SUBCKT CHIP_DW02_mult_0 A[7] A[6] A[5] A[4] A[3] A[2] A[1] A[0] B[4] B[3] B[2]
+ B[1] B[0] TC PRODUCT[12] PRODUCT[11] PRODUCT[10] PRODUCT[9] PRODUCT[8]
+ PRODUCT[7] PRODUCT[6] PRODUCT[5] PRODUCT[4] PRODUCT[3] PRODUCT[2] PRODUCT[1]
+ PRODUCT[0] n257
*.CONNECT PRODUCT[1] ab[0][1]
XS3_3_3 FA1S $PINS S=SUMB[3][3] CO=CARRYB[3][3] A=ab[3][3] B=CARRYB[2][3]
+ CI=ab[2][4]
XS3_4_3 XOR3 $PINS O=SUMB[4][3] I1=ab[4][3] I2=CARRYB[3][3] I3=ab[3][4]
XS2_5_2 XOR3 $PINS O=SUMB[5][2] I1=ab[5][2] I2=CARRYB[4][2] I3=SUMB[4][3]
XS2_2_2 FA1S $PINS S=SUMB[2][2] CO=CARRYB[2][2] A=ab[2][2] B=n3 CI=SUMB[1][3]
XS2_3_2 FA1S $PINS S=SUMB[3][2] CO=CARRYB[3][2] A=ab[3][2] B=CARRYB[2][2]
+ CI=SUMB[2][3]
XS2_4_2 FA1S $PINS S=SUMB[4][2] CO=CARRYB[4][2] A=ab[4][2] B=CARRYB[3][2]
+ CI=SUMB[3][3]
XS3_2_3 FA1S $PINS S=SUMB[2][3] CO=CARRYB[2][3] A=ab[2][3] B=n4 CI=ab[1][4]
XS2_6_1 XOR3 $PINS O=PRODUCT[7] I1=ab[6][1] I2=CARRYB[5][1] I3=SUMB[5][2]
XS2_5_1 FA1S $PINS S=PRODUCT[6] CO=CARRYB[5][1] A=ab[5][1] B=CARRYB[4][1]
+ CI=SUMB[4][2]
XS2_4_1 FA1S $PINS S=PRODUCT[5] CO=CARRYB[4][1] A=ab[4][1] B=CARRYB[3][1]
+ CI=SUMB[3][2]
XS2_3_1 FA1S $PINS S=PRODUCT[4] CO=CARRYB[3][1] A=ab[3][1] B=CARRYB[2][1]
+ CI=SUMB[2][2]
XS2_2_1 FA1S $PINS S=PRODUCT[3] CO=CARRYB[2][1] A=ab[2][1] B=n2 CI=SUMB[1][2]
XU2 AN2 $PINS O=n2 I1=ab[0][2] I2=ab[1][1]
XU3 AN2 $PINS O=n3 I1=ab[0][3] I2=ab[1][2]
XU4 AN2 $PINS O=n4 I1=ab[0][4] I2=ab[1][3]
XU6 XOR2HS $PINS O=PRODUCT[2] I1=ab[1][1] I2=ab[0][2]
XU7 XOR2HS $PINS O=SUMB[1][2] I1=ab[1][2] I2=ab[0][3]
XU8 XOR2HS $PINS O=SUMB[1][3] I1=ab[1][3] I2=ab[0][4]
XU12 INV1S $PINS O=n12 I=A[0]
XU13 INV1S $PINS O=n11 I=A[1]
XU14 INV1S $PINS O=n10 I=A[2]
XU15 INV1S $PINS O=n9 I=A[3]
XU16 INV1S $PINS O=n8 I=A[4]
XU17 INV1S $PINS O=n6 I=A[6]
XU18 INV1S $PINS O=n7 I=A[5]
XU19 NR2 $PINS O=ab[6][1] I1=n257 I2=n6
XU20 NR2 $PINS O=ab[5][2] I1=B[2] I2=n7
XU21 NR2 $PINS O=ab[5][1] I1=n257 I2=n7
XU22 NR2 $PINS O=ab[4][3] I1=B[3] I2=n8
XU23 NR2 $PINS O=ab[4][2] I1=B[2] I2=n8
XU24 NR2 $PINS O=ab[4][1] I1=n257 I2=n8
XU25 NR2 $PINS O=ab[3][4] I1=B[4] I2=n9
XU26 NR2 $PINS O=ab[3][3] I1=B[3] I2=n9
XU27 NR2 $PINS O=ab[3][2] I1=B[2] I2=n9
XU28 NR2 $PINS O=ab[3][1] I1=n257 I2=n9
XU29 NR2 $PINS O=ab[2][4] I1=B[4] I2=n10
XU30 NR2 $PINS O=ab[2][3] I1=B[3] I2=n10
XU31 NR2 $PINS O=ab[2][2] I1=B[2] I2=n10
XU32 NR2 $PINS O=ab[2][1] I1=n257 I2=n10
XU33 NR2 $PINS O=ab[1][4] I1=B[4] I2=n11
XU34 NR2 $PINS O=ab[1][3] I1=B[3] I2=n11
XU35 NR2 $PINS O=ab[1][2] I1=B[2] I2=n11
XU36 NR2 $PINS O=ab[1][1] I1=n257 I2=n11
XU37 NR2 $PINS O=ab[0][4] I1=B[4] I2=n12
XU38 NR2 $PINS O=ab[0][3] I1=B[3] I2=n12
XU39 NR2 $PINS O=ab[0][2] I1=B[2] I2=n12
XU40 NR2 $PINS O=ab[0][1] I1=n257 I2=n12
.ENDS

.SUBCKT CHIP_core clk rst_n i_valid i_ready o_ready o_valid i_data[10]
+ i_data[9] i_data[8] i_data[7] i_data[6] i_data[5] i_data[4] i_data[3]
+ i_data[2] i_data[1] i_data[0] o_data[10] o_data[9] o_data[8] o_data[7]
+ o_data[6] o_data[5] o_data[4] o_data[3] o_data[2] o_data[1] o_data[0]
XFE_PHC2203_current_g_1 BUF1CK $PINS O=FE_PHN2203_current_g_1 I=current_g[1]
XFE_PHC2201_pe_r0_13 BUF1CK $PINS O=FE_PHN2201_pe_r0_13 I=pe_r0[13]
XFE_PHC2200_pe_r0_16 BUF1CK $PINS O=FE_PHN2200_pe_r0_16 I=pe_r0[16]
XFE_PHC2199_pe_r0_4 BUF1CK $PINS O=FE_PHN2199_pe_r0_4 I=pe_r0[4]
XFE_PHC2198_pe_r0_14 BUF1CK $PINS O=FE_PHN2198_pe_r0_14 I=pe_r0[14]
XFE_PHC2193_pe_r0_0 BUF1CK $PINS O=FE_PHN2193_pe_r0_0 I=pe_r0[0]
XFE_PHC2191_pe_i2_16 BUF1CK $PINS O=FE_PHN2191_pe_i2_16 I=FE_PHN1605_pe_i2_16
XFE_PHC2189_pe_i3_14 BUF1CK $PINS O=FE_PHN2189_pe_i3_14 I=pe_i3[14]
XFE_PHC2188_pe_i3_11 BUF1CK $PINS O=FE_PHN2188_pe_i3_11 I=pe_i3[11]
XFE_PHC2184_pe_r0_1 BUF1CK $PINS O=FE_PHN2184_pe_r0_1 I=pe_r0[1]
XFE_PHC2183_pe_r0_3 BUF1CK $PINS O=FE_PHN2183_pe_r0_3 I=pe_r0[3]
XFE_PHC2176_pe_r2_9 BUF1CK $PINS O=FE_PHN2176_pe_r2_9 I=FE_PHN1396_pe_r2_9
XFE_PHC2175_pe_i1_8 BUF1CK $PINS O=FE_PHN2175_pe_i1_8 I=pe_i1[8]
XFE_PHC2172_pe_r1_11 BUF1CK $PINS O=FE_PHN2172_pe_r1_11 I=pe_r1[11]
XFE_PHC2170_pe_r1_16 BUF1CK $PINS O=FE_PHN2170_pe_r1_16 I=FE_PHN1460_pe_r1_16
XFE_PHC2167_pe_r1_15 BUF1CK $PINS O=FE_PHN2167_pe_r1_15 I=pe_r1[15]
XFE_PHC2166_pe_i3_13 BUF1CK $PINS O=FE_PHN2166_pe_i3_13 I=FE_PHN1699_pe_i3_13
XFE_PHC2164_pe_i1_6 BUF1CK $PINS O=FE_PHN2164_pe_i1_6 I=pe_i1[6]
XFE_PHC2153_pe_i1_1 BUF1CK $PINS O=FE_PHN2153_pe_i1_1 I=pe_i1[1]
XFE_PHC2149_current_g_0 BUF1CK $PINS O=FE_PHN2149_current_g_0 I=current_g[0]
XFE_PHC2146_pe_i3_5 BUF1CK $PINS O=FE_PHN2146_pe_i3_5 I=pe_i3[5]
XFE_PHC2139_pe_i3_16 BUF1CK $PINS O=FE_PHN2139_pe_i3_16 I=FE_PHN1582_pe_i3_16
XFE_PHC2134_pe_i3_0 BUF2CK $PINS O=FE_PHN2134_pe_i3_0 I=FE_PHN1394_pe_i3_0
XFE_PHC2132_pe_i2_8 BUF1CK $PINS O=FE_PHN2132_pe_i2_8 I=FE_PHN1401_pe_i2_8
XFE_PHC2131_pe_i3_2 BUF1CK $PINS O=FE_PHN2131_pe_i3_2 I=pe_i3[2]
XFE_PHC2130_c_in_i_0_0 BUF1S $PINS O=FE_PHN2130_c_in_i_0_0 I=c_in_i_0[0]
XFE_PHC2129_pe_r2_5 BUF1CK $PINS O=FE_PHN2129_pe_r2_5 I=pe_r2[5]
XFE_PHC2128_pe_i2_3 BUF1CK $PINS O=FE_PHN2128_pe_i2_3 I=FE_PHN1402_pe_i2_3
XFE_PHC2127_pe_i3_6 BUF2CK $PINS O=FE_PHN2127_pe_i3_6 I=pe_i3[6]
XFE_PHC2126_pe_i3_7 BUF1CK $PINS O=FE_PHN2126_pe_i3_7 I=pe_i3[7]
XFE_PHC2124_pe_i1_0 BUF1CK $PINS O=FE_PHN2124_pe_i1_0 I=pe_i1[0]
XFE_PHC2123_pe_i3_3 BUF1CK $PINS O=FE_PHN2123_pe_i3_3 I=pe_i3[3]
XFE_PHC2120_current_g_2 BUF1CK $PINS O=FE_PHN2120_current_g_2 I=current_g[2]
XFE_PHC2118_pe_i3_1 BUF1CK $PINS O=FE_PHN2118_pe_i3_1 I=pe_i3[1]
XFE_PHC2112_pe_i3_4 BUF1CK $PINS O=FE_PHN2112_pe_i3_4 I=pe_i3[4]
XFE_PHC2108_pe_i3_8 BUF1CK $PINS O=FE_PHN2108_pe_i3_8 I=pe_i3[8]
XFE_PHC2106_pe_i3_9 BUF1CK $PINS O=FE_PHN2106_pe_i3_9 I=pe_i3[9]
XFE_PHC2105_g_cnt_d1_2 BUF1CK $PINS O=FE_PHN2105_g_cnt_d1_2 I=g_cnt_d1[2]
XFE_PHC2101_g_cnt_d2_2 BUF1CK $PINS O=FE_PHN2101_g_cnt_d2_2 I=g_cnt_d2[2]
XFE_PHC2095_g_cnt_d1_1 BUF1CK $PINS O=FE_PHN2095_g_cnt_d1_1 I=g_cnt_d1[1]
XFE_PHC2094_g_cnt_d2_0 BUF1CK $PINS O=g_cnt_d2[0] I=FE_PHN2094_g_cnt_d2_0
XFE_PHC2093_g_cnt_d2_1 BUF1CK $PINS O=FE_PHN2093_g_cnt_d2_1 I=g_cnt_d2[1]
XFE_PHC2090_g_cnt_d1_0 BUF1CK $PINS O=g_cnt_d1[0] I=FE_PHN2090_g_cnt_d1_0
XFE_PHC2078_n284 DELC $PINS O=n284 I=FE_PHN2078_n284
XFE_PHC2077_n283 DELC $PINS O=FE_PHN2077_n283 I=n283
XFE_PHC2063_N63 DELB $PINS O=N63 I=FE_PHN2063_N63
XFE_PHC2044_pe_done_d2 DELC $PINS O=FE_PHN2044_pe_done_d2 I=pe_done_d2
XFE_PHC1924_n285 DELB $PINS O=FE_PHN1924_n285 I=n285
XFE_PHC1903_n287 DELC $PINS O=FE_PHN1903_n287 I=n287
XFE_PHC1886_n282 DELB $PINS O=FE_PHN1886_n282 I=n282
XFE_PHC1884_n281 DELB $PINS O=FE_PHN1884_n281 I=n281
XFE_PHC1883_n280 DELB $PINS O=FE_PHN1883_n280 I=n280
XFE_PHC1881_n286 DELB $PINS O=FE_PHN1881_n286 I=n286
XFE_PHC1850_N116 DELC $PINS O=FE_PHN1850_N116 I=N116
XFE_PHC1848_o_counter_w_5 DELC $PINS O=FE_PHN1848_o_counter_w_5
+ I=o_counter_w[5]
XFE_PHC1839_n241 DELB $PINS O=n241 I=FE_PHN1839_n241
XFE_PHC1838_N123 DELC $PINS O=N123 I=FE_PHN1838_N123
XFE_PHC1834_N124 DELC $PINS O=N124 I=FE_PHN1834_N124
XFE_PHC1833_o_counter_w_4 DELC $PINS O=FE_PHN1833_o_counter_w_4
+ I=o_counter_w[4]
XFE_PHC1831_o_counter_w_3 DELC $PINS O=FE_PHN1831_o_counter_w_3
+ I=o_counter_w[3]
XFE_PHC1826_o_counter_w_2 DELC $PINS O=FE_PHN1826_o_counter_w_2
+ I=o_counter_w[2]
XFE_PHC1804_current_g_2 DELC $PINS O=current_g[2] I=FE_PHN1804_current_g_2
XFE_PHC1803_current_g_0 DELC $PINS O=current_g[0] I=FE_PHN1803_current_g_0
XFE_PHC1802_current_g_1 DELC $PINS O=FE_PHN1802_current_g_1
+ I=FE_PHN2203_current_g_1
XFE_PHC1801_current_n_1 DELC $PINS O=current_n[1] I=FE_PHN1801_current_n_1
XFE_PHC1800_current_n_0 DELC $PINS O=FE_PHN1800_current_n_0 I=current_n[0]
XFE_PHC1799_key_r_0 DELC $PINS O=key_r[0] I=FE_PHN1799_key_r_0
XFE_PHC1797_g_cnt_d3_2 DELC $PINS O=FE_PHN1797_g_cnt_d3_2 I=g_cnt_d3[2]
XFE_PHC1796_g_cnt_d3_0 DELC $PINS O=g_cnt_d3[0] I=FE_PHN1796_g_cnt_d3_0
XFE_PHC1795_g_cnt_d3_1 DELC $PINS O=g_cnt_d3[1] I=FE_PHN1795_g_cnt_d3_1
XFE_PHC1794_pe_i1_11 DELC $PINS O=FE_PHN1794_pe_i1_11 I=pe_i1[11]
XFE_PHC1793_current_n_4 DELB $PINS O=FE_PHN1793_current_n_4 I=current_n[4]
XFE_PHC1792_current_n_3 DELB $PINS O=FE_PHN1792_current_n_3 I=current_n[3]
XFE_PHC1791_pe_i1_14 DELC $PINS O=FE_PHN1791_pe_i1_14 I=pe_i1[14]
XFE_PHC1790_current_n_2 DELB $PINS O=FE_PHN1790_current_n_2 I=current_n[2]
XFE_PHC1773_o_counter_r_1 DELC $PINS O=o_counter_r[1]
+ I=FE_PHN1773_o_counter_r_1
XFE_PHC1763_pe_r0_7 DELC $PINS O=FE_PHN1763_pe_r0_7 I=pe_r0[7]
XFE_PHC1762_pe_r0_1 DELC $PINS O=FE_PHN1762_pe_r0_1 I=FE_PHN2184_pe_r0_1
XFE_PHC1761_pe_r0_3 DELC $PINS O=FE_PHN1761_pe_r0_3 I=FE_PHN2183_pe_r0_3
XFE_PHC1760_pe_r0_9 DELC $PINS O=FE_PHN1760_pe_r0_9 I=pe_r0[9]
XFE_PHC1758_pe_r0_5 DELC $PINS O=FE_PHN1758_pe_r0_5 I=pe_r0[5]
XFE_PHC1757_pe_r0_4 DELC $PINS O=FE_PHN1757_pe_r0_4 I=FE_PHN2199_pe_r0_4
XFE_PHC1756_c_in_i_0_2 DELB $PINS O=FE_PHN1756_c_in_i_0_2 I=c_in_i_0[2]
XFE_PHC1755_pe_r0_6 DELC $PINS O=FE_PHN1755_pe_r0_6 I=pe_r0[6]
XFE_PHC1750_c_in_i_0_3 DELB $PINS O=FE_PHN1750_c_in_i_0_3 I=c_in_i_0[3]
XFE_PHC1746_c_in_i_1_15 DELB $PINS O=FE_PHN1746_c_in_i_1_15 I=c_in_i_1[15]
XFE_PHC1745_pe_r0_10 DELC $PINS O=FE_PHN1745_pe_r0_10 I=pe_r0[10]
XFE_PHC1743_n437 DELB $PINS O=n437 I=FE_PHN1743_n437
XFE_PHC1742_c_in_r_0_0 BUF1S $PINS O=FE_PHN1742_c_in_r_0_0 I=c_in_r_0[0]
XFE_PHC1741_c_in_r_0_6 DELB $PINS O=FE_PHN1741_c_in_r_0_6 I=c_in_r_0[6]
XFE_PHC1740_c_in_r_0_5 DELB $PINS O=FE_PHN1740_c_in_r_0_5 I=c_in_r_0[5]
XFE_PHC1739_c_in_r_0_4 DELB $PINS O=FE_PHN1739_c_in_r_0_4 I=c_in_r_0[4]
XFE_PHC1734_c_in_r_0_8 DELB $PINS O=FE_PHN1734_c_in_r_0_8 I=c_in_r_0[8]
XFE_PHC1733_c_in_r_0_7 DELB $PINS O=FE_PHN1733_c_in_r_0_7 I=c_in_r_0[7]
XFE_PHC1730_c_in_r_1_1 DELB $PINS O=FE_PHN1730_c_in_r_1_1 I=c_in_r_1[1]
XFE_PHC1727_c_in_r_1_11 BUF1S $PINS O=FE_PHN1727_c_in_r_1_11 I=c_in_r_1[11]
XFE_PHC1724_c_in_r_0_10 DELB $PINS O=FE_PHN1724_c_in_r_0_10 I=c_in_r_0[10]
XFE_PHC1722_c_in_r_0_12 DELB $PINS O=FE_PHN1722_c_in_r_0_12 I=c_in_r_0[12]
XFE_PHC1721_pe_i1_9 DELC $PINS O=FE_PHN1721_pe_i1_9 I=pe_i1[9]
XFE_PHC1720_counter_r_8 DELC $PINS O=FE_PHN1720_counter_r_8 I=counter_r[8]
XFE_PHC1719_c_in_r_1_12 BUF1S $PINS O=FE_PHN1719_c_in_r_1_12 I=c_in_r_1[12]
XFE_PHC1718_c_in_i_0_15 DELB $PINS O=FE_PHN1718_c_in_i_0_15 I=c_in_i_0[15]
XFE_PHC1712_pe_r2_11 DELC $PINS O=FE_PHN1712_pe_r2_11 I=pe_r2[11]
XFE_PHC1709_c_in_r_1_0 DELB $PINS O=FE_PHN1709_c_in_r_1_0 I=c_in_r_1[0]
XFE_PHC1706_pe_i2_14 DELC $PINS O=FE_PHN1706_pe_i2_14 I=pe_i2[14]
XFE_PHC1701_c_in_r_1_14 DELB $PINS O=FE_PHN1701_c_in_r_1_14 I=c_in_r_1[14]
XFE_PHC1700_c_in_r_1_13 DELB $PINS O=FE_PHN1700_c_in_r_1_13 I=c_in_r_1[13]
XFE_PHC1699_pe_i3_13 DELC $PINS O=FE_PHN1699_pe_i3_13 I=pe_i3[13]
XFE_PHC1697_pe_i3_12 DELC $PINS O=FE_PHN1697_pe_i3_12 I=pe_i3[12]
XFE_PHC1695_pe_r1_2 DELC $PINS O=FE_PHN1695_pe_r1_2 I=pe_r1[2]
XFE_PHC1691_pe_r1_6 DELC $PINS O=FE_PHN1691_pe_r1_6 I=pe_r1[6]
XFE_PHC1675_c_in_r_1_15 DELB $PINS O=FE_PHN1675_c_in_r_1_15 I=c_in_r_1[15]
XFE_PHC1672_pe_r1_4 DELC $PINS O=FE_PHN1672_pe_r1_4 I=pe_r1[4]
XFE_PHC1668_pe_i1_7 DELC $PINS O=FE_PHN1668_pe_i1_7 I=pe_i1[7]
XFE_PHC1648_pe_r1_8 DELC $PINS O=FE_PHN1648_pe_r1_8 I=pe_r1[8]
XFE_PHC1647_pe_r1_0 DELC $PINS O=FE_PHN1647_pe_r1_0 I=pe_r1[0]
XFE_PHC1644_pe_r1_5 DELC $PINS O=FE_PHN1644_pe_r1_5 I=pe_r1[5]
XFE_PHC1640_delayed_out3_1 BUF3CK $PINS O=FE_PHN1640_delayed_out3_1
+ I=delayed_out3[1]
XFE_PHC1638_pe_r1_3 DELC $PINS O=FE_PHN1638_pe_r1_3 I=pe_r1[3]
XFE_PHC1617_pe_r1_9 DELC $PINS O=FE_PHN1617_pe_r1_9 I=pe_r1[9]
XFE_PHC1609_cor_y_out_0_6 BUF1S $PINS O=FE_PHN1609_cor_y_out_0_6
+ I=cor_y_out[0][6]
XFE_PHC1608_pe_r2_15 DELC $PINS O=FE_PHN1608_pe_r2_15 I=pe_r2[15]
XFE_PHC1605_pe_i2_16 DELC $PINS O=FE_PHN1605_pe_i2_16 I=pe_i2[16]
XFE_PHC1604_cor_x_out_1_10 BUF1S $PINS O=FE_PHN1604_cor_x_out_1_10
+ I=cor_x_out[1][10]
XFE_PHC1596_cor_x_out_1_5 BUF1S $PINS O=FE_PHN1596_cor_x_out_1_5
+ I=cor_x_out[1][5]
XFE_PHC1595_n135 BUF1S $PINS O=FE_PHN1595_n135 I=n135
XFE_PHC1592_n144 BUF1S $PINS O=FE_PHN1592_n144 I=n144
XFE_PHC1591_pe_r2_13 DELC $PINS O=FE_PHN1591_pe_r2_13 I=pe_r2[13]
XFE_PHC1588_cor_y_out_0_1 BUF1S $PINS O=FE_PHN1588_cor_y_out_0_1
+ I=cor_y_out[0][1]
XFE_PHC1587_pe_r1_7 DELC $PINS O=FE_PHN1587_pe_r1_7 I=pe_r1[7]
XFE_PHC1584_cor_x_out_1_11 BUF1S $PINS O=FE_PHN1584_cor_x_out_1_11
+ I=cor_x_out[1][11]
XFE_PHC1582_pe_i3_16 DELC $PINS O=FE_PHN1582_pe_i3_16 I=pe_i3[16]
XFE_PHC1581_cor_y_out_1_6 BUF1S $PINS O=FE_PHN1581_cor_y_out_1_6
+ I=cor_y_out[1][6]
XFE_PHC1579_cor_y_out_1_2 BUF1S $PINS O=FE_PHN1579_cor_y_out_1_2
+ I=cor_y_out[1][2]
XFE_PHC1569_cor_y_out_0_11 DELA $PINS O=FE_PHN1569_cor_y_out_0_11
+ I=cor_y_out[0][11]
XFE_PHC1564_cor_y_out_0_4 DELA $PINS O=FE_PHN1564_cor_y_out_0_4
+ I=cor_y_out[0][4]
XFE_PHC1546_cor_x_out_1_2 DELA $PINS O=FE_PHN1546_cor_x_out_1_2
+ I=cor_x_out[1][2]
XFE_PHC1543_cor_x_out_1_1 DELA $PINS O=FE_PHN1543_cor_x_out_1_1
+ I=cor_x_out[1][1]
XFE_PHC1504_cor_x_out_1_13 DELA $PINS O=FE_PHN1504_cor_x_out_1_13
+ I=cor_x_out[1][13]
XFE_PHC1490_pe_r1_10 DELC $PINS O=FE_PHN1490_pe_r1_10 I=pe_r1[10]
XFE_PHC1489_key_r_3 DELC $PINS O=FE_PHN1489_key_r_3 I=key_r[3]
XFE_PHC1477_g_cnt_d2_2 DELC $PINS O=FE_PHN1477_g_cnt_d2_2
+ I=FE_PHN2101_g_cnt_d2_2
XFE_PHC1476_key_r_1 DELC $PINS O=FE_PHN1476_key_r_1 I=key_r[1]
XFE_PHC1473_g_cnt_d2_1 DELC $PINS O=FE_PHN1473_g_cnt_d2_1
+ I=FE_PHN2093_g_cnt_d2_1
XFE_PHC1471_pe_i1_16 DELC $PINS O=FE_PHN1471_pe_i1_16 I=pe_i1[16]
XFE_PHC1470_g_cnt_d1_0 DELC $PINS O=FE_PHN1470_g_cnt_d1_0 I=g_cnt_d1[0]
XFE_PHC1469_pe_r0_11 DELC $PINS O=FE_PHN1469_pe_r0_11 I=pe_r0[11]
XFE_PHC1468_pe_r0_15 DELC $PINS O=FE_PHN1468_pe_r0_15 I=pe_r0[15]
XFE_PHC1467_g_cnt_d2_0 DELC $PINS O=FE_PHN1467_g_cnt_d2_0 I=g_cnt_d2[0]
XFE_PHC1466_g_cnt_d1_1 DELC $PINS O=FE_PHN1466_g_cnt_d1_1
+ I=FE_PHN2095_g_cnt_d1_1
XFE_PHC1463_pe_r0_12 DELC $PINS O=FE_PHN1463_pe_r0_12 I=pe_r0[12]
XFE_PHC1461_pe_r1_14 DELC $PINS O=FE_PHN1461_pe_r1_14 I=pe_r1[14]
XFE_PHC1460_pe_r1_16 DELC $PINS O=FE_PHN1460_pe_r1_16 I=pe_r1[16]
XFE_PHC1459_pe_r1_15 DELC $PINS O=FE_PHN1459_pe_r1_15 I=FE_PHN2167_pe_r1_15
XFE_PHC1458_pe_r0_2 DELC $PINS O=FE_PHN1458_pe_r0_2 I=pe_r0[2]
XFE_PHC1457_g_cnt_d1_2 DELC $PINS O=FE_PHN1457_g_cnt_d1_2
+ I=FE_PHN2105_g_cnt_d1_2
XFE_PHC1456_pe_i1_12 DELC $PINS O=FE_PHN1456_pe_i1_12 I=pe_i1[12]
XFE_PHC1455_pe_r0_0 DELC $PINS O=FE_PHN1455_pe_r0_0 I=FE_PHN2193_pe_r0_0
XFE_PHC1453_pe_r0_16 DELC $PINS O=FE_PHN1453_pe_r0_16 I=FE_PHN2200_pe_r0_16
XFE_PHC1452_pe_r0_13 DELC $PINS O=FE_PHN1452_pe_r0_13 I=FE_PHN2201_pe_r0_13
XFE_PHC1451_key_r_4 DELC $PINS O=FE_PHN1451_key_r_4 I=key_r[4]
XFE_PHC1448_pe_r1_11 DELC $PINS O=FE_PHN1448_pe_r1_11 I=FE_PHN2172_pe_r1_11
XFE_PHC1447_pe_r0_14 DELC $PINS O=FE_PHN1447_pe_r0_14 I=FE_PHN2198_pe_r0_14
XFE_PHC1440_key_r_2 DELC $PINS O=FE_PHN1440_key_r_2 I=key_r[2]
XFE_PHC1420_key_r_6 DELC $PINS O=FE_PHN1420_key_r_6 I=key_r[6]
XFE_PHC1418_key_r_5 DELC $PINS O=FE_PHN1418_key_r_5 I=key_r[5]
XFE_PHC1413_c_in_r_1_16 BUF1S $PINS O=FE_PHN1413_c_in_r_1_16 I=c_in_r_1[16]
XFE_PHC1410_key_r_7 DELC $PINS O=FE_PHN1410_key_r_7 I=key_r[7]
XFE_PHC1407_pe_r2_0 DELC $PINS O=FE_PHN1407_pe_r2_0 I=pe_r2[0]
XFE_PHC1405_pe_i2_5 DELC $PINS O=FE_PHN1405_pe_i2_5 I=pe_i2[5]
XFE_PHC1404_pe_i2_9 DELC $PINS O=FE_PHN1404_pe_i2_9 I=pe_i2[9]
XFE_PHC1403_pe_i2_6 DELC $PINS O=FE_PHN1403_pe_i2_6 I=pe_i2[6]
XFE_PHC1402_pe_i2_3 DELC $PINS O=FE_PHN1402_pe_i2_3 I=pe_i2[3]
XFE_PHC1401_pe_i2_8 DELC $PINS O=FE_PHN1401_pe_i2_8 I=pe_i2[8]
XFE_PHC1400_pe_r2_1 DELC $PINS O=FE_PHN1400_pe_r2_1 I=pe_r2[1]
XFE_PHC1399_pe_i2_4 DELC $PINS O=FE_PHN1399_pe_i2_4 I=pe_i2[4]
XFE_PHC1398_pe_r2_7 DELC $PINS O=FE_PHN1398_pe_r2_7 I=pe_r2[7]
XFE_PHC1396_pe_r2_9 DELC $PINS O=FE_PHN1396_pe_r2_9 I=pe_r2[9]
XFE_PHC1394_pe_i3_0 DELC $PINS O=FE_PHN1394_pe_i3_0 I=pe_i3[0]
XFE_PHC1385_cordic_valid_out_0 DELB $PINS O=FE_PHN1385_cordic_valid_out_0
+ I=cordic_valid_out[0]
XFE_PHC1381_pe_done_d1 DELC $PINS O=pe_done_d1 I=FE_PHN1381_pe_done_d1
XFE_PHC1277_pe_i0_16 DELC $PINS O=FE_PHN1277_pe_i0_16 I=pe_i0[16]
XFE_PHC1276_pe_i0_10 DELC $PINS O=FE_PHN1276_pe_i0_10 I=pe_i0[10]
XFE_PHC1275_pe_i0_2 DELC $PINS O=FE_PHN1275_pe_i0_2 I=pe_i0[2]
XFE_PHC1274_pe_i0_7 DELC $PINS O=FE_PHN1274_pe_i0_7 I=pe_i0[7]
XFE_PHC1273_pe_i0_14 DELC $PINS O=FE_PHN1273_pe_i0_14 I=pe_i0[14]
XFE_PHC1272_pe_i0_1 DELC $PINS O=FE_PHN1272_pe_i0_1 I=pe_i0[1]
XFE_PHC1271_pe_i0_0 DELC $PINS O=FE_PHN1271_pe_i0_0 I=pe_i0[0]
XFE_PHC1270_pe_i0_4 DELC $PINS O=FE_PHN1270_pe_i0_4 I=pe_i0[4]
XFE_PHC1269_pe_i0_5 DELC $PINS O=FE_PHN1269_pe_i0_5 I=pe_i0[5]
XFE_PHC1268_pe_i0_6 DELC $PINS O=FE_PHN1268_pe_i0_6 I=pe_i0[6]
XFE_PHC1267_pe_i0_11 DELC $PINS O=FE_PHN1267_pe_i0_11 I=pe_i0[11]
XFE_PHC1266_pe_i0_9 DELC $PINS O=FE_PHN1266_pe_i0_9 I=pe_i0[9]
XFE_PHC1265_pe_i0_3 DELC $PINS O=FE_PHN1265_pe_i0_3 I=pe_i0[3]
XFE_PHC1264_pe_i0_8 DELC $PINS O=FE_PHN1264_pe_i0_8 I=pe_i0[8]
XFE_PHC1263_pe_i0_12 DELC $PINS O=FE_PHN1263_pe_i0_12 I=pe_i0[12]
XFE_PHC1262_pe_i0_15 DELC $PINS O=FE_PHN1262_pe_i0_15 I=pe_i0[15]
XFE_PHC1261_pe_i0_13 DELC $PINS O=FE_PHN1261_pe_i0_13 I=pe_i0[13]
XFE_PHC1260_pe_i1_10 DELC $PINS O=FE_PHN1260_pe_i1_10 I=pe_i1[10]
XFE_PHC1259_pe_r1_13 DELC $PINS O=FE_PHN1259_pe_r1_13 I=pe_r1[13]
XFE_PHC1258_pe_i1_15 DELC $PINS O=FE_PHN1258_pe_i1_15 I=pe_i1[15]
XFE_PHC1257_pe_i1_13 DELC $PINS O=FE_PHN1257_pe_i1_13 I=pe_i1[13]
XFE_PHC1256_pe_r1_12 DELC $PINS O=FE_PHN1256_pe_r1_12 I=pe_r1[12]
XFE_PHC1255_pe_r3_1 DELC $PINS O=FE_PHN1255_pe_r3_1 I=pe_r3[1]
XFE_PHC1245_pe_r3_8 DELC $PINS O=FE_PHN1245_pe_r3_8 I=pe_r3[8]
XFE_PHC1243_pe_i2_7 DELC $PINS O=FE_PHN1243_pe_i2_7 I=pe_i2[7]
XFE_PHC1242_pe_r2_2 DELC $PINS O=FE_PHN1242_pe_r2_2 I=pe_r2[2]
XFE_PHC1241_pe_r3_9 DELC $PINS O=FE_PHN1241_pe_r3_9 I=pe_r3[9]
XFE_PHC1240_pe_r2_8 DELC $PINS O=FE_PHN1240_pe_r2_8 I=pe_r2[8]
XFE_PHC1239_pe_r2_6 DELC $PINS O=FE_PHN1239_pe_r2_6 I=pe_r2[6]
XFE_RC_247_0 MOAI1HP $PINS O=mac_in_real[1] A1=n428 A2=n342 B1=FE_RN_2
+ B2=rf_d_rdata_1[1]
XFE_RC_126_0 AOI22S $PINS O=FE_RN_2482_0 A1=FE_OFN428_FE_DBTN12_n247
+ A2=mac_in_imag_s1[6] B1=FE_OCPN329_n247 B2=rf_d_rdata_1[23]
XFE_RC_116_0 AOI22HT $PINS O=FE_RN_1850_0 A1=FE_OFN428_FE_DBTN12_n247
+ A2=mac_in_imag_s1[5] B1=FE_OCPN329_n247 B2=rf_d_rdata_1[22]
XFE_RC_97_0 ND3HT $PINS O=FE_RN_2 I1=FE_DBTN10_state_r_0 I2=n445 I3=state_r[1]
XFE_RC_86_0 ND3HT $PINS O=FE_RN_1 I1=FE_DBTN10_state_r_0 I2=n445 I3=state_r[1]
XFE_OCPC3_state_r_2 INV1S $PINS O=FE_OCPN2_state_r_2 I=n445
XFE_OCPC2_state_r_2 INV6CK $PINS O=n445 I=state_r[2]
XFE_OCPC1_n336 BUF1 $PINS O=FE_OCPN1_n336 I=n336
XCTS_cpc_drv_INV_CLK_G0_L9_24 INV12CK $PINS O=CTS_181 I=CTS_182
XCTS_cpc_drv_INV_CLK_G0_L8_1 INV12CK $PINS O=CTS_182 I=CTS_138
XCTS_ccl_a_INV_CLK_G0_L7_8 INV12CK $PINS O=CTS_175 I=CTS_176
XCTS_ccl_a_INV_CLK_G0_L6_4 INV12CK $PINS O=CTS_176 I=CTS_177
XCTS_ccl_a_INV_CLK_G1_L10_52 INV6CK $PINS O=CTS_170 I=CTS_171
XCTS_ccl_a_INV_CLK_G1_L9_54 INV3CK $PINS O=CTS_171 I=CTS_172
XCTS_ccl_a_INV_CLK_G1_L10_51 INV6CK $PINS O=CTS_167 I=CTS_168
XCTS_ccl_a_INV_CLK_G1_L9_53 INV3CK $PINS O=CTS_168 I=CTS_169
XCTS_ccl_a_INV_CLK_G1_L10_50 INV6CK $PINS O=CTS_164 I=CTS_165
XCTS_ccl_a_INV_CLK_G1_L9_52 INV2CK $PINS O=CTS_165 I=CTS_166
XCTS_ccl_a_INV_CLK_G1_L10_49 INV8CK $PINS O=CTS_161 I=CTS_162
XCTS_ccl_a_INV_CLK_G1_L9_51 INV2CK $PINS O=CTS_162 I=CTS_163
XCTS_ccl_a_INV_CLK_G1_L10_48 INV8CK $PINS O=CTS_158 I=CTS_159
XCTS_ccl_a_INV_CLK_G1_L9_50 INV3CK $PINS O=CTS_159 I=CTS_160
XCTS_ccl_a_INV_CLK_G1_L10_47 INV6CK $PINS O=CTS_155 I=CTS_156
XCTS_ccl_a_INV_CLK_G1_L9_49 INV3CK $PINS O=CTS_156 I=CTS_157
XCTS_ccl_a_INV_CLK_G1_L10_46 INV6CK $PINS O=CTS_152 I=CTS_153
XCTS_ccl_a_INV_CLK_G1_L9_48 INV2CK $PINS O=CTS_153 I=CTS_154
XCTS_ccl_a_INV_CLK_G0_L7_7 INV6CK $PINS O=CTS_173 I=CTS_174
XCTS_ccl_a_INV_CLK_G0_L9_47 INV12CK $PINS O=CTS_149 I=CTS_150
XCTS_ccl_a_INV_CLK_G0_L11_40 INV12CK $PINS O=CTS_146 I=CTS_147
XCTS_ccl_a_INV_CLK_G0_L11_39 INV12CK $PINS O=CTS_145 I=CTS_147
XCTS_ccl_a_INV_CLK_G0_L10_45 INV8CK $PINS O=CTS_147 I=CTS_148
XCTS_ccl_a_INV_CLK_G0_L9_46 INV12CK $PINS O=CTS_148 I=CTS_150
XCTS_ccl_a_INV_CLK_G0_L11_36 INV12CK $PINS O=CTS_142 I=CTS_143
XCTS_ccl_a_INV_CLK_G0_L11_35 INV12CK $PINS O=CTS_141 I=CTS_143
XCTS_ccl_a_INV_CLK_G0_L10_43 INV8CK $PINS O=CTS_143 I=CTS_144
XCTS_ccl_a_INV_CLK_G0_L9_45 INV12CK $PINS O=CTS_144 I=CTS_150
XCTS_ccl_a_INV_CLK_G0_L8_3 INV12CK $PINS O=CTS_150 I=CTS_151
XCTS_ccl_a_INV_CLK_G0_L7_6 INV12CK $PINS O=CTS_151 I=CTS_174
XCTS_ccl_a_INV_CLK_G0_L6_3 INV12CK $PINS O=CTS_174 I=CTS_177
XCTS_ccl_a_INV_CLK_G0_L5_2 INV8CK $PINS O=CTS_177 I=CTS_178
XCTS_ccl_a_INV_CLK_G0_L7_3 INV8CK $PINS O=CTS_138 I=CTS_139
XCTS_ccl_a_INV_CLK_G0_L7_2 INV12CK $PINS O=CTS_137 I=CTS_139
XCTS_ccl_a_INV_CLK_G0_L7_1 INV8CK $PINS O=CTS_136 I=CTS_139
XCTS_ccl_a_INV_CLK_G0_L6_1 INV12CK $PINS O=CTS_139 I=CTS_140
XCTS_ccl_a_INV_CLK_G0_L5_1 INV12CK $PINS O=CTS_140 I=CTS_178
XCTS_ccl_a_INV_CLK_G0_L4_1 INV12CK $PINS O=CTS_178 I=CTS_179
XCTS_ccl_a_INV_CLK_G0_L3_1 INV12CK $PINS O=CTS_179 I=CTS_180
XCTS_ccl_INV_CLK_G0_L2_1 INV6CK $PINS O=CTS_180 I=clk
XFE_OCPC1118_FE_DBTN12_n247 BUF1S $PINS O=FE_OCPN1118_FE_DBTN12_n247
+ I=FE_DBTN12_n247
XFE_OCPC1053_state_r_0 BUF1S $PINS O=FE_OCPN1053_state_r_0 I=state_r[0]
XFE_OCPC1041_state_r_0 BUF1S $PINS O=FE_OCPN1041_state_r_0 I=state_r[0]
XFE_OCPC1011_FE_DBTN12_n247 BUF1S $PINS O=FE_OCPN1011_FE_DBTN12_n247
+ I=FE_DBTN12_n247
XFE_OCPC990_FE_DBTN10_state_r_0 BUF1S $PINS O=FE_OCPN990_FE_DBTN10_state_r_0
+ I=FE_DBTN10_state_r_0
XFE_RC_3783_0 INV2 $PINS O=mac_in_imag[6] I=FE_RN_2482_0
XFE_RC_3606_0 INV1S $PINS O=FE_RN_2356_0 I=rf_d_rdata_1[5]
XFE_RC_3605_0 MXL2H $PINS OB=mac_in_real[5] S=FE_OFN38_n247 A=n424
+ B=FE_RN_2356_0
XFE_RC_3547_0 INV1S $PINS O=FE_RN_2316_0 I=rf_d_rdata_1[7]
XFE_RC_3546_0 MXL2HS $PINS OB=mac_in_real[7] S=FE_OFN38_n247 A=n422
+ B=FE_RN_2316_0
XFE_OCPC501_n247 BUF1S $PINS O=FE_OCPN501_n247 I=FE_OFN348_n247
XFE_OCPC329_n247 BUF3 $PINS O=FE_OCPN329_n247 I=FE_OFN348_n247
XFE_OCPC251_n247 BUF1S $PINS O=FE_OCPN251_n247 I=FE_OFN348_n247
XFE_RC_3472_0 ND2 $PINS O=FE_RN_2267_0 I1=FE_OCPN1041_state_r_0 I2=n445
XFE_RC_3471_0 OR2B1T $PINS O=n336 I1=FE_RN_2267_0 B1=state_r[1]
XFE_RC_3234_0 INV2 $PINS O=FE_RN_2087_0 I=rf_d_rdata_1[3]
XFE_RC_3233_0 MXL2HF $PINS OB=mac_in_real[3] S=FE_OFN38_n247 A=n426
+ B=FE_RN_2087_0
XFE_RC_3188_0 MXL2HT $PINS OB=mac_in_real[4] S=FE_OFN428_FE_DBTN12_n247 A=n315
+ B=FE_RN_42_0
XFE_RC_2896_0 INV6 $PINS O=mac_in_imag[5] I=FE_RN_1850_0
XFE_RC_2322_0 INV1S $PINS O=FE_RN_1430_0 I=rf_d_rdata_1[8]
XFE_RC_2321_0 MXL2HS $PINS OB=mac_in_real[8] S=FE_OCPN474_FE_OFN38_n247 A=n421
+ B=FE_RN_1430_0
XFE_RC_605_0 INV1S $PINS O=FE_RN_179_0 I=rf_d_rdata_1[6]
XFE_RC_604_0 MXL2HS $PINS OB=mac_in_real[6] S=FE_OFN38_n247 A=n423
+ B=FE_RN_179_0
XFE_RC_250_0 INV2 $PINS O=FE_RN_42_0 I=mac_in_real_s1[4]
XFE_RC_181_0 ND2P $PINS O=FE_RN_33_0 I1=FE_RN_2 I2=rf_d_rdata_1[17]
XFE_RC_180_0 ND2T $PINS O=FE_RN_34_0 I1=n353 I2=mac_in_imag_s1[0]
XFE_RC_179_0 ND2F $PINS O=mac_in_imag[0] I1=FE_RN_34_0 I2=FE_RN_33_0
XFE_OCPC870_FE_OFN38_n247 BUF1 $PINS O=FE_OCPN474_FE_OFN38_n247 I=FE_OFN38_n247
XFE_RC_46_0 ND2P $PINS O=FE_RN_2_0 I1=n353 I2=mac_in_imag_s1[1]
XFE_RC_45_0 ND2T $PINS O=FE_RN_3_0 I1=FE_OFN348_n247 I2=rf_d_rdata_1[18]
XFE_RC_44_0 ND2F $PINS O=mac_in_imag[1] I1=FE_RN_3_0 I2=FE_RN_2_0
XFE_RC_33_0 INV2 $PINS O=FE_RN_1_0 I=rf_d_rdata_1[2]
XFE_RC_32_0 MXL2HF $PINS OB=mac_in_real[2] S=FE_OFN38_n247 A=n427 B=FE_RN_1_0
XFE_RC_31_0 ND3HT $PINS O=n247 I1=n445 I2=FE_DBTN10_state_r_0 I3=state_r[1]
XFE_RC_19_0 INV2 $PINS O=FE_RN_0_0 I=rf_d_rdata_1[0]
XFE_RC_18_0 MXL2HF $PINS OB=mac_in_real[0] S=FE_OFN348_n247 A=n429 B=FE_RN_0_0
XFE_OFC808_mac_in_real_s1_1 INV2 $PINS O=n428 I=mac_in_real_s1[1]
XFE_OFC762_FE_DBTN12_n247 BUF6 $PINS O=FE_OFN428_FE_DBTN12_n247
+ I=FE_DBTN12_n247
XFE_OFC745_mac_in_imag_s1_16 INV1S $PINS O=n419 I=mac_in_imag_s1_16
XFE_OFC657_n247 INV4 $PINS O=FE_DBTN12_n247 I=FE_RN_1
XFE_OFC656_n247 BUF12CK $PINS O=FE_OFN38_n247 I=n247
XFE_OFC655_n247 BUF12CK $PINS O=FE_OFN348_n247 I=FE_RN_1
XFE_OFC642_state_r_0 INV6CK $PINS O=FE_DBTN10_state_r_0 I=state_r[0]
XFE_OFC443_mac_in_real_s1_9 INV1S $PINS O=n420 I=mac_in_real_s1[9]
XFE_OFC436_mac_in_real_s1_8 INV1S $PINS O=n421 I=mac_in_real_s1[8]
XFE_OFC435_rf_d_rdata_1_4 INV1S $PINS O=n315 I=rf_d_rdata_1[4]
XFE_OFC434_mac_in_real_s1_5 INV2 $PINS O=n424 I=mac_in_real_s1[5]
XFE_OFC430_mac_in_real_s1_7 INV1S $PINS O=n422 I=mac_in_real_s1[7]
XFE_OFC371_mac_in_real_s1_6 INV2 $PINS O=n423 I=mac_in_real_s1[6]
XFE_OFC367_mac_in_real_s1_3 INV2 $PINS O=n426 I=mac_in_real_s1[3]
XFE_OFC358_mac_in_real_s1_2 INV2 $PINS O=n427 I=mac_in_real_s1[2]
XFE_OFC312_current_g_0 INV1S $PINS O=FE_DBTN5_current_g_0 I=current_g[0]
XFE_OFC311_mac_in_real_s1_0 INV2 $PINS O=n429 I=mac_in_real_s1[0]
XFE_OFC297_current_n_1 INV2 $PINS O=FE_DBTN6_current_n_1 I=current_n[1]
XFE_OFC248_FE_DBTN9_n336 BUF2 $PINS O=FE_OFN30_FE_DBTN9_n336 I=FE_DBTN9_n336
XFE_OFC171_n434 BUF1 $PINS O=FE_OFN171_n434 I=n434
XFE_OFC146_FE_DBTN11_n257 BUF1 $PINS O=FE_OFN146_FE_DBTN11_n257
+ I=FE_DBTN11_n257
XFE_OFC145_FE_DBTN11_n257 BUF1 $PINS O=FE_OFN145_FE_DBTN11_n257
+ I=FE_DBTN11_n257
XFE_OFC40_n257 BUF1 $PINS O=FE_OFN40_n257 I=n257
XFE_OFC39_n257 BUF1 $PINS O=FE_OFN39_n257 I=n257
XFE_OFC26_i_rst_n BUF1 $PINS O=FE_OFN26_i_rst_n I=FE_OFN8_i_rst_n
XFE_OFC24_i_rst_n BUF1 $PINS O=FE_OFN24_i_rst_n I=FE_OFN6_i_rst_n
XFE_OFC21_i_rst_n BUF1 $PINS O=FE_OFN21_i_rst_n I=FE_OFN6_i_rst_n
XFE_OFC20_i_rst_n BUF1 $PINS O=FE_OFN20_i_rst_n I=FE_OFN6_i_rst_n
XFE_OFC16_i_rst_n BUF2 $PINS O=FE_OFN16_i_rst_n I=FE_OFN4_i_rst_n
XFE_OFC14_i_rst_n BUF1 $PINS O=FE_OFN14_i_rst_n I=FE_OFN3_i_rst_n
XFE_OFC13_i_rst_n BUF1 $PINS O=FE_OFN13_i_rst_n I=FE_OFN2_i_rst_n
XFE_OFC12_i_rst_n BUF1 $PINS O=FE_OFN12_i_rst_n I=FE_OFN2_i_rst_n
XFE_OFC11_i_rst_n BUF2 $PINS O=FE_OFN11_i_rst_n I=FE_OFN1_i_rst_n
XFE_OFC10_i_rst_n BUF2 $PINS O=FE_OFN10_i_rst_n I=FE_OFN0_i_rst_n
XFE_OFC8_i_rst_n BUF1 $PINS O=FE_OFN8_i_rst_n I=rst_n
XFE_OFC6_i_rst_n BUF2 $PINS O=FE_OFN6_i_rst_n I=rst_n
XFE_OFC4_i_rst_n BUF1 $PINS O=FE_OFN4_i_rst_n I=rst_n
XFE_OFC3_i_rst_n BUF1 $PINS O=FE_OFN3_i_rst_n I=rst_n
XFE_OFC2_i_rst_n BUF1 $PINS O=FE_OFN2_i_rst_n I=rst_n
XFE_OFC1_i_rst_n BUF1 $PINS O=FE_OFN1_i_rst_n I=rst_n
XFE_OFC0_i_rst_n BUF1 $PINS O=FE_OFN0_i_rst_n I=rst_n
XFE_DBTC13_current_n_0 INV2 $PINS O=FE_DBTN13_current_n_0
+ I=FE_PHN1800_current_n_0
XFE_DBTC11_n257 INV2 $PINS O=FE_DBTN11_n257 I=n257
XFE_DBTC9_n336 INV2 $PINS O=FE_DBTN9_n336 I=n336
XFE_DBTC8_phase_1_8 INV1S $PINS O=FE_DBTN8_phase_1_8 I=phase_1[8]
XFE_DBTC7_phase_0_9 INV1S $PINS O=FE_DBTN7_phase_0_9 I=phase_0[9]
XFE_DBTC4_current_g_1 INV1S $PINS O=FE_DBTN4_current_g_1
+ I=FE_PHN1802_current_g_1
XFE_DBTC3_current_g_2 INV1S $PINS O=FE_DBTN3_current_g_2 I=current_g[2]
XFE_DBTC2_c_group_idx_2 INV1S $PINS O=FE_DBTN2_c_group_idx_2 I=c_group_idx[2]
XFE_DBTC1_c_group_idx_1 INV1S $PINS O=FE_DBTN1_c_group_idx_1 I=c_group_idx[1]
XFE_DBTC0_c_group_idx_0 INV1S $PINS O=FE_DBTN0_c_group_idx_0 I=c_group_idx[0]
XU290 ND2 $PINS O=n135 I1=delayed_out3[9] I2=n434
XU291 ND2 $PINS O=n133 I1=FE_PHN1617_pe_r1_9 I2=n136
XU292 ND2 $PINS O=n138 I1=delayed_out3[8] I2=n434
XU293 ND2 $PINS O=n137 I1=FE_PHN1648_pe_r1_8 I2=n136
XU294 ND2 $PINS O=n140 I1=delayed_out3[7] I2=n434
XU295 ND2 $PINS O=n139 I1=FE_PHN1587_pe_r1_7 I2=n136
XU296 ND2 $PINS O=n142 I1=delayed_out3[6] I2=n434
XU297 ND2 $PINS O=n141 I1=FE_PHN1691_pe_r1_6 I2=n136
XU298 ND2 $PINS O=n144 I1=delayed_out3[5] I2=n434
XU299 ND2 $PINS O=n143 I1=FE_PHN1644_pe_r1_5 I2=n136
XU300 ND2 $PINS O=n146 I1=delayed_out3[4] I2=n434
XU301 ND2 $PINS O=n145 I1=FE_PHN1672_pe_r1_4 I2=n136
XU302 ND2 $PINS O=n148 I1=delayed_out3[3] I2=n434
XU303 ND2 $PINS O=n147 I1=FE_PHN1638_pe_r1_3 I2=n136
XU304 ND2 $PINS O=n150 I1=delayed_out3[2] I2=n434
XU305 ND2 $PINS O=n149 I1=FE_PHN1695_pe_r1_2 I2=n136
XU306 AO222 $PINS O=rf_io_wdata_2[21] A1=pe_i1[10] A2=n151 B1=n152 B2=N307
+ C1=delayed_out3[21] C2=FE_OFN171_n434
XU307 ND2 $PINS O=n156 I1=delayed_out3[20] I2=FE_OFN171_n434
XU308 ND2 $PINS O=n154 I1=FE_PHN1721_pe_i1_9 I2=n151
XU309 ND2 $PINS O=n158 I1=FE_PHN1640_delayed_out3_1 I2=n434
XU310 ND2 $PINS O=n157 I1=pe_r1[1] I2=n136
XU311 ND2 $PINS O=n160 I1=delayed_out3[19] I2=FE_OFN171_n434
XU312 ND2 $PINS O=n159 I1=pe_i1[8] I2=n151
XU313 ND2 $PINS O=n162 I1=delayed_out3[18] I2=FE_OFN171_n434
XU314 ND2 $PINS O=n161 I1=FE_PHN1668_pe_i1_7 I2=n151
XU315 ND2 $PINS O=n164 I1=delayed_out3[17] I2=FE_OFN171_n434
XU316 ND2 $PINS O=n163 I1=pe_i1[6] I2=n151
XU317 ND2 $PINS O=n166 I1=delayed_out3[16] I2=FE_OFN171_n434
XU318 ND2 $PINS O=n165 I1=pe_i1[5] I2=n151
XU319 ND2 $PINS O=n168 I1=delayed_out3[15] I2=FE_OFN171_n434
XU320 ND2 $PINS O=n167 I1=pe_i1[4] I2=n151
XU322 ND2 $PINS O=n169 I1=pe_i1[3] I2=n151
XU323 ND2 $PINS O=n172 I1=delayed_out3[13] I2=n434
XU324 ND2 $PINS O=n171 I1=pe_i1[2] I2=n151
XU325 ND2 $PINS O=n174 I1=delayed_out3[12] I2=n434
XU326 ND2 $PINS O=n173 I1=pe_i1[1] I2=n151
XU327 ND2 $PINS O=n176 I1=delayed_out3[11] I2=n434
XU329 ND2 $PINS O=n175 I1=pe_i1[0] I2=n151
XU330 AO222 $PINS O=rf_io_wdata_2[10] A1=pe_r1[10] A2=n136 B1=n177 B2=N322
+ C1=delayed_out3[10] C2=n434
XU331 ND2 $PINS O=n179 I1=delayed_out3[0] I2=n434
XU333 ND2 $PINS O=n178 I1=FE_PHN1647_pe_r1_0 I2=n136
XU334 ND2 $PINS O=n180 I1=FE_PHN1760_pe_r0_9 I2=n183
XU335 ND2 $PINS O=n184 I1=pe_r0[8] I2=n183
XU336 ND2 $PINS O=n186 I1=FE_PHN1763_pe_r0_7 I2=n183
XU337 ND2 $PINS O=n188 I1=FE_PHN1755_pe_r0_6 I2=n183
XU338 ND2 $PINS O=n190 I1=FE_PHN1758_pe_r0_5 I2=n183
XU339 ND2 $PINS O=n192 I1=FE_PHN1757_pe_r0_4 I2=n183
XU340 ND2 $PINS O=n194 I1=FE_PHN1761_pe_r0_3 I2=n183
XU341 ND2 $PINS O=n196 I1=pe_r0[2] I2=n183
XU343 ND2 $PINS O=n198 I1=pe_i0[10] I2=n201
XU344 ND2 $PINS O=n202 I1=pe_i0[9] I2=n201
XU345 ND2 $PINS O=n205 I1=FE_PHN1762_pe_r0_1 I2=n183
XU346 ND2 $PINS O=n207 I1=pe_i0[8] I2=n201
XU347 ND2 $PINS O=n209 I1=pe_i0[7] I2=n201
XU348 ND2 $PINS O=n211 I1=pe_i0[6] I2=n201
XU349 ND2 $PINS O=n213 I1=pe_i0[5] I2=n201
XU350 ND2 $PINS O=n215 I1=pe_i0[4] I2=n201
XU351 ND2 $PINS O=n217 I1=pe_i0[3] I2=n201
XU352 ND2 $PINS O=n219 I1=pe_i0[2] I2=n201
XU353 ND2 $PINS O=n221 I1=pe_i0[1] I2=n201
XU355 ND2 $PINS O=n223 I1=pe_i0[0] I2=n201
XU356 OR3B2 $PINS O=n226 I1=N291 B1=n436 B2=N292
XU357 ND2 $PINS O=n225 I1=FE_PHN1745_pe_r0_10 I2=n183
XU359 ND2 $PINS O=n228 I1=FE_PHN2193_pe_r0_0 I2=n183
XU360 AO12 $PINS O=rf_io_waddr_1[4] A1=rf_io_waddr_2[4] B1=current_g[0] B2=n331
XU361 AO12 $PINS O=rf_io_waddr_1[3] A1=rf_io_waddr_2[3]
+ B1=FE_PHN1793_current_n_4 B2=n331
XU363 AO12 $PINS O=rf_io_waddr_1[2] A1=rf_io_waddr_2[2]
+ B1=FE_PHN1792_current_n_3 B2=n331
XU365 AO12 $PINS O=rf_io_waddr_1[1] A1=FE_OFN171_n434 B1=n331
+ B2=FE_PHN1790_current_n_2
XU367 ND2 $PINS O=n233 I1=n234 I2=n453
XU369 AO12 $PINS O=FE_PHN2078_n284 A1=n430 B1=c_state[1] B2=n239
XU371 ND2 $PINS O=n288 I1=n238 I2=n253
XU397 OA13S $PINS O=n259 A1=n254 B1=FE_OCPN1_n336 B2=n437 B3=n261
XU398 ND2 $PINS O=n263 I1=n261 I2=n262
XU399 ND2 $PINS O=n261 I1=n265 I2=FE_DBTN6_current_n_1
XU400 ND2 $PINS O=n248 I1=n265 I2=current_n[1]
XU403 AO22 $PINS O=c_in_r_1[8] A1=c_buf_r[3][8] A2=FE_OFN146_FE_DBTN11_n257
+ B1=c_buf_r[1][8] B2=FE_OFN40_n257
XU404 AO22 $PINS O=c_in_r_1[7] A1=c_buf_r[3][7] A2=FE_OFN146_FE_DBTN11_n257
+ B1=c_buf_r[1][7] B2=FE_OFN40_n257
XU405 AO22 $PINS O=c_in_r_1[6] A1=c_buf_r[3][6] A2=FE_OFN146_FE_DBTN11_n257
+ B1=c_buf_r[1][6] B2=FE_OFN40_n257
XU406 AO22 $PINS O=c_in_r_1[5] A1=c_buf_r[3][5] A2=FE_OFN146_FE_DBTN11_n257
+ B1=c_buf_r[1][5] B2=FE_OFN40_n257
XU407 AO22 $PINS O=c_in_r_1[4] A1=c_buf_r[3][4] A2=FE_OFN146_FE_DBTN11_n257
+ B1=c_buf_r[1][4] B2=FE_OFN40_n257
XU408 AO22 $PINS O=c_in_r_1[3] A1=c_buf_r[3][3] A2=FE_OFN146_FE_DBTN11_n257
+ B1=c_buf_r[1][3] B2=FE_OFN40_n257
XU409 AO22 $PINS O=c_in_r_1[2] A1=c_buf_r[3][2] A2=FE_OFN146_FE_DBTN11_n257
+ B1=c_buf_r[1][2] B2=FE_OFN40_n257
XU410 AO22 $PINS O=c_in_r_1[1] A1=c_buf_r[3][1] A2=FE_OFN146_FE_DBTN11_n257
+ B1=c_buf_r[1][1] B2=FE_OFN40_n257
XU411 AO22 $PINS O=c_in_r_1[16] A1=c_buf_r[3][16] A2=FE_OFN146_FE_DBTN11_n257
+ B1=c_buf_r[1][16] B2=FE_OFN40_n257
XU412 AO22 $PINS O=c_in_r_1[15] A1=c_buf_r[3][15] A2=FE_OFN146_FE_DBTN11_n257
+ B1=c_buf_r[1][15] B2=FE_OFN40_n257
XU413 AO22 $PINS O=c_in_r_1[14] A1=c_buf_r[3][14] A2=FE_OFN146_FE_DBTN11_n257
+ B1=c_buf_r[1][14] B2=FE_OFN40_n257
XU414 AO22 $PINS O=c_in_r_1[13] A1=c_buf_r[3][13] A2=FE_OFN146_FE_DBTN11_n257
+ B1=c_buf_r[1][13] B2=FE_OFN40_n257
XU415 AO22 $PINS O=c_in_r_1[12] A1=c_buf_r[3][12] A2=FE_OFN146_FE_DBTN11_n257
+ B1=c_buf_r[1][12] B2=FE_OFN40_n257
XU416 AO22 $PINS O=c_in_r_1[11] A1=c_buf_r[3][11] A2=FE_OFN146_FE_DBTN11_n257
+ B1=c_buf_r[1][11] B2=FE_OFN40_n257
XU417 AO22 $PINS O=c_in_r_1[10] A1=c_buf_r[3][10] A2=FE_OFN146_FE_DBTN11_n257
+ B1=c_buf_r[1][10] B2=FE_OFN40_n257
XU418 AO22 $PINS O=c_in_r_1[0] A1=c_buf_r[3][0] A2=FE_OFN146_FE_DBTN11_n257
+ B1=c_buf_r[1][0] B2=FE_OFN40_n257
XU419 AO22 $PINS O=c_in_r_0[9] A1=c_buf_r[2][9] A2=FE_OFN145_FE_DBTN11_n257
+ B1=c_buf_r[0][9] B2=FE_OFN39_n257
XU420 AO22 $PINS O=c_in_r_0[8] A1=c_buf_r[2][8] A2=FE_OFN145_FE_DBTN11_n257
+ B1=c_buf_r[0][8] B2=FE_OFN39_n257
XU421 AO22 $PINS O=c_in_r_0[7] A1=c_buf_r[2][7] A2=FE_OFN145_FE_DBTN11_n257
+ B1=c_buf_r[0][7] B2=FE_OFN39_n257
XU422 AO22 $PINS O=c_in_r_0[6] A1=c_buf_r[2][6] A2=FE_OFN145_FE_DBTN11_n257
+ B1=c_buf_r[0][6] B2=FE_OFN39_n257
XU423 AO22 $PINS O=c_in_r_0[5] A1=c_buf_r[2][5] A2=FE_OFN145_FE_DBTN11_n257
+ B1=c_buf_r[0][5] B2=FE_OFN39_n257
XU424 AO22 $PINS O=c_in_r_0[4] A1=c_buf_r[2][4] A2=FE_OFN145_FE_DBTN11_n257
+ B1=c_buf_r[0][4] B2=FE_OFN39_n257
XU425 AO22 $PINS O=c_in_r_0[3] A1=c_buf_r[2][3] A2=FE_OFN145_FE_DBTN11_n257
+ B1=c_buf_r[0][3] B2=FE_OFN39_n257
XU426 AO22 $PINS O=c_in_r_0[2] A1=c_buf_r[2][2] A2=FE_OFN145_FE_DBTN11_n257
+ B1=c_buf_r[0][2] B2=FE_OFN39_n257
XU427 AO22 $PINS O=c_in_r_0[1] A1=c_buf_r[2][1] A2=FE_OFN145_FE_DBTN11_n257
+ B1=c_buf_r[0][1] B2=FE_OFN39_n257
XU429 AO22 $PINS O=c_in_r_0[15] A1=c_buf_r[2][15] A2=FE_OFN145_FE_DBTN11_n257
+ B1=c_buf_r[0][15] B2=FE_OFN39_n257
XU430 AO22 $PINS O=c_in_r_0[14] A1=c_buf_r[2][14] A2=FE_OFN145_FE_DBTN11_n257
+ B1=c_buf_r[0][14] B2=FE_OFN39_n257
XU431 AO22 $PINS O=c_in_r_0[13] A1=c_buf_r[2][13] A2=FE_OFN145_FE_DBTN11_n257
+ B1=c_buf_r[0][13] B2=FE_OFN39_n257
XU432 AO22 $PINS O=c_in_r_0[12] A1=c_buf_r[2][12] A2=FE_OFN145_FE_DBTN11_n257
+ B1=c_buf_r[0][12] B2=FE_OFN39_n257
XU433 AO22 $PINS O=c_in_r_0[11] A1=c_buf_r[2][11] A2=FE_OFN145_FE_DBTN11_n257
+ B1=c_buf_r[0][11] B2=FE_OFN39_n257
XU434 AO22 $PINS O=c_in_r_0[10] A1=c_buf_r[2][10] A2=FE_OFN145_FE_DBTN11_n257
+ B1=c_buf_r[0][10] B2=FE_OFN39_n257
XU435 AO22 $PINS O=c_in_r_0[0] A1=c_buf_r[2][0] A2=FE_OFN145_FE_DBTN11_n257
+ B1=c_buf_r[0][0] B2=FE_OFN39_n257
XU436 AO22 $PINS O=c_in_i_1[9] A1=c_buf_i[3][9] A2=FE_OFN146_FE_DBTN11_n257
+ B1=c_buf_i[1][9] B2=FE_OFN40_n257
XU437 AO22 $PINS O=c_in_i_1[8] A1=c_buf_i[3][8] A2=FE_OFN146_FE_DBTN11_n257
+ B1=c_buf_i[1][8] B2=FE_OFN40_n257
XU438 AO22 $PINS O=c_in_i_1[7] A1=c_buf_i[3][7] A2=FE_OFN146_FE_DBTN11_n257
+ B1=c_buf_i[1][7] B2=FE_OFN40_n257
XU439 AO22 $PINS O=c_in_i_1[6] A1=c_buf_i[3][6] A2=FE_OFN146_FE_DBTN11_n257
+ B1=c_buf_i[1][6] B2=FE_OFN40_n257
XU440 AO22 $PINS O=c_in_i_1[5] A1=c_buf_i[3][5] A2=FE_OFN146_FE_DBTN11_n257
+ B1=c_buf_i[1][5] B2=FE_OFN40_n257
XU455 AO22 $PINS O=c_in_i_0[7] A1=c_buf_i[2][7] A2=FE_OFN145_FE_DBTN11_n257
+ B1=c_buf_i[0][7] B2=FE_OFN39_n257
XU470 ND2 $PINS O=FE_PHN2063_N63 I1=n240 I2=n241
XU472 AN3B2S $PINS O=N468 I1=N475 B1=n90 B2=n442
XU476 AO12 $PINS O=N154 A1=N141 B1=FE_PHN1241_pe_r3_9 B2=n276
XU477 AO12 $PINS O=N153 A1=N141 B1=FE_PHN1245_pe_r3_8 B2=n276
XU478 AO12 $PINS O=N152 A1=N141 B1=pe_r3[7] B2=n276
XU479 AO12 $PINS O=N151 A1=N141 B1=pe_r3[6] B2=n276
XU480 AO12 $PINS O=N150 A1=N141 B1=pe_r3[5] B2=n276
XU481 AO12 $PINS O=N149 A1=N141 B1=pe_r3[4] B2=n276
XU482 AO12 $PINS O=N148 A1=N141 B1=pe_r3[3] B2=n276
XU483 AO12 $PINS O=N147 A1=N141 B1=pe_r3[2] B2=n276
XU484 AO12 $PINS O=N146 A1=N141 B1=FE_PHN1255_pe_r3_1 B2=n276
XU485 AO12 $PINS O=N145 A1=N141 B1=pe_r3[0] B2=n276
XU486 AO12 $PINS O=N139 A1=N126 B1=pe_i3[9] B2=n277
XU487 AO12 $PINS O=N138 A1=N126 B1=pe_i3[8] B2=n277
XU488 AO12 $PINS O=N137 A1=N126 B1=pe_i3[7] B2=n277
XU489 AO12 $PINS O=N136 A1=N126 B1=pe_i3[6] B2=n277
XU490 AO12 $PINS O=N135 A1=N126 B1=pe_i3[5] B2=n277
XU491 AO12 $PINS O=N134 A1=N126 B1=pe_i3[4] B2=n277
XU492 AO12 $PINS O=N133 A1=N126 B1=pe_i3[3] B2=n277
XU493 AO12 $PINS O=N132 A1=N126 B1=pe_i3[2] B2=n277
XU494 AO12 $PINS O=N131 A1=N126 B1=pe_i3[1] B2=n277
XU495 AO12 $PINS O=N130 A1=N126 B1=FE_PHN1394_pe_i3_0 B2=n277
XU496 AO12 $PINS O=FE_PHN1834_N124 A1=N111 B1=FE_PHN1396_pe_r2_9 B2=n278
XU497 AO12 $PINS O=FE_PHN1838_N123 A1=N111 B1=FE_PHN1240_pe_r2_8 B2=n278
XU498 AO12 $PINS O=N122 A1=N111 B1=FE_PHN1398_pe_r2_7 B2=n278
XU499 AO12 $PINS O=N121 A1=N111 B1=FE_PHN1239_pe_r2_6 B2=n278
XU500 AO12 $PINS O=N120 A1=N111 B1=pe_r2[5] B2=n278
XU501 AO12 $PINS O=N119 A1=N111 B1=pe_r2[4] B2=n278
XU502 AO12 $PINS O=N118 A1=N111 B1=pe_r2[3] B2=n278
XU503 AO12 $PINS O=N117 A1=N111 B1=FE_PHN1242_pe_r2_2 B2=n278
XU504 AO12 $PINS O=N116 A1=N111 B1=FE_PHN1400_pe_r2_1 B2=n278
XU505 AO12 $PINS O=N115 A1=N111 B1=FE_PHN1407_pe_r2_0 B2=n278
XU506 AO12 $PINS O=N109 A1=N96 B1=FE_PHN1404_pe_i2_9 B2=n279
XU507 AO12 $PINS O=N108 A1=N96 B1=FE_PHN1401_pe_i2_8 B2=n279
XU508 AO12 $PINS O=N107 A1=N96 B1=FE_PHN1243_pe_i2_7 B2=n279
XU509 AO12 $PINS O=N106 A1=N96 B1=FE_PHN1403_pe_i2_6 B2=n279
XU510 AO12 $PINS O=N105 A1=N96 B1=FE_PHN1405_pe_i2_5 B2=n279
XU511 AO12 $PINS O=N104 A1=N96 B1=FE_PHN1399_pe_i2_4 B2=n279
XU512 AO12 $PINS O=N103 A1=N96 B1=FE_PHN1402_pe_i2_3 B2=n279
XU513 AO12 $PINS O=N102 A1=N96 B1=pe_i2[2] B2=n279
XU514 AO12 $PINS O=N101 A1=N96 B1=pe_i2[1] B2=n279
XU515 AO12 $PINS O=N100 A1=N96 B1=pe_i2[0] B2=n279
Xr174/U1_1_1 HA1 $PINS S=N421 C=r174/carry[2] A=o_counter_r[1] B=o_counter_r[0]
Xr174/U1_1_2 HA1 $PINS S=N422 C=r174/carry[3] A=o_counter_r[2] B=r174/carry[2]
Xr174/U1_1_3 HA1 $PINS S=N423 C=r174/carry[4] A=o_counter_r[3] B=r174/carry[3]
Xr174/U1_1_4 HA1 $PINS S=N424 C=r174/carry[5] A=o_counter_r[4] B=r174/carry[4]
Xstate_r_reg[0] QDFFRBP $PINS Q=state_r[0] D=FE_PHN1881_n286 CK=CTS_142
+ RB=FE_OFN8_i_rst_n
Xstate_r_reg[2] QDFFRBP $PINS Q=state_r[2] D=n288 CK=CTS_142 RB=FE_OFN6_i_rst_n
Xpe_done_d1_reg QDFFRBN $PINS Q=FE_PHN1381_pe_done_d1 D=N48 CK=CTS_142
+ RB=FE_OFN8_i_rst_n
Xdelayed_out3_reg[21] QDFFN $PINS Q=delayed_out3[21] D=N140 CK=CTS_152
Xdelayed_out3_reg[10] QDFFN $PINS Q=delayed_out3[10] D=N155 CK=CTS_152
Xdelayed_out3_reg[15] QDFFN $PINS Q=delayed_out3[15] D=N134 CK=CTS_152
Xdelayed_out3_reg[14] QDFFN $PINS Q=delayed_out3[14] D=N133 CK=CTS_152
Xdelayed_out3_reg[13] QDFFN $PINS Q=delayed_out3[13] D=N132 CK=CTS_152
Xdelayed_out3_reg[12] QDFFN $PINS Q=delayed_out3[12] D=N131 CK=CTS_152
Xdelayed_out3_reg[11] QDFFN $PINS Q=delayed_out3[11] D=N130 CK=CTS_152
Xdelayed_out3_reg[0] QDFFN $PINS Q=delayed_out3[0] D=N145 CK=CTS_152
Xdelayed_out3_reg[20] QDFFN $PINS Q=delayed_out3[20] D=N139 CK=CTS_152
Xdelayed_out3_reg[19] QDFFN $PINS Q=delayed_out3[19] D=N138 CK=CTS_152
Xdelayed_out3_reg[18] QDFFN $PINS Q=delayed_out3[18] D=N137 CK=CTS_152
Xdelayed_out3_reg[17] QDFFN $PINS Q=delayed_out3[17] D=N136 CK=CTS_152
Xdelayed_out3_reg[16] QDFFN $PINS Q=delayed_out3[16] D=N135 CK=CTS_152
Xdelayed_out3_reg[9] QDFFN $PINS Q=delayed_out3[9] D=N154 CK=CTS_152
Xdelayed_out3_reg[8] QDFFN $PINS Q=delayed_out3[8] D=N153 CK=CTS_152
Xdelayed_out3_reg[7] QDFFN $PINS Q=delayed_out3[7] D=N152 CK=CTS_152
Xdelayed_out3_reg[6] QDFFN $PINS Q=delayed_out3[6] D=N151 CK=CTS_152
Xdelayed_out3_reg[5] QDFFN $PINS Q=delayed_out3[5] D=N150 CK=CTS_152
Xdelayed_out3_reg[4] QDFFN $PINS Q=delayed_out3[4] D=N149 CK=CTS_152
Xdelayed_out3_reg[3] QDFFN $PINS Q=delayed_out3[3] D=N148 CK=CTS_152
Xdelayed_out3_reg[2] QDFFN $PINS Q=delayed_out3[2] D=N147 CK=CTS_152
Xdelayed_out3_reg[1] QDFFN $PINS Q=delayed_out3[1] D=N146 CK=CTS_152
Xdelayed_out2_reg[20] QDFFN $PINS Q=delayed_out2[20] D=N109 CK=CTS_155
Xdelayed_out2_reg[19] QDFFN $PINS Q=delayed_out2[19] D=N108 CK=CTS_155
Xdelayed_out2_reg[18] QDFFN $PINS Q=delayed_out2[18] D=N107 CK=CTS_155
Xdelayed_out2_reg[17] QDFFN $PINS Q=delayed_out2[17] D=N106 CK=CTS_155
Xdelayed_out2_reg[16] QDFFN $PINS Q=delayed_out2[16] D=N105 CK=CTS_155
Xdelayed_out2_reg[15] QDFFN $PINS Q=delayed_out2[15] D=N104 CK=CTS_155
Xdelayed_out2_reg[14] QDFFN $PINS Q=delayed_out2[14] D=N103 CK=CTS_155
Xdelayed_out2_reg[13] QDFFN $PINS Q=delayed_out2[13] D=N102 CK=CTS_155
Xdelayed_out2_reg[12] QDFFN $PINS Q=delayed_out2[12] D=N101 CK=CTS_155
Xdelayed_out2_reg[11] QDFFN $PINS Q=delayed_out2[11] D=N100 CK=CTS_155
Xdelayed_out2_reg[21] QDFFN $PINS Q=delayed_out2[21] D=N110 CK=CTS_155
Xdelayed_out2_reg[9] QDFFN $PINS Q=delayed_out2[9] D=N124 CK=CTS_155
Xdelayed_out2_reg[8] QDFFN $PINS Q=delayed_out2[8] D=N123 CK=CTS_155
Xdelayed_out2_reg[7] QDFFN $PINS Q=delayed_out2[7] D=N122 CK=CTS_155
Xdelayed_out2_reg[6] QDFFN $PINS Q=delayed_out2[6] D=N121 CK=CTS_155
Xdelayed_out2_reg[5] QDFFN $PINS Q=delayed_out2[5] D=N120 CK=CTS_155
Xdelayed_out2_reg[4] QDFFN $PINS Q=delayed_out2[4] D=N119 CK=CTS_155
Xdelayed_out2_reg[3] QDFFN $PINS Q=delayed_out2[3] D=N118 CK=CTS_155
Xdelayed_out2_reg[2] QDFFN $PINS Q=delayed_out2[2] D=N117 CK=CTS_155
Xdelayed_out2_reg[1] QDFFN $PINS Q=delayed_out2[1] D=FE_PHN1850_N116 CK=CTS_155
Xdelayed_out2_reg[0] QDFFN $PINS Q=delayed_out2[0] D=N115 CK=CTS_152
Xdelayed_out2_reg[10] QDFFN $PINS Q=delayed_out2[10] D=N125 CK=CTS_155
Xreal_hold_reg_reg[10] QDFFRBN $PINS Q=real_hold_reg[10] D=i_data[10]
+ CK=net1705 RB=FE_OFN16_i_rst_n
Xreal_hold_reg_reg[9] QDFFRBN $PINS Q=real_hold_reg[9] D=i_data[9] CK=net1705
+ RB=FE_OFN16_i_rst_n
Xreal_hold_reg_reg[8] QDFFRBN $PINS Q=real_hold_reg[8] D=i_data[8] CK=net1705
+ RB=FE_OFN16_i_rst_n
Xreal_hold_reg_reg[7] QDFFRBN $PINS Q=real_hold_reg[7] D=i_data[7] CK=net1705
+ RB=FE_OFN16_i_rst_n
Xreal_hold_reg_reg[6] QDFFRBN $PINS Q=real_hold_reg[6] D=i_data[6] CK=net1705
+ RB=FE_OFN16_i_rst_n
Xreal_hold_reg_reg[5] QDFFRBN $PINS Q=real_hold_reg[5] D=i_data[5] CK=net1705
+ RB=FE_OFN20_i_rst_n
Xreal_hold_reg_reg[4] QDFFRBN $PINS Q=real_hold_reg[4] D=i_data[4] CK=net1705
+ RB=FE_OFN20_i_rst_n
Xreal_hold_reg_reg[3] QDFFRBN $PINS Q=real_hold_reg[3] D=i_data[3] CK=net1705
+ RB=FE_OFN20_i_rst_n
Xreal_hold_reg_reg[2] QDFFRBN $PINS Q=real_hold_reg[2] D=i_data[2] CK=net1705
+ RB=FE_OFN20_i_rst_n
Xreal_hold_reg_reg[1] QDFFRBN $PINS Q=real_hold_reg[1] D=i_data[1] CK=net1705
+ RB=FE_OFN20_i_rst_n
Xreal_hold_reg_reg[0] QDFFRBN $PINS Q=real_hold_reg[0] D=i_data[0] CK=net1705
+ RB=FE_OFN20_i_rst_n
Xc_buf_i_reg[1][16] QDFFN $PINS Q=c_buf_i[1][16] D=FE_PHN1471_pe_i1_16
+ CK=CTS_170
Xc_buf_r_reg[1][16] QDFFN $PINS Q=c_buf_r[1][16] D=FE_PHN2170_pe_r1_16
+ CK=CTS_161
Xc_buf_i_reg[0][16] QDFFN $PINS Q=c_buf_i[0][16] D=FE_PHN1277_pe_i0_16
+ CK=CTS_170
Xc_buf_r_reg[0][16] QDFFN $PINS Q=c_buf_r[0][16] D=FE_PHN1453_pe_r0_16
+ CK=CTS_164
Xc_buf_i_reg[3][16] QDFFN $PINS Q=c_buf_i[3][16] D=FE_PHN2139_pe_i3_16
+ CK=CTS_167
Xc_buf_r_reg[3][16] QDFFN $PINS Q=c_buf_r[3][16] D=pe_r3[16] CK=CTS_158
Xc_buf_i_reg[2][16] QDFFN $PINS Q=c_buf_i[2][16] D=FE_PHN2191_pe_i2_16
+ CK=CTS_167
Xc_buf_r_reg[2][16] QDFFN $PINS Q=c_buf_r[2][16] D=pe_r2[16] CK=CTS_161
Xc_buf_i_reg[1][15] QDFFN $PINS Q=c_buf_i[1][15] D=FE_PHN1258_pe_i1_15
+ CK=CTS_170
Xc_buf_r_reg[1][15] QDFFN $PINS Q=c_buf_r[1][15] D=FE_PHN1459_pe_r1_15
+ CK=CTS_161
Xc_buf_i_reg[0][15] QDFFN $PINS Q=c_buf_i[0][15] D=FE_PHN1262_pe_i0_15
+ CK=CTS_170
Xc_buf_r_reg[0][15] QDFFN $PINS Q=c_buf_r[0][15] D=FE_PHN1468_pe_r0_15
+ CK=CTS_164
Xc_buf_i_reg[3][15] QDFFN $PINS Q=c_buf_i[3][15] D=pe_i3[15] CK=CTS_167
Xc_buf_r_reg[3][15] QDFFN $PINS Q=c_buf_r[3][15] D=pe_r3[15] CK=CTS_158
Xc_buf_i_reg[2][15] QDFFN $PINS Q=c_buf_i[2][15] D=pe_i2[15] CK=CTS_167
Xc_buf_r_reg[2][15] QDFFN $PINS Q=c_buf_r[2][15] D=FE_PHN1608_pe_r2_15
+ CK=CTS_161
Xc_buf_i_reg[1][14] QDFFN $PINS Q=c_buf_i[1][14] D=FE_PHN1791_pe_i1_14
+ CK=CTS_170
Xc_buf_r_reg[1][14] QDFFN $PINS Q=c_buf_r[1][14] D=FE_PHN1461_pe_r1_14
+ CK=CTS_161
Xc_buf_i_reg[0][14] QDFFN $PINS Q=c_buf_i[0][14] D=FE_PHN1273_pe_i0_14
+ CK=CTS_170
Xc_buf_r_reg[0][14] QDFFN $PINS Q=c_buf_r[0][14] D=FE_PHN1447_pe_r0_14
+ CK=CTS_164
Xc_buf_i_reg[3][14] QDFFN $PINS Q=c_buf_i[3][14] D=FE_PHN2189_pe_i3_14
+ CK=CTS_167
Xc_buf_r_reg[3][14] QDFFN $PINS Q=c_buf_r[3][14] D=pe_r3[14] CK=CTS_158
Xc_buf_i_reg[2][14] QDFFN $PINS Q=c_buf_i[2][14] D=FE_PHN1706_pe_i2_14
+ CK=CTS_167
Xc_buf_r_reg[2][14] QDFFN $PINS Q=c_buf_r[2][14] D=pe_r2[14] CK=CTS_161
Xcounter_r_reg[8] QDFFRBN $PINS Q=counter_r[8] D=counter_w[8] CK=net1700
+ RB=FE_OFN8_i_rst_n
Xc_buf_i_reg[1][13] QDFFN $PINS Q=c_buf_i[1][13] D=FE_PHN1257_pe_i1_13
+ CK=CTS_170
Xc_buf_r_reg[1][13] QDFFN $PINS Q=c_buf_r[1][13] D=FE_PHN1259_pe_r1_13
+ CK=CTS_161
Xc_buf_i_reg[0][13] QDFFN $PINS Q=c_buf_i[0][13] D=FE_PHN1261_pe_i0_13
+ CK=CTS_170
Xc_buf_r_reg[0][13] QDFFN $PINS Q=c_buf_r[0][13] D=FE_PHN1452_pe_r0_13
+ CK=CTS_164
Xc_buf_i_reg[3][13] QDFFN $PINS Q=c_buf_i[3][13] D=FE_PHN2166_pe_i3_13
+ CK=CTS_167
Xc_buf_r_reg[3][13] QDFFN $PINS Q=c_buf_r[3][13] D=pe_r3[13] CK=CTS_158
Xc_buf_i_reg[2][13] QDFFN $PINS Q=c_buf_i[2][13] D=pe_i2[13] CK=CTS_167
Xc_buf_r_reg[2][13] QDFFN $PINS Q=c_buf_r[2][13] D=FE_PHN1591_pe_r2_13
+ CK=CTS_161
Xc_buf_i_reg[1][12] QDFFN $PINS Q=c_buf_i[1][12] D=FE_PHN1456_pe_i1_12
+ CK=CTS_170
Xc_buf_r_reg[1][12] QDFFN $PINS Q=c_buf_r[1][12] D=FE_PHN1256_pe_r1_12
+ CK=CTS_161
Xc_buf_i_reg[0][12] QDFFN $PINS Q=c_buf_i[0][12] D=FE_PHN1263_pe_i0_12
+ CK=CTS_170
Xc_buf_r_reg[0][12] QDFFN $PINS Q=c_buf_r[0][12] D=FE_PHN1463_pe_r0_12
+ CK=CTS_164
Xc_buf_i_reg[3][12] QDFFN $PINS Q=c_buf_i[3][12] D=FE_PHN1697_pe_i3_12
+ CK=CTS_164
Xc_buf_r_reg[3][12] QDFFN $PINS Q=c_buf_r[3][12] D=pe_r3[12] CK=CTS_158
Xc_buf_i_reg[2][12] QDFFN $PINS Q=c_buf_i[2][12] D=pe_i2[12] CK=CTS_167
Xc_buf_r_reg[2][12] QDFFN $PINS Q=c_buf_r[2][12] D=pe_r2[12] CK=CTS_161
Xo_counter_r_reg[5] QDFFRBN $PINS Q=o_counter_r[5] D=FE_PHN1848_o_counter_w_5
+ CK=net1690 RB=FE_OFN6_i_rst_n
Xc_buf_i_reg[1][11] QDFFN $PINS Q=c_buf_i[1][11] D=FE_PHN1794_pe_i1_11
+ CK=CTS_170
Xc_buf_r_reg[1][11] QDFFN $PINS Q=c_buf_r[1][11] D=FE_PHN1448_pe_r1_11
+ CK=CTS_161
Xc_buf_i_reg[0][11] QDFFN $PINS Q=c_buf_i[0][11] D=FE_PHN1267_pe_i0_11
+ CK=CTS_170
Xc_buf_r_reg[0][11] QDFFN $PINS Q=c_buf_r[0][11] D=FE_PHN1469_pe_r0_11
+ CK=CTS_164
Xc_buf_i_reg[3][11] QDFFN $PINS Q=c_buf_i[3][11] D=FE_PHN2188_pe_i3_11
+ CK=CTS_164
Xc_buf_r_reg[3][11] QDFFN $PINS Q=c_buf_r[3][11] D=pe_r3[11] CK=CTS_158
Xc_buf_i_reg[2][11] QDFFN $PINS Q=c_buf_i[2][11] D=pe_i2[11] CK=CTS_167
Xc_buf_r_reg[2][11] QDFFN $PINS Q=c_buf_r[2][11] D=FE_PHN1712_pe_r2_11
+ CK=CTS_161
Xc_buf_i_reg[1][10] QDFFN $PINS Q=c_buf_i[1][10] D=FE_PHN1260_pe_i1_10
+ CK=CTS_170
Xc_buf_r_reg[1][10] QDFFN $PINS Q=c_buf_r[1][10] D=FE_PHN1490_pe_r1_10
+ CK=CTS_161
Xc_buf_i_reg[0][10] QDFFN $PINS Q=c_buf_i[0][10] D=FE_PHN1276_pe_i0_10
+ CK=CTS_170
Xc_buf_r_reg[0][10] QDFFN $PINS Q=c_buf_r[0][10] D=FE_PHN1745_pe_r0_10
+ CK=CTS_164
Xo_counter_r_reg[4] QDFFRBN $PINS Q=o_counter_r[4] D=FE_PHN1833_o_counter_w_4
+ CK=net1690 RB=FE_OFN6_i_rst_n
Xc_buf_i_reg[3][10] QDFFN $PINS Q=c_buf_i[3][10] D=pe_i3[10] CK=CTS_164
Xc_buf_r_reg[3][10] QDFFN $PINS Q=c_buf_r[3][10] D=pe_r3[10] CK=CTS_158
Xc_buf_i_reg[2][10] QDFFN $PINS Q=c_buf_i[2][10] D=pe_i2[10] CK=CTS_167
Xc_buf_r_reg[2][10] QDFFN $PINS Q=c_buf_r[2][10] D=pe_r2[10] CK=CTS_161
Xc_buf_i_reg[1][9] QDFFN $PINS Q=c_buf_i[1][9] D=FE_PHN1721_pe_i1_9 CK=CTS_170
Xc_buf_r_reg[1][9] QDFFN $PINS Q=c_buf_r[1][9] D=FE_PHN1617_pe_r1_9 CK=CTS_161
Xc_buf_i_reg[0][9] QDFFN $PINS Q=c_buf_i[0][9] D=FE_PHN1266_pe_i0_9 CK=CTS_170
Xc_buf_r_reg[0][9] QDFFN $PINS Q=c_buf_r[0][9] D=FE_PHN1760_pe_r0_9 CK=CTS_164
Xo_counter_r_reg[3] QDFFRBN $PINS Q=o_counter_r[3] D=FE_PHN1831_o_counter_w_3
+ CK=net1690 RB=FE_OFN6_i_rst_n
Xc_buf_i_reg[3][9] QDFFN $PINS Q=c_buf_i[3][9] D=FE_PHN2106_pe_i3_9 CK=CTS_164
Xc_buf_r_reg[3][9] QDFFN $PINS Q=c_buf_r[3][9] D=FE_PHN1241_pe_r3_9 CK=CTS_158
Xc_buf_i_reg[2][9] QDFFN $PINS Q=c_buf_i[2][9] D=FE_PHN1404_pe_i2_9 CK=CTS_167
Xc_buf_r_reg[2][9] QDFFN $PINS Q=c_buf_r[2][9] D=FE_PHN2176_pe_r2_9 CK=CTS_158
Xo_counter_r_reg[2] QDFFRBN $PINS Q=o_counter_r[2] D=FE_PHN1826_o_counter_w_2
+ CK=net1690 RB=FE_OFN6_i_rst_n
Xc_buf_i_reg[1][8] QDFFN $PINS Q=c_buf_i[1][8] D=FE_PHN2175_pe_i1_8 CK=CTS_170
Xc_buf_r_reg[1][8] QDFFN $PINS Q=c_buf_r[1][8] D=FE_PHN1648_pe_r1_8 CK=CTS_161
Xc_buf_i_reg[0][8] QDFFN $PINS Q=c_buf_i[0][8] D=FE_PHN1264_pe_i0_8 CK=CTS_170
Xc_buf_r_reg[0][8] QDFFN $PINS Q=c_buf_r[0][8] D=pe_r0[8] CK=CTS_164
Xc_buf_i_reg[3][8] QDFFN $PINS Q=c_buf_i[3][8] D=FE_PHN2108_pe_i3_8 CK=CTS_164
Xc_buf_r_reg[3][8] QDFFN $PINS Q=c_buf_r[3][8] D=FE_PHN1245_pe_r3_8 CK=CTS_158
Xc_buf_i_reg[2][8] QDFFN $PINS Q=c_buf_i[2][8] D=FE_PHN2132_pe_i2_8 CK=CTS_167
Xc_buf_r_reg[2][8] QDFFN $PINS Q=c_buf_r[2][8] D=FE_PHN1240_pe_r2_8 CK=CTS_158
Xo_counter_r_reg[1] QDFFRBN $PINS Q=FE_PHN1773_o_counter_r_1 D=o_counter_w[1]
+ CK=net1690 RB=FE_OFN6_i_rst_n
Xc_buf_i_reg[1][7] QDFFN $PINS Q=c_buf_i[1][7] D=FE_PHN1668_pe_i1_7 CK=CTS_170
Xc_buf_r_reg[1][7] QDFFN $PINS Q=c_buf_r[1][7] D=FE_PHN1587_pe_r1_7 CK=CTS_161
Xc_buf_i_reg[0][7] QDFFN $PINS Q=c_buf_i[0][7] D=FE_PHN1274_pe_i0_7 CK=CTS_170
Xc_buf_r_reg[0][7] QDFFN $PINS Q=c_buf_r[0][7] D=FE_PHN1763_pe_r0_7 CK=CTS_164
Xc_buf_i_reg[3][7] QDFFN $PINS Q=c_buf_i[3][7] D=FE_PHN2126_pe_i3_7 CK=CTS_164
Xc_buf_r_reg[3][7] QDFFN $PINS Q=c_buf_r[3][7] D=pe_r3[7] CK=CTS_158
Xc_buf_i_reg[2][7] QDFFN $PINS Q=c_buf_i[2][7] D=FE_PHN1243_pe_i2_7 CK=CTS_167
Xc_buf_r_reg[2][7] QDFFN $PINS Q=c_buf_r[2][7] D=FE_PHN1398_pe_r2_7 CK=CTS_158
Xo_counter_r_reg[0] QDFFRBN $PINS Q=o_counter_r[0] D=o_counter_w[0] CK=net1690
+ RB=FE_OFN6_i_rst_n
Xc_buf_i_reg[1][6] QDFFN $PINS Q=c_buf_i[1][6] D=FE_PHN2164_pe_i1_6 CK=CTS_170
Xc_buf_r_reg[1][6] QDFFN $PINS Q=c_buf_r[1][6] D=FE_PHN1691_pe_r1_6 CK=CTS_161
Xc_buf_i_reg[0][6] QDFFN $PINS Q=c_buf_i[0][6] D=FE_PHN1268_pe_i0_6 CK=CTS_170
Xc_buf_r_reg[0][6] QDFFN $PINS Q=c_buf_r[0][6] D=FE_PHN1755_pe_r0_6 CK=CTS_164
Xc_buf_i_reg[3][6] QDFFN $PINS Q=c_buf_i[3][6] D=FE_PHN2127_pe_i3_6 CK=CTS_164
Xc_buf_r_reg[3][6] QDFFN $PINS Q=c_buf_r[3][6] D=pe_r3[6] CK=CTS_158
Xc_buf_i_reg[2][6] QDFFN $PINS Q=c_buf_i[2][6] D=FE_PHN1403_pe_i2_6 CK=CTS_167
Xc_buf_r_reg[2][6] QDFFN $PINS Q=c_buf_r[2][6] D=FE_PHN1239_pe_r2_6 CK=CTS_158
Xc_buf_i_reg[1][5] QDFFN $PINS Q=c_buf_i[1][5] D=pe_i1[5] CK=CTS_167
Xc_buf_r_reg[1][5] QDFFN $PINS Q=c_buf_r[1][5] D=FE_PHN1644_pe_r1_5 CK=CTS_161
Xc_buf_i_reg[0][5] QDFFN $PINS Q=c_buf_i[0][5] D=FE_PHN1269_pe_i0_5 CK=CTS_170
Xc_buf_r_reg[0][5] QDFFN $PINS Q=c_buf_r[0][5] D=FE_PHN1758_pe_r0_5 CK=CTS_164
Xc_buf_i_reg[3][5] QDFFN $PINS Q=c_buf_i[3][5] D=FE_PHN2146_pe_i3_5 CK=CTS_164
Xc_buf_r_reg[3][5] QDFFN $PINS Q=c_buf_r[3][5] D=pe_r3[5] CK=CTS_158
Xc_buf_i_reg[2][5] QDFFN $PINS Q=c_buf_i[2][5] D=FE_PHN1405_pe_i2_5 CK=CTS_167
Xc_buf_r_reg[2][5] QDFFN $PINS Q=c_buf_r[2][5] D=FE_PHN2129_pe_r2_5 CK=CTS_158
Xc_buf_r_reg[1][4] QDFFN $PINS Q=c_buf_r[1][4] D=FE_PHN1672_pe_r1_4 CK=CTS_161
Xc_buf_i_reg[1][4] QDFFN $PINS Q=c_buf_i[1][4] D=pe_i1[4] CK=CTS_167
Xc_buf_i_reg[0][4] QDFFN $PINS Q=c_buf_i[0][4] D=FE_PHN1270_pe_i0_4 CK=CTS_170
Xc_buf_r_reg[0][4] QDFFN $PINS Q=c_buf_r[0][4] D=FE_PHN1757_pe_r0_4 CK=CTS_164
Xc_buf_r_reg[3][4] QDFFN $PINS Q=c_buf_r[3][4] D=pe_r3[4] CK=CTS_158
Xc_buf_i_reg[3][4] QDFFN $PINS Q=c_buf_i[3][4] D=FE_PHN2112_pe_i3_4 CK=CTS_164
Xc_buf_i_reg[2][4] QDFFN $PINS Q=c_buf_i[2][4] D=FE_PHN1399_pe_i2_4 CK=CTS_167
Xc_buf_r_reg[2][4] QDFFN $PINS Q=c_buf_r[2][4] D=pe_r2[4] CK=CTS_158
Xc_buf_r_reg[1][3] QDFFN $PINS Q=c_buf_r[1][3] D=FE_PHN1638_pe_r1_3 CK=CTS_161
Xc_buf_i_reg[1][3] QDFFN $PINS Q=c_buf_i[1][3] D=pe_i1[3] CK=CTS_167
Xc_buf_i_reg[0][3] QDFFN $PINS Q=c_buf_i[0][3] D=FE_PHN1265_pe_i0_3 CK=CTS_170
Xc_buf_r_reg[0][3] QDFFN $PINS Q=c_buf_r[0][3] D=FE_PHN1761_pe_r0_3 CK=CTS_164
Xc_buf_r_reg[3][3] QDFFN $PINS Q=c_buf_r[3][3] D=pe_r3[3] CK=CTS_158
Xc_buf_i_reg[3][3] QDFFN $PINS Q=c_buf_i[3][3] D=FE_PHN2123_pe_i3_3 CK=CTS_164
Xc_buf_i_reg[2][3] QDFFN $PINS Q=c_buf_i[2][3] D=FE_PHN2128_pe_i2_3 CK=CTS_167
Xc_buf_r_reg[2][3] QDFFN $PINS Q=c_buf_r[2][3] D=pe_r2[3] CK=CTS_158
Xc_buf_r_reg[1][2] QDFFN $PINS Q=c_buf_r[1][2] D=FE_PHN1695_pe_r1_2 CK=CTS_161
Xc_buf_i_reg[1][2] QDFFN $PINS Q=c_buf_i[1][2] D=pe_i1[2] CK=CTS_167
Xc_buf_i_reg[0][2] QDFFN $PINS Q=c_buf_i[0][2] D=FE_PHN1275_pe_i0_2 CK=CTS_170
Xc_buf_r_reg[0][2] QDFFN $PINS Q=c_buf_r[0][2] D=FE_PHN1458_pe_r0_2 CK=CTS_161
Xc_buf_r_reg[3][2] QDFFN $PINS Q=c_buf_r[3][2] D=pe_r3[2] CK=CTS_158
Xc_buf_i_reg[3][2] QDFFN $PINS Q=c_buf_i[3][2] D=FE_PHN2131_pe_i3_2 CK=CTS_164
Xc_buf_i_reg[2][2] QDFFN $PINS Q=c_buf_i[2][2] D=pe_i2[2] CK=CTS_167
Xc_buf_r_reg[2][2] QDFFN $PINS Q=c_buf_r[2][2] D=FE_PHN1242_pe_r2_2 CK=CTS_158
Xkey_r_reg[7] QDFFRBN $PINS Q=key_r[7] D=key_w[7] CK=net1695 RB=FE_OFN8_i_rst_n
Xc_buf_i_reg[1][1] QDFFN $PINS Q=c_buf_i[1][1] D=FE_PHN2153_pe_i1_1 CK=CTS_167
Xc_buf_r_reg[1][1] QDFFN $PINS Q=c_buf_r[1][1] D=pe_r1[1] CK=CTS_161
Xc_buf_i_reg[0][1] QDFFN $PINS Q=c_buf_i[0][1] D=FE_PHN1272_pe_i0_1 CK=CTS_170
Xc_buf_r_reg[0][1] QDFFN $PINS Q=c_buf_r[0][1] D=FE_PHN1762_pe_r0_1 CK=CTS_161
Xc_buf_i_reg[3][1] QDFFN $PINS Q=c_buf_i[3][1] D=FE_PHN2118_pe_i3_1 CK=CTS_164
Xc_buf_r_reg[3][1] QDFFN $PINS Q=c_buf_r[3][1] D=FE_PHN1255_pe_r3_1 CK=CTS_158
Xc_buf_i_reg[2][1] QDFFN $PINS Q=c_buf_i[2][1] D=pe_i2[1] CK=CTS_167
Xc_buf_r_reg[2][1] QDFFN $PINS Q=c_buf_r[2][1] D=FE_PHN1400_pe_r2_1 CK=CTS_158
Xc_buf_i_reg[1][0] QDFFN $PINS Q=c_buf_i[1][0] D=FE_PHN2124_pe_i1_0 CK=CTS_167
Xc_buf_r_reg[1][0] QDFFN $PINS Q=c_buf_r[1][0] D=FE_PHN1647_pe_r1_0 CK=CTS_161
Xc_buf_i_reg[0][0] QDFFN $PINS Q=c_buf_i[0][0] D=FE_PHN1271_pe_i0_0 CK=CTS_170
Xc_buf_r_reg[0][0] QDFFN $PINS Q=c_buf_r[0][0] D=FE_PHN1455_pe_r0_0 CK=CTS_161
Xc_buf_i_reg[3][0] QDFFN $PINS Q=c_buf_i[3][0] D=FE_PHN2134_pe_i3_0 CK=CTS_164
Xc_buf_r_reg[3][0] QDFFN $PINS Q=c_buf_r[3][0] D=pe_r3[0] CK=CTS_158
Xc_buf_i_reg[2][0] QDFFN $PINS Q=c_buf_i[2][0] D=pe_i2[0] CK=CTS_167
Xc_buf_r_reg[2][0] QDFFN $PINS Q=c_buf_r[2][0] D=FE_PHN1407_pe_r2_0 CK=CTS_158
Xkey_r_reg[6] QDFFRBN $PINS Q=key_r[6] D=key_w[6] CK=net1695
+ RB=FE_OFN26_i_rst_n
Xkey_r_reg[5] QDFFRBN $PINS Q=key_r[5] D=key_w[5] CK=net1695
+ RB=FE_OFN26_i_rst_n
Xkey_r_reg[4] QDFFRBN $PINS Q=key_r[4] D=key_w[4] CK=net1695
+ RB=FE_OFN26_i_rst_n
Xkey_r_reg[0] QDFFRBN $PINS Q=FE_PHN1799_key_r_0 D=key_w[0] CK=net1695
+ RB=FE_OFN26_i_rst_n
Xkey_r_reg[3] QDFFRBN $PINS Q=key_r[3] D=key_w[3] CK=net1695
+ RB=FE_OFN26_i_rst_n
Xkey_r_reg[1] QDFFRBN $PINS Q=key_r[1] D=key_w[1] CK=net1695
+ RB=FE_OFN26_i_rst_n
Xkey_r_reg[2] QDFFRBN $PINS Q=key_r[2] D=key_w[2] CK=net1695
+ RB=FE_OFN26_i_rst_n
Xpe_done_d2_reg QDFFRBN $PINS Q=pe_done_d2 D=N50 CK=CTS_142 RB=FE_OFN8_i_rst_n
Xc_start_reg QDFFRBN $PINS Q=c_start D=N63 CK=CTS_146 RB=FE_OFN3_i_rst_n
Xo_state_r_reg QDFFRBN $PINS Q=o_valid D=FE_PHN1924_n285 CK=CTS_142
+ RB=FE_OFN8_i_rst_n
Xcounter_r_reg[4] QDFFRBN $PINS Q=current_n[4] D=counter_w[4] CK=net1700
+ RB=FE_OFN8_i_rst_n
Xcounter_r_reg[3] QDFFRBN $PINS Q=current_n[3] D=counter_w[3] CK=net1700
+ RB=FE_OFN8_i_rst_n
Xcounter_r_reg[2] QDFFRBN $PINS Q=current_n[2] D=counter_w[2] CK=net1700
+ RB=FE_OFN8_i_rst_n
Xcounter_r_reg[7] QDFFRBN $PINS Q=FE_PHN1804_current_g_2 D=counter_w[7]
+ CK=net1700 RB=FE_OFN8_i_rst_n
Xcounter_r_reg[5] QDFFRBN $PINS Q=FE_PHN1803_current_g_0 D=counter_w[5]
+ CK=net1700 RB=FE_OFN8_i_rst_n
Xcounter_r_reg[6] QDFFRBN $PINS Q=current_g[1] D=counter_w[6] CK=net1700
+ RB=FE_OFN8_i_rst_n
Xcounter_r_reg[1] QDFFRBN $PINS Q=FE_PHN1801_current_n_1 D=counter_w[1]
+ CK=net1700 RB=FE_OFN8_i_rst_n
Xdelayed_mac_group_reg[0] QDFFN $PINS Q=delayed_mac_group[0] D=g_cnt_d3[0]
+ CK=CTS_155
Xg_cnt_d3_reg[2] QDFFRBN $PINS Q=g_cnt_d3[2] D=FE_PHN1477_g_cnt_d2_2 CK=net1650
+ RB=FE_OFN8_i_rst_n
Xg_cnt_d3_reg[0] QDFFRBN $PINS Q=FE_PHN1796_g_cnt_d3_0 D=FE_PHN1467_g_cnt_d2_0
+ CK=net1650 RB=FE_OFN8_i_rst_n
Xdelayed_mac_group_reg[1] QDFFN $PINS Q=delayed_mac_group[1] D=g_cnt_d3[1]
+ CK=CTS_155
Xdelayed_mac_group_reg[2] DFFN $PINS QB=n80 D=FE_PHN1797_g_cnt_d3_2 CK=CTS_155
Xg_cnt_d3_reg[1] QDFFRBN $PINS Q=FE_PHN1795_g_cnt_d3_1 D=FE_PHN1473_g_cnt_d2_1
+ CK=net1650 RB=FE_OFN8_i_rst_n
Xcounter_r_reg[0] QDFFRBN $PINS Q=current_n[0] D=counter_w[0] CK=net1700
+ RB=FE_OFN8_i_rst_n
Xrf_io_write_delay_reg QDFFRBN $PINS Q=rf_io_write_delay D=n436 CK=CTS_141
+ RB=FE_OFN21_i_rst_n
Xmac_valid_out_r_reg QDFFRBN $PINS Q=mac_valid_out_r D=N51 CK=CTS_141
+ RB=FE_OFN21_i_rst_n
Xc_group_idx_reg[1] QDFFRBN $PINS Q=c_group_idx[1] D=FE_PHN1884_n281 CK=CTS_146
+ RB=FE_OFN3_i_rst_n
Xc_group_idx_reg[2] QDFFRBN $PINS Q=c_group_idx[2] D=FE_PHN1883_n280 CK=CTS_146
+ RB=FE_OFN3_i_rst_n
Xc_group_idx_reg[0] QDFFRBN $PINS Q=c_group_idx[0] D=FE_PHN1886_n282 CK=CTS_146
+ RB=FE_OFN3_i_rst_n
Xc_state_reg[1] QDFFRBN $PINS Q=c_state[1] D=n284 CK=CTS_146 RB=FE_OFN3_i_rst_n
Xc_state_reg[0] QDFFRBN $PINS Q=c_state[0] D=FE_PHN2077_n283 CK=CTS_146
+ RB=FE_OFN3_i_rst_n
Xg_cnt_d1_reg[0] QDFFRBN $PINS Q=FE_PHN2090_g_cnt_d1_0 D=FE_PHN2149_current_g_0
+ CK=net1650 RB=FE_OFN8_i_rst_n
Xg_cnt_d2_reg[0] QDFFRBN $PINS Q=FE_PHN2094_g_cnt_d2_0 D=FE_PHN1470_g_cnt_d1_0
+ CK=net1650 RB=FE_OFN8_i_rst_n
Xg_cnt_d1_reg[1] QDFFRBN $PINS Q=g_cnt_d1[1] D=FE_PHN1802_current_g_1
+ CK=net1650 RB=FE_OFN8_i_rst_n
Xg_cnt_d2_reg[1] QDFFRBN $PINS Q=g_cnt_d2[1] D=FE_PHN1466_g_cnt_d1_1 CK=net1650
+ RB=FE_OFN8_i_rst_n
Xg_cnt_d1_reg[2] QDFFRBN $PINS Q=g_cnt_d1[2] D=FE_PHN2120_current_g_2
+ CK=net1650 RB=FE_OFN8_i_rst_n
Xg_cnt_d2_reg[2] QDFFRBN $PINS Q=g_cnt_d2[2] D=FE_PHN1457_g_cnt_d1_2 CK=net1650
+ RB=FE_OFN8_i_rst_n
Xstate_r_reg[1] QDFFRBT $PINS Q=state_r[1] D=FE_PHN1903_n287 CK=CTS_142
+ RB=FE_OFN6_i_rst_n
Xpe_clear_d1_reg QDFFRBP $PINS Q=pe_clear_d1 D=N47 CK=CTS_142
+ RB=FE_OFN6_i_rst_n
XU522 NR2 $PINS O=rf_d_raddr_1[0] I1=FE_DBTN13_current_n_0 I2=FE_OCPN1_n336
XU523 MUX2 $PINS O=key_w[2] S=n289 A=i_data[2] B=FE_PHN1440_key_r_2
XU524 MUX2 $PINS O=key_w[1] S=n289 A=i_data[1] B=FE_PHN1476_key_r_1
XU525 MUX2 $PINS O=key_w[3] S=n289 A=i_data[3] B=FE_PHN1489_key_r_3
XU526 MUX2 $PINS O=key_w[0] S=n289 A=i_data[0] B=key_r[0]
XU528 MUX2 $PINS O=key_w[4] S=n289 A=i_data[4] B=FE_PHN1451_key_r_4
XU529 MUX2 $PINS O=key_w[5] S=n289 A=i_data[5] B=FE_PHN1418_key_r_5
XU530 ND2S $PINS O=n231 I1=FE_OFN30_FE_DBTN9_n336 I2=n230
XU531 OR3B2S $PINS O=n199 I1=N276 B1=n436 B2=N277
XU532 AO22S $PINS O=c_in_r_0[16] A1=c_buf_r[2][16] A2=FE_OFN145_FE_DBTN11_n257
+ B1=c_buf_r[0][16] B2=FE_OFN39_n257
XU533 MUX2 $PINS O=key_w[6] S=n289 A=i_data[6] B=FE_PHN1420_key_r_6
XU534 NR2 $PINS O=sub_149/carry[10] I1=phase_1[8] I2=N85
XU535 NR2 $PINS O=sub_148/carry[11] I1=phase_0[9] I2=N78
XU536 ND2 $PINS O=n153 I1=FE_OFN30_FE_DBTN9_n336 I2=mac_valid_out_r
XU537 AN4S $PINS O=n251 I1=FE_PHN1800_current_n_0 I2=current_g[0] I3=n269
+ I4=n270
XU538 MUX2 $PINS O=key_w[7] S=n289 A=i_data[7] B=FE_PHN1410_key_r_7
XU540 ND2 $PINS O=n289 I1=i_ready I2=FE_OCPN990_FE_DBTN10_state_r_0
XU545 AO22P $PINS O=mac_in_imag[3] A1=mac_in_imag_s1[3] A2=FE_DBTN12_n247
+ B1=rf_d_rdata_1[20] B2=FE_OFN348_n247
XU547 ND2T $PINS O=mac_in_imag[2] I1=n318 I2=n319
XU555 INV1S $PINS O=n425 I=mac_in_real_s1[4]
XU556 AN2T $PINS O=n327 I1=mac_in_imag_s1[4] I2=FE_DBTN12_n247
XU558 INV4 $PINS O=n353 I=FE_RN_2
XU562 MOAI1 $PINS O=o_data[0] A1=o_counter_r[0] A2=n429 B1=mac_in_imag_s1[0]
+ B2=o_counter_r[0]
XU565 MOAI1S $PINS O=o_data[10] A1=n419 A2=n355 B1=n355 B2=mac_in_real_s1_16
XU568 MOAI1 $PINS O=o_data[1] A1=o_counter_r[0] A2=n428 B1=mac_in_imag_s1[1]
+ B2=o_counter_r[0]
XU571 MOAI1 $PINS O=o_data[2] A1=o_counter_r[0] A2=n427 B1=mac_in_imag_s1[2]
+ B2=o_counter_r[0]
XU574 MOAI1 $PINS O=o_data[3] A1=o_counter_r[0] A2=n426 B1=mac_in_imag_s1[3]
+ B2=o_counter_r[0]
XU577 MOAI1 $PINS O=o_data[4] A1=o_counter_r[0] A2=n425 B1=mac_in_imag_s1[4]
+ B2=o_counter_r[0]
XU580 MOAI1 $PINS O=o_data[5] A1=o_counter_r[0] A2=n424 B1=mac_in_imag_s1[5]
+ B2=o_counter_r[0]
XU583 MOAI1 $PINS O=o_data[6] A1=o_counter_r[0] A2=n423 B1=mac_in_imag_s1[6]
+ B2=o_counter_r[0]
XU586 MOAI1 $PINS O=o_data[7] A1=o_counter_r[0] A2=n422 B1=mac_in_imag_s1[7]
+ B2=o_counter_r[0]
XU589 MOAI1 $PINS O=o_data[8] A1=o_counter_r[0] A2=n421 B1=mac_in_imag_s1[8]
+ B2=o_counter_r[0]
XU592 MOAI1 $PINS O=o_data[9] A1=o_counter_r[0] A2=n420 B1=o_counter_r[0]
+ B2=mac_in_imag_s1[9]
XU598 NR2 $PINS O=n256 I1=FE_OCPN329_n247 I2=n419
XU599 ND2 $PINS O=n319 I1=rf_d_rdata_1[19] I2=FE_RN_2
XU600 ND3 $PINS O=n342 I1=FE_DBTN10_state_r_0 I2=n445 I3=state_r[1]
XU603 ND2P $PINS O=n318 I1=FE_DBTN12_n247 I2=mac_in_imag_s1[2]
XU606 OR2S $PINS O=n465 I1=state_r[1] I2=FE_OCPN2_state_r_2
XU607 INV1S $PINS O=i_ready I=n465
XU609 AN2T $PINS O=n328 I1=rf_d_rdata_1[21] I2=FE_OFN348_n247
XU610 OR2T $PINS O=mac_in_imag[4] I1=n327 I2=n328
XU613 ND2S $PINS O=n238 I1=n437 I2=FE_OFN30_FE_DBTN9_n336
XU614 NR2P $PINS O=n331 I1=FE_DBTN13_current_n_0 I2=n232
XU615 ND2S $PINS O=n332 I1=N291 I2=n436
XU616 ND2S $PINS O=n333 I1=N276 I2=n436
XU617 ND2S $PINS O=n334 I1=N321 I2=n436
XU618 ND2S $PINS O=n335 I1=N306 I2=n436
XU619 OR3S $PINS O=n337 I1=N321 I2=N322 I3=n153
XU620 OR3S $PINS O=n338 I1=N306 I2=N307 I3=n153
XU621 OR3S $PINS O=n339 I1=N291 I2=N292 I3=n153
XU622 OR3S $PINS O=n340 I1=N276 I2=N277 I3=n153
XU623 AO22S $PINS O=rf_io_waddr_2[2] A1=n436 A2=g_cnt_d3[0] B1=FE_OFN171_n434
+ B2=delayed_mac_group[0]
XU624 AO22S $PINS O=rf_io_waddr_2[3] A1=n436 A2=g_cnt_d3[1] B1=FE_OFN171_n434
+ B2=delayed_mac_group[1]
XU625 ND3S $PINS O=k_ord_1[0] I1=c_group_idx[2] I2=FE_DBTN11_n257 I3=n258
XU626 OA12S $PINS O=rf_io_wen_2 A1=FE_OFN30_FE_DBTN9_n336 B1=mac_valid_out_r
+ B2=n230
XU628 AO22S $PINS O=c_in_i_1[0] A1=c_buf_i[3][0] A2=FE_OFN146_FE_DBTN11_n257
+ B1=c_buf_i[1][0] B2=FE_OFN40_n257
XU629 AO22S $PINS O=c_in_i_0[0] A1=c_buf_i[2][0] A2=FE_OFN145_FE_DBTN11_n257
+ B1=c_buf_i[0][0] B2=FE_OFN39_n257
XU630 AO22S $PINS O=c_in_i_1[1] A1=c_buf_i[3][1] A2=FE_OFN146_FE_DBTN11_n257
+ B1=c_buf_i[1][1] B2=FE_OFN40_n257
XU631 AO22S $PINS O=c_in_i_0[1] A1=c_buf_i[2][1] A2=FE_OFN145_FE_DBTN11_n257
+ B1=c_buf_i[0][1] B2=FE_OFN39_n257
XU632 AO22S $PINS O=c_in_i_1[2] A1=c_buf_i[3][2] A2=FE_OFN146_FE_DBTN11_n257
+ B1=c_buf_i[1][2] B2=FE_OFN40_n257
XU633 AO22S $PINS O=c_in_i_0[2] A1=c_buf_i[2][2] A2=FE_OFN145_FE_DBTN11_n257
+ B1=c_buf_i[0][2] B2=FE_OFN39_n257
XU634 AO22S $PINS O=c_in_i_1[3] A1=c_buf_i[3][3] A2=FE_OFN146_FE_DBTN11_n257
+ B1=c_buf_i[1][3] B2=FE_OFN40_n257
XU635 AO22S $PINS O=c_in_i_0[3] A1=c_buf_i[2][3] A2=FE_OFN145_FE_DBTN11_n257
+ B1=c_buf_i[0][3] B2=FE_OFN39_n257
XU636 AO22S $PINS O=c_in_i_1[4] A1=c_buf_i[3][4] A2=FE_OFN146_FE_DBTN11_n257
+ B1=c_buf_i[1][4] B2=FE_OFN40_n257
XU637 AO22S $PINS O=c_in_i_0[4] A1=c_buf_i[2][4] A2=FE_OFN145_FE_DBTN11_n257
+ B1=c_buf_i[0][4] B2=FE_OFN39_n257
XU638 AO22S $PINS O=c_in_i_0[5] A1=c_buf_i[2][5] A2=FE_OFN145_FE_DBTN11_n257
+ B1=c_buf_i[0][5] B2=FE_OFN39_n257
XU639 AO22S $PINS O=c_in_i_0[6] A1=c_buf_i[2][6] A2=FE_OFN145_FE_DBTN11_n257
+ B1=c_buf_i[0][6] B2=FE_OFN39_n257
XU640 AO22S $PINS O=c_in_i_0[8] A1=c_buf_i[2][8] A2=FE_DBTN11_n257
+ B1=c_buf_i[0][8] B2=n257
XU641 AO22S $PINS O=c_in_r_1[9] A1=c_buf_r[3][9] A2=FE_OFN146_FE_DBTN11_n257
+ B1=c_buf_r[1][9] B2=FE_OFN40_n257
XU642 AO22S $PINS O=c_in_i_0[9] A1=c_buf_i[2][9] A2=FE_DBTN11_n257
+ B1=c_buf_i[0][9] B2=n257
XU643 AO22S $PINS O=c_in_i_1[10] A1=c_buf_i[3][10] A2=FE_OFN146_FE_DBTN11_n257
+ B1=c_buf_i[1][10] B2=FE_OFN40_n257
XU644 AO22S $PINS O=c_in_i_0[10] A1=c_buf_i[2][10] A2=FE_OFN145_FE_DBTN11_n257
+ B1=c_buf_i[0][10] B2=FE_OFN39_n257
XU645 AO22S $PINS O=c_in_i_1[11] A1=c_buf_i[3][11] A2=FE_OFN146_FE_DBTN11_n257
+ B1=c_buf_i[1][11] B2=FE_OFN40_n257
XU646 AO22S $PINS O=c_in_i_0[11] A1=c_buf_i[2][11] A2=FE_OFN145_FE_DBTN11_n257
+ B1=c_buf_i[0][11] B2=FE_OFN39_n257
XU647 AO22S $PINS O=c_in_i_1[12] A1=c_buf_i[3][12] A2=FE_OFN146_FE_DBTN11_n257
+ B1=c_buf_i[1][12] B2=FE_OFN40_n257
XU648 AO22S $PINS O=c_in_i_0[12] A1=c_buf_i[2][12] A2=FE_OFN145_FE_DBTN11_n257
+ B1=c_buf_i[0][12] B2=FE_OFN39_n257
XU649 AO22S $PINS O=c_in_i_1[13] A1=c_buf_i[3][13] A2=FE_OFN146_FE_DBTN11_n257
+ B1=c_buf_i[1][13] B2=FE_OFN40_n257
XU650 AO22S $PINS O=c_in_i_0[13] A1=c_buf_i[2][13] A2=FE_OFN145_FE_DBTN11_n257
+ B1=c_buf_i[0][13] B2=FE_OFN39_n257
XU651 AO22S $PINS O=c_in_i_1[14] A1=c_buf_i[3][14] A2=FE_DBTN11_n257
+ B1=c_buf_i[1][14] B2=n257
XU652 AO22S $PINS O=c_in_i_0[14] A1=c_buf_i[2][14] A2=FE_OFN145_FE_DBTN11_n257
+ B1=c_buf_i[0][14] B2=FE_OFN39_n257
XU653 AO22S $PINS O=c_in_i_1[15] A1=c_buf_i[3][15] A2=FE_DBTN11_n257
+ B1=c_buf_i[1][15] B2=n257
XU654 AO22S $PINS O=c_in_i_0[15] A1=c_buf_i[2][15] A2=FE_OFN145_FE_DBTN11_n257
+ B1=c_buf_i[0][15] B2=FE_OFN39_n257
XU655 AO22S $PINS O=c_in_i_1[16] A1=c_buf_i[3][16] A2=FE_OFN146_FE_DBTN11_n257
+ B1=c_buf_i[1][16] B2=FE_OFN40_n257
XU656 AO22S $PINS O=c_in_i_0[16] A1=c_buf_i[2][16] A2=FE_OFN145_FE_DBTN11_n257
+ B1=c_buf_i[0][16] B2=FE_OFN39_n257
XU657 AO12S $PINS O=n283 A1=n435 B1=c_state[0] B2=n239
XU663 INV1S $PINS O=n442 I=n232
XU664 INV1S $PINS O=n434 I=n231
XU665 INV2 $PINS O=n90 I=n271
XU666 INV1S $PINS O=n367 I=N91
XU667 NR2 $PINS O=k_ord_1[1] I1=n460 I2=n257
XU668 INV1S $PINS O=n365 I=N89
XU669 INV1S $PINS O=n366 I=N90
XU670 INV1S $PINS O=n364 I=N88
XU671 INV1S $PINS O=n363 I=N87
XU672 INV1S $PINS O=n362 I=N86
XU673 INV1S $PINS O=n361 I=N85
XU675 ND3 $PINS O=n254 I1=n289 I2=n271 I3=n232
XU676 OR2 $PINS O=n253 I1=n254 I2=n439
XU678 INV1S $PINS O=n373 I=N82
XU679 INV1S $PINS O=n372 I=N81
XU682 INV1S $PINS O=n371 I=N80
XU683 INV1S $PINS O=n370 I=N79
XU684 INV1S $PINS O=n369 I=N78
XU686 ND3 $PINS O=N462 I1=n274 I2=n431 I3=o_valid
XU687 AN2 $PINS O=n275 I1=n289 I2=n232
XU688 OR2 $PINS O=rf_io_wen_1 I1=rf_io_wen_2 I2=n331
XU689 INV1S $PINS O=n436 I=n153
XU691 NR2 $PINS O=N475 I1=n249 I2=n439
XU692 NR2 $PINS O=N157 I1=n359 I2=n153
XU693 NR2 $PINS O=n271 I1=FE_OCPN1118_FE_DBTN12_n247 I2=FE_OFN30_FE_DBTN9_n336
XU694 INV1S $PINS O=n439 I=n234
XU695 NR2 $PINS O=N69 I1=n240 I2=n359
XU696 INV1S $PINS O=n460 I=k_ord_1[0]
XU697 NR2 $PINS O=k_ord_1[2] I1=n460 I2=FE_DBTN0_c_group_idx_0
XU698 NR2 $PINS O=k_ord_1[3] I1=n460 I2=FE_DBTN1_c_group_idx_1
XU699 INV1S $PINS O=n374 I=N83
XU700 OA12 $PINS O=n246 A1=n252 B1=n251 B2=n232
XU701 NR2 $PINS O=k_ord_1[4] I1=n460 I2=FE_DBTN2_c_group_idx_2
XU702 MOAI1S $PINS O=counter_w[7] A1=n259 A2=FE_DBTN3_current_g_2 B1=N219
+ B2=n260
XU703 MOAI1S $PINS O=counter_w[6] A1=n259 A2=FE_DBTN4_current_g_1 B1=N218
+ B2=n260
XU704 MOAI1S $PINS O=counter_w[5] A1=n259 A2=FE_DBTN5_current_g_0 B1=N217
+ B2=n260
XU705 MOAI1S $PINS O=n287 A1=n252 A2=n440 B1=n442 B2=n251
XU706 OAI222S $PINS O=n260 A1=n251 A2=n232 B1=n432 B2=FE_OCPN251_n247 C1=n336
+ C2=n263
XU707 INV1S $PINS O=n432 I=n248
XU708 MOAI1S $PINS O=counter_w[4] A1=n449 A2=n254 B1=N216 B2=n260
XU709 MOAI1S $PINS O=counter_w[3] A1=n448 A2=n254 B1=N215 B2=n260
XU710 MOAI1S $PINS O=counter_w[2] A1=n446 A2=n254 B1=N214 B2=n260
XU711 MOAI1S $PINS O=counter_w[1] A1=FE_DBTN6_current_n_1 A2=n254 B1=N213
+ B2=n260
XU712 INV1S $PINS O=n136 I=n337
XU713 INV1S $PINS O=n151 I=n338
XU714 INV1S $PINS O=n183 I=n339
XU715 INV1S $PINS O=n201 I=n340
XU716 MOAI1S $PINS O=rf_io_raddr_1[0] A1=FE_DBTN13_current_n_0 A2=n233
+ B1=o_valid B2=N421
XU717 MOAI1 $PINS O=rf_io_raddr_1[4] A1=n449 A2=n233 B1=N425 B2=o_valid
XU718 MOAI1 $PINS O=rf_io_raddr_1[3] A1=n448 A2=n233 B1=o_valid B2=N424
XU719 INV1S $PINS O=n453 I=o_valid
XU720 MOAI1 $PINS O=rf_io_raddr_1[2] A1=n446 A2=n233 B1=o_valid B2=N423
XU721 MOAI1 $PINS O=rf_io_raddr_1[1] A1=FE_DBTN6_current_n_1 A2=n233 B1=o_valid
+ B2=N422
XU723 NR2 $PINS O=rf_d_raddr_1[3] I1=FE_OCPN1_n336 I2=n448
XU724 NR2 $PINS O=rf_d_raddr_1[2] I1=FE_OCPN1_n336 I2=n446
XU725 NR2 $PINS O=rf_d_raddr_1[1] I1=FE_OCPN1_n336 I2=FE_DBTN6_current_n_1
XU726 AN4B1S $PINS O=N47 I1=FE_DBTN13_current_n_0 I2=FE_DBTN6_current_n_1
+ I3=n90 B1=n273
XU727 ND3 $PINS O=n273 I1=n448 I2=n449 I3=n446
XU728 INV1S $PINS O=n435 I=n240
XU729 ND3 $PINS O=n236 I1=n238 I2=n431 I3=o_valid
XU730 MOAI1S $PINS O=o_counter_w[5] A1=n236 A2=n458 B1=N425 B2=n237
XU731 MOAI1S $PINS O=o_counter_w[4] A1=n236 A2=n457 B1=N424 B2=n237
XU732 MOAI1S $PINS O=o_counter_w[0] A1=n355 A2=n236 B1=n355 B2=n237
XU733 NR2 $PINS O=n237 I1=n431 I2=n453
XU734 INV1S $PINS O=FE_PHN1743_n437 I=n262
XU735 NR2 $PINS O=n278 I1=N111 I2=N112
XU736 NR2 $PINS O=n279 I1=N96 I2=N97
XU737 NR2 $PINS O=n276 I1=N141 I2=N142
XU738 NR2 $PINS O=n277 I1=N126 I2=N127
XU739 NR2 $PINS O=n245 I1=n458 I2=n457
XU743 AN2 $PINS O=rf_io_waddr_1[0] I1=n331 I2=current_n[1]
XU748 NR2P $PINS O=n257 I1=n463 I2=c_state[1]
XU749 INV1S $PINS O=n463 I=c_state[0]
XU750 MOAI1S $PINS O=rf_io_waddr_2[4] A1=n231 A2=n80 B1=n436
+ B2=FE_PHN1797_g_cnt_d3_2
XU752 NR2 $PINS O=n249 I1=i_valid I2=n289
XU753 INV1S $PINS O=n438 I=rf_io_write_delay
XU754 NR2 $PINS O=n230 I1=n438 I2=mac_valid_out_r
XU756 INV1S $PINS O=n440 I=state_r[1]
XU757 NR2 $PINS O=n258 I1=FE_DBTN1_c_group_idx_1 I2=FE_DBTN0_c_group_idx_0
XU758 INV1S $PINS O=n431 I=o_ready
XU761 AOI22S $PINS O=n227 A1=real_hold_reg[10] A2=n331 B1=delayed_out2[10]
+ B2=FE_OFN171_n434
XU762 AOI22S $PINS O=n200 A1=i_data[10] A2=n331 B1=delayed_out2[21]
+ B2=FE_OFN171_n434
XU763 ND3 $PINS O=rf_io_wdata_1[10] I1=n225 I2=n226 I3=n227
XU764 ND3 $PINS O=rf_io_wdata_1[21] I1=n198 I2=n199 I3=n200
XU765 ND3 $PINS O=rf_io_wdata_1[0] I1=n228 I2=n332 I3=n229
XU766 AOI22S $PINS O=n229 A1=real_hold_reg[0] A2=n331 B1=delayed_out2[0]
+ B2=FE_OFN171_n434
XU767 ND3 $PINS O=rf_io_wdata_1[1] I1=n205 I2=n332 I3=n206
XU768 AOI22S $PINS O=n206 A1=real_hold_reg[1] A2=n331 B1=delayed_out2[1]
+ B2=FE_OFN171_n434
XU769 ND3 $PINS O=rf_io_wdata_1[2] I1=n196 I2=n332 I3=n197
XU770 AOI22S $PINS O=n197 A1=real_hold_reg[2] A2=n331 B1=delayed_out2[2]
+ B2=FE_OFN171_n434
XU771 ND3 $PINS O=rf_io_wdata_1[3] I1=n194 I2=n332 I3=n195
XU772 AOI22S $PINS O=n195 A1=real_hold_reg[3] A2=n331 B1=delayed_out2[3]
+ B2=FE_OFN171_n434
XU773 ND3 $PINS O=rf_io_wdata_1[4] I1=n192 I2=n332 I3=n193
XU774 AOI22S $PINS O=n193 A1=real_hold_reg[4] A2=n331 B1=delayed_out2[4]
+ B2=FE_OFN171_n434
XU775 ND3 $PINS O=rf_io_wdata_1[5] I1=n190 I2=n332 I3=n191
XU776 AOI22S $PINS O=n191 A1=real_hold_reg[5] A2=n331 B1=delayed_out2[5]
+ B2=FE_OFN171_n434
XU777 ND3 $PINS O=rf_io_wdata_1[6] I1=n188 I2=n332 I3=n189
XU778 AOI22S $PINS O=n189 A1=real_hold_reg[6] A2=n331 B1=delayed_out2[6]
+ B2=FE_OFN171_n434
XU779 ND3 $PINS O=rf_io_wdata_1[7] I1=n186 I2=n332 I3=n187
XU780 AOI22S $PINS O=n187 A1=real_hold_reg[7] A2=n331 B1=delayed_out2[7]
+ B2=FE_OFN171_n434
XU781 ND3 $PINS O=rf_io_wdata_1[8] I1=n184 I2=n332 I3=n185
XU782 AOI22S $PINS O=n185 A1=real_hold_reg[8] A2=n331 B1=delayed_out2[8]
+ B2=FE_OFN171_n434
XU783 ND3 $PINS O=rf_io_wdata_1[9] I1=n180 I2=n332 I3=n182
XU784 AOI22S $PINS O=n182 A1=real_hold_reg[9] A2=n331 B1=delayed_out2[9]
+ B2=FE_OFN171_n434
XU785 ND3 $PINS O=rf_io_wdata_1[11] I1=n223 I2=n333 I3=n224
XU786 AOI22S $PINS O=n224 A1=i_data[0] A2=n331 B1=delayed_out2[11]
+ B2=FE_OFN171_n434
XU787 ND3 $PINS O=rf_io_wdata_1[12] I1=n221 I2=n333 I3=n222
XU788 AOI22S $PINS O=n222 A1=i_data[1] A2=n331 B1=delayed_out2[12]
+ B2=FE_OFN171_n434
XU789 ND3 $PINS O=rf_io_wdata_1[13] I1=n219 I2=n333 I3=n220
XU790 AOI22S $PINS O=n220 A1=i_data[2] A2=n331 B1=delayed_out2[13]
+ B2=FE_OFN171_n434
XU791 ND3 $PINS O=rf_io_wdata_1[14] I1=n217 I2=n333 I3=n218
XU792 AOI22S $PINS O=n218 A1=i_data[3] A2=n331 B1=delayed_out2[14]
+ B2=FE_OFN171_n434
XU793 ND3 $PINS O=rf_io_wdata_1[15] I1=n215 I2=n333 I3=n216
XU794 AOI22S $PINS O=n216 A1=i_data[4] A2=n331 B1=delayed_out2[15]
+ B2=FE_OFN171_n434
XU795 ND3 $PINS O=rf_io_wdata_1[16] I1=n213 I2=n333 I3=n214
XU796 AOI22S $PINS O=n214 A1=i_data[5] A2=n331 B1=delayed_out2[16]
+ B2=FE_OFN171_n434
XU797 ND3 $PINS O=rf_io_wdata_1[17] I1=n211 I2=n333 I3=n212
XU798 AOI22S $PINS O=n212 A1=i_data[6] A2=n331 B1=delayed_out2[17]
+ B2=FE_OFN171_n434
XU799 ND3 $PINS O=rf_io_wdata_1[18] I1=n209 I2=n333 I3=n210
XU800 AOI22S $PINS O=n210 A1=i_data[7] A2=n331 B1=delayed_out2[18]
+ B2=FE_OFN171_n434
XU801 ND3 $PINS O=rf_io_wdata_1[19] I1=n207 I2=n333 I3=n208
XU802 AOI22S $PINS O=n208 A1=i_data[8] A2=n331 B1=delayed_out2[19]
+ B2=FE_OFN171_n434
XU803 ND3 $PINS O=rf_io_wdata_1[20] I1=n202 I2=n333 I3=n204
XU804 AOI22S $PINS O=n204 A1=i_data[9] A2=n331 B1=delayed_out2[20]
+ B2=FE_OFN171_n434
XU805 MOAI1S $PINS O=counter_w[8] A1=n259 A2=n452 B1=N220 B2=n260
XU806 MOAI1S $PINS O=counter_w[0] A1=FE_DBTN13_current_n_0 A2=n254
+ B1=FE_DBTN13_current_n_0 B2=n260
XU808 NR2 $PINS O=n177 I1=N321 I2=n153
XU809 NR2 $PINS O=n152 I1=N306 I2=n153
XU810 ND3 $PINS O=rf_io_wdata_2[1] I1=n157 I2=n334 I3=n158
XU811 ND3 $PINS O=rf_io_wdata_2[2] I1=n149 I2=n334 I3=n150
XU812 ND3 $PINS O=rf_io_wdata_2[3] I1=n147 I2=n334 I3=n148
XU813 ND3 $PINS O=rf_io_wdata_2[4] I1=n145 I2=n334 I3=n146
XU814 ND3 $PINS O=rf_io_wdata_2[5] I1=n143 I2=n334 I3=FE_PHN1592_n144
XU815 ND3 $PINS O=rf_io_wdata_2[6] I1=n141 I2=n334 I3=n142
XU816 ND3 $PINS O=rf_io_wdata_2[7] I1=n139 I2=n334 I3=n140
XU817 ND3 $PINS O=rf_io_wdata_2[8] I1=n137 I2=n334 I3=n138
XU818 ND3 $PINS O=rf_io_wdata_2[9] I1=n133 I2=n334 I3=FE_PHN1595_n135
XU819 ND3 $PINS O=rf_io_wdata_2[16] I1=n165 I2=n335 I3=n166
XU820 ND3 $PINS O=rf_io_wdata_2[17] I1=n163 I2=n335 I3=n164
XU821 ND3 $PINS O=rf_io_wdata_2[18] I1=n161 I2=n335 I3=n162
XU822 ND3 $PINS O=rf_io_wdata_2[19] I1=n159 I2=n335 I3=n160
XU823 ND3 $PINS O=rf_io_wdata_2[20] I1=n154 I2=n335 I3=n156
XU824 ND3 $PINS O=rf_io_wdata_2[0] I1=n178 I2=n334 I3=n179
XU825 ND3 $PINS O=rf_io_wdata_2[11] I1=n175 I2=n335 I3=n176
XU826 ND3 $PINS O=rf_io_wdata_2[12] I1=n173 I2=n335 I3=n174
XU827 ND3 $PINS O=rf_io_wdata_2[13] I1=n171 I2=n335 I3=n172
XU828 ND3 $PINS O=rf_io_wdata_2[14] I1=n169 I2=n335 I3=n170
XU829 ND3 $PINS O=rf_io_wdata_2[15] I1=n167 I2=n335 I3=n168
XU830 INV1S $PINS O=n355 I=o_counter_r[0]
XU831 INV1S $PINS O=n448 I=FE_PHN1792_current_n_3
XU832 INV1S $PINS O=n449 I=FE_PHN1793_current_n_4
XU833 INV1S $PINS O=n379 I=pe_r1[10]
XU834 INV1S $PINS O=n384 I=pe_i1[10]
XU835 INV1S $PINS O=n446 I=FE_PHN1790_current_n_2
XU836 AN2 $PINS O=n265 I1=n266 I2=n267
XU837 AN4B1S $PINS O=n266 I1=FE_DBTN4_current_g_1 I2=FE_DBTN3_current_g_2
+ I3=FE_DBTN5_current_g_0 B1=n452
XU838 AN4B1S $PINS O=n267 I1=FE_DBTN13_current_n_0 I2=n446 I3=n449
+ B1=FE_PHN1792_current_n_3
XU839 INV1S $PINS O=n394 I=pe_i0[10]
XU840 INV1S $PINS O=n389 I=pe_r0[10]
XU844 MOAI1S $PINS O=o_counter_w[3] A1=n236 A2=n456 B1=N423 B2=n237
XU845 INV1S $PINS O=n456 I=o_counter_r[3]
XU846 MOAI1S $PINS O=o_counter_w[2] A1=n236 A2=n455 B1=N422 B2=n237
XU847 INV1S $PINS O=n455 I=o_counter_r[2]
XU848 MOAI1S $PINS O=o_counter_w[1] A1=n236 A2=n454 B1=N421 B2=n237
XU849 INV1S $PINS O=n454 I=o_counter_r[1]
XU850 AOI12HS $PINS O=n239 A1=N63 B1=n463 B2=FE_PHN1385_cordic_valid_out_0
XU851 ND3 $PINS O=FE_PHN1839_n241 I1=n257 I2=n240
+ I3=FE_PHN1385_cordic_valid_out_0
XU852 INV1S $PINS O=n430 I=n241
XU853 AN4B1S $PINS O=N48 I1=FE_PHN1800_current_n_0 I2=n90
+ I3=FE_PHN1793_current_n_4 B1=n272
XU854 ND3 $PINS O=n272 I1=FE_PHN1790_current_n_2 I2=FE_PHN1792_current_n_3
+ I3=current_n[1]
XU856 AN2 $PINS O=N51 I1=FE_PHN2044_pe_done_d2 I2=n90
XU857 AN2 $PINS O=N50 I1=pe_done_d1 I2=n90
XU858 MOAI1S $PINS O=n282 A1=n435 A2=FE_DBTN0_c_group_idx_0 B1=n435
+ B2=g_cnt_d3[0]
XU859 MOAI1S $PINS O=n281 A1=n435 A2=FE_DBTN1_c_group_idx_1 B1=n435
+ B2=g_cnt_d3[1]
XU860 MOAI1S $PINS O=n280 A1=n435 A2=FE_DBTN2_c_group_idx_2 B1=n435
+ B2=FE_PHN1797_g_cnt_d3_2
XU861 NR3 $PINS O=n269 I1=FE_PHN1720_counter_r_8 I2=current_g[2]
+ I3=FE_PHN1802_current_g_1
XU862 AN4B1S $PINS O=n270 I1=current_n[1] I2=FE_PHN1790_current_n_2
+ I3=FE_PHN1793_current_n_4 B1=n448
XU863 INV1S $PINS O=n452 I=FE_PHN1720_counter_r_8
XU864 ND3 $PINS O=n262 I1=delayed_mac_group[0] I2=delayed_mac_group[1] I3=n264
XU865 NR2 $PINS O=n264 I1=n438 I2=n80
XU866 AOI13HS $PINS O=N111 A1=pe_r2[16] B1=n408 B2=n409 B3=n407
XU867 INV1S $PINS O=n409 I=pe_r2[10]
XU868 AOI13HS $PINS O=N96 A1=FE_PHN2191_pe_i2_16 B1=n413 B2=n414 B3=n412
XU869 INV1S $PINS O=n414 I=pe_i2[10]
XU870 AOI13HS $PINS O=N141 A1=pe_r3[16] B1=n398 B2=n399 B3=n397
XU871 INV1S $PINS O=n399 I=pe_r3[10]
XU872 AOI13HS $PINS O=N126 A1=FE_PHN1582_pe_i3_16 B1=n403 B2=n404 B3=n402
XU873 INV1S $PINS O=n404 I=pe_i3[10]
XU874 MOAI1S $PINS O=N125 A1=N111 A2=n418 B1=pe_r2[10] B2=n278
XU875 INV1S $PINS O=n418 I=N112
XU876 MOAI1S $PINS O=N110 A1=N96 A2=n417 B1=pe_i2[10] B2=n279
XU877 INV1S $PINS O=n417 I=N97
XU878 MOAI1S $PINS O=N155 A1=N141 A2=n416 B1=pe_r3[10] B2=n276
XU879 INV1S $PINS O=n416 I=N142
XU880 MOAI1S $PINS O=N140 A1=N126 A2=n415 B1=pe_i3[10] B2=n277
XU881 INV1S $PINS O=n415 I=N127
XU882 XNR2HS $PINS O=n285 I1=n242 I2=n453
XU883 OAI22S $PINS O=n242 A1=n243 A2=n244 B1=o_valid B2=n234
XU884 ND3 $PINS O=n244 I1=o_counter_r[2] I2=o_counter_r[3] I3=o_counter_r[1]
XU885 ND3 $PINS O=n243 I1=o_counter_r[0] I2=o_valid I3=n245
XU886 INV1S $PINS O=n458 I=o_counter_r[5]
XU887 INV1S $PINS O=n457 I=o_counter_r[4]
XU888 INV1S $PINS O=n359 I=FE_OFN21_i_rst_n
XU891 ND3S $PINS O=n274 I1=FE_OCPN251_n247 I2=n234 I3=n275
XU892 MOAI1S $PINS O=mac_in_real[9] A1=n420 A2=FE_OFN38_n247 B1=rf_d_rdata_1[9]
+ B2=FE_OFN38_n247
XU894 ND2S $PINS O=n240 I1=FE_OCPN1011_FE_DBTN12_n247 I2=mac_valid_out_r
XU895 AN2 $PINS O=n255 I1=FE_OFN428_FE_DBTN12_n247 I2=mac_in_real_s1_16
XU896 OA112S $PINS O=n252 A1=FE_OCPN251_n247 B1=n253 C1=n437 C2=n336
XU897 AO12 $PINS O=mac_in_real[16] A1=n255 B1=rf_d_rdata_1[16]
+ B2=FE_OCPN474_FE_OFN38_n247
XU898 AO12S $PINS O=mac_in_imag[16] A1=n256 B1=rf_d_rdata_1[33]
+ B2=FE_OFN348_n247
XU899 AO12 $PINS O=mac_in_real[15] A1=n255 B1=rf_d_rdata_1[15] B2=FE_OFN38_n247
XU900 AO12S $PINS O=mac_in_imag[15] A1=n256 B1=rf_d_rdata_1[32]
+ B2=FE_OCPN501_n247
XU901 AO12 $PINS O=mac_in_real[14] A1=n255 B1=rf_d_rdata_1[14]
+ B2=FE_OCPN474_FE_OFN38_n247
XU902 AO12S $PINS O=mac_in_imag[14] A1=n256 B1=rf_d_rdata_1[31]
+ B2=FE_OCPN501_n247
XU903 AO12 $PINS O=mac_in_real[13] A1=n255 B1=rf_d_rdata_1[13]
+ B2=FE_OCPN474_FE_OFN38_n247
XU904 AO12S $PINS O=mac_in_imag[13] A1=n256 B1=rf_d_rdata_1[30]
+ B2=FE_OFN348_n247
XU905 AO12 $PINS O=mac_in_real[12] A1=n255 B1=rf_d_rdata_1[12]
+ B2=FE_OCPN474_FE_OFN38_n247
XU906 AO12S $PINS O=mac_in_imag[12] A1=n256 B1=rf_d_rdata_1[29]
+ B2=FE_OCPN501_n247
XU907 AO12 $PINS O=mac_in_real[11] A1=n255 B1=rf_d_rdata_1[11]
+ B2=FE_OCPN474_FE_OFN38_n247
XU908 AO12S $PINS O=mac_in_imag[11] A1=n256 B1=rf_d_rdata_1[28]
+ B2=FE_OCPN501_n247
XU909 AO12 $PINS O=mac_in_imag[10] A1=n256 B1=rf_d_rdata_1[27]
+ B2=FE_OFN348_n247
XU910 AO12 $PINS O=mac_in_real[10] A1=n255 B1=rf_d_rdata_1[10]
+ B2=FE_OCPN474_FE_OFN38_n247
XU911 ND3S $PINS O=n234 I1=FE_DBTN10_state_r_0 I2=n440 I3=FE_OCPN2_state_r_2
XU912 ND2S $PINS O=n232 I1=i_ready I2=FE_OCPN1053_state_r_0
XU913 OAI222S $PINS O=n286 A1=n246 A2=FE_OCPN990_FE_DBTN10_state_r_0
+ B1=FE_OCPN251_n247 B2=n248 C1=n249 C2=n289
XU914 AO22S $PINS O=mac_in_imag[9] A1=mac_in_imag_s1[9] A2=FE_DBTN12_n247
+ B1=rf_d_rdata_1[26] B2=FE_OFN348_n247
XU915 AO22S $PINS O=mac_in_imag[8] A1=mac_in_imag_s1[8] A2=FE_DBTN12_n247
+ B1=rf_d_rdata_1[25] B2=FE_OFN348_n247
XU916 AO22 $PINS O=mac_in_imag[7] A1=mac_in_imag_s1[7]
+ A2=FE_OFN428_FE_DBTN12_n247 B1=rf_d_rdata_1[24] B2=FE_OCPN329_n247
XU921 XOR2HS $PINS O=phase_1[15] I1=n367 I2=sub_149/carry[15]
XU922 AN2 $PINS O=sub_149/carry[15] I1=sub_149/carry[14] I2=n366
XU923 XOR2HS $PINS O=phase_1[14] I1=n366 I2=sub_149/carry[14]
XU924 AN2 $PINS O=sub_149/carry[14] I1=sub_149/carry[13] I2=n365
XU925 XOR2HS $PINS O=phase_1[13] I1=n365 I2=sub_149/carry[13]
XU926 AN2 $PINS O=sub_149/carry[13] I1=sub_149/carry[12] I2=n364
XU927 XOR2HS $PINS O=phase_1[12] I1=n364 I2=sub_149/carry[12]
XU928 AN2 $PINS O=sub_149/carry[12] I1=sub_149/carry[11] I2=n363
XU929 XOR2HS $PINS O=phase_1[11] I1=n363 I2=sub_149/carry[11]
XU930 AN2 $PINS O=sub_149/carry[11] I1=sub_149/carry[10] I2=n362
XU931 XOR2HS $PINS O=phase_1[10] I1=n362 I2=sub_149/carry[10]
XU932 XOR2HS $PINS O=phase_1[9] I1=n361 I2=FE_DBTN8_phase_1_8
XU933 XOR2HS $PINS O=phase_0[15] I1=n374 I2=sub_148/carry[15]
XU934 AN2 $PINS O=sub_148/carry[15] I1=sub_148/carry[14] I2=n373
XU935 XOR2HS $PINS O=phase_0[14] I1=n373 I2=sub_148/carry[14]
XU936 AN2 $PINS O=sub_148/carry[14] I1=sub_148/carry[13] I2=n372
XU937 XOR2HS $PINS O=phase_0[13] I1=n372 I2=sub_148/carry[13]
XU938 AN2 $PINS O=sub_148/carry[13] I1=sub_148/carry[12] I2=n371
XU939 XOR2HS $PINS O=phase_0[12] I1=n371 I2=sub_148/carry[12]
XU940 AN2 $PINS O=sub_148/carry[12] I1=sub_148/carry[11] I2=n370
XU941 XOR2HS $PINS O=phase_0[11] I1=n370 I2=sub_148/carry[11]
XU942 XOR2HS $PINS O=phase_0[10] I1=n369 I2=FE_DBTN7_phase_0_9
XU943 XOR2HS $PINS O=N425 I1=r174/carry[5] I2=o_counter_r[5]
XU944 ND3 $PINS O=n376 I1=pe_r1[13] I2=pe_r1[10] I3=pe_r1[14]
XU945 ND3 $PINS O=n375 I1=pe_r1[11] I2=pe_r1[15] I3=pe_r1[12]
XU946 OA12 $PINS O=N322 A1=pe_r1[16] B1=n376 B2=n375
XU947 NR2 $PINS O=n378 I1=pe_r1[12] I2=pe_r1[11]
XU948 NR3 $PINS O=n377 I1=pe_r1[13] I2=pe_r1[15] I3=pe_r1[14]
XU949 AOI13HS $PINS O=N321 A1=pe_r1[16] B1=n378 B2=n379 B3=n377
XU950 ND3 $PINS O=n381 I1=pe_i1[13] I2=pe_i1[10] I3=FE_PHN1791_pe_i1_14
XU951 ND3 $PINS O=n380 I1=FE_PHN1794_pe_i1_11 I2=pe_i1[15] I3=pe_i1[12]
XU952 OA12 $PINS O=N307 A1=pe_i1[16] B1=n381 B2=n380
XU953 NR2 $PINS O=n383 I1=pe_i1[12] I2=FE_PHN1794_pe_i1_11
XU954 NR3 $PINS O=n382 I1=pe_i1[13] I2=pe_i1[15] I3=FE_PHN1791_pe_i1_14
XU955 AOI13HS $PINS O=N306 A1=pe_i1[16] B1=n383 B2=n384 B3=n382
XU956 ND3 $PINS O=n386 I1=FE_PHN2201_pe_r0_13 I2=pe_r0[10]
+ I3=FE_PHN2198_pe_r0_14
XU957 ND3 $PINS O=n385 I1=pe_r0[11] I2=pe_r0[15] I3=pe_r0[12]
XU958 OA12 $PINS O=N292 A1=FE_PHN2200_pe_r0_16 B1=n386 B2=n385
XU959 NR2 $PINS O=n388 I1=pe_r0[12] I2=pe_r0[11]
XU960 NR3 $PINS O=n387 I1=FE_PHN2201_pe_r0_13 I2=pe_r0[15]
+ I3=FE_PHN2198_pe_r0_14
XU961 AOI13HS $PINS O=N291 A1=FE_PHN2200_pe_r0_16 B1=n388 B2=n389 B3=n387
XU962 ND3 $PINS O=n391 I1=pe_i0[13] I2=pe_i0[10] I3=pe_i0[14]
XU963 ND3 $PINS O=n390 I1=pe_i0[11] I2=pe_i0[15] I3=pe_i0[12]
XU964 OA12 $PINS O=N277 A1=pe_i0[16] B1=n391 B2=n390
XU965 NR2 $PINS O=n393 I1=pe_i0[12] I2=pe_i0[11]
XU966 NR3 $PINS O=n392 I1=pe_i0[13] I2=pe_i0[15] I3=pe_i0[14]
XU967 AOI13HS $PINS O=N276 A1=pe_i0[16] B1=n393 B2=n394 B3=n392
XU968 ND3 $PINS O=n396 I1=pe_r3[13] I2=pe_r3[10] I3=pe_r3[14]
XU969 ND3 $PINS O=n395 I1=pe_r3[11] I2=pe_r3[15] I3=pe_r3[12]
XU970 OA12 $PINS O=N142 A1=pe_r3[16] B1=n396 B2=n395
XU971 NR2 $PINS O=n398 I1=pe_r3[12] I2=pe_r3[11]
XU972 NR3 $PINS O=n397 I1=pe_r3[13] I2=pe_r3[15] I3=pe_r3[14]
XU973 ND3 $PINS O=n401 I1=FE_PHN1699_pe_i3_13 I2=pe_i3[10] I3=pe_i3[14]
XU974 ND3 $PINS O=n400 I1=pe_i3[11] I2=pe_i3[15] I3=FE_PHN1697_pe_i3_12
XU975 OA12 $PINS O=N127 A1=FE_PHN1582_pe_i3_16 B1=n401 B2=n400
XU976 NR2 $PINS O=n403 I1=FE_PHN1697_pe_i3_12 I2=pe_i3[11]
XU977 NR3 $PINS O=n402 I1=FE_PHN1699_pe_i3_13 I2=pe_i3[15] I3=pe_i3[14]
XU978 ND3 $PINS O=n406 I1=FE_PHN1591_pe_r2_13 I2=pe_r2[10] I3=pe_r2[14]
XU979 ND3 $PINS O=n405 I1=FE_PHN1712_pe_r2_11 I2=FE_PHN1608_pe_r2_15
+ I3=pe_r2[12]
XU980 OA12 $PINS O=N112 A1=pe_r2[16] B1=n406 B2=n405
XU981 NR2 $PINS O=n408 I1=pe_r2[12] I2=FE_PHN1712_pe_r2_11
XU982 NR3 $PINS O=n407 I1=pe_r2[13] I2=pe_r2[15] I3=pe_r2[14]
XU983 ND3 $PINS O=n411 I1=pe_i2[13] I2=pe_i2[10] I3=FE_PHN1706_pe_i2_14
XU984 ND3 $PINS O=n410 I1=pe_i2[11] I2=pe_i2[15] I3=pe_i2[12]
XU985 OA12 $PINS O=N97 A1=FE_PHN2191_pe_i2_16 B1=n411 B2=n410
XU986 NR2 $PINS O=n413 I1=pe_i2[12] I2=pe_i2[11]
XU987 NR3 $PINS O=n412 I1=pe_i2[13] I2=pe_i2[15] I3=FE_PHN1706_pe_i2_14
XU658 ND2 $PINS O=n170 I1=n434 I2=delayed_out3[14]
XU722 NR2 $PINS O=rf_d_raddr_1[4] I1=n449 I2=FE_OCPN1_n336
Xcordic0 cordic_rotation_1 $PINS rst_n=FE_UNCONNECTED_1 valid_in=c_start
+ valid_out=cordic_valid_out[0] x_in[16]=c_in_r_0[16] x_in[15]=c_in_r_0[15]
+ x_in[14]=c_in_r_0[14] x_in[13]=c_in_r_0[13] x_in[12]=FE_PHN1722_c_in_r_0_12
+ x_in[11]=c_in_r_0[11] x_in[10]=FE_PHN1724_c_in_r_0_10 x_in[9]=c_in_r_0[9]
+ x_in[8]=FE_PHN1734_c_in_r_0_8 x_in[7]=FE_PHN1733_c_in_r_0_7
+ x_in[6]=FE_PHN1741_c_in_r_0_6 x_in[5]=FE_PHN1740_c_in_r_0_5
+ x_in[4]=FE_PHN1739_c_in_r_0_4 x_in[3]=c_in_r_0[3] x_in[2]=c_in_r_0[2]
+ x_in[1]=c_in_r_0[1] x_in[0]=FE_PHN1742_c_in_r_0_0 y_in[16]=c_in_i_0[16]
+ y_in[15]=FE_PHN1718_c_in_i_0_15 y_in[14]=c_in_i_0[14] y_in[13]=c_in_i_0[13]
+ y_in[12]=c_in_i_0[12] y_in[11]=c_in_i_0[11] y_in[10]=c_in_i_0[10]
+ y_in[9]=c_in_i_0[9] y_in[8]=c_in_i_0[8] y_in[7]=c_in_i_0[7] y_in[6]=c_in_i_0[6]
+ y_in[5]=c_in_i_0[5] y_in[4]=c_in_i_0[4] y_in[3]=FE_PHN1750_c_in_i_0_3
+ y_in[2]=FE_PHN1756_c_in_i_0_2 y_in[1]=c_in_i_0[1] y_in[0]=FE_PHN2130_c_in_i_0_0
+ phase_in[15]=phase_0[15] phase_in[14]=phase_0[14] phase_in[13]=phase_0[13]
+ phase_in[12]=phase_0[12] phase_in[11]=phase_0[11] phase_in[10]=phase_0[10]
+ phase_in[9]=phase_0[9] phase_in[8]=n464 phase_in[7]=n464 phase_in[6]=n464
+ phase_in[5]=n464 phase_in[4]=n464 phase_in[3]=n464 phase_in[2]=n464
+ phase_in[1]=n464 phase_in[0]=n464 x_out[16]=cor_x_out[0][16]
+ x_out[15]=cor_x_out[0][15] x_out[14]=cor_x_out[0][14]
+ x_out[13]=cor_x_out[0][13] x_out[12]=cor_x_out[0][12]
+ x_out[11]=cor_x_out[0][11] x_out[10]=cor_x_out[0][10] x_out[9]=cor_x_out[0][9]
+ x_out[8]=cor_x_out[0][8] x_out[7]=cor_x_out[0][7] x_out[6]=cor_x_out[0][6]
+ x_out[5]=cor_x_out[0][5] x_out[4]=cor_x_out[0][4] x_out[3]=cor_x_out[0][3]
+ x_out[2]=cor_x_out[0][2] x_out[1]=cor_x_out[0][1] x_out[0]=cor_x_out[0][0]
+ y_out[16]=cor_y_out[0][16] y_out[15]=cor_y_out[0][15]
+ y_out[14]=cor_y_out[0][14] y_out[13]=cor_y_out[0][13]
+ y_out[12]=cor_y_out[0][12] y_out[11]=cor_y_out[0][11]
+ y_out[10]=cor_y_out[0][10] y_out[9]=cor_y_out[0][9] y_out[8]=cor_y_out[0][8]
+ y_out[7]=cor_y_out[0][7] y_out[6]=cor_y_out[0][6] y_out[5]=cor_y_out[0][5]
+ y_out[4]=cor_y_out[0][4] y_out[3]=cor_y_out[0][3] y_out[2]=cor_y_out[0][2]
+ y_out[1]=cor_y_out[0][1] y_out[0]=cor_y_out[0][0] i_rst_n=rst_n
+ p1=FE_DBTN7_phase_0_9 FE_OFN50_i_rst_n=FE_OFN26_i_rst_n
+ FE_OFN28_i_rst_n=FE_OFN14_i_rst_n FE_OFN25_i_rst_n=FE_OFN13_i_rst_n
+ FE_OFN19_i_rst_n=FE_OFN11_i_rst_n FE_OFN18_i_rst_n=FE_OFN10_i_rst_n
+ FE_OFN12_i_rst_n=FE_OFN8_i_rst_n FE_OFN5_i_rst_n=FE_OFN3_i_rst_n
+ FE_OFN4_i_rst_n=FE_OFN2_i_rst_n FE_OFN3_i_rst_n=FE_OFN1_i_rst_n
+ clk_clone3=CTS_137 clk_clone2=CTS_181 clk=CTS_146 clk_clone4=CTS_136
+ clk_clone1=CTS_148
Xcordic1 cordic_rotation_0 $PINS rst_n=FE_OFN2_i_rst_n valid_in=c_start
+ valid_out=cordic_valid_out[1] x_in[16]=FE_PHN1413_c_in_r_1_16
+ x_in[15]=FE_PHN1675_c_in_r_1_15 x_in[14]=FE_PHN1701_c_in_r_1_14
+ x_in[13]=FE_PHN1700_c_in_r_1_13 x_in[12]=FE_PHN1719_c_in_r_1_12
+ x_in[11]=FE_PHN1727_c_in_r_1_11 x_in[10]=c_in_r_1[10] x_in[9]=c_in_r_1[9]
+ x_in[8]=c_in_r_1[8] x_in[7]=c_in_r_1[7] x_in[6]=c_in_r_1[6] x_in[5]=c_in_r_1[5]
+ x_in[4]=c_in_r_1[4] x_in[3]=c_in_r_1[3] x_in[2]=c_in_r_1[2]
+ x_in[1]=FE_PHN1730_c_in_r_1_1 x_in[0]=FE_PHN1709_c_in_r_1_0
+ y_in[16]=c_in_i_1[16] y_in[15]=FE_PHN1746_c_in_i_1_15 y_in[14]=c_in_i_1[14]
+ y_in[13]=c_in_i_1[13] y_in[12]=c_in_i_1[12] y_in[11]=c_in_i_1[11]
+ y_in[10]=c_in_i_1[10] y_in[9]=c_in_i_1[9] y_in[8]=c_in_i_1[8]
+ y_in[7]=c_in_i_1[7] y_in[6]=c_in_i_1[6] y_in[5]=c_in_i_1[5] y_in[4]=c_in_i_1[4]
+ y_in[3]=c_in_i_1[3] y_in[2]=c_in_i_1[2] y_in[1]=c_in_i_1[1] y_in[0]=c_in_i_1[0]
+ phase_in[15]=phase_1[15] phase_in[14]=phase_1[14] phase_in[13]=phase_1[13]
+ phase_in[12]=phase_1[12] phase_in[11]=phase_1[11] phase_in[10]=phase_1[10]
+ phase_in[9]=phase_1[9] phase_in[8]=phase_1[8] phase_in[7]=n464 phase_in[6]=n464
+ phase_in[5]=n464 phase_in[4]=n464 phase_in[3]=n464 phase_in[2]=n464
+ phase_in[1]=n464 phase_in[0]=n464 x_out[16]=cor_x_out[1][16]
+ x_out[15]=cor_x_out[1][15] x_out[14]=cor_x_out[1][14]
+ x_out[13]=cor_x_out[1][13] x_out[12]=cor_x_out[1][12]
+ x_out[11]=cor_x_out[1][11] x_out[10]=cor_x_out[1][10] x_out[9]=cor_x_out[1][9]
+ x_out[8]=cor_x_out[1][8] x_out[7]=cor_x_out[1][7] x_out[6]=cor_x_out[1][6]
+ x_out[5]=cor_x_out[1][5] x_out[4]=cor_x_out[1][4] x_out[3]=cor_x_out[1][3]
+ x_out[2]=cor_x_out[1][2] x_out[1]=cor_x_out[1][1] x_out[0]=cor_x_out[1][0]
+ y_out[16]=cor_y_out[1][16] y_out[15]=cor_y_out[1][15]
+ y_out[14]=cor_y_out[1][14] y_out[13]=cor_y_out[1][13]
+ y_out[12]=cor_y_out[1][12] y_out[11]=cor_y_out[1][11]
+ y_out[10]=cor_y_out[1][10] y_out[9]=cor_y_out[1][9] y_out[8]=cor_y_out[1][8]
+ y_out[7]=cor_y_out[1][7] y_out[6]=cor_y_out[1][6] y_out[5]=cor_y_out[1][5]
+ y_out[4]=cor_y_out[1][4] y_out[3]=cor_y_out[1][3] y_out[2]=cor_y_out[1][2]
+ y_out[1]=cor_y_out[1][1] y_out[0]=cor_y_out[1][0] p1=FE_DBTN8_phase_1_8
+ FE_OFN51_i_rst_n=FE_OFN26_i_rst_n FE_OFN27_i_rst_n=FE_OFN14_i_rst_n
+ FE_OFN26_i_rst_n=FE_OFN13_i_rst_n FE_OFN21_i_rst_n=FE_OFN12_i_rst_n
+ FE_OFN7_i_rst_n=FE_OFN3_i_rst_n clk_clone2=CTS_181 clk=CTS_146
+ clk_clone4=CTS_136 clk_clone3=CTS_137 clk_clone1=CTS_148
Xmac DFrFT_MAC $PINS rst_n=FE_UNCONNECTED_1 en=n90 pe_clear=pe_clear_d1
+ pe_done=FE_PHN2044_pe_done_d2 g_cnt[2]=FE_DBTN3_current_g_2
+ g_cnt[1]=FE_DBTN4_current_g_1 g_cnt[0]=FE_DBTN5_current_g_0 n_cnt[5]=n464
+ n_cnt[4]=current_n[4] n_cnt[3]=current_n[3] n_cnt[2]=current_n[2]
+ n_cnt[1]=FE_DBTN6_current_n_1 n_cnt[0]=FE_DBTN13_current_n_0
+ data_in_r[16]=mac_in_real[16] data_in_r[15]=mac_in_real[15]
+ data_in_r[14]=mac_in_real[14] data_in_r[13]=mac_in_real[13]
+ data_in_r[12]=mac_in_real[12] data_in_r[11]=mac_in_real[11]
+ data_in_r[10]=mac_in_real[10] data_in_r[9]=mac_in_real[9]
+ data_in_r[8]=mac_in_real[8] data_in_r[7]=mac_in_real[7]
+ data_in_r[6]=mac_in_real[6] data_in_r[5]=mac_in_real[5]
+ data_in_r[4]=mac_in_real[4] data_in_r[3]=mac_in_real[3]
+ data_in_r[2]=mac_in_real[2] data_in_r[1]=mac_in_real[1]
+ data_in_r[0]=mac_in_real[0] data_in_i[16]=mac_in_imag[16]
+ data_in_i[15]=mac_in_imag[15] data_in_i[14]=mac_in_imag[14]
+ data_in_i[13]=mac_in_imag[13] data_in_i[12]=mac_in_imag[12]
+ data_in_i[11]=mac_in_imag[11] data_in_i[10]=mac_in_imag[10]
+ data_in_i[9]=mac_in_imag[9] data_in_i[8]=mac_in_imag[8]
+ data_in_i[7]=mac_in_imag[7] data_in_i[6]=mac_in_imag[6]
+ data_in_i[5]=mac_in_imag[5] data_in_i[4]=mac_in_imag[4]
+ data_in_i[3]=mac_in_imag[3] data_in_i[2]=mac_in_imag[2]
+ data_in_i[1]=mac_in_imag[1] data_in_i[0]=mac_in_imag[0] y_out_0_r[16]=pe_r0[16]
+ y_out_0_r[15]=pe_r0[15] y_out_0_r[14]=pe_r0[14] y_out_0_r[13]=pe_r0[13]
+ y_out_0_r[12]=pe_r0[12] y_out_0_r[11]=pe_r0[11] y_out_0_r[10]=pe_r0[10]
+ y_out_0_r[9]=pe_r0[9] y_out_0_r[8]=pe_r0[8] y_out_0_r[7]=pe_r0[7]
+ y_out_0_r[6]=pe_r0[6] y_out_0_r[5]=pe_r0[5] y_out_0_r[4]=pe_r0[4]
+ y_out_0_r[3]=pe_r0[3] y_out_0_r[2]=pe_r0[2] y_out_0_r[1]=pe_r0[1]
+ y_out_0_r[0]=pe_r0[0] y_out_0_i[16]=pe_i0[16] y_out_0_i[15]=pe_i0[15]
+ y_out_0_i[14]=pe_i0[14] y_out_0_i[13]=pe_i0[13] y_out_0_i[12]=pe_i0[12]
+ y_out_0_i[11]=pe_i0[11] y_out_0_i[10]=pe_i0[10] y_out_0_i[9]=pe_i0[9]
+ y_out_0_i[8]=pe_i0[8] y_out_0_i[7]=pe_i0[7] y_out_0_i[6]=pe_i0[6]
+ y_out_0_i[5]=pe_i0[5] y_out_0_i[4]=pe_i0[4] y_out_0_i[3]=pe_i0[3]
+ y_out_0_i[2]=pe_i0[2] y_out_0_i[1]=pe_i0[1] y_out_0_i[0]=pe_i0[0]
+ y_out_1_r[16]=pe_r1[16] y_out_1_r[15]=pe_r1[15] y_out_1_r[14]=pe_r1[14]
+ y_out_1_r[13]=pe_r1[13] y_out_1_r[12]=pe_r1[12] y_out_1_r[11]=pe_r1[11]
+ y_out_1_r[10]=pe_r1[10] y_out_1_r[9]=pe_r1[9] y_out_1_r[8]=pe_r1[8]
+ y_out_1_r[7]=pe_r1[7] y_out_1_r[6]=pe_r1[6] y_out_1_r[5]=pe_r1[5]
+ y_out_1_r[4]=pe_r1[4] y_out_1_r[3]=pe_r1[3] y_out_1_r[2]=pe_r1[2]
+ y_out_1_r[1]=pe_r1[1] y_out_1_r[0]=pe_r1[0] y_out_1_i[16]=pe_i1[16]
+ y_out_1_i[15]=pe_i1[15] y_out_1_i[14]=pe_i1[14] y_out_1_i[13]=pe_i1[13]
+ y_out_1_i[12]=pe_i1[12] y_out_1_i[11]=pe_i1[11] y_out_1_i[10]=pe_i1[10]
+ y_out_1_i[9]=pe_i1[9] y_out_1_i[8]=pe_i1[8] y_out_1_i[7]=pe_i1[7]
+ y_out_1_i[6]=pe_i1[6] y_out_1_i[5]=pe_i1[5] y_out_1_i[4]=pe_i1[4]
+ y_out_1_i[3]=pe_i1[3] y_out_1_i[2]=pe_i1[2] y_out_1_i[1]=pe_i1[1]
+ y_out_1_i[0]=pe_i1[0] y_out_2_r[16]=pe_r2[16] y_out_2_r[15]=pe_r2[15]
+ y_out_2_r[14]=pe_r2[14] y_out_2_r[13]=pe_r2[13] y_out_2_r[12]=pe_r2[12]
+ y_out_2_r[11]=pe_r2[11] y_out_2_r[10]=pe_r2[10] y_out_2_r[9]=pe_r2[9]
+ y_out_2_r[8]=pe_r2[8] y_out_2_r[7]=pe_r2[7] y_out_2_r[6]=pe_r2[6]
+ y_out_2_r[5]=pe_r2[5] y_out_2_r[4]=pe_r2[4] y_out_2_r[3]=pe_r2[3]
+ y_out_2_r[2]=pe_r2[2] y_out_2_r[1]=pe_r2[1] y_out_2_r[0]=pe_r2[0]
+ y_out_2_i[16]=pe_i2[16] y_out_2_i[15]=pe_i2[15] y_out_2_i[14]=pe_i2[14]
+ y_out_2_i[13]=pe_i2[13] y_out_2_i[12]=pe_i2[12] y_out_2_i[11]=pe_i2[11]
+ y_out_2_i[10]=pe_i2[10] y_out_2_i[9]=pe_i2[9] y_out_2_i[8]=pe_i2[8]
+ y_out_2_i[7]=pe_i2[7] y_out_2_i[6]=pe_i2[6] y_out_2_i[5]=pe_i2[5]
+ y_out_2_i[4]=pe_i2[4] y_out_2_i[3]=pe_i2[3] y_out_2_i[2]=pe_i2[2]
+ y_out_2_i[1]=pe_i2[1] y_out_2_i[0]=pe_i2[0] y_out_3_r[16]=pe_r3[16]
+ y_out_3_r[15]=pe_r3[15] y_out_3_r[14]=pe_r3[14] y_out_3_r[13]=pe_r3[13]
+ y_out_3_r[12]=pe_r3[12] y_out_3_r[11]=pe_r3[11] y_out_3_r[10]=pe_r3[10]
+ y_out_3_r[9]=pe_r3[9] y_out_3_r[8]=pe_r3[8] y_out_3_r[7]=pe_r3[7]
+ y_out_3_r[6]=pe_r3[6] y_out_3_r[5]=pe_r3[5] y_out_3_r[4]=pe_r3[4]
+ y_out_3_r[3]=pe_r3[3] y_out_3_r[2]=pe_r3[2] y_out_3_r[1]=pe_r3[1]
+ y_out_3_r[0]=pe_r3[0] y_out_3_i[16]=pe_i3[16] y_out_3_i[15]=pe_i3[15]
+ y_out_3_i[14]=pe_i3[14] y_out_3_i[13]=pe_i3[13] y_out_3_i[12]=pe_i3[12]
+ y_out_3_i[11]=pe_i3[11] y_out_3_i[10]=pe_i3[10] y_out_3_i[9]=pe_i3[9]
+ y_out_3_i[8]=pe_i3[8] y_out_3_i[7]=pe_i3[7] y_out_3_i[6]=pe_i3[6]
+ y_out_3_i[5]=pe_i3[5] y_out_3_i[4]=pe_i3[4] y_out_3_i[3]=pe_i3[3]
+ y_out_3_i[2]=pe_i3[2] y_out_3_i[1]=pe_i3[1] y_out_3_i[0]=pe_i3[0]
+ stage_sel_BAR=n336 i_rst_n=rst_n p1=FE_DBTN9_n336
+ FE_OFN45_i_rst_n=FE_OFN24_i_rst_n FE_OFN41_i_rst_n=FE_OFN21_i_rst_n
+ FE_OFN39_i_rst_n=FE_OFN20_i_rst_n FE_OFN32_i_rst_n=FE_OFN16_i_rst_n
+ FE_OFN23_i_rst_n=FE_OFN12_i_rst_n FE_OFN16_i_rst_n=FE_OFN10_i_rst_n
+ FE_OFN11_i_rst_n=FE_OFN6_i_rst_n FE_OFN8_i_rst_n=FE_OFN4_i_rst_n
+ FE_OFN2_i_rst_n=FE_OFN1_i_rst_n FE_OFN0_i_rst_n=FE_OFN0_i_rst_n
+ FE_OFN62_FE_DBTN9_n336=FE_OFN33_FE_DBTN9_n336
+ FE_OFN58_FE_DBTN9_n336=FE_OFN30_FE_DBTN9_n336
+ FE_OFN56_FE_DBTN9_n336=FE_OFN28_FE_DBTN9_n336 clk_clone9=CTS_136
+ clk_clone6=CTS_141 clk_clone5=CTS_142 clk_clone7=CTS_144 clk_clone4=CTS_145
+ clk_clone3=CTS_146 clk_clone2=CTS_149 clk_clone8=CTS_151 clk_clone1=CTS_173
+ clk=CTS_175
Xrf_data RegFileDual_DATA_WIDTH34 $PINS rst_n=FE_UNCONNECTED_1
+ read_addr_1[4]=rf_d_raddr_1[4] read_addr_1[3]=rf_d_raddr_1[3]
+ read_addr_1[2]=rf_d_raddr_1[2] read_addr_1[1]=rf_d_raddr_1[1]
+ read_addr_1[0]=rf_d_raddr_1[0] read_data_1[33]=rf_d_rdata_1[33]
+ read_data_1[32]=rf_d_rdata_1[32] read_data_1[31]=rf_d_rdata_1[31]
+ read_data_1[30]=rf_d_rdata_1[30] read_data_1[29]=rf_d_rdata_1[29]
+ read_data_1[28]=rf_d_rdata_1[28] read_data_1[27]=rf_d_rdata_1[27]
+ read_data_1[26]=rf_d_rdata_1[26] read_data_1[25]=rf_d_rdata_1[25]
+ read_data_1[24]=rf_d_rdata_1[24] read_data_1[23]=rf_d_rdata_1[23]
+ read_data_1[22]=rf_d_rdata_1[22] read_data_1[21]=rf_d_rdata_1[21]
+ read_data_1[20]=rf_d_rdata_1[20] read_data_1[19]=rf_d_rdata_1[19]
+ read_data_1[18]=rf_d_rdata_1[18] read_data_1[17]=rf_d_rdata_1[17]
+ read_data_1[16]=rf_d_rdata_1[16] read_data_1[15]=rf_d_rdata_1[15]
+ read_data_1[14]=rf_d_rdata_1[14] read_data_1[13]=rf_d_rdata_1[13]
+ read_data_1[12]=rf_d_rdata_1[12] read_data_1[11]=rf_d_rdata_1[11]
+ read_data_1[10]=rf_d_rdata_1[10] read_data_1[9]=rf_d_rdata_1[9]
+ read_data_1[8]=rf_d_rdata_1[8] read_data_1[7]=rf_d_rdata_1[7]
+ read_data_1[6]=rf_d_rdata_1[6] read_data_1[5]=rf_d_rdata_1[5]
+ read_data_1[4]=rf_d_rdata_1[4] read_data_1[3]=rf_d_rdata_1[3]
+ read_data_1[2]=rf_d_rdata_1[2] read_data_1[1]=rf_d_rdata_1[1]
+ read_data_1[0]=rf_d_rdata_1[0] wen1=cordic_valid_out[0]
+ wen2=cordic_valid_out[1] write_addr_1[4]=c_group_idx[2]
+ write_addr_1[3]=c_group_idx[1] write_addr_1[2]=c_group_idx[0]
+ write_addr_1[1]=FE_DBTN11_n257 write_addr_1[0]=n464
+ write_addr_2[4]=c_group_idx[2] write_addr_2[3]=c_group_idx[1]
+ write_addr_2[2]=n464 write_addr_2[1]=n464 write_addr_2[0]=*Logic1*
+ write_data_1[33]=cor_y_out[0][16] write_data_1[32]=cor_y_out[0][15]
+ write_data_1[31]=cor_y_out[0][14] write_data_1[30]=cor_y_out[0][13]
+ write_data_1[29]=cor_y_out[0][12] write_data_1[28]=FE_PHN1569_cor_y_out_0_11
+ write_data_1[27]=cor_y_out[0][10] write_data_1[26]=cor_y_out[0][9]
+ write_data_1[25]=cor_y_out[0][8] write_data_1[24]=cor_y_out[0][7]
+ write_data_1[23]=FE_PHN1609_cor_y_out_0_6 write_data_1[22]=cor_y_out[0][5]
+ write_data_1[21]=FE_PHN1564_cor_y_out_0_4 write_data_1[20]=cor_y_out[0][3]
+ write_data_1[19]=cor_y_out[0][2] write_data_1[18]=FE_PHN1588_cor_y_out_0_1
+ write_data_1[17]=cor_y_out[0][0] write_data_1[16]=cor_x_out[0][16]
+ write_data_1[15]=cor_x_out[0][15] write_data_1[14]=cor_x_out[0][14]
+ write_data_1[13]=cor_x_out[0][13] write_data_1[12]=cor_x_out[0][12]
+ write_data_1[11]=cor_x_out[0][11] write_data_1[10]=cor_x_out[0][10]
+ write_data_1[9]=cor_x_out[0][9] write_data_1[8]=cor_x_out[0][8]
+ write_data_1[7]=cor_x_out[0][7] write_data_1[6]=cor_x_out[0][6]
+ write_data_1[5]=cor_x_out[0][5] write_data_1[4]=cor_x_out[0][4]
+ write_data_1[3]=cor_x_out[0][3] write_data_1[2]=cor_x_out[0][2]
+ write_data_1[1]=cor_x_out[0][1] write_data_1[0]=cor_x_out[0][0]
+ write_data_2[33]=cor_y_out[1][16] write_data_2[32]=cor_y_out[1][15]
+ write_data_2[31]=cor_y_out[1][14] write_data_2[30]=cor_y_out[1][13]
+ write_data_2[29]=cor_y_out[1][12] write_data_2[28]=cor_y_out[1][11]
+ write_data_2[27]=cor_y_out[1][10] write_data_2[26]=cor_y_out[1][9]
+ write_data_2[25]=cor_y_out[1][8] write_data_2[24]=cor_y_out[1][7]
+ write_data_2[23]=FE_PHN1581_cor_y_out_1_6 write_data_2[22]=cor_y_out[1][5]
+ write_data_2[21]=cor_y_out[1][4] write_data_2[20]=cor_y_out[1][3]
+ write_data_2[19]=FE_PHN1579_cor_y_out_1_2 write_data_2[18]=cor_y_out[1][1]
+ write_data_2[17]=cor_y_out[1][0] write_data_2[16]=cor_x_out[1][16]
+ write_data_2[15]=cor_x_out[1][15] write_data_2[14]=cor_x_out[1][14]
+ write_data_2[13]=FE_PHN1504_cor_x_out_1_13 write_data_2[12]=cor_x_out[1][12]
+ write_data_2[11]=FE_PHN1584_cor_x_out_1_11
+ write_data_2[10]=FE_PHN1604_cor_x_out_1_10 write_data_2[9]=cor_x_out[1][9]
+ write_data_2[8]=cor_x_out[1][8] write_data_2[7]=cor_x_out[1][7]
+ write_data_2[6]=cor_x_out[1][6] write_data_2[5]=FE_PHN1596_cor_x_out_1_5
+ write_data_2[4]=cor_x_out[1][4] write_data_2[3]=cor_x_out[1][3]
+ write_data_2[2]=FE_PHN1546_cor_x_out_1_2
+ write_data_2[1]=FE_PHN1543_cor_x_out_1_1 write_data_2[0]=cor_x_out[1][0]
+ p_1=n257 i_rst_n=FE_OFN2_i_rst_n p1=FE_DBTN0_c_group_idx_0
+ p2=FE_DBTN1_c_group_idx_1 p3=FE_DBTN2_c_group_idx_2
+ FE_OFN49_i_rst_n=FE_OFN26_i_rst_n FE_OFN22_i_rst_n=FE_OFN12_i_rst_n
+ FE_OFN20_i_rst_n=FE_OFN11_i_rst_n FE_OFN6_i_rst_n=FE_OFN3_i_rst_n
+ clk_clone4=CTS_137 clk_clone2=CTS_140 clk_clone1=CTS_142 clk=CTS_146
+ clk_clone3=CTS_181
Xrf_io RegFileDual_DATA_WIDTH22 $PINS rst_n=FE_UNCONNECTED_1
+ read_addr_1[4]=rf_io_raddr_1[4] read_addr_1[3]=rf_io_raddr_1[3]
+ read_addr_1[2]=rf_io_raddr_1[2] read_addr_1[1]=rf_io_raddr_1[1]
+ read_addr_1[0]=rf_io_raddr_1[0] read_data_1[21]=mac_in_imag_s1_16
+ read_data_1[20]=mac_in_imag_s1[9] read_data_1[19]=mac_in_imag_s1[8]
+ read_data_1[18]=mac_in_imag_s1[7] read_data_1[17]=mac_in_imag_s1[6]
+ read_data_1[16]=mac_in_imag_s1[5] read_data_1[15]=mac_in_imag_s1[4]
+ read_data_1[14]=mac_in_imag_s1[3] read_data_1[13]=mac_in_imag_s1[2]
+ read_data_1[12]=mac_in_imag_s1[1] read_data_1[11]=mac_in_imag_s1[0]
+ read_data_1[10]=mac_in_real_s1_16 read_data_1[9]=mac_in_real_s1[9]
+ read_data_1[8]=mac_in_real_s1[8] read_data_1[7]=mac_in_real_s1[7]
+ read_data_1[6]=mac_in_real_s1[6] read_data_1[5]=mac_in_real_s1[5]
+ read_data_1[4]=mac_in_real_s1[4] read_data_1[3]=mac_in_real_s1[3]
+ read_data_1[2]=mac_in_real_s1[2] read_data_1[1]=mac_in_real_s1[1]
+ read_data_1[0]=mac_in_real_s1[0] wen1=rf_io_wen_1 wen2=rf_io_wen_2
+ write_addr_1[4]=rf_io_waddr_1[4] write_addr_1[3]=rf_io_waddr_1[3]
+ write_addr_1[2]=rf_io_waddr_1[2] write_addr_1[1]=rf_io_waddr_1[1]
+ write_addr_1[0]=rf_io_waddr_1[0] write_addr_2[4]=rf_io_waddr_2[4]
+ write_addr_2[3]=rf_io_waddr_2[3] write_addr_2[2]=rf_io_waddr_2[2]
+ write_addr_2[1]=n434 write_addr_2[0]=rf_io_wen_2
+ write_data_1[21]=rf_io_wdata_1[21] write_data_1[20]=rf_io_wdata_1[20]
+ write_data_1[19]=rf_io_wdata_1[19] write_data_1[18]=rf_io_wdata_1[18]
+ write_data_1[17]=rf_io_wdata_1[17] write_data_1[16]=rf_io_wdata_1[16]
+ write_data_1[15]=rf_io_wdata_1[15] write_data_1[14]=rf_io_wdata_1[14]
+ write_data_1[13]=rf_io_wdata_1[13] write_data_1[12]=rf_io_wdata_1[12]
+ write_data_1[11]=rf_io_wdata_1[11] write_data_1[10]=rf_io_wdata_1[10]
+ write_data_1[9]=rf_io_wdata_1[9] write_data_1[8]=rf_io_wdata_1[8]
+ write_data_1[7]=rf_io_wdata_1[7] write_data_1[6]=rf_io_wdata_1[6]
+ write_data_1[5]=rf_io_wdata_1[5] write_data_1[4]=rf_io_wdata_1[4]
+ write_data_1[3]=rf_io_wdata_1[3] write_data_1[2]=rf_io_wdata_1[2]
+ write_data_1[1]=rf_io_wdata_1[1] write_data_1[0]=rf_io_wdata_1[0]
+ write_data_2[21]=rf_io_wdata_2[21] write_data_2[20]=rf_io_wdata_2[20]
+ write_data_2[19]=rf_io_wdata_2[19] write_data_2[18]=rf_io_wdata_2[18]
+ write_data_2[17]=rf_io_wdata_2[17] write_data_2[16]=rf_io_wdata_2[16]
+ write_data_2[15]=rf_io_wdata_2[15] write_data_2[14]=rf_io_wdata_2[14]
+ write_data_2[13]=rf_io_wdata_2[13] write_data_2[12]=rf_io_wdata_2[12]
+ write_data_2[11]=rf_io_wdata_2[11] write_data_2[10]=rf_io_wdata_2[10]
+ write_data_2[9]=rf_io_wdata_2[9] write_data_2[8]=rf_io_wdata_2[8]
+ write_data_2[7]=rf_io_wdata_2[7] write_data_2[6]=rf_io_wdata_2[6]
+ write_data_2[5]=rf_io_wdata_2[5] write_data_2[4]=rf_io_wdata_2[4]
+ write_data_2[3]=rf_io_wdata_2[3] write_data_2[2]=rf_io_wdata_2[2]
+ write_data_2[1]=rf_io_wdata_2[1] write_data_2[0]=rf_io_wdata_2[0] p_1=n231
+ i_rst_n=FE_OFN24_i_rst_n clk_clone2=CTS_145 clk_clone1=CTS_175 clk=CTS_176
Xclk_gate_g_cnt_d2_reg SNPS_CLOCK_GATE_HIGH_CHIP_0 $PINS EN=n90 ENCLK=net1650
+ CLK=CTS_149
Xclk_gate_c_buf_i_reg[0] SNPS_CLOCK_GATE_HIGH_CHIP_11 $PINS EN=N69
+ ENCLK=CTS_172 CLK=CTS_173
Xclk_gate_c_buf_i_reg[1] SNPS_CLOCK_GATE_HIGH_CHIP_10 $PINS EN=N69
+ ENCLK=CTS_169 CLK=CTS_173
Xclk_gate_c_buf_i_reg[3] SNPS_CLOCK_GATE_HIGH_CHIP_9 $PINS EN=N69 ENCLK=CTS_166
+ CLK=CTS_173
Xclk_gate_c_buf_r_reg[0] SNPS_CLOCK_GATE_HIGH_CHIP_8 $PINS EN=N69 ENCLK=CTS_163
+ CLK=CTS_173
Xclk_gate_c_buf_r_reg[2] SNPS_CLOCK_GATE_HIGH_CHIP_7 $PINS EN=N69 ENCLK=CTS_160
+ CLK=CTS_173
Xclk_gate_delayed_mac_group_reg SNPS_CLOCK_GATE_HIGH_CHIP_6 $PINS EN=N157
+ ENCLK=CTS_157 CLK=CTS_173
Xclk_gate_delayed_out2_reg SNPS_CLOCK_GATE_HIGH_CHIP_5 $PINS EN=N157
+ ENCLK=CTS_154 CLK=CTS_173
Xclk_gate_o_counter_r_reg SNPS_CLOCK_GATE_HIGH_CHIP_4 $PINS EN=N462
+ ENCLK=net1690 CLK=CTS_149
Xclk_gate_key_r_reg SNPS_CLOCK_GATE_HIGH_CHIP_3 $PINS EN=N468 ENCLK=net1695
+ CLK=CTS_149
Xclk_gate_counter_r_reg SNPS_CLOCK_GATE_HIGH_CHIP_2 $PINS EN=N475 ENCLK=net1700
+ CLK=CTS_149
Xclk_gate_real_hold_reg_reg SNPS_CLOCK_GATE_HIGH_CHIP_1 $PINS EN=n442
+ ENCLK=net1705 CLK=CTS_144
Xr165 CHIP_DW01_inc_1_DW01_inc_3 $PINS A[8]=FE_PHN1720_counter_r_8
+ A[7]=current_g[2] A[6]=FE_PHN1802_current_g_1 A[5]=current_g[0]
+ A[4]=FE_PHN1793_current_n_4 A[3]=FE_PHN1792_current_n_3
+ A[2]=FE_PHN1790_current_n_2 A[1]=current_n[1] A[0]=FE_PHN1800_current_n_0
+ SUM[8]=N220 SUM[7]=N219 SUM[6]=N218 SUM[5]=N217 SUM[4]=N216 SUM[3]=N215
+ SUM[2]=N214 SUM[1]=N213 SUM[0]=FE_UNCONNECTED_2
Xmult_149 CHIP_DW02_mult_1 $PINS A[5]=n460 A[4]=k_ord_1[4] A[3]=k_ord_1[3]
+ A[2]=k_ord_1[2] A[1]=k_ord_1[1] A[0]=k_ord_1[0] B[7]=key_r[7] B[6]=key_r[6]
+ B[5]=key_r[5] B[4]=key_r[4] B[3]=key_r[3] B[2]=key_r[2] B[1]=key_r[1]
+ B[0]=key_r[0] TC=n464 PRODUCT[13]=SYNOPSYS_UNCONNECTED__0
+ PRODUCT[12]=SYNOPSYS_UNCONNECTED__1 PRODUCT[11]=SYNOPSYS_UNCONNECTED__2
+ PRODUCT[10]=SYNOPSYS_UNCONNECTED__3 PRODUCT[9]=SYNOPSYS_UNCONNECTED__4
+ PRODUCT[8]=SYNOPSYS_UNCONNECTED__5 PRODUCT[7]=N91 PRODUCT[6]=N90 PRODUCT[5]=N89
+ PRODUCT[4]=N88 PRODUCT[3]=N87 PRODUCT[2]=N86 PRODUCT[1]=N85
+ PRODUCT[0]=phase_1[8]
Xmult_148 CHIP_DW02_mult_0 $PINS A[7]=key_r[7] A[6]=key_r[6] A[5]=key_r[5]
+ A[4]=key_r[4] A[3]=key_r[3] A[2]=key_r[2] A[1]=key_r[1] A[0]=key_r[0]
+ B[4]=FE_DBTN2_c_group_idx_2 B[3]=FE_DBTN1_c_group_idx_1
+ B[2]=FE_DBTN0_c_group_idx_0 B[1]=FE_DBTN11_n257 B[0]=n464 TC=n464
+ PRODUCT[12]=SYNOPSYS_UNCONNECTED__6 PRODUCT[11]=SYNOPSYS_UNCONNECTED__7
+ PRODUCT[10]=SYNOPSYS_UNCONNECTED__8 PRODUCT[9]=SYNOPSYS_UNCONNECTED__9
+ PRODUCT[8]=SYNOPSYS_UNCONNECTED__10 PRODUCT[7]=N83 PRODUCT[6]=N82
+ PRODUCT[5]=N81 PRODUCT[4]=N80 PRODUCT[3]=N79 PRODUCT[2]=N78
+ PRODUCT[1]=phase_0[9] PRODUCT[0]=SYNOPSYS_UNCONNECTED__11 n257=n257
.ENDS

.SUBCKT CHIP clk rst_n i_valid i_ready o_ready o_valid i_data[10] i_data[9]
+ i_data[8] i_data[7] i_data[6] i_data[5] i_data[4] i_data[3] i_data[2]
+ i_data[1] i_data[0] o_data[10] o_data[9] o_data[8] o_data[7] o_data[6]
+ o_data[5] o_data[4] o_data[3] o_data[2] o_data[1] o_data[0]
XFE_OFC37_i_o_data_10 BUF1 $PINS O=FE_OFN37_i_o_data_10 I=i_o_data[10]
XFE_OFC36_n_logic0 BUF2CK $PINS O=FE_OFN36_n_logic0 I=FE_OFN34_n_logic0
XFE_OFC35_n_logic0 BUF2CK $PINS O=FE_OFN35_n_logic0 I=n_logic0
XFE_OFC34_n_logic0 BUF2CK $PINS O=FE_OFN34_n_logic0 I=n_logic0
XU_TIE0 TIE0 $PINS O=n_logic0
XU_TIE1 TIE1 $PINS O=n_logic1
Xipad_clk XMD $PINS O=i_clk I=clk PU=FE_OFN35_n_logic0 PD=FE_OFN35_n_logic0
+ SMT=FE_OFN35_n_logic0
Xipad_rst_n XMD $PINS O=i_rst_n I=rst_n PU=FE_OFN35_n_logic0
+ PD=FE_OFN35_n_logic0 SMT=FE_OFN35_n_logic0
Xipad_i_valid XMD $PINS O=i_i_valid I=i_valid PU=FE_OFN35_n_logic0
+ PD=FE_OFN35_n_logic0 SMT=FE_OFN35_n_logic0
Xipad_o_ready XMD $PINS O=i_o_ready I=o_ready PU=FE_OFN35_n_logic0
+ PD=FE_OFN35_n_logic0 SMT=FE_OFN35_n_logic0
Xipad_i_data_0 XMD $PINS O=i_i_data[0] I=i_data[0] PU=FE_OFN36_n_logic0
+ PD=FE_OFN36_n_logic0 SMT=FE_OFN36_n_logic0
Xipad_i_data_1 XMD $PINS O=i_i_data[1] I=i_data[1] PU=FE_OFN36_n_logic0
+ PD=FE_OFN36_n_logic0 SMT=FE_OFN36_n_logic0
Xipad_i_data_2 XMD $PINS O=i_i_data[2] I=i_data[2] PU=FE_OFN36_n_logic0
+ PD=FE_OFN36_n_logic0 SMT=FE_OFN36_n_logic0
Xipad_i_data_3 XMD $PINS O=i_i_data[3] I=i_data[3] PU=FE_OFN35_n_logic0
+ PD=n_logic0 SMT=FE_OFN35_n_logic0
Xipad_i_data_4 XMD $PINS O=i_i_data[4] I=i_data[4] PU=FE_OFN35_n_logic0
+ PD=FE_OFN35_n_logic0 SMT=FE_OFN35_n_logic0
Xipad_i_data_5 XMD $PINS O=i_i_data[5] I=i_data[5] PU=FE_OFN35_n_logic0
+ PD=FE_OFN35_n_logic0 SMT=FE_OFN35_n_logic0
Xipad_i_data_6 XMD $PINS O=i_i_data[6] I=i_data[6] PU=FE_OFN35_n_logic0
+ PD=FE_OFN35_n_logic0 SMT=FE_OFN35_n_logic0
Xipad_i_data_7 XMD $PINS O=i_i_data[7] I=i_data[7] PU=FE_OFN35_n_logic0
+ PD=FE_OFN35_n_logic0 SMT=FE_OFN35_n_logic0
Xipad_i_data_8 XMD $PINS O=i_i_data[8] I=i_data[8] PU=FE_OFN35_n_logic0
+ PD=FE_OFN35_n_logic0 SMT=FE_OFN35_n_logic0
Xipad_i_data_9 XMD $PINS O=i_i_data[9] I=i_data[9] PU=FE_OFN35_n_logic0
+ PD=FE_OFN35_n_logic0 SMT=FE_OFN35_n_logic0
Xipad_i_data_10 XMD $PINS O=i_i_data[10] I=i_data[10] PU=n_logic0 PD=n_logic0
+ SMT=n_logic0
Xopad_i_ready YA2GSD $PINS O=i_ready I=i_i_ready E=n_logic1 E2=n_logic0
+ E4=n_logic0 E8=n_logic0 SR=n_logic0
Xopad_o_valid YA2GSD $PINS O=o_valid I=i_o_valid E=n_logic1 E2=n_logic0
+ E4=n_logic0 E8=n_logic0 SR=n_logic0
Xopad_o_data_0 YA2GSD $PINS O=o_data[0] I=i_o_data[0] E=n_logic1 E2=n_logic0
+ E4=n_logic0 E8=n_logic0 SR=n_logic0
Xopad_o_data_1 YA2GSD $PINS O=o_data[1] I=i_o_data[1] E=n_logic1 E2=n_logic0
+ E4=n_logic0 E8=n_logic0 SR=n_logic0
Xopad_o_data_2 YA2GSD $PINS O=o_data[2] I=i_o_data[2] E=n_logic1
+ E2=FE_OFN34_n_logic0 E4=FE_OFN34_n_logic0 E8=FE_OFN34_n_logic0
+ SR=FE_OFN34_n_logic0
Xopad_o_data_3 YA2GSD $PINS O=o_data[3] I=i_o_data[3] E=n_logic1
+ E2=FE_OFN34_n_logic0 E4=FE_OFN34_n_logic0 E8=FE_OFN34_n_logic0
+ SR=FE_OFN34_n_logic0
Xopad_o_data_4 YA2GSD $PINS O=o_data[4] I=i_o_data[4] E=n_logic1
+ E2=FE_OFN34_n_logic0 E4=FE_OFN34_n_logic0 E8=FE_OFN34_n_logic0
+ SR=FE_OFN34_n_logic0
Xopad_o_data_5 YA2GSD $PINS O=o_data[5] I=i_o_data[5] E=n_logic1
+ E2=FE_OFN34_n_logic0 E4=FE_OFN34_n_logic0 E8=FE_OFN34_n_logic0
+ SR=FE_OFN34_n_logic0
Xopad_o_data_6 YA2GSD $PINS O=o_data[6] I=i_o_data[6] E=n_logic1
+ E2=FE_OFN34_n_logic0 E4=FE_OFN34_n_logic0 E8=FE_OFN34_n_logic0
+ SR=FE_OFN34_n_logic0
Xopad_o_data_7 YA2GSD $PINS O=o_data[7] I=i_o_data[7] E=n_logic1
+ E2=FE_OFN36_n_logic0 E4=FE_OFN36_n_logic0 E8=FE_OFN36_n_logic0
+ SR=FE_OFN36_n_logic0
Xopad_o_data_8 YA2GSD $PINS O=o_data[8] I=i_o_data[8] E=n_logic1
+ E2=FE_OFN36_n_logic0 E4=FE_OFN36_n_logic0 E8=FE_OFN36_n_logic0
+ SR=FE_OFN36_n_logic0
Xopad_o_data_9 YA2GSD $PINS O=o_data[9] I=i_o_data[9] E=n_logic1
+ E2=FE_OFN36_n_logic0 E4=FE_OFN36_n_logic0 E8=FE_OFN36_n_logic0
+ SR=FE_OFN36_n_logic0
Xopad_o_data_10 YA2GSD $PINS O=o_data[10] I=FE_OFN37_i_o_data_10 E=n_logic1
+ E2=FE_OFN36_n_logic0 E4=FE_OFN36_n_logic0 E8=FE_OFN36_n_logic0
+ SR=FE_OFN36_n_logic0
XU_CORE CHIP_core $PINS clk=i_clk rst_n=i_rst_n i_valid=i_i_valid
+ i_ready=i_i_ready o_ready=i_o_ready o_valid=i_o_valid i_data[10]=i_i_data[10]
+ i_data[9]=i_i_data[9] i_data[8]=i_i_data[8] i_data[7]=i_i_data[7]
+ i_data[6]=i_i_data[6] i_data[5]=i_i_data[5] i_data[4]=i_i_data[4]
+ i_data[3]=i_i_data[3] i_data[2]=i_i_data[2] i_data[1]=i_i_data[1]
+ i_data[0]=i_i_data[0] o_data[10]=i_o_data[10] o_data[9]=i_o_data[9]
+ o_data[8]=i_o_data[8] o_data[7]=i_o_data[7] o_data[6]=i_o_data[6]
+ o_data[5]=i_o_data[5] o_data[4]=i_o_data[4] o_data[3]=i_o_data[3]
+ o_data[2]=i_o_data[2] o_data[1]=i_o_data[1] o_data[0]=i_o_data[0]
.ENDS

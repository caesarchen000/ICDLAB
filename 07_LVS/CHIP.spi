$ Spice netlist generated by v2lvs
$ v2022.3_33.19    Tue Sep 6 12:09:54 PDT 2022
.INCLUDE "core.spi"
.INCLUDE "umc18_io_lvs.spi"
*.BUSDELIMITER [

.SUBCKT SNPS_CLOCK_GATE_HIGH_cordic_rotation_1_0 EN ENCLK CLK
*.CONNECT net2391 EN
XFE_PHC939_net2394 DELC $PINS O=net2394 I=FE_PHN939_net2394
Xlatch QDBHN $PINS Q=FE_PHN939_net2394 D=net2391 CKB=CLK
Xmain_gate AN2T $PINS O=ENCLK I1=net2394 I2=CLK
.ENDS

.SUBCKT SNPS_CLOCK_GATE_HIGH_cordic_rotation_1_4 EN ENCLK CLK
*.CONNECT net2391 EN
XFE_PHC948_net2394 DELC $PINS O=net2394 I=FE_PHN948_net2394
Xlatch QDBHN $PINS Q=FE_PHN948_net2394 D=net2391 CKB=CLK
Xmain_gate AN2T $PINS O=ENCLK I1=net2394 I2=CLK
.ENDS

.SUBCKT SNPS_CLOCK_GATE_HIGH_cordic_rotation_1_3 EN ENCLK CLK
*.CONNECT net2391 EN
XFE_PHC924_net2394 DELC $PINS O=FE_PHN924_net2394 I=net2394
Xlatch QDBHN $PINS Q=net2394 D=net2391 CKB=CLK
Xmain_gate AN2T $PINS O=ENCLK I1=FE_PHN924_net2394 I2=CLK
.ENDS

.SUBCKT SNPS_CLOCK_GATE_HIGH_cordic_rotation_1_2 EN ENCLK CLK
*.CONNECT net2391 EN
XFE_PHC941_net2394 DELC $PINS O=net2394 I=FE_PHN941_net2394
Xlatch QDBHN $PINS Q=FE_PHN941_net2394 D=net2391 CKB=CLK
Xmain_gate AN2T $PINS O=ENCLK I1=net2394 I2=CLK
.ENDS

.SUBCKT SNPS_CLOCK_GATE_HIGH_cordic_rotation_1_1 EN ENCLK CLK
*.CONNECT ENCLK net2390
*.CONNECT net2391 EN
XFE_PHC889_net2394 DELC $PINS O=net2394 I=FE_PHN889_net2394
Xlatch QDBHN $PINS Q=FE_PHN889_net2394 D=net2391 CKB=CLK
Xmain_gate AN2 $PINS O=net2390 I1=net2394 I2=CLK
.ENDS

.SUBCKT cordic_rotation_1_DW01_add_2_DW01_add_8 A[15] A[14] A[13] A[12] A[11]
+ A[10] A[9] A[8] A[7] A[6] A[5] A[4] A[3] A[2] A[1] A[0] B[15] B[14] B[13]
+ B[12] B[11] B[10] B[9] B[8] B[7] B[6] B[5] B[4] B[3] B[2] B[1] B[0] CI
+ SUM[15] SUM[14] SUM[13] SUM[12] SUM[11] SUM[10] SUM[9] SUM[8] SUM[7] SUM[6]
+ SUM[5] SUM[4] SUM[3] SUM[2] SUM[1] SUM[0] CO
XU1_12 FA1S $PINS S=SUM[12] CO=carry[13] A=A[12] B=B[12] CI=carry[12]
XU1_11 FA1S $PINS S=SUM[11] CO=carry[12] A=A[11] B=B[11] CI=carry[11]
XU1_5 FA1S $PINS S=SUM[5] CO=carry[6] A=A[5] B=B[5] CI=carry[5]
XU1_7 FA1S $PINS S=SUM[7] CO=carry[8] A=A[7] B=B[7] CI=carry[7]
XU1_6 FA1S $PINS S=SUM[6] CO=carry[7] A=A[6] B=B[6] CI=carry[6]
XU1_8 FA1S $PINS S=SUM[8] CO=carry[9] A=A[8] B=B[8] CI=carry[8]
XU1_9 FA1S $PINS S=SUM[9] CO=carry[10] A=A[9] B=B[9] CI=carry[9]
XU1_10 FA1S $PINS S=SUM[10] CO=carry[11] A=A[10] B=B[10] CI=carry[10]
XU1_4 FA1S $PINS S=SUM[4] CO=carry[5] A=A[4] B=B[4] CI=carry[4]
XU1_2 FA1S $PINS S=SUM[2] CO=carry[3] A=A[2] B=B[2] CI=carry[2]
XU1_3 FA1S $PINS S=SUM[3] CO=carry[4] A=A[3] B=B[3] CI=carry[3]
XU1_1 FA1S $PINS S=SUM[1] CO=carry[2] A=A[1] B=B[1] CI=n1
XU1_13 FA1S $PINS S=SUM[13] CO=carry[14] A=A[13] B=B[13] CI=carry[13]
XU1 AN2 $PINS O=n1 I1=B[0] I2=A[0]
XU2 XNR2HS $PINS O=SUM[15] I1=A[15] I2=n2
XU3 XOR2HS $PINS O=SUM[14] I1=A[14] I2=carry[14]
XU4 XOR2HS $PINS O=SUM[0] I1=B[0] I2=A[0]
XU5 ND2 $PINS O=n2 I1=A[14] I2=carry[14]
.ENDS

.SUBCKT cordic_rotation_1_DW01_sub_0_DW01_sub_34 A[17] A[16] A[15] A[14] A[13]
+ A[12] A[11] A[10] A[9] A[8] A[7] A[6] A[5] A[4] A[3] A[2] A[1] A[0] B[17]
+ B[16] B[15] B[14] B[13] B[12] B[11] B[10] B[9] B[8] B[7] B[6] B[5] B[4] B[3]
+ B[2] B[1] B[0] CI DIFF[17] DIFF[16] DIFF[15] DIFF[14] DIFF[13] DIFF[12]
+ DIFF[11] DIFF[10] DIFF[9] DIFF[8] DIFF[7] DIFF[6] DIFF[5] DIFF[4] DIFF[3]
+ DIFF[2] DIFF[1] DIFF[0] CO
XU2_2 FA1S $PINS S=DIFF[2] CO=carry[3] A=A[2] B=n12 CI=carry[2]
XU2_3 FA1S $PINS S=DIFF[3] CO=carry[4] A=A[3] B=n13 CI=carry[3]
XU2_1 FA1 $PINS S=DIFF[1] CO=carry[2] A=A[1] B=n11 CI=carry[1]
XU2_6 FA1 $PINS S=DIFF[6] CO=carry[7] A=A[6] B=n16 CI=carry[6]
XU2_14 FA1S $PINS S=DIFF[14] CO=carry[15] A=A[14] B=n6 CI=carry[14]
XU2_9 FA1 $PINS S=DIFF[9] CO=carry[10] A=A[9] B=n10 CI=carry[9]
XU2_7 FA1 $PINS S=DIFF[7] CO=carry[8] A=A[7] B=n17 CI=carry[7]
XU2_8 FA1 $PINS S=DIFF[8] CO=carry[9] A=A[8] B=n18 CI=carry[8]
XU2_5 FA1 $PINS S=DIFF[5] CO=carry[6] A=A[5] B=n15 CI=carry[5]
XU2_4 FA1 $PINS S=DIFF[4] CO=carry[5] A=A[4] B=n14 CI=carry[4]
XU2_11 FA1 $PINS S=DIFF[11] CO=carry[12] A=A[11] B=n4 CI=carry[11]
XU2_12 FA1S $PINS S=DIFF[12] CO=carry[13] A=A[12] B=n9 CI=carry[12]
XU2_10 FA1 $PINS S=DIFF[10] CO=carry[11] A=A[10] B=n3 CI=carry[10]
XU2_13 FA1 $PINS S=DIFF[13] CO=carry[14] A=A[13] B=n5 CI=carry[13]
XU2_17 XOR3S $PINS O=DIFF[17] I1=A[17] I2=n8 I3=carry[17]
XU2_16 FA1S $PINS S=DIFF[16] CO=carry[17] A=A[16] B=n8 CI=carry[16]
XU2_15 FA1S $PINS S=DIFF[15] CO=carry[16] A=A[15] B=n7 CI=carry[15]
XU1 INV1S $PINS O=n2 I=B[0]
XU2 INV1S $PINS O=n8 I=B[17]
XU3 INV1S $PINS O=n5 I=B[13]
XU4 INV1S $PINS O=n3 I=B[10]
XU5 INV1S $PINS O=n9 I=B[12]
XU6 INV1S $PINS O=n4 I=B[11]
XU7 INV1S $PINS O=n14 I=B[4]
XU8 INV1S $PINS O=n15 I=B[5]
XU9 INV1S $PINS O=n18 I=B[8]
XU10 INV1S $PINS O=n17 I=B[7]
XU11 INV1S $PINS O=n10 I=B[9]
XU12 INV1S $PINS O=n7 I=B[15]
XU13 INV1S $PINS O=n6 I=B[14]
XU14 INV1S $PINS O=n16 I=B[6]
XU15 INV1S $PINS O=n11 I=B[1]
XU16 INV1S $PINS O=n1 I=A[0]
XU17 INV1S $PINS O=n13 I=B[3]
XU18 INV1S $PINS O=n12 I=B[2]
XU19 XNR2HS $PINS O=DIFF[0] I1=n2 I2=A[0]
XU20 ND2 $PINS O=carry[1] I1=B[0] I2=n1
.ENDS

.SUBCKT cordic_rotation_1_DW01_add_3_DW01_add_9 A[17] A[16] A[15] A[14] A[13]
+ A[12] A[11] A[10] A[9] A[8] A[7] A[6] A[5] A[4] A[3] A[2] A[1] A[0] B[17]
+ B[16] B[15] B[14] B[13] B[12] B[11] B[10] B[9] B[8] B[7] B[6] B[5] B[4] B[3]
+ B[2] B[1] B[0] CI SUM[17] SUM[16] SUM[15] SUM[14] SUM[13] SUM[12] SUM[11]
+ SUM[10] SUM[9] SUM[8] SUM[7] SUM[6] SUM[5] SUM[4] SUM[3] SUM[2] SUM[1] SUM[0]
+ CO
XU1_14 FA1S $PINS S=SUM[14] CO=carry[15] A=A[14] B=B[14] CI=carry[14]
XU1_1 FA1 $PINS S=SUM[1] CO=carry[2] A=A[1] B=B[1] CI=n1
XU1_9 FA1 $PINS S=SUM[9] CO=carry[10] A=A[9] B=B[9] CI=carry[9]
XU1_6 FA1 $PINS S=SUM[6] CO=carry[7] A=A[6] B=B[6] CI=carry[6]
XU1_5 FA1 $PINS S=SUM[5] CO=carry[6] A=A[5] B=B[5] CI=carry[5]
XU1_4 FA1 $PINS S=SUM[4] CO=carry[5] A=A[4] B=B[4] CI=carry[4]
XU1_3 FA1 $PINS S=SUM[3] CO=carry[4] A=A[3] B=B[3] CI=carry[3]
XU1_7 FA1 $PINS S=SUM[7] CO=carry[8] A=A[7] B=B[7] CI=carry[7]
XU1_8 FA1 $PINS S=SUM[8] CO=carry[9] A=A[8] B=B[8] CI=carry[8]
XU1_2 FA1 $PINS S=SUM[2] CO=carry[3] A=A[2] B=B[2] CI=carry[2]
XU1_11 FA1S $PINS S=SUM[11] CO=carry[12] A=A[11] B=B[11] CI=carry[11]
XU1_12 FA1 $PINS S=SUM[12] CO=carry[13] A=A[12] B=B[12] CI=carry[12]
XU1_10 FA1 $PINS S=SUM[10] CO=carry[11] A=A[10] B=B[10] CI=carry[10]
XU1_13 FA1S $PINS S=SUM[13] CO=carry[14] A=A[13] B=B[13] CI=carry[13]
XU1_15 FA1S $PINS S=SUM[15] CO=carry[16] A=A[15] B=B[15] CI=carry[15]
XU1_17 XOR3S $PINS O=SUM[17] I1=A[17] I2=B[17] I3=carry[17]
XU1_16 FA1S $PINS S=SUM[16] CO=carry[17] A=A[16] B=B[16] CI=carry[16]
XU1 AN2 $PINS O=n1 I1=B[0] I2=A[0]
XU2 XOR2HS $PINS O=SUM[0] I1=B[0] I2=A[0]
.ENDS

.SUBCKT cordic_rotation_1_DW01_sub_1_DW01_sub_35 A[15] A[14] A[13] A[12] A[11]
+ A[10] A[9] A[8] A[7] A[6] A[5] A[4] A[3] A[2] A[1] A[0] B[15] B[14] B[13]
+ B[12] B[11] B[10] B[9] B[8] B[7] B[6] B[5] B[4] B[3] B[2] B[1] B[0] CI
+ DIFF[15] DIFF[14] DIFF[13] DIFF[12] DIFF[11] DIFF[10] DIFF[9] DIFF[8] DIFF[7]
+ DIFF[6] DIFF[5] DIFF[4] DIFF[3] DIFF[2] DIFF[1] DIFF[0] CO n212 p_1 n321
XU2_9 FA1S $PINS S=DIFF[9] CO=carry[10] A=A[9] B=n11 CI=carry[9]
XU2_12 FA1S $PINS S=DIFF[12] CO=carry[13] A=A[12] B=p_1 CI=carry[12]
XU2_8 FA1S $PINS S=DIFF[8] CO=carry[9] A=A[8] B=n14 CI=carry[8]
XU2_11 FA1S $PINS S=DIFF[11] CO=carry[12] A=A[11] B=n212 CI=carry[11]
XU2_7 FA1S $PINS S=DIFF[7] CO=carry[8] A=A[7] B=n8 CI=carry[7]
XU2_10 FA1S $PINS S=DIFF[10] CO=carry[11] A=A[10] B=n321 CI=carry[10]
XU2_6 FA1S $PINS S=DIFF[6] CO=carry[7] A=A[6] B=n15 CI=carry[6]
XU2_5 FA1S $PINS S=DIFF[5] CO=carry[6] A=A[5] B=n9 CI=carry[5]
XU2_4 FA1S $PINS S=DIFF[4] CO=carry[5] A=A[4] B=n6 CI=carry[4]
XU2_3 FA1S $PINS S=DIFF[3] CO=carry[4] A=A[3] B=n12 CI=carry[3]
XU2_2 FA1S $PINS S=DIFF[2] CO=carry[3] A=A[2] B=n5 CI=carry[2]
XU2_1 FA1S $PINS S=DIFF[1] CO=carry[2] A=A[1] B=n7 CI=carry[1]
XU2_13 FA1S $PINS S=DIFF[13] CO=carry[14] A=A[13] B=B[13] CI=carry[13]
XU1 OR2 $PINS O=carry[15] I1=carry[14] I2=A[14]
XU2 INV1S $PINS O=n10 I=B[0]
XU4 XNR2HS $PINS O=DIFF[15] I1=A[15] I2=carry[15]
XU5 INV1S $PINS O=n7 I=B[1]
XU6 INV1S $PINS O=n1 I=A[0]
XU7 INV1S $PINS O=n5 I=B[2]
XU8 INV1S $PINS O=n12 I=B[3]
XU9 INV1S $PINS O=n6 I=B[4]
XU10 INV1S $PINS O=n9 I=B[5]
XU11 INV1S $PINS O=n15 I=B[6]
XU13 INV1S $PINS O=n8 I=B[7]
XU15 INV1S $PINS O=n14 I=B[8]
XU17 INV1S $PINS O=n11 I=B[9]
XU18 XNR2HS $PINS O=DIFF[14] I1=A[14] I2=carry[14]
XU19 XNR2HS $PINS O=DIFF[0] I1=n10 I2=A[0]
XU20 ND2 $PINS O=carry[1] I1=B[0] I2=n1
.ENDS

.SUBCKT cordic_rotation_1_DW01_add_4_DW01_add_10 A[17] A[16] A[15] A[14] A[13]
+ A[12] A[11] A[10] A[9] A[8] A[7] A[6] A[5] A[4] A[3] A[2] A[1] A[0] B[17]
+ B[16] B[15] B[14] B[13] B[12] B[11] B[10] B[9] B[8] B[7] B[6] B[5] B[4] B[3]
+ B[2] B[1] B[0] CI SUM[17] SUM[16] SUM[15] SUM[14] SUM[13] SUM[12] SUM[11]
+ SUM[10] SUM[9] SUM[8] SUM[7] SUM[6] SUM[5] SUM[4] SUM[3] SUM[2] SUM[1] SUM[0]
+ CO
XU1_14 FA1S $PINS S=SUM[14] CO=carry[15] A=A[14] B=B[14] CI=carry[14]
XU1_1 FA1 $PINS S=SUM[1] CO=carry[2] A=A[1] B=B[1] CI=n1
XU1_9 FA1 $PINS S=SUM[9] CO=carry[10] A=A[9] B=B[9] CI=carry[9]
XU1_6 FA1 $PINS S=SUM[6] CO=carry[7] A=A[6] B=B[6] CI=carry[6]
XU1_5 FA1 $PINS S=SUM[5] CO=carry[6] A=A[5] B=B[5] CI=carry[5]
XU1_4 FA1 $PINS S=SUM[4] CO=carry[5] A=A[4] B=B[4] CI=carry[4]
XU1_3 FA1 $PINS S=SUM[3] CO=carry[4] A=A[3] B=B[3] CI=carry[3]
XU1_7 FA1S $PINS S=SUM[7] CO=carry[8] A=A[7] B=B[7] CI=carry[7]
XU1_8 FA1 $PINS S=SUM[8] CO=carry[9] A=A[8] B=B[8] CI=carry[8]
XU1_2 FA1 $PINS S=SUM[2] CO=carry[3] A=A[2] B=B[2] CI=carry[2]
XU1_11 FA1 $PINS S=SUM[11] CO=carry[12] A=A[11] B=B[11] CI=carry[11]
XU1_12 FA1S $PINS S=SUM[12] CO=carry[13] A=A[12] B=B[12] CI=carry[12]
XU1_10 FA1 $PINS S=SUM[10] CO=carry[11] A=A[10] B=B[10] CI=carry[10]
XU1_13 FA1 $PINS S=SUM[13] CO=carry[14] A=A[13] B=B[13] CI=carry[13]
XU1_15 FA1S $PINS S=SUM[15] CO=carry[16] A=A[15] B=B[15] CI=carry[15]
XU1_17 XOR3S $PINS O=SUM[17] I1=A[17] I2=B[17] I3=carry[17]
XU1_16 FA1S $PINS S=SUM[16] CO=carry[17] A=A[16] B=B[16] CI=carry[16]
XU1 AN2 $PINS O=n1 I1=B[0] I2=A[0]
XU2 XOR2HS $PINS O=SUM[0] I1=B[0] I2=A[0]
.ENDS

.SUBCKT cordic_rotation_1_DW01_sub_2_DW01_sub_36 A[17] A[16] A[15] A[14] A[13]
+ A[12] A[11] A[10] A[9] A[8] A[7] A[6] A[5] A[4] A[3] A[2] A[1] A[0] B[17]
+ B[16] B[15] B[14] B[13] B[12] B[11] B[10] B[9] B[8] B[7] B[6] B[5] B[4] B[3]
+ B[2] B[1] B[0] CI DIFF[17] DIFF[16] DIFF[15] DIFF[14] DIFF[13] DIFF[12]
+ DIFF[11] DIFF[10] DIFF[9] DIFF[8] DIFF[7] DIFF[6] DIFF[5] DIFF[4] DIFF[3]
+ DIFF[2] DIFF[1] DIFF[0] CO
XU2_2 FA1S $PINS S=DIFF[2] CO=carry[3] A=A[2] B=n12 CI=carry[2]
XU2_3 FA1 $PINS S=DIFF[3] CO=carry[4] A=A[3] B=n13 CI=carry[3]
XU2_1 FA1S $PINS S=DIFF[1] CO=carry[2] A=A[1] B=n11 CI=carry[1]
XU2_14 FA1S $PINS S=DIFF[14] CO=carry[15] A=A[14] B=n4 CI=carry[14]
XU2_6 FA1S $PINS S=DIFF[6] CO=carry[7] A=A[6] B=n16 CI=carry[6]
XU2_15 FA1 $PINS S=DIFF[15] CO=carry[16] A=A[15] B=n3 CI=carry[15]
XU2_9 FA1 $PINS S=DIFF[9] CO=carry[10] A=A[9] B=n9 CI=carry[9]
XU2_7 FA1 $PINS S=DIFF[7] CO=carry[8] A=A[7] B=n17 CI=carry[7]
XU2_8 FA1 $PINS S=DIFF[8] CO=carry[9] A=A[8] B=n18 CI=carry[8]
XU2_5 FA1 $PINS S=DIFF[5] CO=carry[6] A=A[5] B=n15 CI=carry[5]
XU2_4 FA1 $PINS S=DIFF[4] CO=carry[5] A=A[4] B=n14 CI=carry[4]
XU2_11 FA1 $PINS S=DIFF[11] CO=carry[12] A=A[11] B=n7 CI=carry[11]
XU2_12 FA1S $PINS S=DIFF[12] CO=carry[13] A=A[12] B=n6 CI=carry[12]
XU2_10 FA1 $PINS S=DIFF[10] CO=carry[11] A=A[10] B=n8 CI=carry[10]
XU2_13 FA1 $PINS S=DIFF[13] CO=carry[14] A=A[13] B=n5 CI=carry[13]
XU2_17 XOR3S $PINS O=DIFF[17] I1=A[17] I2=n2 I3=carry[17]
XU2_16 FA1S $PINS S=DIFF[16] CO=carry[17] A=A[16] B=n2 CI=carry[16]
XU1 INV1S $PINS O=n10 I=B[0]
XU2 INV1S $PINS O=n2 I=B[17]
XU3 INV1S $PINS O=n5 I=B[13]
XU4 INV1S $PINS O=n8 I=B[10]
XU5 INV1S $PINS O=n6 I=B[12]
XU6 INV1S $PINS O=n7 I=B[11]
XU7 INV1S $PINS O=n14 I=B[4]
XU8 INV1S $PINS O=n15 I=B[5]
XU9 INV1S $PINS O=n18 I=B[8]
XU10 INV1S $PINS O=n17 I=B[7]
XU11 INV1S $PINS O=n9 I=B[9]
XU12 INV1S $PINS O=n3 I=B[15]
XU13 INV1S $PINS O=n16 I=B[6]
XU14 INV1S $PINS O=n4 I=B[14]
XU15 INV1S $PINS O=n11 I=B[1]
XU16 INV1S $PINS O=n1 I=A[0]
XU17 INV1S $PINS O=n13 I=B[3]
XU18 INV1S $PINS O=n12 I=B[2]
XU19 XNR2HS $PINS O=DIFF[0] I1=n10 I2=A[0]
XU20 ND2 $PINS O=carry[1] I1=B[0] I2=n1
.ENDS

.SUBCKT cordic_rotation_1 clk rst_n valid_in valid_out x_in[16] x_in[15]
+ x_in[14] x_in[13] x_in[12] x_in[11] x_in[10] x_in[9] x_in[8] x_in[7] x_in[6]
+ x_in[5] x_in[4] x_in[3] x_in[2] x_in[1] x_in[0] y_in[16] y_in[15] y_in[14]
+ y_in[13] y_in[12] y_in[11] y_in[10] y_in[9] y_in[8] y_in[7] y_in[6] y_in[5]
+ y_in[4] y_in[3] y_in[2] y_in[1] y_in[0] phase_in[15] phase_in[14]
+ phase_in[13] phase_in[12] phase_in[11] phase_in[10] phase_in[9] phase_in[8]
+ phase_in[7] phase_in[6] phase_in[5] phase_in[4] phase_in[3] phase_in[2]
+ phase_in[1] phase_in[0] x_out[16] x_out[15] x_out[14] x_out[13] x_out[12]
+ x_out[11] x_out[10] x_out[9] x_out[8] x_out[7] x_out[6] x_out[5] x_out[4]
+ x_out[3] x_out[2] x_out[1] x_out[0] y_out[16] y_out[15] y_out[14] y_out[13]
+ y_out[12] y_out[11] y_out[10] y_out[9] y_out[8] y_out[7] y_out[6] y_out[5]
+ y_out[4] y_out[3] y_out[2] y_out[1] y_out[0] p1 FE_OFN79_FE_DBTN17_n206
+ FE_OFN77_FE_DBTN17_n206 FE_OFN76_FE_DBTN17_n206 clk_clone3 clk_clone2
+ clk_clone1
*.CONNECT N130 x_in[0]
*.CONNECT N148 y_in[0]
*.CONNECT N177 phase_in[9]
*.CONNECT N178 phase_in[10]
*.CONNECT N179 phase_in[11]
*.CONNECT N180 phase_in[12]
*.CONNECT N181 phase_in[13]
*.CONNECT N182 phase_in[14]
XFE_PHC1477_N359 BUF1CK $PINS O=FE_PHN1477_N359 I=N359
XFE_PHC1476_N426 BUF1CK $PINS O=FE_PHN1476_N426 I=N426
XFE_PHC1470_z_reg_12 BUF1CK $PINS O=FE_PHN1094_z_reg_12 I=FE_PHN1470_z_reg_12
XFE_PHC1468_z_reg_13 BUF1CK $PINS O=z_reg[13] I=FE_PHN1468_z_reg_13
XFE_PHC1466_n365 BUF1CK $PINS O=FE_PHN1466_n365 I=n365
XFE_PHC1459_N426 BUF1S $PINS O=FE_PHN1459_N426 I=FE_PHN1476_N426
XFE_PHC1457_N430 BUF3 $PINS O=FE_PHN1457_N430 I=N430
XFE_PHC1452_N514 BUF1S $PINS O=FE_PHN1452_N514 I=N514
XFE_PHC1436_N498 DELB $PINS O=N498 I=FE_PHN1436_N498
XFE_PHC1427_N480 DELB $PINS O=FE_PHN1427_N480 I=N480
XFE_PHC1425_N485 DELB $PINS O=FE_PHN1425_N485 I=N485
XFE_PHC1423_N500 DELB $PINS O=FE_PHN1423_N500 I=N500
XFE_PHC1421_N481 DELB $PINS O=FE_PHN1421_N481 I=N481
XFE_PHC1420_N483 DELB $PINS O=FE_PHN1420_N483 I=N483
XFE_PHC1419_N499 DELB $PINS O=FE_PHN1419_N499 I=N499
XFE_PHC1417_N482 DELB $PINS O=N482 I=FE_PHN1417_N482
XFE_PHC1415_N459 DELB $PINS O=FE_PHN1415_N459 I=N459
XFE_PHC1408_N457 DELB $PINS O=N457 I=FE_PHN1408_N457
XFE_PHC1407_c_in_i_0_0 DELB $PINS O=FE_PHN1407_c_in_i_0_0 I=y_in[0]
XFE_PHC1365_c_in_i_0_13 BUF8CK $PINS O=FE_PHN1365_c_in_i_0_13 I=y_in[13]
XFE_PHC1363_c_in_i_0_14 DELA $PINS O=FE_PHN1363_c_in_i_0_14 I=y_in[14]
XFE_PHC1353_N430 BUF1S $PINS O=FE_PHN1353_N430 I=FE_PHN1457_N430
XFE_PHC1349_n437 DELA $PINS O=FE_PHN1349_n437 I=n437
XFE_PHC1344_n436 DELA $PINS O=n436 I=FE_PHN1344_n436
XFE_PHC1343_n438 DELA $PINS O=n438 I=FE_PHN1343_n438
XFE_PHC1341_n439 DELA $PINS O=FE_PHN1341_n439 I=n439
XFE_PHC1339_n417 DELA $PINS O=FE_PHN1339_n417 I=n417
XFE_PHC1336_n435 DELA $PINS O=FE_PHN1336_n435 I=n435
XFE_PHC1335_n434 DELA $PINS O=n434 I=FE_PHN1335_n434
XFE_PHC1333_N438 BUF1S $PINS O=N438 I=FE_PHN1333_N438
XFE_PHC1331_n440 DELA $PINS O=FE_PHN1331_n440 I=n440
XFE_PHC1329_c_in_i_0_15 DELA $PINS O=FE_PHN1329_c_in_i_0_15 I=y_in[15]
XFE_PHC1327_n414 DELA $PINS O=FE_PHN1327_n414 I=n414
XFE_PHC1326_c_in_i_0_11 DELA $PINS O=FE_PHN1326_c_in_i_0_11 I=y_in[11]
XFE_PHC1321_n397 DELB $PINS O=FE_PHN1321_n397 I=n397
XFE_PHC1319_n441 DELA $PINS O=n441 I=FE_PHN1319_n441
XFE_PHC1312_N436 DELB $PINS O=FE_PHN1312_N436 I=N436
XFE_PHC1311_N437 DELB $PINS O=FE_PHN1311_N437 I=N437
XFE_PHC1309_N450 DELB $PINS O=FE_PHN1309_N450 I=N450
XFE_PHC1308_N435 DELB $PINS O=N435 I=FE_PHN1308_N435
XFE_PHC1306_n402 DELB $PINS O=n402 I=FE_PHN1306_n402
XFE_PHC1305_N429 DELB $PINS O=FE_PHN1305_N429 I=N429
XFE_PHC1304_N449 DELB $PINS O=N449 I=FE_PHN1304_N449
XFE_PHC1302_N448 DELB $PINS O=N448 I=FE_PHN1302_N448
XFE_PHC1301_N428 DELB $PINS O=FE_PHN1301_N428 I=N428
XFE_PHC1297_N427 DELB $PINS O=FE_PHN1297_N427 I=N427
XFE_PHC1293_N431 DELB $PINS O=FE_PHN1293_N431 I=N431
XFE_PHC1291_N433 DELB $PINS O=FE_PHN1291_N433 I=N433
XFE_PHC1290_N447 DELB $PINS O=FE_PHN1290_N447 I=N447
XFE_PHC1288_N432 DELB $PINS O=N432 I=FE_PHN1288_N432
XFE_PHC1287_n394 DELB $PINS O=FE_PHN1287_n394 I=n394
XFE_PHC1286_N446 DELB $PINS O=N446 I=FE_PHN1286_N446
XFE_PHC1280_N451 DELB $PINS O=N451 I=FE_PHN1280_N451
XFE_PHC1270_N461 DELB $PINS O=FE_PHN1270_N461 I=N461
XFE_PHC1264_n442 DELB $PINS O=FE_PHN1264_n442 I=n442
XFE_PHC1238_N460 DELB $PINS O=FE_PHN1238_N460 I=N460
XFE_PHC1179_n427 DELB $PINS O=n427 I=FE_PHN1179_n427
XFE_PHC1158_x_reg_4 BUF1S $PINS O=FE_PHN1158_x_reg_4 I=x_reg[4]
XFE_PHC1156_x_reg_11 DELB $PINS O=FE_PHN1156_x_reg_11 I=x_reg[11]
XFE_PHC1154_x_reg_5 DELB $PINS O=FE_PHN1154_x_reg_5 I=x_reg[5]
XFE_PHC1152_y_reg_12 DELB $PINS O=y_reg[12] I=FE_PHN1152_y_reg_12
XFE_PHC1151_x_reg_13 DELB $PINS O=FE_PHN1151_x_reg_13 I=x_reg[13]
XFE_PHC1140_x_reg_17 DELB $PINS O=FE_PHN1140_x_reg_17 I=x_reg[17]
XFE_PHC1139_y_reg_0 DELB $PINS O=y_reg[0] I=FE_PHN1139_y_reg_0
XFE_PHC1130_is_computing DELB $PINS O=is_computing I=FE_PHN1130_is_computing
XFE_PHC1109_x_reg_12 BUF1S $PINS O=FE_PHN1109_x_reg_12 I=x_reg[12]
XFE_PHC1098_z_reg_11 DELA $PINS O=z_reg[11] I=FE_PHN1098_z_reg_11
XFE_PHC1094_z_reg_12 BUF1S $PINS O=z_reg[12] I=FE_PHN1094_z_reg_12
XFE_PHC1067_z_reg_13 BUF1S $PINS O=FE_PHN1067_z_reg_13 I=z_reg[13]
XFE_PHC1053_z_reg_14 BUF1S $PINS O=FE_PHN1053_z_reg_14 I=z_reg[14]
XFE_PHC1051_N441 DELB $PINS O=FE_PHN1051_N441 I=N441
XFE_PHC1050_N442 DELB $PINS O=FE_PHN1050_N442 I=N442
XFE_PHC1048_N443 DELB $PINS O=FE_PHN1048_N443 I=N443
XFE_PHC1045_N445 DELB $PINS O=FE_PHN1045_N445 I=N445
XFE_PHC1041_N444 DELB $PINS O=FE_PHN1041_N444 I=N444
XFE_PHC1037_N440 DELB $PINS O=FE_PHN1037_N440 I=N440
XFE_PHC1033_N439 DELB $PINS O=FE_PHN1033_N439 I=N439
XFE_RC_810_0 INV2 $PINS O=n312 I=FE_RN_387_0
XFE_RC_809_0 AN2T $PINS O=FE_RN_387_0 I1=step_cnt[2] I2=n316
XFE_RC_713_0 INV2 $PINS O=n212 I=FE_RN_343_0
XFE_RC_712_0 AN3 $PINS O=FE_RN_343_0 I1=n313 I2=n317 I3=step_cnt[1]
XCTS_ccl_a_INV_CLK_G1_L8_51 INV3CK $PINS O=CTS_46 I=CTS_47
XCTS_ccl_a_INV_CLK_G1_L7_51 INV3CK $PINS O=CTS_47 I=CTS_48
XCTS_ccl_a_INV_CLK_G1_L8_50 INV4CK $PINS O=CTS_43 I=CTS_44
XCTS_ccl_a_INV_CLK_G1_L7_50 INV2CK $PINS O=CTS_44 I=CTS_45
XCTS_ccl_a_INV_CLK_G1_L8_38 INV6CK $PINS O=CTS_40 I=CTS_41
XCTS_ccl_a_INV_CLK_G1_L7_38 INV3CK $PINS O=CTS_41 I=CTS_42
XCTS_ccl_a_INV_CLK_G1_L8_37 INV8CK $PINS O=CTS_37 I=CTS_38
XCTS_ccl_a_INV_CLK_G1_L7_37 INV4CK $PINS O=CTS_38 I=CTS_39
XFE_OFC461_n443 BUF1 $PINS O=FE_OFN252_n443 I=n443
XFE_OFC449_n135 INV2 $PINS O=FE_OFN240_n135 I=FE_OFN238_n135
XFE_OFC447_n135 INV1S $PINS O=FE_OFN238_n135 I=n135
XFE_OFC445_n162 BUF1 $PINS O=FE_OFN236_n162 I=n162
XFE_OFC443_n163 BUF2 $PINS O=FE_OFN234_n163 I=n163
XFE_OFC433_x_reg_8 INV1S $PINS O=FE_OFN224_x_reg_8 I=x_reg[8]
XFE_OFC409_n41 BUF1 $PINS O=FE_OFN216_n41 I=FE_DBTN166_n41
XFE_OFC408_n41 INV1S $PINS O=FE_OFN215_n41 I=FE_DBTN166_n41
XFE_OFC407_n41 INV1S $PINS O=FE_DBTN166_n41 I=n41
XFE_OFC396_n321 INV1S $PINS O=FE_OFN209_n321 I=N108
XFE_OFC395_n321 INV1S $PINS O=N108 I=n321
XFE_OFC394_n217 INV1S $PINS O=FE_OFN208_n217 I=n140
XFE_OFC393_n217 INV1S $PINS O=FE_OFN207_n217 I=n140
XFE_OFC392_n217 INV1S $PINS O=FE_OFN206_n217 I=n140
XFE_OFC391_n217 INV2 $PINS O=n140 I=n217
XFE_OFC369_y_reg_8 INV1S $PINS O=n150 I=y_reg[8]
XFE_OFC368_y_reg_9 INV1S $PINS O=n149 I=y_reg[9]
XFE_OFC367_x_reg_9 INV1S $PINS O=n245 I=x_reg[9]
XFE_OFC324_n224 INV2 $PINS O=FE_DBTN168_n224 I=n224
XFE_OFC311_y_reg_6 INV1S $PINS O=n171 I=y_reg[6]
XFE_OFC309_x_reg_7 INV1S $PINS O=n254 I=x_reg[7]
XFE_OFC308_n165 INV2 $PINS O=FE_DBTN169_n165 I=n165
XFE_OFC300_x_reg_12 INV1S $PINS O=FE_DBTN175_x_reg_12 I=x_reg[12]
XFE_OFC297_y_reg_7 INV1S $PINS O=n160 I=y_reg[7]
XFE_OFC279_x_reg_11 INV1S $PINS O=FE_DBTN177_x_reg_11 I=FE_PHN1156_x_reg_11
XFE_OFC266_x_reg_10 INV1S $PINS O=FE_DBTN170_x_reg_10 I=x_reg[10]
XFE_OFC263_y_reg_12 INV1S $PINS O=FE_DBTN174_y_reg_12 I=y_reg[12]
XFE_OFC258_n143 INV2 $PINS O=FE_OFN169_n143 I=FE_DBTN167_n143
XFE_OFC257_n143 BUF2 $PINS O=FE_DBTN167_n143 I=n143
XFE_OFC253_y_reg_11 INV1S $PINS O=FE_DBTN176_y_reg_11 I=y_reg[11]
XFE_OFC248_n133 INV2 $PINS O=n48 I=n133
XFE_OFC243_y_reg_10 INV1S $PINS O=FE_DBTN171_y_reg_10 I=y_reg[10]
XFE_OFC120_n212 INV1S $PINS O=FE_OFN108_n212 I=n212
XFE_OFC119_n212 INV1S $PINS O=n443 I=n212
XFE_OFC35_n319 BUF1 $PINS O=FE_OFN37_n319 I=n319
XFE_OFC34_n4 BUF1 $PINS O=FE_OFN36_n4 I=n4
XFE_DBTC173_y_reg_13 INV1S $PINS O=FE_DBTN173_y_reg_13 I=y_reg[13]
XFE_DBTC172_x_reg_13 INV1S $PINS O=FE_DBTN172_x_reg_13 I=FE_PHN1151_x_reg_13
Xy_out_reg[0] QDFFRBN $PINS Q=y_out[0] D=FE_PHN1033_N439 CK=CTS_46
+ RB=FE_OFN76_FE_DBTN17_n206
Xy_out_reg[1] QDFFRBN $PINS Q=y_out[1] D=FE_PHN1037_N440 CK=CTS_46
+ RB=FE_OFN76_FE_DBTN17_n206
Xy_out_reg[2] QDFFRBN $PINS Q=y_out[2] D=FE_PHN1051_N441 CK=CTS_46
+ RB=FE_OFN76_FE_DBTN17_n206
Xy_out_reg[7] QDFFRBN $PINS Q=y_out[7] D=N446 CK=CTS_46
+ RB=FE_OFN76_FE_DBTN17_n206
Xy_out_reg[8] QDFFRBN $PINS Q=y_out[8] D=FE_PHN1290_N447 CK=CTS_46
+ RB=FE_OFN76_FE_DBTN17_n206
Xy_out_reg[9] QDFFRBN $PINS Q=y_out[9] D=N448 CK=CTS_46
+ RB=FE_OFN76_FE_DBTN17_n206
Xy_out_reg[10] QDFFRBN $PINS Q=y_out[10] D=N449 CK=CTS_46
+ RB=FE_OFN76_FE_DBTN17_n206
Xy_out_reg[14] QDFFRBN $PINS Q=y_out[14] D=N451 CK=CTS_46
+ RB=FE_OFN79_FE_DBTN17_n206
Xy_out_reg[15] QDFFRBN $PINS Q=y_out[15] D=N451 CK=CTS_46
+ RB=FE_OFN79_FE_DBTN17_n206
Xy_out_reg[16] QDFFRBN $PINS Q=y_out[16] D=N451 CK=CTS_46
+ RB=FE_OFN79_FE_DBTN17_n206
Xx_out_reg[0] QDFFRBN $PINS Q=x_out[0] D=FE_PHN1459_N426 CK=CTS_43
+ RB=FE_OFN79_FE_DBTN17_n206
Xx_out_reg[1] QDFFRBN $PINS Q=x_out[1] D=FE_PHN1297_N427 CK=CTS_43
+ RB=FE_OFN79_FE_DBTN17_n206
Xx_out_reg[3] QDFFRBN $PINS Q=x_out[3] D=FE_PHN1305_N429 CK=CTS_43
+ RB=FE_OFN79_FE_DBTN17_n206
Xx_out_reg[5] QDFFRBN $PINS Q=x_out[5] D=FE_PHN1293_N431 CK=CTS_43
+ RB=FE_OFN79_FE_DBTN17_n206
Xx_out_reg[6] QDFFRBN $PINS Q=x_out[6] D=N432 CK=CTS_43
+ RB=FE_OFN79_FE_DBTN17_n206
Xx_out_reg[10] QDFFRBN $PINS Q=x_out[10] D=FE_PHN1312_N436 CK=CTS_43
+ RB=FE_OFN79_FE_DBTN17_n206
Xx_out_reg[11] QDFFRBN $PINS Q=x_out[11] D=FE_PHN1311_N437 CK=CTS_43
+ RB=FE_OFN79_FE_DBTN17_n206
Xx_out_reg[12] QDFFRBN $PINS Q=x_out[12] D=N438 CK=CTS_43
+ RB=FE_OFN79_FE_DBTN17_n206
Xx_out_reg[7] QDFFRBN $PINS Q=x_out[7] D=FE_PHN1291_N433 CK=CTS_43
+ RB=FE_OFN79_FE_DBTN17_n206
Xx_out_reg[8] QDFFRBN $PINS Q=x_out[8] D=N434 CK=CTS_43
+ RB=FE_OFN79_FE_DBTN17_n206
Xx_out_reg[9] QDFFRBN $PINS Q=x_out[9] D=N435 CK=CTS_43
+ RB=FE_OFN79_FE_DBTN17_n206
Xy_out_reg[3] QDFFRBN $PINS Q=y_out[3] D=FE_PHN1050_N442 CK=CTS_46
+ RB=FE_OFN76_FE_DBTN17_n206
Xy_out_reg[4] QDFFRBN $PINS Q=y_out[4] D=FE_PHN1048_N443 CK=CTS_46
+ RB=FE_OFN76_FE_DBTN17_n206
Xy_out_reg[5] QDFFRBN $PINS Q=y_out[5] D=FE_PHN1041_N444 CK=CTS_46
+ RB=FE_OFN76_FE_DBTN17_n206
Xy_out_reg[6] QDFFRBN $PINS Q=y_out[6] D=FE_PHN1045_N445 CK=CTS_46
+ RB=FE_OFN76_FE_DBTN17_n206
Xy_out_reg[11] QDFFRBN $PINS Q=y_out[11] D=FE_PHN1309_N450 CK=CTS_46
+ RB=FE_OFN76_FE_DBTN17_n206
Xy_out_reg[12] QDFFRBN $PINS Q=y_out[12] D=N451 CK=CTS_46
+ RB=FE_OFN79_FE_DBTN17_n206
Xy_out_reg[13] QDFFRBN $PINS Q=y_out[13] D=N451 CK=CTS_46
+ RB=FE_OFN79_FE_DBTN17_n206
Xx_out_reg[2] QDFFRBN $PINS Q=x_out[2] D=FE_PHN1301_N428 CK=CTS_43
+ RB=FE_OFN79_FE_DBTN17_n206
Xx_out_reg[4] QDFFRBN $PINS Q=x_out[4] D=FE_PHN1353_N430 CK=CTS_43
+ RB=FE_OFN79_FE_DBTN17_n206
Xx_out_reg[13] QDFFRBN $PINS Q=x_out[13] D=N438 CK=CTS_43
+ RB=FE_OFN79_FE_DBTN17_n206
Xx_out_reg[14] QDFFRBN $PINS Q=x_out[14] D=N438 CK=CTS_43
+ RB=FE_OFN79_FE_DBTN17_n206
Xx_out_reg[15] QDFFRBN $PINS Q=x_out[15] D=N438 CK=CTS_43
+ RB=FE_OFN79_FE_DBTN17_n206
Xx_out_reg[16] QDFFRBN $PINS Q=x_out[16] D=N438 CK=CTS_43
+ RB=FE_OFN79_FE_DBTN17_n206
Xz_reg_reg[14] QDFFRBN $PINS Q=z_reg[14] D=N477 CK=CTS_40
+ RB=FE_OFN77_FE_DBTN17_n206
Xz_reg_reg[13] QDFFRBN $PINS Q=FE_PHN1468_z_reg_13 D=N476 CK=CTS_40
+ RB=FE_OFN77_FE_DBTN17_n206
Xz_reg_reg[15] QDFFRBN $PINS Q=z_reg[15] D=N478 CK=CTS_40
+ RB=FE_OFN77_FE_DBTN17_n206
Xz_reg_reg[12] QDFFRBN $PINS Q=FE_PHN1470_z_reg_12 D=N475 CK=CTS_40
+ RB=FE_OFN77_FE_DBTN17_n206
Xz_reg_reg[11] QDFFRBN $PINS Q=FE_PHN1098_z_reg_11 D=N474 CK=CTS_40
+ RB=FE_OFN77_FE_DBTN17_n206
Xz_reg_reg[10] QDFFRBN $PINS Q=z_reg[10] D=N473 CK=CTS_40
+ RB=FE_OFN77_FE_DBTN17_n206
Xz_reg_reg[9] QDFFRBN $PINS Q=z_reg[9] D=N472 CK=CTS_40
+ RB=FE_OFN77_FE_DBTN17_n206
Xz_reg_reg[8] QDFFRBN $PINS Q=z_reg[8] D=n434 CK=CTS_40
+ RB=FE_OFN77_FE_DBTN17_n206
Xz_reg_reg[7] QDFFRBN $PINS Q=z_reg[7] D=FE_PHN1336_n435 CK=CTS_40
+ RB=FE_OFN77_FE_DBTN17_n206
Xz_reg_reg[6] QDFFRBN $PINS Q=z_reg[6] D=n436 CK=CTS_37
+ RB=FE_OFN77_FE_DBTN17_n206
Xz_reg_reg[5] QDFFRBN $PINS Q=z_reg[5] D=FE_PHN1349_n437 CK=CTS_37
+ RB=FE_OFN77_FE_DBTN17_n206
Xz_reg_reg[4] QDFFRBN $PINS Q=z_reg[4] D=n438 CK=CTS_37
+ RB=FE_OFN77_FE_DBTN17_n206
Xz_reg_reg[3] QDFFRBN $PINS Q=z_reg[3] D=FE_PHN1341_n439 CK=CTS_37
+ RB=FE_OFN77_FE_DBTN17_n206
Xz_reg_reg[2] QDFFRBN $PINS Q=z_reg[2] D=FE_PHN1331_n440 CK=CTS_37 RB=rst_n
Xy_reg_reg[17] QDFFRBN $PINS Q=y_reg[17] D=FE_PHN1452_N514 CK=CTS_40
+ RB=FE_OFN77_FE_DBTN17_n206
Xx_reg_reg[17] QDFFRBN $PINS Q=x_reg[17] D=N496 CK=CTS_37
+ RB=FE_OFN77_FE_DBTN17_n206
Xz_reg_reg[1] QDFFRBN $PINS Q=z_reg[1] D=n441 CK=CTS_37 RB=rst_n
Xx_reg_reg[16] QDFFRBN $PINS Q=x_reg[16] D=N495 CK=CTS_37
+ RB=FE_OFN77_FE_DBTN17_n206
Xy_reg_reg[16] QDFFRBN $PINS Q=y_reg[16] D=N513 CK=CTS_40
+ RB=FE_OFN77_FE_DBTN17_n206
Xz_reg_reg[0] QDFFRBN $PINS Q=z_reg[0] D=FE_PHN1264_n442 CK=CTS_37
+ RB=FE_OFN77_FE_DBTN17_n206
Xx_reg_reg[15] QDFFRBN $PINS Q=x_reg[15] D=N494 CK=CTS_37
+ RB=FE_OFN77_FE_DBTN17_n206
Xy_reg_reg[15] QDFFRBN $PINS Q=y_reg[15] D=N512 CK=CTS_40 RB=rst_n
Xx_reg_reg[14] QDFFRBN $PINS Q=x_reg[14] D=N493 CK=CTS_37
+ RB=FE_OFN77_FE_DBTN17_n206
Xy_reg_reg[14] QDFFRBN $PINS Q=y_reg[14] D=N511 CK=CTS_40 RB=rst_n
Xy_reg_reg[13] QDFFRBN $PINS Q=y_reg[13] D=N510 CK=CTS_40 RB=rst_n
Xx_reg_reg[13] QDFFRBN $PINS Q=x_reg[13] D=N492 CK=CTS_37
+ RB=FE_OFN77_FE_DBTN17_n206
Xy_reg_reg[12] QDFFRBN $PINS Q=FE_PHN1152_y_reg_12 D=N509 CK=CTS_40 RB=rst_n
Xx_reg_reg[12] QDFFRBN $PINS Q=x_reg[12] D=N491 CK=CTS_37
+ RB=FE_OFN77_FE_DBTN17_n206
Xis_computing_reg QDFFRBN $PINS Q=FE_PHN1130_is_computing D=N457 CK=CTS_37
+ RB=FE_OFN77_FE_DBTN17_n206
Xy_reg_reg[11] QDFFRBN $PINS Q=y_reg[11] D=N508 CK=CTS_40 RB=rst_n
Xx_reg_reg[11] QDFFRBN $PINS Q=x_reg[11] D=N490 CK=CTS_37
+ RB=FE_OFN77_FE_DBTN17_n206
Xx_reg_reg[1] QDFFRBN $PINS Q=x_reg[1] D=FE_PHN1427_N480 CK=CTS_37 RB=rst_n
Xy_reg_reg[1] QDFFRBN $PINS Q=y_reg[1] D=N498 CK=CTS_40 RB=rst_n
Xy_reg_reg[3] QDFFRBN $PINS Q=y_reg[3] D=FE_PHN1423_N500 CK=CTS_40 RB=rst_n
Xx_reg_reg[3] QDFFRBN $PINS Q=x_reg[3] D=N482 CK=CTS_37 RB=rst_n
Xy_reg_reg[10] QDFFRBN $PINS Q=y_reg[10] D=N507 CK=CTS_40 RB=rst_n
Xx_reg_reg[4] QDFFRBN $PINS Q=x_reg[4] D=FE_PHN1420_N483 CK=CTS_37 RB=rst_n
Xx_reg_reg[10] QDFFRBN $PINS Q=x_reg[10] D=N489 CK=CTS_37
+ RB=FE_OFN77_FE_DBTN17_n206
Xy_reg_reg[4] QDFFRBN $PINS Q=y_reg[4] D=N501 CK=CTS_40 RB=rst_n
Xy_reg_reg[2] QDFFRBN $PINS Q=y_reg[2] D=FE_PHN1419_N499 CK=CTS_40 RB=rst_n
Xx_reg_reg[0] QDFFRBN $PINS Q=x_reg[0] D=N479 CK=CTS_37 RB=rst_n
Xx_reg_reg[2] QDFFRBN $PINS Q=x_reg[2] D=FE_PHN1421_N481 CK=CTS_37 RB=rst_n
Xy_reg_reg[0] QDFFRBN $PINS Q=FE_PHN1139_y_reg_0 D=N497 CK=CTS_40 RB=rst_n
Xy_reg_reg[7] QDFFRBN $PINS Q=y_reg[7] D=N504 CK=CTS_40 RB=rst_n
Xx_reg_reg[7] QDFFRBN $PINS Q=x_reg[7] D=N486 CK=CTS_37 RB=rst_n
Xy_reg_reg[5] QDFFRBN $PINS Q=y_reg[5] D=N502 CK=CTS_40 RB=rst_n
Xx_reg_reg[5] QDFFRBN $PINS Q=x_reg[5] D=N484 CK=CTS_37 RB=rst_n
Xy_reg_reg[8] QDFFRBN $PINS Q=y_reg[8] D=N505 CK=CTS_40 RB=rst_n
Xx_reg_reg[8] QDFFRBN $PINS Q=x_reg[8] D=N487 CK=CTS_37 RB=rst_n
Xy_reg_reg[6] QDFFRBN $PINS Q=y_reg[6] D=N503 CK=CTS_40 RB=rst_n
Xx_reg_reg[6] QDFFRBN $PINS Q=x_reg[6] D=FE_PHN1425_N485 CK=CTS_37 RB=rst_n
Xy_reg_reg[9] QDFFRBN $PINS Q=y_reg[9] D=N506 CK=CTS_40 RB=rst_n
Xx_reg_reg[9] QDFFRBN $PINS Q=x_reg[9] D=N488 CK=CTS_37
+ RB=FE_OFN77_FE_DBTN17_n206
Xvalid_out_reg QDFFRBN $PINS Q=valid_out D=N515 CK=clk
+ RB=FE_OFN76_FE_DBTN17_n206
Xstep_cnt_reg[2] QDFFRBN $PINS Q=step_cnt[2] D=FE_PHN1238_N460 CK=net2420
+ RB=FE_OFN77_FE_DBTN17_n206
Xstep_cnt_reg[3] QDFFRBN $PINS Q=step_cnt[3] D=FE_PHN1270_N461 CK=net2420
+ RB=FE_OFN77_FE_DBTN17_n206
Xstep_cnt_reg[1] QDFFRBN $PINS Q=step_cnt[1] D=FE_PHN1415_N459 CK=net2420
+ RB=FE_OFN77_FE_DBTN17_n206
Xstep_cnt_reg[0] QDFFRBN $PINS Q=step_cnt[0] D=N458 CK=net2420
+ RB=FE_OFN77_FE_DBTN17_n206
XU3 OAI12HS $PINS O=n426 A1=is_computing B1=n314 B2=n428
XU4 NR2 $PINS O=N147 I1=x_in[16] I2=sub_87/carry[16]
XU5 NR2 $PINS O=n153 I1=n165 I2=n43
XU6 NR2 $PINS O=sub_87/carry[2] I1=N130 I2=x_in[1]
XU7 NR2 $PINS O=sub_88/carry[2] I1=N148 I2=y_in[1]
XU8 NR2P $PINS O=n61 I1=n320 I2=z_reg[15]
XU9 NR2 $PINS O=N165 I1=y_in[16] I2=sub_88/carry[16]
XU11 INV2 $PINS O=n428 I=step_cnt[0]
XU15 ND2S $PINS O=n163 I1=N108 I2=n317
XU16 AOI12HS $PINS O=n4 A1=n421 B1=n419 B2=n420
XU27 INV1S $PINS O=n43 I=n164
XU30 AN3 $PINS O=n165 I1=step_cnt[3] I2=n315 I3=n316
XU34 INV1S $PINS O=n42 I=FE_OFN236_n162
XU44 ND3P $PINS O=n133 I1=n315 I2=n317 I3=n316
XU45 INV2 $PINS O=n317 I=step_cnt[3]
XU60 OA222 $PINS O=n225 A1=FE_OFN234_n163 A2=n189 B1=FE_DBTN171_y_reg_10
+ B2=n164 C1=n149 C2=FE_DBTN169_n165
XU61 INV1S $PINS O=n314 I=step_cnt[1]
XU65 OA222S $PINS O=n286 A1=FE_OFN234_n163 A2=n273 B1=n164
+ B2=FE_DBTN177_x_reg_11 C1=FE_DBTN169_n165 C2=FE_DBTN170_x_reg_10
XU66 OA222S $PINS O=n287 A1=FE_OFN236_n162 A2=n245 B1=n140 B2=n261
+ C1=FE_DBTN168_n224 C2=n254
XU67 OA222S $PINS O=n280 A1=FE_OFN234_n163 A2=n267 B1=n164
+ B2=FE_DBTN175_x_reg_12 C1=FE_DBTN169_n165 C2=FE_DBTN177_x_reg_11
XU68 OA222S $PINS O=n281 A1=FE_OFN236_n162 A2=FE_DBTN170_x_reg_10 B1=n140
+ B2=n254 C1=FE_DBTN168_n224 C2=FE_OFN224_x_reg_8
XU69 OA222S $PINS O=n196 A1=FE_OFN234_n163 A2=n183 B1=FE_DBTN176_y_reg_11
+ B2=n164 C1=FE_DBTN171_y_reg_10 C2=FE_DBTN169_n165
XU70 OA222S $PINS O=n197 A1=n149 A2=FE_OFN236_n162 B1=n140 B2=n171
+ C1=FE_DBTN168_n224 C2=n160
XU71 OA222S $PINS O=n190 A1=FE_OFN234_n163 A2=n177 B1=FE_DBTN174_y_reg_12
+ B2=n164 C1=FE_DBTN176_y_reg_11 C2=FE_DBTN169_n165
XU72 OA222S $PINS O=n191 A1=FE_DBTN171_y_reg_10 A2=FE_OFN236_n162 B1=n140
+ B2=n160 C1=FE_DBTN168_n224 C2=n150
XU73 OA222S $PINS O=n274 A1=FE_OFN234_n163 A2=n261 B1=n164
+ B2=FE_DBTN172_x_reg_13 C1=FE_DBTN169_n165 C2=FE_DBTN175_x_reg_12
XU74 OA222S $PINS O=n275 A1=FE_OFN236_n162 A2=FE_DBTN177_x_reg_11 B1=n140
+ B2=FE_OFN224_x_reg_8 C1=FE_DBTN168_n224 C2=n245
XU75 OA222S $PINS O=n184 A1=FE_OFN234_n163 A2=n171 B1=FE_DBTN173_y_reg_13
+ B2=n164 C1=FE_DBTN174_y_reg_12 C2=FE_DBTN169_n165
XU76 OA222S $PINS O=n185 A1=FE_DBTN176_y_reg_11 A2=FE_OFN236_n162 B1=n140
+ B2=n150 C1=FE_DBTN168_n224 C2=n149
XU77 OA222S $PINS O=n268 A1=FE_OFN234_n163 A2=n254 B1=n164 B2=n239
+ C1=FE_DBTN169_n165 C2=FE_DBTN172_x_reg_13
XU78 OA222S $PINS O=n269 A1=FE_OFN236_n162 A2=FE_DBTN175_x_reg_12 B1=n140
+ B2=n245 C1=FE_DBTN168_n224 C2=FE_DBTN170_x_reg_10
XU79 OA222S $PINS O=n178 A1=FE_OFN234_n163 A2=n160 B1=n141 B2=n164
+ C1=FE_DBTN173_y_reg_13 C2=FE_DBTN169_n165
XU80 OA222S $PINS O=n179 A1=FE_DBTN174_y_reg_12 A2=FE_OFN236_n162 B1=n140
+ B2=n149 C1=FE_DBTN168_n224 C2=FE_DBTN171_y_reg_10
XU81 OA222S $PINS O=n262 A1=FE_OFN234_n163 A2=FE_OFN224_x_reg_8 B1=n164 B2=n237
+ C1=FE_DBTN169_n165 C2=n239
XU82 OA222S $PINS O=n263 A1=FE_OFN236_n162 A2=FE_DBTN172_x_reg_13 B1=n140
+ B2=FE_DBTN170_x_reg_10 C1=FE_DBTN168_n224 C2=FE_DBTN177_x_reg_11
XU83 OA222S $PINS O=n172 A1=FE_OFN234_n163 A2=n150 B1=n137 B2=n164 C1=n141
+ C2=FE_DBTN169_n165
XU84 OA222S $PINS O=n173 A1=FE_DBTN173_y_reg_13 A2=FE_OFN236_n162 B1=n140
+ B2=FE_DBTN171_y_reg_10 C1=FE_DBTN168_n224 C2=FE_DBTN176_y_reg_11
XU85 OA222S $PINS O=n256 A1=FE_OFN234_n163 A2=n245 B1=n164 B2=n236
+ C1=FE_DBTN169_n165 C2=n237
XU86 OA222S $PINS O=n257 A1=FE_OFN236_n162 A2=n239 B1=n140
+ B2=FE_DBTN177_x_reg_11 C1=FE_DBTN168_n224 C2=FE_DBTN175_x_reg_12
XU87 OA222S $PINS O=n166 A1=FE_OFN234_n163 A2=n149 B1=n136 B2=n164 C1=n137
+ C2=FE_DBTN169_n165
XU88 OA222S $PINS O=n167 A1=n141 A2=FE_OFN236_n162 B1=n140
+ B2=FE_DBTN176_y_reg_11 C1=FE_DBTN168_n224 C2=FE_DBTN174_y_reg_12
XU89 OA222S $PINS O=n249 A1=FE_OFN234_n163 A2=FE_DBTN170_x_reg_10 B1=n164
+ B2=n238 C1=FE_DBTN169_n165 C2=n236
XU90 OA222S $PINS O=n250 A1=FE_OFN236_n162 A2=n237 B1=n140
+ B2=FE_DBTN175_x_reg_12 C1=FE_DBTN168_n224 C2=FE_DBTN172_x_reg_13
XU91 OA222S $PINS O=n155 A1=FE_OFN234_n163 A2=FE_DBTN171_y_reg_10 B1=n139
+ B2=n164 C1=n136 C2=FE_DBTN169_n165
XU92 OA222S $PINS O=n156 A1=n137 A2=FE_OFN236_n162 B1=n140
+ B2=FE_DBTN174_y_reg_12 C1=FE_DBTN168_n224 C2=FE_DBTN173_y_reg_13
XU93 ND3S $PINS O=N112 I1=n312 I2=n133 I3=n430
XU94 ND3S $PINS O=N113 I1=n212 I2=n133 I3=n431
XU95 OA222S $PINS O=n296 A1=FE_OFN169_n143 A2=n236 B1=n211 B2=n238
+ C1=FE_OFN234_n163 C2=n237
XU96 OA222S $PINS O=n210 A1=FE_OFN169_n143 A2=n136 B1=n211 B2=n139 C1=n137
+ C2=FE_OFN234_n163
XU97 ND2S $PINS O=N109 I1=n310 I2=n133
XU98 ND3 $PINS O=n310 I1=n428 I2=n314 I3=step_cnt[2]
XU99 ND3 $PINS O=n135 I1=step_cnt[2] I2=step_cnt[0] I3=n425
XU100 AO222S $PINS O=n308 A1=x_reg[0] A2=n41 B1=FE_PHN1158_x_reg_4
+ B2=FE_DBTN167_n143 C1=x_reg[7] C2=FE_OFN238_n135
XU101 AO222S $PINS O=n228 A1=y_reg[0] A2=n41 B1=y_reg[4] B2=FE_DBTN167_n143
+ C1=y_reg[7] C2=FE_OFN238_n135
XU103 ND3P $PINS O=n321 I1=step_cnt[1] I2=n315 I3=step_cnt[0]
XU104 ND3 $PINS O=n311 I1=step_cnt[1] I2=n428 I3=step_cnt[2]
XU105 AO222S $PINS O=n289 A1=n41 A2=x_reg[1] B1=FE_DBTN167_n143
+ B2=FE_PHN1154_x_reg_5 C1=FE_OFN238_n135 C2=x_reg[8]
XU106 AO222S $PINS O=n199 A1=n41 A2=y_reg[1] B1=FE_DBTN167_n143 B2=y_reg[5]
+ C1=FE_OFN238_n135 C2=y_reg[8]
XU107 ND3S $PINS O=n162 I1=n313 I2=n314 I3=step_cnt[3]
XU108 ND3S $PINS O=n164 I1=step_cnt[3] I2=n313 I3=step_cnt[1]
XU109 OA222S $PINS O=n241 A1=FE_DBTN168_n224 A2=n239 B1=n153 B2=n238 C1=n140
+ C2=FE_DBTN172_x_reg_13
XU110 OA222S $PINS O=n145 A1=n141 A2=FE_DBTN168_n224 B1=n153 B2=n139 C1=n140
+ C2=FE_DBTN173_y_reg_13
XU111 OA222S $PINS O=n231 A1=FE_DBTN168_n224 A2=n237 B1=n138 B2=n238 C1=n140
+ C2=n239
XU112 OA222S $PINS O=n129 A1=FE_DBTN168_n224 A2=n137 B1=n138 B2=n139 C1=n140
+ C2=n141
XU113 OA222S $PINS O=n299 A1=n133 A2=FE_DBTN175_x_reg_12 B1=FE_DBTN166_n41
+ B2=FE_DBTN177_x_reg_11 C1=n212 C2=FE_DBTN172_x_reg_13
XU114 OA222S $PINS O=n215 A1=FE_DBTN174_y_reg_12 A2=n133 B1=FE_OFN216_n41
+ B2=FE_DBTN176_y_reg_11 C1=FE_DBTN173_y_reg_13 C2=n212
XU115 OA222S $PINS O=n294 A1=FE_DBTN166_n41 A2=FE_DBTN172_x_reg_13 B1=n208
+ B2=n238 C1=FE_OFN234_n163 C2=n236
XU116 OA222S $PINS O=n207 A1=FE_DBTN173_y_reg_13 A2=FE_OFN216_n41 B1=n208
+ B2=n139 C1=FE_OFN234_n163 C2=n136
XU117 OA12S $PINS O=n424 A1=n426 B1=step_cnt[2] B2=n320
XU118 ND2S $PINS O=FE_PHN1179_n427 I1=is_computing I2=n428
XU158 AN3 $PINS O=n41 I1=n314 I2=n317 I3=n313
XU159 INV1S $PINS O=n127 I=FE_PHN1407_c_in_i_0_0
XU160 INV1S $PINS O=n110 I=N130
XU161 INV1S $PINS O=n109 I=x_in[1]
XU162 INV1S $PINS O=n126 I=y_in[1]
XU163 INV1S $PINS O=n108 I=x_in[2]
XU164 INV1S $PINS O=n125 I=y_in[2]
XU165 INV1S $PINS O=n107 I=x_in[3]
XU166 INV1S $PINS O=n124 I=y_in[3]
XU167 INV1S $PINS O=n106 I=x_in[4]
XU168 INV1S $PINS O=n123 I=y_in[4]
XU169 INV1S $PINS O=n105 I=x_in[5]
XU170 INV1S $PINS O=n122 I=y_in[5]
XU171 INV1S $PINS O=n104 I=x_in[6]
XU172 INV1S $PINS O=n121 I=y_in[6]
XU173 INV1S $PINS O=n103 I=x_in[7]
XU174 INV1S $PINS O=n120 I=y_in[7]
XU175 INV1S $PINS O=n102 I=x_in[8]
XU176 INV1S $PINS O=n119 I=y_in[8]
XU177 INV1S $PINS O=n101 I=x_in[9]
XU178 INV1S $PINS O=n118 I=y_in[9]
XU179 INV1S $PINS O=n117 I=y_in[10]
XU180 INV1S $PINS O=n100 I=x_in[10]
XU181 INV1S $PINS O=n116 I=y_in[11]
XU182 INV1S $PINS O=n99 I=x_in[11]
XU183 INV1S $PINS O=n115 I=y_in[12]
XU184 INV1S $PINS O=n98 I=x_in[12]
XU185 INV1S $PINS O=n114 I=y_in[13]
XU186 INV1S $PINS O=n97 I=x_in[13]
XU187 INV1S $PINS O=n96 I=x_in[14]
XU188 INV1S $PINS O=n113 I=y_in[14]
XU189 INV1S $PINS O=n95 I=x_in[15]
XU190 INV1S $PINS O=n112 I=y_in[15]
XU191 INV1S $PINS O=n94 I=x_in[16]
XU192 INV1S $PINS O=n111 I=y_in[16]
XU199 NR2 $PINS O=n143 I1=n310 I2=step_cnt[3]
XU209 XOR2HS $PINS O=FE_PHN1333_N438 I1=FE_PHN1140_x_reg_17
+ I2=add_116/carry[17]
XU210 AN2 $PINS O=add_116/carry[17] I1=add_116/carry[16] I2=x_reg[16]
XU211 XOR2HS $PINS O=N437 I1=x_reg[16] I2=add_116/carry[16]
XU212 AN2 $PINS O=add_116/carry[16] I1=add_116/carry[15] I2=x_reg[15]
XU213 XOR2HS $PINS O=N436 I1=x_reg[15] I2=add_116/carry[15]
XU214 AN2 $PINS O=add_116/carry[15] I1=add_116/carry[14] I2=x_reg[14]
XU215 XOR2HS $PINS O=FE_PHN1308_N435 I1=x_reg[14] I2=add_116/carry[14]
XU216 AN2 $PINS O=add_116/carry[14] I1=add_116/carry[13] I2=FE_PHN1151_x_reg_13
XU217 XOR2HS $PINS O=N434 I1=FE_PHN1151_x_reg_13 I2=add_116/carry[13]
XU218 AN2 $PINS O=add_116/carry[13] I1=add_116/carry[12] I2=FE_PHN1109_x_reg_12
XU219 XOR2HS $PINS O=N433 I1=FE_PHN1109_x_reg_12 I2=add_116/carry[12]
XU220 AN2 $PINS O=add_116/carry[12] I1=add_116/carry[11] I2=FE_PHN1156_x_reg_11
XU221 XOR2HS $PINS O=FE_PHN1288_N432 I1=FE_PHN1156_x_reg_11
+ I2=add_116/carry[11]
XU222 AN2 $PINS O=add_116/carry[11] I1=add_116/carry[10] I2=x_reg[10]
XU223 XOR2HS $PINS O=N431 I1=x_reg[10] I2=add_116/carry[10]
XU224 AN2 $PINS O=add_116/carry[10] I1=add_116/carry[9] I2=x_reg[9]
XU225 XOR2HS $PINS O=N430 I1=x_reg[9] I2=add_116/carry[9]
XU226 AN2 $PINS O=add_116/carry[9] I1=add_116/carry[8] I2=x_reg[8]
XU227 XOR2HS $PINS O=N429 I1=x_reg[8] I2=add_116/carry[8]
XU228 AN2 $PINS O=add_116/carry[8] I1=add_116/carry[7] I2=x_reg[7]
XU229 XOR2HS $PINS O=N428 I1=x_reg[7] I2=add_116/carry[7]
XU230 AN2 $PINS O=add_116/carry[7] I1=add_116/carry[6] I2=x_reg[6]
XU231 XOR2HS $PINS O=N427 I1=x_reg[6] I2=add_116/carry[6]
XU232 AN2 $PINS O=add_116/carry[6] I1=FE_PHN1158_x_reg_4 I2=FE_PHN1154_x_reg_5
XU233 XOR2HS $PINS O=N426 I1=FE_PHN1154_x_reg_5 I2=FE_PHN1158_x_reg_4
XU234 XOR2HS $PINS O=FE_PHN1280_N451 I1=y_reg[17] I2=add_117/carry[17]
XU235 AN2 $PINS O=add_117/carry[17] I1=add_117/carry[16] I2=y_reg[16]
XU236 XOR2HS $PINS O=N450 I1=y_reg[16] I2=add_117/carry[16]
XU237 AN2 $PINS O=add_117/carry[16] I1=add_117/carry[15] I2=y_reg[15]
XU238 XOR2HS $PINS O=FE_PHN1304_N449 I1=y_reg[15] I2=add_117/carry[15]
XU239 AN2 $PINS O=add_117/carry[15] I1=add_117/carry[14] I2=y_reg[14]
XU240 XOR2HS $PINS O=FE_PHN1302_N448 I1=y_reg[14] I2=add_117/carry[14]
XU241 AN2 $PINS O=add_117/carry[14] I1=add_117/carry[13] I2=y_reg[13]
XU242 XOR2HS $PINS O=N447 I1=y_reg[13] I2=add_117/carry[13]
XU243 AN2 $PINS O=add_117/carry[13] I1=add_117/carry[12] I2=y_reg[12]
XU244 XOR2HS $PINS O=FE_PHN1286_N446 I1=y_reg[12] I2=add_117/carry[12]
XU245 AN2 $PINS O=add_117/carry[12] I1=add_117/carry[11] I2=y_reg[11]
XU246 XOR2HS $PINS O=N445 I1=y_reg[11] I2=add_117/carry[11]
XU247 AN2 $PINS O=add_117/carry[11] I1=add_117/carry[10] I2=y_reg[10]
XU248 XOR2HS $PINS O=N444 I1=y_reg[10] I2=add_117/carry[10]
XU249 AN2 $PINS O=add_117/carry[10] I1=add_117/carry[9] I2=y_reg[9]
XU250 XOR2HS $PINS O=N443 I1=y_reg[9] I2=add_117/carry[9]
XU251 AN2 $PINS O=add_117/carry[9] I1=add_117/carry[8] I2=y_reg[8]
XU252 XOR2HS $PINS O=N442 I1=y_reg[8] I2=add_117/carry[8]
XU253 AN2 $PINS O=add_117/carry[8] I1=add_117/carry[7] I2=y_reg[7]
XU254 XOR2HS $PINS O=N441 I1=y_reg[7] I2=add_117/carry[7]
XU255 AN2 $PINS O=add_117/carry[7] I1=add_117/carry[6] I2=y_reg[6]
XU256 XOR2HS $PINS O=N440 I1=y_reg[6] I2=add_117/carry[6]
XU257 AN2 $PINS O=add_117/carry[6] I1=y_reg[4] I2=y_reg[5]
XU258 XOR2HS $PINS O=N439 I1=y_reg[5] I2=y_reg[4]
XU259 XOR2HS $PINS O=N146 I1=n94 I2=sub_87/carry[16]
XU260 AN2 $PINS O=sub_87/carry[16] I1=sub_87/carry[15] I2=n95
XU261 XOR2HS $PINS O=N145 I1=n95 I2=sub_87/carry[15]
XU262 AN2 $PINS O=sub_87/carry[15] I1=sub_87/carry[14] I2=n96
XU263 XOR2HS $PINS O=N144 I1=n96 I2=sub_87/carry[14]
XU264 AN2 $PINS O=sub_87/carry[14] I1=sub_87/carry[13] I2=n97
XU265 XOR2HS $PINS O=N143 I1=n97 I2=sub_87/carry[13]
XU266 AN2 $PINS O=sub_87/carry[13] I1=sub_87/carry[12] I2=n98
XU267 XOR2HS $PINS O=N142 I1=n98 I2=sub_87/carry[12]
XU268 AN2 $PINS O=sub_87/carry[12] I1=sub_87/carry[11] I2=n99
XU269 XOR2HS $PINS O=N141 I1=n99 I2=sub_87/carry[11]
XU270 AN2 $PINS O=sub_87/carry[11] I1=sub_87/carry[10] I2=n100
XU271 XOR2HS $PINS O=N140 I1=n100 I2=sub_87/carry[10]
XU272 AN2 $PINS O=sub_87/carry[10] I1=sub_87/carry[9] I2=n101
XU273 XOR2HS $PINS O=N139 I1=n101 I2=sub_87/carry[9]
XU274 AN2 $PINS O=sub_87/carry[9] I1=sub_87/carry[8] I2=n102
XU275 XOR2HS $PINS O=N138 I1=n102 I2=sub_87/carry[8]
XU276 AN2 $PINS O=sub_87/carry[8] I1=sub_87/carry[7] I2=n103
XU277 XOR2HS $PINS O=N137 I1=n103 I2=sub_87/carry[7]
XU278 AN2 $PINS O=sub_87/carry[7] I1=sub_87/carry[6] I2=n104
XU279 XOR2HS $PINS O=N136 I1=n104 I2=sub_87/carry[6]
XU280 AN2 $PINS O=sub_87/carry[6] I1=sub_87/carry[5] I2=n105
XU281 XOR2HS $PINS O=N135 I1=n105 I2=sub_87/carry[5]
XU282 AN2 $PINS O=sub_87/carry[5] I1=sub_87/carry[4] I2=n106
XU283 XOR2HS $PINS O=N134 I1=n106 I2=sub_87/carry[4]
XU284 AN2 $PINS O=sub_87/carry[4] I1=sub_87/carry[3] I2=n107
XU285 XOR2HS $PINS O=N133 I1=n107 I2=sub_87/carry[3]
XU286 AN2 $PINS O=sub_87/carry[3] I1=sub_87/carry[2] I2=n108
XU287 XOR2HS $PINS O=N132 I1=n108 I2=sub_87/carry[2]
XU288 XOR2HS $PINS O=N131 I1=n109 I2=n110
XU289 XOR2HS $PINS O=N164 I1=n111 I2=sub_88/carry[16]
XU290 AN2 $PINS O=sub_88/carry[16] I1=sub_88/carry[15] I2=n112
XU291 XOR2HS $PINS O=N163 I1=n112 I2=sub_88/carry[15]
XU292 AN2 $PINS O=sub_88/carry[15] I1=sub_88/carry[14] I2=n113
XU293 XOR2HS $PINS O=N162 I1=n113 I2=sub_88/carry[14]
XU294 AN2 $PINS O=sub_88/carry[14] I1=sub_88/carry[13] I2=n114
XU295 XOR2HS $PINS O=N161 I1=n114 I2=sub_88/carry[13]
XU296 AN2 $PINS O=sub_88/carry[13] I1=sub_88/carry[12] I2=n115
XU297 XOR2HS $PINS O=N160 I1=n115 I2=sub_88/carry[12]
XU298 AN2 $PINS O=sub_88/carry[12] I1=sub_88/carry[11] I2=n116
XU299 XOR2HS $PINS O=N159 I1=n116 I2=sub_88/carry[11]
XU300 AN2 $PINS O=sub_88/carry[11] I1=sub_88/carry[10] I2=n117
XU301 XOR2HS $PINS O=N158 I1=n117 I2=sub_88/carry[10]
XU302 AN2 $PINS O=sub_88/carry[10] I1=sub_88/carry[9] I2=n118
XU303 XOR2HS $PINS O=N157 I1=n118 I2=sub_88/carry[9]
XU304 AN2 $PINS O=sub_88/carry[9] I1=sub_88/carry[8] I2=n119
XU305 XOR2HS $PINS O=N156 I1=n119 I2=sub_88/carry[8]
XU306 AN2 $PINS O=sub_88/carry[8] I1=sub_88/carry[7] I2=n120
XU307 XOR2HS $PINS O=N155 I1=n120 I2=sub_88/carry[7]
XU308 AN2 $PINS O=sub_88/carry[7] I1=sub_88/carry[6] I2=n121
XU309 XOR2HS $PINS O=N154 I1=n121 I2=sub_88/carry[6]
XU310 AN2 $PINS O=sub_88/carry[6] I1=sub_88/carry[5] I2=n122
XU311 XOR2HS $PINS O=N153 I1=n122 I2=sub_88/carry[5]
XU312 AN2 $PINS O=sub_88/carry[5] I1=sub_88/carry[4] I2=n123
XU313 XOR2HS $PINS O=N152 I1=n123 I2=sub_88/carry[4]
XU314 AN2 $PINS O=sub_88/carry[4] I1=sub_88/carry[3] I2=n124
XU315 XOR2HS $PINS O=N151 I1=n124 I2=sub_88/carry[3]
XU316 AN2 $PINS O=sub_88/carry[3] I1=sub_88/carry[2] I2=n125
XU317 XOR2HS $PINS O=N150 I1=n125 I2=sub_88/carry[2]
XU318 XOR2HS $PINS O=N149 I1=n126 I2=n127
XU319 ND3 $PINS O=y_shift[9] I1=n128 I2=n129 I3=n130
XU320 NR2 $PINS O=n130 I1=n131 I2=n132
XU321 MOAI1S $PINS O=n132 A1=n133 A2=FE_DBTN171_y_reg_10 B1=FE_OFN252_n443
+ B2=y_reg[11]
XU322 MOAI1S $PINS O=n131 A1=FE_OFN240_n135 A2=n136 B1=n41 B2=y_reg[9]
XU323 AOI22S $PINS O=n128 A1=y_reg[12] A2=n142 B1=y_reg[13] B2=FE_DBTN167_n143
XU324 ND3 $PINS O=y_shift[8] I1=n144 I2=n145 I3=n146
XU325 NR2 $PINS O=n146 I1=n147 I2=n148
XU326 MOAI1S $PINS O=n148 A1=n149 A2=n133 B1=n443 B2=y_reg[10]
XU327 OAI222S $PINS O=n147 A1=FE_OFN216_n41 A2=n150 B1=FE_DBTN174_y_reg_12
+ B2=FE_OFN169_n143 C1=n137 C2=FE_OFN240_n135
XU328 AOI22S $PINS O=n144 A1=n42 A2=y_reg[16] B1=y_reg[11] B2=n142
XU329 ND3 $PINS O=y_shift[7] I1=n155 I2=n156 I3=n157
XU330 NR2 $PINS O=n157 I1=n158 I2=n159
XU331 MOAI1S $PINS O=n159 A1=n133 A2=n150 B1=y_reg[9] B2=n443
XU332 OAI222S $PINS O=n158 A1=FE_OFN216_n41 A2=n160 B1=FE_OFN169_n143
+ B2=FE_DBTN176_y_reg_11 C1=n141 C2=FE_OFN240_n135
XU333 ND3 $PINS O=y_shift[6] I1=n166 I2=n167 I3=n168
XU334 NR2 $PINS O=n168 I1=n169 I2=n170
XU335 MOAI1S $PINS O=n170 A1=n133 A2=n160 B1=FE_OFN252_n443 B2=y_reg[8]
XU336 OAI222S $PINS O=n169 A1=FE_OFN216_n41 A2=n171 B1=FE_OFN169_n143
+ B2=FE_DBTN171_y_reg_10 C1=FE_DBTN173_y_reg_13 C2=FE_OFN240_n135
XU337 ND3 $PINS O=y_shift[5] I1=n172 I2=n173 I3=n174
XU338 NR2 $PINS O=n174 I1=n175 I2=n176
XU339 MOAI1S $PINS O=n176 A1=n133 A2=n171 B1=n443 B2=y_reg[7]
XU340 OAI222S $PINS O=n175 A1=FE_OFN216_n41 A2=n177 B1=FE_OFN169_n143 B2=n149
+ C1=FE_DBTN174_y_reg_12 C2=FE_OFN240_n135
XU341 ND3 $PINS O=y_shift[4] I1=n178 I2=n179 I3=n180
XU342 NR2 $PINS O=n180 I1=n181 I2=n182
XU343 MOAI1S $PINS O=n182 A1=n133 A2=n177 B1=n443 B2=y_reg[6]
XU344 OAI222S $PINS O=n181 A1=FE_OFN216_n41 A2=n183 B1=FE_OFN169_n143 B2=n150
+ C1=FE_OFN240_n135 C2=FE_DBTN176_y_reg_11
XU345 ND3 $PINS O=y_shift[3] I1=n184 I2=n185 I3=n186
XU346 NR2 $PINS O=n186 I1=n187 I2=n188
XU347 MOAI1S $PINS O=n188 A1=n133 A2=n183 B1=n443 B2=y_reg[5]
XU348 OAI222S $PINS O=n187 A1=FE_DBTN166_n41 A2=n189 B1=FE_OFN169_n143 B2=n160
+ C1=FE_OFN240_n135 C2=FE_DBTN171_y_reg_10
XU349 ND3 $PINS O=y_shift[2] I1=n190 I2=n191 I3=n192
XU350 NR2 $PINS O=n192 I1=n193 I2=n194
XU351 MOAI1S $PINS O=n194 A1=n133 A2=n189 B1=n443 B2=y_reg[4]
XU352 OAI222S $PINS O=n193 A1=FE_DBTN166_n41 A2=n195 B1=FE_OFN169_n143 B2=n171
+ C1=n149 C2=FE_OFN240_n135
XU353 ND3 $PINS O=y_shift[1] I1=n196 I2=n197 I3=n198
XU354 NR2 $PINS O=n198 I1=n199 I2=n200
XU355 MOAI1S $PINS O=n200 A1=n133 A2=n195 B1=n443 B2=y_reg[3]
XU357 INV1S $PINS O=n183 I=y_reg[4]
XU358 MOAI1S $PINS O=y_shift[16] A1=FE_OFN216_n41 A2=n136 B1=y_reg[17] B2=n201
XU359 OAI222S $PINS O=y_shift[15] A1=n137 A2=FE_OFN216_n41 B1=n202 B2=n139
+ C1=n136 C2=n133
XU360 ND2 $PINS O=y_shift[14] I1=n203 I2=n204
XU361 AOI22S $PINS O=n204 A1=y_reg[17] A2=n205 B1=FE_OFN215_n41 B2=y_reg[14]
XU362 AOI22S $PINS O=n203 A1=FE_OFN252_n443 A2=y_reg[16] B1=n48 B2=y_reg[15]
XU363 ND2 $PINS O=y_shift[13] I1=n206 I2=n207
XU364 AOI22S $PINS O=n206 A1=FE_OFN252_n443 A2=y_reg[15] B1=n48 B2=y_reg[14]
XU365 ND2 $PINS O=y_shift[12] I1=n209 I2=n210
XU366 INV1S $PINS O=n137 I=y_reg[15]
XU367 INV1S $PINS O=n139 I=y_reg[17]
XU368 INV1S $PINS O=n136 I=y_reg[16]
XU369 OA222 $PINS O=n209 A1=FE_DBTN173_y_reg_13 A2=n133 B1=FE_DBTN174_y_reg_12
+ B2=FE_OFN216_n41 C1=n141 C2=n212
XU370 INV1S $PINS O=n141 I=y_reg[14]
XU371 ND3 $PINS O=y_shift[11] I1=n213 I2=n214 I3=n215
XU372 AOI22S $PINS O=n214 A1=y_reg[17] A2=n216 B1=y_reg[16] B2=FE_OFN207_n217
XU373 AOI22S $PINS O=n213 A1=n142 A2=y_reg[14] B1=FE_DBTN167_n143 B2=y_reg[15]
XU374 ND3 $PINS O=y_shift[10] I1=n218 I2=n219 I3=n220
XU375 NR2 $PINS O=n220 I1=n221 I2=n222
XU376 MOAI1S $PINS O=n222 A1=FE_DBTN176_y_reg_11 A2=n133 B1=y_reg[12]
+ B2=FE_OFN252_n443
XU377 MOAI1S $PINS O=n221 A1=FE_OFN216_n41 A2=FE_DBTN171_y_reg_10 B1=y_reg[14]
+ B2=FE_DBTN167_n143
XU378 AOI22S $PINS O=n219 A1=y_reg[17] A2=n223 B1=y_reg[15] B2=FE_OFN207_n217
XU379 AOI22S $PINS O=n218 A1=y_reg[16] A2=n224 B1=y_reg[13] B2=n142
XU380 ND3 $PINS O=y_shift[0] I1=n225 I2=n226 I3=n227
XU381 NR2 $PINS O=n227 I1=n228 I2=n229
XU382 MOAI1S $PINS O=n229 A1=n212 A2=n195 B1=n48 B2=y_reg[1]
XU383 INV1S $PINS O=n195 I=y_reg[2]
XU384 OA222 $PINS O=n226 A1=FE_OFN236_n162 A2=n150 B1=n140 B2=n177
+ C1=FE_DBTN168_n224 C2=n171
XU386 INV1S $PINS O=n177 I=y_reg[5]
XU389 INV1S $PINS O=n189 I=y_reg[3]
XU390 ND3 $PINS O=x_shift[9] I1=n230 I2=n231 I3=n232
XU391 NR2 $PINS O=n232 I1=n233 I2=n234
XU392 MOAI1S $PINS O=n234 A1=n133 A2=FE_DBTN170_x_reg_10 B1=FE_OFN252_n443
+ B2=FE_PHN1156_x_reg_11
XU393 MOAI1S $PINS O=n233 A1=FE_OFN240_n135 A2=n236 B1=n41 B2=x_reg[9]
XU394 AOI22S $PINS O=n230 A1=x_reg[12] A2=n142 B1=FE_PHN1151_x_reg_13
+ B2=FE_DBTN167_n143
XU395 ND3 $PINS O=x_shift[8] I1=n240 I2=n241 I3=n242
XU396 NR2 $PINS O=n242 I1=n243 I2=n244
XU397 MOAI1S $PINS O=n244 A1=n133 A2=n245 B1=n443 B2=x_reg[10]
XU398 OAI222S $PINS O=n243 A1=FE_DBTN166_n41 A2=FE_OFN224_x_reg_8
+ B1=FE_OFN169_n143 B2=FE_DBTN175_x_reg_12 C1=FE_OFN240_n135 C2=n237
XU399 AOI22S $PINS O=n240 A1=x_reg[16] A2=n42 B1=FE_PHN1156_x_reg_11 B2=n142
XU400 ND3 $PINS O=x_shift[7] I1=n249 I2=n250 I3=n251
XU401 NR2 $PINS O=n251 I1=n252 I2=n253
XU402 MOAI1S $PINS O=n253 A1=n133 A2=FE_OFN224_x_reg_8 B1=n443 B2=x_reg[9]
XU403 OAI222S $PINS O=n252 A1=FE_DBTN166_n41 A2=n254 B1=FE_OFN169_n143
+ B2=FE_DBTN177_x_reg_11 C1=FE_OFN240_n135 C2=n239
XU404 ND3 $PINS O=x_shift[6] I1=n256 I2=n257 I3=n258
XU405 NR2 $PINS O=n258 I1=n259 I2=n260
XU406 MOAI1S $PINS O=n260 A1=n133 A2=n254 B1=n443 B2=x_reg[8]
XU407 OAI222S $PINS O=n259 A1=FE_DBTN166_n41 A2=n261 B1=FE_OFN169_n143
+ B2=FE_DBTN170_x_reg_10 C1=FE_OFN240_n135 C2=FE_DBTN172_x_reg_13
XU408 ND3 $PINS O=x_shift[5] I1=n262 I2=n263 I3=n264
XU409 NR2 $PINS O=n264 I1=n265 I2=n266
XU410 MOAI1S $PINS O=n266 A1=n133 A2=n261 B1=n443 B2=x_reg[7]
XU411 OAI222S $PINS O=n265 A1=FE_DBTN166_n41 A2=n267 B1=FE_OFN169_n143 B2=n245
+ C1=FE_OFN240_n135 C2=FE_DBTN175_x_reg_12
XU412 ND3 $PINS O=x_shift[4] I1=n268 I2=n269 I3=n270
XU413 NR2 $PINS O=n270 I1=n271 I2=n272
XU414 MOAI1S $PINS O=n272 A1=n133 A2=n267 B1=n443 B2=x_reg[6]
XU415 OAI222S $PINS O=n271 A1=FE_DBTN166_n41 A2=n273 B1=FE_OFN169_n143
+ B2=FE_OFN224_x_reg_8 C1=FE_OFN240_n135 C2=FE_DBTN177_x_reg_11
XU416 ND3 $PINS O=x_shift[3] I1=n274 I2=n275 I3=n276
XU417 NR2 $PINS O=n276 I1=n277 I2=n278
XU418 MOAI1S $PINS O=n278 A1=n133 A2=n273 B1=n443 B2=FE_PHN1154_x_reg_5
XU419 OAI222S $PINS O=n277 A1=FE_DBTN166_n41 A2=n279 B1=FE_OFN169_n143 B2=n254
+ C1=FE_OFN240_n135 C2=FE_DBTN170_x_reg_10
XU420 ND3 $PINS O=x_shift[2] I1=n280 I2=n281 I3=n282
XU421 NR2 $PINS O=n282 I1=n283 I2=n284
XU422 MOAI1S $PINS O=n284 A1=n133 A2=n279 B1=n443 B2=FE_PHN1158_x_reg_4
XU423 OAI222S $PINS O=n283 A1=FE_DBTN166_n41 A2=n285 B1=FE_OFN169_n143 B2=n261
+ C1=FE_OFN240_n135 C2=n245
XU424 ND3 $PINS O=x_shift[1] I1=n286 I2=n287 I3=n288
XU425 NR2 $PINS O=n288 I1=n289 I2=n290
XU426 MOAI1S $PINS O=n290 A1=n133 A2=n285 B1=n443 B2=x_reg[3]
XU428 INV1S $PINS O=n273 I=FE_PHN1158_x_reg_4
XU429 MOAI1S $PINS O=x_shift[16] A1=FE_OFN216_n41 A2=n236
+ B1=FE_PHN1140_x_reg_17 B2=n201
XU430 ND2 $PINS O=n201 I1=n202 I2=n133
XU431 OAI222S $PINS O=x_shift[15] A1=FE_DBTN166_n41 A2=n237 B1=n202 B2=n238
+ C1=n133 C2=n236
XU432 NR2 $PINS O=n202 I1=n205 I2=FE_OFN252_n443
XU433 ND2 $PINS O=x_shift[14] I1=n291 I2=n292
XU434 AOI22S $PINS O=n292 A1=FE_PHN1140_x_reg_17 A2=n205 B1=x_reg[14]
+ B2=FE_OFN215_n41
XU435 ND2 $PINS O=n205 I1=n208 I2=FE_OFN234_n163
XU436 AOI22S $PINS O=n291 A1=x_reg[16] A2=FE_OFN252_n443 B1=x_reg[15] B2=n48
XU437 ND2 $PINS O=x_shift[13] I1=n293 I2=n294
XU438 AN2 $PINS O=n208 I1=n211 I2=FE_OFN169_n143
XU439 AOI22S $PINS O=n293 A1=x_reg[15] A2=n443 B1=x_reg[14] B2=n48
XU440 ND2 $PINS O=x_shift[12] I1=n295 I2=n296
XU441 INV1S $PINS O=n237 I=x_reg[15]
XU442 INV1S $PINS O=n238 I=FE_PHN1140_x_reg_17
XU443 NR2 $PINS O=n211 I1=n216 I2=FE_OFN208_n217
XU444 INV1S $PINS O=n236 I=x_reg[16]
XU445 OA222 $PINS O=n295 A1=n133 A2=FE_DBTN172_x_reg_13 B1=FE_DBTN166_n41
+ B2=FE_DBTN175_x_reg_12 C1=n212 C2=n239
XU446 INV1S $PINS O=n239 I=x_reg[14]
XU447 ND3 $PINS O=x_shift[11] I1=n297 I2=n298 I3=n299
XU448 AOI22S $PINS O=n298 A1=FE_PHN1140_x_reg_17 A2=n216 B1=x_reg[16]
+ B2=FE_OFN206_n217
XU449 OR2 $PINS O=n216 I1=n223 I2=n224
XU450 AOI22S $PINS O=n297 A1=x_reg[14] A2=n142 B1=x_reg[15] B2=FE_DBTN167_n143
XU451 ND3 $PINS O=x_shift[10] I1=n300 I2=n301 I3=n302
XU452 NR2 $PINS O=n302 I1=n303 I2=n304
XU453 MOAI1S $PINS O=n304 A1=n133 A2=FE_DBTN177_x_reg_11 B1=FE_OFN252_n443
+ B2=x_reg[12]
XU454 MOAI1S $PINS O=n303 A1=FE_OFN216_n41 A2=FE_DBTN170_x_reg_10
+ B1=FE_DBTN167_n143 B2=x_reg[14]
XU455 AOI22S $PINS O=n301 A1=FE_PHN1140_x_reg_17 A2=n223 B1=x_reg[15]
+ B2=FE_OFN207_n217
XU456 ND2 $PINS O=n223 I1=n138 I2=FE_OFN240_n135
XU457 AN2 $PINS O=n138 I1=n153 I2=FE_OFN236_n162
XU458 AOI22S $PINS O=n300 A1=x_reg[16] A2=n224 B1=FE_PHN1151_x_reg_13 B2=n142
XU459 INV1S $PINS O=n142 I=FE_OFN234_n163
XU460 ND3 $PINS O=x_shift[0] I1=n305 I2=n306 I3=n307
XU461 NR2 $PINS O=n307 I1=n308 I2=n309
XU462 MOAI1S $PINS O=n309 A1=n212 A2=n285 B1=n48 B2=x_reg[1]
XU463 INV1S $PINS O=n285 I=x_reg[2]
XU464 OA222 $PINS O=n306 A1=FE_OFN236_n162 A2=FE_OFN224_x_reg_8 B1=n140 B2=n267
+ C1=FE_DBTN168_n224 C2=n261
XU465 INV1S $PINS O=n261 I=x_reg[6]
XU466 NR2P $PINS O=n224 I1=n311 I2=step_cnt[3]
XU467 INV1S $PINS O=n267 I=FE_PHN1154_x_reg_5
XU468 NR2 $PINS O=n217 I1=n312 I2=step_cnt[3]
XU470 OA222 $PINS O=n305 A1=FE_OFN234_n163 A2=n279 B1=n164
+ B2=FE_DBTN170_x_reg_10 C1=FE_DBTN169_n165 C2=n245
XU472 INV1S $PINS O=n279 I=x_reg[3]
XU473 AO22 $PINS O=FE_PHN1335_n434 A1=N314 A2=n318 B1=N366 B2=FE_OFN37_n319
XU474 AO22 $PINS O=n435 A1=N313 A2=n318 B1=N365 B2=FE_OFN37_n319
XU475 AO22 $PINS O=FE_PHN1344_n436 A1=N312 A2=n318 B1=N364 B2=FE_OFN37_n319
XU476 AO22 $PINS O=n437 A1=N311 A2=n318 B1=N363 B2=FE_OFN37_n319
XU477 AO22 $PINS O=FE_PHN1343_n438 A1=N310 A2=n318 B1=N362 B2=FE_OFN37_n319
XU478 AO22 $PINS O=n439 A1=N309 A2=n318 B1=N361 B2=FE_OFN37_n319
XU479 AO22 $PINS O=n440 A1=N308 A2=n318 B1=N360 B2=FE_OFN37_n319
XU480 AO22 $PINS O=FE_PHN1319_n441 A1=N307 A2=n318 B1=FE_PHN1477_N359
+ B2=FE_OFN37_n319
XU481 AO22 $PINS O=n442 A1=N306 A2=n318 B1=N358 B2=FE_OFN37_n319
XU482 NR3 $PINS O=N515 I1=n320 I2=n317 I3=n321
XU483 ND2 $PINS O=N514 I1=n322 I2=n323
XU484 AOI22S $PINS O=n323 A1=N357 A2=n319 B1=N305 B2=n318
XU485 AOI22S $PINS O=n322 A1=y_in[16] A2=n324 B1=N165 B2=FE_OFN36_n4
XU486 ND2 $PINS O=N513 I1=n325 I2=n326
XU487 AOI22S $PINS O=n326 A1=N356 A2=n319 B1=N304 B2=n318
XU488 AOI22S $PINS O=n325 A1=y_in[16] A2=n324 B1=N164 B2=FE_OFN36_n4
XU489 ND2 $PINS O=N512 I1=n327 I2=n328
XU490 AOI22S $PINS O=n328 A1=N355 A2=n319 B1=N303 B2=n318
XU491 AOI22S $PINS O=n327 A1=FE_PHN1329_c_in_i_0_15 A2=n324 B1=N163
+ B2=FE_OFN36_n4
XU492 ND2 $PINS O=N511 I1=n329 I2=n330
XU493 AOI22S $PINS O=n330 A1=N354 A2=n319 B1=N302 B2=n318
XU494 AOI22S $PINS O=n329 A1=FE_PHN1363_c_in_i_0_14 A2=n324 B1=N162
+ B2=FE_OFN36_n4
XU495 ND2 $PINS O=N510 I1=n331 I2=n332
XU496 AOI22S $PINS O=n332 A1=N353 A2=n319 B1=N301 B2=n318
XU497 AOI22S $PINS O=n331 A1=FE_PHN1365_c_in_i_0_13 A2=n324 B1=N161
+ B2=FE_OFN36_n4
XU498 ND2 $PINS O=N509 I1=n333 I2=n334
XU499 AOI22S $PINS O=n334 A1=N352 A2=n319 B1=N300 B2=n318
XU500 AOI22S $PINS O=n333 A1=y_in[12] A2=n324 B1=N160 B2=FE_OFN36_n4
XU501 ND2 $PINS O=N508 I1=n335 I2=n336
XU502 AOI22S $PINS O=n336 A1=N351 A2=n319 B1=N299 B2=n318
XU503 AOI22S $PINS O=n335 A1=FE_PHN1326_c_in_i_0_11 A2=n324 B1=N159
+ B2=FE_OFN36_n4
XU504 ND2 $PINS O=N507 I1=n337 I2=n338
XU505 AOI22S $PINS O=n338 A1=N350 A2=n319 B1=N298 B2=n318
XU506 AOI22S $PINS O=n337 A1=y_in[10] A2=n324 B1=N158 B2=FE_OFN36_n4
XU507 ND2 $PINS O=N506 I1=n339 I2=n340
XU508 AOI22S $PINS O=n340 A1=N349 A2=n319 B1=N297 B2=n61
XU509 AOI22S $PINS O=n339 A1=y_in[9] A2=n324 B1=N157 B2=FE_OFN36_n4
XU510 ND2 $PINS O=N505 I1=n341 I2=n342
XU511 AOI22S $PINS O=n342 A1=N348 A2=n319 B1=N296 B2=n318
XU512 AOI22S $PINS O=n341 A1=y_in[8] A2=n324 B1=N156 B2=FE_OFN36_n4
XU513 ND2 $PINS O=N504 I1=n343 I2=n344
XU514 AOI22S $PINS O=n344 A1=N347 A2=n319 B1=N295 B2=n318
XU515 AOI22S $PINS O=n343 A1=y_in[7] A2=n324 B1=N155 B2=FE_OFN36_n4
XU516 ND2 $PINS O=N503 I1=n345 I2=n346
XU517 AOI22S $PINS O=n346 A1=N346 A2=n319 B1=N294 B2=n61
XU518 AOI22S $PINS O=n345 A1=y_in[6] A2=n324 B1=N154 B2=FE_OFN36_n4
XU519 ND2 $PINS O=N502 I1=n347 I2=n348
XU520 AOI22S $PINS O=n348 A1=N345 A2=n319 B1=N293 B2=n61
XU521 AOI22S $PINS O=n347 A1=y_in[5] A2=n324 B1=N153 B2=FE_OFN36_n4
XU522 ND2 $PINS O=N501 I1=n349 I2=n350
XU523 AOI22S $PINS O=n350 A1=N344 A2=n319 B1=N292 B2=n318
XU524 AOI22S $PINS O=n349 A1=y_in[4] A2=n324 B1=N152 B2=FE_OFN36_n4
XU525 ND2 $PINS O=N500 I1=n351 I2=n352
XU526 AOI22S $PINS O=n352 A1=N343 A2=n319 B1=N291 B2=n61
XU527 AOI22S $PINS O=n351 A1=y_in[3] A2=n324 B1=N151 B2=FE_OFN36_n4
XU528 ND2 $PINS O=N499 I1=n353 I2=n354
XU529 AOI22S $PINS O=n354 A1=N342 A2=n319 B1=N290 B2=n318
XU530 AOI22S $PINS O=n353 A1=y_in[2] A2=n324 B1=N150 B2=FE_OFN36_n4
XU531 ND2 $PINS O=FE_PHN1436_N498 I1=n355 I2=n356
XU532 AOI22S $PINS O=n356 A1=N341 A2=n319 B1=N289 B2=n318
XU533 AOI22S $PINS O=n355 A1=y_in[1] A2=n324 B1=N149 B2=FE_OFN36_n4
XU534 ND2 $PINS O=N497 I1=n357 I2=n358
XU535 AOI22S $PINS O=n358 A1=N340 A2=n319 B1=N288 B2=n61
XU536 AOI22S $PINS O=n357 A1=FE_PHN1407_c_in_i_0_0 A2=n324
+ B1=FE_PHN1407_c_in_i_0_0 B2=FE_OFN36_n4
XU537 ND2 $PINS O=N496 I1=n359 I2=n360
XU538 AOI22S $PINS O=n360 A1=N339 A2=FE_OFN37_n319 B1=N287 B2=n61
XU539 AOI22S $PINS O=n359 A1=x_in[16] A2=n324 B1=N147 B2=FE_OFN36_n4
XU540 ND2 $PINS O=N495 I1=n361 I2=n362
XU541 AOI22S $PINS O=n362 A1=N338 A2=FE_OFN37_n319 B1=N286 B2=n61
XU542 AOI22S $PINS O=n361 A1=x_in[16] A2=n324 B1=N146 B2=FE_OFN36_n4
XU543 ND2 $PINS O=N494 I1=n363 I2=n364
XU544 AOI22S $PINS O=n364 A1=N337 A2=FE_OFN37_n319 B1=N285 B2=n61
XU545 AOI22S $PINS O=n363 A1=x_in[15] A2=n324 B1=N145 B2=FE_OFN36_n4
XU546 ND2 $PINS O=N493 I1=FE_PHN1466_n365 I2=n366
XU547 AOI22S $PINS O=n366 A1=N336 A2=FE_OFN37_n319 B1=N284 B2=n61
XU548 AOI22S $PINS O=n365 A1=x_in[14] A2=n324 B1=N144 B2=FE_OFN36_n4
XU549 ND2 $PINS O=N492 I1=n367 I2=n368
XU550 AOI22S $PINS O=n368 A1=N335 A2=FE_OFN37_n319 B1=N283 B2=n61
XU551 AOI22S $PINS O=n367 A1=x_in[13] A2=n324 B1=N143 B2=FE_OFN36_n4
XU552 ND2 $PINS O=N491 I1=n369 I2=n370
XU553 AOI22S $PINS O=n370 A1=N334 A2=FE_OFN37_n319 B1=N282 B2=n61
XU554 AOI22S $PINS O=n369 A1=x_in[12] A2=n324 B1=N142 B2=FE_OFN36_n4
XU555 ND2 $PINS O=N490 I1=n371 I2=n372
XU556 AOI22S $PINS O=n372 A1=N333 A2=FE_OFN37_n319 B1=N281 B2=n61
XU557 AOI22S $PINS O=n371 A1=x_in[11] A2=n324 B1=N141 B2=FE_OFN36_n4
XU558 ND2 $PINS O=N489 I1=n373 I2=n374
XU559 AOI22S $PINS O=n374 A1=N332 A2=FE_OFN37_n319 B1=N280 B2=n61
XU560 AOI22S $PINS O=n373 A1=x_in[10] A2=n324 B1=N140 B2=FE_OFN36_n4
XU561 ND2 $PINS O=N488 I1=n375 I2=n376
XU562 AOI22S $PINS O=n376 A1=N331 A2=FE_OFN37_n319 B1=N279 B2=n61
XU563 AOI22S $PINS O=n375 A1=x_in[9] A2=n324 B1=N139 B2=FE_OFN36_n4
XU564 ND2 $PINS O=N487 I1=n377 I2=n378
XU565 AOI22S $PINS O=n378 A1=N330 A2=FE_OFN37_n319 B1=N278 B2=n318
XU566 AOI22S $PINS O=n377 A1=x_in[8] A2=n324 B1=N138 B2=FE_OFN36_n4
XU567 ND2 $PINS O=N486 I1=n379 I2=n380
XU568 AOI22S $PINS O=n380 A1=N329 A2=FE_OFN37_n319 B1=N277 B2=n318
XU569 AOI22S $PINS O=n379 A1=x_in[7] A2=n324 B1=N137 B2=FE_OFN36_n4
XU570 ND2 $PINS O=N485 I1=n381 I2=n382
XU571 AOI22S $PINS O=n382 A1=N328 A2=FE_OFN37_n319 B1=N276 B2=n318
XU572 AOI22S $PINS O=n381 A1=x_in[6] A2=n324 B1=N136 B2=FE_OFN36_n4
XU573 ND2 $PINS O=N484 I1=n383 I2=n384
XU574 AOI22S $PINS O=n384 A1=N327 A2=n319 B1=N275 B2=n318
XU575 AOI22S $PINS O=n383 A1=x_in[5] A2=n324 B1=N135 B2=FE_OFN36_n4
XU576 ND2 $PINS O=N483 I1=n385 I2=n386
XU577 AOI22S $PINS O=n386 A1=N326 A2=n319 B1=N274 B2=n318
XU578 AOI22S $PINS O=n385 A1=x_in[4] A2=n324 B1=N134 B2=FE_OFN36_n4
XU579 ND2 $PINS O=FE_PHN1417_N482 I1=n387 I2=n388
XU580 AOI22S $PINS O=n388 A1=N325 A2=n319 B1=N273 B2=n318
XU581 AOI22S $PINS O=n387 A1=x_in[3] A2=n324 B1=N133 B2=FE_OFN36_n4
XU582 ND2 $PINS O=N481 I1=n389 I2=n390
XU583 AOI22S $PINS O=n390 A1=N324 A2=n319 B1=N272 B2=n318
XU584 AOI22S $PINS O=n389 A1=x_in[2] A2=n324 B1=N132 B2=FE_OFN36_n4
XU585 ND2 $PINS O=N480 I1=n391 I2=n392
XU586 AOI22S $PINS O=n392 A1=N323 A2=n319 B1=N271 B2=n318
XU587 AOI22S $PINS O=n391 A1=x_in[1] A2=n324 B1=N131 B2=FE_OFN36_n4
XU588 ND2 $PINS O=N479 I1=n393 I2=FE_PHN1287_n394
XU589 AOI22S $PINS O=n394 A1=N322 A2=n319 B1=N270 B2=n61
XU590 AOI22S $PINS O=n393 A1=N130 A2=n324 B1=N130 B2=FE_OFN36_n4
XU591 INV2 $PINS O=n324 I=n395
XU592 OAI112HS $PINS O=N478 A1=FE_PHN1321_n397 B1=n398 C1=n396 C2=n395
XU593 AOI22S $PINS O=n398 A1=n396 A2=n399 B1=n396 B2=n400
XU594 AOI22S $PINS O=n397 A1=N373 A2=FE_OFN37_n319 B1=N321 B2=n61
XU595 OAI112HS $PINS O=N477 A1=n402 B1=n403 C1=n401 C2=n395
XU596 AOI22S $PINS O=n403 A1=N182 A2=n399 B1=N182 B2=n400
XU597 AOI22S $PINS O=FE_PHN1306_n402 A1=N372 A2=FE_OFN37_n319 B1=N320 B2=n61
XU598 OAI112HS $PINS O=N476 A1=n405 B1=n406 C1=n395 C2=n404
XU599 AOI22S $PINS O=n406 A1=N181 A2=n399 B1=N181 B2=n400
XU600 AOI22S $PINS O=n405 A1=N371 A2=FE_OFN37_n319 B1=N319 B2=n61
XU601 INV1S $PINS O=n404 I=N181
XU602 OAI112HS $PINS O=N475 A1=n408 B1=n409 C1=n395 C2=n407
XU603 AOI22S $PINS O=n409 A1=N180 A2=n399 B1=N180 B2=n400
XU604 AOI22S $PINS O=n408 A1=N370 A2=FE_OFN37_n319 B1=N318 B2=n61
XU605 INV1S $PINS O=n407 I=N180
XU606 OAI112HS $PINS O=N474 A1=n411 B1=n412 C1=n395 C2=n410
XU607 AOI22S $PINS O=n412 A1=N179 A2=n399 B1=N179 B2=n400
XU608 AOI22S $PINS O=n411 A1=N369 A2=FE_OFN37_n319 B1=N317 B2=n61
XU609 OAI112HS $PINS O=N473 A1=FE_PHN1327_n414 B1=n415 C1=n395 C2=n413
XU610 AOI22S $PINS O=n415 A1=N178 A2=n399 B1=N178 B2=n400
XU611 AOI22S $PINS O=n414 A1=N368 A2=FE_OFN37_n319 B1=N316 B2=n61
XU612 OAI112HS $PINS O=N472 A1=FE_PHN1339_n417 B1=n418 C1=n395 C2=p1
XU613 AOI22S $PINS O=n418 A1=N177 A2=n399 B1=N177 B2=n400
XU614 AN2 $PINS O=n400 I1=n4 I2=phase_in[15]
XU615 AN2 $PINS O=n399 I1=n4 I2=n396
XU616 AOI22S $PINS O=n417 A1=N367 A2=FE_OFN37_n319 B1=N315 B2=n61
XU617 NR2P $PINS O=n318 I1=n320 I2=z_reg[15]
XU618 AN2 $PINS O=n319 I1=z_reg[15] I2=is_computing
XU620 OR3B2 $PINS O=n395 I1=n421 B1=n420 B2=n419
XU621 ND2 $PINS O=n419 I1=phase_in[15] I2=n401
XU622 INV1S $PINS O=n401 I=N182
XU623 ND3 $PINS O=n420 I1=n422 I2=n396 I3=N182
XU624 INV1S $PINS O=n396 I=phase_in[15]
XU625 ND3 $PINS O=n422 I1=n413 I2=n410 I3=n423
XU626 NR3 $PINS O=n423 I1=N180 I2=N177 I3=N181
XU627 INV1S $PINS O=n410 I=N179
XU628 INV1S $PINS O=n413 I=N178
XU629 ND2 $PINS O=N462 I1=n320 I2=n421
XU630 MOAI1S $PINS O=N461 A1=n424 A2=n317 B1=is_computing B2=FE_OFN238_n135
XU631 NR2 $PINS O=n425 I1=step_cnt[3] I2=n314
XU632 OAI22S $PINS O=N460 A1=n426 A2=n315 B1=n321 B2=n320
XU633 MOAI1S $PINS O=N459 A1=n314 A2=n427 B1=n316 B2=is_computing
XU634 INV1S $PINS O=N458 I=n427
XU635 ND2 $PINS O=FE_PHN1408_N457 I1=n421 I2=n429
XU636 OAI12HS $PINS O=n429 A1=is_computing B1=n317 B2=n321
XU637 ND2 $PINS O=n421 I1=valid_in I2=n320
XU638 INV1S $PINS O=n320 I=is_computing
XU639 ND3 $PINS O=N118 I1=n430 I2=n431 I3=n432
XU640 AN2 $PINS O=n432 I1=n321 I2=n310
XU641 OAI112HS $PINS O=N117 A1=n312 B1=n433 C1=n314 C2=n317
XU642 AN3 $PINS O=n433 I1=n310 I2=n212 I3=n311
XU643 OAI112HS $PINS O=N116 A1=n312 B1=n133 C1=n317 C2=n428
XU644 OAI112HS $PINS O=N115 A1=n310 B1=n212 C1=n316 C2=n317
XU645 OAI112HS $PINS O=N114 A1=n321 B1=n430 C1=n317 C2=n428
XU646 OA13S $PINS O=n431 A1=n311 B1=step_cnt[0] B2=step_cnt[1] B3=n317
XU647 AOI13HS $PINS O=n430 A1=FE_OFN108_n212 B1=step_cnt[0] B2=step_cnt[1]
+ B3=step_cnt[2]
XU649 OR3B2 $PINS O=N111 I1=N109 B1=n212 B2=n311
XU650 ND3 $PINS O=N110 I1=n212 I2=FE_OFN209_n321 I3=n312
XU651 NR2 $PINS O=n313 I1=step_cnt[2] I2=step_cnt[0]
XU652 NR2P $PINS O=n316 I1=n428 I2=step_cnt[1]
XU654 INV1S $PINS O=n315 I=step_cnt[2]
Xclk_gate_y_reg_reg SNPS_CLOCK_GATE_HIGH_cordic_rotation_1_0 $PINS EN=N462
+ ENCLK=CTS_42 CLK=clk_clone2
Xclk_gate_z_reg_reg SNPS_CLOCK_GATE_HIGH_cordic_rotation_1_4 $PINS EN=N462
+ ENCLK=CTS_39 CLK=clk_clone2
Xclk_gate_y_out_reg SNPS_CLOCK_GATE_HIGH_cordic_rotation_1_3 $PINS EN=N515
+ ENCLK=CTS_48 CLK=clk_clone1
Xclk_gate_x_out_reg SNPS_CLOCK_GATE_HIGH_cordic_rotation_1_2 $PINS EN=N515
+ ENCLK=CTS_45 CLK=clk_clone1
Xclk_gate_step_cnt_reg SNPS_CLOCK_GATE_HIGH_cordic_rotation_1_1 $PINS EN=N457
+ ENCLK=net2420 CLK=clk_clone3
Xadd_105 cordic_rotation_1_DW01_add_2_DW01_add_8 $PINS A[15]=z_reg[15]
+ A[14]=FE_PHN1053_z_reg_14 A[13]=FE_PHN1067_z_reg_13 A[12]=z_reg[12]
+ A[11]=z_reg[11] A[10]=z_reg[10] A[9]=z_reg[9] A[8]=z_reg[8] A[7]=z_reg[7]
+ A[6]=z_reg[6] A[5]=z_reg[5] A[4]=z_reg[4] A[3]=z_reg[3] A[2]=z_reg[2]
+ A[1]=z_reg[1] A[0]=z_reg[0] B[15]=n8 B[14]=n8 B[13]=FE_OFN215_n41 B[12]=n48
+ B[11]=FE_OFN108_n212 B[10]=N108 B[9]=N109 B[8]=N110 B[7]=N111 B[6]=N112
+ B[5]=N113 B[4]=N114 B[3]=N115 B[2]=N116 B[1]=N117 B[0]=N118 CI=n8 SUM[15]=N373
+ SUM[14]=N372 SUM[13]=N371 SUM[12]=N370 SUM[11]=N369 SUM[10]=N368 SUM[9]=N367
+ SUM[8]=N366 SUM[7]=N365 SUM[6]=N364 SUM[5]=N363 SUM[4]=N362 SUM[3]=N361
+ SUM[2]=N360 SUM[1]=N359 SUM[0]=N358
Xsub_104 cordic_rotation_1_DW01_sub_0_DW01_sub_34 $PINS A[17]=y_reg[17]
+ A[16]=y_reg[16] A[15]=y_reg[15] A[14]=y_reg[14] A[13]=y_reg[13] A[12]=y_reg[12]
+ A[11]=y_reg[11] A[10]=y_reg[10] A[9]=y_reg[9] A[8]=y_reg[8] A[7]=y_reg[7]
+ A[6]=y_reg[6] A[5]=y_reg[5] A[4]=y_reg[4] A[3]=y_reg[3] A[2]=y_reg[2]
+ A[1]=y_reg[1] A[0]=y_reg[0] B[17]=x_shift[16] B[16]=x_shift[16]
+ B[15]=x_shift[15] B[14]=x_shift[14] B[13]=x_shift[13] B[12]=x_shift[12]
+ B[11]=x_shift[11] B[10]=x_shift[10] B[9]=x_shift[9] B[8]=x_shift[8]
+ B[7]=x_shift[7] B[6]=x_shift[6] B[5]=x_shift[5] B[4]=x_shift[4] B[3]=x_shift[3]
+ B[2]=x_shift[2] B[1]=x_shift[1] B[0]=x_shift[0] CI=n8 DIFF[17]=N357
+ DIFF[16]=N356 DIFF[15]=N355 DIFF[14]=N354 DIFF[13]=N353 DIFF[12]=N352
+ DIFF[11]=N351 DIFF[10]=N350 DIFF[9]=N349 DIFF[8]=N348 DIFF[7]=N347 DIFF[6]=N346
+ DIFF[5]=N345 DIFF[4]=N344 DIFF[3]=N343 DIFF[2]=N342 DIFF[1]=N341 DIFF[0]=N340
Xadd_103 cordic_rotation_1_DW01_add_3_DW01_add_9 $PINS
+ A[17]=FE_PHN1140_x_reg_17 A[16]=x_reg[16] A[15]=x_reg[15] A[14]=x_reg[14]
+ A[13]=FE_PHN1151_x_reg_13 A[12]=x_reg[12] A[11]=FE_PHN1156_x_reg_11
+ A[10]=x_reg[10] A[9]=x_reg[9] A[8]=x_reg[8] A[7]=x_reg[7] A[6]=x_reg[6]
+ A[5]=FE_PHN1154_x_reg_5 A[4]=FE_PHN1158_x_reg_4 A[3]=x_reg[3] A[2]=x_reg[2]
+ A[1]=x_reg[1] A[0]=x_reg[0] B[17]=y_shift[16] B[16]=y_shift[16]
+ B[15]=y_shift[15] B[14]=y_shift[14] B[13]=y_shift[13] B[12]=y_shift[12]
+ B[11]=y_shift[11] B[10]=y_shift[10] B[9]=y_shift[9] B[8]=y_shift[8]
+ B[7]=y_shift[7] B[6]=y_shift[6] B[5]=y_shift[5] B[4]=y_shift[4] B[3]=y_shift[3]
+ B[2]=y_shift[2] B[1]=y_shift[1] B[0]=y_shift[0] CI=n8 SUM[17]=N339 SUM[16]=N338
+ SUM[15]=N337 SUM[14]=N336 SUM[13]=N335 SUM[12]=N334 SUM[11]=N333 SUM[10]=N332
+ SUM[9]=N331 SUM[8]=N330 SUM[7]=N329 SUM[6]=N328 SUM[5]=N327 SUM[4]=N326
+ SUM[3]=N325 SUM[2]=N324 SUM[1]=N323 SUM[0]=N322
Xsub_101 cordic_rotation_1_DW01_sub_1_DW01_sub_35 $PINS A[15]=z_reg[15]
+ A[14]=FE_PHN1053_z_reg_14 A[13]=FE_PHN1067_z_reg_13 A[12]=z_reg[12]
+ A[11]=z_reg[11] A[10]=z_reg[10] A[9]=z_reg[9] A[8]=z_reg[8] A[7]=z_reg[7]
+ A[6]=z_reg[6] A[5]=z_reg[5] A[4]=z_reg[4] A[3]=z_reg[3] A[2]=z_reg[2]
+ A[1]=z_reg[1] A[0]=z_reg[0] B[15]=n8 B[14]=n8 B[13]=FE_DBTN166_n41
+ B[12]=FE_UNCONNECTED_1 B[11]=n443 B[10]=N108 B[9]=N109 B[8]=N110 B[7]=N111
+ B[6]=N112 B[5]=N113 B[4]=N114 B[3]=N115 B[2]=N116 B[1]=N117 B[0]=N118 CI=n8
+ DIFF[15]=N321 DIFF[14]=N320 DIFF[13]=N319 DIFF[12]=N318 DIFF[11]=N317
+ DIFF[10]=N316 DIFF[9]=N315 DIFF[8]=N314 DIFF[7]=N313 DIFF[6]=N312 DIFF[5]=N311
+ DIFF[4]=N310 DIFF[3]=N309 DIFF[2]=N308 DIFF[1]=N307 DIFF[0]=N306 n212=n212
+ p_1=n133 n321=FE_OFN209_n321
Xadd_100 cordic_rotation_1_DW01_add_4_DW01_add_10 $PINS A[17]=y_reg[17]
+ A[16]=y_reg[16] A[15]=y_reg[15] A[14]=y_reg[14] A[13]=y_reg[13] A[12]=y_reg[12]
+ A[11]=y_reg[11] A[10]=y_reg[10] A[9]=y_reg[9] A[8]=y_reg[8] A[7]=y_reg[7]
+ A[6]=y_reg[6] A[5]=y_reg[5] A[4]=y_reg[4] A[3]=y_reg[3] A[2]=y_reg[2]
+ A[1]=y_reg[1] A[0]=y_reg[0] B[17]=x_shift[16] B[16]=x_shift[16]
+ B[15]=x_shift[15] B[14]=x_shift[14] B[13]=x_shift[13] B[12]=x_shift[12]
+ B[11]=x_shift[11] B[10]=x_shift[10] B[9]=x_shift[9] B[8]=x_shift[8]
+ B[7]=x_shift[7] B[6]=x_shift[6] B[5]=x_shift[5] B[4]=x_shift[4] B[3]=x_shift[3]
+ B[2]=x_shift[2] B[1]=x_shift[1] B[0]=x_shift[0] CI=n8 SUM[17]=N305 SUM[16]=N304
+ SUM[15]=N303 SUM[14]=N302 SUM[13]=N301 SUM[12]=N300 SUM[11]=N299 SUM[10]=N298
+ SUM[9]=N297 SUM[8]=N296 SUM[7]=N295 SUM[6]=N294 SUM[5]=N293 SUM[4]=N292
+ SUM[3]=N291 SUM[2]=N290 SUM[1]=N289 SUM[0]=N288
Xsub_99 cordic_rotation_1_DW01_sub_2_DW01_sub_36 $PINS
+ A[17]=FE_PHN1140_x_reg_17 A[16]=x_reg[16] A[15]=x_reg[15] A[14]=x_reg[14]
+ A[13]=FE_PHN1151_x_reg_13 A[12]=FE_PHN1109_x_reg_12 A[11]=FE_PHN1156_x_reg_11
+ A[10]=x_reg[10] A[9]=x_reg[9] A[8]=x_reg[8] A[7]=x_reg[7] A[6]=x_reg[6]
+ A[5]=FE_PHN1154_x_reg_5 A[4]=FE_PHN1158_x_reg_4 A[3]=x_reg[3] A[2]=x_reg[2]
+ A[1]=x_reg[1] A[0]=x_reg[0] B[17]=y_shift[16] B[16]=y_shift[16]
+ B[15]=y_shift[15] B[14]=y_shift[14] B[13]=y_shift[13] B[12]=y_shift[12]
+ B[11]=y_shift[11] B[10]=y_shift[10] B[9]=y_shift[9] B[8]=y_shift[8]
+ B[7]=y_shift[7] B[6]=y_shift[6] B[5]=y_shift[5] B[4]=y_shift[4] B[3]=y_shift[3]
+ B[2]=y_shift[2] B[1]=y_shift[1] B[0]=y_shift[0] CI=n8 DIFF[17]=N287
+ DIFF[16]=N286 DIFF[15]=N285 DIFF[14]=N284 DIFF[13]=N283 DIFF[12]=N282
+ DIFF[11]=N281 DIFF[10]=N280 DIFF[9]=N279 DIFF[8]=N278 DIFF[7]=N277 DIFF[6]=N276
+ DIFF[5]=N275 DIFF[4]=N274 DIFF[3]=N273 DIFF[2]=N272 DIFF[1]=N271 DIFF[0]=N270
.ENDS

.SUBCKT SNPS_CLOCK_GATE_HIGH_cordic_rotation_0_0 EN ENCLK CLK
*.CONNECT net2355 EN
XFE_PHC981_net2358 DELC $PINS O=FE_PHN981_net2358 I=net2358
Xlatch QDBHN $PINS Q=net2358 D=net2355 CKB=CLK
Xmain_gate AN2T $PINS O=ENCLK I1=FE_PHN981_net2358 I2=CLK
.ENDS

.SUBCKT SNPS_CLOCK_GATE_HIGH_cordic_rotation_0_4 EN ENCLK CLK
*.CONNECT net2355 EN
XFE_PHC950_net2358 DELC $PINS O=FE_PHN950_net2358 I=net2358
Xlatch QDBHN $PINS Q=net2358 D=net2355 CKB=CLK
Xmain_gate AN2T $PINS O=ENCLK I1=FE_PHN950_net2358 I2=CLK
.ENDS

.SUBCKT SNPS_CLOCK_GATE_HIGH_cordic_rotation_0_3 EN ENCLK CLK
*.CONNECT net2355 EN
XFE_PHC987_net2358 DELC $PINS O=net2358 I=FE_PHN987_net2358
Xlatch QDBHN $PINS Q=FE_PHN987_net2358 D=net2355 CKB=CLK
Xmain_gate AN2T $PINS O=ENCLK I1=net2358 I2=CLK
.ENDS

.SUBCKT SNPS_CLOCK_GATE_HIGH_cordic_rotation_0_2 EN ENCLK CLK
*.CONNECT net2355 EN
XFE_PHC968_net2358 DELC $PINS O=FE_PHN968_net2358 I=net2358
Xlatch QDBHN $PINS Q=net2358 D=net2355 CKB=CLK
Xmain_gate AN2T $PINS O=ENCLK I1=FE_PHN968_net2358 I2=CLK
.ENDS

.SUBCKT SNPS_CLOCK_GATE_HIGH_cordic_rotation_0_1 EN ENCLK CLK_clone1 CLK
*.CONNECT ENCLK net2354
*.CONNECT net2355 EN
XFE_PHC873_net2358 DELC $PINS O=net2358 I=FE_PHN873_net2358
Xlatch QDBHN $PINS Q=FE_PHN873_net2358 D=net2355 CKB=CLK_clone1
Xmain_gate AN2 $PINS O=net2354 I1=net2358 I2=CLK
.ENDS

.SUBCKT cordic_rotation_0_DW01_add_2 A[15] A[14] A[13] A[12] A[11] A[10] A[9]
+ A[8] A[7] A[6] A[5] A[4] A[3] A[2] A[1] A[0] B[15] B[14] B[13] B[12] B[11]
+ B[10] B[9] B[8] B[7] B[6] B[5] B[4] B[3] B[2] B[1] B[0] CI SUM[15] SUM[14]
+ SUM[13] SUM[12] SUM[11] SUM[10] SUM[9] SUM[8] SUM[7] SUM[6] SUM[5] SUM[4]
+ SUM[3] SUM[2] SUM[1] SUM[0] CO
XU1_12 FA1S $PINS S=SUM[12] CO=carry[13] A=A[12] B=B[12] CI=carry[12]
XU1_11 FA1S $PINS S=SUM[11] CO=carry[12] A=A[11] B=B[11] CI=carry[11]
XU1_5 FA1S $PINS S=SUM[5] CO=carry[6] A=A[5] B=B[5] CI=carry[5]
XU1_7 FA1S $PINS S=SUM[7] CO=carry[8] A=A[7] B=B[7] CI=carry[7]
XU1_6 FA1S $PINS S=SUM[6] CO=carry[7] A=A[6] B=B[6] CI=carry[6]
XU1_8 FA1S $PINS S=SUM[8] CO=carry[9] A=A[8] B=B[8] CI=carry[8]
XU1_9 FA1S $PINS S=SUM[9] CO=carry[10] A=A[9] B=B[9] CI=carry[9]
XU1_10 FA1S $PINS S=SUM[10] CO=carry[11] A=A[10] B=B[10] CI=carry[10]
XU1_4 FA1S $PINS S=SUM[4] CO=carry[5] A=A[4] B=B[4] CI=carry[4]
XU1_2 FA1S $PINS S=SUM[2] CO=carry[3] A=A[2] B=B[2] CI=carry[2]
XU1_3 FA1S $PINS S=SUM[3] CO=carry[4] A=A[3] B=B[3] CI=carry[3]
XU1_1 FA1S $PINS S=SUM[1] CO=carry[2] A=A[1] B=B[1] CI=n1
XU1_13 FA1S $PINS S=SUM[13] CO=carry[14] A=A[13] B=B[13] CI=carry[13]
XU1 AN2 $PINS O=n1 I1=B[0] I2=A[0]
XU2 XNR2HS $PINS O=SUM[15] I1=A[15] I2=n2
XU3 XOR2HS $PINS O=SUM[14] I1=A[14] I2=carry[14]
XU4 XOR2HS $PINS O=SUM[0] I1=B[0] I2=A[0]
XU5 ND2 $PINS O=n2 I1=A[14] I2=carry[14]
.ENDS

.SUBCKT cordic_rotation_0_DW01_sub_0_DW01_sub_28 A[17] A[16] A[15] A[14] A[13]
+ A[12] A[11] A[10] A[9] A[8] A[7] A[6] A[5] A[4] A[3] A[2] A[1] A[0] B[17]
+ B[16] B[15] B[14] B[13] B[12] B[11] B[10] B[9] B[8] B[7] B[6] B[5] B[4] B[3]
+ B[2] B[1] B[0] CI DIFF[17] DIFF[16] DIFF[15] DIFF[14] DIFF[13] DIFF[12]
+ DIFF[11] DIFF[10] DIFF[9] DIFF[8] DIFF[7] DIFF[6] DIFF[5] DIFF[4] DIFF[3]
+ DIFF[2] DIFF[1] DIFF[0] CO
XU2_2 FA1 $PINS S=DIFF[2] CO=carry[3] A=A[2] B=n12 CI=carry[2]
XU2_3 FA1S $PINS S=DIFF[3] CO=carry[4] A=A[3] B=n13 CI=carry[3]
XU2_1 FA1S $PINS S=DIFF[1] CO=carry[2] A=A[1] B=n11 CI=carry[1]
XU2_6 FA1 $PINS S=DIFF[6] CO=carry[7] A=A[6] B=n16 CI=carry[6]
XU2_14 FA1 $PINS S=DIFF[14] CO=carry[15] A=A[14] B=n6 CI=carry[14]
XU2_9 FA1 $PINS S=DIFF[9] CO=carry[10] A=A[9] B=n10 CI=carry[9]
XU2_7 FA1 $PINS S=DIFF[7] CO=carry[8] A=A[7] B=n17 CI=carry[7]
XU2_8 FA1 $PINS S=DIFF[8] CO=carry[9] A=A[8] B=n18 CI=carry[8]
XU2_5 FA1 $PINS S=DIFF[5] CO=carry[6] A=A[5] B=n15 CI=carry[5]
XU2_4 FA1 $PINS S=DIFF[4] CO=carry[5] A=A[4] B=n14 CI=carry[4]
XU2_11 FA1 $PINS S=DIFF[11] CO=carry[12] A=A[11] B=n4 CI=carry[11]
XU2_12 FA1 $PINS S=DIFF[12] CO=carry[13] A=A[12] B=n9 CI=carry[12]
XU2_10 FA1 $PINS S=DIFF[10] CO=carry[11] A=A[10] B=n3 CI=carry[10]
XU2_13 FA1S $PINS S=DIFF[13] CO=carry[14] A=A[13] B=n5 CI=carry[13]
XU2_17 XOR3S $PINS O=DIFF[17] I1=A[17] I2=n8 I3=carry[17]
XU2_16 FA1S $PINS S=DIFF[16] CO=carry[17] A=A[16] B=n8 CI=carry[16]
XU2_15 FA1 $PINS S=DIFF[15] CO=carry[16] A=A[15] B=n7 CI=carry[15]
XU1 INV1S $PINS O=n2 I=B[0]
XU2 INV1S $PINS O=n8 I=B[17]
XU3 INV1S $PINS O=n5 I=B[13]
XU4 INV1S $PINS O=n3 I=B[10]
XU5 INV1S $PINS O=n9 I=B[12]
XU6 INV1S $PINS O=n4 I=B[11]
XU7 INV1S $PINS O=n14 I=B[4]
XU8 INV1S $PINS O=n15 I=B[5]
XU9 INV1S $PINS O=n18 I=B[8]
XU10 INV1S $PINS O=n17 I=B[7]
XU11 INV1S $PINS O=n10 I=B[9]
XU12 INV1S $PINS O=n7 I=B[15]
XU13 INV1S $PINS O=n6 I=B[14]
XU14 INV1S $PINS O=n16 I=B[6]
XU15 INV1S $PINS O=n11 I=B[1]
XU16 INV1S $PINS O=n1 I=A[0]
XU17 INV1S $PINS O=n13 I=B[3]
XU18 INV1S $PINS O=n12 I=B[2]
XU19 XNR2HS $PINS O=DIFF[0] I1=n2 I2=A[0]
XU20 ND2 $PINS O=carry[1] I1=B[0] I2=n1
.ENDS

.SUBCKT cordic_rotation_0_DW01_add_3 A[17] A[16] A[15] A[14] A[13] A[12] A[11]
+ A[10] A[9] A[8] A[7] A[6] A[5] A[4] A[3] A[2] A[1] A[0] B[17] B[16] B[15]
+ B[14] B[13] B[12] B[11] B[10] B[9] B[8] B[7] B[6] B[5] B[4] B[3] B[2] B[1]
+ B[0] CI SUM[17] SUM[16] SUM[15] SUM[14] SUM[13] SUM[12] SUM[11] SUM[10]
+ SUM[9] SUM[8] SUM[7] SUM[6] SUM[5] SUM[4] SUM[3] SUM[2] SUM[1] SUM[0] CO
XFE_RC_146_0 XOR3 $PINS O=SUM[7] I1=A[7] I2=B[7] I3=carry[7]
XFE_RC_145_0 MAO222 $PINS O=carry[8] A1=A[7] B1=B[7] C1=carry[7]
XFE_RC_1596_0 XOR3 $PINS O=SUM[9] I1=A[9] I2=B[9] I3=carry[9]
XFE_RC_1595_0 MAO222 $PINS O=carry[10] A1=A[9] B1=B[9] C1=carry[9]
XU1_14 FA1 $PINS S=SUM[14] CO=carry[15] A=A[14] B=B[14] CI=carry[14]
XU1_1 FA1S $PINS S=SUM[1] CO=carry[2] A=A[1] B=B[1] CI=n1
XU1_6 FA1 $PINS S=SUM[6] CO=carry[7] A=A[6] B=B[6] CI=carry[6]
XU1_5 FA1 $PINS S=SUM[5] CO=carry[6] A=A[5] B=B[5] CI=carry[5]
XU1_4 FA1S $PINS S=SUM[4] CO=carry[5] A=A[4] B=B[4] CI=carry[4]
XU1_3 FA1S $PINS S=SUM[3] CO=carry[4] A=A[3] B=B[3] CI=carry[3]
XU1_8 FA1 $PINS S=SUM[8] CO=carry[9] A=A[8] B=B[8] CI=carry[8]
XU1_2 FA1S $PINS S=SUM[2] CO=carry[3] A=A[2] B=B[2] CI=carry[2]
XU1_11 FA1 $PINS S=SUM[11] CO=carry[12] A=A[11] B=B[11] CI=carry[11]
XU1_12 FA1 $PINS S=SUM[12] CO=carry[13] A=A[12] B=B[12] CI=carry[12]
XU1_10 FA1 $PINS S=SUM[10] CO=carry[11] A=A[10] B=B[10] CI=carry[10]
XU1_13 FA1 $PINS S=SUM[13] CO=carry[14] A=A[13] B=B[13] CI=carry[13]
XU1_15 FA1S $PINS S=SUM[15] CO=carry[16] A=A[15] B=B[15] CI=carry[15]
XU1_17 XOR3S $PINS O=SUM[17] I1=A[17] I2=B[17] I3=carry[17]
XU1_16 FA1S $PINS S=SUM[16] CO=carry[17] A=A[16] B=B[16] CI=carry[16]
XU1 AN2 $PINS O=n1 I1=B[0] I2=A[0]
XU2 XOR2HS $PINS O=SUM[0] I1=B[0] I2=A[0]
.ENDS

.SUBCKT cordic_rotation_0_DW01_sub_1_DW01_sub_29 A[15] A[14] A[13] A[12] A[11]
+ A[10] A[9] A[8] A[7] A[6] A[5] A[4] A[3] A[2] A[1] A[0] B[15] B[14] B[13]
+ B[12] B[11] B[10] B[9] B[8] B[7] B[6] B[5] B[4] B[3] B[2] B[1] B[0] CI
+ DIFF[15] DIFF[14] DIFF[13] DIFF[12] DIFF[11] DIFF[10] DIFF[9] DIFF[8] DIFF[7]
+ DIFF[6] DIFF[5] DIFF[4] DIFF[3] DIFF[2] DIFF[1] DIFF[0] CO n213 p_1 n322
XU2_12 FA1S $PINS S=DIFF[12] CO=carry[13] A=A[12] B=p_1 CI=carry[12]
XU2_11 FA1S $PINS S=DIFF[11] CO=carry[12] A=A[11] B=n213 CI=carry[11]
XU2_10 FA1S $PINS S=DIFF[10] CO=carry[11] A=A[10] B=n322 CI=carry[10]
XU2_9 FA1S $PINS S=DIFF[9] CO=carry[10] A=A[9] B=n11 CI=carry[9]
XU2_8 FA1S $PINS S=DIFF[8] CO=carry[9] A=A[8] B=n14 CI=carry[8]
XU2_7 FA1S $PINS S=DIFF[7] CO=carry[8] A=A[7] B=n8 CI=carry[7]
XU2_6 FA1S $PINS S=DIFF[6] CO=carry[7] A=A[6] B=n15 CI=carry[6]
XU2_5 FA1S $PINS S=DIFF[5] CO=carry[6] A=A[5] B=n9 CI=carry[5]
XU2_4 FA1S $PINS S=DIFF[4] CO=carry[5] A=A[4] B=n6 CI=carry[4]
XU2_3 FA1S $PINS S=DIFF[3] CO=carry[4] A=A[3] B=n12 CI=carry[3]
XU2_2 FA1S $PINS S=DIFF[2] CO=carry[3] A=A[2] B=n5 CI=carry[2]
XU2_1 FA1S $PINS S=DIFF[1] CO=carry[2] A=A[1] B=n7 CI=carry[1]
XU2_13 FA1S $PINS S=DIFF[13] CO=carry[14] A=A[13] B=B[13] CI=carry[13]
XU1 OR2 $PINS O=carry[15] I1=carry[14] I2=A[14]
XU2 INV1S $PINS O=n10 I=B[0]
XU4 XNR2HS $PINS O=DIFF[15] I1=A[15] I2=carry[15]
XU5 INV1S $PINS O=n7 I=B[1]
XU6 INV1S $PINS O=n1 I=A[0]
XU7 INV1S $PINS O=n5 I=B[2]
XU8 INV1S $PINS O=n12 I=B[3]
XU9 INV1S $PINS O=n6 I=B[4]
XU10 INV1S $PINS O=n9 I=B[5]
XU11 INV1S $PINS O=n15 I=B[6]
XU12 INV1S $PINS O=n8 I=B[7]
XU13 INV1S $PINS O=n14 I=B[8]
XU14 INV1S $PINS O=n11 I=B[9]
XU18 XNR2HS $PINS O=DIFF[14] I1=A[14] I2=carry[14]
XU19 XNR2HS $PINS O=DIFF[0] I1=n10 I2=A[0]
XU20 ND2 $PINS O=carry[1] I1=B[0] I2=n1
.ENDS

.SUBCKT cordic_rotation_0_DW01_add_4 A[17] A[16] A[15] A[14] A[13] A[12] A[11]
+ A[10] A[9] A[8] A[7] A[6] A[5] A[4] A[3] A[2] A[1] A[0] B[17] B[16] B[15]
+ B[14] B[13] B[12] B[11] B[10] B[9] B[8] B[7] B[6] B[5] B[4] B[3] B[2] B[1]
+ B[0] CI SUM[17] SUM[16] SUM[15] SUM[14] SUM[13] SUM[12] SUM[11] SUM[10]
+ SUM[9] SUM[8] SUM[7] SUM[6] SUM[5] SUM[4] SUM[3] SUM[2] SUM[1] SUM[0] CO
XU1_14 FA1S $PINS S=SUM[14] CO=carry[15] A=A[14] B=B[14] CI=carry[14]
XU1_1 FA1S $PINS S=SUM[1] CO=carry[2] A=A[1] B=B[1] CI=n1
XU1_9 FA1 $PINS S=SUM[9] CO=carry[10] A=A[9] B=B[9] CI=carry[9]
XU1_6 FA1 $PINS S=SUM[6] CO=carry[7] A=A[6] B=B[6] CI=carry[6]
XU1_5 FA1S $PINS S=SUM[5] CO=carry[6] A=A[5] B=B[5] CI=carry[5]
XU1_4 FA1 $PINS S=SUM[4] CO=carry[5] A=A[4] B=B[4] CI=carry[4]
XU1_3 FA1S $PINS S=SUM[3] CO=carry[4] A=A[3] B=B[3] CI=carry[3]
XU1_8 FA1 $PINS S=SUM[8] CO=carry[9] A=A[8] B=B[8] CI=carry[8]
XU1_7 FA1 $PINS S=SUM[7] CO=carry[8] A=A[7] B=B[7] CI=carry[7]
XU1_2 FA1 $PINS S=SUM[2] CO=carry[3] A=A[2] B=B[2] CI=carry[2]
XU1_11 FA1 $PINS S=SUM[11] CO=carry[12] A=A[11] B=B[11] CI=carry[11]
XU1_12 FA1 $PINS S=SUM[12] CO=carry[13] A=A[12] B=B[12] CI=carry[12]
XU1_10 FA1 $PINS S=SUM[10] CO=carry[11] A=A[10] B=B[10] CI=carry[10]
XU1_13 FA1 $PINS S=SUM[13] CO=carry[14] A=A[13] B=B[13] CI=carry[13]
XU1_15 FA1 $PINS S=SUM[15] CO=carry[16] A=A[15] B=B[15] CI=carry[15]
XU1_17 XOR3S $PINS O=SUM[17] I1=A[17] I2=B[17] I3=carry[17]
XU1_16 FA1S $PINS S=SUM[16] CO=carry[17] A=A[16] B=B[16] CI=carry[16]
XU1 AN2 $PINS O=n1 I1=B[0] I2=A[0]
XU2 XOR2HS $PINS O=SUM[0] I1=B[0] I2=A[0]
.ENDS

.SUBCKT cordic_rotation_0_DW01_sub_2_DW01_sub_30 A[17] A[16] A[15] A[14] A[13]
+ A[12] A[11] A[10] A[9] A[8] A[7] A[6] A[5] A[4] A[3] A[2] A[1] A[0] B[17]
+ B[16] B[15] B[14] B[13] B[12] B[11] B[10] B[9] B[8] B[7] B[6] B[5] B[4] B[3]
+ B[2] B[1] B[0] CI DIFF[17] DIFF[16] DIFF[15] DIFF[14] DIFF[13] DIFF[12]
+ DIFF[11] DIFF[10] DIFF[9] DIFF[8] DIFF[7] DIFF[6] DIFF[5] DIFF[4] DIFF[3]
+ DIFF[2] DIFF[1] DIFF[0] CO
XFE_PHC1461_x_reg_9 BUF1CK $PINS O=FE_PHN1461_x_reg_9 I=A[9]
XFE_RC_197_0 XOR3 $PINS O=DIFF[6] I1=A[6] I2=n16 I3=carry[6]
XFE_RC_196_0 MAO222 $PINS O=carry[7] A1=A[6] B1=n16 C1=carry[6]
XU2_2 FA1S $PINS S=DIFF[2] CO=carry[3] A=A[2] B=n12 CI=carry[2]
XU2_3 FA1 $PINS S=DIFF[3] CO=carry[4] A=A[3] B=n13 CI=carry[3]
XU2_1 FA1S $PINS S=DIFF[1] CO=carry[2] A=A[1] B=n11 CI=carry[1]
XU2_14 FA1 $PINS S=DIFF[14] CO=carry[15] A=A[14] B=n4 CI=carry[14]
XU2_15 FA1S $PINS S=DIFF[15] CO=carry[16] A=A[15] B=n3 CI=carry[15]
XU2_9 FA1 $PINS S=DIFF[9] CO=carry[10] A=FE_PHN1461_x_reg_9 B=n9 CI=carry[9]
XU2_7 FA1 $PINS S=DIFF[7] CO=carry[8] A=A[7] B=n17 CI=carry[7]
XU2_8 FA1 $PINS S=DIFF[8] CO=carry[9] A=A[8] B=n18 CI=carry[8]
XU2_5 FA1S $PINS S=DIFF[5] CO=carry[6] A=A[5] B=n15 CI=carry[5]
XU2_4 FA1 $PINS S=DIFF[4] CO=carry[5] A=A[4] B=n14 CI=carry[4]
XU2_11 FA1 $PINS S=DIFF[11] CO=carry[12] A=A[11] B=n7 CI=carry[11]
XU2_12 FA1 $PINS S=DIFF[12] CO=carry[13] A=A[12] B=n6 CI=carry[12]
XU2_10 FA1 $PINS S=DIFF[10] CO=carry[11] A=A[10] B=n8 CI=carry[10]
XU2_13 FA1 $PINS S=DIFF[13] CO=carry[14] A=A[13] B=n5 CI=carry[13]
XU2_17 XOR3S $PINS O=DIFF[17] I1=A[17] I2=n2 I3=carry[17]
XU2_16 FA1S $PINS S=DIFF[16] CO=carry[17] A=A[16] B=n2 CI=carry[16]
XU1 INV1S $PINS O=n10 I=B[0]
XU2 INV1S $PINS O=n2 I=B[17]
XU3 INV1S $PINS O=n5 I=B[13]
XU4 INV1S $PINS O=n8 I=B[10]
XU5 INV1S $PINS O=n6 I=B[12]
XU6 INV1S $PINS O=n7 I=B[11]
XU7 INV1S $PINS O=n14 I=B[4]
XU8 INV1S $PINS O=n15 I=B[5]
XU9 INV1S $PINS O=n18 I=B[8]
XU10 INV1S $PINS O=n17 I=B[7]
XU11 INV1S $PINS O=n9 I=B[9]
XU12 INV1S $PINS O=n3 I=B[15]
XU13 INV1S $PINS O=n16 I=B[6]
XU14 INV1S $PINS O=n4 I=B[14]
XU15 INV1S $PINS O=n11 I=B[1]
XU16 INV1S $PINS O=n1 I=A[0]
XU17 INV1S $PINS O=n13 I=B[3]
XU18 INV1S $PINS O=n12 I=B[2]
XU19 XNR2HS $PINS O=DIFF[0] I1=n10 I2=A[0]
XU20 ND2 $PINS O=carry[1] I1=B[0] I2=n1
.ENDS

.SUBCKT cordic_rotation_0 clk rst_n valid_in valid_out x_in[16] x_in[15]
+ x_in[14] x_in[13] x_in[12] x_in[11] x_in[10] x_in[9] x_in[8] x_in[7] x_in[6]
+ x_in[5] x_in[4] x_in[3] x_in[2] x_in[1] x_in[0] y_in[16] y_in[15] y_in[14]
+ y_in[13] y_in[12] y_in[11] y_in[10] y_in[9] y_in[8] y_in[7] y_in[6] y_in[5]
+ y_in[4] y_in[3] y_in[2] y_in[1] y_in[0] phase_in[15] phase_in[14]
+ phase_in[13] phase_in[12] phase_in[11] phase_in[10] phase_in[9] phase_in[8]
+ phase_in[7] phase_in[6] phase_in[5] phase_in[4] phase_in[3] phase_in[2]
+ phase_in[1] phase_in[0] x_out[16] x_out[15] x_out[14] x_out[13] x_out[12]
+ x_out[11] x_out[10] x_out[9] x_out[8] x_out[7] x_out[6] x_out[5] x_out[4]
+ x_out[3] x_out[2] x_out[1] x_out[0] y_out[16] y_out[15] y_out[14] y_out[13]
+ y_out[12] y_out[11] y_out[10] y_out[9] y_out[8] y_out[7] y_out[6] y_out[5]
+ y_out[4] y_out[3] y_out[2] y_out[1] y_out[0] p1 FE_OFN78_FE_DBTN17_n206
+ FE_OFN74_FE_DBTN17_n206 FE_OFN73_FE_DBTN17_n206 FE_OFN72_FE_DBTN17_n206
+ FE_OFN70_FE_DBTN17_n206 clk_clone4 clk_clone3 clk_clone2 clk_clone1
*.CONNECT N130 x_in[0]
*.CONNECT N148 y_in[0]
*.CONNECT N176 phase_in[8]
*.CONNECT N177 phase_in[9]
*.CONNECT N178 phase_in[10]
*.CONNECT N179 phase_in[11]
*.CONNECT N180 phase_in[12]
*.CONNECT N181 phase_in[13]
*.CONNECT N182 phase_in[14]
XFE_PHC1475_N433 BUF1S $PINS O=FE_PHN1475_N433 I=N433
XFE_PHC1473_x_reg_10 BUF1S $PINS O=FE_PHN1473_x_reg_10 I=x_reg[10]
XFE_PHC1471_N451 BUF1CK $PINS O=FE_PHN1471_N451 I=N451
XFE_PHC1469_z_reg_12 BUF1CK $PINS O=FE_PHN1469_z_reg_12 I=z_reg[12]
XFE_PHC1467_n441 BUF1CK $PINS O=FE_PHN1467_n441 I=n441
XFE_PHC1465_n442 BUF1CK $PINS O=n442 I=FE_PHN1465_n442
XFE_PHC1464_c_in_r_1_5 DELA $PINS O=FE_PHN1464_c_in_r_1_5 I=x_in[5]
XFE_PHC1463_c_in_i_1_11 BUF1CK $PINS O=FE_PHN1463_c_in_i_1_11 I=y_in[11]
XFE_PHC1460_n394 BUF1CK $PINS O=FE_PHN1460_n394 I=n394
XFE_PHC1456_N448 BUF1S $PINS O=N448 I=FE_PHN1456_N448
XFE_PHC1454_n418 BUF1CK $PINS O=FE_PHN1454_n418 I=n418
XFE_PHC1453_c_in_r_1_4 BUF1S $PINS O=FE_PHN1453_c_in_r_1_4 I=x_in[4]
XFE_PHC1450_N499 DELA $PINS O=FE_PHN1450_N499 I=N499
XFE_PHC1448_N480 DELB $PINS O=FE_PHN1448_N480 I=N480
XFE_PHC1446_N500 DELB $PINS O=N500 I=FE_PHN1446_N500
XFE_PHC1445_n350 DELB $PINS O=FE_PHN1445_n350 I=n350
XFE_PHC1441_N502 DELB $PINS O=FE_PHN1441_N502 I=N502
XFE_PHC1440_N482 DELB $PINS O=FE_PHN1440_N482 I=N482
XFE_PHC1426_N481 DELB $PINS O=FE_PHN1426_N481 I=N481
XFE_PHC1418_N497 DELB $PINS O=N497 I=FE_PHN1418_N497
XFE_PHC1362_n418 BUF1S $PINS O=FE_PHN1362_n418 I=FE_PHN1454_n418
XFE_PHC1359_c_in_r_1_14 DELA $PINS O=FE_PHN1359_c_in_r_1_14 I=x_in[14]
XFE_PHC1347_c_in_i_1_2 DELA $PINS O=FE_PHN1347_c_in_i_1_2 I=y_in[2]
XFE_PHC1346_n421 DELA $PINS O=FE_PHN1346_n421 I=n421
XFE_PHC1342_n440 DELA $PINS O=FE_PHN1342_n440 I=n440
XFE_PHC1340_c_in_r_1_15 DELA $PINS O=FE_PHN1340_c_in_r_1_15 I=x_in[15]
XFE_PHC1334_n439 DELA $PINS O=FE_PHN1334_n439 I=n439
XFE_PHC1332_n438 DELA $PINS O=FE_PHN1332_n438 I=n438
XFE_PHC1330_n412 DELB $PINS O=FE_PHN1330_n412 I=n412
XFE_PHC1328_n415 DELA $PINS O=n415 I=FE_PHN1328_n415
XFE_PHC1324_N498 DELA $PINS O=FE_PHN1324_N498 I=N498
XFE_PHC1320_n398 DELB $PINS O=FE_PHN1320_n398 I=n398
XFE_PHC1310_N428 DELB $PINS O=N428 I=FE_PHN1310_N428
XFE_PHC1300_N434 DELB $PINS O=N434 I=FE_PHN1300_N434
XFE_PHC1299_N436 DELB $PINS O=FE_PHN1299_N436 I=N436
XFE_PHC1298_N429 DELB $PINS O=FE_PHN1298_N429 I=N429
XFE_PHC1296_N430 DELB $PINS O=FE_PHN1296_N430 I=N430
XFE_PHC1295_N435 DELB $PINS O=FE_PHN1295_N435 I=N435
XFE_PHC1294_N427 DELB $PINS O=N427 I=FE_PHN1294_N427
XFE_PHC1292_N447 DELB $PINS O=FE_PHN1292_N447 I=N447
XFE_PHC1285_n359 DELB $PINS O=FE_PHN1285_n359 I=n359
XFE_PHC1282_N426 DELB $PINS O=FE_PHN1282_N426 I=N426
XFE_PHC1278_N459 DELB $PINS O=FE_PHN1278_N459 I=N459
XFE_PHC1177_N457 DELB $PINS O=N457 I=FE_PHN1177_N457
XFE_PHC1176_N438 BUF1S $PINS O=FE_PHN1176_N438 I=N438
XFE_PHC1163_x_reg_12 BUF1S $PINS O=x_reg[12] I=FE_PHN1163_x_reg_12
XFE_PHC1162_x_reg_10 BUF1S $PINS O=FE_PHN1162_x_reg_10 I=FE_PHN1473_x_reg_10
XFE_PHC1161_x_reg_9 BUF1S $PINS O=FE_PHN1161_x_reg_9 I=x_reg[9]
XFE_PHC1160_y_reg_14 BUF1S $PINS O=y_reg[14] I=FE_PHN1160_y_reg_14
XFE_PHC1159_y_reg_16 DELB $PINS O=y_reg[16] I=FE_PHN1159_y_reg_16
XFE_PHC1157_x_reg_11 DELB $PINS O=FE_PHN1157_x_reg_11 I=x_reg[11]
XFE_PHC1155_x_reg_6 BUF1S $PINS O=x_reg[6] I=FE_PHN1155_x_reg_6
XFE_PHC1153_y_reg_13 DELB $PINS O=y_reg[13] I=FE_PHN1153_y_reg_13
XFE_PHC1150_x_reg_5 DELB $PINS O=FE_PHN1150_x_reg_5 I=x_reg[5]
XFE_PHC1149_y_reg_15 DELB $PINS O=FE_PHN1149_y_reg_15 I=y_reg[15]
XFE_PHC1147_x_reg_15 DELB $PINS O=x_reg[15] I=FE_PHN1147_x_reg_15
XFE_PHC1142_y_reg_17 BUF1S $PINS O=y_reg[17] I=FE_PHN1142_y_reg_17
XFE_PHC1135_z_reg_3 BUF1S $PINS O=FE_PHN1135_z_reg_3 I=z_reg[3]
XFE_PHC1134_z_reg_4 BUF1S $PINS O=FE_PHN1134_z_reg_4 I=z_reg[4]
XFE_PHC1105_x_reg_16 DELB $PINS O=FE_PHN1105_x_reg_16 I=x_reg[16]
XFE_PHC1092_z_reg_12 BUF1S $PINS O=FE_PHN1092_z_reg_12 I=FE_PHN1469_z_reg_12
XFE_PHC1077_z_reg_13 DELB $PINS O=FE_PHN1077_z_reg_13 I=z_reg[13]
XFE_PHC1070_n443 DELA $PINS O=FE_PHN1070_n443 I=n443
XFE_PHC1068_n444 DELA $PINS O=n444 I=FE_PHN1068_n444
XFE_PHC1061_x_reg_17 BUF1S $PINS O=FE_PHN1061_x_reg_17 I=x_reg[17]
XFE_PHC1052_N441 DELB $PINS O=FE_PHN1052_N441 I=N441
XFE_PHC1049_n395 DELB $PINS O=FE_PHN1049_n395 I=n395
XFE_PHC1047_N446 DELB $PINS O=FE_PHN1047_N446 I=N446
XFE_PHC1046_N442 DELB $PINS O=FE_PHN1046_N442 I=N442
XFE_PHC1044_N445 DELB $PINS O=FE_PHN1044_N445 I=N445
XFE_PHC1043_N443 DELB $PINS O=FE_PHN1043_N443 I=N443
XFE_PHC1042_N440 DELB $PINS O=N440 I=FE_PHN1042_N440
XFE_PHC1038_N444 DELB $PINS O=FE_PHN1038_N444 I=N444
XFE_PHC1034_N461 DELB $PINS O=FE_PHN1034_N461 I=N461
XFE_PHC1031_N439 DELB $PINS O=FE_PHN1031_N439 I=N439
XFE_PHC1029_z_reg_14 DELB $PINS O=FE_PHN1029_z_reg_14 I=z_reg[14]
XFE_PHC1028_n445 DELB $PINS O=FE_PHN1028_n445 I=n445
XFE_PHC1023_N460 DELB $PINS O=N460 I=FE_PHN1023_N460
XFE_PHC1016_n431 DELB $PINS O=FE_PHN1016_n431 I=n431
XCTS_ccl_a_INV_CLK_G1_L8_49 INV4CK $PINS O=CTS_46 I=CTS_47
XCTS_ccl_a_INV_CLK_G1_L7_49 INV2CK $PINS O=CTS_47 I=CTS_48
XCTS_ccl_a_INV_CLK_G1_L8_48 INV4CK $PINS O=CTS_43 I=CTS_44
XCTS_ccl_a_INV_CLK_G1_L7_48 INV3CK $PINS O=CTS_44 I=CTS_45
XCTS_ccl_a_INV_CLK_G1_L8_26 INV8CK $PINS O=CTS_40 I=CTS_41
XCTS_ccl_a_INV_CLK_G1_L7_26 INV3CK $PINS O=CTS_41 I=CTS_42
XCTS_ccl_a_INV_CLK_G1_L8_25 INV6CK $PINS O=CTS_37 I=CTS_38
XCTS_ccl_a_INV_CLK_G1_L7_25 INV4CK $PINS O=CTS_38 I=CTS_39
XFE_OFC457_n164 BUF1 $PINS O=FE_OFN248_n164 I=FE_OFN247_n164
XFE_OFC456_n164 BUF1 $PINS O=FE_OFN247_n164 I=n164
XFE_OFC423_n40 BUF1 $PINS O=FE_OFN220_n40 I=FE_DBTN154_n40
XFE_OFC422_n40 INV1S $PINS O=FE_DBTN154_n40 I=n40
XFE_OFC402_y_reg_8 INV1S $PINS O=n151 I=y_reg[8]
XFE_OFC380_n166 INV1S $PINS O=FE_OFN202_n166 I=n166
XFE_OFC375_n322 INV1S $PINS O=FE_OFN200_n322 I=N108
XFE_OFC373_n322 INV1S $PINS O=N108 I=n322
XFE_OFC359_y_reg_9 INV1S $PINS O=n150 I=y_reg[9]
XFE_OFC343_n135 INV1S $PINS O=FE_OFN189_n135 I=n45
XFE_OFC341_n135 INV1S $PINS O=n45 I=n135
XFE_OFC330_n218 INV1S $PINS O=FE_OFN184_n218 I=n141
XFE_OFC329_n218 INV2 $PINS O=n141 I=n218
XFE_OFC313_x_reg_8 INV1S $PINS O=n247 I=x_reg[8]
XFE_OFC310_y_reg_6 INV1S $PINS O=n172 I=y_reg[6]
XFE_OFC299_x_reg_6 INV1S $PINS O=n262 I=x_reg[6]
XFE_OFC298_y_reg_7 INV1S $PINS O=n161 I=y_reg[7]
XFE_OFC287_x_reg_7 INV1S $PINS O=n255 I=x_reg[7]
XFE_OFC275_x_reg_10 INV1S $PINS O=FE_DBTN158_x_reg_10 I=FE_PHN1162_x_reg_10
XFE_OFC270_x_reg_9 INV1S $PINS O=n246 I=FE_PHN1161_x_reg_9
XFE_OFC260_x_reg_12 INV1S $PINS O=FE_DBTN163_x_reg_12 I=x_reg[12]
XFE_OFC256_x_reg_11 INV1S $PINS O=FE_DBTN165_x_reg_11 I=FE_PHN1157_x_reg_11
XFE_OFC255_n225 INV1S $PINS O=FE_OFN168_n225 I=FE_DBTN156_n225
XFE_OFC254_n225 INV1S $PINS O=FE_DBTN156_n225 I=n225
XFE_OFC247_y_reg_10 INV1S $PINS O=FE_DBTN159_y_reg_10 I=y_reg[10]
XFE_OFC246_y_reg_11 INV1S $PINS O=FE_DBTN164_y_reg_11 I=y_reg[11]
XFE_OFC242_y_reg_12 INV1S $PINS O=FE_DBTN162_y_reg_12 I=y_reg[12]
XFE_OFC220_n144 INV1S $PINS O=FE_OFN154_n144 I=FE_DBTN155_n144
XFE_OFC219_n144 INV1S $PINS O=FE_DBTN155_n144 I=n144
XFE_OFC181_n133 INV2 $PINS O=n46 I=n133
XFE_OFC143_n213 BUF1 $PINS O=FE_OFN121_n213 I=n446
XFE_OFC142_n213 INV2 $PINS O=n446 I=n213
XFE_OFC37_n320 BUF1 $PINS O=FE_OFN39_n320 I=n320
XFE_OFC36_n4 BUF1 $PINS O=FE_OFN38_n4 I=n4
XFE_DBTC161_y_reg_13 INV1S $PINS O=FE_DBTN161_y_reg_13 I=y_reg[13]
XFE_DBTC160_x_reg_13 INV1S $PINS O=FE_DBTN160_x_reg_13 I=x_reg[13]
Xx_out_reg[7] QDFFRBN $PINS Q=x_out[7] D=FE_PHN1475_N433 CK=CTS_43
+ RB=FE_OFN78_FE_DBTN17_n206
Xx_out_reg[8] QDFFRBN $PINS Q=x_out[8] D=N434 CK=CTS_43
+ RB=FE_OFN78_FE_DBTN17_n206
Xx_out_reg[9] QDFFRBN $PINS Q=x_out[9] D=FE_PHN1295_N435 CK=CTS_43
+ RB=FE_OFN74_FE_DBTN17_n206
Xy_out_reg[0] QDFFRBN $PINS Q=y_out[0] D=FE_PHN1031_N439 CK=CTS_46
+ RB=FE_OFN74_FE_DBTN17_n206
Xy_out_reg[1] QDFFRBN $PINS Q=y_out[1] D=N440 CK=CTS_46
+ RB=FE_OFN72_FE_DBTN17_n206
Xy_out_reg[2] QDFFRBN $PINS Q=y_out[2] D=FE_PHN1052_N441 CK=CTS_46
+ RB=FE_OFN72_FE_DBTN17_n206
Xy_out_reg[7] QDFFRBN $PINS Q=y_out[7] D=FE_PHN1047_N446 CK=CTS_46
+ RB=FE_OFN74_FE_DBTN17_n206
Xy_out_reg[8] QDFFRBN $PINS Q=y_out[8] D=FE_PHN1292_N447 CK=CTS_46
+ RB=FE_OFN74_FE_DBTN17_n206
Xy_out_reg[9] QDFFRBN $PINS Q=y_out[9] D=N448 CK=CTS_46
+ RB=FE_OFN74_FE_DBTN17_n206
Xy_out_reg[10] QDFFRBN $PINS Q=y_out[10] D=N449 CK=CTS_46
+ RB=FE_OFN74_FE_DBTN17_n206
Xy_out_reg[14] QDFFRBN $PINS Q=y_out[14] D=FE_PHN1471_N451 CK=CTS_46
+ RB=FE_OFN78_FE_DBTN17_n206
Xy_out_reg[15] QDFFRBN $PINS Q=y_out[15] D=FE_PHN1471_N451 CK=CTS_46
+ RB=FE_OFN78_FE_DBTN17_n206
Xy_out_reg[16] QDFFRBN $PINS Q=y_out[16] D=FE_PHN1471_N451 CK=CTS_46
+ RB=FE_OFN78_FE_DBTN17_n206
Xx_out_reg[0] QDFFRBN $PINS Q=x_out[0] D=FE_PHN1282_N426 CK=CTS_43
+ RB=FE_OFN74_FE_DBTN17_n206
Xx_out_reg[1] QDFFRBN $PINS Q=x_out[1] D=N427 CK=CTS_43
+ RB=FE_OFN74_FE_DBTN17_n206
Xx_out_reg[3] QDFFRBN $PINS Q=x_out[3] D=FE_PHN1298_N429 CK=CTS_43
+ RB=FE_OFN74_FE_DBTN17_n206
Xx_out_reg[5] QDFFRBN $PINS Q=x_out[5] D=N431 CK=CTS_43
+ RB=FE_OFN78_FE_DBTN17_n206
Xx_out_reg[6] QDFFRBN $PINS Q=x_out[6] D=N432 CK=CTS_43
+ RB=FE_OFN78_FE_DBTN17_n206
Xx_out_reg[10] QDFFRBN $PINS Q=x_out[10] D=FE_PHN1299_N436 CK=CTS_43
+ RB=FE_OFN74_FE_DBTN17_n206
Xx_out_reg[11] QDFFRBN $PINS Q=x_out[11] D=N437 CK=CTS_43
+ RB=FE_OFN74_FE_DBTN17_n206
Xx_out_reg[12] QDFFRBN $PINS Q=x_out[12] D=FE_PHN1176_N438 CK=CTS_43
+ RB=FE_OFN78_FE_DBTN17_n206
Xy_out_reg[3] QDFFRBN $PINS Q=y_out[3] D=FE_PHN1046_N442 CK=CTS_46
+ RB=FE_OFN72_FE_DBTN17_n206
Xy_out_reg[4] QDFFRBN $PINS Q=y_out[4] D=FE_PHN1043_N443 CK=CTS_46
+ RB=FE_OFN72_FE_DBTN17_n206
Xy_out_reg[5] QDFFRBN $PINS Q=y_out[5] D=FE_PHN1038_N444 CK=CTS_46
+ RB=FE_OFN74_FE_DBTN17_n206
Xy_out_reg[6] QDFFRBN $PINS Q=y_out[6] D=FE_PHN1044_N445 CK=CTS_46
+ RB=FE_OFN74_FE_DBTN17_n206
Xy_out_reg[11] QDFFRBN $PINS Q=y_out[11] D=N450 CK=CTS_46
+ RB=FE_OFN74_FE_DBTN17_n206
Xy_out_reg[12] QDFFRBN $PINS Q=y_out[12] D=FE_PHN1471_N451 CK=CTS_46
+ RB=FE_OFN78_FE_DBTN17_n206
Xy_out_reg[13] QDFFRBN $PINS Q=y_out[13] D=FE_PHN1471_N451 CK=CTS_46
+ RB=FE_OFN78_FE_DBTN17_n206
Xx_out_reg[2] QDFFRBN $PINS Q=x_out[2] D=N428 CK=CTS_43
+ RB=FE_OFN74_FE_DBTN17_n206
Xx_out_reg[4] QDFFRBN $PINS Q=x_out[4] D=FE_PHN1296_N430 CK=CTS_43
+ RB=FE_OFN74_FE_DBTN17_n206
Xx_out_reg[13] QDFFRBN $PINS Q=x_out[13] D=FE_PHN1176_N438 CK=CTS_43
+ RB=FE_OFN78_FE_DBTN17_n206
Xx_out_reg[14] QDFFRBN $PINS Q=x_out[14] D=FE_PHN1176_N438 CK=CTS_43
+ RB=FE_OFN78_FE_DBTN17_n206
Xx_out_reg[15] QDFFRBN $PINS Q=x_out[15] D=FE_PHN1176_N438 CK=CTS_43
+ RB=FE_OFN78_FE_DBTN17_n206
Xx_out_reg[16] QDFFRBN $PINS Q=x_out[16] D=FE_PHN1176_N438 CK=CTS_43
+ RB=FE_OFN78_FE_DBTN17_n206
Xz_reg_reg[14] QDFFRBN $PINS Q=z_reg[14] D=N477 CK=CTS_40
+ RB=FE_OFN72_FE_DBTN17_n206
Xz_reg_reg[13] QDFFRBN $PINS Q=z_reg[13] D=N476 CK=CTS_40
+ RB=FE_OFN72_FE_DBTN17_n206
Xz_reg_reg[15] QDFFRBN $PINS Q=z_reg[15] D=N478 CK=CTS_40
+ RB=FE_OFN72_FE_DBTN17_n206
Xz_reg_reg[12] QDFFRBN $PINS Q=z_reg[12] D=N475 CK=CTS_40
+ RB=FE_OFN72_FE_DBTN17_n206
Xz_reg_reg[11] QDFFRBN $PINS Q=z_reg[11] D=N474 CK=CTS_40
+ RB=FE_OFN72_FE_DBTN17_n206
Xz_reg_reg[10] QDFFRBN $PINS Q=z_reg[10] D=N473 CK=CTS_40
+ RB=FE_OFN72_FE_DBTN17_n206
Xz_reg_reg[9] QDFFRBN $PINS Q=z_reg[9] D=N472 CK=CTS_40
+ RB=FE_OFN73_FE_DBTN17_n206
Xz_reg_reg[8] QDFFRBN $PINS Q=z_reg[8] D=N471 CK=CTS_40
+ RB=FE_OFN73_FE_DBTN17_n206
Xz_reg_reg[7] QDFFRBN $PINS Q=z_reg[7] D=FE_PHN1332_n438 CK=CTS_40
+ RB=FE_OFN73_FE_DBTN17_n206
Xz_reg_reg[6] QDFFRBN $PINS Q=z_reg[6] D=FE_PHN1334_n439 CK=CTS_37
+ RB=FE_OFN72_FE_DBTN17_n206
Xz_reg_reg[5] QDFFRBN $PINS Q=z_reg[5] D=FE_PHN1342_n440 CK=CTS_37
+ RB=FE_OFN72_FE_DBTN17_n206
Xz_reg_reg[4] QDFFRBN $PINS Q=z_reg[4] D=FE_PHN1467_n441 CK=CTS_37
+ RB=FE_OFN72_FE_DBTN17_n206
Xz_reg_reg[3] QDFFRBN $PINS Q=z_reg[3] D=n442 CK=CTS_37
+ RB=FE_OFN72_FE_DBTN17_n206
Xz_reg_reg[2] QDFFRBN $PINS Q=z_reg[2] D=FE_PHN1070_n443 CK=CTS_37
+ RB=FE_OFN72_FE_DBTN17_n206
Xy_reg_reg[17] QDFFRBN $PINS Q=FE_PHN1142_y_reg_17 D=N514 CK=CTS_40 RB=rst_n
Xx_reg_reg[17] QDFFRBN $PINS Q=x_reg[17] D=N496 CK=CTS_37
+ RB=FE_OFN72_FE_DBTN17_n206
Xz_reg_reg[1] QDFFRBN $PINS Q=z_reg[1] D=n444 CK=CTS_37
+ RB=FE_OFN72_FE_DBTN17_n206
Xx_reg_reg[16] QDFFRBN $PINS Q=x_reg[16] D=N495 CK=CTS_37
+ RB=FE_OFN72_FE_DBTN17_n206
Xy_reg_reg[16] QDFFRBN $PINS Q=FE_PHN1159_y_reg_16 D=N513 CK=CTS_40 RB=rst_n
Xz_reg_reg[0] QDFFRBN $PINS Q=z_reg[0] D=FE_PHN1028_n445 CK=CTS_37
+ RB=FE_OFN72_FE_DBTN17_n206
Xx_reg_reg[15] QDFFRBN $PINS Q=FE_PHN1147_x_reg_15 D=N494 CK=CTS_37
+ RB=FE_OFN70_FE_DBTN17_n206
Xy_reg_reg[15] QDFFRBN $PINS Q=y_reg[15] D=N512 CK=CTS_40 RB=rst_n
Xx_reg_reg[14] QDFFRBN $PINS Q=x_reg[14] D=N493 CK=CTS_37
+ RB=FE_OFN70_FE_DBTN17_n206
Xy_reg_reg[14] QDFFRBN $PINS Q=FE_PHN1160_y_reg_14 D=N511 CK=CTS_40 RB=rst_n
Xy_reg_reg[13] QDFFRBN $PINS Q=FE_PHN1153_y_reg_13 D=N510 CK=CTS_40 RB=rst_n
Xx_reg_reg[13] QDFFRBN $PINS Q=x_reg[13] D=N492 CK=CTS_37
+ RB=FE_OFN70_FE_DBTN17_n206
Xy_reg_reg[12] QDFFRBN $PINS Q=y_reg[12] D=N509 CK=CTS_40 RB=rst_n
Xx_reg_reg[12] QDFFRBN $PINS Q=FE_PHN1163_x_reg_12 D=N491 CK=CTS_37
+ RB=FE_OFN70_FE_DBTN17_n206
Xis_computing_reg QDFFRBN $PINS Q=is_computing D=N457 CK=CTS_37
+ RB=FE_OFN72_FE_DBTN17_n206
Xy_reg_reg[11] QDFFRBN $PINS Q=y_reg[11] D=N508 CK=CTS_40 RB=rst_n
Xx_reg_reg[11] QDFFRBN $PINS Q=x_reg[11] D=N490 CK=CTS_37
+ RB=FE_OFN70_FE_DBTN17_n206
Xx_reg_reg[1] QDFFRBN $PINS Q=x_reg[1] D=FE_PHN1448_N480 CK=CTS_37
+ RB=FE_OFN70_FE_DBTN17_n206
Xy_reg_reg[1] QDFFRBN $PINS Q=y_reg[1] D=FE_PHN1324_N498 CK=CTS_40
+ RB=FE_OFN72_FE_DBTN17_n206
Xy_reg_reg[3] QDFFRBN $PINS Q=y_reg[3] D=N500 CK=CTS_40
+ RB=FE_OFN72_FE_DBTN17_n206
Xx_reg_reg[3] QDFFRBN $PINS Q=x_reg[3] D=FE_PHN1440_N482 CK=CTS_37
+ RB=FE_OFN70_FE_DBTN17_n206
Xy_reg_reg[10] QDFFRBN $PINS Q=y_reg[10] D=N507 CK=CTS_40 RB=rst_n
Xx_reg_reg[4] QDFFRBN $PINS Q=x_reg[4] D=N483 CK=CTS_37
+ RB=FE_OFN70_FE_DBTN17_n206
Xx_reg_reg[10] QDFFRBN $PINS Q=x_reg[10] D=N489 CK=CTS_37
+ RB=FE_OFN70_FE_DBTN17_n206
Xy_reg_reg[4] QDFFRBN $PINS Q=y_reg[4] D=N501 CK=CTS_40
+ RB=FE_OFN72_FE_DBTN17_n206
Xy_reg_reg[2] QDFFRBN $PINS Q=y_reg[2] D=FE_PHN1450_N499 CK=CTS_40
+ RB=FE_OFN72_FE_DBTN17_n206
Xx_reg_reg[0] QDFFRBN $PINS Q=x_reg[0] D=N479 CK=CTS_37
+ RB=FE_OFN70_FE_DBTN17_n206
Xx_reg_reg[2] QDFFRBN $PINS Q=x_reg[2] D=FE_PHN1426_N481 CK=CTS_37
+ RB=FE_OFN70_FE_DBTN17_n206
Xy_reg_reg[0] QDFFRBN $PINS Q=y_reg[0] D=N497 CK=CTS_40
+ RB=FE_OFN72_FE_DBTN17_n206
Xy_reg_reg[7] QDFFRBN $PINS Q=y_reg[7] D=N504 CK=CTS_40 RB=rst_n
Xx_reg_reg[7] QDFFRBN $PINS Q=x_reg[7] D=N486 CK=CTS_37
+ RB=FE_OFN70_FE_DBTN17_n206
Xy_reg_reg[5] QDFFRBN $PINS Q=y_reg[5] D=FE_PHN1441_N502 CK=CTS_40
+ RB=FE_OFN72_FE_DBTN17_n206
Xx_reg_reg[5] QDFFRBN $PINS Q=x_reg[5] D=N484 CK=CTS_37
+ RB=FE_OFN70_FE_DBTN17_n206
Xy_reg_reg[8] QDFFRBN $PINS Q=y_reg[8] D=N505 CK=CTS_40 RB=rst_n
Xx_reg_reg[8] QDFFRBN $PINS Q=x_reg[8] D=N487 CK=CTS_37
+ RB=FE_OFN70_FE_DBTN17_n206
Xy_reg_reg[6] QDFFRBN $PINS Q=y_reg[6] D=N503 CK=CTS_40 RB=rst_n
Xx_reg_reg[6] QDFFRBN $PINS Q=FE_PHN1155_x_reg_6 D=N485 CK=CTS_37
+ RB=FE_OFN70_FE_DBTN17_n206
Xy_reg_reg[9] QDFFRBN $PINS Q=y_reg[9] D=N506 CK=CTS_40 RB=rst_n
Xx_reg_reg[9] QDFFRBN $PINS Q=x_reg[9] D=N488 CK=CTS_37
+ RB=FE_OFN70_FE_DBTN17_n206
Xvalid_out_reg QDFFRBN $PINS Q=valid_out D=N515 CK=clk
+ RB=FE_OFN74_FE_DBTN17_n206
Xstep_cnt_reg[2] QDFFRBN $PINS Q=step_cnt[2] D=N460 CK=net2384
+ RB=FE_OFN72_FE_DBTN17_n206
Xstep_cnt_reg[3] QDFFRBN $PINS Q=step_cnt[3] D=FE_PHN1034_N461 CK=net2384
+ RB=FE_OFN72_FE_DBTN17_n206
Xstep_cnt_reg[1] QDFFRBN $PINS Q=step_cnt[1] D=FE_PHN1278_N459 CK=net2384
+ RB=FE_OFN72_FE_DBTN17_n206
Xstep_cnt_reg[0] DFFRBN $PINS Q=step_cnt[0] QB=n432 D=N458 CK=net2384
+ RB=FE_OFN72_FE_DBTN17_n206
XU3 NR2P $PINS O=n60 I1=n321 I2=z_reg[15]
XU4 NR2P $PINS O=n61 I1=n321 I2=z_reg[15]
XU5 NR2 $PINS O=N147 I1=x_in[16] I2=sub_87/carry[16]
XU6 NR2 $PINS O=n154 I1=n166 I2=n42
XU7 OAI12HS $PINS O=n430 A1=is_computing B1=n315 B2=n432
XU8 NR2 $PINS O=sub_87/carry[2] I1=N130 I2=x_in[1]
XU9 NR2 $PINS O=sub_88/carry[2] I1=N148 I2=y_in[1]
XU10 NR2 $PINS O=N165 I1=y_in[16] I2=sub_88/carry[16]
XU11 ND3P $PINS O=n133 I1=n316 I2=n318 I3=n317
XU16 ND2S $PINS O=n164 I1=N108 I2=n318
XU17 ND3S $PINS O=n135 I1=step_cnt[2] I2=step_cnt[0] I3=n429
XU18 AOI12HS $PINS O=n4 A1=n425 B1=n423 B2=n424
XU29 INV1S $PINS O=n42 I=n165
XU32 AN3 $PINS O=n166 I1=step_cnt[3] I2=n316 I3=n317
XU36 INV1S $PINS O=n41 I=n163
XU45 INV2 $PINS O=n318 I=step_cnt[3]
XU60 OA222 $PINS O=n226 A1=FE_OFN247_n164 A2=n190 B1=FE_DBTN159_y_reg_10
+ B2=n165 C1=n150 C2=FE_OFN202_n166
XU61 INV1S $PINS O=n315 I=step_cnt[1]
XU62 ND2 $PINS O=n313 I1=step_cnt[2] I2=n317
XU65 OA222S $PINS O=n287 A1=FE_OFN247_n164 A2=n274 B1=n165
+ B2=FE_DBTN165_x_reg_11 C1=FE_OFN202_n166 C2=FE_DBTN158_x_reg_10
XU66 OA222S $PINS O=n288 A1=n163 A2=n246 B1=n141 B2=n262 C1=FE_DBTN156_n225
+ C2=n255
XU67 OA222S $PINS O=n281 A1=FE_OFN247_n164 A2=n268 B1=n165
+ B2=FE_DBTN163_x_reg_12 C1=FE_OFN202_n166 C2=FE_DBTN165_x_reg_11
XU68 OA222S $PINS O=n282 A1=n163 A2=FE_DBTN158_x_reg_10 B1=n141 B2=n255
+ C1=FE_DBTN156_n225 C2=n247
XU69 OA222S $PINS O=n197 A1=FE_OFN247_n164 A2=n184 B1=FE_DBTN164_y_reg_11
+ B2=n165 C1=FE_DBTN159_y_reg_10 C2=FE_OFN202_n166
XU70 OA222S $PINS O=n198 A1=n150 A2=n163 B1=n141 B2=n172 C1=FE_DBTN156_n225
+ C2=n161
XU71 OA222S $PINS O=n191 A1=FE_OFN247_n164 A2=n178 B1=FE_DBTN162_y_reg_12
+ B2=n165 C1=FE_DBTN164_y_reg_11 C2=FE_OFN202_n166
XU72 OA222S $PINS O=n192 A1=FE_DBTN159_y_reg_10 A2=n163 B1=n141 B2=n161
+ C1=FE_DBTN156_n225 C2=n151
XU73 OA222S $PINS O=n275 A1=FE_OFN247_n164 A2=n262 B1=n165
+ B2=FE_DBTN160_x_reg_13 C1=FE_OFN202_n166 C2=FE_DBTN163_x_reg_12
XU74 OA222S $PINS O=n276 A1=n163 A2=FE_DBTN165_x_reg_11 B1=n141 B2=n247
+ C1=FE_DBTN156_n225 C2=n246
XU75 OA222S $PINS O=n185 A1=FE_OFN247_n164 A2=n172 B1=FE_DBTN161_y_reg_13
+ B2=n165 C1=FE_DBTN162_y_reg_12 C2=FE_OFN202_n166
XU76 OA222S $PINS O=n186 A1=FE_DBTN164_y_reg_11 A2=n163 B1=n141 B2=n151
+ C1=FE_DBTN156_n225 C2=n150
XU77 OA222S $PINS O=n269 A1=FE_OFN247_n164 A2=n255 B1=n165 B2=n240
+ C1=FE_OFN202_n166 C2=FE_DBTN160_x_reg_13
XU78 OA222S $PINS O=n270 A1=n163 A2=FE_DBTN163_x_reg_12 B1=n141 B2=n246
+ C1=FE_DBTN156_n225 C2=FE_DBTN158_x_reg_10
XU79 OA222S $PINS O=n179 A1=FE_OFN247_n164 A2=n161 B1=n142 B2=n165
+ C1=FE_DBTN161_y_reg_13 C2=FE_OFN202_n166
XU80 OA222S $PINS O=n180 A1=FE_DBTN162_y_reg_12 A2=n163 B1=n141 B2=n150
+ C1=FE_DBTN156_n225 C2=FE_DBTN159_y_reg_10
XU81 OA222S $PINS O=n263 A1=FE_OFN247_n164 A2=n247 B1=n165 B2=n238
+ C1=FE_OFN202_n166 C2=n240
XU82 OA222S $PINS O=n264 A1=n163 A2=FE_DBTN160_x_reg_13 B1=n141
+ B2=FE_DBTN158_x_reg_10 C1=FE_DBTN156_n225 C2=FE_DBTN165_x_reg_11
XU83 OA222S $PINS O=n173 A1=FE_OFN247_n164 A2=n151 B1=n138 B2=n165 C1=n142
+ C2=FE_OFN202_n166
XU84 OA222S $PINS O=n174 A1=FE_DBTN161_y_reg_13 A2=n163 B1=n141
+ B2=FE_DBTN159_y_reg_10 C1=FE_DBTN156_n225 C2=FE_DBTN164_y_reg_11
XU85 OA222S $PINS O=n257 A1=FE_OFN247_n164 A2=n246 B1=n165 B2=n237
+ C1=FE_OFN202_n166 C2=n238
XU86 OA222S $PINS O=n258 A1=n163 A2=n240 B1=n141 B2=FE_DBTN165_x_reg_11
+ C1=FE_DBTN156_n225 C2=FE_DBTN163_x_reg_12
XU87 OA222S $PINS O=n167 A1=FE_OFN247_n164 A2=n150 B1=n136 B2=n165 C1=n138
+ C2=FE_OFN202_n166
XU88 OA222S $PINS O=n168 A1=n142 A2=n163 B1=n141 B2=FE_DBTN164_y_reg_11
+ C1=FE_DBTN156_n225 C2=FE_DBTN162_y_reg_12
XU89 OA222S $PINS O=n250 A1=FE_OFN248_n164 A2=FE_DBTN158_x_reg_10 B1=n165
+ B2=n239 C1=FE_OFN202_n166 C2=n237
XU90 OA222S $PINS O=n251 A1=n163 A2=n238 B1=n141 B2=FE_DBTN163_x_reg_12
+ C1=FE_DBTN156_n225 C2=FE_DBTN160_x_reg_13
XU91 OA222S $PINS O=n156 A1=FE_OFN247_n164 A2=FE_DBTN159_y_reg_10 B1=n140
+ B2=n165 C1=n136 C2=FE_OFN202_n166
XU92 OA222S $PINS O=n157 A1=n138 A2=n163 B1=n141 B2=FE_DBTN162_y_reg_12
+ C1=FE_DBTN156_n225 C2=FE_DBTN161_y_reg_13
XU93 ND3S $PINS O=N112 I1=n313 I2=n133 I3=n434
XU94 ND3S $PINS O=N113 I1=n213 I2=n133 I3=n435
XU95 OA222S $PINS O=n297 A1=FE_DBTN155_n144 A2=n237 B1=n212 B2=n239
+ C1=FE_OFN248_n164 C2=n238
XU96 OA222S $PINS O=n211 A1=FE_DBTN155_n144 A2=n136 B1=n212 B2=n140 C1=n138
+ C2=FE_OFN248_n164
XU97 ND2S $PINS O=N109 I1=n311 I2=n133
XU98 ND3S $PINS O=n311 I1=n432 I2=n315 I3=step_cnt[2]
XU99 AO222S $PINS O=n309 A1=x_reg[0] A2=n40 B1=x_reg[4] B2=n144 C1=x_reg[7]
+ C2=n45
XU100 AO222S $PINS O=n229 A1=y_reg[0] A2=n40 B1=y_reg[4] B2=n144 C1=y_reg[7]
+ C2=n45
XU101 ND3 $PINS O=n213 I1=n314 I2=n318 I3=step_cnt[1]
XU102 ND3S $PINS O=n322 I1=step_cnt[1] I2=n316 I3=step_cnt[0]
XU103 ND3S $PINS O=n312 I1=step_cnt[1] I2=n432 I3=step_cnt[2]
XU104 AO222S $PINS O=n290 A1=n40 A2=x_reg[1] B1=n144 B2=FE_PHN1150_x_reg_5
+ C1=n45 C2=x_reg[8]
XU105 AO222S $PINS O=n200 A1=n40 A2=y_reg[1] B1=n144 B2=y_reg[5] C1=n45
+ C2=y_reg[8]
XU106 ND3 $PINS O=n163 I1=n314 I2=n315 I3=step_cnt[3]
XU107 ND3S $PINS O=n165 I1=step_cnt[3] I2=n314 I3=step_cnt[1]
XU108 OA222S $PINS O=n242 A1=FE_DBTN156_n225 A2=n240 B1=n154 B2=n239 C1=n141
+ C2=FE_DBTN160_x_reg_13
XU109 OA222S $PINS O=n146 A1=n142 A2=FE_DBTN156_n225 B1=n154 B2=n140 C1=n141
+ C2=FE_DBTN161_y_reg_13
XU110 OA222S $PINS O=n232 A1=FE_DBTN156_n225 A2=n238 B1=n139 B2=n239 C1=n141
+ C2=n240
XU111 OA222S $PINS O=n129 A1=FE_DBTN156_n225 A2=n138 B1=n139 B2=n140 C1=n141
+ C2=n142
XU112 OA222S $PINS O=n300 A1=n133 A2=FE_DBTN163_x_reg_12 B1=FE_DBTN154_n40
+ B2=FE_DBTN165_x_reg_11 C1=n213 C2=FE_DBTN160_x_reg_13
XU113 OA222S $PINS O=n216 A1=FE_DBTN162_y_reg_12 A2=n133 B1=FE_OFN220_n40
+ B2=FE_DBTN164_y_reg_11 C1=FE_DBTN161_y_reg_13 C2=n213
XU114 OA222S $PINS O=n295 A1=FE_OFN220_n40 A2=FE_DBTN160_x_reg_13 B1=n209
+ B2=n239 C1=FE_OFN248_n164 C2=n237
XU115 OA222S $PINS O=n208 A1=FE_DBTN161_y_reg_13 A2=FE_OFN220_n40 B1=n209
+ B2=n140 C1=FE_OFN248_n164 C2=n136
XU116 OA12S $PINS O=n428 A1=n430 B1=step_cnt[2] B2=n321
XU117 ND2S $PINS O=n431 I1=is_computing I2=n432
XU159 AN3 $PINS O=n40 I1=n315 I2=n318 I3=n314
XU161 INV1S $PINS O=n110 I=N130
XU162 INV1S $PINS O=n127 I=N148
XU163 INV1S $PINS O=n109 I=x_in[1]
XU164 INV1S $PINS O=n126 I=y_in[1]
XU165 INV1S $PINS O=n108 I=x_in[2]
XU166 INV1S $PINS O=n125 I=y_in[2]
XU167 INV1S $PINS O=n124 I=y_in[3]
XU168 INV1S $PINS O=n107 I=x_in[3]
XU169 INV1S $PINS O=n123 I=y_in[4]
XU170 INV1S $PINS O=n106 I=x_in[4]
XU171 INV1S $PINS O=n122 I=y_in[5]
XU172 INV1S $PINS O=n105 I=x_in[5]
XU173 INV1S $PINS O=n121 I=y_in[6]
XU174 INV1S $PINS O=n104 I=x_in[6]
XU175 INV1S $PINS O=n120 I=y_in[7]
XU176 INV1S $PINS O=n103 I=x_in[7]
XU177 INV1S $PINS O=n119 I=y_in[8]
XU178 INV1S $PINS O=n102 I=x_in[8]
XU179 INV1S $PINS O=n118 I=y_in[9]
XU180 INV1S $PINS O=n101 I=x_in[9]
XU181 INV1S $PINS O=n100 I=x_in[10]
XU182 INV1S $PINS O=n117 I=y_in[10]
XU183 INV1S $PINS O=n99 I=x_in[11]
XU184 INV1S $PINS O=n116 I=y_in[11]
XU185 INV1S $PINS O=n98 I=x_in[12]
XU186 INV1S $PINS O=n115 I=y_in[12]
XU187 INV1S $PINS O=n97 I=x_in[13]
XU188 INV1S $PINS O=n114 I=y_in[13]
XU189 INV1S $PINS O=n96 I=x_in[14]
XU190 INV1S $PINS O=n113 I=y_in[14]
XU191 INV1S $PINS O=n95 I=x_in[15]
XU192 INV1S $PINS O=n112 I=y_in[15]
XU193 INV1S $PINS O=n94 I=x_in[16]
XU194 INV1S $PINS O=n111 I=y_in[16]
XU199 NR2 $PINS O=n144 I1=n311 I2=step_cnt[3]
XU209 XOR2HS $PINS O=N438 I1=FE_PHN1061_x_reg_17 I2=add_116/carry[17]
XU210 AN2 $PINS O=add_116/carry[17] I1=add_116/carry[16] I2=FE_PHN1105_x_reg_16
XU211 XOR2HS $PINS O=N437 I1=FE_PHN1105_x_reg_16 I2=add_116/carry[16]
XU212 AN2 $PINS O=add_116/carry[16] I1=add_116/carry[15] I2=x_reg[15]
XU213 XOR2HS $PINS O=N436 I1=x_reg[15] I2=add_116/carry[15]
XU214 AN2 $PINS O=add_116/carry[15] I1=add_116/carry[14] I2=x_reg[14]
XU215 XOR2HS $PINS O=N435 I1=x_reg[14] I2=add_116/carry[14]
XU216 AN2 $PINS O=add_116/carry[14] I1=add_116/carry[13] I2=x_reg[13]
XU217 XOR2HS $PINS O=FE_PHN1300_N434 I1=x_reg[13] I2=add_116/carry[13]
XU218 AN2 $PINS O=add_116/carry[13] I1=add_116/carry[12] I2=x_reg[12]
XU219 XOR2HS $PINS O=N433 I1=x_reg[12] I2=add_116/carry[12]
XU220 AN2 $PINS O=add_116/carry[12] I1=add_116/carry[11] I2=FE_PHN1157_x_reg_11
XU221 XOR2HS $PINS O=N432 I1=FE_PHN1157_x_reg_11 I2=add_116/carry[11]
XU222 AN2 $PINS O=add_116/carry[11] I1=add_116/carry[10] I2=FE_PHN1162_x_reg_10
XU223 XOR2HS $PINS O=N431 I1=FE_PHN1162_x_reg_10 I2=add_116/carry[10]
XU224 AN2 $PINS O=add_116/carry[10] I1=add_116/carry[9] I2=FE_PHN1161_x_reg_9
XU225 XOR2HS $PINS O=N430 I1=FE_PHN1161_x_reg_9 I2=add_116/carry[9]
XU226 AN2 $PINS O=add_116/carry[9] I1=add_116/carry[8] I2=x_reg[8]
XU227 XOR2HS $PINS O=N429 I1=x_reg[8] I2=add_116/carry[8]
XU228 AN2 $PINS O=add_116/carry[8] I1=add_116/carry[7] I2=x_reg[7]
XU229 XOR2HS $PINS O=FE_PHN1310_N428 I1=x_reg[7] I2=add_116/carry[7]
XU230 AN2 $PINS O=add_116/carry[7] I1=add_116/carry[6] I2=x_reg[6]
XU231 XOR2HS $PINS O=FE_PHN1294_N427 I1=x_reg[6] I2=add_116/carry[6]
XU232 AN2 $PINS O=add_116/carry[6] I1=x_reg[4] I2=FE_PHN1150_x_reg_5
XU233 XOR2HS $PINS O=N426 I1=FE_PHN1150_x_reg_5 I2=x_reg[4]
XU234 XOR2HS $PINS O=N451 I1=y_reg[17] I2=add_117/carry[17]
XU235 AN2 $PINS O=add_117/carry[17] I1=add_117/carry[16] I2=y_reg[16]
XU236 XOR2HS $PINS O=N450 I1=y_reg[16] I2=add_117/carry[16]
XU237 AN2 $PINS O=add_117/carry[16] I1=add_117/carry[15] I2=FE_PHN1149_y_reg_15
XU238 XOR2HS $PINS O=N449 I1=FE_PHN1149_y_reg_15 I2=add_117/carry[15]
XU239 AN2 $PINS O=add_117/carry[15] I1=add_117/carry[14] I2=y_reg[14]
XU240 XOR2HS $PINS O=FE_PHN1456_N448 I1=y_reg[14] I2=add_117/carry[14]
XU241 AN2 $PINS O=add_117/carry[14] I1=add_117/carry[13] I2=y_reg[13]
XU242 XOR2HS $PINS O=N447 I1=y_reg[13] I2=add_117/carry[13]
XU243 AN2 $PINS O=add_117/carry[13] I1=add_117/carry[12] I2=y_reg[12]
XU244 XOR2HS $PINS O=N446 I1=y_reg[12] I2=add_117/carry[12]
XU245 AN2 $PINS O=add_117/carry[12] I1=add_117/carry[11] I2=y_reg[11]
XU246 XOR2HS $PINS O=N445 I1=y_reg[11] I2=add_117/carry[11]
XU247 AN2 $PINS O=add_117/carry[11] I1=add_117/carry[10] I2=y_reg[10]
XU248 XOR2HS $PINS O=N444 I1=y_reg[10] I2=add_117/carry[10]
XU249 AN2 $PINS O=add_117/carry[10] I1=add_117/carry[9] I2=y_reg[9]
XU250 XOR2HS $PINS O=N443 I1=y_reg[9] I2=add_117/carry[9]
XU251 AN2 $PINS O=add_117/carry[9] I1=add_117/carry[8] I2=y_reg[8]
XU252 XOR2HS $PINS O=N442 I1=y_reg[8] I2=add_117/carry[8]
XU253 AN2 $PINS O=add_117/carry[8] I1=add_117/carry[7] I2=y_reg[7]
XU254 XOR2HS $PINS O=N441 I1=y_reg[7] I2=add_117/carry[7]
XU255 AN2 $PINS O=add_117/carry[7] I1=add_117/carry[6] I2=y_reg[6]
XU256 XOR2HS $PINS O=FE_PHN1042_N440 I1=y_reg[6] I2=add_117/carry[6]
XU257 AN2 $PINS O=add_117/carry[6] I1=y_reg[4] I2=y_reg[5]
XU258 XOR2HS $PINS O=N439 I1=y_reg[5] I2=y_reg[4]
XU259 XOR2HS $PINS O=N146 I1=n94 I2=sub_87/carry[16]
XU260 AN2 $PINS O=sub_87/carry[16] I1=sub_87/carry[15] I2=n95
XU261 XOR2HS $PINS O=N145 I1=n95 I2=sub_87/carry[15]
XU262 AN2 $PINS O=sub_87/carry[15] I1=sub_87/carry[14] I2=n96
XU263 XOR2HS $PINS O=N144 I1=n96 I2=sub_87/carry[14]
XU264 AN2 $PINS O=sub_87/carry[14] I1=sub_87/carry[13] I2=n97
XU265 XOR2HS $PINS O=N143 I1=n97 I2=sub_87/carry[13]
XU266 AN2 $PINS O=sub_87/carry[13] I1=sub_87/carry[12] I2=n98
XU267 XOR2HS $PINS O=N142 I1=n98 I2=sub_87/carry[12]
XU268 AN2 $PINS O=sub_87/carry[12] I1=sub_87/carry[11] I2=n99
XU269 XOR2HS $PINS O=N141 I1=n99 I2=sub_87/carry[11]
XU270 AN2 $PINS O=sub_87/carry[11] I1=sub_87/carry[10] I2=n100
XU271 XOR2HS $PINS O=N140 I1=n100 I2=sub_87/carry[10]
XU272 AN2 $PINS O=sub_87/carry[10] I1=sub_87/carry[9] I2=n101
XU273 XOR2HS $PINS O=N139 I1=n101 I2=sub_87/carry[9]
XU274 AN2 $PINS O=sub_87/carry[9] I1=sub_87/carry[8] I2=n102
XU275 XOR2HS $PINS O=N138 I1=n102 I2=sub_87/carry[8]
XU276 AN2 $PINS O=sub_87/carry[8] I1=sub_87/carry[7] I2=n103
XU277 XOR2HS $PINS O=N137 I1=n103 I2=sub_87/carry[7]
XU278 AN2 $PINS O=sub_87/carry[7] I1=sub_87/carry[6] I2=n104
XU279 XOR2HS $PINS O=N136 I1=n104 I2=sub_87/carry[6]
XU280 AN2 $PINS O=sub_87/carry[6] I1=sub_87/carry[5] I2=n105
XU281 XOR2HS $PINS O=N135 I1=n105 I2=sub_87/carry[5]
XU282 AN2 $PINS O=sub_87/carry[5] I1=sub_87/carry[4] I2=n106
XU283 XOR2HS $PINS O=N134 I1=n106 I2=sub_87/carry[4]
XU284 AN2 $PINS O=sub_87/carry[4] I1=sub_87/carry[3] I2=n107
XU285 XOR2HS $PINS O=N133 I1=n107 I2=sub_87/carry[3]
XU286 AN2 $PINS O=sub_87/carry[3] I1=sub_87/carry[2] I2=n108
XU287 XOR2HS $PINS O=N132 I1=n108 I2=sub_87/carry[2]
XU288 XOR2HS $PINS O=N131 I1=n109 I2=n110
XU289 XOR2HS $PINS O=N164 I1=n111 I2=sub_88/carry[16]
XU290 AN2 $PINS O=sub_88/carry[16] I1=sub_88/carry[15] I2=n112
XU291 XOR2HS $PINS O=N163 I1=n112 I2=sub_88/carry[15]
XU292 AN2 $PINS O=sub_88/carry[15] I1=sub_88/carry[14] I2=n113
XU293 XOR2HS $PINS O=N162 I1=n113 I2=sub_88/carry[14]
XU294 AN2 $PINS O=sub_88/carry[14] I1=sub_88/carry[13] I2=n114
XU295 XOR2HS $PINS O=N161 I1=n114 I2=sub_88/carry[13]
XU296 AN2 $PINS O=sub_88/carry[13] I1=sub_88/carry[12] I2=n115
XU297 XOR2HS $PINS O=N160 I1=n115 I2=sub_88/carry[12]
XU298 AN2 $PINS O=sub_88/carry[12] I1=sub_88/carry[11] I2=n116
XU299 XOR2HS $PINS O=N159 I1=n116 I2=sub_88/carry[11]
XU300 AN2 $PINS O=sub_88/carry[11] I1=sub_88/carry[10] I2=n117
XU301 XOR2HS $PINS O=N158 I1=n117 I2=sub_88/carry[10]
XU302 AN2 $PINS O=sub_88/carry[10] I1=sub_88/carry[9] I2=n118
XU303 XOR2HS $PINS O=N157 I1=n118 I2=sub_88/carry[9]
XU304 AN2 $PINS O=sub_88/carry[9] I1=sub_88/carry[8] I2=n119
XU305 XOR2HS $PINS O=N156 I1=n119 I2=sub_88/carry[8]
XU306 AN2 $PINS O=sub_88/carry[8] I1=sub_88/carry[7] I2=n120
XU307 XOR2HS $PINS O=N155 I1=n120 I2=sub_88/carry[7]
XU308 AN2 $PINS O=sub_88/carry[7] I1=sub_88/carry[6] I2=n121
XU309 XOR2HS $PINS O=N154 I1=n121 I2=sub_88/carry[6]
XU310 AN2 $PINS O=sub_88/carry[6] I1=sub_88/carry[5] I2=n122
XU311 XOR2HS $PINS O=N153 I1=n122 I2=sub_88/carry[5]
XU312 AN2 $PINS O=sub_88/carry[5] I1=sub_88/carry[4] I2=n123
XU313 XOR2HS $PINS O=N152 I1=n123 I2=sub_88/carry[4]
XU314 AN2 $PINS O=sub_88/carry[4] I1=sub_88/carry[3] I2=n124
XU315 XOR2HS $PINS O=N151 I1=n124 I2=sub_88/carry[3]
XU316 AN2 $PINS O=sub_88/carry[3] I1=sub_88/carry[2] I2=n125
XU317 XOR2HS $PINS O=N150 I1=n125 I2=sub_88/carry[2]
XU318 XOR2HS $PINS O=N149 I1=n126 I2=n127
XU319 ND3 $PINS O=y_shift[9] I1=n128 I2=n129 I3=n130
XU320 NR2 $PINS O=n130 I1=n131 I2=n132
XU321 MOAI1S $PINS O=n132 A1=n133 A2=FE_DBTN159_y_reg_10 B1=n446 B2=y_reg[11]
XU322 MOAI1S $PINS O=n131 A1=FE_OFN189_n135 A2=n136 B1=n40 B2=y_reg[9]
XU323 AOI22S $PINS O=n128 A1=y_reg[12] A2=n143 B1=y_reg[13] B2=FE_OFN154_n144
XU324 ND3 $PINS O=y_shift[8] I1=n145 I2=n146 I3=n147
XU325 NR2 $PINS O=n147 I1=n148 I2=n149
XU326 MOAI1S $PINS O=n149 A1=n150 A2=n133 B1=n446 B2=y_reg[10]
XU327 OAI222S $PINS O=n148 A1=FE_DBTN154_n40 A2=n151 B1=FE_DBTN162_y_reg_12
+ B2=FE_DBTN155_n144 C1=n138 C2=FE_OFN189_n135
XU328 AOI22S $PINS O=n145 A1=n41 A2=y_reg[16] B1=y_reg[11] B2=n143
XU329 ND3 $PINS O=y_shift[7] I1=n156 I2=n157 I3=n158
XU330 NR2 $PINS O=n158 I1=n159 I2=n160
XU331 MOAI1S $PINS O=n160 A1=n133 A2=n151 B1=y_reg[9] B2=n446
XU332 OAI222S $PINS O=n159 A1=FE_DBTN154_n40 A2=n161 B1=FE_DBTN155_n144
+ B2=FE_DBTN164_y_reg_11 C1=n142 C2=FE_OFN189_n135
XU333 ND3 $PINS O=y_shift[6] I1=n167 I2=n168 I3=n169
XU334 NR2 $PINS O=n169 I1=n170 I2=n171
XU335 MOAI1S $PINS O=n171 A1=n133 A2=n161 B1=n446 B2=y_reg[8]
XU336 OAI222S $PINS O=n170 A1=FE_DBTN154_n40 A2=n172 B1=FE_DBTN155_n144
+ B2=FE_DBTN159_y_reg_10 C1=FE_DBTN161_y_reg_13 C2=FE_OFN189_n135
XU337 ND3 $PINS O=y_shift[5] I1=n173 I2=n174 I3=n175
XU338 NR2 $PINS O=n175 I1=n176 I2=n177
XU339 MOAI1S $PINS O=n177 A1=n133 A2=n172 B1=n446 B2=y_reg[7]
XU340 OAI222S $PINS O=n176 A1=FE_DBTN154_n40 A2=n178 B1=FE_DBTN155_n144 B2=n150
+ C1=FE_DBTN162_y_reg_12 C2=FE_OFN189_n135
XU341 ND3 $PINS O=y_shift[4] I1=n179 I2=n180 I3=n181
XU342 NR2 $PINS O=n181 I1=n182 I2=n183
XU343 MOAI1S $PINS O=n183 A1=n133 A2=n178 B1=n446 B2=y_reg[6]
XU344 OAI222S $PINS O=n182 A1=FE_DBTN154_n40 A2=n184 B1=FE_DBTN155_n144 B2=n151
+ C1=FE_OFN189_n135 C2=FE_DBTN164_y_reg_11
XU345 ND3 $PINS O=y_shift[3] I1=n185 I2=n186 I3=n187
XU346 NR2 $PINS O=n187 I1=n188 I2=n189
XU347 MOAI1S $PINS O=n189 A1=n133 A2=n184 B1=n446 B2=y_reg[5]
XU348 OAI222S $PINS O=n188 A1=FE_DBTN154_n40 A2=n190 B1=FE_DBTN155_n144 B2=n161
+ C1=FE_OFN189_n135 C2=FE_DBTN159_y_reg_10
XU349 ND3 $PINS O=y_shift[2] I1=n191 I2=n192 I3=n193
XU350 NR2 $PINS O=n193 I1=n194 I2=n195
XU351 MOAI1S $PINS O=n195 A1=n133 A2=n190 B1=n446 B2=y_reg[4]
XU352 OAI222S $PINS O=n194 A1=FE_DBTN154_n40 A2=n196 B1=FE_DBTN155_n144 B2=n172
+ C1=n150 C2=FE_OFN189_n135
XU353 ND3 $PINS O=y_shift[1] I1=n197 I2=n198 I3=n199
XU354 NR2 $PINS O=n199 I1=n200 I2=n201
XU355 MOAI1S $PINS O=n201 A1=n133 A2=n196 B1=n446 B2=y_reg[3]
XU357 INV1S $PINS O=n184 I=y_reg[4]
XU358 MOAI1S $PINS O=y_shift[16] A1=FE_OFN220_n40 A2=n136 B1=y_reg[17] B2=n202
XU359 OAI222S $PINS O=y_shift[15] A1=n138 A2=FE_OFN220_n40 B1=n203 B2=n140
+ C1=n136 C2=n133
XU360 ND2 $PINS O=y_shift[14] I1=n204 I2=n205
XU361 AOI22S $PINS O=n205 A1=y_reg[17] A2=n206 B1=n40 B2=y_reg[14]
XU362 AOI22S $PINS O=n204 A1=FE_OFN121_n213 A2=y_reg[16] B1=n46
+ B2=FE_PHN1149_y_reg_15
XU363 ND2 $PINS O=y_shift[13] I1=n207 I2=n208
XU364 AOI22S $PINS O=n207 A1=FE_OFN121_n213 A2=FE_PHN1149_y_reg_15 B1=n46
+ B2=y_reg[14]
XU365 ND2 $PINS O=y_shift[12] I1=n210 I2=n211
XU366 INV1S $PINS O=n138 I=FE_PHN1149_y_reg_15
XU367 INV1S $PINS O=n140 I=y_reg[17]
XU368 INV1S $PINS O=n136 I=y_reg[16]
XU369 OA222 $PINS O=n210 A1=FE_DBTN161_y_reg_13 A2=n133 B1=FE_DBTN162_y_reg_12
+ B2=FE_OFN220_n40 C1=n142 C2=n213
XU370 INV1S $PINS O=n142 I=y_reg[14]
XU371 ND3 $PINS O=y_shift[11] I1=n214 I2=n215 I3=n216
XU372 AOI22S $PINS O=n215 A1=y_reg[17] A2=n217 B1=y_reg[16] B2=FE_OFN184_n218
XU373 AOI22S $PINS O=n214 A1=n143 A2=y_reg[14] B1=FE_OFN154_n144
+ B2=FE_PHN1149_y_reg_15
XU374 ND3 $PINS O=y_shift[10] I1=n219 I2=n220 I3=n221
XU375 NR2 $PINS O=n221 I1=n222 I2=n223
XU376 MOAI1S $PINS O=n223 A1=FE_DBTN164_y_reg_11 A2=n133 B1=y_reg[12] B2=n446
XU377 MOAI1S $PINS O=n222 A1=FE_OFN220_n40 A2=FE_DBTN159_y_reg_10 B1=y_reg[14]
+ B2=FE_OFN154_n144
XU378 AOI22S $PINS O=n220 A1=y_reg[17] A2=n224 B1=FE_PHN1149_y_reg_15
+ B2=FE_OFN184_n218
XU379 AOI22S $PINS O=n219 A1=y_reg[16] A2=FE_OFN168_n225 B1=y_reg[13] B2=n143
XU380 ND3 $PINS O=y_shift[0] I1=n226 I2=n227 I3=n228
XU381 NR2 $PINS O=n228 I1=n229 I2=n230
XU382 MOAI1S $PINS O=n230 A1=n213 A2=n196 B1=n46 B2=y_reg[1]
XU383 INV1S $PINS O=n196 I=y_reg[2]
XU384 OA222 $PINS O=n227 A1=n163 A2=n151 B1=n141 B2=n178 C1=FE_DBTN156_n225
+ C2=n172
XU386 INV1S $PINS O=n178 I=y_reg[5]
XU389 INV1S $PINS O=n190 I=y_reg[3]
XU390 ND3 $PINS O=x_shift[9] I1=n231 I2=n232 I3=n233
XU391 NR2 $PINS O=n233 I1=n234 I2=n235
XU392 MOAI1S $PINS O=n235 A1=n133 A2=FE_DBTN158_x_reg_10 B1=FE_OFN121_n213
+ B2=FE_PHN1157_x_reg_11
XU393 MOAI1S $PINS O=n234 A1=FE_OFN189_n135 A2=n237 B1=n40
+ B2=FE_PHN1161_x_reg_9
XU394 AOI22S $PINS O=n231 A1=x_reg[12] A2=n143 B1=x_reg[13] B2=FE_OFN154_n144
XU395 ND3 $PINS O=x_shift[8] I1=n241 I2=n242 I3=n243
XU396 NR2 $PINS O=n243 I1=n244 I2=n245
XU397 MOAI1S $PINS O=n245 A1=n133 A2=n246 B1=FE_OFN121_n213
+ B2=FE_PHN1162_x_reg_10
XU398 OAI222S $PINS O=n244 A1=FE_DBTN154_n40 A2=n247 B1=FE_DBTN155_n144
+ B2=FE_DBTN163_x_reg_12 C1=FE_OFN189_n135 C2=n238
XU399 AOI22S $PINS O=n241 A1=x_reg[16] A2=n41 B1=FE_PHN1157_x_reg_11 B2=n143
XU400 ND3 $PINS O=x_shift[7] I1=n250 I2=n251 I3=n252
XU401 NR2 $PINS O=n252 I1=n253 I2=n254
XU402 MOAI1S $PINS O=n254 A1=n133 A2=n247 B1=FE_OFN121_n213
+ B2=FE_PHN1161_x_reg_9
XU403 OAI222S $PINS O=n253 A1=FE_DBTN154_n40 A2=n255 B1=FE_DBTN155_n144
+ B2=FE_DBTN165_x_reg_11 C1=FE_OFN189_n135 C2=n240
XU404 ND3 $PINS O=x_shift[6] I1=n257 I2=n258 I3=n259
XU405 NR2 $PINS O=n259 I1=n260 I2=n261
XU406 MOAI1S $PINS O=n261 A1=n133 A2=n255 B1=FE_OFN121_n213 B2=x_reg[8]
XU407 OAI222S $PINS O=n260 A1=FE_DBTN154_n40 A2=n262 B1=FE_DBTN155_n144
+ B2=FE_DBTN158_x_reg_10 C1=FE_OFN189_n135 C2=FE_DBTN160_x_reg_13
XU408 ND3 $PINS O=x_shift[5] I1=n263 I2=n264 I3=n265
XU409 NR2 $PINS O=n265 I1=n266 I2=n267
XU410 MOAI1S $PINS O=n267 A1=n133 A2=n262 B1=FE_OFN121_n213 B2=x_reg[7]
XU411 OAI222S $PINS O=n266 A1=FE_DBTN154_n40 A2=n268 B1=FE_DBTN155_n144 B2=n246
+ C1=FE_OFN189_n135 C2=FE_DBTN163_x_reg_12
XU412 ND3 $PINS O=x_shift[4] I1=n269 I2=n270 I3=n271
XU413 NR2 $PINS O=n271 I1=n272 I2=n273
XU414 MOAI1S $PINS O=n273 A1=n133 A2=n268 B1=FE_OFN121_n213 B2=x_reg[6]
XU415 OAI222S $PINS O=n272 A1=FE_DBTN154_n40 A2=n274 B1=FE_DBTN155_n144 B2=n247
+ C1=FE_OFN189_n135 C2=FE_DBTN165_x_reg_11
XU416 ND3 $PINS O=x_shift[3] I1=n275 I2=n276 I3=n277
XU417 NR2 $PINS O=n277 I1=n278 I2=n279
XU418 MOAI1S $PINS O=n279 A1=n133 A2=n274 B1=FE_OFN121_n213
+ B2=FE_PHN1150_x_reg_5
XU419 OAI222S $PINS O=n278 A1=FE_DBTN154_n40 A2=n280 B1=FE_DBTN155_n144 B2=n255
+ C1=FE_OFN189_n135 C2=FE_DBTN158_x_reg_10
XU420 ND3 $PINS O=x_shift[2] I1=n281 I2=n282 I3=n283
XU421 NR2 $PINS O=n283 I1=n284 I2=n285
XU422 MOAI1S $PINS O=n285 A1=n133 A2=n280 B1=n446 B2=x_reg[4]
XU423 OAI222S $PINS O=n284 A1=FE_DBTN154_n40 A2=n286 B1=FE_DBTN155_n144 B2=n262
+ C1=FE_OFN189_n135 C2=n246
XU424 ND3 $PINS O=x_shift[1] I1=n287 I2=n288 I3=n289
XU425 NR2 $PINS O=n289 I1=n290 I2=n291
XU426 MOAI1S $PINS O=n291 A1=n133 A2=n286 B1=n446 B2=x_reg[3]
XU428 INV1S $PINS O=n274 I=x_reg[4]
XU429 MOAI1S $PINS O=x_shift[16] A1=FE_OFN220_n40 A2=n237 B1=x_reg[17] B2=n202
XU430 ND2 $PINS O=n202 I1=n203 I2=n133
XU431 OAI222S $PINS O=x_shift[15] A1=FE_OFN220_n40 A2=n238 B1=n203 B2=n239
+ C1=n133 C2=n237
XU432 NR2 $PINS O=n203 I1=n206 I2=FE_OFN121_n213
XU433 ND2 $PINS O=x_shift[14] I1=n292 I2=n293
XU434 AOI22S $PINS O=n293 A1=x_reg[17] A2=n206 B1=x_reg[14] B2=n40
XU435 ND2 $PINS O=n206 I1=n209 I2=FE_OFN248_n164
XU436 AOI22S $PINS O=n292 A1=x_reg[16] A2=FE_OFN121_n213 B1=x_reg[15] B2=n46
XU437 ND2 $PINS O=x_shift[13] I1=n294 I2=n295
XU438 AN2 $PINS O=n209 I1=n212 I2=FE_DBTN155_n144
XU439 AOI22S $PINS O=n294 A1=x_reg[15] A2=FE_OFN121_n213 B1=x_reg[14] B2=n46
XU440 ND2 $PINS O=x_shift[12] I1=n296 I2=n297
XU441 INV1S $PINS O=n238 I=x_reg[15]
XU442 INV1S $PINS O=n239 I=x_reg[17]
XU443 NR2 $PINS O=n212 I1=n217 I2=FE_OFN184_n218
XU444 INV1S $PINS O=n237 I=x_reg[16]
XU445 OA222 $PINS O=n296 A1=n133 A2=FE_DBTN160_x_reg_13 B1=FE_DBTN154_n40
+ B2=FE_DBTN163_x_reg_12 C1=n213 C2=n240
XU446 INV1S $PINS O=n240 I=x_reg[14]
XU447 ND3 $PINS O=x_shift[11] I1=n298 I2=n299 I3=n300
XU448 AOI22S $PINS O=n299 A1=x_reg[17] A2=n217 B1=x_reg[16] B2=FE_OFN184_n218
XU449 OR2 $PINS O=n217 I1=n224 I2=FE_OFN168_n225
XU450 AOI22S $PINS O=n298 A1=x_reg[14] A2=n143 B1=x_reg[15] B2=FE_OFN154_n144
XU451 ND3 $PINS O=x_shift[10] I1=n301 I2=n302 I3=n303
XU452 NR2 $PINS O=n303 I1=n304 I2=n305
XU453 MOAI1S $PINS O=n305 A1=n133 A2=FE_DBTN165_x_reg_11 B1=FE_OFN121_n213
+ B2=x_reg[12]
XU454 MOAI1S $PINS O=n304 A1=FE_DBTN154_n40 A2=FE_DBTN158_x_reg_10
+ B1=FE_OFN154_n144 B2=x_reg[14]
XU455 AOI22S $PINS O=n302 A1=x_reg[17] A2=n224 B1=x_reg[15] B2=FE_OFN184_n218
XU456 ND2 $PINS O=n224 I1=n139 I2=FE_OFN189_n135
XU457 AN2 $PINS O=n139 I1=n154 I2=n163
XU458 AOI22S $PINS O=n301 A1=x_reg[16] A2=FE_OFN168_n225 B1=x_reg[13] B2=n143
XU459 INV1S $PINS O=n143 I=FE_OFN248_n164
XU460 ND3 $PINS O=x_shift[0] I1=n306 I2=n307 I3=n308
XU461 NR2 $PINS O=n308 I1=n309 I2=n310
XU462 MOAI1S $PINS O=n310 A1=n213 A2=n286 B1=n46 B2=x_reg[1]
XU463 INV1S $PINS O=n286 I=x_reg[2]
XU464 OA222 $PINS O=n307 A1=n163 A2=n247 B1=n141 B2=n268 C1=FE_DBTN156_n225
+ C2=n262
XU466 NR2 $PINS O=n225 I1=n312 I2=step_cnt[3]
XU467 INV1S $PINS O=n268 I=FE_PHN1150_x_reg_5
XU468 NR2 $PINS O=n218 I1=n313 I2=step_cnt[3]
XU470 OA222 $PINS O=n306 A1=FE_OFN247_n164 A2=n280 B1=n165
+ B2=FE_DBTN158_x_reg_10 C1=FE_OFN202_n166 C2=n246
XU472 INV1S $PINS O=n280 I=x_reg[3]
XU473 AO22 $PINS O=n438 A1=N313 A2=n60 B1=N365 B2=n320
XU474 AO22 $PINS O=n439 A1=N312 A2=n61 B1=N364 B2=n320
XU475 AO22 $PINS O=n440 A1=N311 A2=n319 B1=N363 B2=FE_OFN39_n320
XU476 AO22 $PINS O=n441 A1=N310 A2=n61 B1=N362 B2=FE_OFN39_n320
XU477 AO22 $PINS O=FE_PHN1465_n442 A1=N309 A2=n60 B1=N361 B2=FE_OFN39_n320
XU478 AO22 $PINS O=n443 A1=N308 A2=n319 B1=N360 B2=FE_OFN39_n320
XU479 AO22 $PINS O=FE_PHN1068_n444 A1=N307 A2=n60 B1=N359 B2=FE_OFN39_n320
XU480 AO22 $PINS O=n445 A1=N306 A2=n60 B1=N358 B2=FE_OFN39_n320
XU481 NR3 $PINS O=N515 I1=n321 I2=n318 I3=FE_OFN200_n322
XU482 ND2 $PINS O=N514 I1=n323 I2=n324
XU483 AOI22S $PINS O=n324 A1=N357 A2=FE_OFN39_n320 B1=N305 B2=n61
XU484 AOI22S $PINS O=n323 A1=y_in[16] A2=n325 B1=N165 B2=FE_OFN38_n4
XU485 ND2 $PINS O=N513 I1=n326 I2=n327
XU486 AOI22S $PINS O=n327 A1=N356 A2=FE_OFN39_n320 B1=N304 B2=n61
XU487 AOI22S $PINS O=n326 A1=y_in[16] A2=n325 B1=N164 B2=FE_OFN38_n4
XU488 ND2 $PINS O=N512 I1=n328 I2=n329
XU489 AOI22S $PINS O=n329 A1=N355 A2=FE_OFN39_n320 B1=N303 B2=n60
XU490 AOI22S $PINS O=n328 A1=y_in[15] A2=n325 B1=N163 B2=FE_OFN38_n4
XU491 ND2 $PINS O=N511 I1=n330 I2=n331
XU492 AOI22S $PINS O=n331 A1=N354 A2=FE_OFN39_n320 B1=N302 B2=n61
XU493 AOI22S $PINS O=n330 A1=y_in[14] A2=n325 B1=N162 B2=FE_OFN38_n4
XU494 ND2 $PINS O=N510 I1=n332 I2=n333
XU495 AOI22S $PINS O=n333 A1=N353 A2=FE_OFN39_n320 B1=N301 B2=n319
XU496 AOI22S $PINS O=n332 A1=y_in[13] A2=n325 B1=N161 B2=FE_OFN38_n4
XU497 ND2 $PINS O=N509 I1=n334 I2=n335
XU498 AOI22S $PINS O=n335 A1=N352 A2=FE_OFN39_n320 B1=N300 B2=n319
XU499 AOI22S $PINS O=n334 A1=y_in[12] A2=n325 B1=N160 B2=FE_OFN38_n4
XU500 ND2 $PINS O=N508 I1=n336 I2=n337
XU501 AOI22S $PINS O=n337 A1=N351 A2=FE_OFN39_n320 B1=N299 B2=n60
XU502 AOI22S $PINS O=n336 A1=FE_PHN1463_c_in_i_1_11 A2=n325 B1=N159
+ B2=FE_OFN38_n4
XU503 ND2 $PINS O=N507 I1=n338 I2=n339
XU504 AOI22S $PINS O=n339 A1=N350 A2=FE_OFN39_n320 B1=N298 B2=n319
XU505 AOI22S $PINS O=n338 A1=y_in[10] A2=n325 B1=N158 B2=FE_OFN38_n4
XU506 ND2 $PINS O=N506 I1=n340 I2=n341
XU507 AOI22S $PINS O=n341 A1=N349 A2=FE_OFN39_n320 B1=N297 B2=n61
XU508 AOI22S $PINS O=n340 A1=y_in[9] A2=n325 B1=N157 B2=FE_OFN38_n4
XU509 ND2 $PINS O=N505 I1=n342 I2=n343
XU510 AOI22S $PINS O=n343 A1=N348 A2=FE_OFN39_n320 B1=N296 B2=n319
XU511 AOI22S $PINS O=n342 A1=y_in[8] A2=n325 B1=N156 B2=FE_OFN38_n4
XU512 ND2 $PINS O=N504 I1=n344 I2=n345
XU513 AOI22S $PINS O=n345 A1=N347 A2=FE_OFN39_n320 B1=N295 B2=n319
XU514 AOI22S $PINS O=n344 A1=y_in[7] A2=n325 B1=N155 B2=FE_OFN38_n4
XU515 ND2 $PINS O=N503 I1=n346 I2=n347
XU516 AOI22S $PINS O=n347 A1=N346 A2=FE_OFN39_n320 B1=N294 B2=n319
XU517 AOI22S $PINS O=n346 A1=y_in[6] A2=n325 B1=N154 B2=FE_OFN38_n4
XU518 ND2 $PINS O=N502 I1=n348 I2=n349
XU519 AOI22S $PINS O=n349 A1=N345 A2=FE_OFN39_n320 B1=N293 B2=n60
XU520 AOI22S $PINS O=n348 A1=y_in[5] A2=n325 B1=N153 B2=FE_OFN38_n4
XU521 ND2 $PINS O=N501 I1=FE_PHN1445_n350 I2=n351
XU522 AOI22S $PINS O=n351 A1=N344 A2=FE_OFN39_n320 B1=N292 B2=n60
XU523 AOI22S $PINS O=n350 A1=y_in[4] A2=n325 B1=N152 B2=FE_OFN38_n4
XU524 ND2 $PINS O=FE_PHN1446_N500 I1=n352 I2=n353
XU525 AOI22S $PINS O=n353 A1=N343 A2=FE_OFN39_n320 B1=N291 B2=n60
XU526 AOI22S $PINS O=n352 A1=y_in[3] A2=n325 B1=N151 B2=FE_OFN38_n4
XU527 ND2 $PINS O=N499 I1=n354 I2=n355
XU528 AOI22S $PINS O=n355 A1=N342 A2=FE_OFN39_n320 B1=N290 B2=n60
XU529 AOI22S $PINS O=n354 A1=FE_PHN1347_c_in_i_1_2 A2=n325 B1=N150
+ B2=FE_OFN38_n4
XU530 ND2 $PINS O=N498 I1=n356 I2=n357
XU531 AOI22S $PINS O=n357 A1=N341 A2=FE_OFN39_n320 B1=N289 B2=n60
XU532 AOI22S $PINS O=n356 A1=y_in[1] A2=n325 B1=N149 B2=FE_OFN38_n4
XU533 ND2 $PINS O=FE_PHN1418_N497 I1=n358 I2=FE_PHN1285_n359
XU534 AOI22S $PINS O=n359 A1=N340 A2=FE_OFN39_n320 B1=N288 B2=n60
XU535 AOI22S $PINS O=n358 A1=N148 A2=n325 B1=N148 B2=FE_OFN38_n4
XU536 ND2 $PINS O=N496 I1=n360 I2=n361
XU537 AOI22S $PINS O=n361 A1=N339 A2=n320 B1=N287 B2=n60
XU538 AOI22S $PINS O=n360 A1=x_in[16] A2=n325 B1=N147 B2=FE_OFN38_n4
XU539 ND2 $PINS O=N495 I1=n362 I2=n363
XU540 AOI22S $PINS O=n363 A1=N338 A2=n320 B1=N286 B2=n60
XU541 AOI22S $PINS O=n362 A1=x_in[16] A2=n325 B1=N146 B2=FE_OFN38_n4
XU542 ND2 $PINS O=N494 I1=n364 I2=n365
XU543 AOI22S $PINS O=n365 A1=N337 A2=n320 B1=N285 B2=n60
XU544 AOI22S $PINS O=n364 A1=FE_PHN1340_c_in_r_1_15 A2=n325 B1=N145
+ B2=FE_OFN38_n4
XU545 ND2 $PINS O=N493 I1=n366 I2=n367
XU546 AOI22S $PINS O=n367 A1=N336 A2=n320 B1=N284 B2=n60
XU547 AOI22S $PINS O=n366 A1=FE_PHN1359_c_in_r_1_14 A2=n325 B1=N144
+ B2=FE_OFN38_n4
XU548 ND2 $PINS O=N492 I1=n368 I2=n369
XU549 AOI22S $PINS O=n369 A1=N335 A2=n320 B1=N283 B2=n60
XU550 AOI22S $PINS O=n368 A1=x_in[13] A2=n325 B1=N143 B2=FE_OFN38_n4
XU551 ND2 $PINS O=N491 I1=n370 I2=n371
XU552 AOI22S $PINS O=n371 A1=N334 A2=n320 B1=N282 B2=n60
XU553 AOI22S $PINS O=n370 A1=x_in[12] A2=n325 B1=N142 B2=FE_OFN38_n4
XU554 ND2 $PINS O=N490 I1=n372 I2=n373
XU555 AOI22S $PINS O=n373 A1=N333 A2=n320 B1=N281 B2=n60
XU556 AOI22S $PINS O=n372 A1=x_in[11] A2=n325 B1=N141 B2=FE_OFN38_n4
XU557 ND2 $PINS O=N489 I1=n374 I2=n375
XU558 AOI22S $PINS O=n375 A1=N332 A2=n320 B1=N280 B2=n60
XU559 AOI22S $PINS O=n374 A1=x_in[10] A2=n325 B1=N140 B2=FE_OFN38_n4
XU560 ND2 $PINS O=N488 I1=n376 I2=n377
XU561 AOI22S $PINS O=n377 A1=N331 A2=FE_OFN39_n320 B1=N279 B2=n60
XU562 AOI22S $PINS O=n376 A1=x_in[9] A2=n325 B1=N139 B2=FE_OFN38_n4
XU563 ND2 $PINS O=N487 I1=n378 I2=n379
XU564 AOI22S $PINS O=n379 A1=N330 A2=FE_OFN39_n320 B1=N278 B2=n60
XU565 AOI22S $PINS O=n378 A1=x_in[8] A2=n325 B1=N138 B2=FE_OFN38_n4
XU566 ND2 $PINS O=N486 I1=n380 I2=n381
XU567 AOI22S $PINS O=n381 A1=N329 A2=FE_OFN39_n320 B1=N277 B2=n61
XU568 AOI22S $PINS O=n380 A1=x_in[7] A2=n325 B1=N137 B2=FE_OFN38_n4
XU569 ND2 $PINS O=N485 I1=n382 I2=n383
XU570 AOI22S $PINS O=n383 A1=N328 A2=FE_OFN39_n320 B1=N276 B2=n61
XU571 AOI22S $PINS O=n382 A1=x_in[6] A2=n325 B1=N136 B2=FE_OFN38_n4
XU572 ND2 $PINS O=N484 I1=n384 I2=n385
XU573 AOI22S $PINS O=n385 A1=N327 A2=FE_OFN39_n320 B1=N275 B2=n61
XU574 AOI22S $PINS O=n384 A1=FE_PHN1464_c_in_r_1_5 A2=n325 B1=N135
+ B2=FE_OFN38_n4
XU575 ND2 $PINS O=N483 I1=n386 I2=n387
XU576 AOI22S $PINS O=n387 A1=N326 A2=FE_OFN39_n320 B1=N274 B2=n61
XU577 AOI22S $PINS O=n386 A1=FE_PHN1453_c_in_r_1_4 A2=n325 B1=N134
+ B2=FE_OFN38_n4
XU578 ND2 $PINS O=N482 I1=n388 I2=n389
XU579 AOI22S $PINS O=n389 A1=N325 A2=FE_OFN39_n320 B1=N273 B2=n61
XU580 AOI22S $PINS O=n388 A1=x_in[3] A2=n325 B1=N133 B2=FE_OFN38_n4
XU581 ND2 $PINS O=N481 I1=n390 I2=n391
XU582 AOI22S $PINS O=n391 A1=N324 A2=FE_OFN39_n320 B1=N272 B2=n61
XU583 AOI22S $PINS O=n390 A1=x_in[2] A2=n325 B1=N132 B2=FE_OFN38_n4
XU584 ND2 $PINS O=N480 I1=n392 I2=n393
XU585 AOI22S $PINS O=n393 A1=N323 A2=FE_OFN39_n320 B1=N271 B2=n61
XU586 AOI22S $PINS O=n392 A1=x_in[1] A2=n325 B1=N131 B2=FE_OFN38_n4
XU587 ND2 $PINS O=N479 I1=FE_PHN1460_n394 I2=FE_PHN1049_n395
XU588 AOI22S $PINS O=n395 A1=N322 A2=FE_OFN39_n320 B1=N270 B2=n61
XU589 AOI22S $PINS O=n394 A1=N130 A2=n325 B1=N130 B2=FE_OFN38_n4
XU590 INV2 $PINS O=n325 I=n396
XU591 OAI112HS $PINS O=N478 A1=FE_PHN1320_n398 B1=n399 C1=n397 C2=n396
XU592 AOI22S $PINS O=n399 A1=n397 A2=n400 B1=n397 B2=n401
XU593 AOI22S $PINS O=n398 A1=N373 A2=n320 B1=N321 B2=n61
XU594 OAI112HS $PINS O=N477 A1=n403 B1=n404 C1=n402 C2=n396
XU595 AOI22S $PINS O=n404 A1=N182 A2=n400 B1=N182 B2=n401
XU596 AOI22S $PINS O=n403 A1=N372 A2=n320 B1=N320 B2=n61
XU597 OAI112HS $PINS O=N476 A1=n406 B1=n407 C1=n396 C2=n405
XU598 AOI22S $PINS O=n407 A1=N181 A2=n400 B1=N181 B2=n401
XU599 AOI22S $PINS O=n406 A1=N371 A2=n320 B1=N319 B2=n61
XU600 OAI112HS $PINS O=N475 A1=n409 B1=n410 C1=n396 C2=n408
XU601 AOI22S $PINS O=n410 A1=N180 A2=n400 B1=N180 B2=n401
XU602 AOI22S $PINS O=n409 A1=N370 A2=n320 B1=N318 B2=n61
XU603 OAI112HS $PINS O=N474 A1=FE_PHN1330_n412 B1=n413 C1=n396 C2=n411
XU604 AOI22S $PINS O=n413 A1=N179 A2=n400 B1=N179 B2=n401
XU605 AOI22S $PINS O=n412 A1=N369 A2=n320 B1=N317 B2=n61
XU606 OAI112HS $PINS O=N473 A1=n415 B1=n416 C1=n396 C2=n414
XU607 AOI22S $PINS O=n416 A1=N178 A2=n400 B1=N178 B2=n401
XU608 AOI22S $PINS O=FE_PHN1328_n415 A1=N368 A2=n320 B1=N316 B2=n61
XU609 OAI112HS $PINS O=N472 A1=FE_PHN1362_n418 B1=n419 C1=n396 C2=n417
XU610 AOI22S $PINS O=n419 A1=N177 A2=n400 B1=N177 B2=n401
XU611 AOI22S $PINS O=n418 A1=N367 A2=n320 B1=N315 B2=n61
XU612 OAI112HS $PINS O=N471 A1=FE_PHN1346_n421 B1=n422 C1=n396 C2=p1
XU613 AOI22S $PINS O=n422 A1=N176 A2=n400 B1=N176 B2=n401
XU614 AN2 $PINS O=n401 I1=n4 I2=phase_in[15]
XU615 AN2 $PINS O=n400 I1=n4 I2=n397
XU616 AOI22S $PINS O=n421 A1=N366 A2=n320 B1=N314 B2=n61
XU617 NR2 $PINS O=n319 I1=n321 I2=z_reg[15]
XU618 AN2 $PINS O=n320 I1=z_reg[15] I2=is_computing
XU619 OR3B2 $PINS O=n396 I1=n425 B1=n424 B2=n423
XU620 ND2 $PINS O=n423 I1=phase_in[15] I2=n402
XU621 INV1S $PINS O=n402 I=N182
XU622 OAI112HS $PINS O=n424 A1=n397 B1=N182 C1=n426 C2=n427
XU623 INV1S $PINS O=n397 I=phase_in[15]
XU624 ND3 $PINS O=n427 I1=n411 I2=n408 I3=n414
XU625 INV1S $PINS O=n414 I=N178
XU626 INV1S $PINS O=n408 I=N180
XU627 INV1S $PINS O=n411 I=N179
XU628 ND3 $PINS O=n426 I1=p1 I2=n417 I3=n405
XU629 INV1S $PINS O=n405 I=N181
XU630 INV1S $PINS O=n417 I=N177
XU632 ND2 $PINS O=N462 I1=n321 I2=n425
XU633 MOAI1S $PINS O=N461 A1=n428 A2=n318 B1=is_computing B2=n45
XU634 NR2 $PINS O=n429 I1=step_cnt[3] I2=n315
XU635 OAI22S $PINS O=FE_PHN1023_N460 A1=n430 A2=n316 B1=FE_OFN200_n322 B2=n321
XU636 MOAI1S $PINS O=N459 A1=n315 A2=FE_PHN1016_n431 B1=n317 B2=is_computing
XU637 INV1S $PINS O=N458 I=FE_PHN1016_n431
XU638 ND2 $PINS O=FE_PHN1177_N457 I1=n425 I2=n433
XU639 OAI12HS $PINS O=n433 A1=is_computing B1=n318 B2=FE_OFN200_n322
XU640 ND2 $PINS O=n425 I1=valid_in I2=n321
XU641 INV1S $PINS O=n321 I=is_computing
XU642 ND3 $PINS O=N118 I1=n434 I2=n435 I3=n436
XU643 AN2 $PINS O=n436 I1=FE_OFN200_n322 I2=n311
XU644 OAI112HS $PINS O=N117 A1=n313 B1=n437 C1=n315 C2=n318
XU645 AN3 $PINS O=n437 I1=n311 I2=n213 I3=n312
XU646 OAI112HS $PINS O=N116 A1=n313 B1=n133 C1=n318 C2=n432
XU647 OAI112HS $PINS O=N115 A1=n311 B1=n213 C1=n317 C2=n318
XU648 OAI112HS $PINS O=N114 A1=FE_OFN200_n322 B1=n434 C1=n318 C2=n432
XU649 OA13S $PINS O=n435 A1=n312 B1=step_cnt[0] B2=step_cnt[1] B3=n318
XU650 AOI13HS $PINS O=n434 A1=n446 B1=step_cnt[0] B2=step_cnt[1] B3=step_cnt[2]
XU652 OR3B2 $PINS O=N111 I1=N109 B1=n213 B2=n312
XU653 ND3 $PINS O=N110 I1=n213 I2=FE_OFN200_n322 I3=n313
XU654 NR2 $PINS O=n314 I1=step_cnt[2] I2=step_cnt[0]
XU655 NR2 $PINS O=n317 I1=n432 I2=step_cnt[1]
XU657 INV1S $PINS O=n316 I=step_cnt[2]
Xclk_gate_y_reg_reg SNPS_CLOCK_GATE_HIGH_cordic_rotation_0_0 $PINS EN=N462
+ ENCLK=CTS_42 CLK=clk_clone2
Xclk_gate_z_reg_reg SNPS_CLOCK_GATE_HIGH_cordic_rotation_0_4 $PINS EN=N462
+ ENCLK=CTS_39 CLK=clk_clone2
Xclk_gate_y_out_reg SNPS_CLOCK_GATE_HIGH_cordic_rotation_0_3 $PINS EN=N515
+ ENCLK=CTS_48 CLK=clk_clone1
Xclk_gate_x_out_reg SNPS_CLOCK_GATE_HIGH_cordic_rotation_0_2 $PINS EN=N515
+ ENCLK=CTS_45 CLK=clk_clone1
Xclk_gate_step_cnt_reg SNPS_CLOCK_GATE_HIGH_cordic_rotation_0_1 $PINS EN=N457
+ ENCLK=net2384 CLK_clone1=clk_clone4 CLK=clk_clone3
Xadd_105 cordic_rotation_0_DW01_add_2 $PINS A[15]=z_reg[15]
+ A[14]=FE_PHN1029_z_reg_14 A[13]=FE_PHN1077_z_reg_13 A[12]=FE_PHN1092_z_reg_12
+ A[11]=z_reg[11] A[10]=z_reg[10] A[9]=z_reg[9] A[8]=z_reg[8] A[7]=z_reg[7]
+ A[6]=z_reg[6] A[5]=z_reg[5] A[4]=FE_PHN1134_z_reg_4 A[3]=FE_PHN1135_z_reg_3
+ A[2]=z_reg[2] A[1]=z_reg[1] A[0]=z_reg[0] B[15]=n8 B[14]=n8 B[13]=n40 B[12]=n46
+ B[11]=FE_OFN121_n213 B[10]=N108 B[9]=N109 B[8]=N110 B[7]=N111 B[6]=N112
+ B[5]=N113 B[4]=N114 B[3]=N115 B[2]=N116 B[1]=N117 B[0]=N118 CI=n8 SUM[15]=N373
+ SUM[14]=N372 SUM[13]=N371 SUM[12]=N370 SUM[11]=N369 SUM[10]=N368 SUM[9]=N367
+ SUM[8]=N366 SUM[7]=N365 SUM[6]=N364 SUM[5]=N363 SUM[4]=N362 SUM[3]=N361
+ SUM[2]=N360 SUM[1]=N359 SUM[0]=N358
Xsub_104 cordic_rotation_0_DW01_sub_0_DW01_sub_28 $PINS A[17]=y_reg[17]
+ A[16]=y_reg[16] A[15]=FE_PHN1149_y_reg_15 A[14]=y_reg[14] A[13]=y_reg[13]
+ A[12]=y_reg[12] A[11]=y_reg[11] A[10]=y_reg[10] A[9]=y_reg[9] A[8]=y_reg[8]
+ A[7]=y_reg[7] A[6]=y_reg[6] A[5]=y_reg[5] A[4]=y_reg[4] A[3]=y_reg[3]
+ A[2]=y_reg[2] A[1]=y_reg[1] A[0]=y_reg[0] B[17]=x_shift[16] B[16]=x_shift[16]
+ B[15]=x_shift[15] B[14]=x_shift[14] B[13]=x_shift[13] B[12]=x_shift[12]
+ B[11]=x_shift[11] B[10]=x_shift[10] B[9]=x_shift[9] B[8]=x_shift[8]
+ B[7]=x_shift[7] B[6]=x_shift[6] B[5]=x_shift[5] B[4]=x_shift[4] B[3]=x_shift[3]
+ B[2]=x_shift[2] B[1]=x_shift[1] B[0]=x_shift[0] CI=n8 DIFF[17]=N357
+ DIFF[16]=N356 DIFF[15]=N355 DIFF[14]=N354 DIFF[13]=N353 DIFF[12]=N352
+ DIFF[11]=N351 DIFF[10]=N350 DIFF[9]=N349 DIFF[8]=N348 DIFF[7]=N347 DIFF[6]=N346
+ DIFF[5]=N345 DIFF[4]=N344 DIFF[3]=N343 DIFF[2]=N342 DIFF[1]=N341 DIFF[0]=N340
Xadd_103 cordic_rotation_0_DW01_add_3 $PINS A[17]=FE_PHN1061_x_reg_17
+ A[16]=FE_PHN1105_x_reg_16 A[15]=x_reg[15] A[14]=x_reg[14] A[13]=x_reg[13]
+ A[12]=x_reg[12] A[11]=FE_PHN1157_x_reg_11 A[10]=FE_PHN1162_x_reg_10
+ A[9]=FE_PHN1161_x_reg_9 A[8]=x_reg[8] A[7]=x_reg[7] A[6]=x_reg[6]
+ A[5]=FE_PHN1150_x_reg_5 A[4]=x_reg[4] A[3]=x_reg[3] A[2]=x_reg[2] A[1]=x_reg[1]
+ A[0]=x_reg[0] B[17]=y_shift[16] B[16]=y_shift[16] B[15]=y_shift[15]
+ B[14]=y_shift[14] B[13]=y_shift[13] B[12]=y_shift[12] B[11]=y_shift[11]
+ B[10]=y_shift[10] B[9]=y_shift[9] B[8]=y_shift[8] B[7]=y_shift[7]
+ B[6]=y_shift[6] B[5]=y_shift[5] B[4]=y_shift[4] B[3]=y_shift[3] B[2]=y_shift[2]
+ B[1]=y_shift[1] B[0]=y_shift[0] CI=n8 SUM[17]=N339 SUM[16]=N338 SUM[15]=N337
+ SUM[14]=N336 SUM[13]=N335 SUM[12]=N334 SUM[11]=N333 SUM[10]=N332 SUM[9]=N331
+ SUM[8]=N330 SUM[7]=N329 SUM[6]=N328 SUM[5]=N327 SUM[4]=N326 SUM[3]=N325
+ SUM[2]=N324 SUM[1]=N323 SUM[0]=N322
Xsub_101 cordic_rotation_0_DW01_sub_1_DW01_sub_29 $PINS A[15]=z_reg[15]
+ A[14]=FE_PHN1029_z_reg_14 A[13]=FE_PHN1077_z_reg_13 A[12]=FE_PHN1092_z_reg_12
+ A[11]=z_reg[11] A[10]=z_reg[10] A[9]=z_reg[9] A[8]=z_reg[8] A[7]=z_reg[7]
+ A[6]=z_reg[6] A[5]=z_reg[5] A[4]=FE_PHN1134_z_reg_4 A[3]=FE_PHN1135_z_reg_3
+ A[2]=z_reg[2] A[1]=z_reg[1] A[0]=z_reg[0] B[15]=n8 B[14]=n8
+ B[13]=FE_DBTN154_n40 B[12]=FE_UNCONNECTED_1 B[11]=n446 B[10]=N108 B[9]=N109
+ B[8]=N110 B[7]=N111 B[6]=N112 B[5]=N113 B[4]=N114 B[3]=N115 B[2]=N116 B[1]=N117
+ B[0]=N118 CI=n8 DIFF[15]=N321 DIFF[14]=N320 DIFF[13]=N319 DIFF[12]=N318
+ DIFF[11]=N317 DIFF[10]=N316 DIFF[9]=N315 DIFF[8]=N314 DIFF[7]=N313 DIFF[6]=N312
+ DIFF[5]=N311 DIFF[4]=N310 DIFF[3]=N309 DIFF[2]=N308 DIFF[1]=N307 DIFF[0]=N306
+ n213=n213 p_1=n133 n322=FE_OFN200_n322
Xadd_100 cordic_rotation_0_DW01_add_4 $PINS A[17]=y_reg[17] A[16]=y_reg[16]
+ A[15]=FE_PHN1149_y_reg_15 A[14]=y_reg[14] A[13]=y_reg[13] A[12]=y_reg[12]
+ A[11]=y_reg[11] A[10]=y_reg[10] A[9]=y_reg[9] A[8]=y_reg[8] A[7]=y_reg[7]
+ A[6]=y_reg[6] A[5]=y_reg[5] A[4]=y_reg[4] A[3]=y_reg[3] A[2]=y_reg[2]
+ A[1]=y_reg[1] A[0]=y_reg[0] B[17]=x_shift[16] B[16]=x_shift[16]
+ B[15]=x_shift[15] B[14]=x_shift[14] B[13]=x_shift[13] B[12]=x_shift[12]
+ B[11]=x_shift[11] B[10]=x_shift[10] B[9]=x_shift[9] B[8]=x_shift[8]
+ B[7]=x_shift[7] B[6]=x_shift[6] B[5]=x_shift[5] B[4]=x_shift[4] B[3]=x_shift[3]
+ B[2]=x_shift[2] B[1]=x_shift[1] B[0]=x_shift[0] CI=n8 SUM[17]=N305 SUM[16]=N304
+ SUM[15]=N303 SUM[14]=N302 SUM[13]=N301 SUM[12]=N300 SUM[11]=N299 SUM[10]=N298
+ SUM[9]=N297 SUM[8]=N296 SUM[7]=N295 SUM[6]=N294 SUM[5]=N293 SUM[4]=N292
+ SUM[3]=N291 SUM[2]=N290 SUM[1]=N289 SUM[0]=N288
Xsub_99 cordic_rotation_0_DW01_sub_2_DW01_sub_30 $PINS
+ A[17]=FE_PHN1061_x_reg_17 A[16]=FE_PHN1105_x_reg_16 A[15]=x_reg[15]
+ A[14]=x_reg[14] A[13]=x_reg[13] A[12]=x_reg[12] A[11]=FE_PHN1157_x_reg_11
+ A[10]=FE_PHN1473_x_reg_10 A[9]=x_reg[9] A[8]=x_reg[8] A[7]=x_reg[7]
+ A[6]=x_reg[6] A[5]=FE_PHN1150_x_reg_5 A[4]=x_reg[4] A[3]=x_reg[3] A[2]=x_reg[2]
+ A[1]=x_reg[1] A[0]=x_reg[0] B[17]=y_shift[16] B[16]=y_shift[16]
+ B[15]=y_shift[15] B[14]=y_shift[14] B[13]=y_shift[13] B[12]=y_shift[12]
+ B[11]=y_shift[11] B[10]=y_shift[10] B[9]=y_shift[9] B[8]=y_shift[8]
+ B[7]=y_shift[7] B[6]=y_shift[6] B[5]=y_shift[5] B[4]=y_shift[4] B[3]=y_shift[3]
+ B[2]=y_shift[2] B[1]=y_shift[1] B[0]=y_shift[0] CI=n8 DIFF[17]=N287
+ DIFF[16]=N286 DIFF[15]=N285 DIFF[14]=N284 DIFF[13]=N283 DIFF[12]=N282
+ DIFF[11]=N281 DIFF[10]=N280 DIFF[9]=N279 DIFF[8]=N278 DIFF[7]=N277 DIFF[6]=N276
+ DIFF[5]=N275 DIFF[4]=N274 DIFF[3]=N273 DIFF[2]=N272 DIFF[1]=N271 DIFF[0]=N270
.ENDS

.SUBCKT CSD_ROM_Table_even_1 n_idx[4] n_idx[3] n_idx[2] n_idx[1] n_idx[0]
+ k_idx[4] k_idx[3] k_idx[2] k_idx[1] k_idx[0] sign1[1] sign1[0] shift1[3]
+ shift1[2] shift1[1] shift1[0] sign2[1] sign2[0] shift2[3] shift2[2] shift2[1]
+ shift2[0] sign3[1] sign3[0] shift3[3] shift3[2] shift3[1] shift3[0]
+ _rom_k_idx_1_1
XFE_DBTC270_rom_k_idx_2_0 INV1S $PINS O=FE_DBTN270_rom_k_idx_2_0 I=k_idx[0]
XFE_DBTC269_fold_n_2 INV1S $PINS O=FE_DBTN269_fold_n_2 I=n_idx[2]
XFE_DBTC268_fold_n_1 INV1S $PINS O=FE_DBTN268_fold_n_1 I=n_idx[1]
XFE_DBTC267_n172 INV1S $PINS O=FE_DBTN267_n172 I=n172
XFE_DBTC266_n301 INV1S $PINS O=FE_DBTN266_n301 I=n301
XFE_DBTC265_n90 INV1S $PINS O=FE_DBTN265_n90 I=n90
XFE_DBTC264_n92 INV1S $PINS O=FE_DBTN264_n92 I=n92
XFE_DBTC263_n323 INV1S $PINS O=FE_DBTN263_n323 I=n323
XFE_DBTC262_n326 INV1S $PINS O=FE_DBTN262_n326 I=n326
XFE_DBTC261_n91 INV1S $PINS O=FE_DBTN261_n91 I=n91
XFE_DBTC260_n585 INV1S $PINS O=FE_DBTN260_n585 I=n585
XFE_DBTC259_n643 INV1S $PINS O=FE_DBTN259_n643 I=n643
XFE_DBTC258_n668 INV1S $PINS O=FE_DBTN258_n668 I=n668
XFE_DBTC257_n953 INV1S $PINS O=FE_DBTN257_n953 I=n953
XFE_DBTC256_n1 INV1S $PINS O=FE_DBTN256_n1 I=n1
XFE_DBTC255_n2 INV1S $PINS O=FE_DBTN255_n2 I=n2
XFE_DBTC254_n4 INV1S $PINS O=FE_DBTN254_n4 I=n4
XFE_DBTC253_n5 INV1S $PINS O=FE_DBTN253_n5 I=n5
XFE_DBTC252_n7 INV1S $PINS O=FE_DBTN252_n7 I=n7
XFE_DBTC251_n8 INV1S $PINS O=FE_DBTN251_n8 I=n8
XFE_DBTC250_n9 INV1S $PINS O=FE_DBTN250_n9 I=n9
XFE_DBTC249_n85 INV1S $PINS O=FE_DBTN249_n85 I=n85
XU776 OA222 $PINS O=n144 A1=n152 A2=n1028 B1=n153 B2=FE_DBTN250_n9 C1=n155
+ C2=n156
XU777 OR3B2 $PINS O=n164 I1=n165 B1=n166 B2=n167
XU778 ND2 $PINS O=n168 I1=n136 I2=n1041
XU779 AO12 $PINS O=n179 A1=n182 B1=n1040 B2=n181
XU780 AO112 $PINS O=n187 A1=n_idx[4] B1=n189 C1=n188 C2=n_idx[3]
XU782 OA222 $PINS O=n226 A1=n227 A2=n163 B1=n228 B2=n229 C1=n230 C2=n231
XU783 ND2 $PINS O=n233 I1=n235 I2=n236
XU784 ND2 $PINS O=n232 I1=n237 I2=n238
XU785 ND2 $PINS O=n240 I1=n241 I2=n1019
XU786 ND2 $PINS O=n239 I1=n176 I2=n242
XU787 AN3B2S $PINS O=n247 I1=n249 B1=n250 B2=n251
XU788 AN3 $PINS O=n258 I1=n259 I2=n260 I3=n220
XU789 OR3B2 $PINS O=n261 I1=n265 B1=n266 B2=n130
XU790 AN3 $PINS O=n268 I1=n271 I2=n272 I3=n273
XU791 AO12 $PINS O=sign2[1] A1=n276 B1=n274 B2=n275
XU792 AO222 $PINS O=n275 A1=n277 A2=n1066 B1=n278 B2=n279 C1=n280 C2=n281
XU793 AO12 $PINS O=n288 A1=k_idx[0] B1=n1041 B2=k_idx[2]
XU794 ND2 $PINS O=n307 I1=n311 I2=FE_DBTN252_n7
XU795 AO12 $PINS O=n303 A1=FE_DBTN264_n92 B1=n312 B2=n223
XU796 OA222 $PINS O=n316 A1=n317 A2=n216 B1=n318 B2=n319 C1=n320
+ C2=FE_DBTN250_n9
XU797 ND2 $PINS O=n353 I1=n1014 I2=FE_DBTN267_n172
XU798 AO12 $PINS O=sign1[1] A1=n276 B1=n274 B2=n356
XU799 ND2 $PINS O=n180 I1=n_idx[4] I2=n1027
XU800 AN3 $PINS O=n357 I1=n358 I2=n1041 I3=n359
XU801 OR3 $PINS O=n358 I1=n282 I2=n136 I3=n_idx[1]
XU802 ND2 $PINS O=n365 I1=FE_DBTN270_rom_k_idx_2_0 I2=n282
XU803 ND2 $PINS O=n282 I1=n286 I2=k_idx[2]
XU804 OA222 $PINS O=n376 A1=n383 A2=n231 B1=n384 B2=n347 C1=n385 C2=n248
XU805 OA222 $PINS O=n375 A1=n389 A2=n172 B1=n390 B2=n391 C1=n392 C2=n393
XU806 OA222 $PINS O=n374 A1=FE_DBTN262_n326 A2=n1030 B1=FE_DBTN259_n643
+ B2=n1025 C1=n1008 C2=n238
XU807 ND2 $PINS O=n270 I1=n413 I2=n414
XU810 OA112 $PINS O=n267 A1=n427 B1=n428 C1=n1008 C2=n426
XU811 ND2 $PINS O=n431 I1=n176 I2=n401
XU812 ND2 $PINS O=n443 I1=FE_DBTN249_n85 I2=n444
XU813 ND2 $PINS O=n447 I1=n450 I2=n242
XU814 AO12 $PINS O=n445 A1=n216 B1=n163 B2=n451
XU815 ND2 $PINS O=n455 I1=n4 I2=n1057
XU816 OA222 $PINS O=n463 A1=n1008 A2=n319 B1=n405 B2=n299 C1=n1029
+ C2=FE_DBTN262_n326
XU817 OA222 $PINS O=n462 A1=n468 A2=n147 B1=n469 B2=n212 C1=n470 C2=n216
XU818 AN3B2S $PINS O=n469 I1=n151 B1=n344 B2=n3
XU819 AN3B2S $PINS O=n486 I1=n498 B1=n499 B2=n500
XU820 AN3 $PINS O=n514 I1=n228 I2=n151 I3=n517
XU821 OA222 $PINS O=n511 A1=FE_DBTN262_n326 A2=n518 B1=n519 B2=n311 C1=n520
+ C2=n319
XU822 OA222 $PINS O=n509 A1=n404 A2=FE_DBTN250_n9 B1=n524 B2=n172 C1=n259
+ C2=n345
XU823 AN3B2S $PINS O=n531 I1=n484 B1=n532 B2=n85
XU824 OA112 $PINS O=n538 A1=n540 B1=n541 C1=n216 C2=FE_DBTN254_n4
XU825 AN3 $PINS O=n555 I1=n563 I2=n564 I3=n427
XU826 ND2 $PINS O=n427 I1=n1056 I2=n565
XU827 ND2 $PINS O=n567 I1=n263 I2=FE_DBTN255_n2
XU828 ND2 $PINS O=n566 I1=n309 I2=n1017
XU829 ND2 $PINS O=n571 I1=n418 I2=n444
XU830 OA222 $PINS O=n547 A1=n1003 A2=n319 B1=n573 B2=n229 C1=n574 C2=n488
XU831 AN3B2S $PINS O=n573 I1=n575 B1=n576 B2=n485
XU832 OR3B2 $PINS O=n587 I1=n322 B1=n472 B2=n399
XU833 ND2 $PINS O=n586 I1=n588 I2=n86
XU834 OA222 $PINS O=n606 A1=n610 A2=n335 B1=n611 B2=n229 C1=n612 C2=n488
XU835 ND2 $PINS O=n430 I1=n323 I2=n386
XU836 OA222 $PINS O=n605 A1=n615 A2=n214 B1=n560 B2=n616 C1=n617 C2=n216
XU837 OA222 $PINS O=n604 A1=n619 A2=n147 B1=n387 B2=n347 C1=n620
+ C2=FE_DBTN250_n9
XU838 AN3B2S $PINS O=n601 I1=n536 B1=n627 B2=n552
XU839 AN3 $PINS O=n504 I1=n633 I2=n634 I3=n635
XU840 OA112 $PINS O=n634 A1=n564 B1=n645 C1=n644 C2=n238
XU841 AO12 $PINS O=n645 A1=n319 B1=FE_DBTN260_n585 B2=n646
XU842 OA222 $PINS O=n633 A1=n392 A2=n214 B1=n647 B2=n299 C1=n235
+ C2=FE_DBTN260_n585
XU843 OA112 $PINS O=n454 A1=n648 B1=n649 C1=n299 C2=FE_DBTN254_n4
XU844 OA222 $PINS O=n649 A1=n156 A2=n125 B1=n650 B2=n90 C1=n595 C2=n238
XU845 OA222 $PINS O=n536 A1=n600 A2=FE_DBTN262_n326 B1=n18 B2=FE_DBTN260_n585
+ C1=n178 C2=n1002
XU846 OA222 $PINS O=n656 A1=FE_DBTN249_n85 A2=n229 B1=n1029 B2=FE_DBTN262_n326
+ C1=n260 C2=n216
XU847 OA222 $PINS O=n655 A1=n661 A2=n488 B1=n662 B2=FE_DBTN250_n9 C1=n663
+ C2=n424
XU848 OA222 $PINS O=n654 A1=n665 A2=n212 B1=n666 B2=n347 C1=n667 C2=n172
XU849 OA112 $PINS O=n652 A1=n669 B1=n670 C1=n299 C2=n176
XU850 OA222 $PINS O=n670 A1=n231 A2=n162 B1=n388 B2=n235 C1=n248 C2=n493
XU851 OR3B2 $PINS O=n671 I1=n352 B1=n245 B2=n562
XU852 OA222 $PINS O=n675 A1=FE_DBTN250_n9 A2=FE_DBTN255_n2 B1=FE_DBTN264_n92
+ B2=n600 C1=n91 C2=n214
XU853 OA222 $PINS O=n681 A1=n594 A2=FE_DBTN258_n668 B1=n432 B2=n1008 C1=n182
+ C2=n86
XU854 ND2 $PINS O=n684 I1=n418 I2=n664
XU855 ND2 $PINS O=n683 I1=n162 I2=n621
XU856 AO12 $PINS O=n679 A1=n299 B1=n621 B2=n404
XU857 OA222 $PINS O=n677 A1=FE_DBTN259_n643 A2=n223 B1=n218 B2=n345 C1=n630
+ C2=n319
XU858 OA112 $PINS O=n676 A1=n272 B1=n685 C1=n146 C2=FE_DBTN251_n8
XU859 OA222 $PINS O=n687 A1=FE_DBTN264_n92 A2=n688 B1=n689 B2=n91 C1=n690
+ C2=n231
XU860 OA112 $PINS O=n561 A1=n697 B1=n698 C1=FE_DBTN259_n643 C2=n223
XU861 ND2 $PINS O=n698 I1=n993 I2=n47
XU862 OA222 $PINS O=n456 A1=n473 A2=FE_DBTN250_n9 B1=n488 B2=n386 C1=n229
+ C2=FE_DBTN254_n4
XU863 AO112 $PINS O=n702 A1=n704 B1=n705 C1=n703 C2=n8
XU864 AN3 $PINS O=n271 I1=n708 I2=n709 I3=n710
XU865 OA112 $PINS O=n710 A1=n669 B1=n711 C1=n473 C2=n301
XU866 OA222 $PINS O=n711 A1=FE_DBTN250_n9 A2=FE_DBTN255_n2 B1=n1008 B2=n319
+ C1=n345 C2=n621
XU867 OA222 $PINS O=n669 A1=n1008 A2=n238 B1=n18 B2=FE_DBTN258_n668 C1=n235
+ C2=n1002
XU868 OA222 $PINS O=n709 A1=n325 A2=n424 B1=n712 B2=n172 C1=n590 C2=n229
XU869 OA222 $PINS O=n708 A1=n178 A2=n86 B1=n328 B2=FE_DBTN264_n92 C1=n411
+ C2=n488
XU870 AN3 $PINS O=n350 I1=n713 I2=n714 I3=n715
XU871 AN3B2S $PINS O=n715 I1=n716 B1=n717 B2=n718
XU872 ND2 $PINS O=n723 I1=n242 I2=n621
XU873 OA222 $PINS O=n726 A1=n172 A2=n162 B1=n346 B2=n391 C1=FE_DBTN250_n9
+ C2=n621
XU874 OA222 $PINS O=n731 A1=n91 A2=n235 B1=FE_DBTN259_n643 B2=n688
+ C1=FE_DBTN264_n92 C2=n1025
XU875 AO12 $PINS O=n730 A1=FE_DBTN262_n326 B1=n329 B2=n1026
XU876 AN3 $PINS O=n317 I1=n473 I2=n146 I3=n343
XU877 OA222 $PINS O=n761 A1=n197 A2=n1012 B1=n762 B2=n248 C1=n1020 C2=n172
XU878 ND2 $PINS O=n485 I1=n497 I2=n166
XU879 ND2 $PINS O=n764 I1=n575 I2=n389
XU880 ND2 $PINS O=n339 I1=n176 I2=n323
XU881 AN3B2S $PINS O=n784 I1=n685 B1=n785 B2=n718
XU882 AO12 $PINS O=n718 A1=n522 B1=n131 B2=FE_DBTN267_n172
XU883 AO222 $PINS O=n785 A1=n234 A2=n1055 B1=n998 B2=n1052 C1=FE_DBTN267_n172
+ C2=n1022
XU884 OA222 $PINS O=n783 A1=n996 A2=FE_DBTN252_n7 B1=n786 B2=n1002 C1=n787
+ C2=FE_DBTN250_n9
XU885 AO112 $PINS O=n798 A1=n553 B1=n502 C1=n572 C2=n1050
XU886 ND2 $PINS O=n421 I1=n309 I2=n533
XU887 OA222 $PINS O=n806 A1=n807 A2=n231 B1=n808 B2=FE_DBTN251_n8 C1=n809
+ C2=n248
XU888 OR3B2 $PINS O=n632 I1=n381 B1=n811 B2=n812
XU889 ND2 $PINS O=n763 I1=n252 I2=n533
XU890 ND2 $PINS O=n381 I1=n497 I2=n442
XU891 AN3 $PINS O=n215 I1=n740 I2=n125 I3=n254
XU892 ND2 $PINS O=n706 I1=n214 I2=n311
XU893 ND2 $PINS O=n813 I1=n824 I2=n825
XU894 ND2 $PINS O=n828 I1=n393 I2=n238
XU895 ND2 $PINS O=n826 I1=FE_DBTN262_n326 I2=FE_DBTN259_n643
XU896 ND2 $PINS O=n564 I1=n4 I2=FE_DBTN266_n301
XU897 ND2 $PINS O=n703 I1=n444 I2=n338
XU898 AN3 $PINS O=n776 I1=n838 I2=n411 I3=n135
XU899 ND2 $PINS O=n849 I1=n1002 I2=FE_DBTN258_n668
XU900 ND2 $PINS O=n848 I1=n1025 I2=n223
XU902 AN3B1 $PINS O=n329 I1=n157 I2=n688 B1=n834
XU904 ND2 $PINS O=n833 I1=n346 I2=n90
XU905 ND2 $PINS O=n496 I1=FE_DBTN254_n4 I2=n338
XU906 OR3B2 $PINS O=n872 I1=n382 B1=n1017 B2=n484
XU907 ND2 $PINS O=n382 I1=n406 I2=FE_DBTN254_n4
XU908 ND2 $PINS O=n251 I1=n484 I2=n442
XU909 ND2 $PINS O=n491 I1=n338 I2=n533
XU910 ND2 $PINS O=n386 I1=n165 I2=n1041
XU911 AN3 $PINS O=n273 I1=n883 I2=n884 I3=n885
XU912 ND2 $PINS O=n697 I1=n279 I2=n186
XU913 OA222 $PINS O=n889 A1=n802 A2=FE_DBTN259_n643 B1=n392 B2=FE_DBTN252_n7
+ C1=n36 C2=n345
XU915 ND2 $PINS O=n757 I1=n688 I2=n1030
XU916 ND2 $PINS O=n200 I1=n570 I2=n18
XU917 ND2 $PINS O=n907 I1=n789 I2=n319
XU919 ND2 $PINS O=n906 I1=n312 I2=n597
XU920 OA222 $PINS O=n911 A1=n238 A2=FE_DBTN260_n585 B1=n440 B2=n176 C1=n135
+ C2=n488
XU921 ND2 $PINS O=n495 I1=FE_DBTN256_n1 I2=n442
XU923 OR3B2 $PINS O=n915 I1=n722 B1=n1038 B2=n688
XU924 ND2 $PINS O=n722 I1=n312 I2=n802
XU925 ND2 $PINS O=n914 I1=n342 I2=n338
XU926 ND2 $PINS O=n728 I1=n318 I2=FE_DBTN258_n668
XU927 ND2 $PINS O=n788 I1=n91 I2=FE_DBTN258_n668
XU928 OA222 $PINS O=n922 A1=n1015 A2=n248 B1=n923 B2=n86 C1=n924 C2=n216
XU929 ND2 $PINS O=n492 I1=n442 I2=n664
XU930 OA222 $PINS O=n637 A1=n415 A2=FE_DBTN259_n643 B1=n34 B2=n345
+ C1=FE_DBTN262_n326 C2=n312
XU931 OA112 $PINS O=n919 A1=n269 B1=n416 C1=n335 C2=n493
XU932 OA222 $PINS O=n926 A1=n1008 A2=n222 B1=n311 B2=FE_DBTN260_n585
+ C1=FE_DBTN259_n643 C2=n600
XU933 ND2 $PINS O=shift1[0] I1=n927 I2=n928
XU934 ND2 $PINS O=n304 I1=n1055 I2=n998
XU935 ND2 $PINS O=n236 I1=n908 I2=n360
XU936 AO12 $PINS O=n933 A1=n388 B1=FE_DBTN252_n7 B2=n650
XU937 ND2 $PINS O=n391 I1=n935 I2=n913
XU939 OA222 $PINS O=n931 A1=n1035 A2=FE_DBTN262_n326 B1=n937 B2=n299 C1=n938
+ C2=n162
XU940 OA222 $PINS O=n930 A1=n404 A2=n229 B1=n197 B2=FE_DBTN260_n585 C1=n524
+ C2=n488
XU941 OA222 $PINS O=n929 A1=n18 A2=n86 B1=n630 B2=n424 C1=n1019 C2=n231
XU942 ND2 $PINS O=n767 I1=n252 I2=n493
XU943 AN3 $PINS O=n920 I1=n944 I2=n945 I3=n946
XU944 AO12 $PINS O=n720 A1=n90 B1=n18 B2=n178
XU945 ND2 $PINS O=n344 I1=n259 I2=n953
XU947 ND2 $PINS O=n957 I1=FE_DBTN256_n1 I2=n252
XU948 ND2 $PINS O=n956 I1=n264 I2=n493
XU949 OA222 $PINS O=n948 A1=n594 A2=n1012 B1=n960 B2=n231 C1=n498 C2=n335
XU950 ND2 $PINS O=n449 I1=n778 I2=n533
XU951 ND2 $PINS O=n301 I1=n16 I2=n936
XU952 ND2 $PINS O=n158 I1=n1039 I2=n_idx[0]
XU954 ND2 $PINS O=n426 I1=n964 I2=n935
XU955 ND2 $PINS O=n673 I1=n966 I2=n967
XU956 OA222 $PINS O=n967 A1=n876 A2=n248 B1=n968 B2=n216 C1=n969 C2=n311
XU957 ND2 $PINS O=n311 I1=n908 I2=n913
XU958 OA222 $PINS O=n966 A1=n146 A2=n231 B1=n399 B2=n299 C1=n328
+ C2=FE_DBTN262_n326
XU960 ND2 $PINS O=n222 I1=n912 I2=n964
XU961 AN3 $PINS O=n792 I1=n971 I2=n1007 I3=n972
XU962 OA222 $PINS O=n972 A1=n646 A2=n424 B1=n594 B2=n1002 C1=n90 C2=n347
XU968 ND2 $PINS O=n234 I1=n302 I2=n90
XU970 OA222 $PINS O=n942 A1=n335 A2=FE_DBTN254_n4 B1=n975 B2=n172 C1=n147
+ C2=n125
XU971 ND2 $PINS O=n500 I1=FE_DBTN254_n4 I2=n533
XU972 ND2 $PINS O=n444 I1=n976 I2=n958
XU973 ND2 $PINS O=n252 I1=n939 I2=n961
XU974 OA222 $PINS O=n941 A1=n156 A2=n91 B1=n977 B2=FE_DBTN259_n643 C1=n978
+ C2=FE_DBTN264_n92
XU976 AN3B2S $PINS O=n186 I1=n291 B1=k_idx[3] B2=k_idx[4]
XU977 ND2 $PINS O=n189 I1=n599 I2=n1025
XU978 ND2 $PINS O=n688 I1=n1036 I2=n_idx[0]
XU979 ND2 $PINS O=n979 I1=n328 I2=n1027
XU980 ND2 $PINS O=n223 I1=n1033 I2=n1041
XU981 ND2 $PINS O=n802 I1=n1037 I2=n1041
XU982 ND2 $PINS O=n894 I1=n981 I2=FE_DBTN268_fold_n_1
XU983 ND2 $PINS O=n518 I1=n1032 I2=n1041
XU984 ND2 $PINS O=n312 I1=n1033 I2=n_idx[0]
XU985 ND2 $PINS O=n157 I1=n1039 I2=n1041
XU986 ND2 $PINS O=n597 I1=n1032 I2=n_idx[0]
XU987 ND2 $PINS O=n415 I1=n175 I2=n1041
XU989 ND2 $PINS O=n851 I1=n981 I2=n_idx[1]
XU990 OA222 $PINS O=n940 A1=n982 A2=FE_DBTN250_n9 B1=n497 B2=n212 C1=n983
+ C2=n345
XU991 ND2 $PINS O=n163 I1=n984 I2=n1041
XU993 ND2 $PINS O=n953 I1=n986 I2=n1041
XU994 ND2 $PINS O=n861 I1=n300 I2=FE_DBTN254_n4
XU995 ND2 $PINS O=n402 I1=n988 I2=n1041
XU996 ND2 $PINS O=n242 I1=n989 I2=n1041
XU998 ND2 $PINS O=n309 I1=n976 I2=n280
XU1000 AN3 $PINS O=n982 I1=n516 I2=n151 I3=n405
XU1001 ND2 $PINS O=n621 I1=n988 I2=n_idx[0]
XU1002 ND2 $PINS O=n974 I1=n990 I2=FE_DBTN268_fold_n_1
XU1003 ND2 $PINS O=n220 I1=n986 I2=n_idx[0]
XU1004 ND2 $PINS O=n181 I1=n961 I2=n_idx[3]
XU1005 ND2 $PINS O=n146 I1=n_idx[0] I2=n985
XU1006 ND2 $PINS O=n149 I1=FE_DBTN269_fold_n_2 I2=n1034
XU1008 ND2 $PINS O=n203 I1=n_idx[3] I2=n_idx[2]
XU1009 ND2 $PINS O=n401 I1=n984 I2=n_idx[0]
XU1010 ND2 $PINS O=n204 I1=n990 I2=n_idx[1]
XU3 MOAI1S $PINS O=n888 A1=n1008 A2=n18 B1=FE_DBTN261_n91 B2=n1047
XU4 AN4B1S $PINS O=n624 I1=n399 I2=n741 I3=n130 B1=n2
XU5 ND2 $PINS O=n85 I1=FE_DBTN256_n1 I2=n166
XU6 ND2 $PINS O=n6 I1=n163 I2=n242
XU7 OR2B1S $PINS O=n199 I1=n1053 B1=n236
XU8 AN2 $PINS O=n318 I1=n595 I2=n91
XU9 AN2 $PINS O=n497 I1=n309 I2=n323
XU10 NR2 $PINS O=n517 I1=n3 I2=n6
XU11 OA22 $PINS O=n884 A1=n222 A2=n520 B1=n345 B2=n472
XU12 ND2 $PINS O=n91 I1=n194 I2=n160
XU14 OR2 $PINS O=n322 I1=n6 I2=n174
XU15 AN4B1S $PINS O=n152 I1=n196 I2=n426 I3=n235 B1=n198
XU16 AN4S $PINS O=n738 I1=n259 I2=n309 I3=n317 I4=n404
XU18 AN2 $PINS O=n1 I1=n985 I2=n1041
XU19 AN2 $PINS O=n2 I1=n989 I2=n_idx[0]
XU20 OR2 $PINS O=n3 I1=n4 I2=n419
XU21 AN3 $PINS O=n4 I1=n987 I2=n1041 I3=n_idx[4]
XU22 OR2 $PINS O=n5 I1=n174 I2=n131
XU23 AN2 $PINS O=n7 I1=n369 I2=n936
XU24 AN2 $PINS O=n8 I1=n291 I2=n954
XU25 AN2 $PINS O=n9 I1=n955 I2=n286
XU32 NR2 $PINS O=n16 I1=_rom_k_idx_1_1 I2=n111
XU34 ND2 $PINS O=n18 I1=n369 I2=n935
XU40 INV1S $PINS O=n24 I=n163
XU49 INV1S $PINS O=n34 I=n6
XU51 INV1S $PINS O=n36 I=n3
XU54 INV1S $PINS O=n39 I=n238
XU62 INV1S $PINS O=n47 I=n345
XU77 INV1S $PINS O=n62 I=n338
XU78 INV1S $PINS O=n63 I=n229
XU86 INV1S $PINS O=n102 I=n299
XU96 INV1S $PINS O=n97 I=n_idx[4]
XU104 NR2 $PINS O=n279 I1=n1027 I2=n_idx[4]
XU105 INV1S $PINS O=n132 I=n478
XU106 NR2 $PINS O=n478 I1=n85 I2=n221
XU107 NR2 $PINS O=n390 I1=n998 I2=n234
XU108 INV1S $PINS O=n1030 I=n721
XU109 INV1S $PINS O=n996 I=n788
XU110 INV1S $PINS O=n1005 I=n682
XU111 AN2 $PINS O=n825 I1=n479 I2=n740
XU112 INV1S $PINS O=n118 I=n472
XU113 INV1S $PINS O=n117 I=n479
XU114 INV1S $PINS O=n128 I=n411
XU115 INV1S $PINS O=n1001 I=n318
XU116 INV1S $PINS O=n991 I=n218
XU117 INV1S $PINS O=n137 I=n389
XU118 INV1S $PINS O=n998 I=n388
XU119 INV1S $PINS O=n130 I=n618
XU120 NR2 $PINS O=n254 I1=n150 I2=n221
XU121 INV1S $PINS O=n221 I=n497
XU123 INV1S $PINS O=n1025 I=n642
XU124 ND3 $PINS O=n834 I1=n600 I2=n415 I3=n638
XU125 INV1S $PINS O=n256 I=n859
XU126 INV1S $PINS O=n116 I=n773
XU127 AN2 $PINS O=n384 I1=n387 I2=n388
XU128 INV1S $PINS O=n995 I=n520
XU129 NR2 $PINS O=n721 I1=n1031 I2=n1041
XU130 INV1S $PINS O=n1026 I=n979
XU131 AN2 $PINS O=n328 I1=n802 I2=n223
XU132 NR2 $PINS O=n263 I1=n150 I2=n1
XU133 INV1S $PINS O=n120 I=n741
XU134 INV1S $PINS O=n138 I=n535
XU135 NR2 $PINS O=n383 I1=n1 I2=n138
XU136 AN2 $PINS O=n625 I1=n801 I2=n318
XU137 INV1S $PINS O=n1003 I=n701
XU138 INV1S $PINS O=n154 I=n471
XU139 INV1S $PINS O=n997 I=n630
XU140 ND3 $PINS O=n528 I1=n86 I2=n1008 I3=n1003
XU142 NR2 $PINS O=n527 I1=n572 I2=n788
XU143 NR2 $PINS O=n754 I1=n834 I2=n642
XU144 INV1S $PINS O=n127 I=n824
XU145 NR2 $PINS O=n682 I1=n90 I2=n237
XU146 NR2 $PINS O=n197 I1=n1051 I2=n1050
XU147 NR2 $PINS O=n237 I1=n1051 I2=n1048
XU148 NR2 $PINS O=n814 I1=n813 I2=n174
XU149 NR2 $PINS O=n300 I1=n123 I2=n993
XU150 AN2 $PINS O=n740 I1=n473 I2=n405
XU151 ND3 $PINS O=n816 I1=n479 I2=FE_DBTN249_n85 I3=n215
XU152 NR2 $PINS O=n484 I1=n1022 I2=n1024
XU153 ND3 $PINS O=n609 I1=n478 I2=n1017 I3=n881
XU154 NR2 $PINS O=n881 I1=n1018 I2=n251
XU155 NR2 $PINS O=n613 I1=n251 I2=n5
XU156 NR2 $PINS O=n472 I1=n119 I2=n2
XU157 NR2 $PINS O=n479 I1=n118 I2=n24
XU158 ND3 $PINS O=shift3[2] I1=n458 I2=n459 I3=n460
XU159 NR2 $PINS O=n459 I1=n481 I2=n482
XU160 NR3 $PINS O=n458 I1=n501 I2=n502 I3=n503
XU161 AN4B1S $PINS O=n460 I1=n461 I2=n462 I3=n463 B1=n464
XU162 INV1S $PINS O=n1016 I=n251
XU163 ND3 $PINS O=shift3[0] I1=n542 I2=n543 I3=n544
XU164 NR3 $PINS O=n542 I1=n591 I2=n592 I3=n593
XU165 AN4B1S $PINS O=n543 I1=n579 I2=n580 I3=n581 B1=n582
XU166 AN4B1S $PINS O=n544 I1=n545 I2=n546 I3=n547 B1=n548
XU168 ND3 $PINS O=n695 I1=n350 I2=n271 I3=n124
XU169 NR2 $PINS O=n968 I1=n123 I2=n126
XU170 NR2 $PINS O=n405 I1=n419 I2=n992
XU171 NR2 $PINS O=n712 I1=n1024 I2=n381
XU172 NR2 $PINS O=n647 I1=n131 I2=n123
XU173 NR3 $PINS O=n406 I1=n417 I2=n337 I3=n5
XU174 NR2 $PINS O=n809 I1=n336 I2=n703
XU175 ND3 $PINS O=n407 I1=n124 I2=n349 I3=n416
XU176 NR2 $PINS O=n707 I1=n131 I2=n3
XU177 NR2 $PINS O=n411 I1=n1021 I2=n131
XU178 NR2 $PINS O=n646 I1=n1001 I2=FE_DBTN265_n90
XU179 AOI22S $PINS O=n580 A1=n1053 A2=n586 B1=n1061 B2=n587
XU180 OAI112HS $PINS O=n557 A1=n561 B1=n562 C1=n560 C2=n235
XU181 ND3 $PINS O=n539 I1=n554 I2=n555 I3=n556
XU182 NR2 $PINS O=n554 I1=n568 I2=n569
XU183 NR3 $PINS O=n556 I1=n557 I2=n558 I3=n559
XU184 NR2 $PINS O=n218 I1=n992 I2=n993
XU185 NR2 $PINS O=n575 I1=n991 I2=FE_DBTN257_n953
XU186 NR2 $PINS O=n389 I1=n174 I2=n337
XU187 NR2 $PINS O=n388 I1=n565 I2=n668
XU188 AOI22S $PINS O=n243 A1=n8 A2=n261 B1=n1062 B2=n262
XU189 ND3 $PINS O=n262 I1=n263 I2=n264 I3=n249
XU190 ND3 $PINS O=n618 I1=FE_DBTN253_n5 I2=FE_DBTN256_n1 I3=n36
XU191 NR2 $PINS O=n151 I1=n5 I2=FE_DBTN263_n323
XU192 INV1S $PINS O=n1031 I=n175
XU193 INV1S $PINS O=n1008 I=n823
XU194 NR2 $PINS O=n404 I1=n1 I2=n419
XU195 NR2 $PINS O=n310 I1=n85 I2=n131
XU196 AOI22S $PINS O=n971 A1=n123 A2=n1057 B1=n1050 B2=n234
XU197 INV1S $PINS O=n1017 I=n491
XU198 NR2 $PINS O=n590 I1=n174 I2=n2
XU199 NR2 $PINS O=n259 I1=n2 I2=n992
XU200 NR2 $PINS O=n302 I1=FE_DBTN261_n91 I2=n823
XU202 INV1S $PINS O=n217 I=n167
XU203 NR2 $PINS O=n343 I1=n217 I2=n24
XU204 OR2 $PINS O=n765 I1=n485 I2=n118
XU205 INV1S $PINS O=n150 I=n450
XU206 AOI13HS $PINS O=n395 A1=n212 B1=n34 B2=n405 B3=n406
XU207 INV1S $PINS O=n135 I=n495
XU208 NR2 $PINS O=n642 I1=n1041 I2=n1028
XU209 NR2 $PINS O=n325 I1=n823 I2=n585
XU210 NR2 $PINS O=n859 I1=n337 I2=n992
XU211 AOI22S $PINS O=n947 A1=n1042 A2=n120 B1=n1057 B2=n256
XU214 NR2 $PINS O=n773 I1=n119 I2=n131
XU215 AOI22S $PINS O=n716 A1=n47 A2=FE_DBTN257_n953 B1=n1043 B2=FE_DBTN265_n90
XU216 INV1S $PINS O=n1004 I=n519
XU217 NR2 $PINS O=n387 I1=n1004 I2=FE_DBTN261_n91
XU218 NR2 $PINS O=n399 I1=FE_DBTN257_n953 I2=n993
XU219 NR2 $PINS O=n520 I1=FE_DBTN261_n91 I2=n585
XU220 AOI22S $PINS O=n428 A1=FE_DBTN261_n91 A2=n1048 B1=FE_DBTN263_n323 B2=n63
XU221 NR2 $PINS O=n638 I1=n721 I2=n577
XU222 NR2 $PINS O=n346 I1=n1009 I2=n565
XU223 INV1S $PINS O=n1009 I=n560
XU224 NR2 $PINS O=n824 I1=n1 I2=n131
XU225 NR2 $PINS O=n801 I1=n1009 I2=FE_DBTN265_n90
XU226 INV1S $PINS O=n1018 I=n252
XU227 NR2 $PINS O=n266 I1=n1018 I2=FE_DBTN263_n323
XU228 NR2 $PINS O=n475 I1=FE_DBTN263_n323 I2=n419
XU229 NR2 $PINS O=n741 I1=FE_DBTN263_n323 I2=n24
XU230 MOAI1S $PINS O=n717 A1=n594 A2=n1002 B1=FE_DBTN265_n90 B2=n1050
XU231 NR2 $PINS O=n535 I1=n150 I2=n417
XU232 NR2 $PINS O=n665 I1=n119 I2=n123
XU233 AOI22S $PINS O=n842 A1=n1056 A2=n833 B1=n47 B2=n127
XU234 NR2 $PINS O=n451 I1=n131 I2=n419
XU235 NR2 $PINS O=n228 I1=n119 I2=FE_DBTN257_n953
XU236 OAI12HS $PINS O=n886 A1=n1053 B1=n565 B2=n585
XU237 NR2 $PINS O=n584 I1=n119 I2=n992
XU238 INV1S $PINS O=n418 I=n421
XU239 NR2 $PINS O=n630 I1=n823 I2=n668
XU240 ND3 $PINS O=n701 I1=n1012 I2=n91 I3=n392
XU241 ND3 $PINS O=n494 I1=FE_DBTN253_n5 I2=n497 I3=n342
XU242 NR2 $PINS O=n471 I1=n174 I2=n417
XU243 AOI12HS $PINS O=n685 A1=n553 B1=FE_DBTN261_n91 B2=n39
XU244 MAOI1 $PINS O=n537 A1=n1048 A2=n728 B1=n346 B2=n426
XU245 NR2 $PINS O=n474 I1=n150 I2=n337
XU246 INV1S $PINS O=n348 I=n260
XU247 INV1S $PINS O=n1029 I=n757
XU248 MOAI1S $PINS O=n569 A1=n570 A2=n86 B1=n997 B2=n39
XU249 NR2 $PINS O=n213 I1=n788 I2=FE_DBTN265_n90
XU250 MOAI1S $PINS O=n918 A1=n213 A2=n347 B1=n1043 B2=n728
XU251 NR2 $PINS O=n324 I1=n491 I2=n337
XU252 OA22 $PINS O=n315 A1=n231 A2=n324 B1=n222 B2=n325
XU253 INV1S $PINS O=n1007 I=n888
XU255 NR2 $PINS O=n787 I1=n992 I2=n131
XU256 ND3 $PINS O=n572 I1=n392 I2=n86 I3=n325
XU257 AN2 $PINS O=n505 I1=n699 I2=n700
XU258 AOI22S $PINS O=n700 A1=n668 A2=n1043 B1=n565 B2=n1050
XU259 AOI22S $PINS O=n699 A1=n1044 A2=n701 B1=n1053 B2=n572
XU260 AOI22S $PINS O=n416 A1=n63 A2=n24 B1=n47 B2=n992
XU261 NR2 $PINS O=n588 I1=n995 I2=n823
XU262 INV1S $PINS O=n1038 I=n577
XU263 MOAI1S $PINS O=n592 A1=n594 A2=n595 B1=n256 B2=n9
XU264 ND2 $PINS O=n600 I1=n1036 I2=n1041
XU265 NR2 $PINS O=n719 I1=n721 I2=n722
XU266 INV1S $PINS O=n1020 I=n763
XU267 NR2 $PINS O=n241 I1=n1022 I2=FE_DBTN263_n323
XU268 ND3 $PINS O=n758 I1=n600 I2=n157 I3=n1038
XU269 NR2 $PINS O=n524 I1=n337 I2=n62
XU270 MOAI1S $PINS O=n623 A1=n318 A2=n594 B1=n102 B2=n24
XU271 NR2 $PINS O=n924 I1=n993 I2=n337
XU273 INV1S $PINS O=n1015 I=n492
XU274 NR2 $PINS O=n439 I1=n1 I2=n993
XU275 INV1S $PINS O=n1055 I=n236
XU276 NR2 $PINS O=n423 I1=n1052 I2=n1054
XU277 ND3 $PINS O=n198 I1=n423 I2=n424 I3=n425
XU278 NR2 $PINS O=n425 I1=n1056 I2=n39
XU279 INV1S $PINS O=n1048 I=n594
XU280 NR2 $PINS O=n570 I1=n1046 I2=n7
XU281 NR3 $PINS O=n196 I1=n199 I2=n1044 I3=n200
XU282 INV1S $PINS O=n1045 I=n200
XU283 INV1S $PINS O=n1051 I=n426
XU284 NR2 $PINS O=n182 I1=n1051 I2=n1052
XU285 AOI22S $PINS O=n546 A1=n577 A2=n92 B1=n1044 B2=FE_DBTN261_n91
XU286 INV1S $PINS O=n1044 I=n222
XU287 INV1S $PINS O=n1067 I=n954
XU288 INV1S $PINS O=n1043 I=n424
XU289 NR2 $PINS O=n650 I1=n1052 I2=n1050
XU290 NR2 $PINS O=n393 I1=n1046 I2=n1044
XU291 NR2 $PINS O=n895 I1=n1043 I2=n1054
XU292 INV1S $PINS O=n1053 I=n347
XU293 INV1S $PINS O=n1050 I=n235
XU294 NR2 $PINS O=n432 I1=n1050 I2=n1056
XU295 NR2 $PINS O=n185 I1=n1048 I2=n1047
XU296 INV1S $PINS O=n1061 I=n212
XU297 NR2 $PINS O=n786 I1=n1054 I2=n1050
XU298 NR2 $PINS O=n227 I1=n102 I2=n47
XU299 NR2 $PINS O=n789 I1=n1052 I2=n1056
XU300 NR2 $PINS O=n440 I1=FE_DBTN267_n172 I2=n1062
XU301 INV1S $PINS O=n1060 I=n231
XU302 INV1S $PINS O=n123 I=n242
XU303 OAI222S $PINS O=n819 A1=n820 A2=n216 B1=n527 B2=n821 C1=n822 C2=n229
XU304 NR2 $PINS O=n821 I1=n1053 I2=n706
XU305 NR2 $PINS O=n822 I1=n131 I2=n816
XU306 NR2 $PINS O=n820 I1=n348 I2=n815
XU307 NR2P $PINS O=n473 I1=n861 I2=FE_DBTN257_n953
XU308 INV1S $PINS O=n1040 I=n160
XU309 ND3 $PINS O=n815 I1=n323 I2=n166 I3=n814
XU310 ND3 $PINS O=shift1[3] I1=n793 I2=n794 I3=n795
XU311 NR3 $PINS O=n793 I1=n830 I2=n831 I3=n832
XU312 NR3 $PINS O=n795 I1=n796 I2=n797 I3=n798
XU313 AN4B1S $PINS O=n794 I1=n817 I2=n564 I3=n818 B1=n819
XU314 ND3 $PINS O=n796 I1=n804 I2=n805 I3=n806
XU315 MAOI1 $PINS O=n805 A1=n102 A2=n813 B1=FE_DBTN250_n9 B2=n814
XU316 AOI22S $PINS O=n804 A1=n1061 A2=n815 B1=n1057 B2=n816
XU317 AN4B1S $PINS O=n205 I1=n267 I2=n268 I3=n269 B1=n270
XU318 OAI222S $PINS O=n210 A1=n211 A2=n212 B1=n213 B2=n214 C1=n215 C2=n216
XU319 AN4B1S $PINS O=n211 I1=n167 I2=FE_DBTN253_n5 I3=n218 B1=n219
XU320 ND3 $PINS O=n219 I1=n220 I2=n166 I3=FE_DBTN255_n2
XU321 AN4B1S $PINS O=n610 I1=n249 I2=FE_DBTN249_n85 I3=n994 B1=n430
XU322 AN4B1S $PINS O=n612 I1=n994 I2=n497 I3=n613 B1=n614
XU323 AN4B1S $PINS O=n611 I1=n471 I2=n317 I3=n516 B1=n992
XU324 ND3 $PINS O=shift2[3] I1=n601 I2=n602 I3=n603
XU325 NR2 $PINS O=n602 I1=n622 I2=n623
XU326 AN4B1S $PINS O=n603 I1=n604 I2=n605 I3=n606 B1=n607
XU327 NR3 $PINS O=n294 I1=n295 I2=n296 I3=n297
XU328 OAI222S $PINS O=n297 A1=n298 A2=n299 B1=n300 B2=n301 C1=n302 C2=n236
XU329 ND3 $PINS O=n296 I1=n303 I2=n304 I3=n305
XU330 ND3 $PINS O=n295 I1=n314 I2=n315 I3=n316
XU331 NR3 $PINS O=n320 I1=n321 I2=n85 I3=n322
XU332 ND3 $PINS O=n321 I1=FE_DBTN255_n2 I2=n323 I3=n218
XU333 INV1S $PINS O=n419 I=n220
XU334 NR3 $PINS O=n808 I1=n477 I2=n1 I3=n62
XU335 INV1S $PINS O=n122 I=n632
XU336 INV1S $PINS O=n1024 I=n386
XU337 INV1S $PINS O=n1028 I=n987
XU338 AN4B1S $PINS O=n885 I1=n697 I2=n886 I3=n887 B1=n522
XU339 NR2 $PINS O=n883 I1=n888 I2=n457
XU340 OAI112HS $PINS O=n457 A1=n716 B1=n889 C1=n193 C2=n125
XU341 OAI222S $PINS O=n830 A1=n34 A2=n301 B1=n599 B2=FE_DBTN262_n326 C1=n825
+ C2=n345
XU342 INV1S $PINS O=n119 I=n401
XU343 AN4B1S $PINS O=n468 I1=n474 I2=n475 I3=n257 B1=n991
XU344 AN4B1S $PINS O=n470 I1=n471 I2=n472 I3=n473 B1=n85
XU345 AN4B1S $PINS O=n574 I1=n1016 I2=n1019 I3=n411 B1=n485
XU346 ND3 $PINS O=n576 I1=FE_DBTN255_n2 I2=n146 I3=n36
XU347 AN4B1S $PINS O=n619 I1=n474 I2=n36 I3=n257 B1=n24
XU348 AN4B1S $PINS O=n620 I1=n621 I2=FE_DBTN256_n1 I3=n473 B1=n116
XU350 OAI22S $PINS O=n736 A1=n737 A2=n147 B1=n738 B2=n216
XU351 AN4B1S $PINS O=n737 I1=n218 I2=n130 I3=n665 B1=n221
XU352 ND3 $PINS O=shift2[1] I1=n691 I2=n692 I3=n693
XU353 AN4B1S $PINS O=n692 I1=n730 I2=n1005 I3=n731 B1=n732
XU354 NR3 $PINS O=n693 I1=n694 I2=n695 I3=n696
XU355 NR3 $PINS O=n691 I1=n734 I2=n735 I3=n736
XU356 OAI222S $PINS O=n797 A1=n625 A2=n236 B1=n803 B2=n172 C1=n1003 C2=n424
XU357 NR3 $PINS O=n803 I1=n626 I2=n421 I3=n85
XU358 ND3 $PINS O=n626 I1=n167 I2=n338 I3=n613
XU359 AN4B1S $PINS O=n928 I1=n929 I2=n930 I3=n931 B1=n932
XU360 AN4B1S $PINS O=n927 I1=n940 I2=n941 I3=n942 B1=n943
XU361 AN4B1S $PINS O=n983 I1=n473 I2=FE_DBTN253_n5 I3=n404 B1=n120
XU362 AN4B1S $PINS O=n635 I1=n636 I2=n540 I3=n637 B1=n355
XU363 ND3 $PINS O=n627 I1=n454 I2=n273 I3=n504
XU364 INV1S $PINS O=n1027 I=n755
XU365 NR2 $PINS O=n969 I1=n565 I2=FE_DBTN261_n91
XU366 INV1S $PINS O=n126 I=n257
XU367 NR2 $PINS O=n945 I1=n962 I2=n963
XU368 AN4B1S $PINS O=n946 I1=n947 I2=n948 I3=n949 B1=n950
XU369 AN4B1S $PINS O=n944 I1=n790 I2=n965 I3=n354 B1=n673
XU370 ND3 $PINS O=shift1[1] I1=n896 I2=n897 I3=n898
XU371 NR3 $PINS O=n897 I1=n916 I2=n917 I3=n918
XU372 NR3 $PINS O=n898 I1=n899 I2=n900 I3=n901
XU373 AN4B1S $PINS O=n896 I1=n919 I2=n637 I3=n920 B1=n672
XU374 OAI112HS $PINS O=n501 A1=n504 B1=n505 C1=FE_DBTN250_n9 C2=FE_DBTN256_n1
XU375 INV1S $PINS O=n417 I=n309
XU376 MOAI1S $PINS O=n856 A1=n857 A2=n299 B1=n9 B2=n858
XU377 AN4B1S $PINS O=n857 I1=n36 I2=n323 I3=n584 B1=n322
XU378 ND3 $PINS O=n858 I1=n343 I2=n473 I3=n859
XU379 ND3 $PINS O=shift1[2] I1=n839 I2=n840 I3=n841
XU380 AN4B1S $PINS O=n840 I1=n862 I2=n863 I3=n864 B1=n865
XU381 AN4B1S $PINS O=n839 I1=n537 I2=n648 I3=n791 B1=n878
XU382 AN4B1S $PINS O=n841 I1=n842 I2=n843 I3=n844 B1=n845
XU383 OAI112HS $PINS O=n878 A1=n273 B1=n879 C1=n624 C2=n147
XU384 AOI22S $PINS O=n879 A1=FE_DBTN267_n172 A2=n880 B1=n1062 B2=n609
XU385 ND3 $PINS O=n880 I1=n498 I2=n135 I3=n882
XU386 NR3 $PINS O=n882 I1=n217 I2=n1024 I3=n1018
XU387 MOAI1S $PINS O=n735 A1=FE_DBTN249_n85 A2=n229 B1=n102 B2=n739
XU388 ND3 $PINS O=n739 I1=n740 I2=n401 I3=n741
XU389 ND3 $PINS O=shift3[3] I1=n433 I2=n434 I3=n435
XU390 NR2 $PINS O=n434 I1=n452 I2=n453
XU391 NR3 $PINS O=n435 I1=n436 I2=n437 I3=n438
XU392 AN4B1S $PINS O=n433 I1=n454 I2=n455 I3=n456 B1=n457
XU393 INV1S $PINS O=n993 I=n402
XU394 OAI222S $PINS O=n622 A1=n624 A2=n212 B1=n129 B2=n172 C1=n625 C2=n236
XU395 INV1S $PINS O=n129 I=n626
XU396 ND3 $PINS O=n696 I1=n505 I2=n456 I3=n561
XU397 AOI22S $PINS O=n461 A1=n63 A2=n476 B1=n8 B2=n477
XU398 ND3 $PINS O=n476 I1=n478 I2=n479 I3=n480
XU399 NR3 $PINS O=n480 I1=n126 I2=n131 I3=n991
XU400 MOAI1S $PINS O=n607 A1=n608 A2=n248 B1=n609 B2=n1060
XU401 AN4B1S $PINS O=n608 I1=FE_DBTN249_n85 I2=n484 I3=n1017 B1=n154
XU402 NR2 $PINS O=n616 I1=n1054 I2=n1051
XU403 NR2 $PINS O=n615 I1=n585 I2=n998
XU404 NR2 $PINS O=n617 I1=n618 I2=n117
XU405 INV1S $PINS O=n1002 I=n422
XU406 OAI222S $PINS O=n377 A1=n378 A2=n229 B1=n379 B2=n216 C1=n380 C2=n335
XU407 NR2 $PINS O=n380 I1=n131 I2=n381
XU408 NR2 $PINS O=n378 I1=n400 I2=n116
XU409 NR2 $PINS O=n379 I1=n382 I2=n117
XU410 AN4B1S $PINS O=n373 I1=n374 I2=n375 I3=n376 B1=n377
XU411 INV1S $PINS O=n131 I=n146
XU412 MOAI1S $PINS O=n865 A1=n235 A2=n213 B1=n1060 B2=n866
XU413 ND3 $PINS O=n866 I1=n1016 I2=n450 I3=n867
XU414 NR2 $PINS O=n867 I1=n496 I2=n534
XU415 ND3 $PINS O=n548 I1=n549 I2=n550 I3=n551
XU416 AOI22S $PINS O=n549 A1=n1043 A2=n1009 B1=n419 B2=n47
XU417 AOI22S $PINS O=n550 A1=n1050 A2=n1001 B1=n1054 B2=n572
XU418 NR3 $PINS O=n551 I1=n552 I2=n553 I3=n539
XU419 ND3 $PINS O=n336 I1=n776 I2=n389 I3=n837
XU420 NR3 $PINS O=n837 I1=n767 I2=n1024 I3=n417
XU421 INV1S $PINS O=n992 I=n621
XU422 INV1S $PINS O=n124 I=n702
XU423 MOAI1S $PINS O=n705 A1=n125 A2=n193 B1=FE_DBTN261_n91 B2=n706
XU424 OAI12HS $PINS O=n704 A1=n304 B1=n707 B2=n345
XU425 AOI22S $PINS O=n863 A1=n1064 A2=n871 B1=n1059 B2=n872
XU426 ND3 $PINS O=n871 I1=n484 I2=n249 I3=n873
XU427 NR3 $PINS O=n873 I1=n348 I2=n1018 I3=n5
XU428 NR2 $PINS O=n498 I1=n128 I2=n1014
XU429 NR2 $PINS O=n960 I1=n221 I2=n449
XU430 NR2 $PINS O=n595 I1=n422 I2=n565
XU431 NR2 $PINS O=n392 I1=FE_DBTN265_n90 I2=n422
XU432 INV1S $PINS O=n1022 I=n444
XU433 OAI112HS $PINS O=n950 A1=n952 B1=n720 C1=n951 C2=n229
XU434 OAI12HS $PINS O=n952 A1=n1061 B1=n150 B2=n344
XU435 NR2 $PINS O=n951 I1=n126 I2=n154
XU436 OA22 $PINS O=n887 A1=FE_DBTN258_n668 A2=n391 B1=n311 B2=n392
XU437 ND3 $PINS O=shift3[1] I1=n506 I2=n507 I3=n508
XU438 AN4B1S $PINS O=n506 I1=n536 I2=n537 I3=n538 B1=n539
XU439 NR2 $PINS O=n507 I1=n525 I2=n526
XU440 AN4B1S $PINS O=n508 I1=n509 I2=n510 I3=n511 B1=n512
XU441 NR3 $PINS O=n510 I1=n521 I2=n522 I3=n523
XU442 AOI13HS $PINS O=n521 A1=FE_DBTN251_n8 B1=n1017 B2=n176 B3=n135
XU443 OA12 $PINS O=n523 A1=n102 B1=n1 B2=n322
XU444 OAI222S $PINS O=n512 A1=n513 A2=n147 B1=n514 B2=n212 C1=n515 C2=n229
XU445 AN4B1S $PINS O=n513 I1=n404 I2=n34 I3=n472 B1=n138
XU446 AN4B1S $PINS O=n515 I1=n218 I2=n516 I3=n451 B1=n417
XU447 NR2 $PINS O=n838 I1=n217 I2=n449
XU448 NR2 $PINS O=n370 I1=n1041 I2=FE_DBTN268_fold_n_1
XU449 INV1S $PINS O=n337 I=n166
XU450 OR2 $PINS O=n86 I1=n1011 I2=n204
XU451 INV1S $PINS O=n565 I=n86
XU453 NR2 $PINS O=n668 I1=n851 I2=n1011
XU455 NR3 $PINS O=n349 I1=n87 I2=n88 I3=n89
XU456 OAI22S $PINS O=n87 A1=FE_DBTN260_n585 A2=n432 B1=n1012 B2=n238
XU457 AO22 $PINS O=n88 A1=FE_DBTN267_n172 A2=n430 B1=n47 B2=n431
XU458 OAI112HS $PINS O=n89 A1=n267 B1=n420 C1=n257 C2=n229
XU459 ND3 $PINS O=n749 I1=n759 I2=n760 I3=n761
XU460 AOI22S $PINS O=n759 A1=n9 A2=n339 B1=n1062 B2=n766
XU461 AOI22S $PINS O=n760 A1=n1042 A2=n764 B1=n1057 B2=n765
XU462 ND3 $PINS O=shift2[0] I1=n746 I2=n747 I3=n748
XU463 NR3 $PINS O=n746 I1=n779 I2=n503 I3=n780
XU464 NR3 $PINS O=n747 I1=n768 I2=n769 I3=n770
XU465 NR3 $PINS O=n748 I1=n749 I2=n750 I3=n751
XU466 NR2 $PINS O=n823 I1=n1011 I2=n1031
XU467 NR2 $PINS O=n175 I1=FE_DBTN268_fold_n_1 I2=n149
XU468 ND3 $PINS O=shift2[2] I1=n651 I2=n652 I3=n653
XU469 AN4B1S $PINS O=n653 I1=n654 I2=n655 I3=n656 B1=n657
XU470 NR3 $PINS O=n651 I1=n671 I2=n672 I3=n673
XU471 ND3 $PINS O=n352 I1=n676 I2=n677 I3=n678
XU472 AN4B1S $PINS O=n678 I1=n679 I2=n680 I3=n681 B1=n682
XU473 INV1S $PINS O=n174 I=n176
XU474 AN2 $PINS O=n385 I1=n386 I2=n310
XU475 ND3 $PINS O=n779 I1=n790 I2=n791 I3=n792
XU476 AOI22S $PINS O=n563 A1=n566 A2=n1059 B1=n1042 B2=n567
XU477 INV1S $PINS O=n1019 I=n767
XU478 ND3 $PINS O=n208 I1=n224 I2=n225 I3=n226
XU479 AOI22S $PINS O=n224 A1=n9 A2=n239 B1=n1064 B2=n240
XU480 AOI22S $PINS O=n225 A1=n232 A2=n998 B1=n233 B2=n234
XU481 AN2 $PINS O=n230 I1=n1019 I2=n442
XU482 MOAI1S $PINS O=n408 A1=n409 A2=n147 B1=n1064 B2=n410
XU483 ND3 $PINS O=n410 I1=n411 I2=n177 I3=n412
XU485 OR2 $PINS O=n90 I1=n1011 I2=n974
XU487 ND3 $PINS O=n503 I1=n782 I2=n783 I3=n784
XU488 OA22 $PINS O=n782 A1=n1008 A2=n789 B1=FE_DBTN260_n585 B2=n424
XU489 NR2 $PINS O=n167 I1=n400 I2=FE_DBTN263_n323
XU490 MOAI1S $PINS O=n333 A1=n334 A2=n335 B1=n336 B2=n1059
XU491 AN4B1S $PINS O=n334 I1=FE_DBTN249_n85 I2=n338 I3=n177 B1=n339
XU492 AOI22S $PINS O=n244 A1=n1057 A2=n255 B1=FE_DBTN257_n953 B2=n102
XU493 ND3 $PINS O=n255 I1=n34 I2=n257 I3=n258
XU494 MOAI1S $PINS O=n769 A1=FE_DBTN252_n7 A2=n90 B1=n47 B2=n774
XU495 ND3 $PINS O=n774 I1=n517 I2=n472 I3=n439
XU496 ND3 $PINS O=n265 I1=n338 I2=n125 I3=FE_DBTN255_n2
XU497 MOAI1S $PINS O=n559 A1=FE_DBTN253_n5 A2=FE_DBTN250_n9 B1=n1001 B2=n1043
XU498 OAI22S $PINS O=n396 A1=n397 A2=FE_DBTN250_n9 B1=n398 B2=n299
XU499 AN4B1S $PINS O=n398 I1=n399 I2=n343 I3=n36 B1=n1
XU500 AN4B1S $PINS O=n397 I1=n401 I2=n125 I3=n402 B1=n403
XU501 ND3 $PINS O=n403 I1=n34 I2=n167 I3=n404
XU502 NR2 $PINS O=n412 I1=n132 I2=n500
XU503 AOI22S $PINS O=n545 A1=n1059 A2=n5 B1=n102 B2=n578
XU504 ND3 $PINS O=n578 I1=n218 I2=n163 I3=n130
XU505 OA22 $PINS O=n862 A1=n874 A2=FE_DBTN251_n8 B1=n875 B2=n229
XU506 NR3 $PINS O=n874 I1=n877 I2=n265 I3=n85
XU507 AN4B1S $PINS O=n875 I1=n876 I2=n472 I3=n647 B1=n256
XU508 ND3 $PINS O=n877 I1=n260 I2=n242 I3=n36
XU509 NR2 $PINS O=n522 I1=FE_DBTN264_n92 I2=n415
XU510 AOI22S $PINS O=n713 A1=n63 A2=n723 B1=n1051 B2=n585
XU511 OA12 $PINS O=n714 A1=n720 B1=n719 B2=FE_DBTN259_n643
XU512 AN2 $PINS O=n272 I1=n686 I2=n687
XU513 AOI22S $PINS O=n686 A1=n1044 A2=FE_DBTN265_n90 B1=n419 B2=n63
XU514 NR2 $PINS O=n689 I1=n7 I2=n1043
XU516 NR2 $PINS O=n450 I1=n174 I2=n400
XU517 ND3 $PINS O=n932 I1=n933 I2=n304 I3=n934
XU518 OAI12HS $PINS O=n934 A1=FE_DBTN266_n301 B1=n1 B2=n861
XU519 OAI222S $PINS O=n482 A1=n345 A2=FE_DBTN255_n2 B1=n483 B2=n231 C1=n172
+ C2=n338
XU520 AN4B1S $PINS O=n483 I1=n484 I2=n146 I3=n1020 B1=n485
XU521 OAI222S $PINS O=n481 A1=n486 A2=n335 B1=n487 B2=n488 C1=n489 C2=n248
XU522 NR3 $PINS O=n487 I1=n494 I2=n495 I3=n496
XU523 NR3 $PINS O=n489 I1=n490 I2=n491 I3=n492
XU524 MOAI1S $PINS O=n780 A1=n388 A2=n311 B1=n1061 B2=n781
XU525 ND3 $PINS O=n781 I1=n474 I2=n34 I3=n575
XU526 NR2 $PINS O=n177 I1=n767 I2=n1014
XU527 OA22 $PINS O=n636 A1=n600 A2=FE_DBTN259_n643 B1=n1002 B2=n424
XU528 OAI112HS $PINS O=n502 A1=n799 B1=n800 C1=n646 C2=n594
XU529 OA22 $PINS O=n800 A1=n426 A2=n801 B1=n18 B2=n560
XU530 OA12 $PINS O=n799 A1=n697 B1=n318 B2=n178
XU531 NR2 $PINS O=n264 I1=n500 I2=FE_DBTN263_n323
XU532 AN2 $PINS O=n562 I1=n674 I2=n675
XU533 AOI22S $PINS O=n674 A1=n24 A2=FE_DBTN266_n301 B1=n1014 B2=n1059
XU534 ND3 $PINS O=n860 I1=n597 I2=n1027 I3=n329
XU535 NR2 $PINS O=n298 I1=n116 I2=n4
XU536 NR2 $PINS O=n519 I1=n422 I2=n823
XU537 OA22 $PINS O=n579 A1=n589 A2=n147 B1=n426 B2=n1012
XU538 AN4B1S $PINS O=n589 I1=n220 I2=n257 I3=n590 B1=n24
XU539 AN4B1S $PINS O=n762 I1=n442 I2=n411 I3=n533 B1=FE_DBTN263_n323
XU540 NR2 $PINS O=n560 I1=n823 I2=n467
XU541 NR2 $PINS O=n876 I1=n217 I2=n4
XU542 NR2 $PINS O=n585 I1=n1011 I2=n894
XU543 MOAI1S $PINS O=n332 A1=n340 A2=n147 B1=n1064 B2=n341
XU544 AN4B1S $PINS O=n340 I1=FE_DBTN253_n5 I2=n343 I3=FE_DBTN249_n85 B1=n344
XU545 ND3 $PINS O=n341 I1=n994 I2=n254 I3=n342
XU546 INV1S $PINS O=n1037 I=n894
XU547 INV1S $PINS O=n1033 I=n974
XU548 NR3 $PINS O=n977 I1=n980 I2=n201 I3=n979
XU549 AN4B1S $PINS O=n978 I1=n688 I2=n415 I3=n1026 B1=n189
XU550 ND3 $PINS O=n980 I1=n600 I2=n415 I3=n1030
XU551 OA22 $PINS O=n354 A1=n299 A2=n166 B1=n266 B2=FE_DBTN251_n8
XU552 NR2 $PINS O=n690 I1=n1014 I2=n174
XU553 NR2 $PINS O=n663 I1=n467 I2=n565
XU554 AN2 $PINS O=n661 I1=n664 I2=n524
XU555 AN2 $PINS O=n662 I1=n389 I2=n475
XU556 OAI22S $PINS O=n770 A1=n771 A2=n229 B1=n772 B2=n299
XU557 AN4B1S $PINS O=n772 I1=n584 I2=n741 I3=n36 B1=n85
XU558 AN4B1S $PINS O=n771 I1=n773 I2=n404 I3=n257 B1=n348
XU559 NR2 $PINS O=n666 I1=n668 I2=FE_DBTN265_n90
XU560 NR2 $PINS O=n667 I1=n337 I2=n1018
XU561 AN4B1S $PINS O=n351 I1=n1007 I2=n353 I3=n354 B1=n355
XU562 OAI222S $PINS O=n331 A1=n345 A2=FE_DBTN255_n2 B1=n346 B2=n347 C1=n220
+ C2=FE_DBTN251_n8
XU563 INV1S $PINS O=n994 I=n500
XU564 OAI22S $PINS O=n657 A1=n658 A2=n335 B1=n659 B2=n147
XU565 AN4B1S $PINS O=n658 I1=n230 I2=n260 I3=FE_DBTN253_n5 B1=n62
XU566 NR3 $PINS O=n659 I1=n660 I2=n991 I3=n118
XU567 ND3 $PINS O=n660 I1=n242 I2=FE_DBTN256_n1 I3=n497
XU568 NR3 $PINS O=n342 I1=n1021 I2=n1022 I3=n767
XU569 ND3 $PINS O=n899 I1=n909 I2=n910 I3=n911
XU570 OA22 $PINS O=n909 A1=n227 A2=FE_DBTN253_n5 B1=FE_DBTN252_n7 B2=n588
XU571 AOI22S $PINS O=n910 A1=FE_DBTN267_n172 A2=n914 B1=n92 B2=n915
XU572 AOI22S $PINS O=n305 A1=FE_DBTN265_n90 A2=n307 B1=n1061 B2=n308
XU573 ND3 $PINS O=n308 I1=FE_DBTN255_n2 I2=n309 I3=n310
XU574 OAI222S $PINS O=n901 A1=n902 A2=n147 B1=n903 B2=FE_DBTN250_n9 C1=n904
+ C2=FE_DBTN251_n8
XU575 NR2 $PINS O=n902 I1=n119 I2=n417
XU576 AN2 $PINS O=n904 I1=n533 I2=FE_DBTN253_n5
XU577 NR2 $PINS O=n903 I1=n116 I2=n132
XU578 ND3 $PINS O=n436 I1=n445 I2=n304 I3=n446
XU579 AOI22S $PINS O=n446 A1=n63 A2=n447 B1=n1064 B2=n448
XU580 OR2 $PINS O=n448 I1=n449 I2=n400
XU581 OAI222S $PINS O=n750 A1=n34 A2=n301 B1=FE_DBTN258_n668 B2=n319 C1=n594
+ C2=n86
XU582 OAI222S $PINS O=n209 A1=n222 A2=n86 B1=n1017 B2=n172 C1=FE_DBTN262_n326
+ C2=n223
XU583 AOI22S $PINS O=n420 A1=n8 A2=n421 B1=n422 B2=n198
XU584 OAI222S $PINS O=n962 A1=n178 A2=FE_DBTN258_n668 B1=n595 B2=n426 C1=n630
+ C2=n319
XU585 MOAI1S $PINS O=n582 A1=n335 A2=n412 B1=n1060 B2=n583
XU586 ND3 $PINS O=n583 I1=n254 I2=n533 I3=n135
XU587 MOAI1S $PINS O=n832 A1=n754 A2=FE_DBTN264_n92 B1=n1052 B2=n833
XU588 NR2 $PINS O=n260 I1=n417 I2=n400
XU589 ND3 $PINS O=n766 I1=n177 I2=n664 I3=n535
XU590 MOAI1S $PINS O=n568 A1=n423 A2=FE_DBTN258_n668 B1=FE_DBTN267_n172 B2=n571
XU591 INV1S $PINS O=n1012 I=n467
XU592 MOAI1S $PINS O=n553 A1=FE_DBTN264_n92 A2=n802 B1=FE_DBTN266_n301
+ B2=FE_DBTN257_n953
XU593 INV1S $PINS O=n1032 I=n204
XU594 AN2 $PINS O=n599 I1=n312 I2=n518
XU595 OAI22S $PINS O=n170 A1=n171 A2=n172 B1=n173 B2=FE_DBTN252_n7
XU596 NR2 $PINS O=n173 I1=n175 I2=n1037
XU597 AN4B1S $PINS O=n171 I1=n176 I2=FE_DBTN256_n1 I3=n177 B1=n4
XU598 OAI222S $PINS O=n591 A1=FE_DBTN259_n643 A2=n1030 B1=n520 B2=n238 C1=n596
+ C2=FE_DBTN262_n326
XU599 AN4B1S $PINS O=n596 I1=n597 I2=n1027 I3=n223 B1=n598
XU600 ND3 $PINS O=n598 I1=n599 I2=n600 I3=n1029
XU601 OAI222S $PINS O=n526 A1=n527 A2=n347 B1=n999 B2=n222 C1=n248 C2=n386
XU602 INV1S $PINS O=n999 I=n528
XU603 ND3 $PINS O=n532 I1=n450 I2=n533 I3=n266
XU604 AOI22S $PINS O=n818 A1=n826 A2=n827 B1=n828 B2=n528
XU605 ND3 $PINS O=n827 I1=n1026 I2=n688 I3=n754
XU606 ND3 $PINS O=n499 I1=n442 I2=n166 I3=n266
XU607 INV1S $PINS O=n1021 I=n664
XU608 INV1S $PINS O=n1036 I=n851
XU609 OAI222S $PINS O=n916 A1=n346 A2=n235 B1=n388 B2=n18 C1=n229 C2=n402
XU610 OAI112HS $PINS O=n464 A1=n466 B1=n427 C1=n465 C2=n236
XU611 OAI12HS $PINS O=n466 A1=n1054 B1=n467 B2=n234
XU612 ND3 $PINS O=n201 I1=n597 I2=n157 I3=n599
XU613 OAI222S $PINS O=n394 A1=n90 A2=n214 B1=FE_DBTN252_n7 B2=n1002
+ C1=FE_DBTN249_n85 C2=FE_DBTN251_n8
XU614 OA22 $PINS O=n414 A1=FE_DBTN262_n326 A2=n415 B1=n319 B2=n91
XU615 AOI22S $PINS O=n413 A1=n39 A2=FE_DBTN265_n90 B1=n1054 B2=n998
XU616 OA22 $PINS O=n581 A1=n236 A2=n465 B1=n216 B2=n584
XU617 NR2 $PINS O=n577 I1=n894 I2=n1041
XU618 OAI222S $PINS O=n751 A1=n752 A2=FE_DBTN262_n326 B1=n753
+ B2=FE_DBTN259_n643 C1=FE_DBTN264_n92 C2=n600
XU619 NR3 $PINS O=n752 I1=n756 I2=n757 I3=n758
XU620 AN4B1S $PINS O=n753 I1=n518 I2=n754 I3=n223 B1=n755
XU621 ND3 $PINS O=n756 I1=n158 I2=n1027 I3=n518
XU622 MOAI1S $PINS O=n963 A1=FE_DBTN262_n326 A2=n158 B1=FE_DBTN266_n301
+ B2=FE_DBTN257_n953
XU623 NR2 $PINS O=n249 I1=n1014 I2=n1021
XU624 MOAI1S $PINS O=n355 A1=n638 A2=FE_DBTN264_n92 B1=n7 B2=n565
XU625 OA22 $PINS O=n648 A1=n391 A2=FE_DBTN260_n585 B1=n638 B2=FE_DBTN259_n643
XU626 MOAI1S $PINS O=n593 A1=n519 A2=n214 B1=n128 B2=FE_DBTN267_n172
XU627 MOAI1S $PINS O=n558 A1=FE_DBTN264_n92 A2=n1030 B1=FE_DBTN265_n90 B2=n1055
XU628 MOAI1S $PINS O=n732 A1=n733 A2=n488 B1=n127 B2=n8
XU629 NR2 $PINS O=n733 I1=n348 I2=n491
XU630 OA22 $PINS O=n245 A1=FE_DBTN262_n326 A2=n518 B1=FE_DBTN252_n7
+ B2=FE_DBTN258_n668
XU631 NR2 $PINS O=n850 I1=n1039 I2=n1033
XU632 NR2 $PINS O=n644 I1=n467 I2=FE_DBTN265_n90
XU633 ND3 $PINS O=n672 I1=n921 I2=n541 I3=n922
XU634 AOI22S $PINS O=n921 A1=n1052 A2=n823 B1=n8 B2=n1022
XU635 NR2 $PINS O=n923 I1=n1047 I2=n1044
XU636 NR2 $PINS O=n465 I1=n422 I2=n585
XU637 OA22 $PINS O=n541 A1=FE_DBTN262_n326 A2=n597 B1=FE_DBTN259_n643 B2=n688
XU638 AOI22S $PINS O=n790 A1=n1057 A2=n400 B1=FE_DBTN265_n90 B2=n1044
XU639 OAI22S $PINS O=n438 A1=n439 A2=n212 B1=n386 B2=n440
XU640 MOAI1S $PINS O=n453 A1=n231 A2=n338 B1=n47 B2=n119
XU641 INV1S $PINS O=n1066 I=n286
XU642 MOAI1S $PINS O=n437 A1=n441 A2=n442 B1=n1059 B2=n443
XU643 NR2 $PINS O=n441 I1=n1060 I2=FE_DBTN267_n172
XU644 INV1S $PINS O=n115 I=k_idx[4]
XU645 OR2 $PINS O=n965 I1=FE_DBTN251_n8 I2=n442
XU646 MOAI1S $PINS O=n452 A1=n214 A2=n1012 B1=n217 B2=FE_DBTN267_n172
XU647 INV1S $PINS O=n1054 I=n311
XU648 ND2 $PINS O=n594 I1=n936 I2=n964
XU649 INV1S $PINS O=n1052 I=n391
XU650 AN2 $PINS O=n908 I1=k_idx[3] I2=n973
XU651 MOAI1S $PINS O=n917 A1=n91 A2=n391 B1=FE_DBTN265_n90 B2=n1055
XU652 NR2 $PINS O=n954 I1=n115 I2=k_idx[3]
XU653 ND3 $PINS O=n829 I1=n850 I2=n851 I3=n852
XU654 NR2 $PINS O=n852 I1=n160 I2=n1032
XU655 ND2 $PINS O=n424 I1=n912 I2=n16
XU656 ND2 $PINS O=n235 I1=n360 I2=n935
XU657 INV1S $PINS O=n1059 I=n248
XU659 ND3 $PINS O=n231 I1=k_idx[3] I2=n115 I3=n291
XU660 INV1S $PINS O=n1046 I=n319
XU661 INV1S $PINS O=n1056 I=n214
XU662 ND2 $PINS O=n347 I1=n908 I2=n964
XU663 NR2 $PINS O=n367 I1=n149 I2=n1066
XU664 ND2 $PINS O=n212 I1=n291 I2=n286
XU666 AOI22S $PINS O=n142 A1=FE_DBTN266_n301 A2=n168 B1=n1048 B2=n1037
XU667 INV1S $PINS O=n1064 I=n488
XU668 INV1S $PINS O=n1047 I=n178
XU669 INV1S $PINS O=n1042 I=n216
XU670 INV1S $PINS O=n1057 I=n147
XU671 INV1S $PINS O=n1062 I=n335
XU672 NR2 $PINS O=n160 I1=FE_DBTN268_fold_n_1 I2=n203
XU673 ND3 $PINS O=sign3[0] I1=n205 I2=n206 I3=n207
XU674 AN4B1S $PINS O=n206 I1=n243 I2=n244 I3=n245 B1=n246
XU675 NR3 $PINS O=n207 I1=n208 I2=n209 I3=n210
XU676 ND3 $PINS O=sign2[0] I1=n292 I2=n293 I3=n294
XU677 NR3 $PINS O=n293 I1=n331 I2=n332 I3=n333
XU678 AN4B1S $PINS O=n292 I1=n349 I2=n350 I3=n351 B1=n352
XU679 NR2 $PINS O=n961 I1=FE_DBTN269_fold_n_2 I2=n_idx[1]
XU680 NR2 $PINS O=n811 I1=n279 I2=n2
XU681 NR3 $PINS O=n812 I1=n763 I2=n3 I3=n137
XU682 ND3 $PINS O=n477 I1=n162 I2=n444 I3=n810
XU683 AN2 $PINS O=n810 I1=n647 I2=n122
XU684 NR2 $PINS O=n987 I1=n149 I2=n_idx[1]
XU685 AN4B1S $PINS O=n807 I1=n664 I2=n162 I3=FE_DBTN253_n5 B1=n609
XU686 INV2 $PINS O=n1041 I=n_idx[0]
XU687 OAI222S $PINS O=n734 A1=n742 A2=n248 B1=n743 B2=n335 C1=n744 C2=n231
XU688 AN4B1S $PINS O=n742 I1=n1016 I2=n177 I3=n478 B1=n745
XU689 AN4B1S $PINS O=n743 I1=n1019 I2=n613 I3=n324 B1=n400
XU690 AN4B1S $PINS O=n744 I1=n664 I2=n493 I3=n613 B1=n496
XU691 NR2 $PINS O=n257 I1=n279 I2=FE_DBTN257_n953
XU692 OAI112HS $PINS O=n943 A1=n792 B1=n920 C1=n248 C2=n778
XU693 NR2 $PINS O=n755 I1=n1028 I2=n_idx[0]
XU694 AN2 $PINS O=n540 I1=n639 I2=n640
XU695 AOI22S $PINS O=n639 A1=n642 A2=n643 B1=n123 B2=FE_DBTN266_n301
XU696 AOI22S $PINS O=n640 A1=n326 A2=n641 B1=n102 B2=n118
XU697 ND3 $PINS O=n641 I1=n415 I2=n1025 I3=n1038
XU698 AN4B1S $PINS O=n844 I1=n853 I2=n854 I3=n855 B1=n856
XU699 AOI22S $PINS O=n853 A1=n1055 A2=n995 B1=n565 B2=n1043
XU700 AOI22S $PINS O=n855 A1=n326 A2=n860 B1=n1046 B2=FE_DBTN265_n90
XU701 AOI22S $PINS O=n854 A1=FE_DBTN266_n301 A2=n861 B1=n1054 B2=n668
XU702 OAI22S $PINS O=n246 A1=n156 A2=n125 B1=n247 B2=n248
XU703 ND3 $PINS O=n250 I1=n252 I2=FE_DBTN254_n4 I3=n254
XU704 NR2 $PINS O=n422 I1=n1011 I2=n181
XU705 NR3 $PINS O=n985 I1=FE_DBTN268_fold_n_1 I2=FE_DBTN269_fold_n_2 I3=n136
XU706 ND3 $PINS O=sign1[0] I1=n371 I2=n372 I3=n373
XU707 NR3 $PINS O=n372 I1=n394 I2=n395 I3=n396
XU708 NR3 $PINS O=n371 I1=n407 I2=n270 I3=n408
XU709 INV1S $PINS O=n136 I=n280
XU710 OAI22S $PINS O=n552 A1=n628 A2=FE_DBTN251_n8 B1=n629 B2=n222
XU711 NR2 $PINS O=n629 I1=n422 I2=n997
XU712 NR3 $PINS O=n628 I1=n631 I2=n123 I3=n632
XU713 ND3 $PINS O=n631 I1=FE_DBTN256_n1 I2=n162 I3=n338
XU714 NR2 $PINS O=n516 I1=n118 I2=n279
XU715 INV1S $PINS O=n125 I=n279
XU716 INV1S $PINS O=n1011 I=n194
XU717 AN4B1S $PINS O=n975 I1=n252 I2=n444 I3=n406 B1=n500
XU718 ND3 $PINS O=n166 I1=n280 I2=FE_DBTN269_fold_n_2 I3=n370
XU719 ND3 $PINS O=n323 I1=n961 I2=n1041 I3=n280
XU720 AN2 $PINS O=n939 I1=n958 I2=n1041
XU721 OAI222S $PINS O=n525 A1=n529 A2=n335 B1=n530 B2=n488 C1=n531 C2=n231
XU722 NR3 $PINS O=n529 I1=n534 I2=n491 I3=n138
XU723 AN4B1S $PINS O=n530 I1=n493 I2=n444 I3=n442 B1=n382
XU724 ND3 $PINS O=n727 I1=n298 I2=FE_DBTN249_n85 I3=n729
XU725 NR3 $PINS O=n729 I1=n991 I2=n279 I3=n417
XU726 ND3 $PINS O=n694 I1=n724 I2=n725 I3=n726
XU727 AOI22S $PINS O=n724 A1=n39 A2=n1001 B1=n1056 B2=n1009
XU728 AOI22S $PINS O=n725 A1=n1061 A2=n727 B1=n7 B2=n728
XU729 ND3 $PINS O=n176 I1=n280 I2=n961 I3=n_idx[0]
XU730 OAI222S $PINS O=n768 A1=n775 A2=n488 B1=n122 B2=FE_DBTN251_n8 C1=n776
+ C2=n231
XU731 NR3 $PINS O=n775 I1=n777 I2=n137 I3=n496
XU732 ND3 $PINS O=n777 I1=n493 I2=n778 I3=n241
XU733 ND3 $PINS O=n533 I1=n958 I2=FE_DBTN269_fold_n_2 I3=n370
XU734 AOI22S $PINS O=n864 A1=n1061 A2=n868 B1=n1042 B2=n869
XU735 ND3 $PINS O=n869 I1=n130 I2=n621 I3=n516
XU736 ND3 $PINS O=n868 I1=n439 I2=n517 I3=n870
XU737 NR3 $PINS O=n870 I1=n116 I2=n279 I3=n348
XU738 OAI22S $PINS O=n831 A1=n835 A2=n335 B1=n836 B2=n488
XU739 NR2 $PINS O=n835 I1=n496 I2=n336
XU740 AN2 $PINS O=n836 I1=FE_DBTN254_n4 I2=n809
XU741 INV1S $PINS O=n400 I=n162
XU743 ND3 $PINS O=n338 I1=n_idx[1] I2=FE_DBTN269_fold_n_2 I3=n939
XU744 ND3 $PINS O=n442 I1=FE_DBTN268_fold_n_1 I2=FE_DBTN269_fold_n_2 I3=n939
XU745 AOI22S $PINS O=n314 A1=n1052 A2=n995 B1=n326 B2=n327
XU746 ND3 $PINS O=n327 I1=n328 I2=n329 I3=n330
XU747 AN2 $PINS O=n330 I1=n158 I2=n312
XU748 ND3 $PINS O=n490 I1=n493 I2=n386 I3=n254
XU749 ND3 $PINS O=n614 I1=FE_DBTN256_n1 I2=n162 I3=n177
XU750 AN4B1S $PINS O=n155 I1=n157 I2=n158 I3=n159 B1=n160
XU751 NR3 $PINS O=n153 I1=n161 I2=n119 I3=n221
XU752 ND3 $PINS O=n161 I1=n162 I2=n125 I3=n163
XU753 ND3 $PINS O=sign3[1] I1=n139 I2=n140 I3=n141
XU754 NR2 $PINS O=n139 I1=n183 I2=n184
XU755 NR2 $PINS O=n140 I1=n169 I2=n170
XU756 AN4B1S $PINS O=n141 I1=n142 I2=n143 I3=n144 B1=n145
XU757 AOI22S $PINS O=n949 A1=n1064 A2=n956 B1=n1059 B2=n957
XU758 INV1S $PINS O=n1014 I=n778
XU759 ND3 $PINS O=n900 I1=n1005 I2=n304 I3=n905
XU760 AOI22S $PINS O=n905 A1=n643 A2=n906 B1=n422 B2=n907
XU761 AOI22S $PINS O=n680 A1=n1061 A2=n683 B1=FE_DBTN267_n172 B2=n684
XU762 INV1S $PINS O=n1039 I=n181
XU763 NR2 $PINS O=n938 I1=n1042 I2=n1062
XU764 INV1S $PINS O=n1035 I=n758
XU765 AN2 $PINS O=n937 I1=n401 I2=n343
XU766 OA12 $PINS O=n467 A1=n194 B1=n1036 B2=n1037
XU767 AN2 $PINS O=n269 I1=n925 I2=n926
XU768 AOI22S $PINS O=n925 A1=n326 A2=n642 B1=n2 B2=n102
XU769 ND3 $PINS O=n664 I1=n_idx[0] I2=n961 I3=n958
XU770 NR2 $PINS O=n278 I1=_rom_k_idx_1_1 I2=n1066
XU771 OAI112HS $PINS O=n277 A1=n289 B1=n290 C1=k_idx[2] C2=n203
XU772 OA22 $PINS O=n791 A1=n891 A2=n1011 B1=n1029 B2=FE_DBTN264_n92
XU773 NR2 $PINS O=n891 I1=n892 I2=n893
XU774 OAI222S $PINS O=n893 A1=n1040 A2=n319 B1=n570 B2=n204 C1=n178 C2=n181
XU775 OAI222S $PINS O=n892 A1=n1045 A2=n894 B1=n895 B2=n1031 C1=n850 C2=n391
XU781 ND3 $PINS O=n845 I1=n846 I2=n720 I3=n847
XU808 ND3 $PINS O=n846 I1=n194 I2=n829 I3=n39
XU809 AOI22S $PINS O=n847 A1=n92 A2=n848 B1=n1044 B2=n849
XU901 OA12 $PINS O=n159 A1=n97 B1=n1040 B2=n1041
XU903 ND3 $PINS O=n534 I1=n493 I2=n778 I3=FE_DBTN249_n85
XU914 AOI22S $PINS O=n843 A1=n1004 A2=n199 B1=n643 B2=n189
XU918 OAI222S $PINS O=n183 A1=n190 A2=n18 B1=n192 B2=n193 C1=n194 C2=n195
XU922 AN2 $PINS O=n190 I1=n203 I2=n204
XU938 AN2 $PINS O=n195 I1=n185 I2=n152
XU946 NR2 $PINS O=n192 I1=n201 I2=n202
XU953 AN2 $PINS O=n92 I1=n186 I2=n97
XU964 NR2 $PINS O=n286 I1=n115 I2=n113
XU965 NR2 $PINS O=n936 I1=n1066 I2=FE_DBTN270_rom_k_idx_2_0
XU966 ND3 $PINS O=n745 I1=n146 I2=n162 I3=n338
XU967 AOI22S $PINS O=n143 A1=n102 A2=n164 B1=n1062 B2=n1022
XU975 NR2 $PINS O=n360 I1=_rom_k_idx_1_1 I2=n111
XU988 OAI12HS $PINS O=n276 A1=n180 B1=FE_DBTN270_rom_k_idx_2_0 B2=n357
XU992 ND3 $PINS O=n356 I1=n361 I2=n362 I3=n363
XU997 ND3 $PINS O=n361 I1=n188 I2=n1066 I3=n368
XU999 ND3 $PINS O=n362 I1=n366 I2=n97 I3=n367
XU1007 OA22 $PINS O=n359 A1=n97 A2=n360 B1=n1028 B2=n286
XU1011 AN2 $PINS O=n291 I1=n287 I2=_rom_k_idx_1_1
XU1013 ND3 $PINS O=n193 I1=n113 I2=n115 I3=n955
XU1014 ND3 $PINS O=n345 I1=n286 I2=FE_DBTN270_rom_k_idx_2_0 I3=n360
XU1015 NR2 $PINS O=n973 I1=FE_DBTN270_rom_k_idx_2_0 I2=k_idx[4]
XU1016 NR2 $PINS O=n964 I1=_rom_k_idx_1_1 I2=k_idx[2]
XU1017 AN2 $PINS O=n935 I1=n973 I2=n113
XU1018 ND2 $PINS O=n229 I1=n954 I2=n955
XU1019 OAI112HS $PINS O=n202 A1=n1040 B1=n97 C1=n203 C2=n1041
XU1020 NR2 $PINS O=n912 I1=n1067 I2=FE_DBTN270_rom_k_idx_2_0
XU1022 ND2 $PINS O=n178 I1=n936 I2=n913
XU1023 ND3 $PINS O=n817 I1=n7 I2=n829 I3=n194
XU1025 ND3 $PINS O=n248 I1=k_idx[3] I2=n115 I3=n955
XU1026 ND2 $PINS O=n238 I1=n912 I2=n913
XU1027 ND2 $PINS O=n319 I1=n912 I2=n369
XU1028 ND3 $PINS O=n156 I1=n913 I2=n113 I3=n959
XU1029 ND2 $PINS O=n214 I1=n908 I2=n369
XU1030 ND3 $PINS O=n289 I1=FE_DBTN270_rom_k_idx_2_0 I2=_rom_k_idx_1_1 I3=n160
XU1032 ND3 $PINS O=n172 I1=n16 I2=n113 I3=n959
XU1034 ND3 $PINS O=n488 I1=n16 I2=k_idx[3] I3=n959
XU1036 ND3 $PINS O=n216 I1=n360 I2=FE_DBTN270_rom_k_idx_2_0 I3=n954
XU1038 ND3 $PINS O=n299 I1=n913 I2=FE_DBTN270_rom_k_idx_2_0 I3=n286
XU1040 ND3 $PINS O=n147 I1=n913 I2=FE_DBTN270_rom_k_idx_2_0 I3=n954
XU1042 ND3 $PINS O=n335 I1=k_idx[3] I2=n913 I3=n959
XU1043 OA12 $PINS O=n274 A1=n1067 B1=k_idx[4] B2=n113
XU1044 NR2 $PINS O=n989 I1=n1040 I2=n_idx[4]
XU1045 NR2 $PINS O=n986 I1=n181 I2=n_idx[4]
XU1046 NR2 $PINS O=n165 I1=n1028 I2=n_idx[4]
XU1047 INV1S $PINS O=n1034 I=n_idx[3]
XU1048 NR2 $PINS O=n984 I1=n204 I2=n_idx[4]
XU1049 NR2 $PINS O=n990 I1=n1034 I2=n_idx[2]
XU1050 NR3 $PINS O=n976 I1=n_idx[1] I2=n_idx[2] I3=n1041
XU1051 NR2 $PINS O=n988 I1=n974 I2=n_idx[4]
XU1052 NR2 $PINS O=n280 I1=n_idx[4] I2=n_idx[3]
XU1053 NR2 $PINS O=n194 I1=n_idx[0] I2=n_idx[4]
XU1054 NR2 $PINS O=n958 I1=n1034 I2=n_idx[4]
XU1056 ND3 $PINS O=n162 I1=n280 I2=n_idx[1] I3=n970
XU1057 NR2 $PINS O=n970 I1=n_idx[2] I2=n_idx[0]
XU1058 ND3 $PINS O=n493 I1=n958 I2=n_idx[2] I3=n370
XU1059 NR2 $PINS O=n981 I1=FE_DBTN269_fold_n_2 I2=n_idx[3]
XU1060 MOAI1S $PINS O=n145 A1=n146 A2=n147 B1=n47 B2=n148
XU1061 OAI112HS $PINS O=n148 A1=FE_DBTN256_n1 B1=n151 C1=n_idx[4] C2=n149
XU1062 ND3 $PINS O=n778 I1=n_idx[1] I2=n_idx[2] I3=n939
XU1063 MOAI1S $PINS O=n184 A1=n185 A2=n149 B1=n186 B2=n187
XU1064 NR2 $PINS O=n643 I1=n193 I2=n_idx[4]
XU1065 INV1S $PINS O=n113 I=k_idx[3]
XU1066 OAI112HS $PINS O=n169 A1=n179 B1=n180 C1=n_idx[3] C2=n178
XU1068 NR2 $PINS O=n326 I1=n156 I2=n_idx[4]
XU1069 NR2 $PINS O=n913 I1=n111 I2=k_idx[1]
XU1070 NR2 $PINS O=n287 I1=k_idx[2] I2=k_idx[0]
XU1071 AN2 $PINS O=n955 I1=n287 I2=k_idx[1]
XU1072 OAI112HS $PINS O=n281 A1=n283 B1=n284 C1=n282 C2=n188
XU1073 ND3 $PINS O=n283 I1=FE_DBTN268_fold_n_1 I2=FE_DBTN269_fold_n_2
+ I3=k_idx[0]
XU1074 AOI13HS $PINS O=n284 A1=FE_DBTN266_n301 B1=k_idx[1] B2=n285 B3=n286
XU1075 MOAI1S $PINS O=n285 A1=n_idx[2] A2=n287 B1=n288 B2=FE_DBTN268_fold_n_1
XU1076 AOI22S $PINS O=n363 A1=n364 A2=n1066 B1=n165 B2=n365
XU1077 MOAI1S $PINS O=n364 A1=k_idx[1] A2=n159 B1=n111 B2=n202
XU1079 OR2 $PINS O=n188 I1=n_idx[2] I2=n370
XU1080 INV1S $PINS O=n111 I=k_idx[2]
XU1081 NR2 $PINS O=n959 I1=k_idx[4] I2=k_idx[0]
XU1082 NR2 $PINS O=n369 I1=k_idx[2] I2=k_idx[1]
XU1083 AOI13HS $PINS O=n290 A1=n_idx[4] B1=n_idx[1] B2=n_idx[3] B3=n291
XU1084 AN2 $PINS O=n368 I1=n_idx[3] I2=n369
XU1085 MOAI1S $PINS O=n366 A1=n287 A2=_rom_k_idx_1_1 B1=k_idx[0] B2=k_idx[2]
XU48 AN4S $PINS O=n409 I1=n220 I2=n401 I3=n406 I4=n399
.ENDS

.SUBCKT SNPS_CLOCK_GATE_HIGH_ROM_Wrapper_Even_1 EN ENCLK CLK
*.CONNECT net2339 EN
XFE_PHC903_net2342 DELC $PINS O=FE_PHN903_net2342 I=net2342
Xlatch QDBHN $PINS Q=net2342 D=net2339 CKB=CLK
Xmain_gate AN2T $PINS O=ENCLK I1=FE_PHN903_net2342 I2=CLK
.ENDS

.SUBCKT ROM_Wrapper_Even_1 rst_n en n_in[4] n_in[3] n_in[2] n_in[1] n_in[0]
+ k_idx[4] k_idx[3] k_idx[2] k_idx[1] k_idx[0] reg_sign1[1] reg_sign1[0]
+ reg_sign2[1] reg_sign2[0] reg_sign3[1] reg_sign3[0] reg_shift1[3]
+ reg_shift1[2] reg_shift1[1] reg_shift1[0] reg_shift2[3] reg_shift2[2]
+ reg_shift2[1] reg_shift2[0] reg_shift3[3] reg_shift3[2] reg_shift3[1]
+ reg_shift3[0] _rom_k_idx_1_1 i_rst_n clk
*.CONNECT N4 n_in[0]
XCTS_ccl_a_INV_CLK_G1_L8_123 INV4CK $PINS O=CTS_10 I=CTS_11
XCTS_ccl_a_INV_CLK_G1_L7_123 INV2CK $PINS O=CTS_11 I=CTS_12
Xreg_sign1_reg[1] DFFSBN $PINS Q=reg_sign1[1] D=raw_s1[1] CK=CTS_10 SB=i_rst_n
Xreg_sign2_reg[1] DFFSBN $PINS Q=reg_sign2[1] D=raw_s2[1] CK=CTS_10 SB=i_rst_n
Xreg_sign3_reg[1] DFFSBN $PINS Q=reg_sign3[1] D=raw_s3[1] CK=CTS_10 SB=i_rst_n
Xreg_sign3_reg[0] QDFFRBN $PINS Q=reg_sign3[0] D=final_s3[0] CK=CTS_10
+ RB=i_rst_n
Xreg_sign1_reg[0] QDFFRBN $PINS Q=reg_sign1[0] D=final_s1[0] CK=CTS_10
+ RB=i_rst_n
Xreg_shift3_reg[1] QDFFRBN $PINS Q=reg_shift3[1] D=raw_h3[1] CK=CTS_10
+ RB=i_rst_n
Xreg_shift1_reg[1] QDFFRBN $PINS Q=reg_shift1[1] D=raw_h1[1] CK=CTS_10
+ RB=i_rst_n
Xreg_shift2_reg[1] QDFFRBN $PINS Q=reg_shift2[1] D=raw_h2[1] CK=CTS_10
+ RB=i_rst_n
Xreg_shift3_reg[3] QDFFRBN $PINS Q=reg_shift3[3] D=raw_h3[3] CK=CTS_10
+ RB=i_rst_n
Xreg_shift3_reg[0] QDFFRBN $PINS Q=reg_shift3[0] D=raw_h3[0] CK=CTS_10
+ RB=i_rst_n
Xreg_shift3_reg[2] QDFFRBN $PINS Q=reg_shift3[2] D=raw_h3[2] CK=CTS_10
+ RB=i_rst_n
Xreg_shift1_reg[0] QDFFRBN $PINS Q=reg_shift1[0] D=raw_h1[0] CK=CTS_10
+ RB=i_rst_n
Xreg_shift2_reg[0] QDFFRBP $PINS Q=reg_shift2[0] D=raw_h2[0] CK=CTS_10
+ RB=i_rst_n
Xreg_shift1_reg[2] QDFFRBS $PINS Q=reg_shift1[2] D=raw_h1[2] CK=CTS_10
+ RB=i_rst_n
Xreg_sign2_reg[0] QDFFRBN $PINS Q=reg_sign2[0] D=final_s2[0] CK=CTS_10
+ RB=i_rst_n
Xreg_shift1_reg[3] QDFFRBN $PINS Q=reg_shift1[3] D=raw_h1[3] CK=CTS_10
+ RB=i_rst_n
Xreg_shift2_reg[2] QDFFRBN $PINS Q=reg_shift2[2] D=raw_h2[2] CK=CTS_10
+ RB=i_rst_n
Xreg_shift2_reg[3] QDFFRBP $PINS Q=reg_shift2[3] D=raw_h2[3] CK=CTS_10
+ RB=i_rst_n
XU3 MOAI1 $PINS O=fold_n[0] A1=n16 A2=N2 B1=N4 B2=N2
XU9 XNR2HS $PINS O=final_s3[0] I1=raw_s3[0] I2=n10
XU10 XNR2HS $PINS O=final_s2[0] I1=raw_s2[0] I2=n10
XU11 XNR2HS $PINS O=final_s1[0] I1=raw_s1[0] I2=n10
XU12 MOAI1 $PINS O=fold_n[1] A1=n13 A2=N2 B1=N5 B2=N2
XU13 INV1S $PINS O=n13 I=n_in[1]
XU14 INV1S $PINS O=n16 I=N4
XU15 ND3 $PINS O=n10 I1=N2 I2=n11 I3=k_idx[0]
XU16 ND3 $PINS O=n11 I1=k_idx[4] I2=k_idx[3] I3=n12
XU17 AN2 $PINS O=n12 I1=k_idx[2] I2=k_idx[1]
XU18 OA13S $PINS O=N2 A1=n_in[4] B1=n_in[1] B2=N4 B3=n15
XU19 MOAI1 $PINS O=fold_n[2] A1=n14 A2=N2 B1=N6 B2=N2
XU20 MOAI1 $PINS O=fold_n[3] A1=n8 A2=N2 B1=N7 B2=N2
XU21 INV1S $PINS O=n14 I=n_in[2]
XU22 INV1S $PINS O=n8 I=n_in[3]
XU23 MOAI1 $PINS O=fold_n[4] A1=n9 A2=N2 B1=N8 B2=N2
XU24 INV1S $PINS O=n9 I=n_in[4]
XU27 XOR2HS $PINS O=N8 I1=n9 I2=sub_79/carry[4]
XU28 AN2 $PINS O=sub_79/carry[4] I1=sub_79/carry[3] I2=n8
XU29 XOR2HS $PINS O=N7 I1=n8 I2=sub_79/carry[3]
XU30 AN2 $PINS O=sub_79/carry[3] I1=sub_79/carry[2] I2=n14
XU31 XOR2HS $PINS O=N6 I1=n14 I2=sub_79/carry[2]
XU33 XOR2HS $PINS O=N5 I1=n13 I2=n16
XU34 OR2 $PINS O=n15 I1=n_in[3] I2=n_in[2]
Xrom_inst CSD_ROM_Table_even_1 $PINS n_idx[4]=fold_n[4] n_idx[3]=fold_n[3]
+ n_idx[2]=fold_n[2] n_idx[1]=fold_n[1] n_idx[0]=fold_n[0] k_idx[4]=k_idx[4]
+ k_idx[3]=k_idx[3] k_idx[2]=k_idx[2] k_idx[1]=k_idx[1] k_idx[0]=k_idx[0]
+ sign1[1]=raw_s1[1] sign1[0]=raw_s1[0] shift1[3]=raw_h1[3] shift1[2]=raw_h1[2]
+ shift1[1]=raw_h1[1] shift1[0]=raw_h1[0] sign2[1]=raw_s2[1] sign2[0]=raw_s2[0]
+ shift2[3]=raw_h2[3] shift2[2]=raw_h2[2] shift2[1]=raw_h2[1] shift2[0]=raw_h2[0]
+ sign3[1]=raw_s3[1] sign3[0]=raw_s3[0] shift3[3]=raw_h3[3] shift3[2]=raw_h3[2]
+ shift3[1]=raw_h3[1] shift3[0]=raw_h3[0] _rom_k_idx_1_1=_rom_k_idx_1_1
Xclk_gate_reg_shift1_reg SNPS_CLOCK_GATE_HIGH_ROM_Wrapper_Even_1 $PINS EN=en
+ ENCLK=CTS_12 CLK=clk
XU32 NR2 $PINS O=sub_79/carry[2] I1=N4 I2=n_in[1]
.ENDS

.SUBCKT CSD_ROM_Table_odd_1 n_idx[4] n_idx[3] n_idx[2] n_idx[1] n_idx[0]
+ k_idx[4] k_idx[3] k_idx[2] k_idx[1] k_idx[0] sign1[1] sign1[0] shift1[3]
+ shift1[2] shift1[1] shift1[0] sign2[1] sign2[0] shift2[3] shift2[2] shift2[1]
+ shift2[0] sign3[1] sign3[0] shift3[3] shift3[2] shift3[1] shift3[0]
+ _rom_k_idx_1_1
XFE_OCPC716_fold_n_0 BUF1 $PINS O=FE_OCPN371_fold_n_0 I=n_idx[0]
XFE_OFC514_n465 INV1S $PINS O=n955 I=n465
XFE_OFC235_n253 INV1S $PINS O=FE_OFN160_n253 I=n972
XFE_OFC234_n253 INV1S $PINS O=n972 I=n253
XFE_OFC167_n144 INV1S $PINS O=n960 I=n144
XFE_OFC123_n195 INV2 $PINS O=n943 I=n195
XFE_DBTC248_fold_n_0 INV1S $PINS O=FE_DBTN248_fold_n_0 I=n_idx[0]
XFE_DBTC247_n147 INV1S $PINS O=FE_DBTN247_n147 I=n147
XFE_DBTC246_n189 INV1S $PINS O=FE_DBTN246_n189 I=n189
XFE_DBTC245_n210 INV1S $PINS O=FE_DBTN245_n210 I=n210
XFE_DBTC244_n215 INV1S $PINS O=FE_DBTN244_n215 I=n215
XFE_DBTC243_n297 INV1S $PINS O=FE_DBTN243_n297 I=n297
XFE_DBTC242_n85 INV1S $PINS O=FE_DBTN242_n85 I=n85
XFE_DBTC241_n355 INV1S $PINS O=FE_DBTN241_n355 I=n355
XFE_DBTC240_n83 INV1S $PINS O=FE_DBTN240_n83 I=n83
XFE_DBTC239_n80 INV1S $PINS O=FE_DBTN239_n80 I=n80
XFE_DBTC238_n440 INV1S $PINS O=FE_DBTN238_n440 I=n440
XFE_DBTC237_n483 INV1S $PINS O=FE_DBTN237_n483 I=n483
XFE_DBTC236_n505 INV1S $PINS O=FE_DBTN236_n505 I=n505
XFE_DBTC235_n84 INV1S $PINS O=FE_DBTN235_n84 I=n84
XFE_DBTC234_n648 INV1S $PINS O=FE_DBTN234_n648 I=n648
XFE_DBTC233_n747 INV1S $PINS O=FE_DBTN233_n747 I=n747
XFE_DBTC232_n4 INV1S $PINS O=FE_DBTN232_n4 I=n4
XFE_DBTC231_n5 INV1S $PINS O=FE_DBTN231_n5 I=n5
XFE_DBTC230_n6 INV1S $PINS O=FE_DBTN230_n6 I=n6
XFE_DBTC229_n109 INV1S $PINS O=FE_DBTN229_n109 I=n109
XU728 ND2 $PINS O=sign3[1] I1=n132 I2=n133
XU729 AO112 $PINS O=n140 A1=n972 B1=n142 C1=n141 C2=n956
XU730 OA222 $PINS O=n136 A1=n145 A2=n146 B1=n147 B2=n148 C1=n149 C2=n150
XU731 AN3B2S $PINS O=n153 I1=n155 B1=n994 B2=n998
XU732 OA222 $PINS O=n135 A1=n165 A2=n166 B1=n167 B2=n168 C1=n169 C2=n170
XU733 OA222 $PINS O=n134 A1=n172 A2=n173 B1=n174 B2=n175 C1=n176 C2=n177
XU736 ND2 $PINS O=n163 I1=n175 I2=n213
XU737 ND2 $PINS O=n247 I1=n248 I2=n234
XU739 ND2 $PINS O=n250 I1=n139 I2=n254
XU740 ND2 $PINS O=n256 I1=n257 I2=n740
XU741 ND2 $PINS O=n255 I1=n258 I2=n54
XU742 OA222 $PINS O=n229 A1=n261 A2=n262 B1=n263 B2=n264 C1=n265 C2=n266
XU743 OA222 $PINS O=n286 A1=n990 A2=n963 B1=n_idx[3] B2=n287 C1=n977 C2=n964
XU744 OA112 $PINS O=n293 A1=n304 B1=n305 C1=n303 C2=n115
XU745 AO12 $PINS O=n305 A1=n307 B1=n173 B2=n306
XU746 AN3B2S $PINS O=n151 I1=n317 B1=n992 B2=n1002
XU747 OA222 $PINS O=n333 A1=n334 A2=n175 B1=n335 B2=n266 C1=n336 C2=n262
XU748 AO12 $PINS O=n351 A1=n240 B1=FE_DBTN238_n440 B2=FE_DBTN243_n297
XU749 ND2 $PINS O=n352 I1=n354 I2=n355
XU750 OA112 $PINS O=n343 A1=n364 B1=n365 C1=n173 C2=n91
XU751 AO12 $PINS O=n371 A1=n182 B1=n991 B2=n375
XU752 ND2 $PINS O=n383 I1=n977 I2=n100
XU753 OA222 $PINS O=n396 A1=n401 A2=n254 B1=n402 B2=n161 C1=n403 C2=n262
XU754 OA222 $PINS O=n395 A1=n405 A2=n202 B1=n406 B2=n213 C1=n407 C2=n266
XU755 OA222 $PINS O=n390 A1=n307 A2=n416 B1=n417 B2=FE_DBTN237_n483 C1=n418
+ C2=n111
XU756 OA112 $PINS O=n434 A1=n435 B1=n436 C1=n188 C2=n122
XU757 ND2 $PINS O=n441 I1=n427 I2=n199
XU758 ND2 $PINS O=n439 I1=n369 I2=n83
XU759 ND2 $PINS O=n442 I1=n211 I2=n84
XU760 AN3 $PINS O=n276 I1=n444 I2=n445 I3=n446
XU761 OA222 $PINS O=n445 A1=n451 A2=n188 B1=n957 B2=n126 C1=n144
+ C2=FE_DBTN238_n440
XU762 OA222 $PINS O=n444 A1=n91 A2=n361 B1=n85 B2=n369 C1=n452 C2=n84
XU763 ND2 $PINS O=n431 I1=n109 I2=n1003
XU764 ND2 $PINS O=n455 I1=n5 I2=n115
XU765 OA222 $PINS O=n457 A1=n300 A2=n412 B1=n463 B2=FE_DBTN243_n297 C1=n4
+ C2=n464
XU766 ND2 $PINS O=n309 I1=n271 I2=n465
XU767 OA222 $PINS O=n456 A1=n199 A2=n126 B1=n466 B2=n271 C1=n128 C2=n54
XU768 OA222 $PINS O=n342 A1=n166 A2=n115 B1=n478 B2=n479 C1=n202 C2=n120
XU769 OA222 $PINS O=n488 A1=n156 A2=n957 B1=n493 B2=n262 C1=n494 C2=n495
XU770 OA222 $PINS O=n487 A1=n496 A2=n266 B1=n497 B2=n264 C1=n498 C2=n213
XU771 OA222 $PINS O=n468 A1=FE_DBTN247_n147 A2=n503 B1=n504 B2=n118 C1=n505
+ C2=n111
XU772 OA222 $PINS O=n513 A1=n516 A2=n264 B1=n517 B2=n161 C1=n518 C2=n246
XU773 OA222 $PINS O=n511 A1=FE_DBTN238_n440 A2=n237 B1=n199 B2=n130 C1=n128
+ C2=n236
XU774 OA222 $PINS O=n510 A1=n173 A2=n111 B1=FE_DBTN243_n297 B2=n83 C1=n520
+ C2=FE_DBTN237_n483
XU775 OA222 $PINS O=n509 A1=n521 A2=n307 B1=n166 B2=n115 C1=n189 C2=n90
XU776 OR3B2 $PINS O=n529 I1=n532 B1=n533 B2=n534
XU777 AO222 $PINS O=n541 A1=n1004 A2=n353 B1=n542 B2=n98 C1=n220 C2=n543
XU778 AO222 $PINS O=n542 A1=n978 A2=n545 B1=n986 B2=n546 C1=n985 C2=n547
XU779 OA222 $PINS O=n540 A1=n126 A2=n4 B1=n312 B2=n119 C1=n550 C2=n130
XU780 AN3B2S $PINS O=n550 I1=n515 B1=n551 B2=n362
XU781 OA222 $PINS O=n539 A1=n329 A2=n118 B1=n552 B2=FE_DBTN238_n440 C1=n619
+ C2=FE_DBTN237_n483
XU782 OA222 $PINS O=n538 A1=n166 A2=n5 B1=n189 B2=n111 C1=FE_DBTN229_n109
+ C2=FE_DBTN230_n6
XU783 ND2 $PINS O=n523 I1=n562 I2=n563
XU784 ND2 $PINS O=n565 I1=n258 I2=n237
XU785 ND2 $PINS O=n564 I1=n268 I2=n969
XU786 OA112 $PINS O=n555 A1=n341 B1=n460 C1=n84 C2=n215
XU787 OA112 $PINS O=n341 A1=n569 B1=n570 C1=n478 C2=n355
XU788 AN3B2S $PINS O=n535 I1=n572 B1=n573 B2=n574
XU789 AO222 $PINS O=n588 A1=n986 A2=n589 B1=n982 B2=FE_DBTN233_n747 C1=n985
+ C2=n590
XU791 OA222 $PINS O=n587 A1=n400 A2=n495 B1=n595 B2=n213 C1=n596 C2=n262
XU793 OA222 $PINS O=n582 A1=n200 A2=n90 B1=n601 B2=n602 C1=n603 C2=n84
XU794 OA222 $PINS O=n581 A1=n604 A2=n118 B1=n618 B2=FE_DBTN243_n297 C1=n605
+ C2=FE_DBTN237_n483
XU795 OA112 $PINS O=n578 A1=n274 B1=n609 C1=n122 C2=n495
XU796 OA222 $PINS O=n609 A1=n307 A2=n479 B1=n610 B2=n503 C1=n525 C2=n611
XU797 ND2 $PINS O=n561 I1=n612 I2=n613
XU798 ND2 $PINS O=n615 I1=FE_DBTN230_n6 I2=n188
XU799 OA112 $PINS O=n472 A1=n527 B1=n617 C1=n152 C2=n91
XU801 ND2 $PINS O=n571 I1=n623 I2=n624
XU802 OA222 $PINS O=n624 A1=n216 A2=FE_DBTN230_n6 B1=n625 B2=n452 C1=n626
+ C2=n361
XU803 OA222 $PINS O=n623 A1=n5 A2=n479 B1=n85 B2=n412 C1=n188 C2=n226
XU806 ND2 $PINS O=n639 I1=FE_DBTN243_n297 I2=n464
XU807 AN3B2S $PINS O=n633 I1=n641 B1=n642 B2=n531
XU808 OA112 $PINS O=n645 A1=n556 B1=n646 C1=n152 C2=n111
XU809 OA222 $PINS O=n556 A1=FE_DBTN243_n297 A2=n143 B1=n128 B2=n51 C1=n611
+ C2=n84
XU810 OA222 $PINS O=n657 A1=n625 A2=FE_DBTN230_n6 B1=n452 B2=n478 C1=n515
+ C2=FE_DBTN237_n483
XU811 OA112 $PINS O=n686 A1=n688 B1=n689 C1=n687 C2=n219
XU812 ND2 $PINS O=n464 I1=n986 I2=n98
XU813 ND2 $PINS O=n690 I1=n118 I2=n300
XU814 ND2 $PINS O=n300 I1=n985 I2=n98
XU815 OA112 $PINS O=n533 A1=n693 B1=n694 C1=n152 C2=n80
XU816 AN3 $PINS O=n471 I1=n696 I2=n697 I3=n698
XU817 OA112 $PINS O=n698 A1=n124 B1=n699 C1=n566 C2=n271
XU818 OA222 $PINS O=n705 A1=n_idx[4] A2=n708 B1=n709 B2=n219 C1=n478
+ C2=FE_DBTN230_n6
XU819 ND2 $PINS O=n478 I1=n147 I2=n710
XU820 OA222 $PINS O=n708 A1=n224 A2=n264 B1=n711 B2=n246 C1=n712 C2=n161
XU821 OA222 $PINS O=n704 A1=n211 A2=n355 B1=n715 B2=n111 C1=n716 C2=n118
XU823 ND2 $PINS O=n519 I1=n248 I2=n237
XU824 AO222 $PINS O=n717 A1=n411 A2=n358 B1=n721 B2=n467 C1=n722 C2=n440
XU825 AN3B2S $PINS O=n700 I1=n534 B1=n726 B2=n727
XU826 OR3B2 $PINS O=n726 I1=n574 B1=n650 B2=n728
XU827 OA112 $PINS O=n735 A1=n736 B1=n737 C1=n152 C2=FE_DBTN229_n109
XU828 ND2 $PINS O=n738 I1=n237 I2=n465
XU832 OA222 $PINS O=n729 A1=n648 A2=FE_DBTN229_n109 B1=n199 B2=n126 C1=n610
+ C2=n503
XU835 ND2 $PINS O=n756 I1=n720 I2=n80
XU836 OA222 $PINS O=n752 A1=n408 A2=n129 B1=n759 B2=FE_DBTN247_n147 C1=n501
+ C2=n127
XU837 ND2 $PINS O=n761 I1=n997 I2=n710
XU838 ND2 $PINS O=n760 I1=n1002 I2=n762
XU839 OR3 $PINS O=n545 I1=n270 I2=n966 I3=n936
XU841 AO222 $PINS O=n767 A1=n23 A2=n770 B1=n983 B2=n771 C1=n984 C2=n772
XU842 AN3B2S $PINS O=n600 I1=n664 B1=n741 B2=n935
XU843 OA222 $PINS O=n765 A1=n664 A2=n177 B1=n773 B2=n774 C1=n775 C2=n254
XU845 AN3 $PINS O=n504 I1=n240 I2=n943 I3=n494
XU846 AO222 $PINS O=n780 A1=n779 A2=n483 B1=n782 B2=n297 C1=n783 C2=n424
XU847 OR3 $PINS O=n779 I1=n783 I2=n92 I3=n967
XU848 AN3B2S $PINS O=n605 I1=n724 B1=n670 B2=n945
XU849 ND2 $PINS O=n225 I1=n720 I2=FE_DBTN229_n109
XU850 OA222 $PINS O=n628 A1=FE_DBTN229_n109 A2=n505 B1=n521 B2=n84 C1=n254
+ C2=n122
XU851 ND2 $PINS O=n799 I1=n235 I2=n356
XU852 ND2 $PINS O=n798 I1=n800 I2=n272
XU853 AO12 $PINS O=n795 A1=FE_DBTN237_n483 B1=n553 B2=n325
XU854 OA222 $PINS O=n793 A1=n307 A2=n296 B1=n801 B2=n503 C1=n_idx[4] C2=n802
XU855 OA222 $PINS O=n802 A1=n803 A2=n264 B1=n804 B2=n246 C1=n805 C2=n161
XU856 ND2 $PINS O=n353 I1=n5 I2=n80
XU857 OA222 $PINS O=n792 A1=n155 A2=n115 B1=n806 B2=n126 C1=n414 C2=n111
XU858 OA222 $PINS O=n791 A1=n807 A2=n130 B1=n338 B2=n219 C1=n808 C2=n119
XU859 ND2 $PINS O=n419 I1=n408 I2=n144
XU860 ND2 $PINS O=n298 I1=n4 I2=n237
XU861 AN3 $PINS O=n728 I1=n821 I2=n822 I3=n823
XU862 OA112 $PINS O=n823 A1=n627 B1=n824 C1=n188 C2=FE_DBTN229_n109
XU863 ND2 $PINS O=n640 I1=n91 I2=n111
XU864 ND2 $PINS O=n661 I1=n54 I2=n957
XU865 AN3 $PINS O=n673 I1=n825 I2=n826 I3=n827
XU866 OA222 $PINS O=n829 A1=n832 A2=FE_DBTN229_n109 B1=n833 B2=n129 C1=n834
+ C2=n127
XU867 ND2 $PINS O=n421 I1=n521 I2=n835
XU868 ND2 $PINS O=n836 I1=n428 I2=n80
XU870 ND2 $PINS O=n840 I1=FE_DBTN244_n215 I2=FE_DBTN235_n84
XU871 ND2 $PINS O=n159 I1=n246 I2=n495
XU872 ND2 $PINS O=n862 I1=n485 I2=n252
XU873 ND2 $PINS O=n861 I1=n54 I2=n83
XU874 OR3 $PINS O=n846 I1=n652 I2=n530 I3=n863
XU875 OA112 $PINS O=n866 A1=n274 B1=n692 C1=n166 C2=FE_DBTN229_n109
XU876 OA13S $PINS O=n865 A1=n688 B1=n591 B2=n_idx[4] B3=n161
XU877 ND2 $PINS O=n503 I1=n867 I2=n384
XU878 OA222 $PINS O=n475 A1=n120 A2=n262 B1=FE_DBTN230_n6 B2=n111 C1=n210 C2=n5
XU879 ND2 $PINS O=n210 I1=n873 I2=n874
XU881 OA222 $PINS O=n869 A1=n369 A2=n130 B1=n404 B2=FE_DBTN238_n440 C1=n219
+ C2=n253
XU882 OA222 $PINS O=n868 A1=n237 A2=FE_DBTN237_n483 B1=n128 B2=n957 C1=n356
+ C2=FE_DBTN243_n297
XU883 OA222 $PINS O=n843 A1=n363 A2=n355 B1=n200 B2=FE_DBTN229_n109 C1=n216
+ C2=n152
XU885 ND2 $PINS O=n139 I1=n385 I2=n888
XU886 ND2 $PINS O=n180 I1=n258 I2=n465
XU887 ND2 $PINS O=n670 I1=n325 I2=n4
XU889 ND2 $PINS O=n254 I1=n892 I2=n372
XU890 OA222 $PINS O=n883 A1=n893 A2=n126 B1=n894 B2=n127 C1=n128
+ C2=FE_OFN160_n253
XU891 ND2 $PINS O=n177 I1=n892 I2=n895
XU892 ND2 $PINS O=n339 I1=n324 I2=n267
XU894 OR3 $PINS O=n896 I1=n260 I2=n954 I3=n340
XU895 ND2 $PINS O=n260 I1=n369 I2=n54
XU898 ND2 $PINS O=n495 I1=n875 I2=n385
XU899 OR3B2 $PINS O=n902 I1=n837 B1=n302 B2=n903
XU900 ND2 $PINS O=n878 I1=n194 I2=n904
XU901 ND2 $PINS O=n837 I1=n758 I2=n366
XU902 ND2 $PINS O=n366 I1=n194 I2=n620
XU905 ND2 $PINS O=n226 I1=n374 I2=n_idx[4]
XU907 ND2 $PINS O=n863 I1=n905 I2=n906
XU908 ND2 $PINS O=n611 I1=n384 I2=n888
XU909 ND2 $PINS O=n551 I1=n430 I2=n83
XU912 ND2 $PINS O=n917 I1=n356 I2=n236
XU920 OA222 $PINS O=n908 A1=n920 A2=n835 B1=n921 B2=n5 C1=n922 C2=n91
XU921 ND2 $PINS O=n189 I1=n891 I2=n384
XU922 ND2 $PINS O=n215 I1=n923 I2=n384
XU923 ND2 $PINS O=n835 I1=n895 I2=n874
XU924 ND2 $PINS O=n648 I1=n372 I2=n384
XU925 ND2 $PINS O=n479 I1=n875 I2=n384
XU927 ND2 $PINS O=n150 I1=n892 I2=n888
XU930 ND2 $PINS O=n452 I1=n867 I2=n874
XU934 ND2 $PINS O=n162 I1=n867 I2=n385
XU936 ND2 $PINS O=n930 I1=n147 I2=n762
XU937 AN3 $PINS O=n932 I1=n942 I2=n171 I3=n198
XU938 ND2 $PINS O=n355 I1=n874 I2=n888
XU939 ND2 $PINS O=n283 I1=k_idx[4] I2=k_idx[3]
XU941 ND2 $PINS O=n787 I1=n601 I2=n302
XU943 ND2 $PINS O=n198 I1=n897 I2=n_idx[1]
XU945 OA222 $PINS O=n649 A1=n118 A2=n4 B1=n119 B2=n412 C1=n202 C2=n120
XU946 ND2 $PINS O=n168 I1=n_idx[1] I2=n919
XU949 ND2 $PINS O=n266 I1=n873 I2=n892
XU950 ND2 $PINS O=n160 I1=n875 I2=n892
XU951 ND2 $PINS O=n376 I1=k_idx[4] I2=n101
XU952 ND2 $PINS O=n505 I1=n873 I2=n384
XU953 ND2 $PINS O=n173 I1=n384 I2=n895
XU3 INV1S $PINS O=n956 I=n_idx[3]
XU4 AN4B1S $PINS O=n599 I1=n267 I2=n679 I3=n330 B1=FE_DBTN232_n4
XU5 NR2 $PINS O=n92 I1=FE_DBTN248_fold_n_0 I2=n168
XU6 AN4B1S $PINS O=n336 I1=n591 I2=n408 I3=n316 B1=n593
XU7 ND2 $PINS O=n80 I1=n147 I2=n182
XU8 AN2 $PINS O=n724 I1=n329 I2=n83
XU9 ND2 $PINS O=n4 I1=FE_OCPN371_fold_n_0 I2=n191
XU11 AN2B1S $PINS O=n415 I1=n479 B1=n6
XU12 ND2 $PINS O=n5 I1=n147 I2=n904
XU13 NR2 $PINS O=n784 I1=n941 I2=n1
XU14 INV1S $PINS O=n1 I=n605
XU15 OR2B1S $PINS O=n175 I1=n977 B1=n895
XU17 INV1S $PINS O=n975 I=n_idx[2]
XU19 INV1S $PINS O=n947 I=n285
XU20 ND2S $PINS O=n569 I1=n1008 I2=n608
XU21 ND2S $PINS O=n304 I1=n608 I2=n1002
XU23 AN2 $PINS O=n6 I1=n875 I2=n874
XU40 INV1S $PINS O=n23 I=n262
XU68 INV1S $PINS O=n51 I=n92
XU71 ND2P $PINS O=n54 I1=n141 I2=n897
XU81 INV1S $PINS O=n91 I=n437
XU89 NR2 $PINS O=n195 I1=n946 I2=FE_DBTN248_fold_n_0
XU91 NR2P $PINS O=n526 I1=n943 I2=n_idx[4]
XU95 INV1S $PINS O=n90 I=n218
XU98 INV1S $PINS O=n935 I=n679
XU99 INV1S $PINS O=n971 I=n426
XU102 ND2S $PINS O=n270 I1=n301 I2=n252
XU103 ND3S $PINS O=n606 I1=n713 I2=n500 I3=n607
XU104 ND3S $PINS O=n546 I1=n492 I2=n325 I3=n549
XU105 ND3S $PINS O=n721 I1=n501 I2=n597 I3=n500
XU106 ND3S $PINS O=n817 I1=n969 I2=n412 I3=n426
XU107 OA222S $PINS O=n586 A1=n598 A2=n161 B1=n599 B2=n266 C1=n600 C2=n202
XU108 ND3S $PINS O=n782 I1=n594 I2=n143 I3=FE_OFN160_n253
XU109 ND3S $PINS O=n484 I1=n325 I2=n201 I3=n485
XU110 ND3S $PINS O=n425 I1=n426 I2=n234 I3=n427
XU111 MAOI1S $PINS O=n294 A1=FE_DBTN234_n648 A2=n299 B1=n300 B2=n301
XU112 OA222S $PINS O=n703 A1=n119 A2=n143 B1=n306 B2=n5 C1=n301
+ C2=FE_DBTN237_n483
XU113 ND3S $PINS O=n814 I1=n54 I2=n465 I3=n500
XU114 ND2S $PINS O=n916 I1=n724 I2=FE_OFN160_n253
XU115 ND2S $PINS O=n251 I1=n252 I2=FE_OFN160_n253
XU116 ND2S $PINS O=n271 I1=n141 I2=n919
XU117 ND3S $PINS O=n547 I1=n500 I2=n252 I3=n548
XU118 ND2S $PINS O=n171 I1=n897 I2=n976
XU119 ND2S $PINS O=n170 I1=n919 I2=n976
XU120 ND2S $PINS O=n237 I1=n918 I2=n919
XU121 ND2S $PINS O=n329 I1=n918 I2=n375
XU122 ND3S $PINS O=n522 I1=n476 I2=n527 I3=n528
XU123 NR2 $PINS O=n76 I1=FE_DBTN247_n147 I2=n946
XU124 OR3S $PINS O=n79 I1=n621 I2=n571 I3=n622
XU125 OA222S $PINS O=n739 A1=n85 A2=n369 B1=n126 B2=n969 C1=n139 C2=n122
XU126 AN3S $PINS O=n758 I1=n226 I2=n122 I3=n707
XU127 ND3S $PINS O=n757 I1=n451 I2=n120 I3=n758
XU128 OR2S $PINS O=n275 I1=n122 I2=n139
XU129 ND3S $PINS O=shift3[2] I1=n468 I2=n469 I3=n470
XU130 OA112S $PINS O=n732 A1=n435 B1=n739 C1=n84 C2=n505
XU131 OA222S $PINS O=n675 A1=n361 A2=n84 B1=n83 B2=FE_DBTN237_n483 C1=n122
+ C2=n246
XU132 ND3S $PINS O=shift1[1] I1=n843 I2=n844 I3=n845
XU133 OA22S $PINS O=n365 A1=n366 A2=n188 B1=n122 B2=n150
XU134 OA222S $PINS O=n534 A1=n648 A2=n84 B1=n747 B2=n119 C1=n122 C2=n160
XU135 ND2S $PINS O=n412 I1=n193 I2=n285
XU136 ND2 $PINS O=n356 I1=n918 I2=n285
XU137 ND2 $PINS O=n465 I1=n141 I2=n285
XU138 ND3S $PINS O=n328 I1=n329 I2=n943 I3=n144
XU139 OA222S $PINS O=n183 A1=n199 A2=n162 B1=n200 B2=n946 C1=n201 C2=n202
XU140 ND2S $PINS O=n707 I1=n194 I2=n179
XU141 OA222S $PINS O=n184 A1=n196 A2=n963 B1=n197 B2=n947 C1=n155 C2=n198
XU142 NR2 $PINS O=n385 I1=n990 I2=_rom_k_idx_1_1
XU143 NR2 $PINS O=n874 I1=_rom_k_idx_1_1 I2=k_idx[0]
XU144 NR2 $PINS O=n610 I1=n112 I2=n106
XU145 INV1S $PINS O=n106 I=n720
XU146 NR2 $PINS O=n301 I1=n592 I2=n960
XU147 NR2 $PINS O=n272 I1=n945 I2=FE_DBTN233_n747
XU148 NR2 $PINS O=n597 I1=n937 I2=n951
XU149 INV1S $PINS O=n951 I=n312
XU150 INV1S $PINS O=n115 I=n76
XU151 INV1S $PINS O=n953 I=n330
XU152 INV1S $PINS O=n112 I=n601
XU153 NR2 $PINS O=n800 I1=n940 I2=n592
XU154 NR2 $PINS O=n720 I1=n107 I2=n76
XU155 INV1S $PINS O=n111 I=n608
XU156 NR2 $PINS O=n596 I1=FE_DBTN233_n747 I2=n741
XU157 NR2 $PINS O=n515 I1=n971 I2=n951
XU158 INV1S $PINS O=n592 I=n500
XU159 AN2 $PINS O=n598 I1=n491 I2=n235
XU160 NR2 $PINS O=n496 I1=n339 I2=n953
XU161 INV1S $PINS O=n937 I=n408
XU162 INV1S $PINS O=n936 I=n713
XU164 INV1S $PINS O=n934 I=n325
XU165 NR2 $PINS O=n494 I1=n934 I2=n949
XU166 INV1S $PINS O=n945 I=n201
XU167 INV1S $PINS O=n108 I=n367
XU168 NR2 $PINS O=n312 I1=n952 I2=n955
XU169 NR2 $PINS O=n594 I1=n606 I2=n952
XU170 AN2 $PINS O=n595 I1=n544 I2=n597
XU171 INV1S $PINS O=n224 I=n409
XU172 INV1S $PINS O=n370 I=n234
XU173 NR2 $PINS O=n330 I1=FE_DBTN233_n747 I2=n955
XU175 INV1S $PINS O=n944 I=n671
XU176 NR2 $PINS O=n601 I1=n113 I2=FE_DBTN239_n80
XU177 INV1S $PINS O=n113 I=n307
XU178 INV1S $PINS O=n966 I=n316
XU179 INV1S $PINS O=n741 I=n485
XU180 INV1S $PINS O=n107 I=n451
XU182 ND3 $PINS O=n315 I1=n83 I2=n943 I3=n316
XU183 NR2 $PINS O=n427 I1=n937 I2=n955
XU184 INV1S $PINS O=n954 I=n252
XU185 INV1S $PINS O=n940 I=n235
XU186 NR2 $PINS O=n608 I1=FE_DBTN247_n147 I2=n961
XU187 NR2 $PINS O=n501 I1=n958 I2=n971
XU188 INV1S $PINS O=n939 I=n492
XU189 AN2 $PINS O=n525 I1=n428 I2=n216
XU190 INV1S $PINS O=n948 I=n401
XU192 INV1S $PINS O=n105 I=n428
XU193 INV1S $PINS O=n124 I=n743
XU194 INV1S $PINS O=n950 I=n248
XU195 INV1S $PINS O=n110 I=n302
XU196 ND3 $PINS O=n573 I1=n528 I2=n575 I3=n576
XU197 ND3 $PINS O=n349 I1=n350 I2=n124 I3=n351
XU198 OR2 $PINS O=n630 I1=n130 I2=n631
XU199 OAI112HS $PINS O=n754 A1=n304 B1=n124 C1=n601 C2=n755
XU200 NR2 $PINS O=n755 I1=n992 I2=n994
XU201 INV1S $PINS O=n998 I=n196
XU202 INV1S $PINS O=n994 I=n521
XU203 INV1S $PINS O=n992 I=n197
XU204 INV1S $PINS O=n996 I=n415
XU205 INV1S $PINS O=n1001 I=n200
XU206 OAI112HS $PINS O=n621 A1=n627 B1=n628 C1=n85 C2=n356
XU207 INV1S $PINS O=n946 I=n179
XU208 NR3 $PINS O=n527 I1=n77 I2=n78 I3=n79
XU209 OAI222S $PINS O=n77 A1=n324 A2=n126 B1=n129 B2=n465 C1=n316 C2=n127
XU210 OAI112HS $PINS O=n78 A1=n630 B1=n350 C1=n629 C2=FE_DBTN238_n440
XU211 INV1S $PINS O=n122 I=n526
XU212 NR2 $PINS O=n500 I1=n92 I2=n777
XU213 NR3 $PINS O=n491 I1=n968 I2=n952 I3=n545
XU214 ND3 $PINS O=shift2[3] I1=n577 I2=n578 I3=n579
XU215 AN4B1S $PINS O=n577 I1=n472 I2=n459 I3=n572 B1=n561
XU216 AN4B1S $PINS O=n579 I1=n580 I2=n581 I3=n582 B1=n583
XU217 NR2P $PINS O=n325 I1=n935 I2=n973
XU218 NR2 $PINS O=n426 I1=n974 I2=n972
XU219 AOI22S $PINS O=n764 A1=n981 A2=n778 B1=n986 B2=n779
XU220 ND3 $PINS O=n778 I1=n252 I2=n51 I3=n504
XU221 NR2 $PINS O=n679 I1=n971 I2=n938
XU222 AN4B1S $PINS O=n906 I1=n907 I2=n908 I3=n909 B1=n910
XU223 NR3 $PINS O=n905 I1=n924 I2=n925 I3=n926
XU224 OA22 $PINS O=n907 A1=n90 A2=n886 B1=n111 B2=n715
XU225 ND3 $PINS O=n924 I1=n641 I2=n675 I3=n927
XU226 AOI22S $PINS O=n927 A1=FE_DBTN239_n80 A2=n1006 B1=n978 B2=n526
XU227 AOI22S $PINS O=n828 A1=n1005 A2=n836 B1=n980 B2=n837
XU228 NR2 $PINS O=n826 I1=n838 I2=n839
XU229 AN4B1S $PINS O=n825 I1=n454 I2=n840 I3=n841 B1=n616
XU230 AN4B1S $PINS O=n827 I1=n828 I2=n829 I3=n830 B1=n831
XU231 ND3 $PINS O=shift2[1] I1=n653 I2=n654 I3=n655
XU232 AN4B1S $PINS O=n655 I1=n656 I2=n657 I3=n658 B1=n659
XU233 NR2 $PINS O=n654 I1=n666 I2=n667
XU234 AN4B1S $PINS O=n653 I1=n672 I2=n673 I3=n651 B1=n462
XU235 ND3 $PINS O=shift3[1] I1=n506 I2=n507 I3=n508
XU236 AN4B1S $PINS O=n508 I1=n509 I2=n510 I3=n511 B1=n512
XU237 NR3 $PINS O=n506 I1=n529 I2=n530 I3=n531
XU238 NR3 $PINS O=n507 I1=n522 I2=n523 I3=n524
XU239 ND3 $PINS O=shift1[2] I1=n788 I2=n789 I3=n790
XU240 NR3 $PINS O=n789 I1=n810 I2=n811 I3=n812
XU241 AN4B1S $PINS O=n790 I1=n791 I2=n792 I3=n793 B1=n794
XU242 AN4B1S $PINS O=n788 I1=n673 I2=n818 I3=n728 B1=n819
XU243 NR2 $PINS O=n408 I1=n949 I2=n938
XU244 NR2 $PINS O=n713 I1=n937 I2=n195
XU245 INV2 $PINS O=n949 I=n412
XU246 NR2 $PINS O=n591 I1=n592 I2=n973
XU247 ND3 $PINS O=n771 I1=n599 I2=n957 I3=n776
XU248 NR2 $PINS O=n776 I1=n952 I2=n949
XU249 AN4B1S $PINS O=n388 I1=n389 I2=n390 I3=n391 B1=n392
XU250 OA22 $PINS O=n391 A1=n91 A2=n414 B1=n84 B2=n415
XU251 AOI22S $PINS O=n389 A1=FE_DBTN242_n85 A2=n419 B1=FE_DBTN239_n80 B2=n421
XU252 NR3 $PINS O=n773 I1=n771 I2=n195 I3=n973
XU253 NR2P $PINS O=n144 I1=FE_DBTN232_n4 I2=n973
XU254 INV1S $PINS O=n961 I=n191
XU255 ND3 $PINS O=shift1[0] I1=n879 I2=n880 I3=n881
XU256 AN4B1S $PINS O=n881 I1=n882 I2=n883 I3=n884 B1=n885
XU257 NR2 $PINS O=n880 I1=n900 I2=n901
XU258 AN4B1S $PINS O=n879 I1=n841 I2=n649 I3=n785 B1=n863
XU259 NR2 $PINS O=n201 I1=n951 I2=n195
XU260 NR2 $PINS O=n234 I1=n592 I2=n968
XU261 AN4B1S $PINS O=n230 I1=n241 I2=n242 I3=n243 B1=n244
XU262 AOI22S $PINS O=n243 A1=n941 A2=n250 B1=n987 B2=n251
XU263 AOI22S $PINS O=n242 A1=n979 A2=n255 B1=n988 B2=n256
XU264 AOI22S $PINS O=n241 A1=n981 A2=n260 B1=n968 B2=n159
XU265 ND3 $PINS O=n409 I1=n629 I2=n713 I3=n714
XU266 NR2 $PINS O=n714 I1=n972 I2=n362
XU267 AN4B1S $PINS O=n804 I1=n331 I2=n301 I3=n356 B1=n941
XU268 INV1S $PINS O=n362 I=n499
XU269 AN4B1S $PINS O=n803 I1=n806 I2=n301 I3=n465 B1=n949
XU270 ND3 $PINS O=n367 I1=n432 I2=n433 I3=n434
XU271 MAOI1 $PINS O=n432 A1=n1007 A2=n442 B1=n363 B2=n443
XU272 AOI22S $PINS O=n433 A1=n438 A2=n439 B1=n440 B2=n441
XU273 AOI12HS $PINS O=n459 A1=n616 B1=n218 B2=n1006
XU274 AOI22S $PINS O=n454 A1=n1002 A2=n437 B1=n526 B2=n989
XU275 AN2 $PINS O=n364 I1=n453 I2=n454
XU276 AOI22S $PINS O=n453 A1=n1005 A2=n455 B1=FE_DBTN242_n85 B2=n950
XU278 INV1S $PINS O=n369 I=n92
XU279 NR2 $PINS O=n417 I1=n967 I2=n270
XU280 ND3 $PINS O=n411 I1=n499 I2=n273 I3=n725
XU281 NR2 $PINS O=n725 I1=n954 I2=n592
XU282 AOI22S $PINS O=n753 A1=n997 A2=n756 B1=n980 B2=n757
XU283 INV1S $PINS O=n618 I=n606
XU284 AN4B1S $PINS O=n604 I1=n607 I2=n494 I3=n943 B1=n777
XU285 MOAI1S $PINS O=n914 A1=n915 A2=n213 B1=n551 B2=n983
XU286 NR2 $PINS O=n915 I1=n937 I2=n741
XU287 ND3 $PINS O=n462 I1=n674 I2=n675 I3=n676
XU288 AOI22S $PINS O=n674 A1=n6 A2=n105 B1=n608 B2=FE_DBTN245_n210
XU289 NR2 $PINS O=n676 I1=n677 I2=n678
XU290 MOAI1S $PINS O=n678 A1=n679 A2=n119 B1=n938 B2=n220
XU291 INV1S $PINS O=n120 I=n212
XU292 INV2 $PINS O=n952 I=n356
XU293 NR3 $PINS O=n322 I1=n327 I2=n949 I3=n941
XU294 NR2 $PINS O=n553 I1=n945 I2=n92
XU295 ND3 $PINS O=n327 I1=n273 I2=n553 I3=n554
XU296 NR2 $PINS O=n554 I1=n973 I2=n968
XU297 NR3 $PINS O=n544 I1=n362 I2=FE_DBTN233_n747 I3=n260
XU298 ND3 $PINS O=shift2[2] I1=n632 I2=n633 I3=n634
XU299 AN4B1S $PINS O=n634 I1=n635 I2=n636 I3=n637 B1=n638
XU300 AN4B1S $PINS O=n632 I1=n649 I2=n650 I3=n651 B1=n652
XU301 NR2 $PINS O=n216 I1=n218 I2=n76
XU302 NR2 $PINS O=n493 I1=FE_DBTN232_n4 I2=n92
XU303 NR2 $PINS O=n430 I1=n960 I2=n92
XU304 NR2 $PINS O=n625 I1=n109 I2=n76
XU305 AN4B1S $PINS O=n323 I1=n324 I2=n178 I3=n325 B1=n944
XU306 NR2 $PINS O=n400 I1=n937 I2=n777
XU307 NR2 $PINS O=n747 I1=n967 I2=FE_DBTN240_n83
XU308 NR2 $PINS O=n671 I1=n195 I2=n967
XU309 OA12 $PINS O=n820 A1=n575 B1=n120 B2=n175
XU310 NR2 $PINS O=n307 I1=n218 I2=n608
XU311 NR2 $PINS O=n252 I1=FE_DBTN240_n83 I2=n955
XU312 AOI22S $PINS O=n460 A1=n987 A2=n526 B1=FE_DBTN233_n747 B2=n358
XU313 AOI22S $PINS O=n824 A1=n973 A2=FE_DBTN242_n85 B1=n1008 B2=n112
XU314 AOI22S $PINS O=n821 A1=n438 A2=n951 B1=n92 B2=n568
XU315 AOI22S $PINS O=n822 A1=n357 A2=n661 B1=n993 B2=n640
XU316 AN4B1S $PINS O=n473 I1=n475 I2=n476 I3=n342 B1=n477
XU317 INV1S $PINS O=n969 I=n340
XU318 NR2 $PINS O=n316 I1=n974 I2=n967
XU319 AOI22S $PINS O=n737 A1=n340 A2=n357 B1=n568 B2=n971
XU321 NR2 $PINS O=n485 I1=FE_DBTN232_n4 I2=n777
XU322 NR2 $PINS O=n451 I1=FE_DBTN235_n84 I2=FE_DBTN231_n5
XU323 NR2 $PINS O=n664 I1=FE_DBTN233_n747 I2=n340
XU325 NR3 $PINS O=n548 I1=n971 I2=n195 I3=n362
XU326 NR2 $PINS O=n607 I1=n954 I2=n941
XU327 AOI22S $PINS O=n650 A1=n979 A2=n526 B1=n967 B2=n483
XU328 NR2 $PINS O=n258 I1=n92 I2=n949
XU329 OAI22S $PINS O=n811 A1=n815 A2=FE_DBTN238_n440 B1=n816 B2=n128
XU330 NR3 $PINS O=n816 I1=n817 I2=n953 I3=n741
XU331 AN4B1S $PINS O=n815 I1=n234 I2=n83 I3=n713 B1=n298
XU332 OAI112HS $PINS O=n885 A1=n887 B1=n569 C1=n886 C2=n5
XU333 OAI12HS $PINS O=n887 A1=FE_DBTN242_n85 B1=n670 B2=n180
XU334 AOI22S $PINS O=n736 A1=FE_DBTN245_n210 A2=FE_DBTN235_n84 B1=n980
+ B2=FE_DBTN231_n5
XU335 NR2 $PINS O=n331 I1=n974 I2=n949
XU336 NR2 $PINS O=n235 I1=n972 I2=n941
XU337 NR2 $PINS O=n404 I1=n940 I2=n973
XU338 NR2 $PINS O=n629 I1=n92 I2=n955
XU339 MOAI1S $PINS O=n876 A1=n196 A2=n91 B1=n526 B2=n164
XU341 AOI22S $PINS O=n680 A1=n967 A2=n985 B1=n978 B2=n940
XU342 NR2 $PINS O=n626 I1=n437 I2=FE_DBTN239_n80
XU343 AOI22S $PINS O=n641 A1=n212 A2=n985 B1=n483 B2=n949
XU344 NR3 $PINS O=n518 I1=n519 I2=n974 I3=n249
XU345 ND3 $PINS O=n794 I1=n795 I2=n796 I3=n797
XU346 ND3 $PINS O=n796 I1=n147 I2=n762 I3=n6
XU347 AOI22S $PINS O=n797 A1=n424 A2=n798 B1=FE_DBTN242_n85 B2=n799
XU348 ND3 $PINS O=n410 I1=n412 I2=n356 I3=n969
XU349 ND3 $PINS O=n722 I1=n723 I2=n331 I3=n724
XU350 NR3 $PINS O=n723 I1=n960 I2=n777 I3=n939
XU351 AOI22S $PINS O=n695 A1=n483 A2=n592 B1=FE_DBTN240_n83 B2=FE_DBTN242_n85
XU352 AOI22S $PINS O=n884 A1=n438 A2=n889 B1=n467 B2=n890
XU353 ND3 $PINS O=n890 I1=n240 I2=n412 I3=n548
XU354 ND3 $PINS O=n889 I1=n591 I2=n408 I3=n502
XU356 NR2 $PINS O=n492 I1=n951 I2=n941
XU357 NR2 $PINS O=n775 I1=n92 I2=n939
XU358 AOI22S $PINS O=n672 A1=FE_DBTN236_n505 A2=FE_DBTN231_n5 B1=n983 B2=n526
XU359 INV1S $PINS O=n958 I=n324
XU360 NR2 $PINS O=n268 I1=FE_DBTN232_n4 I2=n972
XU361 AN4B1S $PINS O=n516 I1=n957 I2=n273 I3=n430 B1=n954
XU362 MOAI1S $PINS O=n910 A1=FE_DBTN229_n109 A2=n354 B1=n424 B2=n249
XU363 MOAI1S $PINS O=n781 A1=n594 A2=n85 B1=n1007 B2=n225
XU364 AOI22S $PINS O=n575 A1=FE_DBTN246_n189 A2=FE_DBTN235_n84
+ B1=FE_DBTN234_n648 B2=n218
XU365 INV1S $PINS O=n740 I=n567
XU366 NR2 $PINS O=n832 I1=n998 I2=n421
XU367 NR2 $PINS O=n833 I1=n777 I2=FE_DBTN240_n83
XU368 AN2 $PINS O=n834 I1=n740 I2=n549
XU369 OAI22S $PINS O=n742 A1=n745 A2=n91 B1=n746 B2=n118
XU370 NR2 $PINS O=n745 I1=FE_DBTN241_n355 I2=n1001
XU371 NR2 $PINS O=n746 I1=n950 I2=n948
XU372 NR2 $PINS O=n401 I1=n973 I2=n949
XU373 NR2 $PINS O=n248 I1=n952 I2=FE_DBTN240_n83
XU374 AOI22S $PINS O=n830 A1=n568 A2=n966 B1=FE_DBTN234_n648 B2=n107
XU376 AOI22S $PINS O=n627 A1=n1006 A2=FE_DBTN235_n84 B1=n1005 B2=n218
XU377 NR2 $PINS O=n428 I1=n437 I2=FE_DBTN231_n5
XU378 AOI22S $PINS O=n692 A1=n437 A2=n1008 B1=n76 B2=FE_DBTN244_n215
XU379 INV1S $PINS O=n129 I=n438
XU380 NR2 $PINS O=n257 I1=n972 I2=n340
XU381 NR2 $PINS O=n239 I1=n968 I2=n974
XU382 NR2 $PINS O=n363 I1=FE_DBTN235_n84 I2=FE_DBTN239_n80
XU383 INV1S $PINS O=n103 I=n571
XU384 NR2 $PINS O=n302 I1=n437 I2=n109
XU386 AOI22S $PINS O=n274 A1=FE_DBTN246_n189 A2=FE_DBTN239_n80
+ B1=FE_DBTN234_n648 B2=n76
XU387 NR2 $PINS O=n403 I1=n973 I2=n966
XU388 INV1S $PINS O=n126 I=n568
XU389 NR2 $PINS O=n691 I1=n968 I2=n967
XU390 ND3 $PINS O=n474 I1=n557 I2=n558 I3=n559
XU391 OA22 $PINS O=n558 A1=n83 A2=n566 B1=n111 B2=n414
XU392 AOI22S $PINS O=n557 A1=n567 A2=n568 B1=n76 B2=n1002
XU393 NR3 $PINS O=n559 I1=n560 I2=n561 I3=n523
XU394 AOI22S $PINS O=n476 A1=FE_DBTN239_n80 A2=n1008 B1=n1002 B2=n105
XU395 NR2 $PINS O=n602 I1=FE_DBTN245_n210 I2=n1008
XU396 MOAI1S $PINS O=n926 A1=FE_DBTN243_n297 A2=n83 B1=n1005 B2=n76
XU397 AOI22S $PINS O=n841 A1=n993 A2=FE_DBTN239_n80 B1=n76 B2=FE_DBTN236_n505
XU398 AOI22S $PINS O=n435 A1=n437 A2=FE_DBTN245_n210 B1=FE_DBTN234_n648
+ B2=FE_DBTN231_n5
XU399 OR2 $PINS O=n350 I1=n707 I2=n188
XU400 NR2 $PINS O=n743 I1=n878 I2=n188
XU401 AOI22S $PINS O=n818 A1=n1004 A2=FE_DBTN231_n5 B1=FE_DBTN241_n355 B2=n608
XU402 AOI22S $PINS O=n332 A1=n988 A2=n777 B1=n984 B2=n951
XU403 NR2 $PINS O=n273 I1=n972 I2=n938
XU404 AOI22S $PINS O=n580 A1=n608 A2=n994 B1=n1007 B2=n106
XU405 AOI22S $PINS O=n871 A1=FE_DBTN244_n215 A2=n218 B1=n109 B2=n980
XU406 AOI22S $PINS O=n528 A1=n212 A2=n983 B1=n218 B2=n997
XU407 AOI22S $PINS O=n292 A1=FE_DBTN242_n85 A2=n309 B1=n105 B2=n1001
XU408 AOI12HS $PINS O=n744 A1=n119 B1=n324 B2=n716
XU409 NR2 $PINS O=n716 I1=n92 I2=n938
XU410 OAI12HS $PINS O=n449 A1=n218 B1=FE_DBTN236_n505 B2=n6
XU411 AOI22S $PINS O=n346 A1=n357 A2=n958 B1=n358 B2=n967
XU412 AOI22S $PINS O=n576 A1=n218 A2=FE_DBTN236_n505 B1=n76 B2=FE_DBTN241_n355
XU413 NR2 $PINS O=n211 I1=n109 I2=n218
XU414 AOI22S $PINS O=n684 A1=n567 A2=n568 B1=n1003 B2=n110
XU415 NR2 $PINS O=n549 I1=n967 I2=n777
XU416 NR2 $PINS O=n240 I1=n952 I2=n777
XU417 NR2 $PINS O=n149 I1=n966 I2=n968
XU418 OA22 $PINS O=n347 A1=n85 A2=n273 B1=n129 B2=n356
XU419 OA22 $PINS O=n685 A1=FE_DBTN229_n109 A2=n155 B1=n119 B2=n957
XU420 AOI22S $PINS O=n699 A1=n941 A2=n438 B1=n972 B2=n357
XU421 AOI22S $PINS O=n461 A1=n1007 A2=n107 B1=n1008 B2=n113
XU422 NR2 $PINS O=n631 I1=n974 I2=n973
XU423 AOI22S $PINS O=n206 A1=FE_DBTN236_n505 A2=n76 B1=FE_DBTN241_n355 B2=n218
XU424 INV1S $PINS O=n127 I=n357
XU425 OAI112HS $PINS O=n659 A1=n569 B1=n304 C1=n660 C2=n219
XU426 NR2 $PINS O=n660 I1=n955 I2=n661
XU427 NR2 $PINS O=n502 I1=n950 I2=n972
XU428 AOI22S $PINS O=n185 A1=n979 A2=n195 B1=FE_DBTN234_n648 B2=n191
XU429 AOI22S $PINS O=n436 A1=n437 A2=n996 B1=FE_DBTN239_n80 B2=n1002
XU430 AOI22S $PINS O=n882 A1=n440 A2=n898 B1=n297 B2=n940
XU431 ND3 $PINS O=n898 I1=n691 I2=n485 I3=n899
XU432 NR2 $PINS O=n899 I1=n951 I2=n940
XU433 NR2 $PINS O=n566 I1=FE_DBTN242_n85 I2=n568
XU435 INV1S $PINS O=n130 I=n467
XU436 AOI22S $PINS O=n857 A1=n986 A2=n938 B1=FE_DBTN232_n4 B2=n981
XU437 ND3 $PINS O=n706 I1=n350 I2=n688 I3=n448
XU438 AOI22S $PINS O=n693 A1=n357 A2=FE_DBTN240_n83 B1=n938 B2=n438
XU439 INV1S $PINS O=n118 I=n424
XU440 MOAI1S $PINS O=n295 A1=n84 A2=n296 B1=n297 B2=n298
XU443 NR2 $PINS O=n196 I1=FE_DBTN241_n355 I2=FE_DBTN234_n648
XU444 AOI22S $PINS O=n207 A1=n109 A2=n996 B1=n220 B2=FE_DBTN233_n747
XU445 NR2 $PINS O=n521 I1=FE_DBTN236_n505 I2=FE_DBTN244_n215
XU446 MOAI1S $PINS O=n480 A1=n502 A2=FE_DBTN243_n297 B1=n954 B2=n467
XU447 AOI22S $PINS O=n635 A1=FE_DBTN246_n189 A2=n640 B1=FE_DBTN232_n4 B2=n220
XU448 INV1S $PINS O=n128 I=n358
XU449 INV1S $PINS O=n980 I=n188
XU450 INV1S $PINS O=n119 I=n647
XU451 NR2 $PINS O=n156 I1=n988 I2=n984
XU452 INV1S $PINS O=n981 I=n495
XU453 INV1S $PINS O=n219 I=n220
XU454 NR3 $PINS O=n306 I1=FE_DBTN245_n210 I2=FE_DBTN246_n189 I3=n994
XU455 AOI22S $PINS O=n572 A1=FE_DBTN234_n648 A2=n437 B1=FE_DBTN246_n189 B2=n109
XU456 NR2 $PINS O=n317 I1=FE_DBTN246_n189 I2=n1006
XU457 INV1S $PINS O=n978 I=n161
XU458 NR2 $PINS O=n197 I1=n993 I2=n1008
XU459 NR2 $PINS O=n157 I1=n163 I2=n164
XU460 OA12 $PINS O=n877 A1=n980 B1=FE_DBTN235_n84 B2=n437
XU461 AOI22S $PINS O=n636 A1=n1006 A2=n608 B1=n218 B2=FE_DBTN241_n355
XU462 NR2 $PINS O=n886 I1=n1006 I2=n1007
XU463 NR2 $PINS O=n603 I1=n998 I2=n1005
XU464 NR2 $PINS O=n715 I1=n997 I2=FE_DBTN234_n648
XU465 NR2 $PINS O=n200 I1=FE_DBTN246_n189 I2=n1004
XU466 NR2 $PINS O=n354 I1=n997 I2=n1002
XU467 NR2 $PINS O=n418 I1=FE_DBTN246_n189 I2=n154
XU468 INV1S $PINS O=n979 I=n213
XU469 NR2 $PINS O=n155 I1=n997 I2=n1007
XU470 NR2 $PINS O=n774 I1=n985 I2=n979
XU471 NR2 $PINS O=n443 I1=n1005 I2=n1003
XU472 INV1S $PINS O=n982 I=n175
XU473 AOI22S $PINS O=n637 A1=n955 A2=n467 B1=n974 B2=n440
XU474 NR2 $PINS O=n463 I1=n938 I2=n309
XU475 NR2 $PINS O=n414 I1=FE_DBTN244_n215 I2=n1006
XU476 NR2 $PINS O=n296 I1=FE_DBTN236_n505 I2=FE_DBTN245_n210
XU477 NR3 $PINS O=n466 I1=n467 I2=n440 I3=n358
XU478 NR2 $PINS O=n169 I1=FE_DBTN244_n215 I2=n992
XU479 NR2 $PINS O=n167 I1=FE_DBTN241_n355 I2=n1008
XU480 NR2 $PINS O=n416 I1=n997 I2=n1004
XU481 NR2 $PINS O=n179 I1=n947 I2=n976
XU482 AOI22S $PINS O=n617 A1=FE_DBTN241_n355 A2=n110 B1=FE_DBTN244_n215
+ B2=FE_DBTN231_n5
XU483 NR2 $PINS O=n469 I1=n480 I2=n481
XU484 AN4B1S $PINS O=n470 I1=n471 I2=n472 I3=n473 B1=n474
XU486 MOAI1S $PINS O=n583 A1=n_idx[4] A2=n584 B1=n105 B2=n6
XU487 AN4B1S $PINS O=n584 I1=n585 I2=n586 I3=n587 B1=n588
XU488 AOI22S $PINS O=n585 A1=n593 A2=n988 B1=n952 B2=n989
XU489 INV1S $PINS O=n974 I=n54
XU490 ND3 $PINS O=n783 I1=n271 I2=n412 I3=n784
XU491 ND3 $PINS O=shift1[3] I1=n748 I2=n749 I3=n750
XU492 AN4B1S $PINS O=n748 I1=n785 I2=n692 I3=n628 B1=n477
XU493 NR2 $PINS O=n749 I1=n780 I2=n781
XU494 AN4B1S $PINS O=n750 I1=n751 I2=n752 I3=n753 B1=n754
XU495 OAI22S $PINS O=n768 A1=n598 A2=n161 B1=n769 B2=n175
XU496 AN4B1S $PINS O=n769 I1=n664 I2=n501 I3=n271 B1=n567
XU497 ND3 $PINS O=n574 I1=n729 I2=n730 I3=n731
XU498 NR3 $PINS O=n730 I1=n742 I2=n743 I3=n744
XU499 AN4B1S $PINS O=n731 I1=n646 I2=n732 I3=n693 B1=n622
XU500 ND3 $PINS O=shift2[0] I1=n700 I2=n701 I3=n702
XU501 NR2 $PINS O=n701 I1=n717 I2=n718
XU502 AN4B1S $PINS O=n702 I1=n703 I2=n704 I3=n705 B1=n706
XU503 NR3 $PINS O=n313 I1=n318 I2=n319 I3=n320
XU504 OAI222S $PINS O=n319 A1=n330 A2=n264 B1=n156 B2=n83 C1=n331 C2=n202
XU505 OAI222S $PINS O=n320 A1=n321 A2=n161 B1=n322 B2=n246 C1=n323 C2=n213
XU506 OAI112HS $PINS O=n318 A1=n332 B1=n333 C1=n254 C2=n271
XU507 NR2 $PINS O=n267 I1=n592 I2=n269
XU508 NR3 $PINS O=n335 I1=n337 I2=FE_DBTN232_n4 I3=n936
XU509 NR3 $PINS O=n334 I1=n339 I2=n340 I3=n966
XU510 NR2 $PINS O=n290 I1=n310 I2=n311
XU511 MOAI1S $PINS O=n311 A1=n312 A2=n118 B1=n1005 B2=n218
XU512 OAI222S $PINS O=n310 A1=n_idx[4] A2=n313 B1=n151 B2=FE_DBTN229_n109
+ C1=n314 C2=FE_DBTN237_n483
XU513 NR3 $PINS O=n314 I1=n315 I2=n370 I3=n948
XU514 NR3 $PINS O=n844 I1=n876 I2=n743 I3=n877
XU515 NR3 $PINS O=n845 I1=n846 I2=n847 I3=n848
XU516 ND3 $PINS O=n772 I1=n499 I2=n369 I3=n600
XU517 ND3 $PINS O=n770 I1=n631 I2=n236 I3=n496
XU518 ND3 $PINS O=shift3[0] I1=n535 I2=n536 I3=n537
XU519 AN4B1S $PINS O=n536 I1=n103 I2=n555 I3=n556 B1=n474
XU520 AN4B1S $PINS O=n537 I1=n538 I2=n539 I3=n540 B1=n541
XU521 NR2 $PINS O=n204 I1=n222 I2=n223
XU522 MOAI1S $PINS O=n223 A1=n5 A2=FE_DBTN230_n6 B1=n1007 B2=n225
XU523 OAI22S $PINS O=n222 A1=n188 A2=n226 B1=n_idx[4] B2=n227
XU524 AN4B1S $PINS O=n227 I1=n228 I2=n229 I3=n230 B1=n231
XU525 AN4B1S $PINS O=n261 I1=n271 I2=n236 I3=n272 B1=n958
XU526 AN4B1S $PINS O=n265 I1=n267 I2=n268 I3=n248 B1=n949
XU527 NR3 $PINS O=n263 I1=n971 I2=n269 I3=n270
XU528 OAI112HS $PINS O=n616 A1=n739 B1=n842 C1=n210 C2=FE_DBTN229_n109
XU529 AOI22S $PINS O=n842 A1=n949 A2=n438 B1=FE_DBTN232_n4 B2=n357
XU530 MOAI1S $PINS O=n392 A1=n_idx[4] A2=n393 B1=n107 B2=FE_DBTN241_n355
XU531 AN4B1S $PINS O=n393 I1=n394 I2=n395 I3=n396 B1=n397
XU532 AOI22S $PINS O=n394 A1=FE_DBTN240_n83 A2=n981 B1=n967 B2=n982
XU533 NR3 $PINS O=n405 I1=n410 I2=n944 I3=n411
XU534 NR3 $PINS O=n406 I1=n409 I2=n952 I3=n973
XU535 AN4B1S $PINS O=n407 I1=n408 I2=n201 I3=n267 B1=n966
XU536 NR2 $PINS O=n191 I1=n964 I2=n976
XU537 OAI22S $PINS O=n489 A1=n490 A2=n246 B1=n161 B2=n491
XU538 AN4B1S $PINS O=n490 I1=n149 I2=n492 I3=n400 B1=n973
XU539 MOAI1S $PINS O=n481 A1=n_idx[4] A2=n482 B1=n483 B2=n484
XU540 AN4B1S $PINS O=n482 I1=n486 I2=n487 I3=n488 B1=n489
XU541 AOI22S $PINS O=n486 A1=n938 A2=n984 B1=n952 B2=n989
XU542 AN4B1S $PINS O=n498 I1=n331 I2=n499 I3=n500 B1=n953
XU543 AN4B1S $PINS O=n497 I1=n501 I2=n201 I3=n500 B1=FE_DBTN240_n83
XU544 MOAI1S $PINS O=n244 A1=n245 A2=n246 B1=n978 B2=n247
XU545 NR2 $PINS O=n245 I1=n952 I2=n249
XU546 MOAI1S $PINS O=n901 A1=n648 A2=n84 B1=n980 B2=n902
XU547 OA12 $PINS O=n903 A1=n878 B1=n_idx[4] B2=n253
XU548 NR3 $PINS O=n801 I1=n353 I2=n76 I3=n608
XU549 AN4B1S $PINS O=n805 I1=n54 I2=n597 I3=n724 B1=FE_DBTN232_n4
XU550 NR2 $PINS O=n499 I1=n269 I2=n593
XU551 ND3 $PINS O=n337 I1=n330 I2=n143 I3=n809
XU552 NR2 $PINS O=n809 I1=n362 I2=n260
XU553 ND3 $PINS O=n277 I1=n343 I2=n344 I3=n345
XU554 NR2 $PINS O=n344 I1=n359 I2=n360
XU555 AN4B1S $PINS O=n345 I1=n346 I2=n347 I3=n348 B1=n349
XU556 ND3 $PINS O=shift3[3] I1=n456 I2=n457 I3=n458
XU557 AN4B1S $PINS O=n458 I1=n459 I2=n460 I3=n461 B1=n462
XU558 AN4B1S $PINS O=n712 I1=n301 I2=n248 I3=n329 B1=n937
XU559 INV1S $PINS O=n777 I=n271
XU560 OAI22S $PINS O=n231 A1=n232 A2=n162 B1=n233 B2=n160
XU561 AN4B1S $PINS O=n232 I1=n236 I2=n943 I3=n237 B1=n238
XU562 AN4B1S $PINS O=n233 I1=n234 I2=n943 I3=n235 B1=FE_DBTN233_n747
XU563 ND3 $PINS O=n238 I1=n239 I2=n144 I3=n240
XU564 AN4B1S $PINS O=n893 I1=n4 I2=n942 I3=n221 B1=n896
XU565 AN4B1S $PINS O=n894 I1=n740 I2=n83 I3=n969 B1=n339
XU566 OA22 $PINS O=n909 A1=n_idx[4] A2=n911 B1=n216 B2=n611
XU567 AN4B1S $PINS O=n911 I1=n912 I2=n680 I3=n913 B1=n914
XU568 AOI22S $PINS O=n912 A1=n938 A2=n984 B1=n978 B2=n967
XU569 AOI22S $PINS O=n913 A1=n986 A2=n916 B1=n985 B2=n917
XU570 ND3 $PINS O=n590 I1=n268 I2=n252 I3=n336
XU571 ND3 $PINS O=n589 I1=n144 I2=n54 I3=n594
XU572 NR2 $PINS O=n212 I1=n221 I2=n_idx[4]
XU573 INV1S $PINS O=n221 I=n269
XU574 NR2 $PINS O=n646 I1=n81 I2=n82
XU575 OAI222S $PINS O=n81 A1=n152 A2=n84 B1=n188 B2=n120 C1=n5 C2=n452
XU576 OAI222S $PINS O=n82 A1=n80 A2=n215 B1=n361 B2=n111 C1=n115 C2=n479
XU577 ND3 $PINS O=n531 I1=n643 I2=n644 I3=n645
XU578 AOI22S $PINS O=n644 A1=n973 A2=n647 B1=n467 B2=n938
XU579 AOI22S $PINS O=n643 A1=FE_DBTN240_n83 A2=n440 B1=n424 B2=n92
XU580 ND3 $PINS O=n652 I1=n868 I2=n869 I3=n870
XU581 AN4B1S $PINS O=n870 I1=n871 I2=n475 I3=n818 B1=n532
XU582 OAI22S $PINS O=n397 A1=n398 A2=n264 B1=n399 B2=n246
XU583 AN4B1S $PINS O=n399 I1=n400 I2=n201 I3=n199 B1=n960
XU584 AN4B1S $PINS O=n398 I1=n258 I2=n272 I3=n268 B1=n269
XU585 NR3 $PINS O=n651 I1=n681 I2=n682 I3=n683
XU586 ND3 $PINS O=n682 I1=n533 I2=n692 I3=n576
XU587 ND3 $PINS O=n683 I1=n684 I2=n685 I3=n686
XU588 OAI112HS $PINS O=n681 A1=n471 B1=n695 C1=n122 C2=n264
XU589 AN4B1S $PINS O=n520 I1=n234 I2=n4 I3=n426 B1=n939
XU590 INV1S $PINS O=n973 I=n143
XU591 OR2 $PINS O=n83 I1=n198 I2=FE_DBTN248_fold_n_0
XU593 OAI112HS $PINS O=n532 A1=n820 B1=n872 C1=n85 C2=FE_OFN160_n253
XU594 OA22 $PINS O=n872 A1=n130 A2=n806 B1=FE_DBTN238_n440 B2=n356
XU595 AN4B1S $PINS O=n133 I1=n134 I2=n135 I3=n136 B1=n137
XU596 AN4B1S $PINS O=n132 I1=n183 I2=n184 I3=n185 B1=n186
XU597 NR2P $PINS O=n218 I1=n171 I2=FE_DBTN247_n147
XU598 INV2 $PINS O=n938 I=n236
XU599 NR3 $PINS O=n321 I1=n328 I2=n950 I3=n940
XU600 INV1S $PINS O=n968 I=n329
XU601 OAI112HS $PINS O=n530 A1=n865 B1=n866 C1=n864 C2=n503
XU602 NR2 $PINS O=n864 I1=n218 I2=FE_DBTN235_n84
XU603 NR2 $PINS O=n340 I1=n171 I2=FE_DBTN248_fold_n_0
XU604 MOAI1S $PINS O=n848 A1=n_idx[4] A2=n849 B1=n988 B2=n212
XU605 AN4B1S $PINS O=n849 I1=n850 I2=n851 I3=n852 B1=n853
XU606 AOI22S $PINS O=n850 A1=n985 A2=n861 B1=n982 B2=n862
XU607 AN4B1S $PINS O=n852 I1=n856 I2=n332 I3=n857 B1=n858
XU608 NR2 $PINS O=n851 I1=n859 I2=n860
XU609 MOAI1S $PINS O=n860 A1=n257 A2=n177 B1=n159 B2=n967
XU610 OAI22S $PINS O=n859 A1=n239 A2=n150 B1=n800 B2=n254
XU611 AN4B1S $PINS O=n552 I1=n258 I2=n329 I3=n325 B1=n939
XU612 INV1S $PINS O=n619 I=n327
XU613 ND3 $PINS O=n622 I1=n733 I2=n734 I3=n735
XU614 OA22 $PINS O=n733 A1=n452 A2=n626 B1=n369 B2=n129
XU615 MAOI1 $PINS O=n734 A1=FE_DBTN242_n85 A2=n738 B1=n361 B2=n625
XU616 OR2 $PINS O=n84 I1=FE_DBTN247_n147 I2=n168
XU618 ND3 $PINS O=n299 I1=n84 I2=n111 I3=n302
XU619 INV1S $PINS O=n942 I=n904
XU620 ND3 $PINS O=n249 I1=n369 I2=n143 I3=n408
XU621 NR2 $PINS O=n324 I1=FE_DBTN232_n4 I2=n593
XU622 OAI22S $PINS O=n853 A1=n854 A2=n139 B1=n855 B2=n465
XU623 NR2 $PINS O=n855 I1=n983 I2=n159
XU624 AN2 $PINS O=n854 I1=n54 I2=n400
XU625 AN4B1S $PINS O=n807 I1=n747 I2=n253 I3=n240 B1=n419
XU626 INV1S $PINS O=n338 I=n337
XU627 AN4B1S $PINS O=n808 I1=n671 I2=n271 I3=n325 B1=n362
XU628 OAI222S $PINS O=n666 A1=n668 A2=FE_DBTN243_n297 B1=n669
+ B2=FE_DBTN238_n440 C1=n199 C2=n118
XU629 AN4B1S $PINS O=n668 I1=n408 I2=n4 I3=n553 B1=n940
XU630 NR3 $PINS O=n669 I1=n670 I2=n370 I3=n944
XU631 MOAI1S $PINS O=n423 A1=n115 A2=FE_DBTN230_n6 B1=n424 B2=n425
XU632 INV1S $PINS O=n967 I=n199
XU633 INV1S $PINS O=n941 I=n237
XU634 AN2 $PINS O=n402 I1=n236 I2=n404
XU635 MOAI1S $PINS O=n477 A1=n786 A2=n648 B1=n787 B2=FE_DBTN246_n189
XU636 NR2 $PINS O=n786 I1=n437 I2=n225
XU637 NR2 $PINS O=n147 I1=FE_DBTN248_fold_n_0 I2=n_idx[4]
XU638 MOAI1S $PINS O=n524 A1=n525 A2=n355 B1=n526 B2=n981
XU639 NR2 $PINS O=n437 I1=FE_DBTN247_n147 I2=n198
XU640 OAI222S $PINS O=n512 A1=n273 A2=n118 B1=n_idx[4] B2=n513 C1=n514 C2=n219
XU641 AN4B1S $PINS O=n514 I1=n515 I2=n401 I3=n271 B1=n362
XU642 NR2 $PINS O=n517 I1=n949 I2=FE_DBTN232_n4
XU643 AOI22S $PINS O=n656 A1=n467 A2=n662 B1=n358 B2=n663
XU644 ND3 $PINS O=n663 I1=n664 I2=n501 I3=n665
XU645 ND3 $PINS O=n662 I1=n272 I2=n267 I3=n401
XU646 NR2 $PINS O=n665 I1=n269 I2=n949
XU647 OAI222S $PINS O=n838 A1=n85 A2=n465 B1=n363 B2=n611 C1=n115 C2=n452
XU648 OAI222S $PINS O=n422 A1=n428 A2=n166 B1=n302 B2=n188 C1=n429
+ C2=FE_DBTN243_n297
XU649 AN4B1S $PINS O=n429 I1=n252 I2=n236 I3=n430 B1=n944
XU650 NR2 $PINS O=n178 I1=n269 I2=n92
XU651 OAI222S $PINS O=n718 A1=n719 A2=FE_DBTN243_n297 B1=n216 B2=n215 C1=n720
+ C2=n166
XU652 NR3 $PINS O=n719 I1=n519 I2=n777 I3=n934
XU653 MOAI1S $PINS O=n812 A1=n813 A2=FE_DBTN243_n297 B1=n110 B2=n1006
XU654 NR3 $PINS O=n813 I1=n814 I2=n936 I3=n298
XU655 INV1S $PINS O=n963 I=n182
XU656 NR2 $PINS O=n567 I1=FE_DBTN248_fold_n_0 I2=n170
XU657 NR2 $PINS O=n921 I1=FE_DBTN244_n215 I2=FE_DBTN246_n189
XU658 NR2 $PINS O=n922 I1=n1007 I2=n994
XU659 NR2 $PINS O=n920 I1=n109 I2=FE_DBTN235_n84
XU660 OA22 $PINS O=n785 A1=n929 A2=n152 B1=n355 B2=n930
XU661 NR2 $PINS O=n929 I1=FE_DBTN235_n84 I2=n787
XU662 NR2 $PINS O=n303 I1=FE_DBTN244_n215 I2=FE_DBTN245_n210
XU663 NR2 $PINS O=n438 I1=n254 I2=n_idx[4]
XU664 OAI222S $PINS O=n450 A1=n415 A2=n80 B1=n354 B2=n5 C1=n129 C2=n236
XU665 AN4B1S $PINS O=n446 I1=n447 I2=n448 I3=n449 B1=n450
XU666 OR2 $PINS O=n688 I1=n479 I2=n363
XU667 AOI22S $PINS O=n348 A1=n76 A2=n352 B1=FE_DBTN245_n210 B2=n353
XU668 MOAI1S $PINS O=n359 A1=n363 A2=n152 B1=n105 B2=n1003
XU669 AN4B1S $PINS O=n711 I1=n199 I2=n426 I3=n144 B1=n519
XU670 OAI222S $PINS O=n925 A1=n363 A2=n505 B1=n485 B2=FE_DBTN237_n483 C1=n302
+ C2=n173
XU671 OR2 $PINS O=n85 I1=n139 I2=n_idx[4]
XU673 OAI112HS $PINS O=n819 A1=n736 B1=n820 C1=n166 C2=n84
XU674 INV1S $PINS O=n957 I=n593
XU675 AOI22S $PINS O=n696 A1=n437 A2=n994 B1=n109 B2=n1002
XU676 AOI22S $PINS O=n697 A1=FE_DBTN245_n210 A2=n76 B1=n6 B2=FE_DBTN239_n80
XU677 OA22 $PINS O=n208 A1=n214 A2=n215 B1=n216 B2=n217
XU678 NR2 $PINS O=n217 I1=n1006 I2=n1003
XU679 NR2 $PINS O=n214 I1=n218 I2=n107
XU680 OAI22S $PINS O=n858 A1=n316 A2=n160 B1=n331 B2=n262
XU681 NR2 $PINS O=n687 I1=n777 I2=n973
XU682 MAOI1 $PINS O=n689 A1=n952 A2=n690 B1=n464 B2=n691
XU683 ND3 $PINS O=n710 I1=n170 I2=n961 I3=n171
XU684 OR2 $PINS O=n448 I1=n478 I2=n611
XU685 NR2 $PINS O=n568 I1=n175 I2=n_idx[4]
XU686 AOI22S $PINS O=n613 A1=FE_DBTN235_n84 A2=n615 B1=n938 B2=FE_DBTN242_n85
XU687 AOI22S $PINS O=n612 A1=FE_DBTN236_n505 A2=FE_DBTN239_n80 B1=n993 B2=n113
XU688 AOI22S $PINS O=n562 A1=FE_DBTN239_n80 A2=FE_DBTN245_n210 B1=n218 B2=n1002
XU689 AOI22S $PINS O=n563 A1=n358 A2=n564 B1=n297 B2=n565
XU690 AOI22S $PINS O=n570 A1=n424 A2=n971 B1=n297 B2=n938
XU691 NR2 $PINS O=n172 I1=n181 I2=n182
XU692 AN2 $PINS O=n176 I1=n947 I2=n178
XU693 NR2 $PINS O=n174 I1=n179 I2=n180
XU694 AN4B1S $PINS O=n759 I1=n760 I2=n452 I3=n761 B1=n154
XU695 MOAI1S $PINS O=n209 A1=n210 A2=n211 B1=n212 B2=n163
XU696 OAI222S $PINS O=n831 A1=n155 A2=n428 B1=n626 B2=n210 C1=n200 C2=n91
XU697 NR2 $PINS O=n806 I1=n972 I2=n593
XU698 ND3 $PINS O=n762 I1=n931 I2=n168 I3=n932
XU699 NR2 $PINS O=n931 I1=n179 I2=n620
XU700 OAI22S $PINS O=n677 A1=n_idx[4] A2=n680 B1=n607 B2=n118
XU701 NR2 $PINS O=n357 I1=n177 I2=n_idx[4]
XU702 OA22 $PINS O=n228 A1=n175 A2=n268 B1=n202 B2=n273
XU703 AOI22S $PINS O=n694 A1=n647 A2=n952 B1=n424 B2=n968
XU704 INV1S $PINS O=n620 I=n170
XU705 MOAI1S $PINS O=n839 A1=n189 A2=n307 B1=n218 B2=n997
XU706 MOAI1S $PINS O=n667 A1=n215 A2=n307 B1=n979 B2=n212
XU707 OA22 $PINS O=n856 A1=n329 A2=n162 B1=n356 B2=n213
XU708 INV1S $PINS O=n983 I=n266
XU709 AN4B1S $PINS O=n145 I1=n156 I2=n157 I3=n158 B1=n159
XU710 AN4B1S $PINS O=n148 I1=n151 I2=n152 I3=n153 B1=n154
XU711 AN4B1S $PINS O=n158 I1=n160 I2=n161 I3=n162 B1=n987
XU712 MOAI1S $PINS O=n360 A1=n361 A2=FE_DBTN229_n109 B1=FE_DBTN231_n5 B2=n1006
XU713 MOAI1S $PINS O=n560 A1=n210 A2=n90 B1=n1005 B2=FE_DBTN231_n5
XU714 OA22 $PINS O=n658 A1=n464 A2=n51 B1=n143 B2=n300
XU715 NR2 $PINS O=n483 I1=n162 I2=n_idx[4]
XU716 NR2 $PINS O=n467 I1=n262 I2=n_idx[4]
XU717 OAI222S $PINS O=n810 A1=n361 A2=FE_DBTN229_n109 B1=n80 B2=n215 C1=n611
+ C2=n5
XU718 NR2 $PINS O=n424 I1=n160 I2=n_idx[4]
XU719 NR2 $PINS O=n440 I1=n495 I2=n_idx[4]
XU720 NR2 $PINS O=n888 I1=n283 I2=k_idx[2]
XU721 NR2 $PINS O=n297 I1=n150 I2=n_idx[4]
XU722 MOAI1S $PINS O=n727 A1=n189 A2=n307 B1=n437 B2=FE_DBTN236_n505
XU723 INV1S $PINS O=n985 I=n264
XU724 OAI222S $PINS O=n900 A1=n611 A2=n80 B1=n361 B2=n111 C1=n189 C2=n90
XU726 INV1S $PINS O=n988 I=n177
XU727 MOAI1S $PINS O=n847 A1=n503 A2=n302 B1=n993 B2=n218
XU734 NR2 $PINS O=n358 I1=n202 I2=n_idx[4]
XU735 ND2 $PINS O=n188 I1=n385 I2=n372
XU738 ND2 $PINS O=n262 I1=n891 I2=n385
XU792 INV1S $PINS O=n989 I=n254
XU800 MOAI1S $PINS O=n642 A1=n648 A2=FE_DBTN229_n109 B1=n993 B2=n437
XU804 INV1S $PINS O=n987 I=n150
XU805 NR2 $PINS O=n647 I1=n266 I2=n_idx[4]
XU822 INV1S $PINS O=n1006 I=n452
XU829 MOAI1S $PINS O=n638 A1=n5 A2=n603 B1=n972 B2=n639
XU830 INV1S $PINS O=n986 I=n246
XU831 NR2 $PINS O=n220 I1=n213 I2=n_idx[4]
XU833 AN2 $PINS O=n165 I1=n171 I2=n964
XU834 INV1S $PINS O=n984 I=n202
XU840 ND2 $PINS O=n161 I1=n385 I2=n923
XU844 INV1S $PINS O=n1008 I=n835
XU880 AN2 $PINS O=n895 I1=n933 I2=n101
XU884 NR2 $PINS O=n933 I1=k_idx[4] I2=k_idx[2]
XU888 ND3 $PINS O=n164 I1=n266 I2=n262 I3=n264
XU893 NR2 $PINS O=n867 I1=n376 I2=k_idx[2]
XU896 NR2 $PINS O=n146 I1=n_idx[4] I2=n374
XU897 ND2 $PINS O=n213 I1=n873 I2=n385
XU903 INV1S $PINS O=n1005 I=n361
XU904 INV1S $PINS O=n1002 I=n611
XU906 INV1S $PINS O=n1007 I=n166
XU910 ND3 $PINS O=n154 I1=FE_DBTN230_n6 I2=n210 I3=n443
XU911 INV1S $PINS O=n1004 I=n152
XU913 INV1S $PINS O=n993 I=n173
XU914 INV1S $PINS O=n997 I=n479
XU915 INV1S $PINS O=n1003 I=n503
XU916 AN2 $PINS O=n891 I1=n928 I2=n101
XU917 INV1S $PINS O=n962 I=n374
XU918 AOI22S $PINS O=n379 A1=n141 A2=n372 B1=n980 B2=n976
XU919 INV1S $PINS O=n977 I=n385
XU926 INV1S $PINS O=n1011 I=n283
XU928 OAI12HS $PINS O=n279 A1=n376 B1=k_idx[4] B2=n101
XU929 NR2 $PINS O=n285 I1=n975 I2=n956
XU931 NR2 $PINS O=n141 I1=n_idx[1] I2=n_idx[0]
XU932 AOI22S $PINS O=n751 A1=n763 A2=n98 B1=n105 B2=n994
XU933 ND3 $PINS O=n763 I1=n764 I2=n765 I3=n766
XU935 NR2 $PINS O=n766 I1=n767 I2=n768
XU940 ND3 $PINS O=sign2[0] I1=n289 I2=n290 I3=n291
XU942 AN4B1S $PINS O=n291 I1=n292 I2=n293 I3=n294 B1=n295
XU944 AN4B1S $PINS O=n289 I1=n108 I2=n341 I3=n342 B1=n277
XU947 NR2 $PINS O=n918 I1=n976 I2=FE_OCPN371_fold_n_0
XU948 INV1S $PINS O=n976 I=n_idx[1]
XU954 ND2 $PINS O=n253 I1=n918 I2=n897
XU955 ND3 $PINS O=sign3[0] I1=n203 I2=n204 I3=n205
XU956 AN4B1S $PINS O=n205 I1=n206 I2=n207 I3=n208 B1=n209
XU957 AN4B1S $PINS O=n203 I1=n274 I2=n275 I3=n276 B1=n277
XU958 ND3 $PINS O=n543 I1=n143 I2=n356 I3=n544
XU959 NR2 $PINS O=n193 I1=FE_DBTN248_fold_n_0 I2=n_idx[1]
XU961 ND3 $PINS O=sign1[0] I1=n386 I2=n387 I3=n388
XU962 NR2 $PINS O=n387 I1=n422 I2=n423
XU963 AN4B1S $PINS O=n386 I1=n364 I2=n431 I3=n276 B1=n367
XU964 INV1S $PINS O=n964 I=n375
XU965 NR2 $PINS O=n269 I1=n168 I2=FE_OCPN371_fold_n_0
XU966 NR2 $PINS O=n709 I1=n592 I2=n948
XU967 ND2 $PINS O=n143 I1=n193 I2=n897
XU968 NR2 $PINS O=n593 I1=n961 I2=FE_OCPN371_fold_n_0
XU969 OAI222S $PINS O=n186 A1=n187 A2=n188 B1=n942 B2=n189 C1=n171 C2=n152
XU970 AN4B1S $PINS O=n187 I1=n91 I2=n122 I3=n190 B1=n191
XU971 AOI22S $PINS O=n190 A1=n192 A2=n956 B1=n_idx[4] B2=n964
XU972 OR2 $PINS O=n192 I1=n193 I2=n194
XU973 ND2 $PINS O=n236 I1=n193 I2=n919
XU974 NR2 $PINS O=n904 I1=n947 I2=n_idx[1]
XU975 ND2 $PINS O=n199 I1=n375 I2=n193
XU977 NR2 $PINS O=n182 I1=n964 I2=n_idx[1]
XU978 NR2 $PINS O=n374 I1=n963 I2=n_idx[0]
XU980 OAI112HS $PINS O=n447 A1=n98 B1=n978 C1=n967 C2=FE_DBTN232_n4
XU981 NR2 $PINS O=n372 I1=n100 I2=n283
XU982 OAI12HS $PINS O=sign2[1] A1=n280 B1=n278 B2=n279
XU983 AOI22S $PINS O=n278 A1=n281 A2=n1011 B1=n282 B2=n283
XU984 NR2 $PINS O=n281 I1=n_idx[4] I2=n286
XU985 MOAI1S $PINS O=n282 A1=k_idx[2] A2=n284 B1=_rom_k_idx_1_1 B2=n195
XU986 NR2 $PINS O=n194 I1=n_idx[4] I2=n_idx[0]
XU990 MOAI1S $PINS O=n137 A1=n138 A2=n139 B1=n989 B2=n140
XU991 AN4B1S $PINS O=n138 I1=n964 I2=n98 I3=n144 B1=n974
XU992 ND3 $PINS O=n142 I1=n964 I2=n98 I3=n143
XU993 ND2 $PINS O=n264 I1=n892 I2=n923
XU994 ND2 $PINS O=n246 I1=n867 I2=n892
XU995 ND2 $PINS O=n202 I1=n891 I2=n892
XU996 INV1S $PINS O=n101 I=k_idx[3]
XU998 AN2 $PINS O=n923 I1=n928 I2=k_idx[3]
XU999 NR2 $PINS O=n928 I1=n100 I2=k_idx[4]
XU1000 ND2 $PINS O=n361 I1=n923 I2=n874
XU1001 ND2 $PINS O=n166 I1=n372 I2=n874
XU1002 AOI12HS $PINS O=n382 A1=n179 B1=n384 B2=n181
XU1003 ND2 $PINS O=n152 I1=n891 I2=n874
XU1004 AN2 $PINS O=n873 I1=n933 I2=k_idx[3]
XU1005 NR2 $PINS O=n875 I1=n376 I2=n100
XU1006 NR2 $PINS O=n181 I1=n976 I2=n956
XU1007 AOI13HS $PINS O=n284 A1=n285 B1=n_idx[0] B2=_rom_k_idx_1_1 B3=n181
XU1008 INV1S $PINS O=n991 I=n384
XU1009 NR2 $PINS O=n919 I1=n956 I2=n_idx[2]
XU1011 NR2 $PINS O=n897 I1=n975 I2=n_idx[3]
XU1012 NR2 $PINS O=n375 I1=n_idx[3] I2=n_idx[2]
XU1013 NR2 $PINS O=n892 I1=n990 I2=k_idx[1]
XU1014 INV1S $PINS O=n990 I=k_idx[0]
XU1017 NR2 $PINS O=n384 I1=k_idx[1] I2=k_idx[0]
XU1018 OAI12HS $PINS O=sign1[1] A1=n280 B1=n368 B2=n279
XU1019 AOI22S $PINS O=n368 A1=n377 A2=n283 B1=n378 B2=n98
XU1020 OAI112HS $PINS O=n378 A1=n380 B1=n962 C1=n_idx[3] C2=n379
XU1021 OAI222S $PINS O=n377 A1=k_idx[2] A2=n382 B1=n947 B2=n383 C1=n991 C2=n946
XU1022 INV1S $PINS O=n100 I=k_idx[2]
XU1023 NR2 $PINS O=n280 I1=n86 I2=n87
XU1024 OAI22S $PINS O=n86 A1=k_idx[0] A2=n_idx[0] B1=n146 B2=n1011
XU1025 AO13S $PINS O=n87 A1=n373 B1=n371 B2=n98 B3=n372
XU1026 AOI13HS $PINS O=n373 A1=n98 B1=k_idx[2] B2=k_idx[1] B3=n374
XU1027 AOI22S $PINS O=n287 A1=k_idx[2] A2=n288 B1=n141 B2=k_idx[1]
XU1028 MOAI1S $PINS O=n288 A1=n_idx[1] A2=n990 B1=FE_DBTN248_fold_n_0
+ B2=k_idx[1]
XU1029 ND3 $PINS O=n380 I1=k_idx[1] I2=n381 I3=n1011
XU1030 MOAI1S $PINS O=n381 A1=n990 A2=n963 B1=FE_DBTN248_fold_n_0 B2=n375
XU1031 INV1S $PINS O=n98 I=n_idx[4]
XU85 NR2 $PINS O=n109 I1=FE_DBTN247_n147 I2=n170
.ENDS

.SUBCKT SNPS_CLOCK_GATE_HIGH_ROM_Wrapper_Odd_1 EN ENCLK CLK
*.CONNECT net2324 EN
XFE_PHC870_net2327 DELC $PINS O=FE_PHN870_net2327 I=net2327
Xlatch QDBHN $PINS Q=net2327 D=net2324 CKB=CLK
Xmain_gate AN2 $PINS O=ENCLK I1=FE_PHN870_net2327 I2=CLK
.ENDS

.SUBCKT ROM_Wrapper_Odd_1 rst_n en n_in[4] n_in[3] n_in[2] n_in[1] n_in[0]
+ k_idx[4] k_idx[3] k_idx[2] k_idx[1] k_idx[0] reg_sign1[1] reg_sign1[0]
+ reg_sign2[1] reg_sign2[0] reg_sign3[1] reg_sign3[0] reg_shift1[3]
+ reg_shift1[2] reg_shift1[1] reg_shift1[0] reg_shift2[3] reg_shift2[2]
+ reg_shift2[1] reg_shift2[0] reg_shift3[3] reg_shift3[2] reg_shift3[1]
+ reg_shift3[0] _rom_k_idx_1_1 i_rst_n FE_OFN86_n clk
*.CONNECT N4 n_in[0]
XCTS_ccl_a_INV_CLK_G1_L8_39 INV4CK $PINS O=CTS_19 I=CTS_20
XCTS_cdb_INV_CLK_G1_L7_39 INV2CK $PINS O=CTS_20 I=CTS_21
XCTS_cdb_INV_CLK_G1_L6_3 INV1CK $PINS O=CTS_21 I=CTS_22
XCTS_ccl_a_INV_CLK_G1_L6_2 INV1CK $PINS O=CTS_18 I=CTS_22
XCTS_ccl_INV_CLK_G1_L5_5 INV1CK $PINS O=CTS_22 I=CTS_23
XFE_OFC136_N2 INV1S $PINS O=n1 I=N2
Xreg_sign1_reg[1] DFFSBN $PINS Q=reg_sign1[1] D=raw_s1[1] CK=CTS_19 SB=i_rst_n
Xreg_sign2_reg[1] DFFSBN $PINS Q=reg_sign2[1] D=raw_s2[1] CK=CTS_19 SB=i_rst_n
Xreg_sign3_reg[1] DFFSBN $PINS Q=reg_sign3[1] D=raw_s3[1] CK=CTS_19 SB=i_rst_n
Xreg_shift1_reg[3] QDFFRBP $PINS Q=reg_shift1[3] D=raw_h1[3] CK=CTS_19
+ RB=i_rst_n
Xreg_sign2_reg[0] QDFFRBN $PINS Q=reg_sign2[0] D=final_s2[0] CK=CTS_19
+ RB=i_rst_n
Xreg_sign3_reg[0] QDFFRBN $PINS Q=reg_sign3[0] D=final_s3[0] CK=CTS_19
+ RB=i_rst_n
Xreg_sign1_reg[0] QDFFRBN $PINS Q=reg_sign1[0] D=final_s1[0] CK=CTS_19
+ RB=i_rst_n
Xreg_shift3_reg[1] QDFFRBN $PINS Q=reg_shift3[1] D=raw_h3[1] CK=CTS_19
+ RB=i_rst_n
Xreg_shift1_reg[1] QDFFRBP $PINS Q=reg_shift1[1] D=raw_h1[1] CK=CTS_19
+ RB=i_rst_n
Xreg_shift2_reg[1] QDFFRBN $PINS Q=reg_shift2[1] D=raw_h2[1] CK=CTS_19
+ RB=i_rst_n
Xreg_shift3_reg[0] QDFFRBT $PINS Q=reg_shift3[0] D=raw_h3[0] CK=CTS_19
+ RB=i_rst_n
Xreg_shift2_reg[0] QDFFRBP $PINS Q=reg_shift2[0] D=raw_h2[0] CK=CTS_19
+ RB=i_rst_n
Xreg_shift2_reg[3] QDFFRBP $PINS Q=reg_shift2[3] D=raw_h2[3] CK=CTS_18
+ RB=i_rst_n
Xreg_shift1_reg[0] QDFFRBN $PINS Q=reg_shift1[0] D=raw_h1[0] CK=CTS_19
+ RB=i_rst_n
Xreg_shift1_reg[2] QDFFRBN $PINS Q=reg_shift1[2] D=raw_h1[2] CK=CTS_19
+ RB=i_rst_n
Xreg_shift3_reg[3] QDFFRBN $PINS Q=reg_shift3[3] D=raw_h3[3] CK=CTS_19
+ RB=i_rst_n
Xreg_shift3_reg[2] QDFFRBP $PINS Q=reg_shift3[2] D=raw_h3[2] CK=CTS_19
+ RB=i_rst_n
Xreg_shift2_reg[2] QDFFRBP $PINS Q=reg_shift2[2] D=raw_h2[2] CK=CTS_19
+ RB=i_rst_n
XU4 MOAI1 $PINS O=fold_n[3] A1=n9 A2=N2 B1=N7 B2=N2
XU5 NR2 $PINS O=sub_17/carry[2] I1=N4 I2=n_in[1]
XU6 MUX2 $PINS O=fold_n[4] S=N2 A=n_in[4] B=N8
XU7 ND3S $PINS O=n10 I1=N2 I2=n11 I3=k_idx[0]
XU8 ND2S $PINS O=n3 I1=sub_17/carry[3] I2=n9
XU12 XNR2HS $PINS O=final_s2[0] I1=raw_s2[0] I2=n10
XU13 XNR2HS $PINS O=final_s3[0] I1=raw_s3[0] I2=n10
XU14 XNR2HS $PINS O=final_s1[0] I1=raw_s1[0] I2=n10
XU15 INV1S $PINS O=n15 I=N4
XU16 MOAI1 $PINS O=fold_n[0] A1=n15 A2=N2 B1=N4 B2=N2
XU17 INV1S $PINS O=n13 I=n_in[1]
XU18 ND3 $PINS O=n11 I1=k_idx[4] I2=k_idx[3] I3=n12
XU19 AN2 $PINS O=n12 I1=k_idx[2] I2=k_idx[1]
XU21 OA13 $PINS O=N2 A1=n_in[4] B1=n_in[1] B2=N4 B3=n16
XU22 MOAI1S $PINS O=fold_n[2] A1=n2 A2=n1 B1=FE_OFN86_n B2=n1
XU24 XNR2HS $PINS O=n2 I1=n14 I2=sub_17/carry[2]
XU25 INV1S $PINS O=n14 I=FE_OFN86_n
XU26 INV1S $PINS O=n9 I=n_in[3]
XU27 XOR2HS $PINS O=N8 I1=n_in[4] I2=n3
XU29 XOR2HS $PINS O=N7 I1=n9 I2=sub_17/carry[3]
XU30 AN2 $PINS O=sub_17/carry[3] I1=sub_17/carry[2] I2=n14
XU31 XOR2HS $PINS O=N5 I1=n13 I2=n15
XU32 OR2 $PINS O=n16 I1=n_in[3] I2=n_in[2]
Xrom_inst CSD_ROM_Table_odd_1 $PINS n_idx[4]=fold_n[4] n_idx[3]=fold_n[3]
+ n_idx[2]=fold_n[2] n_idx[1]=fold_n[1] n_idx[0]=fold_n[0] k_idx[4]=k_idx[4]
+ k_idx[3]=k_idx[3] k_idx[2]=k_idx[2] k_idx[1]=k_idx[1] k_idx[0]=k_idx[0]
+ sign1[1]=raw_s1[1] sign1[0]=raw_s1[0] shift1[3]=raw_h1[3] shift1[2]=raw_h1[2]
+ shift1[1]=raw_h1[1] shift1[0]=raw_h1[0] sign2[1]=raw_s2[1] sign2[0]=raw_s2[0]
+ shift2[3]=raw_h2[3] shift2[2]=raw_h2[2] shift2[1]=raw_h2[1] shift2[0]=raw_h2[0]
+ sign3[1]=raw_s3[1] sign3[0]=raw_s3[0] shift3[3]=raw_h3[3] shift3[2]=raw_h3[2]
+ shift3[1]=raw_h3[1] shift3[0]=raw_h3[0] _rom_k_idx_1_1=_rom_k_idx_1_1
Xclk_gate_reg_shift1_reg SNPS_CLOCK_GATE_HIGH_ROM_Wrapper_Odd_1 $PINS EN=en
+ ENCLK=CTS_23 CLK=clk
XU3 MOAI1 $PINS O=fold_n[1] A1=n13 A2=N2 B1=N5 B2=N2
.ENDS

.SUBCKT CSD_ROM_Table_even_0 n_idx[4] n_idx[3] n_idx[2] n_idx[1] n_idx[0]
+ k_idx[4] k_idx[3] k_idx[2] k_idx[1] k_idx[0] sign1[1] sign1[0] shift1[3]
+ shift1[2] shift1[1] shift1[0] sign2[1] sign2[0] shift2[3] shift2[2] shift2[1]
+ shift2[0] sign3[1] sign3[0] shift3[3] shift3[2] shift3[1] shift3[0]
+ _rom_k_idx_3_1
XFE_OFC125_fold_n_0 INV1S $PINS O=FE_OFN110_fold_n_0 I=n1043
XFE_OFC124_fold_n_0 INV2 $PINS O=n1043 I=n_idx[0]
XFE_DBTC228_fold_n_2 INV1S $PINS O=FE_DBTN228_fold_n_2 I=n_idx[2]
XFE_DBTC227_n1 INV1S $PINS O=FE_DBTN227_n1 I=n1
XFE_DBTC226_n2 INV1S $PINS O=FE_DBTN226_n2 I=n2
XFE_DBTC225_n3 INV1S $PINS O=FE_DBTN225_n3 I=n3
XFE_DBTC224_n5 INV1S $PINS O=FE_DBTN224_n5 I=n5
XFE_DBTC223_n6 INV1S $PINS O=FE_DBTN223_n6 I=n6
XFE_DBTC222_n7 INV1S $PINS O=FE_DBTN222_n7 I=n7
XFE_DBTC221_n93 INV1S $PINS O=FE_DBTN221_n93 I=n93
XFE_DBTC220_n1754 INV1S $PINS O=FE_DBTN220_n1754 I=n1754
XFE_DBTC219_n1475 INV1S $PINS O=FE_DBTN219_n1475 I=n1475
XFE_DBTC218_n1108 INV1S $PINS O=FE_DBTN218_n1108 I=n1108
XFE_DBTC217_n1392 INV1S $PINS O=FE_DBTN217_n1392 I=n1392
XFE_DBTC216_n87 INV1S $PINS O=FE_DBTN216_n87 I=n87
XFE_DBTC215_n1729 INV1S $PINS O=FE_DBTN215_n1729 I=n1729
XFE_DBTC214_n1831 INV1S $PINS O=FE_DBTN214_n1831 I=n1831
XFE_DBTC213_n94 INV1S $PINS O=FE_DBTN213_n94 I=n94
XFE_DBTC212_n1417 INV1S $PINS O=FE_DBTN212_n1417 I=n1417
XFE_DBTC211_n1732 INV1S $PINS O=FE_DBTN211_n1732 I=n1732
XFE_DBTC210_n1878 INV1S $PINS O=FE_DBTN210_n1878 I=n1878
XFE_DBTC209_n92 INV1S $PINS O=FE_DBTN209_n92 I=n92
XU776 OA222 $PINS O=n1905 A1=n1897 A2=n1030 B1=n1896 B2=FE_DBTN222_n7 C1=n1895
+ C2=n1894
XU777 OR3B2 $PINS O=n1886 I1=n1885 B1=n1884 B2=n1883
XU778 ND2 $PINS O=n1882 I1=n138 I2=n1043
XU779 AO12 $PINS O=n1872 A1=n1869 B1=n1042 B2=n1870
XU780 AO112 $PINS O=n1864 A1=n_idx[4] B1=n1862 C1=n1863 C2=n_idx[3]
XU781 AN3B1 $PINS O=n1897 I1=n1855 I2=n1854 B1=n1853
XU782 OA222 $PINS O=n1827 A1=n1826 A2=n1887 B1=n1825 B2=n1824 C1=n1823 C2=n1822
XU783 ND2 $PINS O=n1820 I1=n1818 I2=n1817
XU784 ND2 $PINS O=n1821 I1=n1816 I2=n1815
XU785 ND2 $PINS O=n1813 I1=n1812 I2=n1021
XU786 ND2 $PINS O=n1814 I1=n1875 I2=n1811
XU787 AN3B2S $PINS O=n1806 I1=n1804 B1=n1803 B2=n1802
XU788 AN3 $PINS O=n1797 I1=n1796 I2=n1795 I3=n1832
XU789 OR3B2 $PINS O=n1794 I1=n1790 B1=n1789 B2=n133
XU790 AN3 $PINS O=n1787 I1=n1784 I2=n1783 I3=n1782
XU791 AO12 $PINS O=sign2[1] A1=n1779 B1=n1781 B2=n1780
XU792 AO222 $PINS O=n1780 A1=n1778 A2=n1069 B1=n1777 B2=n1776 C1=n1775 C2=n1774
XU793 AO12 $PINS O=n1767 A1=k_idx[0] B1=n1043 B2=k_idx[2]
XU794 ND2 $PINS O=n1748 I1=n1744 I2=FE_DBTN224_n5
XU795 AO12 $PINS O=n1752 A1=FE_DBTN213_n94 B1=n1743 B2=n1830
XU796 OA222 $PINS O=n1739 A1=n1738 A2=n1835 B1=n1737 B2=n1736 C1=n1735
+ C2=FE_DBTN222_n7
XU797 ND2 $PINS O=n1704 I1=n1016 I2=FE_DBTN210_n1878
XU798 AO12 $PINS O=sign1[1] A1=n1779 B1=n1781 B2=n1701
XU799 ND2 $PINS O=n1871 I1=n_idx[4] I2=n1029
XU800 AN3 $PINS O=n1700 I1=n1699 I2=n1043 I3=n1698
XU801 OR3 $PINS O=n1699 I1=n1773 I2=n138 I3=n_idx[1]
XU802 ND2 $PINS O=n1692 I1=n1061 I2=n1773
XU803 ND2 $PINS O=n1773 I1=n1769 I2=k_idx[2]
XU804 OA222 $PINS O=n1681 A1=n1674 A2=n1822 B1=n1673 B2=n1709 C1=n1672 C2=n1805
XU805 OA222 $PINS O=n1682 A1=n1668 A2=n1878 B1=n1667 B2=n1666 C1=n1665 C2=n1664
XU806 OA222 $PINS O=n1683 A1=FE_DBTN215_n1729 A2=n1032 B1=FE_DBTN212_n1417
+ B2=n1027 C1=n1011 C2=n1815
XU807 ND2 $PINS O=n1785 I1=n1644 I2=n1643
XU810 OA112 $PINS O=n1788 A1=n1633 B1=n1632 C1=n1011 C2=n1634
XU811 ND2 $PINS O=n1629 I1=n1875 I2=n1656
XU812 ND2 $PINS O=n1617 I1=FE_DBTN216_n87 I2=n1616
XU813 ND2 $PINS O=n1613 I1=n1610 I2=n1811
XU814 AO12 $PINS O=n1615 A1=n1835 B1=n1887 B2=n1609
XU815 ND2 $PINS O=n1605 I1=n2 I2=n1059
XU816 OA222 $PINS O=n1597 A1=n1011 A2=n1736 B1=n1652 B2=n1756 C1=n1031
+ C2=FE_DBTN215_n1729
XU817 OA222 $PINS O=n1598 A1=n1592 A2=n1902 B1=n1591 B2=n1839 C1=n1590 C2=n1835
XU818 AN3B2S $PINS O=n1591 I1=n1898 B1=n1712 B2=n35
XU819 AN3B2S $PINS O=n1574 I1=n1562 B1=n1561 B2=n1560
XU820 AN3 $PINS O=n1546 I1=n1825 I2=n1898 I3=n1543
XU821 OA222 $PINS O=n1549 A1=FE_DBTN215_n1729 A2=n1542 B1=n1541 B2=n1744
+ C1=n1540 C2=n1736
XU822 OA222 $PINS O=n1551 A1=n1653 A2=FE_DBTN222_n7 B1=n1536 B2=n1878 C1=n1796
+ C2=n1711
XU823 AN3B2S $PINS O=n1529 I1=n1576 B1=n1528 B2=n87
XU824 OA112 $PINS O=n1522 A1=n1520 B1=n1519 C1=n1835 C2=FE_DBTN226_n2
XU825 AN3 $PINS O=n1505 I1=n1497 I2=n1496 I3=n1633
XU826 ND2 $PINS O=n1633 I1=n1058 I2=n1495
XU827 ND2 $PINS O=n1493 I1=n1792 I2=FE_DBTN227_n1
XU828 ND2 $PINS O=n1494 I1=n1746 I2=n1019
XU829 ND2 $PINS O=n1489 I1=n991 I2=n1616
XU830 OA222 $PINS O=n1513 A1=n1006 A2=n1736 B1=n1487 B2=n1824 C1=n1486 C2=n1572
XU831 AN3B2S $PINS O=n1487 I1=n1485 B1=n1484 B2=n1575
XU832 OR3B2 $PINS O=n1473 I1=n1733 B1=n1588 B2=n1658
XU833 ND2 $PINS O=n1474 I1=n1472 I2=n88
XU834 OA222 $PINS O=n1454 A1=n1450 A2=n1720 B1=n1449 B2=n1824 C1=n1448 C2=n1572
XU835 ND2 $PINS O=n1630 I1=n1732 I2=n1671
XU836 OA222 $PINS O=n1455 A1=n1445 A2=n1837 B1=n1500 B2=n1444 C1=n1443 C2=n1835
XU837 OA222 $PINS O=n1456 A1=n1441 A2=n1902 B1=n1670 B2=n1709 C1=n1440
+ C2=FE_DBTN222_n7
XU838 AN3B2S $PINS O=n1459 I1=n1524 B1=n1433 B2=n1508
XU839 AN3 $PINS O=n1556 I1=n1427 I2=n1426 I3=n1425
XU840 OA112 $PINS O=n1426 A1=n1496 B1=n1415 C1=n1416 C2=n1815
XU841 AO12 $PINS O=n1415 A1=n1736 B1=FE_DBTN219_n1475 B2=n1414
XU842 OA222 $PINS O=n1427 A1=n1665 A2=n1837 B1=n1413 B2=n1756 C1=n1818
+ C2=FE_DBTN219_n1475
XU843 OA112 $PINS O=n1606 A1=n1412 B1=n1411 C1=n1756 C2=FE_DBTN226_n2
XU844 OA222 $PINS O=n1411 A1=n1894 A2=n128 B1=n1410 B2=n92 C1=n1465 C2=n1815
XU845 OA222 $PINS O=n1524 A1=n1460 A2=FE_DBTN215_n1729 B1=n17
+ B2=FE_DBTN219_n1475 C1=n1873 C2=n1005
XU846 OA222 $PINS O=n1404 A1=FE_DBTN216_n87 A2=n1824 B1=n1031
+ B2=FE_DBTN215_n1729 C1=n1795 C2=n1835
XU847 OA222 $PINS O=n1405 A1=n1399 A2=n1572 B1=n1398 B2=FE_DBTN222_n7 C1=n1397
+ C2=n1636
XU848 OA222 $PINS O=n1406 A1=n1395 A2=n1839 B1=n1394 B2=n1709 C1=n1393 C2=n1878
XU849 OA112 $PINS O=n1408 A1=n1391 B1=n1390 C1=n1756 C2=n1875
XU850 OA222 $PINS O=n1390 A1=n1822 A2=n1888 B1=n1669 B2=n1818 C1=n1805 C2=n1567
XU851 OR3B2 $PINS O=n1389 I1=n1705 B1=n1808 B2=n1498
XU852 OA222 $PINS O=n1385 A1=FE_DBTN222_n7 A2=FE_DBTN227_n1 B1=FE_DBTN213_n94
+ B2=n1460 C1=n93 C2=n1837
XU853 OA222 $PINS O=n1379 A1=n1466 A2=FE_DBTN217_n1392 B1=n1628 B2=n1011
+ C1=n1869 C2=n88
XU854 ND2 $PINS O=n1376 I1=n991 I2=n1396
XU855 ND2 $PINS O=n1377 I1=n1888 I2=n1439
XU856 AO12 $PINS O=n1381 A1=n1756 B1=n1439 B2=n1653
XU857 OA222 $PINS O=n1383 A1=FE_DBTN212_n1417 A2=n1830 B1=n1834 B2=n1711
+ C1=n1430 C2=n1736
XU858 OA112 $PINS O=n1384 A1=n1783 B1=n1375 C1=n1903 C2=FE_DBTN223_n6
XU859 OA222 $PINS O=n1373 A1=FE_DBTN213_n94 A2=n1372 B1=n1371 B2=n93 C1=n1370
+ C2=n1822
XU860 OA112 $PINS O=n1499 A1=n1363 B1=n1362 C1=FE_DBTN212_n1417 C2=n1830
XU861 ND2 $PINS O=n1362 I1=n996 I2=n1060
XU862 OA222 $PINS O=n1604 A1=n1587 A2=FE_DBTN222_n7 B1=n1572 B2=n1671 C1=n1824
+ C2=FE_DBTN226_n2
XU863 AO112 $PINS O=n1358 A1=n1356 B1=n1355 C1=n1357 C2=n6
XU864 AN3 $PINS O=n1784 I1=n1352 I2=n1351 I3=n1350
XU865 OA112 $PINS O=n1350 A1=n1391 B1=n1349 C1=n1587 C2=n1754
XU866 OA222 $PINS O=n1349 A1=FE_DBTN222_n7 A2=FE_DBTN227_n1 B1=n1011 B2=n1736
+ C1=n1711 C2=n1439
XU867 OA222 $PINS O=n1391 A1=n1011 A2=n1815 B1=n17 B2=FE_DBTN217_n1392 C1=n1818
+ C2=n1005
XU868 OA222 $PINS O=n1351 A1=n1730 A2=n1636 B1=n1348 B2=n1878 C1=n1470 C2=n1824
XU869 OA222 $PINS O=n1352 A1=n1873 A2=n88 B1=n1727 B2=FE_DBTN213_n94 C1=n1646
+ C2=n1572
XU870 AN3 $PINS O=n1707 I1=n1347 I2=n1346 I3=n1345
XU871 AN3B2S $PINS O=n1345 I1=n1344 B1=n1343 B2=n1342
XU872 ND2 $PINS O=n1337 I1=n1811 I2=n1439
XU873 OA222 $PINS O=n1334 A1=n1878 A2=n1888 B1=n1710 B2=n1666 C1=FE_DBTN222_n7
+ C2=n1439
XU874 OA222 $PINS O=n1329 A1=n93 A2=n1818 B1=FE_DBTN212_n1417 B2=n1372
+ C1=FE_DBTN213_n94 C2=n1027
XU875 AO12 $PINS O=n1330 A1=FE_DBTN215_n1729 B1=n1726 B2=n1028
XU876 AN3 $PINS O=n1738 I1=n1587 I2=n1903 I3=n1713
XU877 OA222 $PINS O=n1299 A1=n1854 A2=n1014 B1=n1298 B2=n1805 C1=n1022 C2=n1878
XU878 ND2 $PINS O=n1575 I1=n1563 I2=n1884
XU879 ND2 $PINS O=n1296 I1=n1485 I2=n1668
XU880 ND2 $PINS O=n1717 I1=n1875 I2=n1732
XU881 AN3B2S $PINS O=n1276 I1=n1375 B1=n1275 B2=n1342
XU882 AO12 $PINS O=n1342 A1=n1538 B1=n134 B2=FE_DBTN210_n1878
XU883 AO222 $PINS O=n1275 A1=n1819 A2=n1057 B1=n1001 B2=n1054
+ C1=FE_DBTN210_n1878 C2=n1024
XU884 OA222 $PINS O=n1277 A1=n999 A2=FE_DBTN224_n5 B1=n1274 B2=n1005 C1=n1273
+ C2=FE_DBTN222_n7
XU885 AO112 $PINS O=n1262 A1=n1507 B1=n1558 C1=n1488 C2=n1052
XU886 ND2 $PINS O=n1639 I1=n1746 I2=n1527
XU887 OA222 $PINS O=n1254 A1=n1253 A2=n1822 B1=n1252 B2=FE_DBTN223_n6 C1=n1251
+ C2=n1805
XU888 OR3B2 $PINS O=n1428 I1=n1676 B1=n1249 B2=n1248
XU889 ND2 $PINS O=n1297 I1=n1801 I2=n1527
XU890 ND2 $PINS O=n1676 I1=n1563 I2=n1618
XU891 AN3 $PINS O=n1836 I1=n1320 I2=n128 I3=n1800
XU892 ND2 $PINS O=n1354 I1=n1837 I2=n1744
XU893 ND2 $PINS O=n1247 I1=n1236 I2=n1235
XU894 ND2 $PINS O=n1232 I1=n1664 I2=n1815
XU895 ND2 $PINS O=n1234 I1=FE_DBTN215_n1729 I2=FE_DBTN212_n1417
XU896 ND2 $PINS O=n1496 I1=n2 I2=FE_DBTN220_n1754
XU897 ND2 $PINS O=n1357 I1=n1616 I2=n1718
XU898 AN3 $PINS O=n1284 I1=n1222 I2=n1646 I3=n137
XU899 ND2 $PINS O=n1211 I1=n1005 I2=FE_DBTN217_n1392
XU900 ND2 $PINS O=n1212 I1=n1027 I2=n1830
XU902 AN3B1 $PINS O=n1726 I1=n1893 I2=n1372 B1=n1226
XU904 ND2 $PINS O=n1227 I1=n1710 I2=n92
XU905 ND2 $PINS O=n1564 I1=FE_DBTN226_n2 I2=n1718
XU906 OR3B2 $PINS O=n1188 I1=n1675 B1=n1019 B2=n1576
XU907 ND2 $PINS O=n1675 I1=n1651 I2=FE_DBTN226_n2
XU908 ND2 $PINS O=n1802 I1=n1576 I2=n1618
XU909 ND2 $PINS O=n1569 I1=n1718 I2=n1527
XU910 ND2 $PINS O=n1671 I1=n1885 I2=n1043
XU911 AN3 $PINS O=n1782 I1=n1177 I2=n1176 I3=n1175
XU912 ND2 $PINS O=n1363 I1=n1776 I2=n1865
XU913 OA222 $PINS O=n1171 A1=n1258 A2=FE_DBTN212_n1417 B1=n1665
+ B2=FE_DBTN224_n5 C1=n1657 C2=n1711
XU915 ND2 $PINS O=n1303 I1=n1372 I2=n1032
XU916 ND2 $PINS O=n1851 I1=n1490 I2=n17
XU917 ND2 $PINS O=n1154 I1=n1271 I2=n1736
XU919 ND2 $PINS O=n1155 I1=n1743 I2=n1463
XU920 OA222 $PINS O=n1150 A1=n1815 A2=FE_DBTN219_n1475 B1=n1620 B2=n1875
+ C1=n137 C2=n1572
XU921 ND2 $PINS O=n1565 I1=n1899 I2=n1618
XU923 OR3B2 $PINS O=n1146 I1=n1338 B1=n1040 B2=n1372
XU924 ND2 $PINS O=n1338 I1=n1743 I2=n1258
XU925 ND2 $PINS O=n1147 I1=n1714 I2=n1718
XU926 ND2 $PINS O=n1332 I1=n1737 I2=FE_DBTN217_n1392
XU927 ND2 $PINS O=n1272 I1=n93 I2=FE_DBTN217_n1392
XU928 OA222 $PINS O=n1139 A1=n1017 A2=n1805 B1=n1138 B2=n88 C1=n1137 C2=n1835
XU929 ND2 $PINS O=n1568 I1=n1618 I2=n1396
XU930 OA222 $PINS O=n1423 A1=n1642 A2=FE_DBTN212_n1417 B1=n34 B2=n1711
+ C1=FE_DBTN215_n1729 C2=n1743
XU931 OA112 $PINS O=n1142 A1=n1786 B1=n1641 C1=n1720 C2=n1567
XU932 OA222 $PINS O=n1135 A1=n1011 A2=n1831 B1=n1744 B2=FE_DBTN219_n1475
+ C1=FE_DBTN212_n1417 C2=n1460
XU933 ND2 $PINS O=shift1[0] I1=n1134 I2=n1133
XU934 ND2 $PINS O=n1751 I1=n1057 I2=n1001
XU935 ND2 $PINS O=n1817 I1=n1153 I2=n1697
XU936 AO12 $PINS O=n1128 A1=n1669 B1=FE_DBTN224_n5 B2=n1410
XU937 ND2 $PINS O=n1666 I1=n1126 I2=n1148
XU939 OA222 $PINS O=n1130 A1=n1037 A2=FE_DBTN215_n1729 B1=n1124 B2=n1756
+ C1=n1123 C2=n1888
XU940 OA222 $PINS O=n1131 A1=n1653 A2=n1824 B1=n1854 B2=FE_DBTN219_n1475
+ C1=n1536 C2=n1572
XU941 OA222 $PINS O=n1132 A1=n17 A2=n88 B1=n1430 B2=n1636 C1=n1021 C2=n1822
XU942 ND2 $PINS O=n1293 I1=n1801 I2=n1567
XU943 AN3 $PINS O=n1141 I1=n1117 I2=n1116 I3=n1115
XU944 AO12 $PINS O=n1340 A1=n92 B1=n17 B2=n1873
XU945 ND2 $PINS O=n1712 I1=n1796 I2=n1108
XU947 ND2 $PINS O=n1104 I1=n1899 I2=n1801
XU948 ND2 $PINS O=n1105 I1=n1791 I2=n1567
XU949 OA222 $PINS O=n1113 A1=n1466 A2=n1014 B1=n1101 B2=n1822 C1=n1562 C2=n1720
XU950 ND2 $PINS O=n1611 I1=n1282 I2=n1527
XU951 ND2 $PINS O=n1754 I1=n15 I2=n1125
XU952 ND2 $PINS O=n1892 I1=n1041 I2=FE_OFN110_fold_n_0
XU954 ND2 $PINS O=n1634 I1=n1097 I2=n1126
XU955 ND2 $PINS O=n1387 I1=n1095 I2=n1094
XU956 OA222 $PINS O=n1094 A1=n1184 A2=n1805 B1=n1093 B2=n1835 C1=n1092 C2=n1744
XU957 ND2 $PINS O=n1744 I1=n1153 I2=n1148
XU958 OA222 $PINS O=n1095 A1=n1903 A2=n1822 B1=n1658 B2=n1756 C1=n1727
+ C2=FE_DBTN215_n1729
XU960 ND2 $PINS O=n1831 I1=n1149 I2=n1097
XU961 AN3 $PINS O=n1268 I1=n1090 I2=n1010 I3=n1089
XU962 OA222 $PINS O=n1089 A1=n1414 A2=n1636 B1=n1466 B2=n1005 C1=n92 C2=n1709
XU968 ND2 $PINS O=n1819 I1=n1753 I2=n92
XU970 OA222 $PINS O=n1119 A1=n1720 A2=FE_DBTN226_n2 B1=n1086 B2=n1878 C1=n1902
+ C2=n128
XU971 ND2 $PINS O=n1560 I1=FE_DBTN226_n2 I2=n1527
XU972 ND2 $PINS O=n1616 I1=n1085 I2=n1103
XU973 ND2 $PINS O=n1801 I1=n1122 I2=n1100
XU974 OA222 $PINS O=n1120 A1=n1894 A2=n93 B1=n1084 B2=FE_DBTN212_n1417 C1=n1083
+ C2=FE_DBTN213_n94
XU976 AN3B2S $PINS O=n1865 I1=n1764 B1=k_idx[3] B2=k_idx[4]
XU977 ND2 $PINS O=n1862 I1=n1461 I2=n1027
XU978 ND2 $PINS O=n1372 I1=n1038 I2=FE_OFN110_fold_n_0
XU979 ND2 $PINS O=n1082 I1=n1727 I2=n1029
XU980 ND2 $PINS O=n1830 I1=n1035 I2=n1043
XU981 ND2 $PINS O=n1258 I1=n1039 I2=n1043
XU982 ND2 $PINS O=n1167 I1=n1080 I2=n97
XU983 ND2 $PINS O=n1542 I1=n1034 I2=n1043
XU984 ND2 $PINS O=n1743 I1=n1035 I2=FE_OFN110_fold_n_0
XU985 ND2 $PINS O=n1893 I1=n1041 I2=n1043
XU986 ND2 $PINS O=n1463 I1=n1034 I2=FE_OFN110_fold_n_0
XU987 ND2 $PINS O=n1642 I1=n1876 I2=n1043
XU989 ND2 $PINS O=n1209 I1=n1080 I2=n_idx[1]
XU990 OA222 $PINS O=n1121 A1=n1079 A2=FE_DBTN222_n7 B1=n1563 B2=n1839 C1=n1078
+ C2=n1711
XU991 ND2 $PINS O=n1887 I1=n1077 I2=n1043
XU993 ND2 $PINS O=n1108 I1=n1075 I2=n1043
XU994 ND2 $PINS O=n1199 I1=n1755 I2=FE_DBTN226_n2
XU995 ND2 $PINS O=n1655 I1=n1073 I2=n1043
XU996 ND2 $PINS O=n1811 I1=n1072 I2=n1043
XU998 ND2 $PINS O=n1746 I1=n1085 I2=n1775
XU1000 AN3 $PINS O=n1079 I1=n1544 I2=n1898 I3=n1652
XU1001 ND2 $PINS O=n1439 I1=n1073 I2=n_idx[0]
XU1002 ND2 $PINS O=n1087 I1=n1071 I2=n97
XU1003 ND2 $PINS O=n1832 I1=n1075 I2=n_idx[0]
XU1004 ND2 $PINS O=n1870 I1=n1100 I2=n_idx[3]
XU1005 ND2 $PINS O=n1903 I1=n_idx[0] I2=n1076
XU1006 ND2 $PINS O=n1900 I1=FE_DBTN228_fold_n_2 I2=n1036
XU1008 ND2 $PINS O=n1848 I1=n_idx[3] I2=n_idx[2]
XU1009 ND2 $PINS O=n1656 I1=n1077 I2=n_idx[0]
XU1010 ND2 $PINS O=n1847 I1=n1071 I2=n_idx[1]
XU3 ND2 $PINS O=n4 I1=n1887 I2=n1811
XU4 ND2 $PINS O=n87 I1=n1899 I2=n1884
XU5 AN4B1S $PINS O=n1436 I1=n1658 I2=n1319 I3=n133 B1=n1
XU6 MOAI1S $PINS O=n1172 A1=n1011 A2=n17 B1=FE_DBTN221_n93 B2=n1049
XU7 OR2B1S $PINS O=n1852 I1=n1055 B1=n1817
XU8 AN2 $PINS O=n1563 I1=n1746 I2=n1732
XU9 AN2 $PINS O=n1737 I1=n1465 I2=n93
XU10 NR2 $PINS O=n1543 I1=n35 I2=n4
XU11 OR2 $PINS O=n1733 I1=n4 I2=n253
XU12 ND2 $PINS O=n93 I1=n1857 I2=n1890
XU13 AN4S $PINS O=n1322 I1=n1796 I2=n1746 I3=n1738 I4=n1653
XU14 ND3S $PINS O=n1718 I1=n_idx[1] I2=FE_DBTN228_fold_n_2 I3=n1122
XU15 ND3S $PINS O=n1888 I1=n1775 I2=n_idx[1] I3=n1091
XU16 AN2 $PINS O=n1 I1=n1072 I2=n_idx[0]
XU17 AN3 $PINS O=n2 I1=n1074 I2=n1043 I3=n_idx[4]
XU18 OR2 $PINS O=n3 I1=n253 I2=n134
XU19 AN2 $PINS O=n5 I1=n1688 I2=n1125
XU20 AN2 $PINS O=n6 I1=n1764 I2=n1107
XU21 AN2 $PINS O=n7 I1=n1106 I2=n1769
XU29 NR2 $PINS O=n15 I1=_rom_k_idx_3_1 I2=n114
XU31 ND2 $PINS O=n17 I1=n1688 I2=n1126
XU37 INV1S $PINS O=n23 I=n1887
XU48 INV1S $PINS O=n34 I=n4
XU49 INV1S $PINS O=n35 I=n1657
XU51 INV1S $PINS O=n37 I=n1815
XU66 INV1S $PINS O=n52 I=n1899
XU68 INV1S $PINS O=n54 I=n1888
XU75 INV1S $PINS O=n61 I=n1718
XU76 INV1S $PINS O=n62 I=n1824
XU83 INV1S $PINS O=n97 I=n_idx[1]
XU88 INV1S $PINS O=n105 I=n1756
XU102 INV1S $PINS O=n100 I=n_idx[4]
XU105 NR2 $PINS O=n1776 I1=n1029 I2=n_idx[4]
XU106 NR2 $PINS O=n1148 I1=n114 I2=k_idx[1]
XU107 INV1S $PINS O=n135 I=n1582
XU108 NR2 $PINS O=n1582 I1=n87 I2=n337
XU109 NR2 $PINS O=n1667 I1=n1001 I2=n1819
XU110 INV1S $PINS O=n1032 I=n1339
XU111 INV1S $PINS O=n999 I=n1272
XU112 INV1S $PINS O=n1008 I=n1378
XU113 AN2 $PINS O=n1235 I1=n1581 I2=n1320
XU114 INV1S $PINS O=n121 I=n1588
XU115 INV1S $PINS O=n120 I=n1581
XU116 INV1S $PINS O=n131 I=n1646
XU117 INV1S $PINS O=n1004 I=n1737
XU118 INV1S $PINS O=n994 I=n1834
XU119 INV1S $PINS O=n154 I=n1668
XU120 INV1S $PINS O=n1001 I=n1669
XU121 INV1S $PINS O=n133 I=n1442
XU122 NR2 $PINS O=n1800 I1=n217 I2=n337
XU123 INV1S $PINS O=n337 I=n1563
XU125 INV1S $PINS O=n1027 I=n1418
XU126 ND3 $PINS O=n1226 I1=n1460 I2=n1642 I3=n1422
XU127 INV1S $PINS O=n417 I=n1201
XU128 INV1S $PINS O=n119 I=n1287
XU129 AN2 $PINS O=n1673 I1=n1670 I2=n1669
XU130 INV1S $PINS O=n998 I=n1540
XU131 NR2 $PINS O=n1339 I1=n1033 I2=n1043
XU132 INV1S $PINS O=n1028 I=n1082
XU133 AN2 $PINS O=n1727 I1=n1258 I2=n1830
XU134 NR2 $PINS O=n1792 I1=n217 I2=n52
XU135 INV1S $PINS O=n123 I=n1319
XU136 INV1S $PINS O=n174 I=n1525
XU137 NR2 $PINS O=n1674 I1=n52 I2=n174
XU138 AN2 $PINS O=n1435 I1=n1259 I2=n1737
XU139 INV1S $PINS O=n1006 I=n1359
XU140 INV1S $PINS O=n221 I=n1589
XU141 INV1S $PINS O=n1000 I=n1430
XU142 ND3 $PINS O=n1532 I1=n88 I2=n1011 I3=n1006
XU144 NR2 $PINS O=n1854 I1=n1053 I2=n1052
XU145 NR2 $PINS O=n1533 I1=n1488 I2=n1272
XU146 NR2 $PINS O=n1306 I1=n1226 I2=n1418
XU147 NR2 $PINS O=n1816 I1=n1053 I2=n1050
XU148 NR2 $PINS O=n1378 I1=n92 I2=n1816
XU149 INV1S $PINS O=n130 I=n1236
XU150 INV1S $PINS O=n1070 I=n1107
XU151 NR2 $PINS O=n1246 I1=n1247 I2=n253
XU152 NR2 $PINS O=n1755 I1=n126 I2=n996
XU153 AN2 $PINS O=n1320 I1=n1587 I2=n1652
XU154 ND3 $PINS O=n1244 I1=n1581 I2=FE_DBTN216_n87 I3=n1836
XU155 NR2 $PINS O=n1576 I1=n1024 I2=n1026
XU156 ND3 $PINS O=n1451 I1=n1582 I2=n1019 I3=n1179
XU157 NR2 $PINS O=n1179 I1=n1020 I2=n1802
XU158 NR2 $PINS O=n1447 I1=n1802 I2=n3
XU159 NR2 $PINS O=n1588 I1=n122 I2=n1
XU160 NR2 $PINS O=n1581 I1=n121 I2=n23
XU161 ND3 $PINS O=shift3[2] I1=n1602 I2=n1601 I3=n1600
XU162 NR2 $PINS O=n1601 I1=n1579 I2=n1578
XU163 NR3 $PINS O=n1602 I1=n1559 I2=n1558 I3=n1557
XU164 AN4B1S $PINS O=n1600 I1=n1599 I2=n1598 I3=n1597 B1=n1596
XU165 INV1S $PINS O=n1018 I=n1802
XU166 ND3 $PINS O=shift3[0] I1=n1518 I2=n1517 I3=n1516
XU167 NR3 $PINS O=n1518 I1=n1469 I2=n1468 I3=n1467
XU168 AN4B1S $PINS O=n1517 I1=n1481 I2=n1480 I3=n1479 B1=n1478
XU169 AN4B1S $PINS O=n1516 I1=n1515 I2=n1514 I3=n1513 B1=n1512
XU171 ND3 $PINS O=n1365 I1=n1707 I2=n1784 I3=n127
XU172 NR2 $PINS O=n1093 I1=n126 I2=n129
XU173 NR2 $PINS O=n1652 I1=n992 I2=n995
XU174 NR2 $PINS O=n1348 I1=n1026 I2=n1676
XU175 NR2 $PINS O=n1413 I1=n134 I2=n126
XU176 NR3 $PINS O=n1651 I1=n890 I2=n418 I3=n3
XU177 NR2 $PINS O=n1251 I1=n1719 I2=n1357
XU178 NR2 $PINS O=n1646 I1=n1023 I2=n134
XU179 ND3 $PINS O=n1650 I1=n127 I2=n1708 I3=n1641
XU180 NR2 $PINS O=n1353 I1=n134 I2=n35
XU181 NR2 $PINS O=n1414 I1=n1004 I2=FE_DBTN209_n92
XU182 AOI22S $PINS O=n1480 A1=n1055 A2=n1474 B1=n1064 B2=n1473
XU183 OAI112HS $PINS O=n1503 A1=n1499 B1=n1498 C1=n1500 C2=n1818
XU184 ND3 $PINS O=n1521 I1=n1506 I2=n1505 I3=n1504
XU185 NR2 $PINS O=n1506 I1=n1492 I2=n1491
XU186 NR3 $PINS O=n1504 I1=n1503 I2=n1502 I3=n1501
XU187 NR2 $PINS O=n1834 I1=n995 I2=n996
XU188 NR2 $PINS O=n1485 I1=n994 I2=FE_DBTN218_n1108
XU189 NR2 $PINS O=n1668 I1=n253 I2=n418
XU190 NR2 $PINS O=n1669 I1=n1495 I2=n1392
XU191 AOI22S $PINS O=n1810 A1=n6 A2=n1794 B1=n1065 B2=n1793
XU192 ND3 $PINS O=n1793 I1=n1792 I2=n1791 I3=n1804
XU193 ND3 $PINS O=n1442 I1=FE_DBTN225_n3 I2=n1899 I3=n1657
XU194 NR2 $PINS O=n1898 I1=n3 I2=FE_DBTN211_n1732
XU195 INV1S $PINS O=n1033 I=n1876
XU196 INV1S $PINS O=n1011 I=n1237
XU197 NR2 $PINS O=n1653 I1=n52 I2=n992
XU198 NR2 $PINS O=n1745 I1=n87 I2=n134
XU199 AOI22S $PINS O=n1090 A1=n126 A2=n1059 B1=n1052 B2=n1819
XU200 INV1S $PINS O=n1019 I=n1569
XU201 NR2 $PINS O=n1796 I1=n1 I2=n995
XU202 NR2 $PINS O=n1470 I1=n253 I2=n1
XU203 NR2 $PINS O=n1753 I1=FE_DBTN221_n93 I2=n1237
XU204 INV1S $PINS O=n256 I=n1883
XU205 NR2 $PINS O=n1713 I1=n256 I2=n23
XU206 OR2 $PINS O=n1295 I1=n1575 I2=n121
XU207 INV1S $PINS O=n1057 I=n1817
XU208 AOI13HS $PINS O=n1662 A1=n1839 B1=n34 B2=n1652 B3=n1651
XU209 INV1S $PINS O=n137 I=n1565
XU210 INV1S $PINS O=n217 I=n1610
XU211 NR2 $PINS O=n1418 I1=n1043 I2=n1030
XU213 NR2 $PINS O=n1730 I1=n1237 I2=n1475
XU214 NR2 $PINS O=n1201 I1=n418 I2=n995
XU215 AOI22S $PINS O=n1114 A1=n1044 A2=n123 B1=n1059 B2=n417
XU216 NR2 $PINS O=n1637 I1=n1054 I2=n1056
XU217 ND3 $PINS O=n1853 I1=n1637 I2=n1636 I3=n1635
XU218 NR2 $PINS O=n1635 I1=n1058 I2=n37
XU219 NR2 $PINS O=n1287 I1=n122 I2=n134
XU220 AOI22S $PINS O=n1344 A1=n1060 A2=FE_DBTN218_n1108 B1=n1045
+ B2=FE_DBTN209_n92
XU221 INV1S $PINS O=n1007 I=n1541
XU222 NR2 $PINS O=n1670 I1=n1007 I2=FE_DBTN221_n93
XU223 NR2 $PINS O=n1658 I1=FE_DBTN218_n1108 I2=n996
XU224 NR2 $PINS O=n1540 I1=FE_DBTN221_n93 I2=n1475
XU225 AOI22S $PINS O=n1632 A1=FE_DBTN221_n93 A2=n1050 B1=FE_DBTN211_n1732
+ B2=n62
XU226 NR2 $PINS O=n1422 I1=n1339 I2=n1483
XU227 NR2 $PINS O=n1710 I1=n1012 I2=n1495
XU228 INV1S $PINS O=n1012 I=n1500
XU229 NR2 $PINS O=n1236 I1=n52 I2=n134
XU230 NR2 $PINS O=n1259 I1=n1012 I2=FE_DBTN209_n92
XU231 INV1S $PINS O=n1020 I=n1801
XU232 NR2 $PINS O=n1789 I1=n1020 I2=FE_DBTN211_n1732
XU233 NR2 $PINS O=n1585 I1=FE_DBTN211_n1732 I2=n992
XU234 NR2 $PINS O=n1319 I1=FE_DBTN211_n1732 I2=n23
XU235 NR2 $PINS O=n1525 I1=n217 I2=n890
XU236 MOAI1S $PINS O=n1343 A1=n1466 A2=n1005 B1=FE_DBTN209_n92 B2=n1052
XU237 NR2 $PINS O=n1395 I1=n122 I2=n126
XU238 NR3 $PINS O=n1855 I1=n1852 I2=FE_DBTN214_n1831 I3=n1851
XU239 AOI22S $PINS O=n1218 A1=n1058 A2=n1227 B1=n1060 B2=n130
XU240 INV1S $PINS O=n1053 I=n1634
XU241 NR2 $PINS O=n1609 I1=n134 I2=n992
XU242 NR2 $PINS O=n1869 I1=n1053 I2=n1054
XU243 OAI12HS $PINS O=n1174 A1=n1055 B1=n1495 B2=n1475
XU244 NR2 $PINS O=n1825 I1=n122 I2=FE_DBTN218_n1108
XU246 NR2 $PINS O=n1476 I1=n122 I2=n995
XU247 INV1S $PINS O=n991 I=n1639
XU249 NR2 $PINS O=n1430 I1=n1237 I2=n1392
XU250 AOI12HS $PINS O=n1375 A1=n1507 B1=FE_DBTN221_n93 B2=n37
XU251 ND3 $PINS O=n1359 I1=n1014 I2=n93 I3=n1665
XU252 ND3 $PINS O=n1566 I1=FE_DBTN225_n3 I2=n1563 I3=n1714
XU253 NR2 $PINS O=n1589 I1=n253 I2=n890
XU254 MAOI1 $PINS O=n1523 A1=n1050 A2=n1332 B1=n1710 B2=n1634
XU255 NR2 $PINS O=n1838 I1=n1272 I2=FE_DBTN209_n92
XU256 NR2 $PINS O=n1586 I1=n217 I2=n418
XU257 INV1S $PINS O=n419 I=n1795
XU258 INV1S $PINS O=n1031 I=n1303
XU259 MOAI1S $PINS O=n1491 A1=n1490 A2=n88 B1=n1000 B2=n37
XU260 MOAI1S $PINS O=n1143 A1=n1838 A2=n1709 B1=n1045 B2=n1332
XU262 NR2 $PINS O=n1273 I1=n995 I2=n134
XU263 NR2 $PINS O=n1731 I1=n1569 I2=n418
XU264 OA22 $PINS O=n1740 A1=n1822 A2=n1731 B1=n1831 B2=n1730
XU265 INV1S $PINS O=n1010 I=n1172
XU266 NR2 $PINS O=n1410 I1=n1054 I2=n1052
XU267 INV1S $PINS O=n1045 I=n1636
XU268 ND3 $PINS O=n1488 I1=n1665 I2=n88 I3=n1730
XU269 AN2 $PINS O=n1555 I1=n1361 I2=n1360
XU270 AOI22S $PINS O=n1360 A1=n1392 A2=n1045 B1=n1495 B2=n1052
XU271 AOI22S $PINS O=n1361 A1=FE_DBTN214_n1831 A2=n1359 B1=n1055 B2=n1488
XU272 AOI22S $PINS O=n1641 A1=n62 A2=n23 B1=n1060 B2=n995
XU273 NR2 $PINS O=n1664 I1=n1048 I2=FE_DBTN214_n1831
XU274 INV1S $PINS O=n1050 I=n1466
XU275 NR2 $PINS O=n1472 I1=n998 I2=n1237
XU276 INV1S $PINS O=n1040 I=n1483
XU277 INV1S $PINS O=n1055 I=n1709
XU278 MOAI1S $PINS O=n1468 A1=n1466 A2=n1465 B1=n417 B2=n7
XU279 NR2 $PINS O=n1166 I1=n1045 I2=n1056
XU280 ND2 $PINS O=n1460 I1=n1038 I2=n1043
XU281 NR2 $PINS O=n1341 I1=n1339 I2=n1338
XU282 INV1S $PINS O=n1022 I=n1297
XU283 NR2 $PINS O=n1812 I1=n1024 I2=FE_DBTN211_n1732
XU284 INV1S $PINS O=n1052 I=n1818
XU285 NR2 $PINS O=n1628 I1=n1052 I2=n1058
XU286 INV1S $PINS O=n1064 I=n1839
XU287 NR2 $PINS O=n1138 I1=n1049 I2=FE_DBTN214_n1831
XU288 ND3 $PINS O=n1302 I1=n1460 I2=n1893 I3=n1040
XU289 NR2 $PINS O=n1536 I1=n418 I2=n61
XU290 NR2 $PINS O=n1274 I1=n1056 I2=n1052
XU291 MOAI1S $PINS O=n1437 A1=n1737 A2=n1466 B1=n105 B2=n23
XU292 NR2 $PINS O=n1826 I1=n105 I2=n1060
XU293 NR2 $PINS O=n1271 I1=n1054 I2=n1058
XU294 NR2 $PINS O=n1490 I1=n1048 I2=n5
XU295 AOI22S $PINS O=n1514 A1=n1483 A2=n94 B1=FE_DBTN214_n1831
+ B2=FE_DBTN221_n93
XU296 NR2 $PINS O=n1137 I1=n996 I2=n418
XU297 INV1S $PINS O=n1069 I=n1769
XU298 INV1S $PINS O=n1047 I=n1851
XU299 NR2 $PINS O=n1621 I1=n52 I2=n996
XU300 NR2 $PINS O=n1620 I1=FE_DBTN210_n1878 I2=n1065
XU301 NR2 $PINS O=n1866 I1=n1050 I2=n1049
XU302 NR2 $PINS O=n1107 I1=n118 I2=k_idx[3]
XU303 INV1S $PINS O=n1063 I=n1822
XU304 INV1S $PINS O=n126 I=n1811
XU305 OAI222S $PINS O=n1241 A1=n1240 A2=n1835 B1=n1533 B2=n1239 C1=n1238
+ C2=n1824
XU306 NR2 $PINS O=n1239 I1=n1055 I2=n1354
XU307 NR2 $PINS O=n1238 I1=n134 I2=n1244
XU308 NR2 $PINS O=n1240 I1=n419 I2=n1245
XU309 NR2 $PINS O=n1587 I1=n1199 I2=FE_DBTN218_n1108
XU310 INV1S $PINS O=n1042 I=n1890
XU311 ND3 $PINS O=n1245 I1=n1732 I2=n1884 I3=n1246
XU312 ND3 $PINS O=shift1[3] I1=n1267 I2=n1266 I3=n1265
XU313 NR3 $PINS O=n1267 I1=n1230 I2=n1229 I3=n1228
XU314 NR3 $PINS O=n1265 I1=n1264 I2=n1263 I3=n1262
XU315 AN4B1S $PINS O=n1266 I1=n1243 I2=n1496 I3=n1242 B1=n1241
XU316 ND3 $PINS O=n1264 I1=n1256 I2=n1255 I3=n1254
XU317 MAOI1 $PINS O=n1255 A1=n105 A2=n1247 B1=FE_DBTN222_n7 B2=n1246
XU318 AOI22S $PINS O=n1256 A1=n1064 A2=n1245 B1=n1059 B2=n1244
XU319 AN4B1S $PINS O=n1846 I1=n1788 I2=n1787 I3=n1786 B1=n1785
XU320 OAI222S $PINS O=n1841 A1=n1840 A2=n1839 B1=n1838 B2=n1837 C1=n1836
+ C2=n1835
XU321 AN4B1S $PINS O=n1840 I1=n1883 I2=FE_DBTN225_n3 I3=n1834 B1=n1833
XU322 ND3 $PINS O=n1833 I1=n1832 I2=n1884 I3=FE_DBTN227_n1
XU323 AN4B1S $PINS O=n1450 I1=n1804 I2=FE_DBTN216_n87 I3=n997 B1=n1630
XU324 AN4B1S $PINS O=n1448 I1=n997 I2=n1563 I3=n1447 B1=n1446
XU325 AN4B1S $PINS O=n1449 I1=n1589 I2=n1738 I3=n1544 B1=n995
XU326 ND3 $PINS O=shift2[3] I1=n1459 I2=n1458 I3=n1457
XU327 NR2 $PINS O=n1458 I1=n1438 I2=n1437
XU328 AN4B1S $PINS O=n1457 I1=n1456 I2=n1455 I3=n1454 B1=n1453
XU329 NR3 $PINS O=n1761 I1=n1760 I2=n1759 I3=n1758
XU330 OAI222S $PINS O=n1758 A1=n1757 A2=n1756 B1=n1755 B2=n1754 C1=n1753
+ C2=n1817
XU331 ND3 $PINS O=n1759 I1=n1752 I2=n1751 I3=n1750
XU332 ND3 $PINS O=n1760 I1=n1741 I2=n1740 I3=n1739
XU333 NR3 $PINS O=n1735 I1=n1734 I2=n87 I3=n1733
XU334 ND3 $PINS O=n1734 I1=FE_DBTN227_n1 I2=n1732 I3=n1834
XU335 INV1S $PINS O=n992 I=n1832
XU336 NR2 $PINS O=n1657 I1=n2 I2=n992
XU337 NR3 $PINS O=n1252 I1=n1583 I2=n52 I3=n61
XU338 INV1S $PINS O=n125 I=n1428
XU339 INV1S $PINS O=n1026 I=n1671
XU340 INV1S $PINS O=n1030 I=n1074
XU341 OAI112HS $PINS O=n1603 A1=n1344 B1=n1171 C1=n1858 C2=n128
XU342 AN4B1S $PINS O=n1175 I1=n1363 I2=n1174 I3=n1173 B1=n1538
XU343 AOI22S $PINS O=n1176 A1=FE_DBTN214_n1831 A2=n998 B1=n1060 B2=n121
XU344 NR2 $PINS O=n1177 I1=n1172 I2=n1603
XU345 OAI222S $PINS O=n1230 A1=n34 A2=n1754 B1=n1461 B2=FE_DBTN215_n1729
+ C1=n1235 C2=n1711
XU346 INV1S $PINS O=n122 I=n1656
XU347 AN4B1S $PINS O=n1592 I1=n1586 I2=n1585 I3=n1798 B1=n994
XU348 AN4B1S $PINS O=n1590 I1=n1589 I2=n1588 I3=n1587 B1=n87
XU349 AN4B1S $PINS O=n1486 I1=n1018 I2=n1021 I3=n1646 B1=n1575
XU350 ND3 $PINS O=n1484 I1=FE_DBTN227_n1 I2=n1903 I3=n1657
XU351 AN4B1S $PINS O=n1441 I1=n1586 I2=n1657 I3=n1798 B1=n23
XU352 AN4B1S $PINS O=n1440 I1=n1439 I2=n1899 I3=n1587 B1=n119
XU354 OAI22S $PINS O=n1324 A1=n1323 A2=n1902 B1=n1322 B2=n1835
XU355 AN4B1S $PINS O=n1323 I1=n1834 I2=n133 I3=n1395 B1=n337
XU356 ND3 $PINS O=shift2[1] I1=n1369 I2=n1368 I3=n1367
XU357 AN4B1S $PINS O=n1368 I1=n1330 I2=n1008 I3=n1329 B1=n1328
XU358 NR3 $PINS O=n1367 I1=n1366 I2=n1365 I3=n1364
XU359 NR3 $PINS O=n1369 I1=n1326 I2=n1325 I3=n1324
XU360 OAI222S $PINS O=n1263 A1=n1435 A2=n1817 B1=n1257 B2=n1878 C1=n1006
+ C2=n1636
XU361 NR3 $PINS O=n1257 I1=n1434 I2=n1639 I3=n87
XU362 ND3 $PINS O=n1434 I1=n1883 I2=n1718 I3=n1447
XU363 AN4B1S $PINS O=n1133 I1=n1132 I2=n1131 I3=n1130 B1=n1129
XU364 AN4B1S $PINS O=n1134 I1=n1121 I2=n1120 I3=n1119 B1=n1118
XU365 AN4B1S $PINS O=n1078 I1=n1587 I2=FE_DBTN225_n3 I3=n1653 B1=n123
XU366 AN4B1S $PINS O=n1425 I1=n1424 I2=n1520 I3=n1423 B1=n1702
XU367 ND3 $PINS O=n1433 I1=n1606 I2=n1782 I3=n1556
XU368 INV1S $PINS O=n1029 I=n1305
XU369 NR2 $PINS O=n1092 I1=n1495 I2=FE_DBTN221_n93
XU370 INV1S $PINS O=n129 I=n1798
XU371 NR2 $PINS O=n1116 I1=n1099 I2=n1098
XU372 AN4B1S $PINS O=n1115 I1=n1114 I2=n1113 I3=n1112 B1=n1111
XU373 AN4B1S $PINS O=n1117 I1=n1270 I2=n1096 I3=n1703 B1=n1387
XU374 ND3 $PINS O=shift1[1] I1=n1165 I2=n1164 I3=n1163
XU375 NR3 $PINS O=n1164 I1=n1145 I2=n1144 I3=n1143
XU376 NR3 $PINS O=n1163 I1=n1162 I2=n1161 I3=n1160
XU377 AN4B1S $PINS O=n1165 I1=n1142 I2=n1423 I3=n1141 B1=n1388
XU378 OAI112HS $PINS O=n1559 A1=n1556 B1=n1555 C1=FE_DBTN222_n7 C2=n1899
XU379 INV1S $PINS O=n890 I=n1746
XU381 MOAI1S $PINS O=n1204 A1=n1203 A2=n1756 B1=n7 B2=n1202
XU382 AN4B1S $PINS O=n1203 I1=n1657 I2=n1732 I3=n1476 B1=n1733
XU383 ND3 $PINS O=n1202 I1=n1713 I2=n1587 I3=n1201
XU384 ND3 $PINS O=shift1[2] I1=n1221 I2=n1220 I3=n1219
XU385 AN4B1S $PINS O=n1220 I1=n1198 I2=n1197 I3=n1196 B1=n1195
XU386 AN4B1S $PINS O=n1221 I1=n1523 I2=n1412 I3=n1269 B1=n1182
XU387 AN4B1S $PINS O=n1219 I1=n1218 I2=n1217 I3=n1216 B1=n1215
XU388 OAI112HS $PINS O=n1182 A1=n1782 B1=n1181 C1=n1436 C2=n1902
XU389 AOI22S $PINS O=n1181 A1=FE_DBTN210_n1878 A2=n1180 B1=n1065 B2=n1451
XU390 ND3 $PINS O=n1180 I1=n1562 I2=n137 I3=n1178
XU391 NR3 $PINS O=n1178 I1=n256 I2=n1026 I3=n1020
XU392 MOAI1S $PINS O=n1325 A1=FE_DBTN216_n87 A2=n1824 B1=n105 B2=n1321
XU393 ND3 $PINS O=n1321 I1=n1320 I2=n1656 I3=n1319
XU394 ND3 $PINS O=shift3[3] I1=n1627 I2=n1626 I3=n1625
XU395 NR2 $PINS O=n1626 I1=n1608 I2=n1607
XU396 NR3 $PINS O=n1625 I1=n1624 I2=n1623 I3=n1622
XU397 AN4B1S $PINS O=n1627 I1=n1606 I2=n1605 I3=n1604 B1=n1603
XU398 INV1S $PINS O=n996 I=n1655
XU399 OAI222S $PINS O=n1438 A1=n1436 A2=n1839 B1=n132 B2=n1878 C1=n1435
+ C2=n1817
XU400 INV1S $PINS O=n132 I=n1434
XU401 AOI22S $PINS O=n1599 A1=n62 A2=n1584 B1=n6 B2=n1583
XU402 ND3 $PINS O=n1584 I1=n1582 I2=n1581 I3=n1580
XU403 NR3 $PINS O=n1580 I1=n129 I2=n134 I3=n994
XU404 ND3 $PINS O=n1364 I1=n1555 I2=n1604 I3=n1499
XU405 MOAI1S $PINS O=n1453 A1=n1452 A2=n1805 B1=n1451 B2=n1063
XU406 AN4B1S $PINS O=n1452 I1=FE_DBTN216_n87 I2=n1576 I3=n1019 B1=n221
XU407 NR2 $PINS O=n1444 I1=n1056 I2=n1053
XU408 NR2 $PINS O=n1445 I1=n1475 I2=n1001
XU409 NR2 $PINS O=n1443 I1=n1442 I2=n120
XU410 OAI222S $PINS O=n1680 A1=n1679 A2=n1824 B1=n1678 B2=n1835 C1=n1677
+ C2=n1720
XU411 NR2 $PINS O=n1677 I1=n134 I2=n1676
XU412 NR2 $PINS O=n1679 I1=n54 I2=n119
XU413 NR2 $PINS O=n1678 I1=n1675 I2=n120
XU414 AN4B1S $PINS O=n1684 I1=n1683 I2=n1682 I3=n1681 B1=n1680
XU415 INV1S $PINS O=n134 I=n1903
XU416 INV1S $PINS O=n1005 I=n1638
XU417 MOAI1S $PINS O=n1195 A1=n1818 A2=n1838 B1=n1063 B2=n1194
XU418 ND3 $PINS O=n1194 I1=n1018 I2=n1610 I3=n1193
XU419 NR2 $PINS O=n1193 I1=n1564 I2=n1526
XU420 ND3 $PINS O=n1512 I1=n1511 I2=n1510 I3=n1509
XU421 AOI22S $PINS O=n1511 A1=n1045 A2=n1012 B1=n992 B2=n1060
XU422 AOI22S $PINS O=n1510 A1=n1052 A2=n1004 B1=n1056 B2=n1488
XU423 NR3 $PINS O=n1509 I1=n1508 I2=n1507 I3=n1521
XU424 ND3 $PINS O=n1719 I1=n1284 I2=n1668 I3=n1223
XU425 NR3 $PINS O=n1223 I1=n1293 I2=n1026 I3=n890
XU426 NR2 $PINS O=n1562 I1=n131 I2=n1016
XU427 NR2 $PINS O=n1101 I1=n337 I2=n1611
XU428 INV1S $PINS O=n995 I=n1439
XU429 INV1S $PINS O=n127 I=n1358
XU430 MOAI1S $PINS O=n1355 A1=n128 A2=n1858 B1=FE_DBTN221_n93 B2=n1354
XU431 OAI12HS $PINS O=n1356 A1=n1751 B1=n1353 B2=n1711
XU432 AOI22S $PINS O=n1197 A1=n1067 A2=n1189 B1=n1062 B2=n1188
XU433 ND3 $PINS O=n1189 I1=n1576 I2=n1804 I3=n1187
XU434 NR3 $PINS O=n1187 I1=n419 I2=n1020 I3=n3
XU435 NR2 $PINS O=n1465 I1=n1638 I2=n1495
XU436 NR2 $PINS O=n1665 I1=FE_DBTN209_n92 I2=n1638
XU437 INV1S $PINS O=n1024 I=n1616
XU438 OA22 $PINS O=n1173 A1=FE_DBTN217_n1392 A2=n1666 B1=n1744 B2=n1665
XU439 OAI112HS $PINS O=n1111 A1=n1109 B1=n1340 C1=n1110 C2=n1824
XU440 OAI12HS $PINS O=n1109 A1=n1064 B1=n217 B2=n1712
XU441 NR2 $PINS O=n1110 I1=n129 I2=n221
XU442 NR2 $PINS O=n1222 I1=n256 I2=n1611
XU443 ND3 $PINS O=shift3[1] I1=n1554 I2=n1553 I3=n1552
XU444 AN4B1S $PINS O=n1554 I1=n1524 I2=n1523 I3=n1522 B1=n1521
XU445 NR2 $PINS O=n1553 I1=n1535 I2=n1534
XU446 AN4B1S $PINS O=n1552 I1=n1551 I2=n1550 I3=n1549 B1=n1548
XU447 NR3 $PINS O=n1550 I1=n1539 I2=n1538 I3=n1537
XU448 AOI13HS $PINS O=n1539 A1=FE_DBTN223_n6 B1=n1019 B2=n1875 B3=n137
XU449 OA12 $PINS O=n1537 A1=n105 B1=n52 B2=n1733
XU450 OAI222S $PINS O=n1548 A1=n1547 A2=n1902 B1=n1546 B2=n1839 C1=n1545
+ C2=n1824
XU451 AN4B1S $PINS O=n1547 I1=n1653 I2=n34 I3=n1588 B1=n174
XU452 AN4B1S $PINS O=n1545 I1=n1834 I2=n1544 I3=n1609 B1=n890
XU453 NR2 $PINS O=n1687 I1=n1043 I2=n97
XU454 INV1S $PINS O=n418 I=n1884
XU455 OR2 $PINS O=n88 I1=n1013 I2=n1847
XU456 INV1S $PINS O=n1495 I=n88
XU457 NR2 $PINS O=n1392 I1=n1209 I2=n1013
XU460 NR3 $PINS O=n1708 I1=n89 I2=n90 I3=n91
XU461 OAI22S $PINS O=n89 A1=FE_DBTN219_n1475 A2=n1628 B1=n1014 B2=n1815
XU462 AO22 $PINS O=n90 A1=FE_DBTN210_n1878 A2=n1630 B1=n1060 B2=n1629
XU463 OAI112HS $PINS O=n91 A1=n1788 B1=n1640 C1=n1798 C2=n1824
XU464 ND3 $PINS O=n1311 I1=n1301 I2=n1300 I3=n1299
XU465 AOI22S $PINS O=n1301 A1=n7 A2=n1717 B1=n1065 B2=n1294
XU466 AOI22S $PINS O=n1300 A1=n1044 A2=n1296 B1=n1059 B2=n1295
XU467 ND3 $PINS O=shift2[0] I1=n1314 I2=n1313 I3=n1312
XU468 NR3 $PINS O=n1314 I1=n1281 I2=n1557 I3=n1280
XU469 NR3 $PINS O=n1313 I1=n1292 I2=n1291 I3=n1290
XU470 NR3 $PINS O=n1312 I1=n1311 I2=n1310 I3=n1309
XU471 NR2 $PINS O=n1237 I1=n1013 I2=n1033
XU472 NR2 $PINS O=n1876 I1=n97 I2=n1900
XU473 ND3 $PINS O=shift2[2] I1=n1409 I2=n1408 I3=n1407
XU474 AN4B1S $PINS O=n1407 I1=n1406 I2=n1405 I3=n1404 B1=n1403
XU475 NR3 $PINS O=n1409 I1=n1389 I2=n1388 I3=n1387
XU476 ND3 $PINS O=n1705 I1=n1384 I2=n1383 I3=n1382
XU477 AN4B1S $PINS O=n1382 I1=n1381 I2=n1380 I3=n1379 B1=n1378
XU478 INV1S $PINS O=n253 I=n1875
XU479 AN2 $PINS O=n1672 I1=n1671 I2=n1745
XU480 ND3 $PINS O=n1281 I1=n1270 I2=n1269 I3=n1268
XU481 AOI22S $PINS O=n1497 A1=n1494 A2=n1062 B1=n1044 B2=n1493
XU482 INV1S $PINS O=n1021 I=n1293
XU483 ND3 $PINS O=n1843 I1=n1829 I2=n1828 I3=n1827
XU484 AOI22S $PINS O=n1829 A1=n7 A2=n1814 B1=n1067 B2=n1813
XU485 AOI22S $PINS O=n1828 A1=n1821 A2=n1001 B1=n1820 B2=n1819
XU486 AN2 $PINS O=n1823 I1=n1021 I2=n1618
XU487 MOAI1S $PINS O=n1649 A1=n1648 A2=n1902 B1=n1067 B2=n1647
XU488 ND3 $PINS O=n1647 I1=n1646 I2=n1874 I3=n1645
XU490 OR2 $PINS O=n92 I1=n1013 I2=n1087
XU492 ND2 $PINS O=n1899 I1=n1076 I2=n1043
XU493 ND3 $PINS O=n1557 I1=n1278 I2=n1277 I3=n1276
XU494 OA22 $PINS O=n1278 A1=n1011 A2=n1271 B1=FE_DBTN219_n1475 B2=n1636
XU495 NR2 $PINS O=n1883 I1=n54 I2=FE_DBTN211_n1732
XU496 MOAI1S $PINS O=n1722 A1=n1721 A2=n1720 B1=n1719 B2=n1062
XU497 AN4B1S $PINS O=n1721 I1=FE_DBTN216_n87 I2=n1718 I3=n1874 B1=n1717
XU498 AOI22S $PINS O=n1809 A1=n1059 A2=n1799 B1=FE_DBTN218_n1108 B2=n105
XU499 ND3 $PINS O=n1799 I1=n34 I2=n1798 I3=n1797
XU500 MOAI1S $PINS O=n1291 A1=FE_DBTN224_n5 A2=n92 B1=n1060 B2=n1286
XU501 ND3 $PINS O=n1286 I1=n1543 I2=n1588 I3=n1621
XU502 ND3 $PINS O=n1790 I1=n1718 I2=n128 I3=FE_DBTN227_n1
XU503 MOAI1S $PINS O=n1501 A1=FE_DBTN225_n3 A2=FE_DBTN222_n7 B1=n1004 B2=n1045
XU504 OAI22S $PINS O=n1661 A1=n1660 A2=FE_DBTN222_n7 B1=n1659 B2=n1756
XU505 AN4B1S $PINS O=n1659 I1=n1658 I2=n1713 I3=n1657 B1=n52
XU506 AN4B1S $PINS O=n1660 I1=n1656 I2=n128 I3=n1655 B1=n1654
XU507 ND3 $PINS O=n1654 I1=n34 I2=n1883 I3=n1653
XU508 NR2 $PINS O=n1645 I1=n135 I2=n1560
XU509 AOI22S $PINS O=n1515 A1=n1062 A2=n3 B1=n105 B2=n1482
XU510 ND3 $PINS O=n1482 I1=n1834 I2=n1887 I3=n133
XU511 OA22 $PINS O=n1198 A1=n1186 A2=FE_DBTN223_n6 B1=n1185 B2=n1824
XU512 NR3 $PINS O=n1186 I1=n1183 I2=n1790 I3=n87
XU513 AN4B1S $PINS O=n1185 I1=n1184 I2=n1588 I3=n1413 B1=n417
XU514 ND3 $PINS O=n1183 I1=n1795 I2=n1811 I3=n1657
XU515 NR2 $PINS O=n1538 I1=FE_DBTN213_n94 I2=n1642
XU516 AOI22S $PINS O=n1347 A1=n62 A2=n1337 B1=n1053 B2=n1475
XU517 OA12 $PINS O=n1346 A1=n1340 B1=n1341 B2=FE_DBTN212_n1417
XU518 AN2 $PINS O=n1783 I1=n1374 I2=n1373
XU519 AOI22S $PINS O=n1374 A1=FE_DBTN214_n1831 A2=FE_DBTN209_n92 B1=n992 B2=n62
XU520 NR2 $PINS O=n1371 I1=n5 I2=n1045
XU521 NR2 $PINS O=n1610 I1=n253 I2=n54
XU522 AN2 $PINS O=n1498 I1=n1386 I2=n1385
XU523 AOI22S $PINS O=n1386 A1=n23 A2=FE_DBTN220_n1754 B1=n1016 B2=n1062
XU525 ND3 $PINS O=n1129 I1=n1128 I2=n1751 I3=n1127
XU526 OAI12HS $PINS O=n1127 A1=FE_DBTN220_n1754 B1=n52 B2=n1199
XU527 MOAI1S $PINS O=n1280 A1=n1669 A2=n1744 B1=n1064 B2=n1279
XU528 ND3 $PINS O=n1279 I1=n1586 I2=n34 I3=n1485
XU529 OAI222S $PINS O=n1578 A1=n1711 A2=FE_DBTN227_n1 B1=n1577 B2=n1822
+ C1=n1878 C2=n1718
XU530 AN4B1S $PINS O=n1577 I1=n1576 I2=n1903 I3=n1022 B1=n1575
XU531 OAI222S $PINS O=n1579 A1=n1574 A2=n1720 B1=n1573 B2=n1572 C1=n1571
+ C2=n1805
XU532 NR3 $PINS O=n1573 I1=n1566 I2=n1565 I3=n1564
XU533 NR3 $PINS O=n1571 I1=n1570 I2=n1569 I3=n1568
XU534 NR2 $PINS O=n1874 I1=n1293 I2=n1016
XU535 OA22 $PINS O=n1424 A1=n1460 A2=FE_DBTN212_n1417 B1=n1005 B2=n1636
XU536 OAI112HS $PINS O=n1558 A1=n1261 B1=n1260 C1=n1414 C2=n1466
XU537 OA22 $PINS O=n1260 A1=n1634 A2=n1259 B1=n17 B2=n1500
XU538 OA12 $PINS O=n1261 A1=n1363 B1=n1737 B2=n1873
XU539 NR2 $PINS O=n1791 I1=n1560 I2=FE_DBTN211_n1732
XU540 ND3 $PINS O=n1200 I1=n1463 I2=n1029 I3=n1726
XU541 INV1S $PINS O=n1056 I=n1744
XU542 AOI22S $PINS O=n1640 A1=n6 A2=n1639 B1=n1638 B2=n1853
XU543 NR2 $PINS O=n1757 I1=n119 I2=n2
XU544 AN4B1S $PINS O=n1298 I1=n1618 I2=n1646 I3=n1527 B1=FE_DBTN211_n1732
XU545 NR2 $PINS O=n1541 I1=n1638 I2=n1237
XU546 OA22 $PINS O=n1481 A1=n1471 A2=n1902 B1=n1634 B2=n1014
XU547 AN4B1S $PINS O=n1471 I1=n1832 I2=n1798 I3=n1470 B1=n23
XU548 INV1S $PINS O=n1054 I=n1666
XU549 NR2 $PINS O=n1475 I1=n1013 I2=n1167
XU550 NR2 $PINS O=n1184 I1=n256 I2=n2
XU551 NR2 $PINS O=n1500 I1=n1237 I2=n1593
XU552 INV1S $PINS O=n1039 I=n1167
XU553 MOAI1S $PINS O=n1723 A1=n1716 A2=n1902 B1=n1067 B2=n1715
XU554 AN4B1S $PINS O=n1716 I1=FE_DBTN225_n3 I2=n1713 I3=FE_DBTN216_n87 B1=n1712
XU555 ND3 $PINS O=n1715 I1=n997 I2=n1800 I3=n1714
XU556 INV1S $PINS O=n1035 I=n1087
XU557 NR3 $PINS O=n1084 I1=n1081 I2=n1850 I3=n1082
XU558 AN4B1S $PINS O=n1083 I1=n1372 I2=n1642 I3=n1028 B1=n1862
XU559 ND3 $PINS O=n1081 I1=n1460 I2=n1642 I3=n1032
XU560 OA22 $PINS O=n1703 A1=n1756 A2=n1884 B1=n1789 B2=FE_DBTN223_n6
XU561 NR2 $PINS O=n1370 I1=n1016 I2=n253
XU562 NR2 $PINS O=n1397 I1=n1593 I2=n1495
XU563 AN2 $PINS O=n1399 I1=n1396 I2=n1536
XU564 AN2 $PINS O=n1398 I1=n1668 I2=n1585
XU565 OAI22S $PINS O=n1290 A1=n1289 A2=n1824 B1=n1288 B2=n1756
XU566 AN4B1S $PINS O=n1288 I1=n1476 I2=n1319 I3=n1657 B1=n87
XU567 AN4B1S $PINS O=n1289 I1=n1287 I2=n1653 I3=n1798 B1=n419
XU568 NR2 $PINS O=n1394 I1=n1392 I2=FE_DBTN209_n92
XU569 NR2 $PINS O=n1393 I1=n418 I2=n1020
XU570 AN4B1S $PINS O=n1706 I1=n1010 I2=n1704 I3=n1703 B1=n1702
XU571 OAI222S $PINS O=n1724 A1=n1711 A2=FE_DBTN227_n1 B1=n1710 B2=n1709
+ C1=n1832 C2=FE_DBTN223_n6
XU572 INV1S $PINS O=n997 I=n1560
XU573 OAI22S $PINS O=n1403 A1=n1402 A2=n1720 B1=n1401 B2=n1902
XU574 AN4B1S $PINS O=n1402 I1=n1823 I2=n1795 I3=FE_DBTN225_n3 B1=n61
XU575 NR3 $PINS O=n1401 I1=n1400 I2=n994 I3=n121
XU576 ND3 $PINS O=n1400 I1=n1811 I2=n1899 I3=n1563
XU577 NR3 $PINS O=n1714 I1=n1023 I2=n1024 I3=n1293
XU578 ND3 $PINS O=n1162 I1=n1152 I2=n1151 I3=n1150
XU579 OA22 $PINS O=n1152 A1=n1826 A2=FE_DBTN225_n3 B1=FE_DBTN224_n5 B2=n1472
XU580 AOI22S $PINS O=n1151 A1=FE_DBTN210_n1878 A2=n1147 B1=n94 B2=n1146
XU581 ND3 $PINS O=n1624 I1=n1615 I2=n1751 I3=n1614
XU582 AOI22S $PINS O=n1614 A1=n62 A2=n1613 B1=n1067 B2=n1612
XU583 OR2 $PINS O=n1612 I1=n1611 I2=n54
XU584 AOI22S $PINS O=n1750 A1=FE_DBTN209_n92 A2=n1748 B1=n1064 B2=n1747
XU585 ND3 $PINS O=n1747 I1=FE_DBTN227_n1 I2=n1746 I3=n1745
XU586 OAI222S $PINS O=n1160 A1=n1159 A2=n1902 B1=n1158 B2=FE_DBTN222_n7
+ C1=n1157 C2=FE_DBTN223_n6
XU587 NR2 $PINS O=n1159 I1=n122 I2=n890
XU588 AN2 $PINS O=n1157 I1=n1527 I2=FE_DBTN225_n3
XU589 NR2 $PINS O=n1158 I1=n119 I2=n135
XU590 OAI222S $PINS O=n1310 A1=n34 A2=n1754 B1=FE_DBTN217_n1392 B2=n1736
+ C1=n1466 C2=n88
XU591 OAI222S $PINS O=n1842 A1=n1831 A2=n88 B1=n1019 B2=n1878
+ C1=FE_DBTN215_n1729 C2=n1830
XU592 OAI222S $PINS O=n1099 A1=n1873 A2=FE_DBTN217_n1392 B1=n1465 B2=n1634
+ C1=n1430 C2=n1736
XU593 MOAI1S $PINS O=n1478 A1=n1720 A2=n1645 B1=n1063 B2=n1477
XU594 ND3 $PINS O=n1477 I1=n1800 I2=n1527 I3=n137
XU595 MOAI1S $PINS O=n1228 A1=n1306 A2=FE_DBTN213_n94 B1=n1054 B2=n1227
XU596 NR2 $PINS O=n1795 I1=n890 I2=n54
XU597 MOAI1S $PINS O=n1507 A1=FE_DBTN213_n94 A2=n1258 B1=FE_DBTN220_n1754
+ B2=FE_DBTN218_n1108
XU598 ND3 $PINS O=n1294 I1=n1874 I2=n1396 I3=n1525
XU599 MOAI1S $PINS O=n1492 A1=n1637 A2=FE_DBTN217_n1392 B1=FE_DBTN210_n1878
+ B2=n1489
XU600 INV1S $PINS O=n1014 I=n1593
XU601 INV1S $PINS O=n1060 I=n1711
XU602 INV1S $PINS O=n1034 I=n1847
XU603 AN2 $PINS O=n1461 I1=n1743 I2=n1542
XU604 OAI22S $PINS O=n1880 A1=n1879 A2=n1878 B1=n1877 B2=FE_DBTN224_n5
XU605 NR2 $PINS O=n1877 I1=n1876 I2=n1039
XU606 AN4B1S $PINS O=n1879 I1=n1875 I2=n1899 I3=n1874 B1=n2
XU607 OAI222S $PINS O=n1469 A1=FE_DBTN212_n1417 A2=n1032 B1=n1540 B2=n1815
+ C1=n1464 C2=FE_DBTN215_n1729
XU608 AN4B1S $PINS O=n1464 I1=n1463 I2=n1029 I3=n1830 B1=n1462
XU609 ND3 $PINS O=n1462 I1=n1461 I2=n1460 I3=n1031
XU610 OAI222S $PINS O=n1534 A1=n1533 A2=n1709 B1=n1002 B2=n1831 C1=n1805
+ C2=n1671
XU611 INV1S $PINS O=n1002 I=n1532
XU612 ND3 $PINS O=n1528 I1=n1610 I2=n1527 I3=n1789
XU613 ND2 $PINS O=n1818 I1=n1697 I2=n1126
XU614 AOI22S $PINS O=n1242 A1=n1234 A2=n1233 B1=n1232 B2=n1532
XU615 ND3 $PINS O=n1233 I1=n1028 I2=n1372 I3=n1306
XU616 ND3 $PINS O=n1561 I1=n1618 I2=n1884 I3=n1789
XU617 ND2 $PINS O=n1636 I1=n1149 I2=n1697
XU618 INV1S $PINS O=n1023 I=n1396
XU620 ND3 $PINS O=n1822 I1=k_idx[3] I2=n118 I3=n1764
XU621 INV1S $PINS O=n1038 I=n1209
XU622 OAI222S $PINS O=n1145 A1=n1710 A2=n1818 B1=n1669 B2=n17 C1=n1824 C2=n1655
XU623 OAI112HS $PINS O=n1596 A1=n1594 B1=n1633 C1=n1595 C2=n1817
XU624 OAI12HS $PINS O=n1594 A1=n1056 B1=n1593 B2=n1819
XU625 MOAI1S $PINS O=n1502 A1=FE_DBTN213_n94 A2=n1032 B1=FE_DBTN209_n92
+ B2=n1057
XU626 MOAI1S $PINS O=n1702 A1=n1422 A2=FE_DBTN213_n94 B1=n5 B2=n1495
XU627 OA22 $PINS O=n1643 A1=FE_DBTN215_n1729 A2=n1642 B1=n1736 B2=n93
XU628 AOI22S $PINS O=n1644 A1=n37 A2=FE_DBTN209_n92 B1=n1056 B2=n1001
XU629 ND3 $PINS O=n1850 I1=n1463 I2=n1893 I3=n1461
XU630 OAI222S $PINS O=n1663 A1=n92 A2=n1837 B1=FE_DBTN224_n5 B2=n1005
+ C1=FE_DBTN216_n87 C2=FE_DBTN223_n6
XU631 ND2 $PINS O=n1466 I1=n1125 I2=n1097
XU632 OA22 $PINS O=n1479 A1=n1817 A2=n1595 B1=n1835 B2=n1476
XU633 NR2 $PINS O=n1483 I1=n1167 I2=n1043
XU634 ND2 $PINS O=n1709 I1=n1153 I2=n1097
XU635 OAI222S $PINS O=n1309 A1=n1308 A2=FE_DBTN215_n1729 B1=n1307
+ B2=FE_DBTN212_n1417 C1=FE_DBTN213_n94 C2=n1460
XU636 NR3 $PINS O=n1308 I1=n1304 I2=n1303 I3=n1302
XU637 AN4B1S $PINS O=n1307 I1=n1542 I2=n1306 I3=n1830 B1=n1305
XU638 ND3 $PINS O=n1304 I1=n1892 I2=n1029 I3=n1542
XU639 MOAI1S $PINS O=n1098 A1=FE_DBTN215_n1729 A2=n1892 B1=FE_DBTN220_n1754
+ B2=FE_DBTN218_n1108
XU640 INV1S $PINS O=n1058 I=n1837
XU641 AOI22S $PINS O=n1270 A1=n1059 A2=n54 B1=FE_DBTN209_n92
+ B2=FE_DBTN214_n1831
XU642 NR2 $PINS O=n1804 I1=n1016 I2=n1023
XU643 MOAI1S $PINS O=n1467 A1=n1541 A2=n1837 B1=n131 B2=FE_DBTN210_n1878
XU644 OA22 $PINS O=n1412 A1=n1666 A2=FE_DBTN219_n1475 B1=n1422
+ B2=FE_DBTN212_n1417
XU645 ND2 $PINS O=n1839 I1=n1764 I2=n1769
XU646 MOAI1S $PINS O=n1328 A1=n1327 A2=n1572 B1=n130 B2=n6
XU647 NR2 $PINS O=n1327 I1=n419 I2=n1569
XU648 OA22 $PINS O=n1808 A1=FE_DBTN215_n1729 A2=n1542 B1=FE_DBTN224_n5
+ B2=FE_DBTN217_n1392
XU650 ND3 $PINS O=n1388 I1=n1140 I2=n1519 I3=n1139
XU651 AOI22S $PINS O=n1140 A1=n1054 A2=n1237 B1=n6 B2=n1024
XU652 INV1S $PINS O=n1017 I=n1568
XU653 NR2 $PINS O=n1210 I1=n1041 I2=n1035
XU654 NR2 $PINS O=n1416 I1=n1593 I2=FE_DBTN209_n92
XU655 INV1S $PINS O=n1067 I=n1572
XU656 INV1S $PINS O=n1044 I=n1835
XU657 INV1S $PINS O=n1048 I=n1736
XU658 NR2 $PINS O=n1595 I1=n1638 I2=n1475
XU659 OA22 $PINS O=n1519 A1=FE_DBTN215_n1729 A2=n1463 B1=FE_DBTN212_n1417
+ B2=n1372
XU660 INV1S $PINS O=n1062 I=n1805
XU661 NR2 $PINS O=n1769 I1=n118 I2=n116
XU662 OAI22S $PINS O=n1622 A1=n1621 A2=n1839 B1=n1671 B2=n1620
XU663 MOAI1S $PINS O=n1607 A1=n1822 A2=n1718 B1=n1060 B2=n122
XU664 MOAI1S $PINS O=n1623 A1=n1619 A2=n1618 B1=n1062 B2=n1617
XU665 NR2 $PINS O=n1619 I1=n1063 I2=FE_DBTN210_n1878
XU666 INV1S $PINS O=n118 I=k_idx[4]
XU667 OR2 $PINS O=n1096 I1=FE_DBTN223_n6 I2=n1618
XU668 MOAI1S $PINS O=n1144 A1=n93 A2=n1666 B1=FE_DBTN209_n92 B2=n1057
XU669 AOI22S $PINS O=n1907 A1=FE_DBTN220_n1754 A2=n1882 B1=n1050 B2=n1039
XU670 MOAI1S $PINS O=n1608 A1=n1837 A2=n1014 B1=n256 B2=FE_DBTN210_n1878
XU671 INV1S $PINS O=n1059 I=n1902
XU672 INV1S $PINS O=n1065 I=n1720
XU674 AN2 $PINS O=n1153 I1=k_idx[3] I2=n1088
XU675 AN2 $PINS O=n1126 I1=n1088 I2=n116
XU676 ND3 $PINS O=n1231 I1=n1210 I2=n1209 I3=n1208
XU677 NR2 $PINS O=n1208 I1=n1890 I2=n1034
XU678 INV1S $PINS O=n1049 I=n1873
XU679 NR2 $PINS O=n1690 I1=n1900 I2=n1069
XU680 OA12 $PINS O=n1781 A1=n1070 B1=k_idx[4] B2=n116
XU681 NR2 $PINS O=n1890 I1=n97 I2=n1848
XU682 ND3 $PINS O=sign3[0] I1=n1846 I2=n1845 I3=n1844
XU683 AN4B1S $PINS O=n1845 I1=n1810 I2=n1809 I3=n1808 B1=n1807
XU684 NR3 $PINS O=n1844 I1=n1843 I2=n1842 I3=n1841
XU685 ND3 $PINS O=sign2[0] I1=n1763 I2=n1762 I3=n1761
XU686 NR3 $PINS O=n1762 I1=n1724 I2=n1723 I3=n1722
XU687 AN4B1S $PINS O=n1763 I1=n1708 I2=n1707 I3=n1706 B1=n1705
XU688 NR2 $PINS O=n1100 I1=FE_DBTN228_fold_n_2 I2=n_idx[1]
XU689 NR2 $PINS O=n1249 I1=n1776 I2=n1
XU690 NR3 $PINS O=n1248 I1=n1297 I2=n35 I3=n154
XU691 ND3 $PINS O=n1583 I1=n1888 I2=n1616 I3=n1250
XU692 AN2 $PINS O=n1250 I1=n1413 I2=n125
XU693 NR2 $PINS O=n1074 I1=n1900 I2=n_idx[1]
XU694 AN4B1S $PINS O=n1253 I1=n1396 I2=n1888 I3=FE_DBTN225_n3 B1=n1451
XU696 OAI222S $PINS O=n1326 A1=n1318 A2=n1805 B1=n1317 B2=n1720 C1=n1316
+ C2=n1822
XU697 AN4B1S $PINS O=n1318 I1=n1018 I2=n1874 I3=n1582 B1=n1315
XU698 AN4B1S $PINS O=n1317 I1=n1021 I2=n1447 I3=n1731 B1=n54
XU699 AN4B1S $PINS O=n1316 I1=n1396 I2=n1567 I3=n1447 B1=n1564
XU700 NR2 $PINS O=n1798 I1=n1776 I2=FE_DBTN218_n1108
XU701 OAI112HS $PINS O=n1118 A1=n1268 B1=n1141 C1=n1805 C2=n1282
XU702 NR2 $PINS O=n1305 I1=n1030 I2=n_idx[0]
XU703 AN2 $PINS O=n1520 I1=n1421 I2=n1420
XU704 AOI22S $PINS O=n1421 A1=n1418 A2=n1417 B1=n126 B2=FE_DBTN220_n1754
XU705 AOI22S $PINS O=n1420 A1=n1729 A2=n1419 B1=n105 B2=n121
XU706 ND3 $PINS O=n1419 I1=n1642 I2=n1027 I3=n1040
XU707 AN4B1S $PINS O=n1216 I1=n1207 I2=n1206 I3=n1205 B1=n1204
XU708 AOI22S $PINS O=n1207 A1=n1057 A2=n998 B1=n1495 B2=n1045
XU709 AOI22S $PINS O=n1205 A1=n1729 A2=n1200 B1=n1048 B2=FE_DBTN209_n92
XU710 AOI22S $PINS O=n1206 A1=FE_DBTN220_n1754 A2=n1199 B1=n1056 B2=n1392
XU711 OAI22S $PINS O=n1807 A1=n1894 A2=n128 B1=n1806 B2=n1805
XU712 ND3 $PINS O=n1803 I1=n1801 I2=FE_DBTN226_n2 I3=n1800
XU713 NR3 $PINS O=n1076 I1=n97 I2=FE_DBTN228_fold_n_2 I3=n138
XU714 ND3 $PINS O=sign1[0] I1=n1686 I2=n1685 I3=n1684
XU715 NR3 $PINS O=n1685 I1=n1663 I2=n1662 I3=n1661
XU716 NR3 $PINS O=n1686 I1=n1650 I2=n1785 I3=n1649
XU717 INV1S $PINS O=n138 I=n1775
XU718 NR2 $PINS O=n1638 I1=n1013 I2=n1870
XU719 OAI22S $PINS O=n1508 A1=n1432 A2=FE_DBTN223_n6 B1=n1431 B2=n1831
XU720 NR2 $PINS O=n1431 I1=n1638 I2=n1000
XU721 NR3 $PINS O=n1432 I1=n1429 I2=n126 I3=n1428
XU722 ND3 $PINS O=n1429 I1=n1899 I2=n1888 I3=n1718
XU723 NR2 $PINS O=n1544 I1=n121 I2=n1776
XU724 INV1S $PINS O=n128 I=n1776
XU725 INV1S $PINS O=n1013 I=n1857
XU726 AN4B1S $PINS O=n1086 I1=n1801 I2=n1616 I3=n1651 B1=n1560
XU727 ND3 $PINS O=n1884 I1=n1775 I2=FE_DBTN228_fold_n_2 I3=n1687
XU728 ND3 $PINS O=n1732 I1=n1100 I2=n1043 I3=n1775
XU729 AN2 $PINS O=n1122 I1=n1103 I2=n1043
XU730 OAI222S $PINS O=n1535 A1=n1531 A2=n1720 B1=n1530 B2=n1572 C1=n1529
+ C2=n1822
XU731 NR3 $PINS O=n1531 I1=n1526 I2=n1569 I3=n174
XU732 AN4B1S $PINS O=n1530 I1=n1567 I2=n1616 I3=n1618 B1=n1675
XU733 ND3 $PINS O=n1333 I1=n1757 I2=FE_DBTN216_n87 I3=n1331
XU734 NR3 $PINS O=n1331 I1=n994 I2=n1776 I3=n890
XU735 ND3 $PINS O=n1366 I1=n1336 I2=n1335 I3=n1334
XU736 AOI22S $PINS O=n1336 A1=n37 A2=n1004 B1=n1058 B2=n1012
XU737 AOI22S $PINS O=n1335 A1=n1064 A2=n1333 B1=n5 B2=n1332
XU738 ND3 $PINS O=n1875 I1=n1775 I2=n1100 I3=n_idx[0]
XU739 OAI222S $PINS O=n1292 A1=n1285 A2=n1572 B1=n125 B2=FE_DBTN223_n6 C1=n1284
+ C2=n1822
XU740 NR3 $PINS O=n1285 I1=n1283 I2=n154 I3=n1564
XU741 ND3 $PINS O=n1283 I1=n1567 I2=n1282 I3=n1812
XU742 ND3 $PINS O=n1527 I1=n1103 I2=FE_DBTN228_fold_n_2 I3=n1687
XU743 AOI22S $PINS O=n1196 A1=n1064 A2=n1192 B1=n1044 B2=n1191
XU744 ND3 $PINS O=n1191 I1=n133 I2=n1439 I3=n1544
XU745 ND3 $PINS O=n1192 I1=n1621 I2=n1543 I3=n1190
XU746 NR3 $PINS O=n1190 I1=n119 I2=n1776 I3=n419
XU747 OAI22S $PINS O=n1229 A1=n1225 A2=n1720 B1=n1224 B2=n1572
XU748 NR2 $PINS O=n1225 I1=n1564 I2=n1719
XU749 AN2 $PINS O=n1224 I1=FE_DBTN226_n2 I2=n1251
XU751 NR2 $PINS O=n1697 I1=_rom_k_idx_3_1 I2=n114
XU752 ND3 $PINS O=n1618 I1=n97 I2=FE_DBTN228_fold_n_2 I3=n1122
XU753 AN2 $PINS O=n1764 I1=n1768 I2=_rom_k_idx_3_1
XU754 AN2 $PINS O=n94 I1=n1865 I2=n100
XU756 AOI22S $PINS O=n1741 A1=n1054 A2=n998 B1=n1729 B2=n1728
XU757 ND3 $PINS O=n1728 I1=n1727 I2=n1726 I3=n1725
XU758 AN2 $PINS O=n1725 I1=n1892 I2=n1743
XU759 ND3 $PINS O=n1570 I1=n1567 I2=n1671 I3=n1800
XU760 ND3 $PINS O=n1446 I1=n1899 I2=n1888 I3=n1874
XU761 AN4B1S $PINS O=n1895 I1=n1893 I2=n1892 I3=n1891 B1=n1890
XU762 NR3 $PINS O=n1896 I1=n1889 I2=n122 I3=n337
XU763 ND3 $PINS O=n1889 I1=n1888 I2=n128 I3=n1887
XU764 ND3 $PINS O=sign3[1] I1=n1910 I2=n1909 I3=n1908
XU765 NR2 $PINS O=n1909 I1=n1881 I2=n1880
XU766 NR2 $PINS O=n1910 I1=n1868 I2=n1867
XU767 AN4B1S $PINS O=n1908 I1=n1907 I2=n1906 I3=n1905 B1=n1904
XU768 AOI22S $PINS O=n1112 A1=n1067 A2=n1105 B1=n1062 B2=n1104
XU769 INV1S $PINS O=n1016 I=n1282
XU770 ND3 $PINS O=n1711 I1=n1769 I2=n1061 I3=n15
XU771 OAI222S $PINS O=n1868 A1=n1861 A2=n17 B1=n1859 B2=n1858 C1=n1857 C2=n1856
XU772 AN2 $PINS O=n1861 I1=n1848 I2=n1847
XU773 NR2 $PINS O=n1859 I1=n1850 I2=n1849
XU774 AN2 $PINS O=n1856 I1=n1866 I2=n1897
XU775 NR2 $PINS O=n1097 I1=_rom_k_idx_3_1 I2=k_idx[2]
XU808 ND3 $PINS O=n1161 I1=n1008 I2=n1751 I3=n1156
XU809 AOI22S $PINS O=n1156 A1=n1417 A2=n1155 B1=n1638 B2=n1154
XU901 AOI22S $PINS O=n1380 A1=n1064 A2=n1377 B1=FE_DBTN210_n1878 B2=n1376
XU903 INV1S $PINS O=n1041 I=n1870
XU914 NR2 $PINS O=n1123 I1=n1044 I2=n1065
XU918 INV1S $PINS O=n1037 I=n1302
XU922 AN2 $PINS O=n1124 I1=n1656 I2=n1713
XU938 OA12 $PINS O=n1593 A1=n1857 B1=n1038 B2=n1039
XU946 AN2 $PINS O=n1786 I1=n1136 I2=n1135
XU953 AOI22S $PINS O=n1136 A1=n1729 A2=n1418 B1=n1 B2=n105
XU959 ND3 $PINS O=n1396 I1=n_idx[0] I2=n1100 I3=n1103
XU963 NR2 $PINS O=n1777 I1=_rom_k_idx_3_1 I2=n1069
XU964 OAI112HS $PINS O=n1778 A1=n1766 B1=n1765 C1=k_idx[2] C2=n1848
XU965 OA22 $PINS O=n1269 A1=n1170 A2=n1013 B1=n1031 B2=FE_DBTN213_n94
XU966 NR2 $PINS O=n1170 I1=n1169 I2=n1168
XU967 OAI222S $PINS O=n1168 A1=n1042 A2=n1736 B1=n1490 B2=n1847 C1=n1873
+ C2=n1870
XU969 OAI222S $PINS O=n1169 A1=n1047 A2=n1167 B1=n1166 B2=n1033 C1=n1210
+ C2=n1666
XU975 ND3 $PINS O=n1858 I1=n116 I2=n118 I3=n1106
XU992 ND2 $PINS O=n1837 I1=n1153 I2=n1688
XU997 ND3 $PINS O=n1894 I1=n1148 I2=n116 I3=n1102
XU1007 ND2 $PINS O=n1815 I1=n1149 I2=n1148
XU1012 ND3 $PINS O=n1878 I1=n15 I2=n116 I3=n1102
XU1014 ND3 $PINS O=n1572 I1=n15 I2=k_idx[3] I3=n1102
XU1015 ND3 $PINS O=n1215 I1=n1214 I2=n1340 I3=n1213
XU1016 ND3 $PINS O=n1214 I1=n1857 I2=n1231 I3=n37
XU1017 AOI22S $PINS O=n1213 A1=n94 A2=n1212 B1=FE_DBTN214_n1831 B2=n1211
XU1018 ND2 $PINS O=n1824 I1=n1107 I2=n1106
XU1020 ND3 $PINS O=n1835 I1=n1697 I2=n1061 I3=n1107
XU1021 OA12 $PINS O=n1891 A1=n100 B1=n1042 B2=n1043
XU1022 ND3 $PINS O=n1526 I1=n1567 I2=n1282 I3=FE_DBTN216_n87
XU1023 AOI22S $PINS O=n1217 A1=n1007 A2=n1852 B1=n1417 B2=n1862
XU1024 ND2 $PINS O=n1736 I1=n1149 I2=n1688
XU1025 ND3 $PINS O=n1805 I1=k_idx[3] I2=n118 I3=n1106
XU1026 NR2 $PINS O=n1125 I1=n1069 I2=n1061
XU1027 INV1S $PINS O=n116 I=k_idx[3]
XU1028 ND3 $PINS O=n1315 I1=n1903 I2=n1888 I3=n1718
XU1030 AOI22S $PINS O=n1906 A1=n105 A2=n1886 B1=n1065 B2=n1024
XU1031 ND3 $PINS O=n1756 I1=n1148 I2=n1061 I3=n1769
XU1033 OAI12HS $PINS O=n1779 A1=n1871 B1=n1061 B2=n1700
XU1034 ND3 $PINS O=n1701 I1=n1696 I2=n1695 I3=n1694
XU1035 ND3 $PINS O=n1696 I1=n1863 I2=n1069 I3=n1689
XU1036 ND3 $PINS O=n1695 I1=n1691 I2=n100 I3=n1690
XU1037 OA22 $PINS O=n1698 A1=n100 A2=n1697 B1=n1030 B2=n1769
XU1038 ND2 $PINS O=n1873 I1=n1125 I2=n1148
XU1040 ND3 $PINS O=n1902 I1=n1148 I2=n1061 I3=n1107
XU1042 ND3 $PINS O=n1720 I1=k_idx[3] I2=n1148 I3=n1102
XU1043 OAI112HS $PINS O=n1849 A1=n1042 B1=n100 C1=n1848 C2=n1043
XU1044 NR2 $PINS O=n1149 I1=n1070 I2=n1061
XU1045 NR2 $PINS O=n1088 I1=n1061 I2=k_idx[4]
XU1046 ND3 $PINS O=n1243 I1=n5 I2=n1231 I3=n1857
XU1048 ND3 $PINS O=n1766 I1=n1061 I2=_rom_k_idx_3_1 I3=n1890
XU1049 NR2 $PINS O=n1072 I1=n1042 I2=n_idx[4]
XU1050 NR2 $PINS O=n1075 I1=n1870 I2=n_idx[4]
XU1051 NR2 $PINS O=n1885 I1=n1030 I2=n_idx[4]
XU1052 INV1S $PINS O=n1036 I=n_idx[3]
XU1053 NR2 $PINS O=n1077 I1=n1847 I2=n_idx[4]
XU1054 NR2 $PINS O=n1071 I1=n1036 I2=n_idx[2]
XU1056 NR3 $PINS O=n1085 I1=n_idx[1] I2=n_idx[2] I3=n1043
XU1057 NR2 $PINS O=n1073 I1=n1087 I2=n_idx[4]
XU1058 NR2 $PINS O=n1775 I1=n_idx[4] I2=n_idx[3]
XU1059 NR2 $PINS O=n1857 I1=n_idx[0] I2=n_idx[4]
XU1060 NR2 $PINS O=n1103 I1=n1036 I2=n_idx[4]
XU1062 NR2 $PINS O=n1091 I1=n_idx[2] I2=n_idx[0]
XU1064 ND3 $PINS O=n1567 I1=n1103 I2=n_idx[2] I3=n1687
XU1065 NR2 $PINS O=n1080 I1=FE_DBTN228_fold_n_2 I2=n_idx[3]
XU1066 MOAI1S $PINS O=n1904 A1=n1903 A2=n1902 B1=n1060 B2=n1901
XU1067 OAI112HS $PINS O=n1901 A1=n1899 B1=n1898 C1=n_idx[4] C2=n1900
XU1068 ND3 $PINS O=n1282 I1=n_idx[1] I2=n_idx[2] I3=n1122
XU1069 MOAI1S $PINS O=n1867 A1=n1866 A2=n1900 B1=n1865 B2=n1864
XU1070 NR2 $PINS O=n1417 I1=n1858 I2=n_idx[4]
XU1071 AN2 $PINS O=n1106 I1=n1768 I2=k_idx[1]
XU1072 NR2 $PINS O=n1688 I1=k_idx[2] I2=k_idx[1]
XU1073 NR2 $PINS O=n1729 I1=n1894 I2=n_idx[4]
XU1074 OAI112HS $PINS O=n1881 A1=n1872 B1=n1871 C1=n_idx[3] C2=n1873
XU1075 OAI112HS $PINS O=n1774 A1=n1772 B1=n1771 C1=n1773 C2=n1863
XU1076 ND3 $PINS O=n1772 I1=n97 I2=FE_DBTN228_fold_n_2 I3=k_idx[0]
XU1077 AOI13HS $PINS O=n1771 A1=FE_DBTN220_n1754 B1=k_idx[1] B2=n1770 B3=n1769
XU1078 MOAI1S $PINS O=n1770 A1=n_idx[2] A2=n1768 B1=n1767 B2=n97
XU1079 NR2 $PINS O=n1768 I1=k_idx[2] I2=k_idx[0]
XU1080 AOI22S $PINS O=n1694 A1=n1693 A2=n1069 B1=n1885 B2=n1692
XU1081 MOAI1S $PINS O=n1693 A1=k_idx[1] A2=n1891 B1=n114 B2=n1849
XU1082 AOI13HS $PINS O=n1765 A1=n_idx[4] B1=n_idx[1] B2=n_idx[3] B3=n1764
XU1083 INV1S $PINS O=n1061 I=k_idx[0]
XU1084 INV1S $PINS O=n114 I=k_idx[2]
XU1085 OR2 $PINS O=n1863 I1=n_idx[2] I2=n1687
XU1086 NR2 $PINS O=n1102 I1=k_idx[4] I2=k_idx[0]
XU1087 AN2 $PINS O=n1689 I1=n_idx[3] I2=n1688
XU1088 MOAI1S $PINS O=n1691 A1=n1768 A2=_rom_k_idx_3_1 B1=k_idx[0] B2=k_idx[2]
XU46 AN4S $PINS O=n1648 I1=n1832 I2=n1656 I3=n1651 I4=n1658
.ENDS

.SUBCKT SNPS_CLOCK_GATE_HIGH_ROM_Wrapper_Even_0 EN ENCLK CLK
*.CONNECT net2309 EN
XFE_PHC933_net2312 DELC $PINS O=FE_PHN933_net2312 I=net2312
Xlatch QDBHN $PINS Q=net2312 D=net2309 CKB=CLK
Xmain_gate AN2T $PINS O=ENCLK I1=FE_PHN933_net2312 I2=CLK
.ENDS

.SUBCKT ROM_Wrapper_Even_0 rst_n en n_in[4] n_in[3] n_in[2] n_in[1] n_in[0]
+ k_idx[4] k_idx[3] k_idx[2] k_idx[1] k_idx[0] reg_sign1[1] reg_sign1[0]
+ reg_sign2[1] reg_sign2[0] reg_sign3[1] reg_sign3[0] reg_shift1[3]
+ reg_shift1[2] reg_shift1[1] reg_shift1[0] reg_shift2[3] reg_shift2[2]
+ reg_shift2[1] reg_shift2[0] reg_shift3[3] reg_shift3[2] reg_shift3[1]
+ reg_shift3[0] _rom_k_idx_3_1 i_rst_n FE_OFN24_i_rst_n clk
*.CONNECT N4 n_in[0]
XFE_RC_443_0 INV2 $PINS O=N2 I=FE_RN_231_0
XFE_RC_442_0 OAI13HS $PINS O=FE_RN_231_0 A1=n_in[4] B1=n_in[1] B2=n_in[0]
+ B3=n15
XCTS_ccl_a_INV_CLK_G1_L8_103 INV4CK $PINS O=CTS_10 I=CTS_11
XCTS_ccl_a_INV_CLK_G1_L7_103 INV2CK $PINS O=CTS_11 I=CTS_12
Xreg_sign1_reg[1] DFFSBN $PINS Q=reg_sign1[1] D=raw_s1[1] CK=CTS_10
+ SB=FE_OFN24_i_rst_n
Xreg_sign2_reg[1] DFFSBN $PINS Q=reg_sign2[1] D=raw_s2[1] CK=CTS_10
+ SB=FE_OFN24_i_rst_n
Xreg_sign3_reg[1] DFFSBN $PINS Q=reg_sign3[1] D=raw_s3[1] CK=CTS_10
+ SB=FE_OFN24_i_rst_n
Xreg_sign2_reg[0] QDFFRBP $PINS Q=reg_sign2[0] D=final_s2[0] CK=CTS_10
+ RB=i_rst_n
Xreg_sign3_reg[0] QDFFRBN $PINS Q=reg_sign3[0] D=final_s3[0] CK=CTS_10
+ RB=i_rst_n
Xreg_sign1_reg[0] QDFFRBN $PINS Q=reg_sign1[0] D=final_s1[0] CK=CTS_10
+ RB=i_rst_n
Xreg_shift1_reg[1] QDFFRBN $PINS Q=reg_shift1[1] D=raw_h1[1] CK=CTS_10
+ RB=FE_OFN24_i_rst_n
Xreg_shift3_reg[1] QDFFRBN $PINS Q=reg_shift3[1] D=raw_h3[1] CK=CTS_10
+ RB=i_rst_n
Xreg_shift3_reg[3] QDFFRBN $PINS Q=reg_shift3[3] D=raw_h3[3] CK=CTS_10
+ RB=i_rst_n
Xreg_shift3_reg[2] QDFFRBN $PINS Q=reg_shift3[2] D=raw_h3[2] CK=CTS_10
+ RB=i_rst_n
Xreg_shift3_reg[0] QDFFRBN $PINS Q=reg_shift3[0] D=raw_h3[0] CK=CTS_10
+ RB=i_rst_n
Xreg_shift1_reg[0] QDFFRBN $PINS Q=reg_shift1[0] D=raw_h1[0] CK=CTS_10
+ RB=i_rst_n
Xreg_shift2_reg[3] QDFFRBN $PINS Q=reg_shift2[3] D=raw_h2[3] CK=CTS_10
+ RB=i_rst_n
Xreg_shift2_reg[2] QDFFRBT $PINS Q=reg_shift2[2] D=raw_h2[2] CK=CTS_10
+ RB=i_rst_n
Xreg_shift2_reg[0] QDFFRBN $PINS Q=reg_shift2[0] D=raw_h2[0] CK=CTS_10
+ RB=i_rst_n
Xreg_shift1_reg[2] QDFFRBN $PINS Q=reg_shift1[2] D=raw_h1[2] CK=CTS_10
+ RB=i_rst_n
Xreg_shift2_reg[1] QDFFRBN $PINS Q=reg_shift2[1] D=raw_h2[1] CK=CTS_10
+ RB=i_rst_n
XU3 NR2 $PINS O=sub_79/carry[2] I1=N4 I2=n_in[1]
XU8 XNR2HS $PINS O=final_s3[0] I1=raw_s3[0] I2=n10
XU9 XNR2HS $PINS O=final_s2[0] I1=raw_s2[0] I2=n10
XU10 XNR2HS $PINS O=final_s1[0] I1=raw_s1[0] I2=n10
XU11 MOAI1 $PINS O=fold_n[1] A1=n9 A2=N2 B1=N5 B2=N2
XU12 INV1S $PINS O=n9 I=n_in[1]
XU13 INV1S $PINS O=n14 I=N4
XU14 MOAI1 $PINS O=fold_n[0] A1=n14 A2=N2 B1=N4 B2=N2
XU16 ND3 $PINS O=n10 I1=N2 I2=n11 I3=k_idx[0]
XU17 ND3 $PINS O=n11 I1=k_idx[4] I2=k_idx[3] I3=n12
XU18 AN2 $PINS O=n12 I1=k_idx[2] I2=k_idx[1]
XU20 MOAI1 $PINS O=fold_n[2] A1=n13 A2=N2 B1=N6 B2=N2
XU21 MOAI1 $PINS O=fold_n[3] A1=n7 A2=N2 B1=N7 B2=N2
XU22 INV1S $PINS O=n13 I=n_in[2]
XU23 INV1S $PINS O=n7 I=n_in[3]
XU24 MOAI1 $PINS O=fold_n[4] A1=n8 A2=N2 B1=N8 B2=N2
XU25 INV1S $PINS O=n8 I=n_in[4]
XU27 XOR2HS $PINS O=N8 I1=n8 I2=sub_79/carry[4]
XU28 AN2 $PINS O=sub_79/carry[4] I1=sub_79/carry[3] I2=n7
XU29 XOR2HS $PINS O=N7 I1=n7 I2=sub_79/carry[3]
XU30 AN2 $PINS O=sub_79/carry[3] I1=sub_79/carry[2] I2=n13
XU31 XOR2HS $PINS O=N6 I1=n13 I2=sub_79/carry[2]
XU32 XOR2HS $PINS O=N5 I1=n9 I2=n14
XU33 OR2 $PINS O=n15 I1=n_in[3] I2=n_in[2]
Xrom_inst CSD_ROM_Table_even_0 $PINS n_idx[4]=fold_n[4] n_idx[3]=fold_n[3]
+ n_idx[2]=fold_n[2] n_idx[1]=fold_n[1] n_idx[0]=fold_n[0] k_idx[4]=k_idx[4]
+ k_idx[3]=k_idx[3] k_idx[2]=k_idx[2] k_idx[1]=k_idx[1] k_idx[0]=k_idx[0]
+ sign1[1]=raw_s1[1] sign1[0]=raw_s1[0] shift1[3]=raw_h1[3] shift1[2]=raw_h1[2]
+ shift1[1]=raw_h1[1] shift1[0]=raw_h1[0] sign2[1]=raw_s2[1] sign2[0]=raw_s2[0]
+ shift2[3]=raw_h2[3] shift2[2]=raw_h2[2] shift2[1]=raw_h2[1] shift2[0]=raw_h2[0]
+ sign3[1]=raw_s3[1] sign3[0]=raw_s3[0] shift3[3]=raw_h3[3] shift3[2]=raw_h3[2]
+ shift3[1]=raw_h3[1] shift3[0]=raw_h3[0] _rom_k_idx_3_1=_rom_k_idx_3_1
Xclk_gate_reg_shift1_reg SNPS_CLOCK_GATE_HIGH_ROM_Wrapper_Even_0 $PINS EN=en
+ ENCLK=CTS_12 CLK=clk
Xreg_shift1_reg[3] QDFFRBN $PINS Q=reg_shift1[3] D=raw_h1[3] CK=CTS_10
+ RB=FE_OFN24_i_rst_n
.ENDS

.SUBCKT CSD_ROM_Table_odd_0 n_idx[4] n_idx[3] n_idx[2] n_idx[1] n_idx[0]
+ k_idx[4] k_idx[3] k_idx[2] k_idx[1] k_idx[0] sign1[1] sign1[0] shift1[3]
+ shift1[2] shift1[1] shift1[0] sign2[1] sign2[0] shift2[3] shift2[2] shift2[1]
+ shift2[0] sign3[1] sign3[0] shift3[3] shift3[2] shift3[1] shift3[0]
+ _rom_k_idx_3_1
XFE_OFC262_n1790 INV1S $PINS O=FE_OFN170_n1790 I=n1790
XFE_OFC261_n1790 BUF1 $PINS O=n962 I=n1790
XFE_OFC238_fold_n_1 INV1S $PINS O=FE_OFN162_fold_n_1 I=n978
XFE_OFC237_fold_n_1 BUF1 $PINS O=n978 I=n_idx[1]
XFE_OFC232_n1532 INV1S $PINS O=FE_OFN159_n1532 I=n940
XFE_OFC231_n1532 INV1S $PINS O=n940 I=n1532
XFE_OFC193_n1683 INV2 $PINS O=n974 I=n1683
XFE_OFC135_n1739 INV1S $PINS O=FE_OFN117_n1739 I=n946
XFE_OFC134_n1739 INV1S $PINS O=n946 I=n1739
XFE_OFC133_fold_n_3 INV1S $PINS O=n1 I=n_idx[3]
XFE_DBTC208_fold_n_0 INV1S $PINS O=FE_DBTN208_fold_n_0 I=n_idx[0]
XFE_DBTC207_n3 INV1S $PINS O=FE_DBTN207_n3 I=n3
XFE_DBTC206_n4 INV1S $PINS O=FE_DBTN206_n4 I=n4
XFE_DBTC205_n5 INV1S $PINS O=FE_DBTN205_n5 I=n5
XFE_DBTC204_n1199 INV1S $PINS O=FE_DBTN204_n1199 I=n1199
XFE_DBTC203_n1500 INV1S $PINS O=FE_DBTN203_n1500 I=n1500
XFE_DBTC202_n1582 INV1S $PINS O=FE_DBTN202_n1582 I=n1582
XFE_DBTC201_n1719 INV1S $PINS O=FE_DBTN201_n1719 I=n1719
XFE_DBTC200_n1435 INV1S $PINS O=FE_DBTN200_n1435 I=n1435
XFE_DBTC199_n1296 INV1S $PINS O=FE_DBTN199_n1296 I=n1296
XFE_DBTC198_n1745 INV1S $PINS O=FE_DBTN198_n1745 I=n1745
XFE_DBTC197_n85 INV1S $PINS O=FE_DBTN197_n85 I=n85
XFE_DBTC196_n86 INV1S $PINS O=FE_DBTN196_n86 I=n86
XFE_DBTC195_n84 INV1S $PINS O=FE_DBTN195_n84 I=n84
XFE_DBTC194_n1787 INV1S $PINS O=FE_DBTN194_n1787 I=n1787
XFE_DBTC193_n1457 INV1S $PINS O=FE_DBTN193_n1457 I=n1457
XFE_DBTC192_n81 INV1S $PINS O=FE_DBTN192_n81 I=n81
XFE_DBTC191_n1639 INV1S $PINS O=FE_DBTN191_n1639 I=n1639
XU728 ND2 $PINS O=sign3[1] I1=n1802 I2=n1801
XU729 AO112 $PINS O=n1794 A1=n974 B1=n1792 C1=n1793 C2=n1
XU730 OA222 $PINS O=n1798 A1=n1789 A2=n1788 B1=n1787 B2=n1786 C1=n1785 C2=n1784
XU731 AN3B2S $PINS O=n1781 I1=n1779 B1=n996 B2=n1000
XU732 OA222 $PINS O=n1799 A1=n1769 A2=n1768 B1=n1767 B2=n1766 C1=n1765 C2=n1764
XU733 OA222 $PINS O=n1800 A1=n1762 A2=n1761 B1=n1760 B2=n1759 C1=n1758 C2=n1757
XU736 ND2 $PINS O=n1771 I1=n1759 I2=n1721
XU737 ND2 $PINS O=n1689 I1=n1688 I2=n1702
XU738 ND2 $PINS O=n1685 I1=n1684 I2=n1683
XU739 ND2 $PINS O=n1686 I1=n1795 I2=n1682
XU740 ND2 $PINS O=n1680 I1=n1679 I2=n934
XU742 OA222 $PINS O=n1707 A1=n1675 A2=n1674 B1=n1673 B2=n1672 C1=n1671 C2=n1670
XU743 OA222 $PINS O=n1650 A1=n992 A2=n965 B1=n_idx[3] B2=n1649 C1=n979 C2=n966
XU744 OA112 $PINS O=n1643 A1=n1632 B1=n1631 C1=n1633 C2=n118
XU745 AO12 $PINS O=n1631 A1=n1629 B1=n1761 B2=n1630
XU746 AN3B2S $PINS O=n1783 I1=n1619 B1=n994 B2=n1004
XU747 OA222 $PINS O=n1603 A1=n1602 A2=n1759 B1=n1601 B2=n1670 C1=n1600 C2=n1674
XU748 AO12 $PINS O=n1586 A1=n1696 B1=FE_DBTN203_n1500 B2=FE_DBTN191_n1639
XU749 ND2 $PINS O=n1585 I1=n1583 I2=n1582
XU750 OA112 $PINS O=n1594 A1=n1574 B1=n1573 C1=n1761 C2=n94
XU751 AO12 $PINS O=n1569 A1=n1752 B1=n993 B2=n1565
XU752 ND2 $PINS O=n1557 I1=n979 I2=n103
XU753 OA222 $PINS O=n1544 A1=n1539 A2=n1682 B1=n1538 B2=n1773 C1=n1537 C2=n1674
XU754 OA222 $PINS O=n1545 A1=n1535 A2=n1732 B1=n1534 B2=n1721 C1=n1533 C2=n1670
XU755 OA222 $PINS O=n1550 A1=n1629 A2=n1524 B1=n1523 B2=FE_DBTN193_n1457
+ C1=n1522 C2=n114
XU756 OA112 $PINS O=n1506 A1=n1505 B1=n1504 C1=n1746 C2=n125
XU757 ND2 $PINS O=n1499 I1=n1513 I2=n1735
XU758 ND2 $PINS O=n1501 I1=n95 I2=n84
XU759 ND2 $PINS O=n1498 I1=n1723 I2=n86
XU760 AN3 $PINS O=n1660 I1=n1496 I2=n1495 I3=n1494
XU761 OA222 $PINS O=n1495 A1=n1489 A2=n1746 B1=n959 B2=n129 C1=n962
+ C2=FE_DBTN203_n1500
XU762 OA222 $PINS O=n1496 A1=n94 A2=n1576 B1=n85 B2=n95 C1=n1488 C2=n86
XU763 ND2 $PINS O=n1509 I1=n1715 I2=n1005
XU764 ND2 $PINS O=n1485 I1=n4 I2=n118
XU765 OA222 $PINS O=n1483 A1=n1636 A2=n1528 B1=n1477 B2=FE_DBTN191_n1639 C1=n3
+ C2=n1476
XU767 OA222 $PINS O=n1484 A1=n1735 A2=n129 B1=n1474 B2=n1665 C1=n131 C2=n1677
XU768 OA222 $PINS O=n1595 A1=n1768 A2=n118 B1=n1462 B2=n1461 C1=n1732 C2=n123
XU769 OA222 $PINS O=n1452 A1=n1778 A2=n959 B1=n1447 B2=n1674 C1=n1446 C2=n1445
XU770 OA222 $PINS O=n1453 A1=n1444 A2=n1670 B1=n1443 B2=n1672 C1=n1442 C2=n1721
XU771 OA222 $PINS O=n1472 A1=FE_DBTN194_n1787 A2=n1437 B1=n1436 B2=n121
+ C1=n1435 C2=n114
XU772 OA222 $PINS O=n1427 A1=n1424 A2=n1672 B1=n1423 B2=n1773 C1=n1422 C2=n1690
XU773 OA222 $PINS O=n1429 A1=FE_DBTN203_n1500 A2=n1699 B1=n1735 B2=n224 C1=n131
+ C2=n1700
XU774 OA222 $PINS O=n1430 A1=n1761 A2=n114 B1=FE_DBTN191_n1639 B2=n84 C1=n1420
+ C2=FE_DBTN193_n1457
XU775 OA222 $PINS O=n1431 A1=n1419 A2=n1629 B1=n1768 B2=n118 C1=n1745 C2=n93
XU776 OR3B2 $PINS O=n1411 I1=n1408 B1=n1407 B2=n1406
XU777 AO222 $PINS O=n1399 A1=n34 A2=n1584 B1=n1398 B2=n101 C1=n1714 C2=n1397
XU778 AO222 $PINS O=n1398 A1=n980 A2=n1395 B1=n26 B2=n1394 C1=n988 C2=n1393
XU779 OA222 $PINS O=n1400 A1=n129 A2=n3 B1=n1624 B2=n122 C1=n1390 C2=n224
XU780 AN3B2S $PINS O=n1390 I1=n1425 B1=n1389 B2=n618
XU781 OA222 $PINS O=n1401 A1=n1607 A2=n121 B1=n1388 B2=FE_DBTN203_n1500 C1=n741
+ C2=FE_DBTN193_n1457
XU782 OA222 $PINS O=n1402 A1=n1768 A2=n4 B1=n1745 B2=n114 C1=n87
+ C2=FE_DBTN205_n5
XU783 ND2 $PINS O=n1417 I1=n1378 I2=n1377
XU784 ND2 $PINS O=n1375 I1=n1678 I2=n1699
XU785 ND2 $PINS O=n1376 I1=n1668 I2=n971
XU786 OA112 $PINS O=n1385 A1=n1596 B1=n1480 C1=n86 C2=n1719
XU787 OA112 $PINS O=n1596 A1=n1371 B1=n1370 C1=n1462 C2=n1582
XU788 AN3B2S $PINS O=n1405 I1=n1368 B1=n1367 B2=n1366
XU789 AO222 $PINS O=n1352 A1=n26 A2=n1351 B1=n984 B2=FE_DBTN204_n1199 C1=n988
+ C2=n1350
XU791 OA222 $PINS O=n1353 A1=n1540 A2=n1445 B1=n1346 B2=n1721 C1=n1345 C2=n1674
XU792 OA222 $PINS O=n1354 A1=n1343 A2=n1773 B1=n1342 B2=n1670 C1=n1341 C2=n1732
XU793 OA222 $PINS O=n1358 A1=n1734 A2=n93 B1=n1340 B2=n1339 C1=n1338 C2=n86
XU794 OA222 $PINS O=n1359 A1=n1337 A2=n121 B1=n740 B2=FE_DBTN191_n1639 C1=n1336
+ C2=FE_DBTN193_n1457
XU795 OA112 $PINS O=n1362 A1=n1662 B1=n1332 C1=n125 C2=n1445
XU796 OA222 $PINS O=n1332 A1=n1629 A2=n1461 B1=n1331 B2=n1437 C1=n1415 C2=n1330
XU797 ND2 $PINS O=n1379 I1=n1329 I2=n1328
XU798 ND2 $PINS O=n1326 I1=FE_DBTN205_n5 I2=n1746
XU799 OA112 $PINS O=n1468 A1=n1413 B1=n1324 C1=n1782 C2=n94
XU801 ND2 $PINS O=n1369 I1=n1321 I2=n1320
XU802 OA222 $PINS O=n1320 A1=n1718 A2=FE_DBTN205_n5 B1=n1319 B2=n1488 C1=n1318
+ C2=n1576
XU803 OA222 $PINS O=n1321 A1=n4 A2=n1461 B1=n85 B2=n1528 C1=n1746 C2=n1710
XU806 ND2 $PINS O=n1305 I1=FE_DBTN191_n1639 I2=n1476
XU807 AN3B2S $PINS O=n1311 I1=n1303 B1=n1302 B2=n1409
XU808 OA112 $PINS O=n1299 A1=n1384 B1=n1298 C1=n1782 C2=n114
XU809 OA222 $PINS O=n1384 A1=FE_DBTN191_n1639 A2=n1791 B1=n131 B2=n95 C1=n1330
+ C2=n86
XU810 OA222 $PINS O=n1287 A1=n1319 A2=FE_DBTN205_n5 B1=n1488 B2=n1462 C1=n1425
+ C2=FE_DBTN193_n1457
XU811 OA112 $PINS O=n1258 A1=n1256 B1=n1255 C1=n1257 C2=n362
XU812 ND2 $PINS O=n1476 I1=n26 I2=n101
XU813 ND2 $PINS O=n1254 I1=n121 I2=n1636
XU814 ND2 $PINS O=n1636 I1=n988 I2=n101
XU815 OA112 $PINS O=n1407 A1=n1251 B1=n1250 C1=n1782 C2=n81
XU816 AN3 $PINS O=n1469 I1=n1248 I2=n1247 I3=n1246
XU817 OA112 $PINS O=n1246 A1=n127 B1=n1245 C1=n1374 C2=n1665
XU818 OA222 $PINS O=n1239 A1=n_idx[4] A2=n1236 B1=n1235 B2=n362 C1=n1462
+ C2=FE_DBTN205_n5
XU819 ND2 $PINS O=n1462 I1=n1787 I2=n1234
XU820 OA222 $PINS O=n1236 A1=n370 A2=n1672 B1=n1233 B2=n1690 C1=n1232 C2=n1773
XU821 OA222 $PINS O=n1240 A1=n1723 A2=n1582 B1=n1229 B2=n114 C1=n1228 C2=n121
XU822 OA222 $PINS O=n1241 A1=n122 A2=n1791 B1=n1630 B2=n4 C1=n1635
+ C2=FE_DBTN193_n1457
XU823 ND2 $PINS O=n1421 I1=n1688 I2=n1699
XU824 AO222 $PINS O=n1227 A1=n1529 A2=n1579 B1=n1223 B2=n1473 C1=n1222 C2=n1500
XU825 AN3B2S $PINS O=n1244 I1=n1406 B1=n1218 B2=n1217
XU826 OR3B2 $PINS O=n1218 I1=n1366 B1=n1294 B2=n1216
XU827 OA112 $PINS O=n1209 A1=n1208 B1=n1207 C1=n1782 C2=n87
XU828 ND2 $PINS O=n1206 I1=n1699 I2=n1475
XU832 OA222 $PINS O=n1215 A1=n1296 A2=n87 B1=n1735 B2=n129 C1=n1331 C2=n1437
XU834 ND2 $PINS O=n1632 I1=n1333 I2=n1004
XU835 ND2 $PINS O=n1190 I1=n1224 I2=n81
XU837 ND2 $PINS O=n1185 I1=n999 I2=n1234
XU838 ND2 $PINS O=n1186 I1=n1004 I2=n1184
XU839 OR3 $PINS O=n1395 I1=n1666 I2=n968 I3=n939
XU841 AO222 $PINS O=n1179 A1=n985 A2=n1176 B1=n986 B2=n1175 C1=n987 C2=n1174
XU842 AN3B2S $PINS O=n1341 I1=n1280 B1=n935 B2=n938
XU843 OA222 $PINS O=n1181 A1=n1280 A2=n1757 B1=n1173 B2=n1172 C1=n1171 C2=n1682
XU845 AN3 $PINS O=n1436 I1=n1696 I2=n946 I3=n1446
XU846 AO222 $PINS O=n1167 A1=n1168 A2=n1457 B1=n1165 B2=n1639 C1=n1164 C2=n1516
XU847 OR3 $PINS O=n1168 I1=n1164 I2=n1610 I3=n969
XU848 AN3B2S $PINS O=n1336 I1=n1220 B1=n1274 B2=n948
XU849 ND2 $PINS O=n1711 I1=n1224 I2=n87
XU850 OA222 $PINS O=n1316 A1=n87 A2=n1435 B1=n1419 B2=n86 C1=n1682 C2=n125
XU851 ND2 $PINS O=n1148 I1=n1701 I2=n1581
XU852 ND2 $PINS O=n1149 I1=n1147 I2=n1664
XU853 AO12 $PINS O=n1152 A1=FE_DBTN193_n1457 B1=n1387 B2=n1611
XU854 OA222 $PINS O=n1154 A1=n1629 A2=n1640 B1=n1146 B2=n1437 C1=n_idx[4]
+ C2=n1145
XU855 OA222 $PINS O=n1145 A1=n1144 A2=n1672 B1=n1143 B2=n1690 C1=n1142 C2=n1773
XU856 ND2 $PINS O=n1584 I1=n4 I2=n81
XU857 OA222 $PINS O=n1155 A1=n1779 A2=n118 B1=n1141 B2=n129 C1=n1526 C2=n114
XU858 OA222 $PINS O=n1156 A1=n1140 A2=n224 B1=n592 B2=n362 C1=n1139 C2=n122
XU859 ND2 $PINS O=n1521 I1=FE_OFN159_n1532 I2=n962
XU860 ND2 $PINS O=n1638 I1=n3 I2=n1699
XU861 AN3 $PINS O=n1216 I1=n1126 I2=n1125 I3=n1124
XU862 OA112 $PINS O=n1124 A1=n1317 B1=n1123 C1=n1746 C2=n87
XU863 ND2 $PINS O=n1304 I1=n94 I2=n114
XU865 AN3 $PINS O=n1271 I1=n1122 I2=n1121 I3=n1120
XU866 OA222 $PINS O=n1118 A1=n1115 A2=n87 B1=n1114 B2=n221 C1=n1113 C2=n130
XU867 ND2 $PINS O=n1519 I1=n1419 I2=n1112
XU868 ND2 $PINS O=n1111 I1=n1512 I2=n81
XU870 ND2 $PINS O=n1107 I1=FE_DBTN201_n1719 I2=FE_DBTN196_n86
XU871 ND2 $PINS O=n1775 I1=n1690 I2=n1445
XU872 ND2 $PINS O=n1085 I1=n1455 I2=n1684
XU874 OR3 $PINS O=n1101 I1=n1292 I2=n1410 I3=n1084
XU875 OA112 $PINS O=n1081 A1=n1662 B1=n1252 C1=n1768 C2=n87
XU876 OA13S $PINS O=n1082 A1=n1256 B1=n1349 B2=n_idx[4] B3=n1773
XU877 ND2 $PINS O=n1437 I1=n1080 I2=n1556
XU878 OA222 $PINS O=n1465 A1=n123 A2=n1674 B1=FE_DBTN205_n5 B2=n114 C1=n1724
+ C2=n4
XU879 ND2 $PINS O=n1724 I1=n1074 I2=n1073
XU881 OA222 $PINS O=n1078 A1=n95 A2=n224 B1=n1536 B2=FE_DBTN203_n1500 C1=n362
+ C2=n1683
XU882 OA222 $PINS O=n1079 A1=n1699 A2=FE_DBTN193_n1457 B1=n131 B2=n959 C1=n1581
+ C2=FE_DBTN191_n1639
XU883 OA222 $PINS O=n1104 A1=n1575 A2=n1582 B1=n1734 B2=n87 C1=n1718 C2=n1782
XU884 ND2 $PINS O=n1371 I1=n1009 I2=n1333
XU885 ND2 $PINS O=n1795 I1=n1555 I2=n1059
XU886 ND2 $PINS O=n1754 I1=n1678 I2=n1475
XU887 ND2 $PINS O=n1274 I1=n1611 I2=n3
XU889 ND2 $PINS O=n1682 I1=n1055 I2=n1568
XU890 OA222 $PINS O=n1064 A1=n1054 A2=n129 B1=n1053 B2=n130 C1=n131 C2=n1683
XU891 ND2 $PINS O=n1757 I1=n1055 I2=n1052
XU892 ND2 $PINS O=n1598 I1=n1612 I2=n1669
XU894 OR3 $PINS O=n1051 I1=n1676 I2=n957 I3=n1597
XU898 ND2 $PINS O=n1445 I1=n1072 I2=n1555
XU899 OR3B2 $PINS O=n1045 I1=n1110 B1=n1634 B2=n1044
XU900 ND2 $PINS O=n1069 I1=n1740 I2=n1043
XU901 ND2 $PINS O=n1110 I1=n1188 I2=n1572
XU902 ND2 $PINS O=n1572 I1=n1740 I2=n777
XU905 ND2 $PINS O=n1710 I1=n1566 I2=n_idx[4]
XU907 ND2 $PINS O=n1084 I1=n1042 I2=n1041
XU908 ND2 $PINS O=n1330 I1=n1556 I2=n1059
XU909 ND2 $PINS O=n1389 I1=n1510 I2=n84
XU912 ND2 $PINS O=n1030 I1=n1581 I2=n1700
XU914 ND2 $PINS O=n1031 I1=n1220 I2=n1683
XU915 ND2 $PINS O=n1607 I1=n1029 I2=n1565
XU920 OA222 $PINS O=n1039 A1=n1027 A2=n1112 B1=n1026 B2=n4 C1=n1025 C2=n94
XU921 ND2 $PINS O=n1745 I1=n1056 I2=n1556
XU922 ND2 $PINS O=n1719 I1=n1024 I2=n1556
XU923 ND2 $PINS O=n1112 I1=n1052 I2=n1073
XU924 ND2 $PINS O=n1296 I1=n1568 I2=n1556
XU925 ND2 $PINS O=n1461 I1=n1072 I2=n1556
XU927 ND2 $PINS O=n1784 I1=n1055 I2=n1059
XU930 ND2 $PINS O=n1488 I1=n1080 I2=n1073
XU934 ND2 $PINS O=n1772 I1=n1080 I2=n1555
XU936 ND2 $PINS O=n1017 I1=n1787 I2=n1184
XU937 AN3 $PINS O=n1015 I1=n945 I2=n1763 I3=n1736
XU938 ND2 $PINS O=n1582 I1=n1073 I2=n1059
XU939 ND2 $PINS O=n1653 I1=k_idx[4] I2=k_idx[3]
XU941 ND2 $PINS O=n1160 I1=n1340 I2=n1634
XU942 ND2 $PINS O=n1764 I1=n1028 I2=FE_OFN162_fold_n_1
XU944 ND2 $PINS O=n1763 I1=n1050 I2=FE_OFN162_fold_n_1
XU945 OA222 $PINS O=n1295 A1=n121 A2=n3 B1=n122 B2=n1528 C1=n1732 C2=n123
XU949 ND2 $PINS O=n1670 I1=n1074 I2=n1055
XU950 ND2 $PINS O=n1774 I1=n1072 I2=n1055
XU951 ND2 $PINS O=n1564 I1=k_idx[4] I2=n105
XU952 ND2 $PINS O=n1435 I1=n1074 I2=n1556
XU953 ND2 $PINS O=n1761 I1=n1556 I2=n1052
XU3 ND2 $PINS O=n3 I1=n_idx[0] I2=n1743
XU4 AN4B1S $PINS O=n1600 I1=n1349 I2=FE_OFN159_n1532 I3=n1620 B1=n1348
XU5 AN2 $PINS O=n1220 I1=n1607 I2=n84
XU6 NR3 $PINS O=n1392 I1=n973 I2=n618 I3=FE_OFN117_n1739
XU7 OR2 $PINS O=n87 I1=n1764 I2=FE_DBTN194_n1787
XU8 ND3S $PINS O=n1608 I1=n946 I2=n1607 I3=n962
XU9 OA222S $PINS O=n1269 A1=n84 A2=FE_DBTN193_n1457 B1=n125 B2=n1690 C1=n1576
+ C2=n86
XU10 ND2 $PINS O=n4 I1=n1787 I2=n1043
XU11 NR2 $PINS O=n1373 I1=FE_DBTN208_fold_n_0 I2=n1764
XU12 OA22S $PINS O=n1573 A1=n1784 A2=n125 B1=n1572 B2=n1746
XU13 ND3S $PINS O=n1621 I1=n84 I2=n946 I3=n1620
XU14 NR2 $PINS O=n77 I1=FE_DBTN194_n1787 I2=n949
XU16 AN4B1S $PINS O=n1342 I1=n1669 I2=n1265 I3=n1606 B1=FE_DBTN207_n3
XU17 AN2B1S $PINS O=n1525 I1=n1461 B1=n5
XU19 OR2B1S $PINS O=n1759 I1=n979 B1=n1052
XU20 NR2P $PINS O=n1414 I1=n946 I2=n_idx[4]
XU23 INV1S $PINS O=n950 I=n1651
XU24 INV1S $PINS O=n949 I=n1755
XU25 AN2 $PINS O=n5 I1=n1072 I2=n1073
XU46 INV1S $PINS O=n26 I=n1690
XU54 INV1S $PINS O=n34 I=n1782
XU76 INV1S $PINS O=n95 I=n1610
XU86 INV1S $PINS O=n94 I=n1503
XU90 NR2 $PINS O=n1739 I1=n949 I2=FE_DBTN208_fold_n_0
XU99 INV1S $PINS O=n93 I=n1716
XU102 ND2S $PINS O=n1666 I1=n1635 I2=n1684
XU103 ND3S $PINS O=n1335 I1=n1231 I2=n1440 I3=n1334
XU104 ND3S $PINS O=n1223 I1=n1439 I2=n1344 I3=n1440
XU105 ND2S $PINS O=n1627 I1=n1665 I2=n1475
XU106 ND3S $PINS O=n1394 I1=n1448 I2=n1611 I3=n1391
XU107 ND3S $PINS O=n1130 I1=n971 I2=n1528 I3=n1514
XU108 ND3S $PINS O=n1456 I1=n1611 I2=n1733 I3=n1455
XU109 ND3S $PINS O=n1351 I1=n962 I2=n1677 I3=n1347
XU110 ND3S $PINS O=n1515 I1=n1514 I2=n1702 I3=n1513
XU111 ND3S $PINS O=n1133 I1=n1677 I2=n1475 I3=n1440
XU112 ND2S $PINS O=n1676 I1=n95 I2=n1677
XU113 ND2S $PINS O=n1283 I1=n1677 I2=n959
XU114 ND2S $PINS O=n1681 I1=n1678 I2=n1677
XU115 ND2S $PINS O=n1086 I1=n1677 I2=n84
XU116 ND2 $PINS O=n1665 I1=n1793 I2=n1028
XU117 INV1S $PINS O=n977 I=n_idx[2]
XU118 ND3S $PINS O=n1418 I1=n1464 I2=n1413 I3=n1412
XU119 OR3S $PINS O=n80 I1=n1323 I2=n1369 I3=n1322
XU120 OA222S $PINS O=n1205 A1=n85 A2=n95 B1=n129 B2=n971 C1=n1795 C2=n125
XU121 AN3S $PINS O=n1188 I1=n1710 I2=n125 I3=n1237
XU122 ND3S $PINS O=n1189 I1=n1489 I2=n123 I3=n1188
XU123 OR2S $PINS O=n1661 I1=n125 I2=n1795
XU124 ND3S $PINS O=shift3[2] I1=n1472 I2=n1471 I3=n1470
XU125 OA112S $PINS O=n1212 A1=n1505 B1=n1205 C1=n86 C2=n1435
XU126 ND3S $PINS O=shift1[1] I1=n1104 I2=n1103 I3=n1102
XU127 OA222S $PINS O=n1406 A1=n1296 A2=n86 B1=n1199 B2=n122 C1=n125 C2=n1774
XU128 ND2S $PINS O=n1528 I1=n1741 I2=n1651
XU129 ND2S $PINS O=n1581 I1=n1029 I2=n1651
XU130 ND2S $PINS O=n1475 I1=n1793 I2=n1651
XU131 OA222S $PINS O=n1751 A1=n1735 A2=n1772 B1=n1734 B2=n949 C1=n1733 C2=n1732
XU132 ND2S $PINS O=n1237 I1=n1740 I2=n1755
XU133 OA222S $PINS O=n1750 A1=n1738 A2=n965 B1=n1737 B2=n950 C1=n1779 C2=n1736
XU134 NR2 $PINS O=n1555 I1=n992 I2=_rom_k_idx_3_1
XU135 NR2 $PINS O=n1073 I1=_rom_k_idx_3_1 I2=k_idx[0]
XU136 NR2 $PINS O=n1331 I1=n115 I2=n110
XU137 INV1S $PINS O=n110 I=n1224
XU138 NR2 $PINS O=n1635 I1=n620 I2=FE_OFN170_n1790
XU139 NR2 $PINS O=n1664 I1=n948 I2=FE_DBTN204_n1199
XU140 NR2 $PINS O=n1344 I1=n940 I2=n954
XU141 INV1S $PINS O=n954 I=n1624
XU142 INV1S $PINS O=n118 I=n77
XU143 INV1S $PINS O=n956 I=n1606
XU144 INV1S $PINS O=n115 I=n1340
XU145 NR2 $PINS O=n1147 I1=n943 I2=n620
XU146 NR2 $PINS O=n1224 I1=n111 I2=n77
XU147 INV1S $PINS O=n114 I=n1333
XU148 NR2 $PINS O=n1345 I1=FE_DBTN204_n1199 I2=n935
XU149 NR2 $PINS O=n1425 I1=n973 I2=n954
XU150 INV1S $PINS O=n620 I=n1440
XU151 AN2 $PINS O=n1343 I1=n1449 I2=n1701
XU152 INV1S $PINS O=n973 I=n1514
XU153 INV1S $PINS O=n938 I=n1265
XU154 NR2 $PINS O=n1444 I1=n1598 I2=n956
XU156 INV1S $PINS O=n939 I=n1231
XU158 INV1S $PINS O=n937 I=n1611
XU159 NR2 $PINS O=n1446 I1=n937 I2=n952
XU160 INV1S $PINS O=n948 I=n1733
XU161 INV1S $PINS O=n112 I=n1571
XU162 NR2 $PINS O=n1624 I1=n955 I2=n958
XU163 NR2 $PINS O=n1347 I1=n1335 I2=n955
XU164 AN2 $PINS O=n1346 I1=n1396 I2=n1344
XU165 INV1S $PINS O=n370 I=n1531
XU166 INV1S $PINS O=n619 I=n1702
XU167 NR2 $PINS O=n1606 I1=FE_DBTN204_n1199 I2=n958
XU169 INV1S $PINS O=n947 I=n1273
XU170 NR2 $PINS O=n1340 I1=n116 I2=FE_DBTN192_n81
XU171 INV1S $PINS O=n116 I=n1629
XU172 INV1S $PINS O=n968 I=n1620
XU173 INV1S $PINS O=n935 I=n1455
XU174 INV1S $PINS O=n111 I=n1489
XU176 NR2 $PINS O=n1513 I1=n940 I2=n958
XU177 INV1S $PINS O=n957 I=n1684
XU178 INV1S $PINS O=n943 I=n1701
XU179 INV1S $PINS O=n1000 I=n1738
XU180 NR2 $PINS O=n1333 I1=FE_DBTN194_n1787 I2=n963
XU181 NR2 $PINS O=n1439 I1=n960 I2=n973
XU182 INV1S $PINS O=n942 I=n1448
XU183 AN2 $PINS O=n1415 I1=n1512 I2=n1718
XU184 INV1S $PINS O=n951 I=n1539
XU186 INV1S $PINS O=n109 I=n1512
XU187 INV1S $PINS O=n996 I=n1419
XU188 INV1S $PINS O=n127 I=n1203
XU189 INV1S $PINS O=n994 I=n1737
XU190 INV1S $PINS O=n953 I=n1688
XU191 INV1S $PINS O=n113 I=n1634
XU192 OR2 $PINS O=n1314 I1=n224 I2=n1313
XU193 ND3 $PINS O=n1367 I1=n1412 I2=n1365 I3=n1364
XU194 ND3 $PINS O=n1588 I1=n1587 I2=n127 I3=n1586
XU195 INV1S $PINS O=n998 I=n1525
XU196 OAI112HS $PINS O=n1192 A1=n1632 B1=n127 C1=n1340 C2=n1191
XU197 NR2 $PINS O=n1191 I1=n994 I2=n996
XU198 INV1S $PINS O=n1002 I=n1734
XU199 OAI112HS $PINS O=n1323 A1=n1317 B1=n1316 C1=n85 C2=n1581
XU200 NR3 $PINS O=n1413 I1=n78 I2=n79 I3=n80
XU201 OAI222S $PINS O=n78 A1=n1612 A2=n129 B1=n221 B2=n1475 C1=n1620 C2=n130
XU202 OAI112HS $PINS O=n79 A1=n1314 B1=n1587 C1=n1315 C2=FE_DBTN203_n1500
XU203 INV1S $PINS O=n125 I=n1414
XU204 NR2 $PINS O=n1440 I1=n1610 I2=n936
XU205 NR3 $PINS O=n1449 I1=n970 I2=n955 I3=n1395
XU206 ND3 $PINS O=shift2[3] I1=n1363 I2=n1362 I3=n1361
XU207 AN4B1S $PINS O=n1363 I1=n1468 I2=n1481 I3=n1368 B1=n1379
XU208 AN4B1S $PINS O=n1361 I1=n1360 I2=n1359 I3=n1358 B1=n1357
XU209 NR2 $PINS O=n1611 I1=n938 I2=n975
XU210 NR2 $PINS O=n1514 I1=n976 I2=n974
XU211 AOI22S $PINS O=n1182 A1=n983 A2=n1169 B1=n26 B2=n1168
XU212 ND3 $PINS O=n1169 I1=n1684 I2=n95 I3=n1436
XU213 NR2 $PINS O=n1265 I1=n973 I2=n941
XU214 AN4B1S $PINS O=n1041 I1=n1040 I2=n1039 I3=n1038 B1=n1037
XU215 NR3 $PINS O=n1042 I1=n1023 I2=n1022 I3=n1021
XU216 OA22 $PINS O=n1040 A1=n93 A2=n1061 B1=n114 B2=n1229
XU217 ND3 $PINS O=n1023 I1=n1303 I2=n1269 I3=n1020
XU218 AOI22S $PINS O=n1020 A1=FE_DBTN192_n81 A2=n1007 B1=n980 B2=n1414
XU219 ND3 $PINS O=shift3[1] I1=n1434 I2=n1433 I3=n1432
XU220 AN4B1S $PINS O=n1432 I1=n1431 I2=n1430 I3=n1429 B1=n1428
XU221 NR3 $PINS O=n1434 I1=n1411 I2=n1410 I3=n1409
XU222 NR3 $PINS O=n1433 I1=n1418 I2=n1417 I3=n1416
XU223 AOI22S $PINS O=n1119 A1=n1006 A2=n1111 B1=n982 B2=n1110
XU224 NR2 $PINS O=n1121 I1=n1109 I2=n1108
XU225 AN4B1S $PINS O=n1122 I1=n1486 I2=n1107 I3=n1106 B1=n1325
XU226 AN4B1S $PINS O=n1120 I1=n1119 I2=n1118 I3=n1117 B1=n1116
XU227 ND3 $PINS O=shift2[1] I1=n1291 I2=n1290 I3=n1289
XU228 AN4B1S $PINS O=n1289 I1=n1288 I2=n1287 I3=n1286 B1=n1285
XU229 NR2 $PINS O=n1290 I1=n1278 I2=n1277
XU230 AN4B1S $PINS O=n1291 I1=n1272 I2=n1271 I3=n1293 B1=n1478
XU231 ND3 $PINS O=shift1[2] I1=n1159 I2=n1158 I3=n1157
XU232 NR3 $PINS O=n1158 I1=n1137 I2=n1136 I3=n1135
XU233 AN4B1S $PINS O=n1157 I1=n1156 I2=n1155 I3=n1154 B1=n1153
XU234 AN4B1S $PINS O=n1159 I1=n1271 I2=n1129 I3=n1216 B1=n1128
XU235 NR2 $PINS O=n1532 I1=n952 I2=n941
XU236 NR2 $PINS O=n1231 I1=n940 I2=FE_OFN117_n1739
XU237 INV1S $PINS O=n952 I=n1528
XU238 NR2 $PINS O=n1349 I1=n620 I2=n975
XU239 ND3 $PINS O=n1175 I1=n1342 I2=n959 I3=n1170
XU240 NR2 $PINS O=n1170 I1=n955 I2=n952
XU241 AN4B1S $PINS O=n1552 I1=n1551 I2=n1550 I3=n1549 B1=n1548
XU242 OA22 $PINS O=n1549 A1=n94 A2=n1526 B1=n86 B2=n1525
XU243 AOI22S $PINS O=n1551 A1=FE_DBTN197_n85 A2=n1521 B1=FE_DBTN192_n81
+ B2=n1519
XU244 NR3 $PINS O=n1173 I1=n1175 I2=FE_OFN117_n1739 I3=n975
XU245 NR2 $PINS O=n1790 I1=FE_DBTN207_n3 I2=n975
XU246 INV1S $PINS O=n963 I=n1743
XU247 ND3 $PINS O=shift1[0] I1=n1068 I2=n1067 I3=n1066
XU248 AN4B1S $PINS O=n1066 I1=n1065 I2=n1064 I3=n1063 B1=n1062
XU249 NR2 $PINS O=n1067 I1=n1047 I2=n1046
XU250 AN4B1S $PINS O=n1068 I1=n1106 I2=n1295 I3=n1162 B1=n1084
XU251 NR2 $PINS O=n1733 I1=n954 I2=FE_OFN117_n1739
XU252 NR2 $PINS O=n1702 I1=n620 I2=n970
XU253 AN4B1S $PINS O=n1706 I1=n1695 I2=n1694 I3=n1693 B1=n1692
XU254 AOI22S $PINS O=n1693 A1=n944 A2=n1686 B1=n989 B2=n1685
XU255 AOI22S $PINS O=n1694 A1=n981 A2=n1681 B1=n990 B2=n1680
XU256 AOI22S $PINS O=n1695 A1=n983 A2=n1676 B1=n970 B2=n1775
XU257 ND3 $PINS O=n1531 I1=n1315 I2=n1231 I3=n1230
XU258 NR2 $PINS O=n1230 I1=n974 I2=n618
XU259 AN4B1S $PINS O=n1143 I1=n1605 I2=n1635 I3=n1581 B1=n944
XU260 INV1S $PINS O=n618 I=n1441
XU261 AN4B1S $PINS O=n1144 I1=n1141 I2=n1635 I3=n1475 B1=n952
XU262 ND3 $PINS O=n1571 I1=n1508 I2=n1507 I3=n1506
XU263 MAOI1 $PINS O=n1508 A1=n1008 A2=n1498 B1=n1575 B2=n1497
XU264 AOI22S $PINS O=n1507 A1=n1502 A2=n1501 B1=n1500 B2=n1499
XU265 AOI12HS $PINS O=n1481 A1=n1325 B1=n1716 B2=n1007
XU266 AOI22S $PINS O=n1486 A1=n1004 A2=n1503 B1=n1414 B2=n991
XU267 AN2 $PINS O=n1574 I1=n1487 I2=n1486
XU268 AOI22S $PINS O=n1487 A1=n1006 A2=n1485 B1=FE_DBTN197_n85 B2=n953
XU269 INV1S $PINS O=n958 I=n1475
XU270 NR2 $PINS O=n1523 I1=n969 I2=n1666
XU271 ND3 $PINS O=n1529 I1=n1441 I2=n1663 I3=n1219
XU272 NR2 $PINS O=n1219 I1=n957 I2=n620
XU273 AOI22S $PINS O=n1193 A1=n999 A2=n1190 B1=n982 B2=n1189
XU274 INV1S $PINS O=n740 I=n1335
XU275 AN4B1S $PINS O=n1337 I1=n1334 I2=n1446 I3=n946 B1=n936
XU276 MOAI1S $PINS O=n1033 A1=n1032 A2=n1721 B1=n1389 B2=n986
XU277 NR2 $PINS O=n1032 I1=n940 I2=n935
XU278 ND3 $PINS O=n1478 I1=n1270 I2=n1269 I3=n1268
XU279 AOI22S $PINS O=n1270 A1=n5 A2=n109 B1=n1333 B2=n1010
XU280 NR2 $PINS O=n1268 I1=n1267 I2=n1266
XU281 MOAI1S $PINS O=n1266 A1=n1265 A2=n122 B1=n941 B2=n1714
XU282 INV1S $PINS O=n123 I=n1722
XU283 INV2 $PINS O=n955 I=n1581
XU284 NR3 $PINS O=n1614 I1=n1609 I2=n952 I3=n944
XU285 NR2 $PINS O=n1387 I1=n948 I2=n1610
XU286 ND3 $PINS O=n1609 I1=n1663 I2=n1387 I3=n1386
XU287 NR2 $PINS O=n1386 I1=n975 I2=n970
XU288 NR3 $PINS O=n1396 I1=n618 I2=FE_DBTN204_n1199 I3=n1676
XU289 ND3 $PINS O=shift2[2] I1=n1312 I2=n1311 I3=n1310
XU290 AN4B1S $PINS O=n1310 I1=n1309 I2=n1308 I3=n1307 B1=n1306
XU291 AN4B1S $PINS O=n1312 I1=n1295 I2=n1294 I3=n1293 B1=n1292
XU292 NR2 $PINS O=n1718 I1=n1716 I2=n77
XU293 NR2 $PINS O=n1447 I1=FE_DBTN207_n3 I2=n1610
XU294 NR2 $PINS O=n1510 I1=FE_OFN170_n1790 I2=n1610
XU295 NR2 $PINS O=n1319 I1=n1715 I2=n77
XU296 AN4B1S $PINS O=n1613 I1=n1612 I2=n1756 I3=n1611 B1=n947
XU297 NR2 $PINS O=n1540 I1=n940 I2=n936
XU298 NR2 $PINS O=n1199 I1=n969 I2=FE_DBTN195_n84
XU299 NR2 $PINS O=n1273 I1=FE_OFN117_n1739 I2=n969
XU300 OA12 $PINS O=n1127 A1=n1365 B1=n123 B2=n1759
XU301 NR2 $PINS O=n1629 I1=n1716 I2=n1333
XU302 NR2 $PINS O=n1684 I1=FE_DBTN195_n84 I2=n958
XU303 AOI22S $PINS O=n1480 A1=n989 A2=n1414 B1=FE_DBTN204_n1199 B2=n1579
XU304 AOI22S $PINS O=n1123 A1=n975 A2=FE_DBTN197_n85 B1=n1009 B2=n115
XU305 AOI22S $PINS O=n1126 A1=n1502 A2=n954 B1=n1610 B2=n1372
XU306 AOI22S $PINS O=n1125 A1=n1580 A2=n1283 B1=n995 B2=n1304
XU307 AN4B1S $PINS O=n1467 I1=n1465 I2=n1464 I3=n1595 B1=n1463
XU309 INV1S $PINS O=n971 I=n1597
XU310 NR2 $PINS O=n1620 I1=n976 I2=n969
XU311 AOI22S $PINS O=n1207 A1=n1597 A2=n1580 B1=n1372 B2=n973
XU312 INV1S $PINS O=n129 I=n1372
XU314 NR2 $PINS O=n1455 I1=FE_DBTN207_n3 I2=n936
XU315 NR2 $PINS O=n1489 I1=FE_DBTN196_n86 I2=FE_DBTN206_n4
XU316 AOI22S $PINS O=n1208 A1=n1010 A2=FE_DBTN196_n86 B1=n982 B2=FE_DBTN206_n4
XU317 NR2 $PINS O=n1280 I1=FE_DBTN204_n1199 I2=n1597
XU319 NR2 $PINS O=n1334 I1=n957 I2=n944
XU320 AOI22S $PINS O=n1294 A1=n981 A2=n1414 B1=n969 B2=n1457
XU321 NR2 $PINS O=n1678 I1=n1610 I2=n952
XU322 OAI22S $PINS O=n1136 A1=n1132 A2=FE_DBTN203_n1500 B1=n1131 B2=n131
XU323 NR3 $PINS O=n1131 I1=n1130 I2=n956 I3=n935
XU324 AN4B1S $PINS O=n1132 I1=n1702 I2=n84 I3=n1231 B1=n1638
XU325 OAI112HS $PINS O=n1062 A1=n1060 B1=n1371 C1=n1061 C2=n4
XU326 OAI12HS $PINS O=n1060 A1=FE_DBTN197_n85 B1=n1274 B2=n1754
XU327 NR2 $PINS O=n1701 I1=n974 I2=n944
XU328 NR2 $PINS O=n1536 I1=n943 I2=n975
XU329 NR2 $PINS O=n1605 I1=n976 I2=n952
XU330 NR2 $PINS O=n1315 I1=n1610 I2=n958
XU331 MOAI1S $PINS O=n1071 A1=n1738 A2=n94 B1=n1414 B2=n1770
XU332 AOI22S $PINS O=n1264 A1=n969 A2=n988 B1=n980 B2=n943
XU333 NR2 $PINS O=n1318 I1=n1503 I2=FE_DBTN192_n81
XU334 NR2 $PINS O=n1738 I1=FE_DBTN202_n1582 I2=FE_DBTN199_n1296
XU335 NR2 $PINS O=n1114 I1=n936 I2=FE_DBTN195_n84
XU336 AN2 $PINS O=n1113 I1=n934 I2=n1391
XU337 NR2 $PINS O=n1115 I1=n1000 I2=n1519
XU338 AOI22S $PINS O=n1303 A1=n1722 A2=n988 B1=n1457 B2=n952
XU339 NR3 $PINS O=n1422 I1=n1421 I2=n976 I3=n1687
XU340 ND3 $PINS O=n1153 I1=n1152 I2=n1151 I3=n1150
XU341 ND3 $PINS O=n1151 I1=n1787 I2=n1184 I3=n5
XU342 AOI22S $PINS O=n1150 A1=n1516 A2=n1149 B1=FE_DBTN197_n85 B2=n1148
XU343 ND3 $PINS O=n1530 I1=n1528 I2=n1581 I3=n971
XU344 ND3 $PINS O=n1222 I1=n1221 I2=n1605 I3=n1220
XU345 NR3 $PINS O=n1221 I1=FE_OFN170_n1790 I2=n936 I3=n942
XU346 AOI22S $PINS O=n1249 A1=n1457 A2=n620 B1=FE_DBTN195_n84 B2=FE_DBTN197_n85
XU347 AOI22S $PINS O=n1063 A1=n1502 A2=n1058 B1=n1473 B2=n1057
XU348 ND3 $PINS O=n1057 I1=n1696 I2=n1528 I3=n1392
XU352 NR2 $PINS O=n1448 I1=n954 I2=n944
XU353 NR2 $PINS O=n1171 I1=n1610 I2=n942
XU354 AOI22S $PINS O=n1272 A1=FE_DBTN200_n1435 A2=FE_DBTN206_n4 B1=n986
+ B2=n1414
XU355 INV1S $PINS O=n960 I=n1612
XU356 NR2 $PINS O=n1668 I1=FE_DBTN207_n3 I2=n974
XU357 AN4B1S $PINS O=n1424 I1=n959 I2=n1663 I3=n1510 B1=n957
XU358 MOAI1S $PINS O=n1037 A1=n87 A2=n1583 B1=n1516 B2=n1687
XU359 MOAI1S $PINS O=n1166 A1=n1347 A2=n85 B1=n1008 B2=n1711
XU360 AOI22S $PINS O=n1365 A1=FE_DBTN198_n1745 A2=FE_DBTN196_n86
+ B1=FE_DBTN199_n1296 B2=n1716
XU361 INV1S $PINS O=n934 I=n1373
XU362 OAI22S $PINS O=n1204 A1=n1201 A2=n94 B1=n1200 B2=n121
XU363 NR2 $PINS O=n1201 I1=FE_DBTN202_n1582 I2=n1002
XU364 NR2 $PINS O=n1200 I1=n953 I2=n951
XU365 NR2 $PINS O=n1539 I1=n975 I2=n952
XU366 NR2 $PINS O=n1688 I1=n955 I2=FE_DBTN195_n84
XU367 INV1S $PINS O=n221 I=n1502
XU368 AOI22S $PINS O=n1117 A1=n1372 A2=n968 B1=FE_DBTN199_n1296 B2=n111
XU370 AOI22S $PINS O=n1317 A1=n1007 A2=FE_DBTN196_n86 B1=n1006 B2=n1716
XU371 NR2 $PINS O=n1512 I1=n1503 I2=FE_DBTN206_n4
XU372 AOI22S $PINS O=n1252 A1=n1503 A2=n1009 B1=n77 B2=FE_DBTN201_n1719
XU373 NR3 $PINS O=n1630 I1=n1010 I2=FE_DBTN198_n1745 I3=n996
XU374 AOI22S $PINS O=n1505 A1=n1503 A2=n1010 B1=FE_DBTN199_n1296
+ B2=FE_DBTN206_n4
XU375 NR2 $PINS O=n1679 I1=n974 I2=n1597
XU376 NR2 $PINS O=n1619 I1=FE_DBTN198_n1745 I2=n1007
XU377 NR2 $PINS O=n1697 I1=n970 I2=n976
XU378 NR2 $PINS O=n1575 I1=FE_DBTN196_n86 I2=FE_DBTN192_n81
XU379 INV1S $PINS O=n107 I=n1369
XU380 NR2 $PINS O=n1634 I1=n1503 I2=n1715
XU381 NR2 $PINS O=n1537 I1=n975 I2=n968
XU382 AOI22S $PINS O=n1662 A1=FE_DBTN198_n1745 A2=FE_DBTN192_n81
+ B1=FE_DBTN199_n1296 B2=n77
XU383 NR2 $PINS O=n1374 I1=FE_DBTN197_n85 I2=n1372
XU385 NR2 $PINS O=n1253 I1=n970 I2=n969
XU386 ND3 $PINS O=n1466 I1=n1383 I2=n1382 I3=n1381
XU387 AOI22S $PINS O=n1383 A1=n1373 A2=n1372 B1=n77 B2=n1004
XU388 OA22 $PINS O=n1382 A1=n84 A2=n1374 B1=n114 B2=n1526
XU389 NR3 $PINS O=n1381 I1=n1380 I2=n1379 I3=n1417
XU390 AOI22S $PINS O=n1464 A1=FE_DBTN192_n81 A2=n1009 B1=n1004 B2=n109
XU391 NR2 $PINS O=n1061 I1=n1007 I2=n1008
XU392 NR2 $PINS O=n1339 I1=n1010 I2=n1009
XU393 NR2 $PINS O=n1338 I1=n1000 I2=n1006
XU394 MOAI1S $PINS O=n1021 A1=FE_DBTN191_n1639 A2=n84 B1=n1006 B2=n77
XU395 AOI22S $PINS O=n1106 A1=n995 A2=FE_DBTN192_n81 B1=n77 B2=FE_DBTN200_n1435
XU397 NR2 $PINS O=n1419 I1=FE_DBTN200_n1435 I2=FE_DBTN201_n1719
XU398 OA22 $PINS O=n1590 A1=n85 A2=n1663 B1=n221 B2=n1581
XU399 OR2 $PINS O=n1587 I1=n1237 I2=n1746
XU400 NR2 $PINS O=n1203 I1=n1069 I2=n1746
XU401 AOI22S $PINS O=n1129 A1=n34 A2=FE_DBTN206_n4 B1=FE_DBTN202_n1582 B2=n1333
XU402 AOI22S $PINS O=n1604 A1=n990 A2=n936 B1=n987 B2=n954
XU403 NR2 $PINS O=n1663 I1=n974 I2=n941
XU404 AOI22S $PINS O=n1360 A1=n1333 A2=n996 B1=n1008 B2=n110
XU405 NR2 $PINS O=n1737 I1=n995 I2=n1009
XU406 AOI22S $PINS O=n1245 A1=n944 A2=n1502 B1=n974 B2=n1580
XU407 NR2 $PINS O=n1522 I1=FE_DBTN198_n1745 I2=n1780
XU408 AOI22S $PINS O=n1076 A1=FE_DBTN201_n1719 A2=n1716 B1=n1715 B2=n982
XU409 AOI22S $PINS O=n1412 A1=n1722 A2=n986 B1=n1716 B2=n999
XU410 INV1S $PINS O=n982 I=n1746
XU411 AOI22S $PINS O=n1644 A1=FE_DBTN197_n85 A2=n1627 B1=n109 B2=n1002
XU412 INV1S $PINS O=n224 I=n1473
XU413 AOI12HS $PINS O=n1202 A1=n122 B1=n1612 B2=n1228
XU414 NR2 $PINS O=n1228 I1=n1610 I2=n941
XU415 OAI12HS $PINS O=n1491 A1=n1716 B1=FE_DBTN200_n1435 B2=n5
XU416 AOI22S $PINS O=n1591 A1=n1580 A2=n960 B1=n1579 B2=n969
XU417 AOI22S $PINS O=n1364 A1=n1716 A2=FE_DBTN200_n1435 B1=n77
+ B2=FE_DBTN202_n1582
XU418 NR2 $PINS O=n1723 I1=n1715 I2=n1716
XU419 AOI22S $PINS O=n1260 A1=n1373 A2=n1372 B1=n1005 B2=n113
XU420 NR2 $PINS O=n1779 I1=n999 I2=n1008
XU421 NR2 $PINS O=n1696 I1=n955 I2=n936
XU422 INV1S $PINS O=n983 I=n1445
XU423 NR2 $PINS O=n1391 I1=n969 I2=n936
XU424 NR2 $PINS O=n1785 I1=n968 I2=n970
XU425 OA22 $PINS O=n1259 A1=n87 A2=n1779 B1=n122 B2=n959
XU426 INV1S $PINS O=n980 I=n1773
XU427 INV1S $PINS O=n130 I=n1580
XU428 NR2 $PINS O=n1777 I1=n1771 I2=n1770
XU429 AOI22S $PINS O=n1479 A1=n1008 A2=n111 B1=n1009 B2=n116
XU430 NR2 $PINS O=n1497 I1=n1006 I2=n1005
XU431 NR2 $PINS O=n1526 I1=FE_DBTN201_n1719 I2=n1007
XU432 NR2 $PINS O=n1640 I1=FE_DBTN200_n1435 I2=n1010
XU434 NR2 $PINS O=n1313 I1=n976 I2=n975
XU435 AOI22S $PINS O=n1728 A1=FE_DBTN200_n1435 A2=n77 B1=FE_DBTN202_n1582
+ B2=n1716
XU436 AOI22S $PINS O=n1251 A1=n1580 A2=FE_DBTN195_n84 B1=n941 B2=n1502
XU437 AOI22S $PINS O=n1504 A1=n1503 A2=n998 B1=FE_DBTN192_n81 B2=n1004
XU438 INV1S $PINS O=n121 I=n1516
XU439 OAI112HS $PINS O=n1285 A1=n1371 B1=n1632 C1=n1284 C2=n362
XU440 NR2 $PINS O=n1284 I1=n958 I2=n1283
XU441 NR2 $PINS O=n1438 I1=n953 I2=n974
XU442 AOI22S $PINS O=n1749 A1=n981 A2=n1739 B1=FE_DBTN199_n1296 B2=n1743
XU443 NR2 $PINS O=n1734 I1=FE_DBTN198_n1745 I2=n34
XU444 MOAI1S $PINS O=n1641 A1=n86 A2=n1640 B1=n1639 B2=n1638
XU445 AOI22S $PINS O=n1065 A1=n1500 A2=n1049 B1=n1639 B2=n943
XU446 ND3 $PINS O=n1049 I1=n1253 I2=n1455 I3=n1048
XU447 NR2 $PINS O=n1048 I1=n954 I2=n943
XU448 AOI22S $PINS O=n1090 A1=n26 A2=n941 B1=FE_DBTN207_n3 B2=n983
XU449 INV1S $PINS O=n362 I=n1714
XU450 ND3 $PINS O=n1238 I1=n1587 I2=n1256 I3=n1492
XU451 INV1S $PINS O=n981 I=n1721
XU452 NR2 $PINS O=n1583 I1=n999 I2=n1004
XU453 INV1S $PINS O=n984 I=n1759
XU454 INV1S $PINS O=n122 I=n1297
XU455 AOI22S $PINS O=n1727 A1=n1715 A2=n998 B1=n1714 B2=FE_DBTN204_n1199
XU456 INV1S $PINS O=n131 I=n1579
XU457 MOAI1S $PINS O=n1460 A1=n1438 A2=FE_DBTN191_n1639 B1=n957 B2=n1473
XU458 AOI22S $PINS O=n1309 A1=FE_DBTN198_n1745 A2=n1304 B1=FE_DBTN207_n3
+ B2=n1714
XU459 NR2 $PINS O=n1778 I1=n990 I2=n987
XU460 AOI22S $PINS O=n1308 A1=n1007 A2=n1333 B1=n1716 B2=FE_DBTN202_n1582
XU461 NR3 $PINS O=n1474 I1=n1473 I2=n1500 I3=n1579
XU462 NR2 $PINS O=n1229 I1=n999 I2=FE_DBTN199_n1296
XU463 NR2 $PINS O=n1172 I1=n988 I2=n981
XU464 AOI22S $PINS O=n1368 A1=FE_DBTN199_n1296 A2=n1503 B1=FE_DBTN198_n1745
+ B2=n1715
XU465 OA12 $PINS O=n1070 A1=n982 B1=FE_DBTN196_n86 B2=n1503
XU466 NR2 $PINS O=n1524 I1=n999 I2=n34
XU467 AOI22S $PINS O=n1307 A1=n958 A2=n1473 B1=n976 B2=n1500
XU468 NR2 $PINS O=n1477 I1=n941 I2=n1627
XU469 NR2 $PINS O=n1755 I1=n950 I2=FE_OFN162_fold_n_1
XU470 AOI22S $PINS O=n1324 A1=FE_DBTN202_n1582 A2=n113 B1=FE_DBTN201_n1719
+ B2=FE_DBTN206_n4
XU471 NR2 $PINS O=n1471 I1=n1460 I2=n1459
XU472 AN4B1S $PINS O=n1470 I1=n1469 I2=n1468 I3=n1467 B1=n1466
XU473 NR2 $PINS O=n1610 I1=FE_DBTN208_fold_n_0 I2=n1766
XU474 MOAI1S $PINS O=n1357 A1=n_idx[4] A2=n1356 B1=n109 B2=n5
XU475 AN4B1S $PINS O=n1356 I1=n1355 I2=n1354 I3=n1353 B1=n1352
XU476 AOI22S $PINS O=n1355 A1=n1348 A2=n990 B1=n955 B2=n991
XU477 INV1S $PINS O=n976 I=n1677
XU478 ND3 $PINS O=n1164 I1=n1665 I2=n1528 I3=n1163
XU479 AN2 $PINS O=n1163 I1=n1699 I2=n1336
XU480 ND3 $PINS O=shift1[3] I1=n1198 I2=n1197 I3=n1196
XU481 AN4B1S $PINS O=n1198 I1=n1162 I2=n1252 I3=n1316 B1=n1463
XU482 NR2 $PINS O=n1197 I1=n1167 I2=n1166
XU483 AN4B1S $PINS O=n1196 I1=n1195 I2=n1194 I3=n1193 B1=n1192
XU484 OAI22S $PINS O=n1178 A1=n1343 A2=n1773 B1=n1177 B2=n1759
XU485 AN4B1S $PINS O=n1177 I1=n1280 I2=n1439 I3=n1665 B1=n1373
XU486 ND3 $PINS O=shift2[0] I1=n1244 I2=n1243 I3=n1242
XU487 NR2 $PINS O=n1243 I1=n1227 I2=n1226
XU488 AN4B1S $PINS O=n1242 I1=n1241 I2=n1240 I3=n1239 B1=n1238
XU489 ND3 $PINS O=n1366 I1=n1215 I2=n1214 I3=n1213
XU490 NR3 $PINS O=n1214 I1=n1204 I2=n1203 I3=n1202
XU491 AN4B1S $PINS O=n1213 I1=n1298 I2=n1212 I3=n1251 B1=n1322
XU492 NR2 $PINS O=n1646 I1=n1626 I2=n1625
XU493 MOAI1S $PINS O=n1625 A1=n1624 A2=n121 B1=n1006 B2=n1716
XU494 OAI222S $PINS O=n1626 A1=n_idx[4] A2=n1623 B1=n1783 B2=n87 C1=n1622
+ C2=FE_DBTN193_n1457
XU495 NR3 $PINS O=n1622 I1=n1621 I2=n619 I3=n951
XU496 NR2 $PINS O=n1669 I1=n620 I2=n1667
XU497 NR3 $PINS O=n1623 I1=n1618 I2=n1617 I3=n1616
XU498 OAI222S $PINS O=n1617 A1=n1606 A2=n1672 B1=n1778 B2=n84 C1=n1605 C2=n1732
XU499 OAI222S $PINS O=n1616 A1=n1615 A2=n1773 B1=n1614 B2=n1690 C1=n1613
+ C2=n1721
XU500 OAI112HS $PINS O=n1618 A1=n1604 B1=n1603 C1=n1682 C2=n1665
XU501 NR3 $PINS O=n1601 I1=n1599 I2=FE_DBTN207_n3 I3=n939
XU502 NR3 $PINS O=n1602 I1=n1598 I2=n1597 I3=n968
XU503 ND3 $PINS O=n1165 I1=n1347 I2=n1791 I3=n1683
XU504 NR3 $PINS O=n1103 I1=n1071 I2=n1203 I3=n1070
XU505 NR3 $PINS O=n1102 I1=n1101 I2=n1100 I3=n1099
XU506 INV1S $PINS O=n985 I=n1674
XU507 ND3 $PINS O=n1174 I1=n1441 I2=n95 I3=n1341
XU508 ND3 $PINS O=n1176 I1=n1313 I2=n1700 I3=n1444
XU510 ND3 $PINS O=shift3[0] I1=n1405 I2=n1404 I3=n1403
XU511 AN4B1S $PINS O=n1404 I1=n107 I2=n1385 I3=n1384 B1=n1466
XU512 AN4B1S $PINS O=n1403 I1=n1402 I2=n1401 I3=n1400 B1=n1399
XU513 NR2 $PINS O=n1730 I1=n1713 I2=n1712
XU514 MOAI1S $PINS O=n1712 A1=n4 A2=FE_DBTN205_n5 B1=n1008 B2=n1711
XU515 OAI22S $PINS O=n1713 A1=n1746 A2=n1710 B1=n_idx[4] B2=n1709
XU516 AN4B1S $PINS O=n1709 I1=n1708 I2=n1707 I3=n1706 B1=n1705
XU517 AN4B1S $PINS O=n1675 I1=n1665 I2=n1700 I3=n1664 B1=n960
XU518 AN4B1S $PINS O=n1671 I1=n1669 I2=n1668 I3=n1688 B1=n952
XU519 NR3 $PINS O=n1673 I1=n973 I2=n1667 I3=n1666
XU520 OAI112HS $PINS O=n1325 A1=n1205 B1=n1105 C1=n1724 C2=n87
XU521 AOI22S $PINS O=n1105 A1=n952 A2=n1502 B1=FE_DBTN207_n3 B2=n1580
XU522 MOAI1S $PINS O=n1548 A1=n_idx[4] A2=n1547 B1=n111 B2=FE_DBTN202_n1582
XU523 AN4B1S $PINS O=n1547 I1=n1546 I2=n1545 I3=n1544 B1=n1543
XU524 AOI22S $PINS O=n1546 A1=FE_DBTN195_n84 A2=n983 B1=n969 B2=n984
XU525 NR3 $PINS O=n1535 I1=n1530 I2=n947 I3=n1529
XU526 NR3 $PINS O=n1534 I1=n1531 I2=n955 I3=n975
XU527 AN4B1S $PINS O=n1533 I1=n1532 I2=n1733 I3=n1669 B1=n968
XU528 NR2 $PINS O=n1743 I1=n966 I2=FE_OFN162_fold_n_1
XU529 OAI22S $PINS O=n1451 A1=n1450 A2=n1690 B1=n1773 B2=n1449
XU530 AN4B1S $PINS O=n1450 I1=n1785 I2=n1448 I3=n1540 B1=n975
XU531 MOAI1S $PINS O=n1459 A1=n_idx[4] A2=n1458 B1=n1457 B2=n1456
XU532 AN4B1S $PINS O=n1458 I1=n1454 I2=n1453 I3=n1452 B1=n1451
XU533 AOI22S $PINS O=n1454 A1=n941 A2=n987 B1=n955 B2=n991
XU534 AN4B1S $PINS O=n1442 I1=n1605 I2=n1441 I3=n1440 B1=n956
XU535 AN4B1S $PINS O=n1443 I1=n1439 I2=n1733 I3=n1440 B1=FE_DBTN195_n84
XU536 MOAI1S $PINS O=n1692 A1=n1691 A2=n1690 B1=n980 B2=n1689
XU537 NR2 $PINS O=n1691 I1=n955 I2=n1687
XU538 MOAI1S $PINS O=n1046 A1=n1296 A2=n86 B1=n982 B2=n1045
XU539 OA12 $PINS O=n1044 A1=n1069 B1=n_idx[4] B2=n1683
XU540 NR3 $PINS O=n1146 I1=n1584 I2=n77 I3=n1333
XU541 AN4B1S $PINS O=n1142 I1=n1677 I2=n1344 I3=n1220 B1=FE_DBTN207_n3
XU542 NR2 $PINS O=n1441 I1=n1667 I2=n1348
XU543 ND3 $PINS O=n1599 I1=n1606 I2=n1791 I3=n1138
XU544 NR2 $PINS O=n1138 I1=n618 I2=n1676
XU545 ND3 $PINS O=n1659 I1=n1594 I2=n1593 I3=n1592
XU546 NR2 $PINS O=n1593 I1=n1578 I2=n1577
XU547 AN4B1S $PINS O=n1592 I1=n1591 I2=n1590 I3=n1589 B1=n1588
XU548 ND3 $PINS O=shift3[3] I1=n1484 I2=n1483 I3=n1482
XU549 AN4B1S $PINS O=n1482 I1=n1481 I2=n1480 I3=n1479 B1=n1478
XU550 AN4B1S $PINS O=n1232 I1=n1635 I2=n1688 I3=n1607 B1=n940
XU551 INV1S $PINS O=n936 I=n1665
XU552 OAI22S $PINS O=n1705 A1=n1704 A2=n1772 B1=n1703 B2=n1774
XU553 AN4B1S $PINS O=n1704 I1=n1700 I2=n946 I3=n1699 B1=n1698
XU554 AN4B1S $PINS O=n1703 I1=n1702 I2=n946 I3=n1701 B1=FE_DBTN204_n1199
XU555 ND3 $PINS O=n1698 I1=n1697 I2=n962 I3=n1696
XU556 AN4B1S $PINS O=n1054 I1=n3 I2=n945 I3=n369 B1=n1051
XU557 AN4B1S $PINS O=n1053 I1=n934 I2=n84 I3=n971 B1=n1598
XU558 OA22 $PINS O=n1038 A1=n_idx[4] A2=n1036 B1=n1718 B2=n1330
XU559 AN4B1S $PINS O=n1036 I1=n1035 I2=n1264 I3=n1034 B1=n1033
XU560 AOI22S $PINS O=n1035 A1=n941 A2=n987 B1=n980 B2=n969
XU561 AOI22S $PINS O=n1034 A1=n26 A2=n1031 B1=n988 B2=n1030
XU562 ND3 $PINS O=n1350 I1=n1668 I2=n1684 I3=n1600
XU563 NR2 $PINS O=n1722 I1=n369 I2=n_idx[4]
XU564 INV1S $PINS O=n369 I=n1667
XU565 NR2 $PINS O=n1298 I1=n82 I2=n83
XU566 OAI222S $PINS O=n82 A1=n1782 A2=n86 B1=n1746 B2=n123 C1=n4 C2=n1488
XU567 OAI222S $PINS O=n83 A1=n81 A2=n1719 B1=n1576 B2=n114 C1=n118 C2=n1461
XU568 ND3 $PINS O=n1409 I1=n1301 I2=n1300 I3=n1299
XU569 AOI22S $PINS O=n1300 A1=n975 A2=n1297 B1=n1473 B2=n941
XU570 AOI22S $PINS O=n1301 A1=FE_DBTN195_n84 A2=n1500 B1=n1516 B2=n1610
XU571 ND3 $PINS O=n1292 I1=n1079 I2=n1078 I3=n1077
XU572 AN4B1S $PINS O=n1077 I1=n1076 I2=n1465 I3=n1129 B1=n1408
XU573 OAI22S $PINS O=n1543 A1=n1542 A2=n1672 B1=n1541 B2=n1690
XU574 AN4B1S $PINS O=n1541 I1=n1540 I2=n1733 I3=n1735 B1=FE_OFN170_n1790
XU575 AN4B1S $PINS O=n1542 I1=n1678 I2=n1664 I3=n1668 B1=n1667
XU576 NR3 $PINS O=n1293 I1=n1263 I2=n1262 I3=n1261
XU577 ND3 $PINS O=n1262 I1=n1407 I2=n1252 I3=n1364
XU578 ND3 $PINS O=n1261 I1=n1260 I2=n1259 I3=n1258
XU579 OAI112HS $PINS O=n1263 A1=n1469 B1=n1249 C1=n125 C2=n1672
XU580 AN4B1S $PINS O=n1420 I1=n1702 I2=n3 I3=n1514 B1=n942
XU581 INV1S $PINS O=n975 I=n1791
XU582 OR2 $PINS O=n84 I1=n1736 I2=FE_DBTN208_fold_n_0
XU584 OAI112HS $PINS O=n1408 A1=n1127 B1=n1075 C1=n85 C2=n1683
XU585 OA22 $PINS O=n1075 A1=n224 A2=n1141 B1=FE_DBTN203_n1500 B2=n1581
XU586 NR2P $PINS O=n1716 I1=n1763 I2=FE_DBTN194_n1787
XU587 AN4B1S $PINS O=n1801 I1=n1800 I2=n1799 I3=n1798 B1=n1797
XU588 AN4B1S $PINS O=n1802 I1=n1751 I2=n1750 I3=n1749 B1=n1748
XU589 MOAI1S $PINS O=n1797 A1=n1796 A2=n1795 B1=n991 B2=n1794
XU590 INV1S $PINS O=n941 I=n1700
XU591 NR3 $PINS O=n1615 I1=n1608 I2=n953 I3=n943
XU592 INV1S $PINS O=n970 I=n1607
XU593 OAI112HS $PINS O=n1410 A1=n1082 B1=n1081 C1=n1083 C2=n1437
XU594 NR2 $PINS O=n1083 I1=n1716 I2=FE_DBTN196_n86
XU595 OR2 $PINS O=n85 I1=n1795 I2=n_idx[4]
XU597 NR2 $PINS O=n1597 I1=n1763 I2=FE_DBTN208_fold_n_0
XU598 MOAI1S $PINS O=n1099 A1=n_idx[4] A2=n1098 B1=n990 B2=n1722
XU599 AN4B1S $PINS O=n1098 I1=n1097 I2=n1096 I3=n1095 B1=n1094
XU600 AOI22S $PINS O=n1097 A1=n988 A2=n1086 B1=n984 B2=n1085
XU601 AN4B1S $PINS O=n1095 I1=n1091 I2=n1604 I3=n1090 B1=n1089
XU602 NR2 $PINS O=n1096 I1=n1088 I2=n1087
XU603 MOAI1S $PINS O=n1087 A1=n1679 A2=n1757 B1=n1775 B2=n969
XU604 OAI22S $PINS O=n1088 A1=n1697 A2=n1784 B1=n1147 B2=n1682
XU605 AN4B1S $PINS O=n1388 I1=n1678 I2=n1607 I3=n1611 B1=n942
XU606 INV1S $PINS O=n741 I=n1609
XU607 ND3 $PINS O=n1322 I1=n1211 I2=n1210 I3=n1209
XU608 OA22 $PINS O=n1211 A1=n1488 A2=n1318 B1=n95 B2=n221
XU609 MAOI1 $PINS O=n1210 A1=FE_DBTN197_n85 A2=n1206 B1=n1576 B2=n1319
XU610 NR2 $PINS O=n1372 I1=n1759 I2=n_idx[4]
XU611 OR2 $PINS O=n86 I1=FE_DBTN194_n1787 I2=n1766
XU613 MAOI1 $PINS O=n1642 A1=FE_DBTN199_n1296 A2=n1637 B1=n1636 B2=n1635
XU614 ND3 $PINS O=n1637 I1=n86 I2=n114 I3=n1634
XU615 INV1S $PINS O=n945 I=n1043
XU617 INV1S $PINS O=n1010 I=n1724
XU618 ND3 $PINS O=n1687 I1=n95 I2=n1791 I3=FE_OFN159_n1532
XU619 NR2 $PINS O=n1612 I1=FE_DBTN207_n3 I2=n1348
XU620 INV1S $PINS O=n1715 I=n87
XU621 OAI22S $PINS O=n1094 A1=n1093 A2=n1795 B1=n1092 B2=n1475
XU622 NR2 $PINS O=n1092 I1=n986 I2=n1775
XU623 AN2 $PINS O=n1093 I1=n1677 I2=n1540
XU624 AN4B1S $PINS O=n1140 I1=n1199 I2=n1683 I3=n1696 B1=n1521
XU625 INV1S $PINS O=n592 I=n1599
XU626 AN4B1S $PINS O=n1139 I1=n1273 I2=n1665 I3=n1611 B1=n618
XU627 OAI222S $PINS O=n1278 A1=n1276 A2=FE_DBTN191_n1639 B1=n1275
+ B2=FE_DBTN203_n1500 C1=n1735 C2=n121
XU628 AN4B1S $PINS O=n1276 I1=FE_OFN159_n1532 I2=n3 I3=n1387 B1=n943
XU629 NR3 $PINS O=n1275 I1=n1274 I2=n619 I3=n947
XU630 MOAI1S $PINS O=n1517 A1=n118 A2=FE_DBTN205_n5 B1=n1516 B2=n1515
XU631 INV2 $PINS O=n969 I=n1735
XU632 INV1S $PINS O=n944 I=n1699
XU633 AN2 $PINS O=n1538 I1=n1700 I2=n1536
XU634 MOAI1S $PINS O=n1463 A1=n1161 A2=n1296 B1=n1160 B2=FE_DBTN198_n1745
XU635 NR2 $PINS O=n1161 I1=n1503 I2=n1711
XU636 NR2 $PINS O=n1787 I1=FE_DBTN208_fold_n_0 I2=n_idx[4]
XU637 MOAI1S $PINS O=n1416 A1=n1415 A2=n1582 B1=n1414 B2=n983
XU638 NR2 $PINS O=n1503 I1=FE_DBTN194_n1787 I2=n1736
XU639 OAI222S $PINS O=n1428 A1=n1663 A2=n121 B1=n_idx[4] B2=n1427 C1=n1426
+ C2=n362
XU640 AN4B1S $PINS O=n1426 I1=n1425 I2=n1539 I3=n1665 B1=n618
XU641 NR2 $PINS O=n1423 I1=n952 I2=FE_DBTN207_n3
XU642 AOI22S $PINS O=n1288 A1=n1473 A2=n1282 B1=n1579 B2=n1281
XU643 ND3 $PINS O=n1281 I1=n1280 I2=n1439 I3=n1279
XU644 ND3 $PINS O=n1282 I1=n1664 I2=n1669 I3=n1539
XU645 NR2 $PINS O=n1279 I1=n1667 I2=n952
XU646 OAI222S $PINS O=n1109 A1=n85 A2=n1475 B1=n1575 B2=n1330 C1=n118 C2=n1488
XU647 OAI222S $PINS O=n1518 A1=n1512 A2=n1768 B1=n1634 B2=n1746 C1=n1511
+ C2=FE_DBTN191_n1639
XU648 AN4B1S $PINS O=n1511 I1=n1684 I2=n1700 I3=n1510 B1=n947
XU649 NR2 $PINS O=n1756 I1=n1667 I2=n1610
XU650 OAI222S $PINS O=n1226 A1=n1225 A2=FE_DBTN191_n1639 B1=n1718 B2=n1719
+ C1=n1224 C2=n1768
XU651 NR3 $PINS O=n1225 I1=n1421 I2=n936 I3=n937
XU652 AN4B1S $PINS O=n1789 I1=n1778 I2=n1777 I3=n1776 B1=n1775
XU653 AN4B1S $PINS O=n1786 I1=n1783 I2=n1782 I3=n1781 B1=n1780
XU654 AN4B1S $PINS O=n1776 I1=n1774 I2=n1773 I3=n1772 B1=n989
XU655 MOAI1S $PINS O=n1135 A1=n1134 A2=FE_DBTN191_n1639 B1=n113 B2=n1007
XU656 NR3 $PINS O=n1134 I1=n1133 I2=n939 I3=n1638
XU657 INV1S $PINS O=n965 I=n1752
XU658 AN4B1S $PINS O=n1494 I1=n1493 I2=n1492 I3=n1491 B1=n1490
XU659 NR2 $PINS O=n1026 I1=FE_DBTN201_n1719 I2=FE_DBTN198_n1745
XU660 NR2 $PINS O=n1025 I1=n1008 I2=n996
XU661 NR2 $PINS O=n1027 I1=n1715 I2=FE_DBTN196_n86
XU662 NR2 $PINS O=n1502 I1=n1682 I2=n_idx[4]
XU663 INV1S $PINS O=n1007 I=n1488
XU664 OA22 $PINS O=n1162 A1=n1018 A2=n1782 B1=n1582 B2=n1017
XU665 NR2 $PINS O=n1018 I1=FE_DBTN196_n86 I2=n1160
XU666 NR2 $PINS O=n1633 I1=FE_DBTN201_n1719 I2=n1010
XU667 OAI222S $PINS O=n1490 A1=n1525 A2=n81 B1=n1583 B2=n4 C1=n221 C2=n1700
XU668 OR2 $PINS O=n1256 I1=n1461 I2=n1575
XU669 AOI22S $PINS O=n1589 A1=n77 A2=n1585 B1=n1010 B2=n1584
XU670 AN4B1S $PINS O=n1233 I1=n1735 I2=n1514 I3=n1790 B1=n1421
XU671 MOAI1S $PINS O=n1578 A1=n1575 A2=n1782 B1=n109 B2=n1005
XU672 OAI222S $PINS O=n1022 A1=n1575 A2=n1435 B1=n1455 B2=FE_DBTN193_n1457
+ C1=n1634 C2=n1761
XU673 OAI112HS $PINS O=n1128 A1=n1208 B1=n1127 C1=n1768 C2=n86
XU674 AOI22S $PINS O=n1248 A1=n1503 A2=n996 B1=n1715 B2=n1004
XU675 AOI22S $PINS O=n1247 A1=n1010 A2=n77 B1=n5 B2=FE_DBTN192_n81
XU676 INV1S $PINS O=n959 I=n1348
XU677 OA22 $PINS O=n1726 A1=n1720 A2=n1719 B1=n1718 B2=n1717
XU678 NR2 $PINS O=n1717 I1=n1007 I2=n1005
XU679 NR2 $PINS O=n1720 I1=n1716 I2=n111
XU680 NR2 $PINS O=n1457 I1=n1772 I2=n_idx[4]
XU681 OAI22S $PINS O=n1089 A1=n1620 A2=n1774 B1=n1605 B2=n1674
XU682 NR2 $PINS O=n1257 I1=n936 I2=n975
XU683 MAOI1 $PINS O=n1255 A1=n955 A2=n1254 B1=n1476 B2=n1253
XU684 ND3 $PINS O=n1234 I1=n1764 I2=n963 I3=n1763
XU685 OR2 $PINS O=n1492 I1=n1462 I2=n1330
XU686 AOI22S $PINS O=n1328 A1=FE_DBTN196_n86 A2=n1326 B1=n941 B2=FE_DBTN197_n85
XU687 AOI22S $PINS O=n1329 A1=FE_DBTN200_n1435 A2=FE_DBTN192_n81 B1=n995
+ B2=n116
XU688 AOI22S $PINS O=n1378 A1=FE_DBTN192_n81 A2=n1010 B1=n1716 B2=n1004
XU689 AOI22S $PINS O=n1377 A1=n1579 A2=n1376 B1=n1639 B2=n1375
XU690 NR2 $PINS O=n1500 I1=n1445 I2=n_idx[4]
XU692 AOI22S $PINS O=n1370 A1=n1516 A2=n973 B1=n1639 B2=n941
XU693 NR2 $PINS O=n1762 I1=n1753 I2=n1752
XU694 AN2 $PINS O=n1758 I1=n950 I2=n1756
XU695 NR2 $PINS O=n1760 I1=n1755 I2=n1754
XU696 AN4B1S $PINS O=n1187 I1=n1186 I2=n1488 I3=n1185 B1=n1780
XU697 NR2 $PINS O=n1580 I1=n1757 I2=n_idx[4]
XU698 MOAI1S $PINS O=n1725 A1=n1724 A2=n1723 B1=n1722 B2=n1771
XU699 OAI222S $PINS O=n1116 A1=n1779 A2=n1512 B1=n1318 B2=n1724 C1=n1734 C2=n94
XU700 NR2 $PINS O=n1141 I1=n974 I2=n1348
XU701 INV1S $PINS O=n986 I=n1670
XU702 ND3 $PINS O=n1184 I1=n1016 I2=n1766 I3=n1015
XU703 NR2 $PINS O=n1016 I1=n1755 I2=n777
XU704 INV1S $PINS O=n1009 I=n1112
XU705 ND3 $PINS O=n1780 I1=FE_DBTN205_n5 I2=n1724 I3=n1497
XU706 ND2 $PINS O=n1746 I1=n1555 I2=n1568
XU707 NR2 $PINS O=n1473 I1=n1674 I2=n_idx[4]
XU708 ND2 $PINS O=n1674 I1=n1056 I2=n1555
XU709 OAI22S $PINS O=n1267 A1=n_idx[4] A2=n1264 B1=n1334 B2=n121
XU710 OA22 $PINS O=n1708 A1=n1759 A2=n1668 B1=n1732 B2=n1663
XU711 AOI22S $PINS O=n1250 A1=n1297 A2=n955 B1=n1516 B2=n970
XU713 INV1S $PINS O=n1008 I=n1768
XU714 INV1S $PINS O=n777 I=n1764
XU715 ND2 $PINS O=n1773 I1=n1555 I2=n1024
XU716 INV1S $PINS O=n1006 I=n1576
XU717 NR2 $PINS O=n1639 I1=n1784 I2=n_idx[4]
XU718 MOAI1S $PINS O=n1108 A1=n1745 A2=n1629 B1=n1716 B2=n999
XU719 MOAI1S $PINS O=n1277 A1=n1719 A2=n1629 B1=n981 B2=n1722
XU720 OA22 $PINS O=n1091 A1=n1607 A2=n1772 B1=n1581 B2=n1721
XU722 NR2 $PINS O=n1516 I1=n1774 I2=n_idx[4]
XU723 MOAI1S $PINS O=n1577 A1=n1576 A2=n87 B1=FE_DBTN206_n4 B2=n1007
XU724 INV1S $PINS O=n991 I=n1682
XU725 INV1S $PINS O=n988 I=n1672
XU726 MOAI1S $PINS O=n1380 A1=n1724 A2=n93 B1=n1006 B2=FE_DBTN206_n4
XU727 MOAI1S $PINS O=n1306 A1=n4 A2=n1338 B1=n974 B2=n1305
XU734 AN2 $PINS O=n1769 I1=n1763 I2=n966
XU735 NR2 $PINS O=n1765 I1=FE_DBTN201_n1719 I2=n994
XU741 NR2 $PINS O=n1767 I1=FE_DBTN202_n1582 I2=n1009
XU766 OA22 $PINS O=n1286 A1=n1476 A2=n95 B1=n1791 B2=n1636
XU790 NR2 $PINS O=n1714 I1=n1721 I2=n_idx[4]
XU800 ND2 $PINS O=n1721 I1=n1074 I2=n1555
XU804 OAI222S $PINS O=n1137 A1=n1576 A2=n87 B1=n81 B2=n1719 C1=n1330 C2=n4
XU805 INV1S $PINS O=n995 I=n1761
XU829 INV1S $PINS O=n987 I=n1732
XU830 NR2 $PINS O=n1059 I1=n1653 I2=k_idx[2]
XU831 INV1S $PINS O=n1004 I=n1330
XU833 INV1S $PINS O=n990 I=n1757
XU840 NR2 $PINS O=n1297 I1=n1670 I2=n_idx[4]
XU844 MOAI1S $PINS O=n1217 A1=n1745 A2=n1629 B1=n1503 B2=FE_DBTN200_n1435
XU864 INV1S $PINS O=n999 I=n1461
XU869 OAI222S $PINS O=n1047 A1=n1330 A2=n81 B1=n1576 B2=n114 C1=n1745 C2=n93
XU873 INV1S $PINS O=n1005 I=n1437
XU880 NR2 $PINS O=n1579 I1=n1732 I2=n_idx[4]
XU888 MOAI1S $PINS O=n1100 A1=n1437 A2=n1634 B1=n995 B2=n1716
XU893 INV1S $PINS O=n989 I=n1784
XU895 MOAI1S $PINS O=n1302 A1=n1296 A2=n87 B1=n995 B2=n1503
XU896 ND3 $PINS O=n1770 I1=n1670 I2=n1674 I3=n1672
XU897 AN2 $PINS O=n1052 I1=n1014 I2=n105
XU903 NR2 $PINS O=n1014 I1=k_idx[4] I2=k_idx[2]
XU904 NR2 $PINS O=n1788 I1=n_idx[4] I2=n1566
XU906 NR2 $PINS O=n1080 I1=n1564 I2=k_idx[2]
XU910 AOI22S $PINS O=n1561 A1=n1793 A2=n1568 B1=n982 B2=FE_OFN162_fold_n_1
XU911 AN2 $PINS O=n1056 I1=n1019 I2=n105
XU913 INV1S $PINS O=n964 I=n1566
XU916 INV1S $PINS O=n979 I=n1555
XU917 INV1S $PINS O=n1013 I=n1653
XU918 OAI12HS $PINS O=n1657 A1=n1564 B1=k_idx[4] B2=n105
XU919 NR2 $PINS O=n1651 I1=n977 I2=n1
XU926 NR2 $PINS O=n1793 I1=n978 I2=n_idx[0]
XU928 ND2 $PINS O=n1677 I1=n1793 I2=n1050
XU929 AOI22S $PINS O=n1195 A1=n1183 A2=n101 B1=n109 B2=n996
XU931 ND3 $PINS O=n1183 I1=n1182 I2=n1181 I3=n1180
XU932 NR2 $PINS O=n1180 I1=n1179 I2=n1178
XU933 ND3 $PINS O=sign2[0] I1=n1647 I2=n1646 I3=n1645
XU935 AN4B1S $PINS O=n1645 I1=n1644 I2=n1643 I3=n1642 B1=n1641
XU940 AN4B1S $PINS O=n1647 I1=n112 I2=n1596 I3=n1595 B1=n1659
XU947 NR2 $PINS O=n1029 I1=FE_OFN162_fold_n_1 I2=n_idx[0]
XU954 ND2 $PINS O=n1683 I1=n1029 I2=n1050
XU955 ND3 $PINS O=sign3[0] I1=n1731 I2=n1730 I3=n1729
XU956 AN4B1S $PINS O=n1729 I1=n1728 I2=n1727 I3=n1726 B1=n1725
XU957 AN4B1S $PINS O=n1731 I1=n1662 I2=n1661 I3=n1660 B1=n1659
XU958 ND3 $PINS O=n1397 I1=n1791 I2=n1581 I3=n1396
XU959 ND3 $PINS O=n1393 I1=n1440 I2=n1684 I3=n1392
XU960 NR2 $PINS O=n1741 I1=FE_DBTN208_fold_n_0 I2=n978
XU962 ND3 $PINS O=sign1[0] I1=n1554 I2=n1553 I3=n1552
XU963 NR2 $PINS O=n1553 I1=n1518 I2=n1517
XU964 AN4B1S $PINS O=n1554 I1=n1574 I2=n1509 I3=n1660 B1=n1571
XU965 INV1S $PINS O=n966 I=n1565
XU966 NR2 $PINS O=n1667 I1=n1766 I2=n_idx[0]
XU967 NR2 $PINS O=n1235 I1=n620 I2=n951
XU968 ND2 $PINS O=n1791 I1=n1741 I2=n1050
XU969 NR2 $PINS O=n1348 I1=n963 I2=n_idx[0]
XU970 OAI222S $PINS O=n1748 A1=n1747 A2=n1746 B1=n945 B2=n1745 C1=n1763
+ C2=n1782
XU971 AN4B1S $PINS O=n1747 I1=n94 I2=n125 I3=n1744 B1=n1743
XU972 AOI22S $PINS O=n1744 A1=n1742 A2=n1 B1=n_idx[4] B2=n966
XU973 OR2 $PINS O=n1742 I1=n1741 I2=n1740
XU974 ND2 $PINS O=n1700 I1=n1741 I2=n1028
XU975 NR2 $PINS O=n1043 I1=n950 I2=n978
XU976 ND2 $PINS O=n1735 I1=n1565 I2=n1741
XU977 ND2 $PINS O=n1699 I1=n1029 I2=n1028
XU979 NR2 $PINS O=n1752 I1=n966 I2=n978
XU980 NR2 $PINS O=n1566 I1=n965 I2=n_idx[0]
XU982 ND2 $PINS O=n1768 I1=n1568 I2=n1073
XU983 ND2 $PINS O=n1576 I1=n1024 I2=n1073
XU984 OAI112HS $PINS O=n1493 A1=n101 B1=n980 C1=n969 C2=FE_DBTN207_n3
XU985 NR2 $PINS O=n1568 I1=n103 I2=n1653
XU986 ND2 $PINS O=n1672 I1=n1055 I2=n1024
XU987 ND2 $PINS O=n1782 I1=n1056 I2=n1073
XU988 OAI12HS $PINS O=sign2[1] A1=n1656 B1=n1658 B2=n1657
XU989 AOI22S $PINS O=n1658 A1=n1655 A2=n1013 B1=n1654 B2=n1653
XU990 NR2 $PINS O=n1655 I1=n_idx[4] I2=n1650
XU991 MOAI1S $PINS O=n1654 A1=k_idx[2] A2=n1652 B1=_rom_k_idx_3_1 B2=n1739
XU992 NR2 $PINS O=n1740 I1=n_idx[4] I2=n_idx[0]
XU995 ND2 $PINS O=n1690 I1=n1080 I2=n1055
XU996 ND2 $PINS O=n1732 I1=n1056 I2=n1055
XU998 AN4B1S $PINS O=n1796 I1=n966 I2=n101 I3=n962 B1=n976
XU999 INV1S $PINS O=n105 I=k_idx[3]
XU1001 AN2 $PINS O=n1024 I1=n1019 I2=k_idx[3]
XU1002 NR2 $PINS O=n1019 I1=n103 I2=k_idx[4]
XU1003 AOI12HS $PINS O=n1558 A1=n1755 B1=n1556 B2=n1753
XU1004 ND3 $PINS O=n1792 I1=n966 I2=n101 I3=n1791
XU1005 AN2 $PINS O=n1074 I1=n1014 I2=k_idx[3]
XU1006 NR2 $PINS O=n1072 I1=n1564 I2=n103
XU1007 NR2 $PINS O=n1753 I1=FE_OFN162_fold_n_1 I2=n1
XU1008 AOI13HS $PINS O=n1652 A1=n1651 B1=n_idx[0] B2=_rom_k_idx_3_1 B3=n1753
XU1009 INV1S $PINS O=n993 I=n1556
XU1010 NR2 $PINS O=n1028 I1=n1 I2=n_idx[2]
XU1012 NR2 $PINS O=n1050 I1=n977 I2=n_idx[3]
XU1013 NR2 $PINS O=n1565 I1=n_idx[3] I2=n_idx[2]
XU1016 NR2 $PINS O=n1055 I1=n992 I2=k_idx[1]
XU1017 INV1S $PINS O=n992 I=k_idx[0]
XU1018 NR2 $PINS O=n1556 I1=k_idx[1] I2=k_idx[0]
XU1020 OAI12HS $PINS O=sign1[1] A1=n1656 B1=n1570 B2=n1657
XU1021 AOI22S $PINS O=n1570 A1=n1563 A2=n1653 B1=n1562 B2=n101
XU1022 OAI112HS $PINS O=n1562 A1=n1560 B1=n964 C1=n_idx[3] C2=n1561
XU1023 OAI222S $PINS O=n1563 A1=k_idx[2] A2=n1558 B1=n950 B2=n1557 C1=n993
+ C2=n949
XU1024 INV1S $PINS O=n103 I=k_idx[2]
XU1025 AOI13HS $PINS O=n1567 A1=n101 B1=k_idx[2] B2=k_idx[1] B3=n1566
XU1026 NR2 $PINS O=n1656 I1=n88 I2=n89
XU1027 OAI22S $PINS O=n88 A1=k_idx[0] A2=n_idx[0] B1=n1788 B2=n1013
XU1028 AO13S $PINS O=n89 A1=n1567 B1=n1569 B2=n101 B3=n1568
XU1029 AOI22S $PINS O=n1649 A1=k_idx[2] A2=n1648 B1=n1793 B2=k_idx[1]
XU1030 MOAI1S $PINS O=n1648 A1=n978 A2=n992 B1=FE_DBTN208_fold_n_0 B2=k_idx[1]
XU1031 ND3S $PINS O=n1560 I1=k_idx[1] I2=n1559 I3=n1013
XU1032 MOAI1S $PINS O=n1559 A1=n992 A2=n965 B1=FE_DBTN208_fold_n_0 B2=n1565
XU1033 INV1S $PINS O=n101 I=n_idx[4]
XU349 ND2S $PINS O=n1766 I1=n978 I2=n1028
XU350 ND2S $PINS O=n1736 I1=n1050 I2=n978
XU836 ND2 $PINS O=n81 I1=n1787 I2=n1752
XU943 OA222S $PINS O=n1194 A1=FE_OFN159_n1532 A2=n221 B1=n1187
+ B2=FE_DBTN194_n1787 C1=n1439 C2=n130
XU946 ND3S $PINS O=n1058 I1=n1349 I2=FE_OFN159_n1532 I3=n1438
.ENDS

.SUBCKT SNPS_CLOCK_GATE_HIGH_ROM_Wrapper_Odd_0 EN ENCLK CLK
*.CONNECT net2294 EN
XFE_PHC980_net2297 DELC $PINS O=FE_PHN980_net2297 I=net2297
Xlatch QDBHN $PINS Q=net2297 D=net2294 CKB=CLK
Xmain_gate AN2T $PINS O=ENCLK I1=FE_PHN980_net2297 I2=CLK
.ENDS

.SUBCKT ROM_Wrapper_Odd_0 rst_n en n_in[4] n_in[3] n_in[2] n_in[1] n_in[0]
+ k_idx[4] k_idx[3] k_idx[2] k_idx[1] k_idx[0] reg_sign1[1] reg_sign1[0]
+ reg_sign2[1] reg_sign2[0] reg_sign3[1] reg_sign3[0] reg_shift1[3]
+ reg_shift1[2] reg_shift1[1] reg_shift1[0] reg_shift2[3] reg_shift2[2]
+ reg_shift2[1] reg_shift2[0] reg_shift3[3] reg_shift3[2] reg_shift3[1]
+ reg_shift3[0] _rom_k_idx_3_1 i_rst_n FE_OFN32_i_rst_n clk
*.CONNECT N4 n_in[0]
XCTS_ccl_a_INV_CLK_G1_L8_84 INV4CK $PINS O=CTS_10 I=CTS_11
XCTS_ccl_a_INV_CLK_G1_L7_84 INV2CK $PINS O=CTS_11 I=CTS_12
XFE_OFC265_rom_n_idx_3__1 INV1S $PINS O=n13 I=n_in[1]
Xreg_sign1_reg[1] DFFSBN $PINS Q=reg_sign1[1] D=raw_s1[1] CK=CTS_10 SB=i_rst_n
Xreg_sign2_reg[1] DFFSBN $PINS Q=reg_sign2[1] D=raw_s2[1] CK=CTS_10 SB=i_rst_n
Xreg_sign3_reg[1] DFFSBN $PINS Q=reg_sign3[1] D=raw_s3[1] CK=CTS_10 SB=i_rst_n
Xreg_shift1_reg[3] QDFFRBN $PINS Q=reg_shift1[3] D=raw_h1[3] CK=CTS_10
+ RB=i_rst_n
Xreg_shift3_reg[2] QDFFRBP $PINS Q=reg_shift3[2] D=raw_h3[2] CK=CTS_10
+ RB=i_rst_n
Xreg_sign2_reg[0] QDFFRBN $PINS Q=reg_sign2[0] D=final_s2[0] CK=CTS_10
+ RB=FE_OFN32_i_rst_n
Xreg_sign3_reg[0] QDFFRBN $PINS Q=reg_sign3[0] D=final_s3[0] CK=CTS_10
+ RB=FE_OFN32_i_rst_n
Xreg_sign1_reg[0] QDFFRBN $PINS Q=reg_sign1[0] D=final_s1[0] CK=CTS_10
+ RB=FE_OFN32_i_rst_n
Xreg_shift1_reg[1] QDFFRBP $PINS Q=reg_shift1[1] D=raw_h1[1] CK=CTS_10
+ RB=i_rst_n
Xreg_shift2_reg[1] QDFFRBP $PINS Q=reg_shift2[1] D=raw_h2[1] CK=CTS_10
+ RB=FE_OFN32_i_rst_n
Xreg_shift1_reg[0] QDFFRBP $PINS Q=reg_shift1[0] D=raw_h1[0] CK=CTS_10
+ RB=i_rst_n
Xreg_shift2_reg[3] QDFFRBN $PINS Q=reg_shift2[3] D=raw_h2[3] CK=CTS_10
+ RB=FE_OFN32_i_rst_n
Xreg_shift2_reg[0] QDFFRBN $PINS Q=reg_shift2[0] D=raw_h2[0] CK=CTS_10
+ RB=FE_OFN32_i_rst_n
Xreg_shift2_reg[2] QDFFRBN $PINS Q=reg_shift2[2] D=raw_h2[2] CK=CTS_10
+ RB=FE_OFN32_i_rst_n
Xreg_shift3_reg[0] QDFFRBP $PINS Q=reg_shift3[0] D=raw_h3[0] CK=CTS_10
+ RB=i_rst_n
Xreg_shift1_reg[2] QDFFRBN $PINS Q=reg_shift1[2] D=raw_h1[2] CK=CTS_10
+ RB=FE_OFN32_i_rst_n
Xreg_shift3_reg[3] QDFFRBN $PINS Q=reg_shift3[3] D=raw_h3[3] CK=CTS_10
+ RB=i_rst_n
Xreg_shift3_reg[1] QDFFRBP $PINS Q=reg_shift3[1] D=raw_h3[1] CK=CTS_10
+ RB=FE_OFN32_i_rst_n
XU4 MUX2 $PINS O=fold_n[4] S=N2 A=n_in[4] B=N8
XU5 MOAI1 $PINS O=fold_n[3] A1=n9 A2=N2 B1=N7 B2=N2
XU6 INV1S $PINS O=n1 I=N2
XU9 ND2S $PINS O=n3 I1=sub_17/carry[3] I2=n9
XU13 XNR2HS $PINS O=final_s2[0] I1=raw_s2[0] I2=n10
XU14 XNR2HS $PINS O=final_s3[0] I1=raw_s3[0] I2=n10
XU15 XNR2HS $PINS O=final_s1[0] I1=raw_s1[0] I2=n10
XU16 INV1S $PINS O=n15 I=N4
XU17 MOAI1 $PINS O=fold_n[0] A1=n15 A2=N2 B1=N4 B2=N2
XU19 ND3 $PINS O=n10 I1=N2 I2=n11 I3=k_idx[0]
XU20 ND3 $PINS O=n11 I1=k_idx[4] I2=k_idx[3] I3=n12
XU21 AN2 $PINS O=n12 I1=k_idx[2] I2=k_idx[1]
XU22 OA13S $PINS O=N2 A1=n_in[4] B1=n_in[1] B2=N4 B3=n16
XU23 MOAI1 $PINS O=fold_n[2] A1=n2 A2=n1 B1=n_in[2] B2=n1
XU24 XNR2HS $PINS O=n2 I1=n14 I2=sub_17/carry[2]
XU25 INV1S $PINS O=n14 I=n_in[2]
XU26 INV1S $PINS O=n9 I=n_in[3]
XU27 XOR2HS $PINS O=N8 I1=n_in[4] I2=n3
XU29 XOR2HS $PINS O=N7 I1=n9 I2=sub_17/carry[3]
XU30 AN2 $PINS O=sub_17/carry[3] I1=sub_17/carry[2] I2=n14
XU31 XOR2HS $PINS O=N5 I1=n13 I2=n15
XU32 OR2 $PINS O=n16 I1=n_in[3] I2=n_in[2]
Xrom_inst CSD_ROM_Table_odd_0 $PINS n_idx[4]=fold_n[4] n_idx[3]=fold_n[3]
+ n_idx[2]=fold_n[2] n_idx[1]=fold_n[1] n_idx[0]=fold_n[0] k_idx[4]=k_idx[4]
+ k_idx[3]=k_idx[3] k_idx[2]=k_idx[2] k_idx[1]=k_idx[1] k_idx[0]=k_idx[0]
+ sign1[1]=raw_s1[1] sign1[0]=raw_s1[0] shift1[3]=raw_h1[3] shift1[2]=raw_h1[2]
+ shift1[1]=raw_h1[1] shift1[0]=raw_h1[0] sign2[1]=raw_s2[1] sign2[0]=raw_s2[0]
+ shift2[3]=raw_h2[3] shift2[2]=raw_h2[2] shift2[1]=raw_h2[1] shift2[0]=raw_h2[0]
+ sign3[1]=raw_s3[1] sign3[0]=raw_s3[0] shift3[3]=raw_h3[3] shift3[2]=raw_h3[2]
+ shift3[1]=raw_h3[1] shift3[0]=raw_h3[0] _rom_k_idx_3_1=_rom_k_idx_3_1
Xclk_gate_reg_shift1_reg SNPS_CLOCK_GATE_HIGH_ROM_Wrapper_Odd_0 $PINS EN=en
+ ENCLK=CTS_12 CLK=clk
XU3 NR2 $PINS O=sub_17/carry[2] I1=N4 I2=n_in[1]
XU8 MOAI1S $PINS O=fold_n[1] A1=n13 A2=N2 B1=N5 B2=N2
.ENDS

.SUBCKT SNPS_CLOCK_GATE_HIGH_PE_Shift_Add_7 EN ENCLK CLK_clone1 CLK
*.CONNECT ENCLK net2278
*.CONNECT net2279 EN
XFE_PHC876_net2282 DELC $PINS O=FE_PHN876_net2282 I=net2282
Xlatch QDBHN $PINS Q=net2282 D=net2279 CKB=CLK_clone1
Xmain_gate AN2T $PINS O=net2278 I1=FE_PHN876_net2282 I2=CLK
.ENDS

.SUBCKT PE_Shift_Add_7_DW01_sub_0_DW01_sub_21 A[26] A[25] A[24] A[23] A[22]
+ A[21] A[20] A[19] A[18] A[17] A[16] A[15] A[14] A[13] A[12] A[11] A[10] A[9]
+ A[8] A[7] A[6] A[5] A[4] A[3] A[2] A[1] A[0] B[26] B[25] B[24] B[23] B[22]
+ B[21] B[20] B[19] B[18] B[17] B[16] B[15] B[14] B[13] B[12] B[11] B[10] B[9]
+ B[8] B[7] B[6] B[5] B[4] B[3] B[2] B[1] B[0] CI DIFF[26] DIFF[25] DIFF[24]
+ DIFF[23] DIFF[22] DIFF[21] DIFF[20] DIFF[19] DIFF[18] DIFF[17] DIFF[16]
+ DIFF[15] DIFF[14] DIFF[13] DIFF[12] DIFF[11] DIFF[10] DIFF[9] DIFF[8] DIFF[7]
+ DIFF[6] DIFF[5] DIFF[4] DIFF[3] DIFF[2] DIFF[1] DIFF[0] CO
*.CONNECT DIFF[0] B[0]
XFE_RC_232_0 XOR2HS $PINS O=DIFF[3] I1=n2 I2=n49
XFE_RC_1102_0 XOR2HS $PINS O=DIFF[2] I1=n1 I2=n50
XFE_RC_1090_0 ND2 $PINS O=FE_RN_102_0 I1=B[1] I2=n52
XFE_RC_1089_0 OAI12HS $PINS O=DIFF[1] A1=FE_RN_102_0 B1=B[1] B2=n52
XFE_OFC642_term3_shifted_4 INV1S $PINS O=n48 I=B[4]
XFE_OFC614_term3_shifted_3 INV2 $PINS O=n49 I=B[3]
XU2 INV2 $PINS O=n52 I=B[0]
XU6 AN2 $PINS O=n2 I1=n50 I2=n1
XU7 INV1S $PINS O=n47 I=B[5]
XU9 AN2S $PINS O=n13 I1=n46 I2=n12
XU11 AN2T $PINS O=n3 I1=n2 I2=n49
XU12 AN2 $PINS O=n4 I1=n40 I2=n18
XU13 AN2 $PINS O=n5 I1=n39 I2=n4
XU14 AN2 $PINS O=n6 I1=n38 I2=n5
XU15 AN2 $PINS O=n7 I1=n37 I2=n6
XU16 AN2 $PINS O=n8 I1=n36 I2=n7
XU17 AN2 $PINS O=n9 I1=n35 I2=n8
XU18 AN2 $PINS O=n10 I1=n34 I2=n9
XU19 AN2 $PINS O=n11 I1=n3 I2=n48
XU20 AN2 $PINS O=n12 I1=n11 I2=n47
XU21 AN2 $PINS O=n14 I1=n45 I2=n13
XU22 AN2 $PINS O=n15 I1=n44 I2=n14
XU23 AN2 $PINS O=n16 I1=n43 I2=n15
XU24 AN2 $PINS O=n17 I1=n42 I2=n16
XU25 AN2 $PINS O=n18 I1=n41 I2=n17
XU26 AN2 $PINS O=n19 I1=n33 I2=n10
XU27 AN2 $PINS O=n20 I1=n32 I2=n19
XU28 AN2 $PINS O=n21 I1=n31 I2=n20
XU29 AN2 $PINS O=n22 I1=n30 I2=n21
XU30 AN2 $PINS O=n23 I1=n29 I2=n22
XU31 AN2 $PINS O=n24 I1=n28 I2=n23
XU32 INV1S $PINS O=n40 I=B[12]
XU33 INV1S $PINS O=n39 I=B[13]
XU34 INV1S $PINS O=n38 I=B[14]
XU35 INV1S $PINS O=n37 I=B[15]
XU36 INV1S $PINS O=n36 I=B[16]
XU37 INV1S $PINS O=n35 I=B[17]
XU38 INV1S $PINS O=n34 I=B[18]
XU41 XOR2HS $PINS O=DIFF[9] I1=n43 I2=n15
XU42 XOR2HS $PINS O=DIFF[10] I1=n42 I2=n16
XU43 XOR2HS $PINS O=DIFF[11] I1=n41 I2=n17
XU44 XOR2HS $PINS O=DIFF[12] I1=n40 I2=n18
XU45 XOR2HS $PINS O=DIFF[13] I1=n39 I2=n4
XU46 XOR2HS $PINS O=DIFF[14] I1=n38 I2=n5
XU47 XOR2HS $PINS O=DIFF[15] I1=n37 I2=n6
XU48 XOR2HS $PINS O=DIFF[16] I1=n36 I2=n7
XU49 XOR2HS $PINS O=DIFF[17] I1=n35 I2=n8
XU50 XOR2HS $PINS O=DIFF[18] I1=n34 I2=n9
XU51 XOR2HS $PINS O=DIFF[19] I1=n33 I2=n10
XU52 XOR2HS $PINS O=DIFF[20] I1=n32 I2=n19
XU53 XOR2HS $PINS O=DIFF[21] I1=n31 I2=n20
XU54 XOR2HS $PINS O=DIFF[22] I1=n30 I2=n21
XU55 XOR2HS $PINS O=DIFF[23] I1=n29 I2=n22
XU56 XOR2HS $PINS O=DIFF[24] I1=n28 I2=n23
XU57 XOR2HS $PINS O=DIFF[25] I1=n27 I2=n24
XU58 XOR2HS $PINS O=DIFF[8] I1=n44 I2=n14
XU59 XOR2HS $PINS O=DIFF[7] I1=n45 I2=n13
XU60 XOR2HS $PINS O=DIFF[6] I1=n46 I2=n12
XU61 XOR2HS $PINS O=DIFF[5] I1=n47 I2=n11
XU62 XOR2HS $PINS O=DIFF[4] I1=n48 I2=n3
XU63 INV1S $PINS O=n45 I=B[7]
XU64 INV1S $PINS O=n46 I=B[6]
XU65 INV1S $PINS O=n44 I=B[8]
XU66 INV1S $PINS O=n43 I=B[9]
XU67 INV1S $PINS O=n42 I=B[10]
XU68 INV1S $PINS O=n41 I=B[11]
XU69 XOR2HS $PINS O=DIFF[26] I1=B[26] I2=n26
XU70 INV1S $PINS O=n33 I=B[19]
XU71 INV1S $PINS O=n32 I=B[20]
XU72 INV1S $PINS O=n31 I=B[21]
XU73 INV1S $PINS O=n30 I=B[22]
XU74 INV1S $PINS O=n29 I=B[23]
XU75 INV1S $PINS O=n28 I=B[24]
XU76 INV1S $PINS O=n27 I=B[25]
XU78 ND2 $PINS O=n26 I1=n27 I2=n24
XU1 INV2 $PINS O=n50 I=B[2]
XU3 NR2 $PINS O=n1 I1=DIFF[0] I2=B[1]
.ENDS

.SUBCKT PE_Shift_Add_7_DW01_sub_1_DW01_sub_22 A[26] A[25] A[24] A[23] A[22]
+ A[21] A[20] A[19] A[18] A[17] A[16] A[15] A[14] A[13] A[12] A[11] A[10] A[9]
+ A[8] A[7] A[6] A[5] A[4] A[3] A[2] A[1] A[0] B[26] B[25] B[24] B[23] B[22]
+ B[21] B[20] B[19] B[18] B[17] B[16] B[15] B[14] B[13] B[12] B[11] B[10] B[9]
+ B[8] B[7] B[6] B[5] B[4] B[3] B[2] B[1] B[0] CI DIFF[26] DIFF[25] DIFF[24]
+ DIFF[23] DIFF[22] DIFF[21] DIFF[20] DIFF[19] DIFF[18] DIFF[17] DIFF[16]
+ DIFF[15] DIFF[14] DIFF[13] DIFF[12] DIFF[11] DIFF[10] DIFF[9] DIFF[8] DIFF[7]
+ DIFF[6] DIFF[5] DIFF[4] DIFF[3] DIFF[2] DIFF[1] DIFF[0] CO
*.CONNECT DIFF[0] B[0]
XFE_RC_837_0 XNR2HS $PINS O=DIFF[2] I1=n2 I2=B[2]
XFE_RC_342_0 AN2 $PINS O=FE_RN_185_0 I1=n29 I2=n30
XFE_RC_341_0 AN2 $PINS O=n25 I1=FE_RN_185_0 I2=n23
XFE_RC_969_0 XOR2HS $PINS O=DIFF[1] I1=n53 I2=n52
XU2 NR3 $PINS O=n3 I1=DIFF[0] I2=B[1] I3=B[2]
XU3 INV2 $PINS O=n53 I=B[0]
XU4 INV1S $PINS O=n50 I=B[3]
XU7 INV2 $PINS O=n49 I=B[4]
XU8 INV1S $PINS O=n48 I=B[5]
XU10 AN2 $PINS O=n14 I1=n47 I2=n13
XU11 AN2S $PINS O=n2 I1=n52 I2=n53
XU12 AN2 $PINS O=n4 I1=n3 I2=n50
XU13 AN2 $PINS O=n5 I1=n41 I2=n19
XU14 AN2 $PINS O=n6 I1=n40 I2=n5
XU15 AN2 $PINS O=n7 I1=n39 I2=n6
XU16 AN2 $PINS O=n8 I1=n38 I2=n7
XU17 AN2 $PINS O=n9 I1=n37 I2=n8
XU18 AN2 $PINS O=n10 I1=n36 I2=n9
XU19 AN2 $PINS O=n11 I1=n35 I2=n10
XU20 AN2 $PINS O=n12 I1=n49 I2=n4
XU21 AN2 $PINS O=n13 I1=n12 I2=n48
XU22 AN2 $PINS O=n15 I1=n46 I2=n14
XU23 AN2 $PINS O=n16 I1=n45 I2=n15
XU24 AN2 $PINS O=n17 I1=n44 I2=n16
XU25 AN2 $PINS O=n18 I1=n43 I2=n17
XU26 AN2 $PINS O=n19 I1=n42 I2=n18
XU27 AN2 $PINS O=n20 I1=n34 I2=n11
XU28 AN2 $PINS O=n21 I1=n33 I2=n20
XU29 AN2 $PINS O=n22 I1=n32 I2=n21
XU30 AN2 $PINS O=n23 I1=n31 I2=n22
XU31 AN2 $PINS O=n24 I1=n30 I2=n23
XU33 INV1S $PINS O=n41 I=B[12]
XU34 INV1S $PINS O=n40 I=B[13]
XU35 INV1S $PINS O=n39 I=B[14]
XU36 INV1S $PINS O=n38 I=B[15]
XU37 INV1S $PINS O=n37 I=B[16]
XU38 INV1S $PINS O=n36 I=B[17]
XU39 INV1S $PINS O=n35 I=B[18]
XU40 INV1S $PINS O=n46 I=B[7]
XU41 INV1S $PINS O=n47 I=B[6]
XU42 INV1S $PINS O=n45 I=B[8]
XU43 INV1S $PINS O=n44 I=B[9]
XU44 INV1S $PINS O=n43 I=B[10]
XU45 INV1S $PINS O=n42 I=B[11]
XU46 XOR2HS $PINS O=DIFF[26] I1=B[26] I2=n27
XU47 INV1S $PINS O=n34 I=B[19]
XU48 INV1S $PINS O=n33 I=B[20]
XU49 INV1S $PINS O=n32 I=B[21]
XU50 INV1S $PINS O=n31 I=B[22]
XU51 INV1S $PINS O=n30 I=B[23]
XU52 INV1S $PINS O=n29 I=B[24]
XU53 INV1S $PINS O=n28 I=B[25]
XU55 XOR2HS $PINS O=DIFF[9] I1=n44 I2=n16
XU56 XOR2HS $PINS O=DIFF[10] I1=n43 I2=n17
XU57 XOR2HS $PINS O=DIFF[11] I1=n42 I2=n18
XU58 XOR2HS $PINS O=DIFF[12] I1=n41 I2=n19
XU59 XOR2HS $PINS O=DIFF[13] I1=n40 I2=n5
XU60 XOR2HS $PINS O=DIFF[14] I1=n39 I2=n6
XU61 XOR2HS $PINS O=DIFF[15] I1=n38 I2=n7
XU62 XOR2HS $PINS O=DIFF[16] I1=n37 I2=n8
XU63 XOR2HS $PINS O=DIFF[17] I1=n36 I2=n9
XU64 XOR2HS $PINS O=DIFF[18] I1=n35 I2=n10
XU65 XOR2HS $PINS O=DIFF[19] I1=n34 I2=n11
XU66 XOR2HS $PINS O=DIFF[20] I1=n33 I2=n20
XU67 XOR2HS $PINS O=DIFF[21] I1=n32 I2=n21
XU68 XOR2HS $PINS O=DIFF[22] I1=n31 I2=n22
XU69 XOR2HS $PINS O=DIFF[23] I1=n30 I2=n23
XU70 XOR2HS $PINS O=DIFF[24] I1=n29 I2=n24
XU71 XOR2HS $PINS O=DIFF[25] I1=n28 I2=n25
XU72 XOR2HS $PINS O=DIFF[8] I1=n45 I2=n15
XU73 XOR2HS $PINS O=DIFF[7] I1=n46 I2=n14
XU74 XOR2HS $PINS O=DIFF[6] I1=n47 I2=n13
XU75 XOR2HS $PINS O=DIFF[5] I1=n48 I2=n12
XU76 XOR2HS $PINS O=DIFF[4] I1=n49 I2=n4
XU77 XOR2HS $PINS O=DIFF[3] I1=n3 I2=n50
XU79 ND2 $PINS O=n27 I1=n28 I2=n25
XU5 INV2 $PINS O=n52 I=B[1]
.ENDS

.SUBCKT PE_Shift_Add_7_DW01_sub_2_DW01_sub_23 A[26] A[25] A[24] A[23] A[22]
+ A[21] A[20] A[19] A[18] A[17] A[16] A[15] A[14] A[13] A[12] A[11] A[10] A[9]
+ A[8] A[7] A[6] A[5] A[4] A[3] A[2] A[1] A[0] B[26] B[25] B[24] B[23] B[22]
+ B[21] B[20] B[19] B[18] B[17] B[16] B[15] B[14] B[13] B[12] B[11] B[10] B[9]
+ B[8] B[7] B[6] B[5] B[4] B[3] B[2] B[1] B[0] CI DIFF[26] DIFF[25] DIFF[24]
+ DIFF[23] DIFF[22] DIFF[21] DIFF[20] DIFF[19] DIFF[18] DIFF[17] DIFF[16]
+ DIFF[15] DIFF[14] DIFF[13] DIFF[12] DIFF[11] DIFF[10] DIFF[9] DIFF[8] DIFF[7]
+ DIFF[6] DIFF[5] DIFF[4] DIFF[3] DIFF[2] DIFF[1] DIFF[0] CO
*.CONNECT DIFF[0] B[0]
XFE_RC_610_0 AN2B1T $PINS O=n16 I1=n15 B1=B[9]
XFE_RC_471_0 XNR2HS $PINS O=DIFF[10] I1=B[10] I2=n16
XFE_RC_294_0 XNR2HS $PINS O=DIFF[7] I1=B[7] I2=n13
XFE_RC_1437_0 INV1S $PINS O=FE_RN_285_0 I=n49
XFE_RC_1436_0 MXL2HS $PINS OB=DIFF[3] S=n3 A=FE_RN_285_0 B=n49
XFE_RC_1327_0 XOR2HS $PINS O=DIFF[2] I1=n1 I2=n50
XFE_RC_1058_0 XOR2HS $PINS O=DIFF[1] I1=n52 I2=n51
XFE_OFC617_term1_shifted_7 INV1S $PINS O=n45 I=B[7]
XU3 INV1S $PINS O=n52 I=B[0]
XU7 INV2 $PINS O=n51 I=B[1]
XU8 INV1S $PINS O=n47 I=B[5]
XU10 XOR2HS $PINS O=DIFF[5] I1=n47 I2=n11
XU11 INV1S $PINS O=n46 I=B[6]
XU13 ND2S $PINS O=n26 I1=n27 I2=n24
XU15 AN2T $PINS O=n1 I1=n51 I2=n52
XU16 AN2T $PINS O=n2 I1=n3 I2=n49
XU17 AN2T $PINS O=n3 I1=n50 I2=n1
XU18 XOR2HS $PINS O=DIFF[12] I1=n40 I2=n18
XU19 XOR2HS $PINS O=DIFF[13] I1=n39 I2=n4
XU20 AN2 $PINS O=n4 I1=n40 I2=n18
XU21 XOR2HS $PINS O=DIFF[14] I1=n38 I2=n5
XU22 AN2 $PINS O=n5 I1=n39 I2=n4
XU23 XOR2HS $PINS O=DIFF[15] I1=n37 I2=n6
XU24 AN2 $PINS O=n6 I1=n38 I2=n5
XU25 XOR2HS $PINS O=DIFF[16] I1=n36 I2=n7
XU26 AN2 $PINS O=n7 I1=n37 I2=n6
XU27 XOR2HS $PINS O=DIFF[17] I1=n35 I2=n8
XU28 AN2 $PINS O=n8 I1=n36 I2=n7
XU29 XOR2HS $PINS O=DIFF[18] I1=n34 I2=n9
XU30 AN2 $PINS O=n9 I1=n35 I2=n8
XU31 AN2 $PINS O=n10 I1=n34 I2=n9
XU32 XOR2HS $PINS O=DIFF[4] I1=n48 I2=n2
XU33 AN2 $PINS O=n11 I1=n2 I2=n48
XU34 XOR2HS $PINS O=DIFF[6] I1=n46 I2=n12
XU35 AN2 $PINS O=n12 I1=n47 I2=n11
XU37 AN2 $PINS O=n13 I1=n46 I2=n12
XU38 XOR2HS $PINS O=DIFF[8] I1=n44 I2=n14
XU39 AN2 $PINS O=n14 I1=n13 I2=n45
XU40 XOR2HS $PINS O=DIFF[9] I1=n43 I2=n15
XU41 AN2 $PINS O=n15 I1=n44 I2=n14
XU44 XOR2HS $PINS O=DIFF[11] I1=n41 I2=n17
XU45 AN2 $PINS O=n17 I1=n42 I2=n16
XU46 AN2 $PINS O=n18 I1=n41 I2=n17
XU47 XOR2HS $PINS O=DIFF[19] I1=n33 I2=n10
XU48 XOR2HS $PINS O=DIFF[20] I1=n32 I2=n19
XU49 AN2 $PINS O=n19 I1=n33 I2=n10
XU50 XOR2HS $PINS O=DIFF[21] I1=n31 I2=n20
XU51 AN2 $PINS O=n20 I1=n32 I2=n19
XU52 XOR2HS $PINS O=DIFF[22] I1=n30 I2=n21
XU53 AN2 $PINS O=n21 I1=n31 I2=n20
XU54 XOR2HS $PINS O=DIFF[23] I1=n29 I2=n22
XU55 AN2 $PINS O=n22 I1=n30 I2=n21
XU56 XOR2HS $PINS O=DIFF[24] I1=n28 I2=n23
XU57 AN2 $PINS O=n23 I1=n29 I2=n22
XU58 AN2 $PINS O=n24 I1=n28 I2=n23
XU59 XOR2HS $PINS O=DIFF[25] I1=n27 I2=n24
XU60 INV1S $PINS O=n40 I=B[12]
XU61 INV1S $PINS O=n39 I=B[13]
XU62 INV1S $PINS O=n38 I=B[14]
XU63 INV1S $PINS O=n37 I=B[15]
XU64 INV1S $PINS O=n36 I=B[16]
XU65 INV1S $PINS O=n35 I=B[17]
XU66 INV1S $PINS O=n34 I=B[18]
XU67 INV1S $PINS O=n44 I=B[8]
XU68 INV1S $PINS O=n43 I=B[9]
XU69 INV1S $PINS O=n42 I=B[10]
XU70 INV1S $PINS O=n41 I=B[11]
XU71 XOR2HS $PINS O=DIFF[26] I1=B[26] I2=n26
XU72 INV1S $PINS O=n33 I=B[19]
XU73 INV1S $PINS O=n32 I=B[20]
XU74 INV1S $PINS O=n31 I=B[21]
XU75 INV1S $PINS O=n30 I=B[22]
XU76 INV1S $PINS O=n29 I=B[23]
XU77 INV1S $PINS O=n28 I=B[24]
XU78 INV1S $PINS O=n27 I=B[25]
XU1 INV2 $PINS O=n48 I=B[4]
XU2 INV2 $PINS O=n49 I=B[3]
XU4 INV2 $PINS O=n50 I=B[2]
.ENDS

.SUBCKT PE_Shift_Add_7_DW01_add_2_DW01_add_25 A[26] A[25] A[24] A[23] A[22]
+ A[21] A[20] A[19] A[18] A[17] A[16] A[15] A[14] A[13] A[12] A[11] A[10] A[9]
+ A[8] A[7] A[6] A[5] A[4] A[3] A[2] A[1] A[0] B[26] B[25] B[24] B[23] B[22]
+ B[21] B[20] B[19] B[18] B[17] B[16] B[15] B[14] B[13] B[12] B[11] B[10] B[9]
+ B[8] B[7] B[6] B[5] B[4] B[3] B[2] B[1] B[0] CI SUM[26] SUM[25] SUM[24]
+ SUM[23] SUM[22] SUM[21] SUM[20] SUM[19] SUM[18] SUM[17] SUM[16] SUM[15]
+ SUM[14] SUM[13] SUM[12] SUM[11] SUM[10] SUM[9] SUM[8] SUM[7] SUM[6] SUM[5]
+ SUM[4] SUM[3] SUM[2] SUM[1] SUM[0] CO
XFE_RC_760_0 INV2 $PINS O=SUM[3] I=FE_RN_362_0
XFE_RC_759_0 XNR3 $PINS O=FE_RN_362_0 I1=A[3] I2=B[3] I3=carry[3]
XFE_RC_708_0 INV2CK $PINS O=SUM[15] I=FE_RN_341_0
XFE_RC_707_0 XNR3 $PINS O=FE_RN_341_0 I1=A[15] I2=B[15] I3=carry[15]
XFE_RC_603_0 INV2 $PINS O=SUM[16] I=FE_RN_297_0
XFE_RC_602_0 XNR3 $PINS O=FE_RN_297_0 I1=A[16] I2=B[16] I3=carry[16]
XFE_RC_441_0 INV2 $PINS O=SUM[6] I=FE_RN_230_0
XFE_RC_440_0 XNR3 $PINS O=FE_RN_230_0 I1=B[6] I2=A[6] I3=carry[6]
XFE_RC_243_0 ND2S $PINS O=FE_RN_130_0 I1=B[23] I2=A[23]
XFE_RC_242_0 ND2 $PINS O=FE_RN_131_0 I1=FE_RN_134_0 I2=carry[23]
XFE_RC_241_0 ND2 $PINS O=carry[24] I1=FE_RN_131_0 I2=FE_RN_130_0
XFE_RC_240_0 NR2 $PINS O=FE_RN_132_0 I1=A[24] I2=B[24]
XFE_RC_239_0 INV1S $PINS O=FE_RN_133_0 I=B[23]
XFE_RC_238_0 OR2B1S $PINS O=FE_RN_134_0 I1=A[23] B1=FE_RN_133_0
XFE_RC_237_0 AOI22S $PINS O=FE_RN_135_0 A1=B[23] A2=A[23] B1=FE_RN_134_0
+ B2=carry[23]
XFE_RC_236_0 MOAI1 $PINS O=carry[25] A1=FE_RN_135_0 A2=FE_RN_132_0 B1=B[24]
+ B2=A[24]
XFE_RC_974_0 XOR3 $PINS O=SUM[24] I1=A[24] I2=B[24] I3=carry[24]
XFE_RC_858_0 XOR3 $PINS O=SUM[25] I1=A[25] I2=B[25] I3=carry[25]
XFE_RC_857_0 MAO222 $PINS O=carry[26] A1=carry[25] B1=B[25] C1=A[25]
XFE_RC_796_0 XOR3 $PINS O=SUM[23] I1=A[23] I2=B[23] I3=carry[23]
XFE_RC_750_0 XOR3 $PINS O=SUM[19] I1=A[19] I2=B[19] I3=carry[19]
XFE_RC_742_0 XOR3 $PINS O=SUM[22] I1=A[22] I2=B[22] I3=carry[22]
XFE_RC_741_0 MAO222P $PINS O=carry[23] A1=carry[22] B1=B[22] C1=A[22]
XFE_RC_690_0 XOR3 $PINS O=SUM[21] I1=A[21] I2=B[21] I3=carry[21]
XFE_RC_689_0 MAO222 $PINS O=carry[22] A1=carry[21] B1=B[21] C1=A[21]
XFE_RC_563_0 MAO222 $PINS O=carry[4] A1=carry[3] B1=A[3] C1=B[3]
XFE_RC_561_0 MAO222P $PINS O=carry[17] A1=carry[16] B1=B[16] C1=A[16]
XFE_RC_504_0 XOR3 $PINS O=SUM[17] I1=A[17] I2=B[17] I3=carry[17]
XFE_RC_503_0 MAO222P $PINS O=carry[18] A1=carry[17] B1=B[17] C1=A[17]
XFE_RC_479_0 MAO222P $PINS O=carry[16] A1=carry[15] B1=B[15] C1=A[15]
XFE_RC_374_0 XOR3 $PINS O=SUM[18] I1=A[18] I2=B[18] I3=carry[18]
XFE_RC_373_0 MAO222P $PINS O=carry[19] A1=carry[18] B1=B[18] C1=A[18]
XFE_RC_370_0 XOR3 $PINS O=SUM[14] I1=A[14] I2=B[14] I3=carry[14]
XFE_RC_369_0 MAO222P $PINS O=carry[15] A1=carry[14] B1=B[14] C1=A[14]
XFE_RC_268_0 XOR3 $PINS O=SUM[5] I1=A[5] I2=B[5] I3=carry[5]
XFE_RC_267_0 MAO222 $PINS O=carry[6] A1=carry[5] B1=B[5] C1=A[5]
XFE_RC_264_0 XOR3 $PINS O=SUM[13] I1=A[13] I2=B[13] I3=carry[13]
XFE_RC_263_0 MAO222P $PINS O=carry[14] A1=carry[13] B1=B[13] C1=A[13]
XFE_RC_191_0 MAO222 $PINS O=carry[7] A1=carry[6] B1=B[6] C1=A[6]
XFE_RC_132_0 XOR3 $PINS O=SUM[7] I1=A[7] I2=B[7] I3=carry[7]
XFE_RC_131_0 MAO222P $PINS O=carry[8] A1=carry[7] B1=B[7] C1=A[7]
XFE_RC_66_0 XOR3 $PINS O=SUM[8] I1=A[8] I2=B[8] I3=carry[8]
XFE_RC_65_0 MAO222P $PINS O=carry[9] A1=carry[8] B1=B[8] C1=A[8]
XFE_RC_64_0 XOR3 $PINS O=SUM[11] I1=A[11] I2=B[11] I3=carry[11]
XFE_RC_63_0 MAO222P $PINS O=carry[12] A1=carry[11] B1=B[11] C1=A[11]
XFE_RC_34_0 XOR3 $PINS O=SUM[12] I1=A[12] I2=B[12] I3=carry[12]
XFE_RC_33_0 MAO222P $PINS O=carry[13] A1=carry[12] B1=B[12] C1=A[12]
XFE_RC_32_0 XOR3 $PINS O=SUM[9] I1=A[9] I2=B[9] I3=carry[9]
XFE_RC_31_0 MAO222P $PINS O=carry[10] A1=carry[9] B1=B[9] C1=A[9]
XFE_RC_24_0 XOR3 $PINS O=SUM[10] I1=A[10] I2=B[10] I3=carry[10]
XFE_RC_23_0 MAO222P $PINS O=carry[11] A1=carry[10] B1=B[10] C1=A[10]
XU1_26 XOR3 $PINS O=SUM[26] I1=A[26] I2=B[26] I3=carry[26]
XU1 MAO222P $PINS O=n1 A1=carry[19] B1=B[19] C1=A[19]
XU2 ND3P $PINS O=carry[3] I1=n9 I2=n8 I3=n7
XU3 ND3P $PINS O=carry[5] I1=n3 I2=n4 I3=n5
XU4 ND2P $PINS O=n12 I1=n2 I2=B[1]
XU5 AN2T $PINS O=n2 I1=B[0] I2=A[0]
XU6 XOR3 $PINS O=SUM[4] I1=A[4] I2=B[4] I3=carry[4]
XU7 ND2 $PINS O=n3 I1=carry[4] I2=B[4]
XU8 ND2 $PINS O=n4 I1=carry[4] I2=A[4]
XU9 ND2 $PINS O=n5 I1=A[4] I2=B[4]
XU10 ND2 $PINS O=n9 I1=A[2] I2=B[2]
XU11 XOR2HS $PINS O=n6 I1=A[2] I2=B[2]
XU12 XOR2HS $PINS O=SUM[2] I1=carry[2] I2=n6
XU13 ND2P $PINS O=n7 I1=carry[2] I2=A[2]
XU14 ND2P $PINS O=n8 I1=carry[2] I2=B[2]
XU15 XOR3 $PINS O=SUM[1] I1=n2 I2=B[1] I3=A[1]
XU16 ND2 $PINS O=n10 I1=A[1] I2=n2
XU17 ND2 $PINS O=n11 I1=A[1] I2=B[1]
XU18 ND3P $PINS O=carry[2] I1=n11 I2=n10 I3=n12
XU19 XOR2HS $PINS O=n13 I1=A[20] I2=B[20]
XU20 XOR2HS $PINS O=SUM[20] I1=n1 I2=n13
XU21 ND2 $PINS O=n14 I1=n1 I2=A[20]
XU22 ND2P $PINS O=n15 I1=n1 I2=B[20]
XU23 ND2S $PINS O=n16 I1=A[20] I2=B[20]
XU24 ND3P $PINS O=carry[21] I1=n14 I2=n15 I3=n16
XU25 XOR2HS $PINS O=SUM[0] I1=B[0] I2=A[0]
.ENDS

.SUBCKT PE_Shift_Add_7_DW01_add_1_DW01_add_24 A[26] A[25] A[24] A[23] A[22]
+ A[21] A[20] A[19] A[18] A[17] A[16] A[15] A[14] A[13] A[12] A[11] A[10] A[9]
+ A[8] A[7] A[6] A[5] A[4] A[3] A[2] A[1] A[0] B[26] B[25] B[24] B[23] B[22]
+ B[21] B[20] B[19] B[18] B[17] B[16] B[15] B[14] B[13] B[12] B[11] B[10] B[9]
+ B[8] B[7] B[6] B[5] B[4] B[3] B[2] B[1] B[0] CI SUM[26] SUM[25] SUM[24]
+ SUM[23] SUM[22] SUM[21] SUM[20] SUM[19] SUM[18] SUM[17] SUM[16] SUM[15]
+ SUM[14] SUM[13] SUM[12] SUM[11] SUM[10] SUM[9] SUM[8] SUM[7] SUM[6] SUM[5]
+ SUM[4] SUM[3] SUM[2] SUM[1] SUM[0] CO
XFE_RC_846_0 INV2 $PINS O=SUM[24] I=FE_RN_401_0
XFE_RC_845_0 XOR2HS $PINS O=FE_RN_402_0 I1=A[24] I2=B[24]
XFE_RC_844_0 XNR2HS $PINS O=FE_RN_401_0 I1=FE_RN_402_0 I2=carry_24
XFE_RC_674_0 INV2 $PINS O=SUM[16] I=FE_RN_324_0
XFE_RC_673_0 XNR3 $PINS O=FE_RN_324_0 I1=A[16] I2=B[16] I3=carry_16
XFE_RC_663_0 INV2 $PINS O=SUM[18] I=FE_RN_319_0
XFE_RC_662_0 XNR3 $PINS O=FE_RN_319_0 I1=A[18] I2=B[18] I3=carry_18
XFE_RC_475_0 INV2 $PINS O=SUM[4] I=FE_RN_245_0
XFE_RC_474_0 XNR3 $PINS O=FE_RN_245_0 I1=A[4] I2=B[4] I3=carry_4
XFE_RC_458_0 INV2 $PINS O=SUM[5] I=FE_RN_238_0
XFE_RC_457_0 XNR3 $PINS O=FE_RN_238_0 I1=A[5] I2=B[5] I3=carry_5
XFE_RC_412_0 INV2 $PINS O=SUM[1] I=FE_RN_218_0
XFE_RC_411_0 XNR3 $PINS O=FE_RN_218_0 I1=A[1] I2=n1 I3=B[1]
XFE_RC_410_0 INV2 $PINS O=SUM[6] I=FE_RN_217_0
XFE_RC_409_0 XNR3 $PINS O=FE_RN_217_0 I1=A[6] I2=B[6] I3=carry_6
XFE_RC_353_0 INV2 $PINS O=SUM[25] I=FE_RN_187_0
XFE_RC_352_0 XNR2HS $PINS O=FE_RN_189_0 I1=A[25] I2=B[25]
XFE_RC_351_0 INV1S $PINS O=FE_RN_188_0 I=FE_RN_189_0
XFE_RC_350_0 XNR2HS $PINS O=FE_RN_187_0 I1=FE_RN_188_0 I2=carry_25
XFE_RC_298_0 ND3P $PINS O=carry_3 I1=n10 I2=n9 I3=n11
XFE_RC_231_0 AOI13HS $PINS O=FE_RN_100_0 A1=FE_RN_99_0 B1=carry_25
+ B2=FE_RN_96_0 B3=FE_RN_102_0
XFE_RC_172_0 INV1S $PINS O=FE_RN_96_0 I=FE_RN_101_0
XFE_RC_171_0 ND2S $PINS O=FE_RN_97_0 I1=A[25] I2=B[25]
XFE_RC_170_0 ND2S $PINS O=FE_RN_98_0 I1=FE_RN_101_0 I2=FE_RN_97_0
XFE_RC_169_0 NR2 $PINS O=FE_RN_99_0 I1=FE_RN_98_0 I2=carry_25
XFE_RC_167_1 XOR2HS $PINS O=FE_RN_101_0 I1=A[26] I2=B[26]
XFE_RC_166_1 OR2 $PINS O=FE_RN_102_0 I1=B[25] I2=A[25]
XFE_RC_165_0 OR2B1S $PINS O=FE_RN_103_0 I1=FE_RN_102_0 B1=FE_RN_101_0
XFE_RC_164_0 OAI112H $PINS O=SUM[26] A1=FE_RN_100_0 B1=FE_RN_103_0
+ C1=FE_RN_101_0 C2=FE_RN_97_0
XFE_RC_1585_0 ND2 $PINS O=FE_RN_368_0 I1=B[4] I2=A[4]
XFE_RC_1584_0 ND2 $PINS O=FE_RN_369_0 I1=carry_4 I2=A[4]
XFE_RC_1583_0 ND2 $PINS O=FE_RN_370_0 I1=carry_4 I2=B[4]
XFE_RC_1582_0 ND3 $PINS O=carry_5 I1=FE_RN_370_0 I2=FE_RN_369_0 I3=FE_RN_368_0
XFE_RC_1010_0 ND2 $PINS O=FE_RN_62_0 I1=B[1] I2=n1
XFE_RC_1009_0 AOI22HP $PINS O=FE_RN_63_0 A1=n1 A2=A[1] B1=B[1] B2=A[1]
XFE_RC_1008_0 ND2P $PINS O=carry_2 I1=FE_RN_63_0 I2=FE_RN_62_0
XFE_RC_997_0 MAO222 $PINS O=carry_25 A1=carry_24 B1=B[24] C1=A[24]
XFE_RC_770_0 XOR3 $PINS O=SUM[22] I1=A[22] I2=B[22] I3=carry_22
XFE_RC_769_0 MAO222 $PINS O=carry_23 A1=carry_22 B1=B[22] C1=A[22]
XFE_RC_756_0 XOR3 $PINS O=SUM[23] I1=A[23] I2=B[23] I3=carry_23
XFE_RC_755_0 MAO222 $PINS O=carry_24 A1=carry_23 B1=B[23] C1=A[23]
XFE_RC_672_0 XOR3 $PINS O=SUM[20] I1=A[20] I2=B[20] I3=carry_20
XFE_RC_671_0 MAO222P $PINS O=carry_21 A1=carry_20 B1=B[20] C1=A[20]
XFE_RC_636_0 XOR3 $PINS O=SUM[21] I1=A[21] I2=B[21] I3=carry_21
XFE_RC_635_0 MAO222P $PINS O=carry_22 A1=carry_21 B1=B[21] C1=A[21]
XFE_RC_576_0 XOR3 $PINS O=SUM[15] I1=A[15] I2=B[15] I3=carry_15
XFE_RC_575_0 MAO222 $PINS O=carry_16 A1=carry_15 B1=B[15] C1=A[15]
XFE_RC_536_0 XOR3 $PINS O=SUM[14] I1=A[14] I2=B[14] I3=carry_14
XFE_RC_535_0 MAO222 $PINS O=carry_15 A1=carry_14 B1=B[14] C1=A[14]
XFE_RC_451_0 MAO222 $PINS O=carry_17 A1=carry_16 B1=B[16] C1=A[16]
XFE_RC_422_0 XOR3 $PINS O=SUM[17] I1=A[17] I2=B[17] I3=carry_17
XFE_RC_421_0 MAO222P $PINS O=carry_18 A1=carry_17 B1=B[17] C1=A[17]
XFE_RC_344_0 XOR3 $PINS O=SUM[3] I1=A[3] I2=B[3] I3=carry_3
XFE_RC_343_0 MAO222P $PINS O=carry_4 A1=carry_3 B1=B[3] C1=A[3]
XFE_RC_315_0 MAO222P $PINS O=carry_19 A1=carry_18 B1=B[18] C1=A[18]
XFE_RC_166_0 MAO222 $PINS O=carry_6 A1=carry_5 B1=B[5] C1=A[5]
XFE_RC_156_0 XOR3 $PINS O=SUM[13] I1=A[13] I2=B[13] I3=carry_13
XFE_RC_155_0 MAO222 $PINS O=carry_14 A1=carry_13 B1=B[13] C1=A[13]
XFE_RC_152_0 XOR3 $PINS O=SUM[19] I1=A[19] I2=B[19] I3=carry_19
XFE_RC_151_0 MAO222P $PINS O=carry_20 A1=carry_19 B1=B[19] C1=A[19]
XFE_RC_91_0 MAO222P $PINS O=carry_7 A1=carry_6 B1=B[6] C1=A[6]
XFE_RC_44_0 XOR3 $PINS O=SUM[8] I1=A[8] I2=B[8] I3=carry_8
XFE_RC_43_0 MAO222P $PINS O=carry_9 A1=carry_8 B1=B[8] C1=A[8]
XFE_RC_38_0 XOR3 $PINS O=SUM[11] I1=A[11] I2=B[11] I3=carry_11
XFE_RC_37_0 MAO222P $PINS O=carry_12 A1=carry_11 B1=B[11] C1=A[11]
XU2 ND3P $PINS O=carry_13 I1=n2 I2=n3 I3=n4
XU3 ND3P $PINS O=carry_10 I1=n17 I2=n18 I3=n19
XU4 ND2 $PINS O=n13 I1=carry_10 I2=B[10]
XU5 ND2 $PINS O=n14 I1=carry_10 I2=A[10]
XU6 AN2T $PINS O=n1 I1=B[0] I2=A[0]
XU7 XOR3 $PINS O=SUM[12] I1=B[12] I2=A[12] I3=carry_12
XU8 ND2 $PINS O=n2 I1=carry_12 I2=B[12]
XU9 ND2P $PINS O=n3 I1=carry_12 I2=A[12]
XU10 ND2 $PINS O=n4 I1=B[12] I2=A[12]
XU11 XOR3 $PINS O=SUM[7] I1=B[7] I2=A[7] I3=carry_7
XU12 ND2 $PINS O=n5 I1=carry_7 I2=B[7]
XU13 ND2P $PINS O=n6 I1=carry_7 I2=A[7]
XU14 ND2 $PINS O=n7 I1=B[7] I2=A[7]
XU15 ND3P $PINS O=carry_8 I1=n5 I2=n6 I3=n7
XU16 XOR2HS $PINS O=n8 I1=A[2] I2=B[2]
XU17 XOR2HS $PINS O=SUM[2] I1=carry_2 I2=n8
XU18 ND2 $PINS O=n9 I1=carry_2 I2=B[2]
XU19 ND2 $PINS O=n10 I1=carry_2 I2=A[2]
XU20 ND2 $PINS O=n11 I1=B[2] I2=A[2]
XU21 XOR2HS $PINS O=n12 I1=B[10] I2=A[10]
XU22 XOR2HS $PINS O=SUM[10] I1=carry_10 I2=n12
XU23 ND2S $PINS O=n15 I1=B[10] I2=A[10]
XU24 ND3P $PINS O=carry_11 I1=n14 I2=n13 I3=n15
XU25 XOR2HS $PINS O=n16 I1=B[9] I2=A[9]
XU26 XOR2HS $PINS O=SUM[9] I1=carry_9 I2=n16
XU27 ND2 $PINS O=n17 I1=carry_9 I2=B[9]
XU28 ND2P $PINS O=n18 I1=carry_9 I2=A[9]
XU29 ND2S $PINS O=n19 I1=B[9] I2=A[9]
XU30 XOR2HS $PINS O=SUM[0] I1=B[0] I2=A[0]
.ENDS

.SUBCKT PE_Shift_Add_7_DW01_add_0_DW01_add_23 A[26] A[25] A[24] A[23] A[22]
+ A[21] A[20] A[19] A[18] A[17] A[16] A[15] A[14] A[13] A[12] A[11] A[10] A[9]
+ A[8] A[7] A[6] A[5] A[4] A[3] A[2] A[1] A[0] B[26] B[25] B[24] B[23] B[22]
+ B[21] B[20] B[19] B[18] B[17] B[16] B[15] B[14] B[13] B[12] B[11] B[10] B[9]
+ B[8] B[7] B[6] B[5] B[4] B[3] B[2] B[1] B[0] CI SUM[26] SUM[25] SUM[24]
+ SUM[23] SUM[22] SUM[21] SUM[20] SUM[19] SUM[18] SUM[17] SUM[16] SUM[15]
+ SUM[14] SUM[13] SUM[12] SUM[11] SUM[10] SUM[9] SUM[8] SUM[7] SUM[6] SUM[5]
+ SUM[4] SUM[3] SUM[2] SUM[1] SUM[0] CO
XFE_RC_841_0 XNR2HS $PINS O=FE_RN_399_0 I1=A[26] I2=B[26]
XFE_RC_840_0 XNR2H $PINS O=SUM[26] I1=FE_RN_399_0 I2=carry[26]
XFE_RC_437_0 INV2CK $PINS O=n10 I=FE_RN_228_0
XFE_RC_436_0 INV2CK $PINS O=FE_RN_229_0 I=B[11]
XFE_RC_435_0 AOI13H $PINS O=FE_RN_228_0 A1=FE_RN_229_0 B1=n7 B2=n6 B3=n8
XFE_RC_277_0 ND3P $PINS O=carry[3] I1=n4 I2=n3 I3=n5
XFE_RC_255_0 ND3P $PINS O=carry[25] I1=FE_RN_65_0 I2=FE_RN_66_0 I3=FE_RN_64_0
XFE_RC_247_0 ND3P $PINS O=carry[4] I1=FE_RN_288_0 I2=FE_RN_289_0 I3=FE_RN_287_0
XFE_RC_110_0 ND2 $PINS O=FE_RN_64_0 I1=B[24] I2=A[24]
XFE_RC_109_0 ND2P $PINS O=FE_RN_65_0 I1=carry[24] I2=A[24]
XFE_RC_108_0 ND2P $PINS O=FE_RN_66_0 I1=carry[24] I2=B[24]
XFE_RC_65_0 ND2 $PINS O=FE_RN_35_0 I1=B[25] I2=A[25]
XFE_RC_64_0 ND2 $PINS O=FE_RN_36_0 I1=carry[25] I2=A[25]
XFE_RC_63_0 ND2 $PINS O=FE_RN_37_0 I1=carry[25] I2=B[25]
XFE_RC_62_0 ND3P $PINS O=carry[26] I1=FE_RN_37_0 I2=FE_RN_36_0 I3=FE_RN_35_0
XFE_RC_1443_0 ND2P $PINS O=FE_RN_287_0 I1=carry[3] I2=A[3]
XFE_RC_1442_0 ND2 $PINS O=FE_RN_288_0 I1=carry[3] I2=B[3]
XFE_RC_1441_0 ND2 $PINS O=FE_RN_289_0 I1=B[3] I2=A[3]
XFE_RC_854_0 XOR3 $PINS O=SUM[4] I1=A[4] I2=B[4] I3=carry[4]
XFE_RC_853_0 MAO222 $PINS O=carry[5] A1=carry[4] B1=B[4] C1=A[4]
XFE_RC_798_0 XOR3 $PINS O=SUM[1] I1=A[1] I2=B[1] I3=n2
XFE_RC_797_0 MAO222P $PINS O=carry[2] A1=A[1] B1=B[1] C1=n2
XFE_RC_744_0 XOR3 $PINS O=SUM[3] I1=A[3] I2=B[3] I3=carry[3]
XFE_RC_696_0 XOR3 $PINS O=SUM[5] I1=A[5] I2=B[5] I3=carry[5]
XFE_RC_695_0 MAO222 $PINS O=carry[6] A1=carry[5] B1=B[5] C1=A[5]
XFE_RC_642_0 XOR3 $PINS O=SUM[6] I1=A[6] I2=B[6] I3=carry[6]
XFE_RC_641_0 MAO222 $PINS O=carry[7] A1=carry[6] B1=B[6] C1=A[6]
XFE_RC_602_0 XOR3 $PINS O=SUM[7] I1=A[7] I2=B[7] I3=carry[7]
XFE_RC_601_0 MAO222 $PINS O=carry[8] A1=carry[7] B1=B[7] C1=A[7]
XFE_RC_544_0 XOR3 $PINS O=SUM[8] I1=A[8] I2=B[8] I3=carry[8]
XFE_RC_543_0 MAO222 $PINS O=carry[9] A1=carry[8] B1=B[8] C1=A[8]
XFE_RC_498_0 XOR3 $PINS O=SUM[9] I1=A[9] I2=B[9] I3=carry[9]
XFE_RC_497_0 MAO222P $PINS O=carry[10] A1=carry[9] B1=B[9] C1=A[9]
XFE_RC_432_0 XOR3 $PINS O=SUM[12] I1=A[12] I2=B[12] I3=carry[12]
XFE_RC_431_0 MAO222P $PINS O=carry[13] A1=carry[12] B1=B[12] C1=A[12]
XFE_RC_420_0 XOR3 $PINS O=SUM[14] I1=A[14] I2=B[14] I3=carry[14]
XFE_RC_419_0 MAO222P $PINS O=carry[15] A1=carry[14] B1=B[14] C1=A[14]
XFE_RC_330_0 XOR3 $PINS O=SUM[16] I1=A[16] I2=B[16] I3=carry[16]
XFE_RC_329_0 MAO222 $PINS O=carry[17] A1=carry[16] B1=B[16] C1=A[16]
XFE_RC_236_0 XOR3 $PINS O=SUM[20] I1=A[20] I2=B[20] I3=carry[20]
XFE_RC_235_0 MAO222 $PINS O=carry[21] A1=carry[20] B1=B[20] C1=A[20]
XFE_RC_229_0 XOR3 $PINS O=SUM[17] I1=A[17] I2=B[17] I3=carry[17]
XFE_RC_228_0 MAO222 $PINS O=carry[18] A1=carry[17] B1=B[17] C1=A[17]
XFE_RC_176_0 XOR3 $PINS O=SUM[25] I1=A[25] I2=B[25] I3=carry[25]
XFE_RC_174_0 XOR3 $PINS O=SUM[21] I1=A[21] I2=B[21] I3=carry[21]
XFE_RC_173_0 MAO222 $PINS O=carry[22] A1=carry[21] B1=B[21] C1=A[21]
XFE_RC_88_0 XOR3 $PINS O=SUM[18] I1=A[18] I2=B[18] I3=carry[18]
XFE_RC_87_0 MAO222P $PINS O=carry[19] A1=carry[18] B1=B[18] C1=A[18]
XFE_RC_84_0 XOR3 $PINS O=SUM[22] I1=A[22] I2=B[22] I3=carry[22]
XFE_RC_83_0 MAO222 $PINS O=carry[23] A1=carry[22] B1=B[22] C1=A[22]
XFE_RC_54_0 XOR3 $PINS O=SUM[23] I1=A[23] I2=B[23] I3=carry[23]
XFE_RC_53_0 MAO222P $PINS O=carry[24] A1=carry[23] B1=B[23] C1=A[23]
XFE_RC_40_0 XOR3 $PINS O=SUM[24] I1=A[24] I2=B[24] I3=carry[24]
XU2 ND3P $PINS O=carry[16] I1=n16 I2=n15 I3=n17
XU5 ND2 $PINS O=n9 I1=carry[11] I2=A[11]
XU6 XOR3 $PINS O=SUM[10] I1=B[10] I2=A[10] I3=carry[10]
XU7 ND3P $PINS O=carry[12] I1=n9 I2=n10 I3=n11
XU8 XOR3 $PINS O=SUM[13] I1=A[13] I2=B[13] I3=carry[13]
XU9 XOR3 $PINS O=SUM[15] I1=A[15] I2=B[15] I3=carry[15]
XU10 XOR3 $PINS O=SUM[19] I1=A[19] I2=B[19] I3=carry[19]
XU11 ND3P $PINS O=carry[20] I1=n19 I2=n18 I3=n20
XU12 AN2 $PINS O=n2 I1=B[0] I2=A[0]
XU13 XOR3 $PINS O=SUM[2] I1=B[2] I2=A[2] I3=carry[2]
XU14 ND2P $PINS O=n3 I1=carry[2] I2=B[2]
XU15 ND2P $PINS O=n4 I1=carry[2] I2=A[2]
XU16 ND2 $PINS O=n5 I1=A[2] I2=B[2]
XU18 ND3P $PINS O=carry[14] I1=n13 I2=n12 I3=n14
XU19 ND3P $PINS O=carry[11] I1=n7 I2=n6 I3=n8
XU20 ND2P $PINS O=n6 I1=carry[10] I2=B[10]
XU21 ND2P $PINS O=n7 I1=carry[10] I2=A[10]
XU22 ND2 $PINS O=n8 I1=A[10] I2=B[10]
XU23 ND2 $PINS O=n11 I1=A[11] I2=B[11]
XU24 ND2P $PINS O=n12 I1=carry[13] I2=A[13]
XU25 ND2P $PINS O=n13 I1=carry[13] I2=B[13]
XU26 ND2 $PINS O=n14 I1=A[13] I2=B[13]
XU27 ND2P $PINS O=n15 I1=carry[15] I2=A[15]
XU28 ND2 $PINS O=n16 I1=carry[15] I2=B[15]
XU29 ND2 $PINS O=n17 I1=A[15] I2=B[15]
XU30 ND2P $PINS O=n18 I1=carry[19] I2=A[19]
XU31 ND2 $PINS O=n19 I1=carry[19] I2=B[19]
XU32 ND2 $PINS O=n20 I1=A[19] I2=B[19]
XU33 XOR2HS $PINS O=SUM[0] I1=B[0] I2=A[0]
XU1 XOR3 $PINS O=SUM[11] I1=A[11] I2=B[11] I3=carry[11]
.ENDS

.SUBCKT PE_Shift_Add_7 rst_n en clear calc_done stage_sel x_in[16] x_in[15]
+ x_in[14] x_in[13] x_in[12] x_in[11] x_in[10] x_in[9] x_in[8] x_in[7] x_in[6]
+ x_in[5] x_in[4] x_in[3] x_in[2] x_in[1] x_in[0] sign1[1] sign1[0] sign2[1]
+ sign2[0] sign3[1] sign3[0] shf1[3] shf1[2] shf1[1] shf1[0] shf2[3] shf2[2]
+ shf2[1] shf2[0] shf3[3] shf3[2] shf3[1] shf3[0] y_out[16] y_out[15] y_out[14]
+ y_out[13] y_out[12] y_out[11] y_out[10] y_out[9] y_out[8] y_out[7] y_out[6]
+ y_out[5] y_out[4] y_out[3] y_out[2] y_out[1] y_out[0] n30 i_rst_n
+ FE_OFN23_i_rst_n FE_OFN22_i_rst_n FE_OFN15_i_rst_n FE_OFN38_s01_0
+ FE_OFN39_h01_3 FE_OFN40_h01_2 FE_OFN41_s02_0 FE_OFN42_h02_3 FE_OFN43_h02_2
+ FE_OFN44_s03_0 FE_OFN45_h03_3 FE_OFN46_h03_2 FE_OFN81_h02_0 FE_OFN89_h01_1
+ FE_OFN90_h03_1 FE_OFN93_s02_1 FE_OFN98_FE_OFN219_h01_0
+ FE_OFN101_FE_OFN195_h02_0 FE_OFN102_FE_OFN218_h03_0 clk_clone2 clk_clone1 clk
XFE_PHC1325_next_acc_0 DELA $PINS O=FE_PHN1325_next_acc_0 I=next_acc[0]
XFE_PHC1267_N235 DELB $PINS O=N235 I=FE_PHN1267_N235
XFE_PHC1262_N236 DELB $PINS O=FE_PHN1262_N236 I=N236
XFE_PHC1256_N237 DELB $PINS O=FE_PHN1256_N237 I=N237
XFE_PHC1245_N238 DELB $PINS O=FE_PHN1245_N238 I=N238
XFE_PHC1244_N239 DELB $PINS O=FE_PHN1244_N239 I=N239
XFE_PHC1144_acc_reg_17 DELB $PINS O=acc_reg[17] I=FE_PHN1144_acc_reg_17
XFE_PHC1131_acc_reg_20 DELB $PINS O=FE_PHN1131_acc_reg_20 I=acc_reg[20]
XFE_PHC1110_acc_reg_21 DELB $PINS O=acc_reg[21] I=FE_PHN1110_acc_reg_21
XFE_PHC1106_acc_reg_22 DELC $PINS O=acc_reg[22] I=FE_PHN1106_acc_reg_22
XFE_PHC1103_acc_reg_23 DELB $PINS O=FE_PHN1103_acc_reg_23 I=acc_reg[23]
XFE_PHC1035_N251 DELC $PINS O=FE_PHN1035_N251 I=N251
XFE_PHC1032_acc_reg_10 DELB $PINS O=FE_PHN1032_acc_reg_10 I=acc_reg[10]
XFE_PHC984_acc_reg_15 DELB $PINS O=FE_PHN984_acc_reg_15 I=acc_reg[15]
XFE_PHC871_acc_reg_16 DELB $PINS O=FE_PHN871_acc_reg_16 I=acc_reg[16]
XFE_PHC869_acc_reg_24 DELB $PINS O=FE_PHN869_acc_reg_24 I=acc_reg[24]
XFE_PHC867_acc_reg_19 DELB $PINS O=FE_PHN867_acc_reg_19 I=acc_reg[19]
XFE_PHC864_acc_reg_18 DELB $PINS O=FE_PHN864_acc_reg_18 I=acc_reg[18]
XFE_PHC859_acc_reg_25 DELB $PINS O=FE_PHN859_acc_reg_25 I=acc_reg[25]
XFE_RC_777_0 INV2 $PINS O=FE_RN_369_0 I=sll_16/ML_int[2][4]
XFE_RC_776_0 MXL2H $PINS OB=sll_16/ML_int[3][4] S=n77 A=FE_RN_369_0 B=n103
XFE_RC_738_0 AN2T $PINS O=term2_shifted[4] I1=sll_17/ML_int[3][4] I2=n55
XFE_RC_714_0 AN2T $PINS O=term1_shifted[4] I1=sll_16/ML_int[3][4] I2=shf1[3]
XFE_RC_591_0 OR2B1S $PINS O=FE_RN_292_0 I1=shf2[1] B1=FE_OFN196_h02_0
XFE_RC_590_0 OR2B1S $PINS O=n114 I1=FE_RN_292_0 B1=term2_in[0]
XFE_RC_517_0 AN2B1 $PINS O=term3_shifted[3] I1=sll_18/ML_int[2][3] B1=n127
XFE_RC_513_0 INV2CK $PINS O=sll_18/ML_int[1][2] I=FE_RN_262_0
XFE_RC_512_0 MXL2HS $PINS OB=FE_RN_262_0 S=FE_OFN102_FE_OFN218_h03_0
+ A=term3_in[2] B=term3_in[1]
XFE_RC_503_0 INV2 $PINS O=N48 I=FE_RN_258_0
XFE_RC_502_0 AOI22S $PINS O=FE_RN_258_0 A1=n90 A2=N21 B1=term1_shifted[7]
+ B2=FE_OFN292_s01_0
XFE_RC_491_0 INV2 $PINS O=FE_RN_253_0 I=sll_17/ML_int[2][2]
XFE_RC_490_0 NR2P $PINS O=term2_shifted[2] I1=n116 I2=FE_RN_253_0
XFE_RC_422_0 AN2S $PINS O=FE_RN_222_0 I1=term2_shifted[3] I2=n62
XFE_RC_421_0 AO12 $PINS O=N99 A1=FE_RN_222_0 B1=N72 B2=sign2[0]
XFE_RC_312_0 INV2 $PINS O=FE_RN_170_0 I=sll_17/ML_int[2][3]
XFE_RC_311_0 NR2P $PINS O=term2_shifted[3] I1=FE_RN_170_0 I2=n116
XFE_RC_272_0 ND2 $PINS O=FE_RN_146_0 I1=sll_16/ML_int[1][1] I2=shf1[1]
XFE_RC_271_0 INV2CK $PINS O=FE_RN_147_0 I=shf1[1]
XFE_RC_270_0 ND2 $PINS O=FE_RN_148_0 I1=sll_16/ML_int[1][3] I2=FE_RN_147_0
XFE_RC_269_0 ND2 $PINS O=sll_16/ML_int[2][3] I1=FE_RN_148_0 I2=FE_RN_146_0
XFE_RC_221_0 OA12 $PINS O=N41 A1=N14 B1=n90 B2=FE_RN_3
XFE_RC_111_0 MOAI1H $PINS O=N43 A1=FE_RN_169_0 A2=FE_RN_168_0
+ B1=term1_shifted[2] B2=FE_RN_3
XFE_RC_45_0 AO22P $PINS O=N45 A1=term1_shifted[4] A2=FE_RN_3 B1=N18 B2=n90
XFE_RC_1569_0 ND2 $PINS O=FE_RN_360_0 I1=term1_in[0]
+ I2=FE_OFN98_FE_OFN219_h01_0
XFE_RC_1568_0 INV1S $PINS O=FE_RN_361_0 I=shf1[0]
XFE_RC_1567_0 ND2S $PINS O=FE_RN_362_0 I1=term1_in[1] I2=FE_RN_361_0
XFE_RC_1566_0 ND2 $PINS O=sll_16/ML_int[1][1] I1=FE_RN_362_0 I2=FE_RN_360_0
XFE_RC_1565_0 ND2 $PINS O=FE_RN_358_0 I1=term1_shifted[3] I2=FE_RN_3
XFE_RC_1564_0 ND2 $PINS O=FE_RN_359_0 I1=N17 I2=n90
XFE_RC_1563_0 ND2 $PINS O=N44 I1=FE_RN_359_0 I2=FE_RN_358_0
XFE_RC_1507_0 ND2S $PINS O=FE_RN_327_0 I1=sll_18/ML_int[1][0] I2=shf3[1]
XFE_RC_1506_0 INV1S $PINS O=FE_RN_328_0 I=shf3[1]
XFE_RC_1505_0 ND2 $PINS O=FE_RN_329_0 I1=sll_18/ML_int[1][2] I2=FE_RN_328_0
XFE_RC_1504_0 ND2 $PINS O=sll_18/ML_int[2][2] I1=FE_RN_329_0 I2=FE_RN_327_0
XFE_RC_1495_0 ND2 $PINS O=FE_RN_318_0 I1=sll_16/ML_int[1][2] I2=shf1[1]
XFE_RC_1494_0 INV1S $PINS O=FE_RN_319_0 I=shf1[1]
XFE_RC_1493_0 ND2S $PINS O=FE_RN_320_0 I1=sll_16/ML_int[1][4] I2=FE_RN_319_0
XFE_RC_1492_0 ND2 $PINS O=sll_16/ML_int[2][4] I1=FE_RN_320_0 I2=FE_RN_318_0
XFE_RC_1475_0 ND2S $PINS O=FE_RN_307_0 I1=term2_in[3]
+ I2=FE_OFN101_FE_OFN195_h02_0
XFE_RC_1474_0 INV1S $PINS O=FE_RN_308_0 I=FE_OFN81_h02_0
XFE_RC_1473_0 ND2S $PINS O=FE_RN_309_0 I1=term2_in[4] I2=FE_RN_308_0
XFE_RC_1472_0 ND2 $PINS O=sll_17/ML_int[1][4] I1=FE_RN_309_0 I2=FE_RN_307_0
XFE_RC_1471_0 ND2S $PINS O=FE_RN_304_0 I1=term3_in[4]
+ I2=FE_OFN102_FE_OFN218_h03_0
XFE_RC_1470_0 INV1S $PINS O=FE_RN_305_0 I=shf3[0]
XFE_RC_1469_0 ND2 $PINS O=FE_RN_306_0 I1=term3_in[5] I2=FE_RN_305_0
XFE_RC_1468_0 ND2 $PINS O=sll_18/ML_int[1][5] I1=FE_RN_306_0 I2=FE_RN_304_0
XFE_RC_1467_0 ND2 $PINS O=FE_RN_301_0 I1=sll_16/ML_int[1][3] I2=shf1[1]
XFE_RC_1466_0 INV1S $PINS O=FE_RN_302_0 I=shf1[1]
XFE_RC_1465_0 ND2 $PINS O=FE_RN_303_0 I1=sll_16/ML_int[1][5] I2=FE_RN_302_0
XFE_RC_1464_0 ND2 $PINS O=sll_16/ML_int[2][5] I1=FE_RN_303_0 I2=FE_RN_301_0
XFE_RC_1463_0 ND2 $PINS O=FE_RN_299_0 I1=term3_shifted[3] I2=FE_OFN44_s03_0
XFE_RC_1462_0 ND2 $PINS O=FE_RN_300_0 I1=N127 I2=n36
XFE_RC_1461_0 ND2 $PINS O=N154 I1=FE_RN_300_0 I2=FE_RN_299_0
XFE_RC_1429_0 ND2S $PINS O=FE_RN_279_0 I1=sll_17/ML_int[1][0] I2=shf2[1]
XFE_RC_1428_0 INV1S $PINS O=FE_RN_280_0 I=shf2[1]
XFE_RC_1427_0 ND2 $PINS O=FE_RN_281_0 I1=sll_17/ML_int[1][2] I2=FE_RN_280_0
XFE_RC_1426_0 ND2 $PINS O=sll_17/ML_int[2][2] I1=FE_RN_281_0 I2=FE_RN_279_0
XFE_RC_1425_0 ND2 $PINS O=FE_RN_271_0 I1=n130 I2=n23
XFE_RC_1424_0 INV1S $PINS O=FE_RN_272_0 I=n23
XFE_RC_1423_0 ND2 $PINS O=FE_RN_273_0 I1=FE_RN_272_0 I2=sll_18/ML_int[2][4]
XFE_RC_1422_0 ND2 $PINS O=sll_18/ML_int[3][4] I1=FE_RN_273_0 I2=FE_RN_271_0
XFE_RC_1421_0 INV1S $PINS O=FE_RN_274_0 I=FE_OFN45_h03_3
XFE_RC_1420_0 OR3B2 $PINS O=FE_RN_275_0 I1=FE_RN_274_0 B1=n23 B2=n130
XFE_RC_1419_0 INV1S $PINS O=FE_RN_276_0 I=FE_OFN45_h03_3
XFE_RC_1418_0 NR2 $PINS O=FE_RN_277_0 I1=n23 I2=FE_RN_276_0
XFE_RC_1417_0 ND2 $PINS O=FE_RN_278_0 I1=FE_RN_277_0 I2=sll_18/ML_int[2][4]
XFE_RC_1416_0 ND2 $PINS O=term3_shifted[4] I1=FE_RN_278_0 I2=FE_RN_275_0
XFE_RC_1409_0 ND2S $PINS O=FE_RN_264_0 I1=term1_in[1]
+ I2=FE_OFN98_FE_OFN219_h01_0
XFE_RC_1407_0 ND2 $PINS O=FE_RN_266_0 I1=term1_in[2] I2=FE_RN_361_0
XFE_RC_1406_0 ND2 $PINS O=sll_16/ML_int[1][2] I1=FE_RN_266_0 I2=FE_RN_264_0
XFE_RC_1326_0 ND2 $PINS O=FE_RN_225_0 I1=sll_16/ML_int[1][0] I2=shf1[1]
XFE_RC_1325_0 INV1S $PINS O=FE_RN_226_0 I=shf1[1]
XFE_RC_1324_0 ND2 $PINS O=FE_RN_227_0 I1=sll_16/ML_int[1][2] I2=FE_RN_226_0
XFE_RC_1323_0 ND2 $PINS O=sll_16/ML_int[2][2] I1=FE_RN_227_0 I2=FE_RN_225_0
XFE_RC_1313_0 INV1S $PINS O=FE_RN_217_0 I=FE_OFN102_FE_OFN218_h03_0
XFE_RC_1312_0 OR2B1S $PINS O=FE_RN_218_0 I1=FE_RN_217_0 B1=term3_in[0]
XFE_RC_1311_0 INV1S $PINS O=FE_RN_219_0 I=FE_OFN102_FE_OFN218_h03_0
XFE_RC_1310_0 ND2S $PINS O=FE_RN_220_0 I1=term3_in[1] I2=FE_RN_219_0
XFE_RC_1309_0 ND2 $PINS O=sll_18/ML_int[1][1] I1=FE_RN_220_0 I2=FE_RN_218_0
XFE_RC_1305_0 ND2 $PINS O=FE_RN_213_0 I1=term1_in[3]
+ I2=FE_OFN98_FE_OFN219_h01_0
XFE_RC_1303_0 ND2S $PINS O=FE_RN_215_0 I1=term1_in[4] I2=FE_RN_361_0
XFE_RC_1302_0 ND2 $PINS O=sll_16/ML_int[1][4] I1=FE_RN_215_0 I2=FE_RN_213_0
XFE_RC_1272_0 ND2 $PINS O=FE_RN_196_0 I1=term1_shifted[1] I2=FE_RN_3
XFE_RC_1271_0 ND2 $PINS O=FE_RN_197_0 I1=N15 I2=n90
XFE_RC_1270_0 ND2P $PINS O=N42 I1=FE_RN_197_0 I2=FE_RN_196_0
XFE_RC_1245_0 ND2S $PINS O=FE_RN_181_0 I1=term2_in[0]
+ I2=FE_OFN101_FE_OFN195_h02_0
XFE_RC_1243_0 ND2S $PINS O=FE_RN_183_0 I1=term2_in[1] I2=FE_RN_308_0
XFE_RC_1242_0 ND2 $PINS O=sll_17/ML_int[1][1] I1=FE_RN_181_0 I2=FE_RN_183_0
XFE_RC_1232_0 ND2 $PINS O=FE_RN_175_0 I1=term3_shifted[1] I2=FE_OFN44_s03_0
XFE_RC_1231_0 ND2 $PINS O=FE_RN_176_0 I1=N125 I2=n36
XFE_RC_1230_0 ND2P $PINS O=N152 I1=FE_RN_176_0 I2=FE_RN_175_0
XFE_RC_1218_0 INV1S $PINS O=FE_RN_168_0 I=n90
XFE_RC_1217_0 INV2 $PINS O=FE_RN_169_0 I=N16
XFE_RC_10_0 OA12 $PINS O=N96 A1=N69 B1=sign2[0] B2=n62
XFE_RC_2_0 OA12 $PINS O=N151 A1=N124 B1=n36 B2=FE_OFN44_s03_0
XFE_OFC699_h03_3 INV1S $PINS O=FE_RN_7 I=FE_OFN45_h03_3
XFE_OFC686_h01_3 INV1S $PINS O=n81 I=shf1[3]
XFE_OFC680_mac_in_real_0 INV2 $PINS O=n153 I=x_in[0]
XFE_OFC659_mac_in_real_1 INV3 $PINS O=n152 I=x_in[1]
XFE_OFC638_s03_0 INV1S $PINS O=FE_OFN333_s03_0 I=FE_OFN332_s03_0
XFE_OFC637_s03_0 INV1S $PINS O=FE_OFN332_s03_0 I=n36
XFE_OFC633_s03_0 INV2 $PINS O=n36 I=FE_OFN44_s03_0
XFE_OFC630_h03_0 INV1S $PINS O=n14 I=FE_OFN102_FE_OFN218_h03_0
XFE_OFC595_h02_0 INV1S $PINS O=FE_OFN196_h02_0 I=FE_OFN101_FE_OFN195_h02_0
XFE_OFC565_h03_3 BUF1 $PINS O=n27 I=FE_RN_7
XFE_OFC558_h01_3 BUF1 $PINS O=FE_RN_6 I=n81
XFE_OFC546_sll_16_ML_int_2__3 INV2 $PINS O=n106 I=sll_16/ML_int[2][3]
XFE_OFC545_h01_2 INV2 $PINS O=n77 I=FE_OFN40_h01_2
XFE_OFC531_h03_2 INV1S $PINS O=n23 I=FE_OFN46_h03_2
XFE_OFC524_s01_0 INV1S $PINS O=FE_OFN294_s01_0 I=FE_OFN292_s01_0
XFE_OFC523_s01_0 INV1S $PINS O=FE_OFN293_s01_0 I=FE_OFN292_s01_0
XFE_OFC522_s01_0 INV1S $PINS O=FE_OFN292_s01_0 I=n90
XFE_OFC521_s01_0 INV2 $PINS O=n90 I=FE_RN_3
XFE_OFC516_s01_0 INV1S $PINS O=FE_RN_3 I=FE_OFN38_s01_0
XFE_OFC510_h02_2 BUF1 $PINS O=FE_OFN286_h02_2 I=FE_OFN43_h02_2
XFE_OFC509_h02_2 INV1S $PINS O=n51 I=FE_OFN43_h02_2
XFE_OFC508_h02_2 BUF1 $PINS O=FE_RN_2 I=FE_OFN43_h02_2
XFE_OFC420_h01_0 INV1S $PINS O=n69 I=FE_OFN98_FE_OFN219_h01_0
XFE_OFC401_h02_3 INV1S $PINS O=FE_OFN211_h02_3 I=n55
XFE_OFC399_h02_3 INV1S $PINS O=n55 I=FE_OFN42_h02_3
XFE_OFC332_h02_1 INV1S $PINS O=FE_DBTN188_h02_1 I=shf2[1]
XFE_OFC291_pe_clear_d1 INV1S $PINS O=n154 I=clear
XFE_OFC285_h03_1 INV1S $PINS O=FE_DBTN186_h03_1 I=shf3[1]
XFE_OFC173_s02_0 INV2 $PINS O=n62 I=sign2[0]
XU110 AO22 $PINS O=base_val[13] A1=acc_reg[13] A2=n154 B1=clear B2=n30
XU115 AO22 $PINS O=N67 A1=FE_OFN294_s01_0 A2=N40 B1=term1_shifted[26]
+ B2=FE_OFN292_s01_0
XU142 AO22 $PINS O=N177 A1=sign3[0] A2=N150 B1=term3_shifted[26]
+ B2=FE_OFN44_s03_0
XU143 AO22 $PINS O=N176 A1=N149 A2=FE_OFN333_s03_0 B1=term3_shifted[25]
+ B2=FE_OFN332_s03_0
XU144 AO22 $PINS O=N175 A1=N148 A2=FE_OFN333_s03_0 B1=term3_shifted[24]
+ B2=FE_OFN332_s03_0
XU145 AO22 $PINS O=N174 A1=N147 A2=FE_OFN333_s03_0 B1=term3_shifted[23]
+ B2=FE_OFN332_s03_0
XU146 AO22 $PINS O=N173 A1=N146 A2=FE_OFN333_s03_0 B1=term3_shifted[22]
+ B2=FE_OFN332_s03_0
XU147 AO22 $PINS O=N172 A1=N145 A2=FE_OFN333_s03_0 B1=term3_shifted[21]
+ B2=FE_OFN332_s03_0
XU149 AO22 $PINS O=N170 A1=N143 A2=FE_OFN333_s03_0 B1=term3_shifted[19]
+ B2=FE_OFN332_s03_0
XU150 AO22 $PINS O=N169 A1=N142 A2=FE_OFN333_s03_0 B1=term3_shifted[18]
+ B2=FE_OFN332_s03_0
XU151 AO22 $PINS O=N168 A1=N141 A2=FE_OFN333_s03_0 B1=term3_shifted[17]
+ B2=FE_OFN332_s03_0
XU152 AO22 $PINS O=N167 A1=N140 A2=FE_OFN333_s03_0 B1=term3_shifted[16]
+ B2=FE_OFN332_s03_0
XU153 AO22 $PINS O=N166 A1=N139 A2=n36 B1=term3_shifted[15] B2=FE_OFN332_s03_0
XU154 AO22 $PINS O=N165 A1=N138 A2=n36 B1=term3_shifted[14] B2=FE_OFN332_s03_0
XU155 AO22 $PINS O=N164 A1=N137 A2=n36 B1=term3_shifted[13] B2=FE_OFN332_s03_0
XU156 AO22 $PINS O=N163 A1=N136 A2=n36 B1=term3_shifted[12] B2=FE_OFN332_s03_0
XU157 AO22 $PINS O=N162 A1=N135 A2=n36 B1=term3_shifted[11] B2=FE_OFN332_s03_0
XU158 AO22 $PINS O=N161 A1=N134 A2=n36 B1=term3_shifted[10] B2=FE_OFN332_s03_0
XU159 AO22 $PINS O=N160 A1=N133 A2=n36 B1=term3_shifted[9] B2=FE_OFN332_s03_0
XU160 AO22 $PINS O=N159 A1=N132 A2=n36 B1=term3_shifted[8] B2=FE_OFN44_s03_0
XU161 AO22 $PINS O=N158 A1=N131 A2=n36 B1=term3_shifted[7] B2=FE_OFN44_s03_0
XU162 AO22 $PINS O=N157 A1=N130 A2=n36 B1=term3_shifted[6] B2=FE_OFN44_s03_0
XU163 AO22 $PINS O=N156 A1=N129 A2=n36 B1=term3_shifted[5] B2=FE_OFN44_s03_0
XU164 AO22 $PINS O=N155 A1=N128 A2=n36 B1=term3_shifted[4] B2=FE_OFN44_s03_0
XU171 AO22 $PINS O=N120 A1=N93 A2=FE_OFN41_s02_0 B1=term2_shifted[24] B2=n62
XU172 AO22 $PINS O=N119 A1=N92 A2=FE_OFN41_s02_0 B1=term2_shifted[23] B2=n62
XU173 AO22 $PINS O=N118 A1=N91 A2=FE_OFN41_s02_0 B1=term2_shifted[22] B2=n62
XU174 AO22 $PINS O=N117 A1=N90 A2=FE_OFN41_s02_0 B1=term2_shifted[21] B2=n62
XU175 AO22 $PINS O=N116 A1=N89 A2=FE_OFN41_s02_0 B1=term2_shifted[20] B2=n62
XU176 AO22 $PINS O=N115 A1=N88 A2=FE_OFN41_s02_0 B1=term2_shifted[19] B2=n62
XU177 AO22 $PINS O=N114 A1=N87 A2=FE_OFN41_s02_0 B1=term2_shifted[18] B2=n62
XU178 AO22 $PINS O=N113 A1=N86 A2=FE_OFN41_s02_0 B1=term2_shifted[17] B2=n62
XU179 AO22 $PINS O=N112 A1=N85 A2=FE_OFN41_s02_0 B1=term2_shifted[16] B2=n62
XU180 AO22 $PINS O=N111 A1=N84 A2=FE_OFN41_s02_0 B1=term2_shifted[15] B2=n62
XU181 AO22 $PINS O=N110 A1=N83 A2=FE_OFN41_s02_0 B1=term2_shifted[14] B2=n62
XU183 AO22 $PINS O=N108 A1=N81 A2=sign2[0] B1=term2_shifted[12] B2=n62
XU184 AO22 $PINS O=N107 A1=N80 A2=sign2[0] B1=term2_shifted[11] B2=n62
XU187 AO22 $PINS O=N104 A1=N77 A2=sign2[0] B1=term2_shifted[8] B2=n62
XU188 AO22 $PINS O=N103 A1=N76 A2=sign2[0] B1=term2_shifted[7] B2=n62
XU189 AO22 $PINS O=N102 A1=N75 A2=sign2[0] B1=term2_shifted[6] B2=n62
XU190 AO22 $PINS O=N101 A1=N74 A2=sign2[0] B1=term2_shifted[5] B2=n62
XU191 AO22 $PINS O=N100 A1=N73 A2=sign2[0] B1=term2_shifted[4] B2=n62
Xsll_18/M1_0_6 MUX2 $PINS O=sll_18/ML_int[1][6] S=FE_OFN102_FE_OFN218_h03_0
+ A=term3_in[6] B=term3_in[5]
Xsll_18/M1_0_7 MUX2 $PINS O=sll_18/ML_int[1][7] S=FE_OFN102_FE_OFN218_h03_0
+ A=term3_in[7] B=term3_in[6]
Xsll_18/M1_1_3 MUX2 $PINS O=sll_18/ML_int[2][3] S=shf3[1] A=sll_18/ML_int[1][3]
+ B=sll_18/ML_int[1][1]
Xsll_18/M1_1_4 MUX2 $PINS O=sll_18/ML_int[2][4] S=shf3[1] A=sll_18/ML_int[1][4]
+ B=sll_18/ML_int[1][2]
Xsll_18/M1_1_5 MUX2 $PINS O=sll_18/ML_int[2][5] S=shf3[1] A=sll_18/ML_int[1][5]
+ B=sll_18/ML_int[1][3]
Xsll_18/M1_1_6 MUX2 $PINS O=sll_18/ML_int[2][6] S=shf3[1] A=sll_18/ML_int[1][6]
+ B=sll_18/ML_int[1][4]
Xsll_18/M1_1_7 MUX2 $PINS O=sll_18/ML_int[2][7] S=shf3[1] A=sll_18/ML_int[1][7]
+ B=sll_18/ML_int[1][5]
Xsll_18/M1_2_5 MUX2 $PINS O=sll_18/ML_int[3][5] S=n23 A=sll_18/ML_int[2][5]
+ B=n131
Xsll_18/M1_2_6 MUX2 $PINS O=sll_18/ML_int[3][6] S=n23 A=sll_18/ML_int[2][6]
+ B=sll_18/ML_int[2][2]
Xsll_18/M1_2_7 MUX2 $PINS O=sll_18/ML_int[3][7] S=n23 A=sll_18/ML_int[2][7]
+ B=sll_18/ML_int[2][3]
Xsll_18/M1_2_8 MUX2 $PINS O=sll_18/ML_int[3][8] S=n23 A=sll_18/ML_int[2][8]
+ B=sll_18/ML_int[2][4]
Xsll_18/M1_2_9 MUX2 $PINS O=sll_18/ML_int[3][9] S=n23 A=sll_18/ML_int[2][9]
+ B=sll_18/ML_int[2][5]
Xsll_18/M1_2_19 MUX2 $PINS O=sll_18/ML_int[3][19] S=n23 A=n6
+ B=sll_18/ML_int[2][15]
Xsll_18/M1_3_8 MUX2 $PINS O=term3_shifted[8] S=FE_RN_7 A=sll_18/ML_int[3][8]
+ B=sll_18/ML_int[3][0]
Xsll_18/M1_3_9 MUX2 $PINS O=term3_shifted[9] S=FE_RN_7 A=sll_18/ML_int[3][9]
+ B=sll_18/ML_int[3][1]
Xsll_18/M1_3_10 MUX2 $PINS O=term3_shifted[10] S=FE_RN_7 A=sll_18/ML_int[3][10]
+ B=sll_18/ML_int[3][2]
Xsll_18/M1_3_11 MUX2 $PINS O=term3_shifted[11] S=FE_RN_7 A=sll_18/ML_int[3][11]
+ B=sll_18/ML_int[3][3]
Xsll_18/M1_3_12 MUX2 $PINS O=term3_shifted[12] S=FE_RN_7 A=sll_18/ML_int[3][12]
+ B=sll_18/ML_int[3][4]
Xsll_18/M1_3_13 MUX2 $PINS O=term3_shifted[13] S=FE_RN_7 A=sll_18/ML_int[3][13]
+ B=sll_18/ML_int[3][5]
Xsll_18/M1_3_15 MUX2 $PINS O=term3_shifted[15] S=n27 A=sll_18/ML_int[3][15]
+ B=sll_18/ML_int[3][7]
Xsll_18/M1_3_23 MUX2 $PINS O=term3_shifted[23] S=n27 A=n6
+ B=sll_18/ML_int[3][15]
Xsll_17/M1_0_3 MUX2 $PINS O=sll_17/ML_int[1][3] S=FE_OFN101_FE_OFN195_h02_0
+ A=term2_in[3] B=term2_in[2]
Xsll_17/M1_0_5 MUX2 $PINS O=sll_17/ML_int[1][5] S=FE_OFN101_FE_OFN195_h02_0
+ A=term2_in[5] B=term2_in[4]
Xsll_17/M1_0_6 MUX2 $PINS O=sll_17/ML_int[1][6] S=FE_OFN101_FE_OFN195_h02_0
+ A=term2_in[6] B=term2_in[5]
Xsll_17/M1_0_7 MUX2 $PINS O=sll_17/ML_int[1][7] S=FE_OFN101_FE_OFN195_h02_0
+ A=term2_in[7] B=term2_in[6]
Xsll_17/M1_1_4 MUX2 $PINS O=sll_17/ML_int[2][4] S=shf2[1] A=sll_17/ML_int[1][4]
+ B=sll_17/ML_int[1][2]
Xsll_17/M1_1_5 MUX2 $PINS O=sll_17/ML_int[2][5] S=shf2[1] A=sll_17/ML_int[1][5]
+ B=sll_17/ML_int[1][3]
Xsll_17/M1_1_6 MUX2 $PINS O=sll_17/ML_int[2][6] S=shf2[1] A=sll_17/ML_int[1][6]
+ B=sll_17/ML_int[1][4]
Xsll_17/M1_1_7 MUX2 $PINS O=sll_17/ML_int[2][7] S=shf2[1] A=sll_17/ML_int[1][7]
+ B=sll_17/ML_int[1][5]
Xsll_17/M1_2_4 MUX2 $PINS O=sll_17/ML_int[3][4] S=FE_RN_2 A=sll_17/ML_int[2][4]
+ B=n119
Xsll_17/M1_2_5 MUX2 $PINS O=sll_17/ML_int[3][5] S=FE_RN_2 A=sll_17/ML_int[2][5]
+ B=n120
Xsll_17/M1_2_6 MUX2 $PINS O=sll_17/ML_int[3][6] S=FE_RN_2 A=sll_17/ML_int[2][6]
+ B=sll_17/ML_int[2][2]
Xsll_17/M1_2_7 MUX2 $PINS O=sll_17/ML_int[3][7] S=FE_RN_2 A=sll_17/ML_int[2][7]
+ B=sll_17/ML_int[2][3]
Xsll_17/M1_2_8 MUX2 $PINS O=sll_17/ML_int[3][8] S=FE_RN_2 A=sll_17/ML_int[2][8]
+ B=sll_17/ML_int[2][4]
Xsll_17/M1_2_9 MUX2 $PINS O=sll_17/ML_int[3][9] S=FE_RN_2 A=sll_17/ML_int[2][9]
+ B=sll_17/ML_int[2][5]
Xsll_17/M1_2_19 MUX2 $PINS O=sll_17/ML_int[3][19] S=FE_OFN286_h02_2 A=n7
+ B=sll_17/ML_int[2][15]
Xsll_17/M1_3_8 MUX2 $PINS O=term2_shifted[8] S=FE_OFN211_h02_3
+ A=sll_17/ML_int[3][8] B=sll_17/ML_int[3][0]
Xsll_17/M1_3_9 MUX2 $PINS O=term2_shifted[9] S=FE_OFN211_h02_3
+ A=sll_17/ML_int[3][9] B=sll_17/ML_int[3][1]
Xsll_17/M1_3_10 MUX2 $PINS O=term2_shifted[10] S=FE_OFN211_h02_3
+ A=sll_17/ML_int[3][10] B=sll_17/ML_int[3][2]
Xsll_17/M1_3_11 MUX2 $PINS O=term2_shifted[11] S=FE_OFN211_h02_3
+ A=sll_17/ML_int[3][11] B=sll_17/ML_int[3][3]
Xsll_17/M1_3_12 MUX2 $PINS O=term2_shifted[12] S=FE_OFN211_h02_3
+ A=sll_17/ML_int[3][12] B=sll_17/ML_int[3][4]
Xsll_17/M1_3_13 MUX2 $PINS O=term2_shifted[13] S=FE_OFN211_h02_3
+ A=sll_17/ML_int[3][13] B=sll_17/ML_int[3][5]
Xsll_17/M1_3_23 MUX2 $PINS O=term2_shifted[23] S=FE_OFN42_h02_3 A=n7
+ B=sll_17/ML_int[3][15]
Xsll_16/M1_0_6 MUX2 $PINS O=sll_16/ML_int[1][6] S=FE_OFN98_FE_OFN219_h01_0
+ A=term1_in[6] B=term1_in[5]
Xsll_16/M1_0_7 MUX2 $PINS O=sll_16/ML_int[1][7] S=FE_OFN98_FE_OFN219_h01_0
+ A=term1_in[7] B=term1_in[6]
Xsll_16/M1_0_8 MUX2 $PINS O=sll_16/ML_int[1][8] S=FE_OFN98_FE_OFN219_h01_0
+ A=term1_in[8] B=term1_in[7]
Xsll_16/M1_1_6 MUX2 $PINS O=sll_16/ML_int[2][6] S=shf1[1] A=sll_16/ML_int[1][6]
+ B=sll_16/ML_int[1][4]
Xsll_16/M1_1_7 MUX2 $PINS O=sll_16/ML_int[2][7] S=shf1[1] A=sll_16/ML_int[1][7]
+ B=sll_16/ML_int[1][5]
Xsll_16/M1_1_8 MUX2 $PINS O=sll_16/ML_int[2][8] S=shf1[1] A=sll_16/ML_int[1][8]
+ B=sll_16/ML_int[1][6]
Xsll_16/M1_1_9 MUX2 $PINS O=sll_16/ML_int[2][9] S=shf1[1] A=sll_16/ML_int[1][9]
+ B=sll_16/ML_int[1][7]
Xsll_16/M1_2_5 MUX2 $PINS O=sll_16/ML_int[3][5] S=n77 A=sll_16/ML_int[2][5]
+ B=n109
Xsll_16/M1_2_7 MUX2 $PINS O=sll_16/ML_int[3][7] S=n77 A=sll_16/ML_int[2][7]
+ B=sll_16/ML_int[2][3]
Xsll_16/M1_2_8 MUX2 $PINS O=sll_16/ML_int[3][8] S=n77 A=sll_16/ML_int[2][8]
+ B=sll_16/ML_int[2][4]
Xsll_16/M1_2_9 MUX2 $PINS O=sll_16/ML_int[3][9] S=n77 A=sll_16/ML_int[2][9]
+ B=sll_16/ML_int[2][5]
Xsll_16/M1_2_10 MUX2 $PINS O=sll_16/ML_int[3][10] S=n77 A=sll_16/ML_int[2][10]
+ B=sll_16/ML_int[2][6]
Xsll_16/M1_2_11 MUX2 $PINS O=sll_16/ML_int[3][11] S=n77 A=sll_16/ML_int[2][11]
+ B=sll_16/ML_int[2][7]
Xsll_16/M1_2_19 MUX2 $PINS O=sll_16/ML_int[3][19] S=n77 A=n5
+ B=sll_16/ML_int[2][15]
Xsll_16/M1_3_8 MUX2 $PINS O=term1_shifted[8] S=n81 A=sll_16/ML_int[3][8]
+ B=sll_16/ML_int[3][0]
Xsll_16/M1_3_9 MUX2 $PINS O=term1_shifted[9] S=n81 A=sll_16/ML_int[3][9]
+ B=sll_16/ML_int[3][1]
Xsll_16/M1_3_10 MUX2 $PINS O=term1_shifted[10] S=n81 A=sll_16/ML_int[3][10]
+ B=sll_16/ML_int[3][2]
Xsll_16/M1_3_11 MUX2 $PINS O=term1_shifted[11] S=n81 A=sll_16/ML_int[3][11]
+ B=sll_16/ML_int[3][3]
Xsll_16/M1_3_12 MUX2 $PINS O=term1_shifted[12] S=n81 A=sll_16/ML_int[3][12]
+ B=sll_16/ML_int[3][4]
Xsll_16/M1_3_13 MUX2 $PINS O=term1_shifted[13] S=n81 A=sll_16/ML_int[3][13]
+ B=sll_16/ML_int[3][5]
Xsll_16/M1_3_14 MUX2 $PINS O=term1_shifted[14] S=FE_RN_6 A=sll_16/ML_int[3][14]
+ B=sll_16/ML_int[3][6]
Xsll_16/M1_3_15 MUX2 $PINS O=term1_shifted[15] S=FE_RN_6 A=sll_16/ML_int[3][15]
+ B=sll_16/ML_int[3][7]
Xsll_16/M1_3_23 MUX2 $PINS O=term1_shifted[23] S=FE_RN_6 A=n5
+ B=sll_16/ML_int[3][15]
Xy_out_reg[10] QDFFRBN $PINS Q=y_out[10] D=N245 CK=net2288 RB=FE_OFN15_i_rst_n
Xy_out_reg[9] QDFFRBN $PINS Q=y_out[9] D=N244 CK=net2288 RB=FE_OFN15_i_rst_n
Xy_out_reg[8] QDFFRBN $PINS Q=y_out[8] D=N243 CK=net2288 RB=FE_OFN15_i_rst_n
Xy_out_reg[7] QDFFRBN $PINS Q=y_out[7] D=N242 CK=net2288 RB=FE_OFN15_i_rst_n
Xy_out_reg[6] QDFFRBN $PINS Q=y_out[6] D=N241 CK=net2288 RB=FE_OFN15_i_rst_n
Xy_out_reg[5] QDFFRBN $PINS Q=y_out[5] D=N240 CK=net2288 RB=FE_OFN15_i_rst_n
Xy_out_reg[4] QDFFRBN $PINS Q=y_out[4] D=FE_PHN1244_N239 CK=net2288
+ RB=FE_OFN15_i_rst_n
Xy_out_reg[3] QDFFRBN $PINS Q=y_out[3] D=FE_PHN1245_N238 CK=net2288
+ RB=FE_OFN15_i_rst_n
Xy_out_reg[2] QDFFRBN $PINS Q=y_out[2] D=FE_PHN1256_N237 CK=net2288
+ RB=FE_OFN15_i_rst_n
Xy_out_reg[1] QDFFRBN $PINS Q=y_out[1] D=FE_PHN1262_N236 CK=net2288
+ RB=FE_OFN15_i_rst_n
Xy_out_reg[0] QDFFRBN $PINS Q=y_out[0] D=N235 CK=net2288 RB=FE_OFN15_i_rst_n
Xacc_reg_reg[25] QDFFRBN $PINS Q=acc_reg[25] D=next_acc[25] CK=clk
+ RB=FE_OFN15_i_rst_n
Xacc_reg_reg[24] QDFFRBN $PINS Q=acc_reg[24] D=next_acc[24] CK=clk
+ RB=FE_OFN15_i_rst_n
Xacc_reg_reg[23] QDFFRBN $PINS Q=acc_reg[23] D=next_acc[23] CK=clk
+ RB=FE_OFN15_i_rst_n
Xacc_reg_reg[22] QDFFRBN $PINS Q=FE_PHN1106_acc_reg_22 D=next_acc[22] CK=clk
+ RB=FE_OFN15_i_rst_n
Xacc_reg_reg[21] QDFFRBN $PINS Q=FE_PHN1110_acc_reg_21 D=next_acc[21] CK=clk
+ RB=FE_OFN15_i_rst_n
Xacc_reg_reg[20] QDFFRBN $PINS Q=acc_reg[20] D=next_acc[20] CK=clk
+ RB=FE_OFN15_i_rst_n
Xacc_reg_reg[19] QDFFRBN $PINS Q=acc_reg[19] D=next_acc[19] CK=clk
+ RB=FE_OFN15_i_rst_n
Xacc_reg_reg[18] QDFFRBN $PINS Q=acc_reg[18] D=next_acc[18] CK=clk
+ RB=FE_OFN15_i_rst_n
Xacc_reg_reg[17] QDFFRBN $PINS Q=FE_PHN1144_acc_reg_17 D=next_acc[17] CK=clk
+ RB=FE_OFN15_i_rst_n
Xacc_reg_reg[16] QDFFRBN $PINS Q=acc_reg[16] D=next_acc[16] CK=clk
+ RB=FE_OFN15_i_rst_n
Xacc_reg_reg[15] QDFFRBN $PINS Q=acc_reg[15] D=next_acc[15] CK=clk
+ RB=FE_OFN23_i_rst_n
Xacc_reg_reg[14] QDFFRBN $PINS Q=acc_reg[14] D=next_acc[14] CK=clk
+ RB=FE_OFN23_i_rst_n
Xacc_reg_reg[13] QDFFRBN $PINS Q=acc_reg[13] D=next_acc[13] CK=clk
+ RB=FE_OFN23_i_rst_n
Xacc_reg_reg[12] QDFFRBN $PINS Q=acc_reg[12] D=next_acc[12] CK=clk
+ RB=FE_OFN23_i_rst_n
Xacc_reg_reg[11] QDFFRBN $PINS Q=acc_reg[11] D=next_acc[11] CK=clk
+ RB=FE_OFN23_i_rst_n
Xacc_reg_reg[10] QDFFRBN $PINS Q=acc_reg[10] D=next_acc[10] CK=clk
+ RB=FE_OFN23_i_rst_n
Xacc_reg_reg[9] QDFFRBN $PINS Q=acc_reg[9] D=next_acc[9] CK=clk
+ RB=FE_OFN23_i_rst_n
Xacc_reg_reg[8] QDFFRBN $PINS Q=acc_reg[8] D=next_acc[8] CK=clk
+ RB=FE_OFN23_i_rst_n
Xacc_reg_reg[7] QDFFRBN $PINS Q=acc_reg[7] D=next_acc[7] CK=clk
+ RB=FE_OFN23_i_rst_n
Xacc_reg_reg[6] QDFFRBN $PINS Q=acc_reg[6] D=next_acc[6] CK=clk
+ RB=FE_OFN23_i_rst_n
Xacc_reg_reg[5] QDFFRBN $PINS Q=acc_reg[5] D=next_acc[5] CK=clk
+ RB=FE_OFN23_i_rst_n
Xacc_reg_reg[4] QDFFRBN $PINS Q=acc_reg[4] D=next_acc[4] CK=clk
+ RB=FE_OFN22_i_rst_n
Xacc_reg_reg[3] QDFFRBN $PINS Q=acc_reg[3] D=next_acc[3] CK=clk
+ RB=FE_OFN22_i_rst_n
Xacc_reg_reg[2] QDFFRBN $PINS Q=acc_reg[2] D=next_acc[2] CK=clk
+ RB=FE_OFN22_i_rst_n
Xacc_reg_reg[1] QDFFRBN $PINS Q=acc_reg[1] D=next_acc[1] CK=clk
+ RB=FE_OFN22_i_rst_n
Xy_out_reg[16] QDFFRBN $PINS Q=y_out[16] D=FE_PHN1035_N251 CK=net2288
+ RB=i_rst_n
Xy_out_reg[15] QDFFRBN $PINS Q=y_out[15] D=N250 CK=net2288 RB=i_rst_n
Xy_out_reg[14] QDFFRBN $PINS Q=y_out[14] D=N249 CK=net2288 RB=FE_OFN15_i_rst_n
Xy_out_reg[13] QDFFRBN $PINS Q=y_out[13] D=N248 CK=net2288 RB=i_rst_n
Xy_out_reg[12] QDFFRBN $PINS Q=y_out[12] D=N247 CK=net2288 RB=i_rst_n
Xy_out_reg[11] QDFFRBN $PINS Q=y_out[11] D=N246 CK=net2288 RB=FE_OFN15_i_rst_n
Xacc_reg_reg[0] QDFFRBS $PINS Q=acc_reg[0] D=FE_PHN1325_next_acc_0 CK=clk
+ RB=FE_OFN22_i_rst_n
Xacc_reg_reg[26] QDFFRBS $PINS Q=N251 D=next_acc[26] CK=clk RB=FE_OFN15_i_rst_n
XU4 AO22 $PINS O=N122 A1=N95 A2=FE_OFN41_s02_0 B1=term2_shifted[26] B2=n62
XU5 AO22 $PINS O=N121 A1=N94 A2=FE_OFN41_s02_0 B1=term2_shifted[25] B2=n62
XU11 MUX2 $PINS O=sll_18/ML_int[1][4] S=FE_OFN102_FE_OFN218_h03_0 A=term3_in[4]
+ B=term3_in[3]
XU14 MUX2 $PINS O=sll_17/ML_int[2][3] S=shf2[1] A=sll_17/ML_int[1][3]
+ B=sll_17/ML_int[1][1]
XU20 NR2 $PINS O=term1_in[2] I1=sign1[1] I2=x_in[2]
XU23 NR2 $PINS O=term2_in[0] I1=FE_OFN93_s02_1 I2=n153
XU24 NR2P $PINS O=term1_shifted[0] I1=n105 I2=n103
XU25 MUX2 $PINS O=N248 S=n30 A=FE_PHN1103_acc_reg_23 B=FE_PHN1035_N251
XU26 AN2 $PINS O=sll_16/ML_int[1][0] I1=term1_in[0] I2=n69
XU27 NR2P $PINS O=term3_shifted[0] I1=n127 I2=n125
XU29 MUX2 $PINS O=N249 S=n30 A=FE_PHN869_acc_reg_24 B=FE_PHN1035_N251
XU30 NR2 $PINS O=term2_in[4] I1=FE_OFN93_s02_1 I2=x_in[4]
XU31 ND3 $PINS O=n103 I1=n69 I2=FE_RN_226_0 I3=term1_in[0]
XU32 ND3 $PINS O=n125 I1=term3_in[0] I2=FE_DBTN186_h03_1 I3=n14
XU34 MUX2 $PINS O=N250 S=n30 A=FE_PHN859_acc_reg_25 B=FE_PHN1035_N251
XU35 NR2P $PINS O=term1_in[0] I1=sign1[1] I2=n153
XU36 NR2 $PINS O=term3_in[0] I1=sign3[1] I2=n153
XU37 ND2P $PINS O=n126 I1=sll_18/ML_int[1][1] I2=FE_DBTN186_h03_1
XU42 NR2 $PINS O=term3_in[2] I1=sign3[1] I2=x_in[2]
XU44 AN2S $PINS O=sll_18/ML_int[1][0] I1=n14 I2=term3_in[0]
XU46 NR2P $PINS O=term2_shifted[0] I1=n116 I2=n114
XU47 AO22P $PINS O=N153 A1=n36 A2=N126 B1=term3_shifted[2] B2=FE_OFN44_s03_0
XU52 AO22 $PINS O=N46 A1=N19 A2=n90 B1=term1_shifted[5] B2=FE_RN_3
XU53 AO22 $PINS O=N47 A1=N20 A2=n90 B1=term1_shifted[6] B2=FE_RN_3
XU59 AO22 $PINS O=N51 A1=N24 A2=n90 B1=term1_shifted[10] B2=FE_OFN292_s01_0
XU60 AO22 $PINS O=N53 A1=N26 A2=n90 B1=term1_shifted[12] B2=FE_OFN292_s01_0
XU63 AO22 $PINS O=N61 A1=N34 A2=FE_OFN294_s01_0 B1=term1_shifted[20]
+ B2=FE_OFN292_s01_0
XU64 AO22 $PINS O=N171 A1=N144 A2=FE_OFN333_s03_0 B1=term3_shifted[20]
+ B2=FE_OFN332_s03_0
XU65 AO22 $PINS O=N52 A1=N25 A2=n90 B1=term1_shifted[11] B2=FE_OFN292_s01_0
XU66 AO22 $PINS O=N55 A1=N28 A2=FE_OFN293_s01_0 B1=term1_shifted[14]
+ B2=FE_OFN292_s01_0
XU68 NR2 $PINS O=term2_in[2] I1=FE_OFN93_s02_1 I2=x_in[2]
XU69 NR2 $PINS O=term1_in[6] I1=sign1[1] I2=x_in[6]
XU75 AN2 $PINS O=sll_17/ML_int[1][0] I1=FE_OFN196_h02_0 I2=term2_in[0]
XU78 INV1S $PINS O=n128 I=sll_18/ML_int[2][3]
XU83 AN2 $PINS O=base_val[2] I1=acc_reg[2] I2=n154
XU84 AO22 $PINS O=N106 A1=N79 A2=sign2[0] B1=term2_shifted[10] B2=n62
XU85 AN2 $PINS O=base_val[10] I1=acc_reg[10] I2=n154
XU88 AO22 $PINS O=N105 A1=N78 A2=sign2[0] B1=term2_shifted[9] B2=n62
XU89 MOAI1S $PINS O=base_val[9] A1=n30 A2=n154 B1=acc_reg[9] B2=n154
XU90 AO22 $PINS O=N50 A1=N23 A2=n90 B1=term1_shifted[9] B2=FE_OFN292_s01_0
XU91 AO22 $PINS O=N54 A1=N27 A2=n90 B1=term1_shifted[13] B2=FE_OFN292_s01_0
XU92 AO22 $PINS O=N109 A1=N82 A2=FE_OFN41_s02_0 B1=term2_shifted[13] B2=n62
XU99 ND2 $PINS O=n1 I1=N71 I2=sign2[0]
XU100 ND2S $PINS O=n2 I1=term2_shifted[2] I2=n62
XU101 ND2P $PINS O=N98 I1=n1 I2=n2
XU102 NR2P $PINS O=term2_shifted[1] I1=n116 I2=n115
XU107 ND2P $PINS O=n104 I1=sll_16/ML_int[1][1] I2=FE_RN_226_0
XU108 AO22 $PINS O=N58 A1=N31 A2=FE_OFN293_s01_0 B1=term1_shifted[17]
+ B2=FE_OFN292_s01_0
XU109 AO22 $PINS O=N59 A1=N32 A2=FE_OFN293_s01_0 B1=term1_shifted[18]
+ B2=FE_OFN292_s01_0
XU113 AO22 $PINS O=N63 A1=N36 A2=FE_OFN294_s01_0 B1=term1_shifted[22]
+ B2=FE_OFN292_s01_0
XU116 AO22 $PINS O=N57 A1=N30 A2=FE_OFN293_s01_0 B1=term1_shifted[16]
+ B2=FE_OFN292_s01_0
XU117 AO22 $PINS O=N56 A1=N29 A2=FE_OFN293_s01_0 B1=term1_shifted[15]
+ B2=FE_OFN292_s01_0
XU118 AO22P $PINS O=N97 A1=N70 A2=sign2[0] B1=term2_shifted[1] B2=n62
XU119 AO22 $PINS O=N60 A1=N33 A2=FE_OFN293_s01_0 B1=term1_shifted[19]
+ B2=FE_OFN292_s01_0
XU122 NR2 $PINS O=term2_in[1] I1=sign2[1] I2=n152
XU123 MUX2 $PINS O=sll_17/ML_int[1][2] S=FE_OFN101_FE_OFN195_h02_0
+ A=term2_in[2] B=term2_in[1]
XU124 NR2 $PINS O=n5 I1=n143 I2=sign1[1]
XU125 MUX2S $PINS O=n113 S=FE_OFN98_FE_OFN219_h01_0 A=term1_in[26]
+ B=term1_in[15]
XU126 MUX2S $PINS O=n112 S=FE_RN_226_0 A=n113 B=term1_in[26]
XU127 NR2 $PINS O=n6 I1=n143 I2=sign3[1]
XU128 MUX2S $PINS O=n135 S=FE_OFN102_FE_OFN218_h03_0 A=term3_in[26]
+ B=term3_in[15]
XU129 NR2 $PINS O=n7 I1=n143 I2=FE_OFN93_s02_1
XU130 MUX2S $PINS O=n124 S=FE_OFN101_FE_OFN195_h02_0 A=term2_in[26]
+ B=term2_in[15]
XU131 MUX2S $PINS O=n123 S=FE_DBTN188_h02_1 A=n124 B=term2_in[26]
XU132 AO22 $PINS O=N49 A1=n90 A2=N22 B1=term1_shifted[8] B2=FE_OFN292_s01_0
XU133 AN2 $PINS O=term3_shifted[7] I1=sll_18/ML_int[3][7] I2=FE_OFN45_h03_3
XU138 INV2 $PINS O=n107 I=sll_16/ML_int[2][2]
XU139 MUX2S $PINS O=sll_18/ML_int[2][8] S=shf3[1] A=sll_18/ML_int[1][8]
+ B=sll_18/ML_int[1][6]
XU140 MUX2S $PINS O=sll_18/ML_int[1][8] S=FE_OFN102_FE_OFN218_h03_0
+ A=term3_in[8] B=term3_in[7]
XU141 MUX2 $PINS O=sll_17/ML_int[2][8] S=shf2[1] A=sll_17/ML_int[1][8]
+ B=sll_17/ML_int[1][6]
XU148 MUX2 $PINS O=sll_17/ML_int[1][8] S=FE_OFN101_FE_OFN195_h02_0
+ A=term2_in[8] B=term2_in[7]
XU165 MUX2S $PINS O=sll_16/ML_int[1][9] S=FE_OFN98_FE_OFN219_h01_0
+ A=term1_in[9] B=term1_in[8]
XU166 MUX2S $PINS O=sll_18/ML_int[2][9] S=shf3[1] A=sll_18/ML_int[1][9]
+ B=sll_18/ML_int[1][7]
XU167 MUX2S $PINS O=sll_18/ML_int[1][9] S=FE_OFN102_FE_OFN218_h03_0
+ A=term3_in[9] B=term3_in[8]
XU168 MUX2S $PINS O=sll_17/ML_int[2][9] S=shf2[1] A=sll_17/ML_int[1][9]
+ B=sll_17/ML_int[1][7]
XU169 MUX2S $PINS O=sll_17/ML_int[1][9] S=FE_OFN101_FE_OFN195_h02_0
+ A=term2_in[9] B=term2_in[8]
XU170 MUX2S $PINS O=sll_16/ML_int[2][10] S=FE_OFN89_h01_1
+ A=sll_16/ML_int[1][10] B=sll_16/ML_int[1][8]
XU182 MUX2S $PINS O=sll_16/ML_int[1][10] S=FE_OFN98_FE_OFN219_h01_0
+ A=term1_in[10] B=term1_in[9]
XU185 MUX2S $PINS O=sll_18/ML_int[2][10] S=shf3[1] A=sll_18/ML_int[1][10]
+ B=sll_18/ML_int[1][8]
XU186 MUX2S $PINS O=sll_18/ML_int[1][10] S=FE_OFN102_FE_OFN218_h03_0
+ A=term3_in[10] B=term3_in[9]
XU192 MUX2S $PINS O=sll_18/ML_int[3][10] S=n23 A=sll_18/ML_int[2][10]
+ B=sll_18/ML_int[2][6]
XU193 MUX2S $PINS O=sll_17/ML_int[2][10] S=shf2[1] A=sll_17/ML_int[1][10]
+ B=sll_17/ML_int[1][8]
XU194 MUX2S $PINS O=sll_17/ML_int[3][10] S=FE_RN_2 A=sll_17/ML_int[2][10]
+ B=sll_17/ML_int[2][6]
XU195 MUX2S $PINS O=sll_17/ML_int[1][10] S=FE_OFN101_FE_OFN195_h02_0
+ A=term2_in[10] B=term2_in[9]
XU196 MUX2S $PINS O=sll_16/ML_int[2][11] S=FE_OFN89_h01_1
+ A=sll_16/ML_int[1][11] B=sll_16/ML_int[1][9]
XU197 MUX2 $PINS O=sll_16/ML_int[1][11] S=FE_OFN98_FE_OFN219_h01_0
+ A=term1_in[11] B=term1_in[10]
XU198 MUX2 $PINS O=sll_18/ML_int[2][11] S=shf3[1] A=sll_18/ML_int[1][11]
+ B=sll_18/ML_int[1][9]
XU199 MUX2S $PINS O=sll_18/ML_int[3][11] S=n23 A=sll_18/ML_int[2][11]
+ B=sll_18/ML_int[2][7]
XU200 MUX2S $PINS O=sll_18/ML_int[1][11] S=FE_OFN102_FE_OFN218_h03_0
+ A=term3_in[11] B=term3_in[10]
XU201 MUX2 $PINS O=sll_17/ML_int[2][11] S=shf2[1] A=sll_17/ML_int[1][11]
+ B=sll_17/ML_int[1][9]
XU202 MUX2S $PINS O=sll_17/ML_int[3][11] S=FE_RN_2 A=sll_17/ML_int[2][11]
+ B=sll_17/ML_int[2][7]
XU203 MUX2S $PINS O=sll_17/ML_int[1][11] S=FE_OFN101_FE_OFN195_h02_0
+ A=term2_in[11] B=term2_in[10]
XU204 AO22S $PINS O=N62 A1=N35 A2=FE_OFN294_s01_0 B1=term1_shifted[21]
+ B2=FE_OFN292_s01_0
XU205 AO22S $PINS O=N64 A1=N37 A2=FE_OFN294_s01_0 B1=term1_shifted[23]
+ B2=FE_OFN292_s01_0
XU206 AO22S $PINS O=N65 A1=N38 A2=FE_OFN294_s01_0 B1=term1_shifted[24]
+ B2=FE_OFN292_s01_0
XU207 AO22S $PINS O=N66 A1=N39 A2=FE_OFN294_s01_0 B1=term1_shifted[25]
+ B2=FE_OFN292_s01_0
XU208 MUX2S $PINS O=sll_16/ML_int[2][12] S=FE_OFN89_h01_1
+ A=sll_16/ML_int[1][12] B=sll_16/ML_int[1][10]
XU209 MUX2S $PINS O=sll_16/ML_int[3][12] S=n77 A=sll_16/ML_int[2][12]
+ B=sll_16/ML_int[2][8]
XU210 MUX2 $PINS O=sll_16/ML_int[1][12] S=FE_OFN98_FE_OFN219_h01_0
+ A=term1_in[12] B=term1_in[11]
XU211 MUX2S $PINS O=sll_18/ML_int[2][12] S=shf3[1] A=sll_18/ML_int[1][12]
+ B=sll_18/ML_int[1][10]
XU212 MUX2S $PINS O=sll_18/ML_int[3][12] S=n23 A=sll_18/ML_int[2][12]
+ B=sll_18/ML_int[2][8]
XU213 MUX2S $PINS O=sll_18/ML_int[1][12] S=FE_OFN102_FE_OFN218_h03_0
+ A=term3_in[12] B=term3_in[11]
XU214 MUX2S $PINS O=sll_17/ML_int[2][12] S=shf2[1] A=sll_17/ML_int[1][12]
+ B=sll_17/ML_int[1][10]
XU215 MUX2S $PINS O=sll_17/ML_int[3][12] S=FE_RN_2 A=sll_17/ML_int[2][12]
+ B=sll_17/ML_int[2][8]
XU216 MUX2S $PINS O=sll_17/ML_int[1][12] S=FE_OFN101_FE_OFN195_h02_0
+ A=term2_in[12] B=term2_in[11]
XU217 MUX2 $PINS O=sll_16/ML_int[2][13] S=FE_OFN89_h01_1 A=sll_16/ML_int[1][13]
+ B=sll_16/ML_int[1][11]
XU218 MUX2S $PINS O=sll_16/ML_int[3][13] S=n77 A=sll_16/ML_int[2][13]
+ B=sll_16/ML_int[2][9]
XU219 MUX2 $PINS O=sll_16/ML_int[1][13] S=FE_OFN98_FE_OFN219_h01_0
+ A=term1_in[13] B=term1_in[12]
XU220 MUX2S $PINS O=sll_18/ML_int[2][13] S=shf3[1] A=sll_18/ML_int[1][13]
+ B=sll_18/ML_int[1][11]
XU221 MUX2S $PINS O=sll_18/ML_int[3][13] S=n23 A=sll_18/ML_int[2][13]
+ B=sll_18/ML_int[2][9]
XU222 MUX2S $PINS O=sll_18/ML_int[1][13] S=FE_OFN102_FE_OFN218_h03_0
+ A=term3_in[13] B=term3_in[12]
XU223 MUX2S $PINS O=sll_17/ML_int[2][13] S=shf2[1] A=sll_17/ML_int[1][13]
+ B=sll_17/ML_int[1][11]
XU224 MUX2S $PINS O=sll_17/ML_int[3][13] S=FE_OFN286_h02_2
+ A=sll_17/ML_int[2][13] B=sll_17/ML_int[2][9]
XU225 MUX2S $PINS O=sll_17/ML_int[1][13] S=FE_OFN101_FE_OFN195_h02_0
+ A=term2_in[13] B=term2_in[12]
XU226 MUX2S $PINS O=sll_16/ML_int[2][14] S=FE_OFN89_h01_1
+ A=sll_16/ML_int[1][14] B=sll_16/ML_int[1][12]
XU227 MUX2S $PINS O=sll_16/ML_int[3][14] S=n77 A=sll_16/ML_int[2][14]
+ B=sll_16/ML_int[2][10]
XU228 MUX2S $PINS O=sll_16/ML_int[1][14] S=FE_OFN98_FE_OFN219_h01_0
+ A=term1_in[14] B=term1_in[13]
XU229 MUX2S $PINS O=term3_shifted[14] S=FE_RN_7 A=sll_18/ML_int[3][14]
+ B=sll_18/ML_int[3][6]
XU230 MUX2S $PINS O=sll_18/ML_int[2][14] S=shf3[1] A=sll_18/ML_int[1][14]
+ B=sll_18/ML_int[1][12]
XU231 MUX2S $PINS O=sll_18/ML_int[3][14] S=n23 A=sll_18/ML_int[2][14]
+ B=sll_18/ML_int[2][10]
XU232 MUX2S $PINS O=sll_18/ML_int[1][14] S=FE_OFN102_FE_OFN218_h03_0
+ A=term3_in[14] B=term3_in[13]
XU233 MUX2S $PINS O=term2_shifted[14] S=FE_OFN211_h02_3 A=sll_17/ML_int[3][14]
+ B=sll_17/ML_int[3][6]
XU234 MUX2S $PINS O=sll_17/ML_int[3][14] S=FE_OFN286_h02_2
+ A=sll_17/ML_int[2][14] B=sll_17/ML_int[2][10]
XU235 MUX2S $PINS O=sll_17/ML_int[2][14] S=shf2[1] A=sll_17/ML_int[1][14]
+ B=sll_17/ML_int[1][12]
XU236 MUX2S $PINS O=sll_17/ML_int[1][14] S=FE_OFN101_FE_OFN195_h02_0
+ A=term2_in[14] B=term2_in[13]
XU237 MUX2S $PINS O=term1_shifted[16] S=FE_RN_6 A=sll_16/ML_int[3][16]
+ B=sll_16/ML_int[3][8]
XU238 MUX2S $PINS O=n110 S=FE_OFN89_h01_1 A=n113 B=sll_16/ML_int[1][14]
XU239 MUX2S $PINS O=term3_shifted[16] S=n27 A=sll_18/ML_int[3][16]
+ B=sll_18/ML_int[3][8]
XU240 MUX2S $PINS O=n132 S=shf3[1] A=n135 B=sll_18/ML_int[1][14]
XU241 MUX2S $PINS O=sll_16/ML_int[3][15] S=n77 A=sll_16/ML_int[2][15]
+ B=sll_16/ML_int[2][11]
XU242 MUX2S $PINS O=sll_16/ML_int[2][15] S=FE_OFN89_h01_1
+ A=sll_16/ML_int[1][15] B=sll_16/ML_int[1][13]
XU243 MUX2S $PINS O=sll_16/ML_int[1][15] S=FE_OFN98_FE_OFN219_h01_0
+ A=term1_in[15] B=term1_in[14]
XU244 MUX2S $PINS O=term2_shifted[16] S=FE_OFN42_h02_3 A=sll_17/ML_int[3][16]
+ B=sll_17/ML_int[3][8]
XU245 MUX2S $PINS O=n121 S=shf2[1] A=n124 B=sll_17/ML_int[1][14]
XU246 MUX2S $PINS O=sll_18/ML_int[3][15] S=n23 A=sll_18/ML_int[2][15]
+ B=sll_18/ML_int[2][11]
XU247 MUX2S $PINS O=sll_18/ML_int[2][15] S=shf3[1] A=sll_18/ML_int[1][15]
+ B=sll_18/ML_int[1][13]
XU248 MUX2S $PINS O=sll_18/ML_int[1][15] S=FE_OFN102_FE_OFN218_h03_0
+ A=term3_in[15] B=term3_in[14]
XU249 MUX2S $PINS O=term2_shifted[15] S=FE_OFN42_h02_3 A=sll_17/ML_int[3][15]
+ B=sll_17/ML_int[3][7]
XU250 MUX2S $PINS O=sll_17/ML_int[3][15] S=FE_OFN286_h02_2
+ A=sll_17/ML_int[2][15] B=sll_17/ML_int[2][11]
XU251 MUX2S $PINS O=sll_17/ML_int[2][15] S=shf2[1] A=sll_17/ML_int[1][15]
+ B=sll_17/ML_int[1][13]
XU252 MUX2S $PINS O=sll_17/ML_int[1][15] S=FE_OFN101_FE_OFN195_h02_0
+ A=term2_in[15] B=term2_in[14]
XU253 MUX2S $PINS O=term1_shifted[17] S=FE_RN_6 A=sll_16/ML_int[3][17]
+ B=sll_16/ML_int[3][9]
XU254 MUX2S $PINS O=term3_shifted[17] S=n27 A=sll_18/ML_int[3][17]
+ B=sll_18/ML_int[3][9]
XU255 MUX2S $PINS O=term2_shifted[17] S=FE_OFN42_h02_3 A=sll_17/ML_int[3][17]
+ B=sll_17/ML_int[3][9]
XU256 MUX2S $PINS O=term1_shifted[18] S=FE_RN_6 A=sll_16/ML_int[3][18]
+ B=sll_16/ML_int[3][10]
XU257 MUX2S $PINS O=term3_shifted[18] S=n27 A=sll_18/ML_int[3][18]
+ B=sll_18/ML_int[3][10]
XU258 MUX2S $PINS O=term2_shifted[18] S=FE_OFN42_h02_3 A=sll_17/ML_int[3][18]
+ B=sll_17/ML_int[3][10]
XU261 MUX2S $PINS O=sll_16/ML_int[3][16] S=n77 A=n110 B=sll_16/ML_int[2][12]
XU262 MUX2S $PINS O=sll_18/ML_int[3][16] S=n23 A=n132 B=sll_18/ML_int[2][12]
XU263 MUX2S $PINS O=sll_17/ML_int[3][16] S=FE_OFN286_h02_2 A=n121
+ B=sll_17/ML_int[2][12]
XU264 MUX2S $PINS O=n111 S=FE_OFN89_h01_1 A=n5 B=sll_16/ML_int[1][15]
XU265 MUX2S $PINS O=sll_16/ML_int[3][17] S=n77 A=n111 B=sll_16/ML_int[2][13]
XU266 MUX2S $PINS O=n133 S=shf3[1] A=n6 B=sll_18/ML_int[1][15]
XU267 MUX2S $PINS O=sll_18/ML_int[3][17] S=n23 A=n133 B=sll_18/ML_int[2][13]
XU268 MUX2S $PINS O=n122 S=shf2[1] A=n7 B=sll_17/ML_int[1][15]
XU269 MUX2S $PINS O=sll_17/ML_int[3][17] S=FE_OFN286_h02_2 A=n122
+ B=sll_17/ML_int[2][13]
XU270 MUX2S $PINS O=sll_16/ML_int[3][18] S=n77 A=n112 B=sll_16/ML_int[2][14]
XU271 MUX2S $PINS O=n134 S=FE_DBTN186_h03_1 A=n135 B=term3_in[26]
XU272 MUX2S $PINS O=sll_18/ML_int[3][18] S=n23 A=n134 B=sll_18/ML_int[2][14]
XU273 MUX2S $PINS O=sll_17/ML_int[3][18] S=FE_OFN286_h02_2 A=n123
+ B=sll_17/ML_int[2][14]
XU275 MUX2S $PINS O=term1_shifted[20] S=FE_RN_6 A=sll_16/ML_int[3][20]
+ B=sll_16/ML_int[3][12]
XU276 MUX2S $PINS O=sll_16/ML_int[3][20] S=n77 A=term1_in[26] B=n110
XU277 MUX2S $PINS O=term1_shifted[19] S=FE_RN_6 A=sll_16/ML_int[3][19]
+ B=sll_16/ML_int[3][11]
XU278 MUX2S $PINS O=term3_shifted[20] S=FE_RN_7 A=sll_18/ML_int[3][20]
+ B=sll_18/ML_int[3][12]
XU279 MUX2S $PINS O=sll_18/ML_int[3][20] S=n23 A=term3_in[26] B=n132
XU280 MUX2S $PINS O=term3_shifted[19] S=n27 A=sll_18/ML_int[3][19]
+ B=sll_18/ML_int[3][11]
XU281 MUX2S $PINS O=term2_shifted[20] S=FE_OFN211_h02_3 A=sll_17/ML_int[3][20]
+ B=sll_17/ML_int[3][12]
XU282 MUX2S $PINS O=sll_17/ML_int[3][20] S=FE_OFN286_h02_2 A=term2_in[26]
+ B=n121
XU283 MUX2S $PINS O=term2_shifted[19] S=FE_OFN42_h02_3 A=sll_17/ML_int[3][19]
+ B=sll_17/ML_int[3][11]
XU284 MUX2S $PINS O=term1_shifted[21] S=FE_RN_6 A=sll_16/ML_int[3][21]
+ B=sll_16/ML_int[3][13]
XU285 MUX2S $PINS O=term2_shifted[21] S=FE_OFN42_h02_3 A=sll_17/ML_int[3][21]
+ B=sll_17/ML_int[3][13]
XU286 MUX2S $PINS O=term3_shifted[21] S=n27 A=sll_18/ML_int[3][21]
+ B=sll_18/ML_int[3][13]
XU287 MUX2S $PINS O=term1_shifted[22] S=FE_RN_6 A=sll_16/ML_int[3][22]
+ B=sll_16/ML_int[3][14]
XU288 MUX2S $PINS O=term2_shifted[22] S=FE_OFN211_h02_3 A=sll_17/ML_int[3][22]
+ B=sll_17/ML_int[3][14]
XU289 MUX2S $PINS O=term3_shifted[22] S=FE_RN_7 A=sll_18/ML_int[3][22]
+ B=sll_18/ML_int[3][14]
XU294 AN2S $PINS O=base_val[3] I1=acc_reg[3] I2=n154
XU295 AN2S $PINS O=base_val[4] I1=acc_reg[4] I2=n154
XU296 AN2S $PINS O=base_val[5] I1=acc_reg[5] I2=n154
XU297 AN2S $PINS O=base_val[6] I1=acc_reg[6] I2=n154
XU299 ND2S $PINS O=n155 I1=FE_PHN1035_N251 I2=n30
XU300 MUX2S $PINS O=FE_PHN1267_N235 S=n30 A=FE_PHN1032_acc_reg_10 B=acc_reg[14]
XU301 MUX2S $PINS O=N244 S=n30 A=FE_PHN867_acc_reg_19 B=FE_PHN1103_acc_reg_23
XU308 INV2 $PINS O=n129 I=sll_18/ML_int[2][2]
XU315 NR2 $PINS O=term2_in[3] I1=FE_OFN93_s02_1 I2=x_in[3]
XU316 NR2 $PINS O=term3_in[3] I1=sign3[1] I2=x_in[3]
XU318 INV1S $PINS O=n119 I=n114
XU319 INV1S $PINS O=n130 I=n125
XU320 NR2 $PINS O=term1_in[5] I1=sign1[1] I2=x_in[5]
XU321 NR2 $PINS O=term2_in[5] I1=FE_OFN93_s02_1 I2=x_in[5]
XU322 INV1S $PINS O=n120 I=n115
XU323 NR2 $PINS O=term3_in[5] I1=sign3[1] I2=x_in[5]
XU324 INV1S $PINS O=n131 I=n126
XU325 NR2 $PINS O=term1_in[7] I1=sign1[1] I2=x_in[7]
XU326 NR2 $PINS O=term2_in[7] I1=FE_OFN93_s02_1 I2=x_in[7]
XU327 NR2 $PINS O=term3_in[7] I1=sign3[1] I2=x_in[7]
XU328 NR2 $PINS O=term2_in[6] I1=FE_OFN93_s02_1 I2=x_in[6]
XU329 NR2 $PINS O=term3_in[6] I1=sign3[1] I2=x_in[6]
XU333 NR2 $PINS O=term1_in[8] I1=sign1[1] I2=x_in[8]
XU334 NR2 $PINS O=term2_in[8] I1=FE_OFN93_s02_1 I2=x_in[8]
XU335 NR2 $PINS O=term3_in[8] I1=sign3[1] I2=x_in[8]
XU339 NR2 $PINS O=term1_in[9] I1=sign1[1] I2=x_in[9]
XU340 NR2 $PINS O=term2_in[9] I1=FE_OFN93_s02_1 I2=x_in[9]
XU341 NR2 $PINS O=term3_in[9] I1=sign3[1] I2=x_in[9]
XU342 NR2 $PINS O=term1_in[10] I1=sign1[1] I2=x_in[10]
XU343 NR2 $PINS O=term2_in[10] I1=FE_OFN93_s02_1 I2=x_in[10]
XU344 NR2 $PINS O=term3_in[10] I1=sign3[1] I2=x_in[10]
XU345 NR2 $PINS O=term1_in[11] I1=sign1[1] I2=x_in[11]
XU346 NR2 $PINS O=term2_in[11] I1=FE_OFN93_s02_1 I2=x_in[11]
XU347 NR2 $PINS O=term3_in[11] I1=sign3[1] I2=x_in[11]
XU348 NR2 $PINS O=term1_in[12] I1=sign1[1] I2=x_in[12]
XU349 NR2 $PINS O=term2_in[12] I1=FE_OFN93_s02_1 I2=x_in[12]
XU350 NR2 $PINS O=term3_in[12] I1=sign3[1] I2=x_in[12]
XU354 NR2 $PINS O=term1_in[13] I1=sign1[1] I2=x_in[13]
XU356 NR2 $PINS O=term2_in[13] I1=FE_OFN93_s02_1 I2=x_in[13]
XU357 NR2 $PINS O=term3_in[13] I1=sign3[1] I2=x_in[13]
XU358 NR2 $PINS O=term1_in[14] I1=sign1[1] I2=n141
XU359 NR2 $PINS O=term2_in[14] I1=FE_OFN93_s02_1 I2=n141
XU360 NR2 $PINS O=term3_in[14] I1=sign3[1] I2=n141
XU365 NR2 $PINS O=term1_in[15] I1=sign1[1] I2=n142
XU367 NR2 $PINS O=term2_in[15] I1=FE_OFN93_s02_1 I2=n142
XU368 NR2 $PINS O=term3_in[15] I1=sign3[1] I2=n142
XU402 INV1S $PINS O=n141 I=x_in[14]
XU406 INV1S $PINS O=n142 I=x_in[15]
XU407 INV1S $PINS O=n143 I=x_in[16]
XU408 NR2 $PINS O=term1_in[26] I1=n143 I2=sign1[1]
XU409 NR2 $PINS O=term2_in[26] I1=n143 I2=FE_OFN93_s02_1
XU411 NR2 $PINS O=term3_in[26] I1=n143 I2=sign3[1]
XU413 AN2 $PINS O=base_val[1] I1=acc_reg[1] I2=n154
XU414 AN2 $PINS O=base_val[11] I1=acc_reg[11] I2=n154
XU415 AN2 $PINS O=base_val[12] I1=acc_reg[12] I2=n154
XU416 AN2 $PINS O=base_val[14] I1=acc_reg[14] I2=n154
XU417 AN2 $PINS O=base_val[15] I1=acc_reg[15] I2=n154
XU418 AN2 $PINS O=base_val[16] I1=acc_reg[16] I2=n154
XU419 AN2 $PINS O=base_val[17] I1=acc_reg[17] I2=n154
XU420 AN2 $PINS O=base_val[18] I1=acc_reg[18] I2=n154
XU421 AN2 $PINS O=base_val[19] I1=acc_reg[19] I2=n154
XU422 AN2 $PINS O=base_val[20] I1=FE_PHN1131_acc_reg_20 I2=n154
XU423 AN2 $PINS O=base_val[21] I1=acc_reg[21] I2=n154
XU424 AN2 $PINS O=base_val[22] I1=acc_reg[22] I2=n154
XU425 AN2 $PINS O=base_val[23] I1=FE_PHN1103_acc_reg_23 I2=n154
XU426 AN2 $PINS O=base_val[24] I1=acc_reg[24] I2=n154
XU427 AN2 $PINS O=base_val[25] I1=acc_reg[25] I2=n154
XU428 AN2 $PINS O=base_val[8] I1=acc_reg[8] I2=n154
XU429 AN2 $PINS O=base_val[7] I1=acc_reg[7] I2=n154
XU432 AN2S $PINS O=base_val[0] I1=acc_reg[0] I2=n154
XU437 AN2 $PINS O=N234 I1=en I2=calc_done
XU438 OAI12HS $PINS O=N247 A1=n155 B1=n30 B2=n136
XU439 INV1S $PINS O=n136 I=acc_reg[22]
XU440 AN2 $PINS O=base_val[26] I1=FE_PHN1035_N251 I2=n154
XU443 INV1S $PINS O=n109 I=n104
XU444 MUX2 $PINS O=sll_16/ML_int[3][6] S=n77 A=sll_16/ML_int[2][6]
+ B=sll_16/ML_int[2][2]
XU445 NR2 $PINS O=sll_16/ML_int[3][0] I1=n77 I2=n103
XU446 NR2 $PINS O=sll_16/ML_int[3][1] I1=n77 I2=n104
XU447 NR2 $PINS O=sll_16/ML_int[3][2] I1=n77 I2=n107
XU448 NR2 $PINS O=sll_16/ML_int[3][3] I1=n77 I2=n106
XU449 AN2S $PINS O=term1_shifted[5] I1=sll_16/ML_int[3][5] I2=shf1[3]
XU450 AN2S $PINS O=term1_shifted[6] I1=sll_16/ML_int[3][6] I2=shf1[3]
XU451 AN2 $PINS O=term1_shifted[7] I1=sll_16/ML_int[3][7] I2=shf1[3]
XU452 MUX2 $PINS O=sll_16/ML_int[3][21] S=n77 A=n5 B=n111
XU453 MUX2 $PINS O=sll_16/ML_int[3][22] S=n77 A=term1_in[26] B=n112
XU454 MUX2 $PINS O=term1_shifted[24] S=FE_RN_6 A=term1_in[26]
+ B=sll_16/ML_int[3][16]
XU455 MUX2 $PINS O=term1_shifted[25] S=FE_RN_6 A=n5 B=sll_16/ML_int[3][17]
XU456 MUX2 $PINS O=term1_shifted[26] S=FE_RN_6 A=term1_in[26]
+ B=sll_16/ML_int[3][18]
XU457 NR2 $PINS O=sll_17/ML_int[3][0] I1=FE_RN_2 I2=n114
XU458 NR2 $PINS O=sll_17/ML_int[3][1] I1=FE_RN_2 I2=n115
XU461 ND2P $PINS O=n116 I1=n51 I2=n55
XU463 AN2 $PINS O=term2_shifted[5] I1=sll_17/ML_int[3][5] I2=n55
XU464 AN2 $PINS O=term2_shifted[6] I1=sll_17/ML_int[3][6] I2=n55
XU465 AN2 $PINS O=term2_shifted[7] I1=sll_17/ML_int[3][7] I2=n55
XU466 MUX2 $PINS O=sll_17/ML_int[3][21] S=FE_OFN286_h02_2 A=n7 B=n122
XU467 MUX2 $PINS O=sll_17/ML_int[3][22] S=FE_OFN286_h02_2 A=term2_in[26] B=n123
XU468 MUX2 $PINS O=term2_shifted[24] S=FE_OFN42_h02_3 A=term2_in[26]
+ B=sll_17/ML_int[3][16]
XU469 MUX2 $PINS O=term2_shifted[25] S=FE_OFN42_h02_3 A=n7
+ B=sll_17/ML_int[3][17]
XU470 MUX2 $PINS O=term2_shifted[26] S=FE_OFN42_h02_3 A=term2_in[26]
+ B=sll_17/ML_int[3][18]
XU471 NR2 $PINS O=sll_18/ML_int[3][0] I1=n23 I2=n125
XU472 NR2 $PINS O=sll_18/ML_int[3][1] I1=n23 I2=n126
XU473 NR2 $PINS O=sll_18/ML_int[3][2] I1=n23 I2=n129
XU474 NR2 $PINS O=sll_18/ML_int[3][3] I1=n23 I2=n128
XU475 ND2 $PINS O=n127 I1=FE_OFN46_h03_2 I2=FE_OFN45_h03_3
XU477 AN2 $PINS O=term3_shifted[5] I1=sll_18/ML_int[3][5] I2=FE_OFN45_h03_3
XU478 AN2 $PINS O=term3_shifted[6] I1=sll_18/ML_int[3][6] I2=FE_OFN45_h03_3
XU479 MUX2 $PINS O=sll_18/ML_int[3][21] S=n23 A=n6 B=n133
XU480 MUX2 $PINS O=sll_18/ML_int[3][22] S=n23 A=term3_in[26] B=n134
XU481 MUX2 $PINS O=term3_shifted[24] S=n27 A=term3_in[26]
+ B=sll_18/ML_int[3][16]
XU482 MUX2 $PINS O=term3_shifted[25] S=n27 A=n6 B=sll_18/ML_int[3][17]
XU483 MUX2 $PINS O=term3_shifted[26] S=n27 A=term3_in[26]
+ B=sll_18/ML_int[3][18]
XU484 MUX2 $PINS O=N245 S=n30 A=FE_PHN1131_acc_reg_20 B=FE_PHN869_acc_reg_24
XU485 MUX2 $PINS O=N246 S=n30 A=acc_reg[21] B=FE_PHN859_acc_reg_25
XU486 MUX2 $PINS O=N236 S=n30 A=acc_reg[11] B=FE_PHN984_acc_reg_15
XU487 MUX2 $PINS O=N237 S=n30 A=acc_reg[12] B=FE_PHN871_acc_reg_16
XU488 MUX2 $PINS O=N238 S=n30 A=acc_reg[13] B=acc_reg[17]
XU489 MUX2 $PINS O=N239 S=n30 A=acc_reg[14] B=FE_PHN864_acc_reg_18
XU490 MUX2 $PINS O=N240 S=n30 A=FE_PHN984_acc_reg_15 B=FE_PHN867_acc_reg_19
XU491 MUX2 $PINS O=N241 S=n30 A=FE_PHN871_acc_reg_16 B=FE_PHN1131_acc_reg_20
XU492 MUX2 $PINS O=N242 S=n30 A=acc_reg[17] B=acc_reg[21]
XU493 MUX2 $PINS O=N243 S=n30 A=FE_PHN864_acc_reg_18 B=acc_reg[22]
Xclk_gate_y_out_reg SNPS_CLOCK_GATE_HIGH_PE_Shift_Add_7 $PINS EN=N234
+ ENCLK=net2288 CLK_clone1=clk_clone2 CLK=clk_clone1
Xsub_28_3 PE_Shift_Add_7_DW01_sub_0_DW01_sub_21 $PINS A[26]=net44395
+ A[25]=net44395 A[24]=net44395 A[23]=net44395 A[22]=net44395 A[21]=net44395
+ A[20]=net44395 A[19]=net44395 A[18]=net44395 A[17]=net44395 A[16]=net44395
+ A[15]=net44395 A[14]=net44395 A[13]=net44395 A[12]=net44395 A[11]=net44395
+ A[10]=net44395 A[9]=net44395 A[8]=net44395 A[7]=net44395 A[6]=net44395
+ A[5]=net44395 A[4]=net44395 A[3]=net44395 A[2]=net44395 A[1]=net44395
+ A[0]=net44395 B[26]=term3_shifted[26] B[25]=term3_shifted[25]
+ B[24]=term3_shifted[24] B[23]=term3_shifted[23] B[22]=term3_shifted[22]
+ B[21]=term3_shifted[21] B[20]=term3_shifted[20] B[19]=term3_shifted[19]
+ B[18]=term3_shifted[18] B[17]=term3_shifted[17] B[16]=term3_shifted[16]
+ B[15]=term3_shifted[15] B[14]=term3_shifted[14] B[13]=term3_shifted[13]
+ B[12]=term3_shifted[12] B[11]=term3_shifted[11] B[10]=term3_shifted[10]
+ B[9]=term3_shifted[9] B[8]=term3_shifted[8] B[7]=term3_shifted[7]
+ B[6]=term3_shifted[6] B[5]=term3_shifted[5] B[4]=term3_shifted[4]
+ B[3]=term3_shifted[3] B[2]=term3_shifted[2] B[1]=term3_shifted[1]
+ B[0]=term3_shifted[0] CI=net44395 DIFF[26]=N150 DIFF[25]=N149 DIFF[24]=N148
+ DIFF[23]=N147 DIFF[22]=N146 DIFF[21]=N145 DIFF[20]=N144 DIFF[19]=N143
+ DIFF[18]=N142 DIFF[17]=N141 DIFF[16]=N140 DIFF[15]=N139 DIFF[14]=N138
+ DIFF[13]=N137 DIFF[12]=N136 DIFF[11]=N135 DIFF[10]=N134 DIFF[9]=N133
+ DIFF[8]=N132 DIFF[7]=N131 DIFF[6]=N130 DIFF[5]=N129 DIFF[4]=N128 DIFF[3]=N127
+ DIFF[2]=N126 DIFF[1]=N125 DIFF[0]=N124
Xsub_28_2 PE_Shift_Add_7_DW01_sub_1_DW01_sub_22 $PINS A[26]=net44395
+ A[25]=net44395 A[24]=net44395 A[23]=net44395 A[22]=net44395 A[21]=net44395
+ A[20]=net44395 A[19]=net44395 A[18]=net44395 A[17]=net44395 A[16]=net44395
+ A[15]=net44395 A[14]=net44395 A[13]=net44395 A[12]=net44395 A[11]=net44395
+ A[10]=net44395 A[9]=net44395 A[8]=net44395 A[7]=net44395 A[6]=net44395
+ A[5]=net44395 A[4]=net44395 A[3]=net44395 A[2]=net44395 A[1]=net44395
+ A[0]=net44395 B[26]=term2_shifted[26] B[25]=term2_shifted[25]
+ B[24]=term2_shifted[24] B[23]=term2_shifted[23] B[22]=term2_shifted[22]
+ B[21]=term2_shifted[21] B[20]=term2_shifted[20] B[19]=term2_shifted[19]
+ B[18]=term2_shifted[18] B[17]=term2_shifted[17] B[16]=term2_shifted[16]
+ B[15]=term2_shifted[15] B[14]=term2_shifted[14] B[13]=term2_shifted[13]
+ B[12]=term2_shifted[12] B[11]=term2_shifted[11] B[10]=term2_shifted[10]
+ B[9]=term2_shifted[9] B[8]=term2_shifted[8] B[7]=term2_shifted[7]
+ B[6]=term2_shifted[6] B[5]=term2_shifted[5] B[4]=term2_shifted[4]
+ B[3]=term2_shifted[3] B[2]=term2_shifted[2] B[1]=term2_shifted[1]
+ B[0]=term2_shifted[0] CI=net44395 DIFF[26]=N95 DIFF[25]=N94 DIFF[24]=N93
+ DIFF[23]=N92 DIFF[22]=N91 DIFF[21]=N90 DIFF[20]=N89 DIFF[19]=N88 DIFF[18]=N87
+ DIFF[17]=N86 DIFF[16]=N85 DIFF[15]=N84 DIFF[14]=N83 DIFF[13]=N82 DIFF[12]=N81
+ DIFF[11]=N80 DIFF[10]=N79 DIFF[9]=N78 DIFF[8]=N77 DIFF[7]=N76 DIFF[6]=N75
+ DIFF[5]=N74 DIFF[4]=N73 DIFF[3]=N72 DIFF[2]=N71 DIFF[1]=N70 DIFF[0]=N69
Xsub_28 PE_Shift_Add_7_DW01_sub_2_DW01_sub_23 $PINS A[26]=net44395
+ A[25]=net44395 A[24]=net44395 A[23]=net44395 A[22]=net44395 A[21]=net44395
+ A[20]=net44395 A[19]=net44395 A[18]=net44395 A[17]=net44395 A[16]=net44395
+ A[15]=net44395 A[14]=net44395 A[13]=net44395 A[12]=net44395 A[11]=net44395
+ A[10]=net44395 A[9]=net44395 A[8]=net44395 A[7]=net44395 A[6]=net44395
+ A[5]=net44395 A[4]=net44395 A[3]=net44395 A[2]=net44395 A[1]=net44395
+ A[0]=net44395 B[26]=term1_shifted[26] B[25]=term1_shifted[25]
+ B[24]=term1_shifted[24] B[23]=term1_shifted[23] B[22]=term1_shifted[22]
+ B[21]=term1_shifted[21] B[20]=term1_shifted[20] B[19]=term1_shifted[19]
+ B[18]=term1_shifted[18] B[17]=term1_shifted[17] B[16]=term1_shifted[16]
+ B[15]=term1_shifted[15] B[14]=term1_shifted[14] B[13]=term1_shifted[13]
+ B[12]=term1_shifted[12] B[11]=term1_shifted[11] B[10]=term1_shifted[10]
+ B[9]=term1_shifted[9] B[8]=term1_shifted[8] B[7]=term1_shifted[7]
+ B[6]=term1_shifted[6] B[5]=term1_shifted[5] B[4]=term1_shifted[4]
+ B[3]=term1_shifted[3] B[2]=term1_shifted[2] B[1]=term1_shifted[1]
+ B[0]=term1_shifted[0] CI=net44395 DIFF[26]=N40 DIFF[25]=N39 DIFF[24]=N38
+ DIFF[23]=N37 DIFF[22]=N36 DIFF[21]=N35 DIFF[20]=N34 DIFF[19]=N33 DIFF[18]=N32
+ DIFF[17]=N31 DIFF[16]=N30 DIFF[15]=N29 DIFF[14]=N28 DIFF[13]=N27 DIFF[12]=N26
+ DIFF[11]=N25 DIFF[10]=N24 DIFF[9]=N23 DIFF[8]=N22 DIFF[7]=N21 DIFF[6]=N20
+ DIFF[5]=N19 DIFF[4]=N18 DIFF[3]=N17 DIFF[2]=N16 DIFF[1]=N15 DIFF[0]=N14
Xadd_1_root_add_0_root_add_28_3 PE_Shift_Add_7_DW01_add_2_DW01_add_25 $PINS
+ A[26]=N67 A[25]=N66 A[24]=N65 A[23]=N64 A[22]=N63 A[21]=N62 A[20]=N61 A[19]=N60
+ A[18]=N59 A[17]=N58 A[16]=N57 A[15]=N56 A[14]=N55 A[13]=N54 A[12]=N53 A[11]=N52
+ A[10]=N51 A[9]=N50 A[8]=N49 A[7]=N48 A[6]=N47 A[5]=N46 A[4]=N45 A[3]=N44
+ A[2]=N43 A[1]=N42 A[0]=N41 B[26]=N177 B[25]=N176 B[24]=N175 B[23]=N174
+ B[22]=N173 B[21]=N172 B[20]=N171 B[19]=N170 B[18]=N169 B[17]=N168 B[16]=N167
+ B[15]=N166 B[14]=N165 B[13]=N164 B[12]=N163 B[11]=N162 B[10]=N161 B[9]=N160
+ B[8]=N159 B[7]=N158 B[6]=N157 B[5]=N156 B[4]=N155 B[3]=N154 B[2]=N153 B[1]=N152
+ B[0]=N151 CI=net44395 SUM[26]=N204 SUM[25]=N203 SUM[24]=N202 SUM[23]=N201
+ SUM[22]=N200 SUM[21]=N199 SUM[20]=N198 SUM[19]=N197 SUM[18]=N196 SUM[17]=N195
+ SUM[16]=N194 SUM[15]=N193 SUM[14]=N192 SUM[13]=N191 SUM[12]=N190 SUM[11]=N189
+ SUM[10]=N188 SUM[9]=N187 SUM[8]=N186 SUM[7]=N185 SUM[6]=N184 SUM[5]=N183
+ SUM[4]=N182 SUM[3]=N181 SUM[2]=N180 SUM[1]=N179 SUM[0]=N178
Xadd_2_root_add_0_root_add_28_3 PE_Shift_Add_7_DW01_add_1_DW01_add_24 $PINS
+ A[26]=base_val[26] A[25]=base_val[25] A[24]=base_val[24] A[23]=base_val[23]
+ A[22]=base_val[22] A[21]=base_val[21] A[20]=base_val[20] A[19]=base_val[19]
+ A[18]=base_val[18] A[17]=base_val[17] A[16]=base_val[16] A[15]=base_val[15]
+ A[14]=base_val[14] A[13]=base_val[13] A[12]=base_val[12] A[11]=base_val[11]
+ A[10]=base_val[10] A[9]=base_val[9] A[8]=base_val[8] A[7]=base_val[7]
+ A[6]=base_val[6] A[5]=base_val[5] A[4]=base_val[4] A[3]=base_val[3]
+ A[2]=base_val[2] A[1]=base_val[1] A[0]=base_val[0] B[26]=N122 B[25]=N121
+ B[24]=N120 B[23]=N119 B[22]=N118 B[21]=N117 B[20]=N116 B[19]=N115 B[18]=N114
+ B[17]=N113 B[16]=N112 B[15]=N111 B[14]=N110 B[13]=N109 B[12]=N108 B[11]=N107
+ B[10]=N106 B[9]=N105 B[8]=N104 B[7]=N103 B[6]=N102 B[5]=N101 B[4]=N100 B[3]=N99
+ B[2]=N98 B[1]=N97 B[0]=N96 CI=net44395 SUM[26]=N231 SUM[25]=N230 SUM[24]=N229
+ SUM[23]=N228 SUM[22]=N227 SUM[21]=N226 SUM[20]=N225 SUM[19]=N224 SUM[18]=N223
+ SUM[17]=N222 SUM[16]=N221 SUM[15]=N220 SUM[14]=N219 SUM[13]=N218 SUM[12]=N217
+ SUM[11]=N216 SUM[10]=N215 SUM[9]=N214 SUM[8]=N213 SUM[7]=N212 SUM[6]=N211
+ SUM[5]=N210 SUM[4]=N209 SUM[3]=N208 SUM[2]=N207 SUM[1]=N206 SUM[0]=N205
Xadd_0_root_add_0_root_add_28_3 PE_Shift_Add_7_DW01_add_0_DW01_add_23 $PINS
+ A[26]=N204 A[25]=N203 A[24]=N202 A[23]=N201 A[22]=N200 A[21]=N199 A[20]=N198
+ A[19]=N197 A[18]=N196 A[17]=N195 A[16]=N194 A[15]=N193 A[14]=N192 A[13]=N191
+ A[12]=N190 A[11]=N189 A[10]=N188 A[9]=N187 A[8]=N186 A[7]=N185 A[6]=N184
+ A[5]=N183 A[4]=N182 A[3]=N181 A[2]=N180 A[1]=N179 A[0]=N178 B[26]=N231
+ B[25]=N230 B[24]=N229 B[23]=N228 B[22]=N227 B[21]=N226 B[20]=N225 B[19]=N224
+ B[18]=N223 B[17]=N222 B[16]=N221 B[15]=N220 B[14]=N219 B[13]=N218 B[12]=N217
+ B[11]=N216 B[10]=N215 B[9]=N214 B[8]=N213 B[7]=N212 B[6]=N211 B[5]=N210
+ B[4]=N209 B[3]=N208 B[2]=N207 B[1]=N206 B[0]=N205 CI=net44395
+ SUM[26]=next_acc[26] SUM[25]=next_acc[25] SUM[24]=next_acc[24]
+ SUM[23]=next_acc[23] SUM[22]=next_acc[22] SUM[21]=next_acc[21]
+ SUM[20]=next_acc[20] SUM[19]=next_acc[19] SUM[18]=next_acc[18]
+ SUM[17]=next_acc[17] SUM[16]=next_acc[16] SUM[15]=next_acc[15]
+ SUM[14]=next_acc[14] SUM[13]=next_acc[13] SUM[12]=next_acc[12]
+ SUM[11]=next_acc[11] SUM[10]=next_acc[10] SUM[9]=next_acc[9] SUM[8]=next_acc[8]
+ SUM[7]=next_acc[7] SUM[6]=next_acc[6] SUM[5]=next_acc[5] SUM[4]=next_acc[4]
+ SUM[3]=next_acc[3] SUM[2]=next_acc[2] SUM[1]=next_acc[1] SUM[0]=next_acc[0]
Xsll_16/M1_0_5 MUX2 $PINS O=sll_16/ML_int[1][5] S=FE_OFN98_FE_OFN219_h01_0
+ A=term1_in[5] B=term1_in[4]
Xsll_16/M1_0_3 MUX2 $PINS O=sll_16/ML_int[1][3] S=FE_OFN98_FE_OFN219_h01_0
+ A=term1_in[3] B=term1_in[2]
Xsll_18/M1_0_3 MUX2 $PINS O=sll_18/ML_int[1][3] S=FE_OFN102_FE_OFN218_h03_0
+ A=term3_in[3] B=term3_in[2]
XU3 NR2 $PINS O=term3_in[4] I1=sign3[1] I2=x_in[4]
XU17 NR2P $PINS O=term3_shifted[2] I1=n127 I2=n129
XU18 ND2P $PINS O=n115 I1=sll_17/ML_int[1][1] I2=FE_DBTN188_h02_1
XU21 NR2 $PINS O=term3_in[1] I1=sign3[1] I2=n152
XU48 NR2P $PINS O=term3_shifted[1] I1=n127 I2=n126
XU50 NR2 $PINS O=sll_17/ML_int[3][2] I1=FE_RN_2 I2=n118
XU51 INV1S $PINS O=n118 I=sll_17/ML_int[2][2]
XU57 AN2 $PINS O=sll_17/ML_int[3][3] I1=n51 I2=sll_17/ML_int[2][3]
XU61 ND2 $PINS O=n105 I1=FE_OFN40_h01_2 I2=shf1[3]
XU70 NR2 $PINS O=term1_in[4] I1=sign1[1] I2=x_in[4]
XU72 NR2P $PINS O=term1_shifted[2] I1=n105 I2=n107
XU77 NR2 $PINS O=term1_in[1] I1=sign1[1] I2=n152
XU293 NR2 $PINS O=term1_shifted[3] I1=n105 I2=n106
XU375 NR2T $PINS O=term1_shifted[1] I1=n105 I2=n104
XU383 NR2 $PINS O=term1_in[3] I1=sign1[1] I2=x_in[3]
.ENDS

.SUBCKT SNPS_CLOCK_GATE_HIGH_PE_Shift_Add_6 EN ENCLK CLK
*.CONNECT net2264 EN
XFE_PHC990_net2267 DELC $PINS O=FE_PHN990_net2267 I=net2267
Xlatch QDBHN $PINS Q=net2267 D=net2264 CKB=CLK
Xmain_gate AN2T $PINS O=ENCLK I1=FE_PHN990_net2267 I2=CLK
.ENDS

.SUBCKT PE_Shift_Add_6_DW01_sub_0_DW01_sub_18 A[26] A[25] A[24] A[23] A[22]
+ A[21] A[20] A[19] A[18] A[17] A[16] A[15] A[14] A[13] A[12] A[11] A[10] A[9]
+ A[8] A[7] A[6] A[5] A[4] A[3] A[2] A[1] A[0] B[26] B[25] B[24] B[23] B[22]
+ B[21] B[20] B[19] B[18] B[17] B[16] B[15] B[14] B[13] B[12] B[11] B[10] B[9]
+ B[8] B[7] B[6] B[5] B[4] B[3] B[2] B[1] B[0] CI DIFF[26] DIFF[25] DIFF[24]
+ DIFF[23] DIFF[22] DIFF[21] DIFF[20] DIFF[19] DIFF[18] DIFF[17] DIFF[16]
+ DIFF[15] DIFF[14] DIFF[13] DIFF[12] DIFF[11] DIFF[10] DIFF[9] DIFF[8] DIFF[7]
+ DIFF[6] DIFF[5] DIFF[4] DIFF[3] DIFF[2] DIFF[1] DIFF[0] CO
*.CONNECT DIFF[0] B[0]
XFE_RC_370_0 XOR2HS $PINS O=DIFF[5] I1=n47 I2=n11
XFE_RC_230_0 XOR2HS $PINS O=DIFF[4] I1=n3 I2=n48
XFE_OCPC0_term3_shifted_2 INV2 $PINS O=n50 I=B[2]
XFE_RC_1110_0 INV1S $PINS O=FE_RN_113_0 I=n46
XFE_RC_1109_0 MXL2HS $PINS OB=DIFF[6] S=n12 A=FE_RN_113_0 B=n46
XFE_RC_970_0 XOR2HS $PINS O=DIFF[7] I1=n45 I2=n13
XFE_RC_284_0 INV1S $PINS O=FE_RN_19_0 I=n52
XFE_RC_283_0 MXL2HS $PINS OB=DIFF[1] S=n51 A=FE_RN_19_0 B=n52
XFE_OFC597_term3_shifted_3 INV2 $PINS O=n49 I=B[3]
XU2 INV2 $PINS O=n51 I=B[1]
XU3 NR2 $PINS O=n1 I1=B[1] I2=B[0]
XU4 INV1S $PINS O=n52 I=B[0]
XU7 INV2 $PINS O=n48 I=B[4]
XU8 INV2 $PINS O=n46 I=B[6]
XU9 INV1S $PINS O=n47 I=B[5]
XU10 AN2 $PINS O=n2 I1=n50 I2=n1
XU11 AN2 $PINS O=n3 I1=n49 I2=n2
XU12 AN2 $PINS O=n4 I1=n18 I2=n40
XU13 AN2 $PINS O=n5 I1=n4 I2=n39
XU14 AN2 $PINS O=n6 I1=n38 I2=n5
XU15 AN2 $PINS O=n7 I1=n37 I2=n6
XU16 AN2 $PINS O=n8 I1=n36 I2=n7
XU17 AN2 $PINS O=n9 I1=n35 I2=n8
XU18 AN2 $PINS O=n10 I1=n34 I2=n9
XU19 AN2 $PINS O=n11 I1=n48 I2=n3
XU20 AN2 $PINS O=n12 I1=n47 I2=n11
XU21 AN2 $PINS O=n13 I1=n12 I2=n46
XU22 AN2 $PINS O=n14 I1=n13 I2=n45
XU23 AN2 $PINS O=n15 I1=n14 I2=n44
XU24 AN2 $PINS O=n16 I1=n15 I2=n43
XU25 AN2 $PINS O=n17 I1=n16 I2=n42
XU26 AN2 $PINS O=n18 I1=n17 I2=n41
XU27 AN2 $PINS O=n19 I1=n33 I2=n10
XU28 AN2 $PINS O=n20 I1=n32 I2=n19
XU29 AN2 $PINS O=n21 I1=n31 I2=n20
XU30 AN2 $PINS O=n22 I1=n30 I2=n21
XU31 AN2 $PINS O=n23 I1=n29 I2=n22
XU32 AN2 $PINS O=n24 I1=n28 I2=n23
XU33 INV1S $PINS O=n40 I=B[12]
XU34 INV1S $PINS O=n39 I=B[13]
XU35 INV1S $PINS O=n38 I=B[14]
XU36 INV1S $PINS O=n37 I=B[15]
XU37 INV1S $PINS O=n36 I=B[16]
XU38 INV1S $PINS O=n35 I=B[17]
XU39 INV1S $PINS O=n34 I=B[18]
XU40 XOR2HS $PINS O=DIFF[2] I1=n1 I2=n50
XU42 XOR2HS $PINS O=DIFF[3] I1=n2 I2=n49
XU43 XOR2HS $PINS O=DIFF[10] I1=n42 I2=n16
XU44 XOR2HS $PINS O=DIFF[11] I1=n41 I2=n17
XU45 XOR2HS $PINS O=DIFF[12] I1=n40 I2=n18
XU46 XOR2HS $PINS O=DIFF[13] I1=n39 I2=n4
XU47 XOR2HS $PINS O=DIFF[14] I1=n38 I2=n5
XU48 XOR2HS $PINS O=DIFF[15] I1=n37 I2=n6
XU49 XOR2HS $PINS O=DIFF[16] I1=n36 I2=n7
XU50 XOR2HS $PINS O=DIFF[17] I1=n35 I2=n8
XU51 XOR2HS $PINS O=DIFF[18] I1=n34 I2=n9
XU52 XOR2HS $PINS O=DIFF[19] I1=n33 I2=n10
XU53 XOR2HS $PINS O=DIFF[20] I1=n32 I2=n19
XU54 XOR2HS $PINS O=DIFF[21] I1=n31 I2=n20
XU55 XOR2HS $PINS O=DIFF[22] I1=n30 I2=n21
XU56 XOR2HS $PINS O=DIFF[23] I1=n29 I2=n22
XU57 XOR2HS $PINS O=DIFF[24] I1=n28 I2=n23
XU58 XOR2HS $PINS O=DIFF[25] I1=n27 I2=n24
XU59 XOR2HS $PINS O=DIFF[9] I1=n43 I2=n15
XU60 XOR2HS $PINS O=DIFF[8] I1=n14 I2=n44
XU64 INV1S $PINS O=n45 I=B[7]
XU65 INV2 $PINS O=n44 I=B[8]
XU66 INV1S $PINS O=n43 I=B[9]
XU67 INV1S $PINS O=n42 I=B[10]
XU68 XOR2HS $PINS O=DIFF[26] I1=B[26] I2=n26
XU69 INV1S $PINS O=n41 I=B[11]
XU70 INV1S $PINS O=n33 I=B[19]
XU71 INV1S $PINS O=n32 I=B[20]
XU72 INV1S $PINS O=n31 I=B[21]
XU73 INV1S $PINS O=n30 I=B[22]
XU74 INV1S $PINS O=n29 I=B[23]
XU75 INV1S $PINS O=n28 I=B[24]
XU76 INV1S $PINS O=n27 I=B[25]
XU78 ND2 $PINS O=n26 I1=n27 I2=n24
.ENDS

.SUBCKT PE_Shift_Add_6_DW01_sub_1_DW01_sub_19 A[26] A[25] A[24] A[23] A[22]
+ A[21] A[20] A[19] A[18] A[17] A[16] A[15] A[14] A[13] A[12] A[11] A[10] A[9]
+ A[8] A[7] A[6] A[5] A[4] A[3] A[2] A[1] A[0] B[26] B[25] B[24] B[23] B[22]
+ B[21] B[20] B[19] B[18] B[17] B[16] B[15] B[14] B[13] B[12] B[11] B[10] B[9]
+ B[8] B[7] B[6] B[5] B[4] B[3] B[2] B[1] B[0] CI DIFF[26] DIFF[25] DIFF[24]
+ DIFF[23] DIFF[22] DIFF[21] DIFF[20] DIFF[19] DIFF[18] DIFF[17] DIFF[16]
+ DIFF[15] DIFF[14] DIFF[13] DIFF[12] DIFF[11] DIFF[10] DIFF[9] DIFF[8] DIFF[7]
+ DIFF[6] DIFF[5] DIFF[4] DIFF[3] DIFF[2] DIFF[1] DIFF[0] CO
*.CONNECT DIFF[0] B[0]
XFE_RC_543_0 XNR2HS $PINS O=DIFF[2] I1=n54 I2=B[2]
XFE_RC_343_0 XOR2HS $PINS O=DIFF[5] I1=n49 I2=n13
XU6 NR2P $PINS O=n13 I1=n1 I2=B[4]
XU7 INV1S $PINS O=n1 I=n5
XU9 NR3H $PINS O=n4 I1=B[0] I2=B[1] I3=B[2]
XU10 AN2 $PINS O=n5 I1=n50 I2=n4
XU11 INV1S $PINS O=n49 I=B[5]
XU12 INV1S $PINS O=n48 I=B[6]
XU15 AN2 $PINS O=n6 I1=n42 I2=n20
XU16 AN2 $PINS O=n7 I1=n41 I2=n6
XU17 AN2 $PINS O=n8 I1=n40 I2=n7
XU18 AN2 $PINS O=n9 I1=n39 I2=n8
XU19 AN2 $PINS O=n10 I1=n38 I2=n9
XU20 AN2 $PINS O=n11 I1=n37 I2=n10
XU21 AN2 $PINS O=n12 I1=n36 I2=n11
XU22 AN2 $PINS O=n14 I1=n49 I2=n13
XU23 AN2 $PINS O=n15 I1=n48 I2=n14
XU24 AN2 $PINS O=n16 I1=n47 I2=n15
XU25 AN2 $PINS O=n17 I1=n46 I2=n16
XU26 AN2 $PINS O=n18 I1=n45 I2=n17
XU27 AN2 $PINS O=n19 I1=n44 I2=n18
XU28 AN2 $PINS O=n20 I1=n43 I2=n19
XU29 AN2 $PINS O=n21 I1=n35 I2=n12
XU30 AN2 $PINS O=n22 I1=n34 I2=n21
XU31 AN2 $PINS O=n23 I1=n33 I2=n22
XU32 AN2 $PINS O=n24 I1=n32 I2=n23
XU33 AN2 $PINS O=n25 I1=n31 I2=n24
XU34 AN2 $PINS O=n26 I1=n30 I2=n25
XU35 INV1S $PINS O=n42 I=B[12]
XU36 INV1S $PINS O=n41 I=B[13]
XU37 INV1S $PINS O=n40 I=B[14]
XU38 INV1S $PINS O=n39 I=B[15]
XU39 INV1S $PINS O=n38 I=B[16]
XU40 INV1S $PINS O=n37 I=B[17]
XU41 INV1S $PINS O=n36 I=B[18]
XU42 INV1S $PINS O=n47 I=B[7]
XU43 INV1S $PINS O=n46 I=B[8]
XU44 INV1S $PINS O=n45 I=B[9]
XU45 INV1S $PINS O=n44 I=B[10]
XU46 XOR2HS $PINS O=DIFF[26] I1=B[26] I2=n28
XU47 INV1S $PINS O=n43 I=B[11]
XU48 INV1S $PINS O=n35 I=B[19]
XU49 INV1S $PINS O=n34 I=B[20]
XU50 INV1S $PINS O=n33 I=B[21]
XU51 INV1S $PINS O=n32 I=B[22]
XU52 INV1S $PINS O=n31 I=B[23]
XU53 INV1S $PINS O=n30 I=B[24]
XU54 INV1S $PINS O=n29 I=B[25]
XU55 XOR2HS $PINS O=DIFF[9] I1=n45 I2=n17
XU56 XOR2HS $PINS O=DIFF[10] I1=n44 I2=n18
XU57 XOR2HS $PINS O=DIFF[11] I1=n43 I2=n19
XU58 XOR2HS $PINS O=DIFF[12] I1=n42 I2=n20
XU59 XOR2HS $PINS O=DIFF[13] I1=n41 I2=n6
XU60 XOR2HS $PINS O=DIFF[14] I1=n40 I2=n7
XU61 XOR2HS $PINS O=DIFF[15] I1=n39 I2=n8
XU62 XOR2HS $PINS O=DIFF[16] I1=n38 I2=n9
XU63 XOR2HS $PINS O=DIFF[17] I1=n37 I2=n10
XU64 XOR2HS $PINS O=DIFF[18] I1=n36 I2=n11
XU65 XOR2HS $PINS O=DIFF[19] I1=n35 I2=n12
XU66 XOR2HS $PINS O=DIFF[20] I1=n34 I2=n21
XU67 XOR2HS $PINS O=DIFF[21] I1=n33 I2=n22
XU68 XOR2HS $PINS O=DIFF[22] I1=n32 I2=n23
XU69 XOR2HS $PINS O=DIFF[23] I1=n31 I2=n24
XU70 XOR2HS $PINS O=DIFF[24] I1=n30 I2=n25
XU71 XOR2HS $PINS O=DIFF[25] I1=n29 I2=n26
XU72 XOR2HS $PINS O=DIFF[8] I1=n16 I2=n46
XU73 XOR2HS $PINS O=DIFF[7] I1=n47 I2=n15
XU74 XOR2HS $PINS O=DIFF[6] I1=n48 I2=n14
XU76 XOR2HS $PINS O=DIFF[3] I1=n4 I2=n50
XU78 ND2 $PINS O=n28 I1=n29 I2=n26
XU1 INV2 $PINS O=n52 I=B[1]
XU3 INV2 $PINS O=n53 I=B[0]
XU4 XOR2HS $PINS O=DIFF[1] I1=n53 I2=n52
XU5 XNR2HS $PINS O=DIFF[4] I1=n5 I2=B[4]
XU13 AN2S $PINS O=n54 I1=n52 I2=n53
XU14 INV1S $PINS O=n50 I=B[3]
.ENDS

.SUBCKT PE_Shift_Add_6_DW01_sub_2_DW01_sub_20 A[26] A[25] A[24] A[23] A[22]
+ A[21] A[20] A[19] A[18] A[17] A[16] A[15] A[14] A[13] A[12] A[11] A[10] A[9]
+ A[8] A[7] A[6] A[5] A[4] A[3] A[2] A[1] A[0] B[26] B[25] B[24] B[23] B[22]
+ B[21] B[20] B[19] B[18] B[17] B[16] B[15] B[14] B[13] B[12] B[11] B[10] B[9]
+ B[8] B[7] B[6] B[5] B[4] B[3] B[2] B[1] B[0] CI DIFF[26] DIFF[25] DIFF[24]
+ DIFF[23] DIFF[22] DIFF[21] DIFF[20] DIFF[19] DIFF[18] DIFF[17] DIFF[16]
+ DIFF[15] DIFF[14] DIFF[13] DIFF[12] DIFF[11] DIFF[10] DIFF[9] DIFF[8] DIFF[7]
+ DIFF[6] DIFF[5] DIFF[4] DIFF[3] DIFF[2] DIFF[1] DIFF[0] CO
*.CONNECT DIFF[0] B[0]
XFE_RC_651_0 XNR2HS $PINS O=DIFF[9] I1=B[9] I2=n15
XFE_RC_334_0 INV1S $PINS O=FE_RN_183_0 I=n38
XFE_RC_333_0 MXL2HS $PINS OB=DIFF[14] S=n5 A=FE_RN_183_0 B=n38
XFE_RC_1080_0 INV1S $PINS O=FE_RN_97_0 I=n3
XFE_RC_1079_0 MXL2HS $PINS OB=DIFF[4] S=n48 A=FE_RN_97_0 B=n3
XFE_OFC598_term1_shifted_3 INV1S $PINS O=n49 I=B[3]
XU4 INV2 $PINS O=n52 I=B[0]
XU5 INV2 $PINS O=n51 I=B[1]
XU7 INV1S $PINS O=n46 I=B[6]
XU8 INV1S $PINS O=n47 I=B[5]
XU9 INV2 $PINS O=n48 I=B[4]
XU10 AN2 $PINS O=n3 I1=n2 I2=n49
XU11 XOR2HS $PINS O=DIFF[1] I1=n52 I2=n51
XU12 AN2 $PINS O=n1 I1=n51 I2=n52
XU13 XOR2HS $PINS O=DIFF[3] I1=n49 I2=n2
XU14 AN2 $PINS O=n2 I1=n50 I2=n1
XU15 XOR2HS $PINS O=DIFF[12] I1=n40 I2=n18
XU16 XOR2HS $PINS O=DIFF[13] I1=n39 I2=n4
XU17 AN2 $PINS O=n4 I1=n18 I2=n40
XU19 AN2 $PINS O=n5 I1=n4 I2=n39
XU20 XOR2HS $PINS O=DIFF[15] I1=n37 I2=n6
XU21 AN2 $PINS O=n6 I1=n38 I2=n5
XU22 XOR2HS $PINS O=DIFF[16] I1=n36 I2=n7
XU23 AN2 $PINS O=n7 I1=n37 I2=n6
XU24 XOR2HS $PINS O=DIFF[17] I1=n35 I2=n8
XU25 AN2 $PINS O=n8 I1=n36 I2=n7
XU26 XOR2HS $PINS O=DIFF[18] I1=n34 I2=n9
XU27 AN2 $PINS O=n9 I1=n35 I2=n8
XU28 AN2 $PINS O=n10 I1=n34 I2=n9
XU30 XOR2HS $PINS O=DIFF[5] I1=n47 I2=n11
XU31 AN2 $PINS O=n11 I1=n48 I2=n3
XU32 XOR2HS $PINS O=DIFF[6] I1=n46 I2=n12
XU33 AN2 $PINS O=n12 I1=n11 I2=n47
XU34 XOR2HS $PINS O=DIFF[7] I1=n45 I2=n13
XU35 AN2 $PINS O=n13 I1=n12 I2=n46
XU36 XOR2HS $PINS O=DIFF[8] I1=n14 I2=n44
XU37 AN2 $PINS O=n14 I1=n45 I2=n13
XU39 AN2 $PINS O=n15 I1=n44 I2=n14
XU40 XOR2HS $PINS O=DIFF[10] I1=n42 I2=n16
XU41 AN2 $PINS O=n16 I1=n15 I2=n43
XU42 XOR2HS $PINS O=DIFF[11] I1=n41 I2=n17
XU43 AN2 $PINS O=n17 I1=n16 I2=n42
XU44 AN2 $PINS O=n18 I1=n17 I2=n41
XU45 XOR2HS $PINS O=DIFF[19] I1=n33 I2=n10
XU46 XOR2HS $PINS O=DIFF[20] I1=n32 I2=n19
XU47 AN2 $PINS O=n19 I1=n33 I2=n10
XU48 XOR2HS $PINS O=DIFF[21] I1=n31 I2=n20
XU49 AN2 $PINS O=n20 I1=n32 I2=n19
XU50 XOR2HS $PINS O=DIFF[22] I1=n30 I2=n21
XU51 AN2 $PINS O=n21 I1=n31 I2=n20
XU52 XOR2HS $PINS O=DIFF[23] I1=n29 I2=n22
XU53 AN2 $PINS O=n22 I1=n30 I2=n21
XU54 XOR2HS $PINS O=DIFF[24] I1=n28 I2=n23
XU55 AN2 $PINS O=n23 I1=n29 I2=n22
XU56 AN2 $PINS O=n24 I1=n28 I2=n23
XU57 XOR2HS $PINS O=DIFF[25] I1=n27 I2=n24
XU58 INV1S $PINS O=n40 I=B[12]
XU59 INV1S $PINS O=n39 I=B[13]
XU60 INV1S $PINS O=n38 I=B[14]
XU61 INV1S $PINS O=n37 I=B[15]
XU62 INV1S $PINS O=n36 I=B[16]
XU63 INV1S $PINS O=n35 I=B[17]
XU64 INV1S $PINS O=n34 I=B[18]
XU65 INV1S $PINS O=n45 I=B[7]
XU66 INV1S $PINS O=n44 I=B[8]
XU67 INV1S $PINS O=n43 I=B[9]
XU68 INV1S $PINS O=n42 I=B[10]
XU69 XOR2HS $PINS O=DIFF[26] I1=B[26] I2=n26
XU70 INV1S $PINS O=n41 I=B[11]
XU71 INV1S $PINS O=n33 I=B[19]
XU72 INV1S $PINS O=n32 I=B[20]
XU73 INV1S $PINS O=n31 I=B[21]
XU74 INV1S $PINS O=n30 I=B[22]
XU75 INV1S $PINS O=n29 I=B[23]
XU76 INV1S $PINS O=n28 I=B[24]
XU77 INV1S $PINS O=n27 I=B[25]
XU78 ND2 $PINS O=n26 I1=n27 I2=n24
XU2 INV2 $PINS O=n50 I=B[2]
XU3 XOR2HS $PINS O=DIFF[2] I1=n1 I2=n50
.ENDS

.SUBCKT PE_Shift_Add_6_DW01_add_2_DW01_add_37 A[26] A[25] A[24] A[23] A[22]
+ A[21] A[20] A[19] A[18] A[17] A[16] A[15] A[14] A[13] A[12] A[11] A[10] A[9]
+ A[8] A[7] A[6] A[5] A[4] A[3] A[2] A[1] A[0] B[26] B[25] B[24] B[23] B[22]
+ B[21] B[20] B[19] B[18] B[17] B[16] B[15] B[14] B[13] B[12] B[11] B[10] B[9]
+ B[8] B[7] B[6] B[5] B[4] B[3] B[2] B[1] B[0] CI SUM[26] SUM[25] SUM[24]
+ SUM[23] SUM[22] SUM[21] SUM[20] SUM[19] SUM[18] SUM[17] SUM[16] SUM[15]
+ SUM[14] SUM[13] SUM[12] SUM[11] SUM[10] SUM[9] SUM[8] SUM[7] SUM[6] SUM[5]
+ SUM[4] SUM[3] SUM[2] SUM[1] SUM[0] CO
XFE_RC_632_0 INV2 $PINS O=SUM[7] I=FE_RN_307_0
XFE_RC_631_0 XNR3 $PINS O=FE_RN_307_0 I1=B[7] I2=A[7] I3=carry[7]
XFE_RC_553_0 INV2 $PINS O=SUM[3] I=FE_RN_277_0
XFE_RC_552_0 XNR3 $PINS O=FE_RN_277_0 I1=carry[3] I2=B[3] I3=A[3]
XFE_RC_432_0 ND3HT $PINS O=carry[14] I1=FE_RN_56_0 I2=FE_RN_57_0 I3=FE_RN_55_0
XFE_RC_374_0 INV2 $PINS O=SUM[8] I=FE_RN_197_0
XFE_RC_373_0 XNR3 $PINS O=FE_RN_197_0 I1=A[8] I2=B[8] I3=carry[8]
XFE_RC_257_0 AOI22H $PINS O=FE_RN_89_0 A1=B[9] A2=A[9] B1=carry[9] B2=A[9]
XFE_RC_206_1 ND3 $PINS O=carry[8] I1=n5 I2=n6 I3=n7
XFE_RC_184_1 ND2 $PINS O=FE_RN_110_0 I1=A[11] I2=B[11]
XFE_RC_183_0 ND2 $PINS O=FE_RN_111_0 I1=carry[11] I2=A[11]
XFE_RC_182_0 ND2 $PINS O=FE_RN_112_0 I1=carry[11] I2=B[11]
XFE_RC_181_0 ND3P $PINS O=carry[12] I1=FE_RN_112_0 I2=FE_RN_111_0
+ I3=FE_RN_110_0
XFE_RC_180_0 ND2 $PINS O=FE_RN_107_0 I1=A[22] I2=B[22]
XFE_RC_179_0 ND2P $PINS O=FE_RN_108_0 I1=carry[22] I2=A[22]
XFE_RC_178_0 ND2 $PINS O=FE_RN_109_0 I1=carry[22] I2=B[22]
XFE_RC_177_0 ND3P $PINS O=carry[23] I1=FE_RN_109_0 I2=FE_RN_108_0
+ I3=FE_RN_107_0
XFE_RC_1220_0 XOR3 $PINS O=SUM[24] I1=A[24] I2=B[24] I3=carry[24]
XFE_RC_1219_0 MAO222 $PINS O=carry[25] A1=carry[24] B1=B[24] C1=A[24]
XFE_RC_1098_0 XOR3 $PINS O=SUM[1] I1=n1 I2=A[1] I3=B[1]
XFE_RC_1097_0 MAO222P $PINS O=carry[2] A1=A[1] B1=B[1] C1=n1
XFE_RC_1061_0 ND2 $PINS O=FE_RN_88_0 I1=carry[9] I2=B[9]
XFE_RC_1059_0 ND2P $PINS O=carry[10] I1=FE_RN_89_0 I2=FE_RN_88_0
XFE_RC_1057_0 ND2 $PINS O=FE_RN_85_0 I1=B[10] I2=A[10]
XFE_RC_1056_0 ND2 $PINS O=FE_RN_86_0 I1=carry[10] I2=A[10]
XFE_RC_1055_0 ND2 $PINS O=FE_RN_87_0 I1=carry[10] I2=B[10]
XFE_RC_1054_0 ND3P $PINS O=carry[11] I1=FE_RN_87_0 I2=FE_RN_86_0 I3=FE_RN_85_0
XFE_RC_1051_0 XOR3 $PINS O=SUM[2] I1=A[2] I2=B[2] I3=carry[2]
XFE_RC_1050_0 MAO222P $PINS O=carry[3] A1=B[2] B1=carry[2] C1=A[2]
XFE_RC_1002_0 ND2 $PINS O=FE_RN_55_0 I1=B[13] I2=A[13]
XFE_RC_1001_0 ND2P $PINS O=FE_RN_56_0 I1=carry[13] I2=A[13]
XFE_RC_1000_0 ND2P $PINS O=FE_RN_57_0 I1=carry[13] I2=B[13]
XFE_RC_988_0 XOR3 $PINS O=SUM[23] I1=A[23] I2=B[23] I3=carry[23]
XFE_RC_987_0 MAO222 $PINS O=carry[24] A1=carry[23] B1=B[23] C1=A[23]
XFE_RC_945_0 XOR3 $PINS O=SUM[22] I1=A[22] I2=B[22] I3=carry[22]
XFE_RC_923_0 XOR3 $PINS O=SUM[9] I1=A[9] I2=B[9] I3=carry[9]
XFE_RC_921_0 XOR3 $PINS O=SUM[21] I1=A[21] I2=B[21] I3=carry[21]
XFE_RC_920_0 MAO222P $PINS O=carry[22] A1=carry[21] B1=B[21] C1=A[21]
XFE_RC_884_0 OR2 $PINS O=FE_RN_21_0 I1=FE_RN_13_0 I2=FE_RN_12_0
XFE_RC_883_0 ND2T $PINS O=carry[15] I1=FE_RN_16_0 I2=FE_RN_21_0
XFE_RC_805_0 MAO222P $PINS O=carry[9] A1=carry[8] B1=A[8] C1=B[8]
XFE_RC_786_0 XOR3 $PINS O=SUM[10] I1=A[10] I2=B[10] I3=carry[10]
XFE_RC_782_0 XOR3 $PINS O=SUM[20] I1=A[20] I2=B[20] I3=carry[20]
XFE_RC_781_0 MAO222 $PINS O=carry[21] A1=carry[20] B1=B[20] C1=A[20]
XFE_RC_724_0 XOR3 $PINS O=SUM[11] I1=A[11] I2=B[11] I3=carry[11]
XFE_RC_650_0 XOR3 $PINS O=SUM[12] I1=A[12] I2=B[12] I3=carry[12]
XFE_RC_649_0 MAO222P $PINS O=carry[13] A1=carry[12] B1=B[12] C1=A[12]
XFE_RC_647_0 MAO222P $PINS O=carry[4] A1=carry[3] B1=B[3] C1=A[3]
XFE_RC_586_0 XOR3 $PINS O=SUM[13] I1=A[13] I2=B[13] I3=carry[13]
XFE_RC_516_0 XOR3 $PINS O=SUM[16] I1=A[16] I2=B[16] I3=carry[16]
XFE_RC_515_0 MAO222 $PINS O=carry[17] A1=carry[16] B1=B[16] C1=A[16]
XFE_RC_468_0 XOR3 $PINS O=SUM[17] I1=A[17] I2=B[17] I3=carry[17]
XFE_RC_467_0 MAO222P $PINS O=carry[18] A1=carry[17] B1=B[17] C1=A[17]
XFE_RC_364_0 XOR3 $PINS O=SUM[18] I1=A[18] I2=B[18] I3=carry[18]
XFE_RC_363_0 MAO222P $PINS O=carry[19] A1=carry[18] B1=B[18] C1=A[18]
XFE_RC_356_0 XOR3 $PINS O=SUM[6] I1=B[6] I2=A[6] I3=carry[6]
XFE_RC_355_0 MAO222P $PINS O=carry[7] A1=carry[6] B1=B[6] C1=A[6]
XFE_RC_211_0 INV1S $PINS O=FE_RN_6_0 I=carry[14]
XFE_RC_210_0 XOR2HS $PINS O=FE_RN_7_0 I1=A[14] I2=B[14]
XFE_RC_209_0 ND2S $PINS O=FE_RN_8_0 I1=FE_RN_7_0 I2=FE_RN_6_0
XFE_RC_208_0 ND2 $PINS O=FE_RN_9_0 I1=B[14] I2=A[14]
XFE_RC_207_0 ND2S $PINS O=FE_RN_10_0 I1=FE_RN_9_0 I2=FE_RN_15_0
XFE_RC_206_0 ND2 $PINS O=FE_RN_11_0 I1=FE_RN_10_0 I2=carry[14]
XFE_RC_205_0 ND2P $PINS O=SUM[14] I1=FE_RN_11_0 I2=FE_RN_8_0
XFE_RC_204_0 INV1S $PINS O=FE_RN_12_0 I=A[14]
XFE_RC_203_0 INV1S $PINS O=FE_RN_13_0 I=B[14]
XFE_RC_201_0 OR2B1P $PINS O=FE_RN_15_0 I1=A[14] B1=FE_RN_13_0
XFE_RC_200_0 ND2T $PINS O=FE_RN_16_0 I1=carry[14] I2=FE_RN_15_0
XFE_RC_184_0 ND3P $PINS O=carry[5] I1=n10 I2=n9 I3=n8
XFE_RC_122_0 ND3P $PINS O=carry[6] I1=n14 I2=n13 I3=n12
XU1_25 FA1 $PINS S=SUM[25] CO=carry[26] A=A[25] B=B[25] CI=carry[25]
XU1_26 XOR3 $PINS O=SUM[26] I1=A[26] I2=B[26] I3=carry[26]
XU1 ND2 $PINS O=n8 I1=A[4] I2=B[4]
XU2 AN2 $PINS O=n1 I1=A[0] I2=B[0]
XU3 XOR3 $PINS O=SUM[4] I1=B[4] I2=A[4] I3=carry[4]
XU4 XOR3 $PINS O=SUM[19] I1=A[19] I2=B[19] I3=carry[19]
XU5 ND2P $PINS O=n2 I1=carry[19] I2=A[19]
XU6 ND2P $PINS O=n3 I1=carry[19] I2=B[19]
XU7 ND2 $PINS O=n4 I1=A[19] I2=B[19]
XU8 ND3P $PINS O=carry[20] I1=n3 I2=n2 I3=n4
XU10 ND2 $PINS O=n5 I1=carry[7] I2=B[7]
XU11 ND2 $PINS O=n6 I1=carry[7] I2=A[7]
XU12 ND2 $PINS O=n7 I1=A[7] I2=B[7]
XU14 ND2P $PINS O=n9 I1=carry[4] I2=A[4]
XU15 ND2 $PINS O=n10 I1=carry[4] I2=B[4]
XU17 XOR2HS $PINS O=n11 I1=A[5] I2=B[5]
XU18 XOR2HS $PINS O=SUM[5] I1=carry[5] I2=n11
XU19 ND2 $PINS O=n12 I1=A[5] I2=B[5]
XU20 ND2 $PINS O=n13 I1=carry[5] I2=A[5]
XU21 ND2 $PINS O=n14 I1=carry[5] I2=B[5]
XU23 XOR2HS $PINS O=n15 I1=B[15] I2=A[15]
XU24 XOR2HS $PINS O=SUM[15] I1=carry[15] I2=n15
XU25 ND2P $PINS O=n16 I1=carry[15] I2=B[15]
XU26 ND2T $PINS O=n17 I1=carry[15] I2=A[15]
XU27 ND2 $PINS O=n18 I1=B[15] I2=A[15]
XU28 ND3P $PINS O=carry[16] I1=n16 I2=n17 I3=n18
XU29 XOR2HS $PINS O=SUM[0] I1=B[0] I2=A[0]
.ENDS

.SUBCKT PE_Shift_Add_6_DW01_add_1_DW01_add_36 A[26] A[25] A[24] A[23] A[22]
+ A[21] A[20] A[19] A[18] A[17] A[16] A[15] A[14] A[13] A[12] A[11] A[10] A[9]
+ A[8] A[7] A[6] A[5] A[4] A[3] A[2] A[1] A[0] B[26] B[25] B[24] B[23] B[22]
+ B[21] B[20] B[19] B[18] B[17] B[16] B[15] B[14] B[13] B[12] B[11] B[10] B[9]
+ B[8] B[7] B[6] B[5] B[4] B[3] B[2] B[1] B[0] CI SUM[26] SUM[25] SUM[24]
+ SUM[23] SUM[22] SUM[21] SUM[20] SUM[19] SUM[18] SUM[17] SUM[16] SUM[15]
+ SUM[14] SUM[13] SUM[12] SUM[11] SUM[10] SUM[9] SUM[8] SUM[7] SUM[6] SUM[5]
+ SUM[4] SUM[3] SUM[2] SUM[1] SUM[0] CO
XFE_RC_395_0 ND2 $PINS O=FE_RN_209_0 I1=B[5] I2=A[5]
XFE_RC_394_0 ND2 $PINS O=FE_RN_210_0 I1=carry[5] I2=A[5]
XFE_RC_393_0 ND2 $PINS O=FE_RN_211_0 I1=carry[5] I2=B[5]
XFE_RC_392_0 ND3P $PINS O=carry[6] I1=FE_RN_211_0 I2=FE_RN_210_0 I3=FE_RN_209_0
XFE_RC_1_0 XOR3 $PINS O=SUM[5] I1=A[5] I2=B[5] I3=carry[5]
XFE_RC_1571_0 XOR3 $PINS O=SUM[24] I1=A[24] I2=B[24] I3=carry[24]
XFE_RC_1570_0 MAO222 $PINS O=carry[25] A1=carry[24] B1=B[24] C1=A[24]
XFE_RC_1335_0 XOR3 $PINS O=SUM[25] I1=A[25] I2=B[25] I3=carry[25]
XFE_RC_1334_0 MAO222 $PINS O=carry[26] A1=carry[25] B1=B[25] C1=A[25]
XFE_RC_1138_0 MAO222 $PINS O=carry[3] A1=B[2] B1=A[2] C1=carry[2]
XFE_RC_1137_0 XOR3 $PINS O=SUM[2] I1=A[2] I2=B[2] I3=carry[2]
XFE_RC_1073_0 MAO222 $PINS O=carry[2] A1=B[1] B1=A[1] C1=n1
XFE_RC_1072_0 XOR3 $PINS O=SUM[1] I1=A[1] I2=n1 I3=B[1]
XFE_RC_1026_0 XOR3 $PINS O=SUM[23] I1=A[23] I2=B[23] I3=carry[23]
XFE_RC_1025_0 MAO222 $PINS O=carry[24] A1=carry[23] B1=B[23] C1=A[23]
XFE_RC_907_0 XNR2HS $PINS O=FE_RN_38_0 I1=A[26] I2=B[26]
XFE_RC_906_0 INV1S $PINS O=FE_RN_37_0 I=FE_RN_38_0
XFE_RC_905_0 XOR2HS $PINS O=SUM[26] I1=FE_RN_37_0 I2=carry[26]
XFE_RC_878_0 XOR3 $PINS O=SUM[20] I1=A[20] I2=B[20] I3=carry[20]
XFE_RC_877_0 MAO222 $PINS O=carry[21] A1=carry[20] B1=B[20] C1=A[20]
XFE_RC_862_0 XOR3 $PINS O=SUM[21] I1=A[21] I2=B[21] I3=carry[21]
XFE_RC_861_0 MAO222 $PINS O=carry[22] A1=carry[21] B1=B[21] C1=A[21]
XFE_RC_830_0 XOR3 $PINS O=SUM[19] I1=A[19] I2=B[19] I3=carry[19]
XFE_RC_829_0 MAO222 $PINS O=carry[20] A1=carry[19] B1=B[19] C1=A[19]
XFE_RC_780_0 XOR3 $PINS O=SUM[22] I1=A[22] I2=B[22] I3=carry[22]
XFE_RC_779_0 MAO222 $PINS O=carry[23] A1=carry[22] B1=B[22] C1=A[22]
XFE_RC_730_0 XOR3 $PINS O=SUM[3] I1=A[3] I2=B[3] I3=carry[3]
XFE_RC_729_0 MAO222 $PINS O=carry[4] A1=B[3] B1=A[3] C1=carry[3]
XFE_RC_676_0 XOR3 $PINS O=SUM[15] I1=A[15] I2=B[15] I3=carry[15]
XFE_RC_675_0 MAO222 $PINS O=carry[16] A1=carry[15] B1=B[15] C1=A[15]
XFE_RC_612_0 XOR3 $PINS O=SUM[16] I1=A[16] I2=B[16] I3=carry[16]
XFE_RC_611_0 MAO222 $PINS O=carry[17] A1=carry[16] B1=B[16] C1=A[16]
XFE_RC_552_0 XOR3 $PINS O=SUM[11] I1=A[11] I2=B[11] I3=carry[11]
XFE_RC_551_0 MAO222 $PINS O=carry[12] A1=carry[11] B1=B[11] C1=A[11]
XFE_RC_520_0 XOR3 $PINS O=SUM[17] I1=A[17] I2=B[17] I3=carry[17]
XFE_RC_519_0 MAO222 $PINS O=carry[18] A1=carry[17] B1=B[17] C1=A[17]
XFE_RC_490_0 XOR3 $PINS O=SUM[18] I1=A[18] I2=B[18] I3=carry[18]
XFE_RC_489_0 MAO222 $PINS O=carry[19] A1=carry[18] B1=B[18] C1=A[18]
XFE_RC_470_0 XOR3 $PINS O=SUM[12] I1=A[12] I2=B[12] I3=carry[12]
XFE_RC_469_0 MAO222 $PINS O=carry[13] A1=carry[12] B1=B[12] C1=A[12]
XFE_RC_366_0 XOR3 $PINS O=SUM[13] I1=A[13] I2=B[13] I3=carry[13]
XFE_RC_365_0 MAO222 $PINS O=carry[14] A1=carry[13] B1=B[13] C1=A[13]
XFE_RC_360_0 XOR3 $PINS O=SUM[10] I1=A[10] I2=B[10] I3=carry[10]
XFE_RC_359_0 MAO222 $PINS O=carry[11] A1=carry[10] B1=B[10] C1=A[10]
XFE_RC_290_0 XOR3 $PINS O=SUM[14] I1=A[14] I2=B[14] I3=carry[14]
XFE_RC_289_0 MAO222 $PINS O=carry[15] A1=carry[14] B1=B[14] C1=A[14]
XFE_RC_288_0 XOR3 $PINS O=SUM[9] I1=A[9] I2=B[9] I3=carry[9]
XFE_RC_287_0 MAO222 $PINS O=carry[10] A1=carry[9] B1=B[9] C1=A[9]
XFE_RC_120_0 XOR3 $PINS O=SUM[6] I1=A[6] I2=B[6] I3=carry[6]
XFE_RC_119_0 MAO222 $PINS O=carry[7] A1=carry[6] B1=B[6] C1=A[6]
XFE_RC_100_0 XOR3 $PINS O=SUM[7] I1=A[7] I2=B[7] I3=carry[7]
XFE_RC_99_0 MAO222 $PINS O=carry[8] A1=carry[7] B1=B[7] C1=A[7]
XU3 AN2 $PINS O=n1 I1=B[0] I2=A[0]
XU4 ND2 $PINS O=n2 I1=carry[4] I2=B[4]
XU5 ND3 $PINS O=carry[9] I1=n6 I2=n5 I3=n7
XU6 ND2 $PINS O=n3 I1=carry[4] I2=A[4]
XU7 ND3P $PINS O=carry[5] I1=n3 I2=n2 I3=n4
XU8 ND2 $PINS O=n4 I1=B[4] I2=A[4]
XU9 ND2 $PINS O=n5 I1=carry[8] I2=B[8]
XU10 ND2 $PINS O=n6 I1=carry[8] I2=A[8]
XU11 ND2 $PINS O=n7 I1=B[8] I2=A[8]
XU12 XOR2HS $PINS O=SUM[0] I1=B[0] I2=A[0]
XU1 XOR3 $PINS O=SUM[4] I1=A[4] I2=B[4] I3=carry[4]
XU2 XOR3 $PINS O=SUM[8] I1=A[8] I2=B[8] I3=carry[8]
.ENDS

.SUBCKT PE_Shift_Add_6_DW01_add_0_DW01_add_35 A[26] A[25] A[24] A[23] A[22]
+ A[21] A[20] A[19] A[18] A[17] A[16] A[15] A[14] A[13] A[12] A[11] A[10] A[9]
+ A[8] A[7] A[6] A[5] A[4] A[3] A[2] A[1] A[0] B[26] B[25] B[24] B[23] B[22]
+ B[21] B[20] B[19] B[18] B[17] B[16] B[15] B[14] B[13] B[12] B[11] B[10] B[9]
+ B[8] B[7] B[6] B[5] B[4] B[3] B[2] B[1] B[0] CI SUM[26] SUM[25] SUM[24]
+ SUM[23] SUM[22] SUM[21] SUM[20] SUM[19] SUM[18] SUM[17] SUM[16] SUM[15]
+ SUM[14] SUM[13] SUM[12] SUM[11] SUM[10] SUM[9] SUM[8] SUM[7] SUM[6] SUM[5]
+ SUM[4] SUM[3] SUM[2] SUM[1] SUM[0] CO
XFE_RC_384_0 ND2 $PINS O=FE_RN_202_0 I1=A[2] I2=carry[2]
XFE_RC_383_0 ND2 $PINS O=FE_RN_203_0 I1=B[2] I2=A[2]
XFE_RC_382_0 ND2 $PINS O=FE_RN_204_0 I1=B[2] I2=carry[2]
XFE_RC_381_0 ND3 $PINS O=carry[3] I1=FE_RN_204_0 I2=FE_RN_203_0 I3=FE_RN_202_0
XFE_RC_191_0 ND2 $PINS O=FE_RN_115_1 I1=A[10] I2=B[10]
XFE_RC_190_0 ND2 $PINS O=FE_RN_116_1 I1=carry[10] I2=A[10]
XFE_RC_189_0 ND2 $PINS O=FE_RN_117_1 I1=carry[10] I2=B[10]
XFE_RC_188_0 ND3 $PINS O=carry[11] I1=FE_RN_117_1 I2=FE_RN_116_1 I3=FE_RN_115_1
XFE_RC_176_0 ND2 $PINS O=FE_RN_104_0 I1=B[25] I2=A[25]
XFE_RC_175_0 ND2 $PINS O=FE_RN_105_0 I1=carry[25] I2=A[25]
XFE_RC_174_0 ND2 $PINS O=FE_RN_106_0 I1=carry[25] I2=B[25]
XFE_RC_173_0 ND3P $PINS O=carry[26] I1=FE_RN_106_0 I2=FE_RN_105_0
+ I3=FE_RN_104_0
XFE_RC_0_0 ND3P $PINS O=carry[4] I1=n11 I2=n10 I3=n9
XFE_RC_1202_0 XOR2HS $PINS O=FE_RN_160_0 I1=B[26] I2=A[26]
XFE_RC_1201_0 XOR2HS $PINS O=SUM[26] I1=FE_RN_160_0 I2=carry[26]
XFE_RC_1119_0 ND2 $PINS O=FE_RN_115_0 I1=B[5] I2=A[5]
XFE_RC_1118_0 ND2 $PINS O=FE_RN_116_0 I1=carry[5] I2=A[5]
XFE_RC_1117_0 ND2 $PINS O=FE_RN_117_0 I1=carry[5] I2=B[5]
XFE_RC_1116_0 ND3P $PINS O=carry[6] I1=FE_RN_117_0 I2=FE_RN_116_0
+ I3=FE_RN_115_0
XFE_RC_852_0 XOR3 $PINS O=SUM[9] I1=A[9] I2=B[9] I3=carry[9]
XFE_RC_851_0 MAO222 $PINS O=carry[10] A1=carry[9] B1=B[9] C1=A[9]
XFE_RC_822_0 XOR3 $PINS O=SUM[10] I1=A[10] I2=B[10] I3=carry[10]
XFE_RC_816_0 XOR3 $PINS O=SUM[1] I1=A[1] I2=B[1] I3=n1
XFE_RC_815_0 MAO222 $PINS O=carry[2] A1=A[1] B1=B[1] C1=n1
XFE_RC_708_0 XOR3 $PINS O=SUM[11] I1=A[11] I2=B[11] I3=carry[11]
XFE_RC_707_0 MAO222 $PINS O=carry[12] A1=carry[11] B1=B[11] C1=A[11]
XFE_RC_706_0 XOR3S $PINS O=SUM[2] I1=A[2] I2=B[2] I3=carry[2]
XFE_RC_638_0 XOR3 $PINS O=SUM[5] I1=A[5] I2=B[5] I3=carry[5]
XFE_RC_634_0 XOR3 $PINS O=SUM[12] I1=A[12] I2=B[12] I3=carry[12]
XFE_RC_633_0 MAO222P $PINS O=carry[13] A1=carry[12] B1=B[12] C1=A[12]
XFE_RC_598_0 XOR3 $PINS O=SUM[6] I1=A[6] I2=B[6] I3=carry[6]
XFE_RC_597_0 MAO222 $PINS O=carry[7] A1=carry[6] B1=B[6] C1=A[6]
XFE_RC_534_0 XOR3 $PINS O=SUM[13] I1=A[13] I2=B[13] I3=carry[13]
XFE_RC_533_0 MAO222P $PINS O=carry[14] A1=carry[13] B1=B[13] C1=A[13]
XFE_RC_450_0 XOR3 $PINS O=SUM[14] I1=A[14] I2=B[14] I3=carry[14]
XFE_RC_449_0 MAO222P $PINS O=carry[15] A1=carry[14] B1=B[14] C1=A[14]
XFE_RC_442_0 XOR3 $PINS O=SUM[7] I1=A[7] I2=B[7] I3=carry[7]
XFE_RC_441_0 MAO222P $PINS O=carry[8] A1=carry[7] B1=B[7] C1=A[7]
XFE_RC_390_0 XOR3 $PINS O=SUM[20] I1=A[20] I2=B[20] I3=carry[20]
XFE_RC_389_0 MAO222 $PINS O=carry[21] A1=carry[20] B1=B[20] C1=A[20]
XFE_RC_388_0 XOR3 $PINS O=SUM[16] I1=A[16] I2=B[16] I3=carry[16]
XFE_RC_387_0 MAO222P $PINS O=carry[17] A1=carry[16] B1=B[16] C1=A[16]
XFE_RC_314_0 XOR3 $PINS O=SUM[18] I1=A[18] I2=B[18] I3=carry[18]
XFE_RC_313_0 MAO222P $PINS O=carry[19] A1=carry[18] B1=B[18] C1=A[18]
XFE_RC_306_0 XOR3 $PINS O=SUM[24] I1=A[24] I2=B[24] I3=carry[24]
XFE_RC_305_0 MAO222P $PINS O=carry[25] A1=carry[24] B1=B[24] C1=A[24]
XFE_RC_278_0 XOR3 $PINS O=SUM[25] I1=A[25] I2=B[25] I3=carry[25]
XU1 ND3P $PINS O=carry[23] I1=n4 I2=n3 I3=n2
XU3 ND3P $PINS O=carry[18] I1=n26 I2=n25 I3=n27
XU4 ND2 $PINS O=n9 I1=B[3] I2=A[3]
XU5 XOR3 $PINS O=SUM[3] I1=A[3] I2=B[3] I3=carry[3]
XU6 XOR3 $PINS O=SUM[8] I1=B[8] I2=A[8] I3=carry[8]
XU7 ND3P $PINS O=carry[9] I1=n16 I2=n17 I3=n18
XU8 XOR3 $PINS O=SUM[15] I1=A[15] I2=B[15] I3=carry[15]
XU9 ND3P $PINS O=carry[16] I1=n22 I2=n23 I3=n24
XU10 XOR3 $PINS O=SUM[17] I1=A[17] I2=B[17] I3=carry[17]
XU11 XOR3 $PINS O=SUM[19] I1=A[19] I2=B[19] I3=carry[19]
XU12 ND3P $PINS O=carry[20] I1=n28 I2=n29 I3=n30
XU13 XOR3 $PINS O=SUM[21] I1=B[21] I2=A[21] I3=carry[21]
XU14 AN2 $PINS O=n1 I1=B[0] I2=A[0]
XU15 XOR3 $PINS O=SUM[22] I1=A[22] I2=B[22] I3=carry[22]
XU16 ND2 $PINS O=n2 I1=A[22] I2=B[22]
XU17 ND2 $PINS O=n3 I1=carry[22] I2=A[22]
XU18 ND2 $PINS O=n4 I1=carry[22] I2=B[22]
XU19 XOR2HS $PINS O=n5 I1=A[23] I2=B[23]
XU20 XOR2HS $PINS O=SUM[23] I1=n5 I2=carry[23]
XU21 ND2 $PINS O=n6 I1=A[23] I2=B[23]
XU22 ND2 $PINS O=n7 I1=carry[23] I2=A[23]
XU23 ND2 $PINS O=n8 I1=carry[23] I2=B[23]
XU24 ND3P $PINS O=carry[24] I1=n7 I2=n8 I3=n6
XU25 ND2 $PINS O=n10 I1=carry[3] I2=A[3]
XU26 ND2 $PINS O=n11 I1=B[3] I2=carry[3]
XU27 XOR2HS $PINS O=n12 I1=A[4] I2=B[4]
XU28 XOR2HS $PINS O=SUM[4] I1=n12 I2=carry[4]
XU29 ND2 $PINS O=n13 I1=A[4] I2=B[4]
XU30 ND2 $PINS O=n14 I1=A[4] I2=carry[4]
XU31 ND2 $PINS O=n15 I1=carry[4] I2=B[4]
XU32 ND3P $PINS O=carry[5] I1=n14 I2=n15 I3=n13
XU33 ND2 $PINS O=n16 I1=carry[8] I2=B[8]
XU34 ND2 $PINS O=n17 I1=carry[8] I2=A[8]
XU35 ND2 $PINS O=n18 I1=B[8] I2=A[8]
XU36 ND2 $PINS O=n19 I1=carry[21] I2=B[21]
XU37 ND2 $PINS O=n20 I1=carry[21] I2=A[21]
XU38 ND2 $PINS O=n21 I1=B[21] I2=A[21]
XU39 ND3P $PINS O=carry[22] I1=n19 I2=n20 I3=n21
XU40 ND2 $PINS O=n30 I1=A[19] I2=B[19]
XU41 ND2P $PINS O=n22 I1=carry[15] I2=A[15]
XU42 ND2P $PINS O=n23 I1=carry[15] I2=B[15]
XU43 ND2S $PINS O=n24 I1=A[15] I2=B[15]
XU44 ND2P $PINS O=n25 I1=carry[17] I2=A[17]
XU45 ND2 $PINS O=n26 I1=carry[17] I2=B[17]
XU46 ND2S $PINS O=n27 I1=A[17] I2=B[17]
XU47 ND2 $PINS O=n28 I1=carry[19] I2=A[19]
XU48 ND2P $PINS O=n29 I1=carry[19] I2=B[19]
XU49 XOR2HS $PINS O=SUM[0] I1=B[0] I2=A[0]
.ENDS

.SUBCKT PE_Shift_Add_6 rst_n en clear calc_done stage_sel x_in[16] x_in[15]
+ x_in[14] x_in[13] x_in[12] x_in[11] x_in[10] x_in[9] x_in[8] x_in[7] x_in[6]
+ x_in[5] x_in[4] x_in[3] x_in[2] x_in[1] x_in[0] sign1[1] sign1[0] sign2[1]
+ sign2[0] sign3[1] sign3[0] shf1[3] shf1[2] shf1[1] shf1[0] shf2[3] shf2[2]
+ shf2[1] shf2[0] shf3[3] shf3[2] shf3[1] shf3[0] y_out[16] y_out[15] y_out[14]
+ y_out[13] y_out[12] y_out[11] y_out[10] y_out[9] y_out[8] y_out[7] y_out[6]
+ y_out[5] y_out[4] y_out[3] y_out[2] y_out[1] y_out[0] p_1 i_rst_n
+ FE_OFN12_i_rst_n FE_OFN10_i_rst_n FE_OFN6_i_rst_n FE_OFN96_s03_0
+ FE_OFN99_FE_OFN219_h01_0 FE_OFN100_FE_OFN195_h02_0 FE_OFN103_FE_OFN218_h03_0
+ clk_clone1 clk_clone2 clk
XFE_PHC1313_next_acc_0 DELB $PINS O=FE_PHN1313_next_acc_0 I=next_acc[0]
XFE_PHC1284_N235 DELB $PINS O=N235 I=FE_PHN1284_N235
XFE_PHC1274_N250 DELB $PINS O=FE_PHN1274_N250 I=N250
XFE_PHC1269_N249 DELB $PINS O=FE_PHN1269_N249 I=N249
XFE_PHC1265_N248 DELB $PINS O=FE_PHN1265_N248 I=N248
XFE_PHC1263_N244 DELB $PINS O=FE_PHN1263_N244 I=N244
XFE_PHC1261_N246 DELB $PINS O=FE_PHN1261_N246 I=N246
XFE_PHC1258_N242 DELB $PINS O=FE_PHN1258_N242 I=N242
XFE_PHC1255_N236 DELB $PINS O=FE_PHN1255_N236 I=N236
XFE_PHC1250_N243 DELB $PINS O=FE_PHN1250_N243 I=N243
XFE_PHC1235_N240 DELB $PINS O=FE_PHN1235_N240 I=N240
XFE_PHC1234_N237 DELB $PINS O=N237 I=FE_PHN1234_N237
XFE_PHC1225_N245 DELB $PINS O=FE_PHN1225_N245 I=N245
XFE_PHC1209_N238 DELB $PINS O=N238 I=FE_PHN1209_N238
XFE_PHC1195_N241 DELB $PINS O=N241 I=FE_PHN1195_N241
XFE_PHC1191_N239 DELB $PINS O=FE_PHN1191_N239 I=N239
XFE_PHC1183_N247 DELC $PINS O=FE_PHN1183_N247 I=N247
XFE_PHC1026_N251 DELC $PINS O=FE_PHN1026_N251 I=N251
XFE_PHC862_acc_reg_16 DELB $PINS O=FE_PHN862_acc_reg_16 I=acc_reg[16]
XFE_RC_424_0 INV1S $PINS O=FE_RN_223_0 I=sll_18/ML_int[2][8]
XFE_RC_423_0 MOAI1 $PINS O=sll_18/ML_int[3][8] A1=FE_RN_223_0 A2=n19
+ B1=sll_18/ML_int[2][4] B2=n19
XFE_RC_420_0 AO22 $PINS O=N48 A1=term1_shifted[7] A2=FE_OFN143_s01_0 B1=N21
+ B2=FE_OFN290_s01_0
XFE_OCPC727_FE_OFN131_mac_in_imag_8 BUF1S $PINS
+ O=FE_OCPN727_FE_OFN131_mac_in_imag_8 I=x_in[8]
XFE_RC_378_0 ND2 $PINS O=FE_RN_198_0 I1=term3_in[3]
+ I2=FE_OFN103_FE_OFN218_h03_0
XFE_RC_377_0 INV1S $PINS O=FE_RN_199_0 I=FE_OFN103_FE_OFN218_h03_0
XFE_RC_376_0 ND2 $PINS O=FE_RN_200_0 I1=term3_in[4] I2=FE_RN_199_0
XFE_RC_375_0 ND2 $PINS O=sll_18/ML_int[1][4] I1=FE_RN_200_0 I2=FE_RN_198_0
XFE_RC_372_0 INV1S $PINS O=FE_RN_196_0 I=term2_in[3]
XFE_RC_371_0 MOAI1H $PINS O=sll_17/ML_int[1][4] A1=FE_RN_196_0 A2=n36
+ B1=term2_in[4] B2=n36
XFE_RC_340_0 AO22 $PINS O=N55 A1=term1_shifted[14] A2=FE_OFN143_s01_0 B1=N28
+ B2=FE_OFN289_s01_0
XFE_RC_339_0 AO22 $PINS O=N158 A1=term3_shifted[7] A2=sign3[0] B1=N131
+ B2=FE_OFN138_s03_0
XFE_RC_308_0 ND2 $PINS O=FE_RN_167_0 I1=term1_shifted[4] I2=FE_OFN143_s01_0
XFE_RC_307_0 ND2 $PINS O=FE_RN_168_0 I1=N18 I2=FE_OFN290_s01_0
XFE_RC_306_0 ND2 $PINS O=N45 I1=FE_RN_168_0 I2=FE_RN_167_0
XFE_RC_293_0 ND2 $PINS O=FE_RN_158_1 I1=term1_shifted[8] I2=FE_OFN143_s01_0
XFE_RC_292_0 ND2 $PINS O=FE_RN_159_0 I1=N22 I2=FE_OFN290_s01_0
XFE_RC_291_0 ND2 $PINS O=N49 I1=FE_RN_159_0 I2=FE_RN_158_1
XFE_RC_262_0 ND2 $PINS O=FE_RN_140_1 I1=term3_shifted[14] I2=sign3[0]
XFE_RC_261_0 ND2P $PINS O=FE_RN_141_0 I1=N138 I2=FE_OFN138_s03_0
XFE_RC_260_0 ND2P $PINS O=N165 I1=FE_RN_141_0 I2=FE_RN_140_1
XFE_RC_4_0 ND2 $PINS O=FE_RN_0_0 I1=term2_shifted[2] I2=n60
XFE_RC_3_0 ND2 $PINS O=FE_RN_1_0 I1=N71 I2=sign2[0]
XFE_RC_2_0 ND2P $PINS O=N98 I1=FE_RN_1_0 I2=FE_RN_0_0
XCTS_ccl_a_INV_CLK_G1_L8_102 INV3CK $PINS O=CTS_10 I=CTS_11
XCTS_ccl_a_INV_CLK_G1_L7_102 INV2CK $PINS O=CTS_11 I=CTS_12
XFE_OFC706_FE_OFN278_h03_1 BUF1 $PINS O=FE_OFN366_FE_OFN278_h03_1 I=shf3[1]
XFE_RC_1555_0 ND2S $PINS O=FE_RN_352_0 I1=term1_in[0]
+ I2=FE_OFN99_FE_OFN219_h01_0
XFE_RC_1554_0 INV1S $PINS O=FE_RN_353_0 I=shf1[0]
XFE_RC_1553_0 ND2S $PINS O=FE_RN_354_0 I1=term1_in[1] I2=FE_RN_353_0
XFE_RC_1552_0 ND2 $PINS O=sll_16/ML_int[1][1] I1=FE_RN_354_0 I2=FE_RN_352_0
XFE_RC_1518_0 INV1S $PINS O=FE_RN_336_0 I=shf3[1]
XFE_RC_1517_0 INV2 $PINS O=sll_18/ML_int[2][2] I=FE_RN_337_0
XFE_RC_1516_0 AOI22H $PINS O=FE_RN_337_0 A1=sll_18/ML_int[1][0]
+ A2=FE_OFN366_FE_OFN278_h03_1 B1=sll_18/ML_int[1][2] B2=FE_RN_336_0
XFE_RC_1515_0 ND2 $PINS O=FE_RN_333_0 I1=term2_in[5]
+ I2=FE_OFN100_FE_OFN195_h02_0
XFE_RC_1514_0 INV1S $PINS O=FE_RN_334_0 I=shf2[0]
XFE_RC_1513_0 ND2 $PINS O=FE_RN_335_0 I1=term2_in[6] I2=FE_RN_334_0
XFE_RC_1512_0 ND2 $PINS O=sll_17/ML_int[1][6] I1=FE_RN_335_0 I2=FE_RN_333_0
XFE_RC_1511_0 ND2 $PINS O=FE_RN_330_0 I1=term1_in[4]
+ I2=FE_OFN99_FE_OFN219_h01_0
XFE_RC_1509_0 ND2 $PINS O=FE_RN_332_0 I1=term1_in[5] I2=FE_RN_353_0
XFE_RC_1508_0 ND2 $PINS O=sll_16/ML_int[1][5] I1=FE_RN_332_0 I2=FE_RN_330_0
XFE_RC_1503_0 ND2S $PINS O=FE_RN_324_0 I1=term2_in[2]
+ I2=FE_OFN100_FE_OFN195_h02_0
XFE_RC_1501_0 ND2S $PINS O=FE_RN_326_0 I1=term2_in[3] I2=FE_RN_334_0
XFE_RC_1500_0 ND2 $PINS O=sll_17/ML_int[1][3] I1=FE_RN_326_0 I2=FE_RN_324_0
XFE_RC_1499_0 ND2S $PINS O=FE_RN_321_0 I1=term1_in[3]
+ I2=FE_OFN99_FE_OFN219_h01_0
XFE_RC_1497_0 ND2 $PINS O=FE_RN_323_0 I1=term1_in[4] I2=FE_RN_353_0
XFE_RC_1496_0 ND2 $PINS O=sll_16/ML_int[1][4] I1=FE_RN_323_0 I2=FE_RN_321_0
XFE_RC_1415_0 ND2 $PINS O=FE_RN_268_0 I1=term3_in[4]
+ I2=FE_OFN103_FE_OFN218_h03_0
XFE_RC_1414_0 INV1S $PINS O=FE_RN_269_0 I=shf3[0]
XFE_RC_1413_0 ND2S $PINS O=FE_RN_270_0 I1=term3_in[5] I2=FE_RN_269_0
XFE_RC_1412_0 ND2 $PINS O=sll_18/ML_int[1][5] I1=FE_RN_270_0 I2=FE_RN_268_0
XFE_RC_1345_0 ND2 $PINS O=FE_RN_233_0 I1=term1_in[1]
+ I2=FE_OFN99_FE_OFN219_h01_0
XFE_RC_1343_0 ND2S $PINS O=FE_RN_235_0 I1=term1_in[2] I2=FE_RN_353_0
XFE_RC_1342_0 ND2 $PINS O=sll_16/ML_int[1][2] I1=FE_RN_235_0 I2=FE_RN_233_0
XFE_RC_1282_0 INV1S $PINS O=FE_RN_201_0 I=FE_RN_334_0
XFE_RC_1281_0 INV1S $PINS O=FE_RN_202_0 I=FE_RN_138_0
XFE_RC_1280_0 ND2 $PINS O=FE_RN_203_0 I1=FE_RN_202_0 I2=FE_RN_201_0
XFE_RC_1279_0 ND2 $PINS O=sll_17/ML_int[1][5] I1=FE_RN_140_0 I2=FE_RN_203_0
XFE_RC_1197_0 ND2 $PINS O=FE_RN_156_0 I1=term1_in[2]
+ I2=FE_OFN99_FE_OFN219_h01_0
XFE_RC_1195_0 ND2S $PINS O=FE_RN_158_0 I1=term1_in[3] I2=FE_RN_353_0
XFE_RC_1194_0 ND2 $PINS O=sll_16/ML_int[1][3] I1=FE_RN_158_0 I2=FE_RN_156_0
XFE_RC_1191_0 ND2 $PINS O=FE_RN_152_0 I1=term2_in[6]
+ I2=FE_OFN100_FE_OFN195_h02_0
XFE_RC_1190_0 INV1S $PINS O=FE_RN_153_0 I=FE_OFN100_FE_OFN195_h02_0
XFE_RC_1189_0 ND2 $PINS O=FE_RN_154_0 I1=term2_in[7] I2=FE_RN_153_0
XFE_RC_1188_0 ND2 $PINS O=sll_17/ML_int[1][7] I1=FE_RN_154_0 I2=FE_RN_152_0
XFE_RC_1187_0 ND2 $PINS O=FE_RN_149_0 I1=sll_18/ML_int[1][2]
+ I2=FE_OFN366_FE_OFN278_h03_1
XFE_RC_1186_0 INV1S $PINS O=FE_RN_150_0 I=shf3[1]
XFE_RC_1185_0 ND2 $PINS O=FE_RN_151_0 I1=sll_18/ML_int[1][4] I2=FE_RN_150_0
XFE_RC_1184_0 ND2 $PINS O=sll_18/ML_int[2][4] I1=FE_RN_151_0 I2=FE_RN_149_0
XFE_RC_1166_0 INV1S $PINS O=FE_RN_138_0 I=term2_in[4]
XFE_RC_1164_0 ND2S $PINS O=FE_RN_140_0 I1=term2_in[5] I2=FE_RN_334_0
XFE_RC_1158_0 ND2 $PINS O=FE_RN_133_0 I1=term3_in[6]
+ I2=FE_OFN103_FE_OFN218_h03_0
XFE_RC_1156_0 ND2 $PINS O=FE_RN_135_0 I1=term3_in[7] I2=FE_RN_269_0
XFE_RC_1155_0 ND2 $PINS O=sll_18/ML_int[1][7] I1=FE_RN_135_0 I2=FE_RN_133_0
XFE_RC_1150_0 ND2 $PINS O=FE_RN_128_0 I1=term1_in[6]
+ I2=FE_OFN99_FE_OFN219_h01_0
XFE_RC_1148_0 ND2S $PINS O=FE_RN_130_0 I1=term1_in[7] I2=FE_RN_353_0
XFE_RC_1147_0 ND2 $PINS O=sll_16/ML_int[1][7] I1=FE_RN_130_0 I2=FE_RN_128_0
XFE_RC_1106_0 ND2 $PINS O=FE_RN_109_0 I1=n125 I2=n19
XFE_RC_1105_0 INV1S $PINS O=FE_RN_110_0 I=n19
XFE_RC_1104_0 ND2 $PINS O=FE_RN_111_0 I1=sll_18/ML_int[2][4] I2=FE_RN_110_0
XFE_RC_1103_0 ND2 $PINS O=sll_18/ML_int[3][4] I1=FE_RN_111_0 I2=FE_RN_109_0
XFE_RC_1065_0 ND2 $PINS O=FE_RN_90_0 I1=n103 I2=n73
XFE_RC_1064_0 INV1S $PINS O=FE_RN_91_0 I=n73
XFE_RC_1063_0 ND2 $PINS O=FE_RN_92_0 I1=sll_16/ML_int[2][4] I2=FE_RN_91_0
XFE_RC_1062_0 ND2 $PINS O=sll_16/ML_int[3][4] I1=FE_RN_92_0 I2=FE_RN_90_0
XFE_RC_1038_0 INV1S $PINS O=FE_RN_77_0 I=shf2[2]
XFE_RC_1037_0 INV2 $PINS O=sll_17/ML_int[3][5] I=FE_RN_78_0
XFE_RC_1036_0 AOI22H $PINS O=FE_RN_78_0 A1=n115 A2=shf2[2]
+ B1=sll_17/ML_int[2][5] B2=FE_RN_77_0
XFE_RC_1018_0 ND2 $PINS O=FE_RN_66_0 I1=term2_shifted[4] I2=n60
XFE_RC_1017_0 ND2 $PINS O=FE_RN_67_0 I1=N73 I2=sign2[0]
XFE_RC_1016_0 ND2P $PINS O=N100 I1=FE_RN_67_0 I2=FE_RN_66_0
XFE_RC_19_0 OA12 $PINS O=N96 A1=N69 B1=sign2[0] B2=n60
XFE_RC_17_0 OA12 $PINS O=N151 A1=N124 B1=FE_OFN138_s03_0 B2=sign3[0]
XFE_RC_16_0 MUX2 $PINS O=N51 S=FE_OFN143_s01_0 A=N24 B=term1_shifted[10]
XFE_RC_11_0 OA12 $PINS O=N41 A1=N14 B1=FE_OFN290_s01_0 B2=FE_OFN143_s01_0
XFE_OFC657_s02_0 INV1S $PINS O=FE_OFN342_n I=sign2[0]
XFE_OFC656_s02_0 INV1S $PINS O=FE_OFN341_n I=sign2[0]
XFE_OFC655_s02_0 BUF1 $PINS O=FE_OFN340_n I=sign2[0]
XFE_OFC654_s02_0 INV1S $PINS O=FE_OFN339_n I=sign2[0]
XFE_OFC653_s02_0 INV2 $PINS O=n60 I=sign2[0]
XFE_OFC635_s03_0 BUF1 $PINS O=n30 I=sign3[0]
XFE_OFC634_s03_0 INV2 $PINS O=FE_OFN138_s03_0 I=sign3[0]
XFE_OFC631_h03_0 INV1S $PINS O=n11 I=FE_OFN103_FE_OFN218_h03_0
XFE_OFC596_h02_0 INV1S $PINS O=n36 I=FE_OFN100_FE_OFN195_h02_0
XFE_OFC581_sll_16_ML_int_2__3 INV2 $PINS O=n101 I=sll_16/ML_int[2][3]
XFE_OFC574_sll_18_ML_int_2__3 INV2CK $PINS O=n123 I=sll_18/ML_int[2][3]
XFE_OFC567_h03_3 INV1S $PINS O=FE_OFN312_h03_3 I=shf3[3]
XFE_OFC566_h03_3 INV1S $PINS O=FE_OFN311_h03_3 I=shf3[3]
XFE_OFC562_h01_3 INV1S $PINS O=FE_OFN309_h01_3 I=shf1[3]
XFE_OFC561_h01_3 INV1S $PINS O=FE_OFN308_h01_3 I=shf1[3]
XFE_OFC551_s02_1 BUF1 $PINS O=FE_OFN249_s02_1 I=sign2[1]
XFE_OFC544_h01_2 INV1S $PINS O=n73 I=shf1[2]
XFE_OFC529_h03_2 INV1S $PINS O=n19 I=shf3[2]
XFE_OFC519_s01_0 INV1S $PINS O=FE_OFN290_s01_0 I=FE_OFN143_s01_0
XFE_OFC518_s01_0 INV1S $PINS O=FE_OFN289_s01_0 I=FE_OFN143_s01_0
XFE_OFC517_s01_0 INV1S $PINS O=n84 I=FE_OFN143_s01_0
XFE_OFC515_s01_0 INV2 $PINS O=FE_OFN143_s01_0 I=sign1[0]
XFE_OFC421_h01_0 INV1S $PINS O=n66 I=FE_OFN99_FE_OFN219_h01_0
XFE_OFC400_h02_3 INV1S $PINS O=FE_OFN210_h02_3 I=shf2[3]
XFE_OFC333_h02_1 INV1S $PINS O=FE_DBTN189_h02_1 I=shf2[1]
XFE_OFC295_pe_clear_d1 INV2 $PINS O=n149 I=clear
XFE_OFC286_h03_1 INV2 $PINS O=FE_DBTN187_h03_1 I=shf3[1]
XFE_OFC227_h01_1 INV1S $PINS O=n69 I=shf1[1]
XFE_OFC115_n64 BUF1 $PINS O=FE_OFN4_FE_DBTN15_n64 I=p_1
XU110 AO22 $PINS O=base_val[13] A1=acc_reg[13] A2=n149 B1=clear
+ B2=FE_OFN4_FE_DBTN15_n64
XU115 AO22 $PINS O=N67 A1=n84 A2=N40 B1=term1_shifted[26] B2=FE_OFN143_s01_0
XU132 AO22P $PINS O=N50 A1=N23 A2=FE_OFN290_s01_0 B1=term1_shifted[9]
+ B2=FE_OFN143_s01_0
XU135 AO22 $PINS O=N47 A1=N20 A2=FE_OFN290_s01_0 B1=term1_shifted[6]
+ B2=FE_OFN143_s01_0
XU136 AO22 $PINS O=N46 A1=N19 A2=FE_OFN290_s01_0 B1=term1_shifted[5]
+ B2=FE_OFN143_s01_0
XU138 AO22 $PINS O=N44 A1=N17 A2=FE_OFN290_s01_0 B1=term1_shifted[3]
+ B2=FE_OFN143_s01_0
XU142 AO22 $PINS O=N177 A1=FE_OFN96_s03_0 A2=N150 B1=term3_shifted[26] B2=n30
XU143 AO22 $PINS O=N176 A1=N149 A2=FE_OFN96_s03_0 B1=term3_shifted[25] B2=n30
XU144 AO22 $PINS O=N175 A1=N148 A2=FE_OFN96_s03_0 B1=term3_shifted[24] B2=n30
XU145 AO22 $PINS O=N174 A1=N147 A2=FE_OFN96_s03_0 B1=term3_shifted[23] B2=n30
XU146 AO22 $PINS O=N173 A1=N146 A2=FE_OFN96_s03_0 B1=term3_shifted[22] B2=n30
XU147 AO22 $PINS O=N172 A1=N145 A2=FE_OFN96_s03_0 B1=term3_shifted[21] B2=n30
XU148 AO22 $PINS O=N171 A1=N144 A2=FE_OFN96_s03_0 B1=term3_shifted[20] B2=n30
XU149 AO22 $PINS O=N170 A1=N143 A2=FE_OFN96_s03_0 B1=term3_shifted[19] B2=n30
XU150 AO22 $PINS O=N169 A1=N142 A2=FE_OFN96_s03_0 B1=term3_shifted[18] B2=n30
XU151 AO22 $PINS O=N168 A1=N141 A2=FE_OFN96_s03_0 B1=term3_shifted[17] B2=n30
XU152 AO22 $PINS O=N167 A1=N140 A2=FE_OFN96_s03_0 B1=term3_shifted[16] B2=n30
XU155 AO22 $PINS O=N164 A1=N137 A2=FE_OFN138_s03_0 B1=term3_shifted[13]
+ B2=sign3[0]
XU157 AO22 $PINS O=N162 A1=N135 A2=FE_OFN138_s03_0 B1=term3_shifted[11]
+ B2=sign3[0]
XU158 AO22 $PINS O=N161 A1=N134 A2=FE_OFN138_s03_0 B1=term3_shifted[10]
+ B2=sign3[0]
XU159 AO22P $PINS O=N160 A1=N133 A2=FE_OFN138_s03_0 B1=term3_shifted[9]
+ B2=sign3[0]
XU160 AO22 $PINS O=N159 A1=FE_OFN138_s03_0 A2=N132 B1=term3_shifted[8]
+ B2=sign3[0]
XU162 AO22 $PINS O=N157 A1=N130 A2=FE_OFN138_s03_0 B1=term3_shifted[6]
+ B2=sign3[0]
XU163 AO22 $PINS O=N156 A1=N129 A2=FE_OFN138_s03_0 B1=term3_shifted[5]
+ B2=sign3[0]
XU164 AO22 $PINS O=N155 A1=FE_OFN138_s03_0 A2=N128 B1=term3_shifted[4]
+ B2=sign3[0]
XU165 AO22 $PINS O=N154 A1=N127 A2=FE_OFN138_s03_0 B1=term3_shifted[3]
+ B2=sign3[0]
XU166 AO22 $PINS O=N153 A1=N126 A2=FE_OFN138_s03_0 B1=term3_shifted[2]
+ B2=sign3[0]
XU169 AO22 $PINS O=N122 A1=N95 A2=FE_OFN340_n B1=term2_shifted[26]
+ B2=FE_OFN339_n
XU170 AO22 $PINS O=N121 A1=N94 A2=FE_OFN340_n B1=term2_shifted[25]
+ B2=FE_OFN339_n
XU171 AO22 $PINS O=N120 A1=N93 A2=FE_OFN340_n B1=term2_shifted[24]
+ B2=FE_OFN341_n
XU172 AO22 $PINS O=N119 A1=N92 A2=FE_OFN340_n B1=term2_shifted[23]
+ B2=FE_OFN341_n
XU174 AO22 $PINS O=N117 A1=N90 A2=FE_OFN340_n B1=term2_shifted[21]
+ B2=FE_OFN341_n
XU175 AO22 $PINS O=N116 A1=N89 A2=FE_OFN340_n B1=term2_shifted[20]
+ B2=FE_OFN341_n
XU176 AO22 $PINS O=N115 A1=N88 A2=FE_OFN340_n B1=term2_shifted[19]
+ B2=FE_OFN341_n
XU177 AO22 $PINS O=N114 A1=N87 A2=FE_OFN340_n B1=term2_shifted[18]
+ B2=FE_OFN341_n
XU178 AO22 $PINS O=N113 A1=N86 A2=FE_OFN340_n B1=term2_shifted[17]
+ B2=FE_OFN341_n
XU179 AO22 $PINS O=N112 A1=N85 A2=FE_OFN340_n B1=term2_shifted[16]
+ B2=FE_OFN342_n
XU180 AO22 $PINS O=N111 A1=N84 A2=FE_OFN340_n B1=term2_shifted[15]
+ B2=FE_OFN342_n
XU181 AO22 $PINS O=N110 A1=N83 A2=sign2[0] B1=term2_shifted[14] B2=FE_OFN342_n
XU183 AO22 $PINS O=N108 A1=N81 A2=sign2[0] B1=term2_shifted[12] B2=FE_OFN342_n
XU184 AO22 $PINS O=N107 A1=N80 A2=sign2[0] B1=term2_shifted[11] B2=n60
XU185 AO22 $PINS O=N106 A1=N79 A2=sign2[0] B1=term2_shifted[10] B2=n60
XU186 AO22 $PINS O=N105 A1=N78 A2=sign2[0] B1=term2_shifted[9] B2=n60
XU188 AO22 $PINS O=N103 A1=N76 A2=sign2[0] B1=term2_shifted[7] B2=n60
XU189 AO22 $PINS O=N102 A1=N75 A2=sign2[0] B1=term2_shifted[6] B2=n60
XU190 AO22 $PINS O=N101 A1=N74 A2=sign2[0] B1=term2_shifted[5] B2=n60
Xsll_18/M1_0_1 MUX2 $PINS O=sll_18/ML_int[1][1] S=FE_OFN103_FE_OFN218_h03_0
+ A=term3_in[1] B=term3_in[0]
Xsll_18/M1_0_6 MUX2 $PINS O=sll_18/ML_int[1][6] S=FE_OFN103_FE_OFN218_h03_0
+ A=term3_in[6] B=term3_in[5]
Xsll_18/M1_0_9 MUX2 $PINS O=sll_18/ML_int[1][9] S=FE_OFN103_FE_OFN218_h03_0
+ A=term3_in[9] B=term3_in[8]
Xsll_18/M1_0_12 MUX2 $PINS O=sll_18/ML_int[1][12] S=FE_OFN103_FE_OFN218_h03_0
+ A=term3_in[12] B=term3_in[11]
Xsll_18/M1_1_5 MUX2 $PINS O=sll_18/ML_int[2][5] S=shf3[1] A=sll_18/ML_int[1][5]
+ B=sll_18/ML_int[1][3]
Xsll_18/M1_1_6 MUX2 $PINS O=sll_18/ML_int[2][6] S=shf3[1] A=sll_18/ML_int[1][6]
+ B=sll_18/ML_int[1][4]
Xsll_18/M1_1_7 MUX2 $PINS O=sll_18/ML_int[2][7] S=shf3[1] A=sll_18/ML_int[1][7]
+ B=sll_18/ML_int[1][5]
Xsll_18/M1_1_8 MUX2 $PINS O=sll_18/ML_int[2][8] S=shf3[1] A=sll_18/ML_int[1][8]
+ B=sll_18/ML_int[1][6]
Xsll_18/M1_2_5 MUX2 $PINS O=sll_18/ML_int[3][5] S=n19 A=sll_18/ML_int[2][5]
+ B=n126
Xsll_18/M1_2_6 MUX2 $PINS O=sll_18/ML_int[3][6] S=n19 A=sll_18/ML_int[2][6]
+ B=sll_18/ML_int[2][2]
Xsll_18/M1_2_7 MUX2 $PINS O=sll_18/ML_int[3][7] S=n19 A=sll_18/ML_int[2][7]
+ B=sll_18/ML_int[2][3]
Xsll_18/M1_2_9 MUX2 $PINS O=sll_18/ML_int[3][9] S=n19 A=sll_18/ML_int[2][9]
+ B=sll_18/ML_int[2][5]
Xsll_18/M1_2_10 MUX2 $PINS O=sll_18/ML_int[3][10] S=n19 A=sll_18/ML_int[2][10]
+ B=sll_18/ML_int[2][6]
Xsll_18/M1_2_19 MUX2 $PINS O=sll_18/ML_int[3][19] S=n19 A=n5
+ B=sll_18/ML_int[2][15]
Xsll_18/M1_3_8 MUX2 $PINS O=term3_shifted[8] S=FE_OFN312_h03_3
+ A=sll_18/ML_int[3][8] B=sll_18/ML_int[3][0]
Xsll_18/M1_3_9 MUX2 $PINS O=term3_shifted[9] S=FE_OFN312_h03_3
+ A=sll_18/ML_int[3][9] B=sll_18/ML_int[3][1]
Xsll_18/M1_3_10 MUX2 $PINS O=term3_shifted[10] S=FE_OFN312_h03_3
+ A=sll_18/ML_int[3][10] B=sll_18/ML_int[3][2]
Xsll_18/M1_3_11 MUX2 $PINS O=term3_shifted[11] S=FE_OFN312_h03_3
+ A=sll_18/ML_int[3][11] B=sll_18/ML_int[3][3]
Xsll_18/M1_3_13 MUX2 $PINS O=term3_shifted[13] S=FE_OFN312_h03_3
+ A=sll_18/ML_int[3][13] B=sll_18/ML_int[3][5]
Xsll_18/M1_3_14 MUX2 $PINS O=term3_shifted[14] S=FE_OFN312_h03_3
+ A=sll_18/ML_int[3][14] B=sll_18/ML_int[3][6]
Xsll_18/M1_3_15 MUX2 $PINS O=term3_shifted[15] S=FE_OFN312_h03_3
+ A=sll_18/ML_int[3][15] B=sll_18/ML_int[3][7]
Xsll_18/M1_3_22 MUX2 $PINS O=term3_shifted[22] S=FE_OFN311_h03_3
+ A=sll_18/ML_int[3][22] B=sll_18/ML_int[3][14]
Xsll_18/M1_3_23 MUX2 $PINS O=term3_shifted[23] S=FE_OFN311_h03_3 A=n5
+ B=sll_18/ML_int[3][15]
Xsll_17/M1_0_1 MUX2 $PINS O=sll_17/ML_int[1][1] S=FE_OFN100_FE_OFN195_h02_0
+ A=term2_in[1] B=term2_in[0]
Xsll_17/M1_0_9 MUX2 $PINS O=sll_17/ML_int[1][9] S=FE_OFN100_FE_OFN195_h02_0
+ A=term2_in[9] B=term2_in[8]
Xsll_17/M1_0_12 MUX2 $PINS O=sll_17/ML_int[1][12] S=FE_OFN100_FE_OFN195_h02_0
+ A=term2_in[12] B=term2_in[11]
Xsll_17/M1_1_2 MUX2 $PINS O=sll_17/ML_int[2][2] S=shf2[1] A=sll_17/ML_int[1][2]
+ B=sll_17/ML_int[1][0]
Xsll_17/M1_1_3 MUX2 $PINS O=sll_17/ML_int[2][3] S=shf2[1] A=sll_17/ML_int[1][3]
+ B=sll_17/ML_int[1][1]
Xsll_17/M1_1_4 MUX2 $PINS O=sll_17/ML_int[2][4] S=shf2[1] A=sll_17/ML_int[1][4]
+ B=sll_17/ML_int[1][2]
Xsll_17/M1_1_5 MUX2 $PINS O=sll_17/ML_int[2][5] S=shf2[1] A=sll_17/ML_int[1][5]
+ B=sll_17/ML_int[1][3]
Xsll_17/M1_1_6 MUX2 $PINS O=sll_17/ML_int[2][6] S=shf2[1] A=sll_17/ML_int[1][6]
+ B=sll_17/ML_int[1][4]
Xsll_17/M1_1_7 MUX2 $PINS O=sll_17/ML_int[2][7] S=shf2[1] A=sll_17/ML_int[1][7]
+ B=sll_17/ML_int[1][5]
Xsll_17/M1_1_8 MUX2 $PINS O=sll_17/ML_int[2][8] S=shf2[1] A=sll_17/ML_int[1][8]
+ B=sll_17/ML_int[1][6]
Xsll_17/M1_2_4 MUX2 $PINS O=sll_17/ML_int[3][4] S=shf2[2] A=sll_17/ML_int[2][4]
+ B=n114
Xsll_17/M1_2_7 MUX2 $PINS O=sll_17/ML_int[3][7] S=shf2[2] A=sll_17/ML_int[2][7]
+ B=sll_17/ML_int[2][3]
Xsll_17/M1_2_8 MUX2 $PINS O=sll_17/ML_int[3][8] S=shf2[2] A=sll_17/ML_int[2][8]
+ B=sll_17/ML_int[2][4]
Xsll_17/M1_2_9 MUX2 $PINS O=sll_17/ML_int[3][9] S=shf2[2] A=sll_17/ML_int[2][9]
+ B=sll_17/ML_int[2][5]
Xsll_17/M1_2_10 MUX2 $PINS O=sll_17/ML_int[3][10] S=shf2[2]
+ A=sll_17/ML_int[2][10] B=sll_17/ML_int[2][6]
Xsll_17/M1_2_19 MUX2 $PINS O=sll_17/ML_int[3][19] S=shf2[2] A=n4
+ B=sll_17/ML_int[2][15]
Xsll_17/M1_3_8 MUX2 $PINS O=term2_shifted[8] S=shf2[3] A=sll_17/ML_int[3][8]
+ B=sll_17/ML_int[3][0]
Xsll_17/M1_3_9 MUX2 $PINS O=term2_shifted[9] S=shf2[3] A=sll_17/ML_int[3][9]
+ B=sll_17/ML_int[3][1]
Xsll_17/M1_3_10 MUX2 $PINS O=term2_shifted[10] S=shf2[3] A=sll_17/ML_int[3][10]
+ B=sll_17/ML_int[3][2]
Xsll_17/M1_3_11 MUX2 $PINS O=term2_shifted[11] S=shf2[3] A=sll_17/ML_int[3][11]
+ B=sll_17/ML_int[3][3]
Xsll_17/M1_3_12 MUX2 $PINS O=term2_shifted[12] S=shf2[3] A=sll_17/ML_int[3][12]
+ B=sll_17/ML_int[3][4]
Xsll_17/M1_3_13 MUX2 $PINS O=term2_shifted[13] S=shf2[3] A=sll_17/ML_int[3][13]
+ B=sll_17/ML_int[3][5]
Xsll_17/M1_3_14 MUX2 $PINS O=term2_shifted[14] S=shf2[3] A=sll_17/ML_int[3][14]
+ B=sll_17/ML_int[3][6]
Xsll_17/M1_3_15 MUX2 $PINS O=term2_shifted[15] S=shf2[3] A=sll_17/ML_int[3][15]
+ B=sll_17/ML_int[3][7]
Xsll_17/M1_3_22 MUX2 $PINS O=term2_shifted[22] S=shf2[3] A=sll_17/ML_int[3][22]
+ B=sll_17/ML_int[3][14]
Xsll_17/M1_3_23 MUX2 $PINS O=term2_shifted[23] S=shf2[3] A=n4
+ B=sll_17/ML_int[3][15]
Xsll_16/M1_0_6 MUX2 $PINS O=sll_16/ML_int[1][6] S=FE_OFN99_FE_OFN219_h01_0
+ A=term1_in[6] B=term1_in[5]
Xsll_16/M1_0_9 MUX2 $PINS O=sll_16/ML_int[1][9] S=FE_OFN99_FE_OFN219_h01_0
+ A=term1_in[9] B=term1_in[8]
Xsll_16/M1_0_12 MUX2 $PINS O=sll_16/ML_int[1][12] S=FE_OFN99_FE_OFN219_h01_0
+ A=term1_in[12] B=term1_in[11]
Xsll_16/M1_1_2 MUX2 $PINS O=sll_16/ML_int[2][2] S=shf1[1] A=sll_16/ML_int[1][2]
+ B=sll_16/ML_int[1][0]
Xsll_16/M1_1_3 MUX2 $PINS O=sll_16/ML_int[2][3] S=shf1[1] A=sll_16/ML_int[1][3]
+ B=sll_16/ML_int[1][1]
Xsll_16/M1_1_4 MUX2 $PINS O=sll_16/ML_int[2][4] S=shf1[1] A=sll_16/ML_int[1][4]
+ B=sll_16/ML_int[1][2]
Xsll_16/M1_1_5 MUX2 $PINS O=sll_16/ML_int[2][5] S=shf1[1] A=sll_16/ML_int[1][5]
+ B=sll_16/ML_int[1][3]
Xsll_16/M1_1_6 MUX2 $PINS O=sll_16/ML_int[2][6] S=shf1[1] A=sll_16/ML_int[1][6]
+ B=sll_16/ML_int[1][4]
Xsll_16/M1_1_7 MUX2 $PINS O=sll_16/ML_int[2][7] S=shf1[1] A=sll_16/ML_int[1][7]
+ B=sll_16/ML_int[1][5]
Xsll_16/M1_1_8 MUX2 $PINS O=sll_16/ML_int[2][8] S=shf1[1] A=sll_16/ML_int[1][8]
+ B=sll_16/ML_int[1][6]
Xsll_16/M1_2_5 MUX2 $PINS O=sll_16/ML_int[3][5] S=n73 A=sll_16/ML_int[2][5]
+ B=n104
Xsll_16/M1_2_6 MUX2 $PINS O=sll_16/ML_int[3][6] S=n73 A=sll_16/ML_int[2][6]
+ B=sll_16/ML_int[2][2]
Xsll_16/M1_2_7 MUX2 $PINS O=sll_16/ML_int[3][7] S=n73 A=sll_16/ML_int[2][7]
+ B=sll_16/ML_int[2][3]
Xsll_16/M1_2_8 MUX2 $PINS O=sll_16/ML_int[3][8] S=n73 A=sll_16/ML_int[2][8]
+ B=sll_16/ML_int[2][4]
Xsll_16/M1_2_9 MUX2 $PINS O=sll_16/ML_int[3][9] S=n73 A=sll_16/ML_int[2][9]
+ B=sll_16/ML_int[2][5]
Xsll_16/M1_2_10 MUX2 $PINS O=sll_16/ML_int[3][10] S=n73 A=sll_16/ML_int[2][10]
+ B=sll_16/ML_int[2][6]
Xsll_16/M1_2_19 MUX2 $PINS O=sll_16/ML_int[3][19] S=n73 A=n3
+ B=sll_16/ML_int[2][15]
Xsll_16/M1_3_8 MUX2 $PINS O=term1_shifted[8] S=FE_OFN309_h01_3
+ A=sll_16/ML_int[3][8] B=sll_16/ML_int[3][0]
Xsll_16/M1_3_9 MUX2 $PINS O=term1_shifted[9] S=FE_OFN309_h01_3
+ A=sll_16/ML_int[3][9] B=sll_16/ML_int[3][1]
Xsll_16/M1_3_10 MUX2 $PINS O=term1_shifted[10] S=FE_OFN309_h01_3
+ A=sll_16/ML_int[3][10] B=sll_16/ML_int[3][2]
Xsll_16/M1_3_11 MUX2 $PINS O=term1_shifted[11] S=FE_OFN309_h01_3
+ A=sll_16/ML_int[3][11] B=sll_16/ML_int[3][3]
Xsll_16/M1_3_12 MUX2 $PINS O=term1_shifted[12] S=FE_OFN309_h01_3
+ A=sll_16/ML_int[3][12] B=sll_16/ML_int[3][4]
Xsll_16/M1_3_13 MUX2 $PINS O=term1_shifted[13] S=FE_OFN309_h01_3
+ A=sll_16/ML_int[3][13] B=sll_16/ML_int[3][5]
Xsll_16/M1_3_14 MUX2 $PINS O=term1_shifted[14] S=FE_OFN309_h01_3
+ A=sll_16/ML_int[3][14] B=sll_16/ML_int[3][6]
Xsll_16/M1_3_22 MUX2 $PINS O=term1_shifted[22] S=FE_OFN308_h01_3
+ A=sll_16/ML_int[3][22] B=sll_16/ML_int[3][14]
Xsll_16/M1_3_23 MUX2 $PINS O=term1_shifted[23] S=FE_OFN308_h01_3 A=n3
+ B=sll_16/ML_int[3][15]
Xy_out_reg[10] QDFFRBN $PINS Q=y_out[10] D=FE_PHN1225_N245 CK=CTS_10
+ RB=FE_OFN12_i_rst_n
Xy_out_reg[9] QDFFRBN $PINS Q=y_out[9] D=FE_PHN1263_N244 CK=CTS_10
+ RB=FE_OFN12_i_rst_n
Xy_out_reg[8] QDFFRBN $PINS Q=y_out[8] D=FE_PHN1250_N243 CK=CTS_10
+ RB=FE_OFN12_i_rst_n
Xy_out_reg[7] QDFFRBN $PINS Q=y_out[7] D=FE_PHN1258_N242 CK=CTS_10
+ RB=FE_OFN12_i_rst_n
Xy_out_reg[6] QDFFRBN $PINS Q=y_out[6] D=N241 CK=CTS_10 RB=FE_OFN6_i_rst_n
Xy_out_reg[5] QDFFRBN $PINS Q=y_out[5] D=FE_PHN1235_N240 CK=CTS_10
+ RB=FE_OFN10_i_rst_n
Xy_out_reg[4] QDFFRBN $PINS Q=y_out[4] D=FE_PHN1191_N239 CK=CTS_10
+ RB=FE_OFN6_i_rst_n
Xy_out_reg[3] QDFFRBN $PINS Q=y_out[3] D=N238 CK=CTS_10 RB=FE_OFN10_i_rst_n
Xy_out_reg[2] QDFFRBN $PINS Q=y_out[2] D=N237 CK=CTS_10 RB=FE_OFN10_i_rst_n
Xy_out_reg[1] QDFFRBN $PINS Q=y_out[1] D=FE_PHN1255_N236 CK=CTS_10
+ RB=FE_OFN12_i_rst_n
Xy_out_reg[0] QDFFRBN $PINS Q=y_out[0] D=N235 CK=CTS_10 RB=FE_OFN6_i_rst_n
Xacc_reg_reg[26] QDFFRBS $PINS Q=N251 D=next_acc[26] CK=clk_clone2
+ RB=FE_OFN6_i_rst_n
Xacc_reg_reg[25] QDFFRBN $PINS Q=acc_reg[25] D=next_acc[25] CK=clk_clone1
+ RB=FE_OFN6_i_rst_n
Xacc_reg_reg[24] QDFFRBN $PINS Q=acc_reg[24] D=next_acc[24] CK=clk_clone2
+ RB=FE_OFN6_i_rst_n
Xacc_reg_reg[23] QDFFRBN $PINS Q=acc_reg[23] D=next_acc[23] CK=clk_clone2
+ RB=FE_OFN6_i_rst_n
Xacc_reg_reg[22] QDFFRBN $PINS Q=acc_reg[22] D=next_acc[22] CK=clk_clone2
+ RB=FE_OFN6_i_rst_n
Xacc_reg_reg[21] QDFFRBN $PINS Q=acc_reg[21] D=next_acc[21] CK=clk_clone2
+ RB=FE_OFN6_i_rst_n
Xacc_reg_reg[20] QDFFRBN $PINS Q=acc_reg[20] D=next_acc[20] CK=clk_clone2
+ RB=FE_OFN6_i_rst_n
Xacc_reg_reg[19] QDFFRBN $PINS Q=acc_reg[19] D=next_acc[19] CK=clk_clone2
+ RB=FE_OFN6_i_rst_n
Xacc_reg_reg[18] QDFFRBN $PINS Q=acc_reg[18] D=next_acc[18] CK=clk_clone2
+ RB=FE_OFN6_i_rst_n
Xacc_reg_reg[17] QDFFRBN $PINS Q=acc_reg[17] D=next_acc[17] CK=clk_clone2
+ RB=FE_OFN6_i_rst_n
Xacc_reg_reg[16] QDFFRBN $PINS Q=acc_reg[16] D=next_acc[16] CK=clk_clone2
+ RB=FE_OFN10_i_rst_n
Xacc_reg_reg[15] QDFFRBN $PINS Q=acc_reg[15] D=next_acc[15] CK=clk_clone2
+ RB=FE_OFN10_i_rst_n
Xacc_reg_reg[14] QDFFRBN $PINS Q=acc_reg[14] D=next_acc[14] CK=clk_clone2
+ RB=FE_OFN10_i_rst_n
Xacc_reg_reg[13] QDFFRBN $PINS Q=acc_reg[13] D=next_acc[13] CK=clk_clone2
+ RB=FE_OFN10_i_rst_n
Xacc_reg_reg[12] QDFFRBN $PINS Q=acc_reg[12] D=next_acc[12] CK=clk_clone2
+ RB=FE_OFN10_i_rst_n
Xacc_reg_reg[11] QDFFRBN $PINS Q=acc_reg[11] D=next_acc[11] CK=clk_clone2
+ RB=FE_OFN10_i_rst_n
Xacc_reg_reg[10] QDFFRBN $PINS Q=acc_reg[10] D=next_acc[10] CK=clk_clone2
+ RB=FE_OFN10_i_rst_n
Xacc_reg_reg[9] QDFFRBN $PINS Q=acc_reg[9] D=next_acc[9] CK=clk_clone2
+ RB=FE_OFN10_i_rst_n
Xacc_reg_reg[8] QDFFRBN $PINS Q=acc_reg[8] D=next_acc[8] CK=clk_clone2
+ RB=FE_OFN10_i_rst_n
Xacc_reg_reg[7] QDFFRBN $PINS Q=acc_reg[7] D=next_acc[7] CK=clk_clone2
+ RB=FE_OFN10_i_rst_n
Xacc_reg_reg[6] QDFFRBN $PINS Q=acc_reg[6] D=next_acc[6] CK=clk_clone2
+ RB=i_rst_n
Xacc_reg_reg[5] QDFFRBN $PINS Q=acc_reg[5] D=next_acc[5] CK=clk_clone2
+ RB=i_rst_n
Xacc_reg_reg[4] QDFFRBN $PINS Q=acc_reg[4] D=next_acc[4] CK=clk_clone2
+ RB=i_rst_n
Xacc_reg_reg[3] QDFFRBN $PINS Q=acc_reg[3] D=next_acc[3] CK=clk_clone2
+ RB=i_rst_n
Xacc_reg_reg[2] QDFFRBN $PINS Q=acc_reg[2] D=next_acc[2] CK=clk_clone2
+ RB=i_rst_n
Xacc_reg_reg[1] QDFFRBN $PINS Q=acc_reg[1] D=next_acc[1] CK=clk_clone2
+ RB=i_rst_n
Xy_out_reg[16] QDFFRBN $PINS Q=y_out[16] D=FE_PHN1026_N251 CK=CTS_10 RB=i_rst_n
Xy_out_reg[15] QDFFRBN $PINS Q=y_out[15] D=FE_PHN1274_N250 CK=CTS_10
+ RB=FE_OFN12_i_rst_n
Xy_out_reg[14] QDFFRBN $PINS Q=y_out[14] D=FE_PHN1269_N249 CK=CTS_10
+ RB=FE_OFN12_i_rst_n
Xy_out_reg[13] QDFFRBN $PINS Q=y_out[13] D=FE_PHN1265_N248 CK=CTS_10
+ RB=FE_OFN12_i_rst_n
Xy_out_reg[12] QDFFRBN $PINS Q=y_out[12] D=FE_PHN1183_N247 CK=CTS_10 RB=i_rst_n
Xy_out_reg[11] QDFFRBN $PINS Q=y_out[11] D=FE_PHN1261_N246 CK=CTS_10
+ RB=FE_OFN12_i_rst_n
Xacc_reg_reg[0] QDFFRBS $PINS Q=acc_reg[0] D=FE_PHN1313_next_acc_0
+ CK=clk_clone2 RB=i_rst_n
XU6 NR2P $PINS O=term2_shifted[0] I1=n111 I2=n109
XU10 NR2P $PINS O=term3_in[0] I1=sign3[1] I2=x_in[0]
XU13 NR2 $PINS O=term1_in[0] I1=sign1[1] I2=x_in[0]
XU17 NR2 $PINS O=term3_in[1] I1=sign3[1] I2=x_in[1]
XU20 MUX2S $PINS O=sll_17/ML_int[3][6] S=shf2[2] A=sll_17/ML_int[2][6]
+ B=sll_17/ML_int[2][2]
XU21 MUX2 $PINS O=N248 S=FE_OFN4_FE_DBTN15_n64 A=acc_reg[23] B=FE_PHN1026_N251
XU22 NR2 $PINS O=sll_17/ML_int[3][2] I1=shf2[2] I2=n113
XU24 AN2 $PINS O=base_val[25] I1=acc_reg[25] I2=n149
XU25 MUX2 $PINS O=N249 S=FE_OFN4_FE_DBTN15_n64 A=acc_reg[24] B=FE_PHN1026_N251
XU26 NR2 $PINS O=term3_in[2] I1=sign3[1] I2=x_in[2]
XU28 MUX2 $PINS O=N250 S=FE_OFN4_FE_DBTN15_n64 A=acc_reg[25] B=FE_PHN1026_N251
XU30 AN2 $PINS O=sll_17/ML_int[1][0] I1=term2_in[0] I2=n36
XU36 NR2 $PINS O=term1_in[2] I1=sign1[1] I2=x_in[2]
XU39 INV2 $PINS O=n124 I=sll_18/ML_int[2][2]
XU41 ND2P $PINS O=n121 I1=sll_18/ML_int[1][1] I2=FE_DBTN187_h03_1
XU46 NR2P $PINS O=term1_shifted[0] I1=n100 I2=n98
XU47 INV2 $PINS O=n102 I=sll_16/ML_int[2][2]
XU48 NR2P $PINS O=term1_shifted[2] I1=n100 I2=n102
XU49 AO22 $PINS O=N52 A1=N25 A2=FE_OFN289_s01_0 B1=term1_shifted[11]
+ B2=FE_OFN143_s01_0
XU52 NR2P $PINS O=term1_shifted[1] I1=n100 I2=n99
XU53 ND2 $PINS O=n99 I1=sll_16/ML_int[1][1] I2=n69
XU57 MUX2 $PINS O=sll_17/ML_int[1][2] S=FE_OFN100_FE_OFN195_h02_0 A=term2_in[2]
+ B=term2_in[1]
XU58 MUX2 $PINS O=sll_18/ML_int[2][3] S=FE_OFN366_FE_OFN278_h03_1
+ A=sll_18/ML_int[1][3] B=sll_18/ML_int[1][1]
XU62 ND2 $PINS O=n100 I1=shf1[2] I2=shf1[3]
XU63 AO22 $PINS O=N163 A1=N136 A2=FE_OFN138_s03_0 B1=term3_shifted[12]
+ B2=sign3[0]
XU64 AO22 $PINS O=N53 A1=N26 A2=FE_OFN289_s01_0 B1=term1_shifted[12]
+ B2=FE_OFN143_s01_0
XU65 AN2 $PINS O=term3_shifted[4] I1=sll_18/ML_int[3][4] I2=shf3[3]
XU66 AO22P $PINS O=N43 A1=N16 A2=FE_OFN290_s01_0 B1=term1_shifted[2]
+ B2=FE_OFN143_s01_0
XU68 AO22 $PINS O=N59 A1=N32 A2=FE_OFN289_s01_0 B1=term1_shifted[18]
+ B2=FE_OFN143_s01_0
XU70 AN2 $PINS O=sll_18/ML_int[1][0] I1=term3_in[0] I2=n11
XU71 AN2 $PINS O=sll_16/ML_int[1][0] I1=term1_in[0] I2=n66
XU79 NR2P $PINS O=term3_shifted[2] I1=n122 I2=n124
XU81 AO22 $PINS O=N56 A1=N29 A2=FE_OFN289_s01_0 B1=term1_shifted[15]
+ B2=FE_OFN143_s01_0
XU82 AO22 $PINS O=N166 A1=N139 A2=FE_OFN138_s03_0 B1=term3_shifted[15]
+ B2=sign3[0]
XU83 AO22 $PINS O=N54 A1=N27 A2=FE_OFN289_s01_0 B1=term1_shifted[13]
+ B2=FE_OFN143_s01_0
XU84 AO22 $PINS O=N109 A1=N82 A2=sign2[0] B1=term2_shifted[13] B2=FE_OFN342_n
XU85 AO22 $PINS O=N58 A1=N31 A2=FE_OFN289_s01_0 B1=term1_shifted[17]
+ B2=FE_OFN143_s01_0
XU86 ND2P $PINS O=n98 I1=sll_16/ML_int[1][0] I2=n69
XU94 AO22 $PINS O=N62 A1=N35 A2=n84 B1=term1_shifted[21] B2=FE_OFN143_s01_0
XU96 AO22 $PINS O=N42 A1=N15 A2=FE_OFN290_s01_0 B1=term1_shifted[1]
+ B2=FE_OFN143_s01_0
XU97 MUX2S $PINS O=term3_shifted[12] S=FE_OFN312_h03_3 A=sll_18/ML_int[3][12]
+ B=sll_18/ML_int[3][4]
XU100 AO22 $PINS O=N64 A1=N37 A2=n84 B1=term1_shifted[23] B2=FE_OFN143_s01_0
XU102 AO22 $PINS O=N104 A1=N77 A2=sign2[0] B1=term2_shifted[8] B2=n60
XU103 NR2 $PINS O=n3 I1=n138 I2=sign1[1]
XU104 MUX2S $PINS O=n108 S=FE_OFN99_FE_OFN219_h01_0 A=term1_in[26]
+ B=term1_in[15]
XU105 NR2 $PINS O=n4 I1=n138 I2=FE_OFN249_s02_1
XU106 MUX2S $PINS O=n119 S=FE_OFN100_FE_OFN195_h02_0 A=term2_in[26]
+ B=term2_in[15]
XU107 NR2 $PINS O=n5 I1=n138 I2=sign3[1]
XU108 MUX2S $PINS O=n129 S=FE_DBTN187_h03_1 A=n130 B=term3_in[26]
XU109 AO22 $PINS O=N60 A1=N33 A2=n84 B1=term1_shifted[19] B2=FE_OFN143_s01_0
XU111 AN2 $PINS O=term3_shifted[7] I1=sll_18/ML_int[3][7] I2=shf3[3]
XU112 AN2 $PINS O=term2_shifted[7] I1=sll_17/ML_int[3][7] I2=FE_OFN210_h02_3
XU120 AO22 $PINS O=N57 A1=N30 A2=FE_OFN289_s01_0 B1=term1_shifted[16]
+ B2=FE_OFN143_s01_0
XU121 MUX2S $PINS O=sll_18/ML_int[2][9] S=shf3[1] A=sll_18/ML_int[1][9]
+ B=sll_18/ML_int[1][7]
XU122 AO22 $PINS O=N61 A1=N34 A2=n84 B1=term1_shifted[20] B2=FE_OFN143_s01_0
XU123 MUX2 $PINS O=sll_16/ML_int[2][9] S=shf1[1] A=sll_16/ML_int[1][9]
+ B=sll_16/ML_int[1][7]
XU124 MUX2S $PINS O=sll_17/ML_int[2][9] S=shf2[1] A=sll_17/ML_int[1][9]
+ B=sll_17/ML_int[1][7]
XU125 AO22S $PINS O=N63 A1=N36 A2=n84 B1=term1_shifted[22] B2=FE_OFN143_s01_0
XU126 AO22S $PINS O=N65 A1=N38 A2=n84 B1=term1_shifted[24] B2=FE_OFN143_s01_0
XU127 AO22S $PINS O=N66 A1=N39 A2=n84 B1=term1_shifted[25] B2=FE_OFN143_s01_0
XU128 MUX2 $PINS O=sll_18/ML_int[1][8] S=FE_OFN103_FE_OFN218_h03_0
+ A=term3_in[8] B=term3_in[7]
XU129 MUX2 $PINS O=sll_16/ML_int[1][8] S=FE_OFN99_FE_OFN219_h01_0 A=term1_in[8]
+ B=term1_in[7]
XU130 MUX2 $PINS O=sll_17/ML_int[1][8] S=FE_OFN100_FE_OFN195_h02_0
+ A=term2_in[8] B=term2_in[7]
XU139 MUX2S $PINS O=sll_18/ML_int[2][10] S=shf3[1] A=sll_18/ML_int[1][10]
+ B=sll_18/ML_int[1][8]
XU140 MUX2S $PINS O=sll_18/ML_int[1][10] S=FE_OFN103_FE_OFN218_h03_0
+ A=term3_in[10] B=term3_in[9]
XU153 MUX2 $PINS O=sll_16/ML_int[1][10] S=FE_OFN99_FE_OFN219_h01_0
+ A=term1_in[10] B=term1_in[9]
XU156 MUX2S $PINS O=sll_16/ML_int[2][10] S=shf1[1] A=sll_16/ML_int[1][10]
+ B=sll_16/ML_int[1][8]
XU167 MUX2S $PINS O=sll_17/ML_int[2][10] S=shf2[1] A=sll_17/ML_int[1][10]
+ B=sll_17/ML_int[1][8]
XU173 MUX2S $PINS O=sll_17/ML_int[1][10] S=FE_OFN100_FE_OFN195_h02_0
+ A=term2_in[10] B=term2_in[9]
XU182 MUX2S $PINS O=sll_16/ML_int[2][11] S=shf1[1] A=sll_16/ML_int[1][11]
+ B=sll_16/ML_int[1][9]
XU187 MUX2S $PINS O=sll_16/ML_int[3][11] S=n73 A=sll_16/ML_int[2][11]
+ B=sll_16/ML_int[2][7]
XU191 MUX2S $PINS O=sll_18/ML_int[2][11] S=shf3[1] A=sll_18/ML_int[1][11]
+ B=sll_18/ML_int[1][9]
XU192 MUX2S $PINS O=sll_18/ML_int[3][11] S=n19 A=sll_18/ML_int[2][11]
+ B=sll_18/ML_int[2][7]
XU193 MUX2S $PINS O=sll_17/ML_int[2][11] S=shf2[1] A=sll_17/ML_int[1][11]
+ B=sll_17/ML_int[1][9]
XU194 MUX2 $PINS O=sll_17/ML_int[3][11] S=shf2[2] A=sll_17/ML_int[2][11]
+ B=sll_17/ML_int[2][7]
XU195 MUX2 $PINS O=sll_16/ML_int[2][12] S=shf1[1] A=sll_16/ML_int[1][12]
+ B=sll_16/ML_int[1][10]
XU196 MUX2S $PINS O=sll_16/ML_int[3][12] S=n73 A=sll_16/ML_int[2][12]
+ B=sll_16/ML_int[2][8]
XU197 MUX2S $PINS O=sll_18/ML_int[2][12] S=shf3[1] A=sll_18/ML_int[1][12]
+ B=sll_18/ML_int[1][10]
XU198 MUX2S $PINS O=sll_18/ML_int[3][12] S=n19 A=sll_18/ML_int[2][12]
+ B=sll_18/ML_int[2][8]
XU199 MUX2S $PINS O=sll_17/ML_int[2][12] S=shf2[1] A=sll_17/ML_int[1][12]
+ B=sll_17/ML_int[1][10]
XU200 MUX2S $PINS O=sll_17/ML_int[3][12] S=shf2[2] A=sll_17/ML_int[2][12]
+ B=sll_17/ML_int[2][8]
XU201 MUX2 $PINS O=sll_16/ML_int[1][11] S=FE_OFN99_FE_OFN219_h01_0
+ A=term1_in[11] B=term1_in[10]
XU202 MUX2S $PINS O=sll_18/ML_int[1][11] S=FE_OFN103_FE_OFN218_h03_0
+ A=term3_in[11] B=term3_in[10]
XU203 MUX2S $PINS O=sll_17/ML_int[1][11] S=FE_OFN100_FE_OFN195_h02_0
+ A=term2_in[11] B=term2_in[10]
XU204 MUX2S $PINS O=sll_16/ML_int[3][13] S=n73 A=sll_16/ML_int[2][13]
+ B=sll_16/ML_int[2][9]
XU205 MUX2S $PINS O=sll_16/ML_int[1][13] S=FE_OFN99_FE_OFN219_h01_0
+ A=term1_in[13] B=term1_in[12]
XU206 MUX2 $PINS O=sll_16/ML_int[2][13] S=shf1[1] A=sll_16/ML_int[1][13]
+ B=sll_16/ML_int[1][11]
XU207 MUX2S $PINS O=sll_18/ML_int[3][13] S=n19 A=sll_18/ML_int[2][13]
+ B=sll_18/ML_int[2][9]
XU208 MUX2S $PINS O=sll_18/ML_int[2][13] S=shf3[1] A=sll_18/ML_int[1][13]
+ B=sll_18/ML_int[1][11]
XU209 MUX2S $PINS O=sll_18/ML_int[1][13] S=FE_OFN103_FE_OFN218_h03_0
+ A=term3_in[13] B=term3_in[12]
XU210 MUX2S $PINS O=sll_17/ML_int[3][13] S=shf2[2] A=sll_17/ML_int[2][13]
+ B=sll_17/ML_int[2][9]
XU211 MUX2S $PINS O=sll_17/ML_int[2][13] S=shf2[1] A=sll_17/ML_int[1][13]
+ B=sll_17/ML_int[1][11]
XU212 MUX2S $PINS O=sll_17/ML_int[1][13] S=FE_OFN100_FE_OFN195_h02_0
+ A=term2_in[13] B=term2_in[12]
XU213 MUX2S $PINS O=sll_16/ML_int[3][14] S=n73 A=sll_16/ML_int[2][14]
+ B=sll_16/ML_int[2][10]
XU214 MUX2S $PINS O=sll_16/ML_int[2][14] S=shf1[1] A=sll_16/ML_int[1][14]
+ B=sll_16/ML_int[1][12]
XU215 MUX2S $PINS O=sll_16/ML_int[1][14] S=FE_OFN99_FE_OFN219_h01_0
+ A=term1_in[14] B=term1_in[13]
XU216 MUX2S $PINS O=sll_18/ML_int[3][14] S=n19 A=sll_18/ML_int[2][14]
+ B=sll_18/ML_int[2][10]
XU217 MUX2S $PINS O=sll_18/ML_int[2][14] S=shf3[1] A=sll_18/ML_int[1][14]
+ B=sll_18/ML_int[1][12]
XU218 MUX2S $PINS O=sll_18/ML_int[1][14] S=FE_OFN103_FE_OFN218_h03_0
+ A=term3_in[14] B=term3_in[13]
XU219 MUX2S $PINS O=sll_17/ML_int[3][14] S=shf2[2] A=sll_17/ML_int[2][14]
+ B=sll_17/ML_int[2][10]
XU220 MUX2S $PINS O=sll_17/ML_int[2][14] S=shf2[1] A=sll_17/ML_int[1][14]
+ B=sll_17/ML_int[1][12]
XU221 MUX2S $PINS O=sll_17/ML_int[1][14] S=FE_OFN100_FE_OFN195_h02_0
+ A=term2_in[14] B=term2_in[13]
XU222 MUX2S $PINS O=term1_shifted[15] S=FE_OFN309_h01_3 A=sll_16/ML_int[3][15]
+ B=sll_16/ML_int[3][7]
XU223 MUX2S $PINS O=sll_16/ML_int[3][15] S=n73 A=sll_16/ML_int[2][15]
+ B=sll_16/ML_int[2][11]
XU224 MUX2S $PINS O=sll_16/ML_int[2][15] S=shf1[1] A=sll_16/ML_int[1][15]
+ B=sll_16/ML_int[1][13]
XU225 MUX2S $PINS O=sll_16/ML_int[1][15] S=FE_OFN99_FE_OFN219_h01_0
+ A=term1_in[15] B=term1_in[14]
XU226 MUX2S $PINS O=sll_18/ML_int[3][15] S=n19 A=sll_18/ML_int[2][15]
+ B=sll_18/ML_int[2][11]
XU227 MUX2S $PINS O=sll_18/ML_int[2][15] S=shf3[1] A=sll_18/ML_int[1][15]
+ B=sll_18/ML_int[1][13]
XU228 MUX2S $PINS O=sll_18/ML_int[1][15] S=FE_OFN103_FE_OFN218_h03_0
+ A=term3_in[15] B=term3_in[14]
XU229 MUX2S $PINS O=sll_17/ML_int[3][15] S=shf2[2] A=sll_17/ML_int[2][15]
+ B=sll_17/ML_int[2][11]
XU230 MUX2S $PINS O=sll_17/ML_int[2][15] S=shf2[1] A=sll_17/ML_int[1][15]
+ B=sll_17/ML_int[1][13]
XU231 MUX2S $PINS O=term1_shifted[16] S=FE_OFN309_h01_3 A=sll_16/ML_int[3][16]
+ B=sll_16/ML_int[3][8]
XU232 MUX2S $PINS O=sll_17/ML_int[1][15] S=FE_OFN100_FE_OFN195_h02_0
+ A=term2_in[15] B=term2_in[14]
XU233 MUX2S $PINS O=term3_shifted[16] S=FE_OFN312_h03_3 A=sll_18/ML_int[3][16]
+ B=sll_18/ML_int[3][8]
XU234 MUX2S $PINS O=n127 S=shf3[1] A=n130 B=sll_18/ML_int[1][14]
XU235 MUX2S $PINS O=term2_shifted[16] S=shf2[3] A=sll_17/ML_int[3][16]
+ B=sll_17/ML_int[3][8]
XU236 MUX2S $PINS O=term1_shifted[17] S=FE_OFN308_h01_3 A=sll_16/ML_int[3][17]
+ B=sll_16/ML_int[3][9]
XU237 MUX2S $PINS O=term3_shifted[17] S=FE_OFN312_h03_3 A=sll_18/ML_int[3][17]
+ B=sll_18/ML_int[3][9]
XU238 MUX2S $PINS O=term2_shifted[17] S=shf2[3] A=sll_17/ML_int[3][17]
+ B=sll_17/ML_int[3][9]
XU239 MUX2S $PINS O=term1_shifted[18] S=FE_OFN308_h01_3 A=sll_16/ML_int[3][18]
+ B=sll_16/ML_int[3][10]
XU240 MUX2S $PINS O=term3_shifted[18] S=FE_OFN311_h03_3 A=sll_18/ML_int[3][18]
+ B=sll_18/ML_int[3][10]
XU241 MUX2S $PINS O=term2_shifted[18] S=shf2[3] A=sll_17/ML_int[3][18]
+ B=sll_17/ML_int[3][10]
XU245 MUX2S $PINS O=sll_16/ML_int[3][16] S=n73 A=n105 B=sll_16/ML_int[2][12]
XU246 MUX2S $PINS O=n130 S=FE_OFN103_FE_OFN218_h03_0 A=term3_in[26]
+ B=term3_in[15]
XU247 MUX2S $PINS O=sll_18/ML_int[3][16] S=n19 A=n127 B=sll_18/ML_int[2][12]
XU248 MUX2S $PINS O=sll_17/ML_int[3][16] S=shf2[2] A=n116
+ B=sll_17/ML_int[2][12]
XU249 MUX2S $PINS O=n106 S=shf1[1] A=n3 B=sll_16/ML_int[1][15]
XU250 MUX2S $PINS O=sll_16/ML_int[3][17] S=n73 A=n106 B=sll_16/ML_int[2][13]
XU252 MUX2S $PINS O=n128 S=shf3[1] A=n5 B=sll_18/ML_int[1][15]
XU253 MUX2S $PINS O=sll_18/ML_int[3][17] S=n19 A=n128 B=sll_18/ML_int[2][13]
XU254 MUX2S $PINS O=n117 S=shf2[1] A=n4 B=sll_17/ML_int[1][15]
XU255 MUX2S $PINS O=sll_17/ML_int[3][17] S=shf2[2] A=n117
+ B=sll_17/ML_int[2][13]
XU256 MUX2S $PINS O=n107 S=n69 A=n108 B=term1_in[26]
XU257 MUX2S $PINS O=sll_16/ML_int[3][18] S=n73 A=n107 B=sll_16/ML_int[2][14]
XU258 MUX2S $PINS O=sll_18/ML_int[3][18] S=n19 A=n129 B=sll_18/ML_int[2][14]
XU259 MUX2S $PINS O=n118 S=FE_DBTN189_h02_1 A=n119 B=term2_in[26]
XU260 MUX2S $PINS O=sll_17/ML_int[3][18] S=shf2[2] A=n118
+ B=sll_17/ML_int[2][14]
XU261 MUX2S $PINS O=term1_shifted[19] S=FE_OFN308_h01_3 A=sll_16/ML_int[3][19]
+ B=sll_16/ML_int[3][11]
XU262 MUX2S $PINS O=term3_shifted[19] S=FE_OFN311_h03_3 A=sll_18/ML_int[3][19]
+ B=sll_18/ML_int[3][11]
XU263 MUX2S $PINS O=term2_shifted[19] S=shf2[3] A=sll_17/ML_int[3][19]
+ B=sll_17/ML_int[3][11]
XU264 MUX2S $PINS O=term1_shifted[20] S=FE_OFN308_h01_3 A=sll_16/ML_int[3][20]
+ B=sll_16/ML_int[3][12]
XU265 MUX2S $PINS O=sll_16/ML_int[3][20] S=n73 A=term1_in[26] B=n105
XU266 MUX2S $PINS O=term3_shifted[20] S=FE_OFN311_h03_3 A=sll_18/ML_int[3][20]
+ B=sll_18/ML_int[3][12]
XU267 MUX2S $PINS O=sll_18/ML_int[3][20] S=n19 A=term3_in[26] B=n127
XU268 MUX2S $PINS O=term2_shifted[20] S=shf2[3] A=sll_17/ML_int[3][20]
+ B=sll_17/ML_int[3][12]
XU269 MUX2S $PINS O=sll_17/ML_int[3][20] S=shf2[2] A=term2_in[26] B=n116
XU271 MUX2S $PINS O=term1_shifted[21] S=FE_OFN308_h01_3 A=sll_16/ML_int[3][21]
+ B=sll_16/ML_int[3][13]
XU272 MUX2S $PINS O=term2_shifted[21] S=shf2[3] A=sll_17/ML_int[3][21]
+ B=sll_17/ML_int[3][13]
XU273 MUX2S $PINS O=term3_shifted[21] S=FE_OFN311_h03_3 A=sll_18/ML_int[3][21]
+ B=sll_18/ML_int[3][13]
XU275 AN2S $PINS O=base_val[6] I1=acc_reg[6] I2=n149
XU276 AO22S $PINS O=N118 A1=N91 A2=FE_OFN340_n B1=term2_shifted[22]
+ B2=FE_OFN341_n
XU277 ND2S $PINS O=n150 I1=FE_PHN1026_N251 I2=FE_OFN4_FE_DBTN15_n64
XU278 MUX2S $PINS O=FE_PHN1284_N235 S=FE_OFN4_FE_DBTN15_n64 A=acc_reg[10]
+ B=acc_reg[14]
XU279 MUX2S $PINS O=N244 S=FE_OFN4_FE_DBTN15_n64 A=acc_reg[19] B=acc_reg[23]
XU293 NR2 $PINS O=term1_in[4] I1=sign1[1] I2=x_in[4]
XU294 INV1S $PINS O=n103 I=n98
XU295 INV1S $PINS O=n114 I=n109
XU296 NR2 $PINS O=term3_in[4] I1=sign3[1] I2=x_in[4]
XU297 INV1S $PINS O=n125 I=n120
XU298 NR2 $PINS O=term1_in[3] I1=sign1[1] I2=x_in[3]
XU299 NR2 $PINS O=term2_in[3] I1=sign2[1] I2=x_in[3]
XU300 NR2 $PINS O=term3_in[3] I1=sign3[1] I2=x_in[3]
XU301 NR2 $PINS O=term1_in[5] I1=sign1[1] I2=x_in[5]
XU302 NR2 $PINS O=term2_in[5] I1=FE_OFN249_s02_1 I2=x_in[5]
XU303 INV1S $PINS O=n115 I=n110
XU304 NR2 $PINS O=term3_in[5] I1=sign3[1] I2=x_in[5]
XU305 NR2 $PINS O=term1_in[6] I1=sign1[1] I2=x_in[6]
XU306 NR2 $PINS O=term2_in[6] I1=FE_OFN249_s02_1 I2=x_in[6]
XU307 NR2 $PINS O=term3_in[6] I1=sign3[1] I2=x_in[6]
XU308 NR2 $PINS O=term1_in[7] I1=sign1[1] I2=x_in[7]
XU309 NR2 $PINS O=term2_in[7] I1=FE_OFN249_s02_1 I2=x_in[7]
XU310 NR2 $PINS O=term3_in[7] I1=sign3[1] I2=x_in[7]
XU312 NR2 $PINS O=term1_in[8] I1=sign1[1] I2=x_in[8]
XU313 NR2 $PINS O=term2_in[8] I1=FE_OFN249_s02_1 I2=x_in[8]
XU314 NR2 $PINS O=term3_in[8] I1=sign3[1] I2=FE_OCPN727_FE_OFN131_mac_in_imag_8
XU318 NR2 $PINS O=term1_in[9] I1=sign1[1] I2=x_in[9]
XU319 NR2 $PINS O=term2_in[9] I1=FE_OFN249_s02_1 I2=x_in[9]
XU320 NR2 $PINS O=term3_in[9] I1=sign3[1] I2=x_in[9]
XU321 NR2 $PINS O=term1_in[10] I1=sign1[1] I2=x_in[10]
XU322 NR2 $PINS O=term2_in[10] I1=FE_OFN249_s02_1 I2=x_in[10]
XU323 NR2 $PINS O=term3_in[10] I1=sign3[1] I2=x_in[10]
XU324 NR2 $PINS O=term1_in[11] I1=sign1[1] I2=x_in[11]
XU325 NR2 $PINS O=term2_in[11] I1=FE_OFN249_s02_1 I2=x_in[11]
XU326 NR2 $PINS O=term3_in[11] I1=sign3[1] I2=x_in[11]
XU327 NR2 $PINS O=term1_in[12] I1=sign1[1] I2=x_in[12]
XU330 NR2 $PINS O=term2_in[12] I1=FE_OFN249_s02_1 I2=x_in[12]
XU331 NR2 $PINS O=term3_in[12] I1=sign3[1] I2=x_in[12]
XU336 NR2 $PINS O=term1_in[13] I1=sign1[1] I2=x_in[13]
XU337 NR2 $PINS O=term2_in[13] I1=FE_OFN249_s02_1 I2=x_in[13]
XU338 NR2 $PINS O=term3_in[13] I1=sign3[1] I2=x_in[13]
XU339 NR2 $PINS O=term1_in[14] I1=sign1[1] I2=x_in[14]
XU341 NR2 $PINS O=term2_in[14] I1=FE_OFN249_s02_1 I2=x_in[14]
XU342 NR2 $PINS O=term3_in[14] I1=sign3[1] I2=x_in[14]
XU347 NR2 $PINS O=term1_in[15] I1=sign1[1] I2=n137
XU348 NR2 $PINS O=term2_in[15] I1=FE_OFN249_s02_1 I2=n137
XU349 NR2 $PINS O=term3_in[15] I1=sign3[1] I2=n137
XU388 INV1S $PINS O=n137 I=x_in[15]
XU389 INV1S $PINS O=n138 I=x_in[16]
XU390 NR2 $PINS O=term1_in[26] I1=n138 I2=sign1[1]
XU392 NR2 $PINS O=term2_in[26] I1=n138 I2=FE_OFN249_s02_1
XU394 NR2 $PINS O=term3_in[26] I1=n138 I2=sign3[1]
XU395 AN2 $PINS O=base_val[1] I1=acc_reg[1] I2=n149
XU396 AN2 $PINS O=base_val[2] I1=acc_reg[2] I2=n149
XU397 MOAI1S $PINS O=base_val[9] A1=FE_OFN4_FE_DBTN15_n64 A2=n149 B1=acc_reg[9]
+ B2=n149
XU398 AN2 $PINS O=base_val[10] I1=acc_reg[10] I2=n149
XU399 AN2 $PINS O=base_val[11] I1=acc_reg[11] I2=n149
XU400 AN2 $PINS O=base_val[12] I1=acc_reg[12] I2=n149
XU401 AN2 $PINS O=base_val[14] I1=acc_reg[14] I2=n149
XU402 AN2 $PINS O=base_val[15] I1=acc_reg[15] I2=n149
XU403 AN2 $PINS O=base_val[16] I1=acc_reg[16] I2=n149
XU404 AN2 $PINS O=base_val[17] I1=acc_reg[17] I2=n149
XU405 AN2 $PINS O=base_val[18] I1=acc_reg[18] I2=n149
XU406 AN2 $PINS O=base_val[19] I1=acc_reg[19] I2=n149
XU407 AN2 $PINS O=base_val[20] I1=acc_reg[20] I2=n149
XU408 AN2 $PINS O=base_val[21] I1=acc_reg[21] I2=n149
XU409 AN2 $PINS O=base_val[23] I1=acc_reg[23] I2=n149
XU410 AN2 $PINS O=base_val[24] I1=acc_reg[24] I2=n149
XU411 AN2 $PINS O=base_val[8] I1=acc_reg[8] I2=n149
XU412 AN2 $PINS O=base_val[7] I1=acc_reg[7] I2=n149
XU413 AN2 $PINS O=base_val[5] I1=acc_reg[5] I2=n149
XU414 AN2 $PINS O=base_val[4] I1=acc_reg[4] I2=n149
XU415 AN2 $PINS O=base_val[3] I1=acc_reg[3] I2=n149
XU418 AN2 $PINS O=base_val[0] I1=acc_reg[0] I2=n149
XU423 AN2 $PINS O=N234 I1=en I2=calc_done
XU424 OAI12HS $PINS O=N247 A1=n150 B1=FE_OFN4_FE_DBTN15_n64 B2=n131
XU425 INV1S $PINS O=n131 I=acc_reg[22]
XU426 AN2 $PINS O=base_val[26] I1=FE_PHN1026_N251 I2=n149
XU428 INV1S $PINS O=n104 I=n99
XU429 AN2 $PINS O=base_val[22] I1=acc_reg[22] I2=n149
XU430 INV1S $PINS O=n126 I=n121
XU431 AO22 $PINS O=N97 A1=N70 A2=sign2[0] B1=term2_shifted[1] B2=n60
XU432 NR2 $PINS O=sll_16/ML_int[3][0] I1=n73 I2=n98
XU433 NR2 $PINS O=sll_16/ML_int[3][1] I1=n73 I2=n99
XU434 NR2 $PINS O=sll_16/ML_int[3][2] I1=n73 I2=n102
XU435 NR2 $PINS O=sll_16/ML_int[3][3] I1=n73 I2=n101
XU436 NR2P $PINS O=term1_shifted[3] I1=n100 I2=n101
XU437 AN2T $PINS O=term1_shifted[4] I1=sll_16/ML_int[3][4] I2=shf1[3]
XU438 AN2 $PINS O=term1_shifted[5] I1=sll_16/ML_int[3][5] I2=shf1[3]
XU439 AN2 $PINS O=term1_shifted[6] I1=sll_16/ML_int[3][6] I2=shf1[3]
XU440 AN2 $PINS O=term1_shifted[7] I1=sll_16/ML_int[3][7] I2=shf1[3]
XU441 MUX2 $PINS O=sll_16/ML_int[3][21] S=n73 A=n3 B=n106
XU442 MUX2 $PINS O=sll_16/ML_int[3][22] S=n73 A=term1_in[26] B=n107
XU443 MUX2 $PINS O=term1_shifted[24] S=FE_OFN308_h01_3 A=term1_in[26]
+ B=sll_16/ML_int[3][16]
XU444 MUX2 $PINS O=n105 S=shf1[1] A=n108 B=sll_16/ML_int[1][14]
XU445 MUX2 $PINS O=term1_shifted[25] S=FE_OFN308_h01_3 A=n3
+ B=sll_16/ML_int[3][17]
XU446 MUX2 $PINS O=term1_shifted[26] S=FE_OFN308_h01_3 A=term1_in[26]
+ B=sll_16/ML_int[3][18]
XU447 NR2 $PINS O=sll_17/ML_int[3][0] I1=shf2[2] I2=n109
XU448 NR2 $PINS O=sll_17/ML_int[3][1] I1=shf2[2] I2=n110
XU449 NR2 $PINS O=sll_17/ML_int[3][3] I1=shf2[2] I2=n112
XU450 AN2 $PINS O=term2_shifted[5] I1=sll_17/ML_int[3][5] I2=FE_OFN210_h02_3
XU451 AN2 $PINS O=term2_shifted[6] I1=sll_17/ML_int[3][6] I2=FE_OFN210_h02_3
XU452 MUX2 $PINS O=sll_17/ML_int[3][21] S=shf2[2] A=n4 B=n117
XU453 MUX2 $PINS O=sll_17/ML_int[3][22] S=shf2[2] A=term2_in[26] B=n118
XU454 MUX2 $PINS O=term2_shifted[24] S=shf2[3] A=term2_in[26]
+ B=sll_17/ML_int[3][16]
XU455 MUX2 $PINS O=n116 S=shf2[1] A=n119 B=sll_17/ML_int[1][14]
XU456 MUX2 $PINS O=term2_shifted[25] S=shf2[3] A=n4 B=sll_17/ML_int[3][17]
XU457 MUX2 $PINS O=term2_shifted[26] S=shf2[3] A=term2_in[26]
+ B=sll_17/ML_int[3][18]
XU458 NR2 $PINS O=sll_18/ML_int[3][0] I1=n19 I2=n120
XU459 NR2 $PINS O=sll_18/ML_int[3][1] I1=n19 I2=n121
XU460 NR2 $PINS O=sll_18/ML_int[3][2] I1=n19 I2=n124
XU461 NR2 $PINS O=sll_18/ML_int[3][3] I1=n19 I2=n123
XU462 ND2 $PINS O=n122 I1=shf3[2] I2=shf3[3]
XU463 NR2 $PINS O=term3_shifted[3] I1=n122 I2=n123
XU464 AN2 $PINS O=term3_shifted[5] I1=sll_18/ML_int[3][5] I2=shf3[3]
XU465 AN2 $PINS O=term3_shifted[6] I1=sll_18/ML_int[3][6] I2=shf3[3]
XU466 MUX2 $PINS O=sll_18/ML_int[3][21] S=n19 A=n5 B=n128
XU467 MUX2 $PINS O=sll_18/ML_int[3][22] S=n19 A=term3_in[26] B=n129
XU468 MUX2 $PINS O=term3_shifted[24] S=FE_OFN311_h03_3 A=term3_in[26]
+ B=sll_18/ML_int[3][16]
XU469 MUX2 $PINS O=term3_shifted[25] S=FE_OFN311_h03_3 A=n5
+ B=sll_18/ML_int[3][17]
XU470 MUX2 $PINS O=term3_shifted[26] S=FE_OFN311_h03_3 A=term3_in[26]
+ B=sll_18/ML_int[3][18]
XU471 MUX2 $PINS O=N245 S=FE_OFN4_FE_DBTN15_n64 A=acc_reg[20] B=acc_reg[24]
XU472 MUX2 $PINS O=N246 S=FE_OFN4_FE_DBTN15_n64 A=acc_reg[21] B=acc_reg[25]
XU473 MUX2 $PINS O=N236 S=FE_OFN4_FE_DBTN15_n64 A=acc_reg[11] B=acc_reg[15]
XU474 MUX2 $PINS O=FE_PHN1234_N237 S=FE_OFN4_FE_DBTN15_n64 A=acc_reg[12]
+ B=FE_PHN862_acc_reg_16
XU475 MUX2 $PINS O=FE_PHN1209_N238 S=FE_OFN4_FE_DBTN15_n64 A=acc_reg[13]
+ B=acc_reg[17]
XU476 MUX2 $PINS O=N239 S=FE_OFN4_FE_DBTN15_n64 A=acc_reg[14] B=acc_reg[18]
XU477 MUX2 $PINS O=N240 S=FE_OFN4_FE_DBTN15_n64 A=acc_reg[15] B=acc_reg[19]
XU478 MUX2 $PINS O=FE_PHN1195_N241 S=FE_OFN4_FE_DBTN15_n64
+ A=FE_PHN862_acc_reg_16 B=acc_reg[20]
XU479 MUX2 $PINS O=N242 S=FE_OFN4_FE_DBTN15_n64 A=acc_reg[17] B=acc_reg[21]
XU480 MUX2 $PINS O=N243 S=FE_OFN4_FE_DBTN15_n64 A=acc_reg[18] B=acc_reg[22]
Xclk_gate_y_out_reg SNPS_CLOCK_GATE_HIGH_PE_Shift_Add_6 $PINS EN=N234
+ ENCLK=CTS_12 CLK=clk
Xsub_28_3 PE_Shift_Add_6_DW01_sub_0_DW01_sub_18 $PINS A[26]=net44447
+ A[25]=net44447 A[24]=net44447 A[23]=net44447 A[22]=net44447 A[21]=net44447
+ A[20]=net44447 A[19]=net44447 A[18]=net44447 A[17]=net44447 A[16]=net44447
+ A[15]=net44447 A[14]=net44447 A[13]=net44447 A[12]=net44447 A[11]=net44447
+ A[10]=net44447 A[9]=net44447 A[8]=net44447 A[7]=net44447 A[6]=net44447
+ A[5]=net44447 A[4]=net44447 A[3]=net44447 A[2]=net44447 A[1]=net44447
+ A[0]=net44447 B[26]=term3_shifted[26] B[25]=term3_shifted[25]
+ B[24]=term3_shifted[24] B[23]=term3_shifted[23] B[22]=term3_shifted[22]
+ B[21]=term3_shifted[21] B[20]=term3_shifted[20] B[19]=term3_shifted[19]
+ B[18]=term3_shifted[18] B[17]=term3_shifted[17] B[16]=term3_shifted[16]
+ B[15]=term3_shifted[15] B[14]=term3_shifted[14] B[13]=term3_shifted[13]
+ B[12]=term3_shifted[12] B[11]=term3_shifted[11] B[10]=term3_shifted[10]
+ B[9]=term3_shifted[9] B[8]=term3_shifted[8] B[7]=term3_shifted[7]
+ B[6]=term3_shifted[6] B[5]=term3_shifted[5] B[4]=term3_shifted[4]
+ B[3]=term3_shifted[3] B[2]=term3_shifted[2] B[1]=term3_shifted[1]
+ B[0]=term3_shifted[0] CI=net44447 DIFF[26]=N150 DIFF[25]=N149 DIFF[24]=N148
+ DIFF[23]=N147 DIFF[22]=N146 DIFF[21]=N145 DIFF[20]=N144 DIFF[19]=N143
+ DIFF[18]=N142 DIFF[17]=N141 DIFF[16]=N140 DIFF[15]=N139 DIFF[14]=N138
+ DIFF[13]=N137 DIFF[12]=N136 DIFF[11]=N135 DIFF[10]=N134 DIFF[9]=N133
+ DIFF[8]=N132 DIFF[7]=N131 DIFF[6]=N130 DIFF[5]=N129 DIFF[4]=N128 DIFF[3]=N127
+ DIFF[2]=N126 DIFF[1]=N125 DIFF[0]=N124
Xsub_28_2 PE_Shift_Add_6_DW01_sub_1_DW01_sub_19 $PINS A[26]=net44447
+ A[25]=net44447 A[24]=net44447 A[23]=net44447 A[22]=net44447 A[21]=net44447
+ A[20]=net44447 A[19]=net44447 A[18]=net44447 A[17]=net44447 A[16]=net44447
+ A[15]=net44447 A[14]=net44447 A[13]=net44447 A[12]=net44447 A[11]=net44447
+ A[10]=net44447 A[9]=net44447 A[8]=net44447 A[7]=net44447 A[6]=net44447
+ A[5]=net44447 A[4]=net44447 A[3]=net44447 A[2]=net44447 A[1]=net44447
+ A[0]=net44447 B[26]=term2_shifted[26] B[25]=term2_shifted[25]
+ B[24]=term2_shifted[24] B[23]=term2_shifted[23] B[22]=term2_shifted[22]
+ B[21]=term2_shifted[21] B[20]=term2_shifted[20] B[19]=term2_shifted[19]
+ B[18]=term2_shifted[18] B[17]=term2_shifted[17] B[16]=term2_shifted[16]
+ B[15]=term2_shifted[15] B[14]=term2_shifted[14] B[13]=term2_shifted[13]
+ B[12]=term2_shifted[12] B[11]=term2_shifted[11] B[10]=term2_shifted[10]
+ B[9]=term2_shifted[9] B[8]=term2_shifted[8] B[7]=term2_shifted[7]
+ B[6]=term2_shifted[6] B[5]=term2_shifted[5] B[4]=term2_shifted[4]
+ B[3]=term2_shifted[3] B[2]=term2_shifted[2] B[1]=term2_shifted[1]
+ B[0]=term2_shifted[0] CI=net44447 DIFF[26]=N95 DIFF[25]=N94 DIFF[24]=N93
+ DIFF[23]=N92 DIFF[22]=N91 DIFF[21]=N90 DIFF[20]=N89 DIFF[19]=N88 DIFF[18]=N87
+ DIFF[17]=N86 DIFF[16]=N85 DIFF[15]=N84 DIFF[14]=N83 DIFF[13]=N82 DIFF[12]=N81
+ DIFF[11]=N80 DIFF[10]=N79 DIFF[9]=N78 DIFF[8]=N77 DIFF[7]=N76 DIFF[6]=N75
+ DIFF[5]=N74 DIFF[4]=N73 DIFF[3]=N72 DIFF[2]=N71 DIFF[1]=N70 DIFF[0]=N69
Xsub_28 PE_Shift_Add_6_DW01_sub_2_DW01_sub_20 $PINS A[26]=net44447
+ A[25]=net44447 A[24]=net44447 A[23]=net44447 A[22]=net44447 A[21]=net44447
+ A[20]=net44447 A[19]=net44447 A[18]=net44447 A[17]=net44447 A[16]=net44447
+ A[15]=net44447 A[14]=net44447 A[13]=net44447 A[12]=net44447 A[11]=net44447
+ A[10]=net44447 A[9]=net44447 A[8]=net44447 A[7]=net44447 A[6]=net44447
+ A[5]=net44447 A[4]=net44447 A[3]=net44447 A[2]=net44447 A[1]=net44447
+ A[0]=net44447 B[26]=term1_shifted[26] B[25]=term1_shifted[25]
+ B[24]=term1_shifted[24] B[23]=term1_shifted[23] B[22]=term1_shifted[22]
+ B[21]=term1_shifted[21] B[20]=term1_shifted[20] B[19]=term1_shifted[19]
+ B[18]=term1_shifted[18] B[17]=term1_shifted[17] B[16]=term1_shifted[16]
+ B[15]=term1_shifted[15] B[14]=term1_shifted[14] B[13]=term1_shifted[13]
+ B[12]=term1_shifted[12] B[11]=term1_shifted[11] B[10]=term1_shifted[10]
+ B[9]=term1_shifted[9] B[8]=term1_shifted[8] B[7]=term1_shifted[7]
+ B[6]=term1_shifted[6] B[5]=term1_shifted[5] B[4]=term1_shifted[4]
+ B[3]=term1_shifted[3] B[2]=term1_shifted[2] B[1]=term1_shifted[1]
+ B[0]=term1_shifted[0] CI=net44447 DIFF[26]=N40 DIFF[25]=N39 DIFF[24]=N38
+ DIFF[23]=N37 DIFF[22]=N36 DIFF[21]=N35 DIFF[20]=N34 DIFF[19]=N33 DIFF[18]=N32
+ DIFF[17]=N31 DIFF[16]=N30 DIFF[15]=N29 DIFF[14]=N28 DIFF[13]=N27 DIFF[12]=N26
+ DIFF[11]=N25 DIFF[10]=N24 DIFF[9]=N23 DIFF[8]=N22 DIFF[7]=N21 DIFF[6]=N20
+ DIFF[5]=N19 DIFF[4]=N18 DIFF[3]=N17 DIFF[2]=N16 DIFF[1]=N15 DIFF[0]=N14
Xadd_1_root_add_0_root_add_28_3 PE_Shift_Add_6_DW01_add_2_DW01_add_37 $PINS
+ A[26]=N67 A[25]=N66 A[24]=N65 A[23]=N64 A[22]=N63 A[21]=N62 A[20]=N61 A[19]=N60
+ A[18]=N59 A[17]=N58 A[16]=N57 A[15]=N56 A[14]=N55 A[13]=N54 A[12]=N53 A[11]=N52
+ A[10]=N51 A[9]=N50 A[8]=N49 A[7]=N48 A[6]=N47 A[5]=N46 A[4]=N45 A[3]=N44
+ A[2]=N43 A[1]=N42 A[0]=N41 B[26]=N177 B[25]=N176 B[24]=N175 B[23]=N174
+ B[22]=N173 B[21]=N172 B[20]=N171 B[19]=N170 B[18]=N169 B[17]=N168 B[16]=N167
+ B[15]=N166 B[14]=N165 B[13]=N164 B[12]=N163 B[11]=N162 B[10]=N161 B[9]=N160
+ B[8]=N159 B[7]=N158 B[6]=N157 B[5]=N156 B[4]=N155 B[3]=N154 B[2]=N153 B[1]=N152
+ B[0]=N151 CI=net44447 SUM[26]=N204 SUM[25]=N203 SUM[24]=N202 SUM[23]=N201
+ SUM[22]=N200 SUM[21]=N199 SUM[20]=N198 SUM[19]=N197 SUM[18]=N196 SUM[17]=N195
+ SUM[16]=N194 SUM[15]=N193 SUM[14]=N192 SUM[13]=N191 SUM[12]=N190 SUM[11]=N189
+ SUM[10]=N188 SUM[9]=N187 SUM[8]=N186 SUM[7]=N185 SUM[6]=N184 SUM[5]=N183
+ SUM[4]=N182 SUM[3]=N181 SUM[2]=N180 SUM[1]=N179 SUM[0]=N178
Xadd_2_root_add_0_root_add_28_3 PE_Shift_Add_6_DW01_add_1_DW01_add_36 $PINS
+ A[26]=base_val[26] A[25]=base_val[25] A[24]=base_val[24] A[23]=base_val[23]
+ A[22]=base_val[22] A[21]=base_val[21] A[20]=base_val[20] A[19]=base_val[19]
+ A[18]=base_val[18] A[17]=base_val[17] A[16]=base_val[16] A[15]=base_val[15]
+ A[14]=base_val[14] A[13]=base_val[13] A[12]=base_val[12] A[11]=base_val[11]
+ A[10]=base_val[10] A[9]=base_val[9] A[8]=base_val[8] A[7]=base_val[7]
+ A[6]=base_val[6] A[5]=base_val[5] A[4]=base_val[4] A[3]=base_val[3]
+ A[2]=base_val[2] A[1]=base_val[1] A[0]=base_val[0] B[26]=N122 B[25]=N121
+ B[24]=N120 B[23]=N119 B[22]=N118 B[21]=N117 B[20]=N116 B[19]=N115 B[18]=N114
+ B[17]=N113 B[16]=N112 B[15]=N111 B[14]=N110 B[13]=N109 B[12]=N108 B[11]=N107
+ B[10]=N106 B[9]=N105 B[8]=N104 B[7]=N103 B[6]=N102 B[5]=N101 B[4]=N100 B[3]=N99
+ B[2]=N98 B[1]=N97 B[0]=N96 CI=net44447 SUM[26]=N231 SUM[25]=N230 SUM[24]=N229
+ SUM[23]=N228 SUM[22]=N227 SUM[21]=N226 SUM[20]=N225 SUM[19]=N224 SUM[18]=N223
+ SUM[17]=N222 SUM[16]=N221 SUM[15]=N220 SUM[14]=N219 SUM[13]=N218 SUM[12]=N217
+ SUM[11]=N216 SUM[10]=N215 SUM[9]=N214 SUM[8]=N213 SUM[7]=N212 SUM[6]=N211
+ SUM[5]=N210 SUM[4]=N209 SUM[3]=N208 SUM[2]=N207 SUM[1]=N206 SUM[0]=N205
Xadd_0_root_add_0_root_add_28_3 PE_Shift_Add_6_DW01_add_0_DW01_add_35 $PINS
+ A[26]=N204 A[25]=N203 A[24]=N202 A[23]=N201 A[22]=N200 A[21]=N199 A[20]=N198
+ A[19]=N197 A[18]=N196 A[17]=N195 A[16]=N194 A[15]=N193 A[14]=N192 A[13]=N191
+ A[12]=N190 A[11]=N189 A[10]=N188 A[9]=N187 A[8]=N186 A[7]=N185 A[6]=N184
+ A[5]=N183 A[4]=N182 A[3]=N181 A[2]=N180 A[1]=N179 A[0]=N178 B[26]=N231
+ B[25]=N230 B[24]=N229 B[23]=N228 B[22]=N227 B[21]=N226 B[20]=N225 B[19]=N224
+ B[18]=N223 B[17]=N222 B[16]=N221 B[15]=N220 B[14]=N219 B[13]=N218 B[12]=N217
+ B[11]=N216 B[10]=N215 B[9]=N214 B[8]=N213 B[7]=N212 B[6]=N211 B[5]=N210
+ B[4]=N209 B[3]=N208 B[2]=N207 B[1]=N206 B[0]=N205 CI=net44447
+ SUM[26]=next_acc[26] SUM[25]=next_acc[25] SUM[24]=next_acc[24]
+ SUM[23]=next_acc[23] SUM[22]=next_acc[22] SUM[21]=next_acc[21]
+ SUM[20]=next_acc[20] SUM[19]=next_acc[19] SUM[18]=next_acc[18]
+ SUM[17]=next_acc[17] SUM[16]=next_acc[16] SUM[15]=next_acc[15]
+ SUM[14]=next_acc[14] SUM[13]=next_acc[13] SUM[12]=next_acc[12]
+ SUM[11]=next_acc[11] SUM[10]=next_acc[10] SUM[9]=next_acc[9] SUM[8]=next_acc[8]
+ SUM[7]=next_acc[7] SUM[6]=next_acc[6] SUM[5]=next_acc[5] SUM[4]=next_acc[4]
+ SUM[3]=next_acc[3] SUM[2]=next_acc[2] SUM[1]=next_acc[1] SUM[0]=next_acc[0]
XU43 MUX2 $PINS O=sll_18/ML_int[1][3] S=FE_OFN103_FE_OFN218_h03_0 A=term3_in[3]
+ B=term3_in[2]
XU42 MUX2 $PINS O=sll_18/ML_int[1][2] S=FE_OFN103_FE_OFN218_h03_0 A=term3_in[2]
+ B=term3_in[1]
XU8 NR2P $PINS O=term2_shifted[2] I1=n111 I2=n113
XU9 OR2 $PINS O=n111 I1=shf2[2] I2=shf2[3]
XU11 NR2 $PINS O=term2_in[0] I1=sign2[1] I2=x_in[0]
XU12 NR2P $PINS O=term3_shifted[0] I1=n122 I2=n120
XU14 ND2 $PINS O=n151 I1=sll_17/ML_int[3][4] I2=FE_OFN210_h02_3
XU15 INV2 $PINS O=term2_shifted[4] I=n151
XU16 ND2P $PINS O=n109 I1=sll_17/ML_int[1][0] I2=FE_DBTN189_h02_1
XU23 ND3 $PINS O=n120 I1=FE_DBTN187_h03_1 I2=term3_in[0] I3=n11
XU27 AN2B1S $PINS O=term2_shifted[3] I1=sll_17/ML_int[2][3] B1=n111
XU29 NR2T $PINS O=term3_shifted[1] I1=n122 I2=n121
XU31 NR2 $PINS O=term2_in[2] I1=sign2[1] I2=x_in[2]
XU34 AO22 $PINS O=N99 A1=N72 A2=sign2[0] B1=term2_shifted[3] B2=n60
XU40 ND2P $PINS O=n110 I1=sll_17/ML_int[1][1] I2=FE_DBTN189_h02_1
XU51 INV1S $PINS O=n113 I=sll_17/ML_int[2][2]
XU74 NR2T $PINS O=term2_in[4] I1=sign2[1] I2=x_in[4]
XU75 NR2 $PINS O=term2_in[1] I1=sign2[1] I2=x_in[1]
XU95 NR2 $PINS O=term1_in[1] I1=sign1[1] I2=x_in[1]
XU101 INV1S $PINS O=n112 I=sll_17/ML_int[2][3]
XU119 NR2P $PINS O=term2_shifted[1] I1=n111 I2=n110
XU352 AO22 $PINS O=N152 A1=N125 A2=FE_OFN138_s03_0 B1=term3_shifted[1]
+ B2=sign3[0]
.ENDS

.SUBCKT SNPS_CLOCK_GATE_HIGH_PE_Shift_Add_5 EN ENCLK CLK
*.CONNECT ENCLK net2248
*.CONNECT net2249 EN
XFE_PHC946_net2252 DELC $PINS O=net2252 I=FE_PHN946_net2252
Xlatch QDBHN $PINS Q=FE_PHN946_net2252 D=net2249 CKB=CLK
Xmain_gate AN2T $PINS O=net2248 I1=net2252 I2=CLK
.ENDS

.SUBCKT PE_Shift_Add_5_DW01_sub_0_DW01_sub_15 A[26] A[25] A[24] A[23] A[22]
+ A[21] A[20] A[19] A[18] A[17] A[16] A[15] A[14] A[13] A[12] A[11] A[10] A[9]
+ A[8] A[7] A[6] A[5] A[4] A[3] A[2] A[1] A[0] B[26] B[25] B[24] B[23] B[22]
+ B[21] B[20] B[19] B[18] B[17] B[16] B[15] B[14] B[13] B[12] B[11] B[10] B[9]
+ B[8] B[7] B[6] B[5] B[4] B[3] B[2] B[1] B[0] CI DIFF[26] DIFF[25] DIFF[24]
+ DIFF[23] DIFF[22] DIFF[21] DIFF[20] DIFF[19] DIFF[18] DIFF[17] DIFF[16]
+ DIFF[15] DIFF[14] DIFF[13] DIFF[12] DIFF[11] DIFF[10] DIFF[9] DIFF[8] DIFF[7]
+ DIFF[6] DIFF[5] DIFF[4] DIFF[3] DIFF[2] DIFF[1] DIFF[0] CO
XFE_RC_743_0 AN2B1T $PINS O=n3 I1=FE_RN_174_0 B1=B[3]
XFE_RC_211_0 XNR2HS $PINS O=DIFF[3] I1=B[3] I2=n4
XFE_RC_1542_0 XNR2HS $PINS O=DIFF[2] I1=n2 I2=B[2]
XFE_RC_1375_0 AN2B1S $PINS O=n12 I1=n3 B1=B[4]
XFE_RC_1367_0 AN2B1S $PINS O=FE_RN_174_0 I1=n2 B1=B[2]
XFE_RC_1144_0 XOR2HS $PINS O=DIFF[1] I1=B[0] I2=B[1]
XU2 NR2 $PINS O=n2 I1=B[0] I2=B[1]
XU3 OAI12HS $PINS O=DIFF[4] A1=n1 B1=B[4] B2=n3
XU5 INV1S $PINS O=n46 I=B[7]
XU9 INV1S $PINS O=n48 I=B[5]
XU11 ND2 $PINS O=n1 I1=B[4] I2=n3
XU12 AN2 $PINS O=n14 I1=n13 I2=n47
XU14 ND2S $PINS O=n27 I1=n28 I2=n25
XU15 AN2 $PINS O=n4 I1=n51 I2=n2
XU16 AN2 $PINS O=n5 I1=n41 I2=n19
XU17 AN2 $PINS O=n6 I1=n40 I2=n5
XU18 AN2 $PINS O=n7 I1=n39 I2=n6
XU19 AN2 $PINS O=n8 I1=n38 I2=n7
XU20 AN2 $PINS O=n9 I1=n37 I2=n8
XU21 AN2 $PINS O=n10 I1=n36 I2=n9
XU22 AN2 $PINS O=n11 I1=n35 I2=n10
XU24 AN2 $PINS O=n13 I1=n48 I2=n12
XU25 AN2 $PINS O=n15 I1=n46 I2=n14
XU26 AN2 $PINS O=n16 I1=n45 I2=n15
XU27 AN2 $PINS O=n17 I1=n44 I2=n16
XU28 AN2 $PINS O=n18 I1=n43 I2=n17
XU29 AN2 $PINS O=n19 I1=n42 I2=n18
XU30 AN2 $PINS O=n20 I1=n34 I2=n11
XU31 AN2 $PINS O=n21 I1=n33 I2=n20
XU32 AN2 $PINS O=n22 I1=n32 I2=n21
XU33 AN2 $PINS O=n23 I1=n31 I2=n22
XU34 AN2 $PINS O=n24 I1=n30 I2=n23
XU35 AN2 $PINS O=n25 I1=n29 I2=n24
XU36 INV1S $PINS O=n41 I=B[12]
XU37 INV1S $PINS O=n40 I=B[13]
XU38 INV1S $PINS O=n39 I=B[14]
XU39 INV1S $PINS O=n38 I=B[15]
XU40 INV1S $PINS O=n37 I=B[16]
XU41 INV1S $PINS O=n36 I=B[17]
XU42 INV1S $PINS O=n35 I=B[18]
XU45 XOR2HS $PINS O=DIFF[5] I1=n48 I2=n12
XU46 XOR2HS $PINS O=DIFF[6] I1=n47 I2=n13
XU47 XOR2HS $PINS O=DIFF[7] I1=n46 I2=n14
XU48 XOR2HS $PINS O=DIFF[8] I1=n45 I2=n15
XU49 XOR2HS $PINS O=DIFF[9] I1=n44 I2=n16
XU50 XOR2HS $PINS O=DIFF[10] I1=n43 I2=n17
XU51 XOR2HS $PINS O=DIFF[11] I1=n42 I2=n18
XU52 XOR2HS $PINS O=DIFF[12] I1=n41 I2=n19
XU53 XOR2HS $PINS O=DIFF[13] I1=n40 I2=n5
XU54 XOR2HS $PINS O=DIFF[14] I1=n39 I2=n6
XU55 XOR2HS $PINS O=DIFF[15] I1=n38 I2=n7
XU56 XOR2HS $PINS O=DIFF[16] I1=n37 I2=n8
XU57 XOR2HS $PINS O=DIFF[17] I1=n36 I2=n9
XU58 XOR2HS $PINS O=DIFF[18] I1=n35 I2=n10
XU59 XOR2HS $PINS O=DIFF[19] I1=n34 I2=n11
XU60 XOR2HS $PINS O=DIFF[20] I1=n33 I2=n20
XU61 XOR2HS $PINS O=DIFF[21] I1=n32 I2=n21
XU62 XOR2HS $PINS O=DIFF[22] I1=n31 I2=n22
XU63 XOR2HS $PINS O=DIFF[23] I1=n30 I2=n23
XU64 XOR2HS $PINS O=DIFF[24] I1=n29 I2=n24
XU65 XOR2HS $PINS O=DIFF[25] I1=n28 I2=n25
XU66 INV1S $PINS O=n47 I=B[6]
XU67 INV1S $PINS O=n45 I=B[8]
XU68 INV1S $PINS O=n44 I=B[9]
XU69 INV1S $PINS O=n43 I=B[10]
XU70 INV1S $PINS O=n42 I=B[11]
XU71 XOR2HS $PINS O=DIFF[26] I1=B[26] I2=n27
XU72 INV1S $PINS O=n34 I=B[19]
XU73 INV1S $PINS O=n33 I=B[20]
XU74 INV1S $PINS O=n32 I=B[21]
XU75 INV1S $PINS O=n31 I=B[22]
XU76 INV1S $PINS O=n30 I=B[23]
XU77 INV1S $PINS O=n29 I=B[24]
XU78 INV1S $PINS O=n28 I=B[25]
XU23 INV1S $PINS O=n51 I=B[2]
.ENDS

.SUBCKT PE_Shift_Add_5_DW01_sub_1_DW01_sub_16 A[26] A[25] A[24] A[23] A[22]
+ A[21] A[20] A[19] A[18] A[17] A[16] A[15] A[14] A[13] A[12] A[11] A[10] A[9]
+ A[8] A[7] A[6] A[5] A[4] A[3] A[2] A[1] A[0] B[26] B[25] B[24] B[23] B[22]
+ B[21] B[20] B[19] B[18] B[17] B[16] B[15] B[14] B[13] B[12] B[11] B[10] B[9]
+ B[8] B[7] B[6] B[5] B[4] B[3] B[2] B[1] B[0] CI DIFF[26] DIFF[25] DIFF[24]
+ DIFF[23] DIFF[22] DIFF[21] DIFF[20] DIFF[19] DIFF[18] DIFF[17] DIFF[16]
+ DIFF[15] DIFF[14] DIFF[13] DIFF[12] DIFF[11] DIFF[10] DIFF[9] DIFF[8] DIFF[7]
+ DIFF[6] DIFF[5] DIFF[4] DIFF[3] DIFF[2] DIFF[1] DIFF[0] CO
XFE_RC_1529_0 OR2B1S $PINS O=FE_RN_341_0 I1=B[1] B1=FE_RN_243_0
XFE_RC_1528_0 XOR2HS $PINS O=DIFF[2] I1=B[2] I2=FE_RN_341_0
XFE_RC_1361_0 INV2 $PINS O=FE_RN_243_0 I=B[0]
XFE_RC_1360_0 OAI12HS $PINS O=DIFF[1] A1=n2 B1=B[1] B2=FE_RN_243_0
XFE_RC_1289_0 AN2S $PINS O=n4 I1=n1 I2=FE_RN_243_0
XU2 INV1S $PINS O=n53 I=B[2]
XU3 INV1S $PINS O=n50 I=B[5]
XU4 INV1S $PINS O=n1 I=B[1]
XU5 ND2 $PINS O=n2 I1=B[1] I2=FE_RN_243_0
XU9 AN2 $PINS O=n16 I1=n15 I2=n49
XU11 INV1S $PINS O=n52 I=B[3]
XU12 ND2S $PINS O=n29 I1=n30 I2=n27
XU13 AN2 $PINS O=n5 I1=n53 I2=n4
XU14 AN2 $PINS O=n6 I1=n5 I2=n52
XU15 AN2 $PINS O=n7 I1=n43 I2=n21
XU16 AN2 $PINS O=n8 I1=n42 I2=n7
XU17 AN2 $PINS O=n9 I1=n41 I2=n8
XU18 AN2 $PINS O=n10 I1=n40 I2=n9
XU19 AN2 $PINS O=n11 I1=n39 I2=n10
XU20 AN2 $PINS O=n12 I1=n38 I2=n11
XU21 AN2 $PINS O=n13 I1=n37 I2=n12
XU22 AN2 $PINS O=n14 I1=n6 I2=n51
XU23 AN2 $PINS O=n15 I1=n14 I2=n50
XU24 AN2 $PINS O=n17 I1=n16 I2=n48
XU25 AN2 $PINS O=n18 I1=n47 I2=n17
XU26 AN2 $PINS O=n19 I1=n46 I2=n18
XU27 AN2 $PINS O=n20 I1=n45 I2=n19
XU28 AN2 $PINS O=n21 I1=n44 I2=n20
XU29 AN2 $PINS O=n22 I1=n36 I2=n13
XU30 AN2 $PINS O=n23 I1=n35 I2=n22
XU31 AN2 $PINS O=n24 I1=n34 I2=n23
XU32 AN2 $PINS O=n25 I1=n33 I2=n24
XU33 AN2 $PINS O=n26 I1=n32 I2=n25
XU34 AN2 $PINS O=n27 I1=n31 I2=n26
XU35 INV1S $PINS O=n43 I=B[12]
XU36 INV1S $PINS O=n42 I=B[13]
XU37 INV1S $PINS O=n41 I=B[14]
XU38 INV1S $PINS O=n40 I=B[15]
XU39 INV1S $PINS O=n39 I=B[16]
XU40 INV1S $PINS O=n38 I=B[17]
XU41 INV1S $PINS O=n37 I=B[18]
XU42 INV2 $PINS O=n51 I=B[4]
XU43 INV1S $PINS O=n48 I=B[7]
XU44 INV1S $PINS O=n49 I=B[6]
XU45 INV1S $PINS O=n47 I=B[8]
XU46 INV1S $PINS O=n46 I=B[9]
XU47 INV1S $PINS O=n45 I=B[10]
XU48 INV1S $PINS O=n44 I=B[11]
XU49 XOR2HS $PINS O=DIFF[26] I1=B[26] I2=n29
XU50 INV1S $PINS O=n36 I=B[19]
XU51 INV1S $PINS O=n35 I=B[20]
XU52 INV1S $PINS O=n34 I=B[21]
XU53 INV1S $PINS O=n33 I=B[22]
XU54 INV1S $PINS O=n32 I=B[23]
XU55 INV1S $PINS O=n31 I=B[24]
XU56 INV1S $PINS O=n30 I=B[25]
XU57 XOR2HS $PINS O=DIFF[9] I1=n46 I2=n18
XU58 XOR2HS $PINS O=DIFF[10] I1=n45 I2=n19
XU59 XOR2HS $PINS O=DIFF[8] I1=n47 I2=n17
XU60 XOR2HS $PINS O=DIFF[7] I1=n48 I2=n16
XU61 XOR2HS $PINS O=DIFF[5] I1=n50 I2=n14
XU62 XOR2HS $PINS O=DIFF[6] I1=n49 I2=n15
XU63 XOR2HS $PINS O=DIFF[4] I1=n51 I2=n6
XU64 XOR2HS $PINS O=DIFF[3] I1=n52 I2=n5
XU66 XOR2HS $PINS O=DIFF[11] I1=n44 I2=n20
XU67 XOR2HS $PINS O=DIFF[12] I1=n43 I2=n21
XU68 XOR2HS $PINS O=DIFF[13] I1=n42 I2=n7
XU69 XOR2HS $PINS O=DIFF[14] I1=n41 I2=n8
XU70 XOR2HS $PINS O=DIFF[15] I1=n40 I2=n9
XU71 XOR2HS $PINS O=DIFF[16] I1=n39 I2=n10
XU72 XOR2HS $PINS O=DIFF[17] I1=n38 I2=n11
XU73 XOR2HS $PINS O=DIFF[18] I1=n37 I2=n12
XU74 XOR2HS $PINS O=DIFF[19] I1=n36 I2=n13
XU75 XOR2HS $PINS O=DIFF[20] I1=n35 I2=n22
XU76 XOR2HS $PINS O=DIFF[21] I1=n34 I2=n23
XU77 XOR2HS $PINS O=DIFF[22] I1=n33 I2=n24
XU78 XOR2HS $PINS O=DIFF[23] I1=n32 I2=n25
XU79 XOR2HS $PINS O=DIFF[24] I1=n31 I2=n26
XU80 XOR2HS $PINS O=DIFF[25] I1=n30 I2=n27
.ENDS

.SUBCKT PE_Shift_Add_5_DW01_sub_2_DW01_sub_17 A[26] A[25] A[24] A[23] A[22]
+ A[21] A[20] A[19] A[18] A[17] A[16] A[15] A[14] A[13] A[12] A[11] A[10] A[9]
+ A[8] A[7] A[6] A[5] A[4] A[3] A[2] A[1] A[0] B[26] B[25] B[24] B[23] B[22]
+ B[21] B[20] B[19] B[18] B[17] B[16] B[15] B[14] B[13] B[12] B[11] B[10] B[9]
+ B[8] B[7] B[6] B[5] B[4] B[3] B[2] B[1] B[0] CI DIFF[26] DIFF[25] DIFF[24]
+ DIFF[23] DIFF[22] DIFF[21] DIFF[20] DIFF[19] DIFF[18] DIFF[17] DIFF[16]
+ DIFF[15] DIFF[14] DIFF[13] DIFF[12] DIFF[11] DIFF[10] DIFF[9] DIFF[8] DIFF[7]
+ DIFF[6] DIFF[5] DIFF[4] DIFF[3] DIFF[2] DIFF[1] DIFF[0] CO
*.CONNECT DIFF[0] B[0]
XFE_RC_122_0 INV2 $PINS O=n52 I=B[1]
XFE_RC_59_0 AN2T $PINS O=n4 I1=n3 I2=n50
XFE_RC_58_0 INV1S $PINS O=FE_RN_32_0 I=n3
XFE_RC_57_0 INV1S $PINS O=FE_RN_33_0 I=n50
XFE_RC_56_0 NR3H $PINS O=n12 I1=FE_RN_32_0 I2=FE_RN_33_0 I3=B[4]
XFE_RC_1372_0 XNR2HS $PINS O=DIFF[6] I1=n13 I2=B[6]
XU2 OAI12HS $PINS O=DIFF[4] A1=n1 B1=B[4] B2=n4
XU3 AN2T $PINS O=n3 I1=n51 I2=n2
XU4 INV2 $PINS O=n51 I=B[2]
XU6 XOR2HS $PINS O=DIFF[2] I1=n2 I2=n51
XU7 INV1S $PINS O=n46 I=B[7]
XU8 INV2 $PINS O=n50 I=B[3]
XU10 INV1S $PINS O=n47 I=B[6]
XU14 ND2P $PINS O=n1 I1=B[4] I2=n4
XU15 AN2T $PINS O=n2 I1=n52 I2=n53
XU16 ND2S $PINS O=n27 I1=n28 I2=n25
XU17 XOR2HS $PINS O=DIFF[3] I1=n50 I2=n3
XU18 XOR2HS $PINS O=DIFF[12] I1=n41 I2=n19
XU19 XOR2HS $PINS O=DIFF[13] I1=n40 I2=n5
XU20 AN2 $PINS O=n5 I1=n41 I2=n19
XU21 XOR2HS $PINS O=DIFF[14] I1=n39 I2=n6
XU22 AN2 $PINS O=n6 I1=n40 I2=n5
XU23 XOR2HS $PINS O=DIFF[15] I1=n38 I2=n7
XU24 AN2 $PINS O=n7 I1=n39 I2=n6
XU25 XOR2HS $PINS O=DIFF[16] I1=n37 I2=n8
XU26 AN2 $PINS O=n8 I1=n38 I2=n7
XU27 XOR2HS $PINS O=DIFF[17] I1=n36 I2=n9
XU28 AN2 $PINS O=n9 I1=n37 I2=n8
XU29 XOR2HS $PINS O=DIFF[18] I1=n35 I2=n10
XU30 AN2 $PINS O=n10 I1=n36 I2=n9
XU31 AN2 $PINS O=n11 I1=n35 I2=n10
XU32 XOR2HS $PINS O=DIFF[5] I1=n48 I2=n12
XU35 AN2 $PINS O=n13 I1=n12 I2=n48
XU36 XOR2HS $PINS O=DIFF[7] I1=n46 I2=n14
XU37 AN2 $PINS O=n14 I1=n13 I2=n47
XU38 XOR2HS $PINS O=DIFF[8] I1=n45 I2=n15
XU39 AN2 $PINS O=n15 I1=n46 I2=n14
XU40 XOR2HS $PINS O=DIFF[9] I1=n44 I2=n16
XU41 AN2 $PINS O=n16 I1=n45 I2=n15
XU42 XOR2HS $PINS O=DIFF[10] I1=n43 I2=n17
XU43 AN2 $PINS O=n17 I1=n44 I2=n16
XU44 XOR2HS $PINS O=DIFF[11] I1=n42 I2=n18
XU45 AN2 $PINS O=n18 I1=n43 I2=n17
XU46 AN2 $PINS O=n19 I1=n42 I2=n18
XU47 XOR2HS $PINS O=DIFF[19] I1=n34 I2=n11
XU48 XOR2HS $PINS O=DIFF[20] I1=n33 I2=n20
XU49 AN2 $PINS O=n20 I1=n34 I2=n11
XU50 XOR2HS $PINS O=DIFF[21] I1=n32 I2=n21
XU51 AN2 $PINS O=n21 I1=n33 I2=n20
XU52 XOR2HS $PINS O=DIFF[22] I1=n31 I2=n22
XU53 AN2 $PINS O=n22 I1=n32 I2=n21
XU54 XOR2HS $PINS O=DIFF[23] I1=n30 I2=n23
XU55 AN2 $PINS O=n23 I1=n31 I2=n22
XU56 AN2 $PINS O=n24 I1=n30 I2=n23
XU57 AN2 $PINS O=n25 I1=n29 I2=n24
XU58 XOR2HS $PINS O=DIFF[24] I1=n29 I2=n24
XU59 XOR2HS $PINS O=DIFF[25] I1=n28 I2=n25
XU60 INV1S $PINS O=n41 I=B[12]
XU61 INV1S $PINS O=n40 I=B[13]
XU62 INV1S $PINS O=n39 I=B[14]
XU63 INV1S $PINS O=n38 I=B[15]
XU64 INV1S $PINS O=n37 I=B[16]
XU65 INV1S $PINS O=n36 I=B[17]
XU66 INV1S $PINS O=n35 I=B[18]
XU67 INV1S $PINS O=n48 I=B[5]
XU68 INV1S $PINS O=n45 I=B[8]
XU69 INV1S $PINS O=n44 I=B[9]
XU70 INV1S $PINS O=n43 I=B[10]
XU71 XOR2HS $PINS O=DIFF[26] I1=B[26] I2=n27
XU72 INV1S $PINS O=n42 I=B[11]
XU73 INV1S $PINS O=n34 I=B[19]
XU74 INV1S $PINS O=n33 I=B[20]
XU75 INV1S $PINS O=n32 I=B[21]
XU76 INV1S $PINS O=n31 I=B[22]
XU77 INV1S $PINS O=n30 I=B[23]
XU78 INV1S $PINS O=n29 I=B[24]
XU79 INV1S $PINS O=n28 I=B[25]
XU13 INV1S $PINS O=n53 I=B[0]
XU33 XOR2HS $PINS O=DIFF[1] I1=n53 I2=n52
.ENDS

.SUBCKT PE_Shift_Add_5_DW01_add_2_DW01_add_22 A[26] A[25] A[24] A[23] A[22]
+ A[21] A[20] A[19] A[18] A[17] A[16] A[15] A[14] A[13] A[12] A[11] A[10] A[9]
+ A[8] A[7] A[6] A[5] A[4] A[3] A[2] A[1] A[0] B[26] B[25] B[24] B[23] B[22]
+ B[21] B[20] B[19] B[18] B[17] B[16] B[15] B[14] B[13] B[12] B[11] B[10] B[9]
+ B[8] B[7] B[6] B[5] B[4] B[3] B[2] B[1] B[0] CI SUM[26] SUM[25] SUM[24]
+ SUM[23] SUM[22] SUM[21] SUM[20] SUM[19] SUM[18] SUM[17] SUM[16] SUM[15]
+ SUM[14] SUM[13] SUM[12] SUM[11] SUM[10] SUM[9] SUM[8] SUM[7] SUM[6] SUM[5]
+ SUM[4] SUM[3] SUM[2] SUM[1] SUM[0] CO
XFE_RC_193_0 MAO222P $PINS O=carry[8] A1=carry[7] B1=A[7] C1=B[7]
XFE_RC_17_0 ND3P $PINS O=carry[10] I1=n4 I2=n5 I3=n3
XFE_RC_12_0 ND2 $PINS O=FE_RN_5_0 I1=A[6] I2=B[6]
XFE_RC_11_0 ND2P $PINS O=FE_RN_6_0 I1=carry[6] I2=B[6]
XFE_RC_10_0 ND2 $PINS O=FE_RN_7_0 I1=carry[6] I2=A[6]
XFE_RC_9_0 ND3P $PINS O=carry[7] I1=FE_RN_7_0 I2=FE_RN_6_0 I3=FE_RN_5_0
XFE_RC_1531_0 INV2 $PINS O=SUM[5] I=FE_RN_342_0
XFE_RC_1530_0 XNR3 $PINS O=FE_RN_342_0 I1=A[5] I2=B[5] I3=carry[5]
XFE_RC_1524_0 INV2 $PINS O=SUM[7] I=FE_RN_339_0
XFE_RC_1523_0 XNR3 $PINS O=FE_RN_339_0 I1=A[7] I2=B[7] I3=carry[7]
XFE_RC_1458_0 INV1S $PINS O=SUM[14] I=FE_RN_297_0
XFE_RC_1457_0 XNR3 $PINS O=FE_RN_297_0 I1=A[14] I2=B[14] I3=carry[14]
XFE_RC_1451_0 INV2 $PINS O=SUM[11] I=FE_RN_293_0
XFE_RC_1450_0 XNR3 $PINS O=FE_RN_293_0 I1=A[11] I2=B[11] I3=carry[11]
XFE_RC_1447_0 INV2 $PINS O=SUM[9] I=FE_RN_291_0
XFE_RC_1446_0 XNR3 $PINS O=FE_RN_291_0 I1=A[9] I2=B[9] I3=carry[9]
XFE_RC_1402_0 INV2 $PINS O=SUM[6] I=FE_RN_262_0
XFE_RC_1401_0 XNR3 $PINS O=FE_RN_262_0 I1=B[6] I2=A[6] I3=carry[6]
XFE_RC_1393_0 INV2 $PINS O=SUM[4] I=FE_RN_257_0
XFE_RC_1392_0 XNR3 $PINS O=FE_RN_257_0 I1=B[4] I2=A[4] I3=carry[4]
XFE_RC_1381_0 INV1S $PINS O=SUM[18] I=FE_RN_251_0
XFE_RC_1380_0 XNR3 $PINS O=FE_RN_251_0 I1=A[18] I2=B[18] I3=carry[18]
XFE_RC_1377_0 INV1S $PINS O=SUM[15] I=FE_RN_249_0
XFE_RC_1376_0 XNR3 $PINS O=FE_RN_249_0 I1=A[15] I2=B[15] I3=carry[15]
XFE_RC_1369_0 INV1S $PINS O=SUM[17] I=FE_RN_246_0
XFE_RC_1368_0 XNR3 $PINS O=FE_RN_246_0 I1=A[17] I2=B[17] I3=carry[17]
XFE_RC_1286_0 INV2 $PINS O=SUM[8] I=FE_RN_205_0
XFE_RC_1285_0 XNR3 $PINS O=FE_RN_205_0 I1=A[8] I2=B[8] I3=carry[8]
XFE_RC_1181_0 XOR3 $PINS O=SUM[26] I1=A[26] I2=B[26] I3=carry[26]
XFE_RC_876_0 XOR3 $PINS O=SUM[25] I1=A[25] I2=B[25] I3=carry[25]
XFE_RC_875_0 MAO222 $PINS O=carry[26] A1=carry[25] B1=B[25] C1=A[25]
XFE_RC_792_0 XOR3 $PINS O=SUM[1] I1=n2 I2=A[1] I3=B[1]
XFE_RC_791_0 MAO222P $PINS O=carry[2] A1=A[1] B1=B[1] C1=n2
XFE_RC_722_0 XOR3 $PINS O=SUM[24] I1=A[24] I2=B[24] I3=carry[24]
XFE_RC_721_0 MAO222P $PINS O=carry[25] A1=carry[24] B1=B[24] C1=A[24]
XFE_RC_714_0 XOR3 $PINS O=SUM[2] I1=A[2] I2=carry[2] I3=B[2]
XFE_RC_713_0 MAO222P $PINS O=carry[3] A1=B[2] B1=carry[2] C1=A[2]
XFE_RC_668_0 XOR3 $PINS O=SUM[23] I1=A[23] I2=B[23] I3=carry[23]
XFE_RC_667_0 MAO222P $PINS O=carry[24] A1=carry[23] B1=B[23] C1=A[23]
XFE_RC_624_0 XOR3 $PINS O=SUM[22] I1=A[22] I2=B[22] I3=carry[22]
XFE_RC_623_0 MAO222P $PINS O=carry[23] A1=carry[22] B1=B[22] C1=A[22]
XFE_RC_600_0 XOR3 $PINS O=SUM[21] I1=A[21] I2=B[21] I3=carry[21]
XFE_RC_599_0 MAO222P $PINS O=carry[22] A1=carry[21] B1=B[21] C1=A[21]
XFE_RC_525_0 MAO222P $PINS O=carry[15] A1=carry[14] B1=B[14] C1=A[14]
XFE_RC_453_0 MAO222P $PINS O=carry[16] A1=carry[15] B1=B[15] C1=A[15]
XFE_RC_439_0 MAO222P $PINS O=carry[12] A1=carry[11] B1=B[11] C1=A[11]
XFE_RC_384_0 XOR3 $PINS O=SUM[16] I1=A[16] I2=B[16] I3=carry[16]
XFE_RC_383_0 MAO222P $PINS O=carry[17] A1=carry[16] B1=B[16] C1=A[16]
XFE_RC_310_0 XOR3 $PINS O=SUM[12] I1=A[12] I2=B[12] I3=carry[12]
XFE_RC_309_0 MAO222P $PINS O=carry[13] A1=carry[12] B1=B[12] C1=A[12]
XFE_RC_307_0 MAO222P $PINS O=carry[18] A1=carry[17] B1=B[17] C1=A[17]
XFE_RC_226_0 MAO222P $PINS O=carry[19] A1=carry[18] B1=B[18] C1=A[18]
XFE_RC_148_0 XOR3 $PINS O=SUM[19] I1=A[19] I2=B[19] I3=carry[19]
XFE_RC_147_0 MAO222P $PINS O=carry[20] A1=carry[19] B1=B[19] C1=A[19]
XFE_RC_142_0 XOR3 $PINS O=SUM[13] I1=A[13] I2=B[13] I3=carry[13]
XFE_RC_141_0 MAO222P $PINS O=carry[14] A1=carry[13] B1=B[13] C1=A[13]
XFE_RC_81_0 MAO222P $PINS O=carry[6] A1=carry[5] B1=B[5] C1=A[5]
XFE_RC_57_0 MAO222 $PINS O=carry[5] A1=carry[4] B1=B[4] C1=A[4]
XU4 ND2 $PINS O=n3 I1=A[9] I2=B[9]
XU5 ND3P $PINS O=carry[11] I1=n9 I2=n8 I3=n7
XU7 AN2 $PINS O=n2 I1=B[0] I2=A[0]
XU9 ND2 $PINS O=n4 I1=carry[9] I2=A[9]
XU10 ND2 $PINS O=n5 I1=carry[9] I2=B[9]
XU12 XOR2HS $PINS O=n6 I1=A[10] I2=B[10]
XU13 XOR2HS $PINS O=SUM[10] I1=n6 I2=carry[10]
XU14 ND2 $PINS O=n7 I1=A[10] I2=B[10]
XU15 ND2P $PINS O=n8 I1=carry[10] I2=A[10]
XU16 ND2 $PINS O=n9 I1=carry[10] I2=B[10]
XU18 ND2P $PINS O=n15 I1=carry[3] I2=B[3]
XU19 ND2P $PINS O=n10 I1=carry[8] I2=A[8]
XU20 ND2 $PINS O=n11 I1=carry[8] I2=B[8]
XU21 ND2 $PINS O=n12 I1=A[8] I2=B[8]
XU22 ND3P $PINS O=carry[9] I1=n11 I2=n10 I3=n12
XU24 XOR2HS $PINS O=n13 I1=B[3] I2=A[3]
XU25 XOR2HS $PINS O=SUM[3] I1=carry[3] I2=n13
XU26 ND2P $PINS O=n14 I1=carry[3] I2=A[3]
XU27 ND3P $PINS O=carry[4] I1=n14 I2=n15 I3=n16
XU31 ND2 $PINS O=n20 I1=carry[20] I2=B[20]
XU32 ND2P $PINS O=n21 I1=carry[20] I2=A[20]
XU33 ND2 $PINS O=n22 I1=B[20] I2=A[20]
XU34 ND3P $PINS O=carry[21] I1=n20 I2=n21 I3=n22
XU35 XOR2HS $PINS O=SUM[0] I1=B[0] I2=A[0]
XU3 ND2P $PINS O=n16 I1=A[3] I2=B[3]
XU17 XOR3 $PINS O=SUM[20] I1=B[20] I2=A[20] I3=carry[20]
.ENDS

.SUBCKT PE_Shift_Add_5_DW01_add_1_DW01_add_21 A[26] A[25] A[24] A[23] A[22]
+ A[21] A[20] A[19] A[18] A[17] A[16] A[15] A[14] A[13] A[12] A[11] A[10] A[9]
+ A[8] A[7] A[6] A[5] A[4] A[3] A[2] A[1] A[0] B[26] B[25] B[24] B[23] B[22]
+ B[21] B[20] B[19] B[18] B[17] B[16] B[15] B[14] B[13] B[12] B[11] B[10] B[9]
+ B[8] B[7] B[6] B[5] B[4] B[3] B[2] B[1] B[0] CI SUM[26] SUM[25] SUM[24]
+ SUM[23] SUM[22] SUM[21] SUM[20] SUM[19] SUM[18] SUM[17] SUM[16] SUM[15]
+ SUM[14] SUM[13] SUM[12] SUM[11] SUM[10] SUM[9] SUM[8] SUM[7] SUM[6] SUM[5]
+ SUM[4] SUM[3] SUM[2] SUM[1] SUM[0] CO
XFE_RC_642_0 XNR2HP $PINS O=SUM[26] I1=FE_RN_69_0 I2=carry[26]
XFE_RC_114_0 XNR2H $PINS O=FE_RN_69_0 I1=A[26] I2=B[26]
XFE_RC_1598_0 INV1S $PINS O=FE_RN_374_0 I=A[0]
XFE_RC_1597_0 AN2B1S $PINS O=n1 I1=B[0] B1=FE_RN_374_0
XFE_RC_1540_0 INV1S $PINS O=SUM[6] I=FE_RN_346_0
XFE_RC_1539_0 XNR3 $PINS O=FE_RN_346_0 I1=A[6] I2=B[6] I3=carry[6]
XFE_RC_1533_0 INV1S $PINS O=SUM[17] I=FE_RN_343_0
XFE_RC_1532_0 XNR3 $PINS O=FE_RN_343_0 I1=A[17] I2=B[17] I3=carry[17]
XFE_RC_1411_0 INV1S $PINS O=SUM[25] I=FE_RN_267_0
XFE_RC_1410_0 XNR3S $PINS O=FE_RN_267_0 I1=A[25] I2=B[25] I3=carry[25]
XFE_RC_1317_0 INV2 $PINS O=SUM[5] I=FE_RN_222_0
XFE_RC_1316_0 XNR3 $PINS O=FE_RN_222_0 I1=A[5] I2=B[5] I3=carry[5]
XFE_RC_1257_0 INV1S $PINS O=SUM[4] I=FE_RN_189_0
XFE_RC_1256_0 XNR3 $PINS O=FE_RN_189_0 I1=A[4] I2=B[4] I3=carry[4]
XFE_RC_1152_0 INV2 $PINS O=SUM[2] I=FE_RN_131_0
XFE_RC_1151_0 XNR3 $PINS O=FE_RN_131_0 I1=A[2] I2=B[2] I3=carry[2]
XFE_RC_968_0 XOR3 $PINS O=SUM[10] I1=A[10] I2=B[10] I3=carry[10]
XFE_RC_967_0 MAO222 $PINS O=carry[11] A1=carry[10] B1=B[10] C1=A[10]
XFE_RC_960_0 XOR3 $PINS O=SUM[20] I1=A[20] I2=B[20] I3=carry[20]
XFE_RC_959_0 MAO222 $PINS O=carry[21] A1=carry[20] B1=B[20] C1=A[20]
XFE_RC_859_0 MAO222 $PINS O=carry[26] A1=carry[25] B1=B[25] C1=A[25]
XFE_RC_828_0 XOR3 $PINS O=SUM[1] I1=A[1] I2=n1 I3=B[1]
XFE_RC_827_0 MAO222 $PINS O=carry[2] A1=B[1] B1=n1 C1=A[1]
XFE_RC_747_0 MAO222P $PINS O=carry[3] A1=carry[2] B1=B[2] C1=A[2]
XFE_RC_746_0 XOR3 $PINS O=SUM[11] I1=A[11] I2=B[11] I3=carry[11]
XFE_RC_745_0 MAO222 $PINS O=carry[12] A1=carry[11] B1=B[11] C1=A[11]
XFE_RC_692_0 XOR3 $PINS O=SUM[12] I1=A[12] I2=B[12] I3=carry[12]
XFE_RC_691_0 MAO222 $PINS O=carry[13] A1=carry[12] B1=B[12] C1=A[12]
XFE_RC_640_0 XOR3 $PINS O=SUM[13] I1=A[13] I2=B[13] I3=carry[13]
XFE_RC_639_0 MAO222 $PINS O=carry[14] A1=carry[13] B1=B[13] C1=A[13]
XFE_RC_582_0 XOR3 $PINS O=SUM[14] I1=A[14] I2=B[14] I3=carry[14]
XFE_RC_581_0 MAO222 $PINS O=carry[15] A1=carry[14] B1=B[14] C1=A[14]
XFE_RC_512_0 XOR3 $PINS O=SUM[15] I1=A[15] I2=B[15] I3=carry[15]
XFE_RC_511_0 MAO222 $PINS O=carry[16] A1=carry[15] B1=B[15] C1=A[15]
XFE_RC_510_0 XOR3 $PINS O=SUM[8] I1=A[8] I2=B[8] I3=carry[8]
XFE_RC_509_0 MAO222 $PINS O=carry[9] A1=carry[8] B1=B[8] C1=A[8]
XFE_RC_430_0 XOR3 $PINS O=SUM[9] I1=B[9] I2=A[9] I3=carry[9]
XFE_RC_429_0 MAO222 $PINS O=carry[10] A1=carry[9] B1=B[9] C1=A[9]
XFE_RC_428_0 XOR3 $PINS O=SUM[16] I1=A[16] I2=B[16] I3=carry[16]
XFE_RC_427_0 MAO222 $PINS O=carry[17] A1=carry[16] B1=B[16] C1=A[16]
XFE_RC_397_0 MAO222 $PINS O=carry[18] A1=carry[17] B1=B[17] C1=A[17]
XFE_RC_340_0 XOR3 $PINS O=SUM[18] I1=A[18] I2=B[18] I3=carry[18]
XFE_RC_339_0 MAO222 $PINS O=carry[19] A1=carry[18] B1=B[18] C1=A[18]
XFE_RC_280_0 XOR3 $PINS O=SUM[19] I1=A[19] I2=B[19] I3=carry[19]
XFE_RC_279_0 MAO222 $PINS O=carry[20] A1=carry[19] B1=B[19] C1=A[19]
XFE_RC_160_0 XOR3 $PINS O=SUM[21] I1=A[21] I2=B[21] I3=carry[21]
XFE_RC_159_0 MAO222 $PINS O=carry[22] A1=carry[21] B1=B[21] C1=A[21]
XFE_RC_157_0 MAO222 $PINS O=carry[6] A1=carry[5] B1=B[5] C1=A[5]
XFE_RC_98_0 XOR3 $PINS O=SUM[22] I1=A[22] I2=B[22] I3=carry[22]
XFE_RC_97_0 MAO222P $PINS O=carry[23] A1=carry[22] B1=B[22] C1=A[22]
XFE_RC_93_0 MAO222P $PINS O=carry[7] A1=carry[6] B1=B[6] C1=A[6]
XU1 ND3P $PINS O=carry[8] I1=n13 I2=n14 I3=n15
XU2 ND2 $PINS O=n5 I1=A[23] I2=B[23]
XU5 ND2 $PINS O=n2 I1=carry[4] I2=B[4]
XU6 ND2 $PINS O=n3 I1=carry[4] I2=A[4]
XU7 ND2 $PINS O=n4 I1=B[4] I2=A[4]
XU8 ND3 $PINS O=carry[5] I1=n3 I2=n2 I3=n4
XU9 ND3 $PINS O=carry[25] I1=n11 I2=n10 I3=n9
XU10 ND3P $PINS O=carry[4] I1=n17 I2=n16 I3=n18
XU11 XOR3 $PINS O=SUM[23] I1=A[23] I2=B[23] I3=carry[23]
XU12 ND2 $PINS O=n6 I1=carry[23] I2=A[23]
XU13 ND2 $PINS O=n7 I1=carry[23] I2=B[23]
XU14 ND3P $PINS O=carry[24] I1=n6 I2=n7 I3=n5
XU15 XOR2HS $PINS O=n8 I1=A[24] I2=B[24]
XU16 XOR2HS $PINS O=SUM[24] I1=n8 I2=carry[24]
XU17 ND2 $PINS O=n9 I1=A[24] I2=B[24]
XU18 ND2 $PINS O=n10 I1=carry[24] I2=A[24]
XU19 ND2 $PINS O=n11 I1=carry[24] I2=B[24]
XU20 XOR2HS $PINS O=n12 I1=B[7] I2=A[7]
XU21 XOR2HS $PINS O=SUM[7] I1=carry[7] I2=n12
XU22 ND2P $PINS O=n13 I1=carry[7] I2=B[7]
XU23 ND2T $PINS O=n14 I1=carry[7] I2=A[7]
XU24 ND2S $PINS O=n15 I1=B[7] I2=A[7]
XU26 XOR3 $PINS O=SUM[3] I1=B[3] I2=A[3] I3=carry[3]
XU27 ND2 $PINS O=n16 I1=carry[3] I2=B[3]
XU28 ND2 $PINS O=n17 I1=carry[3] I2=A[3]
XU29 XOR2HS $PINS O=SUM[0] I1=B[0] I2=A[0]
XU25 ND2 $PINS O=n18 I1=B[3] I2=A[3]
.ENDS

.SUBCKT PE_Shift_Add_5_DW01_add_0_DW01_add_20 A[26] A[25] A[24] A[23] A[22]
+ A[21] A[20] A[19] A[18] A[17] A[16] A[15] A[14] A[13] A[12] A[11] A[10] A[9]
+ A[8] A[7] A[6] A[5] A[4] A[3] A[2] A[1] A[0] B[26] B[25] B[24] B[23] B[22]
+ B[21] B[20] B[19] B[18] B[17] B[16] B[15] B[14] B[13] B[12] B[11] B[10] B[9]
+ B[8] B[7] B[6] B[5] B[4] B[3] B[2] B[1] B[0] CI SUM[26] SUM[25] SUM[24]
+ SUM[23] SUM[22] SUM[21] SUM[20] SUM[19] SUM[18] SUM[17] SUM[16] SUM[15]
+ SUM[14] SUM[13] SUM[12] SUM[11] SUM[10] SUM[9] SUM[8] SUM[7] SUM[6] SUM[5]
+ SUM[4] SUM[3] SUM[2] SUM[1] SUM[0] CO
XFE_RC_132_0 XNR2H $PINS O=FE_RN_77_0 I1=B[26] I2=A[26]
XFE_RC_131_0 XNR2H $PINS O=SUM[26] I1=FE_RN_77_0 I2=carry[26]
XFE_RC_16_0 ND2 $PINS O=FE_RN_8_0 I1=A[9] I2=B[9]
XFE_RC_15_0 ND2T $PINS O=FE_RN_9_0 I1=carry[9] I2=B[9]
XFE_RC_14_0 ND2P $PINS O=FE_RN_10_0 I1=carry[9] I2=A[9]
XFE_RC_13_0 ND3P $PINS O=carry[10] I1=FE_RN_10_0 I2=FE_RN_9_0 I3=FE_RN_8_0
XFE_RC_8_0 ND2 $PINS O=FE_RN_2_0 I1=A[12] I2=B[12]
XFE_RC_7_0 ND2T $PINS O=FE_RN_3_0 I1=carry[12] I2=A[12]
XFE_RC_6_0 ND2P $PINS O=FE_RN_4_0 I1=carry[12] I2=B[12]
XFE_RC_5_0 ND3P $PINS O=carry[13] I1=FE_RN_4_0 I2=FE_RN_3_0 I3=FE_RN_2_0
XFE_RC_947_0 XOR3 $PINS O=SUM[17] I1=A[17] I2=B[17] I3=carry[17]
XFE_RC_946_0 MAO222P $PINS O=carry[18] A1=carry[17] B1=B[17] C1=A[17]
XFE_RC_694_0 XOR3S $PINS O=SUM[3] I1=A[3] I2=B[3] I3=carry[3]
XFE_RC_693_0 MAO222 $PINS O=carry[4] A1=carry[3] B1=B[3] C1=A[3]
XFE_RC_686_0 XOR3 $PINS O=SUM[1] I1=A[1] I2=B[1] I3=n1
XFE_RC_685_0 MAO222 $PINS O=carry[2] A1=A[1] B1=B[1] C1=n1
XFE_RC_616_0 XOR3 $PINS O=SUM[5] I1=A[5] I2=B[5] I3=carry[5]
XFE_RC_615_0 MAO222 $PINS O=carry[6] A1=carry[5] B1=B[5] C1=A[5]
XFE_RC_594_0 XOR3 $PINS O=SUM[6] I1=A[6] I2=B[6] I3=carry[6]
XFE_RC_593_0 MAO222P $PINS O=carry[7] A1=carry[6] B1=B[6] C1=A[6]
XFE_RC_476_0 XOR3 $PINS O=SUM[7] I1=A[7] I2=B[7] I3=carry[7]
XFE_RC_475_0 MAO222 $PINS O=carry[8] A1=carry[7] B1=B[7] C1=A[7]
XFE_RC_474_0 XOR3 $PINS O=SUM[13] I1=A[13] I2=B[13] I3=carry[13]
XFE_RC_473_0 MAO222P $PINS O=carry[14] A1=carry[13] B1=B[13] C1=A[13]
XFE_RC_372_0 XOR3 $PINS O=SUM[14] I1=A[14] I2=B[14] I3=carry[14]
XFE_RC_371_0 MAO222P $PINS O=carry[15] A1=carry[14] B1=B[14] C1=A[14]
XFE_RC_368_0 XOR3 $PINS O=SUM[8] I1=A[8] I2=B[8] I3=carry[8]
XFE_RC_367_0 MAO222P $PINS O=carry[9] A1=carry[8] B1=B[8] C1=A[8]
XFE_RC_294_0 XOR3 $PINS O=SUM[15] I1=A[15] I2=B[15] I3=carry[15]
XFE_RC_293_0 MAO222P $PINS O=carry[16] A1=carry[15] B1=B[15] C1=A[15]
XFE_RC_292_0 XOR3 $PINS O=SUM[9] I1=A[9] I2=B[9] I3=carry[9]
XFE_RC_244_0 XOR3 $PINS O=SUM[25] I1=A[25] I2=B[25] I3=carry[25]
XFE_RC_243_0 MAO222P $PINS O=carry[26] A1=carry[25] B1=B[25] C1=A[25]
XFE_RC_198_0 XOR3 $PINS O=SUM[16] I1=A[16] I2=B[16] I3=carry[16]
XFE_RC_197_0 MAO222P $PINS O=carry[17] A1=carry[16] B1=B[16] C1=A[16]
XFE_RC_190_0 XOR3 $PINS O=SUM[10] I1=A[10] I2=B[10] I3=carry[10]
XFE_RC_189_0 MAO222P $PINS O=carry[11] A1=carry[10] B1=B[10] C1=A[10]
XFE_RC_134_0 XOR3 $PINS O=SUM[11] I1=A[11] I2=B[11] I3=carry[11]
XFE_RC_133_0 MAO222P $PINS O=carry[12] A1=carry[11] B1=B[11] C1=A[11]
XFE_RC_104_0 XOR3 $PINS O=SUM[12] I1=A[12] I2=B[12] I3=carry[12]
XFE_RC_70_0 XOR3 $PINS O=SUM[20] I1=A[20] I2=B[20] I3=carry[20]
XFE_RC_69_0 MAO222P $PINS O=carry[21] A1=carry[20] B1=B[20] C1=A[20]
XFE_RC_50_0 XOR3 $PINS O=SUM[18] I1=A[18] I2=B[18] I3=carry[18]
XFE_RC_49_0 MAO222P $PINS O=carry[19] A1=carry[18] B1=B[18] C1=A[18]
XU1 XOR2HS $PINS O=n18 I1=A[21] I2=B[21]
XU2 XOR3 $PINS O=SUM[22] I1=A[22] I2=B[22] I3=carry[22]
XU3 XOR3 $PINS O=SUM[23] I1=B[23] I2=A[23] I3=carry[23]
XU4 XOR2HS $PINS O=n22 I1=A[24] I2=B[24]
XU5 AN2 $PINS O=n1 I1=B[0] I2=A[0]
XU6 XOR3 $PINS O=SUM[2] I1=A[2] I2=B[2] I3=carry[2]
XU7 ND2 $PINS O=n2 I1=A[2] I2=carry[2]
XU8 ND2 $PINS O=n3 I1=carry[2] I2=B[2]
XU9 ND2 $PINS O=n4 I1=A[2] I2=B[2]
XU10 ND3P $PINS O=carry[3] I1=n4 I2=n3 I3=n2
XU11 ND2 $PINS O=n5 I1=carry[23] I2=B[23]
XU12 ND2 $PINS O=n6 I1=carry[23] I2=A[23]
XU13 ND2 $PINS O=n7 I1=B[23] I2=A[23]
XU14 ND3P $PINS O=carry[24] I1=n6 I2=n5 I3=n7
XU16 ND3P $PINS O=carry[5] I1=n17 I2=n15 I3=n16
XU18 ND2 $PINS O=n11 I1=A[19] I2=B[19]
XU20 ND2 $PINS O=n23 I1=carry[24] I2=A[24]
XU21 ND2 $PINS O=n19 I1=carry[21] I2=A[21]
XU22 XOR3 $PINS O=SUM[19] I1=A[19] I2=B[19] I3=carry[19]
XU23 ND2P $PINS O=n9 I1=carry[19] I2=A[19]
XU24 ND2 $PINS O=n10 I1=carry[19] I2=B[19]
XU25 ND2 $PINS O=n12 I1=carry[22] I2=A[22]
XU26 ND2 $PINS O=n13 I1=carry[22] I2=B[22]
XU27 ND2 $PINS O=n14 I1=A[22] I2=B[22]
XU28 ND3P $PINS O=carry[23] I1=n12 I2=n13 I3=n14
XU29 ND3P $PINS O=carry[22] I1=n19 I2=n20 I3=n21
XU30 XOR3S $PINS O=SUM[4] I1=carry[4] I2=B[4] I3=A[4]
XU31 ND2 $PINS O=n15 I1=carry[4] I2=A[4]
XU32 ND2 $PINS O=n16 I1=B[4] I2=A[4]
XU33 ND2 $PINS O=n17 I1=carry[4] I2=B[4]
XU34 XOR2HS $PINS O=SUM[21] I1=carry[21] I2=n18
XU35 ND2P $PINS O=n20 I1=carry[21] I2=B[21]
XU36 ND2 $PINS O=n21 I1=A[21] I2=B[21]
XU37 XOR2HS $PINS O=SUM[24] I1=carry[24] I2=n22
XU38 ND2 $PINS O=n24 I1=carry[24] I2=B[24]
XU39 ND2 $PINS O=n25 I1=A[24] I2=B[24]
XU40 XOR2HS $PINS O=SUM[0] I1=B[0] I2=A[0]
XU17 ND3P $PINS O=carry[25] I1=n23 I2=n24 I3=n25
XU19 ND3P $PINS O=carry[20] I1=n10 I2=n9 I3=n11
.ENDS

.SUBCKT PE_Shift_Add_5 rst_n en clear calc_done stage_sel x_in[16] x_in[15]
+ x_in[14] x_in[13] x_in[12] x_in[11] x_in[10] x_in[9] x_in[8] x_in[7] x_in[6]
+ x_in[5] x_in[4] x_in[3] x_in[2] x_in[1] x_in[0] sign1[1] sign1[0] sign2[1]
+ sign2[0] sign3[1] sign3[0] shf1[3] shf1[2] shf1[1] shf1[0] shf2[3] shf2[2]
+ shf2[1] shf2[0] shf3[3] shf3[2] shf3[1] shf3[0] y_out[16] y_out[15] y_out[14]
+ y_out[13] y_out[12] y_out[11] y_out[10] y_out[9] y_out[8] y_out[7] y_out[6]
+ y_out[5] y_out[4] y_out[3] y_out[2] y_out[1] y_out[0] n30 i_rst_n
+ FE_OFN35_i_rst_n FE_OFN30_i_rst_n FE_OFN21_i_rst_n FE_OFN47_s11_0
+ FE_OFN48_h11_3 FE_OFN49_h11_2 FE_OFN50_h12_3 FE_OFN51_h12_2 FE_OFN52_h13_3
+ FE_OFN53_h13_2 FE_OFN82_mac_in_real_0 FE_OFN97_h11_3
+ FE_OFN104_FE_OFN232_s11_1 clk_clone2 clk clk_clone1
XFE_PHC1315_next_acc_0 DELB $PINS O=FE_PHN1315_next_acc_0 I=next_acc[0]
XFE_PHC1272_N235 DELB $PINS O=FE_PHN1272_N235 I=N235
XFE_PHC1254_N237 DELB $PINS O=FE_PHN1254_N237 I=N237
XFE_PHC1251_N236 DELB $PINS O=N236 I=FE_PHN1251_N236
XFE_PHC1243_N239 DELB $PINS O=FE_PHN1243_N239 I=N239
XFE_PHC1242_N242 DELB $PINS O=FE_PHN1242_N242 I=N242
XFE_PHC1241_N238 DELB $PINS O=FE_PHN1241_N238 I=N238
XFE_PHC1237_N240 DELB $PINS O=FE_PHN1237_N240 I=N240
XFE_PHC1229_N244 DELB $PINS O=FE_PHN1229_N244 I=N244
XFE_PHC1212_N245 DELB $PINS O=FE_PHN1212_N245 I=N245
XFE_PHC1210_N241 DELB $PINS O=FE_PHN1210_N241 I=N241
XFE_PHC1206_N249 DELB $PINS O=FE_PHN1206_N249 I=N249
XFE_PHC1202_N243 DELB $PINS O=FE_PHN1202_N243 I=N243
XFE_PHC1197_N248 DELB $PINS O=FE_PHN1197_N248 I=N248
XFE_PHC1194_N250 DELB $PINS O=FE_PHN1194_N250 I=N250
XFE_PHC1193_N246 DELB $PINS O=FE_PHN1193_N246 I=N246
XFE_PHC1180_N247 DELC $PINS O=FE_PHN1180_N247 I=N247
XFE_PHC1125_pe_r1_7 DELC $PINS O=y_out[7] I=FE_PHN1125_pe_r1_7
XFE_PHC1121_pe_r1_5 DELC $PINS O=y_out[5] I=FE_PHN1121_pe_r1_5
XFE_PHC978_acc_reg_15 DELB $PINS O=FE_PHN978_acc_reg_15 I=acc_reg[15]
XFE_PHC773_N251 DELC $PINS O=FE_PHN773_N251 I=N251
XFE_RC_762_0 INV3CK $PINS O=sll_16/ML_int[1][2] I=FE_RN_363_0
XFE_RC_761_0 MXL2HS $PINS OB=FE_RN_363_0 S=shf1[0] A=term1_in[2] B=term1_in[1]
XFE_RC_750_0 INV1S $PINS O=FE_RN_357_0 I=n29
XFE_RC_749_0 AN2B1T $PINS O=term3_shifted[5] I1=sll_18/ML_int[3][5]
+ B1=FE_RN_357_0
XFE_RC_634_0 INV2 $PINS O=sll_16/ML_int[1][1] I=FE_RN_308_0
XFE_RC_633_0 MXL2HS $PINS OB=FE_RN_308_0 S=shf1[0] A=FE_RN_121_0 B=term1_in[0]
XFE_RC_627_0 AO22P $PINS O=N45 A1=term1_shifted[4] A2=n88 B1=N18 B2=sign1[0]
XFE_RC_626_0 AN2B1T $PINS O=term3_shifted[3] I1=sll_18/ML_int[2][3] B1=n126
XFE_RC_579_0 AN2T $PINS O=term3_shifted[4] I1=sll_18/ML_int[3][4] I2=n29
XFE_RC_218_0 INV2 $PINS O=FE_RN_125_1 I=sll_18/ML_int[2][4]
XFE_RC_217_0 OAI12H $PINS O=sll_18/ML_int[3][4] A1=FE_RN_93_0 B1=FE_RN_125_1
+ B2=shf3[2]
XFE_RC_216_0 AN3B2S $PINS O=term2_shifted[0] I1=sll_17/ML_int[1][0] B1=n115
+ B2=shf2[1]
XFE_RC_215_0 INV2 $PINS O=N44 I=FE_RN_124_0
XFE_RC_214_0 AOI22H $PINS O=FE_RN_124_0 A1=N17 A2=sign1[0] B1=term1_shifted[3]
+ B2=n88
XFE_RC_213_0 INV4 $PINS O=sll_16/ML_int[2][2] I=FE_RN_123_0
XFE_RC_212_0 MXL2H $PINS OB=FE_RN_123_0 S=shf1[1] A=sll_16/ML_int[1][2]
+ B=sll_16/ML_int[1][0]
XFE_RC_210_0 MXL2H $PINS OB=FE_RN_122_0 S=shf2[0] A=term2_in[1] B=term2_in[0]
XFE_RC_209_0 OR2T $PINS O=n114 I1=FE_RN_122_0 I2=shf2[1]
XFE_RC_208_0 NR2T $PINS O=FE_RN_121_0 I1=sign1[1] I2=n151
XFE_RC_160_0 INV2CK $PINS O=N151 I=FE_RN_94_1
XFE_RC_159_0 OAI12HS $PINS O=FE_RN_94_1 A1=term3_shifted[0] B1=FE_OFN125_s13_0
+ B2=n36
XFE_RC_1605_0 MUXB2P $PINS O=term3_shifted[2] S=shf3[1] A=sll_18/ML_int[1][2]
+ B=sll_18/ML_int[1][0] EB=n126
XFE_RC_1594_0 OR2 $PINS O=n115 I1=shf2[2] I2=FE_RN_1
XFE_RC_1557_0 INV1S $PINS O=FE_RN_355_0 I=n54
XFE_RC_1556_0 AN2B1S $PINS O=term2_shifted[5] I1=sll_17/ML_int[3][5]
+ B1=FE_RN_355_0
XFE_RC_1490_0 INV2 $PINS O=N155 I=FE_RN_317_0
XFE_RC_1489_0 AOI22S $PINS O=FE_RN_317_0 A1=N128 A2=FE_OFN125_s13_0
+ B1=term3_shifted[4] B2=n36
XFE_RC_1397_0 INV2CK $PINS O=FE_RN_259_0 I=sll_16/ML_int[2][4]
XFE_RC_1396_0 MXL2HS $PINS OB=sll_16/ML_int[3][4] S=FE_RN_3 A=FE_RN_259_0
+ B=n102
XFE_RC_1348_0 INV1S $PINS O=FE_RN_236_0 I=FE_OFN345_h11_3
XFE_RC_1347_0 AN2B1T $PINS O=term1_shifted[5] I1=sll_16/ML_int[3][5]
+ B1=FE_RN_236_0
XFE_RC_1333_0 MUXB2 $PINS O=term2_shifted[2] S=shf2[1] A=sll_17/ML_int[1][2]
+ B=sll_17/ML_int[1][0] EB=n115
XFE_RC_1332_0 ND2 $PINS O=FE_RN_228_0 I1=N72 I2=FE_OFN335_s12_0
XFE_RC_1331_0 OR3B1 $PINS O=FE_RN_229_0 I1=n115 I2=n116 B1=n62
XFE_RC_1330_0 ND2 $PINS O=N99 I1=FE_RN_228_0 I2=FE_RN_229_0
XFE_RC_1297_0 ND2 $PINS O=FE_RN_209_0 I1=N125 I2=FE_OFN125_s13_0
XFE_RC_1296_0 OR3B1 $PINS O=FE_RN_210_0 I1=n126 I2=n125 B1=n36
XFE_RC_1295_0 ND2P $PINS O=N152 I1=FE_RN_209_0 I2=FE_RN_210_0
XFE_RC_1229_0 NR3 $PINS O=FE_RN_99_0 I1=shf1[1] I2=sign1[1] I3=FE_RN_4
XFE_RC_1226_0 ND2 $PINS O=FE_RN_172_0 I1=N15 I2=sign1[0]
XFE_RC_1225_0 OR3B1 $PINS O=FE_RN_173_0 I1=n104 I2=n103 B1=n88
XFE_RC_1224_0 ND2P $PINS O=N42 I1=FE_RN_172_0 I2=FE_RN_173_0
XFE_RC_1141_0 ND2 $PINS O=FE_RN_125_0 I1=n6 I2=n88
XFE_RC_1140_0 ND2P $PINS O=FE_RN_126_0 I1=N16 I2=sign1[0]
XFE_RC_1139_0 ND2P $PINS O=N43 I1=FE_RN_126_0 I2=FE_RN_125_0
XFE_RC_1084_0 INV1S $PINS O=FE_RN_98_0 I=shf1[0]
XFE_RC_1081_0 ND2P $PINS O=n102 I1=FE_RN_99_0 I2=FE_RN_98_0
XFE_RC_1069_0 ND2 $PINS O=FE_RN_93_0 I1=n129 I2=shf3[2]
XFE_RC_1033_0 INV2CK $PINS O=FE_RN_72_0 I=FE_RN_3
XFE_RC_1032_0 INV1S $PINS O=FE_RN_73_0 I=n108
XFE_RC_1030_0 ND2S $PINS O=FE_RN_75_0 I1=sll_16/ML_int[2][5] I2=FE_RN_72_0
XFE_RC_1029_0 OAI12HS $PINS O=sll_16/ML_int[3][5] A1=FE_RN_75_0 B1=FE_RN_73_0
+ B2=FE_RN_72_0
XFE_RC_1007_0 INV1S $PINS O=FE_RN_58_0 I=shf2[2]
XFE_RC_1006_0 INV1S $PINS O=FE_RN_59_0 I=n118
XFE_RC_1005_0 INV1S $PINS O=FE_RN_60_0 I=shf2[2]
XFE_RC_1004_0 ND2P $PINS O=FE_RN_61_0 I1=sll_17/ML_int[2][4] I2=FE_RN_60_0
XFE_RC_1003_0 OAI12H $PINS O=sll_17/ML_int[3][4] A1=FE_RN_61_0 B1=FE_RN_59_0
+ B2=FE_RN_58_0
XFE_RC_12_0 OA12 $PINS O=N41 A1=N14 B1=sign1[0] B2=n88
XFE_RC_1_0 OA12 $PINS O=N96 A1=term2_shifted[0] B1=FE_OFN335_s12_0 B2=n62
XFE_OFC700_h11_3 BUF1 $PINS O=FE_RN_6 I=FE_OFN48_h11_3
XFE_OFC697_h13_2 BUF1 $PINS O=FE_OFN357_h13_2 I=shf3[2]
XFE_OFC695_h13_2 INV1S $PINS O=FE_RN_5 I=shf3[2]
XFE_OFC694_h13_2 INV1S $PINS O=n25 I=shf3[2]
XFE_OFC681_mac_in_real_0 INV3 $PINS O=FE_RN_4 I=FE_OFN82_mac_in_real_0
XFE_OFC666_h11_3 INV1S $PINS O=FE_OFN345_h11_3 I=FE_OFN48_h11_3
XFE_OFC660_mac_in_real_1 INV4 $PINS O=n151 I=x_in[1]
XFE_OFC650_s12_0 INV1S $PINS O=FE_OFN336_s12_0 I=FE_OFN124_s12_0
XFE_OFC649_s12_0 INV2 $PINS O=FE_OFN335_s12_0 I=n62
XFE_OFC646_s12_0 INV1S $PINS O=FE_OFN334_s12_0 I=sign2[0]
XFE_OFC645_s12_0 INV1S $PINS O=FE_OFN124_s12_0 I=sign2[0]
XFE_OFC644_s12_0 INV2 $PINS O=n62 I=sign2[0]
XFE_OFC613_n36 INV2 $PINS O=FE_OFN125_s13_0 I=n36
XFE_OFC590_sll_17_ML_int_2__3 INV1S $PINS O=n116 I=sll_17/ML_int[2][3]
XFE_OFC579_sll_16_ML_int_2__3 INV2 $PINS O=n105 I=sll_16/ML_int[2][3]
XFE_OFC549_h11_2 INV1S $PINS O=FE_RN_3 I=FE_OFN49_h11_2
XFE_OFC526_mac_in_real_2 INV2 $PINS O=n150 I=x_in[2]
XFE_OFC488_n36 BUF1 $PINS O=FE_OFN279_n36 I=n36
XFE_OFC484_h13_0 BUF1 $PINS O=FE_OFN275_h13_0 I=shf3[0]
XFE_OFC427_h11_1 INV1S $PINS O=FE_DBTN185_h11_1 I=shf1[1]
XFE_OFC365_h13_2 BUF1 $PINS O=FE_OFN198_h13_2 I=FE_OFN357_h13_2
XFE_OFC346_h13_1 INV2 $PINS O=FE_DBTN184_h13_1 I=shf3[1]
XFE_OFC327_h13_3 BUF1 $PINS O=FE_RN_2 I=shf3[3]
XFE_OFC326_h13_3 INV1S $PINS O=n29 I=shf3[3]
XFE_OFC318_h12_0 INV1S $PINS O=n42 I=shf2[0]
XFE_OFC307_s12_1 BUF2 $PINS O=FE_OFN177_s12_1 I=sign2[1]
XFE_OFC306_s12_1 INV1S $PINS O=n4 I=sign2[1]
XFE_OFC304_h12_3 INV1S $PINS O=n54 I=FE_RN_1
XFE_OFC302_h12_3 BUF1 $PINS O=FE_RN_1 I=shf2[3]
XFE_OFC290_pe_clear_d1 INV1CK $PINS O=n153 I=clear
XFE_OFC251_h11_2 BUF1 $PINS O=FE_OFN167_h11_2 I=FE_RN_3
XFE_OFC216_s11_0 INV2 $PINS O=n88 I=sign1[0]
XFE_OFC153_s13_0 INV2 $PINS O=n36 I=sign3[0]
XU110 AO22 $PINS O=base_val[13] A1=acc_reg[13] A2=n153 B1=clear B2=n30
XU115 AO22 $PINS O=N67 A1=FE_OFN47_s11_0 A2=N40 B1=term1_shifted[26] B2=n88
XU116 AO22 $PINS O=N66 A1=N39 A2=FE_OFN47_s11_0 B1=term1_shifted[25] B2=n88
XU117 AO22 $PINS O=N65 A1=N38 A2=FE_OFN47_s11_0 B1=term1_shifted[24] B2=n88
XU118 AO22 $PINS O=N64 A1=N37 A2=FE_OFN47_s11_0 B1=term1_shifted[23] B2=n88
XU119 AO22 $PINS O=N63 A1=N36 A2=FE_OFN47_s11_0 B1=term1_shifted[22] B2=n88
XU120 AO22 $PINS O=N62 A1=N35 A2=FE_OFN47_s11_0 B1=term1_shifted[21] B2=n88
XU122 AO22 $PINS O=N60 A1=N33 A2=FE_OFN47_s11_0 B1=term1_shifted[19] B2=n88
XU123 AO22 $PINS O=N59 A1=N32 A2=FE_OFN47_s11_0 B1=term1_shifted[18] B2=n88
XU124 AO22 $PINS O=N58 A1=N31 A2=FE_OFN47_s11_0 B1=term1_shifted[17] B2=n88
XU125 AO22 $PINS O=N57 A1=N30 A2=sign1[0] B1=term1_shifted[16] B2=n88
XU126 AO22 $PINS O=N56 A1=N29 A2=sign1[0] B1=term1_shifted[15] B2=n88
XU127 AO22 $PINS O=N55 A1=N28 A2=sign1[0] B1=term1_shifted[14] B2=n88
XU128 AO22 $PINS O=N54 A1=N27 A2=sign1[0] B1=term1_shifted[13] B2=n88
XU129 AO22 $PINS O=N53 A1=N26 A2=sign1[0] B1=term1_shifted[12] B2=n88
XU130 AO22 $PINS O=N52 A1=N25 A2=sign1[0] B1=term1_shifted[11] B2=n88
XU131 AO22 $PINS O=N51 A1=N24 A2=sign1[0] B1=term1_shifted[10] B2=n88
XU132 AO22 $PINS O=N50 A1=N23 A2=sign1[0] B1=term1_shifted[9] B2=n88
XU136 AO22P $PINS O=N46 A1=N19 A2=sign1[0] B1=term1_shifted[5] B2=n88
XU142 AO22 $PINS O=N177 A1=sign3[0] A2=N150 B1=term3_shifted[26]
+ B2=FE_OFN279_n36
XU143 AO22 $PINS O=N176 A1=N149 A2=sign3[0] B1=term3_shifted[25]
+ B2=FE_OFN279_n36
XU144 AO22 $PINS O=N175 A1=N148 A2=sign3[0] B1=term3_shifted[24]
+ B2=FE_OFN279_n36
XU145 AO22 $PINS O=N174 A1=N147 A2=sign3[0] B1=term3_shifted[23]
+ B2=FE_OFN279_n36
XU146 AO22 $PINS O=N173 A1=N146 A2=sign3[0] B1=term3_shifted[22]
+ B2=FE_OFN279_n36
XU147 AO22 $PINS O=N172 A1=N145 A2=sign3[0] B1=term3_shifted[21]
+ B2=FE_OFN279_n36
XU149 AO22 $PINS O=N170 A1=N143 A2=sign3[0] B1=term3_shifted[19]
+ B2=FE_OFN279_n36
XU150 AO22 $PINS O=N169 A1=N142 A2=sign3[0] B1=term3_shifted[18]
+ B2=FE_OFN279_n36
XU151 AO22 $PINS O=N168 A1=N141 A2=sign3[0] B1=term3_shifted[17]
+ B2=FE_OFN279_n36
XU152 AO22 $PINS O=N167 A1=N140 A2=sign3[0] B1=term3_shifted[16]
+ B2=FE_OFN279_n36
XU153 AO22 $PINS O=N166 A1=N139 A2=sign3[0] B1=term3_shifted[15]
+ B2=FE_OFN279_n36
XU154 AO22 $PINS O=N165 A1=N138 A2=sign3[0] B1=term3_shifted[14]
+ B2=FE_OFN279_n36
XU155 AO22 $PINS O=N164 A1=N137 A2=sign3[0] B1=term3_shifted[13]
+ B2=FE_OFN279_n36
XU156 AO22 $PINS O=N163 A1=N136 A2=sign3[0] B1=term3_shifted[12]
+ B2=FE_OFN279_n36
XU157 AO22 $PINS O=N162 A1=N135 A2=sign3[0] B1=term3_shifted[11]
+ B2=FE_OFN279_n36
XU158 AO22 $PINS O=N161 A1=N134 A2=sign3[0] B1=term3_shifted[10] B2=n36
XU159 AO22 $PINS O=N160 A1=N133 A2=FE_OFN125_s13_0 B1=term3_shifted[9] B2=n36
XU162 AO22 $PINS O=N157 A1=N130 A2=FE_OFN125_s13_0 B1=term3_shifted[6] B2=n36
XU163 AO22 $PINS O=N156 A1=N129 A2=FE_OFN125_s13_0 B1=term3_shifted[5] B2=n36
XU169 AO22 $PINS O=N122 A1=N95 A2=sign2[0] B1=term2_shifted[26]
+ B2=FE_OFN334_s12_0
XU170 AO22 $PINS O=N121 A1=N94 A2=sign2[0] B1=term2_shifted[25]
+ B2=FE_OFN334_s12_0
XU171 AO22 $PINS O=N120 A1=N93 A2=sign2[0] B1=term2_shifted[24]
+ B2=FE_OFN334_s12_0
XU172 AO22 $PINS O=N119 A1=N92 A2=sign2[0] B1=term2_shifted[23]
+ B2=FE_OFN334_s12_0
XU173 AO22 $PINS O=N118 A1=N91 A2=sign2[0] B1=term2_shifted[22]
+ B2=FE_OFN334_s12_0
XU174 AO22 $PINS O=N117 A1=N90 A2=sign2[0] B1=term2_shifted[21]
+ B2=FE_OFN334_s12_0
XU175 AO22 $PINS O=N116 A1=N89 A2=sign2[0] B1=term2_shifted[20]
+ B2=FE_OFN334_s12_0
XU176 AO22 $PINS O=N115 A1=N88 A2=sign2[0] B1=term2_shifted[19]
+ B2=FE_OFN334_s12_0
XU177 AO22 $PINS O=N114 A1=N87 A2=FE_OFN336_s12_0 B1=term2_shifted[18]
+ B2=FE_OFN124_s12_0
XU178 AO22 $PINS O=N113 A1=N86 A2=FE_OFN336_s12_0 B1=term2_shifted[17]
+ B2=FE_OFN124_s12_0
XU179 AO22 $PINS O=N112 A1=N85 A2=FE_OFN336_s12_0 B1=term2_shifted[16]
+ B2=FE_OFN124_s12_0
XU180 AO22 $PINS O=N111 A1=N84 A2=FE_OFN336_s12_0 B1=term2_shifted[15]
+ B2=FE_OFN124_s12_0
XU181 AO22 $PINS O=N110 A1=N83 A2=FE_OFN336_s12_0 B1=term2_shifted[14]
+ B2=FE_OFN124_s12_0
XU182 AO22 $PINS O=N109 A1=N82 A2=FE_OFN336_s12_0 B1=term2_shifted[13]
+ B2=FE_OFN124_s12_0
XU183 AO22 $PINS O=N108 A1=N81 A2=FE_OFN335_s12_0 B1=term2_shifted[12] B2=n62
XU184 AO22 $PINS O=N107 A1=N80 A2=FE_OFN335_s12_0 B1=term2_shifted[11] B2=n62
XU185 AO22 $PINS O=N106 A1=N79 A2=FE_OFN335_s12_0 B1=term2_shifted[10] B2=n62
XU186 AO22 $PINS O=N105 A1=N78 A2=FE_OFN335_s12_0 B1=term2_shifted[9] B2=n62
XU187 AO22 $PINS O=N104 A1=N77 A2=FE_OFN335_s12_0 B1=term2_shifted[8] B2=n62
XU189 AO22 $PINS O=N102 A1=N75 A2=FE_OFN335_s12_0 B1=term2_shifted[6] B2=n62
XU190 AO22 $PINS O=N101 A1=N74 A2=FE_OFN335_s12_0 B1=term2_shifted[5] B2=n62
XU191 AO22P $PINS O=N100 A1=N73 A2=FE_OFN335_s12_0 B1=term2_shifted[4] B2=n62
Xsll_18/M1_0_1 MUX2 $PINS O=sll_18/ML_int[1][1] S=shf3[0] A=term3_in[1]
+ B=term3_in[0]
Xsll_18/M1_0_5 MUX2 $PINS O=sll_18/ML_int[1][5] S=shf3[0] A=term3_in[5]
+ B=term3_in[4]
Xsll_18/M1_0_6 MUX2 $PINS O=sll_18/ML_int[1][6] S=shf3[0] A=term3_in[6]
+ B=term3_in[5]
Xsll_18/M1_0_7 MUX2 $PINS O=sll_18/ML_int[1][7] S=shf3[0] A=term3_in[7]
+ B=term3_in[6]
Xsll_18/M1_0_8 MUX2 $PINS O=sll_18/ML_int[1][8] S=shf3[0] A=term3_in[8]
+ B=term3_in[7]
Xsll_18/M1_1_2 MUX2 $PINS O=sll_18/ML_int[2][2] S=shf3[1] A=sll_18/ML_int[1][2]
+ B=sll_18/ML_int[1][0]
Xsll_18/M1_1_8 MUX2 $PINS O=sll_18/ML_int[2][8] S=shf3[1] A=sll_18/ML_int[1][8]
+ B=sll_18/ML_int[1][6]
Xsll_18/M1_1_9 MUX2 $PINS O=sll_18/ML_int[2][9] S=shf3[1] A=sll_18/ML_int[1][9]
+ B=sll_18/ML_int[1][7]
Xsll_18/M1_2_5 MUX2 $PINS O=sll_18/ML_int[3][5] S=FE_OFN357_h13_2
+ A=sll_18/ML_int[2][5] B=n130
Xsll_18/M1_2_6 MUX2 $PINS O=sll_18/ML_int[3][6] S=FE_OFN357_h13_2
+ A=sll_18/ML_int[2][6] B=sll_18/ML_int[2][2]
Xsll_18/M1_2_7 MUX2 $PINS O=sll_18/ML_int[3][7] S=FE_OFN357_h13_2
+ A=sll_18/ML_int[2][7] B=sll_18/ML_int[2][3]
Xsll_18/M1_2_8 MUX2 $PINS O=sll_18/ML_int[3][8] S=FE_OFN357_h13_2
+ A=sll_18/ML_int[2][8] B=sll_18/ML_int[2][4]
Xsll_18/M1_2_9 MUX2 $PINS O=sll_18/ML_int[3][9] S=FE_OFN357_h13_2
+ A=sll_18/ML_int[2][9] B=sll_18/ML_int[2][5]
Xsll_18/M1_2_11 MUX2 $PINS O=sll_18/ML_int[3][11] S=FE_OFN357_h13_2
+ A=sll_18/ML_int[2][11] B=sll_18/ML_int[2][7]
Xsll_18/M1_3_8 MUX2 $PINS O=term3_shifted[8] S=shf3[3] A=sll_18/ML_int[3][8]
+ B=sll_18/ML_int[3][0]
Xsll_18/M1_3_9 MUX2 $PINS O=term3_shifted[9] S=shf3[3] A=sll_18/ML_int[3][9]
+ B=sll_18/ML_int[3][1]
Xsll_18/M1_3_10 MUX2 $PINS O=term3_shifted[10] S=shf3[3] A=sll_18/ML_int[3][10]
+ B=sll_18/ML_int[3][2]
Xsll_18/M1_3_11 MUX2 $PINS O=term3_shifted[11] S=shf3[3] A=sll_18/ML_int[3][11]
+ B=sll_18/ML_int[3][3]
Xsll_18/M1_3_12 MUX2 $PINS O=term3_shifted[12] S=shf3[3] A=sll_18/ML_int[3][12]
+ B=sll_18/ML_int[3][4]
Xsll_18/M1_3_13 MUX2 $PINS O=term3_shifted[13] S=shf3[3] A=sll_18/ML_int[3][13]
+ B=sll_18/ML_int[3][5]
Xsll_18/M1_3_15 MUX2 $PINS O=term3_shifted[15] S=shf3[3] A=sll_18/ML_int[3][15]
+ B=sll_18/ML_int[3][7]
Xsll_17/M1_0_1 MUX2 $PINS O=sll_17/ML_int[1][1] S=shf2[0] A=term2_in[1]
+ B=term2_in[0]
Xsll_17/M1_0_3 MUX2 $PINS O=sll_17/ML_int[1][3] S=shf2[0] A=term2_in[3]
+ B=term2_in[2]
Xsll_17/M1_0_4 MUX2 $PINS O=sll_17/ML_int[1][4] S=shf2[0] A=term2_in[4]
+ B=term2_in[3]
Xsll_17/M1_0_6 MUX2 $PINS O=sll_17/ML_int[1][6] S=shf2[0] A=term2_in[6]
+ B=term2_in[5]
Xsll_17/M1_0_7 MUX2 $PINS O=sll_17/ML_int[1][7] S=shf2[0] A=term2_in[7]
+ B=term2_in[6]
Xsll_17/M1_1_2 MUX2 $PINS O=sll_17/ML_int[2][2] S=shf2[1] A=sll_17/ML_int[1][2]
+ B=sll_17/ML_int[1][0]
Xsll_17/M1_1_3 MUX2 $PINS O=sll_17/ML_int[2][3] S=shf2[1] A=sll_17/ML_int[1][3]
+ B=sll_17/ML_int[1][1]
Xsll_17/M1_1_4 MUX2 $PINS O=sll_17/ML_int[2][4] S=shf2[1] A=sll_17/ML_int[1][4]
+ B=sll_17/ML_int[1][2]
Xsll_17/M1_1_5 MUX2 $PINS O=sll_17/ML_int[2][5] S=shf2[1] A=sll_17/ML_int[1][5]
+ B=sll_17/ML_int[1][3]
Xsll_17/M1_1_6 MUX2 $PINS O=sll_17/ML_int[2][6] S=shf2[1] A=sll_17/ML_int[1][6]
+ B=sll_17/ML_int[1][4]
Xsll_17/M1_1_7 MUX2 $PINS O=sll_17/ML_int[2][7] S=shf2[1] A=sll_17/ML_int[1][7]
+ B=sll_17/ML_int[1][5]
Xsll_17/M1_2_5 MUX2 $PINS O=sll_17/ML_int[3][5] S=shf2[2] A=sll_17/ML_int[2][5]
+ B=n119
Xsll_17/M1_2_6 MUX2 $PINS O=sll_17/ML_int[3][6] S=shf2[2] A=sll_17/ML_int[2][6]
+ B=sll_17/ML_int[2][2]
Xsll_17/M1_2_7 MUX2 $PINS O=sll_17/ML_int[3][7] S=shf2[2] A=sll_17/ML_int[2][7]
+ B=sll_17/ML_int[2][3]
Xsll_17/M1_2_8 MUX2 $PINS O=sll_17/ML_int[3][8] S=shf2[2] A=sll_17/ML_int[2][8]
+ B=sll_17/ML_int[2][4]
Xsll_17/M1_2_9 MUX2 $PINS O=sll_17/ML_int[3][9] S=shf2[2] A=sll_17/ML_int[2][9]
+ B=sll_17/ML_int[2][5]
Xsll_17/M1_3_8 MUX2 $PINS O=term2_shifted[8] S=FE_RN_1 A=sll_17/ML_int[3][8]
+ B=sll_17/ML_int[3][0]
Xsll_17/M1_3_9 MUX2 $PINS O=term2_shifted[9] S=FE_RN_1 A=sll_17/ML_int[3][9]
+ B=sll_17/ML_int[3][1]
Xsll_17/M1_3_10 MUX2 $PINS O=term2_shifted[10] S=FE_RN_1 A=sll_17/ML_int[3][10]
+ B=sll_17/ML_int[3][2]
Xsll_17/M1_3_11 MUX2 $PINS O=term2_shifted[11] S=FE_RN_1 A=sll_17/ML_int[3][11]
+ B=sll_17/ML_int[3][3]
Xsll_17/M1_3_12 MUX2 $PINS O=term2_shifted[12] S=FE_RN_1 A=sll_17/ML_int[3][12]
+ B=sll_17/ML_int[3][4]
Xsll_17/M1_3_13 MUX2 $PINS O=term2_shifted[13] S=FE_RN_1 A=sll_17/ML_int[3][13]
+ B=sll_17/ML_int[3][5]
Xsll_16/M1_0_4 MUX2 $PINS O=sll_16/ML_int[1][4] S=shf1[0] A=term1_in[4]
+ B=term1_in[3]
Xsll_16/M1_0_5 MUX2 $PINS O=sll_16/ML_int[1][5] S=shf1[0] A=term1_in[5]
+ B=term1_in[4]
Xsll_16/M1_0_6 MUX2 $PINS O=sll_16/ML_int[1][6] S=shf1[0] A=term1_in[6]
+ B=term1_in[5]
Xsll_16/M1_0_7 MUX2 $PINS O=sll_16/ML_int[1][7] S=shf1[0] A=term1_in[7]
+ B=term1_in[6]
Xsll_16/M1_0_8 MUX2 $PINS O=sll_16/ML_int[1][8] S=shf1[0] A=term1_in[8]
+ B=term1_in[7]
Xsll_16/M1_1_5 MUX2 $PINS O=sll_16/ML_int[2][5] S=shf1[1] A=sll_16/ML_int[1][5]
+ B=sll_16/ML_int[1][3]
Xsll_16/M1_1_7 MUX2 $PINS O=sll_16/ML_int[2][7] S=shf1[1] A=sll_16/ML_int[1][7]
+ B=sll_16/ML_int[1][5]
Xsll_16/M1_1_8 MUX2 $PINS O=sll_16/ML_int[2][8] S=shf1[1] A=sll_16/ML_int[1][8]
+ B=sll_16/ML_int[1][6]
Xsll_16/M1_1_9 MUX2 $PINS O=sll_16/ML_int[2][9] S=shf1[1] A=sll_16/ML_int[1][9]
+ B=sll_16/ML_int[1][7]
Xsll_16/M1_2_6 MUX2 $PINS O=sll_16/ML_int[3][6] S=FE_RN_3 A=sll_16/ML_int[2][6]
+ B=sll_16/ML_int[2][2]
Xsll_16/M1_2_7 MUX2 $PINS O=sll_16/ML_int[3][7] S=FE_RN_3 A=sll_16/ML_int[2][7]
+ B=sll_16/ML_int[2][3]
Xsll_16/M1_2_8 MUX2 $PINS O=sll_16/ML_int[3][8] S=FE_RN_3 A=sll_16/ML_int[2][8]
+ B=sll_16/ML_int[2][4]
Xsll_16/M1_2_9 MUX2 $PINS O=sll_16/ML_int[3][9] S=FE_OFN167_h11_2
+ A=sll_16/ML_int[2][9] B=sll_16/ML_int[2][5]
Xsll_16/M1_2_10 MUX2 $PINS O=sll_16/ML_int[3][10] S=FE_OFN167_h11_2
+ A=sll_16/ML_int[2][10] B=sll_16/ML_int[2][6]
Xsll_16/M1_2_11 MUX2 $PINS O=sll_16/ML_int[3][11] S=FE_OFN167_h11_2
+ A=sll_16/ML_int[2][11] B=sll_16/ML_int[2][7]
Xsll_16/M1_3_8 MUX2 $PINS O=term1_shifted[8] S=FE_OFN48_h11_3
+ A=sll_16/ML_int[3][8] B=sll_16/ML_int[3][0]
Xsll_16/M1_3_9 MUX2 $PINS O=term1_shifted[9] S=FE_OFN48_h11_3
+ A=sll_16/ML_int[3][9] B=sll_16/ML_int[3][1]
Xsll_16/M1_3_10 MUX2 $PINS O=term1_shifted[10] S=FE_OFN48_h11_3
+ A=sll_16/ML_int[3][10] B=sll_16/ML_int[3][2]
Xsll_16/M1_3_11 MUX2 $PINS O=term1_shifted[11] S=FE_OFN48_h11_3
+ A=sll_16/ML_int[3][11] B=sll_16/ML_int[3][3]
Xsll_16/M1_3_12 MUX2 $PINS O=term1_shifted[12] S=FE_OFN48_h11_3
+ A=sll_16/ML_int[3][12] B=sll_16/ML_int[3][4]
Xsll_16/M1_3_13 MUX2 $PINS O=term1_shifted[13] S=FE_OFN48_h11_3
+ A=sll_16/ML_int[3][13] B=sll_16/ML_int[3][5]
Xsll_16/M1_3_14 MUX2 $PINS O=term1_shifted[14] S=FE_OFN48_h11_3
+ A=sll_16/ML_int[3][14] B=sll_16/ML_int[3][6]
Xsll_16/M1_3_15 MUX2 $PINS O=term1_shifted[15] S=FE_OFN48_h11_3
+ A=sll_16/ML_int[3][15] B=sll_16/ML_int[3][7]
Xy_out_reg[10] QDFFRBN $PINS Q=y_out[10] D=FE_PHN1212_N245 CK=net2258
+ RB=FE_OFN35_i_rst_n
Xy_out_reg[9] QDFFRBN $PINS Q=y_out[9] D=FE_PHN1229_N244 CK=net2258
+ RB=FE_OFN35_i_rst_n
Xy_out_reg[8] QDFFRBN $PINS Q=y_out[8] D=FE_PHN1202_N243 CK=net2258
+ RB=FE_OFN35_i_rst_n
Xy_out_reg[7] QDFFRBN $PINS Q=FE_PHN1125_pe_r1_7 D=FE_PHN1242_N242 CK=net2258
+ RB=FE_OFN35_i_rst_n
Xy_out_reg[6] QDFFRBN $PINS Q=y_out[6] D=FE_PHN1210_N241 CK=net2258
+ RB=FE_OFN35_i_rst_n
Xy_out_reg[5] QDFFRBN $PINS Q=FE_PHN1121_pe_r1_5 D=FE_PHN1237_N240 CK=net2258
+ RB=FE_OFN35_i_rst_n
Xy_out_reg[4] QDFFRBN $PINS Q=y_out[4] D=FE_PHN1243_N239 CK=net2258
+ RB=FE_OFN35_i_rst_n
Xy_out_reg[3] QDFFRBN $PINS Q=y_out[3] D=FE_PHN1241_N238 CK=net2258
+ RB=FE_OFN35_i_rst_n
Xy_out_reg[2] QDFFRBN $PINS Q=y_out[2] D=FE_PHN1254_N237 CK=net2258
+ RB=FE_OFN35_i_rst_n
Xy_out_reg[1] QDFFRBN $PINS Q=y_out[1] D=N236 CK=net2258 RB=FE_OFN35_i_rst_n
Xy_out_reg[0] QDFFRBN $PINS Q=y_out[0] D=FE_PHN1272_N235 CK=net2258
+ RB=FE_OFN35_i_rst_n
Xacc_reg_reg[26] QDFFRBP $PINS Q=N251 D=next_acc[26] CK=clk_clone2
+ RB=FE_OFN21_i_rst_n
Xacc_reg_reg[25] QDFFRBN $PINS Q=acc_reg[25] D=next_acc[25] CK=clk_clone2
+ RB=FE_OFN35_i_rst_n
Xacc_reg_reg[24] QDFFRBN $PINS Q=acc_reg[24] D=next_acc[24] CK=clk_clone2
+ RB=FE_OFN35_i_rst_n
Xacc_reg_reg[23] QDFFRBN $PINS Q=acc_reg[23] D=next_acc[23] CK=clk_clone2
+ RB=FE_OFN35_i_rst_n
Xacc_reg_reg[22] QDFFRBN $PINS Q=acc_reg[22] D=next_acc[22] CK=clk_clone2
+ RB=FE_OFN35_i_rst_n
Xacc_reg_reg[21] QDFFRBN $PINS Q=acc_reg[21] D=next_acc[21] CK=clk_clone2
+ RB=FE_OFN35_i_rst_n
Xacc_reg_reg[20] QDFFRBN $PINS Q=acc_reg[20] D=next_acc[20] CK=clk_clone2
+ RB=FE_OFN30_i_rst_n
Xacc_reg_reg[19] QDFFRBN $PINS Q=acc_reg[19] D=next_acc[19] CK=clk_clone2
+ RB=FE_OFN30_i_rst_n
Xacc_reg_reg[18] QDFFRBN $PINS Q=acc_reg[18] D=next_acc[18] CK=clk RB=i_rst_n
Xacc_reg_reg[17] QDFFRBN $PINS Q=acc_reg[17] D=next_acc[17] CK=clk RB=i_rst_n
Xacc_reg_reg[16] QDFFRBN $PINS Q=acc_reg[16] D=next_acc[16] CK=clk RB=i_rst_n
Xacc_reg_reg[15] QDFFRBN $PINS Q=acc_reg[15] D=next_acc[15] CK=clk RB=i_rst_n
Xacc_reg_reg[14] QDFFRBN $PINS Q=acc_reg[14] D=next_acc[14] CK=clk RB=i_rst_n
Xacc_reg_reg[13] QDFFRBN $PINS Q=acc_reg[13] D=next_acc[13] CK=clk RB=i_rst_n
Xacc_reg_reg[12] QDFFRBN $PINS Q=acc_reg[12] D=next_acc[12] CK=clk RB=i_rst_n
Xacc_reg_reg[11] QDFFRBN $PINS Q=acc_reg[11] D=next_acc[11] CK=clk RB=i_rst_n
Xacc_reg_reg[10] QDFFRBN $PINS Q=acc_reg[10] D=next_acc[10] CK=clk RB=i_rst_n
Xacc_reg_reg[9] QDFFRBN $PINS Q=acc_reg[9] D=next_acc[9] CK=clk RB=i_rst_n
Xacc_reg_reg[8] QDFFRBN $PINS Q=acc_reg[8] D=next_acc[8] CK=clk RB=i_rst_n
Xacc_reg_reg[7] QDFFRBN $PINS Q=acc_reg[7] D=next_acc[7] CK=clk RB=i_rst_n
Xacc_reg_reg[6] QDFFRBN $PINS Q=acc_reg[6] D=next_acc[6] CK=clk RB=i_rst_n
Xacc_reg_reg[5] QDFFRBN $PINS Q=acc_reg[5] D=next_acc[5] CK=clk RB=i_rst_n
Xacc_reg_reg[4] QDFFRBN $PINS Q=acc_reg[4] D=next_acc[4] CK=clk RB=i_rst_n
Xacc_reg_reg[3] QDFFRBN $PINS Q=acc_reg[3] D=next_acc[3] CK=clk
+ RB=FE_OFN21_i_rst_n
Xacc_reg_reg[2] QDFFRBN $PINS Q=acc_reg[2] D=next_acc[2] CK=clk
+ RB=FE_OFN21_i_rst_n
Xacc_reg_reg[1] QDFFRBN $PINS Q=acc_reg[1] D=next_acc[1] CK=clk
+ RB=FE_OFN21_i_rst_n
Xacc_reg_reg[0] QDFFRBN $PINS Q=acc_reg[0] D=FE_PHN1315_next_acc_0 CK=clk
+ RB=FE_OFN21_i_rst_n
Xy_out_reg[16] QDFFRBN $PINS Q=y_out[16] D=FE_PHN773_N251 CK=net2258
+ RB=FE_OFN35_i_rst_n
Xy_out_reg[15] QDFFRBN $PINS Q=y_out[15] D=FE_PHN1194_N250 CK=net2258
+ RB=FE_OFN35_i_rst_n
Xy_out_reg[14] QDFFRBN $PINS Q=y_out[14] D=FE_PHN1206_N249 CK=net2258
+ RB=FE_OFN35_i_rst_n
Xy_out_reg[13] QDFFRBN $PINS Q=y_out[13] D=FE_PHN1197_N248 CK=net2258
+ RB=FE_OFN35_i_rst_n
Xy_out_reg[12] QDFFRBN $PINS Q=y_out[12] D=FE_PHN1180_N247 CK=net2258
+ RB=FE_OFN35_i_rst_n
Xy_out_reg[11] QDFFRBN $PINS Q=y_out[11] D=FE_PHN1193_N246 CK=net2258
+ RB=FE_OFN35_i_rst_n
XU7 MUX2 $PINS O=sll_16/ML_int[1][3] S=shf1[0] A=term1_in[3] B=term1_in[2]
XU9 NR2 $PINS O=term1_in[1] I1=sign1[1] I2=n151
XU11 NR2 $PINS O=term3_in[1] I1=sign3[1] I2=n151
XU13 NR2T $PINS O=term2_in[1] I1=FE_OFN177_s12_1 I2=n151
XU14 MUX2 $PINS O=sll_18/ML_int[1][2] S=shf3[0] A=term3_in[2] B=term3_in[1]
XU18 NR2 $PINS O=term3_in[0] I1=sign3[1] I2=FE_RN_4
XU19 ND3 $PINS O=n124 I1=term3_in[0] I2=FE_DBTN184_h13_1 I3=n17
XU21 MUX2 $PINS O=N248 S=n30 A=acc_reg[23] B=FE_PHN773_N251
XU23 MUX2 $PINS O=N249 S=n30 A=acc_reg[24] B=FE_PHN773_N251
XU25 NR2T $PINS O=term2_shifted[1] I1=n115 I2=n114
XU26 MUX2 $PINS O=N250 S=n30 A=acc_reg[25] B=FE_PHN773_N251
XU29 MUX2 $PINS O=sll_16/ML_int[2][3] S=shf1[1] A=sll_16/ML_int[1][3]
+ B=sll_16/ML_int[1][1]
XU30 MUX2 $PINS O=sll_16/ML_int[2][4] S=shf1[1] A=sll_16/ML_int[1][4]
+ B=sll_16/ML_int[1][2]
XU31 MUX2 $PINS O=sll_16/ML_int[2][6] S=shf1[1] A=sll_16/ML_int[1][6]
+ B=sll_16/ML_int[1][4]
XU34 NR2 $PINS O=term3_in[2] I1=sign3[1] I2=n150
XU36 INV2 $PINS O=n106 I=sll_16/ML_int[2][2]
XU38 MUX2 $PINS O=sll_17/ML_int[1][5] S=shf2[0] A=term2_in[5] B=term2_in[4]
XU39 MUX2 $PINS O=sll_18/ML_int[2][7] S=shf3[1] A=sll_18/ML_int[1][7]
+ B=sll_18/ML_int[1][5]
XU40 MUX2 $PINS O=sll_18/ML_int[2][6] S=shf3[1] A=sll_18/ML_int[1][6]
+ B=sll_18/ML_int[1][4]
XU41 MUX2 $PINS O=sll_18/ML_int[2][5] S=shf3[1] A=sll_18/ML_int[1][5]
+ B=sll_18/ML_int[1][3]
XU42 MUX2 $PINS O=sll_18/ML_int[2][4] S=shf3[1] A=sll_18/ML_int[1][4]
+ B=sll_18/ML_int[1][2]
XU43 MUX2 $PINS O=sll_18/ML_int[2][3] S=shf3[1] A=sll_18/ML_int[1][3]
+ B=sll_18/ML_int[1][1]
XU48 INV1S $PINS O=n117 I=sll_17/ML_int[2][2]
XU49 NR2T $PINS O=n6 I1=n104 I2=n106
XU60 NR2 $PINS O=term2_in[4] I1=FE_OFN177_s12_1 I2=x_in[4]
XU66 NR2T $PINS O=term3_shifted[1] I1=n126 I2=n125
XU67 NR2 $PINS O=term1_shifted[0] I1=n104 I2=n102
XU68 NR2P $PINS O=term3_shifted[0] I1=n126 I2=n124
XU70 INV1S $PINS O=n127 I=sll_18/ML_int[2][3]
XU74 NR2 $PINS O=term2_shifted[3] I1=n115 I2=n116
XU77 AO22P $PINS O=N98 A1=N71 A2=FE_OFN335_s12_0 B1=term2_shifted[2] B2=n62
XU79 AO22 $PINS O=N153 A1=N126 A2=FE_OFN125_s13_0 B1=term3_shifted[2] B2=n36
XU80 AO22 $PINS O=N103 A1=N76 A2=FE_OFN335_s12_0 B1=term2_shifted[7] B2=n62
XU81 AN2 $PINS O=base_val[7] I1=acc_reg[7] I2=n153
XU82 AO22 $PINS O=N159 A1=N132 A2=FE_OFN125_s13_0 B1=term3_shifted[8] B2=n36
XU83 AO22 $PINS O=N49 A1=N22 A2=sign1[0] B1=term1_shifted[8] B2=n88
XU84 AO22 $PINS O=N171 A1=N144 A2=sign3[0] B1=term3_shifted[20]
+ B2=FE_OFN279_n36
XU85 AO22 $PINS O=N61 A1=N34 A2=FE_OFN47_s11_0 B1=term1_shifted[20] B2=n88
XU92 MUX2 $PINS O=sll_17/ML_int[1][2] S=shf2[0] A=term2_in[2] B=term2_in[1]
XU93 AO22 $PINS O=N97 A1=N70 A2=FE_OFN335_s12_0 B1=term2_shifted[1] B2=n62
XU94 AO22P $PINS O=N154 A1=N127 A2=FE_OFN125_s13_0 B1=term3_shifted[3] B2=n36
XU96 AO22 $PINS O=N48 A1=N21 A2=sign1[0] B1=term1_shifted[7] B2=n88
XU97 AO22 $PINS O=N158 A1=N131 A2=FE_OFN125_s13_0 B1=term3_shifted[7] B2=n36
XU98 AN2 $PINS O=sll_17/ML_int[1][0] I1=n5 I2=FE_OFN82_mac_in_real_0
XU100 NR2 $PINS O=n1 I1=n142 I2=sign1[1]
XU101 MUX2S $PINS O=n112 S=shf1[0] A=term1_in[26] B=term1_in[15]
XU102 NR2 $PINS O=n2 I1=n142 I2=FE_OFN177_s12_1
XU103 MUX2S $PINS O=n123 S=shf2[0] A=term2_in[26] B=term2_in[15]
XU104 NR2 $PINS O=n3 I1=n142 I2=sign3[1]
XU112 AN2 $PINS O=n5 I1=n4 I2=n42
XU134 MUX2 $PINS O=sll_17/ML_int[2][8] S=shf2[1] A=sll_17/ML_int[1][8]
+ B=sll_17/ML_int[1][6]
XU139 MUX2S $PINS O=sll_17/ML_int[1][8] S=shf2[0] A=term2_in[8] B=term2_in[7]
XU140 MUX2S $PINS O=sll_18/ML_int[1][9] S=shf3[0] A=term3_in[9] B=term3_in[8]
XU141 MUX2S $PINS O=sll_16/ML_int[1][9] S=shf1[0] A=term1_in[9] B=term1_in[8]
XU148 MUX2S $PINS O=sll_17/ML_int[2][9] S=shf2[1] A=sll_17/ML_int[1][9]
+ B=sll_17/ML_int[1][7]
XU160 MUX2S $PINS O=sll_17/ML_int[1][9] S=shf2[0] A=term2_in[9] B=term2_in[8]
XU165 MUX2S $PINS O=sll_18/ML_int[2][10] S=shf3[1] A=sll_18/ML_int[1][10]
+ B=sll_18/ML_int[1][8]
XU166 MUX2S $PINS O=sll_18/ML_int[1][10] S=FE_OFN275_h13_0 A=term3_in[10]
+ B=term3_in[9]
XU167 MUX2S $PINS O=sll_18/ML_int[3][10] S=FE_OFN357_h13_2
+ A=sll_18/ML_int[2][10] B=sll_18/ML_int[2][6]
XU188 MUX2S $PINS O=sll_16/ML_int[2][10] S=shf1[1] A=sll_16/ML_int[1][10]
+ B=sll_16/ML_int[1][8]
XU192 MUX2S $PINS O=sll_16/ML_int[1][10] S=shf1[0] A=term1_in[10] B=term1_in[9]
XU193 MUX2S $PINS O=sll_17/ML_int[2][10] S=shf2[1] A=sll_17/ML_int[1][10]
+ B=sll_17/ML_int[1][8]
XU194 MUX2S $PINS O=sll_17/ML_int[1][10] S=shf2[0] A=term2_in[10] B=term2_in[9]
XU195 MUX2S $PINS O=sll_17/ML_int[3][10] S=FE_OFN51_h12_2
+ A=sll_17/ML_int[2][10] B=sll_17/ML_int[2][6]
XU196 MUX2S $PINS O=sll_18/ML_int[2][11] S=shf3[1] A=sll_18/ML_int[1][11]
+ B=sll_18/ML_int[1][9]
XU197 MUX2S $PINS O=sll_18/ML_int[1][11] S=shf3[0] A=term3_in[11]
+ B=term3_in[10]
XU198 MUX2S $PINS O=sll_16/ML_int[2][11] S=shf1[1] A=sll_16/ML_int[1][11]
+ B=sll_16/ML_int[1][9]
XU199 MUX2S $PINS O=sll_16/ML_int[1][11] S=shf1[0] A=term1_in[11]
+ B=term1_in[10]
XU200 MUX2S $PINS O=sll_17/ML_int[2][11] S=shf2[1] A=sll_17/ML_int[1][11]
+ B=sll_17/ML_int[1][9]
XU201 MUX2S $PINS O=sll_17/ML_int[3][11] S=shf2[2] A=sll_17/ML_int[2][11]
+ B=sll_17/ML_int[2][7]
XU202 MUX2S $PINS O=sll_17/ML_int[1][11] S=shf2[0] A=term2_in[11]
+ B=term2_in[10]
XU203 MUX2S $PINS O=sll_18/ML_int[2][12] S=shf3[1] A=sll_18/ML_int[1][12]
+ B=sll_18/ML_int[1][10]
XU204 MUX2S $PINS O=sll_18/ML_int[3][12] S=FE_OFN357_h13_2
+ A=sll_18/ML_int[2][12] B=sll_18/ML_int[2][8]
XU205 MUX2S $PINS O=sll_18/ML_int[1][12] S=FE_OFN275_h13_0 A=term3_in[12]
+ B=term3_in[11]
XU206 MUX2S $PINS O=sll_16/ML_int[2][12] S=shf1[1] A=sll_16/ML_int[1][12]
+ B=sll_16/ML_int[1][10]
XU207 MUX2S $PINS O=sll_16/ML_int[3][12] S=FE_OFN167_h11_2
+ A=sll_16/ML_int[2][12] B=sll_16/ML_int[2][8]
XU208 MUX2S $PINS O=sll_16/ML_int[1][12] S=shf1[0] A=term1_in[12]
+ B=term1_in[11]
XU209 MUX2S $PINS O=sll_17/ML_int[2][12] S=shf2[1] A=sll_17/ML_int[1][12]
+ B=sll_17/ML_int[1][10]
XU210 MUX2S $PINS O=sll_17/ML_int[3][12] S=FE_OFN51_h12_2
+ A=sll_17/ML_int[2][12] B=sll_17/ML_int[2][8]
XU211 MUX2S $PINS O=sll_17/ML_int[1][12] S=shf2[0] A=term2_in[12]
+ B=term2_in[11]
XU212 MUX2S $PINS O=sll_18/ML_int[2][13] S=shf3[1] A=sll_18/ML_int[1][13]
+ B=sll_18/ML_int[1][11]
XU213 MUX2S $PINS O=sll_18/ML_int[3][13] S=FE_OFN198_h13_2
+ A=sll_18/ML_int[2][13] B=sll_18/ML_int[2][9]
XU214 MUX2S $PINS O=sll_18/ML_int[1][13] S=FE_OFN275_h13_0 A=term3_in[13]
+ B=term3_in[12]
XU215 MUX2S $PINS O=sll_16/ML_int[2][13] S=shf1[1] A=sll_16/ML_int[1][13]
+ B=sll_16/ML_int[1][11]
XU216 MUX2S $PINS O=sll_16/ML_int[3][13] S=FE_OFN167_h11_2
+ A=sll_16/ML_int[2][13] B=sll_16/ML_int[2][9]
XU217 MUX2S $PINS O=sll_16/ML_int[1][13] S=shf1[0] A=term1_in[13]
+ B=term1_in[12]
XU218 MUX2S $PINS O=sll_17/ML_int[2][13] S=shf2[1] A=sll_17/ML_int[1][13]
+ B=sll_17/ML_int[1][11]
XU219 MUX2S $PINS O=sll_17/ML_int[3][13] S=FE_OFN51_h12_2
+ A=sll_17/ML_int[2][13] B=sll_17/ML_int[2][9]
XU220 MUX2S $PINS O=sll_17/ML_int[1][13] S=shf2[0] A=term2_in[13]
+ B=term2_in[12]
XU221 MUX2S $PINS O=term3_shifted[14] S=shf3[3] A=sll_18/ML_int[3][14]
+ B=sll_18/ML_int[3][6]
XU222 MUX2S $PINS O=sll_18/ML_int[2][14] S=shf3[1] A=sll_18/ML_int[1][14]
+ B=sll_18/ML_int[1][12]
XU223 MUX2S $PINS O=sll_18/ML_int[3][14] S=FE_OFN198_h13_2
+ A=sll_18/ML_int[2][14] B=sll_18/ML_int[2][10]
XU224 MUX2S $PINS O=sll_18/ML_int[1][14] S=FE_OFN275_h13_0 A=term3_in[14]
+ B=term3_in[13]
XU225 MUX2S $PINS O=sll_16/ML_int[2][14] S=shf1[1] A=sll_16/ML_int[1][14]
+ B=sll_16/ML_int[1][12]
XU226 MUX2S $PINS O=sll_16/ML_int[3][14] S=FE_OFN167_h11_2
+ A=sll_16/ML_int[2][14] B=sll_16/ML_int[2][10]
XU227 MUX2S $PINS O=sll_16/ML_int[1][14] S=shf1[0] A=term1_in[14]
+ B=term1_in[13]
XU228 MUX2S $PINS O=term2_shifted[14] S=FE_RN_1 A=sll_17/ML_int[3][14]
+ B=sll_17/ML_int[3][6]
XU229 MUX2S $PINS O=sll_17/ML_int[2][14] S=shf2[1] A=sll_17/ML_int[1][14]
+ B=sll_17/ML_int[1][12]
XU230 MUX2S $PINS O=sll_17/ML_int[3][14] S=FE_OFN51_h12_2
+ A=sll_17/ML_int[2][14] B=sll_17/ML_int[2][10]
XU231 MUX2S $PINS O=sll_17/ML_int[1][14] S=shf2[0] A=term2_in[14]
+ B=term2_in[13]
XU232 MUX2S $PINS O=term1_shifted[16] S=FE_RN_6 A=sll_16/ML_int[3][16]
+ B=sll_16/ML_int[3][8]
XU233 MUX2S $PINS O=n109 S=shf1[1] A=n112 B=sll_16/ML_int[1][14]
XU234 MUX2S $PINS O=term3_shifted[16] S=FE_RN_2 A=sll_18/ML_int[3][16]
+ B=sll_18/ML_int[3][8]
XU235 MUX2S $PINS O=n131 S=shf3[1] A=n134 B=sll_18/ML_int[1][14]
XU236 MUX2S $PINS O=term2_shifted[16] S=FE_RN_1 A=sll_17/ML_int[3][16]
+ B=sll_17/ML_int[3][8]
XU237 MUX2S $PINS O=n120 S=shf2[1] A=n123 B=sll_17/ML_int[1][14]
XU238 MUX2S $PINS O=sll_18/ML_int[3][15] S=FE_OFN198_h13_2
+ A=sll_18/ML_int[2][15] B=sll_18/ML_int[2][11]
XU239 MUX2S $PINS O=sll_18/ML_int[2][15] S=shf3[1] A=sll_18/ML_int[1][15]
+ B=sll_18/ML_int[1][13]
XU240 MUX2S $PINS O=sll_18/ML_int[1][15] S=FE_OFN275_h13_0 A=term3_in[15]
+ B=term3_in[14]
XU241 MUX2S $PINS O=sll_16/ML_int[3][15] S=FE_OFN167_h11_2
+ A=sll_16/ML_int[2][15] B=sll_16/ML_int[2][11]
XU242 MUX2S $PINS O=sll_16/ML_int[2][15] S=shf1[1] A=sll_16/ML_int[1][15]
+ B=sll_16/ML_int[1][13]
XU243 MUX2S $PINS O=sll_16/ML_int[1][15] S=shf1[0] A=term1_in[15]
+ B=term1_in[14]
XU244 MUX2S $PINS O=term2_shifted[15] S=FE_RN_1 A=sll_17/ML_int[3][15]
+ B=sll_17/ML_int[3][7]
XU245 MUX2S $PINS O=sll_17/ML_int[3][15] S=FE_OFN51_h12_2
+ A=sll_17/ML_int[2][15] B=sll_17/ML_int[2][11]
XU246 MUX2S $PINS O=sll_17/ML_int[2][15] S=shf2[1] A=sll_17/ML_int[1][15]
+ B=sll_17/ML_int[1][13]
XU247 MUX2S $PINS O=sll_17/ML_int[1][15] S=shf2[0] A=term2_in[15]
+ B=term2_in[14]
XU248 MUX2S $PINS O=term1_shifted[17] S=FE_RN_6 A=sll_16/ML_int[3][17]
+ B=sll_16/ML_int[3][9]
XU249 MUX2S $PINS O=term3_shifted[17] S=FE_RN_2 A=sll_18/ML_int[3][17]
+ B=sll_18/ML_int[3][9]
XU250 MUX2S $PINS O=term2_shifted[17] S=FE_RN_1 A=sll_17/ML_int[3][17]
+ B=sll_17/ML_int[3][9]
XU251 MUX2S $PINS O=term1_shifted[18] S=FE_RN_6 A=sll_16/ML_int[3][18]
+ B=sll_16/ML_int[3][10]
XU252 MUX2S $PINS O=term3_shifted[18] S=FE_RN_2 A=sll_18/ML_int[3][18]
+ B=sll_18/ML_int[3][10]
XU253 MUX2S $PINS O=term2_shifted[18] S=FE_RN_1 A=sll_17/ML_int[3][18]
+ B=sll_17/ML_int[3][10]
XU257 MUX2S $PINS O=sll_16/ML_int[3][16] S=FE_OFN167_h11_2 A=n109
+ B=sll_16/ML_int[2][12]
XU258 MUX2S $PINS O=n134 S=FE_OFN275_h13_0 A=term3_in[26] B=term3_in[15]
XU259 MUX2S $PINS O=sll_18/ML_int[3][16] S=FE_OFN198_h13_2 A=n131
+ B=sll_18/ML_int[2][12]
XU260 MUX2S $PINS O=sll_17/ML_int[3][16] S=FE_OFN51_h12_2 A=n120
+ B=sll_17/ML_int[2][12]
XU261 MUX2S $PINS O=n110 S=shf1[1] A=n1 B=sll_16/ML_int[1][15]
XU262 MUX2S $PINS O=sll_16/ML_int[3][17] S=FE_OFN167_h11_2 A=n110
+ B=sll_16/ML_int[2][13]
XU263 MUX2S $PINS O=n132 S=shf3[1] A=n3 B=sll_18/ML_int[1][15]
XU264 MUX2S $PINS O=sll_18/ML_int[3][17] S=FE_OFN198_h13_2 A=n132
+ B=sll_18/ML_int[2][13]
XU265 MUX2S $PINS O=n121 S=shf2[1] A=n2 B=sll_17/ML_int[1][15]
XU266 MUX2S $PINS O=sll_17/ML_int[3][17] S=FE_OFN51_h12_2 A=n121
+ B=sll_17/ML_int[2][13]
XU267 MUX2S $PINS O=n111 S=FE_DBTN185_h11_1 A=n112 B=term1_in[26]
XU268 MUX2S $PINS O=sll_16/ML_int[3][18] S=FE_OFN167_h11_2 A=n111
+ B=sll_16/ML_int[2][14]
XU269 MUX2S $PINS O=n133 S=FE_DBTN184_h13_1 A=n134 B=term3_in[26]
XU270 MUX2S $PINS O=sll_18/ML_int[3][18] S=FE_OFN198_h13_2 A=n133
+ B=sll_18/ML_int[2][14]
XU271 MUX2S $PINS O=n122 S=n45 A=n123 B=term2_in[26]
XU272 MUX2S $PINS O=sll_17/ML_int[3][18] S=FE_OFN51_h12_2 A=n122
+ B=sll_17/ML_int[2][14]
XU274 MUX2S $PINS O=term1_shifted[20] S=FE_RN_6 A=sll_16/ML_int[3][20]
+ B=sll_16/ML_int[3][12]
XU275 MUX2S $PINS O=sll_16/ML_int[3][20] S=FE_OFN167_h11_2 A=term1_in[26]
+ B=n109
XU276 MUX2S $PINS O=term1_shifted[19] S=FE_RN_6 A=sll_16/ML_int[3][19]
+ B=sll_16/ML_int[3][11]
XU277 MUX2S $PINS O=sll_16/ML_int[3][19] S=FE_OFN167_h11_2 A=n1
+ B=sll_16/ML_int[2][15]
XU278 MUX2S $PINS O=term3_shifted[20] S=FE_RN_2 A=sll_18/ML_int[3][20]
+ B=sll_18/ML_int[3][12]
XU279 MUX2S $PINS O=sll_18/ML_int[3][20] S=FE_OFN198_h13_2 A=term3_in[26]
+ B=n131
XU280 MUX2S $PINS O=term3_shifted[19] S=FE_RN_2 A=sll_18/ML_int[3][19]
+ B=sll_18/ML_int[3][11]
XU281 MUX2S $PINS O=sll_18/ML_int[3][19] S=FE_OFN198_h13_2 A=n3
+ B=sll_18/ML_int[2][15]
XU282 MUX2S $PINS O=term2_shifted[20] S=FE_RN_1 A=sll_17/ML_int[3][20]
+ B=sll_17/ML_int[3][12]
XU283 MUX2S $PINS O=sll_17/ML_int[3][20] S=FE_OFN51_h12_2 A=term2_in[26] B=n120
XU284 MUX2S $PINS O=term2_shifted[19] S=FE_RN_1 A=sll_17/ML_int[3][19]
+ B=sll_17/ML_int[3][11]
XU285 MUX2S $PINS O=sll_17/ML_int[3][19] S=FE_OFN51_h12_2 A=n2
+ B=sll_17/ML_int[2][15]
XU287 MUX2S $PINS O=term1_shifted[21] S=FE_RN_6 A=sll_16/ML_int[3][21]
+ B=sll_16/ML_int[3][13]
XU288 MUX2S $PINS O=sll_16/ML_int[3][21] S=FE_OFN167_h11_2 A=n1 B=n110
XU289 MUX2S $PINS O=term3_shifted[21] S=FE_RN_2 A=sll_18/ML_int[3][21]
+ B=sll_18/ML_int[3][13]
XU290 MUX2S $PINS O=sll_18/ML_int[3][21] S=FE_OFN198_h13_2 A=n3 B=n132
XU291 MUX2S $PINS O=term2_shifted[21] S=shf2[3] A=sll_17/ML_int[3][21]
+ B=sll_17/ML_int[3][13]
XU292 MUX2S $PINS O=sll_17/ML_int[3][21] S=FE_OFN51_h12_2 A=n2 B=n121
XU293 MUX2S $PINS O=term1_shifted[22] S=FE_RN_6 A=sll_16/ML_int[3][22]
+ B=sll_16/ML_int[3][14]
XU294 MUX2S $PINS O=sll_16/ML_int[3][22] S=FE_OFN167_h11_2 A=term1_in[26]
+ B=n111
XU295 MUX2S $PINS O=term3_shifted[22] S=FE_RN_2 A=sll_18/ML_int[3][22]
+ B=sll_18/ML_int[3][14]
XU296 MUX2S $PINS O=sll_18/ML_int[3][22] S=FE_OFN198_h13_2 A=term3_in[26]
+ B=n133
XU297 MUX2S $PINS O=term2_shifted[22] S=shf2[3] A=sll_17/ML_int[3][22]
+ B=sll_17/ML_int[3][14]
XU298 MUX2S $PINS O=sll_17/ML_int[3][22] S=FE_OFN51_h12_2 A=term2_in[26] B=n122
XU300 MUX2S $PINS O=term1_shifted[24] S=FE_RN_6 A=term1_in[26]
+ B=sll_16/ML_int[3][16]
XU301 MUX2S $PINS O=term3_shifted[24] S=FE_RN_2 A=term3_in[26]
+ B=sll_18/ML_int[3][16]
XU302 MUX2S $PINS O=term2_shifted[24] S=shf2[3] A=term2_in[26]
+ B=sll_17/ML_int[3][16]
XU303 MUX2S $PINS O=term3_shifted[23] S=FE_RN_2 A=n3 B=sll_18/ML_int[3][15]
XU304 MUX2S $PINS O=term1_shifted[23] S=FE_RN_6 A=n1 B=sll_16/ML_int[3][15]
XU305 MUX2S $PINS O=term2_shifted[23] S=shf2[3] A=n2 B=sll_17/ML_int[3][15]
XU306 MUX2S $PINS O=term1_shifted[25] S=FE_RN_6 A=n1 B=sll_16/ML_int[3][17]
XU307 MUX2S $PINS O=term3_shifted[25] S=FE_RN_2 A=n3 B=sll_18/ML_int[3][17]
XU308 MUX2S $PINS O=term2_shifted[25] S=shf2[3] A=n2 B=sll_17/ML_int[3][17]
XU309 MUX2S $PINS O=term1_shifted[26] S=FE_RN_6 A=term1_in[26]
+ B=sll_16/ML_int[3][18]
XU310 MUX2S $PINS O=term3_shifted[26] S=FE_RN_2 A=term3_in[26]
+ B=sll_18/ML_int[3][18]
XU311 MUX2S $PINS O=term2_shifted[26] S=shf2[3] A=term2_in[26]
+ B=sll_17/ML_int[3][18]
XU313 AN2S $PINS O=base_val[6] I1=acc_reg[6] I2=n153
XU315 ND2S $PINS O=n154 I1=FE_PHN773_N251 I2=n30
XU316 MUX2S $PINS O=N235 S=n30 A=acc_reg[10] B=acc_reg[14]
XU317 MUX2S $PINS O=N244 S=n30 A=acc_reg[19] B=acc_reg[23]
XU330 NR2 $PINS O=term1_in[3] I1=sign1[1] I2=x_in[3]
XU331 NR2 $PINS O=term2_in[2] I1=FE_OFN177_s12_1 I2=n150
XU332 NR2 $PINS O=term3_in[3] I1=sign3[1] I2=x_in[3]
XU333 NR2 $PINS O=term2_in[3] I1=FE_OFN177_s12_1 I2=x_in[3]
XU334 NR2 $PINS O=term1_in[4] I1=sign1[1] I2=x_in[4]
XU336 NR2 $PINS O=term3_in[4] I1=sign3[1] I2=x_in[4]
XU337 INV1S $PINS O=n129 I=n124
XU338 INV1S $PINS O=n118 I=n113
XU339 NR2 $PINS O=term1_in[5] I1=sign1[1] I2=x_in[5]
XU340 NR2 $PINS O=term3_in[5] I1=sign3[1] I2=x_in[5]
XU341 INV1S $PINS O=n130 I=n125
XU342 NR2 $PINS O=term2_in[5] I1=FE_OFN177_s12_1 I2=x_in[5]
XU343 INV1S $PINS O=n119 I=n114
XU344 NR2 $PINS O=term1_in[7] I1=sign1[1] I2=x_in[7]
XU345 NR2 $PINS O=term3_in[7] I1=sign3[1] I2=x_in[7]
XU346 NR2 $PINS O=term1_in[6] I1=sign1[1] I2=x_in[6]
XU347 NR2 $PINS O=term3_in[6] I1=sign3[1] I2=x_in[6]
XU348 NR2 $PINS O=term2_in[7] I1=FE_OFN177_s12_1 I2=x_in[7]
XU349 NR2 $PINS O=term2_in[6] I1=FE_OFN177_s12_1 I2=x_in[6]
XU351 NR2 $PINS O=term1_in[8] I1=sign1[1] I2=x_in[8]
XU352 NR2 $PINS O=term3_in[8] I1=sign3[1] I2=x_in[8]
XU354 NR2 $PINS O=term2_in[8] I1=FE_OFN177_s12_1 I2=x_in[8]
XU356 NR2 $PINS O=term1_in[9] I1=sign1[1] I2=x_in[9]
XU357 NR2 $PINS O=term3_in[9] I1=sign3[1] I2=x_in[9]
XU358 NR2 $PINS O=term2_in[9] I1=FE_OFN177_s12_1 I2=x_in[9]
XU359 NR2 $PINS O=term1_in[10] I1=sign1[1] I2=x_in[10]
XU360 NR2 $PINS O=term3_in[10] I1=sign3[1] I2=x_in[10]
XU361 NR2 $PINS O=term2_in[10] I1=FE_OFN177_s12_1 I2=x_in[10]
XU362 NR2 $PINS O=term1_in[11] I1=sign1[1] I2=x_in[11]
XU363 NR2 $PINS O=term3_in[11] I1=sign3[1] I2=x_in[11]
XU364 NR2 $PINS O=term2_in[11] I1=FE_OFN177_s12_1 I2=x_in[11]
XU365 NR2 $PINS O=term1_in[12] I1=sign1[1] I2=x_in[12]
XU366 NR2 $PINS O=term3_in[12] I1=sign3[1] I2=x_in[12]
XU368 NR2 $PINS O=term2_in[12] I1=FE_OFN177_s12_1 I2=x_in[12]
XU372 NR2 $PINS O=term1_in[13] I1=sign1[1] I2=x_in[13]
XU373 NR2 $PINS O=term3_in[13] I1=sign3[1] I2=x_in[13]
XU374 NR2 $PINS O=term2_in[13] I1=FE_OFN177_s12_1 I2=x_in[13]
XU375 NR2 $PINS O=term1_in[14] I1=sign1[1] I2=n140
XU376 NR2 $PINS O=term3_in[14] I1=sign3[1] I2=n140
XU377 NR2 $PINS O=term2_in[14] I1=FE_OFN177_s12_1 I2=n140
XU383 NR2 $PINS O=term1_in[15] I1=sign1[1] I2=n141
XU384 NR2 $PINS O=term3_in[15] I1=sign3[1] I2=n141
XU385 NR2 $PINS O=term2_in[15] I1=FE_OFN177_s12_1 I2=n141
XU398 INV1S $PINS O=n68 I=shf1[0]
XU401 INV1S $PINS O=n17 I=shf3[0]
XU403 INV1S $PINS O=n45 I=shf2[1]
XU413 INV1S $PINS O=n140 I=x_in[14]
XU418 INV1S $PINS O=n141 I=x_in[15]
XU419 INV1S $PINS O=n142 I=x_in[16]
XU420 NR2 $PINS O=term1_in[26] I1=n142 I2=sign1[1]
XU421 NR2 $PINS O=term3_in[26] I1=n142 I2=sign3[1]
XU422 NR2 $PINS O=term2_in[26] I1=n142 I2=FE_OFN177_s12_1
XU423 AN2 $PINS O=base_val[26] I1=N251 I2=n153
XU424 AN2 $PINS O=base_val[1] I1=acc_reg[1] I2=n153
XU425 MOAI1S $PINS O=base_val[9] A1=n30 A2=n153 B1=acc_reg[9] B2=n153
XU426 AN2 $PINS O=base_val[10] I1=acc_reg[10] I2=n153
XU427 AN2 $PINS O=base_val[8] I1=acc_reg[8] I2=n153
XU428 AN2 $PINS O=base_val[5] I1=acc_reg[5] I2=n153
XU429 AN2 $PINS O=base_val[4] I1=acc_reg[4] I2=n153
XU430 AN2 $PINS O=base_val[3] I1=acc_reg[3] I2=n153
XU431 AN2 $PINS O=base_val[2] I1=acc_reg[2] I2=n153
XU432 AN2 $PINS O=base_val[11] I1=acc_reg[11] I2=n153
XU433 AN2 $PINS O=base_val[12] I1=acc_reg[12] I2=n153
XU434 AN2 $PINS O=base_val[14] I1=acc_reg[14] I2=n153
XU435 AN2 $PINS O=base_val[15] I1=acc_reg[15] I2=n153
XU436 AN2 $PINS O=base_val[16] I1=acc_reg[16] I2=n153
XU437 AN2 $PINS O=base_val[17] I1=acc_reg[17] I2=n153
XU438 AN2 $PINS O=base_val[18] I1=acc_reg[18] I2=n153
XU439 AN2 $PINS O=base_val[19] I1=acc_reg[19] I2=n153
XU440 AN2 $PINS O=base_val[20] I1=acc_reg[20] I2=n153
XU441 AN2 $PINS O=base_val[21] I1=acc_reg[21] I2=n153
XU442 AN2 $PINS O=base_val[22] I1=acc_reg[22] I2=n153
XU443 AN2 $PINS O=base_val[23] I1=acc_reg[23] I2=n153
XU444 AN2 $PINS O=base_val[24] I1=acc_reg[24] I2=n153
XU445 AN2 $PINS O=base_val[25] I1=acc_reg[25] I2=n153
XU446 AN2 $PINS O=base_val[0] I1=acc_reg[0] I2=n153
XU452 AN2 $PINS O=N234 I1=en I2=calc_done
XU453 OAI12HS $PINS O=N247 A1=n154 B1=n30 B2=n135
XU454 INV1S $PINS O=n135 I=acc_reg[22]
XU457 INV1S $PINS O=n108 I=n103
XU460 ND2P $PINS O=n125 I1=sll_18/ML_int[1][1] I2=FE_DBTN184_h13_1
XU461 NR2 $PINS O=sll_16/ML_int[3][0] I1=FE_RN_3 I2=n102
XU462 NR2 $PINS O=sll_16/ML_int[3][1] I1=FE_RN_3 I2=n103
XU463 NR2 $PINS O=sll_16/ML_int[3][2] I1=FE_RN_3 I2=n106
XU464 NR2 $PINS O=sll_16/ML_int[3][3] I1=FE_RN_3 I2=n105
XU465 ND2P $PINS O=n104 I1=FE_OFN49_h11_2 I2=FE_OFN345_h11_3
XU466 NR2P $PINS O=term1_shifted[3] I1=n104 I2=n105
XU467 AN2T $PINS O=term1_shifted[4] I1=sll_16/ML_int[3][4] I2=FE_OFN345_h11_3
XU469 AN2 $PINS O=term1_shifted[6] I1=sll_16/ML_int[3][6] I2=FE_OFN345_h11_3
XU470 AN2 $PINS O=term1_shifted[7] I1=sll_16/ML_int[3][7] I2=FE_OFN345_h11_3
XU471 ND2 $PINS O=n113 I1=sll_17/ML_int[1][0] I2=n45
XU472 NR2 $PINS O=sll_17/ML_int[3][0] I1=shf2[2] I2=n113
XU473 NR2 $PINS O=sll_17/ML_int[3][1] I1=shf2[2] I2=n114
XU474 NR2 $PINS O=sll_17/ML_int[3][2] I1=shf2[2] I2=n117
XU475 NR2 $PINS O=sll_17/ML_int[3][3] I1=shf2[2] I2=n116
XU476 AN2 $PINS O=term2_shifted[4] I1=n54 I2=sll_17/ML_int[3][4]
XU478 AN2 $PINS O=term2_shifted[6] I1=sll_17/ML_int[3][6] I2=n54
XU479 AN2 $PINS O=term2_shifted[7] I1=sll_17/ML_int[3][7] I2=n54
XU480 AN2 $PINS O=sll_18/ML_int[1][0] I1=term3_in[0] I2=n17
XU481 NR2 $PINS O=sll_18/ML_int[3][0] I1=shf3[2] I2=n124
XU482 NR2 $PINS O=sll_18/ML_int[3][1] I1=FE_OFN357_h13_2 I2=n125
XU484 NR2 $PINS O=sll_18/ML_int[3][3] I1=FE_OFN357_h13_2 I2=n127
XU485 ND2P $PINS O=n126 I1=FE_RN_5 I2=n29
XU489 AN2 $PINS O=term3_shifted[6] I1=sll_18/ML_int[3][6] I2=n29
XU490 AN2 $PINS O=term3_shifted[7] I1=sll_18/ML_int[3][7] I2=n29
XU491 MUX2 $PINS O=N245 S=n30 A=acc_reg[20] B=acc_reg[24]
XU492 MUX2 $PINS O=N246 S=n30 A=acc_reg[21] B=acc_reg[25]
XU493 MUX2 $PINS O=FE_PHN1251_N236 S=n30 A=acc_reg[11] B=FE_PHN978_acc_reg_15
XU494 MUX2 $PINS O=N237 S=n30 A=acc_reg[12] B=acc_reg[16]
XU495 MUX2 $PINS O=N238 S=n30 A=acc_reg[13] B=acc_reg[17]
XU496 MUX2 $PINS O=N239 S=n30 A=acc_reg[14] B=acc_reg[18]
XU497 MUX2 $PINS O=N240 S=n30 A=FE_PHN978_acc_reg_15 B=acc_reg[19]
XU498 MUX2 $PINS O=N241 S=n30 A=acc_reg[16] B=acc_reg[20]
XU499 MUX2 $PINS O=N242 S=n30 A=acc_reg[17] B=acc_reg[21]
XU500 MUX2 $PINS O=N243 S=n30 A=acc_reg[18] B=acc_reg[22]
Xclk_gate_y_out_reg SNPS_CLOCK_GATE_HIGH_PE_Shift_Add_5 $PINS EN=N234
+ ENCLK=net2258 CLK=clk_clone1
Xsub_28_3 PE_Shift_Add_5_DW01_sub_0_DW01_sub_15 $PINS A[26]=net44382
+ A[25]=net44382 A[24]=net44382 A[23]=net44382 A[22]=net44382 A[21]=net44382
+ A[20]=net44382 A[19]=net44382 A[18]=net44382 A[17]=net44382 A[16]=net44382
+ A[15]=net44382 A[14]=net44382 A[13]=net44382 A[12]=net44382 A[11]=net44382
+ A[10]=net44382 A[9]=net44382 A[8]=net44382 A[7]=net44382 A[6]=net44382
+ A[5]=net44382 A[4]=net44382 A[3]=net44382 A[2]=net44382 A[1]=net44382
+ A[0]=net44382 B[26]=term3_shifted[26] B[25]=term3_shifted[25]
+ B[24]=term3_shifted[24] B[23]=term3_shifted[23] B[22]=term3_shifted[22]
+ B[21]=term3_shifted[21] B[20]=term3_shifted[20] B[19]=term3_shifted[19]
+ B[18]=term3_shifted[18] B[17]=term3_shifted[17] B[16]=term3_shifted[16]
+ B[15]=term3_shifted[15] B[14]=term3_shifted[14] B[13]=term3_shifted[13]
+ B[12]=term3_shifted[12] B[11]=term3_shifted[11] B[10]=term3_shifted[10]
+ B[9]=term3_shifted[9] B[8]=term3_shifted[8] B[7]=term3_shifted[7]
+ B[6]=term3_shifted[6] B[5]=term3_shifted[5] B[4]=term3_shifted[4]
+ B[3]=term3_shifted[3] B[2]=term3_shifted[2] B[1]=term3_shifted[1]
+ B[0]=term3_shifted[0] CI=net44382 DIFF[26]=N150 DIFF[25]=N149 DIFF[24]=N148
+ DIFF[23]=N147 DIFF[22]=N146 DIFF[21]=N145 DIFF[20]=N144 DIFF[19]=N143
+ DIFF[18]=N142 DIFF[17]=N141 DIFF[16]=N140 DIFF[15]=N139 DIFF[14]=N138
+ DIFF[13]=N137 DIFF[12]=N136 DIFF[11]=N135 DIFF[10]=N134 DIFF[9]=N133
+ DIFF[8]=N132 DIFF[7]=N131 DIFF[6]=N130 DIFF[5]=N129 DIFF[4]=N128 DIFF[3]=N127
+ DIFF[2]=N126 DIFF[1]=N125 DIFF[0]=N124
Xsub_28_2 PE_Shift_Add_5_DW01_sub_1_DW01_sub_16 $PINS A[26]=net44382
+ A[25]=net44382 A[24]=net44382 A[23]=net44382 A[22]=net44382 A[21]=net44382
+ A[20]=net44382 A[19]=net44382 A[18]=net44382 A[17]=net44382 A[16]=net44382
+ A[15]=net44382 A[14]=net44382 A[13]=net44382 A[12]=net44382 A[11]=net44382
+ A[10]=net44382 A[9]=net44382 A[8]=net44382 A[7]=net44382 A[6]=net44382
+ A[5]=net44382 A[4]=net44382 A[3]=net44382 A[2]=net44382 A[1]=net44382
+ A[0]=net44382 B[26]=term2_shifted[26] B[25]=term2_shifted[25]
+ B[24]=term2_shifted[24] B[23]=term2_shifted[23] B[22]=term2_shifted[22]
+ B[21]=term2_shifted[21] B[20]=term2_shifted[20] B[19]=term2_shifted[19]
+ B[18]=term2_shifted[18] B[17]=term2_shifted[17] B[16]=term2_shifted[16]
+ B[15]=term2_shifted[15] B[14]=term2_shifted[14] B[13]=term2_shifted[13]
+ B[12]=term2_shifted[12] B[11]=term2_shifted[11] B[10]=term2_shifted[10]
+ B[9]=term2_shifted[9] B[8]=term2_shifted[8] B[7]=term2_shifted[7]
+ B[6]=term2_shifted[6] B[5]=term2_shifted[5] B[4]=term2_shifted[4]
+ B[3]=term2_shifted[3] B[2]=term2_shifted[2] B[1]=term2_shifted[1]
+ B[0]=term2_shifted[0] CI=net44382 DIFF[26]=N95 DIFF[25]=N94 DIFF[24]=N93
+ DIFF[23]=N92 DIFF[22]=N91 DIFF[21]=N90 DIFF[20]=N89 DIFF[19]=N88 DIFF[18]=N87
+ DIFF[17]=N86 DIFF[16]=N85 DIFF[15]=N84 DIFF[14]=N83 DIFF[13]=N82 DIFF[12]=N81
+ DIFF[11]=N80 DIFF[10]=N79 DIFF[9]=N78 DIFF[8]=N77 DIFF[7]=N76 DIFF[6]=N75
+ DIFF[5]=N74 DIFF[4]=N73 DIFF[3]=N72 DIFF[2]=N71 DIFF[1]=N70 DIFF[0]=N69
Xsub_28 PE_Shift_Add_5_DW01_sub_2_DW01_sub_17 $PINS A[26]=net44382
+ A[25]=net44382 A[24]=net44382 A[23]=net44382 A[22]=net44382 A[21]=net44382
+ A[20]=net44382 A[19]=net44382 A[18]=net44382 A[17]=net44382 A[16]=net44382
+ A[15]=net44382 A[14]=net44382 A[13]=net44382 A[12]=net44382 A[11]=net44382
+ A[10]=net44382 A[9]=net44382 A[8]=net44382 A[7]=net44382 A[6]=net44382
+ A[5]=net44382 A[4]=net44382 A[3]=net44382 A[2]=net44382 A[1]=net44382
+ A[0]=net44382 B[26]=term1_shifted[26] B[25]=term1_shifted[25]
+ B[24]=term1_shifted[24] B[23]=term1_shifted[23] B[22]=term1_shifted[22]
+ B[21]=term1_shifted[21] B[20]=term1_shifted[20] B[19]=term1_shifted[19]
+ B[18]=term1_shifted[18] B[17]=term1_shifted[17] B[16]=term1_shifted[16]
+ B[15]=term1_shifted[15] B[14]=term1_shifted[14] B[13]=term1_shifted[13]
+ B[12]=term1_shifted[12] B[11]=term1_shifted[11] B[10]=term1_shifted[10]
+ B[9]=term1_shifted[9] B[8]=term1_shifted[8] B[7]=term1_shifted[7]
+ B[6]=term1_shifted[6] B[5]=term1_shifted[5] B[4]=term1_shifted[4]
+ B[3]=term1_shifted[3] B[2]=n6 B[1]=term1_shifted[1] B[0]=term1_shifted[0]
+ CI=net44382 DIFF[26]=N40 DIFF[25]=N39 DIFF[24]=N38 DIFF[23]=N37 DIFF[22]=N36
+ DIFF[21]=N35 DIFF[20]=N34 DIFF[19]=N33 DIFF[18]=N32 DIFF[17]=N31 DIFF[16]=N30
+ DIFF[15]=N29 DIFF[14]=N28 DIFF[13]=N27 DIFF[12]=N26 DIFF[11]=N25 DIFF[10]=N24
+ DIFF[9]=N23 DIFF[8]=N22 DIFF[7]=N21 DIFF[6]=N20 DIFF[5]=N19 DIFF[4]=N18
+ DIFF[3]=N17 DIFF[2]=N16 DIFF[1]=N15 DIFF[0]=N14
Xadd_1_root_add_0_root_add_28_3 PE_Shift_Add_5_DW01_add_2_DW01_add_22 $PINS
+ A[26]=N67 A[25]=N66 A[24]=N65 A[23]=N64 A[22]=N63 A[21]=N62 A[20]=N61 A[19]=N60
+ A[18]=N59 A[17]=N58 A[16]=N57 A[15]=N56 A[14]=N55 A[13]=N54 A[12]=N53 A[11]=N52
+ A[10]=N51 A[9]=N50 A[8]=N49 A[7]=N48 A[6]=N47 A[5]=N46 A[4]=N45 A[3]=N44
+ A[2]=N43 A[1]=N42 A[0]=N41 B[26]=N177 B[25]=N176 B[24]=N175 B[23]=N174
+ B[22]=N173 B[21]=N172 B[20]=N171 B[19]=N170 B[18]=N169 B[17]=N168 B[16]=N167
+ B[15]=N166 B[14]=N165 B[13]=N164 B[12]=N163 B[11]=N162 B[10]=N161 B[9]=N160
+ B[8]=N159 B[7]=N158 B[6]=N157 B[5]=N156 B[4]=N155 B[3]=N154 B[2]=N153 B[1]=N152
+ B[0]=N151 CI=net44382 SUM[26]=N204 SUM[25]=N203 SUM[24]=N202 SUM[23]=N201
+ SUM[22]=N200 SUM[21]=N199 SUM[20]=N198 SUM[19]=N197 SUM[18]=N196 SUM[17]=N195
+ SUM[16]=N194 SUM[15]=N193 SUM[14]=N192 SUM[13]=N191 SUM[12]=N190 SUM[11]=N189
+ SUM[10]=N188 SUM[9]=N187 SUM[8]=N186 SUM[7]=N185 SUM[6]=N184 SUM[5]=N183
+ SUM[4]=N182 SUM[3]=N181 SUM[2]=N180 SUM[1]=N179 SUM[0]=N178
Xadd_2_root_add_0_root_add_28_3 PE_Shift_Add_5_DW01_add_1_DW01_add_21 $PINS
+ A[26]=base_val[26] A[25]=base_val[25] A[24]=base_val[24] A[23]=base_val[23]
+ A[22]=base_val[22] A[21]=base_val[21] A[20]=base_val[20] A[19]=base_val[19]
+ A[18]=base_val[18] A[17]=base_val[17] A[16]=base_val[16] A[15]=base_val[15]
+ A[14]=base_val[14] A[13]=base_val[13] A[12]=base_val[12] A[11]=base_val[11]
+ A[10]=base_val[10] A[9]=base_val[9] A[8]=base_val[8] A[7]=base_val[7]
+ A[6]=base_val[6] A[5]=base_val[5] A[4]=base_val[4] A[3]=base_val[3]
+ A[2]=base_val[2] A[1]=base_val[1] A[0]=base_val[0] B[26]=N122 B[25]=N121
+ B[24]=N120 B[23]=N119 B[22]=N118 B[21]=N117 B[20]=N116 B[19]=N115 B[18]=N114
+ B[17]=N113 B[16]=N112 B[15]=N111 B[14]=N110 B[13]=N109 B[12]=N108 B[11]=N107
+ B[10]=N106 B[9]=N105 B[8]=N104 B[7]=N103 B[6]=N102 B[5]=N101 B[4]=N100 B[3]=N99
+ B[2]=N98 B[1]=N97 B[0]=N96 CI=net44382 SUM[26]=N231 SUM[25]=N230 SUM[24]=N229
+ SUM[23]=N228 SUM[22]=N227 SUM[21]=N226 SUM[20]=N225 SUM[19]=N224 SUM[18]=N223
+ SUM[17]=N222 SUM[16]=N221 SUM[15]=N220 SUM[14]=N219 SUM[13]=N218 SUM[12]=N217
+ SUM[11]=N216 SUM[10]=N215 SUM[9]=N214 SUM[8]=N213 SUM[7]=N212 SUM[6]=N211
+ SUM[5]=N210 SUM[4]=N209 SUM[3]=N208 SUM[2]=N207 SUM[1]=N206 SUM[0]=N205
Xadd_0_root_add_0_root_add_28_3 PE_Shift_Add_5_DW01_add_0_DW01_add_20 $PINS
+ A[26]=N204 A[25]=N203 A[24]=N202 A[23]=N201 A[22]=N200 A[21]=N199 A[20]=N198
+ A[19]=N197 A[18]=N196 A[17]=N195 A[16]=N194 A[15]=N193 A[14]=N192 A[13]=N191
+ A[12]=N190 A[11]=N189 A[10]=N188 A[9]=N187 A[8]=N186 A[7]=N185 A[6]=N184
+ A[5]=N183 A[4]=N182 A[3]=N181 A[2]=N180 A[1]=N179 A[0]=N178 B[26]=N231
+ B[25]=N230 B[24]=N229 B[23]=N228 B[22]=N227 B[21]=N226 B[20]=N225 B[19]=N224
+ B[18]=N223 B[17]=N222 B[16]=N221 B[15]=N220 B[14]=N219 B[13]=N218 B[12]=N217
+ B[11]=N216 B[10]=N215 B[9]=N214 B[8]=N213 B[7]=N212 B[6]=N211 B[5]=N210
+ B[4]=N209 B[3]=N208 B[2]=N207 B[1]=N206 B[0]=N205 CI=net44382
+ SUM[26]=next_acc[26] SUM[25]=next_acc[25] SUM[24]=next_acc[24]
+ SUM[23]=next_acc[23] SUM[22]=next_acc[22] SUM[21]=next_acc[21]
+ SUM[20]=next_acc[20] SUM[19]=next_acc[19] SUM[18]=next_acc[18]
+ SUM[17]=next_acc[17] SUM[16]=next_acc[16] SUM[15]=next_acc[15]
+ SUM[14]=next_acc[14] SUM[13]=next_acc[13] SUM[12]=next_acc[12]
+ SUM[11]=next_acc[11] SUM[10]=next_acc[10] SUM[9]=next_acc[9] SUM[8]=next_acc[8]
+ SUM[7]=next_acc[7] SUM[6]=next_acc[6] SUM[5]=next_acc[5] SUM[4]=next_acc[4]
+ SUM[3]=next_acc[3] SUM[2]=next_acc[2] SUM[1]=next_acc[1] SUM[0]=next_acc[0]
Xsll_18/M1_0_4 MUX2 $PINS O=sll_18/ML_int[1][4] S=shf3[0] A=term3_in[4]
+ B=term3_in[3]
XU45 MUX2 $PINS O=sll_18/ML_int[1][3] S=shf3[0] A=term3_in[3] B=term3_in[2]
XU12 NR2 $PINS O=term1_in[2] I1=sign1[1] I2=n150
XU16 NR2P $PINS O=term2_in[0] I1=FE_OFN177_s12_1 I2=FE_RN_4
XU32 AN2 $PINS O=sll_18/ML_int[3][2] I1=n25 I2=sll_18/ML_int[2][2]
XU44 AO22P $PINS O=N47 A1=N20 A2=sign1[0] B1=term1_shifted[6] B2=n88
XU50 AN2 $PINS O=sll_16/ML_int[1][0] I1=term1_in[0] I2=n68
XU76 NR2 $PINS O=term1_in[0] I1=sign1[1] I2=FE_RN_4
XU88 ND2P $PINS O=n103 I1=sll_16/ML_int[1][1] I2=FE_DBTN185_h11_1
XU108 NR2P $PINS O=term1_shifted[1] I1=n104 I2=n103
.ENDS

.SUBCKT SNPS_CLOCK_GATE_HIGH_PE_Shift_Add_4 EN ENCLK CLK
*.CONNECT ENCLK net2233
*.CONNECT net2234 EN
XFE_PHC885_net2237 DELC $PINS O=net2237 I=FE_PHN885_net2237
Xlatch QDBHN $PINS Q=FE_PHN885_net2237 D=net2234 CKB=CLK
Xmain_gate AN2T $PINS O=net2233 I1=net2237 I2=CLK
.ENDS

.SUBCKT PE_Shift_Add_4_DW01_sub_0_DW01_sub_12 A[26] A[25] A[24] A[23] A[22]
+ A[21] A[20] A[19] A[18] A[17] A[16] A[15] A[14] A[13] A[12] A[11] A[10] A[9]
+ A[8] A[7] A[6] A[5] A[4] A[3] A[2] A[1] A[0] B[26] B[25] B[24] B[23] B[22]
+ B[21] B[20] B[19] B[18] B[17] B[16] B[15] B[14] B[13] B[12] B[11] B[10] B[9]
+ B[8] B[7] B[6] B[5] B[4] B[3] B[2] B[1] B[0] CI DIFF[26] DIFF[25] DIFF[24]
+ DIFF[23] DIFF[22] DIFF[21] DIFF[20] DIFF[19] DIFF[18] DIFF[17] DIFF[16]
+ DIFF[15] DIFF[14] DIFF[13] DIFF[12] DIFF[11] DIFF[10] DIFF[9] DIFF[8] DIFF[7]
+ DIFF[6] DIFF[5] DIFF[4] DIFF[3] DIFF[2] DIFF[1] DIFF[0] CO
*.CONNECT DIFF[0] B[0]
XFE_RC_771_0 AN2B1S $PINS O=n17 I1=n16 B1=B[10]
XFE_RC_748_0 AN2B1T $PINS O=n16 I1=n15 B1=B[9]
XFE_RC_664_0 XOR2HS $PINS O=FE_RN_278_0 I1=B[11] I2=n17
XFE_RC_555_0 INV2 $PINS O=DIFF[11] I=FE_RN_278_0
XFE_RC_259_0 XOR2HS $PINS O=DIFF[7] I1=n13 I2=n45
XFE_RC_44_0 XOR2HS $PINS O=DIFF[3] I1=n1 I2=n49
XFE_RC_1588_0 AN2 $PINS O=FE_RN_371_0 I1=n16 I2=n41
XFE_RC_1587_0 AN2 $PINS O=n18 I1=FE_RN_371_0 I2=n42
XFE_RC_950_0 XOR2HS $PINS O=DIFF[5] I1=n11 I2=n47
XU2 NR2 $PINS O=n2 I1=B[1] I2=B[0]
XU3 INV2 $PINS O=n50 I=B[2]
XU4 INV1S $PINS O=n46 I=B[6]
XU5 INV2 $PINS O=n49 I=B[3]
XU6 INV2 $PINS O=n47 I=B[5]
XU7 INV2 $PINS O=n48 I=B[4]
XU8 XOR2HS $PINS O=DIFF[2] I1=n2 I2=n50
XU9 AN2T $PINS O=n1 I1=n50 I2=n2
XU10 AN2 $PINS O=n3 I1=n49 I2=n1
XU11 AN2 $PINS O=n4 I1=n40 I2=n18
XU12 AN2 $PINS O=n5 I1=n39 I2=n4
XU13 AN2 $PINS O=n6 I1=n38 I2=n5
XU14 AN2 $PINS O=n7 I1=n37 I2=n6
XU15 AN2 $PINS O=n8 I1=n36 I2=n7
XU16 AN2 $PINS O=n9 I1=n35 I2=n8
XU17 AN2 $PINS O=n10 I1=n34 I2=n9
XU18 AN2 $PINS O=n11 I1=n3 I2=n48
XU19 AN2T $PINS O=n12 I1=n11 I2=n47
XU20 AN2 $PINS O=n13 I1=n12 I2=n46
XU21 AN2 $PINS O=n14 I1=n45 I2=n13
XU22 AN2 $PINS O=n15 I1=n44 I2=n14
XU26 AN2 $PINS O=n19 I1=n33 I2=n10
XU27 AN2 $PINS O=n20 I1=n32 I2=n19
XU28 AN2 $PINS O=n21 I1=n31 I2=n20
XU29 AN2 $PINS O=n22 I1=n30 I2=n21
XU30 AN2 $PINS O=n23 I1=n29 I2=n22
XU31 AN2 $PINS O=n24 I1=n28 I2=n23
XU32 INV1S $PINS O=n40 I=B[12]
XU33 INV1S $PINS O=n39 I=B[13]
XU34 INV1S $PINS O=n38 I=B[14]
XU35 INV1S $PINS O=n37 I=B[15]
XU36 INV1S $PINS O=n36 I=B[16]
XU37 INV1S $PINS O=n35 I=B[17]
XU38 INV1S $PINS O=n34 I=B[18]
XU39 XOR2HS $PINS O=DIFF[4] I1=n3 I2=n48
XU40 XOR2HS $PINS O=DIFF[10] I1=n42 I2=n16
XU42 XOR2HS $PINS O=DIFF[12] I1=n40 I2=n18
XU43 XOR2HS $PINS O=DIFF[13] I1=n39 I2=n4
XU44 XOR2HS $PINS O=DIFF[14] I1=n38 I2=n5
XU45 XOR2HS $PINS O=DIFF[15] I1=n37 I2=n6
XU46 XOR2HS $PINS O=DIFF[16] I1=n36 I2=n7
XU47 XOR2HS $PINS O=DIFF[17] I1=n35 I2=n8
XU48 XOR2HS $PINS O=DIFF[9] I1=n43 I2=n15
XU49 XOR2HS $PINS O=DIFF[18] I1=n34 I2=n9
XU50 XOR2HS $PINS O=DIFF[19] I1=n33 I2=n10
XU51 XOR2HS $PINS O=DIFF[20] I1=n32 I2=n19
XU52 XOR2HS $PINS O=DIFF[21] I1=n31 I2=n20
XU53 XOR2HS $PINS O=DIFF[22] I1=n30 I2=n21
XU54 XOR2HS $PINS O=DIFF[23] I1=n29 I2=n22
XU55 XOR2HS $PINS O=DIFF[8] I1=n14 I2=n44
XU56 XOR2HS $PINS O=DIFF[24] I1=n28 I2=n23
XU59 XOR2HS $PINS O=DIFF[6] I1=n46 I2=n12
XU61 XOR2HS $PINS O=DIFF[25] I1=n27 I2=n24
XU62 INV2CK $PINS O=n45 I=B[7]
XU63 INV1S $PINS O=n44 I=B[8]
XU64 INV1S $PINS O=n43 I=B[9]
XU65 INV1S $PINS O=n42 I=B[10]
XU66 XOR2HS $PINS O=DIFF[26] I1=B[26] I2=n26
XU67 INV1S $PINS O=n41 I=B[11]
XU68 INV1S $PINS O=n33 I=B[19]
XU69 INV1S $PINS O=n32 I=B[20]
XU70 INV1S $PINS O=n31 I=B[21]
XU71 INV1S $PINS O=n30 I=B[22]
XU72 INV1S $PINS O=n29 I=B[23]
XU73 INV1S $PINS O=n28 I=B[24]
XU74 INV1S $PINS O=n27 I=B[25]
XU76 ND2 $PINS O=n26 I1=n27 I2=n24
XU1 XOR2HS $PINS O=DIFF[1] I1=DIFF[0] I2=B[1]
.ENDS

.SUBCKT PE_Shift_Add_4_DW01_sub_1_DW01_sub_13 A[26] A[25] A[24] A[23] A[22]
+ A[21] A[20] A[19] A[18] A[17] A[16] A[15] A[14] A[13] A[12] A[11] A[10] A[9]
+ A[8] A[7] A[6] A[5] A[4] A[3] A[2] A[1] A[0] B[26] B[25] B[24] B[23] B[22]
+ B[21] B[20] B[19] B[18] B[17] B[16] B[15] B[14] B[13] B[12] B[11] B[10] B[9]
+ B[8] B[7] B[6] B[5] B[4] B[3] B[2] B[1] B[0] CI DIFF[26] DIFF[25] DIFF[24]
+ DIFF[23] DIFF[22] DIFF[21] DIFF[20] DIFF[19] DIFF[18] DIFF[17] DIFF[16]
+ DIFF[15] DIFF[14] DIFF[13] DIFF[12] DIFF[11] DIFF[10] DIFF[9] DIFF[8] DIFF[7]
+ DIFF[6] DIFF[5] DIFF[4] DIFF[3] DIFF[2] DIFF[1] DIFF[0] CO
*.CONNECT DIFF[0] B[0]
XFE_RC_643_0 XOR2HS $PINS O=DIFF[5] I1=B[5] I2=FE_RN_208_0
XFE_RC_628_0 XNR2HS $PINS O=DIFF[9] I1=B[9] I2=n16
XFE_RC_386_0 OR2B1T $PINS O=FE_RN_205_0 I1=B[7] B1=n14
XFE_RC_385_0 XOR2H $PINS O=DIFF[8] I1=B[8] I2=FE_RN_205_0
XFE_RC_289_0 XNR2HS $PINS O=DIFF[4] I1=B[4] I2=n4
XFE_RC_162_0 AN2 $PINS O=n17 I1=n16 I2=n44
XFE_RC_1522_0 OR2 $PINS O=FE_RN_338_0 I1=DIFF[0] I2=B[1]
XFE_RC_1521_0 XOR2HS $PINS O=DIFF[2] I1=FE_RN_338_0 I2=B[2]
XFE_RC_1382_0 XNR2HS $PINS O=DIFF[6] I1=B[6] I2=n13
XFE_RC_1294_0 OR2B1S $PINS O=FE_RN_208_0 I1=B[4] B1=n4
XFE_RC_1262_0 AN2B1S $PINS O=n13 I1=n12 B1=B[5]
XFE_OFC599_term2_shifted_3 INV2 $PINS O=n50 I=B[3]
XU1 NR2 $PINS O=n3 I1=B[0] I2=B[1]
XU5 INV1S $PINS O=n49 I=B[4]
XU6 INV1S $PINS O=n47 I=B[6]
XU9 XOR2HS $PINS O=DIFF[1] I1=DIFF[0] I2=B[1]
XU11 AN2 $PINS O=n4 I1=n50 I2=n2
XU12 AN2 $PINS O=n5 I1=n41 I2=n19
XU13 AN2 $PINS O=n6 I1=n40 I2=n5
XU14 AN2 $PINS O=n7 I1=n39 I2=n6
XU15 AN2 $PINS O=n8 I1=n38 I2=n7
XU16 AN2 $PINS O=n9 I1=n37 I2=n8
XU17 AN2 $PINS O=n10 I1=n36 I2=n9
XU18 AN2 $PINS O=n11 I1=n35 I2=n10
XU19 AN2S $PINS O=n12 I1=n49 I2=n4
XU21 AN2 $PINS O=n14 I1=n13 I2=n47
XU22 AN2 $PINS O=n15 I1=n46 I2=n14
XU23 AN2 $PINS O=n16 I1=n45 I2=n15
XU25 AN2 $PINS O=n18 I1=n17 I2=n43
XU26 AN2 $PINS O=n19 I1=n18 I2=n42
XU27 AN2 $PINS O=n20 I1=n34 I2=n11
XU28 AN2 $PINS O=n21 I1=n33 I2=n20
XU29 AN2 $PINS O=n22 I1=n32 I2=n21
XU30 AN2 $PINS O=n23 I1=n31 I2=n22
XU31 AN2 $PINS O=n24 I1=n30 I2=n23
XU32 AN2 $PINS O=n25 I1=n29 I2=n24
XU33 INV1S $PINS O=n41 I=B[12]
XU34 INV1S $PINS O=n40 I=B[13]
XU35 INV1S $PINS O=n39 I=B[14]
XU36 INV1S $PINS O=n38 I=B[15]
XU37 INV1S $PINS O=n37 I=B[16]
XU38 INV1S $PINS O=n36 I=B[17]
XU39 INV1S $PINS O=n35 I=B[18]
XU40 INV1S $PINS O=n46 I=B[7]
XU41 INV1S $PINS O=n45 I=B[8]
XU42 INV1S $PINS O=n44 I=B[9]
XU43 INV1S $PINS O=n43 I=B[10]
XU44 XOR2HS $PINS O=DIFF[26] I1=B[26] I2=n27
XU45 INV1S $PINS O=n42 I=B[11]
XU46 INV1S $PINS O=n34 I=B[19]
XU47 INV1S $PINS O=n33 I=B[20]
XU48 INV1S $PINS O=n32 I=B[21]
XU49 INV1S $PINS O=n31 I=B[22]
XU50 INV1S $PINS O=n30 I=B[23]
XU51 INV1S $PINS O=n29 I=B[24]
XU52 INV1S $PINS O=n28 I=B[25]
XU54 XOR2HS $PINS O=DIFF[10] I1=n43 I2=n17
XU55 XOR2HS $PINS O=DIFF[11] I1=n42 I2=n18
XU56 XOR2HS $PINS O=DIFF[12] I1=n41 I2=n19
XU57 XOR2HS $PINS O=DIFF[13] I1=n40 I2=n5
XU58 XOR2HS $PINS O=DIFF[14] I1=n39 I2=n6
XU59 XOR2HS $PINS O=DIFF[15] I1=n38 I2=n7
XU60 XOR2HS $PINS O=DIFF[16] I1=n37 I2=n8
XU61 XOR2HS $PINS O=DIFF[17] I1=n36 I2=n9
XU63 XOR2HS $PINS O=DIFF[18] I1=n35 I2=n10
XU64 XOR2HS $PINS O=DIFF[19] I1=n34 I2=n11
XU65 XOR2HS $PINS O=DIFF[20] I1=n33 I2=n20
XU66 XOR2HS $PINS O=DIFF[21] I1=n32 I2=n21
XU67 XOR2HS $PINS O=DIFF[7] I1=n14 I2=n46
XU68 XOR2HS $PINS O=DIFF[22] I1=n31 I2=n22
XU69 XOR2HS $PINS O=DIFF[23] I1=n30 I2=n23
XU71 XOR2HS $PINS O=DIFF[24] I1=n29 I2=n24
XU72 XOR2HS $PINS O=DIFF[3] I1=n2 I2=n50
XU75 XOR2HS $PINS O=DIFF[25] I1=n28 I2=n25
XU77 ND2 $PINS O=n27 I1=n28 I2=n25
XU8 NR2 $PINS O=n2 I1=n52 I2=B[2]
XU10 INV1S $PINS O=n52 I=n3
.ENDS

.SUBCKT PE_Shift_Add_4_DW01_sub_2_DW01_sub_14 A[26] A[25] A[24] A[23] A[22]
+ A[21] A[20] A[19] A[18] A[17] A[16] A[15] A[14] A[13] A[12] A[11] A[10] A[9]
+ A[8] A[7] A[6] A[5] A[4] A[3] A[2] A[1] A[0] B[26] B[25] B[24] B[23] B[22]
+ B[21] B[20] B[19] B[18] B[17] B[16] B[15] B[14] B[13] B[12] B[11] B[10] B[9]
+ B[8] B[7] B[6] B[5] B[4] B[3] B[2] B[1] B[0] CI DIFF[26] DIFF[25] DIFF[24]
+ DIFF[23] DIFF[22] DIFF[21] DIFF[20] DIFF[19] DIFF[18] DIFF[17] DIFF[16]
+ DIFF[15] DIFF[14] DIFF[13] DIFF[12] DIFF[11] DIFF[10] DIFF[9] DIFF[8] DIFF[7]
+ DIFF[6] DIFF[5] DIFF[4] DIFF[3] DIFF[2] DIFF[1] DIFF[0] CO
*.CONNECT DIFF[0] B[0]
XFE_RC_652_0 AN2B1 $PINS O=n15 I1=n14 B1=B[8]
XFE_RC_562_0 AN2B1T $PINS O=n13 I1=n12 B1=B[6]
XFE_RC_397_0 XNR2HS $PINS O=DIFF[2] I1=n1 I2=B[2]
XFE_RC_46_0 XOR2HS $PINS O=DIFF[9] I1=n15 I2=n43
XFE_RC_26_0 XOR2HS $PINS O=DIFF[5] I1=B[5] I2=FE_RN_64_0
XFE_RC_1548_0 AN2 $PINS O=FE_RN_349_0 I1=n42 I2=n41
XFE_RC_1547_0 AN2 $PINS O=n18 I1=FE_RN_349_0 I2=n16
XFE_RC_1012_0 INV2 $PINS O=FE_RN_64_0 I=n11
XU3 NR2 $PINS O=n1 I1=DIFF[0] I2=B[1]
XU4 INV1S $PINS O=n51 I=B[0]
XU6 XOR2HS $PINS O=DIFF[4] I1=n3 I2=n48
XU7 INV2 $PINS O=n49 I=B[3]
XU8 INV1S $PINS O=n46 I=B[6]
XU9 INV1S $PINS O=n47 I=B[5]
XU10 XNR2HS $PINS O=DIFF[1] I1=n51 I2=B[1]
XU11 XOR2HS $PINS O=DIFF[3] I1=n2 I2=n49
XU12 AN2T $PINS O=n2 I1=n50 I2=n1
XU13 AN2 $PINS O=n3 I1=n49 I2=n2
XU14 XOR2HS $PINS O=DIFF[12] I1=n40 I2=n18
XU15 XOR2HS $PINS O=DIFF[13] I1=n39 I2=n4
XU16 AN2 $PINS O=n4 I1=n40 I2=n18
XU17 XOR2HS $PINS O=DIFF[14] I1=n38 I2=n5
XU18 AN2 $PINS O=n5 I1=n39 I2=n4
XU19 XOR2HS $PINS O=DIFF[15] I1=n37 I2=n6
XU20 AN2 $PINS O=n6 I1=n38 I2=n5
XU21 XOR2HS $PINS O=DIFF[16] I1=n36 I2=n7
XU22 AN2 $PINS O=n7 I1=n37 I2=n6
XU23 XOR2HS $PINS O=DIFF[17] I1=n35 I2=n8
XU24 AN2 $PINS O=n8 I1=n36 I2=n7
XU25 XOR2HS $PINS O=DIFF[18] I1=n34 I2=n9
XU26 AN2 $PINS O=n9 I1=n35 I2=n8
XU27 AN2 $PINS O=n10 I1=n34 I2=n9
XU29 AN2T $PINS O=n11 I1=n48 I2=n3
XU30 XOR2HS $PINS O=DIFF[6] I1=n46 I2=n12
XU31 AN2 $PINS O=n12 I1=n11 I2=n47
XU32 XOR2HS $PINS O=DIFF[7] I1=n13 I2=n45
XU34 XOR2HS $PINS O=DIFF[8] I1=n44 I2=n14
XU35 AN2T $PINS O=n14 I1=n45 I2=n13
XU38 XOR2HS $PINS O=DIFF[10] I1=n42 I2=n16
XU39 AN2 $PINS O=n16 I1=n15 I2=n43
XU40 XOR2HS $PINS O=DIFF[11] I1=n41 I2=n17
XU41 AN2 $PINS O=n17 I1=n16 I2=n42
XU43 XOR2HS $PINS O=DIFF[19] I1=n33 I2=n10
XU44 XOR2HS $PINS O=DIFF[20] I1=n32 I2=n19
XU45 AN2 $PINS O=n19 I1=n33 I2=n10
XU46 XOR2HS $PINS O=DIFF[21] I1=n31 I2=n20
XU47 AN2 $PINS O=n20 I1=n32 I2=n19
XU48 XOR2HS $PINS O=DIFF[22] I1=n30 I2=n21
XU49 AN2 $PINS O=n21 I1=n31 I2=n20
XU50 XOR2HS $PINS O=DIFF[23] I1=n29 I2=n22
XU51 AN2 $PINS O=n22 I1=n30 I2=n21
XU52 XOR2HS $PINS O=DIFF[24] I1=n28 I2=n23
XU53 AN2 $PINS O=n23 I1=n29 I2=n22
XU54 AN2 $PINS O=n24 I1=n28 I2=n23
XU55 XOR2HS $PINS O=DIFF[25] I1=n27 I2=n24
XU56 INV1S $PINS O=n40 I=B[12]
XU57 INV1S $PINS O=n39 I=B[13]
XU58 INV1S $PINS O=n38 I=B[14]
XU59 INV1S $PINS O=n37 I=B[15]
XU60 INV1S $PINS O=n36 I=B[16]
XU61 INV1S $PINS O=n35 I=B[17]
XU62 INV1S $PINS O=n34 I=B[18]
XU63 INV4CK $PINS O=n48 I=B[4]
XU64 INV2 $PINS O=n45 I=B[7]
XU65 INV1S $PINS O=n44 I=B[8]
XU66 INV2 $PINS O=n43 I=B[9]
XU67 INV1S $PINS O=n42 I=B[10]
XU68 XOR2HS $PINS O=DIFF[26] I1=B[26] I2=n26
XU69 INV1S $PINS O=n41 I=B[11]
XU70 INV1S $PINS O=n33 I=B[19]
XU71 INV1S $PINS O=n32 I=B[20]
XU72 INV1S $PINS O=n31 I=B[21]
XU73 INV1S $PINS O=n30 I=B[22]
XU74 INV1S $PINS O=n29 I=B[23]
XU75 INV1S $PINS O=n28 I=B[24]
XU76 INV1S $PINS O=n27 I=B[25]
XU77 ND2 $PINS O=n26 I1=n27 I2=n24
XU5 INV2 $PINS O=n50 I=B[2]
.ENDS

.SUBCKT PE_Shift_Add_4_DW01_add_2_DW01_add_34 A[26] A[25] A[24] A[23] A[22]
+ A[21] A[20] A[19] A[18] A[17] A[16] A[15] A[14] A[13] A[12] A[11] A[10] A[9]
+ A[8] A[7] A[6] A[5] A[4] A[3] A[2] A[1] A[0] B[26] B[25] B[24] B[23] B[22]
+ B[21] B[20] B[19] B[18] B[17] B[16] B[15] B[14] B[13] B[12] B[11] B[10] B[9]
+ B[8] B[7] B[6] B[5] B[4] B[3] B[2] B[1] B[0] CI SUM[26] SUM[25] SUM[24]
+ SUM[23] SUM[22] SUM[21] SUM[20] SUM[19] SUM[18] SUM[17] SUM[16] SUM[15]
+ SUM[14] SUM[13] SUM[12] SUM[11] SUM[10] SUM[9] SUM[8] SUM[7] SUM[6] SUM[5]
+ SUM[4] SUM[3] SUM[2] SUM[1] SUM[0] CO
XFE_RC_770_0 INV2 $PINS O=SUM[21] I=FE_RN_367_0
XFE_RC_769_0 XNR3 $PINS O=FE_RN_367_0 I1=A[21] I2=B[21] I3=carry[21]
XFE_RC_688_1 INV2 $PINS O=SUM[13] I=FE_RN_331_0
XFE_RC_687_1 XNR3 $PINS O=FE_RN_331_0 I1=A[13] I2=B[13] I3=carry[13]
XFE_RC_615_0 INV2 $PINS O=SUM[1] I=FE_RN_303_0
XFE_RC_614_0 XNR3 $PINS O=FE_RN_303_0 I1=B[1] I2=A[1] I3=n1
XFE_RC_585_0 INV1CK $PINS O=FE_RN_34_0 I=FE_RN_290_1
XFE_RC_584_0 NR2 $PINS O=FE_RN_290_1 I1=FE_RN_22_0 I2=FE_RN_27_0
XFE_RC_557_0 INV2 $PINS O=SUM[9] I=FE_RN_279_0
XFE_RC_556_0 XNR3 $PINS O=FE_RN_279_0 I1=A[9] I2=B[9] I3=carry[9]
XFE_RC_477_0 INV2 $PINS O=SUM[2] I=FE_RN_246_0
XFE_RC_476_0 XNR3 $PINS O=FE_RN_246_0 I1=A[2] I2=carry[2] I3=B[2]
XFE_RC_470_0 INV2 $PINS O=SUM[20] I=FE_RN_243_0
XFE_RC_469_0 XNR3 $PINS O=FE_RN_243_0 I1=A[20] I2=B[20] I3=carry[20]
XFE_RC_468_0 INV2 $PINS O=SUM[18] I=FE_RN_242_0
XFE_RC_467_0 XNR3 $PINS O=FE_RN_242_0 I1=A[18] I2=B[18] I3=carry[18]
XFE_RC_400_0 INV2 $PINS O=SUM[3] I=FE_RN_212_1
XFE_RC_399_0 XNR3 $PINS O=FE_RN_212_1 I1=B[3] I2=A[3] I3=carry[3]
XFE_RC_154_0 ND3P $PINS O=carry[6] I1=n3 I2=n2 I3=n4
XFE_RC_60_0 ND2P $PINS O=SUM[6] I1=FE_RN_34_0 I2=FE_RN_28_0
XFE_RC_54_0 ND3 $PINS O=carry[8] I1=n5 I2=n6 I3=n7
XFE_RC_1579_0 INV2 $PINS O=SUM[4] I=FE_RN_366_0
XFE_RC_1578_0 XNR3 $PINS O=FE_RN_366_0 I1=A[4] I2=B[4] I3=carry[4]
XFE_RC_1445_0 INV2 $PINS O=SUM[10] I=FE_RN_290_0
XFE_RC_1444_0 XNR3 $PINS O=FE_RN_290_0 I1=A[10] I2=B[10] I3=carry[10]
XFE_RC_1433_0 INV2 $PINS O=SUM[8] I=FE_RN_283_0
XFE_RC_1432_0 XNR3 $PINS O=FE_RN_283_0 I1=B[8] I2=A[8] I3=carry[8]
XFE_RC_1301_0 INV2 $PINS O=SUM[7] I=FE_RN_212_0
XFE_RC_1300_0 XNR3 $PINS O=FE_RN_212_0 I1=B[7] I2=A[7] I3=carry[7]
XFE_RC_1278_0 INV2 $PINS O=SUM[15] I=FE_RN_200_0
XFE_RC_1277_0 XNR3 $PINS O=FE_RN_200_0 I1=A[15] I2=B[15] I3=carry[15]
XFE_RC_1241_0 INV2 $PINS O=SUM[5] I=FE_RN_180_0
XFE_RC_1240_0 XNR3 $PINS O=FE_RN_180_0 I1=B[5] I2=A[5] I3=carry[5]
XFE_RC_1123_0 XOR3 $PINS O=SUM[25] I1=A[25] I2=B[25] I3=carry[25]
XFE_RC_1122_0 MAO222 $PINS O=carry[26] A1=carry[25] B1=B[25] C1=A[25]
XFE_RC_1085_0 MAO222 $PINS O=carry[3] A1=B[2] B1=A[2] C1=carry[2]
XFE_RC_1053_0 XOR3 $PINS O=SUM[24] I1=A[24] I2=B[24] I3=carry[24]
XFE_RC_1052_0 MAO222 $PINS O=carry[25] A1=carry[24] B1=B[24] C1=A[24]
XFE_RC_1048_0 MAO222 $PINS O=carry[2] A1=A[1] B1=B[1] C1=n1
XFE_RC_991_0 MAO222 $PINS O=carry[4] A1=carry[3] B1=A[3] C1=B[3]
XFE_RC_942_0 MAO222P $PINS O=carry[5] A1=carry[4] B1=A[4] C1=B[4]
XFE_RC_899_0 ND2 $PINS O=FE_RN_31_0 I1=A[15] I2=B[15]
XFE_RC_898_0 ND2 $PINS O=FE_RN_32_0 I1=carry[15] I2=A[15]
XFE_RC_897_0 ND2 $PINS O=FE_RN_33_0 I1=carry[15] I2=B[15]
XFE_RC_896_0 ND3P $PINS O=carry[16] I1=FE_RN_33_0 I2=FE_RN_32_0 I3=FE_RN_31_0
XFE_RC_895_0 INV1S $PINS O=FE_RN_22_0 I=carry[6]
XFE_RC_893_0 INV2 $PINS O=FE_RN_24_0 I=B[6]
XFE_RC_891_0 ND2 $PINS O=FE_RN_26_0 I1=A[6] I2=FE_RN_24_0
XFE_RC_890_0 OAI12HS $PINS O=FE_RN_27_0 A1=FE_RN_26_0 B1=FE_RN_24_0 B2=A[6]
XFE_RC_889_0 ND2 $PINS O=FE_RN_28_0 I1=FE_RN_27_0 I2=FE_RN_22_0
XFE_RC_887_0 ND2 $PINS O=FE_RN_29_0 I1=B[6] I2=A[6]
XFE_RC_886_0 OAI12HS $PINS O=FE_RN_30_0 A1=carry[6] B1=B[6] B2=A[6]
XFE_RC_885_0 ND2P $PINS O=carry[7] I1=FE_RN_30_0 I2=FE_RN_29_0
XFE_RC_835_0 MAO222 $PINS O=carry[21] A1=carry[20] B1=B[20] C1=A[20]
XFE_RC_825_0 MAO222 $PINS O=carry[22] A1=carry[21] B1=B[21] C1=A[21]
XFE_RC_766_0 XOR3 $PINS O=SUM[22] I1=A[22] I2=B[22] I3=carry[22]
XFE_RC_765_0 MAO222 $PINS O=carry[23] A1=carry[22] B1=B[22] C1=A[22]
XFE_RC_688_0 XOR3 $PINS O=SUM[19] I1=A[19] I2=B[19] I3=carry[19]
XFE_RC_687_0 MAO222 $PINS O=carry[20] A1=carry[19] B1=B[19] C1=A[19]
XFE_RC_684_0 XOR3 $PINS O=SUM[16] I1=A[16] I2=B[16] I3=carry[16]
XFE_RC_683_0 MAO222 $PINS O=carry[17] A1=carry[16] B1=B[16] C1=A[16]
XFE_RC_629_0 MAO222 $PINS O=carry[19] A1=carry[18] B1=B[18] C1=A[18]
XFE_RC_542_0 XOR3 $PINS O=SUM[17] I1=A[17] I2=B[17] I3=carry[17]
XFE_RC_541_0 MAO222 $PINS O=carry[18] A1=carry[17] B1=B[17] C1=A[17]
XFE_RC_528_0 XOR3 $PINS O=SUM[14] I1=A[14] I2=B[14] I3=carry[14]
XFE_RC_527_0 MAO222P $PINS O=carry[15] A1=carry[14] B1=B[14] C1=A[14]
XFE_RC_426_0 XOR3 $PINS O=SUM[12] I1=A[12] I2=B[12] I3=carry[12]
XFE_RC_425_0 MAO222 $PINS O=carry[13] A1=carry[12] B1=B[12] C1=A[12]
XFE_RC_417_0 MAO222 $PINS O=carry[9] A1=carry[8] B1=B[8] C1=A[8]
XFE_RC_311_0 MAO222P $PINS O=carry[11] A1=carry[10] B1=B[10] C1=A[10]
XFE_RC_297_0 MAO222 $PINS O=carry[14] A1=carry[13] B1=B[13] C1=A[13]
XU1_26 XOR3S $PINS O=SUM[26] I1=A[26] I2=B[26] I3=carry[26]
XU1 ND3P $PINS O=carry[12] I1=n12 I2=n11 I3=n13
XU2 ND3 $PINS O=carry[10] I1=n9 I2=n8 I3=n10
XU3 XOR3 $PINS O=SUM[11] I1=B[11] I2=A[11] I3=carry[11]
XU5 AN2 $PINS O=n1 I1=B[0] I2=A[0]
XU9 ND2 $PINS O=n4 I1=A[5] I2=B[5]
XU10 ND2P $PINS O=n2 I1=carry[5] I2=B[5]
XU11 ND2 $PINS O=n3 I1=carry[5] I2=A[5]
XU13 ND2 $PINS O=n5 I1=carry[7] I2=B[7]
XU14 ND2P $PINS O=n6 I1=carry[7] I2=A[7]
XU15 ND2 $PINS O=n7 I1=B[7] I2=A[7]
XU16 ND2 $PINS O=n8 I1=carry[9] I2=B[9]
XU17 ND2 $PINS O=n9 I1=carry[9] I2=A[9]
XU18 ND2S $PINS O=n10 I1=B[9] I2=A[9]
XU19 ND2 $PINS O=n11 I1=carry[11] I2=B[11]
XU20 ND2 $PINS O=n12 I1=carry[11] I2=A[11]
XU21 ND2 $PINS O=n13 I1=B[11] I2=A[11]
XU22 XOR2HS $PINS O=n14 I1=A[23] I2=B[23]
XU23 XOR2HS $PINS O=SUM[23] I1=carry[23] I2=n14
XU24 ND2 $PINS O=n15 I1=carry[23] I2=A[23]
XU25 ND2 $PINS O=n16 I1=carry[23] I2=B[23]
XU26 ND2 $PINS O=n17 I1=A[23] I2=B[23]
XU27 ND3 $PINS O=carry[24] I1=n16 I2=n15 I3=n17
XU28 XOR2HS $PINS O=SUM[0] I1=B[0] I2=A[0]
.ENDS

.SUBCKT PE_Shift_Add_4_DW01_add_1_DW01_add_33 A[26] A[25] A[24] A[23] A[22]
+ A[21] A[20] A[19] A[18] A[17] A[16] A[15] A[14] A[13] A[12] A[11] A[10] A[9]
+ A[8] A[7] A[6] A[5] A[4] A[3] A[2] A[1] A[0] B[26] B[25] B[24] B[23] B[22]
+ B[21] B[20] B[19] B[18] B[17] B[16] B[15] B[14] B[13] B[12] B[11] B[10] B[9]
+ B[8] B[7] B[6] B[5] B[4] B[3] B[2] B[1] B[0] CI SUM[26] SUM[25] SUM[24]
+ SUM[23] SUM[22] SUM[21] SUM[20] SUM[19] SUM[18] SUM[17] SUM[16] SUM[15]
+ SUM[14] SUM[13] SUM[12] SUM[11] SUM[10] SUM[9] SUM[8] SUM[7] SUM[6] SUM[5]
+ SUM[4] SUM[3] SUM[2] SUM[1] SUM[0] CO
XFE_RC_764_0 INV2 $PINS O=SUM[19] I=FE_RN_364_0
XFE_RC_763_0 XNR3 $PINS O=FE_RN_364_0 I1=A[19] I2=B[19] I3=carry[19]
XFE_RC_731_0 INV2 $PINS O=SUM[13] I=FE_RN_350_0
XFE_RC_730_0 XNR3 $PINS O=FE_RN_350_0 I1=A[13] I2=B[13] I3=carry[13]
XFE_RC_698_0 INV2 $PINS O=SUM[16] I=FE_RN_336_0
XFE_RC_697_0 XNR3 $PINS O=FE_RN_336_0 I1=A[16] I2=B[16] I3=carry[16]
XFE_RC_686_0 INV2 $PINS O=SUM[6] I=FE_RN_330_0
XFE_RC_685_0 XNR3 $PINS O=FE_RN_330_0 I1=B[6] I2=A[6] I3=carry[6]
XFE_RC_684_0 INV2 $PINS O=SUM[18] I=FE_RN_329_0
XFE_RC_683_0 XNR3 $PINS O=FE_RN_329_0 I1=A[18] I2=B[18] I3=carry[18]
XFE_RC_661_0 INV2 $PINS O=SUM[20] I=FE_RN_318_0
XFE_RC_660_0 XNR3 $PINS O=FE_RN_318_0 I1=A[20] I2=B[20] I3=carry[20]
XFE_RC_569_0 INV2 $PINS O=SUM[2] I=FE_RN_284_0
XFE_RC_568_1 XNR3 $PINS O=FE_RN_284_0 I1=A[2] I2=carry[2] I3=B[2]
XFE_RC_540_0 INV2 $PINS O=SUM[8] I=FE_RN_273_0
XFE_RC_539_0 XNR3 $PINS O=FE_RN_273_0 I1=A[8] I2=B[8] I3=carry[8]
XFE_RC_419_0 MAO222P $PINS O=carry[5] A1=carry[4] B1=B[4] C1=A[4]
XFE_RC_330_0 INV2 $PINS O=SUM[7] I=FE_RN_181_0
XFE_RC_329_0 XNR3 $PINS O=FE_RN_181_0 I1=A[7] I2=B[7] I3=carry[7]
XFE_RC_324_0 INV2 $PINS O=SUM[10] I=FE_RN_177_0
XFE_RC_323_0 XNR3 $PINS O=FE_RN_177_0 I1=A[10] I2=B[10] I3=carry[10]
XFE_RC_318_0 INV2 $PINS O=SUM[12] I=FE_RN_173_0
XFE_RC_317_0 XNR3 $PINS O=FE_RN_173_0 I1=A[12] I2=B[12] I3=carry[12]
XFE_RC_246_0 ND3P $PINS O=carry[6] I1=FE_RN_27_0 I2=FE_RN_26_0 I3=FE_RN_25_0
XFE_RC_244_0 OAI12H $PINS O=FE_RN_35_0 A1=A[3] B1=carry[3] B2=B[3]
XFE_RC_128_0 ND3HT $PINS O=carry[3] I1=FE_RN_23_0 I2=FE_RN_24_0 I3=FE_RN_22_0
XFE_RC_43_0 ND2 $PINS O=FE_RN_25_0 I1=B[5] I2=A[5]
XFE_RC_42_0 ND2T $PINS O=FE_RN_26_0 I1=carry[5] I2=A[5]
XFE_RC_41_0 ND2P $PINS O=FE_RN_27_0 I1=carry[5] I2=B[5]
XFE_RC_39_0 ND2 $PINS O=FE_RN_22_0 I1=carry[2] I2=A[2]
XFE_RC_38_0 ND2P $PINS O=FE_RN_23_0 I1=B[2] I2=A[2]
XFE_RC_37_0 ND2P $PINS O=FE_RN_24_0 I1=B[2] I2=carry[2]
XFE_RC_1538_0 INV1S $PINS O=SUM[1] I=FE_RN_345_0
XFE_RC_1537_0 XNR3 $PINS O=FE_RN_345_0 I1=A[1] I2=n1 I3=B[1]
XFE_RC_1536_0 INV2 $PINS O=SUM[3] I=FE_RN_344_0
XFE_RC_1535_0 XNR3 $PINS O=FE_RN_344_0 I1=A[3] I2=B[3] I3=carry[3]
XFE_RC_1379_0 INV2 $PINS O=SUM[11] I=FE_RN_250_0
XFE_RC_1378_0 XNR3 $PINS O=FE_RN_250_0 I1=A[11] I2=B[11] I3=carry[11]
XFE_RC_1269_0 INV2 $PINS O=SUM[9] I=FE_RN_195_0
XFE_RC_1268_0 XNR3 $PINS O=FE_RN_195_0 I1=B[9] I2=A[9] I3=carry[9]
XFE_RC_1247_0 INV2 $PINS O=SUM[4] I=FE_RN_184_0
XFE_RC_1246_0 XNR3 $PINS O=FE_RN_184_0 I1=A[4] I2=B[4] I3=carry[4]
XFE_RC_1212_0 INV2 $PINS O=SUM[5] I=FE_RN_166_0
XFE_RC_1211_0 XNR3 $PINS O=FE_RN_166_0 I1=A[5] I2=B[5] I3=carry[5]
XFE_RC_1096_0 INV1S $PINS O=SUM[25] I=FE_RN_104_0
XFE_RC_1095_0 XOR2HS $PINS O=FE_RN_106_0 I1=A[25] I2=B[25]
XFE_RC_1094_0 INV1S $PINS O=FE_RN_105_0 I=FE_RN_106_0
XFE_RC_1093_0 XOR2HS $PINS O=FE_RN_104_0 I1=FE_RN_105_0 I2=carry[25]
XFE_RC_941_0 XOR3 $PINS O=SUM[24] I1=A[24] I2=B[24] I3=carry[24]
XFE_RC_940_0 MAO222 $PINS O=carry[25] A1=carry[24] B1=B[24] C1=A[24]
XFE_RC_936_0 MAO222 $PINS O=carry[14] A1=carry[13] B1=B[13] C1=A[13]
XFE_RC_928_0 MAO222 $PINS O=carry[26] A1=carry[25] B1=B[25] C1=A[25]
XFE_RC_926_0 MAO222 $PINS O=carry[13] A1=carry[12] B1=B[12] C1=A[12]
XFE_RC_912_0 INV2 $PINS O=SUM[26] I=FE_RN_40_0
XFE_RC_911_0 XOR2HS $PINS O=FE_RN_41_0 I1=A[26] I2=B[26]
XFE_RC_910_0 XNR2HS $PINS O=FE_RN_40_0 I1=FE_RN_41_0 I2=carry[26]
XFE_RC_902_0 ND2 $PINS O=FE_RN_34_0 I1=carry[3] I2=B[3]
XFE_RC_900_0 ND2P $PINS O=carry[4] I1=FE_RN_35_0 I2=FE_RN_34_0
XFE_RC_880_0 XOR3 $PINS O=SUM[21] I1=A[21] I2=B[21] I3=carry[21]
XFE_RC_879_0 MAO222 $PINS O=carry[22] A1=carry[21] B1=B[21] C1=A[21]
XFE_RC_866_0 XOR3 $PINS O=SUM[22] I1=A[22] I2=B[22] I3=carry[22]
XFE_RC_865_0 MAO222 $PINS O=carry[23] A1=carry[22] B1=B[22] C1=A[22]
XFE_RC_863_0 MAO222 $PINS O=carry[21] A1=carry[20] B1=B[20] C1=A[20]
XFE_RC_811_0 MAO222 $PINS O=carry[2] A1=B[1] B1=A[1] C1=n1
XFE_RC_761_0 MAO222 $PINS O=carry[19] A1=carry[18] B1=B[18] C1=A[18]
XFE_RC_703_0 MAO222 $PINS O=carry[20] A1=carry[19] B1=B[19] C1=A[19]
XFE_RC_657_0 MAO222 $PINS O=carry[17] A1=carry[16] B1=B[16] C1=A[16]
XFE_RC_626_0 XOR3 $PINS O=SUM[17] I1=A[17] I2=B[17] I3=carry[17]
XFE_RC_625_0 MAO222 $PINS O=carry[18] A1=carry[17] B1=B[17] C1=A[17]
XFE_RC_568_0 XOR3 $PINS O=SUM[14] I1=A[14] I2=B[14] I3=carry[14]
XFE_RC_567_0 MAO222 $PINS O=carry[15] A1=carry[14] B1=B[14] C1=A[14]
XFE_RC_486_0 XOR3 $PINS O=SUM[15] I1=A[15] I2=B[15] I3=carry[15]
XFE_RC_485_0 MAO222 $PINS O=carry[16] A1=carry[15] B1=B[15] C1=A[15]
XFE_RC_477_0 MAO222P $PINS O=carry[11] A1=carry[10] B1=B[10] C1=A[10]
XFE_RC_411_0 MAO222 $PINS O=carry[12] A1=carry[11] B1=B[11] C1=A[11]
XFE_RC_193_0 MAO222P $PINS O=carry[8] A1=carry[7] B1=B[7] C1=A[7]
XU1_23 FA1 $PINS S=SUM[23] CO=carry[24] A=A[23] B=B[23] CI=carry[23]
XU5 AN2T $PINS O=n1 I1=A[0] I2=B[0]
XU7 ND3 $PINS O=carry[7] I1=n3 I2=n2 I3=n4
XU9 ND2 $PINS O=n10 I1=B[8] I2=A[8]
XU10 ND2 $PINS O=n2 I1=carry[6] I2=B[6]
XU11 ND2 $PINS O=n3 I1=carry[6] I2=A[6]
XU12 ND2S $PINS O=n4 I1=B[6] I2=A[6]
XU13 ND2 $PINS O=n7 I1=B[9] I2=A[9]
XU14 ND3P $PINS O=carry[10] I1=n5 I2=n6 I3=n7
XU15 ND2 $PINS O=n8 I1=carry[8] I2=B[8]
XU16 ND2 $PINS O=n9 I1=carry[8] I2=A[8]
XU17 XOR2HS $PINS O=SUM[0] I1=B[0] I2=A[0]
XU1 ND2T $PINS O=n6 I1=carry[9] I2=A[9]
XU3 ND3HT $PINS O=carry[9] I1=n9 I2=n8 I3=n10
XU4 ND2P $PINS O=n5 I1=carry[9] I2=B[9]
.ENDS

.SUBCKT PE_Shift_Add_4_DW01_add_0_DW01_add_32 A[26] A[25] A[24] A[23] A[22]
+ A[21] A[20] A[19] A[18] A[17] A[16] A[15] A[14] A[13] A[12] A[11] A[10] A[9]
+ A[8] A[7] A[6] A[5] A[4] A[3] A[2] A[1] A[0] B[26] B[25] B[24] B[23] B[22]
+ B[21] B[20] B[19] B[18] B[17] B[16] B[15] B[14] B[13] B[12] B[11] B[10] B[9]
+ B[8] B[7] B[6] B[5] B[4] B[3] B[2] B[1] B[0] CI SUM[26] SUM[25] SUM[24]
+ SUM[23] SUM[22] SUM[21] SUM[20] SUM[19] SUM[18] SUM[17] SUM[16] SUM[15]
+ SUM[14] SUM[13] SUM[12] SUM[11] SUM[10] SUM[9] SUM[8] SUM[7] SUM[6] SUM[5]
+ SUM[4] SUM[3] SUM[2] SUM[1] SUM[0] CO
XFE_PHC1322_next_acc_0 DELB $PINS O=SUM[0] I=FE_PHN1322_next_acc_0
XFE_RC_278_0 ND3P $PINS O=carry[5] I1=FE_RN_136_0 I2=FE_RN_137_0 I3=FE_RN_138_0
XFE_RC_251_0 ND2 $PINS O=FE_RN_136_0 I1=carry[4] I2=B[4]
XFE_RC_250_0 ND2 $PINS O=FE_RN_137_0 I1=carry[4] I2=A[4]
XFE_RC_249_0 ND2 $PINS O=FE_RN_138_0 I1=A[4] I2=B[4]
XFE_RC_161_1 ND3P $PINS O=carry[3] I1=FE_RN_70_0 I2=FE_RN_68_0 I3=FE_RN_69_0
XFE_OCPC721_carry_4 BUF1S $PINS O=FE_OCPN721_carry_4 I=carry[4]
XFE_OCPC710_carry_6 BUF1S $PINS O=FE_OCPN710_carry_6 I=carry[6]
XFE_OCPC706_carry_5 BUF1S $PINS O=FE_OCPN706_carry_5 I=carry[5]
XFE_RC_1264_0 INV1S $PINS O=FE_RN_192_0 I=B[12]
XFE_RC_1263_0 AO13P $PINS O=n14 A1=FE_RN_192_0 B1=n8 B2=n7 B3=n6
XFE_RC_1134_0 INV1S $PINS O=FE_RN_123_0 I=B[11]
XFE_RC_1133_0 AO13P $PINS O=n8 A1=FE_RN_123_0 B1=n3 B2=n4 B3=n2
XFE_RC_1132_0 INV1S $PINS O=FE_RN_122_0 I=B[23]
XFE_RC_1131_0 AO13P $PINS O=FE_RN_0_0 A1=FE_RN_122_0 B1=n21 B2=n20 B3=n22
XFE_RC_1042_0 ND2 $PINS O=FE_RN_79_0 I1=carry[5] I2=B[5]
XFE_RC_1041_0 ND2P $PINS O=FE_RN_80_0 I1=A[5] I2=B[5]
XFE_RC_1040_0 ND2 $PINS O=FE_RN_81_0 I1=carry[5] I2=A[5]
XFE_RC_1039_0 ND3P $PINS O=carry[6] I1=FE_RN_81_0 I2=FE_RN_79_0 I3=FE_RN_80_0
XFE_RC_1022_0 ND2 $PINS O=FE_RN_68_0 I1=carry[2] I2=B[2]
XFE_RC_1021_0 ND2 $PINS O=FE_RN_69_0 I1=A[2] I2=carry[2]
XFE_RC_1020_0 ND2 $PINS O=FE_RN_70_0 I1=A[2] I2=B[2]
XFE_RC_964_0 ND2 $PINS O=FE_RN_45_0 I1=A[6] I2=B[6]
XFE_RC_963_0 ND2 $PINS O=FE_RN_46_0 I1=carry[6] I2=B[6]
XFE_RC_962_0 ND2 $PINS O=FE_RN_47_0 I1=carry[6] I2=A[6]
XFE_RC_961_0 ND3P $PINS O=carry[7] I1=FE_RN_47_0 I2=FE_RN_46_0 I3=FE_RN_45_0
XFE_RC_952_0 XOR3 $PINS O=SUM[1] I1=A[1] I2=B[1] I3=n1
XFE_RC_951_0 MAO222 $PINS O=carry[2] A1=A[1] B1=B[1] C1=n1
XFE_RC_872_0 XOR3 $PINS O=SUM[2] I1=A[2] I2=B[2] I3=carry[2]
XFE_RC_832_0 XOR3 $PINS O=SUM[25] I1=A[25] I2=B[25] I3=carry[25]
XFE_RC_831_0 MAO222 $PINS O=carry[26] A1=carry[25] B1=B[25] C1=A[25]
XFE_RC_804_0 XOR3 $PINS O=SUM[3] I1=A[3] I2=B[3] I3=carry[3]
XFE_RC_803_0 MAO222 $PINS O=carry[4] A1=carry[3] B1=B[3] C1=A[3]
XFE_RC_778_0 XOR3 $PINS O=SUM[4] I1=A[4] I2=B[4] I3=FE_OCPN721_carry_4
XFE_RC_726_0 XOR3 $PINS O=SUM[5] I1=A[5] I2=B[5] I3=FE_OCPN706_carry_5
XFE_RC_608_0 XOR3 $PINS O=SUM[15] I1=A[15] I2=B[15] I3=carry[15]
XFE_RC_607_0 MAO222P $PINS O=carry[16] A1=carry[15] B1=B[15] C1=A[15]
XFE_RC_606_0 XOR3 $PINS O=SUM[9] I1=A[9] I2=B[9] I3=carry[9]
XFE_RC_605_0 MAO222P $PINS O=carry[10] A1=carry[9] B1=B[9] C1=A[9]
XFE_RC_554_0 XOR3 $PINS O=SUM[16] I1=A[16] I2=B[16] I3=carry[16]
XFE_RC_553_0 MAO222P $PINS O=carry[17] A1=carry[16] B1=B[16] C1=A[16]
XFE_RC_464_0 XOR3 $PINS O=SUM[17] I1=A[17] I2=B[17] I3=carry[17]
XFE_RC_463_0 MAO222P $PINS O=carry[18] A1=carry[17] B1=B[17] C1=A[17]
XFE_RC_462_0 XOR3 $PINS O=SUM[6] I1=A[6] I2=B[6] I3=FE_OCPN710_carry_6
XFE_RC_362_0 XOR3 $PINS O=SUM[18] I1=A[18] I2=B[18] I3=carry[18]
XFE_RC_361_0 MAO222P $PINS O=carry[19] A1=carry[18] B1=B[18] C1=A[18]
XFE_RC_358_0 XOR3 $PINS O=SUM[7] I1=A[7] I2=B[7] I3=carry[7]
XFE_RC_357_0 MAO222P $PINS O=carry[8] A1=carry[7] B1=B[7] C1=A[7]
XFE_RC_256_0 XOR3 $PINS O=SUM[19] I1=A[19] I2=B[19] I3=carry[19]
XFE_RC_255_0 MAO222P $PINS O=carry[20] A1=carry[19] B1=B[19] C1=A[19]
XFE_RC_248_0 XOR3 $PINS O=SUM[8] I1=A[8] I2=B[8] I3=carry[8]
XFE_RC_247_0 MAO222P $PINS O=carry[9] A1=carry[8] B1=A[8] C1=B[8]
XFE_RC_181_0 XOR3 $PINS O=SUM[20] I1=A[20] I2=B[20] I3=carry[20]
XFE_RC_180_0 MAO222P $PINS O=carry[21] A1=carry[20] B1=B[20] C1=A[20]
XFE_RC_165_0 XOR3 $PINS O=SUM[23] I1=A[23] I2=B[23] I3=carry[23]
XFE_RC_163_0 ND2P $PINS O=FE_RN_1_0 I1=carry[23] I2=A[23]
XFE_RC_162_0 ND2 $PINS O=FE_RN_2_0 I1=A[23] I2=B[23]
XFE_RC_161_0 ND3HT $PINS O=carry[24] I1=FE_RN_0_0 I2=FE_RN_1_0 I3=FE_RN_2_0
XFE_RC_118_0 XOR3 $PINS O=SUM[21] I1=A[21] I2=B[21] I3=carry[21]
XFE_RC_117_0 MAO222P $PINS O=carry[22] A1=carry[21] B1=B[21] C1=A[21]
XU1_26 XOR3 $PINS O=SUM[26] I1=A[26] I2=B[26] I3=carry[26]
XU1 XOR3 $PINS O=SUM[10] I1=A[10] I2=B[10] I3=carry[10]
XU2 XOR3 $PINS O=SUM[12] I1=A[12] I2=B[12] I3=carry[12]
XU3 XOR3 $PINS O=SUM[14] I1=B[14] I2=A[14] I3=carry[14]
XU4 ND2 $PINS O=n2 I1=B[10] I2=A[10]
XU5 ND2 $PINS O=n12 I1=A[12] I2=B[12]
XU6 XOR2HS $PINS O=n19 I1=A[22] I2=B[22]
XU7 XOR2HS $PINS O=n23 I1=A[24] I2=B[24]
XU8 AN2 $PINS O=n1 I1=B[0] I2=A[0]
XU9 ND3P $PINS O=carry[25] I1=n25 I2=n26 I3=n24
XU10 ND2P $PINS O=n24 I1=carry[24] I2=A[24]
XU11 ND2P $PINS O=n3 I1=carry[10] I2=A[10]
XU12 ND2P $PINS O=n4 I1=carry[10] I2=B[10]
XU13 ND3P $PINS O=carry[11] I1=n4 I2=n3 I3=n2
XU14 XOR2HS $PINS O=n5 I1=A[11] I2=B[11]
XU15 XOR2HS $PINS O=SUM[11] I1=n5 I2=carry[11]
XU16 ND2 $PINS O=n6 I1=A[11] I2=B[11]
XU17 ND2P $PINS O=n7 I1=carry[11] I2=A[11]
XU19 ND3P $PINS O=carry[12] I1=n8 I2=n7 I3=n6
XU20 ND2 $PINS O=n9 I1=carry[14] I2=B[14]
XU21 ND2 $PINS O=n10 I1=carry[14] I2=A[14]
XU22 ND2 $PINS O=n11 I1=A[14] I2=B[14]
XU23 ND3P $PINS O=carry[15] I1=n9 I2=n10 I3=n11
XU24 ND3P $PINS O=carry[14] I1=n17 I2=n18 I3=n16
XU25 ND2P $PINS O=n13 I1=carry[12] I2=A[12]
XU27 ND3HT $PINS O=carry[13] I1=n14 I2=n13 I3=n12
XU28 XOR2HS $PINS O=n15 I1=A[13] I2=B[13]
XU29 XOR2HS $PINS O=SUM[13] I1=n15 I2=carry[13]
XU30 ND2 $PINS O=n16 I1=B[13] I2=A[13]
XU31 ND2P $PINS O=n17 I1=carry[13] I2=A[13]
XU32 ND2T $PINS O=n18 I1=carry[13] I2=B[13]
XU33 XOR2HS $PINS O=SUM[22] I1=carry[22] I2=n19
XU34 ND2 $PINS O=n20 I1=carry[22] I2=A[22]
XU35 ND2 $PINS O=n21 I1=carry[22] I2=B[22]
XU36 ND2 $PINS O=n22 I1=B[22] I2=A[22]
XU37 ND3P $PINS O=carry[23] I1=n20 I2=n21 I3=n22
XU38 XOR2HS $PINS O=SUM[24] I1=carry[24] I2=n23
XU39 ND2 $PINS O=n25 I1=carry[24] I2=B[24]
XU40 ND2 $PINS O=n26 I1=B[24] I2=A[24]
XU41 XOR2HS $PINS O=FE_PHN1322_next_acc_0 I1=B[0] I2=A[0]
.ENDS

.SUBCKT PE_Shift_Add_4 rst_n en clear calc_done stage_sel x_in[16] x_in[15]
+ x_in[14] x_in[13] x_in[12] x_in[11] x_in[10] x_in[9] x_in[8] x_in[7] x_in[6]
+ x_in[5] x_in[4] x_in[3] x_in[2] x_in[1] x_in[0] sign1[1] sign1[0] sign2[1]
+ sign2[0] sign3[1] sign3[0] shf1[3] shf1[2] shf1[1] shf1[0] shf2[3] shf2[2]
+ shf2[1] shf2[0] shf3[3] shf3[2] shf3[1] shf3[0] y_out[16] y_out[15] y_out[14]
+ y_out[13] y_out[12] y_out[11] y_out[10] y_out[9] y_out[8] y_out[7] y_out[6]
+ y_out[5] y_out[4] y_out[3] y_out[2] y_out[1] y_out[0] i_rst_n
+ FE_OFN1_FE_DBTN15_n64 FE_OFN36_i_rst_n FE_OFN33_i_rst_n FE_OFN29_i_rst_n
+ FE_OFN20_i_rst_n FE_OFN187_mac_in_imag_1 FE_OFN283_mac_in_imag_0 clk_clone2
+ clk clk_clone1
XFE_PHC1268_N235 DELB $PINS O=N235 I=FE_PHN1268_N235
XFE_PHC1260_N249 DELB $PINS O=FE_PHN1260_N249 I=N249
XFE_PHC1249_N250 DELB $PINS O=N250 I=FE_PHN1249_N250
XFE_PHC1236_N248 DELB $PINS O=FE_PHN1236_N248 I=N248
XFE_PHC1231_N236 DELB $PINS O=FE_PHN1231_N236 I=N236
XFE_PHC1228_N244 DELB $PINS O=N244 I=FE_PHN1228_N244
XFE_PHC1222_N246 DELB $PINS O=FE_PHN1222_N246 I=N246
XFE_PHC1217_N241 DELB $PINS O=N241 I=FE_PHN1217_N241
XFE_PHC1216_N239 DELB $PINS O=N239 I=FE_PHN1216_N239
XFE_PHC1211_N237 DELB $PINS O=N237 I=FE_PHN1211_N237
XFE_PHC1208_N242 DELB $PINS O=FE_PHN1208_N242 I=N242
XFE_PHC1205_N243 DELB $PINS O=FE_PHN1205_N243 I=N243
XFE_PHC1203_N238 DELB $PINS O=N238 I=FE_PHN1203_N238
XFE_PHC1201_N240 DELB $PINS O=FE_PHN1201_N240 I=N240
XFE_PHC1200_N247 DELB $PINS O=FE_PHN1200_N247 I=N247
XFE_PHC1185_N245 DELB $PINS O=N245 I=FE_PHN1185_N245
XFE_PHC1118_pe_i1_1 DELC $PINS O=y_out[1] I=FE_PHN1118_pe_i1_1
XFE_PHC1115_pe_i1_3 DELC $PINS O=y_out[3] I=FE_PHN1115_pe_i1_3
XFE_PHC1114_pe_i1_7 DELC $PINS O=y_out[7] I=FE_PHN1114_pe_i1_7
XFE_PHC860_acc_reg_19 DELB $PINS O=FE_PHN860_acc_reg_19 I=acc_reg[19]
XFE_PHC857_acc_reg_17 DELB $PINS O=FE_PHN857_acc_reg_17 I=acc_reg[17]
XFE_PHC809_pe_i1_16 DELC $PINS O=y_out[16] I=FE_PHN809_pe_i1_16
XFE_PHC806_pe_i1_12 DELC $PINS O=y_out[12] I=FE_PHN806_pe_i1_12
XFE_PHC802_pe_i1_15 DELC $PINS O=y_out[15] I=FE_PHN802_pe_i1_15
XFE_PHC790_pe_i1_11 DELC $PINS O=y_out[11] I=FE_PHN790_pe_i1_11
XFE_PHC775_N251 DELC $PINS O=FE_PHN775_N251 I=N251
XFE_RC_796_0 INV2 $PINS O=term2_shifted[1] I=FE_RN_378_0
XFE_RC_795_0 AN2B1S $PINS O=FE_RN_379_0 I1=n39 B1=n107
XFE_RC_794_0 ND2 $PINS O=FE_RN_378_0 I1=FE_RN_379_0 I2=sll_17/ML_int[1][1]
XFE_RC_745_0 INV1S $PINS O=FE_RN_355_0 I=n21
XFE_RC_744_0 AN2B1T $PINS O=term3_shifted[4] I1=sll_18/ML_int[3][4]
+ B1=FE_RN_355_0
XFE_RC_736_0 AN2T $PINS O=term1_shifted[6] I1=sll_16/ML_int[3][6]
+ I2=FE_OFN174_h11_3
XFE_RC_658_0 AN2B1 $PINS O=term3_shifted[6] I1=sll_18/ML_int[3][6]
+ B1=FE_RN_355_0
XFE_RC_623_0 INV2 $PINS O=N42 I=FE_RN_306_0
XFE_RC_622_0 AOI22H $PINS O=FE_RN_306_0 A1=N15 A2=sign1[0] B1=term1_shifted[1]
+ B2=n80
XFE_RC_620_0 INV2 $PINS O=N153 I=FE_RN_305_0
XFE_RC_619_0 AOI12H $PINS O=FE_RN_305_0 A1=FE_RN_304_0 B1=N126
+ B2=FE_OFN57_s13_0
XFE_RC_617_0 AN2 $PINS O=FE_RN_304_0 I1=term3_shifted[2] I2=n30
XFE_RC_613_0 INV1S $PINS O=FE_RN_301_0 I=n47
XFE_RC_612_0 INV1S $PINS O=FE_RN_302_0 I=n105
XFE_RC_611_0 MUXB2 $PINS O=term2_shifted[4] S=shf2[2] A=sll_17/ML_int[2][4]
+ B=FE_RN_302_0 EB=FE_RN_301_0
XFE_RC_606_0 ND2 $PINS O=FE_RN_298_0 I1=N72 I2=FE_OFN338_s12_0
XFE_RC_605_0 OR3B2T $PINS O=FE_RN_299_0 I1=n107 B1=sll_17/ML_int[2][3]
+ B2=FE_OFN54_s12_0
XFE_RC_604_0 ND2P $PINS O=N99 I1=FE_RN_299_0 I2=FE_RN_298_0
XFE_RC_588_0 INV2 $PINS O=N162 I=FE_RN_291_0
XFE_RC_587_0 AOI22H $PINS O=FE_RN_291_0 A1=N135 A2=FE_OFN57_s13_0
+ B1=term3_shifted[11] B2=FE_OFN351_n30
XFE_RC_580_0 AN2T $PINS O=term2_shifted[7] I1=sll_17/ML_int[3][7] I2=n47
XFE_RC_565_0 AN2S $PINS O=FE_RN_282_0 I1=term3_shifted[4] I2=FE_OFN351_n30
XFE_RC_564_0 AO12T $PINS O=N155 A1=FE_RN_282_0 B1=N128 B2=FE_OFN57_s13_0
XFE_RC_548_0 INV2 $PINS O=N102 I=FE_RN_275_0
XFE_RC_547_0 AOI22H $PINS O=FE_RN_275_0 A1=FE_OFN338_s12_0 A2=N75
+ B1=term2_shifted[6] B2=FE_OFN54_s12_0
XFE_RC_533_0 INV2 $PINS O=N45 I=FE_RN_269_0
XFE_RC_532_0 AOI22H $PINS O=FE_RN_269_0 A1=N18 A2=FE_OFN153_s11_0
+ B1=term1_shifted[4] B2=n80
XFE_RC_528_0 INV2 $PINS O=N46 I=FE_RN_267_0
XFE_RC_527_0 AOI22H $PINS O=FE_RN_267_0 A1=N19 A2=FE_OFN153_s11_0
+ B1=term1_shifted[5] B2=n80
XFE_RC_526_0 INV2 $PINS O=sll_16/ML_int[1][7] I=FE_RN_266_0
XFE_RC_525_0 MXL2HS $PINS OB=FE_RN_266_0 S=shf1[0] A=term1_in[7] B=term1_in[6]
XFE_RC_518_0 AO22P $PINS O=N101 A1=N74 A2=FE_OFN338_s12_0 B1=term2_shifted[5]
+ B2=FE_OFN54_s12_0
XFE_RC_507_0 INV2 $PINS O=term2_shifted[8] I=FE_RN_260_0
XFE_RC_506_0 MXL2H $PINS OB=FE_RN_260_0 S=shf2[3] A=sll_17/ML_int[3][8]
+ B=sll_17/ML_int[3][0]
XFE_RC_494_0 INV2 $PINS O=FE_RN_254_1 I=sll_17/ML_int[2][2]
XFE_RC_493_0 NR2T $PINS O=term2_shifted[2] I1=n107 I2=FE_RN_254_1
XFE_RC_479_0 INV2 $PINS O=sll_16/ML_int[3][4] I=FE_RN_247_0
XFE_RC_478_0 MXL2H $PINS OB=FE_RN_247_0 S=n70 A=sll_16/ML_int[2][4] B=n5
XFE_RC_414_0 INV2 $PINS O=sll_17/ML_int[2][2] I=FE_RN_219_0
XFE_RC_413_0 MXL2H $PINS OB=FE_RN_219_0 S=shf2[1] A=sll_17/ML_int[1][2]
+ B=sll_17/ML_int[1][0]
XFE_RC_310_0 INV2CK $PINS O=FE_RN_169_0 I=sll_17/ML_int[2][3]
XFE_RC_309_0 NR2P $PINS O=term2_shifted[3] I1=n107 I2=FE_RN_169_0
XFE_RC_149_0 ND2 $PINS O=FE_RN_86_0 I1=term3_shifted[3] I2=FE_OFN351_n30
XFE_RC_148_0 ND2 $PINS O=FE_RN_87_0 I1=N127 I2=FE_OFN57_s13_0
XFE_RC_147_0 ND2P $PINS O=N154 I1=FE_RN_87_0 I2=FE_RN_86_0
XFE_RC_138_0 ND2 $PINS O=FE_RN_80_0 I1=term1_shifted[11] I2=n80
XFE_RC_137_0 ND2 $PINS O=FE_RN_81_0 I1=N25 I2=FE_OFN153_s11_0
XFE_RC_136_0 ND2P $PINS O=N52 I1=FE_RN_81_0 I2=FE_RN_80_0
XFE_RC_118_0 ND2 $PINS O=FE_RN_70_0 I1=term1_shifted[6] I2=n80
XFE_RC_117_0 ND2 $PINS O=FE_RN_71_0 I1=N20 I2=FE_OFN153_s11_0
XFE_RC_116_0 ND2 $PINS O=N47 I1=FE_RN_71_0 I2=FE_RN_70_0
XFE_RC_49_0 ND2 $PINS O=FE_RN_28_0 I1=term3_shifted[5] I2=FE_OFN351_n30
XFE_RC_48_0 ND2 $PINS O=FE_RN_29_0 I1=N129 I2=FE_OFN57_s13_0
XFE_RC_47_0 ND2P $PINS O=N156 I1=FE_RN_29_0 I2=FE_RN_28_0
XFE_OFC708_FE_OFN232_s11_1 BUF1 $PINS O=FE_OFN368_FE_OFN232_s11_1 I=sign1[1]
XFE_RC_1600_0 OR3 $PINS O=FE_RN_375_0 I1=FE_OFN283_mac_in_imag_0 I2=shf2[0]
+ I3=n107
XFE_RC_1599_0 NR2 $PINS O=term2_shifted[0] I1=FE_RN_375_0 I2=FE_RN_258_0
XFE_RC_1577_0 INV2 $PINS O=sll_16/ML_int[2][2] I=FE_RN_365_0
XFE_RC_1576_0 MXL2HS $PINS OB=FE_RN_365_0 S=FE_OFN223_h11_1
+ A=sll_16/ML_int[1][2] B=sll_16/ML_int[1][0]
XFE_RC_1546_0 INV1S $PINS O=FE_RN_348_0 I=sll_17/ML_int[2][4]
XFE_RC_1545_0 MXL2HS $PINS OB=sll_17/ML_int[3][4] S=shf2[2] A=FE_RN_348_0
+ B=n105
XFE_RC_1527_0 INV1S $PINS O=FE_RN_340_0 I=sll_18/ML_int[2][5]
XFE_RC_1526_0 MXL2HS $PINS OB=sll_18/ML_int[3][5] S=shf3[2] A=FE_RN_340_0
+ B=n117
XFE_RC_1395_0 OR2B1S $PINS O=FE_RN_258_0 I1=FE_OFN53_s12_1 B1=n39
XFE_RC_1394_0 OR3 $PINS O=n105 I1=FE_RN_258_0 I2=FE_OFN283_mac_in_imag_0
+ I3=shf2[0]
XFE_RC_1389_0 INV1S $PINS O=FE_RN_254_0 I=FE_OFN174_h11_3
XFE_RC_1387_0 MUXB2 $PINS O=term1_shifted[5] S=n70 A=sll_16/ML_int[2][5] B=n100
+ EB=FE_RN_254_0
XFE_RC_1259_0 INV2 $PINS O=term1_shifted[8] I=FE_RN_190_0
XFE_RC_1258_0 MXL2HS $PINS OB=FE_RN_190_0 S=shf1[3] A=sll_16/ML_int[3][8]
+ B=sll_16/ML_int[3][0]
XFE_RC_1214_0 INV1S $PINS O=FE_RN_167_0 I=sll_17/ML_int[2][5]
XFE_RC_1213_0 MXL2HS $PINS OB=sll_17/ML_int[3][5] S=shf2[2] A=FE_RN_167_0 B=n1
XFE_RC_13_0 OA12 $PINS O=N151 A1=N124 B1=FE_OFN57_s13_0 B2=n30
XFE_RC_5_0 OA12 $PINS O=N41 A1=N14 B1=sign1[0] B2=n80
XFE_RC_4_0 OA12 $PINS O=N96 A1=N69 B1=FE_OFN338_s12_0 B2=FE_OFN54_s12_0
XFE_OFC701_h11_3 BUF1 $PINS O=FE_OFN360_h11_3 I=shf1[3]
XFE_OFC696_h13_2 BUF1 $PINS O=FE_OFN356_h13_2 I=shf3[2]
XFE_OFC678_n30 BUF1 $PINS O=FE_OFN351_n30 I=n30
XFE_OFC667_h11_3 INV1S $PINS O=FE_OFN174_h11_3 I=shf1[3]
XFE_OFC652_s12_0 INV1S $PINS O=FE_OFN338_s12_0 I=FE_OFN54_s12_0
XFE_OFC651_s12_0 INV1S $PINS O=FE_OFN337_s12_0 I=FE_OFN54_s12_0
XFE_OFC648_s12_0 INV2 $PINS O=FE_OFN54_s12_0 I=sign2[0]
XFE_OFC647_s12_0 BUF1 $PINS O=n57 I=sign2[0]
XFE_OFC585_h12_2 INV1S $PINS O=n43 I=shf2[2]
XFE_OFC572_sll_18_ML_int_2__3 INV1S $PINS O=n119 I=sll_18/ML_int[2][3]
XFE_OFC548_h11_2 INV2 $PINS O=n70 I=shf1[2]
XFE_OFC513_mac_in_imag_4 INV2 $PINS O=n139 I=x_in[4]
XFE_OFC478_s12_0 BUF1 $PINS O=FE_OFN269_n I=FE_OFN54_s12_0
XFE_OFC430_h11_1 BUF1 $PINS O=FE_OFN223_h11_1 I=shf1[1]
XFE_OFC429_h11_1 INV1S $PINS O=FE_OFN222_h11_1 I=shf1[1]
XFE_OFC428_h11_1 BUF1 $PINS O=n66 I=shf1[1]
XFE_OFC366_h13_2 INV1S $PINS O=n18 I=shf3[2]
XFE_OFC347_h13_1 INV2 $PINS O=n14 I=shf3[1]
XFE_OFC328_h13_3 INV1S $PINS O=n21 I=shf3[3]
XFE_OFC319_h12_0 INV1S $PINS O=FE_OFN180_h12_0 I=shf2[0]
XFE_OFC305_s12_1 BUF2 $PINS O=FE_OFN53_s12_1 I=sign2[1]
XFE_OFC303_h12_3 INV2 $PINS O=n47 I=shf2[3]
XFE_OFC289_pe_clear_d1 INV2 $PINS O=n144 I=clear
XFE_OFC218_s11_0 BUF1 $PINS O=FE_OFN153_s11_0 I=sign1[0]
XFE_OFC217_s11_0 INV2 $PINS O=n80 I=sign1[0]
XFE_OFC154_s13_0 INV1S $PINS O=n30 I=sign3[0]
XFE_OFC152_s13_0 BUF1 $PINS O=FE_OFN57_s13_0 I=sign3[0]
XU110 AO22 $PINS O=base_val[13] A1=acc_reg[13] A2=n144 B1=clear B2=stage_sel
XU113 AO22 $PINS O=N97 A1=N70 A2=FE_OFN338_s12_0 B1=term2_shifted[1]
+ B2=FE_OFN54_s12_0
XU115 AO22 $PINS O=N67 A1=sign1[0] A2=N40 B1=term1_shifted[26] B2=n80
XU116 AO22 $PINS O=N66 A1=N39 A2=sign1[0] B1=term1_shifted[25] B2=n80
XU117 AO22 $PINS O=N65 A1=N38 A2=sign1[0] B1=term1_shifted[24] B2=n80
XU119 AO22 $PINS O=N63 A1=N36 A2=sign1[0] B1=term1_shifted[22] B2=n80
XU120 AO22 $PINS O=N62 A1=N35 A2=sign1[0] B1=term1_shifted[21] B2=n80
XU121 AO22 $PINS O=N61 A1=N34 A2=sign1[0] B1=term1_shifted[20] B2=n80
XU122 AO22 $PINS O=N60 A1=N33 A2=sign1[0] B1=term1_shifted[19] B2=n80
XU123 AO22 $PINS O=N59 A1=N32 A2=sign1[0] B1=term1_shifted[18] B2=n80
XU124 AO22 $PINS O=N58 A1=N31 A2=sign1[0] B1=term1_shifted[17] B2=n80
XU125 AO22 $PINS O=N57 A1=N30 A2=sign1[0] B1=term1_shifted[16] B2=n80
XU126 AO22 $PINS O=N56 A1=N29 A2=FE_OFN153_s11_0 B1=term1_shifted[15] B2=n80
XU127 AO22 $PINS O=N55 A1=N28 A2=FE_OFN153_s11_0 B1=term1_shifted[14] B2=n80
XU128 AO22 $PINS O=N54 A1=N27 A2=FE_OFN153_s11_0 B1=term1_shifted[13] B2=n80
XU129 AO22 $PINS O=N53 A1=N26 A2=FE_OFN153_s11_0 B1=term1_shifted[12] B2=n80
XU131 AO22P $PINS O=N51 A1=N24 A2=FE_OFN153_s11_0 B1=term1_shifted[10] B2=n80
XU133 AO22 $PINS O=N49 A1=N22 A2=FE_OFN153_s11_0 B1=term1_shifted[8] B2=n80
XU138 AO22P $PINS O=N44 A1=N17 A2=sign1[0] B1=term1_shifted[3] B2=n80
XU142 AO22 $PINS O=N177 A1=sign3[0] A2=N150 B1=term3_shifted[26]
+ B2=FE_OFN351_n30
XU143 AO22 $PINS O=N176 A1=N149 A2=sign3[0] B1=term3_shifted[25]
+ B2=FE_OFN351_n30
XU144 AO22 $PINS O=N175 A1=N148 A2=sign3[0] B1=term3_shifted[24]
+ B2=FE_OFN351_n30
XU146 AO22 $PINS O=N173 A1=N146 A2=sign3[0] B1=term3_shifted[22]
+ B2=FE_OFN351_n30
XU147 AO22 $PINS O=N172 A1=N145 A2=sign3[0] B1=term3_shifted[21]
+ B2=FE_OFN351_n30
XU148 AO22 $PINS O=N171 A1=N144 A2=sign3[0] B1=term3_shifted[20]
+ B2=FE_OFN351_n30
XU149 AO22 $PINS O=N170 A1=N143 A2=sign3[0] B1=term3_shifted[19]
+ B2=FE_OFN351_n30
XU150 AO22 $PINS O=N169 A1=N142 A2=sign3[0] B1=term3_shifted[18]
+ B2=FE_OFN351_n30
XU151 AO22 $PINS O=N168 A1=N141 A2=sign3[0] B1=term3_shifted[17] B2=n30
XU152 AO22 $PINS O=N167 A1=N140 A2=FE_OFN57_s13_0 B1=term3_shifted[16] B2=n30
XU153 AO22 $PINS O=N166 A1=N139 A2=FE_OFN57_s13_0 B1=term3_shifted[15] B2=n30
XU154 AO22 $PINS O=N165 A1=N138 A2=FE_OFN57_s13_0 B1=term3_shifted[14]
+ B2=FE_OFN351_n30
XU155 AO22 $PINS O=N164 A1=N137 A2=FE_OFN57_s13_0 B1=term3_shifted[13]
+ B2=FE_OFN351_n30
XU156 AO22 $PINS O=N163 A1=N136 A2=FE_OFN57_s13_0 B1=term3_shifted[12]
+ B2=FE_OFN351_n30
XU158 AO22 $PINS O=N161 A1=N134 A2=FE_OFN57_s13_0 B1=term3_shifted[10]
+ B2=FE_OFN351_n30
XU159 AO22 $PINS O=N160 A1=N133 A2=FE_OFN57_s13_0 B1=term3_shifted[9]
+ B2=FE_OFN351_n30
XU160 AO22 $PINS O=N159 A1=N132 A2=FE_OFN57_s13_0 B1=term3_shifted[8]
+ B2=FE_OFN351_n30
XU167 AO22P $PINS O=N152 A1=N125 A2=FE_OFN57_s13_0 B1=term3_shifted[1] B2=n30
XU169 AO22 $PINS O=N122 A1=N95 A2=sign2[0] B1=term2_shifted[26] B2=FE_OFN269_n
XU170 AO22 $PINS O=N121 A1=N94 A2=sign2[0] B1=term2_shifted[25] B2=FE_OFN269_n
XU171 AO22 $PINS O=N120 A1=N93 A2=n57 B1=term2_shifted[24] B2=FE_OFN269_n
XU173 AO22 $PINS O=N118 A1=N91 A2=n57 B1=term2_shifted[22] B2=FE_OFN269_n
XU174 AO22 $PINS O=N117 A1=N90 A2=n57 B1=term2_shifted[21] B2=FE_OFN269_n
XU175 AO22 $PINS O=N116 A1=N89 A2=n57 B1=term2_shifted[20] B2=FE_OFN269_n
XU176 AO22 $PINS O=N115 A1=N88 A2=n57 B1=term2_shifted[19] B2=FE_OFN269_n
XU177 AO22 $PINS O=N114 A1=N87 A2=n57 B1=term2_shifted[18] B2=FE_OFN269_n
XU178 AO22 $PINS O=N113 A1=N86 A2=n57 B1=term2_shifted[17] B2=FE_OFN269_n
XU179 AO22 $PINS O=N112 A1=N85 A2=n57 B1=term2_shifted[16] B2=FE_OFN269_n
XU180 AO22 $PINS O=N111 A1=N84 A2=n57 B1=term2_shifted[15] B2=FE_OFN269_n
XU181 AO22 $PINS O=N110 A1=N83 A2=FE_OFN337_s12_0 B1=term2_shifted[14]
+ B2=FE_OFN54_s12_0
XU183 AO22 $PINS O=N108 A1=N81 A2=FE_OFN337_s12_0 B1=term2_shifted[12]
+ B2=FE_OFN54_s12_0
XU184 AO22 $PINS O=N107 A1=N80 A2=FE_OFN337_s12_0 B1=term2_shifted[11]
+ B2=FE_OFN54_s12_0
XU185 AO22 $PINS O=N106 A1=N79 A2=FE_OFN337_s12_0 B1=term2_shifted[10]
+ B2=FE_OFN54_s12_0
XU188 AO22 $PINS O=N103 A1=N76 A2=FE_OFN337_s12_0 B1=term2_shifted[7]
+ B2=FE_OFN54_s12_0
XU191 AO22P $PINS O=N100 A1=N73 A2=FE_OFN338_s12_0 B1=term2_shifted[4]
+ B2=FE_OFN54_s12_0
Xsll_18/M1_0_1 MUX2 $PINS O=sll_18/ML_int[1][1] S=shf3[0] A=term3_in[1]
+ B=term3_in[0]
Xsll_18/M1_0_2 MUX2 $PINS O=sll_18/ML_int[1][2] S=shf3[0] A=term3_in[2]
+ B=term3_in[1]
Xsll_18/M1_0_4 MUX2 $PINS O=sll_18/ML_int[1][4] S=shf3[0] A=term3_in[4]
+ B=term3_in[3]
Xsll_18/M1_0_6 MUX2 $PINS O=sll_18/ML_int[1][6] S=shf3[0] A=term3_in[6]
+ B=term3_in[5]
Xsll_18/M1_0_7 MUX2 $PINS O=sll_18/ML_int[1][7] S=shf3[0] A=term3_in[7]
+ B=term3_in[6]
Xsll_18/M1_0_9 MUX2 $PINS O=sll_18/ML_int[1][9] S=shf3[0] A=term3_in[9]
+ B=term3_in[8]
Xsll_18/M1_0_12 MUX2 $PINS O=sll_18/ML_int[1][12] S=shf3[0] A=term3_in[12]
+ B=term3_in[11]
Xsll_18/M1_1_2 MUX2 $PINS O=sll_18/ML_int[2][2] S=shf3[1] A=sll_18/ML_int[1][2]
+ B=sll_18/ML_int[1][0]
Xsll_18/M1_1_3 MUX2 $PINS O=sll_18/ML_int[2][3] S=shf3[1] A=sll_18/ML_int[1][3]
+ B=sll_18/ML_int[1][1]
Xsll_18/M1_1_4 MUX2 $PINS O=sll_18/ML_int[2][4] S=shf3[1] A=sll_18/ML_int[1][4]
+ B=sll_18/ML_int[1][2]
Xsll_18/M1_1_5 MUX2 $PINS O=sll_18/ML_int[2][5] S=shf3[1] A=sll_18/ML_int[1][5]
+ B=sll_18/ML_int[1][3]
Xsll_18/M1_1_6 MUX2 $PINS O=sll_18/ML_int[2][6] S=shf3[1] A=sll_18/ML_int[1][6]
+ B=sll_18/ML_int[1][4]
Xsll_18/M1_1_7 MUX2 $PINS O=sll_18/ML_int[2][7] S=shf3[1] A=sll_18/ML_int[1][7]
+ B=sll_18/ML_int[1][5]
Xsll_18/M1_1_8 MUX2 $PINS O=sll_18/ML_int[2][8] S=shf3[1] A=sll_18/ML_int[1][8]
+ B=sll_18/ML_int[1][6]
Xsll_18/M1_2_4 MUX2 $PINS O=sll_18/ML_int[3][4] S=shf3[2] A=sll_18/ML_int[2][4]
+ B=n121
Xsll_18/M1_2_6 MUX2 $PINS O=sll_18/ML_int[3][6] S=shf3[2] A=sll_18/ML_int[2][6]
+ B=sll_18/ML_int[2][2]
Xsll_18/M1_2_7 MUX2 $PINS O=sll_18/ML_int[3][7] S=shf3[2] A=sll_18/ML_int[2][7]
+ B=sll_18/ML_int[2][3]
Xsll_18/M1_2_8 MUX2 $PINS O=sll_18/ML_int[3][8] S=shf3[2] A=sll_18/ML_int[2][8]
+ B=sll_18/ML_int[2][4]
Xsll_18/M1_2_9 MUX2 $PINS O=sll_18/ML_int[3][9] S=shf3[2] A=sll_18/ML_int[2][9]
+ B=sll_18/ML_int[2][5]
Xsll_18/M1_2_10 MUX2 $PINS O=sll_18/ML_int[3][10] S=shf3[2]
+ A=sll_18/ML_int[2][10] B=sll_18/ML_int[2][6]
Xsll_18/M1_2_19 MUX2 $PINS O=sll_18/ML_int[3][19] S=FE_OFN356_h13_2 A=n3
+ B=sll_18/ML_int[2][15]
Xsll_18/M1_3_8 MUX2 $PINS O=term3_shifted[8] S=shf3[3] A=sll_18/ML_int[3][8]
+ B=sll_18/ML_int[3][0]
Xsll_18/M1_3_9 MUX2 $PINS O=term3_shifted[9] S=shf3[3] A=sll_18/ML_int[3][9]
+ B=sll_18/ML_int[3][1]
Xsll_18/M1_3_10 MUX2 $PINS O=term3_shifted[10] S=shf3[3] A=sll_18/ML_int[3][10]
+ B=sll_18/ML_int[3][2]
Xsll_18/M1_3_11 MUX2 $PINS O=term3_shifted[11] S=shf3[3] A=sll_18/ML_int[3][11]
+ B=sll_18/ML_int[3][3]
Xsll_18/M1_3_12 MUX2 $PINS O=term3_shifted[12] S=shf3[3] A=sll_18/ML_int[3][12]
+ B=sll_18/ML_int[3][4]
Xsll_18/M1_3_13 MUX2 $PINS O=term3_shifted[13] S=shf3[3] A=sll_18/ML_int[3][13]
+ B=sll_18/ML_int[3][5]
Xsll_18/M1_3_14 MUX2 $PINS O=term3_shifted[14] S=shf3[3] A=sll_18/ML_int[3][14]
+ B=sll_18/ML_int[3][6]
Xsll_18/M1_3_15 MUX2 $PINS O=term3_shifted[15] S=shf3[3] A=sll_18/ML_int[3][15]
+ B=sll_18/ML_int[3][7]
Xsll_18/M1_3_23 MUX2 $PINS O=term3_shifted[23] S=shf3[3] A=n3
+ B=sll_18/ML_int[3][15]
Xsll_17/M1_0_1 MUX2 $PINS O=sll_17/ML_int[1][1] S=shf2[0] A=term2_in[1]
+ B=term2_in[0]
Xsll_17/M1_0_2 MUX2 $PINS O=sll_17/ML_int[1][2] S=shf2[0] A=term2_in[2]
+ B=term2_in[1]
Xsll_17/M1_0_3 MUX2 $PINS O=sll_17/ML_int[1][3] S=shf2[0] A=term2_in[3]
+ B=term2_in[2]
Xsll_17/M1_0_4 MUX2 $PINS O=sll_17/ML_int[1][4] S=shf2[0] A=term2_in[4]
+ B=term2_in[3]
Xsll_17/M1_0_6 MUX2 $PINS O=sll_17/ML_int[1][6] S=shf2[0] A=term2_in[6]
+ B=term2_in[5]
Xsll_17/M1_0_7 MUX2 $PINS O=sll_17/ML_int[1][7] S=shf2[0] A=term2_in[7]
+ B=term2_in[6]
Xsll_17/M1_0_9 MUX2 $PINS O=sll_17/ML_int[1][9] S=shf2[0] A=term2_in[9]
+ B=term2_in[8]
Xsll_17/M1_0_12 MUX2 $PINS O=sll_17/ML_int[1][12] S=shf2[0] A=term2_in[12]
+ B=term2_in[11]
Xsll_17/M1_1_3 MUX2 $PINS O=sll_17/ML_int[2][3] S=shf2[1] A=sll_17/ML_int[1][3]
+ B=sll_17/ML_int[1][1]
Xsll_17/M1_1_4 MUX2 $PINS O=sll_17/ML_int[2][4] S=shf2[1] A=sll_17/ML_int[1][4]
+ B=sll_17/ML_int[1][2]
Xsll_17/M1_1_6 MUX2 $PINS O=sll_17/ML_int[2][6] S=shf2[1] A=sll_17/ML_int[1][6]
+ B=sll_17/ML_int[1][4]
Xsll_17/M1_1_7 MUX2 $PINS O=sll_17/ML_int[2][7] S=shf2[1] A=sll_17/ML_int[1][7]
+ B=sll_17/ML_int[1][5]
Xsll_17/M1_1_8 MUX2 $PINS O=sll_17/ML_int[2][8] S=shf2[1] A=sll_17/ML_int[1][8]
+ B=sll_17/ML_int[1][6]
Xsll_17/M1_2_6 MUX2 $PINS O=sll_17/ML_int[3][6] S=shf2[2] A=sll_17/ML_int[2][6]
+ B=sll_17/ML_int[2][2]
Xsll_17/M1_2_7 MUX2 $PINS O=sll_17/ML_int[3][7] S=shf2[2] A=sll_17/ML_int[2][7]
+ B=sll_17/ML_int[2][3]
Xsll_17/M1_2_8 MUX2 $PINS O=sll_17/ML_int[3][8] S=shf2[2] A=sll_17/ML_int[2][8]
+ B=sll_17/ML_int[2][4]
Xsll_17/M1_2_9 MUX2 $PINS O=sll_17/ML_int[3][9] S=shf2[2] A=sll_17/ML_int[2][9]
+ B=sll_17/ML_int[2][5]
Xsll_17/M1_2_10 MUX2 $PINS O=sll_17/ML_int[3][10] S=shf2[2]
+ A=sll_17/ML_int[2][10] B=sll_17/ML_int[2][6]
Xsll_17/M1_2_19 MUX2 $PINS O=sll_17/ML_int[3][19] S=shf2[2] A=n4
+ B=sll_17/ML_int[2][15]
Xsll_17/M1_3_9 MUX2 $PINS O=term2_shifted[9] S=shf2[3] A=sll_17/ML_int[3][9]
+ B=sll_17/ML_int[3][1]
Xsll_17/M1_3_10 MUX2 $PINS O=term2_shifted[10] S=shf2[3] A=sll_17/ML_int[3][10]
+ B=sll_17/ML_int[3][2]
Xsll_17/M1_3_11 MUX2 $PINS O=term2_shifted[11] S=shf2[3] A=sll_17/ML_int[3][11]
+ B=sll_17/ML_int[3][3]
Xsll_17/M1_3_12 MUX2 $PINS O=term2_shifted[12] S=shf2[3] A=sll_17/ML_int[3][12]
+ B=sll_17/ML_int[3][4]
Xsll_17/M1_3_13 MUX2 $PINS O=term2_shifted[13] S=shf2[3] A=sll_17/ML_int[3][13]
+ B=sll_17/ML_int[3][5]
Xsll_17/M1_3_14 MUX2 $PINS O=term2_shifted[14] S=shf2[3] A=sll_17/ML_int[3][14]
+ B=sll_17/ML_int[3][6]
Xsll_17/M1_3_23 MUX2 $PINS O=term2_shifted[23] S=shf2[3] A=n4
+ B=sll_17/ML_int[3][15]
Xsll_16/M1_0_1 MUX2 $PINS O=sll_16/ML_int[1][1] S=shf1[0] A=term1_in[1]
+ B=term1_in[0]
Xsll_16/M1_0_4 MUX2 $PINS O=sll_16/ML_int[1][4] S=shf1[0] A=term1_in[4]
+ B=term1_in[3]
Xsll_16/M1_0_5 MUX2 $PINS O=sll_16/ML_int[1][5] S=shf1[0] A=term1_in[5]
+ B=term1_in[4]
Xsll_16/M1_0_6 MUX2 $PINS O=sll_16/ML_int[1][6] S=shf1[0] A=term1_in[6]
+ B=term1_in[5]
Xsll_16/M1_0_9 MUX2 $PINS O=sll_16/ML_int[1][9] S=shf1[0] A=term1_in[9]
+ B=term1_in[8]
Xsll_16/M1_0_12 MUX2 $PINS O=sll_16/ML_int[1][12] S=shf1[0] A=term1_in[12]
+ B=term1_in[11]
Xsll_16/M1_1_4 MUX2 $PINS O=sll_16/ML_int[2][4] S=FE_OFN223_h11_1
+ A=sll_16/ML_int[1][4] B=sll_16/ML_int[1][2]
Xsll_16/M1_1_6 MUX2 $PINS O=sll_16/ML_int[2][6] S=FE_OFN223_h11_1
+ A=sll_16/ML_int[1][6] B=sll_16/ML_int[1][4]
Xsll_16/M1_1_7 MUX2 $PINS O=sll_16/ML_int[2][7] S=FE_OFN223_h11_1
+ A=sll_16/ML_int[1][7] B=sll_16/ML_int[1][5]
Xsll_16/M1_1_8 MUX2 $PINS O=sll_16/ML_int[2][8] S=FE_OFN223_h11_1
+ A=sll_16/ML_int[1][8] B=sll_16/ML_int[1][6]
Xsll_16/M1_2_5 MUX2 $PINS O=sll_16/ML_int[3][5] S=n70 A=sll_16/ML_int[2][5]
+ B=n100
Xsll_16/M1_2_6 MUX2 $PINS O=sll_16/ML_int[3][6] S=n70 A=sll_16/ML_int[2][6]
+ B=sll_16/ML_int[2][2]
Xsll_16/M1_2_7 MUX2 $PINS O=sll_16/ML_int[3][7] S=n70 A=sll_16/ML_int[2][7]
+ B=sll_16/ML_int[2][3]
Xsll_16/M1_2_8 MUX2 $PINS O=sll_16/ML_int[3][8] S=n70 A=sll_16/ML_int[2][8]
+ B=sll_16/ML_int[2][4]
Xsll_16/M1_2_9 MUX2 $PINS O=sll_16/ML_int[3][9] S=n70 A=sll_16/ML_int[2][9]
+ B=sll_16/ML_int[2][5]
Xsll_16/M1_2_10 MUX2 $PINS O=sll_16/ML_int[3][10] S=n70 A=sll_16/ML_int[2][10]
+ B=sll_16/ML_int[2][6]
Xsll_16/M1_2_19 MUX2 $PINS O=sll_16/ML_int[3][19] S=n70 A=n2
+ B=sll_16/ML_int[2][15]
Xsll_16/M1_3_9 MUX2 $PINS O=term1_shifted[9] S=shf1[3] A=sll_16/ML_int[3][9]
+ B=sll_16/ML_int[3][1]
Xsll_16/M1_3_10 MUX2 $PINS O=term1_shifted[10] S=shf1[3] A=sll_16/ML_int[3][10]
+ B=sll_16/ML_int[3][2]
Xsll_16/M1_3_11 MUX2 $PINS O=term1_shifted[11] S=FE_OFN360_h11_3
+ A=sll_16/ML_int[3][11] B=sll_16/ML_int[3][3]
Xsll_16/M1_3_12 MUX2 $PINS O=term1_shifted[12] S=shf1[3] A=sll_16/ML_int[3][12]
+ B=sll_16/ML_int[3][4]
Xsll_16/M1_3_13 MUX2 $PINS O=term1_shifted[13] S=shf1[3] A=sll_16/ML_int[3][13]
+ B=sll_16/ML_int[3][5]
Xsll_16/M1_3_14 MUX2 $PINS O=term1_shifted[14] S=shf1[3] A=sll_16/ML_int[3][14]
+ B=sll_16/ML_int[3][6]
Xsll_16/M1_3_23 MUX2 $PINS O=term1_shifted[23] S=FE_OFN360_h11_3 A=n2
+ B=sll_16/ML_int[3][15]
Xy_out_reg[10] QDFFRBN $PINS Q=y_out[10] D=N245 CK=net2243 RB=i_rst_n
Xy_out_reg[9] QDFFRBN $PINS Q=y_out[9] D=N244 CK=net2243 RB=i_rst_n
Xy_out_reg[8] QDFFRBN $PINS Q=y_out[8] D=FE_PHN1205_N243 CK=net2243 RB=i_rst_n
Xy_out_reg[7] QDFFRBN $PINS Q=FE_PHN1114_pe_i1_7 D=FE_PHN1208_N242 CK=net2243
+ RB=FE_OFN29_i_rst_n
Xy_out_reg[6] QDFFRBN $PINS Q=y_out[6] D=N241 CK=net2243 RB=FE_OFN29_i_rst_n
Xy_out_reg[5] QDFFRBN $PINS Q=y_out[5] D=FE_PHN1201_N240 CK=net2243
+ RB=FE_OFN29_i_rst_n
Xy_out_reg[4] QDFFRBN $PINS Q=y_out[4] D=N239 CK=net2243 RB=FE_OFN29_i_rst_n
Xy_out_reg[3] QDFFRBN $PINS Q=FE_PHN1115_pe_i1_3 D=N238 CK=net2243
+ RB=FE_OFN29_i_rst_n
Xy_out_reg[2] QDFFRBN $PINS Q=y_out[2] D=N237 CK=net2243 RB=FE_OFN29_i_rst_n
Xy_out_reg[1] QDFFRBN $PINS Q=FE_PHN1118_pe_i1_1 D=FE_PHN1231_N236 CK=net2243
+ RB=FE_OFN29_i_rst_n
Xy_out_reg[0] QDFFRBN $PINS Q=y_out[0] D=N235 CK=net2243 RB=FE_OFN29_i_rst_n
Xacc_reg_reg[26] QDFFRBP $PINS Q=N251 D=next_acc[26] CK=clk RB=FE_OFN20_i_rst_n
Xacc_reg_reg[25] QDFFRBN $PINS Q=acc_reg[25] D=next_acc[25] CK=clk_clone2
+ RB=FE_OFN29_i_rst_n
Xacc_reg_reg[24] QDFFRBN $PINS Q=acc_reg[24] D=next_acc[24] CK=clk_clone2
+ RB=FE_OFN29_i_rst_n
Xacc_reg_reg[23] QDFFRBN $PINS Q=acc_reg[23] D=next_acc[23] CK=clk_clone2
+ RB=FE_OFN29_i_rst_n
Xacc_reg_reg[22] QDFFRBN $PINS Q=acc_reg[22] D=next_acc[22] CK=clk_clone2
+ RB=FE_OFN29_i_rst_n
Xacc_reg_reg[21] QDFFRBN $PINS Q=acc_reg[21] D=next_acc[21] CK=clk_clone2
+ RB=FE_OFN29_i_rst_n
Xacc_reg_reg[20] QDFFRBN $PINS Q=acc_reg[20] D=next_acc[20] CK=clk_clone2
+ RB=FE_OFN29_i_rst_n
Xacc_reg_reg[19] QDFFRBN $PINS Q=acc_reg[19] D=next_acc[19] CK=clk_clone2
+ RB=FE_OFN29_i_rst_n
Xacc_reg_reg[18] QDFFRBN $PINS Q=acc_reg[18] D=next_acc[18] CK=clk_clone2
+ RB=FE_OFN29_i_rst_n
Xacc_reg_reg[17] QDFFRBN $PINS Q=acc_reg[17] D=next_acc[17] CK=clk_clone2
+ RB=FE_OFN29_i_rst_n
Xacc_reg_reg[16] QDFFRBN $PINS Q=acc_reg[16] D=next_acc[16] CK=clk_clone2
+ RB=i_rst_n
Xacc_reg_reg[15] QDFFRBN $PINS Q=acc_reg[15] D=next_acc[15] CK=clk_clone2
+ RB=i_rst_n
Xacc_reg_reg[14] QDFFRBN $PINS Q=acc_reg[14] D=next_acc[14] CK=clk_clone2
+ RB=i_rst_n
Xacc_reg_reg[13] QDFFRBN $PINS Q=acc_reg[13] D=next_acc[13] CK=clk_clone2
+ RB=i_rst_n
Xacc_reg_reg[12] QDFFRBN $PINS Q=acc_reg[12] D=next_acc[12] CK=clk_clone2
+ RB=i_rst_n
Xacc_reg_reg[11] QDFFRBN $PINS Q=acc_reg[11] D=next_acc[11] CK=clk_clone2
+ RB=i_rst_n
Xacc_reg_reg[10] QDFFRBN $PINS Q=acc_reg[10] D=next_acc[10] CK=clk_clone2
+ RB=i_rst_n
Xacc_reg_reg[9] QDFFRBN $PINS Q=acc_reg[9] D=next_acc[9] CK=clk
+ RB=FE_OFN20_i_rst_n
Xacc_reg_reg[8] QDFFRBN $PINS Q=acc_reg[8] D=next_acc[8] CK=clk
+ RB=FE_OFN20_i_rst_n
Xacc_reg_reg[7] QDFFRBN $PINS Q=acc_reg[7] D=next_acc[7] CK=clk
+ RB=FE_OFN20_i_rst_n
Xacc_reg_reg[6] QDFFRBN $PINS Q=acc_reg[6] D=next_acc[6] CK=clk
+ RB=FE_OFN20_i_rst_n
Xacc_reg_reg[5] QDFFRBN $PINS Q=acc_reg[5] D=next_acc[5] CK=clk
+ RB=FE_OFN20_i_rst_n
Xacc_reg_reg[4] QDFFRBN $PINS Q=acc_reg[4] D=next_acc[4] CK=clk
+ RB=FE_OFN20_i_rst_n
Xacc_reg_reg[3] QDFFRBN $PINS Q=acc_reg[3] D=next_acc[3] CK=clk
+ RB=FE_OFN20_i_rst_n
Xacc_reg_reg[2] QDFFRBN $PINS Q=acc_reg[2] D=next_acc[2] CK=clk
+ RB=FE_OFN20_i_rst_n
Xacc_reg_reg[0] QDFFRBN $PINS Q=acc_reg[0] D=next_acc[0] CK=clk
+ RB=FE_OFN20_i_rst_n
Xacc_reg_reg[1] QDFFRBN $PINS Q=acc_reg[1] D=next_acc[1] CK=clk
+ RB=FE_OFN20_i_rst_n
Xy_out_reg[16] QDFFRBN $PINS Q=FE_PHN809_pe_i1_16 D=FE_PHN775_N251 CK=net2243
+ RB=FE_OFN33_i_rst_n
Xy_out_reg[15] QDFFRBN $PINS Q=FE_PHN802_pe_i1_15 D=N250 CK=net2243
+ RB=FE_OFN36_i_rst_n
Xy_out_reg[14] QDFFRBN $PINS Q=y_out[14] D=FE_PHN1260_N249 CK=net2243
+ RB=FE_OFN33_i_rst_n
Xy_out_reg[13] QDFFRBN $PINS Q=y_out[13] D=FE_PHN1236_N248 CK=net2243
+ RB=i_rst_n
Xy_out_reg[12] QDFFRBN $PINS Q=FE_PHN806_pe_i1_12 D=FE_PHN1200_N247 CK=net2243
+ RB=i_rst_n
Xy_out_reg[11] QDFFRBN $PINS Q=FE_PHN790_pe_i1_11 D=FE_PHN1222_N246 CK=net2243
+ RB=FE_OFN33_i_rst_n
XU15 MUX2 $PINS O=sll_17/ML_int[2][5] S=shf2[1] A=sll_17/ML_int[1][5]
+ B=sll_17/ML_int[1][3]
XU16 NR2 $PINS O=term1_shifted[0] I1=n97 I2=n95
XU19 AO22 $PINS O=N98 A1=N71 A2=FE_OFN338_s12_0 B1=term2_shifted[2]
+ B2=FE_OFN54_s12_0
XU23 MUX2 $PINS O=N247 S=stage_sel A=acc_reg[22] B=FE_PHN775_N251
XU24 MUX2 $PINS O=N248 S=stage_sel A=acc_reg[23] B=FE_PHN775_N251
XU25 NR2P $PINS O=term1_in[0] I1=sign1[1] I2=FE_OFN283_mac_in_imag_0
XU27 MUX2 $PINS O=N249 S=stage_sel A=acc_reg[24] B=FE_PHN775_N251
XU29 MUX2 $PINS O=FE_PHN1249_N250 S=stage_sel A=acc_reg[25] B=FE_PHN775_N251
XU30 MUX2 $PINS O=sll_18/ML_int[1][5] S=shf3[0] A=term3_in[5] B=term3_in[4]
XU31 MUX2 $PINS O=sll_18/ML_int[1][3] S=shf3[0] A=term3_in[3] B=term3_in[2]
XU36 ND2P $PINS O=n97 I1=shf1[2] I2=FE_OFN174_h11_3
XU37 NR2 $PINS O=term1_in[2] I1=sign1[1] I2=x_in[2]
XU38 MUX2 $PINS O=sll_16/ML_int[1][3] S=shf1[0] A=term1_in[3] B=term1_in[2]
XU44 NR2 $PINS O=term2_in[1] I1=FE_OFN53_s12_1 I2=FE_OFN187_mac_in_imag_1
XU46 NR2P $PINS O=term1_shifted[3] I1=n97 I2=n98
XU49 NR2 $PINS O=term2_in[4] I1=FE_OFN53_s12_1 I2=n139
XU50 NR2P $PINS O=term3_shifted[2] I1=n118 I2=n120
XU51 NR2P $PINS O=term3_shifted[0] I1=n118 I2=n116
XU54 MUX2 $PINS O=sll_17/ML_int[1][5] S=shf2[0] A=term2_in[5] B=term2_in[4]
XU57 AN2 $PINS O=base_val[6] I1=acc_reg[6] I2=n144
XU58 AO22 $PINS O=N105 A1=N78 A2=FE_OFN337_s12_0 B1=term2_shifted[9]
+ B2=FE_OFN54_s12_0
XU59 MOAI1S $PINS O=base_val[9] A1=stage_sel A2=n144 B1=acc_reg[9] B2=n144
XU60 AO22P $PINS O=N50 A1=FE_OFN153_s11_0 A2=N23 B1=term1_shifted[9] B2=n80
XU66 NR2 $PINS O=term2_in[6] I1=FE_OFN53_s12_1 I2=x_in[6]
XU67 NR2 $PINS O=term2_in[0] I1=FE_OFN53_s12_1 I2=FE_OFN283_mac_in_imag_0
XU68 NR2 $PINS O=term3_in[0] I1=sign3[1] I2=FE_OFN283_mac_in_imag_0
XU70 AN2 $PINS O=sll_16/ML_int[1][0] I1=n63 I2=term1_in[0]
XU75 ND2 $PINS O=n116 I1=sll_18/ML_int[1][0] I2=n14
XU79 AO22 $PINS O=N109 A1=N82 A2=FE_OFN337_s12_0 B1=term2_shifted[13]
+ B2=FE_OFN54_s12_0
XU80 AO22 $PINS O=N174 A1=N147 A2=sign3[0] B1=term3_shifted[23]
+ B2=FE_OFN351_n30
XU89 AN2T $PINS O=term1_shifted[4] I1=sll_16/ML_int[3][4] I2=FE_OFN174_h11_3
XU91 AO22S $PINS O=N119 A1=N92 A2=n57 B1=term2_shifted[23] B2=FE_OFN269_n
XU94 AO22 $PINS O=N104 A1=N77 A2=FE_OFN337_s12_0 B1=term2_shifted[8]
+ B2=FE_OFN54_s12_0
XU95 AO22P $PINS O=N48 A1=N21 A2=FE_OFN153_s11_0 B1=term1_shifted[7] B2=n80
XU96 AO22 $PINS O=N158 A1=N131 A2=FE_OFN57_s13_0 B1=term3_shifted[7]
+ B2=FE_OFN351_n30
XU99 NR2 $PINS O=n2 I1=n133 I2=FE_OFN368_FE_OFN232_s11_1
XU100 MUX2S $PINS O=n104 S=shf1[0] A=n2 B=term1_in[15]
XU101 NR2 $PINS O=n3 I1=n133 I2=sign3[1]
XU102 MUX2S $PINS O=n126 S=shf3[0] A=term3_in[26] B=term3_in[15]
XU103 NR2 $PINS O=n4 I1=n133 I2=FE_OFN53_s12_1
XU104 MUX2S $PINS O=n115 S=shf2[0] A=term2_in[26] B=term2_in[15]
XU105 AN2S $PINS O=n5 I1=sll_16/ML_int[1][0] I2=FE_OFN222_h11_1
XU106 AO22S $PINS O=N64 A1=N37 A2=sign1[0] B1=term1_shifted[23] B2=n80
XU107 NR2 $PINS O=term3_in[1] I1=sign3[1] I2=FE_OFN187_mac_in_imag_1
XU118 MUX2S $PINS O=sll_18/ML_int[2][9] S=shf3[1] A=sll_18/ML_int[1][9]
+ B=sll_18/ML_int[1][7]
XU130 MUX2 $PINS O=sll_16/ML_int[2][9] S=n66 A=sll_16/ML_int[1][9]
+ B=sll_16/ML_int[1][7]
XU132 MUX2 $PINS O=sll_17/ML_int[2][9] S=shf2[1] A=sll_17/ML_int[1][9]
+ B=sll_17/ML_int[1][7]
XU134 MUX2 $PINS O=sll_18/ML_int[1][8] S=shf3[0] A=term3_in[8] B=term3_in[7]
XU136 MUX2 $PINS O=sll_16/ML_int[1][8] S=shf1[0] A=term1_in[8] B=term1_in[7]
XU139 MUX2 $PINS O=sll_17/ML_int[1][8] S=shf2[0] A=term2_in[8] B=term2_in[7]
XU140 MUX2S $PINS O=sll_18/ML_int[2][10] S=shf3[1] A=sll_18/ML_int[1][10]
+ B=sll_18/ML_int[1][8]
XU141 MUX2S $PINS O=sll_18/ML_int[1][10] S=shf3[0] A=term3_in[10] B=term3_in[9]
XU145 MUX2S $PINS O=sll_16/ML_int[2][10] S=FE_OFN223_h11_1
+ A=sll_16/ML_int[1][10] B=sll_16/ML_int[1][8]
XU157 MUX2S $PINS O=sll_16/ML_int[1][10] S=shf1[0] A=term1_in[10] B=term1_in[9]
XU161 MUX2 $PINS O=sll_17/ML_int[2][10] S=shf2[1] A=sll_17/ML_int[1][10]
+ B=sll_17/ML_int[1][8]
XU162 MUX2S $PINS O=sll_17/ML_int[1][10] S=shf2[0] A=term2_in[10] B=term2_in[9]
XU163 MUX2S $PINS O=sll_18/ML_int[2][11] S=shf3[1] A=sll_18/ML_int[1][11]
+ B=sll_18/ML_int[1][9]
XU166 MUX2S $PINS O=sll_18/ML_int[3][11] S=FE_OFN356_h13_2
+ A=sll_18/ML_int[2][11] B=sll_18/ML_int[2][7]
XU172 MUX2S $PINS O=sll_16/ML_int[2][11] S=n66 A=sll_16/ML_int[1][11]
+ B=sll_16/ML_int[1][9]
XU182 MUX2S $PINS O=sll_16/ML_int[3][11] S=n70 A=sll_16/ML_int[2][11]
+ B=sll_16/ML_int[2][7]
XU186 MUX2S $PINS O=sll_17/ML_int[2][11] S=shf2[1] A=sll_17/ML_int[1][11]
+ B=sll_17/ML_int[1][9]
XU187 MUX2S $PINS O=sll_17/ML_int[3][11] S=shf2[2] A=sll_17/ML_int[2][11]
+ B=sll_17/ML_int[2][7]
XU189 MUX2S $PINS O=sll_18/ML_int[2][12] S=shf3[1] A=sll_18/ML_int[1][12]
+ B=sll_18/ML_int[1][10]
XU192 MUX2S $PINS O=sll_18/ML_int[3][12] S=FE_OFN356_h13_2
+ A=sll_18/ML_int[2][12] B=sll_18/ML_int[2][8]
XU193 MUX2S $PINS O=sll_16/ML_int[2][12] S=shf1[1] A=sll_16/ML_int[1][12]
+ B=sll_16/ML_int[1][10]
XU194 MUX2S $PINS O=sll_16/ML_int[3][12] S=n70 A=sll_16/ML_int[2][12]
+ B=sll_16/ML_int[2][8]
XU195 MUX2S $PINS O=sll_17/ML_int[2][12] S=shf2[1] A=sll_17/ML_int[1][12]
+ B=sll_17/ML_int[1][10]
XU196 MUX2S $PINS O=sll_17/ML_int[3][12] S=shf2[2] A=sll_17/ML_int[2][12]
+ B=sll_17/ML_int[2][8]
XU197 MUX2S $PINS O=sll_18/ML_int[1][11] S=shf3[0] A=term3_in[11]
+ B=term3_in[10]
XU198 MUX2S $PINS O=sll_16/ML_int[1][11] S=shf1[0] A=term1_in[11]
+ B=term1_in[10]
XU199 MUX2S $PINS O=sll_17/ML_int[1][11] S=shf2[0] A=term2_in[11]
+ B=term2_in[10]
XU200 MUX2S $PINS O=sll_18/ML_int[3][13] S=FE_OFN356_h13_2
+ A=sll_18/ML_int[2][13] B=sll_18/ML_int[2][9]
XU201 MUX2S $PINS O=sll_18/ML_int[2][13] S=shf3[1] A=sll_18/ML_int[1][13]
+ B=sll_18/ML_int[1][11]
XU202 MUX2S $PINS O=sll_18/ML_int[1][13] S=shf3[0] A=term3_in[13]
+ B=term3_in[12]
XU203 MUX2S $PINS O=sll_16/ML_int[3][13] S=n70 A=sll_16/ML_int[2][13]
+ B=sll_16/ML_int[2][9]
XU204 MUX2S $PINS O=sll_16/ML_int[2][13] S=n66 A=sll_16/ML_int[1][13]
+ B=sll_16/ML_int[1][11]
XU205 MUX2S $PINS O=sll_16/ML_int[1][13] S=shf1[0] A=term1_in[13]
+ B=term1_in[12]
XU206 MUX2S $PINS O=sll_17/ML_int[3][13] S=shf2[2] A=sll_17/ML_int[2][13]
+ B=sll_17/ML_int[2][9]
XU207 MUX2S $PINS O=sll_17/ML_int[2][13] S=shf2[1] A=sll_17/ML_int[1][13]
+ B=sll_17/ML_int[1][11]
XU208 MUX2S $PINS O=sll_17/ML_int[1][13] S=shf2[0] A=term2_in[13]
+ B=term2_in[12]
XU209 MUX2S $PINS O=sll_18/ML_int[3][14] S=FE_OFN356_h13_2
+ A=sll_18/ML_int[2][14] B=sll_18/ML_int[2][10]
XU210 MUX2S $PINS O=sll_18/ML_int[2][14] S=shf3[1] A=sll_18/ML_int[1][14]
+ B=sll_18/ML_int[1][12]
XU211 MUX2S $PINS O=sll_18/ML_int[1][14] S=shf3[0] A=term3_in[14]
+ B=term3_in[13]
XU212 MUX2S $PINS O=sll_16/ML_int[3][14] S=n70 A=sll_16/ML_int[2][14]
+ B=sll_16/ML_int[2][10]
XU213 MUX2S $PINS O=sll_16/ML_int[2][14] S=shf1[1] A=sll_16/ML_int[1][14]
+ B=sll_16/ML_int[1][12]
XU214 MUX2S $PINS O=sll_16/ML_int[1][14] S=shf1[0] A=term1_in[14]
+ B=term1_in[13]
XU215 MUX2S $PINS O=sll_17/ML_int[3][14] S=shf2[2] A=sll_17/ML_int[2][14]
+ B=sll_17/ML_int[2][10]
XU216 MUX2S $PINS O=sll_17/ML_int[2][14] S=shf2[1] A=sll_17/ML_int[1][14]
+ B=sll_17/ML_int[1][12]
XU217 MUX2S $PINS O=sll_17/ML_int[1][14] S=shf2[0] A=term2_in[14]
+ B=term2_in[13]
XU218 MUX2S $PINS O=sll_18/ML_int[3][15] S=FE_OFN356_h13_2
+ A=sll_18/ML_int[2][15] B=sll_18/ML_int[2][11]
XU219 MUX2S $PINS O=sll_18/ML_int[2][15] S=shf3[1] A=sll_18/ML_int[1][15]
+ B=sll_18/ML_int[1][13]
XU220 MUX2S $PINS O=sll_18/ML_int[1][15] S=shf3[0] A=term3_in[15]
+ B=term3_in[14]
XU221 MUX2S $PINS O=term1_shifted[15] S=FE_OFN360_h11_3 A=sll_16/ML_int[3][15]
+ B=sll_16/ML_int[3][7]
XU222 MUX2S $PINS O=sll_16/ML_int[3][15] S=n70 A=sll_16/ML_int[2][15]
+ B=sll_16/ML_int[2][11]
XU223 MUX2S $PINS O=sll_16/ML_int[2][15] S=n66 A=sll_16/ML_int[1][15]
+ B=sll_16/ML_int[1][13]
XU224 MUX2S $PINS O=sll_16/ML_int[1][15] S=shf1[0] A=term1_in[15]
+ B=term1_in[14]
XU225 MUX2S $PINS O=term2_shifted[15] S=shf2[3] A=sll_17/ML_int[3][15]
+ B=sll_17/ML_int[3][7]
XU226 MUX2S $PINS O=sll_17/ML_int[3][15] S=shf2[2] A=sll_17/ML_int[2][15]
+ B=sll_17/ML_int[2][11]
XU227 MUX2S $PINS O=sll_17/ML_int[2][15] S=shf2[1] A=sll_17/ML_int[1][15]
+ B=sll_17/ML_int[1][13]
XU228 MUX2S $PINS O=sll_17/ML_int[1][15] S=shf2[0] A=term2_in[15]
+ B=term2_in[14]
XU229 MUX2S $PINS O=term3_shifted[16] S=shf3[3] A=sll_18/ML_int[3][16]
+ B=sll_18/ML_int[3][8]
XU230 MUX2S $PINS O=n123 S=shf3[1] A=n126 B=sll_18/ML_int[1][14]
XU231 MUX2S $PINS O=term1_shifted[16] S=shf1[3] A=sll_16/ML_int[3][16]
+ B=sll_16/ML_int[3][8]
XU232 MUX2S $PINS O=n101 S=n66 A=n104 B=sll_16/ML_int[1][14]
XU233 MUX2S $PINS O=term2_shifted[16] S=shf2[3] A=sll_17/ML_int[3][16]
+ B=sll_17/ML_int[3][8]
XU234 MUX2S $PINS O=n112 S=shf2[1] A=n115 B=sll_17/ML_int[1][14]
XU235 MUX2S $PINS O=term1_shifted[17] S=shf1[3] A=sll_16/ML_int[3][17]
+ B=sll_16/ML_int[3][9]
XU236 MUX2S $PINS O=term3_shifted[17] S=shf3[3] A=sll_18/ML_int[3][17]
+ B=sll_18/ML_int[3][9]
XU237 MUX2S $PINS O=term2_shifted[17] S=shf2[3] A=sll_17/ML_int[3][17]
+ B=sll_17/ML_int[3][9]
XU238 MUX2S $PINS O=term3_shifted[18] S=shf3[3] A=sll_18/ML_int[3][18]
+ B=sll_18/ML_int[3][10]
XU239 MUX2S $PINS O=term1_shifted[18] S=FE_OFN360_h11_3 A=sll_16/ML_int[3][18]
+ B=sll_16/ML_int[3][10]
XU240 MUX2S $PINS O=term2_shifted[18] S=shf2[3] A=sll_17/ML_int[3][18]
+ B=sll_17/ML_int[3][10]
XU241 AN2T $PINS O=term3_shifted[7] I1=sll_18/ML_int[3][7] I2=n21
XU245 MUX2S $PINS O=sll_18/ML_int[3][16] S=FE_OFN356_h13_2 A=n123
+ B=sll_18/ML_int[2][12]
XU246 MUX2S $PINS O=sll_16/ML_int[3][16] S=n70 A=n101 B=sll_16/ML_int[2][12]
XU247 MUX2S $PINS O=sll_17/ML_int[3][16] S=shf2[2] A=n112
+ B=sll_17/ML_int[2][12]
XU248 MUX2S $PINS O=n102 S=n66 A=n2 B=sll_16/ML_int[1][15]
XU249 MUX2S $PINS O=sll_16/ML_int[3][17] S=n70 A=n102 B=sll_16/ML_int[2][13]
XU250 MUX2S $PINS O=n124 S=shf3[1] A=n3 B=sll_18/ML_int[1][15]
XU251 MUX2S $PINS O=sll_18/ML_int[3][17] S=FE_OFN356_h13_2 A=n124
+ B=sll_18/ML_int[2][13]
XU253 MUX2S $PINS O=n113 S=shf2[1] A=n4 B=sll_17/ML_int[1][15]
XU254 MUX2S $PINS O=sll_17/ML_int[3][17] S=shf2[2] A=n113
+ B=sll_17/ML_int[2][13]
XU255 MUX2S $PINS O=n125 S=n14 A=n126 B=term3_in[26]
XU256 MUX2S $PINS O=sll_18/ML_int[3][18] S=FE_OFN356_h13_2 A=n125
+ B=sll_18/ML_int[2][14]
XU257 MUX2S $PINS O=n103 S=FE_OFN222_h11_1 A=n104 B=n2
XU258 MUX2S $PINS O=sll_16/ML_int[3][18] S=n70 A=n103 B=sll_16/ML_int[2][14]
XU259 MUX2S $PINS O=n114 S=n39 A=n115 B=term2_in[26]
XU260 MUX2S $PINS O=sll_17/ML_int[3][18] S=shf2[2] A=n114
+ B=sll_17/ML_int[2][14]
XU261 MUX2S $PINS O=term3_shifted[19] S=shf3[3] A=sll_18/ML_int[3][19]
+ B=sll_18/ML_int[3][11]
XU262 MUX2S $PINS O=term1_shifted[19] S=FE_OFN360_h11_3 A=sll_16/ML_int[3][19]
+ B=sll_16/ML_int[3][11]
XU263 MUX2S $PINS O=term2_shifted[19] S=shf2[3] A=sll_17/ML_int[3][19]
+ B=sll_17/ML_int[3][11]
XU264 MUX2S $PINS O=term3_shifted[20] S=shf3[3] A=sll_18/ML_int[3][20]
+ B=sll_18/ML_int[3][12]
XU265 MUX2S $PINS O=sll_18/ML_int[3][20] S=FE_OFN356_h13_2 A=term3_in[26]
+ B=n123
XU266 MUX2S $PINS O=term1_shifted[20] S=shf1[3] A=sll_16/ML_int[3][20]
+ B=sll_16/ML_int[3][12]
XU267 MUX2S $PINS O=sll_16/ML_int[3][20] S=n70 A=n2 B=n101
XU268 MUX2S $PINS O=term2_shifted[20] S=shf2[3] A=sll_17/ML_int[3][20]
+ B=sll_17/ML_int[3][12]
XU269 MUX2S $PINS O=sll_17/ML_int[3][20] S=shf2[2] A=term2_in[26] B=n112
XU271 MUX2S $PINS O=term3_shifted[21] S=shf3[3] A=sll_18/ML_int[3][21]
+ B=sll_18/ML_int[3][13]
XU272 MUX2S $PINS O=term1_shifted[21] S=FE_OFN360_h11_3 A=sll_16/ML_int[3][21]
+ B=sll_16/ML_int[3][13]
XU273 MUX2S $PINS O=term2_shifted[21] S=shf2[3] A=sll_17/ML_int[3][21]
+ B=sll_17/ML_int[3][13]
XU274 MUX2S $PINS O=term3_shifted[22] S=shf3[3] A=sll_18/ML_int[3][22]
+ B=sll_18/ML_int[3][14]
XU275 MUX2S $PINS O=term1_shifted[22] S=FE_OFN360_h11_3 A=sll_16/ML_int[3][22]
+ B=sll_16/ML_int[3][14]
XU276 MUX2S $PINS O=term2_shifted[22] S=shf2[3] A=sll_17/ML_int[3][22]
+ B=sll_17/ML_int[3][14]
XU279 AN2S $PINS O=base_val[1] I1=acc_reg[1] I2=n144
XU281 MUX2S $PINS O=FE_PHN1268_N235 S=stage_sel A=acc_reg[10] B=acc_reg[14]
XU282 MUX2S $PINS O=FE_PHN1228_N244 S=stage_sel A=FE_PHN860_acc_reg_19
+ B=acc_reg[23]
XU289 INV1S $PINS O=n120 I=sll_18/ML_int[2][2]
XU291 AO22P $PINS O=N157 A1=N130 A2=FE_OFN57_s13_0 B1=term3_shifted[6]
+ B2=FE_OFN351_n30
XU299 NR2 $PINS O=term3_in[2] I1=sign3[1] I2=x_in[2]
XU300 NR2 $PINS O=term1_in[4] I1=sign1[1] I2=n139
XU302 NR2 $PINS O=term3_in[4] I1=sign3[1] I2=n139
XU303 INV1S $PINS O=n121 I=n116
XU304 NR2 $PINS O=term1_in[3] I1=sign1[1] I2=x_in[3]
XU305 AN2 $PINS O=sll_18/ML_int[1][0] I1=n11 I2=term3_in[0]
XU306 NR2 $PINS O=term2_in[3] I1=FE_OFN53_s12_1 I2=x_in[3]
XU307 NR2 $PINS O=term3_in[3] I1=sign3[1] I2=x_in[3]
XU308 NR2 $PINS O=term1_in[5] I1=sign1[1] I2=x_in[5]
XU309 NR2 $PINS O=term2_in[5] I1=FE_OFN53_s12_1 I2=x_in[5]
XU310 NR2 $PINS O=term3_in[5] I1=sign3[1] I2=x_in[5]
XU312 NR2 $PINS O=term1_in[6] I1=sign1[1] I2=x_in[6]
XU313 NR2 $PINS O=term3_in[6] I1=sign3[1] I2=x_in[6]
XU314 NR2 $PINS O=term1_in[7] I1=sign1[1] I2=x_in[7]
XU315 NR2 $PINS O=term2_in[7] I1=FE_OFN53_s12_1 I2=x_in[7]
XU316 NR2 $PINS O=term3_in[7] I1=sign3[1] I2=x_in[7]
XU317 NR2 $PINS O=term1_in[8] I1=sign1[1] I2=x_in[8]
XU318 NR2 $PINS O=term2_in[8] I1=FE_OFN53_s12_1 I2=x_in[8]
XU319 NR2 $PINS O=term3_in[8] I1=sign3[1] I2=x_in[8]
XU323 NR2 $PINS O=term1_in[9] I1=sign1[1] I2=x_in[9]
XU324 NR2 $PINS O=term2_in[9] I1=FE_OFN53_s12_1 I2=x_in[9]
XU325 NR2 $PINS O=term3_in[9] I1=sign3[1] I2=x_in[9]
XU326 NR2 $PINS O=term1_in[10] I1=sign1[1] I2=x_in[10]
XU327 NR2 $PINS O=term2_in[10] I1=FE_OFN53_s12_1 I2=x_in[10]
XU328 NR2 $PINS O=term3_in[10] I1=sign3[1] I2=x_in[10]
XU329 NR2 $PINS O=term1_in[11] I1=sign1[1] I2=x_in[11]
XU330 NR2 $PINS O=term2_in[11] I1=FE_OFN53_s12_1 I2=x_in[11]
XU331 NR2 $PINS O=term3_in[11] I1=sign3[1] I2=x_in[11]
XU332 NR2 $PINS O=term1_in[12] I1=sign1[1] I2=x_in[12]
XU335 NR2 $PINS O=term2_in[12] I1=FE_OFN53_s12_1 I2=x_in[12]
XU336 NR2 $PINS O=term3_in[12] I1=sign3[1] I2=x_in[12]
XU342 NR2 $PINS O=term1_in[13] I1=sign1[1] I2=x_in[13]
XU343 NR2 $PINS O=term2_in[13] I1=FE_OFN53_s12_1 I2=x_in[13]
XU344 NR2 $PINS O=term3_in[13] I1=sign3[1] I2=x_in[13]
XU345 NR2 $PINS O=term1_in[14] I1=sign1[1] I2=x_in[14]
XU347 NR2 $PINS O=term2_in[14] I1=FE_OFN53_s12_1 I2=x_in[14]
XU348 NR2 $PINS O=term3_in[14] I1=sign3[1] I2=x_in[14]
XU352 NR2 $PINS O=term1_in[15] I1=FE_OFN368_FE_OFN232_s11_1 I2=n132
XU353 NR2 $PINS O=term2_in[15] I1=FE_OFN53_s12_1 I2=n132
XU354 NR2 $PINS O=term3_in[15] I1=sign3[1] I2=n132
XU365 INV1S $PINS O=n63 I=shf1[0]
XU367 INV1S $PINS O=n11 I=shf3[0]
XU384 INV1S $PINS O=n132 I=x_in[15]
XU385 INV1S $PINS O=n133 I=x_in[16]
XU388 NR2 $PINS O=term2_in[26] I1=n133 I2=FE_OFN53_s12_1
XU390 NR2 $PINS O=term3_in[26] I1=n133 I2=sign3[1]
XU391 AN2 $PINS O=base_val[26] I1=N251 I2=n144
XU392 AN2 $PINS O=base_val[2] I1=acc_reg[2] I2=n144
XU393 AN2 $PINS O=base_val[10] I1=acc_reg[10] I2=n144
XU394 AN2 $PINS O=base_val[11] I1=acc_reg[11] I2=n144
XU395 AN2 $PINS O=base_val[12] I1=acc_reg[12] I2=n144
XU396 AN2 $PINS O=base_val[14] I1=acc_reg[14] I2=n144
XU397 AN2 $PINS O=base_val[15] I1=acc_reg[15] I2=n144
XU398 AN2 $PINS O=base_val[16] I1=acc_reg[16] I2=n144
XU399 AN2 $PINS O=base_val[17] I1=acc_reg[17] I2=n144
XU400 AN2 $PINS O=base_val[8] I1=acc_reg[8] I2=n144
XU401 AN2 $PINS O=base_val[18] I1=acc_reg[18] I2=n144
XU402 AN2 $PINS O=base_val[19] I1=acc_reg[19] I2=n144
XU403 AN2 $PINS O=base_val[20] I1=acc_reg[20] I2=n144
XU404 AN2 $PINS O=base_val[21] I1=acc_reg[21] I2=n144
XU405 AN2 $PINS O=base_val[7] I1=acc_reg[7] I2=n144
XU406 AN2 $PINS O=base_val[22] I1=acc_reg[22] I2=n144
XU407 AN2 $PINS O=base_val[23] I1=acc_reg[23] I2=n144
XU408 AN2 $PINS O=base_val[24] I1=acc_reg[24] I2=n144
XU409 AN2 $PINS O=base_val[3] I1=acc_reg[3] I2=n144
XU410 AN2 $PINS O=base_val[4] I1=acc_reg[4] I2=n144
XU411 AN2 $PINS O=base_val[5] I1=acc_reg[5] I2=n144
XU412 AN2 $PINS O=base_val[25] I1=acc_reg[25] I2=n144
XU414 AN2 $PINS O=base_val[0] I1=acc_reg[0] I2=n144
XU417 AN2 $PINS O=N234 I1=en I2=calc_done
XU420 INV1S $PINS O=n100 I=n96
XU421 NR2 $PINS O=sll_16/ML_int[3][0] I1=n70 I2=n95
XU422 NR2 $PINS O=sll_16/ML_int[3][1] I1=n70 I2=n96
XU423 NR2 $PINS O=sll_16/ML_int[3][2] I1=n70 I2=n99
XU424 NR2 $PINS O=sll_16/ML_int[3][3] I1=n70 I2=n98
XU427 AN2T $PINS O=term1_shifted[7] I1=sll_16/ML_int[3][7] I2=FE_OFN174_h11_3
XU428 MUX2 $PINS O=sll_16/ML_int[3][21] S=n70 A=n2 B=n102
XU429 MUX2 $PINS O=sll_16/ML_int[3][22] S=n70 A=n2 B=n103
XU430 MUX2 $PINS O=term1_shifted[24] S=shf1[3] A=n2 B=sll_16/ML_int[3][16]
XU431 MUX2 $PINS O=term1_shifted[25] S=shf1[3] A=n2 B=sll_16/ML_int[3][17]
XU432 MUX2 $PINS O=term1_shifted[26] S=shf1[3] A=n2 B=sll_16/ML_int[3][18]
XU433 AN2 $PINS O=sll_17/ML_int[1][0] I1=term2_in[0] I2=FE_OFN180_h12_0
XU434 NR2 $PINS O=sll_17/ML_int[3][0] I1=shf2[2] I2=n105
XU435 NR2 $PINS O=sll_17/ML_int[3][1] I1=shf2[2] I2=n1
XU436 NR2 $PINS O=sll_17/ML_int[3][2] I1=shf2[2] I2=n109
XU437 NR2 $PINS O=sll_17/ML_int[3][3] I1=shf2[2] I2=FE_RN_169_0
XU438 ND2T $PINS O=n107 I1=n43 I2=n47
XU441 AN2T $PINS O=term2_shifted[5] I1=sll_17/ML_int[3][5] I2=n47
XU442 AN2 $PINS O=term2_shifted[6] I1=sll_17/ML_int[3][6] I2=n47
XU444 MUX2 $PINS O=sll_17/ML_int[3][21] S=shf2[2] A=n4 B=n113
XU445 MUX2 $PINS O=sll_17/ML_int[3][22] S=shf2[2] A=term2_in[26] B=n114
XU446 MUX2 $PINS O=term2_shifted[24] S=shf2[3] A=term2_in[26]
+ B=sll_17/ML_int[3][16]
XU447 MUX2 $PINS O=term2_shifted[25] S=shf2[3] A=n4 B=sll_17/ML_int[3][17]
XU448 MUX2 $PINS O=term2_shifted[26] S=shf2[3] A=term2_in[26]
+ B=sll_17/ML_int[3][18]
XU449 NR2 $PINS O=sll_18/ML_int[3][0] I1=shf3[2] I2=n116
XU450 NR2 $PINS O=sll_18/ML_int[3][1] I1=shf3[2] I2=n117
XU451 NR2 $PINS O=sll_18/ML_int[3][2] I1=shf3[2] I2=n120
XU452 NR2 $PINS O=sll_18/ML_int[3][3] I1=shf3[2] I2=n119
XU453 ND2P $PINS O=n118 I1=n18 I2=n21
XU454 NR2 $PINS O=term3_shifted[3] I1=n118 I2=n119
XU456 AN2T $PINS O=term3_shifted[5] I1=sll_18/ML_int[3][5] I2=n21
XU458 MUX2 $PINS O=sll_18/ML_int[3][21] S=FE_OFN356_h13_2 A=n3 B=n124
XU459 MUX2 $PINS O=sll_18/ML_int[3][22] S=FE_OFN356_h13_2 A=term3_in[26] B=n125
XU460 MUX2 $PINS O=term3_shifted[24] S=shf3[3] A=term3_in[26]
+ B=sll_18/ML_int[3][16]
XU461 MUX2 $PINS O=term3_shifted[25] S=shf3[3] A=n3 B=sll_18/ML_int[3][17]
XU462 MUX2 $PINS O=term3_shifted[26] S=shf3[3] A=term3_in[26]
+ B=sll_18/ML_int[3][18]
XU463 MUX2 $PINS O=FE_PHN1185_N245 S=stage_sel A=acc_reg[20] B=acc_reg[24]
XU464 MUX2 $PINS O=N246 S=stage_sel A=acc_reg[21] B=acc_reg[25]
XU465 MUX2 $PINS O=N236 S=stage_sel A=acc_reg[11] B=acc_reg[15]
XU466 MUX2 $PINS O=FE_PHN1211_N237 S=stage_sel A=acc_reg[12] B=acc_reg[16]
XU467 MUX2 $PINS O=FE_PHN1203_N238 S=stage_sel A=acc_reg[13]
+ B=FE_PHN857_acc_reg_17
XU468 MUX2 $PINS O=FE_PHN1216_N239 S=stage_sel A=acc_reg[14] B=acc_reg[18]
XU469 MUX2 $PINS O=N240 S=stage_sel A=acc_reg[15] B=FE_PHN860_acc_reg_19
XU470 MUX2 $PINS O=FE_PHN1217_N241 S=stage_sel A=acc_reg[16] B=acc_reg[20]
XU471 MUX2 $PINS O=N242 S=stage_sel A=FE_PHN857_acc_reg_17 B=acc_reg[21]
XU472 MUX2 $PINS O=N243 S=stage_sel A=acc_reg[18] B=acc_reg[22]
Xclk_gate_y_out_reg SNPS_CLOCK_GATE_HIGH_PE_Shift_Add_4 $PINS EN=N234
+ ENCLK=net2243 CLK=clk_clone1
Xsub_28_3 PE_Shift_Add_4_DW01_sub_0_DW01_sub_12 $PINS A[26]=net44434
+ A[25]=net44434 A[24]=net44434 A[23]=net44434 A[22]=net44434 A[21]=net44434
+ A[20]=net44434 A[19]=net44434 A[18]=net44434 A[17]=net44434 A[16]=net44434
+ A[15]=net44434 A[14]=net44434 A[13]=net44434 A[12]=net44434 A[11]=net44434
+ A[10]=net44434 A[9]=net44434 A[8]=net44434 A[7]=net44434 A[6]=net44434
+ A[5]=net44434 A[4]=net44434 A[3]=net44434 A[2]=net44434 A[1]=net44434
+ A[0]=net44434 B[26]=term3_shifted[26] B[25]=term3_shifted[25]
+ B[24]=term3_shifted[24] B[23]=term3_shifted[23] B[22]=term3_shifted[22]
+ B[21]=term3_shifted[21] B[20]=term3_shifted[20] B[19]=term3_shifted[19]
+ B[18]=term3_shifted[18] B[17]=term3_shifted[17] B[16]=term3_shifted[16]
+ B[15]=term3_shifted[15] B[14]=term3_shifted[14] B[13]=term3_shifted[13]
+ B[12]=term3_shifted[12] B[11]=term3_shifted[11] B[10]=term3_shifted[10]
+ B[9]=term3_shifted[9] B[8]=term3_shifted[8] B[7]=term3_shifted[7]
+ B[6]=term3_shifted[6] B[5]=term3_shifted[5] B[4]=term3_shifted[4]
+ B[3]=term3_shifted[3] B[2]=term3_shifted[2] B[1]=term3_shifted[1]
+ B[0]=term3_shifted[0] CI=net44434 DIFF[26]=N150 DIFF[25]=N149 DIFF[24]=N148
+ DIFF[23]=N147 DIFF[22]=N146 DIFF[21]=N145 DIFF[20]=N144 DIFF[19]=N143
+ DIFF[18]=N142 DIFF[17]=N141 DIFF[16]=N140 DIFF[15]=N139 DIFF[14]=N138
+ DIFF[13]=N137 DIFF[12]=N136 DIFF[11]=N135 DIFF[10]=N134 DIFF[9]=N133
+ DIFF[8]=N132 DIFF[7]=N131 DIFF[6]=N130 DIFF[5]=N129 DIFF[4]=N128 DIFF[3]=N127
+ DIFF[2]=N126 DIFF[1]=N125 DIFF[0]=N124
Xsub_28_2 PE_Shift_Add_4_DW01_sub_1_DW01_sub_13 $PINS A[26]=net44434
+ A[25]=net44434 A[24]=net44434 A[23]=net44434 A[22]=net44434 A[21]=net44434
+ A[20]=net44434 A[19]=net44434 A[18]=net44434 A[17]=net44434 A[16]=net44434
+ A[15]=net44434 A[14]=net44434 A[13]=net44434 A[12]=net44434 A[11]=net44434
+ A[10]=net44434 A[9]=net44434 A[8]=net44434 A[7]=net44434 A[6]=net44434
+ A[5]=net44434 A[4]=net44434 A[3]=net44434 A[2]=net44434 A[1]=net44434
+ A[0]=net44434 B[26]=term2_shifted[26] B[25]=term2_shifted[25]
+ B[24]=term2_shifted[24] B[23]=term2_shifted[23] B[22]=term2_shifted[22]
+ B[21]=term2_shifted[21] B[20]=term2_shifted[20] B[19]=term2_shifted[19]
+ B[18]=term2_shifted[18] B[17]=term2_shifted[17] B[16]=term2_shifted[16]
+ B[15]=term2_shifted[15] B[14]=term2_shifted[14] B[13]=term2_shifted[13]
+ B[12]=term2_shifted[12] B[11]=term2_shifted[11] B[10]=term2_shifted[10]
+ B[9]=term2_shifted[9] B[8]=term2_shifted[8] B[7]=term2_shifted[7]
+ B[6]=term2_shifted[6] B[5]=term2_shifted[5] B[4]=term2_shifted[4]
+ B[3]=term2_shifted[3] B[2]=term2_shifted[2] B[1]=term2_shifted[1]
+ B[0]=term2_shifted[0] CI=net44434 DIFF[26]=N95 DIFF[25]=N94 DIFF[24]=N93
+ DIFF[23]=N92 DIFF[22]=N91 DIFF[21]=N90 DIFF[20]=N89 DIFF[19]=N88 DIFF[18]=N87
+ DIFF[17]=N86 DIFF[16]=N85 DIFF[15]=N84 DIFF[14]=N83 DIFF[13]=N82 DIFF[12]=N81
+ DIFF[11]=N80 DIFF[10]=N79 DIFF[9]=N78 DIFF[8]=N77 DIFF[7]=N76 DIFF[6]=N75
+ DIFF[5]=N74 DIFF[4]=N73 DIFF[3]=N72 DIFF[2]=N71 DIFF[1]=N70 DIFF[0]=N69
Xsub_28 PE_Shift_Add_4_DW01_sub_2_DW01_sub_14 $PINS A[26]=net44434
+ A[25]=net44434 A[24]=net44434 A[23]=net44434 A[22]=net44434 A[21]=net44434
+ A[20]=net44434 A[19]=net44434 A[18]=net44434 A[17]=net44434 A[16]=net44434
+ A[15]=net44434 A[14]=net44434 A[13]=net44434 A[12]=net44434 A[11]=net44434
+ A[10]=net44434 A[9]=net44434 A[8]=net44434 A[7]=net44434 A[6]=net44434
+ A[5]=net44434 A[4]=net44434 A[3]=net44434 A[2]=net44434 A[1]=net44434
+ A[0]=net44434 B[26]=term1_shifted[26] B[25]=term1_shifted[25]
+ B[24]=term1_shifted[24] B[23]=term1_shifted[23] B[22]=term1_shifted[22]
+ B[21]=term1_shifted[21] B[20]=term1_shifted[20] B[19]=term1_shifted[19]
+ B[18]=term1_shifted[18] B[17]=term1_shifted[17] B[16]=term1_shifted[16]
+ B[15]=term1_shifted[15] B[14]=term1_shifted[14] B[13]=term1_shifted[13]
+ B[12]=term1_shifted[12] B[11]=term1_shifted[11] B[10]=term1_shifted[10]
+ B[9]=term1_shifted[9] B[8]=term1_shifted[8] B[7]=term1_shifted[7]
+ B[6]=term1_shifted[6] B[5]=term1_shifted[5] B[4]=term1_shifted[4]
+ B[3]=term1_shifted[3] B[2]=term1_shifted[2] B[1]=term1_shifted[1]
+ B[0]=term1_shifted[0] CI=net44434 DIFF[26]=N40 DIFF[25]=N39 DIFF[24]=N38
+ DIFF[23]=N37 DIFF[22]=N36 DIFF[21]=N35 DIFF[20]=N34 DIFF[19]=N33 DIFF[18]=N32
+ DIFF[17]=N31 DIFF[16]=N30 DIFF[15]=N29 DIFF[14]=N28 DIFF[13]=N27 DIFF[12]=N26
+ DIFF[11]=N25 DIFF[10]=N24 DIFF[9]=N23 DIFF[8]=N22 DIFF[7]=N21 DIFF[6]=N20
+ DIFF[5]=N19 DIFF[4]=N18 DIFF[3]=N17 DIFF[2]=N16 DIFF[1]=N15 DIFF[0]=N14
Xadd_1_root_add_0_root_add_28_3 PE_Shift_Add_4_DW01_add_2_DW01_add_34 $PINS
+ A[26]=N67 A[25]=N66 A[24]=N65 A[23]=N64 A[22]=N63 A[21]=N62 A[20]=N61 A[19]=N60
+ A[18]=N59 A[17]=N58 A[16]=N57 A[15]=N56 A[14]=N55 A[13]=N54 A[12]=N53 A[11]=N52
+ A[10]=N51 A[9]=N50 A[8]=N49 A[7]=N48 A[6]=N47 A[5]=N46 A[4]=N45 A[3]=N44
+ A[2]=N43 A[1]=N42 A[0]=N41 B[26]=N177 B[25]=N176 B[24]=N175 B[23]=N174
+ B[22]=N173 B[21]=N172 B[20]=N171 B[19]=N170 B[18]=N169 B[17]=N168 B[16]=N167
+ B[15]=N166 B[14]=N165 B[13]=N164 B[12]=N163 B[11]=N162 B[10]=N161 B[9]=N160
+ B[8]=N159 B[7]=N158 B[6]=N157 B[5]=N156 B[4]=N155 B[3]=N154 B[2]=N153 B[1]=N152
+ B[0]=N151 CI=net44434 SUM[26]=N204 SUM[25]=N203 SUM[24]=N202 SUM[23]=N201
+ SUM[22]=N200 SUM[21]=N199 SUM[20]=N198 SUM[19]=N197 SUM[18]=N196 SUM[17]=N195
+ SUM[16]=N194 SUM[15]=N193 SUM[14]=N192 SUM[13]=N191 SUM[12]=N190 SUM[11]=N189
+ SUM[10]=N188 SUM[9]=N187 SUM[8]=N186 SUM[7]=N185 SUM[6]=N184 SUM[5]=N183
+ SUM[4]=N182 SUM[3]=N181 SUM[2]=N180 SUM[1]=N179 SUM[0]=N178
Xadd_2_root_add_0_root_add_28_3 PE_Shift_Add_4_DW01_add_1_DW01_add_33 $PINS
+ A[26]=base_val[26] A[25]=base_val[25] A[24]=base_val[24] A[23]=base_val[23]
+ A[22]=base_val[22] A[21]=base_val[21] A[20]=base_val[20] A[19]=base_val[19]
+ A[18]=base_val[18] A[17]=base_val[17] A[16]=base_val[16] A[15]=base_val[15]
+ A[14]=base_val[14] A[13]=base_val[13] A[12]=base_val[12] A[11]=base_val[11]
+ A[10]=base_val[10] A[9]=base_val[9] A[8]=base_val[8] A[7]=base_val[7]
+ A[6]=base_val[6] A[5]=base_val[5] A[4]=base_val[4] A[3]=base_val[3]
+ A[2]=base_val[2] A[1]=base_val[1] A[0]=base_val[0] B[26]=N122 B[25]=N121
+ B[24]=N120 B[23]=N119 B[22]=N118 B[21]=N117 B[20]=N116 B[19]=N115 B[18]=N114
+ B[17]=N113 B[16]=N112 B[15]=N111 B[14]=N110 B[13]=N109 B[12]=N108 B[11]=N107
+ B[10]=N106 B[9]=N105 B[8]=N104 B[7]=N103 B[6]=N102 B[5]=N101 B[4]=N100 B[3]=N99
+ B[2]=N98 B[1]=N97 B[0]=N96 CI=net44434 SUM[26]=N231 SUM[25]=N230 SUM[24]=N229
+ SUM[23]=N228 SUM[22]=N227 SUM[21]=N226 SUM[20]=N225 SUM[19]=N224 SUM[18]=N223
+ SUM[17]=N222 SUM[16]=N221 SUM[15]=N220 SUM[14]=N219 SUM[13]=N218 SUM[12]=N217
+ SUM[11]=N216 SUM[10]=N215 SUM[9]=N214 SUM[8]=N213 SUM[7]=N212 SUM[6]=N211
+ SUM[5]=N210 SUM[4]=N209 SUM[3]=N208 SUM[2]=N207 SUM[1]=N206 SUM[0]=N205
Xadd_0_root_add_0_root_add_28_3 PE_Shift_Add_4_DW01_add_0_DW01_add_32 $PINS
+ A[26]=N204 A[25]=N203 A[24]=N202 A[23]=N201 A[22]=N200 A[21]=N199 A[20]=N198
+ A[19]=N197 A[18]=N196 A[17]=N195 A[16]=N194 A[15]=N193 A[14]=N192 A[13]=N191
+ A[12]=N190 A[11]=N189 A[10]=N188 A[9]=N187 A[8]=N186 A[7]=N185 A[6]=N184
+ A[5]=N183 A[4]=N182 A[3]=N181 A[2]=N180 A[1]=N179 A[0]=N178 B[26]=N231
+ B[25]=N230 B[24]=N229 B[23]=N228 B[22]=N227 B[21]=N226 B[20]=N225 B[19]=N224
+ B[18]=N223 B[17]=N222 B[16]=N221 B[15]=N220 B[14]=N219 B[13]=N218 B[12]=N217
+ B[11]=N216 B[10]=N215 B[9]=N214 B[8]=N213 B[7]=N212 B[6]=N211 B[5]=N210
+ B[4]=N209 B[3]=N208 B[2]=N207 B[1]=N206 B[0]=N205 CI=net44434
+ SUM[26]=next_acc[26] SUM[25]=next_acc[25] SUM[24]=next_acc[24]
+ SUM[23]=next_acc[23] SUM[22]=next_acc[22] SUM[21]=next_acc[21]
+ SUM[20]=next_acc[20] SUM[19]=next_acc[19] SUM[18]=next_acc[18]
+ SUM[17]=next_acc[17] SUM[16]=next_acc[16] SUM[15]=next_acc[15]
+ SUM[14]=next_acc[14] SUM[13]=next_acc[13] SUM[12]=next_acc[12]
+ SUM[11]=next_acc[11] SUM[10]=next_acc[10] SUM[9]=next_acc[9] SUM[8]=next_acc[8]
+ SUM[7]=next_acc[7] SUM[6]=next_acc[6] SUM[5]=next_acc[5] SUM[4]=next_acc[4]
+ SUM[3]=next_acc[3] SUM[2]=next_acc[2] SUM[1]=next_acc[1] SUM[0]=next_acc[0]
Xsll_16/M1_1_5 MUX2 $PINS O=sll_16/ML_int[2][5] S=FE_OFN223_h11_1
+ A=sll_16/ML_int[1][5] B=sll_16/ML_int[1][3]
Xsll_16/M1_1_3 MUX2 $PINS O=sll_16/ML_int[2][3] S=FE_OFN223_h11_1
+ A=sll_16/ML_int[1][3] B=sll_16/ML_int[1][1]
XU12 MUX2 $PINS O=sll_16/ML_int[1][2] S=shf1[0] A=term1_in[2] B=term1_in[1]
XU5 INV1S $PINS O=n39 I=shf2[1]
XU7 NR2 $PINS O=term1_in[1] I1=sign1[1] I2=FE_OFN187_mac_in_imag_1
XU9 ND3 $PINS O=n95 I1=FE_OFN222_h11_1 I2=n63 I3=term1_in[0]
XU13 ND2S $PINS O=n1 I1=sll_17/ML_int[1][1] I2=n39
XU14 NR2P $PINS O=term3_shifted[1] I1=n118 I2=n117
XU17 AO22P $PINS O=N43 A1=N16 A2=sign1[0] B1=term1_shifted[2] B2=n80
XU18 NR2 $PINS O=term2_in[2] I1=FE_OFN53_s12_1 I2=x_in[2]
XU20 INV2CK $PINS O=n98 I=sll_16/ML_int[2][3]
XU22 NR2T $PINS O=term1_shifted[2] I1=n97 I2=n99
XU32 INV2 $PINS O=n99 I=sll_16/ML_int[2][2]
XU34 ND2P $PINS O=n96 I1=sll_16/ML_int[1][1] I2=FE_OFN222_h11_1
XU53 ND2P $PINS O=n117 I1=sll_18/ML_int[1][1] I2=n14
XU74 INV1S $PINS O=n109 I=sll_17/ML_int[2][2]
XU90 NR2T $PINS O=term1_shifted[1] I1=n97 I2=n96
.ENDS

.SUBCKT SNPS_CLOCK_GATE_HIGH_PE_Shift_Add_3 EN ENCLK CLK
*.CONNECT net2219 EN
XFE_PHC875_net2222 DELC $PINS O=net2222 I=FE_PHN875_net2222
Xlatch QDBHN $PINS Q=FE_PHN875_net2222 D=net2219 CKB=CLK
Xmain_gate AN2T $PINS O=ENCLK I1=net2222 I2=CLK
.ENDS

.SUBCKT PE_Shift_Add_3_DW01_sub_0_DW01_sub_9 A[26] A[25] A[24] A[23] A[22]
+ A[21] A[20] A[19] A[18] A[17] A[16] A[15] A[14] A[13] A[12] A[11] A[10] A[9]
+ A[8] A[7] A[6] A[5] A[4] A[3] A[2] A[1] A[0] B[26] B[25] B[24] B[23] B[22]
+ B[21] B[20] B[19] B[18] B[17] B[16] B[15] B[14] B[13] B[12] B[11] B[10] B[9]
+ B[8] B[7] B[6] B[5] B[4] B[3] B[2] B[1] B[0] CI DIFF[26] DIFF[25] DIFF[24]
+ DIFF[23] DIFF[22] DIFF[21] DIFF[20] DIFF[19] DIFF[18] DIFF[17] DIFF[16]
+ DIFF[15] DIFF[14] DIFF[13] DIFF[12] DIFF[11] DIFF[10] DIFF[9] DIFF[8] DIFF[7]
+ DIFF[6] DIFF[5] DIFF[4] DIFF[3] DIFF[2] DIFF[1] DIFF[0] CO
*.CONNECT DIFF[0] B[0]
XFE_RC_501_0 AN2B1T $PINS O=n2 I1=n1 B1=B[2]
XFE_RC_427_0 XNR2HS $PINS O=DIFF[6] I1=B[6] I2=n12
XFE_RC_365_0 INV1S $PINS O=FE_RN_194_0 I=n52
XFE_RC_364_0 NR2 $PINS O=n1 I1=FE_RN_194_0 I2=B[1]
XFE_RC_252_0 XNR2HS $PINS O=DIFF[3] I1=B[3] I2=n2
XFE_OFC643_term3_shifted_3 INV1S $PINS O=n49 I=B[3]
XU2 INV1S $PINS O=n48 I=B[4]
XU3 INV1S $PINS O=n52 I=B[0]
XU4 XOR2HS $PINS O=DIFF[2] I1=n50 I2=n1
XU8 INV1S $PINS O=n47 I=B[5]
XU9 XNR2HS $PINS O=DIFF[1] I1=n52 I2=B[1]
XU10 AN2 $PINS O=n13 I1=n12 I2=n46
XU13 AN2 $PINS O=n3 I1=n2 I2=n49
XU14 AN2 $PINS O=n4 I1=n40 I2=n18
XU15 AN2 $PINS O=n5 I1=n39 I2=n4
XU16 AN2 $PINS O=n6 I1=n38 I2=n5
XU17 AN2 $PINS O=n7 I1=n37 I2=n6
XU18 AN2 $PINS O=n8 I1=n36 I2=n7
XU19 AN2 $PINS O=n9 I1=n35 I2=n8
XU20 AN2 $PINS O=n10 I1=n34 I2=n9
XU21 AN2 $PINS O=n11 I1=n3 I2=n48
XU22 AN2 $PINS O=n12 I1=n11 I2=n47
XU23 AN2 $PINS O=n14 I1=n45 I2=n13
XU24 AN2 $PINS O=n15 I1=n44 I2=n14
XU25 AN2 $PINS O=n16 I1=n43 I2=n15
XU26 AN2 $PINS O=n17 I1=n42 I2=n16
XU27 AN2 $PINS O=n18 I1=n41 I2=n17
XU28 AN2 $PINS O=n19 I1=n33 I2=n10
XU29 AN2 $PINS O=n20 I1=n32 I2=n19
XU30 AN2 $PINS O=n21 I1=n31 I2=n20
XU31 AN2 $PINS O=n22 I1=n30 I2=n21
XU32 AN2 $PINS O=n23 I1=n29 I2=n22
XU33 AN2 $PINS O=n24 I1=n28 I2=n23
XU34 INV1S $PINS O=n40 I=B[12]
XU35 INV1S $PINS O=n39 I=B[13]
XU36 INV1S $PINS O=n38 I=B[14]
XU37 INV1S $PINS O=n37 I=B[15]
XU38 INV1S $PINS O=n36 I=B[16]
XU39 INV1S $PINS O=n35 I=B[17]
XU40 INV1S $PINS O=n34 I=B[18]
XU42 XOR2HS $PINS O=DIFF[9] I1=n43 I2=n15
XU43 XOR2HS $PINS O=DIFF[10] I1=n42 I2=n16
XU44 XOR2HS $PINS O=DIFF[11] I1=n41 I2=n17
XU45 XOR2HS $PINS O=DIFF[12] I1=n40 I2=n18
XU46 XOR2HS $PINS O=DIFF[13] I1=n39 I2=n4
XU47 XOR2HS $PINS O=DIFF[14] I1=n38 I2=n5
XU48 XOR2HS $PINS O=DIFF[15] I1=n37 I2=n6
XU49 XOR2HS $PINS O=DIFF[16] I1=n36 I2=n7
XU50 XOR2HS $PINS O=DIFF[17] I1=n35 I2=n8
XU51 XOR2HS $PINS O=DIFF[18] I1=n34 I2=n9
XU52 XOR2HS $PINS O=DIFF[19] I1=n33 I2=n10
XU53 XOR2HS $PINS O=DIFF[20] I1=n32 I2=n19
XU54 XOR2HS $PINS O=DIFF[21] I1=n31 I2=n20
XU55 XOR2HS $PINS O=DIFF[22] I1=n30 I2=n21
XU56 XOR2HS $PINS O=DIFF[23] I1=n29 I2=n22
XU57 XOR2HS $PINS O=DIFF[24] I1=n28 I2=n23
XU58 XOR2HS $PINS O=DIFF[25] I1=n27 I2=n24
XU59 XOR2HS $PINS O=DIFF[8] I1=n44 I2=n14
XU60 XOR2HS $PINS O=DIFF[7] I1=n45 I2=n13
XU62 XOR2HS $PINS O=DIFF[5] I1=n47 I2=n11
XU63 XOR2HS $PINS O=DIFF[4] I1=n3 I2=n48
XU64 INV1S $PINS O=n45 I=B[7]
XU65 INV1S $PINS O=n46 I=B[6]
XU66 INV1S $PINS O=n44 I=B[8]
XU67 INV1S $PINS O=n43 I=B[9]
XU68 INV1S $PINS O=n42 I=B[10]
XU69 INV1S $PINS O=n41 I=B[11]
XU70 XOR2HS $PINS O=DIFF[26] I1=B[26] I2=n26
XU71 INV1S $PINS O=n33 I=B[19]
XU72 INV1S $PINS O=n32 I=B[20]
XU73 INV1S $PINS O=n31 I=B[21]
XU74 INV1S $PINS O=n30 I=B[22]
XU75 INV1S $PINS O=n29 I=B[23]
XU76 INV1S $PINS O=n28 I=B[24]
XU77 INV1S $PINS O=n27 I=B[25]
XU78 ND2 $PINS O=n26 I1=n27 I2=n24
XU1 INV2 $PINS O=n50 I=B[2]
.ENDS

.SUBCKT PE_Shift_Add_3_DW01_sub_1_DW01_sub_10 A[26] A[25] A[24] A[23] A[22]
+ A[21] A[20] A[19] A[18] A[17] A[16] A[15] A[14] A[13] A[12] A[11] A[10] A[9]
+ A[8] A[7] A[6] A[5] A[4] A[3] A[2] A[1] A[0] B[26] B[25] B[24] B[23] B[22]
+ B[21] B[20] B[19] B[18] B[17] B[16] B[15] B[14] B[13] B[12] B[11] B[10] B[9]
+ B[8] B[7] B[6] B[5] B[4] B[3] B[2] B[1] B[0] CI DIFF[26] DIFF[25] DIFF[24]
+ DIFF[23] DIFF[22] DIFF[21] DIFF[20] DIFF[19] DIFF[18] DIFF[17] DIFF[16]
+ DIFF[15] DIFF[14] DIFF[13] DIFF[12] DIFF[11] DIFF[10] DIFF[9] DIFF[8] DIFF[7]
+ DIFF[6] DIFF[5] DIFF[4] DIFF[3] DIFF[2] DIFF[1] DIFF[0] CO
*.CONNECT DIFF[0] B[0]
XFE_RC_742_0 INV2 $PINS O=FE_RN_354_0 I=n15
XFE_RC_741_0 NR2T $PINS O=n16 I1=FE_RN_354_0 I2=B[8]
XFE_RC_721_0 AN2B1T $PINS O=n15 I1=n14 B1=B[7]
XFE_RC_599_0 AN2B1 $PINS O=n17 I1=n16 B1=B[9]
XFE_RC_396_0 AN3B2S $PINS O=n12 I1=n3 B1=B[4] B2=B[3]
XFE_RC_227_0 AN2B1T $PINS O=n3 I1=n2 B1=B[2]
XFE_RC_1320_0 XNR2HS $PINS O=DIFF[4] I1=B[4] I2=n4
XFE_RC_1112_0 AN2B1S $PINS O=n4 I1=n3 B1=B[3]
XU3 NR2 $PINS O=n2 I1=DIFF[0] I2=B[1]
XU8 INV1S $PINS O=n48 I=B[5]
XU9 INV1S $PINS O=n50 I=B[3]
XU10 AN2 $PINS O=n14 I1=n47 I2=n13
XU12 AN2 $PINS O=n5 I1=n41 I2=n19
XU13 AN2 $PINS O=n6 I1=n40 I2=n5
XU14 AN2 $PINS O=n7 I1=n39 I2=n6
XU15 AN2 $PINS O=n8 I1=n38 I2=n7
XU16 AN2 $PINS O=n9 I1=n37 I2=n8
XU17 AN2 $PINS O=n10 I1=n36 I2=n9
XU18 AN2 $PINS O=n11 I1=n35 I2=n10
XU20 AN2 $PINS O=n13 I1=n48 I2=n12
XU24 AN2 $PINS O=n18 I1=n43 I2=n17
XU25 AN2 $PINS O=n19 I1=n42 I2=n18
XU26 AN2 $PINS O=n20 I1=n34 I2=n11
XU27 AN2 $PINS O=n21 I1=n33 I2=n20
XU28 AN2 $PINS O=n22 I1=n32 I2=n21
XU29 AN2 $PINS O=n23 I1=n31 I2=n22
XU30 AN2 $PINS O=n24 I1=n30 I2=n23
XU31 AN2 $PINS O=n25 I1=n29 I2=n24
XU32 INV1S $PINS O=n41 I=B[12]
XU33 INV1S $PINS O=n40 I=B[13]
XU34 INV1S $PINS O=n39 I=B[14]
XU35 INV1S $PINS O=n38 I=B[15]
XU36 INV1S $PINS O=n37 I=B[16]
XU37 INV1S $PINS O=n36 I=B[17]
XU38 INV1S $PINS O=n35 I=B[18]
XU39 INV1S $PINS O=n46 I=B[7]
XU40 INV1S $PINS O=n47 I=B[6]
XU41 INV1S $PINS O=n45 I=B[8]
XU42 INV1S $PINS O=n44 I=B[9]
XU43 INV1S $PINS O=n43 I=B[10]
XU44 INV1S $PINS O=n42 I=B[11]
XU45 XOR2HS $PINS O=DIFF[26] I1=B[26] I2=n27
XU46 INV1S $PINS O=n34 I=B[19]
XU47 INV1S $PINS O=n33 I=B[20]
XU48 INV1S $PINS O=n32 I=B[21]
XU49 INV1S $PINS O=n31 I=B[22]
XU50 INV1S $PINS O=n30 I=B[23]
XU51 INV1S $PINS O=n29 I=B[24]
XU52 INV1S $PINS O=n28 I=B[25]
XU53 XOR2HS $PINS O=DIFF[9] I1=n44 I2=n16
XU54 XOR2HS $PINS O=DIFF[10] I1=n43 I2=n17
XU55 XOR2HS $PINS O=DIFF[8] I1=n45 I2=n15
XU56 XOR2HS $PINS O=DIFF[11] I1=n42 I2=n18
XU57 XOR2HS $PINS O=DIFF[12] I1=n41 I2=n19
XU58 XOR2HS $PINS O=DIFF[13] I1=n40 I2=n5
XU59 XOR2HS $PINS O=DIFF[14] I1=n39 I2=n6
XU60 XOR2HS $PINS O=DIFF[15] I1=n38 I2=n7
XU61 XOR2HS $PINS O=DIFF[16] I1=n37 I2=n8
XU62 XOR2HS $PINS O=DIFF[17] I1=n36 I2=n9
XU63 XOR2HS $PINS O=DIFF[18] I1=n35 I2=n10
XU64 XOR2HS $PINS O=DIFF[19] I1=n34 I2=n11
XU65 XOR2HS $PINS O=DIFF[20] I1=n33 I2=n20
XU66 XOR2HS $PINS O=DIFF[21] I1=n32 I2=n21
XU67 XOR2HS $PINS O=DIFF[22] I1=n31 I2=n22
XU68 XOR2HS $PINS O=DIFF[23] I1=n30 I2=n23
XU69 XOR2HS $PINS O=DIFF[24] I1=n29 I2=n24
XU70 XOR2HS $PINS O=DIFF[25] I1=n28 I2=n25
XU71 XOR2HS $PINS O=DIFF[7] I1=n46 I2=n14
XU72 XOR2HS $PINS O=DIFF[6] I1=n13 I2=n47
XU73 XOR2HS $PINS O=DIFF[5] I1=n12 I2=n48
XU75 XOR2HS $PINS O=DIFF[3] I1=n50 I2=n3
XU77 ND2 $PINS O=n27 I1=n28 I2=n25
XU1 INV1S $PINS O=n51 I=B[2]
XU2 XOR2HS $PINS O=DIFF[2] I1=n2 I2=n51
XU76 XOR2HS $PINS O=DIFF[1] I1=DIFF[0] I2=B[1]
.ENDS

.SUBCKT PE_Shift_Add_3_DW01_sub_2_DW01_sub_11 A[26] A[25] A[24] A[23] A[22]
+ A[21] A[20] A[19] A[18] A[17] A[16] A[15] A[14] A[13] A[12] A[11] A[10] A[9]
+ A[8] A[7] A[6] A[5] A[4] A[3] A[2] A[1] A[0] B[26] B[25] B[24] B[23] B[22]
+ B[21] B[20] B[19] B[18] B[17] B[16] B[15] B[14] B[13] B[12] B[11] B[10] B[9]
+ B[8] B[7] B[6] B[5] B[4] B[3] B[2] B[1] B[0] CI DIFF[26] DIFF[25] DIFF[24]
+ DIFF[23] DIFF[22] DIFF[21] DIFF[20] DIFF[19] DIFF[18] DIFF[17] DIFF[16]
+ DIFF[15] DIFF[14] DIFF[13] DIFF[12] DIFF[11] DIFF[10] DIFF[9] DIFF[8] DIFF[7]
+ DIFF[6] DIFF[5] DIFF[4] DIFF[3] DIFF[2] DIFF[1] DIFF[0] CO
*.CONNECT DIFF[0] B[0]
XFE_RC_589_0 AN2B1S $PINS O=n15 I1=n14 B1=B[8]
XFE_RC_448_0 XNR2HS $PINS O=DIFF[3] I1=B[3] I2=n3
XFE_RC_361_0 AN2 $PINS O=FE_RN_192_0 I1=n14 I2=n43
XFE_RC_360_0 AN2 $PINS O=n16 I1=FE_RN_192_0 I2=n44
XFE_RC_359_0 AN2B1S $PINS O=n11 I1=n2 B1=B[4]
XFE_RC_1308_0 XNR2HS $PINS O=DIFF[4] I1=B[4] I2=FE_RN_165_0
XFE_RC_1210_0 AN2B1S $PINS O=FE_RN_165_0 I1=n3 B1=B[3]
XU2 NR2 $PINS O=n1 I1=DIFF[0] I2=B[1]
XU3 INV2 $PINS O=n49 I=B[3]
XU5 INV1S $PINS O=n45 I=B[7]
XU6 XOR2HS $PINS O=DIFF[1] I1=B[0] I2=B[1]
XU7 XOR2HS $PINS O=DIFF[2] I1=n1 I2=n50
XU8 AN2 $PINS O=n13 I1=n12 I2=n46
XU9 ND2S $PINS O=n26 I1=n27 I2=n24
XU11 AN2S $PINS O=n2 I1=n49 I2=n3
XU13 XOR2HS $PINS O=DIFF[12] I1=n40 I2=n18
XU14 XOR2HS $PINS O=DIFF[13] I1=n39 I2=n4
XU15 AN2 $PINS O=n4 I1=n40 I2=n18
XU16 XOR2HS $PINS O=DIFF[14] I1=n38 I2=n5
XU17 AN2 $PINS O=n5 I1=n39 I2=n4
XU18 XOR2HS $PINS O=DIFF[15] I1=n37 I2=n6
XU19 AN2 $PINS O=n6 I1=n38 I2=n5
XU20 XOR2HS $PINS O=DIFF[16] I1=n36 I2=n7
XU21 AN2 $PINS O=n7 I1=n37 I2=n6
XU22 XOR2HS $PINS O=DIFF[17] I1=n35 I2=n8
XU23 AN2 $PINS O=n8 I1=n36 I2=n7
XU24 XOR2HS $PINS O=DIFF[18] I1=n34 I2=n9
XU25 AN2 $PINS O=n9 I1=n35 I2=n8
XU26 AN2 $PINS O=n10 I1=n34 I2=n9
XU28 XOR2HS $PINS O=DIFF[5] I1=n47 I2=n11
XU30 XOR2HS $PINS O=DIFF[6] I1=n46 I2=n12
XU31 AN2 $PINS O=n12 I1=n47 I2=n11
XU32 XOR2HS $PINS O=DIFF[7] I1=n45 I2=n13
XU33 XOR2HS $PINS O=DIFF[8] I1=n44 I2=n14
XU34 AN2 $PINS O=n14 I1=n45 I2=n13
XU35 XOR2HS $PINS O=DIFF[9] I1=n43 I2=n15
XU37 XOR2HS $PINS O=DIFF[10] I1=n42 I2=n16
XU39 XOR2HS $PINS O=DIFF[11] I1=n41 I2=n17
XU40 AN2 $PINS O=n17 I1=n42 I2=n16
XU41 AN2 $PINS O=n18 I1=n41 I2=n17
XU42 XOR2HS $PINS O=DIFF[19] I1=n33 I2=n10
XU43 XOR2HS $PINS O=DIFF[20] I1=n32 I2=n19
XU44 AN2 $PINS O=n19 I1=n33 I2=n10
XU45 XOR2HS $PINS O=DIFF[21] I1=n31 I2=n20
XU46 AN2 $PINS O=n20 I1=n32 I2=n19
XU47 XOR2HS $PINS O=DIFF[22] I1=n30 I2=n21
XU48 AN2 $PINS O=n21 I1=n31 I2=n20
XU49 XOR2HS $PINS O=DIFF[23] I1=n29 I2=n22
XU50 AN2 $PINS O=n22 I1=n30 I2=n21
XU51 XOR2HS $PINS O=DIFF[24] I1=n28 I2=n23
XU52 AN2 $PINS O=n23 I1=n29 I2=n22
XU53 AN2 $PINS O=n24 I1=n28 I2=n23
XU54 XOR2HS $PINS O=DIFF[25] I1=n27 I2=n24
XU55 INV1S $PINS O=n40 I=B[12]
XU56 INV1S $PINS O=n39 I=B[13]
XU57 INV1S $PINS O=n38 I=B[14]
XU58 INV1S $PINS O=n37 I=B[15]
XU59 INV1S $PINS O=n36 I=B[16]
XU60 INV1S $PINS O=n35 I=B[17]
XU61 INV1S $PINS O=n34 I=B[18]
XU62 INV1S $PINS O=n47 I=B[5]
XU63 INV1S $PINS O=n46 I=B[6]
XU64 INV1S $PINS O=n44 I=B[8]
XU65 INV1S $PINS O=n43 I=B[9]
XU66 INV1S $PINS O=n42 I=B[10]
XU67 INV1S $PINS O=n41 I=B[11]
XU68 XOR2HS $PINS O=DIFF[26] I1=B[26] I2=n26
XU69 INV1S $PINS O=n33 I=B[19]
XU70 INV1S $PINS O=n32 I=B[20]
XU71 INV1S $PINS O=n31 I=B[21]
XU72 INV1S $PINS O=n30 I=B[22]
XU73 INV1S $PINS O=n29 I=B[23]
XU74 INV1S $PINS O=n28 I=B[24]
XU75 INV1S $PINS O=n27 I=B[25]
XU4 INV2 $PINS O=n50 I=B[2]
XU12 NR2 $PINS O=n3 I1=B[2] I2=n51
XU77 INV1S $PINS O=n51 I=n1
.ENDS

.SUBCKT PE_Shift_Add_3_DW01_add_2_DW01_add_19 A[26] A[25] A[24] A[23] A[22]
+ A[21] A[20] A[19] A[18] A[17] A[16] A[15] A[14] A[13] A[12] A[11] A[10] A[9]
+ A[8] A[7] A[6] A[5] A[4] A[3] A[2] A[1] A[0] B[26] B[25] B[24] B[23] B[22]
+ B[21] B[20] B[19] B[18] B[17] B[16] B[15] B[14] B[13] B[12] B[11] B[10] B[9]
+ B[8] B[7] B[6] B[5] B[4] B[3] B[2] B[1] B[0] CI SUM[26] SUM[25] SUM[24]
+ SUM[23] SUM[22] SUM[21] SUM[20] SUM[19] SUM[18] SUM[17] SUM[16] SUM[15]
+ SUM[14] SUM[13] SUM[12] SUM[11] SUM[10] SUM[9] SUM[8] SUM[7] SUM[6] SUM[5]
+ SUM[4] SUM[3] SUM[2] SUM[1] SUM[0] CO
XFE_RC_538_0 INV2 $PINS O=SUM[4] I=FE_RN_272_0
XFE_RC_537_0 XNR3 $PINS O=FE_RN_272_0 I1=B[4] I2=A[4] I3=carry[4]
XFE_RC_489_0 INV2 $PINS O=SUM[7] I=FE_RN_252_0
XFE_RC_488_0 XNR3 $PINS O=FE_RN_252_0 I1=A[7] I2=B[7] I3=carry[7]
XFE_RC_367_0 INV2 $PINS O=SUM[10] I=FE_RN_195_0
XFE_RC_366_0 XNR3 $PINS O=FE_RN_195_0 I1=A[10] I2=B[10] I3=carry[10]
XFE_RC_254_0 INV2 $PINS O=SUM[5] I=FE_RN_139_0
XFE_RC_253_0 XNR3 $PINS O=FE_RN_139_0 I1=A[5] I2=B[5] I3=carry[5]
XFE_RC_226_0 INV1S $PINS O=FE_RN_126_0 I=B[24]
XFE_RC_225_0 AO13 $PINS O=n25 A1=FE_RN_126_0 B1=n28 B2=n29 B3=n30
XFE_RC_1491_0 ND3P $PINS O=n18 I1=B[1] I2=B[0] I3=A[0]
XFE_RC_1460_0 INV2 $PINS O=SUM[11] I=FE_RN_298_0
XFE_RC_1459_0 XNR3 $PINS O=FE_RN_298_0 I1=A[11] I2=B[11] I3=carry[11]
XFE_RC_1391_0 INV2 $PINS O=SUM[1] I=FE_RN_256_0
XFE_RC_1390_0 XNR3 $PINS O=FE_RN_256_0 I1=n1 I2=A[1] I3=B[1]
XFE_RC_1357_0 INV2 $PINS O=SUM[18] I=FE_RN_241_0
XFE_RC_1356_0 XNR3 $PINS O=FE_RN_241_0 I1=A[18] I2=B[18] I3=carry[18]
XFE_RC_1352_0 INV2 $PINS O=SUM[12] I=FE_RN_238_0
XFE_RC_1351_0 XNR3 $PINS O=FE_RN_238_0 I1=A[12] I2=B[12] I3=carry[12]
XFE_RC_1337_0 INV2 $PINS O=SUM[14] I=FE_RN_230_0
XFE_RC_1336_0 XNR3 $PINS O=FE_RN_230_0 I1=A[14] I2=B[14] I3=carry[14]
XFE_RC_1307_0 INV2 $PINS O=SUM[16] I=FE_RN_216_0
XFE_RC_1306_0 XNR3 $PINS O=FE_RN_216_0 I1=A[16] I2=B[16] I3=carry[16]
XFE_RC_1160_0 XOR3 $PINS O=SUM[25] I1=A[25] I2=B[25] I3=carry[25]
XFE_RC_1159_0 MAO222 $PINS O=carry[26] A1=carry[25] B1=B[25] C1=A[25]
XFE_RC_1108_0 INV2 $PINS O=SUM[3] I=FE_RN_112_0
XFE_RC_1107_0 XNR3 $PINS O=FE_RN_112_0 I1=B[3] I2=A[3] I3=carry[3]
XFE_RC_1047_0 XOR2HS $PINS O=FE_RN_84_0 I1=B[26] I2=A[26]
XFE_RC_1046_0 XOR2H $PINS O=SUM[26] I1=FE_RN_84_0 I2=carry[26]
XFE_RC_868_0 XOR3 $PINS O=SUM[21] I1=A[21] I2=B[21] I3=carry[21]
XFE_RC_867_0 MAO222P $PINS O=carry[22] A1=carry[21] B1=B[21] C1=A[21]
XFE_RC_712_0 XOR3 $PINS O=SUM[22] I1=A[22] I2=B[22] I3=carry[22]
XFE_RC_711_0 MAO222P $PINS O=carry[23] A1=carry[22] B1=B[22] C1=A[22]
XFE_RC_660_0 XOR3 $PINS O=SUM[20] I1=A[20] I2=B[20] I3=carry[20]
XFE_RC_659_0 MAO222 $PINS O=carry[21] A1=carry[20] B1=B[20] C1=A[20]
XFE_RC_572_0 XOR3 $PINS O=SUM[19] I1=A[19] I2=B[19] I3=carry[19]
XFE_RC_571_0 MAO222 $PINS O=carry[20] A1=carry[19] B1=B[19] C1=A[19]
XFE_RC_565_0 MAO222 $PINS O=carry[11] A1=carry[10] B1=B[10] C1=A[10]
XFE_RC_493_0 MAO222 $PINS O=carry[19] A1=carry[18] B1=B[18] C1=A[18]
XFE_RC_483_0 MAO222 $PINS O=carry[12] A1=carry[11] B1=B[11] C1=A[11]
XFE_RC_424_0 XOR3 $PINS O=SUM[9] I1=B[9] I2=A[9] I3=carry[9]
XFE_RC_423_0 MAO222 $PINS O=carry[10] A1=carry[9] B1=B[9] C1=A[9]
XFE_RC_413_0 MAO222 $PINS O=carry[13] A1=carry[12] B1=B[12] C1=A[12]
XFE_RC_272_0 XOR3 $PINS O=SUM[13] I1=A[13] I2=B[13] I3=carry[13]
XFE_RC_271_0 MAO222 $PINS O=carry[14] A1=carry[13] B1=B[13] C1=A[13]
XFE_RC_265_0 MAO222 $PINS O=carry[4] A1=carry[3] B1=A[3] C1=B[3]
XFE_RC_187_0 MAO222P $PINS O=carry[15] A1=carry[14] B1=B[14] C1=A[14]
XFE_RC_109_0 MAO222 $PINS O=carry[5] A1=carry[4] B1=B[4] C1=A[4]
XFE_RC_108_0 XOR3 $PINS O=SUM[15] I1=A[15] I2=B[15] I3=carry[15]
XFE_RC_107_0 MAO222P $PINS O=carry[16] A1=carry[15] B1=B[15] C1=A[15]
XFE_RC_71_0 MAO222P $PINS O=carry[6] A1=carry[5] B1=B[5] C1=A[5]
XFE_RC_30_0 XOR3 $PINS O=SUM[6] I1=B[6] I2=A[6] I3=carry[6]
XFE_RC_29_0 MAO222P $PINS O=carry[7] A1=carry[6] B1=B[6] C1=A[6]
XU1 ND3P $PINS O=carry[2] I1=n16 I2=n17 I3=n18
XU2 XOR2HS $PINS O=SUM[2] I1=carry[2] I2=n19
XU3 ND3 $PINS O=carry[3] I1=n22 I2=n21 I3=n20
XU4 ND3P $PINS O=carry[25] I1=n24 I2=n25 I3=n26
XU5 XOR2HS $PINS O=n19 I1=A[2] I2=B[2]
XU6 ND3P $PINS O=carry[24] I1=n29 I2=n28 I3=n30
XU7 ND2 $PINS O=n2 I1=A[7] I2=B[7]
XU8 ND2 $PINS O=n20 I1=B[2] I2=A[2]
XU9 ND2 $PINS O=n21 I1=carry[2] I2=A[2]
XU11 ND2 $PINS O=n9 I1=A[16] I2=B[16]
XU12 XOR2HS $PINS O=SUM[23] I1=carry[23] I2=n27
XU13 AN2 $PINS O=n1 I1=B[0] I2=A[0]
XU15 ND2 $PINS O=n3 I1=carry[7] I2=A[7]
XU16 ND2 $PINS O=n4 I1=carry[7] I2=B[7]
XU17 ND3P $PINS O=carry[8] I1=n4 I2=n3 I3=n2
XU18 XOR2HS $PINS O=n5 I1=A[8] I2=B[8]
XU19 XOR2HS $PINS O=SUM[8] I1=carry[8] I2=n5
XU20 ND2 $PINS O=n6 I1=A[8] I2=B[8]
XU21 ND2 $PINS O=n7 I1=carry[8] I2=A[8]
XU22 ND2 $PINS O=n8 I1=carry[8] I2=B[8]
XU23 ND3 $PINS O=carry[9] I1=n7 I2=n8 I3=n6
XU24 ND2P $PINS O=n10 I1=carry[16] I2=A[16]
XU25 ND2 $PINS O=n11 I1=carry[16] I2=B[16]
XU26 ND3P $PINS O=carry[17] I1=n11 I2=n10 I3=n9
XU27 XOR2HS $PINS O=n12 I1=A[17] I2=B[17]
XU28 XOR2HS $PINS O=SUM[17] I1=n12 I2=carry[17]
XU29 ND2 $PINS O=n13 I1=A[17] I2=B[17]
XU30 ND2 $PINS O=n14 I1=carry[17] I2=A[17]
XU31 ND2 $PINS O=n15 I1=carry[17] I2=B[17]
XU32 ND3 $PINS O=carry[18] I1=n14 I2=n15 I3=n13
XU34 ND2 $PINS O=n22 I1=B[2] I2=carry[2]
XU36 ND2 $PINS O=n16 I1=B[1] I2=A[1]
XU37 ND2 $PINS O=n17 I1=A[1] I2=n1
XU38 XOR2HS $PINS O=n23 I1=A[24] I2=B[24]
XU39 XOR2HS $PINS O=SUM[24] I1=carry[24] I2=n23
XU40 ND2 $PINS O=n24 I1=carry[24] I2=A[24]
XU42 ND2S $PINS O=n26 I1=A[24] I2=B[24]
XU43 XOR2HS $PINS O=n27 I1=A[23] I2=B[23]
XU44 ND2P $PINS O=n28 I1=carry[23] I2=A[23]
XU45 ND2P $PINS O=n29 I1=carry[23] I2=B[23]
XU46 ND2 $PINS O=n30 I1=A[23] I2=B[23]
XU47 XOR2HS $PINS O=SUM[0] I1=B[0] I2=A[0]
.ENDS

.SUBCKT PE_Shift_Add_3_DW01_add_1_DW01_add_18 A[26] A[25] A[24] A[23] A[22]
+ A[21] A[20] A[19] A[18] A[17] A[16] A[15] A[14] A[13] A[12] A[11] A[10] A[9]
+ A[8] A[7] A[6] A[5] A[4] A[3] A[2] A[1] A[0] B[26] B[25] B[24] B[23] B[22]
+ B[21] B[20] B[19] B[18] B[17] B[16] B[15] B[14] B[13] B[12] B[11] B[10] B[9]
+ B[8] B[7] B[6] B[5] B[4] B[3] B[2] B[1] B[0] CI SUM[26] SUM[25] SUM[24]
+ SUM[23] SUM[22] SUM[21] SUM[20] SUM[19] SUM[18] SUM[17] SUM[16] SUM[15]
+ SUM[14] SUM[13] SUM[12] SUM[11] SUM[10] SUM[9] SUM[8] SUM[7] SUM[6] SUM[5]
+ SUM[4] SUM[3] SUM[2] SUM[1] SUM[0] CO
XFE_RC_690_0 INV2 $PINS O=SUM[16] I=FE_RN_332_0
XFE_RC_689_0 XNR3 $PINS O=FE_RN_332_0 I1=A[16] I2=B[16] I3=carry[16]
XFE_RC_680_0 INV2 $PINS O=SUM[21] I=FE_RN_327_0
XFE_RC_679_0 XNR3 $PINS O=FE_RN_327_0 I1=A[21] I2=B[21] I3=carry[21]
XFE_RC_668_0 INV1S $PINS O=SUM[7] I=FE_RN_321_0
XFE_RC_667_0 XNR3 $PINS O=FE_RN_321_0 I1=A[7] I2=B[7] I3=carry[7]
XFE_RC_597_0 INV1S $PINS O=FE_RN_295_0 I=B[10]
XFE_RC_596_0 AO13P $PINS O=n18 A1=FE_RN_295_0 B1=n13 B2=n14 B3=n12
XFE_RC_388_0 INV2 $PINS O=SUM[5] I=FE_RN_206_0
XFE_RC_387_0 XNR3 $PINS O=FE_RN_206_0 I1=A[5] I2=B[5] I3=carry[5]
XFE_RC_380_0 INV2 $PINS O=SUM[2] I=FE_RN_201_0
XFE_RC_379_0 XNR3 $PINS O=FE_RN_201_0 I1=A[2] I2=carry[2] I3=B[2]
XFE_RC_338_0 XOR2HS $PINS O=SUM[26] I1=FE_RN_57_0 I2=carry[26]
XFE_RC_97_0 XOR2HS $PINS O=FE_RN_57_0 I1=A[26] I2=B[26]
XFE_RC_1435_0 INV1S $PINS O=FE_RN_284_0 I=A[0]
XFE_RC_1434_0 AN2B1S $PINS O=n1 I1=B[0] B1=FE_RN_284_0
XFE_RC_802_0 XOR3 $PINS O=SUM[25] I1=A[25] I2=B[25] I3=carry[25]
XFE_RC_801_0 MAO222 $PINS O=carry[26] A1=carry[25] B1=B[25] C1=A[25]
XFE_RC_800_0 XOR3 $PINS O=SUM[22] I1=A[22] I2=B[22] I3=carry[22]
XFE_RC_799_0 MAO222P $PINS O=carry[23] A1=carry[22] B1=B[22] C1=A[22]
XFE_RC_776_0 XOR3 $PINS O=SUM[23] I1=A[23] I2=B[23] I3=carry[23]
XFE_RC_775_0 MAO222P $PINS O=carry[24] A1=carry[23] B1=B[23] C1=A[23]
XFE_RC_754_0 XOR3 $PINS O=SUM[24] I1=A[24] I2=B[24] I3=carry[24]
XFE_RC_753_0 MAO222 $PINS O=carry[25] A1=carry[24] B1=B[24] C1=A[24]
XFE_RC_752_0 XOR3 $PINS O=SUM[1] I1=A[1] I2=n1 I3=B[1]
XFE_RC_751_0 MAO222 $PINS O=carry[2] A1=B[1] B1=A[1] C1=n1
XFE_RC_698_0 XOR3 $PINS O=SUM[20] I1=A[20] I2=B[20] I3=carry[20]
XFE_RC_697_0 MAO222 $PINS O=carry[21] A1=carry[20] B1=B[20] C1=A[20]
XFE_RC_643_0 MAO222P $PINS O=carry[22] A1=carry[21] B1=B[21] C1=A[21]
XFE_RC_604_0 XOR3 $PINS O=SUM[19] I1=A[19] I2=B[19] I3=carry[19]
XFE_RC_603_0 MAO222 $PINS O=carry[20] A1=carry[19] B1=B[19] C1=A[19]
XFE_RC_547_0 MAO222 $PINS O=carry[3] A1=B[2] B1=carry[2] C1=A[2]
XFE_RC_546_0 XOR3 $PINS O=SUM[18] I1=A[18] I2=B[18] I3=carry[18]
XFE_RC_545_0 MAO222P $PINS O=carry[19] A1=carry[18] B1=B[18] C1=A[18]
XFE_RC_460_0 XOR3 $PINS O=SUM[3] I1=A[3] I2=B[3] I3=carry[3]
XFE_RC_459_0 MAO222 $PINS O=carry[4] A1=carry[3] B1=B[3] C1=A[3]
XFE_RC_458_0 XOR3 $PINS O=SUM[15] I1=A[15] I2=B[15] I3=carry[15]
XFE_RC_457_0 MAO222 $PINS O=carry[16] A1=carry[15] B1=B[15] C1=A[15]
XFE_RC_395_0 MAO222 $PINS O=carry[17] A1=carry[16] B1=B[16] C1=A[16]
XFE_RC_346_0 XOR3 $PINS O=SUM[17] I1=A[17] I2=B[17] I3=carry[17]
XFE_RC_345_0 MAO222P $PINS O=carry[18] A1=carry[17] B1=B[17] C1=A[17]
XFE_RC_342_0 XOR3 $PINS O=SUM[4] I1=A[4] I2=B[4] I3=carry[4]
XFE_RC_341_0 MAO222 $PINS O=carry[5] A1=carry[4] B1=B[4] C1=A[4]
XFE_RC_242_0 XOR3 $PINS O=SUM[14] I1=A[14] I2=B[14] I3=carry[14]
XFE_RC_241_0 MAO222 $PINS O=carry[15] A1=carry[14] B1=B[14] C1=A[14]
XFE_RC_239_0 MAO222 $PINS O=carry[6] A1=carry[5] B1=B[5] C1=A[5]
XFE_RC_213_0 XOR3 $PINS O=SUM[6] I1=A[6] I2=B[6] I3=carry[6]
XFE_RC_212_0 MAO222 $PINS O=carry[7] A1=carry[6] B1=B[6] C1=A[6]
XFE_RC_111_0 MAO222 $PINS O=carry[8] A1=carry[7] B1=B[7] C1=A[7]
XFE_RC_96_0 XOR3 $PINS O=SUM[8] I1=A[8] I2=B[8] I3=carry[8]
XFE_RC_95_0 MAO222P $PINS O=carry[9] A1=carry[8] B1=B[8] C1=A[8]
XU1 ND2 $PINS O=n12 I1=A[9] I2=B[9]
XU2 ND2 $PINS O=n2 I1=A[12] I2=B[12]
XU4 XOR3 $PINS O=SUM[12] I1=A[12] I2=B[12] I3=carry[12]
XU5 ND2 $PINS O=n3 I1=carry[12] I2=A[12]
XU6 ND2 $PINS O=n4 I1=carry[12] I2=B[12]
XU7 ND3P $PINS O=carry[13] I1=n4 I2=n3 I3=n2
XU8 XOR2HS $PINS O=n5 I1=A[13] I2=B[13]
XU9 XOR2HS $PINS O=SUM[13] I1=n5 I2=carry[13]
XU10 ND2 $PINS O=n6 I1=A[13] I2=B[13]
XU11 ND2 $PINS O=n7 I1=carry[13] I2=A[13]
XU12 ND2 $PINS O=n8 I1=carry[13] I2=B[13]
XU13 ND3P $PINS O=carry[14] I1=n7 I2=n8 I3=n6
XU14 XOR3 $PINS O=SUM[11] I1=B[11] I2=A[11] I3=carry[11]
XU15 ND2 $PINS O=n9 I1=carry[11] I2=B[11]
XU16 ND2 $PINS O=n10 I1=carry[11] I2=A[11]
XU17 ND2 $PINS O=n11 I1=B[11] I2=A[11]
XU19 ND3P $PINS O=carry[11] I1=n17 I2=n18 I3=n16
XU20 XOR3 $PINS O=SUM[9] I1=B[9] I2=A[9] I3=carry[9]
XU21 ND2P $PINS O=n13 I1=carry[9] I2=A[9]
XU22 ND2P $PINS O=n14 I1=carry[9] I2=B[9]
XU23 ND3P $PINS O=carry[10] I1=n13 I2=n14 I3=n12
XU24 XOR2HS $PINS O=n15 I1=A[10] I2=B[10]
XU25 XOR2HS $PINS O=SUM[10] I1=n15 I2=carry[10]
XU26 ND2 $PINS O=n16 I1=A[10] I2=B[10]
XU27 ND2 $PINS O=n17 I1=carry[10] I2=A[10]
XU29 XOR2HS $PINS O=SUM[0] I1=B[0] I2=A[0]
XU18 ND3P $PINS O=carry[12] I1=n9 I2=n10 I3=n11
.ENDS

.SUBCKT PE_Shift_Add_3_DW01_add_0_DW01_add_17 A[26] A[25] A[24] A[23] A[22]
+ A[21] A[20] A[19] A[18] A[17] A[16] A[15] A[14] A[13] A[12] A[11] A[10] A[9]
+ A[8] A[7] A[6] A[5] A[4] A[3] A[2] A[1] A[0] B[26] B[25] B[24] B[23] B[22]
+ B[21] B[20] B[19] B[18] B[17] B[16] B[15] B[14] B[13] B[12] B[11] B[10] B[9]
+ B[8] B[7] B[6] B[5] B[4] B[3] B[2] B[1] B[0] CI SUM[26] SUM[25] SUM[24]
+ SUM[23] SUM[22] SUM[21] SUM[20] SUM[19] SUM[18] SUM[17] SUM[16] SUM[15]
+ SUM[14] SUM[13] SUM[12] SUM[11] SUM[10] SUM[9] SUM[8] SUM[7] SUM[6] SUM[5]
+ SUM[4] SUM[3] SUM[2] SUM[1] SUM[0] CO
XFE_RC_1143_0 XOR2HS $PINS O=FE_RN_127_0 I1=B[26] I2=A[26]
XFE_RC_1142_0 XOR2HS $PINS O=SUM[26] I1=FE_RN_127_0 I2=carry[26]
XFE_RC_949_0 XOR3 $PINS O=SUM[15] I1=A[15] I2=B[15] I3=carry[15]
XFE_RC_948_0 MAO222P $PINS O=carry[16] A1=carry[15] B1=B[15] C1=A[15]
XFE_RC_820_0 XOR3 $PINS O=SUM[1] I1=A[1] I2=B[1] I3=n1
XFE_RC_819_0 MAO222 $PINS O=carry[2] A1=A[1] B1=B[1] C1=n1
XFE_RC_772_0 XOR3 $PINS O=SUM[2] I1=A[2] I2=B[2] I3=carry[2]
XFE_RC_771_0 MAO222 $PINS O=carry[3] A1=carry[2] B1=A[2] C1=B[2]
XFE_RC_716_0 XOR3 $PINS O=SUM[3] I1=A[3] I2=B[3] I3=carry[3]
XFE_RC_715_0 MAO222 $PINS O=carry[4] A1=carry[3] B1=B[3] C1=A[3]
XFE_RC_674_0 XOR3S $PINS O=SUM[4] I1=A[4] I2=B[4] I3=carry[4]
XFE_RC_673_0 MAO222 $PINS O=carry[5] A1=carry[4] B1=B[4] C1=A[4]
XFE_RC_632_0 XOR3 $PINS O=SUM[6] I1=A[6] I2=B[6] I3=carry[6]
XFE_RC_631_0 MAO222 $PINS O=carry[7] A1=carry[6] B1=B[6] C1=A[6]
XFE_RC_580_0 XOR3 $PINS O=SUM[7] I1=A[7] I2=B[7] I3=carry[7]
XFE_RC_579_0 MAO222 $PINS O=carry[8] A1=carry[7] B1=B[7] C1=A[7]
XFE_RC_540_0 XOR3 $PINS O=SUM[5] I1=A[5] I2=B[5] I3=carry[5]
XFE_RC_539_0 MAO222 $PINS O=carry[6] A1=carry[5] B1=B[5] C1=A[5]
XFE_RC_496_0 XOR3 $PINS O=SUM[8] I1=A[8] I2=B[8] I3=carry[8]
XFE_RC_495_0 MAO222P $PINS O=carry[9] A1=carry[8] B1=B[8] C1=A[8]
XFE_RC_394_0 XOR3 $PINS O=SUM[11] I1=A[11] I2=B[11] I3=carry[11]
XFE_RC_393_0 MAO222P $PINS O=carry[12] A1=carry[11] B1=B[11] C1=A[11]
XFE_RC_392_0 XOR3 $PINS O=SUM[9] I1=A[9] I2=B[9] I3=carry[9]
XFE_RC_391_0 MAO222P $PINS O=carry[10] A1=carry[9] B1=B[9] C1=A[9]
XFE_RC_338_0 XOR3 $PINS O=SUM[13] I1=A[13] I2=B[13] I3=carry[13]
XFE_RC_337_0 MAO222P $PINS O=carry[14] A1=carry[13] B1=B[13] C1=A[13]
XFE_RC_238_0 XOR3 $PINS O=SUM[19] I1=A[19] I2=B[19] I3=carry[19]
XFE_RC_237_0 MAO222P $PINS O=carry[20] A1=carry[19] B1=B[19] C1=A[19]
XFE_RC_234_0 XOR3 $PINS O=SUM[21] I1=A[21] I2=B[21] I3=carry[21]
XFE_RC_233_0 MAO222 $PINS O=carry[22] A1=carry[21] B1=A[21] C1=B[21]
XFE_RC_146_0 XOR3 $PINS O=SUM[22] I1=A[22] I2=B[22] I3=carry[22]
XFE_RC_145_0 MAO222P $PINS O=carry[23] A1=carry[22] B1=B[22] C1=A[22]
XFE_RC_144_0 XOR3 $PINS O=SUM[17] I1=A[17] I2=B[17] I3=carry[17]
XFE_RC_143_0 MAO222P $PINS O=carry[18] A1=carry[17] B1=B[17] C1=A[17]
XFE_RC_86_0 XOR3 $PINS O=SUM[23] I1=A[23] I2=B[23] I3=carry[23]
XFE_RC_85_0 MAO222P $PINS O=carry[24] A1=carry[23] B1=B[23] C1=A[23]
XFE_RC_56_0 XOR3 $PINS O=SUM[24] I1=A[24] I2=B[24] I3=carry[24]
XFE_RC_55_0 MAO222P $PINS O=carry[25] A1=carry[24] B1=B[24] C1=A[24]
XU1 ND3P $PINS O=carry[11] I1=n5 I2=n6 I3=n7
XU2 ND3 $PINS O=carry[21] I1=n21 I2=n20 I3=n22
XU3 XOR3 $PINS O=SUM[12] I1=B[12] I2=A[12] I3=carry[12]
XU4 XOR3 $PINS O=SUM[14] I1=B[14] I2=A[14] I3=carry[14]
XU6 XOR3 $PINS O=SUM[16] I1=B[16] I2=A[16] I3=carry[16]
XU7 XOR3 $PINS O=SUM[18] I1=B[18] I2=A[18] I3=carry[18]
XU8 ND3P $PINS O=carry[19] I1=n18 I2=n17 I3=n19
XU9 XOR3 $PINS O=SUM[20] I1=B[20] I2=A[20] I3=carry[20]
XU10 AN2 $PINS O=n1 I1=B[0] I2=A[0]
XU11 XOR3 $PINS O=SUM[25] I1=B[25] I2=A[25] I3=carry[25]
XU12 ND2 $PINS O=n2 I1=carry[25] I2=B[25]
XU13 ND2P $PINS O=n3 I1=carry[25] I2=A[25]
XU14 ND2 $PINS O=n4 I1=A[25] I2=B[25]
XU15 ND3P $PINS O=carry[26] I1=n2 I2=n3 I3=n4
XU16 XOR3 $PINS O=SUM[10] I1=B[10] I2=A[10] I3=carry[10]
XU17 ND2 $PINS O=n5 I1=carry[10] I2=B[10]
XU18 ND2P $PINS O=n6 I1=carry[10] I2=A[10]
XU19 ND2 $PINS O=n7 I1=A[10] I2=B[10]
XU20 ND2 $PINS O=n8 I1=carry[12] I2=B[12]
XU21 ND2 $PINS O=n9 I1=carry[12] I2=A[12]
XU22 ND2 $PINS O=n10 I1=B[12] I2=A[12]
XU23 ND3P $PINS O=carry[13] I1=n8 I2=n9 I3=n10
XU24 ND2 $PINS O=n11 I1=carry[14] I2=B[14]
XU25 ND2 $PINS O=n12 I1=carry[14] I2=A[14]
XU26 ND2 $PINS O=n13 I1=A[14] I2=B[14]
XU27 ND2 $PINS O=n14 I1=carry[16] I2=B[16]
XU28 ND2 $PINS O=n15 I1=carry[16] I2=A[16]
XU29 ND2 $PINS O=n16 I1=B[16] I2=A[16]
XU30 ND3P $PINS O=carry[17] I1=n15 I2=n14 I3=n16
XU31 ND2P $PINS O=n17 I1=carry[18] I2=B[18]
XU32 ND2 $PINS O=n18 I1=carry[18] I2=A[18]
XU33 ND2 $PINS O=n19 I1=B[18] I2=A[18]
XU34 ND2 $PINS O=n20 I1=carry[20] I2=B[20]
XU35 ND2 $PINS O=n21 I1=carry[20] I2=A[20]
XU36 ND2 $PINS O=n22 I1=A[20] I2=B[20]
XU37 XOR2HS $PINS O=SUM[0] I1=B[0] I2=A[0]
XU5 ND3P $PINS O=carry[15] I1=n12 I2=n11 I3=n13
.ENDS

.SUBCKT PE_Shift_Add_3 rst_n en clear calc_done stage_sel x_in[16] x_in[15]
+ x_in[14] x_in[13] x_in[12] x_in[11] x_in[10] x_in[9] x_in[8] x_in[7] x_in[6]
+ x_in[5] x_in[4] x_in[3] x_in[2] x_in[1] x_in[0] sign1[1] sign1[0] sign2[1]
+ sign2[0] sign3[1] sign3[0] shf1[3] shf1[2] shf1[1] shf1[0] shf2[3] shf2[2]
+ shf2[1] shf2[0] shf3[3] shf3[2] shf3[1] shf3[0] y_out[16] y_out[15] y_out[14]
+ y_out[13] y_out[12] y_out[11] y_out[10] y_out[9] y_out[8] y_out[7] y_out[6]
+ y_out[5] y_out[4] y_out[3] y_out[2] y_out[1] y_out[0] n30 i_rst_n
+ FE_OFN4_FE_DBTN15_n64 FE_OFN3_FE_DBTN15_n64 FE_OFN16_i_rst_n FE_OFN13_i_rst_n
+ FE_OFN7_i_rst_n FE_OFN54_s21_0 FE_OFN55_h21_3 FE_OFN56_h21_2 FE_OFN57_h22_3
+ FE_OFN58_h22_2 FE_OFN59_h23_3 FE_OFN60_h23_2 FE_OFN80_s22_0 FE_OFN84_s23_1
+ FE_OFN91_h21_1 FE_OFN94_h23_1 clk_clone3 clk_clone2 clk clk_clone1
XFE_PHC1314_next_acc_0 DELA $PINS O=FE_PHN1314_next_acc_0 I=next_acc[0]
XFE_PHC1283_N235 DELB $PINS O=FE_PHN1283_N235 I=N235
XFE_PHC1253_N236 DELB $PINS O=FE_PHN1253_N236 I=N236
XFE_PHC1252_N239 DELB $PINS O=FE_PHN1252_N239 I=N239
XFE_PHC1248_N238 DELB $PINS O=FE_PHN1248_N238 I=N238
XFE_PHC1247_N250 DELB $PINS O=FE_PHN1247_N250 I=N250
XFE_PHC1246_N237 DELB $PINS O=FE_PHN1246_N237 I=N237
XFE_PHC1239_N244 DELB $PINS O=N244 I=FE_PHN1239_N244
XFE_PHC1230_N249 DELB $PINS O=FE_PHN1230_N249 I=N249
XFE_PHC1224_N241 DELB $PINS O=FE_PHN1224_N241 I=N241
XFE_PHC1221_N240 DELB $PINS O=FE_PHN1221_N240 I=N240
XFE_PHC1219_N243 DELB $PINS O=FE_PHN1219_N243 I=N243
XFE_PHC1207_N245 DELB $PINS O=FE_PHN1207_N245 I=N245
XFE_PHC1196_N246 DELB $PINS O=FE_PHN1196_N246 I=N246
XFE_PHC1186_N248 DELB $PINS O=FE_PHN1186_N248 I=N248
XFE_PHC1184_N242 DELB $PINS O=N242 I=FE_PHN1184_N242
XFE_PHC848_acc_reg_22 DELC $PINS O=FE_PHN848_acc_reg_22 I=acc_reg[22]
XFE_PHC776_N251 DELC $PINS O=FE_PHN776_N251 I=N251
XFE_PHC739_pe_r2_9 DELC $PINS O=y_out[9] I=FE_PHN739_pe_r2_9
XFE_PHC738_pe_r2_6 DELC $PINS O=y_out[6] I=FE_PHN738_pe_r2_6
XFE_PHC735_pe_r2_10 DELC $PINS O=y_out[10] I=FE_PHN735_pe_r2_10
XFE_PHC734_pe_r2_7 DELC $PINS O=y_out[7] I=FE_PHN734_pe_r2_7
XFE_PHC732_pe_r2_4 DELC $PINS O=y_out[4] I=FE_PHN732_pe_r2_4
XFE_PHC731_pe_r2_2 DELC $PINS O=y_out[2] I=FE_PHN731_pe_r2_2
XFE_PHC730_pe_r2_1 DELC $PINS O=y_out[1] I=FE_PHN730_pe_r2_1
XFE_PHC729_pe_r2_3 DELC $PINS O=y_out[3] I=FE_PHN729_pe_r2_3
XFE_RC_843_0 AN2 $PINS O=FE_RN_400_0 I1=shf1[3] I2=n83
XFE_RC_842_0 AN2 $PINS O=FE_RN_392_0 I1=FE_RN_400_0 I2=sll_16/ML_int[3][6]
XFE_RC_820_0 AO12 $PINS O=N47 A1=FE_RN_392_0 B1=N20 B2=FE_RN_1
XFE_RC_819_0 INV2 $PINS O=FE_RN_391_0 I=sll_16/ML_int[2][3]
XFE_RC_818_0 NR2T $PINS O=term1_shifted[3] I1=FE_RN_391_0 I2=n98
XFE_RC_806_0 INV1S $PINS O=FE_RN_385_0 I=shf1[3]
XFE_RC_805_0 AN2B1T $PINS O=term1_shifted[5] I1=sll_16/ML_int[3][5]
+ B1=FE_RN_385_0
XFE_RC_793_0 AN2 $PINS O=FE_RN_377_0 I1=term3_shifted[5] I2=sign3[0]
XFE_RC_792_0 AO12 $PINS O=N156 A1=FE_RN_377_0 B1=N129 B2=FE_OFN137_s23_0
XFE_RC_791_0 AN2S $PINS O=FE_RN_376_0 I1=term3_shifted[2] I2=sign3[0]
XFE_RC_790_0 AO12T $PINS O=N153 A1=FE_RN_376_0 B1=N126 B2=FE_OFN137_s23_0
XFE_RC_789_0 INV2 $PINS O=N100 I=FE_RN_375_0
XFE_RC_788_0 AOI22H $PINS O=FE_RN_375_0 A1=N73 A2=FE_OFN80_s22_0
+ B1=term2_shifted[4] B2=FE_OFN324_s22_0
XFE_RC_784_0 INV2 $PINS O=N98 I=FE_RN_372_0
XFE_RC_783_0 AN2 $PINS O=FE_RN_373_0 I1=term2_shifted[2] I2=FE_OFN324_s22_0
XFE_RC_782_0 AOI12HP $PINS O=FE_RN_372_0 A1=FE_RN_373_0 B1=N71
+ B2=FE_OFN80_s22_0
XFE_RC_781_0 AN2 $PINS O=FE_RN_371_0 I1=term3_shifted[3] I2=sign3[0]
XFE_RC_780_0 AOI12H $PINS O=FE_RN_166_0 A1=FE_RN_371_0 B1=N127
+ B2=FE_OFN137_s23_0
XFE_RC_728_0 INV2 $PINS O=N155 I=FE_RN_349_0
XFE_RC_727_0 AOI12H $PINS O=FE_RN_349_0 A1=FE_RN_231_0 B1=N128
+ B2=FE_OFN137_s23_0
XFE_RC_719_0 INV2 $PINS O=N97 I=FE_RN_345_0
XFE_RC_718_0 AN2T $PINS O=FE_RN_346_0 I1=term2_shifted[1] I2=FE_OFN324_s22_0
XFE_RC_717_0 AOI12HP $PINS O=FE_RN_345_0 A1=FE_RN_346_0 B1=N70
+ B2=FE_OFN80_s22_0
XFE_RC_678_0 INV2 $PINS O=FE_RN_326_0 I=sll_16/ML_int[2][6]
XFE_RC_677_0 MXL2HS $PINS OB=sll_16/ML_int[3][6] S=n72 A=FE_RN_326_0
+ B=FE_RN_152_0
XFE_RC_608_0 OR2 $PINS O=FE_RN_300_0 I1=FE_RN_1 I2=n83
XFE_RC_607_0 AN2 $PINS O=N41 I1=FE_RN_300_0 I2=N14
XFE_RC_598_0 AN2T $PINS O=term1_shifted[6] I1=sll_16/ML_int[3][6] I2=shf1[3]
XFE_RC_574_0 ND2P $PINS O=FE_RN_286_0 I1=N16 I2=FE_RN_1
XFE_RC_573_0 OR3B2 $PINS O=FE_RN_287_0 I1=n98 B1=sll_16/ML_int[2][2] B2=n83
XFE_RC_572_0 ND2P $PINS O=N43 I1=FE_RN_286_0 I2=FE_RN_287_0
XFE_RC_546_0 AN2 $PINS O=FE_RN_274_0 I1=term3_shifted[6] I2=sign3[0]
XFE_RC_545_0 AO12 $PINS O=N157 A1=FE_RN_274_0 B1=N130 B2=FE_OFN137_s23_0
XFE_RC_536_0 INV2 $PINS O=N99 I=FE_RN_270_0
XFE_RC_535_0 AN2 $PINS O=FE_RN_271_0 I1=term2_shifted[3] I2=FE_OFN324_s22_0
XFE_RC_534_0 AOI12H $PINS O=FE_RN_270_0 A1=FE_RN_271_0 B1=N72 B2=FE_OFN80_s22_0
XFE_RC_466_0 INV2 $PINS O=sll_16/ML_int[1][2] I=FE_RN_241_0
XFE_RC_465_0 MXL2HS $PINS OB=FE_RN_241_0 S=FE_OFN259_h21_0 A=term1_in[2]
+ B=term1_in[1]
XFE_RC_431_0 INV2 $PINS O=FE_RN_226_0 I=sll_17/ML_int[2][3]
XFE_RC_430_0 NR2T $PINS O=term2_shifted[3] I1=n109 I2=FE_RN_226_0
XFE_RC_426_0 AN2S $PINS O=FE_RN_224_0 I1=term1_shifted[4] I2=n83
XFE_RC_425_0 AO12T $PINS O=N45 A1=FE_RN_224_0 B1=N18 B2=FE_RN_1
XFE_RC_408_0 ND2T $PINS O=FE_RN_215_0 I1=N125 I2=FE_OFN137_s23_0
XFE_RC_407_0 OR3B1 $PINS O=FE_RN_216_0 I1=n120 I2=n119 B1=sign3[0]
XFE_RC_406_0 ND2T $PINS O=N152 I1=FE_RN_216_0 I2=FE_RN_215_0
XFE_RC_391_0 ND2 $PINS O=FE_RN_207_0 I1=N15 I2=FE_RN_1
XFE_RC_390_0 OR3B1 $PINS O=FE_RN_208_0 I1=n98 I2=n97 B1=n83
XFE_RC_389_0 ND2P $PINS O=N42 I1=FE_RN_208_0 I2=FE_RN_207_0
XFE_RC_368_0 AN2T $PINS O=term1_shifted[4] I1=sll_16/ML_int[3][4] I2=shf1[3]
XFE_RC_358_0 INV2 $PINS O=sll_18/ML_int[1][2] I=FE_RN_191_0
XFE_RC_357_0 MXL2HS $PINS OB=FE_RN_191_0 S=shf3[0] A=term3_in[2] B=term3_in[1]
XFE_RC_332_0 AN2 $PINS O=FE_RN_182_0 I1=term1_shifted[3] I2=n83
XFE_RC_331_0 AO12T $PINS O=N44 A1=FE_RN_182_0 B1=N17 B2=FE_RN_1
XFE_RC_305_0 INV2 $PINS O=N154 I=FE_RN_166_0
XFE_RC_280_0 INV2 $PINS O=sll_16/ML_int[2][2] I=FE_RN_152_0
XFE_RC_279_0 MXL2H $PINS OB=FE_RN_152_0 S=FE_OFN191_h21_1 A=sll_16/ML_int[1][2]
+ B=sll_16/ML_int[1][0]
XFE_RC_224_0 AN2B1T $PINS O=term1_in[1] I1=x_in[1] B1=sign1[1]
XCTS_ccl_a_INV_CLK_G1_L8_101 INV3CK $PINS O=CTS_10 I=CTS_11
XCTS_ccl_a_INV_CLK_G1_L7_101 INV2CK $PINS O=CTS_11 I=CTS_12
XFE_RC_1551_0 OR2B1S $PINS O=FE_RN_351_0 I1=sign2[1] B1=n38
XFE_RC_1550_0 OR3 $PINS O=n107 I1=FE_RN_351_0 I2=FE_RN_211_0 I3=shf2[0]
XFE_RC_1366_0 INV1S $PINS O=FE_RN_245_0 I=sll_17/ML_int[2][4]
XFE_RC_1365_0 MXL2HS $PINS OB=sll_17/ML_int[3][4] S=FE_OFN330_n42 A=FE_RN_245_0
+ B=n107
XFE_RC_1346_0 MUXB2 $PINS O=term3_shifted[2] S=FE_OFN186_h23_1
+ A=sll_18/ML_int[1][2] B=sll_18/ML_int[1][0] EB=n120
XFE_RC_1339_0 AN3 $PINS O=FE_RN_231_0 I1=sll_18/ML_int[3][4] I2=n21 I3=sign3[0]
XFE_RC_1299_0 INV2 $PINS O=FE_RN_211_0 I=x_in[0]
XFE_RC_1298_0 NR2 $PINS O=term1_in[0] I1=sign1[1] I2=FE_RN_211_0
XFE_RC_1255_0 INV1S $PINS O=FE_RN_188_0 I=sll_16/ML_int[2][4]
XFE_RC_1254_0 MXL2HS $PINS OB=sll_16/ML_int[3][4] S=n72 A=FE_RN_188_0 B=n96
XFE_RC_1113_0 MUXB2 $PINS O=term2_shifted[2] S=shf2[1] A=sll_17/ML_int[1][2]
+ B=sll_17/ML_int[1][0] EB=n109
XFE_RC_984_0 INV1S $PINS O=FE_RN_51_0 I=FE_OFN191_h21_1
XFE_RC_983_0 INV1S $PINS O=FE_RN_52_0 I=sll_16/ML_int[1][1]
XFE_RC_982_0 INV1S $PINS O=FE_RN_53_0 I=FE_OFN191_h21_1
XFE_RC_981_0 ND2 $PINS O=FE_RN_54_0 I1=sll_16/ML_int[1][3] I2=FE_RN_53_0
XFE_RC_980_0 OAI12HS $PINS O=sll_16/ML_int[2][3] A1=FE_RN_54_0 B1=FE_RN_52_0
+ B2=FE_RN_51_0
XFE_RC_18_0 OA12 $PINS O=N151 A1=N124 B1=FE_OFN137_s23_0 B2=sign3[0]
XFE_RC_7_0 OA12 $PINS O=N96 A1=N69 B1=FE_OFN80_s22_0 B2=FE_OFN324_s22_0
XFE_OFC658_mac_in_real_1 INV2 $PINS O=n145 I=x_in[1]
XFE_OFC629_n42 INV1S $PINS O=FE_OFN330_n42 I=FE_OFN205_h22_2
XFE_OFC628_n42 INV1S $PINS O=FE_OFN205_h22_2 I=shf2[2]
XFE_OFC626_s22_0 INV1S $PINS O=FE_OFN327_s22_0 I=FE_RN_6
XFE_OFC622_s22_0 INV1S $PINS O=FE_OFN324_s22_0 I=FE_OFN80_s22_0
XFE_OFC621_s22_0 BUF1 $PINS O=n57 I=FE_OFN80_s22_0
XFE_OFC620_s22_0 INV1S $PINS O=FE_RN_6 I=FE_OFN80_s22_0
XFE_OFC611_s23_0 INV1S $PINS O=FE_OFN323_s23_0 I=n28
XFE_OFC607_s23_0 INV2 $PINS O=FE_OFN137_s23_0 I=sign3[0]
XFE_OFC606_s23_0 INV1S $PINS O=n28 I=sign3[0]
XFE_OFC577_h23_1 BUF1 $PINS O=FE_OFN186_h23_1 I=shf3[1]
XFE_OFC533_h21_1 BUF1 $PINS O=FE_OFN191_h21_1 I=shf1[1]
XFE_OFC504_h23_3 INV1S $PINS O=n21 I=shf3[3]
XFE_OFC499_h21_2 INV2 $PINS O=n72 I=shf1[2]
XFE_OFC492_h21_3 INV1S $PINS O=n75 I=shf1[3]
XFE_OFC491_h21_3 INV1S $PINS O=FE_RN_5 I=shf1[3]
XFE_OFC468_h21_0 BUF1 $PINS O=FE_OFN259_h21_0 I=shf1[0]
XFE_OFC451_s23_1 BUF1 $PINS O=FE_OFN242_s23_1 I=sign3[1]
XFE_OFC412_h23_0 INV1S $PINS O=n9 I=shf3[0]
XFE_OFC381_h22_0 INV1S $PINS O=n35 I=shf2[0]
XFE_OFC377_h22_1 INV2 $PINS O=n38 I=shf2[1]
XFE_OFC314_h23_2 BUF1 $PINS O=FE_RN_3 I=FE_OFN60_h23_2
XFE_OFC294_pe_clear_d1 INV2 $PINS O=n147 I=clear
XFE_OFC229_h22_3 INV1S $PINS O=n48 I=FE_OFN57_h22_3
XFE_OFC211_s21_0 INV2 $PINS O=n83 I=sign1[0]
XFE_OFC210_s21_0 BUF1 $PINS O=FE_RN_1 I=sign1[0]
XU110 AO22 $PINS O=base_val[13] A1=acc_reg[13] A2=n147 B1=clear
+ B2=FE_OFN3_FE_DBTN15_n64
XU115 AO22 $PINS O=N67 A1=sign1[0] A2=N40 B1=term1_shifted[26] B2=n83
XU134 AO22 $PINS O=N48 A1=N21 A2=FE_RN_1 B1=term1_shifted[7] B2=n83
XU136 AO22 $PINS O=N46 A1=N19 A2=FE_RN_1 B1=term1_shifted[5] B2=n83
XU142 AO22 $PINS O=N177 A1=n28 A2=N150 B1=term3_shifted[26] B2=FE_OFN323_s23_0
XU143 AO22 $PINS O=N176 A1=N149 A2=n28 B1=term3_shifted[25] B2=FE_OFN323_s23_0
XU146 AO22 $PINS O=N173 A1=N146 A2=n28 B1=term3_shifted[22] B2=FE_OFN323_s23_0
XU147 AO22 $PINS O=N172 A1=N145 A2=n28 B1=term3_shifted[21] B2=FE_OFN323_s23_0
XU148 AO22 $PINS O=N171 A1=N144 A2=n28 B1=term3_shifted[20] B2=FE_OFN323_s23_0
XU149 AO22 $PINS O=N170 A1=N143 A2=n28 B1=term3_shifted[19] B2=FE_OFN323_s23_0
XU150 AO22 $PINS O=N169 A1=N142 A2=n28 B1=term3_shifted[18] B2=FE_OFN323_s23_0
XU151 AO22 $PINS O=N168 A1=N141 A2=n28 B1=term3_shifted[17] B2=FE_OFN323_s23_0
XU152 AO22 $PINS O=N167 A1=N140 A2=n28 B1=term3_shifted[16] B2=FE_OFN323_s23_0
XU153 AO22 $PINS O=N166 A1=N139 A2=n28 B1=term3_shifted[15] B2=FE_OFN323_s23_0
XU154 AO22 $PINS O=N165 A1=N138 A2=FE_OFN137_s23_0 B1=term3_shifted[14]
+ B2=FE_OFN323_s23_0
XU155 AO22 $PINS O=N164 A1=N137 A2=FE_OFN137_s23_0 B1=term3_shifted[13]
+ B2=sign3[0]
XU156 AO22 $PINS O=N163 A1=N136 A2=FE_OFN137_s23_0 B1=term3_shifted[12]
+ B2=sign3[0]
XU157 AO22 $PINS O=N162 A1=N135 A2=FE_OFN137_s23_0 B1=term3_shifted[11]
+ B2=sign3[0]
XU158 AO22 $PINS O=N161 A1=N134 A2=FE_OFN137_s23_0 B1=term3_shifted[10]
+ B2=sign3[0]
XU159 AO22 $PINS O=N160 A1=N133 A2=FE_OFN137_s23_0 B1=term3_shifted[9]
+ B2=sign3[0]
XU160 AO22 $PINS O=N159 A1=N132 A2=FE_OFN137_s23_0 B1=term3_shifted[8]
+ B2=sign3[0]
XU176 AO22 $PINS O=N115 A1=N88 A2=FE_OFN327_s22_0 B1=term2_shifted[19]
+ B2=FE_RN_6
XU177 AO22 $PINS O=N114 A1=N87 A2=FE_OFN327_s22_0 B1=term2_shifted[18]
+ B2=FE_RN_6
XU178 AO22 $PINS O=N113 A1=N86 A2=FE_OFN327_s22_0 B1=term2_shifted[17]
+ B2=FE_RN_6
XU179 AO22 $PINS O=N112 A1=N85 A2=n57 B1=term2_shifted[16] B2=FE_RN_6
XU180 AO22 $PINS O=N111 A1=N84 A2=n57 B1=term2_shifted[15] B2=FE_RN_6
XU181 AO22 $PINS O=N110 A1=N83 A2=n57 B1=term2_shifted[14] B2=FE_OFN324_s22_0
XU183 AO22 $PINS O=N108 A1=N81 A2=n57 B1=term2_shifted[12] B2=FE_OFN324_s22_0
XU184 AO22 $PINS O=N107 A1=N80 A2=n57 B1=term2_shifted[11] B2=FE_OFN324_s22_0
XU185 AO22 $PINS O=N106 A1=n57 A2=N79 B1=term2_shifted[10] B2=FE_OFN324_s22_0
XU186 AO22 $PINS O=N105 A1=N78 A2=n57 B1=term2_shifted[9] B2=FE_OFN324_s22_0
XU187 AO22 $PINS O=N104 A1=N77 A2=FE_OFN80_s22_0 B1=term2_shifted[8]
+ B2=FE_OFN324_s22_0
XU188 AO22 $PINS O=N103 A1=N76 A2=FE_OFN80_s22_0 B1=term2_shifted[7]
+ B2=FE_OFN324_s22_0
XU189 AO22 $PINS O=N102 A1=N75 A2=FE_OFN80_s22_0 B1=term2_shifted[6]
+ B2=FE_OFN324_s22_0
XU190 AO22 $PINS O=N101 A1=N74 A2=FE_OFN80_s22_0 B1=term2_shifted[5]
+ B2=FE_OFN324_s22_0
Xsll_18/M1_0_1 MUX2 $PINS O=sll_18/ML_int[1][1] S=shf3[0] A=term3_in[1]
+ B=term3_in[0]
Xsll_18/M1_0_3 MUX2 $PINS O=sll_18/ML_int[1][3] S=shf3[0] A=term3_in[3]
+ B=term3_in[2]
Xsll_18/M1_0_4 MUX2 $PINS O=sll_18/ML_int[1][4] S=shf3[0] A=term3_in[4]
+ B=term3_in[3]
Xsll_18/M1_0_6 MUX2 $PINS O=sll_18/ML_int[1][6] S=shf3[0] A=term3_in[6]
+ B=term3_in[5]
Xsll_18/M1_0_7 MUX2 $PINS O=sll_18/ML_int[1][7] S=shf3[0] A=term3_in[7]
+ B=term3_in[6]
Xsll_18/M1_1_2 MUX2 $PINS O=sll_18/ML_int[2][2] S=FE_OFN186_h23_1
+ A=sll_18/ML_int[1][2] B=sll_18/ML_int[1][0]
Xsll_18/M1_1_3 MUX2 $PINS O=sll_18/ML_int[2][3] S=FE_OFN186_h23_1
+ A=sll_18/ML_int[1][3] B=sll_18/ML_int[1][1]
Xsll_18/M1_1_4 MUX2 $PINS O=sll_18/ML_int[2][4] S=FE_OFN186_h23_1
+ A=sll_18/ML_int[1][4] B=sll_18/ML_int[1][2]
Xsll_18/M1_1_5 MUX2 $PINS O=sll_18/ML_int[2][5] S=FE_OFN186_h23_1
+ A=sll_18/ML_int[1][5] B=sll_18/ML_int[1][3]
Xsll_18/M1_1_6 MUX2 $PINS O=sll_18/ML_int[2][6] S=FE_OFN186_h23_1
+ A=sll_18/ML_int[1][6] B=sll_18/ML_int[1][4]
Xsll_18/M1_1_7 MUX2 $PINS O=sll_18/ML_int[2][7] S=FE_OFN186_h23_1
+ A=sll_18/ML_int[1][7] B=sll_18/ML_int[1][5]
Xsll_18/M1_2_4 MUX2 $PINS O=sll_18/ML_int[3][4] S=FE_RN_3 A=sll_18/ML_int[2][4]
+ B=n123
Xsll_18/M1_2_5 MUX2 $PINS O=sll_18/ML_int[3][5] S=FE_RN_3 A=sll_18/ML_int[2][5]
+ B=n124
Xsll_18/M1_2_6 MUX2 $PINS O=sll_18/ML_int[3][6] S=FE_RN_3 A=sll_18/ML_int[2][6]
+ B=sll_18/ML_int[2][2]
Xsll_18/M1_2_7 MUX2 $PINS O=sll_18/ML_int[3][7] S=FE_RN_3 A=sll_18/ML_int[2][7]
+ B=sll_18/ML_int[2][3]
Xsll_18/M1_2_8 MUX2 $PINS O=sll_18/ML_int[3][8] S=FE_RN_3 A=sll_18/ML_int[2][8]
+ B=sll_18/ML_int[2][4]
Xsll_18/M1_2_9 MUX2 $PINS O=sll_18/ML_int[3][9] S=FE_RN_3 A=sll_18/ML_int[2][9]
+ B=sll_18/ML_int[2][5]
Xsll_18/M1_2_19 MUX2 $PINS O=sll_18/ML_int[3][19] S=FE_OFN60_h23_2 A=n2
+ B=sll_18/ML_int[2][15]
Xsll_18/M1_3_8 MUX2 $PINS O=term3_shifted[8] S=shf3[3] A=sll_18/ML_int[3][8]
+ B=sll_18/ML_int[3][0]
Xsll_18/M1_3_9 MUX2 $PINS O=term3_shifted[9] S=shf3[3] A=sll_18/ML_int[3][9]
+ B=sll_18/ML_int[3][1]
Xsll_18/M1_3_10 MUX2 $PINS O=term3_shifted[10] S=shf3[3] A=sll_18/ML_int[3][10]
+ B=sll_18/ML_int[3][2]
Xsll_18/M1_3_11 MUX2 $PINS O=term3_shifted[11] S=shf3[3] A=sll_18/ML_int[3][11]
+ B=sll_18/ML_int[3][3]
Xsll_18/M1_3_12 MUX2 $PINS O=term3_shifted[12] S=shf3[3] A=sll_18/ML_int[3][12]
+ B=sll_18/ML_int[3][4]
Xsll_18/M1_3_13 MUX2 $PINS O=term3_shifted[13] S=shf3[3] A=sll_18/ML_int[3][13]
+ B=sll_18/ML_int[3][5]
Xsll_18/M1_3_15 MUX2 $PINS O=term3_shifted[15] S=shf3[3] A=sll_18/ML_int[3][15]
+ B=sll_18/ML_int[3][7]
Xsll_18/M1_3_23 MUX2 $PINS O=term3_shifted[23] S=shf3[3] A=n2
+ B=sll_18/ML_int[3][15]
Xsll_17/M1_1_2 MUX2 $PINS O=sll_17/ML_int[2][2] S=shf2[1] A=sll_17/ML_int[1][2]
+ B=sll_17/ML_int[1][0]
Xsll_17/M1_1_3 MUX2 $PINS O=sll_17/ML_int[2][3] S=shf2[1] A=sll_17/ML_int[1][3]
+ B=sll_17/ML_int[1][1]
Xsll_17/M1_1_4 MUX2 $PINS O=sll_17/ML_int[2][4] S=shf2[1] A=sll_17/ML_int[1][4]
+ B=sll_17/ML_int[1][2]
Xsll_17/M1_1_5 MUX2 $PINS O=sll_17/ML_int[2][5] S=shf2[1] A=sll_17/ML_int[1][5]
+ B=sll_17/ML_int[1][3]
Xsll_17/M1_1_6 MUX2 $PINS O=sll_17/ML_int[2][6] S=shf2[1] A=sll_17/ML_int[1][6]
+ B=sll_17/ML_int[1][4]
Xsll_17/M1_1_7 MUX2 $PINS O=sll_17/ML_int[2][7] S=shf2[1] A=sll_17/ML_int[1][7]
+ B=sll_17/ML_int[1][5]
Xsll_17/M1_2_5 MUX2 $PINS O=sll_17/ML_int[3][5] S=FE_OFN330_n42
+ A=sll_17/ML_int[2][5] B=n113
Xsll_17/M1_2_8 MUX2 $PINS O=sll_17/ML_int[3][8] S=FE_OFN330_n42
+ A=sll_17/ML_int[2][8] B=sll_17/ML_int[2][4]
Xsll_17/M1_2_9 MUX2 $PINS O=sll_17/ML_int[3][9] S=FE_OFN330_n42
+ A=sll_17/ML_int[2][9] B=sll_17/ML_int[2][5]
Xsll_17/M1_2_19 MUX2 $PINS O=sll_17/ML_int[3][19] S=FE_OFN58_h22_2 A=n3
+ B=sll_17/ML_int[2][15]
Xsll_17/M1_3_8 MUX2 $PINS O=term2_shifted[8] S=FE_OFN57_h22_3
+ A=sll_17/ML_int[3][8] B=sll_17/ML_int[3][0]
Xsll_17/M1_3_9 MUX2 $PINS O=term2_shifted[9] S=FE_OFN57_h22_3
+ A=sll_17/ML_int[3][9] B=sll_17/ML_int[3][1]
Xsll_17/M1_3_10 MUX2 $PINS O=term2_shifted[10] S=FE_OFN57_h22_3
+ A=sll_17/ML_int[3][10] B=sll_17/ML_int[3][2]
Xsll_17/M1_3_11 MUX2 $PINS O=term2_shifted[11] S=FE_OFN57_h22_3
+ A=sll_17/ML_int[3][11] B=sll_17/ML_int[3][3]
Xsll_17/M1_3_12 MUX2 $PINS O=term2_shifted[12] S=FE_OFN57_h22_3
+ A=sll_17/ML_int[3][12] B=sll_17/ML_int[3][4]
Xsll_17/M1_3_13 MUX2 $PINS O=term2_shifted[13] S=FE_OFN57_h22_3
+ A=sll_17/ML_int[3][13] B=sll_17/ML_int[3][5]
Xsll_17/M1_3_23 MUX2 $PINS O=term2_shifted[23] S=FE_OFN57_h22_3 A=n3
+ B=sll_17/ML_int[3][15]
Xsll_16/M1_0_3 MUX2 $PINS O=sll_16/ML_int[1][3] S=FE_OFN259_h21_0 A=term1_in[3]
+ B=term1_in[2]
Xsll_16/M1_0_4 MUX2 $PINS O=sll_16/ML_int[1][4] S=FE_OFN259_h21_0 A=term1_in[4]
+ B=term1_in[3]
Xsll_16/M1_0_5 MUX2 $PINS O=sll_16/ML_int[1][5] S=FE_OFN259_h21_0 A=term1_in[5]
+ B=term1_in[4]
Xsll_16/M1_0_6 MUX2 $PINS O=sll_16/ML_int[1][6] S=FE_OFN259_h21_0 A=term1_in[6]
+ B=term1_in[5]
Xsll_16/M1_0_7 MUX2 $PINS O=sll_16/ML_int[1][7] S=FE_OFN259_h21_0 A=term1_in[7]
+ B=term1_in[6]
Xsll_16/M1_0_8 MUX2 $PINS O=sll_16/ML_int[1][8] S=FE_OFN259_h21_0 A=term1_in[8]
+ B=term1_in[7]
Xsll_16/M1_1_4 MUX2 $PINS O=sll_16/ML_int[2][4] S=FE_OFN191_h21_1
+ A=sll_16/ML_int[1][4] B=sll_16/ML_int[1][2]
Xsll_16/M1_1_5 MUX2 $PINS O=sll_16/ML_int[2][5] S=FE_OFN191_h21_1
+ A=sll_16/ML_int[1][5] B=sll_16/ML_int[1][3]
Xsll_16/M1_1_6 MUX2 $PINS O=sll_16/ML_int[2][6] S=FE_OFN191_h21_1
+ A=sll_16/ML_int[1][6] B=sll_16/ML_int[1][4]
Xsll_16/M1_1_7 MUX2 $PINS O=sll_16/ML_int[2][7] S=FE_OFN191_h21_1
+ A=sll_16/ML_int[1][7] B=sll_16/ML_int[1][5]
Xsll_16/M1_1_8 MUX2 $PINS O=sll_16/ML_int[2][8] S=FE_OFN191_h21_1
+ A=sll_16/ML_int[1][8] B=sll_16/ML_int[1][6]
Xsll_16/M1_1_9 MUX2 $PINS O=sll_16/ML_int[2][9] S=FE_OFN191_h21_1
+ A=sll_16/ML_int[1][9] B=sll_16/ML_int[1][7]
Xsll_16/M1_2_5 MUX2 $PINS O=sll_16/ML_int[3][5] S=n72 A=sll_16/ML_int[2][5]
+ B=n102
Xsll_16/M1_2_7 MUX2 $PINS O=sll_16/ML_int[3][7] S=n72 A=sll_16/ML_int[2][7]
+ B=sll_16/ML_int[2][3]
Xsll_16/M1_2_8 MUX2 $PINS O=sll_16/ML_int[3][8] S=n72 A=sll_16/ML_int[2][8]
+ B=sll_16/ML_int[2][4]
Xsll_16/M1_2_9 MUX2 $PINS O=sll_16/ML_int[3][9] S=n72 A=sll_16/ML_int[2][9]
+ B=sll_16/ML_int[2][5]
Xsll_16/M1_2_11 MUX2 $PINS O=sll_16/ML_int[3][11] S=n72 A=sll_16/ML_int[2][11]
+ B=sll_16/ML_int[2][7]
Xsll_16/M1_2_19 MUX2 $PINS O=sll_16/ML_int[3][19] S=n72 A=n1
+ B=sll_16/ML_int[2][15]
Xsll_16/M1_3_8 MUX2 $PINS O=term1_shifted[8] S=n75 A=sll_16/ML_int[3][8]
+ B=sll_16/ML_int[3][0]
Xsll_16/M1_3_9 MUX2 $PINS O=term1_shifted[9] S=n75 A=sll_16/ML_int[3][9]
+ B=sll_16/ML_int[3][1]
Xsll_16/M1_3_10 MUX2 $PINS O=term1_shifted[10] S=n75 A=sll_16/ML_int[3][10]
+ B=sll_16/ML_int[3][2]
Xsll_16/M1_3_11 MUX2 $PINS O=term1_shifted[11] S=n75 A=sll_16/ML_int[3][11]
+ B=sll_16/ML_int[3][3]
Xsll_16/M1_3_12 MUX2 $PINS O=term1_shifted[12] S=n75 A=sll_16/ML_int[3][12]
+ B=sll_16/ML_int[3][4]
Xsll_16/M1_3_13 MUX2 $PINS O=term1_shifted[13] S=n75 A=sll_16/ML_int[3][13]
+ B=sll_16/ML_int[3][5]
Xsll_16/M1_3_15 MUX2 $PINS O=term1_shifted[15] S=n75 A=sll_16/ML_int[3][15]
+ B=sll_16/ML_int[3][7]
Xsll_16/M1_3_23 MUX2 $PINS O=term1_shifted[23] S=FE_RN_5 A=n1
+ B=sll_16/ML_int[3][15]
Xacc_reg_reg[26] QDFFRBN $PINS Q=N251 D=next_acc[26] CK=clk RB=i_rst_n
Xacc_reg_reg[25] QDFFRBN $PINS Q=acc_reg[25] D=next_acc[25] CK=clk RB=i_rst_n
Xacc_reg_reg[24] QDFFRBN $PINS Q=acc_reg[24] D=next_acc[24] CK=clk RB=i_rst_n
Xacc_reg_reg[23] QDFFRBN $PINS Q=acc_reg[23] D=next_acc[23] CK=clk
+ RB=FE_OFN13_i_rst_n
Xacc_reg_reg[22] QDFFRBN $PINS Q=acc_reg[22] D=next_acc[22] CK=clk
+ RB=FE_OFN13_i_rst_n
Xacc_reg_reg[21] QDFFRBN $PINS Q=acc_reg[21] D=next_acc[21] CK=clk
+ RB=FE_OFN13_i_rst_n
Xacc_reg_reg[20] QDFFRBN $PINS Q=acc_reg[20] D=next_acc[20] CK=clk_clone2
+ RB=FE_OFN13_i_rst_n
Xacc_reg_reg[19] QDFFRBN $PINS Q=acc_reg[19] D=next_acc[19] CK=clk_clone2
+ RB=FE_OFN13_i_rst_n
Xacc_reg_reg[18] QDFFRBN $PINS Q=acc_reg[18] D=next_acc[18] CK=clk_clone2
+ RB=FE_OFN13_i_rst_n
Xacc_reg_reg[17] QDFFRBN $PINS Q=acc_reg[17] D=next_acc[17] CK=clk_clone2
+ RB=FE_OFN13_i_rst_n
Xacc_reg_reg[16] QDFFRBN $PINS Q=acc_reg[16] D=next_acc[16] CK=clk_clone2
+ RB=FE_OFN13_i_rst_n
Xacc_reg_reg[15] QDFFRBN $PINS Q=acc_reg[15] D=next_acc[15] CK=clk_clone2
+ RB=FE_OFN13_i_rst_n
Xacc_reg_reg[14] QDFFRBN $PINS Q=acc_reg[14] D=next_acc[14] CK=clk_clone2
+ RB=FE_OFN13_i_rst_n
Xacc_reg_reg[13] QDFFRBN $PINS Q=acc_reg[13] D=next_acc[13] CK=clk_clone2
+ RB=FE_OFN7_i_rst_n
Xacc_reg_reg[12] QDFFRBN $PINS Q=acc_reg[12] D=next_acc[12] CK=clk_clone3
+ RB=FE_OFN7_i_rst_n
Xacc_reg_reg[11] QDFFRBN $PINS Q=acc_reg[11] D=next_acc[11] CK=clk_clone3
+ RB=FE_OFN7_i_rst_n
Xacc_reg_reg[10] QDFFRBN $PINS Q=acc_reg[10] D=next_acc[10] CK=clk_clone3
+ RB=FE_OFN7_i_rst_n
Xacc_reg_reg[9] QDFFRBN $PINS Q=acc_reg[9] D=next_acc[9] CK=clk_clone2
+ RB=FE_OFN7_i_rst_n
Xacc_reg_reg[8] QDFFRBN $PINS Q=acc_reg[8] D=next_acc[8] CK=clk_clone2
+ RB=FE_OFN7_i_rst_n
Xacc_reg_reg[7] QDFFRBN $PINS Q=acc_reg[7] D=next_acc[7] CK=clk_clone2
+ RB=FE_OFN7_i_rst_n
Xacc_reg_reg[6] QDFFRBN $PINS Q=acc_reg[6] D=next_acc[6] CK=clk_clone2
+ RB=FE_OFN16_i_rst_n
Xacc_reg_reg[5] QDFFRBN $PINS Q=acc_reg[5] D=next_acc[5] CK=clk_clone2
+ RB=FE_OFN16_i_rst_n
Xacc_reg_reg[4] QDFFRBN $PINS Q=acc_reg[4] D=next_acc[4] CK=clk_clone2
+ RB=FE_OFN16_i_rst_n
Xacc_reg_reg[3] QDFFRBN $PINS Q=acc_reg[3] D=next_acc[3] CK=clk_clone2
+ RB=FE_OFN16_i_rst_n
Xacc_reg_reg[2] QDFFRBN $PINS Q=acc_reg[2] D=next_acc[2] CK=clk_clone2
+ RB=FE_OFN16_i_rst_n
Xacc_reg_reg[0] QDFFRBN $PINS Q=acc_reg[0] D=FE_PHN1314_next_acc_0
+ CK=clk_clone2 RB=FE_OFN16_i_rst_n
Xacc_reg_reg[1] QDFFRBN $PINS Q=acc_reg[1] D=next_acc[1] CK=clk_clone2
+ RB=FE_OFN16_i_rst_n
Xy_out_reg[16] QDFFRBN $PINS Q=y_out[16] D=FE_PHN776_N251 CK=CTS_10
+ RB=FE_OFN13_i_rst_n
Xy_out_reg[15] QDFFRBN $PINS Q=y_out[15] D=FE_PHN1247_N250 CK=CTS_10
+ RB=FE_OFN13_i_rst_n
Xy_out_reg[14] QDFFRBN $PINS Q=y_out[14] D=FE_PHN1230_N249 CK=CTS_10
+ RB=FE_OFN13_i_rst_n
Xy_out_reg[13] QDFFRBN $PINS Q=y_out[13] D=FE_PHN1186_N248 CK=CTS_10
+ RB=FE_OFN13_i_rst_n
Xy_out_reg[12] QDFFRBN $PINS Q=y_out[12] D=N247 CK=CTS_10 RB=FE_OFN13_i_rst_n
Xy_out_reg[11] QDFFRBN $PINS Q=y_out[11] D=FE_PHN1196_N246 CK=CTS_10
+ RB=FE_OFN13_i_rst_n
Xy_out_reg[10] QDFFRBN $PINS Q=FE_PHN735_pe_r2_10 D=FE_PHN1207_N245 CK=CTS_10
+ RB=i_rst_n
Xy_out_reg[9] QDFFRBN $PINS Q=FE_PHN739_pe_r2_9 D=N244 CK=CTS_10
+ RB=FE_OFN13_i_rst_n
Xy_out_reg[8] QDFFRBN $PINS Q=y_out[8] D=FE_PHN1219_N243 CK=CTS_10
+ RB=FE_OFN13_i_rst_n
Xy_out_reg[7] QDFFRBN $PINS Q=FE_PHN734_pe_r2_7 D=N242 CK=CTS_10 RB=i_rst_n
Xy_out_reg[6] QDFFRBN $PINS Q=FE_PHN738_pe_r2_6 D=FE_PHN1224_N241 CK=CTS_10
+ RB=FE_OFN13_i_rst_n
Xy_out_reg[5] QDFFRBN $PINS Q=y_out[5] D=FE_PHN1221_N240 CK=CTS_10
+ RB=FE_OFN13_i_rst_n
Xy_out_reg[4] QDFFRBN $PINS Q=FE_PHN732_pe_r2_4 D=FE_PHN1252_N239 CK=CTS_10
+ RB=FE_OFN13_i_rst_n
Xy_out_reg[3] QDFFRBN $PINS Q=FE_PHN729_pe_r2_3 D=FE_PHN1248_N238 CK=CTS_10
+ RB=FE_OFN13_i_rst_n
Xy_out_reg[2] QDFFRBN $PINS Q=FE_PHN731_pe_r2_2 D=FE_PHN1246_N237 CK=CTS_10
+ RB=FE_OFN13_i_rst_n
Xy_out_reg[1] QDFFRBN $PINS Q=FE_PHN730_pe_r2_1 D=FE_PHN1253_N236 CK=CTS_10
+ RB=FE_OFN13_i_rst_n
Xy_out_reg[0] QDFFRBN $PINS Q=y_out[0] D=FE_PHN1283_N235 CK=CTS_10
+ RB=FE_OFN13_i_rst_n
XU12 NR2 $PINS O=term3_in[1] I1=FE_OFN242_s23_1 I2=n145
XU19 NR2 $PINS O=term2_in[3] I1=sign2[1] I2=x_in[3]
XU20 NR2 $PINS O=term2_in[4] I1=sign2[1] I2=x_in[4]
XU21 MUX2 $PINS O=sll_17/ML_int[1][1] S=n35 A=term2_in[0] B=term2_in[1]
XU24 NR2P $PINS O=term1_shifted[0] I1=n98 I2=n96
XU25 MUX2 $PINS O=N248 S=FE_OFN3_FE_DBTN15_n64 A=acc_reg[23] B=FE_PHN776_N251
XU26 NR2 $PINS O=term1_in[3] I1=sign1[1] I2=x_in[3]
XU28 MUX2S $PINS O=sll_17/ML_int[3][7] S=FE_OFN205_h22_2 A=sll_17/ML_int[2][3]
+ B=sll_17/ML_int[2][7]
XU29 MUX2 $PINS O=N249 S=FE_OFN3_FE_DBTN15_n64 A=acc_reg[24] B=FE_PHN776_N251
XU30 ND3P $PINS O=n118 I1=term3_in[0] I2=n9 I3=FE_OFN94_h23_1
XU31 ND3 $PINS O=n96 I1=term1_in[0] I2=FE_OFN91_h21_1 I3=n64
XU34 MUX2 $PINS O=N250 S=FE_OFN3_FE_DBTN15_n64 A=acc_reg[25] B=FE_PHN776_N251
XU37 ND2P $PINS O=n97 I1=sll_16/ML_int[1][1] I2=FE_OFN91_h21_1
XU39 AO22S $PINS O=N122 A1=N95 A2=FE_OFN327_s22_0 B1=term2_shifted[26]
+ B2=FE_RN_6
XU40 AO22S $PINS O=N121 A1=N94 A2=FE_OFN327_s22_0 B1=term2_shifted[25]
+ B2=FE_RN_6
XU41 AO22S $PINS O=N120 A1=N93 A2=FE_OFN327_s22_0 B1=term2_shifted[24]
+ B2=FE_RN_6
XU42 AO22S $PINS O=N119 A1=N92 A2=FE_OFN327_s22_0 B1=term2_shifted[23]
+ B2=FE_RN_6
XU43 AO22S $PINS O=N118 A1=N91 A2=FE_OFN327_s22_0 B1=term2_shifted[22]
+ B2=FE_RN_6
XU44 AO22S $PINS O=N117 A1=N90 A2=FE_OFN327_s22_0 B1=term2_shifted[21]
+ B2=FE_RN_6
XU45 AO22S $PINS O=N116 A1=N89 A2=FE_OFN327_s22_0 B1=term2_shifted[20]
+ B2=FE_RN_6
XU48 AN2 $PINS O=sll_18/ML_int[1][0] I1=n9 I2=term3_in[0]
XU51 NR2P $PINS O=term1_shifted[1] I1=n98 I2=n97
XU53 AO22 $PINS O=N54 A1=N27 A2=FE_RN_1 B1=term1_shifted[13] B2=n83
XU56 AO22 $PINS O=N52 A1=N25 A2=FE_RN_1 B1=term1_shifted[11] B2=n83
XU57 AO22 $PINS O=N56 A1=N29 A2=FE_RN_1 B1=term1_shifted[15] B2=n83
XU58 AO22 $PINS O=N60 A1=N33 A2=sign1[0] B1=term1_shifted[19] B2=n83
XU59 AO22 $PINS O=N57 A1=N30 A2=sign1[0] B1=term1_shifted[16] B2=n83
XU61 AO22 $PINS O=N51 A1=N24 A2=FE_RN_1 B1=term1_shifted[10] B2=n83
XU62 AO22 $PINS O=N55 A1=N28 A2=FE_RN_1 B1=term1_shifted[14] B2=n83
XU63 AO22 $PINS O=N59 A1=N32 A2=sign1[0] B1=term1_shifted[18] B2=n83
XU64 AO22 $PINS O=N64 A1=N37 A2=sign1[0] B1=term1_shifted[23] B2=n83
XU65 AO22 $PINS O=N174 A1=N147 A2=n28 B1=term3_shifted[23] B2=FE_OFN323_s23_0
XU70 AN2 $PINS O=sll_16/ML_int[1][0] I1=term1_in[0] I2=n64
XU71 MUX2 $PINS O=sll_16/ML_int[1][1] S=FE_OFN259_h21_0 A=term1_in[1]
+ B=term1_in[0]
XU81 AO22 $PINS O=N50 A1=N23 A2=FE_RN_1 B1=term1_shifted[9] B2=n83
XU82 AO22 $PINS O=N53 A1=N26 A2=FE_RN_1 B1=term1_shifted[12] B2=n83
XU83 AO22 $PINS O=N109 A1=N82 A2=n57 B1=term2_shifted[13] B2=FE_OFN324_s22_0
XU84 AO22 $PINS O=N58 A1=N31 A2=sign1[0] B1=term1_shifted[17] B2=n83
XU85 AO22 $PINS O=N65 A1=N38 A2=sign1[0] B1=term1_shifted[24] B2=n83
XU86 AO22 $PINS O=N175 A1=N148 A2=n28 B1=term3_shifted[24] B2=FE_OFN323_s23_0
XU93 NR2P $PINS O=term3_shifted[3] I1=n120 I2=n121
XU99 MUX2 $PINS O=sll_17/ML_int[3][6] S=FE_OFN330_n42 A=sll_17/ML_int[2][6]
+ B=sll_17/ML_int[2][2]
XU101 MUX2 $PINS O=sll_17/ML_int[1][3] S=shf2[0] A=term2_in[3] B=term2_in[2]
XU103 AO22 $PINS O=N61 A1=N34 A2=sign1[0] B1=term1_shifted[20] B2=n83
XU104 AO22 $PINS O=N62 A1=N35 A2=sign1[0] B1=term1_shifted[21] B2=n83
XU105 NR2 $PINS O=term3_in[2] I1=FE_OFN242_s23_1 I2=x_in[2]
XU116 NR2 $PINS O=n1 I1=n136 I2=sign1[1]
XU117 MUX2S $PINS O=n106 S=shf1[0] A=term1_in[26] B=term1_in[15]
XU118 MUX2S $PINS O=n105 S=FE_OFN91_h21_1 A=n106 B=term1_in[26]
XU119 NR2 $PINS O=n2 I1=n136 I2=FE_OFN84_s23_1
XU120 MUX2S $PINS O=n128 S=shf3[0] A=term3_in[26] B=term3_in[15]
XU121 NR2 $PINS O=n3 I1=n136 I2=sign2[1]
XU122 MUX2S $PINS O=n117 S=shf2[0] A=term2_in[26] B=term2_in[15]
XU124 AO22 $PINS O=N49 A1=N22 A2=FE_RN_1 B1=term1_shifted[8] B2=n83
XU125 AN2 $PINS O=term3_shifted[7] I1=sll_18/ML_int[3][7] I2=n21
XU128 MUX2S $PINS O=sll_17/ML_int[2][8] S=shf2[1] A=sll_17/ML_int[1][8]
+ B=sll_17/ML_int[1][6]
XU129 MUX2S $PINS O=sll_17/ML_int[1][8] S=shf2[0] A=term2_in[8] B=term2_in[7]
XU130 MUX2S $PINS O=sll_18/ML_int[2][8] S=FE_OFN186_h23_1 A=sll_18/ML_int[1][8]
+ B=sll_18/ML_int[1][6]
XU131 MUX2S $PINS O=sll_18/ML_int[1][8] S=shf3[0] A=term3_in[8] B=term3_in[7]
XU132 MUX2S $PINS O=sll_16/ML_int[1][9] S=FE_OFN259_h21_0 A=term1_in[9]
+ B=term1_in[8]
XU133 MUX2S $PINS O=sll_17/ML_int[2][9] S=shf2[1] A=sll_17/ML_int[1][9]
+ B=sll_17/ML_int[1][7]
XU137 MUX2S $PINS O=sll_17/ML_int[1][9] S=shf2[0] A=term2_in[9] B=term2_in[8]
XU138 MUX2S $PINS O=sll_18/ML_int[2][9] S=FE_OFN186_h23_1 A=sll_18/ML_int[1][9]
+ B=sll_18/ML_int[1][7]
XU139 MUX2S $PINS O=sll_18/ML_int[1][9] S=shf3[0] A=term3_in[9] B=term3_in[8]
XU140 MUX2S $PINS O=sll_16/ML_int[2][10] S=FE_OFN191_h21_1
+ A=sll_16/ML_int[1][10] B=sll_16/ML_int[1][8]
XU144 MUX2S $PINS O=sll_16/ML_int[1][10] S=FE_OFN259_h21_0 A=term1_in[10]
+ B=term1_in[9]
XU145 MUX2S $PINS O=sll_16/ML_int[3][10] S=n72 A=sll_16/ML_int[2][10]
+ B=sll_16/ML_int[2][6]
XU164 MUX2S $PINS O=sll_18/ML_int[2][10] S=FE_OFN186_h23_1
+ A=sll_18/ML_int[1][10] B=sll_18/ML_int[1][8]
XU165 MUX2S $PINS O=sll_18/ML_int[1][10] S=shf3[0] A=term3_in[10] B=term3_in[9]
XU166 MUX2S $PINS O=sll_18/ML_int[3][10] S=FE_RN_3 A=sll_18/ML_int[2][10]
+ B=sll_18/ML_int[2][6]
XU167 MUX2S $PINS O=sll_17/ML_int[2][10] S=shf2[1] A=sll_17/ML_int[1][10]
+ B=sll_17/ML_int[1][8]
XU169 MUX2S $PINS O=sll_17/ML_int[3][10] S=FE_OFN330_n42 A=sll_17/ML_int[2][10]
+ B=sll_17/ML_int[2][6]
XU170 MUX2S $PINS O=sll_17/ML_int[1][10] S=shf2[0] A=term2_in[10] B=term2_in[9]
XU171 MUX2S $PINS O=sll_16/ML_int[2][11] S=FE_OFN191_h21_1
+ A=sll_16/ML_int[1][11] B=sll_16/ML_int[1][9]
XU172 MUX2S $PINS O=sll_16/ML_int[1][11] S=FE_OFN259_h21_0 A=term1_in[11]
+ B=term1_in[10]
XU173 MUX2S $PINS O=sll_18/ML_int[2][11] S=FE_OFN186_h23_1
+ A=sll_18/ML_int[1][11] B=sll_18/ML_int[1][9]
XU174 MUX2S $PINS O=sll_18/ML_int[3][11] S=FE_RN_3 A=sll_18/ML_int[2][11]
+ B=sll_18/ML_int[2][7]
XU175 MUX2S $PINS O=sll_18/ML_int[1][11] S=shf3[0] A=term3_in[11]
+ B=term3_in[10]
XU182 MUX2S $PINS O=sll_17/ML_int[2][11] S=shf2[1] A=sll_17/ML_int[1][11]
+ B=sll_17/ML_int[1][9]
XU192 MUX2S $PINS O=sll_17/ML_int[3][11] S=FE_OFN330_n42 A=sll_17/ML_int[2][11]
+ B=sll_17/ML_int[2][7]
XU193 MUX2S $PINS O=sll_17/ML_int[1][11] S=shf2[0] A=term2_in[11]
+ B=term2_in[10]
XU194 AO22 $PINS O=N63 A1=N36 A2=sign1[0] B1=term1_shifted[22] B2=n83
XU195 AO22S $PINS O=N66 A1=N39 A2=sign1[0] B1=term1_shifted[25] B2=n83
XU196 MUX2S $PINS O=sll_16/ML_int[2][12] S=FE_OFN191_h21_1
+ A=sll_16/ML_int[1][12] B=sll_16/ML_int[1][10]
XU197 MUX2S $PINS O=sll_16/ML_int[3][12] S=n72 A=sll_16/ML_int[2][12]
+ B=sll_16/ML_int[2][8]
XU198 MUX2S $PINS O=sll_16/ML_int[1][12] S=FE_OFN259_h21_0 A=term1_in[12]
+ B=term1_in[11]
XU199 MUX2S $PINS O=sll_18/ML_int[2][12] S=FE_OFN186_h23_1
+ A=sll_18/ML_int[1][12] B=sll_18/ML_int[1][10]
XU200 MUX2S $PINS O=sll_18/ML_int[3][12] S=FE_RN_3 A=sll_18/ML_int[2][12]
+ B=sll_18/ML_int[2][8]
XU201 MUX2S $PINS O=sll_18/ML_int[1][12] S=shf3[0] A=term3_in[12]
+ B=term3_in[11]
XU202 MUX2S $PINS O=sll_17/ML_int[2][12] S=shf2[1] A=sll_17/ML_int[1][12]
+ B=sll_17/ML_int[1][10]
XU203 MUX2S $PINS O=sll_17/ML_int[3][12] S=FE_OFN330_n42 A=sll_17/ML_int[2][12]
+ B=sll_17/ML_int[2][8]
XU204 MUX2S $PINS O=sll_17/ML_int[1][12] S=shf2[0] A=term2_in[12]
+ B=term2_in[11]
XU205 MUX2S $PINS O=sll_16/ML_int[2][13] S=FE_OFN191_h21_1
+ A=sll_16/ML_int[1][13] B=sll_16/ML_int[1][11]
XU206 MUX2S $PINS O=sll_16/ML_int[3][13] S=n72 A=sll_16/ML_int[2][13]
+ B=sll_16/ML_int[2][9]
XU207 MUX2S $PINS O=sll_16/ML_int[1][13] S=FE_OFN259_h21_0 A=term1_in[13]
+ B=term1_in[12]
XU208 MUX2S $PINS O=sll_18/ML_int[2][13] S=FE_OFN186_h23_1
+ A=sll_18/ML_int[1][13] B=sll_18/ML_int[1][11]
XU209 MUX2S $PINS O=sll_18/ML_int[3][13] S=FE_RN_3 A=sll_18/ML_int[2][13]
+ B=sll_18/ML_int[2][9]
XU210 MUX2S $PINS O=sll_18/ML_int[1][13] S=shf3[0] A=term3_in[13]
+ B=term3_in[12]
XU211 MUX2S $PINS O=sll_17/ML_int[2][13] S=shf2[1] A=sll_17/ML_int[1][13]
+ B=sll_17/ML_int[1][11]
XU212 MUX2S $PINS O=sll_17/ML_int[3][13] S=FE_OFN330_n42 A=sll_17/ML_int[2][13]
+ B=sll_17/ML_int[2][9]
XU213 MUX2S $PINS O=sll_17/ML_int[1][13] S=shf2[0] A=term2_in[13]
+ B=term2_in[12]
XU214 MUX2S $PINS O=term1_shifted[14] S=n75 A=sll_16/ML_int[3][14]
+ B=sll_16/ML_int[3][6]
XU215 MUX2S $PINS O=sll_16/ML_int[2][14] S=FE_OFN191_h21_1
+ A=sll_16/ML_int[1][14] B=sll_16/ML_int[1][12]
XU216 MUX2S $PINS O=sll_16/ML_int[3][14] S=n72 A=sll_16/ML_int[2][14]
+ B=sll_16/ML_int[2][10]
XU217 MUX2S $PINS O=sll_16/ML_int[1][14] S=FE_OFN259_h21_0 A=term1_in[14]
+ B=term1_in[13]
XU218 MUX2S $PINS O=term3_shifted[14] S=shf3[3] A=sll_18/ML_int[3][14]
+ B=sll_18/ML_int[3][6]
XU219 MUX2S $PINS O=sll_18/ML_int[2][14] S=FE_OFN186_h23_1
+ A=sll_18/ML_int[1][14] B=sll_18/ML_int[1][12]
XU220 MUX2S $PINS O=sll_18/ML_int[3][14] S=FE_RN_3 A=sll_18/ML_int[2][14]
+ B=sll_18/ML_int[2][10]
XU221 MUX2S $PINS O=sll_18/ML_int[1][14] S=shf3[0] A=term3_in[14]
+ B=term3_in[13]
XU222 MUX2S $PINS O=term2_shifted[14] S=FE_OFN57_h22_3 A=sll_17/ML_int[3][14]
+ B=sll_17/ML_int[3][6]
XU223 MUX2S $PINS O=sll_17/ML_int[3][14] S=shf2[2] A=sll_17/ML_int[2][14]
+ B=sll_17/ML_int[2][10]
XU224 MUX2 $PINS O=sll_17/ML_int[2][14] S=shf2[1] A=sll_17/ML_int[1][14]
+ B=sll_17/ML_int[1][12]
XU225 MUX2S $PINS O=sll_17/ML_int[1][14] S=shf2[0] A=term2_in[14]
+ B=term2_in[13]
XU226 MUX2S $PINS O=term1_shifted[16] S=n75 A=sll_16/ML_int[3][16]
+ B=sll_16/ML_int[3][8]
XU227 MUX2S $PINS O=n103 S=FE_OFN191_h21_1 A=n106 B=sll_16/ML_int[1][14]
XU228 MUX2S $PINS O=term3_shifted[16] S=shf3[3] A=sll_18/ML_int[3][16]
+ B=sll_18/ML_int[3][8]
XU229 MUX2S $PINS O=n125 S=FE_OFN186_h23_1 A=n128 B=sll_18/ML_int[1][14]
XU230 MUX2S $PINS O=sll_16/ML_int[3][15] S=n72 A=sll_16/ML_int[2][15]
+ B=sll_16/ML_int[2][11]
XU231 MUX2S $PINS O=sll_16/ML_int[2][15] S=FE_OFN191_h21_1
+ A=sll_16/ML_int[1][15] B=sll_16/ML_int[1][13]
XU232 MUX2S $PINS O=sll_16/ML_int[1][15] S=FE_OFN259_h21_0 A=term1_in[15]
+ B=term1_in[14]
XU233 MUX2S $PINS O=term2_shifted[16] S=FE_OFN57_h22_3 A=sll_17/ML_int[3][16]
+ B=sll_17/ML_int[3][8]
XU234 MUX2S $PINS O=n114 S=shf2[1] A=n117 B=sll_17/ML_int[1][14]
XU235 MUX2S $PINS O=sll_18/ML_int[3][15] S=FE_RN_3 A=sll_18/ML_int[2][15]
+ B=sll_18/ML_int[2][11]
XU236 MUX2S $PINS O=sll_18/ML_int[2][15] S=FE_OFN186_h23_1
+ A=sll_18/ML_int[1][15] B=sll_18/ML_int[1][13]
XU237 MUX2S $PINS O=sll_18/ML_int[1][15] S=shf3[0] A=term3_in[15]
+ B=term3_in[14]
XU238 MUX2S $PINS O=term2_shifted[15] S=FE_OFN57_h22_3 A=sll_17/ML_int[3][15]
+ B=sll_17/ML_int[3][7]
XU239 MUX2S $PINS O=sll_17/ML_int[3][15] S=FE_OFN330_n42 A=sll_17/ML_int[2][15]
+ B=sll_17/ML_int[2][11]
XU240 MUX2S $PINS O=sll_17/ML_int[2][15] S=shf2[1] A=sll_17/ML_int[1][15]
+ B=sll_17/ML_int[1][13]
XU241 MUX2S $PINS O=sll_17/ML_int[1][15] S=shf2[0] A=term2_in[15]
+ B=term2_in[14]
XU242 MUX2S $PINS O=term1_shifted[17] S=FE_RN_5 A=sll_16/ML_int[3][17]
+ B=sll_16/ML_int[3][9]
XU243 MUX2S $PINS O=term3_shifted[17] S=shf3[3] A=sll_18/ML_int[3][17]
+ B=sll_18/ML_int[3][9]
XU244 MUX2S $PINS O=term2_shifted[17] S=FE_OFN57_h22_3 A=sll_17/ML_int[3][17]
+ B=sll_17/ML_int[3][9]
XU245 MUX2S $PINS O=term1_shifted[18] S=FE_RN_5 A=sll_16/ML_int[3][18]
+ B=sll_16/ML_int[3][10]
XU246 MUX2S $PINS O=term3_shifted[18] S=shf3[3] A=sll_18/ML_int[3][18]
+ B=sll_18/ML_int[3][10]
XU247 MUX2S $PINS O=term2_shifted[18] S=shf2[3] A=sll_17/ML_int[3][18]
+ B=sll_17/ML_int[3][10]
XU250 MUX2S $PINS O=sll_16/ML_int[3][16] S=n72 A=n103 B=sll_16/ML_int[2][12]
XU251 MUX2S $PINS O=sll_18/ML_int[3][16] S=FE_RN_3 A=n125
+ B=sll_18/ML_int[2][12]
XU252 MUX2S $PINS O=sll_17/ML_int[3][16] S=shf2[2] A=n114
+ B=sll_17/ML_int[2][12]
XU253 MUX2S $PINS O=n104 S=FE_OFN191_h21_1 A=n1 B=sll_16/ML_int[1][15]
XU254 MUX2S $PINS O=sll_16/ML_int[3][17] S=n72 A=n104 B=sll_16/ML_int[2][13]
XU255 MUX2S $PINS O=n126 S=FE_OFN186_h23_1 A=n2 B=sll_18/ML_int[1][15]
XU256 MUX2S $PINS O=sll_18/ML_int[3][17] S=FE_RN_3 A=n126
+ B=sll_18/ML_int[2][13]
XU257 MUX2S $PINS O=n115 S=shf2[1] A=n3 B=sll_17/ML_int[1][15]
XU258 MUX2S $PINS O=sll_17/ML_int[3][17] S=shf2[2] A=n115
+ B=sll_17/ML_int[2][13]
XU259 MUX2S $PINS O=sll_16/ML_int[3][18] S=n72 A=n105 B=sll_16/ML_int[2][14]
XU260 MUX2S $PINS O=n127 S=FE_OFN94_h23_1 A=n128 B=term3_in[26]
XU261 MUX2S $PINS O=sll_18/ML_int[3][18] S=FE_OFN60_h23_2 A=n127
+ B=sll_18/ML_int[2][14]
XU262 MUX2S $PINS O=n116 S=n38 A=n117 B=term2_in[26]
XU263 MUX2S $PINS O=sll_17/ML_int[3][18] S=shf2[2] A=n116
+ B=sll_17/ML_int[2][14]
XU265 MUX2S $PINS O=term1_shifted[20] S=FE_RN_5 A=sll_16/ML_int[3][20]
+ B=sll_16/ML_int[3][12]
XU266 MUX2S $PINS O=sll_16/ML_int[3][20] S=n72 A=term1_in[26] B=n103
XU267 MUX2S $PINS O=term1_shifted[19] S=FE_RN_5 A=sll_16/ML_int[3][19]
+ B=sll_16/ML_int[3][11]
XU268 MUX2S $PINS O=term3_shifted[20] S=shf3[3] A=sll_18/ML_int[3][20]
+ B=sll_18/ML_int[3][12]
XU269 MUX2S $PINS O=sll_18/ML_int[3][20] S=FE_OFN60_h23_2 A=term3_in[26] B=n125
XU270 MUX2S $PINS O=term3_shifted[19] S=shf3[3] A=sll_18/ML_int[3][19]
+ B=sll_18/ML_int[3][11]
XU271 MUX2S $PINS O=term2_shifted[20] S=FE_OFN57_h22_3 A=sll_17/ML_int[3][20]
+ B=sll_17/ML_int[3][12]
XU272 MUX2S $PINS O=sll_17/ML_int[3][20] S=shf2[2] A=term2_in[26] B=n114
XU273 MUX2S $PINS O=term2_shifted[19] S=FE_OFN57_h22_3 A=sll_17/ML_int[3][19]
+ B=sll_17/ML_int[3][11]
XU275 MUX2S $PINS O=term1_shifted[21] S=FE_RN_5 A=sll_16/ML_int[3][21]
+ B=sll_16/ML_int[3][13]
XU276 MUX2S $PINS O=term2_shifted[21] S=FE_OFN57_h22_3 A=sll_17/ML_int[3][21]
+ B=sll_17/ML_int[3][13]
XU277 MUX2S $PINS O=term3_shifted[21] S=shf3[3] A=sll_18/ML_int[3][21]
+ B=sll_18/ML_int[3][13]
XU278 MUX2S $PINS O=term1_shifted[22] S=FE_RN_5 A=sll_16/ML_int[3][22]
+ B=sll_16/ML_int[3][14]
XU279 MUX2S $PINS O=term2_shifted[22] S=FE_OFN57_h22_3 A=sll_17/ML_int[3][22]
+ B=sll_17/ML_int[3][14]
XU280 MUX2S $PINS O=term3_shifted[22] S=shf3[3] A=sll_18/ML_int[3][22]
+ B=sll_18/ML_int[3][14]
XU286 AN2S $PINS O=base_val[1] I1=acc_reg[1] I2=n147
XU287 AN2S $PINS O=base_val[2] I1=acc_reg[2] I2=n147
XU290 ND2S $PINS O=n148 I1=FE_PHN776_N251 I2=FE_OFN3_FE_DBTN15_n64
XU291 MUX2S $PINS O=N235 S=FE_OFN3_FE_DBTN15_n64 A=acc_reg[10] B=acc_reg[14]
XU292 MUX2S $PINS O=FE_PHN1239_N244 S=FE_OFN3_FE_DBTN15_n64 A=acc_reg[19]
+ B=acc_reg[23]
XU304 NR2 $PINS O=term1_in[4] I1=sign1[1] I2=x_in[4]
XU306 NR2 $PINS O=term3_in[4] I1=FE_OFN242_s23_1 I2=x_in[4]
XU307 INV1S $PINS O=n123 I=n118
XU308 NR2 $PINS O=term1_in[5] I1=sign1[1] I2=x_in[5]
XU309 NR2 $PINS O=term2_in[5] I1=sign2[1] I2=x_in[5]
XU310 INV1S $PINS O=n113 I=n108
XU311 NR2 $PINS O=term3_in[5] I1=FE_OFN242_s23_1 I2=x_in[5]
XU312 INV1S $PINS O=n124 I=n119
XU313 NR2 $PINS O=term1_in[7] I1=sign1[1] I2=x_in[7]
XU314 NR2 $PINS O=term1_in[6] I1=sign1[1] I2=x_in[6]
XU315 NR2 $PINS O=term2_in[7] I1=sign2[1] I2=x_in[7]
XU316 NR2 $PINS O=term3_in[7] I1=FE_OFN242_s23_1 I2=x_in[7]
XU317 NR2 $PINS O=term2_in[6] I1=sign2[1] I2=x_in[6]
XU318 NR2 $PINS O=term3_in[6] I1=FE_OFN242_s23_1 I2=x_in[6]
XU320 NR2 $PINS O=term1_in[8] I1=sign1[1] I2=x_in[8]
XU321 NR2 $PINS O=term2_in[8] I1=sign2[1] I2=x_in[8]
XU322 NR2 $PINS O=term3_in[8] I1=FE_OFN242_s23_1 I2=x_in[8]
XU329 NR2 $PINS O=term1_in[9] I1=sign1[1] I2=x_in[9]
XU330 NR2 $PINS O=term2_in[9] I1=sign2[1] I2=x_in[9]
XU331 NR2 $PINS O=term3_in[9] I1=FE_OFN242_s23_1 I2=x_in[9]
XU332 NR2 $PINS O=term1_in[10] I1=sign1[1] I2=x_in[10]
XU333 NR2 $PINS O=term2_in[10] I1=sign2[1] I2=x_in[10]
XU334 NR2 $PINS O=term3_in[10] I1=FE_OFN242_s23_1 I2=x_in[10]
XU335 NR2 $PINS O=term1_in[11] I1=sign1[1] I2=x_in[11]
XU336 NR2 $PINS O=term2_in[11] I1=sign2[1] I2=x_in[11]
XU337 NR2 $PINS O=term3_in[11] I1=FE_OFN242_s23_1 I2=x_in[11]
XU338 NR2 $PINS O=term1_in[12] I1=sign1[1] I2=x_in[12]
XU340 NR2 $PINS O=term2_in[12] I1=sign2[1] I2=x_in[12]
XU341 NR2 $PINS O=term3_in[12] I1=FE_OFN242_s23_1 I2=x_in[12]
XU345 NR2 $PINS O=term1_in[13] I1=sign1[1] I2=x_in[13]
XU347 NR2 $PINS O=term2_in[13] I1=sign2[1] I2=x_in[13]
XU348 NR2 $PINS O=term3_in[13] I1=FE_OFN242_s23_1 I2=x_in[13]
XU349 NR2 $PINS O=term1_in[14] I1=sign1[1] I2=n134
XU350 NR2 $PINS O=term2_in[14] I1=sign2[1] I2=n134
XU351 NR2 $PINS O=term3_in[14] I1=FE_OFN242_s23_1 I2=n134
XU356 NR2 $PINS O=term1_in[15] I1=sign1[1] I2=n135
XU358 NR2 $PINS O=term2_in[15] I1=sign2[1] I2=n135
XU359 NR2 $PINS O=term3_in[15] I1=FE_OFN242_s23_1 I2=n135
XU375 INV1S $PINS O=n64 I=FE_OFN259_h21_0
XU392 INV1S $PINS O=n134 I=x_in[14]
XU398 INV1S $PINS O=n135 I=x_in[15]
XU399 INV1S $PINS O=n136 I=x_in[16]
XU400 NR2 $PINS O=term1_in[26] I1=n136 I2=sign1[1]
XU402 NR2 $PINS O=term2_in[26] I1=n136 I2=sign2[1]
XU404 NR2 $PINS O=term3_in[26] I1=n136 I2=FE_OFN84_s23_1
XU406 MOAI1S $PINS O=base_val[9] A1=n30 A2=n147 B1=acc_reg[9] B2=n147
XU407 AN2 $PINS O=base_val[10] I1=acc_reg[10] I2=n147
XU408 AN2 $PINS O=base_val[8] I1=acc_reg[8] I2=n147
XU409 AN2 $PINS O=base_val[11] I1=acc_reg[11] I2=n147
XU410 AN2 $PINS O=base_val[12] I1=acc_reg[12] I2=n147
XU411 AN2 $PINS O=base_val[14] I1=acc_reg[14] I2=n147
XU412 AN2 $PINS O=base_val[15] I1=acc_reg[15] I2=n147
XU413 AN2 $PINS O=base_val[16] I1=acc_reg[16] I2=n147
XU414 AN2 $PINS O=base_val[17] I1=acc_reg[17] I2=n147
XU415 AN2 $PINS O=base_val[18] I1=acc_reg[18] I2=n147
XU416 AN2 $PINS O=base_val[19] I1=acc_reg[19] I2=n147
XU417 AN2 $PINS O=base_val[20] I1=acc_reg[20] I2=n147
XU418 AN2 $PINS O=base_val[21] I1=acc_reg[21] I2=n147
XU419 AN2 $PINS O=base_val[22] I1=acc_reg[22] I2=n147
XU420 AN2 $PINS O=base_val[23] I1=acc_reg[23] I2=n147
XU421 AN2 $PINS O=base_val[24] I1=acc_reg[24] I2=n147
XU422 AN2 $PINS O=base_val[25] I1=acc_reg[25] I2=n147
XU423 AN2 $PINS O=base_val[7] I1=acc_reg[7] I2=n147
XU424 AN2 $PINS O=base_val[6] I1=acc_reg[6] I2=n147
XU425 AN2 $PINS O=base_val[5] I1=acc_reg[5] I2=n147
XU426 AN2 $PINS O=base_val[4] I1=acc_reg[4] I2=n147
XU427 AN2 $PINS O=base_val[3] I1=acc_reg[3] I2=n147
XU430 AN2 $PINS O=base_val[0] I1=acc_reg[0] I2=n147
XU434 AN2 $PINS O=N234 I1=en I2=calc_done
XU435 OAI12HS $PINS O=N247 A1=n148 B1=FE_OFN3_FE_DBTN15_n64 B2=n129
XU436 INV1S $PINS O=n129 I=FE_PHN848_acc_reg_22
XU437 AN2 $PINS O=base_val[26] I1=N251 I2=n147
XU439 INV1S $PINS O=n102 I=n97
XU440 ND2P $PINS O=n119 I1=sll_18/ML_int[1][1] I2=FE_OFN94_h23_1
XU441 NR2 $PINS O=sll_16/ML_int[3][0] I1=n72 I2=n96
XU442 NR2 $PINS O=sll_16/ML_int[3][1] I1=n72 I2=n97
XU443 NR2 $PINS O=sll_16/ML_int[3][2] I1=n72 I2=n100
XU445 ND2P $PINS O=n98 I1=shf1[2] I2=shf1[3]
XU449 AN2 $PINS O=term1_shifted[7] I1=sll_16/ML_int[3][7] I2=shf1[3]
XU450 MUX2 $PINS O=sll_16/ML_int[3][21] S=n72 A=n1 B=n104
XU451 MUX2 $PINS O=sll_16/ML_int[3][22] S=n72 A=term1_in[26] B=n105
XU452 MUX2 $PINS O=term1_shifted[24] S=FE_RN_5 A=term1_in[26]
+ B=sll_16/ML_int[3][16]
XU453 MUX2 $PINS O=term1_shifted[25] S=FE_RN_5 A=n1 B=sll_16/ML_int[3][17]
XU454 MUX2 $PINS O=term1_shifted[26] S=FE_RN_5 A=term1_in[26]
+ B=sll_16/ML_int[3][18]
XU455 NR2 $PINS O=sll_17/ML_int[3][0] I1=FE_OFN330_n42 I2=n107
XU456 NR2 $PINS O=sll_17/ML_int[3][1] I1=FE_OFN330_n42 I2=n108
XU457 NR2 $PINS O=sll_17/ML_int[3][2] I1=FE_OFN330_n42 I2=n111
XU458 AN2T $PINS O=term2_shifted[4] I1=n48 I2=sll_17/ML_int[3][4]
XU459 AN2 $PINS O=term2_shifted[5] I1=sll_17/ML_int[3][5] I2=n48
XU460 AN2 $PINS O=term2_shifted[6] I1=sll_17/ML_int[3][6] I2=n48
XU461 AN2 $PINS O=term2_shifted[7] I1=sll_17/ML_int[3][7] I2=n48
XU462 MUX2 $PINS O=sll_17/ML_int[3][21] S=shf2[2] A=n3 B=n115
XU463 MUX2 $PINS O=sll_17/ML_int[3][22] S=shf2[2] A=term2_in[26] B=n116
XU464 MUX2 $PINS O=term2_shifted[24] S=FE_OFN57_h22_3 A=term2_in[26]
+ B=sll_17/ML_int[3][16]
XU465 MUX2 $PINS O=term2_shifted[25] S=FE_OFN57_h22_3 A=n3
+ B=sll_17/ML_int[3][17]
XU466 MUX2 $PINS O=term2_shifted[26] S=FE_OFN57_h22_3 A=term2_in[26]
+ B=sll_17/ML_int[3][18]
XU467 NR2 $PINS O=sll_18/ML_int[3][0] I1=FE_RN_3 I2=n118
XU468 NR2 $PINS O=sll_18/ML_int[3][1] I1=FE_RN_3 I2=n119
XU469 NR2 $PINS O=sll_18/ML_int[3][2] I1=FE_RN_3 I2=n122
XU470 NR2 $PINS O=sll_18/ML_int[3][3] I1=FE_RN_3 I2=n121
XU471 AN2S $PINS O=term3_shifted[4] I1=sll_18/ML_int[3][4] I2=n21
XU472 AN2 $PINS O=term3_shifted[5] I1=sll_18/ML_int[3][5] I2=n21
XU473 AN2 $PINS O=term3_shifted[6] I1=sll_18/ML_int[3][6] I2=n21
XU474 MUX2 $PINS O=sll_18/ML_int[3][21] S=FE_OFN60_h23_2 A=n2 B=n126
XU475 MUX2 $PINS O=sll_18/ML_int[3][22] S=FE_OFN60_h23_2 A=term3_in[26] B=n127
XU476 MUX2 $PINS O=term3_shifted[24] S=shf3[3] A=term3_in[26]
+ B=sll_18/ML_int[3][16]
XU477 MUX2 $PINS O=term3_shifted[25] S=shf3[3] A=n2 B=sll_18/ML_int[3][17]
XU478 MUX2 $PINS O=term3_shifted[26] S=shf3[3] A=term3_in[26]
+ B=sll_18/ML_int[3][18]
XU479 MUX2 $PINS O=N245 S=FE_OFN4_FE_DBTN15_n64 A=acc_reg[20] B=acc_reg[24]
XU480 MUX2 $PINS O=N246 S=FE_OFN3_FE_DBTN15_n64 A=acc_reg[21] B=acc_reg[25]
XU481 MUX2 $PINS O=N236 S=FE_OFN3_FE_DBTN15_n64 A=acc_reg[11] B=acc_reg[15]
XU482 MUX2 $PINS O=N237 S=FE_OFN3_FE_DBTN15_n64 A=acc_reg[12] B=acc_reg[16]
XU483 MUX2 $PINS O=N238 S=FE_OFN3_FE_DBTN15_n64 A=acc_reg[13] B=acc_reg[17]
XU484 MUX2 $PINS O=N239 S=FE_OFN3_FE_DBTN15_n64 A=acc_reg[14] B=acc_reg[18]
XU485 MUX2 $PINS O=N240 S=FE_OFN3_FE_DBTN15_n64 A=acc_reg[15] B=acc_reg[19]
XU486 MUX2 $PINS O=N241 S=FE_OFN3_FE_DBTN15_n64 A=acc_reg[16] B=acc_reg[20]
XU487 MUX2 $PINS O=FE_PHN1184_N242 S=FE_OFN3_FE_DBTN15_n64 A=acc_reg[17]
+ B=acc_reg[21]
XU488 MUX2 $PINS O=N243 S=FE_OFN4_FE_DBTN15_n64 A=acc_reg[18]
+ B=FE_PHN848_acc_reg_22
Xclk_gate_y_out_reg SNPS_CLOCK_GATE_HIGH_PE_Shift_Add_3 $PINS EN=N234
+ ENCLK=CTS_12 CLK=clk_clone1
Xsub_28_3 PE_Shift_Add_3_DW01_sub_0_DW01_sub_9 $PINS A[26]=net44369
+ A[25]=net44369 A[24]=net44369 A[23]=net44369 A[22]=net44369 A[21]=net44369
+ A[20]=net44369 A[19]=net44369 A[18]=net44369 A[17]=net44369 A[16]=net44369
+ A[15]=net44369 A[14]=net44369 A[13]=net44369 A[12]=net44369 A[11]=net44369
+ A[10]=net44369 A[9]=net44369 A[8]=net44369 A[7]=net44369 A[6]=net44369
+ A[5]=net44369 A[4]=net44369 A[3]=net44369 A[2]=net44369 A[1]=net44369
+ A[0]=net44369 B[26]=term3_shifted[26] B[25]=term3_shifted[25]
+ B[24]=term3_shifted[24] B[23]=term3_shifted[23] B[22]=term3_shifted[22]
+ B[21]=term3_shifted[21] B[20]=term3_shifted[20] B[19]=term3_shifted[19]
+ B[18]=term3_shifted[18] B[17]=term3_shifted[17] B[16]=term3_shifted[16]
+ B[15]=term3_shifted[15] B[14]=term3_shifted[14] B[13]=term3_shifted[13]
+ B[12]=term3_shifted[12] B[11]=term3_shifted[11] B[10]=term3_shifted[10]
+ B[9]=term3_shifted[9] B[8]=term3_shifted[8] B[7]=term3_shifted[7]
+ B[6]=term3_shifted[6] B[5]=term3_shifted[5] B[4]=term3_shifted[4]
+ B[3]=term3_shifted[3] B[2]=term3_shifted[2] B[1]=term3_shifted[1]
+ B[0]=term3_shifted[0] CI=net44369 DIFF[26]=N150 DIFF[25]=N149 DIFF[24]=N148
+ DIFF[23]=N147 DIFF[22]=N146 DIFF[21]=N145 DIFF[20]=N144 DIFF[19]=N143
+ DIFF[18]=N142 DIFF[17]=N141 DIFF[16]=N140 DIFF[15]=N139 DIFF[14]=N138
+ DIFF[13]=N137 DIFF[12]=N136 DIFF[11]=N135 DIFF[10]=N134 DIFF[9]=N133
+ DIFF[8]=N132 DIFF[7]=N131 DIFF[6]=N130 DIFF[5]=N129 DIFF[4]=N128 DIFF[3]=N127
+ DIFF[2]=N126 DIFF[1]=N125 DIFF[0]=N124
Xsub_28_2 PE_Shift_Add_3_DW01_sub_1_DW01_sub_10 $PINS A[26]=net44369
+ A[25]=net44369 A[24]=net44369 A[23]=net44369 A[22]=net44369 A[21]=net44369
+ A[20]=net44369 A[19]=net44369 A[18]=net44369 A[17]=net44369 A[16]=net44369
+ A[15]=net44369 A[14]=net44369 A[13]=net44369 A[12]=net44369 A[11]=net44369
+ A[10]=net44369 A[9]=net44369 A[8]=net44369 A[7]=net44369 A[6]=net44369
+ A[5]=net44369 A[4]=net44369 A[3]=net44369 A[2]=net44369 A[1]=net44369
+ A[0]=net44369 B[26]=term2_shifted[26] B[25]=term2_shifted[25]
+ B[24]=term2_shifted[24] B[23]=term2_shifted[23] B[22]=term2_shifted[22]
+ B[21]=term2_shifted[21] B[20]=term2_shifted[20] B[19]=term2_shifted[19]
+ B[18]=term2_shifted[18] B[17]=term2_shifted[17] B[16]=term2_shifted[16]
+ B[15]=term2_shifted[15] B[14]=term2_shifted[14] B[13]=term2_shifted[13]
+ B[12]=term2_shifted[12] B[11]=term2_shifted[11] B[10]=term2_shifted[10]
+ B[9]=term2_shifted[9] B[8]=term2_shifted[8] B[7]=term2_shifted[7]
+ B[6]=term2_shifted[6] B[5]=term2_shifted[5] B[4]=term2_shifted[4]
+ B[3]=term2_shifted[3] B[2]=term2_shifted[2] B[1]=term2_shifted[1]
+ B[0]=term2_shifted[0] CI=net44369 DIFF[26]=N95 DIFF[25]=N94 DIFF[24]=N93
+ DIFF[23]=N92 DIFF[22]=N91 DIFF[21]=N90 DIFF[20]=N89 DIFF[19]=N88 DIFF[18]=N87
+ DIFF[17]=N86 DIFF[16]=N85 DIFF[15]=N84 DIFF[14]=N83 DIFF[13]=N82 DIFF[12]=N81
+ DIFF[11]=N80 DIFF[10]=N79 DIFF[9]=N78 DIFF[8]=N77 DIFF[7]=N76 DIFF[6]=N75
+ DIFF[5]=N74 DIFF[4]=N73 DIFF[3]=N72 DIFF[2]=N71 DIFF[1]=N70 DIFF[0]=N69
Xsub_28 PE_Shift_Add_3_DW01_sub_2_DW01_sub_11 $PINS A[26]=net44369
+ A[25]=net44369 A[24]=net44369 A[23]=net44369 A[22]=net44369 A[21]=net44369
+ A[20]=net44369 A[19]=net44369 A[18]=net44369 A[17]=net44369 A[16]=net44369
+ A[15]=net44369 A[14]=net44369 A[13]=net44369 A[12]=net44369 A[11]=net44369
+ A[10]=net44369 A[9]=net44369 A[8]=net44369 A[7]=net44369 A[6]=net44369
+ A[5]=net44369 A[4]=net44369 A[3]=net44369 A[2]=net44369 A[1]=net44369
+ A[0]=net44369 B[26]=term1_shifted[26] B[25]=term1_shifted[25]
+ B[24]=term1_shifted[24] B[23]=term1_shifted[23] B[22]=term1_shifted[22]
+ B[21]=term1_shifted[21] B[20]=term1_shifted[20] B[19]=term1_shifted[19]
+ B[18]=term1_shifted[18] B[17]=term1_shifted[17] B[16]=term1_shifted[16]
+ B[15]=term1_shifted[15] B[14]=term1_shifted[14] B[13]=term1_shifted[13]
+ B[12]=term1_shifted[12] B[11]=term1_shifted[11] B[10]=term1_shifted[10]
+ B[9]=term1_shifted[9] B[8]=term1_shifted[8] B[7]=term1_shifted[7]
+ B[6]=term1_shifted[6] B[5]=term1_shifted[5] B[4]=term1_shifted[4]
+ B[3]=term1_shifted[3] B[2]=term1_shifted[2] B[1]=term1_shifted[1]
+ B[0]=term1_shifted[0] CI=net44369 DIFF[26]=N40 DIFF[25]=N39 DIFF[24]=N38
+ DIFF[23]=N37 DIFF[22]=N36 DIFF[21]=N35 DIFF[20]=N34 DIFF[19]=N33 DIFF[18]=N32
+ DIFF[17]=N31 DIFF[16]=N30 DIFF[15]=N29 DIFF[14]=N28 DIFF[13]=N27 DIFF[12]=N26
+ DIFF[11]=N25 DIFF[10]=N24 DIFF[9]=N23 DIFF[8]=N22 DIFF[7]=N21 DIFF[6]=N20
+ DIFF[5]=N19 DIFF[4]=N18 DIFF[3]=N17 DIFF[2]=N16 DIFF[1]=N15 DIFF[0]=N14
Xadd_1_root_add_0_root_add_28_3 PE_Shift_Add_3_DW01_add_2_DW01_add_19 $PINS
+ A[26]=N67 A[25]=N66 A[24]=N65 A[23]=N64 A[22]=N63 A[21]=N62 A[20]=N61 A[19]=N60
+ A[18]=N59 A[17]=N58 A[16]=N57 A[15]=N56 A[14]=N55 A[13]=N54 A[12]=N53 A[11]=N52
+ A[10]=N51 A[9]=N50 A[8]=N49 A[7]=N48 A[6]=N47 A[5]=N46 A[4]=N45 A[3]=N44
+ A[2]=N43 A[1]=N42 A[0]=N41 B[26]=N177 B[25]=N176 B[24]=N175 B[23]=N174
+ B[22]=N173 B[21]=N172 B[20]=N171 B[19]=N170 B[18]=N169 B[17]=N168 B[16]=N167
+ B[15]=N166 B[14]=N165 B[13]=N164 B[12]=N163 B[11]=N162 B[10]=N161 B[9]=N160
+ B[8]=N159 B[7]=N158 B[6]=N157 B[5]=N156 B[4]=N155 B[3]=N154 B[2]=N153 B[1]=N152
+ B[0]=N151 CI=net44369 SUM[26]=N204 SUM[25]=N203 SUM[24]=N202 SUM[23]=N201
+ SUM[22]=N200 SUM[21]=N199 SUM[20]=N198 SUM[19]=N197 SUM[18]=N196 SUM[17]=N195
+ SUM[16]=N194 SUM[15]=N193 SUM[14]=N192 SUM[13]=N191 SUM[12]=N190 SUM[11]=N189
+ SUM[10]=N188 SUM[9]=N187 SUM[8]=N186 SUM[7]=N185 SUM[6]=N184 SUM[5]=N183
+ SUM[4]=N182 SUM[3]=N181 SUM[2]=N180 SUM[1]=N179 SUM[0]=N178
Xadd_2_root_add_0_root_add_28_3 PE_Shift_Add_3_DW01_add_1_DW01_add_18 $PINS
+ A[26]=base_val[26] A[25]=base_val[25] A[24]=base_val[24] A[23]=base_val[23]
+ A[22]=base_val[22] A[21]=base_val[21] A[20]=base_val[20] A[19]=base_val[19]
+ A[18]=base_val[18] A[17]=base_val[17] A[16]=base_val[16] A[15]=base_val[15]
+ A[14]=base_val[14] A[13]=base_val[13] A[12]=base_val[12] A[11]=base_val[11]
+ A[10]=base_val[10] A[9]=base_val[9] A[8]=base_val[8] A[7]=base_val[7]
+ A[6]=base_val[6] A[5]=base_val[5] A[4]=base_val[4] A[3]=base_val[3]
+ A[2]=base_val[2] A[1]=base_val[1] A[0]=base_val[0] B[26]=N122 B[25]=N121
+ B[24]=N120 B[23]=N119 B[22]=N118 B[21]=N117 B[20]=N116 B[19]=N115 B[18]=N114
+ B[17]=N113 B[16]=N112 B[15]=N111 B[14]=N110 B[13]=N109 B[12]=N108 B[11]=N107
+ B[10]=N106 B[9]=N105 B[8]=N104 B[7]=N103 B[6]=N102 B[5]=N101 B[4]=N100 B[3]=N99
+ B[2]=N98 B[1]=N97 B[0]=N96 CI=net44369 SUM[26]=N231 SUM[25]=N230 SUM[24]=N229
+ SUM[23]=N228 SUM[22]=N227 SUM[21]=N226 SUM[20]=N225 SUM[19]=N224 SUM[18]=N223
+ SUM[17]=N222 SUM[16]=N221 SUM[15]=N220 SUM[14]=N219 SUM[13]=N218 SUM[12]=N217
+ SUM[11]=N216 SUM[10]=N215 SUM[9]=N214 SUM[8]=N213 SUM[7]=N212 SUM[6]=N211
+ SUM[5]=N210 SUM[4]=N209 SUM[3]=N208 SUM[2]=N207 SUM[1]=N206 SUM[0]=N205
Xadd_0_root_add_0_root_add_28_3 PE_Shift_Add_3_DW01_add_0_DW01_add_17 $PINS
+ A[26]=N204 A[25]=N203 A[24]=N202 A[23]=N201 A[22]=N200 A[21]=N199 A[20]=N198
+ A[19]=N197 A[18]=N196 A[17]=N195 A[16]=N194 A[15]=N193 A[14]=N192 A[13]=N191
+ A[12]=N190 A[11]=N189 A[10]=N188 A[9]=N187 A[8]=N186 A[7]=N185 A[6]=N184
+ A[5]=N183 A[4]=N182 A[3]=N181 A[2]=N180 A[1]=N179 A[0]=N178 B[26]=N231
+ B[25]=N230 B[24]=N229 B[23]=N228 B[22]=N227 B[21]=N226 B[20]=N225 B[19]=N224
+ B[18]=N223 B[17]=N222 B[16]=N221 B[15]=N220 B[14]=N219 B[13]=N218 B[12]=N217
+ B[11]=N216 B[10]=N215 B[9]=N214 B[8]=N213 B[7]=N212 B[6]=N211 B[5]=N210
+ B[4]=N209 B[3]=N208 B[2]=N207 B[1]=N206 B[0]=N205 CI=net44369
+ SUM[26]=next_acc[26] SUM[25]=next_acc[25] SUM[24]=next_acc[24]
+ SUM[23]=next_acc[23] SUM[22]=next_acc[22] SUM[21]=next_acc[21]
+ SUM[20]=next_acc[20] SUM[19]=next_acc[19] SUM[18]=next_acc[18]
+ SUM[17]=next_acc[17] SUM[16]=next_acc[16] SUM[15]=next_acc[15]
+ SUM[14]=next_acc[14] SUM[13]=next_acc[13] SUM[12]=next_acc[12]
+ SUM[11]=next_acc[11] SUM[10]=next_acc[10] SUM[9]=next_acc[9] SUM[8]=next_acc[8]
+ SUM[7]=next_acc[7] SUM[6]=next_acc[6] SUM[5]=next_acc[5] SUM[4]=next_acc[4]
+ SUM[3]=next_acc[3] SUM[2]=next_acc[2] SUM[1]=next_acc[1] SUM[0]=next_acc[0]
XU11 MUX2 $PINS O=sll_17/ML_int[1][2] S=shf2[0] A=term2_in[2] B=term2_in[1]
Xsll_17/M1_0_4 MUX2 $PINS O=sll_17/ML_int[1][4] S=shf2[0] A=term2_in[4]
+ B=term2_in[3]
Xsll_17/M1_0_5 MUX2 $PINS O=sll_17/ML_int[1][5] S=shf2[0] A=term2_in[5]
+ B=term2_in[4]
Xsll_17/M1_0_6 MUX2 $PINS O=sll_17/ML_int[1][6] S=shf2[0] A=term2_in[6]
+ B=term2_in[5]
Xsll_17/M1_0_7 MUX2S $PINS O=sll_17/ML_int[1][7] S=shf2[0] A=term2_in[7]
+ B=term2_in[6]
Xsll_18/M1_0_5 MUX2 $PINS O=sll_18/ML_int[1][5] S=shf3[0] A=term3_in[5]
+ B=term3_in[4]
XU3 NR2 $PINS O=term2_in[1] I1=sign2[1] I2=n145
XU4 AO22 $PINS O=N158 A1=N131 A2=FE_OFN137_s23_0 B1=term3_shifted[7]
+ B2=sign3[0]
XU6 NR2P $PINS O=term3_shifted[1] I1=n120 I2=n119
XU10 NR2P $PINS O=term1_shifted[2] I1=n98 I2=n100
XU14 INV2 $PINS O=n100 I=sll_16/ML_int[2][2]
XU27 INV1S $PINS O=n122 I=sll_18/ML_int[2][2]
XU32 INV1S $PINS O=n111 I=sll_17/ML_int[2][2]
XU35 NR2P $PINS O=term2_shifted[0] I1=n109 I2=n107
XU38 NR2 $PINS O=term1_in[2] I1=sign1[1] I2=x_in[2]
XU46 NR2 $PINS O=term3_shifted[0] I1=n120 I2=n118
XU50 AN2 $PINS O=sll_17/ML_int[3][3] I1=FE_OFN205_h22_2 I2=sll_17/ML_int[2][3]
XU67 NR2 $PINS O=term3_in[0] I1=FE_OFN242_s23_1 I2=FE_RN_211_0
XU77 NR2 $PINS O=term2_in[0] I1=sign2[1] I2=FE_RN_211_0
XU78 OR2 $PINS O=n120 I1=FE_RN_3 I2=shf3[3]
XU98 AN2 $PINS O=sll_16/ML_int[3][3] I1=shf1[2] I2=sll_16/ML_int[2][3]
XU108 NR2 $PINS O=term2_in[2] I1=sign2[1] I2=x_in[2]
XU112 NR2 $PINS O=term3_in[3] I1=FE_OFN242_s23_1 I2=x_in[3]
XU113 ND2P $PINS O=n108 I1=sll_17/ML_int[1][1] I2=n38
XU114 AN2 $PINS O=sll_17/ML_int[1][0] I1=term2_in[0] I2=n35
XU123 ND2P $PINS O=n109 I1=n48 I2=FE_OFN205_h22_2
XU161 INV2 $PINS O=n121 I=sll_18/ML_int[2][3]
XU162 NR2P $PINS O=term2_shifted[1] I1=n109 I2=n108
.ENDS

.SUBCKT SNPS_CLOCK_GATE_HIGH_PE_Shift_Add_2 EN ENCLK CLK
*.CONNECT net2204 EN
XFE_PHC967_net2207 DELC $PINS O=FE_PHN967_net2207 I=net2207
Xlatch QDBHN $PINS Q=net2207 D=net2204 CKB=CLK
Xmain_gate AN2T $PINS O=ENCLK I1=FE_PHN967_net2207 I2=CLK
.ENDS

.SUBCKT PE_Shift_Add_2_DW01_sub_0_DW01_sub_6 A[26] A[25] A[24] A[23] A[22]
+ A[21] A[20] A[19] A[18] A[17] A[16] A[15] A[14] A[13] A[12] A[11] A[10] A[9]
+ A[8] A[7] A[6] A[5] A[4] A[3] A[2] A[1] A[0] B[26] B[25] B[24] B[23] B[22]
+ B[21] B[20] B[19] B[18] B[17] B[16] B[15] B[14] B[13] B[12] B[11] B[10] B[9]
+ B[8] B[7] B[6] B[5] B[4] B[3] B[2] B[1] B[0] CI DIFF[26] DIFF[25] DIFF[24]
+ DIFF[23] DIFF[22] DIFF[21] DIFF[20] DIFF[19] DIFF[18] DIFF[17] DIFF[16]
+ DIFF[15] DIFF[14] DIFF[13] DIFF[12] DIFF[11] DIFF[10] DIFF[9] DIFF[8] DIFF[7]
+ DIFF[6] DIFF[5] DIFF[4] DIFF[3] DIFF[2] DIFF[1] DIFF[0] CO
*.CONNECT DIFF[0] B[0]
XFE_RC_529_0 AN2B1T $PINS O=n2 I1=n1 B1=B[2]
XFE_RC_1586_0 XNR2HS $PINS O=DIFF[7] I1=B[7] I2=n13
XFE_RC_1045_0 INV1S $PINS O=FE_RN_82_0 I=B[5]
XFE_RC_1044_0 AN2 $PINS O=FE_RN_83_0 I1=n46 I2=n11
XFE_RC_1043_0 AN2 $PINS O=n13 I1=FE_RN_83_0 I2=FE_RN_82_0
XFE_RC_985_0 XNR2HS $PINS O=DIFF[4] I1=n3 I2=B[4]
XU2 INV1S $PINS O=n46 I=B[6]
XU3 INV1S $PINS O=n49 I=B[3]
XU4 INV1S $PINS O=n48 I=B[4]
XU6 XOR2HS $PINS O=DIFF[1] I1=n52 I2=n51
XU7 XOR2HS $PINS O=DIFF[2] I1=n50 I2=n1
XU8 AN2 $PINS O=n1 I1=n51 I2=n52
XU9 XOR2HS $PINS O=DIFF[3] I1=n49 I2=n2
XU11 AN2 $PINS O=n3 I1=n49 I2=n2
XU12 AN2 $PINS O=n4 I1=n40 I2=n18
XU13 AN2 $PINS O=n5 I1=n39 I2=n4
XU14 AN2 $PINS O=n6 I1=n38 I2=n5
XU15 AN2 $PINS O=n7 I1=n37 I2=n6
XU16 AN2 $PINS O=n8 I1=n36 I2=n7
XU17 AN2 $PINS O=n9 I1=n35 I2=n8
XU18 AN2 $PINS O=n10 I1=n34 I2=n9
XU19 INV1S $PINS O=n51 I=B[1]
XU20 INV1S $PINS O=n52 I=B[0]
XU21 AN2 $PINS O=n11 I1=n48 I2=n3
XU22 AN2 $PINS O=n12 I1=n11 I2=FE_RN_82_0
XU24 AN2 $PINS O=n14 I1=n45 I2=n13
XU25 AN2 $PINS O=n15 I1=n44 I2=n14
XU26 AN2 $PINS O=n16 I1=n43 I2=n15
XU27 AN2 $PINS O=n17 I1=n42 I2=n16
XU28 AN2 $PINS O=n18 I1=n41 I2=n17
XU29 AN2 $PINS O=n19 I1=n33 I2=n10
XU30 AN2 $PINS O=n20 I1=n32 I2=n19
XU31 AN2 $PINS O=n21 I1=n31 I2=n20
XU32 AN2 $PINS O=n22 I1=n30 I2=n21
XU33 AN2 $PINS O=n23 I1=n29 I2=n22
XU34 AN2 $PINS O=n24 I1=n28 I2=n23
XU35 INV1S $PINS O=n40 I=B[12]
XU36 INV1S $PINS O=n39 I=B[13]
XU37 INV1S $PINS O=n38 I=B[14]
XU38 INV1S $PINS O=n37 I=B[15]
XU39 INV1S $PINS O=n36 I=B[16]
XU40 INV1S $PINS O=n35 I=B[17]
XU41 INV1S $PINS O=n34 I=B[18]
XU43 XOR2HS $PINS O=DIFF[10] I1=n42 I2=n16
XU44 XOR2HS $PINS O=DIFF[11] I1=n41 I2=n17
XU45 XOR2HS $PINS O=DIFF[12] I1=n40 I2=n18
XU46 XOR2HS $PINS O=DIFF[13] I1=n39 I2=n4
XU47 XOR2HS $PINS O=DIFF[14] I1=n38 I2=n5
XU48 XOR2HS $PINS O=DIFF[15] I1=n37 I2=n6
XU49 XOR2HS $PINS O=DIFF[16] I1=n36 I2=n7
XU50 XOR2HS $PINS O=DIFF[17] I1=n35 I2=n8
XU51 XOR2HS $PINS O=DIFF[18] I1=n34 I2=n9
XU52 XOR2HS $PINS O=DIFF[19] I1=n33 I2=n10
XU53 XOR2HS $PINS O=DIFF[20] I1=n32 I2=n19
XU54 XOR2HS $PINS O=DIFF[21] I1=n31 I2=n20
XU55 XOR2HS $PINS O=DIFF[22] I1=n30 I2=n21
XU56 XOR2HS $PINS O=DIFF[23] I1=n29 I2=n22
XU57 XOR2HS $PINS O=DIFF[24] I1=n28 I2=n23
XU58 XOR2HS $PINS O=DIFF[25] I1=n27 I2=n24
XU59 XOR2HS $PINS O=DIFF[9] I1=n43 I2=n15
XU60 XOR2HS $PINS O=DIFF[8] I1=n44 I2=n14
XU62 XOR2HS $PINS O=DIFF[6] I1=n46 I2=n12
XU63 XOR2HS $PINS O=DIFF[5] I1=FE_RN_82_0 I2=n11
XU64 INV1S $PINS O=n45 I=B[7]
XU65 INV1S $PINS O=n44 I=B[8]
XU66 INV1S $PINS O=n43 I=B[9]
XU67 INV1S $PINS O=n42 I=B[10]
XU68 XOR2HS $PINS O=DIFF[26] I1=B[26] I2=n26
XU69 INV1S $PINS O=n41 I=B[11]
XU70 INV1S $PINS O=n33 I=B[19]
XU71 INV1S $PINS O=n32 I=B[20]
XU72 INV1S $PINS O=n31 I=B[21]
XU73 INV1S $PINS O=n30 I=B[22]
XU74 INV1S $PINS O=n29 I=B[23]
XU75 INV1S $PINS O=n28 I=B[24]
XU76 INV1S $PINS O=n27 I=B[25]
XU78 ND2 $PINS O=n26 I1=n27 I2=n24
XU1 INV1S $PINS O=n50 I=B[2]
.ENDS

.SUBCKT PE_Shift_Add_2_DW01_sub_1_DW01_sub_7 A[26] A[25] A[24] A[23] A[22]
+ A[21] A[20] A[19] A[18] A[17] A[16] A[15] A[14] A[13] A[12] A[11] A[10] A[9]
+ A[8] A[7] A[6] A[5] A[4] A[3] A[2] A[1] A[0] B[26] B[25] B[24] B[23] B[22]
+ B[21] B[20] B[19] B[18] B[17] B[16] B[15] B[14] B[13] B[12] B[11] B[10] B[9]
+ B[8] B[7] B[6] B[5] B[4] B[3] B[2] B[1] B[0] CI DIFF[26] DIFF[25] DIFF[24]
+ DIFF[23] DIFF[22] DIFF[21] DIFF[20] DIFF[19] DIFF[18] DIFF[17] DIFF[16]
+ DIFF[15] DIFF[14] DIFF[13] DIFF[12] DIFF[11] DIFF[10] DIFF[9] DIFF[8] DIFF[7]
+ DIFF[6] DIFF[5] DIFF[4] DIFF[3] DIFF[2] DIFF[1] DIFF[0] CO
*.CONNECT DIFF[0] B[0]
XFE_RC_775_0 AN2B1S $PINS O=n15 I1=n14 B1=B[8]
XFE_RC_130_0 XOR2HS $PINS O=DIFF[7] I1=n45 I2=n13
XFE_RC_1573_0 AN2 $PINS O=FE_RN_363_0 I1=n40 I2=n41
XFE_RC_1572_0 AN2 $PINS O=n4 I1=FE_RN_363_0 I2=n17
XFE_RC_1541_0 XNR2HS $PINS O=DIFF[5] I1=B[5] I2=n11
XFE_OFC670_term2_shifted_5 INV1S $PINS O=n47 I=B[5]
XFE_OFC601_term2_shifted_3 INV1S $PINS O=n49 I=B[3]
XFE_OFC591_term2_shifted_4 INV1S $PINS O=n48 I=B[4]
XU2 AN2S $PINS O=n1 I1=n50 I2=n51
XU3 NR3 $PINS O=n2 I1=DIFF[0] I2=B[1] I3=B[2]
XU4 INV1S $PINS O=n46 I=B[6]
XU9 AN2 $PINS O=n3 I1=n49 I2=n2
XU11 AN2 $PINS O=n5 I1=n39 I2=n4
XU12 AN2 $PINS O=n6 I1=n38 I2=n5
XU13 AN2 $PINS O=n7 I1=n37 I2=n6
XU14 AN2 $PINS O=n8 I1=n36 I2=n7
XU15 AN2 $PINS O=n9 I1=n35 I2=n8
XU16 AN2 $PINS O=n10 I1=n34 I2=n9
XU18 AN2 $PINS O=n11 I1=n48 I2=n3
XU19 AN2 $PINS O=n12 I1=n11 I2=n47
XU20 AN2 $PINS O=n13 I1=n46 I2=n12
XU21 AN2 $PINS O=n14 I1=n45 I2=n13
XU23 AN2 $PINS O=n16 I1=n43 I2=n15
XU24 AN2 $PINS O=n17 I1=n42 I2=n16
XU25 AN2 $PINS O=n18 I1=n41 I2=n17
XU26 AN2 $PINS O=n19 I1=n33 I2=n10
XU27 AN2 $PINS O=n20 I1=n32 I2=n19
XU28 AN2 $PINS O=n21 I1=n31 I2=n20
XU29 AN2 $PINS O=n22 I1=n30 I2=n21
XU30 AN2 $PINS O=n23 I1=n29 I2=n22
XU31 AN2 $PINS O=n24 I1=n28 I2=n23
XU32 INV1S $PINS O=n40 I=B[12]
XU33 INV1S $PINS O=n39 I=B[13]
XU34 INV1S $PINS O=n38 I=B[14]
XU35 INV1S $PINS O=n37 I=B[15]
XU36 INV1S $PINS O=n36 I=B[16]
XU37 INV1S $PINS O=n35 I=B[17]
XU38 INV1S $PINS O=n34 I=B[18]
XU39 INV1S $PINS O=n45 I=B[7]
XU40 INV1S $PINS O=n44 I=B[8]
XU41 INV1S $PINS O=n43 I=B[9]
XU42 INV1S $PINS O=n42 I=B[10]
XU43 XOR2HS $PINS O=DIFF[26] I1=B[26] I2=n26
XU44 INV1S $PINS O=n41 I=B[11]
XU45 INV1S $PINS O=n33 I=B[19]
XU46 INV1S $PINS O=n32 I=B[20]
XU47 INV1S $PINS O=n31 I=B[21]
XU48 INV1S $PINS O=n30 I=B[22]
XU49 INV1S $PINS O=n29 I=B[23]
XU50 INV1S $PINS O=n28 I=B[24]
XU51 INV1S $PINS O=n27 I=B[25]
XU52 XOR2HS $PINS O=DIFF[9] I1=n43 I2=n15
XU53 XOR2HS $PINS O=DIFF[10] I1=n42 I2=n16
XU54 XOR2HS $PINS O=DIFF[11] I1=n41 I2=n17
XU55 XOR2HS $PINS O=DIFF[12] I1=n40 I2=n18
XU56 XOR2HS $PINS O=DIFF[13] I1=n39 I2=n4
XU57 XOR2HS $PINS O=DIFF[14] I1=n38 I2=n5
XU58 XOR2HS $PINS O=DIFF[15] I1=n37 I2=n6
XU59 XOR2HS $PINS O=DIFF[16] I1=n36 I2=n7
XU60 XOR2HS $PINS O=DIFF[17] I1=n35 I2=n8
XU61 XOR2HS $PINS O=DIFF[18] I1=n34 I2=n9
XU62 XOR2HS $PINS O=DIFF[19] I1=n33 I2=n10
XU63 XOR2HS $PINS O=DIFF[20] I1=n32 I2=n19
XU64 XOR2HS $PINS O=DIFF[21] I1=n31 I2=n20
XU65 XOR2HS $PINS O=DIFF[22] I1=n30 I2=n21
XU66 XOR2HS $PINS O=DIFF[23] I1=n29 I2=n22
XU67 XOR2HS $PINS O=DIFF[24] I1=n28 I2=n23
XU68 XOR2HS $PINS O=DIFF[25] I1=n27 I2=n24
XU69 XOR2HS $PINS O=DIFF[8] I1=n44 I2=n14
XU71 XOR2HS $PINS O=DIFF[6] I1=n46 I2=n12
XU73 XOR2HS $PINS O=DIFF[4] I1=n3 I2=n48
XU74 XOR2HS $PINS O=DIFF[3] I1=n2 I2=n49
XU76 ND2 $PINS O=n26 I1=n27 I2=n24
XU1 XOR2HS $PINS O=DIFF[1] I1=n51 I2=n50
XU17 INV2 $PINS O=n51 I=B[0]
XU75 INV1S $PINS O=n50 I=B[1]
XU77 XNR2HS $PINS O=DIFF[2] I1=n1 I2=B[2]
.ENDS

.SUBCKT PE_Shift_Add_2_DW01_sub_2_DW01_sub_8 A[26] A[25] A[24] A[23] A[22]
+ A[21] A[20] A[19] A[18] A[17] A[16] A[15] A[14] A[13] A[12] A[11] A[10] A[9]
+ A[8] A[7] A[6] A[5] A[4] A[3] A[2] A[1] A[0] B[26] B[25] B[24] B[23] B[22]
+ B[21] B[20] B[19] B[18] B[17] B[16] B[15] B[14] B[13] B[12] B[11] B[10] B[9]
+ B[8] B[7] B[6] B[5] B[4] B[3] B[2] B[1] B[0] CI DIFF[26] DIFF[25] DIFF[24]
+ DIFF[23] DIFF[22] DIFF[21] DIFF[20] DIFF[19] DIFF[18] DIFF[17] DIFF[16]
+ DIFF[15] DIFF[14] DIFF[13] DIFF[12] DIFF[11] DIFF[10] DIFF[9] DIFF[8] DIFF[7]
+ DIFF[6] DIFF[5] DIFF[4] DIFF[3] DIFF[2] DIFF[1] DIFF[0] CO
*.CONNECT DIFF[0] B[0]
XFE_RC_653_0 XNR2HS $PINS O=DIFF[7] I1=B[7] I2=n14
XFE_RC_344_0 XNR2HS $PINS O=DIFF[3] I1=n3 I2=B[3]
XFE_RC_1322_0 OR2B1S $PINS O=FE_RN_224_0 I1=B[4] B1=n4
XFE_RC_1321_0 XOR2HS $PINS O=DIFF[5] I1=B[5] I2=FE_RN_224_0
XFE_RC_1198_0 XNR2HS $PINS O=DIFF[8] I1=n15 I2=B[8]
XFE_RC_1180_0 OR2B1S $PINS O=FE_RN_147_0 I1=B[3] B1=n3
XFE_RC_1179_0 XOR2HS $PINS O=DIFF[4] I1=FE_RN_147_0 I2=B[4]
XFE_OFC615_term1_shifted_2 INV2 $PINS O=n50 I=B[2]
XU1 INV2 $PINS O=n51 I=B[1]
XU2 NR2 $PINS O=n12 I1=B[4] I2=n1
XU3 INV1S $PINS O=n1 I=n4
XU4 INV1S $PINS O=n52 I=B[0]
XU5 INV1S $PINS O=n49 I=B[3]
XU6 INV1S $PINS O=n47 I=B[6]
XU7 XOR2HS $PINS O=DIFF[1] I1=n52 I2=n51
XU9 INV1S $PINS O=n48 I=B[5]
XU10 XOR2HS $PINS O=DIFF[2] I1=n2 I2=n50
XU13 AN2T $PINS O=n3 I1=n50 I2=n2
XU14 AN2 $PINS O=n4 I1=n49 I2=n3
XU15 XOR2HS $PINS O=DIFF[12] I1=n41 I2=n19
XU16 XOR2HS $PINS O=DIFF[13] I1=n40 I2=n5
XU17 AN2 $PINS O=n5 I1=n41 I2=n19
XU18 XOR2HS $PINS O=DIFF[14] I1=n39 I2=n6
XU19 AN2 $PINS O=n6 I1=n40 I2=n5
XU20 XOR2HS $PINS O=DIFF[15] I1=n38 I2=n7
XU21 AN2 $PINS O=n7 I1=n39 I2=n6
XU22 XOR2HS $PINS O=DIFF[16] I1=n37 I2=n8
XU23 AN2 $PINS O=n8 I1=n38 I2=n7
XU24 XOR2HS $PINS O=DIFF[17] I1=n36 I2=n9
XU25 AN2 $PINS O=n9 I1=n37 I2=n8
XU26 XOR2HS $PINS O=DIFF[18] I1=n35 I2=n10
XU27 AN2 $PINS O=n10 I1=n36 I2=n9
XU28 AN2 $PINS O=n11 I1=n35 I2=n10
XU30 XOR2HS $PINS O=DIFF[6] I1=n47 I2=n13
XU31 AN2 $PINS O=n13 I1=n48 I2=n12
XU33 AN2 $PINS O=n14 I1=n13 I2=n47
XU35 AN2 $PINS O=n15 I1=n14 I2=n46
XU36 XOR2HS $PINS O=DIFF[9] I1=n44 I2=n16
XU37 AN2 $PINS O=n16 I1=n45 I2=n15
XU38 XOR2HS $PINS O=DIFF[10] I1=n43 I2=n17
XU39 AN2 $PINS O=n17 I1=n16 I2=n44
XU40 XOR2HS $PINS O=DIFF[11] I1=n42 I2=n18
XU41 AN2 $PINS O=n18 I1=n43 I2=n17
XU42 AN2 $PINS O=n19 I1=n42 I2=n18
XU43 XOR2HS $PINS O=DIFF[19] I1=n34 I2=n11
XU44 XOR2HS $PINS O=DIFF[20] I1=n33 I2=n20
XU45 AN2 $PINS O=n20 I1=n34 I2=n11
XU46 XOR2HS $PINS O=DIFF[21] I1=n32 I2=n21
XU47 AN2 $PINS O=n21 I1=n33 I2=n20
XU48 XOR2HS $PINS O=DIFF[22] I1=n31 I2=n22
XU49 AN2 $PINS O=n22 I1=n32 I2=n21
XU50 XOR2HS $PINS O=DIFF[23] I1=n30 I2=n23
XU51 AN2 $PINS O=n23 I1=n31 I2=n22
XU52 XOR2HS $PINS O=DIFF[24] I1=n29 I2=n24
XU53 AN2 $PINS O=n24 I1=n30 I2=n23
XU54 AN2 $PINS O=n25 I1=n29 I2=n24
XU55 XOR2HS $PINS O=DIFF[25] I1=n28 I2=n25
XU56 INV1S $PINS O=n41 I=B[12]
XU57 INV1S $PINS O=n40 I=B[13]
XU58 INV1S $PINS O=n39 I=B[14]
XU59 INV1S $PINS O=n38 I=B[15]
XU60 INV1S $PINS O=n37 I=B[16]
XU61 INV1S $PINS O=n36 I=B[17]
XU62 INV1S $PINS O=n35 I=B[18]
XU64 INV1S $PINS O=n46 I=B[7]
XU65 INV1S $PINS O=n45 I=B[8]
XU66 INV1S $PINS O=n44 I=B[9]
XU67 INV1S $PINS O=n43 I=B[10]
XU68 XOR2HS $PINS O=DIFF[26] I1=B[26] I2=n27
XU69 INV1S $PINS O=n42 I=B[11]
XU70 INV1S $PINS O=n34 I=B[19]
XU71 INV1S $PINS O=n33 I=B[20]
XU72 INV1S $PINS O=n32 I=B[21]
XU73 INV1S $PINS O=n31 I=B[22]
XU74 INV1S $PINS O=n30 I=B[23]
XU75 INV1S $PINS O=n29 I=B[24]
XU76 INV1S $PINS O=n28 I=B[25]
XU78 ND2 $PINS O=n27 I1=n28 I2=n25
XU12 NR2 $PINS O=n2 I1=B[1] I2=B[0]
.ENDS

.SUBCKT PE_Shift_Add_2_DW01_add_2_DW01_add_31 A[26] A[25] A[24] A[23] A[22]
+ A[21] A[20] A[19] A[18] A[17] A[16] A[15] A[14] A[13] A[12] A[11] A[10] A[9]
+ A[8] A[7] A[6] A[5] A[4] A[3] A[2] A[1] A[0] B[26] B[25] B[24] B[23] B[22]
+ B[21] B[20] B[19] B[18] B[17] B[16] B[15] B[14] B[13] B[12] B[11] B[10] B[9]
+ B[8] B[7] B[6] B[5] B[4] B[3] B[2] B[1] B[0] CI SUM[26] SUM[25] SUM[24]
+ SUM[23] SUM[22] SUM[21] SUM[20] SUM[19] SUM[18] SUM[17] SUM[16] SUM[15]
+ SUM[14] SUM[13] SUM[12] SUM[11] SUM[10] SUM[9] SUM[8] SUM[7] SUM[6] SUM[5]
+ SUM[4] SUM[3] SUM[2] SUM[1] SUM[0] CO
XFE_RC_704_0 INV2 $PINS O=SUM[23] I=FE_RN_339_0
XFE_RC_703_0 XNR3 $PINS O=FE_RN_339_0 I1=A[23] I2=B[23] I3=carry[23]
XFE_RC_700_1 INV2 $PINS O=SUM[14] I=FE_RN_337_0
XFE_RC_699_1 XNR3 $PINS O=FE_RN_337_0 I1=A[14] I2=B[14] I3=carry[14]
XFE_RC_692_0 INV2 $PINS O=SUM[9] I=FE_RN_333_0
XFE_RC_691_0 XNR3 $PINS O=FE_RN_333_0 I1=A[9] I2=B[9] I3=carry[9]
XFE_RC_452_0 INV2 $PINS O=SUM[12] I=FE_RN_235_0
XFE_RC_451_0 XNR3 $PINS O=FE_RN_235_0 I1=A[12] I2=B[12] I3=carry[12]
XFE_RC_337_0 INV3CK $PINS O=SUM[25] I=FE_RN_184_0
XFE_RC_336_0 XNR3 $PINS O=FE_RN_184_0 I1=A[25] I2=B[25] I3=carry[25]
XFE_RC_106_0 ND3 $PINS O=carry[3] I1=n3 I2=n5 I3=n4
XFE_RC_1478_0 INV2 $PINS O=SUM[13] I=FE_RN_310_0
XFE_RC_1477_0 XNR3 $PINS O=FE_RN_310_0 I1=A[13] I2=B[13] I3=carry[13]
XFE_RC_1274_0 INV2 $PINS O=SUM[2] I=FE_RN_198_0
XFE_RC_1273_0 XNR3 $PINS O=FE_RN_198_0 I1=A[2] I2=carry[2] I3=B[2]
XFE_RC_1253_0 INV2 $PINS O=SUM[8] I=FE_RN_187_0
XFE_RC_1252_0 XNR3 $PINS O=FE_RN_187_0 I1=B[8] I2=A[8] I3=carry[8]
XFE_RC_1239_0 INV2 $PINS O=SUM[1] I=FE_RN_179_0
XFE_RC_1238_0 XNR3 $PINS O=FE_RN_179_0 I1=n2 I2=B[1] I3=A[1]
XFE_RC_1236_0 INV2 $PINS O=SUM[3] I=FE_RN_178_0
XFE_RC_1235_0 XNR3 $PINS O=FE_RN_178_0 I1=A[3] I2=B[3] I3=carry[3]
XFE_RC_1078_0 INV2 $PINS O=SUM[6] I=FE_RN_96_0
XFE_RC_1077_0 XNR3 $PINS O=FE_RN_96_0 I1=A[6] I2=B[6] I3=carry[6]
XFE_RC_1035_0 XOR2HS $PINS O=FE_RN_76_0 I1=A[26] I2=B[26]
XFE_RC_1034_0 XOR2H $PINS O=SUM[26] I1=FE_RN_76_0 I2=carry[26]
XFE_RC_846_0 MAO222 $PINS O=carry[2] A1=A[1] B1=n2 C1=B[1]
XFE_RC_809_0 MAO222 $PINS O=carry[26] A1=carry[25] B1=B[25] C1=A[25]
XFE_RC_728_0 XOR3 $PINS O=SUM[24] I1=A[24] I2=B[24] I3=carry[24]
XFE_RC_727_0 MAO222 $PINS O=carry[25] A1=carry[24] B1=B[24] C1=A[24]
XFE_RC_699_0 MAO222P $PINS O=carry[24] A1=carry[23] B1=B[23] C1=A[23]
XFE_RC_653_0 MAO222 $PINS O=carry[4] A1=carry[3] B1=B[3] C1=A[3]
XFE_RC_652_0 XOR3 $PINS O=SUM[22] I1=A[22] I2=B[22] I3=carry[22]
XFE_RC_651_0 MAO222P $PINS O=carry[23] A1=carry[22] B1=B[22] C1=A[22]
XFE_RC_588_0 XOR3 $PINS O=SUM[21] I1=A[21] I2=B[21] I3=carry[21]
XFE_RC_587_0 MAO222P $PINS O=carry[22] A1=carry[21] B1=B[21] C1=A[21]
XFE_RC_514_0 XOR3 $PINS O=SUM[20] I1=A[20] I2=B[20] I3=carry[20]
XFE_RC_513_0 MAO222P $PINS O=carry[21] A1=carry[20] B1=B[20] C1=A[20]
XFE_RC_500_0 XOR3 $PINS O=SUM[19] I1=A[19] I2=B[19] I3=carry[19]
XFE_RC_499_0 MAO222P $PINS O=carry[20] A1=carry[19] B1=B[19] C1=A[19]
XFE_RC_436_0 XOR3 $PINS O=SUM[18] I1=A[18] I2=B[18] I3=carry[18]
XFE_RC_435_0 MAO222P $PINS O=carry[19] A1=carry[18] B1=B[18] C1=A[18]
XFE_RC_353_0 MAO222 $PINS O=carry[9] A1=carry[8] B1=A[8] C1=B[8]
XFE_RC_319_0 MAO222 $PINS O=carry[10] A1=carry[9] B1=B[9] C1=A[9]
XFE_RC_282_0 XOR3 $PINS O=SUM[10] I1=A[10] I2=B[10] I3=carry[10]
XFE_RC_281_0 MAO222 $PINS O=carry[11] A1=carry[10] B1=B[10] C1=A[10]
XFE_RC_261_0 MAO222P $PINS O=carry[7] A1=carry[6] B1=B[6] C1=A[6]
XFE_RC_215_0 XOR3 $PINS O=SUM[11] I1=A[11] I2=B[11] I3=carry[11]
XFE_RC_214_0 MAO222 $PINS O=carry[12] A1=carry[11] B1=B[11] C1=A[11]
XFE_RC_125_0 MAO222P $PINS O=carry[13] A1=carry[12] B1=B[12] C1=A[12]
XFE_RC_114_0 XOR3 $PINS O=SUM[17] I1=A[17] I2=B[17] I3=carry[17]
XFE_RC_113_0 MAO222 $PINS O=carry[18] A1=carry[17] B1=B[17] C1=A[17]
XFE_RC_77_0 MAO222P $PINS O=carry[14] A1=carry[13] B1=B[13] C1=A[13]
XFE_RC_47_0 MAO222P $PINS O=carry[15] A1=carry[14] B1=B[14] C1=A[14]
XU7 AN2 $PINS O=n2 I1=A[0] I2=B[0]
XU9 ND2 $PINS O=n3 I1=B[2] I2=carry[2]
XU10 ND2 $PINS O=n4 I1=B[2] I2=A[2]
XU11 ND2 $PINS O=n5 I1=carry[2] I2=A[2]
XU13 XOR2HS $PINS O=n6 I1=A[16] I2=B[16]
XU14 XOR2HS $PINS O=SUM[16] I1=carry[16] I2=n6
XU15 ND2 $PINS O=n9 I1=A[16] I2=B[16]
XU16 ND3P $PINS O=carry[17] I1=n8 I2=n7 I3=n9
XU17 XOR3 $PINS O=SUM[4] I1=B[4] I2=A[4] I3=carry[4]
XU18 ND2 $PINS O=n10 I1=B[4] I2=A[4]
XU19 ND2 $PINS O=n11 I1=A[4] I2=carry[4]
XU20 ND2 $PINS O=n12 I1=carry[4] I2=B[4]
XU21 ND3P $PINS O=carry[5] I1=n11 I2=n12 I3=n10
XU22 XOR2HS $PINS O=n13 I1=A[5] I2=B[5]
XU23 XOR2HS $PINS O=SUM[5] I1=carry[5] I2=n13
XU24 ND2 $PINS O=n14 I1=A[5] I2=B[5]
XU25 ND2 $PINS O=n15 I1=carry[5] I2=A[5]
XU26 ND2P $PINS O=n16 I1=carry[5] I2=B[5]
XU27 ND3P $PINS O=carry[6] I1=n15 I2=n14 I3=n16
XU29 XOR2HS $PINS O=n19 I1=B[7] I2=A[7]
XU30 XOR2HS $PINS O=SUM[7] I1=carry[7] I2=n19
XU31 ND2P $PINS O=n20 I1=carry[7] I2=B[7]
XU32 ND2P $PINS O=n21 I1=carry[7] I2=A[7]
XU33 ND2 $PINS O=n22 I1=B[7] I2=A[7]
XU34 ND3P $PINS O=carry[8] I1=n21 I2=n20 I3=n22
XU35 XOR2HS $PINS O=n23 I1=B[15] I2=A[15]
XU36 XOR2HS $PINS O=SUM[15] I1=carry[15] I2=n23
XU37 ND2P $PINS O=n24 I1=carry[15] I2=B[15]
XU38 ND2P $PINS O=n25 I1=carry[15] I2=A[15]
XU39 ND2 $PINS O=n26 I1=B[15] I2=A[15]
XU40 XOR2HS $PINS O=SUM[0] I1=B[0] I2=A[0]
XU1 ND3HT $PINS O=carry[16] I1=n25 I2=n24 I3=n26
XU2 ND2 $PINS O=n8 I1=carry[16] I2=B[16]
XU3 ND2P $PINS O=n7 I1=carry[16] I2=A[16]
.ENDS

.SUBCKT PE_Shift_Add_2_DW01_add_1_DW01_add_30 A[26] A[25] A[24] A[23] A[22]
+ A[21] A[20] A[19] A[18] A[17] A[16] A[15] A[14] A[13] A[12] A[11] A[10] A[9]
+ A[8] A[7] A[6] A[5] A[4] A[3] A[2] A[1] A[0] B[26] B[25] B[24] B[23] B[22]
+ B[21] B[20] B[19] B[18] B[17] B[16] B[15] B[14] B[13] B[12] B[11] B[10] B[9]
+ B[8] B[7] B[6] B[5] B[4] B[3] B[2] B[1] B[0] CI SUM[26] SUM[25] SUM[24]
+ SUM[23] SUM[22] SUM[21] SUM[20] SUM[19] SUM[18] SUM[17] SUM[16] SUM[15]
+ SUM[14] SUM[13] SUM[12] SUM[11] SUM[10] SUM[9] SUM[8] SUM[7] SUM[6] SUM[5]
+ SUM[4] SUM[3] SUM[2] SUM[1] SUM[0] CO
XFE_RC_808_0 INV2 $PINS O=SUM[13] I=FE_RN_386_0
XFE_RC_807_0 XNR3 $PINS O=FE_RN_386_0 I1=A[13] I2=B[13] I3=carry[13]
XFE_RC_766_0 INV2 $PINS O=SUM[3] I=FE_RN_365_0
XFE_RC_765_0 XNR3 $PINS O=FE_RN_365_0 I1=A[3] I2=B[3] I3=carry[3]
XFE_RC_756_0 INV2 $PINS O=SUM[5] I=FE_RN_360_0
XFE_RC_755_0 XNR3 $PINS O=FE_RN_360_0 I1=A[5] I2=B[5] I3=carry[5]
XFE_RC_483_0 INV2 $PINS O=SUM[11] I=FE_RN_249_0
XFE_RC_482_1 XNR3 $PINS O=FE_RN_249_0 I1=A[11] I2=B[11] I3=carry[11]
XFE_RC_158_0 ND2 $PINS O=FE_RN_91_0 I1=carry[4] I2=A[4]
XFE_RC_157_0 ND2 $PINS O=FE_RN_92_0 I1=B[4] I2=A[4]
XFE_RC_156_0 ND2 $PINS O=FE_RN_93_0 I1=B[4] I2=carry[4]
XFE_RC_155_0 ND3 $PINS O=carry[5] I1=FE_RN_93_0 I2=FE_RN_92_0 I3=FE_RN_91_0
XFE_RC_86_0 ND3P $PINS O=carry[8] I1=n6 I2=n7 I3=n8
XFE_RC_1341_0 INV1S $PINS O=SUM[8] I=FE_RN_232_0
XFE_RC_1340_0 XNR3 $PINS O=FE_RN_232_0 I1=A[8] I2=B[8] I3=carry[8]
XFE_RC_1234_0 INV1S $PINS O=SUM[2] I=FE_RN_177_0
XFE_RC_1233_0 XNR3 $PINS O=FE_RN_177_0 I1=A[2] I2=carry[2] I3=B[2]
XFE_RC_1208_0 XOR2HS $PINS O=FE_RN_164_0 I1=A[26] I2=B[26]
XFE_RC_1207_0 XOR2HS $PINS O=SUM[26] I1=FE_RN_164_0 I2=carry[26]
XFE_RC_1130_0 XOR3 $PINS O=SUM[25] I1=A[25] I2=B[25] I3=carry[25]
XFE_RC_1129_0 MAO222 $PINS O=carry[26] A1=carry[25] B1=B[25] C1=A[25]
XFE_RC_994_0 XOR3 $PINS O=SUM[22] I1=A[22] I2=B[22] I3=carry[22]
XFE_RC_993_0 MAO222 $PINS O=carry[23] A1=carry[22] B1=B[22] C1=A[22]
XFE_RC_939_0 XOR3 $PINS O=SUM[23] I1=A[23] I2=B[23] I3=carry[23]
XFE_RC_938_0 MAO222P $PINS O=carry[24] A1=carry[23] B1=B[23] C1=A[23]
XFE_RC_918_0 MAO222 $PINS O=carry[6] A1=carry[5] B1=B[5] C1=A[5]
XFE_RC_870_0 XOR3 $PINS O=SUM[21] I1=A[21] I2=B[21] I3=carry[21]
XFE_RC_869_0 MAO222 $PINS O=carry[22] A1=carry[21] B1=B[21] C1=A[21]
XFE_RC_856_0 XOR3 $PINS O=SUM[20] I1=A[20] I2=B[20] I3=carry[20]
XFE_RC_855_0 MAO222 $PINS O=carry[21] A1=carry[20] B1=B[20] C1=A[20]
XFE_RC_818_0 XOR3 $PINS O=SUM[18] I1=A[18] I2=B[18] I3=carry[18]
XFE_RC_817_0 MAO222 $PINS O=carry[19] A1=carry[18] B1=B[18] C1=A[18]
XFE_RC_774_0 XOR3 $PINS O=SUM[19] I1=A[19] I2=B[19] I3=carry[19]
XFE_RC_773_0 MAO222 $PINS O=carry[20] A1=carry[19] B1=B[19] C1=A[19]
XFE_RC_736_0 XOR3 $PINS O=SUM[1] I1=A[1] I2=carry[1] I3=B[1]
XFE_RC_735_0 MAO222 $PINS O=carry[2] A1=B[1] B1=A[1] C1=carry[1]
XFE_RC_664_0 XOR3 $PINS O=SUM[17] I1=A[17] I2=B[17] I3=carry[17]
XFE_RC_663_0 MAO222 $PINS O=carry[18] A1=carry[17] B1=B[17] C1=A[17]
XFE_RC_661_0 MAO222 $PINS O=carry[3] A1=carry[2] B1=B[2] C1=A[2]
XFE_RC_595_0 MAO222 $PINS O=carry[4] A1=B[3] B1=A[3] C1=carry[3]
XFE_RC_532_0 XOR3 $PINS O=SUM[4] I1=A[4] I2=B[4] I3=carry[4]
XFE_RC_524_0 XOR3 $PINS O=SUM[15] I1=A[15] I2=B[15] I3=carry[15]
XFE_RC_523_0 MAO222 $PINS O=carry[16] A1=carry[15] B1=B[15] C1=A[15]
XFE_RC_482_0 XOR3 $PINS O=SUM[14] I1=A[14] I2=B[14] I3=carry[14]
XFE_RC_481_0 MAO222P $PINS O=carry[15] A1=carry[14] B1=B[14] C1=A[14]
XFE_RC_410_0 XOR3 $PINS O=SUM[10] I1=A[10] I2=B[10] I3=carry[10]
XFE_RC_409_0 MAO222 $PINS O=carry[11] A1=carry[10] B1=B[10] C1=A[10]
XFE_RC_377_0 MAO222 $PINS O=carry[12] A1=carry[11] B1=B[11] C1=A[11]
XFE_RC_304_0 XOR3 $PINS O=SUM[16] I1=A[16] I2=B[16] I3=carry[16]
XFE_RC_303_0 MAO222 $PINS O=carry[17] A1=carry[16] B1=B[16] C1=A[16]
XFE_RC_296_0 XOR3 $PINS O=SUM[12] I1=A[12] I2=B[12] I3=carry[12]
XFE_RC_295_0 MAO222 $PINS O=carry[13] A1=carry[12] B1=B[12] C1=A[12]
XFE_RC_195_0 MAO222P $PINS O=carry[14] A1=carry[13] B1=B[13] C1=A[13]
XFE_RC_171_0 ND2 $PINS O=FE_RN_3_0 I1=carry[8] I2=B[8]
XFE_RC_170_0 ND2 $PINS O=FE_RN_4_0 I1=carry[8] I2=A[8]
XFE_RC_169_0 ND2 $PINS O=FE_RN_5_0 I1=B[8] I2=A[8]
XFE_RC_168_0 ND3P $PINS O=carry[9] I1=FE_RN_4_0 I2=FE_RN_3_0 I3=FE_RN_5_0
XFE_RC_136_0 XOR3 $PINS O=SUM[6] I1=A[6] I2=B[6] I3=carry[6]
XFE_RC_135_0 MAO222P $PINS O=carry[7] A1=carry[6] B1=B[6] C1=A[6]
XU2 XOR2HS $PINS O=n1 I1=B[24] I2=A[24]
XU3 XOR2HS $PINS O=SUM[24] I1=carry[24] I2=n1
XU4 ND2 $PINS O=n2 I1=carry[24] I2=B[24]
XU5 ND2 $PINS O=n3 I1=carry[24] I2=A[24]
XU6 ND2S $PINS O=n4 I1=B[24] I2=A[24]
XU8 XOR2HS $PINS O=n5 I1=A[7] I2=B[7]
XU9 XOR2HS $PINS O=SUM[7] I1=carry[7] I2=n5
XU10 ND2 $PINS O=n6 I1=carry[7] I2=B[7]
XU11 ND2 $PINS O=n7 I1=carry[7] I2=A[7]
XU12 ND2 $PINS O=n8 I1=A[7] I2=B[7]
XU14 ND2 $PINS O=n9 I1=carry[9] I2=B[9]
XU15 ND2 $PINS O=n10 I1=carry[9] I2=A[9]
XU16 ND2 $PINS O=n11 I1=B[9] I2=A[9]
XU17 ND3P $PINS O=carry[10] I1=n10 I2=n9 I3=n11
XU18 XOR2HS $PINS O=SUM[0] I1=B[0] I2=A[0]
XU19 INV1S $PINS O=carry[1] I=n12
XU20 ND2 $PINS O=n12 I1=B[0] I2=A[0]
XU1 ND3P $PINS O=carry[25] I1=n3 I2=n2 I3=n4
XU21 XOR3 $PINS O=SUM[9] I1=B[9] I2=A[9] I3=carry[9]
.ENDS

.SUBCKT PE_Shift_Add_2_DW01_add_0_DW01_add_29 A[26] A[25] A[24] A[23] A[22]
+ A[21] A[20] A[19] A[18] A[17] A[16] A[15] A[14] A[13] A[12] A[11] A[10] A[9]
+ A[8] A[7] A[6] A[5] A[4] A[3] A[2] A[1] A[0] B[26] B[25] B[24] B[23] B[22]
+ B[21] B[20] B[19] B[18] B[17] B[16] B[15] B[14] B[13] B[12] B[11] B[10] B[9]
+ B[8] B[7] B[6] B[5] B[4] B[3] B[2] B[1] B[0] CI SUM[26] SUM[25] SUM[24]
+ SUM[23] SUM[22] SUM[21] SUM[20] SUM[19] SUM[18] SUM[17] SUM[16] SUM[15]
+ SUM[14] SUM[13] SUM[12] SUM[11] SUM[10] SUM[9] SUM[8] SUM[7] SUM[6] SUM[5]
+ SUM[4] SUM[3] SUM[2] SUM[1] SUM[0] CO
XFE_RC_798_0 ND2T $PINS O=FE_RN_380_0 I1=carry[13] I2=B[13]
XFE_RC_797_0 ND3P $PINS O=carry[14] I1=n19 I2=FE_RN_380_0 I3=n20
XFE_RC_202_0 ND2 $PINS O=FE_RN_118_0 I1=A[5] I2=B[5]
XFE_RC_201_0 ND2P $PINS O=FE_RN_119_0 I1=carry[5] I2=A[5]
XFE_RC_200_0 ND2P $PINS O=FE_RN_120_0 I1=carry[5] I2=B[5]
XFE_RC_199_0 ND3P $PINS O=carry[6] I1=FE_RN_120_0 I2=FE_RN_119_0 I3=FE_RN_118_0
XFE_RC_1359_0 XNR2H $PINS O=FE_RN_242_0 I1=B[26] I2=A[26]
XFE_RC_1358_0 XNR2H $PINS O=SUM[26] I1=FE_RN_242_0 I2=carry[26]
XFE_RC_1267_0 INV2CK $PINS O=n12 I=FE_RN_193_0
XFE_RC_1266_0 INV1S $PINS O=FE_RN_194_0 I=B[16]
XFE_RC_1265_0 AOI13H $PINS O=FE_RN_193_0 A1=FE_RN_194_0 B1=n21 B2=n22 B3=n23
XFE_RC_758_0 XOR3 $PINS O=SUM[1] I1=A[1] I2=B[1] I3=n1
XFE_RC_757_0 MAO222 $PINS O=carry[2] A1=A[1] B1=B[1] C1=n1
XFE_RC_702_0 XOR3S $PINS O=SUM[2] I1=A[2] I2=B[2] I3=carry[2]
XFE_RC_701_0 MAO222 $PINS O=carry[3] A1=A[2] B1=carry[2] C1=B[2]
XFE_RC_622_0 XOR3 $PINS O=SUM[10] I1=A[10] I2=B[10] I3=carry[10]
XFE_RC_621_0 MAO222P $PINS O=carry[11] A1=carry[10] B1=B[10] C1=A[10]
XFE_RC_614_0 XOR3 $PINS O=SUM[3] I1=A[3] I2=B[3] I3=carry[3]
XFE_RC_613_0 MAO222P $PINS O=carry[4] A1=carry[3] B1=A[3] C1=B[3]
XFE_RC_560_0 XOR3 $PINS O=SUM[4] I1=A[4] I2=B[4] I3=carry[4]
XFE_RC_559_0 MAO222P $PINS O=carry[5] A1=carry[4] B1=A[4] C1=B[4]
XFE_RC_502_0 XOR3 $PINS O=SUM[5] I1=A[5] I2=B[5] I3=carry[5]
XFE_RC_416_0 XOR3 $PINS O=SUM[12] I1=A[12] I2=B[12] I3=carry[12]
XFE_RC_415_0 MAO222P $PINS O=carry[13] A1=carry[12] B1=B[12] C1=A[12]
XFE_RC_408_0 XOR3 $PINS O=SUM[6] I1=A[6] I2=B[6] I3=carry[6]
XFE_RC_407_0 MAO222P $PINS O=carry[7] A1=carry[6] B1=A[6] C1=B[6]
XFE_RC_376_0 XOR3 $PINS O=SUM[14] I1=A[14] I2=B[14] I3=carry[14]
XFE_RC_375_0 MAO222P $PINS O=carry[15] A1=carry[14] B1=B[14] C1=A[14]
XFE_RC_322_0 XOR3 $PINS O=SUM[18] I1=A[18] I2=B[18] I3=carry[18]
XFE_RC_321_0 MAO222 $PINS O=carry[19] A1=carry[18] B1=B[18] C1=A[18]
XFE_RC_260_0 XOR3 $PINS O=SUM[19] I1=A[19] I2=B[19] I3=carry[19]
XFE_RC_259_0 MAO222P $PINS O=carry[20] A1=carry[19] B1=B[19] C1=A[19]
XFE_RC_258_0 XOR3 $PINS O=SUM[25] I1=B[25] I2=A[25] I3=carry[25]
XFE_RC_257_0 MAO222P $PINS O=carry[26] A1=carry[25] B1=B[25] C1=A[25]
XFE_RC_179_0 XOR3 $PINS O=SUM[20] I1=A[20] I2=B[20] I3=carry[20]
XFE_RC_178_0 MAO222P $PINS O=carry[21] A1=carry[20] B1=B[20] C1=A[20]
XFE_RC_116_0 XOR3 $PINS O=SUM[21] I1=A[21] I2=B[21] I3=carry[21]
XFE_RC_115_0 MAO222P $PINS O=carry[22] A1=carry[21] B1=B[21] C1=A[21]
XFE_RC_80_0 XOR3 $PINS O=SUM[22] I1=A[22] I2=B[22] I3=carry[22]
XFE_RC_79_0 MAO222P $PINS O=carry[23] A1=carry[22] B1=B[22] C1=A[22]
XFE_RC_60_0 XOR3 $PINS O=SUM[24] I1=A[24] I2=B[24] I3=carry[24]
XFE_RC_59_0 MAO222 $PINS O=carry[25] A1=carry[24] B1=B[24] C1=A[24]
XFE_RC_26_0 XOR3 $PINS O=SUM[23] I1=A[23] I2=B[23] I3=carry[23]
XFE_RC_25_0 MAO222P $PINS O=carry[24] A1=carry[23] B1=B[23] C1=A[23]
XU1 ND2 $PINS O=n2 I1=B[8] I2=A[8]
XU2 XOR3 $PINS O=SUM[11] I1=B[11] I2=A[11] I3=carry[11]
XU3 XOR3 $PINS O=SUM[13] I1=B[13] I2=A[13] I3=carry[13]
XU5 XOR3 $PINS O=SUM[15] I1=B[15] I2=A[15] I3=carry[15]
XU6 XOR3 $PINS O=SUM[16] I1=B[16] I2=A[16] I3=carry[16]
XU7 ND3P $PINS O=carry[18] I1=n24 I2=n25 I3=n26
XU8 ND2T $PINS O=n25 I1=carry[17] I2=A[17]
XU9 AN2 $PINS O=n1 I1=B[0] I2=A[0]
XU10 XOR3 $PINS O=SUM[8] I1=A[8] I2=B[8] I3=carry[8]
XU11 ND2 $PINS O=n3 I1=carry[8] I2=A[8]
XU12 ND2 $PINS O=n4 I1=carry[8] I2=B[8]
XU13 ND3P $PINS O=carry[9] I1=n3 I2=n4 I3=n2
XU14 XOR2HS $PINS O=n5 I1=A[9] I2=B[9]
XU15 XOR2HS $PINS O=SUM[9] I1=n5 I2=carry[9]
XU16 ND2 $PINS O=n6 I1=B[9] I2=A[9]
XU17 ND2 $PINS O=n7 I1=carry[9] I2=A[9]
XU18 ND2 $PINS O=n8 I1=carry[9] I2=B[9]
XU19 ND3P $PINS O=carry[10] I1=n7 I2=n8 I3=n6
XU20 XOR3 $PINS O=SUM[7] I1=A[7] I2=B[7] I3=carry[7]
XU21 ND2P $PINS O=n9 I1=carry[7] I2=A[7]
XU22 ND2P $PINS O=n10 I1=carry[7] I2=B[7]
XU23 ND2 $PINS O=n11 I1=B[7] I2=A[7]
XU24 ND3P $PINS O=carry[8] I1=n9 I2=n10 I3=n11
XU26 ND2T $PINS O=n13 I1=carry[16] I2=A[16]
XU27 ND2 $PINS O=n14 I1=B[16] I2=A[16]
XU28 ND3HT $PINS O=carry[17] I1=n13 I2=n12 I3=n14
XU29 XOR3S $PINS O=SUM[17] I1=B[17] I2=A[17] I3=carry[17]
XU30 ND3P $PINS O=carry[12] I1=n16 I2=n15 I3=n17
XU31 ND2P $PINS O=n15 I1=carry[11] I2=B[11]
XU32 ND2P $PINS O=n16 I1=carry[11] I2=A[11]
XU33 ND2 $PINS O=n17 I1=A[11] I2=B[11]
XU35 ND2P $PINS O=n19 I1=carry[13] I2=A[13]
XU36 ND2 $PINS O=n20 I1=A[13] I2=B[13]
XU37 ND2T $PINS O=n21 I1=carry[15] I2=B[15]
XU38 ND2T $PINS O=n22 I1=carry[15] I2=A[15]
XU39 ND2 $PINS O=n23 I1=B[15] I2=A[15]
XU40 ND3P $PINS O=carry[16] I1=n21 I2=n22 I3=n23
XU41 ND2P $PINS O=n24 I1=carry[17] I2=B[17]
XU42 ND2 $PINS O=n26 I1=B[17] I2=A[17]
XU43 XOR2HS $PINS O=SUM[0] I1=B[0] I2=A[0]
.ENDS

.SUBCKT PE_Shift_Add_2 rst_n en clear calc_done stage_sel x_in[16] x_in[15]
+ x_in[14] x_in[13] x_in[12] x_in[11] x_in[10] x_in[9] x_in[8] x_in[7] x_in[6]
+ x_in[5] x_in[4] x_in[3] x_in[2] x_in[1] x_in[0] sign1[1] sign1[0] sign2[1]
+ sign2[0] sign3[1] sign3[0] shf1[3] shf1[2] shf1[1] shf1[0] shf2[3] shf2[2]
+ shf2[1] shf2[0] shf3[3] shf3[2] shf3[1] shf3[0] y_out[16] y_out[15] y_out[14]
+ y_out[13] y_out[12] y_out[11] y_out[10] y_out[9] y_out[8] y_out[7] y_out[6]
+ y_out[5] y_out[4] y_out[3] y_out[2] y_out[1] y_out[0] i_rst_n FE_OFN9_i_rst_n
+ FE_OFN92_h21_1 FE_OFN95_h23_1 clk_clone2 clk_clone1 clk
XFE_PHC1317_next_acc_0 DELB $PINS O=FE_PHN1317_next_acc_0 I=next_acc[0]
XFE_PHC1281_N235 DELB $PINS O=N235 I=FE_PHN1281_N235
XFE_PHC1259_N236 DELB $PINS O=FE_PHN1259_N236 I=N236
XFE_PHC1240_N238 DELB $PINS O=FE_PHN1240_N238 I=N238
XFE_PHC1232_N243 DELB $PINS O=FE_PHN1232_N243 I=N243
XFE_PHC1226_N247 DELB $PINS O=N247 I=FE_PHN1226_N247
XFE_PHC1220_N239 DELB $PINS O=N239 I=FE_PHN1220_N239
XFE_PHC1213_N242 DELB $PINS O=FE_PHN1213_N242 I=N242
XFE_PHC1204_N245 DELB $PINS O=FE_PHN1204_N245 I=N245
XFE_PHC1192_N241 DELB $PINS O=FE_PHN1192_N241 I=N241
XFE_PHC1188_N246 DELB $PINS O=FE_PHN1188_N246 I=N246
XFE_PHC1145_acc_reg_15 DELB $PINS O=FE_PHN1145_acc_reg_15 I=acc_reg[15]
XFE_PHC1141_acc_reg_16 DELB $PINS O=acc_reg[16] I=FE_PHN1141_acc_reg_16
XFE_PHC1111_acc_reg_19 DELB $PINS O=FE_PHN1111_acc_reg_19 I=acc_reg[19]
XFE_PHC1027_acc_reg_25 DELC $PINS O=FE_PHN1027_acc_reg_25 I=acc_reg[25]
XFE_PHC1022_acc_reg_12 DELB $PINS O=FE_PHN1022_acc_reg_12 I=acc_reg[12]
XFE_PHC999_acc_reg_23 DELB $PINS O=FE_PHN999_acc_reg_23 I=acc_reg[23]
XFE_PHC868_acc_reg_24 DELB $PINS O=FE_PHN868_acc_reg_24 I=acc_reg[24]
XFE_PHC863_acc_reg_18 DELB $PINS O=FE_PHN863_acc_reg_18 I=acc_reg[18]
XFE_PHC824_N251 DELC $PINS O=FE_PHN824_N251 I=N251
XFE_PHC804_pe_i2_15 DELC $PINS O=y_out[15] I=FE_PHN804_pe_i2_15
XFE_PHC799_pe_i2_14 DELC $PINS O=y_out[14] I=FE_PHN799_pe_i2_14
XFE_PHC755_pe_i2_8 DELC $PINS O=y_out[8] I=FE_PHN755_pe_i2_8
XFE_PHC748_pe_i2_6 DELC $PINS O=y_out[6] I=FE_PHN748_pe_i2_6
XFE_PHC746_pe_i2_2 DELC $PINS O=y_out[2] I=FE_PHN746_pe_i2_2
XFE_PHC745_pe_i2_5 DELC $PINS O=y_out[5] I=FE_PHN745_pe_i2_5
XFE_PHC744_pe_i2_4 DELC $PINS O=y_out[4] I=FE_PHN744_pe_i2_4
XFE_PHC742_pe_i2_3 DELC $PINS O=y_out[3] I=FE_PHN742_pe_i2_3
XFE_RC_849_0 OA12 $PINS O=N96 A1=N69 B1=sign2[0] B2=FE_OFN325_s22_0
XFE_RC_836_0 AN2B1T $PINS O=term2_shifted[3] I1=sll_17/ML_int[2][3] B1=n114
XFE_RC_835_0 INV2 $PINS O=N98 I=FE_RN_397_0
XFE_RC_834_0 AOI22H $PINS O=FE_RN_397_0 A1=N71 A2=sign2[0] B1=term2_shifted[2]
+ B2=FE_OFN325_s22_0
XFE_RC_827_0 AN2B1T $PINS O=term3_shifted[4] I1=sll_18/ML_int[3][4]
+ B1=FE_RN_103_0
XFE_RC_804_0 OR3B2 $PINS O=FE_RN_383_0 I1=shf2[2] B1=n52 B2=sll_17/ML_int[2][4]
XFE_RC_803_0 OR3B2 $PINS O=FE_RN_384_0 I1=n112 B1=n52 B2=shf2[2]
XFE_RC_802_0 ND2 $PINS O=term2_shifted[4] I1=FE_RN_384_0 I2=FE_RN_383_0
XFE_RC_773_0 INV2 $PINS O=N155 I=FE_RN_368_0
XFE_RC_772_0 AOI22H $PINS O=FE_RN_368_0 A1=N128 A2=FE_OFN322_s23_0
+ B1=term3_shifted[4] B2=sign3[0]
XFE_RC_747_0 INV1S $PINS O=term2_shifted[9] I=FE_RN_356_0
XFE_RC_746_0 MXL2H $PINS OB=FE_RN_356_0 S=shf2[3] A=sll_17/ML_int[3][9]
+ B=sll_17/ML_int[3][1]
XFE_RC_676_0 INV2 $PINS O=FE_RN_325_0 I=sll_16/ML_int[2][2]
XFE_RC_675_0 NR2P $PINS O=term1_shifted[2] I1=n103 I2=FE_RN_325_0
XFE_RC_650_0 INV2 $PINS O=sll_17/ML_int[2][2] I=FE_RN_314_0
XFE_RC_649_0 MXL2HS $PINS OB=FE_RN_314_0 S=shf2[1] A=sll_17/ML_int[1][2]
+ B=sll_17/ML_int[1][0]
XFE_RC_648_0 INV2 $PINS O=N101 I=FE_RN_313_0
XFE_RC_647_0 AOI22H $PINS O=FE_RN_313_0 A1=N74 A2=FE_OFN326_s22_0
+ B1=term2_shifted[5] B2=FE_OFN325_s22_0
XFE_RC_641_0 INV1S $PINS O=sll_16/ML_int[1][9] I=FE_RN_311_0
XFE_RC_640_0 MXL2HS $PINS OB=FE_RN_311_0 S=FE_OFN258_h21_0 A=term1_in[9]
+ B=term1_in[8]
XFE_RC_609_0 AN2T $PINS O=term3_shifted[5] I1=sll_18/ML_int[3][5] I2=n25
XFE_RC_576_0 INV1S $PINS O=sll_16/ML_int[2][3] I=FE_RN_288_0
XFE_RC_575_0 MXL2HS $PINS OB=FE_RN_288_0 S=FE_OFN298_h21_1
+ A=sll_16/ML_int[1][3] B=sll_16/ML_int[1][1]
XFE_RC_542_0 AN2T $PINS O=term1_shifted[4] I1=sll_16/ML_int[3][4] I2=shf1[3]
XFE_RC_463_0 INV1S $PINS O=FE_RN_240_0 I=n52
XFE_RC_462_0 AN2B1T $PINS O=term2_shifted[5] I1=sll_17/ML_int[3][5]
+ B1=FE_RN_240_0
XFE_RC_445_0 INV1S $PINS O=FE_RN_232_0 I=FE_OFN92_h21_1
XFE_RC_444_0 AN4B1 $PINS O=term1_shifted[1] I1=shf1[2] I2=shf1[3]
+ I3=sll_16/ML_int[1][1] B1=FE_RN_232_0
XCTS_ccl_a_INV_CLK_G1_L8_36 INV3CK $PINS O=CTS_10 I=CTS_11
XCTS_ccl_a_INV_CLK_G1_L7_36 INV2CK $PINS O=CTS_11 I=CTS_12
XFE_RC_1544_0 INV1S $PINS O=FE_RN_347_0 I=sll_16/ML_int[2][5]
XFE_RC_1543_0 MXL2HS $PINS OB=sll_16/ML_int[3][5] S=n74 A=FE_RN_347_0 B=n4
XFE_RC_1284_0 INV1S $PINS O=FE_RN_204_0 I=sll_16/ML_int[2][4]
XFE_RC_1283_0 MXL2HS $PINS OB=sll_16/ML_int[3][4] S=n74 A=FE_RN_204_0 B=n101
XFE_RC_1248_0 NR2P $PINS O=term3_shifted[2] I1=n125 I2=n127
XFE_RC_1215_0 AN2 $PINS O=term1_shifted[5] I1=sll_16/ML_int[3][5] I2=shf1[3]
XFE_RC_1200_0 INV1S $PINS O=FE_RN_159_0 I=sll_18/ML_int[2][4]
XFE_RC_1199_0 MXL2HS $PINS OB=sll_18/ML_int[3][4] S=n22 A=FE_RN_159_0 B=n123
XFE_RC_1193_0 INV1S $PINS O=FE_RN_155_0 I=sll_17/ML_int[2][4]
XFE_RC_1192_0 MXL2HS $PINS OB=sll_17/ML_int[3][4] S=shf2[2] A=FE_RN_155_0
+ B=n112
XFE_RC_1092_0 INV1S $PINS O=FE_RN_103_0 I=n25
XFE_RC_979_0 ND2 $PINS O=FE_RN_48_0 I1=sll_16/ML_int[1][2] I2=FE_OFN298_h21_1
XFE_RC_978_0 INV1S $PINS O=FE_RN_49_0 I=FE_OFN298_h21_1
XFE_RC_977_0 ND2 $PINS O=FE_RN_50_0 I1=sll_16/ML_int[1][4] I2=FE_RN_49_0
XFE_RC_976_0 ND2S $PINS O=sll_16/ML_int[2][4] I1=FE_RN_50_0 I2=FE_RN_48_0
XFE_RC_20_0 OA12 $PINS O=N151 A1=N124 B1=FE_OFN322_s23_0 B2=sign3[0]
XFE_RC_14_0 OA12 $PINS O=N41 A1=N14 B1=n86 B2=FE_OFN150_s21_0
XFE_OFC627_s22_0 INV1S $PINS O=FE_OFN328_s22_0 I=FE_OFN63_s22_0
XFE_OFC625_s22_0 BUF1 $PINS O=FE_OFN326_s22_0 I=sign2[0]
XFE_OFC624_s22_0 INV1S $PINS O=FE_OFN325_s22_0 I=sign2[0]
XFE_OFC623_s22_0 BUF1 $PINS O=FE_OFN63_s22_0 I=sign2[0]
XFE_OFC612_sll_16_ML_int_2__3 INV1S $PINS O=n104 I=sll_16/ML_int[2][3]
XFE_OFC610_s23_0 INV2 $PINS O=FE_OFN322_s23_0 I=sign3[0]
XFE_OFC609_s23_0 INV1S $PINS O=n34 I=sign3[0]
XFE_OFC608_s23_0 BUF1 $PINS O=FE_OFN66_s23_0 I=sign3[0]
XFE_OFC587_sll_18_ML_int_2__3 INV2 $PINS O=n126 I=sll_18/ML_int[2][3]
XFE_OFC578_h23_1 BUF1 $PINS O=FE_OFN318_h23_1 I=shf3[1]
XFE_OFC534_h21_1 BUF1 $PINS O=FE_OFN298_h21_1 I=shf1[1]
XFE_OFC503_h23_3 INV1S $PINS O=n25 I=shf3[3]
XFE_OFC498_h21_2 INV1S $PINS O=n74 I=shf1[2]
XFE_OFC493_h21_3 INV1S $PINS O=n77 I=shf1[3]
XFE_OFC467_h21_0 BUF1 $PINS O=FE_OFN258_h21_0 I=shf1[0]
XFE_OFC455_s22_1 BUF1 $PINS O=FE_OFN246_s22_1 I=sign2[1]
XFE_OFC411_h23_0 INV1S $PINS O=n14 I=shf3[0]
XFE_OFC383_h22_0 BUF1 $PINS O=FE_OFN203_h22_0 I=shf2[0]
XFE_OFC382_h22_0 INV1S $PINS O=n40 I=shf2[0]
XFE_OFC378_h22_1 INV1S $PINS O=n43 I=shf2[1]
XFE_OFC316_h23_2 INV1S $PINS O=FE_OFN178_h23_2 I=n22
XFE_OFC315_h23_2 BUF2 $PINS O=n22 I=shf3[2]
XFE_OFC296_pe_clear_d1 INV2 $PINS O=n151 I=clear
XFE_OFC230_h22_3 INV1S $PINS O=n52 I=shf2[3]
XFE_OFC214_s21_0 INV1S $PINS O=FE_OFN151_s21_0 I=FE_OFN150_s21_0
XFE_OFC213_s21_0 INV2 $PINS O=FE_OFN150_s21_0 I=sign1[0]
XFE_OFC212_s21_0 BUF1 $PINS O=n86 I=sign1[0]
XFE_OFC180_s22_0 INV1S $PINS O=n61 I=FE_OFN328_s22_0
XU110 AO22 $PINS O=base_val[13] A1=acc_reg[13] A2=n151 B1=clear B2=stage_sel
XU111 AO22 $PINS O=N99 A1=N72 A2=FE_OFN326_s22_0 B1=term2_shifted[3]
+ B2=FE_OFN325_s22_0
XU115 AO22 $PINS O=N67 A1=FE_OFN151_s21_0 A2=N40 B1=term1_shifted[26]
+ B2=FE_OFN150_s21_0
XU135 AO22 $PINS O=N47 A1=N20 A2=n86 B1=term1_shifted[6] B2=FE_OFN150_s21_0
XU136 AO22 $PINS O=N46 A1=N19 A2=n86 B1=term1_shifted[5] B2=FE_OFN150_s21_0
XU137 AO22P $PINS O=N45 A1=N18 A2=n86 B1=term1_shifted[4] B2=FE_OFN150_s21_0
XU138 AO22 $PINS O=N44 A1=N17 A2=n86 B1=term1_shifted[3] B2=FE_OFN150_s21_0
XU142 AO22 $PINS O=N177 A1=n34 A2=N150 B1=term3_shifted[26] B2=FE_OFN66_s23_0
XU143 AO22 $PINS O=N176 A1=N149 A2=n34 B1=term3_shifted[25] B2=FE_OFN66_s23_0
XU144 AO22 $PINS O=N175 A1=N148 A2=n34 B1=term3_shifted[24] B2=FE_OFN66_s23_0
XU149 AO22 $PINS O=N170 A1=N143 A2=n34 B1=term3_shifted[19] B2=FE_OFN66_s23_0
XU150 AO22 $PINS O=N169 A1=N142 A2=n34 B1=term3_shifted[18] B2=FE_OFN66_s23_0
XU151 AO22 $PINS O=N168 A1=N141 A2=n34 B1=term3_shifted[17] B2=FE_OFN66_s23_0
XU154 AO22 $PINS O=N165 A1=N138 A2=n34 B1=term3_shifted[14] B2=FE_OFN66_s23_0
XU155 AO22 $PINS O=N164 A1=N137 A2=n34 B1=term3_shifted[13] B2=FE_OFN66_s23_0
XU156 AO22 $PINS O=N163 A1=N136 A2=FE_OFN322_s23_0 B1=term3_shifted[12]
+ B2=FE_OFN66_s23_0
XU157 AO22 $PINS O=N162 A1=N135 A2=FE_OFN322_s23_0 B1=term3_shifted[11]
+ B2=sign3[0]
XU158 AO22 $PINS O=N161 A1=N134 A2=FE_OFN322_s23_0 B1=term3_shifted[10]
+ B2=sign3[0]
XU159 AO22 $PINS O=N160 A1=N133 A2=FE_OFN322_s23_0 B1=term3_shifted[9]
+ B2=sign3[0]
XU160 AO22 $PINS O=N159 A1=N132 A2=FE_OFN322_s23_0 B1=term3_shifted[8]
+ B2=sign3[0]
XU162 AO22 $PINS O=N157 A1=N130 A2=FE_OFN322_s23_0 B1=term3_shifted[6]
+ B2=sign3[0]
XU163 AO22 $PINS O=N156 A1=N129 A2=FE_OFN322_s23_0 B1=term3_shifted[5]
+ B2=sign3[0]
XU165 AO22P $PINS O=N154 A1=N127 A2=FE_OFN322_s23_0 B1=term3_shifted[3]
+ B2=sign3[0]
XU169 AO22 $PINS O=N122 A1=N95 A2=n61 B1=term2_shifted[26] B2=FE_OFN328_s22_0
XU170 AO22 $PINS O=N121 A1=N94 A2=n61 B1=term2_shifted[25] B2=FE_OFN328_s22_0
XU172 AO22 $PINS O=N119 A1=N92 A2=n61 B1=term2_shifted[23] B2=FE_OFN328_s22_0
XU173 AO22 $PINS O=N118 A1=N91 A2=n61 B1=term2_shifted[22] B2=FE_OFN328_s22_0
XU174 AO22 $PINS O=N117 A1=N90 A2=n61 B1=term2_shifted[21] B2=FE_OFN328_s22_0
XU175 AO22 $PINS O=N116 A1=N89 A2=n61 B1=term2_shifted[20] B2=FE_OFN328_s22_0
XU176 AO22 $PINS O=N115 A1=N88 A2=n61 B1=term2_shifted[19] B2=FE_OFN328_s22_0
XU177 AO22 $PINS O=N114 A1=N87 A2=n61 B1=term2_shifted[18] B2=FE_OFN328_s22_0
XU178 AO22 $PINS O=N113 A1=N86 A2=n61 B1=term2_shifted[17] B2=FE_OFN328_s22_0
XU179 AO22 $PINS O=N112 A1=N85 A2=FE_OFN63_s22_0 B1=term2_shifted[16]
+ B2=FE_OFN328_s22_0
XU180 AO22 $PINS O=N111 A1=N84 A2=FE_OFN63_s22_0 B1=term2_shifted[15]
+ B2=FE_OFN328_s22_0
XU181 AO22 $PINS O=N110 A1=N83 A2=FE_OFN63_s22_0 B1=term2_shifted[14]
+ B2=FE_OFN328_s22_0
XU183 AO22 $PINS O=N108 A1=N81 A2=FE_OFN63_s22_0 B1=term2_shifted[12]
+ B2=FE_OFN325_s22_0
XU184 AO22 $PINS O=N107 A1=N80 A2=FE_OFN63_s22_0 B1=term2_shifted[11]
+ B2=FE_OFN325_s22_0
XU185 AO22 $PINS O=N106 A1=N79 A2=FE_OFN326_s22_0 B1=term2_shifted[10]
+ B2=FE_OFN325_s22_0
XU187 AO22 $PINS O=N104 A1=N77 A2=FE_OFN326_s22_0 B1=term2_shifted[8]
+ B2=FE_OFN325_s22_0
XU189 AO22 $PINS O=N102 A1=N75 A2=FE_OFN326_s22_0 B1=term2_shifted[6]
+ B2=FE_OFN325_s22_0
XU191 AO22 $PINS O=N100 A1=N73 A2=FE_OFN326_s22_0 B1=term2_shifted[4]
+ B2=FE_OFN325_s22_0
Xsll_18/M1_0_1 MUX2 $PINS O=sll_18/ML_int[1][1] S=shf3[0] A=term3_in[1]
+ B=term3_in[0]
Xsll_18/M1_0_3 MUX2 $PINS O=sll_18/ML_int[1][3] S=shf3[0] A=term3_in[3]
+ B=term3_in[2]
Xsll_18/M1_0_4 MUX2 $PINS O=sll_18/ML_int[1][4] S=shf3[0] A=term3_in[4]
+ B=term3_in[3]
Xsll_18/M1_0_6 MUX2 $PINS O=sll_18/ML_int[1][6] S=shf3[0] A=term3_in[6]
+ B=term3_in[5]
Xsll_18/M1_0_7 MUX2 $PINS O=sll_18/ML_int[1][7] S=shf3[0] A=term3_in[7]
+ B=term3_in[6]
Xsll_18/M1_0_9 MUX2 $PINS O=sll_18/ML_int[1][9] S=shf3[0] A=term3_in[9]
+ B=term3_in[8]
Xsll_18/M1_0_12 MUX2 $PINS O=sll_18/ML_int[1][12] S=shf3[0] A=term3_in[12]
+ B=term3_in[11]
Xsll_18/M1_1_2 MUX2 $PINS O=sll_18/ML_int[2][2] S=FE_OFN318_h23_1
+ A=sll_18/ML_int[1][2] B=sll_18/ML_int[1][0]
Xsll_18/M1_1_3 MUX2 $PINS O=sll_18/ML_int[2][3] S=FE_OFN318_h23_1
+ A=sll_18/ML_int[1][3] B=sll_18/ML_int[1][1]
Xsll_18/M1_1_4 MUX2 $PINS O=sll_18/ML_int[2][4] S=FE_OFN318_h23_1
+ A=sll_18/ML_int[1][4] B=sll_18/ML_int[1][2]
Xsll_18/M1_1_5 MUX2 $PINS O=sll_18/ML_int[2][5] S=FE_OFN318_h23_1
+ A=sll_18/ML_int[1][5] B=sll_18/ML_int[1][3]
Xsll_18/M1_1_6 MUX2 $PINS O=sll_18/ML_int[2][6] S=FE_OFN318_h23_1
+ A=sll_18/ML_int[1][6] B=sll_18/ML_int[1][4]
Xsll_18/M1_1_7 MUX2 $PINS O=sll_18/ML_int[2][7] S=FE_OFN318_h23_1
+ A=sll_18/ML_int[1][7] B=sll_18/ML_int[1][5]
Xsll_18/M1_1_8 MUX2 $PINS O=sll_18/ML_int[2][8] S=FE_OFN318_h23_1
+ A=sll_18/ML_int[1][8] B=sll_18/ML_int[1][6]
Xsll_18/M1_2_5 MUX2 $PINS O=sll_18/ML_int[3][5] S=n22 A=sll_18/ML_int[2][5]
+ B=n129
Xsll_18/M1_2_6 MUX2 $PINS O=sll_18/ML_int[3][6] S=n22 A=sll_18/ML_int[2][6]
+ B=sll_18/ML_int[2][2]
Xsll_18/M1_2_7 MUX2 $PINS O=sll_18/ML_int[3][7] S=n22 A=sll_18/ML_int[2][7]
+ B=sll_18/ML_int[2][3]
Xsll_18/M1_2_8 MUX2 $PINS O=sll_18/ML_int[3][8] S=n22 A=sll_18/ML_int[2][8]
+ B=sll_18/ML_int[2][4]
Xsll_18/M1_2_9 MUX2 $PINS O=sll_18/ML_int[3][9] S=n22 A=sll_18/ML_int[2][9]
+ B=sll_18/ML_int[2][5]
Xsll_18/M1_2_10 MUX2 $PINS O=sll_18/ML_int[3][10] S=n22 A=sll_18/ML_int[2][10]
+ B=sll_18/ML_int[2][6]
Xsll_18/M1_2_19 MUX2 $PINS O=sll_18/ML_int[3][19] S=n22 A=n7
+ B=sll_18/ML_int[2][15]
Xsll_18/M1_3_8 MUX2 $PINS O=term3_shifted[8] S=FE_RN_103_0
+ A=sll_18/ML_int[3][8] B=sll_18/ML_int[3][0]
Xsll_18/M1_3_9 MUX2 $PINS O=term3_shifted[9] S=FE_RN_103_0
+ A=sll_18/ML_int[3][9] B=sll_18/ML_int[3][1]
Xsll_18/M1_3_10 MUX2 $PINS O=term3_shifted[10] S=FE_RN_103_0
+ A=sll_18/ML_int[3][10] B=sll_18/ML_int[3][2]
Xsll_18/M1_3_11 MUX2 $PINS O=term3_shifted[11] S=FE_RN_103_0
+ A=sll_18/ML_int[3][11] B=sll_18/ML_int[3][3]
Xsll_18/M1_3_12 MUX2 $PINS O=term3_shifted[12] S=FE_RN_103_0
+ A=sll_18/ML_int[3][12] B=sll_18/ML_int[3][4]
Xsll_18/M1_3_13 MUX2 $PINS O=term3_shifted[13] S=FE_RN_103_0
+ A=sll_18/ML_int[3][13] B=sll_18/ML_int[3][5]
Xsll_18/M1_3_14 MUX2 $PINS O=term3_shifted[14] S=FE_RN_103_0
+ A=sll_18/ML_int[3][14] B=sll_18/ML_int[3][6]
Xsll_18/M1_3_15 MUX2 $PINS O=term3_shifted[15] S=FE_RN_103_0
+ A=sll_18/ML_int[3][15] B=sll_18/ML_int[3][7]
Xsll_18/M1_3_22 MUX2 $PINS O=term3_shifted[22] S=FE_RN_103_0
+ A=sll_18/ML_int[3][22] B=sll_18/ML_int[3][14]
Xsll_18/M1_3_23 MUX2 $PINS O=term3_shifted[23] S=FE_RN_103_0 A=n7
+ B=sll_18/ML_int[3][15]
Xsll_17/M1_0_1 MUX2 $PINS O=sll_17/ML_int[1][1] S=shf2[0] A=term2_in[1]
+ B=term2_in[0]
Xsll_17/M1_0_4 MUX2 $PINS O=sll_17/ML_int[1][4] S=FE_OFN203_h22_0 A=term2_in[4]
+ B=term2_in[3]
Xsll_17/M1_0_9 MUX2 $PINS O=sll_17/ML_int[1][9] S=FE_OFN203_h22_0 A=term2_in[9]
+ B=term2_in[8]
Xsll_17/M1_0_12 MUX2 $PINS O=sll_17/ML_int[1][12] S=FE_OFN203_h22_0
+ A=term2_in[12] B=term2_in[11]
Xsll_17/M1_1_4 MUX2 $PINS O=sll_17/ML_int[2][4] S=shf2[1] A=sll_17/ML_int[1][4]
+ B=sll_17/ML_int[1][2]
Xsll_17/M1_1_5 MUX2 $PINS O=sll_17/ML_int[2][5] S=shf2[1] A=sll_17/ML_int[1][5]
+ B=sll_17/ML_int[1][3]
Xsll_17/M1_1_6 MUX2 $PINS O=sll_17/ML_int[2][6] S=shf2[1] A=sll_17/ML_int[1][6]
+ B=sll_17/ML_int[1][4]
Xsll_17/M1_1_7 MUX2 $PINS O=sll_17/ML_int[2][7] S=shf2[1] A=sll_17/ML_int[1][7]
+ B=sll_17/ML_int[1][5]
Xsll_17/M1_1_8 MUX2 $PINS O=sll_17/ML_int[2][8] S=shf2[1] A=sll_17/ML_int[1][8]
+ B=sll_17/ML_int[1][6]
Xsll_17/M1_2_5 MUX2 $PINS O=sll_17/ML_int[3][5] S=shf2[2] A=sll_17/ML_int[2][5]
+ B=n118
Xsll_17/M1_2_6 MUX2 $PINS O=sll_17/ML_int[3][6] S=shf2[2] A=sll_17/ML_int[2][6]
+ B=sll_17/ML_int[2][2]
Xsll_17/M1_2_7 MUX2 $PINS O=sll_17/ML_int[3][7] S=shf2[2] A=sll_17/ML_int[2][7]
+ B=sll_17/ML_int[2][3]
Xsll_17/M1_2_8 MUX2 $PINS O=sll_17/ML_int[3][8] S=shf2[2] A=sll_17/ML_int[2][8]
+ B=sll_17/ML_int[2][4]
Xsll_17/M1_2_9 MUX2 $PINS O=sll_17/ML_int[3][9] S=shf2[2] A=sll_17/ML_int[2][9]
+ B=sll_17/ML_int[2][5]
Xsll_17/M1_2_10 MUX2 $PINS O=sll_17/ML_int[3][10] S=shf2[2]
+ A=sll_17/ML_int[2][10] B=sll_17/ML_int[2][6]
Xsll_17/M1_2_19 MUX2 $PINS O=sll_17/ML_int[3][19] S=shf2[2] A=term2_in[26]
+ B=sll_17/ML_int[2][15]
Xsll_17/M1_3_8 MUX2 $PINS O=term2_shifted[8] S=shf2[3] A=sll_17/ML_int[3][8]
+ B=sll_17/ML_int[3][0]
Xsll_17/M1_3_10 MUX2 $PINS O=term2_shifted[10] S=shf2[3] A=sll_17/ML_int[3][10]
+ B=sll_17/ML_int[3][2]
Xsll_17/M1_3_11 MUX2 $PINS O=term2_shifted[11] S=shf2[3] A=sll_17/ML_int[3][11]
+ B=sll_17/ML_int[3][3]
Xsll_17/M1_3_12 MUX2 $PINS O=term2_shifted[12] S=shf2[3] A=sll_17/ML_int[3][12]
+ B=sll_17/ML_int[3][4]
Xsll_17/M1_3_13 MUX2 $PINS O=term2_shifted[13] S=shf2[3] A=sll_17/ML_int[3][13]
+ B=sll_17/ML_int[3][5]
Xsll_17/M1_3_14 MUX2 $PINS O=term2_shifted[14] S=shf2[3] A=sll_17/ML_int[3][14]
+ B=sll_17/ML_int[3][6]
Xsll_17/M1_3_22 MUX2 $PINS O=term2_shifted[22] S=shf2[3] A=sll_17/ML_int[3][22]
+ B=sll_17/ML_int[3][14]
Xsll_17/M1_3_23 MUX2 $PINS O=term2_shifted[23] S=shf2[3] A=term2_in[26]
+ B=sll_17/ML_int[3][15]
Xsll_16/M1_0_1 MUX2 $PINS O=sll_16/ML_int[1][1] S=FE_OFN258_h21_0 A=term1_in[1]
+ B=term1_in[0]
Xsll_16/M1_0_2 MUX2 $PINS O=sll_16/ML_int[1][2] S=FE_OFN258_h21_0 A=term1_in[2]
+ B=term1_in[1]
Xsll_16/M1_0_4 MUX2 $PINS O=sll_16/ML_int[1][4] S=FE_OFN258_h21_0 A=term1_in[4]
+ B=term1_in[3]
Xsll_16/M1_0_5 MUX2 $PINS O=sll_16/ML_int[1][5] S=FE_OFN258_h21_0 A=term1_in[5]
+ B=term1_in[4]
Xsll_16/M1_0_6 MUX2 $PINS O=sll_16/ML_int[1][6] S=FE_OFN258_h21_0 A=term1_in[6]
+ B=term1_in[5]
Xsll_16/M1_0_7 MUX2 $PINS O=sll_16/ML_int[1][7] S=FE_OFN258_h21_0 A=term1_in[7]
+ B=term1_in[6]
Xsll_16/M1_0_12 MUX2 $PINS O=sll_16/ML_int[1][12] S=FE_OFN258_h21_0
+ A=term1_in[12] B=term1_in[11]
Xsll_16/M1_1_2 MUX2 $PINS O=sll_16/ML_int[2][2] S=FE_OFN298_h21_1
+ A=sll_16/ML_int[1][2] B=sll_16/ML_int[1][0]
Xsll_16/M1_1_5 MUX2 $PINS O=sll_16/ML_int[2][5] S=FE_OFN298_h21_1
+ A=sll_16/ML_int[1][5] B=sll_16/ML_int[1][3]
Xsll_16/M1_1_6 MUX2 $PINS O=sll_16/ML_int[2][6] S=FE_OFN298_h21_1
+ A=sll_16/ML_int[1][6] B=sll_16/ML_int[1][4]
Xsll_16/M1_1_7 MUX2 $PINS O=sll_16/ML_int[2][7] S=FE_OFN298_h21_1
+ A=sll_16/ML_int[1][7] B=sll_16/ML_int[1][5]
Xsll_16/M1_1_8 MUX2 $PINS O=sll_16/ML_int[2][8] S=FE_OFN298_h21_1
+ A=sll_16/ML_int[1][8] B=sll_16/ML_int[1][6]
Xsll_16/M1_2_6 MUX2 $PINS O=sll_16/ML_int[3][6] S=n74 A=sll_16/ML_int[2][6]
+ B=sll_16/ML_int[2][2]
Xsll_16/M1_2_7 MUX2 $PINS O=sll_16/ML_int[3][7] S=n74 A=sll_16/ML_int[2][7]
+ B=sll_16/ML_int[2][3]
Xsll_16/M1_2_8 MUX2 $PINS O=sll_16/ML_int[3][8] S=n74 A=sll_16/ML_int[2][8]
+ B=sll_16/ML_int[2][4]
Xsll_16/M1_2_9 MUX2 $PINS O=sll_16/ML_int[3][9] S=n74 A=sll_16/ML_int[2][9]
+ B=sll_16/ML_int[2][5]
Xsll_16/M1_2_10 MUX2 $PINS O=sll_16/ML_int[3][10] S=n74 A=sll_16/ML_int[2][10]
+ B=sll_16/ML_int[2][6]
Xsll_16/M1_2_19 MUX2 $PINS O=sll_16/ML_int[3][19] S=n74 A=n5
+ B=sll_16/ML_int[2][15]
Xsll_16/M1_3_8 MUX2 $PINS O=term1_shifted[8] S=n77 A=sll_16/ML_int[3][8]
+ B=sll_16/ML_int[3][0]
Xsll_16/M1_3_9 MUX2 $PINS O=term1_shifted[9] S=n77 A=sll_16/ML_int[3][9]
+ B=sll_16/ML_int[3][1]
Xsll_16/M1_3_10 MUX2 $PINS O=term1_shifted[10] S=n77 A=sll_16/ML_int[3][10]
+ B=sll_16/ML_int[3][2]
Xsll_16/M1_3_11 MUX2 $PINS O=term1_shifted[11] S=n77 A=sll_16/ML_int[3][11]
+ B=sll_16/ML_int[3][3]
Xsll_16/M1_3_12 MUX2 $PINS O=term1_shifted[12] S=n77 A=sll_16/ML_int[3][12]
+ B=sll_16/ML_int[3][4]
Xsll_16/M1_3_13 MUX2 $PINS O=term1_shifted[13] S=n77 A=sll_16/ML_int[3][13]
+ B=sll_16/ML_int[3][5]
Xsll_16/M1_3_14 MUX2 $PINS O=term1_shifted[14] S=n77 A=sll_16/ML_int[3][14]
+ B=sll_16/ML_int[3][6]
Xsll_16/M1_3_22 MUX2 $PINS O=term1_shifted[22] S=n77 A=sll_16/ML_int[3][22]
+ B=sll_16/ML_int[3][14]
Xsll_16/M1_3_23 MUX2 $PINS O=term1_shifted[23] S=n77 A=n5
+ B=sll_16/ML_int[3][15]
Xacc_reg_reg[26] QDFFRBS $PINS Q=N251 D=next_acc[26] CK=clk RB=i_rst_n
Xacc_reg_reg[25] QDFFRBN $PINS Q=acc_reg[25] D=next_acc[25] CK=clk RB=i_rst_n
Xacc_reg_reg[24] QDFFRBN $PINS Q=acc_reg[24] D=next_acc[24] CK=clk
+ RB=FE_OFN9_i_rst_n
Xacc_reg_reg[23] QDFFRBN $PINS Q=acc_reg[23] D=next_acc[23] CK=clk
+ RB=FE_OFN9_i_rst_n
Xacc_reg_reg[22] QDFFRBN $PINS Q=acc_reg[22] D=next_acc[22] CK=clk
+ RB=FE_OFN9_i_rst_n
Xacc_reg_reg[21] QDFFRBN $PINS Q=acc_reg[21] D=next_acc[21] CK=clk RB=i_rst_n
Xacc_reg_reg[20] QDFFRBN $PINS Q=acc_reg[20] D=next_acc[20] CK=clk RB=i_rst_n
Xacc_reg_reg[19] QDFFRBN $PINS Q=acc_reg[19] D=next_acc[19] CK=clk
+ RB=FE_OFN9_i_rst_n
Xacc_reg_reg[18] QDFFRBN $PINS Q=acc_reg[18] D=next_acc[18] CK=clk
+ RB=FE_OFN9_i_rst_n
Xacc_reg_reg[17] QDFFRBN $PINS Q=acc_reg[17] D=next_acc[17] CK=clk_clone2
+ RB=FE_OFN9_i_rst_n
Xacc_reg_reg[16] QDFFRBN $PINS Q=FE_PHN1141_acc_reg_16 D=next_acc[16]
+ CK=clk_clone2 RB=FE_OFN9_i_rst_n
Xacc_reg_reg[15] QDFFRBN $PINS Q=acc_reg[15] D=next_acc[15] CK=clk_clone2
+ RB=FE_OFN9_i_rst_n
Xacc_reg_reg[14] QDFFRBN $PINS Q=acc_reg[14] D=next_acc[14] CK=clk
+ RB=FE_OFN9_i_rst_n
Xacc_reg_reg[13] QDFFRBN $PINS Q=acc_reg[13] D=next_acc[13] CK=clk
+ RB=FE_OFN9_i_rst_n
Xacc_reg_reg[12] QDFFRBN $PINS Q=acc_reg[12] D=next_acc[12] CK=clk_clone2
+ RB=FE_OFN9_i_rst_n
Xacc_reg_reg[11] QDFFRBN $PINS Q=acc_reg[11] D=next_acc[11] CK=clk_clone2
+ RB=FE_OFN9_i_rst_n
Xacc_reg_reg[10] QDFFRBN $PINS Q=acc_reg[10] D=next_acc[10] CK=clk_clone2
+ RB=FE_OFN9_i_rst_n
Xacc_reg_reg[9] QDFFRBN $PINS Q=acc_reg[9] D=next_acc[9] CK=clk_clone2
+ RB=FE_OFN9_i_rst_n
Xacc_reg_reg[8] QDFFRBN $PINS Q=acc_reg[8] D=next_acc[8] CK=clk_clone2
+ RB=FE_OFN9_i_rst_n
Xacc_reg_reg[7] QDFFRBN $PINS Q=acc_reg[7] D=next_acc[7] CK=clk_clone2
+ RB=FE_OFN9_i_rst_n
Xacc_reg_reg[6] QDFFRBN $PINS Q=acc_reg[6] D=next_acc[6] CK=clk_clone2
+ RB=FE_OFN9_i_rst_n
Xacc_reg_reg[5] QDFFRBN $PINS Q=acc_reg[5] D=next_acc[5] CK=clk_clone2
+ RB=FE_OFN9_i_rst_n
Xacc_reg_reg[4] QDFFRBN $PINS Q=acc_reg[4] D=next_acc[4] CK=clk_clone2
+ RB=FE_OFN9_i_rst_n
Xacc_reg_reg[3] QDFFRBN $PINS Q=acc_reg[3] D=next_acc[3] CK=clk_clone2
+ RB=FE_OFN9_i_rst_n
Xacc_reg_reg[2] QDFFRBN $PINS Q=acc_reg[2] D=next_acc[2] CK=clk_clone2
+ RB=FE_OFN9_i_rst_n
Xacc_reg_reg[0] QDFFRBN $PINS Q=acc_reg[0] D=FE_PHN1317_next_acc_0
+ CK=clk_clone2 RB=FE_OFN9_i_rst_n
Xacc_reg_reg[1] QDFFRBN $PINS Q=acc_reg[1] D=next_acc[1] CK=clk_clone2
+ RB=FE_OFN9_i_rst_n
Xy_out_reg[16] QDFFRBN $PINS Q=y_out[16] D=FE_PHN824_N251 CK=CTS_10 RB=i_rst_n
Xy_out_reg[15] QDFFRBN $PINS Q=FE_PHN804_pe_i2_15 D=N250 CK=CTS_10 RB=i_rst_n
Xy_out_reg[14] QDFFRBN $PINS Q=FE_PHN799_pe_i2_14 D=N249 CK=CTS_10 RB=i_rst_n
Xy_out_reg[13] QDFFRBN $PINS Q=y_out[13] D=N248 CK=CTS_10 RB=i_rst_n
Xy_out_reg[12] QDFFRBN $PINS Q=y_out[12] D=N247 CK=CTS_10 RB=i_rst_n
Xy_out_reg[11] QDFFRBN $PINS Q=y_out[11] D=FE_PHN1188_N246 CK=CTS_10 RB=i_rst_n
Xy_out_reg[10] QDFFRBN $PINS Q=y_out[10] D=FE_PHN1204_N245 CK=CTS_10 RB=i_rst_n
Xy_out_reg[9] QDFFRBN $PINS Q=y_out[9] D=N244 CK=CTS_10 RB=i_rst_n
Xy_out_reg[8] QDFFRBN $PINS Q=FE_PHN755_pe_i2_8 D=FE_PHN1232_N243 CK=CTS_10
+ RB=i_rst_n
Xy_out_reg[7] QDFFRBN $PINS Q=y_out[7] D=FE_PHN1213_N242 CK=CTS_10 RB=i_rst_n
Xy_out_reg[6] QDFFRBN $PINS Q=FE_PHN748_pe_i2_6 D=FE_PHN1192_N241 CK=CTS_10
+ RB=i_rst_n
Xy_out_reg[5] QDFFRBN $PINS Q=FE_PHN745_pe_i2_5 D=N240 CK=CTS_10 RB=i_rst_n
Xy_out_reg[4] QDFFRBN $PINS Q=FE_PHN744_pe_i2_4 D=N239 CK=CTS_10 RB=i_rst_n
Xy_out_reg[3] QDFFRBN $PINS Q=FE_PHN742_pe_i2_3 D=FE_PHN1240_N238 CK=CTS_10
+ RB=i_rst_n
Xy_out_reg[2] QDFFRBN $PINS Q=FE_PHN746_pe_i2_2 D=N237 CK=CTS_10 RB=i_rst_n
Xy_out_reg[1] QDFFRBN $PINS Q=y_out[1] D=FE_PHN1259_N236 CK=CTS_10 RB=i_rst_n
Xy_out_reg[0] QDFFRBN $PINS Q=y_out[0] D=N235 CK=CTS_10 RB=i_rst_n
XU3 NR2P $PINS O=term2_shifted[1] I1=n114 I2=n113
XU7 ND2 $PINS O=n124 I1=sll_18/ML_int[1][1] I2=FE_OFN95_h23_1
XU9 NR2P $PINS O=term1_shifted[0] I1=n103 I2=n101
XU16 INV1S $PINS O=n8 I=N125
XU19 MUX2 $PINS O=FE_PHN1226_N247 S=stage_sel A=acc_reg[22] B=FE_PHN824_N251
XU20 NR2 $PINS O=term1_in[0] I1=sign1[1] I2=x_in[0]
XU21 MUX2 $PINS O=N248 S=stage_sel A=FE_PHN999_acc_reg_23 B=FE_PHN824_N251
XU23 MUX2 $PINS O=N249 S=stage_sel A=FE_PHN868_acc_reg_24 B=FE_PHN824_N251
XU27 MUX2 $PINS O=N250 S=stage_sel A=FE_PHN1027_acc_reg_25 B=FE_PHN824_N251
XU32 MUX2 $PINS O=sll_17/ML_int[2][3] S=shf2[1] A=sll_17/ML_int[1][3]
+ B=sll_17/ML_int[1][1]
XU38 ND2P $PINS O=n113 I1=sll_17/ML_int[1][1] I2=n43
XU43 NR2 $PINS O=term3_in[1] I1=sign3[1] I2=x_in[1]
XU46 AO22 $PINS O=N51 A1=n86 A2=N24 B1=term1_shifted[10] B2=FE_OFN150_s21_0
XU47 AO22 $PINS O=N58 A1=N31 A2=sign1[0] B1=term1_shifted[17]
+ B2=FE_OFN150_s21_0
XU49 ND2 $PINS O=n101 I1=sll_16/ML_int[1][0] I2=FE_OFN92_h21_1
XU51 NR2P $PINS O=term2_in[0] I1=sign2[1] I2=x_in[0]
XU54 MUX2S $PINS O=sll_17/ML_int[1][6] S=FE_OFN203_h22_0 A=term2_in[6]
+ B=term2_in[5]
XU55 MUX2 $PINS O=sll_17/ML_int[1][7] S=FE_OFN203_h22_0 A=term2_in[7]
+ B=term2_in[6]
XU56 NR2 $PINS O=term2_in[4] I1=sign2[1] I2=x_in[4]
XU65 AO22 $PINS O=N53 A1=N26 A2=n86 B1=term1_shifted[12] B2=FE_OFN150_s21_0
XU66 AO22 $PINS O=N55 A1=N28 A2=n86 B1=term1_shifted[14] B2=FE_OFN150_s21_0
XU69 AO22 $PINS O=N56 A1=N29 A2=n86 B1=term1_shifted[15] B2=FE_OFN150_s21_0
XU70 AO22 $PINS O=N166 A1=N139 A2=n34 B1=term3_shifted[15] B2=FE_OFN66_s23_0
XU73 AO22 $PINS O=N54 A1=N27 A2=n86 B1=term1_shifted[13] B2=FE_OFN150_s21_0
XU74 AO22 $PINS O=N109 A1=N82 A2=FE_OFN63_s22_0 B1=term2_shifted[13]
+ B2=FE_OFN328_s22_0
XU75 AO22 $PINS O=N59 A1=N32 A2=sign1[0] B1=term1_shifted[18]
+ B2=FE_OFN150_s21_0
XU78 NR2 $PINS O=term1_in[2] I1=sign1[1] I2=x_in[2]
XU79 NR2 $PINS O=term3_in[2] I1=sign3[1] I2=x_in[2]
XU88 AO22P $PINS O=N103 A1=FE_OFN326_s22_0 A2=N76 B1=term2_shifted[7]
+ B2=FE_OFN325_s22_0
XU89 AN2 $PINS O=base_val[7] I1=acc_reg[7] I2=n151
XU90 AO22 $PINS O=N48 A1=N21 A2=n86 B1=term1_shifted[7] B2=FE_OFN150_s21_0
XU91 AO22 $PINS O=N158 A1=N131 A2=FE_OFN322_s23_0 B1=term3_shifted[7]
+ B2=sign3[0]
XU92 AO22 $PINS O=N105 A1=FE_OFN326_s22_0 A2=N78 B1=term2_shifted[9]
+ B2=FE_OFN325_s22_0
XU93 MOAI1S $PINS O=base_val[9] A1=stage_sel A2=n151 B1=acc_reg[9] B2=n151
XU94 AO22 $PINS O=N57 A1=N30 A2=n86 B1=term1_shifted[16] B2=FE_OFN150_s21_0
XU95 AO22 $PINS O=N167 A1=N140 A2=n34 B1=term3_shifted[16] B2=FE_OFN66_s23_0
XU96 AO22 $PINS O=N42 A1=N15 A2=n86 B1=term1_shifted[1] B2=FE_OFN150_s21_0
XU97 AO22 $PINS O=N43 A1=N16 A2=n86 B1=term1_shifted[2] B2=FE_OFN150_s21_0
XU98 AO22 $PINS O=N52 A1=N25 A2=n86 B1=term1_shifted[11] B2=FE_OFN150_s21_0
XU99 AO22 $PINS O=N120 A1=N93 A2=n61 B1=term2_shifted[24] B2=FE_OFN328_s22_0
XU100 AN2 $PINS O=base_val[24] I1=acc_reg[24] I2=n151
XU113 MUX2 $PINS O=sll_17/ML_int[1][5] S=FE_OFN203_h22_0 A=term2_in[5]
+ B=term2_in[4]
XU116 MUX2 $PINS O=sll_18/ML_int[1][5] S=shf3[0] A=term3_in[5] B=term3_in[4]
XU118 MUX2 $PINS O=sll_16/ML_int[1][3] S=FE_OFN258_h21_0 A=term1_in[3]
+ B=term1_in[2]
XU119 MUX2 $PINS O=sll_18/ML_int[1][2] S=shf3[0] A=term3_in[2] B=term3_in[1]
XU120 NR2 $PINS O=n5 I1=n140 I2=sign1[1]
XU121 MUX2S $PINS O=n111 S=FE_OFN258_h21_0 A=term1_in[26] B=term1_in[15]
XU123 MUX2S $PINS O=n122 S=FE_OFN203_h22_0 A=term2_in[26] B=term2_in[15]
XU124 AO22S $PINS O=N171 A1=N144 A2=n34 B1=term3_shifted[20] B2=FE_OFN66_s23_0
XU125 AO22S $PINS O=N172 A1=N145 A2=n34 B1=term3_shifted[21] B2=FE_OFN66_s23_0
XU126 AO22S $PINS O=N173 A1=N146 A2=n34 B1=term3_shifted[22] B2=FE_OFN66_s23_0
XU127 AO22S $PINS O=N174 A1=N147 A2=n34 B1=term3_shifted[23] B2=FE_OFN66_s23_0
XU128 NR2 $PINS O=n7 I1=n140 I2=sign3[1]
XU129 MUX2S $PINS O=n132 S=FE_OFN95_h23_1 A=n133 B=term3_in[26]
XU130 AO22 $PINS O=N60 A1=N33 A2=FE_OFN151_s21_0 B1=term1_shifted[19]
+ B2=FE_OFN150_s21_0
XU131 AO22 $PINS O=N49 A1=N22 A2=n86 B1=term1_shifted[8] B2=FE_OFN150_s21_0
XU132 AO22 $PINS O=N50 A1=n86 A2=N23 B1=term1_shifted[9] B2=FE_OFN150_s21_0
XU133 AN2 $PINS O=term3_shifted[7] I1=sll_18/ML_int[3][7] I2=n25
XU145 MUX2S $PINS O=sll_16/ML_int[2][9] S=FE_OFN298_h21_1 A=sll_16/ML_int[1][9]
+ B=sll_16/ML_int[1][7]
XU146 MUX2 $PINS O=sll_17/ML_int[2][9] S=shf2[1] A=sll_17/ML_int[1][9]
+ B=sll_17/ML_int[1][7]
XU147 MUX2S $PINS O=sll_18/ML_int[2][9] S=FE_OFN318_h23_1 A=sll_18/ML_int[1][9]
+ B=sll_18/ML_int[1][7]
XU148 MUX2 $PINS O=sll_16/ML_int[1][8] S=FE_OFN258_h21_0 A=term1_in[8]
+ B=term1_in[7]
XU152 MUX2 $PINS O=sll_17/ML_int[1][8] S=FE_OFN203_h22_0 A=term2_in[8]
+ B=term2_in[7]
XU153 MUX2 $PINS O=sll_18/ML_int[1][8] S=shf3[0] A=term3_in[8] B=term3_in[7]
XU161 MUX2S $PINS O=sll_16/ML_int[2][10] S=FE_OFN298_h21_1
+ A=sll_16/ML_int[1][10] B=sll_16/ML_int[1][8]
XU164 MUX2S $PINS O=sll_16/ML_int[1][10] S=FE_OFN258_h21_0 A=term1_in[10]
+ B=term1_in[9]
XU166 MUX2S $PINS O=sll_18/ML_int[2][10] S=FE_OFN318_h23_1
+ A=sll_18/ML_int[1][10] B=sll_18/ML_int[1][8]
XU167 MUX2S $PINS O=sll_18/ML_int[1][10] S=shf3[0] A=term3_in[10] B=term3_in[9]
XU171 MUX2S $PINS O=sll_17/ML_int[2][10] S=shf2[1] A=sll_17/ML_int[1][10]
+ B=sll_17/ML_int[1][8]
XU182 MUX2S $PINS O=sll_17/ML_int[1][10] S=FE_OFN203_h22_0 A=term2_in[10]
+ B=term2_in[9]
XU186 AO22S $PINS O=N61 A1=N34 A2=FE_OFN151_s21_0 B1=term1_shifted[20]
+ B2=FE_OFN150_s21_0
XU188 AO22S $PINS O=N62 A1=N35 A2=FE_OFN151_s21_0 B1=term1_shifted[21]
+ B2=FE_OFN150_s21_0
XU192 AO22S $PINS O=N63 A1=N36 A2=FE_OFN151_s21_0 B1=term1_shifted[22]
+ B2=FE_OFN150_s21_0
XU193 AO22S $PINS O=N64 A1=N37 A2=FE_OFN151_s21_0 B1=term1_shifted[23]
+ B2=FE_OFN150_s21_0
XU194 AO22S $PINS O=N65 A1=N38 A2=FE_OFN151_s21_0 B1=term1_shifted[24]
+ B2=FE_OFN150_s21_0
XU195 AO22S $PINS O=N66 A1=N39 A2=FE_OFN151_s21_0 B1=term1_shifted[25]
+ B2=FE_OFN150_s21_0
XU196 MUX2S $PINS O=sll_16/ML_int[2][11] S=FE_OFN298_h21_1
+ A=sll_16/ML_int[1][11] B=sll_16/ML_int[1][9]
XU197 MUX2S $PINS O=sll_16/ML_int[3][11] S=n74 A=sll_16/ML_int[2][11]
+ B=sll_16/ML_int[2][7]
XU198 MUX2S $PINS O=sll_18/ML_int[2][11] S=FE_OFN318_h23_1
+ A=sll_18/ML_int[1][11] B=sll_18/ML_int[1][9]
XU199 MUX2S $PINS O=sll_18/ML_int[3][11] S=n22 A=sll_18/ML_int[2][11]
+ B=sll_18/ML_int[2][7]
XU200 MUX2S $PINS O=sll_17/ML_int[2][11] S=shf2[1] A=sll_17/ML_int[1][11]
+ B=sll_17/ML_int[1][9]
XU201 MUX2S $PINS O=sll_17/ML_int[3][11] S=shf2[2] A=sll_17/ML_int[2][11]
+ B=sll_17/ML_int[2][7]
XU202 MUX2S $PINS O=sll_16/ML_int[2][12] S=FE_OFN298_h21_1
+ A=sll_16/ML_int[1][12] B=sll_16/ML_int[1][10]
XU203 MUX2S $PINS O=sll_16/ML_int[3][12] S=n74 A=sll_16/ML_int[2][12]
+ B=sll_16/ML_int[2][8]
XU204 MUX2S $PINS O=sll_18/ML_int[2][12] S=FE_OFN318_h23_1
+ A=sll_18/ML_int[1][12] B=sll_18/ML_int[1][10]
XU205 MUX2S $PINS O=sll_18/ML_int[3][12] S=n22 A=sll_18/ML_int[2][12]
+ B=sll_18/ML_int[2][8]
XU206 MUX2 $PINS O=sll_17/ML_int[2][12] S=shf2[1] A=sll_17/ML_int[1][12]
+ B=sll_17/ML_int[1][10]
XU207 MUX2S $PINS O=sll_17/ML_int[3][12] S=shf2[2] A=sll_17/ML_int[2][12]
+ B=sll_17/ML_int[2][8]
XU208 MUX2S $PINS O=sll_16/ML_int[1][11] S=FE_OFN258_h21_0 A=term1_in[11]
+ B=term1_in[10]
XU209 MUX2S $PINS O=sll_18/ML_int[1][11] S=shf3[0] A=term3_in[11]
+ B=term3_in[10]
XU210 MUX2S $PINS O=sll_17/ML_int[1][11] S=FE_OFN203_h22_0 A=term2_in[11]
+ B=term2_in[10]
XU211 MUX2S $PINS O=sll_16/ML_int[3][13] S=n74 A=sll_16/ML_int[2][13]
+ B=sll_16/ML_int[2][9]
XU212 MUX2S $PINS O=sll_16/ML_int[2][13] S=FE_OFN298_h21_1
+ A=sll_16/ML_int[1][13] B=sll_16/ML_int[1][11]
XU213 MUX2S $PINS O=sll_16/ML_int[1][13] S=FE_OFN258_h21_0 A=term1_in[13]
+ B=term1_in[12]
XU214 MUX2S $PINS O=sll_18/ML_int[3][13] S=n22 A=sll_18/ML_int[2][13]
+ B=sll_18/ML_int[2][9]
XU215 MUX2S $PINS O=sll_18/ML_int[2][13] S=FE_OFN318_h23_1
+ A=sll_18/ML_int[1][13] B=sll_18/ML_int[1][11]
XU216 MUX2S $PINS O=sll_18/ML_int[1][13] S=shf3[0] A=term3_in[13]
+ B=term3_in[12]
XU217 MUX2S $PINS O=sll_17/ML_int[3][13] S=shf2[2] A=sll_17/ML_int[2][13]
+ B=sll_17/ML_int[2][9]
XU218 MUX2S $PINS O=sll_17/ML_int[2][13] S=shf2[1] A=sll_17/ML_int[1][13]
+ B=sll_17/ML_int[1][11]
XU219 MUX2S $PINS O=sll_17/ML_int[1][13] S=FE_OFN203_h22_0 A=term2_in[13]
+ B=term2_in[12]
XU220 MUX2S $PINS O=sll_16/ML_int[3][14] S=n74 A=sll_16/ML_int[2][14]
+ B=sll_16/ML_int[2][10]
XU221 MUX2S $PINS O=sll_16/ML_int[2][14] S=FE_OFN298_h21_1
+ A=sll_16/ML_int[1][14] B=sll_16/ML_int[1][12]
XU222 MUX2S $PINS O=sll_16/ML_int[1][14] S=FE_OFN258_h21_0 A=term1_in[14]
+ B=term1_in[13]
XU223 MUX2S $PINS O=sll_18/ML_int[3][14] S=n22 A=sll_18/ML_int[2][14]
+ B=sll_18/ML_int[2][10]
XU224 MUX2S $PINS O=sll_18/ML_int[2][14] S=FE_OFN318_h23_1
+ A=sll_18/ML_int[1][14] B=sll_18/ML_int[1][12]
XU225 MUX2S $PINS O=sll_18/ML_int[1][14] S=shf3[0] A=term3_in[14]
+ B=term3_in[13]
XU226 MUX2S $PINS O=sll_17/ML_int[3][14] S=shf2[2] A=sll_17/ML_int[2][14]
+ B=sll_17/ML_int[2][10]
XU227 MUX2S $PINS O=sll_17/ML_int[2][14] S=shf2[1] A=sll_17/ML_int[1][14]
+ B=sll_17/ML_int[1][12]
XU228 MUX2S $PINS O=sll_17/ML_int[1][14] S=FE_OFN203_h22_0 A=term2_in[14]
+ B=term2_in[13]
XU229 MUX2S $PINS O=term1_shifted[15] S=n77 A=sll_16/ML_int[3][15]
+ B=sll_16/ML_int[3][7]
XU230 MUX2S $PINS O=sll_16/ML_int[3][15] S=n74 A=sll_16/ML_int[2][15]
+ B=sll_16/ML_int[2][11]
XU231 MUX2S $PINS O=sll_16/ML_int[2][15] S=FE_OFN298_h21_1
+ A=sll_16/ML_int[1][15] B=sll_16/ML_int[1][13]
XU232 MUX2S $PINS O=sll_16/ML_int[1][15] S=FE_OFN258_h21_0 A=term1_in[15]
+ B=term1_in[14]
XU233 MUX2S $PINS O=sll_18/ML_int[3][15] S=n22 A=sll_18/ML_int[2][15]
+ B=sll_18/ML_int[2][11]
XU234 MUX2S $PINS O=sll_18/ML_int[2][15] S=FE_OFN318_h23_1
+ A=sll_18/ML_int[1][15] B=sll_18/ML_int[1][13]
XU235 MUX2S $PINS O=sll_18/ML_int[1][15] S=shf3[0] A=term3_in[15]
+ B=term3_in[14]
XU236 MUX2S $PINS O=term2_shifted[15] S=shf2[3] A=sll_17/ML_int[3][15]
+ B=sll_17/ML_int[3][7]
XU237 MUX2S $PINS O=sll_17/ML_int[3][15] S=shf2[2] A=sll_17/ML_int[2][15]
+ B=sll_17/ML_int[2][11]
XU238 MUX2S $PINS O=sll_17/ML_int[2][15] S=shf2[1] A=sll_17/ML_int[1][15]
+ B=sll_17/ML_int[1][13]
XU239 MUX2S $PINS O=term1_shifted[16] S=n77 A=sll_16/ML_int[3][16]
+ B=sll_16/ML_int[3][8]
XU240 MUX2S $PINS O=sll_17/ML_int[1][15] S=FE_OFN203_h22_0 A=term2_in[15]
+ B=term2_in[14]
XU241 MUX2S $PINS O=term3_shifted[16] S=FE_RN_103_0 A=sll_18/ML_int[3][16]
+ B=sll_18/ML_int[3][8]
XU242 MUX2S $PINS O=n130 S=FE_OFN318_h23_1 A=n133 B=sll_18/ML_int[1][14]
XU243 MUX2S $PINS O=term2_shifted[16] S=shf2[3] A=sll_17/ML_int[3][16]
+ B=sll_17/ML_int[3][8]
XU244 MUX2S $PINS O=term1_shifted[17] S=n77 A=sll_16/ML_int[3][17]
+ B=sll_16/ML_int[3][9]
XU245 MUX2S $PINS O=term3_shifted[17] S=FE_RN_103_0 A=sll_18/ML_int[3][17]
+ B=sll_18/ML_int[3][9]
XU246 MUX2S $PINS O=term2_shifted[17] S=shf2[3] A=sll_17/ML_int[3][17]
+ B=sll_17/ML_int[3][9]
XU247 MUX2S $PINS O=term1_shifted[18] S=n77 A=sll_16/ML_int[3][18]
+ B=sll_16/ML_int[3][10]
XU248 MUX2S $PINS O=term3_shifted[18] S=FE_RN_103_0 A=sll_18/ML_int[3][18]
+ B=sll_18/ML_int[3][10]
XU249 MUX2S $PINS O=term2_shifted[18] S=shf2[3] A=sll_17/ML_int[3][18]
+ B=sll_17/ML_int[3][10]
XU252 MUX2S $PINS O=sll_16/ML_int[3][16] S=n74 A=n108 B=sll_16/ML_int[2][12]
XU253 MUX2S $PINS O=n133 S=shf3[0] A=term3_in[26] B=term3_in[15]
XU254 MUX2S $PINS O=sll_18/ML_int[3][16] S=n22 A=n130 B=sll_18/ML_int[2][12]
XU255 MUX2S $PINS O=sll_17/ML_int[3][16] S=shf2[2] A=n119
+ B=sll_17/ML_int[2][12]
XU256 MUX2S $PINS O=n109 S=FE_OFN298_h21_1 A=n5 B=sll_16/ML_int[1][15]
XU257 MUX2S $PINS O=sll_16/ML_int[3][17] S=n74 A=n109 B=sll_16/ML_int[2][13]
XU259 MUX2S $PINS O=n131 S=FE_OFN318_h23_1 A=n7 B=sll_18/ML_int[1][15]
XU260 MUX2S $PINS O=sll_18/ML_int[3][17] S=n22 A=n131 B=sll_18/ML_int[2][13]
XU261 MUX2S $PINS O=n120 S=shf2[1] A=term2_in[26] B=sll_17/ML_int[1][15]
XU262 MUX2S $PINS O=sll_17/ML_int[3][17] S=shf2[2] A=n120
+ B=sll_17/ML_int[2][13]
XU263 MUX2S $PINS O=n110 S=FE_OFN92_h21_1 A=n111 B=term1_in[26]
XU264 MUX2S $PINS O=sll_16/ML_int[3][18] S=n74 A=n110 B=sll_16/ML_int[2][14]
XU265 MUX2S $PINS O=sll_18/ML_int[3][18] S=n22 A=n132 B=sll_18/ML_int[2][14]
XU266 MUX2S $PINS O=n121 S=n43 A=n122 B=term2_in[26]
XU267 MUX2S $PINS O=sll_17/ML_int[3][18] S=shf2[2] A=n121
+ B=sll_17/ML_int[2][14]
XU268 MUX2S $PINS O=term1_shifted[19] S=n77 A=sll_16/ML_int[3][19]
+ B=sll_16/ML_int[3][11]
XU269 MUX2S $PINS O=term3_shifted[19] S=FE_RN_103_0 A=sll_18/ML_int[3][19]
+ B=sll_18/ML_int[3][11]
XU270 MUX2S $PINS O=term2_shifted[19] S=shf2[3] A=sll_17/ML_int[3][19]
+ B=sll_17/ML_int[3][11]
XU271 MUX2S $PINS O=term1_shifted[20] S=n77 A=sll_16/ML_int[3][20]
+ B=sll_16/ML_int[3][12]
XU272 MUX2S $PINS O=sll_16/ML_int[3][20] S=n74 A=term1_in[26] B=n108
XU273 MUX2S $PINS O=term3_shifted[20] S=FE_RN_103_0 A=sll_18/ML_int[3][20]
+ B=sll_18/ML_int[3][12]
XU274 MUX2S $PINS O=sll_18/ML_int[3][20] S=n22 A=term3_in[26] B=n130
XU275 MUX2S $PINS O=term2_shifted[20] S=shf2[3] A=sll_17/ML_int[3][20]
+ B=sll_17/ML_int[3][12]
XU276 MUX2S $PINS O=sll_17/ML_int[3][20] S=shf2[2] A=term2_in[26] B=n119
XU279 MUX2S $PINS O=term1_shifted[21] S=n77 A=sll_16/ML_int[3][21]
+ B=sll_16/ML_int[3][13]
XU280 MUX2S $PINS O=term2_shifted[21] S=shf2[3] A=sll_17/ML_int[3][21]
+ B=sll_17/ML_int[3][13]
XU281 MUX2S $PINS O=term3_shifted[21] S=FE_RN_103_0 A=sll_18/ML_int[3][21]
+ B=sll_18/ML_int[3][13]
XU283 AN2S $PINS O=base_val[6] I1=acc_reg[6] I2=n151
XU284 AN2S $PINS O=base_val[1] I1=acc_reg[1] I2=n151
XU285 AN2S $PINS O=base_val[2] I1=acc_reg[2] I2=n151
XU286 MUX2S $PINS O=FE_PHN1281_N235 S=stage_sel A=acc_reg[10] B=acc_reg[14]
XU287 MUX2S $PINS O=N244 S=stage_sel A=FE_PHN1111_acc_reg_19
+ B=FE_PHN999_acc_reg_23
XU295 MOAI1 $PINS O=N152 A1=n8 A2=sign3[0] B1=term3_shifted[1] B2=sign3[0]
XU302 NR2 $PINS O=term1_in[4] I1=sign1[1] I2=x_in[4]
XU305 NR2P $PINS O=term3_in[4] I1=sign3[1] I2=x_in[4]
XU307 NR2 $PINS O=term1_in[3] I1=sign1[1] I2=x_in[3]
XU308 NR2 $PINS O=term2_in[3] I1=sign2[1] I2=x_in[3]
XU309 NR2 $PINS O=term3_in[3] I1=sign3[1] I2=x_in[3]
XU310 NR2 $PINS O=term1_in[5] I1=sign1[1] I2=x_in[5]
XU311 NR2 $PINS O=term2_in[5] I1=sign2[1] I2=x_in[5]
XU312 INV1S $PINS O=n118 I=n113
XU313 NR2 $PINS O=term3_in[5] I1=sign3[1] I2=x_in[5]
XU314 INV1S $PINS O=n129 I=n124
XU315 NR2 $PINS O=term1_in[6] I1=sign1[1] I2=x_in[6]
XU316 NR2 $PINS O=term2_in[6] I1=sign2[1] I2=x_in[6]
XU317 NR2 $PINS O=term3_in[6] I1=sign3[1] I2=x_in[6]
XU318 NR2 $PINS O=term1_in[7] I1=sign1[1] I2=x_in[7]
XU319 NR2 $PINS O=term2_in[7] I1=sign2[1] I2=x_in[7]
XU320 NR2 $PINS O=term3_in[7] I1=sign3[1] I2=x_in[7]
XU322 NR2 $PINS O=term1_in[8] I1=sign1[1] I2=x_in[8]
XU323 NR2 $PINS O=term2_in[8] I1=sign2[1] I2=x_in[8]
XU324 NR2 $PINS O=term3_in[8] I1=sign3[1] I2=x_in[8]
XU329 NR2 $PINS O=term1_in[9] I1=sign1[1] I2=x_in[9]
XU330 NR2 $PINS O=term2_in[9] I1=sign2[1] I2=x_in[9]
XU331 NR2 $PINS O=term3_in[9] I1=sign3[1] I2=x_in[9]
XU332 NR2 $PINS O=term1_in[10] I1=sign1[1] I2=x_in[10]
XU333 NR2 $PINS O=term2_in[10] I1=FE_OFN246_s22_1 I2=x_in[10]
XU334 NR2 $PINS O=term3_in[10] I1=sign3[1] I2=x_in[10]
XU335 NR2 $PINS O=term1_in[11] I1=sign1[1] I2=x_in[11]
XU336 NR2 $PINS O=term2_in[11] I1=FE_OFN246_s22_1 I2=x_in[11]
XU337 NR2 $PINS O=term3_in[11] I1=sign3[1] I2=x_in[11]
XU338 NR2 $PINS O=term1_in[12] I1=sign1[1] I2=x_in[12]
XU341 NR2 $PINS O=term2_in[12] I1=FE_OFN246_s22_1 I2=x_in[12]
XU342 NR2 $PINS O=term3_in[12] I1=sign3[1] I2=x_in[12]
XU347 NR2 $PINS O=term1_in[13] I1=sign1[1] I2=x_in[13]
XU348 NR2 $PINS O=term2_in[13] I1=FE_OFN246_s22_1 I2=x_in[13]
XU349 NR2 $PINS O=term3_in[13] I1=sign3[1] I2=x_in[13]
XU350 NR2 $PINS O=term1_in[14] I1=sign1[1] I2=x_in[14]
XU352 NR2 $PINS O=term2_in[14] I1=FE_OFN246_s22_1 I2=x_in[14]
XU353 NR2 $PINS O=term3_in[14] I1=sign3[1] I2=x_in[14]
XU355 NR2 $PINS O=term1_in[15] I1=sign1[1] I2=n139
XU356 NR2 $PINS O=term2_in[15] I1=FE_OFN246_s22_1 I2=n139
XU357 NR2 $PINS O=term3_in[15] I1=sign3[1] I2=n139
XU367 INV1S $PINS O=n47 I=shf2[2]
XU368 INV1S $PINS O=n67 I=FE_OFN258_h21_0
XU390 INV1S $PINS O=n139 I=x_in[15]
XU391 INV1S $PINS O=n140 I=x_in[16]
XU392 NR2 $PINS O=term1_in[26] I1=n140 I2=sign1[1]
XU394 NR2 $PINS O=term2_in[26] I1=n140 I2=FE_OFN246_s22_1
XU396 NR2 $PINS O=term3_in[26] I1=n140 I2=sign3[1]
XU398 AN2 $PINS O=base_val[10] I1=acc_reg[10] I2=n151
XU399 AN2 $PINS O=base_val[11] I1=acc_reg[11] I2=n151
XU400 AN2 $PINS O=base_val[12] I1=acc_reg[12] I2=n151
XU401 AN2 $PINS O=base_val[14] I1=acc_reg[14] I2=n151
XU402 AN2 $PINS O=base_val[15] I1=FE_PHN1145_acc_reg_15 I2=n151
XU403 AN2 $PINS O=base_val[16] I1=acc_reg[16] I2=n151
XU404 AN2 $PINS O=base_val[17] I1=acc_reg[17] I2=n151
XU405 AN2 $PINS O=base_val[18] I1=acc_reg[18] I2=n151
XU406 AN2 $PINS O=base_val[19] I1=FE_PHN1111_acc_reg_19 I2=n151
XU407 AN2 $PINS O=base_val[20] I1=acc_reg[20] I2=n151
XU408 AN2 $PINS O=base_val[21] I1=acc_reg[21] I2=n151
XU409 AN2 $PINS O=base_val[22] I1=acc_reg[22] I2=n151
XU410 AN2 $PINS O=base_val[23] I1=acc_reg[23] I2=n151
XU411 AN2 $PINS O=base_val[25] I1=acc_reg[25] I2=n151
XU412 AN2 $PINS O=base_val[8] I1=acc_reg[8] I2=n151
XU413 AN2 $PINS O=base_val[5] I1=acc_reg[5] I2=n151
XU414 AN2 $PINS O=base_val[4] I1=acc_reg[4] I2=n151
XU415 AN2 $PINS O=base_val[3] I1=acc_reg[3] I2=n151
XU418 AN2 $PINS O=base_val[0] I1=acc_reg[0] I2=n151
XU423 AN2 $PINS O=N234 I1=en I2=calc_done
XU424 AN2 $PINS O=base_val[26] I1=N251 I2=n151
XU427 NR2 $PINS O=sll_16/ML_int[3][0] I1=n74 I2=n101
XU428 NR2 $PINS O=sll_16/ML_int[3][1] I1=n74 I2=n4
XU429 NR2 $PINS O=sll_16/ML_int[3][2] I1=n74 I2=n105
XU430 NR2 $PINS O=sll_16/ML_int[3][3] I1=n74 I2=n104
XU431 ND2 $PINS O=n103 I1=shf1[2] I2=shf1[3]
XU432 NR2 $PINS O=term1_shifted[3] I1=n103 I2=n104
XU435 AN2 $PINS O=term1_shifted[6] I1=sll_16/ML_int[3][6] I2=shf1[3]
XU436 AN2 $PINS O=term1_shifted[7] I1=sll_16/ML_int[3][7] I2=shf1[3]
XU437 MUX2 $PINS O=sll_16/ML_int[3][21] S=n74 A=n5 B=n109
XU438 MUX2 $PINS O=sll_16/ML_int[3][22] S=n74 A=term1_in[26] B=n110
XU439 MUX2 $PINS O=term1_shifted[24] S=n77 A=term1_in[26]
+ B=sll_16/ML_int[3][16]
XU440 MUX2 $PINS O=n108 S=FE_OFN298_h21_1 A=n111 B=sll_16/ML_int[1][14]
XU441 MUX2 $PINS O=term1_shifted[25] S=n77 A=n5 B=sll_16/ML_int[3][17]
XU442 MUX2 $PINS O=term1_shifted[26] S=n77 A=term1_in[26]
+ B=sll_16/ML_int[3][18]
XU443 NR2 $PINS O=sll_17/ML_int[3][0] I1=shf2[2] I2=n112
XU444 NR2 $PINS O=sll_17/ML_int[3][1] I1=shf2[2] I2=n113
XU445 NR2 $PINS O=sll_17/ML_int[3][2] I1=shf2[2] I2=n116
XU448 AN2 $PINS O=term2_shifted[6] I1=sll_17/ML_int[3][6] I2=n52
XU449 AN2 $PINS O=term2_shifted[7] I1=sll_17/ML_int[3][7] I2=n52
XU450 MUX2 $PINS O=sll_17/ML_int[3][21] S=shf2[2] A=term2_in[26] B=n120
XU451 MUX2 $PINS O=sll_17/ML_int[3][22] S=shf2[2] A=term2_in[26] B=n121
XU452 MUX2 $PINS O=term2_shifted[24] S=shf2[3] A=term2_in[26]
+ B=sll_17/ML_int[3][16]
XU453 MUX2 $PINS O=n119 S=shf2[1] A=n122 B=sll_17/ML_int[1][14]
XU454 MUX2 $PINS O=term2_shifted[25] S=shf2[3] A=term2_in[26]
+ B=sll_17/ML_int[3][17]
XU455 MUX2 $PINS O=term2_shifted[26] S=shf2[3] A=term2_in[26]
+ B=sll_17/ML_int[3][18]
XU456 AN2 $PINS O=sll_18/ML_int[1][0] I1=n14 I2=term3_in[0]
XU457 NR2 $PINS O=sll_18/ML_int[3][0] I1=n22 I2=n123
XU458 NR2 $PINS O=sll_18/ML_int[3][1] I1=n22 I2=n124
XU459 NR2 $PINS O=sll_18/ML_int[3][2] I1=n22 I2=n127
XU460 NR2 $PINS O=sll_18/ML_int[3][3] I1=n22 I2=n126
XU461 ND2 $PINS O=n125 I1=FE_OFN178_h23_2 I2=n25
XU462 NR2 $PINS O=term3_shifted[3] I1=n125 I2=n126
XU465 AN2 $PINS O=term3_shifted[6] I1=sll_18/ML_int[3][6] I2=n25
XU466 MUX2 $PINS O=sll_18/ML_int[3][21] S=n22 A=n7 B=n131
XU467 MUX2 $PINS O=sll_18/ML_int[3][22] S=n22 A=term3_in[26] B=n132
XU468 MUX2 $PINS O=term3_shifted[24] S=FE_RN_103_0 A=term3_in[26]
+ B=sll_18/ML_int[3][16]
XU469 MUX2 $PINS O=term3_shifted[25] S=FE_RN_103_0 A=n7 B=sll_18/ML_int[3][17]
XU470 MUX2 $PINS O=term3_shifted[26] S=FE_RN_103_0 A=term3_in[26]
+ B=sll_18/ML_int[3][18]
XU471 MUX2 $PINS O=N245 S=stage_sel A=acc_reg[20] B=FE_PHN868_acc_reg_24
XU472 MUX2 $PINS O=N246 S=stage_sel A=acc_reg[21] B=FE_PHN1027_acc_reg_25
XU473 MUX2 $PINS O=N236 S=stage_sel A=acc_reg[11] B=FE_PHN1145_acc_reg_15
XU474 MUX2 $PINS O=N237 S=stage_sel A=FE_PHN1022_acc_reg_12 B=acc_reg[16]
XU475 MUX2 $PINS O=N238 S=stage_sel A=acc_reg[13] B=acc_reg[17]
XU476 MUX2 $PINS O=FE_PHN1220_N239 S=stage_sel A=acc_reg[14]
+ B=FE_PHN863_acc_reg_18
XU477 MUX2 $PINS O=N240 S=stage_sel A=FE_PHN1145_acc_reg_15
+ B=FE_PHN1111_acc_reg_19
XU478 MUX2 $PINS O=N241 S=stage_sel A=acc_reg[16] B=acc_reg[20]
XU479 MUX2 $PINS O=N242 S=stage_sel A=acc_reg[17] B=acc_reg[21]
XU480 MUX2 $PINS O=N243 S=stage_sel A=FE_PHN863_acc_reg_18 B=acc_reg[22]
Xclk_gate_y_out_reg SNPS_CLOCK_GATE_HIGH_PE_Shift_Add_2 $PINS EN=N234
+ ENCLK=CTS_12 CLK=clk_clone1
Xsub_28_3 PE_Shift_Add_2_DW01_sub_0_DW01_sub_6 $PINS A[26]=net44421
+ A[25]=net44421 A[24]=net44421 A[23]=net44421 A[22]=net44421 A[21]=net44421
+ A[20]=net44421 A[19]=net44421 A[18]=net44421 A[17]=net44421 A[16]=net44421
+ A[15]=net44421 A[14]=net44421 A[13]=net44421 A[12]=net44421 A[11]=net44421
+ A[10]=net44421 A[9]=net44421 A[8]=net44421 A[7]=net44421 A[6]=net44421
+ A[5]=net44421 A[4]=net44421 A[3]=net44421 A[2]=net44421 A[1]=net44421
+ A[0]=net44421 B[26]=term3_shifted[26] B[25]=term3_shifted[25]
+ B[24]=term3_shifted[24] B[23]=term3_shifted[23] B[22]=term3_shifted[22]
+ B[21]=term3_shifted[21] B[20]=term3_shifted[20] B[19]=term3_shifted[19]
+ B[18]=term3_shifted[18] B[17]=term3_shifted[17] B[16]=term3_shifted[16]
+ B[15]=term3_shifted[15] B[14]=term3_shifted[14] B[13]=term3_shifted[13]
+ B[12]=term3_shifted[12] B[11]=term3_shifted[11] B[10]=term3_shifted[10]
+ B[9]=term3_shifted[9] B[8]=term3_shifted[8] B[7]=term3_shifted[7]
+ B[6]=term3_shifted[6] B[5]=term3_shifted[5] B[4]=term3_shifted[4]
+ B[3]=term3_shifted[3] B[2]=term3_shifted[2] B[1]=term3_shifted[1]
+ B[0]=term3_shifted[0] CI=net44421 DIFF[26]=N150 DIFF[25]=N149 DIFF[24]=N148
+ DIFF[23]=N147 DIFF[22]=N146 DIFF[21]=N145 DIFF[20]=N144 DIFF[19]=N143
+ DIFF[18]=N142 DIFF[17]=N141 DIFF[16]=N140 DIFF[15]=N139 DIFF[14]=N138
+ DIFF[13]=N137 DIFF[12]=N136 DIFF[11]=N135 DIFF[10]=N134 DIFF[9]=N133
+ DIFF[8]=N132 DIFF[7]=N131 DIFF[6]=N130 DIFF[5]=N129 DIFF[4]=N128 DIFF[3]=N127
+ DIFF[2]=N126 DIFF[1]=N125 DIFF[0]=N124
Xsub_28_2 PE_Shift_Add_2_DW01_sub_1_DW01_sub_7 $PINS A[26]=net44421
+ A[25]=net44421 A[24]=net44421 A[23]=net44421 A[22]=net44421 A[21]=net44421
+ A[20]=net44421 A[19]=net44421 A[18]=net44421 A[17]=net44421 A[16]=net44421
+ A[15]=net44421 A[14]=net44421 A[13]=net44421 A[12]=net44421 A[11]=net44421
+ A[10]=net44421 A[9]=net44421 A[8]=net44421 A[7]=net44421 A[6]=net44421
+ A[5]=net44421 A[4]=net44421 A[3]=net44421 A[2]=net44421 A[1]=net44421
+ A[0]=net44421 B[26]=term2_shifted[26] B[25]=term2_shifted[25]
+ B[24]=term2_shifted[24] B[23]=term2_shifted[23] B[22]=term2_shifted[22]
+ B[21]=term2_shifted[21] B[20]=term2_shifted[20] B[19]=term2_shifted[19]
+ B[18]=term2_shifted[18] B[17]=term2_shifted[17] B[16]=term2_shifted[16]
+ B[15]=term2_shifted[15] B[14]=term2_shifted[14] B[13]=term2_shifted[13]
+ B[12]=term2_shifted[12] B[11]=term2_shifted[11] B[10]=term2_shifted[10]
+ B[9]=term2_shifted[9] B[8]=term2_shifted[8] B[7]=term2_shifted[7]
+ B[6]=term2_shifted[6] B[5]=term2_shifted[5] B[4]=term2_shifted[4]
+ B[3]=term2_shifted[3] B[2]=term2_shifted[2] B[1]=term2_shifted[1]
+ B[0]=term2_shifted[0] CI=net44421 DIFF[26]=N95 DIFF[25]=N94 DIFF[24]=N93
+ DIFF[23]=N92 DIFF[22]=N91 DIFF[21]=N90 DIFF[20]=N89 DIFF[19]=N88 DIFF[18]=N87
+ DIFF[17]=N86 DIFF[16]=N85 DIFF[15]=N84 DIFF[14]=N83 DIFF[13]=N82 DIFF[12]=N81
+ DIFF[11]=N80 DIFF[10]=N79 DIFF[9]=N78 DIFF[8]=N77 DIFF[7]=N76 DIFF[6]=N75
+ DIFF[5]=N74 DIFF[4]=N73 DIFF[3]=N72 DIFF[2]=N71 DIFF[1]=N70 DIFF[0]=N69
Xsub_28 PE_Shift_Add_2_DW01_sub_2_DW01_sub_8 $PINS A[26]=net44421
+ A[25]=net44421 A[24]=net44421 A[23]=net44421 A[22]=net44421 A[21]=net44421
+ A[20]=net44421 A[19]=net44421 A[18]=net44421 A[17]=net44421 A[16]=net44421
+ A[15]=net44421 A[14]=net44421 A[13]=net44421 A[12]=net44421 A[11]=net44421
+ A[10]=net44421 A[9]=net44421 A[8]=net44421 A[7]=net44421 A[6]=net44421
+ A[5]=net44421 A[4]=net44421 A[3]=net44421 A[2]=net44421 A[1]=net44421
+ A[0]=net44421 B[26]=term1_shifted[26] B[25]=term1_shifted[25]
+ B[24]=term1_shifted[24] B[23]=term1_shifted[23] B[22]=term1_shifted[22]
+ B[21]=term1_shifted[21] B[20]=term1_shifted[20] B[19]=term1_shifted[19]
+ B[18]=term1_shifted[18] B[17]=term1_shifted[17] B[16]=term1_shifted[16]
+ B[15]=term1_shifted[15] B[14]=term1_shifted[14] B[13]=term1_shifted[13]
+ B[12]=term1_shifted[12] B[11]=term1_shifted[11] B[10]=term1_shifted[10]
+ B[9]=term1_shifted[9] B[8]=term1_shifted[8] B[7]=term1_shifted[7]
+ B[6]=term1_shifted[6] B[5]=term1_shifted[5] B[4]=term1_shifted[4]
+ B[3]=term1_shifted[3] B[2]=term1_shifted[2] B[1]=term1_shifted[1]
+ B[0]=term1_shifted[0] CI=net44421 DIFF[26]=N40 DIFF[25]=N39 DIFF[24]=N38
+ DIFF[23]=N37 DIFF[22]=N36 DIFF[21]=N35 DIFF[20]=N34 DIFF[19]=N33 DIFF[18]=N32
+ DIFF[17]=N31 DIFF[16]=N30 DIFF[15]=N29 DIFF[14]=N28 DIFF[13]=N27 DIFF[12]=N26
+ DIFF[11]=N25 DIFF[10]=N24 DIFF[9]=N23 DIFF[8]=N22 DIFF[7]=N21 DIFF[6]=N20
+ DIFF[5]=N19 DIFF[4]=N18 DIFF[3]=N17 DIFF[2]=N16 DIFF[1]=N15 DIFF[0]=N14
Xadd_1_root_add_0_root_add_28_3 PE_Shift_Add_2_DW01_add_2_DW01_add_31 $PINS
+ A[26]=N67 A[25]=N66 A[24]=N65 A[23]=N64 A[22]=N63 A[21]=N62 A[20]=N61 A[19]=N60
+ A[18]=N59 A[17]=N58 A[16]=N57 A[15]=N56 A[14]=N55 A[13]=N54 A[12]=N53 A[11]=N52
+ A[10]=N51 A[9]=N50 A[8]=N49 A[7]=N48 A[6]=N47 A[5]=N46 A[4]=N45 A[3]=N44
+ A[2]=N43 A[1]=N42 A[0]=N41 B[26]=N177 B[25]=N176 B[24]=N175 B[23]=N174
+ B[22]=N173 B[21]=N172 B[20]=N171 B[19]=N170 B[18]=N169 B[17]=N168 B[16]=N167
+ B[15]=N166 B[14]=N165 B[13]=N164 B[12]=N163 B[11]=N162 B[10]=N161 B[9]=N160
+ B[8]=N159 B[7]=N158 B[6]=N157 B[5]=N156 B[4]=N155 B[3]=N154 B[2]=N153 B[1]=N152
+ B[0]=N151 CI=net44421 SUM[26]=N204 SUM[25]=N203 SUM[24]=N202 SUM[23]=N201
+ SUM[22]=N200 SUM[21]=N199 SUM[20]=N198 SUM[19]=N197 SUM[18]=N196 SUM[17]=N195
+ SUM[16]=N194 SUM[15]=N193 SUM[14]=N192 SUM[13]=N191 SUM[12]=N190 SUM[11]=N189
+ SUM[10]=N188 SUM[9]=N187 SUM[8]=N186 SUM[7]=N185 SUM[6]=N184 SUM[5]=N183
+ SUM[4]=N182 SUM[3]=N181 SUM[2]=N180 SUM[1]=N179 SUM[0]=N178
Xadd_2_root_add_0_root_add_28_3 PE_Shift_Add_2_DW01_add_1_DW01_add_30 $PINS
+ A[26]=base_val[26] A[25]=base_val[25] A[24]=base_val[24] A[23]=base_val[23]
+ A[22]=base_val[22] A[21]=base_val[21] A[20]=base_val[20] A[19]=base_val[19]
+ A[18]=base_val[18] A[17]=base_val[17] A[16]=base_val[16] A[15]=base_val[15]
+ A[14]=base_val[14] A[13]=base_val[13] A[12]=base_val[12] A[11]=base_val[11]
+ A[10]=base_val[10] A[9]=base_val[9] A[8]=base_val[8] A[7]=base_val[7]
+ A[6]=base_val[6] A[5]=base_val[5] A[4]=base_val[4] A[3]=base_val[3]
+ A[2]=base_val[2] A[1]=base_val[1] A[0]=base_val[0] B[26]=N122 B[25]=N121
+ B[24]=N120 B[23]=N119 B[22]=N118 B[21]=N117 B[20]=N116 B[19]=N115 B[18]=N114
+ B[17]=N113 B[16]=N112 B[15]=N111 B[14]=N110 B[13]=N109 B[12]=N108 B[11]=N107
+ B[10]=N106 B[9]=N105 B[8]=N104 B[7]=N103 B[6]=N102 B[5]=N101 B[4]=N100 B[3]=N99
+ B[2]=N98 B[1]=N97 B[0]=N96 CI=net44421 SUM[26]=N231 SUM[25]=N230 SUM[24]=N229
+ SUM[23]=N228 SUM[22]=N227 SUM[21]=N226 SUM[20]=N225 SUM[19]=N224 SUM[18]=N223
+ SUM[17]=N222 SUM[16]=N221 SUM[15]=N220 SUM[14]=N219 SUM[13]=N218 SUM[12]=N217
+ SUM[11]=N216 SUM[10]=N215 SUM[9]=N214 SUM[8]=N213 SUM[7]=N212 SUM[6]=N211
+ SUM[5]=N210 SUM[4]=N209 SUM[3]=N208 SUM[2]=N207 SUM[1]=N206 SUM[0]=N205
Xadd_0_root_add_0_root_add_28_3 PE_Shift_Add_2_DW01_add_0_DW01_add_29 $PINS
+ A[26]=N204 A[25]=N203 A[24]=N202 A[23]=N201 A[22]=N200 A[21]=N199 A[20]=N198
+ A[19]=N197 A[18]=N196 A[17]=N195 A[16]=N194 A[15]=N193 A[14]=N192 A[13]=N191
+ A[12]=N190 A[11]=N189 A[10]=N188 A[9]=N187 A[8]=N186 A[7]=N185 A[6]=N184
+ A[5]=N183 A[4]=N182 A[3]=N181 A[2]=N180 A[1]=N179 A[0]=N178 B[26]=N231
+ B[25]=N230 B[24]=N229 B[23]=N228 B[22]=N227 B[21]=N226 B[20]=N225 B[19]=N224
+ B[18]=N223 B[17]=N222 B[16]=N221 B[15]=N220 B[14]=N219 B[13]=N218 B[12]=N217
+ B[11]=N216 B[10]=N215 B[9]=N214 B[8]=N213 B[7]=N212 B[6]=N211 B[5]=N210
+ B[4]=N209 B[3]=N208 B[2]=N207 B[1]=N206 B[0]=N205 CI=net44421
+ SUM[26]=next_acc[26] SUM[25]=next_acc[25] SUM[24]=next_acc[24]
+ SUM[23]=next_acc[23] SUM[22]=next_acc[22] SUM[21]=next_acc[21]
+ SUM[20]=next_acc[20] SUM[19]=next_acc[19] SUM[18]=next_acc[18]
+ SUM[17]=next_acc[17] SUM[16]=next_acc[16] SUM[15]=next_acc[15]
+ SUM[14]=next_acc[14] SUM[13]=next_acc[13] SUM[12]=next_acc[12]
+ SUM[11]=next_acc[11] SUM[10]=next_acc[10] SUM[9]=next_acc[9] SUM[8]=next_acc[8]
+ SUM[7]=next_acc[7] SUM[6]=next_acc[6] SUM[5]=next_acc[5] SUM[4]=next_acc[4]
+ SUM[3]=next_acc[3] SUM[2]=next_acc[2] SUM[1]=next_acc[1] SUM[0]=next_acc[0]
Xsll_17/M1_0_3 MUX2 $PINS O=sll_17/ML_int[1][3] S=FE_OFN203_h22_0 A=term2_in[3]
+ B=term2_in[2]
XU53 MUX2 $PINS O=sll_17/ML_int[1][2] S=shf2[0] A=term2_in[2] B=term2_in[1]
XU4 AN2 $PINS O=sll_17/ML_int[1][0] I1=term2_in[0] I2=n40
XU11 NR2P $PINS O=term2_shifted[0] I1=n114 I2=n112
XU12 ND2 $PINS O=n123 I1=sll_18/ML_int[1][0] I2=FE_OFN95_h23_1
XU14 ND2P $PINS O=n112 I1=sll_17/ML_int[1][0] I2=n43
XU17 AO22 $PINS O=N153 A1=N126 A2=FE_OFN322_s23_0 B1=term3_shifted[2]
+ B2=sign3[0]
XU24 NR2 $PINS O=term1_in[1] I1=sign1[1] I2=x_in[1]
XU25 NR2P $PINS O=term2_in[1] I1=sign2[1] I2=x_in[1]
XU30 NR2 $PINS O=term2_in[2] I1=sign2[1] I2=x_in[2]
XU31 AN2 $PINS O=sll_16/ML_int[1][0] I1=term1_in[0] I2=n67
XU33 OR2 $PINS O=n114 I1=shf2[2] I2=shf2[3]
XU34 NR2 $PINS O=term3_shifted[1] I1=n125 I2=n124
XU35 ND2S $PINS O=n4 I1=sll_16/ML_int[1][1] I2=FE_OFN92_h21_1
XU37 AN2 $PINS O=sll_17/ML_int[3][3] I1=sll_17/ML_int[2][3] I2=n47
XU39 NR2P $PINS O=term2_shifted[2] I1=n114 I2=n116
XU40 INV2 $PINS O=n116 I=sll_17/ML_int[2][2]
XU42 INV1S $PINS O=n105 I=sll_16/ML_int[2][2]
XU57 NR2 $PINS O=term3_shifted[0] I1=n125 I2=n123
XU58 NR2 $PINS O=term3_in[0] I1=sign3[1] I2=x_in[0]
XU59 INV2 $PINS O=n127 I=sll_18/ML_int[2][2]
XU63 AO22 $PINS O=N97 A1=N70 A2=sign2[0] B1=term2_shifted[1] B2=FE_OFN325_s22_0
.ENDS

.SUBCKT SNPS_CLOCK_GATE_HIGH_PE_Shift_Add_1 EN ENCLK CLK
*.CONNECT ENCLK net2188
*.CONNECT net2189 EN
XFE_PHC952_net2192 DELC $PINS O=net2192 I=FE_PHN952_net2192
Xlatch QDBHN $PINS Q=FE_PHN952_net2192 D=net2189 CKB=CLK
Xmain_gate AN2T $PINS O=net2188 I1=net2192 I2=CLK
.ENDS

.SUBCKT PE_Shift_Add_1_DW01_sub_0_DW01_sub_3 A[26] A[25] A[24] A[23] A[22]
+ A[21] A[20] A[19] A[18] A[17] A[16] A[15] A[14] A[13] A[12] A[11] A[10] A[9]
+ A[8] A[7] A[6] A[5] A[4] A[3] A[2] A[1] A[0] B[26] B[25] B[24] B[23] B[22]
+ B[21] B[20] B[19] B[18] B[17] B[16] B[15] B[14] B[13] B[12] B[11] B[10] B[9]
+ B[8] B[7] B[6] B[5] B[4] B[3] B[2] B[1] B[0] CI DIFF[26] DIFF[25] DIFF[24]
+ DIFF[23] DIFF[22] DIFF[21] DIFF[20] DIFF[19] DIFF[18] DIFF[17] DIFF[16]
+ DIFF[15] DIFF[14] DIFF[13] DIFF[12] DIFF[11] DIFF[10] DIFF[9] DIFF[8] DIFF[7]
+ DIFF[6] DIFF[5] DIFF[4] DIFF[3] DIFF[2] DIFF[1] DIFF[0] CO
*.CONNECT DIFF[0] B[0]
XFE_RC_785_0 AN2B1T $PINS O=n12 I1=n11 B1=B[5]
XFE_RC_720_0 XNR2HS $PINS O=DIFF[6] I1=B[6] I2=n12
XFE_RC_586_0 AN2B1T $PINS O=n13 I1=n12 B1=B[6]
XFE_RC_509_0 XNR2HS $PINS O=DIFF[3] I1=B[3] I2=n2
XFE_RC_27_0 XOR2HS $PINS O=DIFF[4] I1=n3 I2=n48
XFE_OFC641_term3_shifted_4 INV2 $PINS O=n48 I=B[4]
XU4 INV1S $PINS O=n47 I=B[5]
XU5 INV2 $PINS O=n50 I=B[2]
XU9 AN2T $PINS O=n1 I1=n51 I2=n52
XU10 AN2T $PINS O=n2 I1=n50 I2=n1
XU11 AN2 $PINS O=n3 I1=n2 I2=n49
XU12 AN2 $PINS O=n4 I1=n40 I2=n18
XU13 AN2 $PINS O=n5 I1=n39 I2=n4
XU14 AN2 $PINS O=n6 I1=n38 I2=n5
XU15 AN2 $PINS O=n7 I1=n37 I2=n6
XU16 AN2 $PINS O=n8 I1=n36 I2=n7
XU17 AN2 $PINS O=n9 I1=n35 I2=n8
XU18 AN2 $PINS O=n10 I1=n34 I2=n9
XU19 AN2 $PINS O=n11 I1=n3 I2=n48
XU21 AN2 $PINS O=n14 I1=n45 I2=n13
XU22 AN2 $PINS O=n15 I1=n44 I2=n14
XU23 AN2 $PINS O=n16 I1=n43 I2=n15
XU24 AN2 $PINS O=n17 I1=n42 I2=n16
XU25 AN2 $PINS O=n18 I1=n41 I2=n17
XU26 AN2 $PINS O=n19 I1=n33 I2=n10
XU27 AN2 $PINS O=n20 I1=n32 I2=n19
XU28 AN2 $PINS O=n21 I1=n31 I2=n20
XU29 AN2 $PINS O=n22 I1=n30 I2=n21
XU30 AN2 $PINS O=n23 I1=n29 I2=n22
XU31 AN2 $PINS O=n24 I1=n28 I2=n23
XU32 INV1S $PINS O=n40 I=B[12]
XU33 INV1S $PINS O=n39 I=B[13]
XU34 INV1S $PINS O=n38 I=B[14]
XU35 INV1S $PINS O=n37 I=B[15]
XU36 INV1S $PINS O=n36 I=B[16]
XU37 INV1S $PINS O=n35 I=B[17]
XU38 INV1S $PINS O=n34 I=B[18]
XU40 XOR2HS $PINS O=DIFF[2] I1=n1 I2=n50
XU41 XOR2HS $PINS O=DIFF[9] I1=n43 I2=n15
XU42 XOR2HS $PINS O=DIFF[10] I1=n42 I2=n16
XU43 XOR2HS $PINS O=DIFF[11] I1=n41 I2=n17
XU44 XOR2HS $PINS O=DIFF[12] I1=n40 I2=n18
XU45 XOR2HS $PINS O=DIFF[13] I1=n39 I2=n4
XU46 XOR2HS $PINS O=DIFF[14] I1=n38 I2=n5
XU47 XOR2HS $PINS O=DIFF[15] I1=n37 I2=n6
XU48 XOR2HS $PINS O=DIFF[16] I1=n36 I2=n7
XU49 XOR2HS $PINS O=DIFF[17] I1=n35 I2=n8
XU50 XOR2HS $PINS O=DIFF[18] I1=n34 I2=n9
XU51 XOR2HS $PINS O=DIFF[19] I1=n33 I2=n10
XU52 XOR2HS $PINS O=DIFF[20] I1=n32 I2=n19
XU53 XOR2HS $PINS O=DIFF[21] I1=n31 I2=n20
XU54 XOR2HS $PINS O=DIFF[22] I1=n30 I2=n21
XU55 XOR2HS $PINS O=DIFF[23] I1=n29 I2=n22
XU56 XOR2HS $PINS O=DIFF[24] I1=n28 I2=n23
XU57 XOR2HS $PINS O=DIFF[25] I1=n27 I2=n24
XU58 XOR2HS $PINS O=DIFF[8] I1=n44 I2=n14
XU59 XOR2HS $PINS O=DIFF[7] I1=n45 I2=n13
XU61 XOR2HS $PINS O=DIFF[5] I1=n47 I2=n11
XU63 INV1S $PINS O=n45 I=B[7]
XU65 INV1S $PINS O=n44 I=B[8]
XU66 INV1S $PINS O=n43 I=B[9]
XU67 INV1S $PINS O=n42 I=B[10]
XU68 INV1S $PINS O=n41 I=B[11]
XU69 XOR2HS $PINS O=DIFF[26] I1=B[26] I2=n26
XU70 INV1S $PINS O=n33 I=B[19]
XU71 INV1S $PINS O=n32 I=B[20]
XU72 INV1S $PINS O=n31 I=B[21]
XU73 INV1S $PINS O=n30 I=B[22]
XU74 INV1S $PINS O=n29 I=B[23]
XU75 INV1S $PINS O=n28 I=B[24]
XU76 INV1S $PINS O=n27 I=B[25]
XU78 ND2 $PINS O=n26 I1=n27 I2=n24
XU1 XOR2HS $PINS O=DIFF[1] I1=n52 I2=n51
XU2 INV2 $PINS O=n51 I=B[1]
XU6 INV1S $PINS O=n49 I=B[3]
XU7 INV2 $PINS O=n52 I=B[0]
.ENDS

.SUBCKT PE_Shift_Add_1_DW01_sub_1_DW01_sub_4 A[26] A[25] A[24] A[23] A[22]
+ A[21] A[20] A[19] A[18] A[17] A[16] A[15] A[14] A[13] A[12] A[11] A[10] A[9]
+ A[8] A[7] A[6] A[5] A[4] A[3] A[2] A[1] A[0] B[26] B[25] B[24] B[23] B[22]
+ B[21] B[20] B[19] B[18] B[17] B[16] B[15] B[14] B[13] B[12] B[11] B[10] B[9]
+ B[8] B[7] B[6] B[5] B[4] B[3] B[2] B[1] B[0] CI DIFF[26] DIFF[25] DIFF[24]
+ DIFF[23] DIFF[22] DIFF[21] DIFF[20] DIFF[19] DIFF[18] DIFF[17] DIFF[16]
+ DIFF[15] DIFF[14] DIFF[13] DIFF[12] DIFF[11] DIFF[10] DIFF[9] DIFF[8] DIFF[7]
+ DIFF[6] DIFF[5] DIFF[4] DIFF[3] DIFF[2] DIFF[1] DIFF[0] CO
*.CONNECT DIFF[0] B[0]
XFE_RC_635_0 AN2B1 $PINS O=n14 I1=n13 B1=B[6]
XFE_RC_514_0 AN2B1S $PINS O=n4 I1=n3 B1=B[3]
XFE_RC_203_0 XOR2HS $PINS O=DIFF[8] I1=n45 I2=n15
XFE_RC_91_0 XOR2HS $PINS O=DIFF[5] I1=n48 I2=n12
XFE_RC_286_0 INV1S $PINS O=FE_RN_20_0 I=n53
XFE_RC_285_0 MXL2HS $PINS OB=DIFF[1] S=n52 A=FE_RN_20_0 B=n53
XFE_OFC640_term2_shifted_3 INV1S $PINS O=n50 I=B[3]
XU2 INV2 $PINS O=n52 I=B[1]
XU3 NR2 $PINS O=n2 I1=DIFF[0] I2=B[1]
XU7 INV2 $PINS O=n49 I=B[4]
XU8 INV1S $PINS O=n48 I=B[5]
XU10 INV2 $PINS O=n51 I=B[2]
XU12 AN2 $PINS O=n3 I1=n51 I2=n2
XU13 AN2 $PINS O=n5 I1=n41 I2=n19
XU14 AN2 $PINS O=n6 I1=n40 I2=n5
XU15 AN2 $PINS O=n7 I1=n39 I2=n6
XU16 AN2 $PINS O=n8 I1=n38 I2=n7
XU17 AN2 $PINS O=n9 I1=n37 I2=n8
XU18 AN2 $PINS O=n10 I1=n36 I2=n9
XU19 AN2 $PINS O=n11 I1=n35 I2=n10
XU20 AN2 $PINS O=n12 I1=n49 I2=n4
XU21 AN2 $PINS O=n13 I1=n48 I2=n12
XU22 AN2 $PINS O=n15 I1=n46 I2=n14
XU23 AN2 $PINS O=n16 I1=n45 I2=n15
XU24 AN2 $PINS O=n17 I1=n44 I2=n16
XU25 AN2 $PINS O=n18 I1=n43 I2=n17
XU26 AN2 $PINS O=n19 I1=n42 I2=n18
XU27 AN2 $PINS O=n20 I1=n34 I2=n11
XU28 AN2 $PINS O=n21 I1=n33 I2=n20
XU29 AN2 $PINS O=n22 I1=n32 I2=n21
XU30 AN2 $PINS O=n23 I1=n31 I2=n22
XU31 AN2 $PINS O=n24 I1=n30 I2=n23
XU32 AN2 $PINS O=n25 I1=n29 I2=n24
XU33 INV1S $PINS O=n41 I=B[12]
XU34 INV1S $PINS O=n40 I=B[13]
XU35 INV1S $PINS O=n39 I=B[14]
XU36 INV1S $PINS O=n38 I=B[15]
XU37 INV1S $PINS O=n37 I=B[16]
XU38 INV1S $PINS O=n36 I=B[17]
XU39 INV1S $PINS O=n35 I=B[18]
XU40 INV1S $PINS O=n46 I=B[7]
XU41 INV1S $PINS O=n47 I=B[6]
XU42 INV1S $PINS O=n45 I=B[8]
XU43 INV1S $PINS O=n44 I=B[9]
XU44 INV1S $PINS O=n43 I=B[10]
XU45 INV1S $PINS O=n42 I=B[11]
XU46 XOR2HS $PINS O=DIFF[26] I1=B[26] I2=n27
XU47 INV1S $PINS O=n34 I=B[19]
XU48 INV1S $PINS O=n33 I=B[20]
XU49 INV1S $PINS O=n32 I=B[21]
XU50 INV1S $PINS O=n31 I=B[22]
XU51 INV1S $PINS O=n30 I=B[23]
XU52 INV1S $PINS O=n29 I=B[24]
XU53 INV1S $PINS O=n28 I=B[25]
XU54 XOR2HS $PINS O=DIFF[2] I1=n2 I2=n51
XU55 XOR2HS $PINS O=DIFF[9] I1=n44 I2=n16
XU56 XOR2HS $PINS O=DIFF[10] I1=n43 I2=n17
XU58 XOR2HS $PINS O=DIFF[11] I1=n42 I2=n18
XU59 XOR2HS $PINS O=DIFF[12] I1=n41 I2=n19
XU60 XOR2HS $PINS O=DIFF[13] I1=n40 I2=n5
XU61 XOR2HS $PINS O=DIFF[14] I1=n39 I2=n6
XU62 XOR2HS $PINS O=DIFF[15] I1=n38 I2=n7
XU63 XOR2HS $PINS O=DIFF[16] I1=n37 I2=n8
XU64 XOR2HS $PINS O=DIFF[17] I1=n36 I2=n9
XU65 XOR2HS $PINS O=DIFF[18] I1=n35 I2=n10
XU66 XOR2HS $PINS O=DIFF[19] I1=n34 I2=n11
XU67 XOR2HS $PINS O=DIFF[20] I1=n33 I2=n20
XU68 XOR2HS $PINS O=DIFF[21] I1=n32 I2=n21
XU69 XOR2HS $PINS O=DIFF[22] I1=n31 I2=n22
XU70 XOR2HS $PINS O=DIFF[23] I1=n30 I2=n23
XU71 XOR2HS $PINS O=DIFF[24] I1=n29 I2=n24
XU72 XOR2HS $PINS O=DIFF[25] I1=n28 I2=n25
XU73 XOR2HS $PINS O=DIFF[7] I1=n46 I2=n14
XU74 XOR2HS $PINS O=DIFF[6] I1=n47 I2=n13
XU76 XOR2HS $PINS O=DIFF[4] I1=n4 I2=n49
XU77 XOR2HS $PINS O=DIFF[3] I1=n50 I2=n3
XU79 ND2 $PINS O=n27 I1=n28 I2=n25
XU1 INV2 $PINS O=n53 I=B[0]
.ENDS

.SUBCKT PE_Shift_Add_1_DW01_sub_2_DW01_sub_5 A[26] A[25] A[24] A[23] A[22]
+ A[21] A[20] A[19] A[18] A[17] A[16] A[15] A[14] A[13] A[12] A[11] A[10] A[9]
+ A[8] A[7] A[6] A[5] A[4] A[3] A[2] A[1] A[0] B[26] B[25] B[24] B[23] B[22]
+ B[21] B[20] B[19] B[18] B[17] B[16] B[15] B[14] B[13] B[12] B[11] B[10] B[9]
+ B[8] B[7] B[6] B[5] B[4] B[3] B[2] B[1] B[0] CI DIFF[26] DIFF[25] DIFF[24]
+ DIFF[23] DIFF[22] DIFF[21] DIFF[20] DIFF[19] DIFF[18] DIFF[17] DIFF[16]
+ DIFF[15] DIFF[14] DIFF[13] DIFF[12] DIFF[11] DIFF[10] DIFF[9] DIFF[8] DIFF[7]
+ DIFF[6] DIFF[5] DIFF[4] DIFF[3] DIFF[2] DIFF[1] DIFF[0] CO
XFE_RC_646_0 AN2B1T $PINS O=n14 I1=n13 B1=B[7]
XFE_OFC715_term1_shifted_0 INV1S $PINS O=n52 I=B[0]
XFE_RC_1575_0 AN2 $PINS O=FE_RN_364_0 I1=n4 I2=n38
XFE_RC_1574_0 AN2 $PINS O=n6 I1=FE_RN_364_0 I2=n39
XFE_RC_1261_0 OR2P $PINS O=FE_RN_191_0 I1=B[0] I2=B[1]
XFE_RC_1260_0 XOR2HS $PINS O=DIFF[2] I1=FE_RN_191_0 I2=B[2]
XFE_OFC431_term1_shifted_3 INV1S $PINS O=n49 I=B[3]
XU3 INV1S $PINS O=n50 I=B[2]
XU5 INV1S $PINS O=n46 I=B[6]
XU6 INV1S $PINS O=n45 I=B[7]
XU7 INV1S $PINS O=n51 I=B[1]
XU9 ND2S $PINS O=n26 I1=n27 I2=n24
XU10 INV2 $PINS O=n48 I=B[4]
XU11 XOR2HS $PINS O=DIFF[3] I1=n49 I2=n3
XU12 AN2S $PINS O=n1 I1=n51 I2=n52
XU13 AN2 $PINS O=n2 I1=n3 I2=n49
XU14 AN2 $PINS O=n3 I1=n1 I2=n50
XU15 XOR2HS $PINS O=DIFF[12] I1=n40 I2=n18
XU16 XOR2HS $PINS O=DIFF[13] I1=n39 I2=n4
XU17 AN2 $PINS O=n4 I1=n40 I2=n18
XU18 XOR2HS $PINS O=DIFF[14] I1=n38 I2=n5
XU19 AN2 $PINS O=n5 I1=n39 I2=n4
XU20 XOR2HS $PINS O=DIFF[15] I1=n37 I2=n6
XU22 XOR2HS $PINS O=DIFF[16] I1=n36 I2=n7
XU23 AN2 $PINS O=n7 I1=n37 I2=n6
XU24 XOR2HS $PINS O=DIFF[17] I1=n35 I2=n8
XU25 AN2 $PINS O=n8 I1=n36 I2=n7
XU26 XOR2HS $PINS O=DIFF[18] I1=n34 I2=n9
XU27 AN2 $PINS O=n9 I1=n35 I2=n8
XU28 AN2 $PINS O=n10 I1=n34 I2=n9
XU29 XOR2HS $PINS O=DIFF[4] I1=n2 I2=n48
XU30 XOR2HS $PINS O=DIFF[5] I1=n47 I2=n11
XU31 AN2T $PINS O=n11 I1=n48 I2=n2
XU32 XOR2HS $PINS O=DIFF[6] I1=n46 I2=n12
XU33 AN2 $PINS O=n12 I1=n11 I2=n47
XU34 XOR2HS $PINS O=DIFF[7] I1=n45 I2=n13
XU35 AN2 $PINS O=n13 I1=n46 I2=n12
XU36 XOR2HS $PINS O=DIFF[8] I1=n44 I2=n14
XU38 XOR2HS $PINS O=DIFF[9] I1=n43 I2=n15
XU39 AN2 $PINS O=n15 I1=n44 I2=n14
XU40 XOR2HS $PINS O=DIFF[10] I1=n42 I2=n16
XU41 AN2 $PINS O=n16 I1=n43 I2=n15
XU42 XOR2HS $PINS O=DIFF[11] I1=n41 I2=n17
XU43 AN2 $PINS O=n17 I1=n42 I2=n16
XU44 AN2 $PINS O=n18 I1=n41 I2=n17
XU45 XOR2HS $PINS O=DIFF[19] I1=n33 I2=n10
XU46 XOR2HS $PINS O=DIFF[20] I1=n32 I2=n19
XU47 AN2 $PINS O=n19 I1=n33 I2=n10
XU48 XOR2HS $PINS O=DIFF[21] I1=n31 I2=n20
XU49 AN2 $PINS O=n20 I1=n32 I2=n19
XU50 XOR2HS $PINS O=DIFF[22] I1=n30 I2=n21
XU51 AN2 $PINS O=n21 I1=n31 I2=n20
XU52 XOR2HS $PINS O=DIFF[23] I1=n29 I2=n22
XU53 AN2 $PINS O=n22 I1=n30 I2=n21
XU54 XOR2HS $PINS O=DIFF[24] I1=n28 I2=n23
XU55 AN2 $PINS O=n23 I1=n29 I2=n22
XU56 AN2 $PINS O=n24 I1=n28 I2=n23
XU57 XOR2HS $PINS O=DIFF[25] I1=n27 I2=n24
XU58 INV1S $PINS O=n40 I=B[12]
XU59 INV1S $PINS O=n39 I=B[13]
XU60 INV1S $PINS O=n38 I=B[14]
XU61 INV1S $PINS O=n37 I=B[15]
XU62 INV1S $PINS O=n36 I=B[16]
XU63 INV1S $PINS O=n35 I=B[17]
XU64 INV1S $PINS O=n34 I=B[18]
XU65 INV1S $PINS O=n47 I=B[5]
XU66 INV1S $PINS O=n44 I=B[8]
XU67 INV1S $PINS O=n43 I=B[9]
XU68 INV1S $PINS O=n42 I=B[10]
XU69 INV1S $PINS O=n41 I=B[11]
XU70 XOR2HS $PINS O=DIFF[26] I1=B[26] I2=n26
XU71 INV1S $PINS O=n33 I=B[19]
XU72 INV1S $PINS O=n32 I=B[20]
XU73 INV1S $PINS O=n31 I=B[21]
XU74 INV1S $PINS O=n30 I=B[22]
XU75 INV1S $PINS O=n29 I=B[23]
XU76 INV1S $PINS O=n28 I=B[24]
XU77 INV1S $PINS O=n27 I=B[25]
XU1 XNR2HS $PINS O=DIFF[1] I1=n52 I2=B[1]
.ENDS

.SUBCKT PE_Shift_Add_1_DW01_add_2_DW01_add_16 A[26] A[25] A[24] A[23] A[22]
+ A[21] A[20] A[19] A[18] A[17] A[16] A[15] A[14] A[13] A[12] A[11] A[10] A[9]
+ A[8] A[7] A[6] A[5] A[4] A[3] A[2] A[1] A[0] B[26] B[25] B[24] B[23] B[22]
+ B[21] B[20] B[19] B[18] B[17] B[16] B[15] B[14] B[13] B[12] B[11] B[10] B[9]
+ B[8] B[7] B[6] B[5] B[4] B[3] B[2] B[1] B[0] CI SUM[26] SUM[25] SUM[24]
+ SUM[23] SUM[22] SUM[21] SUM[20] SUM[19] SUM[18] SUM[17] SUM[16] SUM[15]
+ SUM[14] SUM[13] SUM[12] SUM[11] SUM[10] SUM[9] SUM[8] SUM[7] SUM[6] SUM[5]
+ SUM[4] SUM[3] SUM[2] SUM[1] SUM[0] CO
XFE_RC_848_0 INV2 $PINS O=SUM[11] I=FE_RN_403_0
XFE_RC_847_1 XNR3 $PINS O=FE_RN_403_0 I1=A[11] I2=B[11] I3=carry[11]
XFE_RC_839_0 INV2 $PINS O=SUM[21] I=FE_RN_398_0
XFE_RC_838_0 XNR3 $PINS O=FE_RN_398_0 I1=A[21] I2=B[21] I3=carry[21]
XFE_RC_813_0 INV1S $PINS O=FE_RN_388_0 I=B[16]
XFE_RC_812_0 AO13P $PINS O=n10 A1=FE_RN_388_0 B1=n5 B2=n6 B3=n4
XFE_RC_593_0 INV2 $PINS O=SUM[7] I=FE_RN_293_0
XFE_RC_592_0 XNR3 $PINS O=FE_RN_293_0 I1=A[7] I2=B[7] I3=carry[7]
XFE_RC_559_0 INV2 $PINS O=SUM[1] I=FE_RN_280_0
XFE_RC_558_0 XNR3 $PINS O=FE_RN_280_0 I1=n3 I2=A[1] I3=B[1]
XFE_RC_531_0 INV2 $PINS O=SUM[14] I=FE_RN_268_0
XFE_RC_530_0 XNR3 $PINS O=FE_RN_268_0 I1=A[14] I2=B[14] I3=carry[14]
XFE_RC_522_0 INV2 $PINS O=SUM[26] I=FE_RN_264_0
XFE_RC_521_0 XNR3 $PINS O=FE_RN_264_0 I1=A[26] I2=B[26] I3=carry[26]
XFE_RC_516_0 INV2 $PINS O=SUM[13] I=FE_RN_263_0
XFE_RC_515_0 XNR3 $PINS O=FE_RN_263_0 I1=A[13] I2=B[13] I3=carry[13]
XFE_RC_429_0 INV2 $PINS O=SUM[2] I=FE_RN_225_0
XFE_RC_428_0 XNR3 $PINS O=FE_RN_225_0 I1=A[2] I2=B[2] I3=carry[2]
XFE_RC_328_0 ND2 $PINS O=FE_RN_178_0 I1=A[13] I2=B[13]
XFE_RC_327_1 ND2P $PINS O=FE_RN_179_0 I1=carry[13] I2=A[13]
XFE_RC_326_0 ND2P $PINS O=FE_RN_180_0 I1=carry[13] I2=B[13]
XFE_RC_325_0 ND3HT $PINS O=carry[14] I1=FE_RN_180_0 I2=FE_RN_179_0
+ I3=FE_RN_178_0
XFE_RC_322_0 ND2 $PINS O=FE_RN_174_0 I1=B[21] I2=A[21]
XFE_RC_321_0 ND2P $PINS O=FE_RN_175_0 I1=carry[21] I2=A[21]
XFE_RC_320_0 ND2P $PINS O=FE_RN_176_0 I1=carry[21] I2=B[21]
XFE_RC_319_0 ND3P $PINS O=carry[22] I1=FE_RN_176_0 I2=FE_RN_175_0
+ I3=FE_RN_174_0
XFE_RC_256_0 ND3HT $PINS O=carry[15] I1=FE_RN_52_0 I2=FE_RN_53_0 I3=FE_RN_51_0
XFE_RC_90_0 ND2 $PINS O=FE_RN_51_0 I1=A[14] I2=B[14]
XFE_RC_89_0 ND2P $PINS O=FE_RN_52_0 I1=carry[14] I2=A[14]
XFE_RC_88_0 ND2P $PINS O=FE_RN_53_0 I1=carry[14] I2=B[14]
XFE_RC_81_0 ND2 $PINS O=FE_RN_45_0 I1=B[2] I2=A[2]
XFE_RC_80_0 ND2P $PINS O=FE_RN_46_0 I1=carry[2] I2=A[2]
XFE_RC_79_0 ND2 $PINS O=FE_RN_47_0 I1=carry[2] I2=B[2]
XFE_RC_78_0 ND3P $PINS O=carry[3] I1=FE_RN_47_0 I2=FE_RN_45_0 I3=FE_RN_46_0
XFE_RC_55_0 ND3P $PINS O=carry[5] I1=n16 I2=n17 I3=n18
XFE_RC_1590_0 INV2 $PINS O=SUM[20] I=FE_RN_372_0
XFE_RC_1589_0 XNR3 $PINS O=FE_RN_372_0 I1=A[20] I2=B[20] I3=carry[20]
XFE_RC_1319_0 INV2 $PINS O=SUM[15] I=FE_RN_223_0
XFE_RC_1318_0 XNR3 $PINS O=FE_RN_223_0 I1=A[15] I2=B[15] I3=carry[15]
XFE_RC_1024_0 XOR3 $PINS O=SUM[25] I1=A[25] I2=B[25] I3=carry[25]
XFE_RC_1023_0 MAO222 $PINS O=carry[26] A1=carry[25] B1=B[25] C1=A[25]
XFE_RC_972_0 XOR3 $PINS O=SUM[24] I1=A[24] I2=B[24] I3=carry[24]
XFE_RC_971_0 MAO222 $PINS O=carry[25] A1=carry[24] B1=B[24] C1=A[24]
XFE_RC_847_0 MAO222P $PINS O=carry[2] A1=B[1] B1=A[1] C1=n3
XFE_RC_808_0 XOR3 $PINS O=SUM[23] I1=A[23] I2=B[23] I3=carry[23]
XFE_RC_807_0 MAO222P $PINS O=carry[24] A1=carry[23] B1=B[23] C1=A[23]
XFE_RC_732_0 XOR3 $PINS O=SUM[22] I1=A[22] I2=B[22] I3=carry[22]
XFE_RC_731_0 MAO222P $PINS O=carry[23] A1=carry[22] B1=B[22] C1=A[22]
XFE_RC_610_0 XOR3 $PINS O=SUM[19] I1=A[19] I2=B[19] I3=carry[19]
XFE_RC_609_0 MAO222P $PINS O=carry[20] A1=carry[19] B1=B[19] C1=A[19]
XFE_RC_555_0 MAO222P $PINS O=carry[21] A1=carry[20] B1=B[20] C1=A[20]
XFE_RC_518_0 XOR3 $PINS O=SUM[5] I1=A[5] I2=B[5] I3=carry[5]
XFE_RC_517_0 MAO222P $PINS O=carry[6] A1=carry[5] B1=B[5] C1=A[5]
XFE_RC_406_0 XOR3 $PINS O=SUM[6] I1=A[6] I2=B[6] I3=carry[6]
XFE_RC_405_0 MAO222P $PINS O=carry[7] A1=carry[6] B1=B[6] C1=A[6]
XFE_RC_400_0 XOR3 $PINS O=SUM[18] I1=A[18] I2=B[18] I3=carry[18]
XFE_RC_399_0 MAO222P $PINS O=carry[19] A1=carry[18] B1=B[18] C1=A[18]
XFE_RC_327_0 MAO222P $PINS O=carry[8] A1=carry[7] B1=B[7] C1=A[7]
XFE_RC_324_0 XOR3 $PINS O=SUM[3] I1=B[3] I2=A[3] I3=carry[3]
XFE_RC_323_0 MAO222P $PINS O=carry[4] A1=carry[3] B1=B[3] C1=A[3]
XFE_RC_254_0 XOR3 $PINS O=SUM[8] I1=A[8] I2=B[8] I3=carry[8]
XFE_RC_253_0 MAO222P $PINS O=carry[9] A1=carry[8] B1=B[8] C1=A[8]
XFE_RC_232_0 ND2 $PINS O=FE_RN_17_0 I1=carry[10] I2=B[10]
XFE_RC_231_0 AOI22H $PINS O=FE_RN_18_0 A1=A[10] A2=B[10] B1=carry[10] B2=A[10]
XFE_RC_230_0 ND2P $PINS O=carry[11] I1=FE_RN_18_0 I2=FE_RN_17_0
XFE_RC_124_0 XOR3 $PINS O=SUM[9] I1=A[9] I2=B[9] I3=carry[9]
XFE_RC_123_0 MAO222P $PINS O=carry[10] A1=carry[9] B1=B[9] C1=A[9]
XFE_RC_76_0 XOR3 $PINS O=SUM[10] I1=A[10] I2=B[10] I3=carry[10]
XFE_RC_41_0 MAO222P $PINS O=carry[12] A1=carry[11] B1=B[11] C1=A[11]
XFE_RC_22_0 XOR3 $PINS O=SUM[12] I1=A[12] I2=B[12] I3=carry[12]
XFE_RC_21_0 MAO222P $PINS O=carry[13] A1=carry[12] B1=B[12] C1=A[12]
XU2 ND2P $PINS O=n13 I1=carry[17] I2=B[17]
XU3 ND2P $PINS O=n12 I1=carry[17] I2=A[17]
XU7 AN2T $PINS O=n3 I1=B[0] I2=A[0]
XU8 ND2 $PINS O=n4 I1=A[15] I2=B[15]
XU9 ND2T $PINS O=n5 I1=carry[15] I2=A[15]
XU10 ND2T $PINS O=n6 I1=carry[15] I2=B[15]
XU11 ND3HT $PINS O=carry[16] I1=n5 I2=n6 I3=n4
XU12 XOR2HS $PINS O=n7 I1=A[16] I2=B[16]
XU13 XOR2HS $PINS O=SUM[16] I1=n7 I2=carry[16]
XU14 ND2 $PINS O=n8 I1=A[16] I2=B[16]
XU15 ND2T $PINS O=n9 I1=carry[16] I2=A[16]
XU18 ND2 $PINS O=n18 I1=B[4] I2=A[4]
XU19 XOR2HS $PINS O=n11 I1=A[17] I2=B[17]
XU20 XOR2HS $PINS O=SUM[17] I1=carry[17] I2=n11
XU21 ND2 $PINS O=n14 I1=A[17] I2=B[17]
XU22 ND3P $PINS O=carry[18] I1=n12 I2=n13 I3=n14
XU23 XOR2HS $PINS O=n15 I1=A[4] I2=B[4]
XU24 XOR2HS $PINS O=SUM[4] I1=carry[4] I2=n15
XU25 ND2P $PINS O=n16 I1=carry[4] I2=A[4]
XU26 ND2P $PINS O=n17 I1=carry[4] I2=B[4]
XU27 XOR2HS $PINS O=SUM[0] I1=B[0] I2=A[0]
XU1 ND3HT $PINS O=carry[17] I1=n10 I2=n9 I3=n8
.ENDS

.SUBCKT PE_Shift_Add_1_DW01_add_1_DW01_add_15 A[26] A[25] A[24] A[23] A[22]
+ A[21] A[20] A[19] A[18] A[17] A[16] A[15] A[14] A[13] A[12] A[11] A[10] A[9]
+ A[8] A[7] A[6] A[5] A[4] A[3] A[2] A[1] A[0] B[26] B[25] B[24] B[23] B[22]
+ B[21] B[20] B[19] B[18] B[17] B[16] B[15] B[14] B[13] B[12] B[11] B[10] B[9]
+ B[8] B[7] B[6] B[5] B[4] B[3] B[2] B[1] B[0] CI SUM[26] SUM[25] SUM[24]
+ SUM[23] SUM[22] SUM[21] SUM[20] SUM[19] SUM[18] SUM[17] SUM[16] SUM[15]
+ SUM[14] SUM[13] SUM[12] SUM[11] SUM[10] SUM[9] SUM[8] SUM[7] SUM[6] SUM[5]
+ SUM[4] SUM[3] SUM[2] SUM[1] SUM[0] CO
XFE_RC_823_1 INV2 $PINS O=SUM[11] I=FE_RN_393_0
XFE_RC_822_0 XNR3 $PINS O=FE_RN_393_0 I1=A[11] I2=B[11] I3=carry[11]
XFE_RC_710_1 INV2 $PINS O=SUM[1] I=FE_RN_342_0
XFE_RC_709_1 XNR3 $PINS O=FE_RN_342_0 I1=A[1] I2=carry[1] I3=B[1]
XFE_RC_706_0 INV2 $PINS O=SUM[15] I=FE_RN_340_0
XFE_RC_705_0 XNR3 $PINS O=FE_RN_340_0 I1=B[15] I2=A[15] I3=carry[15]
XFE_RC_670_0 INV2 $PINS O=SUM[3] I=FE_RN_322_0
XFE_RC_669_0 XNR3 $PINS O=FE_RN_322_0 I1=A[3] I2=B[3] I3=carry[3]
XFE_RC_500_0 INV2 $PINS O=SUM[8] I=FE_RN_257_0
XFE_RC_499_0 XNR3 $PINS O=FE_RN_257_0 I1=B[8] I2=A[8] I3=n1
XFE_RC_498_0 INV2 $PINS O=SUM[2] I=FE_RN_256_0
XFE_RC_497_0 XNR3 $PINS O=FE_RN_256_0 I1=A[2] I2=B[2] I3=carry[2]
XFE_RC_496_0 INV2 $PINS O=SUM[6] I=FE_RN_255_0
XFE_RC_495_0 XNR3 $PINS O=FE_RN_255_0 I1=B[6] I2=A[6] I3=carry[6]
XFE_RC_417_0 XNR2HS $PINS O=FE_RN_221_0 I1=A[26] I2=B[26]
XFE_RC_416_0 INV1S $PINS O=FE_RN_220_0 I=FE_RN_221_0
XFE_RC_415_0 XOR2HS $PINS O=SUM[26] I1=FE_RN_220_0 I2=carry[26]
XFE_RC_285_0 ND2 $PINS O=FE_RN_153_0 I1=B[21] I2=A[21]
XFE_RC_284_0 ND2 $PINS O=FE_RN_154_0 I1=carry[21] I2=A[21]
XFE_RC_283_0 ND2 $PINS O=FE_RN_155_0 I1=carry[21] I2=B[21]
XFE_RC_282_0 ND3 $PINS O=carry[22] I1=FE_RN_155_0 I2=FE_RN_154_0 I3=FE_RN_153_0
XFE_RC_1329_0 XOR3 $PINS O=SUM[25] I1=A[25] I2=B[25] I3=carry[25]
XFE_RC_1328_0 MAO222 $PINS O=carry[26] A1=carry[25] B1=B[25] C1=A[25]
XFE_RC_1075_0 XOR3 $PINS O=SUM[7] I1=A[7] I2=B[7] I3=carry[7]
XFE_RC_1071_0 XOR3 $PINS O=SUM[24] I1=A[24] I2=B[24] I3=carry[24]
XFE_RC_1070_0 MAO222 $PINS O=carry[25] A1=carry[24] B1=B[24] C1=A[24]
XFE_RC_996_0 XOR3 $PINS O=SUM[23] I1=A[23] I2=B[23] I3=carry[23]
XFE_RC_995_0 MAO222 $PINS O=carry[24] A1=carry[23] B1=B[23] C1=A[23]
XFE_RC_954_0 XOR3 $PINS O=SUM[22] I1=A[22] I2=B[22] I3=carry[22]
XFE_RC_953_0 MAO222 $PINS O=carry[23] A1=carry[22] B1=B[22] C1=A[22]
XFE_RC_917_0 XOR3 $PINS O=SUM[21] I1=A[21] I2=B[21] I3=carry[21]
XFE_RC_850_0 XOR3 $PINS O=SUM[20] I1=A[20] I2=B[20] I3=carry[20]
XFE_RC_849_0 MAO222P $PINS O=carry[21] A1=carry[20] B1=B[20] C1=A[20]
XFE_RC_824_0 XOR3 $PINS O=SUM[19] I1=A[19] I2=B[19] I3=carry[19]
XFE_RC_823_0 MAO222P $PINS O=carry[20] A1=carry[19] B1=B[19] C1=A[19]
XFE_RC_768_0 XOR3 $PINS O=SUM[18] I1=A[18] I2=B[18] I3=carry[18]
XFE_RC_767_0 MAO222P $PINS O=carry[19] A1=carry[18] B1=B[18] C1=A[18]
XFE_RC_710_0 XOR3 $PINS O=SUM[17] I1=A[17] I2=B[17] I3=carry[17]
XFE_RC_709_0 MAO222 $PINS O=carry[18] A1=carry[17] B1=B[17] C1=A[17]
XFE_RC_666_0 XOR3 $PINS O=SUM[9] I1=A[9] I2=B[9] I3=carry[9]
XFE_RC_665_0 MAO222 $PINS O=carry[10] A1=carry[9] B1=B[9] C1=A[9]
XFE_RC_628_0 XOR3 $PINS O=SUM[10] I1=A[10] I2=B[10] I3=carry[10]
XFE_RC_627_0 MAO222 $PINS O=carry[11] A1=carry[10] B1=B[10] C1=A[10]
XFE_RC_573_0 MAO222 $PINS O=carry[12] A1=carry[11] B1=B[11] C1=A[11]
XFE_RC_506_0 XOR3 $PINS O=SUM[12] I1=A[12] I2=B[12] I3=carry[12]
XFE_RC_505_0 MAO222 $PINS O=carry[13] A1=carry[12] B1=B[12] C1=A[12]
XFE_RC_456_0 XOR3 $PINS O=SUM[13] I1=A[13] I2=B[13] I3=carry[13]
XFE_RC_455_0 MAO222 $PINS O=carry[14] A1=carry[13] B1=B[13] C1=A[13]
XFE_RC_446_0 XOR3 $PINS O=SUM[16] I1=A[16] I2=B[16] I3=carry[16]
XFE_RC_445_0 MAO222 $PINS O=carry[17] A1=carry[16] B1=B[16] C1=A[16]
XFE_RC_335_0 MAO222 $PINS O=carry[2] A1=B[1] B1=A[1] C1=carry[1]
XFE_RC_332_0 XOR3 $PINS O=SUM[14] I1=A[14] I2=B[14] I3=carry[14]
XFE_RC_331_0 MAO222P $PINS O=carry[15] A1=carry[14] B1=B[14] C1=A[14]
XFE_RC_275_0 MAO222 $PINS O=carry[3] A1=carry[2] B1=B[2] C1=A[2]
XFE_RC_137_0 MAO222 $PINS O=carry[4] A1=carry[3] B1=A[3] C1=B[3]
XFE_RC_90_0 XOR3 $PINS O=SUM[4] I1=A[4] I2=B[4] I3=carry[4]
XFE_RC_89_0 MAO222 $PINS O=carry[5] A1=carry[4] B1=B[4] C1=A[4]
XFE_RC_52_0 XOR3 $PINS O=SUM[5] I1=A[5] I2=B[5] I3=carry[5]
XFE_RC_51_0 MAO222P $PINS O=carry[6] A1=carry[5] B1=B[5] C1=A[5]
XFE_RC_46_0 ND3P $PINS O=carry[7] I1=n5 I2=n6 I3=n7
XFE_RC_45_0 ND3P $PINS O=carry[9] I1=n9 I2=n8 I3=n10
XU2 MAO222P $PINS O=n1 A1=carry[7] B1=B[7] C1=A[7]
XU3 ND2 $PINS O=n11 I1=B[0] I2=A[0]
XU6 ND2P $PINS O=n2 I1=carry[15] I2=B[15]
XU7 ND2P $PINS O=n3 I1=carry[15] I2=A[15]
XU8 ND2 $PINS O=n4 I1=B[15] I2=A[15]
XU11 INV1S $PINS O=carry[1] I=n11
XU14 ND2S $PINS O=n7 I1=B[6] I2=A[6]
XU15 ND2 $PINS O=n10 I1=B[8] I2=A[8]
XU16 ND2 $PINS O=n5 I1=carry[6] I2=B[6]
XU17 ND2 $PINS O=n6 I1=carry[6] I2=A[6]
XU18 ND2P $PINS O=n8 I1=n1 I2=B[8]
XU19 ND2 $PINS O=n9 I1=n1 I2=A[8]
XU20 XOR2HS $PINS O=SUM[0] I1=B[0] I2=A[0]
XU13 ND3P $PINS O=carry[16] I1=n3 I2=n2 I3=n4
.ENDS

.SUBCKT PE_Shift_Add_1_DW01_add_0_DW01_add_14 A[26] A[25] A[24] A[23] A[22]
+ A[21] A[20] A[19] A[18] A[17] A[16] A[15] A[14] A[13] A[12] A[11] A[10] A[9]
+ A[8] A[7] A[6] A[5] A[4] A[3] A[2] A[1] A[0] B[26] B[25] B[24] B[23] B[22]
+ B[21] B[20] B[19] B[18] B[17] B[16] B[15] B[14] B[13] B[12] B[11] B[10] B[9]
+ B[8] B[7] B[6] B[5] B[4] B[3] B[2] B[1] B[0] CI SUM[26] SUM[25] SUM[24]
+ SUM[23] SUM[22] SUM[21] SUM[20] SUM[19] SUM[18] SUM[17] SUM[16] SUM[15]
+ SUM[14] SUM[13] SUM[12] SUM[11] SUM[10] SUM[9] SUM[8] SUM[7] SUM[6] SUM[5]
+ SUM[4] SUM[3] SUM[2] SUM[1] SUM[0] CO
XFE_RC_817_0 INV1S $PINS O=FE_RN_390_0 I=B[11]
XFE_RC_816_0 AO13P $PINS O=FE_RN_163_0 A1=FE_RN_390_0 B1=FE_RN_314_0
+ B2=FE_RN_313_0 B3=FE_RN_315_0
XFE_RC_85_0 ND2 $PINS O=FE_RN_48_0 I1=A[7] I2=B[7]
XFE_RC_84_0 ND2P $PINS O=FE_RN_49_0 I1=carry[7] I2=A[7]
XFE_RC_83_0 ND2P $PINS O=FE_RN_50_0 I1=carry[7] I2=B[7]
XFE_RC_82_0 ND3P $PINS O=carry[8] I1=FE_RN_50_0 I2=FE_RN_49_0 I3=FE_RN_48_0
XFE_RC_68_0 ND3P $PINS O=carry[4] I1=n11 I2=n12 I3=n13
XFE_RC_25_0 ND2 $PINS O=FE_RN_14_0 I1=A[9] I2=B[9]
XFE_RC_24_0 ND2P $PINS O=FE_RN_15_0 I1=carry[9] I2=B[9]
XFE_RC_23_0 ND2P $PINS O=FE_RN_16_0 I1=carry[9] I2=A[9]
XFE_RC_22_0 ND3HT $PINS O=carry[10] I1=FE_RN_16_0 I2=FE_RN_15_0 I3=FE_RN_14_0
XFE_RC_21_0 ND2 $PINS O=FE_RN_11_0 I1=A[13] I2=B[13]
XFE_RC_20_0 ND2P $PINS O=FE_RN_12_0 I1=carry[13] I2=A[13]
XFE_RC_19_0 ND2P $PINS O=FE_RN_13_0 I1=carry[13] I2=B[13]
XFE_RC_18_0 ND3HT $PINS O=carry[14] I1=FE_RN_13_0 I2=FE_RN_12_0 I3=FE_RN_11_0
XFE_OCPC708_carry_25 BUF1S $PINS O=FE_OCPN708_carry_25 I=carry[25]
XFE_RC_1486_0 ND2P $PINS O=FE_RN_313_0 I1=carry[10] I2=B[10]
XFE_RC_1485_0 ND2P $PINS O=FE_RN_314_0 I1=carry[10] I2=A[10]
XFE_RC_1484_0 ND2P $PINS O=FE_RN_315_0 I1=A[10] I2=B[10]
XFE_RC_1483_0 ND3P $PINS O=carry[11] I1=FE_RN_314_0 I2=FE_RN_313_0
+ I3=FE_RN_315_0
XFE_RC_1206_0 ND2 $PINS O=FE_RN_161_0 I1=A[11] I2=B[11]
XFE_RC_1205_0 ND2P $PINS O=FE_RN_162_0 I1=carry[11] I2=A[11]
XFE_RC_1203_0 ND3P $PINS O=carry[12] I1=FE_RN_163_0 I2=FE_RN_162_0
+ I3=FE_RN_161_0
XFE_RC_1146_0 XOR3 $PINS O=SUM[25] I1=A[25] I2=B[25] I3=FE_OCPN708_carry_25
XFE_RC_1145_0 MAO222 $PINS O=carry[26] A1=carry[25] B1=B[25] C1=A[25]
XFE_RC_794_0 XOR3 $PINS O=SUM[1] I1=A[1] I2=B[1] I3=n1
XFE_RC_793_0 MAO222 $PINS O=carry[2] A1=A[1] B1=B[1] C1=n1
XFE_RC_720_0 XOR3 $PINS O=SUM[2] I1=A[2] I2=B[2] I3=carry[2]
XFE_RC_719_0 MAO222P $PINS O=carry[3] A1=A[2] B1=B[2] C1=carry[2]
XFE_RC_718_0 XOR3 $PINS O=SUM[6] I1=A[6] I2=B[6] I3=carry[6]
XFE_RC_717_0 MAO222P $PINS O=carry[7] A1=carry[6] B1=B[6] C1=A[6]
XFE_RC_670_0 XOR3 $PINS O=SUM[7] I1=A[7] I2=B[7] I3=carry[7]
XFE_RC_584_0 XOR3 $PINS O=SUM[4] I1=A[4] I2=B[4] I3=carry[4]
XFE_RC_583_0 MAO222P $PINS O=carry[5] A1=carry[4] B1=B[4] C1=A[4]
XFE_RC_578_0 XOR3 $PINS O=SUM[8] I1=A[8] I2=B[8] I3=carry[8]
XFE_RC_577_0 MAO222P $PINS O=carry[9] A1=carry[8] B1=B[8] C1=A[8]
XFE_RC_538_0 XOR3 $PINS O=SUM[9] I1=A[9] I2=B[9] I3=carry[9]
XFE_RC_492_0 XOR3 $PINS O=SUM[10] I1=A[10] I2=B[10] I3=carry[10]
XFE_RC_448_0 XOR3 $PINS O=SUM[11] I1=A[11] I2=B[11] I3=carry[11]
XFE_RC_386_0 XOR3 $PINS O=SUM[12] I1=A[12] I2=B[12] I3=carry[12]
XFE_RC_385_0 MAO222P $PINS O=carry[13] A1=carry[12] B1=B[12] C1=A[12]
XFE_RC_352_0 XOR3 $PINS O=SUM[13] I1=A[13] I2=B[13] I3=carry[13]
XFE_RC_225_0 XOR3S $PINS O=SUM[15] I1=A[15] I2=B[15] I3=carry[15]
XFE_RC_224_0 MAO222P $PINS O=carry[16] A1=carry[15] B1=A[15] C1=B[15]
XFE_RC_223_0 XOR3 $PINS O=SUM[19] I1=A[19] I2=B[19] I3=carry[19]
XFE_RC_222_0 MAO222P $PINS O=carry[20] A1=carry[19] B1=B[19] C1=A[19]
XFE_RC_106_0 XOR3 $PINS O=SUM[21] I1=A[21] I2=B[21] I3=carry[21]
XFE_RC_105_0 MAO222 $PINS O=carry[22] A1=carry[21] B1=B[21] C1=A[21]
XFE_RC_102_0 XOR3S $PINS O=SUM[17] I1=A[17] I2=B[17] I3=carry[17]
XFE_RC_101_0 MAO222P $PINS O=carry[18] A1=carry[17] B1=B[17] C1=A[17]
XFE_RC_74_0 XOR3 $PINS O=SUM[24] I1=A[24] I2=B[24] I3=carry[24]
XFE_RC_73_0 MAO222 $PINS O=carry[25] A1=carry[24] B1=B[24] C1=A[24]
XFE_RC_36_0 XOR3 $PINS O=SUM[22] I1=A[22] I2=B[22] I3=carry[22]
XFE_RC_35_0 MAO222P $PINS O=carry[23] A1=carry[22] B1=B[22] C1=A[22]
XU1_26 XOR3 $PINS O=SUM[26] I1=B[26] I2=A[26] I3=carry[26]
XU1 ND3P $PINS O=carry[17] I1=n9 I2=n8 I3=n10
XU2 ND3P $PINS O=carry[6] I1=n19 I2=n17 I3=n18
XU4 XOR3 $PINS O=SUM[14] I1=A[14] I2=B[14] I3=carry[14]
XU5 XOR3 $PINS O=SUM[16] I1=A[16] I2=B[16] I3=carry[16]
XU6 XOR3 $PINS O=SUM[18] I1=B[18] I2=A[18] I3=carry[18]
XU7 XOR3 $PINS O=SUM[20] I1=B[20] I2=A[20] I3=carry[20]
XU8 AN2 $PINS O=n1 I1=B[0] I2=A[0]
XU9 XOR3 $PINS O=SUM[23] I1=B[23] I2=A[23] I3=carry[23]
XU10 ND2P $PINS O=n2 I1=carry[23] I2=B[23]
XU11 ND2P $PINS O=n3 I1=carry[23] I2=A[23]
XU12 ND2 $PINS O=n4 I1=A[23] I2=B[23]
XU13 ND3P $PINS O=carry[24] I1=n2 I2=n3 I3=n4
XU14 ND2P $PINS O=n5 I1=carry[14] I2=A[14]
XU15 ND2P $PINS O=n6 I1=carry[14] I2=B[14]
XU16 ND2 $PINS O=n7 I1=A[14] I2=B[14]
XU18 ND2P $PINS O=n8 I1=carry[16] I2=A[16]
XU19 ND2 $PINS O=n9 I1=carry[16] I2=B[16]
XU20 ND2 $PINS O=n10 I1=A[16] I2=B[16]
XU21 XOR3 $PINS O=SUM[3] I1=A[3] I2=B[3] I3=carry[3]
XU22 ND2 $PINS O=n11 I1=carry[3] I2=A[3]
XU23 ND2 $PINS O=n12 I1=carry[3] I2=B[3]
XU24 ND2 $PINS O=n13 I1=A[3] I2=B[3]
XU26 ND2P $PINS O=n14 I1=carry[18] I2=B[18]
XU27 ND2P $PINS O=n15 I1=carry[18] I2=A[18]
XU28 ND2 $PINS O=n16 I1=A[18] I2=B[18]
XU29 ND3P $PINS O=carry[19] I1=n14 I2=n15 I3=n16
XU30 XOR3S $PINS O=SUM[5] I1=carry[5] I2=B[5] I3=A[5]
XU31 ND2P $PINS O=n17 I1=carry[5] I2=A[5]
XU32 ND2 $PINS O=n18 I1=A[5] I2=B[5]
XU33 ND2 $PINS O=n19 I1=carry[5] I2=B[5]
XU34 ND2P $PINS O=n20 I1=carry[20] I2=B[20]
XU35 ND2P $PINS O=n21 I1=carry[20] I2=A[20]
XU36 ND2 $PINS O=n22 I1=A[20] I2=B[20]
XU37 XOR2HS $PINS O=SUM[0] I1=B[0] I2=A[0]
XU3 ND3P $PINS O=carry[15] I1=n6 I2=n5 I3=n7
XU17 ND3P $PINS O=carry[21] I1=n20 I2=n21 I3=n22
.ENDS

.SUBCKT PE_Shift_Add_1 rst_n en clear calc_done stage_sel x_in[16] x_in[15]
+ x_in[14] x_in[13] x_in[12] x_in[11] x_in[10] x_in[9] x_in[8] x_in[7] x_in[6]
+ x_in[5] x_in[4] x_in[3] x_in[2] x_in[1] x_in[0] sign1[1] sign1[0] sign2[1]
+ sign2[0] sign3[1] sign3[0] shf1[3] shf1[2] shf1[1] shf1[0] shf2[3] shf2[2]
+ shf2[1] shf2[0] shf3[3] shf3[2] shf3[1] shf3[0] y_out[16] y_out[15] y_out[14]
+ y_out[13] y_out[12] y_out[11] y_out[10] y_out[9] y_out[8] y_out[7] y_out[6]
+ y_out[5] y_out[4] y_out[3] y_out[2] y_out[1] y_out[0] n30 i_rst_n
+ FE_OFN31_i_rst_n FE_OFN26_i_rst_n FE_OFN61_s31_0 FE_OFN62_h31_3
+ FE_OFN63_h31_2 FE_OFN64_s32_0 FE_OFN65_h32_3 FE_OFN66_h32_2 FE_OFN67_h33_3
+ FE_OFN68_h33_2 FE_OFN85_s32_1 FE_OFN87_s31_1 FE_OFN88_s33_1 clk_clone1 clk
+ clk_clone2
XFE_PHC1316_next_acc_0 DELB $PINS O=FE_PHN1316_next_acc_0 I=next_acc[0]
XFE_PHC1275_N244 DELC $PINS O=N244 I=FE_PHN1275_N244
XFE_PHC1257_N238 DELB $PINS O=N238 I=FE_PHN1257_N238
XFE_PHC1233_N248 DELB $PINS O=N248 I=FE_PHN1233_N248
XFE_PHC1169_acc_reg_10 DELB $PINS O=FE_PHN1169_acc_reg_10 I=acc_reg[10]
XFE_PHC1167_acc_reg_11 DELB $PINS O=acc_reg[11] I=FE_PHN1167_acc_reg_11
XFE_PHC1146_acc_reg_16 DELB $PINS O=FE_PHN1146_acc_reg_16 I=acc_reg[16]
XFE_PHC1132_acc_reg_21 DELB $PINS O=FE_PHN1132_acc_reg_21 I=acc_reg[21]
XFE_PHC1100_acc_reg_22 DELC $PINS O=acc_reg[22] I=FE_PHN1100_acc_reg_22
XFE_PHC1025_acc_reg_12 DELB $PINS O=FE_PHN1025_acc_reg_12 I=acc_reg[12]
XFE_PHC1015_acc_reg_14 DELB $PINS O=FE_PHN1015_acc_reg_14 I=acc_reg[14]
XFE_PHC1014_acc_reg_15 DELB $PINS O=FE_PHN1014_acc_reg_15 I=acc_reg[15]
XFE_PHC1012_N251 DELC $PINS O=FE_PHN1012_N251 I=N251
XFE_PHC1010_acc_reg_19 DELB $PINS O=FE_PHN1010_acc_reg_19 I=acc_reg[19]
XFE_PHC1006_acc_reg_18 DELB $PINS O=FE_PHN1006_acc_reg_18 I=acc_reg[18]
XFE_PHC1005_acc_reg_20 DELB $PINS O=FE_PHN1005_acc_reg_20 I=acc_reg[20]
XFE_PHC1002_acc_reg_25 DELB $PINS O=FE_PHN1002_acc_reg_25 I=acc_reg[25]
XFE_PHC994_acc_reg_17 DELB $PINS O=FE_PHN994_acc_reg_17 I=acc_reg[17]
XFE_PHC874_acc_reg_24 DELB $PINS O=FE_PHN874_acc_reg_24 I=acc_reg[24]
XFE_PHC808_pe_r3_13 DELC $PINS O=y_out[13] I=FE_PHN808_pe_r3_13
XFE_PHC787_pe_r3_12 DELC $PINS O=y_out[12] I=FE_PHN787_pe_r3_12
XFE_PHC767_pe_r3_1 DELC $PINS O=y_out[1] I=FE_PHN767_pe_r3_1
XFE_PHC765_pe_r3_10 DELC $PINS O=y_out[10] I=FE_PHN765_pe_r3_10
XFE_PHC753_pe_r3_9 DELC $PINS O=y_out[9] I=FE_PHN753_pe_r3_9
XFE_RC_801_0 INV2 $PINS O=N43 I=FE_RN_381_0
XFE_RC_800_0 AN2 $PINS O=FE_RN_382_0 I1=term1_shifted[2] I2=FE_RN_2
XFE_RC_799_0 AOI12H $PINS O=FE_RN_381_0 A1=FE_RN_382_0 B1=N16 B2=sign1[0]
XFE_RC_779_0 INV2CK $PINS O=sll_18/ML_int[2][5] I=FE_RN_370_0
XFE_RC_778_0 MXL2HS $PINS OB=FE_RN_370_0 S=shf3[1] A=sll_18/ML_int[1][5]
+ B=sll_18/ML_int[1][3]
XFE_RC_754_0 INV1S $PINS O=FE_RN_359_0 I=n77
XFE_RC_753_0 AN2B1 $PINS O=term1_shifted[6] I1=sll_16/ML_int[3][6]
+ B1=FE_RN_359_0
XFE_RC_737_0 AN2T $PINS O=term3_shifted[5] I1=sll_18/ML_int[3][5] I2=n25
XFE_RC_733_0 INV1S $PINS O=FE_RN_351_0 I=n25
XFE_RC_732_0 AN2B1T $PINS O=term3_shifted[6] I1=sll_18/ML_int[3][6]
+ B1=FE_RN_351_0
XFE_RC_726_0 INV2 $PINS O=N99 I=FE_RN_348_0
XFE_RC_725_0 AOI22H $PINS O=FE_RN_348_0 A1=N72 A2=sign2[0] B1=term2_shifted[3]
+ B2=n59
XFE_RC_694_0 INV2 $PINS O=sll_16/ML_int[1][6] I=FE_RN_334_0
XFE_RC_693_0 MXL2HS $PINS OB=FE_RN_334_0 S=shf1[0] A=term1_in[6] B=term1_in[5]
XFE_RC_571_0 INV2CK $PINS O=N46 I=FE_RN_285_0
XFE_RC_570_0 AOI22H $PINS O=FE_RN_285_0 A1=N19 A2=sign1[0] B1=term1_shifted[5]
+ B2=FE_RN_2
XFE_RC_524_0 INV3 $PINS O=sll_16/ML_int[2][2] I=FE_RN_265_0
XFE_RC_523_0 MXL2H $PINS OB=FE_RN_265_0 S=shf1[1] A=sll_16/ML_int[1][2]
+ B=sll_16/ML_int[1][0]
XFE_RC_297_0 ND2 $PINS O=FE_RN_160_0 I1=term3_shifted[4] I2=n32
XFE_RC_296_0 ND2 $PINS O=FE_RN_161_0 I1=N128 I2=sign3[0]
XFE_RC_295_0 ND2P $PINS O=N155 I1=FE_RN_161_0 I2=FE_RN_160_0
XFE_RC_268_0 ND2 $PINS O=FE_RN_144_0 I1=term1_shifted[7] I2=FE_RN_2
XFE_RC_267_0 ND2 $PINS O=FE_RN_145_0 I1=N21 I2=sign1[0]
XFE_RC_266_0 ND2 $PINS O=N48 I1=FE_RN_145_0 I2=FE_RN_144_0
XFE_RC_265_0 ND2 $PINS O=FE_RN_142_0 I1=term3_shifted[15] I2=n32
XFE_RC_264_0 ND2 $PINS O=FE_RN_143_0 I1=N139 I2=FE_OFN128_s33_0
XFE_RC_263_0 ND2P $PINS O=N166 I1=FE_RN_143_0 I2=FE_RN_142_0
XFE_RC_235_0 ND2 $PINS O=FE_RN_128_0 I1=term1_shifted[1] I2=FE_RN_2
XFE_RC_234_0 ND2P $PINS O=FE_RN_129_0 I1=N15 I2=sign1[0]
XFE_RC_233_0 ND2P $PINS O=N42 I1=FE_RN_129_0 I2=FE_RN_128_0
XFE_RC_222_0 OA12 $PINS O=N96 A1=N69 B1=sign2[0] B2=n59
XFE_RC_205_0 ND3 $PINS O=n97 I1=term1_in[0] I2=FE_DBTN180_h31_1 I3=n65
XFE_RC_153_0 ND2S $PINS O=FE_RN_88_0 I1=sll_17/ML_int[1][0] I2=shf2[1]
XFE_RC_152_0 INV1S $PINS O=FE_RN_89_0 I=shf2[1]
XFE_RC_151_0 ND2 $PINS O=FE_RN_90_0 I1=sll_17/ML_int[1][2] I2=FE_RN_89_0
XFE_RC_150_0 ND2 $PINS O=sll_17/ML_int[2][2] I1=FE_RN_90_0 I2=FE_RN_88_0
XFE_RC_144_0 ND2 $PINS O=FE_RN_84_0 I1=term1_shifted[6] I2=FE_RN_2
XFE_RC_143_0 ND2S $PINS O=FE_RN_85_0 I1=N20 I2=sign1[0]
XFE_RC_142_0 ND2 $PINS O=N47 I1=FE_RN_85_0 I2=FE_RN_84_0
XFE_RC_141_0 ND2 $PINS O=FE_RN_82_0 I1=term3_shifted[3] I2=n32
XFE_RC_140_0 ND2S $PINS O=FE_RN_83_0 I1=N127 I2=sign3[0]
XFE_RC_139_0 ND2 $PINS O=N154 I1=FE_RN_83_0 I2=FE_RN_82_0
XFE_RC_135_0 ND2 $PINS O=FE_RN_78_0 I1=term2_shifted[4] I2=n59
XFE_RC_134_0 ND2 $PINS O=FE_RN_79_0 I1=N73 I2=sign2[0]
XFE_RC_133_0 ND2 $PINS O=N100 I1=FE_RN_79_0 I2=FE_RN_78_0
XFE_RC_94_0 ND2 $PINS O=FE_RN_54_0 I1=term1_shifted[10] I2=FE_RN_2
XFE_RC_93_0 ND2 $PINS O=FE_RN_55_0 I1=N24 I2=sign1[0]
XFE_RC_92_0 ND2P $PINS O=N51 I1=FE_RN_55_0 I2=FE_RN_54_0
XFE_RC_52_0 ND2 $PINS O=FE_RN_30_0 I1=term3_shifted[10] I2=n32
XFE_RC_51_0 ND2 $PINS O=FE_RN_31_0 I1=N134 I2=sign3[0]
XFE_RC_50_0 ND2 $PINS O=N161 I1=FE_RN_31_0 I2=FE_RN_30_0
XFE_OCPC724_n119 BUF1S $PINS O=FE_OCPN724_n119 I=n119
XFE_OFC713_FE_OFN30_pe_clear_d1 INV1S $PINS O=n148 I=clear
XFE_RC_15_0 OA12 $PINS O=N151 A1=N124 B1=sign3[0] B2=n32
XFE_RC_8_0 OA12 $PINS O=N41 A1=term1_shifted[0] B1=sign1[0] B2=FE_RN_2
XFE_OFC682_mac_in_real_0 INV2 $PINS O=FE_OFN352_mac_in_real_0 I=x_in[0]
XFE_OFC661_mac_in_real_1 INV4 $PINS O=n146 I=x_in[1]
XFE_OFC552_s31_0 INV2 $PINS O=FE_RN_2 I=sign1[0]
XFE_OFC540_s32_0 INV1S $PINS O=FE_OFN301_s32_0 I=FE_RN_5
XFE_OFC539_s32_0 BUF1 $PINS O=FE_OFN300_s32_0 I=sign2[0]
XFE_OFC536_s32_0 BUF1 $PINS O=FE_RN_5 I=sign2[0]
XFE_OFC535_s32_0 INV1S $PINS O=n59 I=sign2[0]
XFE_OFC527_mac_in_real_2 INV2 $PINS O=n145 I=x_in[2]
XFE_OFC482_h31_2 BUF1 $PINS O=FE_OFN273_h31_2 I=shf1[2]
XFE_OFC404_h32_0 INV1S $PINS O=n39 I=shf2[0]
XFE_OFC360_h32_1 INV2 $PINS O=n42 I=shf2[1]
XFE_OFC351_h31_1 INV1S $PINS O=FE_DBTN180_h31_1 I=shf1[1]
XFE_OFC223_h32_3 INV1S $PINS O=FE_RN_4 I=FE_OFN65_h32_3
XFE_OFC205_h33_3 INV1S $PINS O=n25 I=shf3[3]
XFE_OFC204_h33_3 BUF1 $PINS O=FE_RN_3 I=shf3[3]
XFE_OFC164_h31_2 INV1S $PINS O=n74 I=shf1[2]
XFE_OFC161_s33_0 BUF1CK $PINS O=FE_OFN128_s33_0 I=sign3[0]
XFE_OFC160_s33_0 INV2 $PINS O=n32 I=sign3[0]
XFE_OFC156_h32_2 INV1S $PINS O=n46 I=shf2[2]
XFE_OFC137_h31_3 INV1S $PINS O=n77 I=shf1[3]
XFE_OFC126_h33_2 INV1S $PINS O=FE_RN_1 I=FE_OFN68_h33_2
XU110 AO22 $PINS O=base_val[13] A1=acc_reg[13] A2=n148 B1=clear B2=n30
XU112 AO22P $PINS O=N98 A1=N71 A2=sign2[0] B1=term2_shifted[2] B2=n59
XU115 AO22 $PINS O=N67 A1=sign1[0] A2=N40 B1=term1_shifted[26] B2=FE_RN_2
XU132 AO22P $PINS O=N50 A1=N23 A2=sign1[0] B1=term1_shifted[9] B2=FE_RN_2
XU138 AO22P $PINS O=N44 A1=N17 A2=sign1[0] B1=term1_shifted[3] B2=FE_RN_2
XU142 AO22 $PINS O=N177 A1=FE_OFN128_s33_0 A2=N150 B1=term3_shifted[26] B2=n32
XU143 AO22 $PINS O=N176 A1=N149 A2=FE_OFN128_s33_0 B1=term3_shifted[25] B2=n32
XU144 AO22 $PINS O=N175 A1=N148 A2=FE_OFN128_s33_0 B1=term3_shifted[24] B2=n32
XU145 AO22 $PINS O=N174 A1=N147 A2=FE_OFN128_s33_0 B1=term3_shifted[23] B2=n32
XU146 AO22 $PINS O=N173 A1=N146 A2=FE_OFN128_s33_0 B1=term3_shifted[22] B2=n32
XU147 AO22 $PINS O=N172 A1=N145 A2=FE_OFN128_s33_0 B1=term3_shifted[21] B2=n32
XU148 AO22 $PINS O=N171 A1=N144 A2=FE_OFN128_s33_0 B1=term3_shifted[20] B2=n32
XU149 AO22 $PINS O=N170 A1=N143 A2=FE_OFN128_s33_0 B1=term3_shifted[19] B2=n32
XU150 AO22 $PINS O=N169 A1=N142 A2=FE_OFN128_s33_0 B1=term3_shifted[18] B2=n32
XU152 AO22 $PINS O=N167 A1=N140 A2=FE_OFN128_s33_0 B1=term3_shifted[16] B2=n32
XU154 AO22P $PINS O=N165 A1=N138 A2=sign3[0] B1=term3_shifted[14] B2=n32
XU155 AO22 $PINS O=N164 A1=N137 A2=sign3[0] B1=term3_shifted[13] B2=n32
XU156 AO22 $PINS O=N163 A1=N136 A2=sign3[0] B1=term3_shifted[12] B2=n32
XU157 AO22 $PINS O=N162 A1=N135 A2=sign3[0] B1=term3_shifted[11] B2=n32
XU160 AO22 $PINS O=N159 A1=N132 A2=sign3[0] B1=term3_shifted[8] B2=n32
XU161 AO22 $PINS O=N158 A1=N131 A2=sign3[0] B1=term3_shifted[7] B2=n32
XU162 AO22P $PINS O=N157 A1=N130 A2=sign3[0] B1=term3_shifted[6] B2=n32
XU163 AO22P $PINS O=N156 A1=N129 A2=sign3[0] B1=term3_shifted[5] B2=n32
XU169 AO22 $PINS O=N122 A1=N95 A2=FE_RN_5 B1=term2_shifted[26]
+ B2=FE_OFN301_s32_0
XU170 AO22 $PINS O=N121 A1=N94 A2=FE_RN_5 B1=term2_shifted[25]
+ B2=FE_OFN301_s32_0
XU171 AO22 $PINS O=N120 A1=N93 A2=FE_RN_5 B1=term2_shifted[24]
+ B2=FE_OFN301_s32_0
XU172 AO22 $PINS O=N119 A1=N92 A2=FE_RN_5 B1=term2_shifted[23]
+ B2=FE_OFN301_s32_0
XU173 AO22 $PINS O=N118 A1=N91 A2=FE_RN_5 B1=term2_shifted[22]
+ B2=FE_OFN301_s32_0
XU174 AO22 $PINS O=N117 A1=N90 A2=FE_RN_5 B1=term2_shifted[21]
+ B2=FE_OFN301_s32_0
XU175 AO22 $PINS O=N116 A1=N89 A2=FE_RN_5 B1=term2_shifted[20]
+ B2=FE_OFN301_s32_0
XU176 AO22 $PINS O=N115 A1=N88 A2=FE_RN_5 B1=term2_shifted[19]
+ B2=FE_OFN301_s32_0
XU177 AO22 $PINS O=N114 A1=N87 A2=FE_RN_5 B1=term2_shifted[18]
+ B2=FE_OFN301_s32_0
XU178 AO22 $PINS O=N113 A1=N86 A2=FE_RN_5 B1=term2_shifted[17]
+ B2=FE_OFN301_s32_0
XU179 AO22 $PINS O=N112 A1=N85 A2=FE_RN_5 B1=term2_shifted[16]
+ B2=FE_OFN301_s32_0
XU180 AO22 $PINS O=N111 A1=N84 A2=FE_RN_5 B1=term2_shifted[15]
+ B2=FE_OFN301_s32_0
XU181 AO22 $PINS O=N110 A1=N83 A2=FE_RN_5 B1=term2_shifted[14]
+ B2=FE_OFN301_s32_0
XU183 AO22 $PINS O=N108 A1=N81 A2=FE_OFN300_s32_0 B1=term2_shifted[12] B2=n59
XU184 AO22 $PINS O=N107 A1=N80 A2=FE_OFN300_s32_0 B1=term2_shifted[11] B2=n59
XU185 AO22 $PINS O=N106 A1=N79 A2=FE_OFN300_s32_0 B1=term2_shifted[10] B2=n59
XU186 AO22 $PINS O=N105 A1=N78 A2=FE_OFN300_s32_0 B1=term2_shifted[9] B2=n59
XU188 AO22 $PINS O=N103 A1=N76 A2=FE_OFN300_s32_0 B1=term2_shifted[7] B2=n59
XU190 AO22 $PINS O=N101 A1=N74 A2=FE_OFN300_s32_0 B1=term2_shifted[5] B2=n59
Xsll_18/M1_0_1 MUX2 $PINS O=sll_18/ML_int[1][1] S=shf3[0] A=term3_in[1]
+ B=term3_in[0]
Xsll_18/M1_0_3 MUX2 $PINS O=sll_18/ML_int[1][3] S=shf3[0] A=term3_in[3]
+ B=term3_in[2]
Xsll_18/M1_0_4 MUX2 $PINS O=sll_18/ML_int[1][4] S=shf3[0] A=term3_in[4]
+ B=term3_in[3]
Xsll_18/M1_0_5 MUX2 $PINS O=sll_18/ML_int[1][5] S=shf3[0] A=term3_in[5]
+ B=term3_in[4]
Xsll_18/M1_0_6 MUX2 $PINS O=sll_18/ML_int[1][6] S=shf3[0] A=term3_in[6]
+ B=term3_in[5]
Xsll_18/M1_0_7 MUX2 $PINS O=sll_18/ML_int[1][7] S=shf3[0] A=term3_in[7]
+ B=term3_in[6]
Xsll_18/M1_1_2 MUX2 $PINS O=sll_18/ML_int[2][2] S=shf3[1] A=sll_18/ML_int[1][2]
+ B=sll_18/ML_int[1][0]
Xsll_18/M1_2_4 MUX2 $PINS O=sll_18/ML_int[3][4] S=FE_OFN68_h33_2
+ A=sll_18/ML_int[2][4] B=n124
Xsll_18/M1_2_5 MUX2 $PINS O=sll_18/ML_int[3][5] S=FE_OFN68_h33_2
+ A=sll_18/ML_int[2][5] B=n125
Xsll_18/M1_2_6 MUX2 $PINS O=sll_18/ML_int[3][6] S=FE_OFN68_h33_2
+ A=sll_18/ML_int[2][6] B=sll_18/ML_int[2][2]
Xsll_18/M1_2_7 MUX2 $PINS O=sll_18/ML_int[3][7] S=FE_OFN68_h33_2
+ A=sll_18/ML_int[2][7] B=sll_18/ML_int[2][3]
Xsll_18/M1_2_8 MUX2 $PINS O=sll_18/ML_int[3][8] S=FE_OFN68_h33_2
+ A=sll_18/ML_int[2][8] B=sll_18/ML_int[2][4]
Xsll_18/M1_2_9 MUX2 $PINS O=sll_18/ML_int[3][9] S=FE_OFN68_h33_2
+ A=sll_18/ML_int[2][9] B=sll_18/ML_int[2][5]
Xsll_18/M1_2_19 MUX2 $PINS O=sll_18/ML_int[3][19] S=FE_OFN68_h33_2 A=n6
+ B=sll_18/ML_int[2][15]
Xsll_18/M1_3_8 MUX2 $PINS O=term3_shifted[8] S=FE_RN_3 A=sll_18/ML_int[3][8]
+ B=sll_18/ML_int[3][0]
Xsll_18/M1_3_9 MUX2 $PINS O=term3_shifted[9] S=FE_RN_3 A=sll_18/ML_int[3][9]
+ B=sll_18/ML_int[3][1]
Xsll_18/M1_3_10 MUX2 $PINS O=term3_shifted[10] S=FE_RN_3 A=sll_18/ML_int[3][10]
+ B=sll_18/ML_int[3][2]
Xsll_18/M1_3_11 MUX2 $PINS O=term3_shifted[11] S=shf3[3] A=sll_18/ML_int[3][11]
+ B=sll_18/ML_int[3][3]
Xsll_18/M1_3_12 MUX2 $PINS O=term3_shifted[12] S=FE_RN_3 A=sll_18/ML_int[3][12]
+ B=sll_18/ML_int[3][4]
Xsll_18/M1_3_13 MUX2 $PINS O=term3_shifted[13] S=FE_RN_3 A=sll_18/ML_int[3][13]
+ B=sll_18/ML_int[3][5]
Xsll_18/M1_3_23 MUX2 $PINS O=term3_shifted[23] S=shf3[3] A=n6
+ B=sll_18/ML_int[3][15]
Xsll_17/M1_0_4 MUX2 $PINS O=sll_17/ML_int[1][4] S=shf2[0] A=term2_in[4]
+ B=term2_in[3]
Xsll_17/M1_0_6 MUX2 $PINS O=sll_17/ML_int[1][6] S=shf2[0] A=term2_in[6]
+ B=term2_in[5]
Xsll_17/M1_0_7 MUX2 $PINS O=sll_17/ML_int[1][7] S=shf2[0] A=term2_in[7]
+ B=term2_in[6]
Xsll_17/M1_1_3 MUX2 $PINS O=sll_17/ML_int[2][3] S=shf2[1] A=sll_17/ML_int[1][3]
+ B=sll_17/ML_int[1][1]
Xsll_17/M1_1_5 MUX2 $PINS O=sll_17/ML_int[2][5] S=shf2[1] A=sll_17/ML_int[1][5]
+ B=sll_17/ML_int[1][3]
Xsll_17/M1_1_7 MUX2 $PINS O=sll_17/ML_int[2][7] S=shf2[1] A=sll_17/ML_int[1][7]
+ B=sll_17/ML_int[1][5]
Xsll_17/M1_2_4 MUX2 $PINS O=sll_17/ML_int[3][4] S=shf2[2] A=sll_17/ML_int[2][4]
+ B=n113
Xsll_17/M1_2_5 MUX2 $PINS O=sll_17/ML_int[3][5] S=shf2[2] A=sll_17/ML_int[2][5]
+ B=n114
Xsll_17/M1_2_6 MUX2 $PINS O=sll_17/ML_int[3][6] S=shf2[2] A=sll_17/ML_int[2][6]
+ B=sll_17/ML_int[2][2]
Xsll_17/M1_2_8 MUX2 $PINS O=sll_17/ML_int[3][8] S=shf2[2] A=sll_17/ML_int[2][8]
+ B=sll_17/ML_int[2][4]
Xsll_17/M1_2_9 MUX2 $PINS O=sll_17/ML_int[3][9] S=shf2[2] A=sll_17/ML_int[2][9]
+ B=sll_17/ML_int[2][5]
Xsll_17/M1_2_19 MUX2 $PINS O=sll_17/ML_int[3][19] S=shf2[2] A=term2_in[26]
+ B=sll_17/ML_int[2][15]
Xsll_17/M1_3_8 MUX2 $PINS O=term2_shifted[8] S=FE_OFN65_h32_3
+ A=sll_17/ML_int[3][8] B=sll_17/ML_int[3][0]
Xsll_17/M1_3_9 MUX2 $PINS O=term2_shifted[9] S=FE_OFN65_h32_3
+ A=sll_17/ML_int[3][9] B=sll_17/ML_int[3][1]
Xsll_17/M1_3_10 MUX2 $PINS O=term2_shifted[10] S=FE_OFN65_h32_3
+ A=sll_17/ML_int[3][10] B=sll_17/ML_int[3][2]
Xsll_17/M1_3_11 MUX2 $PINS O=term2_shifted[11] S=FE_OFN65_h32_3
+ A=sll_17/ML_int[3][11] B=sll_17/ML_int[3][3]
Xsll_17/M1_3_12 MUX2 $PINS O=term2_shifted[12] S=FE_OFN65_h32_3
+ A=sll_17/ML_int[3][12] B=sll_17/ML_int[3][4]
Xsll_17/M1_3_13 MUX2 $PINS O=term2_shifted[13] S=FE_OFN65_h32_3
+ A=sll_17/ML_int[3][13] B=sll_17/ML_int[3][5]
Xsll_17/M1_3_23 MUX2 $PINS O=term2_shifted[23] S=FE_OFN65_h32_3 A=term2_in[26]
+ B=sll_17/ML_int[3][15]
Xsll_16/M1_0_1 MUX2 $PINS O=sll_16/ML_int[1][1] S=shf1[0] A=term1_in[1]
+ B=term1_in[0]
Xsll_16/M1_0_3 MUX2 $PINS O=sll_16/ML_int[1][3] S=shf1[0] A=term1_in[3]
+ B=term1_in[2]
Xsll_16/M1_0_4 MUX2 $PINS O=sll_16/ML_int[1][4] S=shf1[0] A=term1_in[4]
+ B=term1_in[3]
Xsll_16/M1_0_7 MUX2 $PINS O=sll_16/ML_int[1][7] S=shf1[0] A=term1_in[7]
+ B=term1_in[6]
Xsll_16/M1_1_5 MUX2 $PINS O=sll_16/ML_int[2][5] S=shf1[1] A=sll_16/ML_int[1][5]
+ B=sll_16/ML_int[1][3]
Xsll_16/M1_1_8 MUX2 $PINS O=sll_16/ML_int[2][8] S=shf1[1] A=sll_16/ML_int[1][8]
+ B=sll_16/ML_int[1][6]
Xsll_16/M1_1_9 MUX2 $PINS O=sll_16/ML_int[2][9] S=shf1[1] A=sll_16/ML_int[1][9]
+ B=sll_16/ML_int[1][7]
Xsll_16/M1_2_4 MUX2 $PINS O=sll_16/ML_int[3][4] S=FE_OFN273_h31_2
+ A=sll_16/ML_int[2][4] B=n102
Xsll_16/M1_2_5 MUX2 $PINS O=sll_16/ML_int[3][5] S=FE_OFN273_h31_2
+ A=sll_16/ML_int[2][5] B=n103
Xsll_16/M1_2_7 MUX2 $PINS O=sll_16/ML_int[3][7] S=FE_OFN273_h31_2
+ A=sll_16/ML_int[2][7] B=sll_16/ML_int[2][3]
Xsll_16/M1_2_8 MUX2 $PINS O=sll_16/ML_int[3][8] S=FE_OFN273_h31_2
+ A=sll_16/ML_int[2][8] B=sll_16/ML_int[2][4]
Xsll_16/M1_2_9 MUX2 $PINS O=sll_16/ML_int[3][9] S=FE_OFN273_h31_2
+ A=sll_16/ML_int[2][9] B=sll_16/ML_int[2][5]
Xsll_16/M1_2_10 MUX2 $PINS O=sll_16/ML_int[3][10] S=FE_OFN273_h31_2
+ A=sll_16/ML_int[2][10] B=sll_16/ML_int[2][6]
Xsll_16/M1_2_11 MUX2 $PINS O=sll_16/ML_int[3][11] S=FE_OFN273_h31_2
+ A=sll_16/ML_int[2][11] B=sll_16/ML_int[2][7]
Xsll_16/M1_2_19 MUX2 $PINS O=sll_16/ML_int[3][19] S=FE_OFN273_h31_2 A=n5
+ B=sll_16/ML_int[2][15]
Xsll_16/M1_3_8 MUX2 $PINS O=term1_shifted[8] S=shf1[3] A=sll_16/ML_int[3][8]
+ B=sll_16/ML_int[3][0]
Xsll_16/M1_3_9 MUX2 $PINS O=term1_shifted[9] S=shf1[3] A=sll_16/ML_int[3][9]
+ B=sll_16/ML_int[3][1]
Xsll_16/M1_3_10 MUX2 $PINS O=term1_shifted[10] S=shf1[3] A=sll_16/ML_int[3][10]
+ B=sll_16/ML_int[3][2]
Xsll_16/M1_3_11 MUX2 $PINS O=term1_shifted[11] S=shf1[3] A=sll_16/ML_int[3][11]
+ B=sll_16/ML_int[3][3]
Xsll_16/M1_3_12 MUX2 $PINS O=term1_shifted[12] S=shf1[3] A=sll_16/ML_int[3][12]
+ B=sll_16/ML_int[3][4]
Xsll_16/M1_3_13 MUX2 $PINS O=term1_shifted[13] S=shf1[3] A=sll_16/ML_int[3][13]
+ B=sll_16/ML_int[3][5]
Xsll_16/M1_3_14 MUX2 $PINS O=term1_shifted[14] S=shf1[3] A=sll_16/ML_int[3][14]
+ B=sll_16/ML_int[3][6]
Xsll_16/M1_3_15 MUX2 $PINS O=term1_shifted[15] S=shf1[3] A=sll_16/ML_int[3][15]
+ B=sll_16/ML_int[3][7]
Xsll_16/M1_3_23 MUX2 $PINS O=term1_shifted[23] S=shf1[3] A=n5
+ B=sll_16/ML_int[3][15]
Xacc_reg_reg[25] QDFFRBN $PINS Q=acc_reg[25] D=next_acc[25] CK=clk_clone1
+ RB=i_rst_n
Xacc_reg_reg[24] QDFFRBN $PINS Q=acc_reg[24] D=next_acc[24] CK=clk
+ RB=FE_OFN26_i_rst_n
Xacc_reg_reg[23] QDFFRBN $PINS Q=acc_reg[23] D=next_acc[23] CK=clk_clone1
+ RB=i_rst_n
Xacc_reg_reg[22] QDFFRBN $PINS Q=FE_PHN1100_acc_reg_22 D=next_acc[22] CK=clk
+ RB=i_rst_n
Xacc_reg_reg[21] QDFFRBN $PINS Q=acc_reg[21] D=next_acc[21] CK=clk RB=i_rst_n
Xacc_reg_reg[20] QDFFRBN $PINS Q=acc_reg[20] D=next_acc[20] CK=clk
+ RB=FE_OFN31_i_rst_n
Xacc_reg_reg[19] QDFFRBN $PINS Q=acc_reg[19] D=next_acc[19] CK=clk
+ RB=FE_OFN31_i_rst_n
Xacc_reg_reg[18] QDFFRBN $PINS Q=acc_reg[18] D=next_acc[18] CK=clk
+ RB=FE_OFN31_i_rst_n
Xacc_reg_reg[17] QDFFRBN $PINS Q=acc_reg[17] D=next_acc[17] CK=clk
+ RB=FE_OFN31_i_rst_n
Xacc_reg_reg[16] QDFFRBN $PINS Q=acc_reg[16] D=next_acc[16] CK=clk
+ RB=FE_OFN31_i_rst_n
Xacc_reg_reg[15] QDFFRBN $PINS Q=acc_reg[15] D=next_acc[15] CK=clk
+ RB=FE_OFN31_i_rst_n
Xacc_reg_reg[14] QDFFRBN $PINS Q=acc_reg[14] D=next_acc[14] CK=clk
+ RB=FE_OFN31_i_rst_n
Xacc_reg_reg[13] QDFFRBN $PINS Q=acc_reg[13] D=next_acc[13] CK=clk
+ RB=FE_OFN31_i_rst_n
Xacc_reg_reg[12] QDFFRBN $PINS Q=acc_reg[12] D=next_acc[12] CK=clk
+ RB=FE_OFN31_i_rst_n
Xacc_reg_reg[11] QDFFRBN $PINS Q=FE_PHN1167_acc_reg_11 D=next_acc[11] CK=clk
+ RB=FE_OFN31_i_rst_n
Xacc_reg_reg[10] QDFFRBN $PINS Q=acc_reg[10] D=next_acc[10] CK=clk
+ RB=FE_OFN31_i_rst_n
Xacc_reg_reg[9] QDFFRBN $PINS Q=acc_reg[9] D=next_acc[9] CK=clk
+ RB=FE_OFN31_i_rst_n
Xacc_reg_reg[8] QDFFRBN $PINS Q=acc_reg[8] D=next_acc[8] CK=clk
+ RB=FE_OFN31_i_rst_n
Xacc_reg_reg[7] QDFFRBN $PINS Q=acc_reg[7] D=next_acc[7] CK=clk
+ RB=FE_OFN31_i_rst_n
Xacc_reg_reg[6] QDFFRBN $PINS Q=acc_reg[6] D=next_acc[6] CK=clk
+ RB=FE_OFN31_i_rst_n
Xacc_reg_reg[5] QDFFRBN $PINS Q=acc_reg[5] D=next_acc[5] CK=clk
+ RB=FE_OFN31_i_rst_n
Xacc_reg_reg[4] QDFFRBN $PINS Q=acc_reg[4] D=next_acc[4] CK=clk
+ RB=FE_OFN31_i_rst_n
Xacc_reg_reg[3] QDFFRBN $PINS Q=acc_reg[3] D=next_acc[3] CK=clk
+ RB=FE_OFN31_i_rst_n
Xacc_reg_reg[2] QDFFRBN $PINS Q=acc_reg[2] D=next_acc[2] CK=clk
+ RB=FE_OFN31_i_rst_n
Xacc_reg_reg[0] QDFFRBN $PINS Q=acc_reg[0] D=FE_PHN1316_next_acc_0 CK=clk
+ RB=FE_OFN31_i_rst_n
Xacc_reg_reg[1] QDFFRBN $PINS Q=acc_reg[1] D=next_acc[1] CK=clk
+ RB=FE_OFN31_i_rst_n
Xy_out_reg[16] QDFFRBN $PINS Q=y_out[16] D=FE_PHN1012_N251 CK=net2198
+ RB=FE_OFN26_i_rst_n
Xy_out_reg[15] QDFFRBN $PINS Q=y_out[15] D=N250 CK=net2198 RB=FE_OFN26_i_rst_n
Xy_out_reg[14] QDFFRBN $PINS Q=y_out[14] D=N249 CK=net2198 RB=FE_OFN26_i_rst_n
Xy_out_reg[13] QDFFRBN $PINS Q=FE_PHN808_pe_r3_13 D=N248 CK=net2198
+ RB=FE_OFN26_i_rst_n
Xy_out_reg[12] QDFFRBN $PINS Q=FE_PHN787_pe_r3_12 D=N247 CK=net2198
+ RB=FE_OFN26_i_rst_n
Xy_out_reg[11] QDFFRBN $PINS Q=y_out[11] D=N246 CK=net2198 RB=FE_OFN26_i_rst_n
Xy_out_reg[10] QDFFRBN $PINS Q=FE_PHN765_pe_r3_10 D=N245 CK=net2198
+ RB=FE_OFN26_i_rst_n
Xy_out_reg[9] QDFFRBN $PINS Q=FE_PHN753_pe_r3_9 D=N244 CK=net2198
+ RB=FE_OFN26_i_rst_n
Xy_out_reg[8] QDFFRBN $PINS Q=y_out[8] D=N243 CK=net2198 RB=FE_OFN26_i_rst_n
Xy_out_reg[7] QDFFRBN $PINS Q=y_out[7] D=N242 CK=net2198 RB=FE_OFN26_i_rst_n
Xy_out_reg[6] QDFFRBN $PINS Q=y_out[6] D=N241 CK=net2198 RB=FE_OFN26_i_rst_n
Xy_out_reg[5] QDFFRBN $PINS Q=y_out[5] D=N240 CK=net2198 RB=i_rst_n
Xy_out_reg[4] QDFFRBN $PINS Q=y_out[4] D=N239 CK=net2198 RB=FE_OFN26_i_rst_n
Xy_out_reg[3] QDFFRBN $PINS Q=y_out[3] D=N238 CK=net2198 RB=FE_OFN26_i_rst_n
Xy_out_reg[2] QDFFRBN $PINS Q=y_out[2] D=N237 CK=net2198 RB=i_rst_n
Xy_out_reg[1] QDFFRBN $PINS Q=FE_PHN767_pe_r3_1 D=N236 CK=net2198 RB=i_rst_n
Xy_out_reg[0] QDFFRBN $PINS Q=y_out[0] D=N235 CK=net2198 RB=FE_OFN26_i_rst_n
Xacc_reg_reg[26] QDFFRBS $PINS Q=N251 D=next_acc[26] CK=clk RB=FE_OFN26_i_rst_n
XU4 ND2P $PINS O=n119 I1=sll_18/ML_int[1][0] I2=n16
XU5 NR2P $PINS O=term1_in[1] I1=FE_OFN87_s31_1 I2=n146
XU10 NR2T $PINS O=term3_in[1] I1=FE_OFN88_s33_1 I2=n146
XU13 NR2P $PINS O=term2_in[1] I1=sign2[1] I2=n146
XU15 MUX2 $PINS O=sll_18/ML_int[1][2] S=shf3[0] A=term3_in[2] B=term3_in[1]
XU22 AO22P $PINS O=N97 A1=N70 A2=sign2[0] B1=term2_shifted[1] B2=n59
XU23 NR2 $PINS O=term2_in[2] I1=sign2[1] I2=n145
XU24 MUX2 $PINS O=sll_17/ML_int[1][5] S=n39 A=term2_in[4] B=term2_in[5]
XU25 MUX2 $PINS O=sll_17/ML_int[1][1] S=n39 A=term2_in[0] B=term2_in[1]
XU26 NR2T $PINS O=term3_shifted[1] I1=n121 I2=n120
XU27 MUX2 $PINS O=FE_PHN1233_N248 S=n30 A=acc_reg[23] B=FE_PHN1012_N251
XU28 NR2 $PINS O=term1_in[4] I1=FE_OFN87_s31_1 I2=x_in[4]
XU29 NR2 $PINS O=term3_in[2] I1=FE_OFN88_s33_1 I2=n145
XU30 MUX2S $PINS O=sll_17/ML_int[3][7] S=n46 A=sll_17/ML_int[2][3]
+ B=sll_17/ML_int[2][7]
XU31 NR2P $PINS O=term2_shifted[0] I1=n110 I2=n108
XU32 MUX2 $PINS O=N249 S=n30 A=FE_PHN874_acc_reg_24 B=FE_PHN1012_N251
XU34 AN2B1 $PINS O=term3_shifted[3] I1=sll_18/ML_int[2][3] B1=n121
XU35 NR2 $PINS O=sll_16/ML_int[3][2] I1=FE_OFN273_h31_2 I2=n101
XU36 NR2 $PINS O=sll_17/ML_int[3][3] I1=shf2[2] I2=n111
XU37 INV1S $PINS O=n111 I=sll_17/ML_int[2][3]
XU38 MUX2 $PINS O=N250 S=n30 A=FE_PHN1002_acc_reg_25 B=FE_PHN1012_N251
XU44 INV2CK $PINS O=n123 I=sll_18/ML_int[2][2]
XU46 AO22P $PINS O=N152 A1=N125 A2=FE_OFN128_s33_0 B1=term3_shifted[1] B2=n32
XU47 MUX2 $PINS O=sll_18/ML_int[2][3] S=shf3[1] A=sll_18/ML_int[1][3]
+ B=sll_18/ML_int[1][1]
XU48 MUX2 $PINS O=sll_18/ML_int[2][4] S=shf3[1] A=sll_18/ML_int[1][4]
+ B=sll_18/ML_int[1][2]
XU49 MUX2 $PINS O=sll_18/ML_int[2][6] S=shf3[1] A=sll_18/ML_int[1][6]
+ B=sll_18/ML_int[1][4]
XU50 MUX2 $PINS O=sll_18/ML_int[2][7] S=shf3[1] A=sll_18/ML_int[1][7]
+ B=sll_18/ML_int[1][5]
XU53 MUX2 $PINS O=sll_16/ML_int[2][6] S=shf1[1] A=sll_16/ML_int[1][6]
+ B=sll_16/ML_int[1][4]
XU55 ND2P $PINS O=n120 I1=sll_18/ML_int[1][1] I2=n16
XU57 NR2 $PINS O=term2_in[4] I1=sign2[1] I2=x_in[4]
XU59 ND2P $PINS O=n121 I1=FE_RN_1 I2=n25
XU61 NR2T $PINS O=term3_shifted[2] I1=n121 I2=n123
XU63 INV2 $PINS O=n112 I=sll_17/ML_int[2][2]
XU64 MUX2 $PINS O=sll_16/ML_int[2][3] S=shf1[1] A=sll_16/ML_int[1][3]
+ B=sll_16/ML_int[1][1]
XU65 MUX2 $PINS O=sll_16/ML_int[2][4] S=shf1[1] A=sll_16/ML_int[1][4]
+ B=sll_16/ML_int[1][2]
XU66 MUX2 $PINS O=sll_16/ML_int[2][7] S=shf1[1] A=sll_16/ML_int[1][7]
+ B=sll_16/ML_int[1][5]
XU67 AO22 $PINS O=N160 A1=N133 A2=sign3[0] B1=term3_shifted[9] B2=n32
XU68 AO22 $PINS O=N53 A1=N26 A2=sign1[0] B1=term1_shifted[12] B2=FE_RN_2
XU70 AO22P $PINS O=N54 A1=N27 A2=sign1[0] B1=term1_shifted[13] B2=FE_RN_2
XU72 NR2 $PINS O=term2_in[3] I1=x_in[3] I2=sign2[1]
XU73 NR2 $PINS O=term3_in[3] I1=FE_OFN88_s33_1 I2=x_in[3]
XU74 NR2 $PINS O=term1_in[6] I1=FE_OFN87_s31_1 I2=x_in[6]
XU81 AN2S $PINS O=sll_17/ML_int[1][0] I1=term2_in[0] I2=n39
XU82 AN2 $PINS O=sll_18/ML_int[1][0] I1=term3_in[0] I2=n13
XU85 NR2P $PINS O=term2_shifted[2] I1=n110 I2=n112
XU86 MOAI1H $PINS O=N45 A1=n4 A2=FE_RN_2 B1=term1_shifted[4] B2=FE_RN_2
XU87 INV1S $PINS O=n4 I=N18
XU88 AN2 $PINS O=term1_shifted[7] I1=sll_16/ML_int[3][7] I2=n77
XU89 AO22 $PINS O=N57 A1=N30 A2=sign1[0] B1=term1_shifted[16] B2=FE_RN_2
XU92 AO22 $PINS O=N52 A1=N25 A2=sign1[0] B1=term1_shifted[11] B2=FE_RN_2
XU93 AO22 $PINS O=N109 A1=N82 A2=FE_OFN300_s32_0 B1=term2_shifted[13] B2=n59
XU94 AO22 $PINS O=N55 A1=N28 A2=sign1[0] B1=term1_shifted[14] B2=FE_RN_2
XU95 AO22 $PINS O=N56 A1=N29 A2=sign1[0] B1=term1_shifted[15] B2=FE_RN_2
XU96 AO22 $PINS O=N58 A1=N31 A2=sign1[0] B1=term1_shifted[17] B2=FE_RN_2
XU97 AO22 $PINS O=N168 A1=N141 A2=FE_OFN128_s33_0 B1=term3_shifted[17] B2=n32
XU98 AO22 $PINS O=N60 A1=N33 A2=sign1[0] B1=term1_shifted[19] B2=FE_RN_2
XU104 MUX2 $PINS O=sll_16/ML_int[1][8] S=shf1[0] A=term1_in[8] B=term1_in[7]
XU105 NR2P $PINS O=term2_in[0] I1=sign2[1] I2=FE_OFN352_mac_in_real_0
XU107 AO22 $PINS O=N61 A1=N34 A2=sign1[0] B1=term1_shifted[20] B2=FE_RN_2
XU108 AO22P $PINS O=N153 A1=N126 A2=FE_OFN128_s33_0 B1=term3_shifted[2] B2=n32
XU109 AO22 $PINS O=N63 A1=N36 A2=sign1[0] B1=term1_shifted[22] B2=FE_RN_2
XU114 AO22 $PINS O=N59 A1=N32 A2=sign1[0] B1=term1_shifted[18] B2=FE_RN_2
XU117 AO22 $PINS O=N64 A1=N37 A2=sign1[0] B1=term1_shifted[23] B2=FE_RN_2
XU118 AO22 $PINS O=N102 A1=N75 A2=FE_OFN300_s32_0 B1=term2_shifted[6] B2=n59
XU119 AO22 $PINS O=N104 A1=N77 A2=FE_OFN300_s32_0 B1=term2_shifted[8] B2=n59
XU122 NR2 $PINS O=n5 I1=n137 I2=FE_OFN87_s31_1
XU123 MUX2S $PINS O=n107 S=shf1[0] A=term1_in[26] B=term1_in[15]
XU124 NR2 $PINS O=n6 I1=n137 I2=FE_OFN88_s33_1
XU125 MUX2S $PINS O=n128 S=n16 A=n129 B=term3_in[26]
XU127 MUX2S $PINS O=n118 S=shf2[0] A=term2_in[26] B=term2_in[15]
XU129 AO22P $PINS O=N49 A1=N22 A2=sign1[0] B1=term1_shifted[8] B2=FE_RN_2
XU137 MUX2S $PINS O=sll_17/ML_int[2][8] S=shf2[1] A=sll_17/ML_int[1][8]
+ B=sll_17/ML_int[1][6]
XU140 MUX2S $PINS O=sll_17/ML_int[1][8] S=shf2[0] A=term2_in[8] B=term2_in[7]
XU151 MUX2 $PINS O=sll_18/ML_int[2][8] S=shf3[1] A=sll_18/ML_int[1][8]
+ B=sll_18/ML_int[1][6]
XU159 MUX2S $PINS O=sll_18/ML_int[1][8] S=shf3[0] A=term3_in[8] B=term3_in[7]
XU164 MUX2S $PINS O=sll_16/ML_int[1][9] S=shf1[0] A=term1_in[9] B=term1_in[8]
XU166 MUX2S $PINS O=sll_17/ML_int[2][9] S=shf2[1] A=sll_17/ML_int[1][9]
+ B=sll_17/ML_int[1][7]
XU167 MUX2S $PINS O=sll_17/ML_int[1][9] S=shf2[0] A=term2_in[9] B=term2_in[8]
XU182 MUX2S $PINS O=sll_18/ML_int[2][9] S=shf3[1] A=sll_18/ML_int[1][9]
+ B=sll_18/ML_int[1][7]
XU187 MUX2S $PINS O=sll_18/ML_int[1][9] S=shf3[0] A=term3_in[9] B=term3_in[8]
XU189 MUX2S $PINS O=sll_16/ML_int[2][10] S=shf1[1] A=sll_16/ML_int[1][10]
+ B=sll_16/ML_int[1][8]
XU191 MUX2S $PINS O=sll_16/ML_int[1][10] S=shf1[0] A=term1_in[10] B=term1_in[9]
XU192 MUX2S $PINS O=sll_18/ML_int[2][10] S=shf3[1] A=sll_18/ML_int[1][10]
+ B=sll_18/ML_int[1][8]
XU193 MUX2S $PINS O=sll_18/ML_int[1][10] S=shf3[0] A=term3_in[10] B=term3_in[9]
XU194 MUX2S $PINS O=sll_18/ML_int[3][10] S=FE_OFN68_h33_2
+ A=sll_18/ML_int[2][10] B=sll_18/ML_int[2][6]
XU195 MUX2S $PINS O=sll_17/ML_int[2][10] S=shf2[1] A=sll_17/ML_int[1][10]
+ B=sll_17/ML_int[1][8]
XU196 MUX2S $PINS O=sll_17/ML_int[1][10] S=shf2[0] A=term2_in[10] B=term2_in[9]
XU197 MUX2S $PINS O=sll_17/ML_int[3][10] S=shf2[2] A=sll_17/ML_int[2][10]
+ B=sll_17/ML_int[2][6]
XU198 MUX2S $PINS O=sll_16/ML_int[2][11] S=shf1[1] A=sll_16/ML_int[1][11]
+ B=sll_16/ML_int[1][9]
XU199 MUX2S $PINS O=sll_16/ML_int[1][11] S=shf1[0] A=term1_in[11]
+ B=term1_in[10]
XU200 MUX2S $PINS O=sll_18/ML_int[2][11] S=shf3[1] A=sll_18/ML_int[1][11]
+ B=sll_18/ML_int[1][9]
XU201 MUX2S $PINS O=sll_18/ML_int[3][11] S=FE_OFN68_h33_2
+ A=sll_18/ML_int[2][11] B=sll_18/ML_int[2][7]
XU202 MUX2S $PINS O=sll_18/ML_int[1][11] S=shf3[0] A=term3_in[11]
+ B=term3_in[10]
XU203 MUX2S $PINS O=sll_17/ML_int[2][11] S=shf2[1] A=sll_17/ML_int[1][11]
+ B=sll_17/ML_int[1][9]
XU204 MUX2S $PINS O=sll_17/ML_int[3][11] S=shf2[2] A=sll_17/ML_int[2][11]
+ B=sll_17/ML_int[2][7]
XU205 MUX2S $PINS O=sll_17/ML_int[1][11] S=shf2[0] A=term2_in[11]
+ B=term2_in[10]
XU206 AO22 $PINS O=N62 A1=N35 A2=sign1[0] B1=term1_shifted[21] B2=FE_RN_2
XU207 AO22S $PINS O=N65 A1=N38 A2=sign1[0] B1=term1_shifted[24] B2=FE_RN_2
XU208 AO22S $PINS O=N66 A1=N39 A2=sign1[0] B1=term1_shifted[25] B2=FE_RN_2
XU209 MUX2S $PINS O=sll_16/ML_int[2][12] S=shf1[1] A=sll_16/ML_int[1][12]
+ B=sll_16/ML_int[1][10]
XU210 MUX2S $PINS O=sll_16/ML_int[3][12] S=FE_OFN273_h31_2
+ A=sll_16/ML_int[2][12] B=sll_16/ML_int[2][8]
XU211 MUX2S $PINS O=sll_16/ML_int[1][12] S=shf1[0] A=term1_in[12]
+ B=term1_in[11]
XU212 MUX2S $PINS O=sll_18/ML_int[2][12] S=shf3[1] A=sll_18/ML_int[1][12]
+ B=sll_18/ML_int[1][10]
XU213 MUX2S $PINS O=sll_18/ML_int[3][12] S=FE_OFN68_h33_2
+ A=sll_18/ML_int[2][12] B=sll_18/ML_int[2][8]
XU214 MUX2S $PINS O=sll_18/ML_int[1][12] S=shf3[0] A=term3_in[12]
+ B=term3_in[11]
XU215 MUX2S $PINS O=sll_17/ML_int[2][12] S=shf2[1] A=sll_17/ML_int[1][12]
+ B=sll_17/ML_int[1][10]
XU216 MUX2S $PINS O=sll_17/ML_int[3][12] S=shf2[2] A=sll_17/ML_int[2][12]
+ B=sll_17/ML_int[2][8]
XU217 MUX2S $PINS O=sll_17/ML_int[1][12] S=shf2[0] A=term2_in[12]
+ B=term2_in[11]
XU218 MUX2S $PINS O=sll_16/ML_int[2][13] S=shf1[1] A=sll_16/ML_int[1][13]
+ B=sll_16/ML_int[1][11]
XU219 MUX2S $PINS O=sll_16/ML_int[3][13] S=FE_OFN273_h31_2
+ A=sll_16/ML_int[2][13] B=sll_16/ML_int[2][9]
XU220 MUX2S $PINS O=sll_16/ML_int[1][13] S=shf1[0] A=term1_in[13]
+ B=term1_in[12]
XU221 MUX2S $PINS O=sll_18/ML_int[2][13] S=shf3[1] A=sll_18/ML_int[1][13]
+ B=sll_18/ML_int[1][11]
XU222 MUX2S $PINS O=sll_18/ML_int[3][13] S=FE_OFN68_h33_2
+ A=sll_18/ML_int[2][13] B=sll_18/ML_int[2][9]
XU223 MUX2S $PINS O=sll_18/ML_int[1][13] S=shf3[0] A=term3_in[13]
+ B=term3_in[12]
XU224 MUX2S $PINS O=sll_17/ML_int[2][13] S=shf2[1] A=sll_17/ML_int[1][13]
+ B=sll_17/ML_int[1][11]
XU225 MUX2S $PINS O=sll_17/ML_int[3][13] S=shf2[2] A=sll_17/ML_int[2][13]
+ B=sll_17/ML_int[2][9]
XU226 MUX2S $PINS O=sll_17/ML_int[1][13] S=shf2[0] A=term2_in[13]
+ B=term2_in[12]
XU227 MUX2S $PINS O=sll_16/ML_int[2][14] S=shf1[1] A=sll_16/ML_int[1][14]
+ B=sll_16/ML_int[1][12]
XU228 MUX2S $PINS O=sll_16/ML_int[3][14] S=FE_OFN273_h31_2
+ A=sll_16/ML_int[2][14] B=sll_16/ML_int[2][10]
XU229 MUX2S $PINS O=sll_16/ML_int[1][14] S=shf1[0] A=term1_in[14]
+ B=term1_in[13]
XU230 MUX2S $PINS O=term3_shifted[14] S=FE_RN_3 A=sll_18/ML_int[3][14]
+ B=sll_18/ML_int[3][6]
XU231 MUX2S $PINS O=sll_18/ML_int[2][14] S=shf3[1] A=sll_18/ML_int[1][14]
+ B=sll_18/ML_int[1][12]
XU232 MUX2S $PINS O=sll_18/ML_int[3][14] S=FE_OFN68_h33_2
+ A=sll_18/ML_int[2][14] B=sll_18/ML_int[2][10]
XU233 MUX2S $PINS O=sll_18/ML_int[1][14] S=shf3[0] A=term3_in[14]
+ B=term3_in[13]
XU234 MUX2S $PINS O=term2_shifted[14] S=FE_OFN65_h32_3 A=sll_17/ML_int[3][14]
+ B=sll_17/ML_int[3][6]
XU235 MUX2S $PINS O=sll_17/ML_int[2][14] S=shf2[1] A=sll_17/ML_int[1][14]
+ B=sll_17/ML_int[1][12]
XU236 MUX2S $PINS O=sll_17/ML_int[3][14] S=shf2[2] A=sll_17/ML_int[2][14]
+ B=sll_17/ML_int[2][10]
XU237 MUX2S $PINS O=sll_17/ML_int[1][14] S=shf2[0] A=term2_in[14]
+ B=term2_in[13]
XU238 MUX2S $PINS O=term1_shifted[16] S=shf1[3] A=sll_16/ML_int[3][16]
+ B=sll_16/ML_int[3][8]
XU239 MUX2S $PINS O=n104 S=shf1[1] A=n107 B=sll_16/ML_int[1][14]
XU240 MUX2S $PINS O=term3_shifted[16] S=FE_RN_3 A=sll_18/ML_int[3][16]
+ B=sll_18/ML_int[3][8]
XU241 MUX2S $PINS O=n126 S=shf3[1] A=n129 B=sll_18/ML_int[1][14]
XU242 MUX2S $PINS O=sll_16/ML_int[3][15] S=FE_OFN273_h31_2
+ A=sll_16/ML_int[2][15] B=sll_16/ML_int[2][11]
XU243 MUX2S $PINS O=sll_16/ML_int[2][15] S=shf1[1] A=sll_16/ML_int[1][15]
+ B=sll_16/ML_int[1][13]
XU244 MUX2S $PINS O=sll_16/ML_int[1][15] S=shf1[0] A=term1_in[15]
+ B=term1_in[14]
XU245 MUX2S $PINS O=term2_shifted[16] S=FE_OFN65_h32_3 A=sll_17/ML_int[3][16]
+ B=sll_17/ML_int[3][8]
XU246 MUX2S $PINS O=n115 S=shf2[1] A=n118 B=sll_17/ML_int[1][14]
XU247 MUX2S $PINS O=term3_shifted[15] S=shf3[3] A=sll_18/ML_int[3][15]
+ B=sll_18/ML_int[3][7]
XU248 MUX2S $PINS O=sll_18/ML_int[3][15] S=FE_OFN68_h33_2
+ A=sll_18/ML_int[2][15] B=sll_18/ML_int[2][11]
XU249 MUX2S $PINS O=sll_18/ML_int[2][15] S=shf3[1] A=sll_18/ML_int[1][15]
+ B=sll_18/ML_int[1][13]
XU250 MUX2S $PINS O=sll_18/ML_int[1][15] S=shf3[0] A=term3_in[15]
+ B=term3_in[14]
XU251 MUX2S $PINS O=term2_shifted[15] S=FE_OFN65_h32_3 A=sll_17/ML_int[3][15]
+ B=sll_17/ML_int[3][7]
XU252 MUX2S $PINS O=sll_17/ML_int[3][15] S=shf2[2] A=sll_17/ML_int[2][15]
+ B=sll_17/ML_int[2][11]
XU253 MUX2S $PINS O=sll_17/ML_int[2][15] S=shf2[1] A=sll_17/ML_int[1][15]
+ B=sll_17/ML_int[1][13]
XU254 MUX2S $PINS O=sll_17/ML_int[1][15] S=shf2[0] A=term2_in[15]
+ B=term2_in[14]
XU255 MUX2S $PINS O=term1_shifted[17] S=shf1[3] A=sll_16/ML_int[3][17]
+ B=sll_16/ML_int[3][9]
XU256 MUX2S $PINS O=term3_shifted[17] S=shf3[3] A=sll_18/ML_int[3][17]
+ B=sll_18/ML_int[3][9]
XU257 MUX2S $PINS O=term2_shifted[17] S=FE_OFN65_h32_3 A=sll_17/ML_int[3][17]
+ B=sll_17/ML_int[3][9]
XU258 MUX2S $PINS O=term1_shifted[18] S=shf1[3] A=sll_16/ML_int[3][18]
+ B=sll_16/ML_int[3][10]
XU259 MUX2S $PINS O=term3_shifted[18] S=FE_RN_3 A=sll_18/ML_int[3][18]
+ B=sll_18/ML_int[3][10]
XU260 MUX2S $PINS O=term2_shifted[18] S=FE_OFN65_h32_3 A=sll_17/ML_int[3][18]
+ B=sll_17/ML_int[3][10]
XU263 MUX2S $PINS O=sll_16/ML_int[3][16] S=FE_OFN273_h31_2 A=n104
+ B=sll_16/ML_int[2][12]
XU264 MUX2S $PINS O=n129 S=shf3[0] A=term3_in[26] B=term3_in[15]
XU265 MUX2S $PINS O=sll_18/ML_int[3][16] S=FE_OFN68_h33_2 A=n126
+ B=sll_18/ML_int[2][12]
XU266 MUX2S $PINS O=sll_17/ML_int[3][16] S=shf2[2] A=n115
+ B=sll_17/ML_int[2][12]
XU267 MUX2S $PINS O=n105 S=shf1[1] A=n5 B=sll_16/ML_int[1][15]
XU268 MUX2S $PINS O=sll_16/ML_int[3][17] S=FE_OFN273_h31_2 A=n105
+ B=sll_16/ML_int[2][13]
XU269 MUX2S $PINS O=n127 S=shf3[1] A=n6 B=sll_18/ML_int[1][15]
XU270 MUX2S $PINS O=sll_18/ML_int[3][17] S=FE_OFN68_h33_2 A=n127
+ B=sll_18/ML_int[2][13]
XU271 MUX2S $PINS O=n116 S=shf2[1] A=term2_in[26] B=sll_17/ML_int[1][15]
XU272 MUX2S $PINS O=sll_17/ML_int[3][17] S=shf2[2] A=n116
+ B=sll_17/ML_int[2][13]
XU273 MUX2S $PINS O=n106 S=FE_DBTN180_h31_1 A=n107 B=term1_in[26]
XU274 MUX2S $PINS O=sll_16/ML_int[3][18] S=shf1[2] A=n106
+ B=sll_16/ML_int[2][14]
XU275 MUX2S $PINS O=sll_18/ML_int[3][18] S=FE_OFN68_h33_2 A=n128
+ B=sll_18/ML_int[2][14]
XU276 MUX2S $PINS O=n117 S=n42 A=n118 B=term2_in[26]
XU277 MUX2S $PINS O=sll_17/ML_int[3][18] S=shf2[2] A=n117
+ B=sll_17/ML_int[2][14]
XU279 MUX2S $PINS O=term1_shifted[20] S=shf1[3] A=sll_16/ML_int[3][20]
+ B=sll_16/ML_int[3][12]
XU280 MUX2S $PINS O=sll_16/ML_int[3][20] S=shf1[2] A=term1_in[26] B=n104
XU281 MUX2S $PINS O=term1_shifted[19] S=shf1[3] A=sll_16/ML_int[3][19]
+ B=sll_16/ML_int[3][11]
XU282 MUX2S $PINS O=term3_shifted[20] S=FE_RN_3 A=sll_18/ML_int[3][20]
+ B=sll_18/ML_int[3][12]
XU283 MUX2S $PINS O=sll_18/ML_int[3][20] S=FE_OFN68_h33_2 A=term3_in[26] B=n126
XU284 MUX2S $PINS O=term3_shifted[19] S=shf3[3] A=sll_18/ML_int[3][19]
+ B=sll_18/ML_int[3][11]
XU285 MUX2S $PINS O=term2_shifted[20] S=FE_OFN65_h32_3 A=sll_17/ML_int[3][20]
+ B=sll_17/ML_int[3][12]
XU286 MUX2S $PINS O=sll_17/ML_int[3][20] S=shf2[2] A=term2_in[26] B=n115
XU287 MUX2S $PINS O=term2_shifted[19] S=FE_OFN65_h32_3 A=sll_17/ML_int[3][19]
+ B=sll_17/ML_int[3][11]
XU289 MUX2S $PINS O=term1_shifted[21] S=shf1[3] A=sll_16/ML_int[3][21]
+ B=sll_16/ML_int[3][13]
XU290 MUX2S $PINS O=term2_shifted[21] S=FE_OFN65_h32_3 A=sll_17/ML_int[3][21]
+ B=sll_17/ML_int[3][13]
XU291 MUX2S $PINS O=term3_shifted[21] S=FE_RN_3 A=sll_18/ML_int[3][21]
+ B=sll_18/ML_int[3][13]
XU292 MUX2S $PINS O=term1_shifted[22] S=shf1[3] A=sll_16/ML_int[3][22]
+ B=sll_16/ML_int[3][14]
XU293 MUX2S $PINS O=term2_shifted[22] S=FE_OFN65_h32_3 A=sll_17/ML_int[3][22]
+ B=sll_17/ML_int[3][14]
XU294 MUX2S $PINS O=term3_shifted[22] S=FE_RN_3 A=sll_18/ML_int[3][22]
+ B=sll_18/ML_int[3][14]
XU297 AN2S $PINS O=base_val[1] I1=acc_reg[1] I2=n148
XU298 AN2S $PINS O=base_val[2] I1=acc_reg[2] I2=n148
XU300 ND2S $PINS O=n149 I1=FE_PHN1012_N251 I2=n30
XU301 MUX2S $PINS O=N235 S=n30 A=FE_PHN1169_acc_reg_10 B=FE_PHN1015_acc_reg_14
XU302 MUX2S $PINS O=FE_PHN1275_N244 S=n30 A=FE_PHN1010_acc_reg_19 B=acc_reg[23]
XU316 NR2 $PINS O=term1_in[3] I1=FE_OFN87_s31_1 I2=x_in[3]
XU317 INV1S $PINS O=n102 I=n97
XU318 INV1S $PINS O=n113 I=n108
XU319 NR2P $PINS O=term3_in[4] I1=FE_OFN88_s33_1 I2=x_in[4]
XU320 INV1S $PINS O=n124 I=n119
XU321 NR2T $PINS O=term1_in[5] I1=FE_OFN87_s31_1 I2=x_in[5]
XU322 NR2 $PINS O=term2_in[5] I1=sign2[1] I2=x_in[5]
XU323 INV1S $PINS O=n114 I=n109
XU324 NR2 $PINS O=term3_in[5] I1=FE_OFN88_s33_1 I2=x_in[5]
XU325 NR2 $PINS O=term1_in[7] I1=sign1[1] I2=x_in[7]
XU326 NR2 $PINS O=term2_in[7] I1=sign2[1] I2=x_in[7]
XU327 NR2 $PINS O=term3_in[7] I1=FE_OFN88_s33_1 I2=x_in[7]
XU328 NR2 $PINS O=term2_in[6] I1=sign2[1] I2=x_in[6]
XU329 NR2 $PINS O=term3_in[6] I1=FE_OFN88_s33_1 I2=x_in[6]
XU330 NR2 $PINS O=term1_in[8] I1=sign1[1] I2=x_in[8]
XU331 NR2 $PINS O=term2_in[8] I1=FE_OFN85_s32_1 I2=x_in[8]
XU332 NR2 $PINS O=term3_in[8] I1=FE_OFN88_s33_1 I2=x_in[8]
XU336 NR2 $PINS O=term1_in[9] I1=sign1[1] I2=x_in[9]
XU337 NR2 $PINS O=term2_in[9] I1=FE_OFN85_s32_1 I2=x_in[9]
XU338 NR2 $PINS O=term3_in[9] I1=FE_OFN88_s33_1 I2=x_in[9]
XU339 NR2 $PINS O=term1_in[10] I1=FE_OFN87_s31_1 I2=x_in[10]
XU340 NR2 $PINS O=term2_in[10] I1=FE_OFN85_s32_1 I2=x_in[10]
XU341 NR2 $PINS O=term3_in[10] I1=FE_OFN88_s33_1 I2=x_in[10]
XU342 NR2 $PINS O=term1_in[11] I1=FE_OFN87_s31_1 I2=x_in[11]
XU343 NR2 $PINS O=term2_in[11] I1=FE_OFN85_s32_1 I2=x_in[11]
XU344 NR2 $PINS O=term3_in[11] I1=FE_OFN88_s33_1 I2=x_in[11]
XU345 NR2 $PINS O=term1_in[12] I1=FE_OFN87_s31_1 I2=x_in[12]
XU347 NR2 $PINS O=term2_in[12] I1=FE_OFN85_s32_1 I2=x_in[12]
XU348 NR2 $PINS O=term3_in[12] I1=FE_OFN88_s33_1 I2=x_in[12]
XU353 NR2 $PINS O=term1_in[13] I1=FE_OFN87_s31_1 I2=x_in[13]
XU355 NR2 $PINS O=term2_in[13] I1=FE_OFN85_s32_1 I2=x_in[13]
XU356 NR2 $PINS O=term3_in[13] I1=FE_OFN88_s33_1 I2=x_in[13]
XU357 NR2 $PINS O=term1_in[14] I1=FE_OFN87_s31_1 I2=n135
XU358 NR2 $PINS O=term2_in[14] I1=FE_OFN85_s32_1 I2=n135
XU359 NR2 $PINS O=term3_in[14] I1=FE_OFN88_s33_1 I2=n135
XU364 NR2 $PINS O=term1_in[15] I1=FE_OFN87_s31_1 I2=n136
XU366 NR2 $PINS O=term2_in[15] I1=FE_OFN85_s32_1 I2=n136
XU367 NR2 $PINS O=term3_in[15] I1=FE_OFN88_s33_1 I2=n136
XU382 INV1S $PINS O=n65 I=shf1[0]
XU387 INV1S $PINS O=n13 I=shf3[0]
XU404 INV1S $PINS O=n135 I=x_in[14]
XU408 INV1S $PINS O=n136 I=x_in[15]
XU409 INV1S $PINS O=n137 I=x_in[16]
XU410 NR2 $PINS O=term1_in[26] I1=n137 I2=FE_OFN87_s31_1
XU411 NR2 $PINS O=term2_in[26] I1=n137 I2=sign2[1]
XU412 NR2 $PINS O=term3_in[26] I1=n137 I2=FE_OFN88_s33_1
XU414 MOAI1S $PINS O=base_val[9] A1=n30 A2=n148 B1=acc_reg[9] B2=n148
XU415 AN2 $PINS O=base_val[10] I1=FE_PHN1169_acc_reg_10 I2=n148
XU416 AN2 $PINS O=base_val[8] I1=acc_reg[8] I2=n148
XU417 AN2 $PINS O=base_val[11] I1=acc_reg[11] I2=n148
XU418 AN2 $PINS O=base_val[12] I1=acc_reg[12] I2=n148
XU419 AN2 $PINS O=base_val[14] I1=acc_reg[14] I2=n148
XU420 AN2 $PINS O=base_val[15] I1=acc_reg[15] I2=n148
XU421 AN2 $PINS O=base_val[16] I1=FE_PHN1146_acc_reg_16 I2=n148
XU422 AN2 $PINS O=base_val[17] I1=acc_reg[17] I2=n148
XU423 AN2 $PINS O=base_val[18] I1=acc_reg[18] I2=n148
XU424 AN2 $PINS O=base_val[19] I1=acc_reg[19] I2=n148
XU425 AN2 $PINS O=base_val[20] I1=acc_reg[20] I2=n148
XU426 AN2 $PINS O=base_val[21] I1=FE_PHN1132_acc_reg_21 I2=n148
XU427 AN2 $PINS O=base_val[22] I1=acc_reg[22] I2=n148
XU428 AN2 $PINS O=base_val[23] I1=acc_reg[23] I2=n148
XU429 AN2 $PINS O=base_val[24] I1=acc_reg[24] I2=n148
XU430 AN2 $PINS O=base_val[25] I1=acc_reg[25] I2=n148
XU431 AN2 $PINS O=base_val[7] I1=acc_reg[7] I2=n148
XU432 AN2 $PINS O=base_val[6] I1=acc_reg[6] I2=n148
XU433 AN2 $PINS O=base_val[5] I1=acc_reg[5] I2=n148
XU434 AN2 $PINS O=base_val[4] I1=acc_reg[4] I2=n148
XU435 AN2 $PINS O=base_val[3] I1=acc_reg[3] I2=n148
XU437 AN2 $PINS O=base_val[0] I1=acc_reg[0] I2=n148
XU441 AN2 $PINS O=N234 I1=en I2=calc_done
XU442 OAI12HS $PINS O=N247 A1=n149 B1=n30 B2=n130
XU443 INV1S $PINS O=n130 I=acc_reg[22]
XU444 AN2 $PINS O=base_val[26] I1=N251 I2=n148
XU446 INV1S $PINS O=n103 I=n98
XU447 INV1S $PINS O=n125 I=n120
XU448 MUX2 $PINS O=sll_16/ML_int[3][6] S=FE_OFN273_h31_2 A=sll_16/ML_int[2][6]
+ B=sll_16/ML_int[2][2]
XU449 NR2 $PINS O=sll_16/ML_int[3][0] I1=FE_OFN273_h31_2 I2=n97
XU450 NR2 $PINS O=sll_16/ML_int[3][1] I1=FE_OFN273_h31_2 I2=n98
XU451 NR2 $PINS O=sll_16/ML_int[3][3] I1=shf1[2] I2=n100
XU452 AN2T $PINS O=term1_shifted[4] I1=sll_16/ML_int[3][4] I2=n77
XU453 AN2T $PINS O=term1_shifted[5] I1=sll_16/ML_int[3][5] I2=n77
XU455 MUX2 $PINS O=sll_16/ML_int[3][21] S=shf1[2] A=n5 B=n105
XU456 MUX2 $PINS O=sll_16/ML_int[3][22] S=shf1[2] A=term1_in[26] B=n106
XU457 MUX2 $PINS O=term1_shifted[24] S=shf1[3] A=term1_in[26]
+ B=sll_16/ML_int[3][16]
XU458 MUX2 $PINS O=term1_shifted[25] S=shf1[3] A=n5 B=sll_16/ML_int[3][17]
XU459 MUX2 $PINS O=term1_shifted[26] S=shf1[3] A=term1_in[26]
+ B=sll_16/ML_int[3][18]
XU460 NR2 $PINS O=sll_17/ML_int[3][0] I1=shf2[2] I2=n108
XU461 NR2 $PINS O=sll_17/ML_int[3][1] I1=shf2[2] I2=n109
XU462 NR2 $PINS O=sll_17/ML_int[3][2] I1=shf2[2] I2=n112
XU463 ND2T $PINS O=n110 I1=n46 I2=FE_RN_4
XU464 AN2T $PINS O=term2_shifted[4] I1=sll_17/ML_int[3][4] I2=FE_RN_4
XU465 AN2 $PINS O=term2_shifted[5] I1=sll_17/ML_int[3][5] I2=FE_RN_4
XU466 AN2 $PINS O=term2_shifted[6] I1=sll_17/ML_int[3][6] I2=FE_RN_4
XU467 AN2 $PINS O=term2_shifted[7] I1=sll_17/ML_int[3][7] I2=FE_RN_4
XU468 MUX2 $PINS O=sll_17/ML_int[3][21] S=shf2[2] A=term2_in[26] B=n116
XU469 MUX2 $PINS O=sll_17/ML_int[3][22] S=shf2[2] A=term2_in[26] B=n117
XU470 MUX2 $PINS O=term2_shifted[24] S=FE_OFN65_h32_3 A=term2_in[26]
+ B=sll_17/ML_int[3][16]
XU471 MUX2 $PINS O=term2_shifted[25] S=FE_OFN65_h32_3 A=term2_in[26]
+ B=sll_17/ML_int[3][17]
XU472 MUX2 $PINS O=term2_shifted[26] S=FE_OFN65_h32_3 A=term2_in[26]
+ B=sll_17/ML_int[3][18]
XU473 NR2 $PINS O=sll_18/ML_int[3][0] I1=FE_OFN68_h33_2 I2=FE_OCPN724_n119
XU474 NR2 $PINS O=sll_18/ML_int[3][1] I1=FE_OFN68_h33_2 I2=n120
XU475 NR2 $PINS O=sll_18/ML_int[3][2] I1=FE_OFN68_h33_2 I2=n123
XU477 AN2T $PINS O=term3_shifted[4] I1=sll_18/ML_int[3][4] I2=n25
XU480 AN2 $PINS O=term3_shifted[7] I1=sll_18/ML_int[3][7] I2=n25
XU481 MUX2 $PINS O=sll_18/ML_int[3][21] S=FE_OFN68_h33_2 A=n6 B=n127
XU482 MUX2 $PINS O=sll_18/ML_int[3][22] S=FE_OFN68_h33_2 A=term3_in[26] B=n128
XU483 MUX2 $PINS O=term3_shifted[24] S=shf3[3] A=term3_in[26]
+ B=sll_18/ML_int[3][16]
XU484 MUX2 $PINS O=term3_shifted[25] S=shf3[3] A=n6 B=sll_18/ML_int[3][17]
XU485 MUX2 $PINS O=term3_shifted[26] S=shf3[3] A=term3_in[26]
+ B=sll_18/ML_int[3][18]
XU486 MUX2 $PINS O=N245 S=n30 A=FE_PHN1005_acc_reg_20 B=FE_PHN874_acc_reg_24
XU487 MUX2 $PINS O=N246 S=n30 A=FE_PHN1132_acc_reg_21 B=FE_PHN1002_acc_reg_25
XU488 MUX2 $PINS O=N236 S=n30 A=acc_reg[11] B=FE_PHN1014_acc_reg_15
XU489 MUX2 $PINS O=N237 S=n30 A=FE_PHN1025_acc_reg_12 B=FE_PHN1146_acc_reg_16
XU490 MUX2 $PINS O=FE_PHN1257_N238 S=n30 A=acc_reg[13] B=FE_PHN994_acc_reg_17
XU491 MUX2 $PINS O=N239 S=n30 A=FE_PHN1015_acc_reg_14 B=FE_PHN1006_acc_reg_18
XU492 MUX2 $PINS O=N240 S=n30 A=FE_PHN1014_acc_reg_15 B=FE_PHN1010_acc_reg_19
XU493 MUX2 $PINS O=N241 S=n30 A=FE_PHN1146_acc_reg_16 B=FE_PHN1005_acc_reg_20
XU494 MUX2 $PINS O=N242 S=n30 A=FE_PHN994_acc_reg_17 B=FE_PHN1132_acc_reg_21
XU495 MUX2 $PINS O=N243 S=n30 A=FE_PHN1006_acc_reg_18 B=acc_reg[22]
Xclk_gate_y_out_reg SNPS_CLOCK_GATE_HIGH_PE_Shift_Add_1 $PINS EN=N234
+ ENCLK=net2198 CLK=clk_clone2
Xsub_28_3 PE_Shift_Add_1_DW01_sub_0_DW01_sub_3 $PINS A[26]=net44356
+ A[25]=net44356 A[24]=net44356 A[23]=net44356 A[22]=net44356 A[21]=net44356
+ A[20]=net44356 A[19]=net44356 A[18]=net44356 A[17]=net44356 A[16]=net44356
+ A[15]=net44356 A[14]=net44356 A[13]=net44356 A[12]=net44356 A[11]=net44356
+ A[10]=net44356 A[9]=net44356 A[8]=net44356 A[7]=net44356 A[6]=net44356
+ A[5]=net44356 A[4]=net44356 A[3]=net44356 A[2]=net44356 A[1]=net44356
+ A[0]=net44356 B[26]=term3_shifted[26] B[25]=term3_shifted[25]
+ B[24]=term3_shifted[24] B[23]=term3_shifted[23] B[22]=term3_shifted[22]
+ B[21]=term3_shifted[21] B[20]=term3_shifted[20] B[19]=term3_shifted[19]
+ B[18]=term3_shifted[18] B[17]=term3_shifted[17] B[16]=term3_shifted[16]
+ B[15]=term3_shifted[15] B[14]=term3_shifted[14] B[13]=term3_shifted[13]
+ B[12]=term3_shifted[12] B[11]=term3_shifted[11] B[10]=term3_shifted[10]
+ B[9]=term3_shifted[9] B[8]=term3_shifted[8] B[7]=term3_shifted[7]
+ B[6]=term3_shifted[6] B[5]=term3_shifted[5] B[4]=term3_shifted[4]
+ B[3]=term3_shifted[3] B[2]=term3_shifted[2] B[1]=term3_shifted[1]
+ B[0]=term3_shifted[0] CI=net44356 DIFF[26]=N150 DIFF[25]=N149 DIFF[24]=N148
+ DIFF[23]=N147 DIFF[22]=N146 DIFF[21]=N145 DIFF[20]=N144 DIFF[19]=N143
+ DIFF[18]=N142 DIFF[17]=N141 DIFF[16]=N140 DIFF[15]=N139 DIFF[14]=N138
+ DIFF[13]=N137 DIFF[12]=N136 DIFF[11]=N135 DIFF[10]=N134 DIFF[9]=N133
+ DIFF[8]=N132 DIFF[7]=N131 DIFF[6]=N130 DIFF[5]=N129 DIFF[4]=N128 DIFF[3]=N127
+ DIFF[2]=N126 DIFF[1]=N125 DIFF[0]=N124
Xsub_28_2 PE_Shift_Add_1_DW01_sub_1_DW01_sub_4 $PINS A[26]=net44356
+ A[25]=net44356 A[24]=net44356 A[23]=net44356 A[22]=net44356 A[21]=net44356
+ A[20]=net44356 A[19]=net44356 A[18]=net44356 A[17]=net44356 A[16]=net44356
+ A[15]=net44356 A[14]=net44356 A[13]=net44356 A[12]=net44356 A[11]=net44356
+ A[10]=net44356 A[9]=net44356 A[8]=net44356 A[7]=net44356 A[6]=net44356
+ A[5]=net44356 A[4]=net44356 A[3]=net44356 A[2]=net44356 A[1]=net44356
+ A[0]=net44356 B[26]=term2_shifted[26] B[25]=term2_shifted[25]
+ B[24]=term2_shifted[24] B[23]=term2_shifted[23] B[22]=term2_shifted[22]
+ B[21]=term2_shifted[21] B[20]=term2_shifted[20] B[19]=term2_shifted[19]
+ B[18]=term2_shifted[18] B[17]=term2_shifted[17] B[16]=term2_shifted[16]
+ B[15]=term2_shifted[15] B[14]=term2_shifted[14] B[13]=term2_shifted[13]
+ B[12]=term2_shifted[12] B[11]=term2_shifted[11] B[10]=term2_shifted[10]
+ B[9]=term2_shifted[9] B[8]=term2_shifted[8] B[7]=term2_shifted[7]
+ B[6]=term2_shifted[6] B[5]=term2_shifted[5] B[4]=term2_shifted[4]
+ B[3]=term2_shifted[3] B[2]=term2_shifted[2] B[1]=term2_shifted[1]
+ B[0]=term2_shifted[0] CI=net44356 DIFF[26]=N95 DIFF[25]=N94 DIFF[24]=N93
+ DIFF[23]=N92 DIFF[22]=N91 DIFF[21]=N90 DIFF[20]=N89 DIFF[19]=N88 DIFF[18]=N87
+ DIFF[17]=N86 DIFF[16]=N85 DIFF[15]=N84 DIFF[14]=N83 DIFF[13]=N82 DIFF[12]=N81
+ DIFF[11]=N80 DIFF[10]=N79 DIFF[9]=N78 DIFF[8]=N77 DIFF[7]=N76 DIFF[6]=N75
+ DIFF[5]=N74 DIFF[4]=N73 DIFF[3]=N72 DIFF[2]=N71 DIFF[1]=N70 DIFF[0]=N69
Xsub_28 PE_Shift_Add_1_DW01_sub_2_DW01_sub_5 $PINS A[26]=net44356
+ A[25]=net44356 A[24]=net44356 A[23]=net44356 A[22]=net44356 A[21]=net44356
+ A[20]=net44356 A[19]=net44356 A[18]=net44356 A[17]=net44356 A[16]=net44356
+ A[15]=net44356 A[14]=net44356 A[13]=net44356 A[12]=net44356 A[11]=net44356
+ A[10]=net44356 A[9]=net44356 A[8]=net44356 A[7]=net44356 A[6]=net44356
+ A[5]=net44356 A[4]=net44356 A[3]=net44356 A[2]=net44356 A[1]=net44356
+ A[0]=net44356 B[26]=term1_shifted[26] B[25]=term1_shifted[25]
+ B[24]=term1_shifted[24] B[23]=term1_shifted[23] B[22]=term1_shifted[22]
+ B[21]=term1_shifted[21] B[20]=term1_shifted[20] B[19]=term1_shifted[19]
+ B[18]=term1_shifted[18] B[17]=term1_shifted[17] B[16]=term1_shifted[16]
+ B[15]=term1_shifted[15] B[14]=term1_shifted[14] B[13]=term1_shifted[13]
+ B[12]=term1_shifted[12] B[11]=term1_shifted[11] B[10]=term1_shifted[10]
+ B[9]=term1_shifted[9] B[8]=term1_shifted[8] B[7]=term1_shifted[7]
+ B[6]=term1_shifted[6] B[5]=term1_shifted[5] B[4]=term1_shifted[4]
+ B[3]=term1_shifted[3] B[2]=term1_shifted[2] B[1]=term1_shifted[1]
+ B[0]=term1_shifted[0] CI=net44356 DIFF[26]=N40 DIFF[25]=N39 DIFF[24]=N38
+ DIFF[23]=N37 DIFF[22]=N36 DIFF[21]=N35 DIFF[20]=N34 DIFF[19]=N33 DIFF[18]=N32
+ DIFF[17]=N31 DIFF[16]=N30 DIFF[15]=N29 DIFF[14]=N28 DIFF[13]=N27 DIFF[12]=N26
+ DIFF[11]=N25 DIFF[10]=N24 DIFF[9]=N23 DIFF[8]=N22 DIFF[7]=N21 DIFF[6]=N20
+ DIFF[5]=N19 DIFF[4]=N18 DIFF[3]=N17 DIFF[2]=N16 DIFF[1]=N15 DIFF[0]=N14
Xadd_1_root_add_0_root_add_28_3 PE_Shift_Add_1_DW01_add_2_DW01_add_16 $PINS
+ A[26]=N67 A[25]=N66 A[24]=N65 A[23]=N64 A[22]=N63 A[21]=N62 A[20]=N61 A[19]=N60
+ A[18]=N59 A[17]=N58 A[16]=N57 A[15]=N56 A[14]=N55 A[13]=N54 A[12]=N53 A[11]=N52
+ A[10]=N51 A[9]=N50 A[8]=N49 A[7]=N48 A[6]=N47 A[5]=N46 A[4]=N45 A[3]=N44
+ A[2]=N43 A[1]=N42 A[0]=N41 B[26]=N177 B[25]=N176 B[24]=N175 B[23]=N174
+ B[22]=N173 B[21]=N172 B[20]=N171 B[19]=N170 B[18]=N169 B[17]=N168 B[16]=N167
+ B[15]=N166 B[14]=N165 B[13]=N164 B[12]=N163 B[11]=N162 B[10]=N161 B[9]=N160
+ B[8]=N159 B[7]=N158 B[6]=N157 B[5]=N156 B[4]=N155 B[3]=N154 B[2]=N153 B[1]=N152
+ B[0]=N151 CI=net44356 SUM[26]=N204 SUM[25]=N203 SUM[24]=N202 SUM[23]=N201
+ SUM[22]=N200 SUM[21]=N199 SUM[20]=N198 SUM[19]=N197 SUM[18]=N196 SUM[17]=N195
+ SUM[16]=N194 SUM[15]=N193 SUM[14]=N192 SUM[13]=N191 SUM[12]=N190 SUM[11]=N189
+ SUM[10]=N188 SUM[9]=N187 SUM[8]=N186 SUM[7]=N185 SUM[6]=N184 SUM[5]=N183
+ SUM[4]=N182 SUM[3]=N181 SUM[2]=N180 SUM[1]=N179 SUM[0]=N178
Xadd_2_root_add_0_root_add_28_3 PE_Shift_Add_1_DW01_add_1_DW01_add_15 $PINS
+ A[26]=base_val[26] A[25]=base_val[25] A[24]=base_val[24] A[23]=base_val[23]
+ A[22]=base_val[22] A[21]=base_val[21] A[20]=base_val[20] A[19]=base_val[19]
+ A[18]=base_val[18] A[17]=base_val[17] A[16]=base_val[16] A[15]=base_val[15]
+ A[14]=base_val[14] A[13]=base_val[13] A[12]=base_val[12] A[11]=base_val[11]
+ A[10]=base_val[10] A[9]=base_val[9] A[8]=base_val[8] A[7]=base_val[7]
+ A[6]=base_val[6] A[5]=base_val[5] A[4]=base_val[4] A[3]=base_val[3]
+ A[2]=base_val[2] A[1]=base_val[1] A[0]=base_val[0] B[26]=N122 B[25]=N121
+ B[24]=N120 B[23]=N119 B[22]=N118 B[21]=N117 B[20]=N116 B[19]=N115 B[18]=N114
+ B[17]=N113 B[16]=N112 B[15]=N111 B[14]=N110 B[13]=N109 B[12]=N108 B[11]=N107
+ B[10]=N106 B[9]=N105 B[8]=N104 B[7]=N103 B[6]=N102 B[5]=N101 B[4]=N100 B[3]=N99
+ B[2]=N98 B[1]=N97 B[0]=N96 CI=net44356 SUM[26]=N231 SUM[25]=N230 SUM[24]=N229
+ SUM[23]=N228 SUM[22]=N227 SUM[21]=N226 SUM[20]=N225 SUM[19]=N224 SUM[18]=N223
+ SUM[17]=N222 SUM[16]=N221 SUM[15]=N220 SUM[14]=N219 SUM[13]=N218 SUM[12]=N217
+ SUM[11]=N216 SUM[10]=N215 SUM[9]=N214 SUM[8]=N213 SUM[7]=N212 SUM[6]=N211
+ SUM[5]=N210 SUM[4]=N209 SUM[3]=N208 SUM[2]=N207 SUM[1]=N206 SUM[0]=N205
Xadd_0_root_add_0_root_add_28_3 PE_Shift_Add_1_DW01_add_0_DW01_add_14 $PINS
+ A[26]=N204 A[25]=N203 A[24]=N202 A[23]=N201 A[22]=N200 A[21]=N199 A[20]=N198
+ A[19]=N197 A[18]=N196 A[17]=N195 A[16]=N194 A[15]=N193 A[14]=N192 A[13]=N191
+ A[12]=N190 A[11]=N189 A[10]=N188 A[9]=N187 A[8]=N186 A[7]=N185 A[6]=N184
+ A[5]=N183 A[4]=N182 A[3]=N181 A[2]=N180 A[1]=N179 A[0]=N178 B[26]=N231
+ B[25]=N230 B[24]=N229 B[23]=N228 B[22]=N227 B[21]=N226 B[20]=N225 B[19]=N224
+ B[18]=N223 B[17]=N222 B[16]=N221 B[15]=N220 B[14]=N219 B[13]=N218 B[12]=N217
+ B[11]=N216 B[10]=N215 B[9]=N214 B[8]=N213 B[7]=N212 B[6]=N211 B[5]=N210
+ B[4]=N209 B[3]=N208 B[2]=N207 B[1]=N206 B[0]=N205 CI=net44356
+ SUM[26]=next_acc[26] SUM[25]=next_acc[25] SUM[24]=next_acc[24]
+ SUM[23]=next_acc[23] SUM[22]=next_acc[22] SUM[21]=next_acc[21]
+ SUM[20]=next_acc[20] SUM[19]=next_acc[19] SUM[18]=next_acc[18]
+ SUM[17]=next_acc[17] SUM[16]=next_acc[16] SUM[15]=next_acc[15]
+ SUM[14]=next_acc[14] SUM[13]=next_acc[13] SUM[12]=next_acc[12]
+ SUM[11]=next_acc[11] SUM[10]=next_acc[10] SUM[9]=next_acc[9] SUM[8]=next_acc[8]
+ SUM[7]=next_acc[7] SUM[6]=next_acc[6] SUM[5]=next_acc[5] SUM[4]=next_acc[4]
+ SUM[3]=next_acc[3] SUM[2]=next_acc[2] SUM[1]=next_acc[1] SUM[0]=next_acc[0]
Xsll_16/M1_0_5 MUX2 $PINS O=sll_16/ML_int[1][5] S=shf1[0] A=term1_in[5]
+ B=term1_in[4]
Xsll_16/M1_0_2 MUX2 $PINS O=sll_16/ML_int[1][2] S=shf1[0] A=term1_in[2]
+ B=term1_in[1]
XU14 MUX2 $PINS O=sll_17/ML_int[1][2] S=shf2[0] A=term2_in[2] B=term2_in[1]
Xsll_17/M1_1_6 MUX2 $PINS O=sll_17/ML_int[2][6] S=shf2[1] A=sll_17/ML_int[1][6]
+ B=sll_17/ML_int[1][4]
Xsll_17/M1_1_4 MUX2 $PINS O=sll_17/ML_int[2][4] S=shf2[1] A=sll_17/ML_int[1][4]
+ B=sll_17/ML_int[1][2]
Xsll_17/M1_0_3 MUX2S $PINS O=sll_17/ML_int[1][3] S=shf2[0] A=term2_in[3]
+ B=term2_in[2]
XU6 NR2T $PINS O=term2_shifted[1] I1=n110 I2=n109
XU9 INV2 $PINS O=n101 I=sll_16/ML_int[2][2]
XU12 ND2P $PINS O=n109 I1=sll_17/ML_int[1][1] I2=n42
XU19 AN2B1T $PINS O=term2_shifted[3] I1=sll_17/ML_int[2][3] B1=n110
XU20 NR2P $PINS O=term1_in[0] I1=FE_OFN87_s31_1 I2=FE_OFN352_mac_in_real_0
XU21 NR2P $PINS O=term1_in[2] I1=FE_OFN87_s31_1 I2=n145
XU42 NR2P $PINS O=term1_shifted[0] I1=n99 I2=n97
XU43 NR2T $PINS O=term1_shifted[2] I1=n99 I2=n101
XU45 AN2 $PINS O=sll_16/ML_int[1][0] I1=term1_in[0] I2=n65
XU51 ND3 $PINS O=n108 I1=term2_in[0] I2=n39 I3=n42
XU54 AN2 $PINS O=sll_18/ML_int[3][3] I1=FE_RN_1 I2=sll_18/ML_int[2][3]
XU58 NR2T $PINS O=term3_shifted[0] I1=n121 I2=n119
XU60 INV1S $PINS O=n16 I=shf3[1]
XU75 ND2P $PINS O=n98 I1=sll_16/ML_int[1][1] I2=FE_DBTN180_h31_1
XU76 NR2P $PINS O=term1_shifted[1] I1=n99 I2=n98
XU78 INV2 $PINS O=n100 I=sll_16/ML_int[2][3]
XU102 ND2P $PINS O=n99 I1=n74 I2=n77
XU116 NR2P $PINS O=term3_in[0] I1=FE_OFN88_s33_1 I2=FE_OFN352_mac_in_real_0
XU365 NR2P $PINS O=term1_shifted[3] I1=n99 I2=n100
.ENDS

.SUBCKT SNPS_CLOCK_GATE_HIGH_PE_Shift_Add_0 EN ENCLK CLK
*.CONNECT net2174 EN
XFE_PHC891_net2177 DELC $PINS O=FE_PHN891_net2177 I=net2177
Xlatch QDBHN $PINS Q=net2177 D=net2174 CKB=CLK
Xmain_gate AN2 $PINS O=ENCLK I1=FE_PHN891_net2177 I2=CLK
.ENDS

.SUBCKT PE_Shift_Add_0_DW01_sub_0 A[26] A[25] A[24] A[23] A[22] A[21] A[20]
+ A[19] A[18] A[17] A[16] A[15] A[14] A[13] A[12] A[11] A[10] A[9] A[8] A[7]
+ A[6] A[5] A[4] A[3] A[2] A[1] A[0] B[26] B[25] B[24] B[23] B[22] B[21] B[20]
+ B[19] B[18] B[17] B[16] B[15] B[14] B[13] B[12] B[11] B[10] B[9] B[8] B[7]
+ B[6] B[5] B[4] B[3] B[2] B[1] B[0] CI DIFF[26] DIFF[25] DIFF[24] DIFF[23]
+ DIFF[22] DIFF[21] DIFF[20] DIFF[19] DIFF[18] DIFF[17] DIFF[16] DIFF[15]
+ DIFF[14] DIFF[13] DIFF[12] DIFF[11] DIFF[10] DIFF[9] DIFF[8] DIFF[7] DIFF[6]
+ DIFF[5] DIFF[4] DIFF[3] DIFF[2] DIFF[1] DIFF[0] CO
*.CONNECT DIFF[0] B[0]
XFE_RC_722_0 AN2B1T $PINS O=n13 I1=n12 B1=B[6]
XFE_RC_544_0 XNR2HS $PINS O=DIFF[9] I1=B[9] I2=n15
XFE_RC_519_0 XNR2HS $PINS O=DIFF[8] I1=n14 I2=B[8]
XFE_RC_464_0 AN2B1S $PINS O=n3 I1=n2 B1=B[3]
XFE_RC_405_0 XNR2HS $PINS O=DIFF[7] I1=n13 I2=B[7]
XFE_RC_1591_0 XNR2HS $PINS O=DIFF[5] I1=n11 I2=B[5]
XFE_RC_1562_0 XOR2HS $PINS O=DIFF[1] I1=DIFF[0] I2=B[1]
XFE_OFC616_term3_shifted_3 INV1S $PINS O=n49 I=B[3]
XU3 XOR2HS $PINS O=DIFF[2] I1=n50 I2=n1
XU5 NR2 $PINS O=n1 I1=DIFF[0] I2=B[1]
XU8 INV1S $PINS O=n47 I=B[5]
XU9 XOR2HS $PINS O=DIFF[4] I1=n48 I2=n3
XU11 INV1S $PINS O=n46 I=B[6]
XU13 AN2 $PINS O=n2 I1=n1 I2=n50
XU15 AN2 $PINS O=n4 I1=n40 I2=n18
XU16 AN2 $PINS O=n5 I1=n39 I2=n4
XU17 AN2 $PINS O=n6 I1=n38 I2=n5
XU18 AN2 $PINS O=n7 I1=n37 I2=n6
XU19 AN2 $PINS O=n8 I1=n36 I2=n7
XU20 AN2 $PINS O=n9 I1=n35 I2=n8
XU21 AN2 $PINS O=n10 I1=n34 I2=n9
XU22 AN2 $PINS O=n11 I1=n48 I2=n3
XU23 AN2 $PINS O=n12 I1=n47 I2=n11
XU25 AN2T $PINS O=n14 I1=n45 I2=n13
XU26 AN2 $PINS O=n15 I1=n14 I2=n44
XU27 AN2 $PINS O=n16 I1=n43 I2=n15
XU28 AN2 $PINS O=n17 I1=n16 I2=n42
XU29 AN2 $PINS O=n18 I1=n41 I2=n17
XU30 AN2 $PINS O=n19 I1=n33 I2=n10
XU31 AN2 $PINS O=n20 I1=n32 I2=n19
XU32 AN2 $PINS O=n21 I1=n31 I2=n20
XU33 AN2 $PINS O=n22 I1=n30 I2=n21
XU34 AN2 $PINS O=n23 I1=n29 I2=n22
XU35 AN2 $PINS O=n24 I1=n28 I2=n23
XU36 INV1S $PINS O=n40 I=B[12]
XU37 INV1S $PINS O=n39 I=B[13]
XU38 INV1S $PINS O=n38 I=B[14]
XU39 INV1S $PINS O=n37 I=B[15]
XU40 INV1S $PINS O=n36 I=B[16]
XU41 INV1S $PINS O=n35 I=B[17]
XU42 INV1S $PINS O=n34 I=B[18]
XU43 XOR2HS $PINS O=DIFF[10] I1=n42 I2=n16
XU44 XOR2HS $PINS O=DIFF[11] I1=n41 I2=n17
XU45 XOR2HS $PINS O=DIFF[12] I1=n40 I2=n18
XU46 XOR2HS $PINS O=DIFF[13] I1=n39 I2=n4
XU47 XOR2HS $PINS O=DIFF[14] I1=n38 I2=n5
XU48 XOR2HS $PINS O=DIFF[15] I1=n37 I2=n6
XU49 XOR2HS $PINS O=DIFF[16] I1=n36 I2=n7
XU50 XOR2HS $PINS O=DIFF[17] I1=n35 I2=n8
XU51 XOR2HS $PINS O=DIFF[18] I1=n34 I2=n9
XU52 XOR2HS $PINS O=DIFF[19] I1=n33 I2=n10
XU53 XOR2HS $PINS O=DIFF[20] I1=n32 I2=n19
XU54 XOR2HS $PINS O=DIFF[21] I1=n31 I2=n20
XU55 XOR2HS $PINS O=DIFF[22] I1=n30 I2=n21
XU56 XOR2HS $PINS O=DIFF[23] I1=n29 I2=n22
XU57 XOR2HS $PINS O=DIFF[24] I1=n28 I2=n23
XU58 XOR2HS $PINS O=DIFF[25] I1=n27 I2=n24
XU62 XOR2HS $PINS O=DIFF[6] I1=n46 I2=n12
XU64 XOR2HS $PINS O=DIFF[3] I1=n2 I2=n49
XU65 INV1S $PINS O=n45 I=B[7]
XU66 INV1S $PINS O=n44 I=B[8]
XU67 INV1S $PINS O=n43 I=B[9]
XU68 INV1S $PINS O=n42 I=B[10]
XU69 XOR2HS $PINS O=DIFF[26] I1=B[26] I2=n26
XU70 INV1S $PINS O=n41 I=B[11]
XU71 INV1S $PINS O=n33 I=B[19]
XU72 INV1S $PINS O=n32 I=B[20]
XU73 INV1S $PINS O=n31 I=B[21]
XU74 INV1S $PINS O=n30 I=B[22]
XU75 INV1S $PINS O=n29 I=B[23]
XU76 INV1S $PINS O=n28 I=B[24]
XU77 INV1S $PINS O=n27 I=B[25]
XU78 ND2 $PINS O=n26 I1=n27 I2=n24
XU1 INV1S $PINS O=n50 I=B[2]
XU7 INV1S $PINS O=n48 I=B[4]
.ENDS

.SUBCKT PE_Shift_Add_0_DW01_sub_1 A[26] A[25] A[24] A[23] A[22] A[21] A[20]
+ A[19] A[18] A[17] A[16] A[15] A[14] A[13] A[12] A[11] A[10] A[9] A[8] A[7]
+ A[6] A[5] A[4] A[3] A[2] A[1] A[0] B[26] B[25] B[24] B[23] B[22] B[21] B[20]
+ B[19] B[18] B[17] B[16] B[15] B[14] B[13] B[12] B[11] B[10] B[9] B[8] B[7]
+ B[6] B[5] B[4] B[3] B[2] B[1] B[0] CI DIFF[26] DIFF[25] DIFF[24] DIFF[23]
+ DIFF[22] DIFF[21] DIFF[20] DIFF[19] DIFF[18] DIFF[17] DIFF[16] DIFF[15]
+ DIFF[14] DIFF[13] DIFF[12] DIFF[11] DIFF[10] DIFF[9] DIFF[8] DIFF[7] DIFF[6]
+ DIFF[5] DIFF[4] DIFF[3] DIFF[2] DIFF[1] DIFF[0] CO
*.CONNECT DIFF[0] B[0]
XFE_RC_630_0 XNR2HS $PINS O=DIFF[8] I1=B[8] I2=n14
XFE_RC_346_0 AN2B1T $PINS O=n3 I1=n2 B1=B[3]
XFE_RC_194_0 XNR2HS $PINS O=DIFF[2] I1=n1 I2=B[2]
XFE_OFC672_term2_shifted_5 INV1S $PINS O=n47 I=B[5]
XFE_OFC602_term2_shifted_2 INV1S $PINS O=n50 I=B[2]
XU3 NR2 $PINS O=n1 I1=B[1] I2=B[0]
XU6 XOR2HS $PINS O=DIFF[4] I1=n3 I2=n48
XU7 INV1S $PINS O=n52 I=B[0]
XU8 INV1S $PINS O=n49 I=B[3]
XU10 INV1S $PINS O=n46 I=B[6]
XU11 XOR2HS $PINS O=DIFF[1] I1=n52 I2=n51
XU12 AN2 $PINS O=n2 I1=n50 I2=n1
XU14 AN2 $PINS O=n4 I1=n18 I2=n40
XU15 AN2 $PINS O=n5 I1=n39 I2=n4
XU16 AN2 $PINS O=n6 I1=n38 I2=n5
XU17 AN2 $PINS O=n7 I1=n37 I2=n6
XU18 AN2 $PINS O=n8 I1=n36 I2=n7
XU19 AN2 $PINS O=n9 I1=n35 I2=n8
XU20 AN2 $PINS O=n10 I1=n34 I2=n9
XU21 AN2 $PINS O=n11 I1=n48 I2=n3
XU22 AN2 $PINS O=n12 I1=n47 I2=n11
XU23 AN2 $PINS O=n13 I1=n12 I2=n46
XU24 AN2 $PINS O=n14 I1=n45 I2=n13
XU25 AN2 $PINS O=n15 I1=n44 I2=n14
XU26 AN2 $PINS O=n16 I1=n15 I2=n43
XU27 AN2 $PINS O=n17 I1=n16 I2=n42
XU28 AN2 $PINS O=n18 I1=n17 I2=n41
XU29 AN2 $PINS O=n19 I1=n33 I2=n10
XU30 AN2 $PINS O=n20 I1=n32 I2=n19
XU31 AN2 $PINS O=n21 I1=n31 I2=n20
XU32 AN2 $PINS O=n22 I1=n30 I2=n21
XU33 AN2 $PINS O=n23 I1=n29 I2=n22
XU34 AN2 $PINS O=n24 I1=n28 I2=n23
XU35 INV1S $PINS O=n40 I=B[12]
XU36 INV1S $PINS O=n39 I=B[13]
XU37 INV1S $PINS O=n38 I=B[14]
XU38 INV1S $PINS O=n37 I=B[15]
XU39 INV1S $PINS O=n36 I=B[16]
XU40 INV1S $PINS O=n35 I=B[17]
XU41 INV1S $PINS O=n34 I=B[18]
XU42 INV1S $PINS O=n45 I=B[7]
XU43 INV1S $PINS O=n44 I=B[8]
XU44 INV1S $PINS O=n43 I=B[9]
XU45 INV1S $PINS O=n42 I=B[10]
XU46 XOR2HS $PINS O=DIFF[26] I1=B[26] I2=n26
XU47 INV1S $PINS O=n41 I=B[11]
XU48 INV1S $PINS O=n33 I=B[19]
XU49 INV1S $PINS O=n32 I=B[20]
XU50 INV1S $PINS O=n31 I=B[21]
XU51 INV1S $PINS O=n30 I=B[22]
XU52 INV1S $PINS O=n29 I=B[23]
XU53 INV1S $PINS O=n28 I=B[24]
XU54 INV1S $PINS O=n27 I=B[25]
XU55 XOR2HS $PINS O=DIFF[9] I1=n43 I2=n15
XU56 XOR2HS $PINS O=DIFF[10] I1=n42 I2=n16
XU57 XOR2HS $PINS O=DIFF[11] I1=n41 I2=n17
XU58 XOR2HS $PINS O=DIFF[12] I1=n40 I2=n18
XU59 XOR2HS $PINS O=DIFF[13] I1=n39 I2=n4
XU60 XOR2HS $PINS O=DIFF[14] I1=n38 I2=n5
XU61 XOR2HS $PINS O=DIFF[15] I1=n37 I2=n6
XU62 XOR2HS $PINS O=DIFF[16] I1=n36 I2=n7
XU63 XOR2HS $PINS O=DIFF[17] I1=n35 I2=n8
XU64 XOR2HS $PINS O=DIFF[18] I1=n34 I2=n9
XU65 XOR2HS $PINS O=DIFF[19] I1=n33 I2=n10
XU66 XOR2HS $PINS O=DIFF[20] I1=n32 I2=n19
XU67 XOR2HS $PINS O=DIFF[21] I1=n31 I2=n20
XU68 XOR2HS $PINS O=DIFF[22] I1=n30 I2=n21
XU69 XOR2HS $PINS O=DIFF[23] I1=n29 I2=n22
XU70 XOR2HS $PINS O=DIFF[24] I1=n28 I2=n23
XU71 XOR2HS $PINS O=DIFF[25] I1=n27 I2=n24
XU73 XOR2HS $PINS O=DIFF[7] I1=n13 I2=n45
XU74 XOR2HS $PINS O=DIFF[6] I1=n46 I2=n12
XU75 XOR2HS $PINS O=DIFF[5] I1=n47 I2=n11
XU76 XOR2HS $PINS O=DIFF[3] I1=n2 I2=n49
XU78 ND2 $PINS O=n26 I1=n27 I2=n24
XU1 INV2 $PINS O=n51 I=B[1]
XU4 INV1S $PINS O=n48 I=B[4]
.ENDS

.SUBCKT PE_Shift_Add_0_DW01_sub_2 A[26] A[25] A[24] A[23] A[22] A[21] A[20]
+ A[19] A[18] A[17] A[16] A[15] A[14] A[13] A[12] A[11] A[10] A[9] A[8] A[7]
+ A[6] A[5] A[4] A[3] A[2] A[1] A[0] B[26] B[25] B[24] B[23] B[22] B[21] B[20]
+ B[19] B[18] B[17] B[16] B[15] B[14] B[13] B[12] B[11] B[10] B[9] B[8] B[7]
+ B[6] B[5] B[4] B[3] B[2] B[1] B[0] CI DIFF[26] DIFF[25] DIFF[24] DIFF[23]
+ DIFF[22] DIFF[21] DIFF[20] DIFF[19] DIFF[18] DIFF[17] DIFF[16] DIFF[15]
+ DIFF[14] DIFF[13] DIFF[12] DIFF[11] DIFF[10] DIFF[9] DIFF[8] DIFF[7] DIFF[6]
+ DIFF[5] DIFF[4] DIFF[3] DIFF[2] DIFF[1] DIFF[0] CO
*.CONNECT DIFF[0] B[0]
XFE_RC_629_0 AN2T $PINS O=n2 I1=n51 I2=n52
XFE_RC_581_0 XNR2HS $PINS O=DIFF[8] I1=B[8] I2=n14
XFE_RC_549_0 XNR2HS $PINS O=DIFF[7] I1=B[7] I2=n13
XFE_RC_1121_0 OR2B1S $PINS O=FE_RN_118_0 I1=B[4] B1=n3
XFE_RC_1120_0 XOR2HS $PINS O=DIFF[5] I1=B[5] I2=FE_RN_118_0
XFE_OFC619_term1_shifted_7 INV1S $PINS O=n45 I=B[7]
XFE_OFC618_term1_shifted_3 INV1S $PINS O=n49 I=B[3]
XU3 INV1S $PINS O=n52 I=B[0]
XU5 INV1S $PINS O=n46 I=B[6]
XU6 XOR2HS $PINS O=DIFF[1] I1=n52 I2=n51
XU8 INV1S $PINS O=n47 I=B[5]
XU10 AN2 $PINS O=n3 I1=n49 I2=n1
XU11 XOR2HS $PINS O=DIFF[3] I1=n1 I2=n49
XU13 XOR2HS $PINS O=DIFF[12] I1=n40 I2=n18
XU14 XOR2HS $PINS O=DIFF[13] I1=n39 I2=n4
XU15 AN2 $PINS O=n4 I1=n40 I2=n18
XU16 XOR2HS $PINS O=DIFF[14] I1=n38 I2=n5
XU17 AN2 $PINS O=n5 I1=n39 I2=n4
XU18 XOR2HS $PINS O=DIFF[15] I1=n37 I2=n6
XU19 AN2 $PINS O=n6 I1=n38 I2=n5
XU20 XOR2HS $PINS O=DIFF[16] I1=n36 I2=n7
XU21 AN2 $PINS O=n7 I1=n37 I2=n6
XU22 XOR2HS $PINS O=DIFF[17] I1=n35 I2=n8
XU23 AN2 $PINS O=n8 I1=n36 I2=n7
XU24 XOR2HS $PINS O=DIFF[18] I1=n34 I2=n9
XU25 AN2 $PINS O=n9 I1=n35 I2=n8
XU26 AN2 $PINS O=n10 I1=n34 I2=n9
XU27 XOR2HS $PINS O=DIFF[4] I1=n3 I2=n48
XU29 AN2S $PINS O=n11 I1=n48 I2=n3
XU30 XOR2HS $PINS O=DIFF[6] I1=n46 I2=n12
XU31 AN2 $PINS O=n12 I1=n47 I2=n11
XU33 AN2 $PINS O=n13 I1=n12 I2=n46
XU35 AN2 $PINS O=n14 I1=n13 I2=n45
XU36 XOR2HS $PINS O=DIFF[9] I1=n43 I2=n15
XU37 AN2 $PINS O=n15 I1=n14 I2=n44
XU38 XOR2HS $PINS O=DIFF[10] I1=n42 I2=n16
XU39 AN2 $PINS O=n16 I1=n15 I2=n43
XU40 XOR2HS $PINS O=DIFF[11] I1=n41 I2=n17
XU41 AN2 $PINS O=n17 I1=n42 I2=n16
XU42 AN2 $PINS O=n18 I1=n41 I2=n17
XU43 XOR2HS $PINS O=DIFF[19] I1=n33 I2=n10
XU44 XOR2HS $PINS O=DIFF[20] I1=n32 I2=n19
XU45 AN2 $PINS O=n19 I1=n33 I2=n10
XU46 XOR2HS $PINS O=DIFF[21] I1=n31 I2=n20
XU47 AN2 $PINS O=n20 I1=n32 I2=n19
XU48 XOR2HS $PINS O=DIFF[22] I1=n30 I2=n21
XU49 AN2 $PINS O=n21 I1=n31 I2=n20
XU50 XOR2HS $PINS O=DIFF[23] I1=n29 I2=n22
XU51 AN2 $PINS O=n22 I1=n30 I2=n21
XU52 XOR2HS $PINS O=DIFF[24] I1=n28 I2=n23
XU53 AN2 $PINS O=n23 I1=n29 I2=n22
XU54 AN2 $PINS O=n24 I1=n28 I2=n23
XU55 XOR2HS $PINS O=DIFF[25] I1=n27 I2=n24
XU56 INV1S $PINS O=n40 I=B[12]
XU57 INV1S $PINS O=n39 I=B[13]
XU58 INV1S $PINS O=n38 I=B[14]
XU59 INV1S $PINS O=n37 I=B[15]
XU60 INV1S $PINS O=n36 I=B[16]
XU61 INV1S $PINS O=n35 I=B[17]
XU62 INV1S $PINS O=n34 I=B[18]
XU63 XOR2HS $PINS O=DIFF[2] I1=n50 I2=n2
XU65 INV1S $PINS O=n44 I=B[8]
XU66 INV1S $PINS O=n43 I=B[9]
XU67 INV1S $PINS O=n42 I=B[10]
XU68 XOR2HS $PINS O=DIFF[26] I1=B[26] I2=n26
XU69 INV1S $PINS O=n41 I=B[11]
XU70 INV1S $PINS O=n33 I=B[19]
XU71 INV1S $PINS O=n32 I=B[20]
XU72 INV1S $PINS O=n31 I=B[21]
XU73 INV1S $PINS O=n30 I=B[22]
XU74 INV1S $PINS O=n29 I=B[23]
XU75 INV1S $PINS O=n28 I=B[24]
XU76 INV1S $PINS O=n27 I=B[25]
XU78 ND2 $PINS O=n26 I1=n27 I2=n24
XU1 INV1S $PINS O=n48 I=B[4]
XU2 NR2 $PINS O=n1 I1=B[2] I2=n53
XU7 INV1S $PINS O=n53 I=n2
XU9 INV2 $PINS O=n51 I=B[1]
XU79 INV2 $PINS O=n50 I=B[2]
.ENDS

.SUBCKT PE_Shift_Add_0_DW01_add_2_DW01_add_28 A[26] A[25] A[24] A[23] A[22]
+ A[21] A[20] A[19] A[18] A[17] A[16] A[15] A[14] A[13] A[12] A[11] A[10] A[9]
+ A[8] A[7] A[6] A[5] A[4] A[3] A[2] A[1] A[0] B[26] B[25] B[24] B[23] B[22]
+ B[21] B[20] B[19] B[18] B[17] B[16] B[15] B[14] B[13] B[12] B[11] B[10] B[9]
+ B[8] B[7] B[6] B[5] B[4] B[3] B[2] B[1] B[0] CI SUM[26] SUM[25] SUM[24]
+ SUM[23] SUM[22] SUM[21] SUM[20] SUM[19] SUM[18] SUM[17] SUM[16] SUM[15]
+ SUM[14] SUM[13] SUM[12] SUM[11] SUM[10] SUM[9] SUM[8] SUM[7] SUM[6] SUM[5]
+ SUM[4] SUM[3] SUM[2] SUM[1] SUM[0] CO
XFE_RC_758_0 INV2 $PINS O=SUM[12] I=FE_RN_361_0
XFE_RC_757_0 XNR3 $PINS O=FE_RN_361_0 I1=A[12] I2=B[12] I3=carry[12]
XFE_RC_702_0 INV2 $PINS O=SUM[11] I=FE_RN_338_0
XFE_RC_701_0 XNR3 $PINS O=FE_RN_338_0 I1=A[11] I2=B[11] I3=carry[11]
XFE_RC_682_0 INV2 $PINS O=SUM[6] I=FE_RN_328_0
XFE_RC_681_0 XNR3 $PINS O=FE_RN_328_0 I1=A[6] I2=B[6] I3=carry[6]
XFE_RC_672_0 INV2 $PINS O=SUM[15] I=FE_RN_323_0
XFE_RC_671_0 XNR3 $PINS O=FE_RN_323_0 I1=A[15] I2=B[15] I3=carry[15]
XFE_RC_666_0 INV2 $PINS O=SUM[17] I=FE_RN_320_0
XFE_RC_665_0 XNR3 $PINS O=FE_RN_320_0 I1=A[17] I2=B[17] I3=carry[17]
XFE_RC_655_0 INV2 $PINS O=SUM[13] I=FE_RN_315_0
XFE_RC_654_0 XNR3 $PINS O=FE_RN_315_0 I1=A[13] I2=B[13] I3=carry[13]
XFE_RC_645_0 INV2 $PINS O=SUM[19] I=FE_RN_312_1
XFE_RC_644_0 XNR3 $PINS O=FE_RN_312_1 I1=A[19] I2=B[19] I3=carry[19]
XFE_RC_508_0 XNR2HS $PINS O=SUM[26] I1=FE_RN_60_0 I2=carry[26]
XFE_RC_485_0 INV2 $PINS O=SUM[5] I=FE_RN_250_0
XFE_RC_484_0 XNR3 $PINS O=FE_RN_250_0 I1=A[5] I2=B[5] I3=carry[5]
XFE_RC_100_0 XNR2HS $PINS O=FE_RN_60_0 I1=A[26] I2=B[26]
XFE_RC_1482_0 INV2 $PINS O=SUM[4] I=FE_RN_312_0
XFE_RC_1481_0 XNR3 $PINS O=FE_RN_312_0 I1=B[4] I2=A[4] I3=carry[4]
XFE_RC_1371_0 INV2 $PINS O=SUM[1] I=FE_RN_247_0
XFE_RC_1370_0 XNR3 $PINS O=FE_RN_247_0 I1=carry[1] I2=B[1] I3=A[1]
XFE_RC_966_0 XOR3 $PINS O=SUM[21] I1=A[21] I2=B[21] I3=carry[21]
XFE_RC_965_0 MAO222 $PINS O=carry[22] A1=carry[21] B1=B[21] C1=A[21]
XFE_RC_957_0 MAO222 $PINS O=carry[5] A1=carry[4] B1=A[4] C1=B[4]
XFE_RC_956_0 XOR3 $PINS O=SUM[25] I1=A[25] I2=B[25] I3=carry[25]
XFE_RC_955_0 MAO222 $PINS O=carry[26] A1=carry[25] B1=B[25] C1=A[25]
XFE_RC_882_0 XOR3 $PINS O=SUM[7] I1=A[7] I2=B[7] I3=carry[7]
XFE_RC_881_0 MAO222 $PINS O=carry[8] A1=carry[7] B1=B[7] C1=A[7]
XFE_RC_844_0 XOR3 $PINS O=SUM[24] I1=A[24] I2=B[24] I3=carry[24]
XFE_RC_843_0 MAO222 $PINS O=carry[25] A1=carry[24] B1=B[24] C1=A[24]
XFE_RC_814_0 XOR3 $PINS O=SUM[20] I1=A[20] I2=B[20] I3=carry[20]
XFE_RC_813_0 MAO222 $PINS O=carry[21] A1=carry[20] B1=B[20] C1=A[20]
XFE_RC_738_0 XOR3 $PINS O=SUM[22] I1=A[22] I2=B[22] I3=carry[22]
XFE_RC_737_0 MAO222P $PINS O=carry[23] A1=carry[22] B1=B[22] C1=A[22]
XFE_RC_733_0 MAO222P $PINS O=carry[20] A1=carry[19] B1=B[19] C1=A[19]
XFE_RC_680_0 XOR3 $PINS O=SUM[18] I1=A[18] I2=B[18] I3=carry[18]
XFE_RC_679_0 MAO222P $PINS O=carry[19] A1=carry[18] B1=B[18] C1=A[18]
XFE_RC_619_0 MAO222P $PINS O=carry[18] A1=carry[17] B1=B[17] C1=A[17]
XFE_RC_558_0 XOR3 $PINS O=SUM[14] I1=A[14] I2=B[14] I3=carry[14]
XFE_RC_557_0 MAO222P $PINS O=carry[15] A1=carry[14] B1=B[14] C1=A[14]
XFE_RC_521_0 MAO222P $PINS O=carry[16] A1=carry[15] B1=B[15] C1=A[15]
XFE_RC_488_0 XOR3 $PINS O=SUM[16] I1=A[16] I2=B[16] I3=carry[16]
XFE_RC_487_0 MAO222P $PINS O=carry[17] A1=carry[16] B1=B[16] C1=A[16]
XFE_RC_443_0 MAO222 $PINS O=carry[2] A1=B[1] B1=A[1] C1=carry[1]
XFE_RC_437_0 MAO222 $PINS O=carry[14] A1=carry[13] B1=B[13] C1=A[13]
XFE_RC_334_0 XOR3 $PINS O=SUM[2] I1=B[2] I2=A[2] I3=carry[2]
XFE_RC_333_0 MAO222 $PINS O=carry[3] A1=carry[2] B1=B[2] C1=A[2]
XFE_RC_325_0 MAO222 $PINS O=carry[12] A1=carry[11] B1=B[11] C1=A[11]
XFE_RC_274_0 XOR3 $PINS O=SUM[3] I1=B[3] I2=A[3] I3=carry[3]
XFE_RC_273_0 MAO222 $PINS O=carry[4] A1=carry[3] B1=B[3] C1=A[3]
XFE_RC_269_0 MAO222 $PINS O=carry[13] A1=carry[12] B1=B[12] C1=A[12]
XFE_RC_218_0 MAO222 $PINS O=carry[7] A1=carry[6] B1=B[6] C1=A[6]
XFE_RC_154_0 XOR3 $PINS O=SUM[8] I1=A[8] I2=B[8] I3=carry[8]
XFE_RC_153_0 MAO222P $PINS O=carry[9] A1=carry[8] B1=B[8] C1=A[8]
XFE_RC_129_0 MAO222 $PINS O=carry[6] A1=carry[5] B1=A[5] C1=B[5]
XU7 XOR3 $PINS O=SUM[23] I1=A[23] I2=B[23] I3=carry[23]
XU8 ND2P $PINS O=n3 I1=carry[23] I2=A[23]
XU9 ND2 $PINS O=n4 I1=carry[23] I2=B[23]
XU10 ND2 $PINS O=n5 I1=A[23] I2=B[23]
XU11 ND3 $PINS O=carry[24] I1=n4 I2=n3 I3=n5
XU13 ND2 $PINS O=n14 I1=carry[10] I2=A[10]
XU14 ND2 $PINS O=n13 I1=carry[10] I2=B[10]
XU15 XOR2HS $PINS O=n8 I1=A[9] I2=B[9]
XU16 XOR2HS $PINS O=SUM[9] I1=carry[9] I2=n8
XU19 ND2 $PINS O=n11 I1=A[9] I2=B[9]
XU20 XOR2HS $PINS O=n12 I1=B[10] I2=A[10]
XU21 ND2 $PINS O=n15 I1=B[10] I2=A[10]
XU22 ND3P $PINS O=carry[11] I1=n14 I2=n13 I3=n15
XU23 XOR2HS $PINS O=SUM[0] I1=B[0] I2=A[0]
XU24 INV1S $PINS O=carry[1] I=n16
XU25 ND2 $PINS O=n16 I1=B[0] I2=A[0]
XU1 ND2P $PINS O=n10 I1=carry[9] I2=A[9]
XU2 ND2P $PINS O=n9 I1=carry[9] I2=B[9]
XU3 ND3P $PINS O=carry[10] I1=n9 I2=n10 I3=n11
XU17 XOR2HS $PINS O=SUM[10] I1=carry[10] I2=n12
.ENDS

.SUBCKT PE_Shift_Add_0_DW01_add_1_DW01_add_27 A[26] A[25] A[24] A[23] A[22]
+ A[21] A[20] A[19] A[18] A[17] A[16] A[15] A[14] A[13] A[12] A[11] A[10] A[9]
+ A[8] A[7] A[6] A[5] A[4] A[3] A[2] A[1] A[0] B[26] B[25] B[24] B[23] B[22]
+ B[21] B[20] B[19] B[18] B[17] B[16] B[15] B[14] B[13] B[12] B[11] B[10] B[9]
+ B[8] B[7] B[6] B[5] B[4] B[3] B[2] B[1] B[0] CI SUM[26] SUM[25] SUM[24]
+ SUM[23] SUM[22] SUM[21] SUM[20] SUM[19] SUM[18] SUM[17] SUM[16] SUM[15]
+ SUM[14] SUM[13] SUM[12] SUM[11] SUM[10] SUM[9] SUM[8] SUM[7] SUM[6] SUM[5]
+ SUM[4] SUM[3] SUM[2] SUM[1] SUM[0] CO
XFE_RC_768_0 INV2 $PINS O=SUM[2] I=FE_RN_366_0
XFE_RC_767_0 XNR3 $PINS O=FE_RN_366_0 I1=A[2] I2=carry[2] I3=B[2]
XFE_RC_752_0 INV1S $PINS O=SUM[8] I=FE_RN_358_0
XFE_RC_751_0 XNR3 $PINS O=FE_RN_358_0 I1=B[8] I2=A[8] I3=carry[8]
XFE_RC_696_0 INV2 $PINS O=SUM[3] I=FE_RN_335_0
XFE_RC_695_0 XNR3 $PINS O=FE_RN_335_0 I1=A[3] I2=carry[3] I3=B[3]
XFE_RC_639_0 INV1S $PINS O=SUM[1] I=FE_RN_310_0
XFE_RC_638_0 XNR3 $PINS O=FE_RN_310_0 I1=A[1] I2=n1 I3=B[1]
XFE_RC_637_0 INV2 $PINS O=SUM[9] I=FE_RN_309_0
XFE_RC_636_0 XNR3 $PINS O=FE_RN_309_0 I1=B[9] I2=A[9] I3=carry[9]
XFE_RC_461_0 XOR2HS $PINS O=SUM[26] I1=FE_RN_193_0 I2=carry[26]
XFE_RC_363_0 XOR2HS $PINS O=FE_RN_193_0 I1=A[26] I2=B[26]
XFE_RC_1520_0 XOR3 $PINS O=SUM[24] I1=A[24] I2=B[24] I3=carry[24]
XFE_RC_1519_0 MAO222 $PINS O=carry[25] A1=carry[24] B1=B[24] C1=A[24]
XFE_RC_1015_0 XOR3 $PINS O=SUM[25] I1=A[25] I2=B[25] I3=carry[25]
XFE_RC_1014_0 MAO222 $PINS O=carry[26] A1=carry[25] B1=B[25] C1=A[25]
XFE_RC_935_0 XOR3 $PINS O=SUM[20] I1=A[20] I2=B[20] I3=carry[20]
XFE_RC_934_0 MAO222P $PINS O=carry[21] A1=carry[20] B1=B[20] C1=A[20]
XFE_RC_931_0 XOR3 $PINS O=SUM[21] I1=A[21] I2=B[21] I3=carry[21]
XFE_RC_930_0 MAO222P $PINS O=carry[22] A1=carry[21] B1=B[21] C1=A[21]
XFE_RC_925_0 XOR3 $PINS O=SUM[15] I1=A[15] I2=B[15] I3=carry[15]
XFE_RC_924_0 MAO222 $PINS O=carry[16] A1=carry[15] B1=B[15] C1=A[15]
XFE_RC_874_0 XOR3 $PINS O=SUM[18] I1=A[18] I2=B[18] I3=carry[18]
XFE_RC_873_0 MAO222P $PINS O=carry[19] A1=carry[18] B1=B[18] C1=A[18]
XFE_RC_842_0 XOR3S $PINS O=SUM[19] I1=A[19] I2=B[19] I3=carry[19]
XFE_RC_841_0 MAO222P $PINS O=carry[20] A1=carry[19] B1=B[19] C1=A[19]
XFE_RC_834_0 XOR3 $PINS O=SUM[22] I1=A[22] I2=B[22] I3=carry[22]
XFE_RC_833_0 MAO222P $PINS O=carry[23] A1=carry[22] B1=B[22] C1=A[22]
XFE_RC_790_0 XOR3 $PINS O=SUM[14] I1=A[14] I2=B[14] I3=carry[14]
XFE_RC_789_0 MAO222P $PINS O=carry[15] A1=carry[14] B1=B[14] C1=A[14]
XFE_RC_764_0 XOR3 $PINS O=SUM[16] I1=A[16] I2=B[16] I3=carry[16]
XFE_RC_763_0 MAO222 $PINS O=carry[17] A1=carry[16] B1=B[16] C1=A[16]
XFE_RC_740_0 XOR3S $PINS O=SUM[17] I1=A[17] I2=B[17] I3=carry[17]
XFE_RC_739_0 MAO222P $PINS O=carry[18] A1=carry[17] B1=B[17] C1=A[17]
XFE_RC_678_0 XOR3 $PINS O=SUM[11] I1=A[11] I2=B[11] I3=carry[11]
XFE_RC_677_0 MAO222 $PINS O=carry[12] A1=carry[11] B1=B[11] C1=A[11]
XFE_RC_618_0 XOR3 $PINS O=SUM[10] I1=A[10] I2=B[10] I3=carry[10]
XFE_RC_617_0 MAO222 $PINS O=carry[11] A1=carry[10] B1=B[10] C1=A[10]
XFE_RC_570_0 XOR3 $PINS O=SUM[12] I1=A[12] I2=B[12] I3=carry[12]
XFE_RC_569_0 MAO222P $PINS O=carry[13] A1=carry[12] B1=B[12] C1=A[12]
XFE_RC_550_0 XOR3 $PINS O=SUM[5] I1=A[5] I2=B[5] I3=carry[5]
XFE_RC_549_0 MAO222 $PINS O=carry[6] A1=carry[5] B1=B[5] C1=A[5]
XFE_RC_530_0 XOR3 $PINS O=SUM[13] I1=A[13] I2=B[13] I3=carry[13]
XFE_RC_529_0 MAO222P $PINS O=carry[14] A1=carry[13] B1=B[13] C1=A[13]
XFE_RC_382_0 XOR3 $PINS O=SUM[6] I1=A[6] I2=B[6] I3=carry[6]
XFE_RC_381_0 MAO222 $PINS O=carry[7] A1=carry[6] B1=B[6] C1=A[6]
XFE_RC_379_0 MAO222 $PINS O=carry[2] A1=B[1] B1=A[1] C1=n1
XFE_RC_318_0 XOR3 $PINS O=SUM[7] I1=A[7] I2=B[7] I3=carry[7]
XFE_RC_317_0 MAO222 $PINS O=carry[8] A1=carry[7] B1=B[7] C1=A[7]
XFE_RC_301_0 MAO222 $PINS O=carry[3] A1=carry[2] B1=B[2] C1=A[2]
XFE_RC_220_0 MAO222 $PINS O=carry[4] A1=carry[3] B1=B[3] C1=A[3]
XFE_RC_150_0 XOR3 $PINS O=SUM[4] I1=A[4] I2=B[4] I3=carry[4]
XFE_RC_149_0 MAO222 $PINS O=carry[5] A1=carry[4] B1=B[4] C1=A[4]
XU1 ND3P $PINS O=carry[9] I1=n10 I2=n9 I3=n11
XU2 AN2 $PINS O=n1 I1=B[0] I2=A[0]
XU3 XOR2HS $PINS O=n2 I1=B[23] I2=A[23]
XU4 XOR2HS $PINS O=SUM[23] I1=carry[23] I2=n2
XU5 ND2 $PINS O=n3 I1=carry[23] I2=B[23]
XU6 ND2 $PINS O=n4 I1=carry[23] I2=A[23]
XU7 ND2S $PINS O=n5 I1=B[23] I2=A[23]
XU12 ND2 $PINS O=n8 I1=B[9] I2=A[9]
XU13 ND3 $PINS O=carry[10] I1=n7 I2=n6 I3=n8
XU15 ND2 $PINS O=n9 I1=carry[8] I2=B[8]
XU16 ND2 $PINS O=n10 I1=carry[8] I2=A[8]
XU17 ND2 $PINS O=n11 I1=B[8] I2=A[8]
XU18 XOR2HS $PINS O=SUM[0] I1=B[0] I2=A[0]
XU9 ND3 $PINS O=carry[24] I1=n4 I2=n3 I3=n5
XU10 ND2 $PINS O=n7 I1=carry[9] I2=A[9]
XU11 ND2 $PINS O=n6 I1=carry[9] I2=B[9]
.ENDS

.SUBCKT PE_Shift_Add_0_DW01_add_0_DW01_add_26 A[26] A[25] A[24] A[23] A[22]
+ A[21] A[20] A[19] A[18] A[17] A[16] A[15] A[14] A[13] A[12] A[11] A[10] A[9]
+ A[8] A[7] A[6] A[5] A[4] A[3] A[2] A[1] A[0] B[26] B[25] B[24] B[23] B[22]
+ B[21] B[20] B[19] B[18] B[17] B[16] B[15] B[14] B[13] B[12] B[11] B[10] B[9]
+ B[8] B[7] B[6] B[5] B[4] B[3] B[2] B[1] B[0] CI SUM[26] SUM[25] SUM[24]
+ SUM[23] SUM[22] SUM[21] SUM[20] SUM[19] SUM[18] SUM[17] SUM[16] SUM[15]
+ SUM[14] SUM[13] SUM[12] SUM[11] SUM[10] SUM[9] SUM[8] SUM[7] SUM[6] SUM[5]
+ SUM[4] SUM[3] SUM[2] SUM[1] SUM[0] CO
XFE_OCPC725_carry_5 BUF1S $PINS O=FE_OCPN725_carry_5 I=carry[5]
XFE_OCPC723_carry_4 BUF1S $PINS O=FE_OCPN723_carry_4 I=carry[4]
XFE_RC_1168_0 XNR2HS $PINS O=SUM[26] I1=FE_RN_120_0 I2=carry[26]
XFE_RC_1126_0 XNR2HS $PINS O=FE_RN_120_0 I1=B[26] I2=A[26]
XFE_RC_990_0 XOR3 $PINS O=SUM[1] I1=A[1] I2=B[1] I3=n1
XFE_RC_989_0 MAO222 $PINS O=carry[2] A1=A[1] B1=B[1] C1=n1
XFE_RC_840_0 XOR3 $PINS O=SUM[2] I1=A[2] I2=B[2] I3=carry[2]
XFE_RC_839_0 MAO222 $PINS O=carry[3] A1=A[2] B1=B[2] C1=carry[2]
XFE_RC_838_0 XOR3 $PINS O=SUM[4] I1=A[4] I2=B[4] I3=FE_OCPN723_carry_4
XFE_RC_837_0 MAO222 $PINS O=carry[5] A1=carry[4] B1=A[4] C1=B[4]
XFE_RC_788_0 XOR3 $PINS O=SUM[7] I1=A[7] I2=B[7] I3=carry[7]
XFE_RC_787_0 MAO222 $PINS O=carry[8] A1=carry[7] B1=B[7] C1=A[7]
XFE_RC_760_0 XOR3 $PINS O=SUM[8] I1=A[8] I2=B[8] I3=carry[8]
XFE_RC_759_0 MAO222 $PINS O=carry[9] A1=carry[8] B1=B[8] C1=A[8]
XFE_RC_656_0 XOR3 $PINS O=SUM[9] I1=A[9] I2=B[9] I3=carry[9]
XFE_RC_655_0 MAO222 $PINS O=carry[10] A1=carry[9] B1=B[9] C1=A[9]
XFE_RC_646_0 XOR3 $PINS O=SUM[12] I1=A[12] I2=B[12] I3=carry[12]
XFE_RC_645_0 MAO222P $PINS O=carry[13] A1=carry[12] B1=B[12] C1=A[12]
XFE_RC_592_0 XOR3 $PINS O=SUM[10] I1=A[10] I2=B[10] I3=carry[10]
XFE_RC_591_0 MAO222P $PINS O=carry[11] A1=carry[10] B1=B[10] C1=A[10]
XFE_RC_590_0 XOR3 $PINS O=SUM[13] I1=A[13] I2=B[13] I3=carry[13]
XFE_RC_589_0 MAO222P $PINS O=carry[14] A1=carry[13] B1=B[13] C1=A[13]
XFE_RC_472_0 XOR3 $PINS O=SUM[11] I1=A[11] I2=B[11] I3=carry[11]
XFE_RC_471_0 MAO222 $PINS O=carry[12] A1=carry[11] B1=B[11] C1=A[11]
XFE_RC_466_0 XOR3 $PINS O=SUM[14] I1=A[14] I2=B[14] I3=carry[14]
XFE_RC_465_0 MAO222P $PINS O=carry[15] A1=carry[14] B1=B[14] C1=A[14]
XFE_RC_404_0 XOR3 $PINS O=SUM[15] I1=A[15] I2=B[15] I3=carry[15]
XFE_RC_403_0 MAO222P $PINS O=carry[16] A1=carry[15] B1=B[15] C1=A[15]
XFE_RC_402_0 XOR3 $PINS O=SUM[25] I1=A[25] I2=B[25] I3=carry[25]
XFE_RC_401_0 MAO222 $PINS O=carry[26] A1=carry[25] B1=B[25] C1=A[25]
XFE_RC_348_0 XOR3 $PINS O=SUM[17] I1=A[17] I2=B[17] I3=carry[17]
XFE_RC_347_0 MAO222P $PINS O=carry[18] A1=carry[17] B1=B[17] C1=A[17]
XFE_RC_252_0 XOR3 $PINS O=SUM[24] I1=A[24] I2=B[24] I3=carry[24]
XFE_RC_251_0 MAO222P $PINS O=carry[25] A1=carry[24] B1=B[24] C1=A[24]
XFE_RC_250_0 XOR3 $PINS O=SUM[19] I1=A[19] I2=B[19] I3=carry[19]
XFE_RC_249_0 MAO222P $PINS O=carry[20] A1=carry[19] B1=B[19] C1=A[19]
XFE_RC_183_0 XOR3 $PINS O=SUM[21] I1=A[21] I2=B[21] I3=carry[21]
XFE_RC_182_0 MAO222 $PINS O=carry[22] A1=carry[21] B1=B[21] C1=A[21]
XFE_RC_128_0 XOR3 $PINS O=SUM[23] I1=A[23] I2=B[23] I3=carry[23]
XFE_RC_127_0 MAO222P $PINS O=carry[24] A1=carry[23] B1=B[23] C1=A[23]
XU2 ND3P $PINS O=carry[6] I1=n17 I2=n18 I3=n19
XU3 ND3 $PINS O=carry[4] I1=n14 I2=n15 I3=n16
XU4 XOR3 $PINS O=SUM[5] I1=B[5] I2=A[5] I3=FE_OCPN725_carry_5
XU5 XOR3 $PINS O=SUM[16] I1=A[16] I2=B[16] I3=carry[16]
XU6 XOR3 $PINS O=SUM[18] I1=A[18] I2=B[18] I3=carry[18]
XU7 ND3P $PINS O=carry[19] I1=n11 I2=n12 I3=n13
XU8 XOR3 $PINS O=SUM[20] I1=B[20] I2=A[20] I3=carry[20]
XU9 ND3P $PINS O=carry[23] I1=n2 I2=n3 I3=n4
XU10 AN2 $PINS O=n1 I1=B[0] I2=A[0]
XU11 XOR3 $PINS O=SUM[22] I1=B[22] I2=A[22] I3=carry[22]
XU12 ND2 $PINS O=n2 I1=carry[22] I2=B[22]
XU13 ND2 $PINS O=n3 I1=carry[22] I2=A[22]
XU14 ND2 $PINS O=n4 I1=B[22] I2=A[22]
XU15 ND2 $PINS O=n5 I1=carry[6] I2=A[6]
XU16 ND2 $PINS O=n6 I1=carry[6] I2=B[6]
XU17 ND2 $PINS O=n7 I1=A[6] I2=B[6]
XU18 ND3P $PINS O=carry[7] I1=n5 I2=n6 I3=n7
XU19 ND3 $PINS O=carry[21] I1=n20 I2=n21 I3=n22
XU20 ND2 $PINS O=n8 I1=carry[16] I2=A[16]
XU21 ND2 $PINS O=n9 I1=carry[16] I2=B[16]
XU22 ND2 $PINS O=n10 I1=A[16] I2=B[16]
XU24 ND2 $PINS O=n11 I1=carry[18] I2=A[18]
XU25 ND2P $PINS O=n12 I1=carry[18] I2=B[18]
XU26 ND2 $PINS O=n13 I1=A[18] I2=B[18]
XU27 XOR3 $PINS O=SUM[3] I1=A[3] I2=B[3] I3=carry[3]
XU28 ND2 $PINS O=n14 I1=carry[3] I2=A[3]
XU29 ND2 $PINS O=n15 I1=carry[3] I2=B[3]
XU30 ND2 $PINS O=n16 I1=A[3] I2=B[3]
XU31 ND2 $PINS O=n17 I1=carry[5] I2=B[5]
XU32 ND2 $PINS O=n18 I1=carry[5] I2=A[5]
XU33 ND2 $PINS O=n19 I1=A[5] I2=B[5]
XU34 ND2 $PINS O=n20 I1=carry[20] I2=B[20]
XU35 ND2 $PINS O=n21 I1=carry[20] I2=A[20]
XU36 ND2 $PINS O=n22 I1=A[20] I2=B[20]
XU37 XOR2HS $PINS O=SUM[0] I1=B[0] I2=A[0]
XU1 XOR3 $PINS O=SUM[6] I1=A[6] I2=B[6] I3=carry[6]
XU23 ND3P $PINS O=carry[17] I1=n9 I2=n8 I3=n10
.ENDS

.SUBCKT PE_Shift_Add_0 rst_n en clear calc_done stage_sel x_in[16] x_in[15]
+ x_in[14] x_in[13] x_in[12] x_in[11] x_in[10] x_in[9] x_in[8] x_in[7] x_in[6]
+ x_in[5] x_in[4] x_in[3] x_in[2] x_in[1] x_in[0] sign1[1] sign1[0] sign2[1]
+ sign2[0] sign3[1] sign3[0] shf1[3] shf1[2] shf1[1] shf1[0] shf2[3] shf2[2]
+ shf2[1] shf2[0] shf3[3] shf3[2] shf3[1] shf3[0] y_out[16] y_out[15] y_out[14]
+ y_out[13] y_out[12] y_out[11] y_out[10] y_out[9] y_out[8] y_out[7] y_out[6]
+ y_out[5] y_out[4] y_out[3] y_out[2] y_out[1] y_out[0] n30 i_rst_n
+ FE_OFN2_FE_DBTN15_n64 FE_OFN34_i_rst_n FE_OFN25_i_rst_n FE_OFN17_i_rst_n
+ FE_OFN187_mac_in_imag_1 FE_OFN109_mac_in_imag_6 FE_OFN102_mac_in_imag_5
+ clk_clone2 clk_clone1 clk
XFE_PHC1318_next_acc_0 DELB $PINS O=FE_PHN1318_next_acc_0 I=next_acc[0]
XFE_PHC1227_N244 DELB $PINS O=N244 I=FE_PHN1227_N244
XFE_PHC1223_N238 DELB $PINS O=N238 I=FE_PHN1223_N238
XFE_PHC1215_N245 DELB $PINS O=FE_PHN1215_N245 I=N245
XFE_PHC1214_N237 DELB $PINS O=FE_PHN1214_N237 I=N237
XFE_PHC1199_N242 DELB $PINS O=FE_PHN1199_N242 I=N242
XFE_PHC1198_N248 DELB $PINS O=FE_PHN1198_N248 I=N248
XFE_PHC1190_N239 DELB $PINS O=N239 I=FE_PHN1190_N239
XFE_PHC1189_N241 DELB $PINS O=FE_PHN1189_N241 I=N241
XFE_PHC1182_N243 DELB $PINS O=FE_PHN1182_N243 I=N243
XFE_PHC1148_acc_reg_15 DELB $PINS O=acc_reg[15] I=FE_PHN1148_acc_reg_15
XFE_PHC1137_acc_reg_19 DELB $PINS O=acc_reg[19] I=FE_PHN1137_acc_reg_19
XFE_PHC1107_acc_reg_21 DELB $PINS O=acc_reg[21] I=FE_PHN1107_acc_reg_21
XFE_PHC1073_acc_reg_24 DELB $PINS O=acc_reg[24] I=FE_PHN1073_acc_reg_24
XFE_PHC1030_acc_reg_10 DELB $PINS O=FE_PHN1030_acc_reg_10 I=acc_reg[10]
XFE_PHC1024_acc_reg_11 DELB $PINS O=FE_PHN1024_acc_reg_11 I=acc_reg[11]
XFE_PHC1009_acc_reg_14 DELB $PINS O=FE_PHN1009_acc_reg_14 I=acc_reg[14]
XFE_PHC865_acc_reg_22 DELB $PINS O=FE_PHN865_acc_reg_22 I=acc_reg[22]
XFE_PHC858_acc_reg_25 DELB $PINS O=FE_PHN858_acc_reg_25 I=acc_reg[25]
XFE_PHC827_N251 DELC $PINS O=FE_PHN827_N251 I=N251
XFE_PHC803_pe_i3_11 DELC $PINS O=y_out[11] I=FE_PHN803_pe_i3_11
XFE_PHC793_pe_i3_12 DELC $PINS O=y_out[12] I=FE_PHN793_pe_i3_12
XFE_PHC791_pe_i3_13 DELC $PINS O=y_out[13] I=FE_PHN791_pe_i3_13
XFE_PHC784_pe_i3_16 DELC $PINS O=y_out[16] I=FE_PHN784_pe_i3_16
XFE_PHC758_pe_i3_1 DELC $PINS O=y_out[1] I=FE_PHN758_pe_i3_1
XFE_PHC757_pe_i3_4 DELC $PINS O=y_out[4] I=FE_PHN757_pe_i3_4
XFE_PHC752_pe_i3_0 DELC $PINS O=y_out[0] I=FE_PHN752_pe_i3_0
XFE_PHC751_pe_i3_7 DELC $PINS O=y_out[7] I=FE_PHN751_pe_i3_7
XFE_PHC749_pe_i3_8 DELC $PINS O=y_out[8] I=FE_PHN749_pe_i3_8
XFE_PHC747_pe_i3_6 DELC $PINS O=y_out[6] I=FE_PHN747_pe_i3_6
XFE_PHC740_pe_i3_9 DELC $PINS O=y_out[9] I=FE_PHN740_pe_i3_9
XFE_PHC737_pe_i3_5 DELC $PINS O=y_out[5] I=FE_PHN737_pe_i3_5
XFE_RC_740_0 INV2CK $PINS O=FE_RN_353_0 I=sll_18/ML_int[3][5]
XFE_RC_739_0 NR2P $PINS O=term3_shifted[5] I1=FE_RN_353_0 I2=FE_RN_384_0
XFE_RC_625_0 AN2B1T $PINS O=term1_shifted[4] I1=sll_16/ML_int[3][4]
+ B1=FE_RN_282_0
XFE_RC_624_0 AO12 $PINS O=N155 A1=FE_RN_261_0 B1=N128 B2=sign3[0]
XFE_RC_618_0 AN2T $PINS O=term1_shifted[5] I1=sll_16/ML_int[3][5] I2=n79
XFE_RC_601_0 AN2B1S $PINS O=FE_RN_296_0 I1=FE_DBTN178_h33_1 B1=n125
XFE_RC_600_0 AN2T $PINS O=term3_shifted[1] I1=sll_18/ML_int[1][1]
+ I2=FE_RN_296_0
XFE_RC_563_0 AN2B1T $PINS O=term3_shifted[3] I1=sll_18/ML_int[2][3] B1=n125
XFE_RC_541_0 AN2T $PINS O=term3_shifted[7] I1=sll_18/ML_int[3][7] I2=n24
XFE_RC_520_0 AN2B1T $PINS O=term1_shifted[3] I1=sll_16/ML_int[2][3] B1=n103
XFE_RC_492_0 AO22P $PINS O=sll_16/ML_int[2][2] A1=sll_16/ML_int[1][0]
+ A2=shf1[1] B1=sll_16/ML_int[1][2] B2=FE_RN_41_0
XFE_RC_473_0 INV1S $PINS O=FE_RN_244_0 I=n53
XFE_RC_472_0 AN2B1T $PINS O=term2_shifted[4] I1=sll_17/ML_int[3][4]
+ B1=FE_RN_244_0
XFE_RC_456_0 INV2 $PINS O=sll_17/ML_int[2][2] I=FE_RN_237_0
XFE_RC_455_0 MXL2HS $PINS OB=FE_RN_237_0 S=shf2[1] A=sll_17/ML_int[1][2]
+ B=sll_17/ML_int[1][0]
XFE_RC_438_0 AN2T $PINS O=term1_shifted[7] I1=sll_16/ML_int[3][7] I2=n79
XFE_RC_349_0 AN2B1 $PINS O=term1_shifted[2] I1=sll_16/ML_int[2][2] B1=n103
XFE_RC_303_0 INV2 $PINS O=FE_RN_162_0 I=shf2[1]
XFE_RC_302_0 INV1S $PINS O=FE_RN_163_0 I=sll_17/ML_int[1][2]
XFE_RC_301_0 INV2 $PINS O=FE_RN_164_0 I=shf2[1]
XFE_RC_300_0 ND2S $PINS O=FE_RN_165_0 I1=sll_17/ML_int[1][4] I2=FE_RN_164_0
XFE_RC_299_0 OAI12HS $PINS O=sll_17/ML_int[2][4] A1=FE_RN_165_0 B1=FE_RN_163_0
+ B2=FE_RN_162_0
XFE_RC_276_0 ND2S $PINS O=FE_RN_149_0 I1=term1_in[1] I2=shf1[0]
XFE_RC_275_0 INV1S $PINS O=FE_RN_150_0 I=shf1[0]
XFE_RC_274_0 ND2 $PINS O=FE_RN_151_0 I1=term1_in[2] I2=FE_RN_150_0
XFE_RC_273_0 ND2 $PINS O=sll_16/ML_int[1][2] I1=FE_RN_151_0 I2=FE_RN_149_0
XFE_RC_220_0 OA12 $PINS O=N41 A1=N14 B1=sign1[0] B2=n88
XFE_RC_219_0 OA12 $PINS O=N96 A1=N69 B1=sign2[0] B2=FE_OFN299_s32_0
XFE_RC_127_0 INV1S $PINS O=FE_RN_73_0 I=shf1[1]
XFE_RC_126_0 INV1S $PINS O=FE_RN_74_0 I=sll_16/ML_int[1][1]
XFE_RC_125_0 INV2 $PINS O=FE_RN_75_0 I=shf1[1]
XFE_RC_124_0 ND2S $PINS O=FE_RN_76_0 I1=sll_16/ML_int[1][3] I2=FE_RN_75_0
XFE_RC_123_0 OAI12HS $PINS O=sll_16/ML_int[2][3] A1=FE_RN_76_0 B1=FE_RN_74_0
+ B2=FE_RN_73_0
XFE_RC_121_0 AN4B1S $PINS O=term2_shifted[0] I1=term2_in[0] I2=FE_OFN197_h32_1
+ I3=n40 B1=n114
XFE_RC_105_0 ND2 $PINS O=FE_RN_61_0 I1=term3_in[2] I2=shf3[0]
XFE_RC_104_0 INV2 $PINS O=FE_RN_62_0 I=shf3[0]
XFE_RC_103_0 ND2 $PINS O=FE_RN_63_0 I1=term3_in[3] I2=FE_RN_62_0
XFE_RC_102_0 ND2 $PINS O=sll_18/ML_int[1][3] I1=FE_RN_63_0 I2=FE_RN_61_0
XFE_RC_73_0 INV1S $PINS O=FE_RN_41_0 I=shf1[1]
XFE_RC_71_0 INV1S $PINS O=FE_RN_39_0 I=sign2[0]
XFE_RC_70_0 INV1S $PINS O=FE_RN_40_0 I=N70
XFE_RC_69_0 MOAI1 $PINS O=N97 A1=FE_RN_40_0 A2=FE_RN_39_0 B1=term2_shifted[1]
+ B2=FE_OFN299_s32_0
XFE_RC_53_0 AN2B1 $PINS O=term2_shifted[2] I1=sll_17/ML_int[2][2] B1=n114
XFE_RC_34_0 ND2 $PINS O=FE_RN_19_0 I1=term1_in[3] I2=shf1[0]
XFE_RC_33_0 INV1S $PINS O=FE_RN_20_0 I=shf1[0]
XFE_RC_32_0 ND2 $PINS O=FE_RN_21_0 I1=term1_in[4] I2=FE_RN_20_0
XFE_RC_31_0 ND2 $PINS O=sll_16/ML_int[1][4] I1=FE_RN_21_0 I2=FE_RN_19_0
XFE_RC_30_0 INV1S $PINS O=FE_RN_17_0 I=sign2[0]
XFE_RC_29_0 INV1S $PINS O=FE_RN_18_0 I=N72
XFE_RC_28_0 MOAI1 $PINS O=N99 A1=FE_RN_18_0 A2=FE_RN_17_0 B1=term2_shifted[3]
+ B2=FE_OFN299_s32_0
XCTS_ccl_a_INV_CLK_G1_L8_24 INV4CK $PINS O=CTS_10 I=CTS_11
XCTS_ccl_a_INV_CLK_G1_L7_24 INV2CK $PINS O=CTS_11 I=CTS_12
XFE_RC_1623_0 INV2 $PINS O=n113 I=FE_RN_390_0
XFE_RC_1622_0 INV1S $PINS O=FE_RN_391_0 I=FE_OFN197_h32_1
XFE_RC_1621_0 MUXB2 $PINS O=FE_RN_390_0 S=shf2[0] A=term2_in[1] B=term2_in[0]
+ EB=FE_RN_391_0
XFE_RC_1620_0 OR2B1S $PINS O=FE_RN_380_0 I1=n123 B1=shf3[2]
XFE_RC_1619_0 INV1S $PINS O=FE_RN_381_0 I=shf3[2]
XFE_RC_1618_0 ND2 $PINS O=FE_RN_382_0 I1=FE_RN_381_0 I2=sll_18/ML_int[2][4]
XFE_RC_1617_0 ND2 $PINS O=sll_18/ML_int[3][4] I1=FE_RN_382_0 I2=FE_RN_380_0
XFE_RC_1616_0 INV1S $PINS O=FE_RN_383_0 I=shf3[2]
XFE_RC_1615_0 INV1S $PINS O=FE_RN_384_0 I=n24
XFE_RC_1614_0 NR2 $PINS O=FE_RN_385_0 I1=FE_RN_383_0 I2=FE_RN_384_0
XFE_RC_1613_0 OR2B1S $PINS O=FE_RN_386_0 I1=n123 B1=FE_RN_385_0
XFE_RC_1611_0 NR2 $PINS O=FE_RN_388_0 I1=shf3[2] I2=FE_RN_384_0
XFE_RC_1610_0 ND2 $PINS O=FE_RN_389_0 I1=FE_RN_388_0 I2=sll_18/ML_int[2][4]
XFE_RC_1609_0 ND2S $PINS O=term3_shifted[4] I1=FE_RN_389_0 I2=FE_RN_386_0
XFE_OFC711_h32_2 INV1S $PINS O=n48 I=FE_OFN127_h32_2
XFE_OFC710_h32_2 INV1S $PINS O=FE_OFN127_h32_2 I=shf2[2]
XFE_RC_1559_0 AN3 $PINS O=FE_RN_356_0 I1=sll_16/ML_int[3][5] I2=n79 I3=n88
XFE_RC_1558_0 AO12 $PINS O=N46 A1=FE_RN_356_0 B1=N19 B2=FE_OFN122_s31_0
XFE_RC_1488_0 INV1S $PINS O=FE_RN_316_0 I=n125
XFE_RC_1487_0 AN4B1S $PINS O=term3_shifted[0] I1=FE_RN_316_0
+ I2=FE_DBTN178_h33_1 I3=term3_in[0] B1=shf3[0]
XFE_RC_1456_0 MUXB2 $PINS O=n5 S=shf3[1] A=sll_18/ML_int[1][2]
+ B=sll_18/ML_int[1][0] EB=n125
XFE_RC_1431_0 INV1S $PINS O=FE_RN_282_0 I=n79
XFE_RC_1399_0 AN3 $PINS O=FE_RN_261_0 I1=sll_18/ML_int[3][4] I2=n24 I3=n33
XFE_RC_1384_0 INV1S $PINS O=FE_RN_252_0 I=sll_18/ML_int[2][5]
XFE_RC_1383_0 MXL2HS $PINS OB=sll_18/ML_int[3][5] S=shf3[2] A=FE_RN_252_0
+ B=n124
XFE_RC_9_0 OA12 $PINS O=N151 A1=N124 B1=sign3[0] B2=n33
XFE_OFC692_s33_1 BUF1 $PINS O=FE_OFN355_s33_1 I=sign3[1]
XFE_OFC588_sll_17_ML_int_2__3 INV1S $PINS O=n115 I=sll_17/ML_int[2][3]
XFE_OFC556_sll_16_ML_int_2__3 INV1S $PINS O=n104 I=sll_16/ML_int[2][3]
XFE_OFC555_sll_18_ML_int_2__3 INV1S $PINS O=n126 I=sll_18/ML_int[2][3]
XFE_OFC554_s31_0 BUF1 $PINS O=FE_OFN122_s31_0 I=sign1[0]
XFE_OFC553_s31_0 INV1S $PINS O=n88 I=sign1[0]
XFE_OFC538_s32_0 INV1S $PINS O=FE_OFN299_s32_0 I=sign2[0]
XFE_OFC537_s32_0 INV1S $PINS O=n62 I=sign2[0]
XFE_OFC512_mac_in_imag_4 INV2 $PINS O=n146 I=x_in[4]
XFE_OFC501_mac_in_imag_0 INV2 $PINS O=n150 I=x_in[0]
XFE_OFC486_h31_0 BUF1 $PINS O=FE_OFN277_h31_0 I=shf1[0]
XFE_OFC485_n151 BUF1 $PINS O=FE_OFN276_n151 I=n151
XFE_OFC477_n88 BUF1 $PINS O=FE_OFN268_n88 I=n88
XFE_OFC472_s31_1 BUF1CK $PINS O=FE_OFN263_s31_1 I=sign1[1]
XFE_OFC406_h32_0 BUF1 $PINS O=FE_OFN214_h32_0 I=shf2[0]
XFE_OFC405_h32_0 INV1S $PINS O=n40 I=shf2[0]
XFE_OFC362_h32_1 INV1S $PINS O=FE_OFN197_h32_1 I=shf2[1]
XFE_OFC361_h32_1 BUF1 $PINS O=FE_DBTN179_h32_1 I=shf2[1]
XFE_OFC353_h31_1 BUF1 $PINS O=FE_OFN192_h31_1 I=shf1[1]
XFE_OFC352_h31_1 INV2 $PINS O=n72 I=shf1[1]
XFE_OFC292_pe_clear_d1 INV1S $PINS O=n151 I=clear
XFE_OFC224_h32_3 INV2 $PINS O=n53 I=shf2[3]
XFE_OFC206_h33_3 INV1S $PINS O=n24 I=shf3[3]
XFE_OFC197_s32_0 INV1S $PINS O=FE_OFN142_s32_0 I=FE_OFN299_s32_0
XFE_OFC166_h31_2 BUF1 $PINS O=FE_OFN129_h31_2 I=shf1[2]
XFE_OFC165_h31_2 INV1S $PINS O=n76 I=shf1[2]
XFE_OFC163_s33_0 INV1S $PINS O=FE_OFN75_s33_0 I=n33
XFE_OFC162_s33_0 INV2 $PINS O=n33 I=sign3[0]
XFE_OFC138_h31_3 INV1S $PINS O=n79 I=shf1[3]
XFE_OFC128_h33_2 BUF1 $PINS O=FE_OFN111_h33_2 I=shf3[2]
XFE_OFC127_h33_2 INV1S $PINS O=n20 I=shf3[2]
XFE_DBTC178_h33_1 INV1S $PINS O=FE_DBTN178_h33_1 I=shf3[1]
XU110 AO22 $PINS O=base_val[13] A1=acc_reg[13] A2=FE_OFN276_n151 B1=clear
+ B2=n30
XU115 AO22 $PINS O=N67 A1=FE_OFN122_s31_0 A2=N40 B1=term1_shifted[26]
+ B2=FE_OFN268_n88
XU116 AO22 $PINS O=N66 A1=N39 A2=FE_OFN122_s31_0 B1=term1_shifted[25]
+ B2=FE_OFN268_n88
XU117 AO22 $PINS O=N65 A1=N38 A2=FE_OFN122_s31_0 B1=term1_shifted[24]
+ B2=FE_OFN268_n88
XU118 AO22 $PINS O=N64 A1=N37 A2=FE_OFN122_s31_0 B1=term1_shifted[23]
+ B2=FE_OFN268_n88
XU135 AO22 $PINS O=N47 A1=FE_OFN122_s31_0 A2=N20 B1=term1_shifted[6]
+ B2=FE_OFN268_n88
XU138 AO22 $PINS O=N44 A1=N17 A2=sign1[0] B1=term1_shifted[3] B2=n88
XU139 AO22 $PINS O=N43 A1=N16 A2=sign1[0] B1=term1_shifted[2] B2=n88
XU148 AO22 $PINS O=N171 A1=N144 A2=FE_OFN75_s33_0 B1=term3_shifted[20] B2=n33
XU149 AO22 $PINS O=N170 A1=N143 A2=FE_OFN75_s33_0 B1=term3_shifted[19] B2=n33
XU150 AO22 $PINS O=N169 A1=N142 A2=FE_OFN75_s33_0 B1=term3_shifted[18] B2=n33
XU151 AO22 $PINS O=N168 A1=N141 A2=FE_OFN75_s33_0 B1=term3_shifted[17] B2=n33
XU152 AO22 $PINS O=N167 A1=N140 A2=FE_OFN75_s33_0 B1=term3_shifted[16] B2=n33
XU153 AO22 $PINS O=N166 A1=N139 A2=FE_OFN75_s33_0 B1=term3_shifted[15] B2=n33
XU154 AO22 $PINS O=N165 A1=N138 A2=FE_OFN75_s33_0 B1=term3_shifted[14] B2=n33
XU155 AO22 $PINS O=N164 A1=N137 A2=FE_OFN75_s33_0 B1=term3_shifted[13] B2=n33
XU156 AO22 $PINS O=N163 A1=N136 A2=FE_OFN75_s33_0 B1=term3_shifted[12] B2=n33
XU157 AO22 $PINS O=N162 A1=N135 A2=FE_OFN75_s33_0 B1=term3_shifted[11] B2=n33
XU160 AO22 $PINS O=N159 A1=N132 A2=FE_OFN75_s33_0 B1=term3_shifted[8] B2=n33
XU162 AO22 $PINS O=N157 A1=N130 A2=FE_OFN75_s33_0 B1=term3_shifted[6] B2=n33
XU163 AO22 $PINS O=N156 A1=N129 A2=sign3[0] B1=term3_shifted[5] B2=n33
XU165 AO22 $PINS O=N154 A1=sign3[0] A2=N127 B1=term3_shifted[3] B2=n33
XU169 AO22 $PINS O=N122 A1=N95 A2=FE_OFN142_s32_0 B1=term2_shifted[26] B2=n62
XU170 AO22 $PINS O=N121 A1=N94 A2=FE_OFN142_s32_0 B1=term2_shifted[25] B2=n62
XU171 AO22 $PINS O=N120 A1=N93 A2=FE_OFN142_s32_0 B1=term2_shifted[24] B2=n62
XU172 AO22 $PINS O=N119 A1=N92 A2=FE_OFN142_s32_0 B1=term2_shifted[23] B2=n62
XU173 AO22 $PINS O=N118 A1=N91 A2=FE_OFN142_s32_0 B1=term2_shifted[22] B2=n62
XU174 AO22 $PINS O=N117 A1=N90 A2=FE_OFN142_s32_0 B1=term2_shifted[21] B2=n62
XU175 AO22 $PINS O=N116 A1=N89 A2=FE_OFN142_s32_0 B1=term2_shifted[20] B2=n62
XU176 AO22 $PINS O=N115 A1=N88 A2=FE_OFN142_s32_0 B1=term2_shifted[19] B2=n62
XU177 AO22 $PINS O=N114 A1=N87 A2=FE_OFN142_s32_0 B1=term2_shifted[18] B2=n62
XU178 AO22 $PINS O=N113 A1=N86 A2=FE_OFN142_s32_0 B1=term2_shifted[17] B2=n62
XU179 AO22 $PINS O=N112 A1=N85 A2=FE_OFN142_s32_0 B1=term2_shifted[16] B2=n62
XU180 AO22 $PINS O=N111 A1=N84 A2=FE_OFN142_s32_0 B1=term2_shifted[15] B2=n62
XU181 AO22 $PINS O=N110 A1=N83 A2=FE_OFN142_s32_0 B1=term2_shifted[14] B2=n62
XU183 AO22 $PINS O=N108 A1=N81 A2=FE_OFN142_s32_0 B1=term2_shifted[12]
+ B2=FE_OFN299_s32_0
XU184 AO22 $PINS O=N107 A1=N80 A2=FE_OFN142_s32_0 B1=term2_shifted[11]
+ B2=FE_OFN299_s32_0
XU185 AO22 $PINS O=N106 A1=N79 A2=sign2[0] B1=term2_shifted[10]
+ B2=FE_OFN299_s32_0
XU188 AO22 $PINS O=N103 A1=N76 A2=sign2[0] B1=term2_shifted[7]
+ B2=FE_OFN299_s32_0
XU189 AO22 $PINS O=N102 A1=N75 A2=sign2[0] B1=term2_shifted[6]
+ B2=FE_OFN299_s32_0
XU190 AO22 $PINS O=N101 A1=N74 A2=sign2[0] B1=term2_shifted[5]
+ B2=FE_OFN299_s32_0
Xsll_18/M1_0_4 MUX2 $PINS O=sll_18/ML_int[1][4] S=shf3[0] A=term3_in[4]
+ B=term3_in[3]
Xsll_18/M1_0_6 MUX2 $PINS O=sll_18/ML_int[1][6] S=shf3[0] A=term3_in[6]
+ B=term3_in[5]
Xsll_18/M1_0_7 MUX2 $PINS O=sll_18/ML_int[1][7] S=shf3[0] A=term3_in[7]
+ B=term3_in[6]
Xsll_18/M1_0_9 MUX2 $PINS O=sll_18/ML_int[1][9] S=shf3[0] A=term3_in[9]
+ B=term3_in[8]
Xsll_18/M1_0_12 MUX2 $PINS O=sll_18/ML_int[1][12] S=shf3[0] A=term3_in[12]
+ B=term3_in[11]
Xsll_18/M1_1_2 MUX2 $PINS O=sll_18/ML_int[2][2] S=shf3[1] A=sll_18/ML_int[1][2]
+ B=sll_18/ML_int[1][0]
Xsll_18/M1_1_7 MUX2 $PINS O=sll_18/ML_int[2][7] S=shf3[1] A=sll_18/ML_int[1][7]
+ B=sll_18/ML_int[1][5]
Xsll_18/M1_1_8 MUX2 $PINS O=sll_18/ML_int[2][8] S=shf3[1] A=sll_18/ML_int[1][8]
+ B=sll_18/ML_int[1][6]
Xsll_18/M1_2_6 MUX2 $PINS O=sll_18/ML_int[3][6] S=shf3[2] A=sll_18/ML_int[2][6]
+ B=sll_18/ML_int[2][2]
Xsll_18/M1_2_7 MUX2 $PINS O=sll_18/ML_int[3][7] S=FE_OFN111_h33_2
+ A=sll_18/ML_int[2][7] B=sll_18/ML_int[2][3]
Xsll_18/M1_2_8 MUX2 $PINS O=sll_18/ML_int[3][8] S=FE_OFN111_h33_2
+ A=sll_18/ML_int[2][8] B=sll_18/ML_int[2][4]
Xsll_18/M1_2_9 MUX2 $PINS O=sll_18/ML_int[3][9] S=FE_OFN111_h33_2
+ A=sll_18/ML_int[2][9] B=sll_18/ML_int[2][5]
Xsll_18/M1_2_10 MUX2 $PINS O=sll_18/ML_int[3][10] S=FE_OFN111_h33_2
+ A=sll_18/ML_int[2][10] B=sll_18/ML_int[2][6]
Xsll_18/M1_2_19 MUX2 $PINS O=sll_18/ML_int[3][19] S=FE_OFN111_h33_2
+ A=term3_in[26] B=sll_18/ML_int[2][15]
Xsll_18/M1_3_8 MUX2 $PINS O=term3_shifted[8] S=FE_RN_384_0
+ A=sll_18/ML_int[3][8] B=sll_18/ML_int[3][0]
Xsll_18/M1_3_9 MUX2 $PINS O=term3_shifted[9] S=FE_RN_384_0
+ A=sll_18/ML_int[3][9] B=sll_18/ML_int[3][1]
Xsll_18/M1_3_10 MUX2 $PINS O=term3_shifted[10] S=FE_RN_384_0
+ A=sll_18/ML_int[3][10] B=sll_18/ML_int[3][2]
Xsll_18/M1_3_11 MUX2 $PINS O=term3_shifted[11] S=FE_RN_384_0
+ A=sll_18/ML_int[3][11] B=sll_18/ML_int[3][3]
Xsll_18/M1_3_12 MUX2 $PINS O=term3_shifted[12] S=FE_RN_384_0
+ A=sll_18/ML_int[3][12] B=sll_18/ML_int[3][4]
Xsll_18/M1_3_13 MUX2 $PINS O=term3_shifted[13] S=FE_RN_384_0
+ A=sll_18/ML_int[3][13] B=sll_18/ML_int[3][5]
Xsll_18/M1_3_14 MUX2 $PINS O=term3_shifted[14] S=FE_RN_384_0
+ A=sll_18/ML_int[3][14] B=sll_18/ML_int[3][6]
Xsll_18/M1_3_22 MUX2 $PINS O=term3_shifted[22] S=FE_RN_384_0
+ A=sll_18/ML_int[3][22] B=sll_18/ML_int[3][14]
Xsll_18/M1_3_23 MUX2 $PINS O=term3_shifted[23] S=FE_RN_384_0 A=term3_in[26]
+ B=sll_18/ML_int[3][15]
Xsll_17/M1_0_1 MUX2 $PINS O=sll_17/ML_int[1][1] S=shf2[0] A=term2_in[1]
+ B=term2_in[0]
Xsll_17/M1_0_4 MUX2 $PINS O=sll_17/ML_int[1][4] S=FE_OFN214_h32_0 A=term2_in[4]
+ B=term2_in[3]
Xsll_17/M1_0_6 MUX2 $PINS O=sll_17/ML_int[1][6] S=shf2[0] A=term2_in[6]
+ B=term2_in[5]
Xsll_17/M1_0_7 MUX2 $PINS O=sll_17/ML_int[1][7] S=FE_OFN214_h32_0 A=term2_in[7]
+ B=term2_in[6]
Xsll_17/M1_0_9 MUX2 $PINS O=sll_17/ML_int[1][9] S=FE_OFN214_h32_0 A=term2_in[9]
+ B=term2_in[8]
Xsll_17/M1_0_12 MUX2 $PINS O=sll_17/ML_int[1][12] S=FE_OFN214_h32_0
+ A=term2_in[12] B=term2_in[11]
Xsll_17/M1_1_3 MUX2 $PINS O=sll_17/ML_int[2][3] S=shf2[1] A=sll_17/ML_int[1][3]
+ B=sll_17/ML_int[1][1]
Xsll_17/M1_1_5 MUX2 $PINS O=sll_17/ML_int[2][5] S=shf2[1] A=sll_17/ML_int[1][5]
+ B=sll_17/ML_int[1][3]
Xsll_17/M1_1_6 MUX2 $PINS O=sll_17/ML_int[2][6] S=shf2[1] A=sll_17/ML_int[1][6]
+ B=sll_17/ML_int[1][4]
Xsll_17/M1_1_7 MUX2 $PINS O=sll_17/ML_int[2][7] S=shf2[1] A=sll_17/ML_int[1][7]
+ B=sll_17/ML_int[1][5]
Xsll_17/M1_1_8 MUX2 $PINS O=sll_17/ML_int[2][8] S=shf2[1] A=sll_17/ML_int[1][8]
+ B=sll_17/ML_int[1][6]
Xsll_17/M1_2_4 MUX2 $PINS O=sll_17/ML_int[3][4] S=n48 A=sll_17/ML_int[2][4]
+ B=n117
Xsll_17/M1_2_5 MUX2 $PINS O=sll_17/ML_int[3][5] S=n48 A=sll_17/ML_int[2][5]
+ B=n118
Xsll_17/M1_2_6 MUX2 $PINS O=sll_17/ML_int[3][6] S=n48 A=sll_17/ML_int[2][6]
+ B=sll_17/ML_int[2][2]
Xsll_17/M1_2_7 MUX2 $PINS O=sll_17/ML_int[3][7] S=n48 A=sll_17/ML_int[2][7]
+ B=sll_17/ML_int[2][3]
Xsll_17/M1_2_9 MUX2 $PINS O=sll_17/ML_int[3][9] S=n48 A=sll_17/ML_int[2][9]
+ B=sll_17/ML_int[2][5]
Xsll_17/M1_2_10 MUX2 $PINS O=sll_17/ML_int[3][10] S=n48 A=sll_17/ML_int[2][10]
+ B=sll_17/ML_int[2][6]
Xsll_17/M1_2_19 MUX2 $PINS O=sll_17/ML_int[3][19] S=n48 A=n3
+ B=sll_17/ML_int[2][15]
Xsll_17/M1_3_8 MUX2 $PINS O=term2_shifted[8] S=FE_RN_244_0
+ A=sll_17/ML_int[3][8] B=sll_17/ML_int[3][0]
Xsll_17/M1_3_9 MUX2 $PINS O=term2_shifted[9] S=FE_RN_244_0
+ A=sll_17/ML_int[3][9] B=sll_17/ML_int[3][1]
Xsll_17/M1_3_10 MUX2 $PINS O=term2_shifted[10] S=FE_RN_244_0
+ A=sll_17/ML_int[3][10] B=sll_17/ML_int[3][2]
Xsll_17/M1_3_11 MUX2 $PINS O=term2_shifted[11] S=FE_RN_244_0
+ A=sll_17/ML_int[3][11] B=sll_17/ML_int[3][3]
Xsll_17/M1_3_12 MUX2 $PINS O=term2_shifted[12] S=FE_RN_244_0
+ A=sll_17/ML_int[3][12] B=sll_17/ML_int[3][4]
Xsll_17/M1_3_13 MUX2 $PINS O=term2_shifted[13] S=FE_RN_244_0
+ A=sll_17/ML_int[3][13] B=sll_17/ML_int[3][5]
Xsll_17/M1_3_14 MUX2 $PINS O=term2_shifted[14] S=FE_RN_244_0
+ A=sll_17/ML_int[3][14] B=sll_17/ML_int[3][6]
Xsll_17/M1_3_22 MUX2 $PINS O=term2_shifted[22] S=FE_RN_244_0
+ A=sll_17/ML_int[3][22] B=sll_17/ML_int[3][14]
Xsll_17/M1_3_23 MUX2 $PINS O=term2_shifted[23] S=FE_RN_244_0 A=n3
+ B=sll_17/ML_int[3][15]
Xsll_16/M1_0_1 MUX2 $PINS O=sll_16/ML_int[1][1] S=shf1[0] A=term1_in[1]
+ B=term1_in[0]
Xsll_16/M1_0_6 MUX2 $PINS O=sll_16/ML_int[1][6] S=FE_OFN277_h31_0 A=term1_in[6]
+ B=term1_in[5]
Xsll_16/M1_0_7 MUX2 $PINS O=sll_16/ML_int[1][7] S=FE_OFN277_h31_0 A=term1_in[7]
+ B=term1_in[6]
Xsll_16/M1_0_9 MUX2 $PINS O=sll_16/ML_int[1][9] S=FE_OFN277_h31_0 A=term1_in[9]
+ B=term1_in[8]
Xsll_16/M1_0_12 MUX2 $PINS O=sll_16/ML_int[1][12] S=FE_OFN277_h31_0
+ A=term1_in[12] B=term1_in[11]
Xsll_16/M1_1_4 MUX2 $PINS O=sll_16/ML_int[2][4] S=shf1[1] A=sll_16/ML_int[1][4]
+ B=sll_16/ML_int[1][2]
Xsll_16/M1_1_5 MUX2 $PINS O=sll_16/ML_int[2][5] S=shf1[1] A=sll_16/ML_int[1][5]
+ B=sll_16/ML_int[1][3]
Xsll_16/M1_1_6 MUX2 $PINS O=sll_16/ML_int[2][6] S=shf1[1] A=sll_16/ML_int[1][6]
+ B=sll_16/ML_int[1][4]
Xsll_16/M1_1_7 MUX2 $PINS O=sll_16/ML_int[2][7] S=shf1[1] A=sll_16/ML_int[1][7]
+ B=sll_16/ML_int[1][5]
Xsll_16/M1_1_8 MUX2 $PINS O=sll_16/ML_int[2][8] S=shf1[1] A=sll_16/ML_int[1][8]
+ B=sll_16/ML_int[1][6]
Xsll_16/M1_2_4 MUX2 $PINS O=sll_16/ML_int[3][4] S=FE_OFN129_h31_2
+ A=sll_16/ML_int[2][4] B=n106
Xsll_16/M1_2_5 MUX2 $PINS O=sll_16/ML_int[3][5] S=FE_OFN129_h31_2
+ A=sll_16/ML_int[2][5] B=n107
Xsll_16/M1_2_7 MUX2 $PINS O=sll_16/ML_int[3][7] S=FE_OFN129_h31_2
+ A=sll_16/ML_int[2][7] B=sll_16/ML_int[2][3]
Xsll_16/M1_2_8 MUX2 $PINS O=sll_16/ML_int[3][8] S=FE_OFN129_h31_2
+ A=sll_16/ML_int[2][8] B=sll_16/ML_int[2][4]
Xsll_16/M1_2_9 MUX2 $PINS O=sll_16/ML_int[3][9] S=FE_OFN129_h31_2
+ A=sll_16/ML_int[2][9] B=sll_16/ML_int[2][5]
Xsll_16/M1_2_10 MUX2 $PINS O=sll_16/ML_int[3][10] S=FE_OFN129_h31_2
+ A=sll_16/ML_int[2][10] B=sll_16/ML_int[2][6]
Xsll_16/M1_2_19 MUX2 $PINS O=sll_16/ML_int[3][19] S=FE_OFN129_h31_2
+ A=term1_in[26] B=sll_16/ML_int[2][15]
Xsll_16/M1_3_8 MUX2 $PINS O=term1_shifted[8] S=FE_RN_282_0
+ A=sll_16/ML_int[3][8] B=sll_16/ML_int[3][0]
Xsll_16/M1_3_9 MUX2 $PINS O=term1_shifted[9] S=FE_RN_282_0
+ A=sll_16/ML_int[3][9] B=sll_16/ML_int[3][1]
Xsll_16/M1_3_10 MUX2 $PINS O=term1_shifted[10] S=FE_RN_282_0
+ A=sll_16/ML_int[3][10] B=sll_16/ML_int[3][2]
Xsll_16/M1_3_11 MUX2 $PINS O=term1_shifted[11] S=FE_RN_282_0
+ A=sll_16/ML_int[3][11] B=sll_16/ML_int[3][3]
Xsll_16/M1_3_12 MUX2 $PINS O=term1_shifted[12] S=FE_RN_282_0
+ A=sll_16/ML_int[3][12] B=sll_16/ML_int[3][4]
Xsll_16/M1_3_13 MUX2 $PINS O=term1_shifted[13] S=FE_RN_282_0
+ A=sll_16/ML_int[3][13] B=sll_16/ML_int[3][5]
Xsll_16/M1_3_14 MUX2 $PINS O=term1_shifted[14] S=FE_RN_282_0
+ A=sll_16/ML_int[3][14] B=sll_16/ML_int[3][6]
Xsll_16/M1_3_22 MUX2 $PINS O=term1_shifted[22] S=FE_RN_282_0
+ A=sll_16/ML_int[3][22] B=sll_16/ML_int[3][14]
Xsll_16/M1_3_23 MUX2 $PINS O=term1_shifted[23] S=FE_RN_282_0 A=term1_in[26]
+ B=sll_16/ML_int[3][15]
Xacc_reg_reg[26] QDFFRBP $PINS Q=N251 D=next_acc[26] CK=clk_clone1
+ RB=FE_OFN34_i_rst_n
Xacc_reg_reg[25] QDFFRBN $PINS Q=acc_reg[25] D=next_acc[25] CK=clk_clone1
+ RB=FE_OFN34_i_rst_n
Xacc_reg_reg[24] QDFFRBN $PINS Q=FE_PHN1073_acc_reg_24 D=next_acc[24]
+ CK=clk_clone1 RB=FE_OFN34_i_rst_n
Xacc_reg_reg[23] QDFFRBN $PINS Q=acc_reg[23] D=next_acc[23] CK=clk_clone1
+ RB=FE_OFN34_i_rst_n
Xacc_reg_reg[22] QDFFRBN $PINS Q=acc_reg[22] D=next_acc[22] CK=clk_clone1
+ RB=FE_OFN34_i_rst_n
Xacc_reg_reg[21] QDFFRBN $PINS Q=FE_PHN1107_acc_reg_21 D=next_acc[21]
+ CK=clk_clone1 RB=FE_OFN34_i_rst_n
Xacc_reg_reg[20] QDFFRBN $PINS Q=acc_reg[20] D=next_acc[20] CK=clk_clone1
+ RB=FE_OFN34_i_rst_n
Xacc_reg_reg[19] QDFFRBN $PINS Q=FE_PHN1137_acc_reg_19 D=next_acc[19]
+ CK=clk_clone1 RB=FE_OFN34_i_rst_n
Xacc_reg_reg[18] QDFFRBN $PINS Q=acc_reg[18] D=next_acc[18] CK=clk_clone1
+ RB=FE_OFN25_i_rst_n
Xacc_reg_reg[17] QDFFRBN $PINS Q=acc_reg[17] D=next_acc[17] CK=clk_clone1
+ RB=FE_OFN25_i_rst_n
Xacc_reg_reg[16] QDFFRBN $PINS Q=acc_reg[16] D=next_acc[16] CK=clk_clone1
+ RB=FE_OFN25_i_rst_n
Xacc_reg_reg[15] QDFFRBN $PINS Q=FE_PHN1148_acc_reg_15 D=next_acc[15]
+ CK=clk_clone1 RB=FE_OFN25_i_rst_n
Xacc_reg_reg[14] QDFFRBN $PINS Q=acc_reg[14] D=next_acc[14] CK=clk_clone1
+ RB=FE_OFN25_i_rst_n
Xacc_reg_reg[13] QDFFRBN $PINS Q=acc_reg[13] D=next_acc[13] CK=clk_clone1
+ RB=FE_OFN25_i_rst_n
Xacc_reg_reg[12] QDFFRBN $PINS Q=acc_reg[12] D=next_acc[12] CK=clk_clone1
+ RB=FE_OFN25_i_rst_n
Xacc_reg_reg[11] QDFFRBN $PINS Q=acc_reg[11] D=next_acc[11] CK=clk_clone1
+ RB=FE_OFN25_i_rst_n
Xacc_reg_reg[10] QDFFRBN $PINS Q=acc_reg[10] D=next_acc[10] CK=clk_clone1
+ RB=FE_OFN25_i_rst_n
Xacc_reg_reg[9] QDFFRBN $PINS Q=acc_reg[9] D=next_acc[9] CK=clk_clone1
+ RB=FE_OFN25_i_rst_n
Xacc_reg_reg[8] QDFFRBN $PINS Q=acc_reg[8] D=next_acc[8] CK=clk_clone1
+ RB=FE_OFN25_i_rst_n
Xacc_reg_reg[7] QDFFRBN $PINS Q=acc_reg[7] D=next_acc[7] CK=clk_clone1
+ RB=FE_OFN25_i_rst_n
Xacc_reg_reg[6] QDFFRBN $PINS Q=acc_reg[6] D=next_acc[6] CK=clk_clone1
+ RB=FE_OFN25_i_rst_n
Xacc_reg_reg[5] QDFFRBN $PINS Q=acc_reg[5] D=next_acc[5] CK=clk
+ RB=FE_OFN17_i_rst_n
Xacc_reg_reg[4] QDFFRBN $PINS Q=acc_reg[4] D=next_acc[4] CK=clk
+ RB=FE_OFN17_i_rst_n
Xacc_reg_reg[3] QDFFRBN $PINS Q=acc_reg[3] D=next_acc[3] CK=clk
+ RB=FE_OFN17_i_rst_n
Xacc_reg_reg[2] QDFFRBN $PINS Q=acc_reg[2] D=next_acc[2] CK=clk_clone1
+ RB=FE_OFN25_i_rst_n
Xacc_reg_reg[0] QDFFRBN $PINS Q=acc_reg[0] D=FE_PHN1318_next_acc_0
+ CK=clk_clone1 RB=FE_OFN25_i_rst_n
Xacc_reg_reg[1] QDFFRBN $PINS Q=acc_reg[1] D=next_acc[1] CK=clk_clone1
+ RB=FE_OFN25_i_rst_n
Xy_out_reg[16] QDFFRBN $PINS Q=FE_PHN784_pe_i3_16 D=FE_PHN827_N251 CK=CTS_10
+ RB=FE_OFN34_i_rst_n
Xy_out_reg[15] QDFFRBN $PINS Q=y_out[15] D=N250 CK=CTS_10 RB=FE_OFN34_i_rst_n
Xy_out_reg[14] QDFFRBN $PINS Q=y_out[14] D=N249 CK=CTS_10 RB=FE_OFN34_i_rst_n
Xy_out_reg[13] QDFFRBN $PINS Q=FE_PHN791_pe_i3_13 D=FE_PHN1198_N248 CK=CTS_10
+ RB=FE_OFN34_i_rst_n
Xy_out_reg[12] QDFFRBN $PINS Q=FE_PHN793_pe_i3_12 D=N247 CK=CTS_10
+ RB=FE_OFN34_i_rst_n
Xy_out_reg[11] QDFFRBN $PINS Q=FE_PHN803_pe_i3_11 D=N246 CK=CTS_10
+ RB=FE_OFN34_i_rst_n
Xy_out_reg[10] QDFFRBN $PINS Q=y_out[10] D=FE_PHN1215_N245 CK=CTS_10
+ RB=FE_OFN34_i_rst_n
Xy_out_reg[9] QDFFRBN $PINS Q=FE_PHN740_pe_i3_9 D=N244 CK=CTS_10
+ RB=FE_OFN34_i_rst_n
Xy_out_reg[8] QDFFRBN $PINS Q=FE_PHN749_pe_i3_8 D=FE_PHN1182_N243 CK=CTS_10
+ RB=FE_OFN34_i_rst_n
Xy_out_reg[7] QDFFRBN $PINS Q=FE_PHN751_pe_i3_7 D=FE_PHN1199_N242 CK=CTS_10
+ RB=FE_OFN34_i_rst_n
Xy_out_reg[6] QDFFRBN $PINS Q=FE_PHN747_pe_i3_6 D=FE_PHN1189_N241 CK=CTS_10
+ RB=FE_OFN25_i_rst_n
Xy_out_reg[5] QDFFRBN $PINS Q=FE_PHN737_pe_i3_5 D=N240 CK=CTS_10
+ RB=FE_OFN34_i_rst_n
Xy_out_reg[4] QDFFRBN $PINS Q=FE_PHN757_pe_i3_4 D=N239 CK=CTS_10
+ RB=FE_OFN25_i_rst_n
Xy_out_reg[3] QDFFRBN $PINS Q=y_out[3] D=N238 CK=CTS_10 RB=FE_OFN25_i_rst_n
Xy_out_reg[2] QDFFRBN $PINS Q=y_out[2] D=FE_PHN1214_N237 CK=CTS_10
+ RB=FE_OFN25_i_rst_n
Xy_out_reg[1] QDFFRBN $PINS Q=FE_PHN758_pe_i3_1 D=N236 CK=CTS_10 RB=i_rst_n
Xy_out_reg[0] QDFFRBN $PINS Q=FE_PHN752_pe_i3_0 D=N235 CK=CTS_10
+ RB=FE_OFN34_i_rst_n
XU8 MUX2 $PINS O=sll_18/ML_int[2][4] S=shf3[1] A=sll_18/ML_int[1][4]
+ B=sll_18/ML_int[1][2]
XU9 MUX2 $PINS O=sll_18/ML_int[1][2] S=shf3[0] A=term3_in[2] B=term3_in[1]
XU11 AO22 $PINS O=N152 A1=N125 A2=sign3[0] B1=term3_shifted[1] B2=n33
XU13 INV1S $PINS O=n116 I=sll_17/ML_int[2][2]
XU15 MUX2 $PINS O=sll_18/ML_int[2][5] S=shf3[1] A=sll_18/ML_int[1][5]
+ B=sll_18/ML_int[1][3]
XU18 ND2 $PINS O=n124 I1=sll_18/ML_int[1][1] I2=FE_DBTN178_h33_1
XU20 INV1S $PINS O=n127 I=sll_18/ML_int[2][2]
XU24 MUX2 $PINS O=sll_18/ML_int[1][1] S=shf3[0] A=term3_in[1] B=term3_in[0]
XU29 MUX2 $PINS O=N247 S=n30 A=FE_PHN865_acc_reg_22 B=FE_PHN827_N251
XU30 MUX2 $PINS O=N248 S=n30 A=acc_reg[23] B=FE_PHN827_N251
XU31 NR2 $PINS O=term1_shifted[0] I1=n103 I2=n101
XU32 ND3 $PINS O=n112 I1=FE_OFN197_h32_1 I2=term2_in[0] I3=n40
XU33 MUX2 $PINS O=N249 S=FE_OFN2_FE_DBTN15_n64 A=acc_reg[24] B=FE_PHN827_N251
XU34 ND3 $PINS O=n123 I1=FE_DBTN178_h33_1 I2=term3_in[0] I3=n11
XU35 ND3 $PINS O=n101 I1=term1_in[0] I2=n72 I3=n68
XU36 MUX2 $PINS O=N250 S=n30 A=FE_PHN858_acc_reg_25 B=FE_PHN827_N251
XU37 AO22 $PINS O=N177 A1=FE_OFN75_s33_0 A2=N150 B1=term3_shifted[26] B2=n33
XU38 AO22S $PINS O=N176 A1=N149 A2=FE_OFN75_s33_0 B1=term3_shifted[25] B2=n33
XU39 AO22S $PINS O=N175 A1=N148 A2=FE_OFN75_s33_0 B1=term3_shifted[24] B2=n33
XU40 AO22 $PINS O=N174 A1=N147 A2=FE_OFN75_s33_0 B1=term3_shifted[23] B2=n33
XU41 AO22S $PINS O=N173 A1=N146 A2=FE_OFN75_s33_0 B1=term3_shifted[22] B2=n33
XU42 AO22S $PINS O=N172 A1=N145 A2=FE_OFN75_s33_0 B1=term3_shifted[21] B2=n33
XU44 MUX2 $PINS O=sll_16/ML_int[1][3] S=shf1[0] A=term1_in[3] B=term1_in[2]
XU46 MUX2 $PINS O=sll_17/ML_int[1][2] S=shf2[0] A=term2_in[2] B=term2_in[1]
XU48 MUX2 $PINS O=sll_18/ML_int[2][3] S=shf3[1] A=sll_18/ML_int[1][3]
+ B=sll_18/ML_int[1][1]
XU49 MUX2 $PINS O=sll_18/ML_int[2][6] S=shf3[1] A=sll_18/ML_int[1][6]
+ B=sll_18/ML_int[1][4]
XU54 AO22 $PINS O=N100 A1=N73 A2=sign2[0] B1=term2_shifted[4]
+ B2=FE_OFN299_s32_0
XU56 NR2 $PINS O=term2_in[0] I1=sign2[1] I2=n150
XU57 AO22 $PINS O=N158 A1=N131 A2=FE_OFN75_s33_0 B1=term3_shifted[7] B2=n33
XU60 AO22 $PINS O=N42 A1=N15 A2=sign1[0] B1=term1_shifted[1] B2=n88
XU61 AO22 $PINS O=N45 A1=sign1[0] A2=N18 B1=term1_shifted[4] B2=n88
XU63 MUX2 $PINS O=sll_17/ML_int[1][3] S=shf2[0] A=term2_in[3] B=term2_in[2]
XU69 MUX2 $PINS O=sll_18/ML_int[1][5] S=shf3[0] A=term3_in[5] B=term3_in[4]
XU71 MUX2 $PINS O=sll_16/ML_int[1][5] S=shf1[0] A=term1_in[5] B=term1_in[4]
XU73 AO22 $PINS O=N98 A1=N71 A2=sign2[0] B1=term2_shifted[2] B2=FE_OFN299_s32_0
XU74 AO22 $PINS O=N54 A1=N27 A2=FE_OFN122_s31_0 B1=term1_shifted[13]
+ B2=FE_OFN268_n88
XU75 AO22 $PINS O=N60 A1=N33 A2=FE_OFN122_s31_0 B1=term1_shifted[19]
+ B2=FE_OFN268_n88
XU78 AO22 $PINS O=N50 A1=N23 A2=FE_OFN122_s31_0 B1=term1_shifted[9]
+ B2=FE_OFN268_n88
XU79 AO22 $PINS O=N160 A1=N133 A2=FE_OFN75_s33_0 B1=term3_shifted[9] B2=n33
XU80 AO22 $PINS O=N52 A1=N25 A2=FE_OFN122_s31_0 B1=term1_shifted[11]
+ B2=FE_OFN268_n88
XU81 AO22 $PINS O=N55 A1=N28 A2=FE_OFN122_s31_0 B1=term1_shifted[14]
+ B2=FE_OFN268_n88
XU82 AO22 $PINS O=N59 A1=N32 A2=FE_OFN122_s31_0 B1=term1_shifted[18]
+ B2=FE_OFN268_n88
XU86 AN2S $PINS O=sll_17/ML_int[1][0] I1=term2_in[0] I2=n40
XU87 AN2 $PINS O=sll_18/ML_int[1][0] I1=term3_in[0] I2=n11
XU96 AO22 $PINS O=N51 A1=N24 A2=FE_OFN122_s31_0 B1=term1_shifted[10]
+ B2=FE_OFN268_n88
XU97 AO22 $PINS O=N161 A1=N134 A2=FE_OFN75_s33_0 B1=term3_shifted[10] B2=n33
XU98 AO22 $PINS O=N53 A1=N26 A2=FE_OFN122_s31_0 B1=term1_shifted[12]
+ B2=FE_OFN268_n88
XU99 AO22 $PINS O=N109 A1=N82 A2=FE_OFN142_s32_0 B1=term2_shifted[13] B2=n62
XU100 AO22 $PINS O=N56 A1=N29 A2=FE_OFN122_s31_0 B1=term1_shifted[15]
+ B2=FE_OFN268_n88
XU104 MUX2 $PINS O=sll_17/ML_int[3][8] S=n48 A=sll_17/ML_int[2][8]
+ B=sll_17/ML_int[2][4]
XU106 AO22 $PINS O=N62 A1=N35 A2=FE_OFN122_s31_0 B1=term1_shifted[21]
+ B2=FE_OFN268_n88
XU107 INV1S $PINS O=n117 I=n112
XU108 MUX2 $PINS O=sll_17/ML_int[1][5] S=FE_OFN214_h32_0 A=term2_in[5]
+ B=term2_in[4]
XU113 AO22 $PINS O=N63 A1=N36 A2=FE_OFN122_s31_0 B1=term1_shifted[22]
+ B2=FE_OFN268_n88
XU119 NR2 $PINS O=term3_in[0] I1=sign3[1] I2=n150
XU120 AO22 $PINS O=N58 A1=N31 A2=FE_OFN122_s31_0 B1=term1_shifted[17]
+ B2=FE_OFN268_n88
XU121 AO22 $PINS O=N57 A1=N30 A2=FE_OFN122_s31_0 B1=term1_shifted[16]
+ B2=FE_OFN268_n88
XU123 AO22 $PINS O=N105 A1=N78 A2=sign2[0] B1=term2_shifted[9]
+ B2=FE_OFN299_s32_0
XU124 AO22 $PINS O=N104 A1=N77 A2=sign2[0] B1=term2_shifted[8]
+ B2=FE_OFN299_s32_0
XU126 MUX2S $PINS O=n111 S=FE_OFN277_h31_0 A=term1_in[26] B=term1_in[15]
XU127 MUX2S $PINS O=n110 S=n72 A=n111 B=term1_in[26]
XU128 NR2 $PINS O=n3 I1=n140 I2=sign2[1]
XU129 MUX2S $PINS O=n121 S=FE_OFN197_h32_1 A=n122 B=term2_in[26]
XU131 MUX2S $PINS O=n133 S=shf3[0] A=term3_in[26] B=term3_in[15]
XU133 AO22 $PINS O=N48 A1=FE_OFN122_s31_0 A2=N21 B1=term1_shifted[7]
+ B2=FE_OFN268_n88
XU134 AO22 $PINS O=N49 A1=N22 A2=FE_OFN122_s31_0 B1=term1_shifted[8]
+ B2=FE_OFN268_n88
XU136 AO22S $PINS O=N61 A1=N34 A2=FE_OFN122_s31_0 B1=term1_shifted[20]
+ B2=FE_OFN268_n88
XU144 NR2 $PINS O=term3_shifted[2] I1=n125 I2=n127
XU145 MUX2S $PINS O=sll_16/ML_int[2][9] S=shf1[1] A=sll_16/ML_int[1][9]
+ B=sll_16/ML_int[1][7]
XU146 MUX2S $PINS O=sll_17/ML_int[2][9] S=FE_DBTN179_h32_1
+ A=sll_17/ML_int[1][9] B=sll_17/ML_int[1][7]
XU147 MUX2S $PINS O=sll_18/ML_int[2][9] S=shf3[1] A=sll_18/ML_int[1][9]
+ B=sll_18/ML_int[1][7]
XU158 MUX2 $PINS O=sll_16/ML_int[1][8] S=FE_OFN277_h31_0 A=term1_in[8]
+ B=term1_in[7]
XU159 MUX2 $PINS O=sll_17/ML_int[1][8] S=FE_OFN214_h32_0 A=term2_in[8]
+ B=term2_in[7]
XU161 MUX2 $PINS O=sll_18/ML_int[1][8] S=shf3[0] A=term3_in[8] B=term3_in[7]
XU164 MUX2S $PINS O=sll_16/ML_int[2][10] S=FE_OFN192_h31_1
+ A=sll_16/ML_int[1][10] B=sll_16/ML_int[1][8]
XU166 MUX2S $PINS O=sll_16/ML_int[1][10] S=FE_OFN277_h31_0 A=term1_in[10]
+ B=term1_in[9]
XU167 MUX2S $PINS O=sll_18/ML_int[2][10] S=shf3[1] A=sll_18/ML_int[1][10]
+ B=sll_18/ML_int[1][8]
XU168 MUX2S $PINS O=sll_18/ML_int[1][10] S=shf3[0] A=term3_in[10] B=term3_in[9]
XU182 MUX2S $PINS O=sll_17/ML_int[2][10] S=FE_DBTN179_h32_1
+ A=sll_17/ML_int[1][10] B=sll_17/ML_int[1][8]
XU186 MUX2S $PINS O=sll_17/ML_int[1][10] S=FE_OFN214_h32_0 A=term2_in[10]
+ B=term2_in[9]
XU187 MUX2S $PINS O=sll_16/ML_int[2][11] S=FE_OFN192_h31_1
+ A=sll_16/ML_int[1][11] B=sll_16/ML_int[1][9]
XU191 MUX2S $PINS O=sll_16/ML_int[3][11] S=FE_OFN129_h31_2
+ A=sll_16/ML_int[2][11] B=sll_16/ML_int[2][7]
XU192 MUX2S $PINS O=sll_18/ML_int[2][11] S=shf3[1] A=sll_18/ML_int[1][11]
+ B=sll_18/ML_int[1][9]
XU193 MUX2S $PINS O=sll_18/ML_int[3][11] S=FE_OFN111_h33_2
+ A=sll_18/ML_int[2][11] B=sll_18/ML_int[2][7]
XU194 MUX2S $PINS O=sll_17/ML_int[2][11] S=FE_DBTN179_h32_1
+ A=sll_17/ML_int[1][11] B=sll_17/ML_int[1][9]
XU195 MUX2S $PINS O=sll_17/ML_int[3][11] S=n48 A=sll_17/ML_int[2][11]
+ B=sll_17/ML_int[2][7]
XU196 MUX2S $PINS O=sll_16/ML_int[2][12] S=FE_OFN192_h31_1
+ A=sll_16/ML_int[1][12] B=sll_16/ML_int[1][10]
XU197 MUX2S $PINS O=sll_16/ML_int[3][12] S=FE_OFN129_h31_2
+ A=sll_16/ML_int[2][12] B=sll_16/ML_int[2][8]
XU198 MUX2S $PINS O=sll_18/ML_int[2][12] S=shf3[1] A=sll_18/ML_int[1][12]
+ B=sll_18/ML_int[1][10]
XU199 MUX2S $PINS O=sll_18/ML_int[3][12] S=FE_OFN111_h33_2
+ A=sll_18/ML_int[2][12] B=sll_18/ML_int[2][8]
XU200 MUX2S $PINS O=sll_17/ML_int[2][12] S=shf2[1] A=sll_17/ML_int[1][12]
+ B=sll_17/ML_int[1][10]
XU201 MUX2S $PINS O=sll_17/ML_int[3][12] S=n48 A=sll_17/ML_int[2][12]
+ B=sll_17/ML_int[2][8]
XU202 MUX2S $PINS O=sll_16/ML_int[1][11] S=FE_OFN277_h31_0 A=term1_in[11]
+ B=term1_in[10]
XU203 MUX2S $PINS O=sll_18/ML_int[1][11] S=shf3[0] A=term3_in[11]
+ B=term3_in[10]
XU204 MUX2S $PINS O=sll_17/ML_int[1][11] S=FE_OFN214_h32_0 A=term2_in[11]
+ B=term2_in[10]
XU205 MUX2S $PINS O=sll_16/ML_int[3][13] S=FE_OFN129_h31_2
+ A=sll_16/ML_int[2][13] B=sll_16/ML_int[2][9]
XU206 MUX2S $PINS O=sll_16/ML_int[2][13] S=FE_OFN192_h31_1
+ A=sll_16/ML_int[1][13] B=sll_16/ML_int[1][11]
XU207 MUX2S $PINS O=sll_16/ML_int[1][13] S=FE_OFN277_h31_0 A=term1_in[13]
+ B=term1_in[12]
XU208 MUX2S $PINS O=sll_18/ML_int[3][13] S=FE_OFN111_h33_2
+ A=sll_18/ML_int[2][13] B=sll_18/ML_int[2][9]
XU209 MUX2S $PINS O=sll_18/ML_int[2][13] S=shf3[1] A=sll_18/ML_int[1][13]
+ B=sll_18/ML_int[1][11]
XU210 MUX2S $PINS O=sll_18/ML_int[1][13] S=shf3[0] A=term3_in[13]
+ B=term3_in[12]
XU211 MUX2S $PINS O=sll_17/ML_int[3][13] S=n48 A=sll_17/ML_int[2][13]
+ B=sll_17/ML_int[2][9]
XU212 MUX2S $PINS O=sll_17/ML_int[2][13] S=FE_DBTN179_h32_1
+ A=sll_17/ML_int[1][13] B=sll_17/ML_int[1][11]
XU213 MUX2S $PINS O=sll_17/ML_int[1][13] S=FE_OFN214_h32_0 A=term2_in[13]
+ B=term2_in[12]
XU214 MUX2S $PINS O=sll_16/ML_int[3][14] S=FE_OFN129_h31_2
+ A=sll_16/ML_int[2][14] B=sll_16/ML_int[2][10]
XU215 MUX2S $PINS O=sll_16/ML_int[2][14] S=FE_OFN192_h31_1
+ A=sll_16/ML_int[1][14] B=sll_16/ML_int[1][12]
XU216 MUX2S $PINS O=sll_16/ML_int[1][14] S=FE_OFN277_h31_0 A=term1_in[14]
+ B=term1_in[13]
XU217 MUX2S $PINS O=sll_18/ML_int[3][14] S=FE_OFN111_h33_2
+ A=sll_18/ML_int[2][14] B=sll_18/ML_int[2][10]
XU218 MUX2S $PINS O=sll_18/ML_int[2][14] S=shf3[1] A=sll_18/ML_int[1][14]
+ B=sll_18/ML_int[1][12]
XU219 MUX2S $PINS O=sll_18/ML_int[1][14] S=shf3[0] A=term3_in[14]
+ B=term3_in[13]
XU220 MUX2S $PINS O=sll_17/ML_int[3][14] S=n48 A=sll_17/ML_int[2][14]
+ B=sll_17/ML_int[2][10]
XU221 MUX2S $PINS O=sll_17/ML_int[2][14] S=shf2[1] A=sll_17/ML_int[1][14]
+ B=sll_17/ML_int[1][12]
XU222 MUX2S $PINS O=sll_17/ML_int[1][14] S=FE_OFN214_h32_0 A=term2_in[14]
+ B=term2_in[13]
XU223 MUX2S $PINS O=term1_shifted[15] S=FE_RN_282_0 A=sll_16/ML_int[3][15]
+ B=sll_16/ML_int[3][7]
XU224 MUX2S $PINS O=sll_16/ML_int[3][15] S=FE_OFN129_h31_2
+ A=sll_16/ML_int[2][15] B=sll_16/ML_int[2][11]
XU225 MUX2S $PINS O=sll_16/ML_int[2][15] S=FE_OFN192_h31_1
+ A=sll_16/ML_int[1][15] B=sll_16/ML_int[1][13]
XU226 MUX2S $PINS O=sll_16/ML_int[1][15] S=FE_OFN277_h31_0 A=term1_in[15]
+ B=term1_in[14]
XU227 MUX2S $PINS O=term3_shifted[15] S=FE_RN_384_0 A=sll_18/ML_int[3][15]
+ B=sll_18/ML_int[3][7]
XU228 MUX2S $PINS O=sll_18/ML_int[3][15] S=FE_OFN111_h33_2
+ A=sll_18/ML_int[2][15] B=sll_18/ML_int[2][11]
XU229 MUX2S $PINS O=sll_18/ML_int[2][15] S=shf3[1] A=sll_18/ML_int[1][15]
+ B=sll_18/ML_int[1][13]
XU230 MUX2S $PINS O=sll_18/ML_int[1][15] S=shf3[0] A=term3_in[15]
+ B=term3_in[14]
XU231 MUX2S $PINS O=term2_shifted[15] S=FE_RN_244_0 A=sll_17/ML_int[3][15]
+ B=sll_17/ML_int[3][7]
XU232 MUX2S $PINS O=sll_17/ML_int[3][15] S=n48 A=sll_17/ML_int[2][15]
+ B=sll_17/ML_int[2][11]
XU233 MUX2S $PINS O=sll_17/ML_int[2][15] S=FE_DBTN179_h32_1
+ A=sll_17/ML_int[1][15] B=sll_17/ML_int[1][13]
XU234 MUX2S $PINS O=term1_shifted[16] S=FE_RN_282_0 A=sll_16/ML_int[3][16]
+ B=sll_16/ML_int[3][8]
XU235 MUX2S $PINS O=n108 S=FE_OFN192_h31_1 A=n111 B=sll_16/ML_int[1][14]
XU236 MUX2S $PINS O=sll_17/ML_int[1][15] S=FE_OFN214_h32_0 A=term2_in[15]
+ B=term2_in[14]
XU237 MUX2S $PINS O=term3_shifted[16] S=FE_RN_384_0 A=sll_18/ML_int[3][16]
+ B=sll_18/ML_int[3][8]
XU238 MUX2S $PINS O=term2_shifted[16] S=FE_RN_244_0 A=sll_17/ML_int[3][16]
+ B=sll_17/ML_int[3][8]
XU239 MUX2S $PINS O=n119 S=shf2[1] A=n122 B=sll_17/ML_int[1][14]
XU240 MUX2S $PINS O=term1_shifted[17] S=FE_RN_282_0 A=sll_16/ML_int[3][17]
+ B=sll_16/ML_int[3][9]
XU241 MUX2S $PINS O=term3_shifted[17] S=FE_RN_384_0 A=sll_18/ML_int[3][17]
+ B=sll_18/ML_int[3][9]
XU242 MUX2S $PINS O=term2_shifted[17] S=FE_RN_244_0 A=sll_17/ML_int[3][17]
+ B=sll_17/ML_int[3][9]
XU243 MUX2S $PINS O=term1_shifted[18] S=FE_RN_282_0 A=sll_16/ML_int[3][18]
+ B=sll_16/ML_int[3][10]
XU244 MUX2S $PINS O=term3_shifted[18] S=FE_RN_384_0 A=sll_18/ML_int[3][18]
+ B=sll_18/ML_int[3][10]
XU245 MUX2S $PINS O=term2_shifted[18] S=FE_RN_244_0 A=sll_17/ML_int[3][18]
+ B=sll_17/ML_int[3][10]
XU249 MUX2S $PINS O=sll_16/ML_int[3][16] S=FE_OFN129_h31_2 A=n108
+ B=sll_16/ML_int[2][12]
XU250 MUX2S $PINS O=sll_18/ML_int[3][16] S=FE_OFN111_h33_2 A=n130
+ B=sll_18/ML_int[2][12]
XU251 MUX2S $PINS O=n122 S=FE_OFN214_h32_0 A=term2_in[26] B=term2_in[15]
XU252 MUX2S $PINS O=sll_17/ML_int[3][16] S=n48 A=n119 B=sll_17/ML_int[2][12]
XU255 MUX2S $PINS O=n109 S=FE_OFN192_h31_1 A=term1_in[26]
+ B=sll_16/ML_int[1][15]
XU256 MUX2S $PINS O=sll_16/ML_int[3][17] S=FE_OFN129_h31_2 A=n109
+ B=sll_16/ML_int[2][13]
XU258 MUX2S $PINS O=n131 S=shf3[1] A=term3_in[26] B=sll_18/ML_int[1][15]
XU259 MUX2S $PINS O=sll_18/ML_int[3][17] S=FE_OFN111_h33_2 A=n131
+ B=sll_18/ML_int[2][13]
XU260 MUX2S $PINS O=n120 S=FE_DBTN179_h32_1 A=n3 B=sll_17/ML_int[1][15]
XU261 MUX2S $PINS O=sll_17/ML_int[3][17] S=n48 A=n120 B=sll_17/ML_int[2][13]
XU262 MUX2S $PINS O=sll_16/ML_int[3][18] S=FE_OFN129_h31_2 A=n110
+ B=sll_16/ML_int[2][14]
XU263 MUX2S $PINS O=n132 S=FE_DBTN178_h33_1 A=n133 B=term3_in[26]
XU264 MUX2S $PINS O=sll_18/ML_int[3][18] S=FE_OFN111_h33_2 A=n132
+ B=sll_18/ML_int[2][14]
XU265 MUX2S $PINS O=sll_17/ML_int[3][18] S=n48 A=n121 B=sll_17/ML_int[2][14]
XU266 MUX2S $PINS O=term1_shifted[19] S=FE_RN_282_0 A=sll_16/ML_int[3][19]
+ B=sll_16/ML_int[3][11]
XU267 MUX2S $PINS O=term3_shifted[19] S=FE_RN_384_0 A=sll_18/ML_int[3][19]
+ B=sll_18/ML_int[3][11]
XU268 MUX2S $PINS O=term2_shifted[19] S=FE_RN_244_0 A=sll_17/ML_int[3][19]
+ B=sll_17/ML_int[3][11]
XU269 MUX2S $PINS O=term1_shifted[20] S=FE_RN_282_0 A=sll_16/ML_int[3][20]
+ B=sll_16/ML_int[3][12]
XU270 MUX2S $PINS O=sll_16/ML_int[3][20] S=FE_OFN129_h31_2 A=term1_in[26]
+ B=n108
XU271 MUX2S $PINS O=term3_shifted[20] S=FE_RN_384_0 A=sll_18/ML_int[3][20]
+ B=sll_18/ML_int[3][12]
XU272 MUX2S $PINS O=sll_18/ML_int[3][20] S=FE_OFN111_h33_2 A=term3_in[26]
+ B=n130
XU273 MUX2S $PINS O=term2_shifted[20] S=FE_RN_244_0 A=sll_17/ML_int[3][20]
+ B=sll_17/ML_int[3][12]
XU274 MUX2S $PINS O=sll_17/ML_int[3][20] S=n48 A=term2_in[26] B=n119
XU277 MUX2S $PINS O=term1_shifted[21] S=FE_RN_282_0 A=sll_16/ML_int[3][21]
+ B=sll_16/ML_int[3][13]
XU278 MUX2S $PINS O=term2_shifted[21] S=FE_RN_244_0 A=sll_17/ML_int[3][21]
+ B=sll_17/ML_int[3][13]
XU279 MUX2S $PINS O=term3_shifted[21] S=FE_RN_384_0 A=sll_18/ML_int[3][21]
+ B=sll_18/ML_int[3][13]
XU281 AN2S $PINS O=base_val[6] I1=acc_reg[6] I2=n151
XU284 MUX2S $PINS O=N235 S=n30 A=FE_PHN1030_acc_reg_10 B=FE_PHN1009_acc_reg_14
XU285 MUX2S $PINS O=FE_PHN1227_N244 S=n30 A=acc_reg[19] B=acc_reg[23]
XU300 INV1S $PINS O=n106 I=n101
XU301 NR2 $PINS O=term1_in[2] I1=sign1[1] I2=x_in[2]
XU302 NR2 $PINS O=term1_in[3] I1=sign1[1] I2=x_in[3]
XU305 NR2 $PINS O=term2_in[3] I1=sign2[1] I2=x_in[3]
XU306 NR2 $PINS O=term3_in[3] I1=sign3[1] I2=x_in[3]
XU307 NR2 $PINS O=term1_in[5] I1=sign1[1] I2=FE_OFN102_mac_in_imag_5
XU308 NR2 $PINS O=term2_in[5] I1=sign2[1] I2=FE_OFN102_mac_in_imag_5
XU309 NR2 $PINS O=term3_in[5] I1=FE_OFN355_s33_1 I2=FE_OFN102_mac_in_imag_5
XU311 NR2 $PINS O=term1_in[6] I1=FE_OFN263_s31_1 I2=FE_OFN109_mac_in_imag_6
XU312 NR2 $PINS O=term2_in[6] I1=sign2[1] I2=FE_OFN109_mac_in_imag_6
XU313 NR2 $PINS O=term3_in[6] I1=FE_OFN355_s33_1 I2=FE_OFN109_mac_in_imag_6
XU314 NR2 $PINS O=term1_in[7] I1=FE_OFN263_s31_1 I2=x_in[7]
XU315 NR2 $PINS O=term2_in[7] I1=sign2[1] I2=x_in[7]
XU316 NR2 $PINS O=term3_in[7] I1=FE_OFN355_s33_1 I2=x_in[7]
XU318 NR2 $PINS O=term1_in[8] I1=FE_OFN263_s31_1 I2=x_in[8]
XU319 NR2 $PINS O=term2_in[8] I1=sign2[1] I2=x_in[8]
XU320 NR2 $PINS O=term3_in[8] I1=FE_OFN355_s33_1 I2=x_in[8]
XU322 NR2 $PINS O=term1_in[9] I1=FE_OFN263_s31_1 I2=x_in[9]
XU323 NR2 $PINS O=term2_in[9] I1=sign2[1] I2=x_in[9]
XU324 NR2 $PINS O=term3_in[9] I1=FE_OFN355_s33_1 I2=x_in[9]
XU325 NR2 $PINS O=term1_in[10] I1=FE_OFN263_s31_1 I2=x_in[10]
XU326 NR2 $PINS O=term2_in[10] I1=sign2[1] I2=x_in[10]
XU327 NR2 $PINS O=term3_in[10] I1=FE_OFN355_s33_1 I2=x_in[10]
XU328 NR2 $PINS O=term1_in[11] I1=FE_OFN263_s31_1 I2=x_in[11]
XU329 NR2 $PINS O=term2_in[11] I1=sign2[1] I2=x_in[11]
XU330 NR2 $PINS O=term3_in[11] I1=FE_OFN355_s33_1 I2=x_in[11]
XU331 NR2 $PINS O=term1_in[12] I1=FE_OFN263_s31_1 I2=x_in[12]
XU334 NR2 $PINS O=term2_in[12] I1=sign2[1] I2=x_in[12]
XU335 NR2 $PINS O=term3_in[12] I1=FE_OFN355_s33_1 I2=x_in[12]
XU339 NR2 $PINS O=term1_in[13] I1=FE_OFN263_s31_1 I2=x_in[13]
XU340 NR2 $PINS O=term2_in[13] I1=sign2[1] I2=x_in[13]
XU341 NR2 $PINS O=term3_in[13] I1=FE_OFN355_s33_1 I2=x_in[13]
XU342 NR2 $PINS O=term1_in[14] I1=FE_OFN263_s31_1 I2=x_in[14]
XU344 NR2 $PINS O=term2_in[14] I1=sign2[1] I2=x_in[14]
XU345 NR2 $PINS O=term3_in[14] I1=FE_OFN355_s33_1 I2=x_in[14]
XU350 NR2 $PINS O=term1_in[15] I1=FE_OFN263_s31_1 I2=n139
XU351 NR2 $PINS O=term2_in[15] I1=sign2[1] I2=n139
XU352 NR2 $PINS O=term3_in[15] I1=FE_OFN355_s33_1 I2=n139
XU365 INV1S $PINS O=n11 I=shf3[0]
XU368 INV1S $PINS O=n68 I=shf1[0]
XU392 INV1S $PINS O=n139 I=x_in[15]
XU393 INV1S $PINS O=n140 I=x_in[16]
XU394 NR2 $PINS O=term1_in[26] I1=n140 I2=FE_OFN263_s31_1
XU395 NR2 $PINS O=term2_in[26] I1=n140 I2=sign2[1]
XU397 NR2 $PINS O=term3_in[26] I1=n140 I2=FE_OFN355_s33_1
XU399 AN2 $PINS O=base_val[26] I1=FE_PHN827_N251 I2=FE_OFN276_n151
XU400 AN2 $PINS O=base_val[1] I1=acc_reg[1] I2=n151
XU401 MOAI1S $PINS O=base_val[9] A1=n30 A2=n151 B1=acc_reg[9] B2=n151
XU402 AN2 $PINS O=base_val[10] I1=acc_reg[10] I2=FE_OFN276_n151
XU403 AN2 $PINS O=base_val[11] I1=acc_reg[11] I2=FE_OFN276_n151
XU404 AN2 $PINS O=base_val[12] I1=acc_reg[12] I2=FE_OFN276_n151
XU405 AN2 $PINS O=base_val[14] I1=acc_reg[14] I2=FE_OFN276_n151
XU406 AN2 $PINS O=base_val[15] I1=acc_reg[15] I2=FE_OFN276_n151
XU407 AN2 $PINS O=base_val[16] I1=acc_reg[16] I2=FE_OFN276_n151
XU408 AN2 $PINS O=base_val[17] I1=acc_reg[17] I2=FE_OFN276_n151
XU409 AN2 $PINS O=base_val[18] I1=acc_reg[18] I2=FE_OFN276_n151
XU410 AN2 $PINS O=base_val[19] I1=acc_reg[19] I2=FE_OFN276_n151
XU411 AN2 $PINS O=base_val[20] I1=acc_reg[20] I2=FE_OFN276_n151
XU412 AN2 $PINS O=base_val[21] I1=acc_reg[21] I2=FE_OFN276_n151
XU413 AN2 $PINS O=base_val[22] I1=acc_reg[22] I2=FE_OFN276_n151
XU414 AN2 $PINS O=base_val[23] I1=acc_reg[23] I2=FE_OFN276_n151
XU415 AN2 $PINS O=base_val[24] I1=acc_reg[24] I2=FE_OFN276_n151
XU416 AN2 $PINS O=base_val[25] I1=acc_reg[25] I2=FE_OFN276_n151
XU417 AN2 $PINS O=base_val[8] I1=acc_reg[8] I2=n151
XU418 AN2 $PINS O=base_val[7] I1=acc_reg[7] I2=n151
XU419 AN2 $PINS O=base_val[5] I1=acc_reg[5] I2=n151
XU420 AN2 $PINS O=base_val[4] I1=acc_reg[4] I2=n151
XU421 AN2 $PINS O=base_val[3] I1=acc_reg[3] I2=n151
XU422 AN2 $PINS O=base_val[2] I1=acc_reg[2] I2=n151
XU425 AN2 $PINS O=base_val[0] I1=acc_reg[0] I2=n151
XU428 AN2 $PINS O=N234 I1=en I2=calc_done
XU430 INV1S $PINS O=n118 I=n113
XU432 INV1S $PINS O=n107 I=n102
XU433 ND2 $PINS O=n102 I1=sll_16/ML_int[1][1] I2=n72
XU434 AN2 $PINS O=sll_16/ML_int[1][0] I1=n68 I2=term1_in[0]
XU435 NR2 $PINS O=sll_16/ML_int[3][0] I1=FE_OFN129_h31_2 I2=n101
XU436 NR2 $PINS O=sll_16/ML_int[3][1] I1=FE_OFN129_h31_2 I2=n102
XU438 NR2 $PINS O=sll_16/ML_int[3][3] I1=FE_OFN129_h31_2 I2=n104
XU439 ND2 $PINS O=n103 I1=n76 I2=n79
XU441 AN2 $PINS O=term1_shifted[6] I1=sll_16/ML_int[3][6] I2=n79
XU443 MUX2 $PINS O=sll_16/ML_int[3][21] S=FE_OFN129_h31_2 A=term1_in[26] B=n109
XU444 MUX2 $PINS O=sll_16/ML_int[3][22] S=FE_OFN129_h31_2 A=term1_in[26] B=n110
XU445 MUX2 $PINS O=term1_shifted[24] S=FE_RN_282_0 A=term1_in[26]
+ B=sll_16/ML_int[3][16]
XU446 MUX2 $PINS O=term1_shifted[25] S=FE_RN_282_0 A=term1_in[26]
+ B=sll_16/ML_int[3][17]
XU447 MUX2 $PINS O=term1_shifted[26] S=FE_RN_282_0 A=term1_in[26]
+ B=sll_16/ML_int[3][18]
XU448 NR2 $PINS O=sll_17/ML_int[3][0] I1=n48 I2=n112
XU449 NR2 $PINS O=sll_17/ML_int[3][1] I1=n48 I2=n113
XU450 NR2 $PINS O=sll_17/ML_int[3][2] I1=n48 I2=n116
XU451 NR2 $PINS O=sll_17/ML_int[3][3] I1=n48 I2=n115
XU452 ND2P $PINS O=n114 I1=FE_OFN127_h32_2 I2=n53
XU453 NR2 $PINS O=term2_shifted[3] I1=n114 I2=n115
XU454 AN2S $PINS O=term2_shifted[5] I1=sll_17/ML_int[3][5] I2=n53
XU455 AN2 $PINS O=term2_shifted[6] I1=sll_17/ML_int[3][6] I2=n53
XU456 AN2S $PINS O=term2_shifted[7] I1=sll_17/ML_int[3][7] I2=n53
XU457 MUX2 $PINS O=sll_17/ML_int[3][21] S=n48 A=n3 B=n120
XU458 MUX2 $PINS O=sll_17/ML_int[3][22] S=n48 A=term2_in[26] B=n121
XU459 MUX2 $PINS O=term2_shifted[24] S=FE_RN_244_0 A=term2_in[26]
+ B=sll_17/ML_int[3][16]
XU460 MUX2 $PINS O=term2_shifted[25] S=FE_RN_244_0 A=n3 B=sll_17/ML_int[3][17]
XU461 MUX2 $PINS O=term2_shifted[26] S=FE_RN_244_0 A=term2_in[26]
+ B=sll_17/ML_int[3][18]
XU462 NR2 $PINS O=sll_18/ML_int[3][0] I1=shf3[2] I2=n123
XU463 NR2 $PINS O=sll_18/ML_int[3][1] I1=shf3[2] I2=n124
XU464 NR2 $PINS O=sll_18/ML_int[3][2] I1=shf3[2] I2=n127
XU465 NR2 $PINS O=sll_18/ML_int[3][3] I1=shf3[2] I2=n126
XU466 ND2 $PINS O=n125 I1=n20 I2=n24
XU470 AN2S $PINS O=term3_shifted[6] I1=n24 I2=sll_18/ML_int[3][6]
XU472 MUX2 $PINS O=sll_18/ML_int[3][21] S=FE_OFN111_h33_2 A=term3_in[26] B=n131
XU473 MUX2 $PINS O=sll_18/ML_int[3][22] S=FE_OFN111_h33_2 A=term3_in[26] B=n132
XU474 MUX2 $PINS O=term3_shifted[24] S=FE_RN_384_0 A=term3_in[26]
+ B=sll_18/ML_int[3][16]
XU475 MUX2 $PINS O=n130 S=shf3[1] A=n133 B=sll_18/ML_int[1][14]
XU476 MUX2 $PINS O=term3_shifted[25] S=FE_RN_384_0 A=term3_in[26]
+ B=sll_18/ML_int[3][17]
XU477 MUX2 $PINS O=term3_shifted[26] S=FE_RN_384_0 A=term3_in[26]
+ B=sll_18/ML_int[3][18]
XU478 MUX2 $PINS O=N245 S=n30 A=acc_reg[20] B=acc_reg[24]
XU479 MUX2 $PINS O=N246 S=n30 A=acc_reg[21] B=FE_PHN858_acc_reg_25
XU480 MUX2 $PINS O=N236 S=n30 A=FE_PHN1024_acc_reg_11 B=acc_reg[15]
XU481 MUX2 $PINS O=N237 S=n30 A=acc_reg[12] B=acc_reg[16]
XU482 MUX2 $PINS O=FE_PHN1223_N238 S=n30 A=acc_reg[13] B=acc_reg[17]
XU483 MUX2 $PINS O=FE_PHN1190_N239 S=n30 A=FE_PHN1009_acc_reg_14 B=acc_reg[18]
XU484 MUX2 $PINS O=N240 S=n30 A=acc_reg[15] B=acc_reg[19]
XU485 MUX2 $PINS O=N241 S=n30 A=acc_reg[16] B=acc_reg[20]
XU486 MUX2 $PINS O=N242 S=n30 A=acc_reg[17] B=acc_reg[21]
XU487 MUX2 $PINS O=N243 S=n30 A=acc_reg[18] B=FE_PHN865_acc_reg_22
Xclk_gate_y_out_reg SNPS_CLOCK_GATE_HIGH_PE_Shift_Add_0 $PINS EN=N234
+ ENCLK=CTS_12 CLK=clk_clone2
Xsub_28_3 PE_Shift_Add_0_DW01_sub_0 $PINS A[26]=net44408 A[25]=net44408
+ A[24]=net44408 A[23]=net44408 A[22]=net44408 A[21]=net44408 A[20]=net44408
+ A[19]=net44408 A[18]=net44408 A[17]=net44408 A[16]=net44408 A[15]=net44408
+ A[14]=net44408 A[13]=net44408 A[12]=net44408 A[11]=net44408 A[10]=net44408
+ A[9]=net44408 A[8]=net44408 A[7]=net44408 A[6]=net44408 A[5]=net44408
+ A[4]=net44408 A[3]=net44408 A[2]=net44408 A[1]=net44408 A[0]=net44408
+ B[26]=term3_shifted[26] B[25]=term3_shifted[25] B[24]=term3_shifted[24]
+ B[23]=term3_shifted[23] B[22]=term3_shifted[22] B[21]=term3_shifted[21]
+ B[20]=term3_shifted[20] B[19]=term3_shifted[19] B[18]=term3_shifted[18]
+ B[17]=term3_shifted[17] B[16]=term3_shifted[16] B[15]=term3_shifted[15]
+ B[14]=term3_shifted[14] B[13]=term3_shifted[13] B[12]=term3_shifted[12]
+ B[11]=term3_shifted[11] B[10]=term3_shifted[10] B[9]=term3_shifted[9]
+ B[8]=term3_shifted[8] B[7]=term3_shifted[7] B[6]=term3_shifted[6]
+ B[5]=term3_shifted[5] B[4]=term3_shifted[4] B[3]=term3_shifted[3] B[2]=n5
+ B[1]=term3_shifted[1] B[0]=term3_shifted[0] CI=net44408 DIFF[26]=N150
+ DIFF[25]=N149 DIFF[24]=N148 DIFF[23]=N147 DIFF[22]=N146 DIFF[21]=N145
+ DIFF[20]=N144 DIFF[19]=N143 DIFF[18]=N142 DIFF[17]=N141 DIFF[16]=N140
+ DIFF[15]=N139 DIFF[14]=N138 DIFF[13]=N137 DIFF[12]=N136 DIFF[11]=N135
+ DIFF[10]=N134 DIFF[9]=N133 DIFF[8]=N132 DIFF[7]=N131 DIFF[6]=N130 DIFF[5]=N129
+ DIFF[4]=N128 DIFF[3]=N127 DIFF[2]=N126 DIFF[1]=N125 DIFF[0]=N124
Xsub_28_2 PE_Shift_Add_0_DW01_sub_1 $PINS A[26]=net44408 A[25]=net44408
+ A[24]=net44408 A[23]=net44408 A[22]=net44408 A[21]=net44408 A[20]=net44408
+ A[19]=net44408 A[18]=net44408 A[17]=net44408 A[16]=net44408 A[15]=net44408
+ A[14]=net44408 A[13]=net44408 A[12]=net44408 A[11]=net44408 A[10]=net44408
+ A[9]=net44408 A[8]=net44408 A[7]=net44408 A[6]=net44408 A[5]=net44408
+ A[4]=net44408 A[3]=net44408 A[2]=net44408 A[1]=net44408 A[0]=net44408
+ B[26]=term2_shifted[26] B[25]=term2_shifted[25] B[24]=term2_shifted[24]
+ B[23]=term2_shifted[23] B[22]=term2_shifted[22] B[21]=term2_shifted[21]
+ B[20]=term2_shifted[20] B[19]=term2_shifted[19] B[18]=term2_shifted[18]
+ B[17]=term2_shifted[17] B[16]=term2_shifted[16] B[15]=term2_shifted[15]
+ B[14]=term2_shifted[14] B[13]=term2_shifted[13] B[12]=term2_shifted[12]
+ B[11]=term2_shifted[11] B[10]=term2_shifted[10] B[9]=term2_shifted[9]
+ B[8]=term2_shifted[8] B[7]=term2_shifted[7] B[6]=term2_shifted[6]
+ B[5]=term2_shifted[5] B[4]=term2_shifted[4] B[3]=term2_shifted[3]
+ B[2]=term2_shifted[2] B[1]=term2_shifted[1] B[0]=term2_shifted[0] CI=net44408
+ DIFF[26]=N95 DIFF[25]=N94 DIFF[24]=N93 DIFF[23]=N92 DIFF[22]=N91 DIFF[21]=N90
+ DIFF[20]=N89 DIFF[19]=N88 DIFF[18]=N87 DIFF[17]=N86 DIFF[16]=N85 DIFF[15]=N84
+ DIFF[14]=N83 DIFF[13]=N82 DIFF[12]=N81 DIFF[11]=N80 DIFF[10]=N79 DIFF[9]=N78
+ DIFF[8]=N77 DIFF[7]=N76 DIFF[6]=N75 DIFF[5]=N74 DIFF[4]=N73 DIFF[3]=N72
+ DIFF[2]=N71 DIFF[1]=N70 DIFF[0]=N69
Xsub_28 PE_Shift_Add_0_DW01_sub_2 $PINS A[26]=net44408 A[25]=net44408
+ A[24]=net44408 A[23]=net44408 A[22]=net44408 A[21]=net44408 A[20]=net44408
+ A[19]=net44408 A[18]=net44408 A[17]=net44408 A[16]=net44408 A[15]=net44408
+ A[14]=net44408 A[13]=net44408 A[12]=net44408 A[11]=net44408 A[10]=net44408
+ A[9]=net44408 A[8]=net44408 A[7]=net44408 A[6]=net44408 A[5]=net44408
+ A[4]=net44408 A[3]=net44408 A[2]=net44408 A[1]=net44408 A[0]=net44408
+ B[26]=term1_shifted[26] B[25]=term1_shifted[25] B[24]=term1_shifted[24]
+ B[23]=term1_shifted[23] B[22]=term1_shifted[22] B[21]=term1_shifted[21]
+ B[20]=term1_shifted[20] B[19]=term1_shifted[19] B[18]=term1_shifted[18]
+ B[17]=term1_shifted[17] B[16]=term1_shifted[16] B[15]=term1_shifted[15]
+ B[14]=term1_shifted[14] B[13]=term1_shifted[13] B[12]=term1_shifted[12]
+ B[11]=term1_shifted[11] B[10]=term1_shifted[10] B[9]=term1_shifted[9]
+ B[8]=term1_shifted[8] B[7]=term1_shifted[7] B[6]=term1_shifted[6]
+ B[5]=term1_shifted[5] B[4]=term1_shifted[4] B[3]=term1_shifted[3]
+ B[2]=term1_shifted[2] B[1]=term1_shifted[1] B[0]=term1_shifted[0] CI=net44408
+ DIFF[26]=N40 DIFF[25]=N39 DIFF[24]=N38 DIFF[23]=N37 DIFF[22]=N36 DIFF[21]=N35
+ DIFF[20]=N34 DIFF[19]=N33 DIFF[18]=N32 DIFF[17]=N31 DIFF[16]=N30 DIFF[15]=N29
+ DIFF[14]=N28 DIFF[13]=N27 DIFF[12]=N26 DIFF[11]=N25 DIFF[10]=N24 DIFF[9]=N23
+ DIFF[8]=N22 DIFF[7]=N21 DIFF[6]=N20 DIFF[5]=N19 DIFF[4]=N18 DIFF[3]=N17
+ DIFF[2]=N16 DIFF[1]=N15 DIFF[0]=N14
Xadd_1_root_add_0_root_add_28_3 PE_Shift_Add_0_DW01_add_2_DW01_add_28 $PINS
+ A[26]=N67 A[25]=N66 A[24]=N65 A[23]=N64 A[22]=N63 A[21]=N62 A[20]=N61 A[19]=N60
+ A[18]=N59 A[17]=N58 A[16]=N57 A[15]=N56 A[14]=N55 A[13]=N54 A[12]=N53 A[11]=N52
+ A[10]=N51 A[9]=N50 A[8]=N49 A[7]=N48 A[6]=N47 A[5]=N46 A[4]=N45 A[3]=N44
+ A[2]=N43 A[1]=N42 A[0]=N41 B[26]=N177 B[25]=N176 B[24]=N175 B[23]=N174
+ B[22]=N173 B[21]=N172 B[20]=N171 B[19]=N170 B[18]=N169 B[17]=N168 B[16]=N167
+ B[15]=N166 B[14]=N165 B[13]=N164 B[12]=N163 B[11]=N162 B[10]=N161 B[9]=N160
+ B[8]=N159 B[7]=N158 B[6]=N157 B[5]=N156 B[4]=N155 B[3]=N154 B[2]=N153 B[1]=N152
+ B[0]=N151 CI=net44408 SUM[26]=N204 SUM[25]=N203 SUM[24]=N202 SUM[23]=N201
+ SUM[22]=N200 SUM[21]=N199 SUM[20]=N198 SUM[19]=N197 SUM[18]=N196 SUM[17]=N195
+ SUM[16]=N194 SUM[15]=N193 SUM[14]=N192 SUM[13]=N191 SUM[12]=N190 SUM[11]=N189
+ SUM[10]=N188 SUM[9]=N187 SUM[8]=N186 SUM[7]=N185 SUM[6]=N184 SUM[5]=N183
+ SUM[4]=N182 SUM[3]=N181 SUM[2]=N180 SUM[1]=N179 SUM[0]=N178
Xadd_2_root_add_0_root_add_28_3 PE_Shift_Add_0_DW01_add_1_DW01_add_27 $PINS
+ A[26]=base_val[26] A[25]=base_val[25] A[24]=base_val[24] A[23]=base_val[23]
+ A[22]=base_val[22] A[21]=base_val[21] A[20]=base_val[20] A[19]=base_val[19]
+ A[18]=base_val[18] A[17]=base_val[17] A[16]=base_val[16] A[15]=base_val[15]
+ A[14]=base_val[14] A[13]=base_val[13] A[12]=base_val[12] A[11]=base_val[11]
+ A[10]=base_val[10] A[9]=base_val[9] A[8]=base_val[8] A[7]=base_val[7]
+ A[6]=base_val[6] A[5]=base_val[5] A[4]=base_val[4] A[3]=base_val[3]
+ A[2]=base_val[2] A[1]=base_val[1] A[0]=base_val[0] B[26]=N122 B[25]=N121
+ B[24]=N120 B[23]=N119 B[22]=N118 B[21]=N117 B[20]=N116 B[19]=N115 B[18]=N114
+ B[17]=N113 B[16]=N112 B[15]=N111 B[14]=N110 B[13]=N109 B[12]=N108 B[11]=N107
+ B[10]=N106 B[9]=N105 B[8]=N104 B[7]=N103 B[6]=N102 B[5]=N101 B[4]=N100 B[3]=N99
+ B[2]=N98 B[1]=N97 B[0]=N96 CI=net44408 SUM[26]=N231 SUM[25]=N230 SUM[24]=N229
+ SUM[23]=N228 SUM[22]=N227 SUM[21]=N226 SUM[20]=N225 SUM[19]=N224 SUM[18]=N223
+ SUM[17]=N222 SUM[16]=N221 SUM[15]=N220 SUM[14]=N219 SUM[13]=N218 SUM[12]=N217
+ SUM[11]=N216 SUM[10]=N215 SUM[9]=N214 SUM[8]=N213 SUM[7]=N212 SUM[6]=N211
+ SUM[5]=N210 SUM[4]=N209 SUM[3]=N208 SUM[2]=N207 SUM[1]=N206 SUM[0]=N205
Xadd_0_root_add_0_root_add_28_3 PE_Shift_Add_0_DW01_add_0_DW01_add_26 $PINS
+ A[26]=N204 A[25]=N203 A[24]=N202 A[23]=N201 A[22]=N200 A[21]=N199 A[20]=N198
+ A[19]=N197 A[18]=N196 A[17]=N195 A[16]=N194 A[15]=N193 A[14]=N192 A[13]=N191
+ A[12]=N190 A[11]=N189 A[10]=N188 A[9]=N187 A[8]=N186 A[7]=N185 A[6]=N184
+ A[5]=N183 A[4]=N182 A[3]=N181 A[2]=N180 A[1]=N179 A[0]=N178 B[26]=N231
+ B[25]=N230 B[24]=N229 B[23]=N228 B[22]=N227 B[21]=N226 B[20]=N225 B[19]=N224
+ B[18]=N223 B[17]=N222 B[16]=N221 B[15]=N220 B[14]=N219 B[13]=N218 B[12]=N217
+ B[11]=N216 B[10]=N215 B[9]=N214 B[8]=N213 B[7]=N212 B[6]=N211 B[5]=N210
+ B[4]=N209 B[3]=N208 B[2]=N207 B[1]=N206 B[0]=N205 CI=net44408
+ SUM[26]=next_acc[26] SUM[25]=next_acc[25] SUM[24]=next_acc[24]
+ SUM[23]=next_acc[23] SUM[22]=next_acc[22] SUM[21]=next_acc[21]
+ SUM[20]=next_acc[20] SUM[19]=next_acc[19] SUM[18]=next_acc[18]
+ SUM[17]=next_acc[17] SUM[16]=next_acc[16] SUM[15]=next_acc[15]
+ SUM[14]=next_acc[14] SUM[13]=next_acc[13] SUM[12]=next_acc[12]
+ SUM[11]=next_acc[11] SUM[10]=next_acc[10] SUM[9]=next_acc[9] SUM[8]=next_acc[8]
+ SUM[7]=next_acc[7] SUM[6]=next_acc[6] SUM[5]=next_acc[5] SUM[4]=next_acc[4]
+ SUM[3]=next_acc[3] SUM[2]=next_acc[2] SUM[1]=next_acc[1] SUM[0]=next_acc[0]
XU3 AO22 $PINS O=N153 A1=sign3[0] A2=N126 B1=term3_shifted[2] B2=n33
XU4 NR2 $PINS O=term2_in[1] I1=sign2[1] I2=FE_OFN187_mac_in_imag_1
XU12 NR2 $PINS O=term2_in[2] I1=sign2[1] I2=x_in[2]
XU16 NR2 $PINS O=term3_in[2] I1=sign3[1] I2=x_in[2]
XU25 NR2 $PINS O=term1_in[0] I1=sign1[1] I2=n150
XU50 NR2 $PINS O=term1_in[4] I1=sign1[1] I2=n146
XU55 MUX2S $PINS O=sll_16/ML_int[3][6] S=FE_OFN129_h31_2 A=sll_16/ML_int[2][6]
+ B=sll_16/ML_int[2][2]
XU58 NR2 $PINS O=sll_16/ML_int[3][2] I1=FE_OFN129_h31_2 I2=n105
XU64 INV1S $PINS O=n105 I=sll_16/ML_int[2][2]
XU83 NR2 $PINS O=term2_in[4] I1=sign2[1] I2=n146
XU90 NR2P $PINS O=term1_shifted[1] I1=n103 I2=n102
XU105 NR2 $PINS O=term1_in[1] I1=sign1[1] I2=FE_OFN187_mac_in_imag_1
XU109 NR2 $PINS O=term3_in[4] I1=sign3[1] I2=n146
XU375 NR2 $PINS O=term3_in[1] I1=sign3[1] I2=FE_OFN187_mac_in_imag_1
XU396 NR2P $PINS O=term2_shifted[1] I1=n114 I2=n113
.ENDS

.SUBCKT DFrFT_MAC en stage_sel pe_clear pe_done g_cnt[2] g_cnt[1] g_cnt[0]
+ n_cnt[5] n_cnt[4] n_cnt[3] n_cnt[2] n_cnt[1] n_cnt[0] data_in_r[16]
+ data_in_r[15] data_in_r[14] data_in_r[13] data_in_r[12] data_in_r[11]
+ data_in_r[10] data_in_r[9] data_in_r[8] data_in_r[7] data_in_r[6]
+ data_in_r[5] data_in_r[4] data_in_r[3] data_in_r[2] data_in_r[1] data_in_r[0]
+ data_in_i[16] data_in_i[15] data_in_i[14] data_in_i[13] data_in_i[12]
+ data_in_i[11] data_in_i[10] data_in_i[9] data_in_i[8] data_in_i[7]
+ data_in_i[6] data_in_i[5] data_in_i[4] data_in_i[3] data_in_i[2] data_in_i[1]
+ data_in_i[0] y_out_0_r[16] y_out_0_r[15] y_out_0_r[14] y_out_0_r[13]
+ y_out_0_r[12] y_out_0_r[11] y_out_0_r[10] y_out_0_r[9] y_out_0_r[8]
+ y_out_0_r[7] y_out_0_r[6] y_out_0_r[5] y_out_0_r[4] y_out_0_r[3] y_out_0_r[2]
+ y_out_0_r[1] y_out_0_r[0] y_out_0_i[16] y_out_0_i[15] y_out_0_i[14]
+ y_out_0_i[13] y_out_0_i[12] y_out_0_i[11] y_out_0_i[10] y_out_0_i[9]
+ y_out_0_i[8] y_out_0_i[7] y_out_0_i[6] y_out_0_i[5] y_out_0_i[4] y_out_0_i[3]
+ y_out_0_i[2] y_out_0_i[1] y_out_0_i[0] y_out_1_r[16] y_out_1_r[15]
+ y_out_1_r[14] y_out_1_r[13] y_out_1_r[12] y_out_1_r[11] y_out_1_r[10]
+ y_out_1_r[9] y_out_1_r[8] y_out_1_r[7] y_out_1_r[6] y_out_1_r[5] y_out_1_r[4]
+ y_out_1_r[3] y_out_1_r[2] y_out_1_r[1] y_out_1_r[0] y_out_1_i[16]
+ y_out_1_i[15] y_out_1_i[14] y_out_1_i[13] y_out_1_i[12] y_out_1_i[11]
+ y_out_1_i[10] y_out_1_i[9] y_out_1_i[8] y_out_1_i[7] y_out_1_i[6]
+ y_out_1_i[5] y_out_1_i[4] y_out_1_i[3] y_out_1_i[2] y_out_1_i[1] y_out_1_i[0]
+ y_out_2_r[16] y_out_2_r[15] y_out_2_r[14] y_out_2_r[13] y_out_2_r[12]
+ y_out_2_r[11] y_out_2_r[10] y_out_2_r[9] y_out_2_r[8] y_out_2_r[7]
+ y_out_2_r[6] y_out_2_r[5] y_out_2_r[4] y_out_2_r[3] y_out_2_r[2] y_out_2_r[1]
+ y_out_2_r[0] y_out_2_i[16] y_out_2_i[15] y_out_2_i[14] y_out_2_i[13]
+ y_out_2_i[12] y_out_2_i[11] y_out_2_i[10] y_out_2_i[9] y_out_2_i[8]
+ y_out_2_i[7] y_out_2_i[6] y_out_2_i[5] y_out_2_i[4] y_out_2_i[3] y_out_2_i[2]
+ y_out_2_i[1] y_out_2_i[0] y_out_3_r[16] y_out_3_r[15] y_out_3_r[14]
+ y_out_3_r[13] y_out_3_r[12] y_out_3_r[11] y_out_3_r[10] y_out_3_r[9]
+ y_out_3_r[8] y_out_3_r[7] y_out_3_r[6] y_out_3_r[5] y_out_3_r[4] y_out_3_r[3]
+ y_out_3_r[2] y_out_3_r[1] y_out_3_r[0] y_out_3_i[16] y_out_3_i[15]
+ y_out_3_i[14] y_out_3_i[13] y_out_3_i[12] y_out_3_i[11] y_out_3_i[10]
+ y_out_3_i[9] y_out_3_i[8] y_out_3_i[7] y_out_3_i[6] y_out_3_i[5] y_out_3_i[4]
+ y_out_3_i[3] y_out_3_i[2] y_out_3_i[1] y_out_3_i[0] rst_n_BAR n64 i_rst_n
+ FE_OFN0_FE_DBTN15_n64 FE_OFN28_i_rst_n FE_OFN19_i_rst_n FE_OFN14_i_rst_n
+ FE_OFN11_i_rst_n FE_OFN8_i_rst_n FE_OFN5_i_rst_n FE_OFN83_FE_DBTN15_n64
+ clk_clone13 clk_clone12 clk_clone11 clk_clone10 clk_clone8 clk_clone9
+ clk_clone6 clk_clone5 clk_clone7 clk_clone4 clk_clone2 clk_clone1 clk
+ clk_clone3 p1
XCTS_ccl_a_INV_CLK_G0_L9_2 INV12CK $PINS O=CTS_14 I=CTS_15
XCTS_ccl_a_INV_CLK_G0_L9_1 INV12CK $PINS O=CTS_13 I=CTS_15
XCTS_ccl_a_INV_CLK_G0_L8_17 INV6CK $PINS O=CTS_15 I=clk_clone12
XFE_OFC714_FE_OFN30_pe_clear_d1 BUF1 $PINS O=FE_OFN370_FE_OFN30_pe_clear_d1
+ I=FE_OFN30_pe_clear_d1
XFE_OFC705_FE_OFN218_h03_0 BUF3 $PINS O=FE_OFN365_FE_OFN218_h03_0 I=h03[0]
XFE_OFC704_FE_OFN195_h02_0 BUF3 $PINS O=FE_OFN364_FE_OFN195_h02_0 I=h02[0]
XFE_OFC703_FE_OFN219_h01_0 BUF2 $PINS O=FE_OFN363_FE_OFN219_h01_0 I=h01[0]
XFE_OFC698_h03_3 INV2 $PINS O=FE_OFN359_h03_3 I=h03[3]
XFE_OFC693_h03_1 BUF8 $PINS O=FE_OFN278_h03_1 I=h03[1]
XFE_OFC691_s33_1 BUF3 $PINS O=FE_OFN266_s33_1 I=s33[1]
XFE_OFC690_mac_in_imag_5 INV4 $PINS O=FE_OFN102_mac_in_imag_5 I=data_in_i[5]
XFE_OFC688_mac_in_real_7 INV6 $PINS O=FE_OFN132_mac_in_real_7 I=data_in_r[7]
XFE_OFC685_h01_3 INV2 $PINS O=FE_OFN354_h01_3 I=h01[3]
XFE_OFC684_s02_0 BUF2 $PINS O=FE_OFN44_s02_0 I=s02[0]
XFE_OFC636_s03_0 INV1S $PINS O=FE_OFN331_s03_0 I=FE_OFN47_s03_0
XFE_OFC632_s03_0 INV2 $PINS O=FE_OFN47_s03_0 I=s03[0]
XFE_OFC605_s23_0 INV3 $PINS O=FE_OFN237_s23_0 I=s23[0]
XFE_OFC604_mac_in_imag_7 INV4 $PINS O=FE_OFN116_mac_in_imag_7 I=data_in_i[7]
XFE_OFC589_s01_1 BUF3 $PINS O=FE_OFN227_s01_1 I=s01[1]
XFE_OFC583_mac_in_imag_1 INV12 $PINS O=FE_OFN187_mac_in_imag_1 I=data_in_i[1]
XFE_OFC576_h23_1 INV2 $PINS O=FE_OFN317_h23_1 I=h23[1]
XFE_OFC570_mac_in_imag_3 INV3 $PINS O=FE_OFN315_mac_in_imag_3 I=data_in_i[3]
XFE_OFC547_h11_2 INV1S $PINS O=FE_OFN52_h11_2 I=h11[2]
XFE_OFC542_h01_2 INV1S $PINS O=FE_OFN43_h01_2 I=h01[2]
XFE_OFC532_h21_1 INV2 $PINS O=FE_OFN257_h21_1 I=h21[1]
XFE_OFC528_h03_2 INV1S $PINS O=FE_OFN49_h03_2 I=h03[2]
XFE_OFC525_mac_in_real_2 INV2 $PINS O=FE_OFN296_mac_in_real_2 I=data_in_r[2]
XFE_OFC511_mac_in_imag_4 INV3 $PINS O=FE_OFN288_mac_in_imag_4 I=data_in_i[4]
XFE_OFC507_mac_in_real_4 INV12CK $PINS O=FE_OFN285_mac_in_real_4 I=data_in_r[4]
XFE_OFC500_mac_in_imag_0 INV8 $PINS O=FE_OFN283_mac_in_imag_0 I=data_in_i[0]
XFE_OFC496_h21_2 INV1S $PINS O=FE_OFN282_h21_2 I=h21[2]
XFE_OFC490_h21_3 INV2 $PINS O=FE_OFN61_h21_3 I=h21[3]
XFE_OFC480_h01_1 BUF2 $PINS O=FE_OFN271_h01_1 I=h01[1]
XFE_OFC479_s21_0 BUF1 $PINS O=FE_OFN270_s21_0 I=s21[0]
XFE_OFC471_s31_1 BUF3 $PINS O=FE_OFN262_s31_1 I=s31[1]
XFE_OFC465_s33_0 BUF2 $PINS O=FE_OFN256_s33_0 I=s33[0]
XFE_OFC464_h11_0 BUF2 $PINS O=FE_OFN255_h11_0 I=h11[0]
XFE_OFC463_h12_1 BUF2 $PINS O=FE_OFN254_h12_1 I=h12[1]
XFE_OFC459_s32_1 BUF3 $PINS O=FE_OFN250_s32_1 I=s32[1]
XFE_OFC454_s22_1 BUF4 $PINS O=FE_OFN245_s22_1 I=s22[1]
XFE_OFC453_s31_0 BUF1 $PINS O=FE_OFN244_s31_0 I=s31[0]
XFE_OFC452_s23_1 BUF2 $PINS O=FE_OFN243_s23_1 I=s23[1]
XFE_OFC450_s21_1 BUF3 $PINS O=FE_OFN241_s21_1 I=s21[1]
XFE_OFC444_s03_1 BUF4 $PINS O=FE_OFN235_s03_1 I=s03[1]
XFE_OFC442_s13_1 BUF4 $PINS O=FE_OFN233_s13_1 I=s13[1]
XFE_OFC441_s11_1 BUF4CK $PINS O=FE_OFN232_s11_1 I=s11[1]
XFE_OFC410_h23_0 BUF2 $PINS O=FE_OFN217_h23_0 I=h23[0]
XFE_OFC376_h22_1 BUF3 $PINS O=FE_OFN201_h22_1 I=h22[1]
XFE_OFC355_mac_in_real_5 INV6 $PINS O=FE_OFN194_mac_in_real_5 I=data_in_r[5]
XFE_OFC345_h13_1 BUF6 $PINS O=FE_OFN190_h13_1 I=h13[1]
XFE_OFC339_h12_2 BUF4 $PINS O=FE_OFN56_h12_2 I=h12[2]
XFE_OFC331_h02_1 BUF2 $PINS O=FE_OFN185_h02_1 I=h02[1]
XFE_OFC325_h13_3 BUF2 $PINS O=FE_OFN58_h13_3 I=h13[3]
XFE_OFC288_pe_clear_d1 BUF4 $PINS O=FE_OFN30_pe_clear_d1 I=pe_clear
XFE_OFC245_mac_in_real_12 INV2 $PINS O=FE_OFN166_mac_in_real_12 I=data_in_r[12]
XFE_OFC240_mac_in_imag_14 INV2 $PINS O=FE_OFN164_mac_in_imag_14 I=data_in_i[14]
XFE_OFC228_h22_3 BUF2 $PINS O=FE_OFN64_h22_3 I=h22[3]
XFE_OFC222_mac_in_real_11 INV2 $PINS O=FE_OFN156_mac_in_real_11 I=data_in_r[11]
XFE_OFC221_mac_in_real_13 INV2 $PINS O=FE_OFN155_mac_in_real_13 I=data_in_r[13]
XFE_OFC215_s11_0 BUF3 $PINS O=FE_OFN50_s11_0 I=s11[0]
XFE_OFC209_mac_in_imag_11 INV2 $PINS O=FE_OFN149_mac_in_imag_11 I=data_in_i[11]
XFE_OFC203_mac_in_imag_13 INV2 $PINS O=FE_OFN145_mac_in_imag_13 I=data_in_i[13]
XFE_OFC192_mac_in_imag_12 INV2 $PINS O=FE_OFN141_mac_in_imag_12 I=data_in_i[12]
XFE_OFC190_mac_in_real_9 INV3 $PINS O=FE_OFN139_mac_in_real_9 I=data_in_r[9]
XFE_OFC176_mac_in_real_8 INV4 $PINS O=FE_OFN135_mac_in_real_8 I=data_in_r[8]
XFE_OFC172_mac_in_real_10 INV2 $PINS O=FE_OFN134_mac_in_real_10 I=data_in_r[10]
XFE_OFC169_mac_in_imag_8 INV3 $PINS O=FE_OFN131_mac_in_imag_8 I=data_in_i[8]
XFE_OFC141_mac_in_imag_10 INV2 $PINS O=FE_OFN120_mac_in_imag_10 I=data_in_i[10]
XFE_OFC130_mac_in_imag_9 INV2 $PINS O=FE_OFN114_mac_in_imag_9 I=data_in_i[9]
XFE_OFC122_mac_in_imag_6 INV3 $PINS O=FE_OFN109_mac_in_imag_6 I=data_in_i[6]
XFE_OFC118_mac_in_real_6 INV3 $PINS O=FE_OFN107_mac_in_real_6 I=data_in_r[6]
XFE_OFC116_n64 BUF1 $PINS O=FE_OFN5_FE_DBTN15_n64 I=FE_OFN2_FE_DBTN15_n64
XFE_OFC114_n64 BUF1 $PINS O=FE_OFN3_FE_DBTN15_n64 I=FE_OFN1_FE_DBTN15_n64
XFE_OFC113_n64 BUF1 $PINS O=FE_OFN2_FE_DBTN15_n64 I=stage_sel
XFE_OFC112_n64 BUF1 $PINS O=FE_RN_1 I=stage_sel
XFE_OFC111_n64 INV1S $PINS O=FE_OFN1_FE_DBTN15_n64 I=n64
XFE_OFC108_mac_in_imag_2 INV8 $PINS O=FE_OFN104_mac_in_imag_2 I=data_in_i[2]
XFE_OFC98_mac_in_real_3 INV3 $PINS O=FE_OFN100_mac_in_real_3 I=data_in_r[3]
XFE_OFC97_mac_in_real_3 INV2 $PINS O=FE_OFN99_mac_in_real_3 I=data_in_r[3]
XFE_OFC94_rom_n_idx_3__2 BUF2 $PINS O=FE_OFN96_rom_n_idx_3__2 I=rom_n_idx[3][2]
XFE_OFC90_rom_k_idx_3__2 BUF2CK $PINS O=FE_OFN92_rom_k_idx_3__2
+ I=rom_k_idx[3][2]
XFE_OFC89_rom_k_idx_3__3 BUF1 $PINS O=FE_OFN91_rom_k_idx_3__3 I=rom_k_idx[3][3]
XFE_OFC88_rom_k_idx_3__4 BUF1 $PINS O=FE_OFN90_rom_k_idx_3__4 I=rom_k_idx[3][4]
XFE_OFC87_rom_n_idx_3__3 BUF2 $PINS O=FE_OFN89_rom_n_idx_3__3 I=rom_n_idx[3][3]
XFE_OFC38_rom_n_idx_3__4 BUF1 $PINS O=FE_OFN40_rom_n_idx_3__4 I=rom_n_idx[3][4]
XFE_OFC27_i_rst_n INV2 $PINS O=FE_OFN29_i_rst_n I=FE_OFN25_i_rst_n
XFE_OFC26_i_rst_n INV2 $PINS O=FE_OFN27_i_rst_n I=FE_OFN25_i_rst_n
XFE_OFC25_i_rst_n BUF2CK $PINS O=FE_OFN26_i_rst_n I=FE_OFN18_i_rst_n
XFE_OFC24_i_rst_n INV1S $PINS O=FE_OFN25_i_rst_n I=FE_OFN14_i_rst_n
XFE_OFC22_i_rst_n BUF2CK $PINS O=FE_OFN23_i_rst_n I=FE_OFN14_i_rst_n
XFE_OFC21_i_rst_n INV1S $PINS O=FE_OFN22_i_rst_n I=FE_OFN15_i_rst_n
XFE_OFC20_i_rst_n INV2 $PINS O=FE_OFN21_i_rst_n I=FE_OFN15_i_rst_n
XFE_OFC19_i_rst_n INV2 $PINS O=FE_OFN20_i_rst_n I=FE_OFN8_i_rst_n
XFE_OFC17_i_rst_n INV1S $PINS O=FE_OFN18_i_rst_n I=FE_OFN8_i_rst_n
XFE_OFC16_i_rst_n BUF1 $PINS O=FE_OFN17_i_rst_n I=FE_OFN10_i_rst_n
XFE_OFC14_i_rst_n INV1S $PINS O=FE_OFN15_i_rst_n I=FE_OFN5_i_rst_n
XFE_OFC12_i_rst_n BUF2CK $PINS O=FE_OFN12_i_rst_n I=i_rst_n
XFE_OFC10_i_rst_n BUF1 $PINS O=FE_OFN10_i_rst_n I=i_rst_n
XFE_DBTC153_rom_k_idx_1_1 INV1S $PINS O=FE_DBTN153_rom_k_idx_1_1
+ I=rom_k_idx[1][1]
XFE_DBTC152_rom_k_idx_3_1 INV1S $PINS O=FE_DBTN152_rom_k_idx_3_1
+ I=rom_k_idx[3][1]
XU22 ND2 $PINS O=rom_k_idx[3][0] I1=FE_RN_1 I2=n_cnt[0]
XU5 ND2S $PINS O=rom_n_idx[3][1] I1=n64 I2=n_cnt[1]
XU6 ND2 $PINS O=rom_n_idx[3][0] I1=FE_OFN83_FE_DBTN15_n64 I2=n_cnt[0]
XU7 OR2 $PINS O=rom_k_idx[1][1] I1=n_cnt[1] I2=n64
XU10 MOAI1S $PINS O=rom_n_idx[3][3] A1=g_cnt[1] A2=n64 B1=n64 B2=n_cnt[3]
XU28 MOAI1S $PINS O=rom_n_idx[3][4] A1=n64 A2=g_cnt[2] B1=n64 B2=n_cnt[4]
XU29 MOAI1S $PINS O=rom_n_idx[3][2] A1=g_cnt[0] A2=n64 B1=n64 B2=n_cnt[2]
XU30 NR2P $PINS O=rom_n_idx[1][1] I1=n_cnt[1] I2=FE_OFN1_FE_DBTN15_n64
XU44 NR2P $PINS O=rom_k_idx[2][0] I1=n_cnt[0] I2=n64
XU50 AN2 $PINS O=rom_k_idx[3][1] I1=FE_OFN1_FE_DBTN15_n64 I2=n_cnt[1]
XU53 MOAI1S $PINS O=rom_k_idx[3][3] A1=stage_sel A2=g_cnt[1] B1=n_cnt[3]
+ B2=stage_sel
XU61 NR2P $PINS O=rom_n_idx[2][0] I1=n_cnt[0] I2=stage_sel
XU69 MOAI1S $PINS O=rom_k_idx[3][4] A1=stage_sel A2=g_cnt[2] B1=p1 B2=stage_sel
XU70 MOAI1S $PINS O=rom_k_idx[3][2] A1=stage_sel A2=g_cnt[0] B1=n_cnt[2]
+ B2=stage_sel
Xrom0 ROM_Wrapper_Even_1 $PINS rst_n=FE_UNCONNECTED_2 en=en
+ n_in[4]=FE_OFN40_rom_n_idx_3__4 n_in[3]=FE_OFN89_rom_n_idx_3__3
+ n_in[2]=FE_OFN96_rom_n_idx_3__2 n_in[1]=rom_n_idx[1][1] n_in[0]=rom_n_idx[2][0]
+ k_idx[4]=FE_OFN90_rom_k_idx_3__4 k_idx[3]=FE_OFN91_rom_k_idx_3__3
+ k_idx[2]=FE_OFN92_rom_k_idx_3__2 k_idx[1]=FE_DBTN153_rom_k_idx_1_1
+ k_idx[0]=rom_k_idx[2][0] reg_sign1[1]=s01[1] reg_sign1[0]=s01[0]
+ reg_sign2[1]=s02[1] reg_sign2[0]=s02[0] reg_sign3[1]=s03[1] reg_sign3[0]=s03[0]
+ reg_shift1[3]=h01[3] reg_shift1[2]=h01[2] reg_shift1[1]=h01[1]
+ reg_shift1[0]=h01[0] reg_shift2[3]=h02[3] reg_shift2[2]=h02[2]
+ reg_shift2[1]=h02[1] reg_shift2[0]=h02[0] reg_shift3[3]=h03[3]
+ reg_shift3[2]=h03[2] reg_shift3[1]=h03[1] reg_shift3[0]=h03[0]
+ _rom_k_idx_1_1=rom_k_idx[1][1] i_rst_n=FE_OFN21_i_rst_n clk=clk_clone4
Xrom1 ROM_Wrapper_Odd_1 $PINS rst_n=FE_UNCONNECTED_2 en=en
+ n_in[4]=FE_OFN40_rom_n_idx_3__4 n_in[3]=FE_OFN89_rom_n_idx_3__3
+ n_in[2]=FE_OFN96_rom_n_idx_3__2 n_in[1]=rom_n_idx[1][1] n_in[0]=rom_n_idx[3][0]
+ k_idx[4]=FE_OFN90_rom_k_idx_3__4 k_idx[3]=FE_OFN91_rom_k_idx_3__3
+ k_idx[2]=FE_OFN92_rom_k_idx_3__2 k_idx[1]=FE_DBTN153_rom_k_idx_1_1
+ k_idx[0]=rom_k_idx[3][0] reg_sign1[1]=s11[1] reg_sign1[0]=s11[0]
+ reg_sign2[1]=s12[1] reg_sign2[0]=s12[0] reg_sign3[1]=s13[1] reg_sign3[0]=s13[0]
+ reg_shift1[3]=h11[3] reg_shift1[2]=h11[2] reg_shift1[1]=h11[1]
+ reg_shift1[0]=h11[0] reg_shift2[3]=h12[3] reg_shift2[2]=h12[2]
+ reg_shift2[1]=h12[1] reg_shift2[0]=h12[0] reg_shift3[3]=h13[3]
+ reg_shift3[2]=h13[2] reg_shift3[1]=h13[1] reg_shift3[0]=h13[0]
+ _rom_k_idx_1_1=rom_k_idx[1][1] i_rst_n=FE_OFN20_i_rst_n
+ FE_OFN86_n=FE_OFN96_rom_n_idx_3__2 clk=clk_clone9
Xrom2 ROM_Wrapper_Even_0 $PINS rst_n=FE_UNCONNECTED_2 en=en
+ n_in[4]=FE_OFN40_rom_n_idx_3__4 n_in[3]=FE_OFN89_rom_n_idx_3__3
+ n_in[2]=FE_OFN96_rom_n_idx_3__2 n_in[1]=rom_n_idx[3][1] n_in[0]=rom_n_idx[2][0]
+ k_idx[4]=FE_OFN90_rom_k_idx_3__4 k_idx[3]=FE_OFN91_rom_k_idx_3__3
+ k_idx[2]=FE_OFN92_rom_k_idx_3__2 k_idx[1]=FE_DBTN152_rom_k_idx_3_1
+ k_idx[0]=rom_k_idx[2][0] reg_sign1[1]=s21[1] reg_sign1[0]=s21[0]
+ reg_sign2[1]=s22[1] reg_sign2[0]=s22[0] reg_sign3[1]=s23[1] reg_sign3[0]=s23[0]
+ reg_shift1[3]=h21[3] reg_shift1[2]=h21[2] reg_shift1[1]=h21[1]
+ reg_shift1[0]=h21[0] reg_shift2[3]=h22[3] reg_shift2[2]=h22[2]
+ reg_shift2[1]=h22[1] reg_shift2[0]=h22[0] reg_shift3[3]=h23[3]
+ reg_shift3[2]=h23[2] reg_shift3[1]=h23[1] reg_shift3[0]=h23[0]
+ _rom_k_idx_3_1=rom_k_idx[3][1] i_rst_n=FE_OFN5_i_rst_n
+ FE_OFN24_i_rst_n=FE_OFN22_i_rst_n clk=clk_clone7
Xrom3 ROM_Wrapper_Odd_0 $PINS rst_n=FE_UNCONNECTED_2 en=en
+ n_in[4]=FE_OFN40_rom_n_idx_3__4 n_in[3]=FE_OFN89_rom_n_idx_3__3
+ n_in[2]=FE_OFN96_rom_n_idx_3__2 n_in[1]=rom_n_idx[3][1] n_in[0]=rom_n_idx[3][0]
+ k_idx[4]=FE_OFN90_rom_k_idx_3__4 k_idx[3]=FE_OFN91_rom_k_idx_3__3
+ k_idx[2]=FE_OFN92_rom_k_idx_3__2 k_idx[1]=FE_DBTN152_rom_k_idx_3_1
+ k_idx[0]=rom_k_idx[3][0] reg_sign1[1]=s31[1] reg_sign1[0]=s31[0]
+ reg_sign2[1]=s32[1] reg_sign2[0]=s32[0] reg_sign3[1]=s33[1] reg_sign3[0]=s33[0]
+ reg_shift1[3]=h31[3] reg_shift1[2]=h31[2] reg_shift1[1]=h31[1]
+ reg_shift1[0]=h31[0] reg_shift2[3]=h32[3] reg_shift2[2]=h32[2]
+ reg_shift2[1]=h32[1] reg_shift2[0]=h32[0] reg_shift3[3]=h33[3]
+ reg_shift3[2]=h33[2] reg_shift3[1]=h33[1] reg_shift3[0]=h33[0]
+ _rom_k_idx_3_1=rom_k_idx[3][1] i_rst_n=FE_OFN20_i_rst_n
+ FE_OFN32_i_rst_n=FE_OFN26_i_rst_n clk=clk_clone8
Xpe0_r PE_Shift_Add_7 $PINS rst_n=FE_UNCONNECTED_2 en=en
+ clear=FE_OFN30_pe_clear_d1 calc_done=pe_done stage_sel=FE_UNCONNECTED_1
+ x_in[16]=data_in_r[16] x_in[15]=data_in_r[15] x_in[14]=data_in_r[14]
+ x_in[13]=FE_OFN155_mac_in_real_13 x_in[12]=FE_OFN166_mac_in_real_12
+ x_in[11]=FE_OFN156_mac_in_real_11 x_in[10]=FE_OFN134_mac_in_real_10
+ x_in[9]=FE_OFN139_mac_in_real_9 x_in[8]=FE_OFN135_mac_in_real_8
+ x_in[7]=FE_OFN132_mac_in_real_7 x_in[6]=FE_OFN107_mac_in_real_6
+ x_in[5]=FE_OFN194_mac_in_real_5 x_in[4]=FE_OFN285_mac_in_real_4
+ x_in[3]=FE_OFN99_mac_in_real_3 x_in[2]=FE_OFN296_mac_in_real_2
+ x_in[1]=data_in_r[1] x_in[0]=data_in_r[0] sign1[1]=FE_OFN227_s01_1
+ sign1[0]=s01[0] sign2[1]=s02[1] sign2[0]=s02[0] sign3[1]=FE_OFN235_s03_1
+ sign3[0]=FE_OFN331_s03_0 shf1[3]=FE_OFN354_h01_3 shf1[2]=h01[2] shf1[1]=h01[1]
+ shf1[0]=h01[0] shf2[3]=h02[3] shf2[2]=h02[2] shf2[1]=FE_OFN185_h02_1
+ shf2[0]=h02[0] shf3[3]=h03[3] shf3[2]=h03[2] shf3[1]=FE_OFN278_h03_1
+ shf3[0]=h03[0] y_out[16]=y_out_0_r[16] y_out[15]=y_out_0_r[15]
+ y_out[14]=y_out_0_r[14] y_out[13]=y_out_0_r[13] y_out[12]=y_out_0_r[12]
+ y_out[11]=y_out_0_r[11] y_out[10]=y_out_0_r[10] y_out[9]=y_out_0_r[9]
+ y_out[8]=y_out_0_r[8] y_out[7]=y_out_0_r[7] y_out[6]=y_out_0_r[6]
+ y_out[5]=y_out_0_r[5] y_out[4]=y_out_0_r[4] y_out[3]=y_out_0_r[3]
+ y_out[2]=y_out_0_r[2] y_out[1]=y_out_0_r[1] y_out[0]=y_out_0_r[0]
+ n30=FE_OFN5_FE_DBTN15_n64 i_rst_n=FE_OFN10_i_rst_n
+ FE_OFN23_i_rst_n=FE_OFN22_i_rst_n FE_OFN22_i_rst_n=FE_OFN21_i_rst_n
+ FE_OFN15_i_rst_n=FE_OFN17_i_rst_n FE_OFN38_s01_0=s01[0] FE_OFN39_h01_3=h01[3]
+ FE_OFN40_h01_2=FE_OFN43_h01_2 FE_OFN41_s02_0=FE_OFN44_s02_0
+ FE_OFN42_h02_3=h02[3] FE_OFN43_h02_2=h02[2] FE_OFN44_s03_0=FE_OFN47_s03_0
+ FE_OFN45_h03_3=FE_OFN359_h03_3 FE_OFN46_h03_2=FE_OFN49_h03_2
+ FE_OFN81_h02_0=h02[0] FE_OFN89_h01_1=FE_OFN271_h01_1
+ FE_OFN90_h03_1=FE_OFN278_h03_1 FE_OFN93_s02_1=s02[1]
+ FE_OFN98_FE_OFN219_h01_0=FE_OFN363_FE_OFN219_h01_0
+ FE_OFN101_FE_OFN195_h02_0=FE_OFN364_FE_OFN195_h02_0
+ FE_OFN102_FE_OFN218_h03_0=FE_OFN365_FE_OFN218_h03_0 clk_clone2=clk_clone13
+ clk_clone1=clk_clone12 clk=CTS_14
Xpe0_i PE_Shift_Add_6 $PINS rst_n=FE_UNCONNECTED_2 en=en
+ clear=FE_OFN370_FE_OFN30_pe_clear_d1 calc_done=pe_done
+ stage_sel=FE_UNCONNECTED_1 x_in[16]=data_in_i[16] x_in[15]=data_in_i[15]
+ x_in[14]=FE_OFN164_mac_in_imag_14 x_in[13]=FE_OFN145_mac_in_imag_13
+ x_in[12]=FE_OFN141_mac_in_imag_12 x_in[11]=FE_OFN149_mac_in_imag_11
+ x_in[10]=FE_OFN120_mac_in_imag_10 x_in[9]=FE_OFN114_mac_in_imag_9
+ x_in[8]=FE_OFN131_mac_in_imag_8 x_in[7]=FE_OFN116_mac_in_imag_7
+ x_in[6]=FE_OFN109_mac_in_imag_6 x_in[5]=FE_OFN102_mac_in_imag_5
+ x_in[4]=FE_OFN288_mac_in_imag_4 x_in[3]=FE_OFN315_mac_in_imag_3
+ x_in[2]=FE_OFN104_mac_in_imag_2 x_in[1]=FE_OFN187_mac_in_imag_1
+ x_in[0]=FE_OFN283_mac_in_imag_0 sign1[1]=FE_OFN227_s01_1 sign1[0]=s01[0]
+ sign2[1]=s02[1] sign2[0]=FE_OFN44_s02_0 sign3[1]=FE_OFN235_s03_1
+ sign3[0]=FE_OFN47_s03_0 shf1[3]=FE_OFN354_h01_3 shf1[2]=FE_OFN43_h01_2
+ shf1[1]=FE_OFN271_h01_1 shf1[0]=h01[0] shf2[3]=h02[3] shf2[2]=h02[2]
+ shf2[1]=FE_OFN185_h02_1 shf2[0]=h02[0] shf3[3]=FE_OFN359_h03_3
+ shf3[2]=FE_OFN49_h03_2 shf3[1]=FE_OFN278_h03_1 shf3[0]=h03[0]
+ y_out[16]=y_out_0_i[16] y_out[15]=y_out_0_i[15] y_out[14]=y_out_0_i[14]
+ y_out[13]=y_out_0_i[13] y_out[12]=y_out_0_i[12] y_out[11]=y_out_0_i[11]
+ y_out[10]=y_out_0_i[10] y_out[9]=y_out_0_i[9] y_out[8]=y_out_0_i[8]
+ y_out[7]=y_out_0_i[7] y_out[6]=y_out_0_i[6] y_out[5]=y_out_0_i[5]
+ y_out[4]=y_out_0_i[4] y_out[3]=y_out_0_i[3] y_out[2]=y_out_0_i[2]
+ y_out[1]=y_out_0_i[1] y_out[0]=y_out_0_i[0] p_1=FE_OFN2_FE_DBTN15_n64
+ i_rst_n=i_rst_n FE_OFN12_i_rst_n=FE_OFN11_i_rst_n
+ FE_OFN10_i_rst_n=FE_OFN12_i_rst_n FE_OFN6_i_rst_n=FE_OFN10_i_rst_n
+ FE_OFN96_s03_0=FE_OFN331_s03_0
+ FE_OFN99_FE_OFN219_h01_0=FE_OFN363_FE_OFN219_h01_0
+ FE_OFN100_FE_OFN195_h02_0=FE_OFN364_FE_OFN195_h02_0
+ FE_OFN103_FE_OFN218_h03_0=FE_OFN365_FE_OFN218_h03_0 clk_clone1=CTS_14
+ clk_clone2=CTS_13 clk=clk_clone7
Xpe1_r PE_Shift_Add_5 $PINS rst_n=FE_UNCONNECTED_2 en=en
+ clear=FE_OFN30_pe_clear_d1 calc_done=pe_done stage_sel=FE_UNCONNECTED_1
+ x_in[16]=data_in_r[16] x_in[15]=data_in_r[15] x_in[14]=data_in_r[14]
+ x_in[13]=FE_OFN155_mac_in_real_13 x_in[12]=FE_OFN166_mac_in_real_12
+ x_in[11]=FE_OFN156_mac_in_real_11 x_in[10]=FE_OFN134_mac_in_real_10
+ x_in[9]=FE_OFN139_mac_in_real_9 x_in[8]=FE_OFN135_mac_in_real_8
+ x_in[7]=FE_OFN132_mac_in_real_7 x_in[6]=FE_OFN107_mac_in_real_6
+ x_in[5]=FE_OFN194_mac_in_real_5 x_in[4]=FE_OFN285_mac_in_real_4
+ x_in[3]=FE_OFN100_mac_in_real_3 x_in[2]=data_in_r[2] x_in[1]=data_in_r[1]
+ x_in[0]=data_in_r[0] sign1[1]=FE_OFN232_s11_1 sign1[0]=FE_OFN50_s11_0
+ sign2[1]=s12[1] sign2[0]=s12[0] sign3[1]=FE_OFN233_s13_1 sign3[0]=s13[0]
+ shf1[3]=h11[3] shf1[2]=h11[2] shf1[1]=h11[1] shf1[0]=FE_OFN255_h11_0
+ shf2[3]=h12[3] shf2[2]=h12[2] shf2[1]=FE_OFN254_h12_1 shf2[0]=h12[0]
+ shf3[3]=FE_OFN58_h13_3 shf3[2]=h13[2] shf3[1]=FE_OFN190_h13_1 shf3[0]=h13[0]
+ y_out[16]=y_out_1_r[16] y_out[15]=y_out_1_r[15] y_out[14]=y_out_1_r[14]
+ y_out[13]=y_out_1_r[13] y_out[12]=y_out_1_r[12] y_out[11]=y_out_1_r[11]
+ y_out[10]=y_out_1_r[10] y_out[9]=y_out_1_r[9] y_out[8]=y_out_1_r[8]
+ y_out[7]=y_out_1_r[7] y_out[6]=y_out_1_r[6] y_out[5]=y_out_1_r[5]
+ y_out[4]=y_out_1_r[4] y_out[3]=y_out_1_r[3] y_out[2]=y_out_1_r[2]
+ y_out[1]=y_out_1_r[1] y_out[0]=y_out_1_r[0] n30=FE_RN_1
+ i_rst_n=FE_OFN19_i_rst_n FE_OFN35_i_rst_n=FE_OFN29_i_rst_n
+ FE_OFN30_i_rst_n=FE_OFN28_i_rst_n FE_OFN21_i_rst_n=FE_OFN20_i_rst_n
+ FE_OFN47_s11_0=s11[0] FE_OFN48_h11_3=h11[3] FE_OFN49_h11_2=FE_OFN52_h11_2
+ FE_OFN50_h12_3=h12[3] FE_OFN51_h12_2=FE_OFN56_h12_2
+ FE_OFN52_h13_3=FE_OFN58_h13_3 FE_OFN53_h13_2=FE_OFN59_h13_2
+ FE_OFN82_mac_in_real_0=data_in_r[0] FE_OFN97_h11_3=FE_OFN344_h11_3
+ FE_OFN104_FE_OFN232_s11_1=FE_OFN367_FE_OFN232_s11_1 clk_clone2=clk_clone6
+ clk=clk_clone2 clk_clone1=clk_clone3
Xpe1_i PE_Shift_Add_4 $PINS rst_n=FE_UNCONNECTED_2 en=en
+ clear=FE_OFN30_pe_clear_d1 calc_done=pe_done stage_sel=stage_sel
+ x_in[16]=data_in_i[16] x_in[15]=data_in_i[15] x_in[14]=FE_OFN164_mac_in_imag_14
+ x_in[13]=FE_OFN145_mac_in_imag_13 x_in[12]=FE_OFN141_mac_in_imag_12
+ x_in[11]=FE_OFN149_mac_in_imag_11 x_in[10]=FE_OFN120_mac_in_imag_10
+ x_in[9]=FE_OFN114_mac_in_imag_9 x_in[8]=FE_OFN131_mac_in_imag_8
+ x_in[7]=FE_OFN116_mac_in_imag_7 x_in[6]=FE_OFN109_mac_in_imag_6
+ x_in[5]=FE_OFN102_mac_in_imag_5 x_in[4]=data_in_i[4]
+ x_in[3]=FE_OFN315_mac_in_imag_3 x_in[2]=FE_OFN104_mac_in_imag_2
+ x_in[1]=data_in_i[1] x_in[0]=data_in_i[0] sign1[1]=FE_OFN232_s11_1
+ sign1[0]=FE_OFN50_s11_0 sign2[1]=s12[1] sign2[0]=s12[0]
+ sign3[1]=FE_OFN233_s13_1 sign3[0]=s13[0] shf1[3]=h11[3] shf1[2]=FE_OFN52_h11_2
+ shf1[1]=h11[1] shf1[0]=FE_OFN255_h11_0 shf2[3]=h12[3] shf2[2]=FE_OFN56_h12_2
+ shf2[1]=FE_OFN254_h12_1 shf2[0]=h12[0] shf3[3]=FE_OFN58_h13_3 shf3[2]=h13[2]
+ shf3[1]=FE_OFN190_h13_1 shf3[0]=h13[0] y_out[16]=y_out_1_i[16]
+ y_out[15]=y_out_1_i[15] y_out[14]=y_out_1_i[14] y_out[13]=y_out_1_i[13]
+ y_out[12]=y_out_1_i[12] y_out[11]=y_out_1_i[11] y_out[10]=y_out_1_i[10]
+ y_out[9]=y_out_1_i[9] y_out[8]=y_out_1_i[8] y_out[7]=y_out_1_i[7]
+ y_out[6]=y_out_1_i[6] y_out[5]=y_out_1_i[5] y_out[4]=y_out_1_i[4]
+ y_out[3]=y_out_1_i[3] y_out[2]=y_out_1_i[2] y_out[1]=y_out_1_i[1]
+ y_out[0]=y_out_1_i[0] i_rst_n=FE_OFN14_i_rst_n FE_OFN1_FE_DBTN15_n64=FE_RN_1
+ FE_OFN36_i_rst_n=FE_OFN29_i_rst_n FE_OFN33_i_rst_n=FE_OFN27_i_rst_n
+ FE_OFN29_i_rst_n=FE_OFN28_i_rst_n FE_OFN20_i_rst_n=FE_OFN19_i_rst_n
+ FE_OFN187_mac_in_imag_1=FE_OFN187_mac_in_imag_1
+ FE_OFN283_mac_in_imag_0=FE_OFN283_mac_in_imag_0 clk_clone2=clk_clone6
+ clk=clk_clone2 clk_clone1=clk_clone3
Xpe2_r PE_Shift_Add_3 $PINS rst_n=FE_UNCONNECTED_2 en=en
+ clear=FE_OFN370_FE_OFN30_pe_clear_d1 calc_done=pe_done
+ stage_sel=FE_UNCONNECTED_1 x_in[16]=data_in_r[16] x_in[15]=data_in_r[15]
+ x_in[14]=data_in_r[14] x_in[13]=FE_OFN155_mac_in_real_13
+ x_in[12]=FE_OFN166_mac_in_real_12 x_in[11]=FE_OFN156_mac_in_real_11
+ x_in[10]=FE_OFN134_mac_in_real_10 x_in[9]=FE_OFN139_mac_in_real_9
+ x_in[8]=FE_OFN135_mac_in_real_8 x_in[7]=FE_OFN132_mac_in_real_7
+ x_in[6]=FE_OFN107_mac_in_real_6 x_in[5]=FE_OFN194_mac_in_real_5
+ x_in[4]=FE_OFN285_mac_in_real_4 x_in[3]=FE_OFN99_mac_in_real_3
+ x_in[2]=FE_OFN296_mac_in_real_2 x_in[1]=data_in_r[1] x_in[0]=data_in_r[0]
+ sign1[1]=FE_OFN241_s21_1 sign1[0]=FE_OFN270_s21_0 sign2[1]=FE_OFN245_s22_1
+ sign2[0]=s22[0] sign3[1]=s23[1] sign3[0]=FE_OFN237_s23_0 shf1[3]=FE_OFN61_h21_3
+ shf1[2]=FE_OFN282_h21_2 shf1[1]=h21[1] shf1[0]=h21[0] shf2[3]=FE_OFN64_h22_3
+ shf2[2]=h22[2] shf2[1]=FE_OFN201_h22_1 shf2[0]=h22[0] shf3[3]=h23[3]
+ shf3[2]=h23[2] shf3[1]=h23[1] shf3[0]=FE_OFN217_h23_0 y_out[16]=y_out_2_r[16]
+ y_out[15]=y_out_2_r[15] y_out[14]=y_out_2_r[14] y_out[13]=y_out_2_r[13]
+ y_out[12]=y_out_2_r[12] y_out[11]=y_out_2_r[11] y_out[10]=y_out_2_r[10]
+ y_out[9]=y_out_2_r[9] y_out[8]=y_out_2_r[8] y_out[7]=y_out_2_r[7]
+ y_out[6]=y_out_2_r[6] y_out[5]=y_out_2_r[5] y_out[4]=y_out_2_r[4]
+ y_out[3]=y_out_2_r[3] y_out[2]=y_out_2_r[2] y_out[1]=y_out_2_r[1]
+ y_out[0]=y_out_2_r[0] n30=FE_OFN5_FE_DBTN15_n64 i_rst_n=FE_OFN5_i_rst_n
+ FE_OFN4_FE_DBTN15_n64=stage_sel FE_OFN3_FE_DBTN15_n64=FE_OFN2_FE_DBTN15_n64
+ FE_OFN16_i_rst_n=FE_OFN17_i_rst_n FE_OFN13_i_rst_n=FE_OFN11_i_rst_n
+ FE_OFN7_i_rst_n=FE_OFN10_i_rst_n FE_OFN54_s21_0=FE_OFN60_s21_0
+ FE_OFN55_h21_3=h21[3] FE_OFN56_h21_2=FE_OFN62_h21_2 FE_OFN57_h22_3=h22[3]
+ FE_OFN58_h22_2=h22[2] FE_OFN59_h23_3=FE_OFN67_h23_3 FE_OFN60_h23_2=h23[2]
+ FE_OFN80_s22_0=s22[0] FE_OFN84_s23_1=FE_OFN243_s23_1
+ FE_OFN91_h21_1=FE_OFN257_h21_1 FE_OFN94_h23_1=FE_OFN317_h23_1 clk_clone3=CTS_13
+ clk_clone2=CTS_14 clk=clk_clone5 clk_clone1=clk_clone7
Xpe2_i PE_Shift_Add_2 $PINS rst_n=FE_UNCONNECTED_2 en=en
+ clear=FE_OFN370_FE_OFN30_pe_clear_d1 calc_done=pe_done
+ stage_sel=FE_OFN2_FE_DBTN15_n64 x_in[16]=data_in_i[16] x_in[15]=data_in_i[15]
+ x_in[14]=FE_OFN164_mac_in_imag_14 x_in[13]=FE_OFN145_mac_in_imag_13
+ x_in[12]=FE_OFN141_mac_in_imag_12 x_in[11]=FE_OFN149_mac_in_imag_11
+ x_in[10]=FE_OFN120_mac_in_imag_10 x_in[9]=FE_OFN114_mac_in_imag_9
+ x_in[8]=FE_OFN131_mac_in_imag_8 x_in[7]=FE_OFN116_mac_in_imag_7
+ x_in[6]=FE_OFN109_mac_in_imag_6 x_in[5]=FE_OFN102_mac_in_imag_5
+ x_in[4]=FE_OFN288_mac_in_imag_4 x_in[3]=FE_OFN315_mac_in_imag_3
+ x_in[2]=FE_OFN104_mac_in_imag_2 x_in[1]=FE_OFN187_mac_in_imag_1
+ x_in[0]=FE_OFN283_mac_in_imag_0 sign1[1]=FE_OFN241_s21_1
+ sign1[0]=FE_OFN270_s21_0 sign2[1]=FE_OFN245_s22_1 sign2[0]=s22[0]
+ sign3[1]=FE_OFN243_s23_1 sign3[0]=FE_OFN237_s23_0 shf1[3]=FE_OFN61_h21_3
+ shf1[2]=FE_OFN282_h21_2 shf1[1]=h21[1] shf1[0]=h21[0] shf2[3]=FE_OFN64_h22_3
+ shf2[2]=h22[2] shf2[1]=FE_OFN201_h22_1 shf2[0]=h22[0] shf3[3]=h23[3]
+ shf3[2]=h23[2] shf3[1]=h23[1] shf3[0]=FE_OFN217_h23_0 y_out[16]=y_out_2_i[16]
+ y_out[15]=y_out_2_i[15] y_out[14]=y_out_2_i[14] y_out[13]=y_out_2_i[13]
+ y_out[12]=y_out_2_i[12] y_out[11]=y_out_2_i[11] y_out[10]=y_out_2_i[10]
+ y_out[9]=y_out_2_i[9] y_out[8]=y_out_2_i[8] y_out[7]=y_out_2_i[7]
+ y_out[6]=y_out_2_i[6] y_out[5]=y_out_2_i[5] y_out[4]=y_out_2_i[4]
+ y_out[3]=y_out_2_i[3] y_out[2]=y_out_2_i[2] y_out[1]=y_out_2_i[1]
+ y_out[0]=y_out_2_i[0] i_rst_n=i_rst_n FE_OFN9_i_rst_n=FE_OFN12_i_rst_n
+ FE_OFN92_h21_1=FE_OFN257_h21_1 FE_OFN95_h23_1=FE_OFN317_h23_1 clk_clone2=CTS_13
+ clk_clone1=clk_clone10 clk=clk_clone5
Xpe3_r PE_Shift_Add_1 $PINS rst_n=FE_UNCONNECTED_2 en=en
+ clear=FE_OFN30_pe_clear_d1 calc_done=pe_done stage_sel=FE_UNCONNECTED_1
+ x_in[16]=data_in_r[16] x_in[15]=data_in_r[15] x_in[14]=data_in_r[14]
+ x_in[13]=FE_OFN155_mac_in_real_13 x_in[12]=FE_OFN166_mac_in_real_12
+ x_in[11]=FE_OFN156_mac_in_real_11 x_in[10]=FE_OFN134_mac_in_real_10
+ x_in[9]=FE_OFN139_mac_in_real_9 x_in[8]=FE_OFN135_mac_in_real_8
+ x_in[7]=FE_OFN132_mac_in_real_7 x_in[6]=FE_OFN107_mac_in_real_6
+ x_in[5]=FE_OFN194_mac_in_real_5 x_in[4]=FE_OFN285_mac_in_real_4
+ x_in[3]=FE_OFN100_mac_in_real_3 x_in[2]=data_in_r[2] x_in[1]=data_in_r[1]
+ x_in[0]=data_in_r[0] sign1[1]=s31[1] sign1[0]=FE_OFN244_s31_0 sign2[1]=s32[1]
+ sign2[0]=s32[0] sign3[1]=s33[1] sign3[0]=FE_OFN256_s33_0 shf1[3]=h31[3]
+ shf1[2]=h31[2] shf1[1]=h31[1] shf1[0]=h31[0] shf2[3]=h32[3] shf2[2]=h32[2]
+ shf2[1]=h32[1] shf2[0]=h32[0] shf3[3]=h33[3] shf3[2]=h33[2] shf3[1]=h33[1]
+ shf3[0]=h33[0] y_out[16]=y_out_3_r[16] y_out[15]=y_out_3_r[15]
+ y_out[14]=y_out_3_r[14] y_out[13]=y_out_3_r[13] y_out[12]=y_out_3_r[12]
+ y_out[11]=y_out_3_r[11] y_out[10]=y_out_3_r[10] y_out[9]=y_out_3_r[9]
+ y_out[8]=y_out_3_r[8] y_out[7]=y_out_3_r[7] y_out[6]=y_out_3_r[6]
+ y_out[5]=y_out_3_r[5] y_out[4]=y_out_3_r[4] y_out[3]=y_out_3_r[3]
+ y_out[2]=y_out_3_r[2] y_out[1]=y_out_3_r[1] y_out[0]=y_out_3_r[0]
+ n30=FE_OFN3_FE_DBTN15_n64 i_rst_n=FE_OFN18_i_rst_n
+ FE_OFN31_i_rst_n=FE_OFN26_i_rst_n FE_OFN26_i_rst_n=FE_OFN23_i_rst_n
+ FE_OFN61_s31_0=FE_OFN69_s31_0 FE_OFN62_h31_3=FE_OFN70_h31_3
+ FE_OFN63_h31_2=FE_OFN71_h31_2 FE_OFN64_s32_0=s32[0] FE_OFN65_h32_3=h32[3]
+ FE_OFN66_h32_2=FE_OFN74_h32_2 FE_OFN67_h33_3=FE_OFN76_h33_3
+ FE_OFN68_h33_2=h33[2] FE_OFN85_s32_1=FE_OFN250_s32_1
+ FE_OFN87_s31_1=FE_OFN262_s31_1 FE_OFN88_s33_1=FE_OFN266_s33_1
+ clk_clone1=clk_clone1 clk=clk clk_clone2=clk_clone3
Xpe3_i PE_Shift_Add_0 $PINS rst_n=FE_UNCONNECTED_2 en=en
+ clear=FE_OFN30_pe_clear_d1 calc_done=pe_done stage_sel=FE_UNCONNECTED_1
+ x_in[16]=data_in_i[16] x_in[15]=data_in_i[15] x_in[14]=FE_OFN164_mac_in_imag_14
+ x_in[13]=FE_OFN145_mac_in_imag_13 x_in[12]=FE_OFN141_mac_in_imag_12
+ x_in[11]=FE_OFN149_mac_in_imag_11 x_in[10]=FE_OFN120_mac_in_imag_10
+ x_in[9]=FE_OFN114_mac_in_imag_9 x_in[8]=FE_OFN131_mac_in_imag_8
+ x_in[7]=FE_OFN116_mac_in_imag_7 x_in[6]=data_in_i[6] x_in[5]=data_in_i[5]
+ x_in[4]=data_in_i[4] x_in[3]=FE_OFN315_mac_in_imag_3
+ x_in[2]=FE_OFN104_mac_in_imag_2 x_in[1]=data_in_i[1] x_in[0]=data_in_i[0]
+ sign1[1]=FE_OFN262_s31_1 sign1[0]=FE_OFN244_s31_0 sign2[1]=FE_OFN250_s32_1
+ sign2[0]=s32[0] sign3[1]=FE_OFN266_s33_1 sign3[0]=FE_OFN256_s33_0
+ shf1[3]=h31[3] shf1[2]=h31[2] shf1[1]=h31[1] shf1[0]=h31[0] shf2[3]=h32[3]
+ shf2[2]=h32[2] shf2[1]=h32[1] shf2[0]=h32[0] shf3[3]=h33[3] shf3[2]=h33[2]
+ shf3[1]=h33[1] shf3[0]=h33[0] y_out[16]=y_out_3_i[16] y_out[15]=y_out_3_i[15]
+ y_out[14]=y_out_3_i[14] y_out[13]=y_out_3_i[13] y_out[12]=y_out_3_i[12]
+ y_out[11]=y_out_3_i[11] y_out[10]=y_out_3_i[10] y_out[9]=y_out_3_i[9]
+ y_out[8]=y_out_3_i[8] y_out[7]=y_out_3_i[7] y_out[6]=y_out_3_i[6]
+ y_out[5]=y_out_3_i[5] y_out[4]=y_out_3_i[4] y_out[3]=y_out_3_i[3]
+ y_out[2]=y_out_3_i[2] y_out[1]=y_out_3_i[1] y_out[0]=y_out_3_i[0]
+ n30=FE_OFN3_FE_DBTN15_n64 i_rst_n=FE_OFN14_i_rst_n
+ FE_OFN2_FE_DBTN15_n64=FE_OFN1_FE_DBTN15_n64 FE_OFN34_i_rst_n=FE_OFN27_i_rst_n
+ FE_OFN25_i_rst_n=FE_OFN23_i_rst_n FE_OFN17_i_rst_n=FE_OFN18_i_rst_n
+ FE_OFN187_mac_in_imag_1=FE_OFN187_mac_in_imag_1
+ FE_OFN109_mac_in_imag_6=FE_OFN109_mac_in_imag_6
+ FE_OFN102_mac_in_imag_5=FE_OFN102_mac_in_imag_5 clk_clone2=clk_clone11
+ clk_clone1=clk_clone1 clk=clk
.ENDS

.SUBCKT SNPS_CLOCK_GATE_HIGH_RegFileDual_DATA_WIDTH34_0 EN ENCLK CLK
*.CONNECT net1844 EN
XFE_PHC964_net1847 DELC $PINS O=FE_PHN964_net1847 I=net1847
Xlatch QDBHN $PINS Q=net1847 D=net1844 CKB=CLK
Xmain_gate AN2T $PINS O=ENCLK I1=FE_PHN964_net1847 I2=CLK
.ENDS

.SUBCKT SNPS_CLOCK_GATE_HIGH_RegFileDual_DATA_WIDTH34_63 CLK EN ENCLK
+ CLK_clone1
*.CONNECT net1841 CLK
*.CONNECT net1844 EN
XFE_PHC972_net1847 DELC $PINS O=FE_PHN972_net1847 I=net1847
Xlatch QDBHN $PINS Q=net1847 D=net1844 CKB=CLK_clone1
Xmain_gate AN2T $PINS O=ENCLK I1=FE_PHN972_net1847 I2=net1841
.ENDS

.SUBCKT SNPS_CLOCK_GATE_HIGH_RegFileDual_DATA_WIDTH34_62 EN ENCLK CLK
*.CONNECT net1844 EN
XFE_PHC877_net1847 DELC $PINS O=FE_PHN877_net1847 I=net1847
Xlatch QDBHN $PINS Q=net1847 D=net1844 CKB=CLK
Xmain_gate AN2T $PINS O=ENCLK I1=FE_PHN877_net1847 I2=CLK
.ENDS

.SUBCKT SNPS_CLOCK_GATE_HIGH_RegFileDual_DATA_WIDTH34_61 CLK EN ENCLK
+ CLK_clone1
*.CONNECT net1841 CLK
*.CONNECT net1844 EN
XFE_PHC927_net1847 DELC $PINS O=net1847 I=FE_PHN927_net1847
Xlatch QDBHN $PINS Q=FE_PHN927_net1847 D=net1844 CKB=CLK_clone1
Xmain_gate AN2T $PINS O=ENCLK I1=net1847 I2=net1841
.ENDS

.SUBCKT SNPS_CLOCK_GATE_HIGH_RegFileDual_DATA_WIDTH34_60 EN ENCLK CLK
*.CONNECT net1844 EN
XFE_PHC886_net1847 DELC $PINS O=FE_PHN886_net1847 I=net1847
Xlatch QDBHN $PINS Q=net1847 D=net1844 CKB=CLK
Xmain_gate AN2T $PINS O=ENCLK I1=FE_PHN886_net1847 I2=CLK
.ENDS

.SUBCKT SNPS_CLOCK_GATE_HIGH_RegFileDual_DATA_WIDTH34_59 CLK EN ENCLK
+ CLK_clone1
*.CONNECT net1841 CLK
*.CONNECT net1844 EN
XFE_PHC909_net1847 DELC $PINS O=net1847 I=FE_PHN909_net1847
Xlatch QDBHN $PINS Q=FE_PHN909_net1847 D=net1844 CKB=CLK_clone1
Xmain_gate AN2T $PINS O=ENCLK I1=net1847 I2=net1841
.ENDS

.SUBCKT SNPS_CLOCK_GATE_HIGH_RegFileDual_DATA_WIDTH34_58 EN ENCLK CLK
*.CONNECT net1844 EN
XFE_PHC899_net1847 DELC $PINS O=net1847 I=FE_PHN899_net1847
Xlatch QDBHN $PINS Q=FE_PHN899_net1847 D=net1844 CKB=CLK
Xmain_gate AN2T $PINS O=ENCLK I1=net1847 I2=CLK
.ENDS

.SUBCKT SNPS_CLOCK_GATE_HIGH_RegFileDual_DATA_WIDTH34_57 CLK EN ENCLK
+ CLK_clone1
*.CONNECT net1841 CLK
*.CONNECT net1844 EN
XFE_PHC921_net1847 DELC $PINS O=FE_PHN921_net1847 I=net1847
Xlatch QDBHN $PINS Q=net1847 D=net1844 CKB=CLK_clone1
Xmain_gate AN2T $PINS O=ENCLK I1=FE_PHN921_net1847 I2=net1841
.ENDS

.SUBCKT SNPS_CLOCK_GATE_HIGH_RegFileDual_DATA_WIDTH34_56 CLK EN ENCLK
+ CLK_clone1
*.CONNECT net1841 CLK
*.CONNECT net1844 EN
XFE_PHC932_net1847 DELC $PINS O=FE_PHN932_net1847 I=net1847
Xlatch QDBHN $PINS Q=net1847 D=net1844 CKB=CLK_clone1
Xmain_gate AN2T $PINS O=ENCLK I1=FE_PHN932_net1847 I2=net1841
.ENDS

.SUBCKT SNPS_CLOCK_GATE_HIGH_RegFileDual_DATA_WIDTH34_55 EN ENCLK CLK
*.CONNECT net1844 EN
XFE_PHC966_net1847 DELC $PINS O=net1847 I=FE_PHN966_net1847
Xlatch QDBHN $PINS Q=FE_PHN966_net1847 D=net1844 CKB=CLK
Xmain_gate AN2T $PINS O=ENCLK I1=net1847 I2=CLK
.ENDS

.SUBCKT SNPS_CLOCK_GATE_HIGH_RegFileDual_DATA_WIDTH34_54 EN ENCLK CLK
*.CONNECT net1844 EN
XFE_PHC955_net1847 DELC $PINS O=FE_PHN955_net1847 I=net1847
Xlatch QDBHN $PINS Q=net1847 D=net1844 CKB=CLK
Xmain_gate AN2T $PINS O=ENCLK I1=FE_PHN955_net1847 I2=CLK
.ENDS

.SUBCKT SNPS_CLOCK_GATE_HIGH_RegFileDual_DATA_WIDTH34_53 EN ENCLK CLK
*.CONNECT net1844 EN
XFE_PHC983_net1847 DELC $PINS O=net1847 I=FE_PHN983_net1847
Xlatch QDBHN $PINS Q=FE_PHN983_net1847 D=net1844 CKB=CLK
Xmain_gate AN2T $PINS O=ENCLK I1=net1847 I2=CLK
.ENDS

.SUBCKT SNPS_CLOCK_GATE_HIGH_RegFileDual_DATA_WIDTH34_52 EN ENCLK CLK
*.CONNECT net1844 EN
XFE_PHC956_net1847 DELC $PINS O=FE_PHN956_net1847 I=net1847
Xlatch QDBHN $PINS Q=net1847 D=net1844 CKB=CLK
Xmain_gate AN2T $PINS O=ENCLK I1=FE_PHN956_net1847 I2=CLK
.ENDS

.SUBCKT SNPS_CLOCK_GATE_HIGH_RegFileDual_DATA_WIDTH34_51 EN ENCLK CLK
*.CONNECT net1844 EN
XFE_PHC976_net1847 DELC $PINS O=FE_PHN976_net1847 I=net1847
Xlatch QDBHN $PINS Q=net1847 D=net1844 CKB=CLK
Xmain_gate AN2T $PINS O=ENCLK I1=FE_PHN976_net1847 I2=CLK
.ENDS

.SUBCKT SNPS_CLOCK_GATE_HIGH_RegFileDual_DATA_WIDTH34_50 EN ENCLK CLK
*.CONNECT net1844 EN
XFE_PHC904_net1847 DELC $PINS O=FE_PHN904_net1847 I=net1847
Xlatch QDBHN $PINS Q=net1847 D=net1844 CKB=CLK
Xmain_gate AN2T $PINS O=ENCLK I1=FE_PHN904_net1847 I2=CLK
.ENDS

.SUBCKT SNPS_CLOCK_GATE_HIGH_RegFileDual_DATA_WIDTH34_49 EN ENCLK CLK
*.CONNECT net1844 EN
XFE_PHC922_net1847 DELC $PINS O=FE_PHN922_net1847 I=net1847
Xlatch QDBHN $PINS Q=net1847 D=net1844 CKB=CLK
Xmain_gate AN2T $PINS O=ENCLK I1=FE_PHN922_net1847 I2=CLK
.ENDS

.SUBCKT SNPS_CLOCK_GATE_HIGH_RegFileDual_DATA_WIDTH34_48 EN ENCLK CLK
*.CONNECT net1844 EN
XFE_PHC898_net1847 DELC $PINS O=net1847 I=FE_PHN898_net1847
Xlatch QDBHN $PINS Q=FE_PHN898_net1847 D=net1844 CKB=CLK
Xmain_gate AN2T $PINS O=ENCLK I1=net1847 I2=CLK
.ENDS

.SUBCKT SNPS_CLOCK_GATE_HIGH_RegFileDual_DATA_WIDTH34_47 EN ENCLK CLK
*.CONNECT net1844 EN
XFE_PHC1003_net1847 DELC $PINS O=net1847 I=FE_PHN1003_net1847
Xlatch QDBHN $PINS Q=FE_PHN1003_net1847 D=net1844 CKB=CLK
Xmain_gate AN2T $PINS O=ENCLK I1=net1847 I2=CLK
.ENDS

.SUBCKT SNPS_CLOCK_GATE_HIGH_RegFileDual_DATA_WIDTH34_46 EN ENCLK CLK
*.CONNECT net1844 EN
XFE_PHC945_net1847 DELC $PINS O=FE_PHN945_net1847 I=net1847
Xlatch QDBHN $PINS Q=net1847 D=net1844 CKB=CLK
Xmain_gate AN2T $PINS O=ENCLK I1=FE_PHN945_net1847 I2=CLK
.ENDS

.SUBCKT SNPS_CLOCK_GATE_HIGH_RegFileDual_DATA_WIDTH34_45 EN ENCLK CLK
*.CONNECT net1844 EN
XFE_PHC935_net1847 DELC $PINS O=FE_PHN935_net1847 I=net1847
Xlatch QDBHN $PINS Q=net1847 D=net1844 CKB=CLK
Xmain_gate AN2T $PINS O=ENCLK I1=FE_PHN935_net1847 I2=CLK
.ENDS

.SUBCKT SNPS_CLOCK_GATE_HIGH_RegFileDual_DATA_WIDTH34_44 EN ENCLK CLK
*.CONNECT net1844 EN
XFE_PHC988_net1847 DELC $PINS O=FE_PHN988_net1847 I=net1847
Xlatch QDBHN $PINS Q=net1847 D=net1844 CKB=CLK
Xmain_gate AN2T $PINS O=ENCLK I1=FE_PHN988_net1847 I2=CLK
.ENDS

.SUBCKT SNPS_CLOCK_GATE_HIGH_RegFileDual_DATA_WIDTH34_43 EN ENCLK CLK
*.CONNECT net1844 EN
XFE_PHC934_net1847 DELC $PINS O=net1847 I=FE_PHN934_net1847
Xlatch QDBHN $PINS Q=FE_PHN934_net1847 D=net1844 CKB=CLK
Xmain_gate AN2T $PINS O=ENCLK I1=net1847 I2=CLK
.ENDS

.SUBCKT SNPS_CLOCK_GATE_HIGH_RegFileDual_DATA_WIDTH34_42 EN ENCLK CLK
*.CONNECT net1844 EN
XFE_PHC951_net1847 DELC $PINS O=net1847 I=FE_PHN951_net1847
Xlatch QDBHN $PINS Q=FE_PHN951_net1847 D=net1844 CKB=CLK
Xmain_gate AN2T $PINS O=ENCLK I1=net1847 I2=CLK
.ENDS

.SUBCKT SNPS_CLOCK_GATE_HIGH_RegFileDual_DATA_WIDTH34_41 EN ENCLK CLK
*.CONNECT net1844 EN
XFE_PHC893_net1847 DELC $PINS O=FE_PHN893_net1847 I=net1847
Xlatch QDBHN $PINS Q=net1847 D=net1844 CKB=CLK
Xmain_gate AN2T $PINS O=ENCLK I1=FE_PHN893_net1847 I2=CLK
.ENDS

.SUBCKT SNPS_CLOCK_GATE_HIGH_RegFileDual_DATA_WIDTH34_40 EN ENCLK CLK
*.CONNECT net1844 EN
XFE_PHC912_net1847 DELC $PINS O=net1847 I=FE_PHN912_net1847
Xlatch QDBHN $PINS Q=FE_PHN912_net1847 D=net1844 CKB=CLK
Xmain_gate AN2T $PINS O=ENCLK I1=net1847 I2=CLK
.ENDS

.SUBCKT SNPS_CLOCK_GATE_HIGH_RegFileDual_DATA_WIDTH34_39 EN ENCLK CLK
*.CONNECT net1844 EN
XFE_PHC917_net1847 DELC $PINS O=FE_PHN917_net1847 I=net1847
Xlatch QDBHN $PINS Q=net1847 D=net1844 CKB=CLK
Xmain_gate AN2T $PINS O=ENCLK I1=FE_PHN917_net1847 I2=CLK
.ENDS

.SUBCKT SNPS_CLOCK_GATE_HIGH_RegFileDual_DATA_WIDTH34_38 EN ENCLK CLK
*.CONNECT net1844 EN
XFE_PHC996_net1847 DELC $PINS O=FE_PHN996_net1847 I=net1847
Xlatch QDBHN $PINS Q=net1847 D=net1844 CKB=CLK
Xmain_gate AN2T $PINS O=ENCLK I1=FE_PHN996_net1847 I2=CLK
.ENDS

.SUBCKT SNPS_CLOCK_GATE_HIGH_RegFileDual_DATA_WIDTH34_37 EN ENCLK CLK
*.CONNECT net1844 EN
XFE_PHC963_net1847 DELC $PINS O=net1847 I=FE_PHN963_net1847
Xlatch QDBHN $PINS Q=FE_PHN963_net1847 D=net1844 CKB=CLK
Xmain_gate AN2T $PINS O=ENCLK I1=net1847 I2=CLK
.ENDS

.SUBCKT SNPS_CLOCK_GATE_HIGH_RegFileDual_DATA_WIDTH34_36 EN ENCLK CLK
*.CONNECT net1844 EN
XFE_PHC1001_net1847 DELC $PINS O=net1847 I=FE_PHN1001_net1847
Xlatch QDBHN $PINS Q=FE_PHN1001_net1847 D=net1844 CKB=CLK
Xmain_gate AN2T $PINS O=ENCLK I1=net1847 I2=CLK
.ENDS

.SUBCKT SNPS_CLOCK_GATE_HIGH_RegFileDual_DATA_WIDTH34_35 EN ENCLK CLK
*.CONNECT net1844 EN
XFE_PHC969_net1847 DELC $PINS O=net1847 I=FE_PHN969_net1847
Xlatch QDBHN $PINS Q=FE_PHN969_net1847 D=net1844 CKB=CLK
Xmain_gate AN2T $PINS O=ENCLK I1=net1847 I2=CLK
.ENDS

.SUBCKT SNPS_CLOCK_GATE_HIGH_RegFileDual_DATA_WIDTH34_34 EN ENCLK CLK
*.CONNECT net1844 EN
XFE_PHC943_net1847 DELC $PINS O=FE_PHN943_net1847 I=net1847
Xlatch QDBHN $PINS Q=net1847 D=net1844 CKB=CLK
Xmain_gate AN2T $PINS O=ENCLK I1=FE_PHN943_net1847 I2=CLK
.ENDS

.SUBCKT SNPS_CLOCK_GATE_HIGH_RegFileDual_DATA_WIDTH34_33 EN ENCLK CLK
*.CONNECT net1844 EN
XFE_PHC900_net1847 DELC $PINS O=FE_PHN900_net1847 I=net1847
Xlatch QDBHN $PINS Q=net1847 D=net1844 CKB=CLK
Xmain_gate AN2T $PINS O=ENCLK I1=FE_PHN900_net1847 I2=CLK
.ENDS

.SUBCKT SNPS_CLOCK_GATE_HIGH_RegFileDual_DATA_WIDTH34_32 EN ENCLK CLK
*.CONNECT net1844 EN
XFE_PHC975_net1847 DELC $PINS O=net1847 I=FE_PHN975_net1847
Xlatch QDBHN $PINS Q=FE_PHN975_net1847 D=net1844 CKB=CLK
Xmain_gate AN2T $PINS O=ENCLK I1=net1847 I2=CLK
.ENDS

.SUBCKT SNPS_CLOCK_GATE_HIGH_RegFileDual_DATA_WIDTH34_31 CLK EN ENCLK
+ CLK_clone1
*.CONNECT net1841 CLK
*.CONNECT net1844 EN
XFE_PHC881_net1847 DELC $PINS O=net1847 I=FE_PHN881_net1847
Xlatch QDBHN $PINS Q=FE_PHN881_net1847 D=net1844 CKB=CLK_clone1
Xmain_gate AN2T $PINS O=ENCLK I1=net1847 I2=net1841
.ENDS

.SUBCKT SNPS_CLOCK_GATE_HIGH_RegFileDual_DATA_WIDTH34_30 CLK EN ENCLK
+ CLK_clone1
*.CONNECT net1841 CLK
*.CONNECT net1844 EN
XFE_PHC929_net1847 DELC $PINS O=FE_PHN929_net1847 I=net1847
Xlatch QDBHN $PINS Q=net1847 D=net1844 CKB=net1841
Xmain_gate AN2T $PINS O=ENCLK I1=FE_PHN929_net1847 I2=CLK_clone1
.ENDS

.SUBCKT SNPS_CLOCK_GATE_HIGH_RegFileDual_DATA_WIDTH34_29 EN ENCLK CLK
*.CONNECT net1844 EN
XFE_PHC894_net1847 DELC $PINS O=FE_PHN894_net1847 I=net1847
Xlatch QDBHN $PINS Q=net1847 D=net1844 CKB=CLK
Xmain_gate AN2T $PINS O=ENCLK I1=FE_PHN894_net1847 I2=CLK
.ENDS

.SUBCKT SNPS_CLOCK_GATE_HIGH_RegFileDual_DATA_WIDTH34_28 CLK EN ENCLK
+ CLK_clone1
*.CONNECT net1841 CLK
*.CONNECT net1844 EN
XFE_PHC902_net1847 DELC $PINS O=FE_PHN902_net1847 I=net1847
Xlatch QDBHN $PINS Q=net1847 D=net1844 CKB=net1841
Xmain_gate AN2T $PINS O=ENCLK I1=FE_PHN902_net1847 I2=CLK_clone1
.ENDS

.SUBCKT SNPS_CLOCK_GATE_HIGH_RegFileDual_DATA_WIDTH34_27 EN ENCLK CLK
*.CONNECT net1844 EN
XFE_PHC920_net1847 DELC $PINS O=FE_PHN920_net1847 I=net1847
Xlatch QDBHN $PINS Q=net1847 D=net1844 CKB=CLK
Xmain_gate AN2T $PINS O=ENCLK I1=FE_PHN920_net1847 I2=CLK
.ENDS

.SUBCKT SNPS_CLOCK_GATE_HIGH_RegFileDual_DATA_WIDTH34_26 CLK EN ENCLK
+ CLK_clone1
*.CONNECT net1841 CLK
*.CONNECT net1844 EN
XFE_PHC910_net1847 DELC $PINS O=FE_PHN910_net1847 I=net1847
Xlatch QDBHN $PINS Q=net1847 D=net1844 CKB=net1841
Xmain_gate AN2T $PINS O=ENCLK I1=FE_PHN910_net1847 I2=CLK_clone1
.ENDS

.SUBCKT SNPS_CLOCK_GATE_HIGH_RegFileDual_DATA_WIDTH34_25 EN ENCLK CLK
*.CONNECT net1844 EN
XFE_PHC959_net1847 DELC $PINS O=net1847 I=FE_PHN959_net1847
Xlatch QDBHN $PINS Q=FE_PHN959_net1847 D=net1844 CKB=CLK
Xmain_gate AN2T $PINS O=ENCLK I1=net1847 I2=CLK
.ENDS

.SUBCKT SNPS_CLOCK_GATE_HIGH_RegFileDual_DATA_WIDTH34_24 EN ENCLK CLK
*.CONNECT net1844 EN
XFE_PHC938_net1847 DELC $PINS O=net1847 I=FE_PHN938_net1847
Xlatch QDBHN $PINS Q=FE_PHN938_net1847 D=net1844 CKB=CLK
Xmain_gate AN2T $PINS O=ENCLK I1=net1847 I2=CLK
.ENDS

.SUBCKT SNPS_CLOCK_GATE_HIGH_RegFileDual_DATA_WIDTH34_23 EN ENCLK CLK
*.CONNECT net1844 EN
XFE_PHC884_net1847 DELC $PINS O=FE_PHN884_net1847 I=net1847
Xlatch QDBHN $PINS Q=net1847 D=net1844 CKB=CLK
Xmain_gate AN2T $PINS O=ENCLK I1=FE_PHN884_net1847 I2=CLK
.ENDS

.SUBCKT SNPS_CLOCK_GATE_HIGH_RegFileDual_DATA_WIDTH34_22 EN ENCLK CLK
*.CONNECT net1844 EN
XFE_PHC1000_net1847 DELC $PINS O=FE_PHN1000_net1847 I=net1847
Xlatch QDBHN $PINS Q=net1847 D=net1844 CKB=CLK
Xmain_gate AN2T $PINS O=ENCLK I1=FE_PHN1000_net1847 I2=CLK
.ENDS

.SUBCKT SNPS_CLOCK_GATE_HIGH_RegFileDual_DATA_WIDTH34_21 EN ENCLK CLK
*.CONNECT net1844 EN
XFE_PHC995_net1847 DELC $PINS O=net1847 I=FE_PHN995_net1847
Xlatch QDBHN $PINS Q=FE_PHN995_net1847 D=net1844 CKB=CLK
Xmain_gate AN2T $PINS O=ENCLK I1=net1847 I2=CLK
.ENDS

.SUBCKT SNPS_CLOCK_GATE_HIGH_RegFileDual_DATA_WIDTH34_20 EN ENCLK CLK
*.CONNECT net1844 EN
XFE_PHC913_net1847 DELC $PINS O=FE_PHN913_net1847 I=net1847
Xlatch QDBHN $PINS Q=net1847 D=net1844 CKB=CLK
Xmain_gate AN2T $PINS O=ENCLK I1=FE_PHN913_net1847 I2=CLK
.ENDS

.SUBCKT SNPS_CLOCK_GATE_HIGH_RegFileDual_DATA_WIDTH34_19 EN ENCLK CLK
*.CONNECT net1844 EN
XFE_PHC883_net1847 DELC $PINS O=FE_PHN883_net1847 I=net1847
Xlatch QDBHN $PINS Q=net1847 D=net1844 CKB=CLK
Xmain_gate AN2T $PINS O=ENCLK I1=FE_PHN883_net1847 I2=CLK
.ENDS

.SUBCKT SNPS_CLOCK_GATE_HIGH_RegFileDual_DATA_WIDTH34_18 EN ENCLK CLK
*.CONNECT net1844 EN
XFE_PHC993_net1847 DELC $PINS O=net1847 I=FE_PHN993_net1847
Xlatch QDBHN $PINS Q=FE_PHN993_net1847 D=net1844 CKB=CLK
Xmain_gate AN2T $PINS O=ENCLK I1=net1847 I2=CLK
.ENDS

.SUBCKT SNPS_CLOCK_GATE_HIGH_RegFileDual_DATA_WIDTH34_17 EN ENCLK CLK
*.CONNECT net1844 EN
XFE_PHC914_net1847 DELC $PINS O=FE_PHN914_net1847 I=net1847
Xlatch QDBHN $PINS Q=net1847 D=net1844 CKB=CLK
Xmain_gate AN2T $PINS O=ENCLK I1=FE_PHN914_net1847 I2=CLK
.ENDS

.SUBCKT SNPS_CLOCK_GATE_HIGH_RegFileDual_DATA_WIDTH34_16 EN ENCLK CLK
*.CONNECT net1844 EN
XFE_PHC906_net1847 DELC $PINS O=net1847 I=FE_PHN906_net1847
Xlatch QDBHN $PINS Q=FE_PHN906_net1847 D=net1844 CKB=CLK
Xmain_gate AN2T $PINS O=ENCLK I1=net1847 I2=CLK
.ENDS

.SUBCKT SNPS_CLOCK_GATE_HIGH_RegFileDual_DATA_WIDTH34_15 EN ENCLK CLK
*.CONNECT net1844 EN
XFE_PHC992_net1847 DELC $PINS O=FE_PHN992_net1847 I=net1847
Xlatch QDBHN $PINS Q=net1847 D=net1844 CKB=CLK
Xmain_gate AN2T $PINS O=ENCLK I1=FE_PHN992_net1847 I2=CLK
.ENDS

.SUBCKT SNPS_CLOCK_GATE_HIGH_RegFileDual_DATA_WIDTH34_14 EN ENCLK CLK
*.CONNECT net1844 EN
XFE_PHC926_net1847 DELC $PINS O=net1847 I=FE_PHN926_net1847
Xlatch QDBHN $PINS Q=FE_PHN926_net1847 D=net1844 CKB=CLK
Xmain_gate AN2T $PINS O=ENCLK I1=net1847 I2=CLK
.ENDS

.SUBCKT SNPS_CLOCK_GATE_HIGH_RegFileDual_DATA_WIDTH34_13 EN ENCLK CLK
*.CONNECT net1844 EN
XFE_PHC882_net1847 DELC $PINS O=FE_PHN882_net1847 I=net1847
Xlatch QDBHN $PINS Q=net1847 D=net1844 CKB=CLK
Xmain_gate AN2T $PINS O=ENCLK I1=FE_PHN882_net1847 I2=CLK
.ENDS

.SUBCKT SNPS_CLOCK_GATE_HIGH_RegFileDual_DATA_WIDTH34_12 EN ENCLK CLK
*.CONNECT net1844 EN
XFE_PHC947_net1847 DELC $PINS O=FE_PHN947_net1847 I=net1847
Xlatch QDBHN $PINS Q=net1847 D=net1844 CKB=CLK
Xmain_gate AN2T $PINS O=ENCLK I1=FE_PHN947_net1847 I2=CLK
.ENDS

.SUBCKT SNPS_CLOCK_GATE_HIGH_RegFileDual_DATA_WIDTH34_11 EN ENCLK CLK
*.CONNECT net1844 EN
XFE_PHC905_net1847 DELC $PINS O=FE_PHN905_net1847 I=net1847
Xlatch QDBHN $PINS Q=net1847 D=net1844 CKB=CLK
Xmain_gate AN2T $PINS O=ENCLK I1=FE_PHN905_net1847 I2=CLK
.ENDS

.SUBCKT SNPS_CLOCK_GATE_HIGH_RegFileDual_DATA_WIDTH34_10 EN ENCLK CLK
*.CONNECT net1844 EN
XFE_PHC923_net1847 DELC $PINS O=FE_PHN923_net1847 I=net1847
Xlatch QDBHN $PINS Q=net1847 D=net1844 CKB=CLK
Xmain_gate AN2T $PINS O=ENCLK I1=FE_PHN923_net1847 I2=CLK
.ENDS

.SUBCKT SNPS_CLOCK_GATE_HIGH_RegFileDual_DATA_WIDTH34_9 EN ENCLK CLK
*.CONNECT net1844 EN
XFE_PHC928_net1847 DELC $PINS O=FE_PHN928_net1847 I=net1847
Xlatch QDBHN $PINS Q=net1847 D=net1844 CKB=CLK
Xmain_gate AN2T $PINS O=ENCLK I1=FE_PHN928_net1847 I2=CLK
.ENDS

.SUBCKT SNPS_CLOCK_GATE_HIGH_RegFileDual_DATA_WIDTH34_8 EN ENCLK CLK
*.CONNECT net1844 EN
XFE_PHC919_net1847 DELC $PINS O=FE_PHN919_net1847 I=net1847
Xlatch QDBHN $PINS Q=net1847 D=net1844 CKB=CLK
Xmain_gate AN2T $PINS O=ENCLK I1=FE_PHN919_net1847 I2=CLK
.ENDS

.SUBCKT SNPS_CLOCK_GATE_HIGH_RegFileDual_DATA_WIDTH34_7 EN ENCLK CLK
*.CONNECT net1844 EN
XFE_PHC908_net1847 DELC $PINS O=FE_PHN908_net1847 I=net1847
Xlatch QDBHN $PINS Q=net1847 D=net1844 CKB=CLK
Xmain_gate AN2T $PINS O=ENCLK I1=FE_PHN908_net1847 I2=CLK
.ENDS

.SUBCKT SNPS_CLOCK_GATE_HIGH_RegFileDual_DATA_WIDTH34_6 EN ENCLK CLK
*.CONNECT net1844 EN
XFE_PHC958_net1847 DELC $PINS O=FE_PHN958_net1847 I=net1847
Xlatch QDBHN $PINS Q=net1847 D=net1844 CKB=CLK
Xmain_gate AN2T $PINS O=ENCLK I1=FE_PHN958_net1847 I2=CLK
.ENDS

.SUBCKT SNPS_CLOCK_GATE_HIGH_RegFileDual_DATA_WIDTH34_5 EN ENCLK CLK
*.CONNECT net1844 EN
XFE_PHC997_net1847 DELC $PINS O=FE_PHN997_net1847 I=net1847
Xlatch QDBHN $PINS Q=net1847 D=net1844 CKB=CLK
Xmain_gate AN2T $PINS O=ENCLK I1=FE_PHN997_net1847 I2=CLK
.ENDS

.SUBCKT SNPS_CLOCK_GATE_HIGH_RegFileDual_DATA_WIDTH34_4 EN ENCLK CLK
*.CONNECT net1844 EN
XFE_PHC895_net1847 DELC $PINS O=FE_PHN895_net1847 I=net1847
Xlatch QDBHN $PINS Q=net1847 D=net1844 CKB=CLK
Xmain_gate AN2T $PINS O=ENCLK I1=FE_PHN895_net1847 I2=CLK
.ENDS

.SUBCKT SNPS_CLOCK_GATE_HIGH_RegFileDual_DATA_WIDTH34_3 EN ENCLK CLK
*.CONNECT net1844 EN
XFE_PHC982_net1847 DELC $PINS O=FE_PHN982_net1847 I=net1847
Xlatch QDBHN $PINS Q=net1847 D=net1844 CKB=CLK
Xmain_gate AN2T $PINS O=ENCLK I1=FE_PHN982_net1847 I2=CLK
.ENDS

.SUBCKT SNPS_CLOCK_GATE_HIGH_RegFileDual_DATA_WIDTH34_2 EN ENCLK CLK
*.CONNECT net1844 EN
XFE_PHC911_net1847 DELC $PINS O=FE_PHN911_net1847 I=net1847
Xlatch QDBHN $PINS Q=net1847 D=net1844 CKB=CLK
Xmain_gate AN2T $PINS O=ENCLK I1=FE_PHN911_net1847 I2=CLK
.ENDS

.SUBCKT SNPS_CLOCK_GATE_HIGH_RegFileDual_DATA_WIDTH34_1 EN ENCLK CLK
*.CONNECT net1844 EN
XFE_PHC961_net1847 DELC $PINS O=FE_PHN961_net1847 I=net1847
Xlatch QDBHN $PINS Q=net1847 D=net1844 CKB=CLK
Xmain_gate AN2T $PINS O=ENCLK I1=FE_PHN961_net1847 I2=CLK
.ENDS

.SUBCKT RegFileDual_DATA_WIDTH34 rst_n read_addr_1[4] read_addr_1[3]
+ read_addr_1[2] read_addr_1[1] read_addr_1[0] read_data_1[33] read_data_1[32]
+ read_data_1[31] read_data_1[30] read_data_1[29] read_data_1[28]
+ read_data_1[27] read_data_1[26] read_data_1[25] read_data_1[24]
+ read_data_1[23] read_data_1[22] read_data_1[21] read_data_1[20]
+ read_data_1[19] read_data_1[18] read_data_1[17] read_data_1[16]
+ read_data_1[15] read_data_1[14] read_data_1[13] read_data_1[12]
+ read_data_1[11] read_data_1[10] read_data_1[9] read_data_1[8] read_data_1[7]
+ read_data_1[6] read_data_1[5] read_data_1[4] read_data_1[3] read_data_1[2]
+ read_data_1[1] read_data_1[0] wen1 wen2 write_addr_1[4] write_addr_1[3]
+ write_addr_1[2] write_addr_1[1] write_addr_1[0] write_addr_2[4]
+ write_addr_2[3] write_addr_2[2] write_addr_2[1] write_addr_2[0]
+ write_data_1[33] write_data_1[32] write_data_1[31] write_data_1[30]
+ write_data_1[29] write_data_1[28] write_data_1[27] write_data_1[26]
+ write_data_1[25] write_data_1[24] write_data_1[23] write_data_1[22]
+ write_data_1[21] write_data_1[20] write_data_1[19] write_data_1[18]
+ write_data_1[17] write_data_1[16] write_data_1[15] write_data_1[14]
+ write_data_1[13] write_data_1[12] write_data_1[11] write_data_1[10]
+ write_data_1[9] write_data_1[8] write_data_1[7] write_data_1[6]
+ write_data_1[5] write_data_1[4] write_data_1[3] write_data_1[2]
+ write_data_1[1] write_data_1[0] write_data_2[33] write_data_2[32]
+ write_data_2[31] write_data_2[30] write_data_2[29] write_data_2[28]
+ write_data_2[27] write_data_2[26] write_data_2[25] write_data_2[24]
+ write_data_2[23] write_data_2[22] write_data_2[21] write_data_2[20]
+ write_data_2[19] write_data_2[18] write_data_2[17] write_data_2[16]
+ write_data_2[15] write_data_2[14] write_data_2[13] write_data_2[12]
+ write_data_2[11] write_data_2[10] write_data_2[9] write_data_2[8]
+ write_data_2[7] write_data_2[6] write_data_2[5] write_data_2[4]
+ write_data_2[3] write_data_2[2] write_data_2[1] write_data_2[0] p_1 p1 p2
+ FE_OFN75_FE_DBTN17_n206 FE_OFN71_FE_DBTN17_n206 FE_OFN69_FE_DBTN17_n206
+ clk_clone7 clk_clone6 clk_clone5 clk_clone4 clk_clone3 clk_clone2 clk_clone1
+ clk
XFE_PHC1478_bank_mem_1_6_15 BUF1CK $PINS O=bank_mem_1[6][15]
+ I=FE_PHN1478_bank_mem_1_6_15
XFE_PHC1462_n370 BUF2CK $PINS O=n370 I=FE_PHN1462_n370
XFE_PHC1366_N104 BUF1CK $PINS O=FE_PHN1366_N104 I=N104
XFE_PHC1361_N109 BUF1CK $PINS O=FE_PHN1361_N109 I=N109
XFE_PHC1360_N108 BUF1CK $PINS O=FE_PHN1360_N108 I=N108
XFE_PHC1358_N123 BUF1CK $PINS O=FE_PHN1358_N123 I=N123
XFE_PHC1357_N126 BUF1S $PINS O=FE_PHN1357_N126 I=N126
XFE_PHC1356_N112 BUF1CK $PINS O=FE_PHN1356_N112 I=N112
XFE_PHC1354_N110 DELA $PINS O=FE_PHN1354_N110 I=N110
XFE_PHC1352_N124 DELA $PINS O=FE_PHN1352_N124 I=N124
XFE_PHC1351_n1106 DELB $PINS O=n1106 I=FE_PHN1351_n1106
XFE_PHC1350_N111 BUF1CK $PINS O=N111 I=FE_PHN1350_N111
XFE_PHC1338_N106 DELB $PINS O=N106 I=FE_PHN1338_N106
XFE_PHC1337_N125 DELA $PINS O=FE_PHN1337_N125 I=N125
XFE_PHC1138_bank_rdata_0_16 BUF1CK $PINS O=FE_PHN1138_bank_rdata_0_16
+ I=bank_rdata[0][16]
XFE_PHC1133_n282 BUF1CK $PINS O=n282 I=FE_PHN1133_n282
XFE_PHC1108_n815 BUF1CK $PINS O=n815 I=FE_PHN1108_n815
XFE_PHC1104_n326 BUF1CK $PINS O=FE_PHN1104_n326 I=n326
XFE_PHC1101_bank_mem_1_2_9 BUF1CK $PINS O=FE_PHN1101_bank_mem_1_2_9
+ I=bank_mem_1[2][9]
XFE_PHC1096_n260 BUF1CK $PINS O=FE_PHN1096_n260 I=n260
XFE_PHC1091_n601 BUF1CK $PINS O=FE_PHN1091_n601 I=n601
XFE_PHC1086_n612 BUF1CK $PINS O=n612 I=FE_PHN1086_n612
XFE_PHC1084_bank_rdata_0_4 BUF1CK $PINS O=bank_rdata[0][4]
+ I=FE_PHN1084_bank_rdata_0_4
XFE_PHC1081_bank_rdata_0_14 BUF1CK $PINS O=FE_PHN1081_bank_rdata_0_14
+ I=bank_rdata[0][14]
XFE_PHC1080_bank_rdata_0_7 BUF1CK $PINS O=FE_PHN1080_bank_rdata_0_7
+ I=bank_rdata[0][7]
XFE_PHC1079_bank_rdata_0_27 BUF1CK $PINS O=FE_PHN1079_bank_rdata_0_27
+ I=bank_rdata[0][27]
XFE_PHC1078_bank_rdata_0_9 BUF1CK $PINS O=FE_PHN1078_bank_rdata_0_9
+ I=bank_rdata[0][9]
XFE_PHC1076_bank_rdata_0_15 BUF1CK $PINS O=FE_PHN1076_bank_rdata_0_15
+ I=bank_rdata[0][15]
XFE_PHC1072_n348 BUF1CK $PINS O=FE_PHN1072_n348 I=n348
XFE_PHC1066_bank_mem_1_7_33 BUF1CK $PINS O=bank_mem_1[7][33]
+ I=FE_PHN1066_bank_mem_1_7_33
XFE_PHC1064_n639 DELB $PINS O=FE_PHN1064_n639 I=n639
XCTS_ccl_a_INV_CLK_G1_L8_99 INV6CK $PINS O=CTS_779 I=CTS_780
XCTS_ccl_a_INV_CLK_G1_L7_99 INV3CK $PINS O=CTS_780 I=CTS_781
XCTS_ccl_a_INV_CLK_G1_L8_98 INV4CK $PINS O=CTS_776 I=CTS_777
XCTS_ccl_a_INV_CLK_G1_L7_98 INV2CK $PINS O=CTS_777 I=CTS_778
XCTS_ccl_a_INV_CLK_G1_L8_97 INV4CK $PINS O=CTS_773 I=CTS_774
XCTS_ccl_a_INV_CLK_G1_L7_97 INV2CK $PINS O=CTS_774 I=CTS_775
XCTS_ccl_a_INV_CLK_G1_L8_96 INV6CK $PINS O=CTS_770 I=CTS_771
XCTS_ccl_a_INV_CLK_G1_L7_96 INV3CK $PINS O=CTS_771 I=CTS_772
XCTS_ccl_a_INV_CLK_G1_L8_95 INV4CK $PINS O=CTS_767 I=CTS_768
XCTS_ccl_a_INV_CLK_G1_L7_95 INV3CK $PINS O=CTS_768 I=CTS_769
XCTS_ccl_a_INV_CLK_G1_L8_94 INV6CK $PINS O=CTS_764 I=CTS_765
XCTS_ccl_a_INV_CLK_G1_L7_94 INV3CK $PINS O=CTS_765 I=CTS_766
XCTS_ccl_a_INV_CLK_G1_L8_93 INV6CK $PINS O=CTS_761 I=CTS_762
XCTS_ccl_a_INV_CLK_G1_L7_93 INV3CK $PINS O=CTS_762 I=CTS_763
XCTS_ccl_a_INV_CLK_G1_L8_92 INV6CK $PINS O=CTS_758 I=CTS_759
XCTS_ccl_a_INV_CLK_G1_L7_92 INV3CK $PINS O=CTS_759 I=CTS_760
XCTS_ccl_a_INV_CLK_G1_L8_91 INV6CK $PINS O=CTS_755 I=CTS_756
XCTS_ccl_a_INV_CLK_G1_L7_91 INV3CK $PINS O=CTS_756 I=CTS_757
XCTS_ccl_a_INV_CLK_G1_L8_90 INV4CK $PINS O=CTS_752 I=CTS_753
XCTS_ccl_a_INV_CLK_G1_L7_90 INV3CK $PINS O=CTS_753 I=CTS_754
XCTS_ccl_a_INV_CLK_G1_L8_89 INV4CK $PINS O=CTS_749 I=CTS_750
XCTS_ccl_a_INV_CLK_G1_L7_89 INV2CK $PINS O=CTS_750 I=CTS_751
XCTS_ccl_a_INV_CLK_G1_L8_88 INV4CK $PINS O=CTS_746 I=CTS_747
XCTS_ccl_a_INV_CLK_G1_L7_88 INV3CK $PINS O=CTS_747 I=CTS_748
XCTS_ccl_a_INV_CLK_G1_L8_87 INV4CK $PINS O=CTS_743 I=CTS_744
XCTS_ccl_a_INV_CLK_G1_L7_87 INV3CK $PINS O=CTS_744 I=CTS_745
XCTS_ccl_a_INV_CLK_G1_L8_86 INV4CK $PINS O=CTS_740 I=CTS_741
XCTS_ccl_a_INV_CLK_G1_L7_86 INV2CK $PINS O=CTS_741 I=CTS_742
XCTS_ccl_a_INV_CLK_G1_L8_85 INV4CK $PINS O=CTS_737 I=CTS_738
XCTS_ccl_a_INV_CLK_G1_L7_85 INV4CK $PINS O=CTS_738 I=CTS_739
XCTS_ccl_a_INV_CLK_G0_L5_9 INV12CK $PINS O=CTS_782 I=clk_clone3
XCTS_ccl_a_INV_CLK_G1_L8_83 INV4CK $PINS O=CTS_734 I=CTS_735
XCTS_ccl_a_INV_CLK_G1_L7_83 INV2CK $PINS O=CTS_735 I=CTS_736
XCTS_ccl_a_INV_CLK_G1_L8_82 INV4CK $PINS O=CTS_731 I=CTS_732
XCTS_ccl_a_INV_CLK_G1_L7_82 INV3CK $PINS O=CTS_732 I=CTS_733
XCTS_ccl_a_INV_CLK_G1_L8_81 INV4CK $PINS O=CTS_728 I=CTS_729
XCTS_ccl_a_INV_CLK_G1_L7_81 INV2CK $PINS O=CTS_729 I=CTS_730
XCTS_ccl_a_INV_CLK_G1_L8_80 INV4CK $PINS O=CTS_725 I=CTS_726
XCTS_ccl_a_INV_CLK_G1_L7_80 INV3CK $PINS O=CTS_726 I=CTS_727
XCTS_ccl_a_INV_CLK_G1_L8_79 INV4CK $PINS O=CTS_722 I=CTS_723
XCTS_ccl_a_INV_CLK_G1_L7_79 INV4CK $PINS O=CTS_723 I=CTS_724
XCTS_ccl_a_INV_CLK_G1_L8_78 INV4CK $PINS O=CTS_719 I=CTS_720
XCTS_ccl_a_INV_CLK_G1_L7_78 INV3CK $PINS O=CTS_720 I=CTS_721
XCTS_ccl_a_INV_CLK_G1_L8_77 INV4CK $PINS O=CTS_716 I=CTS_717
XCTS_ccl_a_INV_CLK_G1_L7_77 INV2CK $PINS O=CTS_717 I=CTS_718
XCTS_ccl_a_INV_CLK_G1_L8_76 INV4CK $PINS O=CTS_713 I=CTS_714
XCTS_ccl_a_INV_CLK_G1_L7_76 INV3CK $PINS O=CTS_714 I=CTS_715
XCTS_ccl_a_INV_CLK_G1_L8_75 INV4CK $PINS O=CTS_710 I=CTS_711
XCTS_ccl_a_INV_CLK_G1_L7_75 INV2CK $PINS O=CTS_711 I=CTS_712
XCTS_ccl_a_INV_CLK_G1_L8_74 INV4CK $PINS O=CTS_707 I=CTS_708
XCTS_ccl_a_INV_CLK_G1_L7_74 INV2CK $PINS O=CTS_708 I=CTS_709
XCTS_ccl_a_INV_CLK_G1_L8_73 INV4CK $PINS O=CTS_704 I=CTS_705
XCTS_ccl_a_INV_CLK_G1_L7_73 INV3CK $PINS O=CTS_705 I=CTS_706
XCTS_ccl_a_INV_CLK_G1_L8_72 INV4CK $PINS O=CTS_701 I=CTS_702
XCTS_ccl_a_INV_CLK_G1_L7_72 INV3CK $PINS O=CTS_702 I=CTS_703
XCTS_ccl_a_INV_CLK_G1_L8_71 INV6CK $PINS O=CTS_697 I=CTS_698
XCTS_ccl_a_INV_CLK_G1_L7_71 INV3CK $PINS O=CTS_698 I=CTS_699
XCTS_ccl_a_INV_CLK_G1_L8_70 INV6CK $PINS O=CTS_694 I=CTS_695
XCTS_ccl_a_INV_CLK_G1_L7_70 INV2CK $PINS O=CTS_695 I=CTS_696
XCTS_ccl_a_INV_CLK_G1_L8_69 INV4CK $PINS O=CTS_691 I=CTS_692
XCTS_ccl_a_INV_CLK_G1_L7_69 INV3CK $PINS O=CTS_692 I=CTS_693
XCTS_ccl_a_INV_CLK_G1_L8_68 INV6CK $PINS O=CTS_688 I=CTS_689
XCTS_ccl_a_INV_CLK_G1_L7_68 INV3CK $PINS O=CTS_689 I=CTS_690
XCTS_ccl_a_INV_CLK_G1_L8_67 INV4CK $PINS O=CTS_685 I=CTS_686
XCTS_ccl_a_INV_CLK_G1_L7_67 INV4CK $PINS O=CTS_686 I=CTS_687
XCTS_ccl_a_INV_CLK_G1_L8_66 INV4CK $PINS O=CTS_682 I=CTS_683
XCTS_ccl_a_INV_CLK_G1_L7_66 INV3CK $PINS O=CTS_683 I=CTS_684
XCTS_ccl_a_INV_CLK_G1_L8_65 INV6CK $PINS O=CTS_679 I=CTS_680
XCTS_ccl_a_INV_CLK_G1_L7_65 INV2CK $PINS O=CTS_680 I=CTS_681
XCTS_ccl_a_INV_CLK_G1_L8_64 INV4CK $PINS O=CTS_676 I=CTS_677
XCTS_ccl_a_INV_CLK_G1_L7_64 INV2CK $PINS O=CTS_677 I=CTS_678
XCTS_ccl_a_INV_CLK_G1_L8_63 INV6CK $PINS O=CTS_673 I=CTS_674
XCTS_ccl_a_INV_CLK_G1_L7_63 INV8CK $PINS O=CTS_674 I=CTS_675
XCTS_ccl_a_INV_CLK_G1_L8_62 INV3CK $PINS O=CTS_670 I=CTS_671
XCTS_ccl_a_INV_CLK_G1_L7_62 INV2CK $PINS O=CTS_671 I=CTS_672
XCTS_ccl_a_INV_CLK_G1_L8_61 INV4CK $PINS O=CTS_667 I=CTS_668
XCTS_ccl_a_INV_CLK_G1_L7_61 INV2CK $PINS O=CTS_668 I=CTS_669
XCTS_ccl_a_INV_CLK_G1_L8_60 INV6CK $PINS O=CTS_664 I=CTS_665
XCTS_ccl_a_INV_CLK_G1_L7_60 INV2CK $PINS O=CTS_665 I=CTS_666
XCTS_ccl_a_INV_CLK_G1_L8_59 INV4CK $PINS O=CTS_661 I=CTS_662
XCTS_ccl_a_INV_CLK_G1_L7_59 INV2CK $PINS O=CTS_662 I=CTS_663
XCTS_ccl_a_INV_CLK_G1_L8_58 INV4CK $PINS O=CTS_658 I=CTS_659
XCTS_ccl_a_INV_CLK_G1_L7_58 INV2CK $PINS O=CTS_659 I=CTS_660
XCTS_ccl_a_INV_CLK_G1_L8_57 INV4CK $PINS O=CTS_655 I=CTS_656
XCTS_ccl_a_INV_CLK_G1_L7_57 INV2CK $PINS O=CTS_656 I=CTS_657
XCTS_ccl_a_INV_CLK_G1_L8_56 INV4CK $PINS O=CTS_652 I=CTS_653
XCTS_ccl_a_INV_CLK_G1_L7_56 INV2CK $PINS O=CTS_653 I=CTS_654
XCTS_ccl_a_INV_CLK_G1_L8_55 INV4CK $PINS O=CTS_649 I=CTS_650
XCTS_ccl_a_INV_CLK_G1_L7_55 INV2CK $PINS O=CTS_650 I=CTS_651
XCTS_ccl_a_INV_CLK_G1_L8_54 INV4CK $PINS O=CTS_646 I=CTS_647
XCTS_ccl_a_INV_CLK_G1_L7_54 INV2CK $PINS O=CTS_647 I=CTS_648
XCTS_ccl_a_INV_CLK_G1_L8_53 INV4CK $PINS O=CTS_643 I=CTS_644
XCTS_ccl_a_INV_CLK_G1_L7_53 INV2CK $PINS O=CTS_644 I=CTS_645
XCTS_ccl_a_INV_CLK_G1_L8_52 INV4CK $PINS O=CTS_640 I=CTS_641
XCTS_ccl_a_INV_CLK_G1_L7_52 INV2CK $PINS O=CTS_641 I=CTS_642
XCTS_ccl_a_INV_CLK_G0_L5_7 INV12CK $PINS O=CTS_700 I=clk_clone5
XCTS_ccl_a_INV_CLK_G1_L8_47 INV6CK $PINS O=CTS_637 I=CTS_638
XCTS_ccl_a_INV_CLK_G1_L7_47 INV4CK $PINS O=CTS_638 I=CTS_639
XCTS_ccl_a_INV_CLK_G1_L8_46 INV6CK $PINS O=CTS_634 I=CTS_635
XCTS_ccl_a_INV_CLK_G1_L7_46 INV3CK $PINS O=CTS_635 I=CTS_636
XCTS_ccl_a_INV_CLK_G1_L8_45 INV8CK $PINS O=CTS_631 I=CTS_632
XCTS_ccl_a_INV_CLK_G1_L7_45 INV3CK $PINS O=CTS_632 I=CTS_633
XCTS_ccl_a_INV_CLK_G1_L8_44 INV4CK $PINS O=CTS_628 I=CTS_629
XCTS_ccl_a_INV_CLK_G1_L7_44 INV2CK $PINS O=CTS_629 I=CTS_630
XCTS_ccl_a_INV_CLK_G1_L8_43 INV6CK $PINS O=CTS_625 I=CTS_626
XCTS_ccl_a_INV_CLK_G1_L7_43 INV3CK $PINS O=CTS_626 I=CTS_627
XCTS_ccl_a_INV_CLK_G1_L8_42 INV4CK $PINS O=CTS_622 I=CTS_623
XCTS_ccl_a_INV_CLK_G1_L7_42 INV6CK $PINS O=CTS_623 I=CTS_624
XCTS_ccl_a_INV_CLK_G1_L8_41 INV6CK $PINS O=CTS_619 I=CTS_620
XCTS_ccl_a_INV_CLK_G1_L7_41 INV3CK $PINS O=CTS_620 I=CTS_621
XCTS_ccl_a_INV_CLK_G1_L8_40 INV4CK $PINS O=CTS_616 I=CTS_617
XCTS_ccl_a_INV_CLK_G1_L7_40 INV3CK $PINS O=CTS_617 I=CTS_618
XCTS_ccl_a_INV_CLK_G1_L8_35 INV6CK $PINS O=CTS_613 I=CTS_614
XCTS_ccl_a_INV_CLK_G1_L7_35 INV2CK $PINS O=CTS_614 I=CTS_615
XCTS_ccl_a_INV_CLK_G1_L8_34 INV6CK $PINS O=CTS_610 I=CTS_611
XCTS_ccl_a_INV_CLK_G1_L7_34 INV2CK $PINS O=CTS_611 I=CTS_612
XCTS_ccl_a_INV_CLK_G1_L8_33 INV6CK $PINS O=CTS_607 I=CTS_608
XCTS_ccl_a_INV_CLK_G1_L7_33 INV2CK $PINS O=CTS_608 I=CTS_609
XCTS_ccl_a_INV_CLK_G1_L8_32 INV6CK $PINS O=CTS_604 I=CTS_605
XCTS_ccl_a_INV_CLK_G1_L7_32 INV2CK $PINS O=CTS_605 I=CTS_606
XCTS_ccl_a_INV_CLK_G1_L8_31 INV4CK $PINS O=CTS_601 I=CTS_602
XCTS_ccl_a_INV_CLK_G1_L7_31 INV2CK $PINS O=CTS_602 I=CTS_603
XCTS_ccl_a_INV_CLK_G1_L8_30 INV4CK $PINS O=CTS_598 I=CTS_599
XCTS_ccl_a_INV_CLK_G1_L7_30 INV2CK $PINS O=CTS_599 I=CTS_600
XCTS_ccl_a_INV_CLK_G1_L8_29 INV4CK $PINS O=CTS_595 I=CTS_596
XCTS_ccl_a_INV_CLK_G1_L7_29 INV2CK $PINS O=CTS_596 I=CTS_597
XCTS_ccl_a_INV_CLK_G1_L8_28 INV4CK $PINS O=CTS_592 I=CTS_593
XCTS_ccl_a_INV_CLK_G1_L7_28 INV2CK $PINS O=CTS_593 I=CTS_594
XCTS_ccl_a_INV_CLK_G1_L8_27 INV4CK $PINS O=CTS_589 I=CTS_590
XCTS_ccl_a_INV_CLK_G1_L7_27 INV2CK $PINS O=CTS_590 I=CTS_591
XFE_OFC96_n88 BUF1 $PINS O=FE_OFN98_n88 I=n88
XFE_OFC95_n86 BUF1 $PINS O=FE_OFN97_n86 I=n86
XFE_OFC92_n242 BUF1 $PINS O=FE_OFN94_n242 I=n242
XFE_OFC91_n87 BUF1 $PINS O=FE_OFN93_n87 I=n87
XFE_OFC76_n122 BUF1 $PINS O=FE_OFN78_n122 I=n122
XFE_DBTC151_n1 INV1S $PINS O=FE_DBTN151_n1 I=n1
XFE_DBTC150_n2 INV1S $PINS O=FE_DBTN150_n2 I=n2
XFE_DBTC149_n3 INV1S $PINS O=FE_DBTN149_n3 I=n3
XFE_DBTC148_n4 INV1S $PINS O=FE_DBTN148_n4 I=n4
XFE_DBTC147_n5 INV1S $PINS O=FE_DBTN147_n5 I=n5
XFE_DBTC146_n6 INV1S $PINS O=FE_DBTN146_n6 I=n6
XFE_DBTC145_n7 INV1S $PINS O=FE_DBTN145_n7 I=n7
XFE_DBTC144_n8 INV1S $PINS O=FE_DBTN144_n8 I=n8
XFE_DBTC143_n9 INV1S $PINS O=FE_DBTN143_n9 I=n9
XFE_DBTC142_n10 INV1S $PINS O=FE_DBTN142_n10 I=n10
XFE_DBTC141_n11 INV1S $PINS O=FE_DBTN141_n11 I=n11
XFE_DBTC140_n12 INV1S $PINS O=FE_DBTN140_n12 I=n12
XFE_DBTC139_n13 INV1S $PINS O=FE_DBTN139_n13 I=n13
XFE_DBTC138_n14 INV1S $PINS O=FE_DBTN138_n14 I=n14
XFE_DBTC137_n15 INV1S $PINS O=FE_DBTN137_n15 I=n15
XFE_DBTC136_n16 INV1S $PINS O=FE_DBTN136_n16 I=n16
XFE_DBTC135_n17 INV1S $PINS O=FE_DBTN135_n17 I=n17
XFE_DBTC134_n18 INV1S $PINS O=FE_DBTN134_n18 I=n18
XFE_DBTC133_n19 INV1S $PINS O=FE_DBTN133_n19 I=n19
XFE_DBTC132_n20 INV1S $PINS O=FE_DBTN132_n20 I=n20
XFE_DBTC131_n21 INV1S $PINS O=FE_DBTN131_n21 I=n21
XFE_DBTC130_n22 INV1S $PINS O=FE_DBTN130_n22 I=n22
XFE_DBTC129_n23 INV1S $PINS O=FE_DBTN129_n23 I=n23
XFE_DBTC128_n24 INV1S $PINS O=FE_DBTN128_n24 I=n24
XFE_DBTC127_n25 INV1S $PINS O=FE_DBTN127_n25 I=n25
XFE_DBTC126_n26 INV1S $PINS O=FE_DBTN126_n26 I=n26
XFE_DBTC125_n27 INV1S $PINS O=FE_DBTN125_n27 I=n27
XFE_DBTC124_n28 INV1S $PINS O=FE_DBTN124_n28 I=n28
XFE_DBTC123_n29 INV1S $PINS O=FE_DBTN123_n29 I=n29
XFE_DBTC122_n30 INV1S $PINS O=FE_DBTN122_n30 I=n30
XFE_DBTC121_n31 INV1S $PINS O=FE_DBTN121_n31 I=n31
XFE_DBTC120_n32 INV1S $PINS O=FE_DBTN120_n32 I=n32
XFE_DBTC119_n33 INV1S $PINS O=FE_DBTN119_n33 I=n33
XFE_DBTC118_n34 INV1S $PINS O=FE_DBTN118_n34 I=n34
XFE_DBTC117_n35 INV1S $PINS O=FE_DBTN117_n35 I=n35
XFE_DBTC116_n36 INV1S $PINS O=FE_DBTN116_n36 I=n36
XFE_DBTC115_n37 INV1S $PINS O=FE_DBTN115_n37 I=n37
XFE_DBTC114_n38 INV1S $PINS O=FE_DBTN114_n38 I=n38
XFE_DBTC113_n39 INV1S $PINS O=FE_DBTN113_n39 I=n39
XFE_DBTC112_n40 INV1S $PINS O=FE_DBTN112_n40 I=n40
XFE_DBTC111_n41 INV1S $PINS O=FE_DBTN111_n41 I=n41
XFE_DBTC110_n42 INV1S $PINS O=FE_DBTN110_n42 I=n42
XFE_DBTC109_n43 INV1S $PINS O=FE_DBTN109_n43 I=n43
XFE_DBTC108_n44 INV1S $PINS O=FE_DBTN108_n44 I=n44
XFE_DBTC107_n45 INV1S $PINS O=FE_DBTN107_n45 I=n45
XFE_DBTC106_n46 INV1S $PINS O=FE_DBTN106_n46 I=n46
XFE_DBTC105_n47 INV1S $PINS O=FE_DBTN105_n47 I=n47
XFE_DBTC104_n48 INV1S $PINS O=FE_DBTN104_n48 I=n48
XFE_DBTC103_n49 INV1S $PINS O=FE_DBTN103_n49 I=n49
XFE_DBTC102_n50 INV1S $PINS O=FE_DBTN102_n50 I=n50
XFE_DBTC101_n51 INV1S $PINS O=FE_DBTN101_n51 I=n51
XFE_DBTC100_n52 INV1S $PINS O=FE_DBTN100_n52 I=n52
XFE_DBTC99_n53 INV1S $PINS O=FE_DBTN99_n53 I=n53
XFE_DBTC98_n54 INV1S $PINS O=FE_DBTN98_n54 I=n54
XFE_DBTC97_n55 INV1S $PINS O=FE_DBTN97_n55 I=n55
XFE_DBTC96_n56 INV1S $PINS O=FE_DBTN96_n56 I=n56
XFE_DBTC95_n57 INV1S $PINS O=FE_DBTN95_n57 I=n57
XFE_DBTC94_n58 INV1S $PINS O=FE_DBTN94_n58 I=n58
XFE_DBTC93_n59 INV1S $PINS O=FE_DBTN93_n59 I=n59
XFE_DBTC92_n60 INV1S $PINS O=FE_DBTN92_n60 I=n60
XFE_DBTC91_n61 INV1S $PINS O=FE_DBTN91_n61 I=n61
XFE_DBTC90_n62 INV1S $PINS O=FE_DBTN90_n62 I=n62
XFE_DBTC89_n63 INV1S $PINS O=FE_DBTN89_n63 I=n63
XFE_DBTC88_n64 INV1S $PINS O=FE_DBTN88_n64 I=n64
XFE_DBTC87_n65 INV1S $PINS O=FE_DBTN87_n65 I=n65
XFE_DBTC86_n66 INV1S $PINS O=FE_DBTN86_n66 I=n66
XFE_DBTC85_n67 INV1S $PINS O=FE_DBTN85_n67 I=n67
XFE_DBTC84_n68 INV1S $PINS O=FE_DBTN84_n68 I=n68
Xbank_raddr_reg[0][3] QDLHN $PINS Q=N30 D=read_addr_1[4] CK=n122
Xbank_raddr_reg[0][2] QDLHN $PINS Q=N29 D=read_addr_1[3] CK=n122
Xbank_raddr_reg[0][1] QDLHN $PINS Q=N28 D=read_addr_1[2] CK=n122
Xbank_raddr_reg[0][0] QDLHN $PINS Q=N27 D=read_addr_1[1] CK=n122
Xbank_raddr_reg[1][3] QDBHN $PINS Q=N34 D=read_addr_1[4] CKB=FE_OFN78_n122
Xbank_raddr_reg[1][2] QDBHN $PINS Q=N33 D=read_addr_1[3] CKB=FE_OFN78_n122
Xbank_raddr_reg[1][1] QDBHN $PINS Q=N32 D=read_addr_1[2] CKB=FE_OFN78_n122
Xbank_raddr_reg[1][0] QDBHN $PINS Q=N31 D=read_addr_1[1] CKB=FE_OFN78_n122
XU202 ND2 $PINS O=n89 I1=n95 I2=n96
XU203 ND2 $PINS O=n92 I1=n1217 I2=n99
XU204 ND2 $PINS O=n93 I1=n1218 I2=n100
XU205 ND2 $PINS O=n97 I1=n1219 I2=n101
XU206 ND2 $PINS O=n98 I1=n101 I2=n96
XU207 ND2 $PINS O=n94 I1=n99 I2=n100
XU208 ND2 $PINS O=n102 I1=n108 I2=n1216
XU209 ND2 $PINS O=n104 I1=n108 I2=n109
XU210 ND2 $PINS O=n110 I1=n112 I2=wen1
XU213 ND2 $PINS O=n106 I1=n1214 I2=n116
XU214 ND2 $PINS O=n113 I1=n1216 I2=n111
XU215 ND2 $PINS O=n114 I1=n111 I2=n109
XU217 OR2B1S $PINS O=n87 I1=n117 B1=wen2
XU219 AO22 $PINS O=N135 A1=bank_rdata[0][1] A2=FE_OFN78_n122
+ B1=bank_rdata[1][1] B2=n1188
XU220 AO22 $PINS O=N134 A1=bank_rdata[0][2] A2=FE_OFN78_n122
+ B1=bank_rdata[1][2] B2=n1188
XU221 AO22S $PINS O=N133 A1=bank_rdata[0][3] A2=FE_OFN78_n122
+ B1=bank_rdata[1][3] B2=n1188
XU222 AO22 $PINS O=N132 A1=bank_rdata[0][4] A2=FE_OFN78_n122
+ B1=bank_rdata[1][4] B2=n1188
XU223 AO22S $PINS O=N131 A1=bank_rdata[0][5] A2=FE_OFN78_n122
+ B1=bank_rdata[1][5] B2=n1188
XU224 AO22 $PINS O=N130 A1=bank_rdata[0][6] A2=FE_OFN78_n122
+ B1=bank_rdata[1][6] B2=n1188
XU225 AO22 $PINS O=N129 A1=FE_PHN1080_bank_rdata_0_7 A2=FE_OFN78_n122
+ B1=bank_rdata[1][7] B2=n1188
XU226 AO22 $PINS O=N128 A1=bank_rdata[0][8] A2=FE_OFN78_n122
+ B1=bank_rdata[1][8] B2=n1188
XU227 AO22 $PINS O=N127 A1=FE_PHN1078_bank_rdata_0_9 A2=FE_OFN78_n122
+ B1=bank_rdata[1][9] B2=n1188
XU231 AO22 $PINS O=N123 A1=bank_rdata[0][13] A2=FE_OFN78_n122
+ B1=bank_rdata[1][13] B2=n1188
XU232 AO22 $PINS O=N122 A1=FE_PHN1081_bank_rdata_0_14 A2=FE_OFN78_n122
+ B1=bank_rdata[1][14] B2=n1188
XU233 AO22 $PINS O=N121 A1=FE_PHN1076_bank_rdata_0_15 A2=FE_OFN78_n122
+ B1=bank_rdata[1][15] B2=n1188
XU234 AO22 $PINS O=N120 A1=FE_PHN1138_bank_rdata_0_16 A2=FE_OFN78_n122
+ B1=bank_rdata[1][16] B2=n1188
XU235 AO22 $PINS O=N119 A1=bank_rdata[0][17] A2=FE_OFN78_n122
+ B1=bank_rdata[1][17] B2=n1188
XU236 AO22 $PINS O=N118 A1=bank_rdata[0][18] A2=FE_OFN78_n122
+ B1=bank_rdata[1][18] B2=n1188
XU237 AO22 $PINS O=N117 A1=bank_rdata[0][19] A2=FE_OFN78_n122
+ B1=bank_rdata[1][19] B2=n1188
XU238 AO22 $PINS O=N116 A1=bank_rdata[0][20] A2=FE_OFN78_n122
+ B1=bank_rdata[1][20] B2=n1188
XU239 AO22 $PINS O=N115 A1=bank_rdata[0][21] A2=FE_OFN78_n122
+ B1=bank_rdata[1][21] B2=n1188
XU240 AO22 $PINS O=N114 A1=bank_rdata[0][22] A2=FE_OFN78_n122
+ B1=bank_rdata[1][22] B2=n1188
XU241 AO22 $PINS O=N113 A1=bank_rdata[0][23] A2=FE_OFN78_n122
+ B1=bank_rdata[1][23] B2=n1188
XU242 AO22 $PINS O=N112 A1=bank_rdata[0][24] A2=FE_OFN78_n122
+ B1=bank_rdata[1][24] B2=n1188
XU243 AO22 $PINS O=FE_PHN1350_N111 A1=bank_rdata[0][25] A2=FE_OFN78_n122
+ B1=bank_rdata[1][25] B2=n1188
XU245 AO22 $PINS O=N109 A1=FE_PHN1079_bank_rdata_0_27 A2=FE_OFN78_n122
+ B1=bank_rdata[1][27] B2=n1188
XU246 AO22 $PINS O=N108 A1=bank_rdata[0][28] A2=FE_OFN78_n122
+ B1=bank_rdata[1][28] B2=n1188
XU247 AO22S $PINS O=N107 A1=bank_rdata[0][29] A2=FE_OFN78_n122
+ B1=bank_rdata[1][29] B2=n1188
XU249 AO22 $PINS O=N105 A1=bank_rdata[0][31] A2=FE_OFN78_n122
+ B1=bank_rdata[1][31] B2=n1188
XU250 AO22 $PINS O=N104 A1=bank_rdata[0][32] A2=FE_OFN78_n122
+ B1=bank_rdata[1][32] B2=n1188
XU252 XOR4 $PINS O=n122 I1=read_addr_1[1] I2=read_addr_1[0] I3=n118
+ I4=read_addr_1[2]
XU253 ND2 $PINS O=n91 I1=n1219 I2=n95
XU254 ND2 $PINS O=n119 I1=wen1 I2=n1288
XU255 ND2 $PINS O=n90 I1=n1217 I2=n1218
Xbank_mem_1_reg[4][33] QDFFN $PINS Q=bank_mem_1[4][33] D=FE_DBTN120_n32
+ CK=CTS_679
Xbank_mem_1_reg[4][32] QDFFN $PINS Q=bank_mem_1[4][32] D=FE_DBTN136_n16
+ CK=CTS_679
Xbank_mem_1_reg[4][31] QDFFN $PINS Q=bank_mem_1[4][31] D=FE_DBTN137_n15
+ CK=CTS_679
Xbank_mem_1_reg[4][30] QDFFN $PINS Q=bank_mem_1[4][30] D=FE_DBTN138_n14
+ CK=CTS_679
Xbank_mem_1_reg[4][29] QDFFN $PINS Q=bank_mem_1[4][29] D=FE_DBTN139_n13
+ CK=CTS_679
Xbank_mem_1_reg[4][28] QDFFN $PINS Q=bank_mem_1[4][28] D=FE_DBTN140_n12
+ CK=CTS_679
Xbank_mem_1_reg[4][27] QDFFN $PINS Q=bank_mem_1[4][27] D=FE_DBTN151_n1
+ CK=CTS_679
Xbank_mem_1_reg[4][26] QDFFN $PINS Q=bank_mem_1[4][26] D=FE_DBTN141_n11
+ CK=CTS_679
Xbank_mem_1_reg[4][25] QDFFN $PINS Q=bank_mem_1[4][25] D=FE_DBTN122_n30
+ CK=CTS_679
Xbank_mem_1_reg[4][24] QDFFN $PINS Q=bank_mem_1[4][24] D=FE_DBTN123_n29
+ CK=CTS_679
Xbank_mem_1_reg[4][23] QDFFN $PINS Q=bank_mem_1[4][23] D=FE_DBTN124_n28
+ CK=CTS_679
Xbank_mem_1_reg[4][22] QDFFN $PINS Q=bank_mem_1[4][22] D=FE_DBTN125_n27
+ CK=CTS_679
Xbank_mem_1_reg[4][21] QDFFN $PINS Q=bank_mem_1[4][21] D=FE_DBTN126_n26
+ CK=CTS_679
Xbank_mem_1_reg[4][20] QDFFN $PINS Q=bank_mem_1[4][20] D=FE_DBTN127_n25
+ CK=CTS_679
Xbank_mem_1_reg[4][19] QDFFN $PINS Q=bank_mem_1[4][19] D=FE_DBTN128_n24
+ CK=CTS_679
Xbank_mem_1_reg[4][18] QDFFN $PINS Q=bank_mem_1[4][18] D=FE_DBTN129_n23
+ CK=CTS_679
Xbank_mem_1_reg[4][17] QDFFN $PINS Q=bank_mem_1[4][17] D=FE_DBTN130_n22
+ CK=CTS_679
Xbank_mem_1_reg[4][16] QDFFN $PINS Q=bank_mem_1[4][16] D=FE_DBTN131_n21
+ CK=CTS_631
Xbank_mem_1_reg[4][15] QDFFN $PINS Q=bank_mem_1[4][15] D=FE_DBTN132_n20
+ CK=CTS_631
Xbank_mem_1_reg[4][14] QDFFN $PINS Q=bank_mem_1[4][14] D=FE_DBTN133_n19
+ CK=CTS_631
Xbank_mem_1_reg[4][13] QDFFN $PINS Q=bank_mem_1[4][13] D=FE_DBTN134_n18
+ CK=CTS_631
Xbank_mem_1_reg[4][12] QDFFN $PINS Q=bank_mem_1[4][12] D=FE_DBTN150_n2
+ CK=CTS_631
Xbank_mem_1_reg[4][11] QDFFN $PINS Q=bank_mem_1[4][11] D=FE_DBTN147_n5
+ CK=CTS_631
Xbank_mem_1_reg[4][10] QDFFN $PINS Q=bank_mem_1[4][10] D=FE_DBTN148_n4
+ CK=CTS_631
Xbank_mem_1_reg[4][9] QDFFN $PINS Q=bank_mem_1[4][9] D=FE_DBTN89_n63 CK=CTS_631
Xbank_mem_1_reg[4][8] QDFFN $PINS Q=bank_mem_1[4][8] D=FE_DBTN84_n68 CK=CTS_631
Xbank_mem_1_reg[4][7] QDFFN $PINS Q=bank_mem_1[4][7] D=FE_DBTN85_n67 CK=CTS_631
Xbank_mem_1_reg[4][6] QDFFN $PINS Q=bank_mem_1[4][6] D=FE_DBTN86_n66 CK=CTS_631
Xbank_mem_1_reg[4][5] QDFFN $PINS Q=bank_mem_1[4][5] D=FE_DBTN87_n65 CK=CTS_631
Xbank_mem_1_reg[4][4] QDFFN $PINS Q=bank_mem_1[4][4] D=FE_DBTN88_n64 CK=CTS_631
Xbank_mem_1_reg[4][3] QDFFN $PINS Q=bank_mem_1[4][3] D=FE_DBTN121_n31
+ CK=CTS_631
Xbank_mem_1_reg[4][2] QDFFN $PINS Q=bank_mem_1[4][2] D=FE_DBTN142_n10
+ CK=CTS_631
Xbank_mem_1_reg[4][1] QDFFN $PINS Q=bank_mem_1[4][1] D=FE_DBTN135_n17
+ CK=CTS_631
Xbank_mem_1_reg[4][0] QDFFN $PINS Q=bank_mem_1[4][0] D=FE_DBTN149_n3 CK=CTS_631
Xbank_mem_1_reg[6][33] QDFFN $PINS Q=bank_mem_1[6][33] D=FE_DBTN120_n32
+ CK=CTS_610
Xbank_mem_1_reg[6][32] QDFFN $PINS Q=bank_mem_1[6][32] D=FE_DBTN136_n16
+ CK=CTS_610
Xbank_mem_1_reg[6][31] QDFFN $PINS Q=bank_mem_1[6][31] D=FE_DBTN137_n15
+ CK=CTS_610
Xbank_mem_1_reg[6][30] QDFFN $PINS Q=bank_mem_1[6][30] D=FE_DBTN138_n14
+ CK=CTS_610
Xbank_mem_1_reg[6][29] QDFFN $PINS Q=bank_mem_1[6][29] D=FE_DBTN139_n13
+ CK=CTS_610
Xbank_mem_1_reg[6][28] QDFFN $PINS Q=bank_mem_1[6][28] D=FE_DBTN140_n12
+ CK=CTS_610
Xbank_mem_1_reg[6][27] QDFFN $PINS Q=bank_mem_1[6][27] D=FE_DBTN151_n1
+ CK=CTS_610
Xbank_mem_1_reg[6][26] QDFFN $PINS Q=bank_mem_1[6][26] D=FE_DBTN141_n11
+ CK=CTS_610
Xbank_mem_1_reg[6][25] QDFFN $PINS Q=bank_mem_1[6][25] D=FE_DBTN122_n30
+ CK=CTS_610
Xbank_mem_1_reg[6][24] QDFFN $PINS Q=bank_mem_1[6][24] D=FE_DBTN123_n29
+ CK=CTS_610
Xbank_mem_1_reg[6][23] QDFFN $PINS Q=bank_mem_1[6][23] D=FE_DBTN124_n28
+ CK=CTS_610
Xbank_mem_1_reg[6][22] QDFFN $PINS Q=bank_mem_1[6][22] D=FE_DBTN125_n27
+ CK=CTS_610
Xbank_mem_1_reg[6][21] QDFFN $PINS Q=bank_mem_1[6][21] D=FE_DBTN126_n26
+ CK=CTS_610
Xbank_mem_1_reg[6][20] QDFFN $PINS Q=bank_mem_1[6][20] D=FE_DBTN127_n25
+ CK=CTS_610
Xbank_mem_1_reg[6][19] QDFFN $PINS Q=bank_mem_1[6][19] D=FE_DBTN128_n24
+ CK=CTS_610
Xbank_mem_1_reg[6][18] QDFFN $PINS Q=bank_mem_1[6][18] D=FE_DBTN129_n23
+ CK=CTS_610
Xbank_mem_1_reg[6][17] QDFFN $PINS Q=bank_mem_1[6][17] D=FE_DBTN130_n22
+ CK=CTS_610
Xbank_mem_1_reg[6][16] QDFFN $PINS Q=bank_mem_1[6][16] D=FE_DBTN131_n21
+ CK=CTS_673
Xbank_mem_1_reg[6][15] QDFFN $PINS Q=FE_PHN1478_bank_mem_1_6_15
+ D=FE_DBTN132_n20 CK=CTS_673
Xbank_mem_1_reg[6][14] QDFFN $PINS Q=bank_mem_1[6][14] D=FE_DBTN133_n19
+ CK=CTS_673
Xbank_mem_1_reg[6][13] QDFFN $PINS Q=bank_mem_1[6][13] D=FE_DBTN134_n18
+ CK=CTS_673
Xbank_mem_1_reg[6][12] QDFFN $PINS Q=bank_mem_1[6][12] D=FE_DBTN150_n2
+ CK=CTS_673
Xbank_mem_1_reg[6][11] QDFFN $PINS Q=bank_mem_1[6][11] D=FE_DBTN147_n5
+ CK=CTS_673
Xbank_mem_1_reg[6][10] QDFFN $PINS Q=bank_mem_1[6][10] D=FE_DBTN148_n4
+ CK=CTS_673
Xbank_mem_1_reg[6][9] QDFFN $PINS Q=bank_mem_1[6][9] D=FE_DBTN89_n63 CK=CTS_673
Xbank_mem_1_reg[6][8] QDFFN $PINS Q=bank_mem_1[6][8] D=FE_DBTN84_n68 CK=CTS_673
Xbank_mem_1_reg[6][7] QDFFN $PINS Q=bank_mem_1[6][7] D=FE_DBTN85_n67 CK=CTS_673
Xbank_mem_1_reg[6][6] QDFFN $PINS Q=bank_mem_1[6][6] D=FE_DBTN86_n66 CK=CTS_673
Xbank_mem_1_reg[6][5] QDFFN $PINS Q=bank_mem_1[6][5] D=FE_DBTN87_n65 CK=CTS_673
Xbank_mem_1_reg[6][4] QDFFN $PINS Q=bank_mem_1[6][4] D=FE_DBTN88_n64 CK=CTS_673
Xbank_mem_1_reg[6][3] QDFFN $PINS Q=bank_mem_1[6][3] D=FE_DBTN121_n31
+ CK=CTS_673
Xbank_mem_1_reg[6][2] QDFFN $PINS Q=bank_mem_1[6][2] D=FE_DBTN142_n10
+ CK=CTS_673
Xbank_mem_1_reg[6][1] QDFFN $PINS Q=bank_mem_1[6][1] D=FE_DBTN135_n17
+ CK=CTS_673
Xbank_mem_1_reg[6][0] QDFFN $PINS Q=bank_mem_1[6][0] D=FE_DBTN149_n3 CK=CTS_673
Xbank_mem_1_reg[2][33] QDFFN $PINS Q=bank_mem_1[2][33] D=FE_DBTN120_n32
+ CK=CTS_637
Xbank_mem_1_reg[2][32] QDFFN $PINS Q=bank_mem_1[2][32] D=FE_DBTN136_n16
+ CK=CTS_637
Xbank_mem_1_reg[2][31] QDFFN $PINS Q=bank_mem_1[2][31] D=FE_DBTN137_n15
+ CK=CTS_637
Xbank_mem_1_reg[2][30] QDFFN $PINS Q=bank_mem_1[2][30] D=FE_DBTN138_n14
+ CK=CTS_637
Xbank_mem_1_reg[2][29] QDFFN $PINS Q=bank_mem_1[2][29] D=FE_DBTN139_n13
+ CK=CTS_637
Xbank_mem_1_reg[2][28] QDFFN $PINS Q=bank_mem_1[2][28] D=FE_DBTN140_n12
+ CK=CTS_637
Xbank_mem_1_reg[2][27] QDFFN $PINS Q=bank_mem_1[2][27] D=FE_DBTN151_n1
+ CK=CTS_637
Xbank_mem_1_reg[2][26] QDFFN $PINS Q=bank_mem_1[2][26] D=FE_DBTN141_n11
+ CK=CTS_637
Xbank_mem_1_reg[2][25] QDFFN $PINS Q=bank_mem_1[2][25] D=FE_DBTN122_n30
+ CK=CTS_637
Xbank_mem_1_reg[2][24] QDFFN $PINS Q=bank_mem_1[2][24] D=FE_DBTN123_n29
+ CK=CTS_637
Xbank_mem_1_reg[2][23] QDFFN $PINS Q=bank_mem_1[2][23] D=FE_DBTN124_n28
+ CK=CTS_637
Xbank_mem_1_reg[2][22] QDFFN $PINS Q=bank_mem_1[2][22] D=FE_DBTN125_n27
+ CK=CTS_637
Xbank_mem_1_reg[2][21] QDFFN $PINS Q=bank_mem_1[2][21] D=FE_DBTN126_n26
+ CK=CTS_637
Xbank_mem_1_reg[2][20] QDFFN $PINS Q=bank_mem_1[2][20] D=FE_DBTN127_n25
+ CK=CTS_637
Xbank_mem_1_reg[2][19] QDFFN $PINS Q=bank_mem_1[2][19] D=FE_DBTN128_n24
+ CK=CTS_637
Xbank_mem_1_reg[2][18] QDFFN $PINS Q=bank_mem_1[2][18] D=FE_DBTN129_n23
+ CK=CTS_637
Xbank_mem_1_reg[2][17] QDFFN $PINS Q=bank_mem_1[2][17] D=FE_DBTN130_n22
+ CK=CTS_637
Xbank_mem_1_reg[2][16] QDFFN $PINS Q=bank_mem_1[2][16] D=FE_DBTN131_n21
+ CK=CTS_685
Xbank_mem_1_reg[2][15] QDFFN $PINS Q=bank_mem_1[2][15] D=FE_DBTN132_n20
+ CK=CTS_685
Xbank_mem_1_reg[2][14] QDFFN $PINS Q=bank_mem_1[2][14] D=FE_DBTN133_n19
+ CK=CTS_685
Xbank_mem_1_reg[2][13] QDFFN $PINS Q=bank_mem_1[2][13] D=FE_DBTN134_n18
+ CK=CTS_685
Xbank_mem_1_reg[2][12] QDFFN $PINS Q=bank_mem_1[2][12] D=FE_DBTN150_n2
+ CK=CTS_685
Xbank_mem_1_reg[2][11] QDFFN $PINS Q=bank_mem_1[2][11] D=FE_DBTN147_n5
+ CK=CTS_685
Xbank_mem_1_reg[2][10] QDFFN $PINS Q=bank_mem_1[2][10] D=FE_DBTN148_n4
+ CK=CTS_685
Xbank_mem_1_reg[2][9] QDFFN $PINS Q=bank_mem_1[2][9] D=FE_DBTN89_n63 CK=CTS_685
Xbank_mem_1_reg[2][8] QDFFN $PINS Q=bank_mem_1[2][8] D=FE_DBTN84_n68 CK=CTS_685
Xbank_mem_1_reg[2][7] QDFFN $PINS Q=bank_mem_1[2][7] D=FE_DBTN85_n67 CK=CTS_685
Xbank_mem_1_reg[2][6] QDFFN $PINS Q=bank_mem_1[2][6] D=FE_DBTN86_n66 CK=CTS_685
Xbank_mem_1_reg[2][5] QDFFN $PINS Q=bank_mem_1[2][5] D=FE_DBTN87_n65 CK=CTS_685
Xbank_mem_1_reg[2][4] QDFFN $PINS Q=bank_mem_1[2][4] D=FE_DBTN88_n64 CK=CTS_685
Xbank_mem_1_reg[2][3] QDFFN $PINS Q=bank_mem_1[2][3] D=FE_DBTN121_n31
+ CK=CTS_685
Xbank_mem_1_reg[2][2] QDFFN $PINS Q=bank_mem_1[2][2] D=FE_DBTN142_n10
+ CK=CTS_685
Xbank_mem_1_reg[2][1] QDFFN $PINS Q=bank_mem_1[2][1] D=FE_DBTN135_n17
+ CK=CTS_685
Xbank_mem_1_reg[2][0] QDFFN $PINS Q=bank_mem_1[2][0] D=FE_DBTN149_n3 CK=CTS_685
Xbank_mem_1_reg[7][32] QDFFN $PINS Q=bank_mem_1[7][32] D=FE_DBTN136_n16
+ CK=CTS_670
Xbank_mem_1_reg[7][31] QDFFN $PINS Q=bank_mem_1[7][31] D=FE_DBTN137_n15
+ CK=CTS_670
Xbank_mem_1_reg[7][30] QDFFN $PINS Q=bank_mem_1[7][30] D=FE_DBTN138_n14
+ CK=CTS_670
Xbank_mem_1_reg[7][29] QDFFN $PINS Q=bank_mem_1[7][29] D=FE_DBTN139_n13
+ CK=CTS_670
Xbank_mem_1_reg[7][28] QDFFN $PINS Q=bank_mem_1[7][28] D=FE_DBTN140_n12
+ CK=CTS_670
Xbank_mem_1_reg[7][27] QDFFN $PINS Q=bank_mem_1[7][27] D=FE_DBTN151_n1
+ CK=CTS_670
Xbank_mem_1_reg[7][26] QDFFN $PINS Q=bank_mem_1[7][26] D=FE_DBTN141_n11
+ CK=CTS_670
Xbank_mem_1_reg[7][25] QDFFN $PINS Q=bank_mem_1[7][25] D=FE_DBTN122_n30
+ CK=CTS_670
Xbank_mem_1_reg[7][24] QDFFN $PINS Q=bank_mem_1[7][24] D=FE_DBTN123_n29
+ CK=CTS_670
Xbank_mem_1_reg[7][23] QDFFN $PINS Q=bank_mem_1[7][23] D=FE_DBTN124_n28
+ CK=CTS_670
Xbank_mem_1_reg[7][22] QDFFN $PINS Q=bank_mem_1[7][22] D=FE_DBTN125_n27
+ CK=CTS_670
Xbank_mem_1_reg[7][21] QDFFN $PINS Q=bank_mem_1[7][21] D=FE_DBTN126_n26
+ CK=CTS_670
Xbank_mem_1_reg[7][20] QDFFN $PINS Q=bank_mem_1[7][20] D=FE_DBTN127_n25
+ CK=CTS_670
Xbank_mem_1_reg[7][19] QDFFN $PINS Q=bank_mem_1[7][19] D=FE_DBTN128_n24
+ CK=CTS_670
Xbank_mem_1_reg[7][18] QDFFN $PINS Q=bank_mem_1[7][18] D=FE_DBTN129_n23
+ CK=CTS_670
Xbank_mem_1_reg[7][17] QDFFN $PINS Q=bank_mem_1[7][17] D=FE_DBTN130_n22
+ CK=CTS_670
Xbank_mem_1_reg[7][16] QDFFN $PINS Q=bank_mem_1[7][16] D=FE_DBTN131_n21
+ CK=CTS_667
Xbank_mem_1_reg[7][15] QDFFN $PINS Q=bank_mem_1[7][15] D=FE_DBTN132_n20
+ CK=CTS_667
Xbank_mem_1_reg[7][14] QDFFN $PINS Q=bank_mem_1[7][14] D=FE_DBTN133_n19
+ CK=CTS_667
Xbank_mem_1_reg[7][13] QDFFN $PINS Q=bank_mem_1[7][13] D=FE_DBTN134_n18
+ CK=CTS_667
Xbank_mem_1_reg[7][12] QDFFN $PINS Q=bank_mem_1[7][12] D=FE_DBTN150_n2
+ CK=CTS_667
Xbank_mem_1_reg[7][11] QDFFN $PINS Q=bank_mem_1[7][11] D=FE_DBTN147_n5
+ CK=CTS_667
Xbank_mem_1_reg[7][10] QDFFN $PINS Q=bank_mem_1[7][10] D=FE_DBTN148_n4
+ CK=CTS_667
Xbank_mem_1_reg[7][9] QDFFN $PINS Q=bank_mem_1[7][9] D=FE_DBTN89_n63 CK=CTS_667
Xbank_mem_1_reg[7][8] QDFFN $PINS Q=bank_mem_1[7][8] D=FE_DBTN84_n68 CK=CTS_667
Xbank_mem_1_reg[7][7] QDFFN $PINS Q=bank_mem_1[7][7] D=FE_DBTN85_n67 CK=CTS_667
Xbank_mem_1_reg[7][6] QDFFN $PINS Q=bank_mem_1[7][6] D=FE_DBTN86_n66 CK=CTS_667
Xbank_mem_1_reg[7][5] QDFFN $PINS Q=bank_mem_1[7][5] D=FE_DBTN87_n65 CK=CTS_667
Xbank_mem_1_reg[7][4] QDFFN $PINS Q=bank_mem_1[7][4] D=FE_DBTN88_n64 CK=CTS_667
Xbank_mem_1_reg[7][3] QDFFN $PINS Q=bank_mem_1[7][3] D=FE_DBTN121_n31
+ CK=CTS_667
Xbank_mem_1_reg[7][2] QDFFN $PINS Q=bank_mem_1[7][2] D=FE_DBTN142_n10
+ CK=CTS_667
Xbank_mem_1_reg[7][1] QDFFN $PINS Q=bank_mem_1[7][1] D=FE_DBTN135_n17
+ CK=CTS_667
Xbank_mem_1_reg[7][0] QDFFN $PINS Q=bank_mem_1[7][0] D=FE_DBTN149_n3 CK=CTS_667
Xbank_mem_1_reg[7][33] QDFFN $PINS Q=FE_PHN1066_bank_mem_1_7_33
+ D=FE_DBTN120_n32 CK=CTS_670
Xbank_mem_1_reg[3][33] QDFFN $PINS Q=bank_mem_1[3][33] D=FE_DBTN120_n32
+ CK=CTS_634
Xbank_mem_1_reg[3][32] QDFFN $PINS Q=bank_mem_1[3][32] D=FE_DBTN136_n16
+ CK=CTS_634
Xbank_mem_1_reg[3][31] QDFFN $PINS Q=bank_mem_1[3][31] D=FE_DBTN137_n15
+ CK=CTS_634
Xbank_mem_1_reg[3][30] QDFFN $PINS Q=bank_mem_1[3][30] D=FE_DBTN138_n14
+ CK=CTS_634
Xbank_mem_1_reg[3][29] QDFFN $PINS Q=bank_mem_1[3][29] D=FE_DBTN139_n13
+ CK=CTS_634
Xbank_mem_1_reg[3][28] QDFFN $PINS Q=bank_mem_1[3][28] D=FE_DBTN140_n12
+ CK=CTS_634
Xbank_mem_1_reg[3][27] QDFFN $PINS Q=bank_mem_1[3][27] D=FE_DBTN151_n1
+ CK=CTS_634
Xbank_mem_1_reg[3][26] QDFFN $PINS Q=bank_mem_1[3][26] D=FE_DBTN141_n11
+ CK=CTS_634
Xbank_mem_1_reg[3][25] QDFFN $PINS Q=bank_mem_1[3][25] D=FE_DBTN122_n30
+ CK=CTS_634
Xbank_mem_1_reg[3][24] QDFFN $PINS Q=bank_mem_1[3][24] D=FE_DBTN123_n29
+ CK=CTS_634
Xbank_mem_1_reg[3][23] QDFFN $PINS Q=bank_mem_1[3][23] D=FE_DBTN124_n28
+ CK=CTS_634
Xbank_mem_1_reg[3][22] QDFFN $PINS Q=bank_mem_1[3][22] D=FE_DBTN125_n27
+ CK=CTS_634
Xbank_mem_1_reg[3][21] QDFFN $PINS Q=bank_mem_1[3][21] D=FE_DBTN126_n26
+ CK=CTS_634
Xbank_mem_1_reg[3][20] QDFFN $PINS Q=bank_mem_1[3][20] D=FE_DBTN127_n25
+ CK=CTS_634
Xbank_mem_1_reg[3][19] QDFFN $PINS Q=bank_mem_1[3][19] D=FE_DBTN128_n24
+ CK=CTS_634
Xbank_mem_1_reg[3][18] QDFFN $PINS Q=bank_mem_1[3][18] D=FE_DBTN129_n23
+ CK=CTS_634
Xbank_mem_1_reg[3][17] QDFFN $PINS Q=bank_mem_1[3][17] D=FE_DBTN130_n22
+ CK=CTS_634
Xbank_mem_1_reg[3][16] QDFFN $PINS Q=bank_mem_1[3][16] D=FE_DBTN131_n21
+ CK=CTS_682
Xbank_mem_1_reg[3][15] QDFFN $PINS Q=bank_mem_1[3][15] D=FE_DBTN132_n20
+ CK=CTS_682
Xbank_mem_1_reg[3][14] QDFFN $PINS Q=bank_mem_1[3][14] D=FE_DBTN133_n19
+ CK=CTS_682
Xbank_mem_1_reg[3][13] QDFFN $PINS Q=bank_mem_1[3][13] D=FE_DBTN134_n18
+ CK=CTS_682
Xbank_mem_1_reg[3][12] QDFFN $PINS Q=bank_mem_1[3][12] D=FE_DBTN150_n2
+ CK=CTS_682
Xbank_mem_1_reg[3][11] QDFFN $PINS Q=bank_mem_1[3][11] D=FE_DBTN147_n5
+ CK=CTS_682
Xbank_mem_1_reg[3][10] QDFFN $PINS Q=bank_mem_1[3][10] D=FE_DBTN148_n4
+ CK=CTS_682
Xbank_mem_1_reg[3][9] QDFFN $PINS Q=bank_mem_1[3][9] D=FE_DBTN89_n63 CK=CTS_682
Xbank_mem_1_reg[3][8] QDFFN $PINS Q=bank_mem_1[3][8] D=FE_DBTN84_n68 CK=CTS_682
Xbank_mem_1_reg[3][7] QDFFN $PINS Q=bank_mem_1[3][7] D=FE_DBTN85_n67 CK=CTS_682
Xbank_mem_1_reg[3][6] QDFFN $PINS Q=bank_mem_1[3][6] D=FE_DBTN86_n66 CK=CTS_682
Xbank_mem_1_reg[3][5] QDFFN $PINS Q=bank_mem_1[3][5] D=FE_DBTN87_n65 CK=CTS_682
Xbank_mem_1_reg[3][4] QDFFN $PINS Q=bank_mem_1[3][4] D=FE_DBTN88_n64 CK=CTS_682
Xbank_mem_1_reg[3][3] QDFFN $PINS Q=bank_mem_1[3][3] D=FE_DBTN121_n31
+ CK=CTS_682
Xbank_mem_1_reg[3][2] QDFFN $PINS Q=bank_mem_1[3][2] D=FE_DBTN142_n10
+ CK=CTS_682
Xbank_mem_1_reg[3][1] QDFFN $PINS Q=bank_mem_1[3][1] D=FE_DBTN135_n17
+ CK=CTS_682
Xbank_mem_1_reg[3][0] QDFFN $PINS Q=bank_mem_1[3][0] D=FE_DBTN149_n3 CK=CTS_682
Xbank_mem_1_reg[5][33] QDFFN $PINS Q=bank_mem_1[5][33] D=FE_DBTN120_n32
+ CK=CTS_613
Xbank_mem_1_reg[5][32] QDFFN $PINS Q=bank_mem_1[5][32] D=FE_DBTN136_n16
+ CK=CTS_613
Xbank_mem_1_reg[5][31] QDFFN $PINS Q=bank_mem_1[5][31] D=FE_DBTN137_n15
+ CK=CTS_613
Xbank_mem_1_reg[5][30] QDFFN $PINS Q=bank_mem_1[5][30] D=FE_DBTN138_n14
+ CK=CTS_613
Xbank_mem_1_reg[5][29] QDFFN $PINS Q=bank_mem_1[5][29] D=FE_DBTN139_n13
+ CK=CTS_613
Xbank_mem_1_reg[5][28] QDFFN $PINS Q=bank_mem_1[5][28] D=FE_DBTN140_n12
+ CK=CTS_613
Xbank_mem_1_reg[5][27] QDFFN $PINS Q=bank_mem_1[5][27] D=FE_DBTN151_n1
+ CK=CTS_613
Xbank_mem_1_reg[5][26] QDFFN $PINS Q=bank_mem_1[5][26] D=FE_DBTN141_n11
+ CK=CTS_613
Xbank_mem_1_reg[5][25] QDFFN $PINS Q=bank_mem_1[5][25] D=FE_DBTN122_n30
+ CK=CTS_613
Xbank_mem_1_reg[5][24] QDFFN $PINS Q=bank_mem_1[5][24] D=FE_DBTN123_n29
+ CK=CTS_613
Xbank_mem_1_reg[5][23] QDFFN $PINS Q=bank_mem_1[5][23] D=FE_DBTN124_n28
+ CK=CTS_613
Xbank_mem_1_reg[5][22] QDFFN $PINS Q=bank_mem_1[5][22] D=FE_DBTN125_n27
+ CK=CTS_613
Xbank_mem_1_reg[5][21] QDFFN $PINS Q=bank_mem_1[5][21] D=FE_DBTN126_n26
+ CK=CTS_613
Xbank_mem_1_reg[5][20] QDFFN $PINS Q=bank_mem_1[5][20] D=FE_DBTN127_n25
+ CK=CTS_613
Xbank_mem_1_reg[5][19] QDFFN $PINS Q=bank_mem_1[5][19] D=FE_DBTN128_n24
+ CK=CTS_613
Xbank_mem_1_reg[5][18] QDFFN $PINS Q=bank_mem_1[5][18] D=FE_DBTN129_n23
+ CK=CTS_613
Xbank_mem_1_reg[5][17] QDFFN $PINS Q=bank_mem_1[5][17] D=FE_DBTN130_n22
+ CK=CTS_613
Xbank_mem_1_reg[5][16] QDFFN $PINS Q=bank_mem_1[5][16] D=FE_DBTN131_n21
+ CK=CTS_676
Xbank_mem_1_reg[5][15] QDFFN $PINS Q=bank_mem_1[5][15] D=FE_DBTN132_n20
+ CK=CTS_676
Xbank_mem_1_reg[5][14] QDFFN $PINS Q=bank_mem_1[5][14] D=FE_DBTN133_n19
+ CK=CTS_676
Xbank_mem_1_reg[5][13] QDFFN $PINS Q=bank_mem_1[5][13] D=FE_DBTN134_n18
+ CK=CTS_676
Xbank_mem_1_reg[5][12] QDFFN $PINS Q=bank_mem_1[5][12] D=FE_DBTN150_n2
+ CK=CTS_676
Xbank_mem_1_reg[5][11] QDFFN $PINS Q=bank_mem_1[5][11] D=FE_DBTN147_n5
+ CK=CTS_676
Xbank_mem_1_reg[5][10] QDFFN $PINS Q=bank_mem_1[5][10] D=FE_DBTN148_n4
+ CK=CTS_676
Xbank_mem_1_reg[5][9] QDFFN $PINS Q=bank_mem_1[5][9] D=FE_DBTN89_n63 CK=CTS_676
Xbank_mem_1_reg[5][8] QDFFN $PINS Q=bank_mem_1[5][8] D=FE_DBTN84_n68 CK=CTS_676
Xbank_mem_1_reg[5][7] QDFFN $PINS Q=bank_mem_1[5][7] D=FE_DBTN85_n67 CK=CTS_676
Xbank_mem_1_reg[5][6] QDFFN $PINS Q=bank_mem_1[5][6] D=FE_DBTN86_n66 CK=CTS_676
Xbank_mem_1_reg[5][5] QDFFN $PINS Q=bank_mem_1[5][5] D=FE_DBTN87_n65 CK=CTS_676
Xbank_mem_1_reg[5][4] QDFFN $PINS Q=bank_mem_1[5][4] D=FE_DBTN88_n64 CK=CTS_676
Xbank_mem_1_reg[5][3] QDFFN $PINS Q=bank_mem_1[5][3] D=FE_DBTN121_n31
+ CK=CTS_676
Xbank_mem_1_reg[5][2] QDFFN $PINS Q=bank_mem_1[5][2] D=FE_DBTN142_n10
+ CK=CTS_676
Xbank_mem_1_reg[5][1] QDFFN $PINS Q=bank_mem_1[5][1] D=FE_DBTN135_n17
+ CK=CTS_676
Xbank_mem_1_reg[5][0] QDFFN $PINS Q=bank_mem_1[5][0] D=FE_DBTN149_n3 CK=CTS_676
Xbank_mem_0_reg[4][33] QDFFN $PINS Q=bank_mem_0[4][33] D=FE_DBTN96_n56
+ CK=CTS_770
Xbank_mem_0_reg[4][32] QDFFN $PINS Q=bank_mem_0[4][32] D=FE_DBTN97_n55
+ CK=CTS_770
Xbank_mem_0_reg[4][31] QDFFN $PINS Q=bank_mem_0[4][31] D=FE_DBTN98_n54
+ CK=CTS_770
Xbank_mem_0_reg[4][30] QDFFN $PINS Q=bank_mem_0[4][30] D=FE_DBTN99_n53
+ CK=CTS_770
Xbank_mem_0_reg[4][29] QDFFN $PINS Q=bank_mem_0[4][29] D=FE_DBTN100_n52
+ CK=CTS_770
Xbank_mem_0_reg[4][28] QDFFN $PINS Q=bank_mem_0[4][28] D=FE_DBTN101_n51
+ CK=CTS_770
Xbank_mem_0_reg[4][27] QDFFN $PINS Q=bank_mem_0[4][27] D=FE_DBTN102_n50
+ CK=CTS_770
Xbank_mem_0_reg[4][26] QDFFN $PINS Q=bank_mem_0[4][26] D=FE_DBTN103_n49
+ CK=CTS_770
Xbank_mem_0_reg[4][25] QDFFN $PINS Q=bank_mem_0[4][25] D=FE_DBTN104_n48
+ CK=CTS_770
Xbank_mem_0_reg[4][24] QDFFN $PINS Q=bank_mem_0[4][24] D=FE_DBTN105_n47
+ CK=CTS_770
Xbank_mem_0_reg[4][23] QDFFN $PINS Q=bank_mem_0[4][23] D=FE_DBTN106_n46
+ CK=CTS_770
Xbank_mem_0_reg[4][22] QDFFN $PINS Q=bank_mem_0[4][22] D=FE_DBTN107_n45
+ CK=CTS_770
Xbank_mem_0_reg[4][21] QDFFN $PINS Q=bank_mem_0[4][21] D=FE_DBTN108_n44
+ CK=CTS_770
Xbank_mem_0_reg[4][20] QDFFN $PINS Q=bank_mem_0[4][20] D=FE_DBTN109_n43
+ CK=CTS_770
Xbank_mem_0_reg[4][19] QDFFN $PINS Q=bank_mem_0[4][19] D=FE_DBTN110_n42
+ CK=CTS_770
Xbank_mem_0_reg[4][18] QDFFN $PINS Q=bank_mem_0[4][18] D=FE_DBTN111_n41
+ CK=CTS_770
Xbank_mem_0_reg[4][17] QDFFN $PINS Q=bank_mem_0[4][17] D=FE_DBTN112_n40
+ CK=CTS_770
Xbank_mem_0_reg[4][16] QDFFN $PINS Q=bank_mem_0[4][16] D=FE_DBTN113_n39
+ CK=CTS_767
Xbank_mem_0_reg[4][15] QDFFN $PINS Q=bank_mem_0[4][15] D=FE_DBTN114_n38
+ CK=CTS_767
Xbank_mem_0_reg[4][14] QDFFN $PINS Q=bank_mem_0[4][14] D=FE_DBTN115_n37
+ CK=CTS_767
Xbank_mem_0_reg[4][13] QDFFN $PINS Q=bank_mem_0[4][13] D=FE_DBTN116_n36
+ CK=CTS_767
Xbank_mem_0_reg[4][12] QDFFN $PINS Q=bank_mem_0[4][12] D=FE_DBTN143_n9
+ CK=CTS_767
Xbank_mem_0_reg[4][11] QDFFN $PINS Q=bank_mem_0[4][11] D=FE_DBTN144_n8
+ CK=CTS_767
Xbank_mem_0_reg[4][10] QDFFN $PINS Q=bank_mem_0[4][10] D=FE_DBTN145_n7
+ CK=CTS_767
Xbank_mem_0_reg[4][9] QDFFN $PINS Q=bank_mem_0[4][9] D=FE_DBTN90_n62 CK=CTS_767
Xbank_mem_0_reg[4][8] QDFFN $PINS Q=bank_mem_0[4][8] D=FE_DBTN91_n61 CK=CTS_767
Xbank_mem_0_reg[4][7] QDFFN $PINS Q=bank_mem_0[4][7] D=FE_DBTN92_n60 CK=CTS_767
Xbank_mem_0_reg[4][6] QDFFN $PINS Q=bank_mem_0[4][6] D=FE_DBTN93_n59 CK=CTS_767
Xbank_mem_0_reg[4][5] QDFFN $PINS Q=bank_mem_0[4][5] D=FE_DBTN94_n58 CK=CTS_767
Xbank_mem_0_reg[4][4] QDFFN $PINS Q=bank_mem_0[4][4] D=FE_DBTN95_n57 CK=CTS_767
Xbank_mem_0_reg[4][3] QDFFN $PINS Q=bank_mem_0[4][3] D=FE_DBTN117_n35
+ CK=CTS_767
Xbank_mem_0_reg[4][2] QDFFN $PINS Q=bank_mem_0[4][2] D=FE_DBTN118_n34
+ CK=CTS_767
Xbank_mem_0_reg[4][1] QDFFN $PINS Q=bank_mem_0[4][1] D=FE_DBTN119_n33
+ CK=CTS_767
Xbank_mem_0_reg[4][0] QDFFN $PINS Q=bank_mem_0[4][0] D=FE_DBTN146_n6 CK=CTS_767
Xbank_mem_0_reg[6][33] QDFFN $PINS Q=bank_mem_0[6][33] D=FE_DBTN96_n56
+ CK=CTS_758
Xbank_mem_0_reg[6][32] QDFFN $PINS Q=bank_mem_0[6][32] D=FE_DBTN97_n55
+ CK=CTS_758
Xbank_mem_0_reg[6][31] QDFFN $PINS Q=bank_mem_0[6][31] D=FE_DBTN98_n54
+ CK=CTS_758
Xbank_mem_0_reg[6][30] QDFFN $PINS Q=bank_mem_0[6][30] D=FE_DBTN99_n53
+ CK=CTS_758
Xbank_mem_0_reg[6][29] QDFFN $PINS Q=bank_mem_0[6][29] D=FE_DBTN100_n52
+ CK=CTS_758
Xbank_mem_0_reg[6][28] QDFFN $PINS Q=bank_mem_0[6][28] D=FE_DBTN101_n51
+ CK=CTS_758
Xbank_mem_0_reg[6][27] QDFFN $PINS Q=bank_mem_0[6][27] D=FE_DBTN102_n50
+ CK=CTS_758
Xbank_mem_0_reg[6][26] QDFFN $PINS Q=bank_mem_0[6][26] D=FE_DBTN103_n49
+ CK=CTS_758
Xbank_mem_0_reg[6][25] QDFFN $PINS Q=bank_mem_0[6][25] D=FE_DBTN104_n48
+ CK=CTS_758
Xbank_mem_0_reg[6][24] QDFFN $PINS Q=bank_mem_0[6][24] D=FE_DBTN105_n47
+ CK=CTS_758
Xbank_mem_0_reg[6][23] QDFFN $PINS Q=bank_mem_0[6][23] D=FE_DBTN106_n46
+ CK=CTS_758
Xbank_mem_0_reg[6][22] QDFFN $PINS Q=bank_mem_0[6][22] D=FE_DBTN107_n45
+ CK=CTS_758
Xbank_mem_0_reg[6][21] QDFFN $PINS Q=bank_mem_0[6][21] D=FE_DBTN108_n44
+ CK=CTS_758
Xbank_mem_0_reg[6][20] QDFFN $PINS Q=bank_mem_0[6][20] D=FE_DBTN109_n43
+ CK=CTS_758
Xbank_mem_0_reg[6][19] QDFFN $PINS Q=bank_mem_0[6][19] D=FE_DBTN110_n42
+ CK=CTS_758
Xbank_mem_0_reg[6][18] QDFFN $PINS Q=bank_mem_0[6][18] D=FE_DBTN111_n41
+ CK=CTS_758
Xbank_mem_0_reg[6][17] QDFFN $PINS Q=bank_mem_0[6][17] D=FE_DBTN112_n40
+ CK=CTS_758
Xbank_mem_0_reg[6][16] QDFFN $PINS Q=bank_mem_0[6][16] D=FE_DBTN113_n39
+ CK=CTS_755
Xbank_mem_0_reg[6][15] QDFFN $PINS Q=bank_mem_0[6][15] D=FE_DBTN114_n38
+ CK=CTS_755
Xbank_mem_0_reg[6][14] QDFFN $PINS Q=bank_mem_0[6][14] D=FE_DBTN115_n37
+ CK=CTS_755
Xbank_mem_0_reg[6][13] QDFFN $PINS Q=bank_mem_0[6][13] D=FE_DBTN116_n36
+ CK=CTS_755
Xbank_mem_0_reg[6][12] QDFFN $PINS Q=bank_mem_0[6][12] D=FE_DBTN143_n9
+ CK=CTS_755
Xbank_mem_0_reg[6][11] QDFFN $PINS Q=bank_mem_0[6][11] D=FE_DBTN144_n8
+ CK=CTS_755
Xbank_mem_0_reg[6][10] QDFFN $PINS Q=bank_mem_0[6][10] D=FE_DBTN145_n7
+ CK=CTS_755
Xbank_mem_0_reg[6][9] QDFFN $PINS Q=bank_mem_0[6][9] D=FE_DBTN90_n62 CK=CTS_755
Xbank_mem_0_reg[6][8] QDFFN $PINS Q=bank_mem_0[6][8] D=FE_DBTN91_n61 CK=CTS_755
Xbank_mem_0_reg[6][7] QDFFN $PINS Q=bank_mem_0[6][7] D=FE_DBTN92_n60 CK=CTS_755
Xbank_mem_0_reg[6][6] QDFFN $PINS Q=bank_mem_0[6][6] D=FE_DBTN93_n59 CK=CTS_755
Xbank_mem_0_reg[6][5] QDFFN $PINS Q=bank_mem_0[6][5] D=FE_DBTN94_n58 CK=CTS_755
Xbank_mem_0_reg[6][4] QDFFN $PINS Q=bank_mem_0[6][4] D=FE_DBTN95_n57 CK=CTS_755
Xbank_mem_0_reg[6][3] QDFFN $PINS Q=bank_mem_0[6][3] D=FE_DBTN117_n35
+ CK=CTS_755
Xbank_mem_0_reg[6][2] QDFFN $PINS Q=bank_mem_0[6][2] D=FE_DBTN118_n34
+ CK=CTS_755
Xbank_mem_0_reg[6][1] QDFFN $PINS Q=bank_mem_0[6][1] D=FE_DBTN119_n33
+ CK=CTS_755
Xbank_mem_0_reg[6][0] QDFFN $PINS Q=bank_mem_0[6][0] D=FE_DBTN146_n6 CK=CTS_755
Xbank_mem_0_reg[2][33] QDFFN $PINS Q=bank_mem_0[2][33] D=FE_DBTN96_n56
+ CK=CTS_622
Xbank_mem_0_reg[2][32] QDFFN $PINS Q=bank_mem_0[2][32] D=FE_DBTN97_n55
+ CK=CTS_622
Xbank_mem_0_reg[2][31] QDFFN $PINS Q=bank_mem_0[2][31] D=FE_DBTN98_n54
+ CK=CTS_622
Xbank_mem_0_reg[2][30] QDFFN $PINS Q=bank_mem_0[2][30] D=FE_DBTN99_n53
+ CK=CTS_622
Xbank_mem_0_reg[2][29] QDFFN $PINS Q=bank_mem_0[2][29] D=FE_DBTN100_n52
+ CK=CTS_622
Xbank_mem_0_reg[2][28] QDFFN $PINS Q=bank_mem_0[2][28] D=FE_DBTN101_n51
+ CK=CTS_622
Xbank_mem_0_reg[2][27] QDFFN $PINS Q=bank_mem_0[2][27] D=FE_DBTN102_n50
+ CK=CTS_622
Xbank_mem_0_reg[2][26] QDFFN $PINS Q=bank_mem_0[2][26] D=FE_DBTN103_n49
+ CK=CTS_622
Xbank_mem_0_reg[2][25] QDFFN $PINS Q=bank_mem_0[2][25] D=FE_DBTN104_n48
+ CK=CTS_622
Xbank_mem_0_reg[2][24] QDFFN $PINS Q=bank_mem_0[2][24] D=FE_DBTN105_n47
+ CK=CTS_622
Xbank_mem_0_reg[2][23] QDFFN $PINS Q=bank_mem_0[2][23] D=FE_DBTN106_n46
+ CK=CTS_622
Xbank_mem_0_reg[2][22] QDFFN $PINS Q=bank_mem_0[2][22] D=FE_DBTN107_n45
+ CK=CTS_622
Xbank_mem_0_reg[2][21] QDFFN $PINS Q=bank_mem_0[2][21] D=FE_DBTN108_n44
+ CK=CTS_622
Xbank_mem_0_reg[2][20] QDFFN $PINS Q=bank_mem_0[2][20] D=FE_DBTN109_n43
+ CK=CTS_622
Xbank_mem_0_reg[2][19] QDFFN $PINS Q=bank_mem_0[2][19] D=FE_DBTN110_n42
+ CK=CTS_622
Xbank_mem_0_reg[2][18] QDFFN $PINS Q=bank_mem_0[2][18] D=FE_DBTN111_n41
+ CK=CTS_622
Xbank_mem_0_reg[2][17] QDFFN $PINS Q=bank_mem_0[2][17] D=FE_DBTN112_n40
+ CK=CTS_622
Xbank_mem_0_reg[2][16] QDFFN $PINS Q=bank_mem_0[2][16] D=FE_DBTN113_n39
+ CK=CTS_619
Xbank_mem_0_reg[2][15] QDFFN $PINS Q=bank_mem_0[2][15] D=FE_DBTN114_n38
+ CK=CTS_619
Xbank_mem_0_reg[2][14] QDFFN $PINS Q=bank_mem_0[2][14] D=FE_DBTN115_n37
+ CK=CTS_619
Xbank_mem_0_reg[2][13] QDFFN $PINS Q=bank_mem_0[2][13] D=FE_DBTN116_n36
+ CK=CTS_619
Xbank_mem_0_reg[2][12] QDFFN $PINS Q=bank_mem_0[2][12] D=FE_DBTN143_n9
+ CK=CTS_619
Xbank_mem_0_reg[2][11] QDFFN $PINS Q=bank_mem_0[2][11] D=FE_DBTN144_n8
+ CK=CTS_619
Xbank_mem_0_reg[2][10] QDFFN $PINS Q=bank_mem_0[2][10] D=FE_DBTN145_n7
+ CK=CTS_619
Xbank_mem_0_reg[2][9] QDFFN $PINS Q=bank_mem_0[2][9] D=FE_DBTN90_n62 CK=CTS_619
Xbank_mem_0_reg[2][8] QDFFN $PINS Q=bank_mem_0[2][8] D=FE_DBTN91_n61 CK=CTS_619
Xbank_mem_0_reg[2][7] QDFFN $PINS Q=bank_mem_0[2][7] D=FE_DBTN92_n60 CK=CTS_619
Xbank_mem_0_reg[2][6] QDFFN $PINS Q=bank_mem_0[2][6] D=FE_DBTN93_n59 CK=CTS_619
Xbank_mem_0_reg[2][5] QDFFN $PINS Q=bank_mem_0[2][5] D=FE_DBTN94_n58 CK=CTS_619
Xbank_mem_0_reg[2][4] QDFFN $PINS Q=bank_mem_0[2][4] D=FE_DBTN95_n57 CK=CTS_619
Xbank_mem_0_reg[2][3] QDFFN $PINS Q=bank_mem_0[2][3] D=FE_DBTN117_n35
+ CK=CTS_619
Xbank_mem_0_reg[2][2] QDFFN $PINS Q=bank_mem_0[2][2] D=FE_DBTN118_n34
+ CK=CTS_619
Xbank_mem_0_reg[2][1] QDFFN $PINS Q=bank_mem_0[2][1] D=FE_DBTN119_n33
+ CK=CTS_619
Xbank_mem_0_reg[2][0] QDFFN $PINS Q=bank_mem_0[2][0] D=FE_DBTN146_n6 CK=CTS_619
Xbank_mem_0_reg[7][32] QDFFN $PINS Q=bank_mem_0[7][32] D=FE_DBTN97_n55
+ CK=CTS_752
Xbank_mem_0_reg[7][31] QDFFN $PINS Q=bank_mem_0[7][31] D=FE_DBTN98_n54
+ CK=CTS_752
Xbank_mem_0_reg[7][30] QDFFN $PINS Q=bank_mem_0[7][30] D=FE_DBTN99_n53
+ CK=CTS_752
Xbank_mem_0_reg[7][29] QDFFN $PINS Q=bank_mem_0[7][29] D=FE_DBTN100_n52
+ CK=CTS_752
Xbank_mem_0_reg[7][28] QDFFN $PINS Q=bank_mem_0[7][28] D=FE_DBTN101_n51
+ CK=CTS_752
Xbank_mem_0_reg[7][27] QDFFN $PINS Q=bank_mem_0[7][27] D=FE_DBTN102_n50
+ CK=CTS_752
Xbank_mem_0_reg[7][26] QDFFN $PINS Q=bank_mem_0[7][26] D=FE_DBTN103_n49
+ CK=CTS_752
Xbank_mem_0_reg[7][25] QDFFN $PINS Q=bank_mem_0[7][25] D=FE_DBTN104_n48
+ CK=CTS_752
Xbank_mem_0_reg[7][24] QDFFN $PINS Q=bank_mem_0[7][24] D=FE_DBTN105_n47
+ CK=CTS_752
Xbank_mem_0_reg[7][23] QDFFN $PINS Q=bank_mem_0[7][23] D=FE_DBTN106_n46
+ CK=CTS_752
Xbank_mem_0_reg[7][22] QDFFN $PINS Q=bank_mem_0[7][22] D=FE_DBTN107_n45
+ CK=CTS_752
Xbank_mem_0_reg[7][21] QDFFN $PINS Q=bank_mem_0[7][21] D=FE_DBTN108_n44
+ CK=CTS_752
Xbank_mem_0_reg[7][20] QDFFN $PINS Q=bank_mem_0[7][20] D=FE_DBTN109_n43
+ CK=CTS_752
Xbank_mem_0_reg[7][19] QDFFN $PINS Q=bank_mem_0[7][19] D=FE_DBTN110_n42
+ CK=CTS_752
Xbank_mem_0_reg[7][18] QDFFN $PINS Q=bank_mem_0[7][18] D=FE_DBTN111_n41
+ CK=CTS_752
Xbank_mem_0_reg[7][17] QDFFN $PINS Q=bank_mem_0[7][17] D=FE_DBTN112_n40
+ CK=CTS_752
Xbank_mem_0_reg[7][16] QDFFN $PINS Q=bank_mem_0[7][16] D=FE_DBTN113_n39
+ CK=CTS_749
Xbank_mem_0_reg[7][15] QDFFN $PINS Q=bank_mem_0[7][15] D=FE_DBTN114_n38
+ CK=CTS_749
Xbank_mem_0_reg[7][14] QDFFN $PINS Q=bank_mem_0[7][14] D=FE_DBTN115_n37
+ CK=CTS_749
Xbank_mem_0_reg[7][13] QDFFN $PINS Q=bank_mem_0[7][13] D=FE_DBTN116_n36
+ CK=CTS_749
Xbank_mem_0_reg[7][12] QDFFN $PINS Q=bank_mem_0[7][12] D=FE_DBTN143_n9
+ CK=CTS_749
Xbank_mem_0_reg[7][11] QDFFN $PINS Q=bank_mem_0[7][11] D=FE_DBTN144_n8
+ CK=CTS_749
Xbank_mem_0_reg[7][10] QDFFN $PINS Q=bank_mem_0[7][10] D=FE_DBTN145_n7
+ CK=CTS_749
Xbank_mem_0_reg[7][9] QDFFN $PINS Q=bank_mem_0[7][9] D=FE_DBTN90_n62 CK=CTS_749
Xbank_mem_0_reg[7][8] QDFFN $PINS Q=bank_mem_0[7][8] D=FE_DBTN91_n61 CK=CTS_749
Xbank_mem_0_reg[7][7] QDFFN $PINS Q=bank_mem_0[7][7] D=FE_DBTN92_n60 CK=CTS_749
Xbank_mem_0_reg[7][6] QDFFN $PINS Q=bank_mem_0[7][6] D=FE_DBTN93_n59 CK=CTS_749
Xbank_mem_0_reg[7][5] QDFFN $PINS Q=bank_mem_0[7][5] D=FE_DBTN94_n58 CK=CTS_749
Xbank_mem_0_reg[7][4] QDFFN $PINS Q=bank_mem_0[7][4] D=FE_DBTN95_n57 CK=CTS_749
Xbank_mem_0_reg[7][3] QDFFN $PINS Q=bank_mem_0[7][3] D=FE_DBTN117_n35
+ CK=CTS_749
Xbank_mem_0_reg[7][2] QDFFN $PINS Q=bank_mem_0[7][2] D=FE_DBTN118_n34
+ CK=CTS_749
Xbank_mem_0_reg[7][1] QDFFN $PINS Q=bank_mem_0[7][1] D=FE_DBTN119_n33
+ CK=CTS_749
Xbank_mem_0_reg[7][0] QDFFN $PINS Q=bank_mem_0[7][0] D=FE_DBTN146_n6 CK=CTS_749
Xbank_mem_0_reg[7][33] QDFFN $PINS Q=bank_mem_0[7][33] D=FE_DBTN96_n56
+ CK=CTS_752
Xbank_mem_0_reg[3][33] QDFFN $PINS Q=bank_mem_0[3][33] D=FE_DBTN96_n56
+ CK=CTS_616
Xbank_mem_0_reg[3][32] QDFFN $PINS Q=bank_mem_0[3][32] D=FE_DBTN97_n55
+ CK=CTS_616
Xbank_mem_0_reg[3][31] QDFFN $PINS Q=bank_mem_0[3][31] D=FE_DBTN98_n54
+ CK=CTS_616
Xbank_mem_0_reg[3][30] QDFFN $PINS Q=bank_mem_0[3][30] D=FE_DBTN99_n53
+ CK=CTS_616
Xbank_mem_0_reg[3][29] QDFFN $PINS Q=bank_mem_0[3][29] D=FE_DBTN100_n52
+ CK=CTS_616
Xbank_mem_0_reg[3][28] QDFFN $PINS Q=bank_mem_0[3][28] D=FE_DBTN101_n51
+ CK=CTS_616
Xbank_mem_0_reg[3][27] QDFFN $PINS Q=bank_mem_0[3][27] D=FE_DBTN102_n50
+ CK=CTS_616
Xbank_mem_0_reg[3][26] QDFFN $PINS Q=bank_mem_0[3][26] D=FE_DBTN103_n49
+ CK=CTS_616
Xbank_mem_0_reg[3][25] QDFFN $PINS Q=bank_mem_0[3][25] D=FE_DBTN104_n48
+ CK=CTS_616
Xbank_mem_0_reg[3][24] QDFFN $PINS Q=bank_mem_0[3][24] D=FE_DBTN105_n47
+ CK=CTS_616
Xbank_mem_0_reg[3][23] QDFFN $PINS Q=bank_mem_0[3][23] D=FE_DBTN106_n46
+ CK=CTS_616
Xbank_mem_0_reg[3][22] QDFFN $PINS Q=bank_mem_0[3][22] D=FE_DBTN107_n45
+ CK=CTS_616
Xbank_mem_0_reg[3][21] QDFFN $PINS Q=bank_mem_0[3][21] D=FE_DBTN108_n44
+ CK=CTS_616
Xbank_mem_0_reg[3][20] QDFFN $PINS Q=bank_mem_0[3][20] D=FE_DBTN109_n43
+ CK=CTS_616
Xbank_mem_0_reg[3][19] QDFFN $PINS Q=bank_mem_0[3][19] D=FE_DBTN110_n42
+ CK=CTS_616
Xbank_mem_0_reg[3][18] QDFFN $PINS Q=bank_mem_0[3][18] D=FE_DBTN111_n41
+ CK=CTS_616
Xbank_mem_0_reg[3][17] QDFFN $PINS Q=bank_mem_0[3][17] D=FE_DBTN112_n40
+ CK=CTS_616
Xbank_mem_0_reg[3][16] QDFFN $PINS Q=bank_mem_0[3][16] D=FE_DBTN113_n39
+ CK=CTS_773
Xbank_mem_0_reg[3][15] QDFFN $PINS Q=bank_mem_0[3][15] D=FE_DBTN114_n38
+ CK=CTS_773
Xbank_mem_0_reg[3][14] QDFFN $PINS Q=bank_mem_0[3][14] D=FE_DBTN115_n37
+ CK=CTS_773
Xbank_mem_0_reg[3][13] QDFFN $PINS Q=bank_mem_0[3][13] D=FE_DBTN116_n36
+ CK=CTS_773
Xbank_mem_0_reg[3][12] QDFFN $PINS Q=bank_mem_0[3][12] D=FE_DBTN143_n9
+ CK=CTS_773
Xbank_mem_0_reg[3][11] QDFFN $PINS Q=bank_mem_0[3][11] D=FE_DBTN144_n8
+ CK=CTS_773
Xbank_mem_0_reg[3][10] QDFFN $PINS Q=bank_mem_0[3][10] D=FE_DBTN145_n7
+ CK=CTS_773
Xbank_mem_0_reg[3][9] QDFFN $PINS Q=bank_mem_0[3][9] D=FE_DBTN90_n62 CK=CTS_773
Xbank_mem_0_reg[3][8] QDFFN $PINS Q=bank_mem_0[3][8] D=FE_DBTN91_n61 CK=CTS_773
Xbank_mem_0_reg[3][7] QDFFN $PINS Q=bank_mem_0[3][7] D=FE_DBTN92_n60 CK=CTS_773
Xbank_mem_0_reg[3][6] QDFFN $PINS Q=bank_mem_0[3][6] D=FE_DBTN93_n59 CK=CTS_773
Xbank_mem_0_reg[3][5] QDFFN $PINS Q=bank_mem_0[3][5] D=FE_DBTN94_n58 CK=CTS_773
Xbank_mem_0_reg[3][4] QDFFN $PINS Q=bank_mem_0[3][4] D=FE_DBTN95_n57 CK=CTS_773
Xbank_mem_0_reg[3][3] QDFFN $PINS Q=bank_mem_0[3][3] D=FE_DBTN117_n35
+ CK=CTS_773
Xbank_mem_0_reg[3][2] QDFFN $PINS Q=bank_mem_0[3][2] D=FE_DBTN118_n34
+ CK=CTS_773
Xbank_mem_0_reg[3][1] QDFFN $PINS Q=bank_mem_0[3][1] D=FE_DBTN119_n33
+ CK=CTS_773
Xbank_mem_0_reg[3][0] QDFFN $PINS Q=bank_mem_0[3][0] D=FE_DBTN146_n6 CK=CTS_773
Xbank_mem_0_reg[5][33] QDFFN $PINS Q=bank_mem_0[5][33] D=FE_DBTN96_n56
+ CK=CTS_764
Xbank_mem_0_reg[5][32] QDFFN $PINS Q=bank_mem_0[5][32] D=FE_DBTN97_n55
+ CK=CTS_764
Xbank_mem_0_reg[5][31] QDFFN $PINS Q=bank_mem_0[5][31] D=FE_DBTN98_n54
+ CK=CTS_764
Xbank_mem_0_reg[5][30] QDFFN $PINS Q=bank_mem_0[5][30] D=FE_DBTN99_n53
+ CK=CTS_764
Xbank_mem_0_reg[5][29] QDFFN $PINS Q=bank_mem_0[5][29] D=FE_DBTN100_n52
+ CK=CTS_764
Xbank_mem_0_reg[5][28] QDFFN $PINS Q=bank_mem_0[5][28] D=FE_DBTN101_n51
+ CK=CTS_764
Xbank_mem_0_reg[5][27] QDFFN $PINS Q=bank_mem_0[5][27] D=FE_DBTN102_n50
+ CK=CTS_764
Xbank_mem_0_reg[5][26] QDFFN $PINS Q=bank_mem_0[5][26] D=FE_DBTN103_n49
+ CK=CTS_764
Xbank_mem_0_reg[5][25] QDFFN $PINS Q=bank_mem_0[5][25] D=FE_DBTN104_n48
+ CK=CTS_764
Xbank_mem_0_reg[5][24] QDFFN $PINS Q=bank_mem_0[5][24] D=FE_DBTN105_n47
+ CK=CTS_764
Xbank_mem_0_reg[5][23] QDFFN $PINS Q=bank_mem_0[5][23] D=FE_DBTN106_n46
+ CK=CTS_764
Xbank_mem_0_reg[5][22] QDFFN $PINS Q=bank_mem_0[5][22] D=FE_DBTN107_n45
+ CK=CTS_764
Xbank_mem_0_reg[5][21] QDFFN $PINS Q=bank_mem_0[5][21] D=FE_DBTN108_n44
+ CK=CTS_764
Xbank_mem_0_reg[5][20] QDFFN $PINS Q=bank_mem_0[5][20] D=FE_DBTN109_n43
+ CK=CTS_764
Xbank_mem_0_reg[5][19] QDFFN $PINS Q=bank_mem_0[5][19] D=FE_DBTN110_n42
+ CK=CTS_764
Xbank_mem_0_reg[5][18] QDFFN $PINS Q=bank_mem_0[5][18] D=FE_DBTN111_n41
+ CK=CTS_764
Xbank_mem_0_reg[5][17] QDFFN $PINS Q=bank_mem_0[5][17] D=FE_DBTN112_n40
+ CK=CTS_764
Xbank_mem_0_reg[5][16] QDFFN $PINS Q=bank_mem_0[5][16] D=FE_DBTN113_n39
+ CK=CTS_761
Xbank_mem_0_reg[5][15] QDFFN $PINS Q=bank_mem_0[5][15] D=FE_DBTN114_n38
+ CK=CTS_761
Xbank_mem_0_reg[5][14] QDFFN $PINS Q=bank_mem_0[5][14] D=FE_DBTN115_n37
+ CK=CTS_761
Xbank_mem_0_reg[5][13] QDFFN $PINS Q=bank_mem_0[5][13] D=FE_DBTN116_n36
+ CK=CTS_761
Xbank_mem_0_reg[5][12] QDFFN $PINS Q=bank_mem_0[5][12] D=FE_DBTN143_n9
+ CK=CTS_761
Xbank_mem_0_reg[5][11] QDFFN $PINS Q=bank_mem_0[5][11] D=FE_DBTN144_n8
+ CK=CTS_761
Xbank_mem_0_reg[5][10] QDFFN $PINS Q=bank_mem_0[5][10] D=FE_DBTN145_n7
+ CK=CTS_761
Xbank_mem_0_reg[5][9] QDFFN $PINS Q=bank_mem_0[5][9] D=FE_DBTN90_n62 CK=CTS_761
Xbank_mem_0_reg[5][8] QDFFN $PINS Q=bank_mem_0[5][8] D=FE_DBTN91_n61 CK=CTS_761
Xbank_mem_0_reg[5][7] QDFFN $PINS Q=bank_mem_0[5][7] D=FE_DBTN92_n60 CK=CTS_761
Xbank_mem_0_reg[5][6] QDFFN $PINS Q=bank_mem_0[5][6] D=FE_DBTN93_n59 CK=CTS_761
Xbank_mem_0_reg[5][5] QDFFN $PINS Q=bank_mem_0[5][5] D=FE_DBTN94_n58 CK=CTS_761
Xbank_mem_0_reg[5][4] QDFFN $PINS Q=bank_mem_0[5][4] D=FE_DBTN95_n57 CK=CTS_761
Xbank_mem_0_reg[5][3] QDFFN $PINS Q=bank_mem_0[5][3] D=FE_DBTN117_n35
+ CK=CTS_761
Xbank_mem_0_reg[5][2] QDFFN $PINS Q=bank_mem_0[5][2] D=FE_DBTN118_n34
+ CK=CTS_761
Xbank_mem_0_reg[5][1] QDFFN $PINS Q=bank_mem_0[5][1] D=FE_DBTN119_n33
+ CK=CTS_761
Xbank_mem_0_reg[5][0] QDFFN $PINS Q=bank_mem_0[5][0] D=FE_DBTN146_n6 CK=CTS_761
Xbank_mem_1_reg[0][33] QDFFN $PINS Q=bank_mem_1[0][33] D=FE_DBTN120_n32
+ CK=CTS_697
Xbank_mem_1_reg[0][32] QDFFN $PINS Q=bank_mem_1[0][32] D=FE_DBTN136_n16
+ CK=CTS_697
Xbank_mem_1_reg[0][31] QDFFN $PINS Q=bank_mem_1[0][31] D=FE_DBTN137_n15
+ CK=CTS_697
Xbank_mem_1_reg[0][30] QDFFN $PINS Q=bank_mem_1[0][30] D=FE_DBTN138_n14
+ CK=CTS_697
Xbank_mem_1_reg[0][29] QDFFN $PINS Q=bank_mem_1[0][29] D=FE_DBTN139_n13
+ CK=CTS_697
Xbank_mem_1_reg[0][28] QDFFN $PINS Q=bank_mem_1[0][28] D=FE_DBTN140_n12
+ CK=CTS_697
Xbank_mem_1_reg[0][27] QDFFN $PINS Q=bank_mem_1[0][27] D=FE_DBTN151_n1
+ CK=CTS_697
Xbank_mem_1_reg[0][26] QDFFN $PINS Q=bank_mem_1[0][26] D=FE_DBTN141_n11
+ CK=CTS_697
Xbank_mem_1_reg[0][25] QDFFN $PINS Q=bank_mem_1[0][25] D=FE_DBTN122_n30
+ CK=CTS_697
Xbank_mem_1_reg[0][24] QDFFN $PINS Q=bank_mem_1[0][24] D=FE_DBTN123_n29
+ CK=CTS_697
Xbank_mem_1_reg[0][23] QDFFN $PINS Q=bank_mem_1[0][23] D=FE_DBTN124_n28
+ CK=CTS_697
Xbank_mem_1_reg[0][22] QDFFN $PINS Q=bank_mem_1[0][22] D=FE_DBTN125_n27
+ CK=CTS_697
Xbank_mem_1_reg[0][21] QDFFN $PINS Q=bank_mem_1[0][21] D=FE_DBTN126_n26
+ CK=CTS_697
Xbank_mem_1_reg[0][20] QDFFN $PINS Q=bank_mem_1[0][20] D=FE_DBTN127_n25
+ CK=CTS_697
Xbank_mem_1_reg[0][19] QDFFN $PINS Q=bank_mem_1[0][19] D=FE_DBTN128_n24
+ CK=CTS_697
Xbank_mem_1_reg[0][18] QDFFN $PINS Q=bank_mem_1[0][18] D=FE_DBTN129_n23
+ CK=CTS_697
Xbank_mem_1_reg[0][17] QDFFN $PINS Q=bank_mem_1[0][17] D=FE_DBTN130_n22
+ CK=CTS_697
Xbank_mem_1_reg[0][16] QDFFN $PINS Q=bank_mem_1[0][16] D=FE_DBTN131_n21
+ CK=CTS_694
Xbank_mem_1_reg[0][15] QDFFN $PINS Q=bank_mem_1[0][15] D=FE_DBTN132_n20
+ CK=CTS_694
Xbank_mem_1_reg[0][14] QDFFN $PINS Q=bank_mem_1[0][14] D=FE_DBTN133_n19
+ CK=CTS_694
Xbank_mem_1_reg[0][13] QDFFN $PINS Q=bank_mem_1[0][13] D=FE_DBTN134_n18
+ CK=CTS_694
Xbank_mem_1_reg[0][12] QDFFN $PINS Q=bank_mem_1[0][12] D=FE_DBTN150_n2
+ CK=CTS_694
Xbank_mem_1_reg[0][11] QDFFN $PINS Q=bank_mem_1[0][11] D=FE_DBTN147_n5
+ CK=CTS_694
Xbank_mem_1_reg[0][10] QDFFN $PINS Q=bank_mem_1[0][10] D=FE_DBTN148_n4
+ CK=CTS_694
Xbank_mem_1_reg[0][9] QDFFN $PINS Q=bank_mem_1[0][9] D=FE_DBTN89_n63 CK=CTS_694
Xbank_mem_1_reg[0][8] QDFFN $PINS Q=bank_mem_1[0][8] D=FE_DBTN84_n68 CK=CTS_694
Xbank_mem_1_reg[0][7] QDFFN $PINS Q=bank_mem_1[0][7] D=FE_DBTN85_n67 CK=CTS_694
Xbank_mem_1_reg[0][6] QDFFN $PINS Q=bank_mem_1[0][6] D=FE_DBTN86_n66 CK=CTS_694
Xbank_mem_1_reg[0][5] QDFFN $PINS Q=bank_mem_1[0][5] D=FE_DBTN87_n65 CK=CTS_694
Xbank_mem_1_reg[0][4] QDFFN $PINS Q=bank_mem_1[0][4] D=FE_DBTN88_n64 CK=CTS_694
Xbank_mem_1_reg[0][3] QDFFN $PINS Q=bank_mem_1[0][3] D=FE_DBTN121_n31
+ CK=CTS_694
Xbank_mem_1_reg[0][2] QDFFN $PINS Q=bank_mem_1[0][2] D=FE_DBTN142_n10
+ CK=CTS_694
Xbank_mem_1_reg[0][1] QDFFN $PINS Q=bank_mem_1[0][1] D=FE_DBTN135_n17
+ CK=CTS_694
Xbank_mem_1_reg[0][0] QDFFN $PINS Q=bank_mem_1[0][0] D=FE_DBTN149_n3 CK=CTS_694
Xbank_mem_1_reg[1][33] QDFFN $PINS Q=bank_mem_1[1][33] D=FE_DBTN120_n32
+ CK=CTS_691
Xbank_mem_1_reg[1][32] QDFFN $PINS Q=bank_mem_1[1][32] D=FE_DBTN136_n16
+ CK=CTS_691
Xbank_mem_1_reg[1][31] QDFFN $PINS Q=bank_mem_1[1][31] D=FE_DBTN137_n15
+ CK=CTS_691
Xbank_mem_1_reg[1][30] QDFFN $PINS Q=bank_mem_1[1][30] D=FE_DBTN138_n14
+ CK=CTS_691
Xbank_mem_1_reg[1][29] QDFFN $PINS Q=bank_mem_1[1][29] D=FE_DBTN139_n13
+ CK=CTS_691
Xbank_mem_1_reg[1][28] QDFFN $PINS Q=bank_mem_1[1][28] D=FE_DBTN140_n12
+ CK=CTS_691
Xbank_mem_1_reg[1][27] QDFFN $PINS Q=bank_mem_1[1][27] D=FE_DBTN151_n1
+ CK=CTS_691
Xbank_mem_1_reg[1][26] QDFFN $PINS Q=bank_mem_1[1][26] D=FE_DBTN141_n11
+ CK=CTS_691
Xbank_mem_1_reg[1][25] QDFFN $PINS Q=bank_mem_1[1][25] D=FE_DBTN122_n30
+ CK=CTS_691
Xbank_mem_1_reg[1][24] QDFFN $PINS Q=bank_mem_1[1][24] D=FE_DBTN123_n29
+ CK=CTS_691
Xbank_mem_1_reg[1][23] QDFFN $PINS Q=bank_mem_1[1][23] D=FE_DBTN124_n28
+ CK=CTS_691
Xbank_mem_1_reg[1][22] QDFFN $PINS Q=bank_mem_1[1][22] D=FE_DBTN125_n27
+ CK=CTS_691
Xbank_mem_1_reg[1][21] QDFFN $PINS Q=bank_mem_1[1][21] D=FE_DBTN126_n26
+ CK=CTS_691
Xbank_mem_1_reg[1][20] QDFFN $PINS Q=bank_mem_1[1][20] D=FE_DBTN127_n25
+ CK=CTS_691
Xbank_mem_1_reg[1][19] QDFFN $PINS Q=bank_mem_1[1][19] D=FE_DBTN128_n24
+ CK=CTS_691
Xbank_mem_1_reg[1][18] QDFFN $PINS Q=bank_mem_1[1][18] D=FE_DBTN129_n23
+ CK=CTS_691
Xbank_mem_1_reg[1][17] QDFFN $PINS Q=bank_mem_1[1][17] D=FE_DBTN130_n22
+ CK=CTS_691
Xbank_mem_1_reg[1][16] QDFFN $PINS Q=bank_mem_1[1][16] D=FE_DBTN131_n21
+ CK=CTS_688
Xbank_mem_1_reg[1][15] QDFFN $PINS Q=bank_mem_1[1][15] D=FE_DBTN132_n20
+ CK=CTS_688
Xbank_mem_1_reg[1][14] QDFFN $PINS Q=bank_mem_1[1][14] D=FE_DBTN133_n19
+ CK=CTS_688
Xbank_mem_1_reg[1][13] QDFFN $PINS Q=bank_mem_1[1][13] D=FE_DBTN134_n18
+ CK=CTS_688
Xbank_mem_1_reg[1][12] QDFFN $PINS Q=bank_mem_1[1][12] D=FE_DBTN150_n2
+ CK=CTS_688
Xbank_mem_1_reg[1][11] QDFFN $PINS Q=bank_mem_1[1][11] D=FE_DBTN147_n5
+ CK=CTS_688
Xbank_mem_1_reg[1][10] QDFFN $PINS Q=bank_mem_1[1][10] D=FE_DBTN148_n4
+ CK=CTS_688
Xbank_mem_1_reg[1][9] QDFFN $PINS Q=bank_mem_1[1][9] D=FE_DBTN89_n63 CK=CTS_688
Xbank_mem_1_reg[1][8] QDFFN $PINS Q=bank_mem_1[1][8] D=FE_DBTN84_n68 CK=CTS_688
Xbank_mem_1_reg[1][7] QDFFN $PINS Q=bank_mem_1[1][7] D=FE_DBTN85_n67 CK=CTS_688
Xbank_mem_1_reg[1][6] QDFFN $PINS Q=bank_mem_1[1][6] D=FE_DBTN86_n66 CK=CTS_688
Xbank_mem_1_reg[1][5] QDFFN $PINS Q=bank_mem_1[1][5] D=FE_DBTN87_n65 CK=CTS_688
Xbank_mem_1_reg[1][4] QDFFN $PINS Q=bank_mem_1[1][4] D=FE_DBTN88_n64 CK=CTS_688
Xbank_mem_1_reg[1][3] QDFFN $PINS Q=bank_mem_1[1][3] D=FE_DBTN121_n31
+ CK=CTS_688
Xbank_mem_1_reg[1][2] QDFFN $PINS Q=bank_mem_1[1][2] D=FE_DBTN142_n10
+ CK=CTS_688
Xbank_mem_1_reg[1][1] QDFFN $PINS Q=bank_mem_1[1][1] D=FE_DBTN135_n17
+ CK=CTS_688
Xbank_mem_1_reg[1][0] QDFFN $PINS Q=bank_mem_1[1][0] D=FE_DBTN149_n3 CK=CTS_688
Xbank_mem_0_reg[0][33] QDFFN $PINS Q=bank_mem_0[0][33] D=FE_DBTN96_n56
+ CK=CTS_779
Xbank_mem_0_reg[0][32] QDFFN $PINS Q=bank_mem_0[0][32] D=FE_DBTN97_n55
+ CK=CTS_779
Xbank_mem_0_reg[0][31] QDFFN $PINS Q=bank_mem_0[0][31] D=FE_DBTN98_n54
+ CK=CTS_779
Xbank_mem_0_reg[0][30] QDFFN $PINS Q=bank_mem_0[0][30] D=FE_DBTN99_n53
+ CK=CTS_779
Xbank_mem_0_reg[0][29] QDFFN $PINS Q=bank_mem_0[0][29] D=FE_DBTN100_n52
+ CK=CTS_779
Xbank_mem_0_reg[0][28] QDFFN $PINS Q=bank_mem_0[0][28] D=FE_DBTN101_n51
+ CK=CTS_779
Xbank_mem_0_reg[0][27] QDFFN $PINS Q=bank_mem_0[0][27] D=FE_DBTN102_n50
+ CK=CTS_779
Xbank_mem_0_reg[0][26] QDFFN $PINS Q=bank_mem_0[0][26] D=FE_DBTN103_n49
+ CK=CTS_779
Xbank_mem_0_reg[0][25] QDFFN $PINS Q=bank_mem_0[0][25] D=FE_DBTN104_n48
+ CK=CTS_779
Xbank_mem_0_reg[0][24] QDFFN $PINS Q=bank_mem_0[0][24] D=FE_DBTN105_n47
+ CK=CTS_779
Xbank_mem_0_reg[0][23] QDFFN $PINS Q=bank_mem_0[0][23] D=FE_DBTN106_n46
+ CK=CTS_779
Xbank_mem_0_reg[0][22] QDFFN $PINS Q=bank_mem_0[0][22] D=FE_DBTN107_n45
+ CK=CTS_779
Xbank_mem_0_reg[0][21] QDFFN $PINS Q=bank_mem_0[0][21] D=FE_DBTN108_n44
+ CK=CTS_779
Xbank_mem_0_reg[0][20] QDFFN $PINS Q=bank_mem_0[0][20] D=FE_DBTN109_n43
+ CK=CTS_779
Xbank_mem_0_reg[0][19] QDFFN $PINS Q=bank_mem_0[0][19] D=FE_DBTN110_n42
+ CK=CTS_779
Xbank_mem_0_reg[0][18] QDFFN $PINS Q=bank_mem_0[0][18] D=FE_DBTN111_n41
+ CK=CTS_779
Xbank_mem_0_reg[0][17] QDFFN $PINS Q=bank_mem_0[0][17] D=FE_DBTN112_n40
+ CK=CTS_779
Xbank_mem_0_reg[0][16] QDFFN $PINS Q=bank_mem_0[0][16] D=FE_DBTN113_n39
+ CK=CTS_776
Xbank_mem_0_reg[0][15] QDFFN $PINS Q=bank_mem_0[0][15] D=FE_DBTN114_n38
+ CK=CTS_776
Xbank_mem_0_reg[0][14] QDFFN $PINS Q=bank_mem_0[0][14] D=FE_DBTN115_n37
+ CK=CTS_776
Xbank_mem_0_reg[0][13] QDFFN $PINS Q=bank_mem_0[0][13] D=FE_DBTN116_n36
+ CK=CTS_776
Xbank_mem_0_reg[0][12] QDFFN $PINS Q=bank_mem_0[0][12] D=FE_DBTN143_n9
+ CK=CTS_776
Xbank_mem_0_reg[0][11] QDFFN $PINS Q=bank_mem_0[0][11] D=FE_DBTN144_n8
+ CK=CTS_776
Xbank_mem_0_reg[0][10] QDFFN $PINS Q=bank_mem_0[0][10] D=FE_DBTN145_n7
+ CK=CTS_776
Xbank_mem_0_reg[0][9] QDFFN $PINS Q=bank_mem_0[0][9] D=FE_DBTN90_n62 CK=CTS_776
Xbank_mem_0_reg[0][8] QDFFN $PINS Q=bank_mem_0[0][8] D=FE_DBTN91_n61 CK=CTS_776
Xbank_mem_0_reg[0][7] QDFFN $PINS Q=bank_mem_0[0][7] D=FE_DBTN92_n60 CK=CTS_776
Xbank_mem_0_reg[0][6] QDFFN $PINS Q=bank_mem_0[0][6] D=FE_DBTN93_n59 CK=CTS_776
Xbank_mem_0_reg[0][5] QDFFN $PINS Q=bank_mem_0[0][5] D=FE_DBTN94_n58 CK=CTS_776
Xbank_mem_0_reg[0][4] QDFFN $PINS Q=bank_mem_0[0][4] D=FE_DBTN95_n57 CK=CTS_776
Xbank_mem_0_reg[0][3] QDFFN $PINS Q=bank_mem_0[0][3] D=FE_DBTN117_n35
+ CK=CTS_776
Xbank_mem_0_reg[0][2] QDFFN $PINS Q=bank_mem_0[0][2] D=FE_DBTN118_n34
+ CK=CTS_776
Xbank_mem_0_reg[0][1] QDFFN $PINS Q=bank_mem_0[0][1] D=FE_DBTN119_n33
+ CK=CTS_776
Xbank_mem_0_reg[0][0] QDFFN $PINS Q=bank_mem_0[0][0] D=FE_DBTN146_n6 CK=CTS_776
Xbank_mem_0_reg[1][33] QDFFN $PINS Q=bank_mem_0[1][33] D=FE_DBTN96_n56
+ CK=CTS_628
Xbank_mem_0_reg[1][32] QDFFN $PINS Q=bank_mem_0[1][32] D=FE_DBTN97_n55
+ CK=CTS_628
Xbank_mem_0_reg[1][31] QDFFN $PINS Q=bank_mem_0[1][31] D=FE_DBTN98_n54
+ CK=CTS_628
Xbank_mem_0_reg[1][30] QDFFN $PINS Q=bank_mem_0[1][30] D=FE_DBTN99_n53
+ CK=CTS_628
Xbank_mem_0_reg[1][29] QDFFN $PINS Q=bank_mem_0[1][29] D=FE_DBTN100_n52
+ CK=CTS_628
Xbank_mem_0_reg[1][28] QDFFN $PINS Q=bank_mem_0[1][28] D=FE_DBTN101_n51
+ CK=CTS_628
Xbank_mem_0_reg[1][27] QDFFN $PINS Q=bank_mem_0[1][27] D=FE_DBTN102_n50
+ CK=CTS_628
Xbank_mem_0_reg[1][26] QDFFN $PINS Q=bank_mem_0[1][26] D=FE_DBTN103_n49
+ CK=CTS_628
Xbank_mem_0_reg[1][25] QDFFN $PINS Q=bank_mem_0[1][25] D=FE_DBTN104_n48
+ CK=CTS_628
Xbank_mem_0_reg[1][24] QDFFN $PINS Q=bank_mem_0[1][24] D=FE_DBTN105_n47
+ CK=CTS_628
Xbank_mem_0_reg[1][23] QDFFN $PINS Q=bank_mem_0[1][23] D=FE_DBTN106_n46
+ CK=CTS_628
Xbank_mem_0_reg[1][22] QDFFN $PINS Q=bank_mem_0[1][22] D=FE_DBTN107_n45
+ CK=CTS_628
Xbank_mem_0_reg[1][21] QDFFN $PINS Q=bank_mem_0[1][21] D=FE_DBTN108_n44
+ CK=CTS_628
Xbank_mem_0_reg[1][20] QDFFN $PINS Q=bank_mem_0[1][20] D=FE_DBTN109_n43
+ CK=CTS_628
Xbank_mem_0_reg[1][19] QDFFN $PINS Q=bank_mem_0[1][19] D=FE_DBTN110_n42
+ CK=CTS_628
Xbank_mem_0_reg[1][18] QDFFN $PINS Q=bank_mem_0[1][18] D=FE_DBTN111_n41
+ CK=CTS_628
Xbank_mem_0_reg[1][17] QDFFN $PINS Q=bank_mem_0[1][17] D=FE_DBTN112_n40
+ CK=CTS_628
Xbank_mem_0_reg[1][16] QDFFN $PINS Q=bank_mem_0[1][16] D=FE_DBTN113_n39
+ CK=CTS_625
Xbank_mem_0_reg[1][15] QDFFN $PINS Q=bank_mem_0[1][15] D=FE_DBTN114_n38
+ CK=CTS_625
Xbank_mem_0_reg[1][14] QDFFN $PINS Q=bank_mem_0[1][14] D=FE_DBTN115_n37
+ CK=CTS_625
Xbank_mem_0_reg[1][13] QDFFN $PINS Q=bank_mem_0[1][13] D=FE_DBTN116_n36
+ CK=CTS_625
Xbank_mem_0_reg[1][12] QDFFN $PINS Q=bank_mem_0[1][12] D=FE_DBTN143_n9
+ CK=CTS_625
Xbank_mem_0_reg[1][11] QDFFN $PINS Q=bank_mem_0[1][11] D=FE_DBTN144_n8
+ CK=CTS_625
Xbank_mem_0_reg[1][10] QDFFN $PINS Q=bank_mem_0[1][10] D=FE_DBTN145_n7
+ CK=CTS_625
Xbank_mem_0_reg[1][9] QDFFN $PINS Q=bank_mem_0[1][9] D=FE_DBTN90_n62 CK=CTS_625
Xbank_mem_0_reg[1][8] QDFFN $PINS Q=bank_mem_0[1][8] D=FE_DBTN91_n61 CK=CTS_625
Xbank_mem_0_reg[1][7] QDFFN $PINS Q=bank_mem_0[1][7] D=FE_DBTN92_n60 CK=CTS_625
Xbank_mem_0_reg[1][6] QDFFN $PINS Q=bank_mem_0[1][6] D=FE_DBTN93_n59 CK=CTS_625
Xbank_mem_0_reg[1][5] QDFFN $PINS Q=bank_mem_0[1][5] D=FE_DBTN94_n58 CK=CTS_625
Xbank_mem_0_reg[1][4] QDFFN $PINS Q=bank_mem_0[1][4] D=FE_DBTN95_n57 CK=CTS_625
Xbank_mem_0_reg[1][3] QDFFN $PINS Q=bank_mem_0[1][3] D=FE_DBTN117_n35
+ CK=CTS_625
Xbank_mem_0_reg[1][2] QDFFN $PINS Q=bank_mem_0[1][2] D=FE_DBTN118_n34
+ CK=CTS_625
Xbank_mem_0_reg[1][1] QDFFN $PINS Q=bank_mem_0[1][1] D=FE_DBTN119_n33
+ CK=CTS_625
Xbank_mem_0_reg[1][0] QDFFN $PINS Q=bank_mem_0[1][0] D=FE_DBTN146_n6 CK=CTS_625
Xbank_mem_1_reg[15][32] QDFFN $PINS Q=bank_mem_1[15][32] D=FE_DBTN136_n16
+ CK=CTS_589
Xbank_mem_1_reg[15][31] QDFFN $PINS Q=bank_mem_1[15][31] D=FE_DBTN137_n15
+ CK=CTS_589
Xbank_mem_1_reg[15][30] QDFFN $PINS Q=bank_mem_1[15][30] D=FE_DBTN138_n14
+ CK=CTS_589
Xbank_mem_1_reg[15][29] QDFFN $PINS Q=bank_mem_1[15][29] D=FE_DBTN139_n13
+ CK=CTS_589
Xbank_mem_1_reg[15][28] QDFFN $PINS Q=bank_mem_1[15][28] D=FE_DBTN140_n12
+ CK=CTS_589
Xbank_mem_1_reg[15][27] QDFFN $PINS Q=bank_mem_1[15][27] D=FE_DBTN151_n1
+ CK=CTS_589
Xbank_mem_1_reg[15][26] QDFFN $PINS Q=bank_mem_1[15][26] D=FE_DBTN141_n11
+ CK=CTS_589
Xbank_mem_1_reg[15][25] QDFFN $PINS Q=bank_mem_1[15][25] D=FE_DBTN122_n30
+ CK=CTS_589
Xbank_mem_1_reg[15][24] QDFFN $PINS Q=bank_mem_1[15][24] D=FE_DBTN123_n29
+ CK=CTS_589
Xbank_mem_1_reg[15][23] QDFFN $PINS Q=bank_mem_1[15][23] D=FE_DBTN124_n28
+ CK=CTS_589
Xbank_mem_1_reg[15][22] QDFFN $PINS Q=bank_mem_1[15][22] D=FE_DBTN125_n27
+ CK=CTS_589
Xbank_mem_1_reg[15][21] QDFFN $PINS Q=bank_mem_1[15][21] D=FE_DBTN126_n26
+ CK=CTS_589
Xbank_mem_1_reg[15][20] QDFFN $PINS Q=bank_mem_1[15][20] D=FE_DBTN127_n25
+ CK=CTS_589
Xbank_mem_1_reg[15][19] QDFFN $PINS Q=bank_mem_1[15][19] D=FE_DBTN128_n24
+ CK=CTS_589
Xbank_mem_1_reg[15][18] QDFFN $PINS Q=bank_mem_1[15][18] D=FE_DBTN129_n23
+ CK=CTS_589
Xbank_mem_1_reg[15][17] QDFFN $PINS Q=bank_mem_1[15][17] D=FE_DBTN130_n22
+ CK=CTS_589
Xbank_mem_1_reg[15][16] QDFFN $PINS Q=bank_mem_1[15][16] D=FE_DBTN131_n21
+ CK=CTS_640
Xbank_mem_1_reg[15][15] QDFFN $PINS Q=bank_mem_1[15][15] D=FE_DBTN132_n20
+ CK=CTS_640
Xbank_mem_1_reg[15][14] QDFFN $PINS Q=bank_mem_1[15][14] D=FE_DBTN133_n19
+ CK=CTS_640
Xbank_mem_1_reg[15][13] QDFFN $PINS Q=bank_mem_1[15][13] D=FE_DBTN134_n18
+ CK=CTS_640
Xbank_mem_1_reg[15][12] QDFFN $PINS Q=bank_mem_1[15][12] D=FE_DBTN150_n2
+ CK=CTS_640
Xbank_mem_1_reg[15][11] QDFFN $PINS Q=bank_mem_1[15][11] D=FE_DBTN147_n5
+ CK=CTS_640
Xbank_mem_1_reg[15][10] QDFFN $PINS Q=bank_mem_1[15][10] D=FE_DBTN148_n4
+ CK=CTS_640
Xbank_mem_1_reg[15][9] QDFFN $PINS Q=bank_mem_1[15][9] D=FE_DBTN89_n63
+ CK=CTS_640
Xbank_mem_1_reg[15][8] QDFFN $PINS Q=bank_mem_1[15][8] D=FE_DBTN84_n68
+ CK=CTS_640
Xbank_mem_1_reg[15][7] QDFFN $PINS Q=bank_mem_1[15][7] D=FE_DBTN85_n67
+ CK=CTS_640
Xbank_mem_1_reg[15][6] QDFFN $PINS Q=bank_mem_1[15][6] D=FE_DBTN86_n66
+ CK=CTS_640
Xbank_mem_1_reg[15][5] QDFFN $PINS Q=bank_mem_1[15][5] D=FE_DBTN87_n65
+ CK=CTS_640
Xbank_mem_1_reg[15][4] QDFFN $PINS Q=bank_mem_1[15][4] D=FE_DBTN88_n64
+ CK=CTS_640
Xbank_mem_1_reg[15][3] QDFFN $PINS Q=bank_mem_1[15][3] D=FE_DBTN121_n31
+ CK=CTS_640
Xbank_mem_1_reg[15][2] QDFFN $PINS Q=bank_mem_1[15][2] D=FE_DBTN142_n10
+ CK=CTS_640
Xbank_mem_1_reg[15][1] QDFFN $PINS Q=bank_mem_1[15][1] D=FE_DBTN135_n17
+ CK=CTS_640
Xbank_mem_1_reg[15][0] QDFFN $PINS Q=bank_mem_1[15][0] D=FE_DBTN149_n3
+ CK=CTS_640
Xbank_mem_1_reg[13][32] QDFFN $PINS Q=bank_mem_1[13][32] D=FE_DBTN136_n16
+ CK=CTS_649
Xbank_mem_1_reg[13][31] QDFFN $PINS Q=bank_mem_1[13][31] D=FE_DBTN137_n15
+ CK=CTS_649
Xbank_mem_1_reg[13][30] QDFFN $PINS Q=bank_mem_1[13][30] D=FE_DBTN138_n14
+ CK=CTS_649
Xbank_mem_1_reg[13][29] QDFFN $PINS Q=bank_mem_1[13][29] D=FE_DBTN139_n13
+ CK=CTS_649
Xbank_mem_1_reg[13][28] QDFFN $PINS Q=bank_mem_1[13][28] D=FE_DBTN140_n12
+ CK=CTS_649
Xbank_mem_1_reg[13][27] QDFFN $PINS Q=bank_mem_1[13][27] D=FE_DBTN151_n1
+ CK=CTS_649
Xbank_mem_1_reg[13][26] QDFFN $PINS Q=bank_mem_1[13][26] D=FE_DBTN141_n11
+ CK=CTS_649
Xbank_mem_1_reg[13][25] QDFFN $PINS Q=bank_mem_1[13][25] D=FE_DBTN122_n30
+ CK=CTS_649
Xbank_mem_1_reg[13][24] QDFFN $PINS Q=bank_mem_1[13][24] D=FE_DBTN123_n29
+ CK=CTS_649
Xbank_mem_1_reg[13][23] QDFFN $PINS Q=bank_mem_1[13][23] D=FE_DBTN124_n28
+ CK=CTS_649
Xbank_mem_1_reg[13][22] QDFFN $PINS Q=bank_mem_1[13][22] D=FE_DBTN125_n27
+ CK=CTS_649
Xbank_mem_1_reg[13][21] QDFFN $PINS Q=bank_mem_1[13][21] D=FE_DBTN126_n26
+ CK=CTS_649
Xbank_mem_1_reg[13][20] QDFFN $PINS Q=bank_mem_1[13][20] D=FE_DBTN127_n25
+ CK=CTS_649
Xbank_mem_1_reg[13][19] QDFFN $PINS Q=bank_mem_1[13][19] D=FE_DBTN128_n24
+ CK=CTS_649
Xbank_mem_1_reg[13][18] QDFFN $PINS Q=bank_mem_1[13][18] D=FE_DBTN129_n23
+ CK=CTS_649
Xbank_mem_1_reg[13][17] QDFFN $PINS Q=bank_mem_1[13][17] D=FE_DBTN130_n22
+ CK=CTS_649
Xbank_mem_1_reg[13][16] QDFFN $PINS Q=bank_mem_1[13][16] D=FE_DBTN131_n21
+ CK=CTS_646
Xbank_mem_1_reg[13][15] QDFFN $PINS Q=bank_mem_1[13][15] D=FE_DBTN132_n20
+ CK=CTS_646
Xbank_mem_1_reg[13][14] QDFFN $PINS Q=bank_mem_1[13][14] D=FE_DBTN133_n19
+ CK=CTS_646
Xbank_mem_1_reg[13][13] QDFFN $PINS Q=bank_mem_1[13][13] D=FE_DBTN134_n18
+ CK=CTS_646
Xbank_mem_1_reg[13][12] QDFFN $PINS Q=bank_mem_1[13][12] D=FE_DBTN150_n2
+ CK=CTS_646
Xbank_mem_1_reg[13][11] QDFFN $PINS Q=bank_mem_1[13][11] D=FE_DBTN147_n5
+ CK=CTS_646
Xbank_mem_1_reg[13][10] QDFFN $PINS Q=bank_mem_1[13][10] D=FE_DBTN148_n4
+ CK=CTS_646
Xbank_mem_1_reg[13][9] QDFFN $PINS Q=bank_mem_1[13][9] D=FE_DBTN89_n63
+ CK=CTS_646
Xbank_mem_1_reg[13][8] QDFFN $PINS Q=bank_mem_1[13][8] D=FE_DBTN84_n68
+ CK=CTS_646
Xbank_mem_1_reg[13][7] QDFFN $PINS Q=bank_mem_1[13][7] D=FE_DBTN85_n67
+ CK=CTS_646
Xbank_mem_1_reg[13][6] QDFFN $PINS Q=bank_mem_1[13][6] D=FE_DBTN86_n66
+ CK=CTS_646
Xbank_mem_1_reg[13][5] QDFFN $PINS Q=bank_mem_1[13][5] D=FE_DBTN87_n65
+ CK=CTS_646
Xbank_mem_1_reg[13][4] QDFFN $PINS Q=bank_mem_1[13][4] D=FE_DBTN88_n64
+ CK=CTS_646
Xbank_mem_1_reg[13][3] QDFFN $PINS Q=bank_mem_1[13][3] D=FE_DBTN121_n31
+ CK=CTS_646
Xbank_mem_1_reg[13][2] QDFFN $PINS Q=bank_mem_1[13][2] D=FE_DBTN142_n10
+ CK=CTS_646
Xbank_mem_1_reg[13][1] QDFFN $PINS Q=bank_mem_1[13][1] D=FE_DBTN135_n17
+ CK=CTS_646
Xbank_mem_1_reg[13][0] QDFFN $PINS Q=bank_mem_1[13][0] D=FE_DBTN149_n3
+ CK=CTS_646
Xbank_mem_1_reg[14][32] QDFFN $PINS Q=bank_mem_1[14][32] D=FE_DBTN136_n16
+ CK=CTS_592
Xbank_mem_1_reg[14][31] QDFFN $PINS Q=bank_mem_1[14][31] D=FE_DBTN137_n15
+ CK=CTS_592
Xbank_mem_1_reg[14][30] QDFFN $PINS Q=bank_mem_1[14][30] D=FE_DBTN138_n14
+ CK=CTS_592
Xbank_mem_1_reg[14][29] QDFFN $PINS Q=bank_mem_1[14][29] D=FE_DBTN139_n13
+ CK=CTS_592
Xbank_mem_1_reg[14][28] QDFFN $PINS Q=bank_mem_1[14][28] D=FE_DBTN140_n12
+ CK=CTS_592
Xbank_mem_1_reg[14][27] QDFFN $PINS Q=bank_mem_1[14][27] D=FE_DBTN151_n1
+ CK=CTS_592
Xbank_mem_1_reg[14][26] QDFFN $PINS Q=bank_mem_1[14][26] D=FE_DBTN141_n11
+ CK=CTS_592
Xbank_mem_1_reg[14][25] QDFFN $PINS Q=bank_mem_1[14][25] D=FE_DBTN122_n30
+ CK=CTS_592
Xbank_mem_1_reg[14][24] QDFFN $PINS Q=bank_mem_1[14][24] D=FE_DBTN123_n29
+ CK=CTS_592
Xbank_mem_1_reg[14][23] QDFFN $PINS Q=bank_mem_1[14][23] D=FE_DBTN124_n28
+ CK=CTS_592
Xbank_mem_1_reg[14][22] QDFFN $PINS Q=bank_mem_1[14][22] D=FE_DBTN125_n27
+ CK=CTS_592
Xbank_mem_1_reg[14][21] QDFFN $PINS Q=bank_mem_1[14][21] D=FE_DBTN126_n26
+ CK=CTS_592
Xbank_mem_1_reg[14][20] QDFFN $PINS Q=bank_mem_1[14][20] D=FE_DBTN127_n25
+ CK=CTS_592
Xbank_mem_1_reg[14][19] QDFFN $PINS Q=bank_mem_1[14][19] D=FE_DBTN128_n24
+ CK=CTS_592
Xbank_mem_1_reg[14][18] QDFFN $PINS Q=bank_mem_1[14][18] D=FE_DBTN129_n23
+ CK=CTS_592
Xbank_mem_1_reg[14][17] QDFFN $PINS Q=bank_mem_1[14][17] D=FE_DBTN130_n22
+ CK=CTS_592
Xbank_mem_1_reg[14][16] QDFFN $PINS Q=bank_mem_1[14][16] D=FE_DBTN131_n21
+ CK=CTS_643
Xbank_mem_1_reg[14][15] QDFFN $PINS Q=bank_mem_1[14][15] D=FE_DBTN132_n20
+ CK=CTS_643
Xbank_mem_1_reg[14][14] QDFFN $PINS Q=bank_mem_1[14][14] D=FE_DBTN133_n19
+ CK=CTS_643
Xbank_mem_1_reg[14][13] QDFFN $PINS Q=bank_mem_1[14][13] D=FE_DBTN134_n18
+ CK=CTS_643
Xbank_mem_1_reg[14][12] QDFFN $PINS Q=bank_mem_1[14][12] D=FE_DBTN150_n2
+ CK=CTS_643
Xbank_mem_1_reg[14][11] QDFFN $PINS Q=bank_mem_1[14][11] D=FE_DBTN147_n5
+ CK=CTS_643
Xbank_mem_1_reg[14][10] QDFFN $PINS Q=bank_mem_1[14][10] D=FE_DBTN148_n4
+ CK=CTS_643
Xbank_mem_1_reg[14][9] QDFFN $PINS Q=bank_mem_1[14][9] D=FE_DBTN89_n63
+ CK=CTS_643
Xbank_mem_1_reg[14][8] QDFFN $PINS Q=bank_mem_1[14][8] D=FE_DBTN84_n68
+ CK=CTS_643
Xbank_mem_1_reg[14][7] QDFFN $PINS Q=bank_mem_1[14][7] D=FE_DBTN85_n67
+ CK=CTS_643
Xbank_mem_1_reg[14][6] QDFFN $PINS Q=bank_mem_1[14][6] D=FE_DBTN86_n66
+ CK=CTS_643
Xbank_mem_1_reg[14][5] QDFFN $PINS Q=bank_mem_1[14][5] D=FE_DBTN87_n65
+ CK=CTS_643
Xbank_mem_1_reg[14][4] QDFFN $PINS Q=bank_mem_1[14][4] D=FE_DBTN88_n64
+ CK=CTS_643
Xbank_mem_1_reg[14][3] QDFFN $PINS Q=bank_mem_1[14][3] D=FE_DBTN121_n31
+ CK=CTS_643
Xbank_mem_1_reg[14][2] QDFFN $PINS Q=bank_mem_1[14][2] D=FE_DBTN142_n10
+ CK=CTS_643
Xbank_mem_1_reg[14][1] QDFFN $PINS Q=bank_mem_1[14][1] D=FE_DBTN135_n17
+ CK=CTS_643
Xbank_mem_1_reg[14][0] QDFFN $PINS Q=bank_mem_1[14][0] D=FE_DBTN149_n3
+ CK=CTS_643
Xbank_mem_1_reg[15][33] QDFFN $PINS Q=bank_mem_1[15][33] D=FE_DBTN120_n32
+ CK=CTS_589
Xbank_mem_1_reg[12][32] QDFFN $PINS Q=bank_mem_1[12][32] D=FE_DBTN136_n16
+ CK=CTS_595
Xbank_mem_1_reg[12][31] QDFFN $PINS Q=bank_mem_1[12][31] D=FE_DBTN137_n15
+ CK=CTS_595
Xbank_mem_1_reg[12][30] QDFFN $PINS Q=bank_mem_1[12][30] D=FE_DBTN138_n14
+ CK=CTS_595
Xbank_mem_1_reg[12][29] QDFFN $PINS Q=bank_mem_1[12][29] D=FE_DBTN139_n13
+ CK=CTS_595
Xbank_mem_1_reg[12][28] QDFFN $PINS Q=bank_mem_1[12][28] D=FE_DBTN140_n12
+ CK=CTS_595
Xbank_mem_1_reg[12][27] QDFFN $PINS Q=bank_mem_1[12][27] D=FE_DBTN151_n1
+ CK=CTS_595
Xbank_mem_1_reg[12][26] QDFFN $PINS Q=bank_mem_1[12][26] D=FE_DBTN141_n11
+ CK=CTS_595
Xbank_mem_1_reg[12][25] QDFFN $PINS Q=bank_mem_1[12][25] D=FE_DBTN122_n30
+ CK=CTS_595
Xbank_mem_1_reg[12][24] QDFFN $PINS Q=bank_mem_1[12][24] D=FE_DBTN123_n29
+ CK=CTS_595
Xbank_mem_1_reg[12][23] QDFFN $PINS Q=bank_mem_1[12][23] D=FE_DBTN124_n28
+ CK=CTS_595
Xbank_mem_1_reg[12][22] QDFFN $PINS Q=bank_mem_1[12][22] D=FE_DBTN125_n27
+ CK=CTS_595
Xbank_mem_1_reg[12][21] QDFFN $PINS Q=bank_mem_1[12][21] D=FE_DBTN126_n26
+ CK=CTS_595
Xbank_mem_1_reg[12][20] QDFFN $PINS Q=bank_mem_1[12][20] D=FE_DBTN127_n25
+ CK=CTS_595
Xbank_mem_1_reg[12][19] QDFFN $PINS Q=bank_mem_1[12][19] D=FE_DBTN128_n24
+ CK=CTS_595
Xbank_mem_1_reg[12][18] QDFFN $PINS Q=bank_mem_1[12][18] D=FE_DBTN129_n23
+ CK=CTS_595
Xbank_mem_1_reg[12][17] QDFFN $PINS Q=bank_mem_1[12][17] D=FE_DBTN130_n22
+ CK=CTS_595
Xbank_mem_1_reg[12][16] QDFFN $PINS Q=bank_mem_1[12][16] D=FE_DBTN131_n21
+ CK=CTS_652
Xbank_mem_1_reg[12][15] QDFFN $PINS Q=bank_mem_1[12][15] D=FE_DBTN132_n20
+ CK=CTS_652
Xbank_mem_1_reg[12][14] QDFFN $PINS Q=bank_mem_1[12][14] D=FE_DBTN133_n19
+ CK=CTS_652
Xbank_mem_1_reg[12][13] QDFFN $PINS Q=bank_mem_1[12][13] D=FE_DBTN134_n18
+ CK=CTS_652
Xbank_mem_1_reg[12][12] QDFFN $PINS Q=bank_mem_1[12][12] D=FE_DBTN150_n2
+ CK=CTS_652
Xbank_mem_1_reg[12][11] QDFFN $PINS Q=bank_mem_1[12][11] D=FE_DBTN147_n5
+ CK=CTS_652
Xbank_mem_1_reg[12][10] QDFFN $PINS Q=bank_mem_1[12][10] D=FE_DBTN148_n4
+ CK=CTS_652
Xbank_mem_1_reg[12][9] QDFFN $PINS Q=bank_mem_1[12][9] D=FE_DBTN89_n63
+ CK=CTS_652
Xbank_mem_1_reg[12][8] QDFFN $PINS Q=bank_mem_1[12][8] D=FE_DBTN84_n68
+ CK=CTS_652
Xbank_mem_1_reg[12][7] QDFFN $PINS Q=bank_mem_1[12][7] D=FE_DBTN85_n67
+ CK=CTS_652
Xbank_mem_1_reg[12][6] QDFFN $PINS Q=bank_mem_1[12][6] D=FE_DBTN86_n66
+ CK=CTS_652
Xbank_mem_1_reg[12][5] QDFFN $PINS Q=bank_mem_1[12][5] D=FE_DBTN87_n65
+ CK=CTS_652
Xbank_mem_1_reg[12][4] QDFFN $PINS Q=bank_mem_1[12][4] D=FE_DBTN88_n64
+ CK=CTS_652
Xbank_mem_1_reg[12][3] QDFFN $PINS Q=bank_mem_1[12][3] D=FE_DBTN121_n31
+ CK=CTS_652
Xbank_mem_1_reg[12][2] QDFFN $PINS Q=bank_mem_1[12][2] D=FE_DBTN142_n10
+ CK=CTS_652
Xbank_mem_1_reg[12][1] QDFFN $PINS Q=bank_mem_1[12][1] D=FE_DBTN135_n17
+ CK=CTS_652
Xbank_mem_1_reg[12][0] QDFFN $PINS Q=bank_mem_1[12][0] D=FE_DBTN149_n3
+ CK=CTS_652
Xbank_mem_1_reg[13][33] QDFFN $PINS Q=bank_mem_1[13][33] D=FE_DBTN120_n32
+ CK=CTS_649
Xbank_mem_0_reg[15][32] QDFFN $PINS Q=bank_mem_0[15][32] D=FE_DBTN97_n55
+ CK=CTS_737
Xbank_mem_0_reg[15][31] QDFFN $PINS Q=bank_mem_0[15][31] D=FE_DBTN98_n54
+ CK=CTS_737
Xbank_mem_0_reg[15][30] QDFFN $PINS Q=bank_mem_0[15][30] D=FE_DBTN99_n53
+ CK=CTS_737
Xbank_mem_0_reg[15][29] QDFFN $PINS Q=bank_mem_0[15][29] D=FE_DBTN100_n52
+ CK=CTS_737
Xbank_mem_0_reg[15][28] QDFFN $PINS Q=bank_mem_0[15][28] D=FE_DBTN101_n51
+ CK=CTS_737
Xbank_mem_0_reg[15][27] QDFFN $PINS Q=bank_mem_0[15][27] D=FE_DBTN102_n50
+ CK=CTS_737
Xbank_mem_0_reg[15][26] QDFFN $PINS Q=bank_mem_0[15][26] D=FE_DBTN103_n49
+ CK=CTS_737
Xbank_mem_0_reg[15][25] QDFFN $PINS Q=bank_mem_0[15][25] D=FE_DBTN104_n48
+ CK=CTS_737
Xbank_mem_0_reg[15][24] QDFFN $PINS Q=bank_mem_0[15][24] D=FE_DBTN105_n47
+ CK=CTS_737
Xbank_mem_0_reg[15][23] QDFFN $PINS Q=bank_mem_0[15][23] D=FE_DBTN106_n46
+ CK=CTS_737
Xbank_mem_0_reg[15][22] QDFFN $PINS Q=bank_mem_0[15][22] D=FE_DBTN107_n45
+ CK=CTS_737
Xbank_mem_0_reg[15][21] QDFFN $PINS Q=bank_mem_0[15][21] D=FE_DBTN108_n44
+ CK=CTS_737
Xbank_mem_0_reg[15][20] QDFFN $PINS Q=bank_mem_0[15][20] D=FE_DBTN109_n43
+ CK=CTS_737
Xbank_mem_0_reg[15][19] QDFFN $PINS Q=bank_mem_0[15][19] D=FE_DBTN110_n42
+ CK=CTS_737
Xbank_mem_0_reg[15][18] QDFFN $PINS Q=bank_mem_0[15][18] D=FE_DBTN111_n41
+ CK=CTS_737
Xbank_mem_0_reg[15][17] QDFFN $PINS Q=bank_mem_0[15][17] D=FE_DBTN112_n40
+ CK=CTS_737
Xbank_mem_0_reg[15][16] QDFFN $PINS Q=bank_mem_0[15][16] D=FE_DBTN113_n39
+ CK=CTS_701
Xbank_mem_0_reg[15][15] QDFFN $PINS Q=bank_mem_0[15][15] D=FE_DBTN114_n38
+ CK=CTS_701
Xbank_mem_0_reg[15][14] QDFFN $PINS Q=bank_mem_0[15][14] D=FE_DBTN115_n37
+ CK=CTS_701
Xbank_mem_0_reg[15][13] QDFFN $PINS Q=bank_mem_0[15][13] D=FE_DBTN116_n36
+ CK=CTS_701
Xbank_mem_0_reg[15][12] QDFFN $PINS Q=bank_mem_0[15][12] D=FE_DBTN143_n9
+ CK=CTS_701
Xbank_mem_0_reg[15][11] QDFFN $PINS Q=bank_mem_0[15][11] D=FE_DBTN144_n8
+ CK=CTS_701
Xbank_mem_0_reg[15][10] QDFFN $PINS Q=bank_mem_0[15][10] D=FE_DBTN145_n7
+ CK=CTS_701
Xbank_mem_0_reg[15][9] QDFFN $PINS Q=bank_mem_0[15][9] D=FE_DBTN90_n62
+ CK=CTS_701
Xbank_mem_0_reg[15][8] QDFFN $PINS Q=bank_mem_0[15][8] D=FE_DBTN91_n61
+ CK=CTS_701
Xbank_mem_0_reg[15][7] QDFFN $PINS Q=bank_mem_0[15][7] D=FE_DBTN92_n60
+ CK=CTS_701
Xbank_mem_0_reg[15][6] QDFFN $PINS Q=bank_mem_0[15][6] D=FE_DBTN93_n59
+ CK=CTS_701
Xbank_mem_0_reg[15][5] QDFFN $PINS Q=bank_mem_0[15][5] D=FE_DBTN94_n58
+ CK=CTS_701
Xbank_mem_0_reg[15][4] QDFFN $PINS Q=bank_mem_0[15][4] D=FE_DBTN95_n57
+ CK=CTS_701
Xbank_mem_0_reg[15][3] QDFFN $PINS Q=bank_mem_0[15][3] D=FE_DBTN117_n35
+ CK=CTS_701
Xbank_mem_0_reg[15][2] QDFFN $PINS Q=bank_mem_0[15][2] D=FE_DBTN118_n34
+ CK=CTS_701
Xbank_mem_0_reg[15][1] QDFFN $PINS Q=bank_mem_0[15][1] D=FE_DBTN119_n33
+ CK=CTS_701
Xbank_mem_0_reg[15][0] QDFFN $PINS Q=bank_mem_0[15][0] D=FE_DBTN146_n6
+ CK=CTS_701
Xbank_mem_0_reg[13][32] QDFFN $PINS Q=bank_mem_0[13][32] D=FE_DBTN97_n55
+ CK=CTS_740
Xbank_mem_0_reg[13][31] QDFFN $PINS Q=bank_mem_0[13][31] D=FE_DBTN98_n54
+ CK=CTS_740
Xbank_mem_0_reg[13][30] QDFFN $PINS Q=bank_mem_0[13][30] D=FE_DBTN99_n53
+ CK=CTS_740
Xbank_mem_0_reg[13][29] QDFFN $PINS Q=bank_mem_0[13][29] D=FE_DBTN100_n52
+ CK=CTS_740
Xbank_mem_0_reg[13][28] QDFFN $PINS Q=bank_mem_0[13][28] D=FE_DBTN101_n51
+ CK=CTS_740
Xbank_mem_0_reg[13][27] QDFFN $PINS Q=bank_mem_0[13][27] D=FE_DBTN102_n50
+ CK=CTS_740
Xbank_mem_0_reg[13][26] QDFFN $PINS Q=bank_mem_0[13][26] D=FE_DBTN103_n49
+ CK=CTS_740
Xbank_mem_0_reg[13][25] QDFFN $PINS Q=bank_mem_0[13][25] D=FE_DBTN104_n48
+ CK=CTS_740
Xbank_mem_0_reg[13][24] QDFFN $PINS Q=bank_mem_0[13][24] D=FE_DBTN105_n47
+ CK=CTS_740
Xbank_mem_0_reg[13][23] QDFFN $PINS Q=bank_mem_0[13][23] D=FE_DBTN106_n46
+ CK=CTS_740
Xbank_mem_0_reg[13][22] QDFFN $PINS Q=bank_mem_0[13][22] D=FE_DBTN107_n45
+ CK=CTS_740
Xbank_mem_0_reg[13][21] QDFFN $PINS Q=bank_mem_0[13][21] D=FE_DBTN108_n44
+ CK=CTS_740
Xbank_mem_0_reg[13][20] QDFFN $PINS Q=bank_mem_0[13][20] D=FE_DBTN109_n43
+ CK=CTS_740
Xbank_mem_0_reg[13][19] QDFFN $PINS Q=bank_mem_0[13][19] D=FE_DBTN110_n42
+ CK=CTS_740
Xbank_mem_0_reg[13][18] QDFFN $PINS Q=bank_mem_0[13][18] D=FE_DBTN111_n41
+ CK=CTS_740
Xbank_mem_0_reg[13][17] QDFFN $PINS Q=bank_mem_0[13][17] D=FE_DBTN112_n40
+ CK=CTS_740
Xbank_mem_0_reg[13][16] QDFFN $PINS Q=bank_mem_0[13][16] D=FE_DBTN113_n39
+ CK=CTS_710
Xbank_mem_0_reg[13][15] QDFFN $PINS Q=bank_mem_0[13][15] D=FE_DBTN114_n38
+ CK=CTS_710
Xbank_mem_0_reg[13][14] QDFFN $PINS Q=bank_mem_0[13][14] D=FE_DBTN115_n37
+ CK=CTS_710
Xbank_mem_0_reg[13][13] QDFFN $PINS Q=bank_mem_0[13][13] D=FE_DBTN116_n36
+ CK=CTS_710
Xbank_mem_0_reg[13][12] QDFFN $PINS Q=bank_mem_0[13][12] D=FE_DBTN143_n9
+ CK=CTS_710
Xbank_mem_0_reg[13][11] QDFFN $PINS Q=bank_mem_0[13][11] D=FE_DBTN144_n8
+ CK=CTS_710
Xbank_mem_0_reg[13][10] QDFFN $PINS Q=bank_mem_0[13][10] D=FE_DBTN145_n7
+ CK=CTS_710
Xbank_mem_0_reg[13][9] QDFFN $PINS Q=bank_mem_0[13][9] D=FE_DBTN90_n62
+ CK=CTS_710
Xbank_mem_0_reg[13][8] QDFFN $PINS Q=bank_mem_0[13][8] D=FE_DBTN91_n61
+ CK=CTS_710
Xbank_mem_0_reg[13][7] QDFFN $PINS Q=bank_mem_0[13][7] D=FE_DBTN92_n60
+ CK=CTS_710
Xbank_mem_0_reg[13][6] QDFFN $PINS Q=bank_mem_0[13][6] D=FE_DBTN93_n59
+ CK=CTS_710
Xbank_mem_0_reg[13][5] QDFFN $PINS Q=bank_mem_0[13][5] D=FE_DBTN94_n58
+ CK=CTS_710
Xbank_mem_0_reg[13][4] QDFFN $PINS Q=bank_mem_0[13][4] D=FE_DBTN95_n57
+ CK=CTS_710
Xbank_mem_0_reg[13][3] QDFFN $PINS Q=bank_mem_0[13][3] D=FE_DBTN117_n35
+ CK=CTS_710
Xbank_mem_0_reg[13][2] QDFFN $PINS Q=bank_mem_0[13][2] D=FE_DBTN118_n34
+ CK=CTS_710
Xbank_mem_0_reg[13][1] QDFFN $PINS Q=bank_mem_0[13][1] D=FE_DBTN119_n33
+ CK=CTS_710
Xbank_mem_0_reg[13][0] QDFFN $PINS Q=bank_mem_0[13][0] D=FE_DBTN146_n6
+ CK=CTS_710
Xbank_mem_1_reg[14][33] QDFFN $PINS Q=bank_mem_1[14][33] D=FE_DBTN120_n32
+ CK=CTS_592
Xbank_mem_1_reg[12][33] QDFFN $PINS Q=bank_mem_1[12][33] D=FE_DBTN120_n32
+ CK=CTS_595
Xbank_mem_0_reg[14][32] QDFFN $PINS Q=bank_mem_0[14][32] D=FE_DBTN97_n55
+ CK=CTS_707
Xbank_mem_0_reg[14][31] QDFFN $PINS Q=bank_mem_0[14][31] D=FE_DBTN98_n54
+ CK=CTS_707
Xbank_mem_0_reg[14][30] QDFFN $PINS Q=bank_mem_0[14][30] D=FE_DBTN99_n53
+ CK=CTS_707
Xbank_mem_0_reg[14][29] QDFFN $PINS Q=bank_mem_0[14][29] D=FE_DBTN100_n52
+ CK=CTS_707
Xbank_mem_0_reg[14][28] QDFFN $PINS Q=bank_mem_0[14][28] D=FE_DBTN101_n51
+ CK=CTS_707
Xbank_mem_0_reg[14][27] QDFFN $PINS Q=bank_mem_0[14][27] D=FE_DBTN102_n50
+ CK=CTS_707
Xbank_mem_0_reg[14][26] QDFFN $PINS Q=bank_mem_0[14][26] D=FE_DBTN103_n49
+ CK=CTS_707
Xbank_mem_0_reg[14][25] QDFFN $PINS Q=bank_mem_0[14][25] D=FE_DBTN104_n48
+ CK=CTS_707
Xbank_mem_0_reg[14][24] QDFFN $PINS Q=bank_mem_0[14][24] D=FE_DBTN105_n47
+ CK=CTS_707
Xbank_mem_0_reg[14][23] QDFFN $PINS Q=bank_mem_0[14][23] D=FE_DBTN106_n46
+ CK=CTS_707
Xbank_mem_0_reg[14][22] QDFFN $PINS Q=bank_mem_0[14][22] D=FE_DBTN107_n45
+ CK=CTS_707
Xbank_mem_0_reg[14][21] QDFFN $PINS Q=bank_mem_0[14][21] D=FE_DBTN108_n44
+ CK=CTS_707
Xbank_mem_0_reg[14][20] QDFFN $PINS Q=bank_mem_0[14][20] D=FE_DBTN109_n43
+ CK=CTS_707
Xbank_mem_0_reg[14][19] QDFFN $PINS Q=bank_mem_0[14][19] D=FE_DBTN110_n42
+ CK=CTS_707
Xbank_mem_0_reg[14][18] QDFFN $PINS Q=bank_mem_0[14][18] D=FE_DBTN111_n41
+ CK=CTS_707
Xbank_mem_0_reg[14][17] QDFFN $PINS Q=bank_mem_0[14][17] D=FE_DBTN112_n40
+ CK=CTS_707
Xbank_mem_0_reg[14][16] QDFFN $PINS Q=bank_mem_0[14][16] D=FE_DBTN113_n39
+ CK=CTS_704
Xbank_mem_0_reg[14][15] QDFFN $PINS Q=bank_mem_0[14][15] D=FE_DBTN114_n38
+ CK=CTS_704
Xbank_mem_0_reg[14][14] QDFFN $PINS Q=bank_mem_0[14][14] D=FE_DBTN115_n37
+ CK=CTS_704
Xbank_mem_0_reg[14][13] QDFFN $PINS Q=bank_mem_0[14][13] D=FE_DBTN116_n36
+ CK=CTS_704
Xbank_mem_0_reg[14][12] QDFFN $PINS Q=bank_mem_0[14][12] D=FE_DBTN143_n9
+ CK=CTS_704
Xbank_mem_0_reg[14][11] QDFFN $PINS Q=bank_mem_0[14][11] D=FE_DBTN144_n8
+ CK=CTS_704
Xbank_mem_0_reg[14][10] QDFFN $PINS Q=bank_mem_0[14][10] D=FE_DBTN145_n7
+ CK=CTS_704
Xbank_mem_0_reg[14][9] QDFFN $PINS Q=bank_mem_0[14][9] D=FE_DBTN90_n62
+ CK=CTS_704
Xbank_mem_0_reg[14][8] QDFFN $PINS Q=bank_mem_0[14][8] D=FE_DBTN91_n61
+ CK=CTS_704
Xbank_mem_0_reg[14][7] QDFFN $PINS Q=bank_mem_0[14][7] D=FE_DBTN92_n60
+ CK=CTS_704
Xbank_mem_0_reg[14][6] QDFFN $PINS Q=bank_mem_0[14][6] D=FE_DBTN93_n59
+ CK=CTS_704
Xbank_mem_0_reg[14][5] QDFFN $PINS Q=bank_mem_0[14][5] D=FE_DBTN94_n58
+ CK=CTS_704
Xbank_mem_0_reg[14][4] QDFFN $PINS Q=bank_mem_0[14][4] D=FE_DBTN95_n57
+ CK=CTS_704
Xbank_mem_0_reg[14][3] QDFFN $PINS Q=bank_mem_0[14][3] D=FE_DBTN117_n35
+ CK=CTS_704
Xbank_mem_0_reg[14][2] QDFFN $PINS Q=bank_mem_0[14][2] D=FE_DBTN118_n34
+ CK=CTS_704
Xbank_mem_0_reg[14][1] QDFFN $PINS Q=bank_mem_0[14][1] D=FE_DBTN119_n33
+ CK=CTS_704
Xbank_mem_0_reg[14][0] QDFFN $PINS Q=bank_mem_0[14][0] D=FE_DBTN146_n6
+ CK=CTS_704
Xbank_mem_0_reg[15][33] QDFFN $PINS Q=bank_mem_0[15][33] D=FE_DBTN96_n56
+ CK=CTS_737
Xbank_mem_0_reg[12][32] QDFFN $PINS Q=bank_mem_0[12][32] D=FE_DBTN97_n55
+ CK=CTS_746
Xbank_mem_0_reg[12][31] QDFFN $PINS Q=bank_mem_0[12][31] D=FE_DBTN98_n54
+ CK=CTS_746
Xbank_mem_0_reg[12][30] QDFFN $PINS Q=bank_mem_0[12][30] D=FE_DBTN99_n53
+ CK=CTS_746
Xbank_mem_0_reg[12][29] QDFFN $PINS Q=bank_mem_0[12][29] D=FE_DBTN100_n52
+ CK=CTS_746
Xbank_mem_0_reg[12][28] QDFFN $PINS Q=bank_mem_0[12][28] D=FE_DBTN101_n51
+ CK=CTS_746
Xbank_mem_0_reg[12][27] QDFFN $PINS Q=bank_mem_0[12][27] D=FE_DBTN102_n50
+ CK=CTS_746
Xbank_mem_0_reg[12][26] QDFFN $PINS Q=bank_mem_0[12][26] D=FE_DBTN103_n49
+ CK=CTS_746
Xbank_mem_0_reg[12][25] QDFFN $PINS Q=bank_mem_0[12][25] D=FE_DBTN104_n48
+ CK=CTS_746
Xbank_mem_0_reg[12][24] QDFFN $PINS Q=bank_mem_0[12][24] D=FE_DBTN105_n47
+ CK=CTS_746
Xbank_mem_0_reg[12][23] QDFFN $PINS Q=bank_mem_0[12][23] D=FE_DBTN106_n46
+ CK=CTS_746
Xbank_mem_0_reg[12][22] QDFFN $PINS Q=bank_mem_0[12][22] D=FE_DBTN107_n45
+ CK=CTS_746
Xbank_mem_0_reg[12][21] QDFFN $PINS Q=bank_mem_0[12][21] D=FE_DBTN108_n44
+ CK=CTS_746
Xbank_mem_0_reg[12][20] QDFFN $PINS Q=bank_mem_0[12][20] D=FE_DBTN109_n43
+ CK=CTS_746
Xbank_mem_0_reg[12][19] QDFFN $PINS Q=bank_mem_0[12][19] D=FE_DBTN110_n42
+ CK=CTS_746
Xbank_mem_0_reg[12][18] QDFFN $PINS Q=bank_mem_0[12][18] D=FE_DBTN111_n41
+ CK=CTS_746
Xbank_mem_0_reg[12][17] QDFFN $PINS Q=bank_mem_0[12][17] D=FE_DBTN112_n40
+ CK=CTS_746
Xbank_mem_0_reg[12][16] QDFFN $PINS Q=bank_mem_0[12][16] D=FE_DBTN113_n39
+ CK=CTS_743
Xbank_mem_0_reg[12][15] QDFFN $PINS Q=bank_mem_0[12][15] D=FE_DBTN114_n38
+ CK=CTS_743
Xbank_mem_0_reg[12][14] QDFFN $PINS Q=bank_mem_0[12][14] D=FE_DBTN115_n37
+ CK=CTS_743
Xbank_mem_0_reg[12][13] QDFFN $PINS Q=bank_mem_0[12][13] D=FE_DBTN116_n36
+ CK=CTS_743
Xbank_mem_0_reg[12][12] QDFFN $PINS Q=bank_mem_0[12][12] D=FE_DBTN143_n9
+ CK=CTS_743
Xbank_mem_0_reg[12][11] QDFFN $PINS Q=bank_mem_0[12][11] D=FE_DBTN144_n8
+ CK=CTS_743
Xbank_mem_0_reg[12][10] QDFFN $PINS Q=bank_mem_0[12][10] D=FE_DBTN145_n7
+ CK=CTS_743
Xbank_mem_0_reg[12][9] QDFFN $PINS Q=bank_mem_0[12][9] D=FE_DBTN90_n62
+ CK=CTS_743
Xbank_mem_0_reg[12][8] QDFFN $PINS Q=bank_mem_0[12][8] D=FE_DBTN91_n61
+ CK=CTS_743
Xbank_mem_0_reg[12][7] QDFFN $PINS Q=bank_mem_0[12][7] D=FE_DBTN92_n60
+ CK=CTS_743
Xbank_mem_0_reg[12][6] QDFFN $PINS Q=bank_mem_0[12][6] D=FE_DBTN93_n59
+ CK=CTS_743
Xbank_mem_0_reg[12][5] QDFFN $PINS Q=bank_mem_0[12][5] D=FE_DBTN94_n58
+ CK=CTS_743
Xbank_mem_0_reg[12][4] QDFFN $PINS Q=bank_mem_0[12][4] D=FE_DBTN95_n57
+ CK=CTS_743
Xbank_mem_0_reg[12][3] QDFFN $PINS Q=bank_mem_0[12][3] D=FE_DBTN117_n35
+ CK=CTS_743
Xbank_mem_0_reg[12][2] QDFFN $PINS Q=bank_mem_0[12][2] D=FE_DBTN118_n34
+ CK=CTS_743
Xbank_mem_0_reg[12][1] QDFFN $PINS Q=bank_mem_0[12][1] D=FE_DBTN119_n33
+ CK=CTS_743
Xbank_mem_0_reg[12][0] QDFFN $PINS Q=bank_mem_0[12][0] D=FE_DBTN146_n6
+ CK=CTS_743
Xbank_mem_0_reg[13][33] QDFFN $PINS Q=bank_mem_0[13][33] D=FE_DBTN96_n56
+ CK=CTS_740
Xbank_mem_0_reg[14][33] QDFFN $PINS Q=bank_mem_0[14][33] D=FE_DBTN96_n56
+ CK=CTS_707
Xbank_mem_0_reg[12][33] QDFFN $PINS Q=bank_mem_0[12][33] D=FE_DBTN96_n56
+ CK=CTS_746
Xbank_mem_1_reg[9][32] QDFFN $PINS Q=bank_mem_1[9][32] D=FE_DBTN136_n16
+ CK=CTS_604
Xbank_mem_1_reg[9][31] QDFFN $PINS Q=bank_mem_1[9][31] D=FE_DBTN137_n15
+ CK=CTS_604
Xbank_mem_1_reg[9][30] QDFFN $PINS Q=bank_mem_1[9][30] D=FE_DBTN138_n14
+ CK=CTS_604
Xbank_mem_1_reg[9][29] QDFFN $PINS Q=bank_mem_1[9][29] D=FE_DBTN139_n13
+ CK=CTS_604
Xbank_mem_1_reg[9][28] QDFFN $PINS Q=bank_mem_1[9][28] D=FE_DBTN140_n12
+ CK=CTS_604
Xbank_mem_1_reg[9][27] QDFFN $PINS Q=bank_mem_1[9][27] D=FE_DBTN151_n1
+ CK=CTS_604
Xbank_mem_1_reg[9][26] QDFFN $PINS Q=bank_mem_1[9][26] D=FE_DBTN141_n11
+ CK=CTS_604
Xbank_mem_1_reg[9][25] QDFFN $PINS Q=bank_mem_1[9][25] D=FE_DBTN122_n30
+ CK=CTS_604
Xbank_mem_1_reg[9][24] QDFFN $PINS Q=bank_mem_1[9][24] D=FE_DBTN123_n29
+ CK=CTS_604
Xbank_mem_1_reg[9][23] QDFFN $PINS Q=bank_mem_1[9][23] D=FE_DBTN124_n28
+ CK=CTS_604
Xbank_mem_1_reg[9][22] QDFFN $PINS Q=bank_mem_1[9][22] D=FE_DBTN125_n27
+ CK=CTS_604
Xbank_mem_1_reg[9][21] QDFFN $PINS Q=bank_mem_1[9][21] D=FE_DBTN126_n26
+ CK=CTS_604
Xbank_mem_1_reg[9][20] QDFFN $PINS Q=bank_mem_1[9][20] D=FE_DBTN127_n25
+ CK=CTS_604
Xbank_mem_1_reg[9][19] QDFFN $PINS Q=bank_mem_1[9][19] D=FE_DBTN128_n24
+ CK=CTS_604
Xbank_mem_1_reg[9][18] QDFFN $PINS Q=bank_mem_1[9][18] D=FE_DBTN129_n23
+ CK=CTS_604
Xbank_mem_1_reg[9][17] QDFFN $PINS Q=bank_mem_1[9][17] D=FE_DBTN130_n22
+ CK=CTS_604
Xbank_mem_1_reg[9][16] QDFFN $PINS Q=bank_mem_1[9][16] D=FE_DBTN131_n21
+ CK=CTS_661
Xbank_mem_1_reg[9][15] QDFFN $PINS Q=bank_mem_1[9][15] D=FE_DBTN132_n20
+ CK=CTS_661
Xbank_mem_1_reg[9][14] QDFFN $PINS Q=bank_mem_1[9][14] D=FE_DBTN133_n19
+ CK=CTS_661
Xbank_mem_1_reg[9][13] QDFFN $PINS Q=bank_mem_1[9][13] D=FE_DBTN134_n18
+ CK=CTS_661
Xbank_mem_1_reg[9][12] QDFFN $PINS Q=bank_mem_1[9][12] D=FE_DBTN150_n2
+ CK=CTS_661
Xbank_mem_1_reg[9][11] QDFFN $PINS Q=bank_mem_1[9][11] D=FE_DBTN147_n5
+ CK=CTS_661
Xbank_mem_1_reg[9][10] QDFFN $PINS Q=bank_mem_1[9][10] D=FE_DBTN148_n4
+ CK=CTS_661
Xbank_mem_1_reg[9][9] QDFFN $PINS Q=bank_mem_1[9][9] D=FE_DBTN89_n63 CK=CTS_661
Xbank_mem_1_reg[9][8] QDFFN $PINS Q=bank_mem_1[9][8] D=FE_DBTN84_n68 CK=CTS_661
Xbank_mem_1_reg[9][7] QDFFN $PINS Q=bank_mem_1[9][7] D=FE_DBTN85_n67 CK=CTS_661
Xbank_mem_1_reg[9][6] QDFFN $PINS Q=bank_mem_1[9][6] D=FE_DBTN86_n66 CK=CTS_661
Xbank_mem_1_reg[9][5] QDFFN $PINS Q=bank_mem_1[9][5] D=FE_DBTN87_n65 CK=CTS_661
Xbank_mem_1_reg[9][4] QDFFN $PINS Q=bank_mem_1[9][4] D=FE_DBTN88_n64 CK=CTS_661
Xbank_mem_1_reg[9][3] QDFFN $PINS Q=bank_mem_1[9][3] D=FE_DBTN121_n31
+ CK=CTS_661
Xbank_mem_1_reg[9][2] QDFFN $PINS Q=bank_mem_1[9][2] D=FE_DBTN142_n10
+ CK=CTS_661
Xbank_mem_1_reg[9][1] QDFFN $PINS Q=bank_mem_1[9][1] D=FE_DBTN135_n17
+ CK=CTS_661
Xbank_mem_1_reg[9][0] QDFFN $PINS Q=bank_mem_1[9][0] D=FE_DBTN149_n3 CK=CTS_661
Xbank_mem_1_reg[11][32] QDFFN $PINS Q=bank_mem_1[11][32] D=FE_DBTN136_n16
+ CK=CTS_598
Xbank_mem_1_reg[11][31] QDFFN $PINS Q=bank_mem_1[11][31] D=FE_DBTN137_n15
+ CK=CTS_598
Xbank_mem_1_reg[11][30] QDFFN $PINS Q=bank_mem_1[11][30] D=FE_DBTN138_n14
+ CK=CTS_598
Xbank_mem_1_reg[11][29] QDFFN $PINS Q=bank_mem_1[11][29] D=FE_DBTN139_n13
+ CK=CTS_598
Xbank_mem_1_reg[11][28] QDFFN $PINS Q=bank_mem_1[11][28] D=FE_DBTN140_n12
+ CK=CTS_598
Xbank_mem_1_reg[11][27] QDFFN $PINS Q=bank_mem_1[11][27] D=FE_DBTN151_n1
+ CK=CTS_598
Xbank_mem_1_reg[11][26] QDFFN $PINS Q=bank_mem_1[11][26] D=FE_DBTN141_n11
+ CK=CTS_598
Xbank_mem_1_reg[11][25] QDFFN $PINS Q=bank_mem_1[11][25] D=FE_DBTN122_n30
+ CK=CTS_598
Xbank_mem_1_reg[11][24] QDFFN $PINS Q=bank_mem_1[11][24] D=FE_DBTN123_n29
+ CK=CTS_598
Xbank_mem_1_reg[11][23] QDFFN $PINS Q=bank_mem_1[11][23] D=FE_DBTN124_n28
+ CK=CTS_598
Xbank_mem_1_reg[11][22] QDFFN $PINS Q=bank_mem_1[11][22] D=FE_DBTN125_n27
+ CK=CTS_598
Xbank_mem_1_reg[11][21] QDFFN $PINS Q=bank_mem_1[11][21] D=FE_DBTN126_n26
+ CK=CTS_598
Xbank_mem_1_reg[11][20] QDFFN $PINS Q=bank_mem_1[11][20] D=FE_DBTN127_n25
+ CK=CTS_598
Xbank_mem_1_reg[11][19] QDFFN $PINS Q=bank_mem_1[11][19] D=FE_DBTN128_n24
+ CK=CTS_598
Xbank_mem_1_reg[11][18] QDFFN $PINS Q=bank_mem_1[11][18] D=FE_DBTN129_n23
+ CK=CTS_598
Xbank_mem_1_reg[11][17] QDFFN $PINS Q=bank_mem_1[11][17] D=FE_DBTN130_n22
+ CK=CTS_598
Xbank_mem_1_reg[11][16] QDFFN $PINS Q=bank_mem_1[11][16] D=FE_DBTN131_n21
+ CK=CTS_655
Xbank_mem_1_reg[11][15] QDFFN $PINS Q=bank_mem_1[11][15] D=FE_DBTN132_n20
+ CK=CTS_655
Xbank_mem_1_reg[11][14] QDFFN $PINS Q=bank_mem_1[11][14] D=FE_DBTN133_n19
+ CK=CTS_655
Xbank_mem_1_reg[11][13] QDFFN $PINS Q=bank_mem_1[11][13] D=FE_DBTN134_n18
+ CK=CTS_655
Xbank_mem_1_reg[11][12] QDFFN $PINS Q=bank_mem_1[11][12] D=FE_DBTN150_n2
+ CK=CTS_655
Xbank_mem_1_reg[11][11] QDFFN $PINS Q=bank_mem_1[11][11] D=FE_DBTN147_n5
+ CK=CTS_655
Xbank_mem_1_reg[11][10] QDFFN $PINS Q=bank_mem_1[11][10] D=FE_DBTN148_n4
+ CK=CTS_655
Xbank_mem_1_reg[11][9] QDFFN $PINS Q=bank_mem_1[11][9] D=FE_DBTN89_n63
+ CK=CTS_655
Xbank_mem_1_reg[11][8] QDFFN $PINS Q=bank_mem_1[11][8] D=FE_DBTN84_n68
+ CK=CTS_655
Xbank_mem_1_reg[11][7] QDFFN $PINS Q=bank_mem_1[11][7] D=FE_DBTN85_n67
+ CK=CTS_655
Xbank_mem_1_reg[11][6] QDFFN $PINS Q=bank_mem_1[11][6] D=FE_DBTN86_n66
+ CK=CTS_655
Xbank_mem_1_reg[11][5] QDFFN $PINS Q=bank_mem_1[11][5] D=FE_DBTN87_n65
+ CK=CTS_655
Xbank_mem_1_reg[11][4] QDFFN $PINS Q=bank_mem_1[11][4] D=FE_DBTN88_n64
+ CK=CTS_655
Xbank_mem_1_reg[11][3] QDFFN $PINS Q=bank_mem_1[11][3] D=FE_DBTN121_n31
+ CK=CTS_655
Xbank_mem_1_reg[11][2] QDFFN $PINS Q=bank_mem_1[11][2] D=FE_DBTN142_n10
+ CK=CTS_655
Xbank_mem_1_reg[11][1] QDFFN $PINS Q=bank_mem_1[11][1] D=FE_DBTN135_n17
+ CK=CTS_655
Xbank_mem_1_reg[11][0] QDFFN $PINS Q=bank_mem_1[11][0] D=FE_DBTN149_n3
+ CK=CTS_655
Xbank_mem_1_reg[8][32] QDFFN $PINS Q=bank_mem_1[8][32] D=FE_DBTN136_n16
+ CK=CTS_607
Xbank_mem_1_reg[8][31] QDFFN $PINS Q=bank_mem_1[8][31] D=FE_DBTN137_n15
+ CK=CTS_607
Xbank_mem_1_reg[8][30] QDFFN $PINS Q=bank_mem_1[8][30] D=FE_DBTN138_n14
+ CK=CTS_607
Xbank_mem_1_reg[8][29] QDFFN $PINS Q=bank_mem_1[8][29] D=FE_DBTN139_n13
+ CK=CTS_607
Xbank_mem_1_reg[8][28] QDFFN $PINS Q=bank_mem_1[8][28] D=FE_DBTN140_n12
+ CK=CTS_607
Xbank_mem_1_reg[8][27] QDFFN $PINS Q=bank_mem_1[8][27] D=FE_DBTN151_n1
+ CK=CTS_607
Xbank_mem_1_reg[8][26] QDFFN $PINS Q=bank_mem_1[8][26] D=FE_DBTN141_n11
+ CK=CTS_607
Xbank_mem_1_reg[8][25] QDFFN $PINS Q=bank_mem_1[8][25] D=FE_DBTN122_n30
+ CK=CTS_607
Xbank_mem_1_reg[8][24] QDFFN $PINS Q=bank_mem_1[8][24] D=FE_DBTN123_n29
+ CK=CTS_607
Xbank_mem_1_reg[8][23] QDFFN $PINS Q=bank_mem_1[8][23] D=FE_DBTN124_n28
+ CK=CTS_607
Xbank_mem_1_reg[8][22] QDFFN $PINS Q=bank_mem_1[8][22] D=FE_DBTN125_n27
+ CK=CTS_607
Xbank_mem_1_reg[8][21] QDFFN $PINS Q=bank_mem_1[8][21] D=FE_DBTN126_n26
+ CK=CTS_607
Xbank_mem_1_reg[8][20] QDFFN $PINS Q=bank_mem_1[8][20] D=FE_DBTN127_n25
+ CK=CTS_607
Xbank_mem_1_reg[8][19] QDFFN $PINS Q=bank_mem_1[8][19] D=FE_DBTN128_n24
+ CK=CTS_607
Xbank_mem_1_reg[8][18] QDFFN $PINS Q=bank_mem_1[8][18] D=FE_DBTN129_n23
+ CK=CTS_607
Xbank_mem_1_reg[8][17] QDFFN $PINS Q=bank_mem_1[8][17] D=FE_DBTN130_n22
+ CK=CTS_607
Xbank_mem_1_reg[8][16] QDFFN $PINS Q=bank_mem_1[8][16] D=FE_DBTN131_n21
+ CK=CTS_664
Xbank_mem_1_reg[8][15] QDFFN $PINS Q=bank_mem_1[8][15] D=FE_DBTN132_n20
+ CK=CTS_664
Xbank_mem_1_reg[8][14] QDFFN $PINS Q=bank_mem_1[8][14] D=FE_DBTN133_n19
+ CK=CTS_664
Xbank_mem_1_reg[8][13] QDFFN $PINS Q=bank_mem_1[8][13] D=FE_DBTN134_n18
+ CK=CTS_664
Xbank_mem_1_reg[8][12] QDFFN $PINS Q=bank_mem_1[8][12] D=FE_DBTN150_n2
+ CK=CTS_664
Xbank_mem_1_reg[8][11] QDFFN $PINS Q=bank_mem_1[8][11] D=FE_DBTN147_n5
+ CK=CTS_664
Xbank_mem_1_reg[8][10] QDFFN $PINS Q=bank_mem_1[8][10] D=FE_DBTN148_n4
+ CK=CTS_664
Xbank_mem_1_reg[8][9] QDFFN $PINS Q=bank_mem_1[8][9] D=FE_DBTN89_n63 CK=CTS_664
Xbank_mem_1_reg[8][8] QDFFN $PINS Q=bank_mem_1[8][8] D=FE_DBTN84_n68 CK=CTS_664
Xbank_mem_1_reg[8][7] QDFFN $PINS Q=bank_mem_1[8][7] D=FE_DBTN85_n67 CK=CTS_664
Xbank_mem_1_reg[8][6] QDFFN $PINS Q=bank_mem_1[8][6] D=FE_DBTN86_n66 CK=CTS_664
Xbank_mem_1_reg[8][5] QDFFN $PINS Q=bank_mem_1[8][5] D=FE_DBTN87_n65 CK=CTS_664
Xbank_mem_1_reg[8][4] QDFFN $PINS Q=bank_mem_1[8][4] D=FE_DBTN88_n64 CK=CTS_664
Xbank_mem_1_reg[8][3] QDFFN $PINS Q=bank_mem_1[8][3] D=FE_DBTN121_n31
+ CK=CTS_664
Xbank_mem_1_reg[8][2] QDFFN $PINS Q=bank_mem_1[8][2] D=FE_DBTN142_n10
+ CK=CTS_664
Xbank_mem_1_reg[8][1] QDFFN $PINS Q=bank_mem_1[8][1] D=FE_DBTN135_n17
+ CK=CTS_664
Xbank_mem_1_reg[8][0] QDFFN $PINS Q=bank_mem_1[8][0] D=FE_DBTN149_n3 CK=CTS_664
Xbank_mem_1_reg[9][33] QDFFN $PINS Q=bank_mem_1[9][33] D=FE_DBTN120_n32
+ CK=CTS_604
Xbank_mem_1_reg[10][32] QDFFN $PINS Q=bank_mem_1[10][32] D=FE_DBTN136_n16
+ CK=CTS_601
Xbank_mem_1_reg[10][31] QDFFN $PINS Q=bank_mem_1[10][31] D=FE_DBTN137_n15
+ CK=CTS_601
Xbank_mem_1_reg[10][30] QDFFN $PINS Q=bank_mem_1[10][30] D=FE_DBTN138_n14
+ CK=CTS_601
Xbank_mem_1_reg[10][29] QDFFN $PINS Q=bank_mem_1[10][29] D=FE_DBTN139_n13
+ CK=CTS_601
Xbank_mem_1_reg[10][28] QDFFN $PINS Q=bank_mem_1[10][28] D=FE_DBTN140_n12
+ CK=CTS_601
Xbank_mem_1_reg[10][27] QDFFN $PINS Q=bank_mem_1[10][27] D=FE_DBTN151_n1
+ CK=CTS_601
Xbank_mem_1_reg[10][26] QDFFN $PINS Q=bank_mem_1[10][26] D=FE_DBTN141_n11
+ CK=CTS_601
Xbank_mem_1_reg[10][25] QDFFN $PINS Q=bank_mem_1[10][25] D=FE_DBTN122_n30
+ CK=CTS_601
Xbank_mem_1_reg[10][24] QDFFN $PINS Q=bank_mem_1[10][24] D=FE_DBTN123_n29
+ CK=CTS_601
Xbank_mem_1_reg[10][23] QDFFN $PINS Q=bank_mem_1[10][23] D=FE_DBTN124_n28
+ CK=CTS_601
Xbank_mem_1_reg[10][22] QDFFN $PINS Q=bank_mem_1[10][22] D=FE_DBTN125_n27
+ CK=CTS_601
Xbank_mem_1_reg[10][21] QDFFN $PINS Q=bank_mem_1[10][21] D=FE_DBTN126_n26
+ CK=CTS_601
Xbank_mem_1_reg[10][20] QDFFN $PINS Q=bank_mem_1[10][20] D=FE_DBTN127_n25
+ CK=CTS_601
Xbank_mem_1_reg[10][19] QDFFN $PINS Q=bank_mem_1[10][19] D=FE_DBTN128_n24
+ CK=CTS_601
Xbank_mem_1_reg[10][18] QDFFN $PINS Q=bank_mem_1[10][18] D=FE_DBTN129_n23
+ CK=CTS_601
Xbank_mem_1_reg[10][17] QDFFN $PINS Q=bank_mem_1[10][17] D=FE_DBTN130_n22
+ CK=CTS_601
Xbank_mem_1_reg[10][16] QDFFN $PINS Q=bank_mem_1[10][16] D=FE_DBTN131_n21
+ CK=CTS_658
Xbank_mem_1_reg[10][15] QDFFN $PINS Q=bank_mem_1[10][15] D=FE_DBTN132_n20
+ CK=CTS_658
Xbank_mem_1_reg[10][14] QDFFN $PINS Q=bank_mem_1[10][14] D=FE_DBTN133_n19
+ CK=CTS_658
Xbank_mem_1_reg[10][13] QDFFN $PINS Q=bank_mem_1[10][13] D=FE_DBTN134_n18
+ CK=CTS_658
Xbank_mem_1_reg[10][12] QDFFN $PINS Q=bank_mem_1[10][12] D=FE_DBTN150_n2
+ CK=CTS_658
Xbank_mem_1_reg[10][11] QDFFN $PINS Q=bank_mem_1[10][11] D=FE_DBTN147_n5
+ CK=CTS_658
Xbank_mem_1_reg[10][10] QDFFN $PINS Q=bank_mem_1[10][10] D=FE_DBTN148_n4
+ CK=CTS_658
Xbank_mem_1_reg[10][9] QDFFN $PINS Q=bank_mem_1[10][9] D=FE_DBTN89_n63
+ CK=CTS_658
Xbank_mem_1_reg[10][8] QDFFN $PINS Q=bank_mem_1[10][8] D=FE_DBTN84_n68
+ CK=CTS_658
Xbank_mem_1_reg[10][7] QDFFN $PINS Q=bank_mem_1[10][7] D=FE_DBTN85_n67
+ CK=CTS_658
Xbank_mem_1_reg[10][6] QDFFN $PINS Q=bank_mem_1[10][6] D=FE_DBTN86_n66
+ CK=CTS_658
Xbank_mem_1_reg[10][5] QDFFN $PINS Q=bank_mem_1[10][5] D=FE_DBTN87_n65
+ CK=CTS_658
Xbank_mem_1_reg[10][4] QDFFN $PINS Q=bank_mem_1[10][4] D=FE_DBTN88_n64
+ CK=CTS_658
Xbank_mem_1_reg[10][3] QDFFN $PINS Q=bank_mem_1[10][3] D=FE_DBTN121_n31
+ CK=CTS_658
Xbank_mem_1_reg[10][2] QDFFN $PINS Q=bank_mem_1[10][2] D=FE_DBTN142_n10
+ CK=CTS_658
Xbank_mem_1_reg[10][1] QDFFN $PINS Q=bank_mem_1[10][1] D=FE_DBTN135_n17
+ CK=CTS_658
Xbank_mem_1_reg[10][0] QDFFN $PINS Q=bank_mem_1[10][0] D=FE_DBTN149_n3
+ CK=CTS_658
Xbank_mem_1_reg[11][33] QDFFN $PINS Q=bank_mem_1[11][33] D=FE_DBTN120_n32
+ CK=CTS_598
Xbank_mem_0_reg[9][32] QDFFN $PINS Q=bank_mem_0[9][32] D=FE_DBTN97_n55
+ CK=CTS_728
Xbank_mem_0_reg[9][31] QDFFN $PINS Q=bank_mem_0[9][31] D=FE_DBTN98_n54
+ CK=CTS_728
Xbank_mem_0_reg[9][30] QDFFN $PINS Q=bank_mem_0[9][30] D=FE_DBTN99_n53
+ CK=CTS_728
Xbank_mem_0_reg[9][29] QDFFN $PINS Q=bank_mem_0[9][29] D=FE_DBTN100_n52
+ CK=CTS_728
Xbank_mem_0_reg[9][28] QDFFN $PINS Q=bank_mem_0[9][28] D=FE_DBTN101_n51
+ CK=CTS_728
Xbank_mem_0_reg[9][27] QDFFN $PINS Q=bank_mem_0[9][27] D=FE_DBTN102_n50
+ CK=CTS_728
Xbank_mem_0_reg[9][26] QDFFN $PINS Q=bank_mem_0[9][26] D=FE_DBTN103_n49
+ CK=CTS_728
Xbank_mem_0_reg[9][25] QDFFN $PINS Q=bank_mem_0[9][25] D=FE_DBTN104_n48
+ CK=CTS_728
Xbank_mem_0_reg[9][24] QDFFN $PINS Q=bank_mem_0[9][24] D=FE_DBTN105_n47
+ CK=CTS_728
Xbank_mem_0_reg[9][23] QDFFN $PINS Q=bank_mem_0[9][23] D=FE_DBTN106_n46
+ CK=CTS_728
Xbank_mem_0_reg[9][22] QDFFN $PINS Q=bank_mem_0[9][22] D=FE_DBTN107_n45
+ CK=CTS_728
Xbank_mem_0_reg[9][21] QDFFN $PINS Q=bank_mem_0[9][21] D=FE_DBTN108_n44
+ CK=CTS_728
Xbank_mem_0_reg[9][20] QDFFN $PINS Q=bank_mem_0[9][20] D=FE_DBTN109_n43
+ CK=CTS_728
Xbank_mem_0_reg[9][19] QDFFN $PINS Q=bank_mem_0[9][19] D=FE_DBTN110_n42
+ CK=CTS_728
Xbank_mem_0_reg[9][18] QDFFN $PINS Q=bank_mem_0[9][18] D=FE_DBTN111_n41
+ CK=CTS_728
Xbank_mem_0_reg[9][17] QDFFN $PINS Q=bank_mem_0[9][17] D=FE_DBTN112_n40
+ CK=CTS_728
Xbank_mem_0_reg[9][16] QDFFN $PINS Q=bank_mem_0[9][16] D=FE_DBTN113_n39
+ CK=CTS_725
Xbank_mem_0_reg[9][15] QDFFN $PINS Q=bank_mem_0[9][15] D=FE_DBTN114_n38
+ CK=CTS_725
Xbank_mem_0_reg[9][14] QDFFN $PINS Q=bank_mem_0[9][14] D=FE_DBTN115_n37
+ CK=CTS_725
Xbank_mem_0_reg[9][13] QDFFN $PINS Q=bank_mem_0[9][13] D=FE_DBTN116_n36
+ CK=CTS_725
Xbank_mem_0_reg[9][12] QDFFN $PINS Q=bank_mem_0[9][12] D=FE_DBTN143_n9
+ CK=CTS_725
Xbank_mem_0_reg[9][11] QDFFN $PINS Q=bank_mem_0[9][11] D=FE_DBTN144_n8
+ CK=CTS_725
Xbank_mem_0_reg[9][10] QDFFN $PINS Q=bank_mem_0[9][10] D=FE_DBTN145_n7
+ CK=CTS_725
Xbank_mem_0_reg[9][9] QDFFN $PINS Q=bank_mem_0[9][9] D=FE_DBTN90_n62 CK=CTS_725
Xbank_mem_0_reg[9][8] QDFFN $PINS Q=bank_mem_0[9][8] D=FE_DBTN91_n61 CK=CTS_725
Xbank_mem_0_reg[9][7] QDFFN $PINS Q=bank_mem_0[9][7] D=FE_DBTN92_n60 CK=CTS_725
Xbank_mem_0_reg[9][6] QDFFN $PINS Q=bank_mem_0[9][6] D=FE_DBTN93_n59 CK=CTS_725
Xbank_mem_0_reg[9][5] QDFFN $PINS Q=bank_mem_0[9][5] D=FE_DBTN94_n58 CK=CTS_725
Xbank_mem_0_reg[9][4] QDFFN $PINS Q=bank_mem_0[9][4] D=FE_DBTN95_n57 CK=CTS_725
Xbank_mem_0_reg[9][3] QDFFN $PINS Q=bank_mem_0[9][3] D=FE_DBTN117_n35
+ CK=CTS_725
Xbank_mem_0_reg[9][2] QDFFN $PINS Q=bank_mem_0[9][2] D=FE_DBTN118_n34
+ CK=CTS_725
Xbank_mem_0_reg[9][1] QDFFN $PINS Q=bank_mem_0[9][1] D=FE_DBTN119_n33
+ CK=CTS_725
Xbank_mem_0_reg[9][0] QDFFN $PINS Q=bank_mem_0[9][0] D=FE_DBTN146_n6 CK=CTS_725
Xbank_mem_0_reg[11][32] QDFFN $PINS Q=bank_mem_0[11][32] D=FE_DBTN97_n55
+ CK=CTS_716
Xbank_mem_0_reg[11][31] QDFFN $PINS Q=bank_mem_0[11][31] D=FE_DBTN98_n54
+ CK=CTS_716
Xbank_mem_0_reg[11][30] QDFFN $PINS Q=bank_mem_0[11][30] D=FE_DBTN99_n53
+ CK=CTS_716
Xbank_mem_0_reg[11][29] QDFFN $PINS Q=bank_mem_0[11][29] D=FE_DBTN100_n52
+ CK=CTS_716
Xbank_mem_0_reg[11][28] QDFFN $PINS Q=bank_mem_0[11][28] D=FE_DBTN101_n51
+ CK=CTS_716
Xbank_mem_0_reg[11][27] QDFFN $PINS Q=bank_mem_0[11][27] D=FE_DBTN102_n50
+ CK=CTS_716
Xbank_mem_0_reg[11][26] QDFFN $PINS Q=bank_mem_0[11][26] D=FE_DBTN103_n49
+ CK=CTS_716
Xbank_mem_0_reg[11][25] QDFFN $PINS Q=bank_mem_0[11][25] D=FE_DBTN104_n48
+ CK=CTS_716
Xbank_mem_0_reg[11][24] QDFFN $PINS Q=bank_mem_0[11][24] D=FE_DBTN105_n47
+ CK=CTS_716
Xbank_mem_0_reg[11][23] QDFFN $PINS Q=bank_mem_0[11][23] D=FE_DBTN106_n46
+ CK=CTS_716
Xbank_mem_0_reg[11][22] QDFFN $PINS Q=bank_mem_0[11][22] D=FE_DBTN107_n45
+ CK=CTS_716
Xbank_mem_0_reg[11][21] QDFFN $PINS Q=bank_mem_0[11][21] D=FE_DBTN108_n44
+ CK=CTS_716
Xbank_mem_0_reg[11][20] QDFFN $PINS Q=bank_mem_0[11][20] D=FE_DBTN109_n43
+ CK=CTS_716
Xbank_mem_0_reg[11][19] QDFFN $PINS Q=bank_mem_0[11][19] D=FE_DBTN110_n42
+ CK=CTS_716
Xbank_mem_0_reg[11][18] QDFFN $PINS Q=bank_mem_0[11][18] D=FE_DBTN111_n41
+ CK=CTS_716
Xbank_mem_0_reg[11][17] QDFFN $PINS Q=bank_mem_0[11][17] D=FE_DBTN112_n40
+ CK=CTS_716
Xbank_mem_0_reg[11][16] QDFFN $PINS Q=bank_mem_0[11][16] D=FE_DBTN113_n39
+ CK=CTS_713
Xbank_mem_0_reg[11][15] QDFFN $PINS Q=bank_mem_0[11][15] D=FE_DBTN114_n38
+ CK=CTS_713
Xbank_mem_0_reg[11][14] QDFFN $PINS Q=bank_mem_0[11][14] D=FE_DBTN115_n37
+ CK=CTS_713
Xbank_mem_0_reg[11][13] QDFFN $PINS Q=bank_mem_0[11][13] D=FE_DBTN116_n36
+ CK=CTS_713
Xbank_mem_0_reg[11][12] QDFFN $PINS Q=bank_mem_0[11][12] D=FE_DBTN143_n9
+ CK=CTS_713
Xbank_mem_0_reg[11][11] QDFFN $PINS Q=bank_mem_0[11][11] D=FE_DBTN144_n8
+ CK=CTS_713
Xbank_mem_0_reg[11][10] QDFFN $PINS Q=bank_mem_0[11][10] D=FE_DBTN145_n7
+ CK=CTS_713
Xbank_mem_0_reg[11][9] QDFFN $PINS Q=bank_mem_0[11][9] D=FE_DBTN90_n62
+ CK=CTS_713
Xbank_mem_0_reg[11][8] QDFFN $PINS Q=bank_mem_0[11][8] D=FE_DBTN91_n61
+ CK=CTS_713
Xbank_mem_0_reg[11][7] QDFFN $PINS Q=bank_mem_0[11][7] D=FE_DBTN92_n60
+ CK=CTS_713
Xbank_mem_0_reg[11][6] QDFFN $PINS Q=bank_mem_0[11][6] D=FE_DBTN93_n59
+ CK=CTS_713
Xbank_mem_0_reg[11][5] QDFFN $PINS Q=bank_mem_0[11][5] D=FE_DBTN94_n58
+ CK=CTS_713
Xbank_mem_0_reg[11][4] QDFFN $PINS Q=bank_mem_0[11][4] D=FE_DBTN95_n57
+ CK=CTS_713
Xbank_mem_0_reg[11][3] QDFFN $PINS Q=bank_mem_0[11][3] D=FE_DBTN117_n35
+ CK=CTS_713
Xbank_mem_0_reg[11][2] QDFFN $PINS Q=bank_mem_0[11][2] D=FE_DBTN118_n34
+ CK=CTS_713
Xbank_mem_0_reg[11][1] QDFFN $PINS Q=bank_mem_0[11][1] D=FE_DBTN119_n33
+ CK=CTS_713
Xbank_mem_0_reg[11][0] QDFFN $PINS Q=bank_mem_0[11][0] D=FE_DBTN146_n6
+ CK=CTS_713
Xbank_mem_1_reg[8][33] QDFFN $PINS Q=bank_mem_1[8][33] D=FE_DBTN120_n32
+ CK=CTS_607
Xbank_mem_1_reg[10][33] QDFFN $PINS Q=bank_mem_1[10][33] D=FE_DBTN120_n32
+ CK=CTS_601
Xbank_mem_0_reg[8][32] QDFFN $PINS Q=bank_mem_0[8][32] D=FE_DBTN97_n55
+ CK=CTS_734
Xbank_mem_0_reg[8][31] QDFFN $PINS Q=bank_mem_0[8][31] D=FE_DBTN98_n54
+ CK=CTS_734
Xbank_mem_0_reg[8][30] QDFFN $PINS Q=bank_mem_0[8][30] D=FE_DBTN99_n53
+ CK=CTS_734
Xbank_mem_0_reg[8][29] QDFFN $PINS Q=bank_mem_0[8][29] D=FE_DBTN100_n52
+ CK=CTS_734
Xbank_mem_0_reg[8][28] QDFFN $PINS Q=bank_mem_0[8][28] D=FE_DBTN101_n51
+ CK=CTS_734
Xbank_mem_0_reg[8][27] QDFFN $PINS Q=bank_mem_0[8][27] D=FE_DBTN102_n50
+ CK=CTS_734
Xbank_mem_0_reg[8][26] QDFFN $PINS Q=bank_mem_0[8][26] D=FE_DBTN103_n49
+ CK=CTS_734
Xbank_mem_0_reg[8][25] QDFFN $PINS Q=bank_mem_0[8][25] D=FE_DBTN104_n48
+ CK=CTS_734
Xbank_mem_0_reg[8][24] QDFFN $PINS Q=bank_mem_0[8][24] D=FE_DBTN105_n47
+ CK=CTS_734
Xbank_mem_0_reg[8][23] QDFFN $PINS Q=bank_mem_0[8][23] D=FE_DBTN106_n46
+ CK=CTS_734
Xbank_mem_0_reg[8][22] QDFFN $PINS Q=bank_mem_0[8][22] D=FE_DBTN107_n45
+ CK=CTS_734
Xbank_mem_0_reg[8][21] QDFFN $PINS Q=bank_mem_0[8][21] D=FE_DBTN108_n44
+ CK=CTS_734
Xbank_mem_0_reg[8][20] QDFFN $PINS Q=bank_mem_0[8][20] D=FE_DBTN109_n43
+ CK=CTS_734
Xbank_mem_0_reg[8][19] QDFFN $PINS Q=bank_mem_0[8][19] D=FE_DBTN110_n42
+ CK=CTS_734
Xbank_mem_0_reg[8][18] QDFFN $PINS Q=bank_mem_0[8][18] D=FE_DBTN111_n41
+ CK=CTS_734
Xbank_mem_0_reg[8][17] QDFFN $PINS Q=bank_mem_0[8][17] D=FE_DBTN112_n40
+ CK=CTS_734
Xbank_mem_0_reg[8][16] QDFFN $PINS Q=bank_mem_0[8][16] D=FE_DBTN113_n39
+ CK=CTS_731
Xbank_mem_0_reg[8][15] QDFFN $PINS Q=bank_mem_0[8][15] D=FE_DBTN114_n38
+ CK=CTS_731
Xbank_mem_0_reg[8][14] QDFFN $PINS Q=bank_mem_0[8][14] D=FE_DBTN115_n37
+ CK=CTS_731
Xbank_mem_0_reg[8][13] QDFFN $PINS Q=bank_mem_0[8][13] D=FE_DBTN116_n36
+ CK=CTS_731
Xbank_mem_0_reg[8][12] QDFFN $PINS Q=bank_mem_0[8][12] D=FE_DBTN143_n9
+ CK=CTS_731
Xbank_mem_0_reg[8][11] QDFFN $PINS Q=bank_mem_0[8][11] D=FE_DBTN144_n8
+ CK=CTS_731
Xbank_mem_0_reg[8][10] QDFFN $PINS Q=bank_mem_0[8][10] D=FE_DBTN145_n7
+ CK=CTS_731
Xbank_mem_0_reg[8][9] QDFFN $PINS Q=bank_mem_0[8][9] D=FE_DBTN90_n62 CK=CTS_731
Xbank_mem_0_reg[8][8] QDFFN $PINS Q=bank_mem_0[8][8] D=FE_DBTN91_n61 CK=CTS_731
Xbank_mem_0_reg[8][7] QDFFN $PINS Q=bank_mem_0[8][7] D=FE_DBTN92_n60 CK=CTS_731
Xbank_mem_0_reg[8][6] QDFFN $PINS Q=bank_mem_0[8][6] D=FE_DBTN93_n59 CK=CTS_731
Xbank_mem_0_reg[8][5] QDFFN $PINS Q=bank_mem_0[8][5] D=FE_DBTN94_n58 CK=CTS_731
Xbank_mem_0_reg[8][4] QDFFN $PINS Q=bank_mem_0[8][4] D=FE_DBTN95_n57 CK=CTS_731
Xbank_mem_0_reg[8][3] QDFFN $PINS Q=bank_mem_0[8][3] D=FE_DBTN117_n35
+ CK=CTS_731
Xbank_mem_0_reg[8][2] QDFFN $PINS Q=bank_mem_0[8][2] D=FE_DBTN118_n34
+ CK=CTS_731
Xbank_mem_0_reg[8][1] QDFFN $PINS Q=bank_mem_0[8][1] D=FE_DBTN119_n33
+ CK=CTS_731
Xbank_mem_0_reg[8][0] QDFFN $PINS Q=bank_mem_0[8][0] D=FE_DBTN146_n6 CK=CTS_731
Xbank_mem_0_reg[9][33] QDFFN $PINS Q=bank_mem_0[9][33] D=FE_DBTN96_n56
+ CK=CTS_728
Xbank_mem_0_reg[10][32] QDFFN $PINS Q=bank_mem_0[10][32] D=FE_DBTN97_n55
+ CK=CTS_722
Xbank_mem_0_reg[10][31] QDFFN $PINS Q=bank_mem_0[10][31] D=FE_DBTN98_n54
+ CK=CTS_722
Xbank_mem_0_reg[10][30] QDFFN $PINS Q=bank_mem_0[10][30] D=FE_DBTN99_n53
+ CK=CTS_722
Xbank_mem_0_reg[10][29] QDFFN $PINS Q=bank_mem_0[10][29] D=FE_DBTN100_n52
+ CK=CTS_722
Xbank_mem_0_reg[10][28] QDFFN $PINS Q=bank_mem_0[10][28] D=FE_DBTN101_n51
+ CK=CTS_722
Xbank_mem_0_reg[10][27] QDFFN $PINS Q=bank_mem_0[10][27] D=FE_DBTN102_n50
+ CK=CTS_722
Xbank_mem_0_reg[10][26] QDFFN $PINS Q=bank_mem_0[10][26] D=FE_DBTN103_n49
+ CK=CTS_722
Xbank_mem_0_reg[10][25] QDFFN $PINS Q=bank_mem_0[10][25] D=FE_DBTN104_n48
+ CK=CTS_722
Xbank_mem_0_reg[10][24] QDFFN $PINS Q=bank_mem_0[10][24] D=FE_DBTN105_n47
+ CK=CTS_722
Xbank_mem_0_reg[10][23] QDFFN $PINS Q=bank_mem_0[10][23] D=FE_DBTN106_n46
+ CK=CTS_722
Xbank_mem_0_reg[10][22] QDFFN $PINS Q=bank_mem_0[10][22] D=FE_DBTN107_n45
+ CK=CTS_722
Xbank_mem_0_reg[10][21] QDFFN $PINS Q=bank_mem_0[10][21] D=FE_DBTN108_n44
+ CK=CTS_722
Xbank_mem_0_reg[10][20] QDFFN $PINS Q=bank_mem_0[10][20] D=FE_DBTN109_n43
+ CK=CTS_722
Xbank_mem_0_reg[10][19] QDFFN $PINS Q=bank_mem_0[10][19] D=FE_DBTN110_n42
+ CK=CTS_722
Xbank_mem_0_reg[10][18] QDFFN $PINS Q=bank_mem_0[10][18] D=FE_DBTN111_n41
+ CK=CTS_722
Xbank_mem_0_reg[10][17] QDFFN $PINS Q=bank_mem_0[10][17] D=FE_DBTN112_n40
+ CK=CTS_722
Xbank_mem_0_reg[10][16] QDFFN $PINS Q=bank_mem_0[10][16] D=FE_DBTN113_n39
+ CK=CTS_719
Xbank_mem_0_reg[10][15] QDFFN $PINS Q=bank_mem_0[10][15] D=FE_DBTN114_n38
+ CK=CTS_719
Xbank_mem_0_reg[10][14] QDFFN $PINS Q=bank_mem_0[10][14] D=FE_DBTN115_n37
+ CK=CTS_719
Xbank_mem_0_reg[10][13] QDFFN $PINS Q=bank_mem_0[10][13] D=FE_DBTN116_n36
+ CK=CTS_719
Xbank_mem_0_reg[10][12] QDFFN $PINS Q=bank_mem_0[10][12] D=FE_DBTN143_n9
+ CK=CTS_719
Xbank_mem_0_reg[10][11] QDFFN $PINS Q=bank_mem_0[10][11] D=FE_DBTN144_n8
+ CK=CTS_719
Xbank_mem_0_reg[10][10] QDFFN $PINS Q=bank_mem_0[10][10] D=FE_DBTN145_n7
+ CK=CTS_719
Xbank_mem_0_reg[10][9] QDFFN $PINS Q=bank_mem_0[10][9] D=FE_DBTN90_n62
+ CK=CTS_719
Xbank_mem_0_reg[10][8] QDFFN $PINS Q=bank_mem_0[10][8] D=FE_DBTN91_n61
+ CK=CTS_719
Xbank_mem_0_reg[10][7] QDFFN $PINS Q=bank_mem_0[10][7] D=FE_DBTN92_n60
+ CK=CTS_719
Xbank_mem_0_reg[10][6] QDFFN $PINS Q=bank_mem_0[10][6] D=FE_DBTN93_n59
+ CK=CTS_719
Xbank_mem_0_reg[10][5] QDFFN $PINS Q=bank_mem_0[10][5] D=FE_DBTN94_n58
+ CK=CTS_719
Xbank_mem_0_reg[10][4] QDFFN $PINS Q=bank_mem_0[10][4] D=FE_DBTN95_n57
+ CK=CTS_719
Xbank_mem_0_reg[10][3] QDFFN $PINS Q=bank_mem_0[10][3] D=FE_DBTN117_n35
+ CK=CTS_719
Xbank_mem_0_reg[10][2] QDFFN $PINS Q=bank_mem_0[10][2] D=FE_DBTN118_n34
+ CK=CTS_719
Xbank_mem_0_reg[10][1] QDFFN $PINS Q=bank_mem_0[10][1] D=FE_DBTN119_n33
+ CK=CTS_719
Xbank_mem_0_reg[10][0] QDFFN $PINS Q=bank_mem_0[10][0] D=FE_DBTN146_n6
+ CK=CTS_719
Xbank_mem_0_reg[11][33] QDFFN $PINS Q=bank_mem_0[11][33] D=FE_DBTN96_n56
+ CK=CTS_716
Xbank_mem_0_reg[8][33] QDFFN $PINS Q=bank_mem_0[8][33] D=FE_DBTN96_n56
+ CK=CTS_734
Xbank_mem_0_reg[10][33] QDFFN $PINS Q=bank_mem_0[10][33] D=FE_DBTN96_n56
+ CK=CTS_722
Xread_data_1_reg[33] QDFFRBN $PINS Q=read_data_1[33] D=N103 CK=clk_clone2
+ RB=FE_OFN71_FE_DBTN17_n206
Xread_data_1_reg[16] QDFFRBN $PINS Q=read_data_1[16] D=N120 CK=clk RB=rst_n
Xread_data_1_reg[32] QDFFRBN $PINS Q=read_data_1[32] D=FE_PHN1366_N104
+ CK=clk_clone2 RB=FE_OFN71_FE_DBTN17_n206
Xread_data_1_reg[15] QDFFRBN $PINS Q=read_data_1[15] D=N121 CK=clk RB=rst_n
Xread_data_1_reg[31] QDFFRBN $PINS Q=read_data_1[31] D=N105 CK=clk_clone2
+ RB=FE_OFN71_FE_DBTN17_n206
Xread_data_1_reg[14] QDFFRBN $PINS Q=read_data_1[14] D=N122 CK=clk RB=rst_n
Xread_data_1_reg[30] QDFFRBN $PINS Q=read_data_1[30] D=N106 CK=clk_clone2
+ RB=FE_OFN75_FE_DBTN17_n206
Xread_data_1_reg[13] QDFFRBN $PINS Q=read_data_1[13] D=FE_PHN1358_N123 CK=clk
+ RB=rst_n
Xread_data_1_reg[29] QDFFRBN $PINS Q=read_data_1[29] D=N107 CK=clk_clone2
+ RB=FE_OFN71_FE_DBTN17_n206
Xread_data_1_reg[12] QDFFRBN $PINS Q=read_data_1[12] D=FE_PHN1352_N124 CK=clk
+ RB=rst_n
Xread_data_1_reg[28] QDFFRBN $PINS Q=read_data_1[28] D=FE_PHN1360_N108
+ CK=clk_clone2 RB=FE_OFN71_FE_DBTN17_n206
Xread_data_1_reg[11] QDFFRBN $PINS Q=read_data_1[11] D=FE_PHN1337_N125 CK=clk
+ RB=rst_n
Xread_data_1_reg[27] QDFFRBN $PINS Q=read_data_1[27] D=FE_PHN1361_N109
+ CK=clk_clone2 RB=FE_OFN71_FE_DBTN17_n206
Xread_data_1_reg[10] QDFFRBN $PINS Q=read_data_1[10] D=FE_PHN1357_N126 CK=clk
+ RB=rst_n
Xread_data_1_reg[26] QDFFRBN $PINS Q=read_data_1[26] D=FE_PHN1354_N110
+ CK=clk_clone2 RB=FE_OFN71_FE_DBTN17_n206
Xread_data_1_reg[9] QDFFRBN $PINS Q=read_data_1[9] D=N127 CK=clk RB=rst_n
Xread_data_1_reg[25] QDFFRBN $PINS Q=read_data_1[25] D=N111 CK=clk_clone2
+ RB=FE_OFN71_FE_DBTN17_n206
Xread_data_1_reg[8] QDFFRBN $PINS Q=read_data_1[8] D=N128 CK=clk RB=rst_n
Xread_data_1_reg[24] QDFFRBN $PINS Q=read_data_1[24] D=FE_PHN1356_N112
+ CK=clk_clone2 RB=FE_OFN71_FE_DBTN17_n206
Xread_data_1_reg[7] QDFFRBN $PINS Q=read_data_1[7] D=N129 CK=clk RB=rst_n
Xread_data_1_reg[6] QDFFRBN $PINS Q=read_data_1[6] D=N130 CK=clk RB=rst_n
Xread_data_1_reg[23] QDFFRBN $PINS Q=read_data_1[23] D=N113 CK=clk_clone1
+ RB=FE_OFN69_FE_DBTN17_n206
Xread_data_1_reg[5] QDFFRBN $PINS Q=read_data_1[5] D=N131 CK=clk_clone1
+ RB=rst_n
Xread_data_1_reg[22] QDFFRBN $PINS Q=read_data_1[22] D=N114 CK=clk_clone1
+ RB=FE_OFN69_FE_DBTN17_n206
Xread_data_1_reg[4] QDFFRBN $PINS Q=read_data_1[4] D=N132 CK=clk RB=rst_n
Xread_data_1_reg[21] QDFFRBN $PINS Q=read_data_1[21] D=N115 CK=clk_clone1
+ RB=rst_n
Xread_data_1_reg[20] QDFFRBN $PINS Q=read_data_1[20] D=N116 CK=clk_clone1
+ RB=rst_n
Xread_data_1_reg[3] QDFFRBN $PINS Q=read_data_1[3] D=N133 CK=clk_clone1
+ RB=rst_n
Xread_data_1_reg[19] QDFFRBN $PINS Q=read_data_1[19] D=N117 CK=clk_clone1
+ RB=FE_OFN69_FE_DBTN17_n206
Xread_data_1_reg[1] QDFFRBN $PINS Q=read_data_1[1] D=N135 CK=clk_clone1
+ RB=FE_OFN69_FE_DBTN17_n206
Xread_data_1_reg[17] QDFFRBN $PINS Q=read_data_1[17] D=N119 CK=clk_clone1
+ RB=FE_OFN69_FE_DBTN17_n206
Xread_data_1_reg[0] QDFFRBN $PINS Q=read_data_1[0] D=N136 CK=clk_clone1
+ RB=FE_OFN69_FE_DBTN17_n206
Xread_data_1_reg[2] QDFFRBN $PINS Q=read_data_1[2] D=N134 CK=clk_clone1
+ RB=rst_n
Xread_data_1_reg[18] QDFFRBN $PINS Q=read_data_1[18] D=N118 CK=clk_clone1
+ RB=rst_n
XU3 MXL2HS $PINS OB=N136 S=n1188 A=FE_PHN1096_n260 B=n727
XU4 MXL2HS $PINS OB=N110 S=n1188 A=n546 B=n1013
XU5 MXL2HS $PINS OB=N126 S=n1188 A=n370 B=n837
XU6 MXL2HS $PINS OB=N125 S=FE_OFN78_n122 A=n848 B=n381
XU7 MXL2HS $PINS OB=N124 S=FE_OFN78_n122 A=n859 B=n392
XU8 XNR3 $PINS O=n117 I1=p_1 I2=n120 I3=p2
XU9 OAI22S $PINS O=FE_PHN1338_N106 A1=FE_OFN78_n122 A2=n1057 B1=n590 B2=n1188
XU10 OAI22S $PINS O=N103 A1=FE_OFN78_n122 A2=n1106 B1=FE_PHN1064_n639 B2=n1188
XU11 OA22 $PINS O=n1 A1=FE_OFN94_n242 A2=n1230 B1=FE_OFN97_n86 B2=n1264
XU15 OA22 $PINS O=n2 A1=FE_OFN94_n242 A2=n1249 B1=FE_OFN97_n86 B2=n1283
XU16 OA22 $PINS O=n3 A1=FE_OFN94_n242 A2=n1237 B1=FE_OFN97_n86 B2=n1271
XU17 OA22 $PINS O=n4 A1=FE_OFN94_n242 A2=n1247 B1=FE_OFN97_n86 B2=n1281
XU18 OA22 $PINS O=n5 A1=FE_OFN94_n242 A2=n1248 B1=FE_OFN97_n86 B2=n1282
XU19 OA22 $PINS O=n6 A1=n1237 A2=FE_OFN93_n87 B1=n1271 B2=FE_OFN98_n88
XU20 OA22 $PINS O=n7 A1=n1247 A2=FE_OFN93_n87 B1=n1281 B2=FE_OFN98_n88
XU21 OA22 $PINS O=n8 A1=n1248 A2=FE_OFN93_n87 B1=n1282 B2=FE_OFN98_n88
XU22 OA22 $PINS O=n9 A1=n1249 A2=FE_OFN93_n87 B1=n1283 B2=FE_OFN98_n88
XU23 OA22 $PINS O=n10 A1=FE_OFN94_n242 A2=n1239 B1=FE_OFN97_n86 B2=n1273
XU24 OA22 $PINS O=n11 A1=FE_OFN94_n242 A2=n1229 B1=FE_OFN97_n86 B2=n1263
XU25 OA22 $PINS O=n12 A1=FE_OFN94_n242 A2=n1231 B1=FE_OFN97_n86 B2=n1265
XU26 OA22 $PINS O=n13 A1=FE_OFN94_n242 A2=n1232 B1=FE_OFN97_n86 B2=n1266
XU27 OA22 $PINS O=n14 A1=FE_OFN94_n242 A2=n1233 B1=FE_OFN97_n86 B2=n1267
XU28 OA22 $PINS O=n15 A1=FE_OFN94_n242 A2=n1234 B1=FE_OFN97_n86 B2=n1268
XU29 OA22 $PINS O=n16 A1=FE_OFN94_n242 A2=n1235 B1=FE_OFN97_n86 B2=n1269
XU30 OA22 $PINS O=n17 A1=FE_OFN94_n242 A2=n1238 B1=FE_OFN97_n86 B2=n1272
XU31 OA22 $PINS O=n18 A1=FE_OFN94_n242 A2=n1250 B1=FE_OFN97_n86 B2=n1284
XU32 OA22 $PINS O=n19 A1=FE_OFN94_n242 A2=n1251 B1=FE_OFN97_n86 B2=n1285
XU33 OA22 $PINS O=n20 A1=FE_OFN94_n242 A2=n1252 B1=FE_OFN97_n86 B2=n1286
XU34 OA22 $PINS O=n21 A1=FE_OFN94_n242 A2=n1253 B1=FE_OFN97_n86 B2=n1287
XU35 OA22 $PINS O=n22 A1=FE_OFN94_n242 A2=n1220 B1=n86 B2=n1254
XU36 OA22 $PINS O=n23 A1=n242 A2=n1221 B1=n86 B2=n1255
XU37 OA22 $PINS O=n24 A1=n242 A2=n1222 B1=n86 B2=n1256
XU38 OA22 $PINS O=n25 A1=n242 A2=n1223 B1=n86 B2=n1257
XU39 OA22 $PINS O=n26 A1=n242 A2=n1224 B1=n86 B2=n1258
XU40 OA22 $PINS O=n27 A1=FE_OFN94_n242 A2=n1225 B1=n86 B2=n1259
XU41 OA22 $PINS O=n28 A1=FE_OFN94_n242 A2=n1226 B1=n86 B2=n1260
XU42 OA22 $PINS O=n29 A1=FE_OFN94_n242 A2=n1227 B1=n86 B2=n1261
XU43 OA22 $PINS O=n30 A1=FE_OFN94_n242 A2=n1228 B1=FE_OFN97_n86 B2=n1262
XU44 OA22 $PINS O=n31 A1=FE_OFN94_n242 A2=n1240 B1=FE_OFN97_n86 B2=n1274
XU45 OA22 $PINS O=n32 A1=FE_OFN94_n242 A2=n1236 B1=FE_OFN97_n86 B2=n1270
XU46 OA22 $PINS O=n33 A1=n1238 A2=FE_OFN93_n87 B1=n1272 B2=FE_OFN98_n88
XU47 OA22 $PINS O=n34 A1=n1239 A2=FE_OFN93_n87 B1=n1273 B2=FE_OFN98_n88
XU48 OA22 $PINS O=n35 A1=n1240 A2=FE_OFN93_n87 B1=n1274 B2=FE_OFN98_n88
XU49 OA22 $PINS O=n36 A1=n1250 A2=FE_OFN93_n87 B1=n1284 B2=FE_OFN98_n88
XU50 OA22 $PINS O=n37 A1=n1251 A2=FE_OFN93_n87 B1=n1285 B2=FE_OFN98_n88
XU51 OA22 $PINS O=n38 A1=n1252 A2=FE_OFN93_n87 B1=n1286 B2=FE_OFN98_n88
XU52 OA22 $PINS O=n39 A1=n1253 A2=FE_OFN93_n87 B1=n1287 B2=FE_OFN98_n88
XU53 OA22 $PINS O=n40 A1=n1220 A2=n87 B1=n1254 B2=n88
XU54 OA22 $PINS O=n41 A1=n1221 A2=n87 B1=n1255 B2=n88
XU55 OA22 $PINS O=n42 A1=n1222 A2=n87 B1=n1256 B2=n88
XU56 OA22 $PINS O=n43 A1=n1223 A2=n87 B1=n1257 B2=FE_OFN98_n88
XU57 OA22 $PINS O=n44 A1=n1224 A2=FE_OFN93_n87 B1=n1258 B2=FE_OFN98_n88
XU58 OA22 $PINS O=n45 A1=n1225 A2=FE_OFN93_n87 B1=n1259 B2=FE_OFN98_n88
XU59 OA22 $PINS O=n46 A1=n1226 A2=FE_OFN93_n87 B1=n1260 B2=n88
XU60 OA22 $PINS O=n47 A1=n1227 A2=FE_OFN93_n87 B1=n1261 B2=FE_OFN98_n88
XU61 OA22 $PINS O=n48 A1=n1228 A2=FE_OFN93_n87 B1=n1262 B2=FE_OFN98_n88
XU62 OA22 $PINS O=n49 A1=n1229 A2=FE_OFN93_n87 B1=n1263 B2=FE_OFN98_n88
XU63 OA22 $PINS O=n50 A1=n1230 A2=FE_OFN93_n87 B1=n1264 B2=FE_OFN98_n88
XU64 OA22 $PINS O=n51 A1=n1231 A2=FE_OFN93_n87 B1=n1265 B2=FE_OFN98_n88
XU65 OA22 $PINS O=n52 A1=n1232 A2=FE_OFN93_n87 B1=n1266 B2=FE_OFN98_n88
XU66 OA22 $PINS O=n53 A1=n1233 A2=FE_OFN93_n87 B1=n1267 B2=FE_OFN98_n88
XU67 OA22 $PINS O=n54 A1=n1234 A2=FE_OFN93_n87 B1=n1268 B2=FE_OFN98_n88
XU68 OA22 $PINS O=n55 A1=n1235 A2=FE_OFN93_n87 B1=n1269 B2=FE_OFN98_n88
XU69 OA22 $PINS O=n56 A1=n1236 A2=FE_OFN93_n87 B1=n1270 B2=FE_OFN98_n88
XU70 OA22 $PINS O=n57 A1=n1241 A2=FE_OFN93_n87 B1=n1275 B2=FE_OFN98_n88
XU71 OA22 $PINS O=n58 A1=n1242 A2=FE_OFN93_n87 B1=n1276 B2=FE_OFN98_n88
XU72 OA22 $PINS O=n59 A1=n1243 A2=FE_OFN93_n87 B1=n1277 B2=FE_OFN98_n88
XU73 OA22 $PINS O=n60 A1=n1244 A2=FE_OFN93_n87 B1=n1278 B2=FE_OFN98_n88
XU74 OA22 $PINS O=n61 A1=n1245 A2=FE_OFN93_n87 B1=n1279 B2=FE_OFN98_n88
XU75 OA22 $PINS O=n62 A1=n1246 A2=FE_OFN93_n87 B1=n1280 B2=FE_OFN98_n88
XU76 OA22 $PINS O=n63 A1=FE_OFN94_n242 A2=n1246 B1=FE_OFN97_n86 B2=n1280
XU77 OA22 $PINS O=n64 A1=FE_OFN94_n242 A2=n1241 B1=FE_OFN97_n86 B2=n1275
XU78 OA22 $PINS O=n65 A1=FE_OFN94_n242 A2=n1242 B1=FE_OFN97_n86 B2=n1276
XU79 OA22 $PINS O=n66 A1=FE_OFN94_n242 A2=n1243 B1=FE_OFN97_n86 B2=n1277
XU80 OA22 $PINS O=n67 A1=FE_OFN94_n242 A2=n1244 B1=FE_OFN97_n86 B2=n1278
XU81 OA22 $PINS O=n68 A1=FE_OFN94_n242 A2=n1245 B1=FE_OFN97_n86 B2=n1279
XU266 ND2S $PINS O=n103 I1=n1215 I2=n1214
XU267 ND2S $PINS O=n105 I1=n1215 I2=n115
XU268 ND2S $PINS O=n107 I1=n115 I2=n116
XU273 ND2S $PINS O=n242 I1=wen2 I2=n117
XU274 XNR2HS $PINS O=n112 I1=p_1 I2=n243
XU275 XNR2HS $PINS O=n243 I1=n120 I2=write_addr_1[2]
XU288 INV1S $PINS O=n1216 I=n109
XU289 NR2 $PINS O=N58 I1=n103 I2=n114
XU290 NR2 $PINS O=N59 I1=n103 I2=n113
XU291 NR2 $PINS O=N54 I1=n106 I2=n114
XU292 NR2 $PINS O=N55 I1=n106 I2=n113
XU293 NR2 $PINS O=N56 I1=n105 I2=n114
XU294 NR2 $PINS O=N57 I1=n105 I2=n113
XU295 NR2 $PINS O=N91 I1=n90 I2=n98
XU296 NR2 $PINS O=N92 I1=n90 I2=n97
XU297 NR2 $PINS O=N53 I1=n107 I2=n113
XU298 INV1S $PINS O=n1219 I=n96
XU299 NR2 $PINS O=N87 I1=n93 I2=n98
XU300 NR2 $PINS O=N88 I1=n93 I2=n97
XU301 NR2 $PINS O=N89 I1=n92 I2=n98
XU302 NR2 $PINS O=N90 I1=n92 I2=n97
XU303 NR2 $PINS O=N52 I1=n107 I2=n114
XU304 NR2 $PINS O=N86 I1=n94 I2=n97
XU305 NR2 $PINS O=N85 I1=n94 I2=n98
XU353 OAI22S $PINS O=n109 A1=p_1 A2=FE_OFN93_n87 B1=p_1 B2=FE_OFN98_n88
XU354 NR2 $PINS O=N61 I1=n102 I2=n107
XU355 NR2 $PINS O=N65 I1=n102 I2=n105
XU356 NR2 $PINS O=N63 I1=n102 I2=n106
XU357 NR2 $PINS O=N67 I1=n102 I2=n103
XU358 NR2 $PINS O=N66 I1=n103 I2=n104
XU359 INV1S $PINS O=n1214 I=n115
XU360 INV1S $PINS O=n1215 I=n116
XU361 NR2 $PINS O=N60 I1=n104 I2=n107
XU362 NR2 $PINS O=N64 I1=n104 I2=n105
XU363 NR2 $PINS O=N62 I1=n104 I2=n106
XU364 NR2 $PINS O=N100 I1=n90 I2=n91
XU365 INV1S $PINS O=n1218 I=n99
XU366 INV1S $PINS O=n1217 I=n100
XU367 OAI22S $PINS O=n96 A1=p_1 A2=FE_OFN94_n242 B1=p_1 B2=FE_OFN97_n86
XU368 NR2 $PINS O=N94 I1=n91 I2=n94
XU369 NR2 $PINS O=N98 I1=n91 I2=n92
XU370 NR2 $PINS O=N96 I1=n91 I2=n93
XU371 NR2 $PINS O=N93 I1=n89 I2=n94
XU372 NR2 $PINS O=N97 I1=n89 I2=n92
XU373 NR2 $PINS O=N95 I1=n89 I2=n93
XU374 NR2 $PINS O=N99 I1=n89 I2=n90
XU446 OAI22S $PINS O=n115 A1=p2 A2=FE_OFN93_n87 B1=p2 B2=FE_OFN98_n88
XU447 OAI22S $PINS O=n116 A1=p1 A2=FE_OFN93_n87 B1=p1 B2=FE_OFN98_n88
XU448 OAI22S $PINS O=n111 A1=n1291 A2=FE_OFN93_n87 B1=n1291 B2=FE_OFN98_n88
XU449 OAI22S $PINS O=n99 A1=p2 A2=FE_OFN94_n242 B1=p2 B2=FE_OFN97_n86
XU451 OAI22S $PINS O=n100 A1=p1 A2=FE_OFN94_n242 B1=p1 B2=FE_OFN97_n86
XU452 OAI22S $PINS O=n101 A1=n1291 A2=FE_OFN94_n242 B1=n1291 B2=FE_OFN97_n86
XU453 INV1S $PINS O=n1288 I=n112
XU456 INV2 $PINS O=n1188 I=FE_OFN78_n122
XU457 XNR2HS $PINS O=n118 I1=read_addr_1[4] I2=read_addr_1[3]
XU481 ND3 $PINS O=n88 I1=wen1 I2=FE_OFN93_n87 I3=n112
XU483 AOI12HS $PINS O=n108 A1=n111 B1=FE_OFN93_n87 B2=n110
XU484 ND3 $PINS O=n86 I1=n1288 I2=FE_OFN94_n242 I3=wen1
XU485 AOI12HS $PINS O=n95 A1=n101 B1=FE_OFN94_n242 B2=n119
XU487 XOR2HS $PINS O=n120 I1=write_addr_1[4] I2=write_addr_1[3]
XU488 INV1S $PINS O=n1291 I=write_addr_1[4]
XU490 INV1S $PINS O=n1273 I=write_data_1[2]
XU491 INV1S $PINS O=n1275 I=write_data_1[4]
XU492 INV1S $PINS O=n1284 I=write_data_1[13]
XU493 INV1S $PINS O=n1285 I=write_data_1[14]
XU494 INV1S $PINS O=n1286 I=write_data_1[15]
XU495 INV1S $PINS O=n1287 I=write_data_1[16]
XU496 INV1S $PINS O=n1257 I=write_data_1[20]
XU497 INV1S $PINS O=n1258 I=write_data_1[21]
XU498 INV1S $PINS O=n1259 I=write_data_1[22]
XU499 INV1S $PINS O=n1260 I=write_data_1[23]
XU500 INV1S $PINS O=n1265 I=write_data_1[28]
XU501 INV1S $PINS O=n1266 I=write_data_1[29]
XU502 INV1S $PINS O=n1267 I=write_data_1[30]
XU503 INV1S $PINS O=n1278 I=write_data_1[7]
XU504 INV1S $PINS O=n1279 I=write_data_1[8]
XU505 INV1S $PINS O=n1280 I=write_data_1[9]
XU506 INV1S $PINS O=n1271 I=write_data_1[0]
XU507 INV1S $PINS O=n1272 I=write_data_1[1]
XU508 INV1S $PINS O=n1274 I=write_data_1[3]
XU509 INV1S $PINS O=n1276 I=write_data_1[5]
XU510 INV1S $PINS O=n1277 I=write_data_1[6]
XU511 INV1S $PINS O=n1281 I=write_data_1[10]
XU512 INV1S $PINS O=n1282 I=write_data_1[11]
XU513 INV1S $PINS O=n1283 I=write_data_1[12]
XU514 INV1S $PINS O=n1254 I=write_data_1[17]
XU515 INV1S $PINS O=n1255 I=write_data_1[18]
XU516 INV1S $PINS O=n1256 I=write_data_1[19]
XU517 INV1S $PINS O=n1261 I=write_data_1[24]
XU518 INV1S $PINS O=n1262 I=write_data_1[25]
XU519 INV1S $PINS O=n1263 I=write_data_1[26]
XU520 INV1S $PINS O=n1264 I=write_data_1[27]
XU521 INV1S $PINS O=n1268 I=write_data_1[31]
XU522 INV1S $PINS O=n1269 I=write_data_1[32]
XU523 INV1S $PINS O=n1270 I=write_data_1[33]
XU524 INV1S $PINS O=n1239 I=write_data_2[2]
XU525 INV1S $PINS O=n1241 I=write_data_2[4]
XU526 INV1S $PINS O=n1250 I=write_data_2[13]
XU527 INV1S $PINS O=n1251 I=write_data_2[14]
XU528 INV1S $PINS O=n1252 I=write_data_2[15]
XU529 INV1S $PINS O=n1253 I=write_data_2[16]
XU530 INV1S $PINS O=n1223 I=write_data_2[20]
XU531 INV1S $PINS O=n1224 I=write_data_2[21]
XU532 INV1S $PINS O=n1225 I=write_data_2[22]
XU533 INV1S $PINS O=n1226 I=write_data_2[23]
XU534 INV1S $PINS O=n1231 I=write_data_2[28]
XU535 INV1S $PINS O=n1232 I=write_data_2[29]
XU536 INV1S $PINS O=n1233 I=write_data_2[30]
XU537 INV1S $PINS O=n1237 I=write_data_2[0]
XU538 INV1S $PINS O=n1238 I=write_data_2[1]
XU539 INV1S $PINS O=n1240 I=write_data_2[3]
XU540 INV1S $PINS O=n1242 I=write_data_2[5]
XU541 INV1S $PINS O=n1243 I=write_data_2[6]
XU542 INV1S $PINS O=n1247 I=write_data_2[10]
XU543 INV1S $PINS O=n1248 I=write_data_2[11]
XU544 INV1S $PINS O=n1249 I=write_data_2[12]
XU545 INV1S $PINS O=n1220 I=write_data_2[17]
XU546 INV1S $PINS O=n1221 I=write_data_2[18]
XU547 INV1S $PINS O=n1222 I=write_data_2[19]
XU548 INV1S $PINS O=n1227 I=write_data_2[24]
XU549 INV1S $PINS O=n1228 I=write_data_2[25]
XU550 INV1S $PINS O=n1229 I=write_data_2[26]
XU551 INV1S $PINS O=n1230 I=write_data_2[27]
XU552 INV1S $PINS O=n1234 I=write_data_2[31]
XU553 INV1S $PINS O=n1235 I=write_data_2[32]
XU554 INV1S $PINS O=n1236 I=write_data_2[33]
XU555 INV1S $PINS O=n1244 I=write_data_2[7]
XU556 INV1S $PINS O=n1245 I=write_data_2[8]
XU557 INV1S $PINS O=n1246 I=write_data_2[9]
XU558 INV1S $PINS O=n1109 I=N33
XU559 INV1S $PINS O=n642 I=N29
XU560 INV1S $PINS O=n1108 I=N32
XU561 INV1S $PINS O=n641 I=N28
XU562 INV1S $PINS O=n1107 I=N31
XU563 INV1S $PINS O=n640 I=N27
XU568 NR2 $PINS O=n251 I1=n642 I2=N30
XU569 NR2 $PINS O=n250 I1=n641 I2=n640
XU570 AN2 $PINS O=n627 I1=n251 I2=n250
XU571 NR2 $PINS O=n254 I1=n641 I2=N27
XU572 AN2 $PINS O=n614 I1=n254 I2=N29
XU573 AN2 $PINS O=n613 I1=N29 I2=n250
XU574 AOI22S $PINS O=n248 A1=bank_mem_0[14][0] A2=n614 B1=bank_mem_0[15][0]
+ B2=n613
XU575 NR2 $PINS O=n253 I1=N27 I2=N28
XU576 AN2P $PINS O=n616 I1=n253 I2=N29
XU577 NR2 $PINS O=n252 I1=n640 I2=N28
XU578 AN2 $PINS O=n615 I1=n252 I2=N29
XU579 AOI22S $PINS O=n247 A1=bank_mem_0[12][0] A2=n616 B1=bank_mem_0[13][0]
+ B2=n615
XU580 AN2P $PINS O=n618 I1=n254 I2=n642
XU581 AN2 $PINS O=n617 I1=n250 I2=n642
XU582 AOI22S $PINS O=n245 A1=bank_mem_0[10][0] A2=n618 B1=bank_mem_0[11][0]
+ B2=n617
XU583 AN2P $PINS O=n620 I1=n253 I2=n642
XU584 AN2 $PINS O=n619 I1=n252 I2=n642
XU585 AOI22S $PINS O=n244 A1=bank_mem_0[8][0] A2=n620 B1=bank_mem_0[9][0]
+ B2=n619
XU586 AN2 $PINS O=n246 I1=n245 I2=n244
XU587 ND3 $PINS O=n249 I1=n248 I2=n247 I3=n246
XU588 AOI22S $PINS O=n259 A1=bank_mem_0[7][0] A2=n627 B1=n249 B2=N30
XU589 AN2P $PINS O=n629 I1=n251 I2=n252
XU590 AN2P $PINS O=n628 I1=n251 I2=n254
XU591 AOI22S $PINS O=n258 A1=bank_mem_0[5][0] A2=n629 B1=bank_mem_0[6][0]
+ B2=n628
XU592 NR2 $PINS O=n255 I1=N29 I2=N30
XU593 AN2P $PINS O=n631 I1=n255 I2=n250
XU594 AN2 $PINS O=n630 I1=n251 I2=n253
XU595 AOI22S $PINS O=n257 A1=bank_mem_0[3][0] A2=n631 B1=bank_mem_0[4][0]
+ B2=n630
XU596 AN2 $PINS O=n634 I1=n255 I2=n252
XU597 AN2 $PINS O=n633 I1=n255 I2=n253
XU598 AN2 $PINS O=n632 I1=n255 I2=n254
XU599 AO222 $PINS O=n256 A1=bank_mem_0[1][0] A2=n634 B1=bank_mem_0[0][0]
+ B2=n633 C1=bank_mem_0[2][0] C2=n632
XU600 AN4B1S $PINS O=n260 I1=n259 I2=n258 I3=n257 B1=n256
XU601 AOI22S $PINS O=n265 A1=bank_mem_0[14][1] A2=n614 B1=bank_mem_0[15][1]
+ B2=n613
XU602 AOI22S $PINS O=n264 A1=bank_mem_0[12][1] A2=n616 B1=bank_mem_0[13][1]
+ B2=n615
XU603 AOI22S $PINS O=n262 A1=bank_mem_0[10][1] A2=n618 B1=bank_mem_0[11][1]
+ B2=n617
XU604 AOI22S $PINS O=n261 A1=bank_mem_0[8][1] A2=n620 B1=bank_mem_0[9][1]
+ B2=n619
XU605 AN2 $PINS O=n263 I1=n262 I2=n261
XU606 ND3 $PINS O=n266 I1=n265 I2=n264 I3=n263
XU607 AOI22S $PINS O=n270 A1=bank_mem_0[7][1] A2=n627 B1=n266 B2=N30
XU608 AOI22S $PINS O=n269 A1=bank_mem_0[5][1] A2=n629 B1=bank_mem_0[6][1]
+ B2=n628
XU609 AOI22S $PINS O=n268 A1=bank_mem_0[3][1] A2=n631 B1=bank_mem_0[4][1]
+ B2=n630
XU610 AO222 $PINS O=n267 A1=bank_mem_0[1][1] A2=n634 B1=bank_mem_0[0][1]
+ B2=n633 C1=bank_mem_0[2][1] C2=n632
XU611 AN4B1S $PINS O=n271 I1=n270 I2=n269 I3=n268 B1=n267
XU612 INV1S $PINS O=bank_rdata[0][1] I=n271
XU613 AOI22S $PINS O=n276 A1=bank_mem_0[14][2] A2=n614 B1=bank_mem_0[15][2]
+ B2=n613
XU614 AOI22S $PINS O=n275 A1=bank_mem_0[12][2] A2=n616 B1=bank_mem_0[13][2]
+ B2=n615
XU615 AOI22S $PINS O=n273 A1=bank_mem_0[10][2] A2=n618 B1=bank_mem_0[11][2]
+ B2=n617
XU616 AOI22S $PINS O=n272 A1=bank_mem_0[8][2] A2=n620 B1=bank_mem_0[9][2]
+ B2=n619
XU617 AN2 $PINS O=n274 I1=n273 I2=n272
XU618 ND3 $PINS O=n277 I1=n276 I2=n275 I3=n274
XU619 AOI22S $PINS O=n281 A1=bank_mem_0[7][2] A2=n627 B1=n277 B2=N30
XU620 AOI22S $PINS O=n280 A1=bank_mem_0[5][2] A2=n629 B1=bank_mem_0[6][2]
+ B2=n628
XU621 AOI22S $PINS O=n279 A1=bank_mem_0[3][2] A2=n631 B1=bank_mem_0[4][2]
+ B2=n630
XU622 AO222 $PINS O=n278 A1=bank_mem_0[1][2] A2=n634 B1=bank_mem_0[0][2]
+ B2=n633 C1=bank_mem_0[2][2] C2=n632
XU623 AN4B1S $PINS O=FE_PHN1133_n282 I1=n281 I2=n280 I3=n279 B1=n278
XU624 INV1S $PINS O=bank_rdata[0][2] I=n282
XU625 AOI22S $PINS O=n287 A1=bank_mem_0[14][3] A2=n614 B1=bank_mem_0[15][3]
+ B2=n613
XU626 AOI22S $PINS O=n286 A1=bank_mem_0[12][3] A2=n616 B1=bank_mem_0[13][3]
+ B2=n615
XU627 AOI22S $PINS O=n284 A1=bank_mem_0[10][3] A2=n618 B1=bank_mem_0[11][3]
+ B2=n617
XU628 AOI22S $PINS O=n283 A1=bank_mem_0[8][3] A2=n620 B1=bank_mem_0[9][3]
+ B2=n619
XU629 AN2 $PINS O=n285 I1=n284 I2=n283
XU630 ND3 $PINS O=n288 I1=n287 I2=n286 I3=n285
XU631 AOI22S $PINS O=n292 A1=bank_mem_0[7][3] A2=n627 B1=n288 B2=N30
XU632 AOI22S $PINS O=n291 A1=bank_mem_0[5][3] A2=n629 B1=bank_mem_0[6][3]
+ B2=n628
XU633 AOI22S $PINS O=n290 A1=bank_mem_0[3][3] A2=n631 B1=bank_mem_0[4][3]
+ B2=n630
XU634 AO222 $PINS O=n289 A1=bank_mem_0[1][3] A2=n634 B1=bank_mem_0[0][3]
+ B2=n633 C1=bank_mem_0[2][3] C2=n632
XU635 AN4B1S $PINS O=n293 I1=n292 I2=n291 I3=n290 B1=n289
XU636 INV1S $PINS O=bank_rdata[0][3] I=n293
XU637 AOI22S $PINS O=n298 A1=bank_mem_0[14][4] A2=n614 B1=bank_mem_0[15][4]
+ B2=n613
XU638 AOI22S $PINS O=n297 A1=bank_mem_0[12][4] A2=n616 B1=bank_mem_0[13][4]
+ B2=n615
XU639 AOI22S $PINS O=n295 A1=bank_mem_0[10][4] A2=n618 B1=bank_mem_0[11][4]
+ B2=n617
XU640 AOI22S $PINS O=n294 A1=bank_mem_0[8][4] A2=n620 B1=bank_mem_0[9][4]
+ B2=n619
XU641 AN2 $PINS O=n296 I1=n295 I2=n294
XU642 ND3 $PINS O=n299 I1=n298 I2=n297 I3=n296
XU643 AOI22S $PINS O=n303 A1=bank_mem_0[7][4] A2=n627 B1=n299 B2=N30
XU644 AOI22S $PINS O=n302 A1=bank_mem_0[5][4] A2=n629 B1=bank_mem_0[6][4]
+ B2=n628
XU645 AOI22S $PINS O=n301 A1=bank_mem_0[3][4] A2=n631 B1=bank_mem_0[4][4]
+ B2=n630
XU646 AO222 $PINS O=n300 A1=bank_mem_0[1][4] A2=n634 B1=bank_mem_0[0][4]
+ B2=n633 C1=bank_mem_0[2][4] C2=n632
XU647 AN4B1S $PINS O=n304 I1=n303 I2=n302 I3=n301 B1=n300
XU648 INV1S $PINS O=FE_PHN1084_bank_rdata_0_4 I=n304
XU649 AOI22S $PINS O=n309 A1=bank_mem_0[14][5] A2=n614 B1=bank_mem_0[15][5]
+ B2=n613
XU650 AOI22S $PINS O=n308 A1=bank_mem_0[12][5] A2=n616 B1=bank_mem_0[13][5]
+ B2=n615
XU651 AOI22S $PINS O=n306 A1=bank_mem_0[10][5] A2=n618 B1=bank_mem_0[11][5]
+ B2=n617
XU652 AOI22S $PINS O=n305 A1=bank_mem_0[8][5] A2=n620 B1=bank_mem_0[9][5]
+ B2=n619
XU653 AN2 $PINS O=n307 I1=n306 I2=n305
XU654 ND3 $PINS O=n310 I1=n309 I2=n308 I3=n307
XU655 AOI22S $PINS O=n314 A1=bank_mem_0[7][5] A2=n627 B1=n310 B2=N30
XU656 AOI22S $PINS O=n313 A1=bank_mem_0[5][5] A2=n629 B1=bank_mem_0[6][5]
+ B2=n628
XU657 AOI22S $PINS O=n312 A1=bank_mem_0[3][5] A2=n631 B1=bank_mem_0[4][5]
+ B2=n630
XU658 AO222 $PINS O=n311 A1=bank_mem_0[1][5] A2=n634 B1=bank_mem_0[0][5]
+ B2=n633 C1=bank_mem_0[2][5] C2=n632
XU659 AN4B1S $PINS O=n315 I1=n314 I2=n313 I3=n312 B1=n311
XU660 INV1S $PINS O=bank_rdata[0][5] I=n315
XU661 AOI22S $PINS O=n320 A1=bank_mem_0[14][6] A2=n614 B1=bank_mem_0[15][6]
+ B2=n613
XU662 AOI22S $PINS O=n319 A1=bank_mem_0[12][6] A2=n616 B1=bank_mem_0[13][6]
+ B2=n615
XU663 AOI22S $PINS O=n317 A1=bank_mem_0[10][6] A2=n618 B1=bank_mem_0[11][6]
+ B2=n617
XU664 AOI22S $PINS O=n316 A1=bank_mem_0[8][6] A2=n620 B1=bank_mem_0[9][6]
+ B2=n619
XU665 AN2 $PINS O=n318 I1=n317 I2=n316
XU666 ND3 $PINS O=n321 I1=n320 I2=n319 I3=n318
XU667 AOI22S $PINS O=n325 A1=bank_mem_0[7][6] A2=n627 B1=n321 B2=N30
XU668 AOI22S $PINS O=n324 A1=bank_mem_0[5][6] A2=n629 B1=bank_mem_0[6][6]
+ B2=n628
XU669 AOI22S $PINS O=n323 A1=bank_mem_0[3][6] A2=n631 B1=bank_mem_0[4][6]
+ B2=n630
XU670 AO222 $PINS O=n322 A1=bank_mem_0[1][6] A2=n634 B1=bank_mem_0[0][6]
+ B2=n633 C1=bank_mem_0[2][6] C2=n632
XU671 AN4B1S $PINS O=n326 I1=n325 I2=n324 I3=n323 B1=n322
XU672 INV1S $PINS O=bank_rdata[0][6] I=FE_PHN1104_n326
XU673 AOI22S $PINS O=n331 A1=bank_mem_0[14][7] A2=n614 B1=bank_mem_0[15][7]
+ B2=n613
XU674 AOI22S $PINS O=n330 A1=bank_mem_0[12][7] A2=n616 B1=bank_mem_0[13][7]
+ B2=n615
XU675 AOI22S $PINS O=n328 A1=bank_mem_0[10][7] A2=n618 B1=bank_mem_0[11][7]
+ B2=n617
XU676 AOI22S $PINS O=n327 A1=bank_mem_0[8][7] A2=n620 B1=bank_mem_0[9][7]
+ B2=n619
XU677 AN2 $PINS O=n329 I1=n328 I2=n327
XU678 ND3 $PINS O=n332 I1=n331 I2=n330 I3=n329
XU679 AOI22S $PINS O=n336 A1=bank_mem_0[7][7] A2=n627 B1=n332 B2=N30
XU680 AOI22S $PINS O=n335 A1=bank_mem_0[5][7] A2=n629 B1=bank_mem_0[6][7]
+ B2=n628
XU681 AOI22S $PINS O=n334 A1=bank_mem_0[3][7] A2=n631 B1=bank_mem_0[4][7]
+ B2=n630
XU682 AO222 $PINS O=n333 A1=bank_mem_0[1][7] A2=n634 B1=bank_mem_0[0][7]
+ B2=n633 C1=bank_mem_0[2][7] C2=n632
XU683 AN4B1S $PINS O=n337 I1=n336 I2=n335 I3=n334 B1=n333
XU684 INV1S $PINS O=bank_rdata[0][7] I=n337
XU685 AOI22S $PINS O=n342 A1=bank_mem_0[14][8] A2=n614 B1=bank_mem_0[15][8]
+ B2=n613
XU686 AOI22S $PINS O=n341 A1=bank_mem_0[12][8] A2=n616 B1=bank_mem_0[13][8]
+ B2=n615
XU687 AOI22S $PINS O=n339 A1=bank_mem_0[10][8] A2=n618 B1=bank_mem_0[11][8]
+ B2=n617
XU688 AOI22S $PINS O=n338 A1=bank_mem_0[8][8] A2=n620 B1=bank_mem_0[9][8]
+ B2=n619
XU689 AN2 $PINS O=n340 I1=n339 I2=n338
XU690 ND3 $PINS O=n343 I1=n342 I2=n341 I3=n340
XU691 AOI22S $PINS O=n347 A1=bank_mem_0[7][8] A2=n627 B1=n343 B2=N30
XU692 AOI22S $PINS O=n346 A1=bank_mem_0[5][8] A2=n629 B1=bank_mem_0[6][8]
+ B2=n628
XU693 AOI22S $PINS O=n345 A1=bank_mem_0[3][8] A2=n631 B1=bank_mem_0[4][8]
+ B2=n630
XU694 AO222 $PINS O=n344 A1=bank_mem_0[1][8] A2=n634 B1=bank_mem_0[0][8]
+ B2=n633 C1=bank_mem_0[2][8] C2=n632
XU695 AN4B1S $PINS O=n348 I1=n347 I2=n346 I3=n345 B1=n344
XU696 INV1S $PINS O=bank_rdata[0][8] I=FE_PHN1072_n348
XU697 AOI22S $PINS O=n353 A1=bank_mem_0[14][9] A2=n614 B1=bank_mem_0[15][9]
+ B2=n613
XU698 AOI22S $PINS O=n352 A1=bank_mem_0[12][9] A2=n616 B1=bank_mem_0[13][9]
+ B2=n615
XU699 AOI22S $PINS O=n350 A1=bank_mem_0[10][9] A2=n618 B1=bank_mem_0[11][9]
+ B2=n617
XU700 AOI22S $PINS O=n349 A1=bank_mem_0[8][9] A2=n620 B1=bank_mem_0[9][9]
+ B2=n619
XU701 AN2 $PINS O=n351 I1=n350 I2=n349
XU702 ND3 $PINS O=n354 I1=n353 I2=n352 I3=n351
XU703 AOI22S $PINS O=n358 A1=bank_mem_0[7][9] A2=n627 B1=n354 B2=N30
XU704 AOI22S $PINS O=n357 A1=bank_mem_0[5][9] A2=n629 B1=bank_mem_0[6][9]
+ B2=n628
XU705 AOI22S $PINS O=n356 A1=bank_mem_0[3][9] A2=n631 B1=bank_mem_0[4][9]
+ B2=n630
XU706 AO222 $PINS O=n355 A1=bank_mem_0[1][9] A2=n634 B1=bank_mem_0[0][9]
+ B2=n633 C1=bank_mem_0[2][9] C2=n632
XU707 AN4B1S $PINS O=n359 I1=n358 I2=n357 I3=n356 B1=n355
XU708 INV1S $PINS O=bank_rdata[0][9] I=n359
XU709 AOI22S $PINS O=n364 A1=bank_mem_0[14][10] A2=n614 B1=bank_mem_0[15][10]
+ B2=n613
XU710 AOI22S $PINS O=n363 A1=bank_mem_0[12][10] A2=n616 B1=bank_mem_0[13][10]
+ B2=n615
XU711 AOI22S $PINS O=n361 A1=bank_mem_0[10][10] A2=n618 B1=bank_mem_0[11][10]
+ B2=n617
XU712 AOI22S $PINS O=n360 A1=bank_mem_0[8][10] A2=n620 B1=bank_mem_0[9][10]
+ B2=n619
XU713 AN2 $PINS O=n362 I1=n361 I2=n360
XU714 ND3 $PINS O=n365 I1=n364 I2=n363 I3=n362
XU715 AOI22S $PINS O=n369 A1=bank_mem_0[7][10] A2=n627 B1=n365 B2=N30
XU716 AOI22S $PINS O=n368 A1=bank_mem_0[5][10] A2=n629 B1=bank_mem_0[6][10]
+ B2=n628
XU717 AOI22S $PINS O=n367 A1=bank_mem_0[3][10] A2=n631 B1=bank_mem_0[4][10]
+ B2=n630
XU718 AO222 $PINS O=n366 A1=bank_mem_0[1][10] A2=n634 B1=bank_mem_0[0][10]
+ B2=n633 C1=bank_mem_0[2][10] C2=n632
XU719 AN4B1S $PINS O=FE_PHN1462_n370 I1=n369 I2=n368 I3=n367 B1=n366
XU720 AOI22S $PINS O=n375 A1=bank_mem_0[14][11] A2=n614 B1=bank_mem_0[15][11]
+ B2=n613
XU721 AOI22S $PINS O=n374 A1=bank_mem_0[12][11] A2=n616 B1=bank_mem_0[13][11]
+ B2=n615
XU722 AOI22S $PINS O=n372 A1=bank_mem_0[10][11] A2=n618 B1=bank_mem_0[11][11]
+ B2=n617
XU723 AOI22S $PINS O=n371 A1=bank_mem_0[8][11] A2=n620 B1=bank_mem_0[9][11]
+ B2=n619
XU724 AN2 $PINS O=n373 I1=n372 I2=n371
XU725 ND3 $PINS O=n376 I1=n375 I2=n374 I3=n373
XU726 AOI22S $PINS O=n380 A1=bank_mem_0[7][11] A2=n627 B1=n376 B2=N30
XU727 AOI22S $PINS O=n379 A1=bank_mem_0[5][11] A2=n629 B1=bank_mem_0[6][11]
+ B2=n628
XU728 AOI22S $PINS O=n378 A1=bank_mem_0[3][11] A2=n631 B1=bank_mem_0[4][11]
+ B2=n630
XU729 AO222 $PINS O=n377 A1=bank_mem_0[1][11] A2=n634 B1=bank_mem_0[0][11]
+ B2=n633 C1=bank_mem_0[2][11] C2=n632
XU730 AN4B1S $PINS O=n381 I1=n380 I2=n379 I3=n378 B1=n377
XU731 AOI22S $PINS O=n386 A1=bank_mem_0[14][12] A2=n614 B1=bank_mem_0[15][12]
+ B2=n613
XU732 AOI22S $PINS O=n385 A1=bank_mem_0[12][12] A2=n616 B1=bank_mem_0[13][12]
+ B2=n615
XU733 AOI22S $PINS O=n383 A1=bank_mem_0[10][12] A2=n618 B1=bank_mem_0[11][12]
+ B2=n617
XU734 AOI22S $PINS O=n382 A1=bank_mem_0[8][12] A2=n620 B1=bank_mem_0[9][12]
+ B2=n619
XU735 AN2 $PINS O=n384 I1=n383 I2=n382
XU736 ND3 $PINS O=n387 I1=n386 I2=n385 I3=n384
XU737 AOI22S $PINS O=n391 A1=bank_mem_0[7][12] A2=n627 B1=n387 B2=N30
XU738 AOI22S $PINS O=n390 A1=bank_mem_0[5][12] A2=n629 B1=bank_mem_0[6][12]
+ B2=n628
XU739 AOI22S $PINS O=n389 A1=bank_mem_0[3][12] A2=n631 B1=bank_mem_0[4][12]
+ B2=n630
XU740 AO222 $PINS O=n388 A1=bank_mem_0[1][12] A2=n634 B1=bank_mem_0[0][12]
+ B2=n633 C1=bank_mem_0[2][12] C2=n632
XU741 AN4B1S $PINS O=n392 I1=n391 I2=n390 I3=n389 B1=n388
XU742 AOI22S $PINS O=n397 A1=bank_mem_0[14][13] A2=n614 B1=bank_mem_0[15][13]
+ B2=n613
XU743 AOI22S $PINS O=n396 A1=bank_mem_0[12][13] A2=n616 B1=bank_mem_0[13][13]
+ B2=n615
XU744 AOI22S $PINS O=n394 A1=bank_mem_0[10][13] A2=n618 B1=bank_mem_0[11][13]
+ B2=n617
XU745 AOI22S $PINS O=n393 A1=bank_mem_0[8][13] A2=n620 B1=bank_mem_0[9][13]
+ B2=n619
XU746 AN2 $PINS O=n395 I1=n394 I2=n393
XU747 ND3 $PINS O=n398 I1=n397 I2=n396 I3=n395
XU748 AOI22S $PINS O=n402 A1=bank_mem_0[7][13] A2=n627 B1=n398 B2=N30
XU749 AOI22S $PINS O=n401 A1=bank_mem_0[5][13] A2=n629 B1=bank_mem_0[6][13]
+ B2=n628
XU750 AOI22S $PINS O=n400 A1=bank_mem_0[3][13] A2=n631 B1=bank_mem_0[4][13]
+ B2=n630
XU751 AO222 $PINS O=n399 A1=bank_mem_0[1][13] A2=n634 B1=bank_mem_0[0][13]
+ B2=n633 C1=bank_mem_0[2][13] C2=n632
XU752 AN4B1S $PINS O=n403 I1=n402 I2=n401 I3=n400 B1=n399
XU753 INV1S $PINS O=bank_rdata[0][13] I=n403
XU754 AOI22S $PINS O=n408 A1=bank_mem_0[14][14] A2=n614 B1=bank_mem_0[15][14]
+ B2=n613
XU755 AOI22S $PINS O=n407 A1=bank_mem_0[12][14] A2=n616 B1=bank_mem_0[13][14]
+ B2=n615
XU756 AOI22S $PINS O=n405 A1=bank_mem_0[10][14] A2=n618 B1=bank_mem_0[11][14]
+ B2=n617
XU757 AOI22S $PINS O=n404 A1=bank_mem_0[8][14] A2=n620 B1=bank_mem_0[9][14]
+ B2=n619
XU758 AN2 $PINS O=n406 I1=n405 I2=n404
XU759 ND3 $PINS O=n409 I1=n408 I2=n407 I3=n406
XU760 AOI22S $PINS O=n413 A1=bank_mem_0[7][14] A2=n627 B1=n409 B2=N30
XU761 AOI22S $PINS O=n412 A1=bank_mem_0[5][14] A2=n629 B1=bank_mem_0[6][14]
+ B2=n628
XU762 AOI22S $PINS O=n411 A1=bank_mem_0[3][14] A2=n631 B1=bank_mem_0[4][14]
+ B2=n630
XU763 AO222 $PINS O=n410 A1=bank_mem_0[1][14] A2=n634 B1=bank_mem_0[0][14]
+ B2=n633 C1=bank_mem_0[2][14] C2=n632
XU764 AN4B1S $PINS O=n414 I1=n413 I2=n412 I3=n411 B1=n410
XU765 INV1S $PINS O=bank_rdata[0][14] I=n414
XU766 AOI22S $PINS O=n419 A1=bank_mem_0[14][15] A2=n614 B1=bank_mem_0[15][15]
+ B2=n613
XU767 AOI22S $PINS O=n418 A1=bank_mem_0[12][15] A2=n616 B1=bank_mem_0[13][15]
+ B2=n615
XU768 AOI22S $PINS O=n416 A1=bank_mem_0[10][15] A2=n618 B1=bank_mem_0[11][15]
+ B2=n617
XU769 AOI22S $PINS O=n415 A1=bank_mem_0[8][15] A2=n620 B1=bank_mem_0[9][15]
+ B2=n619
XU770 AN2 $PINS O=n417 I1=n416 I2=n415
XU771 ND3 $PINS O=n420 I1=n419 I2=n418 I3=n417
XU772 AOI22S $PINS O=n424 A1=bank_mem_0[7][15] A2=n627 B1=n420 B2=N30
XU773 AOI22S $PINS O=n423 A1=bank_mem_0[5][15] A2=n629 B1=bank_mem_0[6][15]
+ B2=n628
XU774 AOI22S $PINS O=n422 A1=bank_mem_0[3][15] A2=n631 B1=bank_mem_0[4][15]
+ B2=n630
XU775 AO222 $PINS O=n421 A1=bank_mem_0[1][15] A2=n634 B1=bank_mem_0[0][15]
+ B2=n633 C1=bank_mem_0[2][15] C2=n632
XU776 AN4B1S $PINS O=n425 I1=n424 I2=n423 I3=n422 B1=n421
XU777 INV1S $PINS O=bank_rdata[0][15] I=n425
XU778 AOI22S $PINS O=n430 A1=bank_mem_0[14][16] A2=n614 B1=bank_mem_0[15][16]
+ B2=n613
XU779 AOI22S $PINS O=n429 A1=bank_mem_0[12][16] A2=n616 B1=bank_mem_0[13][16]
+ B2=n615
XU780 AOI22S $PINS O=n427 A1=bank_mem_0[10][16] A2=n618 B1=bank_mem_0[11][16]
+ B2=n617
XU781 AOI22S $PINS O=n426 A1=bank_mem_0[8][16] A2=n620 B1=bank_mem_0[9][16]
+ B2=n619
XU782 AN2 $PINS O=n428 I1=n427 I2=n426
XU783 ND3 $PINS O=n431 I1=n430 I2=n429 I3=n428
XU784 AOI22S $PINS O=n435 A1=bank_mem_0[7][16] A2=n627 B1=n431 B2=N30
XU785 AOI22S $PINS O=n434 A1=bank_mem_0[5][16] A2=n629 B1=bank_mem_0[6][16]
+ B2=n628
XU786 AOI22S $PINS O=n433 A1=bank_mem_0[3][16] A2=n631 B1=bank_mem_0[4][16]
+ B2=n630
XU787 AO222 $PINS O=n432 A1=bank_mem_0[1][16] A2=n634 B1=bank_mem_0[0][16]
+ B2=n633 C1=bank_mem_0[2][16] C2=n632
XU788 AN4B1S $PINS O=n436 I1=n435 I2=n434 I3=n433 B1=n432
XU789 INV1S $PINS O=bank_rdata[0][16] I=n436
XU790 AOI22S $PINS O=n441 A1=bank_mem_0[14][17] A2=n614 B1=bank_mem_0[15][17]
+ B2=n613
XU791 AOI22S $PINS O=n440 A1=bank_mem_0[12][17] A2=n616 B1=bank_mem_0[13][17]
+ B2=n615
XU792 AOI22S $PINS O=n438 A1=bank_mem_0[10][17] A2=n618 B1=bank_mem_0[11][17]
+ B2=n617
XU793 AOI22S $PINS O=n437 A1=bank_mem_0[8][17] A2=n620 B1=bank_mem_0[9][17]
+ B2=n619
XU794 AN2 $PINS O=n439 I1=n438 I2=n437
XU795 ND3 $PINS O=n442 I1=n441 I2=n440 I3=n439
XU796 AOI22S $PINS O=n446 A1=bank_mem_0[7][17] A2=n627 B1=n442 B2=N30
XU797 AOI22S $PINS O=n445 A1=bank_mem_0[5][17] A2=n629 B1=bank_mem_0[6][17]
+ B2=n628
XU798 AOI22S $PINS O=n444 A1=bank_mem_0[3][17] A2=n631 B1=bank_mem_0[4][17]
+ B2=n630
XU799 AO222 $PINS O=n443 A1=bank_mem_0[1][17] A2=n634 B1=bank_mem_0[0][17]
+ B2=n633 C1=bank_mem_0[2][17] C2=n632
XU800 AN4B1S $PINS O=n447 I1=n446 I2=n445 I3=n444 B1=n443
XU801 INV1S $PINS O=bank_rdata[0][17] I=n447
XU802 AOI22S $PINS O=n452 A1=bank_mem_0[14][18] A2=n614 B1=bank_mem_0[15][18]
+ B2=n613
XU803 AOI22S $PINS O=n451 A1=bank_mem_0[12][18] A2=n616 B1=bank_mem_0[13][18]
+ B2=n615
XU804 AOI22S $PINS O=n449 A1=bank_mem_0[10][18] A2=n618 B1=bank_mem_0[11][18]
+ B2=n617
XU805 AOI22S $PINS O=n448 A1=bank_mem_0[8][18] A2=n620 B1=bank_mem_0[9][18]
+ B2=n619
XU806 AN2 $PINS O=n450 I1=n449 I2=n448
XU807 ND3 $PINS O=n453 I1=n452 I2=n451 I3=n450
XU808 AOI22S $PINS O=n457 A1=bank_mem_0[7][18] A2=n627 B1=n453 B2=N30
XU809 AOI22S $PINS O=n456 A1=bank_mem_0[5][18] A2=n629 B1=bank_mem_0[6][18]
+ B2=n628
XU810 AOI22S $PINS O=n455 A1=bank_mem_0[3][18] A2=n631 B1=bank_mem_0[4][18]
+ B2=n630
XU811 AO222 $PINS O=n454 A1=bank_mem_0[1][18] A2=n634 B1=bank_mem_0[0][18]
+ B2=n633 C1=bank_mem_0[2][18] C2=n632
XU812 AN4B1S $PINS O=n458 I1=n457 I2=n456 I3=n455 B1=n454
XU813 INV1S $PINS O=bank_rdata[0][18] I=n458
XU814 AOI22S $PINS O=n463 A1=bank_mem_0[14][19] A2=n614 B1=bank_mem_0[15][19]
+ B2=n613
XU815 AOI22S $PINS O=n462 A1=bank_mem_0[12][19] A2=n616 B1=bank_mem_0[13][19]
+ B2=n615
XU816 AOI22S $PINS O=n460 A1=bank_mem_0[10][19] A2=n618 B1=bank_mem_0[11][19]
+ B2=n617
XU817 AOI22S $PINS O=n459 A1=bank_mem_0[8][19] A2=n620 B1=bank_mem_0[9][19]
+ B2=n619
XU818 AN2 $PINS O=n461 I1=n460 I2=n459
XU819 ND3 $PINS O=n464 I1=n463 I2=n462 I3=n461
XU820 AOI22S $PINS O=n468 A1=bank_mem_0[7][19] A2=n627 B1=n464 B2=N30
XU821 AOI22S $PINS O=n467 A1=bank_mem_0[5][19] A2=n629 B1=bank_mem_0[6][19]
+ B2=n628
XU822 AOI22S $PINS O=n466 A1=bank_mem_0[3][19] A2=n631 B1=bank_mem_0[4][19]
+ B2=n630
XU823 AO222 $PINS O=n465 A1=bank_mem_0[1][19] A2=n634 B1=bank_mem_0[0][19]
+ B2=n633 C1=bank_mem_0[2][19] C2=n632
XU824 AN4B1S $PINS O=n469 I1=n468 I2=n467 I3=n466 B1=n465
XU825 INV1S $PINS O=bank_rdata[0][19] I=n469
XU826 AOI22S $PINS O=n474 A1=bank_mem_0[14][20] A2=n614 B1=bank_mem_0[15][20]
+ B2=n613
XU827 AOI22S $PINS O=n473 A1=bank_mem_0[12][20] A2=n616 B1=bank_mem_0[13][20]
+ B2=n615
XU828 AOI22S $PINS O=n471 A1=bank_mem_0[10][20] A2=n618 B1=bank_mem_0[11][20]
+ B2=n617
XU829 AOI22S $PINS O=n470 A1=bank_mem_0[8][20] A2=n620 B1=bank_mem_0[9][20]
+ B2=n619
XU830 AN2 $PINS O=n472 I1=n471 I2=n470
XU831 ND3 $PINS O=n475 I1=n474 I2=n473 I3=n472
XU832 AOI22S $PINS O=n479 A1=bank_mem_0[7][20] A2=n627 B1=n475 B2=N30
XU833 AOI22S $PINS O=n478 A1=bank_mem_0[5][20] A2=n629 B1=bank_mem_0[6][20]
+ B2=n628
XU834 AOI22S $PINS O=n477 A1=bank_mem_0[3][20] A2=n631 B1=bank_mem_0[4][20]
+ B2=n630
XU835 AO222 $PINS O=n476 A1=bank_mem_0[1][20] A2=n634 B1=bank_mem_0[0][20]
+ B2=n633 C1=bank_mem_0[2][20] C2=n632
XU836 AN4B1S $PINS O=n480 I1=n479 I2=n478 I3=n477 B1=n476
XU837 INV1S $PINS O=bank_rdata[0][20] I=n480
XU838 AOI22S $PINS O=n485 A1=bank_mem_0[14][21] A2=n614 B1=bank_mem_0[15][21]
+ B2=n613
XU839 AOI22S $PINS O=n484 A1=bank_mem_0[12][21] A2=n616 B1=bank_mem_0[13][21]
+ B2=n615
XU840 AOI22S $PINS O=n482 A1=bank_mem_0[10][21] A2=n618 B1=bank_mem_0[11][21]
+ B2=n617
XU841 AOI22S $PINS O=n481 A1=bank_mem_0[8][21] A2=n620 B1=bank_mem_0[9][21]
+ B2=n619
XU842 AN2 $PINS O=n483 I1=n482 I2=n481
XU843 ND3 $PINS O=n486 I1=n485 I2=n484 I3=n483
XU844 AOI22S $PINS O=n490 A1=bank_mem_0[7][21] A2=n627 B1=n486 B2=N30
XU845 AOI22S $PINS O=n489 A1=bank_mem_0[5][21] A2=n629 B1=bank_mem_0[6][21]
+ B2=n628
XU846 AOI22S $PINS O=n488 A1=bank_mem_0[3][21] A2=n631 B1=bank_mem_0[4][21]
+ B2=n630
XU847 AO222 $PINS O=n487 A1=bank_mem_0[1][21] A2=n634 B1=bank_mem_0[0][21]
+ B2=n633 C1=bank_mem_0[2][21] C2=n632
XU848 AN4B1S $PINS O=n491 I1=n490 I2=n489 I3=n488 B1=n487
XU849 INV1S $PINS O=bank_rdata[0][21] I=n491
XU850 AOI22S $PINS O=n496 A1=bank_mem_0[14][22] A2=n614 B1=bank_mem_0[15][22]
+ B2=n613
XU851 AOI22S $PINS O=n495 A1=bank_mem_0[12][22] A2=n616 B1=bank_mem_0[13][22]
+ B2=n615
XU852 AOI22S $PINS O=n493 A1=bank_mem_0[10][22] A2=n618 B1=bank_mem_0[11][22]
+ B2=n617
XU853 AOI22S $PINS O=n492 A1=bank_mem_0[8][22] A2=n620 B1=bank_mem_0[9][22]
+ B2=n619
XU854 AN2 $PINS O=n494 I1=n493 I2=n492
XU855 ND3 $PINS O=n497 I1=n496 I2=n495 I3=n494
XU856 AOI22S $PINS O=n501 A1=bank_mem_0[7][22] A2=n627 B1=n497 B2=N30
XU857 AOI22S $PINS O=n500 A1=bank_mem_0[5][22] A2=n629 B1=bank_mem_0[6][22]
+ B2=n628
XU858 AOI22S $PINS O=n499 A1=bank_mem_0[3][22] A2=n631 B1=bank_mem_0[4][22]
+ B2=n630
XU859 AO222 $PINS O=n498 A1=bank_mem_0[1][22] A2=n634 B1=bank_mem_0[0][22]
+ B2=n633 C1=bank_mem_0[2][22] C2=n632
XU860 AN4B1S $PINS O=n502 I1=n501 I2=n500 I3=n499 B1=n498
XU861 INV1S $PINS O=bank_rdata[0][22] I=n502
XU862 AOI22S $PINS O=n507 A1=bank_mem_0[14][23] A2=n614 B1=bank_mem_0[15][23]
+ B2=n613
XU863 AOI22S $PINS O=n506 A1=bank_mem_0[12][23] A2=n616 B1=bank_mem_0[13][23]
+ B2=n615
XU864 AOI22S $PINS O=n504 A1=bank_mem_0[10][23] A2=n618 B1=bank_mem_0[11][23]
+ B2=n617
XU865 AOI22S $PINS O=n503 A1=bank_mem_0[8][23] A2=n620 B1=bank_mem_0[9][23]
+ B2=n619
XU866 AN2 $PINS O=n505 I1=n504 I2=n503
XU867 ND3 $PINS O=n508 I1=n507 I2=n506 I3=n505
XU868 AOI22S $PINS O=n512 A1=bank_mem_0[7][23] A2=n627 B1=n508 B2=N30
XU869 AOI22S $PINS O=n511 A1=bank_mem_0[5][23] A2=n629 B1=bank_mem_0[6][23]
+ B2=n628
XU870 AOI22S $PINS O=n510 A1=bank_mem_0[3][23] A2=n631 B1=bank_mem_0[4][23]
+ B2=n630
XU871 AO222 $PINS O=n509 A1=bank_mem_0[1][23] A2=n634 B1=bank_mem_0[0][23]
+ B2=n633 C1=bank_mem_0[2][23] C2=n632
XU872 AN4B1S $PINS O=n513 I1=n512 I2=n511 I3=n510 B1=n509
XU873 INV1S $PINS O=bank_rdata[0][23] I=n513
XU874 AOI22S $PINS O=n518 A1=bank_mem_0[14][24] A2=n614 B1=bank_mem_0[15][24]
+ B2=n613
XU875 AOI22S $PINS O=n517 A1=bank_mem_0[12][24] A2=n616 B1=bank_mem_0[13][24]
+ B2=n615
XU876 AOI22S $PINS O=n515 A1=bank_mem_0[10][24] A2=n618 B1=bank_mem_0[11][24]
+ B2=n617
XU877 AOI22S $PINS O=n514 A1=bank_mem_0[8][24] A2=n620 B1=bank_mem_0[9][24]
+ B2=n619
XU878 AN2 $PINS O=n516 I1=n515 I2=n514
XU879 ND3 $PINS O=n519 I1=n518 I2=n517 I3=n516
XU880 AOI22S $PINS O=n523 A1=bank_mem_0[7][24] A2=n627 B1=n519 B2=N30
XU881 AOI22S $PINS O=n522 A1=bank_mem_0[5][24] A2=n629 B1=bank_mem_0[6][24]
+ B2=n628
XU882 AOI22S $PINS O=n521 A1=bank_mem_0[3][24] A2=n631 B1=bank_mem_0[4][24]
+ B2=n630
XU883 AO222 $PINS O=n520 A1=bank_mem_0[1][24] A2=n634 B1=bank_mem_0[0][24]
+ B2=n633 C1=bank_mem_0[2][24] C2=n632
XU884 AN4B1S $PINS O=n524 I1=n523 I2=n522 I3=n521 B1=n520
XU885 INV1S $PINS O=bank_rdata[0][24] I=n524
XU886 AOI22S $PINS O=n529 A1=bank_mem_0[14][25] A2=n614 B1=bank_mem_0[15][25]
+ B2=n613
XU887 AOI22S $PINS O=n528 A1=bank_mem_0[12][25] A2=n616 B1=bank_mem_0[13][25]
+ B2=n615
XU888 AOI22S $PINS O=n526 A1=bank_mem_0[10][25] A2=n618 B1=bank_mem_0[11][25]
+ B2=n617
XU889 AOI22S $PINS O=n525 A1=bank_mem_0[8][25] A2=n620 B1=bank_mem_0[9][25]
+ B2=n619
XU890 AN2 $PINS O=n527 I1=n526 I2=n525
XU891 ND3 $PINS O=n530 I1=n529 I2=n528 I3=n527
XU892 AOI22S $PINS O=n534 A1=bank_mem_0[7][25] A2=n627 B1=n530 B2=N30
XU893 AOI22S $PINS O=n533 A1=bank_mem_0[5][25] A2=n629 B1=bank_mem_0[6][25]
+ B2=n628
XU894 AOI22S $PINS O=n532 A1=bank_mem_0[3][25] A2=n631 B1=bank_mem_0[4][25]
+ B2=n630
XU895 AO222 $PINS O=n531 A1=bank_mem_0[1][25] A2=n634 B1=bank_mem_0[0][25]
+ B2=n633 C1=bank_mem_0[2][25] C2=n632
XU896 AN4B1S $PINS O=n535 I1=n534 I2=n533 I3=n532 B1=n531
XU897 INV1S $PINS O=bank_rdata[0][25] I=n535
XU898 AOI22S $PINS O=n540 A1=bank_mem_0[14][26] A2=n614 B1=bank_mem_0[15][26]
+ B2=n613
XU899 AOI22S $PINS O=n539 A1=bank_mem_0[12][26] A2=n616 B1=bank_mem_0[13][26]
+ B2=n615
XU900 AOI22S $PINS O=n537 A1=bank_mem_0[10][26] A2=n618 B1=bank_mem_0[11][26]
+ B2=n617
XU901 AOI22S $PINS O=n536 A1=bank_mem_0[8][26] A2=n620 B1=bank_mem_0[9][26]
+ B2=n619
XU902 AN2 $PINS O=n538 I1=n537 I2=n536
XU903 ND3 $PINS O=n541 I1=n540 I2=n539 I3=n538
XU904 AOI22S $PINS O=n545 A1=bank_mem_0[7][26] A2=n627 B1=n541 B2=N30
XU905 AOI22S $PINS O=n544 A1=bank_mem_0[5][26] A2=n629 B1=bank_mem_0[6][26]
+ B2=n628
XU906 AOI22S $PINS O=n543 A1=bank_mem_0[3][26] A2=n631 B1=bank_mem_0[4][26]
+ B2=n630
XU907 AO222 $PINS O=n542 A1=bank_mem_0[1][26] A2=n634 B1=bank_mem_0[0][26]
+ B2=n633 C1=bank_mem_0[2][26] C2=n632
XU908 AN4B1S $PINS O=n546 I1=n545 I2=n544 I3=n543 B1=n542
XU909 AOI22S $PINS O=n551 A1=bank_mem_0[14][27] A2=n614 B1=bank_mem_0[15][27]
+ B2=n613
XU910 AOI22S $PINS O=n550 A1=bank_mem_0[12][27] A2=n616 B1=bank_mem_0[13][27]
+ B2=n615
XU911 AOI22S $PINS O=n548 A1=bank_mem_0[10][27] A2=n618 B1=bank_mem_0[11][27]
+ B2=n617
XU912 AOI22S $PINS O=n547 A1=bank_mem_0[8][27] A2=n620 B1=bank_mem_0[9][27]
+ B2=n619
XU913 AN2 $PINS O=n549 I1=n548 I2=n547
XU914 ND3 $PINS O=n552 I1=n551 I2=n550 I3=n549
XU915 AOI22S $PINS O=n556 A1=bank_mem_0[7][27] A2=n627 B1=n552 B2=N30
XU916 AOI22S $PINS O=n555 A1=bank_mem_0[5][27] A2=n629 B1=bank_mem_0[6][27]
+ B2=n628
XU917 AOI22S $PINS O=n554 A1=bank_mem_0[3][27] A2=n631 B1=bank_mem_0[4][27]
+ B2=n630
XU918 AO222 $PINS O=n553 A1=bank_mem_0[1][27] A2=n634 B1=bank_mem_0[0][27]
+ B2=n633 C1=bank_mem_0[2][27] C2=n632
XU919 AN4B1S $PINS O=n557 I1=n556 I2=n555 I3=n554 B1=n553
XU920 INV1S $PINS O=bank_rdata[0][27] I=n557
XU921 AOI22S $PINS O=n562 A1=bank_mem_0[14][28] A2=n614 B1=bank_mem_0[15][28]
+ B2=n613
XU922 AOI22S $PINS O=n561 A1=bank_mem_0[12][28] A2=n616 B1=bank_mem_0[13][28]
+ B2=n615
XU923 AOI22S $PINS O=n559 A1=bank_mem_0[10][28] A2=n618 B1=bank_mem_0[11][28]
+ B2=n617
XU924 AOI22S $PINS O=n558 A1=bank_mem_0[8][28] A2=n620 B1=bank_mem_0[9][28]
+ B2=n619
XU925 AN2 $PINS O=n560 I1=n559 I2=n558
XU926 ND3 $PINS O=n563 I1=n562 I2=n561 I3=n560
XU927 AOI22S $PINS O=n567 A1=bank_mem_0[7][28] A2=n627 B1=n563 B2=N30
XU928 AOI22S $PINS O=n566 A1=bank_mem_0[5][28] A2=n629 B1=bank_mem_0[6][28]
+ B2=n628
XU929 AOI22S $PINS O=n565 A1=bank_mem_0[3][28] A2=n631 B1=bank_mem_0[4][28]
+ B2=n630
XU930 AO222 $PINS O=n564 A1=bank_mem_0[1][28] A2=n634 B1=bank_mem_0[0][28]
+ B2=n633 C1=bank_mem_0[2][28] C2=n632
XU931 AN4B1S $PINS O=n568 I1=n567 I2=n566 I3=n565 B1=n564
XU932 INV1S $PINS O=bank_rdata[0][28] I=n568
XU933 AOI22S $PINS O=n573 A1=bank_mem_0[14][29] A2=n614 B1=bank_mem_0[15][29]
+ B2=n613
XU934 AOI22S $PINS O=n572 A1=bank_mem_0[12][29] A2=n616 B1=bank_mem_0[13][29]
+ B2=n615
XU935 AOI22S $PINS O=n570 A1=bank_mem_0[10][29] A2=n618 B1=bank_mem_0[11][29]
+ B2=n617
XU936 AOI22S $PINS O=n569 A1=bank_mem_0[8][29] A2=n620 B1=bank_mem_0[9][29]
+ B2=n619
XU937 AN2 $PINS O=n571 I1=n570 I2=n569
XU938 ND3 $PINS O=n574 I1=n573 I2=n572 I3=n571
XU939 AOI22S $PINS O=n578 A1=bank_mem_0[7][29] A2=n627 B1=n574 B2=N30
XU940 AOI22S $PINS O=n577 A1=bank_mem_0[5][29] A2=n629 B1=bank_mem_0[6][29]
+ B2=n628
XU941 AOI22S $PINS O=n576 A1=bank_mem_0[3][29] A2=n631 B1=bank_mem_0[4][29]
+ B2=n630
XU942 AO222 $PINS O=n575 A1=bank_mem_0[1][29] A2=n634 B1=bank_mem_0[0][29]
+ B2=n633 C1=bank_mem_0[2][29] C2=n632
XU943 AN4B1S $PINS O=n579 I1=n578 I2=n577 I3=n576 B1=n575
XU944 INV1S $PINS O=bank_rdata[0][29] I=n579
XU945 AOI22S $PINS O=n584 A1=bank_mem_0[14][30] A2=n614 B1=bank_mem_0[15][30]
+ B2=n613
XU946 AOI22S $PINS O=n583 A1=bank_mem_0[12][30] A2=n616 B1=bank_mem_0[13][30]
+ B2=n615
XU947 AOI22S $PINS O=n581 A1=bank_mem_0[10][30] A2=n618 B1=bank_mem_0[11][30]
+ B2=n617
XU948 AOI22S $PINS O=n580 A1=bank_mem_0[8][30] A2=n620 B1=bank_mem_0[9][30]
+ B2=n619
XU949 AN2 $PINS O=n582 I1=n581 I2=n580
XU950 ND3 $PINS O=n585 I1=n584 I2=n583 I3=n582
XU951 AOI22S $PINS O=n589 A1=bank_mem_0[7][30] A2=n627 B1=n585 B2=N30
XU952 AOI22S $PINS O=n588 A1=bank_mem_0[5][30] A2=n629 B1=bank_mem_0[6][30]
+ B2=n628
XU953 AOI22S $PINS O=n587 A1=bank_mem_0[3][30] A2=n631 B1=bank_mem_0[4][30]
+ B2=n630
XU954 AO222 $PINS O=n586 A1=bank_mem_0[1][30] A2=n634 B1=bank_mem_0[0][30]
+ B2=n633 C1=bank_mem_0[2][30] C2=n632
XU955 AN4B1S $PINS O=n590 I1=n589 I2=n588 I3=n587 B1=n586
XU956 AOI22S $PINS O=n595 A1=bank_mem_0[14][31] A2=n614 B1=bank_mem_0[15][31]
+ B2=n613
XU957 AOI22S $PINS O=n594 A1=bank_mem_0[12][31] A2=n616 B1=bank_mem_0[13][31]
+ B2=n615
XU958 AOI22S $PINS O=n592 A1=bank_mem_0[10][31] A2=n618 B1=bank_mem_0[11][31]
+ B2=n617
XU959 AOI22S $PINS O=n591 A1=bank_mem_0[8][31] A2=n620 B1=bank_mem_0[9][31]
+ B2=n619
XU960 AN2 $PINS O=n593 I1=n592 I2=n591
XU961 ND3 $PINS O=n596 I1=n595 I2=n594 I3=n593
XU962 AOI22S $PINS O=n600 A1=bank_mem_0[7][31] A2=n627 B1=n596 B2=N30
XU963 AOI22S $PINS O=n599 A1=bank_mem_0[5][31] A2=n629 B1=bank_mem_0[6][31]
+ B2=n628
XU964 AOI22S $PINS O=n598 A1=bank_mem_0[3][31] A2=n631 B1=bank_mem_0[4][31]
+ B2=n630
XU965 AO222 $PINS O=n597 A1=bank_mem_0[1][31] A2=n634 B1=bank_mem_0[0][31]
+ B2=n633 C1=bank_mem_0[2][31] C2=n632
XU966 AN4B1S $PINS O=n601 I1=n600 I2=n599 I3=n598 B1=n597
XU967 INV1S $PINS O=bank_rdata[0][31] I=FE_PHN1091_n601
XU968 AOI22S $PINS O=n606 A1=bank_mem_0[14][32] A2=n614 B1=bank_mem_0[15][32]
+ B2=n613
XU969 AOI22S $PINS O=n605 A1=bank_mem_0[12][32] A2=n616 B1=bank_mem_0[13][32]
+ B2=n615
XU970 AOI22S $PINS O=n603 A1=bank_mem_0[10][32] A2=n618 B1=bank_mem_0[11][32]
+ B2=n617
XU971 AOI22S $PINS O=n602 A1=bank_mem_0[8][32] A2=n620 B1=bank_mem_0[9][32]
+ B2=n619
XU972 AN2 $PINS O=n604 I1=n603 I2=n602
XU973 ND3 $PINS O=n607 I1=n606 I2=n605 I3=n604
XU974 AOI22S $PINS O=n611 A1=bank_mem_0[7][32] A2=n627 B1=n607 B2=N30
XU975 AOI22S $PINS O=n610 A1=bank_mem_0[5][32] A2=n629 B1=bank_mem_0[6][32]
+ B2=n628
XU976 AOI22S $PINS O=n609 A1=bank_mem_0[3][32] A2=n631 B1=bank_mem_0[4][32]
+ B2=n630
XU977 AO222 $PINS O=n608 A1=bank_mem_0[1][32] A2=n634 B1=bank_mem_0[0][32]
+ B2=n633 C1=bank_mem_0[2][32] C2=n632
XU978 AN4B1S $PINS O=FE_PHN1086_n612 I1=n611 I2=n610 I3=n609 B1=n608
XU979 INV1S $PINS O=bank_rdata[0][32] I=n612
XU980 AOI22S $PINS O=n625 A1=bank_mem_0[14][33] A2=n614 B1=bank_mem_0[15][33]
+ B2=n613
XU981 AOI22S $PINS O=n624 A1=bank_mem_0[12][33] A2=n616 B1=bank_mem_0[13][33]
+ B2=n615
XU982 AOI22S $PINS O=n622 A1=bank_mem_0[10][33] A2=n618 B1=bank_mem_0[11][33]
+ B2=n617
XU983 AOI22S $PINS O=n621 A1=bank_mem_0[8][33] A2=n620 B1=bank_mem_0[9][33]
+ B2=n619
XU984 AN2 $PINS O=n623 I1=n622 I2=n621
XU985 ND3 $PINS O=n626 I1=n625 I2=n624 I3=n623
XU986 AOI22S $PINS O=n638 A1=bank_mem_0[7][33] A2=n627 B1=N30 B2=n626
XU987 AOI22S $PINS O=n637 A1=bank_mem_0[5][33] A2=n629 B1=bank_mem_0[6][33]
+ B2=n628
XU988 AOI22S $PINS O=n636 A1=bank_mem_0[3][33] A2=n631 B1=bank_mem_0[4][33]
+ B2=n630
XU989 AO222 $PINS O=n635 A1=bank_mem_0[1][33] A2=n634 B1=bank_mem_0[0][33]
+ B2=n633 C1=bank_mem_0[2][33] C2=n632
XU990 AN4B1S $PINS O=n639 I1=n638 I2=n637 I3=n636 B1=n635
XU991 NR2 $PINS O=n718 I1=n1109 I2=N34
XU992 NR2 $PINS O=n717 I1=n1108 I2=n1107
XU993 AN2 $PINS O=n1094 I1=n718 I2=n717
XU994 NR2 $PINS O=n721 I1=n1108 I2=N31
XU995 AN2 $PINS O=n1081 I1=n721 I2=N33
XU996 AN2 $PINS O=n1080 I1=N33 I2=n717
XU997 AOI22S $PINS O=n715 A1=bank_mem_1[14][0] A2=n1081 B1=bank_mem_1[15][0]
+ B2=n1080
XU998 NR2 $PINS O=n720 I1=N31 I2=N32
XU999 AN2 $PINS O=n1083 I1=n720 I2=N33
XU1000 NR2 $PINS O=n719 I1=n1107 I2=N32
XU1001 AN2 $PINS O=n1082 I1=n719 I2=N33
XU1002 AOI22S $PINS O=n714 A1=bank_mem_1[12][0] A2=n1083 B1=bank_mem_1[13][0]
+ B2=n1082
XU1003 AN2 $PINS O=n1085 I1=n721 I2=n1109
XU1004 AN2 $PINS O=n1084 I1=n717 I2=n1109
XU1005 AOI22S $PINS O=n712 A1=bank_mem_1[10][0] A2=n1085 B1=bank_mem_1[11][0]
+ B2=n1084
XU1006 AN2P $PINS O=n1087 I1=n720 I2=n1109
XU1007 AN2 $PINS O=n1086 I1=n719 I2=n1109
XU1008 AOI22S $PINS O=n711 A1=bank_mem_1[8][0] A2=n1087 B1=bank_mem_1[9][0]
+ B2=n1086
XU1009 AN2 $PINS O=n713 I1=n712 I2=n711
XU1010 ND3 $PINS O=n716 I1=n715 I2=n714 I3=n713
XU1011 AOI22S $PINS O=n726 A1=bank_mem_1[7][0] A2=n1094 B1=n716 B2=N34
XU1012 AN2P $PINS O=n1096 I1=n718 I2=n719
XU1013 AN2 $PINS O=n1095 I1=n718 I2=n721
XU1014 AOI22S $PINS O=n725 A1=bank_mem_1[5][0] A2=n1096 B1=bank_mem_1[6][0]
+ B2=n1095
XU1015 NR2 $PINS O=n722 I1=N33 I2=N34
XU1016 AN2P $PINS O=n1098 I1=n722 I2=n717
XU1017 AN2P $PINS O=n1097 I1=n718 I2=n720
XU1018 AOI22S $PINS O=n724 A1=bank_mem_1[3][0] A2=n1098 B1=bank_mem_1[4][0]
+ B2=n1097
XU1019 AN2 $PINS O=n1101 I1=n722 I2=n719
XU1020 AN2 $PINS O=n1100 I1=n722 I2=n720
XU1021 AN2 $PINS O=n1099 I1=n722 I2=n721
XU1022 AO222 $PINS O=n723 A1=bank_mem_1[1][0] A2=n1101 B1=bank_mem_1[0][0]
+ B2=n1100 C1=bank_mem_1[2][0] C2=n1099
XU1023 AN4B1S $PINS O=n727 I1=n726 I2=n725 I3=n724 B1=n723
XU1024 AOI22S $PINS O=n732 A1=bank_mem_1[14][1] A2=n1081 B1=bank_mem_1[15][1]
+ B2=n1080
XU1025 AOI22S $PINS O=n731 A1=bank_mem_1[12][1] A2=n1083 B1=bank_mem_1[13][1]
+ B2=n1082
XU1026 AOI22S $PINS O=n729 A1=bank_mem_1[10][1] A2=n1085 B1=bank_mem_1[11][1]
+ B2=n1084
XU1027 AOI22S $PINS O=n728 A1=bank_mem_1[8][1] A2=n1087 B1=bank_mem_1[9][1]
+ B2=n1086
XU1028 AN2 $PINS O=n730 I1=n729 I2=n728
XU1029 ND3 $PINS O=n733 I1=n732 I2=n731 I3=n730
XU1030 AOI22S $PINS O=n737 A1=bank_mem_1[7][1] A2=n1094 B1=n733 B2=N34
XU1031 AOI22S $PINS O=n736 A1=bank_mem_1[5][1] A2=n1096 B1=bank_mem_1[6][1]
+ B2=n1095
XU1032 AOI22S $PINS O=n735 A1=bank_mem_1[3][1] A2=n1098 B1=bank_mem_1[4][1]
+ B2=n1097
XU1033 AO222 $PINS O=n734 A1=bank_mem_1[1][1] A2=n1101 B1=bank_mem_1[0][1]
+ B2=n1100 C1=bank_mem_1[2][1] C2=n1099
XU1034 AN4B1S $PINS O=n738 I1=n737 I2=n736 I3=n735 B1=n734
XU1035 INV1S $PINS O=bank_rdata[1][1] I=n738
XU1036 AOI22S $PINS O=n743 A1=bank_mem_1[14][2] A2=n1081 B1=bank_mem_1[15][2]
+ B2=n1080
XU1037 AOI22S $PINS O=n742 A1=bank_mem_1[12][2] A2=n1083 B1=bank_mem_1[13][2]
+ B2=n1082
XU1038 AOI22S $PINS O=n740 A1=bank_mem_1[10][2] A2=n1085 B1=bank_mem_1[11][2]
+ B2=n1084
XU1039 AOI22S $PINS O=n739 A1=bank_mem_1[8][2] A2=n1087 B1=bank_mem_1[9][2]
+ B2=n1086
XU1040 AN2 $PINS O=n741 I1=n740 I2=n739
XU1041 ND3 $PINS O=n744 I1=n743 I2=n742 I3=n741
XU1042 AOI22S $PINS O=n748 A1=bank_mem_1[7][2] A2=n1094 B1=n744 B2=N34
XU1043 AOI22S $PINS O=n747 A1=bank_mem_1[5][2] A2=n1096 B1=bank_mem_1[6][2]
+ B2=n1095
XU1044 AOI22S $PINS O=n746 A1=bank_mem_1[3][2] A2=n1098 B1=bank_mem_1[4][2]
+ B2=n1097
XU1045 AO222 $PINS O=n745 A1=bank_mem_1[1][2] A2=n1101 B1=bank_mem_1[0][2]
+ B2=n1100 C1=bank_mem_1[2][2] C2=n1099
XU1046 AN4B1S $PINS O=n749 I1=n748 I2=n747 I3=n746 B1=n745
XU1047 INV1S $PINS O=bank_rdata[1][2] I=n749
XU1048 AOI22S $PINS O=n754 A1=bank_mem_1[14][3] A2=n1081 B1=bank_mem_1[15][3]
+ B2=n1080
XU1049 AOI22S $PINS O=n753 A1=bank_mem_1[12][3] A2=n1083 B1=bank_mem_1[13][3]
+ B2=n1082
XU1050 AOI22S $PINS O=n751 A1=bank_mem_1[10][3] A2=n1085 B1=bank_mem_1[11][3]
+ B2=n1084
XU1051 AOI22S $PINS O=n750 A1=bank_mem_1[8][3] A2=n1087 B1=bank_mem_1[9][3]
+ B2=n1086
XU1052 AN2 $PINS O=n752 I1=n751 I2=n750
XU1053 ND3 $PINS O=n755 I1=n754 I2=n753 I3=n752
XU1054 AOI22S $PINS O=n759 A1=bank_mem_1[7][3] A2=n1094 B1=n755 B2=N34
XU1055 AOI22S $PINS O=n758 A1=bank_mem_1[5][3] A2=n1096 B1=bank_mem_1[6][3]
+ B2=n1095
XU1056 AOI22S $PINS O=n757 A1=bank_mem_1[3][3] A2=n1098 B1=bank_mem_1[4][3]
+ B2=n1097
XU1057 AO222 $PINS O=n756 A1=bank_mem_1[1][3] A2=n1101 B1=bank_mem_1[0][3]
+ B2=n1100 C1=bank_mem_1[2][3] C2=n1099
XU1058 AN4B1S $PINS O=n760 I1=n759 I2=n758 I3=n757 B1=n756
XU1059 INV1S $PINS O=bank_rdata[1][3] I=n760
XU1060 AOI22S $PINS O=n765 A1=bank_mem_1[14][4] A2=n1081 B1=bank_mem_1[15][4]
+ B2=n1080
XU1061 AOI22S $PINS O=n764 A1=bank_mem_1[12][4] A2=n1083 B1=bank_mem_1[13][4]
+ B2=n1082
XU1062 AOI22S $PINS O=n762 A1=bank_mem_1[10][4] A2=n1085 B1=bank_mem_1[11][4]
+ B2=n1084
XU1063 AOI22S $PINS O=n761 A1=bank_mem_1[8][4] A2=n1087 B1=bank_mem_1[9][4]
+ B2=n1086
XU1064 AN2 $PINS O=n763 I1=n762 I2=n761
XU1065 ND3 $PINS O=n766 I1=n765 I2=n764 I3=n763
XU1066 AOI22S $PINS O=n770 A1=bank_mem_1[7][4] A2=n1094 B1=n766 B2=N34
XU1067 AOI22S $PINS O=n769 A1=bank_mem_1[5][4] A2=n1096 B1=bank_mem_1[6][4]
+ B2=n1095
XU1068 AOI22S $PINS O=n768 A1=bank_mem_1[3][4] A2=n1098 B1=bank_mem_1[4][4]
+ B2=n1097
XU1069 AO222 $PINS O=n767 A1=bank_mem_1[1][4] A2=n1101 B1=bank_mem_1[0][4]
+ B2=n1100 C1=bank_mem_1[2][4] C2=n1099
XU1070 AN4B1S $PINS O=n771 I1=n770 I2=n769 I3=n768 B1=n767
XU1071 INV1S $PINS O=bank_rdata[1][4] I=n771
XU1072 AOI22S $PINS O=n776 A1=bank_mem_1[14][5] A2=n1081 B1=bank_mem_1[15][5]
+ B2=n1080
XU1073 AOI22S $PINS O=n775 A1=bank_mem_1[12][5] A2=n1083 B1=bank_mem_1[13][5]
+ B2=n1082
XU1074 AOI22S $PINS O=n773 A1=bank_mem_1[10][5] A2=n1085 B1=bank_mem_1[11][5]
+ B2=n1084
XU1075 AOI22S $PINS O=n772 A1=bank_mem_1[8][5] A2=n1087 B1=bank_mem_1[9][5]
+ B2=n1086
XU1076 AN2 $PINS O=n774 I1=n773 I2=n772
XU1077 ND3 $PINS O=n777 I1=n776 I2=n775 I3=n774
XU1078 AOI22S $PINS O=n781 A1=bank_mem_1[7][5] A2=n1094 B1=n777 B2=N34
XU1079 AOI22S $PINS O=n780 A1=bank_mem_1[5][5] A2=n1096 B1=bank_mem_1[6][5]
+ B2=n1095
XU1080 AOI22S $PINS O=n779 A1=bank_mem_1[3][5] A2=n1098 B1=bank_mem_1[4][5]
+ B2=n1097
XU1081 AO222 $PINS O=n778 A1=bank_mem_1[1][5] A2=n1101 B1=bank_mem_1[0][5]
+ B2=n1100 C1=bank_mem_1[2][5] C2=n1099
XU1082 AN4B1S $PINS O=n782 I1=n781 I2=n780 I3=n779 B1=n778
XU1083 INV1S $PINS O=bank_rdata[1][5] I=n782
XU1084 AOI22S $PINS O=n787 A1=bank_mem_1[14][6] A2=n1081 B1=bank_mem_1[15][6]
+ B2=n1080
XU1085 AOI22S $PINS O=n786 A1=bank_mem_1[12][6] A2=n1083 B1=bank_mem_1[13][6]
+ B2=n1082
XU1086 AOI22S $PINS O=n784 A1=bank_mem_1[10][6] A2=n1085 B1=bank_mem_1[11][6]
+ B2=n1084
XU1087 AOI22S $PINS O=n783 A1=bank_mem_1[8][6] A2=n1087 B1=bank_mem_1[9][6]
+ B2=n1086
XU1088 AN2 $PINS O=n785 I1=n784 I2=n783
XU1089 ND3 $PINS O=n788 I1=n787 I2=n786 I3=n785
XU1090 AOI22S $PINS O=n792 A1=bank_mem_1[7][6] A2=n1094 B1=n788 B2=N34
XU1091 AOI22S $PINS O=n791 A1=bank_mem_1[5][6] A2=n1096 B1=bank_mem_1[6][6]
+ B2=n1095
XU1092 AOI22S $PINS O=n790 A1=bank_mem_1[3][6] A2=n1098 B1=bank_mem_1[4][6]
+ B2=n1097
XU1093 AO222 $PINS O=n789 A1=bank_mem_1[1][6] A2=n1101 B1=bank_mem_1[0][6]
+ B2=n1100 C1=bank_mem_1[2][6] C2=n1099
XU1094 AN4B1S $PINS O=n793 I1=n792 I2=n791 I3=n790 B1=n789
XU1095 INV1S $PINS O=bank_rdata[1][6] I=n793
XU1096 AOI22S $PINS O=n798 A1=bank_mem_1[14][7] A2=n1081 B1=bank_mem_1[15][7]
+ B2=n1080
XU1097 AOI22S $PINS O=n797 A1=bank_mem_1[12][7] A2=n1083 B1=bank_mem_1[13][7]
+ B2=n1082
XU1098 AOI22S $PINS O=n795 A1=bank_mem_1[10][7] A2=n1085 B1=bank_mem_1[11][7]
+ B2=n1084
XU1099 AOI22S $PINS O=n794 A1=bank_mem_1[8][7] A2=n1087 B1=bank_mem_1[9][7]
+ B2=n1086
XU1100 AN2 $PINS O=n796 I1=n795 I2=n794
XU1101 ND3 $PINS O=n799 I1=n798 I2=n797 I3=n796
XU1102 AOI22S $PINS O=n803 A1=bank_mem_1[7][7] A2=n1094 B1=n799 B2=N34
XU1103 AOI22S $PINS O=n802 A1=bank_mem_1[5][7] A2=n1096 B1=bank_mem_1[6][7]
+ B2=n1095
XU1104 AOI22S $PINS O=n801 A1=bank_mem_1[3][7] A2=n1098 B1=bank_mem_1[4][7]
+ B2=n1097
XU1105 AO222 $PINS O=n800 A1=bank_mem_1[1][7] A2=n1101 B1=bank_mem_1[0][7]
+ B2=n1100 C1=bank_mem_1[2][7] C2=n1099
XU1106 AN4B1S $PINS O=n804 I1=n803 I2=n802 I3=n801 B1=n800
XU1107 INV1S $PINS O=bank_rdata[1][7] I=n804
XU1108 AOI22S $PINS O=n809 A1=bank_mem_1[14][8] A2=n1081 B1=bank_mem_1[15][8]
+ B2=n1080
XU1109 AOI22S $PINS O=n808 A1=bank_mem_1[12][8] A2=n1083 B1=bank_mem_1[13][8]
+ B2=n1082
XU1110 AOI22S $PINS O=n806 A1=bank_mem_1[10][8] A2=n1085 B1=bank_mem_1[11][8]
+ B2=n1084
XU1111 AOI22S $PINS O=n805 A1=bank_mem_1[8][8] A2=n1087 B1=bank_mem_1[9][8]
+ B2=n1086
XU1112 AN2 $PINS O=n807 I1=n806 I2=n805
XU1113 ND3 $PINS O=n810 I1=n809 I2=n808 I3=n807
XU1114 AOI22S $PINS O=n814 A1=bank_mem_1[7][8] A2=n1094 B1=n810 B2=N34
XU1115 AOI22S $PINS O=n813 A1=bank_mem_1[5][8] A2=n1096 B1=bank_mem_1[6][8]
+ B2=n1095
XU1116 AOI22S $PINS O=n812 A1=bank_mem_1[3][8] A2=n1098 B1=bank_mem_1[4][8]
+ B2=n1097
XU1117 AO222 $PINS O=n811 A1=bank_mem_1[1][8] A2=n1101 B1=bank_mem_1[0][8]
+ B2=n1100 C1=bank_mem_1[2][8] C2=n1099
XU1118 AN4B1S $PINS O=FE_PHN1108_n815 I1=n814 I2=n813 I3=n812 B1=n811
XU1119 INV1S $PINS O=bank_rdata[1][8] I=n815
XU1120 AOI22S $PINS O=n820 A1=bank_mem_1[14][9] A2=n1081 B1=bank_mem_1[15][9]
+ B2=n1080
XU1121 AOI22S $PINS O=n819 A1=bank_mem_1[12][9] A2=n1083 B1=bank_mem_1[13][9]
+ B2=n1082
XU1122 AOI22S $PINS O=n817 A1=bank_mem_1[10][9] A2=n1085 B1=bank_mem_1[11][9]
+ B2=n1084
XU1123 AOI22S $PINS O=n816 A1=bank_mem_1[8][9] A2=n1087 B1=bank_mem_1[9][9]
+ B2=n1086
XU1124 AN2 $PINS O=n818 I1=n817 I2=n816
XU1125 ND3 $PINS O=n821 I1=n820 I2=n819 I3=n818
XU1126 AOI22S $PINS O=n825 A1=bank_mem_1[7][9] A2=n1094 B1=n821 B2=N34
XU1127 AOI22S $PINS O=n824 A1=bank_mem_1[5][9] A2=n1096 B1=bank_mem_1[6][9]
+ B2=n1095
XU1128 AOI22S $PINS O=n823 A1=bank_mem_1[3][9] A2=n1098 B1=bank_mem_1[4][9]
+ B2=n1097
XU1129 AO222 $PINS O=n822 A1=bank_mem_1[1][9] A2=n1101 B1=bank_mem_1[0][9]
+ B2=n1100 C1=FE_PHN1101_bank_mem_1_2_9 C2=n1099
XU1130 AN4B1S $PINS O=n826 I1=n825 I2=n824 I3=n823 B1=n822
XU1131 INV1S $PINS O=bank_rdata[1][9] I=n826
XU1132 AOI22S $PINS O=n831 A1=bank_mem_1[14][10] A2=n1081 B1=bank_mem_1[15][10]
+ B2=n1080
XU1133 AOI22S $PINS O=n830 A1=bank_mem_1[12][10] A2=n1083 B1=bank_mem_1[13][10]
+ B2=n1082
XU1134 AOI22S $PINS O=n828 A1=bank_mem_1[10][10] A2=n1085 B1=bank_mem_1[11][10]
+ B2=n1084
XU1135 AOI22S $PINS O=n827 A1=bank_mem_1[8][10] A2=n1087 B1=bank_mem_1[9][10]
+ B2=n1086
XU1136 AN2 $PINS O=n829 I1=n828 I2=n827
XU1137 ND3 $PINS O=n832 I1=n831 I2=n830 I3=n829
XU1138 AOI22S $PINS O=n836 A1=bank_mem_1[7][10] A2=n1094 B1=n832 B2=N34
XU1139 AOI22S $PINS O=n835 A1=bank_mem_1[5][10] A2=n1096 B1=bank_mem_1[6][10]
+ B2=n1095
XU1140 AOI22S $PINS O=n834 A1=bank_mem_1[3][10] A2=n1098 B1=bank_mem_1[4][10]
+ B2=n1097
XU1141 AO222 $PINS O=n833 A1=bank_mem_1[1][10] A2=n1101 B1=bank_mem_1[0][10]
+ B2=n1100 C1=bank_mem_1[2][10] C2=n1099
XU1142 AN4B1S $PINS O=n837 I1=n836 I2=n835 I3=n834 B1=n833
XU1143 AOI22S $PINS O=n842 A1=bank_mem_1[14][11] A2=n1081 B1=bank_mem_1[15][11]
+ B2=n1080
XU1144 AOI22S $PINS O=n841 A1=bank_mem_1[12][11] A2=n1083 B1=bank_mem_1[13][11]
+ B2=n1082
XU1145 AOI22S $PINS O=n839 A1=bank_mem_1[10][11] A2=n1085 B1=bank_mem_1[11][11]
+ B2=n1084
XU1146 AOI22S $PINS O=n838 A1=bank_mem_1[8][11] A2=n1087 B1=bank_mem_1[9][11]
+ B2=n1086
XU1147 AN2 $PINS O=n840 I1=n839 I2=n838
XU1148 ND3 $PINS O=n843 I1=n842 I2=n841 I3=n840
XU1149 AOI22S $PINS O=n847 A1=bank_mem_1[7][11] A2=n1094 B1=n843 B2=N34
XU1150 AOI22S $PINS O=n846 A1=bank_mem_1[5][11] A2=n1096 B1=bank_mem_1[6][11]
+ B2=n1095
XU1151 AOI22S $PINS O=n845 A1=bank_mem_1[3][11] A2=n1098 B1=bank_mem_1[4][11]
+ B2=n1097
XU1152 AO222 $PINS O=n844 A1=bank_mem_1[1][11] A2=n1101 B1=bank_mem_1[0][11]
+ B2=n1100 C1=bank_mem_1[2][11] C2=n1099
XU1153 AN4B1S $PINS O=n848 I1=n847 I2=n846 I3=n845 B1=n844
XU1154 AOI22S $PINS O=n853 A1=bank_mem_1[14][12] A2=n1081 B1=bank_mem_1[15][12]
+ B2=n1080
XU1155 AOI22S $PINS O=n852 A1=bank_mem_1[12][12] A2=n1083 B1=bank_mem_1[13][12]
+ B2=n1082
XU1156 AOI22S $PINS O=n850 A1=bank_mem_1[10][12] A2=n1085 B1=bank_mem_1[11][12]
+ B2=n1084
XU1157 AOI22S $PINS O=n849 A1=bank_mem_1[8][12] A2=n1087 B1=bank_mem_1[9][12]
+ B2=n1086
XU1158 AN2 $PINS O=n851 I1=n850 I2=n849
XU1159 ND3 $PINS O=n854 I1=n853 I2=n852 I3=n851
XU1160 AOI22S $PINS O=n858 A1=bank_mem_1[7][12] A2=n1094 B1=n854 B2=N34
XU1161 AOI22S $PINS O=n857 A1=bank_mem_1[5][12] A2=n1096 B1=bank_mem_1[6][12]
+ B2=n1095
XU1162 AOI22S $PINS O=n856 A1=bank_mem_1[3][12] A2=n1098 B1=bank_mem_1[4][12]
+ B2=n1097
XU1163 AO222 $PINS O=n855 A1=bank_mem_1[1][12] A2=n1101 B1=bank_mem_1[0][12]
+ B2=n1100 C1=bank_mem_1[2][12] C2=n1099
XU1164 AN4B1S $PINS O=n859 I1=n858 I2=n857 I3=n856 B1=n855
XU1165 AOI22S $PINS O=n864 A1=bank_mem_1[14][13] A2=n1081 B1=bank_mem_1[15][13]
+ B2=n1080
XU1166 AOI22S $PINS O=n863 A1=bank_mem_1[12][13] A2=n1083 B1=bank_mem_1[13][13]
+ B2=n1082
XU1167 AOI22S $PINS O=n861 A1=bank_mem_1[10][13] A2=n1085 B1=bank_mem_1[11][13]
+ B2=n1084
XU1168 AOI22S $PINS O=n860 A1=bank_mem_1[8][13] A2=n1087 B1=bank_mem_1[9][13]
+ B2=n1086
XU1169 AN2 $PINS O=n862 I1=n861 I2=n860
XU1170 ND3 $PINS O=n865 I1=n864 I2=n863 I3=n862
XU1171 AOI22S $PINS O=n869 A1=bank_mem_1[7][13] A2=n1094 B1=n865 B2=N34
XU1172 AOI22S $PINS O=n868 A1=bank_mem_1[5][13] A2=n1096 B1=bank_mem_1[6][13]
+ B2=n1095
XU1173 AOI22S $PINS O=n867 A1=bank_mem_1[3][13] A2=n1098 B1=bank_mem_1[4][13]
+ B2=n1097
XU1174 AO222 $PINS O=n866 A1=bank_mem_1[1][13] A2=n1101 B1=bank_mem_1[0][13]
+ B2=n1100 C1=bank_mem_1[2][13] C2=n1099
XU1175 AN4B1S $PINS O=n870 I1=n869 I2=n868 I3=n867 B1=n866
XU1176 INV1S $PINS O=bank_rdata[1][13] I=n870
XU1177 AOI22S $PINS O=n875 A1=bank_mem_1[14][14] A2=n1081 B1=bank_mem_1[15][14]
+ B2=n1080
XU1178 AOI22S $PINS O=n874 A1=bank_mem_1[12][14] A2=n1083 B1=bank_mem_1[13][14]
+ B2=n1082
XU1179 AOI22S $PINS O=n872 A1=bank_mem_1[10][14] A2=n1085 B1=bank_mem_1[11][14]
+ B2=n1084
XU1180 AOI22S $PINS O=n871 A1=bank_mem_1[8][14] A2=n1087 B1=bank_mem_1[9][14]
+ B2=n1086
XU1181 AN2 $PINS O=n873 I1=n872 I2=n871
XU1182 ND3 $PINS O=n876 I1=n875 I2=n874 I3=n873
XU1183 AOI22S $PINS O=n880 A1=bank_mem_1[7][14] A2=n1094 B1=n876 B2=N34
XU1184 AOI22S $PINS O=n879 A1=bank_mem_1[5][14] A2=n1096 B1=bank_mem_1[6][14]
+ B2=n1095
XU1185 AOI22S $PINS O=n878 A1=bank_mem_1[3][14] A2=n1098 B1=bank_mem_1[4][14]
+ B2=n1097
XU1186 AO222 $PINS O=n877 A1=bank_mem_1[1][14] A2=n1101 B1=bank_mem_1[0][14]
+ B2=n1100 C1=bank_mem_1[2][14] C2=n1099
XU1187 AN4B1S $PINS O=n881 I1=n880 I2=n879 I3=n878 B1=n877
XU1188 INV1S $PINS O=bank_rdata[1][14] I=n881
XU1189 AOI22S $PINS O=n886 A1=bank_mem_1[14][15] A2=n1081 B1=bank_mem_1[15][15]
+ B2=n1080
XU1190 AOI22S $PINS O=n885 A1=bank_mem_1[12][15] A2=n1083 B1=bank_mem_1[13][15]
+ B2=n1082
XU1191 AOI22S $PINS O=n883 A1=bank_mem_1[10][15] A2=n1085 B1=bank_mem_1[11][15]
+ B2=n1084
XU1192 AOI22S $PINS O=n882 A1=bank_mem_1[8][15] A2=n1087 B1=bank_mem_1[9][15]
+ B2=n1086
XU1193 AN2 $PINS O=n884 I1=n883 I2=n882
XU1194 ND3 $PINS O=n887 I1=n886 I2=n885 I3=n884
XU1195 AOI22S $PINS O=n891 A1=bank_mem_1[7][15] A2=n1094 B1=n887 B2=N34
XU1196 AOI22S $PINS O=n890 A1=bank_mem_1[5][15] A2=n1096 B1=bank_mem_1[6][15]
+ B2=n1095
XU1197 AOI22S $PINS O=n889 A1=bank_mem_1[3][15] A2=n1098 B1=bank_mem_1[4][15]
+ B2=n1097
XU1198 AO222 $PINS O=n888 A1=bank_mem_1[1][15] A2=n1101 B1=bank_mem_1[0][15]
+ B2=n1100 C1=bank_mem_1[2][15] C2=n1099
XU1199 AN4B1S $PINS O=n892 I1=n891 I2=n890 I3=n889 B1=n888
XU1200 INV1S $PINS O=bank_rdata[1][15] I=n892
XU1201 AOI22S $PINS O=n897 A1=bank_mem_1[14][16] A2=n1081 B1=bank_mem_1[15][16]
+ B2=n1080
XU1202 AOI22S $PINS O=n896 A1=bank_mem_1[12][16] A2=n1083 B1=bank_mem_1[13][16]
+ B2=n1082
XU1203 AOI22S $PINS O=n894 A1=bank_mem_1[10][16] A2=n1085 B1=bank_mem_1[11][16]
+ B2=n1084
XU1204 AOI22S $PINS O=n893 A1=bank_mem_1[8][16] A2=n1087 B1=bank_mem_1[9][16]
+ B2=n1086
XU1205 AN2 $PINS O=n895 I1=n894 I2=n893
XU1206 ND3 $PINS O=n898 I1=n897 I2=n896 I3=n895
XU1207 AOI22S $PINS O=n902 A1=bank_mem_1[7][16] A2=n1094 B1=n898 B2=N34
XU1208 AOI22S $PINS O=n901 A1=bank_mem_1[5][16] A2=n1096 B1=bank_mem_1[6][16]
+ B2=n1095
XU1209 AOI22S $PINS O=n900 A1=bank_mem_1[3][16] A2=n1098 B1=bank_mem_1[4][16]
+ B2=n1097
XU1210 AO222 $PINS O=n899 A1=bank_mem_1[1][16] A2=n1101 B1=bank_mem_1[0][16]
+ B2=n1100 C1=bank_mem_1[2][16] C2=n1099
XU1211 AN4B1S $PINS O=n903 I1=n902 I2=n901 I3=n900 B1=n899
XU1212 INV1S $PINS O=bank_rdata[1][16] I=n903
XU1213 AOI22S $PINS O=n908 A1=bank_mem_1[14][17] A2=n1081 B1=bank_mem_1[15][17]
+ B2=n1080
XU1214 AOI22S $PINS O=n907 A1=bank_mem_1[12][17] A2=n1083 B1=bank_mem_1[13][17]
+ B2=n1082
XU1215 AOI22S $PINS O=n905 A1=bank_mem_1[10][17] A2=n1085 B1=bank_mem_1[11][17]
+ B2=n1084
XU1216 AOI22S $PINS O=n904 A1=bank_mem_1[8][17] A2=n1087 B1=bank_mem_1[9][17]
+ B2=n1086
XU1217 AN2 $PINS O=n906 I1=n905 I2=n904
XU1218 ND3 $PINS O=n909 I1=n908 I2=n907 I3=n906
XU1219 AOI22S $PINS O=n913 A1=bank_mem_1[7][17] A2=n1094 B1=n909 B2=N34
XU1220 AOI22S $PINS O=n912 A1=bank_mem_1[5][17] A2=n1096 B1=bank_mem_1[6][17]
+ B2=n1095
XU1221 AOI22S $PINS O=n911 A1=bank_mem_1[3][17] A2=n1098 B1=bank_mem_1[4][17]
+ B2=n1097
XU1222 AO222 $PINS O=n910 A1=bank_mem_1[1][17] A2=n1101 B1=bank_mem_1[0][17]
+ B2=n1100 C1=bank_mem_1[2][17] C2=n1099
XU1223 AN4B1S $PINS O=n914 I1=n913 I2=n912 I3=n911 B1=n910
XU1224 INV1S $PINS O=bank_rdata[1][17] I=n914
XU1225 AOI22S $PINS O=n919 A1=bank_mem_1[14][18] A2=n1081 B1=bank_mem_1[15][18]
+ B2=n1080
XU1226 AOI22S $PINS O=n918 A1=bank_mem_1[12][18] A2=n1083 B1=bank_mem_1[13][18]
+ B2=n1082
XU1227 AOI22S $PINS O=n916 A1=bank_mem_1[10][18] A2=n1085 B1=bank_mem_1[11][18]
+ B2=n1084
XU1228 AOI22S $PINS O=n915 A1=bank_mem_1[8][18] A2=n1087 B1=bank_mem_1[9][18]
+ B2=n1086
XU1229 AN2 $PINS O=n917 I1=n916 I2=n915
XU1230 ND3 $PINS O=n920 I1=n919 I2=n918 I3=n917
XU1231 AOI22S $PINS O=n924 A1=bank_mem_1[7][18] A2=n1094 B1=n920 B2=N34
XU1232 AOI22S $PINS O=n923 A1=bank_mem_1[5][18] A2=n1096 B1=bank_mem_1[6][18]
+ B2=n1095
XU1233 AOI22S $PINS O=n922 A1=bank_mem_1[3][18] A2=n1098 B1=bank_mem_1[4][18]
+ B2=n1097
XU1234 AO222 $PINS O=n921 A1=bank_mem_1[1][18] A2=n1101 B1=bank_mem_1[0][18]
+ B2=n1100 C1=bank_mem_1[2][18] C2=n1099
XU1235 AN4B1S $PINS O=n925 I1=n924 I2=n923 I3=n922 B1=n921
XU1236 INV1S $PINS O=bank_rdata[1][18] I=n925
XU1237 AOI22S $PINS O=n930 A1=bank_mem_1[14][19] A2=n1081 B1=bank_mem_1[15][19]
+ B2=n1080
XU1238 AOI22S $PINS O=n929 A1=bank_mem_1[12][19] A2=n1083 B1=bank_mem_1[13][19]
+ B2=n1082
XU1239 AOI22S $PINS O=n927 A1=bank_mem_1[10][19] A2=n1085 B1=bank_mem_1[11][19]
+ B2=n1084
XU1240 AOI22S $PINS O=n926 A1=bank_mem_1[8][19] A2=n1087 B1=bank_mem_1[9][19]
+ B2=n1086
XU1241 AN2 $PINS O=n928 I1=n927 I2=n926
XU1242 ND3 $PINS O=n931 I1=n930 I2=n929 I3=n928
XU1243 AOI22S $PINS O=n935 A1=bank_mem_1[7][19] A2=n1094 B1=n931 B2=N34
XU1244 AOI22S $PINS O=n934 A1=bank_mem_1[5][19] A2=n1096 B1=bank_mem_1[6][19]
+ B2=n1095
XU1245 AOI22S $PINS O=n933 A1=bank_mem_1[3][19] A2=n1098 B1=bank_mem_1[4][19]
+ B2=n1097
XU1246 AO222 $PINS O=n932 A1=bank_mem_1[1][19] A2=n1101 B1=bank_mem_1[0][19]
+ B2=n1100 C1=bank_mem_1[2][19] C2=n1099
XU1247 AN4B1S $PINS O=n936 I1=n935 I2=n934 I3=n933 B1=n932
XU1248 INV1S $PINS O=bank_rdata[1][19] I=n936
XU1249 AOI22S $PINS O=n941 A1=bank_mem_1[14][20] A2=n1081 B1=bank_mem_1[15][20]
+ B2=n1080
XU1250 AOI22S $PINS O=n940 A1=bank_mem_1[12][20] A2=n1083 B1=bank_mem_1[13][20]
+ B2=n1082
XU1251 AOI22S $PINS O=n938 A1=bank_mem_1[10][20] A2=n1085 B1=bank_mem_1[11][20]
+ B2=n1084
XU1252 AOI22S $PINS O=n937 A1=bank_mem_1[8][20] A2=n1087 B1=bank_mem_1[9][20]
+ B2=n1086
XU1253 AN2 $PINS O=n939 I1=n938 I2=n937
XU1254 ND3 $PINS O=n942 I1=n941 I2=n940 I3=n939
XU1255 AOI22S $PINS O=n946 A1=bank_mem_1[7][20] A2=n1094 B1=n942 B2=N34
XU1256 AOI22S $PINS O=n945 A1=bank_mem_1[5][20] A2=n1096 B1=bank_mem_1[6][20]
+ B2=n1095
XU1257 AOI22S $PINS O=n944 A1=bank_mem_1[3][20] A2=n1098 B1=bank_mem_1[4][20]
+ B2=n1097
XU1258 AO222 $PINS O=n943 A1=bank_mem_1[1][20] A2=n1101 B1=bank_mem_1[0][20]
+ B2=n1100 C1=bank_mem_1[2][20] C2=n1099
XU1259 AN4B1S $PINS O=n947 I1=n946 I2=n945 I3=n944 B1=n943
XU1260 INV1S $PINS O=bank_rdata[1][20] I=n947
XU1261 AOI22S $PINS O=n952 A1=bank_mem_1[14][21] A2=n1081 B1=bank_mem_1[15][21]
+ B2=n1080
XU1262 AOI22S $PINS O=n951 A1=bank_mem_1[12][21] A2=n1083 B1=bank_mem_1[13][21]
+ B2=n1082
XU1263 AOI22S $PINS O=n949 A1=bank_mem_1[10][21] A2=n1085 B1=bank_mem_1[11][21]
+ B2=n1084
XU1264 AOI22S $PINS O=n948 A1=bank_mem_1[8][21] A2=n1087 B1=bank_mem_1[9][21]
+ B2=n1086
XU1265 AN2 $PINS O=n950 I1=n949 I2=n948
XU1266 ND3 $PINS O=n953 I1=n952 I2=n951 I3=n950
XU1267 AOI22S $PINS O=n957 A1=bank_mem_1[7][21] A2=n1094 B1=n953 B2=N34
XU1268 AOI22S $PINS O=n956 A1=bank_mem_1[5][21] A2=n1096 B1=bank_mem_1[6][21]
+ B2=n1095
XU1269 AOI22S $PINS O=n955 A1=bank_mem_1[3][21] A2=n1098 B1=bank_mem_1[4][21]
+ B2=n1097
XU1270 AO222 $PINS O=n954 A1=bank_mem_1[1][21] A2=n1101 B1=bank_mem_1[0][21]
+ B2=n1100 C1=bank_mem_1[2][21] C2=n1099
XU1271 AN4B1S $PINS O=n958 I1=n957 I2=n956 I3=n955 B1=n954
XU1272 INV1S $PINS O=bank_rdata[1][21] I=n958
XU1273 AOI22S $PINS O=n963 A1=bank_mem_1[14][22] A2=n1081 B1=bank_mem_1[15][22]
+ B2=n1080
XU1274 AOI22S $PINS O=n962 A1=bank_mem_1[12][22] A2=n1083 B1=bank_mem_1[13][22]
+ B2=n1082
XU1275 AOI22S $PINS O=n960 A1=bank_mem_1[10][22] A2=n1085 B1=bank_mem_1[11][22]
+ B2=n1084
XU1276 AOI22S $PINS O=n959 A1=bank_mem_1[8][22] A2=n1087 B1=bank_mem_1[9][22]
+ B2=n1086
XU1277 AN2 $PINS O=n961 I1=n960 I2=n959
XU1278 ND3 $PINS O=n964 I1=n963 I2=n962 I3=n961
XU1279 AOI22S $PINS O=n968 A1=bank_mem_1[7][22] A2=n1094 B1=n964 B2=N34
XU1280 AOI22S $PINS O=n967 A1=bank_mem_1[5][22] A2=n1096 B1=bank_mem_1[6][22]
+ B2=n1095
XU1281 AOI22S $PINS O=n966 A1=bank_mem_1[3][22] A2=n1098 B1=bank_mem_1[4][22]
+ B2=n1097
XU1282 AO222 $PINS O=n965 A1=bank_mem_1[1][22] A2=n1101 B1=bank_mem_1[0][22]
+ B2=n1100 C1=bank_mem_1[2][22] C2=n1099
XU1283 AN4B1S $PINS O=n969 I1=n968 I2=n967 I3=n966 B1=n965
XU1284 INV1S $PINS O=bank_rdata[1][22] I=n969
XU1285 AOI22S $PINS O=n974 A1=bank_mem_1[14][23] A2=n1081 B1=bank_mem_1[15][23]
+ B2=n1080
XU1286 AOI22S $PINS O=n973 A1=bank_mem_1[12][23] A2=n1083 B1=bank_mem_1[13][23]
+ B2=n1082
XU1287 AOI22S $PINS O=n971 A1=bank_mem_1[10][23] A2=n1085 B1=bank_mem_1[11][23]
+ B2=n1084
XU1288 AOI22S $PINS O=n970 A1=bank_mem_1[8][23] A2=n1087 B1=bank_mem_1[9][23]
+ B2=n1086
XU1289 AN2 $PINS O=n972 I1=n971 I2=n970
XU1290 ND3 $PINS O=n975 I1=n974 I2=n973 I3=n972
XU1291 AOI22S $PINS O=n979 A1=bank_mem_1[7][23] A2=n1094 B1=n975 B2=N34
XU1292 AOI22S $PINS O=n978 A1=bank_mem_1[5][23] A2=n1096 B1=bank_mem_1[6][23]
+ B2=n1095
XU1293 AOI22S $PINS O=n977 A1=bank_mem_1[3][23] A2=n1098 B1=bank_mem_1[4][23]
+ B2=n1097
XU1294 AO222 $PINS O=n976 A1=bank_mem_1[1][23] A2=n1101 B1=bank_mem_1[0][23]
+ B2=n1100 C1=bank_mem_1[2][23] C2=n1099
XU1295 AN4B1S $PINS O=n980 I1=n979 I2=n978 I3=n977 B1=n976
XU1296 INV1S $PINS O=bank_rdata[1][23] I=n980
XU1297 AOI22S $PINS O=n985 A1=bank_mem_1[14][24] A2=n1081 B1=bank_mem_1[15][24]
+ B2=n1080
XU1298 AOI22S $PINS O=n984 A1=bank_mem_1[12][24] A2=n1083 B1=bank_mem_1[13][24]
+ B2=n1082
XU1299 AOI22S $PINS O=n982 A1=bank_mem_1[10][24] A2=n1085 B1=bank_mem_1[11][24]
+ B2=n1084
XU1300 AOI22S $PINS O=n981 A1=bank_mem_1[8][24] A2=n1087 B1=bank_mem_1[9][24]
+ B2=n1086
XU1301 AN2 $PINS O=n983 I1=n982 I2=n981
XU1302 ND3 $PINS O=n986 I1=n985 I2=n984 I3=n983
XU1303 AOI22S $PINS O=n990 A1=bank_mem_1[7][24] A2=n1094 B1=n986 B2=N34
XU1304 AOI22S $PINS O=n989 A1=bank_mem_1[5][24] A2=n1096 B1=bank_mem_1[6][24]
+ B2=n1095
XU1305 AOI22S $PINS O=n988 A1=bank_mem_1[3][24] A2=n1098 B1=bank_mem_1[4][24]
+ B2=n1097
XU1306 AO222 $PINS O=n987 A1=bank_mem_1[1][24] A2=n1101 B1=bank_mem_1[0][24]
+ B2=n1100 C1=bank_mem_1[2][24] C2=n1099
XU1307 AN4B1S $PINS O=n991 I1=n990 I2=n989 I3=n988 B1=n987
XU1308 INV1S $PINS O=bank_rdata[1][24] I=n991
XU1309 AOI22S $PINS O=n996 A1=bank_mem_1[14][25] A2=n1081 B1=bank_mem_1[15][25]
+ B2=n1080
XU1310 AOI22S $PINS O=n995 A1=bank_mem_1[12][25] A2=n1083 B1=bank_mem_1[13][25]
+ B2=n1082
XU1311 AOI22S $PINS O=n993 A1=bank_mem_1[10][25] A2=n1085 B1=bank_mem_1[11][25]
+ B2=n1084
XU1312 AOI22S $PINS O=n992 A1=bank_mem_1[8][25] A2=n1087 B1=bank_mem_1[9][25]
+ B2=n1086
XU1313 AN2 $PINS O=n994 I1=n993 I2=n992
XU1314 ND3 $PINS O=n997 I1=n996 I2=n995 I3=n994
XU1315 AOI22S $PINS O=n1001 A1=bank_mem_1[7][25] A2=n1094 B1=n997 B2=N34
XU1316 AOI22S $PINS O=n1000 A1=bank_mem_1[5][25] A2=n1096 B1=bank_mem_1[6][25]
+ B2=n1095
XU1317 AOI22S $PINS O=n999 A1=bank_mem_1[3][25] A2=n1098 B1=bank_mem_1[4][25]
+ B2=n1097
XU1318 AO222 $PINS O=n998 A1=bank_mem_1[1][25] A2=n1101 B1=bank_mem_1[0][25]
+ B2=n1100 C1=bank_mem_1[2][25] C2=n1099
XU1319 AN4B1S $PINS O=n1002 I1=n1001 I2=n1000 I3=n999 B1=n998
XU1320 INV1S $PINS O=bank_rdata[1][25] I=n1002
XU1321 AOI22S $PINS O=n1007 A1=bank_mem_1[14][26] A2=n1081
+ B1=bank_mem_1[15][26] B2=n1080
XU1322 AOI22S $PINS O=n1006 A1=bank_mem_1[12][26] A2=n1083
+ B1=bank_mem_1[13][26] B2=n1082
XU1323 AOI22S $PINS O=n1004 A1=bank_mem_1[10][26] A2=n1085
+ B1=bank_mem_1[11][26] B2=n1084
XU1324 AOI22S $PINS O=n1003 A1=bank_mem_1[8][26] A2=n1087 B1=bank_mem_1[9][26]
+ B2=n1086
XU1325 AN2 $PINS O=n1005 I1=n1004 I2=n1003
XU1326 ND3 $PINS O=n1008 I1=n1007 I2=n1006 I3=n1005
XU1327 AOI22S $PINS O=n1012 A1=bank_mem_1[7][26] A2=n1094 B1=n1008 B2=N34
XU1328 AOI22S $PINS O=n1011 A1=bank_mem_1[5][26] A2=n1096 B1=bank_mem_1[6][26]
+ B2=n1095
XU1329 AOI22S $PINS O=n1010 A1=bank_mem_1[3][26] A2=n1098 B1=bank_mem_1[4][26]
+ B2=n1097
XU1330 AO222 $PINS O=n1009 A1=bank_mem_1[1][26] A2=n1101 B1=bank_mem_1[0][26]
+ B2=n1100 C1=bank_mem_1[2][26] C2=n1099
XU1331 AN4B1S $PINS O=n1013 I1=n1012 I2=n1011 I3=n1010 B1=n1009
XU1332 AOI22S $PINS O=n1018 A1=bank_mem_1[14][27] A2=n1081
+ B1=bank_mem_1[15][27] B2=n1080
XU1333 AOI22S $PINS O=n1017 A1=bank_mem_1[12][27] A2=n1083
+ B1=bank_mem_1[13][27] B2=n1082
XU1334 AOI22S $PINS O=n1015 A1=bank_mem_1[10][27] A2=n1085
+ B1=bank_mem_1[11][27] B2=n1084
XU1335 AOI22S $PINS O=n1014 A1=bank_mem_1[8][27] A2=n1087 B1=bank_mem_1[9][27]
+ B2=n1086
XU1336 AN2 $PINS O=n1016 I1=n1015 I2=n1014
XU1337 ND3 $PINS O=n1019 I1=n1018 I2=n1017 I3=n1016
XU1338 AOI22S $PINS O=n1023 A1=bank_mem_1[7][27] A2=n1094 B1=n1019 B2=N34
XU1339 AOI22S $PINS O=n1022 A1=bank_mem_1[5][27] A2=n1096 B1=bank_mem_1[6][27]
+ B2=n1095
XU1340 AOI22S $PINS O=n1021 A1=bank_mem_1[3][27] A2=n1098 B1=bank_mem_1[4][27]
+ B2=n1097
XU1341 AO222 $PINS O=n1020 A1=bank_mem_1[1][27] A2=n1101 B1=bank_mem_1[0][27]
+ B2=n1100 C1=bank_mem_1[2][27] C2=n1099
XU1342 AN4B1S $PINS O=n1024 I1=n1023 I2=n1022 I3=n1021 B1=n1020
XU1343 INV1S $PINS O=bank_rdata[1][27] I=n1024
XU1344 AOI22S $PINS O=n1029 A1=bank_mem_1[14][28] A2=n1081
+ B1=bank_mem_1[15][28] B2=n1080
XU1345 AOI22S $PINS O=n1028 A1=bank_mem_1[12][28] A2=n1083
+ B1=bank_mem_1[13][28] B2=n1082
XU1346 AOI22S $PINS O=n1026 A1=bank_mem_1[10][28] A2=n1085
+ B1=bank_mem_1[11][28] B2=n1084
XU1347 AOI22S $PINS O=n1025 A1=bank_mem_1[8][28] A2=n1087 B1=bank_mem_1[9][28]
+ B2=n1086
XU1348 AN2 $PINS O=n1027 I1=n1026 I2=n1025
XU1349 ND3 $PINS O=n1030 I1=n1029 I2=n1028 I3=n1027
XU1350 AOI22S $PINS O=n1034 A1=bank_mem_1[7][28] A2=n1094 B1=n1030 B2=N34
XU1351 AOI22S $PINS O=n1033 A1=bank_mem_1[5][28] A2=n1096 B1=bank_mem_1[6][28]
+ B2=n1095
XU1352 AOI22S $PINS O=n1032 A1=bank_mem_1[3][28] A2=n1098 B1=bank_mem_1[4][28]
+ B2=n1097
XU1353 AO222 $PINS O=n1031 A1=bank_mem_1[1][28] A2=n1101 B1=bank_mem_1[0][28]
+ B2=n1100 C1=bank_mem_1[2][28] C2=n1099
XU1354 AN4B1S $PINS O=n1035 I1=n1034 I2=n1033 I3=n1032 B1=n1031
XU1355 INV1S $PINS O=bank_rdata[1][28] I=n1035
XU1356 AOI22S $PINS O=n1040 A1=bank_mem_1[14][29] A2=n1081
+ B1=bank_mem_1[15][29] B2=n1080
XU1357 AOI22S $PINS O=n1039 A1=bank_mem_1[12][29] A2=n1083
+ B1=bank_mem_1[13][29] B2=n1082
XU1358 AOI22S $PINS O=n1037 A1=bank_mem_1[10][29] A2=n1085
+ B1=bank_mem_1[11][29] B2=n1084
XU1359 AOI22S $PINS O=n1036 A1=bank_mem_1[8][29] A2=n1087 B1=bank_mem_1[9][29]
+ B2=n1086
XU1360 AN2 $PINS O=n1038 I1=n1037 I2=n1036
XU1361 ND3 $PINS O=n1041 I1=n1040 I2=n1039 I3=n1038
XU1362 AOI22S $PINS O=n1045 A1=bank_mem_1[7][29] A2=n1094 B1=n1041 B2=N34
XU1363 AOI22S $PINS O=n1044 A1=bank_mem_1[5][29] A2=n1096 B1=bank_mem_1[6][29]
+ B2=n1095
XU1364 AOI22S $PINS O=n1043 A1=bank_mem_1[3][29] A2=n1098 B1=bank_mem_1[4][29]
+ B2=n1097
XU1365 AO222 $PINS O=n1042 A1=bank_mem_1[1][29] A2=n1101 B1=bank_mem_1[0][29]
+ B2=n1100 C1=bank_mem_1[2][29] C2=n1099
XU1366 AN4B1S $PINS O=n1046 I1=n1045 I2=n1044 I3=n1043 B1=n1042
XU1367 INV1S $PINS O=bank_rdata[1][29] I=n1046
XU1368 AOI22S $PINS O=n1051 A1=bank_mem_1[14][30] A2=n1081
+ B1=bank_mem_1[15][30] B2=n1080
XU1369 AOI22S $PINS O=n1050 A1=bank_mem_1[12][30] A2=n1083
+ B1=bank_mem_1[13][30] B2=n1082
XU1370 AOI22S $PINS O=n1048 A1=bank_mem_1[10][30] A2=n1085
+ B1=bank_mem_1[11][30] B2=n1084
XU1371 AOI22S $PINS O=n1047 A1=bank_mem_1[8][30] A2=n1087 B1=bank_mem_1[9][30]
+ B2=n1086
XU1372 AN2 $PINS O=n1049 I1=n1048 I2=n1047
XU1373 ND3 $PINS O=n1052 I1=n1051 I2=n1050 I3=n1049
XU1374 AOI22S $PINS O=n1056 A1=bank_mem_1[7][30] A2=n1094 B1=n1052 B2=N34
XU1375 AOI22S $PINS O=n1055 A1=bank_mem_1[5][30] A2=n1096 B1=bank_mem_1[6][30]
+ B2=n1095
XU1376 AOI22S $PINS O=n1054 A1=bank_mem_1[3][30] A2=n1098 B1=bank_mem_1[4][30]
+ B2=n1097
XU1377 AO222 $PINS O=n1053 A1=bank_mem_1[1][30] A2=n1101 B1=bank_mem_1[0][30]
+ B2=n1100 C1=bank_mem_1[2][30] C2=n1099
XU1378 AN4B1S $PINS O=n1057 I1=n1056 I2=n1055 I3=n1054 B1=n1053
XU1379 AOI22S $PINS O=n1062 A1=bank_mem_1[14][31] A2=n1081
+ B1=bank_mem_1[15][31] B2=n1080
XU1380 AOI22S $PINS O=n1061 A1=bank_mem_1[12][31] A2=n1083
+ B1=bank_mem_1[13][31] B2=n1082
XU1381 AOI22S $PINS O=n1059 A1=bank_mem_1[10][31] A2=n1085
+ B1=bank_mem_1[11][31] B2=n1084
XU1382 AOI22S $PINS O=n1058 A1=bank_mem_1[8][31] A2=n1087 B1=bank_mem_1[9][31]
+ B2=n1086
XU1383 AN2 $PINS O=n1060 I1=n1059 I2=n1058
XU1384 ND3 $PINS O=n1063 I1=n1062 I2=n1061 I3=n1060
XU1385 AOI22S $PINS O=n1067 A1=bank_mem_1[7][31] A2=n1094 B1=n1063 B2=N34
XU1386 AOI22S $PINS O=n1066 A1=bank_mem_1[5][31] A2=n1096 B1=bank_mem_1[6][31]
+ B2=n1095
XU1387 AOI22S $PINS O=n1065 A1=bank_mem_1[3][31] A2=n1098 B1=bank_mem_1[4][31]
+ B2=n1097
XU1388 AO222 $PINS O=n1064 A1=bank_mem_1[1][31] A2=n1101 B1=bank_mem_1[0][31]
+ B2=n1100 C1=bank_mem_1[2][31] C2=n1099
XU1389 AN4B1S $PINS O=n1068 I1=n1067 I2=n1066 I3=n1065 B1=n1064
XU1390 INV1S $PINS O=bank_rdata[1][31] I=n1068
XU1391 AOI22S $PINS O=n1073 A1=bank_mem_1[14][32] A2=n1081
+ B1=bank_mem_1[15][32] B2=n1080
XU1392 AOI22S $PINS O=n1072 A1=bank_mem_1[12][32] A2=n1083
+ B1=bank_mem_1[13][32] B2=n1082
XU1393 AOI22S $PINS O=n1070 A1=bank_mem_1[10][32] A2=n1085
+ B1=bank_mem_1[11][32] B2=n1084
XU1394 AOI22S $PINS O=n1069 A1=bank_mem_1[8][32] A2=n1087 B1=bank_mem_1[9][32]
+ B2=n1086
XU1395 AN2 $PINS O=n1071 I1=n1070 I2=n1069
XU1396 ND3 $PINS O=n1074 I1=n1073 I2=n1072 I3=n1071
XU1397 AOI22S $PINS O=n1078 A1=bank_mem_1[7][32] A2=n1094 B1=n1074 B2=N34
XU1398 AOI22S $PINS O=n1077 A1=bank_mem_1[5][32] A2=n1096 B1=bank_mem_1[6][32]
+ B2=n1095
XU1399 AOI22S $PINS O=n1076 A1=bank_mem_1[3][32] A2=n1098 B1=bank_mem_1[4][32]
+ B2=n1097
XU1400 AO222 $PINS O=n1075 A1=bank_mem_1[1][32] A2=n1101 B1=bank_mem_1[0][32]
+ B2=n1100 C1=bank_mem_1[2][32] C2=n1099
XU1401 AN4B1S $PINS O=n1079 I1=n1078 I2=n1077 I3=n1076 B1=n1075
XU1402 INV1S $PINS O=bank_rdata[1][32] I=n1079
XU1403 AOI22S $PINS O=n1092 A1=bank_mem_1[14][33] A2=n1081
+ B1=bank_mem_1[15][33] B2=n1080
XU1404 AOI22S $PINS O=n1091 A1=bank_mem_1[12][33] A2=n1083
+ B1=bank_mem_1[13][33] B2=n1082
XU1405 AOI22S $PINS O=n1089 A1=bank_mem_1[10][33] A2=n1085
+ B1=bank_mem_1[11][33] B2=n1084
XU1406 AOI22S $PINS O=n1088 A1=bank_mem_1[8][33] A2=n1087 B1=bank_mem_1[9][33]
+ B2=n1086
XU1407 AN2 $PINS O=n1090 I1=n1089 I2=n1088
XU1408 ND3 $PINS O=n1093 I1=n1092 I2=n1091 I3=n1090
XU1409 AOI22S $PINS O=n1105 A1=bank_mem_1[7][33] A2=n1094 B1=N34 B2=n1093
XU1410 AOI22S $PINS O=n1104 A1=bank_mem_1[5][33] A2=n1096 B1=bank_mem_1[6][33]
+ B2=n1095
XU1411 AOI22S $PINS O=n1103 A1=bank_mem_1[3][33] A2=n1098 B1=bank_mem_1[4][33]
+ B2=n1097
XU1412 AO222 $PINS O=n1102 A1=bank_mem_1[1][33] A2=n1101 B1=bank_mem_1[0][33]
+ B2=n1100 C1=bank_mem_1[2][33] C2=n1099
XU1413 AN4B1S $PINS O=FE_PHN1351_n1106 I1=n1105 I2=n1104 I3=n1103 B1=n1102
Xclk_gate_bank_mem_1_reg[0] SNPS_CLOCK_GATE_HIGH_RegFileDual_DATA_WIDTH34_0
+ $PINS EN=N100 ENCLK=CTS_699 CLK=CTS_700
Xclk_gate_bank_mem_1_reg[0]_0 SNPS_CLOCK_GATE_HIGH_RegFileDual_DATA_WIDTH34_63
+ $PINS CLK=CTS_700 EN=N100 ENCLK=CTS_696 CLK_clone1=clk_clone6
Xclk_gate_bank_mem_1_reg[1] SNPS_CLOCK_GATE_HIGH_RegFileDual_DATA_WIDTH34_62
+ $PINS EN=N99 ENCLK=CTS_693 CLK=CTS_700
Xclk_gate_bank_mem_1_reg[1]_0 SNPS_CLOCK_GATE_HIGH_RegFileDual_DATA_WIDTH34_61
+ $PINS CLK=CTS_700 EN=N99 ENCLK=CTS_690 CLK_clone1=clk_clone6
Xclk_gate_bank_mem_1_reg[2] SNPS_CLOCK_GATE_HIGH_RegFileDual_DATA_WIDTH34_60
+ $PINS EN=N98 ENCLK=CTS_639 CLK=clk_clone6
Xclk_gate_bank_mem_1_reg[2]_0 SNPS_CLOCK_GATE_HIGH_RegFileDual_DATA_WIDTH34_59
+ $PINS CLK=CTS_700 EN=N98 ENCLK=CTS_687 CLK_clone1=clk_clone6
Xclk_gate_bank_mem_1_reg[3] SNPS_CLOCK_GATE_HIGH_RegFileDual_DATA_WIDTH34_58
+ $PINS EN=N97 ENCLK=CTS_636 CLK=clk_clone6
Xclk_gate_bank_mem_1_reg[3]_0 SNPS_CLOCK_GATE_HIGH_RegFileDual_DATA_WIDTH34_57
+ $PINS CLK=CTS_700 EN=N97 ENCLK=CTS_684 CLK_clone1=clk_clone6
Xclk_gate_bank_mem_1_reg[4] SNPS_CLOCK_GATE_HIGH_RegFileDual_DATA_WIDTH34_56
+ $PINS CLK=CTS_700 EN=N96 ENCLK=CTS_681 CLK_clone1=clk_clone6
Xclk_gate_bank_mem_1_reg[4]_0 SNPS_CLOCK_GATE_HIGH_RegFileDual_DATA_WIDTH34_55
+ $PINS EN=N96 ENCLK=CTS_633 CLK=clk_clone6
Xclk_gate_bank_mem_1_reg[5] SNPS_CLOCK_GATE_HIGH_RegFileDual_DATA_WIDTH34_54
+ $PINS EN=N95 ENCLK=CTS_615 CLK=clk_clone7
Xclk_gate_bank_mem_1_reg[5]_0 SNPS_CLOCK_GATE_HIGH_RegFileDual_DATA_WIDTH34_53
+ $PINS EN=N95 ENCLK=CTS_678 CLK=CTS_700
Xclk_gate_bank_mem_1_reg[6] SNPS_CLOCK_GATE_HIGH_RegFileDual_DATA_WIDTH34_52
+ $PINS EN=N94 ENCLK=CTS_612 CLK=clk_clone7
Xclk_gate_bank_mem_1_reg[6]_0 SNPS_CLOCK_GATE_HIGH_RegFileDual_DATA_WIDTH34_51
+ $PINS EN=N94 ENCLK=CTS_675 CLK=CTS_700
Xclk_gate_bank_mem_1_reg[7] SNPS_CLOCK_GATE_HIGH_RegFileDual_DATA_WIDTH34_50
+ $PINS EN=N93 ENCLK=CTS_672 CLK=CTS_700
Xclk_gate_bank_mem_1_reg[7]_0 SNPS_CLOCK_GATE_HIGH_RegFileDual_DATA_WIDTH34_49
+ $PINS EN=N93 ENCLK=CTS_669 CLK=CTS_700
Xclk_gate_bank_mem_1_reg[8] SNPS_CLOCK_GATE_HIGH_RegFileDual_DATA_WIDTH34_48
+ $PINS EN=N92 ENCLK=CTS_609 CLK=clk_clone7
Xclk_gate_bank_mem_1_reg[8]_0 SNPS_CLOCK_GATE_HIGH_RegFileDual_DATA_WIDTH34_47
+ $PINS EN=N92 ENCLK=CTS_666 CLK=CTS_700
Xclk_gate_bank_mem_1_reg[9] SNPS_CLOCK_GATE_HIGH_RegFileDual_DATA_WIDTH34_46
+ $PINS EN=N91 ENCLK=CTS_606 CLK=clk_clone7
Xclk_gate_bank_mem_1_reg[9]_0 SNPS_CLOCK_GATE_HIGH_RegFileDual_DATA_WIDTH34_45
+ $PINS EN=N91 ENCLK=CTS_663 CLK=CTS_700
Xclk_gate_bank_mem_1_reg[10] SNPS_CLOCK_GATE_HIGH_RegFileDual_DATA_WIDTH34_44
+ $PINS EN=N90 ENCLK=CTS_603 CLK=clk_clone7
Xclk_gate_bank_mem_1_reg[10]_0 SNPS_CLOCK_GATE_HIGH_RegFileDual_DATA_WIDTH34_43
+ $PINS EN=N90 ENCLK=CTS_660 CLK=CTS_700
Xclk_gate_bank_mem_1_reg[11] SNPS_CLOCK_GATE_HIGH_RegFileDual_DATA_WIDTH34_42
+ $PINS EN=N89 ENCLK=CTS_600 CLK=clk_clone7
Xclk_gate_bank_mem_1_reg[11]_0 SNPS_CLOCK_GATE_HIGH_RegFileDual_DATA_WIDTH34_41
+ $PINS EN=N89 ENCLK=CTS_657 CLK=CTS_700
Xclk_gate_bank_mem_1_reg[12] SNPS_CLOCK_GATE_HIGH_RegFileDual_DATA_WIDTH34_40
+ $PINS EN=N88 ENCLK=CTS_597 CLK=clk_clone7
Xclk_gate_bank_mem_1_reg[12]_0 SNPS_CLOCK_GATE_HIGH_RegFileDual_DATA_WIDTH34_39
+ $PINS EN=N88 ENCLK=CTS_654 CLK=CTS_700
Xclk_gate_bank_mem_1_reg[13] SNPS_CLOCK_GATE_HIGH_RegFileDual_DATA_WIDTH34_38
+ $PINS EN=N87 ENCLK=CTS_651 CLK=CTS_700
Xclk_gate_bank_mem_1_reg[13]_0 SNPS_CLOCK_GATE_HIGH_RegFileDual_DATA_WIDTH34_37
+ $PINS EN=N87 ENCLK=CTS_648 CLK=CTS_700
Xclk_gate_bank_mem_1_reg[14] SNPS_CLOCK_GATE_HIGH_RegFileDual_DATA_WIDTH34_36
+ $PINS EN=N86 ENCLK=CTS_594 CLK=clk_clone7
Xclk_gate_bank_mem_1_reg[14]_0 SNPS_CLOCK_GATE_HIGH_RegFileDual_DATA_WIDTH34_35
+ $PINS EN=N86 ENCLK=CTS_645 CLK=CTS_700
Xclk_gate_bank_mem_1_reg[15] SNPS_CLOCK_GATE_HIGH_RegFileDual_DATA_WIDTH34_34
+ $PINS EN=N85 ENCLK=CTS_591 CLK=clk_clone7
Xclk_gate_bank_mem_1_reg[15]_0 SNPS_CLOCK_GATE_HIGH_RegFileDual_DATA_WIDTH34_33
+ $PINS EN=N85 ENCLK=CTS_642 CLK=CTS_700
Xclk_gate_bank_mem_0_reg[0] SNPS_CLOCK_GATE_HIGH_RegFileDual_DATA_WIDTH34_32
+ $PINS EN=N67 ENCLK=CTS_781 CLK=CTS_782
Xclk_gate_bank_mem_0_reg[0]_0 SNPS_CLOCK_GATE_HIGH_RegFileDual_DATA_WIDTH34_31
+ $PINS CLK=CTS_782 EN=N67 ENCLK=CTS_778 CLK_clone1=clk_clone6
Xclk_gate_bank_mem_0_reg[1] SNPS_CLOCK_GATE_HIGH_RegFileDual_DATA_WIDTH34_30
+ $PINS CLK=CTS_782 EN=N66 ENCLK=CTS_630 CLK_clone1=clk_clone6
Xclk_gate_bank_mem_0_reg[1]_0 SNPS_CLOCK_GATE_HIGH_RegFileDual_DATA_WIDTH34_29
+ $PINS EN=N66 ENCLK=CTS_627 CLK=clk_clone6
Xclk_gate_bank_mem_0_reg[2] SNPS_CLOCK_GATE_HIGH_RegFileDual_DATA_WIDTH34_28
+ $PINS CLK=CTS_782 EN=N65 ENCLK=CTS_624 CLK_clone1=clk_clone6
Xclk_gate_bank_mem_0_reg[2]_0 SNPS_CLOCK_GATE_HIGH_RegFileDual_DATA_WIDTH34_27
+ $PINS EN=N65 ENCLK=CTS_621 CLK=clk_clone6
Xclk_gate_bank_mem_0_reg[3] SNPS_CLOCK_GATE_HIGH_RegFileDual_DATA_WIDTH34_26
+ $PINS CLK=CTS_782 EN=N64 ENCLK=CTS_618 CLK_clone1=clk_clone6
Xclk_gate_bank_mem_0_reg[3]_0 SNPS_CLOCK_GATE_HIGH_RegFileDual_DATA_WIDTH34_25
+ $PINS EN=N64 ENCLK=CTS_775 CLK=CTS_782
Xclk_gate_bank_mem_0_reg[4] SNPS_CLOCK_GATE_HIGH_RegFileDual_DATA_WIDTH34_24
+ $PINS EN=N63 ENCLK=CTS_772 CLK=CTS_782
Xclk_gate_bank_mem_0_reg[4]_0 SNPS_CLOCK_GATE_HIGH_RegFileDual_DATA_WIDTH34_23
+ $PINS EN=N63 ENCLK=CTS_769 CLK=CTS_782
Xclk_gate_bank_mem_0_reg[5] SNPS_CLOCK_GATE_HIGH_RegFileDual_DATA_WIDTH34_22
+ $PINS EN=N62 ENCLK=CTS_766 CLK=CTS_782
Xclk_gate_bank_mem_0_reg[5]_0 SNPS_CLOCK_GATE_HIGH_RegFileDual_DATA_WIDTH34_21
+ $PINS EN=N62 ENCLK=CTS_763 CLK=CTS_782
Xclk_gate_bank_mem_0_reg[6] SNPS_CLOCK_GATE_HIGH_RegFileDual_DATA_WIDTH34_20
+ $PINS EN=N61 ENCLK=CTS_760 CLK=CTS_782
Xclk_gate_bank_mem_0_reg[6]_0 SNPS_CLOCK_GATE_HIGH_RegFileDual_DATA_WIDTH34_19
+ $PINS EN=N61 ENCLK=CTS_757 CLK=CTS_782
Xclk_gate_bank_mem_0_reg[7] SNPS_CLOCK_GATE_HIGH_RegFileDual_DATA_WIDTH34_18
+ $PINS EN=N60 ENCLK=CTS_754 CLK=CTS_782
Xclk_gate_bank_mem_0_reg[7]_0 SNPS_CLOCK_GATE_HIGH_RegFileDual_DATA_WIDTH34_17
+ $PINS EN=N60 ENCLK=CTS_751 CLK=CTS_782
Xclk_gate_bank_mem_0_reg[8] SNPS_CLOCK_GATE_HIGH_RegFileDual_DATA_WIDTH34_16
+ $PINS EN=N59 ENCLK=CTS_736 CLK=clk_clone4
Xclk_gate_bank_mem_0_reg[8]_0 SNPS_CLOCK_GATE_HIGH_RegFileDual_DATA_WIDTH34_15
+ $PINS EN=N59 ENCLK=CTS_733 CLK=clk_clone4
Xclk_gate_bank_mem_0_reg[9] SNPS_CLOCK_GATE_HIGH_RegFileDual_DATA_WIDTH34_14
+ $PINS EN=N58 ENCLK=CTS_730 CLK=clk_clone4
Xclk_gate_bank_mem_0_reg[9]_0 SNPS_CLOCK_GATE_HIGH_RegFileDual_DATA_WIDTH34_13
+ $PINS EN=N58 ENCLK=CTS_727 CLK=clk_clone4
Xclk_gate_bank_mem_0_reg[10] SNPS_CLOCK_GATE_HIGH_RegFileDual_DATA_WIDTH34_12
+ $PINS EN=N57 ENCLK=CTS_724 CLK=clk_clone4
Xclk_gate_bank_mem_0_reg[10]_0 SNPS_CLOCK_GATE_HIGH_RegFileDual_DATA_WIDTH34_11
+ $PINS EN=N57 ENCLK=CTS_721 CLK=clk_clone4
Xclk_gate_bank_mem_0_reg[11] SNPS_CLOCK_GATE_HIGH_RegFileDual_DATA_WIDTH34_10
+ $PINS EN=N56 ENCLK=CTS_718 CLK=clk_clone4
Xclk_gate_bank_mem_0_reg[11]_0 SNPS_CLOCK_GATE_HIGH_RegFileDual_DATA_WIDTH34_9
+ $PINS EN=N56 ENCLK=CTS_715 CLK=clk_clone4
Xclk_gate_bank_mem_0_reg[12] SNPS_CLOCK_GATE_HIGH_RegFileDual_DATA_WIDTH34_8
+ $PINS EN=N55 ENCLK=CTS_748 CLK=CTS_782
Xclk_gate_bank_mem_0_reg[12]_0 SNPS_CLOCK_GATE_HIGH_RegFileDual_DATA_WIDTH34_7
+ $PINS EN=N55 ENCLK=CTS_745 CLK=CTS_782
Xclk_gate_bank_mem_0_reg[13] SNPS_CLOCK_GATE_HIGH_RegFileDual_DATA_WIDTH34_6
+ $PINS EN=N54 ENCLK=CTS_742 CLK=CTS_782
Xclk_gate_bank_mem_0_reg[13]_0 SNPS_CLOCK_GATE_HIGH_RegFileDual_DATA_WIDTH34_5
+ $PINS EN=N54 ENCLK=CTS_712 CLK=clk_clone4
Xclk_gate_bank_mem_0_reg[14] SNPS_CLOCK_GATE_HIGH_RegFileDual_DATA_WIDTH34_4
+ $PINS EN=N53 ENCLK=CTS_709 CLK=clk_clone4
Xclk_gate_bank_mem_0_reg[14]_0 SNPS_CLOCK_GATE_HIGH_RegFileDual_DATA_WIDTH34_3
+ $PINS EN=N53 ENCLK=CTS_706 CLK=clk_clone4
Xclk_gate_bank_mem_0_reg[15] SNPS_CLOCK_GATE_HIGH_RegFileDual_DATA_WIDTH34_2
+ $PINS EN=N52 ENCLK=CTS_739 CLK=CTS_782
Xclk_gate_bank_mem_0_reg[15]_0 SNPS_CLOCK_GATE_HIGH_RegFileDual_DATA_WIDTH34_1
+ $PINS EN=N52 ENCLK=CTS_703 CLK=clk_clone4
.ENDS

.SUBCKT SNPS_CLOCK_GATE_HIGH_RegFileDual_DATA_WIDTH22_0 EN ENCLK CLK
*.CONNECT net1674 EN
XFE_PHC954_net1677 DELC $PINS O=FE_PHN954_net1677 I=net1677
Xlatch QDBHN $PINS Q=net1677 D=net1674 CKB=CLK
Xmain_gate AN2T $PINS O=ENCLK I1=FE_PHN954_net1677 I2=CLK
.ENDS

.SUBCKT SNPS_CLOCK_GATE_HIGH_RegFileDual_DATA_WIDTH22_31 EN ENCLK CLK
*.CONNECT net1674 EN
XFE_PHC888_net1677 DELC $PINS O=FE_PHN888_net1677 I=net1677
Xlatch QDBHN $PINS Q=net1677 D=net1674 CKB=CLK
Xmain_gate AN2T $PINS O=ENCLK I1=FE_PHN888_net1677 I2=CLK
.ENDS

.SUBCKT SNPS_CLOCK_GATE_HIGH_RegFileDual_DATA_WIDTH22_30 EN ENCLK CLK
*.CONNECT net1674 EN
XFE_PHC1007_net1677 DELC $PINS O=net1677 I=FE_PHN1007_net1677
Xlatch QDBHN $PINS Q=FE_PHN1007_net1677 D=net1674 CKB=CLK
Xmain_gate AN2T $PINS O=ENCLK I1=net1677 I2=CLK
.ENDS

.SUBCKT SNPS_CLOCK_GATE_HIGH_RegFileDual_DATA_WIDTH22_29 EN ENCLK CLK
*.CONNECT net1674 EN
XFE_PHC880_net1677 DELC $PINS O=FE_PHN880_net1677 I=net1677
Xlatch QDBHN $PINS Q=net1677 D=net1674 CKB=CLK
Xmain_gate AN2T $PINS O=ENCLK I1=FE_PHN880_net1677 I2=CLK
.ENDS

.SUBCKT SNPS_CLOCK_GATE_HIGH_RegFileDual_DATA_WIDTH22_28 EN ENCLK CLK
*.CONNECT net1674 EN
XFE_PHC925_net1677 DELC $PINS O=FE_PHN925_net1677 I=net1677
Xlatch QDBHN $PINS Q=net1677 D=net1674 CKB=CLK
Xmain_gate AN2T $PINS O=ENCLK I1=FE_PHN925_net1677 I2=CLK
.ENDS

.SUBCKT SNPS_CLOCK_GATE_HIGH_RegFileDual_DATA_WIDTH22_27 EN ENCLK CLK
*.CONNECT net1674 EN
XFE_PHC960_net1677 DELC $PINS O=FE_PHN960_net1677 I=net1677
Xlatch QDBHN $PINS Q=net1677 D=net1674 CKB=CLK
Xmain_gate AN2T $PINS O=ENCLK I1=FE_PHN960_net1677 I2=CLK
.ENDS

.SUBCKT SNPS_CLOCK_GATE_HIGH_RegFileDual_DATA_WIDTH22_26 EN ENCLK CLK
*.CONNECT net1674 EN
XFE_PHC971_net1677 DELC $PINS O=net1677 I=FE_PHN971_net1677
Xlatch QDBHN $PINS Q=FE_PHN971_net1677 D=net1674 CKB=CLK
Xmain_gate AN2T $PINS O=ENCLK I1=net1677 I2=CLK
.ENDS

.SUBCKT SNPS_CLOCK_GATE_HIGH_RegFileDual_DATA_WIDTH22_25 EN ENCLK CLK
*.CONNECT net1674 EN
XFE_PHC897_net1677 DELC $PINS O=FE_PHN897_net1677 I=net1677
Xlatch QDBHN $PINS Q=net1677 D=net1674 CKB=CLK
Xmain_gate AN2T $PINS O=ENCLK I1=FE_PHN897_net1677 I2=CLK
.ENDS

.SUBCKT SNPS_CLOCK_GATE_HIGH_RegFileDual_DATA_WIDTH22_24 EN ENCLK CLK
*.CONNECT net1674 EN
XFE_PHC907_net1677 DELC $PINS O=FE_PHN907_net1677 I=net1677
Xlatch QDBHN $PINS Q=net1677 D=net1674 CKB=CLK
Xmain_gate AN2T $PINS O=ENCLK I1=FE_PHN907_net1677 I2=CLK
.ENDS

.SUBCKT SNPS_CLOCK_GATE_HIGH_RegFileDual_DATA_WIDTH22_23 EN ENCLK CLK
*.CONNECT net1674 EN
XFE_PHC879_net1677 DELC $PINS O=FE_PHN879_net1677 I=net1677
Xlatch QDBHN $PINS Q=net1677 D=net1674 CKB=CLK
Xmain_gate AN2T $PINS O=ENCLK I1=FE_PHN879_net1677 I2=CLK
.ENDS

.SUBCKT SNPS_CLOCK_GATE_HIGH_RegFileDual_DATA_WIDTH22_22 EN ENCLK CLK
*.CONNECT net1674 EN
XFE_PHC998_net1677 DELC $PINS O=FE_PHN998_net1677 I=net1677
Xlatch QDBHN $PINS Q=net1677 D=net1674 CKB=CLK
Xmain_gate AN2T $PINS O=ENCLK I1=FE_PHN998_net1677 I2=CLK
.ENDS

.SUBCKT SNPS_CLOCK_GATE_HIGH_RegFileDual_DATA_WIDTH22_21 EN ENCLK CLK
*.CONNECT net1674 EN
XFE_PHC937_net1677 DELC $PINS O=FE_PHN937_net1677 I=net1677
Xlatch QDBHN $PINS Q=net1677 D=net1674 CKB=CLK
Xmain_gate AN2T $PINS O=ENCLK I1=FE_PHN937_net1677 I2=CLK
.ENDS

.SUBCKT SNPS_CLOCK_GATE_HIGH_RegFileDual_DATA_WIDTH22_20 EN ENCLK CLK
*.CONNECT net1674 EN
XFE_PHC916_net1677 DELC $PINS O=FE_PHN916_net1677 I=net1677
Xlatch QDBHN $PINS Q=net1677 D=net1674 CKB=CLK
Xmain_gate AN2T $PINS O=ENCLK I1=FE_PHN916_net1677 I2=CLK
.ENDS

.SUBCKT SNPS_CLOCK_GATE_HIGH_RegFileDual_DATA_WIDTH22_19 EN ENCLK CLK
*.CONNECT net1674 EN
XFE_PHC878_net1677 DELC $PINS O=FE_PHN878_net1677 I=net1677
Xlatch QDBHN $PINS Q=net1677 D=net1674 CKB=CLK
Xmain_gate AN2T $PINS O=ENCLK I1=FE_PHN878_net1677 I2=CLK
.ENDS

.SUBCKT SNPS_CLOCK_GATE_HIGH_RegFileDual_DATA_WIDTH22_18 EN ENCLK CLK
*.CONNECT net1674 EN
XFE_PHC953_net1677 DELC $PINS O=net1677 I=FE_PHN953_net1677
Xlatch QDBHN $PINS Q=FE_PHN953_net1677 D=net1674 CKB=CLK
Xmain_gate AN2T $PINS O=ENCLK I1=net1677 I2=CLK
.ENDS

.SUBCKT SNPS_CLOCK_GATE_HIGH_RegFileDual_DATA_WIDTH22_17 EN ENCLK CLK
*.CONNECT net1674 EN
XFE_PHC901_net1677 DELC $PINS O=FE_PHN901_net1677 I=net1677
Xlatch QDBHN $PINS Q=net1677 D=net1674 CKB=CLK
Xmain_gate AN2T $PINS O=ENCLK I1=FE_PHN901_net1677 I2=CLK
.ENDS

.SUBCKT SNPS_CLOCK_GATE_HIGH_RegFileDual_DATA_WIDTH22_16 EN ENCLK CLK
*.CONNECT net1674 EN
XFE_PHC962_net1677 DELC $PINS O=FE_PHN962_net1677 I=net1677
Xlatch QDBHN $PINS Q=net1677 D=net1674 CKB=CLK
Xmain_gate AN2T $PINS O=ENCLK I1=FE_PHN962_net1677 I2=CLK
.ENDS

.SUBCKT SNPS_CLOCK_GATE_HIGH_RegFileDual_DATA_WIDTH22_15 EN ENCLK CLK
*.CONNECT net1674 EN
XFE_PHC1008_net1677 DELC $PINS O=FE_PHN1008_net1677 I=net1677
Xlatch QDBHN $PINS Q=net1677 D=net1674 CKB=CLK
Xmain_gate AN2T $PINS O=ENCLK I1=FE_PHN1008_net1677 I2=CLK
.ENDS

.SUBCKT SNPS_CLOCK_GATE_HIGH_RegFileDual_DATA_WIDTH22_14 EN ENCLK CLK
*.CONNECT net1674 EN
XFE_PHC965_net1677 DELC $PINS O=FE_PHN965_net1677 I=net1677
Xlatch QDBHN $PINS Q=net1677 D=net1674 CKB=CLK
Xmain_gate AN2T $PINS O=ENCLK I1=FE_PHN965_net1677 I2=CLK
.ENDS

.SUBCKT SNPS_CLOCK_GATE_HIGH_RegFileDual_DATA_WIDTH22_13 EN ENCLK CLK
*.CONNECT net1674 EN
XFE_PHC887_net1677 DELC $PINS O=FE_PHN887_net1677 I=net1677
Xlatch QDBHN $PINS Q=net1677 D=net1674 CKB=CLK
Xmain_gate AN2T $PINS O=ENCLK I1=FE_PHN887_net1677 I2=CLK
.ENDS

.SUBCKT SNPS_CLOCK_GATE_HIGH_RegFileDual_DATA_WIDTH22_12 EN ENCLK CLK
*.CONNECT net1674 EN
XFE_PHC936_net1677 DELC $PINS O=FE_PHN936_net1677 I=net1677
Xlatch QDBHN $PINS Q=net1677 D=net1674 CKB=CLK
Xmain_gate AN2T $PINS O=ENCLK I1=FE_PHN936_net1677 I2=CLK
.ENDS

.SUBCKT SNPS_CLOCK_GATE_HIGH_RegFileDual_DATA_WIDTH22_11 EN ENCLK CLK
*.CONNECT net1674 EN
XFE_PHC1004_net1677 DELC $PINS O=net1677 I=FE_PHN1004_net1677
Xlatch QDBHN $PINS Q=FE_PHN1004_net1677 D=net1674 CKB=CLK
Xmain_gate AN2T $PINS O=ENCLK I1=net1677 I2=CLK
.ENDS

.SUBCKT SNPS_CLOCK_GATE_HIGH_RegFileDual_DATA_WIDTH22_10 EN ENCLK CLK
*.CONNECT net1674 EN
XFE_PHC985_net1677 DELC $PINS O=FE_PHN985_net1677 I=net1677
Xlatch QDBHN $PINS Q=net1677 D=net1674 CKB=CLK
Xmain_gate AN2T $PINS O=ENCLK I1=FE_PHN985_net1677 I2=CLK
.ENDS

.SUBCKT SNPS_CLOCK_GATE_HIGH_RegFileDual_DATA_WIDTH22_9 EN ENCLK CLK
*.CONNECT net1674 EN
XFE_PHC930_net1677 DELC $PINS O=FE_PHN930_net1677 I=net1677
Xlatch QDBHN $PINS Q=net1677 D=net1674 CKB=CLK
Xmain_gate AN2T $PINS O=ENCLK I1=FE_PHN930_net1677 I2=CLK
.ENDS

.SUBCKT SNPS_CLOCK_GATE_HIGH_RegFileDual_DATA_WIDTH22_8 EN ENCLK CLK
*.CONNECT net1674 EN
XFE_PHC970_net1677 DELC $PINS O=FE_PHN970_net1677 I=net1677
Xlatch QDBHN $PINS Q=net1677 D=net1674 CKB=CLK
Xmain_gate AN2T $PINS O=ENCLK I1=FE_PHN970_net1677 I2=CLK
.ENDS

.SUBCKT SNPS_CLOCK_GATE_HIGH_RegFileDual_DATA_WIDTH22_7 EN ENCLK CLK
*.CONNECT net1674 EN
XFE_PHC944_net1677 DELC $PINS O=FE_PHN944_net1677 I=net1677
Xlatch QDBHN $PINS Q=net1677 D=net1674 CKB=CLK
Xmain_gate AN2T $PINS O=ENCLK I1=FE_PHN944_net1677 I2=CLK
.ENDS

.SUBCKT SNPS_CLOCK_GATE_HIGH_RegFileDual_DATA_WIDTH22_6 EN ENCLK CLK
*.CONNECT net1674 EN
XFE_PHC896_net1677 DELC $PINS O=FE_PHN896_net1677 I=net1677
Xlatch QDBHN $PINS Q=net1677 D=net1674 CKB=CLK
Xmain_gate AN2T $PINS O=ENCLK I1=FE_PHN896_net1677 I2=CLK
.ENDS

.SUBCKT SNPS_CLOCK_GATE_HIGH_RegFileDual_DATA_WIDTH22_5 EN ENCLK CLK
*.CONNECT net1674 EN
XFE_PHC989_net1677 DELC $PINS O=FE_PHN989_net1677 I=net1677
Xlatch QDBHN $PINS Q=net1677 D=net1674 CKB=CLK
Xmain_gate AN2T $PINS O=ENCLK I1=FE_PHN989_net1677 I2=CLK
.ENDS

.SUBCKT SNPS_CLOCK_GATE_HIGH_RegFileDual_DATA_WIDTH22_4 EN ENCLK CLK
*.CONNECT net1674 EN
XFE_PHC977_net1677 DELC $PINS O=net1677 I=FE_PHN977_net1677
Xlatch QDBHN $PINS Q=FE_PHN977_net1677 D=net1674 CKB=CLK
Xmain_gate AN2T $PINS O=ENCLK I1=net1677 I2=CLK
.ENDS

.SUBCKT SNPS_CLOCK_GATE_HIGH_RegFileDual_DATA_WIDTH22_3 EN ENCLK CLK
*.CONNECT net1674 EN
XFE_PHC979_net1677 DELC $PINS O=net1677 I=FE_PHN979_net1677
Xlatch QDBHN $PINS Q=FE_PHN979_net1677 D=net1674 CKB=CLK
Xmain_gate AN2T $PINS O=ENCLK I1=net1677 I2=CLK
.ENDS

.SUBCKT SNPS_CLOCK_GATE_HIGH_RegFileDual_DATA_WIDTH22_2 EN ENCLK CLK
*.CONNECT net1674 EN
XFE_PHC974_net1677 DELC $PINS O=net1677 I=FE_PHN974_net1677
Xlatch QDBHN $PINS Q=FE_PHN974_net1677 D=net1674 CKB=CLK
Xmain_gate AN2T $PINS O=ENCLK I1=net1677 I2=CLK
.ENDS

.SUBCKT SNPS_CLOCK_GATE_HIGH_RegFileDual_DATA_WIDTH22_1 EN ENCLK CLK
*.CONNECT net1674 EN
XFE_PHC957_net1677 DELC $PINS O=FE_PHN957_net1677 I=net1677
Xlatch QDBHN $PINS Q=net1677 D=net1674 CKB=CLK
Xmain_gate AN2T $PINS O=ENCLK I1=FE_PHN957_net1677 I2=CLK
.ENDS

.SUBCKT RegFileDual_DATA_WIDTH22 read_addr_1[4] read_addr_1[3] read_addr_1[2]
+ read_addr_1[1] read_addr_1[0] read_data_1[21] read_data_1[20] read_data_1[19]
+ read_data_1[18] read_data_1[17] read_data_1[16] read_data_1[15]
+ read_data_1[14] read_data_1[13] read_data_1[12] read_data_1[11]
+ read_data_1[10] read_data_1[9] read_data_1[8] read_data_1[7] read_data_1[6]
+ read_data_1[5] read_data_1[4] read_data_1[3] read_data_1[2] read_data_1[1]
+ read_data_1[0] wen1 wen2 write_addr_1[4] write_addr_1[3] write_addr_1[2]
+ write_addr_1[1] write_addr_1[0] write_addr_2[4] write_addr_2[3]
+ write_addr_2[2] write_addr_2[1] write_addr_2[0] write_data_1[21]
+ write_data_1[20] write_data_1[19] write_data_1[18] write_data_1[17]
+ write_data_1[16] write_data_1[15] write_data_1[14] write_data_1[13]
+ write_data_1[12] write_data_1[11] write_data_1[10] write_data_1[9]
+ write_data_1[8] write_data_1[7] write_data_1[6] write_data_1[5]
+ write_data_1[4] write_data_1[3] write_data_1[2] write_data_1[1]
+ write_data_1[0] write_data_2[21] write_data_2[20] write_data_2[19]
+ write_data_2[18] write_data_2[17] write_data_2[16] write_data_2[15]
+ write_data_2[14] write_data_2[13] write_data_2[12] write_data_2[11]
+ write_data_2[10] write_data_2[9] write_data_2[8] write_data_2[7]
+ write_data_2[6] write_data_2[5] write_data_2[4] write_data_2[3]
+ write_data_2[2] write_data_2[1] write_data_2[0] rst_n_BAR i_rst_n
+ FE_OFN27_i_rst_n FE_OFN18_i_rst_n clk_clone3 clk_clone2 clk_clone1 clk
XFE_PHC1458_n540 BUF1CK $PINS O=n540 I=FE_PHN1458_n540
XFE_PHC1455_bank_rdata_0_8 BUF1CK $PINS O=FE_PHN1455_bank_rdata_0_8
+ I=bank_rdata[0][8]
XFE_PHC1451_N116 BUF1S $PINS O=FE_PHN1451_N116 I=N116
XFE_PHC1449_N109 DELA $PINS O=FE_PHN1449_N109 I=N109
XFE_PHC1447_N103 DELB $PINS O=FE_PHN1447_N103 I=N103
XFE_PHC1444_N115 DELB $PINS O=FE_PHN1444_N115 I=N115
XFE_PHC1443_N108 DELB $PINS O=N108 I=FE_PHN1443_N108
XFE_PHC1442_N121 DELB $PINS O=N121 I=FE_PHN1442_N121
XFE_PHC1439_N106 DELB $PINS O=N106 I=FE_PHN1439_N106
XFE_PHC1438_N112 DELB $PINS O=FE_PHN1438_N112 I=N112
XFE_PHC1437_N111 DELB $PINS O=FE_PHN1437_N111 I=N111
XFE_PHC1435_N104 DELB $PINS O=N104 I=FE_PHN1435_N104
XFE_PHC1434_N122 DELB $PINS O=N122 I=FE_PHN1434_N122
XFE_PHC1433_N113 DELB $PINS O=N113 I=FE_PHN1433_N113
XFE_PHC1432_N124 DELB $PINS O=N124 I=FE_PHN1432_N124
XFE_PHC1431_N110 DELB $PINS O=N110 I=FE_PHN1431_N110
XFE_PHC1430_N114 DELB $PINS O=FE_PHN1430_N114 I=N114
XFE_PHC1429_N119 DELB $PINS O=N119 I=FE_PHN1429_N119
XFE_PHC1428_N123 DELB $PINS O=N123 I=FE_PHN1428_N123
XFE_PHC1424_N118 DELB $PINS O=FE_PHN1424_N118 I=N118
XFE_PHC1416_N107 DELB $PINS O=N107 I=FE_PHN1416_N107
XFE_PHC1364_bank_rdata_1_4 BUF1S $PINS O=FE_PHN1364_bank_rdata_1_4
+ I=bank_rdata[1][4]
XFE_PHC1074_bank_rdata_1_19 BUF1S $PINS O=FE_PHN1074_bank_rdata_1_19
+ I=bank_rdata[1][19]
XFE_PHC1071_bank_mem_1_7_4 BUF1CK $PINS O=FE_PHN1071_bank_mem_1_7_4
+ I=bank_mem_1[7][4]
XFE_PHC1069_bank_rdata_1_7 DELB $PINS O=FE_PHN1069_bank_rdata_1_7
+ I=bank_rdata[1][7]
XFE_PHC1065_bank_rdata_1_8 DELB $PINS O=FE_PHN1065_bank_rdata_1_8
+ I=bank_rdata[1][8]
XFE_PHC1063_bank_rdata_0_19 DELB $PINS O=bank_rdata[0][19]
+ I=FE_PHN1063_bank_rdata_0_19
XFE_PHC1060_bank_rdata_1_16 DELB $PINS O=FE_PHN1060_bank_rdata_1_16
+ I=bank_rdata[1][16]
XFE_PHC1059_bank_rdata_1_3 DELB $PINS O=FE_PHN1059_bank_rdata_1_3
+ I=bank_rdata[1][3]
XFE_PHC1058_bank_rdata_0_4 DELB $PINS O=FE_PHN1058_bank_rdata_0_4
+ I=bank_rdata[0][4]
XFE_PHC1057_bank_rdata_0_20 DELB $PINS O=FE_PHN1057_bank_rdata_0_20
+ I=bank_rdata[0][20]
XFE_PHC1056_bank_rdata_1_2 DELB $PINS O=FE_PHN1056_bank_rdata_1_2
+ I=bank_rdata[1][2]
XFE_PHC1055_bank_rdata_0_7 DELB $PINS O=FE_PHN1055_bank_rdata_0_7
+ I=bank_rdata[0][7]
XFE_PHC1054_bank_rdata_1_5 DELB $PINS O=bank_rdata[1][5]
+ I=FE_PHN1054_bank_rdata_1_5
XFE_PHC1039_bank_rdata_1_17 DELB $PINS O=FE_PHN1039_bank_rdata_1_17
+ I=bank_rdata[1][17]
XCTS_ccl_a_INV_CLK_G1_L8_122 INV6CK $PINS O=CTS_390 I=CTS_391
XCTS_ccl_a_INV_CLK_G1_L7_122 INV4CK $PINS O=CTS_391 I=CTS_392
XCTS_ccl_a_INV_CLK_G1_L8_121 INV6CK $PINS O=CTS_387 I=CTS_388
XCTS_ccl_a_INV_CLK_G1_L7_121 INV4CK $PINS O=CTS_388 I=CTS_389
XCTS_ccl_a_INV_CLK_G1_L8_120 INV6CK $PINS O=CTS_384 I=CTS_385
XCTS_ccl_a_INV_CLK_G1_L7_120 INV4CK $PINS O=CTS_385 I=CTS_386
XCTS_ccl_a_INV_CLK_G1_L8_119 INV6CK $PINS O=CTS_381 I=CTS_382
XCTS_ccl_a_INV_CLK_G1_L7_119 INV4CK $PINS O=CTS_382 I=CTS_383
XCTS_ccl_a_INV_CLK_G1_L8_118 INV6CK $PINS O=CTS_378 I=CTS_379
XCTS_ccl_a_INV_CLK_G1_L7_118 INV4CK $PINS O=CTS_379 I=CTS_380
XCTS_ccl_a_INV_CLK_G1_L8_117 INV6CK $PINS O=CTS_375 I=CTS_376
XCTS_ccl_a_INV_CLK_G1_L7_117 INV3CK $PINS O=CTS_376 I=CTS_377
XCTS_ccl_a_INV_CLK_G1_L8_116 INV6CK $PINS O=CTS_372 I=CTS_373
XCTS_ccl_a_INV_CLK_G1_L7_116 INV4CK $PINS O=CTS_373 I=CTS_374
XCTS_ccl_a_INV_CLK_G1_L8_115 INV6CK $PINS O=CTS_369 I=CTS_370
XCTS_ccl_a_INV_CLK_G1_L7_115 INV3CK $PINS O=CTS_370 I=CTS_371
XCTS_ccl_a_INV_CLK_G1_L8_114 INV6CK $PINS O=CTS_366 I=CTS_367
XCTS_ccl_a_INV_CLK_G1_L7_114 INV3CK $PINS O=CTS_367 I=CTS_368
XCTS_ccl_a_INV_CLK_G1_L8_113 INV6CK $PINS O=CTS_363 I=CTS_364
XCTS_ccl_a_INV_CLK_G1_L7_113 INV4CK $PINS O=CTS_364 I=CTS_365
XCTS_ccl_a_INV_CLK_G1_L8_112 INV6CK $PINS O=CTS_360 I=CTS_361
XCTS_ccl_a_INV_CLK_G1_L7_112 INV4CK $PINS O=CTS_361 I=CTS_362
XCTS_ccl_a_INV_CLK_G1_L8_111 INV6CK $PINS O=CTS_357 I=CTS_358
XCTS_ccl_a_INV_CLK_G1_L7_111 INV4CK $PINS O=CTS_358 I=CTS_359
XCTS_ccl_a_INV_CLK_G1_L8_110 INV6CK $PINS O=CTS_354 I=CTS_355
XCTS_ccl_a_INV_CLK_G1_L7_110 INV4CK $PINS O=CTS_355 I=CTS_356
XCTS_ccl_a_INV_CLK_G1_L8_109 INV6CK $PINS O=CTS_351 I=CTS_352
XCTS_ccl_a_INV_CLK_G1_L7_109 INV4CK $PINS O=CTS_352 I=CTS_353
XCTS_ccl_a_INV_CLK_G1_L8_108 INV6CK $PINS O=CTS_348 I=CTS_349
XCTS_ccl_a_INV_CLK_G1_L7_108 INV4CK $PINS O=CTS_349 I=CTS_350
XCTS_ccl_a_INV_CLK_G1_L8_107 INV6CK $PINS O=CTS_345 I=CTS_346
XCTS_ccl_a_INV_CLK_G1_L7_107 INV4CK $PINS O=CTS_346 I=CTS_347
XCTS_ccl_a_INV_CLK_G1_L8_16 INV6CK $PINS O=CTS_340 I=CTS_341
XCTS_ccl_a_INV_CLK_G1_L7_16 INV3CK $PINS O=CTS_341 I=CTS_342
XCTS_ccl_a_INV_CLK_G1_L8_15 INV6CK $PINS O=CTS_337 I=CTS_338
XCTS_ccl_a_INV_CLK_G1_L7_15 INV4CK $PINS O=CTS_338 I=CTS_339
XCTS_ccl_a_INV_CLK_G1_L8_14 INV6CK $PINS O=CTS_334 I=CTS_335
XCTS_ccl_a_INV_CLK_G1_L7_14 INV4CK $PINS O=CTS_335 I=CTS_336
XCTS_ccl_a_INV_CLK_G1_L8_13 INV6CK $PINS O=CTS_331 I=CTS_332
XCTS_ccl_a_INV_CLK_G1_L7_13 INV3CK $PINS O=CTS_332 I=CTS_333
XCTS_ccl_a_INV_CLK_G1_L8_12 INV6CK $PINS O=CTS_328 I=CTS_329
XCTS_ccl_a_INV_CLK_G1_L7_12 INV3CK $PINS O=CTS_329 I=CTS_330
XCTS_ccl_a_INV_CLK_G1_L8_11 INV6CK $PINS O=CTS_325 I=CTS_326
XCTS_ccl_a_INV_CLK_G1_L7_11 INV4CK $PINS O=CTS_326 I=CTS_327
XCTS_ccl_a_INV_CLK_G1_L8_10 INV6CK $PINS O=CTS_322 I=CTS_323
XCTS_ccl_a_INV_CLK_G1_L7_10 INV3CK $PINS O=CTS_323 I=CTS_324
XCTS_ccl_a_INV_CLK_G1_L8_9 INV6CK $PINS O=CTS_319 I=CTS_320
XCTS_ccl_a_INV_CLK_G1_L7_9 INV3CK $PINS O=CTS_320 I=CTS_321
XCTS_ccl_a_INV_CLK_G1_L8_8 INV6CK $PINS O=CTS_316 I=CTS_317
XCTS_ccl_a_INV_CLK_G1_L7_8 INV3CK $PINS O=CTS_317 I=CTS_318
XCTS_ccl_a_INV_CLK_G1_L8_7 INV6CK $PINS O=CTS_313 I=CTS_314
XCTS_ccl_a_INV_CLK_G1_L7_7 INV3CK $PINS O=CTS_314 I=CTS_315
XCTS_ccl_a_INV_CLK_G1_L8_6 INV6CK $PINS O=CTS_310 I=CTS_311
XCTS_ccl_a_INV_CLK_G1_L7_6 INV3CK $PINS O=CTS_311 I=CTS_312
XCTS_ccl_a_INV_CLK_G1_L8_5 INV6CK $PINS O=CTS_307 I=CTS_308
XCTS_ccl_a_INV_CLK_G1_L7_5 INV4CK $PINS O=CTS_308 I=CTS_309
XCTS_ccl_a_INV_CLK_G1_L8_4 INV6CK $PINS O=CTS_304 I=CTS_305
XCTS_ccl_a_INV_CLK_G1_L7_4 INV3CK $PINS O=CTS_305 I=CTS_306
XCTS_ccl_a_INV_CLK_G1_L8_3 INV6CK $PINS O=CTS_301 I=CTS_302
XCTS_ccl_a_INV_CLK_G1_L7_3 INV3CK $PINS O=CTS_302 I=CTS_303
XCTS_ccl_a_INV_CLK_G1_L8_2 INV6CK $PINS O=CTS_298 I=CTS_299
XCTS_ccl_a_INV_CLK_G1_L7_2 INV3CK $PINS O=CTS_299 I=CTS_300
XCTS_ccl_a_INV_CLK_G1_L8_1 INV6CK $PINS O=CTS_295 I=CTS_296
XCTS_ccl_a_INV_CLK_G1_L7_1 INV3CK $PINS O=CTS_296 I=CTS_297
XCTS_ccl_a_INV_CLK_G0_L5_1 INV12CK $PINS O=CTS_343 I=CTS_344
XCTS_ccl_a_INV_CLK_G0_L4_1 INV12CK $PINS O=CTS_344 I=clk_clone3
XFE_DBTC83_bank_wdata_0_21 INV1S $PINS O=FE_DBTN83_bank_wdata_0_21
+ I=bank_wdata[0][21]
XFE_DBTC82_bank_wdata_0_20 INV1S $PINS O=FE_DBTN82_bank_wdata_0_20
+ I=bank_wdata[0][20]
XFE_DBTC81_bank_wdata_0_18 INV1S $PINS O=FE_DBTN81_bank_wdata_0_18
+ I=bank_wdata[0][18]
XFE_DBTC80_bank_wdata_0_17 INV1S $PINS O=FE_DBTN80_bank_wdata_0_17
+ I=bank_wdata[0][17]
XFE_DBTC79_bank_wdata_0_16 INV1S $PINS O=FE_DBTN79_bank_wdata_0_16
+ I=bank_wdata[0][16]
XFE_DBTC78_bank_wdata_0_15 INV1S $PINS O=FE_DBTN78_bank_wdata_0_15
+ I=bank_wdata[0][15]
XFE_DBTC77_bank_wdata_0_14 INV1S $PINS O=FE_DBTN77_bank_wdata_0_14
+ I=bank_wdata[0][14]
XFE_DBTC76_bank_wdata_0_13 INV1S $PINS O=FE_DBTN76_bank_wdata_0_13
+ I=bank_wdata[0][13]
XFE_DBTC75_bank_wdata_0_12 INV1S $PINS O=FE_DBTN75_bank_wdata_0_12
+ I=bank_wdata[0][12]
XFE_DBTC74_bank_wdata_0_11 INV1S $PINS O=FE_DBTN74_bank_wdata_0_11
+ I=bank_wdata[0][11]
XFE_DBTC73_bank_wdata_0_10 INV1S $PINS O=FE_DBTN73_bank_wdata_0_10
+ I=bank_wdata[0][10]
XFE_DBTC72_bank_wdata_0_9 INV1S $PINS O=FE_DBTN72_bank_wdata_0_9
+ I=bank_wdata[0][9]
XFE_DBTC71_bank_wdata_0_8 INV1S $PINS O=FE_DBTN71_bank_wdata_0_8
+ I=bank_wdata[0][8]
XFE_DBTC70_bank_wdata_0_7 INV1S $PINS O=FE_DBTN70_bank_wdata_0_7
+ I=bank_wdata[0][7]
XFE_DBTC69_bank_wdata_0_6 INV1S $PINS O=FE_DBTN69_bank_wdata_0_6
+ I=bank_wdata[0][6]
XFE_DBTC68_bank_wdata_0_5 INV1S $PINS O=FE_DBTN68_bank_wdata_0_5
+ I=bank_wdata[0][5]
XFE_DBTC67_bank_wdata_0_4 INV1S $PINS O=FE_DBTN67_bank_wdata_0_4
+ I=bank_wdata[0][4]
XFE_DBTC66_bank_wdata_0_3 INV1S $PINS O=FE_DBTN66_bank_wdata_0_3
+ I=bank_wdata[0][3]
XFE_DBTC65_bank_wdata_0_2 INV1S $PINS O=FE_DBTN65_bank_wdata_0_2
+ I=bank_wdata[0][2]
XFE_DBTC64_bank_wdata_0_1 INV1S $PINS O=FE_DBTN64_bank_wdata_0_1
+ I=bank_wdata[0][1]
XFE_DBTC63_bank_wdata_0_0 INV1S $PINS O=FE_DBTN63_bank_wdata_0_0
+ I=bank_wdata[0][0]
XFE_DBTC62_bank_wdata_1_21 INV1S $PINS O=FE_DBTN62_bank_wdata_1_21
+ I=bank_wdata[1][21]
XFE_DBTC61_bank_wdata_1_20 INV1S $PINS O=FE_DBTN61_bank_wdata_1_20
+ I=bank_wdata[1][20]
XFE_DBTC60_bank_wdata_1_19 INV1S $PINS O=FE_DBTN60_bank_wdata_1_19
+ I=bank_wdata[1][19]
XFE_DBTC59_bank_wdata_1_18 INV1S $PINS O=FE_DBTN59_bank_wdata_1_18
+ I=bank_wdata[1][18]
XFE_DBTC58_bank_wdata_1_17 INV1S $PINS O=FE_DBTN58_bank_wdata_1_17
+ I=bank_wdata[1][17]
XFE_DBTC57_bank_wdata_1_16 INV1S $PINS O=FE_DBTN57_bank_wdata_1_16
+ I=bank_wdata[1][16]
XFE_DBTC56_bank_wdata_1_15 INV1S $PINS O=FE_DBTN56_bank_wdata_1_15
+ I=bank_wdata[1][15]
XFE_DBTC55_bank_wdata_1_14 INV1S $PINS O=FE_DBTN55_bank_wdata_1_14
+ I=bank_wdata[1][14]
XFE_DBTC54_bank_wdata_1_13 INV1S $PINS O=FE_DBTN54_bank_wdata_1_13
+ I=bank_wdata[1][13]
XFE_DBTC53_bank_wdata_1_12 INV1S $PINS O=FE_DBTN53_bank_wdata_1_12
+ I=bank_wdata[1][12]
XFE_DBTC52_bank_wdata_1_11 INV1S $PINS O=FE_DBTN52_bank_wdata_1_11
+ I=bank_wdata[1][11]
XFE_DBTC51_bank_wdata_1_10 INV1S $PINS O=FE_DBTN51_bank_wdata_1_10
+ I=bank_wdata[1][10]
XFE_DBTC50_bank_wdata_1_9 INV1S $PINS O=FE_DBTN50_bank_wdata_1_9
+ I=bank_wdata[1][9]
XFE_DBTC49_bank_wdata_1_8 INV1S $PINS O=FE_DBTN49_bank_wdata_1_8
+ I=bank_wdata[1][8]
XFE_DBTC48_bank_wdata_1_7 INV1S $PINS O=FE_DBTN48_bank_wdata_1_7
+ I=bank_wdata[1][7]
XFE_DBTC47_bank_wdata_1_6 INV1S $PINS O=FE_DBTN47_bank_wdata_1_6
+ I=bank_wdata[1][6]
XFE_DBTC46_bank_wdata_1_5 INV1S $PINS O=FE_DBTN46_bank_wdata_1_5
+ I=bank_wdata[1][5]
XFE_DBTC45_bank_wdata_1_4 INV1S $PINS O=FE_DBTN45_bank_wdata_1_4
+ I=bank_wdata[1][4]
XFE_DBTC44_bank_wdata_1_3 INV1S $PINS O=FE_DBTN44_bank_wdata_1_3
+ I=bank_wdata[1][3]
XFE_DBTC43_bank_wdata_1_2 INV1S $PINS O=FE_DBTN43_bank_wdata_1_2
+ I=bank_wdata[1][2]
XFE_DBTC42_bank_wdata_1_1 INV1S $PINS O=FE_DBTN42_bank_wdata_1_1
+ I=bank_wdata[1][1]
XFE_DBTC41_bank_wdata_1_0 INV1S $PINS O=FE_DBTN41_bank_wdata_1_0
+ I=bank_wdata[1][0]
XFE_DBTC40_n2 INV1S $PINS O=FE_DBTN40_n2 I=n2
XFE_DBTC39_n3 INV1S $PINS O=FE_DBTN39_n3 I=n3
XFE_DBTC38_n4 INV1S $PINS O=FE_DBTN38_n4 I=n4
XFE_DBTC37_n5 INV1S $PINS O=FE_DBTN37_n5 I=n5
XFE_DBTC36_n6 INV1S $PINS O=FE_DBTN36_n6 I=n6
XFE_DBTC35_n7 INV1S $PINS O=FE_DBTN35_n7 I=n7
XFE_DBTC34_n8 INV1S $PINS O=FE_DBTN34_n8 I=n8
XFE_DBTC33_n9 INV1S $PINS O=FE_DBTN33_n9 I=n9
XFE_DBTC32_n10 INV1S $PINS O=FE_DBTN32_n10 I=n10
XFE_DBTC31_n744 INV1S $PINS O=FE_DBTN31_n744 I=n744
XFE_DBTC30_n466 INV1S $PINS O=FE_DBTN30_n466 I=n466
XFE_DBTC29_n198 INV1S $PINS O=FE_DBTN29_n198 I=n198
XFE_DBTC28_n197 INV1S $PINS O=FE_DBTN28_n197 I=n197
XFE_DBTC27_n202 INV1S $PINS O=FE_DBTN27_n202 I=n202
XFE_DBTC26_n201 INV1S $PINS O=FE_DBTN26_n201 I=n201
XFE_DBTC25_n200 INV1S $PINS O=FE_DBTN25_n200 I=n200
XFE_DBTC24_n199 INV1S $PINS O=FE_DBTN24_n199 I=n199
XFE_DBTC23_n729 INV1S $PINS O=FE_DBTN23_n729 I=n729
XFE_DBTC22_n451 INV1S $PINS O=FE_DBTN22_n451 I=n451
XFE_DBTC21_n196 INV1S $PINS O=FE_DBTN21_n196 I=n196
XFE_DBTC20_n195 INV1S $PINS O=FE_DBTN20_n195 I=n195
XFE_DBTC19_n746 INV1S $PINS O=FE_DBTN19_n746 I=n746
XFE_DBTC18_n468 INV1S $PINS O=FE_DBTN18_n468 I=n468
Xbank_raddr_reg[0][3] QDLHN $PINS Q=N30 D=read_addr_1[4] CK=n98
Xbank_raddr_reg[0][2] QDLHN $PINS Q=N29 D=read_addr_1[3] CK=n98
Xbank_raddr_reg[0][1] QDLHN $PINS Q=N28 D=read_addr_1[2] CK=n98
Xbank_raddr_reg[0][0] QDLHN $PINS Q=N27 D=read_addr_1[1] CK=n98
Xbank_raddr_reg[1][3] QDBHN $PINS Q=N34 D=read_addr_1[4] CKB=n98
Xbank_raddr_reg[1][2] QDBHN $PINS Q=N33 D=read_addr_1[3] CKB=n98
Xbank_raddr_reg[1][1] QDBHN $PINS Q=N32 D=read_addr_1[2] CKB=n98
Xbank_raddr_reg[1][0] QDBHN $PINS Q=N31 D=read_addr_1[1] CKB=n98
XU90 OAI22S $PINS O=n76 A1=n834 A2=n61 B1=n835 B2=n62
XU155 ND2 $PINS O=n68 I1=n825 I2=n75
XU156 ND2 $PINS O=n69 I1=n826 I2=n76
XU157 ND2 $PINS O=n73 I1=n827 I2=n77
XU158 ND2 $PINS O=n74 I1=n77 I2=n72
XU159 ND2 $PINS O=n70 I1=n75 I2=n76
XU160 ND2 $PINS O=n78 I1=n84 I2=n831
XU161 ND2 $PINS O=n80 I1=n84 I2=n85
XU162 ND2 $PINS O=n86 I1=n88 I2=wen1
XU163 ND2 $PINS O=n79 I1=n830 I2=n829
XU164 ND2 $PINS O=n81 I1=n830 I2=n91
XU165 ND2 $PINS O=n82 I1=n829 I2=n92
XU166 ND2 $PINS O=n89 I1=n831 I2=n87
XU167 ND2 $PINS O=n90 I1=n87 I2=n85
XU168 ND2 $PINS O=n83 I1=n91 I2=n92
XU169 OR2B1 $PINS O=n63 I1=n93 B1=wen2
XU170 AO22 $PINS O=FE_PHN1432_N124 A1=bank_rdata[0][0] A2=n98
+ B1=bank_rdata[1][0] B2=n765
XU171 AO22 $PINS O=FE_PHN1428_N123 A1=bank_rdata[0][1] A2=n98
+ B1=bank_rdata[1][1] B2=n765
XU172 AO22 $PINS O=FE_PHN1434_N122 A1=bank_rdata[0][2] A2=n98
+ B1=FE_PHN1056_bank_rdata_1_2 B2=n765
XU173 AO22 $PINS O=FE_PHN1442_N121 A1=bank_rdata[0][3] A2=n98
+ B1=FE_PHN1059_bank_rdata_1_3 B2=n765
XU174 AO22 $PINS O=N120 A1=FE_PHN1058_bank_rdata_0_4 A2=n98
+ B1=FE_PHN1364_bank_rdata_1_4 B2=n765
XU175 AO22 $PINS O=FE_PHN1429_N119 A1=bank_rdata[0][5] A2=n98
+ B1=bank_rdata[1][5] B2=n765
XU176 AO22 $PINS O=N118 A1=bank_rdata[0][6] A2=n98 B1=bank_rdata[1][6] B2=n765
XU177 AO22 $PINS O=N117 A1=FE_PHN1055_bank_rdata_0_7 A2=n98
+ B1=FE_PHN1069_bank_rdata_1_7 B2=n765
XU178 AO22 $PINS O=N116 A1=FE_PHN1455_bank_rdata_0_8 A2=n98
+ B1=FE_PHN1065_bank_rdata_1_8 B2=n765
XU179 AO22 $PINS O=N115 A1=bank_rdata[0][9] A2=n98 B1=bank_rdata[1][9] B2=n765
XU180 AO22 $PINS O=N114 A1=bank_rdata[0][10] A2=n98 B1=bank_rdata[1][10]
+ B2=n765
XU181 AO22 $PINS O=FE_PHN1433_N113 A1=bank_rdata[0][11] A2=n98
+ B1=bank_rdata[1][11] B2=n765
XU182 AO22 $PINS O=N112 A1=bank_rdata[0][12] A2=n98 B1=bank_rdata[1][12]
+ B2=n765
XU183 AO22 $PINS O=N111 A1=bank_rdata[0][13] A2=n98 B1=bank_rdata[1][13]
+ B2=n765
XU184 AO22 $PINS O=FE_PHN1431_N110 A1=bank_rdata[0][14] A2=n98
+ B1=bank_rdata[1][14] B2=n765
XU185 AO22 $PINS O=N109 A1=bank_rdata[0][15] A2=n98 B1=bank_rdata[1][15]
+ B2=n765
XU186 AO22 $PINS O=FE_PHN1443_N108 A1=bank_rdata[0][16] A2=n98
+ B1=FE_PHN1060_bank_rdata_1_16 B2=n765
XU187 AO22 $PINS O=FE_PHN1416_N107 A1=bank_rdata[0][17] A2=n98
+ B1=FE_PHN1039_bank_rdata_1_17 B2=n765
XU192 XOR4 $PINS O=n98 I1=read_addr_1[1] I2=read_addr_1[0] I3=n94
+ I4=read_addr_1[2]
XU193 ND2 $PINS O=n67 I1=n827 I2=n71
XU194 ND2 $PINS O=n95 I1=wen1 I2=n828
XU195 ND2 $PINS O=n66 I1=n825 I2=n826
XU196 XOR4 $PINS O=n88 I1=write_addr_1[2] I2=n96 I3=n838 I4=write_addr_1[0]
XU197 ND2 $PINS O=n61 I1=wen2 I2=n93
XU198 XOR4 $PINS O=n93 I1=n832 I2=n97 I3=n778 I4=write_addr_2[0]
Xread_data_1_reg[21] QDFFRBN $PINS Q=read_data_1[21] D=FE_PHN1447_N103
+ CK=clk_clone2 RB=i_rst_n
Xread_data_1_reg[20] QDFFRBN $PINS Q=read_data_1[20] D=N104 CK=clk_clone2
+ RB=FE_OFN27_i_rst_n
Xread_data_1_reg[19] QDFFRBN $PINS Q=read_data_1[19] D=N105 CK=clk_clone2
+ RB=i_rst_n
Xread_data_1_reg[18] QDFFRBN $PINS Q=read_data_1[18] D=N106 CK=clk
+ RB=FE_OFN18_i_rst_n
Xread_data_1_reg[17] QDFFRBN $PINS Q=read_data_1[17] D=N107 CK=clk
+ RB=FE_OFN18_i_rst_n
Xread_data_1_reg[16] QDFFRBN $PINS Q=read_data_1[16] D=N108 CK=clk
+ RB=FE_OFN18_i_rst_n
Xbank_mem_1_reg[6][21] QDFFN $PINS Q=bank_mem_1[6][21]
+ D=FE_DBTN62_bank_wdata_1_21 CK=CTS_322
Xbank_mem_1_reg[6][20] QDFFN $PINS Q=bank_mem_1[6][20]
+ D=FE_DBTN61_bank_wdata_1_20 CK=CTS_322
Xbank_mem_1_reg[6][19] QDFFN $PINS Q=bank_mem_1[6][19]
+ D=FE_DBTN60_bank_wdata_1_19 CK=CTS_322
Xbank_mem_1_reg[6][18] QDFFN $PINS Q=bank_mem_1[6][18]
+ D=FE_DBTN59_bank_wdata_1_18 CK=CTS_322
Xbank_mem_1_reg[6][17] QDFFN $PINS Q=bank_mem_1[6][17]
+ D=FE_DBTN58_bank_wdata_1_17 CK=CTS_322
Xbank_mem_1_reg[6][16] QDFFN $PINS Q=bank_mem_1[6][16]
+ D=FE_DBTN57_bank_wdata_1_16 CK=CTS_322
Xbank_mem_1_reg[6][15] QDFFN $PINS Q=bank_mem_1[6][15]
+ D=FE_DBTN56_bank_wdata_1_15 CK=CTS_322
Xbank_mem_1_reg[6][14] QDFFN $PINS Q=bank_mem_1[6][14]
+ D=FE_DBTN55_bank_wdata_1_14 CK=CTS_322
Xbank_mem_1_reg[6][13] QDFFN $PINS Q=bank_mem_1[6][13]
+ D=FE_DBTN54_bank_wdata_1_13 CK=CTS_322
Xbank_mem_1_reg[6][12] QDFFN $PINS Q=bank_mem_1[6][12]
+ D=FE_DBTN53_bank_wdata_1_12 CK=CTS_322
Xbank_mem_1_reg[6][11] QDFFN $PINS Q=bank_mem_1[6][11]
+ D=FE_DBTN52_bank_wdata_1_11 CK=CTS_322
Xbank_mem_1_reg[6][10] QDFFN $PINS Q=bank_mem_1[6][10]
+ D=FE_DBTN51_bank_wdata_1_10 CK=CTS_322
Xbank_mem_1_reg[6][9] QDFFN $PINS Q=bank_mem_1[6][9] D=FE_DBTN50_bank_wdata_1_9
+ CK=CTS_322
Xbank_mem_1_reg[6][8] QDFFN $PINS Q=bank_mem_1[6][8] D=FE_DBTN49_bank_wdata_1_8
+ CK=CTS_322
Xbank_mem_1_reg[6][7] QDFFN $PINS Q=bank_mem_1[6][7] D=FE_DBTN48_bank_wdata_1_7
+ CK=CTS_322
Xbank_mem_1_reg[6][6] QDFFN $PINS Q=bank_mem_1[6][6] D=FE_DBTN47_bank_wdata_1_6
+ CK=CTS_322
Xbank_mem_1_reg[6][5] QDFFN $PINS Q=bank_mem_1[6][5] D=FE_DBTN46_bank_wdata_1_5
+ CK=CTS_322
Xbank_mem_1_reg[6][4] QDFFN $PINS Q=bank_mem_1[6][4] D=FE_DBTN45_bank_wdata_1_4
+ CK=CTS_322
Xbank_mem_1_reg[6][3] QDFFN $PINS Q=bank_mem_1[6][3] D=FE_DBTN44_bank_wdata_1_3
+ CK=CTS_322
Xbank_mem_1_reg[6][2] QDFFN $PINS Q=bank_mem_1[6][2] D=FE_DBTN43_bank_wdata_1_2
+ CK=CTS_322
Xbank_mem_1_reg[6][1] QDFFN $PINS Q=bank_mem_1[6][1] D=FE_DBTN42_bank_wdata_1_1
+ CK=CTS_322
Xbank_mem_1_reg[6][0] QDFFN $PINS Q=bank_mem_1[6][0] D=FE_DBTN41_bank_wdata_1_0
+ CK=CTS_322
Xbank_mem_1_reg[7][20] QDFFN $PINS Q=bank_mem_1[7][20]
+ D=FE_DBTN61_bank_wdata_1_20 CK=CTS_319
Xbank_mem_1_reg[7][19] QDFFN $PINS Q=bank_mem_1[7][19]
+ D=FE_DBTN60_bank_wdata_1_19 CK=CTS_319
Xbank_mem_1_reg[7][18] QDFFN $PINS Q=bank_mem_1[7][18]
+ D=FE_DBTN59_bank_wdata_1_18 CK=CTS_319
Xbank_mem_1_reg[7][17] QDFFN $PINS Q=bank_mem_1[7][17]
+ D=FE_DBTN58_bank_wdata_1_17 CK=CTS_319
Xbank_mem_1_reg[7][16] QDFFN $PINS Q=bank_mem_1[7][16]
+ D=FE_DBTN57_bank_wdata_1_16 CK=CTS_319
Xbank_mem_1_reg[7][15] QDFFN $PINS Q=bank_mem_1[7][15]
+ D=FE_DBTN56_bank_wdata_1_15 CK=CTS_319
Xbank_mem_1_reg[7][14] QDFFN $PINS Q=bank_mem_1[7][14]
+ D=FE_DBTN55_bank_wdata_1_14 CK=CTS_319
Xbank_mem_1_reg[7][13] QDFFN $PINS Q=bank_mem_1[7][13]
+ D=FE_DBTN54_bank_wdata_1_13 CK=CTS_319
Xbank_mem_1_reg[7][12] QDFFN $PINS Q=bank_mem_1[7][12]
+ D=FE_DBTN53_bank_wdata_1_12 CK=CTS_319
Xbank_mem_1_reg[7][11] QDFFN $PINS Q=bank_mem_1[7][11]
+ D=FE_DBTN52_bank_wdata_1_11 CK=CTS_319
Xbank_mem_1_reg[7][10] QDFFN $PINS Q=bank_mem_1[7][10]
+ D=FE_DBTN51_bank_wdata_1_10 CK=CTS_319
Xbank_mem_1_reg[7][9] QDFFN $PINS Q=bank_mem_1[7][9] D=FE_DBTN50_bank_wdata_1_9
+ CK=CTS_319
Xbank_mem_1_reg[7][8] QDFFN $PINS Q=bank_mem_1[7][8] D=FE_DBTN49_bank_wdata_1_8
+ CK=CTS_319
Xbank_mem_1_reg[7][7] QDFFN $PINS Q=bank_mem_1[7][7] D=FE_DBTN48_bank_wdata_1_7
+ CK=CTS_319
Xbank_mem_1_reg[7][6] QDFFN $PINS Q=bank_mem_1[7][6] D=FE_DBTN47_bank_wdata_1_6
+ CK=CTS_319
Xbank_mem_1_reg[7][5] QDFFN $PINS Q=bank_mem_1[7][5] D=FE_DBTN46_bank_wdata_1_5
+ CK=CTS_319
Xbank_mem_1_reg[7][4] QDFFN $PINS Q=bank_mem_1[7][4] D=FE_DBTN45_bank_wdata_1_4
+ CK=CTS_319
Xbank_mem_1_reg[7][3] QDFFN $PINS Q=bank_mem_1[7][3] D=FE_DBTN44_bank_wdata_1_3
+ CK=CTS_319
Xbank_mem_1_reg[7][2] QDFFN $PINS Q=bank_mem_1[7][2] D=FE_DBTN43_bank_wdata_1_2
+ CK=CTS_319
Xbank_mem_1_reg[7][1] QDFFN $PINS Q=bank_mem_1[7][1] D=FE_DBTN42_bank_wdata_1_1
+ CK=CTS_319
Xbank_mem_1_reg[7][0] QDFFN $PINS Q=bank_mem_1[7][0] D=FE_DBTN41_bank_wdata_1_0
+ CK=CTS_319
Xbank_mem_1_reg[7][21] QDFFN $PINS Q=bank_mem_1[7][21]
+ D=FE_DBTN62_bank_wdata_1_21 CK=CTS_319
Xbank_mem_1_reg[5][21] QDFFN $PINS Q=bank_mem_1[5][21]
+ D=FE_DBTN62_bank_wdata_1_21 CK=CTS_325
Xbank_mem_1_reg[5][20] QDFFN $PINS Q=bank_mem_1[5][20]
+ D=FE_DBTN61_bank_wdata_1_20 CK=CTS_325
Xbank_mem_1_reg[5][19] QDFFN $PINS Q=bank_mem_1[5][19]
+ D=FE_DBTN60_bank_wdata_1_19 CK=CTS_325
Xbank_mem_1_reg[5][18] QDFFN $PINS Q=bank_mem_1[5][18]
+ D=FE_DBTN59_bank_wdata_1_18 CK=CTS_325
Xbank_mem_1_reg[5][17] QDFFN $PINS Q=bank_mem_1[5][17]
+ D=FE_DBTN58_bank_wdata_1_17 CK=CTS_325
Xbank_mem_1_reg[5][16] QDFFN $PINS Q=bank_mem_1[5][16]
+ D=FE_DBTN57_bank_wdata_1_16 CK=CTS_325
Xbank_mem_1_reg[5][15] QDFFN $PINS Q=bank_mem_1[5][15]
+ D=FE_DBTN56_bank_wdata_1_15 CK=CTS_325
Xbank_mem_1_reg[5][14] QDFFN $PINS Q=bank_mem_1[5][14]
+ D=FE_DBTN55_bank_wdata_1_14 CK=CTS_325
Xbank_mem_1_reg[5][13] QDFFN $PINS Q=bank_mem_1[5][13]
+ D=FE_DBTN54_bank_wdata_1_13 CK=CTS_325
Xbank_mem_1_reg[5][12] QDFFN $PINS Q=bank_mem_1[5][12]
+ D=FE_DBTN53_bank_wdata_1_12 CK=CTS_325
Xbank_mem_1_reg[5][11] QDFFN $PINS Q=bank_mem_1[5][11]
+ D=FE_DBTN52_bank_wdata_1_11 CK=CTS_325
Xbank_mem_1_reg[5][10] QDFFN $PINS Q=bank_mem_1[5][10]
+ D=FE_DBTN51_bank_wdata_1_10 CK=CTS_325
Xbank_mem_1_reg[5][9] QDFFN $PINS Q=bank_mem_1[5][9] D=FE_DBTN50_bank_wdata_1_9
+ CK=CTS_325
Xbank_mem_1_reg[5][8] QDFFN $PINS Q=bank_mem_1[5][8] D=FE_DBTN49_bank_wdata_1_8
+ CK=CTS_325
Xbank_mem_1_reg[5][7] QDFFN $PINS Q=bank_mem_1[5][7] D=FE_DBTN48_bank_wdata_1_7
+ CK=CTS_325
Xbank_mem_1_reg[5][6] QDFFN $PINS Q=bank_mem_1[5][6] D=FE_DBTN47_bank_wdata_1_6
+ CK=CTS_325
Xbank_mem_1_reg[5][5] QDFFN $PINS Q=bank_mem_1[5][5] D=FE_DBTN46_bank_wdata_1_5
+ CK=CTS_325
Xbank_mem_1_reg[5][4] QDFFN $PINS Q=bank_mem_1[5][4] D=FE_DBTN45_bank_wdata_1_4
+ CK=CTS_325
Xbank_mem_1_reg[5][3] QDFFN $PINS Q=bank_mem_1[5][3] D=FE_DBTN44_bank_wdata_1_3
+ CK=CTS_325
Xbank_mem_1_reg[5][2] QDFFN $PINS Q=bank_mem_1[5][2] D=FE_DBTN43_bank_wdata_1_2
+ CK=CTS_325
Xbank_mem_1_reg[5][1] QDFFN $PINS Q=bank_mem_1[5][1] D=FE_DBTN42_bank_wdata_1_1
+ CK=CTS_325
Xbank_mem_1_reg[5][0] QDFFN $PINS Q=bank_mem_1[5][0] D=FE_DBTN41_bank_wdata_1_0
+ CK=CTS_325
Xbank_mem_0_reg[6][21] QDFFN $PINS Q=bank_mem_0[6][21]
+ D=FE_DBTN83_bank_wdata_0_21 CK=CTS_372
Xbank_mem_0_reg[6][20] QDFFN $PINS Q=bank_mem_0[6][20]
+ D=FE_DBTN82_bank_wdata_0_20 CK=CTS_372
Xbank_mem_0_reg[6][19] QDFFN $PINS Q=bank_mem_0[6][19] D=FE_DBTN40_n2
+ CK=CTS_372
Xbank_mem_0_reg[6][18] QDFFN $PINS Q=bank_mem_0[6][18]
+ D=FE_DBTN81_bank_wdata_0_18 CK=CTS_372
Xbank_mem_0_reg[6][17] QDFFN $PINS Q=bank_mem_0[6][17]
+ D=FE_DBTN80_bank_wdata_0_17 CK=CTS_372
Xbank_mem_0_reg[6][16] QDFFN $PINS Q=bank_mem_0[6][16]
+ D=FE_DBTN79_bank_wdata_0_16 CK=CTS_372
Xbank_mem_0_reg[6][15] QDFFN $PINS Q=bank_mem_0[6][15]
+ D=FE_DBTN78_bank_wdata_0_15 CK=CTS_372
Xbank_mem_0_reg[6][14] QDFFN $PINS Q=bank_mem_0[6][14]
+ D=FE_DBTN77_bank_wdata_0_14 CK=CTS_372
Xbank_mem_0_reg[6][13] QDFFN $PINS Q=bank_mem_0[6][13]
+ D=FE_DBTN76_bank_wdata_0_13 CK=CTS_372
Xbank_mem_0_reg[6][12] QDFFN $PINS Q=bank_mem_0[6][12]
+ D=FE_DBTN75_bank_wdata_0_12 CK=CTS_372
Xbank_mem_0_reg[6][11] QDFFN $PINS Q=bank_mem_0[6][11]
+ D=FE_DBTN74_bank_wdata_0_11 CK=CTS_372
Xbank_mem_0_reg[6][10] QDFFN $PINS Q=bank_mem_0[6][10]
+ D=FE_DBTN73_bank_wdata_0_10 CK=CTS_372
Xbank_mem_0_reg[6][9] QDFFN $PINS Q=bank_mem_0[6][9] D=FE_DBTN72_bank_wdata_0_9
+ CK=CTS_372
Xbank_mem_0_reg[6][8] QDFFN $PINS Q=bank_mem_0[6][8] D=FE_DBTN71_bank_wdata_0_8
+ CK=CTS_372
Xbank_mem_0_reg[6][7] QDFFN $PINS Q=bank_mem_0[6][7] D=FE_DBTN70_bank_wdata_0_7
+ CK=CTS_372
Xbank_mem_0_reg[6][6] QDFFN $PINS Q=bank_mem_0[6][6] D=FE_DBTN69_bank_wdata_0_6
+ CK=CTS_372
Xbank_mem_0_reg[6][5] QDFFN $PINS Q=bank_mem_0[6][5] D=FE_DBTN68_bank_wdata_0_5
+ CK=CTS_372
Xbank_mem_0_reg[6][4] QDFFN $PINS Q=bank_mem_0[6][4] D=FE_DBTN67_bank_wdata_0_4
+ CK=CTS_372
Xbank_mem_0_reg[6][3] QDFFN $PINS Q=bank_mem_0[6][3] D=FE_DBTN66_bank_wdata_0_3
+ CK=CTS_372
Xbank_mem_0_reg[6][2] QDFFN $PINS Q=bank_mem_0[6][2] D=FE_DBTN65_bank_wdata_0_2
+ CK=CTS_372
Xbank_mem_0_reg[6][1] QDFFN $PINS Q=bank_mem_0[6][1] D=FE_DBTN64_bank_wdata_0_1
+ CK=CTS_372
Xbank_mem_0_reg[6][0] QDFFN $PINS Q=bank_mem_0[6][0] D=FE_DBTN63_bank_wdata_0_0
+ CK=CTS_372
Xbank_mem_0_reg[7][20] QDFFN $PINS Q=bank_mem_0[7][20]
+ D=FE_DBTN82_bank_wdata_0_20 CK=CTS_369
Xbank_mem_0_reg[7][19] QDFFN $PINS Q=bank_mem_0[7][19] D=FE_DBTN40_n2
+ CK=CTS_369
Xbank_mem_0_reg[7][18] QDFFN $PINS Q=bank_mem_0[7][18]
+ D=FE_DBTN81_bank_wdata_0_18 CK=CTS_369
Xbank_mem_0_reg[7][17] QDFFN $PINS Q=bank_mem_0[7][17]
+ D=FE_DBTN80_bank_wdata_0_17 CK=CTS_369
Xbank_mem_0_reg[7][16] QDFFN $PINS Q=bank_mem_0[7][16]
+ D=FE_DBTN79_bank_wdata_0_16 CK=CTS_369
Xbank_mem_0_reg[7][15] QDFFN $PINS Q=bank_mem_0[7][15]
+ D=FE_DBTN78_bank_wdata_0_15 CK=CTS_369
Xbank_mem_0_reg[7][14] QDFFN $PINS Q=bank_mem_0[7][14]
+ D=FE_DBTN77_bank_wdata_0_14 CK=CTS_369
Xbank_mem_0_reg[7][13] QDFFN $PINS Q=bank_mem_0[7][13]
+ D=FE_DBTN76_bank_wdata_0_13 CK=CTS_369
Xbank_mem_0_reg[7][12] QDFFN $PINS Q=bank_mem_0[7][12]
+ D=FE_DBTN75_bank_wdata_0_12 CK=CTS_369
Xbank_mem_0_reg[7][11] QDFFN $PINS Q=bank_mem_0[7][11]
+ D=FE_DBTN74_bank_wdata_0_11 CK=CTS_369
Xbank_mem_0_reg[7][10] QDFFN $PINS Q=bank_mem_0[7][10]
+ D=FE_DBTN73_bank_wdata_0_10 CK=CTS_369
Xbank_mem_0_reg[7][9] QDFFN $PINS Q=bank_mem_0[7][9] D=FE_DBTN72_bank_wdata_0_9
+ CK=CTS_369
Xbank_mem_0_reg[7][8] QDFFN $PINS Q=bank_mem_0[7][8] D=FE_DBTN71_bank_wdata_0_8
+ CK=CTS_369
Xbank_mem_0_reg[7][7] QDFFN $PINS Q=bank_mem_0[7][7] D=FE_DBTN70_bank_wdata_0_7
+ CK=CTS_369
Xbank_mem_0_reg[7][6] QDFFN $PINS Q=bank_mem_0[7][6] D=FE_DBTN69_bank_wdata_0_6
+ CK=CTS_369
Xbank_mem_0_reg[7][5] QDFFN $PINS Q=bank_mem_0[7][5] D=FE_DBTN68_bank_wdata_0_5
+ CK=CTS_369
Xbank_mem_0_reg[7][4] QDFFN $PINS Q=bank_mem_0[7][4] D=FE_DBTN67_bank_wdata_0_4
+ CK=CTS_369
Xbank_mem_0_reg[7][3] QDFFN $PINS Q=bank_mem_0[7][3] D=FE_DBTN66_bank_wdata_0_3
+ CK=CTS_369
Xbank_mem_0_reg[7][2] QDFFN $PINS Q=bank_mem_0[7][2] D=FE_DBTN65_bank_wdata_0_2
+ CK=CTS_369
Xbank_mem_0_reg[7][1] QDFFN $PINS Q=bank_mem_0[7][1] D=FE_DBTN64_bank_wdata_0_1
+ CK=CTS_369
Xbank_mem_0_reg[7][0] QDFFN $PINS Q=bank_mem_0[7][0] D=FE_DBTN63_bank_wdata_0_0
+ CK=CTS_369
Xbank_mem_0_reg[7][21] QDFFN $PINS Q=bank_mem_0[7][21]
+ D=FE_DBTN83_bank_wdata_0_21 CK=CTS_369
Xbank_mem_0_reg[5][21] QDFFN $PINS Q=bank_mem_0[5][21]
+ D=FE_DBTN83_bank_wdata_0_21 CK=CTS_375
Xbank_mem_0_reg[5][20] QDFFN $PINS Q=bank_mem_0[5][20]
+ D=FE_DBTN82_bank_wdata_0_20 CK=CTS_375
Xbank_mem_0_reg[5][19] QDFFN $PINS Q=bank_mem_0[5][19] D=FE_DBTN40_n2
+ CK=CTS_375
Xbank_mem_0_reg[5][18] QDFFN $PINS Q=bank_mem_0[5][18]
+ D=FE_DBTN81_bank_wdata_0_18 CK=CTS_375
Xbank_mem_0_reg[5][17] QDFFN $PINS Q=bank_mem_0[5][17]
+ D=FE_DBTN80_bank_wdata_0_17 CK=CTS_375
Xbank_mem_0_reg[5][16] QDFFN $PINS Q=bank_mem_0[5][16]
+ D=FE_DBTN79_bank_wdata_0_16 CK=CTS_375
Xbank_mem_0_reg[5][15] QDFFN $PINS Q=bank_mem_0[5][15]
+ D=FE_DBTN78_bank_wdata_0_15 CK=CTS_375
Xbank_mem_0_reg[5][14] QDFFN $PINS Q=bank_mem_0[5][14]
+ D=FE_DBTN77_bank_wdata_0_14 CK=CTS_375
Xbank_mem_0_reg[5][13] QDFFN $PINS Q=bank_mem_0[5][13]
+ D=FE_DBTN76_bank_wdata_0_13 CK=CTS_375
Xbank_mem_0_reg[5][12] QDFFN $PINS Q=bank_mem_0[5][12]
+ D=FE_DBTN75_bank_wdata_0_12 CK=CTS_375
Xbank_mem_0_reg[5][11] QDFFN $PINS Q=bank_mem_0[5][11]
+ D=FE_DBTN74_bank_wdata_0_11 CK=CTS_375
Xbank_mem_0_reg[5][10] QDFFN $PINS Q=bank_mem_0[5][10]
+ D=FE_DBTN73_bank_wdata_0_10 CK=CTS_375
Xbank_mem_0_reg[5][9] QDFFN $PINS Q=bank_mem_0[5][9] D=FE_DBTN72_bank_wdata_0_9
+ CK=CTS_375
Xbank_mem_0_reg[5][8] QDFFN $PINS Q=bank_mem_0[5][8] D=FE_DBTN71_bank_wdata_0_8
+ CK=CTS_375
Xbank_mem_0_reg[5][7] QDFFN $PINS Q=bank_mem_0[5][7] D=FE_DBTN70_bank_wdata_0_7
+ CK=CTS_375
Xbank_mem_0_reg[5][6] QDFFN $PINS Q=bank_mem_0[5][6] D=FE_DBTN69_bank_wdata_0_6
+ CK=CTS_375
Xbank_mem_0_reg[5][5] QDFFN $PINS Q=bank_mem_0[5][5] D=FE_DBTN68_bank_wdata_0_5
+ CK=CTS_375
Xbank_mem_0_reg[5][4] QDFFN $PINS Q=bank_mem_0[5][4] D=FE_DBTN67_bank_wdata_0_4
+ CK=CTS_375
Xbank_mem_0_reg[5][3] QDFFN $PINS Q=bank_mem_0[5][3] D=FE_DBTN66_bank_wdata_0_3
+ CK=CTS_375
Xbank_mem_0_reg[5][2] QDFFN $PINS Q=bank_mem_0[5][2] D=FE_DBTN65_bank_wdata_0_2
+ CK=CTS_375
Xbank_mem_0_reg[5][1] QDFFN $PINS Q=bank_mem_0[5][1] D=FE_DBTN64_bank_wdata_0_1
+ CK=CTS_375
Xbank_mem_0_reg[5][0] QDFFN $PINS Q=bank_mem_0[5][0] D=FE_DBTN63_bank_wdata_0_0
+ CK=CTS_375
Xbank_mem_1_reg[3][21] QDFFN $PINS Q=bank_mem_1[3][21]
+ D=FE_DBTN62_bank_wdata_1_21 CK=CTS_331
Xbank_mem_1_reg[3][20] QDFFN $PINS Q=bank_mem_1[3][20]
+ D=FE_DBTN61_bank_wdata_1_20 CK=CTS_331
Xbank_mem_1_reg[3][19] QDFFN $PINS Q=bank_mem_1[3][19]
+ D=FE_DBTN60_bank_wdata_1_19 CK=CTS_331
Xbank_mem_1_reg[3][18] QDFFN $PINS Q=bank_mem_1[3][18]
+ D=FE_DBTN59_bank_wdata_1_18 CK=CTS_331
Xbank_mem_1_reg[3][17] QDFFN $PINS Q=bank_mem_1[3][17]
+ D=FE_DBTN58_bank_wdata_1_17 CK=CTS_331
Xbank_mem_1_reg[3][16] QDFFN $PINS Q=bank_mem_1[3][16]
+ D=FE_DBTN57_bank_wdata_1_16 CK=CTS_331
Xbank_mem_1_reg[3][15] QDFFN $PINS Q=bank_mem_1[3][15]
+ D=FE_DBTN56_bank_wdata_1_15 CK=CTS_331
Xbank_mem_1_reg[3][14] QDFFN $PINS Q=bank_mem_1[3][14]
+ D=FE_DBTN55_bank_wdata_1_14 CK=CTS_331
Xbank_mem_1_reg[3][13] QDFFN $PINS Q=bank_mem_1[3][13]
+ D=FE_DBTN54_bank_wdata_1_13 CK=CTS_331
Xbank_mem_1_reg[3][12] QDFFN $PINS Q=bank_mem_1[3][12]
+ D=FE_DBTN53_bank_wdata_1_12 CK=CTS_331
Xbank_mem_1_reg[3][11] QDFFN $PINS Q=bank_mem_1[3][11]
+ D=FE_DBTN52_bank_wdata_1_11 CK=CTS_331
Xbank_mem_1_reg[3][10] QDFFN $PINS Q=bank_mem_1[3][10]
+ D=FE_DBTN51_bank_wdata_1_10 CK=CTS_331
Xbank_mem_1_reg[3][9] QDFFN $PINS Q=bank_mem_1[3][9] D=FE_DBTN50_bank_wdata_1_9
+ CK=CTS_331
Xbank_mem_1_reg[3][8] QDFFN $PINS Q=bank_mem_1[3][8] D=FE_DBTN49_bank_wdata_1_8
+ CK=CTS_331
Xbank_mem_1_reg[3][7] QDFFN $PINS Q=bank_mem_1[3][7] D=FE_DBTN48_bank_wdata_1_7
+ CK=CTS_331
Xbank_mem_1_reg[3][6] QDFFN $PINS Q=bank_mem_1[3][6] D=FE_DBTN47_bank_wdata_1_6
+ CK=CTS_331
Xbank_mem_1_reg[3][5] QDFFN $PINS Q=bank_mem_1[3][5] D=FE_DBTN46_bank_wdata_1_5
+ CK=CTS_331
Xbank_mem_1_reg[3][4] QDFFN $PINS Q=bank_mem_1[3][4] D=FE_DBTN45_bank_wdata_1_4
+ CK=CTS_331
Xbank_mem_1_reg[3][3] QDFFN $PINS Q=bank_mem_1[3][3] D=FE_DBTN44_bank_wdata_1_3
+ CK=CTS_331
Xbank_mem_1_reg[3][2] QDFFN $PINS Q=bank_mem_1[3][2] D=FE_DBTN43_bank_wdata_1_2
+ CK=CTS_331
Xbank_mem_1_reg[3][1] QDFFN $PINS Q=bank_mem_1[3][1] D=FE_DBTN42_bank_wdata_1_1
+ CK=CTS_331
Xbank_mem_1_reg[3][0] QDFFN $PINS Q=bank_mem_1[3][0] D=FE_DBTN41_bank_wdata_1_0
+ CK=CTS_331
Xbank_mem_0_reg[3][21] QDFFN $PINS Q=bank_mem_0[3][21]
+ D=FE_DBTN83_bank_wdata_0_21 CK=CTS_381
Xbank_mem_0_reg[3][20] QDFFN $PINS Q=bank_mem_0[3][20]
+ D=FE_DBTN82_bank_wdata_0_20 CK=CTS_381
Xbank_mem_0_reg[3][19] QDFFN $PINS Q=bank_mem_0[3][19] D=FE_DBTN40_n2
+ CK=CTS_381
Xbank_mem_0_reg[3][18] QDFFN $PINS Q=bank_mem_0[3][18]
+ D=FE_DBTN81_bank_wdata_0_18 CK=CTS_381
Xbank_mem_0_reg[3][17] QDFFN $PINS Q=bank_mem_0[3][17]
+ D=FE_DBTN80_bank_wdata_0_17 CK=CTS_381
Xbank_mem_0_reg[3][16] QDFFN $PINS Q=bank_mem_0[3][16]
+ D=FE_DBTN79_bank_wdata_0_16 CK=CTS_381
Xbank_mem_0_reg[3][15] QDFFN $PINS Q=bank_mem_0[3][15]
+ D=FE_DBTN78_bank_wdata_0_15 CK=CTS_381
Xbank_mem_0_reg[3][14] QDFFN $PINS Q=bank_mem_0[3][14]
+ D=FE_DBTN77_bank_wdata_0_14 CK=CTS_381
Xbank_mem_0_reg[3][13] QDFFN $PINS Q=bank_mem_0[3][13]
+ D=FE_DBTN76_bank_wdata_0_13 CK=CTS_381
Xbank_mem_0_reg[3][12] QDFFN $PINS Q=bank_mem_0[3][12]
+ D=FE_DBTN75_bank_wdata_0_12 CK=CTS_381
Xbank_mem_0_reg[3][11] QDFFN $PINS Q=bank_mem_0[3][11]
+ D=FE_DBTN74_bank_wdata_0_11 CK=CTS_381
Xbank_mem_0_reg[3][10] QDFFN $PINS Q=bank_mem_0[3][10]
+ D=FE_DBTN73_bank_wdata_0_10 CK=CTS_381
Xbank_mem_0_reg[3][9] QDFFN $PINS Q=bank_mem_0[3][9] D=FE_DBTN72_bank_wdata_0_9
+ CK=CTS_381
Xbank_mem_0_reg[3][8] QDFFN $PINS Q=bank_mem_0[3][8] D=FE_DBTN71_bank_wdata_0_8
+ CK=CTS_381
Xbank_mem_0_reg[3][7] QDFFN $PINS Q=bank_mem_0[3][7] D=FE_DBTN70_bank_wdata_0_7
+ CK=CTS_381
Xbank_mem_0_reg[3][6] QDFFN $PINS Q=bank_mem_0[3][6] D=FE_DBTN69_bank_wdata_0_6
+ CK=CTS_381
Xbank_mem_0_reg[3][5] QDFFN $PINS Q=bank_mem_0[3][5] D=FE_DBTN68_bank_wdata_0_5
+ CK=CTS_381
Xbank_mem_0_reg[3][4] QDFFN $PINS Q=bank_mem_0[3][4] D=FE_DBTN67_bank_wdata_0_4
+ CK=CTS_381
Xbank_mem_0_reg[3][3] QDFFN $PINS Q=bank_mem_0[3][3] D=FE_DBTN66_bank_wdata_0_3
+ CK=CTS_381
Xbank_mem_0_reg[3][2] QDFFN $PINS Q=bank_mem_0[3][2] D=FE_DBTN65_bank_wdata_0_2
+ CK=CTS_381
Xbank_mem_0_reg[3][1] QDFFN $PINS Q=bank_mem_0[3][1] D=FE_DBTN64_bank_wdata_0_1
+ CK=CTS_381
Xbank_mem_0_reg[3][0] QDFFN $PINS Q=bank_mem_0[3][0] D=FE_DBTN63_bank_wdata_0_0
+ CK=CTS_381
Xbank_mem_1_reg[4][21] QDFFN $PINS Q=bank_mem_1[4][21]
+ D=FE_DBTN62_bank_wdata_1_21 CK=CTS_328
Xbank_mem_1_reg[4][20] QDFFN $PINS Q=bank_mem_1[4][20]
+ D=FE_DBTN61_bank_wdata_1_20 CK=CTS_328
Xbank_mem_1_reg[4][19] QDFFN $PINS Q=bank_mem_1[4][19]
+ D=FE_DBTN60_bank_wdata_1_19 CK=CTS_328
Xbank_mem_1_reg[4][18] QDFFN $PINS Q=bank_mem_1[4][18]
+ D=FE_DBTN59_bank_wdata_1_18 CK=CTS_328
Xbank_mem_1_reg[4][17] QDFFN $PINS Q=bank_mem_1[4][17]
+ D=FE_DBTN58_bank_wdata_1_17 CK=CTS_328
Xbank_mem_1_reg[4][16] QDFFN $PINS Q=bank_mem_1[4][16]
+ D=FE_DBTN57_bank_wdata_1_16 CK=CTS_328
Xbank_mem_1_reg[4][15] QDFFN $PINS Q=bank_mem_1[4][15]
+ D=FE_DBTN56_bank_wdata_1_15 CK=CTS_328
Xbank_mem_1_reg[4][14] QDFFN $PINS Q=bank_mem_1[4][14]
+ D=FE_DBTN55_bank_wdata_1_14 CK=CTS_328
Xbank_mem_1_reg[4][13] QDFFN $PINS Q=bank_mem_1[4][13]
+ D=FE_DBTN54_bank_wdata_1_13 CK=CTS_328
Xbank_mem_1_reg[4][12] QDFFN $PINS Q=bank_mem_1[4][12]
+ D=FE_DBTN53_bank_wdata_1_12 CK=CTS_328
Xbank_mem_1_reg[4][11] QDFFN $PINS Q=bank_mem_1[4][11]
+ D=FE_DBTN52_bank_wdata_1_11 CK=CTS_328
Xbank_mem_1_reg[4][10] QDFFN $PINS Q=bank_mem_1[4][10]
+ D=FE_DBTN51_bank_wdata_1_10 CK=CTS_328
Xbank_mem_1_reg[4][9] QDFFN $PINS Q=bank_mem_1[4][9] D=FE_DBTN50_bank_wdata_1_9
+ CK=CTS_328
Xbank_mem_1_reg[4][8] QDFFN $PINS Q=bank_mem_1[4][8] D=FE_DBTN49_bank_wdata_1_8
+ CK=CTS_328
Xbank_mem_1_reg[4][7] QDFFN $PINS Q=bank_mem_1[4][7] D=FE_DBTN48_bank_wdata_1_7
+ CK=CTS_328
Xbank_mem_1_reg[4][6] QDFFN $PINS Q=bank_mem_1[4][6] D=FE_DBTN47_bank_wdata_1_6
+ CK=CTS_328
Xbank_mem_1_reg[4][5] QDFFN $PINS Q=bank_mem_1[4][5] D=FE_DBTN46_bank_wdata_1_5
+ CK=CTS_328
Xbank_mem_1_reg[4][4] QDFFN $PINS Q=bank_mem_1[4][4] D=FE_DBTN45_bank_wdata_1_4
+ CK=CTS_328
Xbank_mem_1_reg[4][3] QDFFN $PINS Q=bank_mem_1[4][3] D=FE_DBTN44_bank_wdata_1_3
+ CK=CTS_328
Xbank_mem_1_reg[4][2] QDFFN $PINS Q=bank_mem_1[4][2] D=FE_DBTN43_bank_wdata_1_2
+ CK=CTS_328
Xbank_mem_1_reg[4][1] QDFFN $PINS Q=bank_mem_1[4][1] D=FE_DBTN42_bank_wdata_1_1
+ CK=CTS_328
Xbank_mem_1_reg[4][0] QDFFN $PINS Q=bank_mem_1[4][0] D=FE_DBTN41_bank_wdata_1_0
+ CK=CTS_328
Xbank_mem_1_reg[2][21] QDFFN $PINS Q=bank_mem_1[2][21]
+ D=FE_DBTN62_bank_wdata_1_21 CK=CTS_334
Xbank_mem_1_reg[2][20] QDFFN $PINS Q=bank_mem_1[2][20]
+ D=FE_DBTN61_bank_wdata_1_20 CK=CTS_334
Xbank_mem_1_reg[2][19] QDFFN $PINS Q=bank_mem_1[2][19]
+ D=FE_DBTN60_bank_wdata_1_19 CK=CTS_334
Xbank_mem_1_reg[2][18] QDFFN $PINS Q=bank_mem_1[2][18]
+ D=FE_DBTN59_bank_wdata_1_18 CK=CTS_334
Xbank_mem_1_reg[2][17] QDFFN $PINS Q=bank_mem_1[2][17]
+ D=FE_DBTN58_bank_wdata_1_17 CK=CTS_334
Xbank_mem_1_reg[2][16] QDFFN $PINS Q=bank_mem_1[2][16]
+ D=FE_DBTN57_bank_wdata_1_16 CK=CTS_334
Xbank_mem_1_reg[2][15] QDFFN $PINS Q=bank_mem_1[2][15]
+ D=FE_DBTN56_bank_wdata_1_15 CK=CTS_334
Xbank_mem_1_reg[2][14] QDFFN $PINS Q=bank_mem_1[2][14]
+ D=FE_DBTN55_bank_wdata_1_14 CK=CTS_334
Xbank_mem_1_reg[2][13] QDFFN $PINS Q=bank_mem_1[2][13]
+ D=FE_DBTN54_bank_wdata_1_13 CK=CTS_334
Xbank_mem_1_reg[2][12] QDFFN $PINS Q=bank_mem_1[2][12]
+ D=FE_DBTN53_bank_wdata_1_12 CK=CTS_334
Xbank_mem_1_reg[2][11] QDFFN $PINS Q=bank_mem_1[2][11]
+ D=FE_DBTN52_bank_wdata_1_11 CK=CTS_334
Xbank_mem_1_reg[2][10] QDFFN $PINS Q=bank_mem_1[2][10]
+ D=FE_DBTN51_bank_wdata_1_10 CK=CTS_334
Xbank_mem_1_reg[2][9] QDFFN $PINS Q=bank_mem_1[2][9] D=FE_DBTN50_bank_wdata_1_9
+ CK=CTS_334
Xbank_mem_1_reg[2][8] QDFFN $PINS Q=bank_mem_1[2][8] D=FE_DBTN49_bank_wdata_1_8
+ CK=CTS_334
Xbank_mem_1_reg[2][7] QDFFN $PINS Q=bank_mem_1[2][7] D=FE_DBTN48_bank_wdata_1_7
+ CK=CTS_334
Xbank_mem_1_reg[2][6] QDFFN $PINS Q=bank_mem_1[2][6] D=FE_DBTN47_bank_wdata_1_6
+ CK=CTS_334
Xbank_mem_1_reg[2][5] QDFFN $PINS Q=bank_mem_1[2][5] D=FE_DBTN46_bank_wdata_1_5
+ CK=CTS_334
Xbank_mem_1_reg[2][4] QDFFN $PINS Q=bank_mem_1[2][4] D=FE_DBTN45_bank_wdata_1_4
+ CK=CTS_334
Xbank_mem_1_reg[2][3] QDFFN $PINS Q=bank_mem_1[2][3] D=FE_DBTN44_bank_wdata_1_3
+ CK=CTS_334
Xbank_mem_1_reg[2][2] QDFFN $PINS Q=bank_mem_1[2][2] D=FE_DBTN43_bank_wdata_1_2
+ CK=CTS_334
Xbank_mem_1_reg[2][1] QDFFN $PINS Q=bank_mem_1[2][1] D=FE_DBTN42_bank_wdata_1_1
+ CK=CTS_334
Xbank_mem_1_reg[2][0] QDFFN $PINS Q=bank_mem_1[2][0] D=FE_DBTN41_bank_wdata_1_0
+ CK=CTS_334
Xbank_mem_0_reg[4][21] QDFFN $PINS Q=bank_mem_0[4][21]
+ D=FE_DBTN83_bank_wdata_0_21 CK=CTS_378
Xbank_mem_0_reg[4][20] QDFFN $PINS Q=bank_mem_0[4][20]
+ D=FE_DBTN82_bank_wdata_0_20 CK=CTS_378
Xbank_mem_0_reg[4][19] QDFFN $PINS Q=bank_mem_0[4][19] D=FE_DBTN40_n2
+ CK=CTS_378
Xbank_mem_0_reg[4][18] QDFFN $PINS Q=bank_mem_0[4][18]
+ D=FE_DBTN81_bank_wdata_0_18 CK=CTS_378
Xbank_mem_0_reg[4][17] QDFFN $PINS Q=bank_mem_0[4][17]
+ D=FE_DBTN80_bank_wdata_0_17 CK=CTS_378
Xbank_mem_0_reg[4][16] QDFFN $PINS Q=bank_mem_0[4][16]
+ D=FE_DBTN79_bank_wdata_0_16 CK=CTS_378
Xbank_mem_0_reg[4][15] QDFFN $PINS Q=bank_mem_0[4][15]
+ D=FE_DBTN78_bank_wdata_0_15 CK=CTS_378
Xbank_mem_0_reg[4][14] QDFFN $PINS Q=bank_mem_0[4][14]
+ D=FE_DBTN77_bank_wdata_0_14 CK=CTS_378
Xbank_mem_0_reg[4][13] QDFFN $PINS Q=bank_mem_0[4][13]
+ D=FE_DBTN76_bank_wdata_0_13 CK=CTS_378
Xbank_mem_0_reg[4][12] QDFFN $PINS Q=bank_mem_0[4][12]
+ D=FE_DBTN75_bank_wdata_0_12 CK=CTS_378
Xbank_mem_0_reg[4][11] QDFFN $PINS Q=bank_mem_0[4][11]
+ D=FE_DBTN74_bank_wdata_0_11 CK=CTS_378
Xbank_mem_0_reg[4][10] QDFFN $PINS Q=bank_mem_0[4][10]
+ D=FE_DBTN73_bank_wdata_0_10 CK=CTS_378
Xbank_mem_0_reg[4][9] QDFFN $PINS Q=bank_mem_0[4][9] D=FE_DBTN72_bank_wdata_0_9
+ CK=CTS_378
Xbank_mem_0_reg[4][8] QDFFN $PINS Q=bank_mem_0[4][8] D=FE_DBTN71_bank_wdata_0_8
+ CK=CTS_378
Xbank_mem_0_reg[4][7] QDFFN $PINS Q=bank_mem_0[4][7] D=FE_DBTN70_bank_wdata_0_7
+ CK=CTS_378
Xbank_mem_0_reg[4][6] QDFFN $PINS Q=bank_mem_0[4][6] D=FE_DBTN69_bank_wdata_0_6
+ CK=CTS_378
Xbank_mem_0_reg[4][5] QDFFN $PINS Q=bank_mem_0[4][5] D=FE_DBTN68_bank_wdata_0_5
+ CK=CTS_378
Xbank_mem_0_reg[4][4] QDFFN $PINS Q=bank_mem_0[4][4] D=FE_DBTN67_bank_wdata_0_4
+ CK=CTS_378
Xbank_mem_0_reg[4][3] QDFFN $PINS Q=bank_mem_0[4][3] D=FE_DBTN66_bank_wdata_0_3
+ CK=CTS_378
Xbank_mem_0_reg[4][2] QDFFN $PINS Q=bank_mem_0[4][2] D=FE_DBTN65_bank_wdata_0_2
+ CK=CTS_378
Xbank_mem_0_reg[4][1] QDFFN $PINS Q=bank_mem_0[4][1] D=FE_DBTN64_bank_wdata_0_1
+ CK=CTS_378
Xbank_mem_0_reg[4][0] QDFFN $PINS Q=bank_mem_0[4][0] D=FE_DBTN63_bank_wdata_0_0
+ CK=CTS_378
Xbank_mem_1_reg[15][20] QDFFN $PINS Q=bank_mem_1[15][20]
+ D=FE_DBTN61_bank_wdata_1_20 CK=CTS_295
Xbank_mem_1_reg[15][19] QDFFN $PINS Q=bank_mem_1[15][19]
+ D=FE_DBTN60_bank_wdata_1_19 CK=CTS_295
Xbank_mem_1_reg[15][18] QDFFN $PINS Q=bank_mem_1[15][18]
+ D=FE_DBTN59_bank_wdata_1_18 CK=CTS_295
Xbank_mem_1_reg[15][17] QDFFN $PINS Q=bank_mem_1[15][17]
+ D=FE_DBTN58_bank_wdata_1_17 CK=CTS_295
Xbank_mem_1_reg[15][16] QDFFN $PINS Q=bank_mem_1[15][16]
+ D=FE_DBTN57_bank_wdata_1_16 CK=CTS_295
Xbank_mem_1_reg[15][15] QDFFN $PINS Q=bank_mem_1[15][15]
+ D=FE_DBTN56_bank_wdata_1_15 CK=CTS_295
Xbank_mem_1_reg[15][14] QDFFN $PINS Q=bank_mem_1[15][14]
+ D=FE_DBTN55_bank_wdata_1_14 CK=CTS_295
Xbank_mem_1_reg[15][13] QDFFN $PINS Q=bank_mem_1[15][13]
+ D=FE_DBTN54_bank_wdata_1_13 CK=CTS_295
Xbank_mem_1_reg[15][12] QDFFN $PINS Q=bank_mem_1[15][12]
+ D=FE_DBTN53_bank_wdata_1_12 CK=CTS_295
Xbank_mem_1_reg[15][11] QDFFN $PINS Q=bank_mem_1[15][11]
+ D=FE_DBTN52_bank_wdata_1_11 CK=CTS_295
Xbank_mem_1_reg[15][10] QDFFN $PINS Q=bank_mem_1[15][10]
+ D=FE_DBTN51_bank_wdata_1_10 CK=CTS_295
Xbank_mem_1_reg[15][9] QDFFN $PINS Q=bank_mem_1[15][9]
+ D=FE_DBTN50_bank_wdata_1_9 CK=CTS_295
Xbank_mem_1_reg[15][8] QDFFN $PINS Q=bank_mem_1[15][8]
+ D=FE_DBTN49_bank_wdata_1_8 CK=CTS_295
Xbank_mem_1_reg[15][7] QDFFN $PINS Q=bank_mem_1[15][7]
+ D=FE_DBTN48_bank_wdata_1_7 CK=CTS_295
Xbank_mem_1_reg[15][6] QDFFN $PINS Q=bank_mem_1[15][6]
+ D=FE_DBTN47_bank_wdata_1_6 CK=CTS_295
Xbank_mem_1_reg[15][5] QDFFN $PINS Q=bank_mem_1[15][5]
+ D=FE_DBTN46_bank_wdata_1_5 CK=CTS_295
Xbank_mem_1_reg[15][4] QDFFN $PINS Q=bank_mem_1[15][4]
+ D=FE_DBTN45_bank_wdata_1_4 CK=CTS_295
Xbank_mem_1_reg[15][3] QDFFN $PINS Q=bank_mem_1[15][3]
+ D=FE_DBTN44_bank_wdata_1_3 CK=CTS_295
Xbank_mem_1_reg[15][2] QDFFN $PINS Q=bank_mem_1[15][2]
+ D=FE_DBTN43_bank_wdata_1_2 CK=CTS_295
Xbank_mem_1_reg[15][1] QDFFN $PINS Q=bank_mem_1[15][1]
+ D=FE_DBTN42_bank_wdata_1_1 CK=CTS_295
Xbank_mem_1_reg[15][0] QDFFN $PINS Q=bank_mem_1[15][0]
+ D=FE_DBTN41_bank_wdata_1_0 CK=CTS_295
Xbank_mem_1_reg[13][20] QDFFN $PINS Q=bank_mem_1[13][20]
+ D=FE_DBTN61_bank_wdata_1_20 CK=CTS_301
Xbank_mem_1_reg[13][19] QDFFN $PINS Q=bank_mem_1[13][19]
+ D=FE_DBTN60_bank_wdata_1_19 CK=CTS_301
Xbank_mem_1_reg[13][18] QDFFN $PINS Q=bank_mem_1[13][18]
+ D=FE_DBTN59_bank_wdata_1_18 CK=CTS_301
Xbank_mem_1_reg[13][17] QDFFN $PINS Q=bank_mem_1[13][17]
+ D=FE_DBTN58_bank_wdata_1_17 CK=CTS_301
Xbank_mem_1_reg[13][16] QDFFN $PINS Q=bank_mem_1[13][16]
+ D=FE_DBTN57_bank_wdata_1_16 CK=CTS_301
Xbank_mem_1_reg[13][15] QDFFN $PINS Q=bank_mem_1[13][15]
+ D=FE_DBTN56_bank_wdata_1_15 CK=CTS_301
Xbank_mem_1_reg[13][14] QDFFN $PINS Q=bank_mem_1[13][14]
+ D=FE_DBTN55_bank_wdata_1_14 CK=CTS_301
Xbank_mem_1_reg[13][13] QDFFN $PINS Q=bank_mem_1[13][13]
+ D=FE_DBTN54_bank_wdata_1_13 CK=CTS_301
Xbank_mem_1_reg[13][12] QDFFN $PINS Q=bank_mem_1[13][12]
+ D=FE_DBTN53_bank_wdata_1_12 CK=CTS_301
Xbank_mem_1_reg[13][11] QDFFN $PINS Q=bank_mem_1[13][11]
+ D=FE_DBTN52_bank_wdata_1_11 CK=CTS_301
Xbank_mem_1_reg[13][10] QDFFN $PINS Q=bank_mem_1[13][10]
+ D=FE_DBTN51_bank_wdata_1_10 CK=CTS_301
Xbank_mem_1_reg[13][9] QDFFN $PINS Q=bank_mem_1[13][9]
+ D=FE_DBTN50_bank_wdata_1_9 CK=CTS_301
Xbank_mem_1_reg[13][8] QDFFN $PINS Q=bank_mem_1[13][8]
+ D=FE_DBTN49_bank_wdata_1_8 CK=CTS_301
Xbank_mem_1_reg[13][7] QDFFN $PINS Q=bank_mem_1[13][7]
+ D=FE_DBTN48_bank_wdata_1_7 CK=CTS_301
Xbank_mem_1_reg[13][6] QDFFN $PINS Q=bank_mem_1[13][6]
+ D=FE_DBTN47_bank_wdata_1_6 CK=CTS_301
Xbank_mem_1_reg[13][5] QDFFN $PINS Q=bank_mem_1[13][5]
+ D=FE_DBTN46_bank_wdata_1_5 CK=CTS_301
Xbank_mem_1_reg[13][4] QDFFN $PINS Q=bank_mem_1[13][4]
+ D=FE_DBTN45_bank_wdata_1_4 CK=CTS_301
Xbank_mem_1_reg[13][3] QDFFN $PINS Q=bank_mem_1[13][3]
+ D=FE_DBTN44_bank_wdata_1_3 CK=CTS_301
Xbank_mem_1_reg[13][2] QDFFN $PINS Q=bank_mem_1[13][2]
+ D=FE_DBTN43_bank_wdata_1_2 CK=CTS_301
Xbank_mem_1_reg[13][1] QDFFN $PINS Q=bank_mem_1[13][1]
+ D=FE_DBTN42_bank_wdata_1_1 CK=CTS_301
Xbank_mem_1_reg[13][0] QDFFN $PINS Q=bank_mem_1[13][0]
+ D=FE_DBTN41_bank_wdata_1_0 CK=CTS_301
Xbank_mem_0_reg[2][21] QDFFN $PINS Q=bank_mem_0[2][21]
+ D=FE_DBTN83_bank_wdata_0_21 CK=CTS_384
Xbank_mem_0_reg[2][20] QDFFN $PINS Q=bank_mem_0[2][20]
+ D=FE_DBTN82_bank_wdata_0_20 CK=CTS_384
Xbank_mem_0_reg[2][19] QDFFN $PINS Q=bank_mem_0[2][19] D=FE_DBTN40_n2
+ CK=CTS_384
Xbank_mem_0_reg[2][18] QDFFN $PINS Q=bank_mem_0[2][18]
+ D=FE_DBTN81_bank_wdata_0_18 CK=CTS_384
Xbank_mem_0_reg[2][17] QDFFN $PINS Q=bank_mem_0[2][17]
+ D=FE_DBTN80_bank_wdata_0_17 CK=CTS_384
Xbank_mem_0_reg[2][16] QDFFN $PINS Q=bank_mem_0[2][16]
+ D=FE_DBTN79_bank_wdata_0_16 CK=CTS_384
Xbank_mem_0_reg[2][15] QDFFN $PINS Q=bank_mem_0[2][15]
+ D=FE_DBTN78_bank_wdata_0_15 CK=CTS_384
Xbank_mem_0_reg[2][14] QDFFN $PINS Q=bank_mem_0[2][14]
+ D=FE_DBTN77_bank_wdata_0_14 CK=CTS_384
Xbank_mem_0_reg[2][13] QDFFN $PINS Q=bank_mem_0[2][13]
+ D=FE_DBTN76_bank_wdata_0_13 CK=CTS_384
Xbank_mem_0_reg[2][12] QDFFN $PINS Q=bank_mem_0[2][12]
+ D=FE_DBTN75_bank_wdata_0_12 CK=CTS_384
Xbank_mem_0_reg[2][11] QDFFN $PINS Q=bank_mem_0[2][11]
+ D=FE_DBTN74_bank_wdata_0_11 CK=CTS_384
Xbank_mem_0_reg[2][10] QDFFN $PINS Q=bank_mem_0[2][10]
+ D=FE_DBTN73_bank_wdata_0_10 CK=CTS_384
Xbank_mem_0_reg[2][9] QDFFN $PINS Q=bank_mem_0[2][9] D=FE_DBTN72_bank_wdata_0_9
+ CK=CTS_384
Xbank_mem_0_reg[2][8] QDFFN $PINS Q=bank_mem_0[2][8] D=FE_DBTN71_bank_wdata_0_8
+ CK=CTS_384
Xbank_mem_0_reg[2][7] QDFFN $PINS Q=bank_mem_0[2][7] D=FE_DBTN70_bank_wdata_0_7
+ CK=CTS_384
Xbank_mem_0_reg[2][6] QDFFN $PINS Q=bank_mem_0[2][6] D=FE_DBTN69_bank_wdata_0_6
+ CK=CTS_384
Xbank_mem_0_reg[2][5] QDFFN $PINS Q=bank_mem_0[2][5] D=FE_DBTN68_bank_wdata_0_5
+ CK=CTS_384
Xbank_mem_0_reg[2][4] QDFFN $PINS Q=bank_mem_0[2][4] D=FE_DBTN67_bank_wdata_0_4
+ CK=CTS_384
Xbank_mem_0_reg[2][3] QDFFN $PINS Q=bank_mem_0[2][3] D=FE_DBTN66_bank_wdata_0_3
+ CK=CTS_384
Xbank_mem_0_reg[2][2] QDFFN $PINS Q=bank_mem_0[2][2] D=FE_DBTN65_bank_wdata_0_2
+ CK=CTS_384
Xbank_mem_0_reg[2][1] QDFFN $PINS Q=bank_mem_0[2][1] D=FE_DBTN64_bank_wdata_0_1
+ CK=CTS_384
Xbank_mem_0_reg[2][0] QDFFN $PINS Q=bank_mem_0[2][0] D=FE_DBTN63_bank_wdata_0_0
+ CK=CTS_384
Xbank_mem_1_reg[14][20] QDFFN $PINS Q=bank_mem_1[14][20]
+ D=FE_DBTN61_bank_wdata_1_20 CK=CTS_298
Xbank_mem_1_reg[14][19] QDFFN $PINS Q=bank_mem_1[14][19]
+ D=FE_DBTN60_bank_wdata_1_19 CK=CTS_298
Xbank_mem_1_reg[14][18] QDFFN $PINS Q=bank_mem_1[14][18]
+ D=FE_DBTN59_bank_wdata_1_18 CK=CTS_298
Xbank_mem_1_reg[14][17] QDFFN $PINS Q=bank_mem_1[14][17]
+ D=FE_DBTN58_bank_wdata_1_17 CK=CTS_298
Xbank_mem_1_reg[14][16] QDFFN $PINS Q=bank_mem_1[14][16]
+ D=FE_DBTN57_bank_wdata_1_16 CK=CTS_298
Xbank_mem_1_reg[14][15] QDFFN $PINS Q=bank_mem_1[14][15]
+ D=FE_DBTN56_bank_wdata_1_15 CK=CTS_298
Xbank_mem_1_reg[14][14] QDFFN $PINS Q=bank_mem_1[14][14]
+ D=FE_DBTN55_bank_wdata_1_14 CK=CTS_298
Xbank_mem_1_reg[14][13] QDFFN $PINS Q=bank_mem_1[14][13]
+ D=FE_DBTN54_bank_wdata_1_13 CK=CTS_298
Xbank_mem_1_reg[14][12] QDFFN $PINS Q=bank_mem_1[14][12]
+ D=FE_DBTN53_bank_wdata_1_12 CK=CTS_298
Xbank_mem_1_reg[14][11] QDFFN $PINS Q=bank_mem_1[14][11]
+ D=FE_DBTN52_bank_wdata_1_11 CK=CTS_298
Xbank_mem_1_reg[14][10] QDFFN $PINS Q=bank_mem_1[14][10]
+ D=FE_DBTN51_bank_wdata_1_10 CK=CTS_298
Xbank_mem_1_reg[14][9] QDFFN $PINS Q=bank_mem_1[14][9]
+ D=FE_DBTN50_bank_wdata_1_9 CK=CTS_298
Xbank_mem_1_reg[14][8] QDFFN $PINS Q=bank_mem_1[14][8]
+ D=FE_DBTN49_bank_wdata_1_8 CK=CTS_298
Xbank_mem_1_reg[14][7] QDFFN $PINS Q=bank_mem_1[14][7]
+ D=FE_DBTN48_bank_wdata_1_7 CK=CTS_298
Xbank_mem_1_reg[14][6] QDFFN $PINS Q=bank_mem_1[14][6]
+ D=FE_DBTN47_bank_wdata_1_6 CK=CTS_298
Xbank_mem_1_reg[14][5] QDFFN $PINS Q=bank_mem_1[14][5]
+ D=FE_DBTN46_bank_wdata_1_5 CK=CTS_298
Xbank_mem_1_reg[14][4] QDFFN $PINS Q=bank_mem_1[14][4]
+ D=FE_DBTN45_bank_wdata_1_4 CK=CTS_298
Xbank_mem_1_reg[14][3] QDFFN $PINS Q=bank_mem_1[14][3]
+ D=FE_DBTN44_bank_wdata_1_3 CK=CTS_298
Xbank_mem_1_reg[14][2] QDFFN $PINS Q=bank_mem_1[14][2]
+ D=FE_DBTN43_bank_wdata_1_2 CK=CTS_298
Xbank_mem_1_reg[14][1] QDFFN $PINS Q=bank_mem_1[14][1]
+ D=FE_DBTN42_bank_wdata_1_1 CK=CTS_298
Xbank_mem_1_reg[14][0] QDFFN $PINS Q=bank_mem_1[14][0]
+ D=FE_DBTN41_bank_wdata_1_0 CK=CTS_298
Xbank_mem_1_reg[15][21] QDFFN $PINS Q=bank_mem_1[15][21]
+ D=FE_DBTN62_bank_wdata_1_21 CK=CTS_295
Xbank_mem_1_reg[12][20] QDFFN $PINS Q=bank_mem_1[12][20]
+ D=FE_DBTN61_bank_wdata_1_20 CK=CTS_304
Xbank_mem_1_reg[12][19] QDFFN $PINS Q=bank_mem_1[12][19]
+ D=FE_DBTN60_bank_wdata_1_19 CK=CTS_304
Xbank_mem_1_reg[12][18] QDFFN $PINS Q=bank_mem_1[12][18]
+ D=FE_DBTN59_bank_wdata_1_18 CK=CTS_304
Xbank_mem_1_reg[12][17] QDFFN $PINS Q=bank_mem_1[12][17]
+ D=FE_DBTN58_bank_wdata_1_17 CK=CTS_304
Xbank_mem_1_reg[12][16] QDFFN $PINS Q=bank_mem_1[12][16]
+ D=FE_DBTN57_bank_wdata_1_16 CK=CTS_304
Xbank_mem_1_reg[12][15] QDFFN $PINS Q=bank_mem_1[12][15]
+ D=FE_DBTN56_bank_wdata_1_15 CK=CTS_304
Xbank_mem_1_reg[12][14] QDFFN $PINS Q=bank_mem_1[12][14]
+ D=FE_DBTN55_bank_wdata_1_14 CK=CTS_304
Xbank_mem_1_reg[12][13] QDFFN $PINS Q=bank_mem_1[12][13]
+ D=FE_DBTN54_bank_wdata_1_13 CK=CTS_304
Xbank_mem_1_reg[12][12] QDFFN $PINS Q=bank_mem_1[12][12]
+ D=FE_DBTN53_bank_wdata_1_12 CK=CTS_304
Xbank_mem_1_reg[12][11] QDFFN $PINS Q=bank_mem_1[12][11]
+ D=FE_DBTN52_bank_wdata_1_11 CK=CTS_304
Xbank_mem_1_reg[12][10] QDFFN $PINS Q=bank_mem_1[12][10]
+ D=FE_DBTN51_bank_wdata_1_10 CK=CTS_304
Xbank_mem_1_reg[12][9] QDFFN $PINS Q=bank_mem_1[12][9]
+ D=FE_DBTN50_bank_wdata_1_9 CK=CTS_304
Xbank_mem_1_reg[12][8] QDFFN $PINS Q=bank_mem_1[12][8]
+ D=FE_DBTN49_bank_wdata_1_8 CK=CTS_304
Xbank_mem_1_reg[12][7] QDFFN $PINS Q=bank_mem_1[12][7]
+ D=FE_DBTN48_bank_wdata_1_7 CK=CTS_304
Xbank_mem_1_reg[12][6] QDFFN $PINS Q=bank_mem_1[12][6]
+ D=FE_DBTN47_bank_wdata_1_6 CK=CTS_304
Xbank_mem_1_reg[12][5] QDFFN $PINS Q=bank_mem_1[12][5]
+ D=FE_DBTN46_bank_wdata_1_5 CK=CTS_304
Xbank_mem_1_reg[12][4] QDFFN $PINS Q=bank_mem_1[12][4]
+ D=FE_DBTN45_bank_wdata_1_4 CK=CTS_304
Xbank_mem_1_reg[12][3] QDFFN $PINS Q=bank_mem_1[12][3]
+ D=FE_DBTN44_bank_wdata_1_3 CK=CTS_304
Xbank_mem_1_reg[12][2] QDFFN $PINS Q=bank_mem_1[12][2]
+ D=FE_DBTN43_bank_wdata_1_2 CK=CTS_304
Xbank_mem_1_reg[12][1] QDFFN $PINS Q=bank_mem_1[12][1]
+ D=FE_DBTN42_bank_wdata_1_1 CK=CTS_304
Xbank_mem_1_reg[12][0] QDFFN $PINS Q=bank_mem_1[12][0]
+ D=FE_DBTN41_bank_wdata_1_0 CK=CTS_304
Xbank_mem_1_reg[13][21] QDFFN $PINS Q=bank_mem_1[13][21]
+ D=FE_DBTN62_bank_wdata_1_21 CK=CTS_301
Xbank_mem_0_reg[15][20] QDFFN $PINS Q=bank_mem_0[15][20]
+ D=FE_DBTN82_bank_wdata_0_20 CK=CTS_345
Xbank_mem_0_reg[15][19] QDFFN $PINS Q=bank_mem_0[15][19] D=FE_DBTN40_n2
+ CK=CTS_345
Xbank_mem_0_reg[15][18] QDFFN $PINS Q=bank_mem_0[15][18]
+ D=FE_DBTN81_bank_wdata_0_18 CK=CTS_345
Xbank_mem_0_reg[15][17] QDFFN $PINS Q=bank_mem_0[15][17]
+ D=FE_DBTN80_bank_wdata_0_17 CK=CTS_345
Xbank_mem_0_reg[15][16] QDFFN $PINS Q=bank_mem_0[15][16]
+ D=FE_DBTN79_bank_wdata_0_16 CK=CTS_345
Xbank_mem_0_reg[15][15] QDFFN $PINS Q=bank_mem_0[15][15]
+ D=FE_DBTN78_bank_wdata_0_15 CK=CTS_345
Xbank_mem_0_reg[15][14] QDFFN $PINS Q=bank_mem_0[15][14]
+ D=FE_DBTN77_bank_wdata_0_14 CK=CTS_345
Xbank_mem_0_reg[15][13] QDFFN $PINS Q=bank_mem_0[15][13]
+ D=FE_DBTN76_bank_wdata_0_13 CK=CTS_345
Xbank_mem_0_reg[15][12] QDFFN $PINS Q=bank_mem_0[15][12]
+ D=FE_DBTN75_bank_wdata_0_12 CK=CTS_345
Xbank_mem_0_reg[15][11] QDFFN $PINS Q=bank_mem_0[15][11]
+ D=FE_DBTN74_bank_wdata_0_11 CK=CTS_345
Xbank_mem_0_reg[15][10] QDFFN $PINS Q=bank_mem_0[15][10]
+ D=FE_DBTN73_bank_wdata_0_10 CK=CTS_345
Xbank_mem_0_reg[15][9] QDFFN $PINS Q=bank_mem_0[15][9]
+ D=FE_DBTN72_bank_wdata_0_9 CK=CTS_345
Xbank_mem_0_reg[15][8] QDFFN $PINS Q=bank_mem_0[15][8]
+ D=FE_DBTN71_bank_wdata_0_8 CK=CTS_345
Xbank_mem_0_reg[15][7] QDFFN $PINS Q=bank_mem_0[15][7]
+ D=FE_DBTN70_bank_wdata_0_7 CK=CTS_345
Xbank_mem_0_reg[15][6] QDFFN $PINS Q=bank_mem_0[15][6]
+ D=FE_DBTN69_bank_wdata_0_6 CK=CTS_345
Xbank_mem_0_reg[15][5] QDFFN $PINS Q=bank_mem_0[15][5]
+ D=FE_DBTN68_bank_wdata_0_5 CK=CTS_345
Xbank_mem_0_reg[15][4] QDFFN $PINS Q=bank_mem_0[15][4]
+ D=FE_DBTN67_bank_wdata_0_4 CK=CTS_345
Xbank_mem_0_reg[15][3] QDFFN $PINS Q=bank_mem_0[15][3]
+ D=FE_DBTN66_bank_wdata_0_3 CK=CTS_345
Xbank_mem_0_reg[15][2] QDFFN $PINS Q=bank_mem_0[15][2]
+ D=FE_DBTN65_bank_wdata_0_2 CK=CTS_345
Xbank_mem_0_reg[15][1] QDFFN $PINS Q=bank_mem_0[15][1]
+ D=FE_DBTN64_bank_wdata_0_1 CK=CTS_345
Xbank_mem_0_reg[15][0] QDFFN $PINS Q=bank_mem_0[15][0]
+ D=FE_DBTN63_bank_wdata_0_0 CK=CTS_345
Xbank_mem_0_reg[13][20] QDFFN $PINS Q=bank_mem_0[13][20]
+ D=FE_DBTN82_bank_wdata_0_20 CK=CTS_351
Xbank_mem_0_reg[13][19] QDFFN $PINS Q=bank_mem_0[13][19] D=FE_DBTN40_n2
+ CK=CTS_351
Xbank_mem_0_reg[13][18] QDFFN $PINS Q=bank_mem_0[13][18]
+ D=FE_DBTN81_bank_wdata_0_18 CK=CTS_351
Xbank_mem_0_reg[13][17] QDFFN $PINS Q=bank_mem_0[13][17]
+ D=FE_DBTN80_bank_wdata_0_17 CK=CTS_351
Xbank_mem_0_reg[13][16] QDFFN $PINS Q=bank_mem_0[13][16]
+ D=FE_DBTN79_bank_wdata_0_16 CK=CTS_351
Xbank_mem_0_reg[13][15] QDFFN $PINS Q=bank_mem_0[13][15]
+ D=FE_DBTN78_bank_wdata_0_15 CK=CTS_351
Xbank_mem_0_reg[13][14] QDFFN $PINS Q=bank_mem_0[13][14]
+ D=FE_DBTN77_bank_wdata_0_14 CK=CTS_351
Xbank_mem_0_reg[13][13] QDFFN $PINS Q=bank_mem_0[13][13]
+ D=FE_DBTN76_bank_wdata_0_13 CK=CTS_351
Xbank_mem_0_reg[13][12] QDFFN $PINS Q=bank_mem_0[13][12]
+ D=FE_DBTN75_bank_wdata_0_12 CK=CTS_351
Xbank_mem_0_reg[13][11] QDFFN $PINS Q=bank_mem_0[13][11]
+ D=FE_DBTN74_bank_wdata_0_11 CK=CTS_351
Xbank_mem_0_reg[13][10] QDFFN $PINS Q=bank_mem_0[13][10]
+ D=FE_DBTN73_bank_wdata_0_10 CK=CTS_351
Xbank_mem_0_reg[13][9] QDFFN $PINS Q=bank_mem_0[13][9]
+ D=FE_DBTN72_bank_wdata_0_9 CK=CTS_351
Xbank_mem_0_reg[13][8] QDFFN $PINS Q=bank_mem_0[13][8]
+ D=FE_DBTN71_bank_wdata_0_8 CK=CTS_351
Xbank_mem_0_reg[13][7] QDFFN $PINS Q=bank_mem_0[13][7]
+ D=FE_DBTN70_bank_wdata_0_7 CK=CTS_351
Xbank_mem_0_reg[13][6] QDFFN $PINS Q=bank_mem_0[13][6]
+ D=FE_DBTN69_bank_wdata_0_6 CK=CTS_351
Xbank_mem_0_reg[13][5] QDFFN $PINS Q=bank_mem_0[13][5]
+ D=FE_DBTN68_bank_wdata_0_5 CK=CTS_351
Xbank_mem_0_reg[13][4] QDFFN $PINS Q=bank_mem_0[13][4]
+ D=FE_DBTN67_bank_wdata_0_4 CK=CTS_351
Xbank_mem_0_reg[13][3] QDFFN $PINS Q=bank_mem_0[13][3]
+ D=FE_DBTN66_bank_wdata_0_3 CK=CTS_351
Xbank_mem_0_reg[13][2] QDFFN $PINS Q=bank_mem_0[13][2]
+ D=FE_DBTN65_bank_wdata_0_2 CK=CTS_351
Xbank_mem_0_reg[13][1] QDFFN $PINS Q=bank_mem_0[13][1]
+ D=FE_DBTN64_bank_wdata_0_1 CK=CTS_351
Xbank_mem_0_reg[13][0] QDFFN $PINS Q=bank_mem_0[13][0]
+ D=FE_DBTN63_bank_wdata_0_0 CK=CTS_351
Xbank_mem_1_reg[14][21] QDFFN $PINS Q=bank_mem_1[14][21]
+ D=FE_DBTN62_bank_wdata_1_21 CK=CTS_298
Xbank_mem_1_reg[12][21] QDFFN $PINS Q=bank_mem_1[12][21]
+ D=FE_DBTN62_bank_wdata_1_21 CK=CTS_304
Xbank_mem_1_reg[0][21] QDFFN $PINS Q=bank_mem_1[0][21]
+ D=FE_DBTN62_bank_wdata_1_21 CK=CTS_340
Xbank_mem_1_reg[0][20] QDFFN $PINS Q=bank_mem_1[0][20]
+ D=FE_DBTN61_bank_wdata_1_20 CK=CTS_340
Xbank_mem_1_reg[0][19] QDFFN $PINS Q=bank_mem_1[0][19]
+ D=FE_DBTN60_bank_wdata_1_19 CK=CTS_340
Xbank_mem_1_reg[0][18] QDFFN $PINS Q=bank_mem_1[0][18]
+ D=FE_DBTN59_bank_wdata_1_18 CK=CTS_340
Xbank_mem_1_reg[0][17] QDFFN $PINS Q=bank_mem_1[0][17]
+ D=FE_DBTN58_bank_wdata_1_17 CK=CTS_340
Xbank_mem_1_reg[0][16] QDFFN $PINS Q=bank_mem_1[0][16]
+ D=FE_DBTN57_bank_wdata_1_16 CK=CTS_340
Xbank_mem_1_reg[0][15] QDFFN $PINS Q=bank_mem_1[0][15]
+ D=FE_DBTN56_bank_wdata_1_15 CK=CTS_340
Xbank_mem_1_reg[0][14] QDFFN $PINS Q=bank_mem_1[0][14]
+ D=FE_DBTN55_bank_wdata_1_14 CK=CTS_340
Xbank_mem_1_reg[0][13] QDFFN $PINS Q=bank_mem_1[0][13]
+ D=FE_DBTN54_bank_wdata_1_13 CK=CTS_340
Xbank_mem_1_reg[0][12] QDFFN $PINS Q=bank_mem_1[0][12]
+ D=FE_DBTN53_bank_wdata_1_12 CK=CTS_340
Xbank_mem_1_reg[0][11] QDFFN $PINS Q=bank_mem_1[0][11]
+ D=FE_DBTN52_bank_wdata_1_11 CK=CTS_340
Xbank_mem_1_reg[0][10] QDFFN $PINS Q=bank_mem_1[0][10]
+ D=FE_DBTN51_bank_wdata_1_10 CK=CTS_340
Xbank_mem_1_reg[0][9] QDFFN $PINS Q=bank_mem_1[0][9] D=FE_DBTN50_bank_wdata_1_9
+ CK=CTS_340
Xbank_mem_1_reg[0][8] QDFFN $PINS Q=bank_mem_1[0][8] D=FE_DBTN49_bank_wdata_1_8
+ CK=CTS_340
Xbank_mem_1_reg[0][7] QDFFN $PINS Q=bank_mem_1[0][7] D=FE_DBTN48_bank_wdata_1_7
+ CK=CTS_340
Xbank_mem_1_reg[0][6] QDFFN $PINS Q=bank_mem_1[0][6] D=FE_DBTN47_bank_wdata_1_6
+ CK=CTS_340
Xbank_mem_1_reg[0][5] QDFFN $PINS Q=bank_mem_1[0][5] D=FE_DBTN46_bank_wdata_1_5
+ CK=CTS_340
Xbank_mem_1_reg[0][4] QDFFN $PINS Q=bank_mem_1[0][4] D=FE_DBTN45_bank_wdata_1_4
+ CK=CTS_340
Xbank_mem_1_reg[0][3] QDFFN $PINS Q=bank_mem_1[0][3] D=FE_DBTN44_bank_wdata_1_3
+ CK=CTS_340
Xbank_mem_1_reg[0][2] QDFFN $PINS Q=bank_mem_1[0][2] D=FE_DBTN43_bank_wdata_1_2
+ CK=CTS_340
Xbank_mem_1_reg[0][1] QDFFN $PINS Q=bank_mem_1[0][1] D=FE_DBTN42_bank_wdata_1_1
+ CK=CTS_340
Xbank_mem_1_reg[0][0] QDFFN $PINS Q=bank_mem_1[0][0] D=FE_DBTN41_bank_wdata_1_0
+ CK=CTS_340
Xbank_mem_0_reg[14][20] QDFFN $PINS Q=bank_mem_0[14][20]
+ D=FE_DBTN82_bank_wdata_0_20 CK=CTS_348
Xbank_mem_0_reg[14][19] QDFFN $PINS Q=bank_mem_0[14][19] D=FE_DBTN40_n2
+ CK=CTS_348
Xbank_mem_0_reg[14][18] QDFFN $PINS Q=bank_mem_0[14][18]
+ D=FE_DBTN81_bank_wdata_0_18 CK=CTS_348
Xbank_mem_0_reg[14][17] QDFFN $PINS Q=bank_mem_0[14][17]
+ D=FE_DBTN80_bank_wdata_0_17 CK=CTS_348
Xbank_mem_0_reg[14][16] QDFFN $PINS Q=bank_mem_0[14][16]
+ D=FE_DBTN79_bank_wdata_0_16 CK=CTS_348
Xbank_mem_0_reg[14][15] QDFFN $PINS Q=bank_mem_0[14][15]
+ D=FE_DBTN78_bank_wdata_0_15 CK=CTS_348
Xbank_mem_0_reg[14][14] QDFFN $PINS Q=bank_mem_0[14][14]
+ D=FE_DBTN77_bank_wdata_0_14 CK=CTS_348
Xbank_mem_0_reg[14][13] QDFFN $PINS Q=bank_mem_0[14][13]
+ D=FE_DBTN76_bank_wdata_0_13 CK=CTS_348
Xbank_mem_0_reg[14][12] QDFFN $PINS Q=bank_mem_0[14][12]
+ D=FE_DBTN75_bank_wdata_0_12 CK=CTS_348
Xbank_mem_0_reg[14][11] QDFFN $PINS Q=bank_mem_0[14][11]
+ D=FE_DBTN74_bank_wdata_0_11 CK=CTS_348
Xbank_mem_0_reg[14][10] QDFFN $PINS Q=bank_mem_0[14][10]
+ D=FE_DBTN73_bank_wdata_0_10 CK=CTS_348
Xbank_mem_0_reg[14][9] QDFFN $PINS Q=bank_mem_0[14][9]
+ D=FE_DBTN72_bank_wdata_0_9 CK=CTS_348
Xbank_mem_0_reg[14][8] QDFFN $PINS Q=bank_mem_0[14][8]
+ D=FE_DBTN71_bank_wdata_0_8 CK=CTS_348
Xbank_mem_0_reg[14][7] QDFFN $PINS Q=bank_mem_0[14][7]
+ D=FE_DBTN70_bank_wdata_0_7 CK=CTS_348
Xbank_mem_0_reg[14][6] QDFFN $PINS Q=bank_mem_0[14][6]
+ D=FE_DBTN69_bank_wdata_0_6 CK=CTS_348
Xbank_mem_0_reg[14][5] QDFFN $PINS Q=bank_mem_0[14][5]
+ D=FE_DBTN68_bank_wdata_0_5 CK=CTS_348
Xbank_mem_0_reg[14][4] QDFFN $PINS Q=bank_mem_0[14][4]
+ D=FE_DBTN67_bank_wdata_0_4 CK=CTS_348
Xbank_mem_0_reg[14][3] QDFFN $PINS Q=bank_mem_0[14][3]
+ D=FE_DBTN66_bank_wdata_0_3 CK=CTS_348
Xbank_mem_0_reg[14][2] QDFFN $PINS Q=bank_mem_0[14][2]
+ D=FE_DBTN65_bank_wdata_0_2 CK=CTS_348
Xbank_mem_0_reg[14][1] QDFFN $PINS Q=bank_mem_0[14][1]
+ D=FE_DBTN64_bank_wdata_0_1 CK=CTS_348
Xbank_mem_0_reg[14][0] QDFFN $PINS Q=bank_mem_0[14][0]
+ D=FE_DBTN63_bank_wdata_0_0 CK=CTS_348
Xbank_mem_0_reg[15][21] QDFFN $PINS Q=bank_mem_0[15][21]
+ D=FE_DBTN83_bank_wdata_0_21 CK=CTS_345
Xbank_mem_0_reg[12][20] QDFFN $PINS Q=bank_mem_0[12][20]
+ D=FE_DBTN82_bank_wdata_0_20 CK=CTS_354
Xbank_mem_0_reg[12][19] QDFFN $PINS Q=bank_mem_0[12][19] D=FE_DBTN40_n2
+ CK=CTS_354
Xbank_mem_0_reg[12][18] QDFFN $PINS Q=bank_mem_0[12][18]
+ D=FE_DBTN81_bank_wdata_0_18 CK=CTS_354
Xbank_mem_0_reg[12][17] QDFFN $PINS Q=bank_mem_0[12][17]
+ D=FE_DBTN80_bank_wdata_0_17 CK=CTS_354
Xbank_mem_0_reg[12][16] QDFFN $PINS Q=bank_mem_0[12][16]
+ D=FE_DBTN79_bank_wdata_0_16 CK=CTS_354
Xbank_mem_0_reg[12][15] QDFFN $PINS Q=bank_mem_0[12][15]
+ D=FE_DBTN78_bank_wdata_0_15 CK=CTS_354
Xbank_mem_0_reg[12][14] QDFFN $PINS Q=bank_mem_0[12][14]
+ D=FE_DBTN77_bank_wdata_0_14 CK=CTS_354
Xbank_mem_0_reg[12][13] QDFFN $PINS Q=bank_mem_0[12][13]
+ D=FE_DBTN76_bank_wdata_0_13 CK=CTS_354
Xbank_mem_0_reg[12][12] QDFFN $PINS Q=bank_mem_0[12][12]
+ D=FE_DBTN75_bank_wdata_0_12 CK=CTS_354
Xbank_mem_0_reg[12][11] QDFFN $PINS Q=bank_mem_0[12][11]
+ D=FE_DBTN74_bank_wdata_0_11 CK=CTS_354
Xbank_mem_0_reg[12][10] QDFFN $PINS Q=bank_mem_0[12][10]
+ D=FE_DBTN73_bank_wdata_0_10 CK=CTS_354
Xbank_mem_0_reg[12][9] QDFFN $PINS Q=bank_mem_0[12][9]
+ D=FE_DBTN72_bank_wdata_0_9 CK=CTS_354
Xbank_mem_0_reg[12][8] QDFFN $PINS Q=bank_mem_0[12][8]
+ D=FE_DBTN71_bank_wdata_0_8 CK=CTS_354
Xbank_mem_0_reg[12][7] QDFFN $PINS Q=bank_mem_0[12][7]
+ D=FE_DBTN70_bank_wdata_0_7 CK=CTS_354
Xbank_mem_0_reg[12][6] QDFFN $PINS Q=bank_mem_0[12][6]
+ D=FE_DBTN69_bank_wdata_0_6 CK=CTS_354
Xbank_mem_0_reg[12][5] QDFFN $PINS Q=bank_mem_0[12][5]
+ D=FE_DBTN68_bank_wdata_0_5 CK=CTS_354
Xbank_mem_0_reg[12][4] QDFFN $PINS Q=bank_mem_0[12][4]
+ D=FE_DBTN67_bank_wdata_0_4 CK=CTS_354
Xbank_mem_0_reg[12][3] QDFFN $PINS Q=bank_mem_0[12][3]
+ D=FE_DBTN66_bank_wdata_0_3 CK=CTS_354
Xbank_mem_0_reg[12][2] QDFFN $PINS Q=bank_mem_0[12][2]
+ D=FE_DBTN65_bank_wdata_0_2 CK=CTS_354
Xbank_mem_0_reg[12][1] QDFFN $PINS Q=bank_mem_0[12][1]
+ D=FE_DBTN64_bank_wdata_0_1 CK=CTS_354
Xbank_mem_0_reg[12][0] QDFFN $PINS Q=bank_mem_0[12][0]
+ D=FE_DBTN63_bank_wdata_0_0 CK=CTS_354
Xbank_mem_0_reg[13][21] QDFFN $PINS Q=bank_mem_0[13][21]
+ D=FE_DBTN83_bank_wdata_0_21 CK=CTS_351
Xbank_mem_1_reg[1][21] QDFFN $PINS Q=bank_mem_1[1][21]
+ D=FE_DBTN62_bank_wdata_1_21 CK=CTS_337
Xbank_mem_1_reg[1][20] QDFFN $PINS Q=bank_mem_1[1][20]
+ D=FE_DBTN61_bank_wdata_1_20 CK=CTS_337
Xbank_mem_1_reg[1][19] QDFFN $PINS Q=bank_mem_1[1][19]
+ D=FE_DBTN60_bank_wdata_1_19 CK=CTS_337
Xbank_mem_1_reg[1][18] QDFFN $PINS Q=bank_mem_1[1][18]
+ D=FE_DBTN59_bank_wdata_1_18 CK=CTS_337
Xbank_mem_1_reg[1][17] QDFFN $PINS Q=bank_mem_1[1][17]
+ D=FE_DBTN58_bank_wdata_1_17 CK=CTS_337
Xbank_mem_1_reg[1][16] QDFFN $PINS Q=bank_mem_1[1][16]
+ D=FE_DBTN57_bank_wdata_1_16 CK=CTS_337
Xbank_mem_1_reg[1][15] QDFFN $PINS Q=bank_mem_1[1][15]
+ D=FE_DBTN56_bank_wdata_1_15 CK=CTS_337
Xbank_mem_1_reg[1][14] QDFFN $PINS Q=bank_mem_1[1][14]
+ D=FE_DBTN55_bank_wdata_1_14 CK=CTS_337
Xbank_mem_1_reg[1][13] QDFFN $PINS Q=bank_mem_1[1][13]
+ D=FE_DBTN54_bank_wdata_1_13 CK=CTS_337
Xbank_mem_1_reg[1][12] QDFFN $PINS Q=bank_mem_1[1][12]
+ D=FE_DBTN53_bank_wdata_1_12 CK=CTS_337
Xbank_mem_1_reg[1][11] QDFFN $PINS Q=bank_mem_1[1][11]
+ D=FE_DBTN52_bank_wdata_1_11 CK=CTS_337
Xbank_mem_1_reg[1][10] QDFFN $PINS Q=bank_mem_1[1][10]
+ D=FE_DBTN51_bank_wdata_1_10 CK=CTS_337
Xbank_mem_1_reg[1][9] QDFFN $PINS Q=bank_mem_1[1][9] D=FE_DBTN50_bank_wdata_1_9
+ CK=CTS_337
Xbank_mem_1_reg[1][8] QDFFN $PINS Q=bank_mem_1[1][8] D=FE_DBTN49_bank_wdata_1_8
+ CK=CTS_337
Xbank_mem_1_reg[1][7] QDFFN $PINS Q=bank_mem_1[1][7] D=FE_DBTN48_bank_wdata_1_7
+ CK=CTS_337
Xbank_mem_1_reg[1][6] QDFFN $PINS Q=bank_mem_1[1][6] D=FE_DBTN47_bank_wdata_1_6
+ CK=CTS_337
Xbank_mem_1_reg[1][5] QDFFN $PINS Q=bank_mem_1[1][5] D=FE_DBTN46_bank_wdata_1_5
+ CK=CTS_337
Xbank_mem_1_reg[1][4] QDFFN $PINS Q=bank_mem_1[1][4] D=FE_DBTN45_bank_wdata_1_4
+ CK=CTS_337
Xbank_mem_1_reg[1][3] QDFFN $PINS Q=bank_mem_1[1][3] D=FE_DBTN44_bank_wdata_1_3
+ CK=CTS_337
Xbank_mem_1_reg[1][2] QDFFN $PINS Q=bank_mem_1[1][2] D=FE_DBTN43_bank_wdata_1_2
+ CK=CTS_337
Xbank_mem_1_reg[1][1] QDFFN $PINS Q=bank_mem_1[1][1] D=FE_DBTN42_bank_wdata_1_1
+ CK=CTS_337
Xbank_mem_1_reg[1][0] QDFFN $PINS Q=bank_mem_1[1][0] D=FE_DBTN41_bank_wdata_1_0
+ CK=CTS_337
Xbank_mem_0_reg[14][21] QDFFN $PINS Q=bank_mem_0[14][21]
+ D=FE_DBTN83_bank_wdata_0_21 CK=CTS_348
Xbank_mem_0_reg[12][21] QDFFN $PINS Q=bank_mem_0[12][21]
+ D=FE_DBTN83_bank_wdata_0_21 CK=CTS_354
Xbank_mem_0_reg[0][21] QDFFN $PINS Q=bank_mem_0[0][21]
+ D=FE_DBTN83_bank_wdata_0_21 CK=CTS_390
Xbank_mem_0_reg[0][20] QDFFN $PINS Q=bank_mem_0[0][20]
+ D=FE_DBTN82_bank_wdata_0_20 CK=CTS_390
Xbank_mem_0_reg[0][19] QDFFN $PINS Q=bank_mem_0[0][19] D=FE_DBTN40_n2
+ CK=CTS_390
Xbank_mem_0_reg[0][18] QDFFN $PINS Q=bank_mem_0[0][18]
+ D=FE_DBTN81_bank_wdata_0_18 CK=CTS_390
Xbank_mem_0_reg[0][17] QDFFN $PINS Q=bank_mem_0[0][17]
+ D=FE_DBTN80_bank_wdata_0_17 CK=CTS_390
Xbank_mem_0_reg[0][16] QDFFN $PINS Q=bank_mem_0[0][16]
+ D=FE_DBTN79_bank_wdata_0_16 CK=CTS_390
Xbank_mem_0_reg[0][15] QDFFN $PINS Q=bank_mem_0[0][15]
+ D=FE_DBTN78_bank_wdata_0_15 CK=CTS_390
Xbank_mem_0_reg[0][14] QDFFN $PINS Q=bank_mem_0[0][14]
+ D=FE_DBTN77_bank_wdata_0_14 CK=CTS_390
Xbank_mem_0_reg[0][13] QDFFN $PINS Q=bank_mem_0[0][13]
+ D=FE_DBTN76_bank_wdata_0_13 CK=CTS_390
Xbank_mem_0_reg[0][12] QDFFN $PINS Q=bank_mem_0[0][12]
+ D=FE_DBTN75_bank_wdata_0_12 CK=CTS_390
Xbank_mem_0_reg[0][11] QDFFN $PINS Q=bank_mem_0[0][11]
+ D=FE_DBTN74_bank_wdata_0_11 CK=CTS_390
Xbank_mem_0_reg[0][10] QDFFN $PINS Q=bank_mem_0[0][10]
+ D=FE_DBTN73_bank_wdata_0_10 CK=CTS_390
Xbank_mem_0_reg[0][9] QDFFN $PINS Q=bank_mem_0[0][9] D=FE_DBTN72_bank_wdata_0_9
+ CK=CTS_390
Xbank_mem_0_reg[0][8] QDFFN $PINS Q=bank_mem_0[0][8] D=FE_DBTN71_bank_wdata_0_8
+ CK=CTS_390
Xbank_mem_0_reg[0][7] QDFFN $PINS Q=bank_mem_0[0][7] D=FE_DBTN70_bank_wdata_0_7
+ CK=CTS_390
Xbank_mem_0_reg[0][6] QDFFN $PINS Q=bank_mem_0[0][6] D=FE_DBTN69_bank_wdata_0_6
+ CK=CTS_390
Xbank_mem_0_reg[0][5] QDFFN $PINS Q=bank_mem_0[0][5] D=FE_DBTN68_bank_wdata_0_5
+ CK=CTS_390
Xbank_mem_0_reg[0][4] QDFFN $PINS Q=bank_mem_0[0][4] D=FE_DBTN67_bank_wdata_0_4
+ CK=CTS_390
Xbank_mem_0_reg[0][3] QDFFN $PINS Q=bank_mem_0[0][3] D=FE_DBTN66_bank_wdata_0_3
+ CK=CTS_390
Xbank_mem_0_reg[0][2] QDFFN $PINS Q=bank_mem_0[0][2] D=FE_DBTN65_bank_wdata_0_2
+ CK=CTS_390
Xbank_mem_0_reg[0][1] QDFFN $PINS Q=bank_mem_0[0][1] D=FE_DBTN64_bank_wdata_0_1
+ CK=CTS_390
Xbank_mem_0_reg[0][0] QDFFN $PINS Q=bank_mem_0[0][0] D=FE_DBTN63_bank_wdata_0_0
+ CK=CTS_390
Xbank_mem_0_reg[1][21] QDFFN $PINS Q=bank_mem_0[1][21]
+ D=FE_DBTN83_bank_wdata_0_21 CK=CTS_387
Xbank_mem_0_reg[1][20] QDFFN $PINS Q=bank_mem_0[1][20]
+ D=FE_DBTN82_bank_wdata_0_20 CK=CTS_387
Xbank_mem_0_reg[1][19] QDFFN $PINS Q=bank_mem_0[1][19] D=FE_DBTN40_n2
+ CK=CTS_387
Xbank_mem_0_reg[1][18] QDFFN $PINS Q=bank_mem_0[1][18]
+ D=FE_DBTN81_bank_wdata_0_18 CK=CTS_387
Xbank_mem_0_reg[1][17] QDFFN $PINS Q=bank_mem_0[1][17]
+ D=FE_DBTN80_bank_wdata_0_17 CK=CTS_387
Xbank_mem_0_reg[1][16] QDFFN $PINS Q=bank_mem_0[1][16]
+ D=FE_DBTN79_bank_wdata_0_16 CK=CTS_387
Xbank_mem_0_reg[1][15] QDFFN $PINS Q=bank_mem_0[1][15]
+ D=FE_DBTN78_bank_wdata_0_15 CK=CTS_387
Xbank_mem_0_reg[1][14] QDFFN $PINS Q=bank_mem_0[1][14]
+ D=FE_DBTN77_bank_wdata_0_14 CK=CTS_387
Xbank_mem_0_reg[1][13] QDFFN $PINS Q=bank_mem_0[1][13]
+ D=FE_DBTN76_bank_wdata_0_13 CK=CTS_387
Xbank_mem_0_reg[1][12] QDFFN $PINS Q=bank_mem_0[1][12]
+ D=FE_DBTN75_bank_wdata_0_12 CK=CTS_387
Xbank_mem_0_reg[1][11] QDFFN $PINS Q=bank_mem_0[1][11]
+ D=FE_DBTN74_bank_wdata_0_11 CK=CTS_387
Xbank_mem_0_reg[1][10] QDFFN $PINS Q=bank_mem_0[1][10]
+ D=FE_DBTN73_bank_wdata_0_10 CK=CTS_387
Xbank_mem_0_reg[1][9] QDFFN $PINS Q=bank_mem_0[1][9] D=FE_DBTN72_bank_wdata_0_9
+ CK=CTS_387
Xbank_mem_0_reg[1][8] QDFFN $PINS Q=bank_mem_0[1][8] D=FE_DBTN71_bank_wdata_0_8
+ CK=CTS_387
Xbank_mem_0_reg[1][7] QDFFN $PINS Q=bank_mem_0[1][7] D=FE_DBTN70_bank_wdata_0_7
+ CK=CTS_387
Xbank_mem_0_reg[1][6] QDFFN $PINS Q=bank_mem_0[1][6] D=FE_DBTN69_bank_wdata_0_6
+ CK=CTS_387
Xbank_mem_0_reg[1][5] QDFFN $PINS Q=bank_mem_0[1][5] D=FE_DBTN68_bank_wdata_0_5
+ CK=CTS_387
Xbank_mem_0_reg[1][4] QDFFN $PINS Q=bank_mem_0[1][4] D=FE_DBTN67_bank_wdata_0_4
+ CK=CTS_387
Xbank_mem_0_reg[1][3] QDFFN $PINS Q=bank_mem_0[1][3] D=FE_DBTN66_bank_wdata_0_3
+ CK=CTS_387
Xbank_mem_0_reg[1][2] QDFFN $PINS Q=bank_mem_0[1][2] D=FE_DBTN65_bank_wdata_0_2
+ CK=CTS_387
Xbank_mem_0_reg[1][1] QDFFN $PINS Q=bank_mem_0[1][1] D=FE_DBTN64_bank_wdata_0_1
+ CK=CTS_387
Xbank_mem_0_reg[1][0] QDFFN $PINS Q=bank_mem_0[1][0] D=FE_DBTN63_bank_wdata_0_0
+ CK=CTS_387
Xbank_mem_1_reg[9][20] QDFFN $PINS Q=bank_mem_1[9][20]
+ D=FE_DBTN61_bank_wdata_1_20 CK=CTS_313
Xbank_mem_1_reg[9][19] QDFFN $PINS Q=bank_mem_1[9][19]
+ D=FE_DBTN60_bank_wdata_1_19 CK=CTS_313
Xbank_mem_1_reg[9][18] QDFFN $PINS Q=bank_mem_1[9][18]
+ D=FE_DBTN59_bank_wdata_1_18 CK=CTS_313
Xbank_mem_1_reg[9][17] QDFFN $PINS Q=bank_mem_1[9][17]
+ D=FE_DBTN58_bank_wdata_1_17 CK=CTS_313
Xbank_mem_1_reg[9][16] QDFFN $PINS Q=bank_mem_1[9][16]
+ D=FE_DBTN57_bank_wdata_1_16 CK=CTS_313
Xbank_mem_1_reg[9][15] QDFFN $PINS Q=bank_mem_1[9][15]
+ D=FE_DBTN56_bank_wdata_1_15 CK=CTS_313
Xbank_mem_1_reg[9][14] QDFFN $PINS Q=bank_mem_1[9][14]
+ D=FE_DBTN55_bank_wdata_1_14 CK=CTS_313
Xbank_mem_1_reg[9][13] QDFFN $PINS Q=bank_mem_1[9][13]
+ D=FE_DBTN54_bank_wdata_1_13 CK=CTS_313
Xbank_mem_1_reg[9][12] QDFFN $PINS Q=bank_mem_1[9][12]
+ D=FE_DBTN53_bank_wdata_1_12 CK=CTS_313
Xbank_mem_1_reg[9][11] QDFFN $PINS Q=bank_mem_1[9][11]
+ D=FE_DBTN52_bank_wdata_1_11 CK=CTS_313
Xbank_mem_1_reg[9][10] QDFFN $PINS Q=bank_mem_1[9][10]
+ D=FE_DBTN51_bank_wdata_1_10 CK=CTS_313
Xbank_mem_1_reg[9][9] QDFFN $PINS Q=bank_mem_1[9][9] D=FE_DBTN50_bank_wdata_1_9
+ CK=CTS_313
Xbank_mem_1_reg[9][8] QDFFN $PINS Q=bank_mem_1[9][8] D=FE_DBTN49_bank_wdata_1_8
+ CK=CTS_313
Xbank_mem_1_reg[9][7] QDFFN $PINS Q=bank_mem_1[9][7] D=FE_DBTN48_bank_wdata_1_7
+ CK=CTS_313
Xbank_mem_1_reg[9][6] QDFFN $PINS Q=bank_mem_1[9][6] D=FE_DBTN47_bank_wdata_1_6
+ CK=CTS_313
Xbank_mem_1_reg[9][5] QDFFN $PINS Q=bank_mem_1[9][5] D=FE_DBTN46_bank_wdata_1_5
+ CK=CTS_313
Xbank_mem_1_reg[9][4] QDFFN $PINS Q=bank_mem_1[9][4] D=FE_DBTN45_bank_wdata_1_4
+ CK=CTS_313
Xbank_mem_1_reg[9][3] QDFFN $PINS Q=bank_mem_1[9][3] D=FE_DBTN44_bank_wdata_1_3
+ CK=CTS_313
Xbank_mem_1_reg[9][2] QDFFN $PINS Q=bank_mem_1[9][2] D=FE_DBTN43_bank_wdata_1_2
+ CK=CTS_313
Xbank_mem_1_reg[9][1] QDFFN $PINS Q=bank_mem_1[9][1] D=FE_DBTN42_bank_wdata_1_1
+ CK=CTS_313
Xbank_mem_1_reg[9][0] QDFFN $PINS Q=bank_mem_1[9][0] D=FE_DBTN41_bank_wdata_1_0
+ CK=CTS_313
Xbank_mem_1_reg[11][20] QDFFN $PINS Q=bank_mem_1[11][20]
+ D=FE_DBTN61_bank_wdata_1_20 CK=CTS_307
Xbank_mem_1_reg[11][19] QDFFN $PINS Q=bank_mem_1[11][19]
+ D=FE_DBTN60_bank_wdata_1_19 CK=CTS_307
Xbank_mem_1_reg[11][18] QDFFN $PINS Q=bank_mem_1[11][18]
+ D=FE_DBTN59_bank_wdata_1_18 CK=CTS_307
Xbank_mem_1_reg[11][17] QDFFN $PINS Q=bank_mem_1[11][17]
+ D=FE_DBTN58_bank_wdata_1_17 CK=CTS_307
Xbank_mem_1_reg[11][16] QDFFN $PINS Q=bank_mem_1[11][16]
+ D=FE_DBTN57_bank_wdata_1_16 CK=CTS_307
Xbank_mem_1_reg[11][15] QDFFN $PINS Q=bank_mem_1[11][15]
+ D=FE_DBTN56_bank_wdata_1_15 CK=CTS_307
Xbank_mem_1_reg[11][14] QDFFN $PINS Q=bank_mem_1[11][14]
+ D=FE_DBTN55_bank_wdata_1_14 CK=CTS_307
Xbank_mem_1_reg[11][13] QDFFN $PINS Q=bank_mem_1[11][13]
+ D=FE_DBTN54_bank_wdata_1_13 CK=CTS_307
Xbank_mem_1_reg[11][12] QDFFN $PINS Q=bank_mem_1[11][12]
+ D=FE_DBTN53_bank_wdata_1_12 CK=CTS_307
Xbank_mem_1_reg[11][11] QDFFN $PINS Q=bank_mem_1[11][11]
+ D=FE_DBTN52_bank_wdata_1_11 CK=CTS_307
Xbank_mem_1_reg[11][10] QDFFN $PINS Q=bank_mem_1[11][10]
+ D=FE_DBTN51_bank_wdata_1_10 CK=CTS_307
Xbank_mem_1_reg[11][9] QDFFN $PINS Q=bank_mem_1[11][9]
+ D=FE_DBTN50_bank_wdata_1_9 CK=CTS_307
Xbank_mem_1_reg[11][8] QDFFN $PINS Q=bank_mem_1[11][8]
+ D=FE_DBTN49_bank_wdata_1_8 CK=CTS_307
Xbank_mem_1_reg[11][7] QDFFN $PINS Q=bank_mem_1[11][7]
+ D=FE_DBTN48_bank_wdata_1_7 CK=CTS_307
Xbank_mem_1_reg[11][6] QDFFN $PINS Q=bank_mem_1[11][6]
+ D=FE_DBTN47_bank_wdata_1_6 CK=CTS_307
Xbank_mem_1_reg[11][5] QDFFN $PINS Q=bank_mem_1[11][5]
+ D=FE_DBTN46_bank_wdata_1_5 CK=CTS_307
Xbank_mem_1_reg[11][4] QDFFN $PINS Q=bank_mem_1[11][4]
+ D=FE_DBTN45_bank_wdata_1_4 CK=CTS_307
Xbank_mem_1_reg[11][3] QDFFN $PINS Q=bank_mem_1[11][3]
+ D=FE_DBTN44_bank_wdata_1_3 CK=CTS_307
Xbank_mem_1_reg[11][2] QDFFN $PINS Q=bank_mem_1[11][2]
+ D=FE_DBTN43_bank_wdata_1_2 CK=CTS_307
Xbank_mem_1_reg[11][1] QDFFN $PINS Q=bank_mem_1[11][1]
+ D=FE_DBTN42_bank_wdata_1_1 CK=CTS_307
Xbank_mem_1_reg[11][0] QDFFN $PINS Q=bank_mem_1[11][0]
+ D=FE_DBTN41_bank_wdata_1_0 CK=CTS_307
Xbank_mem_1_reg[8][20] QDFFN $PINS Q=bank_mem_1[8][20]
+ D=FE_DBTN61_bank_wdata_1_20 CK=CTS_316
Xbank_mem_1_reg[8][19] QDFFN $PINS Q=bank_mem_1[8][19]
+ D=FE_DBTN60_bank_wdata_1_19 CK=CTS_316
Xbank_mem_1_reg[8][18] QDFFN $PINS Q=bank_mem_1[8][18]
+ D=FE_DBTN59_bank_wdata_1_18 CK=CTS_316
Xbank_mem_1_reg[8][17] QDFFN $PINS Q=bank_mem_1[8][17]
+ D=FE_DBTN58_bank_wdata_1_17 CK=CTS_316
Xbank_mem_1_reg[8][16] QDFFN $PINS Q=bank_mem_1[8][16]
+ D=FE_DBTN57_bank_wdata_1_16 CK=CTS_316
Xbank_mem_1_reg[8][15] QDFFN $PINS Q=bank_mem_1[8][15]
+ D=FE_DBTN56_bank_wdata_1_15 CK=CTS_316
Xbank_mem_1_reg[8][14] QDFFN $PINS Q=bank_mem_1[8][14]
+ D=FE_DBTN55_bank_wdata_1_14 CK=CTS_316
Xbank_mem_1_reg[8][13] QDFFN $PINS Q=bank_mem_1[8][13]
+ D=FE_DBTN54_bank_wdata_1_13 CK=CTS_316
Xbank_mem_1_reg[8][12] QDFFN $PINS Q=bank_mem_1[8][12]
+ D=FE_DBTN53_bank_wdata_1_12 CK=CTS_316
Xbank_mem_1_reg[8][11] QDFFN $PINS Q=bank_mem_1[8][11]
+ D=FE_DBTN52_bank_wdata_1_11 CK=CTS_316
Xbank_mem_1_reg[8][10] QDFFN $PINS Q=bank_mem_1[8][10]
+ D=FE_DBTN51_bank_wdata_1_10 CK=CTS_316
Xbank_mem_1_reg[8][9] QDFFN $PINS Q=bank_mem_1[8][9] D=FE_DBTN50_bank_wdata_1_9
+ CK=CTS_316
Xbank_mem_1_reg[8][8] QDFFN $PINS Q=bank_mem_1[8][8] D=FE_DBTN49_bank_wdata_1_8
+ CK=CTS_316
Xbank_mem_1_reg[8][7] QDFFN $PINS Q=bank_mem_1[8][7] D=FE_DBTN48_bank_wdata_1_7
+ CK=CTS_316
Xbank_mem_1_reg[8][6] QDFFN $PINS Q=bank_mem_1[8][6] D=FE_DBTN47_bank_wdata_1_6
+ CK=CTS_316
Xbank_mem_1_reg[8][5] QDFFN $PINS Q=bank_mem_1[8][5] D=FE_DBTN46_bank_wdata_1_5
+ CK=CTS_316
Xbank_mem_1_reg[8][4] QDFFN $PINS Q=bank_mem_1[8][4] D=FE_DBTN45_bank_wdata_1_4
+ CK=CTS_316
Xbank_mem_1_reg[8][3] QDFFN $PINS Q=bank_mem_1[8][3] D=FE_DBTN44_bank_wdata_1_3
+ CK=CTS_316
Xbank_mem_1_reg[8][2] QDFFN $PINS Q=bank_mem_1[8][2] D=FE_DBTN43_bank_wdata_1_2
+ CK=CTS_316
Xbank_mem_1_reg[8][1] QDFFN $PINS Q=bank_mem_1[8][1] D=FE_DBTN42_bank_wdata_1_1
+ CK=CTS_316
Xbank_mem_1_reg[8][0] QDFFN $PINS Q=bank_mem_1[8][0] D=FE_DBTN41_bank_wdata_1_0
+ CK=CTS_316
Xbank_mem_1_reg[9][21] QDFFN $PINS Q=bank_mem_1[9][21]
+ D=FE_DBTN62_bank_wdata_1_21 CK=CTS_313
Xbank_mem_1_reg[10][20] QDFFN $PINS Q=bank_mem_1[10][20]
+ D=FE_DBTN61_bank_wdata_1_20 CK=CTS_310
Xbank_mem_1_reg[10][19] QDFFN $PINS Q=bank_mem_1[10][19]
+ D=FE_DBTN60_bank_wdata_1_19 CK=CTS_310
Xbank_mem_1_reg[10][18] QDFFN $PINS Q=bank_mem_1[10][18]
+ D=FE_DBTN59_bank_wdata_1_18 CK=CTS_310
Xbank_mem_1_reg[10][17] QDFFN $PINS Q=bank_mem_1[10][17]
+ D=FE_DBTN58_bank_wdata_1_17 CK=CTS_310
Xbank_mem_1_reg[10][16] QDFFN $PINS Q=bank_mem_1[10][16]
+ D=FE_DBTN57_bank_wdata_1_16 CK=CTS_310
Xbank_mem_1_reg[10][15] QDFFN $PINS Q=bank_mem_1[10][15]
+ D=FE_DBTN56_bank_wdata_1_15 CK=CTS_310
Xbank_mem_1_reg[10][14] QDFFN $PINS Q=bank_mem_1[10][14]
+ D=FE_DBTN55_bank_wdata_1_14 CK=CTS_310
Xbank_mem_1_reg[10][13] QDFFN $PINS Q=bank_mem_1[10][13]
+ D=FE_DBTN54_bank_wdata_1_13 CK=CTS_310
Xbank_mem_1_reg[10][12] QDFFN $PINS Q=bank_mem_1[10][12]
+ D=FE_DBTN53_bank_wdata_1_12 CK=CTS_310
Xbank_mem_1_reg[10][11] QDFFN $PINS Q=bank_mem_1[10][11]
+ D=FE_DBTN52_bank_wdata_1_11 CK=CTS_310
Xbank_mem_1_reg[10][10] QDFFN $PINS Q=bank_mem_1[10][10]
+ D=FE_DBTN51_bank_wdata_1_10 CK=CTS_310
Xbank_mem_1_reg[10][9] QDFFN $PINS Q=bank_mem_1[10][9]
+ D=FE_DBTN50_bank_wdata_1_9 CK=CTS_310
Xbank_mem_1_reg[10][8] QDFFN $PINS Q=bank_mem_1[10][8]
+ D=FE_DBTN49_bank_wdata_1_8 CK=CTS_310
Xbank_mem_1_reg[10][7] QDFFN $PINS Q=bank_mem_1[10][7]
+ D=FE_DBTN48_bank_wdata_1_7 CK=CTS_310
Xbank_mem_1_reg[10][6] QDFFN $PINS Q=bank_mem_1[10][6]
+ D=FE_DBTN47_bank_wdata_1_6 CK=CTS_310
Xbank_mem_1_reg[10][5] QDFFN $PINS Q=bank_mem_1[10][5]
+ D=FE_DBTN46_bank_wdata_1_5 CK=CTS_310
Xbank_mem_1_reg[10][4] QDFFN $PINS Q=bank_mem_1[10][4]
+ D=FE_DBTN45_bank_wdata_1_4 CK=CTS_310
Xbank_mem_1_reg[10][3] QDFFN $PINS Q=bank_mem_1[10][3]
+ D=FE_DBTN44_bank_wdata_1_3 CK=CTS_310
Xbank_mem_1_reg[10][2] QDFFN $PINS Q=bank_mem_1[10][2]
+ D=FE_DBTN43_bank_wdata_1_2 CK=CTS_310
Xbank_mem_1_reg[10][1] QDFFN $PINS Q=bank_mem_1[10][1]
+ D=FE_DBTN42_bank_wdata_1_1 CK=CTS_310
Xbank_mem_1_reg[10][0] QDFFN $PINS Q=bank_mem_1[10][0]
+ D=FE_DBTN41_bank_wdata_1_0 CK=CTS_310
Xbank_mem_1_reg[11][21] QDFFN $PINS Q=bank_mem_1[11][21]
+ D=FE_DBTN62_bank_wdata_1_21 CK=CTS_307
Xbank_mem_0_reg[9][20] QDFFN $PINS Q=bank_mem_0[9][20]
+ D=FE_DBTN82_bank_wdata_0_20 CK=CTS_363
Xbank_mem_0_reg[9][19] QDFFN $PINS Q=bank_mem_0[9][19] D=FE_DBTN40_n2
+ CK=CTS_363
Xbank_mem_0_reg[9][18] QDFFN $PINS Q=bank_mem_0[9][18]
+ D=FE_DBTN81_bank_wdata_0_18 CK=CTS_363
Xbank_mem_0_reg[9][17] QDFFN $PINS Q=bank_mem_0[9][17]
+ D=FE_DBTN80_bank_wdata_0_17 CK=CTS_363
Xbank_mem_0_reg[9][16] QDFFN $PINS Q=bank_mem_0[9][16]
+ D=FE_DBTN79_bank_wdata_0_16 CK=CTS_363
Xbank_mem_0_reg[9][15] QDFFN $PINS Q=bank_mem_0[9][15]
+ D=FE_DBTN78_bank_wdata_0_15 CK=CTS_363
Xbank_mem_0_reg[9][14] QDFFN $PINS Q=bank_mem_0[9][14]
+ D=FE_DBTN77_bank_wdata_0_14 CK=CTS_363
Xbank_mem_0_reg[9][13] QDFFN $PINS Q=bank_mem_0[9][13]
+ D=FE_DBTN76_bank_wdata_0_13 CK=CTS_363
Xbank_mem_0_reg[9][12] QDFFN $PINS Q=bank_mem_0[9][12]
+ D=FE_DBTN75_bank_wdata_0_12 CK=CTS_363
Xbank_mem_0_reg[9][11] QDFFN $PINS Q=bank_mem_0[9][11]
+ D=FE_DBTN74_bank_wdata_0_11 CK=CTS_363
Xbank_mem_0_reg[9][10] QDFFN $PINS Q=bank_mem_0[9][10]
+ D=FE_DBTN73_bank_wdata_0_10 CK=CTS_363
Xbank_mem_0_reg[9][9] QDFFN $PINS Q=bank_mem_0[9][9] D=FE_DBTN72_bank_wdata_0_9
+ CK=CTS_363
Xbank_mem_0_reg[9][8] QDFFN $PINS Q=bank_mem_0[9][8] D=FE_DBTN71_bank_wdata_0_8
+ CK=CTS_363
Xbank_mem_0_reg[9][7] QDFFN $PINS Q=bank_mem_0[9][7] D=FE_DBTN70_bank_wdata_0_7
+ CK=CTS_363
Xbank_mem_0_reg[9][6] QDFFN $PINS Q=bank_mem_0[9][6] D=FE_DBTN69_bank_wdata_0_6
+ CK=CTS_363
Xbank_mem_0_reg[9][5] QDFFN $PINS Q=bank_mem_0[9][5] D=FE_DBTN68_bank_wdata_0_5
+ CK=CTS_363
Xbank_mem_0_reg[9][4] QDFFN $PINS Q=bank_mem_0[9][4] D=FE_DBTN67_bank_wdata_0_4
+ CK=CTS_363
Xbank_mem_0_reg[9][3] QDFFN $PINS Q=bank_mem_0[9][3] D=FE_DBTN66_bank_wdata_0_3
+ CK=CTS_363
Xbank_mem_0_reg[9][2] QDFFN $PINS Q=bank_mem_0[9][2] D=FE_DBTN65_bank_wdata_0_2
+ CK=CTS_363
Xbank_mem_0_reg[9][1] QDFFN $PINS Q=bank_mem_0[9][1] D=FE_DBTN64_bank_wdata_0_1
+ CK=CTS_363
Xbank_mem_0_reg[9][0] QDFFN $PINS Q=bank_mem_0[9][0] D=FE_DBTN63_bank_wdata_0_0
+ CK=CTS_363
Xbank_mem_0_reg[11][20] QDFFN $PINS Q=bank_mem_0[11][20]
+ D=FE_DBTN82_bank_wdata_0_20 CK=CTS_357
Xbank_mem_0_reg[11][19] QDFFN $PINS Q=bank_mem_0[11][19] D=FE_DBTN40_n2
+ CK=CTS_357
Xbank_mem_0_reg[11][18] QDFFN $PINS Q=bank_mem_0[11][18]
+ D=FE_DBTN81_bank_wdata_0_18 CK=CTS_357
Xbank_mem_0_reg[11][17] QDFFN $PINS Q=bank_mem_0[11][17]
+ D=FE_DBTN80_bank_wdata_0_17 CK=CTS_357
Xbank_mem_0_reg[11][16] QDFFN $PINS Q=bank_mem_0[11][16]
+ D=FE_DBTN79_bank_wdata_0_16 CK=CTS_357
Xbank_mem_0_reg[11][15] QDFFN $PINS Q=bank_mem_0[11][15]
+ D=FE_DBTN78_bank_wdata_0_15 CK=CTS_357
Xbank_mem_0_reg[11][14] QDFFN $PINS Q=bank_mem_0[11][14]
+ D=FE_DBTN77_bank_wdata_0_14 CK=CTS_357
Xbank_mem_0_reg[11][13] QDFFN $PINS Q=bank_mem_0[11][13]
+ D=FE_DBTN76_bank_wdata_0_13 CK=CTS_357
Xbank_mem_0_reg[11][12] QDFFN $PINS Q=bank_mem_0[11][12]
+ D=FE_DBTN75_bank_wdata_0_12 CK=CTS_357
Xbank_mem_0_reg[11][11] QDFFN $PINS Q=bank_mem_0[11][11]
+ D=FE_DBTN74_bank_wdata_0_11 CK=CTS_357
Xbank_mem_0_reg[11][10] QDFFN $PINS Q=bank_mem_0[11][10]
+ D=FE_DBTN73_bank_wdata_0_10 CK=CTS_357
Xbank_mem_0_reg[11][9] QDFFN $PINS Q=bank_mem_0[11][9]
+ D=FE_DBTN72_bank_wdata_0_9 CK=CTS_357
Xbank_mem_0_reg[11][8] QDFFN $PINS Q=bank_mem_0[11][8]
+ D=FE_DBTN71_bank_wdata_0_8 CK=CTS_357
Xbank_mem_0_reg[11][7] QDFFN $PINS Q=bank_mem_0[11][7]
+ D=FE_DBTN70_bank_wdata_0_7 CK=CTS_357
Xbank_mem_0_reg[11][6] QDFFN $PINS Q=bank_mem_0[11][6]
+ D=FE_DBTN69_bank_wdata_0_6 CK=CTS_357
Xbank_mem_0_reg[11][5] QDFFN $PINS Q=bank_mem_0[11][5]
+ D=FE_DBTN68_bank_wdata_0_5 CK=CTS_357
Xbank_mem_0_reg[11][4] QDFFN $PINS Q=bank_mem_0[11][4]
+ D=FE_DBTN67_bank_wdata_0_4 CK=CTS_357
Xbank_mem_0_reg[11][3] QDFFN $PINS Q=bank_mem_0[11][3]
+ D=FE_DBTN66_bank_wdata_0_3 CK=CTS_357
Xbank_mem_0_reg[11][2] QDFFN $PINS Q=bank_mem_0[11][2]
+ D=FE_DBTN65_bank_wdata_0_2 CK=CTS_357
Xbank_mem_0_reg[11][1] QDFFN $PINS Q=bank_mem_0[11][1]
+ D=FE_DBTN64_bank_wdata_0_1 CK=CTS_357
Xbank_mem_0_reg[11][0] QDFFN $PINS Q=bank_mem_0[11][0]
+ D=FE_DBTN63_bank_wdata_0_0 CK=CTS_357
Xbank_mem_1_reg[8][21] QDFFN $PINS Q=bank_mem_1[8][21]
+ D=FE_DBTN62_bank_wdata_1_21 CK=CTS_316
Xbank_mem_1_reg[10][21] QDFFN $PINS Q=bank_mem_1[10][21]
+ D=FE_DBTN62_bank_wdata_1_21 CK=CTS_310
Xbank_mem_0_reg[8][20] QDFFN $PINS Q=bank_mem_0[8][20]
+ D=FE_DBTN82_bank_wdata_0_20 CK=CTS_366
Xbank_mem_0_reg[8][19] QDFFN $PINS Q=bank_mem_0[8][19] D=FE_DBTN40_n2
+ CK=CTS_366
Xbank_mem_0_reg[8][18] QDFFN $PINS Q=bank_mem_0[8][18]
+ D=FE_DBTN81_bank_wdata_0_18 CK=CTS_366
Xbank_mem_0_reg[8][17] QDFFN $PINS Q=bank_mem_0[8][17]
+ D=FE_DBTN80_bank_wdata_0_17 CK=CTS_366
Xbank_mem_0_reg[8][16] QDFFN $PINS Q=bank_mem_0[8][16]
+ D=FE_DBTN79_bank_wdata_0_16 CK=CTS_366
Xbank_mem_0_reg[8][15] QDFFN $PINS Q=bank_mem_0[8][15]
+ D=FE_DBTN78_bank_wdata_0_15 CK=CTS_366
Xbank_mem_0_reg[8][14] QDFFN $PINS Q=bank_mem_0[8][14]
+ D=FE_DBTN77_bank_wdata_0_14 CK=CTS_366
Xbank_mem_0_reg[8][13] QDFFN $PINS Q=bank_mem_0[8][13]
+ D=FE_DBTN76_bank_wdata_0_13 CK=CTS_366
Xbank_mem_0_reg[8][12] QDFFN $PINS Q=bank_mem_0[8][12]
+ D=FE_DBTN75_bank_wdata_0_12 CK=CTS_366
Xbank_mem_0_reg[8][11] QDFFN $PINS Q=bank_mem_0[8][11]
+ D=FE_DBTN74_bank_wdata_0_11 CK=CTS_366
Xbank_mem_0_reg[8][10] QDFFN $PINS Q=bank_mem_0[8][10]
+ D=FE_DBTN73_bank_wdata_0_10 CK=CTS_366
Xbank_mem_0_reg[8][9] QDFFN $PINS Q=bank_mem_0[8][9] D=FE_DBTN72_bank_wdata_0_9
+ CK=CTS_366
Xbank_mem_0_reg[8][8] QDFFN $PINS Q=bank_mem_0[8][8] D=FE_DBTN71_bank_wdata_0_8
+ CK=CTS_366
Xbank_mem_0_reg[8][7] QDFFN $PINS Q=bank_mem_0[8][7] D=FE_DBTN70_bank_wdata_0_7
+ CK=CTS_366
Xbank_mem_0_reg[8][6] QDFFN $PINS Q=bank_mem_0[8][6] D=FE_DBTN69_bank_wdata_0_6
+ CK=CTS_366
Xbank_mem_0_reg[8][5] QDFFN $PINS Q=bank_mem_0[8][5] D=FE_DBTN68_bank_wdata_0_5
+ CK=CTS_366
Xbank_mem_0_reg[8][4] QDFFN $PINS Q=bank_mem_0[8][4] D=FE_DBTN67_bank_wdata_0_4
+ CK=CTS_366
Xbank_mem_0_reg[8][3] QDFFN $PINS Q=bank_mem_0[8][3] D=FE_DBTN66_bank_wdata_0_3
+ CK=CTS_366
Xbank_mem_0_reg[8][2] QDFFN $PINS Q=bank_mem_0[8][2] D=FE_DBTN65_bank_wdata_0_2
+ CK=CTS_366
Xbank_mem_0_reg[8][1] QDFFN $PINS Q=bank_mem_0[8][1] D=FE_DBTN64_bank_wdata_0_1
+ CK=CTS_366
Xbank_mem_0_reg[8][0] QDFFN $PINS Q=bank_mem_0[8][0] D=FE_DBTN63_bank_wdata_0_0
+ CK=CTS_366
Xbank_mem_0_reg[9][21] QDFFN $PINS Q=bank_mem_0[9][21]
+ D=FE_DBTN83_bank_wdata_0_21 CK=CTS_363
Xbank_mem_0_reg[10][20] QDFFN $PINS Q=bank_mem_0[10][20]
+ D=FE_DBTN82_bank_wdata_0_20 CK=CTS_360
Xbank_mem_0_reg[10][19] QDFFN $PINS Q=bank_mem_0[10][19] D=FE_DBTN40_n2
+ CK=CTS_360
Xbank_mem_0_reg[10][18] QDFFN $PINS Q=bank_mem_0[10][18]
+ D=FE_DBTN81_bank_wdata_0_18 CK=CTS_360
Xbank_mem_0_reg[10][17] QDFFN $PINS Q=bank_mem_0[10][17]
+ D=FE_DBTN80_bank_wdata_0_17 CK=CTS_360
Xbank_mem_0_reg[10][16] QDFFN $PINS Q=bank_mem_0[10][16]
+ D=FE_DBTN79_bank_wdata_0_16 CK=CTS_360
Xbank_mem_0_reg[10][15] QDFFN $PINS Q=bank_mem_0[10][15]
+ D=FE_DBTN78_bank_wdata_0_15 CK=CTS_360
Xbank_mem_0_reg[10][14] QDFFN $PINS Q=bank_mem_0[10][14]
+ D=FE_DBTN77_bank_wdata_0_14 CK=CTS_360
Xbank_mem_0_reg[10][13] QDFFN $PINS Q=bank_mem_0[10][13]
+ D=FE_DBTN76_bank_wdata_0_13 CK=CTS_360
Xbank_mem_0_reg[10][12] QDFFN $PINS Q=bank_mem_0[10][12]
+ D=FE_DBTN75_bank_wdata_0_12 CK=CTS_360
Xbank_mem_0_reg[10][11] QDFFN $PINS Q=bank_mem_0[10][11]
+ D=FE_DBTN74_bank_wdata_0_11 CK=CTS_360
Xbank_mem_0_reg[10][10] QDFFN $PINS Q=bank_mem_0[10][10]
+ D=FE_DBTN73_bank_wdata_0_10 CK=CTS_360
Xbank_mem_0_reg[10][9] QDFFN $PINS Q=bank_mem_0[10][9]
+ D=FE_DBTN72_bank_wdata_0_9 CK=CTS_360
Xbank_mem_0_reg[10][8] QDFFN $PINS Q=bank_mem_0[10][8]
+ D=FE_DBTN71_bank_wdata_0_8 CK=CTS_360
Xbank_mem_0_reg[10][7] QDFFN $PINS Q=bank_mem_0[10][7]
+ D=FE_DBTN70_bank_wdata_0_7 CK=CTS_360
Xbank_mem_0_reg[10][6] QDFFN $PINS Q=bank_mem_0[10][6]
+ D=FE_DBTN69_bank_wdata_0_6 CK=CTS_360
Xbank_mem_0_reg[10][5] QDFFN $PINS Q=bank_mem_0[10][5]
+ D=FE_DBTN68_bank_wdata_0_5 CK=CTS_360
Xbank_mem_0_reg[10][4] QDFFN $PINS Q=bank_mem_0[10][4]
+ D=FE_DBTN67_bank_wdata_0_4 CK=CTS_360
Xbank_mem_0_reg[10][3] QDFFN $PINS Q=bank_mem_0[10][3]
+ D=FE_DBTN66_bank_wdata_0_3 CK=CTS_360
Xbank_mem_0_reg[10][2] QDFFN $PINS Q=bank_mem_0[10][2]
+ D=FE_DBTN65_bank_wdata_0_2 CK=CTS_360
Xbank_mem_0_reg[10][1] QDFFN $PINS Q=bank_mem_0[10][1]
+ D=FE_DBTN64_bank_wdata_0_1 CK=CTS_360
Xbank_mem_0_reg[10][0] QDFFN $PINS Q=bank_mem_0[10][0]
+ D=FE_DBTN63_bank_wdata_0_0 CK=CTS_360
Xbank_mem_0_reg[11][21] QDFFN $PINS Q=bank_mem_0[11][21]
+ D=FE_DBTN83_bank_wdata_0_21 CK=CTS_357
Xbank_mem_0_reg[8][21] QDFFN $PINS Q=bank_mem_0[8][21]
+ D=FE_DBTN83_bank_wdata_0_21 CK=CTS_366
Xbank_mem_0_reg[10][21] QDFFN $PINS Q=bank_mem_0[10][21]
+ D=FE_DBTN83_bank_wdata_0_21 CK=CTS_360
Xread_data_1_reg[15] QDFFRBN $PINS Q=read_data_1[15] D=FE_PHN1449_N109
+ CK=clk_clone2 RB=i_rst_n
Xread_data_1_reg[6] QDFFRBN $PINS Q=read_data_1[6] D=FE_PHN1424_N118 CK=clk
+ RB=FE_OFN18_i_rst_n
Xread_data_1_reg[7] QDFFRBN $PINS Q=read_data_1[7] D=N117 CK=clk
+ RB=FE_OFN18_i_rst_n
Xread_data_1_reg[14] QDFFRBN $PINS Q=read_data_1[14] D=N110 CK=clk_clone2
+ RB=i_rst_n
Xread_data_1_reg[5] QDFFRBN $PINS Q=read_data_1[5] D=N119 CK=clk
+ RB=FE_OFN18_i_rst_n
Xread_data_1_reg[13] QDFFRBN $PINS Q=read_data_1[13] D=FE_PHN1437_N111
+ CK=clk_clone2 RB=i_rst_n
Xread_data_1_reg[4] QDFFRBN $PINS Q=read_data_1[4] D=N120 CK=clk_clone2
+ RB=i_rst_n
Xread_data_1_reg[12] QDFFRBN $PINS Q=read_data_1[12] D=FE_PHN1438_N112
+ CK=clk_clone2 RB=i_rst_n
Xread_data_1_reg[3] QDFFRBN $PINS Q=read_data_1[3] D=N121 CK=clk_clone2
+ RB=i_rst_n
Xread_data_1_reg[10] QDFFRBN $PINS Q=read_data_1[10] D=FE_PHN1430_N114
+ CK=clk_clone2 RB=FE_OFN27_i_rst_n
Xread_data_1_reg[2] QDFFRBN $PINS Q=read_data_1[2] D=N122 CK=clk_clone2
+ RB=FE_OFN27_i_rst_n
Xread_data_1_reg[9] QDFFRBN $PINS Q=read_data_1[9] D=FE_PHN1444_N115
+ CK=clk_clone2 RB=FE_OFN27_i_rst_n
Xread_data_1_reg[8] QDFFRBN $PINS Q=read_data_1[8] D=FE_PHN1451_N116
+ CK=clk_clone2 RB=FE_OFN27_i_rst_n
Xread_data_1_reg[0] QDFFRBN $PINS Q=read_data_1[0] D=N124 CK=clk_clone2
+ RB=FE_OFN27_i_rst_n
Xread_data_1_reg[11] QDFFRBN $PINS Q=read_data_1[11] D=N113 CK=clk_clone2
+ RB=i_rst_n
Xread_data_1_reg[1] QDFFRBN $PINS Q=read_data_1[1] D=N123 CK=clk_clone2
+ RB=i_rst_n
XU3 MUX2 $PINS O=FE_PHN1439_N106 S=n765 A=bank_rdata[0][18] B=bank_rdata[1][18]
XU4 MUX2 $PINS O=N105 S=n765 A=bank_rdata[0][19] B=FE_PHN1074_bank_rdata_1_19
XU5 MUX2 $PINS O=FE_PHN1435_N104 S=n765 A=FE_PHN1057_bank_rdata_0_20
+ B=bank_rdata[1][20]
XU6 MUX2 $PINS O=N103 S=n765 A=bank_rdata[0][21] B=bank_rdata[1][21]
XU7 ND3 $PINS O=n62 I1=n828 I2=n61 I3=wen1
XU9 OA22 $PINS O=n2 A1=n783 A2=n63 B1=n805 B2=n64
XU10 ND2 $PINS O=n3 I1=n213 I2=n461
XU11 ND2 $PINS O=n4 I1=n209 I2=n461
XU12 ND2 $PINS O=n5 I1=n491 I2=n739
XU13 ND2 $PINS O=n6 I1=n487 I2=n739
XU14 ND2 $PINS O=n7 I1=n212 I2=n210
XU15 ND2 $PINS O=n8 I1=n490 I2=n488
XU16 ND2 $PINS O=n9 I1=n214 I2=n209
XU17 ND2 $PINS O=n10 I1=n492 I2=n487
XU22 OA22 $PINS O=bank_wdata[1][21] A1=n61 A2=n781 B1=n62 B2=n803
XU26 OA22 $PINS O=bank_wdata[0][17] A1=n785 A2=n63 B1=n807 B2=n64
XU30 OA22 $PINS O=bank_wdata[1][19] A1=n61 A2=n783 B1=n62 B2=n805
XU33 OA22 $PINS O=bank_wdata[1][15] A1=n61 A2=n787 B1=n62 B2=n809
XU37 OA22 $PINS O=bank_wdata[0][21] A1=n781 A2=n63 B1=n803 B2=n64
XU40 OA22 $PINS O=bank_wdata[0][16] A1=n786 A2=n63 B1=n808 B2=n64
XU44 OA22 $PINS O=bank_wdata[1][18] A1=n61 A2=n784 B1=n62 B2=n806
XU47 OA22 $PINS O=bank_wdata[1][7] A1=n61 A2=n795 B1=n62 B2=n817
XU50 OA22 $PINS O=bank_wdata[0][20] A1=n782 A2=n63 B1=n804 B2=n64
XU54 OA22 $PINS O=bank_wdata[0][15] A1=n787 A2=n63 B1=n809 B2=n64
XU57 AN2 $PINS O=n37 I1=N33 I2=n491
XU58 AN2 $PINS O=n38 I1=N29 I2=n213
XU59 OA22 $PINS O=bank_wdata[1][20] A1=n61 A2=n782 B1=n62 B2=n804
XU62 OA22 $PINS O=bank_wdata[1][13] A1=n61 A2=n789 B1=n62 B2=n811
XU65 OA22 $PINS O=bank_wdata[1][8] A1=n61 A2=n794 B1=n62 B2=n816
XU68 OA22 $PINS O=bank_wdata[0][18] A1=n784 A2=n63 B1=n806 B2=n64
XU72 OA22 $PINS O=bank_wdata[0][14] A1=n788 A2=n63 B1=n810 B2=n64
XU75 OA22 $PINS O=bank_wdata[0][7] A1=n795 A2=n63 B1=n817 B2=n64
XU78 ND2 $PINS O=n744 I1=n488 I2=N33
XU81 ND2 $PINS O=n466 I1=n210 I2=N29
XU84 AN2 $PINS O=n55 I1=n490 I2=n489
XU85 AN2 $PINS O=n56 I1=n212 I2=n211
XU86 OA22 $PINS O=bank_wdata[1][14] A1=n61 A2=n788 B1=n62 B2=n810
XU89 OA22 $PINS O=bank_wdata[1][5] A1=n61 A2=n797 B1=n62 B2=n819
XU93 OA22 $PINS O=bank_wdata[0][13] A1=n789 A2=n63 B1=n811 B2=n64
XU96 OA22 $PINS O=bank_wdata[0][6] A1=n796 A2=n63 B1=n818 B2=n64
XU99 AN2 $PINS O=n103 I1=n487 I2=N33
XU100 AN2 $PINS O=n104 I1=n209 I2=N29
XU103 OA22 $PINS O=bank_wdata[1][17] A1=n61 A2=n785 B1=n62 B2=n807
XU106 OA22 $PINS O=bank_wdata[1][11] A1=n61 A2=n791 B1=n62 B2=n813
XU109 OA22 $PINS O=bank_wdata[1][6] A1=n61 A2=n796 B1=n62 B2=n818
XU112 OA22 $PINS O=bank_wdata[0][12] A1=n790 A2=n63 B1=n812 B2=n64
XU115 OA22 $PINS O=bank_wdata[0][9] A1=n793 A2=n63 B1=n815 B2=n64
XU118 OA22 $PINS O=bank_wdata[0][5] A1=n797 A2=n63 B1=n819 B2=n64
XU129 OA22 $PINS O=bank_wdata[1][16] A1=n61 A2=n786 B1=n62 B2=n808
XU132 OA22 $PINS O=bank_wdata[1][12] A1=n61 A2=n790 B1=n62 B2=n812
XU135 OA22 $PINS O=bank_wdata[1][4] A1=n61 A2=n798 B1=n62 B2=n820
XU138 OA22 $PINS O=bank_wdata[0][11] A1=n791 A2=n63 B1=n813 B2=n64
XU141 OA22 $PINS O=bank_wdata[0][3] A1=n799 A2=n63 B1=n821 B2=n64
XU190 ND2 $PINS O=n729 I1=n492 I2=n489
XU200 ND2 $PINS O=n451 I1=n214 I2=n211
XU203 OA22 $PINS O=bank_wdata[1][3] A1=n61 A2=n799 B1=n62 B2=n821
XU206 OA22 $PINS O=bank_wdata[1][1] A1=n61 A2=n801 B1=n62 B2=n823
XU209 OA22 $PINS O=bank_wdata[1][0] A1=n61 A2=n802 B1=n62 B2=n824
XU212 OA22 $PINS O=bank_wdata[0][10] A1=n792 A2=n63 B1=n814 B2=n64
XU215 OA22 $PINS O=bank_wdata[0][8] A1=n794 A2=n63 B1=n816 B2=n64
XU218 OA22 $PINS O=bank_wdata[0][2] A1=n800 A2=n63 B1=n822 B2=n64
XU231 ND2 $PINS O=n746 I1=n489 I2=N33
XU234 ND2 $PINS O=n468 I1=n211 I2=N29
XU237 OA22 $PINS O=bank_wdata[1][10] A1=n61 A2=n792 B1=n62 B2=n814
XU240 OA22 $PINS O=bank_wdata[1][9] A1=n61 A2=n793 B1=n62 B2=n815
XU243 OA22 $PINS O=bank_wdata[1][2] A1=n61 A2=n800 B1=n62 B2=n822
XU246 OA22 $PINS O=bank_wdata[0][4] A1=n798 A2=n63 B1=n820 B2=n64
XU249 OA22 $PINS O=bank_wdata[0][1] A1=n801 A2=n63 B1=n823 B2=n64
XU252 OA22 $PINS O=bank_wdata[0][0] A1=n802 A2=n63 B1=n824 B2=n64
XU267 ND2 $PINS O=n195 I1=n212 I2=n213
XU268 ND2 $PINS O=n196 I1=n490 I2=n491
XU269 ND2 $PINS O=n197 I1=n211 I2=n461
XU270 ND2 $PINS O=n198 I1=n489 I2=n739
XU271 ND2 $PINS O=n199 I1=n210 I2=n461
XU272 ND2 $PINS O=n200 I1=n488 I2=n739
XU273 ND2 $PINS O=n201 I1=n212 I2=n209
XU274 ND2 $PINS O=n202 I1=n490 I2=n487
XU275 NR2 $PINS O=N67 I1=n78 I2=n79
XU276 NR2 $PINS O=N65 I1=n78 I2=n81
XU277 NR2 $PINS O=N63 I1=n78 I2=n82
XU278 NR2 $PINS O=N61 I1=n78 I2=n83
XU279 NR2 $PINS O=N98 I1=n67 I2=n68
XU280 NR2 $PINS O=N96 I1=n67 I2=n69
XU281 NR2 $PINS O=N94 I1=n67 I2=n70
XU282 NR2 $PINS O=N92 I1=n66 I2=n73
XU283 NR2 $PINS O=N59 I1=n79 I2=n89
XU284 NR2 $PINS O=N100 I1=n66 I2=n67
XU285 NR2 $PINS O=N57 I1=n81 I2=n89
XU286 NR2 $PINS O=N55 I1=n82 I2=n89
XU287 NR2 $PINS O=N53 I1=n83 I2=n89
XU288 NR2 $PINS O=N88 I1=n69 I2=n73
XU289 NR2 $PINS O=N90 I1=n68 I2=n73
XU290 NR2 $PINS O=N86 I1=n70 I2=n73
XU295 NR2 $PINS O=N99 I1=n65 I2=n66
XU296 NR2 $PINS O=N97 I1=n65 I2=n68
XU297 NR2 $PINS O=N95 I1=n65 I2=n69
XU298 NR2 $PINS O=N93 I1=n65 I2=n70
XU299 NR2 $PINS O=N64 I1=n80 I2=n81
XU300 NR2 $PINS O=N62 I1=n80 I2=n82
XU301 NR2 $PINS O=N60 I1=n80 I2=n83
XU302 NR2 $PINS O=N91 I1=n66 I2=n74
XU303 NR2 $PINS O=N66 I1=n79 I2=n80
XU304 NR2 $PINS O=N58 I1=n79 I2=n90
XU305 NR2 $PINS O=N56 I1=n81 I2=n90
XU306 NR2 $PINS O=N54 I1=n82 I2=n90
XU307 NR2 $PINS O=N52 I1=n83 I2=n90
XU308 INV1S $PINS O=n829 I=n91
XU309 INV1S $PINS O=n826 I=n75
XU310 INV1S $PINS O=n830 I=n92
XU311 NR2 $PINS O=N87 I1=n69 I2=n74
XU312 NR2 $PINS O=N89 I1=n68 I2=n74
XU313 INV1S $PINS O=n825 I=n76
XU314 NR2 $PINS O=N85 I1=n70 I2=n74
XU315 INV1S $PINS O=n778 I=write_addr_2[1]
XU325 ND3 $PINS O=n64 I1=wen1 I2=n63 I3=n88
XU326 OAI22S $PINS O=n77 A1=n836 A2=n61 B1=n837 B2=n62
XU327 OAI22S $PINS O=n87 A1=n836 A2=n63 B1=n837 B2=n64
XU328 OAI22S $PINS O=n92 A1=n834 A2=n63 B1=n835 B2=n64
XU329 OAI22S $PINS O=n91 A1=n832 A2=n63 B1=n833 B2=n64
XU330 OAI22S $PINS O=n75 A1=n832 A2=n61 B1=n833 B2=n62
XU331 AOI12HS $PINS O=n71 A1=n77 B1=n61 B2=n95
XU332 AOI12HS $PINS O=n84 A1=n87 B1=n63 B2=n86
XU333 INV1S $PINS O=n831 I=n85
XU334 INV1S $PINS O=n827 I=n72
XU335 INV1S $PINS O=n828 I=n88
XU338 INV1S $PINS O=n765 I=n98
XU339 OAI22S $PINS O=n72 A1=n778 A2=n61 B1=n838 B2=n62
XU340 OAI22S $PINS O=n85 A1=n778 A2=n63 B1=n838 B2=n64
XU341 INV1S $PINS O=n832 I=write_addr_2[2]
XU342 XOR2HS $PINS O=n97 I1=write_addr_2[4] I2=write_addr_2[3]
XU343 XOR2HS $PINS O=n96 I1=write_addr_1[4] I2=write_addr_1[3]
XU344 INV1S $PINS O=n835 I=write_addr_1[3]
XU345 INV1S $PINS O=n837 I=write_addr_1[4]
XU346 INV1S $PINS O=n833 I=write_addr_1[2]
XU347 INV1S $PINS O=n836 I=write_addr_2[4]
XU348 INV1S $PINS O=n834 I=write_addr_2[3]
XU350 XNR2HS $PINS O=n94 I1=read_addr_1[4] I2=read_addr_1[3]
XU351 AN2 $PINS O=n477 I1=n214 I2=n211
XU352 AN2 $PINS O=n755 I1=n492 I2=n489
XU359 AN2 $PINS O=n450 I1=n214 I2=n210
XU360 AN2 $PINS O=n728 I1=n492 I2=n488
XU362 AN2 $PINS O=n730 I1=n492 I2=n491
XU364 AN2 $PINS O=n452 I1=n214 I2=n213
XU378 INV1S $PINS O=n838 I=write_addr_1[1]
XU379 INV1S $PINS O=n824 I=write_data_1[0]
XU380 INV1S $PINS O=n820 I=write_data_1[4]
XU381 INV1S $PINS O=n819 I=write_data_1[5]
XU382 INV1S $PINS O=n818 I=write_data_1[6]
XU383 INV1S $PINS O=n817 I=write_data_1[7]
XU384 INV1S $PINS O=n816 I=write_data_1[8]
XU385 INV1S $PINS O=n815 I=write_data_1[9]
XU386 INV1S $PINS O=n823 I=write_data_1[1]
XU387 INV1S $PINS O=n822 I=write_data_1[2]
XU388 INV1S $PINS O=n821 I=write_data_1[3]
XU389 INV1S $PINS O=n814 I=write_data_1[10]
XU390 INV1S $PINS O=n813 I=write_data_1[11]
XU391 INV1S $PINS O=n811 I=write_data_1[13]
XU392 INV1S $PINS O=n810 I=write_data_1[14]
XU393 INV1S $PINS O=n809 I=write_data_1[15]
XU394 INV1S $PINS O=n812 I=write_data_1[12]
XU395 INV1S $PINS O=n808 I=write_data_1[16]
XU396 INV1S $PINS O=n807 I=write_data_1[17]
XU397 INV1S $PINS O=n806 I=write_data_1[18]
XU398 INV1S $PINS O=n805 I=write_data_1[19]
XU399 INV1S $PINS O=n804 I=write_data_1[20]
XU400 INV1S $PINS O=n803 I=write_data_1[21]
XU401 INV1S $PINS O=n802 I=write_data_2[0]
XU402 INV1S $PINS O=n793 I=write_data_2[9]
XU403 INV1S $PINS O=n801 I=write_data_2[1]
XU404 INV1S $PINS O=n800 I=write_data_2[2]
XU405 INV1S $PINS O=n799 I=write_data_2[3]
XU406 INV1S $PINS O=n798 I=write_data_2[4]
XU407 INV1S $PINS O=n792 I=write_data_2[10]
XU408 INV1S $PINS O=n791 I=write_data_2[11]
XU409 INV1S $PINS O=n790 I=write_data_2[12]
XU410 INV1S $PINS O=n789 I=write_data_2[13]
XU411 INV1S $PINS O=n788 I=write_data_2[14]
XU412 INV1S $PINS O=n786 I=write_data_2[16]
XU413 INV1S $PINS O=n785 I=write_data_2[17]
XU414 INV1S $PINS O=n784 I=write_data_2[18]
XU415 INV1S $PINS O=n783 I=write_data_2[19]
XU416 INV1S $PINS O=n782 I=write_data_2[20]
XU417 INV1S $PINS O=n781 I=write_data_2[21]
XU418 INV1S $PINS O=n797 I=write_data_2[5]
XU419 INV1S $PINS O=n796 I=write_data_2[6]
XU420 INV1S $PINS O=n795 I=write_data_2[7]
XU421 INV1S $PINS O=n794 I=write_data_2[8]
XU422 INV1S $PINS O=n787 I=write_data_2[15]
XU423 AN2 $PINS O=n443 I1=n211 I2=N29
XU424 AN2 $PINS O=n721 I1=n489 I2=N33
XU425 AN2 $PINS O=n719 I1=n488 I2=N33
XU426 AN2 $PINS O=n441 I1=n210 I2=N29
XU427 AN2 $PINS O=n467 I1=N29 I2=n213
XU428 AN2 $PINS O=n745 I1=N33 I2=n491
XU429 AN2 $PINS O=n440 I1=N29 I2=n213
XU430 AN2 $PINS O=n718 I1=N33 I2=n491
XU431 AN2 $PINS O=n469 I1=n209 I2=N29
XU432 AN2 $PINS O=n747 I1=n487 I2=N33
XU433 AN2 $PINS O=n442 I1=n209 I2=N29
XU434 AN2 $PINS O=n720 I1=n487 I2=N33
XU435 INV1S $PINS O=n739 I=N33
XU436 INV1S $PINS O=n461 I=N29
XU437 INV1S $PINS O=n738 I=N32
XU438 INV1S $PINS O=n460 I=N28
XU439 INV1S $PINS O=n737 I=N31
XU440 INV1S $PINS O=n459 I=N27
XU442 NR2 $PINS O=n212 I1=n461 I2=N30
XU443 NR2 $PINS O=n213 I1=n460 I2=n459
XU444 NR2 $PINS O=n210 I1=n460 I2=N27
XU445 AOI22S $PINS O=n207 A1=bank_mem_0[14][0] A2=FE_DBTN30_n466
+ B1=bank_mem_0[15][0] B2=n440
XU446 NR2 $PINS O=n211 I1=N27 I2=N28
XU447 NR2 $PINS O=n209 I1=n459 I2=N28
XU448 AOI22S $PINS O=n206 A1=bank_mem_0[12][0] A2=FE_DBTN18_n468
+ B1=bank_mem_0[13][0] B2=n442
XU449 AOI22S $PINS O=n204 A1=bank_mem_0[10][0] A2=FE_DBTN24_n199
+ B1=bank_mem_0[11][0] B2=FE_DBTN39_n3
XU450 AOI22S $PINS O=n203 A1=bank_mem_0[8][0] A2=FE_DBTN28_n197
+ B1=bank_mem_0[9][0] B2=FE_DBTN38_n4
XU451 AN2 $PINS O=n205 I1=n204 I2=n203
XU452 ND3 $PINS O=n208 I1=n207 I2=n206 I3=n205
XU453 AOI22S $PINS O=n219 A1=bank_mem_0[7][0] A2=FE_DBTN20_n195 B1=n208 B2=N30
XU454 AOI22S $PINS O=n218 A1=bank_mem_0[5][0] A2=FE_DBTN26_n201
+ B1=bank_mem_0[6][0] B2=FE_DBTN35_n7
XU455 NR2 $PINS O=n214 I1=N29 I2=N30
XU456 AO222 $PINS O=n216 A1=bank_mem_0[1][0] A2=FE_DBTN33_n9
+ B1=bank_mem_0[0][0] B2=FE_DBTN22_n451 C1=bank_mem_0[2][0] C2=n450
XU457 AO22 $PINS O=n215 A1=bank_mem_0[4][0] A2=n56 B1=bank_mem_0[3][0] B2=n452
XU458 NR2 $PINS O=n217 I1=n216 I2=n215
XU459 ND3 $PINS O=bank_rdata[0][0] I1=n219 I2=n218 I3=n217
XU460 AOI22S $PINS O=n224 A1=bank_mem_0[14][1] A2=n441 B1=bank_mem_0[15][1]
+ B2=n38
XU461 AOI22S $PINS O=n223 A1=bank_mem_0[12][1] A2=n443 B1=bank_mem_0[13][1]
+ B2=n104
XU462 AOI22S $PINS O=n221 A1=bank_mem_0[10][1] A2=FE_DBTN24_n199
+ B1=bank_mem_0[11][1] B2=FE_DBTN39_n3
XU463 AOI22S $PINS O=n220 A1=bank_mem_0[8][1] A2=FE_DBTN28_n197
+ B1=bank_mem_0[9][1] B2=FE_DBTN38_n4
XU464 AN2 $PINS O=n222 I1=n221 I2=n220
XU465 ND3 $PINS O=n225 I1=n224 I2=n223 I3=n222
XU466 AOI22S $PINS O=n230 A1=bank_mem_0[7][1] A2=FE_DBTN20_n195 B1=n225 B2=N30
XU467 AOI22S $PINS O=n229 A1=bank_mem_0[5][1] A2=FE_DBTN26_n201
+ B1=bank_mem_0[6][1] B2=FE_DBTN35_n7
XU468 AO222 $PINS O=n227 A1=bank_mem_0[1][1] A2=FE_DBTN33_n9
+ B1=bank_mem_0[0][1] B2=FE_DBTN22_n451 C1=bank_mem_0[2][1] C2=n450
XU469 AO22 $PINS O=n226 A1=bank_mem_0[4][1] A2=n56 B1=bank_mem_0[3][1] B2=n452
XU470 NR2 $PINS O=n228 I1=n227 I2=n226
XU471 ND3 $PINS O=bank_rdata[0][1] I1=n230 I2=n229 I3=n228
XU472 AOI22S $PINS O=n235 A1=bank_mem_0[14][2] A2=FE_DBTN30_n466
+ B1=bank_mem_0[15][2] B2=n467
XU473 AOI22S $PINS O=n234 A1=bank_mem_0[12][2] A2=FE_DBTN18_n468
+ B1=bank_mem_0[13][2] B2=n469
XU474 AOI22S $PINS O=n232 A1=bank_mem_0[10][2] A2=FE_DBTN24_n199
+ B1=bank_mem_0[11][2] B2=FE_DBTN39_n3
XU475 AOI22S $PINS O=n231 A1=bank_mem_0[8][2] A2=FE_DBTN28_n197
+ B1=bank_mem_0[9][2] B2=FE_DBTN38_n4
XU476 AN2 $PINS O=n233 I1=n232 I2=n231
XU477 ND3 $PINS O=n236 I1=n235 I2=n234 I3=n233
XU478 AOI22S $PINS O=n241 A1=bank_mem_0[7][2] A2=FE_DBTN20_n195 B1=n236 B2=N30
XU479 AOI22S $PINS O=n240 A1=bank_mem_0[5][2] A2=FE_DBTN26_n201
+ B1=bank_mem_0[6][2] B2=FE_DBTN35_n7
XU480 AO222 $PINS O=n238 A1=bank_mem_0[1][2] A2=FE_DBTN33_n9
+ B1=bank_mem_0[0][2] B2=FE_DBTN22_n451 C1=bank_mem_0[2][2] C2=n450
XU481 AO22 $PINS O=n237 A1=bank_mem_0[4][2] A2=n56 B1=bank_mem_0[3][2] B2=n452
XU482 NR2 $PINS O=n239 I1=n238 I2=n237
XU483 ND3 $PINS O=bank_rdata[0][2] I1=n241 I2=n240 I3=n239
XU484 AOI22S $PINS O=n246 A1=bank_mem_0[14][3] A2=n441 B1=bank_mem_0[15][3]
+ B2=n467
XU485 AOI22S $PINS O=n245 A1=bank_mem_0[12][3] A2=n443 B1=bank_mem_0[13][3]
+ B2=n469
XU486 AOI22S $PINS O=n243 A1=bank_mem_0[10][3] A2=FE_DBTN24_n199
+ B1=bank_mem_0[11][3] B2=FE_DBTN39_n3
XU487 AOI22S $PINS O=n242 A1=bank_mem_0[8][3] A2=FE_DBTN28_n197
+ B1=bank_mem_0[9][3] B2=FE_DBTN38_n4
XU488 AN2 $PINS O=n244 I1=n243 I2=n242
XU489 ND3 $PINS O=n247 I1=n246 I2=n245 I3=n244
XU490 AOI22S $PINS O=n252 A1=bank_mem_0[7][3] A2=FE_DBTN20_n195 B1=n247 B2=N30
XU491 AOI22S $PINS O=n251 A1=bank_mem_0[5][3] A2=FE_DBTN26_n201
+ B1=bank_mem_0[6][3] B2=FE_DBTN35_n7
XU492 AO222 $PINS O=n249 A1=bank_mem_0[1][3] A2=FE_DBTN33_n9
+ B1=bank_mem_0[0][3] B2=FE_DBTN22_n451 C1=bank_mem_0[2][3] C2=n450
XU493 AO22 $PINS O=n248 A1=bank_mem_0[4][3] A2=n56 B1=bank_mem_0[3][3] B2=n452
XU494 NR2 $PINS O=n250 I1=n249 I2=n248
XU495 ND3 $PINS O=bank_rdata[0][3] I1=n252 I2=n251 I3=n250
XU496 AOI22S $PINS O=n257 A1=bank_mem_0[14][4] A2=FE_DBTN30_n466
+ B1=bank_mem_0[15][4] B2=n38
XU497 AOI22S $PINS O=n256 A1=bank_mem_0[12][4] A2=FE_DBTN18_n468
+ B1=bank_mem_0[13][4] B2=n104
XU498 AOI22S $PINS O=n254 A1=bank_mem_0[10][4] A2=FE_DBTN24_n199
+ B1=bank_mem_0[11][4] B2=FE_DBTN39_n3
XU499 AOI22S $PINS O=n253 A1=bank_mem_0[8][4] A2=FE_DBTN28_n197
+ B1=bank_mem_0[9][4] B2=FE_DBTN38_n4
XU500 AN2 $PINS O=n255 I1=n254 I2=n253
XU501 ND3 $PINS O=n258 I1=n257 I2=n256 I3=n255
XU502 AOI22S $PINS O=n263 A1=bank_mem_0[7][4] A2=FE_DBTN20_n195 B1=n258 B2=N30
XU503 AOI22S $PINS O=n262 A1=bank_mem_0[5][4] A2=FE_DBTN26_n201
+ B1=bank_mem_0[6][4] B2=FE_DBTN35_n7
XU504 AO222 $PINS O=n260 A1=bank_mem_0[1][4] A2=FE_DBTN33_n9
+ B1=bank_mem_0[0][4] B2=FE_DBTN22_n451 C1=bank_mem_0[2][4] C2=n450
XU505 AO22 $PINS O=n259 A1=bank_mem_0[4][4] A2=n56 B1=bank_mem_0[3][4] B2=n452
XU506 NR2 $PINS O=n261 I1=n260 I2=n259
XU507 ND3 $PINS O=bank_rdata[0][4] I1=n263 I2=n262 I3=n261
XU508 AOI22S $PINS O=n268 A1=bank_mem_0[14][5] A2=n441 B1=bank_mem_0[15][5]
+ B2=n440
XU509 AOI22S $PINS O=n267 A1=bank_mem_0[12][5] A2=n443 B1=bank_mem_0[13][5]
+ B2=n442
XU510 AOI22S $PINS O=n265 A1=bank_mem_0[10][5] A2=FE_DBTN24_n199
+ B1=bank_mem_0[11][5] B2=FE_DBTN39_n3
XU511 AOI22S $PINS O=n264 A1=bank_mem_0[8][5] A2=FE_DBTN28_n197
+ B1=bank_mem_0[9][5] B2=FE_DBTN38_n4
XU512 AN2 $PINS O=n266 I1=n265 I2=n264
XU513 ND3 $PINS O=n269 I1=n268 I2=n267 I3=n266
XU514 AOI22S $PINS O=n274 A1=bank_mem_0[7][5] A2=FE_DBTN20_n195 B1=n269 B2=N30
XU515 AOI22S $PINS O=n273 A1=bank_mem_0[5][5] A2=FE_DBTN26_n201
+ B1=bank_mem_0[6][5] B2=FE_DBTN35_n7
XU516 AO222 $PINS O=n271 A1=bank_mem_0[1][5] A2=FE_DBTN33_n9
+ B1=bank_mem_0[0][5] B2=FE_DBTN22_n451 C1=bank_mem_0[2][5] C2=n450
XU517 AO22 $PINS O=n270 A1=bank_mem_0[4][5] A2=n56 B1=bank_mem_0[3][5] B2=n452
XU518 NR2 $PINS O=n272 I1=n271 I2=n270
XU519 ND3 $PINS O=bank_rdata[0][5] I1=n274 I2=n273 I3=n272
XU520 AOI22S $PINS O=n279 A1=bank_mem_0[14][6] A2=FE_DBTN30_n466
+ B1=bank_mem_0[15][6] B2=n440
XU521 AOI22S $PINS O=n278 A1=bank_mem_0[12][6] A2=FE_DBTN18_n468
+ B1=bank_mem_0[13][6] B2=n442
XU522 AOI22S $PINS O=n276 A1=bank_mem_0[10][6] A2=FE_DBTN24_n199
+ B1=bank_mem_0[11][6] B2=FE_DBTN39_n3
XU523 AOI22S $PINS O=n275 A1=bank_mem_0[8][6] A2=FE_DBTN28_n197
+ B1=bank_mem_0[9][6] B2=FE_DBTN38_n4
XU524 AN2 $PINS O=n277 I1=n276 I2=n275
XU525 ND3 $PINS O=n280 I1=n279 I2=n278 I3=n277
XU526 AOI22S $PINS O=n285 A1=bank_mem_0[7][6] A2=FE_DBTN20_n195 B1=n280 B2=N30
XU527 AOI22S $PINS O=n284 A1=bank_mem_0[5][6] A2=FE_DBTN26_n201
+ B1=bank_mem_0[6][6] B2=FE_DBTN35_n7
XU528 AO222 $PINS O=n282 A1=bank_mem_0[1][6] A2=FE_DBTN33_n9
+ B1=bank_mem_0[0][6] B2=n477 C1=bank_mem_0[2][6] C2=n450
XU529 AO22 $PINS O=n281 A1=bank_mem_0[4][6] A2=n56 B1=bank_mem_0[3][6] B2=n452
XU530 NR2 $PINS O=n283 I1=n282 I2=n281
XU531 ND3 $PINS O=bank_rdata[0][6] I1=n285 I2=n284 I3=n283
XU532 AOI22S $PINS O=n290 A1=bank_mem_0[14][7] A2=n441 B1=bank_mem_0[15][7]
+ B2=n38
XU533 AOI22S $PINS O=n289 A1=bank_mem_0[12][7] A2=n443 B1=bank_mem_0[13][7]
+ B2=n104
XU534 AOI22S $PINS O=n287 A1=bank_mem_0[10][7] A2=FE_DBTN24_n199
+ B1=bank_mem_0[11][7] B2=FE_DBTN39_n3
XU535 AOI22S $PINS O=n286 A1=bank_mem_0[8][7] A2=FE_DBTN28_n197
+ B1=bank_mem_0[9][7] B2=FE_DBTN38_n4
XU536 AN2 $PINS O=n288 I1=n287 I2=n286
XU537 ND3 $PINS O=n291 I1=n290 I2=n289 I3=n288
XU538 AOI22S $PINS O=n296 A1=bank_mem_0[7][7] A2=FE_DBTN20_n195 B1=n291 B2=N30
XU539 AOI22S $PINS O=n295 A1=bank_mem_0[5][7] A2=FE_DBTN26_n201
+ B1=bank_mem_0[6][7] B2=FE_DBTN35_n7
XU540 AO222 $PINS O=n293 A1=bank_mem_0[1][7] A2=FE_DBTN33_n9
+ B1=bank_mem_0[0][7] B2=FE_DBTN22_n451 C1=bank_mem_0[2][7] C2=n450
XU541 AO22 $PINS O=n292 A1=bank_mem_0[4][7] A2=n56 B1=bank_mem_0[3][7] B2=n452
XU542 NR2 $PINS O=n294 I1=n293 I2=n292
XU543 ND3 $PINS O=bank_rdata[0][7] I1=n296 I2=n295 I3=n294
XU544 AOI22S $PINS O=n301 A1=bank_mem_0[14][8] A2=FE_DBTN30_n466
+ B1=bank_mem_0[15][8] B2=n467
XU545 AOI22S $PINS O=n300 A1=bank_mem_0[12][8] A2=FE_DBTN18_n468
+ B1=bank_mem_0[13][8] B2=n469
XU546 AOI22S $PINS O=n298 A1=bank_mem_0[10][8] A2=FE_DBTN24_n199
+ B1=bank_mem_0[11][8] B2=FE_DBTN39_n3
XU547 AOI22S $PINS O=n297 A1=bank_mem_0[8][8] A2=FE_DBTN28_n197
+ B1=bank_mem_0[9][8] B2=FE_DBTN38_n4
XU548 AN2 $PINS O=n299 I1=n298 I2=n297
XU549 ND3 $PINS O=n302 I1=n301 I2=n300 I3=n299
XU550 AOI22S $PINS O=n307 A1=bank_mem_0[7][8] A2=FE_DBTN20_n195 B1=n302 B2=N30
XU551 AOI22S $PINS O=n306 A1=bank_mem_0[5][8] A2=FE_DBTN26_n201
+ B1=bank_mem_0[6][8] B2=FE_DBTN35_n7
XU552 AO222 $PINS O=n304 A1=bank_mem_0[1][8] A2=FE_DBTN33_n9
+ B1=bank_mem_0[0][8] B2=n477 C1=bank_mem_0[2][8] C2=n450
XU553 AO22 $PINS O=n303 A1=bank_mem_0[4][8] A2=n56 B1=bank_mem_0[3][8] B2=n452
XU554 NR2 $PINS O=n305 I1=n304 I2=n303
XU555 ND3 $PINS O=bank_rdata[0][8] I1=n307 I2=n306 I3=n305
XU556 AOI22S $PINS O=n312 A1=bank_mem_0[14][9] A2=n441 B1=bank_mem_0[15][9]
+ B2=n467
XU557 AOI22S $PINS O=n311 A1=bank_mem_0[12][9] A2=n443 B1=bank_mem_0[13][9]
+ B2=n469
XU558 AOI22S $PINS O=n309 A1=bank_mem_0[10][9] A2=FE_DBTN24_n199
+ B1=bank_mem_0[11][9] B2=FE_DBTN39_n3
XU559 AOI22S $PINS O=n308 A1=bank_mem_0[8][9] A2=FE_DBTN28_n197
+ B1=bank_mem_0[9][9] B2=FE_DBTN38_n4
XU560 AN2 $PINS O=n310 I1=n309 I2=n308
XU561 ND3 $PINS O=n313 I1=n312 I2=n311 I3=n310
XU562 AOI22S $PINS O=n318 A1=bank_mem_0[7][9] A2=FE_DBTN20_n195 B1=n313 B2=N30
XU563 AOI22S $PINS O=n317 A1=bank_mem_0[5][9] A2=FE_DBTN26_n201
+ B1=bank_mem_0[6][9] B2=FE_DBTN35_n7
XU564 AO222 $PINS O=n315 A1=bank_mem_0[1][9] A2=FE_DBTN33_n9
+ B1=bank_mem_0[0][9] B2=FE_DBTN22_n451 C1=bank_mem_0[2][9] C2=n450
XU565 AO22 $PINS O=n314 A1=bank_mem_0[4][9] A2=n56 B1=bank_mem_0[3][9] B2=n452
XU566 NR2 $PINS O=n316 I1=n315 I2=n314
XU567 ND3 $PINS O=bank_rdata[0][9] I1=n318 I2=n317 I3=n316
XU568 AOI22S $PINS O=n323 A1=bank_mem_0[14][10] A2=FE_DBTN30_n466
+ B1=bank_mem_0[15][10] B2=n38
XU569 AOI22S $PINS O=n322 A1=bank_mem_0[12][10] A2=FE_DBTN18_n468
+ B1=bank_mem_0[13][10] B2=n104
XU570 AOI22S $PINS O=n320 A1=bank_mem_0[10][10] A2=FE_DBTN24_n199
+ B1=bank_mem_0[11][10] B2=FE_DBTN39_n3
XU571 AOI22S $PINS O=n319 A1=bank_mem_0[8][10] A2=FE_DBTN28_n197
+ B1=bank_mem_0[9][10] B2=FE_DBTN38_n4
XU572 AN2 $PINS O=n321 I1=n320 I2=n319
XU573 ND3 $PINS O=n324 I1=n323 I2=n322 I3=n321
XU574 AOI22S $PINS O=n329 A1=bank_mem_0[7][10] A2=FE_DBTN20_n195 B1=n324 B2=N30
XU575 AOI22S $PINS O=n328 A1=bank_mem_0[5][10] A2=FE_DBTN26_n201
+ B1=bank_mem_0[6][10] B2=FE_DBTN35_n7
XU576 AO222 $PINS O=n326 A1=bank_mem_0[1][10] A2=FE_DBTN33_n9
+ B1=bank_mem_0[0][10] B2=n477 C1=bank_mem_0[2][10] C2=n450
XU577 AO22 $PINS O=n325 A1=bank_mem_0[4][10] A2=n56 B1=bank_mem_0[3][10]
+ B2=n452
XU578 NR2 $PINS O=n327 I1=n326 I2=n325
XU579 ND3 $PINS O=bank_rdata[0][10] I1=n329 I2=n328 I3=n327
XU580 AOI22S $PINS O=n334 A1=bank_mem_0[14][11] A2=n441 B1=bank_mem_0[15][11]
+ B2=n440
XU581 AOI22S $PINS O=n333 A1=bank_mem_0[12][11] A2=n443 B1=bank_mem_0[13][11]
+ B2=n442
XU582 AOI22S $PINS O=n331 A1=bank_mem_0[10][11] A2=FE_DBTN24_n199
+ B1=bank_mem_0[11][11] B2=FE_DBTN39_n3
XU583 AOI22S $PINS O=n330 A1=bank_mem_0[8][11] A2=FE_DBTN28_n197
+ B1=bank_mem_0[9][11] B2=FE_DBTN38_n4
XU584 AN2 $PINS O=n332 I1=n331 I2=n330
XU585 ND3 $PINS O=n335 I1=n334 I2=n333 I3=n332
XU586 AOI22S $PINS O=n340 A1=bank_mem_0[7][11] A2=FE_DBTN20_n195 B1=n335 B2=N30
XU587 AOI22S $PINS O=n339 A1=bank_mem_0[5][11] A2=FE_DBTN26_n201
+ B1=bank_mem_0[6][11] B2=FE_DBTN35_n7
XU588 AO222 $PINS O=n337 A1=bank_mem_0[1][11] A2=FE_DBTN33_n9
+ B1=bank_mem_0[0][11] B2=FE_DBTN22_n451 C1=bank_mem_0[2][11] C2=n450
XU589 AO22 $PINS O=n336 A1=bank_mem_0[4][11] A2=n56 B1=bank_mem_0[3][11]
+ B2=n452
XU590 NR2 $PINS O=n338 I1=n337 I2=n336
XU591 ND3 $PINS O=bank_rdata[0][11] I1=n340 I2=n339 I3=n338
XU592 AOI22S $PINS O=n345 A1=bank_mem_0[14][12] A2=FE_DBTN30_n466
+ B1=bank_mem_0[15][12] B2=n440
XU593 AOI22S $PINS O=n344 A1=bank_mem_0[12][12] A2=FE_DBTN18_n468
+ B1=bank_mem_0[13][12] B2=n442
XU594 AOI22S $PINS O=n342 A1=bank_mem_0[10][12] A2=FE_DBTN24_n199
+ B1=bank_mem_0[11][12] B2=FE_DBTN39_n3
XU595 AOI22S $PINS O=n341 A1=bank_mem_0[8][12] A2=FE_DBTN28_n197
+ B1=bank_mem_0[9][12] B2=FE_DBTN38_n4
XU596 AN2 $PINS O=n343 I1=n342 I2=n341
XU597 ND3 $PINS O=n346 I1=n345 I2=n344 I3=n343
XU598 AOI22S $PINS O=n351 A1=bank_mem_0[7][12] A2=FE_DBTN20_n195 B1=n346 B2=N30
XU599 AOI22S $PINS O=n350 A1=bank_mem_0[5][12] A2=FE_DBTN26_n201
+ B1=bank_mem_0[6][12] B2=FE_DBTN35_n7
XU600 AO222 $PINS O=n348 A1=bank_mem_0[1][12] A2=FE_DBTN33_n9
+ B1=bank_mem_0[0][12] B2=n477 C1=bank_mem_0[2][12] C2=n450
XU601 AO22 $PINS O=n347 A1=bank_mem_0[4][12] A2=n56 B1=bank_mem_0[3][12]
+ B2=n452
XU602 NR2 $PINS O=n349 I1=n348 I2=n347
XU603 ND3 $PINS O=bank_rdata[0][12] I1=n351 I2=n350 I3=n349
XU604 AOI22S $PINS O=n356 A1=bank_mem_0[14][13] A2=n441 B1=bank_mem_0[15][13]
+ B2=n38
XU605 AOI22S $PINS O=n355 A1=bank_mem_0[12][13] A2=n443 B1=bank_mem_0[13][13]
+ B2=n104
XU606 AOI22S $PINS O=n353 A1=bank_mem_0[10][13] A2=FE_DBTN24_n199
+ B1=bank_mem_0[11][13] B2=FE_DBTN39_n3
XU607 AOI22S $PINS O=n352 A1=bank_mem_0[8][13] A2=FE_DBTN28_n197
+ B1=bank_mem_0[9][13] B2=FE_DBTN38_n4
XU608 AN2 $PINS O=n354 I1=n353 I2=n352
XU609 ND3 $PINS O=n357 I1=n356 I2=n355 I3=n354
XU610 AOI22S $PINS O=n362 A1=bank_mem_0[7][13] A2=FE_DBTN20_n195 B1=n357 B2=N30
XU611 AOI22S $PINS O=n361 A1=bank_mem_0[5][13] A2=FE_DBTN26_n201
+ B1=bank_mem_0[6][13] B2=FE_DBTN35_n7
XU612 AO222 $PINS O=n359 A1=bank_mem_0[1][13] A2=FE_DBTN33_n9
+ B1=bank_mem_0[0][13] B2=FE_DBTN22_n451 C1=bank_mem_0[2][13] C2=n450
XU613 AO22 $PINS O=n358 A1=bank_mem_0[4][13] A2=n56 B1=bank_mem_0[3][13]
+ B2=n452
XU614 NR2 $PINS O=n360 I1=n359 I2=n358
XU615 ND3 $PINS O=bank_rdata[0][13] I1=n362 I2=n361 I3=n360
XU616 AOI22S $PINS O=n367 A1=bank_mem_0[14][14] A2=FE_DBTN30_n466
+ B1=bank_mem_0[15][14] B2=n467
XU617 AOI22S $PINS O=n366 A1=bank_mem_0[12][14] A2=FE_DBTN18_n468
+ B1=bank_mem_0[13][14] B2=n469
XU618 AOI22S $PINS O=n364 A1=bank_mem_0[10][14] A2=FE_DBTN24_n199
+ B1=bank_mem_0[11][14] B2=FE_DBTN39_n3
XU619 AOI22S $PINS O=n363 A1=bank_mem_0[8][14] A2=FE_DBTN28_n197
+ B1=bank_mem_0[9][14] B2=FE_DBTN38_n4
XU620 AN2 $PINS O=n365 I1=n364 I2=n363
XU621 ND3 $PINS O=n368 I1=n367 I2=n366 I3=n365
XU622 AOI22S $PINS O=n373 A1=bank_mem_0[7][14] A2=FE_DBTN20_n195 B1=n368 B2=N30
XU623 AOI22S $PINS O=n372 A1=bank_mem_0[5][14] A2=FE_DBTN26_n201
+ B1=bank_mem_0[6][14] B2=FE_DBTN35_n7
XU624 AO222 $PINS O=n370 A1=bank_mem_0[1][14] A2=FE_DBTN33_n9
+ B1=bank_mem_0[0][14] B2=n477 C1=bank_mem_0[2][14] C2=n450
XU625 AO22 $PINS O=n369 A1=bank_mem_0[4][14] A2=n56 B1=bank_mem_0[3][14]
+ B2=n452
XU626 NR2 $PINS O=n371 I1=n370 I2=n369
XU627 ND3 $PINS O=bank_rdata[0][14] I1=n373 I2=n372 I3=n371
XU628 AOI22S $PINS O=n378 A1=bank_mem_0[14][15] A2=n441 B1=bank_mem_0[15][15]
+ B2=n467
XU629 AOI22S $PINS O=n377 A1=bank_mem_0[12][15] A2=n443 B1=bank_mem_0[13][15]
+ B2=n469
XU630 AOI22S $PINS O=n375 A1=bank_mem_0[10][15] A2=FE_DBTN24_n199
+ B1=bank_mem_0[11][15] B2=FE_DBTN39_n3
XU631 AOI22S $PINS O=n374 A1=bank_mem_0[8][15] A2=FE_DBTN28_n197
+ B1=bank_mem_0[9][15] B2=FE_DBTN38_n4
XU632 AN2 $PINS O=n376 I1=n375 I2=n374
XU633 ND3 $PINS O=n379 I1=n378 I2=n377 I3=n376
XU634 AOI22S $PINS O=n384 A1=bank_mem_0[7][15] A2=FE_DBTN20_n195 B1=n379 B2=N30
XU635 AOI22S $PINS O=n383 A1=bank_mem_0[5][15] A2=FE_DBTN26_n201
+ B1=bank_mem_0[6][15] B2=FE_DBTN35_n7
XU636 AO222 $PINS O=n381 A1=bank_mem_0[1][15] A2=FE_DBTN33_n9
+ B1=bank_mem_0[0][15] B2=FE_DBTN22_n451 C1=bank_mem_0[2][15] C2=n450
XU637 AO22 $PINS O=n380 A1=bank_mem_0[4][15] A2=n56 B1=bank_mem_0[3][15]
+ B2=n452
XU638 NR2 $PINS O=n382 I1=n381 I2=n380
XU639 ND3 $PINS O=bank_rdata[0][15] I1=n384 I2=n383 I3=n382
XU640 AOI22S $PINS O=n389 A1=bank_mem_0[14][16] A2=FE_DBTN30_n466
+ B1=bank_mem_0[15][16] B2=n38
XU641 AOI22S $PINS O=n388 A1=bank_mem_0[12][16] A2=FE_DBTN18_n468
+ B1=bank_mem_0[13][16] B2=n104
XU642 AOI22S $PINS O=n386 A1=bank_mem_0[10][16] A2=FE_DBTN24_n199
+ B1=bank_mem_0[11][16] B2=FE_DBTN39_n3
XU643 AOI22S $PINS O=n385 A1=bank_mem_0[8][16] A2=FE_DBTN28_n197
+ B1=bank_mem_0[9][16] B2=FE_DBTN38_n4
XU644 AN2 $PINS O=n387 I1=n386 I2=n385
XU645 ND3 $PINS O=n390 I1=n389 I2=n388 I3=n387
XU646 AOI22S $PINS O=n395 A1=bank_mem_0[7][16] A2=FE_DBTN20_n195 B1=n390 B2=N30
XU647 AOI22S $PINS O=n394 A1=bank_mem_0[5][16] A2=FE_DBTN26_n201
+ B1=bank_mem_0[6][16] B2=FE_DBTN35_n7
XU648 AO222 $PINS O=n392 A1=bank_mem_0[1][16] A2=FE_DBTN33_n9
+ B1=bank_mem_0[0][16] B2=n477 C1=bank_mem_0[2][16] C2=n450
XU649 AO22 $PINS O=n391 A1=bank_mem_0[4][16] A2=n56 B1=bank_mem_0[3][16]
+ B2=n452
XU650 NR2 $PINS O=n393 I1=n392 I2=n391
XU651 ND3 $PINS O=bank_rdata[0][16] I1=n395 I2=n394 I3=n393
XU652 AOI22S $PINS O=n400 A1=bank_mem_0[14][17] A2=FE_DBTN30_n466
+ B1=bank_mem_0[15][17] B2=n440
XU653 AOI22S $PINS O=n399 A1=bank_mem_0[12][17] A2=FE_DBTN18_n468
+ B1=bank_mem_0[13][17] B2=n442
XU654 AOI22S $PINS O=n397 A1=bank_mem_0[10][17] A2=FE_DBTN24_n199
+ B1=bank_mem_0[11][17] B2=FE_DBTN39_n3
XU655 AOI22S $PINS O=n396 A1=bank_mem_0[8][17] A2=FE_DBTN28_n197
+ B1=bank_mem_0[9][17] B2=FE_DBTN38_n4
XU656 AN2 $PINS O=n398 I1=n397 I2=n396
XU657 ND3 $PINS O=n401 I1=n400 I2=n399 I3=n398
XU658 AOI22S $PINS O=n406 A1=bank_mem_0[7][17] A2=FE_DBTN20_n195 B1=n401 B2=N30
XU659 AOI22S $PINS O=n405 A1=bank_mem_0[5][17] A2=FE_DBTN26_n201
+ B1=bank_mem_0[6][17] B2=FE_DBTN35_n7
XU660 AO222 $PINS O=n403 A1=bank_mem_0[1][17] A2=FE_DBTN33_n9
+ B1=bank_mem_0[0][17] B2=FE_DBTN22_n451 C1=bank_mem_0[2][17] C2=n450
XU661 AO22 $PINS O=n402 A1=bank_mem_0[4][17] A2=n56 B1=bank_mem_0[3][17]
+ B2=n452
XU662 NR2 $PINS O=n404 I1=n403 I2=n402
XU663 ND3 $PINS O=bank_rdata[0][17] I1=n406 I2=n405 I3=n404
XU664 AOI22S $PINS O=n411 A1=bank_mem_0[14][18] A2=FE_DBTN30_n466
+ B1=bank_mem_0[15][18] B2=n440
XU665 AOI22S $PINS O=n410 A1=bank_mem_0[12][18] A2=FE_DBTN18_n468
+ B1=bank_mem_0[13][18] B2=n442
XU666 AOI22S $PINS O=n408 A1=bank_mem_0[10][18] A2=FE_DBTN24_n199
+ B1=bank_mem_0[11][18] B2=FE_DBTN39_n3
XU667 AOI22S $PINS O=n407 A1=bank_mem_0[8][18] A2=FE_DBTN28_n197
+ B1=bank_mem_0[9][18] B2=FE_DBTN38_n4
XU668 AN2 $PINS O=n409 I1=n408 I2=n407
XU669 ND3 $PINS O=n412 I1=n411 I2=n410 I3=n409
XU670 AOI22S $PINS O=n417 A1=bank_mem_0[7][18] A2=FE_DBTN20_n195 B1=n412 B2=N30
XU671 AOI22S $PINS O=n416 A1=bank_mem_0[5][18] A2=FE_DBTN26_n201
+ B1=bank_mem_0[6][18] B2=FE_DBTN35_n7
XU672 AO222 $PINS O=n414 A1=bank_mem_0[1][18] A2=FE_DBTN33_n9
+ B1=bank_mem_0[0][18] B2=n477 C1=bank_mem_0[2][18] C2=n450
XU673 AO22 $PINS O=n413 A1=bank_mem_0[4][18] A2=n56 B1=bank_mem_0[3][18]
+ B2=n452
XU674 NR2 $PINS O=n415 I1=n414 I2=n413
XU675 ND3 $PINS O=bank_rdata[0][18] I1=n417 I2=n416 I3=n415
XU676 AOI22S $PINS O=n422 A1=bank_mem_0[14][19] A2=FE_DBTN30_n466
+ B1=bank_mem_0[15][19] B2=n38
XU677 AOI22S $PINS O=n421 A1=bank_mem_0[12][19] A2=FE_DBTN18_n468
+ B1=bank_mem_0[13][19] B2=n104
XU678 AOI22S $PINS O=n419 A1=bank_mem_0[10][19] A2=FE_DBTN24_n199
+ B1=bank_mem_0[11][19] B2=FE_DBTN39_n3
XU679 AOI22S $PINS O=n418 A1=bank_mem_0[8][19] A2=FE_DBTN28_n197
+ B1=bank_mem_0[9][19] B2=FE_DBTN38_n4
XU680 AN2 $PINS O=n420 I1=n419 I2=n418
XU681 ND3 $PINS O=n423 I1=n422 I2=n421 I3=n420
XU682 AOI22S $PINS O=n428 A1=bank_mem_0[7][19] A2=FE_DBTN20_n195 B1=n423 B2=N30
XU683 AOI22S $PINS O=n427 A1=bank_mem_0[5][19] A2=FE_DBTN26_n201
+ B1=bank_mem_0[6][19] B2=FE_DBTN35_n7
XU684 AO222 $PINS O=n425 A1=bank_mem_0[1][19] A2=FE_DBTN33_n9
+ B1=bank_mem_0[0][19] B2=FE_DBTN22_n451 C1=bank_mem_0[2][19] C2=n450
XU685 AO22 $PINS O=n424 A1=bank_mem_0[4][19] A2=n56 B1=bank_mem_0[3][19]
+ B2=n452
XU686 NR2 $PINS O=n426 I1=n425 I2=n424
XU687 ND3 $PINS O=FE_PHN1063_bank_rdata_0_19 I1=n428 I2=n427 I3=n426
XU688 AOI22S $PINS O=n433 A1=bank_mem_0[14][20] A2=FE_DBTN30_n466
+ B1=bank_mem_0[15][20] B2=n467
XU689 AOI22S $PINS O=n432 A1=bank_mem_0[12][20] A2=FE_DBTN18_n468
+ B1=bank_mem_0[13][20] B2=n469
XU690 AOI22S $PINS O=n430 A1=bank_mem_0[10][20] A2=FE_DBTN24_n199
+ B1=bank_mem_0[11][20] B2=FE_DBTN39_n3
XU691 AOI22S $PINS O=n429 A1=bank_mem_0[8][20] A2=FE_DBTN28_n197
+ B1=bank_mem_0[9][20] B2=FE_DBTN38_n4
XU692 AN2 $PINS O=n431 I1=n430 I2=n429
XU693 ND3 $PINS O=n434 I1=n433 I2=n432 I3=n431
XU694 AOI22S $PINS O=n439 A1=bank_mem_0[7][20] A2=FE_DBTN20_n195 B1=n434 B2=N30
XU695 AOI22S $PINS O=n438 A1=bank_mem_0[5][20] A2=FE_DBTN26_n201
+ B1=bank_mem_0[6][20] B2=FE_DBTN35_n7
XU696 AO222 $PINS O=n436 A1=bank_mem_0[1][20] A2=FE_DBTN33_n9
+ B1=bank_mem_0[0][20] B2=n477 C1=bank_mem_0[2][20] C2=n450
XU697 AO22 $PINS O=n435 A1=bank_mem_0[4][20] A2=n56 B1=bank_mem_0[3][20]
+ B2=n452
XU698 NR2 $PINS O=n437 I1=n436 I2=n435
XU699 ND3 $PINS O=bank_rdata[0][20] I1=n439 I2=n438 I3=n437
XU700 AOI22S $PINS O=n448 A1=bank_mem_0[14][21] A2=FE_DBTN30_n466
+ B1=bank_mem_0[15][21] B2=n467
XU701 AOI22S $PINS O=n447 A1=bank_mem_0[12][21] A2=FE_DBTN18_n468
+ B1=bank_mem_0[13][21] B2=n469
XU702 AOI22S $PINS O=n445 A1=bank_mem_0[10][21] A2=FE_DBTN24_n199
+ B1=bank_mem_0[11][21] B2=FE_DBTN39_n3
XU703 AOI22S $PINS O=n444 A1=bank_mem_0[8][21] A2=FE_DBTN28_n197
+ B1=bank_mem_0[9][21] B2=FE_DBTN38_n4
XU704 AN2 $PINS O=n446 I1=n445 I2=n444
XU705 ND3 $PINS O=n449 I1=n448 I2=n447 I3=n446
XU706 AOI22S $PINS O=n458 A1=bank_mem_0[7][21] A2=FE_DBTN20_n195 B1=N30 B2=n449
XU707 AOI22S $PINS O=n457 A1=bank_mem_0[5][21] A2=FE_DBTN26_n201
+ B1=bank_mem_0[6][21] B2=FE_DBTN35_n7
XU708 AO222 $PINS O=n455 A1=bank_mem_0[1][21] A2=FE_DBTN33_n9
+ B1=bank_mem_0[0][21] B2=FE_DBTN22_n451 C1=bank_mem_0[2][21] C2=n450
XU709 AO22 $PINS O=n454 A1=bank_mem_0[4][21] A2=n56 B1=bank_mem_0[3][21]
+ B2=n452
XU710 NR2 $PINS O=n456 I1=n455 I2=n454
XU711 ND3 $PINS O=bank_rdata[0][21] I1=n458 I2=n457 I3=n456
XU712 NR2 $PINS O=n490 I1=n739 I2=N34
XU713 NR2 $PINS O=n491 I1=n738 I2=n737
XU714 NR2 $PINS O=n488 I1=n738 I2=N31
XU715 AOI22S $PINS O=n485 A1=bank_mem_1[14][0] A2=FE_DBTN31_n744
+ B1=bank_mem_1[15][0] B2=n718
XU716 NR2 $PINS O=n489 I1=N31 I2=N32
XU717 NR2 $PINS O=n487 I1=n737 I2=N32
XU718 AOI22S $PINS O=n484 A1=bank_mem_1[12][0] A2=FE_DBTN19_n746
+ B1=bank_mem_1[13][0] B2=n720
XU719 AOI22S $PINS O=n482 A1=bank_mem_1[10][0] A2=FE_DBTN25_n200
+ B1=bank_mem_1[11][0] B2=FE_DBTN37_n5
XU720 AOI22S $PINS O=n481 A1=bank_mem_1[8][0] A2=FE_DBTN29_n198
+ B1=bank_mem_1[9][0] B2=FE_DBTN36_n6
XU721 AN2 $PINS O=n483 I1=n482 I2=n481
XU722 ND3 $PINS O=n486 I1=n485 I2=n484 I3=n483
XU723 AOI22S $PINS O=n497 A1=bank_mem_1[7][0] A2=FE_DBTN21_n196 B1=n486 B2=N34
XU724 AOI22S $PINS O=n496 A1=bank_mem_1[5][0] A2=FE_DBTN27_n202
+ B1=bank_mem_1[6][0] B2=FE_DBTN34_n8
XU725 NR2 $PINS O=n492 I1=N33 I2=N34
XU726 AO222 $PINS O=n494 A1=bank_mem_1[1][0] A2=FE_DBTN32_n10
+ B1=bank_mem_1[0][0] B2=FE_DBTN23_n729 C1=bank_mem_1[2][0] C2=n728
XU727 AO22 $PINS O=n493 A1=bank_mem_1[4][0] A2=n55 B1=bank_mem_1[3][0] B2=n730
XU728 NR2 $PINS O=n495 I1=n494 I2=n493
XU729 ND3 $PINS O=bank_rdata[1][0] I1=n497 I2=n496 I3=n495
XU730 AOI22S $PINS O=n502 A1=bank_mem_1[14][1] A2=n719 B1=bank_mem_1[15][1]
+ B2=n37
XU731 AOI22S $PINS O=n501 A1=bank_mem_1[12][1] A2=n721 B1=bank_mem_1[13][1]
+ B2=n103
XU732 AOI22S $PINS O=n499 A1=bank_mem_1[10][1] A2=FE_DBTN25_n200
+ B1=bank_mem_1[11][1] B2=FE_DBTN37_n5
XU733 AOI22S $PINS O=n498 A1=bank_mem_1[8][1] A2=FE_DBTN29_n198
+ B1=bank_mem_1[9][1] B2=FE_DBTN36_n6
XU734 AN2 $PINS O=n500 I1=n499 I2=n498
XU735 ND3 $PINS O=n503 I1=n502 I2=n501 I3=n500
XU736 AOI22S $PINS O=n508 A1=bank_mem_1[7][1] A2=FE_DBTN21_n196 B1=n503 B2=N34
XU737 AOI22S $PINS O=n507 A1=bank_mem_1[5][1] A2=FE_DBTN27_n202
+ B1=bank_mem_1[6][1] B2=FE_DBTN34_n8
XU738 AO222 $PINS O=n505 A1=bank_mem_1[1][1] A2=FE_DBTN32_n10
+ B1=bank_mem_1[0][1] B2=FE_DBTN23_n729 C1=bank_mem_1[2][1] C2=n728
XU739 AO22 $PINS O=n504 A1=bank_mem_1[4][1] A2=n55 B1=bank_mem_1[3][1] B2=n730
XU740 NR2 $PINS O=n506 I1=n505 I2=n504
XU741 ND3 $PINS O=bank_rdata[1][1] I1=n508 I2=n507 I3=n506
XU742 AOI22S $PINS O=n513 A1=bank_mem_1[14][2] A2=FE_DBTN31_n744
+ B1=bank_mem_1[15][2] B2=n745
XU743 AOI22S $PINS O=n512 A1=bank_mem_1[12][2] A2=FE_DBTN19_n746
+ B1=bank_mem_1[13][2] B2=n747
XU744 AOI22S $PINS O=n510 A1=bank_mem_1[10][2] A2=FE_DBTN25_n200
+ B1=bank_mem_1[11][2] B2=FE_DBTN37_n5
XU745 AOI22S $PINS O=n509 A1=bank_mem_1[8][2] A2=FE_DBTN29_n198
+ B1=bank_mem_1[9][2] B2=FE_DBTN36_n6
XU746 AN2 $PINS O=n511 I1=n510 I2=n509
XU747 ND3 $PINS O=n514 I1=n513 I2=n512 I3=n511
XU748 AOI22S $PINS O=n519 A1=bank_mem_1[7][2] A2=FE_DBTN21_n196 B1=n514 B2=N34
XU749 AOI22S $PINS O=n518 A1=bank_mem_1[5][2] A2=FE_DBTN27_n202
+ B1=bank_mem_1[6][2] B2=FE_DBTN34_n8
XU750 AO222 $PINS O=n516 A1=bank_mem_1[1][2] A2=FE_DBTN32_n10
+ B1=bank_mem_1[0][2] B2=FE_DBTN23_n729 C1=bank_mem_1[2][2] C2=n728
XU751 AO22 $PINS O=n515 A1=bank_mem_1[4][2] A2=n55 B1=bank_mem_1[3][2] B2=n730
XU752 NR2 $PINS O=n517 I1=n516 I2=n515
XU753 ND3 $PINS O=bank_rdata[1][2] I1=n519 I2=n518 I3=n517
XU754 AOI22S $PINS O=n524 A1=bank_mem_1[14][3] A2=n719 B1=bank_mem_1[15][3]
+ B2=n745
XU755 AOI22S $PINS O=n523 A1=bank_mem_1[12][3] A2=n721 B1=bank_mem_1[13][3]
+ B2=n747
XU756 AOI22S $PINS O=n521 A1=bank_mem_1[10][3] A2=FE_DBTN25_n200
+ B1=bank_mem_1[11][3] B2=FE_DBTN37_n5
XU757 AOI22S $PINS O=n520 A1=bank_mem_1[8][3] A2=FE_DBTN29_n198
+ B1=bank_mem_1[9][3] B2=FE_DBTN36_n6
XU758 AN2 $PINS O=n522 I1=n521 I2=n520
XU759 ND3 $PINS O=n525 I1=n524 I2=n523 I3=n522
XU760 AOI22S $PINS O=n530 A1=bank_mem_1[7][3] A2=FE_DBTN21_n196 B1=n525 B2=N34
XU761 AOI22S $PINS O=n529 A1=bank_mem_1[5][3] A2=FE_DBTN27_n202
+ B1=bank_mem_1[6][3] B2=FE_DBTN34_n8
XU762 AO222 $PINS O=n527 A1=bank_mem_1[1][3] A2=FE_DBTN32_n10
+ B1=bank_mem_1[0][3] B2=FE_DBTN23_n729 C1=bank_mem_1[2][3] C2=n728
XU763 AO22 $PINS O=n526 A1=bank_mem_1[4][3] A2=n55 B1=bank_mem_1[3][3] B2=n730
XU764 NR2 $PINS O=n528 I1=n527 I2=n526
XU765 ND3 $PINS O=bank_rdata[1][3] I1=n530 I2=n529 I3=n528
XU766 AOI22S $PINS O=n535 A1=bank_mem_1[14][4] A2=FE_DBTN31_n744
+ B1=bank_mem_1[15][4] B2=n37
XU767 AOI22S $PINS O=n534 A1=bank_mem_1[12][4] A2=FE_DBTN19_n746
+ B1=bank_mem_1[13][4] B2=n103
XU768 AOI22S $PINS O=n532 A1=bank_mem_1[10][4] A2=FE_DBTN25_n200
+ B1=bank_mem_1[11][4] B2=FE_DBTN37_n5
XU769 AOI22S $PINS O=n531 A1=bank_mem_1[8][4] A2=FE_DBTN29_n198
+ B1=bank_mem_1[9][4] B2=FE_DBTN36_n6
XU770 AN2 $PINS O=n533 I1=n532 I2=n531
XU771 ND3 $PINS O=n536 I1=n535 I2=n534 I3=n533
XU772 AOI22S $PINS O=n541 A1=FE_PHN1071_bank_mem_1_7_4 A2=FE_DBTN21_n196
+ B1=n536 B2=N34
XU773 AOI22S $PINS O=FE_PHN1458_n540 A1=bank_mem_1[5][4] A2=FE_DBTN27_n202
+ B1=bank_mem_1[6][4] B2=FE_DBTN34_n8
XU774 AO222 $PINS O=n538 A1=bank_mem_1[1][4] A2=FE_DBTN32_n10
+ B1=bank_mem_1[0][4] B2=FE_DBTN23_n729 C1=bank_mem_1[2][4] C2=n728
XU775 AO22 $PINS O=n537 A1=bank_mem_1[4][4] A2=n55 B1=bank_mem_1[3][4] B2=n730
XU776 NR2 $PINS O=n539 I1=n538 I2=n537
XU777 ND3 $PINS O=bank_rdata[1][4] I1=n541 I2=n540 I3=n539
XU778 AOI22S $PINS O=n546 A1=bank_mem_1[14][5] A2=n719 B1=bank_mem_1[15][5]
+ B2=n718
XU779 AOI22S $PINS O=n545 A1=bank_mem_1[12][5] A2=n721 B1=bank_mem_1[13][5]
+ B2=n720
XU780 AOI22S $PINS O=n543 A1=bank_mem_1[10][5] A2=FE_DBTN25_n200
+ B1=bank_mem_1[11][5] B2=FE_DBTN37_n5
XU781 AOI22S $PINS O=n542 A1=bank_mem_1[8][5] A2=FE_DBTN29_n198
+ B1=bank_mem_1[9][5] B2=FE_DBTN36_n6
XU782 AN2 $PINS O=n544 I1=n543 I2=n542
XU783 ND3 $PINS O=n547 I1=n546 I2=n545 I3=n544
XU784 AOI22S $PINS O=n552 A1=bank_mem_1[7][5] A2=FE_DBTN21_n196 B1=n547 B2=N34
XU785 AOI22S $PINS O=n551 A1=bank_mem_1[5][5] A2=FE_DBTN27_n202
+ B1=bank_mem_1[6][5] B2=FE_DBTN34_n8
XU786 AO222 $PINS O=n549 A1=bank_mem_1[1][5] A2=FE_DBTN32_n10
+ B1=bank_mem_1[0][5] B2=FE_DBTN23_n729 C1=bank_mem_1[2][5] C2=n728
XU787 AO22 $PINS O=n548 A1=bank_mem_1[4][5] A2=n55 B1=bank_mem_1[3][5] B2=n730
XU788 NR2 $PINS O=n550 I1=n549 I2=n548
XU789 ND3 $PINS O=FE_PHN1054_bank_rdata_1_5 I1=n552 I2=n551 I3=n550
XU790 AOI22S $PINS O=n557 A1=bank_mem_1[14][6] A2=FE_DBTN31_n744
+ B1=bank_mem_1[15][6] B2=n718
XU791 AOI22S $PINS O=n556 A1=bank_mem_1[12][6] A2=FE_DBTN19_n746
+ B1=bank_mem_1[13][6] B2=n720
XU792 AOI22S $PINS O=n554 A1=bank_mem_1[10][6] A2=FE_DBTN25_n200
+ B1=bank_mem_1[11][6] B2=FE_DBTN37_n5
XU793 AOI22S $PINS O=n553 A1=bank_mem_1[8][6] A2=FE_DBTN29_n198
+ B1=bank_mem_1[9][6] B2=FE_DBTN36_n6
XU794 AN2 $PINS O=n555 I1=n554 I2=n553
XU795 ND3 $PINS O=n558 I1=n557 I2=n556 I3=n555
XU796 AOI22S $PINS O=n563 A1=bank_mem_1[7][6] A2=FE_DBTN21_n196 B1=n558 B2=N34
XU797 AOI22S $PINS O=n562 A1=bank_mem_1[5][6] A2=FE_DBTN27_n202
+ B1=bank_mem_1[6][6] B2=FE_DBTN34_n8
XU798 AO222 $PINS O=n560 A1=bank_mem_1[1][6] A2=FE_DBTN32_n10
+ B1=bank_mem_1[0][6] B2=n755 C1=bank_mem_1[2][6] C2=n728
XU799 AO22 $PINS O=n559 A1=bank_mem_1[4][6] A2=n55 B1=bank_mem_1[3][6] B2=n730
XU800 NR2 $PINS O=n561 I1=n560 I2=n559
XU801 ND3 $PINS O=bank_rdata[1][6] I1=n563 I2=n562 I3=n561
XU802 AOI22S $PINS O=n568 A1=bank_mem_1[14][7] A2=n719 B1=bank_mem_1[15][7]
+ B2=n37
XU803 AOI22S $PINS O=n567 A1=bank_mem_1[12][7] A2=n721 B1=bank_mem_1[13][7]
+ B2=n103
XU804 AOI22S $PINS O=n565 A1=bank_mem_1[10][7] A2=FE_DBTN25_n200
+ B1=bank_mem_1[11][7] B2=FE_DBTN37_n5
XU805 AOI22S $PINS O=n564 A1=bank_mem_1[8][7] A2=FE_DBTN29_n198
+ B1=bank_mem_1[9][7] B2=FE_DBTN36_n6
XU806 AN2 $PINS O=n566 I1=n565 I2=n564
XU807 ND3 $PINS O=n569 I1=n568 I2=n567 I3=n566
XU808 AOI22S $PINS O=n574 A1=bank_mem_1[7][7] A2=FE_DBTN21_n196 B1=n569 B2=N34
XU809 AOI22S $PINS O=n573 A1=bank_mem_1[5][7] A2=FE_DBTN27_n202
+ B1=bank_mem_1[6][7] B2=FE_DBTN34_n8
XU810 AO222 $PINS O=n571 A1=bank_mem_1[1][7] A2=FE_DBTN32_n10
+ B1=bank_mem_1[0][7] B2=FE_DBTN23_n729 C1=bank_mem_1[2][7] C2=n728
XU811 AO22 $PINS O=n570 A1=bank_mem_1[4][7] A2=n55 B1=bank_mem_1[3][7] B2=n730
XU812 NR2 $PINS O=n572 I1=n571 I2=n570
XU813 ND3 $PINS O=bank_rdata[1][7] I1=n574 I2=n573 I3=n572
XU814 AOI22S $PINS O=n579 A1=bank_mem_1[14][8] A2=FE_DBTN31_n744
+ B1=bank_mem_1[15][8] B2=n745
XU815 AOI22S $PINS O=n578 A1=bank_mem_1[12][8] A2=FE_DBTN19_n746
+ B1=bank_mem_1[13][8] B2=n747
XU816 AOI22S $PINS O=n576 A1=bank_mem_1[10][8] A2=FE_DBTN25_n200
+ B1=bank_mem_1[11][8] B2=FE_DBTN37_n5
XU817 AOI22S $PINS O=n575 A1=bank_mem_1[8][8] A2=FE_DBTN29_n198
+ B1=bank_mem_1[9][8] B2=FE_DBTN36_n6
XU818 AN2 $PINS O=n577 I1=n576 I2=n575
XU819 ND3 $PINS O=n580 I1=n579 I2=n578 I3=n577
XU820 AOI22S $PINS O=n585 A1=bank_mem_1[7][8] A2=FE_DBTN21_n196 B1=n580 B2=N34
XU821 AOI22S $PINS O=n584 A1=bank_mem_1[5][8] A2=FE_DBTN27_n202
+ B1=bank_mem_1[6][8] B2=FE_DBTN34_n8
XU822 AO222 $PINS O=n582 A1=bank_mem_1[1][8] A2=FE_DBTN32_n10
+ B1=bank_mem_1[0][8] B2=n755 C1=bank_mem_1[2][8] C2=n728
XU823 AO22 $PINS O=n581 A1=bank_mem_1[4][8] A2=n55 B1=bank_mem_1[3][8] B2=n730
XU824 NR2 $PINS O=n583 I1=n582 I2=n581
XU825 ND3 $PINS O=bank_rdata[1][8] I1=n585 I2=n584 I3=n583
XU826 AOI22S $PINS O=n590 A1=bank_mem_1[14][9] A2=n719 B1=bank_mem_1[15][9]
+ B2=n745
XU827 AOI22S $PINS O=n589 A1=bank_mem_1[12][9] A2=n721 B1=bank_mem_1[13][9]
+ B2=n747
XU828 AOI22S $PINS O=n587 A1=bank_mem_1[10][9] A2=FE_DBTN25_n200
+ B1=bank_mem_1[11][9] B2=FE_DBTN37_n5
XU829 AOI22S $PINS O=n586 A1=bank_mem_1[8][9] A2=FE_DBTN29_n198
+ B1=bank_mem_1[9][9] B2=FE_DBTN36_n6
XU830 AN2 $PINS O=n588 I1=n587 I2=n586
XU831 ND3 $PINS O=n591 I1=n590 I2=n589 I3=n588
XU832 AOI22S $PINS O=n596 A1=bank_mem_1[7][9] A2=FE_DBTN21_n196 B1=n591 B2=N34
XU833 AOI22S $PINS O=n595 A1=bank_mem_1[5][9] A2=FE_DBTN27_n202
+ B1=bank_mem_1[6][9] B2=FE_DBTN34_n8
XU834 AO222 $PINS O=n593 A1=bank_mem_1[1][9] A2=FE_DBTN32_n10
+ B1=bank_mem_1[0][9] B2=FE_DBTN23_n729 C1=bank_mem_1[2][9] C2=n728
XU835 AO22 $PINS O=n592 A1=bank_mem_1[4][9] A2=n55 B1=bank_mem_1[3][9] B2=n730
XU836 NR2 $PINS O=n594 I1=n593 I2=n592
XU837 ND3 $PINS O=bank_rdata[1][9] I1=n596 I2=n595 I3=n594
XU838 AOI22S $PINS O=n601 A1=bank_mem_1[14][10] A2=FE_DBTN31_n744
+ B1=bank_mem_1[15][10] B2=n37
XU839 AOI22S $PINS O=n600 A1=bank_mem_1[12][10] A2=FE_DBTN19_n746
+ B1=bank_mem_1[13][10] B2=n103
XU840 AOI22S $PINS O=n598 A1=bank_mem_1[10][10] A2=FE_DBTN25_n200
+ B1=bank_mem_1[11][10] B2=FE_DBTN37_n5
XU841 AOI22S $PINS O=n597 A1=bank_mem_1[8][10] A2=FE_DBTN29_n198
+ B1=bank_mem_1[9][10] B2=FE_DBTN36_n6
XU842 AN2 $PINS O=n599 I1=n598 I2=n597
XU843 ND3 $PINS O=n602 I1=n601 I2=n600 I3=n599
XU844 AOI22S $PINS O=n607 A1=bank_mem_1[7][10] A2=FE_DBTN21_n196 B1=n602 B2=N34
XU845 AOI22S $PINS O=n606 A1=bank_mem_1[5][10] A2=FE_DBTN27_n202
+ B1=bank_mem_1[6][10] B2=FE_DBTN34_n8
XU846 AO222 $PINS O=n604 A1=bank_mem_1[1][10] A2=FE_DBTN32_n10
+ B1=bank_mem_1[0][10] B2=n755 C1=bank_mem_1[2][10] C2=n728
XU847 AO22 $PINS O=n603 A1=bank_mem_1[4][10] A2=n55 B1=bank_mem_1[3][10]
+ B2=n730
XU848 NR2 $PINS O=n605 I1=n604 I2=n603
XU849 ND3 $PINS O=bank_rdata[1][10] I1=n607 I2=n606 I3=n605
XU850 AOI22S $PINS O=n612 A1=bank_mem_1[14][11] A2=n719 B1=bank_mem_1[15][11]
+ B2=n718
XU851 AOI22S $PINS O=n611 A1=bank_mem_1[12][11] A2=n721 B1=bank_mem_1[13][11]
+ B2=n720
XU852 AOI22S $PINS O=n609 A1=bank_mem_1[10][11] A2=FE_DBTN25_n200
+ B1=bank_mem_1[11][11] B2=FE_DBTN37_n5
XU853 AOI22S $PINS O=n608 A1=bank_mem_1[8][11] A2=FE_DBTN29_n198
+ B1=bank_mem_1[9][11] B2=FE_DBTN36_n6
XU854 AN2 $PINS O=n610 I1=n609 I2=n608
XU855 ND3 $PINS O=n613 I1=n612 I2=n611 I3=n610
XU856 AOI22S $PINS O=n618 A1=bank_mem_1[7][11] A2=FE_DBTN21_n196 B1=n613 B2=N34
XU857 AOI22S $PINS O=n617 A1=bank_mem_1[5][11] A2=FE_DBTN27_n202
+ B1=bank_mem_1[6][11] B2=FE_DBTN34_n8
XU858 AO222 $PINS O=n615 A1=bank_mem_1[1][11] A2=FE_DBTN32_n10
+ B1=bank_mem_1[0][11] B2=FE_DBTN23_n729 C1=bank_mem_1[2][11] C2=n728
XU859 AO22 $PINS O=n614 A1=bank_mem_1[4][11] A2=n55 B1=bank_mem_1[3][11]
+ B2=n730
XU860 NR2 $PINS O=n616 I1=n615 I2=n614
XU861 ND3 $PINS O=bank_rdata[1][11] I1=n618 I2=n617 I3=n616
XU862 AOI22S $PINS O=n623 A1=bank_mem_1[14][12] A2=FE_DBTN31_n744
+ B1=bank_mem_1[15][12] B2=n718
XU863 AOI22S $PINS O=n622 A1=bank_mem_1[12][12] A2=FE_DBTN19_n746
+ B1=bank_mem_1[13][12] B2=n720
XU864 AOI22S $PINS O=n620 A1=bank_mem_1[10][12] A2=FE_DBTN25_n200
+ B1=bank_mem_1[11][12] B2=FE_DBTN37_n5
XU865 AOI22S $PINS O=n619 A1=bank_mem_1[8][12] A2=FE_DBTN29_n198
+ B1=bank_mem_1[9][12] B2=FE_DBTN36_n6
XU866 AN2 $PINS O=n621 I1=n620 I2=n619
XU867 ND3 $PINS O=n624 I1=n623 I2=n622 I3=n621
XU868 AOI22S $PINS O=n629 A1=bank_mem_1[7][12] A2=FE_DBTN21_n196 B1=n624 B2=N34
XU869 AOI22S $PINS O=n628 A1=bank_mem_1[5][12] A2=FE_DBTN27_n202
+ B1=bank_mem_1[6][12] B2=FE_DBTN34_n8
XU870 AO222 $PINS O=n626 A1=bank_mem_1[1][12] A2=FE_DBTN32_n10
+ B1=bank_mem_1[0][12] B2=n755 C1=bank_mem_1[2][12] C2=n728
XU871 AO22 $PINS O=n625 A1=bank_mem_1[4][12] A2=n55 B1=bank_mem_1[3][12]
+ B2=n730
XU872 NR2 $PINS O=n627 I1=n626 I2=n625
XU873 ND3 $PINS O=bank_rdata[1][12] I1=n629 I2=n628 I3=n627
XU874 AOI22S $PINS O=n634 A1=bank_mem_1[14][13] A2=n719 B1=bank_mem_1[15][13]
+ B2=n37
XU875 AOI22S $PINS O=n633 A1=bank_mem_1[12][13] A2=n721 B1=bank_mem_1[13][13]
+ B2=n103
XU876 AOI22S $PINS O=n631 A1=bank_mem_1[10][13] A2=FE_DBTN25_n200
+ B1=bank_mem_1[11][13] B2=FE_DBTN37_n5
XU877 AOI22S $PINS O=n630 A1=bank_mem_1[8][13] A2=FE_DBTN29_n198
+ B1=bank_mem_1[9][13] B2=FE_DBTN36_n6
XU878 AN2 $PINS O=n632 I1=n631 I2=n630
XU879 ND3 $PINS O=n635 I1=n634 I2=n633 I3=n632
XU880 AOI22S $PINS O=n640 A1=bank_mem_1[7][13] A2=FE_DBTN21_n196 B1=n635 B2=N34
XU881 AOI22S $PINS O=n639 A1=bank_mem_1[5][13] A2=FE_DBTN27_n202
+ B1=bank_mem_1[6][13] B2=FE_DBTN34_n8
XU882 AO222 $PINS O=n637 A1=bank_mem_1[1][13] A2=FE_DBTN32_n10
+ B1=bank_mem_1[0][13] B2=FE_DBTN23_n729 C1=bank_mem_1[2][13] C2=n728
XU883 AO22 $PINS O=n636 A1=bank_mem_1[4][13] A2=n55 B1=bank_mem_1[3][13]
+ B2=n730
XU884 NR2 $PINS O=n638 I1=n637 I2=n636
XU885 ND3 $PINS O=bank_rdata[1][13] I1=n640 I2=n639 I3=n638
XU886 AOI22S $PINS O=n645 A1=bank_mem_1[14][14] A2=FE_DBTN31_n744
+ B1=bank_mem_1[15][14] B2=n745
XU887 AOI22S $PINS O=n644 A1=bank_mem_1[12][14] A2=FE_DBTN19_n746
+ B1=bank_mem_1[13][14] B2=n747
XU888 AOI22S $PINS O=n642 A1=bank_mem_1[10][14] A2=FE_DBTN25_n200
+ B1=bank_mem_1[11][14] B2=FE_DBTN37_n5
XU889 AOI22S $PINS O=n641 A1=bank_mem_1[8][14] A2=FE_DBTN29_n198
+ B1=bank_mem_1[9][14] B2=FE_DBTN36_n6
XU890 AN2 $PINS O=n643 I1=n642 I2=n641
XU891 ND3 $PINS O=n646 I1=n645 I2=n644 I3=n643
XU892 AOI22S $PINS O=n651 A1=bank_mem_1[7][14] A2=FE_DBTN21_n196 B1=n646 B2=N34
XU893 AOI22S $PINS O=n650 A1=bank_mem_1[5][14] A2=FE_DBTN27_n202
+ B1=bank_mem_1[6][14] B2=FE_DBTN34_n8
XU894 AO222 $PINS O=n648 A1=bank_mem_1[1][14] A2=FE_DBTN32_n10
+ B1=bank_mem_1[0][14] B2=n755 C1=bank_mem_1[2][14] C2=n728
XU895 AO22 $PINS O=n647 A1=bank_mem_1[4][14] A2=n55 B1=bank_mem_1[3][14]
+ B2=n730
XU896 NR2 $PINS O=n649 I1=n648 I2=n647
XU897 ND3 $PINS O=bank_rdata[1][14] I1=n651 I2=n650 I3=n649
XU898 AOI22S $PINS O=n656 A1=bank_mem_1[14][15] A2=n719 B1=bank_mem_1[15][15]
+ B2=n745
XU899 AOI22S $PINS O=n655 A1=bank_mem_1[12][15] A2=n721 B1=bank_mem_1[13][15]
+ B2=n747
XU900 AOI22S $PINS O=n653 A1=bank_mem_1[10][15] A2=FE_DBTN25_n200
+ B1=bank_mem_1[11][15] B2=FE_DBTN37_n5
XU901 AOI22S $PINS O=n652 A1=bank_mem_1[8][15] A2=FE_DBTN29_n198
+ B1=bank_mem_1[9][15] B2=FE_DBTN36_n6
XU902 AN2 $PINS O=n654 I1=n653 I2=n652
XU903 ND3 $PINS O=n657 I1=n656 I2=n655 I3=n654
XU904 AOI22S $PINS O=n662 A1=bank_mem_1[7][15] A2=FE_DBTN21_n196 B1=n657 B2=N34
XU905 AOI22S $PINS O=n661 A1=bank_mem_1[5][15] A2=FE_DBTN27_n202
+ B1=bank_mem_1[6][15] B2=FE_DBTN34_n8
XU906 AO222 $PINS O=n659 A1=bank_mem_1[1][15] A2=FE_DBTN32_n10
+ B1=bank_mem_1[0][15] B2=FE_DBTN23_n729 C1=bank_mem_1[2][15] C2=n728
XU907 AO22 $PINS O=n658 A1=bank_mem_1[4][15] A2=n55 B1=bank_mem_1[3][15]
+ B2=n730
XU908 NR2 $PINS O=n660 I1=n659 I2=n658
XU909 ND3 $PINS O=bank_rdata[1][15] I1=n662 I2=n661 I3=n660
XU910 AOI22S $PINS O=n667 A1=bank_mem_1[14][16] A2=FE_DBTN31_n744
+ B1=bank_mem_1[15][16] B2=n37
XU911 AOI22S $PINS O=n666 A1=bank_mem_1[12][16] A2=FE_DBTN19_n746
+ B1=bank_mem_1[13][16] B2=n103
XU912 AOI22S $PINS O=n664 A1=bank_mem_1[10][16] A2=FE_DBTN25_n200
+ B1=bank_mem_1[11][16] B2=FE_DBTN37_n5
XU913 AOI22S $PINS O=n663 A1=bank_mem_1[8][16] A2=FE_DBTN29_n198
+ B1=bank_mem_1[9][16] B2=FE_DBTN36_n6
XU914 AN2 $PINS O=n665 I1=n664 I2=n663
XU915 ND3 $PINS O=n668 I1=n667 I2=n666 I3=n665
XU916 AOI22S $PINS O=n673 A1=bank_mem_1[7][16] A2=FE_DBTN21_n196 B1=n668 B2=N34
XU917 AOI22S $PINS O=n672 A1=bank_mem_1[5][16] A2=FE_DBTN27_n202
+ B1=bank_mem_1[6][16] B2=FE_DBTN34_n8
XU918 AO222 $PINS O=n670 A1=bank_mem_1[1][16] A2=FE_DBTN32_n10
+ B1=bank_mem_1[0][16] B2=n755 C1=bank_mem_1[2][16] C2=n728
XU919 AO22 $PINS O=n669 A1=bank_mem_1[4][16] A2=n55 B1=bank_mem_1[3][16]
+ B2=n730
XU920 NR2 $PINS O=n671 I1=n670 I2=n669
XU921 ND3 $PINS O=bank_rdata[1][16] I1=n673 I2=n672 I3=n671
XU922 AOI22S $PINS O=n678 A1=bank_mem_1[14][17] A2=FE_DBTN31_n744
+ B1=bank_mem_1[15][17] B2=n718
XU923 AOI22S $PINS O=n677 A1=bank_mem_1[12][17] A2=FE_DBTN19_n746
+ B1=bank_mem_1[13][17] B2=n720
XU924 AOI22S $PINS O=n675 A1=bank_mem_1[10][17] A2=FE_DBTN25_n200
+ B1=bank_mem_1[11][17] B2=FE_DBTN37_n5
XU925 AOI22S $PINS O=n674 A1=bank_mem_1[8][17] A2=FE_DBTN29_n198
+ B1=bank_mem_1[9][17] B2=FE_DBTN36_n6
XU926 AN2 $PINS O=n676 I1=n675 I2=n674
XU927 ND3 $PINS O=n679 I1=n678 I2=n677 I3=n676
XU928 AOI22S $PINS O=n684 A1=bank_mem_1[7][17] A2=FE_DBTN21_n196 B1=n679 B2=N34
XU929 AOI22S $PINS O=n683 A1=bank_mem_1[5][17] A2=FE_DBTN27_n202
+ B1=bank_mem_1[6][17] B2=FE_DBTN34_n8
XU930 AO222 $PINS O=n681 A1=bank_mem_1[1][17] A2=FE_DBTN32_n10
+ B1=bank_mem_1[0][17] B2=FE_DBTN23_n729 C1=bank_mem_1[2][17] C2=n728
XU931 AO22 $PINS O=n680 A1=bank_mem_1[4][17] A2=n55 B1=bank_mem_1[3][17]
+ B2=n730
XU932 NR2 $PINS O=n682 I1=n681 I2=n680
XU933 ND3 $PINS O=bank_rdata[1][17] I1=n684 I2=n683 I3=n682
XU934 AOI22S $PINS O=n689 A1=bank_mem_1[14][18] A2=FE_DBTN31_n744
+ B1=bank_mem_1[15][18] B2=n718
XU935 AOI22S $PINS O=n688 A1=bank_mem_1[12][18] A2=FE_DBTN19_n746
+ B1=bank_mem_1[13][18] B2=n720
XU936 AOI22S $PINS O=n686 A1=bank_mem_1[10][18] A2=FE_DBTN25_n200
+ B1=bank_mem_1[11][18] B2=FE_DBTN37_n5
XU937 AOI22S $PINS O=n685 A1=bank_mem_1[8][18] A2=FE_DBTN29_n198
+ B1=bank_mem_1[9][18] B2=FE_DBTN36_n6
XU938 AN2 $PINS O=n687 I1=n686 I2=n685
XU939 ND3 $PINS O=n690 I1=n689 I2=n688 I3=n687
XU940 AOI22S $PINS O=n695 A1=bank_mem_1[7][18] A2=FE_DBTN21_n196 B1=n690 B2=N34
XU941 AOI22S $PINS O=n694 A1=bank_mem_1[5][18] A2=FE_DBTN27_n202
+ B1=bank_mem_1[6][18] B2=FE_DBTN34_n8
XU942 AO222 $PINS O=n692 A1=bank_mem_1[1][18] A2=FE_DBTN32_n10
+ B1=bank_mem_1[0][18] B2=n755 C1=bank_mem_1[2][18] C2=n728
XU943 AO22 $PINS O=n691 A1=bank_mem_1[4][18] A2=n55 B1=bank_mem_1[3][18]
+ B2=n730
XU944 NR2 $PINS O=n693 I1=n692 I2=n691
XU945 ND3 $PINS O=bank_rdata[1][18] I1=n695 I2=n694 I3=n693
XU946 AOI22S $PINS O=n700 A1=bank_mem_1[14][19] A2=FE_DBTN31_n744
+ B1=bank_mem_1[15][19] B2=n37
XU947 AOI22S $PINS O=n699 A1=bank_mem_1[12][19] A2=FE_DBTN19_n746
+ B1=bank_mem_1[13][19] B2=n103
XU948 AOI22S $PINS O=n697 A1=bank_mem_1[10][19] A2=FE_DBTN25_n200
+ B1=bank_mem_1[11][19] B2=FE_DBTN37_n5
XU949 AOI22S $PINS O=n696 A1=bank_mem_1[8][19] A2=FE_DBTN29_n198
+ B1=bank_mem_1[9][19] B2=FE_DBTN36_n6
XU950 AN2 $PINS O=n698 I1=n697 I2=n696
XU951 ND3 $PINS O=n701 I1=n700 I2=n699 I3=n698
XU952 AOI22S $PINS O=n706 A1=bank_mem_1[7][19] A2=FE_DBTN21_n196 B1=n701 B2=N34
XU953 AOI22S $PINS O=n705 A1=bank_mem_1[5][19] A2=FE_DBTN27_n202
+ B1=bank_mem_1[6][19] B2=FE_DBTN34_n8
XU954 AO222 $PINS O=n703 A1=bank_mem_1[1][19] A2=FE_DBTN32_n10
+ B1=bank_mem_1[0][19] B2=FE_DBTN23_n729 C1=bank_mem_1[2][19] C2=n728
XU955 AO22 $PINS O=n702 A1=bank_mem_1[4][19] A2=n55 B1=bank_mem_1[3][19]
+ B2=n730
XU956 NR2 $PINS O=n704 I1=n703 I2=n702
XU957 ND3 $PINS O=bank_rdata[1][19] I1=n706 I2=n705 I3=n704
XU958 AOI22S $PINS O=n711 A1=bank_mem_1[14][20] A2=FE_DBTN31_n744
+ B1=bank_mem_1[15][20] B2=n745
XU959 AOI22S $PINS O=n710 A1=bank_mem_1[12][20] A2=FE_DBTN19_n746
+ B1=bank_mem_1[13][20] B2=n747
XU960 AOI22S $PINS O=n708 A1=bank_mem_1[10][20] A2=FE_DBTN25_n200
+ B1=bank_mem_1[11][20] B2=FE_DBTN37_n5
XU961 AOI22S $PINS O=n707 A1=bank_mem_1[8][20] A2=FE_DBTN29_n198
+ B1=bank_mem_1[9][20] B2=FE_DBTN36_n6
XU962 AN2 $PINS O=n709 I1=n708 I2=n707
XU963 ND3 $PINS O=n712 I1=n711 I2=n710 I3=n709
XU964 AOI22S $PINS O=n717 A1=bank_mem_1[7][20] A2=FE_DBTN21_n196 B1=n712 B2=N34
XU965 AOI22S $PINS O=n716 A1=bank_mem_1[5][20] A2=FE_DBTN27_n202
+ B1=bank_mem_1[6][20] B2=FE_DBTN34_n8
XU966 AO222 $PINS O=n714 A1=bank_mem_1[1][20] A2=FE_DBTN32_n10
+ B1=bank_mem_1[0][20] B2=n755 C1=bank_mem_1[2][20] C2=n728
XU967 AO22 $PINS O=n713 A1=bank_mem_1[4][20] A2=n55 B1=bank_mem_1[3][20]
+ B2=n730
XU968 NR2 $PINS O=n715 I1=n714 I2=n713
XU969 ND3 $PINS O=bank_rdata[1][20] I1=n717 I2=n716 I3=n715
XU970 AOI22S $PINS O=n726 A1=bank_mem_1[14][21] A2=FE_DBTN31_n744
+ B1=bank_mem_1[15][21] B2=n745
XU971 AOI22S $PINS O=n725 A1=bank_mem_1[12][21] A2=FE_DBTN19_n746
+ B1=bank_mem_1[13][21] B2=n747
XU972 AOI22S $PINS O=n723 A1=bank_mem_1[10][21] A2=FE_DBTN25_n200
+ B1=bank_mem_1[11][21] B2=FE_DBTN37_n5
XU973 AOI22S $PINS O=n722 A1=bank_mem_1[8][21] A2=FE_DBTN29_n198
+ B1=bank_mem_1[9][21] B2=FE_DBTN36_n6
XU974 AN2 $PINS O=n724 I1=n723 I2=n722
XU975 ND3 $PINS O=n727 I1=n726 I2=n725 I3=n724
XU976 AOI22S $PINS O=n736 A1=bank_mem_1[7][21] A2=FE_DBTN21_n196 B1=N34 B2=n727
XU977 AOI22S $PINS O=n735 A1=bank_mem_1[5][21] A2=FE_DBTN27_n202
+ B1=bank_mem_1[6][21] B2=FE_DBTN34_n8
XU978 AO222 $PINS O=n733 A1=bank_mem_1[1][21] A2=FE_DBTN32_n10
+ B1=bank_mem_1[0][21] B2=FE_DBTN23_n729 C1=bank_mem_1[2][21] C2=n728
XU979 AO22 $PINS O=n732 A1=bank_mem_1[4][21] A2=n55 B1=bank_mem_1[3][21]
+ B2=n730
XU980 NR2 $PINS O=n734 I1=n733 I2=n732
XU981 ND3 $PINS O=bank_rdata[1][21] I1=n736 I2=n735 I3=n734
Xclk_gate_bank_mem_1_reg[0] SNPS_CLOCK_GATE_HIGH_RegFileDual_DATA_WIDTH22_0
+ $PINS EN=N100 ENCLK=CTS_342 CLK=CTS_343
Xclk_gate_bank_mem_1_reg[1] SNPS_CLOCK_GATE_HIGH_RegFileDual_DATA_WIDTH22_31
+ $PINS EN=N99 ENCLK=CTS_339 CLK=CTS_343
Xclk_gate_bank_mem_1_reg[2] SNPS_CLOCK_GATE_HIGH_RegFileDual_DATA_WIDTH22_30
+ $PINS EN=N98 ENCLK=CTS_336 CLK=CTS_343
Xclk_gate_bank_mem_1_reg[3] SNPS_CLOCK_GATE_HIGH_RegFileDual_DATA_WIDTH22_29
+ $PINS EN=N97 ENCLK=CTS_333 CLK=CTS_343
Xclk_gate_bank_mem_1_reg[4] SNPS_CLOCK_GATE_HIGH_RegFileDual_DATA_WIDTH22_28
+ $PINS EN=N96 ENCLK=CTS_330 CLK=CTS_343
Xclk_gate_bank_mem_1_reg[5] SNPS_CLOCK_GATE_HIGH_RegFileDual_DATA_WIDTH22_27
+ $PINS EN=N95 ENCLK=CTS_327 CLK=CTS_343
Xclk_gate_bank_mem_1_reg[6] SNPS_CLOCK_GATE_HIGH_RegFileDual_DATA_WIDTH22_26
+ $PINS EN=N94 ENCLK=CTS_324 CLK=CTS_343
Xclk_gate_bank_mem_1_reg[7] SNPS_CLOCK_GATE_HIGH_RegFileDual_DATA_WIDTH22_25
+ $PINS EN=N93 ENCLK=CTS_321 CLK=CTS_343
Xclk_gate_bank_mem_1_reg[8] SNPS_CLOCK_GATE_HIGH_RegFileDual_DATA_WIDTH22_24
+ $PINS EN=N92 ENCLK=CTS_318 CLK=CTS_343
Xclk_gate_bank_mem_1_reg[9] SNPS_CLOCK_GATE_HIGH_RegFileDual_DATA_WIDTH22_23
+ $PINS EN=N91 ENCLK=CTS_315 CLK=CTS_343
Xclk_gate_bank_mem_1_reg[10] SNPS_CLOCK_GATE_HIGH_RegFileDual_DATA_WIDTH22_22
+ $PINS EN=N90 ENCLK=CTS_312 CLK=CTS_343
Xclk_gate_bank_mem_1_reg[11] SNPS_CLOCK_GATE_HIGH_RegFileDual_DATA_WIDTH22_21
+ $PINS EN=N89 ENCLK=CTS_309 CLK=CTS_343
Xclk_gate_bank_mem_1_reg[12] SNPS_CLOCK_GATE_HIGH_RegFileDual_DATA_WIDTH22_20
+ $PINS EN=N88 ENCLK=CTS_306 CLK=CTS_343
Xclk_gate_bank_mem_1_reg[13] SNPS_CLOCK_GATE_HIGH_RegFileDual_DATA_WIDTH22_19
+ $PINS EN=N87 ENCLK=CTS_303 CLK=CTS_343
Xclk_gate_bank_mem_1_reg[14] SNPS_CLOCK_GATE_HIGH_RegFileDual_DATA_WIDTH22_18
+ $PINS EN=N86 ENCLK=CTS_300 CLK=CTS_343
Xclk_gate_bank_mem_1_reg[15] SNPS_CLOCK_GATE_HIGH_RegFileDual_DATA_WIDTH22_17
+ $PINS EN=N85 ENCLK=CTS_297 CLK=CTS_343
Xclk_gate_bank_mem_0_reg[0] SNPS_CLOCK_GATE_HIGH_RegFileDual_DATA_WIDTH22_16
+ $PINS EN=N67 ENCLK=CTS_392 CLK=clk_clone1
Xclk_gate_bank_mem_0_reg[1] SNPS_CLOCK_GATE_HIGH_RegFileDual_DATA_WIDTH22_15
+ $PINS EN=N66 ENCLK=CTS_389 CLK=clk_clone1
Xclk_gate_bank_mem_0_reg[2] SNPS_CLOCK_GATE_HIGH_RegFileDual_DATA_WIDTH22_14
+ $PINS EN=N65 ENCLK=CTS_386 CLK=clk_clone1
Xclk_gate_bank_mem_0_reg[3] SNPS_CLOCK_GATE_HIGH_RegFileDual_DATA_WIDTH22_13
+ $PINS EN=N64 ENCLK=CTS_383 CLK=clk_clone1
Xclk_gate_bank_mem_0_reg[4] SNPS_CLOCK_GATE_HIGH_RegFileDual_DATA_WIDTH22_12
+ $PINS EN=N63 ENCLK=CTS_380 CLK=clk_clone1
Xclk_gate_bank_mem_0_reg[5] SNPS_CLOCK_GATE_HIGH_RegFileDual_DATA_WIDTH22_11
+ $PINS EN=N62 ENCLK=CTS_377 CLK=clk_clone1
Xclk_gate_bank_mem_0_reg[6] SNPS_CLOCK_GATE_HIGH_RegFileDual_DATA_WIDTH22_10
+ $PINS EN=N61 ENCLK=CTS_374 CLK=clk_clone1
Xclk_gate_bank_mem_0_reg[7] SNPS_CLOCK_GATE_HIGH_RegFileDual_DATA_WIDTH22_9
+ $PINS EN=N60 ENCLK=CTS_371 CLK=clk_clone1
Xclk_gate_bank_mem_0_reg[8] SNPS_CLOCK_GATE_HIGH_RegFileDual_DATA_WIDTH22_8
+ $PINS EN=N59 ENCLK=CTS_368 CLK=clk_clone1
Xclk_gate_bank_mem_0_reg[9] SNPS_CLOCK_GATE_HIGH_RegFileDual_DATA_WIDTH22_7
+ $PINS EN=N58 ENCLK=CTS_365 CLK=clk_clone1
Xclk_gate_bank_mem_0_reg[10] SNPS_CLOCK_GATE_HIGH_RegFileDual_DATA_WIDTH22_6
+ $PINS EN=N57 ENCLK=CTS_362 CLK=clk_clone1
Xclk_gate_bank_mem_0_reg[11] SNPS_CLOCK_GATE_HIGH_RegFileDual_DATA_WIDTH22_5
+ $PINS EN=N56 ENCLK=CTS_359 CLK=clk_clone1
Xclk_gate_bank_mem_0_reg[12] SNPS_CLOCK_GATE_HIGH_RegFileDual_DATA_WIDTH22_4
+ $PINS EN=N55 ENCLK=CTS_356 CLK=clk_clone1
Xclk_gate_bank_mem_0_reg[13] SNPS_CLOCK_GATE_HIGH_RegFileDual_DATA_WIDTH22_3
+ $PINS EN=N54 ENCLK=CTS_353 CLK=clk_clone1
Xclk_gate_bank_mem_0_reg[14] SNPS_CLOCK_GATE_HIGH_RegFileDual_DATA_WIDTH22_2
+ $PINS EN=N53 ENCLK=CTS_350 CLK=clk_clone1
Xclk_gate_bank_mem_0_reg[15] SNPS_CLOCK_GATE_HIGH_RegFileDual_DATA_WIDTH22_1
+ $PINS EN=N52 ENCLK=CTS_347 CLK=clk_clone1
XU154 ND2 $PINS O=n65 I1=n71 I2=n72
.ENDS

.SUBCKT SNPS_CLOCK_GATE_HIGH_CHIP_0 EN ENCLK CLK
*.CONNECT ENCLK net1608
*.CONNECT net1609 EN
XFE_PHC991_net1612 DELC $PINS O=FE_PHN991_net1612 I=net1612
Xlatch QDBHN $PINS Q=net1612 D=net1609 CKB=CLK
Xmain_gate AN2T $PINS O=net1608 I1=FE_PHN991_net1612 I2=CLK
.ENDS

.SUBCKT SNPS_CLOCK_GATE_HIGH_CHIP_10 EN ENCLK CLK
*.CONNECT net1609 EN
XFE_PHC940_net1612 DELC $PINS O=net1612 I=FE_PHN940_net1612
Xlatch QDBHN $PINS Q=FE_PHN940_net1612 D=net1609 CKB=CLK
Xmain_gate AN2T $PINS O=ENCLK I1=net1612 I2=CLK
.ENDS

.SUBCKT SNPS_CLOCK_GATE_HIGH_CHIP_9 EN ENCLK CLK
*.CONNECT net1609 EN
XFE_PHC890_net1612 DELC $PINS O=FE_PHN890_net1612 I=net1612
Xlatch QDBHN $PINS Q=net1612 D=net1609 CKB=CLK
Xmain_gate AN2T $PINS O=ENCLK I1=FE_PHN890_net1612 I2=CLK
.ENDS

.SUBCKT SNPS_CLOCK_GATE_HIGH_CHIP_8 CLK EN ENCLK CLK_clone1
*.CONNECT net1606 CLK
*.CONNECT net1609 EN
XFE_PHC986_net1612 DELC $PINS O=net1612 I=FE_PHN986_net1612
Xlatch QDBHN $PINS Q=FE_PHN986_net1612 D=net1609 CKB=CLK_clone1
Xmain_gate AN2T $PINS O=ENCLK I1=net1612 I2=net1606
.ENDS

.SUBCKT SNPS_CLOCK_GATE_HIGH_CHIP_7 EN ENCLK CLK
*.CONNECT net1609 EN
XFE_PHC918_net1612 DELC $PINS O=FE_PHN918_net1612 I=net1612
Xlatch QDBHN $PINS Q=net1612 D=net1609 CKB=CLK
Xmain_gate AN2T $PINS O=ENCLK I1=FE_PHN918_net1612 I2=CLK
.ENDS

.SUBCKT SNPS_CLOCK_GATE_HIGH_CHIP_6 EN ENCLK CLK
*.CONNECT net1609 EN
XFE_PHC931_net1612 DELC $PINS O=FE_PHN931_net1612 I=net1612
Xlatch QDBHN $PINS Q=net1612 D=net1609 CKB=CLK
Xmain_gate AN2T $PINS O=ENCLK I1=FE_PHN931_net1612 I2=CLK
.ENDS

.SUBCKT SNPS_CLOCK_GATE_HIGH_CHIP_5 EN ENCLK CLK
*.CONNECT net1609 EN
XFE_PHC973_net1612 DELC $PINS O=net1612 I=FE_PHN973_net1612
Xlatch QDBHN $PINS Q=FE_PHN973_net1612 D=net1609 CKB=CLK
Xmain_gate AN2T $PINS O=ENCLK I1=net1612 I2=CLK
.ENDS

.SUBCKT SNPS_CLOCK_GATE_HIGH_CHIP_4 EN ENCLK CLK
*.CONNECT net1609 EN
XFE_PHC942_net1612 DELC $PINS O=net1612 I=FE_PHN942_net1612
Xlatch QDBHN $PINS Q=FE_PHN942_net1612 D=net1609 CKB=CLK
Xmain_gate AN2T $PINS O=ENCLK I1=net1612 I2=CLK
.ENDS

.SUBCKT SNPS_CLOCK_GATE_HIGH_CHIP_3 EN ENCLK CLK
*.CONNECT ENCLK net1608
*.CONNECT net1609 EN
XFE_PHC892_net1612 DELC $PINS O=net1612 I=FE_PHN892_net1612
Xlatch QDBHN $PINS Q=FE_PHN892_net1612 D=net1609 CKB=CLK
Xmain_gate AN2T $PINS O=net1608 I1=net1612 I2=CLK
.ENDS

.SUBCKT SNPS_CLOCK_GATE_HIGH_CHIP_2 EN ENCLK CLK
*.CONNECT ENCLK net1608
*.CONNECT net1609 EN
XFE_PHC866_net1612 DELC $PINS O=FE_PHN866_net1612 I=net1612
Xlatch QDBHN $PINS Q=net1612 D=net1609 CKB=CLK
Xmain_gate AN2P $PINS O=net1608 I1=FE_PHN866_net1612 I2=CLK
.ENDS

.SUBCKT SNPS_CLOCK_GATE_HIGH_CHIP_1 EN ENCLK CLK
*.CONNECT ENCLK net1608
*.CONNECT net1609 EN
XFE_PHC949_net1612 DELC $PINS O=FE_PHN949_net1612 I=net1612
Xlatch QDBHN $PINS Q=net1612 D=net1609 CKB=CLK
Xmain_gate AN2T $PINS O=net1608 I1=FE_PHN949_net1612 I2=CLK
.ENDS

.SUBCKT CHIP_DW01_inc_1_DW01_inc_3 A[8] A[7] A[6] A[5] A[4] A[3] A[2] A[1] A[0]
+ SUM[8] SUM[7] SUM[6] SUM[5] SUM[4] SUM[3] SUM[2] SUM[1] SUM[0]
XU1_1_7 HA1 $PINS S=SUM[7] C=carry[8] A=A[7] B=carry[7]
XU1_1_6 HA1 $PINS S=SUM[6] C=carry[7] A=A[6] B=carry[6]
XU1_1_5 HA1 $PINS S=SUM[5] C=carry[6] A=A[5] B=carry[5]
XU1_1_4 HA1 $PINS S=SUM[4] C=carry[5] A=A[4] B=carry[4]
XU1_1_3 HA1 $PINS S=SUM[3] C=carry[4] A=A[3] B=carry[3]
XU1_1_2 HA1 $PINS S=SUM[2] C=carry[3] A=A[2] B=carry[2]
XU1_1_1 HA1 $PINS S=SUM[1] C=carry[2] A=A[1] B=A[0]
XU1 XOR2HS $PINS O=SUM[8] I1=carry[8] I2=A[8]
.ENDS

.SUBCKT CHIP_DW02_mult_1 A[7] A[6] A[5] A[4] A[3] A[2] A[1] A[0] B[5] B[4] B[3]
+ B[2] B[1] B[0] TC PRODUCT[13] PRODUCT[12] PRODUCT[11] PRODUCT[10] PRODUCT[9]
+ PRODUCT[8] PRODUCT[7] PRODUCT[6] PRODUCT[5] PRODUCT[4] PRODUCT[3] PRODUCT[2]
+ PRODUCT[1] PRODUCT[0]
XS3_2_4 FA1S $PINS S=SUMB[2][4] CO=CARRYB[2][4] A=ab[2][4] B=n6 CI=ab[1][5]
XS3_3_4 XOR3 $PINS O=SUMB[3][4] I1=ab[3][4] I2=CARRYB[2][4] I3=ab[2][5]
XS2_4_3 XOR3 $PINS O=SUMB[4][3] I1=ab[4][3] I2=CARRYB[3][3] I3=SUMB[3][4]
XS2_3_3 FA1S $PINS S=SUMB[3][3] CO=CARRYB[3][3] A=ab[3][3] B=CARRYB[2][3]
+ CI=SUMB[2][4]
XS1_2_0 FA1S $PINS S=PRODUCT[2] CO=CARRYB[2][0] A=ab[2][0] B=n3 CI=SUMB[1][1]
XS2_4_2 FA1S $PINS S=SUMB[4][2] CO=CARRYB[4][2] A=ab[4][2] B=CARRYB[3][2]
+ CI=SUMB[3][3]
XS2_2_3 FA1S $PINS S=SUMB[2][3] CO=CARRYB[2][3] A=ab[2][3] B=n4 CI=SUMB[1][4]
XS2_5_2 XOR3 $PINS O=SUMB[5][2] I1=ab[5][2] I2=CARRYB[4][2] I3=SUMB[4][3]
XS2_6_1 XOR3 $PINS O=SUMB[6][1] I1=ab[6][1] I2=CARRYB[5][1] I3=SUMB[5][2]
XS2_3_2 FA1S $PINS S=SUMB[3][2] CO=CARRYB[3][2] A=ab[3][2] B=CARRYB[2][2]
+ CI=SUMB[2][3]
XS1_4_0 FA1S $PINS S=PRODUCT[4] CO=CARRYB[4][0] A=ab[4][0] B=CARRYB[3][0]
+ CI=SUMB[3][1]
XS1_3_0 FA1S $PINS S=PRODUCT[3] CO=CARRYB[3][0] A=ab[3][0] B=CARRYB[2][0]
+ CI=SUMB[2][1]
XS2_2_1 FA1S $PINS S=SUMB[2][1] CO=CARRYB[2][1] A=ab[2][1] B=n2 CI=SUMB[1][2]
XS2_5_1 FA1S $PINS S=SUMB[5][1] CO=CARRYB[5][1] A=ab[5][1] B=CARRYB[4][1]
+ CI=SUMB[4][2]
XS2_3_1 FA1S $PINS S=SUMB[3][1] CO=CARRYB[3][1] A=ab[3][1] B=CARRYB[2][1]
+ CI=SUMB[2][2]
XS1_6_0 FA1S $PINS S=PRODUCT[6] CO=CARRYB[6][0] A=ab[6][0] B=CARRYB[5][0]
+ CI=SUMB[5][1]
XS1_5_0 FA1S $PINS S=PRODUCT[5] CO=CARRYB[5][0] A=ab[5][0] B=CARRYB[4][0]
+ CI=SUMB[4][1]
XS2_2_2 FA1S $PINS S=SUMB[2][2] CO=CARRYB[2][2] A=ab[2][2] B=n5 CI=SUMB[1][3]
XS2_4_1 FA1S $PINS S=SUMB[4][1] CO=CARRYB[4][1] A=ab[4][1] B=CARRYB[3][1]
+ CI=SUMB[3][2]
XS4_0 XOR3 $PINS O=PRODUCT[7] I1=ab[7][0] I2=CARRYB[6][0] I3=SUMB[6][1]
XU2 AN2 $PINS O=n2 I1=ab[0][2] I2=ab[1][1]
XU3 AN2 $PINS O=n3 I1=ab[0][1] I2=ab[1][0]
XU4 AN2 $PINS O=n4 I1=ab[0][4] I2=ab[1][3]
XU5 AN2 $PINS O=n5 I1=ab[0][3] I2=ab[1][2]
XU6 AN2 $PINS O=n6 I1=ab[0][5] I2=ab[1][4]
XU7 INV1S $PINS O=n9 I=B[1]
XU8 XOR2HS $PINS O=PRODUCT[1] I1=ab[1][0] I2=ab[0][1]
XU9 INV1S $PINS O=n8 I=B[3]
XU10 XOR2HS $PINS O=SUMB[1][3] I1=ab[1][3] I2=ab[0][4]
XU11 INV1S $PINS O=n7 I=B[2]
XU12 XOR2HS $PINS O=SUMB[1][2] I1=ab[1][2] I2=ab[0][3]
XU13 XOR2HS $PINS O=SUMB[1][4] I1=ab[1][4] I2=ab[0][5]
XU14 XOR2HS $PINS O=SUMB[1][1] I1=ab[1][1] I2=ab[0][2]
XU15 INV1S $PINS O=n10 I=B[4]
XU16 INV1S $PINS O=n18 I=A[0]
XU17 INV1S $PINS O=n17 I=A[1]
XU18 INV1S $PINS O=n16 I=A[2]
XU19 INV1S $PINS O=n15 I=A[3]
XU20 INV1S $PINS O=n11 I=A[7]
XU21 INV1S $PINS O=n14 I=A[4]
XU22 INV1S $PINS O=n13 I=A[5]
XU23 INV1S $PINS O=n12 I=A[6]
XU24 NR2 $PINS O=ab[7][0] I1=B[5] I2=n11
XU25 NR2 $PINS O=ab[6][1] I1=n9 I2=n12
XU26 NR2 $PINS O=ab[6][0] I1=B[5] I2=n12
XU27 NR2 $PINS O=ab[5][2] I1=n7 I2=n13
XU28 NR2 $PINS O=ab[5][1] I1=n9 I2=n13
XU29 NR2 $PINS O=ab[5][0] I1=B[5] I2=n13
XU30 NR2 $PINS O=ab[4][3] I1=n8 I2=n14
XU31 NR2 $PINS O=ab[4][2] I1=n7 I2=n14
XU32 NR2 $PINS O=ab[4][1] I1=n9 I2=n14
XU33 NR2 $PINS O=ab[4][0] I1=B[5] I2=n14
XU34 NR2 $PINS O=ab[3][4] I1=n10 I2=n15
XU35 NR2 $PINS O=ab[3][3] I1=n8 I2=n15
XU36 NR2 $PINS O=ab[3][2] I1=n7 I2=n15
XU37 NR2 $PINS O=ab[3][1] I1=n9 I2=n15
XU38 NR2 $PINS O=ab[3][0] I1=B[5] I2=n15
XU39 NR2 $PINS O=ab[2][5] I1=B[0] I2=n16
XU40 NR2 $PINS O=ab[2][4] I1=n10 I2=n16
XU41 NR2 $PINS O=ab[2][3] I1=n8 I2=n16
XU42 NR2 $PINS O=ab[2][2] I1=n7 I2=n16
XU43 NR2 $PINS O=ab[2][1] I1=n9 I2=n16
XU44 NR2 $PINS O=ab[2][0] I1=B[5] I2=n16
XU45 NR2 $PINS O=ab[1][5] I1=B[0] I2=n17
XU46 NR2 $PINS O=ab[1][4] I1=n10 I2=n17
XU47 NR2 $PINS O=ab[1][3] I1=n8 I2=n17
XU48 NR2 $PINS O=ab[1][2] I1=n7 I2=n17
XU49 NR2 $PINS O=ab[1][1] I1=n9 I2=n17
XU50 NR2 $PINS O=ab[1][0] I1=B[5] I2=n17
XU51 NR2 $PINS O=ab[0][5] I1=B[0] I2=n18
XU52 NR2 $PINS O=ab[0][4] I1=n10 I2=n18
XU53 NR2 $PINS O=ab[0][3] I1=n8 I2=n18
XU54 NR2 $PINS O=ab[0][2] I1=n7 I2=n18
XU55 NR2 $PINS O=ab[0][1] I1=n9 I2=n18
XU56 NR2 $PINS O=PRODUCT[0] I1=B[5] I2=n18
.ENDS

.SUBCKT CHIP_DW02_mult_0 A[4] A[3] A[2] A[1] A[0] B[7] B[6] B[5] B[4] B[3] B[2]
+ B[1] B[0] TC PRODUCT[12] PRODUCT[11] PRODUCT[10] PRODUCT[9] PRODUCT[8]
+ PRODUCT[7] PRODUCT[6] PRODUCT[5] PRODUCT[4] PRODUCT[3] PRODUCT[2] PRODUCT[1]
+ PRODUCT[0] n114 FE_OFN37_n114
*.CONNECT PRODUCT[1] ab[1][0]
XS2_3_4 XOR3 $PINS O=SUMB[3][4] I1=ab[3][4] I2=n7 I3=SUMB[2][5]
XS1_3_0 FA1S $PINS S=PRODUCT[3] CO=CARRYB[3][0] A=ab[3][0] B=n6 CI=SUMB[2][1]
XS2_3_3 FA1S $PINS S=SUMB[3][3] CO=CARRYB[3][3] A=ab[3][3] B=n3 CI=SUMB[2][4]
XS4_2 FA1S $PINS S=SUMB[4][2] CO=CARRYB[4][2] A=ab[4][2] B=CARRYB[3][2]
+ CI=SUMB[3][3]
XS2_3_2 FA1S $PINS S=SUMB[3][2] CO=CARRYB[3][2] A=ab[3][2] B=n2 CI=SUMB[2][3]
XS4_1 FA1S $PINS S=SUMB[4][1] CO=CARRYB[4][1] A=ab[4][1] B=CARRYB[3][1]
+ CI=SUMB[3][2]
XS2_3_1 FA1S $PINS S=SUMB[3][1] CO=CARRYB[3][1] A=ab[3][1] B=n4 CI=SUMB[2][2]
XS4_0 FA1S $PINS S=PRODUCT[4] CO=CARRYB[4][0] A=ab[4][0] B=CARRYB[3][0]
+ CI=SUMB[3][1]
XS4_3 XOR3 $PINS O=SUMB[4][3] I1=ab[4][3] I2=CARRYB[3][3] I3=SUMB[3][4]
XU2 XOR3 $PINS O=PRODUCT[7] I1=n11 I2=n5 I3=A1[5]
XU3 AN2 $PINS O=n2 I1=ab[1][3] I2=ab[2][2]
XU4 AN2 $PINS O=n3 I1=ab[1][4] I2=ab[2][3]
XU5 AN2 $PINS O=n4 I1=ab[1][2] I2=ab[2][1]
XU6 AN2 $PINS O=n5 I1=CARRYB[4][1] I2=SUMB[4][2]
XU7 AN2 $PINS O=n6 I1=ab[1][1] I2=ab[2][0]
XU8 AN2 $PINS O=n7 I1=ab[1][5] I2=ab[2][4]
XU10 XOR2HS $PINS O=PRODUCT[6] I1=A1[4] I2=n9
XU11 AN2 $PINS O=n9 I1=SUMB[4][1] I2=CARRYB[4][0]
XU12 XOR2HS $PINS O=A1[4] I1=CARRYB[4][1] I2=SUMB[4][2]
XU13 XOR2HS $PINS O=A1[5] I1=CARRYB[4][2] I2=SUMB[4][3]
XU14 XOR2HS $PINS O=PRODUCT[5] I1=CARRYB[4][0] I2=SUMB[4][1]
XU15 XOR2HS $PINS O=PRODUCT[2] I1=ab[2][0] I2=ab[1][1]
XU16 XOR2HS $PINS O=SUMB[2][2] I1=ab[2][2] I2=ab[1][3]
XU17 XOR2HS $PINS O=SUMB[2][3] I1=ab[2][3] I2=ab[1][4]
XU18 XOR2HS $PINS O=SUMB[2][4] I1=ab[2][4] I2=ab[1][5]
XU19 XOR2HS $PINS O=SUMB[2][1] I1=ab[2][1] I2=ab[1][2]
XU20 XOR2HS $PINS O=SUMB[2][5] I1=ab[2][5] I2=ab[1][6]
XU21 AN2B1S $PINS O=ab[1][6] I1=B[6] B1=FE_OFN37_n114
XU23 INV1S $PINS O=n16 I=B[2]
XU24 INV1S $PINS O=n15 I=B[3]
XU25 INV1S $PINS O=n17 I=B[1]
XU27 INV1S $PINS O=n14 I=B[4]
XU28 INV1S $PINS O=n18 I=B[0]
XU29 INV1S $PINS O=n13 I=B[5]
XU30 INV1S $PINS O=n20 I=A[4]
XU31 AN2 $PINS O=n11 I1=n9 I2=A1[4]
XU32 NR2 $PINS O=ab[4][3] I1=n20 I2=n15
XU33 NR2 $PINS O=ab[4][2] I1=n20 I2=n16
XU34 NR2 $PINS O=ab[4][1] I1=n20 I2=n17
XU35 NR2 $PINS O=ab[4][0] I1=n20 I2=n18
XU36 NR2 $PINS O=ab[3][4] I1=n14 I2=A[3]
XU37 NR2 $PINS O=ab[3][3] I1=n15 I2=A[3]
XU38 NR2 $PINS O=ab[3][2] I1=n16 I2=A[3]
XU39 NR2 $PINS O=ab[3][1] I1=n17 I2=A[3]
XU40 NR2 $PINS O=ab[3][0] I1=n18 I2=A[3]
XU41 NR2 $PINS O=ab[2][5] I1=n13 I2=A[2]
XU42 NR2 $PINS O=ab[2][4] I1=n14 I2=A[2]
XU43 NR2 $PINS O=ab[2][3] I1=n15 I2=A[2]
XU44 NR2 $PINS O=ab[2][2] I1=n16 I2=A[2]
XU45 NR2 $PINS O=ab[2][1] I1=n17 I2=A[2]
XU46 NR2 $PINS O=ab[2][0] I1=n18 I2=A[2]
XU47 NR2 $PINS O=ab[1][5] I1=n13 I2=n114
XU48 NR2 $PINS O=ab[1][4] I1=n14 I2=n114
XU49 NR2 $PINS O=ab[1][3] I1=n15 I2=n114
XU50 NR2 $PINS O=ab[1][2] I1=n16 I2=n114
XU51 NR2 $PINS O=ab[1][1] I1=n17 I2=n114
XU52 NR2 $PINS O=ab[1][0] I1=n18 I2=n114
.ENDS

.SUBCKT CHIP_core clk rst_n i_valid i_ready o_ready o_valid i_data[15]
+ i_data[14] i_data[13] i_data[12] i_data[11] i_data[10] i_data[9] i_data[8]
+ i_data[7] i_data[6] i_data[5] i_data[4] i_data[3] i_data[2] i_data[1]
+ i_data[0] o_data[10] o_data[9] o_data[8] o_data[7] o_data[6] o_data[5]
+ o_data[4] o_data[3] o_data[2] o_data[1] o_data[0]
XFE_PHC1474_pe_done_d2 BUF2CK $PINS O=FE_PHN1474_pe_done_d2
+ I=FE_PHN1323_pe_done_d2
XFE_PHC1472_c_buf_r_3_14 BUF1CK $PINS O=FE_PHN1472_c_buf_r_3_14
+ I=c_buf_r[3][14]
XFE_PHC1422_n112 DELB $PINS O=FE_PHN1422_n112 I=n112
XFE_PHC1414_o_counter_w_5 DELB $PINS O=FE_PHN1414_o_counter_w_5
+ I=o_counter_w[5]
XFE_PHC1413_N286 DELB $PINS O=FE_PHN1413_N286 I=N286
XFE_PHC1412_o_counter_w_4 DELC $PINS O=FE_PHN1412_o_counter_w_4
+ I=o_counter_w[4]
XFE_PHC1411_o_counter_w_2 DELC $PINS O=o_counter_w[2]
+ I=FE_PHN1411_o_counter_w_2
XFE_PHC1410_n110 DELC $PINS O=n110 I=FE_PHN1410_n110
XFE_PHC1409_o_counter_w_3 DELC $PINS O=FE_PHN1409_o_counter_w_3
+ I=o_counter_w[3]
XFE_PHC1406_o_state_r DELB $PINS O=FE_PHN1406_o_state_r I=o_state_r
XFE_PHC1405_c_in_r_1_4 BUF1S $PINS O=c_in_r_1[4] I=FE_PHN1405_c_in_r_1_4
XFE_PHC1404_c_in_r_1_5 BUF1S $PINS O=c_in_r_1[5] I=FE_PHN1404_c_in_r_1_5
XFE_PHC1403_c_in_i_0_6 DELB $PINS O=FE_PHN1403_c_in_i_0_6 I=c_in_i_0[6]
XFE_PHC1402_c_in_i_0_4 DELB $PINS O=c_in_i_0[4] I=FE_PHN1402_c_in_i_0_4
XFE_PHC1401_c_in_i_0_8 DELB $PINS O=FE_PHN1401_c_in_i_0_8 I=c_in_i_0[8]
XFE_PHC1400_c_in_i_0_9 DELB $PINS O=FE_PHN1400_c_in_i_0_9 I=c_in_i_0[9]
XFE_PHC1399_c_in_i_0_7 DELB $PINS O=c_in_i_0[7] I=FE_PHN1399_c_in_i_0_7
XFE_PHC1398_c_in_r_1_0 BUF1S $PINS O=FE_PHN1398_c_in_r_1_0 I=c_in_r_1[0]
XFE_PHC1397_c_in_i_0_5 DELB $PINS O=FE_PHN1397_c_in_i_0_5 I=c_in_i_0[5]
XFE_PHC1396_c_in_i_1_11 BUF1S $PINS O=FE_PHN1396_c_in_i_1_11 I=c_in_i_1[11]
XFE_PHC1395_c_in_r_0_10 DELB $PINS O=FE_PHN1395_c_in_r_0_10 I=c_in_r_0[10]
XFE_PHC1394_c_in_r_1_6 DELB $PINS O=FE_PHN1394_c_in_r_1_6 I=c_in_r_1[6]
XFE_PHC1393_c_in_r_0_7 DELB $PINS O=FE_PHN1393_c_in_r_0_7 I=c_in_r_0[7]
XFE_PHC1392_c_in_i_0_10 DELB $PINS O=FE_PHN1392_c_in_i_0_10 I=c_in_i_0[10]
XFE_PHC1391_c_in_i_1_6 DELB $PINS O=c_in_i_1[6] I=FE_PHN1391_c_in_i_1_6
XFE_PHC1390_c_in_i_0_12 DELB $PINS O=c_in_i_0[12] I=FE_PHN1390_c_in_i_0_12
XFE_PHC1389_c_in_r_1_7 DELB $PINS O=c_in_r_1[7] I=FE_PHN1389_c_in_r_1_7
XFE_PHC1388_c_in_r_1_8 DELB $PINS O=FE_PHN1388_c_in_r_1_8 I=c_in_r_1[8]
XFE_PHC1387_c_in_r_1_10 DELB $PINS O=c_in_r_1[10] I=FE_PHN1387_c_in_r_1_10
XFE_PHC1386_c_in_i_1_9 DELB $PINS O=FE_PHN1386_c_in_i_1_9 I=c_in_i_1[9]
XFE_PHC1385_c_in_r_0_0 DELB $PINS O=FE_PHN1385_c_in_r_0_0 I=c_in_r_0[0]
XFE_PHC1384_c_in_r_0_12 DELA $PINS O=FE_PHN1384_c_in_r_0_12 I=c_in_r_0[12]
XFE_PHC1383_c_in_r_0_5 DELB $PINS O=FE_PHN1383_c_in_r_0_5 I=c_in_r_0[5]
XFE_PHC1382_c_in_r_0_11 DELB $PINS O=c_in_r_0[11] I=FE_PHN1382_c_in_r_0_11
XFE_PHC1381_c_in_r_0_9 DELB $PINS O=FE_PHN1381_c_in_r_0_9 I=c_in_r_0[9]
XFE_PHC1380_c_in_i_1_7 DELB $PINS O=FE_PHN1380_c_in_i_1_7 I=c_in_i_1[7]
XFE_PHC1379_c_in_r_1_9 DELB $PINS O=c_in_r_1[9] I=FE_PHN1379_c_in_r_1_9
XFE_PHC1378_c_in_r_1_11 DELB $PINS O=c_in_r_1[11] I=FE_PHN1378_c_in_r_1_11
XFE_PHC1377_c_in_i_1_12 DELB $PINS O=c_in_i_1[12] I=FE_PHN1377_c_in_i_1_12
XFE_PHC1376_c_in_r_0_8 DELB $PINS O=FE_PHN1376_c_in_r_0_8 I=c_in_r_0[8]
XFE_PHC1375_c_in_i_1_8 DELB $PINS O=c_in_i_1[8] I=FE_PHN1375_c_in_i_1_8
XFE_PHC1374_c_in_r_0_13 DELA $PINS O=FE_PHN1374_c_in_r_0_13 I=c_in_r_0[13]
XFE_PHC1373_c_in_r_0_14 BUF1S $PINS O=FE_PHN1373_c_in_r_0_14 I=c_in_r_0[14]
XFE_PHC1372_c_in_r_1_12 DELB $PINS O=c_in_r_1[12] I=FE_PHN1372_c_in_r_1_12
XFE_PHC1371_c_in_i_1_13 DELB $PINS O=FE_PHN1371_c_in_i_1_13 I=c_in_i_1[13]
XFE_PHC1370_c_in_r_0_15 DELA $PINS O=FE_PHN1370_c_in_r_0_15 I=c_in_r_0[15]
XFE_PHC1369_c_in_r_1_13 DELB $PINS O=c_in_r_1[13] I=FE_PHN1369_c_in_r_1_13
XFE_PHC1368_c_in_i_1_14 DELB $PINS O=FE_PHN1368_c_in_i_1_14 I=c_in_i_1[14]
XFE_PHC1367_c_in_i_1_15 DELA $PINS O=FE_PHN1367_c_in_i_1_15 I=c_in_i_1[15]
XFE_PHC1355_counter_w_2 BUF4CK $PINS O=FE_PHN1355_counter_w_2 I=counter_w[2]
XFE_PHC1348_N106 DELA $PINS O=FE_PHN1348_N106 I=N106
XFE_PHC1345_c_in_i_1_16 BUF1S $PINS O=FE_PHN1345_c_in_i_1_16 I=c_in_i_1[16]
XFE_PHC1323_pe_done_d2 BUF1S $PINS O=FE_PHN1323_pe_done_d2 I=pe_done_d2
XFE_PHC1307_c_in_i_0_16 BUF1S $PINS O=FE_PHN1307_c_in_i_0_16 I=c_in_i_0[16]
XFE_PHC1303_n111 DELB $PINS O=n111 I=FE_PHN1303_n111
XFE_PHC1289_n105 DELB $PINS O=FE_PHN1289_n105 I=n105
XFE_PHC1279_c_in_r_1_16 BUF1S $PINS O=c_in_r_1[16] I=FE_PHN1279_c_in_r_1_16
XFE_PHC1277_c_in_r_0_16 BUF1S $PINS O=FE_PHN1277_c_in_r_0_16 I=c_in_r_0[16]
XFE_PHC1276_n107 DELB $PINS O=FE_PHN1276_n107 I=n107
XFE_PHC1273_n106 DELB $PINS O=FE_PHN1273_n106 I=n106
XFE_PHC1271_N40 DELB $PINS O=FE_PHN1271_N40 I=N40
XFE_PHC1266_n61 DELB $PINS O=FE_PHN1266_n61 I=n61
XFE_PHC1218_counter_w_8 DELC $PINS O=FE_PHN1218_counter_w_8 I=counter_w[8]
XFE_PHC1187_key_w_1 DELB $PINS O=key_w[1] I=FE_PHN1187_key_w_1
XFE_PHC1181_key_w_4 DELC $PINS O=FE_PHN1181_key_w_4 I=key_w[4]
XFE_PHC1178_n109 DELC $PINS O=FE_PHN1178_n109 I=n109
XFE_PHC1175_state_r_2 BUF1CK $PINS O=FE_PHN1175_state_r_2 I=state_r[2]
XFE_PHC1174_current_n_3 DELB $PINS O=FE_PHN1174_current_n_3 I=current_n[3]
XFE_PHC1173_current_n_1 DELB $PINS O=FE_PHN1173_current_n_1 I=current_n[1]
XFE_PHC1172_current_g_0 DELC $PINS O=FE_PHN1172_current_g_0 I=current_g[0]
XFE_PHC1171_current_g_2 DELC $PINS O=current_g[2] I=FE_PHN1171_current_g_2
XFE_PHC1170_current_g_1 DELC $PINS O=FE_PHN1170_current_g_1 I=current_g[1]
XFE_PHC1168_current_n_4 DELB $PINS O=FE_PHN1168_current_n_4 I=current_n[4]
XFE_PHC1166_g_cnt_d3_1 DELC $PINS O=g_cnt_d3[1] I=FE_PHN1166_g_cnt_d3_1
XFE_PHC1165_g_cnt_d3_2 DELC $PINS O=g_cnt_d3[2] I=FE_PHN1165_g_cnt_d3_2
XFE_PHC1164_g_cnt_d3_0 DELC $PINS O=g_cnt_d3[0] I=FE_PHN1164_g_cnt_d3_0
XFE_PHC1143_o_counter_r_1 DELB $PINS O=o_counter_r[1]
+ I=FE_PHN1143_o_counter_r_1
XFE_PHC1136_c_start DELB $PINS O=FE_PHN1136_c_start I=c_start
XFE_PHC1129_pe_r1_9 DELC $PINS O=FE_PHN1129_pe_r1_9 I=pe_r1[9]
XFE_PHC1128_pe_r1_10 DELC $PINS O=FE_PHN1128_pe_r1_10 I=pe_r1[10]
XFE_PHC1127_pe_r1_0 DELC $PINS O=FE_PHN1127_pe_r1_0 I=pe_r1[0]
XFE_PHC1126_pe_r1_1 DELC $PINS O=FE_PHN1126_pe_r1_1 I=pe_r1[1]
XFE_PHC1124_pe_r1_4 DELC $PINS O=FE_PHN1124_pe_r1_4 I=pe_r1[4]
XFE_PHC1123_pe_r1_3 DELC $PINS O=FE_PHN1123_pe_r1_3 I=pe_r1[3]
XFE_PHC1122_pe_r1_6 DELC $PINS O=FE_PHN1122_pe_r1_6 I=pe_r1[6]
XFE_PHC1120_pe_r1_2 DELC $PINS O=FE_PHN1120_pe_r1_2 I=pe_r1[2]
XFE_PHC1119_pe_r1_8 DELC $PINS O=FE_PHN1119_pe_r1_8 I=pe_r1[8]
XFE_PHC1117_pe_i1_2 DELC $PINS O=FE_PHN1117_pe_i1_2 I=pe_i1[2]
XFE_PHC1116_pe_i1_4 DELC $PINS O=FE_PHN1116_pe_i1_4 I=pe_i1[4]
XFE_PHC1113_pe_i1_6 DELC $PINS O=FE_PHN1113_pe_i1_6 I=pe_i1[6]
XFE_PHC1112_pe_i1_5 DELC $PINS O=FE_PHN1112_pe_i1_5 I=pe_i1[5]
XFE_PHC1102_c_buf_i_0_4 DELB $PINS O=c_buf_i[0][4] I=FE_PHN1102_c_buf_i_0_4
XFE_PHC1099_c_buf_i_0_6 DELB $PINS O=FE_PHN1099_c_buf_i_0_6 I=c_buf_i[0][6]
XFE_PHC1097_c_buf_i_0_5 DELB $PINS O=FE_PHN1097_c_buf_i_0_5 I=c_buf_i[0][5]
XFE_PHC1095_c_buf_i_0_10 DELA $PINS O=FE_PHN1095_c_buf_i_0_10 I=c_buf_i[0][10]
XFE_PHC1093_c_buf_i_0_8 DELB $PINS O=FE_PHN1093_c_buf_i_0_8 I=c_buf_i[0][8]
XFE_PHC1090_c_buf_i_3_10 DELB $PINS O=c_buf_i[3][10] I=FE_PHN1090_c_buf_i_3_10
XFE_PHC1089_n91 DELA $PINS O=FE_PHN1089_n91 I=n91
XFE_PHC1088_c_buf_i_1_9 DELB $PINS O=c_buf_i[1][9] I=FE_PHN1088_c_buf_i_1_9
XFE_PHC1087_c_buf_i_0_12 DELB $PINS O=FE_PHN1087_c_buf_i_0_12 I=c_buf_i[0][12]
XFE_PHC1085_c_buf_i_1_10 DELB $PINS O=c_buf_i[1][10] I=FE_PHN1085_c_buf_i_1_10
XFE_PHC1083_c_buf_i_1_11 DELB $PINS O=c_buf_i[1][11] I=FE_PHN1083_c_buf_i_1_11
XFE_PHC1082_c_buf_i_1_12 DELB $PINS O=FE_PHN1082_c_buf_i_1_12 I=c_buf_i[1][12]
XFE_PHC1075_c_buf_i_1_15 DELB $PINS O=c_buf_i[1][15] I=FE_PHN1075_c_buf_i_1_15
XFE_PHC1062_c_buf_i_1_16 BUF1S $PINS O=FE_PHN1062_c_buf_i_1_16 I=c_buf_i[1][16]
XFE_PHC1040_cordic_valid_out_0 DELB $PINS O=FE_PHN1040_cordic_valid_out_0
+ I=cordic_valid_out[0]
XFE_PHC1036_c_buf_i_0_16 BUF1S $PINS O=FE_PHN1036_c_buf_i_0_16 I=c_buf_i[0][16]
XFE_PHC1021_key_r_0 DELC $PINS O=FE_PHN1021_key_r_0 I=key_r[0]
XFE_PHC1020_key_r_5 DELC $PINS O=FE_PHN1020_key_r_5 I=key_r[5]
XFE_PHC1019_key_r_2 DELC $PINS O=FE_PHN1019_key_r_2 I=key_r[2]
XFE_PHC1018_key_r_3 DELC $PINS O=FE_PHN1018_key_r_3 I=key_r[3]
XFE_PHC1017_key_r_6 DELC $PINS O=FE_PHN1017_key_r_6 I=key_r[6]
XFE_PHC1013_pe_done_d1 DELC $PINS O=FE_PHN1013_pe_done_d1 I=pe_done_d1
XFE_PHC1011_key_r_7 DELC $PINS O=FE_PHN1011_key_r_7 I=key_r[7]
XFE_PHC915_pe_r0_9 DELC $PINS O=FE_PHN915_pe_r0_9 I=pe_r0[9]
XFE_PHC872_pe_r0_8 DELC $PINS O=FE_PHN872_pe_r0_8 I=pe_r0[8]
XFE_PHC861_pe_r0_10 DELC $PINS O=FE_PHN861_pe_r0_10 I=pe_r0[10]
XFE_PHC856_pe_r0_7 DELC $PINS O=FE_PHN856_pe_r0_7 I=pe_r0[7]
XFE_PHC855_pe_r0_5 DELC $PINS O=FE_PHN855_pe_r0_5 I=pe_r0[5]
XFE_PHC854_pe_r0_0 DELC $PINS O=FE_PHN854_pe_r0_0 I=pe_r0[0]
XFE_PHC853_pe_r0_4 DELC $PINS O=FE_PHN853_pe_r0_4 I=pe_r0[4]
XFE_PHC852_pe_r0_2 DELC $PINS O=FE_PHN852_pe_r0_2 I=pe_r0[2]
XFE_PHC851_pe_r0_6 DELC $PINS O=FE_PHN851_pe_r0_6 I=pe_r0[6]
XFE_PHC850_pe_r0_3 DELC $PINS O=FE_PHN850_pe_r0_3 I=pe_r0[3]
XFE_PHC849_pe_r0_1 DELC $PINS O=FE_PHN849_pe_r0_1 I=pe_r0[1]
XFE_PHC847_pe_i0_2 DELC $PINS O=FE_PHN847_pe_i0_2 I=pe_i0[2]
XFE_PHC846_pe_i0_4 DELC $PINS O=FE_PHN846_pe_i0_4 I=pe_i0[4]
XFE_PHC845_pe_r1_11 DELC $PINS O=FE_PHN845_pe_r1_11 I=pe_r1[11]
XFE_PHC844_pe_r0_14 DELC $PINS O=FE_PHN844_pe_r0_14 I=pe_r0[14]
XFE_PHC843_pe_r1_12 DELC $PINS O=FE_PHN843_pe_r1_12 I=pe_r1[12]
XFE_PHC842_pe_i0_6 DELC $PINS O=FE_PHN842_pe_i0_6 I=pe_i0[6]
XFE_PHC841_pe_r0_13 DELC $PINS O=FE_PHN841_pe_r0_13 I=pe_r0[13]
XFE_PHC840_pe_i1_8 DELC $PINS O=FE_PHN840_pe_i1_8 I=pe_i1[8]
XFE_PHC839_pe_r0_16 DELC $PINS O=FE_PHN839_pe_r0_16 I=pe_r0[16]
XFE_PHC838_pe_r0_11 DELC $PINS O=FE_PHN838_pe_r0_11 I=pe_r0[11]
XFE_PHC837_pe_i0_3 DELC $PINS O=FE_PHN837_pe_i0_3 I=pe_i0[3]
XFE_PHC836_pe_r1_13 DELC $PINS O=FE_PHN836_pe_r1_13 I=pe_r1[13]
XFE_PHC835_pe_i0_0 DELC $PINS O=FE_PHN835_pe_i0_0 I=pe_i0[0]
XFE_PHC834_pe_r1_16 DELC $PINS O=FE_PHN834_pe_r1_16 I=pe_r1[16]
XFE_PHC833_pe_r1_14 DELC $PINS O=FE_PHN833_pe_r1_14 I=pe_r1[14]
XFE_PHC832_pe_i0_5 DELC $PINS O=FE_PHN832_pe_i0_5 I=pe_i0[5]
XFE_PHC831_pe_r1_15 DELC $PINS O=FE_PHN831_pe_r1_15 I=pe_r1[15]
XFE_PHC830_pe_r0_12 DELC $PINS O=FE_PHN830_pe_r0_12 I=pe_r0[12]
XFE_PHC829_pe_r0_15 DELC $PINS O=FE_PHN829_pe_r0_15 I=pe_r0[15]
XFE_PHC828_pe_i0_10 DELC $PINS O=FE_PHN828_pe_i0_10 I=pe_i0[10]
XFE_PHC826_pe_i1_0 DELC $PINS O=FE_PHN826_pe_i1_0 I=pe_i1[0]
XFE_PHC825_pe_i0_8 DELC $PINS O=FE_PHN825_pe_i0_8 I=pe_i0[8]
XFE_PHC823_pe_i1_9 DELC $PINS O=FE_PHN823_pe_i1_9 I=pe_i1[9]
XFE_PHC822_pe_i1_10 DELC $PINS O=FE_PHN822_pe_i1_10 I=pe_i1[10]
XFE_PHC821_pe_i0_7 DELC $PINS O=FE_PHN821_pe_i0_7 I=pe_i0[7]
XFE_PHC820_pe_i0_9 DELC $PINS O=FE_PHN820_pe_i0_9 I=pe_i0[9]
XFE_PHC819_pe_i0_1 DELC $PINS O=FE_PHN819_pe_i0_1 I=pe_i0[1]
XFE_PHC818_pe_i0_13 DELC $PINS O=FE_PHN818_pe_i0_13 I=pe_i0[13]
XFE_PHC817_pe_i0_12 DELC $PINS O=FE_PHN817_pe_i0_12 I=pe_i0[12]
XFE_PHC816_pe_i0_16 DELC $PINS O=FE_PHN816_pe_i0_16 I=pe_i0[16]
XFE_PHC815_pe_i0_11 DELC $PINS O=FE_PHN815_pe_i0_11 I=pe_i0[11]
XFE_PHC814_pe_i0_15 DELC $PINS O=FE_PHN814_pe_i0_15 I=pe_i0[15]
XFE_PHC813_pe_i0_14 DELC $PINS O=FE_PHN813_pe_i0_14 I=pe_i0[14]
XFE_PHC812_pe_r3_14 DELC $PINS O=FE_PHN812_pe_r3_14 I=pe_r3[14]
XFE_PHC811_pe_r3_11 DELC $PINS O=FE_PHN811_pe_r3_11 I=pe_r3[11]
XFE_PHC810_pe_r2_12 DELC $PINS O=FE_PHN810_pe_r2_12 I=pe_r2[12]
XFE_PHC807_pe_r3_16 DELC $PINS O=FE_PHN807_pe_r3_16 I=pe_r3[16]
XFE_PHC805_pe_i1_13 DELC $PINS O=FE_PHN805_pe_i1_13 I=pe_i1[13]
XFE_PHC801_pe_r2_16 DELC $PINS O=FE_PHN801_pe_r2_16 I=pe_r2[16]
XFE_PHC800_pe_r2_13 DELC $PINS O=FE_PHN800_pe_r2_13 I=pe_r2[13]
XFE_PHC798_pe_i2_13 DELC $PINS O=FE_PHN798_pe_i2_13 I=pe_i2[13]
XFE_PHC797_pe_r3_15 DELC $PINS O=FE_PHN797_pe_r3_15 I=pe_r3[15]
XFE_PHC796_pe_i2_16 DELC $PINS O=FE_PHN796_pe_i2_16 I=pe_i2[16]
XFE_PHC795_pe_i2_12 DELC $PINS O=FE_PHN795_pe_i2_12 I=pe_i2[12]
XFE_PHC794_pe_i1_14 DELC $PINS O=FE_PHN794_pe_i1_14 I=pe_i1[14]
XFE_PHC792_pe_i2_11 DELC $PINS O=FE_PHN792_pe_i2_11 I=pe_i2[11]
XFE_PHC789_pe_r2_15 DELC $PINS O=FE_PHN789_pe_r2_15 I=pe_r2[15]
XFE_PHC788_pe_r2_14 DELC $PINS O=FE_PHN788_pe_r2_14 I=pe_r2[14]
XFE_PHC786_pe_i3_14 DELC $PINS O=FE_PHN786_pe_i3_14 I=pe_i3[14]
XFE_PHC785_pe_r2_11 DELC $PINS O=FE_PHN785_pe_r2_11 I=pe_r2[11]
XFE_PHC783_pe_i3_15 DELC $PINS O=FE_PHN783_pe_i3_15 I=pe_i3[15]
XFE_PHC782_g_cnt_d1_0 DELC $PINS O=FE_PHN782_g_cnt_d1_0 I=g_cnt_d1[0]
XFE_PHC781_g_cnt_d2_2 DELC $PINS O=g_cnt_d2[2] I=FE_PHN781_g_cnt_d2_2
XFE_PHC780_g_cnt_d2_0 DELC $PINS O=g_cnt_d2[0] I=FE_PHN780_g_cnt_d2_0
XFE_PHC779_g_cnt_d2_1 DELC $PINS O=g_cnt_d2[1] I=FE_PHN779_g_cnt_d2_1
XFE_PHC778_g_cnt_d1_2 DELC $PINS O=FE_PHN778_g_cnt_d1_2 I=g_cnt_d1[2]
XFE_PHC777_g_cnt_d1_1 DELC $PINS O=FE_PHN777_g_cnt_d1_1 I=g_cnt_d1[1]
XFE_PHC774_c_state_0 DELC $PINS O=FE_PHN774_c_state_0 I=c_state[0]
XFE_PHC772_pe_r3_2 DELC $PINS O=FE_PHN772_pe_r3_2 I=pe_r3[2]
XFE_PHC771_pe_r3_4 DELC $PINS O=FE_PHN771_pe_r3_4 I=pe_r3[4]
XFE_PHC770_pe_r3_0 DELC $PINS O=FE_PHN770_pe_r3_0 I=pe_r3[0]
XFE_PHC769_pe_r3_3 DELC $PINS O=FE_PHN769_pe_r3_3 I=pe_r3[3]
XFE_PHC768_pe_r3_6 DELC $PINS O=FE_PHN768_pe_r3_6 I=pe_r3[6]
XFE_PHC766_pe_r3_5 DELC $PINS O=FE_PHN766_pe_r3_5 I=pe_r3[5]
XFE_PHC764_pe_r3_7 DELC $PINS O=FE_PHN764_pe_r3_7 I=pe_r3[7]
XFE_PHC763_pe_r3_8 DELC $PINS O=FE_PHN763_pe_r3_8 I=pe_r3[8]
XFE_PHC762_pe_i2_0 DELC $PINS O=FE_PHN762_pe_i2_0 I=pe_i2[0]
XFE_PHC761_pe_i3_2 DELC $PINS O=FE_PHN761_pe_i3_2 I=pe_i3[2]
XFE_PHC760_pe_i2_10 DELC $PINS O=FE_PHN760_pe_i2_10 I=pe_i2[10]
XFE_PHC759_pe_i2_1 DELC $PINS O=FE_PHN759_pe_i2_1 I=pe_i2[1]
XFE_PHC756_pe_i3_3 DELC $PINS O=FE_PHN756_pe_i3_3 I=pe_i3[3]
XFE_PHC754_pe_i2_9 DELC $PINS O=FE_PHN754_pe_i2_9 I=pe_i2[9]
XFE_PHC750_pe_i2_7 DELC $PINS O=FE_PHN750_pe_i2_7 I=pe_i2[7]
XFE_PHC743_pe_r2_8 DELC $PINS O=FE_PHN743_pe_r2_8 I=pe_r2[8]
XFE_PHC741_pe_r2_0 DELC $PINS O=FE_PHN741_pe_r2_0 I=pe_r2[0]
XFE_PHC736_pe_r2_5 DELC $PINS O=FE_PHN736_pe_r2_5 I=pe_r2[5]
XFE_PHC733_pe_i3_10 DELC $PINS O=FE_PHN733_pe_i3_10 I=pe_i3[10]
XFE_RC_290_0 AO12T $PINS O=mac_in_real[7] A1=FE_DBTN13_n83 B1=FE_OFN347_n164
+ B2=rf_d_rdata_1[7]
XFE_RC_187_0 INV2 $PINS O=FE_RN_113_0 I=rf_d_rdata_1[4]
XFE_RC_186_0 INV4CK $PINS O=FE_RN_114_0 I=n164
XFE_RC_185_0 MXL2HP $PINS OB=mac_in_real[4] S=FE_RN_114_0 A=FE_RN_113_0 B=n229
XCTS_ccl_a_INV_CLK_G0_L9_8 INV12CK $PINS O=CTS_193 I=CTS_194
XCTS_ccl_a_INV_CLK_G0_L9_7 INV12CK $PINS O=CTS_192 I=CTS_194
XCTS_ccl_a_INV_CLK_G0_L9_6 INV12CK $PINS O=CTS_191 I=CTS_194
XCTS_ccl_a_INV_CLK_G0_L8_124 INV12CK $PINS O=CTS_194 I=CTS_195
XCTS_ccl_a_INV_CLK_G0_L7_124 INV12CK $PINS O=CTS_195 I=CTS_196
XCTS_cfo_INV_CLK_G0_L6_5 INV6CK $PINS O=CTS_196 I=CTS_197
XCTS_cfo_INV_CLK_G0_L5_12 INV6CK $PINS O=CTS_197 I=CTS_198
XCTS_ccl_a_INV_CLK_G0_L5_11 INV12CK $PINS O=CTS_190 I=CTS_198
XCTS_ccl_a_INV_CLK_G0_L9_5 INV12CK $PINS O=CTS_185 I=CTS_186
XCTS_cdb_INV_CLK_G0_L8_106 INV4CK $PINS O=CTS_186 I=CTS_187
XCTS_cdb_INV_CLK_G0_L7_106 INV3CK $PINS O=CTS_187 I=CTS_188
XCTS_ccl_a_INV_CLK_G0_L7_105 INV1CK $PINS O=CTS_184 I=CTS_188
XCTS_csk_INV_CLK_G0_L9_4 INV1CK $PINS O=CTS_181 I=CTS_182
XCTS_csk_INV_CLK_G0_L8_105 INV4CK $PINS O=CTS_182 I=CTS_183
XCTS_csk_INV_CLK_G0_L9_3 INV1CK $PINS O=CTS_179 I=CTS_180
XCTS_csk_INV_CLK_G0_L8_104 INV8CK $PINS O=CTS_180 I=CTS_183
XCTS_ccl_a_INV_CLK_G0_L7_104 INV12CK $PINS O=CTS_183 I=CTS_188
XCTS_ccl_a_INV_CLK_G0_L6_4 INV6CK $PINS O=CTS_188 I=CTS_189
XCTS_ccl_a_INV_CLK_G1_L8_100 INV8CK $PINS O=CTS_176 I=CTS_177
XCTS_ccl_a_INV_CLK_G1_L7_100 INV6CK $PINS O=CTS_177 I=CTS_178
XCTS_ccl_a_INV_CLK_G0_L5_10 INV8CK $PINS O=CTS_189 I=CTS_198
XCTS_ccl_a_INV_CLK_G0_L4_5 INV12CK $PINS O=CTS_198 I=CTS_199
XCTS_ccl_a_INV_CLK_G0_L3_3 INV8CK $PINS O=CTS_199 I=CTS_200
XCTS_ccl_a_INV_CLK_G0_L5_8 INV12CK $PINS O=CTS_173 I=CTS_174
XCTS_ccl_a_INV_CLK_G0_L4_4 INV12CK $PINS O=CTS_174 I=CTS_175
XCTS_ccl_a_INV_CLK_G0_L5_6 INV8CK $PINS O=CTS_171 I=CTS_172
XCTS_ccl_a_INV_CLK_G0_L4_3 INV12CK $PINS O=CTS_172 I=CTS_175
XCTS_ccl_a_INV_CLK_G0_L3_2 INV12CK $PINS O=CTS_175 I=CTS_200
XCTS_ccl_a_INV_CLK_G0_L5_4 INV12CK $PINS O=CTS_168 I=CTS_169
XCTS_ccl_a_INV_CLK_G1_L8_23 INV8CK $PINS O=CTS_164 I=CTS_165
XCTS_ccl_a_INV_CLK_G1_L7_23 INV6CK $PINS O=CTS_165 I=CTS_166
XCTS_ccl_a_INV_CLK_G1_L8_22 INV12CK $PINS O=CTS_161 I=CTS_162
XCTS_ccl_a_INV_CLK_G1_L7_22 INV6CK $PINS O=CTS_162 I=CTS_163
XCTS_ccl_a_INV_CLK_G1_L8_21 INV8CK $PINS O=CTS_158 I=CTS_159
XCTS_ccl_a_INV_CLK_G1_L7_21 INV4CK $PINS O=CTS_159 I=CTS_160
XCTS_ccl_a_INV_CLK_G1_L8_20 INV8CK $PINS O=CTS_155 I=CTS_156
XCTS_ccl_a_INV_CLK_G1_L7_20 INV4CK $PINS O=CTS_156 I=CTS_157
XCTS_ccl_a_INV_CLK_G1_L8_19 INV8CK $PINS O=CTS_152 I=CTS_153
XCTS_ccl_a_INV_CLK_G1_L7_19 INV3CK $PINS O=CTS_153 I=CTS_154
XCTS_ccl_a_INV_CLK_G1_L8_18 INV6CK $PINS O=CTS_149 I=CTS_150
XCTS_ccl_a_INV_CLK_G1_L7_18 INV4CK $PINS O=CTS_150 I=CTS_151
XCTS_ccl_a_INV_CLK_G0_L5_3 INV12CK $PINS O=CTS_167 I=CTS_169
XCTS_cdb_INV_CLK_G0_L7_17 INV8CK $PINS O=CTS_146 I=CTS_147
XCTS_cdb_INV_CLK_G0_L6_1 INV6CK $PINS O=CTS_147 I=CTS_148
XCTS_ccl_a_INV_CLK_G0_L5_2 INV12CK $PINS O=CTS_148 I=CTS_169
XCTS_ccl_a_INV_CLK_G0_L4_2 INV12CK $PINS O=CTS_169 I=CTS_170
XCTS_ccl_a_INV_CLK_G0_L3_1 INV12CK $PINS O=CTS_170 I=CTS_200
XCTS_ccl_INV_CLK_G0_L2_1 INV12CK $PINS O=CTS_200 I=clk
XFE_RC_1608_0 AN2 $PINS O=FE_RN_379_0 I1=sub_135/carry_14 I2=n214
XFE_RC_1607_0 INV1S $PINS O=FE_RN_378_0 I=FE_RN_379_0
XFE_RC_1606_0 XOR2HS $PINS O=phase_1[15] I1=FE_RN_378_0 I2=N83
XFE_OFC709_n64 INV2 $PINS O=FE_OFN0_FE_DBTN15_n64 I=n64
XFE_RC_1223_0 INV2 $PINS O=FE_RN_170_0 I=rf_d_rdata_1[6]
XFE_RC_1222_0 INV1S $PINS O=FE_RN_171_0 I=n164
XFE_RC_1221_0 MXL2HS $PINS OB=mac_in_real[6] S=FE_RN_171_0 A=FE_RN_170_0 B=n227
XFE_RC_1183_0 INV2 $PINS O=mac_in_real[8] I=FE_RN_148_0
XFE_RC_1182_0 AOI12HS $PINS O=FE_RN_148_0 A1=FE_DBTN13_n83 B1=FE_OFN347_n164
+ B2=rf_d_rdata_1[8]
XFE_RC_1175_0 INV2 $PINS O=FE_RN_143_0 I=rf_d_rdata_1[5]
XFE_RC_1174_0 INV2 $PINS O=FE_RN_144_0 I=n164
XFE_RC_1173_0 MXL2H $PINS OB=mac_in_real[5] S=FE_RN_144_0 A=FE_RN_143_0 B=n228
XFE_RC_1136_0 INV3 $PINS O=FE_RN_71_0 I=FE_RN_124_0
XFE_RC_1135_0 MOAI1HP $PINS O=FE_RN_124_0 A1=n233 A2=n72 B1=n140
+ B2=rf_d_rdata_1[0]
XFE_RC_1101_0 INV1S $PINS O=FE_RN_107_0 I=rf_d_rdata_1[1]
XFE_RC_1100_0 INV4 $PINS O=FE_RN_108_0 I=n72
XFE_RC_1099_0 MXL2HT $PINS OB=mac_in_real[1] S=FE_RN_108_0 A=FE_RN_107_0 B=n232
XFE_RC_1028_0 INV8 $PINS O=mac_in_real[0] I=FE_RN_71_0
XFE_RC_933_0 INV1S $PINS O=FE_RN_44_0 I=FE_RN_108_0
XFE_RC_932_0 AN2B1T $PINS O=n84 I1=rf_io_rdata_1[15] B1=FE_RN_44_0
XFE_RC_0_0 MUX2 $PINS O=mac_in_imag[5] S=FE_RN_108_0 A=rf_d_rdata_1[22]
+ B=rf_io_rdata_1[13]
XFE_OFC674_n164 BUF2 $PINS O=FE_OFN347_n164 I=n164
XFE_OFC669_rf_io_rdata_1_8 INV2 $PINS O=FE_OFN346_rf_io_rdata_1_8
+ I=rf_io_rdata_1[8]
XFE_OFC663_rf_io_rdata_1_9 INV2 $PINS O=n224 I=rf_io_rdata_1[9]
XFE_OFC593_n83 INV2 $PINS O=FE_DBTN13_n83 I=n83
XFE_OFC494_n72 BUF3 $PINS O=n164 I=n72
XFE_OFC435_FE_DBTN15_n64 BUF1 $PINS O=FE_OFN226_FE_DBTN15_n64 I=n64
XFE_OFC344_rf_io_rdata_1_1 INV2 $PINS O=n232 I=rf_io_rdata_1[1]
XFE_OFC312_rf_io_rdata_1_3 INV1S $PINS O=n230 I=rf_io_rdata_1[3]
XFE_OFC280_rf_io_rdata_1_2 INV2 $PINS O=n231 I=rf_io_rdata_1[2]
XFE_OFC259_rf_io_rdata_1_4 INV2 $PINS O=n229 I=rf_io_rdata_1[4]
XFE_OFC241_rf_io_rdata_1_5 INV2 $PINS O=n228 I=rf_io_rdata_1[5]
XFE_OFC233_rf_io_rdata_1_6 INV2 $PINS O=n227 I=rf_io_rdata_1[6]
XFE_OFC104_n114 BUF1 $PINS O=FE_DBTN10_n114 I=FE_OFN32_n114
XFE_OFC103_n114 INV1S $PINS O=FE_OFN87_FE_DBTN10_n114 I=FE_OFN32_n114
XFE_OFC102_n114 INV2 $PINS O=FE_OFN32_n114 I=n114
XFE_OFC93_n238 BUF1 $PINS O=FE_OFN95_n238 I=n238
XFE_OFC86_rf_io_waddr_2_1 BUF1 $PINS O=FE_OFN88_rf_io_waddr_2_1
+ I=rf_io_waddr_2[1]
XFE_OFC84_FE_DBTN17_n206 BUF2CK $PINS O=FE_OFN86_FE_DBTN17_n206
+ I=FE_OFN84_FE_DBTN17_n206
XFE_OFC83_FE_DBTN17_n206 BUF2CK $PINS O=FE_OFN85_FE_DBTN17_n206
+ I=FE_OFN83_FE_DBTN17_n206
XFE_OFC82_FE_DBTN17_n206 BUF2CK $PINS O=FE_OFN84_FE_DBTN17_n206
+ I=FE_OFN82_FE_DBTN17_n206
XFE_OFC81_FE_DBTN17_n206 BUF2CK $PINS O=FE_OFN83_FE_DBTN17_n206
+ I=FE_OFN82_FE_DBTN17_n206
XFE_OFC80_FE_DBTN17_n206 INV2 $PINS O=FE_OFN82_FE_DBTN17_n206
+ I=FE_OFN79_FE_DBTN17_n206
XFE_OFC79_FE_DBTN17_n206 INV2 $PINS O=FE_OFN81_FE_DBTN17_n206
+ I=FE_OFN79_FE_DBTN17_n206
XFE_OFC78_FE_DBTN17_n206 BUF2CK $PINS O=FE_OFN80_FE_DBTN17_n206
+ I=FE_DBTN17_n206
XFE_OFC77_FE_DBTN17_n206 INV1S $PINS O=FE_OFN79_FE_DBTN17_n206 I=FE_DBTN17_n206
XFE_OFC33_o_counter_r_0 BUF2CK $PINS O=FE_OFN35_o_counter_r_0 I=o_counter_r[0]
XFE_OFC31_n114 INV2 $PINS O=FE_OFN33_n114 I=FE_OFN32_n114
XFE_OFC23_i_rst_n BUF1 $PINS O=FE_OFN24_i_rst_n I=FE_OFN16_i_rst_n
XFE_OFC18_i_rst_n INV2 $PINS O=FE_OFN19_i_rst_n I=FE_OFN11_i_rst_n
XFE_OFC15_i_rst_n BUF2CK $PINS O=FE_OFN16_i_rst_n I=FE_OFN9_i_rst_n
XFE_OFC13_i_rst_n BUF2CK $PINS O=FE_OFN13_i_rst_n I=rst_n
XFE_OFC11_i_rst_n INV1S $PINS O=FE_OFN11_i_rst_n I=rst_n
XFE_OFC9_i_rst_n BUF1 $PINS O=FE_OFN9_i_rst_n I=rst_n
XFE_DBTC17_n206 INV2 $PINS O=FE_DBTN17_n206 I=n206
XFE_DBTC16_current_n_0 INV1S $PINS O=FE_DBTN16_current_n_0 I=current_n[0]
XFE_DBTC14_n68 INV1S $PINS O=FE_DBTN14_n68 I=n68
XFE_DBTC12_n85 INV1S $PINS O=FE_DBTN12_n85 I=n85
XFE_DBTC11_n90 INV1S $PINS O=FE_DBTN11_n90 I=n90
XFE_DBTC9_state_r_0 INV8CK $PINS O=FE_DBTN9_state_r_0 I=state_r[0]
XFE_DBTC8_phase_1_8 INV1S $PINS O=FE_DBTN8_phase_1_8 I=phase_1[8]
XFE_DBTC7_phase_0_9 INV1S $PINS O=FE_DBTN7_phase_0_9 I=phase_0[9]
XFE_DBTC6_current_g_0 INV1S $PINS O=FE_DBTN6_current_g_0
+ I=FE_PHN1172_current_g_0
XFE_DBTC5_current_n_1 INV1S $PINS O=FE_DBTN5_current_n_1
+ I=FE_PHN1173_current_n_1
XFE_DBTC4_k_ord_1_0 INV1S $PINS O=FE_DBTN4_k_ord_1_0 I=k_ord_1[0]
XFE_DBTC3_c_group_idx_0 INV1S $PINS O=FE_DBTN3_c_group_idx_0 I=c_group_idx[0]
XFE_DBTC2_current_g_1 INV1S $PINS O=FE_DBTN2_current_g_1
+ I=FE_PHN1170_current_g_1
XFE_DBTC1_c_group_idx_1 INV1S $PINS O=FE_DBTN1_c_group_idx_1 I=c_group_idx[1]
XFE_DBTC0_current_g_2 INV1S $PINS O=FE_DBTN0_current_g_2 I=current_g[2]
XU166 AO22 $PINS O=rf_io_wdata_2[9] A1=FE_PHN1129_pe_r1_9 A2=n238
+ B1=delayed_out3[9] B2=rf_io_waddr_2[1]
XU167 AO22 $PINS O=rf_io_wdata_2[8] A1=FE_PHN1119_pe_r1_8 A2=n238
+ B1=delayed_out3[8] B2=rf_io_waddr_2[1]
XU168 AO22 $PINS O=rf_io_wdata_2[7] A1=pe_r1[7] A2=n238 B1=delayed_out3[7]
+ B2=rf_io_waddr_2[1]
XU169 AO22 $PINS O=rf_io_wdata_2[6] A1=FE_PHN1122_pe_r1_6 A2=n238
+ B1=delayed_out3[6] B2=rf_io_waddr_2[1]
XU170 AO22 $PINS O=rf_io_wdata_2[5] A1=pe_r1[5] A2=n238 B1=delayed_out3[5]
+ B2=rf_io_waddr_2[1]
XU171 AO22 $PINS O=rf_io_wdata_2[4] A1=FE_PHN1124_pe_r1_4 A2=n238
+ B1=delayed_out3[4] B2=rf_io_waddr_2[1]
XU172 AO22 $PINS O=rf_io_wdata_2[3] A1=FE_PHN1123_pe_r1_3 A2=n238
+ B1=delayed_out3[3] B2=rf_io_waddr_2[1]
XU173 AO22 $PINS O=rf_io_wdata_2[2] A1=FE_PHN1120_pe_r1_2 A2=n238
+ B1=delayed_out3[2] B2=rf_io_waddr_2[1]
XU174 AO22 $PINS O=rf_io_wdata_2[21] A1=pe_i1[10] A2=n238 B1=delayed_out3[21]
+ B2=rf_io_waddr_2[1]
XU175 AO22 $PINS O=rf_io_wdata_2[20] A1=pe_i1[9] A2=n238 B1=delayed_out3[20]
+ B2=rf_io_waddr_2[1]
XU176 AO22 $PINS O=rf_io_wdata_2[1] A1=FE_PHN1126_pe_r1_1 A2=n238
+ B1=delayed_out3[1] B2=rf_io_waddr_2[1]
XU177 AO22 $PINS O=rf_io_wdata_2[19] A1=pe_i1[8] A2=n238 B1=delayed_out3[19]
+ B2=rf_io_waddr_2[1]
XU178 AO22 $PINS O=rf_io_wdata_2[18] A1=pe_i1[7] A2=n238 B1=delayed_out3[18]
+ B2=rf_io_waddr_2[1]
XU179 AO22 $PINS O=rf_io_wdata_2[17] A1=FE_PHN1113_pe_i1_6 A2=n238
+ B1=delayed_out3[17] B2=rf_io_waddr_2[1]
XU180 AO22 $PINS O=rf_io_wdata_2[16] A1=FE_PHN1112_pe_i1_5 A2=n238
+ B1=delayed_out3[16] B2=rf_io_waddr_2[1]
XU181 AO22 $PINS O=rf_io_wdata_2[15] A1=FE_PHN1116_pe_i1_4 A2=n238
+ B1=delayed_out3[15] B2=rf_io_waddr_2[1]
XU182 AO22 $PINS O=rf_io_wdata_2[14] A1=pe_i1[3] A2=n238 B1=delayed_out3[14]
+ B2=rf_io_waddr_2[1]
XU183 AO22 $PINS O=rf_io_wdata_2[13] A1=FE_PHN1117_pe_i1_2 A2=n238
+ B1=delayed_out3[13] B2=rf_io_waddr_2[1]
XU184 AO22 $PINS O=rf_io_wdata_2[12] A1=pe_i1[1] A2=n238 B1=delayed_out3[12]
+ B2=rf_io_waddr_2[1]
XU185 AO22 $PINS O=rf_io_wdata_2[11] A1=pe_i1[0] A2=n238 B1=delayed_out3[11]
+ B2=rf_io_waddr_2[1]
XU186 AO22 $PINS O=rf_io_wdata_2[10] A1=FE_PHN1128_pe_r1_10 A2=n238
+ B1=delayed_out3[10] B2=rf_io_waddr_2[1]
XU187 AO22 $PINS O=rf_io_wdata_2[0] A1=FE_PHN1127_pe_r1_0 A2=n238
+ B1=delayed_out3[0] B2=rf_io_waddr_2[1]
XU188 AO222 $PINS O=rf_io_wdata_1[9] A1=pe_r0[9] A2=FE_OFN95_n238 B1=i_data[9]
+ B2=n141 C1=delayed_out2[9] C2=FE_OFN88_rf_io_waddr_2_1
XU189 AO222 $PINS O=rf_io_wdata_1[8] A1=pe_r0[8] A2=FE_OFN95_n238 B1=i_data[8]
+ B2=n141 C1=delayed_out2[8] C2=FE_OFN88_rf_io_waddr_2_1
XU190 AO222 $PINS O=rf_io_wdata_1[7] A1=pe_r0[7] A2=FE_OFN95_n238 B1=i_data[7]
+ B2=n141 C1=delayed_out2[7] C2=FE_OFN88_rf_io_waddr_2_1
XU191 AO222 $PINS O=rf_io_wdata_1[6] A1=pe_r0[6] A2=FE_OFN95_n238 B1=i_data[6]
+ B2=n141 C1=delayed_out2[6] C2=FE_OFN88_rf_io_waddr_2_1
XU192 AO222 $PINS O=rf_io_wdata_1[5] A1=pe_r0[5] A2=FE_OFN95_n238 B1=i_data[5]
+ B2=n141 C1=delayed_out2[5] C2=FE_OFN88_rf_io_waddr_2_1
XU193 AO222 $PINS O=rf_io_wdata_1[4] A1=pe_r0[4] A2=FE_OFN95_n238 B1=i_data[4]
+ B2=n141 C1=delayed_out2[4] C2=FE_OFN88_rf_io_waddr_2_1
XU194 AO222 $PINS O=rf_io_wdata_1[3] A1=pe_r0[3] A2=FE_OFN95_n238 B1=i_data[3]
+ B2=n141 C1=delayed_out2[3] C2=FE_OFN88_rf_io_waddr_2_1
XU195 AO222 $PINS O=rf_io_wdata_1[2] A1=pe_r0[2] A2=FE_OFN95_n238 B1=i_data[2]
+ B2=n141 C1=delayed_out2[2] C2=FE_OFN88_rf_io_waddr_2_1
XU196 AO22 $PINS O=rf_io_wdata_1[21] A1=pe_i0[10] A2=FE_OFN95_n238
+ B1=delayed_out2[21] B2=FE_OFN88_rf_io_waddr_2_1
XU197 AO22 $PINS O=rf_io_wdata_1[20] A1=pe_i0[9] A2=FE_OFN95_n238
+ B1=delayed_out2[20] B2=FE_OFN88_rf_io_waddr_2_1
XU198 AO222 $PINS O=rf_io_wdata_1[1] A1=pe_r0[1] A2=FE_OFN95_n238 B1=i_data[1]
+ B2=n141 C1=delayed_out2[1] C2=FE_OFN88_rf_io_waddr_2_1
XU199 AO22 $PINS O=rf_io_wdata_1[19] A1=pe_i0[8] A2=FE_OFN95_n238
+ B1=delayed_out2[19] B2=FE_OFN88_rf_io_waddr_2_1
XU200 AO22 $PINS O=rf_io_wdata_1[18] A1=pe_i0[7] A2=FE_OFN95_n238
+ B1=delayed_out2[18] B2=FE_OFN88_rf_io_waddr_2_1
XU201 AO22 $PINS O=rf_io_wdata_1[17] A1=pe_i0[6] A2=FE_OFN95_n238
+ B1=delayed_out2[17] B2=FE_OFN88_rf_io_waddr_2_1
XU202 AO22 $PINS O=rf_io_wdata_1[16] A1=pe_i0[5] A2=FE_OFN95_n238
+ B1=delayed_out2[16] B2=FE_OFN88_rf_io_waddr_2_1
XU203 AO222 $PINS O=rf_io_wdata_1[15] A1=pe_i0[4] A2=FE_OFN95_n238
+ B1=i_data[15] B2=n141 C1=delayed_out2[15] C2=FE_OFN88_rf_io_waddr_2_1
XU204 AO222 $PINS O=rf_io_wdata_1[14] A1=pe_i0[3] A2=FE_OFN95_n238
+ B1=i_data[14] B2=n141 C1=delayed_out2[14] C2=FE_OFN88_rf_io_waddr_2_1
XU205 AO222 $PINS O=rf_io_wdata_1[13] A1=pe_i0[2] A2=FE_OFN95_n238
+ B1=i_data[13] B2=n141 C1=delayed_out2[13] C2=FE_OFN88_rf_io_waddr_2_1
XU206 AO222 $PINS O=rf_io_wdata_1[12] A1=pe_i0[1] A2=FE_OFN95_n238
+ B1=i_data[12] B2=n141 C1=delayed_out2[12] C2=FE_OFN88_rf_io_waddr_2_1
XU207 AO222 $PINS O=rf_io_wdata_1[11] A1=pe_i0[0] A2=FE_OFN95_n238
+ B1=i_data[11] B2=n141 C1=delayed_out2[11] C2=FE_OFN88_rf_io_waddr_2_1
XU208 AO222 $PINS O=rf_io_wdata_1[10] A1=pe_r0[10] A2=FE_OFN95_n238
+ B1=i_data[10] B2=n141 C1=delayed_out2[10] C2=FE_OFN88_rf_io_waddr_2_1
XU209 AO222 $PINS O=rf_io_wdata_1[0] A1=pe_r0[0] A2=FE_OFN95_n238 B1=i_data[0]
+ B2=n141 C1=delayed_out2[0] C2=FE_OFN88_rf_io_waddr_2_1
XU210 AO12 $PINS O=rf_io_waddr_1[4] A1=rf_io_waddr_2[4] B1=n141 B2=current_n[4]
XU211 AO12 $PINS O=rf_io_waddr_1[3] A1=rf_io_waddr_2[3] B1=n141 B2=current_n[3]
XU212 AO12 $PINS O=rf_io_waddr_1[2] A1=rf_io_waddr_2[2] B1=n141 B2=current_n[2]
XU213 AO12 $PINS O=rf_io_waddr_1[1] A1=rf_io_waddr_2[1] B1=n141
+ B2=FE_PHN1173_current_n_1
XU214 AN2B1S $PINS O=n60 I1=rf_io_write_delay B1=mac_valid_out_r
XU215 ND2 $PINS O=n62 I1=n63 I2=n246
XU216 AO12 $PINS O=n69 A1=N55 B1=n266 B2=FE_PHN1040_cordic_valid_out_0
XU218 ND2 $PINS O=n113 I1=n67 I2=n77
XU219 ND2 $PINS O=n77 I1=n82 I2=n63
XU220 ND2 $PINS O=n67 I1=n239 I2=FE_OFN0_FE_DBTN15_n64
XU221 AO12 $PINS O=mac_in_real[9] A1=FE_DBTN13_n83 B1=rf_d_rdata_1[9]
+ B2=FE_OFN347_n164
XU224 AO12 $PINS O=mac_in_real[16] A1=FE_DBTN13_n83 B1=rf_d_rdata_1[16]
+ B2=FE_OFN347_n164
XU225 AO12 $PINS O=mac_in_real[15] A1=FE_DBTN13_n83 B1=rf_d_rdata_1[15]
+ B2=FE_OFN347_n164
XU226 AO12 $PINS O=mac_in_real[14] A1=FE_DBTN13_n83 B1=rf_d_rdata_1[14]
+ B2=FE_OFN347_n164
XU228 AO12 $PINS O=mac_in_real[12] A1=FE_DBTN13_n83 B1=rf_d_rdata_1[12]
+ B2=FE_OFN347_n164
XU229 AO12 $PINS O=mac_in_real[11] A1=FE_DBTN13_n83 B1=rf_d_rdata_1[11]
+ B2=FE_OFN347_n164
XU230 AO12 $PINS O=mac_in_real[10] A1=FE_DBTN13_n83 B1=rf_d_rdata_1[10]
+ B2=FE_OFN347_n164
XU234 AO22 $PINS O=mac_in_imag[6] A1=FE_RN_108_0 A2=rf_io_rdata_1[14]
+ B1=rf_d_rdata_1[23] B2=n72
XU245 AO22 $PINS O=key_w[7] A1=i_data[7] A2=n85 B1=FE_PHN1011_key_r_7
+ B2=FE_DBTN12_n85
XU246 AO22 $PINS O=key_w[6] A1=i_data[6] A2=n85 B1=FE_PHN1017_key_r_6
+ B2=FE_DBTN12_n85
XU247 AO22 $PINS O=key_w[5] A1=i_data[5] A2=n85 B1=FE_PHN1020_key_r_5
+ B2=FE_DBTN12_n85
XU248 AO22 $PINS O=key_w[4] A1=i_data[4] A2=n85 B1=key_r[4] B2=FE_DBTN12_n85
XU249 AO22 $PINS O=key_w[3] A1=i_data[3] A2=n85 B1=FE_PHN1018_key_r_3
+ B2=FE_DBTN12_n85
XU250 AO22 $PINS O=key_w[2] A1=i_data[2] A2=n85 B1=FE_PHN1019_key_r_2
+ B2=FE_DBTN12_n85
XU251 AO22 $PINS O=FE_PHN1187_key_w_1 A1=i_data[1] A2=n85 B1=key_r[1]
+ B2=FE_DBTN12_n85
XU252 AO22 $PINS O=key_w[0] A1=i_data[0] A2=n85 B1=FE_PHN1021_key_r_0
+ B2=FE_DBTN12_n85
XU254 AO22 $PINS O=FE_PHN1379_c_in_r_1_9 A1=c_buf_r[3][9] A2=FE_OFN32_n114
+ B1=c_buf_r[1][9] B2=FE_OFN87_FE_DBTN10_n114
XU255 AO22 $PINS O=c_in_r_1[8] A1=c_buf_r[3][8] A2=FE_OFN32_n114
+ B1=c_buf_r[1][8] B2=FE_OFN87_FE_DBTN10_n114
XU256 AO22 $PINS O=FE_PHN1389_c_in_r_1_7 A1=c_buf_r[3][7] A2=FE_OFN32_n114
+ B1=c_buf_r[1][7] B2=FE_OFN87_FE_DBTN10_n114
XU257 AO22 $PINS O=c_in_r_1[6] A1=c_buf_r[3][6] A2=FE_OFN32_n114
+ B1=c_buf_r[1][6] B2=FE_OFN87_FE_DBTN10_n114
XU258 AO22 $PINS O=FE_PHN1404_c_in_r_1_5 A1=c_buf_r[3][5] A2=FE_OFN32_n114
+ B1=c_buf_r[1][5] B2=FE_OFN87_FE_DBTN10_n114
XU261 AO22 $PINS O=c_in_r_1[2] A1=c_buf_r[3][2] A2=FE_OFN32_n114
+ B1=c_buf_r[1][2] B2=FE_OFN87_FE_DBTN10_n114
XU266 AO22 $PINS O=FE_PHN1369_c_in_r_1_13 A1=c_buf_r[3][13] A2=FE_OFN32_n114
+ B1=c_buf_r[1][13] B2=FE_OFN87_FE_DBTN10_n114
XU267 AO22 $PINS O=FE_PHN1372_c_in_r_1_12 A1=c_buf_r[3][12] A2=FE_OFN32_n114
+ B1=c_buf_r[1][12] B2=FE_OFN87_FE_DBTN10_n114
XU268 AO22 $PINS O=FE_PHN1378_c_in_r_1_11 A1=c_buf_r[3][11] A2=FE_OFN32_n114
+ B1=c_buf_r[1][11] B2=FE_OFN87_FE_DBTN10_n114
XU269 AO22 $PINS O=FE_PHN1387_c_in_r_1_10 A1=c_buf_r[3][10] A2=FE_OFN32_n114
+ B1=c_buf_r[1][10] B2=FE_OFN87_FE_DBTN10_n114
XU270 AO22 $PINS O=c_in_r_1[0] A1=c_buf_r[3][0] A2=FE_OFN32_n114
+ B1=c_buf_r[1][0] B2=FE_OFN87_FE_DBTN10_n114
XU271 AO22 $PINS O=c_in_r_0[9] A1=c_buf_r[2][9] A2=FE_DBTN10_n114
+ B1=c_buf_r[0][9] B2=FE_OFN33_n114
XU272 AO22 $PINS O=c_in_r_0[8] A1=c_buf_r[2][8] A2=FE_DBTN10_n114
+ B1=c_buf_r[0][8] B2=FE_OFN33_n114
XU273 AO22 $PINS O=c_in_r_0[7] A1=c_buf_r[2][7] A2=FE_DBTN10_n114
+ B1=c_buf_r[0][7] B2=FE_OFN33_n114
XU274 AO22 $PINS O=c_in_r_0[6] A1=c_buf_r[2][6] A2=FE_DBTN10_n114
+ B1=c_buf_r[0][6] B2=FE_OFN33_n114
XU275 AO22 $PINS O=c_in_r_0[5] A1=c_buf_r[2][5] A2=FE_DBTN10_n114
+ B1=c_buf_r[0][5] B2=FE_OFN33_n114
XU276 AO22 $PINS O=c_in_r_0[4] A1=c_buf_r[2][4] A2=FE_DBTN10_n114
+ B1=c_buf_r[0][4] B2=FE_OFN33_n114
XU277 AO22 $PINS O=c_in_r_0[3] A1=c_buf_r[2][3] A2=FE_DBTN10_n114
+ B1=c_buf_r[0][3] B2=FE_OFN33_n114
XU278 AO22 $PINS O=c_in_r_0[2] A1=c_buf_r[2][2] A2=FE_DBTN10_n114
+ B1=c_buf_r[0][2] B2=FE_OFN33_n114
XU279 AO22 $PINS O=c_in_r_0[1] A1=c_buf_r[2][1] A2=FE_DBTN10_n114
+ B1=c_buf_r[0][1] B2=FE_OFN33_n114
XU280 AO22 $PINS O=c_in_r_0[16] A1=c_buf_r[2][16] A2=FE_DBTN10_n114
+ B1=c_buf_r[0][16] B2=FE_OFN33_n114
XU281 AO22 $PINS O=c_in_r_0[15] A1=c_buf_r[2][15] A2=FE_DBTN10_n114
+ B1=c_buf_r[0][15] B2=FE_OFN33_n114
XU282 AO22 $PINS O=c_in_r_0[14] A1=c_buf_r[2][14] A2=FE_DBTN10_n114
+ B1=c_buf_r[0][14] B2=FE_OFN33_n114
XU283 AO22 $PINS O=c_in_r_0[13] A1=c_buf_r[2][13] A2=FE_DBTN10_n114
+ B1=c_buf_r[0][13] B2=FE_OFN33_n114
XU284 AO22 $PINS O=c_in_r_0[12] A1=c_buf_r[2][12] A2=FE_DBTN10_n114
+ B1=c_buf_r[0][12] B2=FE_OFN33_n114
XU285 AO22 $PINS O=FE_PHN1382_c_in_r_0_11 A1=c_buf_r[2][11] A2=FE_DBTN10_n114
+ B1=c_buf_r[0][11] B2=FE_OFN33_n114
XU286 AO22 $PINS O=c_in_r_0[10] A1=c_buf_r[2][10] A2=FE_DBTN10_n114
+ B1=c_buf_r[0][10] B2=FE_OFN33_n114
XU287 AO22 $PINS O=c_in_r_0[0] A1=c_buf_r[2][0] A2=FE_DBTN10_n114
+ B1=c_buf_r[0][0] B2=FE_OFN33_n114
XU288 AO22 $PINS O=c_in_i_1[9] A1=c_buf_i[3][9] A2=FE_OFN32_n114
+ B1=c_buf_i[1][9] B2=FE_OFN87_FE_DBTN10_n114
XU289 AO22 $PINS O=FE_PHN1375_c_in_i_1_8 A1=c_buf_i[3][8] A2=FE_OFN32_n114
+ B1=c_buf_i[1][8] B2=FE_OFN87_FE_DBTN10_n114
XU290 AO22 $PINS O=c_in_i_1[7] A1=c_buf_i[3][7] A2=FE_OFN32_n114
+ B1=c_buf_i[1][7] B2=FE_OFN87_FE_DBTN10_n114
XU291 AO22 $PINS O=FE_PHN1391_c_in_i_1_6 A1=c_buf_i[3][6] A2=FE_OFN32_n114
+ B1=c_buf_i[1][6] B2=FE_OFN87_FE_DBTN10_n114
XU292 AO22 $PINS O=c_in_i_1[5] A1=c_buf_i[3][5] A2=FE_OFN32_n114
+ B1=c_buf_i[1][5] B2=FE_OFN87_FE_DBTN10_n114
XU293 AO22 $PINS O=c_in_i_1[4] A1=c_buf_i[3][4] A2=FE_OFN32_n114
+ B1=c_buf_i[1][4] B2=FE_OFN87_FE_DBTN10_n114
XU294 AO22 $PINS O=c_in_i_1[3] A1=c_buf_i[3][3] A2=FE_OFN32_n114
+ B1=c_buf_i[1][3] B2=FE_OFN87_FE_DBTN10_n114
XU295 AO22 $PINS O=c_in_i_1[2] A1=c_buf_i[3][2] A2=FE_OFN32_n114
+ B1=c_buf_i[1][2] B2=FE_OFN87_FE_DBTN10_n114
XU296 AO22 $PINS O=c_in_i_1[1] A1=c_buf_i[3][1] A2=FE_OFN32_n114
+ B1=c_buf_i[1][1] B2=FE_OFN87_FE_DBTN10_n114
XU297 AO22 $PINS O=c_in_i_1[16] A1=c_buf_i[3][16] A2=FE_OFN32_n114
+ B1=FE_PHN1062_c_buf_i_1_16 B2=FE_OFN87_FE_DBTN10_n114
XU298 AO22 $PINS O=c_in_i_1[15] A1=c_buf_i[3][15] A2=FE_OFN32_n114
+ B1=c_buf_i[1][15] B2=FE_OFN87_FE_DBTN10_n114
XU299 AO22 $PINS O=c_in_i_1[14] A1=c_buf_i[3][14] A2=FE_OFN32_n114
+ B1=c_buf_i[1][14] B2=FE_OFN87_FE_DBTN10_n114
XU300 AO22 $PINS O=c_in_i_1[13] A1=c_buf_i[3][13] A2=FE_OFN32_n114
+ B1=c_buf_i[1][13] B2=FE_OFN87_FE_DBTN10_n114
XU301 AO22 $PINS O=FE_PHN1377_c_in_i_1_12 A1=c_buf_i[3][12] A2=FE_OFN32_n114
+ B1=FE_PHN1082_c_buf_i_1_12 B2=FE_OFN87_FE_DBTN10_n114
XU302 AO22 $PINS O=c_in_i_1[11] A1=c_buf_i[3][11] A2=FE_OFN32_n114
+ B1=c_buf_i[1][11] B2=FE_OFN87_FE_DBTN10_n114
XU303 AO22 $PINS O=c_in_i_1[10] A1=c_buf_i[3][10] A2=FE_OFN32_n114
+ B1=c_buf_i[1][10] B2=FE_OFN87_FE_DBTN10_n114
XU304 AO22 $PINS O=c_in_i_1[0] A1=c_buf_i[3][0] A2=FE_OFN32_n114
+ B1=c_buf_i[1][0] B2=FE_OFN87_FE_DBTN10_n114
XU305 AO22 $PINS O=c_in_i_0[9] A1=c_buf_i[2][9] A2=FE_DBTN10_n114
+ B1=c_buf_i[0][9] B2=FE_OFN33_n114
XU306 AO22 $PINS O=c_in_i_0[8] A1=c_buf_i[2][8] A2=FE_DBTN10_n114
+ B1=FE_PHN1093_c_buf_i_0_8 B2=FE_OFN33_n114
XU307 AO22 $PINS O=FE_PHN1399_c_in_i_0_7 A1=c_buf_i[2][7] A2=FE_DBTN10_n114
+ B1=c_buf_i[0][7] B2=FE_OFN33_n114
XU308 AO22 $PINS O=c_in_i_0[6] A1=c_buf_i[2][6] A2=FE_DBTN10_n114
+ B1=FE_PHN1099_c_buf_i_0_6 B2=FE_OFN33_n114
XU309 AO22 $PINS O=c_in_i_0[5] A1=c_buf_i[2][5] A2=FE_DBTN10_n114
+ B1=FE_PHN1097_c_buf_i_0_5 B2=FE_OFN33_n114
XU310 AO22 $PINS O=FE_PHN1402_c_in_i_0_4 A1=c_buf_i[2][4] A2=FE_DBTN10_n114
+ B1=c_buf_i[0][4] B2=FE_OFN33_n114
XU311 AO22 $PINS O=c_in_i_0[3] A1=c_buf_i[2][3] A2=FE_DBTN10_n114
+ B1=c_buf_i[0][3] B2=FE_OFN33_n114
XU312 AO22 $PINS O=c_in_i_0[2] A1=c_buf_i[2][2] A2=FE_DBTN10_n114
+ B1=c_buf_i[0][2] B2=FE_OFN33_n114
XU313 AO22 $PINS O=c_in_i_0[1] A1=c_buf_i[2][1] A2=FE_DBTN10_n114
+ B1=c_buf_i[0][1] B2=FE_OFN33_n114
XU314 AO22 $PINS O=c_in_i_0[16] A1=c_buf_i[2][16] A2=FE_DBTN10_n114
+ B1=FE_PHN1036_c_buf_i_0_16 B2=FE_OFN33_n114
XU316 AO22 $PINS O=c_in_i_0[14] A1=c_buf_i[2][14] A2=FE_DBTN10_n114
+ B1=c_buf_i[0][14] B2=FE_OFN33_n114
XU322 ND2 $PINS O=n61 I1=mac_valid_out_r I2=FE_OFN0_FE_DBTN15_n64
XU323 ND2 $PINS O=N55 I1=FE_DBTN14_n68 I2=n70
XU326 AN3B2S $PINS O=N292 I1=N299 B1=mac_en B2=n141
XU328 AN2B1S $PINS O=N299 I1=n63 B1=n73
XU329 ND2 $PINS O=n88 I1=n244 I2=n150
Xr119/U1_1_1 HA1 $PINS S=N254 C=r119/carry[2] A=o_counter_r[1]
+ B=FE_OFN35_o_counter_r_0
Xr119/U1_1_2 HA1 $PINS S=N255 C=r119/carry[3] A=o_counter_r[2] B=r119/carry[2]
Xr119/U1_1_3 HA1 $PINS S=N256 C=r119/carry[4] A=o_counter_r[3] B=r119/carry[3]
Xr119/U1_1_4 HA1 $PINS S=N257 C=r119/carry[5] A=o_counter_r[4] B=r119/carry[4]
Xstate_r_reg[2] QDFFRBP $PINS Q=state_r[2] D=n113 CK=CTS_184
+ RB=FE_OFN16_i_rst_n
Xstate_r_reg[0] QDFFRBP $PINS Q=state_r[0] D=n110 CK=CTS_184
+ RB=FE_OFN80_FE_DBTN17_n206
Xstate_r_reg[1] DFFRBT $PINS Q=state_r[1] QB=n244 D=n111 CK=CTS_183
+ RB=FE_OFN16_i_rst_n
Xpe_done_d1_reg QDFFRBN $PINS Q=pe_done_d1 D=FE_PHN1271_N40 CK=CTS_179
+ RB=FE_OFN80_FE_DBTN17_n206
Xdelayed_out3_reg[11] QDFFN $PINS Q=delayed_out3[11] D=pe_i3[0] CK=CTS_149
Xdelayed_out3_reg[12] QDFFN $PINS Q=delayed_out3[12] D=pe_i3[1] CK=CTS_149
Xdelayed_out3_reg[13] QDFFN $PINS Q=delayed_out3[13] D=FE_PHN761_pe_i3_2
+ CK=CTS_149
Xdelayed_out3_reg[14] QDFFN $PINS Q=delayed_out3[14] D=FE_PHN756_pe_i3_3
+ CK=CTS_149
Xdelayed_out3_reg[15] QDFFN $PINS Q=delayed_out3[15] D=pe_i3[4] CK=CTS_149
Xdelayed_out3_reg[16] QDFFN $PINS Q=delayed_out3[16] D=pe_i3[5] CK=CTS_149
Xdelayed_out3_reg[17] QDFFN $PINS Q=delayed_out3[17] D=pe_i3[6] CK=CTS_149
Xdelayed_out3_reg[18] QDFFN $PINS Q=delayed_out3[18] D=pe_i3[7] CK=CTS_149
Xdelayed_out3_reg[19] QDFFN $PINS Q=delayed_out3[19] D=pe_i3[8] CK=CTS_149
Xdelayed_out3_reg[20] QDFFN $PINS Q=delayed_out3[20] D=pe_i3[9] CK=CTS_149
Xdelayed_out3_reg[21] QDFFN $PINS Q=delayed_out3[21] D=FE_PHN733_pe_i3_10
+ CK=CTS_149
Xdelayed_out3_reg[0] QDFFN $PINS Q=delayed_out3[0] D=FE_PHN770_pe_r3_0
+ CK=CTS_149
Xdelayed_out3_reg[1] QDFFN $PINS Q=delayed_out3[1] D=pe_r3[1] CK=CTS_149
Xdelayed_out3_reg[2] QDFFN $PINS Q=delayed_out3[2] D=FE_PHN772_pe_r3_2
+ CK=CTS_149
Xdelayed_out3_reg[3] QDFFN $PINS Q=delayed_out3[3] D=FE_PHN769_pe_r3_3
+ CK=CTS_149
Xdelayed_out3_reg[4] QDFFN $PINS Q=delayed_out3[4] D=FE_PHN771_pe_r3_4
+ CK=CTS_149
Xdelayed_out3_reg[5] QDFFN $PINS Q=delayed_out3[5] D=FE_PHN766_pe_r3_5
+ CK=CTS_149
Xdelayed_out3_reg[6] QDFFN $PINS Q=delayed_out3[6] D=FE_PHN768_pe_r3_6
+ CK=CTS_149
Xdelayed_out3_reg[7] QDFFN $PINS Q=delayed_out3[7] D=FE_PHN764_pe_r3_7
+ CK=CTS_149
Xdelayed_out3_reg[8] QDFFN $PINS Q=delayed_out3[8] D=FE_PHN763_pe_r3_8
+ CK=CTS_149
Xdelayed_out3_reg[9] QDFFN $PINS Q=delayed_out3[9] D=pe_r3[9] CK=CTS_149
Xdelayed_out3_reg[10] QDFFN $PINS Q=delayed_out3[10] D=pe_r3[10] CK=CTS_149
Xdelayed_out2_reg[16] QDFFN $PINS Q=delayed_out2[16] D=pe_i2[5] CK=CTS_152
Xdelayed_out2_reg[17] QDFFN $PINS Q=delayed_out2[17] D=pe_i2[6] CK=CTS_152
Xdelayed_out2_reg[18] QDFFN $PINS Q=delayed_out2[18] D=FE_PHN750_pe_i2_7
+ CK=CTS_152
Xdelayed_out2_reg[19] QDFFN $PINS Q=delayed_out2[19] D=pe_i2[8] CK=CTS_152
Xdelayed_out2_reg[20] QDFFN $PINS Q=delayed_out2[20] D=FE_PHN754_pe_i2_9
+ CK=CTS_152
Xdelayed_out2_reg[21] QDFFN $PINS Q=delayed_out2[21] D=FE_PHN760_pe_i2_10
+ CK=CTS_152
Xdelayed_out2_reg[11] QDFFN $PINS Q=delayed_out2[11] D=FE_PHN762_pe_i2_0
+ CK=CTS_152
Xdelayed_out2_reg[12] QDFFN $PINS Q=delayed_out2[12] D=FE_PHN759_pe_i2_1
+ CK=CTS_152
Xdelayed_out2_reg[13] QDFFN $PINS Q=delayed_out2[13] D=pe_i2[2] CK=CTS_152
Xdelayed_out2_reg[14] QDFFN $PINS Q=delayed_out2[14] D=pe_i2[3] CK=CTS_152
Xdelayed_out2_reg[15] QDFFN $PINS Q=delayed_out2[15] D=pe_i2[4] CK=CTS_152
Xdelayed_out2_reg[0] QDFFN $PINS Q=delayed_out2[0] D=FE_PHN741_pe_r2_0
+ CK=CTS_149
Xdelayed_out2_reg[1] QDFFN $PINS Q=delayed_out2[1] D=pe_r2[1] CK=CTS_152
Xdelayed_out2_reg[2] QDFFN $PINS Q=delayed_out2[2] D=pe_r2[2] CK=CTS_152
Xdelayed_out2_reg[3] QDFFN $PINS Q=delayed_out2[3] D=pe_r2[3] CK=CTS_152
Xdelayed_out2_reg[4] QDFFN $PINS Q=delayed_out2[4] D=pe_r2[4] CK=CTS_152
Xdelayed_out2_reg[5] QDFFN $PINS Q=delayed_out2[5] D=FE_PHN736_pe_r2_5
+ CK=CTS_152
Xdelayed_out2_reg[6] QDFFN $PINS Q=delayed_out2[6] D=pe_r2[6] CK=CTS_152
Xdelayed_out2_reg[7] QDFFN $PINS Q=delayed_out2[7] D=pe_r2[7] CK=CTS_152
Xdelayed_out2_reg[8] QDFFN $PINS Q=delayed_out2[8] D=FE_PHN743_pe_r2_8
+ CK=CTS_152
Xdelayed_out2_reg[9] QDFFN $PINS Q=delayed_out2[9] D=pe_r2[9] CK=CTS_152
Xdelayed_out2_reg[10] QDFFN $PINS Q=delayed_out2[10] D=pe_r2[10] CK=CTS_152
Xc_buf_i_reg[1][16] QDFFN $PINS Q=c_buf_i[1][16] D=pe_i1[16] CK=CTS_164
Xc_buf_r_reg[1][16] QDFFN $PINS Q=c_buf_r[1][16] D=FE_PHN834_pe_r1_16
+ CK=CTS_158
Xc_buf_i_reg[0][16] QDFFN $PINS Q=c_buf_i[0][16] D=FE_PHN816_pe_i0_16
+ CK=CTS_164
Xc_buf_r_reg[0][16] QDFFN $PINS Q=c_buf_r[0][16] D=FE_PHN839_pe_r0_16
+ CK=CTS_176
Xc_buf_i_reg[3][16] QDFFN $PINS Q=c_buf_i[3][16] D=pe_i3[16] CK=CTS_161
Xc_buf_r_reg[3][16] QDFFN $PINS Q=c_buf_r[3][16] D=FE_PHN807_pe_r3_16
+ CK=CTS_155
Xc_buf_i_reg[2][16] QDFFN $PINS Q=c_buf_i[2][16] D=FE_PHN796_pe_i2_16
+ CK=CTS_161
Xc_buf_r_reg[2][16] QDFFN $PINS Q=c_buf_r[2][16] D=FE_PHN801_pe_r2_16
+ CK=CTS_158
Xc_buf_i_reg[1][15] QDFFN $PINS Q=FE_PHN1075_c_buf_i_1_15 D=pe_i1[15]
+ CK=CTS_164
Xc_buf_r_reg[1][15] QDFFN $PINS Q=c_buf_r[1][15] D=FE_PHN831_pe_r1_15
+ CK=CTS_158
Xc_buf_i_reg[0][15] QDFFN $PINS Q=c_buf_i[0][15] D=FE_PHN814_pe_i0_15
+ CK=CTS_164
Xc_buf_r_reg[0][15] QDFFN $PINS Q=c_buf_r[0][15] D=FE_PHN829_pe_r0_15
+ CK=CTS_176
Xc_buf_i_reg[3][15] QDFFN $PINS Q=c_buf_i[3][15] D=FE_PHN783_pe_i3_15
+ CK=CTS_161
Xc_buf_r_reg[3][15] QDFFN $PINS Q=c_buf_r[3][15] D=FE_PHN797_pe_r3_15
+ CK=CTS_155
Xc_buf_i_reg[2][15] QDFFN $PINS Q=c_buf_i[2][15] D=pe_i2[15] CK=CTS_161
Xc_buf_r_reg[2][15] QDFFN $PINS Q=c_buf_r[2][15] D=FE_PHN789_pe_r2_15
+ CK=CTS_158
Xcounter_r_reg[8] QDFFRBN $PINS Q=counter_r[8] D=FE_PHN1218_counter_w_8
+ CK=net1668 RB=FE_OFN80_FE_DBTN17_n206
Xc_buf_i_reg[1][14] QDFFN $PINS Q=c_buf_i[1][14] D=FE_PHN794_pe_i1_14
+ CK=CTS_164
Xc_buf_r_reg[1][14] QDFFN $PINS Q=c_buf_r[1][14] D=FE_PHN833_pe_r1_14
+ CK=CTS_158
Xc_buf_i_reg[0][14] QDFFN $PINS Q=c_buf_i[0][14] D=FE_PHN813_pe_i0_14
+ CK=CTS_164
Xc_buf_r_reg[0][14] QDFFN $PINS Q=c_buf_r[0][14] D=FE_PHN844_pe_r0_14
+ CK=CTS_176
Xc_buf_i_reg[3][14] QDFFN $PINS Q=c_buf_i[3][14] D=FE_PHN786_pe_i3_14
+ CK=CTS_161
Xc_buf_r_reg[3][14] QDFFN $PINS Q=c_buf_r[3][14] D=FE_PHN812_pe_r3_14
+ CK=CTS_155
Xc_buf_i_reg[2][14] QDFFN $PINS Q=c_buf_i[2][14] D=pe_i2[14] CK=CTS_161
Xc_buf_r_reg[2][14] QDFFN $PINS Q=c_buf_r[2][14] D=FE_PHN788_pe_r2_14
+ CK=CTS_158
Xc_buf_i_reg[1][13] QDFFN $PINS Q=c_buf_i[1][13] D=FE_PHN805_pe_i1_13
+ CK=CTS_164
Xc_buf_r_reg[1][13] QDFFN $PINS Q=c_buf_r[1][13] D=FE_PHN836_pe_r1_13
+ CK=CTS_158
Xc_buf_i_reg[0][13] QDFFN $PINS Q=c_buf_i[0][13] D=FE_PHN818_pe_i0_13
+ CK=CTS_164
Xc_buf_r_reg[0][13] QDFFN $PINS Q=c_buf_r[0][13] D=FE_PHN841_pe_r0_13
+ CK=CTS_176
Xc_buf_i_reg[3][13] QDFFN $PINS Q=c_buf_i[3][13] D=pe_i3[13] CK=CTS_161
Xc_buf_r_reg[3][13] QDFFN $PINS Q=c_buf_r[3][13] D=pe_r3[13] CK=CTS_155
Xc_buf_i_reg[2][13] QDFFN $PINS Q=c_buf_i[2][13] D=FE_PHN798_pe_i2_13
+ CK=CTS_161
Xc_buf_r_reg[2][13] QDFFN $PINS Q=c_buf_r[2][13] D=FE_PHN800_pe_r2_13
+ CK=CTS_158
Xc_buf_i_reg[1][12] QDFFN $PINS Q=c_buf_i[1][12] D=pe_i1[12] CK=CTS_164
Xc_buf_r_reg[1][12] QDFFN $PINS Q=c_buf_r[1][12] D=FE_PHN843_pe_r1_12
+ CK=CTS_158
Xc_buf_i_reg[0][12] QDFFN $PINS Q=c_buf_i[0][12] D=FE_PHN817_pe_i0_12
+ CK=CTS_164
Xc_buf_r_reg[0][12] QDFFN $PINS Q=c_buf_r[0][12] D=FE_PHN830_pe_r0_12
+ CK=CTS_176
Xc_buf_i_reg[3][12] QDFFN $PINS Q=c_buf_i[3][12] D=pe_i3[12] CK=CTS_176
Xc_buf_r_reg[3][12] QDFFN $PINS Q=c_buf_r[3][12] D=pe_r3[12] CK=CTS_155
Xc_buf_i_reg[2][12] QDFFN $PINS Q=c_buf_i[2][12] D=FE_PHN795_pe_i2_12
+ CK=CTS_161
Xc_buf_r_reg[2][12] QDFFN $PINS Q=c_buf_r[2][12] D=FE_PHN810_pe_r2_12
+ CK=CTS_158
Xc_buf_i_reg[1][11] QDFFN $PINS Q=FE_PHN1083_c_buf_i_1_11 D=pe_i1[11]
+ CK=CTS_164
Xc_buf_r_reg[1][11] QDFFN $PINS Q=c_buf_r[1][11] D=FE_PHN845_pe_r1_11
+ CK=CTS_158
Xc_buf_i_reg[0][11] QDFFN $PINS Q=c_buf_i[0][11] D=FE_PHN815_pe_i0_11
+ CK=CTS_164
Xc_buf_r_reg[0][11] QDFFN $PINS Q=c_buf_r[0][11] D=FE_PHN838_pe_r0_11
+ CK=CTS_176
Xc_buf_i_reg[3][11] QDFFN $PINS Q=c_buf_i[3][11] D=pe_i3[11] CK=CTS_176
Xc_buf_r_reg[3][11] QDFFN $PINS Q=c_buf_r[3][11] D=FE_PHN811_pe_r3_11
+ CK=CTS_155
Xc_buf_i_reg[2][11] QDFFN $PINS Q=c_buf_i[2][11] D=FE_PHN792_pe_i2_11
+ CK=CTS_161
Xc_buf_r_reg[2][11] QDFFN $PINS Q=c_buf_r[2][11] D=FE_PHN785_pe_r2_11
+ CK=CTS_158
Xc_buf_i_reg[1][10] QDFFN $PINS Q=FE_PHN1085_c_buf_i_1_10 D=FE_PHN822_pe_i1_10
+ CK=CTS_164
Xc_buf_r_reg[1][10] QDFFN $PINS Q=c_buf_r[1][10] D=FE_PHN1128_pe_r1_10
+ CK=CTS_158
Xc_buf_i_reg[0][10] QDFFN $PINS Q=c_buf_i[0][10] D=FE_PHN828_pe_i0_10
+ CK=CTS_164
Xc_buf_r_reg[0][10] QDFFN $PINS Q=c_buf_r[0][10] D=FE_PHN861_pe_r0_10
+ CK=CTS_176
Xc_buf_i_reg[3][10] QDFFN $PINS Q=FE_PHN1090_c_buf_i_3_10 D=FE_PHN733_pe_i3_10
+ CK=CTS_176
Xc_buf_r_reg[3][10] QDFFN $PINS Q=c_buf_r[3][10] D=pe_r3[10] CK=CTS_155
Xc_buf_i_reg[2][10] QDFFN $PINS Q=c_buf_i[2][10] D=FE_PHN760_pe_i2_10
+ CK=CTS_161
Xc_buf_r_reg[2][10] QDFFN $PINS Q=c_buf_r[2][10] D=pe_r2[10] CK=CTS_158
Xc_buf_i_reg[1][9] QDFFN $PINS Q=FE_PHN1088_c_buf_i_1_9 D=FE_PHN823_pe_i1_9
+ CK=CTS_164
Xc_buf_r_reg[1][9] QDFFN $PINS Q=c_buf_r[1][9] D=FE_PHN1129_pe_r1_9 CK=CTS_158
Xc_buf_i_reg[0][9] QDFFN $PINS Q=c_buf_i[0][9] D=FE_PHN820_pe_i0_9 CK=CTS_164
Xc_buf_r_reg[0][9] QDFFN $PINS Q=c_buf_r[0][9] D=FE_PHN915_pe_r0_9 CK=CTS_176
Xc_buf_i_reg[3][9] QDFFN $PINS Q=c_buf_i[3][9] D=pe_i3[9] CK=CTS_176
Xc_buf_r_reg[3][9] QDFFN $PINS Q=c_buf_r[3][9] D=pe_r3[9] CK=CTS_155
Xc_buf_i_reg[2][9] QDFFN $PINS Q=c_buf_i[2][9] D=FE_PHN754_pe_i2_9 CK=CTS_161
Xc_buf_r_reg[2][9] QDFFN $PINS Q=c_buf_r[2][9] D=pe_r2[9] CK=CTS_155
Xc_buf_i_reg[1][8] QDFFN $PINS Q=c_buf_i[1][8] D=FE_PHN840_pe_i1_8 CK=CTS_164
Xc_buf_r_reg[1][8] QDFFN $PINS Q=c_buf_r[1][8] D=FE_PHN1119_pe_r1_8 CK=CTS_158
Xc_buf_i_reg[0][8] QDFFN $PINS Q=c_buf_i[0][8] D=FE_PHN825_pe_i0_8 CK=CTS_164
Xc_buf_r_reg[0][8] QDFFN $PINS Q=c_buf_r[0][8] D=FE_PHN872_pe_r0_8 CK=CTS_176
Xc_buf_i_reg[3][8] QDFFN $PINS Q=c_buf_i[3][8] D=pe_i3[8] CK=CTS_176
Xc_buf_r_reg[3][8] QDFFN $PINS Q=c_buf_r[3][8] D=FE_PHN763_pe_r3_8 CK=CTS_155
Xc_buf_i_reg[2][8] QDFFN $PINS Q=c_buf_i[2][8] D=pe_i2[8] CK=CTS_161
Xc_buf_r_reg[2][8] QDFFN $PINS Q=c_buf_r[2][8] D=FE_PHN743_pe_r2_8 CK=CTS_155
Xc_buf_i_reg[1][7] QDFFN $PINS Q=c_buf_i[1][7] D=pe_i1[7] CK=CTS_164
Xc_buf_r_reg[1][7] QDFFN $PINS Q=c_buf_r[1][7] D=pe_r1[7] CK=CTS_158
Xc_buf_i_reg[0][7] QDFFN $PINS Q=c_buf_i[0][7] D=FE_PHN821_pe_i0_7 CK=CTS_164
Xc_buf_r_reg[0][7] QDFFN $PINS Q=c_buf_r[0][7] D=FE_PHN856_pe_r0_7 CK=CTS_176
Xc_buf_i_reg[3][7] QDFFN $PINS Q=c_buf_i[3][7] D=pe_i3[7] CK=CTS_176
Xc_buf_r_reg[3][7] QDFFN $PINS Q=c_buf_r[3][7] D=FE_PHN764_pe_r3_7 CK=CTS_155
Xc_buf_i_reg[2][7] QDFFN $PINS Q=c_buf_i[2][7] D=FE_PHN750_pe_i2_7 CK=CTS_161
Xc_buf_r_reg[2][7] QDFFN $PINS Q=c_buf_r[2][7] D=pe_r2[7] CK=CTS_155
Xkey_r_reg[7] QDFFRBN $PINS Q=key_r[7] D=key_w[7] CK=net1663
+ RB=FE_OFN13_i_rst_n
Xc_buf_i_reg[1][6] QDFFN $PINS Q=c_buf_i[1][6] D=FE_PHN1113_pe_i1_6 CK=CTS_164
Xc_buf_r_reg[1][6] QDFFN $PINS Q=c_buf_r[1][6] D=FE_PHN1122_pe_r1_6 CK=CTS_158
Xc_buf_i_reg[0][6] QDFFN $PINS Q=c_buf_i[0][6] D=FE_PHN842_pe_i0_6 CK=CTS_164
Xc_buf_r_reg[0][6] QDFFN $PINS Q=c_buf_r[0][6] D=FE_PHN851_pe_r0_6 CK=CTS_176
Xc_buf_i_reg[3][6] QDFFN $PINS Q=c_buf_i[3][6] D=pe_i3[6] CK=CTS_176
Xc_buf_r_reg[3][6] QDFFN $PINS Q=c_buf_r[3][6] D=FE_PHN768_pe_r3_6 CK=CTS_155
Xc_buf_i_reg[2][6] QDFFN $PINS Q=c_buf_i[2][6] D=pe_i2[6] CK=CTS_161
Xc_buf_r_reg[2][6] QDFFN $PINS Q=c_buf_r[2][6] D=pe_r2[6] CK=CTS_155
Xc_buf_i_reg[1][5] QDFFN $PINS Q=c_buf_i[1][5] D=FE_PHN1112_pe_i1_5 CK=CTS_161
Xc_buf_r_reg[1][5] QDFFN $PINS Q=c_buf_r[1][5] D=pe_r1[5] CK=CTS_158
Xc_buf_i_reg[0][5] QDFFN $PINS Q=c_buf_i[0][5] D=FE_PHN832_pe_i0_5 CK=CTS_164
Xc_buf_r_reg[0][5] QDFFN $PINS Q=c_buf_r[0][5] D=FE_PHN855_pe_r0_5 CK=CTS_176
Xc_buf_i_reg[3][5] QDFFN $PINS Q=c_buf_i[3][5] D=pe_i3[5] CK=CTS_176
Xc_buf_r_reg[3][5] QDFFN $PINS Q=c_buf_r[3][5] D=FE_PHN766_pe_r3_5 CK=CTS_155
Xc_buf_i_reg[2][5] QDFFN $PINS Q=c_buf_i[2][5] D=pe_i2[5] CK=CTS_161
Xc_buf_r_reg[2][5] QDFFN $PINS Q=c_buf_r[2][5] D=FE_PHN736_pe_r2_5 CK=CTS_155
Xc_buf_i_reg[1][4] QDFFN $PINS Q=c_buf_i[1][4] D=FE_PHN1116_pe_i1_4 CK=CTS_161
Xc_buf_r_reg[1][4] QDFFN $PINS Q=c_buf_r[1][4] D=FE_PHN1124_pe_r1_4 CK=CTS_158
Xc_buf_i_reg[0][4] QDFFN $PINS Q=FE_PHN1102_c_buf_i_0_4 D=FE_PHN846_pe_i0_4
+ CK=CTS_164
Xc_buf_r_reg[0][4] QDFFN $PINS Q=c_buf_r[0][4] D=FE_PHN853_pe_r0_4 CK=CTS_176
Xc_buf_i_reg[3][4] QDFFN $PINS Q=c_buf_i[3][4] D=pe_i3[4] CK=CTS_176
Xc_buf_r_reg[3][4] QDFFN $PINS Q=c_buf_r[3][4] D=FE_PHN771_pe_r3_4 CK=CTS_155
Xc_buf_i_reg[2][4] QDFFN $PINS Q=c_buf_i[2][4] D=pe_i2[4] CK=CTS_161
Xc_buf_r_reg[2][4] QDFFN $PINS Q=c_buf_r[2][4] D=pe_r2[4] CK=CTS_155
Xc_buf_i_reg[1][3] QDFFN $PINS Q=c_buf_i[1][3] D=pe_i1[3] CK=CTS_161
Xc_buf_r_reg[1][3] QDFFN $PINS Q=c_buf_r[1][3] D=FE_PHN1123_pe_r1_3 CK=CTS_158
Xc_buf_i_reg[0][3] QDFFN $PINS Q=c_buf_i[0][3] D=FE_PHN837_pe_i0_3 CK=CTS_164
Xc_buf_r_reg[0][3] QDFFN $PINS Q=c_buf_r[0][3] D=FE_PHN850_pe_r0_3 CK=CTS_176
Xc_buf_i_reg[3][3] QDFFN $PINS Q=c_buf_i[3][3] D=FE_PHN756_pe_i3_3 CK=CTS_176
Xc_buf_r_reg[3][3] QDFFN $PINS Q=c_buf_r[3][3] D=FE_PHN769_pe_r3_3 CK=CTS_155
Xc_buf_i_reg[2][3] QDFFN $PINS Q=c_buf_i[2][3] D=pe_i2[3] CK=CTS_161
Xc_buf_r_reg[2][3] QDFFN $PINS Q=c_buf_r[2][3] D=pe_r2[3] CK=CTS_155
Xkey_r_reg[6] QDFFRBN $PINS Q=key_r[6] D=key_w[6] CK=net1663
+ RB=FE_OFN13_i_rst_n
Xc_buf_i_reg[1][2] QDFFN $PINS Q=c_buf_i[1][2] D=FE_PHN1117_pe_i1_2 CK=CTS_161
Xc_buf_r_reg[1][2] QDFFN $PINS Q=c_buf_r[1][2] D=FE_PHN1120_pe_r1_2 CK=CTS_158
Xc_buf_i_reg[0][2] QDFFN $PINS Q=c_buf_i[0][2] D=FE_PHN847_pe_i0_2 CK=CTS_164
Xc_buf_r_reg[0][2] QDFFN $PINS Q=c_buf_r[0][2] D=FE_PHN852_pe_r0_2 CK=CTS_158
Xc_buf_i_reg[3][2] QDFFN $PINS Q=c_buf_i[3][2] D=FE_PHN761_pe_i3_2 CK=CTS_176
Xc_buf_r_reg[3][2] QDFFN $PINS Q=c_buf_r[3][2] D=FE_PHN772_pe_r3_2 CK=CTS_155
Xc_buf_i_reg[2][2] QDFFN $PINS Q=c_buf_i[2][2] D=pe_i2[2] CK=CTS_161
Xc_buf_r_reg[2][2] QDFFN $PINS Q=c_buf_r[2][2] D=pe_r2[2] CK=CTS_155
Xkey_r_reg[5] QDFFRBN $PINS Q=key_r[5] D=key_w[5] CK=net1663 RB=FE_OFN9_i_rst_n
Xc_buf_i_reg[1][1] QDFFN $PINS Q=c_buf_i[1][1] D=pe_i1[1] CK=CTS_161
Xc_buf_r_reg[1][1] QDFFN $PINS Q=c_buf_r[1][1] D=FE_PHN1126_pe_r1_1 CK=CTS_158
Xc_buf_i_reg[0][1] QDFFN $PINS Q=c_buf_i[0][1] D=FE_PHN819_pe_i0_1 CK=CTS_164
Xc_buf_r_reg[0][1] QDFFN $PINS Q=c_buf_r[0][1] D=FE_PHN849_pe_r0_1 CK=CTS_158
Xc_buf_i_reg[3][1] QDFFN $PINS Q=c_buf_i[3][1] D=pe_i3[1] CK=CTS_176
Xc_buf_r_reg[3][1] QDFFN $PINS Q=c_buf_r[3][1] D=pe_r3[1] CK=CTS_155
Xc_buf_i_reg[2][1] QDFFN $PINS Q=c_buf_i[2][1] D=FE_PHN759_pe_i2_1 CK=CTS_161
Xc_buf_r_reg[2][1] QDFFN $PINS Q=c_buf_r[2][1] D=pe_r2[1] CK=CTS_155
Xc_buf_i_reg[1][0] QDFFN $PINS Q=c_buf_i[1][0] D=FE_PHN826_pe_i1_0 CK=CTS_161
Xc_buf_r_reg[1][0] QDFFN $PINS Q=c_buf_r[1][0] D=FE_PHN1127_pe_r1_0 CK=CTS_158
Xc_buf_i_reg[0][0] QDFFN $PINS Q=c_buf_i[0][0] D=FE_PHN835_pe_i0_0 CK=CTS_164
Xc_buf_r_reg[0][0] QDFFN $PINS Q=c_buf_r[0][0] D=FE_PHN854_pe_r0_0 CK=CTS_158
Xc_buf_i_reg[3][0] QDFFN $PINS Q=c_buf_i[3][0] D=pe_i3[0] CK=CTS_176
Xc_buf_r_reg[3][0] QDFFN $PINS Q=c_buf_r[3][0] D=FE_PHN770_pe_r3_0 CK=CTS_155
Xc_buf_i_reg[2][0] QDFFN $PINS Q=c_buf_i[2][0] D=FE_PHN762_pe_i2_0 CK=CTS_161
Xc_buf_r_reg[2][0] QDFFN $PINS Q=c_buf_r[2][0] D=FE_PHN741_pe_r2_0 CK=CTS_155
Xkey_r_reg[4] QDFFRBN $PINS Q=key_r[4] D=FE_PHN1181_key_w_4 CK=net1663
+ RB=FE_OFN85_FE_DBTN17_n206
Xkey_r_reg[3] QDFFRBN $PINS Q=key_r[3] D=key_w[3] CK=net1663
+ RB=FE_OFN85_FE_DBTN17_n206
Xkey_r_reg[2] QDFFRBN $PINS Q=key_r[2] D=key_w[2] CK=net1663
+ RB=FE_OFN85_FE_DBTN17_n206
Xkey_r_reg[1] QDFFRBN $PINS Q=key_r[1] D=key_w[1] CK=net1663
+ RB=FE_OFN85_FE_DBTN17_n206
Xkey_r_reg[0] QDFFRBN $PINS Q=key_r[0] D=key_w[0] CK=net1663
+ RB=FE_OFN83_FE_DBTN17_n206
Xpe_done_d2_reg QDFFRBN $PINS Q=pe_done_d2 D=N42 CK=CTS_181
+ RB=FE_OFN80_FE_DBTN17_n206
Xc_start_reg QDFFRBN $PINS Q=c_start D=N55 CK=CTS_185
+ RB=FE_OFN82_FE_DBTN17_n206
Xcounter_r_reg[7] QDFFRBN $PINS Q=FE_PHN1171_current_g_2 D=counter_w[7]
+ CK=net1668 RB=FE_OFN80_FE_DBTN17_n206
Xcounter_r_reg[5] QDFFRBN $PINS Q=current_g[0] D=counter_w[5] CK=net1668
+ RB=FE_OFN80_FE_DBTN17_n206
Xcounter_r_reg[6] QDFFRBN $PINS Q=current_g[1] D=counter_w[6] CK=net1668
+ RB=FE_OFN80_FE_DBTN17_n206
Xo_counter_r_reg[2] QDFFRBN $PINS Q=o_counter_r[2] D=o_counter_w[2] CK=net1658
+ RB=FE_OFN80_FE_DBTN17_n206
Xo_counter_r_reg[5] QDFFRBN $PINS Q=o_counter_r[5] D=FE_PHN1414_o_counter_w_5
+ CK=net1658 RB=FE_OFN80_FE_DBTN17_n206
Xo_counter_r_reg[1] QDFFRBN $PINS Q=FE_PHN1143_o_counter_r_1 D=o_counter_w[1]
+ CK=net1658 RB=FE_OFN80_FE_DBTN17_n206
Xo_counter_r_reg[4] QDFFRBN $PINS Q=o_counter_r[4] D=FE_PHN1412_o_counter_w_4
+ CK=net1658 RB=FE_OFN80_FE_DBTN17_n206
Xo_state_r_reg QDFFRBN $PINS Q=o_state_r D=FE_PHN1422_n112 CK=CTS_183
+ RB=FE_OFN80_FE_DBTN17_n206
Xo_counter_r_reg[3] QDFFRBN $PINS Q=o_counter_r[3] D=FE_PHN1409_o_counter_w_3
+ CK=net1658 RB=FE_OFN80_FE_DBTN17_n206
Xo_counter_r_reg[0] QDFFRBN $PINS Q=o_counter_r[0] D=o_counter_w[0] CK=net1658
+ RB=FE_OFN80_FE_DBTN17_n206
Xcounter_r_reg[2] QDFFRBN $PINS Q=current_n[2] D=FE_PHN1355_counter_w_2
+ CK=net1668 RB=FE_OFN80_FE_DBTN17_n206
Xcounter_r_reg[4] QDFFRBN $PINS Q=current_n[4] D=counter_w[4] CK=net1668
+ RB=FE_OFN80_FE_DBTN17_n206
Xcounter_r_reg[3] QDFFRBN $PINS Q=current_n[3] D=counter_w[3] CK=net1668
+ RB=FE_OFN80_FE_DBTN17_n206
Xcounter_r_reg[0] QDFFRBN $PINS Q=current_n[0] D=counter_w[0] CK=net1668
+ RB=FE_OFN80_FE_DBTN17_n206
Xcounter_r_reg[1] QDFFRBN $PINS Q=current_n[1] D=counter_w[1] CK=net1668
+ RB=FE_OFN80_FE_DBTN17_n206
Xdelayed_mac_group_reg[0] QDFFN $PINS Q=delayed_mac_group[0] D=g_cnt_d3[0]
+ CK=CTS_152
Xdelayed_mac_group_reg[2] QDFFN $PINS Q=delayed_mac_group[2] D=g_cnt_d3[2]
+ CK=CTS_152
Xdelayed_mac_group_reg[1] QDFFN $PINS Q=delayed_mac_group[1] D=g_cnt_d3[1]
+ CK=CTS_152
Xg_cnt_d3_reg[0] QDFFRBN $PINS Q=FE_PHN1164_g_cnt_d3_0 D=g_cnt_d2[0] CK=net1618
+ RB=FE_OFN16_i_rst_n
Xg_cnt_d3_reg[1] QDFFRBN $PINS Q=FE_PHN1166_g_cnt_d3_1 D=g_cnt_d2[1] CK=net1618
+ RB=FE_OFN80_FE_DBTN17_n206
Xg_cnt_d3_reg[2] QDFFRBN $PINS Q=FE_PHN1165_g_cnt_d3_2 D=g_cnt_d2[2] CK=net1618
+ RB=FE_OFN80_FE_DBTN17_n206
Xc_group_idx_reg[1] QDFFRBN $PINS Q=c_group_idx[1] D=FE_PHN1273_n106 CK=CTS_185
+ RB=FE_OFN83_FE_DBTN17_n206
Xc_group_idx_reg[2] QDFFRBN $PINS Q=c_group_idx[2] D=FE_PHN1289_n105 CK=CTS_185
+ RB=FE_OFN83_FE_DBTN17_n206
Xc_group_idx_reg[0] QDFFRBN $PINS Q=c_group_idx[0] D=FE_PHN1276_n107 CK=CTS_185
+ RB=FE_OFN83_FE_DBTN17_n206
Xc_state_reg[0] QDFFRBN $PINS Q=c_state[0] D=n108 CK=CTS_185
+ RB=FE_OFN84_FE_DBTN17_n206
Xrf_io_write_delay_reg QDFFRBN $PINS Q=rf_io_write_delay D=n238 CK=CTS_192
+ RB=FE_OFN80_FE_DBTN17_n206
Xc_state_reg[1] QDFFRBN $PINS Q=c_state[1] D=FE_PHN1178_n109 CK=CTS_185
+ RB=FE_OFN84_FE_DBTN17_n206
Xmac_valid_out_r_reg QDFFRBN $PINS Q=mac_valid_out_r D=N43 CK=CTS_192
+ RB=FE_OFN80_FE_DBTN17_n206
Xg_cnt_d1_reg[0] QDFFRBN $PINS Q=g_cnt_d1[0] D=FE_PHN1172_current_g_0
+ CK=net1618 RB=FE_OFN80_FE_DBTN17_n206
Xg_cnt_d2_reg[0] QDFFRBN $PINS Q=FE_PHN780_g_cnt_d2_0 D=FE_PHN782_g_cnt_d1_0
+ CK=net1618 RB=FE_OFN80_FE_DBTN17_n206
Xg_cnt_d1_reg[1] QDFFRBN $PINS Q=g_cnt_d1[1] D=FE_PHN1170_current_g_1
+ CK=net1618 RB=FE_OFN80_FE_DBTN17_n206
Xg_cnt_d2_reg[1] QDFFRBN $PINS Q=FE_PHN779_g_cnt_d2_1 D=FE_PHN777_g_cnt_d1_1
+ CK=net1618 RB=FE_OFN80_FE_DBTN17_n206
Xg_cnt_d1_reg[2] QDFFRBN $PINS Q=g_cnt_d1[2] D=current_g[2] CK=net1618
+ RB=FE_OFN80_FE_DBTN17_n206
Xg_cnt_d2_reg[2] QDFFRBN $PINS Q=FE_PHN781_g_cnt_d2_2 D=FE_PHN778_g_cnt_d1_2
+ CK=net1618 RB=FE_OFN80_FE_DBTN17_n206
Xpe_clear_d1_reg QDFFRBN $PINS Q=pe_clear_d1 D=N39 CK=CTS_192
+ RB=FE_OFN80_FE_DBTN17_n206
XU334 ND3P $PINS O=n140 I1=n150 I2=FE_DBTN9_state_r_0 I3=state_r[1]
XU338 MUX2 $PINS O=c_in_r_1[14] S=FE_OFN87_FE_DBTN10_n114
+ A=FE_PHN1472_c_buf_r_3_14 B=c_buf_r[1][14]
XU339 OR3P $PINS O=n64 I1=FE_PHN1175_state_r_2 I2=n244 I3=FE_DBTN9_state_r_0
XU340 MUX2 $PINS O=c_in_r_1[15] S=FE_OFN87_FE_DBTN10_n114 A=c_buf_r[3][15]
+ B=c_buf_r[1][15]
XU341 MUX2 $PINS O=FE_PHN1279_c_in_r_1_16 S=FE_OFN87_FE_DBTN10_n114
+ A=c_buf_r[3][16] B=c_buf_r[1][16]
XU342 MUX2 $PINS O=c_in_i_0[10] S=FE_OFN33_n114 A=c_buf_i[2][10]
+ B=FE_PHN1095_c_buf_i_0_10
XU343 MUX2 $PINS O=c_in_i_0[15] S=FE_OFN33_n114 A=c_buf_i[2][15]
+ B=c_buf_i[0][15]
XU344 ND2 $PINS O=n83 I1=FE_RN_108_0 I2=rf_io_rdata_1[7]
XU345 NR2 $PINS O=sub_135/carry_10 I1=phase_1[8] I2=N77
XU346 NR2 $PINS O=sub_134/carry[11] I1=phase_0[9] I2=N70
XU347 MUX2 $PINS O=c_in_i_0[11] S=FE_OFN33_n114 A=c_buf_i[2][11]
+ B=c_buf_i[0][11]
XU348 AN4B1S $PINS O=n75 I1=FE_PHN1173_current_n_1 I2=current_n[0] I3=n100
+ B1=n98
XU349 ND3HT $PINS O=n138 I1=FE_DBTN9_state_r_0 I2=n150 I3=state_r[1]
XU355 INV1S $PINS O=n144 I=n138
XU358 MOAI1H $PINS O=mac_in_imag[2] A1=n138 A2=n223 B1=n122 B2=rf_d_rdata_1[19]
XU361 INV2 $PINS O=n139 I=rf_io_rdata_1[11]
XU367 MOAI1S $PINS O=rf_io_waddr_2[3] A1=n61 A2=n261 B1=rf_io_waddr_2[1]
+ B2=delayed_mac_group[1]
XU368 MOAI1S $PINS O=rf_io_waddr_2[4] A1=n61 A2=n264 B1=rf_io_waddr_2[1]
+ B2=delayed_mac_group[2]
XU370 INV1S $PINS O=n221 I=N74
XU378 AN2 $PINS O=n114 I1=c_state[0] I2=n267
XU385 MOAI1 $PINS O=o_data[3] A1=FE_OFN35_o_counter_r_0 A2=n230
+ B1=rf_io_rdata_1[14] B2=FE_OFN35_o_counter_r_0
XU388 MOAI1 $PINS O=o_data[4] A1=FE_OFN35_o_counter_r_0 A2=n229
+ B1=rf_io_rdata_1[15] B2=FE_OFN35_o_counter_r_0
XU393 ND3P $PINS O=n122 I1=FE_DBTN9_state_r_0 I2=n150 I3=state_r[1]
XU394 MOAI1HP $PINS O=mac_in_real[2] A1=n231 A2=n138 B1=n72 B2=rf_d_rdata_1[2]
XU395 ND3HT $PINS O=n72 I1=FE_DBTN9_state_r_0 I2=n150 I3=state_r[1]
XU396 AO22 $PINS O=mac_in_imag[4] A1=n144 A2=rf_io_rdata_1[12] B1=n72
+ B2=rf_d_rdata_1[21]
XU399 MOAI1HT $PINS O=o_data[2] A1=FE_OFN35_o_counter_r_0 A2=n231
+ B1=rf_io_rdata_1[13] B2=FE_OFN35_o_counter_r_0
XU400 MOAI1HT $PINS O=o_data[9] A1=FE_OFN35_o_counter_r_0 A2=n224
+ B1=rf_io_rdata_1[20] B2=FE_OFN35_o_counter_r_0
XU401 MOAI1HT $PINS O=o_data[8] A1=FE_OFN35_o_counter_r_0
+ A2=FE_OFN346_rf_io_rdata_1_8 B1=rf_io_rdata_1[19] B2=FE_OFN35_o_counter_r_0
XU402 MOAI1HT $PINS O=o_data[7] A1=FE_OFN35_o_counter_r_0 A2=n226
+ B1=rf_io_rdata_1[18] B2=FE_OFN35_o_counter_r_0
XU403 MOAI1HT $PINS O=o_data[6] A1=FE_OFN35_o_counter_r_0 A2=n227
+ B1=rf_io_rdata_1[17] B2=FE_OFN35_o_counter_r_0
XU404 AO12 $PINS O=mac_in_imag[8] A1=n84 B1=rf_d_rdata_1[25] B2=FE_OFN347_n164
XU405 AO12 $PINS O=mac_in_imag[11] A1=n84 B1=rf_d_rdata_1[28] B2=FE_OFN347_n164
XU406 AO12 $PINS O=mac_in_real[13] A1=FE_DBTN13_n83 B1=rf_d_rdata_1[13]
+ B2=FE_OFN347_n164
XU407 MOAI1HT $PINS O=o_data[10] A1=FE_OFN35_o_counter_r_0 A2=n223
+ B1=rf_io_rdata_1[21] B2=FE_OFN35_o_counter_r_0
XU409 OA222S $PINS O=n90 A1=n75 A2=n168 B1=n74 B2=n72 C1=n64 C2=n93
XU412 INV1S $PINS O=o_valid I=n246
XU413 MOAI1HT $PINS O=o_data[5] A1=FE_OFN35_o_counter_r_0 A2=n228
+ B1=rf_io_rdata_1[16] B2=FE_OFN35_o_counter_r_0
XU417 OA112S $PINS O=n76 A1=n72 B1=n77 C1=n239 C2=n64
XU420 AO12 $PINS O=mac_in_imag[15] A1=n84 B1=rf_d_rdata_1[32] B2=FE_OFN347_n164
XU421 AO12 $PINS O=mac_in_imag[16] A1=n84 B1=rf_d_rdata_1[33] B2=FE_OFN347_n164
XU422 AO12 $PINS O=mac_in_imag[14] A1=n84 B1=rf_d_rdata_1[31] B2=FE_OFN347_n164
XU423 AO12 $PINS O=mac_in_imag[13] A1=n84 B1=rf_d_rdata_1[30] B2=FE_OFN347_n164
XU424 AO12 $PINS O=mac_in_imag[12] A1=n84 B1=rf_d_rdata_1[29] B2=FE_OFN347_n164
XU425 AO12 $PINS O=mac_in_imag[10] A1=n84 B1=rf_d_rdata_1[27] B2=FE_OFN347_n164
XU426 AO12 $PINS O=mac_in_imag[9] A1=n84 B1=FE_OFN347_n164 B2=rf_d_rdata_1[26]
XU427 AO12 $PINS O=mac_in_imag[7] A1=n84 B1=FE_OFN347_n164 B2=rf_d_rdata_1[24]
XU429 MOAI1HT $PINS O=o_data[1] A1=FE_OFN35_o_counter_r_0 A2=n232
+ B1=rf_io_rdata_1[12] B2=FE_OFN35_o_counter_r_0
XU430 AN2 $PINS O=n68 I1=FE_RN_108_0 I2=mac_valid_out_r
XU435 NR2P $PINS O=i_ready I1=n87 I2=n88
XU436 MOAI1HT $PINS O=o_data[0] A1=FE_OFN35_o_counter_r_0 A2=n233
+ B1=rf_io_rdata_1[11] B2=FE_OFN35_o_counter_r_0
XU438 NR2P $PINS O=n141 I1=n88 I2=FE_DBTN9_state_r_0
XU439 ND3S $PINS O=k_ord_1[0] I1=c_group_idx[2] I2=FE_OFN32_n114 I3=n86
XU440 AO22S $PINS O=c_in_i_0[0] A1=c_buf_i[2][0] A2=FE_DBTN10_n114
+ B1=c_buf_i[0][0] B2=FE_OFN33_n114
XU442 AO22S $PINS O=FE_PHN1390_c_in_i_0_12 A1=c_buf_i[2][12] A2=FE_DBTN10_n114
+ B1=FE_PHN1087_c_buf_i_0_12 B2=FE_OFN33_n114
XU443 AO22S $PINS O=c_in_i_0[13] A1=c_buf_i[2][13] A2=FE_DBTN10_n114
+ B1=c_buf_i[0][13] B2=FE_OFN33_n114
XU462 XOR2HS $PINS O=phase_0[15] I1=N75 I2=n142
XU463 ND2 $PINS O=n142 I1=sub_134/carry[14] I2=n221
XU466 INV1S $PINS O=n243 I=n82
XU471 INV1S $PINS O=n168 I=n141
XU473 NR2 $PINS O=k_ord_1[1] I1=FE_DBTN4_k_ord_1_0 I2=FE_OFN33_n114
XU474 INV1S $PINS O=n214 I=N82
XU475 INV1S $PINS O=n213 I=N81
XU476 INV1S $PINS O=n212 I=N80
XU477 INV1S $PINS O=n211 I=N79
XU478 INV1S $PINS O=n210 I=N78
XU479 INV1S $PINS O=n209 I=N77
XU481 INV1S $PINS O=n220 I=N73
XU482 INV1S $PINS O=n219 I=N72
XU484 INV1S $PINS O=n218 I=N71
XU485 INV1S $PINS O=n217 I=N70
XU486 NR3 $PINS O=n82 I1=n85 I2=mac_en I3=n141
XU497 MOAI1S $PINS O=o_counter_w[0] A1=n198 A2=n65 B1=n198 B2=n66
XU505 AN2 $PINS O=rf_io_waddr_2[1] I1=n60 I2=FE_OFN0_FE_DBTN15_n64
XU507 NR2 $PINS O=rf_io_waddr_1[0] I1=n168 I2=FE_DBTN16_current_n_0
XU508 OR2 $PINS O=rf_io_wen_1 I1=rf_io_wen_2 I2=n141
XU509 ND3 $PINS O=N286 I1=n103 I2=n235 I3=FE_PHN1406_o_state_r
XU510 NR2 $PINS O=n104 I1=n85 I2=n141
XU512 NR2 $PINS O=N87 I1=n206 I2=FE_PHN1266_n61
XU513 INV1S $PINS O=n198 I=FE_OFN35_o_counter_r_0
XU516 NR2 $PINS O=k_ord_1[3] I1=FE_DBTN4_k_ord_1_0 I2=FE_DBTN1_c_group_idx_1
XU517 NR2 $PINS O=k_ord_1[2] I1=FE_DBTN4_k_ord_1_0 I2=FE_DBTN3_c_group_idx_0
XU518 INV1S $PINS O=n246 I=FE_PHN1406_o_state_r
XU520 NR2 $PINS O=N61 I1=FE_DBTN14_n68 I2=n206
XU521 INV1S $PINS O=n237 I=n74
XU522 OA12 $PINS O=n71 A1=n76 B1=n75 B2=n168
XU523 MOAI1S $PINS O=rf_io_raddr_1[4] A1=n259 A2=n62 B1=N258 B2=o_state_r
XU524 MOAI1S $PINS O=rf_io_raddr_1[0] A1=FE_DBTN16_current_n_0 A2=n62
+ B1=o_state_r B2=N254
XU525 MOAI1S $PINS O=rf_io_raddr_1[3] A1=n258 A2=n62 B1=o_state_r B2=N257
XU526 AOI13HS $PINS O=n89 A1=n82 B1=FE_OFN0_FE_DBTN15_n64 B2=FE_PHN1089_n91
+ B3=n92
XU527 MOAI1S $PINS O=counter_w[7] A1=n89 A2=FE_DBTN0_current_g_2 B1=N112
+ B2=FE_DBTN11_n90
XU528 MOAI1S $PINS O=counter_w[6] A1=n89 A2=FE_DBTN2_current_g_1 B1=N111
+ B2=FE_DBTN11_n90
XU529 MOAI1S $PINS O=counter_w[5] A1=n89 A2=FE_DBTN6_current_g_0 B1=N110
+ B2=FE_DBTN11_n90
XU530 MOAI1S $PINS O=counter_w[1] A1=FE_DBTN5_current_n_1 A2=n243
+ B1=FE_PHN1348_N106 B2=FE_DBTN11_n90
XU531 MOAI1S $PINS O=counter_w[4] A1=n259 A2=n243 B1=N109 B2=FE_DBTN11_n90
XU532 MOAI1S $PINS O=counter_w[2] A1=n257 A2=n243 B1=N107 B2=FE_DBTN11_n90
XU533 MOAI1S $PINS O=counter_w[3] A1=n258 A2=n243 B1=N108 B2=FE_DBTN11_n90
XU534 MOAI1S $PINS O=rf_io_raddr_1[2] A1=n257 A2=n62 B1=o_state_r B2=N256
XU535 INV1S $PINS O=n238 I=n61
XU536 MOAI1S $PINS O=rf_io_raddr_1[1] A1=FE_DBTN5_current_n_1 A2=n62
+ B1=o_state_r B2=N255
XU537 NR2 $PINS O=rf_d_raddr_1[4] I1=FE_OFN226_FE_DBTN15_n64 I2=n259
XU538 NR2 $PINS O=rf_d_raddr_1[0] I1=FE_OFN226_FE_DBTN15_n64
+ I2=FE_DBTN16_current_n_0
XU539 NR2 $PINS O=rf_d_raddr_1[3] I1=n64 I2=n258
XU540 NR2 $PINS O=rf_d_raddr_1[2] I1=FE_OFN226_FE_DBTN15_n64 I2=n257
XU541 NR2 $PINS O=rf_d_raddr_1[1] I1=FE_OFN226_FE_DBTN15_n64
+ I2=FE_DBTN5_current_n_1
XU542 AN4B1S $PINS O=N39 I1=FE_DBTN16_current_n_0 I2=FE_DBTN5_current_n_1
+ I3=mac_en B1=n102
XU543 ND3 $PINS O=n102 I1=n258 I2=n259 I3=n257
XU544 ND3 $PINS O=n65 I1=n67 I2=n235 I3=FE_PHN1406_o_state_r
XU545 MOAI1S $PINS O=o_counter_w[5] A1=n65 A2=n251 B1=N258 B2=n66
XU546 MOAI1S $PINS O=o_counter_w[4] A1=n65 A2=n250 B1=N257 B2=n66
XU547 OR2 $PINS O=n93 I1=n92 I2=n239
XU548 OAI12HS $PINS O=n109 A1=n70 B1=n267 B2=n69
XU549 OAI12HS $PINS O=n108 A1=FE_DBTN14_n68 B1=n266 B2=n69
XU550 ND3 $PINS O=n98 I1=FE_DBTN2_current_g_1 I2=FE_DBTN0_current_g_2
+ I3=FE_DBTN6_current_g_0
XU551 NR2 $PINS O=n66 I1=n235 I2=n246
XU552 NR2 $PINS O=n74 I1=n95 I2=FE_DBTN5_current_n_1
XU553 INV1S $PINS O=n239 I=FE_PHN1089_n91
XU554 NR2 $PINS O=n81 I1=n251 I2=n250
XU556 MOAI1S $PINS O=rf_io_waddr_2[2] A1=n61 A2=n254 B1=rf_io_waddr_2[1]
+ B2=delayed_mac_group[0]
XU559 OA12 $PINS O=rf_io_wen_2 A1=FE_OFN0_FE_DBTN15_n64 B1=mac_valid_out_r
+ B2=n60
XU560 INV1S $PINS O=n226 I=rf_io_rdata_1[7]
XU562 INV1S $PINS O=n267 I=c_state[1]
XU563 OA12S $PINS O=n73 A1=n85 B1=n234 B2=n87
XU564 INV1S $PINS O=n234 I=i_valid
XU565 INV1S $PINS O=n264 I=g_cnt_d3[2]
XU566 INV1S $PINS O=n261 I=g_cnt_d3[1]
XU567 INV1S $PINS O=n254 I=g_cnt_d3[0]
XU569 NR2 $PINS O=n87 I1=N35 I2=n246
XU572 NR2 $PINS O=n86 I1=FE_DBTN1_c_group_idx_1 I2=FE_DBTN3_c_group_idx_0
XU573 AN2 $PINS O=k_ord_1[4] I1=k_ord_1[0] I2=c_group_idx[2]
XU574 INV1S $PINS O=n206 I=FE_OFN9_i_rst_n
XU575 INV1S $PINS O=n235 I=o_ready
XU578 MOAI1S $PINS O=counter_w[8] A1=n89 A2=n265 B1=N113 B2=FE_DBTN11_n90
XU579 MOAI1S $PINS O=counter_w[0] A1=FE_DBTN16_current_n_0 A2=n243
+ B1=FE_DBTN16_current_n_0 B2=FE_DBTN11_n90
XU580 INV1S $PINS O=n259 I=FE_PHN1168_current_n_4
XU581 INV1S $PINS O=n258 I=FE_PHN1174_current_n_3
XU582 AN4B1S $PINS O=N40 I1=FE_PHN1168_current_n_4 I2=mac_en
+ I3=FE_PHN1174_current_n_3 B1=n101
XU583 ND3 $PINS O=n101 I1=FE_PHN1173_current_n_1 I2=current_n[2]
+ I3=current_n[0]
XU584 AN2 $PINS O=N43 I1=FE_PHN1474_pe_done_d2 I2=mac_en
XU585 AN2 $PINS O=N42 I1=FE_PHN1013_pe_done_d1 I2=mac_en
XU586 MOAI1S $PINS O=o_counter_w[3] A1=n65 A2=n249 B1=N256 B2=n66
XU587 INV1S $PINS O=n249 I=o_counter_r[3]
XU588 MOAI1S $PINS O=FE_PHN1411_o_counter_w_2 A1=n65 A2=n248 B1=N255 B2=n66
XU589 INV1S $PINS O=n248 I=o_counter_r[2]
XU590 MOAI1S $PINS O=o_counter_w[1] A1=n65 A2=n247 B1=N254 B2=n66
XU591 INV1S $PINS O=n247 I=o_counter_r[1]
XU593 INV1S $PINS O=n257 I=current_n[2]
XU594 ND3 $PINS O=n70 I1=n114 I2=FE_DBTN14_n68 I3=FE_PHN1040_cordic_valid_out_0
XU595 XNR2HS $PINS O=n112 I1=n78 I2=n246
XU596 ND3 $PINS O=n80 I1=o_counter_r[2] I2=o_counter_r[3] I3=o_counter_r[1]
XU597 ND3 $PINS O=n79 I1=FE_OFN35_o_counter_r_0 I2=o_valid I3=n81
XU598 AN4B1S $PINS O=n100 I1=current_n[2] I2=FE_PHN1174_current_n_3 I3=n265
+ B1=n259
XU599 ND3 $PINS O=n95 I1=n96 I2=counter_r[8] I3=n97
XU600 NR3 $PINS O=n97 I1=current_n[2] I2=FE_PHN1168_current_n_4
+ I3=FE_PHN1174_current_n_3
XU601 NR2 $PINS O=n96 I1=current_n[0] I2=n98
XU602 NR2 $PINS O=n92 I1=n95 I2=FE_PHN1173_current_n_1
XU606 INV1S $PINS O=n265 I=counter_r[8]
XU607 ND3 $PINS O=n91 I1=delayed_mac_group[0] I2=delayed_mac_group[1] I3=n94
XU608 AN2 $PINS O=n94 I1=rf_io_write_delay I2=delayed_mac_group[2]
XU609 MOAI1S $PINS O=n105 A1=FE_DBTN14_n68 A2=n264 B1=FE_DBTN14_n68
+ B2=c_group_idx[2]
XU610 MOAI1S $PINS O=n106 A1=FE_DBTN14_n68 A2=n261 B1=FE_DBTN14_n68
+ B2=c_group_idx[1]
XU611 MOAI1S $PINS O=n107 A1=FE_DBTN14_n68 A2=n254 B1=FE_DBTN14_n68
+ B2=c_group_idx[0]
XU612 INV1S $PINS O=n251 I=o_counter_r[5]
XU613 INV1S $PINS O=n250 I=o_counter_r[4]
XU614 INV1S $PINS O=n266 I=FE_PHN774_c_state_0
XU617 MOAI1S $PINS O=FE_PHN1303_n111 A1=n76 A2=n244 B1=n141 B2=n75
XU620 OAI22S $PINS O=n78 A1=n79 A2=n80 B1=o_valid B2=n63
XU621 ND3S $PINS O=n103 I1=n72 I2=n63 I3=n104
XU624 NR2 $PINS O=n85 I1=n88 I2=state_r[0]
XU625 OAI222S $PINS O=FE_PHN1410_n110 A1=n71 A2=FE_DBTN9_state_r_0 B1=n72
+ B2=n237 C1=n73 C2=FE_DBTN12_n85
XU626 ND3S $PINS O=n63 I1=FE_DBTN9_state_r_0 I2=n244 I3=FE_PHN1175_state_r_2
XU629 XOR2HS $PINS O=phase_1[14] I1=n214 I2=sub_135/carry_14
XU630 AN2 $PINS O=sub_135/carry_14 I1=sub_135/carry_13 I2=n213
XU631 XOR2HS $PINS O=phase_1[13] I1=n213 I2=sub_135/carry_13
XU632 AN2 $PINS O=sub_135/carry_13 I1=sub_135/carry_12 I2=n212
XU633 XOR2HS $PINS O=phase_1[12] I1=n212 I2=sub_135/carry_12
XU634 AN2 $PINS O=sub_135/carry_12 I1=sub_135/carry_11 I2=n211
XU635 XOR2HS $PINS O=phase_1[11] I1=n211 I2=sub_135/carry_11
XU636 AN2 $PINS O=sub_135/carry_11 I1=sub_135/carry_10 I2=n210
XU637 XOR2HS $PINS O=phase_1[10] I1=n210 I2=sub_135/carry_10
XU638 XOR2HS $PINS O=phase_1[9] I1=n209 I2=FE_DBTN8_phase_1_8
XU639 XOR2HS $PINS O=phase_0[14] I1=n221 I2=sub_134/carry[14]
XU640 AN2 $PINS O=sub_134/carry[14] I1=sub_134/carry[13] I2=n220
XU641 XOR2HS $PINS O=phase_0[13] I1=n220 I2=sub_134/carry[13]
XU642 AN2 $PINS O=sub_134/carry[13] I1=sub_134/carry[12] I2=n219
XU643 XOR2HS $PINS O=phase_0[12] I1=n219 I2=sub_134/carry[12]
XU644 AN2 $PINS O=sub_134/carry[12] I1=sub_134/carry[11] I2=n218
XU645 XOR2HS $PINS O=phase_0[11] I1=n218 I2=sub_134/carry[11]
XU646 XOR2HS $PINS O=phase_0[10] I1=n217 I2=FE_DBTN7_phase_0_9
XU647 XOR2HS $PINS O=N258 I1=r119/carry[5] I2=o_counter_r[5]
XU648 AN3 $PINS O=n222 I1=o_counter_r[4] I2=o_counter_r[3]
+ I3=FE_OFN35_o_counter_r_0
XU649 AO13S $PINS O=N35 A1=o_counter_r[5] B1=o_counter_r[2] B2=o_counter_r[1]
+ B3=n222
Xcordic0 cordic_rotation_1 $PINS clk=CTS_185 rst_n=FE_OFN83_FE_DBTN17_n206
+ valid_in=FE_PHN1136_c_start valid_out=cordic_valid_out[0]
+ x_in[16]=FE_PHN1277_c_in_r_0_16 x_in[15]=FE_PHN1370_c_in_r_0_15
+ x_in[14]=FE_PHN1373_c_in_r_0_14 x_in[13]=FE_PHN1374_c_in_r_0_13
+ x_in[12]=FE_PHN1384_c_in_r_0_12 x_in[11]=c_in_r_0[11]
+ x_in[10]=FE_PHN1395_c_in_r_0_10 x_in[9]=FE_PHN1381_c_in_r_0_9
+ x_in[8]=FE_PHN1376_c_in_r_0_8 x_in[7]=FE_PHN1393_c_in_r_0_7 x_in[6]=c_in_r_0[6]
+ x_in[5]=FE_PHN1383_c_in_r_0_5 x_in[4]=c_in_r_0[4] x_in[3]=c_in_r_0[3]
+ x_in[2]=c_in_r_0[2] x_in[1]=c_in_r_0[1] x_in[0]=FE_PHN1385_c_in_r_0_0
+ y_in[16]=FE_PHN1307_c_in_i_0_16 y_in[15]=c_in_i_0[15] y_in[14]=c_in_i_0[14]
+ y_in[13]=c_in_i_0[13] y_in[12]=c_in_i_0[12] y_in[11]=c_in_i_0[11]
+ y_in[10]=FE_PHN1392_c_in_i_0_10 y_in[9]=FE_PHN1400_c_in_i_0_9
+ y_in[8]=FE_PHN1401_c_in_i_0_8 y_in[7]=c_in_i_0[7] y_in[6]=FE_PHN1403_c_in_i_0_6
+ y_in[5]=FE_PHN1397_c_in_i_0_5 y_in[4]=c_in_i_0[4] y_in[3]=c_in_i_0[3]
+ y_in[2]=c_in_i_0[2] y_in[1]=c_in_i_0[1] y_in[0]=c_in_i_0[0]
+ phase_in[15]=phase_0[15] phase_in[14]=phase_0[14] phase_in[13]=phase_0[13]
+ phase_in[12]=phase_0[12] phase_in[11]=phase_0[11] phase_in[10]=phase_0[10]
+ phase_in[9]=phase_0[9] phase_in[8]=n268 phase_in[7]=n268 phase_in[6]=n268
+ phase_in[5]=n268 phase_in[4]=n268 phase_in[3]=n268 phase_in[2]=n268
+ phase_in[1]=n268 phase_in[0]=n268 x_out[16]=cor_x_out[0][16]
+ x_out[15]=cor_x_out[0][15] x_out[14]=cor_x_out[0][14]
+ x_out[13]=cor_x_out[0][13] x_out[12]=cor_x_out[0][12]
+ x_out[11]=cor_x_out[0][11] x_out[10]=cor_x_out[0][10] x_out[9]=cor_x_out[0][9]
+ x_out[8]=cor_x_out[0][8] x_out[7]=cor_x_out[0][7] x_out[6]=cor_x_out[0][6]
+ x_out[5]=cor_x_out[0][5] x_out[4]=cor_x_out[0][4] x_out[3]=cor_x_out[0][3]
+ x_out[2]=cor_x_out[0][2] x_out[1]=cor_x_out[0][1] x_out[0]=cor_x_out[0][0]
+ y_out[16]=cor_y_out[0][16] y_out[15]=cor_y_out[0][15]
+ y_out[14]=cor_y_out[0][14] y_out[13]=cor_y_out[0][13]
+ y_out[12]=cor_y_out[0][12] y_out[11]=cor_y_out[0][11]
+ y_out[10]=cor_y_out[0][10] y_out[9]=cor_y_out[0][9] y_out[8]=cor_y_out[0][8]
+ y_out[7]=cor_y_out[0][7] y_out[6]=cor_y_out[0][6] y_out[5]=cor_y_out[0][5]
+ y_out[4]=cor_y_out[0][4] y_out[3]=cor_y_out[0][3] y_out[2]=cor_y_out[0][2]
+ y_out[1]=cor_y_out[0][1] y_out[0]=cor_y_out[0][0] p1=FE_DBTN7_phase_0_9
+ FE_OFN79_FE_DBTN17_n206=FE_OFN86_FE_DBTN17_n206
+ FE_OFN77_FE_DBTN17_n206=FE_OFN85_FE_DBTN17_n206
+ FE_OFN76_FE_DBTN17_n206=FE_OFN84_FE_DBTN17_n206 clk_clone3=CTS_148
+ clk_clone2=CTS_168 clk_clone1=CTS_171
Xcordic1 cordic_rotation_0 $PINS clk=CTS_185 rst_n=FE_DBTN17_n206
+ valid_in=FE_PHN1136_c_start valid_out=cordic_valid_out[1] x_in[16]=c_in_r_1[16]
+ x_in[15]=c_in_r_1[15] x_in[14]=c_in_r_1[14] x_in[13]=c_in_r_1[13]
+ x_in[12]=c_in_r_1[12] x_in[11]=c_in_r_1[11] x_in[10]=c_in_r_1[10]
+ x_in[9]=c_in_r_1[9] x_in[8]=FE_PHN1388_c_in_r_1_8 x_in[7]=c_in_r_1[7]
+ x_in[6]=FE_PHN1394_c_in_r_1_6 x_in[5]=c_in_r_1[5] x_in[4]=c_in_r_1[4]
+ x_in[3]=c_in_r_1[3] x_in[2]=c_in_r_1[2] x_in[1]=c_in_r_1[1]
+ x_in[0]=FE_PHN1398_c_in_r_1_0 y_in[16]=FE_PHN1345_c_in_i_1_16
+ y_in[15]=FE_PHN1367_c_in_i_1_15 y_in[14]=FE_PHN1368_c_in_i_1_14
+ y_in[13]=FE_PHN1371_c_in_i_1_13 y_in[12]=c_in_i_1[12]
+ y_in[11]=FE_PHN1396_c_in_i_1_11 y_in[10]=c_in_i_1[10]
+ y_in[9]=FE_PHN1386_c_in_i_1_9 y_in[8]=c_in_i_1[8] y_in[7]=FE_PHN1380_c_in_i_1_7
+ y_in[6]=c_in_i_1[6] y_in[5]=c_in_i_1[5] y_in[4]=c_in_i_1[4] y_in[3]=c_in_i_1[3]
+ y_in[2]=c_in_i_1[2] y_in[1]=c_in_i_1[1] y_in[0]=c_in_i_1[0]
+ phase_in[15]=phase_1[15] phase_in[14]=phase_1[14] phase_in[13]=phase_1[13]
+ phase_in[12]=phase_1[12] phase_in[11]=phase_1[11] phase_in[10]=phase_1[10]
+ phase_in[9]=phase_1[9] phase_in[8]=phase_1[8] phase_in[7]=n268 phase_in[6]=n268
+ phase_in[5]=n268 phase_in[4]=n268 phase_in[3]=n268 phase_in[2]=n268
+ phase_in[1]=n268 phase_in[0]=n268 x_out[16]=cor_x_out[1][16]
+ x_out[15]=cor_x_out[1][15] x_out[14]=cor_x_out[1][14]
+ x_out[13]=cor_x_out[1][13] x_out[12]=cor_x_out[1][12]
+ x_out[11]=cor_x_out[1][11] x_out[10]=cor_x_out[1][10] x_out[9]=cor_x_out[1][9]
+ x_out[8]=cor_x_out[1][8] x_out[7]=cor_x_out[1][7] x_out[6]=cor_x_out[1][6]
+ x_out[5]=cor_x_out[1][5] x_out[4]=cor_x_out[1][4] x_out[3]=cor_x_out[1][3]
+ x_out[2]=cor_x_out[1][2] x_out[1]=cor_x_out[1][1] x_out[0]=cor_x_out[1][0]
+ y_out[16]=cor_y_out[1][16] y_out[15]=cor_y_out[1][15]
+ y_out[14]=cor_y_out[1][14] y_out[13]=cor_y_out[1][13]
+ y_out[12]=cor_y_out[1][12] y_out[11]=cor_y_out[1][11]
+ y_out[10]=cor_y_out[1][10] y_out[9]=cor_y_out[1][9] y_out[8]=cor_y_out[1][8]
+ y_out[7]=cor_y_out[1][7] y_out[6]=cor_y_out[1][6] y_out[5]=cor_y_out[1][5]
+ y_out[4]=cor_y_out[1][4] y_out[3]=cor_y_out[1][3] y_out[2]=cor_y_out[1][2]
+ y_out[1]=cor_y_out[1][1] y_out[0]=cor_y_out[1][0] p1=FE_DBTN8_phase_1_8
+ FE_OFN78_FE_DBTN17_n206=FE_OFN86_FE_DBTN17_n206
+ FE_OFN74_FE_DBTN17_n206=FE_OFN84_FE_DBTN17_n206
+ FE_OFN73_FE_DBTN17_n206=FE_OFN83_FE_DBTN17_n206
+ FE_OFN72_FE_DBTN17_n206=FE_OFN82_FE_DBTN17_n206
+ FE_OFN70_FE_DBTN17_n206=FE_OFN81_FE_DBTN17_n206 clk_clone4=CTS_148
+ clk_clone3=CTS_146 clk_clone2=CTS_167 clk_clone1=CTS_171
Xmac DFrFT_MAC $PINS en=mac_en stage_sel=FE_OFN0_FE_DBTN15_n64
+ pe_clear=pe_clear_d1 pe_done=FE_PHN1323_pe_done_d2
+ g_cnt[2]=FE_DBTN0_current_g_2 g_cnt[1]=FE_DBTN2_current_g_1
+ g_cnt[0]=FE_DBTN6_current_g_0 n_cnt[5]=n268 n_cnt[4]=current_n[4]
+ n_cnt[3]=FE_PHN1174_current_n_3 n_cnt[2]=current_n[2]
+ n_cnt[1]=FE_DBTN5_current_n_1 n_cnt[0]=FE_DBTN16_current_n_0
+ data_in_r[16]=mac_in_real[16] data_in_r[15]=mac_in_real[15]
+ data_in_r[14]=mac_in_real[14] data_in_r[13]=mac_in_real[13]
+ data_in_r[12]=mac_in_real[12] data_in_r[11]=mac_in_real[11]
+ data_in_r[10]=mac_in_real[10] data_in_r[9]=mac_in_real[9]
+ data_in_r[8]=mac_in_real[8] data_in_r[7]=mac_in_real[7]
+ data_in_r[6]=mac_in_real[6] data_in_r[5]=mac_in_real[5]
+ data_in_r[4]=mac_in_real[4] data_in_r[3]=mac_in_real[3]
+ data_in_r[2]=mac_in_real[2] data_in_r[1]=mac_in_real[1]
+ data_in_r[0]=mac_in_real[0] data_in_i[16]=mac_in_imag[16]
+ data_in_i[15]=mac_in_imag[15] data_in_i[14]=mac_in_imag[14]
+ data_in_i[13]=mac_in_imag[13] data_in_i[12]=mac_in_imag[12]
+ data_in_i[11]=mac_in_imag[11] data_in_i[10]=mac_in_imag[10]
+ data_in_i[9]=mac_in_imag[9] data_in_i[8]=mac_in_imag[8]
+ data_in_i[7]=mac_in_imag[7] data_in_i[6]=mac_in_imag[6]
+ data_in_i[5]=mac_in_imag[5] data_in_i[4]=mac_in_imag[4]
+ data_in_i[3]=mac_in_imag[3] data_in_i[2]=mac_in_imag[2]
+ data_in_i[1]=mac_in_imag[1] data_in_i[0]=mac_in_imag[0] y_out_0_r[16]=pe_r0[16]
+ y_out_0_r[15]=pe_r0[15] y_out_0_r[14]=pe_r0[14] y_out_0_r[13]=pe_r0[13]
+ y_out_0_r[12]=pe_r0[12] y_out_0_r[11]=pe_r0[11] y_out_0_r[10]=pe_r0[10]
+ y_out_0_r[9]=pe_r0[9] y_out_0_r[8]=pe_r0[8] y_out_0_r[7]=pe_r0[7]
+ y_out_0_r[6]=pe_r0[6] y_out_0_r[5]=pe_r0[5] y_out_0_r[4]=pe_r0[4]
+ y_out_0_r[3]=pe_r0[3] y_out_0_r[2]=pe_r0[2] y_out_0_r[1]=pe_r0[1]
+ y_out_0_r[0]=pe_r0[0] y_out_0_i[16]=pe_i0[16] y_out_0_i[15]=pe_i0[15]
+ y_out_0_i[14]=pe_i0[14] y_out_0_i[13]=pe_i0[13] y_out_0_i[12]=pe_i0[12]
+ y_out_0_i[11]=pe_i0[11] y_out_0_i[10]=pe_i0[10] y_out_0_i[9]=pe_i0[9]
+ y_out_0_i[8]=pe_i0[8] y_out_0_i[7]=pe_i0[7] y_out_0_i[6]=pe_i0[6]
+ y_out_0_i[5]=pe_i0[5] y_out_0_i[4]=pe_i0[4] y_out_0_i[3]=pe_i0[3]
+ y_out_0_i[2]=pe_i0[2] y_out_0_i[1]=pe_i0[1] y_out_0_i[0]=pe_i0[0]
+ y_out_1_r[16]=pe_r1[16] y_out_1_r[15]=pe_r1[15] y_out_1_r[14]=pe_r1[14]
+ y_out_1_r[13]=pe_r1[13] y_out_1_r[12]=pe_r1[12] y_out_1_r[11]=pe_r1[11]
+ y_out_1_r[10]=pe_r1[10] y_out_1_r[9]=pe_r1[9] y_out_1_r[8]=pe_r1[8]
+ y_out_1_r[7]=pe_r1[7] y_out_1_r[6]=pe_r1[6] y_out_1_r[5]=pe_r1[5]
+ y_out_1_r[4]=pe_r1[4] y_out_1_r[3]=pe_r1[3] y_out_1_r[2]=pe_r1[2]
+ y_out_1_r[1]=pe_r1[1] y_out_1_r[0]=pe_r1[0] y_out_1_i[16]=pe_i1[16]
+ y_out_1_i[15]=pe_i1[15] y_out_1_i[14]=pe_i1[14] y_out_1_i[13]=pe_i1[13]
+ y_out_1_i[12]=pe_i1[12] y_out_1_i[11]=pe_i1[11] y_out_1_i[10]=pe_i1[10]
+ y_out_1_i[9]=pe_i1[9] y_out_1_i[8]=pe_i1[8] y_out_1_i[7]=pe_i1[7]
+ y_out_1_i[6]=pe_i1[6] y_out_1_i[5]=pe_i1[5] y_out_1_i[4]=pe_i1[4]
+ y_out_1_i[3]=pe_i1[3] y_out_1_i[2]=pe_i1[2] y_out_1_i[1]=pe_i1[1]
+ y_out_1_i[0]=pe_i1[0] y_out_2_r[16]=pe_r2[16] y_out_2_r[15]=pe_r2[15]
+ y_out_2_r[14]=pe_r2[14] y_out_2_r[13]=pe_r2[13] y_out_2_r[12]=pe_r2[12]
+ y_out_2_r[11]=pe_r2[11] y_out_2_r[10]=pe_r2[10] y_out_2_r[9]=pe_r2[9]
+ y_out_2_r[8]=pe_r2[8] y_out_2_r[7]=pe_r2[7] y_out_2_r[6]=pe_r2[6]
+ y_out_2_r[5]=pe_r2[5] y_out_2_r[4]=pe_r2[4] y_out_2_r[3]=pe_r2[3]
+ y_out_2_r[2]=pe_r2[2] y_out_2_r[1]=pe_r2[1] y_out_2_r[0]=pe_r2[0]
+ y_out_2_i[16]=pe_i2[16] y_out_2_i[15]=pe_i2[15] y_out_2_i[14]=pe_i2[14]
+ y_out_2_i[13]=pe_i2[13] y_out_2_i[12]=pe_i2[12] y_out_2_i[11]=pe_i2[11]
+ y_out_2_i[10]=pe_i2[10] y_out_2_i[9]=pe_i2[9] y_out_2_i[8]=pe_i2[8]
+ y_out_2_i[7]=pe_i2[7] y_out_2_i[6]=pe_i2[6] y_out_2_i[5]=pe_i2[5]
+ y_out_2_i[4]=pe_i2[4] y_out_2_i[3]=pe_i2[3] y_out_2_i[2]=pe_i2[2]
+ y_out_2_i[1]=pe_i2[1] y_out_2_i[0]=pe_i2[0] y_out_3_r[16]=pe_r3[16]
+ y_out_3_r[15]=pe_r3[15] y_out_3_r[14]=pe_r3[14] y_out_3_r[13]=pe_r3[13]
+ y_out_3_r[12]=pe_r3[12] y_out_3_r[11]=pe_r3[11] y_out_3_r[10]=pe_r3[10]
+ y_out_3_r[9]=pe_r3[9] y_out_3_r[8]=pe_r3[8] y_out_3_r[7]=pe_r3[7]
+ y_out_3_r[6]=pe_r3[6] y_out_3_r[5]=pe_r3[5] y_out_3_r[4]=pe_r3[4]
+ y_out_3_r[3]=pe_r3[3] y_out_3_r[2]=pe_r3[2] y_out_3_r[1]=pe_r3[1]
+ y_out_3_r[0]=pe_r3[0] y_out_3_i[16]=pe_i3[16] y_out_3_i[15]=pe_i3[15]
+ y_out_3_i[14]=pe_i3[14] y_out_3_i[13]=pe_i3[13] y_out_3_i[12]=pe_i3[12]
+ y_out_3_i[11]=pe_i3[11] y_out_3_i[10]=pe_i3[10] y_out_3_i[9]=pe_i3[9]
+ y_out_3_i[8]=pe_i3[8] y_out_3_i[7]=pe_i3[7] y_out_3_i[6]=pe_i3[6]
+ y_out_3_i[5]=pe_i3[5] y_out_3_i[4]=pe_i3[4] y_out_3_i[3]=pe_i3[3]
+ y_out_3_i[2]=pe_i3[2] y_out_3_i[1]=pe_i3[1] y_out_3_i[0]=pe_i3[0]
+ rst_n_BAR=n206 n64=n64 i_rst_n=rst_n
+ FE_OFN0_FE_DBTN15_n64=FE_OFN0_FE_DBTN15_n64 FE_OFN28_i_rst_n=FE_OFN24_i_rst_n
+ FE_OFN19_i_rst_n=FE_OFN19_i_rst_n FE_OFN14_i_rst_n=FE_OFN16_i_rst_n
+ FE_OFN11_i_rst_n=FE_OFN13_i_rst_n FE_OFN8_i_rst_n=FE_OFN11_i_rst_n
+ FE_OFN5_i_rst_n=FE_OFN9_i_rst_n FE_OFN83_FE_DBTN15_n64=FE_OFN226_FE_DBTN15_n64
+ clk_clone13=CTS_148 clk_clone12=CTS_146 clk_clone11=CTS_167 clk_clone10=CTS_168
+ clk_clone8=CTS_173 clk_clone9=CTS_175 clk_clone6=CTS_183 clk_clone5=CTS_185
+ clk_clone7=CTS_189 clk_clone4=CTS_190 clk_clone2=CTS_191 clk_clone1=CTS_192
+ clk=CTS_193 clk_clone3=CTS_195 p1=FE_PHN1168_current_n_4
Xrf_data RegFileDual_DATA_WIDTH34 $PINS rst_n=FE_DBTN17_n206
+ read_addr_1[4]=rf_d_raddr_1[4] read_addr_1[3]=rf_d_raddr_1[3]
+ read_addr_1[2]=rf_d_raddr_1[2] read_addr_1[1]=rf_d_raddr_1[1]
+ read_addr_1[0]=rf_d_raddr_1[0] read_data_1[33]=rf_d_rdata_1[33]
+ read_data_1[32]=rf_d_rdata_1[32] read_data_1[31]=rf_d_rdata_1[31]
+ read_data_1[30]=rf_d_rdata_1[30] read_data_1[29]=rf_d_rdata_1[29]
+ read_data_1[28]=rf_d_rdata_1[28] read_data_1[27]=rf_d_rdata_1[27]
+ read_data_1[26]=rf_d_rdata_1[26] read_data_1[25]=rf_d_rdata_1[25]
+ read_data_1[24]=rf_d_rdata_1[24] read_data_1[23]=rf_d_rdata_1[23]
+ read_data_1[22]=rf_d_rdata_1[22] read_data_1[21]=rf_d_rdata_1[21]
+ read_data_1[20]=rf_d_rdata_1[20] read_data_1[19]=rf_d_rdata_1[19]
+ read_data_1[18]=rf_d_rdata_1[18] read_data_1[17]=rf_d_rdata_1[17]
+ read_data_1[16]=rf_d_rdata_1[16] read_data_1[15]=rf_d_rdata_1[15]
+ read_data_1[14]=rf_d_rdata_1[14] read_data_1[13]=rf_d_rdata_1[13]
+ read_data_1[12]=rf_d_rdata_1[12] read_data_1[11]=rf_d_rdata_1[11]
+ read_data_1[10]=rf_d_rdata_1[10] read_data_1[9]=rf_d_rdata_1[9]
+ read_data_1[8]=rf_d_rdata_1[8] read_data_1[7]=rf_d_rdata_1[7]
+ read_data_1[6]=rf_d_rdata_1[6] read_data_1[5]=rf_d_rdata_1[5]
+ read_data_1[4]=rf_d_rdata_1[4] read_data_1[3]=rf_d_rdata_1[3]
+ read_data_1[2]=rf_d_rdata_1[2] read_data_1[1]=rf_d_rdata_1[1]
+ read_data_1[0]=rf_d_rdata_1[0] wen1=cordic_valid_out[0]
+ wen2=cordic_valid_out[1] write_addr_1[4]=c_group_idx[2]
+ write_addr_1[3]=c_group_idx[1] write_addr_1[2]=c_group_idx[0]
+ write_addr_1[1]=FE_DBTN10_n114 write_addr_1[0]=n268
+ write_addr_2[4]=c_group_idx[2] write_addr_2[3]=c_group_idx[1]
+ write_addr_2[2]=n268 write_addr_2[1]=n268 write_addr_2[0]=*Logic1*
+ write_data_1[33]=cor_y_out[0][16] write_data_1[32]=cor_y_out[0][15]
+ write_data_1[31]=cor_y_out[0][14] write_data_1[30]=cor_y_out[0][13]
+ write_data_1[29]=cor_y_out[0][12] write_data_1[28]=cor_y_out[0][11]
+ write_data_1[27]=cor_y_out[0][10] write_data_1[26]=cor_y_out[0][9]
+ write_data_1[25]=cor_y_out[0][8] write_data_1[24]=cor_y_out[0][7]
+ write_data_1[23]=cor_y_out[0][6] write_data_1[22]=cor_y_out[0][5]
+ write_data_1[21]=cor_y_out[0][4] write_data_1[20]=cor_y_out[0][3]
+ write_data_1[19]=cor_y_out[0][2] write_data_1[18]=cor_y_out[0][1]
+ write_data_1[17]=cor_y_out[0][0] write_data_1[16]=cor_x_out[0][16]
+ write_data_1[15]=cor_x_out[0][15] write_data_1[14]=cor_x_out[0][14]
+ write_data_1[13]=cor_x_out[0][13] write_data_1[12]=cor_x_out[0][12]
+ write_data_1[11]=cor_x_out[0][11] write_data_1[10]=cor_x_out[0][10]
+ write_data_1[9]=cor_x_out[0][9] write_data_1[8]=cor_x_out[0][8]
+ write_data_1[7]=cor_x_out[0][7] write_data_1[6]=cor_x_out[0][6]
+ write_data_1[5]=cor_x_out[0][5] write_data_1[4]=cor_x_out[0][4]
+ write_data_1[3]=cor_x_out[0][3] write_data_1[2]=cor_x_out[0][2]
+ write_data_1[1]=cor_x_out[0][1] write_data_1[0]=cor_x_out[0][0]
+ write_data_2[33]=cor_y_out[1][16] write_data_2[32]=cor_y_out[1][15]
+ write_data_2[31]=cor_y_out[1][14] write_data_2[30]=cor_y_out[1][13]
+ write_data_2[29]=cor_y_out[1][12] write_data_2[28]=cor_y_out[1][11]
+ write_data_2[27]=cor_y_out[1][10] write_data_2[26]=cor_y_out[1][9]
+ write_data_2[25]=cor_y_out[1][8] write_data_2[24]=cor_y_out[1][7]
+ write_data_2[23]=cor_y_out[1][6] write_data_2[22]=cor_y_out[1][5]
+ write_data_2[21]=cor_y_out[1][4] write_data_2[20]=cor_y_out[1][3]
+ write_data_2[19]=cor_y_out[1][2] write_data_2[18]=cor_y_out[1][1]
+ write_data_2[17]=cor_y_out[1][0] write_data_2[16]=cor_x_out[1][16]
+ write_data_2[15]=cor_x_out[1][15] write_data_2[14]=cor_x_out[1][14]
+ write_data_2[13]=cor_x_out[1][13] write_data_2[12]=cor_x_out[1][12]
+ write_data_2[11]=cor_x_out[1][11] write_data_2[10]=cor_x_out[1][10]
+ write_data_2[9]=cor_x_out[1][9] write_data_2[8]=cor_x_out[1][8]
+ write_data_2[7]=cor_x_out[1][7] write_data_2[6]=cor_x_out[1][6]
+ write_data_2[5]=cor_x_out[1][5] write_data_2[4]=cor_x_out[1][4]
+ write_data_2[3]=cor_x_out[1][3] write_data_2[2]=cor_x_out[1][2]
+ write_data_2[1]=cor_x_out[1][1] write_data_2[0]=cor_x_out[1][0] p_1=n114
+ p1=FE_DBTN1_c_group_idx_1 p2=FE_DBTN3_c_group_idx_0
+ FE_OFN75_FE_DBTN17_n206=FE_OFN84_FE_DBTN17_n206
+ FE_OFN71_FE_DBTN17_n206=FE_OFN81_FE_DBTN17_n206
+ FE_OFN69_FE_DBTN17_n206=FE_OFN80_FE_DBTN17_n206 clk_clone7=CTS_168
+ clk_clone6=CTS_171 clk_clone5=CTS_172 clk_clone4=CTS_173 clk_clone3=CTS_174
+ clk_clone2=CTS_185 clk_clone1=CTS_192 clk=CTS_193
Xrf_io RegFileDual_DATA_WIDTH22 $PINS read_addr_1[4]=rf_io_raddr_1[4]
+ read_addr_1[3]=rf_io_raddr_1[3] read_addr_1[2]=rf_io_raddr_1[2]
+ read_addr_1[1]=rf_io_raddr_1[1] read_addr_1[0]=rf_io_raddr_1[0]
+ read_data_1[21]=rf_io_rdata_1[21] read_data_1[20]=rf_io_rdata_1[20]
+ read_data_1[19]=rf_io_rdata_1[19] read_data_1[18]=rf_io_rdata_1[18]
+ read_data_1[17]=rf_io_rdata_1[17] read_data_1[16]=rf_io_rdata_1[16]
+ read_data_1[15]=rf_io_rdata_1[15] read_data_1[14]=rf_io_rdata_1[14]
+ read_data_1[13]=rf_io_rdata_1[13] read_data_1[12]=rf_io_rdata_1[12]
+ read_data_1[11]=rf_io_rdata_1[11] read_data_1[10]=rf_io_rdata_1[10]
+ read_data_1[9]=rf_io_rdata_1[9] read_data_1[8]=rf_io_rdata_1[8]
+ read_data_1[7]=rf_io_rdata_1[7] read_data_1[6]=rf_io_rdata_1[6]
+ read_data_1[5]=rf_io_rdata_1[5] read_data_1[4]=rf_io_rdata_1[4]
+ read_data_1[3]=rf_io_rdata_1[3] read_data_1[2]=rf_io_rdata_1[2]
+ read_data_1[1]=rf_io_rdata_1[1] read_data_1[0]=rf_io_rdata_1[0]
+ wen1=rf_io_wen_1 wen2=rf_io_wen_2 write_addr_1[4]=rf_io_waddr_1[4]
+ write_addr_1[3]=rf_io_waddr_1[3] write_addr_1[2]=rf_io_waddr_1[2]
+ write_addr_1[1]=rf_io_waddr_1[1] write_addr_1[0]=rf_io_waddr_1[0]
+ write_addr_2[4]=rf_io_waddr_2[4] write_addr_2[3]=rf_io_waddr_2[3]
+ write_addr_2[2]=rf_io_waddr_2[2] write_addr_2[1]=rf_io_waddr_2[1]
+ write_addr_2[0]=rf_io_wen_2 write_data_1[21]=rf_io_wdata_1[21]
+ write_data_1[20]=rf_io_wdata_1[20] write_data_1[19]=rf_io_wdata_1[19]
+ write_data_1[18]=rf_io_wdata_1[18] write_data_1[17]=rf_io_wdata_1[17]
+ write_data_1[16]=rf_io_wdata_1[16] write_data_1[15]=rf_io_wdata_1[15]
+ write_data_1[14]=rf_io_wdata_1[14] write_data_1[13]=rf_io_wdata_1[13]
+ write_data_1[12]=rf_io_wdata_1[12] write_data_1[11]=rf_io_wdata_1[11]
+ write_data_1[10]=rf_io_wdata_1[10] write_data_1[9]=rf_io_wdata_1[9]
+ write_data_1[8]=rf_io_wdata_1[8] write_data_1[7]=rf_io_wdata_1[7]
+ write_data_1[6]=rf_io_wdata_1[6] write_data_1[5]=rf_io_wdata_1[5]
+ write_data_1[4]=rf_io_wdata_1[4] write_data_1[3]=rf_io_wdata_1[3]
+ write_data_1[2]=rf_io_wdata_1[2] write_data_1[1]=rf_io_wdata_1[1]
+ write_data_1[0]=rf_io_wdata_1[0] write_data_2[21]=rf_io_wdata_2[21]
+ write_data_2[20]=rf_io_wdata_2[20] write_data_2[19]=rf_io_wdata_2[19]
+ write_data_2[18]=rf_io_wdata_2[18] write_data_2[17]=rf_io_wdata_2[17]
+ write_data_2[16]=rf_io_wdata_2[16] write_data_2[15]=rf_io_wdata_2[15]
+ write_data_2[14]=rf_io_wdata_2[14] write_data_2[13]=rf_io_wdata_2[13]
+ write_data_2[12]=rf_io_wdata_2[12] write_data_2[11]=rf_io_wdata_2[11]
+ write_data_2[10]=rf_io_wdata_2[10] write_data_2[9]=rf_io_wdata_2[9]
+ write_data_2[8]=rf_io_wdata_2[8] write_data_2[7]=rf_io_wdata_2[7]
+ write_data_2[6]=rf_io_wdata_2[6] write_data_2[5]=rf_io_wdata_2[5]
+ write_data_2[4]=rf_io_wdata_2[4] write_data_2[3]=rf_io_wdata_2[3]
+ write_data_2[2]=rf_io_wdata_2[2] write_data_2[1]=rf_io_wdata_2[1]
+ write_data_2[0]=rf_io_wdata_2[0] rst_n_BAR=n206 i_rst_n=FE_OFN16_i_rst_n
+ FE_OFN27_i_rst_n=FE_OFN24_i_rst_n FE_OFN18_i_rst_n=FE_OFN19_i_rst_n
+ clk_clone3=CTS_170 clk_clone2=CTS_183 clk_clone1=CTS_190 clk=CTS_191
Xclk_gate_g_cnt_d2_reg SNPS_CLOCK_GATE_HIGH_CHIP_0 $PINS EN=mac_en
+ ENCLK=net1618 CLK=CTS_195
Xclk_gate_c_buf_i_reg[0] SNPS_CLOCK_GATE_HIGH_CHIP_10 $PINS EN=N61
+ ENCLK=CTS_166 CLK=CTS_167
Xclk_gate_c_buf_i_reg[1] SNPS_CLOCK_GATE_HIGH_CHIP_9 $PINS EN=N61 ENCLK=CTS_163
+ CLK=CTS_167
Xclk_gate_c_buf_i_reg[3] SNPS_CLOCK_GATE_HIGH_CHIP_8 $PINS CLK=CTS_189 EN=N61
+ ENCLK=CTS_178 CLK_clone1=CTS_167
Xclk_gate_c_buf_r_reg[0] SNPS_CLOCK_GATE_HIGH_CHIP_7 $PINS EN=N61 ENCLK=CTS_160
+ CLK=CTS_167
Xclk_gate_c_buf_r_reg[2] SNPS_CLOCK_GATE_HIGH_CHIP_6 $PINS EN=N61 ENCLK=CTS_157
+ CLK=CTS_167
Xclk_gate_delayed_mac_group_reg SNPS_CLOCK_GATE_HIGH_CHIP_5 $PINS EN=N87
+ ENCLK=CTS_154 CLK=CTS_167
Xclk_gate_delayed_out2_reg SNPS_CLOCK_GATE_HIGH_CHIP_4 $PINS EN=N87
+ ENCLK=CTS_151 CLK=CTS_167
Xclk_gate_o_counter_r_reg SNPS_CLOCK_GATE_HIGH_CHIP_3 $PINS EN=FE_PHN1413_N286
+ ENCLK=net1658 CLK=CTS_195
Xclk_gate_key_r_reg SNPS_CLOCK_GATE_HIGH_CHIP_2 $PINS EN=N292 ENCLK=net1663
+ CLK=CTS_148
Xclk_gate_counter_r_reg SNPS_CLOCK_GATE_HIGH_CHIP_1 $PINS EN=N299 ENCLK=net1668
+ CLK=CTS_195
Xr118 CHIP_DW01_inc_1_DW01_inc_3 $PINS A[8]=counter_r[8] A[7]=current_g[2]
+ A[6]=FE_PHN1170_current_g_1 A[5]=FE_PHN1172_current_g_0
+ A[4]=FE_PHN1168_current_n_4 A[3]=FE_PHN1174_current_n_3 A[2]=current_n[2]
+ A[1]=FE_PHN1173_current_n_1 A[0]=current_n[0] SUM[8]=N113 SUM[7]=N112
+ SUM[6]=N111 SUM[5]=N110 SUM[4]=N109 SUM[3]=N108 SUM[2]=N107 SUM[1]=N106
+ SUM[0]=FE_UNCONNECTED_1
Xmult_135 CHIP_DW02_mult_1 $PINS A[7]=key_r[7] A[6]=key_r[6] A[5]=key_r[5]
+ A[4]=key_r[4] A[3]=key_r[3] A[2]=key_r[2] A[1]=key_r[1] A[0]=key_r[0]
+ B[5]=FE_DBTN4_k_ord_1_0 B[4]=k_ord_1[4] B[3]=k_ord_1[3] B[2]=k_ord_1[2]
+ B[1]=k_ord_1[1] B[0]=k_ord_1[0] TC=n268 PRODUCT[13]=SYNOPSYS_UNCONNECTED__0
+ PRODUCT[12]=SYNOPSYS_UNCONNECTED__1 PRODUCT[11]=SYNOPSYS_UNCONNECTED__2
+ PRODUCT[10]=SYNOPSYS_UNCONNECTED__3 PRODUCT[9]=SYNOPSYS_UNCONNECTED__4
+ PRODUCT[8]=SYNOPSYS_UNCONNECTED__5 PRODUCT[7]=N83 PRODUCT[6]=N82 PRODUCT[5]=N81
+ PRODUCT[4]=N80 PRODUCT[3]=N79 PRODUCT[2]=N78 PRODUCT[1]=N77
+ PRODUCT[0]=phase_1[8]
Xmult_134 CHIP_DW02_mult_0 $PINS A[4]=c_group_idx[2]
+ A[3]=FE_DBTN1_c_group_idx_1 A[2]=FE_DBTN3_c_group_idx_0 A[1]=FE_DBTN10_n114
+ A[0]=n268 B[7]=key_r[7] B[6]=key_r[6] B[5]=key_r[5] B[4]=key_r[4] B[3]=key_r[3]
+ B[2]=key_r[2] B[1]=key_r[1] B[0]=key_r[0] TC=n268
+ PRODUCT[12]=SYNOPSYS_UNCONNECTED__6 PRODUCT[11]=SYNOPSYS_UNCONNECTED__7
+ PRODUCT[10]=SYNOPSYS_UNCONNECTED__8 PRODUCT[9]=SYNOPSYS_UNCONNECTED__9
+ PRODUCT[8]=SYNOPSYS_UNCONNECTED__10 PRODUCT[7]=N75 PRODUCT[6]=N74
+ PRODUCT[5]=N73 PRODUCT[4]=N72 PRODUCT[3]=N71 PRODUCT[2]=N70
+ PRODUCT[1]=phase_0[9] PRODUCT[0]=SYNOPSYS_UNCONNECTED__11 n114=n114
+ FE_OFN37_n114=FE_OFN33_n114
XU330 MOAI1HP $PINS O=mac_in_imag[1] A1=n224 A2=n140 B1=n138
+ B2=rf_d_rdata_1[18]
XU332 MOAI1HT $PINS O=mac_in_imag[0] A1=n146 A2=FE_OFN346_rf_io_rdata_1_8
+ B1=n122 B2=rf_d_rdata_1[17]
XU333 ND3P $PINS O=n146 I1=state_r[1] I2=FE_DBTN9_state_r_0 I3=n150
XU335 MOAI1H $PINS O=mac_in_imag[3] A1=n146 A2=n139 B1=n122 B2=rf_d_rdata_1[20]
XU350 INV2 $PINS O=n223 I=rf_io_rdata_1[10]
XU369 MOAI1H $PINS O=mac_in_real[3] A1=n230 A2=n72 B1=n146 B2=rf_d_rdata_1[3]
XU379 INV2 $PINS O=n233 I=rf_io_rdata_1[0]
XU392 MUX2 $PINS O=FE_PHN1405_c_in_r_1_4 S=FE_OFN87_FE_DBTN10_n114
+ A=c_buf_r[3][4] B=c_buf_r[1][4]
XU397 MUX2 $PINS O=c_in_r_1[3] S=FE_OFN87_FE_DBTN10_n114 A=c_buf_r[3][3]
+ B=c_buf_r[1][3]
XU433 MUX2 $PINS O=c_in_r_1[1] S=FE_OFN87_FE_DBTN10_n114 A=c_buf_r[3][1]
+ B=c_buf_r[1][1]
XU441 ND2P $PINS O=mac_en I1=n164 I2=n64
XU650 INV6CK $PINS O=n150 I=FE_PHN1175_state_r_2
.ENDS

.SUBCKT CHIP clk rst_n i_valid i_ready o_ready o_valid i_data[15] i_data[14]
+ i_data[13] i_data[12] i_data[11] i_data[10] i_data[9] i_data[8] i_data[7]
+ i_data[6] i_data[5] i_data[4] i_data[3] i_data[2] i_data[1] i_data[0]
+ o_data[10] o_data[9] o_data[8] o_data[7] o_data[6] o_data[5] o_data[4]
+ o_data[3] o_data[2] o_data[1] o_data[0]
XFE_OFC8_n_logic0 BUF2CK $PINS O=FE_OFN8_n_logic0 I=FE_OFN6_n_logic0
XFE_OFC7_n_logic0 BUF3 $PINS O=FE_OFN7_n_logic0 I=n_logic0
XFE_OFC6_n_logic0 BUF2CK $PINS O=FE_OFN6_n_logic0 I=n_logic0
XU_TIE0 TIE0 $PINS O=n_logic0
XU_TIE1 TIE1 $PINS O=n_logic1
Xipad_clk XMD $PINS O=i_clk I=clk PU=FE_OFN8_n_logic0 PD=FE_OFN8_n_logic0
+ SMT=FE_OFN8_n_logic0
Xipad_rst_n XMD $PINS O=i_rst_n I=rst_n PU=FE_OFN8_n_logic0 PD=FE_OFN8_n_logic0
+ SMT=FE_OFN8_n_logic0
Xipad_i_valid XMD $PINS O=i_i_valid I=i_valid PU=FE_OFN8_n_logic0
+ PD=FE_OFN8_n_logic0 SMT=FE_OFN8_n_logic0
Xipad_o_ready XMD $PINS O=i_o_ready I=o_ready PU=FE_OFN8_n_logic0
+ PD=FE_OFN8_n_logic0 SMT=FE_OFN8_n_logic0
Xipad_i_data_0 XMD $PINS O=i_i_data[0] I=i_data[0] PU=FE_OFN8_n_logic0
+ PD=FE_OFN8_n_logic0 SMT=FE_OFN8_n_logic0
Xipad_i_data_1 XMD $PINS O=i_i_data[1] I=i_data[1] PU=FE_OFN8_n_logic0
+ PD=FE_OFN8_n_logic0 SMT=FE_OFN8_n_logic0
Xipad_i_data_2 XMD $PINS O=i_i_data[2] I=i_data[2] PU=FE_OFN8_n_logic0
+ PD=FE_OFN8_n_logic0 SMT=FE_OFN8_n_logic0
Xipad_i_data_3 XMD $PINS O=i_i_data[3] I=i_data[3] PU=FE_OFN8_n_logic0
+ PD=FE_OFN8_n_logic0 SMT=FE_OFN8_n_logic0
Xipad_i_data_4 XMD $PINS O=i_i_data[4] I=i_data[4] PU=FE_OFN8_n_logic0
+ PD=FE_OFN8_n_logic0 SMT=FE_OFN8_n_logic0
Xipad_i_data_5 XMD $PINS O=i_i_data[5] I=i_data[5] PU=FE_OFN8_n_logic0
+ PD=FE_OFN8_n_logic0 SMT=FE_OFN8_n_logic0
Xipad_i_data_6 XMD $PINS O=i_i_data[6] I=i_data[6] PU=FE_OFN6_n_logic0
+ PD=FE_OFN6_n_logic0 SMT=FE_OFN6_n_logic0
Xipad_i_data_7 XMD $PINS O=i_i_data[7] I=i_data[7] PU=FE_OFN6_n_logic0
+ PD=FE_OFN6_n_logic0 SMT=FE_OFN6_n_logic0
Xipad_i_data_8 XMD $PINS O=i_i_data[8] I=i_data[8] PU=FE_OFN6_n_logic0
+ PD=FE_OFN6_n_logic0 SMT=FE_OFN6_n_logic0
Xipad_i_data_9 XMD $PINS O=i_i_data[9] I=i_data[9] PU=FE_OFN6_n_logic0
+ PD=FE_OFN6_n_logic0 SMT=FE_OFN6_n_logic0
Xipad_i_data_10 XMD $PINS O=i_i_data[10] I=i_data[10] PU=FE_OFN6_n_logic0
+ PD=FE_OFN6_n_logic0 SMT=FE_OFN6_n_logic0
Xipad_i_data_11 XMD $PINS O=i_i_data[11] I=i_data[11] PU=FE_OFN6_n_logic0
+ PD=FE_OFN6_n_logic0 SMT=FE_OFN6_n_logic0
Xipad_i_data_12 XMD $PINS O=i_i_data[12] I=i_data[12] PU=FE_OFN6_n_logic0
+ PD=FE_OFN6_n_logic0 SMT=FE_OFN6_n_logic0
Xipad_i_data_13 XMD $PINS O=i_i_data[13] I=i_data[13] PU=FE_OFN6_n_logic0
+ PD=FE_OFN6_n_logic0 SMT=FE_OFN6_n_logic0
Xipad_i_data_14 XMD $PINS O=i_i_data[14] I=i_data[14] PU=FE_OFN6_n_logic0
+ PD=FE_OFN6_n_logic0 SMT=FE_OFN6_n_logic0
Xipad_i_data_15 XMD $PINS O=i_i_data[15] I=i_data[15] PU=FE_OFN8_n_logic0
+ PD=FE_OFN6_n_logic0 SMT=FE_OFN8_n_logic0
Xopad_i_ready YA2GSD $PINS O=i_ready I=i_i_ready E=n_logic1 E2=n_logic0
+ E4=n_logic0 E8=n_logic0 SR=n_logic0
Xopad_o_valid YA2GSD $PINS O=o_valid I=i_o_valid E=n_logic1 E2=n_logic0
+ E4=n_logic0 E8=n_logic0 SR=n_logic0
Xopad_o_data_0 YA2GSD $PINS O=o_data[0] I=i_o_data[0] E=n_logic1 E2=n_logic0
+ E4=n_logic0 E8=n_logic0 SR=n_logic0
Xopad_o_data_1 YA2GSD $PINS O=o_data[1] I=i_o_data[1] E=n_logic1 E2=n_logic0
+ E4=n_logic0 E8=n_logic0 SR=n_logic0
Xopad_o_data_2 YA2GSD $PINS O=o_data[2] I=i_o_data[2] E=n_logic1 E2=n_logic0
+ E4=FE_OFN7_n_logic0 E8=n_logic0 SR=FE_OFN7_n_logic0
Xopad_o_data_3 YA2GSD $PINS O=o_data[3] I=i_o_data[3] E=n_logic1
+ E2=FE_OFN7_n_logic0 E4=FE_OFN7_n_logic0 E8=FE_OFN7_n_logic0 SR=FE_OFN7_n_logic0
Xopad_o_data_4 YA2GSD $PINS O=o_data[4] I=i_o_data[4] E=n_logic1
+ E2=FE_OFN7_n_logic0 E4=FE_OFN7_n_logic0 E8=FE_OFN7_n_logic0 SR=FE_OFN7_n_logic0
Xopad_o_data_5 YA2GSD $PINS O=o_data[5] I=i_o_data[5] E=n_logic1
+ E2=FE_OFN7_n_logic0 E4=FE_OFN7_n_logic0 E8=FE_OFN7_n_logic0 SR=FE_OFN7_n_logic0
Xopad_o_data_6 YA2GSD $PINS O=o_data[6] I=i_o_data[6] E=n_logic1
+ E2=FE_OFN7_n_logic0 E4=FE_OFN7_n_logic0 E8=FE_OFN7_n_logic0 SR=FE_OFN7_n_logic0
Xopad_o_data_7 YA2GSD $PINS O=o_data[7] I=i_o_data[7] E=n_logic1
+ E2=FE_OFN7_n_logic0 E4=FE_OFN7_n_logic0 E8=FE_OFN7_n_logic0 SR=FE_OFN7_n_logic0
Xopad_o_data_8 YA2GSD $PINS O=o_data[8] I=i_o_data[8] E=n_logic1
+ E2=FE_OFN7_n_logic0 E4=FE_OFN7_n_logic0 E8=FE_OFN7_n_logic0 SR=FE_OFN7_n_logic0
Xopad_o_data_9 YA2GSD $PINS O=o_data[9] I=i_o_data[9] E=n_logic1
+ E2=FE_OFN7_n_logic0 E4=FE_OFN7_n_logic0 E8=FE_OFN7_n_logic0 SR=FE_OFN7_n_logic0
Xopad_o_data_10 YA2GSD $PINS O=o_data[10] I=i_o_data[10] E=n_logic1
+ E2=FE_OFN8_n_logic0 E4=FE_OFN8_n_logic0 E8=FE_OFN8_n_logic0 SR=FE_OFN8_n_logic0
XU_CORE CHIP_core $PINS clk=i_clk rst_n=i_rst_n i_valid=i_i_valid
+ i_ready=i_i_ready o_ready=i_o_ready o_valid=i_o_valid i_data[15]=i_i_data[15]
+ i_data[14]=i_i_data[14] i_data[13]=i_i_data[13] i_data[12]=i_i_data[12]
+ i_data[11]=i_i_data[11] i_data[10]=i_i_data[10] i_data[9]=i_i_data[9]
+ i_data[8]=i_i_data[8] i_data[7]=i_i_data[7] i_data[6]=i_i_data[6]
+ i_data[5]=i_i_data[5] i_data[4]=i_i_data[4] i_data[3]=i_i_data[3]
+ i_data[2]=i_i_data[2] i_data[1]=i_i_data[1] i_data[0]=i_i_data[0]
+ o_data[10]=i_o_data[10] o_data[9]=i_o_data[9] o_data[8]=i_o_data[8]
+ o_data[7]=i_o_data[7] o_data[6]=i_o_data[6] o_data[5]=i_o_data[5]
+ o_data[4]=i_o_data[4] o_data[3]=i_o_data[3] o_data[2]=i_o_data[2]
+ o_data[1]=i_o_data[1] o_data[0]=i_o_data[0]
.ENDS

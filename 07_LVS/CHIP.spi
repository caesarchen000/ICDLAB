$ Spice netlist generated by v2lvs
$ v2022.3_33.19    Tue Sep 6 12:09:54 PDT 2022
.INCLUDE "core.spi"
.INCLUDE "umc18_io_lvs.spi"
*.BUSDELIMITER [

.SUBCKT SNPS_CLOCK_GATE_HIGH_cordic_rotation_1_0 EN ENCLK CLK
*.CONNECT net2417 EN
XFE_PHC833_net2420 DELC $PINS O=FE_PHN833_net2420 I=net2420
Xlatch QDBHN $PINS Q=net2420 D=net2417 CKB=CLK
Xmain_gate AN2T $PINS O=ENCLK I1=FE_PHN833_net2420 I2=CLK
.ENDS

.SUBCKT SNPS_CLOCK_GATE_HIGH_cordic_rotation_1_4 EN ENCLK CLK
*.CONNECT net2417 EN
XFE_PHC870_net2420 DELC $PINS O=FE_PHN870_net2420 I=net2420
Xlatch QDBHN $PINS Q=net2420 D=net2417 CKB=CLK
Xmain_gate AN2T $PINS O=ENCLK I1=FE_PHN870_net2420 I2=CLK
.ENDS

.SUBCKT SNPS_CLOCK_GATE_HIGH_cordic_rotation_1_3 EN ENCLK CLK
*.CONNECT net2417 EN
XFE_PHC860_net2420 DELC $PINS O=FE_PHN860_net2420 I=net2420
Xlatch QDBHN $PINS Q=net2420 D=net2417 CKB=CLK
Xmain_gate AN2 $PINS O=ENCLK I1=FE_PHN860_net2420 I2=CLK
.ENDS

.SUBCKT SNPS_CLOCK_GATE_HIGH_cordic_rotation_1_2 EN ENCLK CLK
*.CONNECT net2417 EN
XFE_PHC852_net2420 DELC $PINS O=net2420 I=FE_PHN852_net2420
Xlatch QDBHN $PINS Q=FE_PHN852_net2420 D=net2417 CKB=CLK
Xmain_gate AN2T $PINS O=ENCLK I1=net2420 I2=CLK
.ENDS

.SUBCKT SNPS_CLOCK_GATE_HIGH_cordic_rotation_1_1 EN ENCLK CLK
*.CONNECT ENCLK net2416
*.CONNECT net2417 EN
XFE_PHC862_net2420 DELC $PINS O=FE_PHN862_net2420 I=net2420
Xlatch QDBHN $PINS Q=net2420 D=net2417 CKB=CLK
Xmain_gate AN2P $PINS O=net2416 I1=FE_PHN862_net2420 I2=CLK
.ENDS

.SUBCKT cordic_rotation_1_DW01_add_2_DW01_add_8 A[15] A[14] A[13] A[12] A[11]
+ A[10] A[9] A[8] A[7] A[6] A[5] A[4] A[3] A[2] A[1] A[0] B[15] B[14] B[13]
+ B[12] B[11] B[10] B[9] B[8] B[7] B[6] B[5] B[4] B[3] B[2] B[1] B[0] CI
+ SUM[15] SUM[14] SUM[13] SUM[12] SUM[11] SUM[10] SUM[9] SUM[8] SUM[7] SUM[6]
+ SUM[5] SUM[4] SUM[3] SUM[2] SUM[1] SUM[0] CO
XU1_12 FA1S $PINS S=SUM[12] CO=carry[13] A=A[12] B=B[12] CI=carry[12]
XU1_11 FA1S $PINS S=SUM[11] CO=carry[12] A=A[11] B=B[11] CI=carry[11]
XU1_5 FA1S $PINS S=SUM[5] CO=carry[6] A=A[5] B=B[5] CI=carry[5]
XU1_7 FA1S $PINS S=SUM[7] CO=carry[8] A=A[7] B=B[7] CI=carry[7]
XU1_6 FA1S $PINS S=SUM[6] CO=carry[7] A=A[6] B=B[6] CI=carry[6]
XU1_8 FA1S $PINS S=SUM[8] CO=carry[9] A=A[8] B=B[8] CI=carry[8]
XU1_9 FA1S $PINS S=SUM[9] CO=carry[10] A=A[9] B=B[9] CI=carry[9]
XU1_10 FA1S $PINS S=SUM[10] CO=carry[11] A=A[10] B=B[10] CI=carry[10]
XU1_4 FA1S $PINS S=SUM[4] CO=carry[5] A=A[4] B=B[4] CI=carry[4]
XU1_2 FA1S $PINS S=SUM[2] CO=carry[3] A=A[2] B=B[2] CI=carry[2]
XU1_3 FA1S $PINS S=SUM[3] CO=carry[4] A=A[3] B=B[3] CI=carry[3]
XU1_1 FA1S $PINS S=SUM[1] CO=carry[2] A=A[1] B=B[1] CI=n1
XU1_13 FA1S $PINS S=SUM[13] CO=carry[14] A=A[13] B=B[13] CI=carry[13]
XU1 AN2 $PINS O=n1 I1=B[0] I2=A[0]
XU2 XNR2HS $PINS O=SUM[15] I1=A[15] I2=n2
XU3 XOR2HS $PINS O=SUM[14] I1=A[14] I2=carry[14]
XU4 XOR2HS $PINS O=SUM[0] I1=B[0] I2=A[0]
XU5 ND2 $PINS O=n2 I1=A[14] I2=carry[14]
.ENDS

.SUBCKT cordic_rotation_1_DW01_sub_0_DW01_sub_34 A[17] A[16] A[15] A[14] A[13]
+ A[12] A[11] A[10] A[9] A[8] A[7] A[6] A[5] A[4] A[3] A[2] A[1] A[0] B[17]
+ B[16] B[15] B[14] B[13] B[12] B[11] B[10] B[9] B[8] B[7] B[6] B[5] B[4] B[3]
+ B[2] B[1] B[0] CI DIFF[17] DIFF[16] DIFF[15] DIFF[14] DIFF[13] DIFF[12]
+ DIFF[11] DIFF[10] DIFF[9] DIFF[8] DIFF[7] DIFF[6] DIFF[5] DIFF[4] DIFF[3]
+ DIFF[2] DIFF[1] DIFF[0] CO
XFE_RC_1759_0 XOR3 $PINS O=DIFF[10] I1=A[10] I2=n3 I3=carry[10]
XFE_RC_1758_0 MAO222 $PINS O=carry[11] A1=A[10] B1=n3 C1=carry[10]
XFE_RC_1566_0 XOR3 $PINS O=DIFF[9] I1=A[9] I2=n10 I3=carry[9]
XFE_RC_1565_0 MAO222 $PINS O=carry[10] A1=A[9] B1=n10 C1=carry[9]
XU2_1 FA1S $PINS S=DIFF[1] CO=carry[2] A=A[1] B=n11 CI=carry[1]
XU2_6 FA1 $PINS S=DIFF[6] CO=carry[7] A=A[6] B=n16 CI=carry[6]
XU2_14 FA1S $PINS S=DIFF[14] CO=carry[15] A=A[14] B=n6 CI=carry[14]
XU2_15 FA1 $PINS S=DIFF[15] CO=carry[16] A=A[15] B=n7 CI=carry[15]
XU2_16 FA1S $PINS S=DIFF[16] CO=carry[17] A=A[16] B=n8 CI=carry[16]
XU2_11 FA1 $PINS S=DIFF[11] CO=carry[12] A=A[11] B=n4 CI=carry[11]
XU2_12 FA1 $PINS S=DIFF[12] CO=carry[13] A=A[12] B=n9 CI=carry[12]
XU2_13 FA1S $PINS S=DIFF[13] CO=carry[14] A=A[13] B=n5 CI=carry[13]
XU2_17 XOR3 $PINS O=DIFF[17] I1=A[17] I2=n8 I3=carry[17]
XU2_5 FA1 $PINS S=DIFF[5] CO=carry[6] A=A[5] B=n15 CI=carry[5]
XU2_2 FA1S $PINS S=DIFF[2] CO=carry[3] A=A[2] B=n12 CI=carry[2]
XU2_3 FA1 $PINS S=DIFF[3] CO=carry[4] A=A[3] B=n13 CI=carry[3]
XU2_7 FA1 $PINS S=DIFF[7] CO=carry[8] A=A[7] B=n17 CI=carry[7]
XU2_4 FA1 $PINS S=DIFF[4] CO=carry[5] A=A[4] B=n14 CI=carry[4]
XU2_8 FA1 $PINS S=DIFF[8] CO=carry[9] A=A[8] B=n18 CI=carry[8]
XU1 INV1S $PINS O=n12 I=B[2]
XU2 INV1S $PINS O=n2 I=B[0]
XU3 INV1S $PINS O=n8 I=B[17]
XU4 INV1S $PINS O=n5 I=B[13]
XU5 INV1S $PINS O=n3 I=B[10]
XU6 INV1S $PINS O=n9 I=B[12]
XU7 INV1S $PINS O=n4 I=B[11]
XU8 INV1S $PINS O=n14 I=B[4]
XU9 INV1S $PINS O=n15 I=B[5]
XU10 INV1S $PINS O=n18 I=B[8]
XU11 INV1S $PINS O=n17 I=B[7]
XU12 INV1S $PINS O=n10 I=B[9]
XU13 INV1S $PINS O=n7 I=B[15]
XU14 INV1S $PINS O=n6 I=B[14]
XU15 INV1S $PINS O=n16 I=B[6]
XU16 INV1S $PINS O=n11 I=B[1]
XU17 INV1S $PINS O=n1 I=A[0]
XU18 INV1S $PINS O=n13 I=B[3]
XU19 XNR2HS $PINS O=DIFF[0] I1=n2 I2=A[0]
XU20 ND2 $PINS O=carry[1] I1=B[0] I2=n1
.ENDS

.SUBCKT cordic_rotation_1_DW01_add_3_DW01_add_9 A[17] A[16] A[15] A[14] A[13]
+ A[12] A[11] A[10] A[9] A[8] A[7] A[6] A[5] A[4] A[3] A[2] A[1] A[0] B[17]
+ B[16] B[15] B[14] B[13] B[12] B[11] B[10] B[9] B[8] B[7] B[6] B[5] B[4] B[3]
+ B[2] B[1] B[0] CI SUM[17] SUM[16] SUM[15] SUM[14] SUM[13] SUM[12] SUM[11]
+ SUM[10] SUM[9] SUM[8] SUM[7] SUM[6] SUM[5] SUM[4] SUM[3] SUM[2] SUM[1] SUM[0]
+ CO
XU1_14 FA1S $PINS S=SUM[14] CO=carry[15] A=A[14] B=B[14] CI=carry[14]
XU1_1 FA1 $PINS S=SUM[1] CO=carry[2] A=A[1] B=B[1] CI=n1
XU1_9 FA1S $PINS S=SUM[9] CO=carry[10] A=A[9] B=B[9] CI=carry[9]
XU1_6 FA1S $PINS S=SUM[6] CO=carry[7] A=A[6] B=B[6] CI=carry[6]
XU1_5 FA1 $PINS S=SUM[5] CO=carry[6] A=A[5] B=B[5] CI=carry[5]
XU1_4 FA1 $PINS S=SUM[4] CO=carry[5] A=A[4] B=B[4] CI=carry[4]
XU1_3 FA1 $PINS S=SUM[3] CO=carry[4] A=A[3] B=B[3] CI=carry[3]
XU1_7 FA1 $PINS S=SUM[7] CO=carry[8] A=A[7] B=B[7] CI=carry[7]
XU1_8 FA1 $PINS S=SUM[8] CO=carry[9] A=A[8] B=B[8] CI=carry[8]
XU1_2 FA1 $PINS S=SUM[2] CO=carry[3] A=A[2] B=B[2] CI=carry[2]
XU1_11 FA1 $PINS S=SUM[11] CO=carry[12] A=A[11] B=B[11] CI=carry[11]
XU1_12 FA1 $PINS S=SUM[12] CO=carry[13] A=A[12] B=B[12] CI=carry[12]
XU1_10 FA1 $PINS S=SUM[10] CO=carry[11] A=A[10] B=B[10] CI=carry[10]
XU1_13 FA1 $PINS S=SUM[13] CO=carry[14] A=A[13] B=B[13] CI=carry[13]
XU1_15 FA1S $PINS S=SUM[15] CO=carry[16] A=A[15] B=B[15] CI=carry[15]
XU1_16 FA1S $PINS S=SUM[16] CO=carry[17] A=A[16] B=B[16] CI=carry[16]
XU1_17 XOR3S $PINS O=SUM[17] I1=A[17] I2=B[17] I3=carry[17]
XU1 AN2 $PINS O=n1 I1=B[0] I2=A[0]
XU2 XOR2HS $PINS O=SUM[0] I1=B[0] I2=A[0]
.ENDS

.SUBCKT cordic_rotation_1_DW01_sub_1_DW01_sub_35 A[15] A[14] A[13] A[12] A[11]
+ A[10] A[9] A[8] A[7] A[6] A[5] A[4] A[3] A[2] A[1] A[0] B[15] B[14] B[13]
+ B[12] B[11] B[10] B[9] B[8] B[7] B[6] B[5] B[4] B[3] B[2] B[1] B[0] CI
+ DIFF[15] DIFF[14] DIFF[13] DIFF[12] DIFF[11] DIFF[10] DIFF[9] DIFF[8] DIFF[7]
+ DIFF[6] DIFF[5] DIFF[4] DIFF[3] DIFF[2] DIFF[1] DIFF[0] CO n58 n247
XU2_9 FA1S $PINS S=DIFF[9] CO=carry[10] A=A[9] B=n11 CI=carry[9]
XU2_12 FA1S $PINS S=DIFF[12] CO=carry[13] A=A[12] B=n58 CI=carry[12]
XU2_8 FA1S $PINS S=DIFF[8] CO=carry[9] A=A[8] B=n14 CI=carry[8]
XU2_11 FA1S $PINS S=DIFF[11] CO=carry[12] A=A[11] B=n2 CI=carry[11]
XU2_7 FA1S $PINS S=DIFF[7] CO=carry[8] A=A[7] B=n8 CI=carry[7]
XU2_10 FA1S $PINS S=DIFF[10] CO=carry[11] A=A[10] B=n247 CI=carry[10]
XU2_6 FA1S $PINS S=DIFF[6] CO=carry[7] A=A[6] B=n15 CI=carry[6]
XU2_5 FA1S $PINS S=DIFF[5] CO=carry[6] A=A[5] B=n9 CI=carry[5]
XU2_4 FA1S $PINS S=DIFF[4] CO=carry[5] A=A[4] B=n6 CI=carry[4]
XU2_3 FA1S $PINS S=DIFF[3] CO=carry[4] A=A[3] B=n12 CI=carry[3]
XU2_2 FA1S $PINS S=DIFF[2] CO=carry[3] A=A[2] B=n5 CI=carry[2]
XU2_1 FA1S $PINS S=DIFF[1] CO=carry[2] A=A[1] B=n7 CI=carry[1]
XU2_13 FA1S $PINS S=DIFF[13] CO=carry[14] A=A[13] B=B[13] CI=carry[13]
XU1 OR2 $PINS O=carry[15] I1=carry[14] I2=A[14]
XU2 INV1S $PINS O=n10 I=B[0]
XU4 XNR2HS $PINS O=DIFF[15] I1=A[15] I2=carry[15]
XU5 INV1S $PINS O=n7 I=B[1]
XU6 INV1S $PINS O=n1 I=A[0]
XU7 INV1S $PINS O=n5 I=B[2]
XU8 INV1S $PINS O=n12 I=B[3]
XU9 INV1S $PINS O=n6 I=B[4]
XU10 INV1S $PINS O=n9 I=B[5]
XU11 INV1S $PINS O=n15 I=B[6]
XU13 INV1S $PINS O=n8 I=B[7]
XU14 INV1S $PINS O=n2 I=B[11]
XU15 INV1S $PINS O=n14 I=B[8]
XU17 INV1S $PINS O=n11 I=B[9]
XU18 XNR2HS $PINS O=DIFF[14] I1=A[14] I2=carry[14]
XU19 XNR2HS $PINS O=DIFF[0] I1=n10 I2=A[0]
XU20 ND2 $PINS O=carry[1] I1=B[0] I2=n1
.ENDS

.SUBCKT cordic_rotation_1_DW01_add_4_DW01_add_10 A[17] A[16] A[15] A[14] A[13]
+ A[12] A[11] A[10] A[9] A[8] A[7] A[6] A[5] A[4] A[3] A[2] A[1] A[0] B[17]
+ B[16] B[15] B[14] B[13] B[12] B[11] B[10] B[9] B[8] B[7] B[6] B[5] B[4] B[3]
+ B[2] B[1] B[0] CI SUM[17] SUM[16] SUM[15] SUM[14] SUM[13] SUM[12] SUM[11]
+ SUM[10] SUM[9] SUM[8] SUM[7] SUM[6] SUM[5] SUM[4] SUM[3] SUM[2] SUM[1] SUM[0]
+ CO
XFE_RC_1568_0 XOR3 $PINS O=SUM[15] I1=A[15] I2=B[15] I3=carry[15]
XFE_RC_1567_0 MAO222 $PINS O=carry[16] A1=A[15] B1=B[15] C1=carry[15]
XU1_14 FA1S $PINS S=SUM[14] CO=carry[15] A=A[14] B=B[14] CI=carry[14]
XU1_1 FA1S $PINS S=SUM[1] CO=carry[2] A=A[1] B=B[1] CI=n1
XU1_9 FA1 $PINS S=SUM[9] CO=carry[10] A=A[9] B=B[9] CI=carry[9]
XU1_6 FA1 $PINS S=SUM[6] CO=carry[7] A=A[6] B=B[6] CI=carry[6]
XU1_5 FA1 $PINS S=SUM[5] CO=carry[6] A=A[5] B=B[5] CI=carry[5]
XU1_4 FA1 $PINS S=SUM[4] CO=carry[5] A=A[4] B=B[4] CI=carry[4]
XU1_3 FA1 $PINS S=SUM[3] CO=carry[4] A=A[3] B=B[3] CI=carry[3]
XU1_7 FA1 $PINS S=SUM[7] CO=carry[8] A=A[7] B=B[7] CI=carry[7]
XU1_8 FA1 $PINS S=SUM[8] CO=carry[9] A=A[8] B=B[8] CI=carry[8]
XU1_2 FA1S $PINS S=SUM[2] CO=carry[3] A=A[2] B=B[2] CI=carry[2]
XU1_11 FA1 $PINS S=SUM[11] CO=carry[12] A=A[11] B=B[11] CI=carry[11]
XU1_12 FA1 $PINS S=SUM[12] CO=carry[13] A=A[12] B=B[12] CI=carry[12]
XU1_10 FA1 $PINS S=SUM[10] CO=carry[11] A=A[10] B=B[10] CI=carry[10]
XU1_13 FA1S $PINS S=SUM[13] CO=carry[14] A=A[13] B=B[13] CI=carry[13]
XU1_16 FA1S $PINS S=SUM[16] CO=carry[17] A=A[16] B=B[16] CI=carry[16]
XU1_17 XOR3S $PINS O=SUM[17] I1=A[17] I2=B[17] I3=carry[17]
XU1 AN2 $PINS O=n1 I1=B[0] I2=A[0]
XU2 XOR2HS $PINS O=SUM[0] I1=B[0] I2=A[0]
.ENDS

.SUBCKT cordic_rotation_1_DW01_sub_2_DW01_sub_36 A[17] A[16] A[15] A[14] A[13]
+ A[12] A[11] A[10] A[9] A[8] A[7] A[6] A[5] A[4] A[3] A[2] A[1] A[0] B[17]
+ B[16] B[15] B[14] B[13] B[12] B[11] B[10] B[9] B[8] B[7] B[6] B[5] B[4] B[3]
+ B[2] B[1] B[0] CI DIFF[17] DIFF[16] DIFF[15] DIFF[14] DIFF[13] DIFF[12]
+ DIFF[11] DIFF[10] DIFF[9] DIFF[8] DIFF[7] DIFF[6] DIFF[5] DIFF[4] DIFF[3]
+ DIFF[2] DIFF[1] DIFF[0] CO
XFE_RC_1631_0 XOR3T $PINS O=DIFF[8] I1=A[8] I2=n18 I3=carry[8]
XFE_RC_1630_0 MAO222 $PINS O=carry[9] A1=A[8] B1=n18 C1=carry[8]
XFE_RC_1564_0 XOR3 $PINS O=DIFF[9] I1=A[9] I2=n9 I3=carry[9]
XFE_RC_1563_0 MAO222 $PINS O=carry[10] A1=A[9] B1=n9 C1=carry[9]
XU2_2 FA1 $PINS S=DIFF[2] CO=carry[3] A=A[2] B=n12 CI=carry[2]
XU2_1 FA1 $PINS S=DIFF[1] CO=carry[2] A=A[1] B=n11 CI=carry[1]
XU2_6 FA1S $PINS S=DIFF[6] CO=carry[7] A=A[6] B=n16 CI=carry[6]
XU2_16 FA1 $PINS S=DIFF[16] CO=carry[17] A=A[16] B=n2 CI=carry[16]
XU2_7 FA1S $PINS S=DIFF[7] CO=carry[8] A=A[7] B=n17 CI=carry[7]
XU2_11 FA1S $PINS S=DIFF[11] CO=carry[12] A=A[11] B=n7 CI=carry[11]
XU2_12 FA1 $PINS S=DIFF[12] CO=carry[13] A=A[12] B=n6 CI=carry[12]
XU2_10 FA1 $PINS S=DIFF[10] CO=carry[11] A=A[10] B=n8 CI=carry[10]
XU2_13 FA1S $PINS S=DIFF[13] CO=carry[14] A=A[13] B=n5 CI=carry[13]
XU2_17 XOR3 $PINS O=DIFF[17] I1=A[17] I2=n2 I3=carry[17]
XU2_4 FA1 $PINS S=DIFF[4] CO=carry[5] A=A[4] B=n14 CI=carry[4]
XU2_14 FA1 $PINS S=DIFF[14] CO=carry[15] A=A[14] B=n4 CI=carry[14]
XU2_15 FA1 $PINS S=DIFF[15] CO=carry[16] A=A[15] B=n3 CI=carry[15]
XU2_3 FA1 $PINS S=DIFF[3] CO=carry[4] A=A[3] B=n13 CI=carry[3]
XU2_5 FA1S $PINS S=DIFF[5] CO=carry[6] A=A[5] B=n15 CI=carry[5]
XU1 INV1S $PINS O=n10 I=B[0]
XU2 INV1S $PINS O=n2 I=B[17]
XU3 INV1S $PINS O=n5 I=B[13]
XU4 INV1S $PINS O=n8 I=B[10]
XU5 INV1S $PINS O=n6 I=B[12]
XU6 INV1S $PINS O=n7 I=B[11]
XU7 INV1S $PINS O=n14 I=B[4]
XU8 INV1S $PINS O=n15 I=B[5]
XU9 INV1S $PINS O=n18 I=B[8]
XU10 INV1S $PINS O=n17 I=B[7]
XU11 INV1S $PINS O=n9 I=B[9]
XU12 INV1S $PINS O=n3 I=B[15]
XU13 INV1S $PINS O=n16 I=B[6]
XU14 INV1S $PINS O=n4 I=B[14]
XU15 INV1S $PINS O=n11 I=B[1]
XU16 INV1S $PINS O=n1 I=A[0]
XU17 INV1S $PINS O=n13 I=B[3]
XU18 INV1S $PINS O=n12 I=B[2]
XU19 XNR2HS $PINS O=DIFF[0] I1=n10 I2=A[0]
XU20 ND2 $PINS O=carry[1] I1=B[0] I2=n1
.ENDS

.SUBCKT cordic_rotation_1 rst_n valid_in valid_out x_in[16] x_in[15] x_in[14]
+ x_in[13] x_in[12] x_in[11] x_in[10] x_in[9] x_in[8] x_in[7] x_in[6] x_in[5]
+ x_in[4] x_in[3] x_in[2] x_in[1] x_in[0] y_in[16] y_in[15] y_in[14] y_in[13]
+ y_in[12] y_in[11] y_in[10] y_in[9] y_in[8] y_in[7] y_in[6] y_in[5] y_in[4]
+ y_in[3] y_in[2] y_in[1] y_in[0] phase_in[15] phase_in[14] phase_in[13]
+ phase_in[12] phase_in[11] phase_in[10] phase_in[9] phase_in[8] phase_in[7]
+ phase_in[6] phase_in[5] phase_in[4] phase_in[3] phase_in[2] phase_in[1]
+ phase_in[0] x_out[16] x_out[15] x_out[14] x_out[13] x_out[12] x_out[11]
+ x_out[10] x_out[9] x_out[8] x_out[7] x_out[6] x_out[5] x_out[4] x_out[3]
+ x_out[2] x_out[1] x_out[0] y_out[16] y_out[15] y_out[14] y_out[13] y_out[12]
+ y_out[11] y_out[10] y_out[9] y_out[8] y_out[7] y_out[6] y_out[5] y_out[4]
+ y_out[3] y_out[2] y_out[1] y_out[0] i_rst_n p1 FE_OFN24_i_rst_n
+ FE_OFN6_i_rst_n FE_OFN37_n FE_OFN33_n clk clk_clone4 clk_clone3 clk_clone2
+ clk_clone1
*.CONNECT N130 x_in[0]
*.CONNECT N148 y_in[0]
*.CONNECT N177 phase_in[9]
*.CONNECT N178 phase_in[10]
*.CONNECT N179 phase_in[11]
*.CONNECT N180 phase_in[12]
*.CONNECT N181 phase_in[13]
*.CONNECT N182 phase_in[14]
XFE_PHC1536_n298 BUF1CK $PINS O=FE_PHN1536_n298 I=n298
XFE_PHC1531_y_reg_17 BUF1CK $PINS O=FE_PHN1531_y_reg_17 I=y_reg[17]
XFE_PHC1528_y_reg_14 BUF1S $PINS O=FE_PHN1528_y_reg_14 I=y_reg[14]
XFE_PHC1522_n260 BUF1CK $PINS O=FE_PHN1522_n260 I=n260
XFE_PHC1520_n262 BUF1CK $PINS O=FE_PHN1520_n262 I=n262
XFE_PHC1518_cor_y_out_0_10 BUF2CK $PINS O=y_out[10] I=FE_PHN1518_cor_y_out_0_10
XFE_PHC1516_n258 BUF1CK $PINS O=FE_PHN1516_n258 I=n258
XFE_PHC1515_n266 BUF1CK $PINS O=FE_PHN1515_n266 I=n266
XFE_PHC1513_n338 BUF1CK $PINS O=FE_PHN1513_n338 I=n338
XFE_PHC1512_n344 BUF1CK $PINS O=FE_PHN1512_n344 I=n344
XFE_PHC1510_n366 BUF2CK $PINS O=FE_PHN1510_n366 I=n366
XFE_PHC1508_n254 BUF1CK $PINS O=FE_PHN1508_n254 I=n254
XFE_PHC1500_c_in_r_0_10 BUF1CK $PINS O=FE_PHN1500_c_in_r_0_10 I=x_in[10]
XFE_PHC1487_N505 DELA $PINS O=N505 I=FE_PHN1487_N505
XFE_PHC1486_N503 DELB $PINS O=N503 I=FE_PHN1486_N503
XFE_PHC1485_N491 DELB $PINS O=FE_PHN1485_N491 I=N491
XFE_PHC1484_n274 DELA $PINS O=FE_PHN1484_n274 I=n274
XFE_PHC1483_N494 DELB $PINS O=FE_PHN1483_N494 I=N494
XFE_PHC1481_N504 DELB $PINS O=FE_PHN1481_N504 I=N504
XFE_PHC1480_N480 DELB $PINS O=FE_PHN1480_N480 I=N480
XFE_PHC1479_N461 DELB $PINS O=FE_PHN1479_N461 I=N461
XFE_PHC1478_N488 DELB $PINS O=FE_PHN1478_N488 I=N488
XFE_PHC1477_N482 DELB $PINS O=FE_PHN1477_N482 I=N482
XFE_PHC1476_N481 DELB $PINS O=FE_PHN1476_N481 I=N481
XFE_PHC1475_N485 DELB $PINS O=FE_PHN1475_N485 I=N485
XFE_PHC1472_N460 DELC $PINS O=FE_PHN1472_N460 I=N460
XFE_PHC1443_n344 BUF1S $PINS O=FE_PHN1443_n344 I=FE_PHN1512_n344
XFE_PHC1441_N448 BUF1S $PINS O=FE_PHN1441_N448 I=N448
XFE_PHC1440_n338 BUF1S $PINS O=FE_PHN1440_n338 I=FE_PHN1513_n338
XFE_PHC1439_N442 DELA $PINS O=FE_PHN1439_N442 I=N442
XFE_PHC1431_n341 DELA $PINS O=n341 I=FE_PHN1431_n341
XFE_PHC1424_n335 DELA $PINS O=FE_PHN1424_n335 I=n335
XFE_PHC1422_n362 DELA $PINS O=n362 I=FE_PHN1422_n362
XFE_PHC1421_n332 DELA $PINS O=FE_PHN1421_n332 I=n332
XFE_PHC1420_n361 DELA $PINS O=n361 I=FE_PHN1420_n361
XFE_PHC1419_n363 DELA $PINS O=n363 I=FE_PHN1419_n363
XFE_PHC1417_N450 DELA $PINS O=FE_PHN1417_N450 I=N450
XFE_PHC1413_N449 DELB $PINS O=FE_PHN1413_N449 I=N449
XFE_PHC1398_N497 DELB $PINS O=FE_PHN1398_N497 I=N497
XFE_PHC1397_N498 DELB $PINS O=FE_PHN1397_N498 I=N498
XFE_PHC1396_N499 DELB $PINS O=N499 I=FE_PHN1396_N499
XFE_PHC1395_n329 DELB $PINS O=FE_PHN1395_n329 I=n329
XFE_PHC1394_N447 DELB $PINS O=FE_PHN1394_N447 I=N447
XFE_PHC1391_N457 DELB $PINS O=FE_PHN1391_N457 I=N457
XFE_PHC1390_n324 DELB $PINS O=n324 I=FE_PHN1390_n324
XFE_PHC1382_n353 DELB $PINS O=n353 I=FE_PHN1382_n353
XFE_PHC1381_N446 DELB $PINS O=FE_PHN1381_N446 I=N446
XFE_PHC1380_N445 DELB $PINS O=FE_PHN1380_N445 I=N445
XFE_PHC1377_N441 DELB $PINS O=FE_PHN1377_N441 I=N441
XFE_PHC1373_N443 DELB $PINS O=FE_PHN1373_N443 I=N443
XFE_PHC1372_n321 DELB $PINS O=n321 I=FE_PHN1372_n321
XFE_PHC1371_N444 DELB $PINS O=FE_PHN1371_N444 I=N444
XFE_PHC1363_N437 DELB $PINS O=N437 I=FE_PHN1363_N437
XFE_PHC1357_N435 DELB $PINS O=FE_PHN1357_N435 I=N435
XFE_PHC1352_N436 DELB $PINS O=FE_PHN1352_N436 I=N436
XFE_PHC1336_N459 DELB $PINS O=FE_PHN1336_N459 I=N459
XFE_PHC1324_N432 DELB $PINS O=FE_PHN1324_N432 I=N432
XFE_PHC1321_N434 DELB $PINS O=FE_PHN1321_N434 I=N434
XFE_PHC1318_N429 DELB $PINS O=FE_PHN1318_N429 I=N429
XFE_PHC1315_N433 DELB $PINS O=FE_PHN1315_N433 I=N433
XFE_PHC1313_N428 DELB $PINS O=FE_PHN1313_N428 I=N428
XFE_PHC1311_N430 DELB $PINS O=FE_PHN1311_N430 I=N430
XFE_PHC1302_N431 DELB $PINS O=FE_PHN1302_N431 I=N431
XFE_PHC1300_N427 DELB $PINS O=FE_PHN1300_N427 I=N427
XFE_PHC1284_N438 DELB $PINS O=FE_PHN1284_N438 I=N438
XFE_PHC1275_N426 DELB $PINS O=FE_PHN1275_N426 I=N426
XFE_PHC1248_y_reg_9 BUF1S $PINS O=y_reg[9] I=FE_PHN1248_y_reg_9
XFE_PHC1246_y_reg_13 BUF1S $PINS O=y_reg[13] I=FE_PHN1246_y_reg_13
XFE_PHC1236_y_reg_5 DELB $PINS O=y_reg[5] I=FE_PHN1236_y_reg_5
XFE_PHC1233_y_reg_4 DELB $PINS O=y_reg[4] I=FE_PHN1233_y_reg_4
XFE_PHC1228_x_reg_11 DELB $PINS O=FE_PHN1228_x_reg_11 I=x_reg[11]
XFE_PHC1219_x_reg_7 DELB $PINS O=x_reg[7] I=FE_PHN1219_x_reg_7
XFE_PHC1218_x_reg_17 DELB $PINS O=FE_PHN1218_x_reg_17 I=x_reg[17]
XFE_PHC1213_x_reg_5 DELB $PINS O=FE_PHN1213_x_reg_5 I=x_reg[5]
XFE_PHC1206_z_reg_5 DELA $PINS O=z_reg[5] I=FE_PHN1206_z_reg_5
XFE_PHC1142_x_reg_13 DELB $PINS O=FE_PHN1142_x_reg_13 I=x_reg[13]
XFE_PHC1115_c_in_i_0_11 DELA $PINS O=FE_PHN1115_c_in_i_0_11 I=y_in[11]
XFE_PHC1108_c_in_i_0_12 DELA $PINS O=FE_PHN1108_c_in_i_0_12 I=y_in[12]
XFE_PHC1105_c_in_i_0_15 BUF2CK $PINS O=FE_PHN1105_c_in_i_0_15 I=y_in[15]
XFE_PHC1101_c_in_i_0_13 DELB $PINS O=FE_PHN1101_c_in_i_0_13 I=y_in[13]
XFE_PHC1098_c_in_i_0_9 DELA $PINS O=FE_PHN1098_c_in_i_0_9 I=y_in[9]
XFE_PHC1097_n366 BUF1S $PINS O=FE_PHN1097_n366 I=FE_PHN1510_n366
XFE_PHC1072_n365 DELA $PINS O=FE_PHN1072_n365 I=n365
XFE_PHC1071_n367 DELA $PINS O=FE_PHN1071_n367 I=n367
XFE_PHC1069_y_reg_17 DELB $PINS O=FE_PHN1069_y_reg_17 I=FE_PHN1531_y_reg_17
XFE_PHC1065_n368 DELA $PINS O=FE_PHN1065_n368 I=n368
XFE_PHC1053_n354 DELB $PINS O=FE_PHN1053_n354 I=n354
XFE_PHC989_n369 DELB $PINS O=FE_PHN989_n369 I=n369
XCTS_ccl_a_INV_CLK_G1_L10_15 INV4CK $PINS O=CTS_46 I=CTS_47
XCTS_ccl_a_INV_CLK_G1_L9_18 INV2CK $PINS O=CTS_47 I=CTS_48
XCTS_ccl_a_INV_CLK_G1_L8_94 INV3CK $PINS O=CTS_43 I=CTS_44
XCTS_ccl_a_INV_CLK_G1_L7_96 INV2CK $PINS O=CTS_44 I=CTS_45
XCTS_ccl_a_INV_CLK_G1_L8_41 INV6CK $PINS O=CTS_40 I=CTS_41
XCTS_ccl_a_INV_CLK_G1_L7_43 INV3CK $PINS O=CTS_41 I=CTS_42
XCTS_ccl_a_INV_CLK_G1_L8_40 INV8CK $PINS O=CTS_37 I=CTS_38
XCTS_ccl_a_INV_CLK_G1_L7_42 INV3CK $PINS O=CTS_38 I=CTS_39
XFE_OFC572_step_cnt_1 INV1S $PINS O=FE_OFN337_step_cnt_1 I=n241
XFE_OFC569_step_cnt_1 INV2 $PINS O=n241 I=step_cnt[1]
XFE_OFC499_n68 INV1S $PINS O=FE_OFN309_n68 I=n68
XFE_OFC498_n68 INV1S $PINS O=n77 I=n68
XFE_OFC441_n58 BUF1 $PINS O=FE_OFN258_n58 I=n58
XFE_OFC440_n58 BUF1 $PINS O=FE_OFN257_n58 I=n58
XFE_OFC418_y_reg_8 INV1S $PINS O=FE_OFN244_y_reg_8 I=n75
XFE_OFC416_y_reg_8 INV1S $PINS O=n75 I=y_reg[8]
XFE_OFC403_y_reg_6 INV1S $PINS O=FE_OFN234_y_reg_6 I=n97
XFE_OFC402_y_reg_6 INV1S $PINS O=n97 I=y_reg[6]
XFE_OFC389_x_reg_8 INV1S $PINS O=n173 I=x_reg[8]
XFE_OFC361_x_reg_9 INV1S $PINS O=n172 I=x_reg[9]
XFE_OFC351_y_reg_9 INV1S $PINS O=n74 I=y_reg[9]
XFE_OFC342_x_reg_10 INV1S $PINS O=n162 I=x_reg[10]
XFE_OFC332_n151 INV2 $PINS O=n61 I=n151
XFE_OFC315_y_reg_10 INV1S $PINS O=n59 I=y_reg[10]
XFE_OFC306_x_reg_7 INV1S $PINS O=n181 I=x_reg[7]
XFE_OFC293_x_reg_11 INV1S $PINS O=n182 I=FE_PHN1228_x_reg_11
XFE_OFC291_y_reg_11 INV1S $PINS O=n87 I=y_reg[11]
XFE_OFC269_n4 INV1S $PINS O=FE_OFN187_n4 I=n127
XFE_OFC268_n4 INV1S $PINS O=n127 I=n4
XFE_OFC151_n58 INV1S $PINS O=n7 I=n58
XFE_OFC23_n10 BUF1CK $PINS O=FE_OFN23_n10 I=n2
XFE_DBTC14_n3 INV2 $PINS O=FE_DBTN14_n3 I=n3
Xx_out_reg[5] QDFFRBN $PINS Q=x_out[5] D=FE_PHN1302_N431 CK=CTS_46
+ RB=FE_OFN33_n
Xx_out_reg[6] QDFFRBN $PINS Q=x_out[6] D=FE_PHN1324_N432 CK=CTS_46
+ RB=FE_OFN33_n
Xx_out_reg[7] QDFFRBN $PINS Q=x_out[7] D=FE_PHN1315_N433 CK=CTS_46
+ RB=FE_OFN33_n
Xx_out_reg[8] QDFFRBN $PINS Q=x_out[8] D=FE_PHN1321_N434 CK=CTS_46
+ RB=FE_OFN33_n
Xx_out_reg[9] QDFFRBN $PINS Q=x_out[9] D=FE_PHN1357_N435 CK=CTS_46
+ RB=FE_OFN33_n
Xx_out_reg[0] QDFFRBN $PINS Q=x_out[0] D=FE_PHN1275_N426 CK=CTS_46
+ RB=FE_OFN33_n
Xx_out_reg[10] QDFFRBN $PINS Q=x_out[10] D=FE_PHN1352_N436 CK=CTS_46
+ RB=FE_OFN33_n
Xx_out_reg[11] QDFFRBN $PINS Q=x_out[11] D=N437 CK=CTS_46 RB=FE_OFN33_n
Xx_out_reg[12] QDFFRBN $PINS Q=x_out[12] D=FE_PHN1284_N438 CK=CTS_46
+ RB=FE_OFN33_n
Xx_out_reg[13] QDFFRBN $PINS Q=x_out[13] D=FE_PHN1284_N438 CK=CTS_46
+ RB=FE_OFN33_n
Xx_out_reg[14] QDFFRBN $PINS Q=x_out[14] D=FE_PHN1284_N438 CK=CTS_46
+ RB=FE_OFN33_n
Xx_out_reg[15] QDFFRBN $PINS Q=x_out[15] D=FE_PHN1284_N438 CK=CTS_46
+ RB=FE_OFN33_n
Xy_out_reg[0] QDFFRBN $PINS Q=y_out[0] D=N439 CK=CTS_43 RB=FE_OFN33_n
Xy_out_reg[1] QDFFRBN $PINS Q=y_out[1] D=N440 CK=CTS_43 RB=FE_OFN33_n
Xy_out_reg[2] QDFFRBN $PINS Q=y_out[2] D=FE_PHN1377_N441 CK=CTS_43
+ RB=FE_OFN33_n
Xy_out_reg[3] QDFFRBN $PINS Q=y_out[3] D=FE_PHN1439_N442 CK=CTS_43
+ RB=FE_OFN33_n
Xy_out_reg[4] QDFFRBN $PINS Q=y_out[4] D=FE_PHN1373_N443 CK=CTS_43
+ RB=FE_OFN33_n
Xy_out_reg[5] QDFFRBN $PINS Q=y_out[5] D=FE_PHN1371_N444 CK=CTS_43
+ RB=FE_OFN33_n
Xy_out_reg[6] QDFFRBN $PINS Q=y_out[6] D=FE_PHN1380_N445 CK=CTS_43
+ RB=FE_OFN33_n
Xy_out_reg[7] QDFFRBN $PINS Q=y_out[7] D=FE_PHN1381_N446 CK=CTS_43
+ RB=FE_OFN33_n
Xy_out_reg[8] QDFFRBN $PINS Q=y_out[8] D=FE_PHN1394_N447 CK=CTS_43
+ RB=FE_OFN33_n
Xy_out_reg[9] QDFFRBN $PINS Q=y_out[9] D=FE_PHN1441_N448 CK=CTS_43
+ RB=FE_OFN33_n
Xy_out_reg[10] QDFFRBN $PINS Q=FE_PHN1518_cor_y_out_0_10 D=FE_PHN1413_N449
+ CK=CTS_43 RB=FE_OFN33_n
Xy_out_reg[11] QDFFRBN $PINS Q=y_out[11] D=FE_PHN1417_N450 CK=CTS_43
+ RB=FE_OFN33_n
Xy_out_reg[12] QDFFRBN $PINS Q=y_out[12] D=N451 CK=CTS_43 RB=FE_OFN33_n
Xy_out_reg[13] QDFFRBN $PINS Q=y_out[13] D=N451 CK=CTS_43 RB=FE_OFN33_n
Xy_out_reg[14] QDFFRBN $PINS Q=y_out[14] D=N451 CK=CTS_43 RB=FE_OFN33_n
Xy_out_reg[15] QDFFRBN $PINS Q=y_out[15] D=N451 CK=CTS_43 RB=FE_OFN33_n
Xy_out_reg[16] QDFFRBN $PINS Q=y_out[16] D=N451 CK=CTS_43 RB=FE_OFN33_n
Xx_out_reg[1] QDFFRBN $PINS Q=x_out[1] D=FE_PHN1300_N427 CK=CTS_46
+ RB=FE_OFN33_n
Xx_out_reg[2] QDFFRBN $PINS Q=x_out[2] D=FE_PHN1313_N428 CK=CTS_46
+ RB=FE_OFN33_n
Xx_out_reg[3] QDFFRBN $PINS Q=x_out[3] D=FE_PHN1318_N429 CK=CTS_46
+ RB=FE_OFN33_n
Xx_out_reg[4] QDFFRBN $PINS Q=x_out[4] D=FE_PHN1311_N430 CK=CTS_46
+ RB=FE_OFN33_n
Xx_out_reg[16] QDFFRBN $PINS Q=x_out[16] D=FE_PHN1284_N438 CK=CTS_46
+ RB=FE_OFN33_n
Xz_reg_reg[14] QDFFRBN $PINS Q=z_reg[14] D=N477 CK=CTS_40 RB=i_rst_n
Xz_reg_reg[15] QDFFRBN $PINS Q=z_reg[15] D=N478 CK=CTS_40 RB=i_rst_n
Xz_reg_reg[13] QDFFRBN $PINS Q=z_reg[13] D=N476 CK=CTS_40 RB=i_rst_n
Xz_reg_reg[12] QDFFRBN $PINS Q=z_reg[12] D=N475 CK=CTS_40 RB=i_rst_n
Xz_reg_reg[11] QDFFRBN $PINS Q=z_reg[11] D=N474 CK=CTS_40 RB=i_rst_n
Xz_reg_reg[10] QDFFRBN $PINS Q=z_reg[10] D=N473 CK=CTS_40 RB=i_rst_n
Xz_reg_reg[9] QDFFRBN $PINS Q=z_reg[9] D=N472 CK=CTS_40 RB=i_rst_n
Xz_reg_reg[8] QDFFRBN $PINS Q=z_reg[8] D=n361 CK=CTS_40 RB=i_rst_n
Xz_reg_reg[7] QDFFRBN $PINS Q=z_reg[7] D=n362 CK=CTS_40 RB=i_rst_n
Xz_reg_reg[6] QDFFRBN $PINS Q=z_reg[6] D=n363 CK=CTS_37 RB=i_rst_n
Xz_reg_reg[5] QDFFRBN $PINS Q=FE_PHN1206_z_reg_5 D=n364 CK=CTS_37 RB=i_rst_n
Xz_reg_reg[4] QDFFRBN $PINS Q=z_reg[4] D=FE_PHN1072_n365 CK=CTS_37 RB=i_rst_n
Xz_reg_reg[3] QDFFRBN $PINS Q=z_reg[3] D=FE_PHN1097_n366 CK=CTS_37 RB=i_rst_n
Xz_reg_reg[2] QDFFRBN $PINS Q=z_reg[2] D=FE_PHN1071_n367 CK=CTS_37 RB=i_rst_n
Xy_reg_reg[17] QDFFRBN $PINS Q=y_reg[17] D=N514 CK=CTS_40 RB=FE_OFN6_i_rst_n
Xx_reg_reg[17] QDFFRBN $PINS Q=x_reg[17] D=N496 CK=CTS_37 RB=i_rst_n
Xz_reg_reg[1] QDFFRBN $PINS Q=z_reg[1] D=FE_PHN1065_n368 CK=CTS_37 RB=i_rst_n
Xx_reg_reg[16] QDFFRBN $PINS Q=x_reg[16] D=N495 CK=CTS_37 RB=i_rst_n
Xy_reg_reg[16] QDFFRBN $PINS Q=y_reg[16] D=N513 CK=CTS_40 RB=FE_OFN6_i_rst_n
Xz_reg_reg[0] QDFFRBN $PINS Q=z_reg[0] D=FE_PHN989_n369 CK=CTS_37 RB=i_rst_n
Xx_reg_reg[15] QDFFRBN $PINS Q=x_reg[15] D=FE_PHN1483_N494 CK=CTS_37 RB=i_rst_n
Xy_reg_reg[15] QDFFRBN $PINS Q=y_reg[15] D=N512 CK=CTS_40 RB=FE_OFN6_i_rst_n
Xx_reg_reg[14] QDFFRBN $PINS Q=x_reg[14] D=N493 CK=CTS_37 RB=i_rst_n
Xy_reg_reg[14] QDFFRBN $PINS Q=y_reg[14] D=N511 CK=CTS_40 RB=FE_OFN6_i_rst_n
Xy_reg_reg[13] QDFFRBN $PINS Q=FE_PHN1246_y_reg_13 D=N510 CK=CTS_40
+ RB=FE_OFN6_i_rst_n
Xx_reg_reg[13] QDFFRBN $PINS Q=x_reg[13] D=N492 CK=CTS_37 RB=i_rst_n
Xy_reg_reg[12] QDFFRBN $PINS Q=y_reg[12] D=N509 CK=CTS_40 RB=FE_OFN6_i_rst_n
Xx_reg_reg[12] QDFFRBN $PINS Q=x_reg[12] D=FE_PHN1485_N491 CK=CTS_37 RB=i_rst_n
Xis_computing_reg QDFFRBN $PINS Q=is_computing D=FE_PHN1391_N457 CK=CTS_37
+ RB=i_rst_n
Xy_reg_reg[11] QDFFRBN $PINS Q=y_reg[11] D=N508 CK=CTS_40 RB=FE_OFN6_i_rst_n
Xx_reg_reg[11] QDFFRBN $PINS Q=x_reg[11] D=N490 CK=CTS_37 RB=i_rst_n
Xx_reg_reg[1] QDFFRBN $PINS Q=x_reg[1] D=FE_PHN1480_N480 CK=CTS_37
+ RB=FE_OFN37_n
Xy_reg_reg[1] QDFFRBN $PINS Q=y_reg[1] D=FE_PHN1397_N498 CK=CTS_40
+ RB=FE_OFN24_i_rst_n
Xy_reg_reg[3] QDFFRBN $PINS Q=y_reg[3] D=N500 CK=CTS_40 RB=FE_OFN24_i_rst_n
Xx_reg_reg[3] QDFFRBN $PINS Q=x_reg[3] D=FE_PHN1477_N482 CK=CTS_37
+ RB=FE_OFN37_n
Xy_reg_reg[10] QDFFRBN $PINS Q=y_reg[10] D=N507 CK=CTS_40 RB=FE_OFN6_i_rst_n
Xx_reg_reg[4] QDFFRBN $PINS Q=x_reg[4] D=N483 CK=CTS_37 RB=i_rst_n
Xx_reg_reg[10] QDFFRBN $PINS Q=x_reg[10] D=N489 CK=CTS_37 RB=i_rst_n
Xy_reg_reg[4] QDFFRBN $PINS Q=FE_PHN1233_y_reg_4 D=N501 CK=CTS_40
+ RB=FE_OFN24_i_rst_n
Xy_reg_reg[2] QDFFRBN $PINS Q=y_reg[2] D=N499 CK=CTS_40 RB=FE_OFN24_i_rst_n
Xx_reg_reg[0] QDFFRBN $PINS Q=x_reg[0] D=N479 CK=CTS_37 RB=FE_OFN37_n
Xx_reg_reg[2] QDFFRBN $PINS Q=x_reg[2] D=FE_PHN1476_N481 CK=CTS_37
+ RB=FE_OFN37_n
Xy_reg_reg[0] QDFFRBN $PINS Q=y_reg[0] D=FE_PHN1398_N497 CK=CTS_40
+ RB=FE_OFN37_n
Xy_reg_reg[7] QDFFRBN $PINS Q=y_reg[7] D=FE_PHN1481_N504 CK=CTS_40
+ RB=FE_OFN24_i_rst_n
Xx_reg_reg[7] QDFFRBN $PINS Q=FE_PHN1219_x_reg_7 D=N486 CK=CTS_37 RB=i_rst_n
Xy_reg_reg[5] QDFFRBN $PINS Q=FE_PHN1236_y_reg_5 D=N502 CK=CTS_40
+ RB=FE_OFN24_i_rst_n
Xx_reg_reg[5] QDFFRBN $PINS Q=x_reg[5] D=N484 CK=CTS_37 RB=i_rst_n
Xy_reg_reg[8] QDFFRBN $PINS Q=y_reg[8] D=N505 CK=CTS_40 RB=FE_OFN24_i_rst_n
Xx_reg_reg[8] QDFFRBN $PINS Q=x_reg[8] D=N487 CK=CTS_37 RB=i_rst_n
Xy_reg_reg[6] QDFFRBN $PINS Q=y_reg[6] D=N503 CK=CTS_40 RB=FE_OFN24_i_rst_n
Xx_reg_reg[6] QDFFRBN $PINS Q=x_reg[6] D=FE_PHN1475_N485 CK=CTS_37 RB=i_rst_n
Xy_reg_reg[9] QDFFRBN $PINS Q=FE_PHN1248_y_reg_9 D=N506 CK=CTS_40
+ RB=FE_OFN6_i_rst_n
Xx_reg_reg[9] QDFFRBN $PINS Q=x_reg[9] D=FE_PHN1478_N488 CK=CTS_37 RB=i_rst_n
Xvalid_out_reg QDFFRBN $PINS Q=valid_out D=N515 CK=clk RB=FE_OFN33_n
Xstep_cnt_reg[0] QDFFRBN $PINS Q=step_cnt[0] D=N458 CK=net2446
+ RB=FE_OFN6_i_rst_n
Xstep_cnt_reg[3] QDFFRBN $PINS Q=step_cnt[3] D=FE_PHN1479_N461 CK=net2446
+ RB=FE_OFN6_i_rst_n
Xstep_cnt_reg[1] QDFFRBN $PINS Q=step_cnt[1] D=FE_PHN1336_N459 CK=net2446
+ RB=FE_OFN6_i_rst_n
Xstep_cnt_reg[2] DFFRBN $PINS Q=step_cnt[2] QB=n242 D=FE_PHN1472_N460
+ CK=net2446 RB=FE_OFN6_i_rst_n
XU4 ND3S $PINS O=n4 I1=step_cnt[2] I2=step_cnt[0] I3=n352
XU6 AN2 $PINS O=n15 I1=n1 I2=n244
XU7 NR2 $PINS O=N147 I1=x_in[16] I2=sub_87/carry[16]
XU8 NR2 $PINS O=sub_87/carry[2] I1=N130 I2=x_in[1]
XU9 NR2 $PINS O=sub_88/carry[2] I1=N148 I2=y_in[1]
XU11 NR2 $PINS O=N165 I1=y_in[16] I2=sub_88/carry[16]
XU13 AN2 $PINS O=n1 I1=n240 I2=FE_OFN337_step_cnt_1
XU15 ND2 $PINS O=n139 I1=n244 I2=n1
XU18 ND2 $PINS O=N514 I1=n248 I2=n249
XU19 AOI22S $PINS O=n249 A1=N357 A2=n245 B1=N305 B2=FE_OFN23_n10
XU20 INV2 $PINS O=n65 I=n144
XU21 NR2 $PINS O=n2 I1=n246 I2=z_reg[15]
XU22 INV2 $PINS O=n244 I=step_cnt[3]
XU23 ND2 $PINS O=n239 I1=step_cnt[2] I2=n243
XU24 NR2P $PINS O=n243 I1=n355 I2=step_cnt[1]
XU25 INV2 $PINS O=n355 I=step_cnt[0]
XU27 OA222S $PINS O=n152 A1=n89 A2=n115 B1=n59 B2=n90 C1=n74 C2=n91
XU28 OA222S $PINS O=n213 A1=n89 A2=n200 B1=n90 B2=n182 C1=n91 C2=n162
XU29 OA222 $PINS O=n214 A1=n88 A2=n172 B1=n65 B2=n188 C1=n61 C2=n181
XU30 OA222S $PINS O=n207 A1=n89 A2=n194 B1=n90 B2=n174 C1=n91 C2=n182
XU31 OA222S $PINS O=n208 A1=n88 A2=n162 B1=n65 B2=n181 C1=n61 C2=n173
XU32 OA222S $PINS O=n122 A1=n89 A2=n109 B1=n87 B2=n90 C1=n59 C2=n91
XU33 OA222S $PINS O=n123 A1=n74 A2=n88 B1=n65 B2=n97 C1=n61 C2=n86
XU34 OA222S $PINS O=n116 A1=n89 A2=n103 B1=n76 B2=n90 C1=n87 C2=n91
XU35 OA222S $PINS O=n117 A1=n59 A2=n88 B1=n65 B2=n86 C1=n61 C2=n75
XU36 OA222S $PINS O=n201 A1=n89 A2=n188 B1=n90 B2=n175 C1=n91 C2=n174
XU37 OA222S $PINS O=n202 A1=n88 A2=n182 B1=n65 B2=n173 C1=n61 C2=n172
XU38 OA222S $PINS O=n110 A1=n89 A2=n97 B1=n79 B2=n90 C1=n76 C2=n91
XU39 OA222S $PINS O=n111 A1=n87 A2=n88 B1=n65 B2=n75 C1=n61 C2=n74
XU40 OA222S $PINS O=n195 A1=n89 A2=n181 B1=n90 B2=n166 C1=n91 C2=n175
XU41 OA222S $PINS O=n196 A1=n88 A2=n174 B1=n65 B2=n172 C1=n61 C2=n162
XU42 OA222S $PINS O=n104 A1=n89 A2=n86 B1=n66 B2=n90 C1=n79 C2=n91
XU43 OA222S $PINS O=n105 A1=n76 A2=n88 B1=n65 B2=n74 C1=n61 C2=n59
XU44 OA222S $PINS O=n189 A1=n89 A2=n173 B1=n90 B2=n164 C1=n91 C2=n166
XU45 OA222S $PINS O=n190 A1=n88 A2=n175 B1=n65 B2=n162 C1=n61 C2=n182
XU46 OA222S $PINS O=n98 A1=n89 A2=n75 B1=n62 B2=n90 C1=n66 C2=n91
XU47 OA222S $PINS O=n99 A1=n79 A2=n88 B1=n65 B2=n59 C1=n61 C2=n87
XU48 OA222S $PINS O=n183 A1=n89 A2=n172 B1=n90 B2=n163 C1=n91 C2=n164
XU49 OA222S $PINS O=n184 A1=n88 A2=n166 B1=n65 B2=n182 C1=n61 C2=n174
XU50 OA222S $PINS O=n92 A1=n89 A2=n74 B1=n60 B2=n90 C1=n62 C2=n91
XU51 OA222S $PINS O=n93 A1=n66 A2=n88 B1=n65 B2=n87 C1=n61 C2=n76
XU52 OA222S $PINS O=n176 A1=n89 A2=n162 B1=n90 B2=n165 C1=n91 C2=n163
XU53 OA222S $PINS O=n177 A1=n88 A2=n164 B1=n65 B2=n174 C1=n61 C2=n175
XU54 OA222S $PINS O=n81 A1=n89 A2=n59 B1=n64 B2=n90 C1=n60 C2=n91
XU55 OA222S $PINS O=n82 A1=n62 A2=n88 B1=n65 B2=n76 C1=n61 C2=n79
XU56 ND3S $PINS O=N112 I1=n239 I2=n58 I3=n357
XU57 ND3S $PINS O=N113 I1=n139 I2=n58 I3=n358
XU58 OR2S $PINS O=n143 I1=n150 I2=n151
XU59 OA222S $PINS O=n222 A1=FE_OFN257_n58 A2=n175 B1=FE_DBTN14_n3 B2=n174
+ C1=n139 C2=n166
XU60 OA222S $PINS O=n223 A1=FE_OFN309_n68 A2=n163 B1=n138 B2=n165 C1=n89
+ C2=n164
XU61 OA222S $PINS O=n136 A1=n79 A2=FE_OFN258_n58 B1=n76 B2=FE_DBTN14_n3 C1=n66
+ C2=n139
XU62 OA222S $PINS O=n137 A1=n77 A2=n60 B1=n138 B2=n64 C1=n62 C2=n89
XU63 ND2S $PINS O=N109 I1=n237 I2=n58
XU64 ND3S $PINS O=n237 I1=n355 I2=n241 I3=step_cnt[2]
XU65 AO222S $PINS O=n235 A1=x_reg[0] A2=n3 B1=x_reg[4] B2=n68 C1=x_reg[7]
+ C2=n127
XU66 AO222S $PINS O=n155 A1=y_reg[0] A2=n3 B1=y_reg[4] B2=n68 C1=y_reg[7]
+ C2=n127
XU67 ND3S $PINS O=n247 I1=FE_OFN337_step_cnt_1 I2=n242 I3=step_cnt[0]
XU68 ND3 $PINS O=n91 I1=step_cnt[3] I2=n242 I3=n243
XU69 ND3S $PINS O=n238 I1=FE_OFN337_step_cnt_1 I2=n355 I3=step_cnt[2]
XU70 AO222S $PINS O=n216 A1=n3 A2=x_reg[1] B1=n68 B2=FE_PHN1213_x_reg_5 C1=n127
+ C2=x_reg[8]
XU71 AO222S $PINS O=n125 A1=n3 A2=y_reg[1] B1=n68 B2=y_reg[5] C1=n127
+ C2=y_reg[8]
XU72 ND3S $PINS O=n88 I1=n240 I2=n241 I3=step_cnt[3]
XU73 ND3S $PINS O=n90 I1=step_cnt[3] I2=n240 I3=FE_OFN337_step_cnt_1
XU74 OA222S $PINS O=n168 A1=n61 A2=n166 B1=n78 B2=n165 C1=n65 C2=n175
XU75 OA222S $PINS O=n70 A1=n66 A2=n61 B1=n78 B2=n64 C1=n65 C2=n79
XU76 OA222S $PINS O=n158 A1=n61 A2=n164 B1=n63 B2=n165 C1=n65 C2=n166
XU77 OA222S $PINS O=n54 A1=n61 A2=n62 B1=n63 B2=n64 C1=n65 C2=n66
XU78 OA222S $PINS O=n226 A1=FE_OFN257_n58 A2=n174 B1=FE_DBTN14_n3 B2=n182
+ C1=n139 C2=n175
XU79 OA222S $PINS O=n142 A1=n76 A2=FE_OFN258_n58 B1=FE_DBTN14_n3 B2=n87 C1=n79
+ C2=n139
XU80 OA222S $PINS O=n221 A1=FE_DBTN14_n3 A2=n175 B1=n135 B2=n165 C1=n89 C2=n163
XU81 OA222S $PINS O=n134 A1=n79 A2=FE_DBTN14_n3 B1=n135 B2=n64 C1=n89 C2=n60
XU82 OA12S $PINS O=n351 A1=n353 B1=step_cnt[2] B2=n246
XU83 ND2S $PINS O=n354 I1=is_computing I2=n355
XU84 OA12S $PINS O=FE_PHN1382_n353 A1=FE_PHN1053_n354 B1=step_cnt[1] B2=n246
XU92 ND2P $PINS O=n89 I1=N108 I2=n244
XU94 AN3 $PINS O=n3 I1=n241 I2=n244 I3=n240
XU95 INV1S $PINS O=n52 I=N148
XU96 INV1S $PINS O=n35 I=N130
XU97 INV1S $PINS O=n51 I=y_in[1]
XU98 INV1S $PINS O=n34 I=x_in[1]
XU99 INV1S $PINS O=n50 I=y_in[2]
XU100 INV1S $PINS O=n33 I=x_in[2]
XU101 INV1S $PINS O=n49 I=y_in[3]
XU102 INV1S $PINS O=n32 I=x_in[3]
XU103 INV1S $PINS O=n48 I=y_in[4]
XU104 INV1S $PINS O=n31 I=x_in[4]
XU105 INV1S $PINS O=n47 I=y_in[5]
XU106 INV1S $PINS O=n30 I=x_in[5]
XU107 INV1S $PINS O=n46 I=y_in[6]
XU108 INV1S $PINS O=n29 I=x_in[6]
XU109 INV1S $PINS O=n28 I=x_in[7]
XU110 INV1S $PINS O=n45 I=y_in[7]
XU111 INV1S $PINS O=n44 I=y_in[8]
XU112 INV1S $PINS O=n27 I=x_in[8]
XU113 INV1S $PINS O=n43 I=y_in[9]
XU114 INV1S $PINS O=n26 I=x_in[9]
XU115 INV1S $PINS O=n42 I=y_in[10]
XU116 INV1S $PINS O=n25 I=x_in[10]
XU117 INV1S $PINS O=n41 I=y_in[11]
XU118 INV1S $PINS O=n24 I=x_in[11]
XU119 INV1S $PINS O=n40 I=y_in[12]
XU120 INV1S $PINS O=n23 I=x_in[12]
XU121 INV1S $PINS O=n39 I=y_in[13]
XU122 INV1S $PINS O=n22 I=x_in[13]
XU123 INV1S $PINS O=n38 I=y_in[14]
XU124 INV1S $PINS O=n21 I=x_in[14]
XU125 INV1S $PINS O=n37 I=y_in[15]
XU126 INV1S $PINS O=n20 I=x_in[15]
XU127 INV1S $PINS O=n36 I=y_in[16]
XU128 INV1S $PINS O=n19 I=x_in[16]
XU129 NR2P $PINS O=n68 I1=n237 I2=step_cnt[3]
XU134 INV1S $PINS O=n174 I=x_reg[12]
XU135 INV1S $PINS O=n76 I=y_reg[12]
XU136 INV1S $PINS O=n175 I=x_reg[13]
XU137 INV1S $PINS O=n79 I=y_reg[13]
XU139 XOR2HS $PINS O=N438 I1=FE_PHN1218_x_reg_17 I2=add_116/carry[17]
XU140 AN2 $PINS O=add_116/carry[17] I1=add_116/carry[16] I2=x_reg[16]
XU141 XOR2HS $PINS O=FE_PHN1363_N437 I1=x_reg[16] I2=add_116/carry[16]
XU142 AN2 $PINS O=add_116/carry[16] I1=add_116/carry[15] I2=x_reg[15]
XU143 XOR2HS $PINS O=N436 I1=x_reg[15] I2=add_116/carry[15]
XU144 AN2 $PINS O=add_116/carry[15] I1=add_116/carry[14] I2=x_reg[14]
XU145 XOR2HS $PINS O=N435 I1=x_reg[14] I2=add_116/carry[14]
XU146 AN2 $PINS O=add_116/carry[14] I1=add_116/carry[13] I2=FE_PHN1142_x_reg_13
XU147 XOR2HS $PINS O=N434 I1=FE_PHN1142_x_reg_13 I2=add_116/carry[13]
XU148 AN2 $PINS O=add_116/carry[13] I1=add_116/carry[12] I2=x_reg[12]
XU149 XOR2HS $PINS O=N433 I1=x_reg[12] I2=add_116/carry[12]
XU150 AN2 $PINS O=add_116/carry[12] I1=add_116/carry[11] I2=FE_PHN1228_x_reg_11
XU151 XOR2HS $PINS O=N432 I1=FE_PHN1228_x_reg_11 I2=add_116/carry[11]
XU152 AN2 $PINS O=add_116/carry[11] I1=add_116/carry[10] I2=x_reg[10]
XU153 XOR2HS $PINS O=N431 I1=x_reg[10] I2=add_116/carry[10]
XU154 AN2 $PINS O=add_116/carry[10] I1=add_116/carry[9] I2=x_reg[9]
XU155 XOR2HS $PINS O=N430 I1=x_reg[9] I2=add_116/carry[9]
XU156 AN2 $PINS O=add_116/carry[9] I1=add_116/carry[8] I2=x_reg[8]
XU157 XOR2HS $PINS O=N429 I1=x_reg[8] I2=add_116/carry[8]
XU158 AN2 $PINS O=add_116/carry[8] I1=add_116/carry[7] I2=x_reg[7]
XU159 XOR2HS $PINS O=N428 I1=x_reg[7] I2=add_116/carry[7]
XU160 AN2 $PINS O=add_116/carry[7] I1=add_116/carry[6] I2=x_reg[6]
XU161 XOR2HS $PINS O=N427 I1=x_reg[6] I2=add_116/carry[6]
XU162 AN2 $PINS O=add_116/carry[6] I1=x_reg[4] I2=FE_PHN1213_x_reg_5
XU163 XOR2HS $PINS O=N426 I1=FE_PHN1213_x_reg_5 I2=x_reg[4]
XU164 XOR2HS $PINS O=N451 I1=FE_PHN1069_y_reg_17 I2=add_117/carry[17]
XU165 AN2 $PINS O=add_117/carry[17] I1=add_117/carry[16] I2=y_reg[16]
XU166 XOR2HS $PINS O=N450 I1=y_reg[16] I2=add_117/carry[16]
XU167 AN2 $PINS O=add_117/carry[16] I1=add_117/carry[15] I2=y_reg[15]
XU168 XOR2HS $PINS O=N449 I1=y_reg[15] I2=add_117/carry[15]
XU169 AN2 $PINS O=add_117/carry[15] I1=add_117/carry[14] I2=FE_PHN1528_y_reg_14
XU170 XOR2HS $PINS O=N448 I1=FE_PHN1528_y_reg_14 I2=add_117/carry[14]
XU171 AN2 $PINS O=add_117/carry[14] I1=add_117/carry[13] I2=y_reg[13]
XU172 XOR2HS $PINS O=N447 I1=y_reg[13] I2=add_117/carry[13]
XU173 AN2 $PINS O=add_117/carry[13] I1=add_117/carry[12] I2=y_reg[12]
XU174 XOR2HS $PINS O=N446 I1=y_reg[12] I2=add_117/carry[12]
XU175 AN2 $PINS O=add_117/carry[12] I1=add_117/carry[11] I2=y_reg[11]
XU176 XOR2HS $PINS O=N445 I1=y_reg[11] I2=add_117/carry[11]
XU177 AN2 $PINS O=add_117/carry[11] I1=add_117/carry[10] I2=y_reg[10]
XU178 XOR2HS $PINS O=N444 I1=y_reg[10] I2=add_117/carry[10]
XU179 AN2 $PINS O=add_117/carry[10] I1=add_117/carry[9] I2=y_reg[9]
XU180 XOR2HS $PINS O=N443 I1=y_reg[9] I2=add_117/carry[9]
XU181 AN2 $PINS O=add_117/carry[9] I1=add_117/carry[8] I2=FE_OFN244_y_reg_8
XU182 XOR2HS $PINS O=N442 I1=FE_OFN244_y_reg_8 I2=add_117/carry[8]
XU183 AN2 $PINS O=add_117/carry[8] I1=add_117/carry[7] I2=y_reg[7]
XU184 XOR2HS $PINS O=N441 I1=y_reg[7] I2=add_117/carry[7]
XU185 AN2 $PINS O=add_117/carry[7] I1=add_117/carry[6] I2=FE_OFN234_y_reg_6
XU186 XOR2HS $PINS O=N440 I1=FE_OFN234_y_reg_6 I2=add_117/carry[6]
XU187 AN2 $PINS O=add_117/carry[6] I1=y_reg[4] I2=y_reg[5]
XU188 XOR2HS $PINS O=N439 I1=y_reg[5] I2=y_reg[4]
XU189 XOR2HS $PINS O=N146 I1=n19 I2=sub_87/carry[16]
XU190 AN2 $PINS O=sub_87/carry[16] I1=sub_87/carry[15] I2=n20
XU191 XOR2HS $PINS O=N145 I1=n20 I2=sub_87/carry[15]
XU192 AN2 $PINS O=sub_87/carry[15] I1=sub_87/carry[14] I2=n21
XU193 XOR2HS $PINS O=N144 I1=n21 I2=sub_87/carry[14]
XU194 AN2 $PINS O=sub_87/carry[14] I1=sub_87/carry[13] I2=n22
XU195 XOR2HS $PINS O=N143 I1=n22 I2=sub_87/carry[13]
XU196 AN2 $PINS O=sub_87/carry[13] I1=sub_87/carry[12] I2=n23
XU197 XOR2HS $PINS O=N142 I1=n23 I2=sub_87/carry[12]
XU198 AN2 $PINS O=sub_87/carry[12] I1=sub_87/carry[11] I2=n24
XU199 XOR2HS $PINS O=N141 I1=n24 I2=sub_87/carry[11]
XU200 AN2 $PINS O=sub_87/carry[11] I1=sub_87/carry[10] I2=n25
XU201 XOR2HS $PINS O=N140 I1=n25 I2=sub_87/carry[10]
XU202 AN2 $PINS O=sub_87/carry[10] I1=sub_87/carry[9] I2=n26
XU203 XOR2HS $PINS O=N139 I1=n26 I2=sub_87/carry[9]
XU204 AN2 $PINS O=sub_87/carry[9] I1=sub_87/carry[8] I2=n27
XU205 XOR2HS $PINS O=N138 I1=n27 I2=sub_87/carry[8]
XU206 AN2 $PINS O=sub_87/carry[8] I1=sub_87/carry[7] I2=n28
XU207 XOR2HS $PINS O=N137 I1=n28 I2=sub_87/carry[7]
XU208 AN2 $PINS O=sub_87/carry[7] I1=sub_87/carry[6] I2=n29
XU209 XOR2HS $PINS O=N136 I1=n29 I2=sub_87/carry[6]
XU210 AN2 $PINS O=sub_87/carry[6] I1=sub_87/carry[5] I2=n30
XU211 XOR2HS $PINS O=N135 I1=n30 I2=sub_87/carry[5]
XU212 AN2 $PINS O=sub_87/carry[5] I1=sub_87/carry[4] I2=n31
XU213 XOR2HS $PINS O=N134 I1=n31 I2=sub_87/carry[4]
XU214 AN2 $PINS O=sub_87/carry[4] I1=sub_87/carry[3] I2=n32
XU215 XOR2HS $PINS O=N133 I1=n32 I2=sub_87/carry[3]
XU216 AN2 $PINS O=sub_87/carry[3] I1=sub_87/carry[2] I2=n33
XU217 XOR2HS $PINS O=N132 I1=n33 I2=sub_87/carry[2]
XU218 XOR2HS $PINS O=N131 I1=n34 I2=n35
XU219 XOR2HS $PINS O=N164 I1=n36 I2=sub_88/carry[16]
XU220 AN2 $PINS O=sub_88/carry[16] I1=sub_88/carry[15] I2=n37
XU221 XOR2HS $PINS O=N163 I1=n37 I2=sub_88/carry[15]
XU222 AN2 $PINS O=sub_88/carry[15] I1=sub_88/carry[14] I2=n38
XU223 XOR2HS $PINS O=N162 I1=n38 I2=sub_88/carry[14]
XU224 AN2 $PINS O=sub_88/carry[14] I1=sub_88/carry[13] I2=n39
XU225 XOR2HS $PINS O=N161 I1=n39 I2=sub_88/carry[13]
XU226 AN2 $PINS O=sub_88/carry[13] I1=sub_88/carry[12] I2=n40
XU227 XOR2HS $PINS O=N160 I1=n40 I2=sub_88/carry[12]
XU228 AN2 $PINS O=sub_88/carry[12] I1=sub_88/carry[11] I2=n41
XU229 XOR2HS $PINS O=N159 I1=n41 I2=sub_88/carry[11]
XU230 AN2 $PINS O=sub_88/carry[11] I1=sub_88/carry[10] I2=n42
XU231 XOR2HS $PINS O=N158 I1=n42 I2=sub_88/carry[10]
XU232 AN2 $PINS O=sub_88/carry[10] I1=sub_88/carry[9] I2=n43
XU233 XOR2HS $PINS O=N157 I1=n43 I2=sub_88/carry[9]
XU234 AN2 $PINS O=sub_88/carry[9] I1=sub_88/carry[8] I2=n44
XU235 XOR2HS $PINS O=N156 I1=n44 I2=sub_88/carry[8]
XU236 AN2 $PINS O=sub_88/carry[8] I1=sub_88/carry[7] I2=n45
XU237 XOR2HS $PINS O=N155 I1=n45 I2=sub_88/carry[7]
XU238 AN2 $PINS O=sub_88/carry[7] I1=sub_88/carry[6] I2=n46
XU239 XOR2HS $PINS O=N154 I1=n46 I2=sub_88/carry[6]
XU240 AN2 $PINS O=sub_88/carry[6] I1=sub_88/carry[5] I2=n47
XU241 XOR2HS $PINS O=N153 I1=n47 I2=sub_88/carry[5]
XU242 AN2 $PINS O=sub_88/carry[5] I1=sub_88/carry[4] I2=n48
XU243 XOR2HS $PINS O=N152 I1=n48 I2=sub_88/carry[4]
XU244 AN2 $PINS O=sub_88/carry[4] I1=sub_88/carry[3] I2=n49
XU245 XOR2HS $PINS O=N151 I1=n49 I2=sub_88/carry[3]
XU246 AN2 $PINS O=sub_88/carry[3] I1=sub_88/carry[2] I2=n50
XU247 XOR2HS $PINS O=N150 I1=n50 I2=sub_88/carry[2]
XU248 XOR2HS $PINS O=N149 I1=n51 I2=n52
XU249 ND3 $PINS O=y_shift[9] I1=n53 I2=n54 I3=n55
XU250 NR2 $PINS O=n55 I1=n56 I2=n57
XU251 MOAI1S $PINS O=n57 A1=FE_OFN258_n58 A2=n59 B1=n15 B2=y_reg[11]
XU252 MOAI1S $PINS O=n56 A1=FE_OFN187_n4 A2=n60 B1=n3 B2=y_reg[9]
XU253 AOI22S $PINS O=n53 A1=y_reg[12] A2=n67 B1=y_reg[13] B2=n68
XU254 ND3 $PINS O=y_shift[8] I1=n69 I2=n70 I3=n71
XU255 NR2 $PINS O=n71 I1=n72 I2=n73
XU256 MOAI1S $PINS O=n73 A1=n74 A2=FE_OFN258_n58 B1=n15 B2=y_reg[10]
XU257 OAI222S $PINS O=n72 A1=FE_DBTN14_n3 A2=n75 B1=n76 B2=n77 C1=n62
+ C2=FE_OFN187_n4
XU258 AOI22S $PINS O=n69 A1=n80 A2=y_reg[16] B1=y_reg[11] B2=n67
XU259 ND3 $PINS O=y_shift[7] I1=n81 I2=n82 I3=n83
XU260 NR2 $PINS O=n83 I1=n84 I2=n85
XU261 MOAI1S $PINS O=n85 A1=FE_OFN258_n58 A2=n75 B1=y_reg[9] B2=n15
XU262 OAI222S $PINS O=n84 A1=FE_DBTN14_n3 A2=n86 B1=n77 B2=n87 C1=n66
+ C2=FE_OFN187_n4
XU263 ND3 $PINS O=y_shift[6] I1=n92 I2=n93 I3=n94
XU264 NR2 $PINS O=n94 I1=n95 I2=n96
XU265 MOAI1S $PINS O=n96 A1=FE_OFN258_n58 A2=n86 B1=n15 B2=FE_OFN244_y_reg_8
XU266 OAI222S $PINS O=n95 A1=FE_DBTN14_n3 A2=n97 B1=n77 B2=n59 C1=n79
+ C2=FE_OFN187_n4
XU267 ND3 $PINS O=y_shift[5] I1=n98 I2=n99 I3=n100
XU268 NR2 $PINS O=n100 I1=n101 I2=n102
XU269 MOAI1S $PINS O=n102 A1=FE_OFN258_n58 A2=n97 B1=n15 B2=y_reg[7]
XU270 OAI222S $PINS O=n101 A1=FE_DBTN14_n3 A2=n103 B1=n77 B2=n74 C1=n76
+ C2=FE_OFN187_n4
XU271 ND3 $PINS O=y_shift[4] I1=n104 I2=n105 I3=n106
XU272 NR2 $PINS O=n106 I1=n107 I2=n108
XU273 MOAI1S $PINS O=n108 A1=FE_OFN258_n58 A2=n103 B1=n15 B2=FE_OFN234_y_reg_6
XU274 OAI222S $PINS O=n107 A1=FE_DBTN14_n3 A2=n109 B1=n77 B2=n75
+ C1=FE_OFN187_n4 C2=n87
XU275 ND3 $PINS O=y_shift[3] I1=n110 I2=n111 I3=n112
XU276 NR2 $PINS O=n112 I1=n113 I2=n114
XU277 MOAI1S $PINS O=n114 A1=FE_OFN258_n58 A2=n109 B1=n15 B2=y_reg[5]
XU278 OAI222S $PINS O=n113 A1=FE_DBTN14_n3 A2=n115 B1=n77 B2=n86
+ C1=FE_OFN187_n4 C2=n59
XU279 ND3 $PINS O=y_shift[2] I1=n116 I2=n117 I3=n118
XU280 NR2 $PINS O=n118 I1=n119 I2=n120
XU281 MOAI1S $PINS O=n120 A1=FE_OFN258_n58 A2=n115 B1=n15 B2=y_reg[4]
XU282 OAI222S $PINS O=n119 A1=FE_DBTN14_n3 A2=n121 B1=n77 B2=n97 C1=n74
+ C2=FE_OFN187_n4
XU283 ND3 $PINS O=y_shift[1] I1=n122 I2=n123 I3=n124
XU284 NR2 $PINS O=n124 I1=n125 I2=n126
XU285 MOAI1S $PINS O=n126 A1=FE_OFN257_n58 A2=n121 B1=n15 B2=y_reg[3]
XU286 INV1S $PINS O=n86 I=y_reg[7]
XU287 INV1S $PINS O=n109 I=y_reg[4]
XU288 MOAI1S $PINS O=y_shift[16] A1=FE_DBTN14_n3 A2=n60 B1=FE_PHN1531_y_reg_17
+ B2=n128
XU289 OAI222S $PINS O=y_shift[15] A1=n62 A2=FE_DBTN14_n3 B1=n129 B2=n64 C1=n60
+ C2=FE_OFN258_n58
XU290 ND2 $PINS O=y_shift[14] I1=n130 I2=n131
XU291 AOI22S $PINS O=n131 A1=FE_PHN1531_y_reg_17 A2=n132 B1=n3
+ B2=FE_PHN1528_y_reg_14
XU292 AOI22S $PINS O=n130 A1=n15 A2=y_reg[16] B1=n7 B2=y_reg[15]
XU293 ND2 $PINS O=y_shift[13] I1=n133 I2=n134
XU294 AOI22S $PINS O=n133 A1=n15 A2=y_reg[15] B1=n7 B2=FE_PHN1528_y_reg_14
XU295 ND2 $PINS O=y_shift[12] I1=n136 I2=n137
XU296 INV1S $PINS O=n62 I=y_reg[15]
XU297 INV1S $PINS O=n64 I=FE_PHN1531_y_reg_17
XU298 INV1S $PINS O=n60 I=y_reg[16]
XU299 INV1S $PINS O=n66 I=FE_PHN1528_y_reg_14
XU300 ND3 $PINS O=y_shift[11] I1=n140 I2=n141 I3=n142
XU301 AOI22S $PINS O=n141 A1=FE_PHN1531_y_reg_17 A2=n143 B1=y_reg[16] B2=n144
XU302 AOI22S $PINS O=n140 A1=n67 A2=FE_PHN1528_y_reg_14 B1=n68 B2=y_reg[15]
XU303 ND3 $PINS O=y_shift[10] I1=n145 I2=n146 I3=n147
XU304 NR2 $PINS O=n147 I1=n148 I2=n149
XU305 MOAI1S $PINS O=n149 A1=n87 A2=FE_OFN258_n58 B1=y_reg[12] B2=n15
XU306 MOAI1S $PINS O=n148 A1=FE_DBTN14_n3 A2=n59 B1=FE_PHN1528_y_reg_14 B2=n68
XU307 AOI22S $PINS O=n146 A1=FE_PHN1531_y_reg_17 A2=n150 B1=y_reg[15] B2=n144
XU308 AOI22S $PINS O=n145 A1=y_reg[16] A2=n151 B1=y_reg[13] B2=n67
XU309 ND3 $PINS O=y_shift[0] I1=n152 I2=n153 I3=n154
XU310 NR2 $PINS O=n154 I1=n155 I2=n156
XU311 MOAI1S $PINS O=n156 A1=n139 A2=n121 B1=n7 B2=y_reg[1]
XU312 INV1S $PINS O=n121 I=y_reg[2]
XU313 OA222S $PINS O=n153 A1=n88 A2=n75 B1=n65 B2=n103 C1=n61 C2=n97
XU315 INV1S $PINS O=n103 I=y_reg[5]
XU318 INV1S $PINS O=n115 I=y_reg[3]
XU319 ND3 $PINS O=x_shift[9] I1=n157 I2=n158 I3=n159
XU320 NR2 $PINS O=n159 I1=n160 I2=n161
XU321 MOAI1S $PINS O=n161 A1=FE_OFN257_n58 A2=n162 B1=n15
+ B2=FE_PHN1228_x_reg_11
XU322 MOAI1S $PINS O=n160 A1=FE_OFN187_n4 A2=n163 B1=n3 B2=x_reg[9]
XU323 AOI22S $PINS O=n157 A1=x_reg[12] A2=n67 B1=x_reg[13] B2=n68
XU324 ND3 $PINS O=x_shift[8] I1=n167 I2=n168 I3=n169
XU325 NR2 $PINS O=n169 I1=n170 I2=n171
XU326 MOAI1S $PINS O=n171 A1=FE_OFN257_n58 A2=n172 B1=n15 B2=x_reg[10]
XU327 OAI222S $PINS O=n170 A1=FE_DBTN14_n3 A2=n173 B1=FE_OFN309_n68 B2=n174
+ C1=FE_OFN187_n4 C2=n164
XU328 AOI22S $PINS O=n167 A1=x_reg[16] A2=n80 B1=FE_PHN1228_x_reg_11 B2=n67
XU329 INV1S $PINS O=n80 I=n88
XU330 ND3 $PINS O=x_shift[7] I1=n176 I2=n177 I3=n178
XU331 NR2 $PINS O=n178 I1=n179 I2=n180
XU332 MOAI1S $PINS O=n180 A1=FE_OFN257_n58 A2=n173 B1=n15 B2=x_reg[9]
XU333 OAI222S $PINS O=n179 A1=FE_DBTN14_n3 A2=n181 B1=FE_OFN309_n68 B2=n182
+ C1=FE_OFN187_n4 C2=n166
XU334 ND3 $PINS O=x_shift[6] I1=n183 I2=n184 I3=n185
XU335 NR2 $PINS O=n185 I1=n186 I2=n187
XU336 MOAI1S $PINS O=n187 A1=FE_OFN257_n58 A2=n181 B1=n15 B2=x_reg[8]
XU337 OAI222S $PINS O=n186 A1=FE_DBTN14_n3 A2=n188 B1=FE_OFN309_n68 B2=n162
+ C1=FE_OFN187_n4 C2=n175
XU338 ND3 $PINS O=x_shift[5] I1=n189 I2=n190 I3=n191
XU339 NR2 $PINS O=n191 I1=n192 I2=n193
XU340 MOAI1S $PINS O=n193 A1=FE_OFN257_n58 A2=n188 B1=n15 B2=x_reg[7]
XU341 OAI222S $PINS O=n192 A1=FE_DBTN14_n3 A2=n194 B1=FE_OFN309_n68 B2=n172
+ C1=FE_OFN187_n4 C2=n174
XU342 ND3 $PINS O=x_shift[4] I1=n195 I2=n196 I3=n197
XU343 NR2 $PINS O=n197 I1=n198 I2=n199
XU344 MOAI1S $PINS O=n199 A1=FE_OFN257_n58 A2=n194 B1=n15 B2=x_reg[6]
XU345 OAI222S $PINS O=n198 A1=FE_DBTN14_n3 A2=n200 B1=FE_OFN309_n68 B2=n173
+ C1=FE_OFN187_n4 C2=n182
XU346 ND3 $PINS O=x_shift[3] I1=n201 I2=n202 I3=n203
XU347 NR2 $PINS O=n203 I1=n204 I2=n205
XU348 MOAI1S $PINS O=n205 A1=FE_OFN257_n58 A2=n200 B1=n15 B2=FE_PHN1213_x_reg_5
XU349 OAI222S $PINS O=n204 A1=FE_DBTN14_n3 A2=n206 B1=FE_OFN309_n68 B2=n181
+ C1=FE_OFN187_n4 C2=n162
XU350 ND3 $PINS O=x_shift[2] I1=n207 I2=n208 I3=n209
XU351 NR2 $PINS O=n209 I1=n210 I2=n211
XU352 MOAI1S $PINS O=n211 A1=FE_OFN257_n58 A2=n206 B1=n15 B2=x_reg[4]
XU353 OAI222S $PINS O=n210 A1=FE_DBTN14_n3 A2=n212 B1=FE_OFN309_n68 B2=n188
+ C1=FE_OFN187_n4 C2=n172
XU354 ND3 $PINS O=x_shift[1] I1=n213 I2=n214 I3=n215
XU355 NR2 $PINS O=n215 I1=n216 I2=n217
XU356 MOAI1S $PINS O=n217 A1=FE_OFN257_n58 A2=n212 B1=n15 B2=x_reg[3]
XU358 INV1S $PINS O=n200 I=x_reg[4]
XU359 MOAI1S $PINS O=x_shift[16] A1=FE_DBTN14_n3 A2=n163 B1=FE_PHN1218_x_reg_17
+ B2=n128
XU360 ND2 $PINS O=n128 I1=n129 I2=FE_OFN258_n58
XU361 OAI222S $PINS O=x_shift[15] A1=FE_DBTN14_n3 A2=n164 B1=n129 B2=n165
+ C1=FE_OFN257_n58 C2=n163
XU362 NR2 $PINS O=n129 I1=n132 I2=n15
XU363 ND2 $PINS O=x_shift[14] I1=n218 I2=n219
XU364 AOI22S $PINS O=n219 A1=FE_PHN1218_x_reg_17 A2=n132 B1=x_reg[14] B2=n3
XU365 ND2 $PINS O=n132 I1=n135 I2=n89
XU366 AOI22S $PINS O=n218 A1=x_reg[16] A2=n15 B1=x_reg[15] B2=n7
XU367 ND2 $PINS O=x_shift[13] I1=n220 I2=n221
XU368 AN2 $PINS O=n135 I1=n138 I2=FE_OFN309_n68
XU369 AOI22S $PINS O=n220 A1=x_reg[15] A2=n15 B1=x_reg[14] B2=n7
XU370 ND2 $PINS O=x_shift[12] I1=n222 I2=n223
XU371 INV1S $PINS O=n164 I=x_reg[15]
XU372 INV1S $PINS O=n165 I=FE_PHN1218_x_reg_17
XU373 NR2 $PINS O=n138 I1=n143 I2=n144
XU374 INV1S $PINS O=n163 I=x_reg[16]
XU375 INV1S $PINS O=n166 I=x_reg[14]
XU376 ND3 $PINS O=x_shift[11] I1=n224 I2=n225 I3=n226
XU377 AOI22S $PINS O=n225 A1=FE_PHN1218_x_reg_17 A2=n143 B1=x_reg[16] B2=n144
XU378 AOI22S $PINS O=n224 A1=x_reg[14] A2=n67 B1=x_reg[15] B2=n68
XU379 ND3 $PINS O=x_shift[10] I1=n227 I2=n228 I3=n229
XU380 NR2 $PINS O=n229 I1=n230 I2=n231
XU381 MOAI1S $PINS O=n231 A1=FE_OFN257_n58 A2=n182 B1=n15 B2=x_reg[12]
XU382 MOAI1S $PINS O=n230 A1=FE_DBTN14_n3 A2=n162 B1=n68 B2=x_reg[14]
XU383 AOI22S $PINS O=n228 A1=FE_PHN1218_x_reg_17 A2=n150 B1=x_reg[15] B2=n144
XU384 ND2 $PINS O=n150 I1=n63 I2=FE_OFN187_n4
XU385 AN2 $PINS O=n63 I1=n78 I2=n88
XU386 AN2 $PINS O=n78 I1=n91 I2=n90
XU387 AOI22S $PINS O=n227 A1=x_reg[16] A2=n151 B1=x_reg[13] B2=n67
XU388 INV1S $PINS O=n67 I=n89
XU389 ND3 $PINS O=x_shift[0] I1=n232 I2=n233 I3=n234
XU390 NR2 $PINS O=n234 I1=n235 I2=n236
XU391 MOAI1S $PINS O=n236 A1=n139 A2=n212 B1=n7 B2=x_reg[1]
XU392 INV1S $PINS O=n212 I=x_reg[2]
XU393 OA222 $PINS O=n233 A1=n88 A2=n173 B1=n65 B2=n194 C1=n61 C2=n188
XU394 INV1S $PINS O=n188 I=x_reg[6]
XU395 NR2 $PINS O=n151 I1=n238 I2=step_cnt[3]
XU396 INV1S $PINS O=n194 I=FE_PHN1213_x_reg_5
XU397 NR2 $PINS O=n144 I1=n239 I2=step_cnt[3]
XU399 OA222 $PINS O=n232 A1=n89 A2=n206 B1=n90 B2=n162 C1=n91 C2=n172
XU401 INV1S $PINS O=n206 I=x_reg[3]
XU402 AO22 $PINS O=FE_PHN1420_n361 A1=N314 A2=FE_OFN23_n10 B1=N366 B2=n245
XU403 AO22 $PINS O=FE_PHN1422_n362 A1=N313 A2=FE_OFN23_n10 B1=N365 B2=n245
XU404 AO22 $PINS O=FE_PHN1419_n363 A1=N312 A2=FE_OFN23_n10 B1=N364 B2=n245
XU405 AO22 $PINS O=n364 A1=N311 A2=FE_OFN23_n10 B1=N363 B2=n245
XU406 AO22 $PINS O=n365 A1=N310 A2=FE_OFN23_n10 B1=N362 B2=n245
XU407 AO22 $PINS O=n366 A1=N309 A2=FE_OFN23_n10 B1=N361 B2=n245
XU408 AO22 $PINS O=n367 A1=N308 A2=n2 B1=N360 B2=n245
XU409 AO22 $PINS O=n368 A1=N307 A2=n2 B1=N359 B2=n245
XU410 AO22 $PINS O=n369 A1=N306 A2=FE_OFN23_n10 B1=N358 B2=n245
XU411 NR3 $PINS O=N515 I1=n246 I2=n244 I3=n247
XU412 AOI22S $PINS O=n248 A1=y_in[16] A2=n250 B1=N165 B2=n251
XU413 ND2 $PINS O=N513 I1=n252 I2=n253
XU414 AOI22S $PINS O=n253 A1=N356 A2=n245 B1=N304 B2=FE_OFN23_n10
XU415 AOI22S $PINS O=n252 A1=y_in[16] A2=n250 B1=N164 B2=n251
XU416 ND2 $PINS O=N512 I1=FE_PHN1508_n254 I2=n255
XU417 AOI22S $PINS O=n255 A1=N355 A2=n245 B1=N303 B2=FE_OFN23_n10
XU418 AOI22S $PINS O=n254 A1=FE_PHN1105_c_in_i_0_15 A2=n250 B1=N163 B2=n251
XU419 ND2 $PINS O=N511 I1=n256 I2=n257
XU420 AOI22S $PINS O=n257 A1=N354 A2=n245 B1=N302 B2=FE_OFN23_n10
XU421 AOI22S $PINS O=n256 A1=y_in[14] A2=n250 B1=N162 B2=n251
XU422 ND2 $PINS O=N510 I1=FE_PHN1516_n258 I2=n259
XU423 AOI22S $PINS O=n259 A1=N353 A2=n245 B1=N301 B2=FE_OFN23_n10
XU424 AOI22S $PINS O=n258 A1=FE_PHN1101_c_in_i_0_13 A2=n250 B1=N161 B2=n251
XU425 ND2 $PINS O=N509 I1=FE_PHN1522_n260 I2=n261
XU426 AOI22S $PINS O=n261 A1=N352 A2=n245 B1=N300 B2=FE_OFN23_n10
XU427 AOI22S $PINS O=n260 A1=FE_PHN1108_c_in_i_0_12 A2=n250 B1=N160 B2=n251
XU428 ND2 $PINS O=N508 I1=FE_PHN1520_n262 I2=n263
XU429 AOI22S $PINS O=n263 A1=N351 A2=n245 B1=N299 B2=FE_OFN23_n10
XU430 AOI22S $PINS O=n262 A1=FE_PHN1115_c_in_i_0_11 A2=n250 B1=N159 B2=n251
XU431 ND2 $PINS O=N507 I1=n264 I2=n265
XU432 AOI22S $PINS O=n265 A1=N350 A2=n245 B1=N298 B2=FE_OFN23_n10
XU433 AOI22S $PINS O=n264 A1=y_in[10] A2=n250 B1=N158 B2=n251
XU434 ND2 $PINS O=N506 I1=FE_PHN1515_n266 I2=n267
XU435 AOI22S $PINS O=n267 A1=N349 A2=n245 B1=N297 B2=FE_OFN23_n10
XU436 AOI22S $PINS O=n266 A1=FE_PHN1098_c_in_i_0_9 A2=n250 B1=N157 B2=n251
XU437 ND2 $PINS O=FE_PHN1487_N505 I1=n268 I2=n269
XU438 AOI22S $PINS O=n269 A1=N348 A2=n245 B1=N296 B2=FE_OFN23_n10
XU439 AOI22S $PINS O=n268 A1=y_in[8] A2=n250 B1=N156 B2=n251
XU440 ND2 $PINS O=N504 I1=n270 I2=n271
XU441 AOI22S $PINS O=n271 A1=N347 A2=n245 B1=N295 B2=FE_OFN23_n10
XU442 AOI22S $PINS O=n270 A1=y_in[7] A2=n250 B1=N155 B2=n251
XU443 ND2 $PINS O=FE_PHN1486_N503 I1=n272 I2=n273
XU444 AOI22S $PINS O=n273 A1=N346 A2=n245 B1=N294 B2=FE_OFN23_n10
XU445 AOI22S $PINS O=n272 A1=y_in[6] A2=n250 B1=N154 B2=n251
XU446 ND2 $PINS O=N502 I1=FE_PHN1484_n274 I2=n275
XU447 AOI22S $PINS O=n275 A1=N345 A2=n245 B1=N293 B2=FE_OFN23_n10
XU448 AOI22S $PINS O=n274 A1=y_in[5] A2=n250 B1=N153 B2=n251
XU449 ND2 $PINS O=N501 I1=n276 I2=n277
XU450 AOI22S $PINS O=n277 A1=N344 A2=n245 B1=N292 B2=FE_OFN23_n10
XU451 AOI22S $PINS O=n276 A1=y_in[4] A2=n250 B1=N152 B2=n251
XU452 ND2 $PINS O=N500 I1=n278 I2=n279
XU453 AOI22S $PINS O=n279 A1=N343 A2=n245 B1=N291 B2=FE_OFN23_n10
XU454 AOI22S $PINS O=n278 A1=y_in[3] A2=n250 B1=N151 B2=n251
XU455 ND2 $PINS O=FE_PHN1396_N499 I1=n280 I2=n281
XU456 AOI22S $PINS O=n281 A1=N342 A2=n245 B1=N290 B2=FE_OFN23_n10
XU457 AOI22S $PINS O=n280 A1=y_in[2] A2=n250 B1=N150 B2=n251
XU458 ND2 $PINS O=N498 I1=n282 I2=n283
XU459 AOI22S $PINS O=n283 A1=N341 A2=n245 B1=N289 B2=FE_OFN23_n10
XU460 AOI22S $PINS O=n282 A1=y_in[1] A2=n250 B1=N149 B2=n251
XU461 ND2 $PINS O=N497 I1=n284 I2=n285
XU462 AOI22S $PINS O=n285 A1=N340 A2=n245 B1=N288 B2=FE_OFN23_n10
XU463 AOI22S $PINS O=n284 A1=N148 A2=n250 B1=N148 B2=n251
XU464 ND2 $PINS O=N496 I1=n286 I2=n287
XU465 AOI22S $PINS O=n287 A1=N339 A2=n245 B1=N287 B2=FE_OFN23_n10
XU466 AOI22S $PINS O=n286 A1=x_in[16] A2=n250 B1=N147 B2=n251
XU467 ND2 $PINS O=N495 I1=n288 I2=n289
XU468 AOI22S $PINS O=n289 A1=N338 A2=n245 B1=N286 B2=FE_OFN23_n10
XU469 AOI22S $PINS O=n288 A1=x_in[16] A2=n250 B1=N146 B2=n251
XU470 ND2 $PINS O=N494 I1=n290 I2=n291
XU471 AOI22S $PINS O=n291 A1=N337 A2=n245 B1=N285 B2=FE_OFN23_n10
XU472 AOI22S $PINS O=n290 A1=x_in[15] A2=n250 B1=N145 B2=n251
XU473 ND2 $PINS O=N493 I1=n292 I2=n293
XU474 AOI22S $PINS O=n293 A1=N336 A2=n245 B1=N284 B2=n2
XU475 AOI22S $PINS O=n292 A1=x_in[14] A2=n250 B1=N144 B2=n251
XU476 ND2 $PINS O=N492 I1=n294 I2=n295
XU477 AOI22S $PINS O=n295 A1=N335 A2=n245 B1=N283 B2=n2
XU478 AOI22S $PINS O=n294 A1=x_in[13] A2=n250 B1=N143 B2=n251
XU479 ND2 $PINS O=N491 I1=n296 I2=n297
XU480 AOI22S $PINS O=n297 A1=N334 A2=n245 B1=N282 B2=n2
XU481 AOI22S $PINS O=n296 A1=x_in[12] A2=n250 B1=N142 B2=n251
XU482 ND2 $PINS O=N490 I1=FE_PHN1536_n298 I2=n299
XU483 AOI22S $PINS O=n299 A1=N333 A2=n245 B1=N281 B2=FE_OFN23_n10
XU484 AOI22S $PINS O=n298 A1=x_in[11] A2=n250 B1=N141 B2=n251
XU485 ND2 $PINS O=N489 I1=n300 I2=n301
XU486 AOI22S $PINS O=n301 A1=N332 A2=n245 B1=N280 B2=n2
XU487 AOI22S $PINS O=n300 A1=FE_PHN1500_c_in_r_0_10 A2=n250 B1=N140 B2=n251
XU488 ND2 $PINS O=N488 I1=n302 I2=n303
XU489 AOI22S $PINS O=n303 A1=N331 A2=n245 B1=N279 B2=FE_OFN23_n10
XU490 AOI22S $PINS O=n302 A1=x_in[9] A2=n250 B1=N139 B2=n251
XU491 ND2 $PINS O=N487 I1=n304 I2=n305
XU492 AOI22S $PINS O=n305 A1=N330 A2=n245 B1=N278 B2=FE_OFN23_n10
XU493 AOI22S $PINS O=n304 A1=x_in[8] A2=n250 B1=N138 B2=n251
XU494 ND2 $PINS O=N486 I1=n306 I2=n307
XU495 AOI22S $PINS O=n307 A1=N329 A2=n245 B1=N277 B2=FE_OFN23_n10
XU496 AOI22S $PINS O=n306 A1=x_in[7] A2=n250 B1=N137 B2=n251
XU497 ND2 $PINS O=N485 I1=n308 I2=n309
XU498 AOI22S $PINS O=n309 A1=N328 A2=n245 B1=N276 B2=n2
XU499 AOI22S $PINS O=n308 A1=x_in[6] A2=n250 B1=N136 B2=n251
XU500 ND2 $PINS O=N484 I1=n310 I2=n311
XU501 AOI22S $PINS O=n311 A1=N327 A2=n245 B1=N275 B2=FE_OFN23_n10
XU502 AOI22S $PINS O=n310 A1=x_in[5] A2=n250 B1=N135 B2=n251
XU503 ND2 $PINS O=N483 I1=n312 I2=n313
XU504 AOI22S $PINS O=n313 A1=N326 A2=n245 B1=N274 B2=n2
XU505 AOI22S $PINS O=n312 A1=x_in[4] A2=n250 B1=N134 B2=n251
XU506 ND2 $PINS O=N482 I1=n314 I2=n315
XU507 AOI22S $PINS O=n315 A1=N325 A2=n245 B1=N273 B2=n2
XU508 AOI22S $PINS O=n314 A1=x_in[3] A2=n250 B1=N133 B2=n251
XU509 ND2 $PINS O=N481 I1=n316 I2=n317
XU510 AOI22S $PINS O=n317 A1=N324 A2=n245 B1=N272 B2=n2
XU511 AOI22S $PINS O=n316 A1=x_in[2] A2=n250 B1=N132 B2=n251
XU512 ND2 $PINS O=N480 I1=n318 I2=n319
XU513 AOI22S $PINS O=n319 A1=N323 A2=n245 B1=N271 B2=FE_OFN23_n10
XU514 AOI22S $PINS O=n318 A1=x_in[1] A2=n250 B1=N131 B2=n251
XU515 ND2 $PINS O=N479 I1=n320 I2=n321
XU516 AOI22S $PINS O=FE_PHN1372_n321 A1=N322 A2=n245 B1=N270 B2=FE_OFN23_n10
XU517 AOI22S $PINS O=n320 A1=N130 A2=n250 B1=N130 B2=n251
XU518 INV2 $PINS O=n250 I=n322
XU519 OAI112HS $PINS O=N478 A1=n324 B1=n325 C1=n323 C2=n322
XU520 AOI22S $PINS O=n325 A1=n323 A2=n326 B1=n323 B2=n327
XU521 AOI22S $PINS O=FE_PHN1390_n324 A1=N373 A2=n245 B1=N321 B2=FE_OFN23_n10
XU522 OAI112HS $PINS O=N477 A1=FE_PHN1395_n329 B1=n330 C1=n328 C2=n322
XU523 AOI22S $PINS O=n330 A1=N182 A2=n326 B1=N182 B2=n327
XU524 AOI22S $PINS O=n329 A1=N372 A2=n245 B1=N320 B2=FE_OFN23_n10
XU525 OAI112HS $PINS O=N476 A1=FE_PHN1421_n332 B1=n333 C1=n322 C2=n331
XU526 AOI22S $PINS O=n333 A1=N181 A2=n326 B1=N181 B2=n327
XU527 AOI22S $PINS O=n332 A1=N371 A2=n245 B1=N319 B2=FE_OFN23_n10
XU528 INV1S $PINS O=n331 I=N181
XU529 OAI112HS $PINS O=N475 A1=FE_PHN1424_n335 B1=n336 C1=n322 C2=n334
XU530 AOI22S $PINS O=n336 A1=N180 A2=n326 B1=N180 B2=n327
XU531 AOI22S $PINS O=n335 A1=N370 A2=n245 B1=N318 B2=n2
XU532 INV1S $PINS O=n334 I=N180
XU533 OAI112HS $PINS O=N474 A1=FE_PHN1440_n338 B1=n339 C1=n322 C2=n337
XU534 AOI22S $PINS O=n339 A1=N179 A2=n326 B1=N179 B2=n327
XU535 AOI22S $PINS O=n338 A1=N369 A2=n245 B1=N317 B2=n2
XU536 OAI112HS $PINS O=N473 A1=n341 B1=n342 C1=n322 C2=n340
XU537 AOI22S $PINS O=n342 A1=N178 A2=n326 B1=N178 B2=n327
XU538 AOI22S $PINS O=FE_PHN1431_n341 A1=N368 A2=n245 B1=N316 B2=n2
XU539 OAI112HS $PINS O=N472 A1=FE_PHN1443_n344 B1=n345 C1=n322 C2=p1
XU540 AOI22S $PINS O=n345 A1=N177 A2=n326 B1=N177 B2=n327
XU541 AN2 $PINS O=n327 I1=n251 I2=phase_in[15]
XU542 AN2 $PINS O=n326 I1=n251 I2=n323
XU543 AOI12H $PINS O=n251 A1=n348 B1=n346 B2=n347
XU544 AOI22S $PINS O=n344 A1=N367 A2=n245 B1=N315 B2=n2
XU545 AN2P $PINS O=n245 I1=z_reg[15] I2=is_computing
XU547 OR3B2 $PINS O=n322 I1=n348 B1=n347 B2=n346
XU548 ND2 $PINS O=n346 I1=phase_in[15] I2=n328
XU549 INV1S $PINS O=n328 I=N182
XU550 ND3 $PINS O=n347 I1=n349 I2=n323 I3=N182
XU551 INV1S $PINS O=n323 I=phase_in[15]
XU552 ND3 $PINS O=n349 I1=n340 I2=n337 I3=n350
XU553 NR3 $PINS O=n350 I1=N180 I2=N177 I3=N181
XU554 INV1S $PINS O=n337 I=N179
XU555 INV1S $PINS O=n340 I=N178
XU556 ND2 $PINS O=N462 I1=n246 I2=n348
XU557 MOAI1S $PINS O=N461 A1=n351 A2=n244 B1=is_computing B2=n127
XU558 NR2 $PINS O=n352 I1=step_cnt[3] I2=n241
XU559 OAI22S $PINS O=N460 A1=n353 A2=n242 B1=n247 B2=n246
XU560 MOAI1S $PINS O=N459 A1=n241 A2=FE_PHN1053_n354 B1=n243 B2=is_computing
XU561 INV1S $PINS O=N458 I=FE_PHN1053_n354
XU562 ND2 $PINS O=N457 I1=n348 I2=n356
XU563 OAI12HS $PINS O=n356 A1=is_computing B1=n244 B2=n247
XU564 ND2 $PINS O=n348 I1=valid_in I2=n246
XU565 INV1S $PINS O=n246 I=is_computing
XU566 ND3 $PINS O=N118 I1=n357 I2=n358 I3=n359
XU567 AN2 $PINS O=n359 I1=n247 I2=n237
XU568 OAI112HS $PINS O=N117 A1=n239 B1=n360 C1=n241 C2=n244
XU569 AN3 $PINS O=n360 I1=n237 I2=n139 I3=n238
XU570 OAI112HS $PINS O=N116 A1=n239 B1=n58 C1=n244 C2=n355
XU571 OAI112HS $PINS O=N115 A1=n237 B1=n139 C1=n243 C2=n244
XU572 OAI112HS $PINS O=N114 A1=n247 B1=n357 C1=n244 C2=n355
XU573 OA13S $PINS O=n358 A1=n238 B1=step_cnt[0] B2=FE_OFN337_step_cnt_1 B3=n244
XU574 AOI13HS $PINS O=n357 A1=n15 B1=step_cnt[0] B2=FE_OFN337_step_cnt_1
+ B3=step_cnt[2]
XU575 OR3B2 $PINS O=N111 I1=N109 B1=n139 B2=n238
XU576 ND3 $PINS O=N110 I1=n139 I2=n247 I3=n239
XU577 NR2 $PINS O=n240 I1=step_cnt[2] I2=step_cnt[0]
XU578 ND3 $PINS O=n58 I1=n242 I2=n244 I3=n243
XU579 INV2 $PINS O=N108 I=n247
Xclk_gate_y_reg_reg SNPS_CLOCK_GATE_HIGH_cordic_rotation_1_0 $PINS EN=N462
+ ENCLK=CTS_42 CLK=clk_clone3
Xclk_gate_z_reg_reg SNPS_CLOCK_GATE_HIGH_cordic_rotation_1_4 $PINS EN=N462
+ ENCLK=CTS_39 CLK=clk_clone3
Xclk_gate_y_out_reg SNPS_CLOCK_GATE_HIGH_cordic_rotation_1_3 $PINS EN=N515
+ ENCLK=CTS_45 CLK=clk_clone2
Xclk_gate_x_out_reg SNPS_CLOCK_GATE_HIGH_cordic_rotation_1_2 $PINS EN=N515
+ ENCLK=CTS_48 CLK=clk_clone1
Xclk_gate_step_cnt_reg SNPS_CLOCK_GATE_HIGH_cordic_rotation_1_1 $PINS
+ EN=FE_PHN1391_N457 ENCLK=net2446 CLK=clk_clone4
Xadd_105 cordic_rotation_1_DW01_add_2_DW01_add_8 $PINS A[15]=z_reg[15]
+ A[14]=z_reg[14] A[13]=z_reg[13] A[12]=z_reg[12] A[11]=z_reg[11] A[10]=z_reg[10]
+ A[9]=z_reg[9] A[8]=z_reg[8] A[7]=z_reg[7] A[6]=z_reg[6] A[5]=z_reg[5]
+ A[4]=z_reg[4] A[3]=z_reg[3] A[2]=z_reg[2] A[1]=z_reg[1] A[0]=z_reg[0] B[15]=n8
+ B[14]=n8 B[13]=n3 B[12]=n7 B[11]=n15 B[10]=N108 B[9]=N109 B[8]=N110 B[7]=N111
+ B[6]=N112 B[5]=N113 B[4]=N114 B[3]=N115 B[2]=N116 B[1]=N117 B[0]=N118 CI=n8
+ SUM[15]=N373 SUM[14]=N372 SUM[13]=N371 SUM[12]=N370 SUM[11]=N369 SUM[10]=N368
+ SUM[9]=N367 SUM[8]=N366 SUM[7]=N365 SUM[6]=N364 SUM[5]=N363 SUM[4]=N362
+ SUM[3]=N361 SUM[2]=N360 SUM[1]=N359 SUM[0]=N358
Xsub_104 cordic_rotation_1_DW01_sub_0_DW01_sub_34 $PINS
+ A[17]=FE_PHN1531_y_reg_17 A[16]=y_reg[16] A[15]=y_reg[15]
+ A[14]=FE_PHN1528_y_reg_14 A[13]=y_reg[13] A[12]=y_reg[12] A[11]=y_reg[11]
+ A[10]=y_reg[10] A[9]=y_reg[9] A[8]=y_reg[8] A[7]=y_reg[7] A[6]=y_reg[6]
+ A[5]=y_reg[5] A[4]=y_reg[4] A[3]=y_reg[3] A[2]=y_reg[2] A[1]=y_reg[1]
+ A[0]=y_reg[0] B[17]=x_shift[16] B[16]=x_shift[16] B[15]=x_shift[15]
+ B[14]=x_shift[14] B[13]=x_shift[13] B[12]=x_shift[12] B[11]=x_shift[11]
+ B[10]=x_shift[10] B[9]=x_shift[9] B[8]=x_shift[8] B[7]=x_shift[7]
+ B[6]=x_shift[6] B[5]=x_shift[5] B[4]=x_shift[4] B[3]=x_shift[3] B[2]=x_shift[2]
+ B[1]=x_shift[1] B[0]=x_shift[0] CI=n8 DIFF[17]=N357 DIFF[16]=N356 DIFF[15]=N355
+ DIFF[14]=N354 DIFF[13]=N353 DIFF[12]=N352 DIFF[11]=N351 DIFF[10]=N350
+ DIFF[9]=N349 DIFF[8]=N348 DIFF[7]=N347 DIFF[6]=N346 DIFF[5]=N345 DIFF[4]=N344
+ DIFF[3]=N343 DIFF[2]=N342 DIFF[1]=N341 DIFF[0]=N340
Xadd_103 cordic_rotation_1_DW01_add_3_DW01_add_9 $PINS
+ A[17]=FE_PHN1218_x_reg_17 A[16]=x_reg[16] A[15]=x_reg[15] A[14]=x_reg[14]
+ A[13]=FE_PHN1142_x_reg_13 A[12]=x_reg[12] A[11]=FE_PHN1228_x_reg_11
+ A[10]=x_reg[10] A[9]=x_reg[9] A[8]=x_reg[8] A[7]=x_reg[7] A[6]=x_reg[6]
+ A[5]=FE_PHN1213_x_reg_5 A[4]=x_reg[4] A[3]=x_reg[3] A[2]=x_reg[2] A[1]=x_reg[1]
+ A[0]=x_reg[0] B[17]=y_shift[16] B[16]=y_shift[16] B[15]=y_shift[15]
+ B[14]=y_shift[14] B[13]=y_shift[13] B[12]=y_shift[12] B[11]=y_shift[11]
+ B[10]=y_shift[10] B[9]=y_shift[9] B[8]=y_shift[8] B[7]=y_shift[7]
+ B[6]=y_shift[6] B[5]=y_shift[5] B[4]=y_shift[4] B[3]=y_shift[3] B[2]=y_shift[2]
+ B[1]=y_shift[1] B[0]=y_shift[0] CI=n8 SUM[17]=N339 SUM[16]=N338 SUM[15]=N337
+ SUM[14]=N336 SUM[13]=N335 SUM[12]=N334 SUM[11]=N333 SUM[10]=N332 SUM[9]=N331
+ SUM[8]=N330 SUM[7]=N329 SUM[6]=N328 SUM[5]=N327 SUM[4]=N326 SUM[3]=N325
+ SUM[2]=N324 SUM[1]=N323 SUM[0]=N322
Xsub_101 cordic_rotation_1_DW01_sub_1_DW01_sub_35 $PINS A[15]=z_reg[15]
+ A[14]=z_reg[14] A[13]=z_reg[13] A[12]=z_reg[12] A[11]=z_reg[11] A[10]=z_reg[10]
+ A[9]=z_reg[9] A[8]=z_reg[8] A[7]=z_reg[7] A[6]=z_reg[6] A[5]=z_reg[5]
+ A[4]=z_reg[4] A[3]=z_reg[3] A[2]=z_reg[2] A[1]=z_reg[1] A[0]=z_reg[0] B[15]=n8
+ B[14]=n8 B[13]=FE_DBTN14_n3 B[12]=n7 B[11]=n15 B[10]=N108 B[9]=N109 B[8]=N110
+ B[7]=N111 B[6]=N112 B[5]=N113 B[4]=N114 B[3]=N115 B[2]=N116 B[1]=N117 B[0]=N118
+ CI=n8 DIFF[15]=N321 DIFF[14]=N320 DIFF[13]=N319 DIFF[12]=N318 DIFF[11]=N317
+ DIFF[10]=N316 DIFF[9]=N315 DIFF[8]=N314 DIFF[7]=N313 DIFF[6]=N312 DIFF[5]=N311
+ DIFF[4]=N310 DIFF[3]=N309 DIFF[2]=N308 DIFF[1]=N307 DIFF[0]=N306 n58=n58
+ n247=n247
Xadd_100 cordic_rotation_1_DW01_add_4_DW01_add_10 $PINS
+ A[17]=FE_PHN1531_y_reg_17 A[16]=y_reg[16] A[15]=y_reg[15]
+ A[14]=FE_PHN1528_y_reg_14 A[13]=y_reg[13] A[12]=y_reg[12] A[11]=y_reg[11]
+ A[10]=y_reg[10] A[9]=y_reg[9] A[8]=y_reg[8] A[7]=y_reg[7] A[6]=y_reg[6]
+ A[5]=y_reg[5] A[4]=y_reg[4] A[3]=y_reg[3] A[2]=y_reg[2] A[1]=y_reg[1]
+ A[0]=y_reg[0] B[17]=x_shift[16] B[16]=x_shift[16] B[15]=x_shift[15]
+ B[14]=x_shift[14] B[13]=x_shift[13] B[12]=x_shift[12] B[11]=x_shift[11]
+ B[10]=x_shift[10] B[9]=x_shift[9] B[8]=x_shift[8] B[7]=x_shift[7]
+ B[6]=x_shift[6] B[5]=x_shift[5] B[4]=x_shift[4] B[3]=x_shift[3] B[2]=x_shift[2]
+ B[1]=x_shift[1] B[0]=x_shift[0] CI=n8 SUM[17]=N305 SUM[16]=N304 SUM[15]=N303
+ SUM[14]=N302 SUM[13]=N301 SUM[12]=N300 SUM[11]=N299 SUM[10]=N298 SUM[9]=N297
+ SUM[8]=N296 SUM[7]=N295 SUM[6]=N294 SUM[5]=N293 SUM[4]=N292 SUM[3]=N291
+ SUM[2]=N290 SUM[1]=N289 SUM[0]=N288
Xsub_99 cordic_rotation_1_DW01_sub_2_DW01_sub_36 $PINS
+ A[17]=FE_PHN1218_x_reg_17 A[16]=x_reg[16] A[15]=x_reg[15] A[14]=x_reg[14]
+ A[13]=FE_PHN1142_x_reg_13 A[12]=x_reg[12] A[11]=FE_PHN1228_x_reg_11
+ A[10]=x_reg[10] A[9]=x_reg[9] A[8]=x_reg[8] A[7]=x_reg[7] A[6]=x_reg[6]
+ A[5]=FE_PHN1213_x_reg_5 A[4]=x_reg[4] A[3]=x_reg[3] A[2]=x_reg[2] A[1]=x_reg[1]
+ A[0]=x_reg[0] B[17]=y_shift[16] B[16]=y_shift[16] B[15]=y_shift[15]
+ B[14]=y_shift[14] B[13]=y_shift[13] B[12]=y_shift[12] B[11]=y_shift[11]
+ B[10]=y_shift[10] B[9]=y_shift[9] B[8]=y_shift[8] B[7]=y_shift[7]
+ B[6]=y_shift[6] B[5]=y_shift[5] B[4]=y_shift[4] B[3]=y_shift[3] B[2]=y_shift[2]
+ B[1]=y_shift[1] B[0]=y_shift[0] CI=n8 DIFF[17]=N287 DIFF[16]=N286 DIFF[15]=N285
+ DIFF[14]=N284 DIFF[13]=N283 DIFF[12]=N282 DIFF[11]=N281 DIFF[10]=N280
+ DIFF[9]=N279 DIFF[8]=N278 DIFF[7]=N277 DIFF[6]=N276 DIFF[5]=N275 DIFF[4]=N274
+ DIFF[3]=N273 DIFF[2]=N272 DIFF[1]=N271 DIFF[0]=N270
.ENDS

.SUBCKT SNPS_CLOCK_GATE_HIGH_cordic_rotation_0_0 EN ENCLK CLK
*.CONNECT net2381 EN
XFE_PHC821_net2384 DELC $PINS O=net2384 I=FE_PHN821_net2384
Xlatch QDBHN $PINS Q=FE_PHN821_net2384 D=net2381 CKB=CLK
Xmain_gate AN2T $PINS O=ENCLK I1=net2384 I2=CLK
.ENDS

.SUBCKT SNPS_CLOCK_GATE_HIGH_cordic_rotation_0_4 EN ENCLK CLK
*.CONNECT net2381 EN
XFE_PHC865_net2384 DELC $PINS O=FE_PHN865_net2384 I=net2384
Xlatch QDBHN $PINS Q=net2384 D=net2381 CKB=CLK
Xmain_gate AN2T $PINS O=ENCLK I1=FE_PHN865_net2384 I2=CLK
.ENDS

.SUBCKT SNPS_CLOCK_GATE_HIGH_cordic_rotation_0_3 EN ENCLK CLK
*.CONNECT net2381 EN
XFE_PHC853_net2384 DELC $PINS O=FE_PHN853_net2384 I=net2384
Xlatch QDBHN $PINS Q=net2384 D=net2381 CKB=CLK
Xmain_gate AN2 $PINS O=ENCLK I1=FE_PHN853_net2384 I2=CLK
.ENDS

.SUBCKT SNPS_CLOCK_GATE_HIGH_cordic_rotation_0_2 EN ENCLK CLK
*.CONNECT net2381 EN
XFE_PHC869_net2384 DELC $PINS O=FE_PHN869_net2384 I=net2384
Xlatch QDBHN $PINS Q=net2384 D=net2381 CKB=CLK
Xmain_gate AN2 $PINS O=ENCLK I1=FE_PHN869_net2384 I2=CLK
.ENDS

.SUBCKT SNPS_CLOCK_GATE_HIGH_cordic_rotation_0_1 EN ENCLK CLK
*.CONNECT net2381 EN
XFE_PHC1526_net2384 BUF1CK $PINS O=FE_PHN1526_net2384 I=net2384
XFE_PHC938_net2384 DELC $PINS O=FE_PHN938_net2384 I=FE_PHN1526_net2384
XCTS_cdb_INV_CLK_G0_L5_8 INV3CK $PINS O=CTS_11 I=CTS_12
XCTS_cdb_INV_CLK_G0_L4_4 INV1CK $PINS O=CTS_12 I=CLK
Xlatch QDBHN $PINS Q=net2384 D=net2381 CKB=CLK
Xmain_gate AN2P $PINS O=ENCLK I1=FE_PHN938_net2384 I2=CTS_11
.ENDS

.SUBCKT cordic_rotation_0_DW01_add_2 A[15] A[14] A[13] A[12] A[11] A[10] A[9]
+ A[8] A[7] A[6] A[5] A[4] A[3] A[2] A[1] A[0] B[15] B[14] B[13] B[12] B[11]
+ B[10] B[9] B[8] B[7] B[6] B[5] B[4] B[3] B[2] B[1] B[0] CI SUM[15] SUM[14]
+ SUM[13] SUM[12] SUM[11] SUM[10] SUM[9] SUM[8] SUM[7] SUM[6] SUM[5] SUM[4]
+ SUM[3] SUM[2] SUM[1] SUM[0] CO
XU1_12 FA1S $PINS S=SUM[12] CO=carry[13] A=A[12] B=B[12] CI=carry[12]
XU1_11 FA1S $PINS S=SUM[11] CO=carry[12] A=A[11] B=B[11] CI=carry[11]
XU1_5 FA1S $PINS S=SUM[5] CO=carry[6] A=A[5] B=B[5] CI=carry[5]
XU1_7 FA1S $PINS S=SUM[7] CO=carry[8] A=A[7] B=B[7] CI=carry[7]
XU1_6 FA1S $PINS S=SUM[6] CO=carry[7] A=A[6] B=B[6] CI=carry[6]
XU1_8 FA1S $PINS S=SUM[8] CO=carry[9] A=A[8] B=B[8] CI=carry[8]
XU1_9 FA1S $PINS S=SUM[9] CO=carry[10] A=A[9] B=B[9] CI=carry[9]
XU1_10 FA1S $PINS S=SUM[10] CO=carry[11] A=A[10] B=B[10] CI=carry[10]
XU1_4 FA1S $PINS S=SUM[4] CO=carry[5] A=A[4] B=B[4] CI=carry[4]
XU1_2 FA1S $PINS S=SUM[2] CO=carry[3] A=A[2] B=B[2] CI=carry[2]
XU1_3 FA1S $PINS S=SUM[3] CO=carry[4] A=A[3] B=B[3] CI=carry[3]
XU1_1 FA1S $PINS S=SUM[1] CO=carry[2] A=A[1] B=B[1] CI=n1
XU1_13 FA1S $PINS S=SUM[13] CO=carry[14] A=A[13] B=B[13] CI=carry[13]
XU1 AN2 $PINS O=n1 I1=B[0] I2=A[0]
XU2 XNR2HS $PINS O=SUM[15] I1=A[15] I2=n2
XU3 XOR2HS $PINS O=SUM[14] I1=A[14] I2=carry[14]
XU4 XOR2HS $PINS O=SUM[0] I1=B[0] I2=A[0]
XU5 ND2 $PINS O=n2 I1=A[14] I2=carry[14]
.ENDS

.SUBCKT cordic_rotation_0_DW01_sub_0_DW01_sub_28 A[17] A[16] A[15] A[14] A[13]
+ A[12] A[11] A[10] A[9] A[8] A[7] A[6] A[5] A[4] A[3] A[2] A[1] A[0] B[17]
+ B[16] B[15] B[14] B[13] B[12] B[11] B[10] B[9] B[8] B[7] B[6] B[5] B[4] B[3]
+ B[2] B[1] B[0] CI DIFF[17] DIFF[16] DIFF[15] DIFF[14] DIFF[13] DIFF[12]
+ DIFF[11] DIFF[10] DIFF[9] DIFF[8] DIFF[7] DIFF[6] DIFF[5] DIFF[4] DIFF[3]
+ DIFF[2] DIFF[1] DIFF[0] CO
XFE_RC_1570_0 XOR3 $PINS O=DIFF[2] I1=A[2] I2=n12 I3=carry[2]
XFE_RC_1569_0 MAO222 $PINS O=carry[3] A1=A[2] B1=n12 C1=carry[2]
XU2_3 FA1S $PINS S=DIFF[3] CO=carry[4] A=A[3] B=n13 CI=carry[3]
XU2_1 FA1S $PINS S=DIFF[1] CO=carry[2] A=A[1] B=n11 CI=carry[1]
XU2_6 FA1 $PINS S=DIFF[6] CO=carry[7] A=A[6] B=n16 CI=carry[6]
XU2_16 FA1S $PINS S=DIFF[16] CO=carry[17] A=A[16] B=n8 CI=carry[16]
XU2_9 FA1S $PINS S=DIFF[9] CO=carry[10] A=A[9] B=n10 CI=carry[9]
XU2_7 FA1S $PINS S=DIFF[7] CO=carry[8] A=A[7] B=n17 CI=carry[7]
XU2_8 FA1S $PINS S=DIFF[8] CO=carry[9] A=A[8] B=n18 CI=carry[8]
XU2_5 FA1 $PINS S=DIFF[5] CO=carry[6] A=A[5] B=n15 CI=carry[5]
XU2_4 FA1 $PINS S=DIFF[4] CO=carry[5] A=A[4] B=n14 CI=carry[4]
XU2_11 FA1 $PINS S=DIFF[11] CO=carry[12] A=A[11] B=n4 CI=carry[11]
XU2_12 FA1 $PINS S=DIFF[12] CO=carry[13] A=A[12] B=n9 CI=carry[12]
XU2_10 FA1 $PINS S=DIFF[10] CO=carry[11] A=A[10] B=n3 CI=carry[10]
XU2_13 FA1S $PINS S=DIFF[13] CO=carry[14] A=A[13] B=n5 CI=carry[13]
XU2_17 XOR3 $PINS O=DIFF[17] I1=A[17] I2=n8 I3=carry[17]
XU2_15 FA1 $PINS S=DIFF[15] CO=carry[16] A=A[15] B=n7 CI=carry[15]
XU2_14 FA1 $PINS S=DIFF[14] CO=carry[15] A=A[14] B=n6 CI=carry[14]
XU1 INV1S $PINS O=n2 I=B[0]
XU2 INV1S $PINS O=n8 I=B[17]
XU3 INV1S $PINS O=n5 I=B[13]
XU4 INV1S $PINS O=n3 I=B[10]
XU5 INV1S $PINS O=n9 I=B[12]
XU6 INV1S $PINS O=n4 I=B[11]
XU7 INV1S $PINS O=n14 I=B[4]
XU8 INV1S $PINS O=n15 I=B[5]
XU9 INV1S $PINS O=n18 I=B[8]
XU10 INV1S $PINS O=n17 I=B[7]
XU11 INV1S $PINS O=n10 I=B[9]
XU12 INV1S $PINS O=n7 I=B[15]
XU13 INV1S $PINS O=n6 I=B[14]
XU14 INV1S $PINS O=n16 I=B[6]
XU15 INV1S $PINS O=n11 I=B[1]
XU16 INV1S $PINS O=n1 I=A[0]
XU17 INV1S $PINS O=n13 I=B[3]
XU18 INV1S $PINS O=n12 I=B[2]
XU19 XNR2HS $PINS O=DIFF[0] I1=n2 I2=A[0]
XU20 ND2 $PINS O=carry[1] I1=B[0] I2=n1
.ENDS

.SUBCKT cordic_rotation_0_DW01_add_3 A[17] A[16] A[15] A[14] A[13] A[12] A[11]
+ A[10] A[9] A[8] A[7] A[6] A[5] A[4] A[3] A[2] A[1] A[0] B[17] B[16] B[15]
+ B[14] B[13] B[12] B[11] B[10] B[9] B[8] B[7] B[6] B[5] B[4] B[3] B[2] B[1]
+ B[0] CI SUM[17] SUM[16] SUM[15] SUM[14] SUM[13] SUM[12] SUM[11] SUM[10]
+ SUM[9] SUM[8] SUM[7] SUM[6] SUM[5] SUM[4] SUM[3] SUM[2] SUM[1] SUM[0] CO
XU1_14 FA1S $PINS S=SUM[14] CO=carry[15] A=A[14] B=B[14] CI=carry[14]
XU1_1 FA1S $PINS S=SUM[1] CO=carry[2] A=A[1] B=B[1] CI=n1
XU1_9 FA1 $PINS S=SUM[9] CO=carry[10] A=A[9] B=B[9] CI=carry[9]
XU1_6 FA1 $PINS S=SUM[6] CO=carry[7] A=A[6] B=B[6] CI=carry[6]
XU1_5 FA1S $PINS S=SUM[5] CO=carry[6] A=A[5] B=B[5] CI=carry[5]
XU1_4 FA1 $PINS S=SUM[4] CO=carry[5] A=A[4] B=B[4] CI=carry[4]
XU1_3 FA1 $PINS S=SUM[3] CO=carry[4] A=A[3] B=B[3] CI=carry[3]
XU1_8 FA1S $PINS S=SUM[8] CO=carry[9] A=A[8] B=B[8] CI=carry[8]
XU1_7 FA1 $PINS S=SUM[7] CO=carry[8] A=A[7] B=B[7] CI=carry[7]
XU1_2 FA1 $PINS S=SUM[2] CO=carry[3] A=A[2] B=B[2] CI=carry[2]
XU1_11 FA1S $PINS S=SUM[11] CO=carry[12] A=A[11] B=B[11] CI=carry[11]
XU1_12 FA1S $PINS S=SUM[12] CO=carry[13] A=A[12] B=B[12] CI=carry[12]
XU1_10 FA1 $PINS S=SUM[10] CO=carry[11] A=A[10] B=B[10] CI=carry[10]
XU1_13 FA1 $PINS S=SUM[13] CO=carry[14] A=A[13] B=B[13] CI=carry[13]
XU1_15 FA1 $PINS S=SUM[15] CO=carry[16] A=A[15] B=B[15] CI=carry[15]
XU1_16 FA1S $PINS S=SUM[16] CO=carry[17] A=A[16] B=B[16] CI=carry[16]
XU1_17 XOR3S $PINS O=SUM[17] I1=A[17] I2=B[17] I3=carry[17]
XU1 AN2 $PINS O=n1 I1=B[0] I2=A[0]
XU2 XOR2HS $PINS O=SUM[0] I1=B[0] I2=A[0]
.ENDS

.SUBCKT cordic_rotation_0_DW01_sub_1_DW01_sub_29 A[15] A[14] A[13] A[12] A[11]
+ A[10] A[9] A[8] A[7] A[6] A[5] A[4] A[3] A[2] A[1] A[0] B[15] B[14] B[13]
+ B[12] B[11] B[10] B[9] B[8] B[7] B[6] B[5] B[4] B[3] B[2] B[1] B[0] CI
+ DIFF[15] DIFF[14] DIFF[13] DIFF[12] DIFF[11] DIFF[10] DIFF[9] DIFF[8] DIFF[7]
+ DIFF[6] DIFF[5] DIFF[4] DIFF[3] DIFF[2] DIFF[1] DIFF[0] CO n73 n262 p1
XU2_12 FA1S $PINS S=DIFF[12] CO=carry[13] A=A[12] B=n73 CI=carry[12]
XU2_11 FA1S $PINS S=DIFF[11] CO=carry[12] A=A[11] B=n2 CI=carry[11]
XU2_10 FA1S $PINS S=DIFF[10] CO=carry[11] A=A[10] B=n262 CI=carry[10]
XU2_9 FA1S $PINS S=DIFF[9] CO=carry[10] A=A[9] B=n11 CI=carry[9]
XU2_8 FA1S $PINS S=DIFF[8] CO=carry[9] A=A[8] B=n14 CI=carry[8]
XU2_7 FA1S $PINS S=DIFF[7] CO=carry[8] A=A[7] B=n8 CI=carry[7]
XU2_6 FA1S $PINS S=DIFF[6] CO=carry[7] A=A[6] B=n15 CI=carry[6]
XU2_5 FA1S $PINS S=DIFF[5] CO=carry[6] A=A[5] B=n9 CI=carry[5]
XU2_4 FA1S $PINS S=DIFF[4] CO=carry[5] A=A[4] B=n6 CI=carry[4]
XU2_3 FA1S $PINS S=DIFF[3] CO=carry[4] A=A[3] B=n12 CI=carry[3]
XU2_2 FA1S $PINS S=DIFF[2] CO=carry[3] A=A[2] B=n5 CI=carry[2]
XU2_1 FA1S $PINS S=DIFF[1] CO=carry[2] A=A[1] B=n7 CI=carry[1]
XU2_13 FA1S $PINS S=DIFF[13] CO=carry[14] A=A[13] B=B[13] CI=carry[13]
XU1 OR2 $PINS O=carry[15] I1=carry[14] I2=A[14]
XU2 INV1S $PINS O=n10 I=B[0]
XU4 XNR2HS $PINS O=DIFF[15] I1=A[15] I2=carry[15]
XU5 INV1S $PINS O=n7 I=B[1]
XU6 INV1S $PINS O=n1 I=A[0]
XU7 INV1S $PINS O=n5 I=B[2]
XU8 INV1S $PINS O=n12 I=B[3]
XU9 INV1S $PINS O=n6 I=B[4]
XU10 INV1S $PINS O=n9 I=B[5]
XU11 INV1S $PINS O=n15 I=B[6]
XU12 INV1S $PINS O=n8 I=B[7]
XU13 INV1S $PINS O=n14 I=B[8]
XU14 INV1S $PINS O=n11 I=B[9]
XU16 INV1S $PINS O=n2 I=B[11]
XU18 XNR2HS $PINS O=DIFF[14] I1=A[14] I2=carry[14]
XU19 XNR2HS $PINS O=DIFF[0] I1=n10 I2=p1
XU20 ND2 $PINS O=carry[1] I1=B[0] I2=n1
.ENDS

.SUBCKT cordic_rotation_0_DW01_add_4 A[17] A[16] A[15] A[14] A[13] A[12] A[11]
+ A[10] A[9] A[8] A[7] A[6] A[5] A[4] A[3] A[2] A[1] A[0] B[17] B[16] B[15]
+ B[14] B[13] B[12] B[11] B[10] B[9] B[8] B[7] B[6] B[5] B[4] B[3] B[2] B[1]
+ B[0] CI SUM[17] SUM[16] SUM[15] SUM[14] SUM[13] SUM[12] SUM[11] SUM[10]
+ SUM[9] SUM[8] SUM[7] SUM[6] SUM[5] SUM[4] SUM[3] SUM[2] SUM[1] SUM[0] CO
XFE_PHC1519_y_reg_16 BUF3 $PINS O=FE_PHN1519_y_reg_16 I=A[16]
XU1_14 FA1S $PINS S=SUM[14] CO=carry[15] A=A[14] B=B[14] CI=carry[14]
XU1_1 FA1S $PINS S=SUM[1] CO=carry[2] A=A[1] B=B[1] CI=n1
XU1_9 FA1 $PINS S=SUM[9] CO=carry[10] A=A[9] B=B[9] CI=carry[9]
XU1_6 FA1 $PINS S=SUM[6] CO=carry[7] A=A[6] B=B[6] CI=carry[6]
XU1_5 FA1 $PINS S=SUM[5] CO=carry[6] A=A[5] B=B[5] CI=carry[5]
XU1_4 FA1 $PINS S=SUM[4] CO=carry[5] A=A[4] B=B[4] CI=carry[4]
XU1_3 FA1S $PINS S=SUM[3] CO=carry[4] A=A[3] B=B[3] CI=carry[3]
XU1_8 FA1 $PINS S=SUM[8] CO=carry[9] A=A[8] B=B[8] CI=carry[8]
XU1_7 FA1 $PINS S=SUM[7] CO=carry[8] A=A[7] B=B[7] CI=carry[7]
XU1_2 FA1 $PINS S=SUM[2] CO=carry[3] A=A[2] B=B[2] CI=carry[2]
XU1_11 FA1S $PINS S=SUM[11] CO=carry[12] A=A[11] B=B[11] CI=carry[11]
XU1_12 FA1 $PINS S=SUM[12] CO=carry[13] A=A[12] B=B[12] CI=carry[12]
XU1_10 FA1S $PINS S=SUM[10] CO=carry[11] A=A[10] B=B[10] CI=carry[10]
XU1_13 FA1S $PINS S=SUM[13] CO=carry[14] A=A[13] B=B[13] CI=carry[13]
XU1_15 FA1 $PINS S=SUM[15] CO=carry[16] A=A[15] B=B[15] CI=carry[15]
XU1_16 FA1S $PINS S=SUM[16] CO=carry[17] A=FE_PHN1519_y_reg_16 B=B[16]
+ CI=carry[16]
XU1_17 XOR3S $PINS O=SUM[17] I1=A[17] I2=B[17] I3=carry[17]
XU1 AN2 $PINS O=n1 I1=B[0] I2=A[0]
XU2 XOR2HS $PINS O=SUM[0] I1=B[0] I2=A[0]
.ENDS

.SUBCKT cordic_rotation_0_DW01_sub_2_DW01_sub_30 A[17] A[16] A[15] A[14] A[13]
+ A[12] A[11] A[10] A[9] A[8] A[7] A[6] A[5] A[4] A[3] A[2] A[1] A[0] B[17]
+ B[16] B[15] B[14] B[13] B[12] B[11] B[10] B[9] B[8] B[7] B[6] B[5] B[4] B[3]
+ B[2] B[1] B[0] CI DIFF[17] DIFF[16] DIFF[15] DIFF[14] DIFF[13] DIFF[12]
+ DIFF[11] DIFF[10] DIFF[9] DIFF[8] DIFF[7] DIFF[6] DIFF[5] DIFF[4] DIFF[3]
+ DIFF[2] DIFF[1] DIFF[0] CO
XFE_PHC1435_N272 DELA $PINS O=DIFF[2] I=FE_PHN1435_N272
XU2_2 FA1S $PINS S=FE_PHN1435_N272 CO=carry[3] A=A[2] B=n12 CI=carry[2]
XU2_3 FA1 $PINS S=DIFF[3] CO=carry[4] A=A[3] B=n13 CI=carry[3]
XU2_1 FA1S $PINS S=DIFF[1] CO=carry[2] A=A[1] B=n11 CI=carry[1]
XU2_14 FA1 $PINS S=DIFF[14] CO=carry[15] A=A[14] B=n4 CI=carry[14]
XU2_6 FA1 $PINS S=DIFF[6] CO=carry[7] A=A[6] B=n16 CI=carry[6]
XU2_15 FA1 $PINS S=DIFF[15] CO=carry[16] A=A[15] B=n3 CI=carry[15]
XU2_16 FA1S $PINS S=DIFF[16] CO=carry[17] A=A[16] B=n2 CI=carry[16]
XU2_9 FA1S $PINS S=DIFF[9] CO=carry[10] A=A[9] B=n9 CI=carry[9]
XU2_7 FA1S $PINS S=DIFF[7] CO=carry[8] A=A[7] B=n17 CI=carry[7]
XU2_8 FA1 $PINS S=DIFF[8] CO=carry[9] A=A[8] B=n18 CI=carry[8]
XU2_5 FA1S $PINS S=DIFF[5] CO=carry[6] A=A[5] B=n15 CI=carry[5]
XU2_4 FA1 $PINS S=DIFF[4] CO=carry[5] A=A[4] B=n14 CI=carry[4]
XU2_11 FA1 $PINS S=DIFF[11] CO=carry[12] A=A[11] B=n7 CI=carry[11]
XU2_12 FA1 $PINS S=DIFF[12] CO=carry[13] A=A[12] B=n6 CI=carry[12]
XU2_10 FA1 $PINS S=DIFF[10] CO=carry[11] A=A[10] B=n8 CI=carry[10]
XU2_13 FA1S $PINS S=DIFF[13] CO=carry[14] A=A[13] B=n5 CI=carry[13]
XU2_17 XOR3S $PINS O=DIFF[17] I1=A[17] I2=n2 I3=carry[17]
XU1 INV1S $PINS O=n10 I=B[0]
XU2 INV1S $PINS O=n2 I=B[17]
XU3 INV1S $PINS O=n5 I=B[13]
XU4 INV1S $PINS O=n8 I=B[10]
XU5 INV1S $PINS O=n6 I=B[12]
XU6 INV1S $PINS O=n7 I=B[11]
XU7 INV1S $PINS O=n14 I=B[4]
XU8 INV1S $PINS O=n15 I=B[5]
XU9 INV1S $PINS O=n18 I=B[8]
XU10 INV1S $PINS O=n17 I=B[7]
XU11 INV1S $PINS O=n9 I=B[9]
XU12 INV1S $PINS O=n3 I=B[15]
XU13 INV1S $PINS O=n16 I=B[6]
XU14 INV1S $PINS O=n4 I=B[14]
XU15 INV1S $PINS O=n11 I=B[1]
XU16 INV1S $PINS O=n1 I=A[0]
XU17 INV1S $PINS O=n13 I=B[3]
XU18 INV1S $PINS O=n12 I=B[2]
XU19 XNR2HS $PINS O=DIFF[0] I1=n10 I2=A[0]
XU20 ND2 $PINS O=carry[1] I1=B[0] I2=n1
.ENDS

.SUBCKT cordic_rotation_0 valid_in valid_out x_in[16] x_in[15] x_in[14]
+ x_in[13] x_in[12] x_in[11] x_in[10] x_in[9] x_in[8] x_in[7] x_in[6] x_in[5]
+ x_in[4] x_in[3] x_in[2] x_in[1] x_in[0] y_in[16] y_in[15] y_in[14] y_in[13]
+ y_in[12] y_in[11] y_in[10] y_in[9] y_in[8] y_in[7] y_in[6] y_in[5] y_in[4]
+ y_in[3] y_in[2] y_in[1] y_in[0] phase_in[15] phase_in[14] phase_in[13]
+ phase_in[12] phase_in[11] phase_in[10] phase_in[9] phase_in[8] phase_in[7]
+ phase_in[6] phase_in[5] phase_in[4] phase_in[3] phase_in[2] phase_in[1]
+ phase_in[0] x_out[16] x_out[15] x_out[14] x_out[13] x_out[12] x_out[11]
+ x_out[10] x_out[9] x_out[8] x_out[7] x_out[6] x_out[5] x_out[4] x_out[3]
+ x_out[2] x_out[1] x_out[0] y_out[16] y_out[15] y_out[14] y_out[13] y_out[12]
+ y_out[11] y_out[10] y_out[9] y_out[8] y_out[7] y_out[6] y_out[5] y_out[4]
+ y_out[3] y_out[2] y_out[1] y_out[0] rst_n i_rst_n p1 FE_OFN18_i_rst_n
+ FE_OFN2_i_rst_n FE_OFN32_n clk clk_clone3 clk_clone2 clk_clone1
*.CONNECT N130 x_in[0]
*.CONNECT N148 y_in[0]
*.CONNECT N176 phase_in[8]
*.CONNECT N177 phase_in[9]
*.CONNECT N178 phase_in[10]
*.CONNECT N179 phase_in[11]
*.CONNECT N180 phase_in[12]
*.CONNECT N181 phase_in[13]
*.CONNECT N182 phase_in[14]
XFE_PHC1540_n319 BUF1CK $PINS O=FE_PHN1540_n319 I=n319
XFE_PHC1539_n323 BUF1CK $PINS O=FE_PHN1539_n323 I=n323
XFE_PHC1538_n286 BUF1CK $PINS O=n286 I=FE_PHN1538_n286
XFE_PHC1537_n274 BUF1CK $PINS O=FE_PHN1537_n274 I=n274
XFE_PHC1535_N441 BUF4 $PINS O=FE_PHN1535_N441 I=N441
XFE_PHC1527_y_reg_6 BUF1S $PINS O=y_reg[6] I=FE_PHN1527_y_reg_6
XFE_PHC1524_y_reg_9 BUF1S $PINS O=FE_PHN1524_y_reg_9 I=y_reg[9]
XFE_PHC1523_y_reg_11 BUF1S $PINS O=y_reg[11] I=FE_PHN1523_y_reg_11
XFE_PHC1514_z_reg_12 BUF1CK $PINS O=FE_PHN1514_z_reg_12 I=z_reg[12]
XFE_PHC1507_n289 BUF1CK $PINS O=FE_PHN1507_n289 I=n289
XFE_PHC1492_c_in_i_1_8 BUF1CK $PINS O=FE_PHN1492_c_in_i_1_8 I=y_in[8]
XFE_PHC1490_N480 DELA $PINS O=FE_PHN1490_N480 I=N480
XFE_PHC1489_N481 DELA $PINS O=FE_PHN1489_N481 I=N481
XFE_PHC1488_n379 DELA $PINS O=FE_PHN1488_n379 I=n379
XFE_PHC1482_N514 DELB $PINS O=N514 I=FE_PHN1482_N514
XFE_PHC1474_N497 DELB $PINS O=N497 I=FE_PHN1474_N497
XFE_PHC1473_N479 DELB $PINS O=FE_PHN1473_N479 I=N479
XFE_PHC1445_n334 DELA $PINS O=FE_PHN1445_n334 I=n334
XFE_PHC1442_n294 DELA $PINS O=n294 I=FE_PHN1442_n294
XFE_PHC1434_n384 DELA $PINS O=FE_PHN1434_n384 I=n384
XFE_PHC1433_n380 DELA $PINS O=n380 I=FE_PHN1433_n380
XFE_PHC1432_n381 DELA $PINS O=n381 I=FE_PHN1432_n381
XFE_PHC1429_n382 DELA $PINS O=n382 I=FE_PHN1429_n382
XFE_PHC1427_N365 DELA $PINS O=FE_PHN1427_N365 I=N365
XFE_PHC1426_n385 DELA $PINS O=FE_PHN1426_n385 I=n385
XFE_PHC1425_n353 DELA $PINS O=FE_PHN1425_n353 I=n353
XFE_PHC1423_n383 DELA $PINS O=n383 I=FE_PHN1423_n383
XFE_PHC1418_n339 DELB $PINS O=FE_PHN1418_n339 I=n339
XFE_PHC1416_N459 DELB $PINS O=FE_PHN1416_N459 I=N459
XFE_PHC1412_N490 DELB $PINS O=N490 I=FE_PHN1412_N490
XFE_PHC1410_N461 DELB $PINS O=N461 I=FE_PHN1410_N461
XFE_PHC1409_n315 DELB $PINS O=FE_PHN1409_n315 I=n315
XFE_PHC1408_n296 BUF1S $PINS O=FE_PHN1408_n296 I=n296
XFE_PHC1406_N457 DELB $PINS O=FE_PHN1406_N457 I=N457
XFE_PHC1386_N437 DELB $PINS O=FE_PHN1386_N437 I=N437
XFE_PHC1374_N498 BUF1S $PINS O=FE_PHN1374_N498 I=N498
XFE_PHC1367_N436 DELB $PINS O=FE_PHN1367_N436 I=N436
XFE_PHC1366_N435 DELB $PINS O=FE_PHN1366_N435 I=N435
XFE_PHC1358_n300 DELB $PINS O=FE_PHN1358_n300 I=n300
XFE_PHC1355_n336 DELB $PINS O=FE_PHN1355_n336 I=n336
XFE_PHC1350_N434 DELB $PINS O=FE_PHN1350_N434 I=N434
XFE_PHC1347_N429 DELB $PINS O=FE_PHN1347_N429 I=N429
XFE_PHC1346_N428 DELB $PINS O=N428 I=FE_PHN1346_N428
XFE_PHC1341_N432 DELB $PINS O=N432 I=FE_PHN1341_N432
XFE_PHC1340_N433 DELB $PINS O=FE_PHN1340_N433 I=N433
XFE_PHC1329_N438 DELB $PINS O=FE_PHN1329_N438 I=N438
XFE_PHC1322_N451 DELB $PINS O=FE_PHN1322_N451 I=N451
XFE_PHC1308_N431 DELB $PINS O=FE_PHN1308_N431 I=N431
XFE_PHC1306_N427 DELB $PINS O=FE_PHN1306_N427 I=N427
XFE_PHC1270_N460 DELC $PINS O=N460 I=FE_PHN1270_N460
XFE_PHC1259_step_cnt_1 BUF1S $PINS O=step_cnt[1] I=FE_PHN1259_step_cnt_1
XFE_PHC1247_y_reg_9 BUF1S $PINS O=FE_PHN1247_y_reg_9 I=FE_PHN1524_y_reg_9
XFE_PHC1245_y_reg_11 BUF1S $PINS O=FE_PHN1245_y_reg_11 I=y_reg[11]
XFE_PHC1243_y_reg_8 DELB $PINS O=FE_PHN1243_y_reg_8 I=y_reg[8]
XFE_PHC1242_y_reg_10 DELB $PINS O=FE_PHN1242_y_reg_10 I=y_reg[10]
XFE_PHC1237_y_reg_6 BUF1S $PINS O=FE_PHN1237_y_reg_6 I=y_reg[6]
XFE_PHC1235_y_reg_12 DELB $PINS O=FE_PHN1235_y_reg_12 I=y_reg[12]
XFE_PHC1234_y_reg_14 DELB $PINS O=y_reg[14] I=FE_PHN1234_y_reg_14
XFE_PHC1232_x_reg_13 DELB $PINS O=x_reg[13] I=FE_PHN1232_x_reg_13
XFE_PHC1230_x_reg_12 DELB $PINS O=FE_PHN1230_x_reg_12 I=x_reg[12]
XFE_PHC1226_x_reg_9 DELB $PINS O=x_reg[9] I=FE_PHN1226_x_reg_9
XFE_PHC1225_x_reg_8 DELB $PINS O=x_reg[8] I=FE_PHN1225_x_reg_8
XFE_PHC1220_x_reg_7 DELB $PINS O=FE_PHN1220_x_reg_7 I=x_reg[7]
XFE_PHC1216_y_reg_4 DELB $PINS O=FE_PHN1216_y_reg_4 I=y_reg[4]
XFE_PHC1215_x_reg_5 DELB $PINS O=x_reg[5] I=FE_PHN1215_x_reg_5
XFE_PHC1191_y_reg_7 BUF1S $PINS O=FE_PHN1191_y_reg_7 I=y_reg[7]
XFE_PHC1176_z_reg_9 DELA $PINS O=FE_PHN1176_z_reg_9 I=z_reg[9]
XFE_PHC1172_cor_x_out_1_4 BUF1CK $PINS O=x_out[4] I=FE_PHN1172_cor_x_out_1_4
XFE_PHC1168_y_reg_5 DELB $PINS O=FE_PHN1168_y_reg_5 I=y_reg[5]
XFE_PHC1167_z_reg_0 DELB $PINS O=FE_PHN1167_z_reg_0 I=z_reg[0]
XFE_PHC1165_z_reg_10 DELA $PINS O=FE_PHN1165_z_reg_10 I=z_reg[10]
XFE_PHC1160_cor_x_out_1_3 BUF1CK $PINS O=x_out[3] I=FE_PHN1160_cor_x_out_1_3
XFE_PHC1159_y_reg_13 DELB $PINS O=FE_PHN1159_y_reg_13 I=y_reg[13]
XFE_PHC1149_z_reg_8 BUF1S $PINS O=FE_PHN1149_z_reg_8 I=z_reg[8]
XFE_PHC1147_z_reg_12 BUF1S $PINS O=FE_PHN1147_z_reg_12 I=FE_PHN1514_z_reg_12
XFE_PHC1139_y_reg_16 DELB $PINS O=FE_PHN1139_y_reg_16 I=y_reg[16]
XFE_PHC1127_cor_x_out_1_0 BUF1CK $PINS O=x_out[0] I=FE_PHN1127_cor_x_out_1_0
XFE_PHC1119_cor_x_out_1_5 BUF1CK $PINS O=x_out[5] I=FE_PHN1119_cor_x_out_1_5
XFE_PHC1113_cor_x_out_1_8 BUF1S $PINS O=x_out[8] I=FE_PHN1113_cor_x_out_1_8
XFE_PHC1111_y_reg_15 DELB $PINS O=FE_PHN1111_y_reg_15 I=y_reg[15]
XFE_PHC1095_c_in_i_1_5 BUF1S $PINS O=FE_PHN1095_c_in_i_1_5 I=y_in[5]
XFE_PHC1081_c_in_i_1_3 BUF3 $PINS O=FE_PHN1081_c_in_i_1_3 I=y_in[3]
XFE_PHC1076_c_in_i_1_4 BUF1CK $PINS O=FE_PHN1076_c_in_i_1_4 I=y_in[4]
XFE_PHC1067_n372 DELB $PINS O=FE_PHN1067_n372 I=n372
XFE_PHC1066_z_reg_13 DELA $PINS O=FE_PHN1066_z_reg_13 I=z_reg[13]
XFE_PHC1059_cor_y_out_1_14 BUF1S $PINS O=y_out[14] I=FE_PHN1059_cor_y_out_1_14
XFE_PHC1049_x_reg_4 DELC $PINS O=FE_PHN1049_x_reg_4 I=x_reg[4]
XFE_PHC994_z_reg_14 DELB $PINS O=FE_PHN994_z_reg_14 I=z_reg[14]
XCTS_ccl_a_INV_CLK_G1_L8_93 INV4CK $PINS O=CTS_65 I=CTS_66
XCTS_ccl_a_INV_CLK_G1_L7_95 INV2CK $PINS O=CTS_66 I=CTS_67
XCTS_ccl_a_INV_CLK_G1_L8_92 INV4CK $PINS O=CTS_62 I=CTS_63
XCTS_ccl_a_INV_CLK_G1_L7_94 INV2CK $PINS O=CTS_63 I=CTS_64
XCTS_ccl_a_INV_CLK_G1_L8_81 INV1CK $PINS O=CTS_59 I=CTS_60
XCTS_ccl_a_INV_CLK_G1_L8_80 INV1CK $PINS O=CTS_58 I=CTS_60
XCTS_ccl_INV_CLK_G1_L7_83 INV2CK $PINS O=CTS_60 I=CTS_61
XCTS_ccl_a_INV_CLK_G1_L8_39 INV6CK $PINS O=CTS_55 I=CTS_56
XCTS_ccl_a_INV_CLK_G1_L7_41 INV3CK $PINS O=CTS_56 I=CTS_57
XCTS_ccl_a_INV_CLK_G1_L8_38 INV6CK $PINS O=CTS_52 I=CTS_53
XCTS_ccl_a_INV_CLK_G1_L7_40 INV4CK $PINS O=CTS_53 I=CTS_54
XFE_OFC531_step_cnt_0 INV2 $PINS O=n373 I=step_cnt[0]
XFE_OFC489_n104 BUF1 $PINS O=FE_OFN306_n104 I=n104
XFE_OFC464_n73 BUF1 $PINS O=FE_OFN281_n73 I=FE_OFN280_n73
XFE_OFC463_n73 BUF1 $PINS O=FE_OFN280_n73 I=n73
XFE_OFC433_y_reg_8 INV1S $PINS O=FE_OFN251_y_reg_8 I=FE_PHN1243_y_reg_8
XFE_OFC415_n262 INV1S $PINS O=FE_OFN242_n262 I=N108
XFE_OFC411_n262 INV1S $PINS O=N108 I=n262
XFE_OFC401_x_reg_6 INV1S $PINS O=n203 I=x_reg[6]
XFE_OFC382_x_reg_8 INV1S $PINS O=n188 I=x_reg[8]
XFE_OFC377_x_reg_9 INV1S $PINS O=n187 I=x_reg[9]
XFE_OFC369_n159 INV1S $PINS O=FE_OFN221_n159 I=n80
XFE_OFC368_n159 INV2 $PINS O=n80 I=n159
XFE_OFC365_y_reg_9 INV1S $PINS O=n89 I=FE_PHN1247_y_reg_9
XFE_OFC308_x_reg_7 INV1S $PINS O=n196 I=FE_PHN1220_x_reg_7
XFE_OFC294_y_reg_7 INV1S $PINS O=n101 I=y_reg[7]
XFE_OFC286_x_reg_12 INV1S $PINS O=n189 I=FE_PHN1230_x_reg_12
XFE_OFC282_x_reg_11 INV1S $PINS O=n197 I=x_reg[11]
XFE_OFC271_y_reg_11 INV1S $PINS O=n102 I=FE_PHN1245_y_reg_11
XFE_OFC270_x_reg_10 INV1S $PINS O=n177 I=x_reg[10]
XFE_OFC263_y_reg_10 INV1S $PINS O=n74 I=FE_PHN1242_y_reg_10
XFE_OFC241_n75 INV2 $PINS O=FE_OFN173_n75 I=n142
XFE_OFC240_n75 INV1S $PINS O=n142 I=n75
XFE_OFC166_n73 INV2 $PINS O=n7 I=n73
XFE_DBTC13_n1 INV2 $PINS O=FE_DBTN13_n1 I=n1
Xx_out_reg[5] QDFFRBN $PINS Q=FE_PHN1119_cor_x_out_1_5 D=FE_PHN1308_N431
+ CK=CTS_62 RB=i_rst_n
Xx_out_reg[6] QDFFRBN $PINS Q=x_out[6] D=N432 CK=CTS_62 RB=i_rst_n
Xx_out_reg[7] QDFFRBN $PINS Q=x_out[7] D=FE_PHN1340_N433 CK=CTS_62 RB=i_rst_n
Xx_out_reg[8] QDFFRBN $PINS Q=FE_PHN1113_cor_x_out_1_8 D=FE_PHN1350_N434
+ CK=CTS_62 RB=i_rst_n
Xx_out_reg[9] QDFFRBN $PINS Q=x_out[9] D=FE_PHN1366_N435 CK=CTS_62 RB=i_rst_n
Xy_out_reg[0] QDFFRBN $PINS Q=y_out[0] D=N439 CK=CTS_65 RB=i_rst_n
Xy_out_reg[1] QDFFRBN $PINS Q=y_out[1] D=N440 CK=CTS_65 RB=i_rst_n
Xy_out_reg[2] QDFFRBN $PINS Q=y_out[2] D=FE_PHN1535_N441 CK=CTS_65 RB=i_rst_n
Xy_out_reg[3] QDFFRBN $PINS Q=y_out[3] D=N442 CK=CTS_65 RB=i_rst_n
Xy_out_reg[4] QDFFRBN $PINS Q=y_out[4] D=N443 CK=CTS_65 RB=i_rst_n
Xy_out_reg[5] QDFFRBN $PINS Q=y_out[5] D=N444 CK=CTS_65 RB=i_rst_n
Xy_out_reg[6] QDFFRBN $PINS Q=y_out[6] D=N445 CK=CTS_65 RB=FE_OFN32_n
Xy_out_reg[7] QDFFRBN $PINS Q=y_out[7] D=N446 CK=CTS_65 RB=i_rst_n
Xy_out_reg[8] QDFFRBN $PINS Q=y_out[8] D=N447 CK=CTS_65 RB=i_rst_n
Xy_out_reg[9] QDFFRBN $PINS Q=y_out[9] D=N448 CK=CTS_65 RB=i_rst_n
Xy_out_reg[10] QDFFRBN $PINS Q=y_out[10] D=N449 CK=CTS_65 RB=i_rst_n
Xy_out_reg[11] QDFFRBN $PINS Q=y_out[11] D=N450 CK=CTS_65 RB=i_rst_n
Xy_out_reg[12] QDFFRBN $PINS Q=y_out[12] D=FE_PHN1322_N451 CK=CTS_65 RB=i_rst_n
Xy_out_reg[13] QDFFRBN $PINS Q=y_out[13] D=FE_PHN1322_N451 CK=CTS_65 RB=i_rst_n
Xy_out_reg[14] QDFFRBN $PINS Q=FE_PHN1059_cor_y_out_1_14 D=FE_PHN1322_N451
+ CK=CTS_65 RB=i_rst_n
Xy_out_reg[15] QDFFRBN $PINS Q=y_out[15] D=FE_PHN1322_N451 CK=CTS_65 RB=i_rst_n
Xy_out_reg[16] QDFFRBN $PINS Q=y_out[16] D=FE_PHN1322_N451 CK=CTS_65 RB=i_rst_n
Xx_out_reg[0] QDFFRBN $PINS Q=FE_PHN1127_cor_x_out_1_0 D=N426 CK=CTS_62
+ RB=i_rst_n
Xx_out_reg[1] QDFFRBN $PINS Q=x_out[1] D=FE_PHN1306_N427 CK=CTS_62 RB=i_rst_n
Xx_out_reg[2] QDFFRBN $PINS Q=x_out[2] D=N428 CK=CTS_62 RB=i_rst_n
Xx_out_reg[3] QDFFRBN $PINS Q=FE_PHN1160_cor_x_out_1_3 D=FE_PHN1347_N429
+ CK=CTS_62 RB=i_rst_n
Xx_out_reg[4] QDFFRBN $PINS Q=FE_PHN1172_cor_x_out_1_4 D=N430 CK=CTS_62
+ RB=i_rst_n
Xx_out_reg[10] QDFFRBN $PINS Q=x_out[10] D=FE_PHN1367_N436 CK=CTS_62 RB=i_rst_n
Xx_out_reg[11] QDFFRBN $PINS Q=x_out[11] D=FE_PHN1386_N437 CK=CTS_62 RB=i_rst_n
Xx_out_reg[12] QDFFRBN $PINS Q=x_out[12] D=FE_PHN1329_N438 CK=CTS_62
+ RB=FE_OFN32_n
Xx_out_reg[13] QDFFRBN $PINS Q=x_out[13] D=FE_PHN1329_N438 CK=CTS_62
+ RB=FE_OFN32_n
Xx_out_reg[14] QDFFRBN $PINS Q=x_out[14] D=FE_PHN1329_N438 CK=CTS_62
+ RB=FE_OFN32_n
Xx_out_reg[15] QDFFRBN $PINS Q=x_out[15] D=FE_PHN1329_N438 CK=CTS_62
+ RB=FE_OFN32_n
Xx_out_reg[16] QDFFRBN $PINS Q=x_out[16] D=FE_PHN1329_N438 CK=CTS_62
+ RB=FE_OFN32_n
Xz_reg_reg[14] QDFFRBN $PINS Q=z_reg[14] D=N477 CK=CTS_55 RB=FE_OFN2_i_rst_n
Xz_reg_reg[15] QDFFRBN $PINS Q=z_reg[15] D=N478 CK=CTS_55 RB=FE_OFN2_i_rst_n
Xz_reg_reg[13] QDFFRBN $PINS Q=z_reg[13] D=N476 CK=CTS_55 RB=FE_OFN2_i_rst_n
Xz_reg_reg[12] QDFFRBN $PINS Q=z_reg[12] D=N475 CK=CTS_55 RB=FE_OFN2_i_rst_n
Xz_reg_reg[11] QDFFRBN $PINS Q=z_reg[11] D=N474 CK=CTS_55 RB=FE_OFN2_i_rst_n
Xz_reg_reg[10] QDFFRBN $PINS Q=z_reg[10] D=N473 CK=CTS_55 RB=FE_OFN2_i_rst_n
Xz_reg_reg[9] QDFFRBN $PINS Q=z_reg[9] D=N472 CK=CTS_55 RB=FE_OFN2_i_rst_n
Xz_reg_reg[8] QDFFRBN $PINS Q=z_reg[8] D=N471 CK=CTS_55 RB=FE_OFN2_i_rst_n
Xz_reg_reg[7] QDFFRBN $PINS Q=z_reg[7] D=FE_PHN1488_n379 CK=CTS_55
+ RB=FE_OFN2_i_rst_n
Xz_reg_reg[6] QDFFRBN $PINS Q=z_reg[6] D=n380 CK=CTS_52 RB=FE_OFN2_i_rst_n
Xz_reg_reg[5] QDFFRBN $PINS Q=z_reg[5] D=n381 CK=CTS_52 RB=FE_OFN2_i_rst_n
Xz_reg_reg[4] QDFFRBN $PINS Q=z_reg[4] D=n382 CK=CTS_52 RB=FE_OFN2_i_rst_n
Xz_reg_reg[3] QDFFRBN $PINS Q=z_reg[3] D=n383 CK=CTS_52 RB=FE_OFN2_i_rst_n
Xz_reg_reg[2] QDFFRBN $PINS Q=z_reg[2] D=FE_PHN1434_n384 CK=CTS_52
+ RB=FE_OFN2_i_rst_n
Xy_reg_reg[17] QDFFRBN $PINS Q=y_reg[17] D=N514 CK=CTS_55 RB=i_rst_n
Xx_reg_reg[17] QDFFRBN $PINS Q=x_reg[17] D=N496 CK=CTS_52 RB=i_rst_n
Xz_reg_reg[1] QDFFRBN $PINS Q=z_reg[1] D=FE_PHN1426_n385 CK=CTS_52
+ RB=FE_OFN2_i_rst_n
Xx_reg_reg[16] QDFFRBN $PINS Q=x_reg[16] D=N495 CK=CTS_52 RB=i_rst_n
Xy_reg_reg[16] QDFFRBN $PINS Q=y_reg[16] D=N513 CK=CTS_55 RB=i_rst_n
Xz_reg_reg[0] QDFFRBN $PINS Q=z_reg[0] D=n386 CK=CTS_52 RB=FE_OFN2_i_rst_n
Xx_reg_reg[15] QDFFRBN $PINS Q=x_reg[15] D=N494 CK=CTS_52 RB=i_rst_n
Xy_reg_reg[15] QDFFRBN $PINS Q=y_reg[15] D=N512 CK=CTS_55 RB=i_rst_n
Xx_reg_reg[14] QDFFRBN $PINS Q=x_reg[14] D=N493 CK=CTS_52 RB=i_rst_n
Xy_reg_reg[14] QDFFRBN $PINS Q=FE_PHN1234_y_reg_14 D=N511 CK=CTS_55 RB=i_rst_n
Xy_reg_reg[13] QDFFRBN $PINS Q=y_reg[13] D=N510 CK=CTS_55 RB=i_rst_n
Xx_reg_reg[13] QDFFRBN $PINS Q=FE_PHN1232_x_reg_13 D=N492 CK=CTS_52 RB=i_rst_n
Xy_reg_reg[12] QDFFRBN $PINS Q=y_reg[12] D=N509 CK=CTS_55 RB=i_rst_n
Xx_reg_reg[12] QDFFRBN $PINS Q=x_reg[12] D=N491 CK=CTS_52 RB=i_rst_n
Xis_computing_reg QDFFRBN $PINS Q=is_computing D=FE_PHN1406_N457 CK=CTS_52
+ RB=FE_OFN2_i_rst_n
Xy_reg_reg[11] QDFFRBN $PINS Q=FE_PHN1523_y_reg_11 D=N508 CK=CTS_55 RB=i_rst_n
Xx_reg_reg[11] QDFFRBN $PINS Q=x_reg[11] D=N490 CK=CTS_52 RB=i_rst_n
Xx_reg_reg[1] QDFFRBN $PINS Q=x_reg[1] D=FE_PHN1490_N480 CK=CTS_52 RB=i_rst_n
Xy_reg_reg[1] QDFFRBN $PINS Q=y_reg[1] D=FE_PHN1374_N498 CK=CTS_55
+ RB=FE_OFN2_i_rst_n
Xy_reg_reg[3] QDFFRBN $PINS Q=y_reg[3] D=N500 CK=CTS_55 RB=FE_OFN2_i_rst_n
Xx_reg_reg[3] QDFFRBN $PINS Q=x_reg[3] D=N482 CK=CTS_52 RB=i_rst_n
Xy_reg_reg[10] QDFFRBN $PINS Q=y_reg[10] D=N507 CK=CTS_55 RB=i_rst_n
Xx_reg_reg[4] QDFFRBN $PINS Q=x_reg[4] D=N483 CK=CTS_52 RB=i_rst_n
Xx_reg_reg[10] QDFFRBN $PINS Q=x_reg[10] D=N489 CK=CTS_52 RB=i_rst_n
Xy_reg_reg[4] QDFFRBN $PINS Q=y_reg[4] D=N501 CK=CTS_55 RB=FE_OFN2_i_rst_n
Xy_reg_reg[2] QDFFRBN $PINS Q=y_reg[2] D=N499 CK=CTS_55 RB=FE_OFN2_i_rst_n
Xx_reg_reg[0] QDFFRBN $PINS Q=x_reg[0] D=FE_PHN1473_N479 CK=CTS_52
+ RB=FE_OFN2_i_rst_n
Xx_reg_reg[2] QDFFRBN $PINS Q=x_reg[2] D=FE_PHN1489_N481 CK=CTS_52 RB=i_rst_n
Xy_reg_reg[0] QDFFRBN $PINS Q=y_reg[0] D=N497 CK=CTS_55 RB=FE_OFN2_i_rst_n
Xy_reg_reg[7] QDFFRBN $PINS Q=y_reg[7] D=N504 CK=CTS_55 RB=i_rst_n
Xx_reg_reg[7] QDFFRBN $PINS Q=x_reg[7] D=N486 CK=CTS_52 RB=i_rst_n
Xy_reg_reg[5] QDFFRBN $PINS Q=y_reg[5] D=N502 CK=CTS_55 RB=FE_OFN18_i_rst_n
Xx_reg_reg[5] QDFFRBN $PINS Q=FE_PHN1215_x_reg_5 D=N484 CK=CTS_52 RB=i_rst_n
Xy_reg_reg[8] QDFFRBN $PINS Q=y_reg[8] D=N505 CK=CTS_55 RB=i_rst_n
Xx_reg_reg[8] QDFFRBN $PINS Q=FE_PHN1225_x_reg_8 D=N487 CK=CTS_52 RB=i_rst_n
Xy_reg_reg[6] QDFFRBN $PINS Q=FE_PHN1527_y_reg_6 D=N503 CK=CTS_55 RB=i_rst_n
Xx_reg_reg[6] QDFFRBN $PINS Q=x_reg[6] D=N485 CK=CTS_52 RB=i_rst_n
Xy_reg_reg[9] QDFFRBN $PINS Q=y_reg[9] D=N506 CK=CTS_55 RB=i_rst_n
Xx_reg_reg[9] QDFFRBN $PINS Q=FE_PHN1226_x_reg_9 D=N488 CK=CTS_52 RB=i_rst_n
Xvalid_out_reg QDFFRBN $PINS Q=valid_out D=N515 CK=clk RB=i_rst_n
Xstep_cnt_reg[0] QDFFRBN $PINS Q=step_cnt[0] D=N458 CK=CTS_58
+ RB=FE_OFN2_i_rst_n
Xstep_cnt_reg[3] QDFFRBN $PINS Q=step_cnt[3] D=N461 CK=CTS_58
+ RB=FE_OFN2_i_rst_n
Xstep_cnt_reg[1] QDFFRBP $PINS Q=FE_PHN1259_step_cnt_1 D=FE_PHN1416_N459
+ CK=CTS_59 RB=FE_OFN2_i_rst_n
XU3 NR2P $PINS O=n11 I1=n261 I2=z_reg[15]
XU4 AN3 $PINS O=n26 I1=n255 I2=step_cnt[1] I3=n259
XU5 NR2P $PINS O=n10 I1=n261 I2=z_reg[15]
XU6 OR2P $PINS O=n2 I1=n253 I2=step_cnt[3]
XU7 ND2 $PINS O=n372 I1=n373 I2=is_computing
XU9 NR2P $PINS O=n16 I1=n261 I2=z_reg[15]
XU10 NR2 $PINS O=N147 I1=x_in[16] I2=sub_87/carry[16]
XU11 AN2B1 $PINS O=n258 I1=step_cnt[0] B1=step_cnt[1]
XU12 NR2 $PINS O=sub_87/carry[2] I1=N130 I2=x_in[1]
XU13 NR2 $PINS O=sub_88/carry[2] I1=N148 I2=y_in[1]
XU14 AN2 $PINS O=n23 I1=z_reg[15] I2=is_computing
XU15 NR2 $PINS O=N165 I1=y_in[16] I2=sub_88/carry[16]
XU23 INV2 $PINS O=n259 I=step_cnt[3]
XU24 INV2 $PINS O=n92 I=n83
XU25 INV1S $PINS O=n256 I=step_cnt[1]
XU26 ND2 $PINS O=n254 I1=step_cnt[2] I2=n258
XU28 OA222S $PINS O=n167 A1=n104 A2=n130 B1=n74 B2=n105 C1=n89 C2=n106
XU29 OA222S $PINS O=n228 A1=n104 A2=n215 B1=n105 B2=n197 C1=n106 C2=n177
XU30 OA222S $PINS O=n229 A1=n103 A2=n187 B1=n80 B2=n203 C1=n2 C2=n196
XU31 OA222S $PINS O=n222 A1=n104 A2=n209 B1=n105 B2=n189 C1=n106 C2=n197
XU32 OA222S $PINS O=n223 A1=n103 A2=n177 B1=n80 B2=n196 C1=n2 C2=n188
XU33 OA222S $PINS O=n137 A1=n104 A2=n124 B1=n102 B2=n105 C1=n74 C2=n106
XU34 OA222S $PINS O=n138 A1=n89 A2=n103 B1=n80 B2=n112 C1=n2 C2=n101
XU35 OA222S $PINS O=n131 A1=FE_OFN306_n104 A2=n118 B1=n91 B2=n105 C1=n102
+ C2=n106
XU36 OA222S $PINS O=n132 A1=n74 A2=n103 B1=n80 B2=n101 C1=n2
+ C2=FE_OFN251_y_reg_8
XU37 OA222S $PINS O=n216 A1=n104 A2=n203 B1=n105 B2=n190 C1=n106 C2=n189
XU38 OA222S $PINS O=n217 A1=n103 A2=n197 B1=n80 B2=n188 C1=n2 C2=n187
XU39 OA222S $PINS O=n125 A1=FE_OFN306_n104 A2=n112 B1=n94 B2=n105 C1=n91
+ C2=n106
XU40 OA222S $PINS O=n126 A1=n102 A2=n103 B1=n80 B2=FE_OFN251_y_reg_8 C1=n2
+ C2=n89
XU41 OA222S $PINS O=n210 A1=n104 A2=n196 B1=n105 B2=n181 C1=n106 C2=n190
XU42 OA222S $PINS O=n211 A1=n103 A2=n189 B1=n80 B2=n187 C1=n2 C2=n177
XU43 OA222S $PINS O=n119 A1=FE_OFN306_n104 A2=n101 B1=n81 B2=n105 C1=n94
+ C2=n106
XU44 OA222S $PINS O=n120 A1=n91 A2=n103 B1=n80 B2=n89 C1=n2 C2=n74
XU45 OA222S $PINS O=n204 A1=n104 A2=n188 B1=n105 B2=n179 C1=n106 C2=n181
XU46 OA222S $PINS O=n205 A1=n103 A2=n190 B1=n80 B2=n177 C1=n2 C2=n197
XU47 OA222S $PINS O=n113 A1=FE_OFN306_n104 A2=FE_OFN251_y_reg_8 B1=n77 B2=n105
+ C1=n81 C2=n106
XU48 OA222S $PINS O=n114 A1=n94 A2=n103 B1=n80 B2=n74 C1=n2 C2=n102
XU49 OA222S $PINS O=n198 A1=n104 A2=n187 B1=n105 B2=n178 C1=n106 C2=n179
XU50 OA222S $PINS O=n199 A1=n103 A2=n181 B1=n80 B2=n197 C1=n2 C2=n189
XU51 OA222S $PINS O=n107 A1=FE_OFN306_n104 A2=n89 B1=n76 B2=n105 C1=n77 C2=n106
XU52 OA222S $PINS O=n108 A1=n81 A2=n103 B1=n80 B2=n102 C1=n2 C2=n91
XU53 OA222S $PINS O=n191 A1=n104 A2=n177 B1=n105 B2=n180 C1=n106 C2=n178
XU54 OA222S $PINS O=n192 A1=n103 A2=n179 B1=n80 B2=n189 C1=n2 C2=n190
XU55 OA222S $PINS O=n96 A1=FE_OFN306_n104 A2=n74 B1=n79 B2=n105 C1=n76 C2=n106
XU56 OA222S $PINS O=n97 A1=n77 A2=n103 B1=n80 B2=n91 C1=n2 C2=n94
XU57 ND3S $PINS O=N112 I1=n254 I2=n73 I3=n375
XU58 ND3S $PINS O=N113 I1=n154 I2=n73 I3=n376
XU59 OR2S $PINS O=n158 I1=n165 I2=n166
XU60 OA222S $PINS O=n237 A1=FE_OFN281_n73 A2=n190 B1=FE_DBTN13_n1 B2=n189
+ C1=n154 C2=n181
XU61 OA222S $PINS O=n238 A1=n92 A2=n178 B1=n153 B2=n180 C1=FE_OFN306_n104
+ C2=n179
XU62 OA222S $PINS O=n151 A1=n94 A2=FE_OFN281_n73 B1=n91 B2=FE_DBTN13_n1 C1=n81
+ C2=n154
XU63 OA222S $PINS O=n152 A1=n92 A2=n76 B1=n153 B2=n79 C1=n77 C2=FE_OFN306_n104
XU64 ND2S $PINS O=N109 I1=n252 I2=n73
XU65 ND3P $PINS O=n252 I1=n373 I2=n256 I3=step_cnt[2]
XU66 ND3 $PINS O=n154 I1=n255 I2=n259 I3=step_cnt[1]
XU67 ND3S $PINS O=n75 I1=step_cnt[2] I2=step_cnt[0] I3=n370
XU69 AO222S $PINS O=n250 A1=x_reg[0] A2=n1 B1=x_reg[4] B2=n83
+ C1=FE_PHN1220_x_reg_7 C2=n142
XU70 AO222S $PINS O=n170 A1=y_reg[0] A2=n1 B1=y_reg[4] B2=n83 C1=y_reg[7]
+ C2=n142
XU71 ND3S $PINS O=n262 I1=step_cnt[1] I2=n257 I3=step_cnt[0]
XU72 ND3 $PINS O=n106 I1=step_cnt[3] I2=n257 I3=n258
XU73 ND3S $PINS O=n253 I1=step_cnt[1] I2=n373 I3=step_cnt[2]
XU74 AO222S $PINS O=n231 A1=n1 A2=x_reg[1] B1=n83 B2=x_reg[5] C1=n142
+ C2=x_reg[8]
XU75 AO222S $PINS O=n140 A1=n1 A2=y_reg[1] B1=n83 B2=y_reg[5] C1=n142
+ C2=FE_PHN1243_y_reg_8
XU76 ND3 $PINS O=n103 I1=n255 I2=n256 I3=step_cnt[3]
XU77 ND3 $PINS O=n105 I1=step_cnt[3] I2=n255 I3=step_cnt[1]
XU78 OA222S $PINS O=n183 A1=n2 A2=n181 B1=n93 B2=n180 C1=n80 C2=n190
XU79 OA222S $PINS O=n85 A1=n81 A2=n2 B1=n93 B2=n79 C1=n80 C2=n94
XU80 OA222S $PINS O=n173 A1=n2 A2=n179 B1=n78 B2=n180 C1=n80 C2=n181
XU81 OA222S $PINS O=n69 A1=n2 A2=n77 B1=n78 B2=n79 C1=n80 C2=n81
XU82 OA222S $PINS O=n241 A1=FE_OFN281_n73 A2=n189 B1=FE_DBTN13_n1 B2=n197
+ C1=n154 C2=n190
XU83 OA222S $PINS O=n157 A1=n91 A2=FE_OFN281_n73 B1=FE_DBTN13_n1 B2=n102 C1=n94
+ C2=n154
XU84 OA222S $PINS O=n236 A1=FE_DBTN13_n1 A2=n190 B1=n150 B2=n180
+ C1=FE_OFN306_n104 C2=n178
XU85 OA222S $PINS O=n149 A1=n94 A2=FE_DBTN13_n1 B1=n150 B2=n79
+ C1=FE_OFN306_n104 C2=n76
XU86 OA12S $PINS O=n369 A1=n371 B1=step_cnt[2] B2=n261
XU87 OA12S $PINS O=n371 A1=FE_PHN1067_n372 B1=step_cnt[1] B2=n261
XU103 ND2 $PINS O=n104 I1=N108 I2=n259
XU104 AN3 $PINS O=n1 I1=n256 I2=n259 I3=n255
XU105 INV1S $PINS O=n67 I=N148
XU106 INV1S $PINS O=n50 I=N130
XU107 INV1S $PINS O=n66 I=y_in[1]
XU108 INV1S $PINS O=n49 I=x_in[1]
XU109 INV1S $PINS O=n65 I=y_in[2]
XU110 INV1S $PINS O=n48 I=x_in[2]
XU111 INV1S $PINS O=n64 I=y_in[3]
XU112 INV1S $PINS O=n47 I=x_in[3]
XU113 INV1S $PINS O=n63 I=y_in[4]
XU114 INV1S $PINS O=n46 I=x_in[4]
XU115 INV1S $PINS O=n62 I=y_in[5]
XU116 INV1S $PINS O=n45 I=x_in[5]
XU117 INV1S $PINS O=n61 I=y_in[6]
XU118 INV1S $PINS O=n44 I=x_in[6]
XU119 INV1S $PINS O=n60 I=y_in[7]
XU120 INV1S $PINS O=n43 I=x_in[7]
XU121 INV1S $PINS O=n59 I=y_in[8]
XU122 INV1S $PINS O=n42 I=x_in[8]
XU123 INV1S $PINS O=n41 I=x_in[9]
XU124 INV1S $PINS O=n58 I=y_in[9]
XU125 INV1S $PINS O=n57 I=y_in[10]
XU126 INV1S $PINS O=n40 I=x_in[10]
XU127 INV1S $PINS O=n56 I=y_in[11]
XU128 INV1S $PINS O=n39 I=x_in[11]
XU129 INV1S $PINS O=n55 I=y_in[12]
XU130 INV1S $PINS O=n38 I=x_in[12]
XU131 INV1S $PINS O=n54 I=y_in[13]
XU132 INV1S $PINS O=n37 I=x_in[13]
XU133 INV1S $PINS O=n53 I=y_in[14]
XU134 INV1S $PINS O=n36 I=x_in[14]
XU135 INV1S $PINS O=n52 I=y_in[15]
XU136 INV1S $PINS O=n35 I=x_in[15]
XU137 INV1S $PINS O=n51 I=y_in[16]
XU138 INV1S $PINS O=n34 I=x_in[16]
XU141 NR2P $PINS O=n83 I1=n252 I2=step_cnt[3]
XU147 INV1S $PINS O=n91 I=FE_PHN1235_y_reg_12
XU148 INV1S $PINS O=n190 I=x_reg[13]
XU149 INV1S $PINS O=n94 I=y_reg[13]
XU151 XOR2HS $PINS O=N438 I1=x_reg[17] I2=add_116/carry[17]
XU152 AN2 $PINS O=add_116/carry[17] I1=add_116/carry[16] I2=x_reg[16]
XU153 XOR2HS $PINS O=N437 I1=x_reg[16] I2=add_116/carry[16]
XU154 AN2 $PINS O=add_116/carry[16] I1=add_116/carry[15] I2=x_reg[15]
XU155 XOR2HS $PINS O=N436 I1=x_reg[15] I2=add_116/carry[15]
XU156 AN2 $PINS O=add_116/carry[15] I1=add_116/carry[14] I2=x_reg[14]
XU157 XOR2HS $PINS O=N435 I1=x_reg[14] I2=add_116/carry[14]
XU158 AN2 $PINS O=add_116/carry[14] I1=add_116/carry[13] I2=x_reg[13]
XU159 XOR2HS $PINS O=N434 I1=x_reg[13] I2=add_116/carry[13]
XU160 AN2 $PINS O=add_116/carry[13] I1=add_116/carry[12] I2=FE_PHN1230_x_reg_12
XU161 XOR2HS $PINS O=N433 I1=FE_PHN1230_x_reg_12 I2=add_116/carry[12]
XU162 AN2 $PINS O=add_116/carry[12] I1=add_116/carry[11] I2=x_reg[11]
XU163 XOR2HS $PINS O=FE_PHN1341_N432 I1=x_reg[11] I2=add_116/carry[11]
XU164 AN2 $PINS O=add_116/carry[11] I1=add_116/carry[10] I2=x_reg[10]
XU165 XOR2HS $PINS O=N431 I1=x_reg[10] I2=add_116/carry[10]
XU166 AN2 $PINS O=add_116/carry[10] I1=add_116/carry[9] I2=x_reg[9]
XU167 XOR2HS $PINS O=N430 I1=x_reg[9] I2=add_116/carry[9]
XU168 AN2 $PINS O=add_116/carry[9] I1=add_116/carry[8] I2=x_reg[8]
XU169 XOR2HS $PINS O=N429 I1=x_reg[8] I2=add_116/carry[8]
XU170 AN2 $PINS O=add_116/carry[8] I1=add_116/carry[7] I2=FE_PHN1220_x_reg_7
XU171 XOR2HS $PINS O=FE_PHN1346_N428 I1=FE_PHN1220_x_reg_7 I2=add_116/carry[7]
XU172 AN2 $PINS O=add_116/carry[7] I1=add_116/carry[6] I2=x_reg[6]
XU173 XOR2HS $PINS O=N427 I1=x_reg[6] I2=add_116/carry[6]
XU174 AN2 $PINS O=add_116/carry[6] I1=FE_PHN1049_x_reg_4 I2=x_reg[5]
XU175 XOR2HS $PINS O=N426 I1=x_reg[5] I2=FE_PHN1049_x_reg_4
XU176 XOR2HS $PINS O=N451 I1=y_reg[17] I2=add_117/carry[17]
XU177 AN2 $PINS O=add_117/carry[17] I1=add_117/carry[16] I2=FE_PHN1139_y_reg_16
XU178 XOR2HS $PINS O=N450 I1=FE_PHN1139_y_reg_16 I2=add_117/carry[16]
XU179 AN2 $PINS O=add_117/carry[16] I1=add_117/carry[15] I2=FE_PHN1111_y_reg_15
XU180 XOR2HS $PINS O=N449 I1=FE_PHN1111_y_reg_15 I2=add_117/carry[15]
XU181 AN2 $PINS O=add_117/carry[15] I1=add_117/carry[14] I2=y_reg[14]
XU182 XOR2HS $PINS O=N448 I1=y_reg[14] I2=add_117/carry[14]
XU183 AN2 $PINS O=add_117/carry[14] I1=add_117/carry[13] I2=FE_PHN1159_y_reg_13
XU184 XOR2HS $PINS O=N447 I1=FE_PHN1159_y_reg_13 I2=add_117/carry[13]
XU185 AN2 $PINS O=add_117/carry[13] I1=add_117/carry[12] I2=FE_PHN1235_y_reg_12
XU186 XOR2HS $PINS O=N446 I1=FE_PHN1235_y_reg_12 I2=add_117/carry[12]
XU187 AN2 $PINS O=add_117/carry[12] I1=add_117/carry[11] I2=FE_PHN1245_y_reg_11
XU188 XOR2HS $PINS O=N445 I1=FE_PHN1245_y_reg_11 I2=add_117/carry[11]
XU189 AN2 $PINS O=add_117/carry[11] I1=add_117/carry[10] I2=FE_PHN1242_y_reg_10
XU190 XOR2HS $PINS O=N444 I1=FE_PHN1242_y_reg_10 I2=add_117/carry[10]
XU191 AN2 $PINS O=add_117/carry[10] I1=add_117/carry[9] I2=FE_PHN1247_y_reg_9
XU192 XOR2HS $PINS O=N443 I1=FE_PHN1247_y_reg_9 I2=add_117/carry[9]
XU193 AN2 $PINS O=add_117/carry[9] I1=add_117/carry[8] I2=FE_PHN1243_y_reg_8
XU194 XOR2HS $PINS O=N442 I1=FE_PHN1243_y_reg_8 I2=add_117/carry[8]
XU195 AN2 $PINS O=add_117/carry[8] I1=add_117/carry[7] I2=FE_PHN1191_y_reg_7
XU196 XOR2HS $PINS O=N441 I1=FE_PHN1191_y_reg_7 I2=add_117/carry[7]
XU197 AN2 $PINS O=add_117/carry[7] I1=add_117/carry[6] I2=FE_PHN1237_y_reg_6
XU198 XOR2HS $PINS O=N440 I1=FE_PHN1237_y_reg_6 I2=add_117/carry[6]
XU199 AN2 $PINS O=add_117/carry[6] I1=FE_PHN1216_y_reg_4 I2=FE_PHN1168_y_reg_5
XU200 XOR2HS $PINS O=N439 I1=FE_PHN1168_y_reg_5 I2=FE_PHN1216_y_reg_4
XU201 XOR2HS $PINS O=N146 I1=n34 I2=sub_87/carry[16]
XU202 AN2 $PINS O=sub_87/carry[16] I1=sub_87/carry[15] I2=n35
XU203 XOR2HS $PINS O=N145 I1=n35 I2=sub_87/carry[15]
XU204 AN2 $PINS O=sub_87/carry[15] I1=sub_87/carry[14] I2=n36
XU205 XOR2HS $PINS O=N144 I1=n36 I2=sub_87/carry[14]
XU206 AN2 $PINS O=sub_87/carry[14] I1=sub_87/carry[13] I2=n37
XU207 XOR2HS $PINS O=N143 I1=n37 I2=sub_87/carry[13]
XU208 AN2 $PINS O=sub_87/carry[13] I1=sub_87/carry[12] I2=n38
XU209 XOR2HS $PINS O=N142 I1=n38 I2=sub_87/carry[12]
XU210 AN2 $PINS O=sub_87/carry[12] I1=sub_87/carry[11] I2=n39
XU211 XOR2HS $PINS O=N141 I1=n39 I2=sub_87/carry[11]
XU212 AN2 $PINS O=sub_87/carry[11] I1=sub_87/carry[10] I2=n40
XU213 XOR2HS $PINS O=N140 I1=n40 I2=sub_87/carry[10]
XU214 AN2 $PINS O=sub_87/carry[10] I1=sub_87/carry[9] I2=n41
XU215 XOR2HS $PINS O=N139 I1=n41 I2=sub_87/carry[9]
XU216 AN2 $PINS O=sub_87/carry[9] I1=sub_87/carry[8] I2=n42
XU217 XOR2HS $PINS O=N138 I1=n42 I2=sub_87/carry[8]
XU218 AN2 $PINS O=sub_87/carry[8] I1=sub_87/carry[7] I2=n43
XU219 XOR2HS $PINS O=N137 I1=n43 I2=sub_87/carry[7]
XU220 AN2 $PINS O=sub_87/carry[7] I1=sub_87/carry[6] I2=n44
XU221 XOR2HS $PINS O=N136 I1=n44 I2=sub_87/carry[6]
XU222 AN2 $PINS O=sub_87/carry[6] I1=sub_87/carry[5] I2=n45
XU223 XOR2HS $PINS O=N135 I1=n45 I2=sub_87/carry[5]
XU224 AN2 $PINS O=sub_87/carry[5] I1=sub_87/carry[4] I2=n46
XU225 XOR2HS $PINS O=N134 I1=n46 I2=sub_87/carry[4]
XU226 AN2 $PINS O=sub_87/carry[4] I1=sub_87/carry[3] I2=n47
XU227 XOR2HS $PINS O=N133 I1=n47 I2=sub_87/carry[3]
XU228 AN2 $PINS O=sub_87/carry[3] I1=sub_87/carry[2] I2=n48
XU229 XOR2HS $PINS O=N132 I1=n48 I2=sub_87/carry[2]
XU230 XOR2HS $PINS O=N131 I1=n49 I2=n50
XU231 XOR2HS $PINS O=N164 I1=n51 I2=sub_88/carry[16]
XU232 AN2 $PINS O=sub_88/carry[16] I1=sub_88/carry[15] I2=n52
XU233 XOR2HS $PINS O=N163 I1=n52 I2=sub_88/carry[15]
XU234 AN2 $PINS O=sub_88/carry[15] I1=sub_88/carry[14] I2=n53
XU235 XOR2HS $PINS O=N162 I1=n53 I2=sub_88/carry[14]
XU236 AN2 $PINS O=sub_88/carry[14] I1=sub_88/carry[13] I2=n54
XU237 XOR2HS $PINS O=N161 I1=n54 I2=sub_88/carry[13]
XU238 AN2 $PINS O=sub_88/carry[13] I1=sub_88/carry[12] I2=n55
XU239 XOR2HS $PINS O=N160 I1=n55 I2=sub_88/carry[12]
XU240 AN2 $PINS O=sub_88/carry[12] I1=sub_88/carry[11] I2=n56
XU241 XOR2HS $PINS O=N159 I1=n56 I2=sub_88/carry[11]
XU242 AN2 $PINS O=sub_88/carry[11] I1=sub_88/carry[10] I2=n57
XU243 XOR2HS $PINS O=N158 I1=n57 I2=sub_88/carry[10]
XU244 AN2 $PINS O=sub_88/carry[10] I1=sub_88/carry[9] I2=n58
XU245 XOR2HS $PINS O=N157 I1=n58 I2=sub_88/carry[9]
XU246 AN2 $PINS O=sub_88/carry[9] I1=sub_88/carry[8] I2=n59
XU247 XOR2HS $PINS O=N156 I1=n59 I2=sub_88/carry[8]
XU248 AN2 $PINS O=sub_88/carry[8] I1=sub_88/carry[7] I2=n60
XU249 XOR2HS $PINS O=N155 I1=n60 I2=sub_88/carry[7]
XU250 AN2 $PINS O=sub_88/carry[7] I1=sub_88/carry[6] I2=n61
XU251 XOR2HS $PINS O=N154 I1=n61 I2=sub_88/carry[6]
XU252 AN2 $PINS O=sub_88/carry[6] I1=sub_88/carry[5] I2=n62
XU253 XOR2HS $PINS O=N153 I1=n62 I2=sub_88/carry[5]
XU254 AN2 $PINS O=sub_88/carry[5] I1=sub_88/carry[4] I2=n63
XU255 XOR2HS $PINS O=N152 I1=n63 I2=sub_88/carry[4]
XU256 AN2 $PINS O=sub_88/carry[4] I1=sub_88/carry[3] I2=n64
XU257 XOR2HS $PINS O=N151 I1=n64 I2=sub_88/carry[3]
XU258 AN2 $PINS O=sub_88/carry[3] I1=sub_88/carry[2] I2=n65
XU259 XOR2HS $PINS O=N150 I1=n65 I2=sub_88/carry[2]
XU260 XOR2HS $PINS O=N149 I1=n66 I2=n67
XU261 ND3 $PINS O=y_shift[9] I1=n68 I2=n69 I3=n70
XU262 NR2 $PINS O=n70 I1=n71 I2=n72
XU263 MOAI1S $PINS O=n72 A1=FE_OFN281_n73 A2=n74 B1=n26 B2=FE_PHN1245_y_reg_11
XU264 MOAI1S $PINS O=n71 A1=FE_OFN173_n75 A2=n76 B1=n1 B2=FE_PHN1247_y_reg_9
XU265 AOI22S $PINS O=n68 A1=FE_PHN1235_y_reg_12 A2=n82 B1=y_reg[13] B2=n83
XU266 ND3 $PINS O=y_shift[8] I1=n84 I2=n85 I3=n86
XU267 NR2 $PINS O=n86 I1=n87 I2=n88
XU268 MOAI1S $PINS O=n88 A1=n89 A2=FE_OFN281_n73 B1=n26 B2=FE_PHN1242_y_reg_10
XU269 OAI222S $PINS O=n87 A1=FE_DBTN13_n1 A2=FE_OFN251_y_reg_8 B1=n91 B2=n92
+ C1=n77 C2=FE_OFN173_n75
XU270 AOI22S $PINS O=n84 A1=n95 A2=y_reg[16] B1=FE_PHN1245_y_reg_11 B2=n82
XU271 ND3 $PINS O=y_shift[7] I1=n96 I2=n97 I3=n98
XU272 NR2 $PINS O=n98 I1=n99 I2=n100
XU273 MOAI1S $PINS O=n100 A1=FE_OFN281_n73 A2=FE_OFN251_y_reg_8
+ B1=FE_PHN1247_y_reg_9 B2=n26
XU274 OAI222S $PINS O=n99 A1=FE_DBTN13_n1 A2=n101 B1=n92 B2=n102 C1=n81
+ C2=FE_OFN173_n75
XU275 ND3 $PINS O=y_shift[6] I1=n107 I2=n108 I3=n109
XU276 NR2 $PINS O=n109 I1=n110 I2=n111
XU277 MOAI1S $PINS O=n111 A1=FE_OFN281_n73 A2=n101 B1=n26 B2=FE_PHN1243_y_reg_8
XU278 OAI222S $PINS O=n110 A1=FE_DBTN13_n1 A2=n112 B1=n92 B2=n74 C1=n94
+ C2=FE_OFN173_n75
XU279 ND3 $PINS O=y_shift[5] I1=n113 I2=n114 I3=n115
XU280 NR2 $PINS O=n115 I1=n116 I2=n117
XU281 MOAI1S $PINS O=n117 A1=FE_OFN280_n73 A2=n112 B1=n26 B2=y_reg[7]
XU282 OAI222S $PINS O=n116 A1=FE_DBTN13_n1 A2=n118 B1=n92 B2=n89 C1=n91
+ C2=FE_OFN173_n75
XU283 ND3 $PINS O=y_shift[4] I1=n119 I2=n120 I3=n121
XU284 NR2 $PINS O=n121 I1=n122 I2=n123
XU285 MOAI1S $PINS O=n123 A1=FE_OFN281_n73 A2=n118 B1=n26 B2=FE_PHN1237_y_reg_6
XU286 OAI222S $PINS O=n122 A1=FE_DBTN13_n1 A2=n124 B1=n92 B2=FE_OFN251_y_reg_8
+ C1=FE_OFN173_n75 C2=n102
XU287 ND3 $PINS O=y_shift[3] I1=n125 I2=n126 I3=n127
XU288 NR2 $PINS O=n127 I1=n128 I2=n129
XU289 MOAI1S $PINS O=n129 A1=FE_OFN280_n73 A2=n124 B1=n26 B2=y_reg[5]
XU290 OAI222S $PINS O=n128 A1=FE_DBTN13_n1 A2=n130 B1=n92 B2=n101
+ C1=FE_OFN173_n75 C2=n74
XU291 ND3 $PINS O=y_shift[2] I1=n131 I2=n132 I3=n133
XU292 NR2 $PINS O=n133 I1=n134 I2=n135
XU293 MOAI1S $PINS O=n135 A1=n73 A2=n130 B1=n26 B2=FE_PHN1216_y_reg_4
XU294 OAI222S $PINS O=n134 A1=FE_DBTN13_n1 A2=n136 B1=n92 B2=n112 C1=n89
+ C2=FE_OFN173_n75
XU295 ND3 $PINS O=y_shift[1] I1=n137 I2=n138 I3=n139
XU296 NR2 $PINS O=n139 I1=n140 I2=n141
XU297 MOAI1S $PINS O=n141 A1=n73 A2=n136 B1=n26 B2=y_reg[3]
XU299 INV1S $PINS O=n124 I=y_reg[4]
XU300 MOAI1S $PINS O=y_shift[16] A1=FE_DBTN13_n1 A2=n76 B1=y_reg[17] B2=n143
XU301 OAI222S $PINS O=y_shift[15] A1=n77 A2=FE_DBTN13_n1 B1=n144 B2=n79 C1=n76
+ C2=FE_OFN281_n73
XU302 ND2 $PINS O=y_shift[14] I1=n145 I2=n146
XU303 AOI22S $PINS O=n146 A1=y_reg[17] A2=n147 B1=n1 B2=y_reg[14]
XU304 AOI22S $PINS O=n145 A1=n26 A2=y_reg[16] B1=n7 B2=y_reg[15]
XU305 ND2 $PINS O=y_shift[13] I1=n148 I2=n149
XU306 AOI22S $PINS O=n148 A1=n26 A2=y_reg[15] B1=n7 B2=y_reg[14]
XU307 ND2 $PINS O=y_shift[12] I1=n151 I2=n152
XU308 INV1S $PINS O=n77 I=y_reg[15]
XU309 INV1S $PINS O=n79 I=y_reg[17]
XU310 INV1S $PINS O=n76 I=y_reg[16]
XU311 INV1S $PINS O=n81 I=y_reg[14]
XU312 ND3 $PINS O=y_shift[11] I1=n155 I2=n156 I3=n157
XU313 AOI22S $PINS O=n156 A1=y_reg[17] A2=n158 B1=y_reg[16] B2=FE_OFN221_n159
XU314 AOI22S $PINS O=n155 A1=n82 A2=y_reg[14] B1=n83 B2=y_reg[15]
XU315 ND3 $PINS O=y_shift[10] I1=n160 I2=n161 I3=n162
XU316 NR2 $PINS O=n162 I1=n163 I2=n164
XU317 MOAI1S $PINS O=n164 A1=n102 A2=FE_OFN281_n73 B1=FE_PHN1235_y_reg_12
+ B2=n26
XU318 MOAI1S $PINS O=n163 A1=FE_DBTN13_n1 A2=n74 B1=y_reg[14] B2=n83
XU319 AOI22S $PINS O=n161 A1=y_reg[17] A2=n165 B1=y_reg[15] B2=FE_OFN221_n159
XU320 AOI22S $PINS O=n160 A1=y_reg[16] A2=n166 B1=y_reg[13] B2=n82
XU321 ND3 $PINS O=y_shift[0] I1=n167 I2=n168 I3=n169
XU322 NR2 $PINS O=n169 I1=n170 I2=n171
XU323 MOAI1 $PINS O=n171 A1=n154 A2=n136 B1=n7 B2=y_reg[1]
XU324 INV1S $PINS O=n136 I=y_reg[2]
XU325 OA222 $PINS O=n168 A1=n103 A2=FE_OFN251_y_reg_8 B1=n80 B2=n118 C1=n2
+ C2=n112
XU326 INV1S $PINS O=n112 I=FE_PHN1237_y_reg_6
XU327 INV1S $PINS O=n118 I=y_reg[5]
XU330 INV1S $PINS O=n130 I=y_reg[3]
XU331 ND3 $PINS O=x_shift[9] I1=n172 I2=n173 I3=n174
XU332 NR2 $PINS O=n174 I1=n175 I2=n176
XU333 MOAI1S $PINS O=n176 A1=FE_OFN281_n73 A2=n177 B1=n26 B2=x_reg[11]
XU334 MOAI1S $PINS O=n175 A1=FE_OFN173_n75 A2=n178 B1=n1 B2=x_reg[9]
XU335 AOI22S $PINS O=n172 A1=FE_PHN1230_x_reg_12 A2=n82 B1=x_reg[13] B2=n83
XU336 ND3 $PINS O=x_shift[8] I1=n182 I2=n183 I3=n184
XU337 NR2 $PINS O=n184 I1=n185 I2=n186
XU338 MOAI1S $PINS O=n186 A1=FE_OFN281_n73 A2=n187 B1=n26 B2=x_reg[10]
XU339 OAI222S $PINS O=n185 A1=FE_DBTN13_n1 A2=n188 B1=n92 B2=n189
+ C1=FE_OFN173_n75 C2=n179
XU340 AOI22S $PINS O=n182 A1=x_reg[16] A2=n95 B1=x_reg[11] B2=n82
XU341 INV1S $PINS O=n95 I=n103
XU342 ND3 $PINS O=x_shift[7] I1=n191 I2=n192 I3=n193
XU343 NR2 $PINS O=n193 I1=n194 I2=n195
XU344 MOAI1S $PINS O=n195 A1=FE_OFN281_n73 A2=n188 B1=n26 B2=x_reg[9]
XU345 OAI222S $PINS O=n194 A1=FE_DBTN13_n1 A2=n196 B1=n92 B2=n197
+ C1=FE_OFN173_n75 C2=n181
XU346 ND3 $PINS O=x_shift[6] I1=n198 I2=n199 I3=n200
XU347 NR2 $PINS O=n200 I1=n201 I2=n202
XU348 MOAI1S $PINS O=n202 A1=FE_OFN280_n73 A2=n196 B1=n26 B2=x_reg[8]
XU349 OAI222S $PINS O=n201 A1=FE_DBTN13_n1 A2=n203 B1=n92 B2=n177
+ C1=FE_OFN173_n75 C2=n190
XU350 ND3 $PINS O=x_shift[5] I1=n204 I2=n205 I3=n206
XU351 NR2 $PINS O=n206 I1=n207 I2=n208
XU352 MOAI1S $PINS O=n208 A1=FE_OFN280_n73 A2=n203 B1=n26 B2=FE_PHN1220_x_reg_7
XU353 OAI222S $PINS O=n207 A1=FE_DBTN13_n1 A2=n209 B1=n92 B2=n187
+ C1=FE_OFN173_n75 C2=n189
XU354 ND3 $PINS O=x_shift[4] I1=n210 I2=n211 I3=n212
XU355 NR2 $PINS O=n212 I1=n213 I2=n214
XU356 MOAI1S $PINS O=n214 A1=FE_OFN280_n73 A2=n209 B1=n26 B2=x_reg[6]
XU357 OAI222S $PINS O=n213 A1=FE_DBTN13_n1 A2=n215 B1=n92 B2=n188
+ C1=FE_OFN173_n75 C2=n197
XU358 ND3 $PINS O=x_shift[3] I1=n216 I2=n217 I3=n218
XU359 NR2 $PINS O=n218 I1=n219 I2=n220
XU360 MOAI1S $PINS O=n220 A1=n73 A2=n215 B1=n26 B2=x_reg[5]
XU361 OAI222S $PINS O=n219 A1=FE_DBTN13_n1 A2=n221 B1=n92 B2=n196
+ C1=FE_OFN173_n75 C2=n177
XU362 ND3 $PINS O=x_shift[2] I1=n222 I2=n223 I3=n224
XU363 NR2 $PINS O=n224 I1=n225 I2=n226
XU364 MOAI1S $PINS O=n226 A1=n73 A2=n221 B1=n26 B2=x_reg[4]
XU365 OAI222S $PINS O=n225 A1=FE_DBTN13_n1 A2=n227 B1=n92 B2=n203
+ C1=FE_OFN173_n75 C2=n187
XU366 ND3 $PINS O=x_shift[1] I1=n228 I2=n229 I3=n230
XU367 NR2 $PINS O=n230 I1=n231 I2=n232
XU368 MOAI1S $PINS O=n232 A1=n73 A2=n227 B1=n26 B2=x_reg[3]
XU370 INV1S $PINS O=n215 I=x_reg[4]
XU371 MOAI1S $PINS O=x_shift[16] A1=FE_DBTN13_n1 A2=n178 B1=x_reg[17] B2=n143
XU372 ND2 $PINS O=n143 I1=n144 I2=FE_OFN281_n73
XU373 OAI222S $PINS O=x_shift[15] A1=FE_DBTN13_n1 A2=n179 B1=n144 B2=n180
+ C1=FE_OFN281_n73 C2=n178
XU374 NR2 $PINS O=n144 I1=n147 I2=n26
XU375 ND2 $PINS O=x_shift[14] I1=n233 I2=n234
XU376 AOI22S $PINS O=n234 A1=x_reg[17] A2=n147 B1=x_reg[14] B2=n1
XU377 ND2 $PINS O=n147 I1=n150 I2=FE_OFN306_n104
XU378 AOI22S $PINS O=n233 A1=x_reg[16] A2=n26 B1=x_reg[15] B2=n7
XU379 ND2 $PINS O=x_shift[13] I1=n235 I2=n236
XU380 AN2 $PINS O=n150 I1=n153 I2=n92
XU381 AOI22S $PINS O=n235 A1=x_reg[15] A2=n26 B1=x_reg[14] B2=n7
XU382 ND2 $PINS O=x_shift[12] I1=n237 I2=n238
XU383 INV1S $PINS O=n179 I=x_reg[15]
XU384 INV1S $PINS O=n180 I=x_reg[17]
XU385 NR2 $PINS O=n153 I1=n158 I2=FE_OFN221_n159
XU386 INV1S $PINS O=n178 I=x_reg[16]
XU387 INV1S $PINS O=n181 I=x_reg[14]
XU388 ND3 $PINS O=x_shift[11] I1=n239 I2=n240 I3=n241
XU389 AOI22S $PINS O=n240 A1=x_reg[17] A2=n158 B1=x_reg[16] B2=FE_OFN221_n159
XU390 AOI22S $PINS O=n239 A1=x_reg[14] A2=n82 B1=x_reg[15] B2=n83
XU391 ND3 $PINS O=x_shift[10] I1=n242 I2=n243 I3=n244
XU392 NR2 $PINS O=n244 I1=n245 I2=n246
XU393 MOAI1S $PINS O=n246 A1=FE_OFN281_n73 A2=n197 B1=n26
+ B2=FE_PHN1230_x_reg_12
XU394 MOAI1S $PINS O=n245 A1=FE_DBTN13_n1 A2=n177 B1=n83 B2=x_reg[14]
XU395 AOI22S $PINS O=n243 A1=x_reg[17] A2=n165 B1=x_reg[15] B2=FE_OFN221_n159
XU396 ND2 $PINS O=n165 I1=n78 I2=FE_OFN173_n75
XU397 AN2 $PINS O=n78 I1=n93 I2=n103
XU398 AN2 $PINS O=n93 I1=n106 I2=n105
XU399 AOI22S $PINS O=n242 A1=x_reg[16] A2=n166 B1=x_reg[13] B2=n82
XU400 INV1S $PINS O=n82 I=FE_OFN306_n104
XU401 ND3 $PINS O=x_shift[0] I1=n247 I2=n248 I3=n249
XU402 NR2 $PINS O=n249 I1=n250 I2=n251
XU403 MOAI1S $PINS O=n251 A1=n154 A2=n227 B1=n7 B2=x_reg[1]
XU404 INV1S $PINS O=n227 I=x_reg[2]
XU405 OA222 $PINS O=n248 A1=n103 A2=n188 B1=n80 B2=n209 C1=n2 C2=n203
XU407 NR2 $PINS O=n166 I1=n253 I2=step_cnt[3]
XU408 INV1S $PINS O=n209 I=x_reg[5]
XU409 NR2 $PINS O=n159 I1=n254 I2=step_cnt[3]
XU411 OA222 $PINS O=n247 A1=n104 A2=n221 B1=n105 B2=n177 C1=n106 C2=n187
XU413 INV1S $PINS O=n221 I=x_reg[3]
XU414 AO22 $PINS O=n379 A1=N313 A2=n16 B1=FE_PHN1427_N365 B2=n23
XU415 AO22 $PINS O=FE_PHN1433_n380 A1=N312 A2=n16 B1=N364 B2=n23
XU416 AO22 $PINS O=FE_PHN1432_n381 A1=N311 A2=n16 B1=N363 B2=n23
XU417 AO22 $PINS O=FE_PHN1429_n382 A1=N310 A2=n16 B1=N362 B2=n23
XU418 AO22 $PINS O=FE_PHN1423_n383 A1=N309 A2=n16 B1=N361 B2=n23
XU419 AO22 $PINS O=n384 A1=N308 A2=n16 B1=N360 B2=n23
XU420 AO22 $PINS O=n385 A1=N307 A2=n16 B1=N359 B2=n23
XU421 AO22 $PINS O=n386 A1=N306 A2=n16 B1=N358 B2=n23
XU422 NR3 $PINS O=N515 I1=n261 I2=n259 I3=FE_OFN242_n262
XU423 ND2 $PINS O=FE_PHN1482_N514 I1=n263 I2=n264
XU424 AOI22S $PINS O=n264 A1=N357 A2=n23 B1=N305 B2=n10
XU425 AOI22S $PINS O=n263 A1=y_in[16] A2=n265 B1=N165 B2=n266
XU426 ND2 $PINS O=N513 I1=n267 I2=n268
XU427 AOI22S $PINS O=n268 A1=N356 A2=n23 B1=N304 B2=n11
XU428 AOI22S $PINS O=n267 A1=y_in[16] A2=n265 B1=N164 B2=n266
XU429 ND2 $PINS O=N512 I1=n269 I2=n270
XU430 AOI22S $PINS O=n270 A1=N355 A2=n23 B1=N303 B2=n11
XU431 AOI22S $PINS O=n269 A1=y_in[15] A2=n265 B1=N163 B2=n266
XU432 ND2 $PINS O=N511 I1=n271 I2=n272
XU433 AOI22S $PINS O=n272 A1=N354 A2=n23 B1=N302 B2=n11
XU434 AOI22S $PINS O=n271 A1=y_in[14] A2=n265 B1=N162 B2=n266
XU435 ND2 $PINS O=N510 I1=n273 I2=FE_PHN1537_n274
XU436 AOI22S $PINS O=n274 A1=N353 A2=n23 B1=N301 B2=n11
XU437 AOI22S $PINS O=n273 A1=y_in[13] A2=n265 B1=N161 B2=n266
XU438 ND2 $PINS O=N509 I1=n275 I2=n276
XU439 AOI22S $PINS O=n276 A1=N352 A2=n23 B1=N300 B2=n16
XU440 AOI22S $PINS O=n275 A1=y_in[12] A2=n265 B1=N160 B2=n266
XU441 ND2 $PINS O=N508 I1=n277 I2=n278
XU442 AOI22S $PINS O=n278 A1=N351 A2=n23 B1=N299 B2=n11
XU443 AOI22S $PINS O=n277 A1=y_in[11] A2=n265 B1=N159 B2=n266
XU444 ND2 $PINS O=N507 I1=n279 I2=n280
XU445 AOI22S $PINS O=n280 A1=N350 A2=n23 B1=N298 B2=n16
XU446 AOI22S $PINS O=n279 A1=y_in[10] A2=n265 B1=N158 B2=n266
XU447 ND2 $PINS O=N506 I1=n281 I2=n282
XU448 AOI22S $PINS O=n282 A1=N349 A2=n23 B1=N297 B2=n10
XU449 AOI22S $PINS O=n281 A1=y_in[9] A2=n265 B1=N157 B2=n266
XU450 ND2 $PINS O=N505 I1=n283 I2=n284
XU451 AOI22S $PINS O=n284 A1=N348 A2=n23 B1=N296 B2=n11
XU452 AOI22S $PINS O=n283 A1=FE_PHN1492_c_in_i_1_8 A2=n265 B1=N156 B2=n266
XU453 ND2 $PINS O=N504 I1=n285 I2=n286
XU454 AOI22S $PINS O=FE_PHN1538_n286 A1=N347 A2=n23 B1=N295 B2=n16
XU455 AOI22S $PINS O=n285 A1=y_in[7] A2=n265 B1=N155 B2=n266
XU456 ND2 $PINS O=N503 I1=n287 I2=n288
XU457 AOI22S $PINS O=n288 A1=N346 A2=n260 B1=N294 B2=n11
XU458 AOI22S $PINS O=n287 A1=y_in[6] A2=n265 B1=N154 B2=n266
XU459 ND2 $PINS O=N502 I1=FE_PHN1507_n289 I2=n290
XU460 AOI22S $PINS O=n290 A1=N345 A2=n23 B1=N293 B2=n11
XU461 AOI22S $PINS O=n289 A1=FE_PHN1095_c_in_i_1_5 A2=n265 B1=N153 B2=n266
XU462 ND2 $PINS O=N501 I1=n291 I2=n292
XU463 AOI22S $PINS O=n292 A1=N344 A2=n260 B1=N292 B2=n11
XU464 AOI22S $PINS O=n291 A1=FE_PHN1076_c_in_i_1_4 A2=n265 B1=N152 B2=n266
XU465 ND2 $PINS O=N500 I1=n293 I2=n294
XU466 AOI22S $PINS O=FE_PHN1442_n294 A1=N343 A2=n260 B1=N291 B2=n11
XU467 AOI22S $PINS O=n293 A1=FE_PHN1081_c_in_i_1_3 A2=n265 B1=N151 B2=n266
XU468 ND2 $PINS O=N499 I1=n295 I2=FE_PHN1408_n296
XU469 AOI22S $PINS O=n296 A1=N342 A2=n260 B1=N290 B2=n11
XU470 AOI22S $PINS O=n295 A1=y_in[2] A2=n265 B1=N150 B2=n266
XU471 ND2 $PINS O=N498 I1=n297 I2=n298
XU472 AOI22S $PINS O=n298 A1=N341 A2=n260 B1=N289 B2=n11
XU473 AOI22S $PINS O=n297 A1=y_in[1] A2=n265 B1=N149 B2=n266
XU474 ND2 $PINS O=FE_PHN1474_N497 I1=n299 I2=FE_PHN1358_n300
XU475 AOI22S $PINS O=n300 A1=N340 A2=n260 B1=N288 B2=n11
XU476 AOI22S $PINS O=n299 A1=N148 A2=n265 B1=N148 B2=n266
XU477 ND2 $PINS O=N496 I1=n301 I2=n302
XU478 AOI22S $PINS O=n302 A1=N339 A2=n260 B1=N287 B2=n11
XU479 AOI22S $PINS O=n301 A1=x_in[16] A2=n265 B1=N147 B2=n266
XU480 ND2 $PINS O=N495 I1=n303 I2=n304
XU481 AOI22S $PINS O=n304 A1=N338 A2=n260 B1=N286 B2=n11
XU482 AOI22S $PINS O=n303 A1=x_in[16] A2=n265 B1=N146 B2=n266
XU483 ND2 $PINS O=N494 I1=n305 I2=n306
XU484 AOI22S $PINS O=n306 A1=N337 A2=n260 B1=N285 B2=n11
XU485 AOI22S $PINS O=n305 A1=x_in[15] A2=n265 B1=N145 B2=n266
XU486 ND2 $PINS O=N493 I1=n307 I2=n308
XU487 AOI22S $PINS O=n308 A1=N336 A2=n260 B1=N284 B2=n11
XU488 AOI22S $PINS O=n307 A1=x_in[14] A2=n265 B1=N144 B2=n266
XU489 ND2 $PINS O=N492 I1=n309 I2=n310
XU490 AOI22S $PINS O=n310 A1=N335 A2=n23 B1=N283 B2=n10
XU491 AOI22S $PINS O=n309 A1=x_in[13] A2=n265 B1=N143 B2=n266
XU492 ND2 $PINS O=N491 I1=n311 I2=n312
XU493 AOI22S $PINS O=n312 A1=N334 A2=n260 B1=N282 B2=n10
XU494 AOI22S $PINS O=n311 A1=x_in[12] A2=n265 B1=N142 B2=n266
XU495 ND2 $PINS O=FE_PHN1412_N490 I1=n313 I2=n314
XU496 AOI22S $PINS O=n314 A1=N333 A2=n260 B1=N281 B2=n10
XU497 AOI22S $PINS O=n313 A1=x_in[11] A2=n265 B1=N141 B2=n266
XU498 ND2 $PINS O=N489 I1=FE_PHN1409_n315 I2=n316
XU499 AOI22S $PINS O=n316 A1=N332 A2=n260 B1=N280 B2=n10
XU500 AOI22S $PINS O=n315 A1=x_in[10] A2=n265 B1=N140 B2=n266
XU501 ND2 $PINS O=N488 I1=n317 I2=n318
XU502 AOI22S $PINS O=n318 A1=N331 A2=n260 B1=N279 B2=n10
XU503 AOI22S $PINS O=n317 A1=x_in[9] A2=n265 B1=N139 B2=n266
XU504 ND2 $PINS O=N487 I1=FE_PHN1540_n319 I2=n320
XU505 AOI22S $PINS O=n320 A1=N330 A2=n260 B1=N278 B2=n10
XU506 AOI22S $PINS O=n319 A1=x_in[8] A2=n265 B1=N138 B2=n266
XU507 ND2 $PINS O=N486 I1=n321 I2=n322
XU508 AOI22S $PINS O=n322 A1=N329 A2=n260 B1=N277 B2=n10
XU509 AOI22S $PINS O=n321 A1=x_in[7] A2=n265 B1=N137 B2=n266
XU510 ND2 $PINS O=N485 I1=FE_PHN1539_n323 I2=n324
XU511 AOI22S $PINS O=n324 A1=N328 A2=n260 B1=N276 B2=n10
XU512 AOI22S $PINS O=n323 A1=x_in[6] A2=n265 B1=N136 B2=n266
XU513 ND2 $PINS O=N484 I1=n325 I2=n326
XU514 AOI22S $PINS O=n326 A1=N327 A2=n260 B1=N275 B2=n10
XU515 AOI22S $PINS O=n325 A1=x_in[5] A2=n265 B1=N135 B2=n266
XU516 ND2 $PINS O=N483 I1=n327 I2=n328
XU517 AOI22S $PINS O=n328 A1=N326 A2=n260 B1=N274 B2=n10
XU518 AOI22S $PINS O=n327 A1=x_in[4] A2=n265 B1=N134 B2=n266
XU519 ND2 $PINS O=N482 I1=n329 I2=n330
XU520 AOI22S $PINS O=n330 A1=N325 A2=n260 B1=N273 B2=n10
XU521 AOI22S $PINS O=n329 A1=x_in[3] A2=n265 B1=N133 B2=n266
XU522 ND2 $PINS O=N481 I1=n331 I2=n332
XU523 AOI22S $PINS O=n332 A1=N324 A2=n260 B1=N272 B2=n16
XU524 AOI22S $PINS O=n331 A1=x_in[2] A2=n265 B1=N132 B2=n266
XU525 ND2 $PINS O=N480 I1=n333 I2=FE_PHN1445_n334
XU526 AOI22S $PINS O=n334 A1=N323 A2=n260 B1=N271 B2=n11
XU527 AOI22S $PINS O=n333 A1=x_in[1] A2=n265 B1=N131 B2=n266
XU528 ND2 $PINS O=N479 I1=n335 I2=FE_PHN1355_n336
XU529 AOI22S $PINS O=n336 A1=N322 A2=n260 B1=N270 B2=n10
XU530 AOI22S $PINS O=n335 A1=N130 A2=n265 B1=N130 B2=n266
XU531 INV2 $PINS O=n265 I=n337
XU532 OAI112HS $PINS O=N478 A1=FE_PHN1418_n339 B1=n340 C1=n338 C2=n337
XU533 AOI22S $PINS O=n340 A1=n338 A2=n341 B1=n338 B2=n342
XU534 AOI22S $PINS O=n339 A1=N373 A2=n260 B1=N321 B2=n11
XU535 OAI112HS $PINS O=N477 A1=n344 B1=n345 C1=n343 C2=n337
XU536 AOI22S $PINS O=n345 A1=N182 A2=n341 B1=N182 B2=n342
XU537 AOI22S $PINS O=n344 A1=N372 A2=n260 B1=N320 B2=n16
XU538 OAI112HS $PINS O=N476 A1=n347 B1=n348 C1=n337 C2=n346
XU539 AOI22S $PINS O=n348 A1=N181 A2=n341 B1=N181 B2=n342
XU540 AOI22S $PINS O=n347 A1=N371 A2=n260 B1=N319 B2=n11
XU541 OAI112HS $PINS O=N475 A1=n350 B1=n351 C1=n337 C2=n349
XU542 AOI22S $PINS O=n351 A1=N180 A2=n341 B1=N180 B2=n342
XU543 AOI22S $PINS O=n350 A1=N370 A2=n260 B1=N318 B2=n16
XU544 OAI112HS $PINS O=N474 A1=FE_PHN1425_n353 B1=n354 C1=n337 C2=n352
XU545 AOI22S $PINS O=n354 A1=N179 A2=n341 B1=N179 B2=n342
XU546 AOI22S $PINS O=n353 A1=N369 A2=n260 B1=N317 B2=n11
XU547 OAI112HS $PINS O=N473 A1=n356 B1=n357 C1=n337 C2=n355
XU548 AOI22S $PINS O=n357 A1=N178 A2=n341 B1=N178 B2=n342
XU549 AOI22S $PINS O=n356 A1=N368 A2=n260 B1=N316 B2=n16
XU550 OAI112HS $PINS O=N472 A1=n359 B1=n360 C1=n337 C2=n358
XU551 AOI22S $PINS O=n360 A1=N177 A2=n341 B1=N177 B2=n342
XU552 AOI22S $PINS O=n359 A1=N367 A2=n260 B1=N315 B2=n11
XU553 OAI112HS $PINS O=N471 A1=n362 B1=n363 C1=n337 C2=p1
XU554 AOI22S $PINS O=n363 A1=N176 A2=n341 B1=N176 B2=n342
XU555 AN2 $PINS O=n342 I1=n266 I2=phase_in[15]
XU556 AN2 $PINS O=n341 I1=n266 I2=n338
XU557 AOI12H $PINS O=n266 A1=n366 B1=n364 B2=n365
XU558 AOI22S $PINS O=n362 A1=N366 A2=n260 B1=N314 B2=n11
XU559 AN2 $PINS O=n260 I1=z_reg[15] I2=is_computing
XU560 OR3B2 $PINS O=n337 I1=n366 B1=n365 B2=n364
XU561 ND2 $PINS O=n364 I1=phase_in[15] I2=n343
XU562 INV1S $PINS O=n343 I=N182
XU563 OAI112HS $PINS O=n365 A1=n338 B1=N182 C1=n367 C2=n368
XU564 INV1S $PINS O=n338 I=phase_in[15]
XU565 ND3 $PINS O=n368 I1=n352 I2=n349 I3=n355
XU566 INV1S $PINS O=n355 I=N178
XU567 INV1S $PINS O=n349 I=N180
XU568 INV1S $PINS O=n352 I=N179
XU569 ND3 $PINS O=n367 I1=p1 I2=n358 I3=n346
XU570 INV1S $PINS O=n346 I=N181
XU571 INV1S $PINS O=n358 I=N177
XU573 ND2 $PINS O=N462 I1=n261 I2=n366
XU574 MOAI1S $PINS O=FE_PHN1410_N461 A1=n369 A2=n259 B1=is_computing B2=n142
XU576 NR2 $PINS O=n370 I1=step_cnt[3] I2=n256
XU577 OAI22S $PINS O=FE_PHN1270_N460 A1=n371 A2=n257 B1=FE_OFN242_n262 B2=n261
XU578 MOAI1S $PINS O=N459 A1=n256 A2=FE_PHN1067_n372 B1=n258 B2=is_computing
XU579 INV1S $PINS O=N458 I=FE_PHN1067_n372
XU580 ND2 $PINS O=N457 I1=n366 I2=n374
XU581 OAI12HS $PINS O=n374 A1=is_computing B1=n259 B2=FE_OFN242_n262
XU582 ND2 $PINS O=n366 I1=valid_in I2=n261
XU583 INV1S $PINS O=n261 I=is_computing
XU584 ND3 $PINS O=N118 I1=n375 I2=n376 I3=n377
XU585 AN2 $PINS O=n377 I1=FE_OFN242_n262 I2=n252
XU586 OAI112HS $PINS O=N117 A1=n254 B1=n378 C1=n256 C2=n259
XU587 AN3 $PINS O=n378 I1=n252 I2=n154 I3=n253
XU588 OAI112HS $PINS O=N116 A1=n254 B1=n73 C1=n259 C2=n373
XU589 OAI112HS $PINS O=N115 A1=n252 B1=n154 C1=n258 C2=n259
XU590 OAI112HS $PINS O=N114 A1=FE_OFN242_n262 B1=n375 C1=n259 C2=n373
XU591 OA13S $PINS O=n376 A1=n253 B1=step_cnt[0] B2=step_cnt[1] B3=n259
XU592 AOI13HS $PINS O=n375 A1=n26 B1=step_cnt[0] B2=step_cnt[1] B3=step_cnt[2]
XU593 OR3B2 $PINS O=N111 I1=N109 B1=n154 B2=n253
XU594 ND3 $PINS O=N110 I1=n154 I2=FE_OFN242_n262 I3=n254
XU595 NR2 $PINS O=n255 I1=step_cnt[2] I2=step_cnt[0]
XU596 ND3 $PINS O=n73 I1=n257 I2=n259 I3=n258
Xstep_cnt_reg[2] DFFRBN $PINS Q=step_cnt[2] QB=n257 D=N460 CK=CTS_58
+ RB=FE_OFN2_i_rst_n
Xclk_gate_y_reg_reg SNPS_CLOCK_GATE_HIGH_cordic_rotation_0_0 $PINS EN=N462
+ ENCLK=CTS_57 CLK=clk_clone3
Xclk_gate_z_reg_reg SNPS_CLOCK_GATE_HIGH_cordic_rotation_0_4 $PINS EN=N462
+ ENCLK=CTS_54 CLK=clk_clone3
Xclk_gate_y_out_reg SNPS_CLOCK_GATE_HIGH_cordic_rotation_0_3 $PINS EN=N515
+ ENCLK=CTS_67 CLK=clk_clone1
Xclk_gate_x_out_reg SNPS_CLOCK_GATE_HIGH_cordic_rotation_0_2 $PINS EN=N515
+ ENCLK=CTS_64 CLK=clk_clone1
Xclk_gate_step_cnt_reg SNPS_CLOCK_GATE_HIGH_cordic_rotation_0_1 $PINS
+ EN=FE_PHN1406_N457 ENCLK=CTS_61 CLK=clk_clone2
Xadd_105 cordic_rotation_0_DW01_add_2 $PINS A[15]=z_reg[15]
+ A[14]=FE_PHN994_z_reg_14 A[13]=FE_PHN1066_z_reg_13 A[12]=FE_PHN1147_z_reg_12
+ A[11]=z_reg[11] A[10]=FE_PHN1165_z_reg_10 A[9]=FE_PHN1176_z_reg_9
+ A[8]=FE_PHN1149_z_reg_8 A[7]=z_reg[7] A[6]=z_reg[6] A[5]=z_reg[5] A[4]=z_reg[4]
+ A[3]=z_reg[3] A[2]=z_reg[2] A[1]=z_reg[1] A[0]=FE_PHN1167_z_reg_0 B[15]=n8
+ B[14]=n8 B[13]=n1 B[12]=n7 B[11]=n26 B[10]=N108 B[9]=N109 B[8]=N110 B[7]=N111
+ B[6]=N112 B[5]=N113 B[4]=N114 B[3]=N115 B[2]=N116 B[1]=N117 B[0]=N118 CI=n8
+ SUM[15]=N373 SUM[14]=N372 SUM[13]=N371 SUM[12]=N370 SUM[11]=N369 SUM[10]=N368
+ SUM[9]=N367 SUM[8]=N366 SUM[7]=N365 SUM[6]=N364 SUM[5]=N363 SUM[4]=N362
+ SUM[3]=N361 SUM[2]=N360 SUM[1]=N359 SUM[0]=N358
Xsub_104 cordic_rotation_0_DW01_sub_0_DW01_sub_28 $PINS A[17]=y_reg[17]
+ A[16]=y_reg[16] A[15]=y_reg[15] A[14]=y_reg[14] A[13]=y_reg[13]
+ A[12]=FE_PHN1235_y_reg_12 A[11]=y_reg[11] A[10]=FE_PHN1242_y_reg_10
+ A[9]=FE_PHN1524_y_reg_9 A[8]=FE_PHN1243_y_reg_8 A[7]=y_reg[7] A[6]=y_reg[6]
+ A[5]=y_reg[5] A[4]=y_reg[4] A[3]=y_reg[3] A[2]=y_reg[2] A[1]=y_reg[1]
+ A[0]=y_reg[0] B[17]=x_shift[16] B[16]=x_shift[16] B[15]=x_shift[15]
+ B[14]=x_shift[14] B[13]=x_shift[13] B[12]=x_shift[12] B[11]=x_shift[11]
+ B[10]=x_shift[10] B[9]=x_shift[9] B[8]=x_shift[8] B[7]=x_shift[7]
+ B[6]=x_shift[6] B[5]=x_shift[5] B[4]=x_shift[4] B[3]=x_shift[3] B[2]=x_shift[2]
+ B[1]=x_shift[1] B[0]=x_shift[0] CI=n8 DIFF[17]=N357 DIFF[16]=N356 DIFF[15]=N355
+ DIFF[14]=N354 DIFF[13]=N353 DIFF[12]=N352 DIFF[11]=N351 DIFF[10]=N350
+ DIFF[9]=N349 DIFF[8]=N348 DIFF[7]=N347 DIFF[6]=N346 DIFF[5]=N345 DIFF[4]=N344
+ DIFF[3]=N343 DIFF[2]=N342 DIFF[1]=N341 DIFF[0]=N340
Xadd_103 cordic_rotation_0_DW01_add_3 $PINS A[17]=x_reg[17] A[16]=x_reg[16]
+ A[15]=x_reg[15] A[14]=x_reg[14] A[13]=x_reg[13] A[12]=FE_PHN1230_x_reg_12
+ A[11]=x_reg[11] A[10]=x_reg[10] A[9]=x_reg[9] A[8]=x_reg[8]
+ A[7]=FE_PHN1220_x_reg_7 A[6]=x_reg[6] A[5]=x_reg[5] A[4]=x_reg[4] A[3]=x_reg[3]
+ A[2]=x_reg[2] A[1]=x_reg[1] A[0]=x_reg[0] B[17]=y_shift[16] B[16]=y_shift[16]
+ B[15]=y_shift[15] B[14]=y_shift[14] B[13]=y_shift[13] B[12]=y_shift[12]
+ B[11]=y_shift[11] B[10]=y_shift[10] B[9]=y_shift[9] B[8]=y_shift[8]
+ B[7]=y_shift[7] B[6]=y_shift[6] B[5]=y_shift[5] B[4]=y_shift[4] B[3]=y_shift[3]
+ B[2]=y_shift[2] B[1]=y_shift[1] B[0]=y_shift[0] CI=n8 SUM[17]=N339 SUM[16]=N338
+ SUM[15]=N337 SUM[14]=N336 SUM[13]=N335 SUM[12]=N334 SUM[11]=N333 SUM[10]=N332
+ SUM[9]=N331 SUM[8]=N330 SUM[7]=N329 SUM[6]=N328 SUM[5]=N327 SUM[4]=N326
+ SUM[3]=N325 SUM[2]=N324 SUM[1]=N323 SUM[0]=N322
Xsub_101 cordic_rotation_0_DW01_sub_1_DW01_sub_29 $PINS A[15]=z_reg[15]
+ A[14]=FE_PHN994_z_reg_14 A[13]=FE_PHN1066_z_reg_13 A[12]=FE_PHN1147_z_reg_12
+ A[11]=z_reg[11] A[10]=FE_PHN1165_z_reg_10 A[9]=FE_PHN1176_z_reg_9
+ A[8]=FE_PHN1149_z_reg_8 A[7]=z_reg[7] A[6]=z_reg[6] A[5]=z_reg[5] A[4]=z_reg[4]
+ A[3]=z_reg[3] A[2]=z_reg[2] A[1]=z_reg[1] A[0]=z_reg[0] B[15]=n8 B[14]=n8
+ B[13]=FE_DBTN13_n1 B[12]=n7 B[11]=n26 B[10]=N108 B[9]=N109 B[8]=N110 B[7]=N111
+ B[6]=N112 B[5]=N113 B[4]=N114 B[3]=N115 B[2]=N116 B[1]=N117 B[0]=N118 CI=n8
+ DIFF[15]=N321 DIFF[14]=N320 DIFF[13]=N319 DIFF[12]=N318 DIFF[11]=N317
+ DIFF[10]=N316 DIFF[9]=N315 DIFF[8]=N314 DIFF[7]=N313 DIFF[6]=N312 DIFF[5]=N311
+ DIFF[4]=N310 DIFF[3]=N309 DIFF[2]=N308 DIFF[1]=N307 DIFF[0]=N306 n73=n73
+ n262=FE_OFN242_n262 p1=FE_PHN1167_z_reg_0
Xadd_100 cordic_rotation_0_DW01_add_4 $PINS A[17]=y_reg[17] A[16]=y_reg[16]
+ A[15]=y_reg[15] A[14]=y_reg[14] A[13]=y_reg[13] A[12]=FE_PHN1235_y_reg_12
+ A[11]=y_reg[11] A[10]=FE_PHN1242_y_reg_10 A[9]=FE_PHN1524_y_reg_9
+ A[8]=FE_PHN1243_y_reg_8 A[7]=y_reg[7] A[6]=y_reg[6] A[5]=y_reg[5] A[4]=y_reg[4]
+ A[3]=y_reg[3] A[2]=y_reg[2] A[1]=y_reg[1] A[0]=y_reg[0] B[17]=x_shift[16]
+ B[16]=x_shift[16] B[15]=x_shift[15] B[14]=x_shift[14] B[13]=x_shift[13]
+ B[12]=x_shift[12] B[11]=x_shift[11] B[10]=x_shift[10] B[9]=x_shift[9]
+ B[8]=x_shift[8] B[7]=x_shift[7] B[6]=x_shift[6] B[5]=x_shift[5] B[4]=x_shift[4]
+ B[3]=x_shift[3] B[2]=x_shift[2] B[1]=x_shift[1] B[0]=x_shift[0] CI=n8
+ SUM[17]=N305 SUM[16]=N304 SUM[15]=N303 SUM[14]=N302 SUM[13]=N301 SUM[12]=N300
+ SUM[11]=N299 SUM[10]=N298 SUM[9]=N297 SUM[8]=N296 SUM[7]=N295 SUM[6]=N294
+ SUM[5]=N293 SUM[4]=N292 SUM[3]=N291 SUM[2]=N290 SUM[1]=N289 SUM[0]=N288
Xsub_99 cordic_rotation_0_DW01_sub_2_DW01_sub_30 $PINS A[17]=x_reg[17]
+ A[16]=x_reg[16] A[15]=x_reg[15] A[14]=x_reg[14] A[13]=x_reg[13]
+ A[12]=FE_PHN1230_x_reg_12 A[11]=x_reg[11] A[10]=x_reg[10] A[9]=x_reg[9]
+ A[8]=x_reg[8] A[7]=FE_PHN1220_x_reg_7 A[6]=x_reg[6] A[5]=x_reg[5] A[4]=x_reg[4]
+ A[3]=x_reg[3] A[2]=x_reg[2] A[1]=x_reg[1] A[0]=x_reg[0] B[17]=y_shift[16]
+ B[16]=y_shift[16] B[15]=y_shift[15] B[14]=y_shift[14] B[13]=y_shift[13]
+ B[12]=y_shift[12] B[11]=y_shift[11] B[10]=y_shift[10] B[9]=y_shift[9]
+ B[8]=y_shift[8] B[7]=y_shift[7] B[6]=y_shift[6] B[5]=y_shift[5] B[4]=y_shift[4]
+ B[3]=y_shift[3] B[2]=y_shift[2] B[1]=y_shift[1] B[0]=y_shift[0] CI=n8
+ DIFF[17]=N287 DIFF[16]=N286 DIFF[15]=N285 DIFF[14]=N284 DIFF[13]=N283
+ DIFF[12]=N282 DIFF[11]=N281 DIFF[10]=N280 DIFF[9]=N279 DIFF[8]=N278
+ DIFF[7]=N277 DIFF[6]=N276 DIFF[5]=N275 DIFF[4]=N274 DIFF[3]=N273 DIFF[2]=N272
+ DIFF[1]=N271 DIFF[0]=N270
.ENDS

.SUBCKT CSD_ROM_Table_even_1 n_idx[4] n_idx[3] n_idx[2] n_idx[1] n_idx[0]
+ k_idx[4] k_idx[3] k_idx[2] k_idx[1] k_idx[0] sign1[1] sign1[0] shift1[3]
+ shift1[2] shift1[1] shift1[0] sign2[1] sign2[0] shift2[3] shift2[2] shift2[1]
+ shift2[0] sign3[1] sign3[0] shift3[3] shift3[2] shift3[1] shift3[0]
XFE_OFC139_fold_n_0 INV1S $PINS O=FE_OFN126_fold_n_0 I=n_idx[0]
XFE_OFC138_fold_n_0 INV2 $PINS O=n112 I=n_idx[0]
XFE_OFC137_n1 INV2 $PINS O=n37 I=n1
XU776 OA222 $PINS O=n144 A1=n152 A2=n97 B1=n153 B2=n154 C1=n155 C2=n156
XU777 OR3B2 $PINS O=n164 I1=n165 B1=n166 B2=n167
XU778 ND2 $PINS O=n168 I1=n40 I2=n112
XU779 AO12 $PINS O=n179 A1=n182 B1=n109 B2=n181
XU780 AO112 $PINS O=n187 A1=n_idx[4] B1=n189 C1=n188 C2=n_idx[3]
XU782 OA222 $PINS O=n226 A1=n227 A2=n163 B1=n228 B2=n229 C1=n230 C2=n231
XU783 ND2 $PINS O=n233 I1=n235 I2=n236
XU784 ND2 $PINS O=n232 I1=n237 I2=n238
XU785 ND2 $PINS O=n240 I1=n241 I2=n88
XU786 ND2 $PINS O=n239 I1=n176 I2=n242
XU787 AN3B2S $PINS O=n247 I1=n249 B1=n250 B2=n251
XU788 AN3 $PINS O=n258 I1=n259 I2=n260 I3=n220
XU789 OR3B2 $PINS O=n261 I1=n265 B1=n266 B2=n34
XU790 AN3 $PINS O=n268 I1=n271 I2=n272 I3=n273
XU791 AO12 $PINS O=sign2[1] A1=n276 B1=n274 B2=n275
XU792 AO222 $PINS O=n275 A1=n277 A2=n991 B1=n278 B2=n279 C1=n280 C2=n281
XU793 AO12 $PINS O=n288 A1=k_idx[0] B1=n112 B2=k_idx[2]
XU794 ND2 $PINS O=n307 I1=n311 I2=n174
XU795 AO12 $PINS O=n303 A1=n313 B1=n312 B2=n223
XU796 OA222 $PINS O=n316 A1=n317 A2=n216 B1=n318 B2=n319 C1=n320 C2=n154
XU797 ND2 $PINS O=n353 I1=n82 I2=n418
XU798 AO12 $PINS O=sign1[1] A1=n276 B1=n274 B2=n356
XU799 ND2 $PINS O=n180 I1=n_idx[4] I2=n96
XU800 AN3 $PINS O=n357 I1=n358 I2=n112 I3=n359
XU801 OR3 $PINS O=n358 I1=n282 I2=n40 I3=n_idx[1]
XU802 ND2 $PINS O=n365 I1=n133 I2=n282
XU803 ND2 $PINS O=n282 I1=n286 I2=k_idx[2]
XU804 OA222 $PINS O=n376 A1=n383 A2=n231 B1=n384 B2=n347 C1=n385 C2=n248
XU805 OA222 $PINS O=n375 A1=n389 A2=n172 B1=n390 B2=n391 C1=n392 C2=n393
XU806 OA222 $PINS O=n374 A1=n92 A2=n99 B1=n81 B2=n94 C1=n77 C2=n238
XU807 ND2 $PINS O=n270 I1=n413 I2=n414
XU810 OA112 $PINS O=n267 A1=n427 B1=n428 C1=n77 C2=n426
XU811 ND2 $PINS O=n431 I1=n176 I2=n401
XU812 ND2 $PINS O=n443 I1=n1 I2=n444
XU813 ND2 $PINS O=n447 I1=n450 I2=n242
XU814 AO12 $PINS O=n445 A1=n216 B1=n163 B2=n451
XU815 ND2 $PINS O=n455 I1=n62 I2=n131
XU816 OA222 $PINS O=n463 A1=n77 A2=n319 B1=n405 B2=n299 C1=n98 C2=n92
XU817 OA222 $PINS O=n462 A1=n468 A2=n147 B1=n469 B2=n212 C1=n470 C2=n216
XU818 AN3B2S $PINS O=n469 I1=n151 B1=n344 B2=n55
XU819 AN3B2S $PINS O=n486 I1=n498 B1=n499 B2=n500
XU820 AN3 $PINS O=n514 I1=n228 I2=n151 I3=n517
XU821 OA222 $PINS O=n511 A1=n92 A2=n518 B1=n519 B2=n311 C1=n520 C2=n319
XU822 OA222 $PINS O=n509 A1=n404 A2=n154 B1=n524 B2=n172 C1=n259 C2=n345
XU823 AN3B2S $PINS O=n531 I1=n484 B1=n532 B2=n37
XU824 OA112 $PINS O=n538 A1=n540 B1=n541 C1=n216 C2=n253
XU825 AN3 $PINS O=n555 I1=n563 I2=n564 I3=n427
XU826 ND2 $PINS O=n427 I1=n130 I2=n565
XU827 ND2 $PINS O=n567 I1=n263 I2=n221
XU828 ND2 $PINS O=n566 I1=n309 I2=n86
XU829 ND2 $PINS O=n571 I1=n54 I2=n444
XU830 OA222 $PINS O=n547 A1=n73 A2=n319 B1=n573 B2=n229 C1=n574 C2=n488
XU831 AN3B2S $PINS O=n573 I1=n575 B1=n576 B2=n485
XU832 OR3B2 $PINS O=n587 I1=n322 B1=n472 B2=n399
XU833 ND2 $PINS O=n586 I1=n588 I2=n2
XU834 OA222 $PINS O=n606 A1=n610 A2=n335 B1=n611 B2=n229 C1=n612 C2=n488
XU835 ND2 $PINS O=n430 I1=n323 I2=n386
XU836 OA222 $PINS O=n605 A1=n615 A2=n214 B1=n560 B2=n616 C1=n617 C2=n216
XU837 OA222 $PINS O=n604 A1=n619 A2=n147 B1=n387 B2=n347 C1=n620 C2=n154
XU838 AN3B2S $PINS O=n601 I1=n536 B1=n627 B2=n552
XU839 AN3 $PINS O=n504 I1=n633 I2=n634 I3=n635
XU840 OA112 $PINS O=n634 A1=n564 B1=n645 C1=n644 C2=n238
XU841 AO12 $PINS O=n645 A1=n319 B1=n64 B2=n646
XU842 OA222 $PINS O=n633 A1=n392 A2=n214 B1=n647 B2=n299 C1=n235 C2=n64
XU843 OA112 $PINS O=n454 A1=n648 B1=n649 C1=n299 C2=n253
XU844 OA222 $PINS O=n649 A1=n156 A2=n28 B1=n650 B2=n6 C1=n595 C2=n238
XU845 OA222 $PINS O=n536 A1=n600 A2=n92 B1=n191 B2=n64 C1=n178 C2=n72
XU847 OA222 $PINS O=n655 A1=n661 A2=n488 B1=n662 B2=n154 C1=n663 C2=n424
XU848 OA222 $PINS O=n654 A1=n665 A2=n212 B1=n666 B2=n347 C1=n667 C2=n172
XU849 OA112 $PINS O=n652 A1=n669 B1=n670 C1=n299 C2=n176
XU850 OA222 $PINS O=n670 A1=n231 A2=n162 B1=n388 B2=n235 C1=n248 C2=n493
XU851 OR3B2 $PINS O=n671 I1=n352 B1=n245 B2=n562
XU852 OA222 $PINS O=n675 A1=n154 A2=n221 B1=n313 B2=n600 C1=n7 C2=n214
XU853 OA222 $PINS O=n681 A1=n594 A2=n67 B1=n432 B2=n77 C1=n182 C2=n2
XU854 ND2 $PINS O=n684 I1=n54 I2=n664
XU855 ND2 $PINS O=n683 I1=n162 I2=n621
XU856 AO12 $PINS O=n679 A1=n299 B1=n621 B2=n404
XU857 OA222 $PINS O=n677 A1=n81 A2=n223 B1=n218 B2=n345 C1=n630 C2=n319
XU858 OA112 $PINS O=n676 A1=n272 B1=n685 C1=n146 C2=n348
XU859 OA222 $PINS O=n687 A1=n313 A2=n688 B1=n689 B2=n7 C1=n690 C2=n231
XU860 OA112 $PINS O=n561 A1=n697 B1=n698 C1=n81 C2=n223
XU861 ND2 $PINS O=n698 I1=n61 I2=n132
XU862 OA222 $PINS O=n456 A1=n473 A2=n154 B1=n488 B2=n386 C1=n229 C2=n253
XU863 AO112 $PINS O=n702 A1=n704 B1=n705 C1=n703 C2=n337
XU864 AN3 $PINS O=n271 I1=n708 I2=n709 I3=n710
XU865 OA112 $PINS O=n710 A1=n669 B1=n711 C1=n473 C2=n301
XU866 OA222 $PINS O=n711 A1=n154 A2=n221 B1=n77 B2=n319 C1=n345 C2=n621
XU867 OA222 $PINS O=n669 A1=n77 A2=n238 B1=n191 B2=n67 C1=n235 C2=n72
XU868 OA222 $PINS O=n709 A1=n325 A2=n424 B1=n712 B2=n172 C1=n590 C2=n229
XU869 OA222 $PINS O=n708 A1=n178 A2=n2 B1=n328 B2=n313 C1=n411 C2=n488
XU870 AN3 $PINS O=n350 I1=n713 I2=n714 I3=n715
XU871 AN3B2S $PINS O=n715 I1=n716 B1=n717 B2=n718
XU872 ND2 $PINS O=n723 I1=n242 I2=n621
XU873 OA222 $PINS O=n726 A1=n172 A2=n162 B1=n346 B2=n391 C1=n154 C2=n621
XU874 OA222 $PINS O=n731 A1=n7 A2=n235 B1=n81 B2=n688 C1=n313 C2=n94
XU875 AO12 $PINS O=n730 A1=n92 B1=n329 B2=n95
XU876 AN3 $PINS O=n317 I1=n473 I2=n146 I3=n343
XU877 OA222 $PINS O=n761 A1=n197 A2=n80 B1=n762 B2=n248 C1=n89 C2=n172
XU878 ND2 $PINS O=n485 I1=n497 I2=n166
XU879 ND2 $PINS O=n764 I1=n575 I2=n389
XU880 ND2 $PINS O=n339 I1=n176 I2=n323
XU881 AN3B2S $PINS O=n784 I1=n685 B1=n785 B2=n718
XU882 AO12 $PINS O=n718 A1=n522 B1=n35 B2=n418
XU883 AO222 $PINS O=n785 A1=n234 A2=n129 B1=n69 B2=n126 C1=n418 C2=n91
XU884 OA222 $PINS O=n783 A1=n66 A2=n174 B1=n786 B2=n72 C1=n787 C2=n154
XU885 AO112 $PINS O=n798 A1=n553 B1=n502 C1=n572 C2=n124
XU886 ND2 $PINS O=n421 I1=n309 I2=n533
XU887 OA222 $PINS O=n806 A1=n807 A2=n231 B1=n808 B2=n348 C1=n809 C2=n248
XU888 OR3B2 $PINS O=n632 I1=n381 B1=n811 B2=n812
XU889 ND2 $PINS O=n763 I1=n252 I2=n533
XU890 ND2 $PINS O=n381 I1=n497 I2=n442
XU891 AN3 $PINS O=n215 I1=n740 I2=n28 I3=n254
XU892 ND2 $PINS O=n706 I1=n214 I2=n311
XU893 ND2 $PINS O=n813 I1=n824 I2=n825
XU894 ND2 $PINS O=n828 I1=n393 I2=n238
XU895 ND2 $PINS O=n826 I1=n92 I2=n81
XU896 ND2 $PINS O=n564 I1=n62 I2=n122
XU897 ND2 $PINS O=n703 I1=n444 I2=n338
XU898 AN3 $PINS O=n776 I1=n838 I2=n411 I3=n39
XU899 ND2 $PINS O=n849 I1=n72 I2=n67
XU900 ND2 $PINS O=n848 I1=n94 I2=n223
XU901 ND2 $PINS O=n322 I1=n256 I2=n176
XU902 AN3B1 $PINS O=n329 I1=n157 I2=n688 B1=n834
XU903 ND2 $PINS O=n199 I1=n347 I2=n236
XU904 ND2 $PINS O=n833 I1=n346 I2=n6
XU905 ND2 $PINS O=n496 I1=n253 I2=n338
XU906 OR3B2 $PINS O=n872 I1=n382 B1=n86 B2=n484
XU907 ND2 $PINS O=n382 I1=n406 I2=n253
XU908 ND2 $PINS O=n251 I1=n484 I2=n442
XU909 ND2 $PINS O=n491 I1=n338 I2=n533
XU910 ND2 $PINS O=n386 I1=n165 I2=n112
XU911 AN3 $PINS O=n273 I1=n883 I2=n884 I3=n885
XU912 ND2 $PINS O=n697 I1=n279 I2=n186
XU913 OA222 $PINS O=n889 A1=n802 A2=n81 B1=n392 B2=n174 C1=n400 C2=n345
XU915 ND2 $PINS O=n757 I1=n688 I2=n99
XU916 ND2 $PINS O=n200 I1=n570 I2=n191
XU917 ND2 $PINS O=n907 I1=n789 I2=n319
XU919 ND2 $PINS O=n906 I1=n312 I2=n597
XU920 OA222 $PINS O=n911 A1=n238 A2=n64 B1=n440 B2=n176 C1=n39 C2=n488
XU923 OR3B2 $PINS O=n915 I1=n722 B1=n107 B2=n688
XU924 ND2 $PINS O=n722 I1=n312 I2=n802
XU925 ND2 $PINS O=n914 I1=n342 I2=n338
XU926 ND2 $PINS O=n728 I1=n318 I2=n67
XU927 ND2 $PINS O=n788 I1=n7 I2=n67
XU928 OA222 $PINS O=n922 A1=n83 A2=n248 B1=n923 B2=n2 C1=n924 C2=n216
XU929 ND2 $PINS O=n492 I1=n442 I2=n664
XU930 OA222 $PINS O=n637 A1=n415 A2=n81 B1=n256 B2=n345 C1=n92 C2=n312
XU931 OA112 $PINS O=n919 A1=n269 B1=n416 C1=n335 C2=n493
XU932 OA222 $PINS O=n926 A1=n77 A2=n222 B1=n311 B2=n64 C1=n81 C2=n600
XU933 ND2 $PINS O=shift1[0] I1=n927 I2=n928
XU934 ND2 $PINS O=n304 I1=n129 I2=n69
XU935 ND2 $PINS O=n236 I1=n908 I2=n360
XU936 AO12 $PINS O=n933 A1=n388 B1=n174 B2=n650
XU937 ND2 $PINS O=n391 I1=n935 I2=n913
XU939 OA222 $PINS O=n931 A1=n104 A2=n92 B1=n937 B2=n299 C1=n938 C2=n162
XU940 OA222 $PINS O=n930 A1=n404 A2=n229 B1=n197 B2=n64 C1=n524 C2=n488
XU941 OA222 $PINS O=n929 A1=n191 A2=n2 B1=n630 B2=n424 C1=n88 C2=n231
XU942 ND2 $PINS O=n767 I1=n252 I2=n493
XU943 AN3 $PINS O=n920 I1=n944 I2=n945 I3=n946
XU944 AO12 $PINS O=n720 A1=n6 B1=n191 B2=n178
XU945 ND2 $PINS O=n344 I1=n259 I2=n953
XU947 ND2 $PINS O=n957 I1=n150 I2=n252
XU948 ND2 $PINS O=n956 I1=n264 I2=n493
XU949 OA222 $PINS O=n948 A1=n594 A2=n80 B1=n960 B2=n231 C1=n498 C2=n335
XU950 ND2 $PINS O=n449 I1=n778 I2=n533
XU951 ND2 $PINS O=n301 I1=n360 I2=n936
XU952 ND2 $PINS O=n158 I1=n108 I2=n_idx[0]
XU954 ND2 $PINS O=n426 I1=n964 I2=n935
XU955 ND2 $PINS O=n673 I1=n966 I2=n967
XU956 OA222 $PINS O=n967 A1=n876 A2=n248 B1=n968 B2=n216 C1=n969 C2=n311
XU957 ND2 $PINS O=n311 I1=n908 I2=n913
XU958 OA222 $PINS O=n966 A1=n146 A2=n231 B1=n399 B2=n299 C1=n328 C2=n92
XU960 ND2 $PINS O=n222 I1=n912 I2=n964
XU961 AN3 $PINS O=n792 I1=n971 I2=n76 I3=n972
XU962 OA222 $PINS O=n972 A1=n646 A2=n424 B1=n594 B2=n72 C1=n6 C2=n347
XU968 ND2 $PINS O=n234 I1=n302 I2=n6
XU970 OA222 $PINS O=n942 A1=n335 A2=n253 B1=n975 B2=n172 C1=n147 C2=n28
XU971 ND2 $PINS O=n500 I1=n253 I2=n533
XU972 ND2 $PINS O=n444 I1=n976 I2=n958
XU973 ND2 $PINS O=n252 I1=n939 I2=n961
XU974 OA222 $PINS O=n941 A1=n156 A2=n7 B1=n977 B2=n81 C1=n978 C2=n313
XU976 AN3B2S $PINS O=n186 I1=n291 B1=k_idx[3] B2=k_idx[4]
XU977 ND2 $PINS O=n189 I1=n599 I2=n94
XU978 ND2 $PINS O=n688 I1=n105 I2=n_idx[0]
XU979 ND2 $PINS O=n979 I1=n328 I2=n96
XU980 ND2 $PINS O=n223 I1=n102 I2=FE_OFN126_fold_n_0
XU981 ND2 $PINS O=n802 I1=n106 I2=FE_OFN126_fold_n_0
XU982 ND2 $PINS O=n894 I1=n981 I2=n111
XU983 ND2 $PINS O=n518 I1=n101 I2=FE_OFN126_fold_n_0
XU984 ND2 $PINS O=n312 I1=n102 I2=n_idx[0]
XU985 ND2 $PINS O=n157 I1=n108 I2=FE_OFN126_fold_n_0
XU986 ND2 $PINS O=n597 I1=n101 I2=n_idx[0]
XU987 ND2 $PINS O=n415 I1=n175 I2=FE_OFN126_fold_n_0
XU989 ND2 $PINS O=n851 I1=n981 I2=n_idx[1]
XU990 OA222 $PINS O=n940 A1=n982 A2=n154 B1=n497 B2=n212 C1=n983 C2=n345
XU991 ND2 $PINS O=n163 I1=n984 I2=n112
XU993 ND2 $PINS O=n953 I1=n986 I2=n112
XU994 ND2 $PINS O=n861 I1=n300 I2=n253
XU995 ND2 $PINS O=n402 I1=n988 I2=n112
XU996 ND2 $PINS O=n242 I1=n989 I2=n112
XU1000 AN3 $PINS O=n982 I1=n516 I2=n151 I3=n405
XU1001 ND2 $PINS O=n621 I1=n988 I2=n_idx[0]
XU1002 ND2 $PINS O=n974 I1=n990 I2=n111
XU1003 ND2 $PINS O=n220 I1=n986 I2=n_idx[0]
XU1004 ND2 $PINS O=n181 I1=n961 I2=n_idx[3]
XU1006 ND2 $PINS O=n149 I1=n110 I2=n103
XU1008 ND2 $PINS O=n203 I1=n_idx[3] I2=n_idx[2]
XU1009 ND2 $PINS O=n401 I1=n984 I2=n_idx[0]
XU1010 ND2 $PINS O=n204 I1=n990 I2=n_idx[1]
XU3 AN4B1S $PINS O=n624 I1=n399 I2=n741 I3=n221 B1=n618
XU4 ND2 $PINS O=n7 I1=n194 I2=n160
XU5 AN2 $PINS O=n318 I1=n595 I2=n7
XU6 AN4B1S $PINS O=n152 I1=n196 I2=n426 I3=n235 B1=n198
XU7 AN4S $PINS O=n738 I1=n259 I2=n309 I3=n317 I4=n404
XU8 NR2 $PINS O=n1 I1=n38 I2=n50
XU9 ND2 $PINS O=n150 I1=n985 I2=n112
XU10 INV1S $PINS O=n40 I=n280
XU12 ND3S $PINS O=n609 I1=n478 I2=n86 I3=n881
XU13 ND3S $PINS O=n816 I1=n479 I2=n1 I3=n215
XU14 AN2S $PINS O=n385 I1=n386 I2=n310
XU15 ND3S $PINS O=shift1[3] I1=n793 I2=n794 I3=n795
XU16 ND3S $PINS O=n796 I1=n804 I2=n805 I3=n806
XU17 ND3S $PINS O=n308 I1=n221 I2=n309 I3=n310
XU18 ND3S $PINS O=n476 I1=n478 I2=n479 I3=n480
XU19 OA222S $PINS O=n656 A1=n1 A2=n229 B1=n98 B2=n92 C1=n260 C2=n216
XU20 ND2S $PINS O=n495 I1=n150 I2=n442
XU21 OA12S $PINS O=n523 A1=n114 B1=n38 B2=n322
XU22 ND3S $PINS O=n660 I1=n242 I2=n150 I3=n497
XU23 ND3S $PINS O=n166 I1=n280 I2=n110 I3=n370
XU24 ND2 $PINS O=n146 I1=n_idx[0] I2=n985
XU25 ND3S $PINS O=n323 I1=n961 I2=n112 I3=n280
XU26 ND3S $PINS O=n176 I1=n280 I2=n961 I3=n_idx[0]
XU27 ND3S $PINS O=n534 I1=n493 I2=n778 I3=n1
XU28 ND2S $PINS O=n309 I1=n976 I2=n280
XU29 ND3S $PINS O=n727 I1=n298 I2=n1 I3=n729
XU30 ND3S $PINS O=n631 I1=n150 I2=n162 I3=n338
XU31 ND3S $PINS O=n614 I1=n150 I2=n162 I3=n177
XU32 ND3S $PINS O=n162 I1=n280 I2=n_idx[1] I3=n970
XU33 NR2 $PINS O=n279 I1=n96 I2=n_idx[4]
XU34 INV1S $PINS O=n36 I=n478
XU35 NR2 $PINS O=n478 I1=n37 I2=n47
XU36 NR2 $PINS O=n390 I1=n69 I2=n234
XU37 INV1S $PINS O=n66 I=n788
XU38 INV1S $PINS O=n75 I=n682
XU39 AN2 $PINS O=n825 I1=n479 I2=n740
XU40 INV1S $PINS O=n20 I=n472
XU41 INV1S $PINS O=n19 I=n479
XU42 INV1S $PINS O=n33 I=n217
XU43 INV1S $PINS O=n31 I=n411
XU44 INV1S $PINS O=n71 I=n318
XU45 INV1S $PINS O=n59 I=n218
XU46 INV1S $PINS O=n69 I=n388
XU47 INV1S $PINS O=n34 I=n618
XU48 INV1S $PINS O=n41 I=n389
XU49 NR2 $PINS O=n254 I1=n43 I2=n47
XU50 INV1S $PINS O=n47 I=n497
XU52 INV1S $PINS O=n94 I=n642
XU53 ND3 $PINS O=n834 I1=n600 I2=n415 I3=n638
XU54 INV1S $PINS O=n49 I=n859
XU55 INV1S $PINS O=n18 I=n773
XU56 AN2 $PINS O=n384 I1=n387 I2=n388
XU57 INV1S $PINS O=n65 I=n520
XU58 NR2 $PINS O=n263 I1=n43 I2=n38
XU59 INV1S $PINS O=n95 I=n979
XU60 AN2 $PINS O=n328 I1=n802 I2=n223
XU61 INV1S $PINS O=n42 I=n535
XU62 NR2 $PINS O=n383 I1=n38 I2=n42
XU63 INV1S $PINS O=n22 I=n741
XU64 AN2 $PINS O=n625 I1=n801 I2=n318
XU65 INV1S $PINS O=n73 I=n701
XU66 INV1S $PINS O=n68 I=n630
XU67 INV1S $PINS O=n99 I=n721
XU68 ND3 $PINS O=n528 I1=n2 I2=n77 I3=n73
XU69 INV1S $PINS O=n44 I=n471
XU71 NR2 $PINS O=n527 I1=n572 I2=n788
XU72 NR2 $PINS O=n754 I1=n834 I2=n642
XU73 INV1S $PINS O=n30 I=n824
XU74 NR2 $PINS O=n682 I1=n6 I2=n237
XU75 NR2 $PINS O=n197 I1=n125 I2=n124
XU76 NR2 $PINS O=n237 I1=n125 I2=n121
XU77 NR2 $PINS O=n814 I1=n813 I2=n45
XU78 NR2 $PINS O=n300 I1=n26 I2=n61
XU79 AN2 $PINS O=n740 I1=n473 I2=n405
XU80 INV1S $PINS O=n55 I=n400
XU81 NR2 $PINS O=n484 I1=n91 I2=n93
XU82 NR2 $PINS O=n881 I1=n87 I2=n251
XU83 NR2 $PINS O=n613 I1=n251 I2=n33
XU84 NR2 $PINS O=n472 I1=n21 I2=n25
XU85 NR2 $PINS O=n479 I1=n20 I2=n23
XU86 ND3 $PINS O=shift3[2] I1=n458 I2=n459 I3=n460
XU87 NR2 $PINS O=n459 I1=n481 I2=n482
XU88 NR3 $PINS O=n458 I1=n501 I2=n502 I3=n503
XU89 AN4B1S $PINS O=n460 I1=n461 I2=n462 I3=n463 B1=n464
XU90 INV1S $PINS O=n84 I=n251
XU91 ND3 $PINS O=shift3[0] I1=n542 I2=n543 I3=n544
XU92 NR3 $PINS O=n542 I1=n591 I2=n592 I3=n593
XU93 AN4B1S $PINS O=n543 I1=n579 I2=n580 I3=n581 B1=n582
XU94 AN4B1S $PINS O=n544 I1=n545 I2=n546 I3=n547 B1=n548
XU95 NR2 $PINS O=n256 I1=n23 I2=n26
XU96 ND3 $PINS O=n695 I1=n350 I2=n271 I3=n27
XU97 NR2 $PINS O=n968 I1=n26 I2=n29
XU98 NR2 $PINS O=n405 I1=n56 I2=n60
XU99 NR2 $PINS O=n712 I1=n93 I2=n381
XU100 NR2 $PINS O=n497 I1=n53 I2=n48
XU101 NR2 $PINS O=n217 I1=n45 I2=n35
XU102 NR3 $PINS O=n406 I1=n53 I2=n50 I3=n33
XU103 NR2 $PINS O=n647 I1=n35 I2=n26
XU104 NR2 $PINS O=n411 I1=n90 I2=n35
XU105 NR2 $PINS O=n809 I1=n336 I2=n703
XU106 ND3 $PINS O=n407 I1=n27 I2=n349 I3=n416
XU107 NR2 $PINS O=n707 I1=n35 I2=n55
XU108 NR2 $PINS O=n646 I1=n71 I2=n306
XU109 AOI22S $PINS O=n580 A1=n127 A2=n586 B1=n138 B2=n587
XU110 OAI112HS $PINS O=n557 A1=n561 B1=n562 C1=n560 C2=n235
XU111 ND3 $PINS O=n539 I1=n554 I2=n555 I3=n556
XU112 NR2 $PINS O=n554 I1=n568 I2=n569
XU113 NR3 $PINS O=n556 I1=n557 I2=n558 I3=n559
XU114 NR2 $PINS O=n218 I1=n60 I2=n61
XU115 NR2 $PINS O=n575 I1=n59 I2=n58
XU116 AN2 $PINS O=n517 I1=n400 I2=n256
XU117 NR2 $PINS O=n388 I1=n565 I2=n668
XU118 AOI22S $PINS O=n243 A1=n337 A2=n261 B1=n417 B2=n262
XU119 ND3 $PINS O=n262 I1=n263 I2=n264 I3=n249
XU120 ND3 $PINS O=n618 I1=n217 I2=n150 I3=n400
XU121 NR2 $PINS O=n151 I1=n33 I2=n48
XU122 NR2 $PINS O=n389 I1=n45 I2=n50
XU123 INV1S $PINS O=n100 I=n175
XU124 INV1S $PINS O=n77 I=n823
XU125 NR2 $PINS O=n404 I1=n38 I2=n56
XU126 AOI22S $PINS O=n971 A1=n26 A2=n131 B1=n124 B2=n234
XU127 NR2 $PINS O=n310 I1=n37 I2=n35
XU128 INV1S $PINS O=n38 I=n150
XU129 NR2 $PINS O=n590 I1=n45 I2=n25
XU130 NR2 $PINS O=n259 I1=n25 I2=n60
XU131 INV1S $PINS O=n46 I=n167
XU132 NR2 $PINS O=n343 I1=n46 I2=n23
XU133 NR2 $PINS O=n302 I1=n429 I2=n823
XU134 INV1S $PINS O=n86 I=n491
XU135 INV1S $PINS O=n67 I=n668
XU136 OR2 $PINS O=n765 I1=n485 I2=n20
XU137 AOI13HS $PINS O=n395 A1=n212 B1=n256 B2=n405 B3=n406
XU138 INV1S $PINS O=n39 I=n495
XU139 INV1S $PINS O=n43 I=n450
XU140 NR2 $PINS O=n642 I1=FE_OFN126_fold_n_0 I2=n97
XU141 NR2 $PINS O=n325 I1=n823 I2=n585
XU142 NR2 $PINS O=n859 I1=n50 I2=n60
XU143 AOI22S $PINS O=n947 A1=n113 A2=n22 B1=n131 B2=n49
XU144 NR2 $PINS O=n773 I1=n21 I2=n35
XU145 AOI22S $PINS O=n716 A1=n132 A2=n58 B1=n115 B2=n306
XU146 INV1S $PINS O=n74 I=n519
XU147 NR2 $PINS O=n387 I1=n74 I2=n429
XU148 NR2 $PINS O=n399 I1=n58 I2=n61
XU149 NR2 $PINS O=n520 I1=n429 I2=n585
XU150 NR2 $PINS O=n824 I1=n38 I2=n35
XU151 AOI22S $PINS O=n428 A1=n429 A2=n121 B1=n48 B2=n136
XU152 NR2 $PINS O=n721 I1=n100 I2=FE_OFN126_fold_n_0
XU153 NR2 $PINS O=n638 I1=n721 I2=n577
XU154 NR2 $PINS O=n346 I1=n78 I2=n565
XU155 INV1S $PINS O=n78 I=n560
XU156 NR2 $PINS O=n801 I1=n78 I2=n306
XU157 INV1S $PINS O=n87 I=n252
XU158 NR2 $PINS O=n266 I1=n87 I2=n48
XU159 NR2 $PINS O=n475 I1=n48 I2=n56
XU160 NR2 $PINS O=n535 I1=n43 I2=n53
XU161 NR2 $PINS O=n741 I1=n48 I2=n23
XU162 MOAI1S $PINS O=n717 A1=n594 A2=n72 B1=n306 B2=n124
XU163 NR2 $PINS O=n665 I1=n21 I2=n26
XU164 OAI12HS $PINS O=n886 A1=n127 B1=n565 B2=n585
XU165 AOI22S $PINS O=n842 A1=n130 A2=n833 B1=n132 B2=n30
XU166 NR2 $PINS O=n451 I1=n35 I2=n56
XU167 NR2 $PINS O=n228 I1=n21 I2=n58
XU168 NR2 $PINS O=n584 I1=n21 I2=n60
XU169 NR2 $PINS O=n630 I1=n823 I2=n668
XU170 ND3 $PINS O=n701 I1=n80 I2=n7 I3=n392
XU171 ND3 $PINS O=n494 I1=n217 I2=n497 I3=n342
XU172 NR2 $PINS O=n213 I1=n788 I2=n306
XU173 NR2 $PINS O=n474 I1=n43 I2=n50
XU174 AOI12HS $PINS O=n685 A1=n553 B1=n429 B2=n119
XU175 MAOI1 $PINS O=n537 A1=n121 A2=n728 B1=n346 B2=n426
XU176 INV1S $PINS O=n54 I=n421
XU177 INV1S $PINS O=n98 I=n757
XU178 MOAI1S $PINS O=n569 A1=n570 A2=n2 B1=n68 B2=n119
XU179 MOAI1S $PINS O=n918 A1=n213 A2=n347 B1=n115 B2=n728
XU180 NR2 $PINS O=n787 I1=n60 I2=n35
XU181 INV1S $PINS O=n64 I=n585
XU182 INV1S $PINS O=n76 I=n888
XU183 NR2 $PINS O=n471 I1=n45 I2=n53
XU184 ND3 $PINS O=n572 I1=n392 I2=n2 I3=n325
XU185 AN2 $PINS O=n505 I1=n699 I2=n700
XU186 AOI22S $PINS O=n700 A1=n668 A2=n115 B1=n565 B2=n124
XU187 AOI22S $PINS O=n699 A1=n116 A2=n701 B1=n127 B2=n572
XU188 INV1S $PINS O=n51 I=n260
XU189 NR2 $PINS O=n324 I1=n491 I2=n50
XU190 AOI22S $PINS O=n416 A1=n136 A2=n23 B1=n132 B2=n60
XU191 NR2 $PINS O=n588 I1=n65 I2=n823
XU192 INV1S $PINS O=n107 I=n577
XU193 MOAI1S $PINS O=n592 A1=n594 A2=n595 B1=n49 B2=n135
XU194 ND2 $PINS O=n600 I1=n105 I2=FE_OFN126_fold_n_0
XU195 NR2 $PINS O=n719 I1=n721 I2=n722
XU196 INV1S $PINS O=n89 I=n763
XU197 NR2 $PINS O=n241 I1=n91 I2=n48
XU198 ND3 $PINS O=n758 I1=n600 I2=n157 I3=n107
XU199 MOAI1S $PINS O=n623 A1=n318 A2=n594 B1=n114 B2=n23
XU200 NR2 $PINS O=n524 I1=n50 I2=n85
XU201 NR2 $PINS O=n924 I1=n61 I2=n50
XU202 NR2 $PINS O=n439 I1=n38 I2=n61
XU203 INV1S $PINS O=n122 I=n301
XU204 INV1S $PINS O=n129 I=n236
XU205 INV1S $PINS O=n83 I=n492
XU206 NR2 $PINS O=n423 I1=n126 I2=n128
XU207 ND3 $PINS O=n198 I1=n423 I2=n424 I3=n425
XU208 NR2 $PINS O=n425 I1=n130 I2=n119
XU209 INV1S $PINS O=n121 I=n594
XU210 NR2 $PINS O=n570 I1=n118 I2=n123
XU211 NR3 $PINS O=n196 I1=n199 I2=n116 I3=n200
XU212 INV1S $PINS O=n117 I=n200
XU213 AOI22S $PINS O=n546 A1=n577 A2=n8 B1=n116 B2=n429
XU214 INV1S $PINS O=n125 I=n426
XU215 NR2 $PINS O=n182 I1=n125 I2=n126
XU216 INV1S $PINS O=n116 I=n222
XU217 INV1S $PINS O=n115 I=n424
XU218 NR2 $PINS O=n393 I1=n118 I2=n116
XU219 INV1S $PINS O=n337 I=n348
XU220 NR2 $PINS O=n650 I1=n126 I2=n124
XU221 NR2 $PINS O=n895 I1=n115 I2=n128
XU222 INV1S $PINS O=n127 I=n347
XU223 INV1S $PINS O=n124 I=n235
XU224 NR2 $PINS O=n432 I1=n124 I2=n130
XU225 INV1S $PINS O=n138 I=n212
XU226 NR2 $PINS O=n185 I1=n121 I2=n120
XU227 NR2 $PINS O=n786 I1=n128 I2=n124
XU228 NR2 $PINS O=n227 I1=n114 I2=n132
XU229 NR2 $PINS O=n789 I1=n126 I2=n130
XU230 NR2 $PINS O=n440 I1=n418 I2=n417
XU231 INV1S $PINS O=n26 I=n242
XU232 OAI222S $PINS O=n819 A1=n820 A2=n216 B1=n527 B2=n821 C1=n822 C2=n229
XU233 NR2 $PINS O=n821 I1=n127 I2=n706
XU234 NR2 $PINS O=n822 I1=n35 I2=n816
XU235 NR2 $PINS O=n820 I1=n51 I2=n815
XU236 NR2 $PINS O=n473 I1=n861 I2=n58
XU237 INV1S $PINS O=n109 I=n160
XU238 ND3 $PINS O=n815 I1=n323 I2=n166 I3=n814
XU239 NR3 $PINS O=n793 I1=n830 I2=n831 I3=n832
XU240 NR3 $PINS O=n795 I1=n796 I2=n797 I3=n798
XU241 AN4B1S $PINS O=n794 I1=n817 I2=n564 I3=n818 B1=n819
XU242 MAOI1 $PINS O=n805 A1=n114 A2=n813 B1=n154 B2=n814
XU243 AOI22S $PINS O=n804 A1=n138 A2=n815 B1=n131 B2=n816
XU244 AN4B1S $PINS O=n205 I1=n267 I2=n268 I3=n269 B1=n270
XU245 OAI222S $PINS O=n210 A1=n211 A2=n212 B1=n213 B2=n214 C1=n215 C2=n216
XU246 AN4B1S $PINS O=n211 I1=n167 I2=n217 I3=n218 B1=n219
XU247 ND3 $PINS O=n219 I1=n220 I2=n166 I3=n221
XU248 AN4B1S $PINS O=n610 I1=n249 I2=n1 I3=n63 B1=n430
XU249 AN4B1S $PINS O=n612 I1=n63 I2=n497 I3=n613 B1=n614
XU250 AN4B1S $PINS O=n611 I1=n471 I2=n317 I3=n516 B1=n60
XU251 ND3 $PINS O=shift2[3] I1=n601 I2=n602 I3=n603
XU252 NR2 $PINS O=n602 I1=n622 I2=n623
XU253 AN4B1S $PINS O=n603 I1=n604 I2=n605 I3=n606 B1=n607
XU254 NR3 $PINS O=n294 I1=n295 I2=n296 I3=n297
XU255 OAI222S $PINS O=n297 A1=n298 A2=n299 B1=n300 B2=n301 C1=n302 C2=n236
XU256 ND3 $PINS O=n296 I1=n303 I2=n304 I3=n305
XU257 ND3 $PINS O=n295 I1=n314 I2=n315 I3=n316
XU258 NR3 $PINS O=n320 I1=n321 I2=n37 I3=n322
XU259 ND3 $PINS O=n321 I1=n221 I2=n323 I3=n218
XU260 INV1S $PINS O=n56 I=n220
XU261 NR2 $PINS O=n400 I1=n62 I2=n56
XU262 NR3 $PINS O=n808 I1=n477 I2=n38 I3=n85
XU263 INV1S $PINS O=n24 I=n632
XU264 INV1S $PINS O=n93 I=n386
XU265 INV1S $PINS O=n97 I=n987
XU266 AN4B1S $PINS O=n885 I1=n697 I2=n886 I3=n887 B1=n522
XU267 AOI22S $PINS O=n884 A1=n116 A2=n65 B1=n132 B2=n20
XU268 NR2 $PINS O=n883 I1=n888 I2=n457
XU269 OAI112HS $PINS O=n457 A1=n716 B1=n889 C1=n193 C2=n28
XU270 OAI222S $PINS O=n830 A1=n256 A2=n301 B1=n599 B2=n92 C1=n825 C2=n345
XU271 INV1S $PINS O=n21 I=n401
XU272 AN4B1S $PINS O=n468 I1=n474 I2=n475 I3=n257 B1=n59
XU273 AN4B1S $PINS O=n470 I1=n471 I2=n472 I3=n473 B1=n37
XU274 AN4B1S $PINS O=n574 I1=n84 I2=n88 I3=n411 B1=n485
XU275 ND3 $PINS O=n576 I1=n221 I2=n146 I3=n400
XU276 AN4B1S $PINS O=n619 I1=n474 I2=n400 I3=n257 B1=n23
XU277 AN4B1S $PINS O=n620 I1=n621 I2=n150 I3=n473 B1=n18
XU278 OAI22S $PINS O=n736 A1=n737 A2=n147 B1=n738 B2=n216
XU279 AN4B1S $PINS O=n737 I1=n218 I2=n34 I3=n665 B1=n47
XU280 ND3 $PINS O=shift2[1] I1=n691 I2=n692 I3=n693
XU281 AN4B1S $PINS O=n692 I1=n730 I2=n75 I3=n731 B1=n732
XU282 NR3 $PINS O=n693 I1=n694 I2=n695 I3=n696
XU283 NR3 $PINS O=n691 I1=n734 I2=n735 I3=n736
XU284 OAI222S $PINS O=n797 A1=n625 A2=n236 B1=n803 B2=n172 C1=n73 C2=n424
XU285 NR3 $PINS O=n803 I1=n626 I2=n421 I3=n37
XU286 ND3 $PINS O=n626 I1=n167 I2=n338 I3=n613
XU287 AN4B1S $PINS O=n928 I1=n929 I2=n930 I3=n931 B1=n932
XU288 AN4B1S $PINS O=n927 I1=n940 I2=n941 I3=n942 B1=n943
XU289 AN4B1S $PINS O=n983 I1=n473 I2=n217 I3=n404 B1=n22
XU290 AN4B1S $PINS O=n635 I1=n636 I2=n540 I3=n637 B1=n355
XU291 ND3 $PINS O=n627 I1=n454 I2=n273 I3=n504
XU292 INV1S $PINS O=n25 I=n221
XU293 INV1S $PINS O=n96 I=n755
XU294 NR2 $PINS O=n969 I1=n565 I2=n429
XU295 INV1S $PINS O=n29 I=n257
XU296 NR2 $PINS O=n945 I1=n962 I2=n963
XU297 AN4B1S $PINS O=n946 I1=n947 I2=n948 I3=n949 B1=n950
XU298 AN4B1S $PINS O=n944 I1=n790 I2=n965 I3=n354 B1=n673
XU299 ND3 $PINS O=shift1[1] I1=n896 I2=n897 I3=n898
XU300 NR3 $PINS O=n897 I1=n916 I2=n917 I3=n918
XU301 NR3 $PINS O=n898 I1=n899 I2=n900 I3=n901
XU302 AN4B1S $PINS O=n896 I1=n919 I2=n637 I3=n920 B1=n672
XU303 OAI112HS $PINS O=n501 A1=n504 B1=n505 C1=n154 C2=n150
XU304 MOAI1S $PINS O=n856 A1=n857 A2=n299 B1=n135 B2=n858
XU305 AN4B1S $PINS O=n857 I1=n400 I2=n323 I3=n584 B1=n322
XU306 ND3 $PINS O=n858 I1=n343 I2=n473 I3=n859
XU307 ND3 $PINS O=shift1[2] I1=n839 I2=n840 I3=n841
XU308 AN4B1S $PINS O=n840 I1=n862 I2=n863 I3=n864 B1=n865
XU309 AN4B1S $PINS O=n839 I1=n537 I2=n648 I3=n791 B1=n878
XU310 AN4B1S $PINS O=n841 I1=n842 I2=n843 I3=n844 B1=n845
XU311 OAI112HS $PINS O=n878 A1=n273 B1=n879 C1=n624 C2=n147
XU312 AOI22S $PINS O=n879 A1=n418 A2=n880 B1=n417 B2=n609
XU313 ND3 $PINS O=n880 I1=n498 I2=n39 I3=n882
XU314 NR3 $PINS O=n882 I1=n46 I2=n93 I3=n87
XU315 MOAI1S $PINS O=n735 A1=n1 A2=n229 B1=n114 B2=n739
XU316 ND3 $PINS O=n739 I1=n740 I2=n401 I3=n741
XU317 ND3 $PINS O=shift3[3] I1=n433 I2=n434 I3=n435
XU318 NR2 $PINS O=n434 I1=n452 I2=n453
XU319 NR3 $PINS O=n435 I1=n436 I2=n437 I3=n438
XU320 AN4B1S $PINS O=n433 I1=n454 I2=n455 I3=n456 B1=n457
XU321 INV1S $PINS O=n61 I=n402
XU322 OAI222S $PINS O=n622 A1=n624 A2=n212 B1=n32 B2=n172 C1=n625 C2=n236
XU323 INV1S $PINS O=n32 I=n626
XU324 INV1S $PINS O=n53 I=n309
XU325 ND3 $PINS O=n696 I1=n505 I2=n456 I3=n561
XU326 AOI22S $PINS O=n461 A1=n136 A2=n476 B1=n337 B2=n477
XU327 NR3 $PINS O=n480 I1=n29 I2=n35 I3=n59
XU328 MOAI1S $PINS O=n607 A1=n608 A2=n248 B1=n609 B2=n137
XU329 AN4B1S $PINS O=n608 I1=n1 I2=n484 I3=n86 B1=n44
XU330 NR2 $PINS O=n616 I1=n128 I2=n125
XU331 NR2 $PINS O=n615 I1=n585 I2=n69
XU332 NR2 $PINS O=n617 I1=n618 I2=n19
XU333 OAI222S $PINS O=n377 A1=n378 A2=n229 B1=n379 B2=n216 C1=n380 C2=n335
XU334 NR2 $PINS O=n380 I1=n35 I2=n381
XU335 NR2 $PINS O=n378 I1=n52 I2=n18
XU336 NR2 $PINS O=n379 I1=n382 I2=n19
XU337 AN4B1S $PINS O=n373 I1=n374 I2=n375 I3=n376 B1=n377
XU338 INV1S $PINS O=n35 I=n146
XU339 INV1S $PINS O=n72 I=n422
XU340 NR2 $PINS O=n498 I1=n31 I2=n82
XU341 NR2 $PINS O=n960 I1=n47 I2=n449
XU342 MOAI1S $PINS O=n865 A1=n235 A2=n213 B1=n137 B2=n866
XU343 ND3 $PINS O=n866 I1=n84 I2=n450 I3=n867
XU344 NR2 $PINS O=n867 I1=n496 I2=n534
XU345 AOI22S $PINS O=n863 A1=n419 A2=n871 B1=n134 B2=n872
XU346 ND3 $PINS O=n871 I1=n484 I2=n249 I3=n873
XU347 NR3 $PINS O=n873 I1=n51 I2=n87 I3=n33
XU348 ND3 $PINS O=n336 I1=n776 I2=n389 I3=n837
XU349 NR3 $PINS O=n837 I1=n767 I2=n93 I3=n53
XU350 ND3 $PINS O=n548 I1=n549 I2=n550 I3=n551
XU351 AOI22S $PINS O=n549 A1=n115 A2=n78 B1=n56 B2=n132
XU352 AOI22S $PINS O=n550 A1=n124 A2=n71 B1=n128 B2=n572
XU353 NR3 $PINS O=n551 I1=n552 I2=n553 I3=n539
XU354 INV1S $PINS O=n60 I=n621
XU355 INV1S $PINS O=n27 I=n702
XU356 MOAI1S $PINS O=n705 A1=n28 A2=n193 B1=n429 B2=n706
XU357 OAI12HS $PINS O=n704 A1=n304 B1=n707 B2=n345
XU358 NR2 $PINS O=n595 I1=n422 I2=n565
XU359 NR2 $PINS O=n392 I1=n306 I2=n422
XU360 NR2 $PINS O=n838 I1=n46 I2=n449
XU361 OAI112HS $PINS O=n950 A1=n952 B1=n720 C1=n951 C2=n229
XU362 OAI12HS $PINS O=n952 A1=n138 B1=n43 B2=n344
XU363 NR2 $PINS O=n951 I1=n29 I2=n44
XU364 OA22 $PINS O=n887 A1=n67 A2=n391 B1=n311 B2=n392
XU365 ND3 $PINS O=shift3[1] I1=n506 I2=n507 I3=n508
XU366 AN4B1S $PINS O=n506 I1=n536 I2=n537 I3=n538 B1=n539
XU367 NR2 $PINS O=n507 I1=n525 I2=n526
XU368 AN4B1S $PINS O=n508 I1=n509 I2=n510 I3=n511 B1=n512
XU369 NR3 $PINS O=n510 I1=n521 I2=n522 I3=n523
XU370 AOI13HS $PINS O=n521 A1=n348 B1=n86 B2=n176 B3=n39
XU371 OAI222S $PINS O=n512 A1=n513 A2=n147 B1=n514 B2=n212 C1=n515 C2=n229
XU372 AN4B1S $PINS O=n513 I1=n404 I2=n256 I3=n472 B1=n42
XU373 AN4B1S $PINS O=n515 I1=n218 I2=n516 I3=n451 B1=n53
XU374 OR2 $PINS O=n2 I1=n79 I2=n204
XU375 INV1S $PINS O=n565 I=n2
XU376 NR2 $PINS O=n668 I1=n851 I2=n79
XU377 INV1S $PINS O=n23 I=n163
XU378 INV1S $PINS O=n58 I=n953
XU379 INV1S $PINS O=n91 I=n444
XU380 NR3 $PINS O=n349 I1=n3 I2=n4 I3=n5
XU381 OAI22S $PINS O=n3 A1=n64 A2=n432 B1=n80 B2=n238
XU382 AO22 $PINS O=n4 A1=n418 A2=n430 B1=n132 B2=n431
XU383 OAI112HS $PINS O=n5 A1=n267 B1=n420 C1=n257 C2=n229
XU384 ND3 $PINS O=n749 I1=n759 I2=n760 I3=n761
XU385 AOI22S $PINS O=n759 A1=n135 A2=n339 B1=n417 B2=n766
XU386 AOI22S $PINS O=n760 A1=n113 A2=n764 B1=n131 B2=n765
XU387 ND3 $PINS O=shift2[0] I1=n746 I2=n747 I3=n748
XU388 NR3 $PINS O=n746 I1=n779 I2=n503 I3=n780
XU389 NR3 $PINS O=n747 I1=n768 I2=n769 I3=n770
XU390 NR3 $PINS O=n748 I1=n749 I2=n750 I3=n751
XU391 NR2 $PINS O=n370 I1=n112 I2=n111
XU392 INV1S $PINS O=n50 I=n166
XU393 NR2 $PINS O=n823 I1=n79 I2=n100
XU394 NR2 $PINS O=n175 I1=n111 I2=n149
XU395 ND3 $PINS O=shift2[2] I1=n651 I2=n652 I3=n653
XU396 AN4B1S $PINS O=n653 I1=n654 I2=n655 I3=n656 B1=n657
XU397 NR3 $PINS O=n651 I1=n671 I2=n672 I3=n673
XU398 INV1S $PINS O=n45 I=n176
XU399 ND3 $PINS O=n352 I1=n676 I2=n677 I3=n678
XU400 AN4B1S $PINS O=n678 I1=n679 I2=n680 I3=n681 B1=n682
XU401 INV1S $PINS O=n48 I=n323
XU402 ND3 $PINS O=n779 I1=n790 I2=n791 I3=n792
XU403 MOAI1S $PINS O=n408 A1=n409 A2=n147 B1=n419 B2=n410
XU404 ND3 $PINS O=n410 I1=n411 I2=n177 I3=n412
XU406 OR2 $PINS O=n6 I1=n79 I2=n974
XU407 INV1S $PINS O=n306 I=n6
XU408 INV1S $PINS O=n88 I=n767
XU409 ND3 $PINS O=n208 I1=n224 I2=n225 I3=n226
XU410 AOI22S $PINS O=n224 A1=n135 A2=n239 B1=n419 B2=n240
XU411 AOI22S $PINS O=n225 A1=n232 A2=n69 B1=n233 B2=n234
XU412 AN2 $PINS O=n230 I1=n88 I2=n442
XU413 NR2 $PINS O=n167 I1=n52 I2=n48
XU414 ND3 $PINS O=n503 I1=n782 I2=n783 I3=n784
XU415 OA22 $PINS O=n782 A1=n77 A2=n789 B1=n64 B2=n424
XU416 AOI22S $PINS O=n563 A1=n566 A2=n134 B1=n113 B2=n567
XU417 MOAI1S $PINS O=n333 A1=n334 A2=n335 B1=n336 B2=n134
XU418 AN4B1S $PINS O=n334 I1=n1 I2=n338 I3=n177 B1=n339
XU419 AOI22S $PINS O=n244 A1=n131 A2=n255 B1=n58 B2=n114
XU420 ND3 $PINS O=n255 I1=n256 I2=n257 I3=n258
XU421 MOAI1S $PINS O=n769 A1=n174 A2=n6 B1=n132 B2=n774
XU422 ND3 $PINS O=n774 I1=n517 I2=n472 I3=n439
XU423 ND3 $PINS O=n265 I1=n338 I2=n28 I3=n221
XU424 MOAI1S $PINS O=n559 A1=n217 A2=n154 B1=n71 B2=n115
XU425 OAI22S $PINS O=n396 A1=n397 A2=n154 B1=n398 B2=n299
XU426 AN4B1S $PINS O=n398 I1=n399 I2=n343 I3=n400 B1=n38
XU427 AN4B1S $PINS O=n397 I1=n401 I2=n28 I3=n402 B1=n403
XU428 ND3 $PINS O=n403 I1=n256 I2=n167 I3=n404
XU429 NR2 $PINS O=n450 I1=n45 I2=n52
XU430 AOI22S $PINS O=n545 A1=n134 A2=n33 B1=n114 B2=n578
XU431 ND3 $PINS O=n578 I1=n218 I2=n163 I3=n34
XU432 OA22 $PINS O=n862 A1=n874 A2=n348 B1=n875 B2=n229
XU433 NR3 $PINS O=n874 I1=n877 I2=n265 I3=n37
XU434 AN4B1S $PINS O=n875 I1=n876 I2=n472 I3=n647 B1=n49
XU435 ND3 $PINS O=n877 I1=n260 I2=n242 I3=n400
XU436 NR2 $PINS O=n522 I1=n313 I2=n415
XU437 AOI22S $PINS O=n713 A1=n136 A2=n723 B1=n125 B2=n585
XU438 OA12 $PINS O=n714 A1=n720 B1=n719 B2=n81
XU439 AN2 $PINS O=n272 I1=n686 I2=n687
XU440 AOI22S $PINS O=n686 A1=n116 A2=n306 B1=n56 B2=n136
XU441 NR2 $PINS O=n689 I1=n123 I2=n115
XU442 INV1S $PINS O=n429 I=n7
XU443 ND3 $PINS O=n932 I1=n933 I2=n304 I3=n934
XU444 OAI12HS $PINS O=n934 A1=n122 B1=n38 B2=n861
XU445 OAI222S $PINS O=n482 A1=n345 A2=n221 B1=n483 B2=n231 C1=n172 C2=n338
XU446 AN4B1S $PINS O=n483 I1=n484 I2=n146 I3=n89 B1=n485
XU447 NR2 $PINS O=n412 I1=n36 I2=n500
XU448 MOAI1S $PINS O=n780 A1=n388 A2=n311 B1=n138 B2=n781
XU449 ND3 $PINS O=n781 I1=n474 I2=n256 I3=n575
XU450 NR2 $PINS O=n177 I1=n767 I2=n82
XU451 OA22 $PINS O=n636 A1=n600 A2=n81 B1=n72 B2=n424
XU452 OAI112HS $PINS O=n502 A1=n799 B1=n800 C1=n646 C2=n594
XU453 OA22 $PINS O=n800 A1=n426 A2=n801 B1=n191 B2=n560
XU454 OA12 $PINS O=n799 A1=n697 B1=n318 B2=n178
XU455 NR2 $PINS O=n264 I1=n500 I2=n48
XU456 AN2 $PINS O=n562 I1=n674 I2=n675
XU457 AOI22S $PINS O=n674 A1=n23 A2=n122 B1=n82 B2=n134
XU458 ND3 $PINS O=n860 I1=n597 I2=n96 I3=n329
XU459 AN4B1S $PINS O=n762 I1=n442 I2=n411 I3=n533 B1=n48
XU460 OAI22S $PINS O=n888 A1=n191 A2=n77 B1=n178 B2=n7
XU461 NR2 $PINS O=n298 I1=n18 I2=n62
XU462 NR2 $PINS O=n519 I1=n422 I2=n823
XU463 NR2 $PINS O=n585 I1=n79 I2=n894
XU464 OA22 $PINS O=n579 A1=n589 A2=n147 B1=n426 B2=n80
XU465 AN4B1S $PINS O=n589 I1=n220 I2=n257 I3=n590 B1=n23
XU466 NR2 $PINS O=n876 I1=n46 I2=n62
XU467 NR2 $PINS O=n560 I1=n823 I2=n467
XU468 OAI222S $PINS O=n481 A1=n486 A2=n335 B1=n487 B2=n488 C1=n489 C2=n248
XU469 NR3 $PINS O=n487 I1=n494 I2=n495 I3=n496
XU470 NR3 $PINS O=n489 I1=n490 I2=n491 I3=n492
XU471 INV1S $PINS O=n106 I=n894
XU472 INV1S $PINS O=n102 I=n974
XU473 NR3 $PINS O=n977 I1=n980 I2=n201 I3=n979
XU474 AN4B1S $PINS O=n978 I1=n688 I2=n415 I3=n95 B1=n189
XU475 ND3 $PINS O=n980 I1=n600 I2=n415 I3=n99
XU476 OA22 $PINS O=n354 A1=n299 A2=n166 B1=n266 B2=n348
XU477 NR2 $PINS O=n663 I1=n467 I2=n565
XU478 AN2 $PINS O=n661 I1=n664 I2=n524
XU479 AN2 $PINS O=n662 I1=n389 I2=n475
XU480 OAI22S $PINS O=n770 A1=n771 A2=n229 B1=n772 B2=n299
XU481 AN4B1S $PINS O=n772 I1=n584 I2=n741 I3=n400 B1=n37
XU482 AN4B1S $PINS O=n771 I1=n773 I2=n404 I3=n257 B1=n51
XU483 NR2 $PINS O=n666 I1=n668 I2=n306
XU484 NR2 $PINS O=n667 I1=n50 I2=n87
XU485 AN4B1S $PINS O=n351 I1=n76 I2=n353 I3=n354 B1=n355
XU486 MOAI1S $PINS O=n332 A1=n340 A2=n147 B1=n419 B2=n341
XU487 AN4B1S $PINS O=n340 I1=n217 I2=n343 I3=n1 B1=n344
XU488 ND3 $PINS O=n341 I1=n63 I2=n254 I3=n342
XU489 OAI222S $PINS O=n331 A1=n345 A2=n221 B1=n346 B2=n347 C1=n220 C2=n348
XU490 ND3 $PINS O=n436 I1=n445 I2=n304 I3=n446
XU491 AOI22S $PINS O=n446 A1=n136 A2=n447 B1=n419 B2=n448
XU492 OR2 $PINS O=n448 I1=n449 I2=n52
XU493 OAI22S $PINS O=n657 A1=n658 A2=n335 B1=n659 B2=n147
XU494 AN4B1S $PINS O=n658 I1=n230 I2=n260 I3=n217 B1=n85
XU495 NR3 $PINS O=n659 I1=n660 I2=n59 I3=n20
XU496 NR2 $PINS O=n690 I1=n82 I2=n45
XU497 OAI222S $PINS O=n750 A1=n256 A2=n301 B1=n67 B2=n319 C1=n594 C2=n2
XU498 AOI22S $PINS O=n305 A1=n306 A2=n307 B1=n138 B2=n308
XU499 INV1S $PINS O=n63 I=n500
XU500 OAI222S $PINS O=n962 A1=n178 A2=n67 B1=n595 B2=n426 C1=n630 C2=n319
XU501 OAI222S $PINS O=n901 A1=n902 A2=n147 B1=n903 B2=n154 C1=n904 C2=n348
XU502 NR2 $PINS O=n902 I1=n21 I2=n53
XU503 NR2 $PINS O=n903 I1=n18 I2=n36
XU504 AN2 $PINS O=n904 I1=n533 I2=n217
XU505 MOAI1S $PINS O=n832 A1=n754 A2=n313 B1=n126 B2=n833
XU506 NR3 $PINS O=n342 I1=n90 I2=n91 I3=n767
XU507 ND3 $PINS O=n899 I1=n909 I2=n910 I3=n911
XU508 OA22 $PINS O=n909 A1=n227 A2=n217 B1=n174 B2=n588
XU509 AOI22S $PINS O=n910 A1=n418 A2=n914 B1=n8 B2=n915
XU510 OAI222S $PINS O=n209 A1=n222 A2=n2 B1=n86 B2=n172 C1=n92 C2=n223
XU511 INV1S $PINS O=n80 I=n467
XU512 MOAI1S $PINS O=n553 A1=n313 A2=n802 B1=n122 B2=n58
XU513 AOI22S $PINS O=n420 A1=n337 A2=n421 B1=n422 B2=n198
XU514 INV1S $PINS O=n101 I=n204
XU515 AN2 $PINS O=n599 I1=n312 I2=n518
XU516 OAI22S $PINS O=n170 A1=n171 A2=n172 B1=n173 B2=n174
XU517 NR2 $PINS O=n173 I1=n175 I2=n106
XU518 AN4B1S $PINS O=n171 I1=n176 I2=n150 I3=n177 B1=n62
XU519 MOAI1S $PINS O=n582 A1=n335 A2=n412 B1=n137 B2=n583
XU520 ND3 $PINS O=n583 I1=n254 I2=n533 I3=n39
XU521 OAI222S $PINS O=n591 A1=n81 A2=n99 B1=n520 B2=n238 C1=n596 C2=n92
XU522 AN4B1S $PINS O=n596 I1=n597 I2=n96 I3=n223 B1=n598
XU523 ND3 $PINS O=n598 I1=n599 I2=n600 I3=n98
XU524 OAI222S $PINS O=n526 A1=n527 A2=n347 B1=n70 B2=n222 C1=n248 C2=n386
XU525 INV1S $PINS O=n70 I=n528
XU526 NR2 $PINS O=n260 I1=n53 I2=n52
XU527 AOI22S $PINS O=n818 A1=n826 A2=n827 B1=n828 B2=n528
XU528 ND3 $PINS O=n827 I1=n95 I2=n688 I3=n754
XU529 MOAI1S $PINS O=n568 A1=n423 A2=n67 B1=n418 B2=n571
XU530 ND3 $PINS O=n766 I1=n177 I2=n664 I3=n535
XU531 INV1S $PINS O=n90 I=n664
XU532 INV1S $PINS O=n105 I=n851
XU533 ND3 $PINS O=n532 I1=n450 I2=n533 I3=n266
XU534 OAI222S $PINS O=n916 A1=n346 A2=n235 B1=n388 B2=n191 C1=n229 C2=n402
XU535 OAI112HS $PINS O=n464 A1=n466 B1=n427 C1=n465 C2=n236
XU536 OAI12HS $PINS O=n466 A1=n128 B1=n467 B2=n234
XU537 OA22 $PINS O=n315 A1=n231 A2=n324 B1=n222 B2=n325
XU538 OA22 $PINS O=n414 A1=n92 A2=n415 B1=n319 B2=n7
XU539 AOI22S $PINS O=n413 A1=n119 A2=n306 B1=n128 B2=n69
XU540 ND3 $PINS O=n201 I1=n597 I2=n157 I3=n599
XU541 OAI222S $PINS O=n394 A1=n6 A2=n214 B1=n174 B2=n72 C1=n1 C2=n348
XU542 ND3 $PINS O=n499 I1=n442 I2=n166 I3=n266
XU543 OA22 $PINS O=n581 A1=n236 A2=n465 B1=n216 B2=n584
XU544 NR2 $PINS O=n577 I1=n894 I2=FE_OFN126_fold_n_0
XU545 OAI222S $PINS O=n751 A1=n752 A2=n92 B1=n753 B2=n81 C1=n313 C2=n600
XU546 NR3 $PINS O=n752 I1=n756 I2=n757 I3=n758
XU547 AN4B1S $PINS O=n753 I1=n518 I2=n754 I3=n223 B1=n755
XU548 ND3 $PINS O=n756 I1=n158 I2=n96 I3=n518
XU549 MOAI1S $PINS O=n593 A1=n519 A2=n214 B1=n31 B2=n418
XU550 MOAI1S $PINS O=n963 A1=n92 A2=n158 B1=n122 B2=n58
XU551 MOAI1S $PINS O=n355 A1=n638 A2=n313 B1=n123 B2=n565
XU552 OA22 $PINS O=n648 A1=n391 A2=n64 B1=n638 B2=n81
XU553 NR2 $PINS O=n249 I1=n82 I2=n90
XU554 MOAI1S $PINS O=n732 A1=n733 A2=n488 B1=n30 B2=n337
XU555 NR2 $PINS O=n733 I1=n51 I2=n491
XU556 OA22 $PINS O=n245 A1=n92 A2=n518 B1=n174 B2=n67
XU557 MOAI1S $PINS O=n558 A1=n313 A2=n99 B1=n306 B2=n129
XU558 NR2 $PINS O=n850 I1=n108 I2=n102
XU559 NR2 $PINS O=n644 I1=n467 I2=n306
XU560 AOI22S $PINS O=n790 A1=n131 A2=n52 B1=n306 B2=n116
XU561 INV1S $PINS O=n85 I=n338
XU562 ND3 $PINS O=n672 I1=n921 I2=n541 I3=n922
XU563 AOI22S $PINS O=n921 A1=n126 A2=n823 B1=n337 B2=n91
XU564 NR2 $PINS O=n923 I1=n120 I2=n116
XU565 NR2 $PINS O=n465 I1=n422 I2=n585
XU566 OA22 $PINS O=n541 A1=n92 A2=n597 B1=n81 B2=n688
XU567 OAI22S $PINS O=n438 A1=n439 A2=n212 B1=n386 B2=n440
XU568 MOAI1S $PINS O=n453 A1=n231 A2=n338 B1=n132 B2=n21
XU569 INV1S $PINS O=n991 I=n286
XU570 MOAI1S $PINS O=n437 A1=n441 A2=n442 B1=n134 B2=n443
XU571 NR2 $PINS O=n441 I1=n137 I2=n418
XU572 OR2 $PINS O=n965 I1=n348 I2=n442
XU573 MOAI1S $PINS O=n452 A1=n214 A2=n80 B1=n46 B2=n418
XU574 INV1S $PINS O=n128 I=n311
XU575 INV1S $PINS O=n126 I=n391
XU576 INV1S $PINS O=n123 I=n174
XU577 ND2 $PINS O=n594 I1=n936 I2=n964
XU578 INV1S $PINS O=n992 I=n954
XU579 INV1S $PINS O=n136 I=n229
XU580 MOAI1S $PINS O=n917 A1=n7 A2=n391 B1=n306 B2=n129
XU581 ND3 $PINS O=n829 I1=n850 I2=n851 I3=n852
XU582 NR2 $PINS O=n852 I1=n160 I2=n101
XU583 INV1S $PINS O=n132 I=n345
XU584 ND2 $PINS O=n235 I1=n360 I2=n935
XU585 INV1S $PINS O=n134 I=n248
XU586 ND2 $PINS O=n424 I1=n912 I2=n360
XU587 ND2 $PINS O=n348 I1=n291 I2=n954
XU588 INV1S $PINS O=n119 I=n238
XU589 INV1S $PINS O=n118 I=n319
XU590 INV1S $PINS O=n130 I=n214
XU591 ND2 $PINS O=n347 I1=n908 I2=n964
XU592 NR2 $PINS O=n367 I1=n149 I2=n991
XU593 ND2 $PINS O=n212 I1=n291 I2=n286
XU594 INV1S $PINS O=n418 I=n172
XU595 AOI22S $PINS O=n142 A1=n122 A2=n168 B1=n121 B2=n106
XU596 INV1S $PINS O=n419 I=n488
XU597 INV1S $PINS O=n113 I=n216
XU598 INV1S $PINS O=n120 I=n178
XU599 INV1S $PINS O=n114 I=n299
XU600 INV1S $PINS O=n131 I=n147
XU601 INV1S $PINS O=n417 I=n335
XU602 INV1S $PINS O=n135 I=n154
XU603 INV1S $PINS O=n137 I=n231
XU604 NR2 $PINS O=n160 I1=n111 I2=n203
XU605 INV1S $PINS O=n111 I=n_idx[1]
XU606 NR2 $PINS O=n961 I1=n110 I2=n_idx[1]
XU607 NR2 $PINS O=n811 I1=n279 I2=n25
XU608 NR3 $PINS O=n812 I1=n763 I2=n55 I3=n41
XU609 ND3 $PINS O=n477 I1=n162 I2=n444 I3=n810
XU610 AN2 $PINS O=n810 I1=n647 I2=n24
XU611 NR2 $PINS O=n987 I1=n149 I2=n_idx[1]
XU612 AN4B1S $PINS O=n807 I1=n664 I2=n162 I3=n217 B1=n609
XU614 OAI222S $PINS O=n734 A1=n742 A2=n248 B1=n743 B2=n335 C1=n744 C2=n231
XU615 AN4B1S $PINS O=n742 I1=n84 I2=n177 I3=n478 B1=n745
XU616 AN4B1S $PINS O=n743 I1=n88 I2=n613 I3=n324 B1=n52
XU617 AN4B1S $PINS O=n744 I1=n664 I2=n493 I3=n613 B1=n496
XU618 INV1S $PINS O=n62 I=n253
XU619 ND2 $PINS O=n221 I1=n989 I2=n_idx[0]
XU620 NR2 $PINS O=n257 I1=n279 I2=n58
XU621 OAI112HS $PINS O=n943 A1=n792 B1=n920 C1=n248 C2=n778
XU622 NR2 $PINS O=n755 I1=n97 I2=n_idx[0]
XU623 AN2 $PINS O=n540 I1=n639 I2=n640
XU624 AOI22S $PINS O=n639 A1=n642 A2=n643 B1=n26 B2=n122
XU625 AOI22S $PINS O=n640 A1=n326 A2=n641 B1=n114 B2=n20
XU626 ND3 $PINS O=n641 I1=n415 I2=n94 I3=n107
XU627 AN4B1S $PINS O=n844 I1=n853 I2=n854 I3=n855 B1=n856
XU628 AOI22S $PINS O=n853 A1=n129 A2=n65 B1=n565 B2=n115
XU629 AOI22S $PINS O=n855 A1=n326 A2=n860 B1=n118 B2=n306
XU630 AOI22S $PINS O=n854 A1=n122 A2=n861 B1=n128 B2=n668
XU631 OAI22S $PINS O=n246 A1=n156 A2=n28 B1=n247 B2=n248
XU632 ND3 $PINS O=n250 I1=n252 I2=n253 I3=n254
XU633 NR3 $PINS O=n985 I1=n111 I2=n110 I3=n40
XU634 NR2 $PINS O=n422 I1=n79 I2=n181
XU635 OAI22S $PINS O=n552 A1=n628 A2=n348 B1=n629 B2=n222
XU636 NR2 $PINS O=n629 I1=n422 I2=n68
XU637 NR3 $PINS O=n628 I1=n631 I2=n26 I3=n632
XU638 NR2 $PINS O=n516 I1=n20 I2=n279
XU639 INV1S $PINS O=n79 I=n194
XU640 INV1S $PINS O=n28 I=n279
XU641 AN4B1S $PINS O=n975 I1=n252 I2=n444 I3=n406 B1=n500
XU642 OAI222S $PINS O=n525 A1=n529 A2=n335 B1=n530 B2=n488 C1=n531 C2=n231
XU643 NR3 $PINS O=n529 I1=n534 I2=n491 I3=n42
XU644 AN4B1S $PINS O=n530 I1=n493 I2=n444 I3=n442 B1=n382
XU645 AN2 $PINS O=n939 I1=n958 I2=n112
XU646 NR3 $PINS O=n729 I1=n59 I2=n279 I3=n53
XU647 ND3 $PINS O=n694 I1=n724 I2=n725 I3=n726
XU648 AOI22S $PINS O=n724 A1=n119 A2=n71 B1=n130 B2=n78
XU649 AOI22S $PINS O=n725 A1=n138 A2=n727 B1=n123 B2=n728
XU650 OAI222S $PINS O=n768 A1=n775 A2=n488 B1=n24 B2=n348 C1=n776 C2=n231
XU651 NR3 $PINS O=n775 I1=n777 I2=n41 I3=n496
XU652 ND3 $PINS O=n777 I1=n493 I2=n778 I3=n241
XU653 OAI22S $PINS O=n831 A1=n835 A2=n335 B1=n836 B2=n488
XU654 NR2 $PINS O=n835 I1=n496 I2=n336
XU655 AN2 $PINS O=n836 I1=n253 I2=n809
XU656 AOI22S $PINS O=n864 A1=n138 A2=n868 B1=n113 B2=n869
XU657 ND3 $PINS O=n869 I1=n34 I2=n621 I3=n516
XU658 ND3 $PINS O=n868 I1=n439 I2=n517 I3=n870
XU659 NR3 $PINS O=n870 I1=n18 I2=n279 I3=n51
XU660 INV1S $PINS O=n52 I=n162
XU661 ND3 $PINS O=n338 I1=n_idx[1] I2=n110 I3=n939
XU662 ND3 $PINS O=n533 I1=n958 I2=n110 I3=n370
XU663 ND3 $PINS O=n442 I1=n111 I2=n110 I3=n939
XU664 AOI22S $PINS O=n314 A1=n126 A2=n65 B1=n326 B2=n327
XU665 ND3 $PINS O=n327 I1=n328 I2=n329 I3=n330
XU666 AN2 $PINS O=n330 I1=n158 I2=n312
XU667 AN4B1S $PINS O=n155 I1=n157 I2=n158 I3=n159 B1=n160
XU668 NR3 $PINS O=n153 I1=n161 I2=n21 I3=n47
XU669 ND3 $PINS O=n161 I1=n162 I2=n28 I3=n163
XU670 ND3 $PINS O=sign3[1] I1=n139 I2=n140 I3=n141
XU671 NR2 $PINS O=n139 I1=n183 I2=n184
XU672 NR2 $PINS O=n140 I1=n169 I2=n170
XU673 AN4B1S $PINS O=n141 I1=n142 I2=n143 I3=n144 B1=n145
XU674 AOI22S $PINS O=n949 A1=n419 A2=n956 B1=n134 B2=n957
XU675 ND3 $PINS O=n490 I1=n493 I2=n386 I3=n254
XU676 INV1S $PINS O=n82 I=n778
XU677 ND3 $PINS O=n900 I1=n75 I2=n304 I3=n905
XU678 AOI22S $PINS O=n905 A1=n643 A2=n906 B1=n422 B2=n907
XU679 INV1S $PINS O=n108 I=n181
XU680 NR2 $PINS O=n938 I1=n113 I2=n417
XU681 INV1S $PINS O=n104 I=n758
XU682 AN2 $PINS O=n937 I1=n401 I2=n343
XU683 OA12 $PINS O=n467 A1=n194 B1=n105 B2=n106
XU684 AOI22S $PINS O=n680 A1=n138 A2=n683 B1=n418 B2=n684
XU685 AN2 $PINS O=n269 I1=n925 I2=n926
XU686 AOI22S $PINS O=n925 A1=n326 A2=n642 B1=n25 B2=n114
XU687 ND3 $PINS O=n664 I1=n_idx[0] I2=n961 I3=n958
XU688 NR2 $PINS O=n278 I1=n890 I2=n991
XU689 OAI112HS $PINS O=n277 A1=n289 B1=n290 C1=k_idx[2] C2=n203
XU690 OA22 $PINS O=n791 A1=n891 A2=n79 B1=n98 B2=n313
XU691 NR2 $PINS O=n891 I1=n892 I2=n893
XU692 OAI222S $PINS O=n893 A1=n109 A2=n319 B1=n570 B2=n204 C1=n178 C2=n181
XU693 OAI222S $PINS O=n892 A1=n117 A2=n894 B1=n895 B2=n100 C1=n850 C2=n391
XU694 ND3 $PINS O=n845 I1=n846 I2=n720 I3=n847
XU695 ND3 $PINS O=n846 I1=n194 I2=n829 I3=n119
XU696 AOI22S $PINS O=n847 A1=n8 A2=n848 B1=n116 B2=n849
XU697 OA12 $PINS O=n159 A1=n17 B1=n109 B2=n112
XU698 AOI22S $PINS O=n843 A1=n74 A2=n199 B1=n643 B2=n189
XU699 OAI222S $PINS O=n183 A1=n190 A2=n191 B1=n192 B2=n193 C1=n194 C2=n195
XU700 AN2 $PINS O=n190 I1=n203 I2=n204
XU701 AN2 $PINS O=n195 I1=n185 I2=n152
XU702 NR2 $PINS O=n192 I1=n201 I2=n202
XU703 AN2 $PINS O=n8 I1=n186 I2=n17
XU704 INV1S $PINS O=n313 I=n8
XU705 INV1S $PINS O=n81 I=n643
XU706 ND3 $PINS O=n745 I1=n146 I2=n162 I3=n338
XU707 AOI22S $PINS O=n143 A1=n114 A2=n164 B1=n417 B2=n91
XU708 NR2 $PINS O=n286 I1=n16 I2=n15
XU709 NR2 $PINS O=n936 I1=n991 I2=n133
XU710 NR2 $PINS O=n360 I1=n890 I2=n14
XU711 OAI12HS $PINS O=n276 A1=n180 B1=n133 B2=n357
XU712 OA22 $PINS O=n359 A1=n17 A2=n360 B1=n97 B2=n286
XU713 ND3 $PINS O=n356 I1=n361 I2=n362 I3=n363
XU714 ND3 $PINS O=n361 I1=n188 I2=n991 I3=n368
XU715 ND3 $PINS O=n362 I1=n366 I2=n17 I3=n367
XU716 INV1S $PINS O=n92 I=n326
XU717 AN2 $PINS O=n291 I1=n287 I2=n890
XU718 ND2 $PINS O=n174 I1=n369 I2=n936
XU719 ND3 $PINS O=n193 I1=n15 I2=n16 I3=n955
XU720 ND3 $PINS O=n345 I1=n286 I2=n133 I3=n360
XU721 AN2 $PINS O=n908 I1=k_idx[3] I2=n973
XU722 NR2 $PINS O=n964 I1=n890 I2=k_idx[2]
XU723 AN2 $PINS O=n935 I1=n973 I2=n15
XU724 NR2 $PINS O=n954 I1=n16 I2=k_idx[3]
XU725 NR2 $PINS O=n912 I1=n992 I2=n133
XU726 ND2 $PINS O=n229 I1=n954 I2=n955
XU727 OAI112HS $PINS O=n202 A1=n109 B1=n17 C1=n203 C2=n112
XU728 ND3 $PINS O=n817 I1=n123 I2=n829 I3=n194
XU729 ND2 $PINS O=n178 I1=n936 I2=n913
XU730 ND3 $PINS O=n248 I1=k_idx[3] I2=n16 I3=n955
XU731 ND3 $PINS O=n231 I1=k_idx[3] I2=n16 I3=n291
XU732 ND2 $PINS O=n319 I1=n912 I2=n369
XU733 ND2 $PINS O=n238 I1=n912 I2=n913
XU734 ND2 $PINS O=n154 I1=n955 I2=n286
XU735 ND3 $PINS O=n156 I1=n913 I2=n15 I3=n959
XU736 ND2 $PINS O=n214 I1=n908 I2=n369
XU737 ND3 $PINS O=n289 I1=n133 I2=n890 I3=n160
XU738 ND3 $PINS O=n172 I1=n360 I2=n15 I3=n959
XU739 ND3 $PINS O=n488 I1=n360 I2=k_idx[3] I3=n959
XU740 ND3 $PINS O=n216 I1=n360 I2=n133 I3=n954
XU741 ND2 $PINS O=n191 I1=n369 I2=n935
XU742 ND3 $PINS O=n299 I1=n913 I2=n133 I3=n286
XU743 ND3 $PINS O=n147 I1=n913 I2=n133 I3=n954
XU744 ND3 $PINS O=n335 I1=k_idx[3] I2=n913 I3=n959
XU745 NR2 $PINS O=n989 I1=n109 I2=n_idx[4]
XU746 ND3 $PINS O=sign3[0] I1=n205 I2=n206 I3=n207
XU747 AN4B1S $PINS O=n206 I1=n243 I2=n244 I3=n245 B1=n246
XU748 NR3 $PINS O=n207 I1=n208 I2=n209 I3=n210
XU750 ND3 $PINS O=sign2[0] I1=n292 I2=n293 I3=n294
XU751 NR3 $PINS O=n293 I1=n331 I2=n332 I3=n333
XU752 AN4B1S $PINS O=n292 I1=n349 I2=n350 I3=n351 B1=n352
XU753 NR2 $PINS O=n986 I1=n181 I2=n_idx[4]
XU754 NR2 $PINS O=n165 I1=n97 I2=n_idx[4]
XU755 INV1S $PINS O=n103 I=n_idx[3]
XU756 INV1S $PINS O=n110 I=n_idx[2]
XU757 NR2 $PINS O=n984 I1=n204 I2=n_idx[4]
XU758 NR2 $PINS O=n990 I1=n103 I2=n_idx[2]
XU760 ND3 $PINS O=n253 I1=n987 I2=n112 I3=n_idx[4]
XU761 NR2 $PINS O=n988 I1=n974 I2=n_idx[4]
XU762 NR3 $PINS O=n976 I1=n_idx[1] I2=n_idx[2] I3=n112
XU763 NR2 $PINS O=n280 I1=n_idx[4] I2=n_idx[3]
XU764 ND3 $PINS O=sign1[0] I1=n371 I2=n372 I3=n373
XU765 NR3 $PINS O=n372 I1=n394 I2=n395 I3=n396
XU766 NR3 $PINS O=n371 I1=n407 I2=n270 I3=n408
XU767 NR2 $PINS O=n194 I1=n_idx[0] I2=n_idx[4]
XU768 NR2 $PINS O=n958 I1=n103 I2=n_idx[4]
XU769 NR2 $PINS O=n970 I1=n_idx[2] I2=n_idx[0]
XU770 NR2 $PINS O=n981 I1=n110 I2=n_idx[3]
XU771 ND3 $PINS O=n493 I1=n958 I2=n_idx[2] I3=n370
XU772 MOAI1S $PINS O=n145 A1=n146 A2=n147 B1=n132 B2=n148
XU773 OAI112HS $PINS O=n148 A1=n150 B1=n151 C1=n_idx[4] C2=n149
XU774 ND3 $PINS O=n778 I1=n_idx[1] I2=n_idx[2] I3=n939
XU775 MOAI1S $PINS O=n184 A1=n185 A2=n149 B1=n186 B2=n187
XU781 INV1S $PINS O=n17 I=n_idx[4]
XU808 NR2 $PINS O=n643 I1=n193 I2=n_idx[4]
XU809 OAI112HS $PINS O=n169 A1=n179 B1=n180 C1=n_idx[3] C2=n178
XU846 INV1S $PINS O=n16 I=k_idx[4]
XU914 INV1S $PINS O=n890 I=k_idx[1]
XU918 INV1S $PINS O=n15 I=k_idx[3]
XU921 NR2 $PINS O=n326 I1=n156 I2=n_idx[4]
XU922 NR2 $PINS O=n913 I1=n14 I2=k_idx[1]
XU938 NR2 $PINS O=n287 I1=k_idx[2] I2=k_idx[0]
XU946 AN2 $PINS O=n955 I1=n287 I2=k_idx[1]
XU953 AOI22S $PINS O=n363 A1=n364 A2=n991 B1=n165 B2=n365
XU959 MOAI1S $PINS O=n364 A1=k_idx[1] A2=n159 B1=n14 B2=n202
XU963 INV1S $PINS O=n133 I=k_idx[0]
XU964 NR2 $PINS O=n973 I1=n133 I2=k_idx[4]
XU965 OAI112HS $PINS O=n281 A1=n283 B1=n284 C1=n282 C2=n188
XU966 ND3 $PINS O=n283 I1=n111 I2=n110 I3=k_idx[0]
XU967 AOI13HS $PINS O=n284 A1=n122 B1=k_idx[1] B2=n285 B3=n286
XU969 MOAI1S $PINS O=n285 A1=n_idx[2] A2=n287 B1=n288 B2=n111
XU975 INV1S $PINS O=n14 I=k_idx[2]
XU988 OR2 $PINS O=n188 I1=n_idx[2] I2=n370
XU992 NR2 $PINS O=n959 I1=k_idx[4] I2=k_idx[0]
XU997 NR2 $PINS O=n369 I1=k_idx[2] I2=k_idx[1]
XU998 AOI13HS $PINS O=n290 A1=n_idx[4] B1=n_idx[1] B2=n_idx[3] B3=n291
XU999 AN2 $PINS O=n368 I1=n_idx[3] I2=n369
XU1005 MOAI1S $PINS O=n366 A1=n287 A2=n890 B1=k_idx[0] B2=k_idx[2]
XU1007 OA12 $PINS O=n274 A1=n992 B1=k_idx[4] B2=n15
XU70 AN4S $PINS O=n409 I1=n220 I2=n401 I3=n406 I4=n399
.ENDS

.SUBCKT SNPS_CLOCK_GATE_HIGH_ROM_Wrapper_Even_1 EN ENCLK CLK
*.CONNECT net2365 EN
XFE_PHC868_net2368 DELC $PINS O=net2368 I=FE_PHN868_net2368
Xlatch QDBHN $PINS Q=FE_PHN868_net2368 D=net2365 CKB=CLK
Xmain_gate AN2T $PINS O=ENCLK I1=net2368 I2=CLK
.ENDS

.SUBCKT ROM_Wrapper_Even_1 rst_n en n_in[4] n_in[3] n_in[2] n_in[1] n_in[0]
+ k_idx[4] k_idx[3] k_idx[2] k_idx[1] k_idx[0] reg_sign1[1] reg_sign1[0]
+ reg_sign2[1] reg_sign2[0] reg_sign3[1] reg_sign3[0] reg_shift1[3]
+ reg_shift1[2] reg_shift1[1] reg_shift1[0] reg_shift2[3] reg_shift2[2]
+ reg_shift2[1] reg_shift2[0] reg_shift3[3] reg_shift3[2] reg_shift3[1]
+ reg_shift3[0] i_rst_n clk
*.CONNECT N4 n_in[0]
XCTS_ccl_a_INV_CLK_G1_L8_45 INV6CK $PINS O=CTS_10 I=CTS_11
XCTS_ccl_a_INV_CLK_G1_L7_48 INV3CK $PINS O=CTS_11 I=CTS_12
Xreg_sign1_reg[1] DFFSBN $PINS Q=reg_sign1[1] D=raw_s1[1] CK=CTS_10 SB=i_rst_n
Xreg_sign2_reg[1] DFFSBN $PINS Q=reg_sign2[1] D=raw_s2[1] CK=CTS_10 SB=i_rst_n
Xreg_sign3_reg[1] DFFSBN $PINS Q=reg_sign3[1] D=raw_s3[1] CK=CTS_10 SB=i_rst_n
Xreg_shift1_reg[1] QDFFRBP $PINS Q=reg_shift1[1] D=raw_h1[1] CK=CTS_10
+ RB=i_rst_n
Xreg_shift2_reg[1] QDFFRBN $PINS Q=reg_shift2[1] D=raw_h2[1] CK=CTS_10
+ RB=i_rst_n
Xreg_shift3_reg[1] QDFFRBN $PINS Q=reg_shift3[1] D=raw_h3[1] CK=CTS_10
+ RB=i_rst_n
Xreg_shift2_reg[2] QDFFRBN $PINS Q=reg_shift2[2] D=raw_h2[2] CK=CTS_10
+ RB=i_rst_n
Xreg_shift2_reg[3] QDFFRBN $PINS Q=reg_shift2[3] D=raw_h2[3] CK=CTS_10
+ RB=i_rst_n
Xreg_shift1_reg[0] QDFFRBP $PINS Q=reg_shift1[0] D=raw_h1[0] CK=CTS_10
+ RB=i_rst_n
Xreg_shift3_reg[2] QDFFRBN $PINS Q=reg_shift3[2] D=raw_h3[2] CK=CTS_10
+ RB=i_rst_n
Xreg_shift1_reg[2] QDFFRBN $PINS Q=reg_shift1[2] D=raw_h1[2] CK=CTS_10
+ RB=i_rst_n
Xreg_shift1_reg[3] QDFFRBN $PINS Q=reg_shift1[3] D=raw_h1[3] CK=CTS_10
+ RB=i_rst_n
Xreg_shift2_reg[0] QDFFRBN $PINS Q=reg_shift2[0] D=raw_h2[0] CK=CTS_10
+ RB=i_rst_n
Xreg_sign1_reg[0] QDFFRBN $PINS Q=reg_sign1[0] D=final_s1[0] CK=CTS_10
+ RB=i_rst_n
Xreg_sign2_reg[0] QDFFRBN $PINS Q=reg_sign2[0] D=final_s2[0] CK=CTS_10
+ RB=i_rst_n
Xreg_shift3_reg[3] QDFFRBN $PINS Q=reg_shift3[3] D=raw_h3[3] CK=CTS_10
+ RB=i_rst_n
Xreg_shift3_reg[0] QDFFRBT $PINS Q=reg_shift3[0] D=raw_h3[0] CK=CTS_10
+ RB=i_rst_n
Xreg_sign3_reg[0] QDFFRBN $PINS Q=reg_sign3[0] D=final_s3[0] CK=CTS_10
+ RB=i_rst_n
XU3 NR2 $PINS O=sub_79/carry[2] I1=N4 I2=n_in[1]
XU4 AN2S $PINS O=sub_79/carry[4] I1=sub_79/carry[3] I2=n5
XU7 XNR2HS $PINS O=final_s3[0] I1=raw_s3[0] I2=n10
XU8 MOAI1 $PINS O=fold_n[1] A1=n7 A2=N2 B1=N5 B2=N2
XU9 XNR2HS $PINS O=final_s2[0] I1=raw_s2[0] I2=n10
XU10 INV1S $PINS O=n9 I=N4
XU11 INV1S $PINS O=n7 I=n_in[1]
XU12 MOAI1 $PINS O=fold_n[0] A1=n9 A2=N2 B1=N4 B2=N2
XU13 XNR2HS $PINS O=final_s1[0] I1=raw_s1[0] I2=n10
XU14 MOAI1 $PINS O=fold_n[2] A1=n8 A2=N2 B1=N6 B2=N2
XU15 OA13S $PINS O=N2 A1=n_in[4] B1=n_in[1] B2=N4 B3=n13
XU16 MOAI1 $PINS O=fold_n[3] A1=n5 A2=N2 B1=N7 B2=N2
XU17 INV1S $PINS O=n8 I=n_in[2]
XU18 INV1S $PINS O=n5 I=n_in[3]
XU19 MOAI1 $PINS O=fold_n[4] A1=n6 A2=N2 B1=N8 B2=N2
XU20 INV1S $PINS O=n6 I=n_in[4]
XU23 ND3 $PINS O=n10 I1=N2 I2=n11 I3=k_idx[0]
XU24 ND3 $PINS O=n11 I1=k_idx[4] I2=k_idx[3] I3=n12
XU25 AN2 $PINS O=n12 I1=k_idx[2] I2=k_idx[1]
XU26 XOR2HS $PINS O=N8 I1=n6 I2=sub_79/carry[4]
XU27 XOR2HS $PINS O=N7 I1=n5 I2=sub_79/carry[3]
XU28 AN2 $PINS O=sub_79/carry[3] I1=sub_79/carry[2] I2=n8
XU29 XOR2HS $PINS O=N6 I1=n8 I2=sub_79/carry[2]
XU30 XOR2HS $PINS O=N5 I1=n7 I2=n9
XU31 OR2 $PINS O=n13 I1=n_in[3] I2=n_in[2]
Xrom_inst CSD_ROM_Table_even_1 $PINS n_idx[4]=fold_n[4] n_idx[3]=fold_n[3]
+ n_idx[2]=fold_n[2] n_idx[1]=fold_n[1] n_idx[0]=fold_n[0] k_idx[4]=k_idx[4]
+ k_idx[3]=k_idx[3] k_idx[2]=k_idx[2] k_idx[1]=k_idx[1] k_idx[0]=k_idx[0]
+ sign1[1]=raw_s1[1] sign1[0]=raw_s1[0] shift1[3]=raw_h1[3] shift1[2]=raw_h1[2]
+ shift1[1]=raw_h1[1] shift1[0]=raw_h1[0] sign2[1]=raw_s2[1] sign2[0]=raw_s2[0]
+ shift2[3]=raw_h2[3] shift2[2]=raw_h2[2] shift2[1]=raw_h2[1] shift2[0]=raw_h2[0]
+ sign3[1]=raw_s3[1] sign3[0]=raw_s3[0] shift3[3]=raw_h3[3] shift3[2]=raw_h3[2]
+ shift3[1]=raw_h3[1] shift3[0]=raw_h3[0]
Xclk_gate_reg_shift1_reg SNPS_CLOCK_GATE_HIGH_ROM_Wrapper_Even_1 $PINS EN=en
+ ENCLK=CTS_12 CLK=clk
.ENDS

.SUBCKT CSD_ROM_Table_odd_1 n_idx[4] n_idx[3] n_idx[2] n_idx[1] n_idx[0]
+ k_idx[4] k_idx[3] k_idx[2] k_idx[1] k_idx[0] sign1[1] sign1[0] shift1[3]
+ shift1[2] shift1[1] shift1[0] sign2[1] sign2[0] shift2[3] shift2[2] shift2[1]
+ shift2[0] sign3[1] sign3[0] shift3[3] shift3[2] shift3[1] shift3[0]
XFE_OFC497_n271 INV1S $PINS O=FE_OFN308_n271 I=n271
XFE_OFC350_n325 INV1S $PINS O=n63 I=n325
XFE_OFC340_fold_n_3 INV1S $PINS O=FE_OFN211_fold_n_3 I=n1
XFE_OFC336_fold_n_3 INV2 $PINS O=n1 I=n_idx[3]
XFE_OFC312_fold_n_0 INV2 $PINS O=n620 I=n_idx[0]
XFE_OFC199_n253 INV2 $PINS O=n99 I=n253
XFE_OFC190_fold_n_1 INV1S $PINS O=n103 I=n_idx[1]
XFE_OFC150_n526 INV1S $PINS O=n40 I=n526
XFE_OFC40_fold_n_4 BUF1 $PINS O=FE_OFN40_fold_n_4 I=n_idx[4]
XU728 ND2 $PINS O=sign3[1] I1=n132 I2=n133
XU729 AO112 $PINS O=n140 A1=n99 B1=n142 C1=n141 C2=n1
XU730 OA222 $PINS O=n136 A1=n145 A2=n146 B1=n147 B2=n148 C1=n149 C2=n150
XU731 AN3B2S $PINS O=n153 I1=n155 B1=n122 B2=n126
XU732 OA222 $PINS O=n135 A1=n165 A2=n166 B1=n167 B2=n168 C1=n169 C2=n170
XU733 OA222 $PINS O=n134 A1=n172 A2=n173 B1=n174 B2=n175 C1=n176 C2=n177
XU736 ND2 $PINS O=n163 I1=n175 I2=n213
XU737 ND2 $PINS O=n247 I1=n248 I2=n234
XU738 ND2 $PINS O=n251 I1=n252 I2=n253
XU739 ND2 $PINS O=n250 I1=n139 I2=n254
XU740 ND2 $PINS O=n256 I1=n257 I2=n60
XU741 ND2 $PINS O=n255 I1=n258 I2=n259
XU742 OA222 $PINS O=n229 A1=n261 A2=n262 B1=n263 B2=n264 C1=n265 C2=n266
XU744 OA112 $PINS O=n293 A1=n304 B1=n305 C1=n303 C2=n34
XU745 AO12 $PINS O=n305 A1=n307 B1=n173 B2=n306
XU747 OA222 $PINS O=n333 A1=n334 A2=n175 B1=n335 B2=n266 C1=n336 C2=n262
XU748 AO12 $PINS O=n351 A1=n240 B1=n43 B2=n41
XU749 ND2 $PINS O=n352 I1=n354 I2=n355
XU750 OA112 $PINS O=n343 A1=n364 B1=n365 C1=n173 C2=n29
XU751 AO12 $PINS O=n371 A1=n182 B1=n119 B2=n375
XU752 ND2 $PINS O=n383 I1=n104 I2=n19
XU753 OA222 $PINS O=n396 A1=n401 A2=n254 B1=n402 B2=n161 C1=n403 C2=n262
XU754 OA222 $PINS O=n395 A1=n405 A2=n202 B1=n406 B2=n213 C1=n407 C2=n266
XU755 OA222 $PINS O=n390 A1=n307 A2=n416 B1=n417 B2=n39 C1=n418 C2=n30
XU756 OA112 $PINS O=n434 A1=n435 B1=n436 C1=n188 C2=n40
XU757 ND2 $PINS O=n441 I1=n427 I2=n199
XU758 ND2 $PINS O=n439 I1=n54 I2=n10
XU759 ND2 $PINS O=n442 I1=n211 I2=n11
XU760 AN3 $PINS O=n276 I1=n444 I2=n445 I3=n446
XU761 OA222 $PINS O=n445 A1=n451 A2=n188 B1=n85 B2=n44 C1=n144 C2=n43
XU762 OA222 $PINS O=n444 A1=n29 A2=n361 B1=n12 B2=n54 C1=n452 C2=n11
XU763 ND2 $PINS O=n431 I1=n2 I2=n218
XU764 ND2 $PINS O=n455 I1=n22 I2=n34
XU765 OA222 $PINS O=n457 A1=n300 A2=n412 B1=n463 B2=n41 C1=n87 C2=n464
XU766 ND2 $PINS O=n309 I1=n271 I2=n465
XU767 OA222 $PINS O=n456 A1=n199 A2=n44 B1=n466 B2=n271 C1=n46 C2=n259
XU768 OA222 $PINS O=n342 A1=n166 A2=n34 B1=n478 B2=n479 C1=n202 C2=n38
XU769 OA222 $PINS O=n488 A1=n156 A2=n85 B1=n493 B2=n262 C1=n494 C2=n495
XU770 OA222 $PINS O=n487 A1=n496 A2=n266 B1=n497 B2=n264 C1=n498 C2=n213
XU771 OA222 $PINS O=n468 A1=n35 A2=n503 B1=n504 B2=n36 C1=n505 C2=n30
XU772 OA222 $PINS O=n513 A1=n516 A2=n264 B1=n517 B2=n161 C1=n518 C2=n246
XU774 OA222 $PINS O=n510 A1=n173 A2=n30 B1=n41 B2=n10 C1=n520 C2=n39
XU775 OA222 $PINS O=n509 A1=n521 A2=n307 B1=n166 B2=n34 C1=n189 C2=n33
XU776 OR3B2 $PINS O=n529 I1=n532 B1=n533 B2=n534
XU777 AO222 $PINS O=n541 A1=n219 A2=n353 B1=n542 B2=n18 C1=n220 C2=n543
XU778 AO222 $PINS O=n542 A1=n105 A2=n545 B1=n114 B2=n546 C1=n113 C2=n547
XU780 AN3B2S $PINS O=n550 I1=n515 B1=n551 B2=n53
XU781 OA222 $PINS O=n539 A1=n329 A2=n36 B1=n552 B2=n43 C1=n58 C2=n39
XU782 OA222 $PINS O=n538 A1=n166 A2=n22 B1=n189 B2=n30 C1=n27 C2=n224
XU783 ND2 $PINS O=n523 I1=n562 I2=n563
XU784 ND2 $PINS O=n565 I1=n258 I2=n237
XU785 ND2 $PINS O=n564 I1=n268 I2=n97
XU786 OA112 $PINS O=n555 A1=n341 B1=n460 C1=n11 C2=n215
XU787 OA112 $PINS O=n341 A1=n569 B1=n570 C1=n478 C2=n355
XU788 AN3B2S $PINS O=n535 I1=n572 B1=n573 B2=n574
XU789 AO222 $PINS O=n588 A1=n114 A2=n589 B1=n109 B2=n93 C1=n113 C2=n590
XU791 OA222 $PINS O=n587 A1=n400 A2=n495 B1=n595 B2=n213 C1=n596 C2=n262
XU793 OA222 $PINS O=n582 A1=n200 A2=n33 B1=n601 B2=n602 C1=n603 C2=n11
XU794 OA222 $PINS O=n581 A1=n604 A2=n36 B1=n57 B2=n41 C1=n605 C2=n39
XU795 OA112 $PINS O=n578 A1=n274 B1=n609 C1=n40 C2=n495
XU796 OA222 $PINS O=n609 A1=n307 A2=n479 B1=n610 B2=n503 C1=n525 C2=n611
XU797 ND2 $PINS O=n561 I1=n612 I2=n613
XU798 ND2 $PINS O=n615 I1=n224 I2=n188
XU799 OA112 $PINS O=n472 A1=n527 B1=n617 C1=n152 C2=n29
XU801 ND2 $PINS O=n571 I1=n623 I2=n624
XU802 OA222 $PINS O=n624 A1=n216 A2=n224 B1=n625 B2=n452 C1=n626 C2=n361
XU803 OA222 $PINS O=n623 A1=n22 A2=n479 B1=n12 B2=n412 C1=n188 C2=n226
XU806 ND2 $PINS O=n639 I1=n41 I2=n464
XU807 AN3B2S $PINS O=n633 I1=n641 B1=n642 B2=n531
XU808 OA112 $PINS O=n645 A1=n556 B1=n646 C1=n152 C2=n30
XU810 OA222 $PINS O=n657 A1=n625 A2=n224 B1=n452 B2=n478 C1=n515 C2=n39
XU811 OA112 $PINS O=n686 A1=n688 B1=n689 C1=n687 C2=n49
XU812 ND2 $PINS O=n464 I1=n114 I2=n18
XU813 ND2 $PINS O=n690 I1=n36 I2=n300
XU814 ND2 $PINS O=n300 I1=n113 I2=n18
XU815 OA112 $PINS O=n533 A1=n693 B1=n694 C1=n152 C2=n7
XU816 AN3 $PINS O=n471 I1=n696 I2=n697 I3=n698
XU817 OA112 $PINS O=n698 A1=n42 B1=n699 C1=n566 C2=n271
XU818 OA222 $PINS O=n705 A1=FE_OFN40_fold_n_4 A2=n708 B1=n709 B2=n49 C1=n478
+ C2=n224
XU819 ND2 $PINS O=n478 I1=n147 I2=n710
XU820 OA222 $PINS O=n708 A1=n51 A2=n264 B1=n711 B2=n246 C1=n712 C2=n161
XU821 OA222 $PINS O=n704 A1=n211 A2=n355 B1=n715 B2=n30 C1=n716 C2=n36
XU823 ND2 $PINS O=n519 I1=n248 I2=n237
XU824 AO222 $PINS O=n717 A1=n411 A2=n358 B1=n721 B2=n467 C1=n722 C2=n440
XU825 AN3B2S $PINS O=n700 I1=n534 B1=n726 B2=n727
XU826 OR3B2 $PINS O=n726 I1=n574 B1=n650 B2=n728
XU827 OA112 $PINS O=n735 A1=n736 B1=n737 C1=n152 C2=n27
XU828 ND2 $PINS O=n738 I1=n237 I2=n465
XU832 OA222 $PINS O=n729 A1=n648 A2=n27 B1=n199 B2=n44 C1=n610 C2=n503
XU834 ND2 $PINS O=n304 I1=n608 I2=n131
XU835 ND2 $PINS O=n756 I1=n720 I2=n7
XU836 OA222 $PINS O=n752 A1=n408 A2=n47 B1=n759 B2=n35 C1=n501 C2=n45
XU837 ND2 $PINS O=n761 I1=n125 I2=n710
XU838 ND2 $PINS O=n760 I1=n131 I2=n762
XU839 OR3 $PINS O=n545 I1=n270 I2=n94 I3=n65
XU841 AO222 $PINS O=n767 A1=n110 A2=n770 B1=n111 B2=n771 C1=n112 C2=n772
XU842 AN3B2S $PINS O=n600 I1=n664 B1=n61 B2=n64
XU843 OA222 $PINS O=n765 A1=n664 A2=n177 B1=n773 B2=n774 C1=n775 C2=n254
XU845 AN3 $PINS O=n504 I1=n240 I2=n72 I3=n494
XU846 AO222 $PINS O=n780 A1=n779 A2=n483 B1=n782 B2=n297 C1=n783 C2=n424
XU847 OR3 $PINS O=n779 I1=n783 I2=n326 I3=n95
XU848 AN3B2S $PINS O=n605 I1=n724 B1=n670 B2=n74
XU849 ND2 $PINS O=n225 I1=n720 I2=n27
XU850 OA222 $PINS O=n628 A1=n27 A2=n505 B1=n521 B2=n11 C1=n254 C2=n40
XU853 AO12 $PINS O=n795 A1=n39 B1=n553 B2=n325
XU854 OA222 $PINS O=n793 A1=n307 A2=n296 B1=n801 B2=n503 C1=FE_OFN40_fold_n_4
+ C2=n802
XU855 OA222 $PINS O=n802 A1=n803 A2=n264 B1=n804 B2=n246 C1=n805 C2=n161
XU856 ND2 $PINS O=n353 I1=n22 I2=n7
XU857 OA222 $PINS O=n792 A1=n155 A2=n34 B1=n806 B2=n44 C1=n414 C2=n30
XU858 OA222 $PINS O=n791 A1=n807 A2=n48 B1=n52 B2=n49 C1=n808 C2=n37
XU860 ND2 $PINS O=n298 I1=n87 I2=n237
XU861 AN3 $PINS O=n728 I1=n821 I2=n822 I3=n823
XU862 OA112 $PINS O=n823 A1=n627 B1=n824 C1=n188 C2=n27
XU863 ND2 $PINS O=n640 I1=n29 I2=n30
XU864 ND2 $PINS O=n661 I1=n259 I2=n85
XU865 AN3 $PINS O=n673 I1=n825 I2=n826 I3=n827
XU866 OA222 $PINS O=n829 A1=n832 A2=n27 B1=n833 B2=n47 C1=n834 C2=n45
XU867 ND2 $PINS O=n421 I1=n521 I2=n835
XU868 ND2 $PINS O=n836 I1=n428 I2=n7
XU870 ND2 $PINS O=n840 I1=n128 I2=n614
XU871 ND2 $PINS O=n159 I1=n246 I2=n495
XU872 ND2 $PINS O=n862 I1=n485 I2=n252
XU873 ND2 $PINS O=n861 I1=n259 I2=n10
XU874 OR3 $PINS O=n846 I1=n652 I2=n530 I3=n863
XU875 OA112 $PINS O=n866 A1=n274 B1=n692 C1=n166 C2=n27
XU876 OA13S $PINS O=n865 A1=n688 B1=n591 B2=FE_OFN40_fold_n_4 B3=n161
XU877 ND2 $PINS O=n503 I1=n867 I2=n384
XU878 OA222 $PINS O=n475 A1=n38 A2=n262 B1=n224 B2=n30 C1=n210 C2=n22
XU879 ND2 $PINS O=n210 I1=n873 I2=n874
XU881 OA222 $PINS O=n869 A1=n54 A2=n48 B1=n404 B2=n43 C1=n49 C2=n253
XU882 OA222 $PINS O=n868 A1=n237 A2=n39 B1=n46 B2=n85 C1=n356 C2=n41
XU883 OA222 $PINS O=n843 A1=n363 A2=n355 B1=n200 B2=n27 C1=n216 C2=n152
XU884 ND2 $PINS O=n569 I1=n592 I2=n608
XU885 ND2 $PINS O=n139 I1=n385 I2=n888
XU886 ND2 $PINS O=n180 I1=n258 I2=n465
XU887 ND2 $PINS O=n670 I1=n325 I2=n87
XU889 ND2 $PINS O=n254 I1=n892 I2=n372
XU890 OA222 $PINS O=n883 A1=n893 A2=n44 B1=n894 B2=n45 C1=n46 C2=n253
XU891 ND2 $PINS O=n177 I1=n892 I2=n895
XU893 ND2 $PINS O=n175 I1=n385 I2=n895
XU894 OR3 $PINS O=n896 I1=n260 I2=n83 I3=n340
XU895 ND2 $PINS O=n260 I1=n54 I2=n259
XU898 ND2 $PINS O=n495 I1=n875 I2=n385
XU899 OR3B2 $PINS O=n902 I1=n837 B1=n302 B2=n903
XU900 ND2 $PINS O=n878 I1=n194 I2=n904
XU901 ND2 $PINS O=n837 I1=n758 I2=n366
XU902 ND2 $PINS O=n366 I1=n194 I2=n59
XU905 ND2 $PINS O=n226 I1=n374 I2=FE_OFN40_fold_n_4
XU907 ND2 $PINS O=n863 I1=n905 I2=n906
XU908 ND2 $PINS O=n611 I1=n384 I2=n888
XU909 ND2 $PINS O=n551 I1=n430 I2=n10
XU914 ND2 $PINS O=n916 I1=n724 I2=n253
XU920 OA222 $PINS O=n908 A1=n920 A2=n835 B1=n921 B2=n22 C1=n922 C2=n29
XU921 ND2 $PINS O=n189 I1=n891 I2=n384
XU922 ND2 $PINS O=n215 I1=n923 I2=n384
XU923 ND2 $PINS O=n835 I1=n895 I2=n874
XU924 ND2 $PINS O=n648 I1=n372 I2=n384
XU925 ND2 $PINS O=n479 I1=n875 I2=n384
XU927 ND2 $PINS O=n150 I1=n892 I2=n888
XU930 ND2 $PINS O=n452 I1=n867 I2=n874
XU934 ND2 $PINS O=n162 I1=n867 I2=n385
XU936 ND2 $PINS O=n930 I1=n147 I2=n762
XU937 AN3 $PINS O=n932 I1=n71 I2=n171 I3=n198
XU938 ND2 $PINS O=n355 I1=n874 I2=n888
XU939 ND2 $PINS O=n283 I1=k_idx[4] I2=k_idx[3]
XU941 ND2 $PINS O=n787 I1=n601 I2=n302
XU943 ND2 $PINS O=n198 I1=n897 I2=n_idx[1]
XU945 OA222 $PINS O=n649 A1=n36 A2=n87 B1=n37 B2=n412 C1=n202 C2=n38
XU946 ND2 $PINS O=n168 I1=n_idx[1] I2=n919
XU948 ND2 $PINS O=n412 I1=n193 I2=n285
XU949 ND2 $PINS O=n266 I1=n873 I2=n892
XU950 ND2 $PINS O=n160 I1=n875 I2=n892
XU951 ND2 $PINS O=n376 I1=k_idx[4] I2=n20
XU952 ND2 $PINS O=n505 I1=n873 I2=n384
XU953 ND2 $PINS O=n173 I1=n384 I2=n895
XU3 AN4B1S $PINS O=n599 I1=n267 I2=n679 I3=n330 B1=n338
XU4 AN4B1S $PINS O=n336 I1=n591 I2=n408 I3=n316 B1=n593
XU5 NR2P $PINS O=n16 I1=n35 I2=n171
XU6 ND2 $PINS O=n7 I1=n147 I2=n182
XU7 OAI222S $PINS O=n5 A1=n43 A2=n629 B1=n48 B2=n631 C1=n707 C2=n188
XU8 AN4B1S $PINS O=n151 I1=n189 I2=n452 I3=n197 B1=n131
XU10 OA222S $PINS O=n286 A1=n118 A2=n91 B1=FE_OFN211_fold_n_3 B2=n287 C1=n104
+ C2=n92
XU11 INV1S $PINS O=n102 I=n_idx[2]
XU12 NR2P $PINS O=n526 I1=n72 I2=FE_OFN40_fold_n_4
XU13 NR2 $PINS O=n285 I1=n102 I2=n1
XU14 NR2 $PINS O=n179 I1=n76 I2=n103
XU15 NR2 $PINS O=n195 I1=n75 I2=n620
XU16 NR2 $PINS O=n2 I1=n35 I2=n170
XU17 INV1S $PINS O=n80 I=n312
XU18 INV1S $PINS O=n98 I=n426
XU19 NR2 $PINS O=n500 I1=n326 I2=FE_OFN308_n271
XU20 INV1S $PINS O=n81 I=n356
XU21 ND3S $PINS O=shift3[2] I1=n468 I2=n469 I3=n470
XU22 ND3S $PINS O=shift1[3] I1=n748 I2=n749 I3=n750
XU23 INV1S $PINS O=n67 I=n236
XU24 INV1S $PINS O=n100 I=n143
XU25 ND2 $PINS O=n253 I1=n918 I2=n897
XU27 ND2 $PINS O=n259 I1=n141 I2=n897
XU28 ND2S $PINS O=n798 I1=n800 I2=n272
XU29 ND2S $PINS O=n270 I1=n301 I2=n252
XU30 ND3S $PINS O=n606 I1=n713 I2=n500 I3=n607
XU31 ND3S $PINS O=n546 I1=n492 I2=n325 I3=n549
XU32 OA222S $PINS O=n540 A1=n44 A2=n87 B1=n312 B2=n37 C1=n550 C2=n48
XU33 ND2S $PINS O=n419 I1=n408 I2=n144
XU34 ND2S $PINS O=n339 I1=n324 I2=n267
XU35 ND3S $PINS O=n409 I1=n629 I2=n713 I3=n714
XU36 ND3S $PINS O=n721 I1=n501 I2=n597 I3=n500
XU37 ND3S $PINS O=n817 I1=n97 I2=n412 I3=n426
XU38 ND3S $PINS O=n889 I1=n591 I2=n408 I3=n502
XU39 OA22S $PINS O=n347 A1=n12 A2=n273 B1=n47 B2=n356
XU40 ND3S $PINS O=n410 I1=n412 I2=n356 I3=n97
XU41 ND2S $PINS O=n799 I1=n235 I2=n356
XU42 OA222S $PINS O=n586 A1=n598 A2=n161 B1=n599 B2=n266 C1=n600 C2=n202
XU43 ND3S $PINS O=n484 I1=n325 I2=n201 I3=n485
XU44 ND3S $PINS O=n589 I1=n144 I2=n259 I3=n594
XU45 ND3S $PINS O=n337 I1=n330 I2=n143 I3=n809
XU46 ND3S $PINS O=n662 I1=n272 I2=n267 I3=n401
XU47 OA222S $PINS O=n556 A1=n41 A2=n143 B1=n46 B2=n54 C1=n611 C2=n11
XU48 ND3S $PINS O=n425 I1=n426 I2=n234 I3=n427
XU49 MAOI1S $PINS O=n294 A1=n127 A2=n299 B1=n300 B2=n301
XU50 OA222S $PINS O=n703 A1=n37 A2=n143 B1=n306 B2=n22 C1=n301 C2=n39
XU51 ND3S $PINS O=n814 I1=n259 I2=n465 I3=n500
XU52 ND3S $PINS O=n249 I1=n54 I2=n143 I3=n408
XU53 MAOI1S $PINS O=n689 A1=n81 A2=n690 B1=n464 B2=n691
XU54 OA22S $PINS O=n872 A1=n48 A2=n806 B1=n43 B2=n356
XU55 ND2S $PINS O=n917 I1=n356 I2=n236
XU56 ND3S $PINS O=n710 I1=n170 I2=n89 I3=n171
XU57 OA22S $PINS O=n856 A1=n329 A2=n162 B1=n356 B2=n213
XU58 OA22S $PINS O=n658 A1=n464 A2=n54 B1=n143 B2=n300
XU59 OA222S $PINS O=n511 A1=n43 A2=n237 B1=n199 B2=n48 C1=n46 C2=n236
XU60 ND2 $PINS O=n271 I1=n141 I2=n919
XU61 ND3S $PINS O=n547 I1=n500 I2=n252 I3=n548
XU62 ND3S $PINS O=n543 I1=n143 I2=n356 I3=n544
XU63 ND2S $PINS O=n199 I1=n375 I2=n193
XU64 ND2S $PINS O=n171 I1=n897 I2=n103
XU65 ND2S $PINS O=n170 I1=n919 I2=n103
XU66 ND2S $PINS O=n237 I1=n918 I2=n919
XU67 ND2S $PINS O=n329 I1=n918 I2=n375
XU68 ND3S $PINS O=n522 I1=n476 I2=n527 I3=n528
XU69 NR2 $PINS O=n3 I1=n35 I2=n75
XU70 OR3S $PINS O=n6 I1=n621 I2=n571 I3=n622
XU71 OA222S $PINS O=n739 A1=n12 A2=n54 B1=n44 B2=n97 C1=n139 C2=n40
XU72 AN3S $PINS O=n758 I1=n226 I2=n40 I3=n707
XU73 ND3S $PINS O=n757 I1=n451 I2=n38 I3=n758
XU74 OR2S $PINS O=n275 I1=n40 I2=n139
XU75 OA112S $PINS O=n732 A1=n435 B1=n739 C1=n11 C2=n505
XU76 OA222S $PINS O=n675 A1=n361 A2=n11 B1=n10 B2=n39 C1=n40 C2=n246
XU77 ND3S $PINS O=shift1[1] I1=n843 I2=n844 I3=n845
XU78 OA22S $PINS O=n365 A1=n366 A2=n188 B1=n40 B2=n150
XU79 ND3S $PINS O=shift3[3] I1=n456 I2=n457 I3=n458
XU80 OA222S $PINS O=n534 A1=n648 A2=n11 B1=n747 B2=n37 C1=n40 C2=n160
XU81 ND3S $PINS O=n328 I1=n329 I2=n72 I3=n144
XU82 OA222S $PINS O=n183 A1=n199 A2=n162 B1=n200 B2=n75 C1=n201 C2=n202
XU83 ND2S $PINS O=n707 I1=n194 I2=n179
XU84 OA222S $PINS O=n184 A1=n196 A2=n91 B1=n197 B2=n76 C1=n155 C2=n198
XU85 NR2 $PINS O=n874 I1=n630 I2=k_idx[0]
XU86 NR2 $PINS O=n610 I1=n31 I2=n24
XU87 INV1S $PINS O=n24 I=n720
XU88 NR2 $PINS O=n301 I1=n56 I2=n88
XU89 NR2 $PINS O=n272 I1=n74 I2=n93
XU90 NR2 $PINS O=n597 I1=n66 I2=n80
XU91 INV1S $PINS O=n34 I=n3
XU92 INV1S $PINS O=n82 I=n330
XU93 INV1S $PINS O=n31 I=n601
XU94 NR2 $PINS O=n800 I1=n69 I2=n56
XU95 NR2 $PINS O=n720 I1=n25 I2=n3
XU96 INV1S $PINS O=n30 I=n608
XU97 NR2 $PINS O=n596 I1=n93 I2=n61
XU98 NR2 $PINS O=n515 I1=n98 I2=n80
XU99 INV1S $PINS O=n56 I=n500
XU100 AN2 $PINS O=n598 I1=n491 I2=n235
XU101 INV1S $PINS O=n64 I=n679
XU102 NR2 $PINS O=n496 I1=n339 I2=n82
XU103 INV1S $PINS O=n66 I=n408
XU104 INV1S $PINS O=n65 I=n713
XU105 INV1S $PINS O=n88 I=n144
XU107 NR2 $PINS O=n494 I1=n63 I2=n78
XU108 INV1S $PINS O=n74 I=n201
XU109 INV1S $PINS O=n26 I=n367
XU110 NR2 $PINS O=n312 I1=n81 I2=n84
XU111 NR2 $PINS O=n594 I1=n606 I2=n81
XU112 AN2 $PINS O=n595 I1=n544 I2=n597
XU113 INV1S $PINS O=n51 I=n409
XU114 INV1S $PINS O=n55 I=n234
XU115 NR2 $PINS O=n330 I1=n93 I2=n84
XU116 INV1S $PINS O=n93 I=n747
XU117 INV1S $PINS O=n73 I=n671
XU118 NR2 $PINS O=n601 I1=n32 I2=n420
XU119 INV1S $PINS O=n32 I=n307
XU120 INV1S $PINS O=n94 I=n316
XU121 INV1S $PINS O=n61 I=n485
XU122 INV1S $PINS O=n25 I=n451
XU123 INV1S $PINS O=n22 I=n362
XU124 ND3 $PINS O=n315 I1=n10 I2=n72 I3=n316
XU125 NR2 $PINS O=n427 I1=n66 I2=n84
XU126 INV1S $PINS O=n83 I=n252
XU127 INV1S $PINS O=n69 I=n235
XU128 NR2 $PINS O=n608 I1=n35 I2=n89
XU129 NR2 $PINS O=n501 I1=n86 I2=n98
XU130 INV1S $PINS O=n68 I=n492
XU131 AN2 $PINS O=n525 I1=n428 I2=n216
XU132 INV1S $PINS O=n77 I=n401
XU133 INV1S $PINS O=n23 I=n428
XU134 INV1S $PINS O=n42 I=n743
XU135 INV1S $PINS O=n79 I=n248
XU136 INV1S $PINS O=n28 I=n302
XU137 ND3 $PINS O=n573 I1=n528 I2=n575 I3=n576
XU138 ND3 $PINS O=n349 I1=n350 I2=n42 I3=n351
XU139 OAI112HS $PINS O=n754 A1=n304 B1=n42 C1=n601 C2=n755
XU140 NR2 $PINS O=n755 I1=n120 I2=n122
XU141 INV1S $PINS O=n126 I=n196
XU142 INV1S $PINS O=n122 I=n521
XU143 INV1S $PINS O=n120 I=n197
XU144 INV1S $PINS O=n124 I=n415
XU145 INV1S $PINS O=n129 I=n200
XU146 INV1S $PINS O=n72 I=n195
XU147 OAI112HS $PINS O=n621 A1=n627 B1=n628 C1=n12 C2=n356
XU148 INV1S $PINS O=n75 I=n179
XU149 NR3 $PINS O=n527 I1=n4 I2=n5 I3=n6
XU150 OAI222S $PINS O=n4 A1=n324 A2=n44 B1=n47 B2=n465 C1=n316 C2=n45
XU152 NR3 $PINS O=n491 I1=n96 I2=n81 I3=n545
XU153 ND3 $PINS O=shift2[3] I1=n577 I2=n578 I3=n579
XU154 AN4B1S $PINS O=n577 I1=n472 I2=n459 I3=n572 B1=n561
XU155 AN4B1S $PINS O=n579 I1=n580 I2=n581 I3=n582 B1=n583
XU156 NR2P $PINS O=n325 I1=n64 I2=n100
XU157 NR2 $PINS O=n426 I1=n101 I2=n99
XU158 AOI22S $PINS O=n764 A1=n108 A2=n778 B1=n114 B2=n779
XU159 ND3 $PINS O=n778 I1=n252 I2=n54 I3=n504
XU160 NR2 $PINS O=n679 I1=n98 I2=n67
XU161 ND3 $PINS O=shift2[0] I1=n700 I2=n701 I3=n702
XU162 NR2 $PINS O=n701 I1=n717 I2=n718
XU163 AN4B1S $PINS O=n702 I1=n703 I2=n704 I3=n705 B1=n706
XU164 AN4B1S $PINS O=n906 I1=n907 I2=n908 I3=n909 B1=n910
XU165 NR3 $PINS O=n905 I1=n924 I2=n925 I3=n926
XU166 OA22 $PINS O=n907 A1=n33 A2=n886 B1=n30 B2=n715
XU167 ND3 $PINS O=n924 I1=n641 I2=n675 I3=n927
XU168 AOI22S $PINS O=n927 A1=n420 A2=n369 B1=n105 B2=n526
XU169 AOI22S $PINS O=n828 A1=n317 A2=n836 B1=n107 B2=n837
XU170 NR2 $PINS O=n826 I1=n838 I2=n839
XU171 AN4B1S $PINS O=n825 I1=n454 I2=n840 I3=n841 B1=n616
XU172 AN4B1S $PINS O=n827 I1=n828 I2=n829 I3=n830 B1=n831
XU173 ND3 $PINS O=shift2[1] I1=n653 I2=n654 I3=n655
XU174 AN4B1S $PINS O=n655 I1=n656 I2=n657 I3=n658 B1=n659
XU175 NR2 $PINS O=n654 I1=n666 I2=n667
XU176 AN4B1S $PINS O=n653 I1=n672 I2=n673 I3=n651 B1=n462
XU177 ND3 $PINS O=shift3[1] I1=n506 I2=n507 I3=n508
XU178 AN4B1S $PINS O=n508 I1=n509 I2=n510 I3=n511 B1=n512
XU179 NR3 $PINS O=n506 I1=n529 I2=n530 I3=n531
XU180 NR3 $PINS O=n507 I1=n522 I2=n523 I3=n524
XU181 ND3 $PINS O=shift1[2] I1=n788 I2=n789 I3=n790
XU182 NR3 $PINS O=n789 I1=n810 I2=n811 I3=n812
XU183 AN4B1S $PINS O=n790 I1=n791 I2=n792 I3=n793 B1=n794
XU184 AN4B1S $PINS O=n788 I1=n673 I2=n818 I3=n728 B1=n819
XU185 NR2 $PINS O=n408 I1=n78 I2=n67
XU186 NR2 $PINS O=n713 I1=n66 I2=n195
XU187 INV1S $PINS O=n78 I=n412
XU188 ND3 $PINS O=n771 I1=n599 I2=n85 I3=n776
XU189 NR2 $PINS O=n776 I1=n81 I2=n78
XU190 NR2 $PINS O=n591 I1=n56 I2=n100
XU191 NR3 $PINS O=n773 I1=n771 I2=n195 I3=n100
XU192 AN4B1S $PINS O=n388 I1=n389 I2=n390 I3=n391 B1=n392
XU193 OA22 $PINS O=n391 A1=n29 A2=n414 B1=n11 B2=n415
XU194 AOI22S $PINS O=n389 A1=n308 A2=n419 B1=n420 B2=n421
XU195 NR2P $PINS O=n144 I1=n338 I2=n100
XU196 INV1S $PINS O=n89 I=n191
XU197 ND3 $PINS O=shift1[0] I1=n879 I2=n880 I3=n881
XU198 AN4B1S $PINS O=n881 I1=n882 I2=n883 I3=n884 B1=n885
XU199 NR2 $PINS O=n880 I1=n900 I2=n901
XU200 AN4B1S $PINS O=n879 I1=n841 I2=n649 I3=n785 B1=n863
XU201 NR2 $PINS O=n201 I1=n80 I2=n195
XU202 NR2 $PINS O=n234 I1=n56 I2=n96
XU203 AN4B1S $PINS O=n230 I1=n241 I2=n242 I3=n243 B1=n244
XU204 AOI22S $PINS O=n243 A1=n70 A2=n250 B1=n115 B2=n251
XU205 AOI22S $PINS O=n242 A1=n106 A2=n255 B1=n116 B2=n256
XU206 AOI22S $PINS O=n241 A1=n108 A2=n260 B1=n96 B2=n159
XU207 NR2 $PINS O=n714 I1=n99 I2=n53
XU208 AN4B1S $PINS O=n804 I1=n331 I2=n301 I3=n356 B1=n70
XU209 INV1S $PINS O=n53 I=n499
XU210 AN4B1S $PINS O=n803 I1=n806 I2=n301 I3=n465 B1=n78
XU211 ND3 $PINS O=n367 I1=n432 I2=n433 I3=n434
XU212 MAOI1 $PINS O=n432 A1=n370 A2=n442 B1=n363 B2=n443
XU213 AOI22S $PINS O=n433 A1=n438 A2=n439 B1=n440 B2=n441
XU214 AOI12HS $PINS O=n459 A1=n616 B1=n16 B2=n369
XU215 AOI22S $PINS O=n454 A1=n131 A2=n437 B1=n526 B2=n117
XU216 AN2 $PINS O=n364 I1=n453 I2=n454
XU217 AOI22S $PINS O=n453 A1=n317 A2=n455 B1=n308 B2=n79
XU218 INV1S $PINS O=n84 I=n465
XU219 INV1S $PINS O=n54 I=n326
XU220 NR2 $PINS O=n417 I1=n95 I2=n270
XU221 ND3 $PINS O=n411 I1=n499 I2=n273 I3=n725
XU222 NR2 $PINS O=n725 I1=n83 I2=n56
XU223 AOI22S $PINS O=n753 A1=n125 A2=n756 B1=n107 B2=n757
XU224 INV1S $PINS O=n57 I=n606
XU225 AN4B1S $PINS O=n604 I1=n607 I2=n494 I3=n72 B1=FE_OFN308_n271
XU226 ND3 $PINS O=n462 I1=n674 I2=n675 I3=n676
XU227 AOI22S $PINS O=n674 A1=n618 A2=n23 B1=n608 B2=n619
XU228 NR2 $PINS O=n676 I1=n677 I2=n678
XU229 MOAI1S $PINS O=n678 A1=n679 A2=n37 B1=n67 B2=n220
XU230 INV1S $PINS O=n38 I=n212
XU231 NR3 $PINS O=n322 I1=n327 I2=n78 I3=n70
XU232 NR2 $PINS O=n553 I1=n74 I2=n326
XU233 ND3 $PINS O=n327 I1=n273 I2=n553 I3=n554
XU234 NR2 $PINS O=n554 I1=n100 I2=n96
XU235 NR3 $PINS O=n544 I1=n53 I2=n93 I3=n260
XU236 ND3 $PINS O=shift2[2] I1=n632 I2=n633 I3=n634
XU237 AN4B1S $PINS O=n634 I1=n635 I2=n636 I3=n637 B1=n638
XU238 AN4B1S $PINS O=n632 I1=n649 I2=n650 I3=n651 B1=n652
XU239 NR2 $PINS O=n216 I1=n16 I2=n3
XU240 NR2 $PINS O=n493 I1=n338 I2=n326
XU241 NR2 $PINS O=n430 I1=n88 I2=n326
XU242 NR2 $PINS O=n625 I1=n2 I2=n3
XU243 AN4B1S $PINS O=n323 I1=n324 I2=n178 I3=n325 B1=n73
XU244 NR2 $PINS O=n400 I1=n66 I2=FE_OFN308_n271
XU245 NR2 $PINS O=n747 I1=n95 I2=n413
XU246 NR2 $PINS O=n671 I1=n195 I2=n95
XU247 OA12 $PINS O=n820 A1=n575 B1=n38 B2=n175
XU248 NR2 $PINS O=n307 I1=n16 I2=n608
XU249 NR2 $PINS O=n252 I1=n413 I2=n84
XU250 NR2 $PINS O=n724 I1=n96 I2=n413
XU251 AOI22S $PINS O=n460 A1=n115 A2=n526 B1=n93 B2=n358
XU252 AOI22S $PINS O=n824 A1=n100 A2=n308 B1=n592 B2=n31
XU253 AOI22S $PINS O=n821 A1=n438 A2=n80 B1=n326 B2=n568
XU254 AOI22S $PINS O=n822 A1=n357 A2=n661 B1=n121 B2=n640
XU255 AN4B1S $PINS O=n473 I1=n475 I2=n476 I3=n342 B1=n477
XU256 INV1S $PINS O=n97 I=n340
XU257 NR2 $PINS O=n316 I1=n101 I2=n95
XU258 AOI22S $PINS O=n737 A1=n340 A2=n357 B1=n568 B2=n98
XU259 NR3 $PINS O=n548 I1=n98 I2=n195 I3=n53
XU260 NR2 $PINS O=n485 I1=n338 I2=FE_OFN308_n271
XU261 NR2 $PINS O=n362 I1=n35 I2=n71
XU262 NR2 $PINS O=n451 I1=n614 I2=n362
XU263 NR2 $PINS O=n664 I1=n93 I2=n340
XU264 INV1S $PINS O=n87 I=n338
XU265 NR2 $PINS O=n607 I1=n83 I2=n70
XU266 AOI22S $PINS O=n650 A1=n106 A2=n526 B1=n95 B2=n483
XU267 INV1S $PINS O=n27 I=n2
XU268 NR2 $PINS O=n258 I1=n326 I2=n78
XU269 OAI22S $PINS O=n811 A1=n815 A2=n43 B1=n816 B2=n46
XU270 NR3 $PINS O=n816 I1=n817 I2=n82 I3=n61
XU271 AN4B1S $PINS O=n815 I1=n234 I2=n10 I3=n713 B1=n298
XU272 OAI112HS $PINS O=n885 A1=n887 B1=n569 C1=n886 C2=n22
XU273 OAI12HS $PINS O=n887 A1=n308 B1=n670 B2=n180
XU274 AOI22S $PINS O=n736 A1=n619 A2=n614 B1=n107 B2=n362
XU275 NR2 $PINS O=n235 I1=n99 I2=n70
XU276 NR2 $PINS O=n404 I1=n69 I2=n100
XU277 NR2 $PINS O=n331 I1=n101 I2=n78
XU278 NR2 $PINS O=n629 I1=n326 I2=n84
XU279 MOAI1S $PINS O=n876 A1=n196 A2=n29 B1=n526 B2=n164
XU280 AOI22S $PINS O=n680 A1=n95 A2=n113 B1=n105 B2=n69
XU281 INV1S $PINS O=n35 I=n147
XU282 ND3 $PINS O=n722 I1=n723 I2=n331 I3=n724
XU283 NR3 $PINS O=n723 I1=n88 I2=FE_OFN308_n271 I3=n68
XU284 AOI22S $PINS O=n641 A1=n212 A2=n113 B1=n483 B2=n78
XU285 AOI22S $PINS O=n695 A1=n483 A2=n56 B1=n413 B2=n308
XU286 NR3 $PINS O=n518 I1=n519 I2=n101 I3=n249
XU287 ND3 $PINS O=n794 I1=n795 I2=n796 I3=n797
XU288 ND3 $PINS O=n796 I1=n147 I2=n762 I3=n618
XU289 AOI22S $PINS O=n797 A1=n424 A2=n798 B1=n308 B2=n799
XU290 NR2 $PINS O=n626 I1=n437 I2=n420
XU291 AOI22S $PINS O=n884 A1=n438 A2=n889 B1=n467 B2=n890
XU292 ND3 $PINS O=n890 I1=n240 I2=n412 I3=n548
XU293 INV1S $PINS O=n86 I=n324
XU294 NR2 $PINS O=n268 I1=n338 I2=n99
XU295 NR2 $PINS O=n492 I1=n80 I2=n70
XU296 NR2 $PINS O=n775 I1=n326 I2=n68
XU297 AN4B1S $PINS O=n516 I1=n85 I2=n273 I3=n430 B1=n83
XU298 AOI22S $PINS O=n672 A1=n123 A2=n362 B1=n111 B2=n526
XU299 INV1S $PINS O=n420 I=n7
XU300 MOAI1S $PINS O=n910 A1=n27 A2=n354 B1=n424 B2=n249
XU301 MOAI1S $PINS O=n781 A1=n594 A2=n12 B1=n370 B2=n225
XU302 INV1S $PINS O=n47 I=n438
XU303 AOI22S $PINS O=n575 A1=n130 A2=n614 B1=n127 B2=n16
XU304 INV1S $PINS O=n60 I=n567
XU305 NR2 $PINS O=n832 I1=n126 I2=n421
XU306 NR2 $PINS O=n833 I1=FE_OFN308_n271 I2=n413
XU307 AN2 $PINS O=n834 I1=n60 I2=n549
XU308 OAI22S $PINS O=n742 A1=n745 A2=n29 B1=n746 B2=n36
XU309 NR2 $PINS O=n745 I1=n221 I2=n129
XU310 NR2 $PINS O=n746 I1=n79 I2=n77
XU311 NR2 $PINS O=n401 I1=n100 I2=n78
XU312 NR2 $PINS O=n248 I1=n81 I2=n413
XU313 AOI22S $PINS O=n830 A1=n568 A2=n94 B1=n127 B2=n25
XU314 AOI22S $PINS O=n627 A1=n369 A2=n614 B1=n317 B2=n16
XU315 INV1S $PINS O=n44 I=n568
XU316 NR2 $PINS O=n428 I1=n437 I2=n362
XU317 AOI22S $PINS O=n692 A1=n437 A2=n592 B1=n3 B2=n128
XU318 NR2 $PINS O=n257 I1=n99 I2=n340
XU319 NR2 $PINS O=n239 I1=n96 I2=n101
XU320 NR2 $PINS O=n363 I1=n614 I2=n420
XU321 INV1S $PINS O=n21 I=n571
XU322 NR2 $PINS O=n302 I1=n437 I2=n2
XU323 AOI22S $PINS O=n274 A1=n130 A2=n420 B1=n127 B2=n3
XU324 NR2 $PINS O=n403 I1=n100 I2=n94
XU325 NR2 $PINS O=n691 I1=n96 I2=n95
XU326 ND3 $PINS O=n474 I1=n557 I2=n558 I3=n559
XU327 OA22 $PINS O=n558 A1=n10 A2=n566 B1=n30 B2=n414
XU328 AOI22S $PINS O=n557 A1=n567 A2=n568 B1=n3 B2=n131
XU329 NR3 $PINS O=n559 I1=n560 I2=n561 I3=n523
XU330 AOI22S $PINS O=n476 A1=n420 A2=n592 B1=n131 B2=n23
XU331 NR2 $PINS O=n602 I1=n619 I2=n592
XU332 MOAI1S $PINS O=n926 A1=n41 A2=n10 B1=n317 B2=n3
XU333 AOI22S $PINS O=n841 A1=n121 A2=n420 B1=n3 B2=n123
XU334 INV1S $PINS O=n33 I=n16
XU335 AOI22S $PINS O=n435 A1=n437 A2=n619 B1=n127 B2=n362
XU336 OR2 $PINS O=n350 I1=n707 I2=n188
XU337 NR2 $PINS O=n743 I1=n878 I2=n188
XU338 AOI22S $PINS O=n818 A1=n219 A2=n362 B1=n221 B2=n608
XU339 AOI22S $PINS O=n332 A1=n116 A2=FE_OFN308_n271 B1=n112 B2=n80
XU340 NR2 $PINS O=n273 I1=n99 I2=n67
XU341 AOI22S $PINS O=n580 A1=n608 A2=n122 B1=n370 B2=n24
XU342 INV1S $PINS O=n29 I=n437
XU343 AOI22S $PINS O=n871 A1=n128 A2=n16 B1=n2 B2=n107
XU344 AOI22S $PINS O=n528 A1=n212 A2=n111 B1=n16 B2=n125
XU345 AOI22S $PINS O=n292 A1=n308 A2=n309 B1=n23 B2=n129
XU346 AOI12HS $PINS O=n744 A1=n37 B1=n324 B2=n716
XU347 NR2 $PINS O=n716 I1=n326 I2=n67
XU348 OAI12HS $PINS O=n449 A1=n16 B1=n123 B2=n618
XU349 AOI22S $PINS O=n346 A1=n357 A2=n86 B1=n358 B2=n95
XU350 AOI22S $PINS O=n576 A1=n16 A2=n123 B1=n3 B2=n221
XU351 NR2 $PINS O=n211 I1=n2 I2=n16
XU352 AOI22S $PINS O=n699 A1=n70 A2=n438 B1=n99 B2=n357
XU353 AOI22S $PINS O=n684 A1=n567 A2=n568 B1=n218 B2=n28
XU354 NR2 $PINS O=n549 I1=n95 I2=FE_OFN308_n271
XU355 NR2 $PINS O=n240 I1=n81 I2=FE_OFN308_n271
XU356 INV1S $PINS O=n45 I=n357
XU357 NR2 $PINS O=n149 I1=n94 I2=n96
XU358 OA22 $PINS O=n685 A1=n27 A2=n155 B1=n37 B2=n85
XU359 AOI22S $PINS O=n461 A1=n370 A2=n25 B1=n592 B2=n32
XU360 NR2 $PINS O=n631 I1=n101 I2=n100
XU361 AOI22S $PINS O=n206 A1=n123 A2=n3 B1=n221 B2=n16
XU362 OAI112HS $PINS O=n659 A1=n569 B1=n304 C1=n660 C2=n49
XU363 NR2 $PINS O=n660 I1=n84 I2=n661
XU364 NR2 $PINS O=n566 I1=n308 I2=n568
XU365 INV1S $PINS O=n39 I=n483
XU366 NR2 $PINS O=n502 I1=n79 I2=n99
XU367 AOI22S $PINS O=n185 A1=n106 A2=n195 B1=n127 B2=n191
XU368 AOI22S $PINS O=n882 A1=n440 A2=n898 B1=n297 B2=n69
XU369 ND3 $PINS O=n898 I1=n691 I2=n485 I3=n899
XU370 NR2 $PINS O=n899 I1=n80 I2=n69
XU371 AOI22S $PINS O=n436 A1=n437 A2=n124 B1=n420 B2=n131
XU372 INV1S $PINS O=n36 I=n424
XU373 AOI22S $PINS O=n857 A1=n114 A2=n67 B1=n338 B2=n108
XU374 INV1S $PINS O=n43 I=n440
XU375 INV1S $PINS O=n41 I=n297
XU376 ND3 $PINS O=n706 I1=n350 I2=n688 I3=n448
XU377 NR2 $PINS O=n196 I1=n221 I2=n127
XU378 AOI22S $PINS O=n693 A1=n357 A2=n413 B1=n67 B2=n438
XU379 INV1S $PINS O=n48 I=n467
XU380 MOAI1S $PINS O=n295 A1=n11 A2=n296 B1=n297 B2=n298
XU381 NR2 $PINS O=n521 I1=n123 I2=n128
XU382 INV1S $PINS O=n107 I=n188
XU383 AOI22S $PINS O=n207 A1=n2 A2=n124 B1=n220 B2=n93
XU384 INV1S $PINS O=n37 I=n647
XU385 AOI22S $PINS O=n635 A1=n130 A2=n640 B1=n338 B2=n220
XU386 MOAI1S $PINS O=n480 A1=n502 A2=n41 B1=n83 B2=n467
XU387 NR2 $PINS O=n156 I1=n116 I2=n112
XU388 INV1S $PINS O=n108 I=n495
XU389 INV1S $PINS O=n46 I=n358
XU390 NR2 $PINS O=n197 I1=n121 I2=n592
XU391 NR3 $PINS O=n306 I1=n619 I2=n130 I3=n122
XU392 NR2 $PINS O=n157 I1=n163 I2=n164
XU393 AOI22S $PINS O=n572 A1=n127 A2=n437 B1=n130 B2=n2
XU394 INV1S $PINS O=n49 I=n220
XU395 OA12 $PINS O=n877 A1=n107 B1=n614 B2=n437
XU396 NR2 $PINS O=n886 I1=n369 I2=n370
XU397 NR2 $PINS O=n603 I1=n126 I2=n317
XU398 AOI22S $PINS O=n636 A1=n369 A2=n608 B1=n16 B2=n221
XU399 NR2 $PINS O=n415 I1=n125 I2=n618
XU400 NR2 $PINS O=n200 I1=n130 I2=n219
XU401 NR2 $PINS O=n354 I1=n125 I2=n131
XU402 NR2 $PINS O=n155 I1=n125 I2=n370
XU403 NR2 $PINS O=n418 I1=n130 I2=n154
XU404 NR2 $PINS O=n774 I1=n113 I2=n106
XU405 INV1S $PINS O=n109 I=n175
XU406 NR2 $PINS O=n443 I1=n317 I2=n218
XU407 NR2 $PINS O=n715 I1=n125 I2=n127
XU408 NR2 $PINS O=n414 I1=n128 I2=n369
XU409 NR2 $PINS O=n296 I1=n123 I2=n619
XU410 AOI22S $PINS O=n637 A1=n84 A2=n467 B1=n101 B2=n440
XU411 NR2 $PINS O=n463 I1=n67 I2=n309
XU412 NR3 $PINS O=n466 I1=n467 I2=n440 I3=n358
XU413 NR2 $PINS O=n169 I1=n128 I2=n120
XU414 NR2 $PINS O=n167 I1=n221 I2=n592
XU415 NR2 $PINS O=n416 I1=n125 I2=n219
XU416 INV1S $PINS O=n76 I=n285
XU417 AOI22S $PINS O=n617 A1=n221 A2=n28 B1=n128 B2=n362
XU418 NR2 $PINS O=n469 I1=n480 I2=n481
XU419 AN4B1S $PINS O=n470 I1=n471 I2=n472 I3=n473 B1=n474
XU420 NR2 $PINS O=n326 I1=n620 I2=n168
XU421 MOAI1S $PINS O=n583 A1=FE_OFN40_fold_n_4 A2=n584 B1=n23 B2=n618
XU422 AN4B1S $PINS O=n584 I1=n585 I2=n586 I3=n587 B1=n588
XU423 AOI22S $PINS O=n585 A1=n593 A2=n116 B1=n81 B2=n117
XU424 INV1S $PINS O=n101 I=n259
XU425 ND3 $PINS O=n783 I1=n271 I2=n412 I3=n784
XU426 AN2 $PINS O=n784 I1=n237 I2=n605
XU427 AN4B1S $PINS O=n748 I1=n785 I2=n692 I3=n628 B1=n477
XU428 NR2 $PINS O=n749 I1=n780 I2=n781
XU429 AN4B1S $PINS O=n750 I1=n751 I2=n752 I3=n753 B1=n754
XU430 OAI22S $PINS O=n768 A1=n598 A2=n161 B1=n769 B2=n175
XU431 AN4B1S $PINS O=n769 I1=n664 I2=n501 I3=n271 B1=n567
XU432 ND3 $PINS O=n574 I1=n729 I2=n730 I3=n731
XU433 NR3 $PINS O=n730 I1=n742 I2=n743 I3=n744
XU434 AN4B1S $PINS O=n731 I1=n646 I2=n732 I3=n693 B1=n622
XU435 NR3 $PINS O=n313 I1=n318 I2=n319 I3=n320
XU436 OAI222S $PINS O=n319 A1=n330 A2=n264 B1=n156 B2=n10 C1=n331 C2=n202
XU437 OAI222S $PINS O=n320 A1=n321 A2=n161 B1=n322 B2=n246 C1=n323 C2=n213
XU438 OAI112HS $PINS O=n318 A1=n332 B1=n333 C1=n254 C2=n271
XU439 NR2 $PINS O=n267 I1=n56 I2=n269
XU440 ND3 $PINS O=n782 I1=n594 I2=n143 I3=n253
XU441 NR3 $PINS O=n335 I1=n337 I2=n338 I3=n65
XU442 NR3 $PINS O=n334 I1=n339 I2=n340 I3=n94
XU443 NR2 $PINS O=n290 I1=n310 I2=n311
XU444 MOAI1S $PINS O=n311 A1=n312 A2=n36 B1=n317 B2=n16
XU445 OAI222S $PINS O=n310 A1=FE_OFN40_fold_n_4 A2=n313 B1=n151 B2=n27 C1=n314
+ C2=n39
XU446 NR3 $PINS O=n314 I1=n315 I2=n55 I3=n77
XU447 INV1S $PINS O=n110 I=n262
XU448 ND3 $PINS O=n772 I1=n499 I2=n54 I3=n600
XU449 ND3 $PINS O=n770 I1=n631 I2=n236 I3=n496
XU450 NR3 $PINS O=n844 I1=n876 I2=n743 I3=n877
XU451 NR3 $PINS O=n845 I1=n846 I2=n847 I3=n848
XU453 ND3 $PINS O=shift3[0] I1=n535 I2=n536 I3=n537
XU454 AN4B1S $PINS O=n536 I1=n21 I2=n555 I3=n556 B1=n474
XU455 AN4B1S $PINS O=n537 I1=n538 I2=n539 I3=n540 B1=n541
XU456 NR2 $PINS O=n204 I1=n222 I2=n223
XU457 MOAI1S $PINS O=n223 A1=n22 A2=n224 B1=n370 B2=n225
XU458 OAI22S $PINS O=n222 A1=n188 A2=n226 B1=FE_OFN40_fold_n_4 B2=n227
XU459 AN4B1S $PINS O=n227 I1=n228 I2=n229 I3=n230 B1=n231
XU460 AN4B1S $PINS O=n261 I1=n271 I2=n236 I3=n272 B1=n86
XU461 AN4B1S $PINS O=n265 I1=n267 I2=n268 I3=n248 B1=n78
XU462 NR3 $PINS O=n263 I1=n98 I2=n269 I3=n270
XU463 OAI112HS $PINS O=n616 A1=n739 B1=n842 C1=n210 C2=n27
XU464 AOI22S $PINS O=n842 A1=n78 A2=n438 B1=n338 B2=n357
XU465 MOAI1S $PINS O=n392 A1=FE_OFN40_fold_n_4 A2=n393 B1=n25 B2=n221
XU466 AN4B1S $PINS O=n393 I1=n394 I2=n395 I3=n396 B1=n397
XU467 AOI22S $PINS O=n394 A1=n413 A2=n108 B1=n95 B2=n109
XU468 NR3 $PINS O=n405 I1=n410 I2=n73 I3=n411
XU469 NR3 $PINS O=n406 I1=n409 I2=n81 I3=n100
XU470 AN4B1S $PINS O=n407 I1=n408 I2=n201 I3=n267 B1=n94
XU471 NR2 $PINS O=n191 I1=n92 I2=n103
XU472 NR2P $PINS O=n338 I1=n89 I2=n620
XU473 OAI22S $PINS O=n489 A1=n490 A2=n246 B1=n161 B2=n491
XU474 AN4B1S $PINS O=n490 I1=n149 I2=n492 I3=n400 B1=n100
XU475 MOAI1S $PINS O=n481 A1=FE_OFN40_fold_n_4 A2=n482 B1=n483 B2=n484
XU476 AN4B1S $PINS O=n482 I1=n486 I2=n487 I3=n488 B1=n489
XU477 AOI22S $PINS O=n486 A1=n67 A2=n112 B1=n81 B2=n117
XU478 AN4B1S $PINS O=n498 I1=n331 I2=n499 I3=n500 B1=n82
XU479 AN4B1S $PINS O=n497 I1=n501 I2=n201 I3=n500 B1=n413
XU480 MOAI1S $PINS O=n244 A1=n245 A2=n246 B1=n105 B2=n247
XU481 NR2 $PINS O=n245 I1=n81 I2=n249
XU482 MOAI1S $PINS O=n901 A1=n648 A2=n11 B1=n107 B2=n902
XU483 OA12 $PINS O=n903 A1=n878 B1=FE_OFN40_fold_n_4 B2=n253
XU484 NR3 $PINS O=n801 I1=n353 I2=n3 I3=n608
XU485 AN4B1S $PINS O=n805 I1=n259 I2=n597 I3=n724 B1=n338
XU486 NR2 $PINS O=n499 I1=n269 I2=n593
XU487 NR2 $PINS O=n809 I1=n53 I2=n260
XU488 ND3 $PINS O=n277 I1=n343 I2=n344 I3=n345
XU489 NR2 $PINS O=n344 I1=n359 I2=n360
XU490 AN4B1S $PINS O=n345 I1=n346 I2=n347 I3=n348 B1=n349
XU491 AN4B1S $PINS O=n458 I1=n459 I2=n460 I3=n461 B1=n462
XU492 AN4B1S $PINS O=n712 I1=n301 I2=n248 I3=n329 B1=n66
XU493 NR2 $PINS O=n709 I1=n56 I2=n77
XU494 AN4B1S $PINS O=n711 I1=n199 I2=n426 I3=n144 B1=n519
XU496 OAI22S $PINS O=n231 A1=n232 A2=n162 B1=n233 B2=n160
XU497 AN4B1S $PINS O=n232 I1=n236 I2=n72 I3=n237 B1=n238
XU498 AN4B1S $PINS O=n233 I1=n234 I2=n72 I3=n235 B1=n93
XU499 ND3 $PINS O=n238 I1=n239 I2=n144 I3=n240
XU500 ND2 $PINS O=n465 I1=n141 I2=n285
XU501 AN4B1S $PINS O=n893 I1=n87 I2=n71 I3=n50 B1=n896
XU502 AN4B1S $PINS O=n894 I1=n60 I2=n10 I3=n97 B1=n339
XU503 MOAI1S $PINS O=n914 A1=n915 A2=n213 B1=n551 B2=n111
XU504 NR2 $PINS O=n915 I1=n66 I2=n61
XU505 OA22 $PINS O=n909 A1=FE_OFN40_fold_n_4 A2=n911 B1=n216 B2=n611
XU506 AN4B1S $PINS O=n911 I1=n912 I2=n680 I3=n913 B1=n914
XU507 AOI22S $PINS O=n912 A1=n67 A2=n112 B1=n105 B2=n95
XU508 AOI22S $PINS O=n913 A1=n114 A2=n916 B1=n113 B2=n917
XU509 ND3 $PINS O=n590 I1=n268 I2=n252 I3=n336
XU510 NR2 $PINS O=n212 I1=n50 I2=FE_OFN40_fold_n_4
XU511 INV1S $PINS O=n50 I=n269
XU512 NR2 $PINS O=n646 I1=n8 I2=n9
XU513 OAI222S $PINS O=n8 A1=n152 A2=n11 B1=n188 B2=n38 C1=n22 C2=n452
XU514 OAI222S $PINS O=n9 A1=n7 A2=n215 B1=n361 B2=n30 C1=n34 C2=n479
XU515 ND2 $PINS O=n356 I1=n918 I2=n285
XU516 ND3 $PINS O=n531 I1=n643 I2=n644 I3=n645
XU517 AOI22S $PINS O=n644 A1=n100 A2=n647 B1=n467 B2=n67
XU518 AOI22S $PINS O=n643 A1=n413 A2=n440 B1=n424 B2=n326
XU519 ND3 $PINS O=n652 I1=n868 I2=n869 I3=n870
XU520 AN4B1S $PINS O=n870 I1=n871 I2=n475 I3=n818 B1=n532
XU521 OAI22S $PINS O=n397 A1=n398 A2=n264 B1=n399 B2=n246
XU522 AN4B1S $PINS O=n399 I1=n400 I2=n201 I3=n199 B1=n88
XU523 AN4B1S $PINS O=n398 I1=n258 I2=n272 I3=n268 B1=n269
XU524 NR3 $PINS O=n651 I1=n681 I2=n682 I3=n683
XU525 ND3 $PINS O=n682 I1=n533 I2=n692 I3=n576
XU526 ND3 $PINS O=n683 I1=n684 I2=n685 I3=n686
XU527 OAI112HS $PINS O=n681 A1=n471 B1=n695 C1=n40 C2=n264
XU528 AN4B1S $PINS O=n520 I1=n234 I2=n87 I3=n426 B1=n68
XU529 OR2 $PINS O=n10 I1=n198 I2=n620
XU530 INV1S $PINS O=n413 I=n10
XU531 OAI112HS $PINS O=n532 A1=n820 B1=n872 C1=n12 C2=n253
XU532 AN4B1S $PINS O=n133 I1=n134 I2=n135 I3=n136 B1=n137
XU533 AN4B1S $PINS O=n132 I1=n183 I2=n184 I3=n185 B1=n186
XU534 NR3 $PINS O=n321 I1=n328 I2=n79 I3=n69
XU535 INV1S $PINS O=n96 I=n329
XU536 OAI112HS $PINS O=n530 A1=n865 B1=n866 C1=n864 C2=n503
XU537 NR2 $PINS O=n864 I1=n16 I2=n614
XU538 NR2 $PINS O=n340 I1=n171 I2=n620
XU539 MOAI1S $PINS O=n848 A1=FE_OFN40_fold_n_4 A2=n849 B1=n116 B2=n212
XU540 AN4B1S $PINS O=n849 I1=n850 I2=n851 I3=n852 B1=n853
XU541 AOI22S $PINS O=n850 A1=n113 A2=n861 B1=n109 B2=n862
XU542 AN4B1S $PINS O=n852 I1=n856 I2=n332 I3=n857 B1=n858
XU543 NR2 $PINS O=n851 I1=n859 I2=n860
XU544 MOAI1S $PINS O=n860 A1=n257 A2=n177 B1=n159 B2=n95
XU545 OAI22S $PINS O=n859 A1=n239 A2=n150 B1=n800 B2=n254
XU546 AN4B1S $PINS O=n552 I1=n258 I2=n329 I3=n325 B1=n68
XU547 INV1S $PINS O=n58 I=n327
XU548 ND3 $PINS O=n622 I1=n733 I2=n734 I3=n735
XU549 OA22 $PINS O=n733 A1=n452 A2=n626 B1=n54 B2=n47
XU550 MAOI1 $PINS O=n734 A1=n308 A2=n738 B1=n361 B2=n625
XU551 OR2 $PINS O=n11 I1=n35 I2=n168
XU552 INV1S $PINS O=n614 I=n11
XU553 ND3 $PINS O=n299 I1=n11 I2=n30 I3=n302
XU554 INV1S $PINS O=n71 I=n904
XU555 NR2 $PINS O=n324 I1=n338 I2=n593
XU556 OAI22S $PINS O=n853 A1=n854 A2=n139 B1=n855 B2=n465
XU557 NR2 $PINS O=n855 I1=n111 I2=n159
XU558 AN2 $PINS O=n854 I1=n259 I2=n400
XU559 AN4B1S $PINS O=n807 I1=n747 I2=n253 I3=n240 B1=n419
XU560 INV1S $PINS O=n52 I=n337
XU561 AN4B1S $PINS O=n808 I1=n671 I2=n271 I3=n325 B1=n53
XU562 OAI222S $PINS O=n666 A1=n668 A2=n41 B1=n669 B2=n43 C1=n199 C2=n36
XU563 AN4B1S $PINS O=n668 I1=n408 I2=n87 I3=n553 B1=n69
XU564 NR3 $PINS O=n669 I1=n670 I2=n55 I3=n73
XU565 MOAI1S $PINS O=n423 A1=n34 A2=n224 B1=n424 B2=n425
XU566 INV1S $PINS O=n95 I=n199
XU567 INV1S $PINS O=n70 I=n237
XU568 AN2 $PINS O=n402 I1=n236 I2=n404
XU569 MOAI1S $PINS O=n477 A1=n786 A2=n648 B1=n787 B2=n130
XU570 NR2 $PINS O=n786 I1=n437 I2=n225
XU571 NR2 $PINS O=n147 I1=n620 I2=FE_OFN40_fold_n_4
XU572 MOAI1S $PINS O=n524 A1=n525 A2=n355 B1=n526 B2=n108
XU573 OAI222S $PINS O=n512 A1=n273 A2=n36 B1=FE_OFN40_fold_n_4 B2=n513 C1=n514
+ C2=n49
XU574 AN4B1S $PINS O=n514 I1=n515 I2=n401 I3=n271 B1=n53
XU575 NR2 $PINS O=n517 I1=n78 I2=n338
XU576 NR2 $PINS O=n437 I1=n35 I2=n198
XU577 AOI22S $PINS O=n656 A1=n467 A2=n662 B1=n358 B2=n663
XU578 ND3 $PINS O=n663 I1=n664 I2=n501 I3=n665
XU579 NR2 $PINS O=n665 I1=n269 I2=n78
XU580 OAI222S $PINS O=n838 A1=n12 A2=n465 B1=n363 B2=n611 C1=n34 C2=n452
XU581 OAI222S $PINS O=n422 A1=n428 A2=n166 B1=n302 B2=n188 C1=n429 C2=n41
XU582 AN4B1S $PINS O=n429 I1=n252 I2=n236 I3=n430 B1=n73
XU583 NR2 $PINS O=n178 I1=n269 I2=n326
XU584 OAI222S $PINS O=n718 A1=n719 A2=n41 B1=n216 B2=n215 C1=n720 C2=n166
XU585 NR3 $PINS O=n719 I1=n519 I2=FE_OFN308_n271 I3=n63
XU586 INV1S $PINS O=n91 I=n182
XU587 MOAI1S $PINS O=n812 A1=n813 A2=n41 B1=n28 B2=n369
XU588 NR3 $PINS O=n813 I1=n814 I2=n65 I3=n298
XU589 NR2 $PINS O=n438 I1=n254 I2=FE_OFN40_fold_n_4
XU590 NR2 $PINS O=n567 I1=n620 I2=n170
XU591 NR2 $PINS O=n921 I1=n128 I2=n130
XU592 NR2 $PINS O=n922 I1=n370 I2=n122
XU593 NR2 $PINS O=n920 I1=n2 I2=n614
XU594 OR2 $PINS O=n12 I1=n139 I2=FE_OFN40_fold_n_4
XU595 INV1S $PINS O=n308 I=n12
XU596 NR2 $PINS O=n568 I1=n175 I2=FE_OFN40_fold_n_4
XU597 OA22 $PINS O=n785 A1=n929 A2=n152 B1=n355 B2=n930
XU598 NR2 $PINS O=n929 I1=n614 I2=n787
XU599 NR2 $PINS O=n303 I1=n128 I2=n619
XU600 OAI222S $PINS O=n450 A1=n415 A2=n7 B1=n354 B2=n22 C1=n47 C2=n236
XU601 AN4B1S $PINS O=n446 I1=n447 I2=n448 I3=n449 B1=n450
XU602 OR2 $PINS O=n688 I1=n479 I2=n363
XU603 AOI22S $PINS O=n348 A1=n3 A2=n352 B1=n619 B2=n353
XU604 MOAI1S $PINS O=n359 A1=n363 A2=n152 B1=n23 B2=n218
XU605 INV1S $PINS O=n85 I=n593
XU606 OAI222S $PINS O=n925 A1=n363 A2=n505 B1=n485 B2=n39 C1=n302 C2=n173
XU607 OAI112HS $PINS O=n819 A1=n736 B1=n820 C1=n166 C2=n11
XU608 AOI22S $PINS O=n696 A1=n437 A2=n122 B1=n2 B2=n131
XU609 AOI22S $PINS O=n697 A1=n619 A2=n3 B1=n618 B2=n420
XU610 OA22 $PINS O=n208 A1=n214 A2=n215 B1=n216 B2=n217
XU611 NR2 $PINS O=n217 I1=n369 I2=n218
XU612 NR2 $PINS O=n214 I1=n16 I2=n25
XU613 OAI22S $PINS O=n858 A1=n316 A2=n160 B1=n331 B2=n262
XU614 NR2 $PINS O=n687 I1=FE_OFN308_n271 I2=n100
XU615 OR2 $PINS O=n448 I1=n478 I2=n611
XU616 AOI22S $PINS O=n613 A1=n614 A2=n615 B1=n67 B2=n308
XU617 AOI22S $PINS O=n612 A1=n123 A2=n420 B1=n121 B2=n32
XU618 AOI22S $PINS O=n562 A1=n420 A2=n619 B1=n16 B2=n131
XU619 AOI22S $PINS O=n563 A1=n358 A2=n564 B1=n297 B2=n565
XU620 AOI22S $PINS O=n570 A1=n424 A2=n98 B1=n297 B2=n67
XU621 NR2 $PINS O=n172 I1=n181 I2=n182
XU622 AN2 $PINS O=n176 I1=n76 I2=n178
XU623 NR2 $PINS O=n174 I1=n179 I2=n180
XU624 AN4B1S $PINS O=n759 I1=n760 I2=n452 I3=n761 B1=n154
XU625 NR2 $PINS O=n806 I1=n99 I2=n593
XU626 MOAI1S $PINS O=n209 A1=n210 A2=n211 B1=n212 B2=n163
XU627 OAI222S $PINS O=n831 A1=n155 A2=n428 B1=n626 B2=n210 C1=n200 C2=n29
XU628 NR2 $PINS O=n357 I1=n177 I2=FE_OFN40_fold_n_4
XU629 ND3 $PINS O=n762 I1=n931 I2=n168 I3=n932
XU630 NR2 $PINS O=n931 I1=n179 I2=n59
XU631 OAI22S $PINS O=n677 A1=FE_OFN40_fold_n_4 A2=n680 B1=n607 B2=n36
XU632 OA22 $PINS O=n228 A1=n175 A2=n268 B1=n202 B2=n273
XU633 AOI22S $PINS O=n694 A1=n647 A2=n81 B1=n424 B2=n96
XU634 INV1S $PINS O=n111 I=n266
XU635 INV1S $PINS O=n619 I=n210
XU636 INV1S $PINS O=n59 I=n170
XU637 MOAI1S $PINS O=n839 A1=n189 A2=n307 B1=n16 B2=n125
XU638 MOAI1S $PINS O=n667 A1=n215 A2=n307 B1=n106 B2=n212
XU639 AN4B1S $PINS O=n145 I1=n156 I2=n157 I3=n158 B1=n159
XU640 AN4B1S $PINS O=n148 I1=n151 I2=n152 I3=n153 B1=n154
XU641 AN4B1S $PINS O=n158 I1=n160 I2=n161 I3=n162 B1=n115
XU642 NR2 $PINS O=n483 I1=n162 I2=FE_OFN40_fold_n_4
XU643 MOAI1S $PINS O=n360 A1=n361 A2=n27 B1=n362 B2=n369
XU644 MOAI1S $PINS O=n560 A1=n210 A2=n33 B1=n317 B2=n362
XU645 NR2 $PINS O=n424 I1=n160 I2=FE_OFN40_fold_n_4
XU646 NR2 $PINS O=n440 I1=n495 I2=FE_OFN40_fold_n_4
XU647 NR2 $PINS O=n297 I1=n150 I2=FE_OFN40_fold_n_4
XU648 OAI222S $PINS O=n810 A1=n361 A2=n27 B1=n7 B2=n215 C1=n611 C2=n22
XU649 INV1S $PINS O=n221 I=n355
XU650 NR2 $PINS O=n467 I1=n262 I2=FE_OFN40_fold_n_4
XU651 INV1S $PINS O=n113 I=n264
XU652 INV1S $PINS O=n128 I=n215
XU653 INV1S $PINS O=n116 I=n177
XU654 ND2 $PINS O=n188 I1=n385 I2=n372
XU655 ND2 $PINS O=n262 I1=n891 I2=n385
XU656 MOAI1S $PINS O=n727 A1=n189 A2=n307 B1=n437 B2=n123
XU657 INV1S $PINS O=n117 I=n254
XU658 INV1S $PINS O=n115 I=n150
XU659 NR2 $PINS O=n647 I1=n266 I2=FE_OFN40_fold_n_4
XU660 OAI222S $PINS O=n900 A1=n611 A2=n7 B1=n361 B2=n30 C1=n189 C2=n33
XU661 INV1S $PINS O=n369 I=n452
XU662 INV1S $PINS O=n114 I=n246
XU663 MOAI1S $PINS O=n847 A1=n503 A2=n302 B1=n121 B2=n16
XU664 MOAI1S $PINS O=n642 A1=n648 A2=n27 B1=n121 B2=n437
XU665 NR2 $PINS O=n358 I1=n202 I2=FE_OFN40_fold_n_4
XU666 INV1S $PINS O=n112 I=n202
XU667 INV1S $PINS O=n105 I=n161
XU668 INV1S $PINS O=n592 I=n835
XU669 MOAI1S $PINS O=n638 A1=n22 A2=n603 B1=n99 B2=n639
XU670 INV1S $PINS O=n123 I=n505
XU671 AN2 $PINS O=n165 I1=n171 I2=n92
XU672 INV1S $PINS O=n127 I=n648
XU673 NR2 $PINS O=n220 I1=n213 I2=FE_OFN40_fold_n_4
XU674 INV1S $PINS O=n130 I=n189
XU675 ND3 $PINS O=n164 I1=n266 I2=n262 I3=n264
XU676 INV1S $PINS O=n618 I=n224
XU677 INV1S $PINS O=n317 I=n361
XU678 NR2 $PINS O=n146 I1=FE_OFN40_fold_n_4 I2=n374
XU679 INV1S $PINS O=n370 I=n166
XU680 INV1S $PINS O=n131 I=n611
XU681 INV1S $PINS O=n106 I=n213
XU682 ND3 $PINS O=n154 I1=n224 I2=n210 I3=n443
XU683 INV1S $PINS O=n219 I=n152
XU684 INV1S $PINS O=n121 I=n173
XU685 INV1S $PINS O=n125 I=n479
XU686 INV1S $PINS O=n218 I=n503
XU687 INV1S $PINS O=n90 I=n374
XU688 AOI22S $PINS O=n379 A1=n141 A2=n372 B1=n107 B2=n103
XU689 INV1S $PINS O=n104 I=n385
XU690 NR2 $PINS O=n141 I1=n_idx[1] I2=n_idx[0]
XU691 AOI22S $PINS O=n751 A1=n763 A2=n18 B1=n23 B2=n122
XU692 ND3 $PINS O=n763 I1=n764 I2=n765 I3=n766
XU693 NR2 $PINS O=n766 I1=n767 I2=n768
XU694 NR2 $PINS O=n918 I1=n103 I2=n_idx[0]
XU696 NR2 $PINS O=n193 I1=n620 I2=n_idx[1]
XU697 INV1S $PINS O=n92 I=n375
XU698 NR2 $PINS O=n269 I1=n168 I2=n_idx[0]
XU699 NR2 $PINS O=n593 I1=n89 I2=n_idx[0]
XU700 ND2 $PINS O=n143 I1=n193 I2=n897
XU701 ND2 $PINS O=n236 I1=n193 I2=n919
XU702 OAI222S $PINS O=n186 A1=n187 A2=n188 B1=n71 B2=n189 C1=n171 C2=n152
XU703 AN4B1S $PINS O=n187 I1=n29 I2=n40 I3=n190 B1=n191
XU704 AOI22S $PINS O=n190 A1=n192 A2=n1 B1=FE_OFN40_fold_n_4 B2=n92
XU705 OR2 $PINS O=n192 I1=n193 I2=n194
XU706 NR2 $PINS O=n904 I1=n76 I2=n_idx[1]
XU707 NR2 $PINS O=n182 I1=n92 I2=n_idx[1]
XU708 NR2 $PINS O=n374 I1=n91 I2=n_idx[0]
XU709 NR2 $PINS O=n385 I1=n118 I2=n630
XU711 OAI112HS $PINS O=n447 A1=n18 B1=n105 C1=n95 C2=n338
XU712 OAI12HS $PINS O=sign2[1] A1=n280 B1=n278 B2=n279
XU713 AOI22S $PINS O=n278 A1=n281 A2=n740 B1=n282 B2=n283
XU714 NR2 $PINS O=n281 I1=FE_OFN40_fold_n_4 I2=n286
XU715 MOAI1S $PINS O=n282 A1=k_idx[2] A2=n284 B1=n630 B2=n195
XU716 NR2 $PINS O=n372 I1=n19 I2=n283
XU717 NR2 $PINS O=n194 I1=FE_OFN40_fold_n_4 I2=n_idx[0]
XU718 ND2 $PINS O=n264 I1=n892 I2=n923
XU719 MOAI1S $PINS O=n137 A1=n138 A2=n139 B1=n117 B2=n140
XU720 AN4B1S $PINS O=n138 I1=n92 I2=n18 I3=n144 B1=n101
XU721 ND3 $PINS O=n142 I1=n92 I2=n18 I3=n143
XU722 NR2 $PINS O=n888 I1=n283 I2=k_idx[2]
XU723 ND2 $PINS O=n246 I1=n867 I2=n892
XU724 ND2 $PINS O=n202 I1=n891 I2=n892
XU725 ND2 $PINS O=n161 I1=n385 I2=n923
XU726 ND2 $PINS O=n224 I1=n875 I2=n874
XU727 AN2 $PINS O=n895 I1=n933 I2=n20
XU734 ND2 $PINS O=n213 I1=n873 I2=n385
XU735 ND2 $PINS O=n361 I1=n923 I2=n874
XU743 ND2 $PINS O=n166 I1=n372 I2=n874
XU746 ND2 $PINS O=n152 I1=n891 I2=n874
XU773 AOI12HS $PINS O=n382 A1=n179 B1=n384 B2=n181
XU779 NR2 $PINS O=n867 I1=n376 I2=k_idx[2]
XU790 NR2 $PINS O=n875 I1=n376 I2=n19
XU792 AN2 $PINS O=n891 I1=n928 I2=n20
XU800 NR2 $PINS O=n181 I1=n103 I2=n1
XU804 AOI13HS $PINS O=n284 A1=n285 B1=n_idx[0] B2=n630 B3=n181
XU805 INV1S $PINS O=n119 I=n384
XU809 INV1S $PINS O=n740 I=n283
XU822 NR2 $PINS O=n919 I1=n1 I2=n_idx[2]
XU830 NR2 $PINS O=n897 I1=n102 I2=FE_OFN211_fold_n_3
XU831 ND3 $PINS O=sign2[0] I1=n289 I2=n290 I3=n291
XU833 AN4B1S $PINS O=n291 I1=n292 I2=n293 I3=n294 B1=n295
XU840 AN4B1S $PINS O=n289 I1=n26 I2=n341 I3=n342 B1=n277
XU844 ND3 $PINS O=sign3[0] I1=n203 I2=n204 I3=n205
XU851 AN4B1S $PINS O=n205 I1=n206 I2=n207 I3=n208 B1=n209
XU852 AN4B1S $PINS O=n203 I1=n274 I2=n275 I3=n276 B1=n277
XU859 ND3 $PINS O=sign1[0] I1=n386 I2=n387 I3=n388
XU869 NR2 $PINS O=n387 I1=n422 I2=n423
XU880 AN4B1S $PINS O=n386 I1=n364 I2=n431 I3=n276 B1=n367
XU888 NR2 $PINS O=n375 I1=FE_OFN211_fold_n_3 I2=n_idx[2]
XU892 INV1S $PINS O=n18 I=FE_OFN40_fold_n_4
XU896 NR2 $PINS O=n892 I1=n118 I2=k_idx[1]
XU897 INV1S $PINS O=n118 I=k_idx[0]
XU903 INV1S $PINS O=n630 I=k_idx[1]
XU904 NR2 $PINS O=n384 I1=k_idx[1] I2=k_idx[0]
XU906 OAI12HS $PINS O=sign1[1] A1=n280 B1=n368 B2=n279
XU910 AOI22S $PINS O=n368 A1=n377 A2=n283 B1=n378 B2=n18
XU911 OAI112HS $PINS O=n378 A1=n380 B1=n90 C1=FE_OFN211_fold_n_3 C2=n379
XU912 OAI222S $PINS O=n377 A1=k_idx[2] A2=n382 B1=n76 B2=n383 C1=n119 C2=n75
XU913 NR2 $PINS O=n933 I1=k_idx[4] I2=k_idx[2]
XU915 INV1S $PINS O=n19 I=k_idx[2]
XU916 AN2 $PINS O=n923 I1=n928 I2=k_idx[3]
XU917 NR2 $PINS O=n928 I1=n19 I2=k_idx[4]
XU918 INV1S $PINS O=n20 I=k_idx[3]
XU919 NR2 $PINS O=n280 I1=n13 I2=n14
XU926 OAI22S $PINS O=n13 A1=k_idx[0] A2=n_idx[0] B1=n146 B2=n740
XU928 AO13S $PINS O=n14 A1=n373 B1=n371 B2=n18 B3=n372
XU929 AOI13HS $PINS O=n373 A1=n18 B1=k_idx[2] B2=k_idx[1] B3=n374
XU931 AN2 $PINS O=n873 I1=n933 I2=k_idx[3]
XU932 AOI22S $PINS O=n287 A1=k_idx[2] A2=n288 B1=n141 B2=k_idx[1]
XU933 MOAI1S $PINS O=n288 A1=n_idx[1] A2=n118 B1=n620 B2=k_idx[1]
XU935 ND3 $PINS O=n380 I1=k_idx[1] I2=n381 I3=n740
XU940 MOAI1S $PINS O=n381 A1=n118 A2=n91 B1=n620 B2=n375
XU942 OAI12HS $PINS O=n279 A1=n376 B1=k_idx[4] B2=n20
.ENDS

.SUBCKT SNPS_CLOCK_GATE_HIGH_ROM_Wrapper_Odd_1 EN ENCLK CLK
*.CONNECT net2350 EN
XFE_PHC893_net2353 DELC $PINS O=FE_PHN893_net2353 I=net2353
Xlatch QDBHN $PINS Q=net2353 D=net2350 CKB=CLK
Xmain_gate AN2T $PINS O=ENCLK I1=FE_PHN893_net2353 I2=CLK
.ENDS

.SUBCKT ROM_Wrapper_Odd_1 rst_n en n_in[4] n_in[3] n_in[2] n_in[1] n_in[0]
+ k_idx[4] k_idx[3] k_idx[2] k_idx[1] k_idx[0] reg_sign1[1] reg_sign1[0]
+ reg_sign2[1] reg_sign2[0] reg_sign3[1] reg_sign3[0] reg_shift1[3]
+ reg_shift1[2] reg_shift1[1] reg_shift1[0] reg_shift2[3] reg_shift2[2]
+ reg_shift2[1] reg_shift2[0] reg_shift3[3] reg_shift3[2] reg_shift3[1]
+ reg_shift3[0] i_rst_n FE_OFN13_i_rst_n clk
*.CONNECT N4 n_in[0]
XCTS_ccl_a_INV_CLK_G1_L8_17 INV3CK $PINS O=CTS_10 I=CTS_11
XCTS_ccl_a_INV_CLK_G1_L7_17 INV2CK $PINS O=CTS_11 I=CTS_12
XFE_OFC223_rom_n_idx_3__0 INV1S $PINS O=n6 I=n_in[0]
Xreg_sign1_reg[1] DFFSBN $PINS Q=reg_sign1[1] D=raw_s1[1] CK=CTS_10
+ SB=FE_OFN13_i_rst_n
Xreg_sign2_reg[1] DFFSBN $PINS Q=reg_sign2[1] D=raw_s2[1] CK=CTS_10
+ SB=FE_OFN13_i_rst_n
Xreg_sign3_reg[1] DFFSBN $PINS Q=reg_sign3[1] D=raw_s3[1] CK=CTS_10
+ SB=FE_OFN13_i_rst_n
Xreg_shift2_reg[1] QDFFRBP $PINS Q=reg_shift2[1] D=raw_h2[1] CK=CTS_10
+ RB=FE_OFN13_i_rst_n
Xreg_shift3_reg[1] QDFFRBN $PINS Q=reg_shift3[1] D=raw_h3[1] CK=CTS_10
+ RB=FE_OFN13_i_rst_n
Xreg_shift1_reg[1] QDFFRBN $PINS Q=reg_shift1[1] D=raw_h1[1] CK=CTS_10
+ RB=FE_OFN13_i_rst_n
Xreg_shift2_reg[2] QDFFRBN $PINS Q=reg_shift2[2] D=raw_h2[2] CK=CTS_10
+ RB=i_rst_n
Xreg_shift2_reg[3] QDFFRBN $PINS Q=reg_shift2[3] D=raw_h2[3] CK=CTS_10
+ RB=FE_OFN13_i_rst_n
Xreg_shift1_reg[2] QDFFRBN $PINS Q=reg_shift1[2] D=raw_h1[2] CK=CTS_10
+ RB=i_rst_n
Xreg_shift2_reg[0] QDFFRBP $PINS Q=reg_shift2[0] D=raw_h2[0] CK=CTS_10
+ RB=FE_OFN13_i_rst_n
Xreg_shift3_reg[0] QDFFRBP $PINS Q=reg_shift3[0] D=raw_h3[0] CK=CTS_10
+ RB=FE_OFN13_i_rst_n
Xreg_sign2_reg[0] QDFFRBN $PINS Q=reg_sign2[0] D=final_s2[0] CK=CTS_10
+ RB=FE_OFN13_i_rst_n
Xreg_sign3_reg[0] QDFFRBN $PINS Q=reg_sign3[0] D=final_s3[0] CK=CTS_10
+ RB=FE_OFN13_i_rst_n
Xreg_shift1_reg[3] QDFFRBP $PINS Q=reg_shift1[3] D=raw_h1[3] CK=CTS_10
+ RB=FE_OFN13_i_rst_n
Xreg_shift1_reg[0] QDFFRBN $PINS Q=reg_shift1[0] D=raw_h1[0] CK=CTS_10
+ RB=FE_OFN13_i_rst_n
Xreg_shift3_reg[3] QDFFRBN $PINS Q=reg_shift3[3] D=raw_h3[3] CK=CTS_10
+ RB=i_rst_n
Xreg_shift3_reg[2] QDFFRBS $PINS Q=reg_shift3[2] D=raw_h3[2] CK=CTS_10
+ RB=i_rst_n
Xreg_sign1_reg[0] QDFFRBN $PINS Q=reg_sign1[0] D=final_s1[0] CK=CTS_10
+ RB=FE_OFN13_i_rst_n
XU3 NR2 $PINS O=sub_17/carry[2] I1=N4 I2=n_in[1]
XU5 MOAI1 $PINS O=fold_n[1] A1=n4 A2=N2 B1=N5 B2=N2
XU6 MOAI1S $PINS O=fold_n[3] A1=n3 A2=N2 B1=N7 B2=N2
XU7 AN2S $PINS O=sub_17/carry[3] I1=sub_17/carry[2] I2=n5
XU8 ND3S $PINS O=n10 I1=N2 I2=n11 I3=k_idx[0]
XU10 MOAI1 $PINS O=fold_n[0] A1=n6 A2=N2 B1=N4 B2=N2
XU11 XNR2HS $PINS O=final_s2[0] I1=raw_s2[0] I2=n10
XU12 XNR2HS $PINS O=final_s3[0] I1=raw_s3[0] I2=n10
XU13 INV1S $PINS O=n4 I=n_in[1]
XU14 XNR2HS $PINS O=final_s1[0] I1=raw_s1[0] I2=n10
XU15 OA13 $PINS O=N2 A1=n_in[4] B1=n_in[1] B2=N4 B3=n7
XU16 INV1S $PINS O=n5 I=n_in[2]
XU17 MOAI1S $PINS O=fold_n[2] A1=n5 A2=N2 B1=N6 B2=N2
XU18 INV1S $PINS O=n3 I=n_in[3]
XU19 MOAI1S $PINS O=fold_n[4] A1=n8 A2=N2 B1=N8 B2=N2
XU20 INV1S $PINS O=n8 I=n_in[4]
XU22 ND3 $PINS O=n11 I1=k_idx[4] I2=k_idx[3] I3=n12
XU23 AN2 $PINS O=n12 I1=k_idx[2] I2=k_idx[1]
XU24 XOR2HS $PINS O=N8 I1=n8 I2=sub_17/carry[4]
XU25 AN2 $PINS O=sub_17/carry[4] I1=sub_17/carry[3] I2=n3
XU26 XOR2HS $PINS O=N7 I1=n3 I2=sub_17/carry[3]
XU27 XOR2HS $PINS O=N6 I1=n5 I2=sub_17/carry[2]
XU28 XOR2HS $PINS O=N5 I1=n4 I2=n6
XU29 OR2 $PINS O=n7 I1=n_in[3] I2=n_in[2]
Xrom_inst CSD_ROM_Table_odd_1 $PINS n_idx[4]=fold_n[4] n_idx[3]=fold_n[3]
+ n_idx[2]=fold_n[2] n_idx[1]=fold_n[1] n_idx[0]=fold_n[0] k_idx[4]=k_idx[4]
+ k_idx[3]=k_idx[3] k_idx[2]=k_idx[2] k_idx[1]=k_idx[1] k_idx[0]=k_idx[0]
+ sign1[1]=raw_s1[1] sign1[0]=raw_s1[0] shift1[3]=raw_h1[3] shift1[2]=raw_h1[2]
+ shift1[1]=raw_h1[1] shift1[0]=raw_h1[0] sign2[1]=raw_s2[1] sign2[0]=raw_s2[0]
+ shift2[3]=raw_h2[3] shift2[2]=raw_h2[2] shift2[1]=raw_h2[1] shift2[0]=raw_h2[0]
+ sign3[1]=raw_s3[1] sign3[0]=raw_s3[0] shift3[3]=raw_h3[3] shift3[2]=raw_h3[2]
+ shift3[1]=raw_h3[1] shift3[0]=raw_h3[0]
Xclk_gate_reg_shift1_reg SNPS_CLOCK_GATE_HIGH_ROM_Wrapper_Odd_1 $PINS EN=en
+ ENCLK=CTS_12 CLK=clk
.ENDS

.SUBCKT CSD_ROM_Table_even_0 n_idx[4] n_idx[3] n_idx[2] n_idx[1] n_idx[0]
+ k_idx[4] k_idx[3] k_idx[2] k_idx[1] k_idx[0] sign1[1] sign1[0] shift1[3]
+ shift1[2] shift1[1] shift1[0] sign2[1] sign2[0] shift2[3] shift2[2] shift2[1]
+ shift2[0] sign3[1] sign3[0] shift3[3] shift3[2] shift3[1] shift3[0]
XFE_OFC165_fold_n_0 INV1S $PINS O=FE_OFN141_fold_n_0 I=n_idx[0]
XFE_OFC164_fold_n_0 INV1S $PINS O=FE_OFN140_fold_n_0 I=n_idx[0]
XFE_OFC163_fold_n_0 BUF1 $PINS O=n112 I=n_idx[0]
XFE_OFC146_n1 INV1S $PINS O=n37 I=n1
XU776 OA222 $PINS O=n1834 A1=n1826 A2=n97 B1=n1825 B2=n1824 C1=n1823 C2=n1822
XU777 OR3B2 $PINS O=n1814 I1=n1813 B1=n1812 B2=n1811
XU778 ND2 $PINS O=n1810 I1=n40 I2=FE_OFN141_fold_n_0
XU779 AO12 $PINS O=n1799 A1=n1796 B1=n109 B2=n1797
XU780 AO112 $PINS O=n1791 A1=n_idx[4] B1=n1789 C1=n1790 C2=n_idx[3]
XU782 OA222 $PINS O=n1752 A1=n1751 A2=n1815 B1=n1750 B2=n1749 C1=n1748 C2=n1747
XU783 ND2 $PINS O=n1745 I1=n1743 I2=n1742
XU784 ND2 $PINS O=n1746 I1=n1741 I2=n1740
XU785 ND2 $PINS O=n1738 I1=n1737 I2=n88
XU786 ND2 $PINS O=n1739 I1=n1802 I2=n1736
XU787 AN3B2S $PINS O=n1731 I1=n1729 B1=n1728 B2=n1727
XU788 AN3 $PINS O=n1720 I1=n1719 I2=n1718 I3=n1758
XU789 OR3B2 $PINS O=n1717 I1=n1713 B1=n1712 B2=n34
XU790 AN3 $PINS O=n1710 I1=n1707 I2=n1706 I3=n1705
XU791 AO12 $PINS O=sign2[1] A1=n1702 B1=n1704 B2=n1703
XU792 AO222 $PINS O=n1703 A1=n1701 A2=n991 B1=n1700 B2=n1699 C1=n1698 C2=n1697
XU793 AO12 $PINS O=n1690 A1=k_idx[0] B1=FE_OFN141_fold_n_0 B2=k_idx[2]
XU794 ND2 $PINS O=n1671 I1=n1667 I2=n1804
XU795 AO12 $PINS O=n1675 A1=n1665 B1=n1666 B2=n1755
XU796 OA222 $PINS O=n1662 A1=n1661 A2=n1762 B1=n1660 B2=n1659 C1=n1658 C2=n1824
XU797 ND2 $PINS O=n1626 I1=n82 I2=n418
XU798 AO12 $PINS O=sign1[1] A1=n1702 B1=n1704 B2=n1623
XU799 ND2 $PINS O=n1798 I1=n_idx[4] I2=n96
XU800 AN3 $PINS O=n1622 I1=n1621 I2=FE_OFN141_fold_n_0 I3=n1620
XU801 OR3 $PINS O=n1621 I1=n1696 I2=n40 I3=n_idx[1]
XU802 ND2 $PINS O=n1614 I1=n133 I2=n1696
XU803 ND2 $PINS O=n1696 I1=n1692 I2=k_idx[2]
XU804 OA222 $PINS O=n1603 A1=n1596 A2=n1747 B1=n1595 B2=n1632 C1=n1594 C2=n1730
XU805 OA222 $PINS O=n1604 A1=n1590 A2=n1806 B1=n1589 B2=n1588 C1=n1587 C2=n1586
XU806 OA222 $PINS O=n1605 A1=n92 A2=n99 B1=n81 B2=n94 C1=n77 C2=n1740
XU807 ND2 $PINS O=n1708 I1=n1566 I2=n1565
XU810 OA112 $PINS O=n1711 A1=n1555 B1=n1554 C1=n77 C2=n1556
XU811 ND2 $PINS O=n1551 I1=n1802 I2=n1578
XU812 ND2 $PINS O=n1539 I1=n1 I2=n1538
XU813 ND2 $PINS O=n1535 I1=n1532 I2=n1736
XU814 AO12 $PINS O=n1537 A1=n1762 B1=n1815 B2=n1531
XU815 ND2 $PINS O=n1527 I1=n62 I2=n131
XU816 OA222 $PINS O=n1519 A1=n77 A2=n1659 B1=n1574 B2=n1679 C1=n98 C2=n92
XU817 OA222 $PINS O=n1520 A1=n1514 A2=n1831 B1=n1513 B2=n1766 C1=n1512 C2=n1762
XU818 AN3B2S $PINS O=n1513 I1=n1827 B1=n1635 B2=n55
XU819 AN3B2S $PINS O=n1496 I1=n1484 B1=n1483 B2=n1482
XU820 AN3 $PINS O=n1468 I1=n1750 I2=n1827 I3=n1465
XU821 OA222 $PINS O=n1471 A1=n92 A2=n1464 B1=n1463 B2=n1667 C1=n1462 C2=n1659
XU822 OA222 $PINS O=n1473 A1=n1575 A2=n1824 B1=n1458 B2=n1806 C1=n1719 C2=n1634
XU823 AN3B2S $PINS O=n1451 I1=n1498 B1=n1450 B2=n37
XU824 OA112 $PINS O=n1444 A1=n1442 B1=n1441 C1=n1762 C2=n1725
XU825 AN3 $PINS O=n1427 I1=n1419 I2=n1418 I3=n1555
XU826 ND2 $PINS O=n1555 I1=n130 I2=n1417
XU827 ND2 $PINS O=n1415 I1=n1715 I2=n1757
XU828 ND2 $PINS O=n1416 I1=n1669 I2=n86
XU829 ND2 $PINS O=n1411 I1=n54 I2=n1538
XU830 OA222 $PINS O=n1435 A1=n73 A2=n1659 B1=n1409 B2=n1749 C1=n1408 C2=n1494
XU831 AN3B2S $PINS O=n1409 I1=n1407 B1=n1406 B2=n1497
XU832 OR3B2 $PINS O=n1395 I1=n1656 B1=n1510 B2=n1580
XU833 ND2 $PINS O=n1396 I1=n1394 I2=n2
XU834 OA222 $PINS O=n1376 A1=n1372 A2=n1643 B1=n1371 B2=n1749 C1=n1370 C2=n1494
XU835 ND2 $PINS O=n1552 I1=n1655 I2=n1593
XU836 OA222 $PINS O=n1377 A1=n1367 A2=n1764 B1=n1422 B2=n1366 C1=n1365 C2=n1762
XU837 OA222 $PINS O=n1378 A1=n1363 A2=n1831 B1=n1592 B2=n1632 C1=n1362 C2=n1824
XU838 AN3B2S $PINS O=n1381 I1=n1446 B1=n1355 B2=n1430
XU839 AN3 $PINS O=n1478 I1=n1349 I2=n1348 I3=n1347
XU840 OA112 $PINS O=n1348 A1=n1418 B1=n1337 C1=n1338 C2=n1740
XU841 AO12 $PINS O=n1337 A1=n1659 B1=n64 B2=n1336
XU842 OA222 $PINS O=n1349 A1=n1587 A2=n1764 B1=n1335 B2=n1679 C1=n1743 C2=n64
XU843 OA112 $PINS O=n1528 A1=n1334 B1=n1333 C1=n1679 C2=n1725
XU844 OA222 $PINS O=n1333 A1=n1822 A2=n28 B1=n1332 B2=n6 C1=n1387 C2=n1740
XU845 OA222 $PINS O=n1446 A1=n1382 A2=n92 B1=n1787 B2=n64 C1=n1800 C2=n72
XU847 OA222 $PINS O=n1327 A1=n1321 A2=n1494 B1=n1320 B2=n1824 C1=n1319 C2=n1558
XU848 OA222 $PINS O=n1328 A1=n1317 A2=n1766 B1=n1316 B2=n1632 C1=n1315 C2=n1806
XU849 OA112 $PINS O=n1330 A1=n1313 B1=n1312 C1=n1679 C2=n1802
XU850 OA222 $PINS O=n1312 A1=n1747 A2=n1816 B1=n1591 B2=n1743 C1=n1730 C2=n1489
XU851 OR3B2 $PINS O=n1311 I1=n1627 B1=n1733 B2=n1420
XU852 OA222 $PINS O=n1307 A1=n1824 A2=n1757 B1=n1665 B2=n1382 C1=n7 C2=n1764
XU853 OA222 $PINS O=n1301 A1=n1388 A2=n67 B1=n1550 B2=n77 C1=n1796 C2=n2
XU854 ND2 $PINS O=n1298 I1=n54 I2=n1318
XU855 ND2 $PINS O=n1299 I1=n1816 I2=n1361
XU856 AO12 $PINS O=n1303 A1=n1679 B1=n1361 B2=n1575
XU857 OA222 $PINS O=n1305 A1=n81 A2=n1755 B1=n1760 B2=n1634 C1=n1352 C2=n1659
XU858 OA112 $PINS O=n1306 A1=n1706 B1=n1297 C1=n1832 C2=n1631
XU859 OA222 $PINS O=n1295 A1=n1665 A2=n1294 B1=n1293 B2=n7 C1=n1292 C2=n1747
XU860 OA112 $PINS O=n1421 A1=n1285 B1=n1284 C1=n81 C2=n1755
XU861 ND2 $PINS O=n1284 I1=n61 I2=n132
XU862 OA222 $PINS O=n1526 A1=n1509 A2=n1824 B1=n1494 B2=n1593 C1=n1749 C2=n1725
XU863 AO112 $PINS O=n1280 A1=n1278 B1=n1277 C1=n1279 C2=n337
XU864 AN3 $PINS O=n1707 I1=n1274 I2=n1273 I3=n1272
XU865 OA112 $PINS O=n1272 A1=n1313 B1=n1271 C1=n1509 C2=n1677
XU866 OA222 $PINS O=n1271 A1=n1824 A2=n1757 B1=n77 B2=n1659 C1=n1634 C2=n1361
XU867 OA222 $PINS O=n1313 A1=n77 A2=n1740 B1=n1787 B2=n67 C1=n1743 C2=n72
XU868 OA222 $PINS O=n1273 A1=n1653 A2=n1558 B1=n1270 B2=n1806 C1=n1392 C2=n1749
XU869 OA222 $PINS O=n1274 A1=n1800 A2=n2 B1=n1650 B2=n1665 C1=n1568 C2=n1494
XU870 AN3 $PINS O=n1629 I1=n1269 I2=n1268 I3=n1267
XU871 AN3B2S $PINS O=n1267 I1=n1266 B1=n1265 B2=n1264
XU872 ND2 $PINS O=n1259 I1=n1736 I2=n1361
XU873 OA222 $PINS O=n1256 A1=n1806 A2=n1816 B1=n1633 B2=n1588 C1=n1824 C2=n1361
XU874 OA222 $PINS O=n1251 A1=n7 A2=n1743 B1=n81 B2=n1294 C1=n1665 C2=n94
XU875 AO12 $PINS O=n1252 A1=n92 B1=n1649 B2=n95
XU876 AN3 $PINS O=n1661 I1=n1509 I2=n1832 I3=n1636
XU877 OA222 $PINS O=n1221 A1=n1781 A2=n80 B1=n1220 B2=n1730 C1=n89 C2=n1806
XU878 ND2 $PINS O=n1497 I1=n1485 I2=n1812
XU879 ND2 $PINS O=n1218 I1=n1407 I2=n1590
XU880 ND2 $PINS O=n1640 I1=n1802 I2=n1655
XU881 AN3B2S $PINS O=n1198 I1=n1297 B1=n1197 B2=n1264
XU882 AO12 $PINS O=n1264 A1=n1460 B1=n35 B2=n418
XU883 AO222 $PINS O=n1197 A1=n1744 A2=n129 B1=n69 B2=n126 C1=n418 C2=n91
XU884 OA222 $PINS O=n1199 A1=n66 A2=n1804 B1=n1196 B2=n72 C1=n1195 C2=n1824
XU885 AO112 $PINS O=n1184 A1=n1429 B1=n1480 C1=n1410 C2=n124
XU886 ND2 $PINS O=n1561 I1=n1669 I2=n1449
XU887 OA222 $PINS O=n1176 A1=n1175 A2=n1747 B1=n1174 B2=n1631 C1=n1173 C2=n1730
XU888 OR3B2 $PINS O=n1350 I1=n1598 B1=n1171 B2=n1170
XU889 ND2 $PINS O=n1219 I1=n1726 I2=n1449
XU890 ND2 $PINS O=n1598 I1=n1485 I2=n1540
XU891 AN3 $PINS O=n1763 I1=n1242 I2=n28 I3=n1724
XU892 ND2 $PINS O=n1276 I1=n1764 I2=n1667
XU893 ND2 $PINS O=n1169 I1=n1158 I2=n1157
XU894 ND2 $PINS O=n1154 I1=n1586 I2=n1740
XU895 ND2 $PINS O=n1156 I1=n92 I2=n81
XU896 ND2 $PINS O=n1418 I1=n62 I2=n122
XU897 ND2 $PINS O=n1279 I1=n1538 I2=n1641
XU898 AN3 $PINS O=n1206 I1=n1144 I2=n1568 I3=n39
XU899 ND2 $PINS O=n1133 I1=n72 I2=n67
XU900 ND2 $PINS O=n1134 I1=n94 I2=n1755
XU901 ND2 $PINS O=n1656 I1=n1722 I2=n1802
XU902 AN3B1 $PINS O=n1649 I1=n1821 I2=n1294 B1=n1148
XU903 ND2 $PINS O=n1779 I1=n1632 I2=n1742
XU904 ND2 $PINS O=n1149 I1=n1633 I2=n6
XU905 ND2 $PINS O=n1486 I1=n1725 I2=n1641
XU906 OR3B2 $PINS O=n1110 I1=n1597 B1=n86 B2=n1498
XU907 ND2 $PINS O=n1597 I1=n1573 I2=n1725
XU908 ND2 $PINS O=n1727 I1=n1498 I2=n1540
XU909 ND2 $PINS O=n1491 I1=n1641 I2=n1449
XU910 ND2 $PINS O=n1593 I1=n1813 I2=FE_OFN141_fold_n_0
XU911 AN3 $PINS O=n1705 I1=n1099 I2=n1098 I3=n1097
XU912 ND2 $PINS O=n1285 I1=n1699 I2=n1792
XU913 OA222 $PINS O=n1093 A1=n1180 A2=n81 B1=n1587 B2=n1804 C1=n1579 C2=n1634
XU915 ND2 $PINS O=n1225 I1=n1294 I2=n99
XU916 ND2 $PINS O=n1778 I1=n1412 I2=n1787
XU917 ND2 $PINS O=n1076 I1=n1193 I2=n1659
XU919 ND2 $PINS O=n1077 I1=n1666 I2=n1385
XU920 OA222 $PINS O=n1072 A1=n1740 A2=n64 B1=n1542 B2=n1802 C1=n39 C2=n1494
XU923 OR3B2 $PINS O=n1068 I1=n1260 B1=n107 B2=n1294
XU924 ND2 $PINS O=n1260 I1=n1666 I2=n1180
XU925 ND2 $PINS O=n1069 I1=n1637 I2=n1641
XU926 ND2 $PINS O=n1254 I1=n1660 I2=n67
XU927 ND2 $PINS O=n1194 I1=n7 I2=n67
XU928 OA222 $PINS O=n1061 A1=n83 A2=n1730 B1=n1060 B2=n2 C1=n1059 C2=n1762
XU929 ND2 $PINS O=n1490 I1=n1540 I2=n1318
XU930 OA222 $PINS O=n1345 A1=n1564 A2=n81 B1=n1722 B2=n1634 C1=n92 C2=n1666
XU931 OA112 $PINS O=n1064 A1=n1709 B1=n1563 C1=n1643 C2=n1489
XU932 OA222 $PINS O=n1057 A1=n77 A2=n1756 B1=n1667 B2=n64 C1=n81 C2=n1382
XU933 ND2 $PINS O=shift1[0] I1=n1056 I2=n1055
XU934 ND2 $PINS O=n1674 I1=n129 I2=n69
XU935 ND2 $PINS O=n1742 I1=n1075 I2=n1619
XU936 AO12 $PINS O=n1050 A1=n1591 B1=n1804 B2=n1332
XU937 ND2 $PINS O=n1588 I1=n1048 I2=n1070
XU939 OA222 $PINS O=n1052 A1=n104 A2=n92 B1=n1046 B2=n1679 C1=n1045 C2=n1816
XU940 OA222 $PINS O=n1053 A1=n1575 A2=n1749 B1=n1781 B2=n64 C1=n1458 C2=n1494
XU941 OA222 $PINS O=n1054 A1=n1787 A2=n2 B1=n1352 B2=n1558 C1=n88 C2=n1747
XU942 ND2 $PINS O=n1215 I1=n1726 I2=n1489
XU943 AN3 $PINS O=n1063 I1=n1039 I2=n1038 I3=n1037
XU944 AO12 $PINS O=n1262 A1=n6 B1=n1787 B2=n1800
XU945 ND2 $PINS O=n1635 I1=n1719 I2=n1030
XU947 ND2 $PINS O=n1026 I1=n1828 I2=n1726
XU948 ND2 $PINS O=n1027 I1=n1714 I2=n1489
XU949 OA222 $PINS O=n1035 A1=n1388 A2=n80 B1=n1023 B2=n1747 C1=n1484 C2=n1643
XU950 ND2 $PINS O=n1533 I1=n1204 I2=n1449
XU951 ND2 $PINS O=n1677 I1=n1619 I2=n1047
XU952 ND2 $PINS O=n1820 I1=n108 I2=n112
XU954 ND2 $PINS O=n1556 I1=n1019 I2=n1048
XU955 ND2 $PINS O=n1309 I1=n1017 I2=n1016
XU956 OA222 $PINS O=n1016 A1=n1106 A2=n1730 B1=n1015 B2=n1762 C1=n1014 C2=n1667
XU957 ND2 $PINS O=n1667 I1=n1075 I2=n1070
XU958 OA222 $PINS O=n1017 A1=n1832 A2=n1747 B1=n1580 B2=n1679 C1=n1650 C2=n92
XU960 ND2 $PINS O=n1756 I1=n1071 I2=n1019
XU961 AN3 $PINS O=n1190 I1=n1012 I2=n76 I3=n1011
XU962 OA222 $PINS O=n1011 A1=n1336 A2=n1558 B1=n1388 B2=n72 C1=n6 C2=n1632
XU968 ND2 $PINS O=n1744 I1=n1676 I2=n6
XU970 OA222 $PINS O=n1041 A1=n1643 A2=n1725 B1=n1008 B2=n1806 C1=n1831 C2=n28
XU971 ND2 $PINS O=n1482 I1=n1725 I2=n1449
XU972 ND2 $PINS O=n1538 I1=n1007 I2=n1025
XU973 ND2 $PINS O=n1726 I1=n1044 I2=n1022
XU974 OA222 $PINS O=n1042 A1=n1822 A2=n7 B1=n1006 B2=n81 C1=n1005 C2=n1665
XU976 AN3B2S $PINS O=n1792 I1=n1687 B1=k_idx[3] B2=k_idx[4]
XU977 ND2 $PINS O=n1789 I1=n1383 I2=n94
XU978 ND2 $PINS O=n1294 I1=n105 I2=n112
XU979 ND2 $PINS O=n1004 I1=n1650 I2=n96
XU980 ND2 $PINS O=n1755 I1=n102 I2=FE_OFN140_fold_n_0
XU981 ND2 $PINS O=n1180 I1=n106 I2=FE_OFN140_fold_n_0
XU982 ND2 $PINS O=n1089 I1=n1002 I2=n111
XU983 ND2 $PINS O=n1464 I1=n101 I2=FE_OFN140_fold_n_0
XU984 ND2 $PINS O=n1666 I1=n102 I2=n112
XU985 ND2 $PINS O=n1821 I1=n108 I2=FE_OFN140_fold_n_0
XU986 ND2 $PINS O=n1385 I1=n101 I2=n112
XU987 ND2 $PINS O=n1564 I1=n1803 I2=FE_OFN140_fold_n_0
XU989 ND2 $PINS O=n1131 I1=n1002 I2=n_idx[1]
XU990 OA222 $PINS O=n1043 A1=n1001 A2=n1824 B1=n1485 B2=n1766 C1=n1000 C2=n1634
XU991 ND2 $PINS O=n1815 I1=n999 I2=FE_OFN141_fold_n_0
XU993 ND2 $PINS O=n1030 I1=n997 I2=FE_OFN141_fold_n_0
XU994 ND2 $PINS O=n1121 I1=n1678 I2=n1725
XU995 ND2 $PINS O=n1577 I1=n995 I2=FE_OFN141_fold_n_0
XU996 ND2 $PINS O=n1736 I1=n994 I2=FE_OFN141_fold_n_0
XU1000 AN3 $PINS O=n1001 I1=n1466 I2=n1827 I3=n1574
XU1001 ND2 $PINS O=n1361 I1=n995 I2=n_idx[0]
XU1002 ND2 $PINS O=n1009 I1=n993 I2=n111
XU1003 ND2 $PINS O=n1758 I1=n997 I2=n_idx[0]
XU1004 ND2 $PINS O=n1797 I1=n1022 I2=n_idx[3]
XU1006 ND2 $PINS O=n1829 I1=n110 I2=n103
XU1008 ND2 $PINS O=n1775 I1=n_idx[3] I2=n_idx[2]
XU1009 ND2 $PINS O=n1578 I1=n999 I2=n_idx[0]
XU1010 ND2 $PINS O=n1774 I1=n993 I2=n_idx[1]
XU3 AN4B1S $PINS O=n1358 I1=n1580 I2=n1241 I3=n1757 B1=n1364
XU4 ND2 $PINS O=n7 I1=n1784 I2=n1818
XU5 AN2 $PINS O=n1660 I1=n1387 I2=n7
XU6 AN4B1S $PINS O=n1826 I1=n1782 I2=n1556 I3=n1743 B1=n1780
XU7 AN4S $PINS O=n1244 I1=n1719 I2=n1669 I3=n1661 I4=n1575
XU8 NR2P $PINS O=n1 I1=n38 I2=n50
XU10 ND2 $PINS O=n1828 I1=n998 I2=FE_OFN141_fold_n_0
XU11 INV1S $PINS O=n40 I=n1698
XU12 ND3S $PINS O=n1373 I1=n1504 I2=n86 I3=n1101
XU13 ND3S $PINS O=n1166 I1=n1503 I2=n1 I3=n1763
XU14 AN2S $PINS O=n1594 I1=n1593 I2=n1668
XU15 ND3S $PINS O=shift1[3] I1=n1189 I2=n1188 I3=n1187
XU16 ND3S $PINS O=n1186 I1=n1178 I2=n1177 I3=n1176
XU17 ND3S $PINS O=n1670 I1=n1757 I2=n1669 I3=n1668
XU18 ND3S $PINS O=n1506 I1=n1504 I2=n1503 I3=n1502
XU19 OA222S $PINS O=n1326 A1=n1 A2=n1749 B1=n98 B2=n92 C1=n1718 C2=n1762
XU20 ND2S $PINS O=n1487 I1=n1828 I2=n1540
XU21 OA12S $PINS O=n1459 A1=n114 B1=n38 B2=n1656
XU22 ND3S $PINS O=n1322 I1=n1736 I2=n1828 I3=n1485
XU23 ND3S $PINS O=n1812 I1=n1698 I2=n110 I3=n1609
XU24 ND2S $PINS O=n1832 I1=n_idx[0] I2=n998
XU25 ND3S $PINS O=n1655 I1=n1022 I2=FE_OFN141_fold_n_0 I3=n1698
XU26 ND3S $PINS O=n1802 I1=n1698 I2=n1022 I3=n_idx[0]
XU27 ND3S $PINS O=n1448 I1=n1489 I2=n1204 I3=n1
XU28 ND2S $PINS O=n1669 I1=n1007 I2=n1698
XU29 ND3S $PINS O=n1255 I1=n1680 I2=n1 I3=n1253
XU30 ND3S $PINS O=n1351 I1=n1828 I2=n1816 I3=n1641
XU31 ND3S $PINS O=n1368 I1=n1828 I2=n1816 I3=n1801
XU32 ND3S $PINS O=n1816 I1=n1698 I2=n_idx[1] I3=n1013
XU33 NR2 $PINS O=n1699 I1=n96 I2=n_idx[4]
XU34 NR2 $PINS O=n1070 I1=n14 I2=k_idx[1]
XU35 INV1S $PINS O=n36 I=n1504
XU36 NR2 $PINS O=n1589 I1=n69 I2=n1744
XU37 NR2 $PINS O=n1504 I1=n37 I2=n47
XU38 INV1S $PINS O=n66 I=n1194
XU39 INV1S $PINS O=n75 I=n1300
XU40 AN2 $PINS O=n1157 I1=n1503 I2=n1242
XU41 INV1S $PINS O=n20 I=n1510
XU42 INV1S $PINS O=n33 I=n1761
XU43 INV1S $PINS O=n19 I=n1503
XU44 INV1S $PINS O=n31 I=n1568
XU45 INV1S $PINS O=n71 I=n1660
XU46 INV1S $PINS O=n59 I=n1760
XU47 INV1S $PINS O=n69 I=n1591
XU48 INV1S $PINS O=n34 I=n1364
XU49 INV1S $PINS O=n41 I=n1590
XU50 NR2 $PINS O=n1724 I1=n43 I2=n47
XU51 INV1S $PINS O=n47 I=n1485
XU53 INV1S $PINS O=n94 I=n1340
XU54 ND3 $PINS O=n1148 I1=n1382 I2=n1564 I3=n1344
XU55 INV1S $PINS O=n49 I=n1123
XU56 INV1S $PINS O=n18 I=n1209
XU57 INV1S $PINS O=n65 I=n1462
XU58 AN2 $PINS O=n1595 I1=n1592 I2=n1591
XU59 NR2 $PINS O=n1715 I1=n43 I2=n38
XU60 INV1S $PINS O=n42 I=n1447
XU61 NR2 $PINS O=n1596 I1=n38 I2=n42
XU62 INV1S $PINS O=n95 I=n1004
XU63 AN2 $PINS O=n1650 I1=n1180 I2=n1755
XU64 INV1S $PINS O=n22 I=n1241
XU65 AN2 $PINS O=n1357 I1=n1181 I2=n1660
XU66 INV1S $PINS O=n73 I=n1281
XU67 INV1S $PINS O=n68 I=n1352
XU68 NR2 $PINS O=n1781 I1=n125 I2=n124
XU69 INV1S $PINS O=n99 I=n1261
XU70 ND3 $PINS O=n1454 I1=n2 I2=n77 I3=n73
XU71 INV1S $PINS O=n44 I=n1511
XU73 NR2 $PINS O=n1741 I1=n125 I2=n121
XU74 NR2 $PINS O=n1300 I1=n6 I2=n1741
XU75 NR2 $PINS O=n1455 I1=n1410 I2=n1194
XU76 NR2 $PINS O=n1228 I1=n1148 I2=n1340
XU77 INV1S $PINS O=n30 I=n1158
XU78 NR2 $PINS O=n1168 I1=n1169 I2=n45
XU79 NR2 $PINS O=n1678 I1=n26 I2=n61
XU80 AN2 $PINS O=n1242 I1=n1509 I2=n1574
XU81 INV1S $PINS O=n55 I=n1579
XU82 NR2 $PINS O=n1498 I1=n91 I2=n93
XU83 NR2 $PINS O=n1101 I1=n87 I2=n1727
XU84 NR2 $PINS O=n1369 I1=n1727 I2=n33
XU85 NR2 $PINS O=n1510 I1=n21 I2=n25
XU86 NR2 $PINS O=n1503 I1=n20 I2=n23
XU87 ND3 $PINS O=shift3[2] I1=n1524 I2=n1523 I3=n1522
XU88 NR2 $PINS O=n1523 I1=n1501 I2=n1500
XU89 NR3 $PINS O=n1524 I1=n1481 I2=n1480 I3=n1479
XU90 AN4B1S $PINS O=n1522 I1=n1521 I2=n1520 I3=n1519 B1=n1518
XU91 INV1S $PINS O=n84 I=n1727
XU92 ND3 $PINS O=shift3[0] I1=n1440 I2=n1439 I3=n1438
XU93 NR3 $PINS O=n1440 I1=n1391 I2=n1390 I3=n1389
XU94 AN4B1S $PINS O=n1439 I1=n1403 I2=n1402 I3=n1401 B1=n1400
XU95 AN4B1S $PINS O=n1438 I1=n1437 I2=n1436 I3=n1435 B1=n1434
XU96 NR2 $PINS O=n1722 I1=n23 I2=n26
XU97 ND3 $PINS O=n1287 I1=n1629 I2=n1707 I3=n27
XU98 NR2 $PINS O=n1015 I1=n26 I2=n29
XU99 NR2 $PINS O=n1574 I1=n56 I2=n60
XU100 NR2 $PINS O=n1270 I1=n93 I2=n1598
XU101 NR2 $PINS O=n1485 I1=n53 I2=n48
XU102 NR2P $PINS O=n1761 I1=n45 I2=n35
XU103 NR3 $PINS O=n1573 I1=n53 I2=n50 I3=n33
XU104 NR2 $PINS O=n1335 I1=n35 I2=n26
XU105 NR2 $PINS O=n1568 I1=n90 I2=n35
XU106 NR2 $PINS O=n1173 I1=n1642 I2=n1279
XU107 ND3 $PINS O=n1572 I1=n27 I2=n1630 I3=n1563
XU108 NR2 $PINS O=n1275 I1=n35 I2=n55
XU109 NR2 $PINS O=n1336 I1=n71 I2=n1672
XU110 AOI22S $PINS O=n1402 A1=n127 A2=n1396 B1=n138 B2=n1395
XU111 OAI112HS $PINS O=n1425 A1=n1421 B1=n1420 C1=n1422 C2=n1743
XU112 ND3 $PINS O=n1443 I1=n1428 I2=n1427 I3=n1426
XU113 NR2 $PINS O=n1428 I1=n1414 I2=n1413
XU114 NR3 $PINS O=n1426 I1=n1425 I2=n1424 I3=n1423
XU115 NR2 $PINS O=n1760 I1=n60 I2=n61
XU116 NR2 $PINS O=n1407 I1=n59 I2=n58
XU117 NR2 $PINS O=n1591 I1=n1417 I2=n1314
XU118 AN2 $PINS O=n1465 I1=n1579 I2=n1722
XU119 NR2 $PINS O=n1827 I1=n33 I2=n48
XU120 AOI22S $PINS O=n1735 A1=n337 A2=n1717 B1=n417 B2=n1716
XU121 ND3 $PINS O=n1716 I1=n1715 I2=n1714 I3=n1729
XU122 ND3 $PINS O=n1364 I1=n1761 I2=n1828 I3=n1579
XU123 NR2 $PINS O=n1590 I1=n45 I2=n50
XU124 INV1S $PINS O=n100 I=n1803
XU125 INV1S $PINS O=n77 I=n1159
XU126 NR2 $PINS O=n1575 I1=n38 I2=n56
XU127 AOI22S $PINS O=n1012 A1=n26 A2=n131 B1=n124 B2=n1744
XU128 NR2 $PINS O=n1668 I1=n37 I2=n35
XU129 INV1S $PINS O=n38 I=n1828
XU130 INV1S $PINS O=n46 I=n1811
XU131 NR2 $PINS O=n1636 I1=n46 I2=n23
XU132 NR2 $PINS O=n1719 I1=n25 I2=n60
XU133 NR2 $PINS O=n1392 I1=n45 I2=n25
XU134 INV1S $PINS O=n129 I=n1742
XU135 NR2 $PINS O=n1676 I1=n1553 I2=n1159
XU136 INV1S $PINS O=n67 I=n1314
XU137 INV1S $PINS O=n86 I=n1491
XU138 OR2 $PINS O=n1217 I1=n1497 I2=n20
XU139 AOI13HS $PINS O=n1584 A1=n1766 B1=n1722 B2=n1574 B3=n1573
XU140 INV1S $PINS O=n39 I=n1487
XU141 INV1S $PINS O=n43 I=n1532
XU142 NR2 $PINS O=n1559 I1=n126 I2=n128
XU143 ND3 $PINS O=n1780 I1=n1559 I2=n1558 I3=n1557
XU144 NR2 $PINS O=n1557 I1=n130 I2=n119
XU145 NR2 $PINS O=n1340 I1=FE_OFN140_fold_n_0 I2=n97
XU146 NR2 $PINS O=n1653 I1=n1159 I2=n1397
XU147 NR2 $PINS O=n1123 I1=n50 I2=n60
XU148 AOI22S $PINS O=n1036 A1=n113 A2=n22 B1=n131 B2=n49
XU149 NR2 $PINS O=n1209 I1=n21 I2=n35
XU150 NR2 $PINS O=n1462 I1=n1553 I2=n1397
XU151 NR2 $PINS O=n1158 I1=n38 I2=n35
XU152 AOI22S $PINS O=n1266 A1=n132 A2=n58 B1=n115 B2=n1672
XU153 INV1S $PINS O=n74 I=n1463
XU154 NR2 $PINS O=n1592 I1=n74 I2=n1553
XU155 NR2 $PINS O=n1580 I1=n58 I2=n61
XU156 AOI22S $PINS O=n1554 A1=n1553 A2=n121 B1=n48 B2=n136
XU157 NR2 $PINS O=n1261 I1=n100 I2=FE_OFN140_fold_n_0
XU158 NR2 $PINS O=n1344 I1=n1261 I2=n1405
XU159 NR2 $PINS O=n1633 I1=n78 I2=n1417
XU160 INV1S $PINS O=n78 I=n1422
XU161 NR3 $PINS O=n1782 I1=n1779 I2=n116 I3=n1778
XU162 INV1S $PINS O=n125 I=n1556
XU163 NR2 $PINS O=n1796 I1=n125 I2=n126
XU164 NR2 $PINS O=n1447 I1=n43 I2=n53
XU165 NR2 $PINS O=n1181 I1=n78 I2=n1672
XU166 INV1S $PINS O=n87 I=n1726
XU167 NR2 $PINS O=n1712 I1=n87 I2=n48
XU168 INV1S $PINS O=n122 I=n1677
XU169 NR2 $PINS O=n1507 I1=n48 I2=n56
XU170 NR2 $PINS O=n1241 I1=n48 I2=n23
XU171 MOAI1S $PINS O=n1265 A1=n1388 A2=n72 B1=n1672 B2=n124
XU172 OAI12HS $PINS O=n1096 A1=n127 B1=n1417 B2=n1397
XU173 INV1S $PINS O=n116 I=n1756
XU174 NR2 $PINS O=n1317 I1=n21 I2=n26
XU175 AOI22S $PINS O=n1140 A1=n130 A2=n1149 B1=n132 B2=n30
XU176 NR2 $PINS O=n1531 I1=n35 I2=n56
XU177 NR2 $PINS O=n1750 I1=n21 I2=n58
XU178 AOI12HS $PINS O=n1297 A1=n1429 B1=n1553 B2=n119
XU179 NR2 $PINS O=n1398 I1=n21 I2=n60
XU180 NR2 $PINS O=n1352 I1=n1159 I2=n1314
XU181 INV1S $PINS O=n337 I=n1631
XU182 NR2 $PINS O=n1332 I1=n126 I2=n124
XU183 NR2 $PINS O=n1765 I1=n1194 I2=n1672
XU184 NR2 $PINS O=n1508 I1=n43 I2=n50
XU185 ND3 $PINS O=n1281 I1=n80 I2=n7 I3=n1587
XU186 ND3 $PINS O=n1488 I1=n1761 I2=n1485 I3=n1637
XU187 INV1S $PINS O=n115 I=n1558
XU188 MAOI1 $PINS O=n1445 A1=n121 A2=n1254 B1=n1633 B2=n1556
XU189 NR2 $PINS O=n1195 I1=n60 I2=n35
XU190 MOAI1S $PINS O=n1413 A1=n1412 A2=n2 B1=n68 B2=n119
XU191 INV1S $PINS O=n54 I=n1561
XU192 INV1S $PINS O=n98 I=n1225
XU193 INV1S $PINS O=n64 I=n1397
XU194 MOAI1S $PINS O=n1065 A1=n1765 A2=n1632 B1=n115 B2=n1254
XU195 NR2 $PINS O=n1586 I1=n118 I2=n116
XU196 INV1S $PINS O=n76 I=n1094
XU197 INV1S $PINS O=n121 I=n1388
XU198 NR2 $PINS O=n1511 I1=n45 I2=n53
XU199 ND3 $PINS O=n1410 I1=n1587 I2=n2 I3=n1653
XU200 AN2 $PINS O=n1477 I1=n1283 I2=n1282
XU201 AOI22S $PINS O=n1282 A1=n1314 A2=n115 B1=n1417 B2=n124
XU202 AOI22S $PINS O=n1283 A1=n116 A2=n1281 B1=n127 B2=n1410
XU203 INV1S $PINS O=n51 I=n1718
XU204 INV1S $PINS O=n127 I=n1632
XU205 NR2 $PINS O=n1654 I1=n1491 I2=n50
XU206 AOI22S $PINS O=n1563 A1=n136 A2=n23 B1=n132 B2=n60
XU207 NR2 $PINS O=n1088 I1=n115 I2=n128
XU208 NR2 $PINS O=n1394 I1=n65 I2=n1159
XU209 INV1S $PINS O=n107 I=n1405
XU210 INV1S $PINS O=n124 I=n1743
XU211 NR2 $PINS O=n1550 I1=n124 I2=n130
XU212 INV1S $PINS O=n138 I=n1766
XU213 MOAI1S $PINS O=n1390 A1=n1388 A2=n1387 B1=n49 B2=n135
XU214 ND2 $PINS O=n1382 I1=n105 I2=FE_OFN140_fold_n_0
XU215 NR2 $PINS O=n1263 I1=n1261 I2=n1260
XU216 INV1S $PINS O=n89 I=n1219
XU217 NR2 $PINS O=n1060 I1=n120 I2=n116
XU218 NR2 $PINS O=n1196 I1=n128 I2=n124
XU219 NR2 $PINS O=n1751 I1=n114 I2=n132
XU220 NR2 $PINS O=n1737 I1=n91 I2=n48
XU221 NR2 $PINS O=n1193 I1=n126 I2=n130
XU222 ND3 $PINS O=n1224 I1=n1382 I2=n1821 I3=n107
XU223 NR2 $PINS O=n1412 I1=n118 I2=n123
XU224 AOI22S $PINS O=n1436 A1=n1405 A2=n8 B1=n116 B2=n1553
XU225 MOAI1S $PINS O=n1359 A1=n1660 A2=n1388 B1=n114 B2=n23
XU226 INV1S $PINS O=n117 I=n1778
XU227 NR2 $PINS O=n1458 I1=n50 I2=n85
XU228 NR2 $PINS O=n1059 I1=n61 I2=n50
XU229 NR2 $PINS O=n1542 I1=n418 I2=n417
XU230 NR2 $PINS O=n1543 I1=n38 I2=n61
XU231 NR2 $PINS O=n1793 I1=n121 I2=n120
XU232 INV1S $PINS O=n26 I=n1736
XU233 OAI222S $PINS O=n1163 A1=n1162 A2=n1762 B1=n1455 B2=n1161 C1=n1160
+ C2=n1749
XU234 NR2 $PINS O=n1161 I1=n127 I2=n1276
XU235 NR2 $PINS O=n1160 I1=n35 I2=n1166
XU236 NR2 $PINS O=n1162 I1=n51 I2=n1167
XU237 NR2 $PINS O=n1509 I1=n1121 I2=n58
XU238 INV1S $PINS O=n109 I=n1818
XU239 ND3 $PINS O=n1167 I1=n1655 I2=n1812 I3=n1168
XU240 NR3 $PINS O=n1189 I1=n1152 I2=n1151 I3=n1150
XU241 NR3 $PINS O=n1187 I1=n1186 I2=n1185 I3=n1184
XU242 AN4B1S $PINS O=n1188 I1=n1165 I2=n1418 I3=n1164 B1=n1163
XU243 MAOI1 $PINS O=n1177 A1=n114 A2=n1169 B1=n1824 B2=n1168
XU244 AOI22S $PINS O=n1178 A1=n138 A2=n1167 B1=n131 B2=n1166
XU245 AN4B1S $PINS O=n1773 I1=n1711 I2=n1710 I3=n1709 B1=n1708
XU246 OAI222S $PINS O=n1768 A1=n1767 A2=n1766 B1=n1765 B2=n1764 C1=n1763
+ C2=n1762
XU247 AN4B1S $PINS O=n1767 I1=n1811 I2=n1761 I3=n1760 B1=n1759
XU248 ND3 $PINS O=n1759 I1=n1758 I2=n1812 I3=n1757
XU249 AN4B1S $PINS O=n1372 I1=n1729 I2=n1 I3=n63 B1=n1552
XU250 AN4B1S $PINS O=n1370 I1=n63 I2=n1485 I3=n1369 B1=n1368
XU251 AN4B1S $PINS O=n1371 I1=n1511 I2=n1661 I3=n1466 B1=n60
XU252 ND3 $PINS O=shift2[3] I1=n1381 I2=n1380 I3=n1379
XU253 NR2 $PINS O=n1380 I1=n1360 I2=n1359
XU254 AN4B1S $PINS O=n1379 I1=n1378 I2=n1377 I3=n1376 B1=n1375
XU255 NR3 $PINS O=n1684 I1=n1683 I2=n1682 I3=n1681
XU256 OAI222S $PINS O=n1681 A1=n1680 A2=n1679 B1=n1678 B2=n1677 C1=n1676
+ C2=n1742
XU257 ND3 $PINS O=n1682 I1=n1675 I2=n1674 I3=n1673
XU258 ND3 $PINS O=n1683 I1=n1664 I2=n1663 I3=n1662
XU259 NR3 $PINS O=n1658 I1=n1657 I2=n37 I3=n1656
XU260 ND3 $PINS O=n1657 I1=n1757 I2=n1655 I3=n1760
XU261 INV1S $PINS O=n56 I=n1758
XU262 NR2 $PINS O=n1579 I1=n62 I2=n56
XU263 NR3 $PINS O=n1174 I1=n1505 I2=n38 I3=n85
XU264 INV1S $PINS O=n24 I=n1350
XU265 INV1S $PINS O=n93 I=n1593
XU266 INV1S $PINS O=n97 I=n996
XU267 OAI112HS $PINS O=n1525 A1=n1266 B1=n1093 C1=n1785 C2=n28
XU268 AN4B1S $PINS O=n1097 I1=n1285 I2=n1096 I3=n1095 B1=n1460
XU269 AOI22S $PINS O=n1098 A1=n116 A2=n65 B1=n132 B2=n20
XU270 NR2 $PINS O=n1099 I1=n1094 I2=n1525
XU271 OAI222S $PINS O=n1152 A1=n1722 A2=n1677 B1=n1383 B2=n92 C1=n1157 C2=n1634
XU272 INV1S $PINS O=n21 I=n1578
XU273 AN4B1S $PINS O=n1514 I1=n1508 I2=n1507 I3=n1721 B1=n59
XU274 AN4B1S $PINS O=n1512 I1=n1511 I2=n1510 I3=n1509 B1=n37
XU275 AN4B1S $PINS O=n1408 I1=n84 I2=n88 I3=n1568 B1=n1497
XU276 ND3 $PINS O=n1406 I1=n1757 I2=n1832 I3=n1579
XU277 AN4B1S $PINS O=n1363 I1=n1508 I2=n1579 I3=n1721 B1=n23
XU278 AN4B1S $PINS O=n1362 I1=n1361 I2=n1828 I3=n1509 B1=n18
XU279 OAI22S $PINS O=n1246 A1=n1245 A2=n1831 B1=n1244 B2=n1762
XU280 AN4B1S $PINS O=n1245 I1=n1760 I2=n34 I3=n1317 B1=n47
XU281 ND3 $PINS O=shift2[1] I1=n1291 I2=n1290 I3=n1289
XU282 AN4B1S $PINS O=n1290 I1=n1252 I2=n75 I3=n1251 B1=n1250
XU283 NR3 $PINS O=n1289 I1=n1288 I2=n1287 I3=n1286
XU284 NR3 $PINS O=n1291 I1=n1248 I2=n1247 I3=n1246
XU285 OAI222S $PINS O=n1185 A1=n1357 A2=n1742 B1=n1179 B2=n1806 C1=n73 C2=n1558
XU286 NR3 $PINS O=n1179 I1=n1356 I2=n1561 I3=n37
XU287 ND3 $PINS O=n1356 I1=n1811 I2=n1641 I3=n1369
XU288 AN4B1S $PINS O=n1055 I1=n1054 I2=n1053 I3=n1052 B1=n1051
XU289 AN4B1S $PINS O=n1056 I1=n1043 I2=n1042 I3=n1041 B1=n1040
XU290 AN4B1S $PINS O=n1000 I1=n1509 I2=n1761 I3=n1575 B1=n22
XU291 AN4B1S $PINS O=n1347 I1=n1346 I2=n1442 I3=n1345 B1=n1624
XU292 ND3 $PINS O=n1355 I1=n1528 I2=n1705 I3=n1478
XU293 INV1S $PINS O=n25 I=n1757
XU294 INV1S $PINS O=n96 I=n1227
XU295 NR2 $PINS O=n1014 I1=n1417 I2=n1553
XU296 INV1S $PINS O=n29 I=n1721
XU297 NR2 $PINS O=n1038 I1=n1021 I2=n1020
XU298 AN4B1S $PINS O=n1037 I1=n1036 I2=n1035 I3=n1034 B1=n1033
XU299 AN4B1S $PINS O=n1039 I1=n1192 I2=n1018 I3=n1625 B1=n1309
XU300 ND3 $PINS O=shift1[1] I1=n1087 I2=n1086 I3=n1085
XU301 NR3 $PINS O=n1086 I1=n1067 I2=n1066 I3=n1065
XU302 NR3 $PINS O=n1085 I1=n1084 I2=n1083 I3=n1082
XU303 AN4B1S $PINS O=n1087 I1=n1064 I2=n1345 I3=n1063 B1=n1310
XU304 OAI112HS $PINS O=n1481 A1=n1478 B1=n1477 C1=n1824 C2=n1828
XU305 MOAI1S $PINS O=n1126 A1=n1125 A2=n1679 B1=n135 B2=n1124
XU306 AN4B1S $PINS O=n1125 I1=n1579 I2=n1655 I3=n1398 B1=n1656
XU307 ND3 $PINS O=n1124 I1=n1636 I2=n1509 I3=n1123
XU308 ND3 $PINS O=shift1[2] I1=n1143 I2=n1142 I3=n1141
XU309 AN4B1S $PINS O=n1142 I1=n1120 I2=n1119 I3=n1118 B1=n1117
XU310 AN4B1S $PINS O=n1143 I1=n1445 I2=n1334 I3=n1191 B1=n1104
XU311 AN4B1S $PINS O=n1141 I1=n1140 I2=n1139 I3=n1138 B1=n1137
XU312 OAI112HS $PINS O=n1104 A1=n1705 B1=n1103 C1=n1358 C2=n1831
XU313 AOI22S $PINS O=n1103 A1=n418 A2=n1102 B1=n417 B2=n1373
XU314 ND3 $PINS O=n1102 I1=n1484 I2=n39 I3=n1100
XU315 NR3 $PINS O=n1100 I1=n46 I2=n93 I3=n87
XU316 MOAI1S $PINS O=n1247 A1=n1 A2=n1749 B1=n114 B2=n1243
XU317 ND3 $PINS O=n1243 I1=n1242 I2=n1578 I3=n1241
XU318 ND3 $PINS O=shift3[3] I1=n1549 I2=n1548 I3=n1547
XU319 NR2 $PINS O=n1548 I1=n1530 I2=n1529
XU320 NR3 $PINS O=n1547 I1=n1546 I2=n1545 I3=n1544
XU321 AN4B1S $PINS O=n1549 I1=n1528 I2=n1527 I3=n1526 B1=n1525
XU322 INV1S $PINS O=n61 I=n1577
XU323 OAI222S $PINS O=n1360 A1=n1358 A2=n1766 B1=n32 B2=n1806 C1=n1357 C2=n1742
XU324 INV1S $PINS O=n32 I=n1356
XU325 INV1S $PINS O=n53 I=n1669
XU326 AOI22S $PINS O=n1521 A1=n136 A2=n1506 B1=n337 B2=n1505
XU327 NR3 $PINS O=n1502 I1=n29 I2=n35 I3=n59
XU328 ND3 $PINS O=n1286 I1=n1477 I2=n1526 I3=n1421
XU329 MOAI1S $PINS O=n1375 A1=n1374 A2=n1730 B1=n1373 B2=n137
XU330 AN4B1S $PINS O=n1374 I1=n1 I2=n1498 I3=n86 B1=n44
XU331 OAI222S $PINS O=n1602 A1=n1601 A2=n1749 B1=n1600 B2=n1762 C1=n1599
+ C2=n1643
XU332 NR2 $PINS O=n1599 I1=n35 I2=n1598
XU333 NR2 $PINS O=n1601 I1=n52 I2=n18
XU334 NR2 $PINS O=n1600 I1=n1597 I2=n19
XU335 AN4B1S $PINS O=n1606 I1=n1605 I2=n1604 I3=n1603 B1=n1602
XU336 INV1S $PINS O=n35 I=n1832
XU337 NR2 $PINS O=n1366 I1=n128 I2=n125
XU338 NR2 $PINS O=n1367 I1=n1397 I2=n69
XU339 NR2 $PINS O=n1365 I1=n1364 I2=n19
XU340 NR2 $PINS O=n1484 I1=n31 I2=n82
XU341 NR2 $PINS O=n1023 I1=n47 I2=n1533
XU342 AOI22S $PINS O=n1119 A1=n419 A2=n1111 B1=n134 B2=n1110
XU343 ND3 $PINS O=n1111 I1=n1498 I2=n1729 I3=n1109
XU344 NR3 $PINS O=n1109 I1=n51 I2=n87 I3=n33
XU345 INV1S $PINS O=n72 I=n1560
XU346 MOAI1S $PINS O=n1117 A1=n1743 A2=n1765 B1=n137 B2=n1116
XU347 ND3 $PINS O=n1116 I1=n84 I2=n1532 I3=n1115
XU348 NR2 $PINS O=n1115 I1=n1486 I2=n1448
XU349 ND3 $PINS O=n1434 I1=n1433 I2=n1432 I3=n1431
XU350 AOI22S $PINS O=n1433 A1=n115 A2=n78 B1=n56 B2=n132
XU351 AOI22S $PINS O=n1432 A1=n124 A2=n71 B1=n128 B2=n1410
XU352 NR3 $PINS O=n1431 I1=n1430 I2=n1429 I3=n1443
XU353 ND3 $PINS O=n1642 I1=n1206 I2=n1590 I3=n1145
XU354 NR3 $PINS O=n1145 I1=n1215 I2=n93 I3=n53
XU355 INV1S $PINS O=n60 I=n1361
XU356 INV1S $PINS O=n27 I=n1280
XU357 MOAI1S $PINS O=n1277 A1=n28 A2=n1785 B1=n1553 B2=n1276
XU358 OAI12HS $PINS O=n1278 A1=n1674 B1=n1275 B2=n1634
XU359 NR2 $PINS O=n1387 I1=n1560 I2=n1417
XU360 NR2 $PINS O=n1144 I1=n46 I2=n1533
XU361 NR2 $PINS O=n1587 I1=n1672 I2=n1560
XU362 OA22 $PINS O=n1095 A1=n67 A2=n1588 B1=n1667 B2=n1587
XU363 OAI112HS $PINS O=n1033 A1=n1031 B1=n1262 C1=n1032 C2=n1749
XU364 OAI12HS $PINS O=n1031 A1=n138 B1=n43 B2=n1635
XU365 NR2 $PINS O=n1032 I1=n29 I2=n44
XU366 OR2 $PINS O=n2 I1=n79 I2=n1774
XU367 INV1S $PINS O=n1417 I=n2
XU368 NR2 $PINS O=n1314 I1=n1131 I2=n79
XU369 ND3 $PINS O=shift3[1] I1=n1476 I2=n1475 I3=n1474
XU370 AN4B1S $PINS O=n1476 I1=n1446 I2=n1445 I3=n1444 B1=n1443
XU371 NR2 $PINS O=n1475 I1=n1457 I2=n1456
XU372 AN4B1S $PINS O=n1474 I1=n1473 I2=n1472 I3=n1471 B1=n1470
XU373 NR3 $PINS O=n1472 I1=n1461 I2=n1460 I3=n1459
XU374 AOI13HS $PINS O=n1461 A1=n1631 B1=n86 B2=n1802 B3=n39
XU375 OAI222S $PINS O=n1470 A1=n1469 A2=n1831 B1=n1468 B2=n1766 C1=n1467
+ C2=n1749
XU376 AN4B1S $PINS O=n1469 I1=n1575 I2=n1722 I3=n1510 B1=n42
XU377 AN4B1S $PINS O=n1467 I1=n1760 I2=n1466 I3=n1531 B1=n53
XU378 INV1S $PINS O=n23 I=n1815
XU379 INV1S $PINS O=n58 I=n1030
XU380 INV1S $PINS O=n91 I=n1538
XU381 NR3 $PINS O=n1630 I1=n3 I2=n4 I3=n5
XU382 OAI22S $PINS O=n3 A1=n64 A2=n1550 B1=n80 B2=n1740
XU383 AO22 $PINS O=n4 A1=n418 A2=n1552 B1=n132 B2=n1551
XU384 OAI112HS $PINS O=n5 A1=n1711 B1=n1562 C1=n1721 C2=n1749
XU385 INV1S $PINS O=n45 I=n1802
XU386 ND3 $PINS O=n1233 I1=n1223 I2=n1222 I3=n1221
XU387 AOI22S $PINS O=n1223 A1=n135 A2=n1640 B1=n417 B2=n1216
XU388 AOI22S $PINS O=n1222 A1=n113 A2=n1218 B1=n131 B2=n1217
XU389 ND3 $PINS O=shift2[0] I1=n1236 I2=n1235 I3=n1234
XU390 NR3 $PINS O=n1236 I1=n1203 I2=n1479 I3=n1202
XU391 NR3 $PINS O=n1235 I1=n1214 I2=n1213 I3=n1212
XU392 NR3 $PINS O=n1234 I1=n1233 I2=n1232 I3=n1231
XU393 NR2 $PINS O=n1609 I1=FE_OFN141_fold_n_0 I2=n111
XU394 INV1S $PINS O=n50 I=n1812
XU395 NR2 $PINS O=n1159 I1=n79 I2=n100
XU396 NR2 $PINS O=n1803 I1=n111 I2=n1829
XU397 ND3 $PINS O=shift2[2] I1=n1331 I2=n1330 I3=n1329
XU398 AN4B1S $PINS O=n1329 I1=n1328 I2=n1327 I3=n1326 B1=n1325
XU399 NR3 $PINS O=n1331 I1=n1311 I2=n1310 I3=n1309
XU400 ND3 $PINS O=n1627 I1=n1306 I2=n1305 I3=n1304
XU401 AN4B1S $PINS O=n1304 I1=n1303 I2=n1302 I3=n1301 B1=n1300
XU402 INV1S $PINS O=n48 I=n1655
XU403 MOAI1S $PINS O=n1571 A1=n1570 A2=n1831 B1=n419 B2=n1569
XU404 ND3 $PINS O=n1569 I1=n1568 I2=n1801 I3=n1567
XU406 OR2 $PINS O=n6 I1=n79 I2=n1009
XU407 INV1S $PINS O=n1672 I=n6
XU408 ND3 $PINS O=n1203 I1=n1192 I2=n1191 I3=n1190
XU409 INV1S $PINS O=n88 I=n1215
XU410 ND3 $PINS O=n1770 I1=n1754 I2=n1753 I3=n1752
XU411 AOI22S $PINS O=n1754 A1=n135 A2=n1739 B1=n419 B2=n1738
XU412 AOI22S $PINS O=n1753 A1=n1746 A2=n69 B1=n1745 B2=n1744
XU413 AN2 $PINS O=n1748 I1=n88 I2=n1540
XU414 NR2 $PINS O=n1811 I1=n52 I2=n48
XU415 ND3 $PINS O=n1479 I1=n1200 I2=n1199 I3=n1198
XU416 OA22 $PINS O=n1200 A1=n77 A2=n1193 B1=n64 B2=n1558
XU417 AN2 $PINS O=n1420 I1=n1308 I2=n1307
XU418 AOI22S $PINS O=n1308 A1=n23 A2=n122 B1=n82 B2=n134
XU419 AOI22S $PINS O=n1419 A1=n1416 A2=n134 B1=n113 B2=n1415
XU420 NR2 $PINS O=n1460 I1=n1665 I2=n1564
XU421 AOI22S $PINS O=n1269 A1=n136 A2=n1259 B1=n125 B2=n1397
XU422 OA12 $PINS O=n1268 A1=n1262 B1=n1263 B2=n81
XU423 MOAI1S $PINS O=n1645 A1=n1644 A2=n1643 B1=n1642 B2=n134
XU424 AN4B1S $PINS O=n1644 I1=n1 I2=n1641 I3=n1801 B1=n1640
XU425 AOI22S $PINS O=n1734 A1=n131 A2=n1723 B1=n58 B2=n114
XU426 ND3 $PINS O=n1723 I1=n1722 I2=n1721 I3=n1720
XU427 MOAI1S $PINS O=n1213 A1=n1804 A2=n6 B1=n132 B2=n1208
XU428 ND3 $PINS O=n1208 I1=n1465 I2=n1510 I3=n1543
XU429 ND3 $PINS O=n1713 I1=n1641 I2=n28 I3=n1757
XU430 NR2 $PINS O=n1532 I1=n45 I2=n52
XU431 MOAI1S $PINS O=n1423 A1=n1761 A2=n1824 B1=n71 B2=n115
XU432 OAI22S $PINS O=n1583 A1=n1582 A2=n1824 B1=n1581 B2=n1679
XU433 AN4B1S $PINS O=n1581 I1=n1580 I2=n1636 I3=n1579 B1=n38
XU434 AN4B1S $PINS O=n1582 I1=n1578 I2=n28 I3=n1577 B1=n1576
XU435 ND3 $PINS O=n1576 I1=n1722 I2=n1811 I3=n1575
XU436 INV1S $PINS O=n128 I=n1667
XU437 AOI22S $PINS O=n1562 A1=n337 A2=n1561 B1=n1560 B2=n1780
XU438 AOI22S $PINS O=n1437 A1=n134 A2=n33 B1=n114 B2=n1404
XU439 ND3 $PINS O=n1404 I1=n1760 I2=n1815 I3=n34
XU440 OA22 $PINS O=n1120 A1=n1108 A2=n1631 B1=n1107 B2=n1749
XU441 NR3 $PINS O=n1108 I1=n1105 I2=n1713 I3=n37
XU442 AN4B1S $PINS O=n1107 I1=n1106 I2=n1510 I3=n1335 B1=n49
XU443 ND3 $PINS O=n1105 I1=n1718 I2=n1736 I3=n1579
XU444 AN2 $PINS O=n1706 I1=n1296 I2=n1295
XU445 AOI22S $PINS O=n1296 A1=n116 A2=n1672 B1=n56 B2=n136
XU446 NR2 $PINS O=n1293 I1=n123 I2=n115
XU447 INV1S $PINS O=n1553 I=n7
XU448 INV1S $PINS O=n126 I=n1588
XU449 NR2 $PINS O=n1567 I1=n36 I2=n1482
XU450 ND3 $PINS O=n1051 I1=n1050 I2=n1674 I3=n1049
XU451 OAI12HS $PINS O=n1049 A1=n122 B1=n38 B2=n1121
XU452 MOAI1S $PINS O=n1202 A1=n1591 A2=n1667 B1=n138 B2=n1201
XU453 ND3 $PINS O=n1201 I1=n1508 I2=n1722 I3=n1407
XU454 OAI222S $PINS O=n1500 A1=n1634 A2=n1757 B1=n1499 B2=n1747 C1=n1806
+ C2=n1641
XU455 AN4B1S $PINS O=n1499 I1=n1498 I2=n1832 I3=n89 B1=n1497
XU456 NR2 $PINS O=n1801 I1=n1215 I2=n82
XU457 OA22 $PINS O=n1346 A1=n1382 A2=n81 B1=n72 B2=n1558
XU458 AN4B1S $PINS O=n1220 I1=n1540 I2=n1568 I3=n1449 B1=n48
XU459 OAI112HS $PINS O=n1480 A1=n1183 B1=n1182 C1=n1336 C2=n1388
XU460 OA22 $PINS O=n1182 A1=n1556 A2=n1181 B1=n1787 B2=n1422
XU461 OA12 $PINS O=n1183 A1=n1285 B1=n1660 B2=n1800
XU462 NR2 $PINS O=n1714 I1=n1482 I2=n48
XU463 ND3 $PINS O=n1122 I1=n1385 I2=n96 I3=n1649
XU464 OAI22S $PINS O=n1094 A1=n1787 A2=n77 B1=n1800 B2=n7
XU465 NR2 $PINS O=n1680 I1=n18 I2=n62
XU466 NR2 $PINS O=n1397 I1=n79 I2=n1089
XU467 NR2 $PINS O=n1106 I1=n46 I2=n62
XU468 NR2 $PINS O=n1463 I1=n1560 I2=n1159
XU469 OA22 $PINS O=n1403 A1=n1393 A2=n1831 B1=n1556 B2=n80
XU470 AN4B1S $PINS O=n1393 I1=n1758 I2=n1721 I3=n1392 B1=n23
XU471 NR2 $PINS O=n1422 I1=n1159 I2=n1515
XU472 OAI222S $PINS O=n1501 A1=n1496 A2=n1643 B1=n1495 B2=n1494 C1=n1493
+ C2=n1730
XU473 NR3 $PINS O=n1495 I1=n1488 I2=n1487 I3=n1486
XU474 NR3 $PINS O=n1493 I1=n1492 I2=n1491 I3=n1490
XU475 INV1S $PINS O=n106 I=n1089
XU476 INV1S $PINS O=n102 I=n1009
XU477 NR3 $PINS O=n1006 I1=n1003 I2=n1777 I3=n1004
XU478 AN4B1S $PINS O=n1005 I1=n1294 I2=n1564 I3=n95 B1=n1789
XU479 ND3 $PINS O=n1003 I1=n1382 I2=n1564 I3=n99
XU480 OA22 $PINS O=n1625 A1=n1679 A2=n1812 B1=n1712 B2=n1631
XU481 NR2 $PINS O=n1319 I1=n1515 I2=n1417
XU482 AN2 $PINS O=n1321 I1=n1318 I2=n1458
XU483 AN2 $PINS O=n1320 I1=n1590 I2=n1507
XU484 OAI22S $PINS O=n1212 A1=n1211 A2=n1749 B1=n1210 B2=n1679
XU485 AN4B1S $PINS O=n1210 I1=n1398 I2=n1241 I3=n1579 B1=n37
XU486 AN4B1S $PINS O=n1211 I1=n1209 I2=n1575 I3=n1721 B1=n51
XU487 MOAI1S $PINS O=n1646 A1=n1639 A2=n1831 B1=n419 B2=n1638
XU488 AN4B1S $PINS O=n1639 I1=n1761 I2=n1636 I3=n1 B1=n1635
XU489 ND3 $PINS O=n1638 I1=n63 I2=n1724 I3=n1637
XU490 ND3 $PINS O=n1546 I1=n1537 I2=n1674 I3=n1536
XU491 AOI22S $PINS O=n1536 A1=n136 A2=n1535 B1=n419 B2=n1534
XU492 OR2 $PINS O=n1534 I1=n1533 I2=n52
XU493 OAI222S $PINS O=n1647 A1=n1634 A2=n1757 B1=n1633 B2=n1632 C1=n1758
+ C2=n1631
XU494 NR2 $PINS O=n1316 I1=n1314 I2=n1672
XU495 NR2 $PINS O=n1315 I1=n50 I2=n87
XU496 AN4B1S $PINS O=n1628 I1=n76 I2=n1626 I3=n1625 B1=n1624
XU497 OAI22S $PINS O=n1325 A1=n1324 A2=n1643 B1=n1323 B2=n1831
XU498 AN4B1S $PINS O=n1324 I1=n1748 I2=n1718 I3=n1761 B1=n85
XU499 NR3 $PINS O=n1323 I1=n1322 I2=n59 I3=n20
XU500 MOAI1S $PINS O=n1429 A1=n1665 A2=n1180 B1=n122 B2=n58
XU501 NR2 $PINS O=n1292 I1=n82 I2=n45
XU502 AOI22S $PINS O=n1673 A1=n1672 A2=n1671 B1=n138 B2=n1670
XU503 OAI222S $PINS O=n1232 A1=n1722 A2=n1677 B1=n67 B2=n1659 C1=n1388 C2=n2
XU504 OAI222S $PINS O=n1082 A1=n1081 A2=n1831 B1=n1080 B2=n1824 C1=n1079
+ C2=n1631
XU505 NR2 $PINS O=n1081 I1=n21 I2=n53
XU506 NR2 $PINS O=n1080 I1=n18 I2=n36
XU507 AN2 $PINS O=n1079 I1=n1449 I2=n1761
XU508 INV1S $PINS O=n132 I=n1634
XU509 INV1S $PINS O=n63 I=n1482
XU510 OAI222S $PINS O=n1021 A1=n1800 A2=n67 B1=n1387 B2=n1556 C1=n1352 C2=n1659
XU511 MOAI1S $PINS O=n1150 A1=n1228 A2=n1665 B1=n126 B2=n1149
XU512 ND2 $PINS O=n1631 I1=n1687 I2=n1029
XU513 ND2 $PINS O=n1743 I1=n1619 I2=n1048
XU514 NR3 $PINS O=n1637 I1=n90 I2=n91 I3=n1215
XU515 ND3 $PINS O=n1084 I1=n1074 I2=n1073 I3=n1072
XU516 OA22 $PINS O=n1074 A1=n1751 A2=n1761 B1=n1804 B2=n1394
XU517 AOI22S $PINS O=n1073 A1=n418 A2=n1069 B1=n8 B2=n1068
XU518 ND2 $PINS O=n1558 I1=n1071 I2=n1619
XU519 OAI222S $PINS O=n1769 A1=n1756 A2=n2 B1=n86 B2=n1806 C1=n92 C2=n1755
XU520 INV1S $PINS O=n80 I=n1515
XU521 MOAI1S $PINS O=n1400 A1=n1643 A2=n1567 B1=n137 B2=n1399
XU522 ND3 $PINS O=n1399 I1=n1724 I2=n1449 I3=n39
XU523 INV1S $PINS O=n101 I=n1774
XU524 AN2 $PINS O=n1383 I1=n1666 I2=n1464
XU525 OAI22S $PINS O=n1808 A1=n1807 A2=n1806 B1=n1805 B2=n1804
XU526 NR2 $PINS O=n1805 I1=n1803 I2=n106
XU527 AN4B1S $PINS O=n1807 I1=n1802 I2=n1828 I3=n1801 B1=n62
XU528 OAI222S $PINS O=n1391 A1=n81 A2=n99 B1=n1462 B2=n1740 C1=n1386 C2=n92
XU529 AN4B1S $PINS O=n1386 I1=n1385 I2=n96 I3=n1755 B1=n1384
XU530 ND3 $PINS O=n1384 I1=n1383 I2=n1382 I3=n98
XU531 MOAI1S $PINS O=n1424 A1=n1665 A2=n99 B1=n1672 B2=n129
XU532 OAI222S $PINS O=n1456 A1=n1455 A2=n1632 B1=n70 B2=n1756 C1=n1730 C2=n1593
XU533 INV1S $PINS O=n70 I=n1454
XU534 MOAI1S $PINS O=n1624 A1=n1344 A2=n1665 B1=n123 B2=n1417
XU535 NR2 $PINS O=n1718 I1=n53 I2=n52
XU536 AOI22S $PINS O=n1164 A1=n1156 A2=n1155 B1=n1154 B2=n1454
XU537 ND3 $PINS O=n1155 I1=n95 I2=n1294 I3=n1228
XU538 MOAI1S $PINS O=n1414 A1=n1559 A2=n67 B1=n418 B2=n1411
XU539 ND2 $PINS O=n1388 I1=n1047 I2=n1019
XU540 ND3 $PINS O=n1216 I1=n1801 I2=n1318 I3=n1447
XU541 INV1S $PINS O=n90 I=n1318
XU542 INV1S $PINS O=n105 I=n1131
XU543 ND3 $PINS O=n1450 I1=n1532 I2=n1449 I3=n1712
XU544 OAI222S $PINS O=n1067 A1=n1633 A2=n1743 B1=n1591 B2=n1787 C1=n1749
+ C2=n1577
XU545 OA22 $PINS O=n1565 A1=n92 A2=n1564 B1=n1659 B2=n7
XU546 AOI22S $PINS O=n1566 A1=n119 A2=n1672 B1=n128 B2=n69
XU547 OAI112HS $PINS O=n1518 A1=n1516 B1=n1555 C1=n1517 C2=n1742
XU548 OAI12HS $PINS O=n1516 A1=n128 B1=n1515 B2=n1744
XU549 ND2 $PINS O=n1632 I1=n1075 I2=n1019
XU550 OA22 $PINS O=n1663 A1=n1747 A2=n1654 B1=n1756 B2=n1653
XU551 MOAI1S $PINS O=n1020 A1=n92 A2=n1820 B1=n122 B2=n58
XU552 INV1S $PINS O=n130 I=n1764
XU553 AOI22S $PINS O=n1192 A1=n131 A2=n52 B1=n1672 B2=n116
XU554 INV1S $PINS O=n119 I=n1740
XU555 ND3 $PINS O=n1777 I1=n1385 I2=n1821 I3=n1383
XU556 OAI222S $PINS O=n1585 A1=n6 A2=n1764 B1=n1804 B2=n72 C1=n1 C2=n1631
XU557 ND3 $PINS O=n1483 I1=n1540 I2=n1812 I3=n1712
XU558 OA22 $PINS O=n1401 A1=n1742 A2=n1517 B1=n1762 B2=n1398
XU559 NR2 $PINS O=n1405 I1=n1089 I2=FE_OFN140_fold_n_0
XU560 MOAI1S $PINS O=n1389 A1=n1463 A2=n1764 B1=n31 B2=n418
XU561 OAI222S $PINS O=n1231 A1=n1230 A2=n92 B1=n1229 B2=n81 C1=n1665 C2=n1382
XU562 NR3 $PINS O=n1230 I1=n1226 I2=n1225 I3=n1224
XU563 AN4B1S $PINS O=n1229 I1=n1464 I2=n1228 I3=n1755 B1=n1227
XU564 ND3 $PINS O=n1226 I1=n1820 I2=n96 I3=n1464
XU565 ND2 $PINS O=n1766 I1=n1687 I2=n1692
XU566 INV1S $PINS O=n136 I=n1749
XU567 OA22 $PINS O=n1334 A1=n1588 A2=n64 B1=n1344 B2=n81
XU568 INV1S $PINS O=n418 I=n1806
XU569 NR2 $PINS O=n1729 I1=n82 I2=n90
XU570 ND3 $PINS O=n1310 I1=n1062 I2=n1441 I3=n1061
XU571 AOI22S $PINS O=n1062 A1=n126 A2=n1159 B1=n337 B2=n91
XU572 INV1S $PINS O=n83 I=n1490
XU573 MOAI1S $PINS O=n1250 A1=n1249 A2=n1494 B1=n30 B2=n337
XU574 NR2 $PINS O=n1249 I1=n51 I2=n1491
XU575 OA22 $PINS O=n1733 A1=n92 A2=n1464 B1=n1804 B2=n67
XU576 INV1S $PINS O=n419 I=n1494
XU577 INV1S $PINS O=n123 I=n1804
XU578 INV1S $PINS O=n113 I=n1762
XU579 NR2 $PINS O=n1338 I1=n1515 I2=n1672
XU580 NR2 $PINS O=n1132 I1=n108 I2=n102
XU581 INV1S $PINS O=n118 I=n1659
XU582 INV1S $PINS O=n134 I=n1730
XU583 INV1S $PINS O=n85 I=n1641
XU584 NR2 $PINS O=n1517 I1=n1560 I2=n1397
XU585 OA22 $PINS O=n1441 A1=n92 A2=n1385 B1=n81 B2=n1294
XU586 INV1S $PINS O=n114 I=n1679
XU587 OAI22S $PINS O=n1544 A1=n1543 A2=n1766 B1=n1593 B2=n1542
XU588 MOAI1S $PINS O=n1529 A1=n1747 A2=n1641 B1=n132 B2=n21
XU589 MOAI1S $PINS O=n1066 A1=n7 A2=n1588 B1=n1672 B2=n129
XU590 OR2 $PINS O=n1018 I1=n1631 I2=n1540
XU591 AOI22S $PINS O=n1836 A1=n122 A2=n1810 B1=n121 B2=n106
XU592 MOAI1S $PINS O=n1545 A1=n1541 A2=n1540 B1=n134 B2=n1539
XU593 NR2 $PINS O=n1541 I1=n137 I2=n418
XU594 INV1S $PINS O=n991 I=n1692
XU595 INV1S $PINS O=n131 I=n1831
XU596 MOAI1S $PINS O=n1530 A1=n1764 A2=n80 B1=n46 B2=n418
XU597 INV1S $PINS O=n417 I=n1643
XU598 INV1S $PINS O=n137 I=n1747
XU599 INV1S $PINS O=n992 I=n1029
XU600 ND3 $PINS O=n1153 I1=n1132 I2=n1131 I3=n1130
XU601 NR2 $PINS O=n1130 I1=n1818 I2=n101
XU602 INV1S $PINS O=n120 I=n1800
XU603 INV1S $PINS O=n135 I=n1824
XU604 NR2 $PINS O=n1612 I1=n1829 I2=n991
XU605 NR2 $PINS O=n1818 I1=n111 I2=n1775
XU606 INV1S $PINS O=n111 I=n_idx[1]
XU607 NR2 $PINS O=n1022 I1=n110 I2=n_idx[1]
XU608 NR2 $PINS O=n1171 I1=n1699 I2=n25
XU609 NR3 $PINS O=n1170 I1=n1219 I2=n55 I3=n41
XU610 ND3 $PINS O=n1505 I1=n1816 I2=n1538 I3=n1172
XU611 AN2 $PINS O=n1172 I1=n1335 I2=n24
XU612 NR2 $PINS O=n996 I1=n1829 I2=n_idx[1]
XU613 AN4B1S $PINS O=n1175 I1=n1318 I2=n1816 I3=n1761 B1=n1373
XU615 OAI222S $PINS O=n1248 A1=n1240 A2=n1730 B1=n1239 B2=n1643 C1=n1238
+ C2=n1747
XU616 AN4B1S $PINS O=n1240 I1=n84 I2=n1801 I3=n1504 B1=n1237
XU617 AN4B1S $PINS O=n1239 I1=n88 I2=n1369 I3=n1654 B1=n52
XU618 AN4B1S $PINS O=n1238 I1=n1318 I2=n1489 I3=n1369 B1=n1486
XU619 INV1S $PINS O=n62 I=n1725
XU620 ND2 $PINS O=n1757 I1=n994 I2=n_idx[0]
XU621 NR2 $PINS O=n1721 I1=n1699 I2=n58
XU622 OAI112HS $PINS O=n1040 A1=n1190 B1=n1063 C1=n1730 C2=n1204
XU623 NR2 $PINS O=n1227 I1=n97 I2=n112
XU624 AN2 $PINS O=n1442 I1=n1343 I2=n1342
XU625 AOI22S $PINS O=n1343 A1=n1340 A2=n1339 B1=n26 B2=n122
XU626 AOI22S $PINS O=n1342 A1=n1652 A2=n1341 B1=n114 B2=n20
XU627 ND3 $PINS O=n1341 I1=n1564 I2=n94 I3=n107
XU628 AN4B1S $PINS O=n1138 I1=n1129 I2=n1128 I3=n1127 B1=n1126
XU629 AOI22S $PINS O=n1129 A1=n129 A2=n65 B1=n1417 B2=n115
XU630 AOI22S $PINS O=n1127 A1=n1652 A2=n1122 B1=n118 B2=n1672
XU631 AOI22S $PINS O=n1128 A1=n122 A2=n1121 B1=n128 B2=n1314
XU632 OAI22S $PINS O=n1732 A1=n1822 A2=n28 B1=n1731 B2=n1730
XU633 ND3 $PINS O=n1728 I1=n1726 I2=n1725 I3=n1724
XU634 NR3 $PINS O=n998 I1=n111 I2=n110 I3=n40
XU635 NR2 $PINS O=n1560 I1=n79 I2=n1797
XU636 OAI22S $PINS O=n1430 A1=n1354 A2=n1631 B1=n1353 B2=n1756
XU637 NR2 $PINS O=n1353 I1=n1560 I2=n68
XU638 NR3 $PINS O=n1354 I1=n1351 I2=n26 I3=n1350
XU639 NR2 $PINS O=n1466 I1=n20 I2=n1699
XU640 INV1S $PINS O=n79 I=n1784
XU641 AN4B1S $PINS O=n1008 I1=n1726 I2=n1538 I3=n1573 B1=n1482
XU642 INV1S $PINS O=n28 I=n1699
XU643 OAI222S $PINS O=n1457 A1=n1453 A2=n1643 B1=n1452 B2=n1494 C1=n1451
+ C2=n1747
XU644 NR3 $PINS O=n1453 I1=n1448 I2=n1491 I3=n42
XU645 AN4B1S $PINS O=n1452 I1=n1489 I2=n1538 I3=n1540 B1=n1597
XU646 AN2 $PINS O=n1044 I1=n1025 I2=FE_OFN141_fold_n_0
XU647 NR3 $PINS O=n1253 I1=n59 I2=n1699 I3=n53
XU648 ND3 $PINS O=n1288 I1=n1258 I2=n1257 I3=n1256
XU649 AOI22S $PINS O=n1258 A1=n119 A2=n71 B1=n130 B2=n78
XU650 AOI22S $PINS O=n1257 A1=n138 A2=n1255 B1=n123 B2=n1254
XU651 OAI22S $PINS O=n1151 A1=n1147 A2=n1643 B1=n1146 B2=n1494
XU652 NR2 $PINS O=n1147 I1=n1486 I2=n1642
XU653 AN2 $PINS O=n1146 I1=n1725 I2=n1173
XU654 OAI222S $PINS O=n1214 A1=n1207 A2=n1494 B1=n24 B2=n1631 C1=n1206 C2=n1747
XU655 NR3 $PINS O=n1207 I1=n1205 I2=n41 I3=n1486
XU656 ND3 $PINS O=n1205 I1=n1489 I2=n1204 I3=n1737
XU657 AOI22S $PINS O=n1118 A1=n138 A2=n1114 B1=n113 B2=n1113
XU658 ND3 $PINS O=n1113 I1=n34 I2=n1361 I3=n1466
XU659 ND3 $PINS O=n1114 I1=n1543 I2=n1465 I3=n1112
XU660 NR3 $PINS O=n1112 I1=n18 I2=n1699 I3=n51
XU661 INV1S $PINS O=n52 I=n1816
XU662 NR2 $PINS O=n1619 I1=n890 I2=n14
XU663 AN2 $PINS O=n1687 I1=n1691 I2=n890
XU664 AN2 $PINS O=n8 I1=n1792 I2=n17
XU665 INV1S $PINS O=n1665 I=n8
XU666 ND3 $PINS O=n1641 I1=n_idx[1] I2=n110 I3=n1044
XU667 ND3 $PINS O=n1449 I1=n1025 I2=n110 I3=n1609
XU668 ND3 $PINS O=n1540 I1=n111 I2=n110 I3=n1044
XU669 AOI22S $PINS O=n1664 A1=n126 A2=n65 B1=n1652 B2=n1651
XU670 ND3 $PINS O=n1651 I1=n1650 I2=n1649 I3=n1648
XU671 AN2 $PINS O=n1648 I1=n1820 I2=n1666
XU672 AN4B1S $PINS O=n1823 I1=n1821 I2=n1820 I3=n1819 B1=n1818
XU673 NR3 $PINS O=n1825 I1=n1817 I2=n21 I3=n47
XU674 ND3 $PINS O=n1817 I1=n1816 I2=n28 I3=n1815
XU675 ND3 $PINS O=sign3[1] I1=n1839 I2=n1838 I3=n1837
XU676 NR2 $PINS O=n1838 I1=n1809 I2=n1808
XU677 NR2 $PINS O=n1839 I1=n1795 I2=n1794
XU678 AN4B1S $PINS O=n1837 I1=n1836 I2=n1835 I3=n1834 B1=n1833
XU679 AOI22S $PINS O=n1034 A1=n419 A2=n1027 B1=n134 B2=n1026
XU680 ND3 $PINS O=n1634 I1=n1692 I2=n133 I3=n1619
XU681 ND3 $PINS O=n1492 I1=n1489 I2=n1593 I3=n1724
XU682 OAI222S $PINS O=n1795 A1=n1788 A2=n1787 B1=n1786 B2=n1785 C1=n1784
+ C2=n1783
XU683 AN2 $PINS O=n1788 I1=n1775 I2=n1774
XU684 NR2 $PINS O=n1786 I1=n1777 I2=n1776
XU685 AN2 $PINS O=n1783 I1=n1793 I2=n1826
XU686 NR2 $PINS O=n1019 I1=n890 I2=k_idx[2]
XU687 ND3 $PINS O=n1083 I1=n75 I2=n1674 I3=n1078
XU688 AOI22S $PINS O=n1078 A1=n1339 A2=n1077 B1=n1560 B2=n1076
XU689 INV1S $PINS O=n82 I=n1204
XU690 INV1S $PINS O=n108 I=n1797
XU691 NR2 $PINS O=n1045 I1=n113 I2=n417
XU692 INV1S $PINS O=n104 I=n1224
XU693 AN2 $PINS O=n1046 I1=n1578 I2=n1636
XU694 OA12 $PINS O=n1515 A1=n1784 B1=n105 B2=n106
XU695 ND3 $PINS O=n1747 I1=k_idx[3] I2=n16 I3=n1687
XU696 AOI22S $PINS O=n1302 A1=n138 A2=n1299 B1=n418 B2=n1298
XU697 AN2 $PINS O=n1709 I1=n1058 I2=n1057
XU698 AOI22S $PINS O=n1058 A1=n1652 A2=n1340 B1=n25 B2=n114
XU699 ND3 $PINS O=n1318 I1=n_idx[0] I2=n1022 I3=n1025
XU700 NR2 $PINS O=n1700 I1=n890 I2=n991
XU701 OAI112HS $PINS O=n1701 A1=n1689 B1=n1688 C1=k_idx[2] C2=n1775
XU702 ND2 $PINS O=n1764 I1=n1075 I2=n1610
XU703 ND3 $PINS O=n1822 I1=n1070 I2=n15 I3=n1024
XU704 INV1S $PINS O=n92 I=n1652
XU705 OA22 $PINS O=n1191 A1=n1092 A2=n79 B1=n98 B2=n1665
XU706 NR2 $PINS O=n1092 I1=n1091 I2=n1090
XU707 OAI222S $PINS O=n1090 A1=n109 A2=n1659 B1=n1412 B2=n1774 C1=n1800
+ C2=n1797
XU708 OAI222S $PINS O=n1091 A1=n117 A2=n1089 B1=n1088 B2=n100 C1=n1132 C2=n1588
XU709 ND3 $PINS O=n1785 I1=n15 I2=n16 I3=n1028
XU710 INV1S $PINS O=n81 I=n1339
XU711 ND2 $PINS O=n1740 I1=n1071 I2=n1070
XU712 ND3 $PINS O=n1806 I1=n1619 I2=n15 I3=n1024
XU713 ND3 $PINS O=n1494 I1=n1619 I2=k_idx[3] I3=n1024
XU714 ND2 $PINS O=n1749 I1=n1029 I2=n1028
XU715 ND3 $PINS O=n1762 I1=n1619 I2=n133 I3=n1029
XU716 ND3 $PINS O=n1137 I1=n1136 I2=n1262 I3=n1135
XU717 ND3 $PINS O=n1136 I1=n1784 I2=n1153 I3=n119
XU718 AOI22S $PINS O=n1135 A1=n8 A2=n1134 B1=n116 B2=n1133
XU719 ND2 $PINS O=n1804 I1=n1610 I2=n1047
XU720 OA12 $PINS O=n1819 A1=n17 B1=n109 B2=FE_OFN141_fold_n_0
XU721 ND2 $PINS O=n1659 I1=n1071 I2=n1610
XU722 AOI22S $PINS O=n1139 A1=n74 A2=n1779 B1=n1339 B2=n1789
XU723 ND3 $PINS O=n1730 I1=k_idx[3] I2=n16 I3=n1028
XU724 ND2 $PINS O=n1787 I1=n1610 I2=n1048
XU725 ND3 $PINS O=n1679 I1=n1070 I2=n133 I3=n1692
XU726 ND3 $PINS O=n1237 I1=n1832 I2=n1816 I3=n1641
XU727 ND2 $PINS O=n1824 I1=n1028 I2=n1692
XU728 ND2 $PINS O=n1800 I1=n1047 I2=n1070
XU729 AOI22S $PINS O=n1835 A1=n114 A2=n1814 B1=n417 B2=n91
XU730 NR2 $PINS O=n1692 I1=n16 I2=n15
XU731 NR2 $PINS O=n1047 I1=n991 I2=n133
XU732 ND3 $PINS O=n1831 I1=n1070 I2=n133 I3=n1029
XU733 OAI12HS $PINS O=n1702 A1=n1798 B1=n133 B2=n1622
XU734 OA22 $PINS O=n1620 A1=n17 A2=n1619 B1=n97 B2=n1692
XU735 ND3 $PINS O=n1623 I1=n1618 I2=n1617 I3=n1616
XU736 ND3 $PINS O=n1618 I1=n1790 I2=n991 I3=n1611
XU737 ND3 $PINS O=n1617 I1=n1613 I2=n17 I3=n1612
XU738 ND3 $PINS O=n1643 I1=k_idx[3] I2=n1070 I3=n1024
XU739 OAI112HS $PINS O=n1776 A1=n109 B1=n17 C1=n1775 C2=FE_OFN141_fold_n_0
XU740 NR2 $PINS O=n1029 I1=n16 I2=k_idx[3]
XU741 NR2 $PINS O=n1071 I1=n992 I2=n133
XU742 AN2 $PINS O=n1075 I1=k_idx[3] I2=n1010
XU743 AN2 $PINS O=n1048 I1=n1010 I2=n15
XU744 ND3 $PINS O=n1165 I1=n123 I2=n1153 I3=n1784
XU745 ND3 $PINS O=n1689 I1=n133 I2=n890 I3=n1818
XU746 NR2 $PINS O=n994 I1=n109 I2=n_idx[4]
XU747 ND3 $PINS O=sign3[0] I1=n1773 I2=n1772 I3=n1771
XU748 AN4B1S $PINS O=n1772 I1=n1735 I2=n1734 I3=n1733 B1=n1732
XU749 NR3 $PINS O=n1771 I1=n1770 I2=n1769 I3=n1768
XU751 ND3 $PINS O=sign2[0] I1=n1686 I2=n1685 I3=n1684
XU752 NR3 $PINS O=n1685 I1=n1647 I2=n1646 I3=n1645
XU753 AN4B1S $PINS O=n1686 I1=n1630 I2=n1629 I3=n1628 B1=n1627
XU754 NR2 $PINS O=n997 I1=n1797 I2=n_idx[4]
XU755 NR2 $PINS O=n1813 I1=n97 I2=n_idx[4]
XU756 INV1S $PINS O=n103 I=n_idx[3]
XU757 INV1S $PINS O=n110 I=n_idx[2]
XU758 NR2 $PINS O=n999 I1=n1774 I2=n_idx[4]
XU759 NR2 $PINS O=n993 I1=n103 I2=n_idx[2]
XU761 ND3 $PINS O=n1725 I1=n996 I2=FE_OFN141_fold_n_0 I3=n_idx[4]
XU762 NR2 $PINS O=n995 I1=n1009 I2=n_idx[4]
XU763 NR3 $PINS O=n1007 I1=n_idx[1] I2=n_idx[2] I3=FE_OFN141_fold_n_0
XU764 NR2 $PINS O=n1698 I1=n_idx[4] I2=n_idx[3]
XU765 ND3 $PINS O=sign1[0] I1=n1608 I2=n1607 I3=n1606
XU766 NR3 $PINS O=n1607 I1=n1585 I2=n1584 I3=n1583
XU767 NR3 $PINS O=n1608 I1=n1572 I2=n1708 I3=n1571
XU768 NR2 $PINS O=n1784 I1=n_idx[0] I2=n_idx[4]
XU769 NR2 $PINS O=n1025 I1=n103 I2=n_idx[4]
XU770 NR2 $PINS O=n1013 I1=n_idx[2] I2=n_idx[0]
XU771 INV1S $PINS O=n890 I=k_idx[1]
XU772 NR2 $PINS O=n1002 I1=n110 I2=n_idx[3]
XU773 ND3 $PINS O=n1489 I1=n1025 I2=n_idx[2] I3=n1609
XU774 MOAI1S $PINS O=n1833 A1=n1832 A2=n1831 B1=n132 B2=n1830
XU775 OAI112HS $PINS O=n1830 A1=n1828 B1=n1827 C1=n_idx[4] C2=n1829
XU781 ND3 $PINS O=n1204 I1=n_idx[1] I2=n_idx[2] I3=n1044
XU808 NR2 $PINS O=n1610 I1=k_idx[2] I2=k_idx[1]
XU809 NR2 $PINS O=n1652 I1=n1822 I2=n_idx[4]
XU846 NR2 $PINS O=n1339 I1=n1785 I2=n_idx[4]
XU914 AN2 $PINS O=n1028 I1=n1691 I2=k_idx[1]
XU918 MOAI1S $PINS O=n1794 A1=n1793 A2=n1829 B1=n1792 B2=n1791
XU921 OAI112HS $PINS O=n1809 A1=n1799 B1=n1798 C1=n_idx[3] C2=n1800
XU922 OAI112HS $PINS O=n1697 A1=n1695 B1=n1694 C1=n1696 C2=n1790
XU938 ND3 $PINS O=n1695 I1=n111 I2=n110 I3=k_idx[0]
XU946 AOI13HS $PINS O=n1694 A1=n122 B1=k_idx[1] B2=n1693 B3=n1692
XU953 MOAI1S $PINS O=n1693 A1=n_idx[2] A2=n1691 B1=n1690 B2=n111
XU959 INV1S $PINS O=n17 I=n_idx[4]
XU963 INV1S $PINS O=n16 I=k_idx[4]
XU964 INV1S $PINS O=n15 I=k_idx[3]
XU965 AOI13HS $PINS O=n1688 A1=n_idx[4] B1=n_idx[1] B2=n_idx[3] B3=n1687
XU966 NR2 $PINS O=n1691 I1=k_idx[2] I2=k_idx[0]
XU967 AOI22S $PINS O=n1616 A1=n1615 A2=n991 B1=n1813 B2=n1614
XU969 MOAI1S $PINS O=n1615 A1=k_idx[1] A2=n1819 B1=n14 B2=n1776
XU975 INV1S $PINS O=n14 I=k_idx[2]
XU988 INV1S $PINS O=n133 I=k_idx[0]
XU992 NR2 $PINS O=n1010 I1=n133 I2=k_idx[4]
XU997 OR2 $PINS O=n1790 I1=n_idx[2] I2=n1609
XU998 NR2 $PINS O=n1024 I1=k_idx[4] I2=k_idx[0]
XU999 AN2 $PINS O=n1611 I1=n_idx[3] I2=n1610
XU1005 MOAI1S $PINS O=n1613 A1=n1691 A2=n890 B1=k_idx[0] B2=k_idx[2]
XU1007 OA12 $PINS O=n1704 A1=n992 B1=k_idx[4] B2=n15
XU72 AN4S $PINS O=n1570 I1=n1758 I2=n1578 I3=n1573 I4=n1580
.ENDS

.SUBCKT SNPS_CLOCK_GATE_HIGH_ROM_Wrapper_Even_0 EN ENCLK CLK
*.CONNECT net2335 EN
XFE_PHC874_net2338 DELC $PINS O=net2338 I=FE_PHN874_net2338
Xlatch QDBHN $PINS Q=FE_PHN874_net2338 D=net2335 CKB=CLK
Xmain_gate AN2T $PINS O=ENCLK I1=net2338 I2=CLK
.ENDS

.SUBCKT ROM_Wrapper_Even_0 rst_n en n_in[4] n_in[3] n_in[2] n_in[1] n_in[0]
+ k_idx[4] k_idx[3] k_idx[2] k_idx[1] k_idx[0] reg_sign1[1] reg_sign1[0]
+ reg_sign2[1] reg_sign2[0] reg_sign3[1] reg_sign3[0] reg_shift1[3]
+ reg_shift1[2] reg_shift1[1] reg_shift1[0] reg_shift2[3] reg_shift2[2]
+ reg_shift2[1] reg_shift2[0] reg_shift3[3] reg_shift3[2] reg_shift3[1]
+ reg_shift3[0] i_rst_n clk
*.CONNECT N4 n_in[0]
XCTS_ccl_a_INV_CLK_G1_L8_44 INV6CK $PINS O=CTS_10 I=CTS_11
XCTS_ccl_a_INV_CLK_G1_L7_47 INV3CK $PINS O=CTS_11 I=CTS_12
Xreg_sign1_reg[1] DFFSBN $PINS Q=reg_sign1[1] D=raw_s1[1] CK=CTS_10 SB=i_rst_n
Xreg_sign2_reg[1] DFFSBN $PINS Q=reg_sign2[1] D=raw_s2[1] CK=CTS_10 SB=i_rst_n
Xreg_sign3_reg[1] DFFSBN $PINS Q=reg_sign3[1] D=raw_s3[1] CK=CTS_10 SB=i_rst_n
Xreg_shift1_reg[1] QDFFRBN $PINS Q=reg_shift1[1] D=raw_h1[1] CK=CTS_10
+ RB=i_rst_n
Xreg_shift2_reg[1] QDFFRBP $PINS Q=reg_shift2[1] D=raw_h2[1] CK=CTS_10
+ RB=i_rst_n
Xreg_shift3_reg[1] QDFFRBN $PINS Q=reg_shift3[1] D=raw_h3[1] CK=CTS_10
+ RB=i_rst_n
Xreg_shift1_reg[0] QDFFRBN $PINS Q=reg_shift1[0] D=raw_h1[0] CK=CTS_10
+ RB=i_rst_n
Xreg_shift2_reg[2] QDFFRBN $PINS Q=reg_shift2[2] D=raw_h2[2] CK=CTS_10
+ RB=i_rst_n
Xreg_shift2_reg[3] QDFFRBN $PINS Q=reg_shift2[3] D=raw_h2[3] CK=CTS_10
+ RB=i_rst_n
Xreg_shift2_reg[0] QDFFRBN $PINS Q=reg_shift2[0] D=raw_h2[0] CK=CTS_10
+ RB=i_rst_n
Xreg_sign1_reg[0] QDFFRBN $PINS Q=reg_sign1[0] D=final_s1[0] CK=CTS_10
+ RB=i_rst_n
Xreg_sign2_reg[0] QDFFRBN $PINS Q=reg_sign2[0] D=final_s2[0] CK=CTS_10
+ RB=i_rst_n
Xreg_shift1_reg[3] QDFFRBP $PINS Q=reg_shift1[3] D=raw_h1[3] CK=CTS_10
+ RB=i_rst_n
Xreg_shift1_reg[2] QDFFRBN $PINS Q=reg_shift1[2] D=raw_h1[2] CK=CTS_10
+ RB=i_rst_n
Xreg_shift3_reg[3] QDFFRBN $PINS Q=reg_shift3[3] D=raw_h3[3] CK=CTS_10
+ RB=i_rst_n
Xreg_shift3_reg[2] QDFFRBN $PINS Q=reg_shift3[2] D=raw_h3[2] CK=CTS_10
+ RB=i_rst_n
Xreg_shift3_reg[0] QDFFRBN $PINS Q=reg_shift3[0] D=raw_h3[0] CK=CTS_10
+ RB=i_rst_n
Xreg_sign3_reg[0] QDFFRBN $PINS Q=reg_sign3[0] D=final_s3[0] CK=CTS_10
+ RB=i_rst_n
XU3 NR2 $PINS O=sub_79/carry[2] I1=N4 I2=n_in[1]
XU4 AN2S $PINS O=sub_79/carry[4] I1=sub_79/carry[3] I2=n5
XU7 INV1S $PINS O=n7 I=n_in[1]
XU8 XNR2HS $PINS O=final_s3[0] I1=raw_s3[0] I2=n10
XU9 MOAI1 $PINS O=fold_n[1] A1=n7 A2=N2 B1=N5 B2=N2
XU10 XNR2HS $PINS O=final_s2[0] I1=raw_s2[0] I2=n10
XU11 INV1S $PINS O=n9 I=N4
XU12 MOAI1 $PINS O=fold_n[0] A1=n9 A2=N2 B1=N4 B2=N2
XU13 XNR2HS $PINS O=final_s1[0] I1=raw_s1[0] I2=n10
XU14 MOAI1 $PINS O=fold_n[2] A1=n8 A2=N2 B1=N6 B2=N2
XU15 OA13S $PINS O=N2 A1=n_in[4] B1=n_in[1] B2=N4 B3=n13
XU16 MOAI1 $PINS O=fold_n[3] A1=n5 A2=N2 B1=N7 B2=N2
XU17 INV1S $PINS O=n8 I=n_in[2]
XU18 INV1S $PINS O=n5 I=n_in[3]
XU19 MOAI1 $PINS O=fold_n[4] A1=n6 A2=N2 B1=N8 B2=N2
XU20 INV1S $PINS O=n6 I=n_in[4]
XU23 ND3 $PINS O=n10 I1=N2 I2=n11 I3=k_idx[0]
XU24 ND3 $PINS O=n11 I1=k_idx[4] I2=k_idx[3] I3=n12
XU25 AN2 $PINS O=n12 I1=k_idx[2] I2=k_idx[1]
XU26 XOR2HS $PINS O=N8 I1=n6 I2=sub_79/carry[4]
XU27 XOR2HS $PINS O=N7 I1=n5 I2=sub_79/carry[3]
XU28 AN2 $PINS O=sub_79/carry[3] I1=sub_79/carry[2] I2=n8
XU29 XOR2HS $PINS O=N6 I1=n8 I2=sub_79/carry[2]
XU30 XOR2HS $PINS O=N5 I1=n7 I2=n9
XU31 OR2 $PINS O=n13 I1=n_in[3] I2=n_in[2]
Xrom_inst CSD_ROM_Table_even_0 $PINS n_idx[4]=fold_n[4] n_idx[3]=fold_n[3]
+ n_idx[2]=fold_n[2] n_idx[1]=fold_n[1] n_idx[0]=fold_n[0] k_idx[4]=k_idx[4]
+ k_idx[3]=k_idx[3] k_idx[2]=k_idx[2] k_idx[1]=k_idx[1] k_idx[0]=k_idx[0]
+ sign1[1]=raw_s1[1] sign1[0]=raw_s1[0] shift1[3]=raw_h1[3] shift1[2]=raw_h1[2]
+ shift1[1]=raw_h1[1] shift1[0]=raw_h1[0] sign2[1]=raw_s2[1] sign2[0]=raw_s2[0]
+ shift2[3]=raw_h2[3] shift2[2]=raw_h2[2] shift2[1]=raw_h2[1] shift2[0]=raw_h2[0]
+ sign3[1]=raw_s3[1] sign3[0]=raw_s3[0] shift3[3]=raw_h3[3] shift3[2]=raw_h3[2]
+ shift3[1]=raw_h3[1] shift3[0]=raw_h3[0]
Xclk_gate_reg_shift1_reg SNPS_CLOCK_GATE_HIGH_ROM_Wrapper_Even_0 $PINS EN=en
+ ENCLK=CTS_12 CLK=clk
.ENDS

.SUBCKT CSD_ROM_Table_odd_0 n_idx[4] n_idx[3] n_idx[2] n_idx[1] n_idx[0]
+ k_idx[4] k_idx[3] k_idx[2] k_idx[1] k_idx[0] sign1[1] sign1[0] shift1[3]
+ shift1[2] shift1[1] shift1[0] sign2[1] sign2[0] shift2[3] shift2[2] shift2[1]
+ shift2[0] sign3[1] sign3[0] shift3[3] shift3[2] shift3[1] shift3[0]
XFE_OFC236_n1650 BUF1 $PINS O=FE_OFN171_n1650 I=n95
XFE_OFC235_n1650 INV1S $PINS O=FE_OFN170_n1650 I=n95
XFE_OFC234_n1650 INV1S $PINS O=n95 I=n1650
XFE_OFC172_n1654 INV1S $PINS O=n72 I=n1654
XFE_OFC169_fold_n_1 INV1S $PINS O=n103 I=n_idx[1]
XFE_OFC41_fold_n_4 BUF1 $PINS O=FE_OFN41_fold_n_4 I=n_idx[4]
XU728 ND2 $PINS O=sign3[1] I1=n1717 I2=n1716
XU729 AO112 $PINS O=n1709 A1=n99 B1=n1707 C1=n1708 C2=n1
XU730 OA222 $PINS O=n1713 A1=n1704 A2=n1703 B1=n1702 B2=n1701 C1=n1700 C2=n1699
XU731 AN3B2S $PINS O=n1696 I1=n1694 B1=n122 B2=n126
XU732 OA222 $PINS O=n1714 A1=n1684 A2=n1683 B1=n1682 B2=n1681 C1=n1680 C2=n1679
XU733 OA222 $PINS O=n1715 A1=n1677 A2=n1676 B1=n1675 B2=n1674 C1=n1673 C2=n1672
XU736 ND2 $PINS O=n1686 I1=n1674 I2=n1636
XU737 ND2 $PINS O=n1605 I1=n1604 I2=n1618
XU738 ND2 $PINS O=n1601 I1=n1600 I2=n1599
XU739 ND2 $PINS O=n1602 I1=n1710 I2=n1598
XU740 ND2 $PINS O=n1596 I1=n1595 I2=n60
XU741 ND2 $PINS O=n1597 I1=n1594 I2=n1593
XU742 OA222 $PINS O=n1623 A1=n1591 A2=n1590 B1=n1589 B2=n1588 C1=n1587 C2=n1586
XU743 OA222 $PINS O=n1566 A1=n118 A2=n91 B1=n_idx[3] B2=n1565 C1=n104 C2=n92
XU744 OA112 $PINS O=n1559 A1=n1548 B1=n1547 C1=n1549 C2=n34
XU745 AO12 $PINS O=n1547 A1=n1545 B1=n1676 B2=n1546
XU747 OA222 $PINS O=n1520 A1=n1519 A2=n1674 B1=n1518 B2=n1586 C1=n1517 C2=n1590
XU748 AO12 $PINS O=n1502 A1=n1612 B1=n43 B2=n41
XU749 ND2 $PINS O=n1501 I1=n1499 I2=n1498
XU750 OA112 $PINS O=n1510 A1=n1489 B1=n1488 C1=n1676 C2=n29
XU751 AO12 $PINS O=n1484 A1=n1667 B1=n119 B2=n1480
XU752 ND2 $PINS O=n1472 I1=n104 I2=n19
XU753 OA222 $PINS O=n1459 A1=n1454 A2=n1598 B1=n1453 B2=n1688 C1=n1452 C2=n1590
XU754 OA222 $PINS O=n1460 A1=n1450 A2=n1647 B1=n1449 B2=n1636 C1=n1448 C2=n1586
XU755 OA222 $PINS O=n1465 A1=n1545 A2=n1439 B1=n1438 B2=n39 C1=n1437 C2=n30
XU756 OA112 $PINS O=n1421 A1=n1420 B1=n1419 C1=n1661 C2=n40
XU757 ND2 $PINS O=n1414 I1=n1428 I2=FE_OFN170_n1650
XU758 ND2 $PINS O=n1416 I1=n54 I2=n10
XU759 ND2 $PINS O=n1413 I1=n1638 I2=n12
XU760 AN3 $PINS O=n1576 I1=n1411 I2=n1410 I3=n1409
XU762 OA222 $PINS O=n1411 A1=n29 A2=n1492 B1=n11 B2=n54 C1=n1403 C2=n12
XU763 ND2 $PINS O=n1424 I1=n2 I2=n218
XU764 ND2 $PINS O=n1400 I1=n22 I2=n34
XU765 OA222 $PINS O=n1398 A1=n1552 A2=n1443 B1=n1392 B2=n41 C1=n87 C2=n1391
XU767 OA222 $PINS O=n1399 A1=FE_OFN170_n1650 A2=n44 B1=n1389 B2=n1581 C1=n46
+ C2=n1593
XU768 OA222 $PINS O=n1511 A1=n1683 A2=n34 B1=n1377 B2=n1376 C1=n1647 C2=n38
XU769 OA222 $PINS O=n1367 A1=n1693 A2=n85 B1=n1362 B2=n1590 C1=n1361 C2=n1360
XU770 OA222 $PINS O=n1368 A1=n1359 A2=n1586 B1=n1358 B2=n1588 C1=n1357 C2=n1636
XU771 OA222 $PINS O=n1387 A1=n35 A2=n1352 B1=n1351 B2=n36 C1=n1350 C2=n30
XU772 OA222 $PINS O=n1342 A1=n1339 A2=n1588 B1=n1338 B2=n1688 C1=n1337 C2=n1606
XU773 OA222 $PINS O=n1344 A1=n43 A2=n1615 B1=FE_OFN170_n1650 B2=n48 C1=n46
+ C2=n1616
XU774 OA222 $PINS O=n1345 A1=n1676 A2=n30 B1=n41 B2=n10 C1=n1335 C2=n39
XU775 OA222 $PINS O=n1346 A1=n1334 A2=n1545 B1=n1683 B2=n34 C1=n1660 C2=n33
XU776 OR3B2 $PINS O=n1326 I1=n1323 B1=n1322 B2=n1321
XU777 AO222 $PINS O=n1314 A1=n219 A2=n1500 B1=n1313 B2=n18 C1=n1631 C2=n1312
XU778 AO222 $PINS O=n1313 A1=n105 A2=n1310 B1=n114 B2=n1309 C1=n113 C2=n1308
XU780 AN3B2S $PINS O=n1305 I1=n1340 B1=n1304 B2=n53
XU781 OA222 $PINS O=n1316 A1=n1524 A2=n36 B1=n1303 B2=n43 C1=n58 C2=n39
XU782 OA222 $PINS O=n1317 A1=n1683 A2=n22 B1=n1660 B2=n30 C1=n27 C2=n1628
XU783 ND2 $PINS O=n1332 I1=n1293 I2=n1292
XU784 ND2 $PINS O=n1290 I1=n1594 I2=n1615
XU785 ND2 $PINS O=n1291 I1=n1584 I2=n97
XU786 OA112 $PINS O=n1300 A1=n1512 B1=n1395 C1=n12 C2=n1634
XU787 OA112 $PINS O=n1512 A1=n1286 B1=n1285 C1=n1377 C2=n1498
XU788 AN3B2S $PINS O=n1320 I1=n1283 B1=n1282 B2=n1281
XU789 AO222 $PINS O=n1267 A1=n114 A2=n1266 B1=n109 B2=n93 C1=n113 C2=n1265
XU791 OA222 $PINS O=n1268 A1=n1455 A2=n1360 B1=n1261 B2=n1636 C1=n1260 C2=n1590
XU793 OA222 $PINS O=n1273 A1=n1649 A2=n33 B1=n1255 B2=n1254 C1=n1253 C2=n12
XU794 OA222 $PINS O=n1274 A1=n1252 A2=n36 B1=n57 B2=n41 C1=n1251 C2=n39
XU795 OA112 $PINS O=n1277 A1=n1578 B1=n1247 C1=n40 C2=n1360
XU796 OA222 $PINS O=n1247 A1=n1545 A2=n1376 B1=n1246 B2=n1352 C1=n1330 C2=n1245
XU797 ND2 $PINS O=n1294 I1=n1244 I2=n1243
XU798 ND2 $PINS O=n1241 I1=n1628 I2=n1661
XU799 OA112 $PINS O=n1383 A1=n1328 B1=n1239 C1=n1697 C2=n29
XU801 ND2 $PINS O=n1284 I1=n1236 I2=n1235
XU802 OA222 $PINS O=n1235 A1=n1633 A2=n1628 B1=n1234 B2=n1403 C1=n1233 C2=n1492
XU803 OA222 $PINS O=n1236 A1=n22 A2=n1376 B1=n11 B2=n1443 C1=n1661 C2=n1626
XU806 ND2 $PINS O=n1221 I1=n41 I2=n1391
XU807 AN3B2S $PINS O=n1227 I1=n1219 B1=n1218 B2=n1324
XU808 OA112 $PINS O=n1215 A1=n1299 B1=n1214 C1=n1697 C2=n30
XU810 OA222 $PINS O=n1203 A1=n1234 A2=n1628 B1=n1403 B2=n1377 C1=n1340 C2=n39
XU811 OA112 $PINS O=n1174 A1=n1172 B1=n1171 C1=n1173 C2=n49
XU812 ND2 $PINS O=n1391 I1=n114 I2=n18
XU813 ND2 $PINS O=n1170 I1=n36 I2=n1552
XU814 ND2 $PINS O=n1552 I1=n113 I2=n18
XU815 OA112 $PINS O=n1322 A1=n1167 B1=n1166 C1=n1697 C2=n7
XU816 AN3 $PINS O=n1384 I1=n1164 I2=n1163 I3=n1162
XU817 OA112 $PINS O=n1162 A1=n42 B1=n1161 C1=n1289 C2=n1581
XU818 OA222 $PINS O=n1155 A1=FE_OFN41_fold_n_4 A2=n1152 B1=n1151 B2=n49
+ C1=n1377 C2=n1628
XU819 ND2 $PINS O=n1377 I1=n1702 I2=n1150
XU820 OA222 $PINS O=n1152 A1=n51 A2=n1588 B1=n1149 B2=n1606 C1=n1148 C2=n1688
XU821 OA222 $PINS O=n1156 A1=n1638 A2=n1498 B1=n1145 B2=n30 C1=n1144 C2=n36
XU823 ND2 $PINS O=n1336 I1=n1604 I2=n1615
XU824 AO222 $PINS O=n1143 A1=n1444 A2=n1495 B1=n1139 B2=n1388 C1=n1138 C2=n1415
XU825 AN3B2S $PINS O=n1160 I1=n1321 B1=n1134 B2=n1133
XU826 OR3B2 $PINS O=n1134 I1=n1281 B1=n1210 B2=n1132
XU827 OA112 $PINS O=n1125 A1=n1124 B1=n1123 C1=n1697 C2=n27
XU828 ND2 $PINS O=n1122 I1=n1615 I2=n1390
XU832 OA222 $PINS O=n1131 A1=n1212 A2=n27 B1=n1650 B2=n44 C1=n1246 C2=n1352
XU834 ND2 $PINS O=n1548 I1=n1248 I2=n131
XU835 ND2 $PINS O=n1106 I1=n1140 I2=n7
XU836 OA222 $PINS O=n1110 A1=n1447 A2=n47 B1=n1103 B2=n35 C1=n1354 C2=n45
XU837 ND2 $PINS O=n1101 I1=n125 I2=n1150
XU838 ND2 $PINS O=n1102 I1=n131 I2=n1100
XU839 OR3 $PINS O=n1310 I1=n1582 I2=n94 I3=n65
XU841 AO222 $PINS O=n1095 A1=n110 A2=n1092 B1=n111 B2=n1091 C1=n112 C2=n1090
XU842 AN3B2S $PINS O=n1256 I1=n1196 B1=n61 B2=n64
XU843 OA222 $PINS O=n1097 A1=n1196 A2=n1672 B1=n1089 B2=n1088 C1=n1087 C2=n1598
XU846 AO222 $PINS O=n1083 A1=n1084 A2=n1372 B1=n1081 B2=n1555 C1=n1080 C2=n1431
XU847 OR3 $PINS O=n1084 I1=n1080 I2=n1527 I3=n95
XU848 AN3B2S $PINS O=n1251 I1=n1136 B1=n1190 B2=n74
XU849 ND2 $PINS O=n1627 I1=n1140 I2=n27
XU850 OA222 $PINS O=n1231 A1=n27 A2=n1350 B1=n1334 B2=n12 C1=n1598 C2=n40
XU853 AO12 $PINS O=n1068 A1=n39 B1=n1302 B2=n1528
XU854 OA222 $PINS O=n1070 A1=n1545 A2=n1556 B1=n1062 B2=n1352
+ C1=FE_OFN41_fold_n_4 C2=n1061
XU855 OA222 $PINS O=n1061 A1=n1060 A2=n1588 B1=n1059 B2=n1606 C1=n1058 C2=n1688
XU856 ND2 $PINS O=n1500 I1=n22 I2=n7
XU857 OA222 $PINS O=n1071 A1=n1694 A2=n34 B1=n1057 B2=n44 C1=n1441 C2=n30
XU858 OA222 $PINS O=n1072 A1=n1056 A2=n48 B1=n52 B2=n49 C1=n1055 C2=n37
XU860 ND2 $PINS O=n1554 I1=n87 I2=n1615
XU861 AN3 $PINS O=n1132 I1=n1042 I2=n1041 I3=n1040
XU862 OA112 $PINS O=n1040 A1=n1232 B1=n1039 C1=n1661 C2=n27
XU863 ND2 $PINS O=n1220 I1=n29 I2=n30
XU864 ND2 $PINS O=n1199 I1=n1593 I2=n85
XU865 AN3 $PINS O=n1187 I1=n1038 I2=n1037 I3=n1036
XU866 OA222 $PINS O=n1034 A1=n1031 A2=n27 B1=n1030 B2=n47 C1=n1029 C2=n45
XU867 ND2 $PINS O=n1434 I1=n1334 I2=n1028
XU868 ND2 $PINS O=n1027 I1=n1427 I2=n7
XU869 OA222 $PINS O=n1121 A1=n11 A2=n54 B1=n44 B2=n97 C1=n1710 C2=n40
XU870 ND2 $PINS O=n1023 I1=n128 I2=n1242
XU871 ND2 $PINS O=n1690 I1=n1606 I2=n1360
XU872 ND2 $PINS O=n1001 I1=n1370 I2=n1600
XU873 ND2 $PINS O=n1002 I1=n1593 I2=n10
XU874 OR3 $PINS O=n1017 I1=n1208 I2=n1325 I3=n1000
XU875 OA112 $PINS O=n997 A1=n1578 B1=n1168 C1=n1683 C2=n27
XU876 OA13S $PINS O=n998 A1=n1172 B1=n1264 B2=FE_OFN41_fold_n_4 B3=n1688
XU877 ND2 $PINS O=n1352 I1=n996 I2=n1471
XU878 OA222 $PINS O=n1380 A1=n38 A2=n1590 B1=n1628 B2=n30 C1=n1639 C2=n22
XU879 ND2 $PINS O=n1639 I1=n990 I2=n989
XU881 OA222 $PINS O=n994 A1=n54 A2=n48 B1=n1451 B2=n43 C1=n49 C2=n1599
XU882 OA222 $PINS O=n995 A1=n1615 A2=n39 B1=n46 B2=n85 C1=n1497 C2=n41
XU883 OA222 $PINS O=n1020 A1=n1490 A2=n1498 B1=n1649 B2=n27 C1=n1633 C2=n1697
XU884 ND2 $PINS O=n1286 I1=n592 I2=n1248
XU885 ND2 $PINS O=n1710 I1=n1470 I2=n975
XU886 ND2 $PINS O=n1669 I1=n1594 I2=n1390
XU887 ND2 $PINS O=n1190 I1=n1528 I2=n87
XU889 ND2 $PINS O=n1598 I1=n971 I2=n1483
XU890 OA222 $PINS O=n980 A1=n970 A2=n44 B1=n969 B2=n45 C1=n46 C2=n1599
XU891 ND2 $PINS O=n1672 I1=n971 I2=n968
XU892 ND2 $PINS O=n1514 I1=n1529 I2=n1585
XU893 ND2 $PINS O=n1674 I1=n1470 I2=n968
XU894 OR3 $PINS O=n967 I1=n1592 I2=n83 I3=n1513
XU895 ND2 $PINS O=n1592 I1=n54 I2=n1593
XU898 ND2 $PINS O=n1360 I1=n988 I2=n1470
XU899 OR3B2 $PINS O=n961 I1=n1026 B1=n1550 B2=n960
XU900 ND2 $PINS O=n985 I1=n1655 I2=n959
XU901 ND2 $PINS O=n1026 I1=n1104 I2=n1487
XU902 ND2 $PINS O=n1487 I1=n1655 I2=n59
XU905 ND2 $PINS O=n1626 I1=n1481 I2=FE_OFN41_fold_n_4
XU907 ND2 $PINS O=n1000 I1=n958 I2=n957
XU908 ND2 $PINS O=n1245 I1=n1471 I2=n975
XU909 ND2 $PINS O=n1304 I1=n1425 I2=n10
XU914 ND2 $PINS O=n947 I1=n1136 I2=n1599
XU920 OA222 $PINS O=n955 A1=n943 A2=n1028 B1=n942 B2=n22 C1=n941 C2=n29
XU921 ND2 $PINS O=n1660 I1=n972 I2=n1471
XU922 ND2 $PINS O=n1634 I1=n940 I2=n1471
XU923 ND2 $PINS O=n1028 I1=n968 I2=n989
XU924 ND2 $PINS O=n1212 I1=n1483 I2=n1471
XU925 ND2 $PINS O=n1376 I1=n988 I2=n1471
XU927 ND2 $PINS O=n1699 I1=n971 I2=n975
XU930 ND2 $PINS O=n1403 I1=n996 I2=n989
XU934 ND2 $PINS O=n1687 I1=n996 I2=n1470
XU936 ND2 $PINS O=n933 I1=n1702 I2=n1100
XU937 AN3 $PINS O=n777 I1=n71 I2=n1678 I3=n1651
XU938 ND2 $PINS O=n1498 I1=n989 I2=n975
XU939 ND2 $PINS O=n1569 I1=k_idx[4] I2=k_idx[3]
XU941 ND2 $PINS O=n1076 I1=n1255 I2=n1550
XU945 OA222 $PINS O=n1211 A1=n36 A2=n87 B1=n37 B2=n1443 C1=n1647 C2=n38
XU949 ND2 $PINS O=n1586 I1=n990 I2=n971
XU950 ND2 $PINS O=n1689 I1=n988 I2=n971
XU951 ND2 $PINS O=n1479 I1=k_idx[4] I2=n20
XU952 ND2 $PINS O=n1350 I1=n990 I2=n1471
XU953 ND2 $PINS O=n1676 I1=n1471 I2=n968
XU3 AN4B1S $PINS O=n1257 I1=n1585 I2=n1181 I3=n1523 B1=n1515
XU4 OAI222S $PINS O=n5 A1=n43 A2=n1230 B1=n48 B2=n1229 C1=n1153 C2=n1661
XU5 ND2 $PINS O=n7 I1=n1702 I2=n1667
XU6 AN4B1S $PINS O=n1517 I1=n1264 I2=n1447 I3=n1536 B1=n1263
XU7 NR2P $PINS O=n16 I1=n35 I2=n1678
XU8 AN4B1S $PINS O=n1698 I1=n1660 I2=n1403 I3=n1652 B1=n131
XU9 INV1S $PINS O=n1 I=n_idx[3]
XU11 NR2P $PINS O=n1329 I1=n72 I2=FE_OFN41_fold_n_4
XU12 NR2 $PINS O=n2 I1=n35 I2=n1679
XU13 INV1S $PINS O=n80 I=n1540
XU14 INV1S $PINS O=n64 I=n1181
XU15 INV1S $PINS O=n74 I=n1648
XU16 INV1S $PINS O=n56 I=n1355
XU17 NR2 $PINS O=n1429 I1=n101 I2=n99
XU18 INV1S $PINS O=n81 I=n1497
XU19 INV1S $PINS O=n100 I=n1706
XU20 INV1S $PINS O=n62 I=n1581
XU22 ND2 $PINS O=n1593 I1=n1708 I2=n966
XU23 ND2 $PINS O=n1599 I1=n945 I2=n966
XU24 INV1S $PINS O=n102 I=n_idx[2]
XU25 ND2S $PINS O=n1065 I1=n1063 I2=n1580
XU26 ND2S $PINS O=n1582 I1=n1551 I2=n1600
XU27 ND3S $PINS O=n1250 I1=n1147 I2=n1355 I3=n1249
XU28 ND3S $PINS O=n1309 I1=n1363 I2=n1528 I3=n1306
XU29 OA222S $PINS O=n1315 A1=n44 A2=n87 B1=n1540 B2=n37 C1=n1305 C2=n48
XU30 ND2S $PINS O=n1436 I1=n1447 I2=n1705
XU31 ND3S $PINS O=n1105 I1=n1404 I2=n38 I3=n1104
XU32 ND3S $PINS O=n1393 I1=n1186 I2=n1185 I3=n1184
XU33 ND3S $PINS O=n1139 I1=n1354 I2=n1259 I3=n1355
XU34 ND3S $PINS O=n1046 I1=n97 I2=n1443 I3=n1429
XU35 OA22S $PINS O=n1506 A1=n11 A2=n1579 B1=n47 B2=n1497
XU36 ND3S $PINS O=n1445 I1=n1443 I2=n1497 I3=n97
XU37 ND2S $PINS O=n1064 I1=n1617 I2=n1497
XU38 OA112S $PINS O=n1128 A1=n1420 B1=n1121 C1=n12 C2=n1350
XU39 ND3S $PINS O=shift1[1] I1=n1020 I2=n1019 I3=n1018
XU40 ND3S $PINS O=shift3[3] I1=n1399 I2=n1398 I3=n1397
XU41 OA222S $PINS O=n1269 A1=n1258 A2=n1688 B1=n1257 B2=n1586 C1=n1256 C2=n1647
XU42 ND3S $PINS O=n1371 I1=n1528 I2=n1648 I3=n1370
XU43 ND3S $PINS O=n1266 I1=n1705 I2=n1593 I3=n1262
XU44 ND3S $PINS O=n1430 I1=n1429 I2=n1618 I3=n1428
XU45 ND3S $PINS O=n1516 I1=n1523 I2=n1706 I3=n1054
XU46 OA222S $PINS O=n1410 A1=n1404 A2=n1661 B1=n85 B2=n44 C1=n1705 C2=n43
XU47 ND3S $PINS O=n1198 I1=n1580 I2=n1585 I3=n1454
XU48 OA222S $PINS O=n1299 A1=n41 A2=n1706 B1=n46 B2=n54 C1=n1245 C2=n12
XU49 MAOI1S $PINS O=n1558 A1=n127 A2=n1553 B1=n1552 B2=n1551
XU50 OA222S $PINS O=n1157 A1=n37 A2=n1706 B1=n1546 B2=n22 C1=n1551 C2=n39
XU51 ND3S $PINS O=n1049 I1=n1593 I2=n1390 I3=n1355
XU52 OA22S $PINS O=n991 A1=n48 A2=n1057 B1=n43 B2=n1497
XU53 ND3S $PINS O=n1603 I1=n54 I2=n1706 I3=n1447
XU54 MAOI1S $PINS O=n1171 A1=n81 A2=n1170 B1=n1391 B2=n1169
XU55 ND2S $PINS O=n946 I1=n1497 I2=n1616
XU56 OA22S $PINS O=n1007 A1=n1524 A2=n1687 B1=n1497 B2=n1636
XU57 OA22S $PINS O=n1202 A1=n1391 A2=n54 B1=n1706 B2=n1552
XU58 ND2S $PINS O=n1543 I1=n1581 I2=n1390
XU59 ND3S $PINS O=n1308 I1=n1355 I2=n1600 I3=n1307
XU60 ND3S $PINS O=n1312 I1=n1706 I2=n1497 I3=n1311
XU61 ND2S $PINS O=n1681 I1=n_idx[1] I2=n944
XU62 ND2 $PINS O=n1650 I1=n1480 I2=n1656
XU63 ND2S $PINS O=n1678 I1=n966 I2=n103
XU64 ND2S $PINS O=n1679 I1=n944 I2=n103
XU65 ND2S $PINS O=n1615 I1=n945 I2=n944
XU66 ND2S $PINS O=n1651 I1=n966 I2=n_idx[1]
XU67 ND2S $PINS O=n1524 I1=n945 I2=n1480
XU68 ND3S $PINS O=n1333 I1=n1379 I2=n1328 I3=n1327
XU69 AN3S $PINS O=n1351 I1=n1612 I2=n72 I3=n1361
XU70 NR2 $PINS O=n3 I1=n35 I2=n75
XU71 ND3S $PINS O=n1537 I1=n10 I2=n72 I3=n1536
XU72 OR3S $PINS O=n6 I1=n1238 I2=n1284 I3=n1237
XU73 AN3S $PINS O=n1104 I1=n1626 I2=n40 I3=n1153
XU74 OR2S $PINS O=n1577 I1=n40 I2=n1710
XU75 ND3S $PINS O=shift3[2] I1=n1387 I2=n1386 I3=n1385
XU76 OA222S $PINS O=n1185 A1=n1492 A2=n12 B1=n10 B2=n39 C1=n40 C2=n1606
XU77 OA22S $PINS O=n1488 A1=n1487 A2=n1661 B1=n40 B2=n1699
XU78 OA222S $PINS O=n1321 A1=n1212 A2=n12 B1=n1115 B2=n37 C1=n40 C2=n1689
XU79 ND2S $PINS O=n1443 I1=n1656 I2=n1567
XU80 ND2S $PINS O=n1497 I1=n945 I2=n1567
XU81 ND2S $PINS O=n1390 I1=n1708 I2=n1567
XU82 ND3S $PINS O=n1525 I1=n1524 I2=n72 I3=n1705
XU83 OA222S $PINS O=n1666 A1=n1650 A2=n1687 B1=n1649 B2=n75 C1=n1648 C2=n1647
XU84 ND2S $PINS O=n1153 I1=n1655 I2=n1670
XU85 OA222S $PINS O=n1665 A1=n1653 A2=n91 B1=n1652 B2=n76 C1=n1694 C2=n1651
XU86 NR2 $PINS O=n989 I1=n630 I2=k_idx[0]
XU87 NR2 $PINS O=n1246 I1=n31 I2=n24
XU88 INV1S $PINS O=n24 I=n1140
XU89 NR2 $PINS O=n1551 I1=n56 I2=n88
XU90 NR2 $PINS O=n1580 I1=n74 I2=n93
XU91 NR2 $PINS O=n1259 I1=n66 I2=n80
XU92 INV1S $PINS O=n34 I=n3
XU93 INV1S $PINS O=n82 I=n1523
XU94 INV1S $PINS O=n31 I=n1255
XU95 NR2 $PINS O=n1063 I1=n69 I2=n56
XU96 NR2 $PINS O=n1140 I1=n25 I2=n3
XU97 INV1S $PINS O=n30 I=n1248
XU98 NR2 $PINS O=n1260 I1=n93 I2=n61
XU99 NR2 $PINS O=n1340 I1=n98 I2=n80
XU100 AN2 $PINS O=n1258 I1=n1364 I2=n1617
XU101 INV1S $PINS O=n98 I=n1429
XU102 NR2 $PINS O=n1359 I1=n1514 I2=n82
XU103 INV1S $PINS O=n66 I=n1447
XU104 INV1S $PINS O=n65 I=n1147
XU105 INV1S $PINS O=n88 I=n1705
XU106 INV1S $PINS O=n63 I=n1528
XU107 NR2 $PINS O=n1361 I1=n63 I2=n78
XU108 INV1S $PINS O=n26 I=n1486
XU109 NR2 $PINS O=n1540 I1=n81 I2=n84
XU110 NR2 $PINS O=n1262 I1=n1250 I2=n81
XU111 AN2 $PINS O=n1261 I1=n1311 I2=n1259
XU112 INV1S $PINS O=n51 I=n1446
XU113 INV1S $PINS O=n55 I=n1618
XU114 NR2 $PINS O=n1523 I1=n93 I2=n84
XU115 INV1S $PINS O=n93 I=n1115
XU116 INV1S $PINS O=n73 I=n1189
XU117 NR2 $PINS O=n1255 I1=n32 I2=n1435
XU118 INV1S $PINS O=n32 I=n1545
XU119 INV1S $PINS O=n94 I=n1536
XU120 INV1S $PINS O=n61 I=n1370
XU121 INV1S $PINS O=n25 I=n1404
XU122 INV1S $PINS O=n22 I=n1491
XU123 NR2 $PINS O=n1428 I1=n66 I2=n84
XU124 INV1S $PINS O=n83 I=n1600
XU125 INV1S $PINS O=n126 I=n1653
XU126 INV1S $PINS O=n69 I=n1617
XU127 NR2 $PINS O=n1248 I1=n35 I2=n89
XU128 NR2 $PINS O=n1354 I1=n86 I2=n98
XU129 INV1S $PINS O=n68 I=n1363
XU130 AN2 $PINS O=n1330 I1=n1427 I2=n1633
XU131 INV1S $PINS O=n77 I=n1454
XU132 INV1S $PINS O=n23 I=n1427
XU133 INV1S $PINS O=n122 I=n1334
XU134 INV1S $PINS O=n120 I=n1652
XU135 INV1S $PINS O=n42 I=n1119
XU136 ND3 $PINS O=n1504 I1=n1503 I2=n42 I3=n1502
XU137 INV1S $PINS O=n79 I=n1604
XU138 INV1S $PINS O=n28 I=n1550
XU139 ND3 $PINS O=n1282 I1=n1327 I2=n1280 I3=n1279
XU140 INV1S $PINS O=n124 I=n1440
XU141 INV1S $PINS O=n129 I=n1649
XU142 OAI112HS $PINS O=n1108 A1=n1548 B1=n42 C1=n1255 C2=n1107
XU143 NR2 $PINS O=n1107 I1=n120 I2=n122
XU144 OAI112HS $PINS O=n1238 A1=n1232 B1=n1231 C1=n11 C2=n1497
XU145 INV1S $PINS O=n75 I=n1670
XU146 NR3 $PINS O=n1328 I1=n4 I2=n5 I3=n6
XU147 OAI222S $PINS O=n4 A1=n1529 A2=n44 B1=n47 B2=n1390 C1=n1536 C2=n45
XU148 INV1S $PINS O=n40 I=n1329
XU149 NR2 $PINS O=n1355 I1=n1527 I2=n62
XU150 NR3 $PINS O=n1364 I1=n96 I2=n81 I3=n1310
XU151 ND3 $PINS O=shift2[3] I1=n1278 I2=n1277 I3=n1276
XU152 AN4B1S $PINS O=n1278 I1=n1383 I2=n1396 I3=n1283 B1=n1294
XU153 AN4B1S $PINS O=n1276 I1=n1275 I2=n1274 I3=n1273 B1=n1272
XU154 NR2 $PINS O=n1528 I1=n64 I2=n100
XU155 AOI22S $PINS O=n1098 A1=n108 A2=n1085 B1=n114 B2=n1084
XU156 ND3 $PINS O=n1085 I1=n1600 I2=n54 I3=n1351
XU157 NR2 $PINS O=n1181 I1=n98 I2=n67
XU158 ND3 $PINS O=shift2[0] I1=n1160 I2=n1159 I3=n1158
XU159 NR2 $PINS O=n1159 I1=n1143 I2=n1142
XU160 AN4B1S $PINS O=n1158 I1=n1157 I2=n1156 I3=n1155 B1=n1154
XU161 AN4B1S $PINS O=n957 I1=n956 I2=n955 I3=n954 B1=n953
XU162 NR3 $PINS O=n958 I1=n939 I2=n938 I3=n937
XU163 OA22 $PINS O=n956 A1=n33 A2=n977 B1=n30 B2=n1145
XU164 ND3 $PINS O=n939 I1=n1219 I2=n1185 I3=n936
XU165 AOI22S $PINS O=n936 A1=n1435 A2=n369 B1=n105 B2=n1329
XU166 ND3 $PINS O=shift3[1] I1=n1349 I2=n1348 I3=n1347
XU167 AN4B1S $PINS O=n1347 I1=n1346 I2=n1345 I3=n1344 B1=n1343
XU168 NR3 $PINS O=n1349 I1=n1326 I2=n1325 I3=n1324
XU169 NR3 $PINS O=n1348 I1=n1333 I2=n1332 I3=n1331
XU170 AOI22S $PINS O=n1035 A1=n317 A2=n1027 B1=n107 B2=n1026
XU171 NR2 $PINS O=n1037 I1=n1025 I2=n1024
XU172 AN4B1S $PINS O=n1038 I1=n1401 I2=n1023 I3=n1022 B1=n1240
XU173 AN4B1S $PINS O=n1036 I1=n1035 I2=n1034 I3=n1033 B1=n1032
XU174 ND3 $PINS O=shift2[1] I1=n1207 I2=n1206 I3=n1205
XU175 AN4B1S $PINS O=n1205 I1=n1204 I2=n1203 I3=n1202 B1=n1201
XU176 NR2 $PINS O=n1206 I1=n1194 I2=n1193
XU177 AN4B1S $PINS O=n1207 I1=n1188 I2=n1187 I3=n1209 B1=n1393
XU178 ND3 $PINS O=shift1[2] I1=n1075 I2=n1074 I3=n1073
XU179 NR3 $PINS O=n1074 I1=n1053 I2=n1052 I3=n1051
XU180 AN4B1S $PINS O=n1073 I1=n1072 I2=n1071 I3=n1070 B1=n1069
XU181 AN4B1S $PINS O=n1075 I1=n1187 I2=n1045 I3=n1132 B1=n1044
XU182 NR2P $PINS O=n1447 I1=n78 I2=n67
XU183 NR2 $PINS O=n1147 I1=n66 I2=n1654
XU184 INV1S $PINS O=n78 I=n1443
XU185 NR2 $PINS O=n1264 I1=n56 I2=n100
XU186 ND3 $PINS O=n1091 I1=n1257 I2=n85 I3=n1086
XU187 NR2 $PINS O=n1086 I1=n81 I2=n78
XU188 NR3 $PINS O=n1089 I1=n1091 I2=n1654 I3=n100
XU189 AN4B1S $PINS O=n1467 I1=n1466 I2=n1465 I3=n1464 B1=n1463
XU190 OA22 $PINS O=n1464 A1=n29 A2=n1441 B1=n12 B2=n1440
XU191 AOI22S $PINS O=n1466 A1=n1544 A2=n1436 B1=n1435 B2=n1434
XU192 NR2P $PINS O=n1705 I1=n1515 I2=n100
XU193 INV1S $PINS O=n89 I=n1658
XU194 ND3 $PINS O=shift1[0] I1=n984 I2=n983 I3=n982
XU195 AN4B1S $PINS O=n982 I1=n981 I2=n980 I3=n979 B1=n978
XU196 NR2 $PINS O=n983 I1=n963 I2=n962
XU197 AN4B1S $PINS O=n984 I1=n1022 I2=n1211 I3=n1078 B1=n1000
XU198 NR2 $PINS O=n1648 I1=n80 I2=n1654
XU199 NR2 $PINS O=n1618 I1=n56 I2=n96
XU200 AN4B1S $PINS O=n1622 I1=n1611 I2=n1610 I3=n1609 B1=n1608
XU201 AOI22S $PINS O=n1609 A1=n70 A2=n1602 B1=n115 B2=n1601
XU202 AOI22S $PINS O=n1610 A1=n106 A2=n1597 B1=n116 B2=n1596
XU203 AOI22S $PINS O=n1611 A1=n108 A2=n1592 B1=n96 B2=n1690
XU204 ND3 $PINS O=n1446 I1=n1230 I2=n1147 I3=n1146
XU205 NR2 $PINS O=n1146 I1=n99 I2=n53
XU206 AN4B1S $PINS O=n1059 I1=n1522 I2=n1551 I3=n1497 B1=n70
XU207 INV1S $PINS O=n53 I=n1356
XU208 AN4B1S $PINS O=n1060 I1=n1057 I2=n1551 I3=n1390 B1=n78
XU209 ND3 $PINS O=n1486 I1=n1423 I2=n1422 I3=n1421
XU210 MAOI1 $PINS O=n1423 A1=n370 A2=n1413 B1=n1490 B2=n1412
XU211 AOI22S $PINS O=n1422 A1=n1417 A2=n1416 B1=n1415 B2=n1414
XU212 AOI12HS $PINS O=n1396 A1=n1240 B1=n16 B2=n369
XU213 AOI22S $PINS O=n1401 A1=n131 A2=n1418 B1=n1329 B2=n117
XU214 AN2 $PINS O=n1489 I1=n1402 I2=n1401
XU215 AOI22S $PINS O=n1402 A1=n317 A2=n1400 B1=n1544 B2=n79
XU216 INV1S $PINS O=n84 I=n1390
XU217 INV1S $PINS O=n54 I=n1527
XU218 NR2 $PINS O=n1438 I1=n95 I2=n1582
XU219 ND3 $PINS O=n1444 I1=n1356 I2=n1579 I3=n1135
XU220 NR2 $PINS O=n1135 I1=n83 I2=n56
XU221 AOI22S $PINS O=n1109 A1=n125 A2=n1106 B1=n107 B2=n1105
XU222 INV1S $PINS O=n57 I=n1250
XU223 AN4B1S $PINS O=n1252 I1=n1249 I2=n1361 I3=n72 B1=n62
XU224 AOI22S $PINS O=n1186 A1=n618 A2=n23 B1=n1248 B2=n619
XU225 NR2 $PINS O=n1184 I1=n1183 I2=n1182
XU226 MOAI1S $PINS O=n1182 A1=n1181 A2=n37 B1=n67 B2=n1631
XU227 INV1S $PINS O=n38 I=n1637
XU228 NR3 $PINS O=n1531 I1=n1526 I2=n78 I3=n70
XU229 NR2 $PINS O=n1302 I1=n74 I2=n1527
XU230 ND3 $PINS O=n1526 I1=n1579 I2=n1302 I3=n1301
XU231 NR2 $PINS O=n1301 I1=n100 I2=n96
XU232 NR3 $PINS O=n1311 I1=n53 I2=n93 I3=n1592
XU233 ND3 $PINS O=shift2[2] I1=n1228 I2=n1227 I3=n1226
XU234 AN4B1S $PINS O=n1226 I1=n1225 I2=n1224 I3=n1223 B1=n1222
XU235 AN4B1S $PINS O=n1228 I1=n1211 I2=n1210 I3=n1209 B1=n1208
XU236 NR2 $PINS O=n1633 I1=n16 I2=n3
XU237 NR2 $PINS O=n1362 I1=n1515 I2=n1527
XU238 NR2 $PINS O=n1425 I1=n88 I2=n1527
XU239 NR2 $PINS O=n1234 I1=n2 I2=n3
XU240 AN4B1S $PINS O=n1530 I1=n1529 I2=n1671 I3=n1528 B1=n73
XU241 NR2 $PINS O=n1455 I1=n66 I2=n62
XU242 NR2 $PINS O=n1115 I1=n95 I2=n1442
XU243 NR2 $PINS O=n1189 I1=n1654 I2=n95
XU244 OA12 $PINS O=n1043 A1=n1280 B1=n38 B2=n1674
XU245 NR2 $PINS O=n1545 I1=n16 I2=n1248
XU246 NR2 $PINS O=n1600 I1=n1442 I2=n84
XU247 NR2 $PINS O=n1136 I1=n96 I2=n1442
XU248 AOI22S $PINS O=n1395 A1=n115 A2=n1329 B1=n93 B2=n1495
XU249 INV1S $PINS O=n44 I=n1287
XU250 AOI22S $PINS O=n1039 A1=n100 A2=n1544 B1=n592 B2=n31
XU251 AOI22S $PINS O=n1042 A1=n1417 A2=n80 B1=n1527 B2=n1287
XU252 AOI22S $PINS O=n1041 A1=n1496 A2=n1199 B1=n121 B2=n1220
XU253 AN4B1S $PINS O=n1382 I1=n1380 I2=n1379 I3=n1511 B1=n1378
XU254 AOI22S $PINS O=n1124 A1=n619 A2=n1242 B1=n107 B2=n1491
XU255 INV1S $PINS O=n97 I=n1513
XU256 NR2 $PINS O=n1536 I1=n101 I2=FE_OFN171_n1650
XU257 AOI22S $PINS O=n1123 A1=n1513 A2=n1496 B1=n1287 B2=n98
XU258 NR3 $PINS O=n1307 I1=n98 I2=n1654 I3=n53
XU259 NR2 $PINS O=n1370 I1=n1515 I2=n62
XU260 NR2 $PINS O=n1491 I1=n35 I2=n71
XU261 NR2 $PINS O=n1404 I1=n1242 I2=n1491
XU262 NR2 $PINS O=n1196 I1=n93 I2=n1513
XU263 INV1S $PINS O=n87 I=n1515
XU264 NR2 $PINS O=n1249 I1=n83 I2=n70
XU265 AOI22S $PINS O=n1210 A1=n106 A2=n1329 B1=n95 B2=n1372
XU266 INV1S $PINS O=n27 I=n2
XU267 NR2 $PINS O=n1594 I1=n1527 I2=n78
XU268 OAI22S $PINS O=n1052 A1=n1048 A2=n43 B1=n1047 B2=n46
XU269 NR3 $PINS O=n1047 I1=n1046 I2=n82 I3=n61
XU270 AN4B1S $PINS O=n1048 I1=n1618 I2=n10 I3=n1147 B1=n1554
XU271 NR2 $PINS O=n1653 I1=n221 I2=n127
XU272 NR2 $PINS O=n1030 I1=n62 I2=n1442
XU273 AN2 $PINS O=n1029 I1=n60 I2=n1306
XU274 NR2 $PINS O=n1031 I1=n126 I2=n1434
XU275 OAI112HS $PINS O=n978 A1=n976 B1=n1286 C1=n977 C2=n22
XU276 OAI12HS $PINS O=n976 A1=n1544 B1=n1190 B2=n1669
XU277 NR2 $PINS O=n1617 I1=n99 I2=n70
XU278 NR2 $PINS O=n1451 I1=n69 I2=n100
XU279 NR2 $PINS O=n1522 I1=n101 I2=n78
XU280 NR2 $PINS O=n1230 I1=n1527 I2=n84
XU281 MOAI1S $PINS O=n987 A1=n1653 A2=n29 B1=n1329 B2=n1685
XU282 AOI22S $PINS O=n1180 A1=n95 A2=n113 B1=n105 B2=n69
XU283 INV1S $PINS O=n35 I=n1702
XU284 ND3 $PINS O=n1138 I1=n1137 I2=n1522 I3=n1136
XU285 NR3 $PINS O=n1137 I1=n88 I2=n62 I3=n68
XU286 AOI22S $PINS O=n1165 A1=n1372 A2=n56 B1=n1442 B2=n1544
XU287 AOI22S $PINS O=n1219 A1=n1637 A2=n113 B1=n1372 B2=n78
XU288 NR3 $PINS O=n1337 I1=n1336 I2=n101 I3=n1603
XU289 ND3 $PINS O=n1069 I1=n1068 I2=n1067 I3=n1066
XU290 ND3 $PINS O=n1067 I1=n1702 I2=n1100 I3=n618
XU291 AOI22S $PINS O=n1066 A1=n1431 A2=n1065 B1=n1544 B2=n1064
XU292 NR2 $PINS O=n1233 I1=n1418 I2=n1435
XU293 AOI22S $PINS O=n979 A1=n1417 A2=n974 B1=n1388 B2=n973
XU294 ND3 $PINS O=n973 I1=n1612 I2=n1443 I3=n1307
XU295 ND3 $PINS O=n974 I1=n1264 I2=n1447 I3=n1353
XU296 INV1S $PINS O=n86 I=n1529
XU297 NR2 $PINS O=n1584 I1=n1515 I2=n99
XU298 NR2 $PINS O=n1363 I1=n80 I2=n70
XU299 NR2 $PINS O=n1087 I1=n1527 I2=n68
XU300 AN4B1S $PINS O=n1339 I1=n85 I2=n1579 I3=n1425 B1=n83
XU301 AOI22S $PINS O=n1188 A1=n123 A2=n1491 B1=n111 B2=n1329
XU302 INV1S $PINS O=n47 I=n1417
XU303 INV1S $PINS O=n1435 I=n7
XU304 MOAI1S $PINS O=n953 A1=n27 A2=n1499 B1=n1431 B2=n1603
XU305 MOAI1S $PINS O=n1082 A1=n1262 A2=n11 B1=n370 B2=n1627
XU306 AOI22S $PINS O=n1232 A1=n369 A2=n1242 B1=n317 B2=n16
XU307 AOI22S $PINS O=n1280 A1=n130 A2=n1242 B1=n127 B2=n16
XU308 INV1S $PINS O=n60 I=n1288
XU309 NR3 $PINS O=n1546 I1=n619 I2=n130 I3=n122
XU310 AOI22S $PINS O=n1420 A1=n1418 A2=n619 B1=n127 B2=n1491
XU311 OAI22S $PINS O=n1120 A1=n1117 A2=n29 B1=n1116 B2=n36
XU312 NR2 $PINS O=n1117 I1=n221 I2=n129
XU313 NR2 $PINS O=n1116 I1=n79 I2=n77
XU314 NR2 $PINS O=n1454 I1=n100 I2=n78
XU315 NR2 $PINS O=n1604 I1=n81 I2=n1442
XU316 NR2 $PINS O=n1289 I1=n1544 I2=n1287
XU317 AOI22S $PINS O=n1033 A1=n1287 A2=n94 B1=n127 B2=n25
XU318 INV1S $PINS O=n39 I=n1372
XU319 NR2 $PINS O=n1427 I1=n1418 I2=n1491
XU320 AOI22S $PINS O=n1168 A1=n1418 A2=n592 B1=n3 B2=n128
XU321 NR2 $PINS O=n1595 I1=n99 I2=n1513
XU322 NR2 $PINS O=n1613 I1=n96 I2=n101
XU323 NR2 $PINS O=n1490 I1=n1242 I2=n1435
XU324 NR2 $PINS O=n977 I1=n369 I2=n370
XU325 NR2 $PINS O=n1253 I1=n126 I2=n317
XU326 NR2 $PINS O=n1254 I1=n619 I2=n592
XU327 INV1S $PINS O=n21 I=n1284
XU328 NR2 $PINS O=n1550 I1=n1418 I2=n2
XU329 NR2 $PINS O=n1452 I1=n100 I2=n94
XU330 AOI22S $PINS O=n1578 A1=n130 A2=n1435 B1=n127 B2=n3
XU331 INV1S $PINS O=n43 I=n1415
XU332 NR2 $PINS O=n1334 I1=n123 I2=n128
XU333 NR2 $PINS O=n1169 I1=n96 I2=n95
XU334 ND3 $PINS O=n1381 I1=n1298 I2=n1297 I3=n1296
XU335 AOI22S $PINS O=n1298 A1=n1288 A2=n1287 B1=n3 B2=n131
XU336 OA22 $PINS O=n1297 A1=n10 A2=n1289 B1=n30 B2=n1441
XU337 NR3 $PINS O=n1296 I1=n1295 I2=n1294 I3=n1332
XU338 AOI22S $PINS O=n1379 A1=n1435 A2=n592 B1=n131 B2=n23
XU339 MOAI1S $PINS O=n937 A1=n41 A2=n10 B1=n317 B2=n3
XU340 AOI22S $PINS O=n1022 A1=n121 A2=n1435 B1=n3 B2=n123
XU341 NR2 $PINS O=n1652 I1=n121 I2=n592
XU342 AOI22S $PINS O=n1161 A1=n70 A2=n1417 B1=n99 B2=n1496
XU343 INV1S $PINS O=n33 I=n16
XU344 AOI22S $PINS O=n1045 A1=n219 A2=n1491 B1=n221 B2=n1248
XU345 NR2 $PINS O=n1437 I1=n130 I2=n1695
XU346 OR2 $PINS O=n1503 I1=n1153 I2=n1661
XU347 NR2 $PINS O=n1119 I1=n985 I2=n1661
XU348 INV1S $PINS O=n107 I=n1661
XU349 INV1S $PINS O=n48 I=n1388
XU350 AOI22S $PINS O=n1521 A1=n116 A2=n62 B1=n112 B2=n80
XU351 NR2 $PINS O=n1579 I1=n99 I2=n67
XU352 AOI22S $PINS O=n1275 A1=n1248 A2=n122 B1=n370 B2=n24
XU353 INV1S $PINS O=n29 I=n1418
XU354 NR2 $PINS O=n1694 I1=n125 I2=n370
XU355 INV1S $PINS O=n108 I=n1360
XU356 AOI22S $PINS O=n992 A1=n128 A2=n16 B1=n2 B2=n107
XU357 AOI22S $PINS O=n1327 A1=n1637 A2=n111 B1=n16 B2=n125
XU358 AOI22S $PINS O=n1560 A1=n1544 A2=n1543 B1=n23 B2=n129
XU359 AOI12HS $PINS O=n1118 A1=n37 B1=n1529 B2=n1144
XU360 NR2 $PINS O=n1144 I1=n1527 I2=n67
XU361 OAI12HS $PINS O=n1406 A1=n16 B1=n123 B2=n618
XU362 AOI22S $PINS O=n1507 A1=n1496 A2=n86 B1=n1495 B2=n95
XU363 AOI22S $PINS O=n1279 A1=n16 A2=n123 B1=n3 B2=n221
XU364 NR2 $PINS O=n1638 I1=n2 I2=n16
XU365 NR2 $PINS O=n1692 I1=n1686 I2=n1685
XU366 INV1S $PINS O=n45 I=n1496
XU367 NR2 $PINS O=n1412 I1=n317 I2=n218
XU368 NR2 $PINS O=n1441 I1=n128 I2=n369
XU369 NR2 $PINS O=n1556 I1=n123 I2=n619
XU370 INV1S $PINS O=n41 I=n1555
XU371 AOI22S $PINS O=n1176 A1=n1288 A2=n1287 B1=n218 B2=n28
XU372 NR2 $PINS O=n1612 I1=n81 I2=n62
XU373 NR2 $PINS O=n1306 I1=FE_OFN171_n1650 I2=n62
XU374 AOI22S $PINS O=n1167 A1=n1496 A2=n1442 B1=n67 B2=n1417
XU375 NR2 $PINS O=n1700 I1=n94 I2=n96
XU376 OA22 $PINS O=n1175 A1=n27 A2=n1694 B1=n37 B2=n85
XU377 NR2 $PINS O=n1440 I1=n125 I2=n618
XU378 AOI22S $PINS O=n1419 A1=n1418 A2=n124 B1=n1435 B2=n131
XU379 INV1S $PINS O=n36 I=n1431
XU380 AOI22S $PINS O=n1394 A1=n370 A2=n25 B1=n592 B2=n32
XU381 NR2 $PINS O=n1229 I1=n101 I2=n100
XU382 AOI22S $PINS O=n1643 A1=n123 A2=n3 B1=n221 B2=n16
XU383 NR2 $PINS O=n1649 I1=n130 I2=n219
XU384 MOAI1S $PINS O=n1557 A1=n12 A2=n1556 B1=n1555 B2=n1554
XU385 OAI112HS $PINS O=n1201 A1=n1286 B1=n1548 C1=n1200 C2=n49
XU386 NR2 $PINS O=n1200 I1=n84 I2=n1199
XU387 INV1S $PINS O=n49 I=n1631
XU388 NR2 $PINS O=n1353 I1=n79 I2=n99
XU389 AOI22S $PINS O=n1664 A1=n106 A2=n1654 B1=n127 B2=n1658
XU390 AOI22S $PINS O=n1006 A1=n114 A2=n67 B1=n1515 B2=n108
XU391 AOI22S $PINS O=n981 A1=n1415 A2=n965 B1=n1555 B2=n69
XU392 ND3 $PINS O=n965 I1=n1169 I2=n1370 I3=n964
XU393 NR2 $PINS O=n964 I1=n80 I2=n69
XU394 NR2 $PINS O=n1499 I1=n125 I2=n131
XU395 INV1S $PINS O=n109 I=n1674
XU396 INV1S $PINS O=n37 I=n1213
XU397 ND3 $PINS O=n1154 I1=n1503 I2=n1172 I3=n1407
XU398 INV1S $PINS O=n46 I=n1495
XU399 NR2 $PINS O=n1693 I1=n116 I2=n112
XU400 AOI22S $PINS O=n1642 A1=n2 A2=n124 B1=n1631 B2=n93
XU401 AOI22S $PINS O=n1224 A1=n369 A2=n1248 B1=n16 B2=n221
XU402 AOI22S $PINS O=n1225 A1=n130 A2=n1220 B1=n1515 B2=n1631
XU403 MOAI1S $PINS O=n1375 A1=n1353 A2=n41 B1=n83 B2=n1388
XU404 NR3 $PINS O=n1389 I1=n1388 I2=n1415 I3=n1495
XU405 NR2 $PINS O=n1145 I1=n125 I2=n127
XU406 NR2 $PINS O=n1088 I1=n113 I2=n106
XU407 NR2 $PINS O=n1439 I1=n125 I2=n219
XU408 AOI22S $PINS O=n1223 A1=n84 A2=n1388 B1=n101 B2=n1415
XU409 AOI22S $PINS O=n1283 A1=n127 A2=n1418 B1=n130 B2=n2
XU410 OA12 $PINS O=n986 A1=n107 B1=n1242 B2=n1418
XU411 NR2 $PINS O=n1392 I1=n67 I2=n1543
XU412 NR2P $PINS O=n1654 I1=n75 I2=n620
XU413 NR2 $PINS O=n1670 I1=n76 I2=n103
XU414 INV1S $PINS O=n76 I=n1567
XU415 AOI22S $PINS O=n1239 A1=n221 A2=n28 B1=n128 B2=n1491
XU416 NR2 $PINS O=n1386 I1=n1375 I2=n1374
XU417 AN4B1S $PINS O=n1385 I1=n1384 I2=n1383 I3=n1382 B1=n1381
XU418 NR2 $PINS O=n1527 I1=n620 I2=n1681
XU419 MOAI1S $PINS O=n1272 A1=FE_OFN41_fold_n_4 A2=n1271 B1=n23 B2=n618
XU420 AN4B1S $PINS O=n1271 I1=n1270 I2=n1269 I3=n1268 B1=n1267
XU421 AOI22S $PINS O=n1270 A1=n1263 A2=n116 B1=n81 B2=n117
XU422 INV1S $PINS O=n101 I=n1593
XU423 ND3 $PINS O=n1080 I1=n1581 I2=n1443 I3=n1079
XU424 AN2 $PINS O=n1079 I1=n1615 I2=n1251
XU425 ND3 $PINS O=shift1[3] I1=n1114 I2=n1113 I3=n1112
XU426 AN4B1S $PINS O=n1114 I1=n1078 I2=n1168 I3=n1231 B1=n1378
XU427 NR2 $PINS O=n1113 I1=n1083 I2=n1082
XU428 AN4B1S $PINS O=n1112 I1=n1111 I2=n1110 I3=n1109 B1=n1108
XU429 OAI22S $PINS O=n1094 A1=n1258 A2=n1688 B1=n1093 B2=n1674
XU430 AN4B1S $PINS O=n1093 I1=n1196 I2=n1354 I3=n1581 B1=n1288
XU431 ND3 $PINS O=n1281 I1=n1131 I2=n1130 I3=n1129
XU432 NR3 $PINS O=n1130 I1=n1120 I2=n1119 I3=n1118
XU433 AN4B1S $PINS O=n1129 I1=n1214 I2=n1128 I3=n1167 B1=n1237
XU434 NR2 $PINS O=n1562 I1=n1542 I2=n1541
XU435 MOAI1S $PINS O=n1541 A1=n1540 A2=n36 B1=n317 B2=n16
XU436 OAI222S $PINS O=n1542 A1=FE_OFN41_fold_n_4 A2=n1539 B1=n1698 B2=n27
+ C1=n1538 C2=n39
XU437 NR3 $PINS O=n1538 I1=n1537 I2=n55 I3=n77
XU438 NR2 $PINS O=n1585 I1=n56 I2=n1583
XU439 NR3 $PINS O=n1539 I1=n1535 I2=n1534 I3=n1533
XU440 OAI222S $PINS O=n1534 A1=n1523 A2=n1588 B1=n1693 B2=n10 C1=n1522 C2=n1647
XU441 OAI222S $PINS O=n1533 A1=n1532 A2=n1688 B1=n1531 B2=n1606 C1=n1530
+ C2=n1636
XU442 OAI112HS $PINS O=n1535 A1=n1521 B1=n1520 C1=n1598 C2=n1581
XU443 NR3 $PINS O=n1518 I1=n1516 I2=n1515 I3=n65
XU444 NR3 $PINS O=n1519 I1=n1514 I2=n1513 I3=n94
XU445 ND3 $PINS O=n1081 I1=n1262 I2=n1706 I3=n1599
XU446 INV1S $PINS O=n110 I=n1590
XU447 ND3 $PINS O=n1090 I1=n1356 I2=n54 I3=n1256
XU448 ND3 $PINS O=n1092 I1=n1229 I2=n1616 I3=n1359
XU449 NR3 $PINS O=n1019 I1=n987 I2=n1119 I3=n986
XU450 NR3 $PINS O=n1018 I1=n1017 I2=n1016 I3=n1015
XU451 INV1S $PINS O=n99 I=n1599
XU452 ND3 $PINS O=shift3[0] I1=n1320 I2=n1319 I3=n1318
XU453 AN4B1S $PINS O=n1319 I1=n21 I2=n1300 I3=n1299 B1=n1381
XU454 AN4B1S $PINS O=n1318 I1=n1317 I2=n1316 I3=n1315 B1=n1314
XU455 NR2 $PINS O=n1645 I1=n1630 I2=n1629
XU456 MOAI1S $PINS O=n1629 A1=n22 A2=n1628 B1=n370 B2=n1627
XU457 OAI22S $PINS O=n1630 A1=n1661 A2=n1626 B1=FE_OFN41_fold_n_4 B2=n1625
XU458 AN4B1S $PINS O=n1625 I1=n1624 I2=n1623 I3=n1622 B1=n1621
XU459 AN4B1S $PINS O=n1591 I1=n1581 I2=n1616 I3=n1580 B1=n86
XU460 AN4B1S $PINS O=n1587 I1=n1585 I2=n1584 I3=n1604 B1=n78
XU461 NR3 $PINS O=n1589 I1=n98 I2=n1583 I3=n1582
XU462 OAI112HS $PINS O=n1240 A1=n1121 B1=n1021 C1=n1639 C2=n27
XU463 AOI22S $PINS O=n1021 A1=n78 A2=n1417 B1=n1515 B2=n1496
XU464 MOAI1S $PINS O=n1463 A1=FE_OFN41_fold_n_4 A2=n1462 B1=n25 B2=n221
XU465 AN4B1S $PINS O=n1462 I1=n1461 I2=n1460 I3=n1459 B1=n1458
XU466 AOI22S $PINS O=n1461 A1=n1442 A2=n108 B1=FE_OFN171_n1650 B2=n109
XU467 NR3 $PINS O=n1450 I1=n1445 I2=n73 I3=n1444
XU468 NR3 $PINS O=n1449 I1=n1446 I2=n81 I3=n100
XU469 AN4B1S $PINS O=n1448 I1=n1447 I2=n1648 I3=n1585 B1=n94
XU470 NR2 $PINS O=n1658 I1=n92 I2=n103
XU471 NR2P $PINS O=n1515 I1=n89 I2=n620
XU472 OAI22S $PINS O=n1366 A1=n1365 A2=n1606 B1=n1688 B2=n1364
XU473 AN4B1S $PINS O=n1365 I1=n1700 I2=n1363 I3=n1455 B1=n100
XU474 MOAI1S $PINS O=n1374 A1=FE_OFN41_fold_n_4 A2=n1373 B1=n1372 B2=n1371
XU475 AN4B1S $PINS O=n1373 I1=n1369 I2=n1368 I3=n1367 B1=n1366
XU476 AOI22S $PINS O=n1369 A1=n67 A2=n112 B1=n81 B2=n117
XU477 AN4B1S $PINS O=n1357 I1=n1522 I2=n1356 I3=n1355 B1=n82
XU478 AN4B1S $PINS O=n1358 I1=n1354 I2=n1648 I3=n1355 B1=n1442
XU479 MOAI1S $PINS O=n1608 A1=n1607 A2=n1606 B1=n105 B2=n1605
XU480 NR2 $PINS O=n1607 I1=n81 I2=n1603
XU481 MOAI1S $PINS O=n962 A1=n1212 A2=n12 B1=n107 B2=n961
XU482 OA12 $PINS O=n960 A1=n985 B1=FE_OFN41_fold_n_4 B2=n1599
XU483 NR3 $PINS O=n1062 I1=n1500 I2=n3 I3=n1248
XU484 AN4B1S $PINS O=n1058 I1=n1593 I2=n1259 I3=n1136 B1=n1515
XU485 NR2 $PINS O=n1356 I1=n1583 I2=n1263
XU486 NR2 $PINS O=n1054 I1=n53 I2=n1592
XU487 ND3 $PINS O=n1575 I1=n1510 I2=n1509 I3=n1508
XU488 NR2 $PINS O=n1509 I1=n1494 I2=n1493
XU489 AN4B1S $PINS O=n1508 I1=n1507 I2=n1506 I3=n1505 B1=n1504
XU490 AN4B1S $PINS O=n1397 I1=n1396 I2=n1395 I3=n1394 B1=n1393
XU491 AN4B1S $PINS O=n1148 I1=n1551 I2=n1604 I3=n1524 B1=n66
XU492 NR2 $PINS O=n1151 I1=n56 I2=n77
XU493 AN4B1S $PINS O=n1149 I1=FE_OFN170_n1650 I2=n1429 I3=n1705 B1=n1336
XU494 OAI22S $PINS O=n1621 A1=n1620 A2=n1687 B1=n1619 B2=n1689
XU495 AN4B1S $PINS O=n1620 I1=n1616 I2=n72 I3=n1615 B1=n1614
XU496 AN4B1S $PINS O=n1619 I1=n1618 I2=n72 I3=n1617 B1=n93
XU497 ND3 $PINS O=n1614 I1=n1613 I2=n1705 I3=n1612
XU498 AN4B1S $PINS O=n970 I1=n87 I2=n71 I3=n50 B1=n967
XU499 AN4B1S $PINS O=n969 I1=n60 I2=n10 I3=n97 B1=n1514
XU500 MOAI1S $PINS O=n949 A1=n948 A2=n1636 B1=n1304 B2=n111
XU501 NR2 $PINS O=n948 I1=n66 I2=n61
XU502 OA22 $PINS O=n954 A1=FE_OFN41_fold_n_4 A2=n952 B1=n1633 B2=n1245
XU503 AN4B1S $PINS O=n952 I1=n951 I2=n1180 I3=n950 B1=n949
XU504 AOI22S $PINS O=n951 A1=n67 A2=n112 B1=n105 B2=FE_OFN171_n1650
XU505 AOI22S $PINS O=n950 A1=n114 A2=n947 B1=n113 B2=n946
XU506 ND3 $PINS O=n1265 I1=n1584 I2=n1600 I3=n1517
XU507 NR2 $PINS O=n1637 I1=n50 I2=FE_OFN41_fold_n_4
XU508 INV1S $PINS O=n50 I=n1583
XU509 NR2 $PINS O=n1214 I1=n8 I2=n9
XU510 OAI222S $PINS O=n8 A1=n1697 A2=n12 B1=n1661 B2=n38 C1=n22 C2=n1403
XU511 OAI222S $PINS O=n9 A1=n7 A2=n1634 B1=n1492 B2=n30 C1=n34 C2=n1376
XU512 ND3 $PINS O=n1324 I1=n1217 I2=n1216 I3=n1215
XU513 AOI22S $PINS O=n1216 A1=n100 A2=n1213 B1=n1388 B2=n67
XU514 AOI22S $PINS O=n1217 A1=n1442 A2=n1415 B1=n1431 B2=n1527
XU515 ND3 $PINS O=n1208 I1=n995 I2=n994 I3=n993
XU516 AN4B1S $PINS O=n993 I1=n992 I2=n1380 I3=n1045 B1=n1323
XU517 OAI22S $PINS O=n1458 A1=n1457 A2=n1588 B1=n1456 B2=n1606
XU518 AN4B1S $PINS O=n1456 I1=n1455 I2=n1648 I3=FE_OFN170_n1650 B1=n88
XU519 AN4B1S $PINS O=n1457 I1=n1594 I2=n1580 I3=n1584 B1=n1583
XU520 NR3 $PINS O=n1209 I1=n1179 I2=n1178 I3=n1177
XU521 ND3 $PINS O=n1178 I1=n1322 I2=n1168 I3=n1279
XU522 ND3 $PINS O=n1177 I1=n1176 I2=n1175 I3=n1174
XU523 OAI112HS $PINS O=n1179 A1=n1384 B1=n1165 C1=n40 C2=n1588
XU524 AN4B1S $PINS O=n1335 I1=n1618 I2=n87 I3=n1429 B1=n68
XU525 INV1S $PINS O=n67 I=n1616
XU526 OR2 $PINS O=n10 I1=n1651 I2=n620
XU527 INV1S $PINS O=n1442 I=n10
XU528 OAI112HS $PINS O=n1323 A1=n1043 B1=n991 C1=n11 C2=n1599
XU529 OR2 $PINS O=n11 I1=n1710 I2=FE_OFN41_fold_n_4
XU530 INV1S $PINS O=n1544 I=n11
XU531 AN4B1S $PINS O=n1716 I1=n1715 I2=n1714 I3=n1713 B1=n1712
XU532 AN4B1S $PINS O=n1717 I1=n1666 I2=n1665 I3=n1664 B1=n1663
XU533 MOAI1S $PINS O=n1712 A1=n1711 A2=n1710 B1=n117 B2=n1709
XU534 NR3 $PINS O=n1532 I1=n1525 I2=n79 I3=n69
XU535 INV1S $PINS O=n96 I=n1524
XU536 NR2 $PINS O=n1287 I1=n1674 I2=FE_OFN41_fold_n_4
XU537 OAI112HS $PINS O=n1325 A1=n998 B1=n997 C1=n999 C2=n1352
XU538 NR2 $PINS O=n999 I1=n16 I2=n1242
XU539 ND3 $PINS O=n1237 I1=n1127 I2=n1126 I3=n1125
XU540 OA22 $PINS O=n1127 A1=n1403 A2=n1233 B1=n54 B2=n47
XU541 MAOI1 $PINS O=n1126 A1=n1544 A2=n1122 B1=n1492 B2=n1234
XU542 INV1S $PINS O=n619 I=n1639
XU543 NR2 $PINS O=n1513 I1=n1678 I2=n620
XU544 MOAI1S $PINS O=n1015 A1=FE_OFN41_fold_n_4 A2=n1014 B1=n116 B2=n1637
XU545 AN4B1S $PINS O=n1014 I1=n1013 I2=n1012 I3=n1011 B1=n1010
XU546 AOI22S $PINS O=n1013 A1=n113 A2=n1002 B1=n109 B2=n1001
XU547 AN4B1S $PINS O=n1011 I1=n1007 I2=n1521 I3=n1006 B1=n1005
XU548 NR2 $PINS O=n1012 I1=n1004 I2=n1003
XU549 MOAI1S $PINS O=n1003 A1=n1595 A2=n1672 B1=n1690 B2=FE_OFN171_n1650
XU550 OAI22S $PINS O=n1004 A1=n1613 A2=n1699 B1=n1063 B2=n1598
XU551 AN4B1S $PINS O=n1303 I1=n1594 I2=n1524 I3=n1528 B1=n68
XU552 INV1S $PINS O=n58 I=n1526
XU553 OR2 $PINS O=n12 I1=n35 I2=n1681
XU554 INV1S $PINS O=n1242 I=n12
XU555 ND3 $PINS O=n1553 I1=n12 I2=n30 I3=n1550
XU556 INV1S $PINS O=n71 I=n959
XU557 NR2 $PINS O=n1529 I1=n1515 I2=n1263
XU558 OAI22S $PINS O=n1010 A1=n1009 A2=n1710 B1=n1008 B2=n1390
XU559 NR2 $PINS O=n1008 I1=n111 I2=n1690
XU560 AN2 $PINS O=n1009 I1=n1593 I2=n1455
XU561 AN4B1S $PINS O=n1056 I1=n1115 I2=n1599 I3=n1612 B1=n1436
XU562 INV1S $PINS O=n52 I=n1516
XU563 AN4B1S $PINS O=n1055 I1=n1189 I2=n1581 I3=n1528 B1=n53
XU564 OAI222S $PINS O=n1194 A1=n1192 A2=n41 B1=n1191 B2=n43 C1=FE_OFN170_n1650
+ C2=n36
XU565 AN4B1S $PINS O=n1192 I1=n1447 I2=n87 I3=n1302 B1=n69
XU566 NR3 $PINS O=n1191 I1=n1190 I2=n55 I3=n73
XU567 MOAI1S $PINS O=n1432 A1=n34 A2=n1628 B1=n1431 B2=n1430
XU568 INV1S $PINS O=n221 I=n1498
XU570 INV1S $PINS O=n70 I=n1615
XU571 AN2 $PINS O=n1453 I1=n1616 I2=n1451
XU572 MOAI1S $PINS O=n1378 A1=n1077 A2=n1212 B1=n1076 B2=n130
XU573 NR2 $PINS O=n1077 I1=n1418 I2=n1627
XU574 NR2 $PINS O=n1702 I1=n620 I2=FE_OFN41_fold_n_4
XU575 AN4B1S $PINS O=n1704 I1=n1693 I2=n1692 I3=n1691 B1=n1690
XU576 AN4B1S $PINS O=n1701 I1=n1698 I2=n1697 I3=n1696 B1=n1695
XU577 AN4B1S $PINS O=n1691 I1=n1689 I2=n1688 I3=n1687 B1=n115
XU578 MOAI1S $PINS O=n1331 A1=n1330 A2=n1498 B1=n1329 B2=n108
XU579 OAI222S $PINS O=n1343 A1=n1579 A2=n36 B1=FE_OFN41_fold_n_4 B2=n1342
+ C1=n1341 C2=n49
XU580 AN4B1S $PINS O=n1341 I1=n1340 I2=n1454 I3=n1581 B1=n53
XU581 NR2 $PINS O=n1338 I1=n78 I2=n1515
XU582 NR2 $PINS O=n1418 I1=n35 I2=n1651
XU583 AOI22S $PINS O=n1204 A1=n1388 A2=n1198 B1=n1495 B2=n1197
XU584 ND3 $PINS O=n1197 I1=n1196 I2=n1354 I3=n1195
XU585 NR2 $PINS O=n1195 I1=n1583 I2=n78
XU586 OAI222S $PINS O=n1025 A1=n11 A2=n1390 B1=n1490 B2=n1245 C1=n34 C2=n1403
XU587 OAI222S $PINS O=n1433 A1=n1427 A2=n1683 B1=n1550 B2=n1661 C1=n1426 C2=n41
XU588 AN4B1S $PINS O=n1426 I1=n1600 I2=n1616 I3=n1425 B1=n73
XU589 AN4B1S $PINS O=n1409 I1=n1408 I2=n1407 I3=n1406 B1=n1405
XU590 NR2 $PINS O=n1671 I1=n1583 I2=n1527
XU591 OAI222S $PINS O=n1142 A1=n1141 A2=n41 B1=n1633 B2=n1634 C1=n1140 C2=n1683
XU592 NR3 $PINS O=n1141 I1=n1336 I2=n62 I3=n63
XU593 NR2 $PINS O=n1417 I1=n1598 I2=FE_OFN41_fold_n_4
XU594 INV1S $PINS O=n91 I=n1667
XU595 MOAI1S $PINS O=n1051 A1=n1050 A2=n41 B1=n28 B2=n369
XU596 NR3 $PINS O=n1050 I1=n1049 I2=n65 I3=n1554
XU597 INV1S $PINS O=n369 I=n1403
XU598 NR2 $PINS O=n1288 I1=n620 I2=n1679
XU599 NR2 $PINS O=n1549 I1=n128 I2=n619
XU600 NR2 $PINS O=n942 I1=n128 I2=n130
XU601 NR2 $PINS O=n943 I1=n2 I2=n1242
XU602 NR2 $PINS O=n941 I1=n370 I2=n122
XU603 AOI22S $PINS O=n1164 A1=n1418 A2=n122 B1=n2 B2=n131
XU604 AOI22S $PINS O=n1163 A1=n619 A2=n3 B1=n618 B2=n1435
XU605 NR2 $PINS O=n1372 I1=n1687 I2=FE_OFN41_fold_n_4
XU606 OA22 $PINS O=n1078 A1=n934 A2=n1697 B1=n1498 B2=n933
XU607 NR2 $PINS O=n934 I1=n1242 I2=n1076
XU608 OAI222S $PINS O=n1405 A1=n1440 A2=n7 B1=n1499 B2=n22 C1=n47 C2=n1616
XU609 OR2 $PINS O=n1172 I1=n1376 I2=n1490
XU610 AOI22S $PINS O=n1505 A1=n3 A2=n1501 B1=n619 B2=n1500
XU611 MOAI1S $PINS O=n1494 A1=n1490 A2=n1697 B1=n23 B2=n218
XU612 INV1S $PINS O=n85 I=n1263
XU613 OAI222S $PINS O=n938 A1=n1490 A2=n1350 B1=n1370 B2=n39 C1=n1550 C2=n1676
XU614 OAI112HS $PINS O=n1044 A1=n1124 B1=n1043 C1=n1683 C2=n12
XU615 NR2 $PINS O=n1415 I1=n1360 I2=FE_OFN41_fold_n_4
XU616 INV1S $PINS O=n128 I=n1634
XU617 OA22 $PINS O=n1641 A1=n1635 A2=n1634 B1=n1633 B2=n1632
XU618 NR2 $PINS O=n1632 I1=n369 I2=n218
XU619 NR2 $PINS O=n1635 I1=n16 I2=n25
XU620 OAI22S $PINS O=n1005 A1=n1536 A2=n1689 B1=n1522 B2=n1590
XU621 NR2 $PINS O=n1173 I1=n62 I2=n100
XU622 ND3 $PINS O=n1150 I1=n1679 I2=n89 I3=n1678
XU623 OR2 $PINS O=n1407 I1=n1377 I2=n1245
XU624 AOI22S $PINS O=n1243 A1=n1242 A2=n1241 B1=n67 B2=n1544
XU625 AOI22S $PINS O=n1244 A1=n123 A2=n1435 B1=n121 B2=n32
XU626 NR2 $PINS O=n1496 I1=n1672 I2=FE_OFN41_fold_n_4
XU627 INV1S $PINS O=n111 I=n1586
XU628 AOI22S $PINS O=n1293 A1=n1435 A2=n619 B1=n16 B2=n131
XU629 AOI22S $PINS O=n1292 A1=n1495 A2=n1291 B1=n1555 B2=n1290
XU630 INV1S $PINS O=n592 I=n1028
XU631 AOI22S $PINS O=n1285 A1=n1431 A2=n98 B1=n1555 B2=n67
XU632 NR2 $PINS O=n1677 I1=n1668 I2=n1667
XU633 AN2 $PINS O=n1673 I1=n76 I2=n1671
XU634 NR2 $PINS O=n1675 I1=n1670 I2=n1669
XU635 ND3 $PINS O=n1695 I1=n1628 I2=n1639 I3=n1412
XU636 ND2 $PINS O=n1661 I1=n1470 I2=n1483
XU637 AN4B1S $PINS O=n1103 I1=n1102 I2=n1403 I3=n1101 B1=n1695
XU638 NR2 $PINS O=n1388 I1=n1590 I2=FE_OFN41_fold_n_4
XU639 ND2 $PINS O=n1590 I1=n972 I2=n1470
XU640 NR2 $PINS O=n1057 I1=n99 I2=n1263
XU641 MOAI1S $PINS O=n1640 A1=n1639 A2=n1638 B1=n1637 B2=n1686
XU642 OAI222S $PINS O=n1032 A1=n1694 A2=n1427 B1=n1233 B2=n1639 C1=n1649 C2=n29
XU643 ND3 $PINS O=n1100 I1=n932 I2=n1681 I3=n777
XU644 NR2 $PINS O=n932 I1=n1670 I2=n59
XU645 INV1S $PINS O=n123 I=n1350
XU646 INV1S $PINS O=n370 I=n1683
XU647 OAI22S $PINS O=n1183 A1=FE_OFN41_fold_n_4 A2=n1180 B1=n1249 B2=n36
XU648 OA22 $PINS O=n1624 A1=n1674 A2=n1584 B1=n1647 B2=n1579
XU649 INV1S $PINS O=n105 I=n1688
XU650 AOI22S $PINS O=n1166 A1=n1213 A2=n81 B1=n1431 B2=n96
XU651 INV1S $PINS O=n317 I=n1492
XU652 NR2 $PINS O=n1555 I1=n1699 I2=FE_OFN41_fold_n_4
XU653 INV1S $PINS O=n130 I=n1660
XU654 INV1S $PINS O=n618 I=n1628
XU655 NR2 $PINS O=n1431 I1=n1689 I2=FE_OFN41_fold_n_4
XU656 INV1S $PINS O=n59 I=n1679
XU657 INV1S $PINS O=n117 I=n1598
XU658 INV1S $PINS O=n113 I=n1588
XU659 MOAI1S $PINS O=n1493 A1=n1492 A2=n27 B1=n1491 B2=n369
XU660 MOAI1S $PINS O=n1024 A1=n1660 A2=n1545 B1=n16 B2=n125
XU661 MOAI1S $PINS O=n1222 A1=n22 A2=n1253 B1=n99 B2=n1221
XU662 MOAI1S $PINS O=n1193 A1=n1634 A2=n1545 B1=n106 B2=n1637
XU663 AN2 $PINS O=n1684 I1=n1678 I2=n92
XU664 NR2 $PINS O=n1680 I1=n128 I2=n120
XU665 NR2 $PINS O=n1682 I1=n221 I2=n592
XU666 INV1S $PINS O=n127 I=n1212
XU667 NR2 $PINS O=n1631 I1=n1636 I2=FE_OFN41_fold_n_4
XU668 INV1S $PINS O=n219 I=n1697
XU669 MOAI1S $PINS O=n1295 A1=n1639 A2=n33 B1=n317 B2=n1491
XU670 INV1S $PINS O=n121 I=n1676
XU671 INV1S $PINS O=n114 I=n1606
XU672 INV1S $PINS O=n112 I=n1647
XU673 INV1S $PINS O=n106 I=n1636
XU674 INV1S $PINS O=n131 I=n1245
XU675 OAI222S $PINS O=n1053 A1=n1492 A2=n27 B1=n7 B2=n1634 C1=n1245 C2=n22
XU676 INV1S $PINS O=n116 I=n1672
XU677 NR2 $PINS O=n1213 I1=n1586 I2=FE_OFN41_fold_n_4
XU678 INV1S $PINS O=n125 I=n1376
XU679 INV1S $PINS O=n218 I=n1352
XU680 NR2 $PINS O=n1495 I1=n1647 I2=FE_OFN41_fold_n_4
XU681 INV1S $PINS O=n115 I=n1699
XU682 MOAI1S $PINS O=n1133 A1=n1660 A2=n1545 B1=n1418 B2=n123
XU683 OAI222S $PINS O=n963 A1=n1245 A2=n7 B1=n1492 B2=n30 C1=n1660 C2=n33
XU684 MOAI1S $PINS O=n1016 A1=n1352 A2=n1550 B1=n121 B2=n16
XU685 MOAI1S $PINS O=n1218 A1=n1212 A2=n27 B1=n121 B2=n1418
XU686 ND3 $PINS O=n1685 I1=n1586 I2=n1590 I3=n1588
XU687 NR2 $PINS O=n1703 I1=FE_OFN41_fold_n_4 I2=n1481
XU688 AOI22S $PINS O=n1476 A1=n1708 A2=n1483 B1=n107 B2=n103
XU689 INV1S $PINS O=n90 I=n1481
XU690 INV1S $PINS O=n104 I=n1470
XU691 NR2 $PINS O=n1567 I1=n102 I2=n1
XU692 NR2 $PINS O=n1708 I1=n_idx[1] I2=n_idx[0]
XU693 AOI22S $PINS O=n1111 A1=n1099 A2=n18 B1=n23 B2=n122
XU694 ND3 $PINS O=n1099 I1=n1098 I2=n1097 I3=n1096
XU695 NR2 $PINS O=n1096 I1=n1095 I2=n1094
XU696 NR2 $PINS O=n945 I1=n103 I2=n_idx[0]
XU697 NR2 $PINS O=n1656 I1=n620 I2=n_idx[1]
XU698 INV1S $PINS O=n620 I=n_idx[0]
XU699 INV1S $PINS O=n92 I=n1480
XU700 NR2 $PINS O=n1583 I1=n1681 I2=n_idx[0]
XU701 ND2 $PINS O=n1581 I1=n1708 I2=n944
XU702 NR2 $PINS O=n1263 I1=n89 I2=n_idx[0]
XU703 ND2 $PINS O=n1706 I1=n1656 I2=n966
XU704 ND2 $PINS O=n1616 I1=n1656 I2=n944
XU705 NR2 $PINS O=n1470 I1=n118 I2=n630
XU706 OAI222S $PINS O=n1663 A1=n1662 A2=n1661 B1=n71 B2=n1660 C1=n1678 C2=n1697
XU707 AN4B1S $PINS O=n1662 I1=n29 I2=n40 I3=n1659 B1=n1658
XU708 AOI22S $PINS O=n1659 A1=n1657 A2=n1 B1=FE_OFN41_fold_n_4 B2=n92
XU709 OR2 $PINS O=n1657 I1=n1656 I2=n1655
XU710 NR2 $PINS O=n959 I1=n76 I2=n_idx[1]
XU711 NR2 $PINS O=n1667 I1=n92 I2=n_idx[1]
XU712 NR2 $PINS O=n1481 I1=n91 I2=n_idx[0]
XU713 ND2 $PINS O=n1683 I1=n1483 I2=n989
XU714 ND2 $PINS O=n1492 I1=n940 I2=n989
XU716 ND2 $PINS O=n1688 I1=n1470 I2=n940
XU717 ND2 $PINS O=n1628 I1=n988 I2=n989
XU718 OAI112HS $PINS O=n1408 A1=n18 B1=n105 C1=n95 C2=n1515
XU719 ND2 $PINS O=n1588 I1=n971 I2=n940
XU720 ND2 $PINS O=n1697 I1=n972 I2=n989
XU721 ND2 $PINS O=n1636 I1=n990 I2=n1470
XU722 ND2 $PINS O=n1606 I1=n996 I2=n971
XU723 ND2 $PINS O=n1647 I1=n972 I2=n971
XU724 OAI12HS $PINS O=sign2[1] A1=n1572 B1=n1574 B2=n1573
XU725 AOI22S $PINS O=n1574 A1=n1571 A2=n740 B1=n1570 B2=n1569
XU726 NR2 $PINS O=n1571 I1=FE_OFN41_fold_n_4 I2=n1566
XU727 MOAI1S $PINS O=n1570 A1=k_idx[2] A2=n1568 B1=n630 B2=n1654
XU734 NR2 $PINS O=n1483 I1=n19 I2=n1569
XU735 NR2 $PINS O=n1655 I1=FE_OFN41_fold_n_4 I2=n_idx[0]
XU746 AN4B1S $PINS O=n1711 I1=n92 I2=n18 I3=n1705 B1=n101
XU761 NR2 $PINS O=n975 I1=n1569 I2=k_idx[2]
XU766 AN2 $PINS O=n968 I1=n741 I2=n20
XU779 AOI12HS $PINS O=n1473 A1=n1670 B1=n1471 B2=n1668
XU790 ND3 $PINS O=n1707 I1=n92 I2=n18 I3=n1706
XU792 NR2 $PINS O=n996 I1=n1479 I2=k_idx[2]
XU800 NR2 $PINS O=n988 I1=n1479 I2=n19
XU804 AN2 $PINS O=n972 I1=n935 I2=n20
XU805 NR2 $PINS O=n1668 I1=n103 I2=n1
XU809 AOI13HS $PINS O=n1568 A1=n1567 B1=n_idx[0] B2=n630 B3=n1668
XU822 INV1S $PINS O=n119 I=n1471
XU829 INV1S $PINS O=n740 I=n1569
XU830 NR2 $PINS O=n944 I1=n1 I2=n_idx[2]
XU833 ND3 $PINS O=sign2[0] I1=n1563 I2=n1562 I3=n1561
XU840 AN4B1S $PINS O=n1561 I1=n1560 I2=n1559 I3=n1558 B1=n1557
XU844 AN4B1S $PINS O=n1563 I1=n26 I2=n1512 I3=n1511 B1=n1575
XU845 NR2 $PINS O=n966 I1=n102 I2=n_idx[3]
XU851 ND3 $PINS O=sign3[0] I1=n1646 I2=n1645 I3=n1644
XU852 AN4B1S $PINS O=n1644 I1=n1643 I2=n1642 I3=n1641 B1=n1640
XU859 AN4B1S $PINS O=n1646 I1=n1578 I2=n1577 I3=n1576 B1=n1575
XU880 ND3 $PINS O=sign1[0] I1=n1469 I2=n1468 I3=n1467
XU888 NR2 $PINS O=n1468 I1=n1433 I2=n1432
XU896 AN4B1S $PINS O=n1469 I1=n1489 I2=n1424 I3=n1576 B1=n1486
XU897 NR2 $PINS O=n1480 I1=n_idx[3] I2=n_idx[2]
XU903 INV1S $PINS O=n630 I=k_idx[1]
XU904 INV1S $PINS O=n18 I=FE_OFN41_fold_n_4
XU906 NR2 $PINS O=n971 I1=n118 I2=k_idx[1]
XU910 INV1S $PINS O=n118 I=k_idx[0]
XU911 NR2 $PINS O=n1471 I1=k_idx[1] I2=k_idx[0]
XU912 OAI12HS $PINS O=sign1[1] A1=n1572 B1=n1485 B2=n1573
XU913 AOI22S $PINS O=n1485 A1=n1478 A2=n1569 B1=n1477 B2=n18
XU915 OAI112HS $PINS O=n1477 A1=n1475 B1=n90 C1=n_idx[3] C2=n1476
XU916 OAI222S $PINS O=n1478 A1=k_idx[2] A2=n1473 B1=n76 B2=n1472 C1=n119 C2=n75
XU917 NR2 $PINS O=n741 I1=k_idx[4] I2=k_idx[2]
XU918 INV1S $PINS O=n19 I=k_idx[2]
XU919 AN2 $PINS O=n940 I1=n935 I2=k_idx[3]
XU926 NR2 $PINS O=n935 I1=n19 I2=k_idx[4]
XU928 AOI13HS $PINS O=n1482 A1=n18 B1=k_idx[2] B2=k_idx[1] B3=n1481
XU929 NR2 $PINS O=n1572 I1=n13 I2=n14
XU931 OAI22S $PINS O=n13 A1=k_idx[0] A2=n_idx[0] B1=n1703 B2=n740
XU932 AO13S $PINS O=n14 A1=n1482 B1=n1484 B2=n18 B3=n1483
XU933 INV1S $PINS O=n20 I=k_idx[3]
XU935 AN2 $PINS O=n990 I1=n741 I2=k_idx[3]
XU940 AOI22S $PINS O=n1565 A1=k_idx[2] A2=n1564 B1=n1708 B2=k_idx[1]
XU942 MOAI1S $PINS O=n1564 A1=n_idx[1] A2=n118 B1=n620 B2=k_idx[1]
XU943 ND3S $PINS O=n1475 I1=k_idx[1] I2=n1474 I3=n740
XU944 MOAI1S $PINS O=n1474 A1=n118 A2=n91 B1=n620 B2=n1480
XU946 OAI12HS $PINS O=n1573 A1=n1479 B1=k_idx[4] B2=n20
.ENDS

.SUBCKT SNPS_CLOCK_GATE_HIGH_ROM_Wrapper_Odd_0 EN ENCLK CLK
*.CONNECT net2320 EN
XFE_PHC832_net2323 DELC $PINS O=FE_PHN832_net2323 I=net2323
Xlatch QDBHN $PINS Q=net2323 D=net2320 CKB=CLK
Xmain_gate AN2T $PINS O=ENCLK I1=FE_PHN832_net2323 I2=CLK
.ENDS

.SUBCKT ROM_Wrapper_Odd_0 rst_n en n_in[4] n_in[3] n_in[2] n_in[1] n_in[0]
+ k_idx[4] k_idx[3] k_idx[2] k_idx[1] k_idx[0] reg_sign1[1] reg_sign1[0]
+ reg_sign2[1] reg_sign2[0] reg_sign3[1] reg_sign3[0] reg_shift1[3]
+ reg_shift1[2] reg_shift1[1] reg_shift1[0] reg_shift2[3] reg_shift2[2]
+ reg_shift2[1] reg_shift2[0] reg_shift3[3] reg_shift3[2] reg_shift3[1]
+ reg_shift3[0] i_rst_n clk
*.CONNECT N4 n_in[0]
XCTS_ccl_a_INV_CLK_G1_L8_37 INV4CK $PINS O=CTS_10 I=CTS_11
XCTS_ccl_a_INV_CLK_G1_L7_39 INV2CK $PINS O=CTS_11 I=CTS_12
XFE_OFC224_rom_n_idx_3__0 INV1S $PINS O=n8 I=n_in[0]
Xreg_sign1_reg[1] DFFSBN $PINS Q=reg_sign1[1] D=raw_s1[1] CK=CTS_10 SB=i_rst_n
Xreg_sign2_reg[1] DFFSBN $PINS Q=reg_sign2[1] D=raw_s2[1] CK=CTS_10 SB=i_rst_n
Xreg_sign3_reg[1] DFFSBN $PINS Q=reg_sign3[1] D=raw_s3[1] CK=CTS_10 SB=i_rst_n
Xreg_shift1_reg[1] QDFFRBN $PINS Q=reg_shift1[1] D=raw_h1[1] CK=CTS_10
+ RB=i_rst_n
Xreg_shift2_reg[1] QDFFRBN $PINS Q=reg_shift2[1] D=raw_h2[1] CK=CTS_10
+ RB=i_rst_n
Xreg_shift1_reg[0] QDFFRBN $PINS Q=reg_shift1[0] D=raw_h1[0] CK=CTS_10
+ RB=i_rst_n
Xreg_shift1_reg[2] QDFFRBN $PINS Q=reg_shift1[2] D=raw_h1[2] CK=CTS_10
+ RB=i_rst_n
Xreg_shift2_reg[2] QDFFRBN $PINS Q=reg_shift2[2] D=raw_h2[2] CK=CTS_10
+ RB=i_rst_n
Xreg_shift2_reg[3] QDFFRBN $PINS Q=reg_shift2[3] D=raw_h2[3] CK=CTS_10
+ RB=i_rst_n
Xreg_shift2_reg[0] QDFFRBN $PINS Q=reg_shift2[0] D=raw_h2[0] CK=CTS_10
+ RB=i_rst_n
Xreg_shift3_reg[1] QDFFRBN $PINS Q=reg_shift3[1] D=raw_h3[1] CK=CTS_10
+ RB=i_rst_n
Xreg_shift1_reg[3] QDFFRBN $PINS Q=reg_shift1[3] D=raw_h1[3] CK=CTS_10
+ RB=i_rst_n
Xreg_sign3_reg[0] QDFFRBN $PINS Q=reg_sign3[0] D=final_s3[0] CK=CTS_10
+ RB=i_rst_n
Xreg_shift3_reg[3] QDFFRBN $PINS Q=reg_shift3[3] D=raw_h3[3] CK=CTS_10
+ RB=i_rst_n
Xreg_shift3_reg[2] QDFFRBN $PINS Q=reg_shift3[2] D=raw_h3[2] CK=CTS_10
+ RB=i_rst_n
Xreg_shift3_reg[0] QDFFRBN $PINS Q=reg_shift3[0] D=raw_h3[0] CK=CTS_10
+ RB=i_rst_n
Xreg_sign2_reg[0] QDFFRBP $PINS Q=reg_sign2[0] D=final_s2[0] CK=CTS_10
+ RB=i_rst_n
Xreg_sign1_reg[0] QDFFRBN $PINS Q=reg_sign1[0] D=final_s1[0] CK=CTS_10
+ RB=i_rst_n
XU4 NR2 $PINS O=sub_17/carry[2] I1=N4 I2=n_in[1]
XU5 MOAI1 $PINS O=fold_n[1] A1=n6 A2=N2 B1=N5 B2=N2
XU6 ND3S $PINS O=n10 I1=N2 I2=n11 I3=k_idx[0]
XU10 MOAI1 $PINS O=fold_n[0] A1=n8 A2=N2 B1=N4 B2=N2
XU11 XNR2HS $PINS O=final_s2[0] I1=raw_s2[0] I2=n10
XU12 INV1S $PINS O=n6 I=n_in[1]
XU13 XNR2HS $PINS O=final_s3[0] I1=raw_s3[0] I2=n10
XU14 XNR2HS $PINS O=final_s1[0] I1=raw_s1[0] I2=n10
XU15 OA13 $PINS O=N2 A1=n_in[4] B1=n_in[1] B2=N4 B3=n9
XU16 INV1S $PINS O=n7 I=n_in[2]
XU17 MOAI1S $PINS O=fold_n[2] A1=n7 A2=N2 B1=N6 B2=N2
XU18 INV1S $PINS O=n4 I=n_in[3]
XU19 MOAI1S $PINS O=fold_n[4] A1=n5 A2=N2 B1=N8 B2=N2
XU20 INV1S $PINS O=n5 I=n_in[4]
XU22 ND3 $PINS O=n11 I1=k_idx[4] I2=k_idx[3] I3=n12
XU23 AN2 $PINS O=n12 I1=k_idx[2] I2=k_idx[1]
XU24 XOR2HS $PINS O=N8 I1=n5 I2=sub_17/carry[4]
XU25 AN2 $PINS O=sub_17/carry[4] I1=sub_17/carry[3] I2=n4
XU26 XOR2HS $PINS O=N7 I1=n4 I2=sub_17/carry[3]
XU27 AN2 $PINS O=sub_17/carry[3] I1=sub_17/carry[2] I2=n7
XU28 XOR2HS $PINS O=N6 I1=n7 I2=sub_17/carry[2]
XU29 XOR2HS $PINS O=N5 I1=n6 I2=n8
XU30 OR2 $PINS O=n9 I1=n_in[3] I2=n_in[2]
XU3 MOAI1 $PINS O=fold_n[3] A1=n4 A2=N2 B1=N7 B2=N2
Xrom_inst CSD_ROM_Table_odd_0 $PINS n_idx[4]=fold_n[4] n_idx[3]=fold_n[3]
+ n_idx[2]=fold_n[2] n_idx[1]=fold_n[1] n_idx[0]=fold_n[0] k_idx[4]=k_idx[4]
+ k_idx[3]=k_idx[3] k_idx[2]=k_idx[2] k_idx[1]=k_idx[1] k_idx[0]=k_idx[0]
+ sign1[1]=raw_s1[1] sign1[0]=raw_s1[0] shift1[3]=raw_h1[3] shift1[2]=raw_h1[2]
+ shift1[1]=raw_h1[1] shift1[0]=raw_h1[0] sign2[1]=raw_s2[1] sign2[0]=raw_s2[0]
+ shift2[3]=raw_h2[3] shift2[2]=raw_h2[2] shift2[1]=raw_h2[1] shift2[0]=raw_h2[0]
+ sign3[1]=raw_s3[1] sign3[0]=raw_s3[0] shift3[3]=raw_h3[3] shift3[2]=raw_h3[2]
+ shift3[1]=raw_h3[1] shift3[0]=raw_h3[0]
Xclk_gate_reg_shift1_reg SNPS_CLOCK_GATE_HIGH_ROM_Wrapper_Odd_0 $PINS EN=en
+ ENCLK=CTS_12 CLK=clk
.ENDS

.SUBCKT SNPS_CLOCK_GATE_HIGH_PE_Shift_Add_7 EN ENCLK CLK
*.CONNECT net2305 EN
XFE_PHC825_net2308 DELC $PINS O=net2308 I=FE_PHN825_net2308
Xlatch QDBHN $PINS Q=FE_PHN825_net2308 D=net2305 CKB=CLK
Xmain_gate AN2 $PINS O=ENCLK I1=net2308 I2=CLK
.ENDS

.SUBCKT PE_Shift_Add_7_DW01_sub_0_DW01_sub_21 A[26] A[25] A[24] A[23] A[22]
+ A[21] A[20] A[19] A[18] A[17] A[16] A[15] A[14] A[13] A[12] A[11] A[10] A[9]
+ A[8] A[7] A[6] A[5] A[4] A[3] A[2] A[1] A[0] B[26] B[25] B[24] B[23] B[22]
+ B[21] B[20] B[19] B[18] B[17] B[16] B[15] B[14] B[13] B[12] B[11] B[10] B[9]
+ B[8] B[7] B[6] B[5] B[4] B[3] B[2] B[1] B[0] CI DIFF[26] DIFF[25] DIFF[24]
+ DIFF[23] DIFF[22] DIFF[21] DIFF[20] DIFF[19] DIFF[18] DIFF[17] DIFF[16]
+ DIFF[15] DIFF[14] DIFF[13] DIFF[12] DIFF[11] DIFF[10] DIFF[9] DIFF[8] DIFF[7]
+ DIFF[6] DIFF[5] DIFF[4] DIFF[3] DIFF[2] DIFF[1] DIFF[0] CO p1
XFE_RC_1562_0 OR2B1S $PINS O=FE_RN_371_0 I1=B[2] B1=n1
XFE_RC_1561_0 XOR2HS $PINS O=DIFF[3] I1=FE_RN_371_0 I2=B[3]
XFE_RC_1288_0 NR4 $PINS O=n3 I1=B[2] I2=B[1] I3=B[0] I4=B[3]
XFE_OFC608_term3_shifted_4 INV2 $PINS O=n48 I=B[4]
XFE_OFC547_term3_shifted_0 INV2 $PINS O=DIFF[0] I=B[0]
XU1 INV2 $PINS O=n50 I=B[2]
XU6 XOR2HS $PINS O=DIFF[4] I1=n48 I2=n3
XU10 INV1S $PINS O=n47 I=B[5]
XU11 XOR2H $PINS O=DIFF[1] I1=DIFF[0] I2=p1
XU13 AN2 $PINS O=n21 I1=n3 I2=n48
XU14 ND2S $PINS O=n26 I1=n27 I2=n20
XU16 AN2 $PINS O=n4 I1=n44 I2=n24
XU17 AN2 $PINS O=n5 I1=n43 I2=n4
XU18 AN2 $PINS O=n6 I1=n42 I2=n5
XU19 AN2 $PINS O=n7 I1=n41 I2=n6
XU20 AN2 $PINS O=n8 I1=n40 I2=n7
XU21 AN2 $PINS O=n9 I1=n39 I2=n8
XU22 AN2 $PINS O=n10 I1=n38 I2=n9
XU23 AN2 $PINS O=n11 I1=n37 I2=n10
XU24 AN2 $PINS O=n12 I1=n36 I2=n11
XU25 AN2 $PINS O=n13 I1=n35 I2=n12
XU26 AN2 $PINS O=n14 I1=n34 I2=n13
XU27 AN2 $PINS O=n15 I1=n33 I2=n14
XU28 AN2 $PINS O=n16 I1=n32 I2=n15
XU29 AN2 $PINS O=n17 I1=n31 I2=n16
XU30 AN2 $PINS O=n18 I1=n30 I2=n17
XU31 AN2 $PINS O=n19 I1=n29 I2=n18
XU32 AN2 $PINS O=n20 I1=n28 I2=n19
XU33 AN2 $PINS O=n22 I1=n21 I2=n47
XU34 AN2 $PINS O=n23 I1=n46 I2=n22
XU35 AN2 $PINS O=n24 I1=n45 I2=n23
XU36 INV1S $PINS O=n44 I=B[8]
XU37 INV1S $PINS O=n43 I=B[9]
XU38 INV1S $PINS O=n42 I=B[10]
XU39 INV1S $PINS O=n41 I=B[11]
XU40 INV1S $PINS O=n40 I=B[12]
XU41 INV1S $PINS O=n39 I=B[13]
XU42 INV1S $PINS O=n38 I=B[14]
XU43 INV1S $PINS O=n37 I=B[15]
XU44 INV1S $PINS O=n36 I=B[16]
XU45 INV1S $PINS O=n35 I=B[17]
XU46 INV1S $PINS O=n34 I=B[18]
XU47 INV1S $PINS O=n33 I=B[19]
XU48 INV1S $PINS O=n32 I=B[20]
XU49 INV1S $PINS O=n31 I=B[21]
XU50 INV1S $PINS O=n30 I=B[22]
XU51 INV1S $PINS O=n29 I=B[23]
XU52 INV1S $PINS O=n28 I=B[24]
XU53 INV1S $PINS O=n27 I=B[25]
XU54 INV1S $PINS O=n46 I=B[6]
XU55 INV1S $PINS O=n45 I=B[7]
XU56 XOR2HS $PINS O=DIFF[26] I1=B[26] I2=n26
XU57 XOR2HS $PINS O=DIFF[11] I1=n41 I2=n6
XU58 XOR2HS $PINS O=DIFF[12] I1=n40 I2=n7
XU59 XOR2HS $PINS O=DIFF[13] I1=n39 I2=n8
XU60 XOR2HS $PINS O=DIFF[14] I1=n38 I2=n9
XU61 XOR2HS $PINS O=DIFF[15] I1=n37 I2=n10
XU62 XOR2HS $PINS O=DIFF[16] I1=n36 I2=n11
XU63 XOR2HS $PINS O=DIFF[17] I1=n35 I2=n12
XU64 XOR2HS $PINS O=DIFF[18] I1=n34 I2=n13
XU65 XOR2HS $PINS O=DIFF[19] I1=n33 I2=n14
XU66 XOR2HS $PINS O=DIFF[20] I1=n32 I2=n15
XU67 XOR2HS $PINS O=DIFF[10] I1=n42 I2=n5
XU68 XOR2HS $PINS O=DIFF[21] I1=n31 I2=n16
XU69 XOR2HS $PINS O=DIFF[22] I1=n30 I2=n17
XU70 XOR2HS $PINS O=DIFF[23] I1=n29 I2=n18
XU71 XOR2HS $PINS O=DIFF[24] I1=n28 I2=n19
XU72 XOR2HS $PINS O=DIFF[25] I1=n27 I2=n20
XU73 XOR2HS $PINS O=DIFF[9] I1=n43 I2=n4
XU74 XOR2HS $PINS O=DIFF[8] I1=n44 I2=n24
XU75 XOR2HS $PINS O=DIFF[7] I1=n45 I2=n23
XU76 XOR2HS $PINS O=DIFF[6] I1=n46 I2=n22
XU77 XOR2HS $PINS O=DIFF[5] I1=n47 I2=n21
XU2 XOR2HS $PINS O=DIFF[2] I1=n1 I2=n50
XU8 NR2 $PINS O=n1 I1=B[1] I2=B[0]
.ENDS

.SUBCKT PE_Shift_Add_7_DW01_sub_1_DW01_sub_22 A[26] A[25] A[24] A[23] A[22]
+ A[21] A[20] A[19] A[18] A[17] A[16] A[15] A[14] A[13] A[12] A[11] A[10] A[9]
+ A[8] A[7] A[6] A[5] A[4] A[3] A[2] A[1] A[0] B[26] B[25] B[24] B[23] B[22]
+ B[21] B[20] B[19] B[18] B[17] B[16] B[15] B[14] B[13] B[12] B[11] B[10] B[9]
+ B[8] B[7] B[6] B[5] B[4] B[3] B[2] B[1] B[0] CI DIFF[26] DIFF[25] DIFF[24]
+ DIFF[23] DIFF[22] DIFF[21] DIFF[20] DIFF[19] DIFF[18] DIFF[17] DIFF[16]
+ DIFF[15] DIFF[14] DIFF[13] DIFF[12] DIFF[11] DIFF[10] DIFF[9] DIFF[8] DIFF[7]
+ DIFF[6] DIFF[5] DIFF[4] DIFF[3] DIFF[2] DIFF[1] DIFF[0] CO
*.CONNECT DIFF[0] B[0]
XFE_RC_1808_0 INV2 $PINS O=DIFF[3] I=FE_RN_497_0
XFE_RC_1807_0 XNR2HS $PINS O=FE_RN_497_0 I1=B[3] I2=FE_RN_353_0
XFE_RC_1524_0 OR2B1S $PINS O=FE_RN_353_0 I1=B[2] B1=n4
XFE_RC_1470_0 AN2 $PINS O=FE_RN_334_0 I1=n46 I2=n47
XFE_RC_1469_0 AN2 $PINS O=n25 I1=FE_RN_334_0 I2=n23
XFE_RC_1147_0 XNR2HS $PINS O=DIFF[6] I1=B[6] I2=n23
XFE_RC_1134_0 XNR2HS $PINS O=DIFF[2] I1=n4 I2=B[2]
XFE_OFC680_term2_shifted_2 INV1S $PINS O=n51 I=B[2]
XFE_OFC656_term2_shifted_4 INV2 $PINS O=n49 I=B[4]
XFE_OFC650_term2_shifted_7 INV1S $PINS O=n46 I=B[7]
XFE_OFC630_term2_shifted_1 INV2 $PINS O=n2 I=B[1]
XU1 NR2P $PINS O=n4 I1=DIFF[0] I2=B[1]
XU5 INV1S $PINS O=n50 I=B[3]
XU6 INV1S $PINS O=n48 I=B[5]
XU9 AN2 $PINS O=n1 I1=n50 I2=n3
XU10 XNR2HS $PINS O=DIFF[1] I1=B[0] I2=n2
XU11 AN2 $PINS O=n22 I1=n1 I2=n49
XU12 ND2S $PINS O=n27 I1=n28 I2=n21
XU13 XOR2HS $PINS O=DIFF[4] I1=n49 I2=n1
XU14 AN2S $PINS O=n3 I1=n51 I2=n4
XU15 AN2 $PINS O=n5 I1=n45 I2=n25
XU16 AN2 $PINS O=n6 I1=n44 I2=n5
XU17 AN2 $PINS O=n7 I1=n43 I2=n6
XU18 AN2 $PINS O=n8 I1=n42 I2=n7
XU19 AN2 $PINS O=n9 I1=n41 I2=n8
XU20 AN2 $PINS O=n10 I1=n40 I2=n9
XU21 AN2 $PINS O=n11 I1=n39 I2=n10
XU22 AN2 $PINS O=n12 I1=n38 I2=n11
XU23 AN2 $PINS O=n13 I1=n37 I2=n12
XU24 AN2 $PINS O=n14 I1=n36 I2=n13
XU25 AN2 $PINS O=n15 I1=n35 I2=n14
XU26 AN2 $PINS O=n16 I1=n34 I2=n15
XU27 AN2 $PINS O=n17 I1=n33 I2=n16
XU28 AN2 $PINS O=n18 I1=n32 I2=n17
XU29 AN2 $PINS O=n19 I1=n31 I2=n18
XU30 AN2 $PINS O=n20 I1=n30 I2=n19
XU31 AN2 $PINS O=n21 I1=n29 I2=n20
XU32 AN2 $PINS O=n23 I1=n22 I2=n48
XU33 AN2 $PINS O=n24 I1=n47 I2=n23
XU35 INV1S $PINS O=n45 I=B[8]
XU36 INV1S $PINS O=n44 I=B[9]
XU37 INV1S $PINS O=n43 I=B[10]
XU38 INV1S $PINS O=n42 I=B[11]
XU39 INV1S $PINS O=n41 I=B[12]
XU40 INV1S $PINS O=n40 I=B[13]
XU41 INV1S $PINS O=n39 I=B[14]
XU42 INV1S $PINS O=n38 I=B[15]
XU43 INV1S $PINS O=n37 I=B[16]
XU44 INV1S $PINS O=n36 I=B[17]
XU45 INV1S $PINS O=n35 I=B[18]
XU46 INV1S $PINS O=n34 I=B[19]
XU47 INV1S $PINS O=n33 I=B[20]
XU48 INV1S $PINS O=n32 I=B[21]
XU49 INV1S $PINS O=n31 I=B[22]
XU50 INV1S $PINS O=n30 I=B[23]
XU51 INV1S $PINS O=n29 I=B[24]
XU52 INV1S $PINS O=n28 I=B[25]
XU53 INV1S $PINS O=n47 I=B[6]
XU55 XOR2HS $PINS O=DIFF[26] I1=B[26] I2=n27
XU56 XOR2HS $PINS O=DIFF[9] I1=n44 I2=n5
XU57 XOR2HS $PINS O=DIFF[10] I1=n43 I2=n6
XU58 XOR2HS $PINS O=DIFF[11] I1=n42 I2=n7
XU59 XOR2HS $PINS O=DIFF[12] I1=n41 I2=n8
XU60 XOR2HS $PINS O=DIFF[13] I1=n40 I2=n9
XU61 XOR2HS $PINS O=DIFF[14] I1=n39 I2=n10
XU62 XOR2HS $PINS O=DIFF[15] I1=n38 I2=n11
XU63 XOR2HS $PINS O=DIFF[16] I1=n37 I2=n12
XU64 XOR2HS $PINS O=DIFF[17] I1=n36 I2=n13
XU65 XOR2HS $PINS O=DIFF[18] I1=n35 I2=n14
XU66 XOR2HS $PINS O=DIFF[19] I1=n34 I2=n15
XU67 XOR2HS $PINS O=DIFF[20] I1=n33 I2=n16
XU68 XOR2HS $PINS O=DIFF[8] I1=n45 I2=n25
XU69 XOR2HS $PINS O=DIFF[21] I1=n32 I2=n17
XU70 XOR2HS $PINS O=DIFF[22] I1=n31 I2=n18
XU71 XOR2HS $PINS O=DIFF[23] I1=n30 I2=n19
XU72 XOR2HS $PINS O=DIFF[24] I1=n29 I2=n20
XU73 XOR2HS $PINS O=DIFF[25] I1=n28 I2=n21
XU74 XOR2HS $PINS O=DIFF[7] I1=n46 I2=n24
XU76 XOR2HS $PINS O=DIFF[5] I1=n48 I2=n22
.ENDS

.SUBCKT PE_Shift_Add_7_DW01_sub_2_DW01_sub_23 A[26] A[25] A[24] A[23] A[22]
+ A[21] A[20] A[19] A[18] A[17] A[16] A[15] A[14] A[13] A[12] A[11] A[10] A[9]
+ A[8] A[7] A[6] A[5] A[4] A[3] A[2] A[1] A[0] B[26] B[25] B[24] B[23] B[22]
+ B[21] B[20] B[19] B[18] B[17] B[16] B[15] B[14] B[13] B[12] B[11] B[10] B[9]
+ B[8] B[7] B[6] B[5] B[4] B[3] B[2] B[1] B[0] CI DIFF[26] DIFF[25] DIFF[24]
+ DIFF[23] DIFF[22] DIFF[21] DIFF[20] DIFF[19] DIFF[18] DIFF[17] DIFF[16]
+ DIFF[15] DIFF[14] DIFF[13] DIFF[12] DIFF[11] DIFF[10] DIFF[9] DIFF[8] DIFF[7]
+ DIFF[6] DIFF[5] DIFF[4] DIFF[3] DIFF[2] DIFF[1] DIFF[0] CO
XFE_RC_1513_0 AN2B1S $PINS O=n4 I1=n3 B1=B[3]
XFE_RC_1498_0 XNR2HS $PINS O=DIFF[2] I1=n2 I2=B[2]
XFE_OFC434_term1_shifted_0 INV1S $PINS O=DIFF[0] I=B[0]
XFE_OFC390_term1_shifted_2 INV1S $PINS O=n50 I=B[2]
XU4 AN2 $PINS O=n3 I1=n50 I2=n2
XU5 NR2 $PINS O=n22 I1=B[4] I2=n1
XU6 INV1S $PINS O=n1 I=n4
XU7 NR2 $PINS O=n2 I1=B[0] I2=B[1]
XU11 XNR2HS $PINS O=DIFF[4] I1=n4 I2=B[4]
XU12 INV2 $PINS O=n48 I=B[5]
XU13 INV1S $PINS O=n47 I=B[6]
XU14 ND2S $PINS O=n27 I1=n28 I2=n21
XU16 XOR2HS $PINS O=DIFF[3] I1=n3 I2=n49
XU18 XOR2HS $PINS O=DIFF[8] I1=n45 I2=n25
XU19 XOR2HS $PINS O=DIFF[9] I1=n44 I2=n5
XU20 AN2 $PINS O=n5 I1=n45 I2=n25
XU21 XOR2HS $PINS O=DIFF[10] I1=n43 I2=n6
XU22 AN2 $PINS O=n6 I1=n44 I2=n5
XU23 XOR2HS $PINS O=DIFF[11] I1=n42 I2=n7
XU24 AN2 $PINS O=n7 I1=n43 I2=n6
XU25 XOR2HS $PINS O=DIFF[12] I1=n41 I2=n8
XU26 AN2 $PINS O=n8 I1=n42 I2=n7
XU27 XOR2HS $PINS O=DIFF[13] I1=n40 I2=n9
XU28 AN2 $PINS O=n9 I1=n41 I2=n8
XU29 XOR2HS $PINS O=DIFF[14] I1=n39 I2=n10
XU30 AN2 $PINS O=n10 I1=n40 I2=n9
XU31 XOR2HS $PINS O=DIFF[15] I1=n38 I2=n11
XU32 AN2 $PINS O=n11 I1=n39 I2=n10
XU33 XOR2HS $PINS O=DIFF[16] I1=n37 I2=n12
XU34 AN2 $PINS O=n12 I1=n38 I2=n11
XU35 XOR2HS $PINS O=DIFF[17] I1=n36 I2=n13
XU36 AN2 $PINS O=n13 I1=n37 I2=n12
XU37 XOR2HS $PINS O=DIFF[18] I1=n35 I2=n14
XU38 AN2 $PINS O=n14 I1=n36 I2=n13
XU39 XOR2HS $PINS O=DIFF[19] I1=n34 I2=n15
XU40 AN2 $PINS O=n15 I1=n35 I2=n14
XU41 XOR2HS $PINS O=DIFF[20] I1=n33 I2=n16
XU42 AN2 $PINS O=n16 I1=n34 I2=n15
XU43 XOR2HS $PINS O=DIFF[21] I1=n32 I2=n17
XU44 AN2 $PINS O=n17 I1=n33 I2=n16
XU45 XOR2HS $PINS O=DIFF[22] I1=n31 I2=n18
XU46 AN2 $PINS O=n18 I1=n32 I2=n17
XU47 XOR2HS $PINS O=DIFF[23] I1=n30 I2=n19
XU48 AN2 $PINS O=n19 I1=n31 I2=n18
XU49 XOR2HS $PINS O=DIFF[24] I1=n29 I2=n20
XU50 AN2 $PINS O=n20 I1=n30 I2=n19
XU51 AN2 $PINS O=n21 I1=n29 I2=n20
XU52 XOR2HS $PINS O=DIFF[25] I1=n28 I2=n21
XU53 XOR2HS $PINS O=DIFF[5] I1=n48 I2=n22
XU54 XOR2HS $PINS O=DIFF[6] I1=n47 I2=n23
XU55 AN2 $PINS O=n23 I1=n48 I2=n22
XU56 XOR2HS $PINS O=DIFF[7] I1=n46 I2=n24
XU57 AN2 $PINS O=n24 I1=n47 I2=n23
XU58 AN2 $PINS O=n25 I1=n46 I2=n24
XU59 INV1S $PINS O=n45 I=B[8]
XU60 INV1S $PINS O=n44 I=B[9]
XU61 INV1S $PINS O=n43 I=B[10]
XU62 INV1S $PINS O=n42 I=B[11]
XU63 INV1S $PINS O=n41 I=B[12]
XU64 INV1S $PINS O=n40 I=B[13]
XU65 INV1S $PINS O=n39 I=B[14]
XU66 INV1S $PINS O=n38 I=B[15]
XU67 INV1S $PINS O=n37 I=B[16]
XU68 INV1S $PINS O=n36 I=B[17]
XU69 INV1S $PINS O=n35 I=B[18]
XU70 INV1S $PINS O=n34 I=B[19]
XU71 INV1S $PINS O=n33 I=B[20]
XU72 INV1S $PINS O=n32 I=B[21]
XU73 INV1S $PINS O=n31 I=B[22]
XU74 INV1S $PINS O=n30 I=B[23]
XU75 INV1S $PINS O=n29 I=B[24]
XU76 INV1S $PINS O=n28 I=B[25]
XU77 INV1S $PINS O=n46 I=B[7]
XU78 XOR2HS $PINS O=DIFF[26] I1=B[26] I2=n27
XU1 INV1S $PINS O=n49 I=B[3]
XU2 XOR2HS $PINS O=DIFF[1] I1=DIFF[0] I2=n51
XU10 INV1S $PINS O=n51 I=B[1]
.ENDS

.SUBCKT PE_Shift_Add_7_DW01_add_2_DW01_add_37 A[26] A[25] A[24] A[23] A[22]
+ A[21] A[20] A[19] A[18] A[17] A[16] A[15] A[14] A[13] A[12] A[11] A[10] A[9]
+ A[8] A[7] A[6] A[5] A[4] A[3] A[2] A[1] A[0] B[26] B[25] B[24] B[23] B[22]
+ B[21] B[20] B[19] B[18] B[17] B[16] B[15] B[14] B[13] B[12] B[11] B[10] B[9]
+ B[8] B[7] B[6] B[5] B[4] B[3] B[2] B[1] B[0] CI SUM[26] SUM[25] SUM[24]
+ SUM[23] SUM[22] SUM[21] SUM[20] SUM[19] SUM[18] SUM[17] SUM[16] SUM[15]
+ SUM[14] SUM[13] SUM[12] SUM[11] SUM[10] SUM[9] SUM[8] SUM[7] SUM[6] SUM[5]
+ SUM[4] SUM[3] SUM[2] SUM[1] SUM[0] CO
XFE_RC_1795_0 XNR3 $PINS O=FE_RN_161_0 I1=FE_RN_491_0 I2=B[1] I3=A[1]
XFE_RC_1794_0 AN2S $PINS O=FE_RN_491_0 I1=B[0] I2=A[0]
XFE_RC_1703_0 INV2 $PINS O=SUM[23] I=FE_RN_444_0
XFE_RC_1702_0 XNR3 $PINS O=FE_RN_444_0 I1=A[23] I2=B[23] I3=carry[23]
XFE_RC_1541_0 INV2 $PINS O=SUM[16] I=FE_RN_361_0
XFE_RC_1540_0 XNR3 $PINS O=FE_RN_361_0 I1=A[16] I2=B[16] I3=carry[16]
XFE_RC_1508_0 INV1S $PINS O=FE_RN_346_0 I=A[0]
XFE_RC_1507_0 AN2B1S $PINS O=n8 I1=B[0] B1=FE_RN_346_0
XFE_RC_1334_0 INV2 $PINS O=SUM[8] I=FE_RN_277_0
XFE_RC_1333_0 XNR3 $PINS O=FE_RN_277_0 I1=B[8] I2=A[8] I3=carry[8]
XFE_RC_1065_0 INV2 $PINS O=SUM[1] I=FE_RN_161_0
XFE_RC_972_0 XOR3 $PINS O=SUM[13] I1=A[13] I2=B[13] I3=carry[13]
XFE_RC_971_0 MAO222P $PINS O=carry[14] A1=carry[13] B1=B[13] C1=A[13]
XFE_RC_961_0 XOR2HT $PINS O=FE_RN_137_0 I1=A[26] I2=B[26]
XFE_RC_960_0 XOR2HS $PINS O=SUM[26] I1=FE_RN_137_0 I2=carry[26]
XFE_RC_788_0 ND2T $PINS O=FE_RN_47_0 I1=carry[23] I2=B[23]
XFE_RC_787_0 ND2P $PINS O=FE_RN_48_0 I1=carry[23] I2=A[23]
XFE_RC_786_0 ND2 $PINS O=FE_RN_49_0 I1=A[23] I2=B[23]
XFE_RC_785_0 ND3HT $PINS O=carry[24] I1=FE_RN_48_0 I2=FE_RN_47_0 I3=FE_RN_49_0
XFE_RC_762_0 XOR3 $PINS O=SUM[24] I1=A[24] I2=B[24] I3=carry[24]
XFE_RC_761_0 MAO222 $PINS O=carry[25] A1=carry[24] B1=B[24] C1=A[24]
XFE_RC_760_0 XOR3 $PINS O=SUM[21] I1=A[21] I2=B[21] I3=carry[21]
XFE_RC_759_0 MAO222P $PINS O=carry[22] A1=carry[21] B1=B[21] C1=A[21]
XFE_RC_735_0 XOR3 $PINS O=SUM[25] I1=A[25] I2=B[25] I3=carry[25]
XFE_RC_734_0 MAO222 $PINS O=carry[26] A1=carry[25] B1=B[25] C1=A[25]
XFE_RC_733_0 XOR3 $PINS O=SUM[22] I1=A[22] I2=B[22] I3=carry[22]
XFE_RC_732_0 MAO222P $PINS O=carry[23] A1=carry[22] B1=B[22] C1=A[22]
XFE_RC_647_0 XOR3 $PINS O=SUM[3] I1=B[3] I2=A[3] I3=carry[3]
XFE_RC_646_0 MAO222 $PINS O=carry[4] A1=carry[3] B1=B[3] C1=A[3]
XFE_RC_597_0 XOR3 $PINS O=SUM[17] I1=A[17] I2=B[17] I3=carry[17]
XFE_RC_596_0 MAO222P $PINS O=carry[18] A1=carry[17] B1=B[17] C1=A[17]
XFE_RC_589_0 XOR3 $PINS O=SUM[18] I1=A[18] I2=B[18] I3=carry[18]
XFE_RC_588_0 MAO222P $PINS O=carry[19] A1=carry[18] B1=B[18] C1=A[18]
XFE_RC_478_0 XOR3 $PINS O=SUM[9] I1=B[9] I2=A[9] I3=carry[9]
XFE_RC_477_0 MAO222 $PINS O=carry[10] A1=carry[9] B1=B[9] C1=A[9]
XFE_RC_476_0 XOR3 $PINS O=SUM[12] I1=A[12] I2=B[12] I3=carry[12]
XFE_RC_475_0 MAO222P $PINS O=carry[13] A1=carry[12] B1=B[12] C1=A[12]
XFE_RC_420_0 XOR3 $PINS O=SUM[10] I1=A[10] I2=B[10] I3=carry[10]
XFE_RC_419_0 MAO222 $PINS O=carry[11] A1=carry[10] B1=B[10] C1=A[10]
XFE_RC_331_0 XOR3 $PINS O=SUM[4] I1=A[4] I2=B[4] I3=carry[4]
XFE_RC_330_0 MAO222 $PINS O=carry[5] A1=carry[4] B1=B[4] C1=A[4]
XFE_RC_329_0 XOR3 $PINS O=SUM[11] I1=A[11] I2=B[11] I3=carry[11]
XFE_RC_328_0 MAO222 $PINS O=carry[12] A1=carry[11] B1=B[11] C1=A[11]
XFE_RC_263_0 XOR3 $PINS O=SUM[5] I1=A[5] I2=B[5] I3=carry[5]
XFE_RC_262_0 MAO222 $PINS O=carry[6] A1=carry[5] B1=B[5] C1=A[5]
XFE_RC_207_0 XOR3 $PINS O=SUM[6] I1=A[6] I2=B[6] I3=carry[6]
XFE_RC_206_0 MAO222 $PINS O=carry[7] A1=carry[6] B1=B[6] C1=A[6]
XFE_RC_153_0 XOR3 $PINS O=SUM[14] I1=A[14] I2=B[14] I3=carry[14]
XFE_RC_152_0 MAO222P $PINS O=carry[15] A1=carry[14] B1=B[14] C1=A[14]
XFE_RC_140_0 XOR3 $PINS O=SUM[7] I1=B[7] I2=A[7] I3=carry[7]
XFE_RC_139_0 MAO222P $PINS O=carry[8] A1=carry[7] B1=B[7] C1=A[7]
XU1 XNR2HS $PINS O=SUM[19] I1=carry[19] I2=n1
XU2 XNR2HS $PINS O=n1 I1=A[19] I2=B[19]
XU3 ND2S $PINS O=n4 I1=A[15] I2=B[15]
XU5 ND3P $PINS O=carry[16] I1=n3 I2=n2 I3=n4
XU7 ND3P $PINS O=carry[21] I1=n23 I2=n24 I3=n25
XU8 XOR3 $PINS O=SUM[15] I1=A[15] I2=B[15] I3=carry[15]
XU9 ND2P $PINS O=n2 I1=carry[15] I2=A[15]
XU10 ND2 $PINS O=n3 I1=carry[15] I2=B[15]
XU11 ND2P $PINS O=n5 I1=carry[19] I2=A[19]
XU12 ND2P $PINS O=n6 I1=carry[19] I2=B[19]
XU13 ND2 $PINS O=n7 I1=A[19] I2=B[19]
XU14 ND3HT $PINS O=carry[20] I1=n5 I2=n6 I3=n7
XU16 ND2 $PINS O=n9 I1=carry[16] I2=A[16]
XU17 ND2 $PINS O=n10 I1=carry[16] I2=B[16]
XU18 ND2 $PINS O=n11 I1=A[16] I2=B[16]
XU19 ND3P $PINS O=carry[3] I1=n20 I2=n21 I3=n19
XU21 ND2 $PINS O=n12 I1=carry[8] I2=A[8]
XU22 ND2P $PINS O=n13 I1=carry[8] I2=B[8]
XU23 ND2 $PINS O=n14 I1=A[8] I2=B[8]
XU24 ND3P $PINS O=carry[9] I1=n12 I2=n13 I3=n14
XU26 ND2 $PINS O=n15 I1=B[1] I2=n8
XU29 ND3P $PINS O=carry[2] I1=n16 I2=n17 I3=n15
XU30 XOR2HS $PINS O=n18 I1=A[2] I2=B[2]
XU31 XOR2HS $PINS O=SUM[2] I1=carry[2] I2=n18
XU32 ND2 $PINS O=n19 I1=A[2] I2=B[2]
XU33 ND2 $PINS O=n20 I1=carry[2] I2=A[2]
XU34 ND2 $PINS O=n21 I1=carry[2] I2=B[2]
XU35 XOR2HS $PINS O=n22 I1=A[20] I2=B[20]
XU36 XOR2HS $PINS O=SUM[20] I1=carry[20] I2=n22
XU37 ND2 $PINS O=n23 I1=carry[20] I2=A[20]
XU38 ND2P $PINS O=n24 I1=carry[20] I2=B[20]
XU39 ND2S $PINS O=n25 I1=A[20] I2=B[20]
XU41 XOR2HS $PINS O=SUM[0] I1=B[0] I2=A[0]
XU4 ND2 $PINS O=n17 I1=A[1] I2=n8
XU6 ND2 $PINS O=n16 I1=A[1] I2=B[1]
XU25 ND3P $PINS O=carry[17] I1=n10 I2=n9 I3=n11
.ENDS

.SUBCKT PE_Shift_Add_7_DW01_add_1_DW01_add_36 A[26] A[25] A[24] A[23] A[22]
+ A[21] A[20] A[19] A[18] A[17] A[16] A[15] A[14] A[13] A[12] A[11] A[10] A[9]
+ A[8] A[7] A[6] A[5] A[4] A[3] A[2] A[1] A[0] B[26] B[25] B[24] B[23] B[22]
+ B[21] B[20] B[19] B[18] B[17] B[16] B[15] B[14] B[13] B[12] B[11] B[10] B[9]
+ B[8] B[7] B[6] B[5] B[4] B[3] B[2] B[1] B[0] CI SUM[26] SUM[25] SUM[24]
+ SUM[23] SUM[22] SUM[21] SUM[20] SUM[19] SUM[18] SUM[17] SUM[16] SUM[15]
+ SUM[14] SUM[13] SUM[12] SUM[11] SUM[10] SUM[9] SUM[8] SUM[7] SUM[6] SUM[5]
+ SUM[4] SUM[3] SUM[2] SUM[1] SUM[0] CO
XFE_RC_1828_0 INV1S $PINS O=FE_RN_507_0 I=A[0]
XFE_RC_1827_0 AN2B1T $PINS O=n4 I1=B[0] B1=FE_RN_507_0
XFE_RC_1778_0 INV2 $PINS O=SUM[8] I=FE_RN_483_0
XFE_RC_1777_0 XNR3 $PINS O=FE_RN_483_0 I1=A[8] I2=B[8] I3=carry[8]
XFE_RC_1754_0 INV2 $PINS O=SUM[16] I=FE_RN_470_0
XFE_RC_1753_0 XNR3 $PINS O=FE_RN_470_0 I1=A[16] I2=B[16] I3=n25
XFE_RC_1752_0 INV2 $PINS O=SUM[19] I=FE_RN_469_0
XFE_RC_1751_0 XNR3 $PINS O=FE_RN_469_0 I1=A[19] I2=B[19] I3=carry[19]
XFE_RC_1748_0 XNR2HS $PINS O=FE_RN_467_0 I1=A[22] I2=B[22]
XFE_RC_1747_0 XOR2HS $PINS O=FE_RN_166_0 I1=FE_RN_467_0 I2=carry[22]
XFE_RC_1693_0 INV2 $PINS O=SUM[1] I=FE_RN_439_0
XFE_RC_1692_0 XNR3 $PINS O=FE_RN_439_0 I1=A[1] I2=n4 I3=B[1]
XFE_RC_1552_0 INV2 $PINS O=SUM[3] I=FE_RN_367_0
XFE_RC_1551_0 XNR3 $PINS O=FE_RN_367_0 I1=A[3] I2=B[3] I3=carry[3]
XFE_RC_1480_0 INV2 $PINS O=SUM[2] I=FE_RN_337_0
XFE_RC_1479_0 XNR3 $PINS O=FE_RN_337_0 I1=A[2] I2=B[2] I3=carry[2]
XFE_RC_1452_0 XOR3 $PINS O=SUM[21] I1=A[21] I2=B[21] I3=carry[21]
XFE_RC_1451_0 MAO222 $PINS O=carry[22] A1=A[21] B1=B[21] C1=carry[21]
XFE_RC_1413_0 XOR2HS $PINS O=FE_RN_309_0 I1=A[26] I2=B[26]
XFE_RC_1412_0 INV2 $PINS O=FE_RN_308_0 I=FE_RN_309_0
XFE_RC_1411_0 XNR2HS $PINS O=SUM[26] I1=FE_RN_308_0 I2=carry[26]
XFE_RC_1198_0 INV2 $PINS O=SUM[5] I=FE_RN_215_0
XFE_RC_1197_0 XNR3 $PINS O=FE_RN_215_0 I1=A[5] I2=B[5] I3=carry[5]
XFE_RC_1158_0 INV2 $PINS O=SUM[20] I=FE_RN_197_0
XFE_RC_1157_0 XNR3 $PINS O=FE_RN_197_0 I1=A[20] I2=B[20] I3=carry[20]
XFE_RC_1141_0 INV2 $PINS O=SUM[4] I=FE_RN_190_0
XFE_RC_1140_0 XNR3 $PINS O=FE_RN_190_0 I1=A[4] I2=B[4] I3=carry[4]
XFE_RC_1078_0 INV2 $PINS O=SUM[22] I=FE_RN_166_0
XFE_RC_1019_0 XOR3 $PINS O=SUM[15] I1=A[15] I2=B[15] I3=carry[15]
XFE_RC_1017_0 XOR3 $PINS O=SUM[25] I1=A[25] I2=B[25] I3=carry[25]
XFE_RC_1016_0 MAO222 $PINS O=carry[26] A1=carry[25] B1=B[25] C1=A[25]
XFE_RC_872_0 MAO222 $PINS O=FE_RN_91_0 A1=carry[21] B1=B[21] C1=A[21]
XFE_RC_871_0 MAO222 $PINS O=carry[23] A1=FE_RN_91_0 B1=B[22] C1=A[22]
XFE_RC_781_0 MAO222P $PINS O=carry[21] A1=carry[20] B1=B[20] C1=A[20]
XFE_RC_678_0 MAO222P $PINS O=carry[20] A1=carry[19] B1=B[19] C1=A[19]
XFE_RC_677_0 XOR3 $PINS O=SUM[23] I1=A[23] I2=B[23] I3=carry[23]
XFE_RC_676_0 MAO222 $PINS O=carry[24] A1=carry[23] B1=B[23] C1=A[23]
XFE_RC_633_0 XOR3 $PINS O=SUM[18] I1=A[18] I2=B[18] I3=carry[18]
XFE_RC_632_0 MAO222P $PINS O=carry[19] A1=carry[18] B1=B[18] C1=A[18]
XFE_RC_629_0 XOR3 $PINS O=SUM[24] I1=A[24] I2=B[24] I3=carry[24]
XFE_RC_628_0 MAO222P $PINS O=carry[25] A1=carry[24] B1=B[24] C1=A[24]
XFE_RC_590_0 MAO222P $PINS O=carry[9] A1=carry[8] B1=B[8] C1=A[8]
XFE_RC_551_0 XOR3 $PINS O=SUM[9] I1=A[9] I2=B[9] I3=carry[9]
XFE_RC_550_0 MAO222P $PINS O=carry[10] A1=carry[9] B1=B[9] C1=A[9]
XFE_RC_503_0 XOR3 $PINS O=SUM[10] I1=A[10] I2=B[10] I3=carry[10]
XFE_RC_502_0 MAO222P $PINS O=carry[11] A1=carry[10] B1=B[10] C1=A[10]
XFE_RC_467_0 XOR3 $PINS O=SUM[11] I1=A[11] I2=B[11] I3=carry[11]
XFE_RC_466_0 MAO222P $PINS O=carry[12] A1=carry[11] B1=B[11] C1=A[11]
XFE_RC_379_0 MAO222 $PINS O=carry[2] A1=B[1] B1=A[1] C1=n4
XFE_RC_377_0 MAO222P $PINS O=carry[5] A1=carry[4] B1=B[4] C1=A[4]
XFE_RC_371_0 XOR3 $PINS O=SUM[12] I1=A[12] I2=B[12] I3=carry[12]
XFE_RC_370_0 MAO222P $PINS O=carry[13] A1=carry[12] B1=B[12] C1=A[12]
XU1 ND3P $PINS O=carry[8] I1=n11 I2=n12 I3=n13
XU3 XOR3 $PINS O=SUM[13] I1=B[13] I2=A[13] I3=carry[13]
XU4 ND2P $PINS O=n1 I1=carry[13] I2=B[13]
XU5 ND2 $PINS O=n2 I1=carry[13] I2=A[13]
XU6 ND2 $PINS O=n3 I1=B[13] I2=A[13]
XU10 ND3P $PINS O=carry[6] I1=n15 I2=n16 I3=n14
XU11 ND2 $PINS O=n26 I1=A[16] I2=B[16]
XU12 ND2 $PINS O=n14 I1=B[5] I2=A[5]
XU14 ND2P $PINS O=n27 I1=n25 I2=A[16]
XU17 ND2 $PINS O=n5 I1=carry[2] I2=B[2]
XU18 ND2 $PINS O=n6 I1=carry[2] I2=A[2]
XU19 ND2 $PINS O=n7 I1=B[2] I2=A[2]
XU20 ND3P $PINS O=carry[3] I1=n6 I2=n5 I3=n7
XU22 ND2 $PINS O=n8 I1=B[3] I2=carry[3]
XU23 ND2 $PINS O=n9 I1=carry[3] I2=A[3]
XU24 ND2 $PINS O=n10 I1=B[3] I2=A[3]
XU25 ND3 $PINS O=carry[4] I1=n8 I2=n10 I3=n9
XU26 XOR3 $PINS O=SUM[7] I1=B[7] I2=A[7] I3=carry[7]
XU27 ND2 $PINS O=n11 I1=carry[7] I2=B[7]
XU28 ND2 $PINS O=n12 I1=carry[7] I2=A[7]
XU29 ND2 $PINS O=n13 I1=B[7] I2=A[7]
XU32 ND2 $PINS O=n15 I1=carry[5] I2=A[5]
XU33 ND2P $PINS O=n16 I1=carry[5] I2=B[5]
XU34 XOR2HS $PINS O=n17 I1=A[6] I2=B[6]
XU35 XOR2HS $PINS O=SUM[6] I1=n17 I2=carry[6]
XU36 ND2 $PINS O=n18 I1=A[6] I2=B[6]
XU37 ND2 $PINS O=n19 I1=carry[6] I2=A[6]
XU38 ND2 $PINS O=n20 I1=carry[6] I2=B[6]
XU39 XOR2HS $PINS O=n21 I1=B[14] I2=A[14]
XU40 XOR2HS $PINS O=SUM[14] I1=carry[14] I2=n21
XU41 ND2 $PINS O=n22 I1=carry[14] I2=B[14]
XU42 ND2 $PINS O=n23 I1=carry[14] I2=A[14]
XU43 ND2 $PINS O=n24 I1=B[14] I2=A[14]
XU44 ND3P $PINS O=carry[15] I1=n22 I2=n23 I3=n24
XU45 MAO222P $PINS O=n25 A1=carry[15] B1=B[15] C1=A[15]
XU47 ND2 $PINS O=n28 I1=n25 I2=B[16]
XU48 XOR2HS $PINS O=n29 I1=A[17] I2=B[17]
XU49 XOR2HS $PINS O=SUM[17] I1=carry[17] I2=n29
XU50 ND2 $PINS O=n30 I1=A[17] I2=B[17]
XU51 XOR2HS $PINS O=SUM[0] I1=B[0] I2=A[0]
XU2 ND3P $PINS O=carry[17] I1=n28 I2=n27 I3=n26
XU7 ND3P $PINS O=carry[7] I1=n19 I2=n20 I3=n18
XU8 ND3P $PINS O=carry[18] I1=n32 I2=n31 I3=n30
XU9 ND3P $PINS O=carry[14] I1=n2 I2=n1 I3=n3
XU30 ND2 $PINS O=n32 I1=carry[17] I2=B[17]
XU31 ND2 $PINS O=n31 I1=carry[17] I2=A[17]
.ENDS

.SUBCKT PE_Shift_Add_7_DW01_add_0_DW01_add_35 A[26] A[25] A[24] A[23] A[22]
+ A[21] A[20] A[19] A[18] A[17] A[16] A[15] A[14] A[13] A[12] A[11] A[10] A[9]
+ A[8] A[7] A[6] A[5] A[4] A[3] A[2] A[1] A[0] B[26] B[25] B[24] B[23] B[22]
+ B[21] B[20] B[19] B[18] B[17] B[16] B[15] B[14] B[13] B[12] B[11] B[10] B[9]
+ B[8] B[7] B[6] B[5] B[4] B[3] B[2] B[1] B[0] CI SUM[26] SUM[25] SUM[24]
+ SUM[23] SUM[22] SUM[21] SUM[20] SUM[19] SUM[18] SUM[17] SUM[16] SUM[15]
+ SUM[14] SUM[13] SUM[12] SUM[11] SUM[10] SUM[9] SUM[8] SUM[7] SUM[6] SUM[5]
+ SUM[4] SUM[3] SUM[2] SUM[1] SUM[0] CO
XFE_RC_1734_0 MAO222P $PINS O=carry[13] A1=carry[12] B1=A[12] C1=B[12]
XFE_RC_1362_0 AN2 $PINS O=n4 I1=A[0] I2=B[0]
XFE_RC_878_0 XOR2HS $PINS O=FE_RN_94_0 I1=A[26] I2=B[26]
XFE_RC_877_0 XOR2H $PINS O=SUM[26] I1=FE_RN_94_0 I2=carry[26]
XFE_RC_709_0 XOR3 $PINS O=SUM[2] I1=A[2] I2=B[2] I3=carry[2]
XFE_RC_708_0 MAO222P $PINS O=carry[3] A1=carry[2] B1=B[2] C1=A[2]
XFE_RC_659_0 XOR3 $PINS O=SUM[1] I1=A[1] I2=n4 I3=B[1]
XFE_RC_658_0 MAO222 $PINS O=carry[2] A1=A[1] B1=n4 C1=B[1]
XFE_RC_593_0 XOR3 $PINS O=SUM[3] I1=A[3] I2=B[3] I3=carry[3]
XFE_RC_592_0 MAO222P $PINS O=carry[4] A1=B[3] B1=carry[3] C1=A[3]
XFE_RC_569_0 XOR3 $PINS O=SUM[4] I1=A[4] I2=B[4] I3=carry[4]
XFE_RC_568_0 MAO222P $PINS O=carry[5] A1=carry[4] B1=B[4] C1=A[4]
XFE_RC_507_0 XOR3 $PINS O=SUM[5] I1=A[5] I2=B[5] I3=carry[5]
XFE_RC_506_0 MAO222P $PINS O=carry[6] A1=carry[5] B1=B[5] C1=A[5]
XFE_RC_480_0 XOR3 $PINS O=SUM[6] I1=A[6] I2=B[6] I3=carry[6]
XFE_RC_479_0 MAO222P $PINS O=carry[7] A1=carry[6] B1=B[6] C1=A[6]
XFE_RC_386_0 XOR3 $PINS O=SUM[25] I1=A[25] I2=B[25] I3=carry[25]
XFE_RC_385_0 MAO222P $PINS O=carry[26] A1=carry[25] B1=B[25] C1=A[25]
XFE_RC_384_0 XOR3 $PINS O=SUM[8] I1=A[8] I2=B[8] I3=carry[8]
XFE_RC_383_0 MAO222P $PINS O=carry[9] A1=carry[8] B1=B[8] C1=A[8]
XFE_RC_276_0 XOR3 $PINS O=SUM[11] I1=A[11] I2=B[11] I3=carry[11]
XFE_RC_275_0 MAO222P $PINS O=carry[12] A1=carry[11] B1=B[11] C1=A[11]
XFE_RC_274_0 XOR3 $PINS O=SUM[9] I1=A[9] I2=B[9] I3=carry[9]
XFE_RC_273_0 MAO222P $PINS O=carry[10] A1=carry[9] B1=B[9] C1=A[9]
XFE_RC_205_0 XOR3 $PINS O=SUM[19] I1=B[19] I2=A[19] I3=carry[19]
XFE_RC_204_0 MAO222 $PINS O=carry[20] A1=carry[19] B1=A[19] C1=B[19]
XFE_RC_201_0 XOR3 $PINS O=SUM[22] I1=A[22] I2=B[22] I3=carry[22]
XFE_RC_200_0 MAO222P $PINS O=carry[23] A1=carry[22] B1=B[22] C1=A[22]
XFE_RC_135_0 XOR3 $PINS O=SUM[20] I1=A[20] I2=B[20] I3=carry[20]
XFE_RC_134_0 MAO222P $PINS O=carry[21] A1=carry[20] B1=B[20] C1=A[20]
XFE_RC_95_0 XOR3 $PINS O=SUM[23] I1=A[23] I2=B[23] I3=carry[23]
XFE_RC_94_0 MAO222P $PINS O=carry[24] A1=carry[23] B1=B[23] C1=A[23]
XFE_RC_49_0 XOR3 $PINS O=SUM[21] I1=A[21] I2=B[21] I3=carry[21]
XFE_RC_48_0 MAO222P $PINS O=carry[22] A1=carry[21] B1=B[21] C1=A[21]
XFE_RC_45_0 XOR3 $PINS O=SUM[24] I1=A[24] I2=B[24] I3=carry[24]
XFE_RC_44_0 MAO222P $PINS O=carry[25] A1=carry[24] B1=B[24] C1=A[24]
XU1_16 FA1S $PINS S=SUM[16] CO=carry[17] A=A[16] B=B[16] CI=carry[16]
XU1 ND3P $PINS O=carry[16] I1=n1 I2=n2 I3=n3
XU2 ND3P $PINS O=carry[8] I1=n19 I2=n20 I3=n21
XU3 ND3P $PINS O=carry[19] I1=n17 I2=n18 I3=n16
XU4 ND2 $PINS O=n14 I1=n9 I2=B[17]
XU6 ND2 $PINS O=n1 I1=carry[15] I2=B[15]
XU7 ND2 $PINS O=n2 I1=carry[15] I2=A[15]
XU8 ND2 $PINS O=n3 I1=B[15] I2=A[15]
XU10 ND2 $PINS O=n12 I1=A[17] I2=B[17]
XU11 XOR3 $PINS O=SUM[14] I1=A[14] I2=B[14] I3=carry[14]
XU12 XOR3 $PINS O=SUM[17] I1=A[17] I2=B[17] I3=carry[17]
XU13 ND2 $PINS O=n18 I1=carry[18] I2=B[18]
XU15 XOR3 $PINS O=SUM[12] I1=A[12] I2=B[12] I3=carry[12]
XU16 XOR3S $PINS O=SUM[7] I1=B[7] I2=A[7] I3=carry[7]
XU17 XOR3 $PINS O=SUM[10] I1=A[10] I2=B[10] I3=carry[10]
XU18 ND3P $PINS O=carry[11] I1=n22 I2=n23 I3=n24
XU19 XOR2HS $PINS O=n5 I1=B[13] I2=A[13]
XU20 XOR2HS $PINS O=SUM[13] I1=carry[13] I2=n5
XU21 ND2 $PINS O=n6 I1=carry[13] I2=B[13]
XU22 ND2 $PINS O=n7 I1=carry[13] I2=A[13]
XU23 ND2 $PINS O=n8 I1=B[13] I2=A[13]
XU24 ND3P $PINS O=carry[14] I1=n7 I2=n6 I3=n8
XU25 MAO222 $PINS O=n9 A1=carry[16] B1=B[16] C1=A[16]
XU26 MAO222 $PINS O=n10 A1=carry[16] B1=B[16] C1=A[16]
XU28 ND2P $PINS O=n13 I1=n10 I2=A[17]
XU29 XOR2HS $PINS O=n15 I1=A[18] I2=B[18]
XU30 XOR2HS $PINS O=SUM[18] I1=n15 I2=carry[18]
XU31 ND2 $PINS O=n16 I1=A[18] I2=B[18]
XU33 ND2 $PINS O=n19 I1=carry[7] I2=B[7]
XU34 ND2P $PINS O=n20 I1=carry[7] I2=A[7]
XU35 ND2 $PINS O=n21 I1=A[7] I2=B[7]
XU36 ND2 $PINS O=n22 I1=carry[10] I2=A[10]
XU37 ND2P $PINS O=n23 I1=carry[10] I2=B[10]
XU38 ND2 $PINS O=n24 I1=B[10] I2=A[10]
XU43 ND2 $PINS O=n28 I1=carry[14] I2=A[14]
XU44 ND2 $PINS O=n29 I1=carry[14] I2=B[14]
XU45 ND2 $PINS O=n30 I1=A[14] I2=B[14]
XU46 ND3P $PINS O=carry[15] I1=n29 I2=n28 I3=n30
XU47 XOR2HS $PINS O=SUM[0] I1=B[0] I2=A[0]
XU5 ND2 $PINS O=n17 I1=carry[18] I2=A[18]
XU9 ND3P $PINS O=carry[18] I1=n14 I2=n13 I3=n12
XU32 XOR3S $PINS O=SUM[15] I1=A[15] I2=B[15] I3=carry[15]
.ENDS

.SUBCKT PE_Shift_Add_7 rst_n en clear calc_done stage_sel x_in[16] x_in[15]
+ x_in[14] x_in[13] x_in[12] x_in[11] x_in[10] x_in[9] x_in[8] x_in[7] x_in[6]
+ x_in[5] x_in[4] x_in[3] x_in[2] x_in[1] x_in[0] sign1[1] sign1[0] sign2[1]
+ sign2[0] sign3[1] sign3[0] shf1[3] shf1[2] shf1[1] shf1[0] shf2[3] shf2[2]
+ shf2[1] shf2[0] shf3[3] shf3[2] shf3[1] shf3[0] y_out[16] y_out[15] y_out[14]
+ y_out[13] y_out[12] y_out[11] y_out[10] y_out[9] y_out[8] y_out[7] y_out[6]
+ y_out[5] y_out[4] y_out[3] y_out[2] y_out[1] y_out[0] i_rst_n
+ FE_OFN12_i_rst_n FE_OFN8_i_rst_n FE_OFN39_FE_DBTN10_n289 FE_OFN43_s03_0
+ FE_OFN74_n FE_OFN70_n FE_OFN83_n FE_OFN116_mac_in_real_3 clk clk_clone2
+ clk_clone1
XFE_PHC1292_N245 DELC $PINS O=FE_PHN1292_N245 I=N245
XFE_PHC1289_N242 DELB $PINS O=N242 I=FE_PHN1289_N242
XFE_PHC1288_N243 DELB $PINS O=N243 I=FE_PHN1288_N243
XFE_PHC1286_N244 DELB $PINS O=N244 I=FE_PHN1286_N244
XFE_PHC1196_pe_r0_9 DELC $PINS O=y_out[9] I=FE_PHN1196_pe_r0_9
XFE_PHC1136_acc_reg_22 DELB $PINS O=acc_reg[22] I=FE_PHN1136_acc_reg_22
XFE_PHC1104_acc_reg_23 DELB $PINS O=FE_PHN1104_acc_reg_23 I=acc_reg[23]
XFE_PHC1075_acc_reg_24 DELB $PINS O=FE_PHN1075_acc_reg_24 I=acc_reg[24]
XFE_PHC1058_next_acc_0 DELB $PINS O=FE_PHN1058_next_acc_0 I=next_acc[0]
XFE_PHC1034_acc_reg_25 DELB $PINS O=acc_reg[25] I=FE_PHN1034_acc_reg_25
XFE_PHC995_N235 DELB $PINS O=FE_PHN995_N235 I=N235
XFE_PHC988_N239 DELB $PINS O=N239 I=FE_PHN988_N239
XFE_PHC973_N236 DELB $PINS O=FE_PHN973_N236 I=N236
XFE_PHC967_N238 DELB $PINS O=N238 I=FE_PHN967_N238
XFE_PHC959_N237 DELB $PINS O=N237 I=FE_PHN959_N237
XFE_PHC958_N240 DELB $PINS O=FE_PHN958_N240 I=N240
XFE_PHC942_N241 DELB $PINS O=FE_PHN942_N241 I=N241
XFE_PHC888_acc_reg_21 DELB $PINS O=FE_PHN888_acc_reg_21 I=acc_reg[21]
XFE_PHC720_N251 DELC $PINS O=FE_PHN720_N251 I=N251
XFE_RC_1846_0 INV3 $PINS O=n58 I=FE_RN_515_0
XFE_RC_1845_0 NR2T $PINS O=FE_RN_515_0 I1=shf1[1] I2=FE_RN_454_0
XFE_RC_1832_0 INV2CK $PINS O=sll_16/ML_int[1][2] I=FE_RN_509_0
XFE_RC_1831_0 MXL2HS $PINS OB=FE_RN_509_0 S=shf1[0] A=term1_in[2] B=term1_in[1]
XFE_RC_1826_0 INV2 $PINS O=FE_RN_506_0 I=sll_17/ML_int[2][4]
XFE_RC_1825_0 MXL2H $PINS OB=sll_17/ML_int[3][4] S=FE_OFN190_h02_2
+ A=FE_RN_506_0 B=n3
XFE_RC_1824_0 INV2CK $PINS O=FE_RN_505_0 I=FE_RN_496_0
XFE_RC_1823_0 NR2P $PINS O=term3_shifted[2] I1=FE_RN_505_0 I2=n78
XFE_RC_1822_0 MXL2H $PINS OB=FE_RN_501_0 S=FE_OFN43_s03_0 A=FE_RN_502_0 B=N125
XFE_RC_1816_0 INV2 $PINS O=N152 I=FE_RN_501_0
XFE_RC_1815_0 AN2T $PINS O=FE_RN_502_0 I1=n11 I2=FE_RN_368_0
XFE_RC_1806_0 MUX2 $PINS O=FE_RN_496_0 S=FE_OFN203_h03_1 A=sll_18/ML_int[1][2]
+ B=sll_18/ML_int[1][0]
XFE_RC_1803_0 INV1S $PINS O=FE_RN_495_0 I=n36
XFE_RC_1802_0 AN2B1T $PINS O=term2_shifted[4] I1=sll_17/ML_int[3][4]
+ B1=FE_RN_495_0
XFE_RC_1801_0 INV1S $PINS O=FE_RN_494_0 I=sll_16/ML_int[2][3]
XFE_RC_1800_0 NR2P $PINS O=term1_shifted[3] I1=FE_RN_494_0 I2=n59
XFE_RC_1799_0 AN3 $PINS O=FE_RN_493_0 I1=sll_18/ML_int[3][4] I2=n28
+ I3=FE_OFN361_FE_DBTN28_s03_0
XFE_RC_1798_0 AO12 $PINS O=N155 A1=FE_RN_493_0 B1=N128 B2=sign3[0]
XFE_RC_1797_0 INV1S $PINS O=FE_RN_492_0 I=n107
XFE_RC_1796_0 AN2B1T $PINS O=term2_shifted[0] I1=sll_17/ML_int[1][0]
+ B1=FE_RN_492_0
XFE_RC_1743_0 AN2B1T $PINS O=term2_shifted[2] I1=sll_17/ML_int[2][2] B1=n67
XFE_RC_1727_0 AN2B1T $PINS O=term3_shifted[3] I1=sll_18/ML_int[2][3] B1=n78
XFE_RC_1723_0 MXL2H $PINS OB=FE_RN_454_0 S=shf1[0] A=term1_in[1] B=term1_in[0]
XCTS_ccl_a_INV_CLK_G1_L8_91 INV4CK $PINS O=CTS_10 I=CTS_11
XCTS_ccl_a_INV_CLK_G1_L7_93 INV2CK $PINS O=CTS_11 I=CTS_12
XFE_RC_1554_0 AN2B1S $PINS O=FE_RN_368_0 I1=n27 B1=n78
XFE_RC_1529_0 INV2 $PINS O=sll_16/ML_int[3][4] I=FE_RN_354_0
XFE_RC_1528_0 MXL2HS $PINS OB=FE_RN_354_0 S=shf1[2] A=sll_16/ML_int[2][4] B=n17
XFE_RC_1519_0 INV2 $PINS O=N154 I=FE_RN_351_0
XFE_RC_1518_0 AOI22H $PINS O=FE_RN_351_0 A1=N127 A2=FE_OFN43_s03_0
+ B1=term3_shifted[3] B2=FE_DBTN28_s03_0
XFE_RC_1517_0 OR2B1S $PINS O=FE_RN_350_0 I1=FE_OFN291_s03_1 B1=n27
XFE_RC_1516_0 OR3 $PINS O=n76 I1=FE_RN_350_0 I2=shf3[0] I3=x_in[0]
XFE_RC_1515_0 INV2 $PINS O=N101 I=FE_RN_349_0
XFE_RC_1514_0 AOI22H $PINS O=FE_RN_349_0 A1=N74 A2=sign2[0] B1=term2_shifted[5]
+ B2=n39
XFE_RC_1497_0 AO22P $PINS O=N100 A1=N73 A2=sign2[0] B1=term2_shifted[4] B2=n39
XFE_RC_1365_0 INV1S $PINS O=N47 I=FE_RN_289_0
XFE_RC_1364_0 AOI22S $PINS O=FE_RN_289_0 A1=N20 A2=sign1[0] B1=term1_shifted[6]
+ B2=FE_OFN83_n
XFE_RC_1361_0 AN2S $PINS O=FE_RN_288_0 I1=term1_shifted[3] I2=FE_OFN83_n
XFE_RC_1360_0 AO12T $PINS O=N44 A1=FE_RN_288_0 B1=N17 B2=sign1[0]
XFE_RC_1292_0 NR4 $PINS O=term1_shifted[0] I1=n16 I2=FE_OFN237_s01_1 I3=x_in[0]
+ I4=shf1[0]
XFE_RC_1279_0 INV1S $PINS O=FE_RN_255_0 I=FE_RN_176_0
XFE_RC_1278_0 MUXB2 $PINS O=term2_shifted[3] S=FE_OFN212_h02_1
+ A=sll_17/ML_int[1][3] B=FE_RN_255_0 EB=n67
XFE_RC_1249_0 ND2P $PINS O=FE_RN_242_0 I1=N71 I2=sign2[0]
XFE_RC_1248_0 OR3B1 $PINS O=FE_RN_243_0 I1=n67 I2=n69 B1=n39
XFE_RC_1247_0 ND2P $PINS O=N98 I1=FE_RN_243_0 I2=FE_RN_242_0
XFE_RC_1231_0 ND2P $PINS O=FE_RN_231_0 I1=N70 I2=sign2[0]
XFE_RC_1230_0 OR3B2 $PINS O=FE_RN_232_0 I1=FE_RN_176_0 B1=n107 B2=n39
XFE_RC_1229_0 ND2P $PINS O=N97 I1=FE_RN_231_0 I2=FE_RN_232_0
XFE_RC_1192_0 INV2 $PINS O=N45 I=FE_RN_211_0
XFE_RC_1191_0 AOI22H $PINS O=FE_RN_211_0 A1=N18 A2=sign1[0] B1=term1_shifted[4]
+ B2=FE_OFN83_n
XFE_RC_1145_0 INV1S $PINS O=sll_18/ML_int[1][4] I=FE_RN_192_0
XFE_RC_1144_0 MXL2HS $PINS OB=FE_RN_192_0 S=FE_OFN245_h03_0 A=term3_in[4]
+ B=term3_in[3]
XFE_RC_1099_0 MXL2HS $PINS OB=FE_RN_176_0 S=shf2[0] A=term2_in[1] B=term2_in[0]
XFE_RC_1082_0 INV2 $PINS O=sll_17/ML_int[2][2] I=FE_RN_167_0
XFE_RC_1081_0 MXL2HS $PINS OB=FE_RN_167_0 S=FE_OFN212_h02_1
+ A=sll_17/ML_int[1][2] B=sll_17/ML_int[1][0]
XFE_RC_0_0 OA12 $PINS O=N96 A1=N69 B1=sign2[0] B2=n39
XFE_OFC686_h02_2 BUF1 $PINS O=FE_OFN366_n I=FE_OFN190_h02_2
XFE_OFC682_FE_DBTN28_s03_0 BUF1 $PINS O=FE_OFN362_FE_DBTN28_s03_0
+ I=FE_OFN361_FE_DBTN28_s03_0
XFE_OFC681_FE_DBTN28_s03_0 BUF1 $PINS O=FE_OFN361_FE_DBTN28_s03_0
+ I=FE_DBTN28_s03_0
XFE_OFC674_s01_0 INV1S $PINS O=FE_OFN274_FE_DBTN29_s01_0 I=sign1[0]
XFE_OFC666_h01_2 BUF1 $PINS O=FE_OFN356_n I=shf1[2]
XFE_OFC660_s01_1 BUF2 $PINS O=FE_OFN237_s01_1 I=sign1[1]
XFE_OFC575_sll_17_ML_int_2__3 INV1S $PINS O=n68 I=sll_17/ML_int[2][3]
XFE_OFC501_h02_3 INV2 $PINS O=n36 I=shf2[3]
XFE_OFC474_s03_1 BUF2 $PINS O=FE_OFN291_s03_1 I=sign3[1]
XFE_OFC466_h03_2 BUF1 $PINS O=FE_OFN283_h03_2 I=shf3[2]
XFE_OFC421_h03_0 BUF1 $PINS O=FE_OFN245_h03_0 I=shf3[0]
XFE_OFC419_h03_0 INV1S $PINS O=n25 I=shf3[0]
XFE_OFC345_h02_1 BUF1 $PINS O=FE_OFN213_h02_1 I=FE_OFN212_h02_1
XFE_OFC343_h02_1 BUF1 $PINS O=FE_OFN212_h02_1 I=shf2[1]
XFE_OFC324_h03_1 INV2 $PINS O=FE_OFN203_h03_1 I=n27
XFE_OFC321_h03_1 INV1S $PINS O=n27 I=shf3[1]
XFE_OFC320_term3_shifted_1 INV2 $PINS O=FE_DBTN20_term3_shifted_1 I=FE_RN_502_0
XFE_OFC278_h02_2 INV1S $PINS O=FE_OFN190_h02_2 I=n34
XFE_OFC276_h02_2 INV1S $PINS O=n34 I=shf2[2]
XFE_OFC259_h03_3 INV1S $PINS O=FE_OFN182_h03_3 I=n28
XFE_OFC257_h03_3 INV1S $PINS O=n28 I=shf3[3]
XFE_OFC244_s03_0 BUF1 $PINS O=FE_OFN174_s03_0 I=sign3[0]
XFE_OFC242_s03_0 INV1S $PINS O=FE_DBTN28_s03_0 I=sign3[0]
XFE_OFC239_h01_3 INV1S $PINS O=FE_OFN172_h01_3 I=n46
XFE_OFC237_h01_3 INV1S $PINS O=n46 I=shf1[3]
XFE_OFC211_s01_0 BUF1 $PINS O=FE_OFN159_s01_0 I=sign1[0]
XFE_OFC203_s02_0 INV1S $PINS O=FE_OFN156_s02_0 I=n39
XFE_OFC202_s02_0 INV2 $PINS O=n39 I=sign2[0]
XU110 AO22 $PINS O=base_val[13] A1=acc_reg[13] A2=FE_OFN70_n B1=clear
+ B2=stage_sel
XU111 AO22 $PINS O=N99 A1=N72 A2=sign2[0] B1=term2_shifted[3] B2=n39
XU115 AO22 $PINS O=N67 A1=FE_OFN159_s01_0 A2=N40 B1=term1_shifted[26]
+ B2=FE_OFN274_FE_DBTN29_s01_0
XU134 AO22 $PINS O=N48 A1=N21 A2=FE_OFN159_s01_0 B1=term1_shifted[7]
+ B2=FE_OFN83_n
XU136 AO22P $PINS O=N46 A1=N19 A2=sign1[0] B1=term1_shifted[5] B2=FE_OFN83_n
XU142 AO22 $PINS O=N177 A1=FE_OFN174_s03_0 A2=N150 B1=term3_shifted[26]
+ B2=FE_OFN362_FE_DBTN28_s03_0
XU143 AO22 $PINS O=N176 A1=N149 A2=FE_OFN174_s03_0 B1=term3_shifted[25]
+ B2=FE_OFN362_FE_DBTN28_s03_0
XU144 AO22 $PINS O=N175 A1=N148 A2=FE_OFN174_s03_0 B1=term3_shifted[24]
+ B2=FE_OFN362_FE_DBTN28_s03_0
XU145 AO22 $PINS O=N174 A1=N147 A2=FE_OFN174_s03_0 B1=term3_shifted[23]
+ B2=FE_OFN362_FE_DBTN28_s03_0
XU146 AO22 $PINS O=N173 A1=N146 A2=FE_OFN174_s03_0 B1=term3_shifted[22]
+ B2=FE_OFN362_FE_DBTN28_s03_0
XU147 AO22 $PINS O=N172 A1=N145 A2=FE_OFN174_s03_0 B1=term3_shifted[21]
+ B2=FE_OFN362_FE_DBTN28_s03_0
XU149 AO22 $PINS O=N170 A1=N143 A2=FE_OFN174_s03_0 B1=term3_shifted[19]
+ B2=FE_OFN362_FE_DBTN28_s03_0
XU150 AO22 $PINS O=N169 A1=N142 A2=FE_OFN174_s03_0 B1=term3_shifted[18]
+ B2=FE_OFN362_FE_DBTN28_s03_0
XU151 AO22 $PINS O=N168 A1=N141 A2=FE_OFN174_s03_0 B1=term3_shifted[17]
+ B2=FE_OFN361_FE_DBTN28_s03_0
XU152 AO22 $PINS O=N167 A1=N140 A2=FE_OFN174_s03_0 B1=term3_shifted[16]
+ B2=FE_OFN361_FE_DBTN28_s03_0
XU153 AO22 $PINS O=N166 A1=N139 A2=FE_OFN174_s03_0 B1=term3_shifted[15]
+ B2=FE_OFN361_FE_DBTN28_s03_0
XU154 AO22 $PINS O=N165 A1=N138 A2=FE_OFN174_s03_0 B1=term3_shifted[14]
+ B2=FE_OFN361_FE_DBTN28_s03_0
XU155 AO22 $PINS O=N164 A1=N137 A2=FE_OFN174_s03_0 B1=term3_shifted[13]
+ B2=FE_OFN361_FE_DBTN28_s03_0
XU156 AO22 $PINS O=N163 A1=N136 A2=FE_OFN174_s03_0 B1=term3_shifted[12]
+ B2=FE_OFN361_FE_DBTN28_s03_0
XU157 AO22 $PINS O=N162 A1=N135 A2=FE_OFN174_s03_0 B1=term3_shifted[11]
+ B2=FE_OFN361_FE_DBTN28_s03_0
XU158 AO22 $PINS O=N161 A1=N134 A2=FE_OFN174_s03_0 B1=term3_shifted[10]
+ B2=FE_OFN361_FE_DBTN28_s03_0
XU159 AO22 $PINS O=N160 A1=N133 A2=sign3[0] B1=term3_shifted[9]
+ B2=FE_OFN361_FE_DBTN28_s03_0
XU161 AO22 $PINS O=N158 A1=N131 A2=sign3[0] B1=term3_shifted[7]
+ B2=FE_OFN361_FE_DBTN28_s03_0
XU162 AO22 $PINS O=N157 A1=N130 A2=sign3[0] B1=term3_shifted[6]
+ B2=FE_OFN361_FE_DBTN28_s03_0
XU163 AO22 $PINS O=N156 A1=N129 A2=sign3[0] B1=term3_shifted[5]
+ B2=FE_OFN361_FE_DBTN28_s03_0
XU169 AO22 $PINS O=N122 A1=N95 A2=FE_OFN156_s02_0 B1=term2_shifted[26] B2=n39
XU170 AO22 $PINS O=N121 A1=N94 A2=FE_OFN156_s02_0 B1=term2_shifted[25] B2=n39
XU171 AO22 $PINS O=N120 A1=N93 A2=FE_OFN156_s02_0 B1=term2_shifted[24] B2=n39
XU172 AO22 $PINS O=N119 A1=N92 A2=FE_OFN156_s02_0 B1=term2_shifted[23] B2=n39
XU173 AO22 $PINS O=N118 A1=N91 A2=FE_OFN156_s02_0 B1=term2_shifted[22] B2=n39
XU174 AO22 $PINS O=N117 A1=N90 A2=FE_OFN156_s02_0 B1=term2_shifted[21] B2=n39
XU175 AO22 $PINS O=N116 A1=N89 A2=FE_OFN156_s02_0 B1=term2_shifted[20] B2=n39
XU176 AO22 $PINS O=N115 A1=N88 A2=FE_OFN156_s02_0 B1=term2_shifted[19] B2=n39
XU177 AO22 $PINS O=N114 A1=N87 A2=FE_OFN156_s02_0 B1=term2_shifted[18] B2=n39
XU178 AO22 $PINS O=N113 A1=N86 A2=FE_OFN156_s02_0 B1=term2_shifted[17] B2=n39
XU179 AO22 $PINS O=N112 A1=N85 A2=FE_OFN156_s02_0 B1=term2_shifted[16] B2=n39
XU184 AO22 $PINS O=N107 A1=N80 A2=FE_OFN156_s02_0 B1=term2_shifted[11] B2=n39
XU187 AO22 $PINS O=N104 A1=N77 A2=sign2[0] B1=term2_shifted[8] B2=n39
XU188 AO22 $PINS O=N103 A1=N76 A2=sign2[0] B1=term2_shifted[7] B2=n39
XU189 AO22 $PINS O=N102 A1=N75 A2=sign2[0] B1=term2_shifted[6] B2=n39
Xsll_18/M1_0_2 MUX2 $PINS O=sll_18/ML_int[1][2] S=shf3[0] A=term3_in[2]
+ B=term3_in[1]
Xsll_18/M1_0_5 MUX2 $PINS O=sll_18/ML_int[1][5] S=FE_OFN245_h03_0 A=term3_in[5]
+ B=term3_in[4]
Xsll_18/M1_0_6 MUX2 $PINS O=sll_18/ML_int[1][6] S=FE_OFN245_h03_0 A=term3_in[6]
+ B=term3_in[5]
Xsll_18/M1_1_4 MUX2 $PINS O=sll_18/ML_int[2][4] S=FE_OFN203_h03_1
+ A=sll_18/ML_int[1][4] B=sll_18/ML_int[1][2]
Xsll_18/M1_1_5 MUX2 $PINS O=sll_18/ML_int[2][5] S=FE_OFN203_h03_1
+ A=sll_18/ML_int[1][5] B=sll_18/ML_int[1][3]
Xsll_18/M1_1_6 MUX2 $PINS O=sll_18/ML_int[2][6] S=FE_OFN203_h03_1
+ A=sll_18/ML_int[1][6] B=sll_18/ML_int[1][4]
Xsll_18/M1_1_7 MUX2 $PINS O=sll_18/ML_int[2][7] S=FE_OFN203_h03_1
+ A=sll_18/ML_int[1][7] B=sll_18/ML_int[1][5]
Xsll_18/M1_2_4 MUX2 $PINS O=sll_18/ML_int[3][4] S=shf3[2] A=sll_18/ML_int[2][4]
+ B=n81
Xsll_18/M1_2_5 MUX2 $PINS O=sll_18/ML_int[3][5] S=shf3[2] A=sll_18/ML_int[2][5]
+ B=n82
Xsll_18/M1_2_7 MUX2 $PINS O=sll_18/ML_int[3][7] S=shf3[2] A=sll_18/ML_int[2][7]
+ B=sll_18/ML_int[2][3]
Xsll_18/M1_2_8 MUX2 $PINS O=sll_18/ML_int[3][8] S=shf3[2] A=sll_18/ML_int[2][8]
+ B=sll_18/ML_int[2][4]
Xsll_18/M1_2_9 MUX2 $PINS O=sll_18/ML_int[3][9] S=shf3[2] A=sll_18/ML_int[2][9]
+ B=sll_18/ML_int[2][5]
Xsll_18/M1_3_8 MUX2 $PINS O=term3_shifted[8] S=FE_OFN182_h03_3
+ A=sll_18/ML_int[3][8] B=sll_18/ML_int[3][0]
Xsll_18/M1_3_9 MUX2 $PINS O=term3_shifted[9] S=FE_OFN182_h03_3
+ A=sll_18/ML_int[3][9] B=sll_18/ML_int[3][1]
Xsll_18/M1_3_10 MUX2 $PINS O=term3_shifted[10] S=FE_OFN182_h03_3
+ A=sll_18/ML_int[3][10] B=sll_18/ML_int[3][2]
Xsll_18/M1_3_11 MUX2 $PINS O=term3_shifted[11] S=FE_OFN182_h03_3
+ A=sll_18/ML_int[3][11] B=sll_18/ML_int[3][3]
Xsll_18/M1_3_12 MUX2 $PINS O=term3_shifted[12] S=FE_OFN182_h03_3
+ A=sll_18/ML_int[3][12] B=sll_18/ML_int[3][4]
Xsll_18/M1_3_13 MUX2 $PINS O=term3_shifted[13] S=FE_OFN182_h03_3
+ A=sll_18/ML_int[3][13] B=sll_18/ML_int[3][5]
Xsll_18/M1_3_20 MUX2 $PINS O=term3_shifted[20] S=FE_OFN182_h03_3
+ A=sll_18/ML_int[3][20] B=sll_18/ML_int[3][12]
Xsll_18/M1_3_21 MUX2 $PINS O=term3_shifted[21] S=FE_OFN182_h03_3
+ A=sll_18/ML_int[3][21] B=sll_18/ML_int[3][13]
Xsll_18/M1_3_22 MUX2 $PINS O=term3_shifted[22] S=FE_OFN182_h03_3
+ A=sll_18/ML_int[3][22] B=sll_18/ML_int[3][14]
Xsll_18/M1_3_23 MUX2 $PINS O=term3_shifted[23] S=FE_OFN182_h03_3 A=term3_in[26]
+ B=sll_18/ML_int[3][15]
Xsll_17/M1_0_2 MUX2 $PINS O=sll_17/ML_int[1][2] S=shf2[0] A=term2_in[2]
+ B=term2_in[1]
Xsll_17/M1_0_3 MUX2 $PINS O=sll_17/ML_int[1][3] S=shf2[0] A=term2_in[3]
+ B=term2_in[2]
Xsll_17/M1_0_4 MUX2 $PINS O=sll_17/ML_int[1][4] S=shf2[0] A=term2_in[4]
+ B=term2_in[3]
Xsll_17/M1_0_5 MUX2 $PINS O=sll_17/ML_int[1][5] S=shf2[0] A=term2_in[5]
+ B=term2_in[4]
Xsll_17/M1_0_6 MUX2 $PINS O=sll_17/ML_int[1][6] S=shf2[0] A=term2_in[6]
+ B=term2_in[5]
Xsll_17/M1_2_5 MUX2 $PINS O=sll_17/ML_int[3][5] S=FE_OFN190_h02_2
+ A=sll_17/ML_int[2][5] B=n71
Xsll_17/M1_2_7 MUX2 $PINS O=sll_17/ML_int[3][7] S=FE_OFN190_h02_2
+ A=sll_17/ML_int[2][7] B=sll_17/ML_int[2][3]
Xsll_17/M1_2_8 MUX2 $PINS O=sll_17/ML_int[3][8] S=FE_OFN190_h02_2
+ A=sll_17/ML_int[2][8] B=sll_17/ML_int[2][4]
Xsll_17/M1_2_9 MUX2 $PINS O=sll_17/ML_int[3][9] S=FE_OFN366_n
+ A=sll_17/ML_int[2][9] B=sll_17/ML_int[2][5]
Xsll_17/M1_3_8 MUX2 $PINS O=term2_shifted[8] S=FE_RN_495_0
+ A=sll_17/ML_int[3][8] B=sll_17/ML_int[3][0]
Xsll_17/M1_3_9 MUX2 $PINS O=term2_shifted[9] S=FE_RN_495_0
+ A=sll_17/ML_int[3][9] B=sll_17/ML_int[3][1]
Xsll_17/M1_3_10 MUX2 $PINS O=term2_shifted[10] S=FE_RN_495_0
+ A=sll_17/ML_int[3][10] B=sll_17/ML_int[3][2]
Xsll_17/M1_3_11 MUX2 $PINS O=term2_shifted[11] S=FE_RN_495_0
+ A=sll_17/ML_int[3][11] B=sll_17/ML_int[3][3]
Xsll_17/M1_3_12 MUX2 $PINS O=term2_shifted[12] S=FE_RN_495_0
+ A=sll_17/ML_int[3][12] B=sll_17/ML_int[3][4]
Xsll_17/M1_3_13 MUX2 $PINS O=term2_shifted[13] S=FE_RN_495_0
+ A=sll_17/ML_int[3][13] B=sll_17/ML_int[3][5]
Xsll_17/M1_3_20 MUX2 $PINS O=term2_shifted[20] S=FE_RN_495_0
+ A=sll_17/ML_int[3][20] B=sll_17/ML_int[3][12]
Xsll_17/M1_3_21 MUX2 $PINS O=term2_shifted[21] S=FE_RN_495_0
+ A=sll_17/ML_int[3][21] B=sll_17/ML_int[3][13]
Xsll_17/M1_3_22 MUX2 $PINS O=term2_shifted[22] S=FE_RN_495_0
+ A=sll_17/ML_int[3][22] B=sll_17/ML_int[3][14]
Xsll_17/M1_3_23 MUX2 $PINS O=term2_shifted[23] S=FE_RN_495_0 A=term2_in[26]
+ B=sll_17/ML_int[3][15]
Xsll_16/M1_0_3 MUX2 $PINS O=sll_16/ML_int[1][3] S=shf1[0] A=term1_in[3]
+ B=term1_in[2]
Xsll_16/M1_0_4 MUX2 $PINS O=sll_16/ML_int[1][4] S=shf1[0] A=term1_in[4]
+ B=term1_in[3]
Xsll_16/M1_0_6 MUX2 $PINS O=sll_16/ML_int[1][6] S=shf1[0] A=term1_in[6]
+ B=term1_in[5]
Xsll_16/M1_0_7 MUX2 $PINS O=sll_16/ML_int[1][7] S=shf1[0] A=term1_in[7]
+ B=term1_in[6]
Xsll_16/M1_1_4 MUX2 $PINS O=sll_16/ML_int[2][4] S=shf1[1] A=sll_16/ML_int[1][4]
+ B=sll_16/ML_int[1][2]
Xsll_16/M1_1_5 MUX2 $PINS O=sll_16/ML_int[2][5] S=shf1[1] A=sll_16/ML_int[1][5]
+ B=sll_16/ML_int[1][3]
Xsll_16/M1_1_6 MUX2 $PINS O=sll_16/ML_int[2][6] S=shf1[1] A=sll_16/ML_int[1][6]
+ B=sll_16/ML_int[1][4]
Xsll_16/M1_1_7 MUX2 $PINS O=sll_16/ML_int[2][7] S=shf1[1] A=sll_16/ML_int[1][7]
+ B=sll_16/ML_int[1][5]
Xsll_16/M1_1_8 MUX2 $PINS O=sll_16/ML_int[2][8] S=shf1[1] A=sll_16/ML_int[1][8]
+ B=sll_16/ML_int[1][6]
Xsll_16/M1_2_5 MUX2 $PINS O=sll_16/ML_int[3][5] S=shf1[2] A=sll_16/ML_int[2][5]
+ B=n61
Xsll_16/M1_2_7 MUX2 $PINS O=sll_16/ML_int[3][7] S=shf1[2] A=sll_16/ML_int[2][7]
+ B=sll_16/ML_int[2][3]
Xsll_16/M1_2_8 MUX2 $PINS O=sll_16/ML_int[3][8] S=shf1[2] A=sll_16/ML_int[2][8]
+ B=sll_16/ML_int[2][4]
Xsll_16/M1_2_9 MUX2 $PINS O=sll_16/ML_int[3][9] S=FE_OFN356_n
+ A=sll_16/ML_int[2][9] B=sll_16/ML_int[2][5]
Xsll_16/M1_2_10 MUX2 $PINS O=sll_16/ML_int[3][10] S=FE_OFN356_n
+ A=sll_16/ML_int[2][10] B=sll_16/ML_int[2][6]
Xsll_16/M1_3_8 MUX2 $PINS O=term1_shifted[8] S=FE_OFN172_h01_3
+ A=sll_16/ML_int[3][8] B=sll_16/ML_int[3][0]
Xsll_16/M1_3_9 MUX2 $PINS O=term1_shifted[9] S=FE_OFN172_h01_3
+ A=sll_16/ML_int[3][9] B=sll_16/ML_int[3][1]
Xsll_16/M1_3_10 MUX2 $PINS O=term1_shifted[10] S=FE_OFN172_h01_3
+ A=sll_16/ML_int[3][10] B=sll_16/ML_int[3][2]
Xsll_16/M1_3_11 MUX2 $PINS O=term1_shifted[11] S=FE_OFN172_h01_3
+ A=sll_16/ML_int[3][11] B=sll_16/ML_int[3][3]
Xsll_16/M1_3_12 MUX2 $PINS O=term1_shifted[12] S=FE_OFN172_h01_3
+ A=sll_16/ML_int[3][12] B=sll_16/ML_int[3][4]
Xsll_16/M1_3_13 MUX2 $PINS O=term1_shifted[13] S=FE_OFN172_h01_3
+ A=sll_16/ML_int[3][13] B=sll_16/ML_int[3][5]
Xsll_16/M1_3_14 MUX2 $PINS O=term1_shifted[14] S=FE_OFN172_h01_3
+ A=sll_16/ML_int[3][14] B=sll_16/ML_int[3][6]
Xsll_16/M1_3_20 MUX2 $PINS O=term1_shifted[20] S=FE_OFN172_h01_3
+ A=sll_16/ML_int[3][20] B=sll_16/ML_int[3][12]
Xsll_16/M1_3_21 MUX2 $PINS O=term1_shifted[21] S=FE_OFN172_h01_3
+ A=sll_16/ML_int[3][21] B=sll_16/ML_int[3][13]
Xsll_16/M1_3_22 MUX2 $PINS O=term1_shifted[22] S=FE_OFN172_h01_3
+ A=sll_16/ML_int[3][22] B=sll_16/ML_int[3][14]
Xsll_16/M1_3_23 MUX2 $PINS O=term1_shifted[23] S=FE_OFN172_h01_3 A=term1_in[26]
+ B=sll_16/ML_int[3][15]
Xy_out_reg[0] QDFFRBN $PINS Q=y_out[0] D=FE_PHN995_N235 CK=CTS_10 RB=i_rst_n
Xy_out_reg[9] QDFFRBN $PINS Q=FE_PHN1196_pe_r0_9 D=N244 CK=CTS_10 RB=i_rst_n
Xy_out_reg[8] QDFFRBN $PINS Q=y_out[8] D=N243 CK=CTS_10 RB=i_rst_n
Xy_out_reg[7] QDFFRBN $PINS Q=y_out[7] D=N242 CK=CTS_10 RB=i_rst_n
Xy_out_reg[6] QDFFRBN $PINS Q=y_out[6] D=FE_PHN942_N241 CK=CTS_10 RB=i_rst_n
Xy_out_reg[5] QDFFRBN $PINS Q=y_out[5] D=FE_PHN958_N240 CK=CTS_10 RB=i_rst_n
Xy_out_reg[4] QDFFRBN $PINS Q=y_out[4] D=N239 CK=CTS_10 RB=i_rst_n
Xy_out_reg[3] QDFFRBN $PINS Q=y_out[3] D=N238 CK=CTS_10 RB=i_rst_n
Xy_out_reg[2] QDFFRBN $PINS Q=y_out[2] D=N237 CK=CTS_10 RB=i_rst_n
Xy_out_reg[1] QDFFRBN $PINS Q=y_out[1] D=FE_PHN973_N236 CK=CTS_10 RB=i_rst_n
Xacc_reg_reg[25] QDFFRBN $PINS Q=FE_PHN1034_acc_reg_25 D=next_acc[25]
+ CK=clk_clone2 RB=i_rst_n
Xy_out_reg[16] QDFFRBN $PINS Q=y_out[16] D=FE_PHN720_N251 CK=CTS_10 RB=i_rst_n
Xacc_reg_reg[24] QDFFRBN $PINS Q=acc_reg[24] D=next_acc[24] CK=clk_clone2
+ RB=i_rst_n
Xy_out_reg[10] QDFFRBN $PINS Q=y_out[10] D=FE_PHN1292_N245 CK=CTS_10 RB=i_rst_n
Xy_out_reg[11] QDFFRBN $PINS Q=y_out[11] D=N246 CK=CTS_10 RB=i_rst_n
Xy_out_reg[12] QDFFRBN $PINS Q=y_out[12] D=N247 CK=CTS_10 RB=i_rst_n
Xy_out_reg[14] QDFFRBN $PINS Q=y_out[14] D=N249 CK=CTS_10 RB=i_rst_n
Xy_out_reg[15] QDFFRBN $PINS Q=y_out[15] D=N250 CK=CTS_10 RB=i_rst_n
Xy_out_reg[13] QDFFRBN $PINS Q=y_out[13] D=N248 CK=CTS_10 RB=i_rst_n
Xacc_reg_reg[23] QDFFRBN $PINS Q=acc_reg[23] D=next_acc[23] CK=clk_clone2
+ RB=i_rst_n
Xacc_reg_reg[22] QDFFRBN $PINS Q=FE_PHN1136_acc_reg_22 D=next_acc[22]
+ CK=clk_clone2 RB=i_rst_n
Xacc_reg_reg[21] QDFFRBN $PINS Q=acc_reg[21] D=next_acc[21] CK=clk_clone2
+ RB=i_rst_n
Xacc_reg_reg[20] QDFFRBN $PINS Q=acc_reg[20] D=next_acc[20] CK=clk_clone2
+ RB=i_rst_n
Xacc_reg_reg[19] QDFFRBN $PINS Q=acc_reg[19] D=next_acc[19] CK=clk_clone2
+ RB=i_rst_n
Xacc_reg_reg[18] QDFFRBN $PINS Q=acc_reg[18] D=next_acc[18] CK=clk_clone2
+ RB=i_rst_n
Xacc_reg_reg[17] QDFFRBN $PINS Q=acc_reg[17] D=next_acc[17] CK=clk_clone2
+ RB=i_rst_n
Xacc_reg_reg[16] QDFFRBN $PINS Q=acc_reg[16] D=next_acc[16] CK=clk_clone2
+ RB=i_rst_n
Xacc_reg_reg[15] QDFFRBN $PINS Q=acc_reg[15] D=next_acc[15] CK=clk_clone2
+ RB=i_rst_n
Xacc_reg_reg[14] QDFFRBN $PINS Q=acc_reg[14] D=next_acc[14] CK=clk_clone2
+ RB=FE_OFN12_i_rst_n
Xacc_reg_reg[13] QDFFRBN $PINS Q=acc_reg[13] D=next_acc[13] CK=clk_clone2
+ RB=FE_OFN12_i_rst_n
Xacc_reg_reg[12] QDFFRBN $PINS Q=acc_reg[12] D=next_acc[12] CK=clk_clone2
+ RB=FE_OFN12_i_rst_n
Xacc_reg_reg[11] QDFFRBN $PINS Q=acc_reg[11] D=next_acc[11] CK=clk_clone2
+ RB=FE_OFN12_i_rst_n
Xacc_reg_reg[10] QDFFRBN $PINS Q=acc_reg[10] D=next_acc[10] CK=clk_clone2
+ RB=FE_OFN12_i_rst_n
Xacc_reg_reg[9] QDFFRBN $PINS Q=acc_reg[9] D=next_acc[9] CK=clk_clone2
+ RB=FE_OFN12_i_rst_n
Xacc_reg_reg[8] QDFFRBN $PINS Q=acc_reg[8] D=next_acc[8] CK=clk_clone2
+ RB=FE_OFN12_i_rst_n
Xacc_reg_reg[7] QDFFRBN $PINS Q=acc_reg[7] D=next_acc[7] CK=clk_clone2
+ RB=FE_OFN12_i_rst_n
Xacc_reg_reg[6] QDFFRBN $PINS Q=acc_reg[6] D=next_acc[6] CK=clk_clone2
+ RB=FE_OFN8_i_rst_n
Xacc_reg_reg[5] QDFFRBN $PINS Q=acc_reg[5] D=next_acc[5] CK=clk
+ RB=FE_OFN8_i_rst_n
Xacc_reg_reg[4] QDFFRBN $PINS Q=acc_reg[4] D=next_acc[4] CK=clk_clone2
+ RB=FE_OFN8_i_rst_n
Xacc_reg_reg[3] QDFFRBN $PINS Q=acc_reg[3] D=next_acc[3] CK=clk_clone2
+ RB=FE_OFN8_i_rst_n
Xacc_reg_reg[2] QDFFRBN $PINS Q=acc_reg[2] D=next_acc[2] CK=clk_clone2
+ RB=FE_OFN8_i_rst_n
Xacc_reg_reg[1] QDFFRBN $PINS Q=acc_reg[1] D=next_acc[1] CK=clk_clone2
+ RB=FE_OFN8_i_rst_n
Xacc_reg_reg[0] QDFFRBS $PINS Q=acc_reg[0] D=FE_PHN1058_next_acc_0
+ CK=clk_clone2 RB=FE_OFN8_i_rst_n
XU8 AN2 $PINS O=sll_16/ML_int[1][0] I1=term1_in[0] I2=n43
XU9 NR2P $PINS O=term1_shifted[2] I1=n59 I2=n10
XU13 OR2 $PINS O=n78 I1=shf3[2] I2=shf3[3]
XU16 AN2 $PINS O=base_val[7] I1=acc_reg[7] I2=FE_OFN74_n
XU17 MUX2 $PINS O=N248 S=FE_OFN39_FE_DBTN10_n289 A=FE_PHN1104_acc_reg_23
+ B=FE_PHN720_N251
XU18 INV1S $PINS O=n8 I=sll_17/ML_int[1][0]
XU20 OR2 $PINS O=n59 I1=shf1[2] I2=shf1[3]
XU21 MUX2 $PINS O=N250 S=FE_OFN39_FE_DBTN10_n289 A=acc_reg[25] B=FE_PHN720_N251
XU24 AN2T $PINS O=term2_shifted[1] I1=FE_RN_255_0 I2=n107
XU26 AN2 $PINS O=base_val[8] I1=acc_reg[8] I2=FE_OFN74_n
XU27 MUX2 $PINS O=N249 S=FE_OFN39_FE_DBTN10_n289 A=FE_PHN1075_acc_reg_24
+ B=FE_PHN720_N251
XU29 INV1S $PINS O=n4 I=FE_RN_255_0
XU32 MUX2 $PINS O=N247 S=FE_OFN39_FE_DBTN10_n289 A=acc_reg[22] B=FE_PHN720_N251
XU35 NR2 $PINS O=term3_in[0] I1=FE_OFN291_s03_1 I2=x_in[0]
XU37 MOAI1H $PINS O=N151 A1=N124 A2=FE_DBTN28_s03_0 B1=n6 B2=FE_DBTN28_s03_0
XU38 MOAI1 $PINS O=N41 A1=N14 A2=FE_OFN83_n B1=term1_shifted[0] B2=FE_OFN83_n
XU39 NR2T $PINS O=term1_in[0] I1=FE_OFN237_s01_1 I2=x_in[0]
XU41 MUX2 $PINS O=sll_18/ML_int[2][2] S=FE_OFN203_h03_1 A=sll_18/ML_int[1][2]
+ B=sll_18/ML_int[1][0]
XU42 INV1S $PINS O=n79 I=sll_18/ML_int[2][3]
XU43 INV1S $PINS O=n60 I=sll_16/ML_int[2][3]
XU50 NR2 $PINS O=term2_in[0] I1=sign2[1] I2=x_in[0]
XU53 AN2 $PINS O=sll_18/ML_int[1][0] I1=term3_in[0] I2=n25
XU55 MUX2 $PINS O=sll_16/ML_int[1][1] S=shf1[0] A=term1_in[1] B=term1_in[0]
XU56 OR2 $PINS O=n16 I1=n59 I2=shf1[1]
XU58 NR2 $PINS O=n17 I1=n15 I2=shf1[1]
XU60 NR2 $PINS O=term3_in[4] I1=FE_OFN291_s03_1 I2=x_in[4]
XU66 ND2 $PINS O=n77 I1=sll_18/ML_int[1][1] I2=n27
XU69 INV1S $PINS O=n57 I=n17
XU70 AO22 $PINS O=N110 A1=N83 A2=FE_OFN156_s02_0 B1=term2_shifted[14] B2=n39
XU71 AN2 $PINS O=base_val[14] I1=acc_reg[14] I2=FE_OFN70_n
XU74 AO22 $PINS O=N43 A1=N16 A2=sign1[0] B1=term1_shifted[2] B2=FE_OFN83_n
XU75 AN2 $PINS O=base_val[2] I1=acc_reg[2] I2=FE_OFN74_n
XU76 AO22 $PINS O=N159 A1=N132 A2=sign3[0] B1=term3_shifted[8]
+ B2=FE_OFN361_FE_DBTN28_s03_0
XU77 AO22 $PINS O=N106 A1=N79 A2=FE_OFN156_s02_0 B1=term2_shifted[10] B2=n39
XU78 AO22 $PINS O=N51 A1=N24 A2=FE_OFN159_s01_0 B1=term1_shifted[10]
+ B2=FE_OFN274_FE_DBTN29_s01_0
XU79 AO22 $PINS O=N109 A1=N82 A2=FE_OFN156_s02_0 B1=term2_shifted[13] B2=n39
XU80 AO22 $PINS O=N171 A1=N144 A2=FE_OFN174_s03_0 B1=term3_shifted[20]
+ B2=FE_OFN362_FE_DBTN28_s03_0
XU81 NR2 $PINS O=term3_in[2] I1=FE_OFN291_s03_1 I2=x_in[2]
XU85 MOAI1S $PINS O=base_val[9] A1=stage_sel A2=FE_OFN74_n B1=acc_reg[9]
+ B2=FE_OFN74_n
XU87 MUX2S $PINS O=sll_18/ML_int[3][6] S=shf3[2] A=sll_18/ML_int[2][6]
+ B=sll_18/ML_int[2][2]
XU89 MUX2 $PINS O=sll_16/ML_int[1][5] S=shf1[0] A=term1_in[5] B=term1_in[4]
XU91 AO22 $PINS O=N49 A1=N22 A2=FE_OFN159_s01_0 B1=term1_shifted[8]
+ B2=FE_OFN83_n
XU92 NR2 $PINS O=n6 I1=n78 I2=n76
XU93 OR2S $PINS O=n7 I1=n59 I2=n58
XU95 MXL2HS $PINS OB=n10 S=shf1[1] A=sll_16/ML_int[1][2] B=sll_16/ML_int[1][0]
XU96 AO22 $PINS O=N111 A1=N84 A2=FE_OFN156_s02_0 B1=term2_shifted[15] B2=n39
XU97 ND2 $PINS O=n11 I1=n19 I2=n18
XU98 MUX2 $PINS O=sll_16/ML_int[2][3] S=shf1[1] A=sll_16/ML_int[1][3]
+ B=sll_16/ML_int[1][1]
XU99 INV1S $PINS O=n14 I=n10
XU100 MUX2 $PINS O=sll_16/ML_int[3][6] S=shf1[2] A=sll_16/ML_int[2][6] B=n14
XU103 MUX2S $PINS O=sll_17/ML_int[3][6] S=FE_OFN190_h02_2 A=sll_17/ML_int[2][6]
+ B=sll_17/ML_int[2][2]
XU104 AO22 $PINS O=N105 A1=N78 A2=FE_OFN156_s02_0 B1=term2_shifted[9] B2=n39
XU105 AO22S $PINS O=N108 A1=N81 A2=FE_OFN156_s02_0 B1=term2_shifted[12] B2=n39
XU106 MUX2 $PINS O=sll_18/ML_int[2][3] S=FE_OFN203_h03_1 A=sll_18/ML_int[1][3]
+ B=sll_18/ML_int[1][1]
XU107 NR2 $PINS O=term1_in[6] I1=FE_OFN237_s01_1 I2=x_in[6]
XU108 NR2 $PINS O=term1_in[4] I1=FE_OFN237_s01_1 I2=x_in[4]
XU109 NR2 $PINS O=term1_in[5] I1=FE_OFN237_s01_1 I2=x_in[5]
XU112 AO22 $PINS O=N50 A1=N23 A2=FE_OFN159_s01_0 B1=term1_shifted[9]
+ B2=FE_OFN83_n
XU114 AO22 $PINS O=N52 A1=N25 A2=FE_OFN159_s01_0 B1=term1_shifted[11]
+ B2=FE_OFN274_FE_DBTN29_s01_0
XU116 AO22 $PINS O=N53 A1=N26 A2=FE_OFN159_s01_0 B1=term1_shifted[12]
+ B2=FE_OFN274_FE_DBTN29_s01_0
XU117 AN2 $PINS O=base_val[3] I1=acc_reg[3] I2=FE_OFN74_n
XU118 AN2 $PINS O=base_val[4] I1=acc_reg[4] I2=FE_OFN74_n
XU119 AN2 $PINS O=base_val[0] I1=acc_reg[0] I2=FE_OFN74_n
XU120 MUX2S $PINS O=N235 S=stage_sel A=acc_reg[10] B=acc_reg[14]
XU121 MUX2S $PINS O=N236 S=stage_sel A=acc_reg[11] B=acc_reg[15]
XU122 MUX2S $PINS O=FE_PHN959_N237 S=stage_sel A=acc_reg[12] B=acc_reg[16]
XU123 MUX2S $PINS O=FE_PHN967_N238 S=stage_sel A=acc_reg[13] B=acc_reg[17]
XU124 MUX2S $PINS O=FE_PHN988_N239 S=stage_sel A=acc_reg[14] B=acc_reg[18]
XU125 MUX2S $PINS O=N240 S=stage_sel A=acc_reg[15] B=acc_reg[19]
XU126 MUX2S $PINS O=FE_PHN1289_N242 S=stage_sel A=acc_reg[17]
+ B=FE_PHN888_acc_reg_21
XU127 MUX2S $PINS O=N245 S=FE_OFN39_FE_DBTN10_n289 A=acc_reg[20]
+ B=FE_PHN1075_acc_reg_24
XU128 MUX2S $PINS O=N246 S=FE_OFN39_FE_DBTN10_n289 A=FE_PHN888_acc_reg_21
+ B=acc_reg[25]
XU129 MUX2S $PINS O=sll_18/ML_int[1][7] S=FE_OFN245_h03_0 A=term3_in[7]
+ B=term3_in[6]
XU130 MUX2S $PINS O=sll_17/ML_int[1][7] S=shf2[0] A=term2_in[7] B=term2_in[6]
XU131 MUX2S $PINS O=sll_16/ML_int[1][8] S=shf1[0] A=term1_in[8] B=term1_in[7]
XU132 MUX2S $PINS O=sll_18/ML_int[2][8] S=FE_OFN203_h03_1 A=sll_18/ML_int[1][8]
+ B=sll_18/ML_int[1][6]
XU133 MUX2S $PINS O=sll_18/ML_int[1][8] S=FE_OFN245_h03_0 A=term3_in[8]
+ B=term3_in[7]
XU139 MUX2S $PINS O=sll_17/ML_int[2][8] S=FE_OFN212_h02_1 A=sll_17/ML_int[1][8]
+ B=sll_17/ML_int[1][6]
XU140 MUX2S $PINS O=sll_17/ML_int[1][8] S=shf2[0] A=term2_in[8] B=term2_in[7]
XU141 MUX2S $PINS O=sll_16/ML_int[2][9] S=shf1[1] A=sll_16/ML_int[1][9]
+ B=sll_16/ML_int[1][7]
XU148 MUX2S $PINS O=sll_16/ML_int[1][9] S=shf1[0] A=term1_in[9] B=term1_in[8]
XU160 MUX2S $PINS O=sll_18/ML_int[2][9] S=FE_OFN203_h03_1 A=sll_18/ML_int[1][9]
+ B=sll_18/ML_int[1][7]
XU166 MUX2S $PINS O=sll_18/ML_int[1][9] S=FE_OFN245_h03_0 A=term3_in[9]
+ B=term3_in[8]
XU167 MUX2S $PINS O=sll_17/ML_int[2][9] S=FE_OFN213_h02_1 A=sll_17/ML_int[1][9]
+ B=sll_17/ML_int[1][7]
XU168 MUX2S $PINS O=sll_17/ML_int[1][9] S=shf2[0] A=term2_in[9] B=term2_in[8]
XU180 MUX2S $PINS O=sll_16/ML_int[2][10] S=shf1[1] A=sll_16/ML_int[1][10]
+ B=sll_16/ML_int[1][8]
XU181 MUX2S $PINS O=sll_16/ML_int[1][10] S=shf1[0] A=term1_in[10] B=term1_in[9]
XU182 MUX2S $PINS O=sll_18/ML_int[3][10] S=shf3[2] A=sll_18/ML_int[2][10]
+ B=sll_18/ML_int[2][6]
XU183 MUX2S $PINS O=sll_18/ML_int[2][10] S=FE_OFN203_h03_1
+ A=sll_18/ML_int[1][10] B=sll_18/ML_int[1][8]
XU185 MUX2 $PINS O=sll_18/ML_int[1][10] S=FE_OFN245_h03_0 A=term3_in[10]
+ B=term3_in[9]
XU186 MUX2S $PINS O=sll_17/ML_int[3][10] S=FE_OFN366_n A=sll_17/ML_int[2][10]
+ B=sll_17/ML_int[2][6]
XU192 MUX2S $PINS O=sll_17/ML_int[2][10] S=FE_OFN213_h02_1
+ A=sll_17/ML_int[1][10] B=sll_17/ML_int[1][8]
XU193 MUX2S $PINS O=sll_17/ML_int[1][10] S=shf2[0] A=term2_in[10] B=term2_in[9]
XU194 MUX2S $PINS O=sll_16/ML_int[3][11] S=FE_OFN356_n A=sll_16/ML_int[2][11]
+ B=sll_16/ML_int[2][7]
XU195 MUX2S $PINS O=sll_16/ML_int[2][11] S=shf1[1] A=sll_16/ML_int[1][11]
+ B=sll_16/ML_int[1][9]
XU196 MUX2S $PINS O=sll_18/ML_int[3][11] S=FE_OFN283_h03_2
+ A=sll_18/ML_int[2][11] B=sll_18/ML_int[2][7]
XU197 MUX2S $PINS O=sll_18/ML_int[2][11] S=FE_OFN203_h03_1
+ A=sll_18/ML_int[1][11] B=sll_18/ML_int[1][9]
XU198 MUX2S $PINS O=sll_17/ML_int[3][11] S=FE_OFN366_n A=sll_17/ML_int[2][11]
+ B=sll_17/ML_int[2][7]
XU199 MUX2S $PINS O=sll_17/ML_int[2][11] S=FE_OFN213_h02_1
+ A=sll_17/ML_int[1][11] B=sll_17/ML_int[1][9]
XU200 MUX2S $PINS O=sll_16/ML_int[1][11] S=shf1[0] A=term1_in[11]
+ B=term1_in[10]
XU201 MUX2S $PINS O=sll_18/ML_int[1][11] S=FE_OFN245_h03_0 A=term3_in[11]
+ B=term3_in[10]
XU202 MUX2S $PINS O=sll_17/ML_int[1][11] S=shf2[0] A=term2_in[11]
+ B=term2_in[10]
XU203 MUX2S $PINS O=sll_16/ML_int[3][12] S=FE_OFN356_n A=sll_16/ML_int[2][12]
+ B=sll_16/ML_int[2][8]
XU204 MUX2S $PINS O=sll_16/ML_int[2][12] S=shf1[1] A=sll_16/ML_int[1][12]
+ B=sll_16/ML_int[1][10]
XU205 MUX2S $PINS O=sll_18/ML_int[3][12] S=FE_OFN283_h03_2
+ A=sll_18/ML_int[2][12] B=sll_18/ML_int[2][8]
XU206 MUX2S $PINS O=sll_18/ML_int[2][12] S=FE_OFN203_h03_1
+ A=sll_18/ML_int[1][12] B=sll_18/ML_int[1][10]
XU207 MUX2S $PINS O=sll_17/ML_int[3][12] S=FE_OFN366_n A=sll_17/ML_int[2][12]
+ B=sll_17/ML_int[2][8]
XU208 MUX2S $PINS O=sll_17/ML_int[2][12] S=FE_OFN213_h02_1
+ A=sll_17/ML_int[1][12] B=sll_17/ML_int[1][10]
XU209 MUX2S $PINS O=sll_16/ML_int[1][12] S=shf1[0] A=term1_in[12]
+ B=term1_in[11]
XU210 MUX2S $PINS O=sll_18/ML_int[1][12] S=FE_OFN245_h03_0 A=term3_in[12]
+ B=term3_in[11]
XU211 MUX2S $PINS O=sll_17/ML_int[1][12] S=shf2[0] A=term2_in[12]
+ B=term2_in[11]
XU212 MUX2S $PINS O=sll_16/ML_int[3][13] S=FE_OFN356_n A=sll_16/ML_int[2][13]
+ B=sll_16/ML_int[2][9]
XU213 MUX2S $PINS O=sll_18/ML_int[3][13] S=FE_OFN283_h03_2
+ A=sll_18/ML_int[2][13] B=sll_18/ML_int[2][9]
XU214 MUX2S $PINS O=sll_17/ML_int[3][13] S=FE_OFN366_n A=sll_17/ML_int[2][13]
+ B=sll_17/ML_int[2][9]
XU215 MUX2S $PINS O=sll_16/ML_int[2][13] S=shf1[1] A=sll_16/ML_int[1][13]
+ B=sll_16/ML_int[1][11]
XU216 MUX2S $PINS O=sll_16/ML_int[1][13] S=shf1[0] A=term1_in[13]
+ B=term1_in[12]
XU217 MUX2S $PINS O=sll_18/ML_int[2][13] S=FE_OFN203_h03_1
+ A=sll_18/ML_int[1][13] B=sll_18/ML_int[1][11]
XU218 MUX2S $PINS O=sll_18/ML_int[1][13] S=FE_OFN245_h03_0 A=term3_in[13]
+ B=term3_in[12]
XU219 MUX2S $PINS O=sll_17/ML_int[2][13] S=FE_OFN213_h02_1
+ A=sll_17/ML_int[1][13] B=sll_17/ML_int[1][11]
XU220 MUX2S $PINS O=sll_17/ML_int[1][13] S=shf2[0] A=term2_in[13]
+ B=term2_in[12]
XU221 MUX2S $PINS O=sll_16/ML_int[3][14] S=FE_OFN356_n A=sll_16/ML_int[2][14]
+ B=sll_16/ML_int[2][10]
XU222 MUX2S $PINS O=term3_shifted[14] S=FE_OFN182_h03_3 A=sll_18/ML_int[3][14]
+ B=sll_18/ML_int[3][6]
XU223 MUX2S $PINS O=sll_18/ML_int[3][14] S=FE_OFN283_h03_2
+ A=sll_18/ML_int[2][14] B=sll_18/ML_int[2][10]
XU224 MUX2S $PINS O=sll_16/ML_int[2][14] S=shf1[1] A=sll_16/ML_int[1][14]
+ B=sll_16/ML_int[1][12]
XU225 MUX2S $PINS O=sll_16/ML_int[1][14] S=shf1[0] A=term1_in[14]
+ B=term1_in[13]
XU226 MUX2S $PINS O=term2_shifted[14] S=FE_RN_495_0 A=sll_17/ML_int[3][14]
+ B=sll_17/ML_int[3][6]
XU227 MUX2S $PINS O=sll_17/ML_int[3][14] S=FE_OFN366_n A=sll_17/ML_int[2][14]
+ B=sll_17/ML_int[2][10]
XU228 MUX2S $PINS O=sll_18/ML_int[2][14] S=FE_OFN203_h03_1
+ A=sll_18/ML_int[1][14] B=sll_18/ML_int[1][12]
XU229 MUX2S $PINS O=sll_18/ML_int[1][14] S=FE_OFN245_h03_0 A=term3_in[14]
+ B=term3_in[13]
XU230 MUX2S $PINS O=sll_17/ML_int[2][14] S=FE_OFN213_h02_1
+ A=sll_17/ML_int[1][14] B=sll_17/ML_int[1][12]
XU231 MUX2S $PINS O=sll_17/ML_int[1][14] S=shf2[0] A=term2_in[14]
+ B=term2_in[13]
XU232 MUX2S $PINS O=term1_shifted[16] S=FE_OFN172_h01_3 A=sll_16/ML_int[3][16]
+ B=sll_16/ML_int[3][8]
XU233 MUX2S $PINS O=sll_16/ML_int[3][16] S=FE_OFN356_n A=n62
+ B=sll_16/ML_int[2][12]
XU234 MUX2S $PINS O=term2_shifted[16] S=FE_RN_495_0 A=sll_17/ML_int[3][16]
+ B=sll_17/ML_int[3][8]
XU235 MUX2S $PINS O=sll_17/ML_int[3][16] S=FE_OFN366_n A=n72
+ B=sll_17/ML_int[2][12]
XU236 MUX2S $PINS O=term3_shifted[16] S=FE_OFN182_h03_3 A=sll_18/ML_int[3][16]
+ B=sll_18/ML_int[3][8]
XU237 MUX2S $PINS O=sll_18/ML_int[3][16] S=FE_OFN283_h03_2 A=n83
+ B=sll_18/ML_int[2][12]
XU238 MUX2S $PINS O=term1_shifted[15] S=FE_OFN172_h01_3 A=sll_16/ML_int[3][15]
+ B=sll_16/ML_int[3][7]
XU239 MUX2S $PINS O=sll_16/ML_int[3][15] S=FE_OFN356_n A=sll_16/ML_int[2][15]
+ B=sll_16/ML_int[2][11]
XU240 MUX2S $PINS O=term2_shifted[15] S=FE_RN_495_0 A=sll_17/ML_int[3][15]
+ B=sll_17/ML_int[3][7]
XU241 MUX2S $PINS O=sll_17/ML_int[3][15] S=FE_OFN366_n A=sll_17/ML_int[2][15]
+ B=sll_17/ML_int[2][11]
XU242 MUX2S $PINS O=term3_shifted[15] S=FE_OFN182_h03_3 A=sll_18/ML_int[3][15]
+ B=sll_18/ML_int[3][7]
XU243 MUX2S $PINS O=sll_18/ML_int[3][15] S=FE_OFN283_h03_2
+ A=sll_18/ML_int[2][15] B=sll_18/ML_int[2][11]
XU244 MUX2S $PINS O=sll_16/ML_int[2][15] S=shf1[1] A=sll_16/ML_int[1][15]
+ B=sll_16/ML_int[1][13]
XU245 MUX2S $PINS O=sll_16/ML_int[1][15] S=shf1[0] A=term1_in[15]
+ B=term1_in[14]
XU246 MUX2S $PINS O=sll_17/ML_int[2][15] S=FE_OFN213_h02_1
+ A=sll_17/ML_int[1][15] B=sll_17/ML_int[1][13]
XU247 MUX2S $PINS O=sll_17/ML_int[1][15] S=shf2[0] A=term2_in[15]
+ B=term2_in[14]
XU248 MUX2S $PINS O=sll_18/ML_int[2][15] S=FE_OFN203_h03_1
+ A=sll_18/ML_int[1][15] B=sll_18/ML_int[1][13]
XU249 MUX2S $PINS O=sll_18/ML_int[1][15] S=FE_OFN245_h03_0 A=term3_in[15]
+ B=term3_in[14]
XU250 MUX2S $PINS O=term1_shifted[17] S=FE_OFN172_h01_3 A=sll_16/ML_int[3][17]
+ B=sll_16/ML_int[3][9]
XU251 MUX2S $PINS O=sll_16/ML_int[3][17] S=FE_OFN356_n A=n63
+ B=sll_16/ML_int[2][13]
XU252 MUX2S $PINS O=term2_shifted[17] S=FE_RN_495_0 A=sll_17/ML_int[3][17]
+ B=sll_17/ML_int[3][9]
XU253 MUX2S $PINS O=sll_17/ML_int[3][17] S=FE_OFN366_n A=n73
+ B=sll_17/ML_int[2][13]
XU254 MUX2S $PINS O=term3_shifted[17] S=FE_OFN182_h03_3 A=sll_18/ML_int[3][17]
+ B=sll_18/ML_int[3][9]
XU255 MUX2S $PINS O=sll_18/ML_int[3][17] S=FE_OFN283_h03_2 A=n84
+ B=sll_18/ML_int[2][13]
XU256 MUX2S $PINS O=term1_shifted[18] S=FE_OFN172_h01_3 A=sll_16/ML_int[3][18]
+ B=sll_16/ML_int[3][10]
XU257 MUX2S $PINS O=sll_16/ML_int[3][18] S=FE_OFN356_n A=n64
+ B=sll_16/ML_int[2][14]
XU258 MUX2S $PINS O=term2_shifted[18] S=FE_RN_495_0 A=sll_17/ML_int[3][18]
+ B=sll_17/ML_int[3][10]
XU259 MUX2S $PINS O=sll_17/ML_int[3][18] S=FE_OFN366_n A=n74
+ B=sll_17/ML_int[2][14]
XU260 MUX2S $PINS O=term3_shifted[18] S=FE_OFN182_h03_3 A=sll_18/ML_int[3][18]
+ B=sll_18/ML_int[3][10]
XU261 MUX2S $PINS O=sll_18/ML_int[3][18] S=FE_OFN283_h03_2 A=n85
+ B=sll_18/ML_int[2][14]
XU262 MUX2S $PINS O=sll_16/ML_int[3][20] S=FE_OFN356_n A=term1_in[26] B=n62
XU263 MUX2S $PINS O=sll_17/ML_int[3][20] S=FE_OFN366_n A=term2_in[26] B=n72
XU264 MUX2S $PINS O=sll_18/ML_int[3][20] S=FE_OFN283_h03_2 A=term3_in[26] B=n83
XU265 MUX2S $PINS O=term1_shifted[19] S=FE_OFN172_h01_3 A=sll_16/ML_int[3][19]
+ B=sll_16/ML_int[3][11]
XU266 MUX2S $PINS O=sll_16/ML_int[3][19] S=FE_OFN356_n A=term1_in[26]
+ B=sll_16/ML_int[2][15]
XU267 MUX2S $PINS O=term2_shifted[19] S=FE_RN_495_0 A=sll_17/ML_int[3][19]
+ B=sll_17/ML_int[3][11]
XU268 MUX2S $PINS O=sll_17/ML_int[3][19] S=FE_OFN366_n A=term2_in[26]
+ B=sll_17/ML_int[2][15]
XU269 MUX2S $PINS O=term3_shifted[19] S=FE_OFN182_h03_3 A=sll_18/ML_int[3][19]
+ B=sll_18/ML_int[3][11]
XU270 MUX2S $PINS O=sll_18/ML_int[3][19] S=FE_OFN283_h03_2 A=term3_in[26]
+ B=sll_18/ML_int[2][15]
XU271 MUX2S $PINS O=sll_16/ML_int[3][21] S=FE_OFN356_n A=term1_in[26] B=n63
XU272 MUX2S $PINS O=sll_17/ML_int[3][21] S=FE_OFN366_n A=term2_in[26] B=n73
XU273 MUX2S $PINS O=sll_18/ML_int[3][21] S=FE_OFN283_h03_2 A=term3_in[26] B=n84
XU274 MUX2S $PINS O=sll_16/ML_int[3][22] S=FE_OFN356_n A=term1_in[26] B=n64
XU275 MUX2S $PINS O=sll_17/ML_int[3][22] S=FE_OFN366_n A=term2_in[26] B=n74
XU276 MUX2S $PINS O=sll_18/ML_int[3][22] S=FE_OFN283_h03_2 A=term3_in[26] B=n85
XU277 AO22 $PINS O=N54 A1=N27 A2=FE_OFN159_s01_0 B1=term1_shifted[13]
+ B2=FE_OFN274_FE_DBTN29_s01_0
XU278 AO22 $PINS O=N55 A1=N28 A2=FE_OFN159_s01_0 B1=term1_shifted[14]
+ B2=FE_OFN274_FE_DBTN29_s01_0
XU279 AO22 $PINS O=N56 A1=N29 A2=FE_OFN159_s01_0 B1=term1_shifted[15]
+ B2=FE_OFN274_FE_DBTN29_s01_0
XU280 AO22 $PINS O=N57 A1=N30 A2=FE_OFN159_s01_0 B1=term1_shifted[16]
+ B2=FE_OFN274_FE_DBTN29_s01_0
XU281 AO22 $PINS O=N59 A1=N32 A2=FE_OFN159_s01_0 B1=term1_shifted[18]
+ B2=FE_OFN274_FE_DBTN29_s01_0
XU282 AO22 $PINS O=N60 A1=N33 A2=FE_OFN159_s01_0 B1=term1_shifted[19]
+ B2=FE_OFN274_FE_DBTN29_s01_0
XU283 AO22 $PINS O=N61 A1=N34 A2=FE_OFN159_s01_0 B1=term1_shifted[20]
+ B2=FE_OFN274_FE_DBTN29_s01_0
XU284 AO22 $PINS O=N62 A1=N35 A2=FE_OFN159_s01_0 B1=term1_shifted[21]
+ B2=FE_OFN274_FE_DBTN29_s01_0
XU285 AO22 $PINS O=N63 A1=N36 A2=FE_OFN159_s01_0 B1=term1_shifted[22]
+ B2=FE_OFN274_FE_DBTN29_s01_0
XU286 AO22 $PINS O=N64 A1=N37 A2=FE_OFN159_s01_0 B1=term1_shifted[23]
+ B2=FE_OFN274_FE_DBTN29_s01_0
XU287 AO22 $PINS O=N65 A1=N38 A2=FE_OFN159_s01_0 B1=term1_shifted[24]
+ B2=FE_OFN274_FE_DBTN29_s01_0
XU288 AO22S $PINS O=N66 A1=N39 A2=FE_OFN159_s01_0 B1=term1_shifted[25]
+ B2=FE_OFN274_FE_DBTN29_s01_0
XU297 INV1S $PINS O=n81 I=n76
XU298 INV1S $PINS O=n61 I=n58
XU299 INV1S $PINS O=n71 I=n66
XU300 NR2F $PINS O=term1_in[1] I1=FE_OFN237_s01_1 I2=x_in[1]
XU301 NR2 $PINS O=term2_in[1] I1=sign2[1] I2=x_in[1]
XU302 NR2 $PINS O=term1_in[3] I1=FE_OFN237_s01_1 I2=FE_OFN116_mac_in_real_3
XU303 NR2 $PINS O=term1_in[2] I1=FE_OFN237_s01_1 I2=x_in[2]
XU304 NR2 $PINS O=term2_in[4] I1=sign2[1] I2=x_in[4]
XU305 NR2 $PINS O=term3_in[3] I1=FE_OFN291_s03_1 I2=FE_OFN116_mac_in_real_3
XU306 NR2 $PINS O=term2_in[2] I1=sign2[1] I2=x_in[2]
XU307 NR2 $PINS O=term2_in[3] I1=sign2[1] I2=FE_OFN116_mac_in_real_3
XU308 NR2 $PINS O=term2_in[5] I1=sign2[1] I2=x_in[5]
XU309 NR2 $PINS O=term3_in[5] I1=FE_OFN291_s03_1 I2=x_in[5]
XU310 NR2 $PINS O=term2_in[6] I1=sign2[1] I2=x_in[6]
XU311 NR2 $PINS O=term3_in[6] I1=FE_OFN291_s03_1 I2=x_in[6]
XU312 NR2 $PINS O=term1_in[7] I1=FE_OFN237_s01_1 I2=x_in[7]
XU313 NR2 $PINS O=term2_in[7] I1=sign2[1] I2=x_in[7]
XU314 NR2 $PINS O=term3_in[7] I1=FE_OFN291_s03_1 I2=x_in[7]
XU315 NR2 $PINS O=term1_in[8] I1=FE_OFN237_s01_1 I2=x_in[8]
XU316 NR2 $PINS O=term2_in[8] I1=sign2[1] I2=x_in[8]
XU317 NR2 $PINS O=term3_in[8] I1=FE_OFN291_s03_1 I2=x_in[8]
XU320 NR2 $PINS O=term1_in[9] I1=FE_OFN237_s01_1 I2=x_in[9]
XU322 NR2 $PINS O=term2_in[9] I1=sign2[1] I2=x_in[9]
XU323 NR2 $PINS O=term3_in[9] I1=FE_OFN291_s03_1 I2=x_in[9]
XU325 NR2 $PINS O=term1_in[10] I1=FE_OFN237_s01_1 I2=x_in[10]
XU326 NR2 $PINS O=term2_in[10] I1=sign2[1] I2=x_in[10]
XU327 NR2 $PINS O=term3_in[10] I1=FE_OFN291_s03_1 I2=x_in[10]
XU328 NR2 $PINS O=term1_in[11] I1=FE_OFN237_s01_1 I2=x_in[11]
XU329 NR2 $PINS O=term2_in[11] I1=sign2[1] I2=x_in[11]
XU330 NR2 $PINS O=term3_in[11] I1=FE_OFN291_s03_1 I2=x_in[11]
XU331 NR2 $PINS O=term1_in[12] I1=FE_OFN237_s01_1 I2=x_in[12]
XU332 NR2 $PINS O=term2_in[12] I1=sign2[1] I2=x_in[12]
XU333 NR2 $PINS O=term3_in[12] I1=FE_OFN291_s03_1 I2=x_in[12]
XU334 NR2 $PINS O=term1_in[13] I1=FE_OFN237_s01_1 I2=n90
XU335 NR2 $PINS O=term2_in[13] I1=sign2[1] I2=n90
XU336 NR2 $PINS O=term3_in[13] I1=FE_OFN291_s03_1 I2=n90
XU338 NR2 $PINS O=term1_in[14] I1=FE_OFN237_s01_1 I2=n91
XU340 NR2 $PINS O=term2_in[14] I1=sign2[1] I2=n91
XU341 NR2 $PINS O=term3_in[14] I1=FE_OFN291_s03_1 I2=n91
XU342 NR2 $PINS O=term1_in[15] I1=FE_OFN237_s01_1 I2=n92
XU343 NR2 $PINS O=term2_in[15] I1=sign2[1] I2=n92
XU344 NR2 $PINS O=term3_in[15] I1=FE_OFN291_s03_1 I2=n92
XU345 NR2 $PINS O=term1_in[26] I1=n93 I2=FE_OFN237_s01_1
XU346 NR2 $PINS O=term2_in[26] I1=n93 I2=sign2[1]
XU347 NR2 $PINS O=term3_in[26] I1=n93 I2=FE_OFN291_s03_1
XU352 INV1S $PINS O=n43 I=shf1[0]
XU372 INV1S $PINS O=n90 I=x_in[13]
XU373 INV1S $PINS O=n91 I=x_in[14]
XU374 INV1S $PINS O=n92 I=x_in[15]
XU375 INV1S $PINS O=n93 I=x_in[16]
XU376 AN2 $PINS O=base_val[26] I1=N251 I2=FE_OFN70_n
XU377 AN2 $PINS O=base_val[1] I1=acc_reg[1] I2=FE_OFN74_n
XU378 AN2 $PINS O=base_val[10] I1=acc_reg[10] I2=FE_OFN74_n
XU379 AN2 $PINS O=base_val[11] I1=acc_reg[11] I2=FE_OFN74_n
XU380 AN2 $PINS O=base_val[12] I1=acc_reg[12] I2=FE_OFN74_n
XU381 AN2 $PINS O=base_val[15] I1=acc_reg[15] I2=FE_OFN70_n
XU382 AN2 $PINS O=base_val[16] I1=acc_reg[16] I2=FE_OFN70_n
XU383 AN2 $PINS O=base_val[17] I1=acc_reg[17] I2=FE_OFN70_n
XU384 AN2 $PINS O=base_val[18] I1=acc_reg[18] I2=FE_OFN70_n
XU385 AN2 $PINS O=base_val[19] I1=acc_reg[19] I2=FE_OFN70_n
XU386 AN2 $PINS O=base_val[20] I1=acc_reg[20] I2=FE_OFN70_n
XU387 AN2 $PINS O=base_val[21] I1=acc_reg[21] I2=FE_OFN70_n
XU388 AN2 $PINS O=base_val[22] I1=acc_reg[22] I2=FE_OFN70_n
XU389 AN2 $PINS O=base_val[23] I1=FE_PHN1104_acc_reg_23 I2=FE_OFN70_n
XU390 AN2 $PINS O=base_val[24] I1=FE_PHN1075_acc_reg_24 I2=FE_OFN70_n
XU391 AN2 $PINS O=base_val[25] I1=acc_reg[25] I2=FE_OFN70_n
XU392 AN2 $PINS O=base_val[6] I1=acc_reg[6] I2=FE_OFN74_n
XU393 AN2 $PINS O=base_val[5] I1=acc_reg[5] I2=FE_OFN74_n
XU395 AN2 $PINS O=N234 I1=en I2=calc_done
XU398 INV1S $PINS O=n82 I=n77
XU399 NR2 $PINS O=sll_16/ML_int[3][0] I1=shf1[2] I2=n57
XU400 NR2 $PINS O=sll_16/ML_int[3][1] I1=shf1[2] I2=n58
XU401 NR2 $PINS O=sll_16/ML_int[3][2] I1=shf1[2] I2=n10
XU402 NR2 $PINS O=sll_16/ML_int[3][3] I1=shf1[2] I2=n60
XU403 AN2 $PINS O=term1_shifted[4] I1=sll_16/ML_int[3][4] I2=n46
XU404 AN2 $PINS O=term1_shifted[5] I1=sll_16/ML_int[3][5] I2=n46
XU405 AN2 $PINS O=term1_shifted[6] I1=sll_16/ML_int[3][6] I2=n46
XU406 AN2 $PINS O=term1_shifted[7] I1=sll_16/ML_int[3][7] I2=n46
XU407 MUX2 $PINS O=term1_shifted[24] S=FE_OFN172_h01_3 A=term1_in[26]
+ B=sll_16/ML_int[3][16]
XU408 MUX2 $PINS O=n62 S=shf1[1] A=n65 B=sll_16/ML_int[1][14]
XU409 MUX2 $PINS O=term1_shifted[25] S=FE_OFN172_h01_3 A=term1_in[26]
+ B=sll_16/ML_int[3][17]
XU410 MUX2 $PINS O=n63 S=shf1[1] A=term1_in[26] B=sll_16/ML_int[1][15]
XU411 MUX2 $PINS O=term1_shifted[26] S=FE_OFN172_h01_3 A=term1_in[26]
+ B=sll_16/ML_int[3][18]
XU412 MUX2 $PINS O=n64 S=shf1[1] A=term1_in[26] B=n65
XU413 MUX2 $PINS O=n65 S=shf1[0] A=term1_in[26] B=term1_in[15]
XU414 NR2 $PINS O=sll_17/ML_int[3][0] I1=FE_OFN190_h02_2 I2=n3
XU415 NR2 $PINS O=sll_17/ML_int[3][1] I1=FE_OFN190_h02_2 I2=n66
XU416 NR2 $PINS O=sll_17/ML_int[3][2] I1=FE_OFN190_h02_2 I2=n69
XU417 NR2 $PINS O=sll_17/ML_int[3][3] I1=FE_OFN190_h02_2 I2=n68
XU418 ND2P $PINS O=n67 I1=n34 I2=n36
XU421 AN2 $PINS O=term2_shifted[5] I1=sll_17/ML_int[3][5] I2=n36
XU422 AN2 $PINS O=term2_shifted[6] I1=sll_17/ML_int[3][6] I2=n36
XU423 AN2 $PINS O=term2_shifted[7] I1=sll_17/ML_int[3][7] I2=n36
XU424 MUX2 $PINS O=term2_shifted[24] S=FE_RN_495_0 A=term2_in[26]
+ B=sll_17/ML_int[3][16]
XU426 MUX2 $PINS O=term2_shifted[25] S=FE_RN_495_0 A=term2_in[26]
+ B=sll_17/ML_int[3][17]
XU428 MUX2 $PINS O=term2_shifted[26] S=FE_RN_495_0 A=term2_in[26]
+ B=sll_17/ML_int[3][18]
XU430 MUX2 $PINS O=n75 S=shf2[0] A=term2_in[26] B=term2_in[15]
XU431 NR2 $PINS O=sll_18/ML_int[3][0] I1=shf3[2] I2=n76
XU432 NR2 $PINS O=sll_18/ML_int[3][1] I1=shf3[2] I2=n77
XU433 NR2 $PINS O=sll_18/ML_int[3][2] I1=shf3[2] I2=n80
XU434 NR2 $PINS O=sll_18/ML_int[3][3] I1=shf3[2] I2=n79
XU435 AN2T $PINS O=term3_shifted[4] I1=sll_18/ML_int[3][4] I2=n28
XU436 AN2 $PINS O=term3_shifted[5] I1=sll_18/ML_int[3][5] I2=n28
XU437 AN2 $PINS O=term3_shifted[6] I1=sll_18/ML_int[3][6] I2=n28
XU438 AN2 $PINS O=term3_shifted[7] I1=sll_18/ML_int[3][7] I2=n28
XU439 MUX2 $PINS O=term3_shifted[24] S=FE_OFN182_h03_3 A=term3_in[26]
+ B=sll_18/ML_int[3][16]
XU440 MUX2 $PINS O=n83 S=FE_OFN203_h03_1 A=n86 B=sll_18/ML_int[1][14]
XU441 MUX2 $PINS O=term3_shifted[25] S=FE_OFN182_h03_3 A=term3_in[26]
+ B=sll_18/ML_int[3][17]
XU442 MUX2 $PINS O=n84 S=FE_OFN203_h03_1 A=term3_in[26] B=sll_18/ML_int[1][15]
XU443 MUX2 $PINS O=term3_shifted[26] S=FE_OFN182_h03_3 A=term3_in[26]
+ B=sll_18/ML_int[3][18]
XU444 MUX2 $PINS O=n85 S=FE_OFN203_h03_1 A=term3_in[26] B=n86
XU445 MUX2 $PINS O=n86 S=FE_OFN245_h03_0 A=term3_in[26] B=term3_in[15]
XU446 MUX2 $PINS O=N241 S=stage_sel A=acc_reg[16] B=acc_reg[20]
XU447 MUX2 $PINS O=FE_PHN1288_N243 S=stage_sel A=acc_reg[18] B=acc_reg[22]
XU448 MUX2 $PINS O=FE_PHN1286_N244 S=FE_OFN39_FE_DBTN10_n289 A=acc_reg[19]
+ B=FE_PHN1104_acc_reg_23
Xsll_17/M1_1_4 MUX2 $PINS O=sll_17/ML_int[2][4] S=FE_OFN212_h02_1
+ A=sll_17/ML_int[1][4] B=sll_17/ML_int[1][2]
Xsll_17/M1_1_5 MUX2 $PINS O=sll_17/ML_int[2][5] S=FE_OFN212_h02_1
+ A=sll_17/ML_int[1][5] B=sll_17/ML_int[1][3]
Xsll_17/M1_1_6 MUX2S $PINS O=sll_17/ML_int[2][6] S=FE_OFN212_h02_1
+ A=sll_17/ML_int[1][6] B=sll_17/ML_int[1][4]
Xsll_17/M1_1_7 MUX2S $PINS O=sll_17/ML_int[2][7] S=FE_OFN212_h02_1
+ A=sll_17/ML_int[1][7] B=sll_17/ML_int[1][5]
XU34 MUX2 $PINS O=sll_18/ML_int[1][3] S=shf3[0] A=term3_in[3] B=term3_in[2]
Xacc_reg_reg[26] QDFFRBP $PINS Q=N251 D=next_acc[26] CK=clk_clone2 RB=i_rst_n
XU102 MUX2 $PINS O=sll_17/ML_int[2][3] S=FE_OFN212_h02_1 A=sll_17/ML_int[1][3]
+ B=FE_RN_255_0
XU3 MOAI1 $PINS O=N153 A1=n105 A2=FE_DBTN28_s03_0 B1=term3_shifted[2]
+ B2=FE_DBTN28_s03_0
XU4 INV2 $PINS O=n105 I=N126
XU5 AO22 $PINS O=N58 A1=N31 A2=FE_OFN159_s01_0 B1=term1_shifted[17]
+ B2=FE_OFN274_FE_DBTN29_s01_0
XU6 NR2 $PINS O=term3_in[1] I1=FE_OFN291_s03_1 I2=x_in[1]
XU30 NR2 $PINS O=n107 I1=n67 I2=FE_OFN212_h02_1
XU36 ND2 $PINS O=n15 I1=term1_in[0] I2=n43
XU44 NR2P $PINS O=term1_shifted[1] I1=n59 I2=n58
XU63 ND2S $PINS O=n19 I1=term3_in[0] I2=shf3[0]
XU64 ND2 $PINS O=sll_18/ML_int[1][1] I1=n18 I2=n19
XU65 ND2S $PINS O=n18 I1=term3_in[1] I2=n25
XU72 MOAI1HP $PINS O=N42 A1=n7 A2=sign1[0] B1=N15 B2=sign1[0]
XU84 NR3 $PINS O=sll_17/ML_int[1][0] I1=shf2[0] I2=sign2[1] I3=x_in[0]
XU88 INV1S $PINS O=n69 I=sll_17/ML_int[2][2]
XU90 MUX2S $PINS O=n74 S=FE_OFN213_h02_1 A=term2_in[26] B=n75
XU94 MUX2S $PINS O=n73 S=FE_OFN213_h02_1 A=term2_in[26] B=sll_17/ML_int[1][15]
XU101 MUX2S $PINS O=n72 S=FE_OFN213_h02_1 A=n75 B=sll_17/ML_int[1][14]
XU165 OR2 $PINS O=n66 I1=n4 I2=FE_OFN212_h02_1
XU291 OR2S $PINS O=n3 I1=n8 I2=FE_OFN212_h02_1
XU294 INV1S $PINS O=n80 I=sll_18/ML_int[2][2]
Xclk_gate_y_out_reg SNPS_CLOCK_GATE_HIGH_PE_Shift_Add_7 $PINS EN=N234
+ ENCLK=CTS_12 CLK=clk_clone1
Xsub_28_3 PE_Shift_Add_7_DW01_sub_0_DW01_sub_21 $PINS A[26]=net45578
+ A[25]=net45578 A[24]=net45578 A[23]=net45578 A[22]=net45578 A[21]=net45578
+ A[20]=net45578 A[19]=net45578 A[18]=net45578 A[17]=net45578 A[16]=net45578
+ A[15]=net45578 A[14]=net45578 A[13]=net45578 A[12]=net45578 A[11]=net45578
+ A[10]=net45578 A[9]=net45578 A[8]=net45578 A[7]=net45578 A[6]=net45578
+ A[5]=net45578 A[4]=net45578 A[3]=net45578 A[2]=net45578 A[1]=net45578
+ A[0]=net45578 B[26]=term3_shifted[26] B[25]=term3_shifted[25]
+ B[24]=term3_shifted[24] B[23]=term3_shifted[23] B[22]=term3_shifted[22]
+ B[21]=term3_shifted[21] B[20]=term3_shifted[20] B[19]=term3_shifted[19]
+ B[18]=term3_shifted[18] B[17]=term3_shifted[17] B[16]=term3_shifted[16]
+ B[15]=term3_shifted[15] B[14]=term3_shifted[14] B[13]=term3_shifted[13]
+ B[12]=term3_shifted[12] B[11]=term3_shifted[11] B[10]=term3_shifted[10]
+ B[9]=term3_shifted[9] B[8]=term3_shifted[8] B[7]=term3_shifted[7]
+ B[6]=term3_shifted[6] B[5]=term3_shifted[5] B[4]=term3_shifted[4]
+ B[3]=term3_shifted[3] B[2]=term3_shifted[2] B[1]=FE_RN_502_0 B[0]=n6
+ CI=net45578 DIFF[26]=N150 DIFF[25]=N149 DIFF[24]=N148 DIFF[23]=N147
+ DIFF[22]=N146 DIFF[21]=N145 DIFF[20]=N144 DIFF[19]=N143 DIFF[18]=N142
+ DIFF[17]=N141 DIFF[16]=N140 DIFF[15]=N139 DIFF[14]=N138 DIFF[13]=N137
+ DIFF[12]=N136 DIFF[11]=N135 DIFF[10]=N134 DIFF[9]=N133 DIFF[8]=N132
+ DIFF[7]=N131 DIFF[6]=N130 DIFF[5]=N129 DIFF[4]=N128 DIFF[3]=N127 DIFF[2]=N126
+ DIFF[1]=N125 DIFF[0]=N124 p1=FE_DBTN20_term3_shifted_1
Xsub_28_2 PE_Shift_Add_7_DW01_sub_1_DW01_sub_22 $PINS A[26]=net45578
+ A[25]=net45578 A[24]=net45578 A[23]=net45578 A[22]=net45578 A[21]=net45578
+ A[20]=net45578 A[19]=net45578 A[18]=net45578 A[17]=net45578 A[16]=net45578
+ A[15]=net45578 A[14]=net45578 A[13]=net45578 A[12]=net45578 A[11]=net45578
+ A[10]=net45578 A[9]=net45578 A[8]=net45578 A[7]=net45578 A[6]=net45578
+ A[5]=net45578 A[4]=net45578 A[3]=net45578 A[2]=net45578 A[1]=net45578
+ A[0]=net45578 B[26]=term2_shifted[26] B[25]=term2_shifted[25]
+ B[24]=term2_shifted[24] B[23]=term2_shifted[23] B[22]=term2_shifted[22]
+ B[21]=term2_shifted[21] B[20]=term2_shifted[20] B[19]=term2_shifted[19]
+ B[18]=term2_shifted[18] B[17]=term2_shifted[17] B[16]=term2_shifted[16]
+ B[15]=term2_shifted[15] B[14]=term2_shifted[14] B[13]=term2_shifted[13]
+ B[12]=term2_shifted[12] B[11]=term2_shifted[11] B[10]=term2_shifted[10]
+ B[9]=term2_shifted[9] B[8]=term2_shifted[8] B[7]=term2_shifted[7]
+ B[6]=term2_shifted[6] B[5]=term2_shifted[5] B[4]=term2_shifted[4]
+ B[3]=term2_shifted[3] B[2]=term2_shifted[2] B[1]=term2_shifted[1]
+ B[0]=term2_shifted[0] CI=net45578 DIFF[26]=N95 DIFF[25]=N94 DIFF[24]=N93
+ DIFF[23]=N92 DIFF[22]=N91 DIFF[21]=N90 DIFF[20]=N89 DIFF[19]=N88 DIFF[18]=N87
+ DIFF[17]=N86 DIFF[16]=N85 DIFF[15]=N84 DIFF[14]=N83 DIFF[13]=N82 DIFF[12]=N81
+ DIFF[11]=N80 DIFF[10]=N79 DIFF[9]=N78 DIFF[8]=N77 DIFF[7]=N76 DIFF[6]=N75
+ DIFF[5]=N74 DIFF[4]=N73 DIFF[3]=N72 DIFF[2]=N71 DIFF[1]=N70 DIFF[0]=N69
Xsub_28 PE_Shift_Add_7_DW01_sub_2_DW01_sub_23 $PINS A[26]=net45578
+ A[25]=net45578 A[24]=net45578 A[23]=net45578 A[22]=net45578 A[21]=net45578
+ A[20]=net45578 A[19]=net45578 A[18]=net45578 A[17]=net45578 A[16]=net45578
+ A[15]=net45578 A[14]=net45578 A[13]=net45578 A[12]=net45578 A[11]=net45578
+ A[10]=net45578 A[9]=net45578 A[8]=net45578 A[7]=net45578 A[6]=net45578
+ A[5]=net45578 A[4]=net45578 A[3]=net45578 A[2]=net45578 A[1]=net45578
+ A[0]=net45578 B[26]=term1_shifted[26] B[25]=term1_shifted[25]
+ B[24]=term1_shifted[24] B[23]=term1_shifted[23] B[22]=term1_shifted[22]
+ B[21]=term1_shifted[21] B[20]=term1_shifted[20] B[19]=term1_shifted[19]
+ B[18]=term1_shifted[18] B[17]=term1_shifted[17] B[16]=term1_shifted[16]
+ B[15]=term1_shifted[15] B[14]=term1_shifted[14] B[13]=term1_shifted[13]
+ B[12]=term1_shifted[12] B[11]=term1_shifted[11] B[10]=term1_shifted[10]
+ B[9]=term1_shifted[9] B[8]=term1_shifted[8] B[7]=term1_shifted[7]
+ B[6]=term1_shifted[6] B[5]=term1_shifted[5] B[4]=term1_shifted[4]
+ B[3]=term1_shifted[3] B[2]=term1_shifted[2] B[1]=term1_shifted[1]
+ B[0]=term1_shifted[0] CI=net45578 DIFF[26]=N40 DIFF[25]=N39 DIFF[24]=N38
+ DIFF[23]=N37 DIFF[22]=N36 DIFF[21]=N35 DIFF[20]=N34 DIFF[19]=N33 DIFF[18]=N32
+ DIFF[17]=N31 DIFF[16]=N30 DIFF[15]=N29 DIFF[14]=N28 DIFF[13]=N27 DIFF[12]=N26
+ DIFF[11]=N25 DIFF[10]=N24 DIFF[9]=N23 DIFF[8]=N22 DIFF[7]=N21 DIFF[6]=N20
+ DIFF[5]=N19 DIFF[4]=N18 DIFF[3]=N17 DIFF[2]=N16 DIFF[1]=N15 DIFF[0]=N14
Xadd_1_root_add_0_root_add_28_3 PE_Shift_Add_7_DW01_add_2_DW01_add_37 $PINS
+ A[26]=N67 A[25]=N66 A[24]=N65 A[23]=N64 A[22]=N63 A[21]=N62 A[20]=N61 A[19]=N60
+ A[18]=N59 A[17]=N58 A[16]=N57 A[15]=N56 A[14]=N55 A[13]=N54 A[12]=N53 A[11]=N52
+ A[10]=N51 A[9]=N50 A[8]=N49 A[7]=N48 A[6]=N47 A[5]=N46 A[4]=N45 A[3]=N44
+ A[2]=N43 A[1]=N42 A[0]=N41 B[26]=N177 B[25]=N176 B[24]=N175 B[23]=N174
+ B[22]=N173 B[21]=N172 B[20]=N171 B[19]=N170 B[18]=N169 B[17]=N168 B[16]=N167
+ B[15]=N166 B[14]=N165 B[13]=N164 B[12]=N163 B[11]=N162 B[10]=N161 B[9]=N160
+ B[8]=N159 B[7]=N158 B[6]=N157 B[5]=N156 B[4]=N155 B[3]=N154 B[2]=N153 B[1]=N152
+ B[0]=N151 CI=net45578 SUM[26]=N204 SUM[25]=N203 SUM[24]=N202 SUM[23]=N201
+ SUM[22]=N200 SUM[21]=N199 SUM[20]=N198 SUM[19]=N197 SUM[18]=N196 SUM[17]=N195
+ SUM[16]=N194 SUM[15]=N193 SUM[14]=N192 SUM[13]=N191 SUM[12]=N190 SUM[11]=N189
+ SUM[10]=N188 SUM[9]=N187 SUM[8]=N186 SUM[7]=N185 SUM[6]=N184 SUM[5]=N183
+ SUM[4]=N182 SUM[3]=N181 SUM[2]=N180 SUM[1]=N179 SUM[0]=N178
Xadd_2_root_add_0_root_add_28_3 PE_Shift_Add_7_DW01_add_1_DW01_add_36 $PINS
+ A[26]=base_val[26] A[25]=base_val[25] A[24]=base_val[24] A[23]=base_val[23]
+ A[22]=base_val[22] A[21]=base_val[21] A[20]=base_val[20] A[19]=base_val[19]
+ A[18]=base_val[18] A[17]=base_val[17] A[16]=base_val[16] A[15]=base_val[15]
+ A[14]=base_val[14] A[13]=base_val[13] A[12]=base_val[12] A[11]=base_val[11]
+ A[10]=base_val[10] A[9]=base_val[9] A[8]=base_val[8] A[7]=base_val[7]
+ A[6]=base_val[6] A[5]=base_val[5] A[4]=base_val[4] A[3]=base_val[3]
+ A[2]=base_val[2] A[1]=base_val[1] A[0]=base_val[0] B[26]=N122 B[25]=N121
+ B[24]=N120 B[23]=N119 B[22]=N118 B[21]=N117 B[20]=N116 B[19]=N115 B[18]=N114
+ B[17]=N113 B[16]=N112 B[15]=N111 B[14]=N110 B[13]=N109 B[12]=N108 B[11]=N107
+ B[10]=N106 B[9]=N105 B[8]=N104 B[7]=N103 B[6]=N102 B[5]=N101 B[4]=N100 B[3]=N99
+ B[2]=N98 B[1]=N97 B[0]=N96 CI=net45578 SUM[26]=N231 SUM[25]=N230 SUM[24]=N229
+ SUM[23]=N228 SUM[22]=N227 SUM[21]=N226 SUM[20]=N225 SUM[19]=N224 SUM[18]=N223
+ SUM[17]=N222 SUM[16]=N221 SUM[15]=N220 SUM[14]=N219 SUM[13]=N218 SUM[12]=N217
+ SUM[11]=N216 SUM[10]=N215 SUM[9]=N214 SUM[8]=N213 SUM[7]=N212 SUM[6]=N211
+ SUM[5]=N210 SUM[4]=N209 SUM[3]=N208 SUM[2]=N207 SUM[1]=N206 SUM[0]=N205
Xadd_0_root_add_0_root_add_28_3 PE_Shift_Add_7_DW01_add_0_DW01_add_35 $PINS
+ A[26]=N204 A[25]=N203 A[24]=N202 A[23]=N201 A[22]=N200 A[21]=N199 A[20]=N198
+ A[19]=N197 A[18]=N196 A[17]=N195 A[16]=N194 A[15]=N193 A[14]=N192 A[13]=N191
+ A[12]=N190 A[11]=N189 A[10]=N188 A[9]=N187 A[8]=N186 A[7]=N185 A[6]=N184
+ A[5]=N183 A[4]=N182 A[3]=N181 A[2]=N180 A[1]=N179 A[0]=N178 B[26]=N231
+ B[25]=N230 B[24]=N229 B[23]=N228 B[22]=N227 B[21]=N226 B[20]=N225 B[19]=N224
+ B[18]=N223 B[17]=N222 B[16]=N221 B[15]=N220 B[14]=N219 B[13]=N218 B[12]=N217
+ B[11]=N216 B[10]=N215 B[9]=N214 B[8]=N213 B[7]=N212 B[6]=N211 B[5]=N210
+ B[4]=N209 B[3]=N208 B[2]=N207 B[1]=N206 B[0]=N205 CI=net45578
+ SUM[26]=next_acc[26] SUM[25]=next_acc[25] SUM[24]=next_acc[24]
+ SUM[23]=next_acc[23] SUM[22]=next_acc[22] SUM[21]=next_acc[21]
+ SUM[20]=next_acc[20] SUM[19]=next_acc[19] SUM[18]=next_acc[18]
+ SUM[17]=next_acc[17] SUM[16]=next_acc[16] SUM[15]=next_acc[15]
+ SUM[14]=next_acc[14] SUM[13]=next_acc[13] SUM[12]=next_acc[12]
+ SUM[11]=next_acc[11] SUM[10]=next_acc[10] SUM[9]=next_acc[9] SUM[8]=next_acc[8]
+ SUM[7]=next_acc[7] SUM[6]=next_acc[6] SUM[5]=next_acc[5] SUM[4]=next_acc[4]
+ SUM[3]=next_acc[3] SUM[2]=next_acc[2] SUM[1]=next_acc[1] SUM[0]=next_acc[0]
.ENDS

.SUBCKT SNPS_CLOCK_GATE_HIGH_PE_Shift_Add_6 EN ENCLK CLK
*.CONNECT net2290 EN
XFE_PHC859_net2293 DELC $PINS O=net2293 I=FE_PHN859_net2293
Xlatch QDBHN $PINS Q=FE_PHN859_net2293 D=net2290 CKB=CLK
Xmain_gate AN2T $PINS O=ENCLK I1=net2293 I2=CLK
.ENDS

.SUBCKT PE_Shift_Add_6_DW01_sub_0_DW01_sub_18 A[26] A[25] A[24] A[23] A[22]
+ A[21] A[20] A[19] A[18] A[17] A[16] A[15] A[14] A[13] A[12] A[11] A[10] A[9]
+ A[8] A[7] A[6] A[5] A[4] A[3] A[2] A[1] A[0] B[26] B[25] B[24] B[23] B[22]
+ B[21] B[20] B[19] B[18] B[17] B[16] B[15] B[14] B[13] B[12] B[11] B[10] B[9]
+ B[8] B[7] B[6] B[5] B[4] B[3] B[2] B[1] B[0] CI DIFF[26] DIFF[25] DIFF[24]
+ DIFF[23] DIFF[22] DIFF[21] DIFF[20] DIFF[19] DIFF[18] DIFF[17] DIFF[16]
+ DIFF[15] DIFF[14] DIFF[13] DIFF[12] DIFF[11] DIFF[10] DIFF[9] DIFF[8] DIFF[7]
+ DIFF[6] DIFF[5] DIFF[4] DIFF[3] DIFF[2] DIFF[1] DIFF[0] CO
*.CONNECT DIFF[0] B[0]
XFE_RC_1273_0 AN3B1 $PINS O=n27 I1=n48 I2=n25 B1=B[6]
XFE_RC_1201_0 AO12 $PINS O=n2 A1=B[3] B1=n52 B2=n4
XFE_RC_1146_0 AN2B1S $PINS O=n26 I1=n25 B1=B[6]
XFE_RC_1105_0 AN2B1S $PINS O=n6 I1=n5 B1=B[3]
XFE_RC_846_0 XOR2HS $PINS O=DIFF[1] I1=DIFF[0] I2=B[1]
XFE_OFC635_term3_shifted_7 INV1S $PINS O=n48 I=B[7]
XFE_OFC631_term3_shifted_10 INV1S $PINS O=n45 I=B[10]
XFE_OFC588_term3_shifted_9 INV1S $PINS O=n46 I=B[9]
XFE_OFC581_term3_shifted_8 INV1S $PINS O=n47 I=B[8]
XU8 AN2 $PINS O=n5 I1=n52 I2=n4
XU9 INV1S $PINS O=n51 I=B[4]
XU11 ND2 $PINS O=n3 I1=B[3] I2=n5
XU12 INV1S $PINS O=n50 I=B[5]
XU13 ND2 $PINS O=DIFF[3] I1=n2 I2=n3
XU14 ND2S $PINS O=n29 I1=n30 I2=n23
XU15 XOR2HS $PINS O=DIFF[2] I1=n52 I2=n4
XU17 XOR2HS $PINS O=DIFF[8] I1=n47 I2=n27
XU18 XOR2HS $PINS O=DIFF[9] I1=n46 I2=n7
XU19 AN2 $PINS O=n7 I1=n47 I2=n27
XU20 XOR2HS $PINS O=DIFF[10] I1=n45 I2=n8
XU21 AN2 $PINS O=n8 I1=n46 I2=n7
XU22 XOR2HS $PINS O=DIFF[11] I1=n44 I2=n9
XU23 AN2 $PINS O=n9 I1=n45 I2=n8
XU24 XOR2HS $PINS O=DIFF[12] I1=n43 I2=n10
XU25 AN2 $PINS O=n10 I1=n44 I2=n9
XU26 XOR2HS $PINS O=DIFF[13] I1=n42 I2=n11
XU27 AN2 $PINS O=n11 I1=n43 I2=n10
XU28 XOR2HS $PINS O=DIFF[14] I1=n41 I2=n12
XU29 AN2 $PINS O=n12 I1=n42 I2=n11
XU30 XOR2HS $PINS O=DIFF[15] I1=n40 I2=n13
XU31 AN2 $PINS O=n13 I1=n41 I2=n12
XU32 XOR2HS $PINS O=DIFF[16] I1=n39 I2=n14
XU33 AN2 $PINS O=n14 I1=n40 I2=n13
XU34 XOR2HS $PINS O=DIFF[17] I1=n38 I2=n15
XU35 AN2 $PINS O=n15 I1=n39 I2=n14
XU36 XOR2HS $PINS O=DIFF[18] I1=n37 I2=n16
XU37 AN2 $PINS O=n16 I1=n38 I2=n15
XU38 XOR2HS $PINS O=DIFF[19] I1=n36 I2=n17
XU39 AN2 $PINS O=n17 I1=n37 I2=n16
XU40 XOR2HS $PINS O=DIFF[20] I1=n35 I2=n18
XU41 AN2 $PINS O=n18 I1=n36 I2=n17
XU42 XOR2HS $PINS O=DIFF[21] I1=n34 I2=n19
XU43 AN2 $PINS O=n19 I1=n35 I2=n18
XU44 XOR2HS $PINS O=DIFF[22] I1=n33 I2=n20
XU45 AN2 $PINS O=n20 I1=n34 I2=n19
XU46 XOR2HS $PINS O=DIFF[23] I1=n32 I2=n21
XU47 AN2 $PINS O=n21 I1=n33 I2=n20
XU48 XOR2HS $PINS O=DIFF[24] I1=n31 I2=n22
XU49 AN2 $PINS O=n22 I1=n32 I2=n21
XU50 AN2 $PINS O=n23 I1=n31 I2=n22
XU51 XOR2HS $PINS O=DIFF[25] I1=n30 I2=n23
XU52 XOR2HS $PINS O=DIFF[4] I1=n51 I2=n6
XU53 XOR2HS $PINS O=DIFF[5] I1=n50 I2=n24
XU54 AN2 $PINS O=n24 I1=n6 I2=n51
XU55 XOR2HS $PINS O=DIFF[6] I1=n49 I2=n25
XU56 AN2 $PINS O=n25 I1=n50 I2=n24
XU57 XOR2HS $PINS O=DIFF[7] I1=n48 I2=n26
XU63 INV1S $PINS O=n44 I=B[11]
XU64 INV1S $PINS O=n43 I=B[12]
XU65 INV1S $PINS O=n42 I=B[13]
XU66 INV1S $PINS O=n41 I=B[14]
XU67 INV1S $PINS O=n40 I=B[15]
XU68 INV1S $PINS O=n39 I=B[16]
XU69 INV1S $PINS O=n38 I=B[17]
XU70 INV1S $PINS O=n37 I=B[18]
XU71 INV1S $PINS O=n36 I=B[19]
XU72 INV1S $PINS O=n35 I=B[20]
XU73 INV1S $PINS O=n34 I=B[21]
XU74 INV1S $PINS O=n33 I=B[22]
XU75 INV1S $PINS O=n32 I=B[23]
XU76 INV1S $PINS O=n31 I=B[24]
XU77 INV1S $PINS O=n30 I=B[25]
XU78 INV1S $PINS O=n49 I=B[6]
XU80 XOR2HS $PINS O=DIFF[26] I1=B[26] I2=n29
XU1 INV2 $PINS O=n52 I=B[2]
XU2 NR2P $PINS O=n4 I1=DIFF[0] I2=B[1]
.ENDS

.SUBCKT PE_Shift_Add_6_DW01_sub_1_DW01_sub_19 A[26] A[25] A[24] A[23] A[22]
+ A[21] A[20] A[19] A[18] A[17] A[16] A[15] A[14] A[13] A[12] A[11] A[10] A[9]
+ A[8] A[7] A[6] A[5] A[4] A[3] A[2] A[1] A[0] B[26] B[25] B[24] B[23] B[22]
+ B[21] B[20] B[19] B[18] B[17] B[16] B[15] B[14] B[13] B[12] B[11] B[10] B[9]
+ B[8] B[7] B[6] B[5] B[4] B[3] B[2] B[1] B[0] CI DIFF[26] DIFF[25] DIFF[24]
+ DIFF[23] DIFF[22] DIFF[21] DIFF[20] DIFF[19] DIFF[18] DIFF[17] DIFF[16]
+ DIFF[15] DIFF[14] DIFF[13] DIFF[12] DIFF[11] DIFF[10] DIFF[9] DIFF[8] DIFF[7]
+ DIFF[6] DIFF[5] DIFF[4] DIFF[3] DIFF[2] DIFF[1] DIFF[0] CO
XFE_RC_1298_0 ND2P $PINS O=FE_RN_263_0 I1=n4 I2=n53
XFE_RC_1297_0 XNR2HS $PINS O=DIFF[3] I1=FE_RN_263_0 I2=n52
XFE_RC_1266_0 AN4B1S $PINS O=n6 I1=n54 I2=n55 I3=n53 B1=B[3]
XFE_OFC655_term2_shifted_10 INV1S $PINS O=n45 I=B[10]
XFE_OFC629_term2_shifted_6 INV1S $PINS O=n49 I=B[6]
XFE_OFC586_term2_shifted_8 INV1S $PINS O=n47 I=B[8]
XFE_OFC573_N69 INV1S $PINS O=n55 I=B[0]
XU1 INV2 $PINS O=n54 I=B[1]
XU3 ND2 $PINS O=n2 I1=n54 I2=B[0]
XU7 ND2S $PINS O=DIFF[1] I1=n3 I2=n2
XU8 INV2 $PINS O=n52 I=B[3]
XU9 INV2 $PINS O=n53 I=B[2]
XU10 ND2 $PINS O=n3 I1=B[1] I2=n55
XU13 AN2 $PINS O=n4 I1=n54 I2=n55
XU14 INV1S $PINS O=n50 I=B[5]
XU15 ND2S $PINS O=n29 I1=n30 I2=n23
XU17 AN2 $PINS O=n7 I1=n47 I2=n27
XU18 AN2 $PINS O=n8 I1=n46 I2=n7
XU19 AN2 $PINS O=n9 I1=n45 I2=n8
XU20 AN2 $PINS O=n10 I1=n44 I2=n9
XU21 AN2 $PINS O=n11 I1=n43 I2=n10
XU22 AN2 $PINS O=n12 I1=n42 I2=n11
XU23 AN2 $PINS O=n13 I1=n41 I2=n12
XU24 AN2 $PINS O=n14 I1=n40 I2=n13
XU25 AN2 $PINS O=n15 I1=n39 I2=n14
XU26 AN2 $PINS O=n16 I1=n38 I2=n15
XU27 AN2 $PINS O=n17 I1=n37 I2=n16
XU28 AN2 $PINS O=n18 I1=n36 I2=n17
XU29 AN2 $PINS O=n19 I1=n35 I2=n18
XU30 AN2 $PINS O=n20 I1=n34 I2=n19
XU31 AN2 $PINS O=n21 I1=n33 I2=n20
XU32 AN2 $PINS O=n22 I1=n32 I2=n21
XU33 AN2 $PINS O=n23 I1=n31 I2=n22
XU34 AN2 $PINS O=n24 I1=n51 I2=n6
XU35 AN2 $PINS O=n25 I1=n50 I2=n24
XU36 AN2 $PINS O=n26 I1=n49 I2=n25
XU37 AN2 $PINS O=n27 I1=n48 I2=n26
XU39 INV1S $PINS O=n46 I=B[9]
XU41 INV1S $PINS O=n44 I=B[11]
XU42 INV1S $PINS O=n43 I=B[12]
XU43 INV1S $PINS O=n42 I=B[13]
XU44 INV1S $PINS O=n41 I=B[14]
XU45 INV1S $PINS O=n40 I=B[15]
XU46 INV1S $PINS O=n39 I=B[16]
XU47 INV1S $PINS O=n38 I=B[17]
XU48 INV1S $PINS O=n37 I=B[18]
XU49 INV1S $PINS O=n36 I=B[19]
XU50 INV1S $PINS O=n35 I=B[20]
XU51 INV1S $PINS O=n34 I=B[21]
XU52 INV1S $PINS O=n33 I=B[22]
XU53 INV1S $PINS O=n32 I=B[23]
XU54 INV1S $PINS O=n31 I=B[24]
XU55 INV1S $PINS O=n30 I=B[25]
XU57 INV1S $PINS O=n48 I=B[7]
XU58 XOR2HS $PINS O=DIFF[26] I1=B[26] I2=n29
XU59 XOR2HS $PINS O=DIFF[9] I1=n46 I2=n7
XU60 XOR2HS $PINS O=DIFF[10] I1=n45 I2=n8
XU61 XOR2HS $PINS O=DIFF[11] I1=n44 I2=n9
XU62 XOR2HS $PINS O=DIFF[7] I1=n48 I2=n26
XU63 XOR2HS $PINS O=DIFF[6] I1=n49 I2=n25
XU64 XOR2HS $PINS O=DIFF[8] I1=n47 I2=n27
XU65 XOR2HS $PINS O=DIFF[5] I1=n50 I2=n24
XU66 XOR2HS $PINS O=DIFF[4] I1=n51 I2=n6
XU67 XOR2HS $PINS O=DIFF[2] I1=n53 I2=n4
XU68 XOR2HS $PINS O=DIFF[12] I1=n43 I2=n10
XU69 XOR2HS $PINS O=DIFF[13] I1=n42 I2=n11
XU70 XOR2HS $PINS O=DIFF[14] I1=n41 I2=n12
XU71 XOR2HS $PINS O=DIFF[15] I1=n40 I2=n13
XU72 XOR2HS $PINS O=DIFF[16] I1=n39 I2=n14
XU73 XOR2HS $PINS O=DIFF[17] I1=n38 I2=n15
XU74 XOR2HS $PINS O=DIFF[18] I1=n37 I2=n16
XU75 XOR2HS $PINS O=DIFF[19] I1=n36 I2=n17
XU76 XOR2HS $PINS O=DIFF[20] I1=n35 I2=n18
XU77 XOR2HS $PINS O=DIFF[21] I1=n34 I2=n19
XU78 XOR2HS $PINS O=DIFF[22] I1=n33 I2=n20
XU79 XOR2HS $PINS O=DIFF[23] I1=n32 I2=n21
XU80 XOR2HS $PINS O=DIFF[24] I1=n31 I2=n22
XU81 XOR2HS $PINS O=DIFF[25] I1=n30 I2=n23
XU11 INV1S $PINS O=n51 I=B[4]
.ENDS

.SUBCKT PE_Shift_Add_6_DW01_sub_2_DW01_sub_20 A[26] A[25] A[24] A[23] A[22]
+ A[21] A[20] A[19] A[18] A[17] A[16] A[15] A[14] A[13] A[12] A[11] A[10] A[9]
+ A[8] A[7] A[6] A[5] A[4] A[3] A[2] A[1] A[0] B[26] B[25] B[24] B[23] B[22]
+ B[21] B[20] B[19] B[18] B[17] B[16] B[15] B[14] B[13] B[12] B[11] B[10] B[9]
+ B[8] B[7] B[6] B[5] B[4] B[3] B[2] B[1] B[0] CI DIFF[26] DIFF[25] DIFF[24]
+ DIFF[23] DIFF[22] DIFF[21] DIFF[20] DIFF[19] DIFF[18] DIFF[17] DIFF[16]
+ DIFF[15] DIFF[14] DIFF[13] DIFF[12] DIFF[11] DIFF[10] DIFF[9] DIFF[8] DIFF[7]
+ DIFF[6] DIFF[5] DIFF[4] DIFF[3] DIFF[2] DIFF[1] DIFF[0] CO
*.CONNECT DIFF[0] B[0]
XFE_RC_1323_0 INV1S $PINS O=FE_RN_272_0 I=n3
XFE_RC_1322_0 NR2P $PINS O=n4 I1=B[3] I2=FE_RN_272_0
XFE_RC_1282_0 ND2P $PINS O=FE_RN_256_0 I1=n46 I2=n24
XFE_RC_1281_0 XNR2H $PINS O=DIFF[8] I1=FE_RN_256_0 I2=n45
XFE_RC_1176_0 AN2B1T $PINS O=n23 I1=n22 B1=B[5]
XFE_OFC658_term1_shifted_4 INV1S $PINS O=n49 I=B[4]
XFE_OFC657_term1_shifted_9 INV1S $PINS O=n44 I=B[9]
XFE_OFC633_term1_shifted_3 INV1S $PINS O=n50 I=B[3]
XFE_OFC617_term1_shifted_8 INV2 $PINS O=n45 I=B[8]
XFE_OFC615_term1_shifted_7 INV1S $PINS O=n46 I=B[7]
XFE_OFC521_term1_shifted_2 INV1S $PINS O=n51 I=B[2]
XU7 INV1S $PINS O=n48 I=B[5]
XU9 ND2S $PINS O=n27 I1=n28 I2=n21
XU10 AN2 $PINS O=n3 I1=n51 I2=n52
XU12 AN2 $PINS O=n5 I1=n45 I2=n25
XU13 AN2 $PINS O=n6 I1=n44 I2=n5
XU14 AN2 $PINS O=n7 I1=n43 I2=n6
XU15 AN2 $PINS O=n8 I1=n42 I2=n7
XU16 AN2 $PINS O=n9 I1=n41 I2=n8
XU17 AN2 $PINS O=n10 I1=n40 I2=n9
XU18 AN2 $PINS O=n11 I1=n39 I2=n10
XU19 AN2 $PINS O=n12 I1=n38 I2=n11
XU20 AN2 $PINS O=n13 I1=n37 I2=n12
XU21 AN2 $PINS O=n14 I1=n36 I2=n13
XU22 AN2 $PINS O=n15 I1=n35 I2=n14
XU23 AN2 $PINS O=n16 I1=n34 I2=n15
XU24 AN2 $PINS O=n17 I1=n33 I2=n16
XU25 AN2 $PINS O=n18 I1=n32 I2=n17
XU26 AN2 $PINS O=n19 I1=n31 I2=n18
XU27 AN2 $PINS O=n20 I1=n30 I2=n19
XU28 AN2 $PINS O=n21 I1=n29 I2=n20
XU29 AN2 $PINS O=n22 I1=n49 I2=n4
XU31 AN2T $PINS O=n24 I1=n23 I2=n47
XU32 AN2 $PINS O=n25 I1=n46 I2=n24
XU35 INV1S $PINS O=n43 I=B[10]
XU36 INV1S $PINS O=n42 I=B[11]
XU37 INV1S $PINS O=n41 I=B[12]
XU38 INV1S $PINS O=n40 I=B[13]
XU39 INV1S $PINS O=n39 I=B[14]
XU40 INV1S $PINS O=n38 I=B[15]
XU41 INV1S $PINS O=n37 I=B[16]
XU42 INV1S $PINS O=n36 I=B[17]
XU43 INV1S $PINS O=n35 I=B[18]
XU44 INV1S $PINS O=n34 I=B[19]
XU45 INV1S $PINS O=n33 I=B[20]
XU46 INV1S $PINS O=n32 I=B[21]
XU47 INV1S $PINS O=n31 I=B[22]
XU48 INV1S $PINS O=n30 I=B[23]
XU49 INV1S $PINS O=n29 I=B[24]
XU50 INV1S $PINS O=n28 I=B[25]
XU51 INV1S $PINS O=n47 I=B[6]
XU53 XOR2HS $PINS O=DIFF[3] I1=n3 I2=n50
XU54 XOR2HS $PINS O=DIFF[2] I1=n52 I2=n51
XU55 XOR2HS $PINS O=DIFF[5] I1=n48 I2=n22
XU56 XOR2HS $PINS O=DIFF[4] I1=n49 I2=n4
XU57 XOR2HS $PINS O=DIFF[6] I1=n47 I2=n23
XU58 XOR2HS $PINS O=DIFF[7] I1=n46 I2=n24
XU59 XOR2HS $PINS O=DIFF[9] I1=n44 I2=n5
XU61 XOR2HS $PINS O=DIFF[11] I1=n42 I2=n7
XU62 XOR2HS $PINS O=DIFF[10] I1=n43 I2=n6
XU63 XOR2HS $PINS O=DIFF[12] I1=n41 I2=n8
XU64 XOR2HS $PINS O=DIFF[13] I1=n40 I2=n9
XU65 XOR2HS $PINS O=DIFF[14] I1=n39 I2=n10
XU66 XOR2HS $PINS O=DIFF[15] I1=n38 I2=n11
XU67 XOR2HS $PINS O=DIFF[16] I1=n37 I2=n12
XU68 XOR2HS $PINS O=DIFF[17] I1=n36 I2=n13
XU69 XOR2HS $PINS O=DIFF[18] I1=n35 I2=n14
XU70 XOR2HS $PINS O=DIFF[19] I1=n34 I2=n15
XU71 XOR2HS $PINS O=DIFF[20] I1=n33 I2=n16
XU72 XOR2HS $PINS O=DIFF[21] I1=n32 I2=n17
XU73 XOR2HS $PINS O=DIFF[22] I1=n31 I2=n18
XU74 XOR2HS $PINS O=DIFF[23] I1=n30 I2=n19
XU75 XOR2HS $PINS O=DIFF[24] I1=n29 I2=n20
XU76 XOR2HS $PINS O=DIFF[25] I1=n28 I2=n21
XU77 XOR2HS $PINS O=DIFF[26] I1=B[26] I2=n27
XU2 XOR2HS $PINS O=DIFF[1] I1=DIFF[0] I2=B[1]
XU3 NR2 $PINS O=n52 I1=DIFF[0] I2=B[1]
.ENDS

.SUBCKT PE_Shift_Add_6_DW01_add_2_DW01_add_25 A[26] A[25] A[24] A[23] A[22]
+ A[21] A[20] A[19] A[18] A[17] A[16] A[15] A[14] A[13] A[12] A[11] A[10] A[9]
+ A[8] A[7] A[6] A[5] A[4] A[3] A[2] A[1] A[0] B[26] B[25] B[24] B[23] B[22]
+ B[21] B[20] B[19] B[18] B[17] B[16] B[15] B[14] B[13] B[12] B[11] B[10] B[9]
+ B[8] B[7] B[6] B[5] B[4] B[3] B[2] B[1] B[0] CI SUM[26] SUM[25] SUM[24]
+ SUM[23] SUM[22] SUM[21] SUM[20] SUM[19] SUM[18] SUM[17] SUM[16] SUM[15]
+ SUM[14] SUM[13] SUM[12] SUM[11] SUM[10] SUM[9] SUM[8] SUM[7] SUM[6] SUM[5]
+ SUM[4] SUM[3] SUM[2] SUM[1] SUM[0] CO
XFE_RC_1181_0 XOR3 $PINS O=SUM[25] I1=A[25] I2=B[25] I3=carry[25]
XFE_RC_1180_0 ND2P $PINS O=FE_RN_204_0 I1=carry[25] I2=B[25]
XFE_RC_1179_0 ND2P $PINS O=FE_RN_205_0 I1=carry[25] I2=A[25]
XFE_RC_1178_0 ND2 $PINS O=FE_RN_206_0 I1=A[25] I2=B[25]
XFE_RC_1177_0 ND3P $PINS O=carry[26] I1=FE_RN_204_0 I2=FE_RN_205_0
+ I3=FE_RN_206_0
XFE_RC_917_0 XOR2HS $PINS O=FE_RN_53_0 I1=B[8] I2=A[8]
XFE_RC_808_0 XOR2HS $PINS O=SUM[8] I1=FE_RN_53_0 I2=carry[8]
XFE_RC_791_0 XOR3 $PINS O=SUM[23] I1=A[23] I2=B[23] I3=carry[23]
XFE_RC_790_0 MAO222P $PINS O=carry[24] A1=carry[23] B1=B[23] C1=A[23]
XFE_RC_756_0 XOR3 $PINS O=SUM[24] I1=A[24] I2=B[24] I3=carry[24]
XFE_RC_755_0 MAO222P $PINS O=carry[25] A1=carry[24] B1=B[24] C1=A[24]
XFE_RC_713_0 XOR3 $PINS O=SUM[22] I1=A[22] I2=B[22] I3=carry[22]
XFE_RC_712_0 MAO222P $PINS O=carry[23] A1=carry[22] B1=B[22] C1=A[22]
XFE_RC_587_0 XOR3 $PINS O=SUM[15] I1=A[15] I2=B[15] I3=carry[15]
XFE_RC_586_0 MAO222P $PINS O=carry[16] A1=carry[15] B1=B[15] C1=A[15]
XFE_RC_583_0 XOR3 $PINS O=SUM[21] I1=A[21] I2=B[21] I3=carry[21]
XFE_RC_582_0 MAO222 $PINS O=carry[22] A1=carry[21] B1=B[21] C1=A[21]
XFE_RC_581_0 XOR3 $PINS O=SUM[1] I1=A[1] I2=n1 I3=B[1]
XFE_RC_580_0 MAO222P $PINS O=carry[2] A1=B[1] B1=n1 C1=A[1]
XFE_RC_539_0 XOR3 $PINS O=SUM[16] I1=A[16] I2=B[16] I3=carry[16]
XFE_RC_538_0 MAO222P $PINS O=carry[17] A1=carry[16] B1=B[16] C1=A[16]
XFE_RC_486_0 XOR3 $PINS O=SUM[17] I1=A[17] I2=B[17] I3=carry[17]
XFE_RC_485_0 MAO222P $PINS O=carry[18] A1=carry[17] B1=B[17] C1=A[17]
XFE_RC_353_0 XOR3 $PINS O=SUM[6] I1=A[6] I2=B[6] I3=carry[6]
XFE_RC_352_0 MAO222P $PINS O=carry[7] A1=carry[6] B1=B[6] C1=A[6]
XFE_RC_351_0 XOR3 $PINS O=SUM[18] I1=A[18] I2=B[18] I3=carry[18]
XFE_RC_350_0 MAO222P $PINS O=carry[19] A1=carry[18] B1=B[18] C1=A[18]
XFE_RC_230_0 MAO222P $PINS O=carry[9] A1=carry[8] B1=B[8] C1=A[8]
XFE_RC_215_0 XOR3 $PINS O=SUM[19] I1=A[19] I2=B[19] I3=carry[19]
XFE_RC_214_0 MAO222P $PINS O=carry[20] A1=carry[19] B1=B[19] C1=A[19]
XFE_RC_126_0 XOR3 $PINS O=SUM[10] I1=A[10] I2=B[10] I3=carry[10]
XFE_RC_125_0 MAO222P $PINS O=carry[11] A1=carry[10] B1=B[10] C1=A[10]
XFE_RC_87_0 XOR3 $PINS O=SUM[11] I1=A[11] I2=B[11] I3=carry[11]
XFE_RC_86_0 MAO222P $PINS O=carry[12] A1=carry[11] B1=B[11] C1=A[11]
XFE_RC_22_0 ND3P $PINS O=carry[10] I1=n30 I2=n29 I3=n31
XFE_RC_19_0 XOR3 $PINS O=SUM[12] I1=A[12] I2=B[12] I3=carry[12]
XFE_RC_18_0 MAO222P $PINS O=carry[13] A1=carry[12] B1=B[12] C1=A[12]
XU1_26 XOR3 $PINS O=SUM[26] I1=A[26] I2=B[26] I3=carry[26]
XU2 AN2 $PINS O=n1 I1=B[0] I2=A[0]
XU3 XOR3 $PINS O=SUM[13] I1=A[13] I2=B[13] I3=carry[13]
XU4 ND2 $PINS O=n2 I1=A[13] I2=B[13]
XU5 ND2 $PINS O=n3 I1=carry[13] I2=A[13]
XU6 ND2 $PINS O=n4 I1=carry[13] I2=B[13]
XU7 ND3P $PINS O=carry[14] I1=n3 I2=n4 I3=n2
XU8 XOR2HS $PINS O=n5 I1=A[14] I2=B[14]
XU9 XOR2HS $PINS O=SUM[14] I1=n5 I2=carry[14]
XU10 ND2 $PINS O=n6 I1=A[14] I2=B[14]
XU11 ND2 $PINS O=n7 I1=carry[14] I2=A[14]
XU12 ND2 $PINS O=n8 I1=carry[14] I2=B[14]
XU13 ND3P $PINS O=carry[15] I1=n7 I2=n8 I3=n6
XU14 XOR2HS $PINS O=n9 I1=B[4] I2=A[4]
XU15 XOR2HS $PINS O=SUM[4] I1=carry[4] I2=n9
XU16 ND2 $PINS O=n10 I1=carry[4] I2=B[4]
XU17 ND2 $PINS O=n11 I1=carry[4] I2=A[4]
XU18 ND2 $PINS O=n12 I1=A[4] I2=B[4]
XU19 ND3P $PINS O=carry[5] I1=n11 I2=n10 I3=n12
XU20 ND3P $PINS O=carry[4] I1=n15 I2=n14 I3=n13
XU21 ND2 $PINS O=n22 I1=carry[2] I2=A[2]
XU22 ND2 $PINS O=n13 I1=carry[3] I2=B[3]
XU23 ND2 $PINS O=n23 I1=A[2] I2=B[2]
XU24 ND2 $PINS O=n21 I1=carry[2] I2=B[2]
XU25 ND3P $PINS O=carry[3] I1=n22 I2=n21 I3=n23
XU26 XOR3 $PINS O=SUM[20] I1=A[20] I2=B[20] I3=carry[20]
XU27 XOR3 $PINS O=SUM[3] I1=A[3] I2=B[3] I3=carry[3]
XU29 ND2 $PINS O=n15 I1=carry[3] I2=A[3]
XU30 XOR2HS $PINS O=n16 I1=B[5] I2=A[5]
XU31 XOR2HS $PINS O=SUM[5] I1=carry[5] I2=n16
XU32 ND2 $PINS O=n17 I1=carry[5] I2=B[5]
XU33 ND2 $PINS O=n18 I1=carry[5] I2=A[5]
XU34 ND2 $PINS O=n19 I1=B[5] I2=A[5]
XU36 XOR2HS $PINS O=n20 I1=B[2] I2=A[2]
XU37 XOR2HS $PINS O=SUM[2] I1=carry[2] I2=n20
XU38 XOR2HS $PINS O=n24 I1=A[7] I2=B[7]
XU39 XOR2HS $PINS O=SUM[7] I1=carry[7] I2=n24
XU40 ND2T $PINS O=n25 I1=carry[7] I2=A[7]
XU41 ND2P $PINS O=n26 I1=carry[7] I2=B[7]
XU42 ND2 $PINS O=n27 I1=A[7] I2=B[7]
XU43 ND3P $PINS O=carry[8] I1=n26 I2=n25 I3=n27
XU44 XOR2HS $PINS O=n28 I1=A[9] I2=B[9]
XU45 XOR2HS $PINS O=SUM[9] I1=carry[9] I2=n28
XU46 ND2P $PINS O=n29 I1=carry[9] I2=A[9]
XU47 ND2P $PINS O=n30 I1=carry[9] I2=B[9]
XU48 ND2S $PINS O=n31 I1=A[9] I2=B[9]
XU49 ND2 $PINS O=n32 I1=carry[20] I2=A[20]
XU50 ND2 $PINS O=n33 I1=carry[20] I2=B[20]
XU51 ND2S $PINS O=n34 I1=A[20] I2=B[20]
XU53 XOR2HS $PINS O=SUM[0] I1=A[0] I2=B[0]
XU28 ND3P $PINS O=carry[6] I1=n17 I2=n18 I3=n19
XU35 ND3 $PINS O=carry[21] I1=n33 I2=n32 I3=n34
XU52 ND2 $PINS O=n14 I1=B[3] I2=A[3]
.ENDS

.SUBCKT PE_Shift_Add_6_DW01_add_1_DW01_add_24 A[26] A[25] A[24] A[23] A[22]
+ A[21] A[20] A[19] A[18] A[17] A[16] A[15] A[14] A[13] A[12] A[11] A[10] A[9]
+ A[8] A[7] A[6] A[5] A[4] A[3] A[2] A[1] A[0] B[26] B[25] B[24] B[23] B[22]
+ B[21] B[20] B[19] B[18] B[17] B[16] B[15] B[14] B[13] B[12] B[11] B[10] B[9]
+ B[8] B[7] B[6] B[5] B[4] B[3] B[2] B[1] B[0] CI SUM[26] SUM[25] SUM[24]
+ SUM[23] SUM[22] SUM[21] SUM[20] SUM[19] SUM[18] SUM[17] SUM[16] SUM[15]
+ SUM[14] SUM[13] SUM[12] SUM[11] SUM[10] SUM[9] SUM[8] SUM[7] SUM[6] SUM[5]
+ SUM[4] SUM[3] SUM[2] SUM[1] SUM[0] CO
XFE_RC_1713_0 INV2CK $PINS O=SUM[26] I=FE_RN_447_0
XFE_RC_1712_0 XNR2HT $PINS O=FE_RN_448_0 I1=A[26] I2=B[26]
XFE_RC_1711_0 XOR2HS $PINS O=FE_RN_447_0 I1=FE_RN_448_0 I2=carry[26]
XFE_RC_1472_0 XOR3 $PINS O=SUM[25] I1=A[25] I2=B[25] I3=carry[25]
XFE_RC_1471_0 MAO222 $PINS O=carry[26] A1=A[25] B1=B[25] C1=carry[25]
XFE_RC_1407_0 MAO222P $PINS O=carry[6] A1=A[5] B1=B[5] C1=carry[5]
XFE_RC_1406_0 XOR3 $PINS O=SUM[5] I1=A[5] I2=B[5] I3=carry[5]
XFE_RC_1332_0 INV2 $PINS O=SUM[9] I=FE_RN_276_0
XFE_RC_1331_0 XNR3 $PINS O=FE_RN_276_0 I1=A[9] I2=B[9] I3=carry[9]
XFE_RC_1308_0 OR2P $PINS O=FE_RN_19_0 I1=FE_RN_2_0 I2=FE_RN_10_0
XFE_RC_1256_0 ND3P $PINS O=carry[2] I1=n19 I2=n18 I3=n20
XFE_RC_1050_0 INV2 $PINS O=SUM[8] I=FE_RN_158_0
XFE_RC_1049_0 XNR3 $PINS O=FE_RN_158_0 I1=A[8] I2=B[8] I3=carry[8]
XFE_RC_1036_0 XOR3 $PINS O=SUM[16] I1=A[16] I2=B[16] I3=carry[16]
XFE_RC_1035_0 MAO222P $PINS O=carry[17] A1=carry[16] B1=B[16] C1=A[16]
XFE_RC_978_0 XOR3 $PINS O=SUM[11] I1=A[11] I2=B[11] I3=carry[11]
XFE_RC_977_0 MAO222 $PINS O=carry[12] A1=carry[11] B1=B[11] C1=A[11]
XFE_RC_801_0 XOR3 $PINS O=SUM[17] I1=A[17] I2=B[17] I3=carry[17]
XFE_RC_800_0 MAO222P $PINS O=carry[18] A1=carry[17] B1=B[17] C1=A[17]
XFE_RC_797_0 XOR3 $PINS O=SUM[12] I1=A[12] I2=B[12] I3=carry[12]
XFE_RC_796_0 MAO222P $PINS O=carry[13] A1=carry[12] B1=B[12] C1=A[12]
XFE_RC_752_0 XOR3 $PINS O=SUM[24] I1=A[24] I2=B[24] I3=carry[24]
XFE_RC_751_0 ND2P $PINS O=FE_RN_44_0 I1=carry[24] I2=B[24]
XFE_RC_750_0 ND2P $PINS O=FE_RN_45_0 I1=carry[24] I2=A[24]
XFE_RC_749_0 ND2 $PINS O=FE_RN_46_0 I1=A[24] I2=B[24]
XFE_RC_748_0 ND3P $PINS O=carry[25] I1=FE_RN_44_0 I2=FE_RN_45_0 I3=FE_RN_46_0
XFE_RC_689_0 XOR3 $PINS O=SUM[22] I1=A[22] I2=B[22] I3=carry[22]
XFE_RC_688_0 MAO222P $PINS O=carry[23] A1=carry[22] B1=B[22] C1=A[22]
XFE_RC_631_0 XOR3 $PINS O=SUM[23] I1=A[23] I2=B[23] I3=carry[23]
XFE_RC_630_0 MAO222P $PINS O=carry[24] A1=carry[23] B1=B[23] C1=A[23]
XFE_RC_623_0 XOR3 $PINS O=SUM[3] I1=A[3] I2=B[3] I3=carry[3]
XFE_RC_622_0 MAO222 $PINS O=carry[4] A1=carry[3] B1=B[3] C1=A[3]
XFE_RC_525_0 XOR3 $PINS O=SUM[4] I1=A[4] I2=B[4] I3=carry[4]
XFE_RC_524_0 MAO222P $PINS O=carry[5] A1=carry[4] B1=B[4] C1=A[4]
XFE_RC_515_0 XOR3 $PINS O=SUM[20] I1=A[20] I2=B[20] I3=carry[20]
XFE_RC_514_0 MAO222P $PINS O=carry[21] A1=carry[20] B1=B[20] C1=A[20]
XFE_RC_465_0 XOR3 $PINS O=SUM[21] I1=A[21] I2=B[21] I3=carry[21]
XFE_RC_464_0 MAO222P $PINS O=carry[22] A1=carry[21] B1=B[21] C1=A[21]
XFE_RC_454_0 XOR3 $PINS O=SUM[18] I1=A[18] I2=B[18] I3=carry[18]
XFE_RC_453_0 MAO222P $PINS O=carry[19] A1=carry[18] B1=B[18] C1=A[18]
XFE_RC_363_0 XOR3 $PINS O=SUM[10] I1=A[10] I2=B[10] I3=carry[10]
XFE_RC_362_0 MAO222 $PINS O=carry[11] A1=carry[10] B1=B[10] C1=A[10]
XFE_RC_359_0 XOR3 $PINS O=SUM[19] I1=A[19] I2=B[19] I3=carry[19]
XFE_RC_358_0 MAO222P $PINS O=carry[20] A1=carry[19] B1=B[19] C1=A[19]
XFE_RC_264_0 MAO222 $PINS O=carry[9] A1=carry[8] B1=B[8] C1=A[8]
XFE_RC_258_0 MAO222 $PINS O=carry[10] A1=carry[9] B1=B[9] C1=A[9]
XFE_RC_145_0 ND2P $PINS O=carry[7] I1=FE_RN_14_0 I2=FE_RN_19_0
XFE_RC_80_0 INV1S $PINS O=FE_RN_1_0 I=carry[6]
XFE_RC_79_0 INV1S $PINS O=FE_RN_2_0 I=A[6]
XFE_RC_77_0 ND2 $PINS O=FE_RN_4_0 I1=FE_RN_2_0 I2=B[6]
XFE_RC_76_0 OAI12HS $PINS O=FE_RN_5_0 A1=FE_RN_4_0 B1=FE_RN_2_0 B2=B[6]
XFE_RC_75_0 ND2S $PINS O=FE_RN_6_0 I1=FE_RN_5_0 I2=FE_RN_1_0
XFE_RC_74_0 ND2 $PINS O=FE_RN_7_0 I1=A[6] I2=B[6]
XFE_RC_73_0 ND2 $PINS O=FE_RN_8_0 I1=FE_RN_7_0 I2=FE_RN_13_0
XFE_RC_72_0 ND2 $PINS O=FE_RN_9_0 I1=FE_RN_8_0 I2=carry[6]
XFE_RC_71_0 ND2 $PINS O=SUM[6] I1=FE_RN_9_0 I2=FE_RN_6_0
XFE_RC_70_0 INV1S $PINS O=FE_RN_10_0 I=B[6]
XFE_RC_67_0 OR2B1 $PINS O=FE_RN_13_0 I1=B[6] B1=FE_RN_2_0
XFE_RC_66_0 ND2P $PINS O=FE_RN_14_0 I1=FE_RN_13_0 I2=carry[6]
XFE_RC_62_0 XOR3 $PINS O=SUM[13] I1=A[13] I2=B[13] I3=carry[13]
XFE_RC_61_0 MAO222P $PINS O=carry[14] A1=carry[13] B1=B[13] C1=A[13]
XU6 ND2P $PINS O=n13 I1=carry[15] I2=A[15]
XU7 ND2P $PINS O=n12 I1=carry[15] I2=B[15]
XU9 ND2 $PINS O=n18 I1=B[1] I2=carry[1]
XU13 XOR2HS $PINS O=n4 I1=B[2] I2=A[2]
XU14 XOR2HS $PINS O=SUM[2] I1=carry[2] I2=n4
XU15 XOR3 $PINS O=SUM[14] I1=B[14] I2=A[14] I3=carry[14]
XU16 ND2 $PINS O=n5 I1=carry[14] I2=B[14]
XU17 ND2 $PINS O=n6 I1=carry[14] I2=A[14]
XU18 ND2 $PINS O=n7 I1=B[14] I2=A[14]
XU20 ND2 $PINS O=n9 I1=B[2] I2=A[2]
XU22 XOR2HS $PINS O=n11 I1=B[15] I2=A[15]
XU23 XOR2HS $PINS O=SUM[15] I1=carry[15] I2=n11
XU24 ND2 $PINS O=n14 I1=B[15] I2=A[15]
XU25 ND3P $PINS O=carry[16] I1=n13 I2=n12 I3=n14
XU26 ND3P $PINS O=carry[8] I1=n15 I2=n16 I3=n17
XU27 ND2 $PINS O=n17 I1=B[7] I2=A[7]
XU28 XOR3 $PINS O=SUM[7] I1=B[7] I2=A[7] I3=carry[7]
XU29 ND2P $PINS O=n15 I1=carry[7] I2=B[7]
XU30 ND2P $PINS O=n16 I1=carry[7] I2=A[7]
XU32 INV1S $PINS O=carry[1] I=n21
XU33 XOR2HS $PINS O=SUM[0] I1=B[0] I2=A[0]
XU1 ND3HT $PINS O=carry[15] I1=n5 I2=n6 I3=n7
XU3 XOR3 $PINS O=SUM[1] I1=A[1] I2=carry[1] I3=B[1]
XU5 ND2 $PINS O=n10 I1=carry[2] I2=A[2]
XU10 ND2 $PINS O=n19 I1=B[1] I2=A[1]
XU11 ND2 $PINS O=n8 I1=carry[2] I2=B[2]
XU19 ND2S $PINS O=n20 I1=carry[1] I2=A[1]
XU21 ND2 $PINS O=n21 I1=B[0] I2=A[0]
XU31 ND3 $PINS O=carry[3] I1=n8 I2=n10 I3=n9
.ENDS

.SUBCKT PE_Shift_Add_6_DW01_add_0_DW01_add_23 A[26] A[25] A[24] A[23] A[22]
+ A[21] A[20] A[19] A[18] A[17] A[16] A[15] A[14] A[13] A[12] A[11] A[10] A[9]
+ A[8] A[7] A[6] A[5] A[4] A[3] A[2] A[1] A[0] B[26] B[25] B[24] B[23] B[22]
+ B[21] B[20] B[19] B[18] B[17] B[16] B[15] B[14] B[13] B[12] B[11] B[10] B[9]
+ B[8] B[7] B[6] B[5] B[4] B[3] B[2] B[1] B[0] CI SUM[26] SUM[25] SUM[24]
+ SUM[23] SUM[22] SUM[21] SUM[20] SUM[19] SUM[18] SUM[17] SUM[16] SUM[15]
+ SUM[14] SUM[13] SUM[12] SUM[11] SUM[10] SUM[9] SUM[8] SUM[7] SUM[6] SUM[5]
+ SUM[4] SUM[3] SUM[2] SUM[1] SUM[0] CO
XFE_RC_1419_0 XOR2HS $PINS O=FE_RN_311_0 I1=B[26] I2=A[26]
XFE_RC_1418_0 XOR2HS $PINS O=SUM[26] I1=FE_RN_311_0 I2=carry[26]
XFE_RC_1072_0 XOR3 $PINS O=SUM[2] I1=A[2] I2=B[2] I3=carry[2]
XFE_RC_1071_0 MAO222 $PINS O=carry[3] A1=carry[2] B1=B[2] C1=A[2]
XFE_RC_997_0 ND2 $PINS O=FE_RN_74_0 I1=B[7] I2=A[7]
XFE_RC_974_0 XOR3 $PINS O=SUM[1] I1=A[1] I2=B[1] I3=n4
XFE_RC_973_0 MAO222 $PINS O=carry[2] A1=A[1] B1=B[1] C1=n4
XFE_RC_847_0 ND3P $PINS O=carry[8] I1=n21 I2=n20 I3=FE_RN_74_0
XFE_RC_806_0 NR2 $PINS O=FE_RN_52_0 I1=FE_RN_26_0 I2=FE_RN_25_0
XFE_RC_805_0 INV2 $PINS O=FE_RN_51_0 I=FE_RN_52_0
XFE_RC_804_0 ND2P $PINS O=carry[9] I1=FE_RN_29_0 I2=FE_RN_51_0
XFE_RC_803_0 INV1S $PINS O=FE_RN_50_0 I=FE_RN_26_0
XFE_RC_802_0 OAI12H $PINS O=FE_RN_29_0 A1=carry[8] B1=FE_RN_50_0 B2=B[8]
XFE_RC_621_0 XOR3 $PINS O=SUM[5] I1=A[5] I2=B[5] I3=carry[5]
XFE_RC_620_0 MAO222P $PINS O=carry[6] A1=carry[5] B1=B[5] C1=A[5]
XFE_RC_531_0 XOR3 $PINS O=SUM[25] I1=A[25] I2=B[25] I3=carry[25]
XFE_RC_530_0 MAO222 $PINS O=carry[26] A1=carry[25] B1=B[25] C1=A[25]
XFE_RC_490_0 XOR3 $PINS O=SUM[22] I1=A[22] I2=B[22] I3=carry[22]
XFE_RC_489_0 MAO222P $PINS O=carry[23] A1=carry[22] B1=B[22] C1=A[22]
XFE_RC_418_0 XOR3 $PINS O=SUM[17] I1=A[17] I2=B[17] I3=carry[17]
XFE_RC_417_0 MAO222P $PINS O=carry[18] A1=carry[17] B1=B[17] C1=A[17]
XFE_RC_298_0 XOR3 $PINS O=SUM[23] I1=A[23] I2=B[23] I3=carry[23]
XFE_RC_297_0 MAO222P $PINS O=carry[24] A1=carry[23] B1=B[23] C1=A[23]
XFE_RC_294_0 XOR3 $PINS O=SUM[18] I1=A[18] I2=B[18] I3=carry[18]
XFE_RC_293_0 MAO222P $PINS O=carry[19] A1=carry[18] B1=B[18] C1=A[18]
XFE_RC_251_0 XOR3 $PINS O=SUM[19] I1=A[19] I2=B[19] I3=carry[19]
XFE_RC_250_0 MAO222P $PINS O=carry[20] A1=carry[19] B1=B[19] C1=A[19]
XFE_RC_247_0 XOR3 $PINS O=SUM[16] I1=A[16] I2=B[16] I3=carry[16]
XFE_RC_246_0 MAO222 $PINS O=carry[17] A1=carry[16] B1=B[16] C1=A[16]
XFE_RC_173_0 XOR3 $PINS O=SUM[14] I1=A[14] I2=B[14] I3=carry[14]
XFE_RC_172_0 MAO222 $PINS O=carry[15] A1=carry[14] B1=B[14] C1=A[14]
XFE_RC_171_0 XOR2HS $PINS O=FE_RN_20_0 I1=B[8] I2=A[8]
XFE_RC_170_0 OR2B1S $PINS O=FE_RN_21_0 I1=carry[8] B1=FE_RN_20_0
XFE_RC_169_0 ND2 $PINS O=FE_RN_22_0 I1=A[8] I2=B[8]
XFE_RC_168_0 ND2 $PINS O=FE_RN_23_0 I1=FE_RN_22_0 I2=FE_RN_28_0
XFE_RC_167_0 ND2 $PINS O=FE_RN_24_0 I1=FE_RN_23_0 I2=carry[8]
XFE_RC_166_0 ND2 $PINS O=SUM[8] I1=FE_RN_24_0 I2=FE_RN_21_0
XFE_RC_165_0 INV1S $PINS O=FE_RN_25_0 I=B[8]
XFE_RC_164_0 INV2CK $PINS O=FE_RN_26_0 I=A[8]
XFE_RC_162_0 OR2B1 $PINS O=FE_RN_28_0 I1=B[8] B1=FE_RN_26_0
XFE_RC_157_0 ND3 $PINS O=carry[5] I1=n14 I2=n15 I3=n13
XFE_RC_104_0 XOR3 $PINS O=SUM[10] I1=A[10] I2=B[10] I3=carry[10]
XFE_RC_103_0 MAO222P $PINS O=carry[11] A1=carry[10] B1=B[10] C1=A[10]
XFE_RC_60_0 ND3P $PINS O=carry[4] I1=n11 I2=n10 I3=n9
XFE_RC_55_0 XOR3 $PINS O=SUM[11] I1=A[11] I2=B[11] I3=carry[11]
XFE_RC_54_0 MAO222P $PINS O=carry[12] A1=carry[11] B1=B[11] C1=A[11]
XFE_RC_33_0 ND3P $PINS O=carry[7] I1=n18 I2=n17 I3=n16
XFE_RC_26_0 XOR3 $PINS O=SUM[12] I1=A[12] I2=B[12] I3=carry[12]
XFE_RC_25_0 MAO222P $PINS O=carry[13] A1=carry[12] B1=B[12] C1=A[12]
XU2 ND3P $PINS O=carry[14] I1=n22 I2=n23 I3=n24
XU3 ND3 $PINS O=carry[25] I1=n32 I2=n33 I3=n34
XU4 ND3 $PINS O=carry[16] I1=n25 I2=n26 I3=n27
XU5 ND2 $PINS O=n27 I1=A[15] I2=B[15]
XU7 ND2 $PINS O=n3 I1=A[20] I2=B[20]
XU8 XOR3 $PINS O=SUM[20] I1=A[20] I2=B[20] I3=carry[20]
XU9 ND2 $PINS O=n1 I1=carry[20] I2=A[20]
XU10 ND2 $PINS O=n2 I1=carry[20] I2=B[20]
XU11 ND2 $PINS O=n9 I1=A[3] I2=B[3]
XU12 ND2 $PINS O=n16 I1=A[6] I2=B[6]
XU13 XOR3 $PINS O=SUM[3] I1=A[3] I2=B[3] I3=carry[3]
XU14 XOR3 $PINS O=SUM[6] I1=A[6] I2=B[6] I3=carry[6]
XU15 XOR3 $PINS O=SUM[9] I1=B[9] I2=A[9] I3=carry[9]
XU16 XOR3 $PINS O=SUM[15] I1=A[15] I2=B[15] I3=carry[15]
XU17 XOR3 $PINS O=SUM[24] I1=A[24] I2=B[24] I3=carry[24]
XU18 ND2 $PINS O=n10 I1=carry[3] I2=A[3]
XU19 AN2 $PINS O=n4 I1=B[0] I2=A[0]
XU20 ND3P $PINS O=carry[10] I1=n5 I2=n6 I3=n7
XU21 ND2 $PINS O=n5 I1=carry[9] I2=B[9]
XU22 ND2P $PINS O=n6 I1=carry[9] I2=A[9]
XU23 ND2 $PINS O=n7 I1=B[9] I2=A[9]
XU24 XOR3 $PINS O=SUM[13] I1=B[13] I2=A[13] I3=carry[13]
XU27 ND2 $PINS O=n11 I1=carry[3] I2=B[3]
XU29 XOR2HS $PINS O=n12 I1=A[4] I2=B[4]
XU30 XOR2HS $PINS O=SUM[4] I1=n12 I2=carry[4]
XU31 ND2 $PINS O=n13 I1=A[4] I2=B[4]
XU32 ND2 $PINS O=n14 I1=carry[4] I2=A[4]
XU33 ND2 $PINS O=n15 I1=carry[4] I2=B[4]
XU34 ND2 $PINS O=n17 I1=carry[6] I2=A[6]
XU35 ND2 $PINS O=n18 I1=carry[6] I2=B[6]
XU37 XOR2HS $PINS O=n19 I1=A[7] I2=B[7]
XU38 XOR2HS $PINS O=SUM[7] I1=n19 I2=carry[7]
XU39 ND2 $PINS O=n20 I1=carry[7] I2=A[7]
XU40 ND2 $PINS O=n21 I1=carry[7] I2=B[7]
XU41 ND3P $PINS O=carry[22] I1=n29 I2=n30 I3=n31
XU42 XOR2HS $PINS O=SUM[21] I1=carry[21] I2=n28
XU44 ND2 $PINS O=n31 I1=A[21] I2=B[21]
XU46 ND2 $PINS O=n22 I1=carry[13] I2=B[13]
XU47 ND2 $PINS O=n23 I1=carry[13] I2=A[13]
XU48 ND2S $PINS O=n24 I1=B[13] I2=A[13]
XU49 ND2 $PINS O=n25 I1=carry[15] I2=A[15]
XU50 ND2 $PINS O=n26 I1=carry[15] I2=B[15]
XU51 XOR2HS $PINS O=n28 I1=A[21] I2=B[21]
XU52 ND2 $PINS O=n32 I1=carry[24] I2=A[24]
XU53 ND2 $PINS O=n33 I1=carry[24] I2=B[24]
XU54 ND2 $PINS O=n34 I1=B[24] I2=A[24]
XU55 XOR2HS $PINS O=SUM[0] I1=B[0] I2=A[0]
XU6 ND3HT $PINS O=carry[21] I1=n1 I2=n2 I3=n3
XU43 ND2P $PINS O=n30 I1=carry[21] I2=B[21]
XU45 ND2P $PINS O=n29 I1=carry[21] I2=A[21]
.ENDS

.SUBCKT PE_Shift_Add_6 rst_n en clear calc_done stage_sel x_in[16] x_in[15]
+ x_in[14] x_in[13] x_in[12] x_in[11] x_in[10] x_in[9] x_in[8] x_in[7] x_in[6]
+ x_in[5] x_in[4] x_in[3] x_in[2] x_in[1] x_in[0] sign1[1] sign1[0] sign2[1]
+ sign2[0] sign3[1] sign3[0] shf1[3] shf1[2] shf1[1] shf1[0] shf2[3] shf2[2]
+ shf2[1] shf2[0] shf3[3] shf3[2] shf3[1] shf3[0] y_out[16] y_out[15] y_out[14]
+ y_out[13] y_out[12] y_out[11] y_out[10] y_out[9] y_out[8] y_out[7] y_out[6]
+ y_out[5] y_out[4] y_out[3] y_out[2] y_out[1] y_out[0] i_rst_n
+ FE_OFN29_FE_OFN4_i_rst_n FE_OFN45_h02_3 FE_OFN52_h01_1 FE_OFN77_n FE_OFN68_n
+ FE_OFN84_n clk_clone1 clk_clone2 clk
XFE_PHC1388_N237 DELB $PINS O=FE_PHN1388_N237 I=N237
XFE_PHC1383_N235 DELB $PINS O=FE_PHN1383_N235 I=N235
XFE_PHC1353_N239 DELB $PINS O=FE_PHN1353_N239 I=N239
XFE_PHC1343_N245 DELB $PINS O=FE_PHN1343_N245 I=N245
XFE_PHC1331_N241 DELB $PINS O=FE_PHN1331_N241 I=N241
XFE_PHC1327_N246 DELB $PINS O=FE_PHN1327_N246 I=N246
XFE_PHC1316_N248 DELB $PINS O=FE_PHN1316_N248 I=N248
XFE_PHC1307_N247 DELB $PINS O=FE_PHN1307_N247 I=N247
XFE_PHC1055_next_acc_0 DELB $PINS O=FE_PHN1055_next_acc_0 I=next_acc[0]
XFE_PHC1019_N236 DELB $PINS O=FE_PHN1019_N236 I=N236
XFE_PHC1014_N238 DELB $PINS O=FE_PHN1014_N238 I=N238
XFE_PHC1003_N242 DELB $PINS O=FE_PHN1003_N242 I=N242
XFE_PHC1000_N240 DELB $PINS O=FE_PHN1000_N240 I=N240
XFE_PHC975_N244 DELB $PINS O=FE_PHN975_N244 I=N244
XFE_PHC968_N243 DELB $PINS O=FE_PHN968_N243 I=N243
XFE_PHC951_acc_reg_14 DELB $PINS O=FE_PHN951_acc_reg_14 I=acc_reg[14]
XFE_PHC947_acc_reg_16 DELB $PINS O=FE_PHN947_acc_reg_16 I=acc_reg[16]
XFE_PHC926_acc_reg_24 DELB $PINS O=FE_PHN926_acc_reg_24 I=acc_reg[24]
XFE_PHC894_acc_reg_25 DELB $PINS O=FE_PHN894_acc_reg_25 I=acc_reg[25]
XFE_PHC728_N251 DELC $PINS O=FE_PHN728_N251 I=N251
XFE_RC_1854_0 OA12 $PINS O=N96 A1=term2_shifted[0] B1=sign2[0] B2=n32
XCTS_cdb_INV_CLK_G1_L8_34 INV3CK $PINS O=CTS_4 I=CTS_5
XCTS_cdb_INV_CLK_G1_L7_34 INV2CK $PINS O=CTS_5 I=CTS_6
XFE_RC_1373_0 INV2 $PINS O=N47 I=FE_RN_293_0
XFE_RC_1372_0 AOI22S $PINS O=FE_RN_293_0 A1=N20 A2=sign1[0] B1=term1_shifted[6]
+ B2=FE_OFN359_n
XFE_RC_1344_0 INV1S $PINS O=FE_RN_280_0 I=sll_18/ML_int[2][4]
XFE_RC_1343_0 MXL2HS $PINS OB=sll_18/ML_int[3][4] S=FE_OFN180_h03_2
+ A=FE_RN_280_0 B=n75
XFE_RC_1342_0 INV2 $PINS O=N157 I=FE_RN_279_0
XFE_RC_1341_0 AOI22S $PINS O=FE_RN_279_0 A1=N130 A2=sign3[0]
+ B1=term3_shifted[6] B2=n21
XFE_RC_1337_0 AN2 $PINS O=term1_shifted[5] I1=sll_16/ML_int[3][5] I2=n42
XFE_RC_1305_0 AN2 $PINS O=term3_shifted[4] I1=sll_18/ML_int[3][4] I2=n18
XFE_RC_1300_0 INV1S $PINS O=FE_RN_264_0 I=shf3[0]
XFE_RC_1299_0 AN4B1 $PINS O=term3_shifted[0] I1=FE_RN_264_0 I2=term3_in[0]
+ I3=n14 B1=n77
XFE_RC_1251_0 AN3 $PINS O=FE_RN_244_0 I1=sll_16/ML_int[3][4] I2=n42
+ I3=FE_OFN359_n
XFE_RC_1250_0 AO12 $PINS O=N45 A1=FE_RN_244_0 B1=N18 B2=sign1[0]
XFE_RC_1213_0 INV1S $PINS O=N151 I=FE_RN_222_0
XFE_RC_1212_0 OAI12HS $PINS O=FE_RN_222_0 A1=N124 B1=sign3[0] B2=n21
XFE_RC_1124_0 INV1S $PINS O=FE_RN_185_0 I=FE_OFN359_n
XFE_RC_1123_0 MAOI1 $PINS O=FE_RN_105_0 A1=N15 A2=sign1[0] B1=n2 B2=FE_RN_185_0
XFE_RC_1120_0 AN2 $PINS O=term2_shifted[4] I1=sll_17/ML_int[3][4] I2=n29
XFE_RC_1029_0 INV1S $PINS O=FE_RN_152_0 I=FE_RN_89_0
XFE_RC_1028_0 MUXB2 $PINS O=term3_shifted[2] S=shf3[1] A=sll_18/ML_int[1][2]
+ B=sll_18/ML_int[1][0] EB=FE_RN_152_0
XFE_RC_1023_0 AN2 $PINS O=FE_RN_149_0 I1=term3_shifted[3] I2=n21
XFE_RC_1022_0 AO12T $PINS O=N154 A1=FE_RN_149_0 B1=N127 B2=sign3[0]
XFE_RC_1015_0 MUXB2 $PINS O=term1_shifted[2] S=shf1[1] A=sll_16/ML_int[1][2]
+ B=sll_16/ML_int[1][0] EB=n55
XFE_RC_1001_0 AN2S $PINS O=FE_RN_147_0 I1=term1_shifted[3] I2=FE_OFN359_n
XFE_RC_1000_0 AO12 $PINS O=N44 A1=FE_RN_147_0 B1=N17 B2=sign1[0]
XFE_RC_996_0 INV3 $PINS O=N49 I=FE_RN_146_0
XFE_RC_995_0 AOI22HP $PINS O=FE_RN_146_0 A1=N22 A2=sign1[0] B1=term1_shifted[8]
+ B2=FE_OFN359_n
XFE_RC_970_0 ND2 $PINS O=FE_RN_142_0 I1=sign1[0] I2=N16
XFE_RC_969_0 OR3B1 $PINS O=FE_RN_143_0 I1=n55 I2=n57 B1=FE_OFN359_n
XFE_RC_968_0 ND2 $PINS O=N43 I1=FE_RN_142_0 I2=FE_RN_143_0
XFE_RC_901_0 INV2 $PINS O=N99 I=FE_RN_107_0
XFE_RC_900_0 AOI22H $PINS O=FE_RN_107_0 A1=N72 A2=sign2[0] B1=term2_shifted[3]
+ B2=n32
XFE_RC_897_0 INV2 $PINS O=N42 I=FE_RN_105_0
XFE_RC_868_0 AN2 $PINS O=FE_RN_89_0 I1=n16 I2=n18
XFE_RC_851_0 ND2 $PINS O=FE_RN_75_0 I1=N125 I2=sign3[0]
XFE_RC_850_0 OR3B1 $PINS O=FE_RN_76_0 I1=n77 I2=n76 B1=n21
XFE_RC_849_0 ND2P $PINS O=N152 I1=FE_RN_75_0 I2=FE_RN_76_0
XFE_RC_835_0 INV1S $PINS O=FE_RN_66_0 I=term3_in[0]
XFE_RC_834_0 NR2 $PINS O=sll_18/ML_int[1][0] I1=shf3[0] I2=FE_RN_66_0
XFE_RC_827_0 AN2S $PINS O=FE_RN_63_0 I1=term3_shifted[8] I2=n21
XFE_RC_826_0 AO12 $PINS O=N159 A1=FE_RN_63_0 B1=sign3[0] B2=N132
XFE_RC_825_0 AN2 $PINS O=FE_RN_62_0 I1=term2_shifted[6] I2=n32
XFE_RC_824_0 AO12T $PINS O=N102 A1=FE_RN_62_0 B1=sign2[0] B2=N75
XFE_OFC690_h03_2 BUF1 $PINS O=FE_OFN370_n I=FE_OFN180_h03_2
XFE_OFC678_s01_0 INV1S $PINS O=FE_OFN360_n I=FE_OFN160_s01_0
XFE_OFC677_s01_0 INV2 $PINS O=FE_OFN359_n I=sign1[0]
XFE_OFC675_s01_0 BUF1 $PINS O=FE_OFN160_s01_0 I=sign1[0]
XFE_OFC673_s01_0 INV1S $PINS O=n45 I=sign1[0]
XFE_OFC667_h01_2 INV1S $PINS O=FE_OFN357_n I=shf1[2]
XFE_OFC665_h01_2 BUF1 $PINS O=n40 I=shf1[2]
XFE_OFC661_s01_1 INV1S $PINS O=n1 I=sign1[1]
XFE_OFC603_mac_in_imag_2 INV1S $PINS O=n100 I=x_in[2]
XFE_OFC584_sll_16_ML_int_2__3 INV1S $PINS O=n56 I=sll_16/ML_int[2][3]
XFE_OFC543_pe_clear_d1 INV1S $PINS O=FE_OFN324_n I=clear
XFE_OFC500_h02_3 INV1S $PINS O=n29 I=shf2[3]
XFE_OFC482_h02_2 BUF1 $PINS O=FE_OFN299_h02_2 I=shf2[2]
XFE_OFC476_s03_1 BUF1 $PINS O=FE_OFN293_s03_1 I=sign3[1]
XFE_OFC422_h03_0 BUF1 $PINS O=FE_OFN246_h03_0 I=shf3[0]
XFE_OFC410_s01_1 BUF1 $PINS O=FE_OFN238_s01_1 I=sign1[1]
XFE_OFC400_h02_0 INV1S $PINS O=n23 I=shf2[0]
XFE_OFC378_h01_1 INV1S $PINS O=n38 I=shf1[1]
XFE_OFC344_h02_1 INV1S $PINS O=n25 I=shf2[1]
XFE_OFC323_h03_1 BUF1 $PINS O=FE_OFN202_h03_1 I=shf3[1]
XFE_OFC322_h03_1 INV1S $PINS O=n14 I=shf3[1]
XFE_OFC277_h02_2 INV1S $PINS O=n27 I=shf2[2]
XFE_OFC258_h03_3 INV1S $PINS O=FE_OFN181_h03_3 I=n18
XFE_OFC256_h03_3 INV1S $PINS O=n18 I=shf3[3]
XFE_OFC255_h03_2 INV1S $PINS O=FE_OFN180_h03_2 I=n16
XFE_OFC254_h03_2 INV1S $PINS O=n16 I=shf3[2]
XFE_OFC246_s03_0 INV1S $PINS O=FE_OFN175_s03_0 I=sign3[0]
XFE_OFC245_s03_0 INV2 $PINS O=n21 I=sign3[0]
XFE_OFC238_h01_3 INV2 $PINS O=n42 I=shf1[3]
XFE_OFC201_s02_0 INV2 $PINS O=n32 I=sign2[0]
XFE_OFC10_i_rst_n BUF1 $PINS O=FE_OFN10_i_rst_n I=FE_OFN29_FE_OFN4_i_rst_n
XU110 AO22 $PINS O=base_val[13] A1=acc_reg[13] A2=FE_OFN324_n B1=FE_OFN68_n
+ B2=stage_sel
XU115 AO22 $PINS O=N67 A1=sign1[0] A2=N40 B1=term1_shifted[26] B2=FE_OFN84_n
XU116 AO22 $PINS O=N66 A1=N39 A2=FE_OFN160_s01_0 B1=term1_shifted[25]
+ B2=FE_OFN360_n
XU117 AO22 $PINS O=N65 A1=N38 A2=FE_OFN160_s01_0 B1=term1_shifted[24]
+ B2=FE_OFN360_n
XU118 AO22 $PINS O=N64 A1=N37 A2=FE_OFN160_s01_0 B1=term1_shifted[23]
+ B2=FE_OFN360_n
XU119 AO22 $PINS O=N63 A1=N36 A2=FE_OFN160_s01_0 B1=term1_shifted[22]
+ B2=FE_OFN360_n
XU120 AO22 $PINS O=N62 A1=N35 A2=FE_OFN160_s01_0 B1=term1_shifted[21]
+ B2=FE_OFN360_n
XU122 AO22 $PINS O=N60 A1=N33 A2=FE_OFN160_s01_0 B1=term1_shifted[19]
+ B2=FE_OFN360_n
XU123 AO22 $PINS O=N59 A1=N32 A2=FE_OFN160_s01_0 B1=term1_shifted[18]
+ B2=FE_OFN360_n
XU124 AO22 $PINS O=N58 A1=N31 A2=FE_OFN160_s01_0 B1=term1_shifted[17] B2=n45
XU125 AO22 $PINS O=N57 A1=N30 A2=FE_OFN160_s01_0 B1=term1_shifted[16] B2=n45
XU126 AO22 $PINS O=N56 A1=N29 A2=sign1[0] B1=term1_shifted[15] B2=n45
XU127 AO22 $PINS O=N55 A1=N28 A2=sign1[0] B1=term1_shifted[14] B2=n45
XU128 AO22 $PINS O=N54 A1=N27 A2=sign1[0] B1=term1_shifted[13] B2=n45
XU129 AO22 $PINS O=N53 A1=N26 A2=sign1[0] B1=term1_shifted[12] B2=n45
XU130 AO22 $PINS O=N52 A1=N25 A2=sign1[0] B1=term1_shifted[11] B2=FE_OFN359_n
XU131 AO22 $PINS O=N51 A1=N24 A2=sign1[0] B1=term1_shifted[10] B2=FE_OFN359_n
XU142 AO22 $PINS O=N177 A1=sign3[0] A2=N150 B1=term3_shifted[26]
+ B2=FE_OFN175_s03_0
XU143 AO22 $PINS O=N176 A1=N149 A2=sign3[0] B1=term3_shifted[25]
+ B2=FE_OFN175_s03_0
XU144 AO22 $PINS O=N175 A1=N148 A2=sign3[0] B1=term3_shifted[24]
+ B2=FE_OFN175_s03_0
XU145 AO22 $PINS O=N174 A1=N147 A2=sign3[0] B1=term3_shifted[23]
+ B2=FE_OFN175_s03_0
XU146 AO22 $PINS O=N173 A1=N146 A2=sign3[0] B1=term3_shifted[22]
+ B2=FE_OFN175_s03_0
XU147 AO22 $PINS O=N172 A1=N145 A2=sign3[0] B1=term3_shifted[21]
+ B2=FE_OFN175_s03_0
XU149 AO22 $PINS O=N170 A1=N143 A2=sign3[0] B1=term3_shifted[19]
+ B2=FE_OFN175_s03_0
XU150 AO22 $PINS O=N169 A1=N142 A2=sign3[0] B1=term3_shifted[18]
+ B2=FE_OFN175_s03_0
XU151 AO22 $PINS O=N168 A1=N141 A2=sign3[0] B1=term3_shifted[17]
+ B2=FE_OFN175_s03_0
XU152 AO22 $PINS O=N167 A1=N140 A2=sign3[0] B1=term3_shifted[16]
+ B2=FE_OFN175_s03_0
XU153 AO22 $PINS O=N166 A1=N139 A2=sign3[0] B1=term3_shifted[15] B2=n21
XU154 AO22 $PINS O=N165 A1=N138 A2=sign3[0] B1=term3_shifted[14] B2=n21
XU155 AO22 $PINS O=N164 A1=N137 A2=sign3[0] B1=term3_shifted[13] B2=n21
XU156 AO22 $PINS O=N163 A1=N136 A2=sign3[0] B1=term3_shifted[12] B2=n21
XU157 AO22 $PINS O=N162 A1=N135 A2=sign3[0] B1=term3_shifted[11] B2=n21
XU169 AO22 $PINS O=N122 A1=N95 A2=sign2[0] B1=term2_shifted[26] B2=n32
XU170 AO22 $PINS O=N121 A1=N94 A2=sign2[0] B1=term2_shifted[25] B2=n32
XU171 AO22 $PINS O=N120 A1=N93 A2=sign2[0] B1=term2_shifted[24] B2=n32
XU173 AO22 $PINS O=N118 A1=N91 A2=sign2[0] B1=term2_shifted[22] B2=n32
XU174 AO22 $PINS O=N117 A1=N90 A2=sign2[0] B1=term2_shifted[21] B2=n32
XU176 AO22 $PINS O=N115 A1=N88 A2=sign2[0] B1=term2_shifted[19] B2=n32
XU177 AO22 $PINS O=N114 A1=N87 A2=sign2[0] B1=term2_shifted[18] B2=n32
XU178 AO22 $PINS O=N113 A1=N86 A2=sign2[0] B1=term2_shifted[17] B2=n32
XU179 AO22 $PINS O=N112 A1=N85 A2=sign2[0] B1=term2_shifted[16] B2=n32
XU181 AO22 $PINS O=N110 A1=N83 A2=sign2[0] B1=term2_shifted[14] B2=n32
XU183 AO22 $PINS O=N108 A1=N81 A2=sign2[0] B1=term2_shifted[12] B2=n32
XU184 AO22 $PINS O=N107 A1=N80 A2=sign2[0] B1=term2_shifted[11] B2=n32
XU185 AO22 $PINS O=N106 A1=N79 A2=sign2[0] B1=term2_shifted[10] B2=n32
XU186 AO22 $PINS O=N105 A1=N78 A2=sign2[0] B1=term2_shifted[9] B2=n32
XU187 AO22 $PINS O=N104 A1=N77 A2=sign2[0] B1=term2_shifted[8] B2=n32
XU190 AO22 $PINS O=N101 A1=N74 A2=sign2[0] B1=term2_shifted[5] B2=n32
XU191 AO22P $PINS O=N100 A1=N73 A2=sign2[0] B1=term2_shifted[4] B2=n32
Xsll_18/M1_0_1 MUX2 $PINS O=sll_18/ML_int[1][1] S=shf3[0] A=term3_in[1]
+ B=term3_in[0]
Xsll_18/M1_0_2 MUX2 $PINS O=sll_18/ML_int[1][2] S=shf3[0] A=term3_in[2]
+ B=term3_in[1]
Xsll_18/M1_0_4 MUX2 $PINS O=sll_18/ML_int[1][4] S=shf3[0] A=term3_in[4]
+ B=term3_in[3]
Xsll_18/M1_0_5 MUX2 $PINS O=sll_18/ML_int[1][5] S=shf3[0] A=term3_in[5]
+ B=term3_in[4]
Xsll_18/M1_0_6 MUX2 $PINS O=sll_18/ML_int[1][6] S=shf3[0] A=term3_in[6]
+ B=term3_in[5]
Xsll_18/M1_1_2 MUX2 $PINS O=sll_18/ML_int[2][2] S=shf3[1] A=sll_18/ML_int[1][2]
+ B=sll_18/ML_int[1][0]
Xsll_18/M1_1_3 MUX2 $PINS O=sll_18/ML_int[2][3] S=shf3[1] A=sll_18/ML_int[1][3]
+ B=sll_18/ML_int[1][1]
Xsll_18/M1_1_4 MUX2 $PINS O=sll_18/ML_int[2][4] S=shf3[1] A=sll_18/ML_int[1][4]
+ B=sll_18/ML_int[1][2]
Xsll_18/M1_1_5 MUX2 $PINS O=sll_18/ML_int[2][5] S=shf3[1] A=sll_18/ML_int[1][5]
+ B=sll_18/ML_int[1][3]
Xsll_18/M1_1_6 MUX2 $PINS O=sll_18/ML_int[2][6] S=FE_OFN202_h03_1
+ A=sll_18/ML_int[1][6] B=sll_18/ML_int[1][4]
Xsll_18/M1_1_7 MUX2 $PINS O=sll_18/ML_int[2][7] S=FE_OFN202_h03_1
+ A=sll_18/ML_int[1][7] B=sll_18/ML_int[1][5]
Xsll_18/M1_2_5 MUX2 $PINS O=sll_18/ML_int[3][5] S=FE_OFN180_h03_2
+ A=sll_18/ML_int[2][5] B=n81
Xsll_18/M1_2_6 MUX2 $PINS O=sll_18/ML_int[3][6] S=FE_OFN180_h03_2
+ A=sll_18/ML_int[2][6] B=sll_18/ML_int[2][2]
Xsll_18/M1_2_7 MUX2 $PINS O=sll_18/ML_int[3][7] S=FE_OFN180_h03_2
+ A=sll_18/ML_int[2][7] B=sll_18/ML_int[2][3]
Xsll_18/M1_2_8 MUX2 $PINS O=sll_18/ML_int[3][8] S=FE_OFN370_n
+ A=sll_18/ML_int[2][8] B=sll_18/ML_int[2][4]
Xsll_18/M1_2_9 MUX2 $PINS O=sll_18/ML_int[3][9] S=FE_OFN370_n
+ A=sll_18/ML_int[2][9] B=sll_18/ML_int[2][5]
Xsll_18/M1_3_8 MUX2 $PINS O=term3_shifted[8] S=FE_OFN181_h03_3
+ A=sll_18/ML_int[3][8] B=sll_18/ML_int[3][0]
Xsll_18/M1_3_9 MUX2 $PINS O=term3_shifted[9] S=FE_OFN181_h03_3
+ A=sll_18/ML_int[3][9] B=sll_18/ML_int[3][1]
Xsll_18/M1_3_10 MUX2 $PINS O=term3_shifted[10] S=FE_OFN181_h03_3
+ A=sll_18/ML_int[3][10] B=sll_18/ML_int[3][2]
Xsll_18/M1_3_11 MUX2 $PINS O=term3_shifted[11] S=FE_OFN181_h03_3
+ A=sll_18/ML_int[3][11] B=sll_18/ML_int[3][3]
Xsll_18/M1_3_12 MUX2 $PINS O=term3_shifted[12] S=FE_OFN181_h03_3
+ A=sll_18/ML_int[3][12] B=sll_18/ML_int[3][4]
Xsll_18/M1_3_13 MUX2 $PINS O=term3_shifted[13] S=FE_OFN181_h03_3
+ A=sll_18/ML_int[3][13] B=sll_18/ML_int[3][5]
Xsll_17/M1_0_1 MUX2 $PINS O=sll_17/ML_int[1][1] S=shf2[0] A=term2_in[1]
+ B=term2_in[0]
Xsll_17/M1_0_2 MUX2 $PINS O=sll_17/ML_int[1][2] S=shf2[0] A=term2_in[2]
+ B=term2_in[1]
Xsll_17/M1_0_4 MUX2 $PINS O=sll_17/ML_int[1][4] S=shf2[0] A=term2_in[4]
+ B=term2_in[3]
Xsll_17/M1_0_6 MUX2 $PINS O=sll_17/ML_int[1][6] S=shf2[0] A=term2_in[6]
+ B=term2_in[5]
Xsll_17/M1_1_4 MUX2 $PINS O=sll_17/ML_int[2][4] S=shf2[1] A=sll_17/ML_int[1][4]
+ B=sll_17/ML_int[1][2]
Xsll_17/M1_1_5 MUX2 $PINS O=sll_17/ML_int[2][5] S=shf2[1] A=sll_17/ML_int[1][5]
+ B=sll_17/ML_int[1][3]
Xsll_17/M1_1_6 MUX2 $PINS O=sll_17/ML_int[2][6] S=shf2[1] A=sll_17/ML_int[1][6]
+ B=sll_17/ML_int[1][4]
Xsll_17/M1_1_7 MUX2 $PINS O=sll_17/ML_int[2][7] S=shf2[1] A=sll_17/ML_int[1][7]
+ B=sll_17/ML_int[1][5]
Xsll_17/M1_2_4 MUX2 $PINS O=sll_17/ML_int[3][4] S=shf2[2] A=sll_17/ML_int[2][4]
+ B=n69
Xsll_17/M1_2_5 MUX2 $PINS O=sll_17/ML_int[3][5] S=shf2[2] A=sll_17/ML_int[2][5]
+ B=n70
Xsll_17/M1_2_6 MUX2 $PINS O=sll_17/ML_int[3][6] S=shf2[2] A=sll_17/ML_int[2][6]
+ B=sll_17/ML_int[2][2]
Xsll_17/M1_2_7 MUX2 $PINS O=sll_17/ML_int[3][7] S=shf2[2] A=sll_17/ML_int[2][7]
+ B=sll_17/ML_int[2][3]
Xsll_17/M1_2_8 MUX2 $PINS O=sll_17/ML_int[3][8] S=shf2[2] A=sll_17/ML_int[2][8]
+ B=sll_17/ML_int[2][4]
Xsll_17/M1_2_9 MUX2 $PINS O=sll_17/ML_int[3][9] S=shf2[2] A=sll_17/ML_int[2][9]
+ B=sll_17/ML_int[2][5]
Xsll_17/M1_3_8 MUX2 $PINS O=term2_shifted[8] S=shf2[3] A=sll_17/ML_int[3][8]
+ B=sll_17/ML_int[3][0]
Xsll_17/M1_3_9 MUX2 $PINS O=term2_shifted[9] S=shf2[3] A=sll_17/ML_int[3][9]
+ B=sll_17/ML_int[3][1]
Xsll_17/M1_3_10 MUX2 $PINS O=term2_shifted[10] S=shf2[3] A=sll_17/ML_int[3][10]
+ B=sll_17/ML_int[3][2]
Xsll_17/M1_3_11 MUX2 $PINS O=term2_shifted[11] S=shf2[3] A=sll_17/ML_int[3][11]
+ B=sll_17/ML_int[3][3]
Xsll_17/M1_3_13 MUX2 $PINS O=term2_shifted[13] S=shf2[3] A=sll_17/ML_int[3][13]
+ B=sll_17/ML_int[3][5]
Xsll_16/M1_0_1 MUX2 $PINS O=sll_16/ML_int[1][1] S=shf1[0] A=term1_in[1]
+ B=term1_in[0]
Xsll_16/M1_0_2 MUX2 $PINS O=sll_16/ML_int[1][2] S=shf1[0] A=term1_in[2]
+ B=term1_in[1]
Xsll_16/M1_0_3 MUX2 $PINS O=sll_16/ML_int[1][3] S=shf1[0] A=term1_in[3]
+ B=term1_in[2]
Xsll_16/M1_0_4 MUX2 $PINS O=sll_16/ML_int[1][4] S=shf1[0] A=term1_in[4]
+ B=term1_in[3]
Xsll_16/M1_0_5 MUX2 $PINS O=sll_16/ML_int[1][5] S=shf1[0] A=term1_in[5]
+ B=term1_in[4]
Xsll_16/M1_0_6 MUX2 $PINS O=sll_16/ML_int[1][6] S=shf1[0] A=term1_in[6]
+ B=term1_in[5]
Xsll_16/M1_1_2 MUX2 $PINS O=sll_16/ML_int[2][2] S=shf1[1] A=sll_16/ML_int[1][2]
+ B=sll_16/ML_int[1][0]
Xsll_16/M1_1_3 MUX2 $PINS O=sll_16/ML_int[2][3] S=shf1[1] A=sll_16/ML_int[1][3]
+ B=sll_16/ML_int[1][1]
Xsll_16/M1_1_4 MUX2 $PINS O=sll_16/ML_int[2][4] S=shf1[1] A=sll_16/ML_int[1][4]
+ B=sll_16/ML_int[1][2]
Xsll_16/M1_1_5 MUX2 $PINS O=sll_16/ML_int[2][5] S=FE_OFN52_h01_1
+ A=sll_16/ML_int[1][5] B=sll_16/ML_int[1][3]
Xsll_16/M1_1_6 MUX2 $PINS O=sll_16/ML_int[2][6] S=FE_OFN52_h01_1
+ A=sll_16/ML_int[1][6] B=sll_16/ML_int[1][4]
Xsll_16/M1_1_7 MUX2 $PINS O=sll_16/ML_int[2][7] S=FE_OFN52_h01_1
+ A=sll_16/ML_int[1][7] B=sll_16/ML_int[1][5]
Xsll_16/M1_2_4 MUX2 $PINS O=sll_16/ML_int[3][4] S=shf1[2] A=sll_16/ML_int[2][4]
+ B=n58
Xsll_16/M1_2_5 MUX2 $PINS O=sll_16/ML_int[3][5] S=shf1[2] A=sll_16/ML_int[2][5]
+ B=n59
Xsll_16/M1_2_6 MUX2 $PINS O=sll_16/ML_int[3][6] S=shf1[2] A=sll_16/ML_int[2][6]
+ B=sll_16/ML_int[2][2]
Xsll_16/M1_2_7 MUX2 $PINS O=sll_16/ML_int[3][7] S=shf1[2] A=sll_16/ML_int[2][7]
+ B=sll_16/ML_int[2][3]
Xsll_16/M1_2_8 MUX2 $PINS O=sll_16/ML_int[3][8] S=shf1[2] A=sll_16/ML_int[2][8]
+ B=sll_16/ML_int[2][4]
Xsll_16/M1_2_9 MUX2 $PINS O=sll_16/ML_int[3][9] S=shf1[2] A=sll_16/ML_int[2][9]
+ B=sll_16/ML_int[2][5]
Xsll_16/M1_3_8 MUX2 $PINS O=term1_shifted[8] S=shf1[3] A=sll_16/ML_int[3][8]
+ B=sll_16/ML_int[3][0]
Xsll_16/M1_3_9 MUX2 $PINS O=term1_shifted[9] S=shf1[3] A=sll_16/ML_int[3][9]
+ B=sll_16/ML_int[3][1]
Xsll_16/M1_3_10 MUX2 $PINS O=term1_shifted[10] S=shf1[3] A=sll_16/ML_int[3][10]
+ B=sll_16/ML_int[3][2]
Xsll_16/M1_3_11 MUX2 $PINS O=term1_shifted[11] S=shf1[3] A=sll_16/ML_int[3][11]
+ B=sll_16/ML_int[3][3]
Xsll_16/M1_3_12 MUX2 $PINS O=term1_shifted[12] S=shf1[3] A=sll_16/ML_int[3][12]
+ B=sll_16/ML_int[3][4]
Xsll_16/M1_3_13 MUX2 $PINS O=term1_shifted[13] S=shf1[3] A=sll_16/ML_int[3][13]
+ B=sll_16/ML_int[3][5]
Xy_out_reg[9] QDFFRBN $PINS Q=y_out[9] D=FE_PHN975_N244 CK=CTS_4 RB=i_rst_n
Xy_out_reg[8] QDFFRBN $PINS Q=y_out[8] D=FE_PHN968_N243 CK=CTS_4 RB=i_rst_n
Xy_out_reg[7] QDFFRBN $PINS Q=y_out[7] D=FE_PHN1003_N242 CK=CTS_4 RB=i_rst_n
Xy_out_reg[6] QDFFRBN $PINS Q=y_out[6] D=FE_PHN1331_N241 CK=CTS_4 RB=i_rst_n
Xy_out_reg[5] QDFFRBN $PINS Q=y_out[5] D=FE_PHN1000_N240 CK=CTS_4 RB=i_rst_n
Xy_out_reg[4] QDFFRBN $PINS Q=y_out[4] D=FE_PHN1353_N239 CK=CTS_4 RB=i_rst_n
Xy_out_reg[3] QDFFRBN $PINS Q=y_out[3] D=FE_PHN1014_N238 CK=CTS_4 RB=i_rst_n
Xy_out_reg[2] QDFFRBN $PINS Q=y_out[2] D=FE_PHN1388_N237 CK=CTS_4 RB=i_rst_n
Xy_out_reg[1] QDFFRBN $PINS Q=y_out[1] D=FE_PHN1019_N236 CK=CTS_4 RB=i_rst_n
Xy_out_reg[0] QDFFRBN $PINS Q=y_out[0] D=FE_PHN1383_N235 CK=CTS_4 RB=i_rst_n
Xacc_reg_reg[25] QDFFRBN $PINS Q=acc_reg[25] D=next_acc[25] CK=clk_clone1
+ RB=i_rst_n
Xy_out_reg[16] QDFFRBN $PINS Q=y_out[16] D=FE_PHN728_N251 CK=CTS_4 RB=i_rst_n
Xy_out_reg[10] QDFFRBN $PINS Q=y_out[10] D=FE_PHN1343_N245 CK=CTS_4 RB=i_rst_n
Xacc_reg_reg[24] QDFFRBN $PINS Q=acc_reg[24] D=next_acc[24] CK=clk_clone1
+ RB=i_rst_n
Xy_out_reg[11] QDFFRBN $PINS Q=y_out[11] D=FE_PHN1327_N246 CK=CTS_4 RB=i_rst_n
Xy_out_reg[12] QDFFRBN $PINS Q=y_out[12] D=FE_PHN1307_N247 CK=CTS_4 RB=i_rst_n
Xy_out_reg[14] QDFFRBN $PINS Q=y_out[14] D=N249 CK=CTS_4 RB=i_rst_n
Xy_out_reg[15] QDFFRBN $PINS Q=y_out[15] D=N250 CK=CTS_4 RB=i_rst_n
Xy_out_reg[13] QDFFRBN $PINS Q=y_out[13] D=FE_PHN1316_N248 CK=CTS_4 RB=i_rst_n
Xacc_reg_reg[23] QDFFRBN $PINS Q=acc_reg[23] D=next_acc[23] CK=clk_clone1
+ RB=i_rst_n
Xacc_reg_reg[22] QDFFRBN $PINS Q=acc_reg[22] D=next_acc[22] CK=clk_clone1
+ RB=i_rst_n
Xacc_reg_reg[21] QDFFRBN $PINS Q=acc_reg[21] D=next_acc[21] CK=clk_clone1
+ RB=i_rst_n
Xacc_reg_reg[20] QDFFRBN $PINS Q=acc_reg[20] D=next_acc[20] CK=clk_clone1
+ RB=i_rst_n
Xacc_reg_reg[19] QDFFRBN $PINS Q=acc_reg[19] D=next_acc[19] CK=clk_clone1
+ RB=i_rst_n
Xacc_reg_reg[18] QDFFRBN $PINS Q=acc_reg[18] D=next_acc[18] CK=clk_clone1
+ RB=i_rst_n
Xacc_reg_reg[17] QDFFRBN $PINS Q=acc_reg[17] D=next_acc[17] CK=clk_clone1
+ RB=i_rst_n
Xacc_reg_reg[16] QDFFRBN $PINS Q=acc_reg[16] D=next_acc[16] CK=clk_clone1
+ RB=FE_OFN29_FE_OFN4_i_rst_n
Xacc_reg_reg[15] QDFFRBN $PINS Q=acc_reg[15] D=next_acc[15] CK=clk_clone1
+ RB=FE_OFN29_FE_OFN4_i_rst_n
Xacc_reg_reg[14] QDFFRBN $PINS Q=acc_reg[14] D=next_acc[14] CK=clk_clone1
+ RB=FE_OFN29_FE_OFN4_i_rst_n
Xacc_reg_reg[13] QDFFRBN $PINS Q=acc_reg[13] D=next_acc[13] CK=clk_clone1
+ RB=FE_OFN29_FE_OFN4_i_rst_n
Xacc_reg_reg[12] QDFFRBN $PINS Q=acc_reg[12] D=next_acc[12] CK=clk_clone1
+ RB=FE_OFN29_FE_OFN4_i_rst_n
Xacc_reg_reg[11] QDFFRBN $PINS Q=acc_reg[11] D=next_acc[11] CK=clk_clone1
+ RB=FE_OFN29_FE_OFN4_i_rst_n
Xacc_reg_reg[10] QDFFRBN $PINS Q=acc_reg[10] D=next_acc[10] CK=clk_clone1
+ RB=FE_OFN29_FE_OFN4_i_rst_n
Xacc_reg_reg[9] QDFFRBN $PINS Q=acc_reg[9] D=next_acc[9] CK=clk
+ RB=FE_OFN10_i_rst_n
Xacc_reg_reg[8] QDFFRBN $PINS Q=acc_reg[8] D=next_acc[8] CK=clk
+ RB=FE_OFN10_i_rst_n
Xacc_reg_reg[7] QDFFRBN $PINS Q=acc_reg[7] D=next_acc[7] CK=clk
+ RB=FE_OFN10_i_rst_n
Xacc_reg_reg[6] QDFFRBN $PINS Q=acc_reg[6] D=next_acc[6] CK=clk
+ RB=FE_OFN10_i_rst_n
Xacc_reg_reg[5] QDFFRBN $PINS Q=acc_reg[5] D=next_acc[5] CK=clk
+ RB=FE_OFN10_i_rst_n
Xacc_reg_reg[4] QDFFRBN $PINS Q=acc_reg[4] D=next_acc[4] CK=clk
+ RB=FE_OFN29_FE_OFN4_i_rst_n
Xacc_reg_reg[3] QDFFRBN $PINS Q=acc_reg[3] D=next_acc[3] CK=clk
+ RB=FE_OFN29_FE_OFN4_i_rst_n
Xacc_reg_reg[2] QDFFRBN $PINS Q=acc_reg[2] D=next_acc[2] CK=clk
+ RB=FE_OFN29_FE_OFN4_i_rst_n
Xacc_reg_reg[1] QDFFRBN $PINS Q=acc_reg[1] D=next_acc[1] CK=clk
+ RB=FE_OFN29_FE_OFN4_i_rst_n
Xacc_reg_reg[0] QDFFRBS $PINS Q=acc_reg[0] D=FE_PHN1055_next_acc_0 CK=clk
+ RB=FE_OFN29_FE_OFN4_i_rst_n
Xacc_reg_reg[26] QDFFRBP $PINS Q=N251 D=next_acc[26] CK=clk_clone1 RB=i_rst_n
XU4 INV2 $PINS O=n67 I=sll_17/ML_int[2][3]
XU10 INV1S $PINS O=n78 I=sll_18/ML_int[2][3]
XU13 NR2 $PINS O=term2_in[2] I1=sign2[1] I2=x_in[2]
XU21 MUX2S $PINS O=sll_18/ML_int[1][3] S=shf3[0] A=term3_in[3] B=term3_in[2]
XU25 NR2P $PINS O=term2_shifted[1] I1=n66 I2=n65
XU26 ND2 $PINS O=n65 I1=sll_17/ML_int[1][1] I2=n25
XU27 AN2 $PINS O=term1_in[2] I1=n100 I2=n1
XU28 INV2 $PINS O=n68 I=sll_17/ML_int[2][2]
XU29 NR2 $PINS O=term2_shifted[2] I1=n66 I2=n68
XU32 MUX2 $PINS O=N248 S=stage_sel A=acc_reg[23] B=FE_PHN728_N251
XU33 MUX2 $PINS O=N250 S=stage_sel A=FE_PHN894_acc_reg_25 B=FE_PHN728_N251
XU34 AN2S $PINS O=sll_17/ML_int[1][0] I1=term2_in[0] I2=n23
XU37 MUX2S $PINS O=term2_shifted[12] S=n29 A=sll_17/ML_int[3][4]
+ B=sll_17/ML_int[3][12]
XU38 MUX2 $PINS O=N249 S=stage_sel A=FE_PHN926_acc_reg_24 B=FE_PHN728_N251
XU39 NR2 $PINS O=term1_in[1] I1=sign1[1] I2=x_in[1]
XU40 ND3 $PINS O=n53 I1=term1_in[0] I2=n36 I3=n38
XU41 ND3 $PINS O=n64 I1=term2_in[0] I2=n23 I3=n25
XU42 NR2P $PINS O=term2_shifted[3] I1=n66 I2=n67
XU43 AN2 $PINS O=base_val[24] I1=acc_reg[24] I2=FE_OFN77_n
XU44 MUX2 $PINS O=N247 S=stage_sel A=acc_reg[22] B=FE_PHN728_N251
XU46 NR2P $PINS O=term3_shifted[3] I1=n78 I2=n77
XU47 ND2 $PINS O=n2 I1=sll_16/ML_int[1][1] I2=n10
XU48 INV2 $PINS O=term1_shifted[1] I=n2
XU54 NR2 $PINS O=term3_in[1] I1=sign3[1] I2=x_in[1]
XU55 NR2P $PINS O=term3_in[0] I1=sign3[1] I2=x_in[0]
XU58 ND2 $PINS O=n3 I1=N71 I2=sign2[0]
XU59 ND2S $PINS O=n4 I1=term2_shifted[2] I2=n32
XU64 INV1S $PINS O=n79 I=sll_18/ML_int[2][2]
XU65 ND2 $PINS O=N41 I1=n8 I2=n9
XU67 NR2P $PINS O=term1_shifted[3] I1=n55 I2=n56
XU70 AO22 $PINS O=N155 A1=N128 A2=sign3[0] B1=term3_shifted[4] B2=n21
XU71 AO22 $PINS O=N160 A1=N133 A2=sign3[0] B1=term3_shifted[9] B2=n21
XU72 AO22 $PINS O=N50 A1=N23 A2=sign1[0] B1=term1_shifted[9] B2=FE_OFN359_n
XU73 AO22 $PINS O=N111 A1=N84 A2=sign2[0] B1=term2_shifted[15] B2=n32
XU74 AN2 $PINS O=base_val[15] I1=acc_reg[15] I2=FE_OFN77_n
XU75 AO22 $PINS O=N153 A1=sign3[0] A2=N126 B1=term3_shifted[2] B2=n21
XU77 AO22 $PINS O=N171 A1=N144 A2=sign3[0] B1=term3_shifted[20]
+ B2=FE_OFN175_s03_0
XU78 AO22 $PINS O=N61 A1=N34 A2=FE_OFN160_s01_0 B1=term1_shifted[20]
+ B2=FE_OFN360_n
XU83 ND2 $PINS O=n55 I1=FE_OFN357_n I2=n42
XU87 AO22S $PINS O=N116 A1=N89 A2=sign2[0] B1=term2_shifted[20] B2=n32
XU88 AO22S $PINS O=N119 A1=N92 A2=sign2[0] B1=term2_shifted[23] B2=n32
XU89 AO22 $PINS O=N46 A1=N19 A2=sign1[0] B1=term1_shifted[5] B2=FE_OFN359_n
XU90 AO22 $PINS O=N156 A1=N129 A2=sign3[0] B1=term3_shifted[5] B2=n21
XU91 AO22 $PINS O=N103 A1=sign2[0] A2=N76 B1=term2_shifted[7] B2=n32
XU92 ND2S $PINS O=n7 I1=term2_shifted[1] I2=n32
XU93 ND2 $PINS O=N97 I1=n6 I2=n7
XU94 AO22 $PINS O=N48 A1=N21 A2=sign1[0] B1=term1_shifted[7] B2=FE_OFN359_n
XU95 AO22 $PINS O=N158 A1=N131 A2=sign3[0] B1=term3_shifted[7] B2=n21
XU96 ND2S $PINS O=n8 I1=N14 I2=sign1[0]
XU97 ND2S $PINS O=n9 I1=term1_shifted[0] I2=FE_OFN359_n
XU98 MUX2S $PINS O=sll_16/ML_int[1][8] S=shf1[0] A=term1_in[8] B=term1_in[7]
XU99 MUX2S $PINS O=sll_18/ML_int[1][8] S=FE_OFN246_h03_0 A=term3_in[8]
+ B=term3_in[7]
XU100 MUX2S $PINS O=sll_17/ML_int[1][8] S=shf2[0] A=term2_in[8] B=term2_in[7]
XU101 NR2 $PINS O=n10 I1=shf1[1] I2=n55
XU103 INV1S $PINS O=n70 I=n65
XU104 ND2S $PINS O=n54 I1=sll_16/ML_int[1][1] I2=n38
XU105 AN2 $PINS O=base_val[0] I1=acc_reg[0] I2=FE_OFN324_n
XU106 MUX2 $PINS O=sll_16/ML_int[1][7] S=shf1[0] A=term1_in[7] B=term1_in[6]
XU107 MUX2S $PINS O=sll_18/ML_int[1][7] S=shf3[0] A=term3_in[7] B=term3_in[6]
XU108 MUX2S $PINS O=sll_17/ML_int[1][7] S=shf2[0] A=term2_in[7] B=term2_in[6]
XU109 MUX2S $PINS O=sll_18/ML_int[2][8] S=FE_OFN202_h03_1 A=sll_18/ML_int[1][8]
+ B=sll_18/ML_int[1][6]
XU111 MUX2S $PINS O=sll_16/ML_int[2][8] S=FE_OFN52_h01_1 A=sll_16/ML_int[1][8]
+ B=sll_16/ML_int[1][6]
XU112 MUX2S $PINS O=sll_17/ML_int[2][8] S=shf2[1] A=sll_17/ML_int[1][8]
+ B=sll_17/ML_int[1][6]
XU113 MUX2S $PINS O=sll_18/ML_int[2][9] S=FE_OFN202_h03_1 A=sll_18/ML_int[1][9]
+ B=sll_18/ML_int[1][7]
XU114 MUX2S $PINS O=sll_18/ML_int[1][9] S=FE_OFN246_h03_0 A=term3_in[9]
+ B=term3_in[8]
XU121 MUX2S $PINS O=sll_16/ML_int[2][9] S=FE_OFN52_h01_1 A=sll_16/ML_int[1][9]
+ B=sll_16/ML_int[1][7]
XU132 MUX2S $PINS O=sll_16/ML_int[1][9] S=shf1[0] A=term1_in[9] B=term1_in[8]
XU134 MUX2S $PINS O=sll_17/ML_int[2][9] S=shf2[1] A=sll_17/ML_int[1][9]
+ B=sll_17/ML_int[1][7]
XU136 MUX2S $PINS O=sll_17/ML_int[1][9] S=shf2[0] A=term2_in[9] B=term2_in[8]
XU137 MUX2S $PINS O=sll_16/ML_int[3][10] S=shf1[2] A=sll_16/ML_int[2][10]
+ B=sll_16/ML_int[2][6]
XU138 MUX2S $PINS O=sll_16/ML_int[2][10] S=FE_OFN52_h01_1
+ A=sll_16/ML_int[1][10] B=sll_16/ML_int[1][8]
XU139 MUX2S $PINS O=sll_16/ML_int[1][10] S=shf1[0] A=term1_in[10] B=term1_in[9]
XU140 MUX2S $PINS O=sll_18/ML_int[3][10] S=FE_OFN370_n A=sll_18/ML_int[2][10]
+ B=sll_18/ML_int[2][6]
XU141 MUX2S $PINS O=sll_18/ML_int[2][10] S=FE_OFN202_h03_1
+ A=sll_18/ML_int[1][10] B=sll_18/ML_int[1][8]
XU148 MUX2S $PINS O=sll_18/ML_int[1][10] S=FE_OFN246_h03_0 A=term3_in[10]
+ B=term3_in[9]
XU158 MUX2S $PINS O=sll_17/ML_int[3][10] S=shf2[2] A=sll_17/ML_int[2][10]
+ B=sll_17/ML_int[2][6]
XU159 MUX2S $PINS O=sll_17/ML_int[2][10] S=shf2[1] A=sll_17/ML_int[1][10]
+ B=sll_17/ML_int[1][8]
XU161 MUX2S $PINS O=sll_17/ML_int[1][10] S=shf2[0] A=term2_in[10] B=term2_in[9]
XU163 MUX2S $PINS O=sll_16/ML_int[3][11] S=n40 A=sll_16/ML_int[2][11]
+ B=sll_16/ML_int[2][7]
XU164 MUX2S $PINS O=sll_16/ML_int[2][11] S=FE_OFN52_h01_1
+ A=sll_16/ML_int[1][11] B=sll_16/ML_int[1][9]
XU165 MUX2S $PINS O=sll_16/ML_int[1][11] S=shf1[0] A=term1_in[11]
+ B=term1_in[10]
XU166 MUX2S $PINS O=sll_18/ML_int[3][11] S=FE_OFN370_n A=sll_18/ML_int[2][11]
+ B=sll_18/ML_int[2][7]
XU167 MUX2S $PINS O=sll_18/ML_int[2][11] S=FE_OFN202_h03_1
+ A=sll_18/ML_int[1][11] B=sll_18/ML_int[1][9]
XU172 MUX2S $PINS O=sll_18/ML_int[1][11] S=FE_OFN246_h03_0 A=term3_in[11]
+ B=term3_in[10]
XU175 MUX2S $PINS O=sll_17/ML_int[3][11] S=shf2[2] A=sll_17/ML_int[2][11]
+ B=sll_17/ML_int[2][7]
XU180 MUX2S $PINS O=sll_17/ML_int[2][11] S=shf2[1] A=sll_17/ML_int[1][11]
+ B=sll_17/ML_int[1][9]
XU182 MUX2S $PINS O=sll_17/ML_int[1][11] S=shf2[0] A=term2_in[11]
+ B=term2_in[10]
XU188 MUX2S $PINS O=sll_16/ML_int[3][12] S=n40 A=sll_16/ML_int[2][12]
+ B=sll_16/ML_int[2][8]
XU192 MUX2S $PINS O=sll_16/ML_int[2][12] S=FE_OFN52_h01_1
+ A=sll_16/ML_int[1][12] B=sll_16/ML_int[1][10]
XU193 MUX2S $PINS O=sll_16/ML_int[1][12] S=shf1[0] A=term1_in[12]
+ B=term1_in[11]
XU194 MUX2S $PINS O=sll_18/ML_int[3][12] S=FE_OFN370_n A=sll_18/ML_int[2][12]
+ B=sll_18/ML_int[2][8]
XU195 MUX2S $PINS O=sll_18/ML_int[2][12] S=FE_OFN202_h03_1
+ A=sll_18/ML_int[1][12] B=sll_18/ML_int[1][10]
XU196 MUX2S $PINS O=sll_18/ML_int[1][12] S=FE_OFN246_h03_0 A=term3_in[12]
+ B=term3_in[11]
XU197 MUX2S $PINS O=sll_17/ML_int[3][12] S=shf2[2] A=sll_17/ML_int[2][12]
+ B=sll_17/ML_int[2][8]
XU198 MUX2S $PINS O=sll_17/ML_int[2][12] S=shf2[1] A=sll_17/ML_int[1][12]
+ B=sll_17/ML_int[1][10]
XU199 MUX2S $PINS O=sll_17/ML_int[1][12] S=shf2[0] A=term2_in[12]
+ B=term2_in[11]
XU200 MUX2S $PINS O=sll_16/ML_int[3][13] S=n40 A=sll_16/ML_int[2][13]
+ B=sll_16/ML_int[2][9]
XU201 MUX2S $PINS O=sll_16/ML_int[2][13] S=FE_OFN52_h01_1
+ A=sll_16/ML_int[1][13] B=sll_16/ML_int[1][11]
XU202 MUX2S $PINS O=sll_16/ML_int[1][13] S=shf1[0] A=term1_in[13]
+ B=term1_in[12]
XU203 MUX2S $PINS O=sll_18/ML_int[3][13] S=FE_OFN370_n A=sll_18/ML_int[2][13]
+ B=sll_18/ML_int[2][9]
XU204 MUX2S $PINS O=sll_18/ML_int[2][13] S=FE_OFN202_h03_1
+ A=sll_18/ML_int[1][13] B=sll_18/ML_int[1][11]
XU205 MUX2S $PINS O=sll_18/ML_int[1][13] S=FE_OFN246_h03_0 A=term3_in[13]
+ B=term3_in[12]
XU206 MUX2S $PINS O=sll_17/ML_int[3][13] S=FE_OFN299_h02_2
+ A=sll_17/ML_int[2][13] B=sll_17/ML_int[2][9]
XU207 MUX2S $PINS O=sll_17/ML_int[2][13] S=shf2[1] A=sll_17/ML_int[1][13]
+ B=sll_17/ML_int[1][11]
XU208 MUX2S $PINS O=sll_17/ML_int[1][13] S=shf2[0] A=term2_in[13]
+ B=term2_in[12]
XU209 MUX2S $PINS O=term1_shifted[14] S=shf1[3] A=sll_16/ML_int[3][14]
+ B=sll_16/ML_int[3][6]
XU210 MUX2S $PINS O=sll_16/ML_int[3][14] S=n40 A=sll_16/ML_int[2][14]
+ B=sll_16/ML_int[2][10]
XU211 MUX2S $PINS O=sll_16/ML_int[2][14] S=FE_OFN52_h01_1
+ A=sll_16/ML_int[1][14] B=sll_16/ML_int[1][12]
XU212 MUX2S $PINS O=sll_16/ML_int[1][14] S=shf1[0] A=term1_in[14]
+ B=term1_in[13]
XU213 MUX2S $PINS O=term3_shifted[14] S=FE_OFN181_h03_3 A=sll_18/ML_int[3][14]
+ B=sll_18/ML_int[3][6]
XU214 MUX2S $PINS O=sll_18/ML_int[3][14] S=FE_OFN370_n A=sll_18/ML_int[2][14]
+ B=sll_18/ML_int[2][10]
XU215 MUX2S $PINS O=sll_18/ML_int[2][14] S=FE_OFN202_h03_1
+ A=sll_18/ML_int[1][14] B=sll_18/ML_int[1][12]
XU216 MUX2S $PINS O=sll_18/ML_int[1][14] S=FE_OFN246_h03_0 A=term3_in[14]
+ B=term3_in[13]
XU217 MUX2S $PINS O=term2_shifted[14] S=shf2[3] A=sll_17/ML_int[3][14]
+ B=sll_17/ML_int[3][6]
XU218 MUX2S $PINS O=sll_17/ML_int[3][14] S=shf2[2] A=sll_17/ML_int[2][14]
+ B=sll_17/ML_int[2][10]
XU219 MUX2S $PINS O=sll_17/ML_int[2][14] S=shf2[1] A=sll_17/ML_int[1][14]
+ B=sll_17/ML_int[1][12]
XU220 MUX2S $PINS O=sll_17/ML_int[1][14] S=shf2[0] A=term2_in[14]
+ B=term2_in[13]
XU221 MUX2S $PINS O=term1_shifted[16] S=shf1[3] A=sll_16/ML_int[3][16]
+ B=sll_16/ML_int[3][8]
XU222 MUX2S $PINS O=sll_16/ML_int[3][16] S=n40 A=n60 B=sll_16/ML_int[2][12]
XU223 MUX2S $PINS O=n60 S=FE_OFN52_h01_1 A=n63 B=sll_16/ML_int[1][14]
XU224 MUX2S $PINS O=term3_shifted[16] S=FE_OFN181_h03_3 A=sll_18/ML_int[3][16]
+ B=sll_18/ML_int[3][8]
XU225 MUX2S $PINS O=sll_18/ML_int[3][16] S=FE_OFN370_n A=n82
+ B=sll_18/ML_int[2][12]
XU226 MUX2S $PINS O=n82 S=FE_OFN202_h03_1 A=n85 B=sll_18/ML_int[1][14]
XU227 MUX2S $PINS O=term2_shifted[16] S=shf2[3] A=sll_17/ML_int[3][16]
+ B=sll_17/ML_int[3][8]
XU228 MUX2S $PINS O=sll_17/ML_int[3][16] S=FE_OFN299_h02_2 A=n71
+ B=sll_17/ML_int[2][12]
XU229 MUX2S $PINS O=n71 S=shf2[1] A=n74 B=sll_17/ML_int[1][14]
XU230 MUX2S $PINS O=term1_shifted[15] S=shf1[3] A=sll_16/ML_int[3][15]
+ B=sll_16/ML_int[3][7]
XU231 MUX2S $PINS O=sll_16/ML_int[3][15] S=n40 A=sll_16/ML_int[2][15]
+ B=sll_16/ML_int[2][11]
XU232 MUX2S $PINS O=sll_16/ML_int[2][15] S=FE_OFN52_h01_1
+ A=sll_16/ML_int[1][15] B=sll_16/ML_int[1][13]
XU233 MUX2S $PINS O=sll_16/ML_int[1][15] S=shf1[0] A=term1_in[15]
+ B=term1_in[14]
XU234 MUX2S $PINS O=term3_shifted[15] S=FE_OFN181_h03_3 A=sll_18/ML_int[3][15]
+ B=sll_18/ML_int[3][7]
XU235 MUX2S $PINS O=sll_18/ML_int[3][15] S=FE_OFN370_n A=sll_18/ML_int[2][15]
+ B=sll_18/ML_int[2][11]
XU236 MUX2S $PINS O=sll_18/ML_int[2][15] S=FE_OFN202_h03_1
+ A=sll_18/ML_int[1][15] B=sll_18/ML_int[1][13]
XU237 MUX2S $PINS O=sll_18/ML_int[1][15] S=FE_OFN246_h03_0 A=term3_in[15]
+ B=term3_in[14]
XU238 MUX2S $PINS O=term2_shifted[15] S=shf2[3] A=sll_17/ML_int[3][15]
+ B=sll_17/ML_int[3][7]
XU239 MUX2S $PINS O=sll_17/ML_int[3][15] S=FE_OFN299_h02_2
+ A=sll_17/ML_int[2][15] B=sll_17/ML_int[2][11]
XU240 MUX2S $PINS O=sll_17/ML_int[2][15] S=shf2[1] A=sll_17/ML_int[1][15]
+ B=sll_17/ML_int[1][13]
XU241 MUX2S $PINS O=sll_17/ML_int[1][15] S=shf2[0] A=term2_in[15]
+ B=term2_in[14]
XU242 MUX2S $PINS O=term1_shifted[17] S=shf1[3] A=sll_16/ML_int[3][17]
+ B=sll_16/ML_int[3][9]
XU243 MUX2S $PINS O=n61 S=FE_OFN52_h01_1 A=term1_in[26] B=sll_16/ML_int[1][15]
XU244 MUX2S $PINS O=sll_16/ML_int[3][17] S=n40 A=n61 B=sll_16/ML_int[2][13]
XU245 MUX2S $PINS O=term3_shifted[17] S=FE_OFN181_h03_3 A=sll_18/ML_int[3][17]
+ B=sll_18/ML_int[3][9]
XU246 MUX2S $PINS O=n83 S=FE_OFN202_h03_1 A=term3_in[26] B=sll_18/ML_int[1][15]
XU247 MUX2S $PINS O=sll_18/ML_int[3][17] S=FE_OFN370_n A=n83
+ B=sll_18/ML_int[2][13]
XU248 MUX2S $PINS O=term2_shifted[17] S=shf2[3] A=sll_17/ML_int[3][17]
+ B=sll_17/ML_int[3][9]
XU249 MUX2S $PINS O=n72 S=shf2[1] A=term2_in[26] B=sll_17/ML_int[1][15]
XU250 MUX2S $PINS O=sll_17/ML_int[3][17] S=FE_OFN299_h02_2 A=n72
+ B=sll_17/ML_int[2][13]
XU251 MUX2S $PINS O=term1_shifted[18] S=shf1[3] A=sll_16/ML_int[3][18]
+ B=sll_16/ML_int[3][10]
XU252 MUX2S $PINS O=sll_16/ML_int[3][18] S=n40 A=n62 B=sll_16/ML_int[2][14]
XU253 MUX2S $PINS O=n62 S=FE_OFN52_h01_1 A=term1_in[26] B=n63
XU254 MUX2S $PINS O=term3_shifted[18] S=FE_OFN181_h03_3 A=sll_18/ML_int[3][18]
+ B=sll_18/ML_int[3][10]
XU255 MUX2S $PINS O=sll_18/ML_int[3][18] S=FE_OFN370_n A=n84
+ B=sll_18/ML_int[2][14]
XU256 MUX2S $PINS O=n84 S=FE_OFN202_h03_1 A=term3_in[26] B=n85
XU257 MUX2S $PINS O=term2_shifted[18] S=shf2[3] A=sll_17/ML_int[3][18]
+ B=sll_17/ML_int[3][10]
XU258 MUX2S $PINS O=sll_17/ML_int[3][18] S=FE_OFN299_h02_2 A=n73
+ B=sll_17/ML_int[2][14]
XU259 MUX2S $PINS O=n73 S=shf2[1] A=term2_in[26] B=n74
XU260 MUX2S $PINS O=term1_shifted[20] S=shf1[3] A=sll_16/ML_int[3][20]
+ B=sll_16/ML_int[3][12]
XU261 MUX2S $PINS O=sll_16/ML_int[3][20] S=n40 A=term1_in[26] B=n60
XU262 MUX2S $PINS O=term1_shifted[19] S=shf1[3] A=sll_16/ML_int[3][19]
+ B=sll_16/ML_int[3][11]
XU263 MUX2S $PINS O=sll_16/ML_int[3][19] S=n40 A=term1_in[26]
+ B=sll_16/ML_int[2][15]
XU264 MUX2S $PINS O=term3_shifted[20] S=FE_OFN181_h03_3 A=sll_18/ML_int[3][20]
+ B=sll_18/ML_int[3][12]
XU265 MUX2S $PINS O=sll_18/ML_int[3][20] S=FE_OFN370_n A=term3_in[26] B=n82
XU266 MUX2S $PINS O=term3_shifted[19] S=FE_OFN181_h03_3 A=sll_18/ML_int[3][19]
+ B=sll_18/ML_int[3][11]
XU267 MUX2S $PINS O=sll_18/ML_int[3][19] S=FE_OFN370_n A=term3_in[26]
+ B=sll_18/ML_int[2][15]
XU268 MUX2S $PINS O=term2_shifted[20] S=shf2[3] A=sll_17/ML_int[3][20]
+ B=sll_17/ML_int[3][12]
XU269 MUX2S $PINS O=sll_17/ML_int[3][20] S=FE_OFN299_h02_2 A=term2_in[26] B=n71
XU270 MUX2S $PINS O=term2_shifted[19] S=shf2[3] A=sll_17/ML_int[3][19]
+ B=sll_17/ML_int[3][11]
XU271 MUX2S $PINS O=sll_17/ML_int[3][19] S=FE_OFN299_h02_2 A=term2_in[26]
+ B=sll_17/ML_int[2][15]
XU272 MUX2S $PINS O=term1_shifted[21] S=shf1[3] A=sll_16/ML_int[3][21]
+ B=sll_16/ML_int[3][13]
XU273 MUX2S $PINS O=sll_16/ML_int[3][21] S=n40 A=term1_in[26] B=n61
XU274 MUX2S $PINS O=term3_shifted[21] S=FE_OFN181_h03_3 A=sll_18/ML_int[3][21]
+ B=sll_18/ML_int[3][13]
XU275 MUX2S $PINS O=sll_18/ML_int[3][21] S=FE_OFN370_n A=term3_in[26] B=n83
XU276 MUX2S $PINS O=term2_shifted[21] S=shf2[3] A=sll_17/ML_int[3][21]
+ B=sll_17/ML_int[3][13]
XU277 MUX2S $PINS O=sll_17/ML_int[3][21] S=FE_OFN299_h02_2 A=term2_in[26] B=n72
XU278 MUX2S $PINS O=term1_shifted[22] S=shf1[3] A=sll_16/ML_int[3][22]
+ B=sll_16/ML_int[3][14]
XU279 MUX2S $PINS O=sll_16/ML_int[3][22] S=n40 A=term1_in[26] B=n62
XU280 MUX2S $PINS O=term3_shifted[22] S=FE_OFN181_h03_3 A=sll_18/ML_int[3][22]
+ B=sll_18/ML_int[3][14]
XU281 MUX2S $PINS O=sll_18/ML_int[3][22] S=FE_OFN370_n A=term3_in[26] B=n84
XU282 MUX2S $PINS O=term2_shifted[22] S=shf2[3] A=sll_17/ML_int[3][22]
+ B=sll_17/ML_int[3][14]
XU283 MUX2S $PINS O=sll_17/ML_int[3][22] S=FE_OFN299_h02_2 A=term2_in[26] B=n73
XU284 MUX2S $PINS O=term1_shifted[24] S=shf1[3] A=term1_in[26]
+ B=sll_16/ML_int[3][16]
XU285 MUX2S $PINS O=term3_shifted[24] S=FE_OFN181_h03_3 A=term3_in[26]
+ B=sll_18/ML_int[3][16]
XU286 MUX2S $PINS O=term2_shifted[24] S=shf2[3] A=term2_in[26]
+ B=sll_17/ML_int[3][16]
XU287 MUX2S $PINS O=term1_shifted[23] S=shf1[3] A=term1_in[26]
+ B=sll_16/ML_int[3][15]
XU288 MUX2S $PINS O=term3_shifted[23] S=FE_OFN181_h03_3 A=term3_in[26]
+ B=sll_18/ML_int[3][15]
XU289 MUX2S $PINS O=term2_shifted[23] S=shf2[3] A=term2_in[26]
+ B=sll_17/ML_int[3][15]
XU290 MUX2S $PINS O=term1_shifted[25] S=shf1[3] A=term1_in[26]
+ B=sll_16/ML_int[3][17]
XU291 MUX2S $PINS O=term3_shifted[25] S=FE_OFN181_h03_3 A=term3_in[26]
+ B=sll_18/ML_int[3][17]
XU292 MUX2S $PINS O=term2_shifted[25] S=shf2[3] A=term2_in[26]
+ B=sll_17/ML_int[3][17]
XU293 MUX2S $PINS O=term1_shifted[26] S=shf1[3] A=term1_in[26]
+ B=sll_16/ML_int[3][18]
XU294 MUX2S $PINS O=term3_shifted[26] S=FE_OFN181_h03_3 A=term3_in[26]
+ B=sll_18/ML_int[3][18]
XU295 MUX2S $PINS O=term2_shifted[26] S=shf2[3] A=term2_in[26]
+ B=sll_17/ML_int[3][18]
XU296 AO22S $PINS O=N161 A1=N134 A2=sign3[0] B1=term3_shifted[10] B2=n21
XU298 AO22 $PINS O=N109 A1=N82 A2=sign2[0] B1=term2_shifted[13] B2=n32
XU299 MUX2S $PINS O=N235 S=stage_sel A=acc_reg[10] B=FE_PHN951_acc_reg_14
XU300 MUX2S $PINS O=N236 S=stage_sel A=acc_reg[11] B=acc_reg[15]
XU301 MUX2S $PINS O=N237 S=stage_sel A=acc_reg[12] B=FE_PHN947_acc_reg_16
XU302 MUX2S $PINS O=N238 S=stage_sel A=acc_reg[13] B=acc_reg[17]
XU303 MUX2S $PINS O=N239 S=stage_sel A=FE_PHN951_acc_reg_14 B=acc_reg[18]
XU304 MUX2S $PINS O=N240 S=stage_sel A=acc_reg[15] B=acc_reg[19]
XU305 MUX2S $PINS O=N242 S=stage_sel A=acc_reg[17] B=acc_reg[21]
XU306 MUX2S $PINS O=N245 S=stage_sel A=acc_reg[20] B=FE_PHN926_acc_reg_24
XU307 MUX2S $PINS O=N246 S=stage_sel A=acc_reg[21] B=FE_PHN894_acc_reg_25
XU313 INV1S $PINS O=n58 I=n53
XU315 INV1S $PINS O=n69 I=n64
XU316 INV1S $PINS O=n59 I=n54
XU317 INV1S $PINS O=n81 I=n76
XU318 NR2 $PINS O=term3_in[2] I1=sign3[1] I2=x_in[2]
XU319 NR2 $PINS O=term1_in[3] I1=sign1[1] I2=x_in[3]
XU320 NR2 $PINS O=term1_in[4] I1=sign1[1] I2=x_in[4]
XU321 NR2 $PINS O=term3_in[3] I1=sign3[1] I2=x_in[3]
XU322 NR2 $PINS O=term3_in[4] I1=sign3[1] I2=x_in[4]
XU323 NR2 $PINS O=term1_in[5] I1=sign1[1] I2=x_in[5]
XU324 NR2 $PINS O=term3_in[5] I1=sign3[1] I2=x_in[5]
XU325 NR2 $PINS O=term2_in[5] I1=sign2[1] I2=x_in[5]
XU326 NR2 $PINS O=term1_in[6] I1=sign1[1] I2=x_in[6]
XU327 NR2 $PINS O=term3_in[6] I1=sign3[1] I2=x_in[6]
XU328 NR2 $PINS O=term2_in[6] I1=sign2[1] I2=x_in[6]
XU329 NR2 $PINS O=term1_in[7] I1=sign1[1] I2=x_in[7]
XU330 NR2 $PINS O=term3_in[7] I1=sign3[1] I2=x_in[7]
XU331 NR2 $PINS O=term2_in[7] I1=sign2[1] I2=x_in[7]
XU332 NR2 $PINS O=term1_in[8] I1=sign1[1] I2=x_in[8]
XU333 NR2 $PINS O=term3_in[8] I1=FE_OFN293_s03_1 I2=x_in[8]
XU334 NR2 $PINS O=term2_in[8] I1=sign2[1] I2=x_in[8]
XU339 NR2 $PINS O=term1_in[9] I1=sign1[1] I2=x_in[9]
XU340 NR2 $PINS O=term3_in[9] I1=sign3[1] I2=x_in[9]
XU342 NR2 $PINS O=term1_in[10] I1=FE_OFN238_s01_1 I2=x_in[10]
XU343 NR2 $PINS O=term3_in[10] I1=FE_OFN293_s03_1 I2=x_in[10]
XU344 NR2 $PINS O=term2_in[9] I1=sign2[1] I2=x_in[9]
XU345 NR2 $PINS O=term2_in[10] I1=sign2[1] I2=x_in[10]
XU346 NR2 $PINS O=term1_in[11] I1=FE_OFN238_s01_1 I2=x_in[11]
XU347 NR2 $PINS O=term3_in[11] I1=FE_OFN293_s03_1 I2=x_in[11]
XU348 NR2 $PINS O=term2_in[11] I1=sign2[1] I2=x_in[11]
XU349 NR2 $PINS O=term1_in[12] I1=FE_OFN238_s01_1 I2=x_in[12]
XU350 NR2 $PINS O=term3_in[12] I1=FE_OFN293_s03_1 I2=x_in[12]
XU351 NR2 $PINS O=term2_in[12] I1=sign2[1] I2=x_in[12]
XU352 NR2 $PINS O=term1_in[13] I1=FE_OFN238_s01_1 I2=x_in[13]
XU353 NR2 $PINS O=term3_in[13] I1=FE_OFN293_s03_1 I2=x_in[13]
XU354 NR2 $PINS O=term2_in[13] I1=sign2[1] I2=x_in[13]
XU355 NR2 $PINS O=term1_in[14] I1=FE_OFN238_s01_1 I2=n90
XU357 NR2 $PINS O=term3_in[14] I1=FE_OFN293_s03_1 I2=n90
XU359 NR2 $PINS O=term2_in[14] I1=sign2[1] I2=n90
XU361 NR2 $PINS O=term1_in[15] I1=FE_OFN238_s01_1 I2=n91
XU362 NR2 $PINS O=term3_in[15] I1=FE_OFN293_s03_1 I2=n91
XU363 NR2 $PINS O=term1_in[26] I1=n92 I2=FE_OFN238_s01_1
XU364 NR2 $PINS O=term2_in[15] I1=sign2[1] I2=n91
XU365 NR2 $PINS O=term3_in[26] I1=n92 I2=FE_OFN293_s03_1
XU366 NR2 $PINS O=term2_in[26] I1=n92 I2=sign2[1]
XU372 INV1S $PINS O=n36 I=shf1[0]
XU391 INV1S $PINS O=n90 I=x_in[14]
XU392 INV1S $PINS O=n91 I=x_in[15]
XU393 INV1S $PINS O=n92 I=x_in[16]
XU394 AN2 $PINS O=base_val[26] I1=N251 I2=FE_OFN77_n
XU395 AN2 $PINS O=base_val[1] I1=acc_reg[1] I2=FE_OFN324_n
XU396 MOAI1S $PINS O=base_val[9] A1=stage_sel A2=FE_OFN324_n B1=acc_reg[9]
+ B2=FE_OFN324_n
XU397 AN2 $PINS O=base_val[10] I1=acc_reg[10] I2=FE_OFN324_n
XU398 AN2 $PINS O=base_val[11] I1=acc_reg[11] I2=FE_OFN324_n
XU399 AN2 $PINS O=base_val[7] I1=acc_reg[7] I2=FE_OFN324_n
XU400 AN2 $PINS O=base_val[6] I1=acc_reg[6] I2=FE_OFN324_n
XU401 AN2 $PINS O=base_val[8] I1=acc_reg[8] I2=FE_OFN324_n
XU402 AN2 $PINS O=base_val[5] I1=acc_reg[5] I2=FE_OFN324_n
XU403 AN2 $PINS O=base_val[4] I1=acc_reg[4] I2=FE_OFN324_n
XU404 AN2 $PINS O=base_val[3] I1=acc_reg[3] I2=FE_OFN324_n
XU405 AN2 $PINS O=base_val[2] I1=acc_reg[2] I2=FE_OFN324_n
XU406 AN2 $PINS O=base_val[12] I1=acc_reg[12] I2=FE_OFN324_n
XU407 AN2 $PINS O=base_val[14] I1=acc_reg[14] I2=FE_OFN77_n
XU408 AN2 $PINS O=base_val[16] I1=acc_reg[16] I2=FE_OFN77_n
XU409 AN2 $PINS O=base_val[17] I1=acc_reg[17] I2=FE_OFN77_n
XU410 AN2 $PINS O=base_val[18] I1=acc_reg[18] I2=FE_OFN77_n
XU411 AN2 $PINS O=base_val[19] I1=acc_reg[19] I2=FE_OFN77_n
XU412 AN2 $PINS O=base_val[20] I1=acc_reg[20] I2=FE_OFN77_n
XU413 AN2 $PINS O=base_val[21] I1=acc_reg[21] I2=FE_OFN77_n
XU414 AN2 $PINS O=base_val[22] I1=acc_reg[22] I2=FE_OFN77_n
XU415 AN2 $PINS O=base_val[23] I1=acc_reg[23] I2=FE_OFN77_n
XU416 AN2 $PINS O=base_val[25] I1=acc_reg[25] I2=FE_OFN77_n
XU418 AN2 $PINS O=N234 I1=en I2=calc_done
XU420 AN2 $PINS O=sll_16/ML_int[1][0] I1=term1_in[0] I2=n36
XU421 NR2 $PINS O=sll_16/ML_int[3][0] I1=shf1[2] I2=n53
XU422 NR2 $PINS O=sll_16/ML_int[3][1] I1=shf1[2] I2=n54
XU423 NR2 $PINS O=sll_16/ML_int[3][2] I1=shf1[2] I2=n57
XU424 NR2 $PINS O=sll_16/ML_int[3][3] I1=shf1[2] I2=n56
XU425 AN2S $PINS O=term1_shifted[4] I1=sll_16/ML_int[3][4] I2=n42
XU427 AN2 $PINS O=term1_shifted[6] I1=sll_16/ML_int[3][6] I2=n42
XU428 AN2 $PINS O=term1_shifted[7] I1=sll_16/ML_int[3][7] I2=n42
XU429 MUX2 $PINS O=n63 S=shf1[0] A=term1_in[26] B=term1_in[15]
XU430 NR2 $PINS O=sll_17/ML_int[3][0] I1=shf2[2] I2=n64
XU431 NR2 $PINS O=sll_17/ML_int[3][1] I1=shf2[2] I2=n65
XU432 NR2 $PINS O=sll_17/ML_int[3][2] I1=shf2[2] I2=n68
XU433 NR2 $PINS O=sll_17/ML_int[3][3] I1=shf2[2] I2=n67
XU434 ND2 $PINS O=n66 I1=n27 I2=n29
XU436 AN2 $PINS O=term2_shifted[5] I1=sll_17/ML_int[3][5] I2=n29
XU437 AN2 $PINS O=term2_shifted[6] I1=sll_17/ML_int[3][6] I2=n29
XU438 AN2 $PINS O=term2_shifted[7] I1=sll_17/ML_int[3][7] I2=n29
XU439 MUX2 $PINS O=n74 S=shf2[0] A=term2_in[26] B=term2_in[15]
XU441 NR2 $PINS O=sll_18/ML_int[3][0] I1=FE_OFN180_h03_2 I2=n75
XU442 NR2 $PINS O=sll_18/ML_int[3][1] I1=FE_OFN180_h03_2 I2=n76
XU443 NR2 $PINS O=sll_18/ML_int[3][2] I1=FE_OFN180_h03_2 I2=n79
XU444 NR2 $PINS O=sll_18/ML_int[3][3] I1=FE_OFN180_h03_2 I2=n78
XU445 ND2 $PINS O=n77 I1=n16 I2=n18
XU447 AN2 $PINS O=term3_shifted[5] I1=sll_18/ML_int[3][5] I2=n18
XU448 AN2 $PINS O=term3_shifted[6] I1=sll_18/ML_int[3][6] I2=n18
XU449 AN2 $PINS O=term3_shifted[7] I1=sll_18/ML_int[3][7] I2=n18
XU450 MUX2 $PINS O=n85 S=FE_OFN246_h03_0 A=term3_in[26] B=term3_in[15]
XU451 MUX2 $PINS O=N241 S=stage_sel A=FE_PHN947_acc_reg_16 B=acc_reg[20]
XU452 MUX2 $PINS O=N243 S=stage_sel A=acc_reg[18] B=acc_reg[22]
XU453 MUX2 $PINS O=N244 S=stage_sel A=acc_reg[19] B=acc_reg[23]
Xsll_17/M1_0_5 MUX2 $PINS O=sll_17/ML_int[1][5] S=shf2[0] A=term2_in[5]
+ B=term2_in[4]
XU22 MUX2 $PINS O=sll_17/ML_int[1][3] S=shf2[0] A=term2_in[3] B=term2_in[2]
Xsll_17/M1_1_2 MUX2 $PINS O=sll_17/ML_int[2][2] S=shf2[1] A=sll_17/ML_int[1][2]
+ B=sll_17/ML_int[1][0]
Xsll_17/M1_1_3 MUX2 $PINS O=sll_17/ML_int[2][3] S=shf2[1] A=sll_17/ML_int[1][3]
+ B=sll_17/ML_int[1][1]
XU3 ND2 $PINS O=n6 I1=N70 I2=sign2[0]
XU5 NR2 $PINS O=term2_in[0] I1=sign2[1] I2=x_in[0]
XU6 NR2 $PINS O=term2_in[4] I1=sign2[1] I2=x_in[4]
XU8 INV1S $PINS O=n57 I=sll_16/ML_int[2][2]
XU9 NR2 $PINS O=term2_in[1] I1=sign2[1] I2=x_in[1]
XU17 NR2 $PINS O=term2_shifted[0] I1=n66 I2=n64
XU19 ND2P $PINS O=N98 I1=n3 I2=n4
XU20 ND2 $PINS O=n76 I1=sll_18/ML_int[1][1] I2=n14
XU24 NR2 $PINS O=term1_in[0] I1=sign1[1] I2=x_in[0]
XU35 NR2P $PINS O=term3_shifted[1] I1=n77 I2=n76
XU51 NR2 $PINS O=term1_shifted[0] I1=n55 I2=n53
XU60 ND2 $PINS O=n75 I1=sll_18/ML_int[1][0] I2=n14
XU66 NR2 $PINS O=term2_in[3] I1=sign2[1] I2=x_in[3]
Xclk_gate_y_out_reg SNPS_CLOCK_GATE_HIGH_PE_Shift_Add_6 $PINS EN=N234
+ ENCLK=CTS_6 CLK=clk_clone2
Xsub_28_3 PE_Shift_Add_6_DW01_sub_0_DW01_sub_18 $PINS A[26]=net45526
+ A[25]=net45526 A[24]=net45526 A[23]=net45526 A[22]=net45526 A[21]=net45526
+ A[20]=net45526 A[19]=net45526 A[18]=net45526 A[17]=net45526 A[16]=net45526
+ A[15]=net45526 A[14]=net45526 A[13]=net45526 A[12]=net45526 A[11]=net45526
+ A[10]=net45526 A[9]=net45526 A[8]=net45526 A[7]=net45526 A[6]=net45526
+ A[5]=net45526 A[4]=net45526 A[3]=net45526 A[2]=net45526 A[1]=net45526
+ A[0]=net45526 B[26]=term3_shifted[26] B[25]=term3_shifted[25]
+ B[24]=term3_shifted[24] B[23]=term3_shifted[23] B[22]=term3_shifted[22]
+ B[21]=term3_shifted[21] B[20]=term3_shifted[20] B[19]=term3_shifted[19]
+ B[18]=term3_shifted[18] B[17]=term3_shifted[17] B[16]=term3_shifted[16]
+ B[15]=term3_shifted[15] B[14]=term3_shifted[14] B[13]=term3_shifted[13]
+ B[12]=term3_shifted[12] B[11]=term3_shifted[11] B[10]=term3_shifted[10]
+ B[9]=term3_shifted[9] B[8]=term3_shifted[8] B[7]=term3_shifted[7]
+ B[6]=term3_shifted[6] B[5]=term3_shifted[5] B[4]=term3_shifted[4]
+ B[3]=term3_shifted[3] B[2]=term3_shifted[2] B[1]=term3_shifted[1]
+ B[0]=term3_shifted[0] CI=net45526 DIFF[26]=N150 DIFF[25]=N149 DIFF[24]=N148
+ DIFF[23]=N147 DIFF[22]=N146 DIFF[21]=N145 DIFF[20]=N144 DIFF[19]=N143
+ DIFF[18]=N142 DIFF[17]=N141 DIFF[16]=N140 DIFF[15]=N139 DIFF[14]=N138
+ DIFF[13]=N137 DIFF[12]=N136 DIFF[11]=N135 DIFF[10]=N134 DIFF[9]=N133
+ DIFF[8]=N132 DIFF[7]=N131 DIFF[6]=N130 DIFF[5]=N129 DIFF[4]=N128 DIFF[3]=N127
+ DIFF[2]=N126 DIFF[1]=N125 DIFF[0]=N124
Xsub_28_2 PE_Shift_Add_6_DW01_sub_1_DW01_sub_19 $PINS A[26]=net45526
+ A[25]=net45526 A[24]=net45526 A[23]=net45526 A[22]=net45526 A[21]=net45526
+ A[20]=net45526 A[19]=net45526 A[18]=net45526 A[17]=net45526 A[16]=net45526
+ A[15]=net45526 A[14]=net45526 A[13]=net45526 A[12]=net45526 A[11]=net45526
+ A[10]=net45526 A[9]=net45526 A[8]=net45526 A[7]=net45526 A[6]=net45526
+ A[5]=net45526 A[4]=net45526 A[3]=net45526 A[2]=net45526 A[1]=net45526
+ A[0]=net45526 B[26]=term2_shifted[26] B[25]=term2_shifted[25]
+ B[24]=term2_shifted[24] B[23]=term2_shifted[23] B[22]=term2_shifted[22]
+ B[21]=term2_shifted[21] B[20]=term2_shifted[20] B[19]=term2_shifted[19]
+ B[18]=term2_shifted[18] B[17]=term2_shifted[17] B[16]=term2_shifted[16]
+ B[15]=term2_shifted[15] B[14]=term2_shifted[14] B[13]=term2_shifted[13]
+ B[12]=term2_shifted[12] B[11]=term2_shifted[11] B[10]=term2_shifted[10]
+ B[9]=term2_shifted[9] B[8]=term2_shifted[8] B[7]=term2_shifted[7]
+ B[6]=term2_shifted[6] B[5]=term2_shifted[5] B[4]=term2_shifted[4]
+ B[3]=term2_shifted[3] B[2]=term2_shifted[2] B[1]=term2_shifted[1]
+ B[0]=term2_shifted[0] CI=net45526 DIFF[26]=N95 DIFF[25]=N94 DIFF[24]=N93
+ DIFF[23]=N92 DIFF[22]=N91 DIFF[21]=N90 DIFF[20]=N89 DIFF[19]=N88 DIFF[18]=N87
+ DIFF[17]=N86 DIFF[16]=N85 DIFF[15]=N84 DIFF[14]=N83 DIFF[13]=N82 DIFF[12]=N81
+ DIFF[11]=N80 DIFF[10]=N79 DIFF[9]=N78 DIFF[8]=N77 DIFF[7]=N76 DIFF[6]=N75
+ DIFF[5]=N74 DIFF[4]=N73 DIFF[3]=N72 DIFF[2]=N71 DIFF[1]=N70 DIFF[0]=N69
Xsub_28 PE_Shift_Add_6_DW01_sub_2_DW01_sub_20 $PINS A[26]=net45526
+ A[25]=net45526 A[24]=net45526 A[23]=net45526 A[22]=net45526 A[21]=net45526
+ A[20]=net45526 A[19]=net45526 A[18]=net45526 A[17]=net45526 A[16]=net45526
+ A[15]=net45526 A[14]=net45526 A[13]=net45526 A[12]=net45526 A[11]=net45526
+ A[10]=net45526 A[9]=net45526 A[8]=net45526 A[7]=net45526 A[6]=net45526
+ A[5]=net45526 A[4]=net45526 A[3]=net45526 A[2]=net45526 A[1]=net45526
+ A[0]=net45526 B[26]=term1_shifted[26] B[25]=term1_shifted[25]
+ B[24]=term1_shifted[24] B[23]=term1_shifted[23] B[22]=term1_shifted[22]
+ B[21]=term1_shifted[21] B[20]=term1_shifted[20] B[19]=term1_shifted[19]
+ B[18]=term1_shifted[18] B[17]=term1_shifted[17] B[16]=term1_shifted[16]
+ B[15]=term1_shifted[15] B[14]=term1_shifted[14] B[13]=term1_shifted[13]
+ B[12]=term1_shifted[12] B[11]=term1_shifted[11] B[10]=term1_shifted[10]
+ B[9]=term1_shifted[9] B[8]=term1_shifted[8] B[7]=term1_shifted[7]
+ B[6]=term1_shifted[6] B[5]=term1_shifted[5] B[4]=term1_shifted[4]
+ B[3]=term1_shifted[3] B[2]=term1_shifted[2] B[1]=term1_shifted[1]
+ B[0]=term1_shifted[0] CI=net45526 DIFF[26]=N40 DIFF[25]=N39 DIFF[24]=N38
+ DIFF[23]=N37 DIFF[22]=N36 DIFF[21]=N35 DIFF[20]=N34 DIFF[19]=N33 DIFF[18]=N32
+ DIFF[17]=N31 DIFF[16]=N30 DIFF[15]=N29 DIFF[14]=N28 DIFF[13]=N27 DIFF[12]=N26
+ DIFF[11]=N25 DIFF[10]=N24 DIFF[9]=N23 DIFF[8]=N22 DIFF[7]=N21 DIFF[6]=N20
+ DIFF[5]=N19 DIFF[4]=N18 DIFF[3]=N17 DIFF[2]=N16 DIFF[1]=N15 DIFF[0]=N14
Xadd_1_root_add_0_root_add_28_3 PE_Shift_Add_6_DW01_add_2_DW01_add_25 $PINS
+ A[26]=N67 A[25]=N66 A[24]=N65 A[23]=N64 A[22]=N63 A[21]=N62 A[20]=N61 A[19]=N60
+ A[18]=N59 A[17]=N58 A[16]=N57 A[15]=N56 A[14]=N55 A[13]=N54 A[12]=N53 A[11]=N52
+ A[10]=N51 A[9]=N50 A[8]=N49 A[7]=N48 A[6]=N47 A[5]=N46 A[4]=N45 A[3]=N44
+ A[2]=N43 A[1]=N42 A[0]=N41 B[26]=N177 B[25]=N176 B[24]=N175 B[23]=N174
+ B[22]=N173 B[21]=N172 B[20]=N171 B[19]=N170 B[18]=N169 B[17]=N168 B[16]=N167
+ B[15]=N166 B[14]=N165 B[13]=N164 B[12]=N163 B[11]=N162 B[10]=N161 B[9]=N160
+ B[8]=N159 B[7]=N158 B[6]=N157 B[5]=N156 B[4]=N155 B[3]=N154 B[2]=N153 B[1]=N152
+ B[0]=N151 CI=net45526 SUM[26]=N204 SUM[25]=N203 SUM[24]=N202 SUM[23]=N201
+ SUM[22]=N200 SUM[21]=N199 SUM[20]=N198 SUM[19]=N197 SUM[18]=N196 SUM[17]=N195
+ SUM[16]=N194 SUM[15]=N193 SUM[14]=N192 SUM[13]=N191 SUM[12]=N190 SUM[11]=N189
+ SUM[10]=N188 SUM[9]=N187 SUM[8]=N186 SUM[7]=N185 SUM[6]=N184 SUM[5]=N183
+ SUM[4]=N182 SUM[3]=N181 SUM[2]=N180 SUM[1]=N179 SUM[0]=N178
Xadd_2_root_add_0_root_add_28_3 PE_Shift_Add_6_DW01_add_1_DW01_add_24 $PINS
+ A[26]=base_val[26] A[25]=base_val[25] A[24]=base_val[24] A[23]=base_val[23]
+ A[22]=base_val[22] A[21]=base_val[21] A[20]=base_val[20] A[19]=base_val[19]
+ A[18]=base_val[18] A[17]=base_val[17] A[16]=base_val[16] A[15]=base_val[15]
+ A[14]=base_val[14] A[13]=base_val[13] A[12]=base_val[12] A[11]=base_val[11]
+ A[10]=base_val[10] A[9]=base_val[9] A[8]=base_val[8] A[7]=base_val[7]
+ A[6]=base_val[6] A[5]=base_val[5] A[4]=base_val[4] A[3]=base_val[3]
+ A[2]=base_val[2] A[1]=base_val[1] A[0]=base_val[0] B[26]=N122 B[25]=N121
+ B[24]=N120 B[23]=N119 B[22]=N118 B[21]=N117 B[20]=N116 B[19]=N115 B[18]=N114
+ B[17]=N113 B[16]=N112 B[15]=N111 B[14]=N110 B[13]=N109 B[12]=N108 B[11]=N107
+ B[10]=N106 B[9]=N105 B[8]=N104 B[7]=N103 B[6]=N102 B[5]=N101 B[4]=N100 B[3]=N99
+ B[2]=N98 B[1]=N97 B[0]=N96 CI=net45526 SUM[26]=N231 SUM[25]=N230 SUM[24]=N229
+ SUM[23]=N228 SUM[22]=N227 SUM[21]=N226 SUM[20]=N225 SUM[19]=N224 SUM[18]=N223
+ SUM[17]=N222 SUM[16]=N221 SUM[15]=N220 SUM[14]=N219 SUM[13]=N218 SUM[12]=N217
+ SUM[11]=N216 SUM[10]=N215 SUM[9]=N214 SUM[8]=N213 SUM[7]=N212 SUM[6]=N211
+ SUM[5]=N210 SUM[4]=N209 SUM[3]=N208 SUM[2]=N207 SUM[1]=N206 SUM[0]=N205
Xadd_0_root_add_0_root_add_28_3 PE_Shift_Add_6_DW01_add_0_DW01_add_23 $PINS
+ A[26]=N204 A[25]=N203 A[24]=N202 A[23]=N201 A[22]=N200 A[21]=N199 A[20]=N198
+ A[19]=N197 A[18]=N196 A[17]=N195 A[16]=N194 A[15]=N193 A[14]=N192 A[13]=N191
+ A[12]=N190 A[11]=N189 A[10]=N188 A[9]=N187 A[8]=N186 A[7]=N185 A[6]=N184
+ A[5]=N183 A[4]=N182 A[3]=N181 A[2]=N180 A[1]=N179 A[0]=N178 B[26]=N231
+ B[25]=N230 B[24]=N229 B[23]=N228 B[22]=N227 B[21]=N226 B[20]=N225 B[19]=N224
+ B[18]=N223 B[17]=N222 B[16]=N221 B[15]=N220 B[14]=N219 B[13]=N218 B[12]=N217
+ B[11]=N216 B[10]=N215 B[9]=N214 B[8]=N213 B[7]=N212 B[6]=N211 B[5]=N210
+ B[4]=N209 B[3]=N208 B[2]=N207 B[1]=N206 B[0]=N205 CI=net45526
+ SUM[26]=next_acc[26] SUM[25]=next_acc[25] SUM[24]=next_acc[24]
+ SUM[23]=next_acc[23] SUM[22]=next_acc[22] SUM[21]=next_acc[21]
+ SUM[20]=next_acc[20] SUM[19]=next_acc[19] SUM[18]=next_acc[18]
+ SUM[17]=next_acc[17] SUM[16]=next_acc[16] SUM[15]=next_acc[15]
+ SUM[14]=next_acc[14] SUM[13]=next_acc[13] SUM[12]=next_acc[12]
+ SUM[11]=next_acc[11] SUM[10]=next_acc[10] SUM[9]=next_acc[9] SUM[8]=next_acc[8]
+ SUM[7]=next_acc[7] SUM[6]=next_acc[6] SUM[5]=next_acc[5] SUM[4]=next_acc[4]
+ SUM[3]=next_acc[3] SUM[2]=next_acc[2] SUM[1]=next_acc[1] SUM[0]=next_acc[0]
.ENDS

.SUBCKT SNPS_CLOCK_GATE_HIGH_PE_Shift_Add_5 EN ENCLK CLK
*.CONNECT net2275 EN
XFE_PHC824_net2278 DELC $PINS O=net2278 I=FE_PHN824_net2278
Xlatch QDBHN $PINS Q=FE_PHN824_net2278 D=net2275 CKB=CLK
Xmain_gate AN2 $PINS O=ENCLK I1=net2278 I2=CLK
.ENDS

.SUBCKT PE_Shift_Add_5_DW01_sub_0_DW01_sub_15 A[26] A[25] A[24] A[23] A[22]
+ A[21] A[20] A[19] A[18] A[17] A[16] A[15] A[14] A[13] A[12] A[11] A[10] A[9]
+ A[8] A[7] A[6] A[5] A[4] A[3] A[2] A[1] A[0] B[26] B[25] B[24] B[23] B[22]
+ B[21] B[20] B[19] B[18] B[17] B[16] B[15] B[14] B[13] B[12] B[11] B[10] B[9]
+ B[8] B[7] B[6] B[5] B[4] B[3] B[2] B[1] B[0] CI DIFF[26] DIFF[25] DIFF[24]
+ DIFF[23] DIFF[22] DIFF[21] DIFF[20] DIFF[19] DIFF[18] DIFF[17] DIFF[16]
+ DIFF[15] DIFF[14] DIFF[13] DIFF[12] DIFF[11] DIFF[10] DIFF[9] DIFF[8] DIFF[7]
+ DIFF[6] DIFF[5] DIFF[4] DIFF[3] DIFF[2] DIFF[1] DIFF[0] CO p1
XFE_RC_1340_0 XNR2HS $PINS O=DIFF[2] I1=n1 I2=B[2]
XFE_RC_1327_0 INV1S $PINS O=FE_RN_274_0 I=n46
XFE_RC_1326_0 AN2B1S $PINS O=n23 I1=n22 B1=FE_RN_274_0
XFE_RC_1291_0 AN3B2S $PINS O=n3 I1=n1 B1=B[2] B2=B[3]
XFE_RC_1060_0 XNR2HS $PINS O=DIFF[1] I1=B[0] I2=B[1]
XFE_OFC668_term3_shifted_4 INV1S $PINS O=n48 I=B[4]
XFE_OFC609_term3_shifted_2 INV1S $PINS O=n50 I=B[2]
XU2 NR2 $PINS O=n1 I1=p1 I2=B[0]
XU3 INV1S $PINS O=n49 I=B[3]
XU8 INV1S $PINS O=n47 I=B[5]
XU10 AN2 $PINS O=n21 I1=n48 I2=n3
XU11 ND2S $PINS O=n26 I1=n27 I2=n20
XU12 AN2 $PINS O=n2 I1=n50 I2=n1
XU14 AN2 $PINS O=n4 I1=n44 I2=n24
XU15 AN2 $PINS O=n5 I1=n43 I2=n4
XU16 AN2 $PINS O=n6 I1=n42 I2=n5
XU17 AN2 $PINS O=n7 I1=n41 I2=n6
XU18 AN2 $PINS O=n8 I1=n40 I2=n7
XU19 AN2 $PINS O=n9 I1=n39 I2=n8
XU20 AN2 $PINS O=n10 I1=n38 I2=n9
XU21 AN2 $PINS O=n11 I1=n37 I2=n10
XU22 AN2 $PINS O=n12 I1=n36 I2=n11
XU23 AN2 $PINS O=n13 I1=n35 I2=n12
XU24 AN2 $PINS O=n14 I1=n34 I2=n13
XU25 AN2 $PINS O=n15 I1=n33 I2=n14
XU26 AN2 $PINS O=n16 I1=n32 I2=n15
XU27 AN2 $PINS O=n17 I1=n31 I2=n16
XU28 AN2 $PINS O=n18 I1=n30 I2=n17
XU29 AN2 $PINS O=n19 I1=n29 I2=n18
XU30 AN2 $PINS O=n20 I1=n28 I2=n19
XU31 AN2 $PINS O=n22 I1=n47 I2=n21
XU33 AN2 $PINS O=n24 I1=n45 I2=n23
XU34 INV1S $PINS O=n44 I=B[8]
XU35 INV1S $PINS O=n43 I=B[9]
XU36 INV1S $PINS O=n42 I=B[10]
XU37 INV1S $PINS O=n41 I=B[11]
XU38 INV1S $PINS O=n40 I=B[12]
XU39 INV1S $PINS O=n39 I=B[13]
XU40 INV1S $PINS O=n38 I=B[14]
XU41 INV1S $PINS O=n37 I=B[15]
XU42 INV1S $PINS O=n36 I=B[16]
XU43 INV1S $PINS O=n35 I=B[17]
XU44 INV1S $PINS O=n34 I=B[18]
XU45 INV1S $PINS O=n33 I=B[19]
XU46 INV1S $PINS O=n32 I=B[20]
XU47 INV1S $PINS O=n31 I=B[21]
XU48 INV1S $PINS O=n30 I=B[22]
XU49 INV1S $PINS O=n29 I=B[23]
XU50 INV1S $PINS O=n28 I=B[24]
XU51 INV1S $PINS O=n27 I=B[25]
XU52 INV1S $PINS O=n46 I=B[6]
XU53 INV1S $PINS O=n45 I=B[7]
XU54 XOR2HS $PINS O=DIFF[10] I1=n42 I2=n5
XU55 XOR2HS $PINS O=DIFF[11] I1=n41 I2=n6
XU56 XOR2HS $PINS O=DIFF[12] I1=n40 I2=n7
XU57 XOR2HS $PINS O=DIFF[13] I1=n39 I2=n8
XU58 XOR2HS $PINS O=DIFF[14] I1=n38 I2=n9
XU59 XOR2HS $PINS O=DIFF[15] I1=n37 I2=n10
XU60 XOR2HS $PINS O=DIFF[16] I1=n36 I2=n11
XU61 XOR2HS $PINS O=DIFF[17] I1=n35 I2=n12
XU62 XOR2HS $PINS O=DIFF[18] I1=n34 I2=n13
XU63 XOR2HS $PINS O=DIFF[19] I1=n33 I2=n14
XU64 XOR2HS $PINS O=DIFF[20] I1=n32 I2=n15
XU65 XOR2HS $PINS O=DIFF[21] I1=n31 I2=n16
XU66 XOR2HS $PINS O=DIFF[22] I1=n30 I2=n17
XU67 XOR2HS $PINS O=DIFF[23] I1=n29 I2=n18
XU68 XOR2HS $PINS O=DIFF[24] I1=n28 I2=n19
XU69 XOR2HS $PINS O=DIFF[25] I1=n27 I2=n20
XU70 XOR2HS $PINS O=DIFF[9] I1=n43 I2=n4
XU71 XOR2HS $PINS O=DIFF[8] I1=n44 I2=n24
XU72 XOR2HS $PINS O=DIFF[7] I1=n45 I2=n23
XU73 XOR2HS $PINS O=DIFF[6] I1=n46 I2=n22
XU74 XOR2HS $PINS O=DIFF[5] I1=n47 I2=n21
XU75 XOR2HS $PINS O=DIFF[4] I1=n48 I2=n3
XU76 XOR2HS $PINS O=DIFF[3] I1=n49 I2=n2
XU77 XOR2HS $PINS O=DIFF[26] I1=B[26] I2=n26
.ENDS

.SUBCKT PE_Shift_Add_5_DW01_sub_1_DW01_sub_16 A[26] A[25] A[24] A[23] A[22]
+ A[21] A[20] A[19] A[18] A[17] A[16] A[15] A[14] A[13] A[12] A[11] A[10] A[9]
+ A[8] A[7] A[6] A[5] A[4] A[3] A[2] A[1] A[0] B[26] B[25] B[24] B[23] B[22]
+ B[21] B[20] B[19] B[18] B[17] B[16] B[15] B[14] B[13] B[12] B[11] B[10] B[9]
+ B[8] B[7] B[6] B[5] B[4] B[3] B[2] B[1] B[0] CI DIFF[26] DIFF[25] DIFF[24]
+ DIFF[23] DIFF[22] DIFF[21] DIFF[20] DIFF[19] DIFF[18] DIFF[17] DIFF[16]
+ DIFF[15] DIFF[14] DIFF[13] DIFF[12] DIFF[11] DIFF[10] DIFF[9] DIFF[8] DIFF[7]
+ DIFF[6] DIFF[5] DIFF[4] DIFF[3] DIFF[2] DIFF[1] DIFF[0] CO
XFE_RC_1756_0 OR2B1S $PINS O=FE_RN_471_0 I1=B[3] B1=n1
XFE_RC_1755_0 XOR2HS $PINS O=DIFF[4] I1=FE_RN_471_0 I2=B[4]
XFE_RC_1533_0 AN2 $PINS O=FE_RN_356_0 I1=n23 I2=n44
XFE_RC_1532_0 AN2 $PINS O=n4 I1=FE_RN_356_0 I2=n45
XFE_RC_1313_0 XNR2HS $PINS O=DIFF[3] I1=n1 I2=B[3]
XFE_RC_1228_0 NR3H $PINS O=n1 I1=B[1] I2=B[0] I3=B[2]
XFE_RC_1004_0 XNR2HS $PINS O=DIFF[2] I1=n3 I2=B[2]
XFE_RC_944_0 XOR2HS $PINS O=DIFF[1] I1=B[0] I2=B[1]
XFE_OFC634_term2_shifted_11 INV1S $PINS O=n41 I=B[11]
XFE_OFC619_term2_shifted_5 INV1S $PINS O=n47 I=B[5]
XU4 INV1S $PINS O=n49 I=B[3]
XU5 INV1S $PINS O=n48 I=B[4]
XU9 XOR2HS $PINS O=DIFF[5] I1=n47 I2=n21
XU11 AN2 $PINS O=n2 I1=n49 I2=n1
XU12 AN2 $PINS O=n21 I1=n2 I2=n48
XU13 ND2S $PINS O=n26 I1=n27 I2=n20
XU17 AN2 $PINS O=n5 I1=n43 I2=n4
XU18 AN2 $PINS O=n6 I1=n42 I2=n5
XU19 AN2 $PINS O=n7 I1=n41 I2=n6
XU20 AN2 $PINS O=n8 I1=n40 I2=n7
XU21 AN2 $PINS O=n9 I1=n39 I2=n8
XU22 AN2 $PINS O=n10 I1=n38 I2=n9
XU23 AN2 $PINS O=n11 I1=n37 I2=n10
XU24 AN2 $PINS O=n12 I1=n36 I2=n11
XU25 AN2 $PINS O=n13 I1=n35 I2=n12
XU26 AN2 $PINS O=n14 I1=n34 I2=n13
XU27 AN2 $PINS O=n15 I1=n33 I2=n14
XU28 AN2 $PINS O=n16 I1=n32 I2=n15
XU29 AN2 $PINS O=n17 I1=n31 I2=n16
XU30 AN2 $PINS O=n18 I1=n30 I2=n17
XU31 AN2 $PINS O=n19 I1=n29 I2=n18
XU32 AN2 $PINS O=n20 I1=n28 I2=n19
XU33 AN2 $PINS O=n22 I1=n21 I2=n47
XU34 AN2 $PINS O=n23 I1=n22 I2=n46
XU35 AN2 $PINS O=n24 I1=n45 I2=n23
XU36 INV1S $PINS O=n44 I=B[8]
XU37 INV1S $PINS O=n43 I=B[9]
XU38 INV1S $PINS O=n42 I=B[10]
XU40 INV1S $PINS O=n40 I=B[12]
XU41 INV1S $PINS O=n39 I=B[13]
XU42 INV1S $PINS O=n38 I=B[14]
XU43 INV1S $PINS O=n37 I=B[15]
XU44 INV1S $PINS O=n36 I=B[16]
XU45 INV1S $PINS O=n35 I=B[17]
XU46 INV1S $PINS O=n34 I=B[18]
XU47 INV1S $PINS O=n33 I=B[19]
XU48 INV1S $PINS O=n32 I=B[20]
XU49 INV1S $PINS O=n31 I=B[21]
XU50 INV1S $PINS O=n30 I=B[22]
XU51 INV1S $PINS O=n29 I=B[23]
XU52 INV1S $PINS O=n28 I=B[24]
XU53 INV1S $PINS O=n27 I=B[25]
XU54 INV1S $PINS O=n46 I=B[6]
XU55 INV1S $PINS O=n45 I=B[7]
XU56 XOR2HS $PINS O=DIFF[26] I1=B[26] I2=n26
XU57 XOR2HS $PINS O=DIFF[9] I1=n43 I2=n4
XU58 XOR2HS $PINS O=DIFF[10] I1=n42 I2=n5
XU59 XOR2HS $PINS O=DIFF[11] I1=n41 I2=n6
XU60 XOR2HS $PINS O=DIFF[12] I1=n40 I2=n7
XU61 XOR2HS $PINS O=DIFF[13] I1=n39 I2=n8
XU62 XOR2HS $PINS O=DIFF[14] I1=n38 I2=n9
XU63 XOR2HS $PINS O=DIFF[15] I1=n37 I2=n10
XU64 XOR2HS $PINS O=DIFF[16] I1=n36 I2=n11
XU65 XOR2HS $PINS O=DIFF[17] I1=n35 I2=n12
XU66 XOR2HS $PINS O=DIFF[18] I1=n34 I2=n13
XU67 XOR2HS $PINS O=DIFF[19] I1=n33 I2=n14
XU68 XOR2HS $PINS O=DIFF[20] I1=n32 I2=n15
XU69 XOR2HS $PINS O=DIFF[21] I1=n31 I2=n16
XU70 XOR2HS $PINS O=DIFF[22] I1=n30 I2=n17
XU71 XOR2HS $PINS O=DIFF[23] I1=n29 I2=n18
XU72 XOR2HS $PINS O=DIFF[24] I1=n28 I2=n19
XU73 XOR2HS $PINS O=DIFF[25] I1=n27 I2=n20
XU74 XOR2HS $PINS O=DIFF[8] I1=n44 I2=n24
XU75 XOR2HS $PINS O=DIFF[7] I1=n45 I2=n23
XU76 XOR2HS $PINS O=DIFF[6] I1=n46 I2=n22
XU6 NR2 $PINS O=n3 I1=B[0] I2=B[1]
.ENDS

.SUBCKT PE_Shift_Add_5_DW01_sub_2_DW01_sub_17 A[26] A[25] A[24] A[23] A[22]
+ A[21] A[20] A[19] A[18] A[17] A[16] A[15] A[14] A[13] A[12] A[11] A[10] A[9]
+ A[8] A[7] A[6] A[5] A[4] A[3] A[2] A[1] A[0] B[26] B[25] B[24] B[23] B[22]
+ B[21] B[20] B[19] B[18] B[17] B[16] B[15] B[14] B[13] B[12] B[11] B[10] B[9]
+ B[8] B[7] B[6] B[5] B[4] B[3] B[2] B[1] B[0] CI DIFF[26] DIFF[25] DIFF[24]
+ DIFF[23] DIFF[22] DIFF[21] DIFF[20] DIFF[19] DIFF[18] DIFF[17] DIFF[16]
+ DIFF[15] DIFF[14] DIFF[13] DIFF[12] DIFF[11] DIFF[10] DIFF[9] DIFF[8] DIFF[7]
+ DIFF[6] DIFF[5] DIFF[4] DIFF[3] DIFF[2] DIFF[1] DIFF[0] CO
XFE_RC_1468_0 XNR2HS $PINS O=DIFF[4] I1=n5 I2=B[4]
XFE_RC_1280_0 NR4 $PINS O=n5 I1=B[2] I2=B[3] I3=B[1] I4=B[0]
XFE_RC_1131_0 XNR2HS $PINS O=DIFF[2] I1=n3 I2=B[2]
XFE_RC_888_0 XNR2HS $PINS O=DIFF[1] I1=DIFF[0] I2=B[1]
XFE_OFC653_term1_shifted_6 INV1S $PINS O=n48 I=B[6]
XFE_OFC605_term1_shifted_3 INV1S $PINS O=n50 I=B[3]
XFE_OFC492_term1_shifted_0 INV2 $PINS O=DIFF[0] I=B[0]
XFE_OFC341_term1_shifted_2 INV2 $PINS O=n51 I=B[2]
XU2 XOR2HS $PINS O=DIFF[5] I1=B[5] I2=n2
XU4 ND2 $PINS O=n2 I1=n5 I2=n49
XU5 NR2 $PINS O=n24 I1=B[5] I2=n2
XU10 INV1S $PINS O=n49 I=B[4]
XU14 ND2S $PINS O=n28 I1=n29 I2=n22
XU16 XOR2HS $PINS O=DIFF[3] I1=n50 I2=n4
XU18 AN2S $PINS O=n4 I1=n51 I2=n3
XU20 XOR2HS $PINS O=DIFF[8] I1=n46 I2=n26
XU21 XOR2HS $PINS O=DIFF[9] I1=n45 I2=n6
XU22 AN2 $PINS O=n6 I1=n46 I2=n26
XU23 XOR2HS $PINS O=DIFF[10] I1=n44 I2=n7
XU24 AN2 $PINS O=n7 I1=n45 I2=n6
XU25 XOR2HS $PINS O=DIFF[11] I1=n43 I2=n8
XU26 AN2 $PINS O=n8 I1=n44 I2=n7
XU27 XOR2HS $PINS O=DIFF[12] I1=n42 I2=n9
XU28 AN2 $PINS O=n9 I1=n43 I2=n8
XU29 XOR2HS $PINS O=DIFF[13] I1=n41 I2=n10
XU30 AN2 $PINS O=n10 I1=n42 I2=n9
XU31 XOR2HS $PINS O=DIFF[14] I1=n40 I2=n11
XU32 AN2 $PINS O=n11 I1=n41 I2=n10
XU33 XOR2HS $PINS O=DIFF[15] I1=n39 I2=n12
XU34 AN2 $PINS O=n12 I1=n40 I2=n11
XU35 XOR2HS $PINS O=DIFF[16] I1=n38 I2=n13
XU36 AN2 $PINS O=n13 I1=n39 I2=n12
XU37 XOR2HS $PINS O=DIFF[17] I1=n37 I2=n14
XU38 AN2 $PINS O=n14 I1=n38 I2=n13
XU39 XOR2HS $PINS O=DIFF[18] I1=n36 I2=n15
XU40 AN2 $PINS O=n15 I1=n37 I2=n14
XU41 XOR2HS $PINS O=DIFF[19] I1=n35 I2=n16
XU42 AN2 $PINS O=n16 I1=n36 I2=n15
XU43 XOR2HS $PINS O=DIFF[20] I1=n34 I2=n17
XU44 AN2 $PINS O=n17 I1=n35 I2=n16
XU45 XOR2HS $PINS O=DIFF[21] I1=n33 I2=n18
XU46 AN2 $PINS O=n18 I1=n34 I2=n17
XU47 XOR2HS $PINS O=DIFF[22] I1=n32 I2=n19
XU48 AN2 $PINS O=n19 I1=n33 I2=n18
XU49 XOR2HS $PINS O=DIFF[23] I1=n31 I2=n20
XU50 AN2 $PINS O=n20 I1=n32 I2=n19
XU51 XOR2HS $PINS O=DIFF[24] I1=n30 I2=n21
XU52 AN2 $PINS O=n21 I1=n31 I2=n20
XU53 AN2 $PINS O=n22 I1=n30 I2=n21
XU54 XOR2HS $PINS O=DIFF[25] I1=n29 I2=n22
XU56 XOR2HS $PINS O=DIFF[6] I1=n48 I2=n24
XU57 XOR2HS $PINS O=DIFF[7] I1=n47 I2=n25
XU58 AN2 $PINS O=n25 I1=n48 I2=n24
XU59 AN2 $PINS O=n26 I1=n47 I2=n25
XU60 INV1S $PINS O=n46 I=B[8]
XU61 INV1S $PINS O=n45 I=B[9]
XU62 INV1S $PINS O=n44 I=B[10]
XU63 INV1S $PINS O=n43 I=B[11]
XU64 INV1S $PINS O=n42 I=B[12]
XU65 INV1S $PINS O=n41 I=B[13]
XU66 INV1S $PINS O=n40 I=B[14]
XU67 INV1S $PINS O=n39 I=B[15]
XU68 INV1S $PINS O=n38 I=B[16]
XU69 INV1S $PINS O=n37 I=B[17]
XU70 INV1S $PINS O=n36 I=B[18]
XU71 INV1S $PINS O=n35 I=B[19]
XU72 INV1S $PINS O=n34 I=B[20]
XU73 INV1S $PINS O=n33 I=B[21]
XU74 INV1S $PINS O=n32 I=B[22]
XU75 INV1S $PINS O=n31 I=B[23]
XU76 INV1S $PINS O=n30 I=B[24]
XU77 INV1S $PINS O=n29 I=B[25]
XU78 INV1S $PINS O=n47 I=B[7]
XU79 XOR2HS $PINS O=DIFF[26] I1=B[26] I2=n28
XU8 NR2 $PINS O=n3 I1=B[0] I2=B[1]
.ENDS

.SUBCKT PE_Shift_Add_5_DW01_add_2_DW01_add_34 A[26] A[25] A[24] A[23] A[22]
+ A[21] A[20] A[19] A[18] A[17] A[16] A[15] A[14] A[13] A[12] A[11] A[10] A[9]
+ A[8] A[7] A[6] A[5] A[4] A[3] A[2] A[1] A[0] B[26] B[25] B[24] B[23] B[22]
+ B[21] B[20] B[19] B[18] B[17] B[16] B[15] B[14] B[13] B[12] B[11] B[10] B[9]
+ B[8] B[7] B[6] B[5] B[4] B[3] B[2] B[1] B[0] CI SUM[26] SUM[25] SUM[24]
+ SUM[23] SUM[22] SUM[21] SUM[20] SUM[19] SUM[18] SUM[17] SUM[16] SUM[15]
+ SUM[14] SUM[13] SUM[12] SUM[11] SUM[10] SUM[9] SUM[8] SUM[7] SUM[6] SUM[5]
+ SUM[4] SUM[3] SUM[2] SUM[1] SUM[0] CO
XFE_RC_1390_0 XOR3 $PINS O=SUM[5] I1=A[5] I2=B[5] I3=carry[5]
XFE_RC_1389_0 MAO222 $PINS O=carry[6] A1=A[5] B1=B[5] C1=carry[5]
XFE_RC_1303_0 AN2T $PINS O=n41 I1=A[0] I2=B[0]
XFE_RC_1156_0 INV2 $PINS O=SUM[10] I=FE_RN_196_0
XFE_RC_1155_0 XNR3 $PINS O=FE_RN_196_0 I1=A[10] I2=B[10] I3=carry[10]
XFE_RC_1138_0 INV2 $PINS O=SUM[6] I=FE_RN_189_0
XFE_RC_1137_0 XNR3 $PINS O=FE_RN_189_0 I1=A[6] I2=B[6] I3=n20
XFE_RC_1095_0 INV2 $PINS O=SUM[3] I=FE_RN_174_0
XFE_RC_1094_0 XNR3 $PINS O=FE_RN_174_0 I1=A[3] I2=B[3] I3=carry[3]
XFE_RC_1076_0 INV2 $PINS O=SUM[4] I=FE_RN_165_0
XFE_RC_1075_0 XNR3 $PINS O=FE_RN_165_0 I1=A[4] I2=B[4] I3=carry[4]
XFE_RC_1062_0 INV2 $PINS O=SUM[2] I=FE_RN_160_0
XFE_RC_1061_0 XNR3 $PINS O=FE_RN_160_0 I1=carry[2] I2=A[2] I3=B[2]
XFE_RC_1044_0 XOR3 $PINS O=SUM[24] I1=A[24] I2=B[24] I3=carry[24]
XFE_RC_1043_0 MAO222 $PINS O=carry[25] A1=carry[24] B1=B[24] C1=A[24]
XFE_RC_1042_0 XOR3 $PINS O=SUM[19] I1=A[19] I2=B[19] I3=carry[19]
XFE_RC_1041_0 MAO222 $PINS O=carry[20] A1=carry[19] B1=B[19] C1=A[19]
XFE_RC_1034_0 XOR3 $PINS O=SUM[12] I1=A[12] I2=B[12] I3=carry[12]
XFE_RC_958_0 XOR3 $PINS O=SUM[18] I1=A[18] I2=B[18] I3=carry[18]
XFE_RC_957_0 MAO222 $PINS O=carry[19] A1=carry[18] B1=B[18] C1=A[18]
XFE_RC_895_0 ND2 $PINS O=FE_RN_104_0 I1=carry[14] I2=B[14]
XFE_RC_894_0 ND3P $PINS O=carry[15] I1=FE_RN_104_0 I2=n23 I3=n22
XFE_RC_737_0 XOR3 $PINS O=SUM[20] I1=A[20] I2=B[20] I3=carry[20]
XFE_RC_736_0 MAO222P $PINS O=carry[21] A1=carry[20] B1=B[20] C1=A[20]
XFE_RC_731_0 XOR3 $PINS O=SUM[17] I1=A[17] I2=B[17] I3=carry[17]
XFE_RC_730_0 MAO222 $PINS O=carry[18] A1=carry[17] B1=B[17] C1=A[17]
XFE_RC_641_0 MAO222P $PINS O=carry[2] A1=A[1] B1=n41 C1=B[1]
XFE_RC_640_0 XOR3 $PINS O=SUM[1] I1=A[1] I2=B[1] I3=n41
XFE_RC_609_0 XOR3 $PINS O=SUM[8] I1=A[8] I2=B[8] I3=carry[8]
XFE_RC_608_0 MAO222 $PINS O=carry[9] A1=carry[8] B1=B[8] C1=A[8]
XFE_RC_601_0 XOR3 $PINS O=SUM[16] I1=A[16] I2=B[16] I3=carry[16]
XFE_RC_600_0 MAO222 $PINS O=carry[17] A1=carry[16] B1=B[16] C1=A[16]
XFE_RC_549_0 XOR3 $PINS O=SUM[9] I1=A[9] I2=B[9] I3=carry[9]
XFE_RC_548_0 MAO222 $PINS O=carry[10] A1=carry[9] B1=B[9] C1=A[9]
XFE_RC_493_0 MAO222 $PINS O=carry[11] A1=carry[10] B1=B[10] C1=A[10]
XFE_RC_409_0 MAO222 $PINS O=carry[4] A1=carry[3] B1=B[3] C1=A[3]
XFE_RC_404_0 XOR3 $PINS O=SUM[11] I1=A[11] I2=B[11] I3=carry[11]
XFE_RC_403_0 MAO222 $PINS O=carry[12] A1=carry[11] B1=B[11] C1=A[11]
XFE_RC_302_0 MAO222P $PINS O=carry[5] A1=carry[4] B1=B[4] C1=A[4]
XU1_13 FA1 $PINS S=SUM[13] CO=carry[14] A=A[13] B=B[13] CI=n19
XU2 ND3P $PINS O=carry[7] I1=n31 I2=n30 I3=n29
XU3 XOR3 $PINS O=SUM[14] I1=A[14] I2=B[14] I3=n21
XU5 ND3 $PINS O=carry[24] I1=n38 I2=n37 I3=n39
XU6 ND2 $PINS O=n23 I1=n21 I2=A[14]
XU8 ND2S $PINS O=n16 I1=A[2] I2=carry[2]
XU9 ND2 $PINS O=n17 I1=B[2] I2=A[2]
XU13 XOR2HS $PINS O=n1 I1=A[21] I2=B[21]
XU14 XOR2HS $PINS O=SUM[21] I1=carry[21] I2=n1
XU15 ND2 $PINS O=n2 I1=carry[21] I2=A[21]
XU16 ND2 $PINS O=n3 I1=carry[21] I2=B[21]
XU17 ND2 $PINS O=n4 I1=A[21] I2=B[21]
XU20 XOR2HS $PINS O=n8 I1=A[22] I2=B[22]
XU22 ND2 $PINS O=n10 I1=carry[22] I2=B[22]
XU23 ND2S $PINS O=n11 I1=A[22] I2=B[22]
XU24 ND2 $PINS O=n22 I1=A[14] I2=B[14]
XU26 ND2 $PINS O=n29 I1=A[6] I2=B[6]
XU27 ND2 $PINS O=n31 I1=carry[6] I2=B[6]
XU28 ND3 $PINS O=carry[26] I1=n12 I2=n13 I3=n14
XU29 ND3 $PINS O=carry[3] I1=n17 I2=n15 I3=n16
XU32 XOR3 $PINS O=SUM[25] I1=A[25] I2=B[25] I3=carry[25]
XU33 ND2 $PINS O=n12 I1=carry[25] I2=A[25]
XU34 ND2 $PINS O=n13 I1=carry[25] I2=B[25]
XU35 ND2 $PINS O=n14 I1=A[25] I2=B[25]
XU36 ND2 $PINS O=n15 I1=B[2] I2=carry[2]
XU37 XOR2HS $PINS O=n18 I1=A[26] I2=B[26]
XU38 XOR2HS $PINS O=SUM[26] I1=n18 I2=carry[26]
XU39 ND2 $PINS O=n28 I1=carry[15] I2=B[15]
XU40 ND2 $PINS O=n27 I1=carry[15] I2=A[15]
XU41 MAO222 $PINS O=n19 A1=carry[12] B1=B[12] C1=A[12]
XU42 MAO222 $PINS O=n20 A1=carry[5] B1=B[5] C1=A[5]
XU43 MAO222 $PINS O=n21 A1=n19 B1=B[13] C1=A[13]
XU45 ND3 $PINS O=carry[16] I1=n27 I2=n28 I3=n26
XU47 XOR2HS $PINS O=n25 I1=A[15] I2=B[15]
XU48 XOR2HS $PINS O=SUM[15] I1=n25 I2=carry[15]
XU49 ND2 $PINS O=n26 I1=A[15] I2=B[15]
XU50 ND2P $PINS O=n30 I1=n20 I2=A[6]
XU51 XOR2HS $PINS O=n32 I1=A[7] I2=B[7]
XU52 XOR2HS $PINS O=SUM[7] I1=carry[7] I2=n32
XU53 ND2 $PINS O=n33 I1=A[7] I2=B[7]
XU54 ND2 $PINS O=n35 I1=carry[7] I2=B[7]
XU55 XOR2HS $PINS O=n36 I1=A[23] I2=B[23]
XU56 XOR2HS $PINS O=SUM[23] I1=carry[23] I2=n36
XU57 ND2 $PINS O=n37 I1=carry[23] I2=A[23]
XU58 ND2 $PINS O=n38 I1=carry[23] I2=B[23]
XU59 ND2S $PINS O=n39 I1=A[23] I2=B[23]
XU60 XOR2HS $PINS O=SUM[0] I1=A[0] I2=B[0]
XU4 XOR2HS $PINS O=SUM[22] I1=carry[22] I2=n8
XU7 ND3P $PINS O=carry[23] I1=n9 I2=n10 I3=n11
XU11 ND3P $PINS O=carry[22] I1=n2 I2=n3 I3=n4
XU12 ND3 $PINS O=carry[8] I1=n34 I2=n35 I3=n33
XU18 ND2 $PINS O=n9 I1=carry[22] I2=A[22]
XU19 ND2 $PINS O=n34 I1=carry[7] I2=A[7]
.ENDS

.SUBCKT PE_Shift_Add_5_DW01_add_1_DW01_add_33 A[26] A[25] A[24] A[23] A[22]
+ A[21] A[20] A[19] A[18] A[17] A[16] A[15] A[14] A[13] A[12] A[11] A[10] A[9]
+ A[8] A[7] A[6] A[5] A[4] A[3] A[2] A[1] A[0] B[26] B[25] B[24] B[23] B[22]
+ B[21] B[20] B[19] B[18] B[17] B[16] B[15] B[14] B[13] B[12] B[11] B[10] B[9]
+ B[8] B[7] B[6] B[5] B[4] B[3] B[2] B[1] B[0] CI SUM[26] SUM[25] SUM[24]
+ SUM[23] SUM[22] SUM[21] SUM[20] SUM[19] SUM[18] SUM[17] SUM[16] SUM[15]
+ SUM[14] SUM[13] SUM[12] SUM[11] SUM[10] SUM[9] SUM[8] SUM[7] SUM[6] SUM[5]
+ SUM[4] SUM[3] SUM[2] SUM[1] SUM[0] CO
XFE_RC_1776_0 INV1S $PINS O=FE_RN_481_0 I=A[3]
XFE_RC_1775_0 INV1S $PINS O=FE_RN_482_0 I=n13
XFE_RC_1774_0 OAI112H $PINS O=carry[4] A1=n14 B1=n16 C1=FE_RN_482_0
+ C2=FE_RN_481_0
XFE_RC_1485_0 XOR3 $PINS O=SUM[25] I1=A[25] I2=B[25] I3=carry[25]
XFE_RC_1484_0 MAO222P $PINS O=carry[26] A1=carry[25] B1=B[25] C1=A[25]
XFE_RC_1302_0 INV2 $PINS O=SUM[4] I=FE_RN_265_0
XFE_RC_1301_0 XNR3 $PINS O=FE_RN_265_0 I1=A[4] I2=B[4] I3=carry[4]
XFE_RC_1196_0 INV2CK $PINS O=SUM[26] I=FE_RN_212_0
XFE_RC_1195_0 XNR2HS $PINS O=FE_RN_214_0 I1=A[26] I2=B[26]
XFE_RC_1194_0 INV1S $PINS O=FE_RN_213_0 I=FE_RN_214_0
XFE_RC_1193_0 XNR2HS $PINS O=FE_RN_212_0 I1=FE_RN_213_0 I2=carry[26]
XFE_RC_1190_0 MAO222 $PINS O=carry[11] A1=carry[10] B1=A[10] C1=B[10]
XFE_RC_1040_0 INV2 $PINS O=SUM[3] I=FE_RN_155_0
XFE_RC_1039_0 XNR3 $PINS O=FE_RN_155_0 I1=A[3] I2=B[3] I3=carry[3]
XFE_RC_980_0 XOR3 $PINS O=SUM[24] I1=A[24] I2=B[24] I3=carry[24]
XFE_RC_979_0 MAO222P $PINS O=carry[25] A1=carry[24] B1=B[24] C1=A[24]
XFE_RC_766_0 XOR3 $PINS O=SUM[23] I1=A[23] I2=B[23] I3=carry[23]
XFE_RC_765_0 MAO222P $PINS O=carry[24] A1=carry[23] B1=B[23] C1=A[23]
XFE_RC_741_0 XOR3 $PINS O=SUM[22] I1=A[22] I2=B[22] I3=carry[22]
XFE_RC_740_0 MAO222P $PINS O=carry[23] A1=carry[22] B1=B[22] C1=A[22]
XFE_RC_683_0 XOR3 $PINS O=SUM[21] I1=A[21] I2=B[21] I3=carry[21]
XFE_RC_682_0 MAO222P $PINS O=carry[22] A1=carry[21] B1=B[21] C1=A[21]
XFE_RC_625_0 XOR3 $PINS O=SUM[16] I1=A[16] I2=B[16] I3=carry[16]
XFE_RC_624_0 MAO222P $PINS O=carry[17] A1=carry[16] B1=B[16] C1=A[16]
XFE_RC_613_0 XOR3 $PINS O=SUM[19] I1=A[19] I2=B[19] I3=carry[19]
XFE_RC_612_0 MAO222P $PINS O=carry[20] A1=carry[19] B1=B[19] C1=A[19]
XFE_RC_543_0 XOR3 $PINS O=SUM[20] I1=A[20] I2=B[20] I3=carry[20]
XFE_RC_542_0 MAO222P $PINS O=carry[21] A1=carry[20] B1=B[20] C1=A[20]
XFE_RC_541_0 XOR3 $PINS O=SUM[17] I1=A[17] I2=B[17] I3=carry[17]
XFE_RC_540_0 MAO222P $PINS O=carry[18] A1=carry[17] B1=B[17] C1=A[17]
XFE_RC_446_0 XOR3 $PINS O=SUM[5] I1=A[5] I2=B[5] I3=carry[5]
XFE_RC_445_0 MAO222P $PINS O=carry[6] A1=carry[5] B1=B[5] C1=A[5]
XFE_RC_444_0 XOR3 $PINS O=SUM[18] I1=A[18] I2=B[18] I3=carry[18]
XFE_RC_443_0 MAO222P $PINS O=carry[19] A1=carry[18] B1=B[18] C1=A[18]
XFE_RC_398_0 XOR3 $PINS O=SUM[12] I1=A[12] I2=B[12] I3=carry[12]
XFE_RC_397_0 MAO222P $PINS O=carry[13] A1=carry[12] B1=B[12] C1=A[12]
XFE_RC_290_0 XOR3 $PINS O=SUM[6] I1=A[6] I2=B[6] I3=carry[6]
XFE_RC_289_0 MAO222P $PINS O=carry[7] A1=carry[6] B1=B[6] C1=A[6]
XFE_RC_288_0 XOR3 $PINS O=SUM[13] I1=A[13] I2=B[13] I3=carry[13]
XFE_RC_287_0 MAO222P $PINS O=carry[14] A1=carry[13] B1=B[13] C1=A[13]
XFE_RC_213_0 XOR3 $PINS O=SUM[7] I1=A[7] I2=B[7] I3=carry[7]
XFE_RC_212_0 MAO222P $PINS O=carry[8] A1=carry[7] B1=B[7] C1=A[7]
XFE_RC_209_0 XOR3 $PINS O=SUM[14] I1=A[14] I2=B[14] I3=carry[14]
XFE_RC_208_0 MAO222P $PINS O=carry[15] A1=carry[14] B1=B[14] C1=A[14]
XFE_RC_144_0 XOR3 $PINS O=SUM[8] I1=A[8] I2=B[8] I3=carry[8]
XFE_RC_143_0 MAO222P $PINS O=carry[9] A1=carry[8] B1=B[8] C1=A[8]
XFE_RC_102_0 XOR3 $PINS O=SUM[9] I1=A[9] I2=B[9] I3=carry[9]
XFE_RC_101_0 MAO222 $PINS O=carry[10] A1=carry[9] B1=B[9] C1=A[9]
XU1_1 FA1 $PINS S=SUM[1] CO=carry[2] A=A[1] B=B[1] CI=carry[1]
XU1_2 FA1 $PINS S=SUM[2] CO=carry[3] A=A[2] B=carry[2] CI=B[2]
XU3 ND2 $PINS O=n8 I1=carry[11] I2=A[11]
XU4 ND2 $PINS O=n7 I1=carry[11] I2=B[11]
XU9 XOR3 $PINS O=SUM[10] I1=B[10] I2=A[10] I3=carry[10]
XU13 ND3P $PINS O=carry[12] I1=n8 I2=n7 I3=n9
XU14 XOR3 $PINS O=SUM[15] I1=B[15] I2=A[15] I3=carry[15]
XU15 ND2 $PINS O=n4 I1=carry[15] I2=B[15]
XU16 ND2 $PINS O=n5 I1=carry[15] I2=A[15]
XU17 ND2 $PINS O=n6 I1=B[15] I2=A[15]
XU19 INV1S $PINS O=carry[1] I=n17
XU20 ND2S $PINS O=n9 I1=B[11] I2=A[11]
XU21 ND2 $PINS O=n10 I1=carry[4] I2=B[4]
XU22 ND2 $PINS O=n11 I1=carry[4] I2=A[4]
XU23 ND2 $PINS O=n12 I1=B[4] I2=A[4]
XU26 ND2 $PINS O=n14 I1=n13 I2=B[3]
XU27 MAO222 $PINS O=n13 A1=B[2] B1=carry[2] C1=A[2]
XU29 XOR2HS $PINS O=SUM[0] I1=B[0] I2=A[0]
XU1 ND3 $PINS O=carry[16] I1=n4 I2=n5 I3=n6
XU6 ND3 $PINS O=carry[5] I1=n11 I2=n10 I3=n12
XU7 ND2 $PINS O=n16 I1=B[3] I2=A[3]
XU18 XOR3 $PINS O=SUM[11] I1=B[11] I2=A[11] I3=carry[11]
XU24 ND2 $PINS O=n17 I1=B[0] I2=A[0]
.ENDS

.SUBCKT PE_Shift_Add_5_DW01_add_0_DW01_add_32 A[26] A[25] A[24] A[23] A[22]
+ A[21] A[20] A[19] A[18] A[17] A[16] A[15] A[14] A[13] A[12] A[11] A[10] A[9]
+ A[8] A[7] A[6] A[5] A[4] A[3] A[2] A[1] A[0] B[26] B[25] B[24] B[23] B[22]
+ B[21] B[20] B[19] B[18] B[17] B[16] B[15] B[14] B[13] B[12] B[11] B[10] B[9]
+ B[8] B[7] B[6] B[5] B[4] B[3] B[2] B[1] B[0] CI SUM[26] SUM[25] SUM[24]
+ SUM[23] SUM[22] SUM[21] SUM[20] SUM[19] SUM[18] SUM[17] SUM[16] SUM[15]
+ SUM[14] SUM[13] SUM[12] SUM[11] SUM[10] SUM[9] SUM[8] SUM[7] SUM[6] SUM[5]
+ SUM[4] SUM[3] SUM[2] SUM[1] SUM[0] CO
XFE_RC_1474_0 INV1S $PINS O=FE_RN_335_0 I=B[9]
XFE_RC_1473_0 AO13 $PINS O=n18 A1=FE_RN_335_0 B1=n14 B2=n13 B3=n12
XFE_RC_1006_0 INV1S $PINS O=FE_RN_148_0 I=B[8]
XFE_RC_1005_0 AO13P $PINS O=n14 A1=FE_RN_148_0 B1=n20 B2=n19 B3=n21
XFE_RC_823_0 XNR2H $PINS O=FE_RN_61_0 I1=B[26] I2=A[26]
XFE_RC_822_0 XNR2HS $PINS O=SUM[26] I1=FE_RN_61_0 I2=carry[26]
XFE_RC_537_0 XOR3 $PINS O=SUM[1] I1=A[1] I2=B[1] I3=n4
XFE_RC_536_0 MAO222 $PINS O=carry[2] A1=B[1] B1=A[1] C1=n4
XFE_RC_492_0 XOR3 $PINS O=SUM[2] I1=A[2] I2=B[2] I3=carry[2]
XFE_RC_491_0 MAO222P $PINS O=carry[3] A1=B[2] B1=carry[2] C1=A[2]
XFE_RC_438_0 XOR3 $PINS O=SUM[3] I1=A[3] I2=B[3] I3=carry[3]
XFE_RC_437_0 MAO222P $PINS O=carry[4] A1=carry[3] B1=B[3] C1=A[3]
XFE_RC_369_0 XOR3 $PINS O=SUM[12] I1=A[12] I2=B[12] I3=carry[12]
XFE_RC_368_0 MAO222P $PINS O=carry[13] A1=carry[12] B1=B[12] C1=A[12]
XFE_RC_357_0 XOR3 $PINS O=SUM[4] I1=A[4] I2=B[4] I3=carry[4]
XFE_RC_356_0 MAO222P $PINS O=carry[5] A1=carry[4] B1=B[4] C1=A[4]
XFE_RC_319_0 XOR3 $PINS O=SUM[10] I1=A[10] I2=B[10] I3=carry[10]
XFE_RC_318_0 MAO222P $PINS O=carry[11] A1=carry[10] B1=B[10] C1=A[10]
XFE_RC_309_0 XOR3 $PINS O=SUM[16] I1=A[16] I2=B[16] I3=carry[16]
XFE_RC_308_0 MAO222 $PINS O=carry[17] A1=carry[16] B1=B[16] C1=A[16]
XFE_RC_245_0 XOR3 $PINS O=SUM[5] I1=A[5] I2=B[5] I3=carry[5]
XFE_RC_244_0 MAO222P $PINS O=carry[6] A1=carry[5] B1=B[5] C1=A[5]
XFE_RC_149_0 XOR3 $PINS O=SUM[6] I1=A[6] I2=B[6] I3=carry[6]
XFE_RC_148_0 MAO222P $PINS O=carry[7] A1=carry[6] B1=B[6] C1=A[6]
XFE_RC_142_0 XOR3 $PINS O=SUM[22] I1=B[22] I2=A[22] I3=carry[22]
XFE_RC_141_0 MAO222P $PINS O=carry[23] A1=carry[22] B1=A[22] C1=B[22]
XFE_RC_115_0 XOR3 $PINS O=SUM[23] I1=A[23] I2=B[23] I3=carry[23]
XFE_RC_114_0 ND2P $PINS O=FE_RN_15_0 I1=carry[23] I2=B[23]
XFE_RC_113_0 ND2P $PINS O=FE_RN_16_0 I1=carry[23] I2=A[23]
XFE_RC_112_0 ND2 $PINS O=FE_RN_17_0 I1=B[23] I2=A[23]
XFE_RC_111_0 ND3HT $PINS O=carry[24] I1=FE_RN_16_0 I2=FE_RN_15_0 I3=FE_RN_17_0
XFE_RC_110_0 XOR3P $PINS O=SUM[18] I1=A[18] I2=B[18] I3=carry[18]
XFE_RC_109_0 MAO222P $PINS O=carry[19] A1=carry[18] B1=B[18] C1=A[18]
XU1_20 FA1S $PINS S=SUM[20] CO=carry[21] A=A[20] B=B[20] CI=carry[20]
XU1_14 FA1S $PINS S=SUM[14] CO=carry[15] A=A[14] B=B[14] CI=carry[14]
XU1 XOR3 $PINS O=SUM[8] I1=A[8] I2=B[8] I3=carry[8]
XU2 ND3P $PINS O=carry[22] I1=n39 I2=n38 I3=n40
XU3 ND2 $PINS O=n40 I1=A[21] I2=B[21]
XU4 ND2 $PINS O=n3 I1=A[19] I2=B[19]
XU5 ND3P $PINS O=carry[9] I1=n14 I2=n13 I3=n12
XU6 ND3P $PINS O=carry[25] I1=n5 I2=n6 I3=n7
XU7 ND2 $PINS O=n33 I1=n23 I2=B[15]
XU8 ND3P $PINS O=carry[12] I1=n27 I2=n26 I3=n28
XU9 ND3 $PINS O=carry[18] I1=n35 I2=n36 I3=n37
XU10 XOR3 $PINS O=SUM[19] I1=A[19] I2=B[19] I3=carry[19]
XU11 ND2 $PINS O=n1 I1=carry[19] I2=A[19]
XU12 ND2P $PINS O=n2 I1=carry[19] I2=B[19]
XU13 ND3P $PINS O=carry[20] I1=n1 I2=n2 I3=n3
XU14 ND2 $PINS O=n12 I1=A[8] I2=B[8]
XU15 ND2 $PINS O=n5 I1=A[24] I2=B[24]
XU16 XOR3 $PINS O=SUM[7] I1=A[7] I2=B[7] I3=carry[7]
XU17 XOR3 $PINS O=SUM[11] I1=A[11] I2=B[11] I3=carry[11]
XU18 XOR3 $PINS O=SUM[13] I1=A[13] I2=B[13] I3=carry[13]
XU19 XOR3 $PINS O=SUM[15] I1=A[15] I2=B[15] I3=carry[15]
XU20 ND2 $PINS O=n32 I1=n23 I2=A[15]
XU21 XOR3 $PINS O=SUM[17] I1=A[17] I2=B[17] I3=carry[17]
XU22 XOR3 $PINS O=SUM[21] I1=A[21] I2=B[21] I3=carry[21]
XU23 XOR3 $PINS O=SUM[24] I1=A[24] I2=B[24] I3=carry[24]
XU24 AN2 $PINS O=n4 I1=B[0] I2=A[0]
XU25 ND2 $PINS O=n6 I1=carry[24] I2=A[24]
XU26 ND2 $PINS O=n7 I1=carry[24] I2=B[24]
XU27 XOR2HS $PINS O=n8 I1=A[25] I2=B[25]
XU28 XOR2HS $PINS O=SUM[25] I1=carry[25] I2=n8
XU29 ND2 $PINS O=n9 I1=A[25] I2=B[25]
XU30 ND2 $PINS O=n10 I1=carry[25] I2=A[25]
XU31 ND2 $PINS O=n11 I1=carry[25] I2=B[25]
XU32 ND3P $PINS O=carry[26] I1=n11 I2=n10 I3=n9
XU33 ND2P $PINS O=n13 I1=carry[8] I2=A[8]
XU35 XOR2HS $PINS O=n15 I1=A[9] I2=B[9]
XU36 XOR2HS $PINS O=SUM[9] I1=n15 I2=carry[9]
XU37 ND2 $PINS O=n16 I1=A[9] I2=B[9]
XU38 ND2 $PINS O=n17 I1=carry[9] I2=A[9]
XU40 ND3 $PINS O=carry[10] I1=n18 I2=n17 I3=n16
XU41 ND2T $PINS O=n19 I1=carry[7] I2=A[7]
XU42 ND2P $PINS O=n20 I1=carry[7] I2=B[7]
XU43 ND2 $PINS O=n21 I1=B[7] I2=A[7]
XU44 ND3P $PINS O=carry[8] I1=n20 I2=n19 I3=n21
XU45 ND2 $PINS O=n39 I1=n25 I2=B[21]
XU47 MAO222 $PINS O=n23 A1=carry[14] B1=B[14] C1=A[14]
XU49 MAO222 $PINS O=n25 A1=carry[20] B1=B[20] C1=A[20]
XU51 ND2P $PINS O=n26 I1=carry[11] I2=A[11]
XU52 ND2 $PINS O=n27 I1=carry[11] I2=B[11]
XU53 ND2 $PINS O=n28 I1=A[11] I2=B[11]
XU54 ND2 $PINS O=n29 I1=carry[13] I2=A[13]
XU55 ND2 $PINS O=n30 I1=carry[13] I2=B[13]
XU56 ND2 $PINS O=n31 I1=A[13] I2=B[13]
XU57 ND3P $PINS O=carry[14] I1=n29 I2=n30 I3=n31
XU58 ND2S $PINS O=n34 I1=A[15] I2=B[15]
XU59 ND2 $PINS O=n35 I1=carry[17] I2=A[17]
XU60 ND2 $PINS O=n36 I1=carry[17] I2=B[17]
XU61 ND2 $PINS O=n37 I1=A[17] I2=B[17]
XU62 ND2 $PINS O=n38 I1=n25 I2=A[21]
XU63 XOR2HS $PINS O=SUM[0] I1=B[0] I2=A[0]
XU50 ND3 $PINS O=carry[16] I1=n32 I2=n33 I3=n34
.ENDS

.SUBCKT PE_Shift_Add_5 rst_n en clear calc_done stage_sel x_in[16] x_in[15]
+ x_in[14] x_in[13] x_in[12] x_in[11] x_in[10] x_in[9] x_in[8] x_in[7] x_in[6]
+ x_in[5] x_in[4] x_in[3] x_in[2] x_in[1] x_in[0] sign1[1] sign1[0] sign2[1]
+ sign2[0] sign3[1] sign3[0] shf1[3] shf1[2] shf1[1] shf1[0] shf2[3] shf2[2]
+ shf2[1] shf2[0] shf3[3] shf3[2] shf3[1] shf3[0] y_out[16] y_out[15] y_out[14]
+ y_out[13] y_out[12] y_out[11] y_out[10] y_out[9] y_out[8] y_out[7] y_out[6]
+ y_out[5] y_out[4] y_out[3] y_out[2] y_out[1] y_out[0] i_rst_n
+ FE_OFN28_i_rst_n FE_OFN16_i_rst_n FE_OFN10_i_rst_n FE_OFN36_n
+ FE_OFN38_FE_DBTN10_n289 FE_OFN56_FE_DBTN10_n289 FE_OFN75_n FE_OFN71_n
+ FE_OFN69_n FE_OFN132_mac_in_real_4 clk_clone2 clk_clone1 clk
XFE_PHC1533_acc_reg_12 BUF1CK $PINS O=acc_reg[12] I=FE_PHN1533_acc_reg_12
XFE_PHC1337_N249 DELB $PINS O=FE_PHN1337_N249 I=N249
XFE_PHC1332_N248 DELB $PINS O=FE_PHN1332_N248 I=N248
XFE_PHC1330_N250 DELB $PINS O=FE_PHN1330_N250 I=N250
XFE_PHC1319_N247 DELB $PINS O=FE_PHN1319_N247 I=N247
XFE_PHC1295_N235 DELB $PINS O=FE_PHN1295_N235 I=N235
XFE_PHC1276_N239 DELC $PINS O=FE_PHN1276_N239 I=N239
XFE_PHC1253_pe_r1_12 DELC $PINS O=y_out[12] I=FE_PHN1253_pe_r1_12
XFE_PHC1252_pe_r1_15 DELC $PINS O=y_out[15] I=FE_PHN1252_pe_r1_15
XFE_PHC1251_pe_r1_11 DELC $PINS O=y_out[11] I=FE_PHN1251_pe_r1_11
XFE_PHC1195_pe_r1_5 DELC $PINS O=y_out[5] I=FE_PHN1195_pe_r1_5
XFE_PHC1193_pe_r1_1 DELC $PINS O=y_out[1] I=FE_PHN1193_pe_r1_1
XFE_PHC1192_pe_r1_8 DELC $PINS O=y_out[8] I=FE_PHN1192_pe_r1_8
XFE_PHC1190_pe_r1_6 DELC $PINS O=y_out[6] I=FE_PHN1190_pe_r1_6
XFE_PHC1188_pe_r1_3 DELC $PINS O=y_out[3] I=FE_PHN1188_pe_r1_3
XFE_PHC1157_pe_r1_9 DELC $PINS O=y_out[9] I=FE_PHN1157_pe_r1_9
XFE_PHC1057_next_acc_0 DELB $PINS O=FE_PHN1057_next_acc_0 I=next_acc[0]
XFE_PHC1046_N237 DELB $PINS O=FE_PHN1046_N237 I=N237
XFE_PHC1026_N243 DELB $PINS O=FE_PHN1026_N243 I=N243
XFE_PHC990_N246 DELB $PINS O=FE_PHN990_N246 I=N246
XFE_PHC987_N245 DELB $PINS O=FE_PHN987_N245 I=N245
XFE_PHC969_N244 DELB $PINS O=FE_PHN969_N244 I=N244
XFE_PHC962_N236 DELB $PINS O=N236 I=FE_PHN962_N236
XFE_PHC952_N238 DELC $PINS O=N238 I=FE_PHN952_N238
XFE_PHC949_N240 DELC $PINS O=FE_PHN949_N240 I=N240
XFE_PHC946_N241 DELC $PINS O=FE_PHN946_N241 I=N241
XFE_PHC941_N242 DELC $PINS O=FE_PHN941_N242 I=N242
XFE_PHC937_N251 DELC $PINS O=FE_PHN937_N251 I=N251
XFE_PHC814_acc_reg_14 DELB $PINS O=FE_PHN814_acc_reg_14 I=acc_reg[14]
XFE_RC_1851_0 INV2 $PINS O=N43 I=FE_RN_517_0
XFE_RC_1850_0 AOI22H $PINS O=FE_RN_517_0 A1=N16 A2=sign1[0] B1=term1_shifted[2]
+ B2=FE_DBTN27_s11_0
XFE_RC_1849_0 MUXB2 $PINS O=term3_shifted[2] S=shf3[1] A=sll_18/ML_int[1][2]
+ B=sll_18/ML_int[1][0] EB=n67
XFE_RC_1833_0 AN2B1T $PINS O=sll_18/ML_int[1][0] I1=term3_in[0] B1=shf3[0]
XFE_RC_1740_0 INV2 $PINS O=N42 I=FE_RN_463_0
XFE_RC_1739_0 AOI12H $PINS O=FE_RN_463_0 A1=FE_RN_153_0 B1=N15
+ B2=FE_OFN261_s11_0
XCTS_ccl_a_INV_CLK_G1_L8_90 INV4CK $PINS O=CTS_10 I=CTS_11
XCTS_ccl_a_INV_CLK_G1_L7_92 INV2CK $PINS O=CTS_11 I=CTS_12
XFE_RC_1417_0 AN2 $PINS O=FE_RN_310_0 I1=term1_shifted[3] I2=FE_DBTN27_s11_0
XFE_RC_1416_0 AO12T $PINS O=N44 A1=FE_RN_310_0 B1=N17 B2=sign1[0]
XFE_RC_1410_0 INV2 $PINS O=sll_16/ML_int[2][2] I=FE_RN_306_0
XFE_RC_1409_0 AN2B1S $PINS O=FE_RN_307_0 I1=term1_in[0] B1=shf1[0]
XFE_RC_1408_0 MXL2H $PINS OB=FE_RN_306_0 S=shf1[1] A=sll_16/ML_int[1][2]
+ B=FE_RN_307_0
XFE_RC_1405_0 ND2P $PINS O=FE_RN_304_0 I1=N127 I2=sign3[0]
XFE_RC_1404_0 OR3B2 $PINS O=FE_RN_305_0 I1=n67 B1=sll_18/ML_int[2][3] B2=n22
XFE_RC_1403_0 ND2P $PINS O=N154 I1=FE_RN_304_0 I2=FE_RN_305_0
XFE_RC_1392_0 NR3H $PINS O=term3_shifted[1] I1=n67 I2=shf3[1] I3=FE_RN_169_0
XFE_RC_1346_0 INV1S $PINS O=FE_RN_281_0 I=sll_17/ML_int[2][3]
XFE_RC_1345_0 NR2P $PINS O=term2_shifted[3] I1=FE_RN_281_0 I2=n58
XFE_RC_1315_0 INV1S $PINS O=FE_RN_268_0 I=sll_16/ML_int[2][5]
XFE_RC_1314_0 MXL2HS $PINS OB=sll_16/ML_int[3][5] S=shf1[2] A=FE_RN_268_0 B=n48
XFE_RC_1186_0 INV2 $PINS O=FE_RN_208_0 I=N125
XFE_RC_1185_0 INV1S $PINS O=FE_RN_209_0 I=sign3[0]
XFE_RC_1184_0 MXL2H $PINS OB=N152 S=FE_RN_209_0 A=FE_RN_208_0
+ B=FE_DBTN18_term3_shifted_1
XFE_RC_1121_0 AN2 $PINS O=term1_shifted[4] I1=sll_16/ML_int[3][4] I2=n39
XFE_RC_1089_0 INV1S $PINS O=FE_RN_171_0 I=n27
XFE_RC_1088_0 NR3HP $PINS O=term2_shifted[1] I1=FE_RN_171_0 I2=n58
+ I3=FE_RN_154_0
XFE_RC_1087_0 INV1S $PINS O=sll_18/ML_int[1][1] I=FE_RN_169_0
XFE_RC_1086_0 NR2T $PINS O=FE_RN_170_0 I1=sign3[1] I2=x_in[0]
XFE_RC_1085_0 MXL2H $PINS OB=FE_RN_169_0 S=shf3[0] A=term3_in[1] B=FE_RN_170_0
XFE_RC_1084_0 INV2 $PINS O=N156 I=FE_RN_168_0
XFE_RC_1083_0 AOI22S $PINS O=FE_RN_168_0 A1=N129 A2=sign3[0]
+ B1=term3_shifted[5] B2=n22
XFE_RC_1053_0 NR4 $PINS O=n10 I1=sign1[1] I2=x_in[0] I3=shf1[1] I4=shf1[0]
XFE_RC_1048_0 INV2 $PINS O=sll_16/ML_int[3][4] I=FE_RN_157_0
XFE_RC_1047_0 MXL2HS $PINS OB=FE_RN_157_0 S=shf1[2] A=sll_16/ML_int[2][4] B=n10
XFE_RC_1046_0 INV2 $PINS O=N46 I=FE_RN_156_0
XFE_RC_1045_0 AOI22S $PINS O=FE_RN_156_0 A1=N19 A2=sign1[0] B1=term1_shifted[5]
+ B2=FE_DBTN27_s11_0
XFE_RC_1038_0 MXL2HS $PINS OB=FE_RN_154_0 S=shf2[0] A=term2_in[1] B=term2_in[0]
XFE_RC_1032_0 AN3 $PINS O=FE_RN_153_0 I1=n9 I2=n6 I3=FE_DBTN27_s11_0
XFE_RC_1030_0 MUX2 $PINS O=n9 S=shf1[0] A=term1_in[1] B=term1_in[0]
XFE_RC_948_0 INV2 $PINS O=sll_17/ML_int[2][2] I=FE_RN_132_0
XFE_RC_947_0 MXL2HS $PINS OB=FE_RN_132_0 S=shf2[1] A=sll_17/ML_int[1][2]
+ B=sll_17/ML_int[1][0]
XFE_RC_12_0 OA12 $PINS O=N151 A1=term3_shifted[0] B1=sign3[0] B2=n22
XFE_RC_4_0 OA12 $PINS O=N96 A1=term2_shifted[0] B1=sign2[0] B2=FE_DBTN26_s12_0
XFE_OFC592_FE_DBTN27_s11_0 BUF1 $PINS O=FE_OFN342_FE_DBTN27_s11_0
+ I=FE_DBTN27_s11_0
XFE_OFC582_sll_18_ML_int_2__3 INV1S $PINS O=n68 I=sll_18/ML_int[2][3]
XFE_OFC551_mac_in_real_3 INV1S $PINS O=FE_OFN327_mac_in_real_3 I=x_in[3]
XFE_OFC550_h12_2 INV1S $PINS O=n29 I=shf2[2]
XFE_OFC539_pe_clear_d1 INV2 $PINS O=FE_OFN320_n I=clear
XFE_OFC532_sll_16_ML_int_2__3 INV2 $PINS O=n50 I=sll_16/ML_int[2][3]
XFE_OFC530_term3_shifted_1 INV2 $PINS O=FE_DBTN18_term3_shifted_1
+ I=term3_shifted[1]
XFE_OFC503_sll_16_ML_int_2__2 INV2 $PINS O=n51 I=sll_16/ML_int[2][2]
XFE_OFC484_h11_0 BUF1 $PINS O=FE_OFN301_h11_0 I=shf1[0]
XFE_OFC444_s11_0 BUF1 $PINS O=FE_OFN261_s11_0 I=sign1[0]
XFE_OFC398_h12_1 BUF1 $PINS O=FE_OFN232_h12_1 I=shf2[1]
XFE_OFC396_h12_1 INV1S $PINS O=n27 I=shf2[1]
XFE_OFC394_h12_0 BUF1 $PINS O=FE_OFN230_h12_0 I=shf2[0]
XFE_OFC391_h12_0 INV1S $PINS O=n26 I=shf2[0]
XFE_OFC388_h13_1 INV2 $PINS O=FE_OFN228_h13_1 I=shf3[1]
XFE_OFC387_h13_1 BUF1 $PINS O=n16 I=shf3[1]
XFE_OFC331_h11_1 BUF1 $PINS O=FE_OFN206_h11_1 I=shf1[1]
XFE_OFC330_h11_1 INV1S $PINS O=n37 I=shf1[1]
XFE_OFC311_h11_3 BUF1 $PINS O=FE_OFN199_h11_3 I=shf1[3]
XFE_OFC310_h11_3 INV1S $PINS O=n39 I=shf1[3]
XFE_OFC285_h13_3 INV1S $PINS O=n18 I=shf3[3]
XFE_OFC275_h12_3 INV1S $PINS O=FE_OFN189_h12_3 I=n31
XFE_OFC273_h12_3 INV1S $PINS O=n31 I=shf2[3]
XFE_OFC251_s12_0 INV1S $PINS O=FE_OFN178_s12_0 I=FE_DBTN26_s12_0
XFE_OFC248_s12_0 INV2 $PINS O=FE_DBTN26_s12_0 I=sign2[0]
XFE_OFC221_s13_0 INV1S $PINS O=FE_OFN163_s13_0 I=n22
XFE_OFC218_s13_0 INV2 $PINS O=n22 I=sign3[0]
XFE_OFC159_s11_0 BUF1 $PINS O=FE_OFN137_s11_0 I=FE_OFN261_s11_0
XFE_OFC158_s11_0 INV2 $PINS O=FE_DBTN27_s11_0 I=sign1[0]
XU110 AO22 $PINS O=base_val[13] A1=acc_reg[13] A2=FE_OFN320_n B1=FE_OFN69_n
+ B2=FE_OFN56_FE_DBTN10_n289
XU112 AO22 $PINS O=N98 A1=N71 A2=sign2[0] B1=term2_shifted[2]
+ B2=FE_DBTN26_s12_0
XU115 AO22 $PINS O=N67 A1=FE_OFN137_s11_0 A2=N40 B1=term1_shifted[26]
+ B2=FE_OFN342_FE_DBTN27_s11_0
XU133 AO22 $PINS O=N49 A1=N22 A2=FE_OFN261_s11_0 B1=term1_shifted[8]
+ B2=FE_DBTN27_s11_0
XU134 AO22 $PINS O=N48 A1=N21 A2=FE_OFN261_s11_0 B1=term1_shifted[7]
+ B2=FE_DBTN27_s11_0
XU135 AO22 $PINS O=N47 A1=N20 A2=FE_OFN261_s11_0 B1=term1_shifted[6]
+ B2=FE_DBTN27_s11_0
XU137 AO22 $PINS O=N45 A1=N18 A2=sign1[0] B1=term1_shifted[4]
+ B2=FE_DBTN27_s11_0
XU143 AO22 $PINS O=N176 A1=N149 A2=FE_OFN163_s13_0 B1=term3_shifted[25] B2=n22
XU144 AO22 $PINS O=N175 A1=N148 A2=FE_OFN163_s13_0 B1=term3_shifted[24] B2=n22
XU146 AO22 $PINS O=N173 A1=N146 A2=FE_OFN163_s13_0 B1=term3_shifted[22] B2=n22
XU147 AO22 $PINS O=N172 A1=N145 A2=FE_OFN163_s13_0 B1=term3_shifted[21] B2=n22
XU148 AO22 $PINS O=N171 A1=N144 A2=FE_OFN163_s13_0 B1=term3_shifted[20] B2=n22
XU149 AO22 $PINS O=N170 A1=N143 A2=FE_OFN163_s13_0 B1=term3_shifted[19] B2=n22
XU150 AO22 $PINS O=N169 A1=N142 A2=FE_OFN163_s13_0 B1=term3_shifted[18] B2=n22
XU151 AO22 $PINS O=N168 A1=N141 A2=FE_OFN163_s13_0 B1=term3_shifted[17] B2=n22
XU152 AO22 $PINS O=N167 A1=N140 A2=FE_OFN163_s13_0 B1=term3_shifted[16] B2=n22
XU153 AO22 $PINS O=N166 A1=N139 A2=FE_OFN163_s13_0 B1=term3_shifted[15] B2=n22
XU154 AO22 $PINS O=N165 A1=N138 A2=FE_OFN163_s13_0 B1=term3_shifted[14] B2=n22
XU155 AO22 $PINS O=N164 A1=N137 A2=FE_OFN163_s13_0 B1=term3_shifted[13] B2=n22
XU156 AO22 $PINS O=N163 A1=N136 A2=FE_OFN163_s13_0 B1=term3_shifted[12] B2=n22
XU157 AO22 $PINS O=N162 A1=N135 A2=FE_OFN163_s13_0 B1=term3_shifted[11] B2=n22
XU158 AO22 $PINS O=N161 A1=N134 A2=FE_OFN163_s13_0 B1=term3_shifted[10] B2=n22
XU159 AO22 $PINS O=N160 A1=N133 A2=FE_OFN163_s13_0 B1=term3_shifted[9] B2=n22
XU160 AO22 $PINS O=N159 A1=N132 A2=FE_OFN163_s13_0 B1=term3_shifted[8] B2=n22
XU161 AO22 $PINS O=N158 A1=N131 A2=FE_OFN163_s13_0 B1=term3_shifted[7] B2=n22
XU162 AO22 $PINS O=N157 A1=N130 A2=sign3[0] B1=term3_shifted[6] B2=n22
XU164 AO22 $PINS O=N155 A1=N128 A2=sign3[0] B1=term3_shifted[4] B2=n22
XU179 AO22 $PINS O=N112 A1=N85 A2=FE_OFN178_s12_0 B1=term2_shifted[16]
+ B2=FE_DBTN26_s12_0
XU180 AO22 $PINS O=N111 A1=N84 A2=FE_OFN178_s12_0 B1=term2_shifted[15]
+ B2=FE_DBTN26_s12_0
XU181 AO22 $PINS O=N110 A1=N83 A2=FE_OFN178_s12_0 B1=term2_shifted[14]
+ B2=FE_DBTN26_s12_0
XU183 AO22 $PINS O=N108 A1=N81 A2=FE_OFN178_s12_0 B1=term2_shifted[12]
+ B2=FE_DBTN26_s12_0
XU185 AO22 $PINS O=N106 A1=N79 A2=FE_OFN178_s12_0 B1=term2_shifted[10]
+ B2=FE_DBTN26_s12_0
XU186 AO22 $PINS O=N105 A1=N78 A2=FE_OFN178_s12_0 B1=term2_shifted[9]
+ B2=FE_DBTN26_s12_0
XU187 AO22 $PINS O=N104 A1=N77 A2=sign2[0] B1=term2_shifted[8]
+ B2=FE_DBTN26_s12_0
XU188 AO22 $PINS O=N103 A1=N76 A2=sign2[0] B1=term2_shifted[7]
+ B2=FE_DBTN26_s12_0
XU189 AO22 $PINS O=N102 A1=N75 A2=sign2[0] B1=term2_shifted[6]
+ B2=FE_DBTN26_s12_0
XU190 AO22 $PINS O=N101 A1=N74 A2=sign2[0] B1=term2_shifted[5]
+ B2=FE_DBTN26_s12_0
Xsll_18/M1_0_2 MUX2 $PINS O=sll_18/ML_int[1][2] S=shf3[0] A=term3_in[2]
+ B=term3_in[1]
Xsll_18/M1_0_3 MUX2 $PINS O=sll_18/ML_int[1][3] S=shf3[0] A=term3_in[3]
+ B=term3_in[2]
Xsll_18/M1_0_4 MUX2 $PINS O=sll_18/ML_int[1][4] S=shf3[0] A=term3_in[4]
+ B=term3_in[3]
Xsll_18/M1_0_5 MUX2 $PINS O=sll_18/ML_int[1][5] S=shf3[0] A=term3_in[5]
+ B=term3_in[4]
Xsll_18/M1_0_6 MUX2 $PINS O=sll_18/ML_int[1][6] S=shf3[0] A=term3_in[6]
+ B=term3_in[5]
Xsll_18/M1_1_2 MUX2 $PINS O=sll_18/ML_int[2][2] S=shf3[1] A=sll_18/ML_int[1][2]
+ B=sll_18/ML_int[1][0]
Xsll_18/M1_1_4 MUX2 $PINS O=sll_18/ML_int[2][4] S=shf3[1] A=sll_18/ML_int[1][4]
+ B=sll_18/ML_int[1][2]
Xsll_18/M1_1_5 MUX2 $PINS O=sll_18/ML_int[2][5] S=shf3[1] A=sll_18/ML_int[1][5]
+ B=sll_18/ML_int[1][3]
Xsll_18/M1_1_6 MUX2 $PINS O=sll_18/ML_int[2][6] S=shf3[1] A=sll_18/ML_int[1][6]
+ B=sll_18/ML_int[1][4]
Xsll_18/M1_1_7 MUX2 $PINS O=sll_18/ML_int[2][7] S=shf3[1] A=sll_18/ML_int[1][7]
+ B=sll_18/ML_int[1][5]
Xsll_18/M1_2_4 MUX2 $PINS O=sll_18/ML_int[3][4] S=shf3[2] A=sll_18/ML_int[2][4]
+ B=n70
Xsll_18/M1_2_5 MUX2 $PINS O=sll_18/ML_int[3][5] S=shf3[2] A=sll_18/ML_int[2][5]
+ B=n71
Xsll_18/M1_2_8 MUX2 $PINS O=sll_18/ML_int[3][8] S=shf3[2] A=sll_18/ML_int[2][8]
+ B=sll_18/ML_int[2][4]
Xsll_18/M1_2_9 MUX2 $PINS O=sll_18/ML_int[3][9] S=shf3[2] A=sll_18/ML_int[2][9]
+ B=sll_18/ML_int[2][5]
Xsll_18/M1_3_8 MUX2 $PINS O=term3_shifted[8] S=shf3[3] A=sll_18/ML_int[3][8]
+ B=sll_18/ML_int[3][0]
Xsll_18/M1_3_9 MUX2 $PINS O=term3_shifted[9] S=shf3[3] A=sll_18/ML_int[3][9]
+ B=sll_18/ML_int[3][1]
Xsll_18/M1_3_10 MUX2 $PINS O=term3_shifted[10] S=shf3[3] A=sll_18/ML_int[3][10]
+ B=sll_18/ML_int[3][2]
Xsll_18/M1_3_11 MUX2 $PINS O=term3_shifted[11] S=shf3[3] A=sll_18/ML_int[3][11]
+ B=sll_18/ML_int[3][3]
Xsll_18/M1_3_12 MUX2 $PINS O=term3_shifted[12] S=shf3[3] A=sll_18/ML_int[3][12]
+ B=sll_18/ML_int[3][4]
Xsll_18/M1_3_13 MUX2 $PINS O=term3_shifted[13] S=shf3[3] A=sll_18/ML_int[3][13]
+ B=sll_18/ML_int[3][5]
Xsll_18/M1_3_22 MUX2 $PINS O=term3_shifted[22] S=shf3[3] A=sll_18/ML_int[3][22]
+ B=sll_18/ML_int[3][14]
Xsll_18/M1_3_23 MUX2 $PINS O=term3_shifted[23] S=shf3[3] A=term3_in[26]
+ B=sll_18/ML_int[3][15]
Xsll_17/M1_0_2 MUX2 $PINS O=sll_17/ML_int[1][2] S=shf2[0] A=term2_in[2]
+ B=term2_in[1]
Xsll_17/M1_0_3 MUX2 $PINS O=sll_17/ML_int[1][3] S=shf2[0] A=term2_in[3]
+ B=term2_in[2]
Xsll_17/M1_0_4 MUX2 $PINS O=sll_17/ML_int[1][4] S=shf2[0] A=term2_in[4]
+ B=term2_in[3]
Xsll_17/M1_0_5 MUX2 $PINS O=sll_17/ML_int[1][5] S=shf2[0] A=term2_in[5]
+ B=term2_in[4]
Xsll_17/M1_0_6 MUX2 $PINS O=sll_17/ML_int[1][6] S=FE_OFN230_h12_0 A=term2_in[6]
+ B=term2_in[5]
Xsll_17/M1_1_4 MUX2 $PINS O=sll_17/ML_int[2][4] S=shf2[1] A=sll_17/ML_int[1][4]
+ B=sll_17/ML_int[1][2]
Xsll_17/M1_1_5 MUX2 $PINS O=sll_17/ML_int[2][5] S=shf2[1] A=sll_17/ML_int[1][5]
+ B=sll_17/ML_int[1][3]
Xsll_17/M1_1_6 MUX2 $PINS O=sll_17/ML_int[2][6] S=FE_OFN232_h12_1
+ A=sll_17/ML_int[1][6] B=sll_17/ML_int[1][4]
Xsll_17/M1_1_7 MUX2 $PINS O=sll_17/ML_int[2][7] S=FE_OFN232_h12_1
+ A=sll_17/ML_int[1][7] B=sll_17/ML_int[1][5]
Xsll_17/M1_2_4 MUX2 $PINS O=sll_17/ML_int[3][4] S=shf2[2] A=sll_17/ML_int[2][4]
+ B=n3
Xsll_17/M1_2_5 MUX2 $PINS O=sll_17/ML_int[3][5] S=shf2[2] A=sll_17/ML_int[2][5]
+ B=n60
Xsll_17/M1_2_6 MUX2 $PINS O=sll_17/ML_int[3][6] S=shf2[2] A=sll_17/ML_int[2][6]
+ B=sll_17/ML_int[2][2]
Xsll_17/M1_2_7 MUX2 $PINS O=sll_17/ML_int[3][7] S=shf2[2] A=sll_17/ML_int[2][7]
+ B=sll_17/ML_int[2][3]
Xsll_17/M1_2_8 MUX2 $PINS O=sll_17/ML_int[3][8] S=shf2[2] A=sll_17/ML_int[2][8]
+ B=sll_17/ML_int[2][4]
Xsll_17/M1_2_9 MUX2 $PINS O=sll_17/ML_int[3][9] S=shf2[2] A=sll_17/ML_int[2][9]
+ B=sll_17/ML_int[2][5]
Xsll_17/M1_3_8 MUX2 $PINS O=term2_shifted[8] S=FE_OFN189_h12_3
+ A=sll_17/ML_int[3][8] B=sll_17/ML_int[3][0]
Xsll_17/M1_3_9 MUX2 $PINS O=term2_shifted[9] S=FE_OFN189_h12_3
+ A=sll_17/ML_int[3][9] B=sll_17/ML_int[3][1]
Xsll_17/M1_3_10 MUX2 $PINS O=term2_shifted[10] S=FE_OFN189_h12_3
+ A=sll_17/ML_int[3][10] B=sll_17/ML_int[3][2]
Xsll_17/M1_3_11 MUX2 $PINS O=term2_shifted[11] S=FE_OFN189_h12_3
+ A=sll_17/ML_int[3][11] B=sll_17/ML_int[3][3]
Xsll_17/M1_3_12 MUX2 $PINS O=term2_shifted[12] S=FE_OFN189_h12_3
+ A=sll_17/ML_int[3][12] B=sll_17/ML_int[3][4]
Xsll_17/M1_3_13 MUX2 $PINS O=term2_shifted[13] S=FE_OFN189_h12_3
+ A=sll_17/ML_int[3][13] B=sll_17/ML_int[3][5]
Xsll_17/M1_3_22 MUX2 $PINS O=term2_shifted[22] S=FE_OFN189_h12_3
+ A=sll_17/ML_int[3][22] B=sll_17/ML_int[3][14]
Xsll_17/M1_3_23 MUX2 $PINS O=term2_shifted[23] S=FE_OFN189_h12_3 A=term2_in[26]
+ B=sll_17/ML_int[3][15]
Xsll_16/M1_0_2 MUX2 $PINS O=sll_16/ML_int[1][2] S=shf1[0] A=term1_in[2]
+ B=term1_in[1]
Xsll_16/M1_0_4 MUX2 $PINS O=sll_16/ML_int[1][4] S=shf1[0] A=term1_in[4]
+ B=term1_in[3]
Xsll_16/M1_0_5 MUX2 $PINS O=sll_16/ML_int[1][5] S=shf1[0] A=term1_in[5]
+ B=term1_in[4]
Xsll_16/M1_0_6 MUX2 $PINS O=sll_16/ML_int[1][6] S=shf1[0] A=term1_in[6]
+ B=term1_in[5]
Xsll_16/M1_0_7 MUX2 $PINS O=sll_16/ML_int[1][7] S=shf1[0] A=term1_in[7]
+ B=term1_in[6]
Xsll_16/M1_1_4 MUX2 $PINS O=sll_16/ML_int[2][4] S=shf1[1] A=sll_16/ML_int[1][4]
+ B=sll_16/ML_int[1][2]
Xsll_16/M1_1_7 MUX2 $PINS O=sll_16/ML_int[2][7] S=shf1[1] A=sll_16/ML_int[1][7]
+ B=sll_16/ML_int[1][5]
Xsll_16/M1_1_8 MUX2 $PINS O=sll_16/ML_int[2][8] S=shf1[1] A=sll_16/ML_int[1][8]
+ B=sll_16/ML_int[1][6]
Xsll_16/M1_2_6 MUX2 $PINS O=sll_16/ML_int[3][6] S=shf1[2] A=sll_16/ML_int[2][6]
+ B=sll_16/ML_int[2][2]
Xsll_16/M1_2_7 MUX2 $PINS O=sll_16/ML_int[3][7] S=shf1[2] A=sll_16/ML_int[2][7]
+ B=sll_16/ML_int[2][3]
Xsll_16/M1_2_8 MUX2 $PINS O=sll_16/ML_int[3][8] S=shf1[2] A=sll_16/ML_int[2][8]
+ B=sll_16/ML_int[2][4]
Xsll_16/M1_2_9 MUX2 $PINS O=sll_16/ML_int[3][9] S=shf1[2] A=sll_16/ML_int[2][9]
+ B=sll_16/ML_int[2][5]
Xsll_16/M1_2_10 MUX2 $PINS O=sll_16/ML_int[3][10] S=shf1[2]
+ A=sll_16/ML_int[2][10] B=sll_16/ML_int[2][6]
Xsll_16/M1_3_8 MUX2 $PINS O=term1_shifted[8] S=shf1[3] A=sll_16/ML_int[3][8]
+ B=sll_16/ML_int[3][0]
Xsll_16/M1_3_9 MUX2 $PINS O=term1_shifted[9] S=shf1[3] A=sll_16/ML_int[3][9]
+ B=sll_16/ML_int[3][1]
Xsll_16/M1_3_10 MUX2 $PINS O=term1_shifted[10] S=shf1[3] A=sll_16/ML_int[3][10]
+ B=sll_16/ML_int[3][2]
Xsll_16/M1_3_11 MUX2 $PINS O=term1_shifted[11] S=shf1[3] A=sll_16/ML_int[3][11]
+ B=sll_16/ML_int[3][3]
Xsll_16/M1_3_12 MUX2 $PINS O=term1_shifted[12] S=shf1[3] A=sll_16/ML_int[3][12]
+ B=sll_16/ML_int[3][4]
Xsll_16/M1_3_13 MUX2 $PINS O=term1_shifted[13] S=shf1[3] A=sll_16/ML_int[3][13]
+ B=sll_16/ML_int[3][5]
Xsll_16/M1_3_14 MUX2 $PINS O=term1_shifted[14] S=shf1[3] A=sll_16/ML_int[3][14]
+ B=sll_16/ML_int[3][6]
Xsll_16/M1_3_22 MUX2 $PINS O=term1_shifted[22] S=FE_OFN199_h11_3
+ A=sll_16/ML_int[3][22] B=sll_16/ML_int[3][14]
Xsll_16/M1_3_23 MUX2 $PINS O=term1_shifted[23] S=FE_OFN199_h11_3 A=term1_in[26]
+ B=sll_16/ML_int[3][15]
Xy_out_reg[9] QDFFRBN $PINS Q=FE_PHN1157_pe_r1_9 D=FE_PHN969_N244 CK=CTS_10
+ RB=FE_OFN36_n
Xy_out_reg[8] QDFFRBN $PINS Q=FE_PHN1192_pe_r1_8 D=FE_PHN1026_N243 CK=CTS_10
+ RB=FE_OFN36_n
Xy_out_reg[7] QDFFRBN $PINS Q=y_out[7] D=FE_PHN941_N242 CK=CTS_10 RB=FE_OFN36_n
Xy_out_reg[6] QDFFRBN $PINS Q=FE_PHN1190_pe_r1_6 D=FE_PHN946_N241 CK=CTS_10
+ RB=FE_OFN36_n
Xy_out_reg[5] QDFFRBN $PINS Q=FE_PHN1195_pe_r1_5 D=FE_PHN949_N240 CK=CTS_10
+ RB=FE_OFN36_n
Xy_out_reg[4] QDFFRBN $PINS Q=y_out[4] D=FE_PHN1276_N239 CK=CTS_10
+ RB=FE_OFN36_n
Xy_out_reg[3] QDFFRBN $PINS Q=FE_PHN1188_pe_r1_3 D=N238 CK=CTS_10 RB=FE_OFN36_n
Xy_out_reg[2] QDFFRBN $PINS Q=y_out[2] D=FE_PHN1046_N237 CK=CTS_10
+ RB=FE_OFN16_i_rst_n
Xy_out_reg[1] QDFFRBN $PINS Q=FE_PHN1193_pe_r1_1 D=N236 CK=CTS_10 RB=FE_OFN36_n
Xy_out_reg[0] QDFFRBN $PINS Q=y_out[0] D=FE_PHN1295_N235 CK=CTS_10
+ RB=FE_OFN36_n
Xacc_reg_reg[25] QDFFRBN $PINS Q=acc_reg[25] D=next_acc[25] CK=clk_clone2
+ RB=FE_OFN10_i_rst_n
Xacc_reg_reg[24] QDFFRBN $PINS Q=acc_reg[24] D=next_acc[24] CK=clk_clone2
+ RB=FE_OFN36_n
Xy_out_reg[16] QDFFRBN $PINS Q=y_out[16] D=FE_PHN937_N251 CK=CTS_10
+ RB=FE_OFN36_n
Xy_out_reg[11] QDFFRBN $PINS Q=FE_PHN1251_pe_r1_11 D=FE_PHN990_N246 CK=CTS_10
+ RB=FE_OFN36_n
Xy_out_reg[12] QDFFRBN $PINS Q=FE_PHN1253_pe_r1_12 D=FE_PHN1319_N247 CK=CTS_10
+ RB=FE_OFN36_n
Xy_out_reg[10] QDFFRBN $PINS Q=y_out[10] D=FE_PHN987_N245 CK=CTS_10
+ RB=FE_OFN36_n
Xacc_reg_reg[23] QDFFRBN $PINS Q=acc_reg[23] D=next_acc[23] CK=clk_clone2
+ RB=FE_OFN36_n
Xy_out_reg[14] QDFFRBN $PINS Q=y_out[14] D=FE_PHN1337_N249 CK=CTS_10
+ RB=FE_OFN36_n
Xy_out_reg[15] QDFFRBN $PINS Q=FE_PHN1252_pe_r1_15 D=FE_PHN1330_N250 CK=CTS_10
+ RB=FE_OFN36_n
Xy_out_reg[13] QDFFRBN $PINS Q=y_out[13] D=FE_PHN1332_N248 CK=CTS_10
+ RB=FE_OFN36_n
Xacc_reg_reg[22] QDFFRBN $PINS Q=acc_reg[22] D=next_acc[22] CK=clk_clone2
+ RB=FE_OFN36_n
Xacc_reg_reg[21] QDFFRBN $PINS Q=acc_reg[21] D=next_acc[21] CK=clk_clone2
+ RB=FE_OFN36_n
Xacc_reg_reg[20] QDFFRBN $PINS Q=acc_reg[20] D=next_acc[20] CK=clk_clone2
+ RB=FE_OFN36_n
Xacc_reg_reg[19] QDFFRBN $PINS Q=acc_reg[19] D=next_acc[19] CK=clk_clone2
+ RB=i_rst_n
Xacc_reg_reg[18] QDFFRBN $PINS Q=acc_reg[18] D=next_acc[18] CK=clk RB=i_rst_n
Xacc_reg_reg[17] QDFFRBN $PINS Q=acc_reg[17] D=next_acc[17] CK=clk RB=i_rst_n
Xacc_reg_reg[16] QDFFRBN $PINS Q=acc_reg[16] D=next_acc[16] CK=clk RB=i_rst_n
Xacc_reg_reg[15] QDFFRBN $PINS Q=acc_reg[15] D=next_acc[15] CK=clk RB=i_rst_n
Xacc_reg_reg[14] QDFFRBN $PINS Q=acc_reg[14] D=next_acc[14] CK=clk RB=i_rst_n
Xacc_reg_reg[13] QDFFRBN $PINS Q=acc_reg[13] D=next_acc[13] CK=clk
+ RB=FE_OFN28_i_rst_n
Xacc_reg_reg[12] QDFFRBN $PINS Q=FE_PHN1533_acc_reg_12 D=next_acc[12] CK=clk
+ RB=FE_OFN28_i_rst_n
Xacc_reg_reg[11] QDFFRBN $PINS Q=acc_reg[11] D=next_acc[11] CK=clk
+ RB=FE_OFN28_i_rst_n
Xacc_reg_reg[10] QDFFRBN $PINS Q=acc_reg[10] D=next_acc[10] CK=clk
+ RB=FE_OFN28_i_rst_n
Xacc_reg_reg[9] QDFFRBN $PINS Q=acc_reg[9] D=next_acc[9] CK=clk
+ RB=FE_OFN10_i_rst_n
Xacc_reg_reg[8] QDFFRBN $PINS Q=acc_reg[8] D=next_acc[8] CK=clk
+ RB=FE_OFN10_i_rst_n
Xacc_reg_reg[7] QDFFRBN $PINS Q=acc_reg[7] D=next_acc[7] CK=clk
+ RB=FE_OFN10_i_rst_n
Xacc_reg_reg[6] QDFFRBN $PINS Q=acc_reg[6] D=next_acc[6] CK=clk
+ RB=FE_OFN10_i_rst_n
Xacc_reg_reg[5] QDFFRBN $PINS Q=acc_reg[5] D=next_acc[5] CK=clk
+ RB=FE_OFN10_i_rst_n
Xacc_reg_reg[4] QDFFRBN $PINS Q=acc_reg[4] D=next_acc[4] CK=clk
+ RB=FE_OFN10_i_rst_n
Xacc_reg_reg[3] QDFFRBN $PINS Q=acc_reg[3] D=next_acc[3] CK=clk
+ RB=FE_OFN10_i_rst_n
Xacc_reg_reg[2] QDFFRBN $PINS Q=acc_reg[2] D=next_acc[2] CK=clk
+ RB=FE_OFN10_i_rst_n
Xacc_reg_reg[0] QDFFRBN $PINS Q=acc_reg[0] D=FE_PHN1057_next_acc_0 CK=clk
+ RB=FE_OFN10_i_rst_n
Xacc_reg_reg[1] QDFFRBN $PINS Q=acc_reg[1] D=next_acc[1] CK=clk
+ RB=FE_OFN10_i_rst_n
Xacc_reg_reg[26] QDFFRBS $PINS Q=N251 D=next_acc[26] CK=clk_clone2
+ RB=FE_OFN10_i_rst_n
XU7 NR2 $PINS O=term2_in[2] I1=sign2[1] I2=x_in[2]
XU8 NR2T $PINS O=term2_shifted[2] I1=n58 I2=n59
XU9 NR2P $PINS O=term1_shifted[2] I1=n49 I2=n51
XU11 AN2 $PINS O=sll_17/ML_int[3][3] I1=n29 I2=sll_17/ML_int[2][3]
XU12 MUX2 $PINS O=N248 S=FE_OFN56_FE_DBTN10_n289 A=acc_reg[23] B=FE_PHN937_N251
XU13 OR2P $PINS O=n49 I1=shf1[2] I2=shf1[3]
XU15 MUX2 $PINS O=N250 S=stage_sel A=acc_reg[25] B=FE_PHN937_N251
XU16 OR2T $PINS O=n67 I1=shf3[2] I2=shf3[3]
XU17 AN2 $PINS O=sll_17/ML_int[3][0] I1=n29 I2=n3
XU18 MUX2 $PINS O=N249 S=FE_OFN56_FE_DBTN10_n289 A=acc_reg[24] B=FE_PHN937_N251
XU20 MUX2 $PINS O=N247 S=FE_OFN56_FE_DBTN10_n289 A=acc_reg[22] B=FE_PHN937_N251
XU23 AO22 $PINS O=N99 A1=N72 A2=sign2[0] B1=term2_shifted[3] B2=FE_DBTN26_s12_0
XU27 MUX2 $PINS O=sll_16/ML_int[2][3] S=shf1[1] A=sll_16/ML_int[1][3] B=n9
XU28 MUX2 $PINS O=sll_16/ML_int[2][5] S=shf1[1] A=sll_16/ML_int[1][5]
+ B=sll_16/ML_int[1][3]
XU29 MUX2S $PINS O=sll_16/ML_int[2][6] S=shf1[1] A=sll_16/ML_int[1][6]
+ B=sll_16/ML_int[1][4]
XU31 MOAI1 $PINS O=N41 A1=N14 A2=FE_DBTN27_s11_0 B1=term1_shifted[0]
+ B2=FE_DBTN27_s11_0
XU33 AO22 $PINS O=N63 A1=N36 A2=FE_OFN137_s11_0 B1=term1_shifted[22]
+ B2=FE_OFN342_FE_DBTN27_s11_0
XU34 NR2 $PINS O=term2_in[3] I1=sign2[1] I2=FE_OFN327_mac_in_real_3
XU35 NR2 $PINS O=term2_in[4] I1=sign2[1] I2=FE_OFN132_mac_in_real_4
XU38 NR2P $PINS O=term1_in[0] I1=sign1[1] I2=x_in[0]
XU47 AO22 $PINS O=N153 A1=N126 A2=sign3[0] B1=term3_shifted[2] B2=n22
XU49 ND2 $PINS O=n66 I1=sll_18/ML_int[1][1] I2=FE_OFN228_h13_1
XU50 ND2 $PINS O=n57 I1=sll_17/ML_int[1][1] I2=n27
XU52 OR2 $PINS O=n2 I1=n58 I2=shf2[1]
XU56 AO22 $PINS O=N51 A1=N24 A2=FE_OFN137_s11_0 B1=term1_shifted[10]
+ B2=FE_DBTN27_s11_0
XU57 NR2 $PINS O=term3_in[0] I1=sign3[1] I2=x_in[0]
XU60 AN2 $PINS O=term1_shifted[5] I1=sll_16/ML_int[3][5] I2=n39
XU62 AN2T $PINS O=term1_shifted[1] I1=n9 I2=n6
XU63 INV1S $PINS O=n6 I=n8
XU64 AN2 $PINS O=base_val[11] I1=acc_reg[11] I2=FE_OFN320_n
XU65 AO22 $PINS O=N50 A1=N23 A2=FE_OFN137_s11_0 B1=term1_shifted[9]
+ B2=FE_DBTN27_s11_0
XU66 AO22 $PINS O=N64 A1=N37 A2=FE_OFN137_s11_0 B1=term1_shifted[23]
+ B2=FE_OFN342_FE_DBTN27_s11_0
XU67 AO22 $PINS O=N174 A1=N147 A2=FE_OFN163_s13_0 B1=term3_shifted[23] B2=n22
XU69 AO22 $PINS O=N122 A1=N95 A2=FE_OFN178_s12_0 B1=term2_shifted[26]
+ B2=FE_DBTN26_s12_0
XU70 AO22S $PINS O=N121 A1=N94 A2=FE_OFN178_s12_0 B1=term2_shifted[25]
+ B2=FE_DBTN26_s12_0
XU71 AO22S $PINS O=N120 A1=N93 A2=FE_OFN178_s12_0 B1=term2_shifted[24]
+ B2=FE_DBTN26_s12_0
XU72 AO22S $PINS O=N118 A1=N91 A2=FE_OFN178_s12_0 B1=term2_shifted[22]
+ B2=FE_DBTN26_s12_0
XU73 AO22S $PINS O=N117 A1=N90 A2=FE_OFN178_s12_0 B1=term2_shifted[21]
+ B2=FE_DBTN26_s12_0
XU74 AO22S $PINS O=N116 A1=N89 A2=FE_OFN178_s12_0 B1=term2_shifted[20]
+ B2=FE_DBTN26_s12_0
XU75 AO22S $PINS O=N115 A1=N88 A2=FE_OFN178_s12_0 B1=term2_shifted[19]
+ B2=FE_DBTN26_s12_0
XU76 AO22 $PINS O=N114 A1=N87 A2=FE_OFN178_s12_0 B1=term2_shifted[18]
+ B2=FE_DBTN26_s12_0
XU77 AO22 $PINS O=N113 A1=N86 A2=FE_OFN178_s12_0 B1=term2_shifted[17]
+ B2=FE_DBTN26_s12_0
XU82 MUX2 $PINS O=sll_17/ML_int[2][3] S=shf2[1] A=sll_17/ML_int[1][3]
+ B=sll_17/ML_int[1][1]
XU83 AO22 $PINS O=N107 A1=N80 A2=FE_OFN178_s12_0 B1=term2_shifted[11]
+ B2=FE_DBTN26_s12_0
XU84 MOAI1 $PINS O=N97 A1=n4 A2=FE_DBTN26_s12_0 B1=term2_shifted[1]
+ B2=FE_DBTN26_s12_0
XU86 AO22S $PINS O=N177 A1=FE_OFN163_s13_0 A2=N150 B1=term3_shifted[26] B2=n22
XU88 AO22 $PINS O=N100 A1=N73 A2=sign2[0] B1=term2_shifted[4]
+ B2=FE_DBTN26_s12_0
XU89 NR2 $PINS O=n3 I1=n1 I2=shf2[1]
XU90 AO22S $PINS O=N119 A1=N92 A2=FE_OFN178_s12_0 B1=term2_shifted[23]
+ B2=FE_DBTN26_s12_0
XU91 AO22 $PINS O=N52 A1=N25 A2=FE_OFN137_s11_0 B1=term1_shifted[11]
+ B2=FE_DBTN27_s11_0
XU94 INV1S $PINS O=n7 I=n49
XU95 OR2B1S $PINS O=n8 I1=shf1[1] B1=n7
XU98 MUX2 $PINS O=sll_17/ML_int[1][1] S=shf2[0] A=term2_in[1] B=term2_in[0]
XU100 ND2S $PINS O=n48 I1=n9 I2=n37
XU101 NR2 $PINS O=term1_in[4] I1=sign1[1] I2=FE_OFN132_mac_in_real_4
XU102 AN2 $PINS O=base_val[4] I1=acc_reg[4] I2=FE_OFN320_n
XU103 AN2 $PINS O=base_val[5] I1=acc_reg[5] I2=FE_OFN320_n
XU104 AN2 $PINS O=base_val[6] I1=acc_reg[6] I2=FE_OFN320_n
XU105 AN2 $PINS O=base_val[0] I1=acc_reg[0] I2=FE_OFN320_n
XU106 MUX2S $PINS O=N235 S=FE_OFN56_FE_DBTN10_n289 A=acc_reg[10]
+ B=FE_PHN814_acc_reg_14
XU107 MUX2S $PINS O=FE_PHN962_N236 S=FE_OFN56_FE_DBTN10_n289 A=acc_reg[11]
+ B=acc_reg[15]
XU108 MUX2S $PINS O=N237 S=FE_OFN56_FE_DBTN10_n289 A=acc_reg[12] B=acc_reg[16]
XU109 MUX2S $PINS O=FE_PHN952_N238 S=FE_OFN56_FE_DBTN10_n289 A=acc_reg[13]
+ B=acc_reg[17]
XU111 MUX2S $PINS O=N239 S=FE_OFN56_FE_DBTN10_n289 A=FE_PHN814_acc_reg_14
+ B=acc_reg[18]
XU113 MUX2S $PINS O=N240 S=FE_OFN56_FE_DBTN10_n289 A=acc_reg[15] B=acc_reg[19]
XU114 MUX2S $PINS O=N242 S=FE_OFN56_FE_DBTN10_n289 A=acc_reg[17] B=acc_reg[21]
XU116 MUX2S $PINS O=N245 S=FE_OFN56_FE_DBTN10_n289 A=acc_reg[20] B=acc_reg[24]
XU117 MUX2S $PINS O=N246 S=stage_sel A=acc_reg[21] B=acc_reg[25]
XU118 MUX2S $PINS O=sll_18/ML_int[1][7] S=shf3[0] A=term3_in[7] B=term3_in[6]
XU119 MUX2S $PINS O=sll_17/ML_int[1][7] S=FE_OFN230_h12_0 A=term2_in[7]
+ B=term2_in[6]
XU120 MUX2S $PINS O=sll_16/ML_int[1][8] S=FE_OFN301_h11_0 A=term1_in[8]
+ B=term1_in[7]
XU121 MUX2S $PINS O=sll_18/ML_int[2][8] S=shf3[1] A=sll_18/ML_int[1][8]
+ B=sll_18/ML_int[1][6]
XU122 MUX2S $PINS O=sll_18/ML_int[1][8] S=shf3[0] A=term3_in[8] B=term3_in[7]
XU123 MUX2S $PINS O=sll_17/ML_int[2][8] S=FE_OFN232_h12_1 A=sll_17/ML_int[1][8]
+ B=sll_17/ML_int[1][6]
XU124 MUX2S $PINS O=sll_17/ML_int[1][8] S=FE_OFN230_h12_0 A=term2_in[8]
+ B=term2_in[7]
XU125 MUX2S $PINS O=sll_16/ML_int[2][9] S=shf1[1] A=sll_16/ML_int[1][9]
+ B=sll_16/ML_int[1][7]
XU126 MUX2S $PINS O=sll_16/ML_int[1][9] S=FE_OFN301_h11_0 A=term1_in[9]
+ B=term1_in[8]
XU127 MUX2S $PINS O=sll_18/ML_int[2][9] S=shf3[1] A=sll_18/ML_int[1][9]
+ B=sll_18/ML_int[1][7]
XU128 MUX2S $PINS O=sll_18/ML_int[1][9] S=shf3[0] A=term3_in[9] B=term3_in[8]
XU129 MUX2S $PINS O=sll_17/ML_int[2][9] S=FE_OFN232_h12_1 A=sll_17/ML_int[1][9]
+ B=sll_17/ML_int[1][7]
XU130 MUX2S $PINS O=sll_17/ML_int[1][9] S=FE_OFN230_h12_0 A=term2_in[9]
+ B=term2_in[8]
XU131 MUX2S $PINS O=sll_16/ML_int[2][10] S=shf1[1] A=sll_16/ML_int[1][10]
+ B=sll_16/ML_int[1][8]
XU132 MUX2 $PINS O=sll_16/ML_int[1][10] S=FE_OFN301_h11_0 A=term1_in[10]
+ B=term1_in[9]
XU136 MUX2S $PINS O=sll_18/ML_int[3][10] S=shf3[2] A=sll_18/ML_int[2][10]
+ B=sll_18/ML_int[2][6]
XU139 MUX2S $PINS O=sll_18/ML_int[2][10] S=shf3[1] A=sll_18/ML_int[1][10]
+ B=sll_18/ML_int[1][8]
XU140 MUX2S $PINS O=sll_18/ML_int[1][10] S=shf3[0] A=term3_in[10] B=term3_in[9]
XU141 MUX2S $PINS O=sll_17/ML_int[3][10] S=shf2[2] A=sll_17/ML_int[2][10]
+ B=sll_17/ML_int[2][6]
XU142 MUX2S $PINS O=sll_17/ML_int[2][10] S=FE_OFN232_h12_1
+ A=sll_17/ML_int[1][10] B=sll_17/ML_int[1][8]
XU145 MUX2S $PINS O=sll_17/ML_int[1][10] S=FE_OFN230_h12_0 A=term2_in[10]
+ B=term2_in[9]
XU166 MUX2S $PINS O=sll_16/ML_int[3][11] S=shf1[2] A=sll_16/ML_int[2][11]
+ B=sll_16/ML_int[2][7]
XU167 MUX2S $PINS O=sll_16/ML_int[2][11] S=shf1[1] A=sll_16/ML_int[1][11]
+ B=sll_16/ML_int[1][9]
XU169 MUX2S $PINS O=sll_18/ML_int[3][11] S=shf3[2] A=sll_18/ML_int[2][11]
+ B=sll_18/ML_int[2][7]
XU170 MUX2S $PINS O=sll_18/ML_int[2][11] S=shf3[1] A=sll_18/ML_int[1][11]
+ B=sll_18/ML_int[1][9]
XU171 MUX2S $PINS O=sll_17/ML_int[3][11] S=shf2[2] A=sll_17/ML_int[2][11]
+ B=sll_17/ML_int[2][7]
XU172 MUX2S $PINS O=sll_17/ML_int[2][11] S=FE_OFN232_h12_1
+ A=sll_17/ML_int[1][11] B=sll_17/ML_int[1][9]
XU173 MUX2S $PINS O=sll_16/ML_int[1][11] S=FE_OFN301_h11_0 A=term1_in[11]
+ B=term1_in[10]
XU174 MUX2S $PINS O=sll_18/ML_int[1][11] S=shf3[0] A=term3_in[11]
+ B=term3_in[10]
XU175 MUX2S $PINS O=sll_17/ML_int[1][11] S=FE_OFN230_h12_0 A=term2_in[11]
+ B=term2_in[10]
XU176 MUX2S $PINS O=sll_16/ML_int[3][12] S=shf1[2] A=sll_16/ML_int[2][12]
+ B=sll_16/ML_int[2][8]
XU177 MUX2S $PINS O=sll_16/ML_int[2][12] S=shf1[1] A=sll_16/ML_int[1][12]
+ B=sll_16/ML_int[1][10]
XU178 MUX2S $PINS O=sll_18/ML_int[3][12] S=shf3[2] A=sll_18/ML_int[2][12]
+ B=sll_18/ML_int[2][8]
XU182 MUX2S $PINS O=sll_18/ML_int[2][12] S=shf3[1] A=sll_18/ML_int[1][12]
+ B=sll_18/ML_int[1][10]
XU184 MUX2S $PINS O=sll_17/ML_int[3][12] S=shf2[2] A=sll_17/ML_int[2][12]
+ B=sll_17/ML_int[2][8]
XU191 MUX2S $PINS O=sll_17/ML_int[2][12] S=FE_OFN232_h12_1
+ A=sll_17/ML_int[1][12] B=sll_17/ML_int[1][10]
XU192 MUX2S $PINS O=sll_16/ML_int[1][12] S=FE_OFN301_h11_0 A=term1_in[12]
+ B=term1_in[11]
XU193 MUX2S $PINS O=sll_18/ML_int[1][12] S=shf3[0] A=term3_in[12]
+ B=term3_in[11]
XU194 MUX2S $PINS O=sll_17/ML_int[1][12] S=FE_OFN230_h12_0 A=term2_in[12]
+ B=term2_in[11]
XU195 MUX2S $PINS O=sll_16/ML_int[3][13] S=shf1[2] A=sll_16/ML_int[2][13]
+ B=sll_16/ML_int[2][9]
XU196 MUX2S $PINS O=sll_18/ML_int[3][13] S=shf3[2] A=sll_18/ML_int[2][13]
+ B=sll_18/ML_int[2][9]
XU197 MUX2S $PINS O=sll_17/ML_int[3][13] S=shf2[2] A=sll_17/ML_int[2][13]
+ B=sll_17/ML_int[2][9]
XU198 MUX2S $PINS O=sll_16/ML_int[2][13] S=FE_OFN206_h11_1
+ A=sll_16/ML_int[1][13] B=sll_16/ML_int[1][11]
XU199 MUX2S $PINS O=sll_16/ML_int[1][13] S=FE_OFN301_h11_0 A=term1_in[13]
+ B=term1_in[12]
XU200 MUX2S $PINS O=sll_18/ML_int[2][13] S=shf3[1] A=sll_18/ML_int[1][13]
+ B=sll_18/ML_int[1][11]
XU201 MUX2S $PINS O=sll_18/ML_int[1][13] S=shf3[0] A=term3_in[13]
+ B=term3_in[12]
XU202 MUX2S $PINS O=sll_17/ML_int[2][13] S=FE_OFN232_h12_1
+ A=sll_17/ML_int[1][13] B=sll_17/ML_int[1][11]
XU203 MUX2S $PINS O=sll_17/ML_int[1][13] S=FE_OFN230_h12_0 A=term2_in[13]
+ B=term2_in[12]
XU204 MUX2S $PINS O=sll_16/ML_int[3][14] S=shf1[2] A=sll_16/ML_int[2][14]
+ B=sll_16/ML_int[2][10]
XU205 MUX2S $PINS O=term3_shifted[14] S=shf3[3] A=sll_18/ML_int[3][14]
+ B=sll_18/ML_int[3][6]
XU206 MUX2S $PINS O=sll_18/ML_int[3][14] S=shf3[2] A=sll_18/ML_int[2][14]
+ B=sll_18/ML_int[2][10]
XU207 MUX2S $PINS O=sll_16/ML_int[2][14] S=FE_OFN206_h11_1
+ A=sll_16/ML_int[1][14] B=sll_16/ML_int[1][12]
XU208 MUX2S $PINS O=sll_16/ML_int[1][14] S=FE_OFN301_h11_0 A=term1_in[14]
+ B=term1_in[13]
XU209 MUX2S $PINS O=term2_shifted[14] S=FE_OFN189_h12_3 A=sll_17/ML_int[3][14]
+ B=sll_17/ML_int[3][6]
XU210 MUX2S $PINS O=sll_17/ML_int[3][14] S=shf2[2] A=sll_17/ML_int[2][14]
+ B=sll_17/ML_int[2][10]
XU211 MUX2S $PINS O=sll_18/ML_int[2][14] S=n16 A=sll_18/ML_int[1][14]
+ B=sll_18/ML_int[1][12]
XU212 MUX2S $PINS O=sll_18/ML_int[1][14] S=shf3[0] A=term3_in[14]
+ B=term3_in[13]
XU213 MUX2S $PINS O=sll_17/ML_int[2][14] S=FE_OFN232_h12_1
+ A=sll_17/ML_int[1][14] B=sll_17/ML_int[1][12]
XU214 MUX2S $PINS O=sll_17/ML_int[1][14] S=FE_OFN230_h12_0 A=term2_in[14]
+ B=term2_in[13]
XU215 MUX2S $PINS O=term1_shifted[16] S=FE_OFN199_h11_3 A=sll_16/ML_int[3][16]
+ B=sll_16/ML_int[3][8]
XU216 MUX2S $PINS O=sll_16/ML_int[3][16] S=shf1[2] A=n53 B=sll_16/ML_int[2][12]
XU217 MUX2S $PINS O=term1_shifted[15] S=shf1[3] A=sll_16/ML_int[3][15]
+ B=sll_16/ML_int[3][7]
XU218 MUX2S $PINS O=sll_16/ML_int[3][15] S=shf1[2] A=sll_16/ML_int[2][15]
+ B=sll_16/ML_int[2][11]
XU219 MUX2S $PINS O=term3_shifted[16] S=shf3[3] A=sll_18/ML_int[3][16]
+ B=sll_18/ML_int[3][8]
XU220 MUX2S $PINS O=sll_18/ML_int[3][16] S=shf3[2] A=n72 B=sll_18/ML_int[2][12]
XU221 MUX2S $PINS O=term2_shifted[16] S=FE_OFN189_h12_3 A=sll_17/ML_int[3][16]
+ B=sll_17/ML_int[3][8]
XU222 MUX2S $PINS O=sll_17/ML_int[3][16] S=shf2[2] A=n61 B=sll_17/ML_int[2][12]
XU223 MUX2S $PINS O=term3_shifted[15] S=shf3[3] A=sll_18/ML_int[3][15]
+ B=sll_18/ML_int[3][7]
XU224 MUX2S $PINS O=sll_16/ML_int[2][15] S=FE_OFN206_h11_1
+ A=sll_16/ML_int[1][15] B=sll_16/ML_int[1][13]
XU225 MUX2S $PINS O=sll_16/ML_int[1][15] S=FE_OFN301_h11_0 A=term1_in[15]
+ B=term1_in[14]
XU226 MUX2S $PINS O=sll_18/ML_int[3][15] S=shf3[2] A=sll_18/ML_int[2][15]
+ B=sll_18/ML_int[2][11]
XU227 MUX2S $PINS O=term2_shifted[15] S=FE_OFN189_h12_3 A=sll_17/ML_int[3][15]
+ B=sll_17/ML_int[3][7]
XU228 MUX2S $PINS O=sll_17/ML_int[3][15] S=shf2[2] A=sll_17/ML_int[2][15]
+ B=sll_17/ML_int[2][11]
XU229 MUX2S $PINS O=sll_18/ML_int[2][15] S=n16 A=sll_18/ML_int[1][15]
+ B=sll_18/ML_int[1][13]
XU230 MUX2S $PINS O=sll_18/ML_int[1][15] S=shf3[0] A=term3_in[15]
+ B=term3_in[14]
XU231 MUX2S $PINS O=sll_17/ML_int[2][15] S=FE_OFN232_h12_1
+ A=sll_17/ML_int[1][15] B=sll_17/ML_int[1][13]
XU232 MUX2S $PINS O=sll_17/ML_int[1][15] S=FE_OFN230_h12_0 A=term2_in[15]
+ B=term2_in[14]
XU233 MUX2S $PINS O=term1_shifted[17] S=FE_OFN199_h11_3 A=sll_16/ML_int[3][17]
+ B=sll_16/ML_int[3][9]
XU234 MUX2S $PINS O=sll_16/ML_int[3][17] S=shf1[2] A=n54 B=sll_16/ML_int[2][13]
XU235 MUX2S $PINS O=term3_shifted[17] S=shf3[3] A=sll_18/ML_int[3][17]
+ B=sll_18/ML_int[3][9]
XU236 MUX2S $PINS O=sll_18/ML_int[3][17] S=shf3[2] A=n73 B=sll_18/ML_int[2][13]
XU237 MUX2S $PINS O=term2_shifted[17] S=FE_OFN189_h12_3 A=sll_17/ML_int[3][17]
+ B=sll_17/ML_int[3][9]
XU238 MUX2S $PINS O=sll_17/ML_int[3][17] S=shf2[2] A=n62 B=sll_17/ML_int[2][13]
XU239 MUX2S $PINS O=term1_shifted[18] S=FE_OFN199_h11_3 A=sll_16/ML_int[3][18]
+ B=sll_16/ML_int[3][10]
XU240 MUX2S $PINS O=sll_16/ML_int[3][18] S=shf1[2] A=n55 B=sll_16/ML_int[2][14]
XU241 MUX2S $PINS O=term3_shifted[18] S=shf3[3] A=sll_18/ML_int[3][18]
+ B=sll_18/ML_int[3][10]
XU242 MUX2S $PINS O=sll_18/ML_int[3][18] S=shf3[2] A=n74 B=sll_18/ML_int[2][14]
XU243 MUX2S $PINS O=term2_shifted[18] S=FE_OFN189_h12_3 A=sll_17/ML_int[3][18]
+ B=sll_17/ML_int[3][10]
XU244 MUX2S $PINS O=sll_17/ML_int[3][18] S=shf2[2] A=n63 B=sll_17/ML_int[2][14]
XU245 MUX2S $PINS O=term1_shifted[20] S=FE_OFN199_h11_3 A=sll_16/ML_int[3][20]
+ B=sll_16/ML_int[3][12]
XU246 MUX2S $PINS O=sll_16/ML_int[3][20] S=shf1[2] A=term1_in[26] B=n53
XU247 MUX2S $PINS O=term1_shifted[19] S=FE_OFN199_h11_3 A=sll_16/ML_int[3][19]
+ B=sll_16/ML_int[3][11]
XU248 MUX2S $PINS O=sll_16/ML_int[3][19] S=shf1[2] A=term1_in[26]
+ B=sll_16/ML_int[2][15]
XU249 MUX2S $PINS O=term3_shifted[20] S=shf3[3] A=sll_18/ML_int[3][20]
+ B=sll_18/ML_int[3][12]
XU250 MUX2S $PINS O=sll_18/ML_int[3][20] S=shf3[2] A=term3_in[26] B=n72
XU251 MUX2S $PINS O=term3_shifted[19] S=shf3[3] A=sll_18/ML_int[3][19]
+ B=sll_18/ML_int[3][11]
XU252 MUX2S $PINS O=sll_18/ML_int[3][19] S=shf3[2] A=term3_in[26]
+ B=sll_18/ML_int[2][15]
XU253 MUX2S $PINS O=term2_shifted[20] S=FE_OFN189_h12_3 A=sll_17/ML_int[3][20]
+ B=sll_17/ML_int[3][12]
XU254 MUX2S $PINS O=sll_17/ML_int[3][20] S=shf2[2] A=term2_in[26] B=n61
XU255 MUX2S $PINS O=term2_shifted[19] S=FE_OFN189_h12_3 A=sll_17/ML_int[3][19]
+ B=sll_17/ML_int[3][11]
XU256 MUX2S $PINS O=sll_17/ML_int[3][19] S=shf2[2] A=term2_in[26]
+ B=sll_17/ML_int[2][15]
XU257 MUX2S $PINS O=term1_shifted[21] S=FE_OFN199_h11_3 A=sll_16/ML_int[3][21]
+ B=sll_16/ML_int[3][13]
XU258 MUX2S $PINS O=sll_16/ML_int[3][21] S=shf1[2] A=term1_in[26] B=n54
XU259 MUX2S $PINS O=term3_shifted[21] S=shf3[3] A=sll_18/ML_int[3][21]
+ B=sll_18/ML_int[3][13]
XU260 MUX2S $PINS O=sll_18/ML_int[3][21] S=shf3[2] A=term3_in[26] B=n73
XU261 MUX2S $PINS O=term2_shifted[21] S=FE_OFN189_h12_3 A=sll_17/ML_int[3][21]
+ B=sll_17/ML_int[3][13]
XU262 MUX2S $PINS O=sll_17/ML_int[3][21] S=shf2[2] A=term2_in[26] B=n62
XU263 MUX2S $PINS O=sll_16/ML_int[3][22] S=shf1[2] A=term1_in[26] B=n55
XU264 MUX2S $PINS O=sll_17/ML_int[3][22] S=shf2[2] A=term2_in[26] B=n63
XU265 MUX2S $PINS O=sll_18/ML_int[3][22] S=shf3[2] A=term3_in[26] B=n74
XU266 AO22 $PINS O=N53 A1=N26 A2=FE_OFN137_s11_0 B1=term1_shifted[12]
+ B2=FE_OFN342_FE_DBTN27_s11_0
XU267 AO22 $PINS O=N54 A1=N27 A2=FE_OFN137_s11_0 B1=term1_shifted[13]
+ B2=FE_OFN342_FE_DBTN27_s11_0
XU268 AO22 $PINS O=N55 A1=N28 A2=FE_OFN137_s11_0 B1=term1_shifted[14]
+ B2=FE_OFN342_FE_DBTN27_s11_0
XU269 AO22 $PINS O=N56 A1=N29 A2=FE_OFN137_s11_0 B1=term1_shifted[15]
+ B2=FE_OFN342_FE_DBTN27_s11_0
XU270 AO22 $PINS O=N57 A1=N30 A2=FE_OFN137_s11_0 B1=term1_shifted[16]
+ B2=FE_OFN342_FE_DBTN27_s11_0
XU271 AO22 $PINS O=N58 A1=N31 A2=FE_OFN137_s11_0 B1=term1_shifted[17]
+ B2=FE_OFN342_FE_DBTN27_s11_0
XU272 AO22 $PINS O=N59 A1=N32 A2=FE_OFN137_s11_0 B1=term1_shifted[18]
+ B2=FE_OFN342_FE_DBTN27_s11_0
XU273 AO22 $PINS O=N60 A1=N33 A2=FE_OFN137_s11_0 B1=term1_shifted[19]
+ B2=FE_OFN342_FE_DBTN27_s11_0
XU274 AO22 $PINS O=N61 A1=N34 A2=FE_OFN137_s11_0 B1=term1_shifted[20]
+ B2=FE_OFN342_FE_DBTN27_s11_0
XU275 AO22 $PINS O=N62 A1=N35 A2=FE_OFN137_s11_0 B1=term1_shifted[21]
+ B2=FE_OFN342_FE_DBTN27_s11_0
XU276 AO22S $PINS O=N65 A1=N38 A2=FE_OFN137_s11_0 B1=term1_shifted[24]
+ B2=FE_OFN342_FE_DBTN27_s11_0
XU277 AO22 $PINS O=N66 A1=N39 A2=FE_OFN137_s11_0 B1=term1_shifted[25]
+ B2=FE_OFN342_FE_DBTN27_s11_0
XU282 AO22S $PINS O=N109 A1=N82 A2=FE_OFN178_s12_0 B1=term2_shifted[13]
+ B2=FE_DBTN26_s12_0
XU286 INV1S $PINS O=n70 I=n65
XU287 INV1S $PINS O=n60 I=n57
XU288 NR2T $PINS O=term3_in[1] I1=sign3[1] I2=x_in[1]
XU289 NR2T $PINS O=term2_in[1] I1=sign2[1] I2=x_in[1]
XU290 NR2 $PINS O=term1_in[3] I1=sign1[1] I2=FE_OFN327_mac_in_real_3
XU291 NR2 $PINS O=term1_in[2] I1=sign1[1] I2=x_in[2]
XU292 NR2 $PINS O=term3_in[2] I1=sign3[1] I2=x_in[2]
XU294 NR2 $PINS O=term3_in[3] I1=sign3[1] I2=FE_OFN327_mac_in_real_3
XU295 NR2 $PINS O=term1_in[5] I1=sign1[1] I2=x_in[5]
XU296 NR2 $PINS O=term2_in[5] I1=sign2[1] I2=x_in[5]
XU297 NR2 $PINS O=term3_in[5] I1=sign3[1] I2=x_in[5]
XU298 NR2 $PINS O=term1_in[6] I1=sign1[1] I2=x_in[6]
XU299 NR2 $PINS O=term3_in[6] I1=sign3[1] I2=x_in[6]
XU300 NR2 $PINS O=term2_in[6] I1=sign2[1] I2=x_in[6]
XU301 NR2 $PINS O=term1_in[7] I1=sign1[1] I2=x_in[7]
XU302 NR2 $PINS O=term3_in[7] I1=sign3[1] I2=x_in[7]
XU303 NR2 $PINS O=term2_in[7] I1=sign2[1] I2=x_in[7]
XU304 NR2 $PINS O=term1_in[8] I1=sign1[1] I2=x_in[8]
XU305 NR2 $PINS O=term2_in[8] I1=sign2[1] I2=x_in[8]
XU306 NR2 $PINS O=term3_in[8] I1=sign3[1] I2=x_in[8]
XU307 NR2 $PINS O=term1_in[9] I1=sign1[1] I2=x_in[9]
XU309 NR2 $PINS O=term2_in[9] I1=sign2[1] I2=x_in[9]
XU310 NR2 $PINS O=term3_in[9] I1=sign3[1] I2=x_in[9]
XU312 NR2 $PINS O=term1_in[10] I1=sign1[1] I2=x_in[10]
XU313 NR2 $PINS O=term2_in[10] I1=sign2[1] I2=x_in[10]
XU314 NR2 $PINS O=term3_in[10] I1=sign3[1] I2=x_in[10]
XU315 NR2 $PINS O=term1_in[11] I1=sign1[1] I2=x_in[11]
XU316 NR2 $PINS O=term2_in[11] I1=sign2[1] I2=x_in[11]
XU317 NR2 $PINS O=term3_in[11] I1=sign3[1] I2=x_in[11]
XU318 NR2 $PINS O=term1_in[12] I1=sign1[1] I2=x_in[12]
XU319 NR2 $PINS O=term2_in[12] I1=sign2[1] I2=x_in[12]
XU320 NR2 $PINS O=term3_in[12] I1=sign3[1] I2=x_in[12]
XU321 NR2 $PINS O=term1_in[13] I1=sign1[1] I2=n79
XU322 NR2 $PINS O=term2_in[13] I1=sign2[1] I2=n79
XU323 NR2 $PINS O=term3_in[13] I1=sign3[1] I2=n79
XU325 NR2 $PINS O=term1_in[14] I1=sign1[1] I2=n80
XU328 NR2 $PINS O=term2_in[14] I1=sign2[1] I2=n80
XU329 NR2 $PINS O=term3_in[14] I1=sign3[1] I2=n80
XU330 NR2 $PINS O=term1_in[15] I1=sign1[1] I2=n81
XU331 NR2 $PINS O=term2_in[15] I1=sign2[1] I2=n81
XU332 NR2 $PINS O=term3_in[15] I1=sign3[1] I2=n81
XU333 NR2 $PINS O=term1_in[26] I1=n82 I2=sign1[1]
XU334 NR2 $PINS O=term2_in[26] I1=n82 I2=sign2[1]
XU335 NR2 $PINS O=term3_in[26] I1=n82 I2=sign3[1]
XU358 INV1S $PINS O=n79 I=x_in[13]
XU359 INV1S $PINS O=n80 I=x_in[14]
XU360 INV1S $PINS O=n81 I=x_in[15]
XU361 INV1S $PINS O=n82 I=x_in[16]
XU362 AN2 $PINS O=base_val[26] I1=N251 I2=FE_OFN75_n
XU363 MOAI1S $PINS O=base_val[9] A1=FE_OFN56_FE_DBTN10_n289 A2=FE_OFN320_n
+ B1=acc_reg[9] B2=FE_OFN320_n
XU364 AN2 $PINS O=base_val[10] I1=acc_reg[10] I2=FE_OFN320_n
XU367 AN2 $PINS O=base_val[15] I1=acc_reg[15] I2=FE_OFN320_n
XU369 AN2 $PINS O=base_val[17] I1=acc_reg[17] I2=FE_OFN320_n
XU370 AN2 $PINS O=base_val[18] I1=acc_reg[18] I2=FE_OFN320_n
XU371 AN2 $PINS O=base_val[19] I1=acc_reg[19] I2=FE_OFN320_n
XU372 AN2 $PINS O=base_val[20] I1=acc_reg[20] I2=FE_OFN320_n
XU373 AN2 $PINS O=base_val[21] I1=acc_reg[21] I2=FE_OFN320_n
XU374 AN2 $PINS O=base_val[22] I1=acc_reg[22] I2=FE_OFN71_n
XU375 AN2 $PINS O=base_val[23] I1=acc_reg[23] I2=FE_OFN71_n
XU376 AN2 $PINS O=base_val[24] I1=acc_reg[24] I2=FE_OFN71_n
XU377 AN2 $PINS O=base_val[25] I1=acc_reg[25] I2=FE_OFN71_n
XU378 AN2 $PINS O=base_val[8] I1=acc_reg[8] I2=FE_OFN320_n
XU379 AN2 $PINS O=base_val[7] I1=acc_reg[7] I2=FE_OFN320_n
XU380 AN2 $PINS O=base_val[3] I1=acc_reg[3] I2=FE_OFN320_n
XU381 AN2 $PINS O=base_val[2] I1=acc_reg[2] I2=FE_OFN320_n
XU382 AN2 $PINS O=base_val[1] I1=acc_reg[1] I2=FE_OFN320_n
XU384 AN2 $PINS O=N234 I1=en I2=calc_done
XU388 INV1S $PINS O=n71 I=n66
XU389 MUX2 $PINS O=sll_18/ML_int[2][3] S=shf3[1] A=sll_18/ML_int[1][3]
+ B=sll_18/ML_int[1][1]
XU390 MUX2 $PINS O=sll_18/ML_int[3][7] S=shf3[2] A=sll_18/ML_int[2][7]
+ B=sll_18/ML_int[2][3]
XU391 MUX2S $PINS O=sll_18/ML_int[3][6] S=shf3[2] A=sll_18/ML_int[2][6]
+ B=sll_18/ML_int[2][2]
XU392 NR2 $PINS O=sll_16/ML_int[3][0] I1=shf1[2] I2=n47
XU393 NR2 $PINS O=sll_16/ML_int[3][1] I1=shf1[2] I2=n48
XU394 NR2 $PINS O=sll_16/ML_int[3][2] I1=shf1[2] I2=n51
XU395 NR2 $PINS O=sll_16/ML_int[3][3] I1=shf1[2] I2=n50
XU396 NR2P $PINS O=term1_shifted[3] I1=n49 I2=n50
XU398 AN2 $PINS O=term1_shifted[6] I1=sll_16/ML_int[3][6] I2=n39
XU399 AN2S $PINS O=term1_shifted[7] I1=sll_16/ML_int[3][7] I2=n39
XU400 MUX2 $PINS O=term1_shifted[24] S=FE_OFN199_h11_3 A=term1_in[26]
+ B=sll_16/ML_int[3][16]
XU401 MUX2 $PINS O=n53 S=FE_OFN206_h11_1 A=n56 B=sll_16/ML_int[1][14]
XU402 MUX2 $PINS O=term1_shifted[25] S=FE_OFN199_h11_3 A=term1_in[26]
+ B=sll_16/ML_int[3][17]
XU403 MUX2 $PINS O=n54 S=FE_OFN206_h11_1 A=term1_in[26] B=sll_16/ML_int[1][15]
XU404 MUX2 $PINS O=term1_shifted[26] S=FE_OFN199_h11_3 A=term1_in[26]
+ B=sll_16/ML_int[3][18]
XU405 MUX2 $PINS O=n55 S=FE_OFN206_h11_1 A=term1_in[26] B=n56
XU406 MUX2 $PINS O=n56 S=FE_OFN301_h11_0 A=term1_in[26] B=term1_in[15]
XU407 NR2 $PINS O=sll_17/ML_int[3][1] I1=shf2[2] I2=n57
XU409 ND2P $PINS O=n58 I1=n29 I2=n31
XU410 AN2 $PINS O=term2_shifted[4] I1=sll_17/ML_int[3][4] I2=n31
XU411 AN2 $PINS O=term2_shifted[5] I1=sll_17/ML_int[3][5] I2=n31
XU412 AN2 $PINS O=term2_shifted[6] I1=sll_17/ML_int[3][6] I2=n31
XU413 AN2 $PINS O=term2_shifted[7] I1=sll_17/ML_int[3][7] I2=n31
XU414 MUX2 $PINS O=term2_shifted[24] S=FE_OFN189_h12_3 A=term2_in[26]
+ B=sll_17/ML_int[3][16]
XU415 MUX2 $PINS O=n61 S=FE_OFN232_h12_1 A=n64 B=sll_17/ML_int[1][14]
XU416 MUX2 $PINS O=term2_shifted[25] S=FE_OFN189_h12_3 A=term2_in[26]
+ B=sll_17/ML_int[3][17]
XU417 MUX2 $PINS O=n62 S=FE_OFN232_h12_1 A=term2_in[26] B=sll_17/ML_int[1][15]
XU418 MUX2 $PINS O=term2_shifted[26] S=FE_OFN189_h12_3 A=term2_in[26]
+ B=sll_17/ML_int[3][18]
XU419 MUX2 $PINS O=n63 S=FE_OFN232_h12_1 A=term2_in[26] B=n64
XU420 MUX2 $PINS O=n64 S=FE_OFN230_h12_0 A=term2_in[26] B=term2_in[15]
XU421 NR2 $PINS O=sll_18/ML_int[3][0] I1=shf3[2] I2=n65
XU422 NR2 $PINS O=sll_18/ML_int[3][1] I1=shf3[2] I2=n66
XU423 NR2 $PINS O=sll_18/ML_int[3][2] I1=shf3[2] I2=n69
XU424 NR2 $PINS O=sll_18/ML_int[3][3] I1=shf3[2] I2=n68
XU426 NR2 $PINS O=term3_shifted[3] I1=n67 I2=n68
XU427 AN2S $PINS O=term3_shifted[4] I1=sll_18/ML_int[3][4] I2=n18
XU428 AN2 $PINS O=term3_shifted[5] I1=sll_18/ML_int[3][5] I2=n18
XU429 AN2 $PINS O=term3_shifted[6] I1=sll_18/ML_int[3][6] I2=n18
XU430 AN2 $PINS O=term3_shifted[7] I1=sll_18/ML_int[3][7] I2=n18
XU431 MUX2 $PINS O=term3_shifted[24] S=shf3[3] A=term3_in[26]
+ B=sll_18/ML_int[3][16]
XU432 MUX2 $PINS O=n72 S=n16 A=n75 B=sll_18/ML_int[1][14]
XU433 MUX2 $PINS O=term3_shifted[25] S=shf3[3] A=term3_in[26]
+ B=sll_18/ML_int[3][17]
XU434 MUX2 $PINS O=n73 S=n16 A=term3_in[26] B=sll_18/ML_int[1][15]
XU435 MUX2 $PINS O=term3_shifted[26] S=shf3[3] A=term3_in[26]
+ B=sll_18/ML_int[3][18]
XU436 MUX2 $PINS O=n74 S=n16 A=term3_in[26] B=n75
XU437 MUX2 $PINS O=n75 S=shf3[0] A=term3_in[26] B=term3_in[15]
XU438 MUX2 $PINS O=N241 S=FE_OFN56_FE_DBTN10_n289 A=acc_reg[16] B=acc_reg[20]
XU439 MUX2 $PINS O=N243 S=FE_OFN56_FE_DBTN10_n289 A=acc_reg[18] B=acc_reg[22]
XU440 MUX2 $PINS O=N244 S=FE_OFN56_FE_DBTN10_n289 A=acc_reg[19] B=acc_reg[23]
Xsll_16/M1_0_3 MUX2S $PINS O=sll_16/ML_int[1][3] S=shf1[0] A=term1_in[3]
+ B=term1_in[2]
XU3 INV1S $PINS O=n69 I=sll_18/ML_int[2][2]
XU4 NR2P $PINS O=term1_shifted[0] I1=n49 I2=n47
XU6 INV2 $PINS O=n47 I=n10
XU22 INV2 $PINS O=n59 I=sll_17/ML_int[2][2]
XU25 INV1S $PINS O=n4 I=N70
XU32 NR2 $PINS O=term3_in[4] I1=sign3[1] I2=FE_OFN132_mac_in_real_4
XU37 AN2 $PINS O=sll_17/ML_int[1][0] I1=term2_in[0] I2=n26
XU39 AN2 $PINS O=base_val[12] I1=acc_reg[12] I2=FE_OFN320_n
XU41 AN2 $PINS O=base_val[14] I1=acc_reg[14] I2=FE_OFN320_n
XU42 NR2 $PINS O=sll_17/ML_int[3][2] I1=shf2[2] I2=n59
XU43 NR2 $PINS O=term1_in[1] I1=sign1[1] I2=x_in[1]
XU44 ND2 $PINS O=n1 I1=n26 I2=term2_in[0]
XU51 AN2 $PINS O=base_val[16] I1=acc_reg[16] I2=FE_OFN320_n
XU61 NR2P $PINS O=term3_shifted[0] I1=n67 I2=n65
XU92 NR2P $PINS O=term2_shifted[0] I1=n2 I2=n1
XU339 ND2P $PINS O=n65 I1=sll_18/ML_int[1][0] I2=FE_OFN228_h13_1
XU368 NR2T $PINS O=term2_in[0] I1=sign2[1] I2=x_in[0]
Xclk_gate_y_out_reg SNPS_CLOCK_GATE_HIGH_PE_Shift_Add_5 $PINS EN=N234
+ ENCLK=CTS_12 CLK=clk_clone1
Xsub_28_3 PE_Shift_Add_5_DW01_sub_0_DW01_sub_15 $PINS A[26]=net45565
+ A[25]=net45565 A[24]=net45565 A[23]=net45565 A[22]=net45565 A[21]=net45565
+ A[20]=net45565 A[19]=net45565 A[18]=net45565 A[17]=net45565 A[16]=net45565
+ A[15]=net45565 A[14]=net45565 A[13]=net45565 A[12]=net45565 A[11]=net45565
+ A[10]=net45565 A[9]=net45565 A[8]=net45565 A[7]=net45565 A[6]=net45565
+ A[5]=net45565 A[4]=net45565 A[3]=net45565 A[2]=net45565 A[1]=net45565
+ A[0]=net45565 B[26]=term3_shifted[26] B[25]=term3_shifted[25]
+ B[24]=term3_shifted[24] B[23]=term3_shifted[23] B[22]=term3_shifted[22]
+ B[21]=term3_shifted[21] B[20]=term3_shifted[20] B[19]=term3_shifted[19]
+ B[18]=term3_shifted[18] B[17]=term3_shifted[17] B[16]=term3_shifted[16]
+ B[15]=term3_shifted[15] B[14]=term3_shifted[14] B[13]=term3_shifted[13]
+ B[12]=term3_shifted[12] B[11]=term3_shifted[11] B[10]=term3_shifted[10]
+ B[9]=term3_shifted[9] B[8]=term3_shifted[8] B[7]=term3_shifted[7]
+ B[6]=term3_shifted[6] B[5]=term3_shifted[5] B[4]=term3_shifted[4]
+ B[3]=term3_shifted[3] B[2]=term3_shifted[2] B[1]=FE_DBTN18_term3_shifted_1
+ B[0]=term3_shifted[0] CI=net45565 DIFF[26]=N150 DIFF[25]=N149 DIFF[24]=N148
+ DIFF[23]=N147 DIFF[22]=N146 DIFF[21]=N145 DIFF[20]=N144 DIFF[19]=N143
+ DIFF[18]=N142 DIFF[17]=N141 DIFF[16]=N140 DIFF[15]=N139 DIFF[14]=N138
+ DIFF[13]=N137 DIFF[12]=N136 DIFF[11]=N135 DIFF[10]=N134 DIFF[9]=N133
+ DIFF[8]=N132 DIFF[7]=N131 DIFF[6]=N130 DIFF[5]=N129 DIFF[4]=N128 DIFF[3]=N127
+ DIFF[2]=N126 DIFF[1]=N125 DIFF[0]=N124 p1=term3_shifted[1]
Xsub_28_2 PE_Shift_Add_5_DW01_sub_1_DW01_sub_16 $PINS A[26]=net45565
+ A[25]=net45565 A[24]=net45565 A[23]=net45565 A[22]=net45565 A[21]=net45565
+ A[20]=net45565 A[19]=net45565 A[18]=net45565 A[17]=net45565 A[16]=net45565
+ A[15]=net45565 A[14]=net45565 A[13]=net45565 A[12]=net45565 A[11]=net45565
+ A[10]=net45565 A[9]=net45565 A[8]=net45565 A[7]=net45565 A[6]=net45565
+ A[5]=net45565 A[4]=net45565 A[3]=net45565 A[2]=net45565 A[1]=net45565
+ A[0]=net45565 B[26]=term2_shifted[26] B[25]=term2_shifted[25]
+ B[24]=term2_shifted[24] B[23]=term2_shifted[23] B[22]=term2_shifted[22]
+ B[21]=term2_shifted[21] B[20]=term2_shifted[20] B[19]=term2_shifted[19]
+ B[18]=term2_shifted[18] B[17]=term2_shifted[17] B[16]=term2_shifted[16]
+ B[15]=term2_shifted[15] B[14]=term2_shifted[14] B[13]=term2_shifted[13]
+ B[12]=term2_shifted[12] B[11]=term2_shifted[11] B[10]=term2_shifted[10]
+ B[9]=term2_shifted[9] B[8]=term2_shifted[8] B[7]=term2_shifted[7]
+ B[6]=term2_shifted[6] B[5]=term2_shifted[5] B[4]=term2_shifted[4]
+ B[3]=term2_shifted[3] B[2]=term2_shifted[2] B[1]=term2_shifted[1]
+ B[0]=term2_shifted[0] CI=net45565 DIFF[26]=N95 DIFF[25]=N94 DIFF[24]=N93
+ DIFF[23]=N92 DIFF[22]=N91 DIFF[21]=N90 DIFF[20]=N89 DIFF[19]=N88 DIFF[18]=N87
+ DIFF[17]=N86 DIFF[16]=N85 DIFF[15]=N84 DIFF[14]=N83 DIFF[13]=N82 DIFF[12]=N81
+ DIFF[11]=N80 DIFF[10]=N79 DIFF[9]=N78 DIFF[8]=N77 DIFF[7]=N76 DIFF[6]=N75
+ DIFF[5]=N74 DIFF[4]=N73 DIFF[3]=N72 DIFF[2]=N71 DIFF[1]=N70 DIFF[0]=N69
Xsub_28 PE_Shift_Add_5_DW01_sub_2_DW01_sub_17 $PINS A[26]=net45565
+ A[25]=net45565 A[24]=net45565 A[23]=net45565 A[22]=net45565 A[21]=net45565
+ A[20]=net45565 A[19]=net45565 A[18]=net45565 A[17]=net45565 A[16]=net45565
+ A[15]=net45565 A[14]=net45565 A[13]=net45565 A[12]=net45565 A[11]=net45565
+ A[10]=net45565 A[9]=net45565 A[8]=net45565 A[7]=net45565 A[6]=net45565
+ A[5]=net45565 A[4]=net45565 A[3]=net45565 A[2]=net45565 A[1]=net45565
+ A[0]=net45565 B[26]=term1_shifted[26] B[25]=term1_shifted[25]
+ B[24]=term1_shifted[24] B[23]=term1_shifted[23] B[22]=term1_shifted[22]
+ B[21]=term1_shifted[21] B[20]=term1_shifted[20] B[19]=term1_shifted[19]
+ B[18]=term1_shifted[18] B[17]=term1_shifted[17] B[16]=term1_shifted[16]
+ B[15]=term1_shifted[15] B[14]=term1_shifted[14] B[13]=term1_shifted[13]
+ B[12]=term1_shifted[12] B[11]=term1_shifted[11] B[10]=term1_shifted[10]
+ B[9]=term1_shifted[9] B[8]=term1_shifted[8] B[7]=term1_shifted[7]
+ B[6]=term1_shifted[6] B[5]=term1_shifted[5] B[4]=term1_shifted[4]
+ B[3]=term1_shifted[3] B[2]=term1_shifted[2] B[1]=term1_shifted[1]
+ B[0]=term1_shifted[0] CI=net45565 DIFF[26]=N40 DIFF[25]=N39 DIFF[24]=N38
+ DIFF[23]=N37 DIFF[22]=N36 DIFF[21]=N35 DIFF[20]=N34 DIFF[19]=N33 DIFF[18]=N32
+ DIFF[17]=N31 DIFF[16]=N30 DIFF[15]=N29 DIFF[14]=N28 DIFF[13]=N27 DIFF[12]=N26
+ DIFF[11]=N25 DIFF[10]=N24 DIFF[9]=N23 DIFF[8]=N22 DIFF[7]=N21 DIFF[6]=N20
+ DIFF[5]=N19 DIFF[4]=N18 DIFF[3]=N17 DIFF[2]=N16 DIFF[1]=N15 DIFF[0]=N14
Xadd_1_root_add_0_root_add_28_3 PE_Shift_Add_5_DW01_add_2_DW01_add_34 $PINS
+ A[26]=N67 A[25]=N66 A[24]=N65 A[23]=N64 A[22]=N63 A[21]=N62 A[20]=N61 A[19]=N60
+ A[18]=N59 A[17]=N58 A[16]=N57 A[15]=N56 A[14]=N55 A[13]=N54 A[12]=N53 A[11]=N52
+ A[10]=N51 A[9]=N50 A[8]=N49 A[7]=N48 A[6]=N47 A[5]=N46 A[4]=N45 A[3]=N44
+ A[2]=N43 A[1]=N42 A[0]=N41 B[26]=N177 B[25]=N176 B[24]=N175 B[23]=N174
+ B[22]=N173 B[21]=N172 B[20]=N171 B[19]=N170 B[18]=N169 B[17]=N168 B[16]=N167
+ B[15]=N166 B[14]=N165 B[13]=N164 B[12]=N163 B[11]=N162 B[10]=N161 B[9]=N160
+ B[8]=N159 B[7]=N158 B[6]=N157 B[5]=N156 B[4]=N155 B[3]=N154 B[2]=N153 B[1]=N152
+ B[0]=N151 CI=net45565 SUM[26]=N204 SUM[25]=N203 SUM[24]=N202 SUM[23]=N201
+ SUM[22]=N200 SUM[21]=N199 SUM[20]=N198 SUM[19]=N197 SUM[18]=N196 SUM[17]=N195
+ SUM[16]=N194 SUM[15]=N193 SUM[14]=N192 SUM[13]=N191 SUM[12]=N190 SUM[11]=N189
+ SUM[10]=N188 SUM[9]=N187 SUM[8]=N186 SUM[7]=N185 SUM[6]=N184 SUM[5]=N183
+ SUM[4]=N182 SUM[3]=N181 SUM[2]=N180 SUM[1]=N179 SUM[0]=N178
Xadd_2_root_add_0_root_add_28_3 PE_Shift_Add_5_DW01_add_1_DW01_add_33 $PINS
+ A[26]=base_val[26] A[25]=base_val[25] A[24]=base_val[24] A[23]=base_val[23]
+ A[22]=base_val[22] A[21]=base_val[21] A[20]=base_val[20] A[19]=base_val[19]
+ A[18]=base_val[18] A[17]=base_val[17] A[16]=base_val[16] A[15]=base_val[15]
+ A[14]=base_val[14] A[13]=base_val[13] A[12]=base_val[12] A[11]=base_val[11]
+ A[10]=base_val[10] A[9]=base_val[9] A[8]=base_val[8] A[7]=base_val[7]
+ A[6]=base_val[6] A[5]=base_val[5] A[4]=base_val[4] A[3]=base_val[3]
+ A[2]=base_val[2] A[1]=base_val[1] A[0]=base_val[0] B[26]=N122 B[25]=N121
+ B[24]=N120 B[23]=N119 B[22]=N118 B[21]=N117 B[20]=N116 B[19]=N115 B[18]=N114
+ B[17]=N113 B[16]=N112 B[15]=N111 B[14]=N110 B[13]=N109 B[12]=N108 B[11]=N107
+ B[10]=N106 B[9]=N105 B[8]=N104 B[7]=N103 B[6]=N102 B[5]=N101 B[4]=N100 B[3]=N99
+ B[2]=N98 B[1]=N97 B[0]=N96 CI=net45565 SUM[26]=N231 SUM[25]=N230 SUM[24]=N229
+ SUM[23]=N228 SUM[22]=N227 SUM[21]=N226 SUM[20]=N225 SUM[19]=N224 SUM[18]=N223
+ SUM[17]=N222 SUM[16]=N221 SUM[15]=N220 SUM[14]=N219 SUM[13]=N218 SUM[12]=N217
+ SUM[11]=N216 SUM[10]=N215 SUM[9]=N214 SUM[8]=N213 SUM[7]=N212 SUM[6]=N211
+ SUM[5]=N210 SUM[4]=N209 SUM[3]=N208 SUM[2]=N207 SUM[1]=N206 SUM[0]=N205
Xadd_0_root_add_0_root_add_28_3 PE_Shift_Add_5_DW01_add_0_DW01_add_32 $PINS
+ A[26]=N204 A[25]=N203 A[24]=N202 A[23]=N201 A[22]=N200 A[21]=N199 A[20]=N198
+ A[19]=N197 A[18]=N196 A[17]=N195 A[16]=N194 A[15]=N193 A[14]=N192 A[13]=N191
+ A[12]=N190 A[11]=N189 A[10]=N188 A[9]=N187 A[8]=N186 A[7]=N185 A[6]=N184
+ A[5]=N183 A[4]=N182 A[3]=N181 A[2]=N180 A[1]=N179 A[0]=N178 B[26]=N231
+ B[25]=N230 B[24]=N229 B[23]=N228 B[22]=N227 B[21]=N226 B[20]=N225 B[19]=N224
+ B[18]=N223 B[17]=N222 B[16]=N221 B[15]=N220 B[14]=N219 B[13]=N218 B[12]=N217
+ B[11]=N216 B[10]=N215 B[9]=N214 B[8]=N213 B[7]=N212 B[6]=N211 B[5]=N210
+ B[4]=N209 B[3]=N208 B[2]=N207 B[1]=N206 B[0]=N205 CI=net45565
+ SUM[26]=next_acc[26] SUM[25]=next_acc[25] SUM[24]=next_acc[24]
+ SUM[23]=next_acc[23] SUM[22]=next_acc[22] SUM[21]=next_acc[21]
+ SUM[20]=next_acc[20] SUM[19]=next_acc[19] SUM[18]=next_acc[18]
+ SUM[17]=next_acc[17] SUM[16]=next_acc[16] SUM[15]=next_acc[15]
+ SUM[14]=next_acc[14] SUM[13]=next_acc[13] SUM[12]=next_acc[12]
+ SUM[11]=next_acc[11] SUM[10]=next_acc[10] SUM[9]=next_acc[9] SUM[8]=next_acc[8]
+ SUM[7]=next_acc[7] SUM[6]=next_acc[6] SUM[5]=next_acc[5] SUM[4]=next_acc[4]
+ SUM[3]=next_acc[3] SUM[2]=next_acc[2] SUM[1]=next_acc[1] SUM[0]=next_acc[0]
.ENDS

.SUBCKT SNPS_CLOCK_GATE_HIGH_PE_Shift_Add_4 EN ENCLK CLK
*.CONNECT net2260 EN
XFE_PHC897_net2263 DELC $PINS O=FE_PHN897_net2263 I=net2263
Xlatch QDBHN $PINS Q=net2263 D=net2260 CKB=CLK
Xmain_gate AN2T $PINS O=ENCLK I1=FE_PHN897_net2263 I2=CLK
.ENDS

.SUBCKT PE_Shift_Add_4_DW01_sub_0_DW01_sub_12 A[26] A[25] A[24] A[23] A[22]
+ A[21] A[20] A[19] A[18] A[17] A[16] A[15] A[14] A[13] A[12] A[11] A[10] A[9]
+ A[8] A[7] A[6] A[5] A[4] A[3] A[2] A[1] A[0] B[26] B[25] B[24] B[23] B[22]
+ B[21] B[20] B[19] B[18] B[17] B[16] B[15] B[14] B[13] B[12] B[11] B[10] B[9]
+ B[8] B[7] B[6] B[5] B[4] B[3] B[2] B[1] B[0] CI DIFF[26] DIFF[25] DIFF[24]
+ DIFF[23] DIFF[22] DIFF[21] DIFF[20] DIFF[19] DIFF[18] DIFF[17] DIFF[16]
+ DIFF[15] DIFF[14] DIFF[13] DIFF[12] DIFF[11] DIFF[10] DIFF[9] DIFF[8] DIFF[7]
+ DIFF[6] DIFF[5] DIFF[4] DIFF[3] DIFF[2] DIFF[1] DIFF[0] CO
*.CONNECT DIFF[0] B[0]
XFE_RC_1539_0 AN2 $PINS O=FE_RN_360_0 I1=n46 I2=n47
XFE_RC_1538_0 AN2 $PINS O=n23 I1=FE_RN_360_0 I2=n21
XFE_RC_1127_0 XNR2HS $PINS O=DIFF[2] I1=n1 I2=B[2]
XFE_OFC659_term3_shifted_4 INV1S $PINS O=n48 I=B[4]
XU3 NR2 $PINS O=n1 I1=B[1] I2=B[0]
XU4 XOR2HS $PINS O=DIFF[1] I1=DIFF[0] I2=B[1]
XU5 INV2 $PINS O=n49 I=B[3]
XU6 INV1S $PINS O=n47 I=B[5]
XU8 ND2S $PINS O=n26 I1=n27 I2=n20
XU9 AN2 $PINS O=n2 I1=n50 I2=n1
XU10 AN2 $PINS O=n3 I1=n2 I2=n49
XU11 AN2 $PINS O=n4 I1=n44 I2=n24
XU12 AN2 $PINS O=n5 I1=n43 I2=n4
XU13 AN2 $PINS O=n6 I1=n42 I2=n5
XU14 AN2 $PINS O=n7 I1=n41 I2=n6
XU15 AN2 $PINS O=n8 I1=n40 I2=n7
XU16 AN2 $PINS O=n9 I1=n39 I2=n8
XU17 AN2 $PINS O=n10 I1=n38 I2=n9
XU18 AN2 $PINS O=n11 I1=n37 I2=n10
XU19 AN2 $PINS O=n12 I1=n36 I2=n11
XU20 AN2 $PINS O=n13 I1=n35 I2=n12
XU21 AN2 $PINS O=n14 I1=n34 I2=n13
XU22 AN2 $PINS O=n15 I1=n33 I2=n14
XU23 AN2 $PINS O=n16 I1=n32 I2=n15
XU24 AN2 $PINS O=n17 I1=n31 I2=n16
XU25 AN2 $PINS O=n18 I1=n30 I2=n17
XU26 AN2 $PINS O=n19 I1=n29 I2=n18
XU27 AN2 $PINS O=n20 I1=n28 I2=n19
XU28 AN2 $PINS O=n21 I1=n48 I2=n3
XU29 AN2T $PINS O=n22 I1=n47 I2=n21
XU31 AN2 $PINS O=n24 I1=n45 I2=n23
XU32 INV1S $PINS O=n44 I=B[8]
XU33 INV1S $PINS O=n43 I=B[9]
XU34 INV1S $PINS O=n42 I=B[10]
XU35 INV1S $PINS O=n41 I=B[11]
XU36 INV1S $PINS O=n40 I=B[12]
XU37 INV1S $PINS O=n39 I=B[13]
XU38 INV1S $PINS O=n38 I=B[14]
XU39 INV1S $PINS O=n37 I=B[15]
XU40 INV1S $PINS O=n36 I=B[16]
XU41 INV1S $PINS O=n35 I=B[17]
XU42 INV1S $PINS O=n34 I=B[18]
XU43 INV1S $PINS O=n33 I=B[19]
XU44 INV1S $PINS O=n32 I=B[20]
XU45 INV1S $PINS O=n31 I=B[21]
XU46 INV1S $PINS O=n30 I=B[22]
XU47 INV1S $PINS O=n29 I=B[23]
XU48 INV1S $PINS O=n28 I=B[24]
XU49 INV1S $PINS O=n27 I=B[25]
XU50 INV1S $PINS O=n46 I=B[6]
XU51 INV1S $PINS O=n45 I=B[7]
XU52 XOR2HS $PINS O=DIFF[4] I1=n3 I2=n48
XU53 XOR2HS $PINS O=DIFF[3] I1=n49 I2=n2
XU54 XOR2HS $PINS O=DIFF[6] I1=n46 I2=n22
XU55 XOR2HS $PINS O=DIFF[5] I1=n47 I2=n21
XU56 XOR2HS $PINS O=DIFF[7] I1=n45 I2=n23
XU57 XOR2HS $PINS O=DIFF[8] I1=n44 I2=n24
XU58 XOR2HS $PINS O=DIFF[10] I1=n42 I2=n5
XU59 XOR2HS $PINS O=DIFF[9] I1=n43 I2=n4
XU60 XOR2HS $PINS O=DIFF[11] I1=n41 I2=n6
XU61 XOR2HS $PINS O=DIFF[12] I1=n40 I2=n7
XU62 XOR2HS $PINS O=DIFF[13] I1=n39 I2=n8
XU63 XOR2HS $PINS O=DIFF[14] I1=n38 I2=n9
XU64 XOR2HS $PINS O=DIFF[15] I1=n37 I2=n10
XU65 XOR2HS $PINS O=DIFF[16] I1=n36 I2=n11
XU66 XOR2HS $PINS O=DIFF[17] I1=n35 I2=n12
XU67 XOR2HS $PINS O=DIFF[18] I1=n34 I2=n13
XU68 XOR2HS $PINS O=DIFF[19] I1=n33 I2=n14
XU69 XOR2HS $PINS O=DIFF[20] I1=n32 I2=n15
XU70 XOR2HS $PINS O=DIFF[21] I1=n31 I2=n16
XU71 XOR2HS $PINS O=DIFF[22] I1=n30 I2=n17
XU72 XOR2HS $PINS O=DIFF[23] I1=n29 I2=n18
XU73 XOR2HS $PINS O=DIFF[24] I1=n28 I2=n19
XU74 XOR2HS $PINS O=DIFF[25] I1=n27 I2=n20
XU75 XOR2HS $PINS O=DIFF[26] I1=B[26] I2=n26
XU2 INV1S $PINS O=n50 I=B[2]
.ENDS

.SUBCKT PE_Shift_Add_4_DW01_sub_1_DW01_sub_13 A[26] A[25] A[24] A[23] A[22]
+ A[21] A[20] A[19] A[18] A[17] A[16] A[15] A[14] A[13] A[12] A[11] A[10] A[9]
+ A[8] A[7] A[6] A[5] A[4] A[3] A[2] A[1] A[0] B[26] B[25] B[24] B[23] B[22]
+ B[21] B[20] B[19] B[18] B[17] B[16] B[15] B[14] B[13] B[12] B[11] B[10] B[9]
+ B[8] B[7] B[6] B[5] B[4] B[3] B[2] B[1] B[0] CI DIFF[26] DIFF[25] DIFF[24]
+ DIFF[23] DIFF[22] DIFF[21] DIFF[20] DIFF[19] DIFF[18] DIFF[17] DIFF[16]
+ DIFF[15] DIFF[14] DIFF[13] DIFF[12] DIFF[11] DIFF[10] DIFF[9] DIFF[8] DIFF[7]
+ DIFF[6] DIFF[5] DIFF[4] DIFF[3] DIFF[2] DIFF[1] DIFF[0] CO
*.CONNECT DIFF[0] B[0]
XFE_RC_1840_0 AN2B1S $PINS O=n5 I1=n4 B1=B[3]
XFE_RC_1135_0 XNR2HS $PINS O=DIFF[4] I1=B[4] I2=n5
XFE_OFC654_term2_shifted_9 INV1S $PINS O=n45 I=B[9]
XFE_OFC649_term2_shifted_7 INV1S $PINS O=n47 I=B[7]
XFE_OFC639_term2_shifted_3 INV1S $PINS O=n51 I=B[3]
XFE_OFC637_term2_shifted_8 INV1S $PINS O=n46 I=B[8]
XU2 NR2 $PINS O=n3 I1=DIFF[0] I2=B[1]
XU3 ND2 $PINS O=DIFF[1] I1=n1 I2=n2
XU4 INV1S $PINS O=n50 I=B[4]
XU5 ND2 $PINS O=n1 I1=n53 I2=B[0]
XU6 ND2 $PINS O=n2 I1=B[1] I2=n54
XU7 INV1S $PINS O=n49 I=B[5]
XU9 INV1S $PINS O=n53 I=B[1]
XU12 ND2S $PINS O=n28 I1=n29 I2=n22
XU13 AN2 $PINS O=n4 I1=n52 I2=n3
XU15 AN2 $PINS O=n6 I1=n46 I2=n26
XU16 AN2 $PINS O=n7 I1=n45 I2=n6
XU17 AN2 $PINS O=n8 I1=n44 I2=n7
XU18 AN2 $PINS O=n9 I1=n43 I2=n8
XU19 AN2 $PINS O=n10 I1=n42 I2=n9
XU20 AN2 $PINS O=n11 I1=n41 I2=n10
XU21 AN2 $PINS O=n12 I1=n40 I2=n11
XU22 AN2 $PINS O=n13 I1=n39 I2=n12
XU23 AN2 $PINS O=n14 I1=n38 I2=n13
XU24 AN2 $PINS O=n15 I1=n37 I2=n14
XU25 AN2 $PINS O=n16 I1=n36 I2=n15
XU26 AN2 $PINS O=n17 I1=n35 I2=n16
XU27 AN2 $PINS O=n18 I1=n34 I2=n17
XU28 AN2 $PINS O=n19 I1=n33 I2=n18
XU29 AN2 $PINS O=n20 I1=n32 I2=n19
XU30 AN2 $PINS O=n21 I1=n31 I2=n20
XU31 AN2 $PINS O=n22 I1=n30 I2=n21
XU32 AN2 $PINS O=n23 I1=n5 I2=n50
XU33 AN2 $PINS O=n24 I1=n23 I2=n49
XU34 AN2 $PINS O=n25 I1=n48 I2=n24
XU35 AN2 $PINS O=n26 I1=n47 I2=n25
XU38 INV1S $PINS O=n44 I=B[10]
XU39 INV1S $PINS O=n43 I=B[11]
XU40 INV1S $PINS O=n42 I=B[12]
XU41 INV1S $PINS O=n41 I=B[13]
XU42 INV1S $PINS O=n40 I=B[14]
XU43 INV1S $PINS O=n39 I=B[15]
XU44 INV1S $PINS O=n38 I=B[16]
XU45 INV1S $PINS O=n37 I=B[17]
XU46 INV1S $PINS O=n36 I=B[18]
XU47 INV1S $PINS O=n35 I=B[19]
XU48 INV1S $PINS O=n34 I=B[20]
XU49 INV1S $PINS O=n33 I=B[21]
XU50 INV1S $PINS O=n32 I=B[22]
XU51 INV1S $PINS O=n31 I=B[23]
XU52 INV1S $PINS O=n30 I=B[24]
XU53 INV1S $PINS O=n29 I=B[25]
XU54 INV1S $PINS O=n48 I=B[6]
XU56 XOR2HS $PINS O=DIFF[26] I1=B[26] I2=n28
XU57 XOR2HS $PINS O=DIFF[9] I1=n45 I2=n6
XU58 XOR2HS $PINS O=DIFF[10] I1=n44 I2=n7
XU59 XOR2HS $PINS O=DIFF[8] I1=n46 I2=n26
XU60 XOR2HS $PINS O=DIFF[6] I1=n48 I2=n24
XU61 XOR2HS $PINS O=DIFF[5] I1=n49 I2=n23
XU62 XOR2HS $PINS O=DIFF[7] I1=n47 I2=n25
XU64 XOR2HS $PINS O=DIFF[3] I1=n4 I2=n51
XU65 XOR2HS $PINS O=DIFF[11] I1=n43 I2=n8
XU66 XOR2HS $PINS O=DIFF[12] I1=n42 I2=n9
XU67 XOR2HS $PINS O=DIFF[13] I1=n41 I2=n10
XU68 XOR2HS $PINS O=DIFF[14] I1=n40 I2=n11
XU69 XOR2HS $PINS O=DIFF[15] I1=n39 I2=n12
XU70 XOR2HS $PINS O=DIFF[16] I1=n38 I2=n13
XU71 XOR2HS $PINS O=DIFF[17] I1=n37 I2=n14
XU72 XOR2HS $PINS O=DIFF[18] I1=n36 I2=n15
XU73 XOR2HS $PINS O=DIFF[19] I1=n35 I2=n16
XU74 XOR2HS $PINS O=DIFF[20] I1=n34 I2=n17
XU75 XOR2HS $PINS O=DIFF[21] I1=n33 I2=n18
XU76 XOR2HS $PINS O=DIFF[22] I1=n32 I2=n19
XU77 XOR2HS $PINS O=DIFF[23] I1=n31 I2=n20
XU78 XOR2HS $PINS O=DIFF[24] I1=n30 I2=n21
XU79 XOR2HS $PINS O=DIFF[25] I1=n29 I2=n22
XU1 INV1S $PINS O=n54 I=B[0]
XU8 INV1S $PINS O=n52 I=B[2]
XU11 XOR2HS $PINS O=DIFF[2] I1=n3 I2=n52
.ENDS

.SUBCKT PE_Shift_Add_4_DW01_sub_2_DW01_sub_14 A[26] A[25] A[24] A[23] A[22]
+ A[21] A[20] A[19] A[18] A[17] A[16] A[15] A[14] A[13] A[12] A[11] A[10] A[9]
+ A[8] A[7] A[6] A[5] A[4] A[3] A[2] A[1] A[0] B[26] B[25] B[24] B[23] B[22]
+ B[21] B[20] B[19] B[18] B[17] B[16] B[15] B[14] B[13] B[12] B[11] B[10] B[9]
+ B[8] B[7] B[6] B[5] B[4] B[3] B[2] B[1] B[0] CI DIFF[26] DIFF[25] DIFF[24]
+ DIFF[23] DIFF[22] DIFF[21] DIFF[20] DIFF[19] DIFF[18] DIFF[17] DIFF[16]
+ DIFF[15] DIFF[14] DIFF[13] DIFF[12] DIFF[11] DIFF[10] DIFF[9] DIFF[8] DIFF[7]
+ DIFF[6] DIFF[5] DIFF[4] DIFF[3] DIFF[2] DIFF[1] DIFF[0] CO
*.CONNECT DIFF[0] B[0]
XFE_RC_1395_0 XNR2HS $PINS O=DIFF[2] I1=n1 I2=B[2]
XFE_RC_1294_0 OR3B1 $PINS O=FE_RN_261_0 I1=B[4] I2=B[5] B1=n3
XFE_RC_1293_0 XOR2H $PINS O=DIFF[6] I1=B[6] I2=FE_RN_261_0
XFE_RC_1272_0 AN3B2 $PINS O=n22 I1=n3 B1=B[4] B2=B[5]
XFE_OFC664_term1_shifted_8 INV1S $PINS O=n44 I=B[8]
XFE_OFC663_term1_shifted_4 INV1S $PINS O=n48 I=B[4]
XFE_OFC585_term1_shifted_3 INV1S $PINS O=n49 I=B[3]
XU7 XOR2HS $PINS O=DIFF[3] I1=n49 I2=n2
XU10 AN2 $PINS O=n2 I1=n50 I2=n1
XU12 INV1S $PINS O=n47 I=B[5]
XU13 ND2S $PINS O=n26 I1=n27 I2=n20
XU14 AN2T $PINS O=n3 I1=n2 I2=n49
XU15 XOR2HS $PINS O=DIFF[8] I1=n44 I2=n24
XU16 XOR2HS $PINS O=DIFF[9] I1=n43 I2=n4
XU17 AN2 $PINS O=n4 I1=n44 I2=n24
XU18 XOR2HS $PINS O=DIFF[10] I1=n42 I2=n5
XU19 AN2 $PINS O=n5 I1=n43 I2=n4
XU20 XOR2HS $PINS O=DIFF[11] I1=n41 I2=n6
XU21 AN2 $PINS O=n6 I1=n42 I2=n5
XU22 XOR2HS $PINS O=DIFF[12] I1=n40 I2=n7
XU23 AN2 $PINS O=n7 I1=n41 I2=n6
XU24 XOR2HS $PINS O=DIFF[13] I1=n39 I2=n8
XU25 AN2 $PINS O=n8 I1=n40 I2=n7
XU26 XOR2HS $PINS O=DIFF[14] I1=n38 I2=n9
XU27 AN2 $PINS O=n9 I1=n39 I2=n8
XU28 XOR2HS $PINS O=DIFF[15] I1=n37 I2=n10
XU29 AN2 $PINS O=n10 I1=n38 I2=n9
XU30 XOR2HS $PINS O=DIFF[16] I1=n36 I2=n11
XU31 AN2 $PINS O=n11 I1=n37 I2=n10
XU32 XOR2HS $PINS O=DIFF[17] I1=n35 I2=n12
XU33 AN2 $PINS O=n12 I1=n36 I2=n11
XU34 XOR2HS $PINS O=DIFF[18] I1=n34 I2=n13
XU35 AN2 $PINS O=n13 I1=n35 I2=n12
XU36 XOR2HS $PINS O=DIFF[19] I1=n33 I2=n14
XU37 AN2 $PINS O=n14 I1=n34 I2=n13
XU38 XOR2HS $PINS O=DIFF[20] I1=n32 I2=n15
XU39 AN2 $PINS O=n15 I1=n33 I2=n14
XU40 XOR2HS $PINS O=DIFF[21] I1=n31 I2=n16
XU41 AN2 $PINS O=n16 I1=n32 I2=n15
XU42 XOR2HS $PINS O=DIFF[22] I1=n30 I2=n17
XU43 AN2 $PINS O=n17 I1=n31 I2=n16
XU44 XOR2HS $PINS O=DIFF[23] I1=n29 I2=n18
XU45 AN2 $PINS O=n18 I1=n30 I2=n17
XU46 AN2 $PINS O=n19 I1=n29 I2=n18
XU47 AN2 $PINS O=n20 I1=n28 I2=n19
XU48 XOR2HS $PINS O=DIFF[24] I1=n28 I2=n19
XU49 XOR2HS $PINS O=DIFF[25] I1=n27 I2=n20
XU50 XOR2HS $PINS O=DIFF[4] I1=n3 I2=n48
XU51 XOR2HS $PINS O=DIFF[5] I1=n47 I2=n21
XU52 AN2 $PINS O=n21 I1=n3 I2=n48
XU55 XOR2HS $PINS O=DIFF[7] I1=n45 I2=n23
XU56 AN2 $PINS O=n23 I1=n46 I2=n22
XU57 AN2 $PINS O=n24 I1=n45 I2=n23
XU59 INV1S $PINS O=n43 I=B[9]
XU60 INV1S $PINS O=n42 I=B[10]
XU61 INV1S $PINS O=n41 I=B[11]
XU62 INV1S $PINS O=n40 I=B[12]
XU63 INV1S $PINS O=n39 I=B[13]
XU64 INV1S $PINS O=n38 I=B[14]
XU65 INV1S $PINS O=n37 I=B[15]
XU66 INV1S $PINS O=n36 I=B[16]
XU67 INV1S $PINS O=n35 I=B[17]
XU68 INV1S $PINS O=n34 I=B[18]
XU69 INV1S $PINS O=n33 I=B[19]
XU70 INV1S $PINS O=n32 I=B[20]
XU71 INV1S $PINS O=n31 I=B[21]
XU72 INV1S $PINS O=n30 I=B[22]
XU73 INV1S $PINS O=n29 I=B[23]
XU74 INV1S $PINS O=n28 I=B[24]
XU75 INV1S $PINS O=n27 I=B[25]
XU76 INV1S $PINS O=n46 I=B[6]
XU77 INV1S $PINS O=n45 I=B[7]
XU78 XOR2HS $PINS O=DIFF[26] I1=B[26] I2=n26
XU1 XOR2HS $PINS O=DIFF[1] I1=DIFF[0] I2=B[1]
XU2 NR2 $PINS O=n1 I1=B[1] I2=B[0]
XU4 INV1S $PINS O=n50 I=B[2]
.ENDS

.SUBCKT PE_Shift_Add_4_DW01_add_2_DW01_add_22 A[26] A[25] A[24] A[23] A[22]
+ A[21] A[20] A[19] A[18] A[17] A[16] A[15] A[14] A[13] A[12] A[11] A[10] A[9]
+ A[8] A[7] A[6] A[5] A[4] A[3] A[2] A[1] A[0] B[26] B[25] B[24] B[23] B[22]
+ B[21] B[20] B[19] B[18] B[17] B[16] B[15] B[14] B[13] B[12] B[11] B[10] B[9]
+ B[8] B[7] B[6] B[5] B[4] B[3] B[2] B[1] B[0] CI SUM[26] SUM[25] SUM[24]
+ SUM[23] SUM[22] SUM[21] SUM[20] SUM[19] SUM[18] SUM[17] SUM[16] SUM[15]
+ SUM[14] SUM[13] SUM[12] SUM[11] SUM[10] SUM[9] SUM[8] SUM[7] SUM[6] SUM[5]
+ SUM[4] SUM[3] SUM[2] SUM[1] SUM[0] CO
XFE_RC_1848_0 INV2 $PINS O=SUM[3] I=FE_RN_516_0
XFE_RC_1847_0 XNR3 $PINS O=FE_RN_516_0 I1=A[3] I2=B[3] I3=carry[3]
XFE_RC_1780_0 INV2CK $PINS O=SUM[21] I=FE_RN_484_0
XFE_RC_1779_0 XNR3 $PINS O=FE_RN_484_0 I1=A[21] I2=B[21] I3=carry[21]
XFE_RC_1750_0 INV2 $PINS O=SUM[20] I=FE_RN_468_0
XFE_RC_1749_0 XNR3 $PINS O=FE_RN_468_0 I1=A[20] I2=B[20] I3=carry[20]
XFE_RC_1421_0 XOR3 $PINS O=SUM[19] I1=A[19] I2=B[19] I3=carry[19]
XFE_RC_1420_0 MAO222P $PINS O=carry[20] A1=carry[19] B1=B[19] C1=A[19]
XFE_RC_1270_0 ND2P $PINS O=n18 I1=carry[20] I2=B[20]
XFE_RC_1150_0 INV2 $PINS O=SUM[8] I=FE_RN_193_0
XFE_RC_1149_0 XNR3 $PINS O=FE_RN_193_0 I1=A[8] I2=B[8] I3=carry[8]
XFE_RC_1119_0 INV1S $PINS O=SUM[26] I=FE_RN_184_0
XFE_RC_1118_0 XNR2HS $PINS O=FE_RN_184_0 I1=FE_RN_90_0 I2=carry[26]
XFE_RC_1021_0 MAO222P $PINS O=carry[4] A1=carry[3] B1=B[3] C1=A[3]
XFE_RC_986_0 XOR3 $PINS O=SUM[25] I1=A[25] I2=B[25] I3=carry[25]
XFE_RC_985_0 MAO222 $PINS O=carry[26] A1=A[25] B1=B[25] C1=carry[25]
XFE_RC_870_0 XOR2HS $PINS O=FE_RN_90_0 I1=A[26] I2=B[26]
XFE_RC_778_0 XOR3 $PINS O=SUM[23] I1=A[23] I2=B[23] I3=carry[23]
XFE_RC_777_0 MAO222 $PINS O=carry[24] A1=carry[23] B1=B[23] C1=A[23]
XFE_RC_711_0 XOR3 $PINS O=SUM[2] I1=B[2] I2=A[2] I3=carry[2]
XFE_RC_710_0 MAO222 $PINS O=carry[3] A1=carry[2] B1=A[2] C1=B[2]
XFE_RC_669_0 XOR3 $PINS O=SUM[1] I1=A[1] I2=carry[1] I3=B[1]
XFE_RC_668_0 MAO222 $PINS O=carry[2] A1=B[1] B1=A[1] C1=carry[1]
XFE_RC_667_0 XOR3 $PINS O=SUM[24] I1=A[24] I2=B[24] I3=carry[24]
XFE_RC_666_0 MAO222 $PINS O=carry[25] A1=carry[24] B1=B[24] C1=A[24]
XFE_RC_617_0 XOR3 $PINS O=SUM[22] I1=A[22] I2=B[22] I3=carry[22]
XFE_RC_616_0 MAO222 $PINS O=carry[23] A1=carry[22] B1=B[22] C1=A[22]
XFE_RC_556_0 MAO222P $PINS O=carry[22] A1=carry[21] B1=B[21] C1=A[21]
XFE_RC_553_0 XOR3 $PINS O=SUM[13] I1=A[13] I2=B[13] I3=carry[13]
XFE_RC_552_0 MAO222P $PINS O=carry[14] A1=carry[13] B1=B[13] C1=A[13]
XFE_RC_513_0 XOR3 $PINS O=SUM[12] I1=A[12] I2=B[12] I3=carry[12]
XFE_RC_512_0 MAO222P $PINS O=carry[13] A1=carry[12] B1=B[12] C1=A[12]
XFE_RC_440_0 XOR3 $PINS O=SUM[14] I1=A[14] I2=B[14] I3=carry[14]
XFE_RC_439_0 MAO222P $PINS O=carry[15] A1=carry[14] B1=B[14] C1=A[14]
XFE_RC_422_0 XOR3 $PINS O=SUM[15] I1=A[15] I2=B[15] I3=carry[15]
XFE_RC_421_0 MAO222P $PINS O=carry[16] A1=carry[15] B1=B[15] C1=A[15]
XFE_RC_355_0 XOR3 $PINS O=SUM[16] I1=A[16] I2=B[16] I3=carry[16]
XFE_RC_354_0 MAO222P $PINS O=carry[17] A1=carry[16] B1=B[16] C1=A[16]
XFE_RC_296_0 XOR3 $PINS O=SUM[17] I1=A[17] I2=B[17] I3=carry[17]
XFE_RC_295_0 MAO222P $PINS O=carry[18] A1=carry[17] B1=B[17] C1=A[17]
XFE_RC_255_0 XOR3 $PINS O=SUM[18] I1=A[18] I2=B[18] I3=carry[18]
XFE_RC_254_0 MAO222P $PINS O=carry[19] A1=carry[18] B1=B[18] C1=A[18]
XFE_RC_190_0 XOR3 $PINS O=SUM[10] I1=A[10] I2=B[10] I3=carry[10]
XFE_RC_189_0 MAO222P $PINS O=carry[11] A1=carry[10] B1=B[10] C1=A[10]
XFE_RC_130_0 XOR3 $PINS O=SUM[11] I1=A[11] I2=B[11] I3=carry[11]
XFE_RC_129_0 MAO222P $PINS O=carry[12] A1=carry[11] B1=B[11] C1=A[11]
XFE_RC_92_0 MAO222P $PINS O=carry[9] A1=carry[8] B1=B[8] C1=A[8]
XU1_6 FA1 $PINS S=SUM[6] CO=carry[7] A=A[6] B=B[6] CI=carry[6]
XU1 MAO222 $PINS O=n1 A1=carry[6] B1=B[6] C1=A[6]
XU4 XOR2HS $PINS O=SUM[5] I1=carry[5] I2=n6
XU5 ND3P $PINS O=carry[10] I1=n15 I2=n14 I3=n16
XU6 XOR2HS $PINS O=n2 I1=B[4] I2=A[4]
XU7 XOR2HS $PINS O=SUM[4] I1=carry[4] I2=n2
XU8 ND2 $PINS O=n3 I1=carry[4] I2=B[4]
XU9 ND2 $PINS O=n4 I1=carry[4] I2=A[4]
XU10 ND2 $PINS O=n5 I1=A[4] I2=B[4]
XU11 ND3P $PINS O=carry[5] I1=n4 I2=n3 I3=n5
XU12 ND3P $PINS O=carry[6] I1=n7 I2=n8 I3=n9
XU14 INV2 $PINS O=carry[1] I=n20
XU15 ND2 $PINS O=n9 I1=A[5] I2=B[5]
XU16 XOR2HS $PINS O=n6 I1=A[5] I2=B[5]
XU17 ND2 $PINS O=n7 I1=carry[5] I2=A[5]
XU18 ND2 $PINS O=n8 I1=carry[5] I2=B[5]
XU19 XOR2HS $PINS O=n10 I1=A[7] I2=B[7]
XU20 XOR2HS $PINS O=SUM[7] I1=n1 I2=n10
XU21 ND2 $PINS O=n11 I1=n1 I2=A[7]
XU22 ND2 $PINS O=n12 I1=carry[7] I2=B[7]
XU23 ND2 $PINS O=n13 I1=A[7] I2=B[7]
XU24 ND3P $PINS O=carry[8] I1=n12 I2=n11 I3=n13
XU25 ND2P $PINS O=n14 I1=carry[9] I2=A[9]
XU26 ND2 $PINS O=n15 I1=carry[9] I2=B[9]
XU27 ND2 $PINS O=n16 I1=A[9] I2=B[9]
XU28 ND2P $PINS O=n17 I1=carry[20] I2=A[20]
XU30 ND2S $PINS O=n19 I1=A[20] I2=B[20]
XU32 XOR2HS $PINS O=SUM[0] I1=B[0] I2=A[0]
XU33 ND2 $PINS O=n20 I1=B[0] I2=A[0]
XU2 ND3P $PINS O=carry[21] I1=n18 I2=n17 I3=n19
XU3 XOR3 $PINS O=SUM[9] I1=A[9] I2=B[9] I3=carry[9]
.ENDS

.SUBCKT PE_Shift_Add_4_DW01_add_1_DW01_add_21 A[26] A[25] A[24] A[23] A[22]
+ A[21] A[20] A[19] A[18] A[17] A[16] A[15] A[14] A[13] A[12] A[11] A[10] A[9]
+ A[8] A[7] A[6] A[5] A[4] A[3] A[2] A[1] A[0] B[26] B[25] B[24] B[23] B[22]
+ B[21] B[20] B[19] B[18] B[17] B[16] B[15] B[14] B[13] B[12] B[11] B[10] B[9]
+ B[8] B[7] B[6] B[5] B[4] B[3] B[2] B[1] B[0] CI SUM[26] SUM[25] SUM[24]
+ SUM[23] SUM[22] SUM[21] SUM[20] SUM[19] SUM[18] SUM[17] SUM[16] SUM[15]
+ SUM[14] SUM[13] SUM[12] SUM[11] SUM[10] SUM[9] SUM[8] SUM[7] SUM[6] SUM[5]
+ SUM[4] SUM[3] SUM[2] SUM[1] SUM[0] CO
XFE_RC_1629_0 XOR3 $PINS O=SUM[24] I1=A[24] I2=B[24] I3=carry[24]
XFE_RC_1628_0 MAO222 $PINS O=carry[25] A1=A[24] B1=B[24] C1=carry[24]
XFE_RC_1504_0 XOR3 $PINS O=SUM[25] I1=A[25] I2=B[25] I3=carry[25]
XFE_RC_1503_0 MAO222 $PINS O=carry[26] A1=A[25] B1=B[25] C1=carry[25]
XFE_RC_1459_0 XOR3 $PINS O=SUM[23] I1=A[23] I2=B[23] I3=carry[23]
XFE_RC_1458_0 MAO222 $PINS O=carry[24] A1=carry[23] B1=B[23] C1=A[23]
XFE_RC_1339_0 INV1S $PINS O=FE_RN_278_0 I=A[0]
XFE_RC_1338_0 AN2B1S $PINS O=n4 I1=B[0] B1=FE_RN_278_0
XFE_RC_1276_0 ND2 $PINS O=n24 I1=n19 I2=B[9]
XFE_RC_1257_0 MAO222P $PINS O=carry[4] A1=carry[3] B1=A[3] C1=B[3]
XFE_RC_1207_0 INV2 $PINS O=SUM[26] I=FE_RN_219_0
XFE_RC_1206_0 XNR2HS $PINS O=FE_RN_220_0 I1=A[26] I2=B[26]
XFE_RC_1205_0 XOR2HS $PINS O=FE_RN_219_0 I1=FE_RN_220_0 I2=carry[26]
XFE_RC_723_0 XOR3 $PINS O=SUM[12] I1=A[12] I2=B[12] I3=carry[12]
XFE_RC_722_0 MAO222 $PINS O=carry[13] A1=carry[12] B1=B[12] C1=A[12]
XFE_RC_707_0 XOR3 $PINS O=SUM[13] I1=A[13] I2=B[13] I3=carry[13]
XFE_RC_706_0 MAO222 $PINS O=carry[14] A1=carry[13] B1=B[13] C1=A[13]
XFE_RC_655_0 XOR3 $PINS O=SUM[22] I1=A[22] I2=B[22] I3=carry[22]
XFE_RC_654_0 MAO222 $PINS O=carry[23] A1=carry[22] B1=B[22] C1=A[22]
XFE_RC_627_0 XOR3 $PINS O=SUM[21] I1=A[21] I2=B[21] I3=carry[21]
XFE_RC_626_0 MAO222 $PINS O=carry[22] A1=carry[21] B1=B[21] C1=A[21]
XFE_RC_561_0 XOR3 $PINS O=SUM[11] I1=A[11] I2=B[11] I3=carry[11]
XFE_RC_560_0 MAO222 $PINS O=carry[12] A1=carry[11] B1=B[11] C1=A[11]
XFE_RC_523_0 XOR3 $PINS O=SUM[19] I1=A[19] I2=B[19] I3=carry[19]
XFE_RC_522_0 MAO222P $PINS O=carry[20] A1=carry[19] B1=B[19] C1=A[19]
XFE_RC_461_0 XOR3 $PINS O=SUM[10] I1=A[10] I2=B[10] I3=carry[10]
XFE_RC_460_0 MAO222 $PINS O=carry[11] A1=carry[10] B1=B[10] C1=A[10]
XFE_RC_458_0 XOR3 $PINS O=SUM[20] I1=A[20] I2=B[20] I3=carry[20]
XFE_RC_457_0 MAO222P $PINS O=carry[21] A1=carry[20] B1=B[20] C1=A[20]
XFE_RC_406_0 XOR3 $PINS O=SUM[16] I1=A[16] I2=B[16] I3=carry[16]
XFE_RC_405_0 MAO222 $PINS O=carry[17] A1=carry[16] B1=B[16] C1=A[16]
XFE_RC_365_0 XOR3 $PINS O=SUM[17] I1=A[17] I2=B[17] I3=carry[17]
XFE_RC_364_0 MAO222 $PINS O=carry[18] A1=carry[17] B1=B[17] C1=A[17]
XFE_RC_317_0 XOR3 $PINS O=SUM[18] I1=A[18] I2=B[18] I3=carry[18]
XFE_RC_316_0 MAO222 $PINS O=carry[19] A1=carry[18] B1=B[18] C1=A[18]
XFE_RC_257_0 XOR3 $PINS O=SUM[7] I1=A[7] I2=B[7] I3=carry[7]
XFE_RC_256_0 MAO222P $PINS O=carry[8] A1=carry[7] B1=B[7] C1=A[7]
XFE_RC_132_0 XOR3 $PINS O=SUM[1] I1=A[1] I2=n4 I3=B[1]
XFE_RC_131_0 MAO222 $PINS O=carry[2] A1=B[1] B1=A[1] C1=n4
XFE_RC_89_0 XOR3 $PINS O=SUM[2] I1=A[2] I2=B[2] I3=carry[2]
XFE_RC_88_0 MAO222P $PINS O=carry[3] A1=carry[2] B1=B[2] C1=A[2]
XU1_8 FA1 $PINS S=SUM[8] CO=carry[9] A=A[8] B=B[8] CI=carry[8]
XU1_5 FA1 $PINS S=SUM[5] CO=carry[6] A=A[5] B=B[5] CI=carry[5]
XU1 ND3P $PINS O=carry[10] I1=n24 I2=n25 I3=n26
XU5 XOR3 $PINS O=SUM[3] I1=B[3] I2=A[3] I3=carry[3]
XU7 ND3P $PINS O=carry[5] I1=n16 I2=n15 I3=n14
XU8 ND2 $PINS O=n22 I1=n17 I2=A[6]
XU9 XOR3 $PINS O=SUM[9] I1=B[9] I2=A[9] I3=n19
XU10 ND2 $PINS O=n5 I1=A[14] I2=B[14]
XU11 XOR3 $PINS O=SUM[14] I1=A[14] I2=B[14] I3=n12
XU13 ND2 $PINS O=n6 I1=A[14] I2=n12
XU14 ND2 $PINS O=n7 I1=B[14] I2=carry[14]
XU15 ND3P $PINS O=carry[15] I1=n6 I2=n5 I3=n7
XU16 XOR2HS $PINS O=n8 I1=A[15] I2=B[15]
XU17 XOR2HS $PINS O=SUM[15] I1=n8 I2=carry[15]
XU18 ND2 $PINS O=n9 I1=A[15] I2=B[15]
XU19 ND2 $PINS O=n10 I1=carry[15] I2=A[15]
XU20 ND2 $PINS O=n11 I1=carry[15] I2=B[15]
XU21 ND3 $PINS O=carry[16] I1=n11 I2=n10 I3=n9
XU22 MAO222 $PINS O=n12 A1=carry[13] B1=B[13] C1=A[13]
XU23 XOR2HS $PINS O=n13 I1=B[4] I2=A[4]
XU24 XOR2HS $PINS O=SUM[4] I1=carry[4] I2=n13
XU25 ND2P $PINS O=n14 I1=carry[4] I2=B[4]
XU26 ND2P $PINS O=n15 I1=carry[4] I2=A[4]
XU27 ND2 $PINS O=n16 I1=B[4] I2=A[4]
XU28 MAO222 $PINS O=n17 A1=carry[5] B1=B[5] C1=A[5]
XU29 MAO222 $PINS O=n18 A1=carry[5] B1=B[5] C1=A[5]
XU30 MAO222 $PINS O=n19 A1=carry[8] B1=B[8] C1=A[8]
XU31 ND2S $PINS O=n26 I1=B[9] I2=A[9]
XU32 XOR2HS $PINS O=n20 I1=B[6] I2=A[6]
XU33 XOR2HS $PINS O=SUM[6] I1=carry[6] I2=n20
XU34 ND2 $PINS O=n21 I1=n18 I2=B[6]
XU35 ND2 $PINS O=n23 I1=B[6] I2=A[6]
XU36 ND3P $PINS O=carry[7] I1=n21 I2=n22 I3=n23
XU38 ND2 $PINS O=n25 I1=n19 I2=A[9]
XU39 XOR2HS $PINS O=SUM[0] I1=B[0] I2=A[0]
.ENDS

.SUBCKT PE_Shift_Add_4_DW01_add_0_DW01_add_20 A[26] A[25] A[24] A[23] A[22]
+ A[21] A[20] A[19] A[18] A[17] A[16] A[15] A[14] A[13] A[12] A[11] A[10] A[9]
+ A[8] A[7] A[6] A[5] A[4] A[3] A[2] A[1] A[0] B[26] B[25] B[24] B[23] B[22]
+ B[21] B[20] B[19] B[18] B[17] B[16] B[15] B[14] B[13] B[12] B[11] B[10] B[9]
+ B[8] B[7] B[6] B[5] B[4] B[3] B[2] B[1] B[0] CI SUM[26] SUM[25] SUM[24]
+ SUM[23] SUM[22] SUM[21] SUM[20] SUM[19] SUM[18] SUM[17] SUM[16] SUM[15]
+ SUM[14] SUM[13] SUM[12] SUM[11] SUM[10] SUM[9] SUM[8] SUM[7] SUM[6] SUM[5]
+ SUM[4] SUM[3] SUM[2] SUM[1] SUM[0] CO
XFE_RC_1175_0 XOR3 $PINS O=SUM[1] I1=A[1] I2=B[1] I3=n4
XFE_RC_1174_0 MAO222 $PINS O=carry[2] A1=A[1] B1=B[1] C1=n4
XFE_RC_1070_0 INV1S $PINS O=FE_RN_164_0 I=A[8]
XFE_RC_1069_0 AO13 $PINS O=n6 A1=FE_RN_164_0 B1=n19 B2=n18 B3=n20
XFE_RC_1067_0 INV2CK $PINS O=FE_RN_163_0 I=A[22]
XFE_RC_1066_0 AO13P $PINS O=n21 A1=FE_RN_163_0 B1=n25 B2=n26 B3=n27
XFE_RC_697_0 XOR3 $PINS O=SUM[25] I1=A[25] I2=B[25] I3=carry[25]
XFE_RC_696_0 MAO222 $PINS O=carry[26] A1=carry[25] B1=B[25] C1=A[25]
XFE_RC_639_0 XOR3 $PINS O=SUM[10] I1=A[10] I2=B[10] I3=carry[10]
XFE_RC_638_0 MAO222 $PINS O=carry[11] A1=carry[10] B1=B[10] C1=A[10]
XFE_RC_637_0 XOR3 $PINS O=SUM[2] I1=A[2] I2=B[2] I3=carry[2]
XFE_RC_636_0 MAO222 $PINS O=carry[3] A1=A[2] B1=carry[2] C1=B[2]
XFE_RC_575_0 XOR3 $PINS O=SUM[23] I1=A[23] I2=B[23] I3=carry[23]
XFE_RC_574_0 MAO222P $PINS O=carry[24] A1=carry[23] B1=B[23] C1=A[23]
XFE_RC_571_0 XOR3 $PINS O=SUM[11] I1=A[11] I2=B[11] I3=carry[11]
XFE_RC_570_0 MAO222P $PINS O=carry[12] A1=carry[11] B1=B[11] C1=A[11]
XFE_RC_535_0 XOR3 $PINS O=SUM[12] I1=A[12] I2=B[12] I3=carry[12]
XFE_RC_534_0 MAO222P $PINS O=carry[13] A1=carry[12] B1=B[12] C1=A[12]
XFE_RC_472_0 XOR3 $PINS O=SUM[13] I1=A[13] I2=B[13] I3=carry[13]
XFE_RC_471_0 MAO222P $PINS O=carry[14] A1=carry[13] B1=B[13] C1=A[13]
XFE_RC_392_0 XOR3 $PINS O=SUM[14] I1=A[14] I2=B[14] I3=carry[14]
XFE_RC_391_0 MAO222P $PINS O=carry[15] A1=carry[14] B1=B[14] C1=A[14]
XFE_RC_390_0 XOR3 $PINS O=SUM[3] I1=A[3] I2=B[3] I3=carry[3]
XFE_RC_389_0 MAO222 $PINS O=carry[4] A1=carry[3] B1=B[3] C1=A[3]
XFE_RC_327_0 XOR3 $PINS O=SUM[15] I1=A[15] I2=B[15] I3=carry[15]
XFE_RC_326_0 MAO222P $PINS O=carry[16] A1=carry[15] B1=B[15] C1=A[15]
XFE_RC_238_0 XOR3 $PINS O=SUM[16] I1=A[16] I2=B[16] I3=carry[16]
XFE_RC_237_0 MAO222P $PINS O=carry[17] A1=carry[16] B1=B[16] C1=A[16]
XFE_RC_234_0 XOR3 $PINS O=SUM[4] I1=A[4] I2=B[4] I3=carry[4]
XFE_RC_233_0 MAO222P $PINS O=carry[5] A1=carry[4] B1=B[4] C1=A[4]
XFE_RC_188_0 XOR3 $PINS O=SUM[6] I1=A[6] I2=B[6] I3=carry[6]
XFE_RC_187_0 MAO222P $PINS O=carry[7] A1=carry[6] B1=B[6] C1=A[6]
XFE_RC_120_0 XOR3 $PINS O=SUM[17] I1=A[17] I2=B[17] I3=carry[17]
XFE_RC_119_0 MAO222P $PINS O=carry[18] A1=carry[17] B1=B[17] C1=A[17]
XFE_RC_83_0 XOR3 $PINS O=SUM[18] I1=A[18] I2=B[18] I3=carry[18]
XFE_RC_82_0 MAO222P $PINS O=carry[19] A1=carry[18] B1=B[18] C1=A[18]
XU1_26 XOR3 $PINS O=SUM[26] I1=A[26] I2=B[26] I3=carry[26]
XU1_20 FA1S $PINS S=SUM[20] CO=carry[21] A=A[20] B=B[20] CI=carry[20]
XU2 ND2 $PINS O=n3 I1=A[19] I2=B[19]
XU3 ND3P $PINS O=carry[9] I1=n6 I2=n7 I3=n5
XU4 ND3P $PINS O=carry[20] I1=n2 I2=n1 I3=n3
XU5 ND2P $PINS O=n25 I1=n14 I2=A[21]
XU6 ND3 $PINS O=carry[22] I1=n26 I2=n25 I3=n27
XU7 ND3 $PINS O=carry[23] I1=n21 I2=n22 I3=n23
XU8 ND2 $PINS O=n22 I1=carry[22] I2=B[22]
XU9 XOR3 $PINS O=SUM[19] I1=A[19] I2=B[19] I3=carry[19]
XU10 ND2P $PINS O=n1 I1=carry[19] I2=A[19]
XU11 ND2 $PINS O=n2 I1=carry[19] I2=B[19]
XU13 ND2 $PINS O=n27 I1=A[21] I2=B[21]
XU15 XOR3 $PINS O=SUM[5] I1=B[5] I2=A[5] I3=carry[5]
XU16 XOR2HS $PINS O=n24 I1=A[21] I2=B[21]
XU17 XOR3 $PINS O=SUM[22] I1=A[22] I2=B[22] I3=n12
XU18 XOR2HS $PINS O=n28 I1=A[24] I2=B[24]
XU19 ND3P $PINS O=carry[25] I1=n30 I2=n29 I3=n31
XU20 AN2 $PINS O=n4 I1=B[0] I2=A[0]
XU21 XOR3 $PINS O=SUM[8] I1=A[8] I2=B[8] I3=carry[8]
XU22 ND2 $PINS O=n5 I1=A[8] I2=B[8]
XU24 ND2 $PINS O=n7 I1=carry[8] I2=B[8]
XU25 XOR2HS $PINS O=n8 I1=A[9] I2=B[9]
XU26 XOR2HS $PINS O=SUM[9] I1=n8 I2=carry[9]
XU27 ND2 $PINS O=n9 I1=A[9] I2=B[9]
XU28 ND2 $PINS O=n10 I1=carry[9] I2=A[9]
XU29 ND2 $PINS O=n11 I1=carry[9] I2=B[9]
XU30 ND3 $PINS O=carry[10] I1=n10 I2=n11 I3=n9
XU31 ND3 $PINS O=carry[6] I1=n15 I2=n17 I3=n16
XU32 MAO222 $PINS O=n13 A1=carry[20] B1=B[20] C1=A[20]
XU33 MAO222 $PINS O=n14 A1=carry[20] B1=B[20] C1=A[20]
XU34 ND2P $PINS O=n29 I1=carry[24] I2=A[24]
XU35 ND2 $PINS O=n15 I1=B[5] I2=carry[5]
XU36 ND2 $PINS O=n16 I1=carry[5] I2=A[5]
XU37 ND2 $PINS O=n17 I1=B[5] I2=A[5]
XU38 XOR3S $PINS O=SUM[7] I1=B[7] I2=A[7] I3=carry[7]
XU39 ND2P $PINS O=n18 I1=carry[7] I2=B[7]
XU40 ND2P $PINS O=n19 I1=carry[7] I2=A[7]
XU41 ND2 $PINS O=n20 I1=B[7] I2=A[7]
XU42 ND3P $PINS O=carry[8] I1=n19 I2=n18 I3=n20
XU43 ND2S $PINS O=n23 I1=A[22] I2=B[22]
XU44 XOR2HS $PINS O=SUM[21] I1=carry[21] I2=n24
XU45 XOR2HS $PINS O=SUM[24] I1=carry[24] I2=n28
XU46 ND2 $PINS O=n30 I1=carry[24] I2=B[24]
XU47 ND2S $PINS O=n31 I1=A[24] I2=B[24]
XU48 XOR2HS $PINS O=SUM[0] I1=B[0] I2=A[0]
XU12 ND2P $PINS O=n26 I1=n13 I2=B[21]
XU14 ND3 $PINS O=n12 I1=n25 I2=n26 I3=n27
.ENDS

.SUBCKT PE_Shift_Add_4 rst_n en clear calc_done stage_sel x_in[16] x_in[15]
+ x_in[14] x_in[13] x_in[12] x_in[11] x_in[10] x_in[9] x_in[8] x_in[7] x_in[6]
+ x_in[5] x_in[4] x_in[3] x_in[2] x_in[1] x_in[0] sign1[1] sign1[0] sign2[1]
+ sign2[0] sign3[1] sign3[0] shf1[3] shf1[2] shf1[1] shf1[0] shf2[3] shf2[2]
+ shf2[1] shf2[0] shf3[3] shf3[2] shf3[1] shf3[0] y_out[16] y_out[15] y_out[14]
+ y_out[13] y_out[12] y_out[11] y_out[10] y_out[9] y_out[8] y_out[7] y_out[6]
+ y_out[5] y_out[4] y_out[3] y_out[2] y_out[1] y_out[0] i_rst_n
+ FE_OFN11_i_rst_n FE_OFN41_mac_in_imag_3 FE_OFN46_h13_3 FE_OFN50_h13_0
+ FE_OFN54_s11_1 FE_OFN59_h13_2 FE_OFN62_h13_1 FE_OFN63_s12_1 FE_OFN65_s13_1
+ FE_OFN76_n FE_OFN346_mac_in_imag_0 clk_clone2 clk_clone1 clk
XFE_PHC1349_N246 DELB $PINS O=FE_PHN1349_N246 I=N246
XFE_PHC1339_N248 DELB $PINS O=FE_PHN1339_N248 I=N248
XFE_PHC1333_N249 DELB $PINS O=FE_PHN1333_N249 I=N249
XFE_PHC1305_N247 DELB $PINS O=FE_PHN1305_N247 I=N247
XFE_PHC1050_next_acc_0 DELB $PINS O=FE_PHN1050_next_acc_0 I=next_acc[0]
XFE_PHC1013_N236 DELB $PINS O=FE_PHN1013_N236 I=N236
XFE_PHC1011_N235 DELB $PINS O=FE_PHN1011_N235 I=N235
XFE_PHC1009_N237 DELB $PINS O=FE_PHN1009_N237 I=N237
XFE_PHC1006_N238 DELB $PINS O=FE_PHN1006_N238 I=N238
XFE_PHC1004_N239 DELB $PINS O=FE_PHN1004_N239 I=N239
XFE_PHC1001_N245 DELB $PINS O=FE_PHN1001_N245 I=N245
XFE_PHC992_N240 DELB $PINS O=FE_PHN992_N240 I=N240
XFE_PHC984_N243 DELB $PINS O=FE_PHN984_N243 I=N243
XFE_PHC979_N242 DELB $PINS O=FE_PHN979_N242 I=N242
XFE_PHC961_N244 DELB $PINS O=FE_PHN961_N244 I=N244
XFE_PHC955_N241 DELB $PINS O=FE_PHN955_N241 I=N241
XFE_PHC939_acc_reg_25 DELB $PINS O=FE_PHN939_acc_reg_25 I=acc_reg[25]
XFE_PHC802_N251 DELC $PINS O=FE_PHN802_N251 I=N251
XFE_RC_1842_0 INV1S $PINS O=FE_RN_513_0 I=n37
XFE_RC_1841_0 AN2B1T $PINS O=term1_shifted[5] I1=sll_16/ML_int[3][5]
+ B1=FE_RN_513_0
XFE_RC_1839_0 INV2 $PINS O=FE_RN_512_0 I=sll_18/ML_int[2][4]
XFE_RC_1838_0 MXL2HS $PINS OB=sll_18/ML_int[3][4] S=FE_OFN59_h13_2
+ A=FE_RN_512_0 B=n66
XFE_RC_1835_0 INV2 $PINS O=N157 I=FE_RN_510_0
XFE_RC_1834_0 AOI22H $PINS O=FE_RN_510_0 A1=sign3[0] A2=N130
+ B1=term3_shifted[6] B2=n20
XFE_RC_1821_0 AO22P $PINS O=N42 A1=N15 A2=sign1[0] B1=term1_shifted[1] B2=n40
XFE_RC_1820_0 AN2 $PINS O=term2_shifted[4] I1=sll_17/ML_int[3][4]
+ I2=FE_OFN188_h12_3
XFE_RC_1785_0 AN2B1T $PINS O=term2_shifted[3] I1=sll_17/ML_int[2][3] B1=n58
XFE_RC_1761_0 AN2T $PINS O=term3_shifted[1] I1=sll_18/ML_int[1][1] I2=n2
XCTS_ccl_a_INV_CLK_G1_L8_43 INV3CK $PINS O=CTS_10 I=CTS_11
XCTS_ccl_a_INV_CLK_G1_L7_46 INV4CK $PINS O=CTS_11 I=CTS_12
XFE_RC_1522_0 INV1S $PINS O=FE_RN_352_0 I=sll_17/ML_int[2][4]
XFE_RC_1521_0 MXL2HS $PINS OB=sll_17/ML_int[3][4] S=shf2[2] A=FE_RN_352_0 B=n56
XFE_RC_1477_0 AO22 $PINS O=N100 A1=N73 A2=n29 B1=term2_shifted[4]
+ B2=FE_OFN177_s12_0
XFE_RC_1306_0 OA12 $PINS O=N96 A1=N69 B1=n29 B2=FE_OFN177_s12_0
XFE_RC_1246_0 ND2 $PINS O=FE_RN_240_0 I1=N126 I2=sign3[0]
XFE_RC_1245_0 OR3B1 $PINS O=FE_RN_241_0 I1=n95 I2=n70 B1=n20
XFE_RC_1244_0 ND2 $PINS O=N153 I1=FE_RN_240_0 I2=FE_RN_241_0
XFE_RC_1238_0 ND2 $PINS O=FE_RN_235_0 I1=N17 I2=FE_OFN262_s11_0
XFE_RC_1237_0 OR3B1 $PINS O=FE_RN_236_0 I1=n48 I2=n47 B1=n40
XFE_RC_1236_0 ND2 $PINS O=N44 I1=FE_RN_236_0 I2=FE_RN_235_0
XFE_RC_1234_0 ND2P $PINS O=FE_RN_233_0 I1=n29 I2=N72
XFE_RC_1233_0 OR3B1 $PINS O=FE_RN_234_0 I1=n58 I2=n59 B1=FE_OFN177_s12_0
XFE_RC_1232_0 ND2P $PINS O=N99 I1=FE_RN_234_0 I2=FE_RN_233_0
XFE_RC_1211_0 MUXB2 $PINS O=term2_shifted[2] S=shf2[1] A=sll_17/ML_int[1][2]
+ B=sll_17/ML_int[1][0] EB=n58
XFE_RC_1109_0 INV2 $PINS O=N47 I=FE_RN_179_0
XFE_RC_1108_0 AOI22H $PINS O=FE_RN_179_0 A1=N20 A2=sign1[0] B1=term1_shifted[6]
+ B2=n40
XFE_RC_5_0 OA12 $PINS O=N41 A1=N14 B1=sign1[0] B2=n40
XFE_OFC671_h11_1 INV1S $PINS O=n33 I=shf1[1]
XFE_OFC555_n29 INV2 $PINS O=FE_OFN177_s12_0 I=n29
XFE_OFC445_s11_0 BUF1 $PINS O=FE_OFN262_s11_0 I=sign1[0]
XFE_OFC430_s11_1 INV1S $PINS O=FE_OFN249_s11_1 I=FE_OFN54_s11_1
XFE_OFC428_s11_1 BUF1 $PINS O=n6 I=sign1[1]
XFE_OFC397_h12_1 BUF1 $PINS O=FE_OFN231_h12_1 I=shf2[1]
XFE_OFC395_h12_1 INV1S $PINS O=n24 I=shf2[1]
XFE_OFC393_h12_0 BUF1 $PINS O=FE_OFN229_h12_0 I=shf2[0]
XFE_OFC392_h12_0 INV1S $PINS O=n22 I=shf2[0]
XFE_OFC386_h13_1 INV1S $PINS O=n13 I=shf3[1]
XFE_OFC362_h13_0 INV1S $PINS O=n12 I=shf3[0]
XFE_OFC309_h11_3 INV1S $PINS O=n37 I=shf1[3]
XFE_OFC296_h11_2 INV1S $PINS O=n35 I=shf1[2]
XFE_OFC283_h13_3 INV1S $PINS O=n17 I=shf3[3]
XFE_OFC274_h12_3 INV1S $PINS O=FE_OFN188_h12_3 I=n26
XFE_OFC272_h12_3 BUF1 $PINS O=n26 I=shf2[3]
XFE_OFC249_s12_0 INV1S $PINS O=FE_OFN176_s12_0 I=n29
XFE_OFC247_s12_0 BUF2 $PINS O=n29 I=sign2[0]
XFE_OFC220_s13_0 INV2 $PINS O=FE_OFN162_s13_0 I=sign3[0]
XFE_OFC219_s13_0 INV1S $PINS O=n20 I=sign3[0]
XFE_OFC160_s11_0 INV3 $PINS O=n40 I=sign1[0]
XU110 AO22 $PINS O=base_val[13] A1=acc_reg[13] A2=FE_OFN76_n B1=clear
+ B2=stage_sel
XU112 AO22 $PINS O=N98 A1=N71 A2=n29 B1=term2_shifted[2] B2=FE_OFN177_s12_0
XU115 AO22 $PINS O=N67 A1=sign1[0] A2=N40 B1=term1_shifted[26] B2=n40
XU116 AO22 $PINS O=N66 A1=N39 A2=sign1[0] B1=term1_shifted[25] B2=n40
XU117 AO22 $PINS O=N65 A1=N38 A2=sign1[0] B1=term1_shifted[24] B2=n40
XU118 AO22 $PINS O=N64 A1=N37 A2=sign1[0] B1=term1_shifted[23] B2=n40
XU119 AO22 $PINS O=N63 A1=N36 A2=sign1[0] B1=term1_shifted[22] B2=n40
XU120 AO22 $PINS O=N62 A1=N35 A2=sign1[0] B1=term1_shifted[21] B2=n40
XU122 AO22 $PINS O=N60 A1=N33 A2=sign1[0] B1=term1_shifted[19] B2=n40
XU123 AO22 $PINS O=N59 A1=N32 A2=sign1[0] B1=term1_shifted[18] B2=n40
XU124 AO22 $PINS O=N58 A1=N31 A2=sign1[0] B1=term1_shifted[17] B2=n40
XU125 AO22 $PINS O=N57 A1=N30 A2=sign1[0] B1=term1_shifted[16] B2=n40
XU126 AO22 $PINS O=N56 A1=N29 A2=sign1[0] B1=term1_shifted[15] B2=n40
XU127 AO22 $PINS O=N55 A1=N28 A2=sign1[0] B1=term1_shifted[14] B2=n40
XU128 AO22 $PINS O=N54 A1=N27 A2=sign1[0] B1=term1_shifted[13] B2=n40
XU129 AO22 $PINS O=N53 A1=N26 A2=sign1[0] B1=term1_shifted[12] B2=n40
XU130 AO22 $PINS O=N52 A1=N25 A2=sign1[0] B1=term1_shifted[11] B2=n40
XU131 AO22 $PINS O=N51 A1=N24 A2=FE_OFN262_s11_0 B1=term1_shifted[10] B2=n40
XU133 AO22 $PINS O=N49 A1=N22 A2=FE_OFN262_s11_0 B1=term1_shifted[8] B2=n40
XU142 AO22 $PINS O=N177 A1=sign3[0] A2=N150 B1=term3_shifted[26]
+ B2=FE_OFN162_s13_0
XU143 AO22 $PINS O=N176 A1=N149 A2=sign3[0] B1=term3_shifted[25]
+ B2=FE_OFN162_s13_0
XU144 AO22 $PINS O=N175 A1=N148 A2=sign3[0] B1=term3_shifted[24]
+ B2=FE_OFN162_s13_0
XU145 AO22 $PINS O=N174 A1=N147 A2=sign3[0] B1=term3_shifted[23]
+ B2=FE_OFN162_s13_0
XU146 AO22 $PINS O=N173 A1=N146 A2=sign3[0] B1=term3_shifted[22]
+ B2=FE_OFN162_s13_0
XU147 AO22 $PINS O=N172 A1=N145 A2=sign3[0] B1=term3_shifted[21]
+ B2=FE_OFN162_s13_0
XU149 AO22 $PINS O=N170 A1=N143 A2=sign3[0] B1=term3_shifted[19]
+ B2=FE_OFN162_s13_0
XU150 AO22 $PINS O=N169 A1=N142 A2=sign3[0] B1=term3_shifted[18]
+ B2=FE_OFN162_s13_0
XU151 AO22 $PINS O=N168 A1=N141 A2=sign3[0] B1=term3_shifted[17]
+ B2=FE_OFN162_s13_0
XU152 AO22 $PINS O=N167 A1=N140 A2=sign3[0] B1=term3_shifted[16]
+ B2=FE_OFN162_s13_0
XU153 AO22 $PINS O=N166 A1=N139 A2=sign3[0] B1=term3_shifted[15]
+ B2=FE_OFN162_s13_0
XU154 AO22 $PINS O=N165 A1=N138 A2=sign3[0] B1=term3_shifted[14]
+ B2=FE_OFN162_s13_0
XU155 AO22 $PINS O=N164 A1=N137 A2=sign3[0] B1=term3_shifted[13]
+ B2=FE_OFN162_s13_0
XU156 AO22 $PINS O=N163 A1=N136 A2=sign3[0] B1=term3_shifted[12]
+ B2=FE_OFN162_s13_0
XU157 AO22 $PINS O=N162 A1=N135 A2=sign3[0] B1=term3_shifted[11]
+ B2=FE_OFN162_s13_0
XU158 AO22 $PINS O=N161 A1=N134 A2=sign3[0] B1=term3_shifted[10]
+ B2=FE_OFN162_s13_0
XU160 AO22 $PINS O=N159 A1=N132 A2=sign3[0] B1=term3_shifted[8] B2=n20
XU165 AO22 $PINS O=N154 A1=N127 A2=sign3[0] B1=term3_shifted[3] B2=n20
XU169 AO22 $PINS O=N122 A1=N95 A2=n29 B1=term2_shifted[26] B2=FE_OFN176_s12_0
XU170 AO22 $PINS O=N121 A1=N94 A2=n29 B1=term2_shifted[25] B2=FE_OFN176_s12_0
XU171 AO22 $PINS O=N120 A1=N93 A2=n29 B1=term2_shifted[24] B2=FE_OFN176_s12_0
XU172 AO22 $PINS O=N119 A1=N92 A2=n29 B1=term2_shifted[23] B2=FE_OFN176_s12_0
XU173 AO22 $PINS O=N118 A1=N91 A2=n29 B1=term2_shifted[22] B2=FE_OFN176_s12_0
XU174 AO22 $PINS O=N117 A1=N90 A2=n29 B1=term2_shifted[21] B2=FE_OFN176_s12_0
XU175 AO22 $PINS O=N116 A1=N89 A2=n29 B1=term2_shifted[20] B2=FE_OFN176_s12_0
XU176 AO22 $PINS O=N115 A1=N88 A2=n29 B1=term2_shifted[19] B2=FE_OFN176_s12_0
XU177 AO22 $PINS O=N114 A1=N87 A2=n29 B1=term2_shifted[18] B2=FE_OFN176_s12_0
XU178 AO22 $PINS O=N113 A1=N86 A2=n29 B1=term2_shifted[17] B2=FE_OFN176_s12_0
XU179 AO22 $PINS O=N112 A1=N85 A2=n29 B1=term2_shifted[16] B2=FE_OFN176_s12_0
XU180 AO22 $PINS O=N111 A1=N84 A2=n29 B1=term2_shifted[15] B2=FE_OFN176_s12_0
XU181 AO22 $PINS O=N110 A1=N83 A2=n29 B1=term2_shifted[14] B2=FE_OFN176_s12_0
XU183 AO22 $PINS O=N108 A1=N81 A2=n29 B1=term2_shifted[12] B2=FE_OFN176_s12_0
XU184 AO22 $PINS O=N107 A1=N80 A2=n29 B1=term2_shifted[11] B2=FE_OFN176_s12_0
XU185 AO22 $PINS O=N106 A1=N79 A2=n29 B1=term2_shifted[10] B2=FE_OFN177_s12_0
XU187 AO22 $PINS O=N104 A1=N77 A2=n29 B1=term2_shifted[8] B2=FE_OFN177_s12_0
XU188 AO22 $PINS O=N103 A1=N76 A2=n29 B1=term2_shifted[7] B2=FE_OFN177_s12_0
XU190 AO22 $PINS O=N101 A1=N74 A2=n29 B1=term2_shifted[5] B2=FE_OFN177_s12_0
Xsll_18/M1_0_2 MUX2 $PINS O=sll_18/ML_int[1][2] S=shf3[0] A=term3_in[2]
+ B=term3_in[1]
Xsll_18/M1_0_3 MUX2 $PINS O=sll_18/ML_int[1][3] S=shf3[0] A=term3_in[3]
+ B=term3_in[2]
Xsll_18/M1_0_4 MUX2 $PINS O=sll_18/ML_int[1][4] S=shf3[0] A=term3_in[4]
+ B=term3_in[3]
Xsll_18/M1_0_6 MUX2 $PINS O=sll_18/ML_int[1][6] S=FE_OFN50_h13_0 A=term3_in[6]
+ B=term3_in[5]
Xsll_18/M1_1_2 MUX2 $PINS O=sll_18/ML_int[2][2] S=shf3[1] A=sll_18/ML_int[1][2]
+ B=sll_18/ML_int[1][0]
Xsll_18/M1_1_3 MUX2 $PINS O=sll_18/ML_int[2][3] S=shf3[1] A=sll_18/ML_int[1][3]
+ B=sll_18/ML_int[1][1]
Xsll_18/M1_1_4 MUX2 $PINS O=sll_18/ML_int[2][4] S=FE_OFN62_h13_1
+ A=sll_18/ML_int[1][4] B=sll_18/ML_int[1][2]
Xsll_18/M1_1_5 MUX2 $PINS O=sll_18/ML_int[2][5] S=FE_OFN62_h13_1
+ A=sll_18/ML_int[1][5] B=sll_18/ML_int[1][3]
Xsll_18/M1_1_6 MUX2 $PINS O=sll_18/ML_int[2][6] S=FE_OFN62_h13_1
+ A=sll_18/ML_int[1][6] B=sll_18/ML_int[1][4]
Xsll_18/M1_1_7 MUX2 $PINS O=sll_18/ML_int[2][7] S=FE_OFN62_h13_1
+ A=sll_18/ML_int[1][7] B=sll_18/ML_int[1][5]
Xsll_18/M1_2_5 MUX2 $PINS O=sll_18/ML_int[3][5] S=FE_OFN59_h13_2
+ A=sll_18/ML_int[2][5] B=n72
Xsll_18/M1_2_6 MUX2 $PINS O=sll_18/ML_int[3][6] S=FE_OFN59_h13_2
+ A=sll_18/ML_int[2][6] B=sll_18/ML_int[2][2]
Xsll_18/M1_2_7 MUX2 $PINS O=sll_18/ML_int[3][7] S=FE_OFN59_h13_2
+ A=sll_18/ML_int[2][7] B=sll_18/ML_int[2][3]
Xsll_18/M1_2_8 MUX2 $PINS O=sll_18/ML_int[3][8] S=FE_OFN59_h13_2
+ A=sll_18/ML_int[2][8] B=sll_18/ML_int[2][4]
Xsll_18/M1_2_9 MUX2 $PINS O=sll_18/ML_int[3][9] S=FE_OFN59_h13_2
+ A=sll_18/ML_int[2][9] B=sll_18/ML_int[2][5]
Xsll_18/M1_3_8 MUX2 $PINS O=term3_shifted[8] S=shf3[3] A=sll_18/ML_int[3][8]
+ B=sll_18/ML_int[3][0]
Xsll_18/M1_3_9 MUX2 $PINS O=term3_shifted[9] S=shf3[3] A=sll_18/ML_int[3][9]
+ B=sll_18/ML_int[3][1]
Xsll_18/M1_3_10 MUX2 $PINS O=term3_shifted[10] S=FE_OFN46_h13_3
+ A=sll_18/ML_int[3][10] B=sll_18/ML_int[3][2]
Xsll_18/M1_3_11 MUX2 $PINS O=term3_shifted[11] S=FE_OFN46_h13_3
+ A=sll_18/ML_int[3][11] B=sll_18/ML_int[3][3]
Xsll_18/M1_3_12 MUX2 $PINS O=term3_shifted[12] S=FE_OFN46_h13_3
+ A=sll_18/ML_int[3][12] B=sll_18/ML_int[3][4]
Xsll_18/M1_3_13 MUX2 $PINS O=term3_shifted[13] S=FE_OFN46_h13_3
+ A=sll_18/ML_int[3][13] B=sll_18/ML_int[3][5]
Xsll_17/M1_0_2 MUX2 $PINS O=sll_17/ML_int[1][2] S=shf2[0] A=term2_in[2]
+ B=term2_in[1]
Xsll_17/M1_0_4 MUX2 $PINS O=sll_17/ML_int[1][4] S=FE_OFN229_h12_0 A=term2_in[4]
+ B=term2_in[3]
Xsll_17/M1_0_5 MUX2 $PINS O=sll_17/ML_int[1][5] S=FE_OFN229_h12_0 A=term2_in[5]
+ B=term2_in[4]
Xsll_17/M1_0_6 MUX2 $PINS O=sll_17/ML_int[1][6] S=FE_OFN229_h12_0 A=term2_in[6]
+ B=term2_in[5]
Xsll_17/M1_1_2 MUX2 $PINS O=sll_17/ML_int[2][2] S=shf2[1] A=sll_17/ML_int[1][2]
+ B=sll_17/ML_int[1][0]
Xsll_17/M1_1_3 MUX2 $PINS O=sll_17/ML_int[2][3] S=shf2[1] A=sll_17/ML_int[1][3]
+ B=sll_17/ML_int[1][1]
Xsll_17/M1_1_4 MUX2 $PINS O=sll_17/ML_int[2][4] S=shf2[1] A=sll_17/ML_int[1][4]
+ B=sll_17/ML_int[1][2]
Xsll_17/M1_1_5 MUX2 $PINS O=sll_17/ML_int[2][5] S=shf2[1] A=sll_17/ML_int[1][5]
+ B=sll_17/ML_int[1][3]
Xsll_17/M1_1_6 MUX2 $PINS O=sll_17/ML_int[2][6] S=FE_OFN231_h12_1
+ A=sll_17/ML_int[1][6] B=sll_17/ML_int[1][4]
Xsll_17/M1_1_7 MUX2 $PINS O=sll_17/ML_int[2][7] S=FE_OFN231_h12_1
+ A=sll_17/ML_int[1][7] B=sll_17/ML_int[1][5]
Xsll_17/M1_2_5 MUX2 $PINS O=sll_17/ML_int[3][5] S=shf2[2] A=sll_17/ML_int[2][5]
+ B=n5
Xsll_17/M1_2_6 MUX2 $PINS O=sll_17/ML_int[3][6] S=shf2[2] A=sll_17/ML_int[2][6]
+ B=sll_17/ML_int[2][2]
Xsll_17/M1_2_7 MUX2 $PINS O=sll_17/ML_int[3][7] S=shf2[2] A=sll_17/ML_int[2][7]
+ B=sll_17/ML_int[2][3]
Xsll_17/M1_2_8 MUX2 $PINS O=sll_17/ML_int[3][8] S=shf2[2] A=sll_17/ML_int[2][8]
+ B=sll_17/ML_int[2][4]
Xsll_17/M1_2_9 MUX2 $PINS O=sll_17/ML_int[3][9] S=shf2[2] A=sll_17/ML_int[2][9]
+ B=sll_17/ML_int[2][5]
Xsll_17/M1_3_8 MUX2 $PINS O=term2_shifted[8] S=n26 A=sll_17/ML_int[3][8]
+ B=sll_17/ML_int[3][0]
Xsll_17/M1_3_9 MUX2 $PINS O=term2_shifted[9] S=n26 A=sll_17/ML_int[3][9]
+ B=sll_17/ML_int[3][1]
Xsll_17/M1_3_10 MUX2 $PINS O=term2_shifted[10] S=n26 A=sll_17/ML_int[3][10]
+ B=sll_17/ML_int[3][2]
Xsll_17/M1_3_11 MUX2 $PINS O=term2_shifted[11] S=n26 A=sll_17/ML_int[3][11]
+ B=sll_17/ML_int[3][3]
Xsll_17/M1_3_12 MUX2 $PINS O=term2_shifted[12] S=n26 A=sll_17/ML_int[3][12]
+ B=sll_17/ML_int[3][4]
Xsll_17/M1_3_13 MUX2 $PINS O=term2_shifted[13] S=n26 A=sll_17/ML_int[3][13]
+ B=sll_17/ML_int[3][5]
Xsll_16/M1_0_2 MUX2 $PINS O=sll_16/ML_int[1][2] S=shf1[0] A=term1_in[2]
+ B=term1_in[1]
Xsll_16/M1_0_3 MUX2 $PINS O=sll_16/ML_int[1][3] S=shf1[0] A=term1_in[3]
+ B=term1_in[2]
Xsll_16/M1_0_4 MUX2 $PINS O=sll_16/ML_int[1][4] S=shf1[0] A=term1_in[4]
+ B=term1_in[3]
Xsll_16/M1_0_6 MUX2 $PINS O=sll_16/ML_int[1][6] S=shf1[0] A=term1_in[6]
+ B=term1_in[5]
Xsll_16/M1_1_3 MUX2 $PINS O=sll_16/ML_int[2][3] S=shf1[1] A=sll_16/ML_int[1][3]
+ B=sll_16/ML_int[1][1]
Xsll_16/M1_1_4 MUX2 $PINS O=sll_16/ML_int[2][4] S=shf1[1] A=sll_16/ML_int[1][4]
+ B=sll_16/ML_int[1][2]
Xsll_16/M1_1_5 MUX2 $PINS O=sll_16/ML_int[2][5] S=shf1[1] A=sll_16/ML_int[1][5]
+ B=sll_16/ML_int[1][3]
Xsll_16/M1_1_6 MUX2 $PINS O=sll_16/ML_int[2][6] S=shf1[1] A=sll_16/ML_int[1][6]
+ B=sll_16/ML_int[1][4]
Xsll_16/M1_1_7 MUX2 $PINS O=sll_16/ML_int[2][7] S=shf1[1] A=sll_16/ML_int[1][7]
+ B=sll_16/ML_int[1][5]
Xsll_16/M1_2_4 MUX2 $PINS O=sll_16/ML_int[3][4] S=shf1[2] A=sll_16/ML_int[2][4]
+ B=n50
Xsll_16/M1_2_5 MUX2 $PINS O=sll_16/ML_int[3][5] S=shf1[2] A=sll_16/ML_int[2][5]
+ B=n51
Xsll_16/M1_2_7 MUX2 $PINS O=sll_16/ML_int[3][7] S=shf1[2] A=sll_16/ML_int[2][7]
+ B=sll_16/ML_int[2][3]
Xsll_16/M1_2_8 MUX2 $PINS O=sll_16/ML_int[3][8] S=shf1[2] A=sll_16/ML_int[2][8]
+ B=sll_16/ML_int[2][4]
Xsll_16/M1_2_9 MUX2 $PINS O=sll_16/ML_int[3][9] S=shf1[2] A=sll_16/ML_int[2][9]
+ B=sll_16/ML_int[2][5]
Xsll_16/M1_3_8 MUX2 $PINS O=term1_shifted[8] S=shf1[3] A=sll_16/ML_int[3][8]
+ B=sll_16/ML_int[3][0]
Xsll_16/M1_3_9 MUX2 $PINS O=term1_shifted[9] S=shf1[3] A=sll_16/ML_int[3][9]
+ B=sll_16/ML_int[3][1]
Xsll_16/M1_3_10 MUX2 $PINS O=term1_shifted[10] S=shf1[3] A=sll_16/ML_int[3][10]
+ B=sll_16/ML_int[3][2]
Xsll_16/M1_3_11 MUX2 $PINS O=term1_shifted[11] S=shf1[3] A=sll_16/ML_int[3][11]
+ B=sll_16/ML_int[3][3]
Xsll_16/M1_3_12 MUX2 $PINS O=term1_shifted[12] S=shf1[3] A=sll_16/ML_int[3][12]
+ B=sll_16/ML_int[3][4]
Xsll_16/M1_3_13 MUX2 $PINS O=term1_shifted[13] S=shf1[3] A=sll_16/ML_int[3][13]
+ B=sll_16/ML_int[3][5]
Xy_out_reg[9] QDFFRBN $PINS Q=y_out[9] D=FE_PHN961_N244 CK=CTS_10
+ RB=FE_OFN11_i_rst_n
Xy_out_reg[8] QDFFRBN $PINS Q=y_out[8] D=FE_PHN984_N243 CK=CTS_10
+ RB=FE_OFN11_i_rst_n
Xy_out_reg[7] QDFFRBN $PINS Q=y_out[7] D=FE_PHN979_N242 CK=CTS_10
+ RB=FE_OFN11_i_rst_n
Xy_out_reg[6] QDFFRBN $PINS Q=y_out[6] D=FE_PHN955_N241 CK=CTS_10
+ RB=FE_OFN11_i_rst_n
Xy_out_reg[5] QDFFRBN $PINS Q=y_out[5] D=FE_PHN992_N240 CK=CTS_10
+ RB=FE_OFN11_i_rst_n
Xy_out_reg[4] QDFFRBN $PINS Q=y_out[4] D=FE_PHN1004_N239 CK=CTS_10
+ RB=FE_OFN11_i_rst_n
Xy_out_reg[3] QDFFRBN $PINS Q=y_out[3] D=FE_PHN1006_N238 CK=CTS_10
+ RB=FE_OFN11_i_rst_n
Xy_out_reg[2] QDFFRBN $PINS Q=y_out[2] D=FE_PHN1009_N237 CK=CTS_10
+ RB=FE_OFN11_i_rst_n
Xy_out_reg[1] QDFFRBN $PINS Q=y_out[1] D=FE_PHN1013_N236 CK=CTS_10
+ RB=FE_OFN11_i_rst_n
Xy_out_reg[0] QDFFRBN $PINS Q=y_out[0] D=FE_PHN1011_N235 CK=CTS_10
+ RB=FE_OFN11_i_rst_n
Xacc_reg_reg[26] QDFFRBP $PINS Q=N251 D=next_acc[26] CK=clk_clone2
+ RB=FE_OFN11_i_rst_n
Xacc_reg_reg[25] QDFFRBN $PINS Q=acc_reg[25] D=next_acc[25] CK=clk_clone2
+ RB=FE_OFN11_i_rst_n
Xacc_reg_reg[24] QDFFRBN $PINS Q=acc_reg[24] D=next_acc[24] CK=clk_clone2
+ RB=FE_OFN11_i_rst_n
Xy_out_reg[16] QDFFRBN $PINS Q=y_out[16] D=FE_PHN802_N251 CK=CTS_10
+ RB=FE_OFN11_i_rst_n
Xy_out_reg[11] QDFFRBN $PINS Q=y_out[11] D=FE_PHN1349_N246 CK=CTS_10
+ RB=FE_OFN11_i_rst_n
Xy_out_reg[12] QDFFRBN $PINS Q=y_out[12] D=FE_PHN1305_N247 CK=CTS_10
+ RB=FE_OFN11_i_rst_n
Xy_out_reg[10] QDFFRBN $PINS Q=y_out[10] D=FE_PHN1001_N245 CK=CTS_10
+ RB=FE_OFN11_i_rst_n
Xacc_reg_reg[23] QDFFRBN $PINS Q=acc_reg[23] D=next_acc[23] CK=clk_clone2
+ RB=FE_OFN11_i_rst_n
Xy_out_reg[14] QDFFRBN $PINS Q=y_out[14] D=FE_PHN1333_N249 CK=CTS_10
+ RB=FE_OFN11_i_rst_n
Xy_out_reg[15] QDFFRBN $PINS Q=y_out[15] D=N250 CK=CTS_10 RB=FE_OFN11_i_rst_n
Xy_out_reg[13] QDFFRBN $PINS Q=y_out[13] D=FE_PHN1339_N248 CK=CTS_10
+ RB=FE_OFN11_i_rst_n
Xacc_reg_reg[22] QDFFRBN $PINS Q=acc_reg[22] D=next_acc[22] CK=clk_clone2
+ RB=FE_OFN11_i_rst_n
Xacc_reg_reg[21] QDFFRBN $PINS Q=acc_reg[21] D=next_acc[21] CK=clk_clone2
+ RB=FE_OFN11_i_rst_n
Xacc_reg_reg[20] QDFFRBN $PINS Q=acc_reg[20] D=next_acc[20] CK=clk RB=i_rst_n
Xacc_reg_reg[19] QDFFRBN $PINS Q=acc_reg[19] D=next_acc[19] CK=clk RB=i_rst_n
Xacc_reg_reg[18] QDFFRBN $PINS Q=acc_reg[18] D=next_acc[18] CK=clk RB=i_rst_n
Xacc_reg_reg[17] QDFFRBN $PINS Q=acc_reg[17] D=next_acc[17] CK=clk RB=i_rst_n
Xacc_reg_reg[16] QDFFRBN $PINS Q=acc_reg[16] D=next_acc[16] CK=clk RB=i_rst_n
Xacc_reg_reg[15] QDFFRBN $PINS Q=acc_reg[15] D=next_acc[15] CK=clk RB=i_rst_n
Xacc_reg_reg[14] QDFFRBN $PINS Q=acc_reg[14] D=next_acc[14] CK=clk RB=i_rst_n
Xacc_reg_reg[13] QDFFRBN $PINS Q=acc_reg[13] D=next_acc[13] CK=clk RB=i_rst_n
Xacc_reg_reg[12] QDFFRBN $PINS Q=acc_reg[12] D=next_acc[12] CK=clk RB=i_rst_n
Xacc_reg_reg[11] QDFFRBN $PINS Q=acc_reg[11] D=next_acc[11] CK=clk RB=i_rst_n
Xacc_reg_reg[10] QDFFRBN $PINS Q=acc_reg[10] D=next_acc[10] CK=clk RB=i_rst_n
Xacc_reg_reg[9] QDFFRBN $PINS Q=acc_reg[9] D=next_acc[9] CK=clk RB=i_rst_n
Xacc_reg_reg[8] QDFFRBN $PINS Q=acc_reg[8] D=next_acc[8] CK=clk RB=i_rst_n
Xacc_reg_reg[7] QDFFRBN $PINS Q=acc_reg[7] D=next_acc[7] CK=clk RB=i_rst_n
Xacc_reg_reg[6] QDFFRBN $PINS Q=acc_reg[6] D=next_acc[6] CK=clk RB=i_rst_n
Xacc_reg_reg[5] QDFFRBN $PINS Q=acc_reg[5] D=next_acc[5] CK=clk RB=i_rst_n
Xacc_reg_reg[4] QDFFRBN $PINS Q=acc_reg[4] D=next_acc[4] CK=clk RB=i_rst_n
Xacc_reg_reg[3] QDFFRBN $PINS Q=acc_reg[3] D=next_acc[3] CK=clk RB=i_rst_n
Xacc_reg_reg[2] QDFFRBN $PINS Q=acc_reg[2] D=next_acc[2] CK=clk RB=i_rst_n
Xacc_reg_reg[1] QDFFRBN $PINS Q=acc_reg[1] D=next_acc[1] CK=clk RB=i_rst_n
Xacc_reg_reg[0] QDFFRBS $PINS Q=acc_reg[0] D=FE_PHN1050_next_acc_0 CK=clk
+ RB=i_rst_n
XU3 MUX2 $PINS O=sll_17/ML_int[1][3] S=shf2[0] A=term2_in[3] B=term2_in[2]
XU4 AN2S $PINS O=sll_17/ML_int[1][0] I1=term2_in[0] I2=n22
XU10 MUX2 $PINS O=sll_16/ML_int[3][6] S=shf1[2] A=sll_16/ML_int[2][6]
+ B=sll_16/ML_int[2][2]
XU19 AO22 $PINS O=N151 A1=N124 A2=sign3[0] B1=n8 B2=FE_OFN162_s13_0
XU23 MUX2 $PINS O=N248 S=stage_sel A=acc_reg[23] B=FE_PHN802_N251
XU25 ND2P $PINS O=n46 I1=sll_16/ML_int[1][1] I2=n33
XU26 OR2 $PINS O=n58 I1=shf2[2] I2=n26
XU27 AN2 $PINS O=base_val[6] I1=acc_reg[6] I2=FE_OFN76_n
XU28 MUX2 $PINS O=N250 S=stage_sel A=FE_PHN939_acc_reg_25 B=FE_PHN802_N251
XU29 AN2 $PINS O=sll_18/ML_int[1][0] I1=n12 I2=term3_in[0]
XU30 AN2 $PINS O=base_val[7] I1=acc_reg[7] I2=FE_OFN76_n
XU31 MUX2 $PINS O=N249 S=stage_sel A=acc_reg[24] B=FE_PHN802_N251
XU33 NR2 $PINS O=term1_shifted[3] I1=n48 I2=n47
XU34 INV2 $PINS O=n48 I=sll_16/ML_int[2][3]
XU35 MUX2 $PINS O=N247 S=stage_sel A=acc_reg[22] B=FE_PHN802_N251
XU43 AN2 $PINS O=term1_in[3] I1=FE_OFN41_mac_in_imag_3 I2=FE_OFN249_s11_1
XU46 NR2 $PINS O=term1_in[0] I1=n6 I2=FE_OFN346_mac_in_imag_0
XU47 MUX2 $PINS O=sll_17/ML_int[1][1] S=shf2[0] A=term2_in[1] B=term2_in[0]
XU49 AO22 $PINS O=N152 A1=N125 A2=sign3[0] B1=term3_shifted[1]
+ B2=FE_OFN162_s13_0
XU52 INV1S $PINS O=n59 I=sll_17/ML_int[2][3]
XU54 MUX2 $PINS O=sll_18/ML_int[1][5] S=shf3[0] A=term3_in[5] B=term3_in[4]
XU55 MUX2 $PINS O=sll_16/ML_int[1][5] S=shf1[0] A=term1_in[5] B=term1_in[4]
XU57 INV2 $PINS O=n3 I=sll_17/ML_int[1][1]
XU58 NR2 $PINS O=term3_in[0] I1=sign3[1] I2=FE_OFN346_mac_in_imag_0
XU59 AO22 $PINS O=N61 A1=N34 A2=sign1[0] B1=term1_shifted[20] B2=n40
XU60 AO22 $PINS O=N171 A1=N144 A2=sign3[0] B1=term3_shifted[20]
+ B2=FE_OFN162_s13_0
XU64 NR2 $PINS O=term2_in[1] I1=sign2[1] I2=x_in[1]
XU65 NR2T $PINS O=term1_in[1] I1=n6 I2=x_in[1]
XU67 MUX2 $PINS O=sll_16/ML_int[1][1] S=shf1[0] A=term1_in[1] B=term1_in[0]
XU68 INV1S $PINS O=n57 I=n5
XU72 AN2 $PINS O=base_val[4] I1=acc_reg[4] I2=FE_OFN76_n
XU74 AO22 $PINS O=N45 A1=N18 A2=sign1[0] B1=term1_shifted[4] B2=n40
XU75 NR2P $PINS O=term3_shifted[2] I1=n95 I2=n70
XU78 NR2 $PINS O=n2 I1=shf3[1] I2=n95
XU82 MUX2 $PINS O=sll_18/ML_int[1][1] S=n12 A=term3_in[0] B=term3_in[1]
XU83 OR2 $PINS O=n4 I1=n58 I2=shf2[1]
XU84 NR2 $PINS O=n5 I1=n3 I2=shf2[1]
XU85 AO22 $PINS O=N155 A1=sign3[0] A2=N128 B1=term3_shifted[4] B2=n20
XU89 AO22 $PINS O=N158 A1=N131 A2=sign3[0] B1=term3_shifted[7] B2=n20
XU90 AO22 $PINS O=N46 A1=N19 A2=sign1[0] B1=term1_shifted[5] B2=n40
XU91 AO22 $PINS O=N156 A1=N129 A2=sign3[0] B1=term3_shifted[5] B2=n20
XU92 AO22 $PINS O=N102 A1=N75 A2=n29 B1=term2_shifted[6] B2=FE_OFN177_s12_0
XU93 AO22 $PINS O=N48 A1=N21 A2=FE_OFN262_s11_0 B1=term1_shifted[7] B2=n40
XU94 AO22 $PINS O=N105 A1=N78 A2=n29 B1=term2_shifted[9] B2=FE_OFN177_s12_0
XU95 AO22 $PINS O=N97 A1=N70 A2=n29 B1=term2_shifted[1] B2=FE_OFN177_s12_0
XU96 AO22 $PINS O=N50 A1=N23 A2=FE_OFN262_s11_0 B1=term1_shifted[9] B2=n40
XU97 AO22 $PINS O=N160 A1=N133 A2=sign3[0] B1=term3_shifted[9] B2=n20
XU101 ND2S $PINS O=n66 I1=sll_18/ML_int[1][0] I2=n13
XU102 MUX2S $PINS O=sll_16/ML_int[1][8] S=shf1[0] A=term1_in[8] B=term1_in[7]
XU103 MUX2S $PINS O=sll_18/ML_int[1][8] S=FE_OFN50_h13_0 A=term3_in[8]
+ B=term3_in[7]
XU104 MUX2S $PINS O=sll_17/ML_int[1][8] S=FE_OFN229_h12_0 A=term2_in[8]
+ B=term2_in[7]
XU105 NR2 $PINS O=n8 I1=n95 I2=n66
XU106 AN2 $PINS O=base_val[0] I1=acc_reg[0] I2=FE_OFN76_n
XU107 MUX2S $PINS O=sll_16/ML_int[1][7] S=shf1[0] A=term1_in[7] B=term1_in[6]
XU108 MUX2S $PINS O=sll_18/ML_int[1][7] S=FE_OFN50_h13_0 A=term3_in[7]
+ B=term3_in[6]
XU109 MUX2S $PINS O=sll_17/ML_int[1][7] S=FE_OFN229_h12_0 A=term2_in[7]
+ B=term2_in[6]
XU111 MUX2S $PINS O=sll_18/ML_int[2][8] S=FE_OFN62_h13_1 A=sll_18/ML_int[1][8]
+ B=sll_18/ML_int[1][6]
XU113 MUX2S $PINS O=sll_16/ML_int[2][8] S=shf1[1] A=sll_16/ML_int[1][8]
+ B=sll_16/ML_int[1][6]
XU121 MUX2S $PINS O=sll_17/ML_int[2][8] S=FE_OFN231_h12_1 A=sll_17/ML_int[1][8]
+ B=sll_17/ML_int[1][6]
XU132 MUX2S $PINS O=sll_18/ML_int[2][9] S=FE_OFN62_h13_1 A=sll_18/ML_int[1][9]
+ B=sll_18/ML_int[1][7]
XU134 MUX2S $PINS O=sll_18/ML_int[1][9] S=FE_OFN50_h13_0 A=term3_in[9]
+ B=term3_in[8]
XU136 MUX2S $PINS O=sll_16/ML_int[2][9] S=shf1[1] A=sll_16/ML_int[1][9]
+ B=sll_16/ML_int[1][7]
XU137 MUX2S $PINS O=sll_16/ML_int[1][9] S=shf1[0] A=term1_in[9] B=term1_in[8]
XU138 MUX2S $PINS O=sll_17/ML_int[2][9] S=FE_OFN231_h12_1 A=sll_17/ML_int[1][9]
+ B=sll_17/ML_int[1][7]
XU139 MUX2S $PINS O=sll_17/ML_int[1][9] S=FE_OFN229_h12_0 A=term2_in[9]
+ B=term2_in[8]
XU140 MUX2S $PINS O=sll_16/ML_int[3][10] S=shf1[2] A=sll_16/ML_int[2][10]
+ B=sll_16/ML_int[2][6]
XU141 MUX2S $PINS O=sll_16/ML_int[2][10] S=shf1[1] A=sll_16/ML_int[1][10]
+ B=sll_16/ML_int[1][8]
XU148 MUX2S $PINS O=sll_16/ML_int[1][10] S=shf1[0] A=term1_in[10] B=term1_in[9]
XU159 MUX2S $PINS O=sll_18/ML_int[3][10] S=FE_OFN59_h13_2
+ A=sll_18/ML_int[2][10] B=sll_18/ML_int[2][6]
XU161 MUX2S $PINS O=sll_18/ML_int[2][10] S=FE_OFN62_h13_1
+ A=sll_18/ML_int[1][10] B=sll_18/ML_int[1][8]
XU163 MUX2S $PINS O=sll_18/ML_int[1][10] S=FE_OFN50_h13_0 A=term3_in[10]
+ B=term3_in[9]
XU164 MUX2S $PINS O=sll_17/ML_int[3][10] S=shf2[2] A=sll_17/ML_int[2][10]
+ B=sll_17/ML_int[2][6]
XU167 MUX2S $PINS O=sll_17/ML_int[2][10] S=FE_OFN231_h12_1
+ A=sll_17/ML_int[1][10] B=sll_17/ML_int[1][8]
XU168 MUX2S $PINS O=sll_17/ML_int[1][10] S=FE_OFN229_h12_0 A=term2_in[10]
+ B=term2_in[9]
XU182 MUX2S $PINS O=sll_16/ML_int[3][11] S=shf1[2] A=sll_16/ML_int[2][11]
+ B=sll_16/ML_int[2][7]
XU186 MUX2S $PINS O=sll_16/ML_int[2][11] S=shf1[1] A=sll_16/ML_int[1][11]
+ B=sll_16/ML_int[1][9]
XU189 MUX2S $PINS O=sll_16/ML_int[1][11] S=shf1[0] A=term1_in[11]
+ B=term1_in[10]
XU191 MUX2S $PINS O=sll_18/ML_int[3][11] S=FE_OFN59_h13_2
+ A=sll_18/ML_int[2][11] B=sll_18/ML_int[2][7]
XU192 MUX2S $PINS O=sll_18/ML_int[2][11] S=FE_OFN62_h13_1
+ A=sll_18/ML_int[1][11] B=sll_18/ML_int[1][9]
XU193 MUX2S $PINS O=sll_18/ML_int[1][11] S=FE_OFN50_h13_0 A=term3_in[11]
+ B=term3_in[10]
XU194 MUX2S $PINS O=sll_17/ML_int[3][11] S=shf2[2] A=sll_17/ML_int[2][11]
+ B=sll_17/ML_int[2][7]
XU195 MUX2S $PINS O=sll_17/ML_int[2][11] S=FE_OFN231_h12_1
+ A=sll_17/ML_int[1][11] B=sll_17/ML_int[1][9]
XU196 MUX2S $PINS O=sll_17/ML_int[1][11] S=FE_OFN229_h12_0 A=term2_in[11]
+ B=term2_in[10]
XU197 MUX2S $PINS O=sll_16/ML_int[3][12] S=shf1[2] A=sll_16/ML_int[2][12]
+ B=sll_16/ML_int[2][8]
XU198 MUX2S $PINS O=sll_16/ML_int[2][12] S=shf1[1] A=sll_16/ML_int[1][12]
+ B=sll_16/ML_int[1][10]
XU199 MUX2S $PINS O=sll_16/ML_int[1][12] S=shf1[0] A=term1_in[12]
+ B=term1_in[11]
XU200 MUX2S $PINS O=sll_18/ML_int[3][12] S=FE_OFN59_h13_2
+ A=sll_18/ML_int[2][12] B=sll_18/ML_int[2][8]
XU201 MUX2S $PINS O=sll_18/ML_int[2][12] S=FE_OFN62_h13_1
+ A=sll_18/ML_int[1][12] B=sll_18/ML_int[1][10]
XU202 MUX2S $PINS O=sll_18/ML_int[1][12] S=FE_OFN50_h13_0 A=term3_in[12]
+ B=term3_in[11]
XU203 MUX2S $PINS O=sll_17/ML_int[3][12] S=shf2[2] A=sll_17/ML_int[2][12]
+ B=sll_17/ML_int[2][8]
XU204 MUX2S $PINS O=sll_17/ML_int[2][12] S=FE_OFN231_h12_1
+ A=sll_17/ML_int[1][12] B=sll_17/ML_int[1][10]
XU205 MUX2S $PINS O=sll_17/ML_int[1][12] S=FE_OFN229_h12_0 A=term2_in[12]
+ B=term2_in[11]
XU206 MUX2S $PINS O=sll_16/ML_int[3][13] S=shf1[2] A=sll_16/ML_int[2][13]
+ B=sll_16/ML_int[2][9]
XU207 MUX2S $PINS O=sll_16/ML_int[2][13] S=shf1[1] A=sll_16/ML_int[1][13]
+ B=sll_16/ML_int[1][11]
XU208 MUX2S $PINS O=sll_16/ML_int[1][13] S=shf1[0] A=term1_in[13]
+ B=term1_in[12]
XU209 MUX2S $PINS O=sll_18/ML_int[3][13] S=FE_OFN59_h13_2
+ A=sll_18/ML_int[2][13] B=sll_18/ML_int[2][9]
XU210 MUX2S $PINS O=sll_18/ML_int[2][13] S=FE_OFN62_h13_1
+ A=sll_18/ML_int[1][13] B=sll_18/ML_int[1][11]
XU211 MUX2S $PINS O=sll_18/ML_int[1][13] S=FE_OFN50_h13_0 A=term3_in[13]
+ B=term3_in[12]
XU212 MUX2S $PINS O=sll_17/ML_int[3][13] S=shf2[2] A=sll_17/ML_int[2][13]
+ B=sll_17/ML_int[2][9]
XU213 MUX2S $PINS O=sll_17/ML_int[2][13] S=FE_OFN231_h12_1
+ A=sll_17/ML_int[1][13] B=sll_17/ML_int[1][11]
XU214 MUX2S $PINS O=sll_17/ML_int[1][13] S=FE_OFN229_h12_0 A=term2_in[13]
+ B=term2_in[12]
XU215 MUX2S $PINS O=term1_shifted[14] S=shf1[3] A=sll_16/ML_int[3][14]
+ B=sll_16/ML_int[3][6]
XU216 MUX2S $PINS O=sll_16/ML_int[3][14] S=shf1[2] A=sll_16/ML_int[2][14]
+ B=sll_16/ML_int[2][10]
XU217 MUX2S $PINS O=sll_16/ML_int[2][14] S=shf1[1] A=sll_16/ML_int[1][14]
+ B=sll_16/ML_int[1][12]
XU218 MUX2S $PINS O=sll_16/ML_int[1][14] S=shf1[0] A=term1_in[14]
+ B=term1_in[13]
XU219 MUX2S $PINS O=term3_shifted[14] S=FE_OFN46_h13_3 A=sll_18/ML_int[3][14]
+ B=sll_18/ML_int[3][6]
XU220 MUX2S $PINS O=sll_18/ML_int[3][14] S=FE_OFN59_h13_2
+ A=sll_18/ML_int[2][14] B=sll_18/ML_int[2][10]
XU221 MUX2S $PINS O=sll_18/ML_int[2][14] S=FE_OFN62_h13_1
+ A=sll_18/ML_int[1][14] B=sll_18/ML_int[1][12]
XU222 MUX2S $PINS O=sll_18/ML_int[1][14] S=FE_OFN50_h13_0 A=term3_in[14]
+ B=term3_in[13]
XU223 MUX2S $PINS O=term2_shifted[14] S=n26 A=sll_17/ML_int[3][14]
+ B=sll_17/ML_int[3][6]
XU224 MUX2S $PINS O=sll_17/ML_int[3][14] S=shf2[2] A=sll_17/ML_int[2][14]
+ B=sll_17/ML_int[2][10]
XU225 MUX2S $PINS O=sll_17/ML_int[2][14] S=FE_OFN231_h12_1
+ A=sll_17/ML_int[1][14] B=sll_17/ML_int[1][12]
XU226 MUX2S $PINS O=sll_17/ML_int[1][14] S=FE_OFN229_h12_0 A=term2_in[14]
+ B=term2_in[13]
XU227 MUX2S $PINS O=term1_shifted[16] S=shf1[3] A=sll_16/ML_int[3][16]
+ B=sll_16/ML_int[3][8]
XU228 MUX2S $PINS O=sll_16/ML_int[3][16] S=shf1[2] A=n52 B=sll_16/ML_int[2][12]
XU229 MUX2S $PINS O=n52 S=shf1[1] A=n55 B=sll_16/ML_int[1][14]
XU230 MUX2S $PINS O=term3_shifted[16] S=FE_OFN46_h13_3 A=sll_18/ML_int[3][16]
+ B=sll_18/ML_int[3][8]
XU231 MUX2S $PINS O=sll_18/ML_int[3][16] S=FE_OFN59_h13_2 A=n73
+ B=sll_18/ML_int[2][12]
XU232 MUX2S $PINS O=n73 S=FE_OFN62_h13_1 A=n76 B=sll_18/ML_int[1][14]
XU233 MUX2S $PINS O=n62 S=FE_OFN231_h12_1 A=n65 B=sll_17/ML_int[1][14]
XU234 MUX2S $PINS O=term2_shifted[16] S=n26 A=sll_17/ML_int[3][16]
+ B=sll_17/ML_int[3][8]
XU235 MUX2S $PINS O=sll_17/ML_int[3][16] S=shf2[2] A=n62 B=sll_17/ML_int[2][12]
XU236 MUX2S $PINS O=term1_shifted[15] S=shf1[3] A=sll_16/ML_int[3][15]
+ B=sll_16/ML_int[3][7]
XU237 MUX2S $PINS O=sll_16/ML_int[3][15] S=shf1[2] A=sll_16/ML_int[2][15]
+ B=sll_16/ML_int[2][11]
XU238 MUX2S $PINS O=sll_16/ML_int[2][15] S=shf1[1] A=sll_16/ML_int[1][15]
+ B=sll_16/ML_int[1][13]
XU239 MUX2S $PINS O=sll_16/ML_int[1][15] S=shf1[0] A=term1_in[15]
+ B=term1_in[14]
XU240 MUX2S $PINS O=term3_shifted[15] S=FE_OFN46_h13_3 A=sll_18/ML_int[3][15]
+ B=sll_18/ML_int[3][7]
XU241 MUX2S $PINS O=sll_18/ML_int[3][15] S=FE_OFN59_h13_2
+ A=sll_18/ML_int[2][15] B=sll_18/ML_int[2][11]
XU242 MUX2S $PINS O=sll_18/ML_int[2][15] S=FE_OFN62_h13_1
+ A=sll_18/ML_int[1][15] B=sll_18/ML_int[1][13]
XU243 MUX2S $PINS O=sll_18/ML_int[1][15] S=FE_OFN50_h13_0 A=term3_in[15]
+ B=term3_in[14]
XU244 MUX2S $PINS O=term2_shifted[15] S=n26 A=sll_17/ML_int[3][15]
+ B=sll_17/ML_int[3][7]
XU245 MUX2S $PINS O=sll_17/ML_int[3][15] S=shf2[2] A=sll_17/ML_int[2][15]
+ B=sll_17/ML_int[2][11]
XU246 MUX2S $PINS O=sll_17/ML_int[2][15] S=FE_OFN231_h12_1
+ A=sll_17/ML_int[1][15] B=sll_17/ML_int[1][13]
XU247 MUX2S $PINS O=sll_17/ML_int[1][15] S=FE_OFN229_h12_0 A=term2_in[15]
+ B=term2_in[14]
XU248 MUX2S $PINS O=term1_shifted[17] S=shf1[3] A=sll_16/ML_int[3][17]
+ B=sll_16/ML_int[3][9]
XU249 MUX2S $PINS O=n53 S=shf1[1] A=term1_in[26] B=sll_16/ML_int[1][15]
XU250 MUX2S $PINS O=sll_16/ML_int[3][17] S=shf1[2] A=n53 B=sll_16/ML_int[2][13]
XU251 MUX2S $PINS O=term3_shifted[17] S=FE_OFN46_h13_3 A=sll_18/ML_int[3][17]
+ B=sll_18/ML_int[3][9]
XU252 MUX2S $PINS O=n74 S=FE_OFN62_h13_1 A=term3_in[26] B=sll_18/ML_int[1][15]
XU253 MUX2S $PINS O=sll_18/ML_int[3][17] S=FE_OFN59_h13_2 A=n74
+ B=sll_18/ML_int[2][13]
XU254 MUX2S $PINS O=term2_shifted[17] S=n26 A=sll_17/ML_int[3][17]
+ B=sll_17/ML_int[3][9]
XU255 MUX2S $PINS O=n63 S=FE_OFN231_h12_1 A=term2_in[26] B=sll_17/ML_int[1][15]
XU256 MUX2S $PINS O=sll_17/ML_int[3][17] S=shf2[2] A=n63 B=sll_17/ML_int[2][13]
XU257 MUX2S $PINS O=term1_shifted[18] S=shf1[3] A=sll_16/ML_int[3][18]
+ B=sll_16/ML_int[3][10]
XU258 MUX2S $PINS O=sll_16/ML_int[3][18] S=shf1[2] A=n54 B=sll_16/ML_int[2][14]
XU259 MUX2S $PINS O=n54 S=shf1[1] A=term1_in[26] B=n55
XU260 MUX2S $PINS O=term3_shifted[18] S=FE_OFN46_h13_3 A=sll_18/ML_int[3][18]
+ B=sll_18/ML_int[3][10]
XU261 MUX2S $PINS O=sll_18/ML_int[3][18] S=FE_OFN59_h13_2 A=n75
+ B=sll_18/ML_int[2][14]
XU262 MUX2S $PINS O=n75 S=FE_OFN62_h13_1 A=term3_in[26] B=n76
XU263 MUX2S $PINS O=term2_shifted[18] S=n26 A=sll_17/ML_int[3][18]
+ B=sll_17/ML_int[3][10]
XU264 MUX2S $PINS O=sll_17/ML_int[3][18] S=shf2[2] A=n64 B=sll_17/ML_int[2][14]
XU265 MUX2S $PINS O=n64 S=FE_OFN231_h12_1 A=term2_in[26] B=n65
XU266 MUX2S $PINS O=term1_shifted[20] S=shf1[3] A=sll_16/ML_int[3][20]
+ B=sll_16/ML_int[3][12]
XU267 MUX2S $PINS O=sll_16/ML_int[3][20] S=shf1[2] A=term1_in[26] B=n52
XU268 MUX2S $PINS O=term1_shifted[19] S=shf1[3] A=sll_16/ML_int[3][19]
+ B=sll_16/ML_int[3][11]
XU269 MUX2S $PINS O=sll_16/ML_int[3][19] S=shf1[2] A=term1_in[26]
+ B=sll_16/ML_int[2][15]
XU270 MUX2S $PINS O=term3_shifted[20] S=FE_OFN46_h13_3 A=sll_18/ML_int[3][20]
+ B=sll_18/ML_int[3][12]
XU271 MUX2S $PINS O=sll_18/ML_int[3][20] S=FE_OFN59_h13_2 A=term3_in[26] B=n73
XU272 MUX2S $PINS O=term3_shifted[19] S=FE_OFN46_h13_3 A=sll_18/ML_int[3][19]
+ B=sll_18/ML_int[3][11]
XU273 MUX2S $PINS O=sll_18/ML_int[3][19] S=FE_OFN59_h13_2 A=term3_in[26]
+ B=sll_18/ML_int[2][15]
XU274 MUX2S $PINS O=term2_shifted[20] S=n26 A=sll_17/ML_int[3][20]
+ B=sll_17/ML_int[3][12]
XU275 MUX2S $PINS O=sll_17/ML_int[3][20] S=shf2[2] A=term2_in[26] B=n62
XU276 MUX2S $PINS O=term2_shifted[19] S=n26 A=sll_17/ML_int[3][19]
+ B=sll_17/ML_int[3][11]
XU277 MUX2S $PINS O=sll_17/ML_int[3][19] S=shf2[2] A=term2_in[26]
+ B=sll_17/ML_int[2][15]
XU278 MUX2S $PINS O=term1_shifted[21] S=shf1[3] A=sll_16/ML_int[3][21]
+ B=sll_16/ML_int[3][13]
XU279 MUX2S $PINS O=sll_16/ML_int[3][21] S=shf1[2] A=term1_in[26] B=n53
XU280 MUX2S $PINS O=term3_shifted[21] S=FE_OFN46_h13_3 A=sll_18/ML_int[3][21]
+ B=sll_18/ML_int[3][13]
XU281 MUX2S $PINS O=sll_18/ML_int[3][21] S=FE_OFN59_h13_2 A=term3_in[26] B=n74
XU282 MUX2S $PINS O=term2_shifted[21] S=n26 A=sll_17/ML_int[3][21]
+ B=sll_17/ML_int[3][13]
XU283 MUX2S $PINS O=sll_17/ML_int[3][21] S=shf2[2] A=term2_in[26] B=n63
XU284 MUX2S $PINS O=term1_shifted[22] S=shf1[3] A=sll_16/ML_int[3][22]
+ B=sll_16/ML_int[3][14]
XU285 MUX2S $PINS O=sll_16/ML_int[3][22] S=shf1[2] A=term1_in[26] B=n54
XU286 MUX2S $PINS O=term3_shifted[22] S=FE_OFN46_h13_3 A=sll_18/ML_int[3][22]
+ B=sll_18/ML_int[3][14]
XU287 MUX2S $PINS O=sll_18/ML_int[3][22] S=FE_OFN59_h13_2 A=term3_in[26] B=n75
XU288 MUX2S $PINS O=term2_shifted[22] S=n26 A=sll_17/ML_int[3][22]
+ B=sll_17/ML_int[3][14]
XU289 MUX2S $PINS O=sll_17/ML_int[3][22] S=shf2[2] A=term2_in[26] B=n64
XU290 MUX2S $PINS O=term1_shifted[24] S=shf1[3] A=term1_in[26]
+ B=sll_16/ML_int[3][16]
XU291 MUX2S $PINS O=term3_shifted[24] S=FE_OFN46_h13_3 A=term3_in[26]
+ B=sll_18/ML_int[3][16]
XU292 MUX2S $PINS O=term2_shifted[24] S=n26 A=term2_in[26]
+ B=sll_17/ML_int[3][16]
XU293 MUX2S $PINS O=term1_shifted[23] S=shf1[3] A=term1_in[26]
+ B=sll_16/ML_int[3][15]
XU294 MUX2S $PINS O=term3_shifted[23] S=FE_OFN46_h13_3 A=term3_in[26]
+ B=sll_18/ML_int[3][15]
XU295 MUX2S $PINS O=term2_shifted[23] S=n26 A=term2_in[26]
+ B=sll_17/ML_int[3][15]
XU296 MUX2S $PINS O=term1_shifted[25] S=shf1[3] A=term1_in[26]
+ B=sll_16/ML_int[3][17]
XU297 MUX2S $PINS O=term3_shifted[25] S=FE_OFN46_h13_3 A=term3_in[26]
+ B=sll_18/ML_int[3][17]
XU298 MUX2S $PINS O=term2_shifted[25] S=n26 A=term2_in[26]
+ B=sll_17/ML_int[3][17]
XU299 MUX2S $PINS O=term1_shifted[26] S=shf1[3] A=term1_in[26]
+ B=sll_16/ML_int[3][18]
XU300 MUX2S $PINS O=term3_shifted[26] S=FE_OFN46_h13_3 A=term3_in[26]
+ B=sll_18/ML_int[3][18]
XU301 MUX2S $PINS O=term2_shifted[26] S=n26 A=term2_in[26]
+ B=sll_17/ML_int[3][18]
XU303 AO22 $PINS O=N109 A1=N82 A2=n29 B1=term2_shifted[13] B2=FE_OFN176_s12_0
XU304 MUX2S $PINS O=N235 S=stage_sel A=acc_reg[10] B=acc_reg[14]
XU305 MUX2S $PINS O=N236 S=stage_sel A=acc_reg[11] B=acc_reg[15]
XU306 MUX2S $PINS O=N237 S=stage_sel A=acc_reg[12] B=acc_reg[16]
XU307 MUX2S $PINS O=N238 S=stage_sel A=acc_reg[13] B=acc_reg[17]
XU308 MUX2S $PINS O=N239 S=stage_sel A=acc_reg[14] B=acc_reg[18]
XU309 MUX2S $PINS O=N240 S=stage_sel A=acc_reg[15] B=acc_reg[19]
XU310 MUX2S $PINS O=N242 S=stage_sel A=acc_reg[17] B=acc_reg[21]
XU311 MUX2S $PINS O=N245 S=stage_sel A=acc_reg[20] B=acc_reg[24]
XU312 MUX2S $PINS O=N246 S=stage_sel A=acc_reg[21] B=FE_PHN939_acc_reg_25
XU313 INV2 $PINS O=n70 I=sll_18/ML_int[2][2]
XU315 INV1S $PINS O=n50 I=n45
XU318 INV1S $PINS O=n51 I=n46
XU319 INV1S $PINS O=n72 I=n67
XU320 NR2 $PINS O=term3_in[1] I1=sign3[1] I2=x_in[1]
XU322 NR2T $PINS O=term3_in[3] I1=sign3[1] I2=x_in[3]
XU323 NR2 $PINS O=term3_in[4] I1=sign3[1] I2=x_in[4]
XU324 NR2 $PINS O=term2_in[3] I1=sign2[1] I2=x_in[3]
XU325 NR2 $PINS O=term2_in[4] I1=sign2[1] I2=x_in[4]
XU326 NR2 $PINS O=term1_in[5] I1=n6 I2=x_in[5]
XU327 NR2 $PINS O=term3_in[5] I1=sign3[1] I2=x_in[5]
XU328 NR2 $PINS O=term2_in[5] I1=sign2[1] I2=x_in[5]
XU329 NR2 $PINS O=term1_in[6] I1=n6 I2=x_in[6]
XU330 NR2 $PINS O=term3_in[6] I1=sign3[1] I2=x_in[6]
XU331 NR2 $PINS O=term2_in[6] I1=sign2[1] I2=x_in[6]
XU332 NR2 $PINS O=term1_in[7] I1=n6 I2=x_in[7]
XU333 NR2 $PINS O=term3_in[7] I1=sign3[1] I2=x_in[7]
XU334 NR2 $PINS O=term2_in[7] I1=sign2[1] I2=x_in[7]
XU335 NR2 $PINS O=term1_in[8] I1=n6 I2=x_in[8]
XU336 NR2 $PINS O=term3_in[8] I1=sign3[1] I2=x_in[8]
XU338 NR2 $PINS O=term2_in[8] I1=sign2[1] I2=x_in[8]
XU341 NR2 $PINS O=term1_in[9] I1=n6 I2=x_in[9]
XU342 NR2 $PINS O=term3_in[9] I1=FE_OFN65_s13_1 I2=x_in[9]
XU344 NR2 $PINS O=term1_in[10] I1=n6 I2=x_in[10]
XU345 NR2 $PINS O=term3_in[10] I1=FE_OFN65_s13_1 I2=x_in[10]
XU346 NR2 $PINS O=term2_in[9] I1=sign2[1] I2=x_in[9]
XU347 NR2 $PINS O=term2_in[10] I1=sign2[1] I2=x_in[10]
XU348 NR2 $PINS O=term1_in[11] I1=n6 I2=x_in[11]
XU349 NR2 $PINS O=term3_in[11] I1=FE_OFN65_s13_1 I2=x_in[11]
XU350 NR2 $PINS O=term2_in[11] I1=sign2[1] I2=x_in[11]
XU351 NR2 $PINS O=term1_in[12] I1=sign1[1] I2=x_in[12]
XU352 NR2 $PINS O=term3_in[12] I1=FE_OFN65_s13_1 I2=x_in[12]
XU353 NR2 $PINS O=term2_in[12] I1=sign2[1] I2=x_in[12]
XU354 NR2 $PINS O=term1_in[13] I1=sign1[1] I2=x_in[13]
XU355 NR2 $PINS O=term3_in[13] I1=FE_OFN65_s13_1 I2=x_in[13]
XU356 NR2 $PINS O=term2_in[13] I1=FE_OFN63_s12_1 I2=x_in[13]
XU357 NR2 $PINS O=term1_in[14] I1=sign1[1] I2=n81
XU359 NR2 $PINS O=term3_in[14] I1=FE_OFN65_s13_1 I2=n81
XU361 NR2 $PINS O=term2_in[14] I1=FE_OFN63_s12_1 I2=n81
XU363 NR2 $PINS O=term1_in[15] I1=sign1[1] I2=n82
XU364 NR2 $PINS O=term3_in[15] I1=FE_OFN65_s13_1 I2=n82
XU365 NR2 $PINS O=term1_in[26] I1=n83 I2=sign1[1]
XU366 NR2 $PINS O=term2_in[15] I1=FE_OFN63_s12_1 I2=n82
XU367 NR2 $PINS O=term3_in[26] I1=n83 I2=FE_OFN65_s13_1
XU368 NR2 $PINS O=term2_in[26] I1=n83 I2=FE_OFN63_s12_1
XU369 INV1S $PINS O=n32 I=shf1[0]
XU391 INV1S $PINS O=n81 I=x_in[14]
XU392 INV1S $PINS O=n82 I=x_in[15]
XU393 INV1S $PINS O=n83 I=x_in[16]
XU394 AN2 $PINS O=base_val[26] I1=N251 I2=FE_OFN76_n
XU395 AN2 $PINS O=base_val[1] I1=acc_reg[1] I2=FE_OFN76_n
XU396 MOAI1S $PINS O=base_val[9] A1=stage_sel A2=FE_OFN76_n B1=acc_reg[9]
+ B2=FE_OFN76_n
XU397 AN2 $PINS O=base_val[10] I1=acc_reg[10] I2=FE_OFN76_n
XU398 AN2 $PINS O=base_val[8] I1=acc_reg[8] I2=FE_OFN76_n
XU399 AN2 $PINS O=base_val[5] I1=acc_reg[5] I2=FE_OFN76_n
XU400 AN2 $PINS O=base_val[3] I1=acc_reg[3] I2=FE_OFN76_n
XU401 AN2 $PINS O=base_val[2] I1=acc_reg[2] I2=FE_OFN76_n
XU402 AN2 $PINS O=base_val[11] I1=acc_reg[11] I2=FE_OFN76_n
XU403 AN2 $PINS O=base_val[12] I1=acc_reg[12] I2=FE_OFN76_n
XU404 AN2 $PINS O=base_val[14] I1=acc_reg[14] I2=FE_OFN76_n
XU405 AN2 $PINS O=base_val[15] I1=acc_reg[15] I2=FE_OFN76_n
XU406 AN2 $PINS O=base_val[16] I1=acc_reg[16] I2=FE_OFN76_n
XU407 AN2 $PINS O=base_val[17] I1=acc_reg[17] I2=FE_OFN76_n
XU408 AN2 $PINS O=base_val[18] I1=acc_reg[18] I2=FE_OFN76_n
XU409 AN2 $PINS O=base_val[19] I1=acc_reg[19] I2=FE_OFN76_n
XU410 AN2 $PINS O=base_val[20] I1=acc_reg[20] I2=FE_OFN76_n
XU411 AN2 $PINS O=base_val[21] I1=acc_reg[21] I2=FE_OFN76_n
XU412 AN2 $PINS O=base_val[22] I1=acc_reg[22] I2=FE_OFN76_n
XU413 AN2 $PINS O=base_val[23] I1=acc_reg[23] I2=FE_OFN76_n
XU414 AN2 $PINS O=base_val[24] I1=acc_reg[24] I2=FE_OFN76_n
XU415 AN2 $PINS O=base_val[25] I1=acc_reg[25] I2=FE_OFN76_n
XU417 AN2 $PINS O=N234 I1=en I2=calc_done
XU419 NR2 $PINS O=sll_16/ML_int[3][0] I1=shf1[2] I2=n45
XU420 NR2 $PINS O=sll_16/ML_int[3][1] I1=shf1[2] I2=n46
XU421 NR2 $PINS O=sll_16/ML_int[3][2] I1=shf1[2] I2=n49
XU422 NR2 $PINS O=sll_16/ML_int[3][3] I1=shf1[2] I2=n48
XU423 ND2P $PINS O=n47 I1=n35 I2=n37
XU424 AN2 $PINS O=term1_shifted[4] I1=sll_16/ML_int[3][4] I2=n37
XU426 AN2 $PINS O=term1_shifted[6] I1=sll_16/ML_int[3][6] I2=n37
XU427 AN2 $PINS O=term1_shifted[7] I1=sll_16/ML_int[3][7] I2=n37
XU428 MUX2 $PINS O=n55 S=shf1[0] A=term1_in[26] B=term1_in[15]
XU429 NR2 $PINS O=sll_17/ML_int[3][0] I1=shf2[2] I2=n56
XU430 NR2 $PINS O=sll_17/ML_int[3][1] I1=shf2[2] I2=n57
XU431 NR2 $PINS O=sll_17/ML_int[3][2] I1=shf2[2] I2=n60
XU432 NR2 $PINS O=sll_17/ML_int[3][3] I1=shf2[2] I2=n59
XU434 AN2 $PINS O=term2_shifted[5] I1=sll_17/ML_int[3][5] I2=FE_OFN188_h12_3
XU435 AN2 $PINS O=term2_shifted[6] I1=sll_17/ML_int[3][6] I2=FE_OFN188_h12_3
XU436 AN2 $PINS O=term2_shifted[7] I1=sll_17/ML_int[3][7] I2=FE_OFN188_h12_3
XU437 MUX2 $PINS O=n65 S=FE_OFN229_h12_0 A=term2_in[26] B=term2_in[15]
XU438 NR2 $PINS O=sll_18/ML_int[3][0] I1=FE_OFN59_h13_2 I2=n66
XU439 NR2 $PINS O=sll_18/ML_int[3][1] I1=FE_OFN59_h13_2 I2=n67
XU440 NR2 $PINS O=sll_18/ML_int[3][2] I1=FE_OFN59_h13_2 I2=n70
XU441 NR2 $PINS O=sll_18/ML_int[3][3] I1=FE_OFN59_h13_2 I2=n69
XU442 AN2 $PINS O=term3_shifted[4] I1=sll_18/ML_int[3][4] I2=n17
XU443 AN2 $PINS O=term3_shifted[5] I1=sll_18/ML_int[3][5] I2=n17
XU444 AN2 $PINS O=term3_shifted[6] I1=sll_18/ML_int[3][6] I2=n17
XU445 AN2 $PINS O=term3_shifted[7] I1=sll_18/ML_int[3][7] I2=n17
XU446 MUX2 $PINS O=n76 S=FE_OFN50_h13_0 A=term3_in[26] B=term3_in[15]
XU447 MUX2 $PINS O=N241 S=stage_sel A=acc_reg[16] B=acc_reg[20]
XU448 MUX2 $PINS O=N243 S=stage_sel A=acc_reg[18] B=acc_reg[22]
XU449 MUX2 $PINS O=N244 S=stage_sel A=acc_reg[19] B=acc_reg[23]
XU11 MUX2 $PINS O=sll_16/ML_int[2][2] S=shf1[1] A=sll_16/ML_int[1][2]
+ B=sll_16/ML_int[1][0]
XU6 NR2 $PINS O=term3_in[2] I1=sign3[1] I2=x_in[2]
XU12 NR2P $PINS O=term3_shifted[3] I1=n95 I2=n69
XU14 INV1S $PINS O=n69 I=sll_18/ML_int[2][3]
XU15 NR2 $PINS O=term2_in[2] I1=sign2[1] I2=x_in[2]
XU16 NR2P $PINS O=term2_in[0] I1=sign2[1] I2=FE_OFN346_mac_in_imag_0
XU21 NR2P $PINS O=term2_shifted[0] I1=n58 I2=n56
XU22 INV1S $PINS O=n60 I=sll_17/ML_int[2][2]
XU24 NR2 $PINS O=term1_in[2] I1=n6 I2=x_in[2]
XU32 ND3 $PINS O=n56 I1=term2_in[0] I2=n22 I3=n24
XU37 ND2P $PINS O=n45 I1=sll_16/ML_int[1][0] I2=n33
XU38 NR2P $PINS O=term2_shifted[1] I1=n4 I2=n3
XU39 NR2T $PINS O=term1_in[4] I1=n6 I2=x_in[4]
XU41 NR2P $PINS O=term1_shifted[1] I1=n47 I2=n46
XU42 AO22 $PINS O=N43 A1=N16 A2=sign1[0] B1=term1_shifted[2] B2=n40
XU44 OR2 $PINS O=n95 I1=shf3[2] I2=shf3[3]
XU45 INV3 $PINS O=n49 I=sll_16/ML_int[2][2]
XU66 NR2P $PINS O=term1_shifted[0] I1=n47 I2=n45
XU69 ND2 $PINS O=n67 I1=sll_18/ML_int[1][1] I2=n13
XU86 NR2P $PINS O=term1_shifted[2] I1=n47 I2=n49
XU87 AN2 $PINS O=sll_16/ML_int[1][0] I1=term1_in[0] I2=n32
XU88 AN2 $PINS O=term3_shifted[0] I1=sll_18/ML_int[1][0] I2=n2
Xclk_gate_y_out_reg SNPS_CLOCK_GATE_HIGH_PE_Shift_Add_4 $PINS EN=N234
+ ENCLK=CTS_12 CLK=clk_clone1
Xsub_28_3 PE_Shift_Add_4_DW01_sub_0_DW01_sub_12 $PINS A[26]=net45513
+ A[25]=net45513 A[24]=net45513 A[23]=net45513 A[22]=net45513 A[21]=net45513
+ A[20]=net45513 A[19]=net45513 A[18]=net45513 A[17]=net45513 A[16]=net45513
+ A[15]=net45513 A[14]=net45513 A[13]=net45513 A[12]=net45513 A[11]=net45513
+ A[10]=net45513 A[9]=net45513 A[8]=net45513 A[7]=net45513 A[6]=net45513
+ A[5]=net45513 A[4]=net45513 A[3]=net45513 A[2]=net45513 A[1]=net45513
+ A[0]=net45513 B[26]=term3_shifted[26] B[25]=term3_shifted[25]
+ B[24]=term3_shifted[24] B[23]=term3_shifted[23] B[22]=term3_shifted[22]
+ B[21]=term3_shifted[21] B[20]=term3_shifted[20] B[19]=term3_shifted[19]
+ B[18]=term3_shifted[18] B[17]=term3_shifted[17] B[16]=term3_shifted[16]
+ B[15]=term3_shifted[15] B[14]=term3_shifted[14] B[13]=term3_shifted[13]
+ B[12]=term3_shifted[12] B[11]=term3_shifted[11] B[10]=term3_shifted[10]
+ B[9]=term3_shifted[9] B[8]=term3_shifted[8] B[7]=term3_shifted[7]
+ B[6]=term3_shifted[6] B[5]=term3_shifted[5] B[4]=term3_shifted[4]
+ B[3]=term3_shifted[3] B[2]=term3_shifted[2] B[1]=term3_shifted[1]
+ B[0]=term3_shifted[0] CI=net45513 DIFF[26]=N150 DIFF[25]=N149 DIFF[24]=N148
+ DIFF[23]=N147 DIFF[22]=N146 DIFF[21]=N145 DIFF[20]=N144 DIFF[19]=N143
+ DIFF[18]=N142 DIFF[17]=N141 DIFF[16]=N140 DIFF[15]=N139 DIFF[14]=N138
+ DIFF[13]=N137 DIFF[12]=N136 DIFF[11]=N135 DIFF[10]=N134 DIFF[9]=N133
+ DIFF[8]=N132 DIFF[7]=N131 DIFF[6]=N130 DIFF[5]=N129 DIFF[4]=N128 DIFF[3]=N127
+ DIFF[2]=N126 DIFF[1]=N125 DIFF[0]=N124
Xsub_28_2 PE_Shift_Add_4_DW01_sub_1_DW01_sub_13 $PINS A[26]=net45513
+ A[25]=net45513 A[24]=net45513 A[23]=net45513 A[22]=net45513 A[21]=net45513
+ A[20]=net45513 A[19]=net45513 A[18]=net45513 A[17]=net45513 A[16]=net45513
+ A[15]=net45513 A[14]=net45513 A[13]=net45513 A[12]=net45513 A[11]=net45513
+ A[10]=net45513 A[9]=net45513 A[8]=net45513 A[7]=net45513 A[6]=net45513
+ A[5]=net45513 A[4]=net45513 A[3]=net45513 A[2]=net45513 A[1]=net45513
+ A[0]=net45513 B[26]=term2_shifted[26] B[25]=term2_shifted[25]
+ B[24]=term2_shifted[24] B[23]=term2_shifted[23] B[22]=term2_shifted[22]
+ B[21]=term2_shifted[21] B[20]=term2_shifted[20] B[19]=term2_shifted[19]
+ B[18]=term2_shifted[18] B[17]=term2_shifted[17] B[16]=term2_shifted[16]
+ B[15]=term2_shifted[15] B[14]=term2_shifted[14] B[13]=term2_shifted[13]
+ B[12]=term2_shifted[12] B[11]=term2_shifted[11] B[10]=term2_shifted[10]
+ B[9]=term2_shifted[9] B[8]=term2_shifted[8] B[7]=term2_shifted[7]
+ B[6]=term2_shifted[6] B[5]=term2_shifted[5] B[4]=term2_shifted[4]
+ B[3]=term2_shifted[3] B[2]=term2_shifted[2] B[1]=term2_shifted[1]
+ B[0]=term2_shifted[0] CI=net45513 DIFF[26]=N95 DIFF[25]=N94 DIFF[24]=N93
+ DIFF[23]=N92 DIFF[22]=N91 DIFF[21]=N90 DIFF[20]=N89 DIFF[19]=N88 DIFF[18]=N87
+ DIFF[17]=N86 DIFF[16]=N85 DIFF[15]=N84 DIFF[14]=N83 DIFF[13]=N82 DIFF[12]=N81
+ DIFF[11]=N80 DIFF[10]=N79 DIFF[9]=N78 DIFF[8]=N77 DIFF[7]=N76 DIFF[6]=N75
+ DIFF[5]=N74 DIFF[4]=N73 DIFF[3]=N72 DIFF[2]=N71 DIFF[1]=N70 DIFF[0]=N69
Xsub_28 PE_Shift_Add_4_DW01_sub_2_DW01_sub_14 $PINS A[26]=net45513
+ A[25]=net45513 A[24]=net45513 A[23]=net45513 A[22]=net45513 A[21]=net45513
+ A[20]=net45513 A[19]=net45513 A[18]=net45513 A[17]=net45513 A[16]=net45513
+ A[15]=net45513 A[14]=net45513 A[13]=net45513 A[12]=net45513 A[11]=net45513
+ A[10]=net45513 A[9]=net45513 A[8]=net45513 A[7]=net45513 A[6]=net45513
+ A[5]=net45513 A[4]=net45513 A[3]=net45513 A[2]=net45513 A[1]=net45513
+ A[0]=net45513 B[26]=term1_shifted[26] B[25]=term1_shifted[25]
+ B[24]=term1_shifted[24] B[23]=term1_shifted[23] B[22]=term1_shifted[22]
+ B[21]=term1_shifted[21] B[20]=term1_shifted[20] B[19]=term1_shifted[19]
+ B[18]=term1_shifted[18] B[17]=term1_shifted[17] B[16]=term1_shifted[16]
+ B[15]=term1_shifted[15] B[14]=term1_shifted[14] B[13]=term1_shifted[13]
+ B[12]=term1_shifted[12] B[11]=term1_shifted[11] B[10]=term1_shifted[10]
+ B[9]=term1_shifted[9] B[8]=term1_shifted[8] B[7]=term1_shifted[7]
+ B[6]=term1_shifted[6] B[5]=term1_shifted[5] B[4]=term1_shifted[4]
+ B[3]=term1_shifted[3] B[2]=term1_shifted[2] B[1]=term1_shifted[1]
+ B[0]=term1_shifted[0] CI=net45513 DIFF[26]=N40 DIFF[25]=N39 DIFF[24]=N38
+ DIFF[23]=N37 DIFF[22]=N36 DIFF[21]=N35 DIFF[20]=N34 DIFF[19]=N33 DIFF[18]=N32
+ DIFF[17]=N31 DIFF[16]=N30 DIFF[15]=N29 DIFF[14]=N28 DIFF[13]=N27 DIFF[12]=N26
+ DIFF[11]=N25 DIFF[10]=N24 DIFF[9]=N23 DIFF[8]=N22 DIFF[7]=N21 DIFF[6]=N20
+ DIFF[5]=N19 DIFF[4]=N18 DIFF[3]=N17 DIFF[2]=N16 DIFF[1]=N15 DIFF[0]=N14
Xadd_1_root_add_0_root_add_28_3 PE_Shift_Add_4_DW01_add_2_DW01_add_22 $PINS
+ A[26]=N67 A[25]=N66 A[24]=N65 A[23]=N64 A[22]=N63 A[21]=N62 A[20]=N61 A[19]=N60
+ A[18]=N59 A[17]=N58 A[16]=N57 A[15]=N56 A[14]=N55 A[13]=N54 A[12]=N53 A[11]=N52
+ A[10]=N51 A[9]=N50 A[8]=N49 A[7]=N48 A[6]=N47 A[5]=N46 A[4]=N45 A[3]=N44
+ A[2]=N43 A[1]=N42 A[0]=N41 B[26]=N177 B[25]=N176 B[24]=N175 B[23]=N174
+ B[22]=N173 B[21]=N172 B[20]=N171 B[19]=N170 B[18]=N169 B[17]=N168 B[16]=N167
+ B[15]=N166 B[14]=N165 B[13]=N164 B[12]=N163 B[11]=N162 B[10]=N161 B[9]=N160
+ B[8]=N159 B[7]=N158 B[6]=N157 B[5]=N156 B[4]=N155 B[3]=N154 B[2]=N153 B[1]=N152
+ B[0]=N151 CI=net45513 SUM[26]=N204 SUM[25]=N203 SUM[24]=N202 SUM[23]=N201
+ SUM[22]=N200 SUM[21]=N199 SUM[20]=N198 SUM[19]=N197 SUM[18]=N196 SUM[17]=N195
+ SUM[16]=N194 SUM[15]=N193 SUM[14]=N192 SUM[13]=N191 SUM[12]=N190 SUM[11]=N189
+ SUM[10]=N188 SUM[9]=N187 SUM[8]=N186 SUM[7]=N185 SUM[6]=N184 SUM[5]=N183
+ SUM[4]=N182 SUM[3]=N181 SUM[2]=N180 SUM[1]=N179 SUM[0]=N178
Xadd_2_root_add_0_root_add_28_3 PE_Shift_Add_4_DW01_add_1_DW01_add_21 $PINS
+ A[26]=base_val[26] A[25]=base_val[25] A[24]=base_val[24] A[23]=base_val[23]
+ A[22]=base_val[22] A[21]=base_val[21] A[20]=base_val[20] A[19]=base_val[19]
+ A[18]=base_val[18] A[17]=base_val[17] A[16]=base_val[16] A[15]=base_val[15]
+ A[14]=base_val[14] A[13]=base_val[13] A[12]=base_val[12] A[11]=base_val[11]
+ A[10]=base_val[10] A[9]=base_val[9] A[8]=base_val[8] A[7]=base_val[7]
+ A[6]=base_val[6] A[5]=base_val[5] A[4]=base_val[4] A[3]=base_val[3]
+ A[2]=base_val[2] A[1]=base_val[1] A[0]=base_val[0] B[26]=N122 B[25]=N121
+ B[24]=N120 B[23]=N119 B[22]=N118 B[21]=N117 B[20]=N116 B[19]=N115 B[18]=N114
+ B[17]=N113 B[16]=N112 B[15]=N111 B[14]=N110 B[13]=N109 B[12]=N108 B[11]=N107
+ B[10]=N106 B[9]=N105 B[8]=N104 B[7]=N103 B[6]=N102 B[5]=N101 B[4]=N100 B[3]=N99
+ B[2]=N98 B[1]=N97 B[0]=N96 CI=net45513 SUM[26]=N231 SUM[25]=N230 SUM[24]=N229
+ SUM[23]=N228 SUM[22]=N227 SUM[21]=N226 SUM[20]=N225 SUM[19]=N224 SUM[18]=N223
+ SUM[17]=N222 SUM[16]=N221 SUM[15]=N220 SUM[14]=N219 SUM[13]=N218 SUM[12]=N217
+ SUM[11]=N216 SUM[10]=N215 SUM[9]=N214 SUM[8]=N213 SUM[7]=N212 SUM[6]=N211
+ SUM[5]=N210 SUM[4]=N209 SUM[3]=N208 SUM[2]=N207 SUM[1]=N206 SUM[0]=N205
Xadd_0_root_add_0_root_add_28_3 PE_Shift_Add_4_DW01_add_0_DW01_add_20 $PINS
+ A[26]=N204 A[25]=N203 A[24]=N202 A[23]=N201 A[22]=N200 A[21]=N199 A[20]=N198
+ A[19]=N197 A[18]=N196 A[17]=N195 A[16]=N194 A[15]=N193 A[14]=N192 A[13]=N191
+ A[12]=N190 A[11]=N189 A[10]=N188 A[9]=N187 A[8]=N186 A[7]=N185 A[6]=N184
+ A[5]=N183 A[4]=N182 A[3]=N181 A[2]=N180 A[1]=N179 A[0]=N178 B[26]=N231
+ B[25]=N230 B[24]=N229 B[23]=N228 B[22]=N227 B[21]=N226 B[20]=N225 B[19]=N224
+ B[18]=N223 B[17]=N222 B[16]=N221 B[15]=N220 B[14]=N219 B[13]=N218 B[12]=N217
+ B[11]=N216 B[10]=N215 B[9]=N214 B[8]=N213 B[7]=N212 B[6]=N211 B[5]=N210
+ B[4]=N209 B[3]=N208 B[2]=N207 B[1]=N206 B[0]=N205 CI=net45513
+ SUM[26]=next_acc[26] SUM[25]=next_acc[25] SUM[24]=next_acc[24]
+ SUM[23]=next_acc[23] SUM[22]=next_acc[22] SUM[21]=next_acc[21]
+ SUM[20]=next_acc[20] SUM[19]=next_acc[19] SUM[18]=next_acc[18]
+ SUM[17]=next_acc[17] SUM[16]=next_acc[16] SUM[15]=next_acc[15]
+ SUM[14]=next_acc[14] SUM[13]=next_acc[13] SUM[12]=next_acc[12]
+ SUM[11]=next_acc[11] SUM[10]=next_acc[10] SUM[9]=next_acc[9] SUM[8]=next_acc[8]
+ SUM[7]=next_acc[7] SUM[6]=next_acc[6] SUM[5]=next_acc[5] SUM[4]=next_acc[4]
+ SUM[3]=next_acc[3] SUM[2]=next_acc[2] SUM[1]=next_acc[1] SUM[0]=next_acc[0]
.ENDS

.SUBCKT SNPS_CLOCK_GATE_HIGH_PE_Shift_Add_3 EN ENCLK CLK_clone1 CLK
*.CONNECT ENCLK net2244
*.CONNECT net2245 EN
XFE_PHC739_net2248 DELC $PINS O=FE_PHN739_net2248 I=net2248
XCTS_cdb_INV_CLK_G0_L7_37 INV1CK $PINS O=CTS_4 I=CLK
Xlatch QDBHN $PINS Q=net2248 D=net2245 CKB=CLK_clone1
Xmain_gate AN2T $PINS O=net2244 I1=FE_PHN739_net2248 I2=CTS_4
.ENDS

.SUBCKT PE_Shift_Add_3_DW01_sub_0_DW01_sub_9 A[26] A[25] A[24] A[23] A[22]
+ A[21] A[20] A[19] A[18] A[17] A[16] A[15] A[14] A[13] A[12] A[11] A[10] A[9]
+ A[8] A[7] A[6] A[5] A[4] A[3] A[2] A[1] A[0] B[26] B[25] B[24] B[23] B[22]
+ B[21] B[20] B[19] B[18] B[17] B[16] B[15] B[14] B[13] B[12] B[11] B[10] B[9]
+ B[8] B[7] B[6] B[5] B[4] B[3] B[2] B[1] B[0] CI DIFF[26] DIFF[25] DIFF[24]
+ DIFF[23] DIFF[22] DIFF[21] DIFF[20] DIFF[19] DIFF[18] DIFF[17] DIFF[16]
+ DIFF[15] DIFF[14] DIFF[13] DIFF[12] DIFF[11] DIFF[10] DIFF[9] DIFF[8] DIFF[7]
+ DIFF[6] DIFF[5] DIFF[4] DIFF[3] DIFF[2] DIFF[1] DIFF[0] CO
XFE_RC_1544_0 AN2 $PINS O=n6 I1=n26 I2=n46
XFE_RC_1336_0 AN2T $PINS O=n4 I1=n52 I2=n3
XFE_RC_1235_0 XOR2HS $PINS O=DIFF[1] I1=B[0] I2=B[1]
XFE_OFC610_term3_shifted_4 INV2 $PINS O=n50 I=B[4]
XU2 NR2 $PINS O=n3 I1=B[1] I2=B[0]
XU8 XOR2HS $PINS O=DIFF[2] I1=n3 I2=n52
XU10 INV1S $PINS O=n48 I=B[6]
XU11 INV1S $PINS O=n51 I=B[3]
XU12 INV1S $PINS O=n49 I=B[5]
XU13 ND2S $PINS O=n28 I1=n29 I2=n22
XU15 AN2 $PINS O=n5 I1=n4 I2=n51
XU17 AN2 $PINS O=n7 I1=n45 I2=n6
XU18 AN2 $PINS O=n8 I1=n44 I2=n7
XU19 AN2 $PINS O=n9 I1=n43 I2=n8
XU20 AN2 $PINS O=n10 I1=n42 I2=n9
XU21 AN2 $PINS O=n11 I1=n41 I2=n10
XU22 AN2 $PINS O=n12 I1=n40 I2=n11
XU23 AN2 $PINS O=n13 I1=n39 I2=n12
XU24 AN2 $PINS O=n14 I1=n38 I2=n13
XU25 AN2 $PINS O=n15 I1=n37 I2=n14
XU26 AN2 $PINS O=n16 I1=n36 I2=n15
XU27 AN2 $PINS O=n17 I1=n35 I2=n16
XU28 AN2 $PINS O=n18 I1=n34 I2=n17
XU29 AN2 $PINS O=n19 I1=n33 I2=n18
XU30 AN2 $PINS O=n20 I1=n32 I2=n19
XU31 AN2 $PINS O=n21 I1=n31 I2=n20
XU32 AN2 $PINS O=n22 I1=n30 I2=n21
XU33 AN2 $PINS O=n23 I1=n5 I2=n50
XU34 AN2 $PINS O=n24 I1=n23 I2=n49
XU35 AN2 $PINS O=n25 I1=n24 I2=n48
XU36 AN2 $PINS O=n26 I1=n25 I2=n47
XU37 INV1S $PINS O=n46 I=B[8]
XU38 INV1S $PINS O=n45 I=B[9]
XU39 INV1S $PINS O=n44 I=B[10]
XU40 INV1S $PINS O=n43 I=B[11]
XU41 INV1S $PINS O=n42 I=B[12]
XU42 INV1S $PINS O=n41 I=B[13]
XU43 INV1S $PINS O=n40 I=B[14]
XU44 INV1S $PINS O=n39 I=B[15]
XU45 INV1S $PINS O=n38 I=B[16]
XU46 INV1S $PINS O=n37 I=B[17]
XU47 INV1S $PINS O=n36 I=B[18]
XU48 INV1S $PINS O=n35 I=B[19]
XU49 INV1S $PINS O=n34 I=B[20]
XU50 INV1S $PINS O=n33 I=B[21]
XU51 INV1S $PINS O=n32 I=B[22]
XU52 INV1S $PINS O=n31 I=B[23]
XU53 INV1S $PINS O=n30 I=B[24]
XU54 INV1S $PINS O=n29 I=B[25]
XU55 INV1S $PINS O=n47 I=B[7]
XU56 XOR2HS $PINS O=DIFF[3] I1=n51 I2=n4
XU57 XOR2HS $PINS O=DIFF[4] I1=n50 I2=n5
XU58 XOR2HS $PINS O=DIFF[5] I1=n49 I2=n23
XU59 XOR2HS $PINS O=DIFF[7] I1=n47 I2=n25
XU60 XOR2HS $PINS O=DIFF[6] I1=n48 I2=n24
XU61 XOR2HS $PINS O=DIFF[9] I1=n45 I2=n6
XU62 XOR2HS $PINS O=DIFF[8] I1=n46 I2=n26
XU63 XOR2HS $PINS O=DIFF[10] I1=n44 I2=n7
XU64 XOR2HS $PINS O=DIFF[11] I1=n43 I2=n8
XU65 XOR2HS $PINS O=DIFF[12] I1=n42 I2=n9
XU66 XOR2HS $PINS O=DIFF[13] I1=n41 I2=n10
XU67 XOR2HS $PINS O=DIFF[14] I1=n40 I2=n11
XU68 XOR2HS $PINS O=DIFF[15] I1=n39 I2=n12
XU69 XOR2HS $PINS O=DIFF[16] I1=n38 I2=n13
XU70 XOR2HS $PINS O=DIFF[17] I1=n37 I2=n14
XU71 XOR2HS $PINS O=DIFF[18] I1=n36 I2=n15
XU72 XOR2HS $PINS O=DIFF[19] I1=n35 I2=n16
XU73 XOR2HS $PINS O=DIFF[20] I1=n34 I2=n17
XU74 XOR2HS $PINS O=DIFF[21] I1=n33 I2=n18
XU75 XOR2HS $PINS O=DIFF[22] I1=n32 I2=n19
XU76 XOR2HS $PINS O=DIFF[23] I1=n31 I2=n20
XU77 XOR2HS $PINS O=DIFF[24] I1=n30 I2=n21
XU78 XOR2HS $PINS O=DIFF[25] I1=n29 I2=n22
XU79 XOR2HS $PINS O=DIFF[26] I1=B[26] I2=n28
XU6 INV2 $PINS O=n52 I=B[2]
.ENDS

.SUBCKT PE_Shift_Add_3_DW01_sub_1_DW01_sub_10 A[26] A[25] A[24] A[23] A[22]
+ A[21] A[20] A[19] A[18] A[17] A[16] A[15] A[14] A[13] A[12] A[11] A[10] A[9]
+ A[8] A[7] A[6] A[5] A[4] A[3] A[2] A[1] A[0] B[26] B[25] B[24] B[23] B[22]
+ B[21] B[20] B[19] B[18] B[17] B[16] B[15] B[14] B[13] B[12] B[11] B[10] B[9]
+ B[8] B[7] B[6] B[5] B[4] B[3] B[2] B[1] B[0] CI DIFF[26] DIFF[25] DIFF[24]
+ DIFF[23] DIFF[22] DIFF[21] DIFF[20] DIFF[19] DIFF[18] DIFF[17] DIFF[16]
+ DIFF[15] DIFF[14] DIFF[13] DIFF[12] DIFF[11] DIFF[10] DIFF[9] DIFF[8] DIFF[7]
+ DIFF[6] DIFF[5] DIFF[4] DIFF[3] DIFF[2] DIFF[1] DIFF[0] CO
XFE_RC_1757_0 XOR2HS $PINS O=DIFF[1] I1=n51 I2=n52
XFE_RC_1486_0 XNR2HS $PINS O=DIFF[3] I1=n2 I2=B[3]
XFE_RC_1265_0 AN3B2S $PINS O=n22 I1=n3 B1=B[4] B2=B[5]
XFE_RC_1148_0 XNR2HS $PINS O=DIFF[7] I1=B[7] I2=n23
XFE_OFC672_term2_shifted_8 INV1S $PINS O=n44 I=B[8]
XFE_OFC641_term2_shifted_4 INV1S $PINS O=n48 I=B[4]
XFE_OFC638_term2_shifted_7 INV1S $PINS O=n45 I=B[7]
XFE_OFC576_N69 INV1S $PINS O=n52 I=B[0]
XFE_OFC546_term2_shifted_1 INV2 $PINS O=n51 I=B[1]
XU6 INV1S $PINS O=n47 I=B[5]
XU8 INV1S $PINS O=n49 I=B[3]
XU11 AN2 $PINS O=n21 I1=n3 I2=n48
XU12 ND2S $PINS O=n26 I1=n27 I2=n20
XU13 AN2T $PINS O=n2 I1=n50 I2=n1
XU14 AN2 $PINS O=n3 I1=n49 I2=n2
XU15 AN2 $PINS O=n4 I1=n24 I2=n44
XU16 AN2 $PINS O=n5 I1=n43 I2=n4
XU17 AN2 $PINS O=n6 I1=n42 I2=n5
XU18 AN2 $PINS O=n7 I1=n41 I2=n6
XU19 AN2 $PINS O=n8 I1=n40 I2=n7
XU20 AN2 $PINS O=n9 I1=n39 I2=n8
XU21 AN2 $PINS O=n10 I1=n38 I2=n9
XU22 AN2 $PINS O=n11 I1=n37 I2=n10
XU23 AN2 $PINS O=n12 I1=n36 I2=n11
XU24 AN2 $PINS O=n13 I1=n35 I2=n12
XU25 AN2 $PINS O=n14 I1=n34 I2=n13
XU26 AN2 $PINS O=n15 I1=n33 I2=n14
XU27 AN2 $PINS O=n16 I1=n32 I2=n15
XU28 AN2 $PINS O=n17 I1=n31 I2=n16
XU29 AN2 $PINS O=n18 I1=n30 I2=n17
XU30 AN2 $PINS O=n19 I1=n29 I2=n18
XU31 AN2 $PINS O=n20 I1=n28 I2=n19
XU33 AN2 $PINS O=n23 I1=n22 I2=n46
XU34 AN2 $PINS O=n24 I1=n45 I2=n23
XU36 INV1S $PINS O=n43 I=B[9]
XU37 INV1S $PINS O=n42 I=B[10]
XU38 INV1S $PINS O=n41 I=B[11]
XU39 INV1S $PINS O=n40 I=B[12]
XU40 INV1S $PINS O=n39 I=B[13]
XU41 INV1S $PINS O=n38 I=B[14]
XU42 INV1S $PINS O=n37 I=B[15]
XU43 INV1S $PINS O=n36 I=B[16]
XU44 INV1S $PINS O=n35 I=B[17]
XU45 INV1S $PINS O=n34 I=B[18]
XU46 INV1S $PINS O=n33 I=B[19]
XU47 INV1S $PINS O=n32 I=B[20]
XU48 INV1S $PINS O=n31 I=B[21]
XU49 INV1S $PINS O=n30 I=B[22]
XU50 INV1S $PINS O=n29 I=B[23]
XU51 INV1S $PINS O=n28 I=B[24]
XU52 INV1S $PINS O=n27 I=B[25]
XU53 INV1S $PINS O=n46 I=B[6]
XU55 XOR2HS $PINS O=DIFF[26] I1=B[26] I2=n26
XU56 XOR2HS $PINS O=DIFF[9] I1=n43 I2=n4
XU57 XOR2HS $PINS O=DIFF[10] I1=n42 I2=n5
XU58 XOR2HS $PINS O=DIFF[8] I1=n44 I2=n24
XU59 XOR2HS $PINS O=DIFF[6] I1=n46 I2=n22
XU60 XOR2HS $PINS O=DIFF[5] I1=n47 I2=n21
XU62 XOR2HS $PINS O=DIFF[4] I1=n48 I2=n3
XU64 XOR2HS $PINS O=DIFF[11] I1=n41 I2=n6
XU65 XOR2HS $PINS O=DIFF[12] I1=n40 I2=n7
XU66 XOR2HS $PINS O=DIFF[13] I1=n39 I2=n8
XU67 XOR2HS $PINS O=DIFF[14] I1=n38 I2=n9
XU68 XOR2HS $PINS O=DIFF[15] I1=n37 I2=n10
XU69 XOR2HS $PINS O=DIFF[16] I1=n36 I2=n11
XU70 XOR2HS $PINS O=DIFF[17] I1=n35 I2=n12
XU71 XOR2HS $PINS O=DIFF[18] I1=n34 I2=n13
XU72 XOR2HS $PINS O=DIFF[19] I1=n33 I2=n14
XU73 XOR2HS $PINS O=DIFF[20] I1=n32 I2=n15
XU74 XOR2HS $PINS O=DIFF[21] I1=n31 I2=n16
XU75 XOR2HS $PINS O=DIFF[22] I1=n30 I2=n17
XU76 XOR2HS $PINS O=DIFF[23] I1=n29 I2=n18
XU77 XOR2HS $PINS O=DIFF[24] I1=n28 I2=n19
XU78 XOR2HS $PINS O=DIFF[25] I1=n27 I2=n20
XU1 NR2 $PINS O=n1 I1=B[0] I2=B[1]
XU2 INV1S $PINS O=n50 I=B[2]
XU10 XOR2HS $PINS O=DIFF[2] I1=n1 I2=n50
.ENDS

.SUBCKT PE_Shift_Add_3_DW01_sub_2_DW01_sub_11 A[26] A[25] A[24] A[23] A[22]
+ A[21] A[20] A[19] A[18] A[17] A[16] A[15] A[14] A[13] A[12] A[11] A[10] A[9]
+ A[8] A[7] A[6] A[5] A[4] A[3] A[2] A[1] A[0] B[26] B[25] B[24] B[23] B[22]
+ B[21] B[20] B[19] B[18] B[17] B[16] B[15] B[14] B[13] B[12] B[11] B[10] B[9]
+ B[8] B[7] B[6] B[5] B[4] B[3] B[2] B[1] B[0] CI DIFF[26] DIFF[25] DIFF[24]
+ DIFF[23] DIFF[22] DIFF[21] DIFF[20] DIFF[19] DIFF[18] DIFF[17] DIFF[16]
+ DIFF[15] DIFF[14] DIFF[13] DIFF[12] DIFF[11] DIFF[10] DIFF[9] DIFF[8] DIFF[7]
+ DIFF[6] DIFF[5] DIFF[4] DIFF[3] DIFF[2] DIFF[1] DIFF[0] CO
XFE_RC_1672_0 INV1S $PINS O=FE_RN_428_0 I=B[5]
XFE_RC_1671_0 MXL2HS $PINS OB=DIFF[5] S=n54 A=FE_RN_428_0 B=B[5]
XFE_RC_1422_0 XNR2HS $PINS O=DIFF[3] I1=n4 I2=B[3]
XFE_RC_1106_0 XOR2HS $PINS O=DIFF[1] I1=B[0] I2=B[1]
XFE_OFC669_term1_shifted_7 INV1S $PINS O=n47 I=B[7]
XU4 NR2 $PINS O=n5 I1=B[0] I2=B[1]
XU5 NR2 $PINS O=n24 I1=B[5] I2=n54
XU7 INV1S $PINS O=n49 I=B[4]
XU9 INV1S $PINS O=n48 I=B[6]
XU11 AN2 $PINS O=n4 I1=n51 I2=n5
XU12 INV1S $PINS O=n50 I=B[3]
XU16 ND2S $PINS O=n28 I1=n29 I2=n22
XU18 AN2 $PINS O=n3 I1=n50 I2=n4
XU19 XOR2HS $PINS O=DIFF[8] I1=n46 I2=n26
XU20 XOR2HS $PINS O=DIFF[9] I1=n45 I2=n6
XU21 AN2 $PINS O=n6 I1=n46 I2=n26
XU22 XOR2HS $PINS O=DIFF[10] I1=n44 I2=n7
XU23 AN2 $PINS O=n7 I1=n45 I2=n6
XU24 XOR2HS $PINS O=DIFF[11] I1=n43 I2=n8
XU25 AN2 $PINS O=n8 I1=n44 I2=n7
XU26 XOR2HS $PINS O=DIFF[12] I1=n42 I2=n9
XU27 AN2 $PINS O=n9 I1=n43 I2=n8
XU28 XOR2HS $PINS O=DIFF[13] I1=n41 I2=n10
XU29 AN2 $PINS O=n10 I1=n42 I2=n9
XU30 XOR2HS $PINS O=DIFF[14] I1=n40 I2=n11
XU31 AN2 $PINS O=n11 I1=n41 I2=n10
XU32 XOR2HS $PINS O=DIFF[15] I1=n39 I2=n12
XU33 AN2 $PINS O=n12 I1=n40 I2=n11
XU34 XOR2HS $PINS O=DIFF[16] I1=n38 I2=n13
XU35 AN2 $PINS O=n13 I1=n39 I2=n12
XU36 XOR2HS $PINS O=DIFF[17] I1=n37 I2=n14
XU37 AN2 $PINS O=n14 I1=n38 I2=n13
XU38 XOR2HS $PINS O=DIFF[18] I1=n36 I2=n15
XU39 AN2 $PINS O=n15 I1=n37 I2=n14
XU40 XOR2HS $PINS O=DIFF[19] I1=n35 I2=n16
XU41 AN2 $PINS O=n16 I1=n36 I2=n15
XU42 XOR2HS $PINS O=DIFF[20] I1=n34 I2=n17
XU43 AN2 $PINS O=n17 I1=n35 I2=n16
XU44 XOR2HS $PINS O=DIFF[21] I1=n33 I2=n18
XU45 AN2 $PINS O=n18 I1=n34 I2=n17
XU46 XOR2HS $PINS O=DIFF[22] I1=n32 I2=n19
XU47 AN2 $PINS O=n19 I1=n33 I2=n18
XU48 XOR2HS $PINS O=DIFF[23] I1=n31 I2=n20
XU49 AN2 $PINS O=n20 I1=n32 I2=n19
XU50 AN2 $PINS O=n21 I1=n31 I2=n20
XU51 AN2 $PINS O=n22 I1=n30 I2=n21
XU52 XOR2HS $PINS O=DIFF[24] I1=n30 I2=n21
XU53 XOR2HS $PINS O=DIFF[25] I1=n29 I2=n22
XU54 XOR2HS $PINS O=DIFF[4] I1=n3 I2=n49
XU55 XOR2HS $PINS O=DIFF[6] I1=n48 I2=n24
XU56 XOR2HS $PINS O=DIFF[7] I1=n47 I2=n25
XU57 AN2 $PINS O=n25 I1=n48 I2=n24
XU58 AN2 $PINS O=n26 I1=n47 I2=n25
XU59 INV1S $PINS O=n46 I=B[8]
XU60 INV1S $PINS O=n45 I=B[9]
XU61 INV1S $PINS O=n44 I=B[10]
XU62 INV1S $PINS O=n43 I=B[11]
XU63 INV1S $PINS O=n42 I=B[12]
XU64 INV1S $PINS O=n41 I=B[13]
XU65 INV1S $PINS O=n40 I=B[14]
XU66 INV1S $PINS O=n39 I=B[15]
XU67 INV1S $PINS O=n38 I=B[16]
XU68 INV1S $PINS O=n37 I=B[17]
XU69 INV1S $PINS O=n36 I=B[18]
XU70 INV1S $PINS O=n35 I=B[19]
XU71 INV1S $PINS O=n34 I=B[20]
XU72 INV1S $PINS O=n33 I=B[21]
XU73 INV1S $PINS O=n32 I=B[22]
XU74 INV1S $PINS O=n31 I=B[23]
XU75 INV1S $PINS O=n30 I=B[24]
XU76 INV1S $PINS O=n29 I=B[25]
XU78 XOR2HS $PINS O=DIFF[26] I1=B[26] I2=n28
XU1 XOR2HS $PINS O=DIFF[2] I1=n51 I2=n5
XU3 ND2 $PINS O=n54 I1=n49 I2=n3
XU6 INV1S $PINS O=n51 I=B[2]
.ENDS

.SUBCKT PE_Shift_Add_3_DW01_add_2_DW01_add_31 A[26] A[25] A[24] A[23] A[22]
+ A[21] A[20] A[19] A[18] A[17] A[16] A[15] A[14] A[13] A[12] A[11] A[10] A[9]
+ A[8] A[7] A[6] A[5] A[4] A[3] A[2] A[1] A[0] B[26] B[25] B[24] B[23] B[22]
+ B[21] B[20] B[19] B[18] B[17] B[16] B[15] B[14] B[13] B[12] B[11] B[10] B[9]
+ B[8] B[7] B[6] B[5] B[4] B[3] B[2] B[1] B[0] CI SUM[26] SUM[25] SUM[24]
+ SUM[23] SUM[22] SUM[21] SUM[20] SUM[19] SUM[18] SUM[17] SUM[16] SUM[15]
+ SUM[14] SUM[13] SUM[12] SUM[11] SUM[10] SUM[9] SUM[8] SUM[7] SUM[6] SUM[5]
+ SUM[4] SUM[3] SUM[2] SUM[1] SUM[0] CO
XFE_RC_1773_0 INV3 $PINS O=SUM[16] I=FE_RN_480_0
XFE_RC_1772_0 XNR3 $PINS O=FE_RN_480_0 I1=A[16] I2=B[16] I3=carry[16]
XFE_RC_1686_0 ND3 $PINS O=FE_RN_434_0 I1=n23 I2=n24 I3=n25
XFE_RC_1685_0 INV1S $PINS O=FE_RN_435_0 I=FE_RN_313_0
XFE_RC_1684_0 ND2 $PINS O=n2 I1=FE_RN_435_0 I2=FE_RN_434_0
XFE_RC_1658_0 ND2P $PINS O=FE_RN_421_0 I1=carry[3] I2=A[3]
XFE_RC_1657_0 ND3HT $PINS O=carry[4] I1=FE_RN_421_0 I2=n5 I3=n7
XFE_RC_1642_0 ND3P $PINS O=carry[6] I1=n2 I2=n4 I3=n3
XFE_RC_1560_0 XOR3 $PINS O=SUM[25] I1=A[25] I2=B[25] I3=carry[25]
XFE_RC_1559_0 MAO222P $PINS O=carry[26] A1=carry[25] B1=B[25] C1=A[25]
XFE_RC_1543_0 INV2 $PINS O=SUM[15] I=FE_RN_362_0
XFE_RC_1542_0 XNR3 $PINS O=FE_RN_362_0 I1=A[15] I2=B[15] I3=carry[15]
XFE_RC_1426_0 INV1S $PINS O=FE_RN_313_0 I=A[5]
XFE_RC_1424_0 INV2 $PINS O=SUM[10] I=FE_RN_312_0
XFE_RC_1423_0 XNR3 $PINS O=FE_RN_312_0 I1=A[10] I2=B[10] I3=carry[10]
XFE_RC_1394_0 INV2 $PINS O=SUM[3] I=FE_RN_300_0
XFE_RC_1393_0 XNR3 $PINS O=FE_RN_300_0 I1=A[3] I2=B[3] I3=carry[3]
XFE_RC_1388_0 XOR3 $PINS O=SUM[23] I1=A[23] I2=B[23] I3=carry[23]
XFE_RC_1387_0 MAO222P $PINS O=carry[24] A1=carry[23] B1=B[23] C1=A[23]
XFE_RC_1379_0 XOR3 $PINS O=SUM[24] I1=A[24] I2=B[24] I3=carry[24]
XFE_RC_1378_0 MAO222P $PINS O=carry[25] A1=carry[24] B1=B[24] C1=A[24]
XFE_RC_1357_0 INV2 $PINS O=SUM[7] I=FE_RN_286_0
XFE_RC_1356_0 XNR3 $PINS O=FE_RN_286_0 I1=A[7] I2=B[7] I3=carry[7]
XFE_RC_1217_0 INV2 $PINS O=SUM[2] I=FE_RN_224_0
XFE_RC_1216_0 XNR3 $PINS O=FE_RN_224_0 I1=B[2] I2=carry[2] I3=A[2]
XFE_RC_992_0 XOR3 $PINS O=SUM[22] I1=A[22] I2=B[22] I3=carry[22]
XFE_RC_991_0 MAO222P $PINS O=carry[23] A1=carry[22] B1=B[22] C1=A[22]
XFE_RC_829_0 XOR2HS $PINS O=FE_RN_64_0 I1=A[26] I2=B[26]
XFE_RC_828_0 XOR2H $PINS O=SUM[26] I1=FE_RN_64_0 I2=carry[26]
XFE_RC_812_0 XOR3 $PINS O=SUM[21] I1=A[21] I2=B[21] I3=carry[21]
XFE_RC_811_0 MAO222P $PINS O=carry[22] A1=carry[21] B1=B[21] C1=A[21]
XFE_RC_780_0 XOR3 $PINS O=SUM[20] I1=A[20] I2=B[20] I3=carry[20]
XFE_RC_779_0 MAO222P $PINS O=carry[21] A1=carry[20] B1=B[20] C1=A[20]
XFE_RC_758_0 XOR3 $PINS O=SUM[18] I1=A[18] I2=B[18] I3=carry[18]
XFE_RC_757_0 MAO222P $PINS O=carry[19] A1=carry[18] B1=B[18] C1=A[18]
XFE_RC_701_0 XOR3 $PINS O=SUM[1] I1=A[1] I2=B[1] I3=n34
XFE_RC_700_0 MAO222P $PINS O=carry[2] A1=B[1] B1=A[1] C1=n34
XFE_RC_699_0 XOR3 $PINS O=SUM[19] I1=A[19] I2=B[19] I3=carry[19]
XFE_RC_698_0 MAO222P $PINS O=carry[20] A1=carry[19] B1=B[19] C1=A[19]
XFE_RC_675_0 XOR3 $PINS O=SUM[17] I1=A[17] I2=B[17] I3=carry[17]
XFE_RC_674_0 MAO222P $PINS O=carry[18] A1=carry[17] B1=B[17] C1=A[17]
XFE_RC_603_0 XOR3 $PINS O=SUM[14] I1=A[14] I2=B[14] I3=carry[14]
XFE_RC_602_0 MAO222P $PINS O=carry[15] A1=carry[14] B1=B[14] C1=A[14]
XFE_RC_498_0 MAO222P $PINS O=carry[3] A1=A[2] B1=carry[2] C1=B[2]
XFE_RC_497_0 ND3P $PINS O=carry[9] I1=n13 I2=n14 I3=n15
XFE_RC_459_0 ND3P $PINS O=carry[11] I1=n30 I2=n31 I3=n32
XFE_RC_414_0 XOR3 $PINS O=SUM[9] I1=A[9] I2=B[9] I3=carry[9]
XFE_RC_413_0 MAO222P $PINS O=carry[10] A1=carry[9] B1=B[9] C1=A[9]
XFE_RC_315_0 XOR3 $PINS O=SUM[11] I1=A[11] I2=B[11] I3=carry[11]
XFE_RC_314_0 MAO222P $PINS O=carry[12] A1=carry[11] B1=B[11] C1=A[11]
XFE_RC_272_0 XOR3 $PINS O=SUM[12] I1=A[12] I2=B[12] I3=carry[12]
XFE_RC_271_0 MAO222P $PINS O=carry[13] A1=carry[12] B1=B[12] C1=A[12]
XFE_RC_269_0 MAO222P $PINS O=carry[8] A1=carry[7] B1=B[7] C1=A[7]
XU3 ND3P $PINS O=carry[16] I1=n17 I2=n16 I3=n18
XU6 ND2P $PINS O=n16 I1=carry[15] I2=A[15]
XU8 ND3P $PINS O=carry[7] I1=n27 I2=n28 I3=n29
XU10 ND3P $PINS O=carry[14] I1=n10 I2=n9 I3=n11
XU11 XOR2HS $PINS O=n1 I1=B[5] I2=carry[5]
XU13 ND2 $PINS O=n3 I1=B[5] I2=A[5]
XU16 ND2P $PINS O=n5 I1=carry[3] I2=B[3]
XU18 ND2 $PINS O=n7 I1=B[3] I2=A[3]
XU20 ND2P $PINS O=n19 I1=carry[16] I2=A[16]
XU21 ND3P $PINS O=carry[17] I1=n20 I2=n19 I3=n21
XU23 XOR2HS $PINS O=n8 I1=A[13] I2=B[13]
XU24 XOR2HS $PINS O=SUM[13] I1=carry[13] I2=n8
XU25 ND2P $PINS O=n9 I1=carry[13] I2=A[13]
XU26 ND2 $PINS O=n10 I1=carry[13] I2=B[13]
XU27 ND2 $PINS O=n11 I1=A[13] I2=B[13]
XU28 XOR2HS $PINS O=n12 I1=A[8] I2=B[8]
XU29 XOR2HS $PINS O=SUM[8] I1=carry[8] I2=n12
XU30 ND2P $PINS O=n13 I1=carry[8] I2=A[8]
XU31 ND2P $PINS O=n14 I1=carry[8] I2=B[8]
XU32 ND2 $PINS O=n15 I1=B[8] I2=A[8]
XU34 ND2P $PINS O=n17 I1=carry[15] I2=B[15]
XU35 ND2 $PINS O=n18 I1=A[15] I2=B[15]
XU36 ND2 $PINS O=n20 I1=carry[16] I2=B[16]
XU37 ND2S $PINS O=n21 I1=A[16] I2=B[16]
XU38 XOR2H $PINS O=n22 I1=A[4] I2=B[4]
XU39 XOR2HS $PINS O=SUM[4] I1=carry[4] I2=n22
XU40 ND2P $PINS O=n23 I1=carry[4] I2=A[4]
XU41 ND2P $PINS O=n24 I1=carry[4] I2=B[4]
XU42 ND2P $PINS O=n25 I1=B[4] I2=A[4]
XU43 XOR2HS $PINS O=n26 I1=A[6] I2=B[6]
XU44 XOR2HS $PINS O=SUM[6] I1=carry[6] I2=n26
XU45 ND2 $PINS O=n27 I1=carry[6] I2=A[6]
XU46 ND2 $PINS O=n28 I1=carry[6] I2=B[6]
XU47 ND2 $PINS O=n29 I1=B[6] I2=A[6]
XU49 ND2 $PINS O=n30 I1=carry[10] I2=A[10]
XU50 ND2 $PINS O=n31 I1=carry[10] I2=B[10]
XU51 ND2 $PINS O=n32 I1=B[10] I2=A[10]
XU52 XOR2HS $PINS O=SUM[0] I1=B[0] I2=A[0]
XU2 ND2 $PINS O=n4 I1=carry[5] I2=B[5]
XU4 ND3P $PINS O=carry[5] I1=n24 I2=n23 I3=n25
XU12 XOR2HS $PINS O=SUM[5] I1=A[5] I2=n1
XU14 AN2 $PINS O=n34 I1=A[0] I2=B[0]
.ENDS

.SUBCKT PE_Shift_Add_3_DW01_add_1_DW01_add_30 A[26] A[25] A[24] A[23] A[22]
+ A[21] A[20] A[19] A[18] A[17] A[16] A[15] A[14] A[13] A[12] A[11] A[10] A[9]
+ A[8] A[7] A[6] A[5] A[4] A[3] A[2] A[1] A[0] B[26] B[25] B[24] B[23] B[22]
+ B[21] B[20] B[19] B[18] B[17] B[16] B[15] B[14] B[13] B[12] B[11] B[10] B[9]
+ B[8] B[7] B[6] B[5] B[4] B[3] B[2] B[1] B[0] CI SUM[26] SUM[25] SUM[24]
+ SUM[23] SUM[22] SUM[21] SUM[20] SUM[19] SUM[18] SUM[17] SUM[16] SUM[15]
+ SUM[14] SUM[13] SUM[12] SUM[11] SUM[10] SUM[9] SUM[8] SUM[7] SUM[6] SUM[5]
+ SUM[4] SUM[3] SUM[2] SUM[1] SUM[0] CO
XFE_RC_1550_0 INV2 $PINS O=SUM[2] I=FE_RN_366_0
XFE_RC_1549_0 XNR3 $PINS O=FE_RN_366_0 I1=A[2] I2=B[2] I3=carry[2]
XFE_RC_1506_0 INV2 $PINS O=SUM[3] I=FE_RN_345_0
XFE_RC_1505_0 XNR3 $PINS O=FE_RN_345_0 I1=A[3] I2=carry[3] I3=B[3]
XFE_RC_1493_0 XOR2HS $PINS O=FE_RN_342_0 I1=A[26] I2=B[26]
XFE_RC_1492_0 XOR2H $PINS O=SUM[26] I1=FE_RN_342_0 I2=carry[26]
XFE_RC_1489_0 XNR2HS $PINS O=FE_RN_340_0 I1=A[12] I2=B[12]
XFE_RC_1488_0 INV2 $PINS O=FE_RN_339_0 I=FE_RN_340_0
XFE_RC_1487_0 XOR2HS $PINS O=SUM[12] I1=FE_RN_339_0 I2=carry[12]
XFE_RC_1160_0 INV2 $PINS O=SUM[5] I=FE_RN_198_0
XFE_RC_1159_0 XNR3 $PINS O=FE_RN_198_0 I1=A[5] I2=B[5] I3=carry[5]
XFE_RC_1074_0 XOR3 $PINS O=SUM[18] I1=A[18] I2=B[18] I3=carry[18]
XFE_RC_1073_0 MAO222 $PINS O=carry[19] A1=carry[18] B1=B[18] C1=A[18]
XFE_RC_943_0 INV2 $PINS O=SUM[16] I=FE_RN_130_0
XFE_RC_942_0 XNR3 $PINS O=FE_RN_130_0 I1=A[16] I2=B[16] I3=carry[16]
XFE_RC_935_0 INV2 $PINS O=SUM[21] I=FE_RN_125_0
XFE_RC_934_0 XNR3 $PINS O=FE_RN_125_0 I1=A[21] I2=B[21] I3=carry[21]
XFE_RC_918_0 MAO222 $PINS O=carry[13] A1=carry[12] B1=B[12] C1=A[12]
XFE_RC_912_0 INV2 $PINS O=SUM[22] I=FE_RN_112_0
XFE_RC_911_0 XNR3 $PINS O=FE_RN_112_0 I1=A[22] I2=B[22] I3=carry[22]
XFE_RC_909_0 INV2 $PINS O=SUM[19] I=FE_RN_111_0
XFE_RC_908_0 XNR3 $PINS O=FE_RN_111_0 I1=A[19] I2=B[19] I3=carry[19]
XFE_RC_907_0 INV2 $PINS O=SUM[23] I=FE_RN_110_0
XFE_RC_906_0 XNR3 $PINS O=FE_RN_110_0 I1=A[23] I2=B[23] I3=carry[23]
XFE_RC_899_0 INV2 $PINS O=SUM[24] I=FE_RN_106_0
XFE_RC_898_0 XNR3 $PINS O=FE_RN_106_0 I1=B[24] I2=A[24] I3=carry[24]
XFE_RC_721_0 XOR3 $PINS O=SUM[25] I1=A[25] I2=B[25] I3=carry[25]
XFE_RC_720_0 MAO222 $PINS O=carry[26] A1=carry[25] B1=B[25] C1=A[25]
XFE_RC_718_0 MAO222 $PINS O=carry[22] A1=carry[21] B1=B[21] C1=A[21]
XFE_RC_670_0 MAO222 $PINS O=carry[23] A1=carry[22] B1=B[22] C1=A[22]
XFE_RC_652_0 MAO222P $PINS O=carry[24] A1=carry[23] B1=B[23] C1=A[23]
XFE_RC_643_0 XOR3 $PINS O=SUM[1] I1=A[1] I2=n5 I3=B[1]
XFE_RC_642_0 MAO222 $PINS O=carry[2] A1=B[1] B1=A[1] C1=n5
XFE_RC_546_0 MAO222P $PINS O=carry[3] A1=carry[2] B1=B[2] C1=A[2]
XFE_RC_544_0 MAO222 $PINS O=carry[20] A1=carry[19] B1=B[19] C1=A[19]
XFE_RC_529_0 XOR3 $PINS O=SUM[20] I1=A[20] I2=B[20] I3=carry[20]
XFE_RC_528_0 MAO222 $PINS O=carry[21] A1=carry[20] B1=B[20] C1=A[20]
XFE_RC_448_0 XOR3 $PINS O=SUM[11] I1=A[11] I2=B[11] I3=carry[11]
XFE_RC_447_0 MAO222P $PINS O=carry[12] A1=carry[11] B1=B[11] C1=A[11]
XFE_RC_375_0 ND2P $PINS O=FE_RN_36_0 I1=carry[16] I2=B[16]
XFE_RC_374_0 ND2P $PINS O=FE_RN_37_0 I1=carry[16] I2=A[16]
XFE_RC_373_0 ND2 $PINS O=FE_RN_38_0 I1=A[16] I2=B[16]
XFE_RC_372_0 ND3P $PINS O=carry[17] I1=FE_RN_36_0 I2=FE_RN_37_0 I3=FE_RN_38_0
XFE_RC_361_0 XOR3 $PINS O=SUM[13] I1=A[13] I2=B[13] I3=carry[13]
XFE_RC_360_0 MAO222 $PINS O=carry[14] A1=carry[13] B1=B[13] C1=A[13]
XFE_RC_311_0 XOR3 $PINS O=SUM[17] I1=A[17] I2=B[17] I3=carry[17]
XFE_RC_310_0 MAO222 $PINS O=carry[18] A1=carry[17] B1=B[17] C1=A[17]
XFE_RC_305_0 XOR3 $PINS O=SUM[14] I1=A[14] I2=B[14] I3=carry[14]
XFE_RC_304_0 MAO222 $PINS O=carry[15] A1=carry[14] B1=B[14] C1=A[14]
XFE_RC_223_0 XOR3 $PINS O=SUM[9] I1=B[9] I2=A[9] I3=carry[9]
XFE_RC_222_0 MAO222 $PINS O=carry[10] A1=carry[9] B1=B[9] C1=A[9]
XFE_RC_219_0 XOR3 $PINS O=SUM[15] I1=A[15] I2=B[15] I3=carry[15]
XFE_RC_218_0 MAO222P $PINS O=carry[16] A1=carry[15] B1=B[15] C1=A[15]
XFE_RC_151_0 XOR3 $PINS O=SUM[10] I1=A[10] I2=B[10] I3=carry[10]
XFE_RC_150_0 MAO222P $PINS O=carry[11] A1=carry[10] B1=B[10] C1=A[10]
XU1_7 FA1 $PINS S=SUM[7] CO=carry[8] A=A[7] B=B[7] CI=carry[7]
XU1 ND3P $PINS O=carry[7] I1=n15 I2=n14 I3=n13
XU2 ND3 $PINS O=carry[9] I1=n21 I2=n22 I3=n23
XU5 ND2 $PINS O=n1 I1=B[3] I2=carry[3]
XU6 ND2 $PINS O=n2 I1=carry[3] I2=A[3]
XU7 ND2 $PINS O=n3 I1=B[3] I2=A[3]
XU9 MAO222 $PINS O=n16 A1=carry[7] B1=B[7] C1=A[7]
XU10 ND2 $PINS O=n9 I1=B[5] I2=A[5]
XU11 ND3 $PINS O=carry[25] I1=n6 I2=n7 I3=n8
XU13 AN2 $PINS O=n5 I1=B[0] I2=A[0]
XU14 ND2 $PINS O=n20 I1=B[4] I2=A[4]
XU16 ND2 $PINS O=n6 I1=carry[24] I2=B[24]
XU17 ND2 $PINS O=n7 I1=carry[24] I2=A[24]
XU18 ND2S $PINS O=n8 I1=B[24] I2=A[24]
XU20 ND2 $PINS O=n10 I1=carry[5] I2=A[5]
XU21 ND2 $PINS O=n11 I1=carry[5] I2=B[5]
XU23 XOR2HS $PINS O=n12 I1=A[6] I2=B[6]
XU24 XOR2HS $PINS O=SUM[6] I1=n12 I2=carry[6]
XU25 ND2 $PINS O=n13 I1=A[6] I2=B[6]
XU26 ND2 $PINS O=n14 I1=carry[6] I2=A[6]
XU27 ND2 $PINS O=n15 I1=carry[6] I2=B[6]
XU28 ND2 $PINS O=n22 I1=n16 I2=A[8]
XU29 ND2 $PINS O=n21 I1=n16 I2=B[8]
XU30 XOR3 $PINS O=SUM[8] I1=B[8] I2=A[8] I3=carry[8]
XU31 XOR2HS $PINS O=n17 I1=B[4] I2=A[4]
XU32 XOR2HS $PINS O=SUM[4] I1=carry[4] I2=n17
XU34 ND3P $PINS O=carry[5] I1=n18 I2=n19 I3=n20
XU35 ND2S $PINS O=n23 I1=B[8] I2=A[8]
XU36 XOR2HS $PINS O=SUM[0] I1=B[0] I2=A[0]
XU8 ND3P $PINS O=carry[4] I1=n3 I2=n1 I3=n2
XU12 ND3P $PINS O=carry[6] I1=n11 I2=n10 I3=n9
XU22 ND2P $PINS O=n19 I1=carry[4] I2=A[4]
XU33 ND2P $PINS O=n18 I1=carry[4] I2=B[4]
.ENDS

.SUBCKT PE_Shift_Add_3_DW01_add_0_DW01_add_29 A[26] A[25] A[24] A[23] A[22]
+ A[21] A[20] A[19] A[18] A[17] A[16] A[15] A[14] A[13] A[12] A[11] A[10] A[9]
+ A[8] A[7] A[6] A[5] A[4] A[3] A[2] A[1] A[0] B[26] B[25] B[24] B[23] B[22]
+ B[21] B[20] B[19] B[18] B[17] B[16] B[15] B[14] B[13] B[12] B[11] B[10] B[9]
+ B[8] B[7] B[6] B[5] B[4] B[3] B[2] B[1] B[0] CI SUM[26] SUM[25] SUM[24]
+ SUM[23] SUM[22] SUM[21] SUM[20] SUM[19] SUM[18] SUM[17] SUM[16] SUM[15]
+ SUM[14] SUM[13] SUM[12] SUM[11] SUM[10] SUM[9] SUM[8] SUM[7] SUM[6] SUM[5]
+ SUM[4] SUM[3] SUM[2] SUM[1] SUM[0] CO
XFE_RC_1718_0 XNR2H $PINS O=FE_RN_451_0 I1=A[26] I2=B[26]
XFE_RC_1717_0 XNR2H $PINS O=SUM[26] I1=FE_RN_451_0 I2=carry[26]
XFE_RC_1654_0 ND2 $PINS O=FE_RN_417_0 I1=carry[2] I2=B[2]
XFE_RC_1653_0 ND2 $PINS O=FE_RN_418_0 I1=A[2] I2=B[2]
XFE_RC_1652_0 ND2 $PINS O=FE_RN_419_0 I1=carry[2] I2=A[2]
XFE_RC_1651_0 ND3P $PINS O=carry[3] I1=FE_RN_419_0 I2=FE_RN_417_0
+ I3=FE_RN_418_0
XFE_RC_1650_0 ND2 $PINS O=FE_RN_414_0 I1=A[4] I2=B[4]
XFE_RC_1649_0 ND2P $PINS O=FE_RN_415_0 I1=carry[4] I2=A[4]
XFE_RC_1648_0 ND2 $PINS O=FE_RN_416_0 I1=carry[4] I2=B[4]
XFE_RC_1647_0 ND3P $PINS O=n31 I1=FE_RN_416_0 I2=FE_RN_415_0 I3=FE_RN_414_0
XFE_RC_1494_0 MAO222P $PINS O=carry[19] A1=carry[18] B1=B[18] C1=A[18]
XFE_RC_1269_0 INV1S $PINS O=FE_RN_251_0 I=B[12]
XFE_RC_1268_0 AO13 $PINS O=n28 A1=FE_RN_251_0 B1=n24 B2=n23 B3=n22
XFE_RC_1008_0 XOR3 $PINS O=SUM[25] I1=A[25] I2=B[25] I3=carry[25]
XFE_RC_1007_0 MAO222P $PINS O=carry[26] A1=carry[25] B1=B[25] C1=A[25]
XFE_RC_725_0 XOR3 $PINS O=SUM[1] I1=A[1] I2=B[1] I3=n4
XFE_RC_724_0 MAO222 $PINS O=carry[2] A1=A[1] B1=B[1] C1=n4
XFE_RC_511_0 XOR3 $PINS O=SUM[8] I1=A[8] I2=B[8] I3=carry[8]
XFE_RC_510_0 MAO222P $PINS O=carry[9] A1=carry[8] B1=B[8] C1=A[8]
XFE_RC_505_0 XOR3 $PINS O=SUM[2] I1=A[2] I2=B[2] I3=carry[2]
XFE_RC_442_0 XOR3P $PINS O=SUM[21] I1=A[21] I2=B[21] I3=carry[21]
XFE_RC_441_0 MAO222 $PINS O=carry[22] A1=carry[21] B1=A[21] C1=B[21]
XFE_RC_434_0 XOR3 $PINS O=SUM[9] I1=A[9] I2=B[9] I3=carry[9]
XFE_RC_433_0 MAO222P $PINS O=carry[10] A1=carry[9] B1=B[9] C1=A[9]
XFE_RC_345_0 XOR3 $PINS O=SUM[10] I1=A[10] I2=B[10] I3=carry[10]
XFE_RC_344_0 MAO222P $PINS O=carry[11] A1=carry[10] B1=B[10] C1=A[10]
XFE_RC_343_0 XOR3P $PINS O=SUM[22] I1=A[22] I2=B[22] I3=carry[22]
XFE_RC_342_0 MAO222P $PINS O=carry[23] A1=carry[22] B1=A[22] C1=B[22]
XFE_RC_240_0 XOR3T $PINS O=SUM[23] I1=A[23] I2=B[23] I3=carry[23]
XFE_RC_239_0 MAO222P $PINS O=carry[24] A1=carry[23] B1=B[23] C1=A[23]
XFE_RC_236_0 XOR3 $PINS O=SUM[13] I1=A[13] I2=B[13] I3=carry[13]
XFE_RC_235_0 MAO222 $PINS O=carry[14] A1=carry[13] B1=B[13] C1=A[13]
XFE_RC_100_0 XOR3 $PINS O=SUM[24] I1=A[24] I2=B[24] I3=carry[24]
XFE_RC_99_0 MAO222P $PINS O=carry[25] A1=carry[24] B1=B[24] C1=A[24]
XFE_RC_98_0 XOR3 $PINS O=SUM[14] I1=A[14] I2=B[14] I3=carry[14]
XFE_RC_97_0 MAO222P $PINS O=carry[15] A1=carry[14] B1=B[14] C1=A[14]
XFE_RC_53_0 XOR3 $PINS O=SUM[15] I1=A[15] I2=B[15] I3=carry[15]
XFE_RC_52_0 MAO222P $PINS O=carry[16] A1=carry[15] B1=B[15] C1=A[15]
XFE_RC_39_0 XOR3P $PINS O=SUM[19] I1=A[19] I2=B[19] I3=carry[19]
XFE_RC_38_0 MAO222P $PINS O=carry[20] A1=carry[19] B1=B[19] C1=A[19]
XU1_4 FA1S $PINS S=SUM[4] CO=carry[5] A=A[4] B=B[4] CI=carry[4]
XU4 ND3P $PINS O=carry[6] I1=n35 I2=n36 I3=n37
XU5 ND2 $PINS O=n3 I1=A[16] I2=B[16]
XU7 ND2 $PINS O=n37 I1=A[5] I2=B[5]
XU8 ND2 $PINS O=n35 I1=n31 I2=B[5]
XU9 ND2 $PINS O=n36 I1=n31 I2=A[5]
XU10 ND3 $PINS O=carry[13] I1=n28 I2=n27 I3=n26
XU11 XOR3S $PINS O=SUM[5] I1=B[5] I2=A[5] I3=carry[5]
XU13 ND3P $PINS O=carry[17] I1=n2 I2=n1 I3=n3
XU14 XOR3 $PINS O=SUM[16] I1=A[16] I2=B[16] I3=carry[16]
XU15 ND2P $PINS O=n1 I1=carry[16] I2=A[16]
XU16 ND2 $PINS O=n2 I1=carry[16] I2=B[16]
XU17 ND2 $PINS O=n8 I1=A[17] I2=B[17]
XU18 ND2 $PINS O=n15 I1=A[6] I2=B[6]
XU19 ND2 $PINS O=n22 I1=A[11] I2=B[11]
XU20 XOR3 $PINS O=SUM[3] I1=A[3] I2=B[3] I3=carry[3]
XU21 XOR3 $PINS O=SUM[11] I1=A[11] I2=B[11] I3=carry[11]
XU22 AN2 $PINS O=n4 I1=B[0] I2=A[0]
XU23 XOR3 $PINS O=SUM[20] I1=B[20] I2=A[20] I3=carry[20]
XU24 ND2P $PINS O=n5 I1=carry[20] I2=B[20]
XU25 ND2 $PINS O=n6 I1=carry[20] I2=A[20]
XU26 ND2 $PINS O=n7 I1=B[20] I2=A[20]
XU27 ND3P $PINS O=carry[21] I1=n6 I2=n5 I3=n7
XU28 ND2 $PINS O=n9 I1=carry[17] I2=A[17]
XU29 ND2 $PINS O=n10 I1=carry[17] I2=B[17]
XU30 ND3P $PINS O=carry[18] I1=n9 I2=n10 I3=n8
XU31 XOR2HS $PINS O=n11 I1=A[18] I2=B[18]
XU32 XOR2HS $PINS O=SUM[18] I1=n11 I2=carry[18]
XU36 ND2 $PINS O=n16 I1=carry[6] I2=A[6]
XU37 ND2 $PINS O=n17 I1=carry[6] I2=B[6]
XU38 ND3P $PINS O=carry[7] I1=n17 I2=n16 I3=n15
XU39 XOR2HS $PINS O=n18 I1=A[7] I2=B[7]
XU40 XOR2HS $PINS O=SUM[7] I1=carry[7] I2=n18
XU41 ND2 $PINS O=n19 I1=A[7] I2=B[7]
XU42 ND2 $PINS O=n20 I1=carry[7] I2=A[7]
XU43 ND2 $PINS O=n21 I1=carry[7] I2=B[7]
XU44 ND2P $PINS O=n23 I1=carry[11] I2=A[11]
XU45 ND2P $PINS O=n24 I1=carry[11] I2=B[11]
XU46 ND3P $PINS O=carry[12] I1=n23 I2=n24 I3=n22
XU47 XOR2HS $PINS O=n25 I1=A[12] I2=B[12]
XU48 XOR2HS $PINS O=SUM[12] I1=n25 I2=carry[12]
XU49 ND2 $PINS O=n26 I1=A[12] I2=B[12]
XU50 ND2 $PINS O=n27 I1=carry[12] I2=A[12]
XU53 ND2 $PINS O=n34 I1=B[3] I2=A[3]
XU56 ND2 $PINS O=n32 I1=carry[3] I2=A[3]
XU57 ND2 $PINS O=n33 I1=carry[3] I2=B[3]
XU58 XOR2HS $PINS O=SUM[0] I1=B[0] I2=A[0]
XU3 ND3P $PINS O=carry[4] I1=n33 I2=n32 I3=n34
XU6 XOR3 $PINS O=SUM[6] I1=A[6] I2=B[6] I3=carry[6]
XU12 ND3 $PINS O=carry[8] I1=n20 I2=n21 I3=n19
XU59 XOR3 $PINS O=SUM[17] I1=A[17] I2=B[17] I3=carry[17]
.ENDS

.SUBCKT PE_Shift_Add_3 rst_n en clear calc_done stage_sel x_in[16] x_in[15]
+ x_in[14] x_in[13] x_in[12] x_in[11] x_in[10] x_in[9] x_in[8] x_in[7] x_in[6]
+ x_in[5] x_in[4] x_in[3] x_in[2] x_in[1] x_in[0] sign1[1] sign1[0] sign2[1]
+ sign2[0] sign3[1] sign3[0] shf1[3] shf1[2] shf1[1] shf1[0] shf2[3] shf2[2]
+ shf2[1] shf2[0] shf3[3] shf3[2] shf3[1] shf3[0] y_out[16] y_out[15] y_out[14]
+ y_out[13] y_out[12] y_out[11] y_out[10] y_out[9] y_out[8] y_out[7] y_out[6]
+ y_out[5] y_out[4] y_out[3] y_out[2] y_out[1] y_out[0] i_rst_n
+ FE_OFN22_i_rst_n FE_OFN79_n FE_OFN81_n clk_clone2 clk_clone1 clk
XFE_PHC1345_N236 DELB $PINS O=N236 I=FE_PHN1345_N236
XFE_PHC1328_N237 DELB $PINS O=N237 I=FE_PHN1328_N237
XFE_PHC1326_N247 DELB $PINS O=FE_PHN1326_N247 I=N247
XFE_PHC1320_N248 DELB $PINS O=FE_PHN1320_N248 I=N248
XFE_PHC1309_N238 DELB $PINS O=N238 I=FE_PHN1309_N238
XFE_PHC1299_N240 DELB $PINS O=FE_PHN1299_N240 I=N240
XFE_PHC1298_N246 DELC $PINS O=N246 I=FE_PHN1298_N246
XFE_PHC1291_N245 DELC $PINS O=N245 I=FE_PHN1291_N245
XFE_PHC1272_N241 DELB $PINS O=FE_PHN1272_N241 I=N241
XFE_PHC1099_acc_reg_24 DELC $PINS O=FE_PHN1099_acc_reg_24 I=acc_reg[24]
XFE_PHC1087_pe_r2_16 DELC $PINS O=y_out[16] I=FE_PHN1087_pe_r2_16
XFE_PHC1061_next_acc_0 DELA $PINS O=FE_PHN1061_next_acc_0 I=next_acc[0]
XFE_PHC1056_acc_reg_25 DELB $PINS O=FE_PHN1056_acc_reg_25 I=acc_reg[25]
XFE_PHC991_N235 DELB $PINS O=FE_PHN991_N235 I=N235
XFE_PHC980_N242 DELB $PINS O=N242 I=FE_PHN980_N242
XFE_PHC977_N239 DELB $PINS O=FE_PHN977_N239 I=N239
XFE_PHC971_acc_reg_13 DELB $PINS O=FE_PHN971_acc_reg_13 I=acc_reg[13]
XFE_PHC966_N244 DELB $PINS O=FE_PHN966_N244 I=N244
XFE_PHC963_N243 DELB $PINS O=FE_PHN963_N243 I=N243
XFE_PHC933_acc_reg_15 DELB $PINS O=FE_PHN933_acc_reg_15 I=acc_reg[15]
XFE_PHC920_acc_reg_16 DELB $PINS O=FE_PHN920_acc_reg_16 I=acc_reg[16]
XFE_PHC743_N251 DELC $PINS O=FE_PHN743_N251 I=N251
XFE_PHC727_pe_r2_9 DELC $PINS O=y_out[9] I=FE_PHN727_pe_r2_9
XFE_RC_1837_0 INV1S $PINS O=FE_RN_511_0 I=shf2[3]
XFE_RC_1836_0 AN2B1T $PINS O=term2_shifted[4] I1=sll_17/ML_int[3][4]
+ B1=FE_RN_511_0
XFE_RC_1804_0 MUX2 $PINS O=sll_16/ML_int[1][1] S=shf1[0] A=term1_in[1]
+ B=term1_in[0]
XFE_RC_1682_0 ND2 $PINS O=FE_RN_432_0 I1=term1_shifted[3] I2=FE_OFN351_n
XFE_RC_1681_0 ND2 $PINS O=FE_RN_433_0 I1=N17 I2=sign1[0]
XFE_RC_1680_0 ND2P $PINS O=N44 I1=FE_RN_433_0 I2=FE_RN_432_0
XFE_RC_1625_0 AOI22S $PINS O=FE_RN_369_0 A1=term3_shifted[4] A2=FE_OFN365_n20
+ B1=N128 B2=sign3[0]
XFE_RC_1556_0 INV2 $PINS O=N155 I=FE_RN_369_0
XFE_RC_1520_0 OR3B2 $PINS O=n73 I1=shf3[1] B1=term3_in[0] B2=n13
XFE_RC_1491_0 INV1S $PINS O=FE_RN_341_0 I=sll_18/ML_int[2][4]
XFE_RC_1490_0 MXL2HS $PINS OB=sll_18/ML_int[3][4] S=FE_OFN332_h23_2
+ A=FE_RN_341_0 B=n73
XFE_RC_1432_0 OR2 $PINS O=FE_RN_314_0 I1=n75 I2=shf3[1]
XFE_RC_1431_0 NR2P $PINS O=term3_shifted[1] I1=FE_RN_314_0 I2=FE_RN_65_0
XFE_RC_1312_0 AN2B1 $PINS O=term2_shifted[3] I1=sll_17/ML_int[2][3] B1=n65
XFE_RC_1311_0 INV1S $PINS O=N158 I=FE_RN_267_0
XFE_RC_1310_0 AOI22S $PINS O=FE_RN_267_0 A1=N131 A2=sign3[0]
+ B1=term3_shifted[7] B2=FE_OFN365_n20
XFE_RC_1285_0 ND2 $PINS O=FE_RN_257_0 I1=N70 I2=FE_OFN317_s22_0
XFE_RC_1284_0 OR3B1 $PINS O=FE_RN_258_0 I1=n65 I2=n64 B1=sign2[0]
XFE_RC_1283_0 ND2 $PINS O=N97 I1=FE_RN_258_0 I2=FE_RN_257_0
XFE_RC_1262_0 AN3 $PINS O=FE_RN_248_0 I1=sll_16/ML_int[3][4] I2=n41
+ I3=FE_OFN351_n
XFE_RC_1261_0 AO12P $PINS O=N45 A1=FE_RN_248_0 B1=N18 B2=sign1[0]
XFE_RC_1241_0 ND2P $PINS O=FE_RN_237_0 I1=N15 I2=sign1[0]
XFE_RC_1240_0 OR3B1 $PINS O=FE_RN_238_0 I1=n54 I2=n53 B1=FE_OFN351_n
XFE_RC_1239_0 ND2P $PINS O=N42 I1=FE_RN_237_0 I2=FE_RN_238_0
XFE_RC_1220_0 ND2 $PINS O=FE_RN_225_0 I1=term3_shifted[2] I2=n20
XFE_RC_1219_0 ND2 $PINS O=FE_RN_226_0 I1=N126 I2=sign3[0]
XFE_RC_1218_0 ND2P $PINS O=N153 I1=FE_RN_226_0 I2=FE_RN_225_0
XFE_RC_1165_0 MUXB2 $PINS O=term1_shifted[2] S=shf1[1] A=sll_16/ML_int[1][2]
+ B=sll_16/ML_int[1][0] EB=n54
XFE_RC_1107_0 OR2 $PINS O=n74 I1=shf3[1] I2=FE_RN_65_0
XFE_RC_941_0 MUXB2 $PINS O=term2_shifted[2] S=shf2[1] A=sll_17/ML_int[1][2]
+ B=sll_17/ML_int[1][0] EB=n65
XFE_RC_832_0 MXL2HS $PINS OB=FE_RN_65_0 S=shf3[0] A=term3_in[1] B=term3_in[0]
XFE_RC_15_0 OA12 $PINS O=N151 A1=term3_shifted[0] B1=sign3[0] B2=n20
XFE_RC_13_0 MUX2 $PINS O=N122 S=sign2[0] A=N95 B=term2_shifted[26]
XFE_RC_7_0 OA12 $PINS O=N96 A1=term2_shifted[0] B1=FE_OFN317_s22_0 B2=sign2[0]
XFE_RC_6_0 OA12 $PINS O=N41 A1=term1_shifted[0] B1=sign1[0] B2=FE_OFN351_n
XFE_OFC685_n20 BUF1 $PINS O=FE_OFN365_n20 I=n20
XFE_OFC626_s21_0 INV1S $PINS O=FE_OFN351_n I=sign1[0]
XFE_OFC625_s21_0 INV1S $PINS O=FE_OFN350_n I=sign1[0]
XFE_OFC624_s21_0 BUF1 $PINS O=FE_OFN349_n I=sign1[0]
XFE_OFC583_sll_17_ML_int_2__3 INV1S $PINS O=n66 I=sll_17/ML_int[2][3]
XFE_OFC579_sll_16_ML_int_2__3 INV1S $PINS O=n55 I=sll_16/ML_int[2][3]
XFE_OFC567_sll_18_ML_int_2__3 INV2 $PINS O=n76 I=sll_18/ML_int[2][3]
XFE_OFC564_h23_2 INV1S $PINS O=FE_OFN332_h23_2 I=shf3[2]
XFE_OFC563_h23_2 INV1S $PINS O=FE_OFN331_h23_2 I=shf3[2]
XFE_OFC529_sll_17_ML_int_2__2 INV1S $PINS O=n67 I=sll_17/ML_int[2][2]
XFE_OFC528_s22_0 INV2 $PINS O=FE_OFN317_s22_0 I=sign2[0]
XFE_OFC527_s22_0 INV1S $PINS O=FE_OFN316_s22_0 I=sign2[0]
XFE_OFC526_s22_0 INV1S $PINS O=FE_OFN266_n I=sign2[0]
XFE_OFC514_h22_3 INV1S $PINS O=FE_OFN314_h22_3 I=shf2[3]
XFE_OFC513_h22_3 INV1S $PINS O=FE_OFN313_h22_3 I=shf2[3]
XFE_OFC512_h22_3 INV1S $PINS O=n30 I=shf2[3]
XFE_OFC506_h22_2 INV1S $PINS O=n28 I=shf2[2]
XFE_OFC504_sll_16_ML_int_2__2 INV1S $PINS O=n56 I=sll_16/ML_int[2][2]
XFE_OFC385_h23_0 INV1S $PINS O=n13 I=shf3[0]
XFE_OFC367_h22_1 INV1S $PINS O=n26 I=shf2[1]
XFE_OFC348_h22_0 INV1S $PINS O=n24 I=shf2[0]
XFE_OFC262_h21_3 INV1S $PINS O=n41 I=shf1[3]
XFE_OFC216_h23_3 INV1S $PINS O=n17 I=shf3[3]
XFE_OFC196_s23_0 INV1S $PINS O=n20 I=sign3[0]
XU110 AO22 $PINS O=base_val[13] A1=acc_reg[13] A2=FE_OFN79_n B1=clear
+ B2=stage_sel
XU115 AO22 $PINS O=N67 A1=FE_OFN349_n A2=N40 B1=term1_shifted[26]
+ B2=FE_OFN350_n
XU116 AO22 $PINS O=N66 A1=N39 A2=FE_OFN81_n B1=term1_shifted[25] B2=FE_OFN350_n
XU117 AO22 $PINS O=N65 A1=N38 A2=FE_OFN81_n B1=term1_shifted[24] B2=FE_OFN350_n
XU118 AO22 $PINS O=N64 A1=N37 A2=FE_OFN81_n B1=term1_shifted[23] B2=FE_OFN350_n
XU119 AO22 $PINS O=N63 A1=N36 A2=FE_OFN81_n B1=term1_shifted[22] B2=FE_OFN350_n
XU120 AO22 $PINS O=N62 A1=N35 A2=FE_OFN349_n B1=term1_shifted[21]
+ B2=FE_OFN350_n
XU121 AO22 $PINS O=N61 A1=N34 A2=FE_OFN349_n B1=term1_shifted[20]
+ B2=FE_OFN350_n
XU122 AO22 $PINS O=N60 A1=N33 A2=FE_OFN349_n B1=term1_shifted[19]
+ B2=FE_OFN350_n
XU123 AO22 $PINS O=N59 A1=N32 A2=FE_OFN349_n B1=term1_shifted[18]
+ B2=FE_OFN350_n
XU124 AO22 $PINS O=N58 A1=N31 A2=FE_OFN349_n B1=term1_shifted[17]
+ B2=FE_OFN350_n
XU127 AO22 $PINS O=N55 A1=N28 A2=sign1[0] B1=term1_shifted[14] B2=FE_OFN351_n
XU128 AO22 $PINS O=N54 A1=N27 A2=sign1[0] B1=term1_shifted[13] B2=FE_OFN350_n
XU129 AO22 $PINS O=N53 A1=N26 A2=sign1[0] B1=term1_shifted[12] B2=FE_OFN351_n
XU130 AO22 $PINS O=N52 A1=N25 A2=sign1[0] B1=term1_shifted[11] B2=FE_OFN351_n
XU132 AO22 $PINS O=N50 A1=N23 A2=sign1[0] B1=term1_shifted[9] B2=FE_OFN351_n
XU134 AO22 $PINS O=N48 A1=N21 A2=sign1[0] B1=term1_shifted[7] B2=FE_OFN351_n
XU136 AO22 $PINS O=N46 A1=N19 A2=sign1[0] B1=term1_shifted[5] B2=FE_OFN351_n
XU142 AO22 $PINS O=N177 A1=sign3[0] A2=N150 B1=term3_shifted[26]
+ B2=FE_OFN365_n20
XU143 AO22 $PINS O=N176 A1=N149 A2=sign3[0] B1=term3_shifted[25]
+ B2=FE_OFN365_n20
XU144 AO22 $PINS O=N175 A1=N148 A2=sign3[0] B1=term3_shifted[24]
+ B2=FE_OFN365_n20
XU145 AO22 $PINS O=N174 A1=N147 A2=sign3[0] B1=term3_shifted[23]
+ B2=FE_OFN365_n20
XU146 AO22 $PINS O=N173 A1=N146 A2=sign3[0] B1=term3_shifted[22]
+ B2=FE_OFN365_n20
XU147 AO22 $PINS O=N172 A1=N145 A2=sign3[0] B1=term3_shifted[21]
+ B2=FE_OFN365_n20
XU148 AO22 $PINS O=N171 A1=N144 A2=sign3[0] B1=term3_shifted[20]
+ B2=FE_OFN365_n20
XU149 AO22 $PINS O=N170 A1=N143 A2=sign3[0] B1=term3_shifted[19]
+ B2=FE_OFN365_n20
XU150 AO22 $PINS O=N169 A1=N142 A2=sign3[0] B1=term3_shifted[18]
+ B2=FE_OFN365_n20
XU151 AO22 $PINS O=N168 A1=N141 A2=sign3[0] B1=term3_shifted[17]
+ B2=FE_OFN365_n20
XU152 AO22 $PINS O=N167 A1=N140 A2=sign3[0] B1=term3_shifted[16]
+ B2=FE_OFN365_n20
XU153 AO22 $PINS O=N166 A1=N139 A2=sign3[0] B1=term3_shifted[15]
+ B2=FE_OFN365_n20
XU154 AO22 $PINS O=N165 A1=N138 A2=sign3[0] B1=term3_shifted[14]
+ B2=FE_OFN365_n20
XU155 AO22 $PINS O=N164 A1=N137 A2=sign3[0] B1=term3_shifted[13] B2=n20
XU156 AO22 $PINS O=N163 A1=N136 A2=sign3[0] B1=term3_shifted[12] B2=n20
XU157 AO22 $PINS O=N162 A1=N135 A2=sign3[0] B1=term3_shifted[11] B2=n20
XU159 AO22 $PINS O=N160 A1=N133 A2=sign3[0] B1=term3_shifted[9] B2=n20
XU163 AO22 $PINS O=N156 A1=N129 A2=sign3[0] B1=term3_shifted[5]
+ B2=FE_OFN365_n20
XU170 AO22 $PINS O=N121 A1=N94 A2=FE_OFN316_s22_0 B1=term2_shifted[25]
+ B2=sign2[0]
XU173 AO22 $PINS O=N118 A1=N91 A2=FE_OFN316_s22_0 B1=term2_shifted[22]
+ B2=sign2[0]
XU174 AO22 $PINS O=N117 A1=N90 A2=FE_OFN316_s22_0 B1=term2_shifted[21]
+ B2=sign2[0]
XU175 AO22 $PINS O=N116 A1=N89 A2=FE_OFN316_s22_0 B1=term2_shifted[20]
+ B2=sign2[0]
XU176 AO22 $PINS O=N115 A1=N88 A2=FE_OFN266_n B1=term2_shifted[19] B2=sign2[0]
XU177 AO22 $PINS O=N114 A1=N87 A2=FE_OFN266_n B1=term2_shifted[18] B2=sign2[0]
XU178 AO22 $PINS O=N113 A1=N86 A2=FE_OFN266_n B1=term2_shifted[17] B2=sign2[0]
XU179 AO22 $PINS O=N112 A1=N85 A2=FE_OFN266_n B1=term2_shifted[16] B2=sign2[0]
XU180 AO22 $PINS O=N111 A1=N84 A2=FE_OFN266_n B1=term2_shifted[15] B2=sign2[0]
XU181 AO22 $PINS O=N110 A1=N83 A2=FE_OFN266_n B1=term2_shifted[14] B2=sign2[0]
XU183 AO22 $PINS O=N108 A1=N81 A2=FE_OFN266_n B1=term2_shifted[12] B2=sign2[0]
XU184 AO22 $PINS O=N107 A1=N80 A2=FE_OFN266_n B1=term2_shifted[11] B2=sign2[0]
XU185 AO22 $PINS O=N106 A1=N79 A2=FE_OFN317_s22_0 B1=term2_shifted[10]
+ B2=sign2[0]
XU186 AO22 $PINS O=N105 A1=N78 A2=FE_OFN317_s22_0 B1=term2_shifted[9]
+ B2=sign2[0]
XU188 AO22 $PINS O=N103 A1=N76 A2=FE_OFN317_s22_0 B1=term2_shifted[7]
+ B2=sign2[0]
XU189 AO22 $PINS O=N102 A1=N75 A2=FE_OFN317_s22_0 B1=term2_shifted[6]
+ B2=sign2[0]
XU190 AO22 $PINS O=N101 A1=N74 A2=FE_OFN317_s22_0 B1=term2_shifted[5]
+ B2=sign2[0]
Xsll_18/M1_0_2 MUX2 $PINS O=sll_18/ML_int[1][2] S=shf3[0] A=term3_in[2]
+ B=term3_in[1]
Xsll_18/M1_0_4 MUX2 $PINS O=sll_18/ML_int[1][4] S=shf3[0] A=term3_in[4]
+ B=term3_in[3]
Xsll_18/M1_0_5 MUX2 $PINS O=sll_18/ML_int[1][5] S=shf3[0] A=term3_in[5]
+ B=term3_in[4]
Xsll_18/M1_0_6 MUX2 $PINS O=sll_18/ML_int[1][6] S=shf3[0] A=term3_in[6]
+ B=term3_in[5]
Xsll_18/M1_0_7 MUX2 $PINS O=sll_18/ML_int[1][7] S=shf3[0] A=term3_in[7]
+ B=term3_in[6]
Xsll_18/M1_1_4 MUX2 $PINS O=sll_18/ML_int[2][4] S=shf3[1] A=sll_18/ML_int[1][4]
+ B=sll_18/ML_int[1][2]
Xsll_18/M1_1_5 MUX2 $PINS O=sll_18/ML_int[2][5] S=shf3[1] A=sll_18/ML_int[1][5]
+ B=sll_18/ML_int[1][3]
Xsll_18/M1_1_6 MUX2 $PINS O=sll_18/ML_int[2][6] S=shf3[1] A=sll_18/ML_int[1][6]
+ B=sll_18/ML_int[1][4]
Xsll_18/M1_1_7 MUX2 $PINS O=sll_18/ML_int[2][7] S=shf3[1] A=sll_18/ML_int[1][7]
+ B=sll_18/ML_int[1][5]
Xsll_18/M1_1_8 MUX2 $PINS O=sll_18/ML_int[2][8] S=shf3[1] A=sll_18/ML_int[1][8]
+ B=sll_18/ML_int[1][6]
Xsll_18/M1_2_5 MUX2 $PINS O=sll_18/ML_int[3][5] S=FE_OFN332_h23_2
+ A=sll_18/ML_int[2][5] B=n79
Xsll_18/M1_2_7 MUX2 $PINS O=sll_18/ML_int[3][7] S=FE_OFN332_h23_2
+ A=sll_18/ML_int[2][7] B=sll_18/ML_int[2][3]
Xsll_18/M1_2_8 MUX2 $PINS O=sll_18/ML_int[3][8] S=FE_OFN332_h23_2
+ A=sll_18/ML_int[2][8] B=sll_18/ML_int[2][4]
Xsll_18/M1_2_9 MUX2 $PINS O=sll_18/ML_int[3][9] S=FE_OFN331_h23_2
+ A=sll_18/ML_int[2][9] B=sll_18/ML_int[2][5]
Xsll_18/M1_2_10 MUX2 $PINS O=sll_18/ML_int[3][10] S=FE_OFN331_h23_2
+ A=sll_18/ML_int[2][10] B=sll_18/ML_int[2][6]
Xsll_18/M1_3_8 MUX2 $PINS O=term3_shifted[8] S=shf3[3] A=sll_18/ML_int[3][8]
+ B=sll_18/ML_int[3][0]
Xsll_18/M1_3_9 MUX2 $PINS O=term3_shifted[9] S=shf3[3] A=sll_18/ML_int[3][9]
+ B=sll_18/ML_int[3][1]
Xsll_18/M1_3_10 MUX2 $PINS O=term3_shifted[10] S=shf3[3] A=sll_18/ML_int[3][10]
+ B=sll_18/ML_int[3][2]
Xsll_18/M1_3_11 MUX2 $PINS O=term3_shifted[11] S=shf3[3] A=sll_18/ML_int[3][11]
+ B=sll_18/ML_int[3][3]
Xsll_18/M1_3_12 MUX2 $PINS O=term3_shifted[12] S=shf3[3] A=sll_18/ML_int[3][12]
+ B=sll_18/ML_int[3][4]
Xsll_18/M1_3_13 MUX2 $PINS O=term3_shifted[13] S=shf3[3] A=sll_18/ML_int[3][13]
+ B=sll_18/ML_int[3][5]
Xsll_18/M1_3_14 MUX2 $PINS O=term3_shifted[14] S=shf3[3] A=sll_18/ML_int[3][14]
+ B=sll_18/ML_int[3][6]
Xsll_18/M1_3_23 MUX2 $PINS O=term3_shifted[23] S=shf3[3] A=term3_in[26]
+ B=sll_18/ML_int[3][15]
Xsll_17/M1_0_2 MUX2 $PINS O=sll_17/ML_int[1][2] S=shf2[0] A=term2_in[2]
+ B=term2_in[1]
Xsll_17/M1_0_3 MUX2 $PINS O=sll_17/ML_int[1][3] S=shf2[0] A=term2_in[3]
+ B=term2_in[2]
Xsll_17/M1_0_4 MUX2 $PINS O=sll_17/ML_int[1][4] S=shf2[0] A=term2_in[4]
+ B=term2_in[3]
Xsll_17/M1_0_5 MUX2 $PINS O=sll_17/ML_int[1][5] S=shf2[0] A=term2_in[5]
+ B=term2_in[4]
Xsll_17/M1_0_6 MUX2 $PINS O=sll_17/ML_int[1][6] S=shf2[0] A=term2_in[6]
+ B=term2_in[5]
Xsll_17/M1_1_3 MUX2 $PINS O=sll_17/ML_int[2][3] S=shf2[1] A=sll_17/ML_int[1][3]
+ B=sll_17/ML_int[1][1]
Xsll_17/M1_1_4 MUX2 $PINS O=sll_17/ML_int[2][4] S=shf2[1] A=sll_17/ML_int[1][4]
+ B=sll_17/ML_int[1][2]
Xsll_17/M1_1_5 MUX2 $PINS O=sll_17/ML_int[2][5] S=shf2[1] A=sll_17/ML_int[1][5]
+ B=sll_17/ML_int[1][3]
Xsll_17/M1_1_6 MUX2 $PINS O=sll_17/ML_int[2][6] S=shf2[1] A=sll_17/ML_int[1][6]
+ B=sll_17/ML_int[1][4]
Xsll_17/M1_1_7 MUX2 $PINS O=sll_17/ML_int[2][7] S=shf2[1] A=sll_17/ML_int[1][7]
+ B=sll_17/ML_int[1][5]
Xsll_17/M1_2_4 MUX2 $PINS O=sll_17/ML_int[3][4] S=n28 A=sll_17/ML_int[2][4]
+ B=n5
Xsll_17/M1_2_5 MUX2 $PINS O=sll_17/ML_int[3][5] S=n28 A=sll_17/ML_int[2][5]
+ B=n68
Xsll_17/M1_2_6 MUX2 $PINS O=sll_17/ML_int[3][6] S=n28 A=sll_17/ML_int[2][6]
+ B=sll_17/ML_int[2][2]
Xsll_17/M1_2_7 MUX2 $PINS O=sll_17/ML_int[3][7] S=n28 A=sll_17/ML_int[2][7]
+ B=sll_17/ML_int[2][3]
Xsll_17/M1_2_8 MUX2 $PINS O=sll_17/ML_int[3][8] S=n28 A=sll_17/ML_int[2][8]
+ B=sll_17/ML_int[2][4]
Xsll_17/M1_2_9 MUX2 $PINS O=sll_17/ML_int[3][9] S=n28 A=sll_17/ML_int[2][9]
+ B=sll_17/ML_int[2][5]
Xsll_17/M1_3_8 MUX2 $PINS O=term2_shifted[8] S=FE_OFN314_h22_3
+ A=sll_17/ML_int[3][8] B=sll_17/ML_int[3][0]
Xsll_17/M1_3_9 MUX2 $PINS O=term2_shifted[9] S=FE_OFN314_h22_3
+ A=sll_17/ML_int[3][9] B=sll_17/ML_int[3][1]
Xsll_17/M1_3_10 MUX2 $PINS O=term2_shifted[10] S=FE_OFN314_h22_3
+ A=sll_17/ML_int[3][10] B=sll_17/ML_int[3][2]
Xsll_17/M1_3_11 MUX2 $PINS O=term2_shifted[11] S=FE_OFN314_h22_3
+ A=sll_17/ML_int[3][11] B=sll_17/ML_int[3][3]
Xsll_17/M1_3_12 MUX2 $PINS O=term2_shifted[12] S=FE_OFN314_h22_3
+ A=sll_17/ML_int[3][12] B=sll_17/ML_int[3][4]
Xsll_17/M1_3_13 MUX2 $PINS O=term2_shifted[13] S=FE_OFN314_h22_3
+ A=sll_17/ML_int[3][13] B=sll_17/ML_int[3][5]
Xsll_17/M1_3_23 MUX2 $PINS O=term2_shifted[23] S=FE_OFN313_h22_3 A=term2_in[26]
+ B=sll_17/ML_int[3][15]
Xsll_16/M1_0_2 MUX2 $PINS O=sll_16/ML_int[1][2] S=shf1[0] A=term1_in[2]
+ B=term1_in[1]
Xsll_16/M1_0_4 MUX2 $PINS O=sll_16/ML_int[1][4] S=shf1[0] A=term1_in[4]
+ B=term1_in[3]
Xsll_16/M1_0_5 MUX2 $PINS O=sll_16/ML_int[1][5] S=shf1[0] A=term1_in[5]
+ B=term1_in[4]
Xsll_16/M1_0_6 MUX2 $PINS O=sll_16/ML_int[1][6] S=shf1[0] A=term1_in[6]
+ B=term1_in[5]
Xsll_16/M1_0_7 MUX2 $PINS O=sll_16/ML_int[1][7] S=shf1[0] A=term1_in[7]
+ B=term1_in[6]
Xsll_16/M1_1_4 MUX2 $PINS O=sll_16/ML_int[2][4] S=shf1[1] A=sll_16/ML_int[1][4]
+ B=sll_16/ML_int[1][2]
Xsll_16/M1_1_5 MUX2 $PINS O=sll_16/ML_int[2][5] S=shf1[1] A=sll_16/ML_int[1][5]
+ B=sll_16/ML_int[1][3]
Xsll_16/M1_1_6 MUX2 $PINS O=sll_16/ML_int[2][6] S=shf1[1] A=sll_16/ML_int[1][6]
+ B=sll_16/ML_int[1][4]
Xsll_16/M1_1_7 MUX2 $PINS O=sll_16/ML_int[2][7] S=shf1[1] A=sll_16/ML_int[1][7]
+ B=sll_16/ML_int[1][5]
Xsll_16/M1_1_8 MUX2 $PINS O=sll_16/ML_int[2][8] S=shf1[1] A=sll_16/ML_int[1][8]
+ B=sll_16/ML_int[1][6]
Xsll_16/M1_2_4 MUX2 $PINS O=sll_16/ML_int[3][4] S=shf1[2] A=sll_16/ML_int[2][4]
+ B=n57
Xsll_16/M1_2_5 MUX2 $PINS O=sll_16/ML_int[3][5] S=shf1[2] A=sll_16/ML_int[2][5]
+ B=n58
Xsll_16/M1_2_7 MUX2 $PINS O=sll_16/ML_int[3][7] S=shf1[2] A=sll_16/ML_int[2][7]
+ B=sll_16/ML_int[2][3]
Xsll_16/M1_2_8 MUX2 $PINS O=sll_16/ML_int[3][8] S=shf1[2] A=sll_16/ML_int[2][8]
+ B=sll_16/ML_int[2][4]
Xsll_16/M1_2_9 MUX2 $PINS O=sll_16/ML_int[3][9] S=shf1[2] A=sll_16/ML_int[2][9]
+ B=sll_16/ML_int[2][5]
Xsll_16/M1_2_10 MUX2 $PINS O=sll_16/ML_int[3][10] S=shf1[2]
+ A=sll_16/ML_int[2][10] B=sll_16/ML_int[2][6]
Xsll_16/M1_3_8 MUX2 $PINS O=term1_shifted[8] S=shf1[3] A=sll_16/ML_int[3][8]
+ B=sll_16/ML_int[3][0]
Xsll_16/M1_3_9 MUX2 $PINS O=term1_shifted[9] S=shf1[3] A=sll_16/ML_int[3][9]
+ B=sll_16/ML_int[3][1]
Xsll_16/M1_3_10 MUX2 $PINS O=term1_shifted[10] S=shf1[3] A=sll_16/ML_int[3][10]
+ B=sll_16/ML_int[3][2]
Xsll_16/M1_3_11 MUX2 $PINS O=term1_shifted[11] S=shf1[3] A=sll_16/ML_int[3][11]
+ B=sll_16/ML_int[3][3]
Xsll_16/M1_3_12 MUX2 $PINS O=term1_shifted[12] S=shf1[3] A=sll_16/ML_int[3][12]
+ B=sll_16/ML_int[3][4]
Xsll_16/M1_3_13 MUX2 $PINS O=term1_shifted[13] S=shf1[3] A=sll_16/ML_int[3][13]
+ B=sll_16/ML_int[3][5]
Xsll_16/M1_3_14 MUX2 $PINS O=term1_shifted[14] S=shf1[3] A=sll_16/ML_int[3][14]
+ B=sll_16/ML_int[3][6]
Xsll_16/M1_3_23 MUX2 $PINS O=term1_shifted[23] S=shf1[3] A=term1_in[26]
+ B=sll_16/ML_int[3][15]
Xy_out_reg[9] QDFFRBN $PINS Q=FE_PHN727_pe_r2_9 D=FE_PHN966_N244 CK=net2254
+ RB=FE_OFN22_i_rst_n
Xy_out_reg[8] QDFFRBN $PINS Q=y_out[8] D=FE_PHN963_N243 CK=net2254
+ RB=FE_OFN22_i_rst_n
Xy_out_reg[7] QDFFRBN $PINS Q=y_out[7] D=N242 CK=net2254 RB=FE_OFN22_i_rst_n
Xy_out_reg[6] QDFFRBN $PINS Q=y_out[6] D=FE_PHN1272_N241 CK=net2254
+ RB=FE_OFN22_i_rst_n
Xy_out_reg[5] QDFFRBN $PINS Q=y_out[5] D=FE_PHN1299_N240 CK=net2254
+ RB=FE_OFN22_i_rst_n
Xy_out_reg[4] QDFFRBN $PINS Q=y_out[4] D=FE_PHN977_N239 CK=net2254
+ RB=FE_OFN22_i_rst_n
Xy_out_reg[3] QDFFRBN $PINS Q=y_out[3] D=N238 CK=net2254 RB=FE_OFN22_i_rst_n
Xy_out_reg[2] QDFFRBN $PINS Q=y_out[2] D=N237 CK=net2254 RB=FE_OFN22_i_rst_n
Xy_out_reg[1] QDFFRBN $PINS Q=y_out[1] D=N236 CK=net2254 RB=FE_OFN22_i_rst_n
Xy_out_reg[0] QDFFRBN $PINS Q=y_out[0] D=FE_PHN991_N235 CK=net2254
+ RB=FE_OFN22_i_rst_n
Xy_out_reg[16] QDFFRBN $PINS Q=FE_PHN1087_pe_r2_16 D=FE_PHN743_N251 CK=net2254
+ RB=FE_OFN22_i_rst_n
Xy_out_reg[10] QDFFRBN $PINS Q=y_out[10] D=N245 CK=net2254 RB=FE_OFN22_i_rst_n
Xy_out_reg[11] QDFFRBN $PINS Q=y_out[11] D=N246 CK=net2254 RB=FE_OFN22_i_rst_n
Xy_out_reg[12] QDFFRBN $PINS Q=y_out[12] D=FE_PHN1326_N247 CK=net2254
+ RB=FE_OFN22_i_rst_n
Xy_out_reg[14] QDFFRBN $PINS Q=y_out[14] D=N249 CK=net2254 RB=FE_OFN22_i_rst_n
Xy_out_reg[15] QDFFRBN $PINS Q=y_out[15] D=N250 CK=net2254 RB=FE_OFN22_i_rst_n
Xy_out_reg[13] QDFFRBN $PINS Q=y_out[13] D=FE_PHN1320_N248 CK=net2254
+ RB=FE_OFN22_i_rst_n
Xacc_reg_reg[25] QDFFRBN $PINS Q=acc_reg[25] D=next_acc[25] CK=clk_clone1
+ RB=FE_OFN22_i_rst_n
Xacc_reg_reg[24] QDFFRBN $PINS Q=acc_reg[24] D=next_acc[24] CK=clk_clone1
+ RB=FE_OFN22_i_rst_n
Xacc_reg_reg[23] QDFFRBN $PINS Q=acc_reg[23] D=next_acc[23] CK=clk_clone1
+ RB=FE_OFN22_i_rst_n
Xacc_reg_reg[22] QDFFRBN $PINS Q=acc_reg[22] D=next_acc[22] CK=clk_clone1
+ RB=FE_OFN22_i_rst_n
Xacc_reg_reg[21] QDFFRBN $PINS Q=acc_reg[21] D=next_acc[21] CK=clk_clone1
+ RB=FE_OFN22_i_rst_n
Xacc_reg_reg[20] QDFFRBN $PINS Q=acc_reg[20] D=next_acc[20] CK=clk_clone1
+ RB=FE_OFN22_i_rst_n
Xacc_reg_reg[19] QDFFRBN $PINS Q=acc_reg[19] D=next_acc[19] CK=clk_clone1
+ RB=FE_OFN22_i_rst_n
Xacc_reg_reg[18] QDFFRBN $PINS Q=acc_reg[18] D=next_acc[18] CK=clk_clone1
+ RB=FE_OFN22_i_rst_n
Xacc_reg_reg[17] QDFFRBN $PINS Q=acc_reg[17] D=next_acc[17] CK=clk_clone1
+ RB=FE_OFN22_i_rst_n
Xacc_reg_reg[16] QDFFRBN $PINS Q=acc_reg[16] D=next_acc[16] CK=clk_clone1
+ RB=FE_OFN22_i_rst_n
Xacc_reg_reg[15] QDFFRBN $PINS Q=acc_reg[15] D=next_acc[15] CK=clk_clone1
+ RB=FE_OFN22_i_rst_n
Xacc_reg_reg[14] QDFFRBN $PINS Q=acc_reg[14] D=next_acc[14] CK=clk_clone1
+ RB=FE_OFN22_i_rst_n
Xacc_reg_reg[13] QDFFRBN $PINS Q=acc_reg[13] D=next_acc[13] CK=clk_clone1
+ RB=i_rst_n
Xacc_reg_reg[12] QDFFRBN $PINS Q=acc_reg[12] D=next_acc[12] CK=clk_clone1
+ RB=i_rst_n
Xacc_reg_reg[11] QDFFRBN $PINS Q=acc_reg[11] D=next_acc[11] CK=clk_clone1
+ RB=i_rst_n
Xacc_reg_reg[10] QDFFRBN $PINS Q=acc_reg[10] D=next_acc[10] CK=clk_clone1
+ RB=i_rst_n
Xacc_reg_reg[9] QDFFRBN $PINS Q=acc_reg[9] D=next_acc[9] CK=clk_clone1
+ RB=i_rst_n
Xacc_reg_reg[8] QDFFRBN $PINS Q=acc_reg[8] D=next_acc[8] CK=clk_clone1
+ RB=i_rst_n
Xacc_reg_reg[7] QDFFRBN $PINS Q=acc_reg[7] D=next_acc[7] CK=clk_clone1
+ RB=i_rst_n
Xacc_reg_reg[6] QDFFRBN $PINS Q=acc_reg[6] D=next_acc[6] CK=clk_clone1
+ RB=i_rst_n
Xacc_reg_reg[5] QDFFRBN $PINS Q=acc_reg[5] D=next_acc[5] CK=clk_clone1
+ RB=i_rst_n
Xacc_reg_reg[4] QDFFRBN $PINS Q=acc_reg[4] D=next_acc[4] CK=clk_clone1
+ RB=i_rst_n
Xacc_reg_reg[3] QDFFRBN $PINS Q=acc_reg[3] D=next_acc[3] CK=clk_clone1
+ RB=i_rst_n
Xacc_reg_reg[2] QDFFRBN $PINS Q=acc_reg[2] D=next_acc[2] CK=clk_clone1
+ RB=i_rst_n
Xacc_reg_reg[1] QDFFRBN $PINS Q=acc_reg[1] D=next_acc[1] CK=clk_clone1
+ RB=i_rst_n
Xacc_reg_reg[0] QDFFRBS $PINS Q=acc_reg[0] D=FE_PHN1061_next_acc_0
+ CK=clk_clone1 RB=i_rst_n
Xacc_reg_reg[26] QDFFRBP $PINS Q=N251 D=next_acc[26] CK=clk_clone1
+ RB=FE_OFN22_i_rst_n
XU6 MUX2S $PINS O=sll_16/ML_int[1][3] S=shf1[0] A=term1_in[3] B=term1_in[2]
XU8 ND2P $PINS O=n53 I1=sll_16/ML_int[1][1] I2=n39
XU9 ND2 $PINS O=N98 I1=n8 I2=n9
XU10 MUX2 $PINS O=sll_18/ML_int[1][3] S=shf3[0] A=term3_in[3] B=term3_in[2]
XU17 AO22 $PINS O=N99 A1=N72 A2=FE_OFN317_s22_0 B1=term2_shifted[3] B2=sign2[0]
XU20 OR2P $PINS O=n54 I1=shf1[2] I2=shf1[3]
XU22 AN2 $PINS O=sll_17/ML_int[1][0] I1=term2_in[0] I2=n24
XU24 MUX2 $PINS O=N248 S=stage_sel A=acc_reg[23] B=FE_PHN743_N251
XU25 MUX2 $PINS O=sll_17/ML_int[1][1] S=n24 A=n7 B=term2_in[1]
XU26 ND3 $PINS O=n52 I1=term1_in[0] I2=n37 I3=n39
XU27 OR2 $PINS O=n75 I1=FE_OFN332_h23_2 I2=shf3[3]
XU28 AN2 $PINS O=base_val[4] I1=acc_reg[4] I2=FE_OFN79_n
XU29 MUX2 $PINS O=N250 S=stage_sel A=FE_PHN1056_acc_reg_25 B=FE_PHN743_N251
XU30 AN2 $PINS O=sll_16/ML_int[1][0] I1=n37 I2=term1_in[0]
XU32 MUX2 $PINS O=N247 S=stage_sel A=acc_reg[22] B=FE_PHN743_N251
XU34 NR2P $PINS O=term3_shifted[0] I1=n75 I2=n73
XU38 NR2 $PINS O=term1_in[1] I1=sign1[1] I2=x_in[1]
XU39 NR2P $PINS O=term3_in[1] I1=sign3[1] I2=x_in[1]
XU40 MUX2 $PINS O=sll_18/ML_int[1][1] S=shf3[0] A=term3_in[1] B=term3_in[0]
XU41 NR2 $PINS O=term2_shifted[0] I1=n4 I2=n3
XU42 INV2CK $PINS O=n77 I=sll_18/ML_int[2][2]
XU46 ND2 $PINS O=n1 I1=N73 I2=FE_OFN317_s22_0
XU47 ND2 $PINS O=n2 I1=term2_shifted[4] I2=sign2[0]
XU48 ND2 $PINS O=N100 I1=n1 I2=n2
XU49 AO22 $PINS O=N152 A1=N125 A2=sign3[0] B1=term3_shifted[1] B2=n20
XU50 MUX2 $PINS O=sll_16/ML_int[2][3] S=shf1[1] A=sll_16/ML_int[1][3]
+ B=sll_16/ML_int[1][1]
XU51 MUX2S $PINS O=sll_18/ML_int[3][6] S=FE_OFN332_h23_2 A=sll_18/ML_int[2][6]
+ B=sll_18/ML_int[2][2]
XU52 MUX2 $PINS O=sll_18/ML_int[2][2] S=shf3[1] A=sll_18/ML_int[1][2]
+ B=sll_18/ML_int[1][0]
XU55 AO22 $PINS O=N119 A1=N92 A2=FE_OFN316_s22_0 B1=term2_shifted[23]
+ B2=sign2[0]
XU60 AN2 $PINS O=sll_18/ML_int[1][0] I1=term3_in[0] I2=n13
XU62 NR2P $PINS O=term1_shifted[0] I1=n54 I2=n52
XU66 NR2P $PINS O=term2_shifted[1] I1=n65 I2=n64
XU67 AO22 $PINS O=N159 A1=N132 A2=sign3[0] B1=term3_shifted[8] B2=n20
XU68 AO22 $PINS O=N49 A1=N22 A2=sign1[0] B1=term1_shifted[8] B2=FE_OFN351_n
XU69 INV1S $PINS O=n63 I=n5
XU71 AN2 $PINS O=base_val[24] I1=FE_PHN1099_acc_reg_24 I2=FE_OFN79_n
XU72 AO22 $PINS O=N43 A1=N16 A2=sign1[0] B1=term1_shifted[2] B2=FE_OFN351_n
XU80 OR2 $PINS O=n4 I1=n65 I2=shf2[1]
XU81 NR2 $PINS O=n5 I1=n3 I2=shf2[1]
XU82 AO22S $PINS O=N120 A1=N93 A2=FE_OFN316_s22_0 B1=term2_shifted[24]
+ B2=sign2[0]
XU83 MUX2 $PINS O=sll_17/ML_int[2][2] S=shf2[1] A=sll_17/ML_int[1][2]
+ B=sll_17/ML_int[1][0]
XU84 AO22 $PINS O=N56 A1=N29 A2=FE_OFN349_n B1=term1_shifted[15] B2=FE_OFN350_n
XU85 AO22S $PINS O=N57 A1=N30 A2=FE_OFN349_n B1=term1_shifted[16]
+ B2=FE_OFN350_n
XU87 NR2P $PINS O=term3_in[0] I1=sign3[1] I2=x_in[0]
XU88 NR2 $PINS O=term1_in[0] I1=sign1[1] I2=x_in[0]
XU90 MUX2S $PINS O=sll_16/ML_int[3][6] S=shf1[2] A=sll_16/ML_int[2][6]
+ B=sll_16/ML_int[2][2]
XU92 NR2 $PINS O=n7 I1=sign2[1] I2=x_in[0]
XU93 NR2 $PINS O=term2_in[0] I1=sign2[1] I2=x_in[0]
XU94 AO22P $PINS O=N154 A1=N127 A2=sign3[0] B1=term3_shifted[3]
+ B2=FE_OFN365_n20
XU97 ND2S $PINS O=n9 I1=term2_shifted[2] I2=sign2[0]
XU99 AO22 $PINS O=N47 A1=N20 A2=sign1[0] B1=term1_shifted[6] B2=FE_OFN351_n
XU100 AO22 $PINS O=N157 A1=N130 A2=sign3[0] B1=term3_shifted[6]
+ B2=FE_OFN365_n20
XU101 AO22 $PINS O=N104 A1=N77 A2=FE_OFN317_s22_0 B1=term2_shifted[8]
+ B2=sign2[0]
XU102 AO22 $PINS O=N51 A1=N24 A2=sign1[0] B1=term1_shifted[10] B2=FE_OFN351_n
XU103 AO22 $PINS O=N161 A1=N134 A2=sign3[0] B1=term3_shifted[10] B2=n20
XU105 AN2 $PINS O=base_val[0] I1=acc_reg[0] I2=FE_OFN79_n
XU106 MUX2S $PINS O=sll_17/ML_int[1][7] S=shf2[0] A=term2_in[7] B=term2_in[6]
XU107 MUX2S $PINS O=sll_16/ML_int[1][8] S=shf1[0] A=term1_in[8] B=term1_in[7]
XU108 MUX2S $PINS O=sll_18/ML_int[1][8] S=shf3[0] A=term3_in[8] B=term3_in[7]
XU109 MUX2S $PINS O=sll_17/ML_int[2][8] S=shf2[1] A=sll_17/ML_int[1][8]
+ B=sll_17/ML_int[1][6]
XU111 MUX2S $PINS O=sll_17/ML_int[1][8] S=shf2[0] A=term2_in[8] B=term2_in[7]
XU112 MUX2S $PINS O=sll_16/ML_int[2][9] S=shf1[1] A=sll_16/ML_int[1][9]
+ B=sll_16/ML_int[1][7]
XU113 MUX2S $PINS O=sll_16/ML_int[1][9] S=shf1[0] A=term1_in[9] B=term1_in[8]
XU114 MUX2S $PINS O=sll_18/ML_int[2][9] S=shf3[1] A=sll_18/ML_int[1][9]
+ B=sll_18/ML_int[1][7]
XU125 MUX2S $PINS O=sll_18/ML_int[1][9] S=shf3[0] A=term3_in[9] B=term3_in[8]
XU126 MUX2S $PINS O=sll_17/ML_int[2][9] S=shf2[1] A=sll_17/ML_int[1][9]
+ B=sll_17/ML_int[1][7]
XU131 MUX2S $PINS O=sll_17/ML_int[1][9] S=shf2[0] A=term2_in[9] B=term2_in[8]
XU133 MUX2S $PINS O=sll_16/ML_int[2][10] S=shf1[1] A=sll_16/ML_int[1][10]
+ B=sll_16/ML_int[1][8]
XU135 MUX2S $PINS O=sll_16/ML_int[1][10] S=shf1[0] A=term1_in[10] B=term1_in[9]
XU137 MUX2 $PINS O=sll_18/ML_int[2][10] S=shf3[1] A=sll_18/ML_int[1][10]
+ B=sll_18/ML_int[1][8]
XU138 MUX2S $PINS O=sll_18/ML_int[1][10] S=shf3[0] A=term3_in[10] B=term3_in[9]
XU139 MUX2S $PINS O=sll_17/ML_int[3][10] S=n28 A=sll_17/ML_int[2][10]
+ B=sll_17/ML_int[2][6]
XU140 MUX2S $PINS O=sll_17/ML_int[2][10] S=shf2[1] A=sll_17/ML_int[1][10]
+ B=sll_17/ML_int[1][8]
XU158 MUX2S $PINS O=sll_17/ML_int[1][10] S=shf2[0] A=term2_in[10] B=term2_in[9]
XU160 MUX2S $PINS O=sll_16/ML_int[3][11] S=shf1[2] A=sll_16/ML_int[2][11]
+ B=sll_16/ML_int[2][7]
XU162 MUX2S $PINS O=sll_16/ML_int[2][11] S=shf1[1] A=sll_16/ML_int[1][11]
+ B=sll_16/ML_int[1][9]
XU164 MUX2S $PINS O=sll_18/ML_int[3][11] S=FE_OFN331_h23_2
+ A=sll_18/ML_int[2][11] B=sll_18/ML_int[2][7]
XU165 MUX2S $PINS O=sll_18/ML_int[2][11] S=shf3[1] A=sll_18/ML_int[1][11]
+ B=sll_18/ML_int[1][9]
XU166 MUX2S $PINS O=sll_17/ML_int[3][11] S=n28 A=sll_17/ML_int[2][11]
+ B=sll_17/ML_int[2][7]
XU167 MUX2S $PINS O=sll_17/ML_int[2][11] S=shf2[1] A=sll_17/ML_int[1][11]
+ B=sll_17/ML_int[1][9]
XU171 MUX2S $PINS O=sll_16/ML_int[1][11] S=shf1[0] A=term1_in[11]
+ B=term1_in[10]
XU172 MUX2S $PINS O=sll_18/ML_int[1][11] S=shf3[0] A=term3_in[11]
+ B=term3_in[10]
XU182 MUX2S $PINS O=sll_17/ML_int[1][11] S=shf2[0] A=term2_in[11]
+ B=term2_in[10]
XU187 MUX2S $PINS O=sll_16/ML_int[3][12] S=shf1[2] A=sll_16/ML_int[2][12]
+ B=sll_16/ML_int[2][8]
XU191 MUX2S $PINS O=sll_16/ML_int[2][12] S=shf1[1] A=sll_16/ML_int[1][12]
+ B=sll_16/ML_int[1][10]
XU192 MUX2S $PINS O=sll_18/ML_int[3][12] S=FE_OFN331_h23_2
+ A=sll_18/ML_int[2][12] B=sll_18/ML_int[2][8]
XU193 MUX2S $PINS O=sll_18/ML_int[2][12] S=shf3[1] A=sll_18/ML_int[1][12]
+ B=sll_18/ML_int[1][10]
XU194 MUX2S $PINS O=sll_17/ML_int[3][12] S=n28 A=sll_17/ML_int[2][12]
+ B=sll_17/ML_int[2][8]
XU195 MUX2S $PINS O=sll_17/ML_int[2][12] S=shf2[1] A=sll_17/ML_int[1][12]
+ B=sll_17/ML_int[1][10]
XU196 MUX2S $PINS O=sll_16/ML_int[1][12] S=shf1[0] A=term1_in[12]
+ B=term1_in[11]
XU197 MUX2S $PINS O=sll_18/ML_int[1][12] S=shf3[0] A=term3_in[12]
+ B=term3_in[11]
XU198 MUX2S $PINS O=sll_17/ML_int[1][12] S=shf2[0] A=term2_in[12]
+ B=term2_in[11]
XU199 MUX2S $PINS O=sll_16/ML_int[3][13] S=shf1[2] A=sll_16/ML_int[2][13]
+ B=sll_16/ML_int[2][9]
XU200 MUX2S $PINS O=sll_18/ML_int[3][13] S=FE_OFN331_h23_2
+ A=sll_18/ML_int[2][13] B=sll_18/ML_int[2][9]
XU201 MUX2S $PINS O=sll_17/ML_int[3][13] S=n28 A=sll_17/ML_int[2][13]
+ B=sll_17/ML_int[2][9]
XU202 MUX2S $PINS O=sll_16/ML_int[2][13] S=shf1[1] A=sll_16/ML_int[1][13]
+ B=sll_16/ML_int[1][11]
XU203 MUX2S $PINS O=sll_16/ML_int[1][13] S=shf1[0] A=term1_in[13]
+ B=term1_in[12]
XU204 MUX2S $PINS O=sll_18/ML_int[2][13] S=shf3[1] A=sll_18/ML_int[1][13]
+ B=sll_18/ML_int[1][11]
XU205 MUX2S $PINS O=sll_18/ML_int[1][13] S=shf3[0] A=term3_in[13]
+ B=term3_in[12]
XU206 MUX2S $PINS O=sll_17/ML_int[2][13] S=shf2[1] A=sll_17/ML_int[1][13]
+ B=sll_17/ML_int[1][11]
XU207 MUX2S $PINS O=sll_17/ML_int[1][13] S=shf2[0] A=term2_in[13]
+ B=term2_in[12]
XU208 MUX2S $PINS O=sll_16/ML_int[3][14] S=shf1[2] A=sll_16/ML_int[2][14]
+ B=sll_16/ML_int[2][10]
XU209 MUX2S $PINS O=sll_18/ML_int[3][14] S=FE_OFN331_h23_2
+ A=sll_18/ML_int[2][14] B=sll_18/ML_int[2][10]
XU210 MUX2S $PINS O=term2_shifted[14] S=FE_OFN314_h22_3 A=sll_17/ML_int[3][14]
+ B=sll_17/ML_int[3][6]
XU211 MUX2S $PINS O=sll_17/ML_int[3][14] S=n28 A=sll_17/ML_int[2][14]
+ B=sll_17/ML_int[2][10]
XU212 MUX2S $PINS O=sll_16/ML_int[2][14] S=shf1[1] A=sll_16/ML_int[1][14]
+ B=sll_16/ML_int[1][12]
XU213 MUX2S $PINS O=sll_16/ML_int[1][14] S=shf1[0] A=term1_in[14]
+ B=term1_in[13]
XU214 MUX2S $PINS O=sll_18/ML_int[2][14] S=shf3[1] A=sll_18/ML_int[1][14]
+ B=sll_18/ML_int[1][12]
XU215 MUX2S $PINS O=sll_18/ML_int[1][14] S=shf3[0] A=term3_in[14]
+ B=term3_in[13]
XU216 MUX2S $PINS O=sll_17/ML_int[2][14] S=shf2[1] A=sll_17/ML_int[1][14]
+ B=sll_17/ML_int[1][12]
XU217 MUX2S $PINS O=sll_17/ML_int[1][14] S=shf2[0] A=term2_in[14]
+ B=term2_in[13]
XU218 MUX2S $PINS O=term1_shifted[16] S=shf1[3] A=sll_16/ML_int[3][16]
+ B=sll_16/ML_int[3][8]
XU219 MUX2S $PINS O=sll_16/ML_int[3][16] S=shf1[2] A=n59 B=sll_16/ML_int[2][12]
XU220 MUX2S $PINS O=term3_shifted[16] S=shf3[3] A=sll_18/ML_int[3][16]
+ B=sll_18/ML_int[3][8]
XU221 MUX2S $PINS O=sll_18/ML_int[3][16] S=FE_OFN331_h23_2 A=n80
+ B=sll_18/ML_int[2][12]
XU222 MUX2S $PINS O=term2_shifted[16] S=FE_OFN314_h22_3 A=sll_17/ML_int[3][16]
+ B=sll_17/ML_int[3][8]
XU223 MUX2S $PINS O=sll_17/ML_int[3][16] S=n28 A=n69 B=sll_17/ML_int[2][12]
XU224 MUX2S $PINS O=term1_shifted[15] S=shf1[3] A=sll_16/ML_int[3][15]
+ B=sll_16/ML_int[3][7]
XU225 MUX2S $PINS O=sll_16/ML_int[3][15] S=shf1[2] A=sll_16/ML_int[2][15]
+ B=sll_16/ML_int[2][11]
XU226 MUX2S $PINS O=term3_shifted[15] S=shf3[3] A=sll_18/ML_int[3][15]
+ B=sll_18/ML_int[3][7]
XU227 MUX2S $PINS O=sll_18/ML_int[3][15] S=FE_OFN331_h23_2
+ A=sll_18/ML_int[2][15] B=sll_18/ML_int[2][11]
XU228 MUX2S $PINS O=term2_shifted[15] S=FE_OFN314_h22_3 A=sll_17/ML_int[3][15]
+ B=sll_17/ML_int[3][7]
XU229 MUX2S $PINS O=sll_17/ML_int[3][15] S=n28 A=sll_17/ML_int[2][15]
+ B=sll_17/ML_int[2][11]
XU230 MUX2S $PINS O=sll_16/ML_int[2][15] S=shf1[1] A=sll_16/ML_int[1][15]
+ B=sll_16/ML_int[1][13]
XU231 MUX2S $PINS O=sll_16/ML_int[1][15] S=shf1[0] A=term1_in[15]
+ B=term1_in[14]
XU232 MUX2S $PINS O=sll_18/ML_int[2][15] S=shf3[1] A=sll_18/ML_int[1][15]
+ B=sll_18/ML_int[1][13]
XU233 MUX2S $PINS O=sll_18/ML_int[1][15] S=shf3[0] A=term3_in[15]
+ B=term3_in[14]
XU234 MUX2S $PINS O=sll_17/ML_int[2][15] S=shf2[1] A=sll_17/ML_int[1][15]
+ B=sll_17/ML_int[1][13]
XU235 MUX2S $PINS O=sll_17/ML_int[1][15] S=shf2[0] A=term2_in[15]
+ B=term2_in[14]
XU236 MUX2S $PINS O=term1_shifted[17] S=shf1[3] A=sll_16/ML_int[3][17]
+ B=sll_16/ML_int[3][9]
XU237 MUX2S $PINS O=sll_16/ML_int[3][17] S=shf1[2] A=n60 B=sll_16/ML_int[2][13]
XU238 MUX2S $PINS O=term3_shifted[17] S=shf3[3] A=sll_18/ML_int[3][17]
+ B=sll_18/ML_int[3][9]
XU239 MUX2S $PINS O=sll_18/ML_int[3][17] S=FE_OFN331_h23_2 A=n81
+ B=sll_18/ML_int[2][13]
XU240 MUX2S $PINS O=term2_shifted[17] S=FE_OFN314_h22_3 A=sll_17/ML_int[3][17]
+ B=sll_17/ML_int[3][9]
XU241 MUX2S $PINS O=sll_17/ML_int[3][17] S=n28 A=n70 B=sll_17/ML_int[2][13]
XU242 MUX2S $PINS O=term1_shifted[18] S=shf1[3] A=sll_16/ML_int[3][18]
+ B=sll_16/ML_int[3][10]
XU243 MUX2S $PINS O=sll_16/ML_int[3][18] S=shf1[2] A=n61 B=sll_16/ML_int[2][14]
XU244 MUX2S $PINS O=term3_shifted[18] S=shf3[3] A=sll_18/ML_int[3][18]
+ B=sll_18/ML_int[3][10]
XU245 MUX2S $PINS O=sll_18/ML_int[3][18] S=FE_OFN331_h23_2 A=n82
+ B=sll_18/ML_int[2][14]
XU246 MUX2S $PINS O=term2_shifted[18] S=FE_OFN313_h22_3 A=sll_17/ML_int[3][18]
+ B=sll_17/ML_int[3][10]
XU247 MUX2S $PINS O=sll_17/ML_int[3][18] S=n28 A=n71 B=sll_17/ML_int[2][14]
XU248 MUX2S $PINS O=term1_shifted[20] S=shf1[3] A=sll_16/ML_int[3][20]
+ B=sll_16/ML_int[3][12]
XU249 MUX2S $PINS O=sll_16/ML_int[3][20] S=shf1[2] A=term1_in[26] B=n59
XU250 MUX2S $PINS O=term1_shifted[19] S=shf1[3] A=sll_16/ML_int[3][19]
+ B=sll_16/ML_int[3][11]
XU251 MUX2S $PINS O=sll_16/ML_int[3][19] S=shf1[2] A=term1_in[26]
+ B=sll_16/ML_int[2][15]
XU252 MUX2S $PINS O=term3_shifted[20] S=shf3[3] A=sll_18/ML_int[3][20]
+ B=sll_18/ML_int[3][12]
XU253 MUX2S $PINS O=sll_18/ML_int[3][20] S=FE_OFN331_h23_2 A=term3_in[26] B=n80
XU254 MUX2S $PINS O=term3_shifted[19] S=shf3[3] A=sll_18/ML_int[3][19]
+ B=sll_18/ML_int[3][11]
XU255 MUX2S $PINS O=sll_18/ML_int[3][19] S=FE_OFN331_h23_2 A=term3_in[26]
+ B=sll_18/ML_int[2][15]
XU256 MUX2S $PINS O=term2_shifted[19] S=FE_OFN313_h22_3 A=sll_17/ML_int[3][19]
+ B=sll_17/ML_int[3][11]
XU257 MUX2S $PINS O=sll_17/ML_int[3][19] S=n28 A=term2_in[26]
+ B=sll_17/ML_int[2][15]
XU258 MUX2S $PINS O=term2_shifted[20] S=FE_OFN313_h22_3 A=sll_17/ML_int[3][20]
+ B=sll_17/ML_int[3][12]
XU259 MUX2S $PINS O=sll_17/ML_int[3][20] S=n28 A=term2_in[26] B=n69
XU260 MUX2S $PINS O=term1_shifted[21] S=shf1[3] A=sll_16/ML_int[3][21]
+ B=sll_16/ML_int[3][13]
XU261 MUX2S $PINS O=sll_16/ML_int[3][21] S=shf1[2] A=term1_in[26] B=n60
XU262 MUX2S $PINS O=term3_shifted[21] S=shf3[3] A=sll_18/ML_int[3][21]
+ B=sll_18/ML_int[3][13]
XU263 MUX2S $PINS O=sll_18/ML_int[3][21] S=FE_OFN331_h23_2 A=term3_in[26] B=n81
XU264 MUX2S $PINS O=term2_shifted[21] S=FE_OFN313_h22_3 A=sll_17/ML_int[3][21]
+ B=sll_17/ML_int[3][13]
XU265 MUX2S $PINS O=sll_17/ML_int[3][21] S=n28 A=term2_in[26] B=n70
XU266 MUX2S $PINS O=term1_shifted[22] S=shf1[3] A=sll_16/ML_int[3][22]
+ B=sll_16/ML_int[3][14]
XU267 MUX2S $PINS O=sll_16/ML_int[3][22] S=shf1[2] A=term1_in[26] B=n61
XU268 MUX2S $PINS O=term3_shifted[22] S=shf3[3] A=sll_18/ML_int[3][22]
+ B=sll_18/ML_int[3][14]
XU269 MUX2S $PINS O=sll_18/ML_int[3][22] S=FE_OFN331_h23_2 A=term3_in[26] B=n82
XU270 MUX2S $PINS O=term2_shifted[22] S=FE_OFN313_h22_3 A=sll_17/ML_int[3][22]
+ B=sll_17/ML_int[3][14]
XU271 MUX2S $PINS O=sll_17/ML_int[3][22] S=n28 A=term2_in[26] B=n71
XU272 MUX2S $PINS O=term1_shifted[24] S=shf1[3] A=term1_in[26]
+ B=sll_16/ML_int[3][16]
XU273 MUX2S $PINS O=term3_shifted[24] S=shf3[3] A=term3_in[26]
+ B=sll_18/ML_int[3][16]
XU274 MUX2S $PINS O=term2_shifted[24] S=FE_OFN313_h22_3 A=term2_in[26]
+ B=sll_17/ML_int[3][16]
XU275 MUX2S $PINS O=term1_shifted[25] S=shf1[3] A=term1_in[26]
+ B=sll_16/ML_int[3][17]
XU276 MUX2S $PINS O=term3_shifted[25] S=shf3[3] A=term3_in[26]
+ B=sll_18/ML_int[3][17]
XU277 MUX2S $PINS O=term2_shifted[25] S=FE_OFN313_h22_3 A=term2_in[26]
+ B=sll_17/ML_int[3][17]
XU278 MUX2S $PINS O=term1_shifted[26] S=shf1[3] A=term1_in[26]
+ B=sll_16/ML_int[3][18]
XU279 MUX2S $PINS O=term3_shifted[26] S=shf3[3] A=term3_in[26]
+ B=sll_18/ML_int[3][18]
XU280 MUX2S $PINS O=term2_shifted[26] S=n30 A=term2_in[26]
+ B=sll_17/ML_int[3][18]
XU283 AO22S $PINS O=N109 A1=N82 A2=FE_OFN266_n B1=term2_shifted[13] B2=sign2[0]
XU284 ND2S $PINS O=n103 I1=FE_PHN743_N251 I2=stage_sel
XU285 MUX2S $PINS O=N235 S=stage_sel A=acc_reg[10] B=acc_reg[14]
XU286 MUX2S $PINS O=FE_PHN1345_N236 S=stage_sel A=acc_reg[11]
+ B=FE_PHN933_acc_reg_15
XU287 MUX2S $PINS O=FE_PHN1328_N237 S=stage_sel A=acc_reg[12]
+ B=FE_PHN920_acc_reg_16
XU288 MUX2S $PINS O=FE_PHN1309_N238 S=stage_sel A=FE_PHN971_acc_reg_13
+ B=acc_reg[17]
XU289 MUX2S $PINS O=N239 S=stage_sel A=acc_reg[14] B=acc_reg[18]
XU290 MUX2S $PINS O=N240 S=stage_sel A=FE_PHN933_acc_reg_15 B=acc_reg[19]
XU291 MUX2S $PINS O=FE_PHN980_N242 S=stage_sel A=acc_reg[17] B=acc_reg[21]
XU292 MUX2S $PINS O=FE_PHN1291_N245 S=stage_sel A=acc_reg[20]
+ B=FE_PHN1099_acc_reg_24
XU293 MUX2S $PINS O=FE_PHN1298_N246 S=stage_sel A=acc_reg[21]
+ B=FE_PHN1056_acc_reg_25
XU297 MUX2 $PINS O=sll_16/ML_int[2][2] S=shf1[1] A=sll_16/ML_int[1][2]
+ B=sll_16/ML_int[1][0]
XU298 INV1S $PINS O=n57 I=n52
XU300 INV1S $PINS O=n58 I=n53
XU301 INV1S $PINS O=n68 I=n64
XU302 NR2 $PINS O=term1_in[4] I1=sign1[1] I2=x_in[4]
XU303 NR2 $PINS O=term1_in[3] I1=sign1[1] I2=x_in[3]
XU304 NR2 $PINS O=term3_in[3] I1=sign3[1] I2=x_in[3]
XU305 NR2 $PINS O=term3_in[4] I1=sign3[1] I2=x_in[4]
XU306 NR2 $PINS O=term2_in[4] I1=sign2[1] I2=x_in[4]
XU308 NR2 $PINS O=term1_in[5] I1=sign1[1] I2=x_in[5]
XU309 NR2 $PINS O=term3_in[5] I1=sign3[1] I2=x_in[5]
XU310 NR2 $PINS O=term2_in[5] I1=sign2[1] I2=x_in[5]
XU311 NR2 $PINS O=term1_in[6] I1=sign1[1] I2=x_in[6]
XU312 NR2 $PINS O=term3_in[6] I1=sign3[1] I2=x_in[6]
XU313 NR2 $PINS O=term2_in[6] I1=sign2[1] I2=x_in[6]
XU314 NR2 $PINS O=term1_in[7] I1=sign1[1] I2=x_in[7]
XU315 NR2 $PINS O=term3_in[7] I1=sign3[1] I2=x_in[7]
XU316 NR2 $PINS O=term2_in[7] I1=sign2[1] I2=x_in[7]
XU317 NR2 $PINS O=term1_in[8] I1=sign1[1] I2=x_in[8]
XU318 NR2 $PINS O=term3_in[8] I1=sign3[1] I2=x_in[8]
XU319 NR2 $PINS O=term2_in[8] I1=sign2[1] I2=x_in[8]
XU320 NR2 $PINS O=term1_in[9] I1=sign1[1] I2=x_in[9]
XU321 NR2 $PINS O=term3_in[9] I1=sign3[1] I2=x_in[9]
XU323 NR2 $PINS O=term2_in[9] I1=sign2[1] I2=x_in[9]
XU325 NR2 $PINS O=term1_in[10] I1=sign1[1] I2=x_in[10]
XU326 NR2 $PINS O=term3_in[10] I1=sign3[1] I2=x_in[10]
XU327 NR2 $PINS O=term2_in[10] I1=sign2[1] I2=x_in[10]
XU328 NR2 $PINS O=term1_in[11] I1=sign1[1] I2=x_in[11]
XU329 NR2 $PINS O=term3_in[11] I1=sign3[1] I2=x_in[11]
XU330 NR2 $PINS O=term2_in[11] I1=sign2[1] I2=x_in[11]
XU331 NR2 $PINS O=term1_in[12] I1=sign1[1] I2=x_in[12]
XU332 NR2 $PINS O=term3_in[12] I1=sign3[1] I2=x_in[12]
XU333 NR2 $PINS O=term2_in[12] I1=sign2[1] I2=x_in[12]
XU334 NR2 $PINS O=term1_in[13] I1=sign1[1] I2=n88
XU335 NR2 $PINS O=term3_in[13] I1=sign3[1] I2=n88
XU336 NR2 $PINS O=term2_in[13] I1=sign2[1] I2=n88
XU339 NR2 $PINS O=term1_in[14] I1=sign1[1] I2=n89
XU341 NR2 $PINS O=term3_in[14] I1=sign3[1] I2=n89
XU342 NR2 $PINS O=term2_in[14] I1=sign2[1] I2=n89
XU343 NR2 $PINS O=term1_in[15] I1=sign1[1] I2=n90
XU344 NR2 $PINS O=term3_in[15] I1=sign3[1] I2=n90
XU345 NR2 $PINS O=term2_in[15] I1=sign2[1] I2=n90
XU346 NR2 $PINS O=term1_in[26] I1=n91 I2=sign1[1]
XU347 NR2 $PINS O=term3_in[26] I1=n91 I2=sign3[1]
XU348 NR2 $PINS O=term2_in[26] I1=n91 I2=sign2[1]
XU355 INV1S $PINS O=n37 I=shf1[0]
XU358 INV2 $PINS O=n39 I=shf1[1]
XU375 INV1S $PINS O=n88 I=x_in[13]
XU376 INV1S $PINS O=n89 I=x_in[14]
XU377 INV1S $PINS O=n90 I=x_in[15]
XU378 INV1S $PINS O=n91 I=x_in[16]
XU379 AN2 $PINS O=base_val[26] I1=N251 I2=FE_OFN79_n
XU380 AN2 $PINS O=base_val[1] I1=acc_reg[1] I2=FE_OFN79_n
XU381 MOAI1S $PINS O=base_val[9] A1=stage_sel A2=FE_OFN79_n B1=acc_reg[9]
+ B2=FE_OFN79_n
XU382 AN2 $PINS O=base_val[10] I1=acc_reg[10] I2=FE_OFN79_n
XU383 AN2 $PINS O=base_val[8] I1=acc_reg[8] I2=FE_OFN79_n
XU384 AN2 $PINS O=base_val[6] I1=acc_reg[6] I2=FE_OFN79_n
XU385 AN2 $PINS O=base_val[5] I1=acc_reg[5] I2=FE_OFN79_n
XU386 AN2 $PINS O=base_val[7] I1=acc_reg[7] I2=FE_OFN79_n
XU387 AN2 $PINS O=base_val[3] I1=acc_reg[3] I2=FE_OFN79_n
XU388 AN2 $PINS O=base_val[11] I1=acc_reg[11] I2=FE_OFN79_n
XU389 AN2 $PINS O=base_val[12] I1=acc_reg[12] I2=FE_OFN79_n
XU390 AN2 $PINS O=base_val[14] I1=acc_reg[14] I2=FE_OFN79_n
XU391 AN2 $PINS O=base_val[15] I1=acc_reg[15] I2=FE_OFN79_n
XU392 AN2 $PINS O=base_val[16] I1=acc_reg[16] I2=FE_OFN79_n
XU393 AN2 $PINS O=base_val[17] I1=acc_reg[17] I2=FE_OFN79_n
XU394 AN2 $PINS O=base_val[18] I1=acc_reg[18] I2=FE_OFN79_n
XU395 AN2 $PINS O=base_val[19] I1=acc_reg[19] I2=FE_OFN79_n
XU396 AN2 $PINS O=base_val[20] I1=acc_reg[20] I2=FE_OFN79_n
XU397 AN2 $PINS O=base_val[21] I1=acc_reg[21] I2=FE_OFN79_n
XU398 AN2 $PINS O=base_val[22] I1=acc_reg[22] I2=FE_OFN79_n
XU399 AN2 $PINS O=base_val[23] I1=acc_reg[23] I2=FE_OFN79_n
XU400 AN2 $PINS O=base_val[25] I1=FE_PHN1056_acc_reg_25 I2=FE_OFN79_n
XU402 AN2 $PINS O=N234 I1=en I2=calc_done
XU403 OAI12HS $PINS O=N249 A1=n103 B1=stage_sel B2=n84
XU404 INV1S $PINS O=n84 I=FE_PHN1099_acc_reg_24
XU406 INV1S $PINS O=n79 I=n74
XU407 MUX2 $PINS O=sll_18/ML_int[2][3] S=shf3[1] A=sll_18/ML_int[1][3]
+ B=sll_18/ML_int[1][1]
XU408 AN2 $PINS O=base_val[2] I1=acc_reg[2] I2=FE_OFN79_n
XU409 NR2 $PINS O=sll_16/ML_int[3][0] I1=shf1[2] I2=n52
XU410 NR2 $PINS O=sll_16/ML_int[3][1] I1=shf1[2] I2=n53
XU411 NR2 $PINS O=sll_16/ML_int[3][2] I1=shf1[2] I2=n56
XU412 NR2 $PINS O=sll_16/ML_int[3][3] I1=shf1[2] I2=n55
XU413 NR2P $PINS O=term1_shifted[3] I1=n54 I2=n55
XU414 AN2 $PINS O=term1_shifted[4] I1=sll_16/ML_int[3][4] I2=n41
XU415 AN2 $PINS O=term1_shifted[5] I1=sll_16/ML_int[3][5] I2=n41
XU416 AN2 $PINS O=term1_shifted[6] I1=sll_16/ML_int[3][6] I2=n41
XU417 AN2 $PINS O=term1_shifted[7] I1=sll_16/ML_int[3][7] I2=n41
XU418 MUX2 $PINS O=n59 S=shf1[1] A=n62 B=sll_16/ML_int[1][14]
XU419 MUX2 $PINS O=n60 S=shf1[1] A=term1_in[26] B=sll_16/ML_int[1][15]
XU420 MUX2 $PINS O=n61 S=shf1[1] A=term1_in[26] B=n62
XU421 MUX2 $PINS O=n62 S=shf1[0] A=term1_in[26] B=term1_in[15]
XU422 NR2 $PINS O=sll_17/ML_int[3][0] I1=n28 I2=n63
XU423 NR2 $PINS O=sll_17/ML_int[3][1] I1=n28 I2=n64
XU424 NR2 $PINS O=sll_17/ML_int[3][2] I1=n28 I2=n67
XU425 NR2 $PINS O=sll_17/ML_int[3][3] I1=n28 I2=n66
XU426 ND2P $PINS O=n65 I1=shf2[2] I2=shf2[3]
XU429 AN2 $PINS O=term2_shifted[5] I1=sll_17/ML_int[3][5] I2=shf2[3]
XU430 AN2 $PINS O=term2_shifted[6] I1=sll_17/ML_int[3][6] I2=shf2[3]
XU431 AN2 $PINS O=term2_shifted[7] I1=sll_17/ML_int[3][7] I2=shf2[3]
XU432 MUX2 $PINS O=n69 S=shf2[1] A=n72 B=sll_17/ML_int[1][14]
XU433 MUX2 $PINS O=n70 S=shf2[1] A=term2_in[26] B=sll_17/ML_int[1][15]
XU434 MUX2 $PINS O=n71 S=shf2[1] A=term2_in[26] B=n72
XU435 MUX2 $PINS O=n72 S=shf2[0] A=term2_in[26] B=term2_in[15]
XU436 NR2 $PINS O=sll_18/ML_int[3][0] I1=FE_OFN332_h23_2 I2=n73
XU437 NR2 $PINS O=sll_18/ML_int[3][1] I1=FE_OFN332_h23_2 I2=n74
XU438 NR2 $PINS O=sll_18/ML_int[3][2] I1=FE_OFN332_h23_2 I2=n77
XU439 NR2 $PINS O=sll_18/ML_int[3][3] I1=FE_OFN332_h23_2 I2=n76
XU440 NR2P $PINS O=term3_shifted[3] I1=n75 I2=n76
XU441 AN2 $PINS O=term3_shifted[4] I1=sll_18/ML_int[3][4] I2=n17
XU442 AN2 $PINS O=term3_shifted[5] I1=sll_18/ML_int[3][5] I2=n17
XU443 AN2 $PINS O=term3_shifted[6] I1=sll_18/ML_int[3][6] I2=n17
XU444 AN2 $PINS O=term3_shifted[7] I1=sll_18/ML_int[3][7] I2=n17
XU445 MUX2 $PINS O=n80 S=shf3[1] A=n83 B=sll_18/ML_int[1][14]
XU446 MUX2 $PINS O=n81 S=shf3[1] A=term3_in[26] B=sll_18/ML_int[1][15]
XU447 MUX2 $PINS O=n82 S=shf3[1] A=term3_in[26] B=n83
XU448 MUX2 $PINS O=n83 S=shf3[0] A=term3_in[26] B=term3_in[15]
XU449 MUX2 $PINS O=N241 S=stage_sel A=FE_PHN920_acc_reg_16 B=acc_reg[20]
XU450 MUX2 $PINS O=N243 S=stage_sel A=acc_reg[18] B=acc_reg[22]
XU451 MUX2 $PINS O=N244 S=stage_sel A=acc_reg[19] B=acc_reg[23]
XU4 NR2T $PINS O=term3_shifted[2] I1=n75 I2=n77
XU7 NR2T $PINS O=term1_shifted[1] I1=n54 I2=n53
XU11 NR2 $PINS O=term2_in[1] I1=sign2[1] I2=x_in[1]
XU13 NR2 $PINS O=term2_in[2] I1=sign2[1] I2=x_in[2]
XU14 ND2P $PINS O=n64 I1=sll_17/ML_int[1][1] I2=n26
XU16 NR2 $PINS O=term3_in[2] I1=sign3[1] I2=x_in[2]
XU33 NR2 $PINS O=term1_in[2] I1=sign1[1] I2=x_in[2]
XU53 NR2 $PINS O=term2_in[3] I1=sign2[1] I2=x_in[3]
XU77 ND2S $PINS O=n3 I1=term2_in[0] I2=n24
XU86 ND2 $PINS O=n8 I1=N71 I2=FE_OFN317_s22_0
Xclk_gate_y_out_reg SNPS_CLOCK_GATE_HIGH_PE_Shift_Add_3 $PINS EN=N234
+ ENCLK=net2254 CLK_clone1=clk_clone2 CLK=clk
Xsub_28_3 PE_Shift_Add_3_DW01_sub_0_DW01_sub_9 $PINS A[26]=net45552
+ A[25]=net45552 A[24]=net45552 A[23]=net45552 A[22]=net45552 A[21]=net45552
+ A[20]=net45552 A[19]=net45552 A[18]=net45552 A[17]=net45552 A[16]=net45552
+ A[15]=net45552 A[14]=net45552 A[13]=net45552 A[12]=net45552 A[11]=net45552
+ A[10]=net45552 A[9]=net45552 A[8]=net45552 A[7]=net45552 A[6]=net45552
+ A[5]=net45552 A[4]=net45552 A[3]=net45552 A[2]=net45552 A[1]=net45552
+ A[0]=net45552 B[26]=term3_shifted[26] B[25]=term3_shifted[25]
+ B[24]=term3_shifted[24] B[23]=term3_shifted[23] B[22]=term3_shifted[22]
+ B[21]=term3_shifted[21] B[20]=term3_shifted[20] B[19]=term3_shifted[19]
+ B[18]=term3_shifted[18] B[17]=term3_shifted[17] B[16]=term3_shifted[16]
+ B[15]=term3_shifted[15] B[14]=term3_shifted[14] B[13]=term3_shifted[13]
+ B[12]=term3_shifted[12] B[11]=term3_shifted[11] B[10]=term3_shifted[10]
+ B[9]=term3_shifted[9] B[8]=term3_shifted[8] B[7]=term3_shifted[7]
+ B[6]=term3_shifted[6] B[5]=term3_shifted[5] B[4]=term3_shifted[4]
+ B[3]=term3_shifted[3] B[2]=term3_shifted[2] B[1]=term3_shifted[1]
+ B[0]=term3_shifted[0] CI=net45552 DIFF[26]=N150 DIFF[25]=N149 DIFF[24]=N148
+ DIFF[23]=N147 DIFF[22]=N146 DIFF[21]=N145 DIFF[20]=N144 DIFF[19]=N143
+ DIFF[18]=N142 DIFF[17]=N141 DIFF[16]=N140 DIFF[15]=N139 DIFF[14]=N138
+ DIFF[13]=N137 DIFF[12]=N136 DIFF[11]=N135 DIFF[10]=N134 DIFF[9]=N133
+ DIFF[8]=N132 DIFF[7]=N131 DIFF[6]=N130 DIFF[5]=N129 DIFF[4]=N128 DIFF[3]=N127
+ DIFF[2]=N126 DIFF[1]=N125 DIFF[0]=N124
Xsub_28_2 PE_Shift_Add_3_DW01_sub_1_DW01_sub_10 $PINS A[26]=net45552
+ A[25]=net45552 A[24]=net45552 A[23]=net45552 A[22]=net45552 A[21]=net45552
+ A[20]=net45552 A[19]=net45552 A[18]=net45552 A[17]=net45552 A[16]=net45552
+ A[15]=net45552 A[14]=net45552 A[13]=net45552 A[12]=net45552 A[11]=net45552
+ A[10]=net45552 A[9]=net45552 A[8]=net45552 A[7]=net45552 A[6]=net45552
+ A[5]=net45552 A[4]=net45552 A[3]=net45552 A[2]=net45552 A[1]=net45552
+ A[0]=net45552 B[26]=term2_shifted[26] B[25]=term2_shifted[25]
+ B[24]=term2_shifted[24] B[23]=term2_shifted[23] B[22]=term2_shifted[22]
+ B[21]=term2_shifted[21] B[20]=term2_shifted[20] B[19]=term2_shifted[19]
+ B[18]=term2_shifted[18] B[17]=term2_shifted[17] B[16]=term2_shifted[16]
+ B[15]=term2_shifted[15] B[14]=term2_shifted[14] B[13]=term2_shifted[13]
+ B[12]=term2_shifted[12] B[11]=term2_shifted[11] B[10]=term2_shifted[10]
+ B[9]=term2_shifted[9] B[8]=term2_shifted[8] B[7]=term2_shifted[7]
+ B[6]=term2_shifted[6] B[5]=term2_shifted[5] B[4]=term2_shifted[4]
+ B[3]=term2_shifted[3] B[2]=term2_shifted[2] B[1]=term2_shifted[1]
+ B[0]=term2_shifted[0] CI=net45552 DIFF[26]=N95 DIFF[25]=N94 DIFF[24]=N93
+ DIFF[23]=N92 DIFF[22]=N91 DIFF[21]=N90 DIFF[20]=N89 DIFF[19]=N88 DIFF[18]=N87
+ DIFF[17]=N86 DIFF[16]=N85 DIFF[15]=N84 DIFF[14]=N83 DIFF[13]=N82 DIFF[12]=N81
+ DIFF[11]=N80 DIFF[10]=N79 DIFF[9]=N78 DIFF[8]=N77 DIFF[7]=N76 DIFF[6]=N75
+ DIFF[5]=N74 DIFF[4]=N73 DIFF[3]=N72 DIFF[2]=N71 DIFF[1]=N70 DIFF[0]=N69
Xsub_28 PE_Shift_Add_3_DW01_sub_2_DW01_sub_11 $PINS A[26]=net45552
+ A[25]=net45552 A[24]=net45552 A[23]=net45552 A[22]=net45552 A[21]=net45552
+ A[20]=net45552 A[19]=net45552 A[18]=net45552 A[17]=net45552 A[16]=net45552
+ A[15]=net45552 A[14]=net45552 A[13]=net45552 A[12]=net45552 A[11]=net45552
+ A[10]=net45552 A[9]=net45552 A[8]=net45552 A[7]=net45552 A[6]=net45552
+ A[5]=net45552 A[4]=net45552 A[3]=net45552 A[2]=net45552 A[1]=net45552
+ A[0]=net45552 B[26]=term1_shifted[26] B[25]=term1_shifted[25]
+ B[24]=term1_shifted[24] B[23]=term1_shifted[23] B[22]=term1_shifted[22]
+ B[21]=term1_shifted[21] B[20]=term1_shifted[20] B[19]=term1_shifted[19]
+ B[18]=term1_shifted[18] B[17]=term1_shifted[17] B[16]=term1_shifted[16]
+ B[15]=term1_shifted[15] B[14]=term1_shifted[14] B[13]=term1_shifted[13]
+ B[12]=term1_shifted[12] B[11]=term1_shifted[11] B[10]=term1_shifted[10]
+ B[9]=term1_shifted[9] B[8]=term1_shifted[8] B[7]=term1_shifted[7]
+ B[6]=term1_shifted[6] B[5]=term1_shifted[5] B[4]=term1_shifted[4]
+ B[3]=term1_shifted[3] B[2]=term1_shifted[2] B[1]=term1_shifted[1]
+ B[0]=term1_shifted[0] CI=net45552 DIFF[26]=N40 DIFF[25]=N39 DIFF[24]=N38
+ DIFF[23]=N37 DIFF[22]=N36 DIFF[21]=N35 DIFF[20]=N34 DIFF[19]=N33 DIFF[18]=N32
+ DIFF[17]=N31 DIFF[16]=N30 DIFF[15]=N29 DIFF[14]=N28 DIFF[13]=N27 DIFF[12]=N26
+ DIFF[11]=N25 DIFF[10]=N24 DIFF[9]=N23 DIFF[8]=N22 DIFF[7]=N21 DIFF[6]=N20
+ DIFF[5]=N19 DIFF[4]=N18 DIFF[3]=N17 DIFF[2]=N16 DIFF[1]=N15 DIFF[0]=N14
Xadd_1_root_add_0_root_add_28_3 PE_Shift_Add_3_DW01_add_2_DW01_add_31 $PINS
+ A[26]=N67 A[25]=N66 A[24]=N65 A[23]=N64 A[22]=N63 A[21]=N62 A[20]=N61 A[19]=N60
+ A[18]=N59 A[17]=N58 A[16]=N57 A[15]=N56 A[14]=N55 A[13]=N54 A[12]=N53 A[11]=N52
+ A[10]=N51 A[9]=N50 A[8]=N49 A[7]=N48 A[6]=N47 A[5]=N46 A[4]=N45 A[3]=N44
+ A[2]=N43 A[1]=N42 A[0]=N41 B[26]=N177 B[25]=N176 B[24]=N175 B[23]=N174
+ B[22]=N173 B[21]=N172 B[20]=N171 B[19]=N170 B[18]=N169 B[17]=N168 B[16]=N167
+ B[15]=N166 B[14]=N165 B[13]=N164 B[12]=N163 B[11]=N162 B[10]=N161 B[9]=N160
+ B[8]=N159 B[7]=N158 B[6]=N157 B[5]=N156 B[4]=N155 B[3]=N154 B[2]=N153 B[1]=N152
+ B[0]=N151 CI=net45552 SUM[26]=N204 SUM[25]=N203 SUM[24]=N202 SUM[23]=N201
+ SUM[22]=N200 SUM[21]=N199 SUM[20]=N198 SUM[19]=N197 SUM[18]=N196 SUM[17]=N195
+ SUM[16]=N194 SUM[15]=N193 SUM[14]=N192 SUM[13]=N191 SUM[12]=N190 SUM[11]=N189
+ SUM[10]=N188 SUM[9]=N187 SUM[8]=N186 SUM[7]=N185 SUM[6]=N184 SUM[5]=N183
+ SUM[4]=N182 SUM[3]=N181 SUM[2]=N180 SUM[1]=N179 SUM[0]=N178
Xadd_2_root_add_0_root_add_28_3 PE_Shift_Add_3_DW01_add_1_DW01_add_30 $PINS
+ A[26]=base_val[26] A[25]=base_val[25] A[24]=base_val[24] A[23]=base_val[23]
+ A[22]=base_val[22] A[21]=base_val[21] A[20]=base_val[20] A[19]=base_val[19]
+ A[18]=base_val[18] A[17]=base_val[17] A[16]=base_val[16] A[15]=base_val[15]
+ A[14]=base_val[14] A[13]=base_val[13] A[12]=base_val[12] A[11]=base_val[11]
+ A[10]=base_val[10] A[9]=base_val[9] A[8]=base_val[8] A[7]=base_val[7]
+ A[6]=base_val[6] A[5]=base_val[5] A[4]=base_val[4] A[3]=base_val[3]
+ A[2]=base_val[2] A[1]=base_val[1] A[0]=base_val[0] B[26]=N122 B[25]=N121
+ B[24]=N120 B[23]=N119 B[22]=N118 B[21]=N117 B[20]=N116 B[19]=N115 B[18]=N114
+ B[17]=N113 B[16]=N112 B[15]=N111 B[14]=N110 B[13]=N109 B[12]=N108 B[11]=N107
+ B[10]=N106 B[9]=N105 B[8]=N104 B[7]=N103 B[6]=N102 B[5]=N101 B[4]=N100 B[3]=N99
+ B[2]=N98 B[1]=N97 B[0]=N96 CI=net45552 SUM[26]=N231 SUM[25]=N230 SUM[24]=N229
+ SUM[23]=N228 SUM[22]=N227 SUM[21]=N226 SUM[20]=N225 SUM[19]=N224 SUM[18]=N223
+ SUM[17]=N222 SUM[16]=N221 SUM[15]=N220 SUM[14]=N219 SUM[13]=N218 SUM[12]=N217
+ SUM[11]=N216 SUM[10]=N215 SUM[9]=N214 SUM[8]=N213 SUM[7]=N212 SUM[6]=N211
+ SUM[5]=N210 SUM[4]=N209 SUM[3]=N208 SUM[2]=N207 SUM[1]=N206 SUM[0]=N205
Xadd_0_root_add_0_root_add_28_3 PE_Shift_Add_3_DW01_add_0_DW01_add_29 $PINS
+ A[26]=N204 A[25]=N203 A[24]=N202 A[23]=N201 A[22]=N200 A[21]=N199 A[20]=N198
+ A[19]=N197 A[18]=N196 A[17]=N195 A[16]=N194 A[15]=N193 A[14]=N192 A[13]=N191
+ A[12]=N190 A[11]=N189 A[10]=N188 A[9]=N187 A[8]=N186 A[7]=N185 A[6]=N184
+ A[5]=N183 A[4]=N182 A[3]=N181 A[2]=N180 A[1]=N179 A[0]=N178 B[26]=N231
+ B[25]=N230 B[24]=N229 B[23]=N228 B[22]=N227 B[21]=N226 B[20]=N225 B[19]=N224
+ B[18]=N223 B[17]=N222 B[16]=N221 B[15]=N220 B[14]=N219 B[13]=N218 B[12]=N217
+ B[11]=N216 B[10]=N215 B[9]=N214 B[8]=N213 B[7]=N212 B[6]=N211 B[5]=N210
+ B[4]=N209 B[3]=N208 B[2]=N207 B[1]=N206 B[0]=N205 CI=net45552
+ SUM[26]=next_acc[26] SUM[25]=next_acc[25] SUM[24]=next_acc[24]
+ SUM[23]=next_acc[23] SUM[22]=next_acc[22] SUM[21]=next_acc[21]
+ SUM[20]=next_acc[20] SUM[19]=next_acc[19] SUM[18]=next_acc[18]
+ SUM[17]=next_acc[17] SUM[16]=next_acc[16] SUM[15]=next_acc[15]
+ SUM[14]=next_acc[14] SUM[13]=next_acc[13] SUM[12]=next_acc[12]
+ SUM[11]=next_acc[11] SUM[10]=next_acc[10] SUM[9]=next_acc[9] SUM[8]=next_acc[8]
+ SUM[7]=next_acc[7] SUM[6]=next_acc[6] SUM[5]=next_acc[5] SUM[4]=next_acc[4]
+ SUM[3]=next_acc[3] SUM[2]=next_acc[2] SUM[1]=next_acc[1] SUM[0]=next_acc[0]
.ENDS

.SUBCKT SNPS_CLOCK_GATE_HIGH_PE_Shift_Add_2 EN ENCLK CLK
*.CONNECT net2230 EN
XFE_PHC900_net2233 DELC $PINS O=net2233 I=FE_PHN900_net2233
Xlatch QDBHN $PINS Q=FE_PHN900_net2233 D=net2230 CKB=CLK
Xmain_gate AN2T $PINS O=ENCLK I1=net2233 I2=CLK
.ENDS

.SUBCKT PE_Shift_Add_2_DW01_sub_0_DW01_sub_6 A[26] A[25] A[24] A[23] A[22]
+ A[21] A[20] A[19] A[18] A[17] A[16] A[15] A[14] A[13] A[12] A[11] A[10] A[9]
+ A[8] A[7] A[6] A[5] A[4] A[3] A[2] A[1] A[0] B[26] B[25] B[24] B[23] B[22]
+ B[21] B[20] B[19] B[18] B[17] B[16] B[15] B[14] B[13] B[12] B[11] B[10] B[9]
+ B[8] B[7] B[6] B[5] B[4] B[3] B[2] B[1] B[0] CI DIFF[26] DIFF[25] DIFF[24]
+ DIFF[23] DIFF[22] DIFF[21] DIFF[20] DIFF[19] DIFF[18] DIFF[17] DIFF[16]
+ DIFF[15] DIFF[14] DIFF[13] DIFF[12] DIFF[11] DIFF[10] DIFF[9] DIFF[8] DIFF[7]
+ DIFF[6] DIFF[5] DIFF[4] DIFF[3] DIFF[2] DIFF[1] DIFF[0] CO
*.CONNECT DIFF[0] B[0]
XFE_RC_1791_0 OR2 $PINS O=FE_RN_489_0 I1=B[1] I2=DIFF[0]
XFE_RC_1790_0 XOR2HS $PINS O=DIFF[2] I1=FE_RN_489_0 I2=B[2]
XFE_RC_1683_0 XNR2HS $PINS O=DIFF[4] I1=B[4] I2=n3
XFE_RC_1668_0 AN2B1S $PINS O=n2 I1=n1 B1=B[2]
XFE_RC_1456_0 AN2S $PINS O=FE_RN_326_0 I1=n46 I2=n21
XFE_RC_1455_0 AN2 $PINS O=n23 I1=FE_RN_326_0 I2=n47
XFE_RC_1128_0 XNR2HS $PINS O=DIFF[3] I1=B[3] I2=n2
XFE_OFC670_term3_shifted_5 INV1S $PINS O=n47 I=B[5]
XFE_OFC643_term3_shifted_9 INV1S $PINS O=n43 I=B[9]
XFE_OFC642_term3_shifted_10 INV1S $PINS O=n42 I=B[10]
XU4 INV1S $PINS O=n46 I=B[6]
XU5 XNR2HS $PINS O=DIFF[1] I1=B[1] I2=n52
XU7 INV1S $PINS O=n51 I=B[1]
XU8 INV1S $PINS O=n48 I=B[4]
XU9 INV1S $PINS O=n49 I=B[3]
XU10 XOR2HS $PINS O=DIFF[6] I1=n46 I2=n22
XU12 ND2S $PINS O=n26 I1=n27 I2=n20
XU13 AN2 $PINS O=n1 I1=n51 I2=n52
XU16 AN2 $PINS O=n3 I1=n49 I2=n2
XU17 XOR2HS $PINS O=DIFF[8] I1=n44 I2=n24
XU18 XOR2HS $PINS O=DIFF[9] I1=n43 I2=n4
XU19 AN2 $PINS O=n4 I1=n44 I2=n24
XU20 XOR2HS $PINS O=DIFF[10] I1=n42 I2=n5
XU21 AN2 $PINS O=n5 I1=n43 I2=n4
XU22 XOR2HS $PINS O=DIFF[11] I1=n41 I2=n6
XU23 AN2 $PINS O=n6 I1=n42 I2=n5
XU24 XOR2HS $PINS O=DIFF[12] I1=n40 I2=n7
XU25 AN2 $PINS O=n7 I1=n41 I2=n6
XU26 XOR2HS $PINS O=DIFF[13] I1=n39 I2=n8
XU27 AN2 $PINS O=n8 I1=n40 I2=n7
XU28 XOR2HS $PINS O=DIFF[14] I1=n38 I2=n9
XU29 AN2 $PINS O=n9 I1=n39 I2=n8
XU30 XOR2HS $PINS O=DIFF[15] I1=n37 I2=n10
XU31 AN2 $PINS O=n10 I1=n38 I2=n9
XU32 XOR2HS $PINS O=DIFF[16] I1=n36 I2=n11
XU33 AN2 $PINS O=n11 I1=n37 I2=n10
XU34 XOR2HS $PINS O=DIFF[17] I1=n35 I2=n12
XU35 AN2 $PINS O=n12 I1=n36 I2=n11
XU36 XOR2HS $PINS O=DIFF[18] I1=n34 I2=n13
XU37 AN2 $PINS O=n13 I1=n35 I2=n12
XU38 XOR2HS $PINS O=DIFF[19] I1=n33 I2=n14
XU39 AN2 $PINS O=n14 I1=n34 I2=n13
XU40 XOR2HS $PINS O=DIFF[20] I1=n32 I2=n15
XU41 AN2 $PINS O=n15 I1=n33 I2=n14
XU42 XOR2HS $PINS O=DIFF[21] I1=n31 I2=n16
XU43 AN2 $PINS O=n16 I1=n32 I2=n15
XU44 XOR2HS $PINS O=DIFF[22] I1=n30 I2=n17
XU45 AN2 $PINS O=n17 I1=n31 I2=n16
XU46 XOR2HS $PINS O=DIFF[23] I1=n29 I2=n18
XU47 AN2 $PINS O=n18 I1=n30 I2=n17
XU48 XOR2HS $PINS O=DIFF[24] I1=n28 I2=n19
XU49 AN2 $PINS O=n19 I1=n29 I2=n18
XU50 AN2 $PINS O=n20 I1=n28 I2=n19
XU51 XOR2HS $PINS O=DIFF[25] I1=n27 I2=n20
XU53 XOR2HS $PINS O=DIFF[5] I1=n47 I2=n21
XU54 AN2 $PINS O=n21 I1=n48 I2=n3
XU55 AN2 $PINS O=n22 I1=n47 I2=n21
XU56 XOR2HS $PINS O=DIFF[7] I1=n45 I2=n23
XU58 AN2 $PINS O=n24 I1=n45 I2=n23
XU59 INV1S $PINS O=n44 I=B[8]
XU62 INV1S $PINS O=n41 I=B[11]
XU63 INV1S $PINS O=n40 I=B[12]
XU64 INV1S $PINS O=n39 I=B[13]
XU65 INV1S $PINS O=n38 I=B[14]
XU66 INV1S $PINS O=n37 I=B[15]
XU67 INV1S $PINS O=n36 I=B[16]
XU68 INV1S $PINS O=n35 I=B[17]
XU69 INV1S $PINS O=n34 I=B[18]
XU70 INV1S $PINS O=n33 I=B[19]
XU71 INV1S $PINS O=n32 I=B[20]
XU72 INV1S $PINS O=n31 I=B[21]
XU73 INV1S $PINS O=n30 I=B[22]
XU74 INV1S $PINS O=n29 I=B[23]
XU75 INV1S $PINS O=n28 I=B[24]
XU76 INV1S $PINS O=n27 I=B[25]
XU77 INV1S $PINS O=n45 I=B[7]
XU78 XOR2HS $PINS O=DIFF[26] I1=B[26] I2=n26
XU2 INV2 $PINS O=n52 I=B[0]
.ENDS

.SUBCKT PE_Shift_Add_2_DW01_sub_1_DW01_sub_7 A[26] A[25] A[24] A[23] A[22]
+ A[21] A[20] A[19] A[18] A[17] A[16] A[15] A[14] A[13] A[12] A[11] A[10] A[9]
+ A[8] A[7] A[6] A[5] A[4] A[3] A[2] A[1] A[0] B[26] B[25] B[24] B[23] B[22]
+ B[21] B[20] B[19] B[18] B[17] B[16] B[15] B[14] B[13] B[12] B[11] B[10] B[9]
+ B[8] B[7] B[6] B[5] B[4] B[3] B[2] B[1] B[0] CI DIFF[26] DIFF[25] DIFF[24]
+ DIFF[23] DIFF[22] DIFF[21] DIFF[20] DIFF[19] DIFF[18] DIFF[17] DIFF[16]
+ DIFF[15] DIFF[14] DIFF[13] DIFF[12] DIFF[11] DIFF[10] DIFF[9] DIFF[8] DIFF[7]
+ DIFF[6] DIFF[5] DIFF[4] DIFF[3] DIFF[2] DIFF[1] DIFF[0] CO
*.CONNECT DIFF[0] B[0]
XFE_OFC648_term2_shifted_2 INV1S $PINS O=n51 I=B[2]
XFE_OFC644_term2_shifted_6 INV1S $PINS O=n47 I=B[6]
XFE_OFC640_term2_shifted_7 INV1S $PINS O=n46 I=B[7]
XU2 NR2 $PINS O=n2 I1=B[1] I2=B[0]
XU3 NR2 $PINS O=n3 I1=B[2] I2=n1
XU4 INV1S $PINS O=n1 I=n2
XU9 XOR2HS $PINS O=DIFF[2] I1=n2 I2=n51
XU10 INV1S $PINS O=n48 I=B[5]
XU11 ND2S $PINS O=n27 I1=n28 I2=n21
XU12 AN2 $PINS O=n4 I1=n50 I2=n3
XU13 AN2 $PINS O=n5 I1=n45 I2=n25
XU14 AN2 $PINS O=n6 I1=n44 I2=n5
XU15 AN2 $PINS O=n7 I1=n43 I2=n6
XU16 AN2 $PINS O=n8 I1=n42 I2=n7
XU17 AN2 $PINS O=n9 I1=n41 I2=n8
XU18 AN2 $PINS O=n10 I1=n40 I2=n9
XU19 AN2 $PINS O=n11 I1=n39 I2=n10
XU20 AN2 $PINS O=n12 I1=n38 I2=n11
XU21 AN2 $PINS O=n13 I1=n37 I2=n12
XU22 AN2 $PINS O=n14 I1=n36 I2=n13
XU23 AN2 $PINS O=n15 I1=n35 I2=n14
XU24 AN2 $PINS O=n16 I1=n34 I2=n15
XU25 AN2 $PINS O=n17 I1=n33 I2=n16
XU26 AN2 $PINS O=n18 I1=n32 I2=n17
XU27 AN2 $PINS O=n19 I1=n31 I2=n18
XU28 AN2 $PINS O=n20 I1=n30 I2=n19
XU29 AN2 $PINS O=n21 I1=n29 I2=n20
XU30 AN2 $PINS O=n22 I1=n49 I2=n4
XU31 AN2 $PINS O=n23 I1=n48 I2=n22
XU32 AN2 $PINS O=n24 I1=n47 I2=n23
XU33 AN2 $PINS O=n25 I1=n46 I2=n24
XU34 INV1S $PINS O=n45 I=B[8]
XU35 INV1S $PINS O=n44 I=B[9]
XU36 INV1S $PINS O=n43 I=B[10]
XU37 INV1S $PINS O=n42 I=B[11]
XU38 INV1S $PINS O=n41 I=B[12]
XU39 INV1S $PINS O=n40 I=B[13]
XU40 INV1S $PINS O=n39 I=B[14]
XU41 INV1S $PINS O=n38 I=B[15]
XU42 INV1S $PINS O=n37 I=B[16]
XU43 INV1S $PINS O=n36 I=B[17]
XU44 INV1S $PINS O=n35 I=B[18]
XU45 INV1S $PINS O=n34 I=B[19]
XU46 INV1S $PINS O=n33 I=B[20]
XU47 INV1S $PINS O=n32 I=B[21]
XU48 INV1S $PINS O=n31 I=B[22]
XU49 INV1S $PINS O=n30 I=B[23]
XU50 INV1S $PINS O=n29 I=B[24]
XU51 INV1S $PINS O=n28 I=B[25]
XU54 XOR2HS $PINS O=DIFF[26] I1=B[26] I2=n27
XU55 XOR2HS $PINS O=DIFF[9] I1=n44 I2=n5
XU56 XOR2HS $PINS O=DIFF[10] I1=n43 I2=n6
XU57 XOR2HS $PINS O=DIFF[11] I1=n42 I2=n7
XU58 XOR2HS $PINS O=DIFF[7] I1=n46 I2=n24
XU59 XOR2HS $PINS O=DIFF[6] I1=n47 I2=n23
XU60 XOR2HS $PINS O=DIFF[8] I1=n45 I2=n25
XU61 XOR2HS $PINS O=DIFF[5] I1=n48 I2=n22
XU62 XOR2HS $PINS O=DIFF[4] I1=n4 I2=n49
XU63 XOR2HS $PINS O=DIFF[3] I1=n3 I2=n50
XU64 XOR2HS $PINS O=DIFF[12] I1=n41 I2=n8
XU65 XOR2HS $PINS O=DIFF[13] I1=n40 I2=n9
XU66 XOR2HS $PINS O=DIFF[14] I1=n39 I2=n10
XU67 XOR2HS $PINS O=DIFF[15] I1=n38 I2=n11
XU68 XOR2HS $PINS O=DIFF[16] I1=n37 I2=n12
XU69 XOR2HS $PINS O=DIFF[17] I1=n36 I2=n13
XU70 XOR2HS $PINS O=DIFF[18] I1=n35 I2=n14
XU71 XOR2HS $PINS O=DIFF[19] I1=n34 I2=n15
XU72 XOR2HS $PINS O=DIFF[20] I1=n33 I2=n16
XU73 XOR2HS $PINS O=DIFF[21] I1=n32 I2=n17
XU74 XOR2HS $PINS O=DIFF[22] I1=n31 I2=n18
XU75 XOR2HS $PINS O=DIFF[23] I1=n30 I2=n19
XU76 XOR2HS $PINS O=DIFF[24] I1=n29 I2=n20
XU77 XOR2HS $PINS O=DIFF[25] I1=n28 I2=n21
XU1 XOR2HS $PINS O=DIFF[1] I1=DIFF[0] I2=B[1]
XU5 INV2 $PINS O=n50 I=B[3]
XU8 INV1S $PINS O=n49 I=B[4]
.ENDS

.SUBCKT PE_Shift_Add_2_DW01_sub_2_DW01_sub_8 A[26] A[25] A[24] A[23] A[22]
+ A[21] A[20] A[19] A[18] A[17] A[16] A[15] A[14] A[13] A[12] A[11] A[10] A[9]
+ A[8] A[7] A[6] A[5] A[4] A[3] A[2] A[1] A[0] B[26] B[25] B[24] B[23] B[22]
+ B[21] B[20] B[19] B[18] B[17] B[16] B[15] B[14] B[13] B[12] B[11] B[10] B[9]
+ B[8] B[7] B[6] B[5] B[4] B[3] B[2] B[1] B[0] CI DIFF[26] DIFF[25] DIFF[24]
+ DIFF[23] DIFF[22] DIFF[21] DIFF[20] DIFF[19] DIFF[18] DIFF[17] DIFF[16]
+ DIFF[15] DIFF[14] DIFF[13] DIFF[12] DIFF[11] DIFF[10] DIFF[9] DIFF[8] DIFF[7]
+ DIFF[6] DIFF[5] DIFF[4] DIFF[3] DIFF[2] DIFF[1] DIFF[0] CO
*.CONNECT DIFF[0] B[0]
XFE_RC_1853_0 OR2T $PINS O=FE_RN_518_0 I1=B[1] I2=DIFF[0]
XFE_RC_1852_0 XOR2H $PINS O=DIFF[2] I1=FE_RN_518_0 I2=B[2]
XFE_RC_1732_0 AN2T $PINS O=n23 I1=n22 I2=n46
XFE_RC_1709_0 OR2B1S $PINS O=FE_RN_446_0 I1=B[2] B1=n1
XFE_RC_1708_0 XOR2HS $PINS O=DIFF[3] I1=FE_RN_446_0 I2=B[3]
XFE_OFC636_term1_shifted_7 INV1S $PINS O=n45 I=B[7]
XFE_OFC611_term1_shifted_3 INV2 $PINS O=n49 I=B[3]
XFE_OFC548_term1_shifted_2 INV1S $PINS O=n50 I=B[2]
XU2 NR2 $PINS O=n1 I1=B[1] I2=B[0]
XU5 INV1S $PINS O=n48 I=B[4]
XU7 INV1S $PINS O=n47 I=B[5]
XU10 XNR2HS $PINS O=DIFF[1] I1=n51 I2=B[1]
XU11 ND2S $PINS O=n26 I1=n27 I2=n20
XU12 AN2 $PINS O=n2 I1=n50 I2=n1
XU13 AN2 $PINS O=n3 I1=n49 I2=n2
XU14 AN2 $PINS O=n4 I1=n44 I2=n24
XU15 AN2 $PINS O=n5 I1=n43 I2=n4
XU16 AN2 $PINS O=n6 I1=n42 I2=n5
XU17 AN2 $PINS O=n7 I1=n41 I2=n6
XU18 AN2 $PINS O=n8 I1=n40 I2=n7
XU19 AN2 $PINS O=n9 I1=n39 I2=n8
XU20 AN2 $PINS O=n10 I1=n38 I2=n9
XU21 AN2 $PINS O=n11 I1=n37 I2=n10
XU22 AN2 $PINS O=n12 I1=n36 I2=n11
XU23 AN2 $PINS O=n13 I1=n35 I2=n12
XU24 AN2 $PINS O=n14 I1=n34 I2=n13
XU25 AN2 $PINS O=n15 I1=n33 I2=n14
XU26 AN2 $PINS O=n16 I1=n32 I2=n15
XU27 AN2 $PINS O=n17 I1=n31 I2=n16
XU28 AN2 $PINS O=n18 I1=n30 I2=n17
XU29 AN2 $PINS O=n19 I1=n29 I2=n18
XU30 AN2 $PINS O=n20 I1=n28 I2=n19
XU31 AN2 $PINS O=n21 I1=n48 I2=n3
XU32 AN2 $PINS O=n22 I1=n47 I2=n21
XU34 AN2 $PINS O=n24 I1=n45 I2=n23
XU35 INV1S $PINS O=n44 I=B[8]
XU36 INV1S $PINS O=n43 I=B[9]
XU37 INV1S $PINS O=n42 I=B[10]
XU38 INV1S $PINS O=n41 I=B[11]
XU39 INV1S $PINS O=n40 I=B[12]
XU40 INV1S $PINS O=n39 I=B[13]
XU41 INV1S $PINS O=n38 I=B[14]
XU42 INV1S $PINS O=n37 I=B[15]
XU43 INV1S $PINS O=n36 I=B[16]
XU44 INV1S $PINS O=n35 I=B[17]
XU45 INV1S $PINS O=n34 I=B[18]
XU46 INV1S $PINS O=n33 I=B[19]
XU47 INV1S $PINS O=n32 I=B[20]
XU48 INV1S $PINS O=n31 I=B[21]
XU49 INV1S $PINS O=n30 I=B[22]
XU50 INV1S $PINS O=n29 I=B[23]
XU51 INV1S $PINS O=n28 I=B[24]
XU52 INV1S $PINS O=n27 I=B[25]
XU53 INV1S $PINS O=n46 I=B[6]
XU55 XOR2HS $PINS O=DIFF[4] I1=n48 I2=n3
XU56 XOR2HS $PINS O=DIFF[6] I1=n46 I2=n22
XU57 XOR2HS $PINS O=DIFF[5] I1=n47 I2=n21
XU58 XOR2HS $PINS O=DIFF[8] I1=n44 I2=n24
XU59 XOR2HS $PINS O=DIFF[7] I1=n45 I2=n23
XU60 XOR2HS $PINS O=DIFF[9] I1=n43 I2=n4
XU61 XOR2HS $PINS O=DIFF[11] I1=n41 I2=n6
XU62 XOR2HS $PINS O=DIFF[10] I1=n42 I2=n5
XU63 XOR2HS $PINS O=DIFF[12] I1=n40 I2=n7
XU64 XOR2HS $PINS O=DIFF[13] I1=n39 I2=n8
XU65 XOR2HS $PINS O=DIFF[14] I1=n38 I2=n9
XU66 XOR2HS $PINS O=DIFF[15] I1=n37 I2=n10
XU67 XOR2HS $PINS O=DIFF[16] I1=n36 I2=n11
XU68 XOR2HS $PINS O=DIFF[17] I1=n35 I2=n12
XU69 XOR2HS $PINS O=DIFF[18] I1=n34 I2=n13
XU70 XOR2HS $PINS O=DIFF[19] I1=n33 I2=n14
XU71 XOR2HS $PINS O=DIFF[20] I1=n32 I2=n15
XU72 XOR2HS $PINS O=DIFF[21] I1=n31 I2=n16
XU73 XOR2HS $PINS O=DIFF[22] I1=n30 I2=n17
XU74 XOR2HS $PINS O=DIFF[23] I1=n29 I2=n18
XU75 XOR2HS $PINS O=DIFF[24] I1=n28 I2=n19
XU76 XOR2HS $PINS O=DIFF[25] I1=n27 I2=n20
XU77 XOR2HS $PINS O=DIFF[26] I1=B[26] I2=n26
XU1 INV1S $PINS O=n51 I=B[0]
.ENDS

.SUBCKT PE_Shift_Add_2_DW01_add_2_DW01_add_19 A[26] A[25] A[24] A[23] A[22]
+ A[21] A[20] A[19] A[18] A[17] A[16] A[15] A[14] A[13] A[12] A[11] A[10] A[9]
+ A[8] A[7] A[6] A[5] A[4] A[3] A[2] A[1] A[0] B[26] B[25] B[24] B[23] B[22]
+ B[21] B[20] B[19] B[18] B[17] B[16] B[15] B[14] B[13] B[12] B[11] B[10] B[9]
+ B[8] B[7] B[6] B[5] B[4] B[3] B[2] B[1] B[0] CI SUM[26] SUM[25] SUM[24]
+ SUM[23] SUM[22] SUM[21] SUM[20] SUM[19] SUM[18] SUM[17] SUM[16] SUM[15]
+ SUM[14] SUM[13] SUM[12] SUM[11] SUM[10] SUM[9] SUM[8] SUM[7] SUM[6] SUM[5]
+ SUM[4] SUM[3] SUM[2] SUM[1] SUM[0] CO
XFE_RC_1670_0 INV2 $PINS O=SUM[9] I=FE_RN_427_0
XFE_RC_1669_0 XNR3 $PINS O=FE_RN_427_0 I1=A[9] I2=B[9] I3=carry[9]
XFE_RC_1510_0 INV2 $PINS O=SUM[4] I=FE_RN_347_0
XFE_RC_1509_0 XNR3 $PINS O=FE_RN_347_0 I1=A[4] I2=B[4] I3=carry[4]
XFE_RC_1500_0 XOR3 $PINS O=SUM[25] I1=A[25] I2=B[25] I3=carry[25]
XFE_RC_1499_0 MAO222 $PINS O=carry[26] A1=carry[25] B1=B[25] C1=A[25]
XFE_RC_1162_0 INV2 $PINS O=SUM[10] I=FE_RN_199_0
XFE_RC_1161_0 XNR3 $PINS O=FE_RN_199_0 I1=A[10] I2=B[10] I3=carry[10]
XFE_RC_1154_0 INV2 $PINS O=SUM[14] I=FE_RN_195_0
XFE_RC_1153_0 XNR3 $PINS O=FE_RN_195_0 I1=A[14] I2=B[14] I3=carry[14]
XFE_RC_1152_0 INV2 $PINS O=SUM[8] I=FE_RN_194_0
XFE_RC_1151_0 XNR3 $PINS O=FE_RN_194_0 I1=A[8] I2=B[8] I3=carry[8]
XFE_RC_946_0 INV2 $PINS O=SUM[3] I=FE_RN_131_0
XFE_RC_945_0 XNR3 $PINS O=FE_RN_131_0 I1=A[3] I2=carry[3] I3=B[3]
XFE_RC_776_0 XOR3 $PINS O=SUM[24] I1=A[24] I2=B[24] I3=carry[24]
XFE_RC_775_0 MAO222P $PINS O=carry[25] A1=carry[24] B1=B[24] C1=A[24]
XFE_RC_774_0 XOR3 $PINS O=SUM[1] I1=A[1] I2=n3 I3=B[1]
XFE_RC_773_0 MAO222P $PINS O=carry[2] A1=A[1] B1=B[1] C1=n3
XFE_RC_739_0 XOR3 $PINS O=SUM[23] I1=A[23] I2=B[23] I3=carry[23]
XFE_RC_738_0 MAO222P $PINS O=carry[24] A1=carry[23] B1=B[23] C1=A[23]
XFE_RC_685_0 XOR3 $PINS O=SUM[2] I1=A[2] I2=B[2] I3=carry[2]
XFE_RC_684_0 MAO222P $PINS O=carry[3] A1=carry[2] B1=B[2] C1=A[2]
XFE_RC_665_0 XOR3 $PINS O=SUM[22] I1=A[22] I2=B[22] I3=carry[22]
XFE_RC_664_0 MAO222P $PINS O=carry[23] A1=carry[22] B1=B[22] C1=A[22]
XFE_RC_595_0 XOR3 $PINS O=SUM[20] I1=A[20] I2=B[20] I3=carry[20]
XFE_RC_594_0 MAO222P $PINS O=carry[21] A1=carry[20] B1=B[20] C1=A[20]
XFE_RC_555_0 XOR3 $PINS O=SUM[21] I1=A[21] I2=B[21] I3=carry[21]
XFE_RC_554_0 MAO222P $PINS O=carry[22] A1=carry[21] B1=B[21] C1=A[21]
XFE_RC_484_0 XOR3 $PINS O=SUM[19] I1=A[19] I2=B[19] I3=carry[19]
XFE_RC_483_0 MAO222P $PINS O=carry[20] A1=carry[19] B1=B[19] C1=A[19]
XFE_RC_436_0 XOR3 $PINS O=SUM[11] I1=A[11] I2=B[11] I3=carry[11]
XFE_RC_435_0 MAO222 $PINS O=carry[12] A1=carry[11] B1=B[11] C1=A[11]
XFE_RC_366_0 MAO222P $PINS O=carry[4] A1=B[3] B1=carry[3] C1=A[3]
XFE_RC_349_0 XOR3 $PINS O=SUM[12] I1=A[12] I2=B[12] I3=carry[12]
XFE_RC_348_0 MAO222P $PINS O=carry[13] A1=carry[12] B1=B[12] C1=A[12]
XFE_RC_292_0 XOR3 $PINS O=SUM[13] I1=A[13] I2=B[13] I3=carry[13]
XFE_RC_291_0 MAO222P $PINS O=carry[14] A1=carry[13] B1=B[13] C1=A[13]
XFE_RC_202_0 MAO222P $PINS O=carry[15] A1=carry[14] B1=B[14] C1=A[14]
XFE_RC_196_0 XOR3 $PINS O=SUM[15] I1=A[15] I2=B[15] I3=carry[15]
XFE_RC_195_0 MAO222P $PINS O=carry[16] A1=carry[15] B1=B[15] C1=A[15]
XFE_RC_128_0 XOR3 $PINS O=SUM[7] I1=A[7] I2=B[7] I3=carry[7]
XFE_RC_127_0 MAO222 $PINS O=carry[8] A1=carry[7] B1=B[7] C1=A[7]
XFE_RC_58_0 MAO222 $PINS O=carry[9] A1=carry[8] B1=B[8] C1=A[8]
XFE_RC_57_0 XOR3 $PINS O=SUM[16] I1=A[16] I2=B[16] I3=carry[16]
XFE_RC_56_0 MAO222P $PINS O=carry[17] A1=carry[16] B1=B[16] C1=A[16]
XFE_RC_27_0 MAO222P $PINS O=carry[10] A1=carry[9] B1=B[9] C1=A[9]
XFE_RC_24_0 XOR3 $PINS O=SUM[17] I1=A[17] I2=B[17] I3=carry[17]
XFE_RC_23_0 MAO222P $PINS O=carry[18] A1=carry[17] B1=B[17] C1=A[17]
XU1 ND2 $PINS O=n19 I1=carry[6] I2=B[6]
XU2 ND2 $PINS O=n18 I1=carry[6] I2=A[6]
XU4 XNR2HS $PINS O=SUM[26] I1=n21 I2=carry[26]
XU6 ND3P $PINS O=carry[19] I1=n5 I2=n4 I3=n6
XU7 ND3P $PINS O=carry[11] I1=n8 I2=n7 I3=n9
XU9 ND3 $PINS O=carry[5] I1=n11 I2=n12 I3=n10
XU10 AN2 $PINS O=n3 I1=A[0] I2=B[0]
XU12 ND2 $PINS O=n4 I1=carry[18] I2=A[18]
XU13 ND2 $PINS O=n5 I1=carry[18] I2=B[18]
XU14 ND2 $PINS O=n6 I1=A[18] I2=B[18]
XU16 ND2 $PINS O=n7 I1=carry[10] I2=A[10]
XU17 ND2 $PINS O=n8 I1=carry[10] I2=B[10]
XU18 ND2 $PINS O=n9 I1=A[10] I2=B[10]
XU20 ND2 $PINS O=n10 I1=A[4] I2=B[4]
XU21 ND2 $PINS O=n11 I1=carry[4] I2=A[4]
XU22 ND2 $PINS O=n12 I1=carry[4] I2=B[4]
XU23 XOR2HS $PINS O=n13 I1=A[5] I2=B[5]
XU24 XOR2HS $PINS O=SUM[5] I1=carry[5] I2=n13
XU25 ND2 $PINS O=n14 I1=A[5] I2=B[5]
XU26 ND2 $PINS O=n15 I1=carry[5] I2=A[5]
XU27 ND2 $PINS O=n16 I1=carry[5] I2=B[5]
XU28 XOR2HS $PINS O=n17 I1=A[6] I2=B[6]
XU29 XOR2HS $PINS O=SUM[6] I1=carry[6] I2=n17
XU30 ND2 $PINS O=n20 I1=A[6] I2=B[6]
XU31 ND3 $PINS O=carry[7] I1=n18 I2=n19 I3=n20
XU32 XOR2HS $PINS O=SUM[0] I1=B[0] I2=A[0]
XU3 ND3P $PINS O=carry[6] I1=n15 I2=n16 I3=n14
XU11 XOR3 $PINS O=SUM[18] I1=A[18] I2=B[18] I3=carry[18]
XU15 XNR2HS $PINS O=n21 I1=B[26] I2=A[26]
.ENDS

.SUBCKT PE_Shift_Add_2_DW01_add_1_DW01_add_18 A[26] A[25] A[24] A[23] A[22]
+ A[21] A[20] A[19] A[18] A[17] A[16] A[15] A[14] A[13] A[12] A[11] A[10] A[9]
+ A[8] A[7] A[6] A[5] A[4] A[3] A[2] A[1] A[0] B[26] B[25] B[24] B[23] B[22]
+ B[21] B[20] B[19] B[18] B[17] B[16] B[15] B[14] B[13] B[12] B[11] B[10] B[9]
+ B[8] B[7] B[6] B[5] B[4] B[3] B[2] B[1] B[0] CI SUM[26] SUM[25] SUM[24]
+ SUM[23] SUM[22] SUM[21] SUM[20] SUM[19] SUM[18] SUM[17] SUM[16] SUM[15]
+ SUM[14] SUM[13] SUM[12] SUM[11] SUM[10] SUM[9] SUM[8] SUM[7] SUM[6] SUM[5]
+ SUM[4] SUM[3] SUM[2] SUM[1] SUM[0] CO
XFE_RC_1830_0 INV2 $PINS O=SUM[1] I=FE_RN_508_0
XFE_RC_1829_0 XNR3 $PINS O=FE_RN_508_0 I1=A[1] I2=B[1] I3=n5
XFE_RC_1624_0 XOR3 $PINS O=SUM[24] I1=A[24] I2=B[24] I3=carry[24]
XFE_RC_1623_0 MAO222 $PINS O=carry[25] A1=A[24] B1=B[24] C1=carry[24]
XFE_RC_1512_0 INV1S $PINS O=FE_RN_348_0 I=n14
XFE_RC_1511_0 ND3P $PINS O=carry[22] I1=n20 I2=n19 I3=FE_RN_348_0
XFE_RC_1258_0 MAO222P $PINS O=carry[21] A1=carry[20] B1=A[20] C1=B[20]
XFE_RC_1122_0 XOR3 $PINS O=SUM[26] I1=A[26] I2=B[26] I3=carry[26]
XFE_RC_982_0 XOR3 $PINS O=SUM[5] I1=A[5] I2=B[5] I3=carry[5]
XFE_RC_981_0 MAO222 $PINS O=carry[6] A1=carry[5] B1=B[5] C1=A[5]
XFE_RC_754_0 XOR3 $PINS O=SUM[25] I1=A[25] I2=B[25] I3=carry[25]
XFE_RC_753_0 MAO222 $PINS O=carry[26] A1=carry[25] B1=B[25] C1=A[25]
XFE_RC_745_0 XOR3 $PINS O=SUM[22] I1=A[22] I2=B[22] I3=carry[22]
XFE_RC_744_0 MAO222P $PINS O=carry[23] A1=carry[22] B1=B[22] C1=A[22]
XFE_RC_717_0 XOR3 $PINS O=SUM[23] I1=A[23] I2=B[23] I3=carry[23]
XFE_RC_716_0 MAO222P $PINS O=carry[24] A1=carry[23] B1=B[23] C1=A[23]
XFE_RC_673_0 XOR3 $PINS O=SUM[4] I1=A[4] I2=B[4] I3=carry[4]
XFE_RC_672_0 MAO222 $PINS O=carry[5] A1=carry[4] B1=B[4] C1=A[4]
XFE_RC_619_0 XOR3 $PINS O=SUM[10] I1=A[10] I2=B[10] I3=carry[10]
XFE_RC_618_0 MAO222P $PINS O=carry[11] A1=carry[10] B1=B[10] C1=A[10]
XFE_RC_585_0 XOR3 $PINS O=SUM[11] I1=A[11] I2=B[11] I3=carry[11]
XFE_RC_584_0 MAO222P $PINS O=carry[12] A1=carry[11] B1=B[11] C1=A[11]
XFE_RC_519_0 XOR3 $PINS O=SUM[13] I1=A[13] I2=B[13] I3=carry[13]
XFE_RC_518_0 MAO222P $PINS O=carry[14] A1=carry[13] B1=B[13] C1=A[13]
XFE_RC_456_0 XOR3 $PINS O=SUM[14] I1=A[14] I2=B[14] I3=carry[14]
XFE_RC_455_0 MAO222P $PINS O=carry[15] A1=carry[14] B1=B[14] C1=A[14]
XFE_RC_412_0 XOR3 $PINS O=SUM[12] I1=A[12] I2=B[12] I3=carry[12]
XFE_RC_411_0 MAO222P $PINS O=carry[13] A1=carry[12] B1=B[12] C1=A[12]
XFE_RC_408_0 XOR3 $PINS O=SUM[15] I1=A[15] I2=B[15] I3=carry[15]
XFE_RC_407_0 MAO222P $PINS O=carry[16] A1=carry[15] B1=B[15] C1=A[15]
XFE_RC_322_0 XOR3 $PINS O=SUM[9] I1=A[9] I2=B[9] I3=carry[9]
XFE_RC_321_0 MAO222 $PINS O=carry[10] A1=carry[9] B1=B[9] C1=A[9]
XFE_RC_313_0 XOR3 $PINS O=SUM[16] I1=A[16] I2=B[16] I3=carry[16]
XFE_RC_312_0 MAO222P $PINS O=carry[17] A1=carry[16] B1=B[16] C1=A[16]
XFE_RC_217_0 XOR3 $PINS O=SUM[2] I1=A[2] I2=carry[2] I3=B[2]
XFE_RC_216_0 MAO222 $PINS O=carry[3] A1=B[2] B1=carry[2] C1=A[2]
XFE_RC_175_0 XOR3 $PINS O=SUM[3] I1=A[3] I2=B[3] I3=carry[3]
XFE_RC_174_0 MAO222 $PINS O=carry[4] A1=carry[3] B1=B[3] C1=A[3]
XFE_RC_159_0 XOR3 $PINS O=SUM[17] I1=A[17] I2=B[17] I3=carry[17]
XFE_RC_158_0 MAO222P $PINS O=carry[18] A1=carry[17] B1=B[17] C1=A[17]
XFE_RC_64_0 XOR3 $PINS O=SUM[6] I1=A[6] I2=B[6] I3=carry[6]
XFE_RC_63_0 MAO222 $PINS O=carry[7] A1=carry[6] B1=B[6] C1=A[6]
XFE_RC_34_0 MAO222 $PINS O=carry[2] A1=B[1] B1=A[1] C1=n5
XFE_RC_32_0 XOR3 $PINS O=SUM[7] I1=A[7] I2=B[7] I3=carry[7]
XFE_RC_31_0 MAO222 $PINS O=carry[8] A1=carry[7] B1=B[7] C1=A[7]
XU2 AN2 $PINS O=n5 I1=B[0] I2=A[0]
XU3 XOR3 $PINS O=SUM[8] I1=B[8] I2=A[8] I3=carry[8]
XU4 XOR2HS $PINS O=n1 I1=B[18] I2=A[18]
XU5 XOR2HS $PINS O=SUM[18] I1=carry[18] I2=n1
XU6 ND2P $PINS O=n2 I1=carry[18] I2=B[18]
XU7 ND2 $PINS O=n3 I1=carry[18] I2=A[18]
XU8 ND2S $PINS O=n4 I1=B[18] I2=A[18]
XU9 ND3P $PINS O=carry[19] I1=n3 I2=n2 I3=n4
XU10 ND2 $PINS O=n19 I1=carry[21] I2=A[21]
XU14 ND3P $PINS O=carry[9] I1=n7 I2=n6 I3=n8
XU15 ND2 $PINS O=n6 I1=carry[8] I2=B[8]
XU16 ND2 $PINS O=n7 I1=carry[8] I2=A[8]
XU17 ND2 $PINS O=n8 I1=B[8] I2=A[8]
XU19 ND2 $PINS O=n11 I1=carry[19] I2=B[19]
XU20 XOR3 $PINS O=SUM[19] I1=B[19] I2=A[19] I3=carry[19]
XU21 ND2 $PINS O=n12 I1=carry[19] I2=A[19]
XU22 ND2S $PINS O=n13 I1=B[19] I2=A[19]
XU25 AN2 $PINS O=n14 I1=A[21] I2=B[21]
XU29 XOR2HS $PINS O=n18 I1=A[21] I2=B[21]
XU30 XOR2HS $PINS O=SUM[21] I1=carry[21] I2=n18
XU31 ND2 $PINS O=n20 I1=B[21] I2=carry[21]
XU32 XOR2HS $PINS O=SUM[0] I1=B[0] I2=A[0]
XU1 XOR3 $PINS O=SUM[20] I1=A[20] I2=B[20] I3=carry[20]
XU23 ND3P $PINS O=carry[20] I1=n11 I2=n12 I3=n13
.ENDS

.SUBCKT PE_Shift_Add_2_DW01_add_0_DW01_add_17 A[26] A[25] A[24] A[23] A[22]
+ A[21] A[20] A[19] A[18] A[17] A[16] A[15] A[14] A[13] A[12] A[11] A[10] A[9]
+ A[8] A[7] A[6] A[5] A[4] A[3] A[2] A[1] A[0] B[26] B[25] B[24] B[23] B[22]
+ B[21] B[20] B[19] B[18] B[17] B[16] B[15] B[14] B[13] B[12] B[11] B[10] B[9]
+ B[8] B[7] B[6] B[5] B[4] B[3] B[2] B[1] B[0] CI SUM[26] SUM[25] SUM[24]
+ SUM[23] SUM[22] SUM[21] SUM[20] SUM[19] SUM[18] SUM[17] SUM[16] SUM[15]
+ SUM[14] SUM[13] SUM[12] SUM[11] SUM[10] SUM[9] SUM[8] SUM[7] SUM[6] SUM[5]
+ SUM[4] SUM[3] SUM[2] SUM[1] SUM[0] CO
XFE_PHC1051_next_acc_0 DELB $PINS O=SUM[0] I=FE_PHN1051_next_acc_0
XFE_RC_1296_0 INV1S $PINS O=FE_RN_262_0 I=B[21]
XFE_RC_1295_0 AO13 $PINS O=n22 A1=FE_RN_262_0 B1=n2 B2=n1 B3=n3
XFE_RC_1057_0 XOR3 $PINS O=SUM[25] I1=A[25] I2=B[25] I3=carry[25]
XFE_RC_1056_0 MAO222 $PINS O=carry[26] A1=carry[25] B1=B[25] C1=A[25]
XFE_RC_988_0 XNR2HS $PINS O=FE_RN_144_0 I1=A[26] I2=B[26]
XFE_RC_987_0 XNR2HS $PINS O=SUM[26] I1=FE_RN_144_0 I2=carry[26]
XFE_RC_663_0 XOR3 $PINS O=SUM[1] I1=A[1] I2=B[1] I3=n4
XFE_RC_662_0 MAO222 $PINS O=carry[2] A1=A[1] B1=B[1] C1=n4
XFE_RC_615_0 XOR3 $PINS O=SUM[2] I1=A[2] I2=B[2] I3=carry[2]
XFE_RC_614_0 MAO222 $PINS O=carry[3] A1=A[2] B1=carry[2] C1=B[2]
XFE_RC_573_0 XOR3 $PINS O=SUM[3] I1=A[3] I2=B[3] I3=carry[3]
XFE_RC_572_0 MAO222 $PINS O=carry[4] A1=carry[3] B1=B[3] C1=A[3]
XFE_RC_509_0 XOR3 $PINS O=SUM[4] I1=A[4] I2=B[4] I3=carry[4]
XFE_RC_508_0 MAO222 $PINS O=carry[5] A1=carry[4] B1=A[4] C1=B[4]
XFE_RC_488_0 XOR3 $PINS O=SUM[5] I1=A[5] I2=B[5] I3=carry[5]
XFE_RC_487_0 MAO222 $PINS O=carry[6] A1=carry[5] B1=B[5] C1=A[5]
XFE_RC_416_0 XOR3 $PINS O=SUM[8] I1=A[8] I2=B[8] I3=carry[8]
XFE_RC_415_0 MAO222 $PINS O=carry[9] A1=carry[8] B1=B[8] C1=A[8]
XFE_RC_347_0 XOR3 $PINS O=SUM[9] I1=A[9] I2=B[9] I3=carry[9]
XFE_RC_346_0 MAO222 $PINS O=carry[10] A1=carry[9] B1=B[9] C1=A[9]
XFE_RC_284_0 XOR3 $PINS O=SUM[6] I1=A[6] I2=B[6] I3=carry[6]
XFE_RC_283_0 MAO222 $PINS O=carry[7] A1=carry[6] B1=B[6] C1=A[6]
XFE_RC_253_0 XOR3 $PINS O=SUM[7] I1=A[7] I2=B[7] I3=carry[7]
XFE_RC_252_0 MAO222P $PINS O=carry[8] A1=carry[7] B1=B[7] C1=A[7]
XFE_RC_249_0 XOR3 $PINS O=SUM[10] I1=A[10] I2=B[10] I3=carry[10]
XFE_RC_248_0 MAO222 $PINS O=carry[11] A1=carry[10] B1=B[10] C1=A[10]
XFE_RC_184_0 XOR3 $PINS O=SUM[22] I1=A[22] I2=B[22] I3=carry[22]
XFE_RC_183_0 MAO222P $PINS O=carry[23] A1=carry[22] B1=B[22] C1=A[22]
XFE_RC_122_0 XOR3 $PINS O=SUM[16] I1=A[16] I2=B[16] I3=carry[16]
XFE_RC_121_0 MAO222P $PINS O=carry[17] A1=carry[16] B1=B[16] C1=A[16]
XFE_RC_85_0 XOR3 $PINS O=SUM[11] I1=A[11] I2=B[11] I3=carry[11]
XFE_RC_84_0 MAO222P $PINS O=carry[12] A1=carry[11] B1=B[11] C1=A[11]
XFE_RC_43_0 XOR3 $PINS O=SUM[18] I1=A[18] I2=B[18] I3=carry[18]
XFE_RC_42_0 MAO222 $PINS O=carry[19] A1=carry[18] B1=B[18] C1=A[18]
XFE_RC_41_0 XOR3 $PINS O=SUM[14] I1=A[14] I2=B[14] I3=carry[14]
XFE_RC_40_0 MAO222P $PINS O=carry[15] A1=carry[14] B1=B[14] C1=A[14]
XFE_RC_17_0 XOR3 $PINS O=SUM[19] I1=A[19] I2=B[19] I3=carry[19]
XFE_RC_16_0 MAO222P $PINS O=carry[20] A1=carry[19] B1=B[19] C1=A[19]
XU1 ND2 $PINS O=n3 I1=B[20] I2=A[20]
XU2 ND3 $PINS O=carry[14] I1=n12 I2=n11 I3=n13
XU3 ND3P $PINS O=carry[13] I1=n5 I2=n6 I3=n7
XU6 XOR3 $PINS O=SUM[20] I1=B[20] I2=A[20] I3=carry[20]
XU7 ND2P $PINS O=n1 I1=carry[20] I2=B[20]
XU8 ND2P $PINS O=n2 I1=carry[20] I2=A[20]
XU10 XOR3 $PINS O=SUM[12] I1=B[12] I2=A[12] I3=carry[12]
XU11 XOR3 $PINS O=SUM[15] I1=A[15] I2=B[15] I3=carry[15]
XU12 XOR3 $PINS O=SUM[17] I1=A[17] I2=B[17] I3=carry[17]
XU15 XOR3 $PINS O=SUM[23] I1=A[23] I2=B[23] I3=carry[23]
XU18 AN2 $PINS O=n4 I1=B[0] I2=A[0]
XU19 ND2 $PINS O=n5 I1=carry[12] I2=B[12]
XU20 ND2P $PINS O=n6 I1=carry[12] I2=A[12]
XU21 ND2 $PINS O=n7 I1=B[12] I2=A[12]
XU22 ND2 $PINS O=n8 I1=carry[23] I2=A[23]
XU23 ND2P $PINS O=n9 I1=carry[23] I2=B[23]
XU24 ND2 $PINS O=n10 I1=A[23] I2=B[23]
XU25 ND3P $PINS O=carry[24] I1=n8 I2=n9 I3=n10
XU28 ND2 $PINS O=n23 I1=A[21] I2=B[21]
XU29 ND2 $PINS O=n13 I1=B[13] I2=A[13]
XU30 ND2 $PINS O=n14 I1=carry[15] I2=A[15]
XU31 ND2P $PINS O=n15 I1=carry[15] I2=B[15]
XU32 ND2 $PINS O=n16 I1=A[15] I2=B[15]
XU33 ND2 $PINS O=n17 I1=carry[17] I2=A[17]
XU34 ND2 $PINS O=n18 I1=carry[17] I2=B[17]
XU35 ND2S $PINS O=n19 I1=A[17] I2=B[17]
XU36 XOR2HS $PINS O=n20 I1=A[21] I2=B[21]
XU37 XOR2HS $PINS O=SUM[21] I1=carry[21] I2=n20
XU40 ND2 $PINS O=n24 I1=carry[24] I2=A[24]
XU41 ND2 $PINS O=n25 I1=carry[24] I2=B[24]
XU42 ND2S $PINS O=n26 I1=A[24] I2=B[24]
XU43 XOR2HS $PINS O=FE_PHN1051_next_acc_0 I1=B[0] I2=A[0]
XU4 XOR3 $PINS O=SUM[24] I1=A[24] I2=B[24] I3=carry[24]
XU5 XOR3 $PINS O=SUM[13] I1=B[13] I2=A[13] I3=carry[13]
XU13 ND3 $PINS O=carry[18] I1=n17 I2=n18 I3=n19
XU14 ND2P $PINS O=n21 I1=carry[21] I2=A[21]
XU16 ND3 $PINS O=carry[25] I1=n25 I2=n24 I3=n26
XU17 ND3P $PINS O=carry[21] I1=n1 I2=n2 I3=n3
XU26 ND3P $PINS O=carry[16] I1=n14 I2=n15 I3=n16
XU27 ND3P $PINS O=carry[22] I1=n22 I2=n21 I3=n23
XU38 ND2 $PINS O=n12 I1=carry[13] I2=A[13]
XU39 ND2 $PINS O=n11 I1=carry[13] I2=B[13]
.ENDS

.SUBCKT PE_Shift_Add_2 rst_n en clear calc_done stage_sel x_in[16] x_in[15]
+ x_in[14] x_in[13] x_in[12] x_in[11] x_in[10] x_in[9] x_in[8] x_in[7] x_in[6]
+ x_in[5] x_in[4] x_in[3] x_in[2] x_in[1] x_in[0] sign1[1] sign1[0] sign2[1]
+ sign2[0] sign3[1] sign3[0] shf1[3] shf1[2] shf1[1] shf1[0] shf2[3] shf2[2]
+ shf2[1] shf2[0] shf3[3] shf3[2] shf3[1] shf3[0] y_out[16] y_out[15] y_out[14]
+ y_out[13] y_out[12] y_out[11] y_out[10] y_out[9] y_out[8] y_out[7] y_out[6]
+ y_out[5] y_out[4] y_out[3] y_out[2] y_out[1] y_out[0] i_rst_n
+ FE_OFN23_i_rst_n FE_OFN42_h23_3 FE_OFN44_h21_3 FE_OFN47_h23_2 FE_OFN48_h22_2
+ FE_OFN49_h23_1 FE_OFN51_h22_1 FE_OFN53_h23_0 FE_OFN58_h21_2 FE_OFN60_s22_1
+ FE_OFN61_h21_0 FE_OFN64_h21_1 FE_OFN78_n FE_OFN82_n clk_clone2 clk_clone1 clk
XFE_PHC1303_N246 DELB $PINS O=N246 I=FE_PHN1303_N246
XFE_PHC1301_N239 DELB $PINS O=N239 I=FE_PHN1301_N239
XFE_PHC1296_N245 DELB $PINS O=N245 I=FE_PHN1296_N245
XFE_PHC1281_N244 DELB $PINS O=FE_PHN1281_N244 I=N244
XFE_PHC1249_acc_reg_18 DELB $PINS O=acc_reg[18] I=FE_PHN1249_acc_reg_18
XFE_PHC1183_pe_i2_12 DELC $PINS O=y_out[12] I=FE_PHN1183_pe_i2_12
XFE_PHC1182_pe_i2_14 DELC $PINS O=y_out[14] I=FE_PHN1182_pe_i2_14
XFE_PHC1177_acc_reg_22 DELB $PINS O=FE_PHN1177_acc_reg_22 I=acc_reg[22]
XFE_PHC1156_acc_reg_23 DELB $PINS O=FE_PHN1156_acc_reg_23 I=acc_reg[23]
XFE_PHC1082_pe_i2_16 DELC $PINS O=y_out[16] I=FE_PHN1082_pe_i2_16
XFE_PHC982_N242 DELB $PINS O=N242 I=FE_PHN982_N242
XFE_PHC972_N238 DELB $PINS O=FE_PHN972_N238 I=N238
XFE_PHC970_N236 DELB $PINS O=FE_PHN970_N236 I=N236
XFE_PHC964_N240 DELB $PINS O=FE_PHN964_N240 I=N240
XFE_PHC960_N235 DELB $PINS O=N235 I=FE_PHN960_N235
XFE_PHC957_N237 DELB $PINS O=N237 I=FE_PHN957_N237
XFE_PHC950_N241 DELB $PINS O=N241 I=FE_PHN950_N241
XFE_PHC940_N251 DELC $PINS O=FE_PHN940_N251 I=N251
XFE_PHC935_acc_reg_24 DELB $PINS O=FE_PHN935_acc_reg_24 I=acc_reg[24]
XFE_PHC934_acc_reg_25 DELB $PINS O=FE_PHN934_acc_reg_25 I=acc_reg[25]
XFE_PHC723_pe_i2_8 DELC $PINS O=y_out[8] I=FE_PHN723_pe_i2_8
XFE_PHC721_pe_i2_3 DELC $PINS O=y_out[3] I=FE_PHN721_pe_i2_3
XFE_PHC719_pe_i2_5 DELC $PINS O=y_out[5] I=FE_PHN719_pe_i2_5
XFE_PHC718_pe_i2_4 DELC $PINS O=y_out[4] I=FE_PHN718_pe_i2_4
XFE_PHC717_pe_i2_6 DELC $PINS O=y_out[6] I=FE_PHN717_pe_i2_6
XFE_RC_1844_0 INV2 $PINS O=N44 I=FE_RN_514_0
XFE_RC_1843_0 AOI22H $PINS O=FE_RN_514_0 A1=N17 A2=sign1[0] B1=term1_shifted[3]
+ B2=n52
XFE_RC_1819_0 ND2 $PINS O=FE_RN_503_0 I1=N126 I2=sign3[0]
XFE_RC_1818_0 OR3B1 $PINS O=FE_RN_504_0 I1=n77 I2=n79 B1=n29
XFE_RC_1817_0 ND2P $PINS O=N153 I1=FE_RN_504_0 I2=FE_RN_503_0
XFE_RC_1810_0 AN3 $PINS O=FE_RN_498_0 I1=sll_18/ML_int[3][4] I2=n26 I3=n29
XFE_RC_1809_0 AO12P $PINS O=N155 A1=FE_RN_498_0 B1=N128 B2=sign3[0]
XFE_RC_1789_0 NR2 $PINS O=FE_RN_488_0 I1=shf1[1] I2=n58
XFE_RC_1788_0 AN2T $PINS O=term1_shifted[1] I1=sll_16/ML_int[1][1]
+ I2=FE_RN_488_0
XFE_RC_1787_0 INV2 $PINS O=N42 I=FE_RN_487_0
XFE_RC_1786_0 AOI22S $PINS O=FE_RN_487_0 A1=N15 A2=sign1[0] B1=term1_shifted[1]
+ B2=n52
XFE_RC_1784_0 INV2 $PINS O=N152 I=FE_RN_485_0
XFE_RC_1783_0 AN2T $PINS O=FE_RN_486_0 I1=term3_shifted[1] I2=n29
XFE_RC_1782_0 AOI12H $PINS O=FE_RN_485_0 A1=FE_RN_486_0 B1=N125 B2=sign3[0]
XFE_RC_1707_0 AN2B1T $PINS O=term2_shifted[1] I1=sll_17/ML_int[1][1] B1=n15
XFE_RC_1675_0 AN2T $PINS O=term3_shifted[1] I1=sll_18/ML_int[1][1] I2=n104
XFE_RC_1674_0 INV1S $PINS O=FE_RN_429_0 I=n26
XFE_RC_1673_0 AN2B1T $PINS O=term3_shifted[4] I1=sll_18/ML_int[3][4]
+ B1=FE_RN_429_0
XFE_RC_1664_0 INV2 $PINS O=FE_RN_424_0 I=sll_17/ML_int[2][2]
XFE_RC_1663_0 NR2P $PINS O=term2_shifted[2] I1=FE_RN_424_0 I2=n67
XFE_RC_1627_0 INV1S $PINS O=FE_RN_403_0 I=n75
XFE_RC_1626_0 MUX2 $PINS O=sll_18/ML_int[3][4] S=FE_OFN330_h23_2
+ A=sll_18/ML_int[2][4] B=FE_RN_403_0
XFE_RC_1620_0 NR2 $PINS O=FE_RN_401_0 I1=n1 I2=n67
XFE_RC_1619_0 INV1S $PINS O=FE_RN_400_0 I=FE_RN_401_0
XFE_RC_1618_0 NR2 $PINS O=n17 I1=FE_OFN51_h22_1 I2=FE_RN_400_0
XCTS_ccl_a_INV_CLK_G1_L8_42 INV4CK $PINS O=CTS_10 I=CTS_11
XCTS_ccl_a_INV_CLK_G1_L7_45 INV3CK $PINS O=CTS_11 I=CTS_12
XFE_RC_1501_0 NR2P $PINS O=term2_shifted[3] I1=n68 I2=n67
XFE_RC_8_0 OA12 $PINS O=N151 A1=N124 B1=sign3[0] B2=n29
XFE_RC_1_0 OA12 $PINS O=N41 A1=N14 B1=sign1[0] B2=n52
XFE_OFC628_s21_0 INV1S $PINS O=FE_OFN353_n I=FE_OFN82_n
XFE_OFC627_s21_0 INV1S $PINS O=FE_OFN352_n I=FE_OFN82_n
XFE_OFC622_s21_0 INV1S $PINS O=n52 I=sign1[0]
XFE_OFC578_sll_18_ML_int_2__3 INV1S $PINS O=n78 I=sll_18/ML_int[2][3]
XFE_OFC562_h23_2 INV1S $PINS O=FE_OFN330_h23_2 I=FE_OFN47_h23_2
XFE_OFC533_sll_16_ML_int_2__3 INV1S $PINS O=n59 I=sll_16/ML_int[2][3]
XFE_OFC524_s22_0 INV2 $PINS O=FE_OFN315_s22_0 I=sign2[0]
XFE_OFC523_s22_0 INV1S $PINS O=FE_DBTN25_s22_0 I=sign2[0]
XFE_OFC511_h22_3 INV1S $PINS O=FE_OFN312_h22_3 I=shf2[3]
XFE_OFC510_h22_3 INV1S $PINS O=n39 I=shf2[3]
XFE_OFC508_h22_2 INV1S $PINS O=n37 I=FE_OFN48_h22_2
XFE_OFC485_n103 BUF1 $PINS O=FE_OFN302_n103 I=FE_OFN78_n
XFE_OFC473_FE_DBTN25_s22_0 BUF1 $PINS O=FE_OFN290_FE_DBTN25_s22_0 I=sign2[0]
XFE_OFC383_h23_0 INV1S $PINS O=n21 I=shf3[0]
XFE_OFC358_h23_1 INV1S $PINS O=FE_OFN218_h23_1 I=FE_OFN49_h23_1
XFE_OFC347_h22_0 INV1S $PINS O=n33 I=shf2[0]
XFE_OFC261_h21_3 INV1S $PINS O=FE_OFN184_h21_3 I=FE_OFN44_h21_3
XFE_OFC214_h23_3 INV1S $PINS O=n26 I=shf3[3]
XFE_OFC195_s23_0 INV2 $PINS O=n29 I=sign3[0]
XU110 AO22 $PINS O=base_val[13] A1=acc_reg[13] A2=FE_OFN302_n103 B1=clear
+ B2=stage_sel
XU116 AO22 $PINS O=N66 A1=N39 A2=FE_OFN82_n B1=term1_shifted[25] B2=FE_OFN352_n
XU117 AO22 $PINS O=N65 A1=N38 A2=FE_OFN82_n B1=term1_shifted[24] B2=FE_OFN352_n
XU118 AO22 $PINS O=N64 A1=N37 A2=FE_OFN82_n B1=term1_shifted[23] B2=FE_OFN352_n
XU119 AO22 $PINS O=N63 A1=N36 A2=FE_OFN82_n B1=term1_shifted[22] B2=FE_OFN352_n
XU120 AO22 $PINS O=N62 A1=N35 A2=FE_OFN82_n B1=term1_shifted[21] B2=FE_OFN352_n
XU121 AO22 $PINS O=N61 A1=N34 A2=FE_OFN82_n B1=term1_shifted[20] B2=FE_OFN352_n
XU122 AO22 $PINS O=N60 A1=N33 A2=FE_OFN82_n B1=term1_shifted[19] B2=FE_OFN352_n
XU123 AO22 $PINS O=N59 A1=N32 A2=FE_OFN82_n B1=term1_shifted[18] B2=FE_OFN352_n
XU124 AO22 $PINS O=N58 A1=N31 A2=FE_OFN82_n B1=term1_shifted[17] B2=FE_OFN352_n
XU125 AO22 $PINS O=N57 A1=N30 A2=FE_OFN82_n B1=term1_shifted[16] B2=FE_OFN353_n
XU126 AO22 $PINS O=N56 A1=N29 A2=FE_OFN82_n B1=term1_shifted[15] B2=FE_OFN353_n
XU127 AO22 $PINS O=N55 A1=N28 A2=FE_OFN82_n B1=term1_shifted[14] B2=FE_OFN353_n
XU128 AO22 $PINS O=N54 A1=N27 A2=FE_OFN82_n B1=term1_shifted[13] B2=FE_OFN353_n
XU129 AO22 $PINS O=N53 A1=N26 A2=FE_OFN82_n B1=term1_shifted[12] B2=FE_OFN353_n
XU130 AO22 $PINS O=N52 A1=N25 A2=FE_OFN82_n B1=term1_shifted[11] B2=FE_OFN353_n
XU131 AO22 $PINS O=N51 A1=N24 A2=FE_OFN82_n B1=term1_shifted[10] B2=FE_OFN353_n
XU132 AO22 $PINS O=N50 A1=N23 A2=sign1[0] B1=term1_shifted[9] B2=n52
XU133 AO22 $PINS O=N49 A1=N22 A2=sign1[0] B1=term1_shifted[8] B2=n52
XU134 AO22 $PINS O=N48 A1=N21 A2=sign1[0] B1=term1_shifted[7] B2=n52
XU136 AO22 $PINS O=N46 A1=N19 A2=sign1[0] B1=term1_shifted[5] B2=n52
XU137 AO22 $PINS O=N45 A1=N18 A2=sign1[0] B1=term1_shifted[4] B2=n52
XU143 AO22 $PINS O=N176 A1=N149 A2=sign3[0] B1=term3_shifted[25] B2=n29
XU144 AO22 $PINS O=N175 A1=N148 A2=sign3[0] B1=term3_shifted[24] B2=n29
XU145 AO22 $PINS O=N174 A1=N147 A2=sign3[0] B1=term3_shifted[23] B2=n29
XU146 AO22 $PINS O=N173 A1=N146 A2=sign3[0] B1=term3_shifted[22] B2=n29
XU147 AO22 $PINS O=N172 A1=N145 A2=sign3[0] B1=term3_shifted[21] B2=n29
XU148 AO22 $PINS O=N171 A1=N144 A2=sign3[0] B1=term3_shifted[20] B2=n29
XU149 AO22 $PINS O=N170 A1=N143 A2=sign3[0] B1=term3_shifted[19] B2=n29
XU150 AO22 $PINS O=N169 A1=N142 A2=sign3[0] B1=term3_shifted[18] B2=n29
XU151 AO22 $PINS O=N168 A1=N141 A2=sign3[0] B1=term3_shifted[17] B2=n29
XU152 AO22 $PINS O=N167 A1=N140 A2=sign3[0] B1=term3_shifted[16] B2=n29
XU153 AO22 $PINS O=N166 A1=N139 A2=sign3[0] B1=term3_shifted[15] B2=n29
XU154 AO22 $PINS O=N165 A1=N138 A2=sign3[0] B1=term3_shifted[14] B2=n29
XU155 AO22 $PINS O=N164 A1=N137 A2=sign3[0] B1=term3_shifted[13] B2=n29
XU156 AO22 $PINS O=N163 A1=N136 A2=sign3[0] B1=term3_shifted[12] B2=n29
XU157 AO22 $PINS O=N162 A1=N135 A2=sign3[0] B1=term3_shifted[11] B2=n29
XU159 AO22 $PINS O=N160 A1=N133 A2=sign3[0] B1=term3_shifted[9] B2=n29
XU160 AO22 $PINS O=N159 A1=N132 A2=sign3[0] B1=term3_shifted[8] B2=n29
XU161 AO22 $PINS O=N158 A1=N131 A2=sign3[0] B1=term3_shifted[7] B2=n29
XU165 AO22 $PINS O=N154 A1=N127 A2=sign3[0] B1=term3_shifted[3] B2=n29
XU169 AO22 $PINS O=N122 A1=N95 A2=FE_DBTN25_s22_0 B1=term2_shifted[26]
+ B2=FE_OFN290_FE_DBTN25_s22_0
XU170 AO22 $PINS O=N121 A1=N94 A2=FE_DBTN25_s22_0 B1=term2_shifted[25]
+ B2=FE_OFN290_FE_DBTN25_s22_0
XU171 AO22 $PINS O=N120 A1=N93 A2=FE_DBTN25_s22_0 B1=term2_shifted[24]
+ B2=FE_OFN290_FE_DBTN25_s22_0
XU173 AO22 $PINS O=N118 A1=N91 A2=FE_DBTN25_s22_0 B1=term2_shifted[22]
+ B2=FE_OFN290_FE_DBTN25_s22_0
XU174 AO22 $PINS O=N117 A1=N90 A2=FE_DBTN25_s22_0 B1=term2_shifted[21]
+ B2=FE_OFN290_FE_DBTN25_s22_0
XU179 AO22 $PINS O=N112 A1=N85 A2=FE_DBTN25_s22_0 B1=term2_shifted[16]
+ B2=FE_OFN290_FE_DBTN25_s22_0
XU180 AO22 $PINS O=N111 A1=N84 A2=FE_DBTN25_s22_0 B1=term2_shifted[15]
+ B2=FE_OFN290_FE_DBTN25_s22_0
XU181 AO22 $PINS O=N110 A1=N83 A2=FE_DBTN25_s22_0 B1=term2_shifted[14]
+ B2=FE_OFN290_FE_DBTN25_s22_0
XU183 AO22 $PINS O=N108 A1=N81 A2=FE_OFN315_s22_0 B1=term2_shifted[12]
+ B2=FE_OFN290_FE_DBTN25_s22_0
XU184 AO22 $PINS O=N107 A1=N80 A2=FE_OFN315_s22_0 B1=term2_shifted[11]
+ B2=sign2[0]
XU185 AO22 $PINS O=N106 A1=N79 A2=FE_OFN315_s22_0 B1=term2_shifted[10]
+ B2=sign2[0]
XU186 AO22 $PINS O=N105 A1=N78 A2=FE_OFN315_s22_0 B1=term2_shifted[9]
+ B2=sign2[0]
XU187 AO22 $PINS O=N104 A1=N77 A2=FE_OFN315_s22_0 B1=term2_shifted[8]
+ B2=sign2[0]
XU188 AO22 $PINS O=N103 A1=N76 A2=FE_OFN315_s22_0 B1=term2_shifted[7]
+ B2=sign2[0]
XU189 AO22 $PINS O=N102 A1=N75 A2=FE_OFN315_s22_0 B1=term2_shifted[6]
+ B2=sign2[0]
XU190 AO22 $PINS O=N101 A1=N74 A2=FE_OFN315_s22_0 B1=term2_shifted[5]
+ B2=sign2[0]
XU191 AO22 $PINS O=N100 A1=N73 A2=FE_OFN315_s22_0 B1=term2_shifted[4]
+ B2=sign2[0]
Xsll_18/M1_0_4 MUX2 $PINS O=sll_18/ML_int[1][4] S=FE_OFN53_h23_0 A=term3_in[4]
+ B=term3_in[3]
Xsll_18/M1_0_5 MUX2 $PINS O=sll_18/ML_int[1][5] S=FE_OFN53_h23_0 A=term3_in[5]
+ B=term3_in[4]
Xsll_18/M1_0_6 MUX2 $PINS O=sll_18/ML_int[1][6] S=FE_OFN53_h23_0 A=term3_in[6]
+ B=term3_in[5]
Xsll_18/M1_1_2 MUX2 $PINS O=sll_18/ML_int[2][2] S=FE_OFN49_h23_1
+ A=sll_18/ML_int[1][2] B=sll_18/ML_int[1][0]
Xsll_18/M1_1_3 MUX2 $PINS O=sll_18/ML_int[2][3] S=FE_OFN49_h23_1
+ A=sll_18/ML_int[1][3] B=sll_18/ML_int[1][1]
Xsll_18/M1_1_4 MUX2 $PINS O=sll_18/ML_int[2][4] S=FE_OFN49_h23_1
+ A=sll_18/ML_int[1][4] B=sll_18/ML_int[1][2]
Xsll_18/M1_1_5 MUX2 $PINS O=sll_18/ML_int[2][5] S=FE_OFN49_h23_1
+ A=sll_18/ML_int[1][5] B=sll_18/ML_int[1][3]
Xsll_18/M1_1_6 MUX2 $PINS O=sll_18/ML_int[2][6] S=FE_OFN49_h23_1
+ A=sll_18/ML_int[1][6] B=sll_18/ML_int[1][4]
Xsll_18/M1_1_7 MUX2 $PINS O=sll_18/ML_int[2][7] S=FE_OFN49_h23_1
+ A=sll_18/ML_int[1][7] B=sll_18/ML_int[1][5]
Xsll_18/M1_2_5 MUX2 $PINS O=sll_18/ML_int[3][5] S=FE_OFN330_h23_2
+ A=sll_18/ML_int[2][5] B=n81
Xsll_18/M1_2_7 MUX2 $PINS O=sll_18/ML_int[3][7] S=FE_OFN330_h23_2
+ A=sll_18/ML_int[2][7] B=sll_18/ML_int[2][3]
Xsll_18/M1_2_8 MUX2 $PINS O=sll_18/ML_int[3][8] S=FE_OFN330_h23_2
+ A=sll_18/ML_int[2][8] B=sll_18/ML_int[2][4]
Xsll_18/M1_2_9 MUX2 $PINS O=sll_18/ML_int[3][9] S=FE_OFN330_h23_2
+ A=sll_18/ML_int[2][9] B=sll_18/ML_int[2][5]
Xsll_18/M1_3_8 MUX2 $PINS O=term3_shifted[8] S=FE_OFN42_h23_3
+ A=sll_18/ML_int[3][8] B=sll_18/ML_int[3][0]
Xsll_18/M1_3_9 MUX2 $PINS O=term3_shifted[9] S=FE_OFN42_h23_3
+ A=sll_18/ML_int[3][9] B=sll_18/ML_int[3][1]
Xsll_18/M1_3_10 MUX2 $PINS O=term3_shifted[10] S=FE_OFN42_h23_3
+ A=sll_18/ML_int[3][10] B=sll_18/ML_int[3][2]
Xsll_18/M1_3_11 MUX2 $PINS O=term3_shifted[11] S=FE_OFN42_h23_3
+ A=sll_18/ML_int[3][11] B=sll_18/ML_int[3][3]
Xsll_18/M1_3_12 MUX2 $PINS O=term3_shifted[12] S=FE_OFN42_h23_3
+ A=sll_18/ML_int[3][12] B=sll_18/ML_int[3][4]
Xsll_18/M1_3_13 MUX2 $PINS O=term3_shifted[13] S=FE_OFN42_h23_3
+ A=sll_18/ML_int[3][13] B=sll_18/ML_int[3][5]
Xsll_17/M1_0_2 MUX2 $PINS O=sll_17/ML_int[1][2] S=shf2[0] A=term2_in[2]
+ B=term2_in[1]
Xsll_17/M1_0_4 MUX2 $PINS O=sll_17/ML_int[1][4] S=shf2[0] A=term2_in[4]
+ B=term2_in[3]
Xsll_17/M1_0_6 MUX2 $PINS O=sll_17/ML_int[1][6] S=shf2[0] A=term2_in[6]
+ B=term2_in[5]
Xsll_17/M1_1_2 MUX2 $PINS O=sll_17/ML_int[2][2] S=FE_OFN51_h22_1
+ A=sll_17/ML_int[1][2] B=sll_17/ML_int[1][0]
Xsll_17/M1_1_3 MUX2 $PINS O=sll_17/ML_int[2][3] S=FE_OFN51_h22_1
+ A=sll_17/ML_int[1][3] B=sll_17/ML_int[1][1]
Xsll_17/M1_1_4 MUX2 $PINS O=sll_17/ML_int[2][4] S=FE_OFN51_h22_1
+ A=sll_17/ML_int[1][4] B=sll_17/ML_int[1][2]
Xsll_17/M1_1_5 MUX2 $PINS O=sll_17/ML_int[2][5] S=FE_OFN51_h22_1
+ A=sll_17/ML_int[1][5] B=sll_17/ML_int[1][3]
Xsll_17/M1_1_6 MUX2 $PINS O=sll_17/ML_int[2][6] S=FE_OFN51_h22_1
+ A=sll_17/ML_int[1][6] B=sll_17/ML_int[1][4]
Xsll_17/M1_1_7 MUX2 $PINS O=sll_17/ML_int[2][7] S=FE_OFN51_h22_1
+ A=sll_17/ML_int[1][7] B=sll_17/ML_int[1][5]
Xsll_17/M1_2_4 MUX2 $PINS O=sll_17/ML_int[3][4] S=n37 A=sll_17/ML_int[2][4]
+ B=n6
Xsll_17/M1_2_5 MUX2 $PINS O=sll_17/ML_int[3][5] S=n37 A=sll_17/ML_int[2][5]
+ B=n70
Xsll_17/M1_2_6 MUX2 $PINS O=sll_17/ML_int[3][6] S=n37 A=sll_17/ML_int[2][6]
+ B=sll_17/ML_int[2][2]
Xsll_17/M1_2_7 MUX2 $PINS O=sll_17/ML_int[3][7] S=n37 A=sll_17/ML_int[2][7]
+ B=sll_17/ML_int[2][3]
Xsll_17/M1_2_8 MUX2 $PINS O=sll_17/ML_int[3][8] S=n37 A=sll_17/ML_int[2][8]
+ B=sll_17/ML_int[2][4]
Xsll_17/M1_2_9 MUX2 $PINS O=sll_17/ML_int[3][9] S=n37 A=sll_17/ML_int[2][9]
+ B=sll_17/ML_int[2][5]
Xsll_17/M1_3_8 MUX2 $PINS O=term2_shifted[8] S=FE_OFN312_h22_3
+ A=sll_17/ML_int[3][8] B=sll_17/ML_int[3][0]
Xsll_17/M1_3_9 MUX2 $PINS O=term2_shifted[9] S=FE_OFN312_h22_3
+ A=sll_17/ML_int[3][9] B=sll_17/ML_int[3][1]
Xsll_17/M1_3_10 MUX2 $PINS O=term2_shifted[10] S=FE_OFN312_h22_3
+ A=sll_17/ML_int[3][10] B=sll_17/ML_int[3][2]
Xsll_17/M1_3_11 MUX2 $PINS O=term2_shifted[11] S=FE_OFN312_h22_3
+ A=sll_17/ML_int[3][11] B=sll_17/ML_int[3][3]
Xsll_17/M1_3_12 MUX2 $PINS O=term2_shifted[12] S=FE_OFN312_h22_3
+ A=sll_17/ML_int[3][12] B=sll_17/ML_int[3][4]
Xsll_17/M1_3_13 MUX2 $PINS O=term2_shifted[13] S=FE_OFN312_h22_3
+ A=sll_17/ML_int[3][13] B=sll_17/ML_int[3][5]
Xsll_16/M1_0_6 MUX2 $PINS O=sll_16/ML_int[1][6] S=FE_OFN61_h21_0 A=term1_in[6]
+ B=term1_in[5]
Xsll_16/M1_1_2 MUX2 $PINS O=sll_16/ML_int[2][2] S=shf1[1] A=sll_16/ML_int[1][2]
+ B=sll_16/ML_int[1][0]
Xsll_16/M1_1_3 MUX2 $PINS O=sll_16/ML_int[2][3] S=shf1[1] A=sll_16/ML_int[1][3]
+ B=sll_16/ML_int[1][1]
Xsll_16/M1_1_4 MUX2 $PINS O=sll_16/ML_int[2][4] S=FE_OFN64_h21_1
+ A=sll_16/ML_int[1][4] B=sll_16/ML_int[1][2]
Xsll_16/M1_1_5 MUX2 $PINS O=sll_16/ML_int[2][5] S=FE_OFN64_h21_1
+ A=sll_16/ML_int[1][5] B=sll_16/ML_int[1][3]
Xsll_16/M1_1_6 MUX2 $PINS O=sll_16/ML_int[2][6] S=FE_OFN64_h21_1
+ A=sll_16/ML_int[1][6] B=sll_16/ML_int[1][4]
Xsll_16/M1_1_7 MUX2 $PINS O=sll_16/ML_int[2][7] S=FE_OFN64_h21_1
+ A=sll_16/ML_int[1][7] B=sll_16/ML_int[1][5]
Xsll_16/M1_2_4 MUX2 $PINS O=sll_16/ML_int[3][4] S=shf1[2] A=sll_16/ML_int[2][4]
+ B=n12
Xsll_16/M1_2_5 MUX2 $PINS O=sll_16/ML_int[3][5] S=shf1[2] A=sll_16/ML_int[2][5]
+ B=n60
Xsll_16/M1_2_6 MUX2 $PINS O=sll_16/ML_int[3][6] S=FE_OFN58_h21_2
+ A=sll_16/ML_int[2][6] B=sll_16/ML_int[2][2]
Xsll_16/M1_2_7 MUX2 $PINS O=sll_16/ML_int[3][7] S=FE_OFN58_h21_2
+ A=sll_16/ML_int[2][7] B=sll_16/ML_int[2][3]
Xsll_16/M1_2_8 MUX2 $PINS O=sll_16/ML_int[3][8] S=FE_OFN58_h21_2
+ A=sll_16/ML_int[2][8] B=sll_16/ML_int[2][4]
Xsll_16/M1_2_9 MUX2 $PINS O=sll_16/ML_int[3][9] S=FE_OFN58_h21_2
+ A=sll_16/ML_int[2][9] B=sll_16/ML_int[2][5]
Xsll_16/M1_3_8 MUX2 $PINS O=term1_shifted[8] S=FE_OFN44_h21_3
+ A=sll_16/ML_int[3][8] B=sll_16/ML_int[3][0]
Xsll_16/M1_3_9 MUX2 $PINS O=term1_shifted[9] S=FE_OFN44_h21_3
+ A=sll_16/ML_int[3][9] B=sll_16/ML_int[3][1]
Xsll_16/M1_3_10 MUX2 $PINS O=term1_shifted[10] S=FE_OFN44_h21_3
+ A=sll_16/ML_int[3][10] B=sll_16/ML_int[3][2]
Xsll_16/M1_3_11 MUX2 $PINS O=term1_shifted[11] S=FE_OFN44_h21_3
+ A=sll_16/ML_int[3][11] B=sll_16/ML_int[3][3]
Xsll_16/M1_3_13 MUX2 $PINS O=term1_shifted[13] S=FE_OFN44_h21_3
+ A=sll_16/ML_int[3][13] B=sll_16/ML_int[3][5]
Xy_out_reg[9] QDFFRBN $PINS Q=y_out[9] D=FE_PHN1281_N244 CK=CTS_10
+ RB=FE_OFN23_i_rst_n
Xy_out_reg[8] QDFFRBN $PINS Q=FE_PHN723_pe_i2_8 D=N243 CK=CTS_10
+ RB=FE_OFN23_i_rst_n
Xy_out_reg[7] QDFFRBN $PINS Q=y_out[7] D=N242 CK=CTS_10 RB=FE_OFN23_i_rst_n
Xy_out_reg[6] QDFFRBN $PINS Q=FE_PHN717_pe_i2_6 D=N241 CK=CTS_10
+ RB=FE_OFN23_i_rst_n
Xy_out_reg[5] QDFFRBN $PINS Q=FE_PHN719_pe_i2_5 D=FE_PHN964_N240 CK=CTS_10
+ RB=i_rst_n
Xy_out_reg[4] QDFFRBN $PINS Q=FE_PHN718_pe_i2_4 D=N239 CK=CTS_10 RB=i_rst_n
Xy_out_reg[3] QDFFRBN $PINS Q=FE_PHN721_pe_i2_3 D=FE_PHN972_N238 CK=CTS_10
+ RB=i_rst_n
Xy_out_reg[2] QDFFRBN $PINS Q=y_out[2] D=N237 CK=CTS_10 RB=i_rst_n
Xy_out_reg[1] QDFFRBN $PINS Q=y_out[1] D=FE_PHN970_N236 CK=CTS_10 RB=i_rst_n
Xy_out_reg[0] QDFFRBN $PINS Q=y_out[0] D=N235 CK=CTS_10 RB=i_rst_n
Xy_out_reg[16] QDFFRBN $PINS Q=FE_PHN1082_pe_i2_16 D=FE_PHN940_N251 CK=CTS_10
+ RB=FE_OFN23_i_rst_n
Xy_out_reg[10] QDFFRBN $PINS Q=y_out[10] D=N245 CK=CTS_10 RB=FE_OFN23_i_rst_n
Xy_out_reg[11] QDFFRBN $PINS Q=y_out[11] D=N246 CK=CTS_10 RB=FE_OFN23_i_rst_n
Xy_out_reg[12] QDFFRBN $PINS Q=FE_PHN1183_pe_i2_12 D=N247 CK=CTS_10
+ RB=FE_OFN23_i_rst_n
Xy_out_reg[14] QDFFRBN $PINS Q=FE_PHN1182_pe_i2_14 D=N249 CK=CTS_10
+ RB=FE_OFN23_i_rst_n
Xy_out_reg[15] QDFFRBN $PINS Q=y_out[15] D=N250 CK=CTS_10 RB=FE_OFN23_i_rst_n
Xy_out_reg[13] QDFFRBN $PINS Q=y_out[13] D=N248 CK=CTS_10 RB=FE_OFN23_i_rst_n
Xacc_reg_reg[25] QDFFRBN $PINS Q=acc_reg[25] D=next_acc[25] CK=clk_clone2
+ RB=FE_OFN23_i_rst_n
Xacc_reg_reg[24] QDFFRBN $PINS Q=acc_reg[24] D=next_acc[24] CK=clk_clone2
+ RB=FE_OFN23_i_rst_n
Xacc_reg_reg[23] QDFFRBN $PINS Q=acc_reg[23] D=next_acc[23] CK=clk_clone2
+ RB=FE_OFN23_i_rst_n
Xacc_reg_reg[22] QDFFRBN $PINS Q=acc_reg[22] D=next_acc[22] CK=clk_clone2
+ RB=FE_OFN23_i_rst_n
Xacc_reg_reg[21] QDFFRBN $PINS Q=acc_reg[21] D=next_acc[21] CK=clk_clone1
+ RB=FE_OFN23_i_rst_n
Xacc_reg_reg[20] QDFFRBN $PINS Q=acc_reg[20] D=next_acc[20] CK=clk_clone1
+ RB=FE_OFN23_i_rst_n
Xacc_reg_reg[19] QDFFRBN $PINS Q=acc_reg[19] D=next_acc[19] CK=clk_clone1
+ RB=FE_OFN23_i_rst_n
Xacc_reg_reg[18] QDFFRBN $PINS Q=FE_PHN1249_acc_reg_18 D=next_acc[18]
+ CK=clk_clone1 RB=i_rst_n
Xacc_reg_reg[17] QDFFRBN $PINS Q=acc_reg[17] D=next_acc[17] CK=clk_clone1
+ RB=i_rst_n
Xacc_reg_reg[16] QDFFRBN $PINS Q=acc_reg[16] D=next_acc[16] CK=clk_clone1
+ RB=i_rst_n
Xacc_reg_reg[15] QDFFRBN $PINS Q=acc_reg[15] D=next_acc[15] CK=clk_clone1
+ RB=i_rst_n
Xacc_reg_reg[14] QDFFRBN $PINS Q=acc_reg[14] D=next_acc[14] CK=clk_clone1
+ RB=i_rst_n
Xacc_reg_reg[13] QDFFRBN $PINS Q=acc_reg[13] D=next_acc[13] CK=clk_clone1
+ RB=i_rst_n
Xacc_reg_reg[12] QDFFRBN $PINS Q=acc_reg[12] D=next_acc[12] CK=clk_clone1
+ RB=i_rst_n
Xacc_reg_reg[11] QDFFRBN $PINS Q=acc_reg[11] D=next_acc[11] CK=clk_clone1
+ RB=i_rst_n
Xacc_reg_reg[10] QDFFRBN $PINS Q=acc_reg[10] D=next_acc[10] CK=clk_clone1
+ RB=i_rst_n
Xacc_reg_reg[9] QDFFRBN $PINS Q=acc_reg[9] D=next_acc[9] CK=clk_clone1
+ RB=i_rst_n
Xacc_reg_reg[8] QDFFRBN $PINS Q=acc_reg[8] D=next_acc[8] CK=clk_clone1
+ RB=i_rst_n
Xacc_reg_reg[7] QDFFRBN $PINS Q=acc_reg[7] D=next_acc[7] CK=clk_clone1
+ RB=i_rst_n
Xacc_reg_reg[6] QDFFRBN $PINS Q=acc_reg[6] D=next_acc[6] CK=clk_clone1
+ RB=i_rst_n
Xacc_reg_reg[5] QDFFRBN $PINS Q=acc_reg[5] D=next_acc[5] CK=clk_clone1
+ RB=i_rst_n
Xacc_reg_reg[4] QDFFRBN $PINS Q=acc_reg[4] D=next_acc[4] CK=clk_clone1
+ RB=i_rst_n
Xacc_reg_reg[3] QDFFRBN $PINS Q=acc_reg[3] D=next_acc[3] CK=clk_clone1
+ RB=i_rst_n
Xacc_reg_reg[2] QDFFRBN $PINS Q=acc_reg[2] D=next_acc[2] CK=clk_clone1
+ RB=i_rst_n
Xacc_reg_reg[1] QDFFRBN $PINS Q=acc_reg[1] D=next_acc[1] CK=clk_clone1
+ RB=i_rst_n
Xacc_reg_reg[0] QDFFRBS $PINS Q=acc_reg[0] D=next_acc[0] CK=clk_clone1
+ RB=i_rst_n
XU8 MUX2 $PINS O=sll_17/ML_int[1][3] S=shf2[0] A=term2_in[3] B=term2_in[2]
XU9 MUX2 $PINS O=sll_18/ML_int[1][3] S=shf3[0] A=term3_in[3] B=term3_in[2]
XU12 INV1S $PINS O=sll_17/ML_int[1][0] I=n1
XU17 MUX2 $PINS O=sll_16/ML_int[1][3] S=FE_OFN61_h21_0 A=term1_in[3]
+ B=term1_in[2]
XU23 ND2 $PINS O=n1 I1=term2_in[0] I2=n33
XU24 MUX2 $PINS O=N248 S=stage_sel A=FE_PHN1156_acc_reg_23 B=FE_PHN940_N251
XU25 MUX2 $PINS O=N250 S=stage_sel A=FE_PHN934_acc_reg_25 B=FE_PHN940_N251
XU29 MUX2S $PINS O=term1_shifted[12] S=FE_OFN184_h21_3 A=sll_16/ML_int[3][4]
+ B=sll_16/ML_int[3][12]
XU30 MUX2 $PINS O=N249 S=stage_sel A=FE_PHN935_acc_reg_24 B=FE_PHN940_N251
XU32 INV1S $PINS O=sll_16/ML_int[1][0] I=n3
XU33 ND2 $PINS O=n76 I1=sll_18/ML_int[1][1] I2=FE_OFN218_h23_1
XU35 MUX2 $PINS O=N247 S=stage_sel A=FE_PHN1177_acc_reg_22 B=FE_PHN940_N251
XU36 NR2 $PINS O=term1_in[0] I1=sign1[1] I2=x_in[0]
XU37 MUX2 $PINS O=sll_16/ML_int[1][4] S=FE_OFN61_h21_0 A=term1_in[4]
+ B=term1_in[3]
XU38 NR2 $PINS O=term2_in[0] I1=sign2[1] I2=x_in[0]
XU39 AO22 $PINS O=N96 A1=N69 A2=FE_OFN315_s22_0 B1=n17 B2=sign2[0]
XU40 INV2 $PINS O=n79 I=sll_18/ML_int[2][2]
XU42 NR2P $PINS O=term1_shifted[3] I1=n58 I2=n59
XU45 AO22 $PINS O=N43 A1=N16 A2=sign1[0] B1=term1_shifted[2] B2=n52
XU47 MOAI1 $PINS O=N98 A1=n16 A2=sign2[0] B1=term2_shifted[2] B2=sign2[0]
XU49 OR2S $PINS O=n11 I1=n58 I2=shf1[1]
XU53 NR2 $PINS O=term2_in[3] I1=FE_OFN60_s22_1 I2=x_in[3]
XU54 NR2 $PINS O=term2_in[2] I1=FE_OFN60_s22_1 I2=x_in[2]
XU57 NR2P $PINS O=term3_in[1] I1=sign3[1] I2=x_in[1]
XU59 INV2 $PINS O=n68 I=sll_17/ML_int[2][3]
XU60 NR2P $PINS O=term3_shifted[2] I1=n77 I2=n79
XU64 AO22S $PINS O=N67 A1=FE_OFN82_n A2=N40 B1=term1_shifted[26] B2=FE_OFN352_n
XU65 AO22S $PINS O=N177 A1=sign3[0] A2=N150 B1=term3_shifted[26] B2=n29
XU66 AO22S $PINS O=N114 A1=N87 A2=FE_DBTN25_s22_0 B1=term2_shifted[18]
+ B2=FE_OFN290_FE_DBTN25_s22_0
XU67 MUX2S $PINS O=sll_17/ML_int[1][5] S=shf2[0] A=term2_in[5] B=term2_in[4]
XU68 AO22 $PINS O=N156 A1=N129 A2=sign3[0] B1=term3_shifted[5] B2=n29
XU70 MUX2 $PINS O=sll_16/ML_int[1][5] S=FE_OFN61_h21_0 A=term1_in[5]
+ B=term1_in[4]
XU71 NR2 $PINS O=term2_in[1] I1=sign2[1] I2=x_in[1]
XU73 NR2 $PINS O=term3_in[0] I1=sign3[1] I2=x_in[0]
XU75 MUX2 $PINS O=sll_17/ML_int[1][1] S=shf2[0] A=term2_in[1] B=term2_in[0]
XU77 ND2 $PINS O=n57 I1=sll_16/ML_int[1][1] I2=n45
XU79 OR2 $PINS O=n8 I1=n77 I2=shf3[1]
XU82 AN2 $PINS O=sll_18/ML_int[1][0] I1=term3_in[0] I2=n21
XU84 MUX2 $PINS O=sll_16/ML_int[1][1] S=n44 A=term1_in[0] B=term1_in[1]
XU85 MUX2 $PINS O=sll_18/ML_int[1][1] S=shf3[0] A=term3_in[1] B=term3_in[0]
XU86 INV1S $PINS O=n7 I=sll_18/ML_int[1][0]
XU89 OR2 $PINS O=n15 I1=n67 I2=shf2[1]
XU90 INV1S $PINS O=n56 I=n12
XU95 OR2 $PINS O=n5 I1=n67 I2=FE_OFN51_h22_1
XU98 INV1S $PINS O=n16 I=N71
XU100 MUX2 $PINS O=sll_16/ML_int[1][2] S=shf1[0] A=term1_in[2] B=term1_in[1]
XU101 NR2 $PINS O=n12 I1=n3 I2=shf1[1]
XU102 MUX2S $PINS O=sll_18/ML_int[3][6] S=FE_OFN330_h23_2 A=sll_18/ML_int[2][6]
+ B=sll_18/ML_int[2][2]
XU103 MXL2HS $PINS OB=n13 S=shf1[1] A=sll_16/ML_int[1][2] B=sll_16/ML_int[1][0]
XU104 AO22S $PINS O=N115 A1=N88 A2=FE_DBTN25_s22_0 B1=term2_shifted[19]
+ B2=FE_OFN290_FE_DBTN25_s22_0
XU105 AO22 $PINS O=N116 A1=N89 A2=FE_DBTN25_s22_0 B1=term2_shifted[20]
+ B2=FE_OFN290_FE_DBTN25_s22_0
XU106 MUX2 $PINS O=sll_18/ML_int[1][2] S=shf3[0] A=term3_in[2] B=term3_in[1]
XU107 OR2S $PINS O=n66 I1=n14 I2=FE_OFN51_h22_1
XU108 NR2P $PINS O=term1_shifted[0] I1=n11 I2=n3
XU109 AO22 $PINS O=N157 A1=N130 A2=sign3[0] B1=term3_shifted[6] B2=n29
XU111 AO22S $PINS O=N113 A1=N86 A2=FE_DBTN25_s22_0 B1=term2_shifted[17]
+ B2=FE_OFN290_FE_DBTN25_s22_0
XU112 AO22S $PINS O=N119 A1=N92 A2=FE_DBTN25_s22_0 B1=term2_shifted[23]
+ B2=FE_OFN290_FE_DBTN25_s22_0
XU114 MUX2S $PINS O=sll_16/ML_int[1][8] S=FE_OFN61_h21_0 A=term1_in[8]
+ B=term1_in[7]
XU115 MUX2S $PINS O=sll_18/ML_int[1][8] S=FE_OFN53_h23_0 A=term3_in[8]
+ B=term3_in[7]
XU135 MUX2S $PINS O=sll_17/ML_int[1][8] S=shf2[0] A=term2_in[8] B=term2_in[7]
XU140 INV1S $PINS O=n70 I=n66
XU141 AN2 $PINS O=base_val[0] I1=acc_reg[0] I2=FE_OFN78_n
XU142 MUX2S $PINS O=sll_16/ML_int[1][7] S=FE_OFN61_h21_0 A=term1_in[7]
+ B=term1_in[6]
XU158 MUX2S $PINS O=sll_18/ML_int[1][7] S=FE_OFN53_h23_0 A=term3_in[7]
+ B=term3_in[6]
XU162 MUX2S $PINS O=sll_17/ML_int[1][7] S=shf2[0] A=term2_in[7] B=term2_in[6]
XU163 MUX2S $PINS O=sll_18/ML_int[2][8] S=FE_OFN49_h23_1 A=sll_18/ML_int[1][8]
+ B=sll_18/ML_int[1][6]
XU164 MUX2S $PINS O=sll_16/ML_int[2][8] S=FE_OFN64_h21_1 A=sll_16/ML_int[1][8]
+ B=sll_16/ML_int[1][6]
XU166 MUX2S $PINS O=sll_17/ML_int[2][8] S=FE_OFN51_h22_1 A=sll_17/ML_int[1][8]
+ B=sll_17/ML_int[1][6]
XU167 MUX2S $PINS O=sll_16/ML_int[2][9] S=FE_OFN64_h21_1 A=sll_16/ML_int[1][9]
+ B=sll_16/ML_int[1][7]
XU168 MUX2S $PINS O=sll_16/ML_int[1][9] S=FE_OFN61_h21_0 A=term1_in[9]
+ B=term1_in[8]
XU172 MUX2S $PINS O=sll_18/ML_int[2][9] S=FE_OFN49_h23_1 A=sll_18/ML_int[1][9]
+ B=sll_18/ML_int[1][7]
XU175 MUX2S $PINS O=sll_18/ML_int[1][9] S=FE_OFN53_h23_0 A=term3_in[9]
+ B=term3_in[8]
XU176 MUX2S $PINS O=sll_17/ML_int[2][9] S=FE_OFN51_h22_1 A=sll_17/ML_int[1][9]
+ B=sll_17/ML_int[1][7]
XU177 MUX2S $PINS O=sll_17/ML_int[1][9] S=shf2[0] A=term2_in[9] B=term2_in[8]
XU178 MUX2S $PINS O=sll_16/ML_int[3][10] S=FE_OFN58_h21_2
+ A=sll_16/ML_int[2][10] B=sll_16/ML_int[2][6]
XU182 MUX2S $PINS O=sll_16/ML_int[2][10] S=FE_OFN64_h21_1
+ A=sll_16/ML_int[1][10] B=sll_16/ML_int[1][8]
XU192 MUX2S $PINS O=sll_16/ML_int[1][10] S=FE_OFN61_h21_0 A=term1_in[10]
+ B=term1_in[9]
XU193 MUX2S $PINS O=sll_18/ML_int[3][10] S=FE_OFN330_h23_2
+ A=sll_18/ML_int[2][10] B=sll_18/ML_int[2][6]
XU194 MUX2S $PINS O=sll_18/ML_int[2][10] S=FE_OFN49_h23_1
+ A=sll_18/ML_int[1][10] B=sll_18/ML_int[1][8]
XU195 MUX2S $PINS O=sll_18/ML_int[1][10] S=FE_OFN53_h23_0 A=term3_in[10]
+ B=term3_in[9]
XU196 MUX2S $PINS O=sll_17/ML_int[3][10] S=n37 A=sll_17/ML_int[2][10]
+ B=sll_17/ML_int[2][6]
XU197 MUX2S $PINS O=sll_17/ML_int[2][10] S=FE_OFN51_h22_1
+ A=sll_17/ML_int[1][10] B=sll_17/ML_int[1][8]
XU198 MUX2S $PINS O=sll_17/ML_int[1][10] S=shf2[0] A=term2_in[10] B=term2_in[9]
XU199 MUX2S $PINS O=sll_16/ML_int[3][11] S=FE_OFN58_h21_2
+ A=sll_16/ML_int[2][11] B=sll_16/ML_int[2][7]
XU200 MUX2S $PINS O=sll_16/ML_int[2][11] S=FE_OFN64_h21_1
+ A=sll_16/ML_int[1][11] B=sll_16/ML_int[1][9]
XU201 MUX2S $PINS O=sll_16/ML_int[1][11] S=FE_OFN61_h21_0 A=term1_in[11]
+ B=term1_in[10]
XU202 MUX2S $PINS O=sll_18/ML_int[3][11] S=FE_OFN330_h23_2
+ A=sll_18/ML_int[2][11] B=sll_18/ML_int[2][7]
XU203 MUX2S $PINS O=sll_18/ML_int[2][11] S=FE_OFN49_h23_1
+ A=sll_18/ML_int[1][11] B=sll_18/ML_int[1][9]
XU204 MUX2S $PINS O=sll_18/ML_int[1][11] S=FE_OFN53_h23_0 A=term3_in[11]
+ B=term3_in[10]
XU205 MUX2S $PINS O=sll_17/ML_int[3][11] S=n37 A=sll_17/ML_int[2][11]
+ B=sll_17/ML_int[2][7]
XU206 MUX2S $PINS O=sll_17/ML_int[2][11] S=FE_OFN51_h22_1
+ A=sll_17/ML_int[1][11] B=sll_17/ML_int[1][9]
XU207 MUX2S $PINS O=sll_17/ML_int[1][11] S=shf2[0] A=term2_in[11]
+ B=term2_in[10]
XU208 MUX2S $PINS O=sll_16/ML_int[3][12] S=FE_OFN58_h21_2
+ A=sll_16/ML_int[2][12] B=sll_16/ML_int[2][8]
XU209 MUX2S $PINS O=sll_16/ML_int[2][12] S=FE_OFN64_h21_1
+ A=sll_16/ML_int[1][12] B=sll_16/ML_int[1][10]
XU210 MUX2S $PINS O=sll_16/ML_int[1][12] S=FE_OFN61_h21_0 A=term1_in[12]
+ B=term1_in[11]
XU211 MUX2S $PINS O=sll_18/ML_int[3][12] S=FE_OFN330_h23_2
+ A=sll_18/ML_int[2][12] B=sll_18/ML_int[2][8]
XU212 MUX2S $PINS O=sll_18/ML_int[2][12] S=FE_OFN49_h23_1
+ A=sll_18/ML_int[1][12] B=sll_18/ML_int[1][10]
XU213 MUX2S $PINS O=sll_18/ML_int[1][12] S=FE_OFN53_h23_0 A=term3_in[12]
+ B=term3_in[11]
XU214 MUX2S $PINS O=sll_17/ML_int[3][12] S=n37 A=sll_17/ML_int[2][12]
+ B=sll_17/ML_int[2][8]
XU215 MUX2S $PINS O=sll_17/ML_int[2][12] S=FE_OFN51_h22_1
+ A=sll_17/ML_int[1][12] B=sll_17/ML_int[1][10]
XU216 MUX2S $PINS O=sll_17/ML_int[1][12] S=shf2[0] A=term2_in[12]
+ B=term2_in[11]
XU217 MUX2S $PINS O=sll_16/ML_int[3][13] S=FE_OFN58_h21_2
+ A=sll_16/ML_int[2][13] B=sll_16/ML_int[2][9]
XU218 MUX2S $PINS O=sll_16/ML_int[2][13] S=FE_OFN64_h21_1
+ A=sll_16/ML_int[1][13] B=sll_16/ML_int[1][11]
XU219 MUX2S $PINS O=sll_16/ML_int[1][13] S=FE_OFN61_h21_0 A=term1_in[13]
+ B=term1_in[12]
XU220 MUX2S $PINS O=sll_18/ML_int[3][13] S=FE_OFN330_h23_2
+ A=sll_18/ML_int[2][13] B=sll_18/ML_int[2][9]
XU221 MUX2S $PINS O=sll_18/ML_int[2][13] S=FE_OFN49_h23_1
+ A=sll_18/ML_int[1][13] B=sll_18/ML_int[1][11]
XU222 MUX2S $PINS O=sll_18/ML_int[1][13] S=FE_OFN53_h23_0 A=term3_in[13]
+ B=term3_in[12]
XU223 MUX2S $PINS O=sll_17/ML_int[3][13] S=n37 A=sll_17/ML_int[2][13]
+ B=sll_17/ML_int[2][9]
XU224 MUX2S $PINS O=sll_17/ML_int[2][13] S=FE_OFN51_h22_1
+ A=sll_17/ML_int[1][13] B=sll_17/ML_int[1][11]
XU225 MUX2S $PINS O=sll_17/ML_int[1][13] S=shf2[0] A=term2_in[13]
+ B=term2_in[12]
XU226 MUX2S $PINS O=term1_shifted[14] S=FE_OFN44_h21_3 A=sll_16/ML_int[3][14]
+ B=sll_16/ML_int[3][6]
XU227 MUX2S $PINS O=sll_16/ML_int[3][14] S=FE_OFN58_h21_2
+ A=sll_16/ML_int[2][14] B=sll_16/ML_int[2][10]
XU228 MUX2S $PINS O=sll_16/ML_int[2][14] S=FE_OFN64_h21_1
+ A=sll_16/ML_int[1][14] B=sll_16/ML_int[1][12]
XU229 MUX2S $PINS O=sll_16/ML_int[1][14] S=FE_OFN61_h21_0 A=term1_in[14]
+ B=term1_in[13]
XU230 MUX2S $PINS O=term3_shifted[14] S=FE_OFN42_h23_3 A=sll_18/ML_int[3][14]
+ B=sll_18/ML_int[3][6]
XU231 MUX2S $PINS O=sll_18/ML_int[3][14] S=FE_OFN330_h23_2
+ A=sll_18/ML_int[2][14] B=sll_18/ML_int[2][10]
XU232 MUX2S $PINS O=sll_18/ML_int[2][14] S=FE_OFN49_h23_1
+ A=sll_18/ML_int[1][14] B=sll_18/ML_int[1][12]
XU233 MUX2S $PINS O=sll_18/ML_int[1][14] S=FE_OFN53_h23_0 A=term3_in[14]
+ B=term3_in[13]
XU234 MUX2S $PINS O=term2_shifted[14] S=FE_OFN312_h22_3 A=sll_17/ML_int[3][14]
+ B=sll_17/ML_int[3][6]
XU235 MUX2S $PINS O=sll_17/ML_int[3][14] S=n37 A=sll_17/ML_int[2][14]
+ B=sll_17/ML_int[2][10]
XU236 MUX2S $PINS O=sll_17/ML_int[2][14] S=FE_OFN51_h22_1
+ A=sll_17/ML_int[1][14] B=sll_17/ML_int[1][12]
XU237 MUX2S $PINS O=sll_17/ML_int[1][14] S=shf2[0] A=term2_in[14]
+ B=term2_in[13]
XU238 MUX2S $PINS O=term1_shifted[16] S=FE_OFN44_h21_3 A=sll_16/ML_int[3][16]
+ B=sll_16/ML_int[3][8]
XU239 MUX2S $PINS O=sll_16/ML_int[3][16] S=FE_OFN58_h21_2 A=n61
+ B=sll_16/ML_int[2][12]
XU240 MUX2S $PINS O=n61 S=FE_OFN64_h21_1 A=n64 B=sll_16/ML_int[1][14]
XU241 MUX2S $PINS O=term3_shifted[16] S=FE_OFN42_h23_3 A=sll_18/ML_int[3][16]
+ B=sll_18/ML_int[3][8]
XU242 MUX2S $PINS O=sll_18/ML_int[3][16] S=FE_OFN330_h23_2 A=n82
+ B=sll_18/ML_int[2][12]
XU243 MUX2S $PINS O=n82 S=FE_OFN49_h23_1 A=n85 B=sll_18/ML_int[1][14]
XU244 MUX2S $PINS O=n71 S=FE_OFN51_h22_1 A=n74 B=sll_17/ML_int[1][14]
XU245 MUX2S $PINS O=term2_shifted[16] S=n39 A=sll_17/ML_int[3][16]
+ B=sll_17/ML_int[3][8]
XU246 MUX2S $PINS O=sll_17/ML_int[3][16] S=n37 A=n71 B=sll_17/ML_int[2][12]
XU247 MUX2S $PINS O=term1_shifted[15] S=FE_OFN44_h21_3 A=sll_16/ML_int[3][15]
+ B=sll_16/ML_int[3][7]
XU248 MUX2S $PINS O=sll_16/ML_int[3][15] S=FE_OFN58_h21_2
+ A=sll_16/ML_int[2][15] B=sll_16/ML_int[2][11]
XU249 MUX2S $PINS O=sll_16/ML_int[2][15] S=FE_OFN64_h21_1
+ A=sll_16/ML_int[1][15] B=sll_16/ML_int[1][13]
XU250 MUX2S $PINS O=sll_16/ML_int[1][15] S=FE_OFN61_h21_0 A=term1_in[15]
+ B=term1_in[14]
XU251 MUX2S $PINS O=term3_shifted[15] S=FE_OFN42_h23_3 A=sll_18/ML_int[3][15]
+ B=sll_18/ML_int[3][7]
XU252 MUX2S $PINS O=sll_18/ML_int[3][15] S=FE_OFN330_h23_2
+ A=sll_18/ML_int[2][15] B=sll_18/ML_int[2][11]
XU253 MUX2S $PINS O=sll_18/ML_int[2][15] S=FE_OFN49_h23_1
+ A=sll_18/ML_int[1][15] B=sll_18/ML_int[1][13]
XU254 MUX2S $PINS O=sll_18/ML_int[1][15] S=FE_OFN53_h23_0 A=term3_in[15]
+ B=term3_in[14]
XU255 MUX2S $PINS O=term2_shifted[15] S=n39 A=sll_17/ML_int[3][15]
+ B=sll_17/ML_int[3][7]
XU256 MUX2S $PINS O=sll_17/ML_int[3][15] S=n37 A=sll_17/ML_int[2][15]
+ B=sll_17/ML_int[2][11]
XU257 MUX2S $PINS O=sll_17/ML_int[2][15] S=FE_OFN51_h22_1
+ A=sll_17/ML_int[1][15] B=sll_17/ML_int[1][13]
XU258 MUX2S $PINS O=sll_17/ML_int[1][15] S=shf2[0] A=term2_in[15]
+ B=term2_in[14]
XU259 MUX2S $PINS O=term1_shifted[17] S=FE_OFN44_h21_3 A=sll_16/ML_int[3][17]
+ B=sll_16/ML_int[3][9]
XU260 MUX2S $PINS O=n62 S=FE_OFN64_h21_1 A=term1_in[26] B=sll_16/ML_int[1][15]
XU261 MUX2S $PINS O=sll_16/ML_int[3][17] S=FE_OFN58_h21_2 A=n62
+ B=sll_16/ML_int[2][13]
XU262 MUX2S $PINS O=term3_shifted[17] S=FE_OFN42_h23_3 A=sll_18/ML_int[3][17]
+ B=sll_18/ML_int[3][9]
XU263 MUX2S $PINS O=n83 S=FE_OFN49_h23_1 A=term3_in[26] B=sll_18/ML_int[1][15]
XU264 MUX2S $PINS O=sll_18/ML_int[3][17] S=FE_OFN330_h23_2 A=n83
+ B=sll_18/ML_int[2][13]
XU265 MUX2S $PINS O=term2_shifted[17] S=n39 A=sll_17/ML_int[3][17]
+ B=sll_17/ML_int[3][9]
XU266 MUX2S $PINS O=n72 S=FE_OFN51_h22_1 A=term2_in[26] B=sll_17/ML_int[1][15]
XU267 MUX2S $PINS O=sll_17/ML_int[3][17] S=n37 A=n72 B=sll_17/ML_int[2][13]
XU268 MUX2S $PINS O=term1_shifted[18] S=FE_OFN44_h21_3 A=sll_16/ML_int[3][18]
+ B=sll_16/ML_int[3][10]
XU269 MUX2S $PINS O=sll_16/ML_int[3][18] S=FE_OFN58_h21_2 A=n63
+ B=sll_16/ML_int[2][14]
XU270 MUX2S $PINS O=n63 S=FE_OFN64_h21_1 A=term1_in[26] B=n64
XU271 MUX2S $PINS O=term3_shifted[18] S=FE_OFN42_h23_3 A=sll_18/ML_int[3][18]
+ B=sll_18/ML_int[3][10]
XU272 MUX2S $PINS O=sll_18/ML_int[3][18] S=FE_OFN330_h23_2 A=n84
+ B=sll_18/ML_int[2][14]
XU273 MUX2S $PINS O=n84 S=FE_OFN49_h23_1 A=term3_in[26] B=n85
XU274 MUX2S $PINS O=term2_shifted[18] S=n39 A=sll_17/ML_int[3][18]
+ B=sll_17/ML_int[3][10]
XU275 MUX2S $PINS O=sll_17/ML_int[3][18] S=n37 A=n73 B=sll_17/ML_int[2][14]
XU276 MUX2S $PINS O=n73 S=FE_OFN51_h22_1 A=term2_in[26] B=n74
XU277 MUX2S $PINS O=term1_shifted[20] S=FE_OFN44_h21_3 A=sll_16/ML_int[3][20]
+ B=sll_16/ML_int[3][12]
XU278 MUX2S $PINS O=sll_16/ML_int[3][20] S=FE_OFN58_h21_2 A=term1_in[26] B=n61
XU279 MUX2S $PINS O=term1_shifted[19] S=FE_OFN44_h21_3 A=sll_16/ML_int[3][19]
+ B=sll_16/ML_int[3][11]
XU280 MUX2S $PINS O=sll_16/ML_int[3][19] S=FE_OFN58_h21_2 A=term1_in[26]
+ B=sll_16/ML_int[2][15]
XU281 MUX2S $PINS O=term3_shifted[20] S=FE_OFN42_h23_3 A=sll_18/ML_int[3][20]
+ B=sll_18/ML_int[3][12]
XU282 MUX2S $PINS O=sll_18/ML_int[3][20] S=FE_OFN330_h23_2 A=term3_in[26] B=n82
XU283 MUX2S $PINS O=term3_shifted[19] S=FE_OFN42_h23_3 A=sll_18/ML_int[3][19]
+ B=sll_18/ML_int[3][11]
XU284 MUX2S $PINS O=sll_18/ML_int[3][19] S=FE_OFN330_h23_2 A=term3_in[26]
+ B=sll_18/ML_int[2][15]
XU285 MUX2S $PINS O=term2_shifted[20] S=n39 A=sll_17/ML_int[3][20]
+ B=sll_17/ML_int[3][12]
XU286 MUX2S $PINS O=sll_17/ML_int[3][20] S=n37 A=term2_in[26] B=n71
XU287 MUX2S $PINS O=term2_shifted[19] S=n39 A=sll_17/ML_int[3][19]
+ B=sll_17/ML_int[3][11]
XU288 MUX2S $PINS O=sll_17/ML_int[3][19] S=n37 A=term2_in[26]
+ B=sll_17/ML_int[2][15]
XU289 MUX2S $PINS O=term1_shifted[21] S=FE_OFN44_h21_3 A=sll_16/ML_int[3][21]
+ B=sll_16/ML_int[3][13]
XU290 MUX2S $PINS O=sll_16/ML_int[3][21] S=FE_OFN58_h21_2 A=term1_in[26] B=n62
XU291 MUX2S $PINS O=term3_shifted[21] S=FE_OFN42_h23_3 A=sll_18/ML_int[3][21]
+ B=sll_18/ML_int[3][13]
XU292 MUX2S $PINS O=sll_18/ML_int[3][21] S=FE_OFN330_h23_2 A=term3_in[26] B=n83
XU293 MUX2S $PINS O=term2_shifted[21] S=n39 A=sll_17/ML_int[3][21]
+ B=sll_17/ML_int[3][13]
XU294 MUX2S $PINS O=sll_17/ML_int[3][21] S=n37 A=term2_in[26] B=n72
XU295 MUX2S $PINS O=term1_shifted[22] S=FE_OFN44_h21_3 A=sll_16/ML_int[3][22]
+ B=sll_16/ML_int[3][14]
XU296 MUX2S $PINS O=sll_16/ML_int[3][22] S=FE_OFN58_h21_2 A=term1_in[26] B=n63
XU297 MUX2S $PINS O=term3_shifted[22] S=FE_OFN42_h23_3 A=sll_18/ML_int[3][22]
+ B=sll_18/ML_int[3][14]
XU298 MUX2S $PINS O=sll_18/ML_int[3][22] S=FE_OFN330_h23_2 A=term3_in[26] B=n84
XU299 MUX2S $PINS O=term2_shifted[22] S=n39 A=sll_17/ML_int[3][22]
+ B=sll_17/ML_int[3][14]
XU300 MUX2S $PINS O=sll_17/ML_int[3][22] S=n37 A=term2_in[26] B=n73
XU301 MUX2S $PINS O=term1_shifted[24] S=FE_OFN44_h21_3 A=term1_in[26]
+ B=sll_16/ML_int[3][16]
XU302 MUX2S $PINS O=term3_shifted[24] S=FE_OFN42_h23_3 A=term3_in[26]
+ B=sll_18/ML_int[3][16]
XU303 MUX2S $PINS O=term2_shifted[24] S=n39 A=term2_in[26]
+ B=sll_17/ML_int[3][16]
XU304 MUX2S $PINS O=term1_shifted[23] S=FE_OFN44_h21_3 A=term1_in[26]
+ B=sll_16/ML_int[3][15]
XU305 MUX2S $PINS O=term3_shifted[23] S=FE_OFN42_h23_3 A=term3_in[26]
+ B=sll_18/ML_int[3][15]
XU306 MUX2S $PINS O=term2_shifted[23] S=n39 A=term2_in[26]
+ B=sll_17/ML_int[3][15]
XU307 MUX2S $PINS O=term1_shifted[25] S=FE_OFN44_h21_3 A=term1_in[26]
+ B=sll_16/ML_int[3][17]
XU308 MUX2S $PINS O=term3_shifted[25] S=FE_OFN42_h23_3 A=term3_in[26]
+ B=sll_18/ML_int[3][17]
XU309 MUX2S $PINS O=term2_shifted[25] S=n39 A=term2_in[26]
+ B=sll_17/ML_int[3][17]
XU310 MUX2S $PINS O=term1_shifted[26] S=FE_OFN44_h21_3 A=term1_in[26]
+ B=sll_16/ML_int[3][18]
XU311 MUX2S $PINS O=term3_shifted[26] S=FE_OFN42_h23_3 A=term3_in[26]
+ B=sll_18/ML_int[3][18]
XU312 MUX2S $PINS O=term2_shifted[26] S=n39 A=term2_in[26]
+ B=sll_17/ML_int[3][18]
XU313 AO22 $PINS O=N161 A1=N134 A2=sign3[0] B1=term3_shifted[10] B2=n29
XU315 AO22 $PINS O=N109 A1=N82 A2=FE_OFN315_s22_0 B1=term2_shifted[13]
+ B2=FE_OFN290_FE_DBTN25_s22_0
XU316 MUX2S $PINS O=FE_PHN960_N235 S=stage_sel A=acc_reg[10] B=acc_reg[14]
XU317 MUX2S $PINS O=N236 S=stage_sel A=acc_reg[11] B=acc_reg[15]
XU318 MUX2S $PINS O=FE_PHN957_N237 S=stage_sel A=acc_reg[12] B=acc_reg[16]
XU319 MUX2S $PINS O=N238 S=stage_sel A=acc_reg[13] B=acc_reg[17]
XU320 MUX2S $PINS O=FE_PHN1301_N239 S=stage_sel A=acc_reg[14] B=acc_reg[18]
XU321 MUX2S $PINS O=N240 S=stage_sel A=acc_reg[15] B=acc_reg[19]
XU322 MUX2S $PINS O=FE_PHN982_N242 S=stage_sel A=acc_reg[17] B=acc_reg[21]
XU323 MUX2S $PINS O=FE_PHN1296_N245 S=stage_sel A=acc_reg[20]
+ B=FE_PHN935_acc_reg_24
XU324 MUX2S $PINS O=FE_PHN1303_N246 S=stage_sel A=acc_reg[21]
+ B=FE_PHN934_acc_reg_25
XU326 INV1S $PINS O=n60 I=n57
XU327 INV1S $PINS O=n81 I=n76
XU328 NR2 $PINS O=term1_in[4] I1=sign1[1] I2=x_in[4]
XU329 NR2 $PINS O=term3_in[4] I1=sign3[1] I2=x_in[4]
XU330 NR2 $PINS O=term1_in[5] I1=sign1[1] I2=x_in[5]
XU331 NR2 $PINS O=term3_in[5] I1=sign3[1] I2=x_in[5]
XU332 NR2 $PINS O=term2_in[5] I1=FE_OFN60_s22_1 I2=x_in[5]
XU333 NR2 $PINS O=term1_in[6] I1=sign1[1] I2=x_in[6]
XU334 NR2 $PINS O=term3_in[6] I1=sign3[1] I2=x_in[6]
XU335 NR2 $PINS O=term2_in[6] I1=FE_OFN60_s22_1 I2=x_in[6]
XU337 NR2 $PINS O=term1_in[7] I1=sign1[1] I2=x_in[7]
XU338 NR2 $PINS O=term3_in[7] I1=sign3[1] I2=x_in[7]
XU339 NR2 $PINS O=term2_in[7] I1=FE_OFN60_s22_1 I2=x_in[7]
XU340 NR2 $PINS O=term1_in[8] I1=sign1[1] I2=x_in[8]
XU341 NR2 $PINS O=term3_in[8] I1=sign3[1] I2=x_in[8]
XU342 NR2 $PINS O=term2_in[8] I1=FE_OFN60_s22_1 I2=x_in[8]
XU347 NR2 $PINS O=term1_in[9] I1=sign1[1] I2=x_in[9]
XU348 NR2 $PINS O=term3_in[9] I1=sign3[1] I2=x_in[9]
XU349 NR2 $PINS O=term1_in[10] I1=sign1[1] I2=x_in[10]
XU350 NR2 $PINS O=term3_in[10] I1=sign3[1] I2=x_in[10]
XU351 NR2 $PINS O=term2_in[9] I1=FE_OFN60_s22_1 I2=x_in[9]
XU352 NR2 $PINS O=term2_in[10] I1=FE_OFN60_s22_1 I2=x_in[10]
XU353 NR2 $PINS O=term1_in[11] I1=sign1[1] I2=x_in[11]
XU354 NR2 $PINS O=term3_in[11] I1=sign3[1] I2=x_in[11]
XU355 NR2 $PINS O=term2_in[11] I1=FE_OFN60_s22_1 I2=x_in[11]
XU356 NR2 $PINS O=term1_in[12] I1=sign1[1] I2=x_in[12]
XU357 NR2 $PINS O=term3_in[12] I1=sign3[1] I2=x_in[12]
XU358 NR2 $PINS O=term2_in[12] I1=FE_OFN60_s22_1 I2=x_in[12]
XU359 NR2 $PINS O=term1_in[13] I1=sign1[1] I2=x_in[13]
XU360 NR2 $PINS O=term3_in[13] I1=sign3[1] I2=x_in[13]
XU361 NR2 $PINS O=term2_in[13] I1=FE_OFN60_s22_1 I2=x_in[13]
XU362 NR2 $PINS O=term1_in[14] I1=sign1[1] I2=n90
XU364 NR2 $PINS O=term3_in[14] I1=sign3[1] I2=n90
XU366 NR2 $PINS O=term2_in[14] I1=FE_OFN60_s22_1 I2=n90
XU368 NR2 $PINS O=term1_in[15] I1=sign1[1] I2=n91
XU369 NR2 $PINS O=term3_in[15] I1=sign3[1] I2=n91
XU370 NR2 $PINS O=term1_in[26] I1=n92 I2=sign1[1]
XU371 NR2 $PINS O=term2_in[15] I1=FE_OFN60_s22_1 I2=n91
XU372 NR2 $PINS O=term3_in[26] I1=n92 I2=sign3[1]
XU373 NR2 $PINS O=term2_in[26] I1=n92 I2=FE_OFN60_s22_1
XU381 INV1S $PINS O=n44 I=shf1[0]
XU385 INV1S $PINS O=n45 I=shf1[1]
XU400 INV1S $PINS O=n90 I=x_in[14]
XU401 INV1S $PINS O=n91 I=x_in[15]
XU402 INV1S $PINS O=n92 I=x_in[16]
XU403 AN2P $PINS O=base_val[26] I1=N251 I2=FE_OFN302_n103
XU404 AN2 $PINS O=base_val[1] I1=acc_reg[1] I2=FE_OFN78_n
XU405 MOAI1S $PINS O=base_val[9] A1=stage_sel A2=FE_OFN78_n B1=acc_reg[9]
+ B2=FE_OFN78_n
XU406 AN2 $PINS O=base_val[10] I1=acc_reg[10] I2=FE_OFN78_n
XU407 AN2 $PINS O=base_val[11] I1=acc_reg[11] I2=FE_OFN78_n
XU408 AN2 $PINS O=base_val[7] I1=acc_reg[7] I2=FE_OFN78_n
XU409 AN2 $PINS O=base_val[6] I1=acc_reg[6] I2=FE_OFN78_n
XU410 AN2 $PINS O=base_val[8] I1=acc_reg[8] I2=FE_OFN78_n
XU411 AN2 $PINS O=base_val[5] I1=acc_reg[5] I2=FE_OFN78_n
XU412 AN2 $PINS O=base_val[4] I1=acc_reg[4] I2=FE_OFN78_n
XU413 AN2 $PINS O=base_val[3] I1=acc_reg[3] I2=FE_OFN78_n
XU414 AN2 $PINS O=base_val[2] I1=acc_reg[2] I2=FE_OFN78_n
XU415 AN2 $PINS O=base_val[12] I1=acc_reg[12] I2=FE_OFN78_n
XU416 AN2 $PINS O=base_val[14] I1=acc_reg[14] I2=FE_OFN302_n103
XU417 AN2 $PINS O=base_val[15] I1=acc_reg[15] I2=FE_OFN302_n103
XU418 AN2 $PINS O=base_val[16] I1=acc_reg[16] I2=FE_OFN302_n103
XU419 AN2 $PINS O=base_val[17] I1=acc_reg[17] I2=FE_OFN302_n103
XU420 AN2 $PINS O=base_val[18] I1=acc_reg[18] I2=FE_OFN302_n103
XU421 AN2 $PINS O=base_val[19] I1=acc_reg[19] I2=FE_OFN302_n103
XU422 AN2 $PINS O=base_val[20] I1=acc_reg[20] I2=FE_OFN302_n103
XU423 AN2 $PINS O=base_val[21] I1=acc_reg[21] I2=FE_OFN302_n103
XU424 AN2 $PINS O=base_val[22] I1=FE_PHN1177_acc_reg_22 I2=FE_OFN302_n103
XU425 AN2 $PINS O=base_val[23] I1=FE_PHN1156_acc_reg_23 I2=FE_OFN302_n103
XU426 AN2 $PINS O=base_val[24] I1=acc_reg[24] I2=FE_OFN302_n103
XU427 AN2 $PINS O=base_val[25] I1=acc_reg[25] I2=FE_OFN302_n103
XU429 AN2 $PINS O=N234 I1=en I2=calc_done
XU431 NR2 $PINS O=sll_16/ML_int[3][0] I1=shf1[2] I2=n56
XU432 NR2 $PINS O=sll_16/ML_int[3][1] I1=shf1[2] I2=n57
XU433 NR2 $PINS O=sll_16/ML_int[3][2] I1=shf1[2] I2=n13
XU434 NR2 $PINS O=sll_16/ML_int[3][3] I1=shf1[2] I2=n59
XU435 AN2 $PINS O=term1_shifted[4] I1=sll_16/ML_int[3][4] I2=FE_OFN184_h21_3
XU436 AN2 $PINS O=term1_shifted[5] I1=sll_16/ML_int[3][5] I2=FE_OFN184_h21_3
XU437 AN2 $PINS O=term1_shifted[6] I1=sll_16/ML_int[3][6] I2=FE_OFN184_h21_3
XU438 AN2 $PINS O=term1_shifted[7] I1=sll_16/ML_int[3][7] I2=FE_OFN184_h21_3
XU439 MUX2 $PINS O=n64 S=FE_OFN61_h21_0 A=term1_in[26] B=term1_in[15]
XU440 NR2 $PINS O=sll_17/ML_int[3][0] I1=n37 I2=n65
XU441 NR2 $PINS O=sll_17/ML_int[3][1] I1=n37 I2=n66
XU442 NR2 $PINS O=sll_17/ML_int[3][2] I1=n37 I2=n69
XU443 NR2 $PINS O=sll_17/ML_int[3][3] I1=n37 I2=n68
XU444 ND2 $PINS O=n67 I1=FE_OFN48_h22_2 I2=shf2[3]
XU445 AN2 $PINS O=term2_shifted[4] I1=sll_17/ML_int[3][4] I2=shf2[3]
XU446 AN2 $PINS O=term2_shifted[5] I1=sll_17/ML_int[3][5] I2=shf2[3]
XU447 AN2 $PINS O=term2_shifted[6] I1=sll_17/ML_int[3][6] I2=shf2[3]
XU448 AN2 $PINS O=term2_shifted[7] I1=sll_17/ML_int[3][7] I2=shf2[3]
XU449 MUX2 $PINS O=n74 S=shf2[0] A=term2_in[26] B=term2_in[15]
XU450 NR2 $PINS O=sll_18/ML_int[3][0] I1=FE_OFN330_h23_2 I2=n75
XU451 NR2 $PINS O=sll_18/ML_int[3][1] I1=FE_OFN330_h23_2 I2=n76
XU452 NR2 $PINS O=sll_18/ML_int[3][2] I1=FE_OFN330_h23_2 I2=n79
XU453 NR2 $PINS O=sll_18/ML_int[3][3] I1=FE_OFN330_h23_2 I2=n78
XU454 ND2 $PINS O=n77 I1=FE_OFN47_h23_2 I2=n26
XU455 NR2P $PINS O=term3_shifted[3] I1=n77 I2=n78
XU457 AN2 $PINS O=term3_shifted[5] I1=sll_18/ML_int[3][5] I2=n26
XU458 AN2 $PINS O=term3_shifted[6] I1=sll_18/ML_int[3][6] I2=n26
XU459 AN2 $PINS O=term3_shifted[7] I1=sll_18/ML_int[3][7] I2=n26
XU460 MUX2 $PINS O=n85 S=FE_OFN53_h23_0 A=term3_in[26] B=term3_in[15]
XU461 MUX2 $PINS O=FE_PHN950_N241 S=stage_sel A=acc_reg[16] B=acc_reg[20]
XU462 MUX2 $PINS O=N243 S=stage_sel A=acc_reg[18] B=FE_PHN1177_acc_reg_22
XU463 MUX2 $PINS O=N244 S=stage_sel A=acc_reg[19] B=FE_PHN1156_acc_reg_23
Xacc_reg_reg[26] QDFFRBP $PINS Q=N251 D=next_acc[26] CK=clk_clone2
+ RB=FE_OFN23_i_rst_n
XU5 ND2 $PINS O=n3 I1=n44 I2=term1_in[0]
XU7 NR2P $PINS O=term1_shifted[2] I1=n58 I2=n13
XU10 INV1S $PINS O=n14 I=sll_17/ML_int[1][1]
XU11 NR2 $PINS O=term1_in[3] I1=sign1[1] I2=x_in[3]
XU13 NR2 $PINS O=term3_in[3] I1=sign3[1] I2=x_in[3]
XU15 AO22 $PINS O=N97 A1=N70 A2=FE_OFN315_s22_0 B1=term2_shifted[1] B2=sign2[0]
XU16 NR2P $PINS O=term3_shifted[0] I1=n8 I2=n7
XU20 OR2 $PINS O=n58 I1=shf1[2] I2=shf1[3]
XU21 OR2 $PINS O=n75 I1=n7 I2=FE_OFN49_h23_1
XU22 INV1S $PINS O=n69 I=sll_17/ML_int[2][2]
XU27 NR2 $PINS O=n104 I1=n77 I2=FE_OFN49_h23_1
XU31 AO22 $PINS O=N99 A1=N72 A2=FE_OFN315_s22_0 B1=term2_shifted[3] B2=sign2[0]
XU34 INV1S $PINS O=n65 I=n6
XU43 AO22 $PINS O=N47 A1=N20 A2=sign1[0] B1=term1_shifted[6] B2=n52
XU48 NR2 $PINS O=term2_shifted[0] I1=n1 I2=n5
XU56 NR2 $PINS O=term2_in[4] I1=FE_OFN60_s22_1 I2=x_in[4]
XU61 NR2 $PINS O=term3_in[2] I1=sign3[1] I2=x_in[2]
XU78 NR2 $PINS O=term1_in[2] I1=sign1[1] I2=x_in[2]
XU92 NR2 $PINS O=term1_in[1] I1=sign1[1] I2=x_in[1]
XU96 NR2 $PINS O=n6 I1=FE_OFN51_h22_1 I2=n1
Xclk_gate_y_out_reg SNPS_CLOCK_GATE_HIGH_PE_Shift_Add_2 $PINS EN=N234
+ ENCLK=CTS_12 CLK=clk
Xsub_28_3 PE_Shift_Add_2_DW01_sub_0_DW01_sub_6 $PINS A[26]=net45500
+ A[25]=net45500 A[24]=net45500 A[23]=net45500 A[22]=net45500 A[21]=net45500
+ A[20]=net45500 A[19]=net45500 A[18]=net45500 A[17]=net45500 A[16]=net45500
+ A[15]=net45500 A[14]=net45500 A[13]=net45500 A[12]=net45500 A[11]=net45500
+ A[10]=net45500 A[9]=net45500 A[8]=net45500 A[7]=net45500 A[6]=net45500
+ A[5]=net45500 A[4]=net45500 A[3]=net45500 A[2]=net45500 A[1]=net45500
+ A[0]=net45500 B[26]=term3_shifted[26] B[25]=term3_shifted[25]
+ B[24]=term3_shifted[24] B[23]=term3_shifted[23] B[22]=term3_shifted[22]
+ B[21]=term3_shifted[21] B[20]=term3_shifted[20] B[19]=term3_shifted[19]
+ B[18]=term3_shifted[18] B[17]=term3_shifted[17] B[16]=term3_shifted[16]
+ B[15]=term3_shifted[15] B[14]=term3_shifted[14] B[13]=term3_shifted[13]
+ B[12]=term3_shifted[12] B[11]=term3_shifted[11] B[10]=term3_shifted[10]
+ B[9]=term3_shifted[9] B[8]=term3_shifted[8] B[7]=term3_shifted[7]
+ B[6]=term3_shifted[6] B[5]=term3_shifted[5] B[4]=term3_shifted[4]
+ B[3]=term3_shifted[3] B[2]=term3_shifted[2] B[1]=term3_shifted[1]
+ B[0]=term3_shifted[0] CI=net45500 DIFF[26]=N150 DIFF[25]=N149 DIFF[24]=N148
+ DIFF[23]=N147 DIFF[22]=N146 DIFF[21]=N145 DIFF[20]=N144 DIFF[19]=N143
+ DIFF[18]=N142 DIFF[17]=N141 DIFF[16]=N140 DIFF[15]=N139 DIFF[14]=N138
+ DIFF[13]=N137 DIFF[12]=N136 DIFF[11]=N135 DIFF[10]=N134 DIFF[9]=N133
+ DIFF[8]=N132 DIFF[7]=N131 DIFF[6]=N130 DIFF[5]=N129 DIFF[4]=N128 DIFF[3]=N127
+ DIFF[2]=N126 DIFF[1]=N125 DIFF[0]=N124
Xsub_28_2 PE_Shift_Add_2_DW01_sub_1_DW01_sub_7 $PINS A[26]=net45500
+ A[25]=net45500 A[24]=net45500 A[23]=net45500 A[22]=net45500 A[21]=net45500
+ A[20]=net45500 A[19]=net45500 A[18]=net45500 A[17]=net45500 A[16]=net45500
+ A[15]=net45500 A[14]=net45500 A[13]=net45500 A[12]=net45500 A[11]=net45500
+ A[10]=net45500 A[9]=net45500 A[8]=net45500 A[7]=net45500 A[6]=net45500
+ A[5]=net45500 A[4]=net45500 A[3]=net45500 A[2]=net45500 A[1]=net45500
+ A[0]=net45500 B[26]=term2_shifted[26] B[25]=term2_shifted[25]
+ B[24]=term2_shifted[24] B[23]=term2_shifted[23] B[22]=term2_shifted[22]
+ B[21]=term2_shifted[21] B[20]=term2_shifted[20] B[19]=term2_shifted[19]
+ B[18]=term2_shifted[18] B[17]=term2_shifted[17] B[16]=term2_shifted[16]
+ B[15]=term2_shifted[15] B[14]=term2_shifted[14] B[13]=term2_shifted[13]
+ B[12]=term2_shifted[12] B[11]=term2_shifted[11] B[10]=term2_shifted[10]
+ B[9]=term2_shifted[9] B[8]=term2_shifted[8] B[7]=term2_shifted[7]
+ B[6]=term2_shifted[6] B[5]=term2_shifted[5] B[4]=term2_shifted[4]
+ B[3]=term2_shifted[3] B[2]=term2_shifted[2] B[1]=term2_shifted[1]
+ B[0]=term2_shifted[0] CI=net45500 DIFF[26]=N95 DIFF[25]=N94 DIFF[24]=N93
+ DIFF[23]=N92 DIFF[22]=N91 DIFF[21]=N90 DIFF[20]=N89 DIFF[19]=N88 DIFF[18]=N87
+ DIFF[17]=N86 DIFF[16]=N85 DIFF[15]=N84 DIFF[14]=N83 DIFF[13]=N82 DIFF[12]=N81
+ DIFF[11]=N80 DIFF[10]=N79 DIFF[9]=N78 DIFF[8]=N77 DIFF[7]=N76 DIFF[6]=N75
+ DIFF[5]=N74 DIFF[4]=N73 DIFF[3]=N72 DIFF[2]=N71 DIFF[1]=N70 DIFF[0]=N69
Xsub_28 PE_Shift_Add_2_DW01_sub_2_DW01_sub_8 $PINS A[26]=net45500
+ A[25]=net45500 A[24]=net45500 A[23]=net45500 A[22]=net45500 A[21]=net45500
+ A[20]=net45500 A[19]=net45500 A[18]=net45500 A[17]=net45500 A[16]=net45500
+ A[15]=net45500 A[14]=net45500 A[13]=net45500 A[12]=net45500 A[11]=net45500
+ A[10]=net45500 A[9]=net45500 A[8]=net45500 A[7]=net45500 A[6]=net45500
+ A[5]=net45500 A[4]=net45500 A[3]=net45500 A[2]=net45500 A[1]=net45500
+ A[0]=net45500 B[26]=term1_shifted[26] B[25]=term1_shifted[25]
+ B[24]=term1_shifted[24] B[23]=term1_shifted[23] B[22]=term1_shifted[22]
+ B[21]=term1_shifted[21] B[20]=term1_shifted[20] B[19]=term1_shifted[19]
+ B[18]=term1_shifted[18] B[17]=term1_shifted[17] B[16]=term1_shifted[16]
+ B[15]=term1_shifted[15] B[14]=term1_shifted[14] B[13]=term1_shifted[13]
+ B[12]=term1_shifted[12] B[11]=term1_shifted[11] B[10]=term1_shifted[10]
+ B[9]=term1_shifted[9] B[8]=term1_shifted[8] B[7]=term1_shifted[7]
+ B[6]=term1_shifted[6] B[5]=term1_shifted[5] B[4]=term1_shifted[4]
+ B[3]=term1_shifted[3] B[2]=term1_shifted[2] B[1]=term1_shifted[1]
+ B[0]=term1_shifted[0] CI=net45500 DIFF[26]=N40 DIFF[25]=N39 DIFF[24]=N38
+ DIFF[23]=N37 DIFF[22]=N36 DIFF[21]=N35 DIFF[20]=N34 DIFF[19]=N33 DIFF[18]=N32
+ DIFF[17]=N31 DIFF[16]=N30 DIFF[15]=N29 DIFF[14]=N28 DIFF[13]=N27 DIFF[12]=N26
+ DIFF[11]=N25 DIFF[10]=N24 DIFF[9]=N23 DIFF[8]=N22 DIFF[7]=N21 DIFF[6]=N20
+ DIFF[5]=N19 DIFF[4]=N18 DIFF[3]=N17 DIFF[2]=N16 DIFF[1]=N15 DIFF[0]=N14
Xadd_1_root_add_0_root_add_28_3 PE_Shift_Add_2_DW01_add_2_DW01_add_19 $PINS
+ A[26]=N67 A[25]=N66 A[24]=N65 A[23]=N64 A[22]=N63 A[21]=N62 A[20]=N61 A[19]=N60
+ A[18]=N59 A[17]=N58 A[16]=N57 A[15]=N56 A[14]=N55 A[13]=N54 A[12]=N53 A[11]=N52
+ A[10]=N51 A[9]=N50 A[8]=N49 A[7]=N48 A[6]=N47 A[5]=N46 A[4]=N45 A[3]=N44
+ A[2]=N43 A[1]=N42 A[0]=N41 B[26]=N177 B[25]=N176 B[24]=N175 B[23]=N174
+ B[22]=N173 B[21]=N172 B[20]=N171 B[19]=N170 B[18]=N169 B[17]=N168 B[16]=N167
+ B[15]=N166 B[14]=N165 B[13]=N164 B[12]=N163 B[11]=N162 B[10]=N161 B[9]=N160
+ B[8]=N159 B[7]=N158 B[6]=N157 B[5]=N156 B[4]=N155 B[3]=N154 B[2]=N153 B[1]=N152
+ B[0]=N151 CI=net45500 SUM[26]=N204 SUM[25]=N203 SUM[24]=N202 SUM[23]=N201
+ SUM[22]=N200 SUM[21]=N199 SUM[20]=N198 SUM[19]=N197 SUM[18]=N196 SUM[17]=N195
+ SUM[16]=N194 SUM[15]=N193 SUM[14]=N192 SUM[13]=N191 SUM[12]=N190 SUM[11]=N189
+ SUM[10]=N188 SUM[9]=N187 SUM[8]=N186 SUM[7]=N185 SUM[6]=N184 SUM[5]=N183
+ SUM[4]=N182 SUM[3]=N181 SUM[2]=N180 SUM[1]=N179 SUM[0]=N178
Xadd_2_root_add_0_root_add_28_3 PE_Shift_Add_2_DW01_add_1_DW01_add_18 $PINS
+ A[26]=base_val[26] A[25]=base_val[25] A[24]=base_val[24] A[23]=base_val[23]
+ A[22]=base_val[22] A[21]=base_val[21] A[20]=base_val[20] A[19]=base_val[19]
+ A[18]=base_val[18] A[17]=base_val[17] A[16]=base_val[16] A[15]=base_val[15]
+ A[14]=base_val[14] A[13]=base_val[13] A[12]=base_val[12] A[11]=base_val[11]
+ A[10]=base_val[10] A[9]=base_val[9] A[8]=base_val[8] A[7]=base_val[7]
+ A[6]=base_val[6] A[5]=base_val[5] A[4]=base_val[4] A[3]=base_val[3]
+ A[2]=base_val[2] A[1]=base_val[1] A[0]=base_val[0] B[26]=N122 B[25]=N121
+ B[24]=N120 B[23]=N119 B[22]=N118 B[21]=N117 B[20]=N116 B[19]=N115 B[18]=N114
+ B[17]=N113 B[16]=N112 B[15]=N111 B[14]=N110 B[13]=N109 B[12]=N108 B[11]=N107
+ B[10]=N106 B[9]=N105 B[8]=N104 B[7]=N103 B[6]=N102 B[5]=N101 B[4]=N100 B[3]=N99
+ B[2]=N98 B[1]=N97 B[0]=N96 CI=net45500 SUM[26]=N231 SUM[25]=N230 SUM[24]=N229
+ SUM[23]=N228 SUM[22]=N227 SUM[21]=N226 SUM[20]=N225 SUM[19]=N224 SUM[18]=N223
+ SUM[17]=N222 SUM[16]=N221 SUM[15]=N220 SUM[14]=N219 SUM[13]=N218 SUM[12]=N217
+ SUM[11]=N216 SUM[10]=N215 SUM[9]=N214 SUM[8]=N213 SUM[7]=N212 SUM[6]=N211
+ SUM[5]=N210 SUM[4]=N209 SUM[3]=N208 SUM[2]=N207 SUM[1]=N206 SUM[0]=N205
Xadd_0_root_add_0_root_add_28_3 PE_Shift_Add_2_DW01_add_0_DW01_add_17 $PINS
+ A[26]=N204 A[25]=N203 A[24]=N202 A[23]=N201 A[22]=N200 A[21]=N199 A[20]=N198
+ A[19]=N197 A[18]=N196 A[17]=N195 A[16]=N194 A[15]=N193 A[14]=N192 A[13]=N191
+ A[12]=N190 A[11]=N189 A[10]=N188 A[9]=N187 A[8]=N186 A[7]=N185 A[6]=N184
+ A[5]=N183 A[4]=N182 A[3]=N181 A[2]=N180 A[1]=N179 A[0]=N178 B[26]=N231
+ B[25]=N230 B[24]=N229 B[23]=N228 B[22]=N227 B[21]=N226 B[20]=N225 B[19]=N224
+ B[18]=N223 B[17]=N222 B[16]=N221 B[15]=N220 B[14]=N219 B[13]=N218 B[12]=N217
+ B[11]=N216 B[10]=N215 B[9]=N214 B[8]=N213 B[7]=N212 B[6]=N211 B[5]=N210
+ B[4]=N209 B[3]=N208 B[2]=N207 B[1]=N206 B[0]=N205 CI=net45500
+ SUM[26]=next_acc[26] SUM[25]=next_acc[25] SUM[24]=next_acc[24]
+ SUM[23]=next_acc[23] SUM[22]=next_acc[22] SUM[21]=next_acc[21]
+ SUM[20]=next_acc[20] SUM[19]=next_acc[19] SUM[18]=next_acc[18]
+ SUM[17]=next_acc[17] SUM[16]=next_acc[16] SUM[15]=next_acc[15]
+ SUM[14]=next_acc[14] SUM[13]=next_acc[13] SUM[12]=next_acc[12]
+ SUM[11]=next_acc[11] SUM[10]=next_acc[10] SUM[9]=next_acc[9] SUM[8]=next_acc[8]
+ SUM[7]=next_acc[7] SUM[6]=next_acc[6] SUM[5]=next_acc[5] SUM[4]=next_acc[4]
+ SUM[3]=next_acc[3] SUM[2]=next_acc[2] SUM[1]=next_acc[1] SUM[0]=next_acc[0]
.ENDS

.SUBCKT SNPS_CLOCK_GATE_HIGH_PE_Shift_Add_1 EN ENCLK CLK
*.CONNECT net2215 EN
XFE_PHC836_net2218 DELC $PINS O=net2218 I=FE_PHN836_net2218
Xlatch QDBHN $PINS Q=FE_PHN836_net2218 D=net2215 CKB=CLK
Xmain_gate AN2T $PINS O=ENCLK I1=net2218 I2=CLK
.ENDS

.SUBCKT PE_Shift_Add_1_DW01_sub_0_DW01_sub_3 A[26] A[25] A[24] A[23] A[22]
+ A[21] A[20] A[19] A[18] A[17] A[16] A[15] A[14] A[13] A[12] A[11] A[10] A[9]
+ A[8] A[7] A[6] A[5] A[4] A[3] A[2] A[1] A[0] B[26] B[25] B[24] B[23] B[22]
+ B[21] B[20] B[19] B[18] B[17] B[16] B[15] B[14] B[13] B[12] B[11] B[10] B[9]
+ B[8] B[7] B[6] B[5] B[4] B[3] B[2] B[1] B[0] CI DIFF[26] DIFF[25] DIFF[24]
+ DIFF[23] DIFF[22] DIFF[21] DIFF[20] DIFF[19] DIFF[18] DIFF[17] DIFF[16]
+ DIFF[15] DIFF[14] DIFF[13] DIFF[12] DIFF[11] DIFF[10] DIFF[9] DIFF[8] DIFF[7]
+ DIFF[6] DIFF[5] DIFF[4] DIFF[3] DIFF[2] DIFF[1] DIFF[0] CO
*.CONNECT DIFF[0] B[0]
XFE_RC_1347_0 XNR2HS $PINS O=DIFF[4] I1=n5 I2=B[4]
XFE_RC_1098_0 AN2B1S $PINS O=n3 I1=n52 B1=B[1]
XFE_RC_905_0 INV1S $PINS O=FE_RN_109_0 I=n52
XFE_RC_904_0 MXL2HS $PINS OB=DIFF[1] S=B[1] A=n52 B=FE_RN_109_0
XFE_OFC614_term3_shifted_4 INV1S $PINS O=n49 I=B[4]
XFE_OFC613_term3_shifted_3 INV1S $PINS O=n50 I=B[3]
XU1 NR2 $PINS O=n24 I1=B[5] I2=n53
XU3 NR3 $PINS O=n4 I1=B[1] I2=DIFF[0] I3=B[2]
XU5 XOR2HS $PINS O=DIFF[5] I1=B[5] I2=n53
XU8 XNR2HS $PINS O=DIFF[2] I1=B[2] I2=n3
XU10 INV1S $PINS O=n52 I=B[0]
XU15 AN2 $PINS O=n5 I1=n4 I2=n50
XU16 AN2 $PINS O=n6 I1=n46 I2=n26
XU17 AN2 $PINS O=n7 I1=n45 I2=n6
XU18 AN2 $PINS O=n8 I1=n44 I2=n7
XU19 AN2 $PINS O=n9 I1=n43 I2=n8
XU20 AN2 $PINS O=n10 I1=n42 I2=n9
XU21 AN2 $PINS O=n11 I1=n41 I2=n10
XU22 AN2 $PINS O=n12 I1=n40 I2=n11
XU23 AN2 $PINS O=n13 I1=n39 I2=n12
XU24 AN2 $PINS O=n14 I1=n38 I2=n13
XU25 AN2 $PINS O=n15 I1=n37 I2=n14
XU26 AN2 $PINS O=n16 I1=n36 I2=n15
XU27 AN2 $PINS O=n17 I1=n35 I2=n16
XU28 AN2 $PINS O=n18 I1=n34 I2=n17
XU29 AN2 $PINS O=n19 I1=n33 I2=n18
XU30 AN2 $PINS O=n20 I1=n32 I2=n19
XU31 AN2 $PINS O=n21 I1=n31 I2=n20
XU32 AN2 $PINS O=n22 I1=n30 I2=n21
XU33 AN2 $PINS O=n25 I1=n48 I2=n24
XU34 AN2 $PINS O=n26 I1=n47 I2=n25
XU35 INV1S $PINS O=n46 I=B[8]
XU36 INV1S $PINS O=n45 I=B[9]
XU37 INV1S $PINS O=n44 I=B[10]
XU38 XOR2HS $PINS O=DIFF[26] I1=B[26] I2=n28
XU39 INV1S $PINS O=n43 I=B[11]
XU40 INV1S $PINS O=n42 I=B[12]
XU41 INV1S $PINS O=n41 I=B[13]
XU42 INV1S $PINS O=n40 I=B[14]
XU43 INV1S $PINS O=n39 I=B[15]
XU44 INV1S $PINS O=n38 I=B[16]
XU45 INV1S $PINS O=n37 I=B[17]
XU46 INV1S $PINS O=n36 I=B[18]
XU47 INV1S $PINS O=n35 I=B[19]
XU48 INV1S $PINS O=n34 I=B[20]
XU49 INV1S $PINS O=n33 I=B[21]
XU50 INV1S $PINS O=n32 I=B[22]
XU51 INV1S $PINS O=n31 I=B[23]
XU52 INV1S $PINS O=n30 I=B[24]
XU53 INV1S $PINS O=n29 I=B[25]
XU54 INV1S $PINS O=n48 I=B[6]
XU55 INV1S $PINS O=n47 I=B[7]
XU56 XOR2HS $PINS O=DIFF[10] I1=n44 I2=n7
XU57 XOR2HS $PINS O=DIFF[11] I1=n43 I2=n8
XU58 XOR2HS $PINS O=DIFF[12] I1=n42 I2=n9
XU59 XOR2HS $PINS O=DIFF[13] I1=n41 I2=n10
XU60 XOR2HS $PINS O=DIFF[14] I1=n40 I2=n11
XU61 XOR2HS $PINS O=DIFF[15] I1=n39 I2=n12
XU62 XOR2HS $PINS O=DIFF[16] I1=n38 I2=n13
XU63 XOR2HS $PINS O=DIFF[9] I1=n45 I2=n6
XU64 XOR2HS $PINS O=DIFF[17] I1=n37 I2=n14
XU65 XOR2HS $PINS O=DIFF[8] I1=n46 I2=n26
XU66 XOR2HS $PINS O=DIFF[6] I1=n48 I2=n24
XU67 XOR2HS $PINS O=DIFF[7] I1=n47 I2=n25
XU69 XOR2HS $PINS O=DIFF[3] I1=n50 I2=n4
XU70 XOR2HS $PINS O=DIFF[18] I1=n36 I2=n15
XU71 XOR2HS $PINS O=DIFF[19] I1=n35 I2=n16
XU72 XOR2HS $PINS O=DIFF[20] I1=n34 I2=n17
XU73 XOR2HS $PINS O=DIFF[21] I1=n33 I2=n18
XU74 XOR2HS $PINS O=DIFF[22] I1=n32 I2=n19
XU75 XOR2HS $PINS O=DIFF[23] I1=n31 I2=n20
XU76 XOR2HS $PINS O=DIFF[24] I1=n30 I2=n21
XU77 XOR2HS $PINS O=DIFF[25] I1=n29 I2=n22
XU78 ND2 $PINS O=n28 I1=n29 I2=n22
XU2 ND2 $PINS O=n53 I1=n49 I2=n5
.ENDS

.SUBCKT PE_Shift_Add_1_DW01_sub_1_DW01_sub_4 A[26] A[25] A[24] A[23] A[22]
+ A[21] A[20] A[19] A[18] A[17] A[16] A[15] A[14] A[13] A[12] A[11] A[10] A[9]
+ A[8] A[7] A[6] A[5] A[4] A[3] A[2] A[1] A[0] B[26] B[25] B[24] B[23] B[22]
+ B[21] B[20] B[19] B[18] B[17] B[16] B[15] B[14] B[13] B[12] B[11] B[10] B[9]
+ B[8] B[7] B[6] B[5] B[4] B[3] B[2] B[1] B[0] CI DIFF[26] DIFF[25] DIFF[24]
+ DIFF[23] DIFF[22] DIFF[21] DIFF[20] DIFF[19] DIFF[18] DIFF[17] DIFF[16]
+ DIFF[15] DIFF[14] DIFF[13] DIFF[12] DIFF[11] DIFF[10] DIFF[9] DIFF[8] DIFF[7]
+ DIFF[6] DIFF[5] DIFF[4] DIFF[3] DIFF[2] DIFF[1] DIFF[0] CO
XFE_RC_118_0 XOR2HS $PINS O=DIFF[1] I1=B[0] I2=B[1]
XFE_OFC647_term2_shifted_4 INV2 $PINS O=n48 I=B[4]
XFE_OFC352_term2_shifted_3 INV2 $PINS O=n49 I=B[3]
XU2 NR2 $PINS O=n1 I1=B[1] I2=B[0]
XU3 NR3 $PINS O=n2 I1=B[0] I2=B[1] I3=B[2]
XU4 INV1S $PINS O=n50 I=B[2]
XU7 INV1S $PINS O=n47 I=B[5]
XU9 XOR2HS $PINS O=DIFF[2] I1=n1 I2=n50
XU10 AN2 $PINS O=n21 I1=n48 I2=n3
XU11 ND2S $PINS O=n26 I1=n27 I2=n20
XU12 AN2 $PINS O=n3 I1=n49 I2=n2
XU13 AN2 $PINS O=n4 I1=n44 I2=n24
XU14 AN2 $PINS O=n5 I1=n43 I2=n4
XU15 AN2 $PINS O=n6 I1=n42 I2=n5
XU16 AN2 $PINS O=n7 I1=n41 I2=n6
XU17 AN2 $PINS O=n8 I1=n40 I2=n7
XU18 AN2 $PINS O=n9 I1=n39 I2=n8
XU19 AN2 $PINS O=n10 I1=n38 I2=n9
XU20 AN2 $PINS O=n11 I1=n37 I2=n10
XU21 AN2 $PINS O=n12 I1=n36 I2=n11
XU22 AN2 $PINS O=n13 I1=n35 I2=n12
XU23 AN2 $PINS O=n14 I1=n34 I2=n13
XU24 AN2 $PINS O=n15 I1=n33 I2=n14
XU25 AN2 $PINS O=n16 I1=n32 I2=n15
XU26 AN2 $PINS O=n17 I1=n31 I2=n16
XU27 AN2 $PINS O=n18 I1=n30 I2=n17
XU28 AN2 $PINS O=n19 I1=n29 I2=n18
XU29 AN2 $PINS O=n20 I1=n28 I2=n19
XU30 AN2 $PINS O=n22 I1=n21 I2=n47
XU31 AN2 $PINS O=n23 I1=n46 I2=n22
XU32 AN2 $PINS O=n24 I1=n45 I2=n23
XU33 INV1S $PINS O=n44 I=B[8]
XU34 INV1S $PINS O=n43 I=B[9]
XU35 INV1S $PINS O=n42 I=B[10]
XU36 INV1S $PINS O=n41 I=B[11]
XU37 INV1S $PINS O=n40 I=B[12]
XU38 INV1S $PINS O=n39 I=B[13]
XU39 INV1S $PINS O=n38 I=B[14]
XU40 INV1S $PINS O=n37 I=B[15]
XU41 INV1S $PINS O=n36 I=B[16]
XU42 INV1S $PINS O=n35 I=B[17]
XU43 INV1S $PINS O=n34 I=B[18]
XU44 INV1S $PINS O=n33 I=B[19]
XU45 INV1S $PINS O=n32 I=B[20]
XU46 INV1S $PINS O=n31 I=B[21]
XU47 INV1S $PINS O=n30 I=B[22]
XU48 INV1S $PINS O=n29 I=B[23]
XU49 INV1S $PINS O=n28 I=B[24]
XU50 INV1S $PINS O=n27 I=B[25]
XU51 INV1S $PINS O=n46 I=B[6]
XU52 INV1S $PINS O=n45 I=B[7]
XU53 XOR2HS $PINS O=DIFF[26] I1=B[26] I2=n26
XU54 XOR2HS $PINS O=DIFF[9] I1=n43 I2=n4
XU55 XOR2HS $PINS O=DIFF[10] I1=n42 I2=n5
XU56 XOR2HS $PINS O=DIFF[11] I1=n41 I2=n6
XU57 XOR2HS $PINS O=DIFF[12] I1=n40 I2=n7
XU58 XOR2HS $PINS O=DIFF[13] I1=n39 I2=n8
XU59 XOR2HS $PINS O=DIFF[14] I1=n38 I2=n9
XU60 XOR2HS $PINS O=DIFF[15] I1=n37 I2=n10
XU61 XOR2HS $PINS O=DIFF[16] I1=n36 I2=n11
XU62 XOR2HS $PINS O=DIFF[17] I1=n35 I2=n12
XU63 XOR2HS $PINS O=DIFF[18] I1=n34 I2=n13
XU64 XOR2HS $PINS O=DIFF[19] I1=n33 I2=n14
XU65 XOR2HS $PINS O=DIFF[20] I1=n32 I2=n15
XU66 XOR2HS $PINS O=DIFF[7] I1=n45 I2=n23
XU67 XOR2HS $PINS O=DIFF[6] I1=n46 I2=n22
XU68 XOR2HS $PINS O=DIFF[21] I1=n31 I2=n16
XU69 XOR2HS $PINS O=DIFF[8] I1=n44 I2=n24
XU70 XOR2HS $PINS O=DIFF[5] I1=n47 I2=n21
XU71 XOR2HS $PINS O=DIFF[22] I1=n30 I2=n17
XU72 XOR2HS $PINS O=DIFF[23] I1=n29 I2=n18
XU73 XOR2HS $PINS O=DIFF[4] I1=n3 I2=n48
XU74 XOR2HS $PINS O=DIFF[24] I1=n28 I2=n19
XU75 XOR2HS $PINS O=DIFF[3] I1=n2 I2=n49
XU76 XOR2HS $PINS O=DIFF[25] I1=n27 I2=n20
.ENDS

.SUBCKT PE_Shift_Add_1_DW01_sub_2_DW01_sub_5 A[26] A[25] A[24] A[23] A[22]
+ A[21] A[20] A[19] A[18] A[17] A[16] A[15] A[14] A[13] A[12] A[11] A[10] A[9]
+ A[8] A[7] A[6] A[5] A[4] A[3] A[2] A[1] A[0] B[26] B[25] B[24] B[23] B[22]
+ B[21] B[20] B[19] B[18] B[17] B[16] B[15] B[14] B[13] B[12] B[11] B[10] B[9]
+ B[8] B[7] B[6] B[5] B[4] B[3] B[2] B[1] B[0] CI DIFF[26] DIFF[25] DIFF[24]
+ DIFF[23] DIFF[22] DIFF[21] DIFF[20] DIFF[19] DIFF[18] DIFF[17] DIFF[16]
+ DIFF[15] DIFF[14] DIFF[13] DIFF[12] DIFF[11] DIFF[10] DIFF[9] DIFF[8] DIFF[7]
+ DIFF[6] DIFF[5] DIFF[4] DIFF[3] DIFF[2] DIFF[1] DIFF[0] CO p1
*.CONNECT DIFF[0] B[0]
XFE_RC_1415_0 XOR2HS $PINS O=DIFF[3] I1=n50 I2=n4
XFE_RC_1307_0 XNR2HS $PINS O=DIFF[4] I1=B[4] I2=n5
XFE_OFC616_term1_shifted_7 INV1S $PINS O=n47 I=B[7]
XFE_OFC593_term1_shifted_3 INV1S $PINS O=n50 I=B[3]
XU1 NR2P $PINS O=n24 I1=B[5] I2=n55
XU3 INV2 $PINS O=n52 I=B[1]
XU4 XOR2HS $PINS O=DIFF[1] I1=p1 I2=n52
XU6 INV1S $PINS O=n49 I=B[4]
XU7 XOR2HS $PINS O=DIFF[5] I1=B[5] I2=n55
XU9 INV1S $PINS O=n48 I=B[6]
XU11 XNR2HS $PINS O=DIFF[2] I1=n3 I2=B[2]
XU15 ND2S $PINS O=n28 I1=n29 I2=n22
XU16 AN2T $PINS O=n3 I1=n52 I2=p1
XU19 AN2 $PINS O=n5 I1=n50 I2=n4
XU20 XOR2HS $PINS O=DIFF[8] I1=n46 I2=n26
XU21 XOR2HS $PINS O=DIFF[9] I1=n45 I2=n6
XU22 AN2 $PINS O=n6 I1=n46 I2=n26
XU23 XOR2HS $PINS O=DIFF[10] I1=n44 I2=n7
XU24 AN2 $PINS O=n7 I1=n45 I2=n6
XU25 XOR2HS $PINS O=DIFF[11] I1=n43 I2=n8
XU26 AN2 $PINS O=n8 I1=n44 I2=n7
XU27 XOR2HS $PINS O=DIFF[12] I1=n42 I2=n9
XU28 AN2 $PINS O=n9 I1=n43 I2=n8
XU29 XOR2HS $PINS O=DIFF[13] I1=n41 I2=n10
XU30 AN2 $PINS O=n10 I1=n42 I2=n9
XU31 XOR2HS $PINS O=DIFF[14] I1=n40 I2=n11
XU32 AN2 $PINS O=n11 I1=n41 I2=n10
XU33 XOR2HS $PINS O=DIFF[15] I1=n39 I2=n12
XU34 AN2 $PINS O=n12 I1=n40 I2=n11
XU35 XOR2HS $PINS O=DIFF[16] I1=n38 I2=n13
XU36 AN2 $PINS O=n13 I1=n39 I2=n12
XU37 XOR2HS $PINS O=DIFF[17] I1=n37 I2=n14
XU38 AN2 $PINS O=n14 I1=n38 I2=n13
XU39 XOR2HS $PINS O=DIFF[18] I1=n36 I2=n15
XU40 AN2 $PINS O=n15 I1=n37 I2=n14
XU41 XOR2HS $PINS O=DIFF[19] I1=n35 I2=n16
XU42 AN2 $PINS O=n16 I1=n36 I2=n15
XU43 XOR2HS $PINS O=DIFF[20] I1=n34 I2=n17
XU44 AN2 $PINS O=n17 I1=n35 I2=n16
XU45 XOR2HS $PINS O=DIFF[21] I1=n33 I2=n18
XU46 AN2 $PINS O=n18 I1=n34 I2=n17
XU47 XOR2HS $PINS O=DIFF[22] I1=n32 I2=n19
XU48 AN2 $PINS O=n19 I1=n33 I2=n18
XU49 XOR2HS $PINS O=DIFF[23] I1=n31 I2=n20
XU50 AN2 $PINS O=n20 I1=n32 I2=n19
XU51 XOR2HS $PINS O=DIFF[24] I1=n30 I2=n21
XU52 AN2 $PINS O=n21 I1=n31 I2=n20
XU53 AN2 $PINS O=n22 I1=n30 I2=n21
XU54 XOR2HS $PINS O=DIFF[25] I1=n29 I2=n22
XU56 XOR2HS $PINS O=DIFF[6] I1=n48 I2=n24
XU57 XOR2HS $PINS O=DIFF[7] I1=n47 I2=n25
XU58 AN2 $PINS O=n25 I1=n48 I2=n24
XU59 AN2 $PINS O=n26 I1=n47 I2=n25
XU60 INV1S $PINS O=n46 I=B[8]
XU61 INV1S $PINS O=n45 I=B[9]
XU62 INV1S $PINS O=n44 I=B[10]
XU63 INV1S $PINS O=n43 I=B[11]
XU64 INV1S $PINS O=n42 I=B[12]
XU65 INV1S $PINS O=n41 I=B[13]
XU66 INV1S $PINS O=n40 I=B[14]
XU67 INV1S $PINS O=n39 I=B[15]
XU68 INV1S $PINS O=n38 I=B[16]
XU69 INV1S $PINS O=n37 I=B[17]
XU70 INV1S $PINS O=n36 I=B[18]
XU71 INV1S $PINS O=n35 I=B[19]
XU72 INV1S $PINS O=n34 I=B[20]
XU73 INV1S $PINS O=n33 I=B[21]
XU74 INV1S $PINS O=n32 I=B[22]
XU75 INV1S $PINS O=n31 I=B[23]
XU76 INV1S $PINS O=n30 I=B[24]
XU77 INV1S $PINS O=n29 I=B[25]
XU79 XOR2HS $PINS O=DIFF[26] I1=B[26] I2=n28
XU2 NR2P $PINS O=n4 I1=n54 I2=B[2]
XU5 INV1S $PINS O=n54 I=n3
XU12 ND2 $PINS O=n55 I1=n49 I2=n5
.ENDS

.SUBCKT PE_Shift_Add_1_DW01_add_2_DW01_add_28 A[26] A[25] A[24] A[23] A[22]
+ A[21] A[20] A[19] A[18] A[17] A[16] A[15] A[14] A[13] A[12] A[11] A[10] A[9]
+ A[8] A[7] A[6] A[5] A[4] A[3] A[2] A[1] A[0] B[26] B[25] B[24] B[23] B[22]
+ B[21] B[20] B[19] B[18] B[17] B[16] B[15] B[14] B[13] B[12] B[11] B[10] B[9]
+ B[8] B[7] B[6] B[5] B[4] B[3] B[2] B[1] B[0] CI SUM[26] SUM[25] SUM[24]
+ SUM[23] SUM[22] SUM[21] SUM[20] SUM[19] SUM[18] SUM[17] SUM[16] SUM[15]
+ SUM[14] SUM[13] SUM[12] SUM[11] SUM[10] SUM[9] SUM[8] SUM[7] SUM[6] SUM[5]
+ SUM[4] SUM[3] SUM[2] SUM[1] SUM[0] CO
XFE_OCPC708_carry_23 BUF1S $PINS O=FE_OCPN708_carry_23 I=carry[23]
XFE_OCPC700_carry_5 BUF1S $PINS O=FE_OCPN700_carry_5 I=carry[5]
XFE_RC_1438_0 XOR3 $PINS O=SUM[24] I1=A[24] I2=B[24] I3=carry[24]
XFE_RC_1437_0 MAO222 $PINS O=carry[25] A1=A[24] B1=B[24] C1=carry[24]
XFE_RC_1381_0 MAO222P $PINS O=carry[2] A1=A[1] B1=n4 C1=B[1]
XFE_RC_1380_0 XOR3 $PINS O=SUM[1] I1=A[1] I2=n4 I3=B[1]
XFE_RC_1369_0 INV2 $PINS O=SUM[4] I=FE_RN_291_0
XFE_RC_1368_0 XNR3 $PINS O=FE_RN_291_0 I1=A[4] I2=B[4] I3=carry[4]
XFE_RC_1359_0 INV2 $PINS O=SUM[8] I=FE_RN_287_0
XFE_RC_1358_0 XNR3 $PINS O=FE_RN_287_0 I1=B[8] I2=A[8] I3=carry[8]
XFE_RC_1355_0 INV2 $PINS O=SUM[13] I=FE_RN_285_0
XFE_RC_1354_0 XNR3 $PINS O=FE_RN_285_0 I1=A[13] I2=B[13] I3=carry[13]
XFE_RC_1353_0 INV2 $PINS O=SUM[14] I=FE_RN_284_0
XFE_RC_1352_0 XNR3 $PINS O=FE_RN_284_0 I1=A[14] I2=B[14] I3=carry[14]
XFE_RC_1242_0 XOR3 $PINS O=SUM[2] I1=carry[2] I2=B[2] I3=A[2]
XFE_RC_1014_0 XOR3 $PINS O=SUM[25] I1=A[25] I2=B[25] I3=carry[25]
XFE_RC_1013_0 MAO222P $PINS O=carry[26] A1=carry[25] B1=B[25] C1=A[25]
XFE_RC_1012_0 XOR3 $PINS O=SUM[15] I1=A[15] I2=B[15] I3=carry[15]
XFE_RC_1011_0 MAO222P $PINS O=carry[16] A1=carry[15] B1=B[15] C1=A[15]
XFE_RC_964_0 XOR2HS $PINS O=FE_RN_139_0 I1=A[26] I2=B[26]
XFE_RC_963_0 INV1S $PINS O=FE_RN_138_0 I=FE_RN_139_0
XFE_RC_962_0 XOR2H $PINS O=FE_RN_108_0 I1=FE_RN_138_0 I2=carry[26]
XFE_RC_916_0 ND2 $PINS O=FE_RN_113_0 I1=A[2] I2=B[2]
XFE_RC_915_0 ND2 $PINS O=FE_RN_114_0 I1=carry[2] I2=B[2]
XFE_RC_914_0 ND2 $PINS O=FE_RN_115_0 I1=carry[2] I2=A[2]
XFE_RC_913_0 ND3 $PINS O=carry[3] I1=FE_RN_115_0 I2=FE_RN_114_0 I3=FE_RN_113_0
XFE_RC_903_0 INV3 $PINS O=SUM[26] I=FE_RN_108_0
XFE_RC_886_0 ND2 $PINS O=FE_RN_98_0 I1=A[16] I2=B[16]
XFE_RC_885_0 ND2P $PINS O=FE_RN_99_0 I1=carry[16] I2=A[16]
XFE_RC_884_0 ND2P $PINS O=FE_RN_100_0 I1=carry[16] I2=B[16]
XFE_RC_883_0 ND3P $PINS O=carry[17] I1=FE_RN_100_0 I2=FE_RN_99_0 I3=FE_RN_98_0
XFE_RC_882_0 ND2 $PINS O=FE_RN_95_0 I1=A[13] I2=B[13]
XFE_RC_881_0 ND2T $PINS O=FE_RN_96_0 I1=carry[13] I2=A[13]
XFE_RC_880_0 ND2P $PINS O=FE_RN_97_0 I1=carry[13] I2=B[13]
XFE_RC_879_0 ND3HT $PINS O=carry[14] I1=FE_RN_97_0 I2=FE_RN_96_0 I3=FE_RN_95_0
XFE_RC_772_0 XOR3 $PINS O=SUM[16] I1=A[16] I2=B[16] I3=carry[16]
XFE_RC_695_0 XOR3 $PINS O=SUM[3] I1=A[3] I2=B[3] I3=carry[3]
XFE_RC_694_0 MAO222P $PINS O=carry[4] A1=carry[3] B1=B[3] C1=A[3]
XFE_RC_691_0 XOR3 $PINS O=SUM[17] I1=A[17] I2=B[17] I3=carry[17]
XFE_RC_690_0 MAO222P $PINS O=carry[18] A1=carry[17] B1=B[17] C1=A[17]
XFE_RC_607_0 XOR3 $PINS O=SUM[18] I1=A[18] I2=B[18] I3=carry[18]
XFE_RC_606_0 MAO222P $PINS O=carry[19] A1=carry[18] B1=B[18] C1=A[18]
XFE_RC_605_0 XOR3 $PINS O=SUM[9] I1=A[9] I2=B[9] I3=carry[9]
XFE_RC_604_0 MAO222 $PINS O=carry[10] A1=carry[9] B1=B[9] C1=A[9]
XFE_RC_501_0 XOR3 $PINS O=SUM[19] I1=A[19] I2=B[19] I3=carry[19]
XFE_RC_500_0 MAO222P $PINS O=carry[20] A1=carry[19] B1=B[19] C1=A[19]
XFE_RC_496_0 XOR3 $PINS O=SUM[10] I1=A[10] I2=B[10] I3=carry[10]
XFE_RC_495_0 MAO222 $PINS O=carry[11] A1=carry[10] B1=B[10] C1=A[10]
XFE_RC_432_0 XOR3 $PINS O=SUM[11] I1=A[11] I2=B[11] I3=carry[11]
XFE_RC_431_0 MAO222P $PINS O=carry[12] A1=carry[11] B1=B[11] C1=A[11]
XFE_RC_341_0 XOR3 $PINS O=SUM[12] I1=A[12] I2=B[12] I3=carry[12]
XFE_RC_340_0 MAO222P $PINS O=carry[13] A1=carry[12] B1=B[12] C1=A[12]
XFE_RC_339_0 XOR3 $PINS O=SUM[20] I1=A[20] I2=B[20] I3=carry[20]
XFE_RC_338_0 MAO222P $PINS O=carry[21] A1=carry[20] B1=B[20] C1=A[20]
XFE_RC_232_0 ND3P $PINS O=carry[23] I1=n12 I2=n13 I3=n11
XFE_RC_178_0 ND3P $PINS O=carry[24] I1=n16 I2=n17 I3=n15
XFE_RC_177_0 XOR3 $PINS O=SUM[21] I1=A[21] I2=B[21] I3=carry[21]
XFE_RC_176_0 MAO222P $PINS O=carry[22] A1=carry[21] B1=B[21] C1=A[21]
XU1_6 FA1 $PINS S=SUM[6] CO=carry[7] A=A[6] B=B[6] CI=carry[6]
XU1 ND3P $PINS O=carry[6] I1=n21 I2=n22 I3=n23
XU2 AN2 $PINS O=n4 I1=A[0] I2=B[0]
XU4 ND2 $PINS O=n23 I1=A[5] I2=B[5]
XU5 ND3P $PINS O=carry[5] I1=n1 I2=n2 I3=n3
XU6 ND2 $PINS O=n3 I1=A[4] I2=B[4]
XU8 ND2P $PINS O=n1 I1=carry[4] I2=A[4]
XU9 ND2P $PINS O=n2 I1=carry[4] I2=B[4]
XU10 XOR3 $PINS O=SUM[22] I1=A[22] I2=B[22] I3=carry[22]
XU11 ND2 $PINS O=n11 I1=A[22] I2=B[22]
XU13 ND2P $PINS O=n5 I1=carry[14] I2=A[14]
XU14 ND2P $PINS O=n6 I1=carry[14] I2=B[14]
XU15 ND2 $PINS O=n7 I1=A[14] I2=B[14]
XU16 ND3P $PINS O=carry[15] I1=n6 I2=n5 I3=n7
XU18 ND2 $PINS O=n8 I1=carry[8] I2=B[8]
XU19 ND2 $PINS O=n9 I1=carry[8] I2=A[8]
XU20 ND2 $PINS O=n10 I1=B[8] I2=A[8]
XU21 ND3P $PINS O=carry[9] I1=n8 I2=n9 I3=n10
XU23 ND2P $PINS O=n12 I1=carry[22] I2=A[22]
XU24 ND2T $PINS O=n13 I1=carry[22] I2=B[22]
XU26 XOR2HS $PINS O=n14 I1=A[23] I2=B[23]
XU27 XOR2HS $PINS O=SUM[23] I1=n14 I2=FE_OCPN708_carry_23
XU28 ND2 $PINS O=n15 I1=A[23] I2=B[23]
XU29 ND2 $PINS O=n16 I1=carry[23] I2=A[23]
XU30 ND2 $PINS O=n17 I1=carry[23] I2=B[23]
XU31 ND2 $PINS O=n27 I1=B[7] I2=A[7]
XU33 MAO222 $PINS O=n19 A1=carry[6] B1=B[6] C1=A[6]
XU34 XOR2HS $PINS O=n20 I1=A[5] I2=B[5]
XU35 XOR2HS $PINS O=SUM[5] I1=FE_OCPN700_carry_5 I2=n20
XU36 ND2 $PINS O=n21 I1=carry[5] I2=A[5]
XU37 ND2 $PINS O=n22 I1=carry[5] I2=B[5]
XU38 XOR2HS $PINS O=n24 I1=B[7] I2=A[7]
XU39 XOR2HS $PINS O=SUM[7] I1=carry[7] I2=n24
XU40 ND2 $PINS O=n25 I1=n19 I2=B[7]
XU41 ND3P $PINS O=carry[8] I1=n25 I2=n26 I3=n27
XU42 XOR2HS $PINS O=SUM[0] I1=B[0] I2=A[0]
XU3 ND2 $PINS O=n26 I1=n19 I2=A[7]
.ENDS

.SUBCKT PE_Shift_Add_1_DW01_add_1_DW01_add_27 A[26] A[25] A[24] A[23] A[22]
+ A[21] A[20] A[19] A[18] A[17] A[16] A[15] A[14] A[13] A[12] A[11] A[10] A[9]
+ A[8] A[7] A[6] A[5] A[4] A[3] A[2] A[1] A[0] B[26] B[25] B[24] B[23] B[22]
+ B[21] B[20] B[19] B[18] B[17] B[16] B[15] B[14] B[13] B[12] B[11] B[10] B[9]
+ B[8] B[7] B[6] B[5] B[4] B[3] B[2] B[1] B[0] CI SUM[26] SUM[25] SUM[24]
+ SUM[23] SUM[22] SUM[21] SUM[20] SUM[19] SUM[18] SUM[17] SUM[16] SUM[15]
+ SUM[14] SUM[13] SUM[12] SUM[11] SUM[10] SUM[9] SUM[8] SUM[7] SUM[6] SUM[5]
+ SUM[4] SUM[3] SUM[2] SUM[1] SUM[0] CO
XFE_RC_1771_0 OR2 $PINS O=carry[2] I1=FE_RN_478_0 I2=FE_RN_477_0
XFE_RC_1770_0 OR2 $PINS O=FE_RN_473_0 I1=A[2] I2=FE_RN_478_0
XFE_RC_1769_0 OAI12H $PINS O=FE_RN_474_0 A1=B[2] B1=FE_RN_473_0 B2=FE_RN_477_0
XFE_RC_1768_0 INV1S $PINS O=FE_RN_475_0 I=A[1]
XFE_RC_1767_0 OR2B1S $PINS O=FE_RN_476_0 I1=n7 B1=FE_RN_475_0
XFE_RC_1766_0 AN2T $PINS O=FE_RN_477_0 I1=FE_RN_476_0 I2=B[1]
XFE_RC_1765_0 AN2 $PINS O=FE_RN_478_0 I1=A[1] I2=n7
XFE_RC_1764_0 OAI12H $PINS O=FE_RN_479_0 A1=A[2] B1=FE_RN_478_0 B2=FE_RN_477_0
XFE_RC_1763_0 ND2P $PINS O=carry[3] I1=FE_RN_479_0 I2=FE_RN_474_0
XFE_RC_1698_0 ND3P $PINS O=carry[6] I1=n11 I2=n12 I3=n13
XFE_RC_1527_0 XOR3 $PINS O=SUM[25] I1=A[25] I2=B[25] I3=carry[25]
XFE_RC_1526_0 MAO222 $PINS O=carry[26] A1=carry[25] B1=B[25] C1=A[25]
XFE_RC_1055_0 XOR3 $PINS O=SUM[24] I1=A[24] I2=B[24] I3=carry[24]
XFE_RC_1054_0 MAO222P $PINS O=carry[25] A1=carry[24] B1=B[24] C1=A[24]
XFE_RC_1010_0 XOR3 $PINS O=SUM[17] I1=A[17] I2=B[17] I3=carry[17]
XFE_RC_1009_0 MAO222P $PINS O=carry[18] A1=carry[17] B1=B[17] C1=A[17]
XFE_RC_984_0 XOR3 $PINS O=SUM[18] I1=A[18] I2=B[18] I3=carry[18]
XFE_RC_983_0 MAO222P $PINS O=carry[19] A1=carry[18] B1=B[18] C1=A[18]
XFE_RC_926_0 ND2P $PINS O=FE_RN_118_0 I1=carry[3] I2=A[3]
XFE_RC_925_0 ND2 $PINS O=FE_RN_119_0 I1=B[3] I2=A[3]
XFE_RC_924_0 ND2 $PINS O=FE_RN_120_0 I1=carry[3] I2=B[3]
XFE_RC_923_0 ND3P $PINS O=carry[4] I1=FE_RN_120_0 I2=FE_RN_119_0 I3=FE_RN_118_0
XFE_RC_793_0 XOR3 $PINS O=SUM[19] I1=A[19] I2=B[19] I3=carry[19]
XFE_RC_792_0 MAO222P $PINS O=carry[20] A1=carry[19] B1=B[19] C1=A[19]
XFE_RC_784_0 XOR3 $PINS O=SUM[20] I1=A[20] I2=B[20] I3=carry[20]
XFE_RC_783_0 MAO222P $PINS O=carry[21] A1=carry[20] B1=B[20] C1=A[20]
XFE_RC_768_0 XOR3 $PINS O=SUM[21] I1=A[21] I2=B[21] I3=carry[21]
XFE_RC_767_0 MAO222 $PINS O=carry[22] A1=carry[21] B1=B[21] C1=A[21]
XFE_RC_743_0 XOR3 $PINS O=SUM[22] I1=A[22] I2=B[22] I3=carry[22]
XFE_RC_742_0 MAO222P $PINS O=carry[23] A1=carry[22] B1=B[22] C1=A[22]
XFE_RC_687_0 XOR3 $PINS O=SUM[23] I1=A[23] I2=B[23] I3=carry[23]
XFE_RC_686_0 MAO222P $PINS O=carry[24] A1=carry[23] B1=B[23] C1=A[23]
XFE_RC_651_0 XOR3 $PINS O=SUM[1] I1=A[1] I2=B[1] I3=n7
XFE_RC_645_0 XOR3 $PINS O=SUM[13] I1=A[13] I2=B[13] I3=carry[13]
XFE_RC_644_0 MAO222P $PINS O=carry[14] A1=carry[13] B1=B[13] C1=A[13]
XFE_RC_577_0 XOR3 $PINS O=SUM[14] I1=A[14] I2=B[14] I3=carry[14]
XFE_RC_576_0 MAO222P $PINS O=carry[15] A1=carry[14] B1=B[14] C1=A[14]
XFE_RC_521_0 XOR3 $PINS O=SUM[2] I1=A[2] I2=B[2] I3=carry[2]
XFE_RC_463_0 XOR3 $PINS O=SUM[3] I1=A[3] I2=B[3] I3=carry[3]
XFE_RC_450_0 XOR3 $PINS O=SUM[15] I1=A[15] I2=B[15] I3=carry[15]
XFE_RC_449_0 MAO222P $PINS O=carry[16] A1=carry[15] B1=B[15] C1=A[15]
XFE_RC_400_0 XOR3 $PINS O=SUM[4] I1=A[4] I2=B[4] I3=carry[4]
XFE_RC_399_0 MAO222P $PINS O=carry[5] A1=carry[4] B1=B[4] C1=A[4]
XFE_RC_333_0 XOR3 $PINS O=SUM[6] I1=A[6] I2=B[6] I3=carry[6]
XFE_RC_332_0 MAO222P $PINS O=carry[7] A1=carry[6] B1=B[6] C1=A[6]
XFE_RC_323_0 ND3HT $PINS O=carry[8] I1=n2 I2=n1 I3=n3
XFE_RC_320_0 ND3P $PINS O=carry[10] I1=n27 I2=n26 I3=n25
XFE_RC_299_0 ND3P $PINS O=carry[12] I1=n15 I2=n16 I3=n14
XFE_RC_261_0 ND3P $PINS O=carry[17] I1=n8 I2=n9 I3=n10
XFE_RC_260_0 ND3P $PINS O=carry[13] I1=n20 I2=n19 I3=n18
XU8 XOR3 $PINS O=SUM[7] I1=B[7] I2=A[7] I3=carry[7]
XU9 ND2T $PINS O=n1 I1=carry[7] I2=B[7]
XU10 ND2P $PINS O=n2 I1=carry[7] I2=A[7]
XU11 ND2 $PINS O=n3 I1=B[7] I2=A[7]
XU12 XOR3 $PINS O=SUM[10] I1=B[10] I2=A[10] I3=carry[10]
XU13 ND2 $PINS O=n4 I1=carry[10] I2=B[10]
XU14 ND2 $PINS O=n5 I1=carry[10] I2=A[10]
XU15 ND2 $PINS O=n6 I1=B[10] I2=A[10]
XU16 ND2 $PINS O=n21 I1=A[8] I2=B[8]
XU17 ND2 $PINS O=n14 I1=A[11] I2=B[11]
XU18 AN2S $PINS O=n7 I1=B[0] I2=A[0]
XU19 XOR3 $PINS O=SUM[16] I1=B[16] I2=A[16] I3=carry[16]
XU20 ND2P $PINS O=n8 I1=carry[16] I2=B[16]
XU21 ND2T $PINS O=n9 I1=carry[16] I2=A[16]
XU22 ND2 $PINS O=n10 I1=B[16] I2=A[16]
XU23 XOR3 $PINS O=SUM[5] I1=A[5] I2=carry[5] I3=B[5]
XU24 ND2P $PINS O=n11 I1=carry[5] I2=B[5]
XU25 ND2P $PINS O=n12 I1=carry[5] I2=A[5]
XU26 ND2 $PINS O=n13 I1=B[5] I2=A[5]
XU27 ND2 $PINS O=n15 I1=carry[11] I2=A[11]
XU28 ND2P $PINS O=n16 I1=carry[11] I2=B[11]
XU30 XOR2HS $PINS O=n17 I1=A[12] I2=B[12]
XU31 XOR2HS $PINS O=SUM[12] I1=n17 I2=carry[12]
XU32 ND2 $PINS O=n18 I1=A[12] I2=B[12]
XU33 ND2 $PINS O=n19 I1=carry[12] I2=A[12]
XU34 ND2 $PINS O=n20 I1=carry[12] I2=B[12]
XU36 ND2P $PINS O=n22 I1=carry[8] I2=A[8]
XU37 ND2P $PINS O=n23 I1=carry[8] I2=B[8]
XU39 XOR2HS $PINS O=n24 I1=A[9] I2=B[9]
XU40 XOR2HS $PINS O=SUM[9] I1=n24 I2=carry[9]
XU41 ND2 $PINS O=n25 I1=A[9] I2=B[9]
XU42 ND2P $PINS O=n26 I1=carry[9] I2=A[9]
XU43 ND2 $PINS O=n27 I1=carry[9] I2=B[9]
XU44 XOR3S $PINS O=SUM[26] I1=A[26] I2=B[26] I3=carry[26]
XU45 XOR2HS $PINS O=SUM[0] I1=B[0] I2=A[0]
XU1 XOR3 $PINS O=SUM[11] I1=A[11] I2=B[11] I3=carry[11]
XU3 ND3P $PINS O=carry[11] I1=n4 I2=n5 I3=n6
XU4 ND3HT $PINS O=carry[9] I1=n22 I2=n23 I3=n21
XU38 XOR3 $PINS O=SUM[8] I1=A[8] I2=B[8] I3=carry[8]
.ENDS

.SUBCKT PE_Shift_Add_1_DW01_add_0_DW01_add_26 A[26] A[25] A[24] A[23] A[22]
+ A[21] A[20] A[19] A[18] A[17] A[16] A[15] A[14] A[13] A[12] A[11] A[10] A[9]
+ A[8] A[7] A[6] A[5] A[4] A[3] A[2] A[1] A[0] B[26] B[25] B[24] B[23] B[22]
+ B[21] B[20] B[19] B[18] B[17] B[16] B[15] B[14] B[13] B[12] B[11] B[10] B[9]
+ B[8] B[7] B[6] B[5] B[4] B[3] B[2] B[1] B[0] CI SUM[26] SUM[25] SUM[24]
+ SUM[23] SUM[22] SUM[21] SUM[20] SUM[19] SUM[18] SUM[17] SUM[16] SUM[15]
+ SUM[14] SUM[13] SUM[12] SUM[11] SUM[10] SUM[9] SUM[8] SUM[7] SUM[6] SUM[5]
+ SUM[4] SUM[3] SUM[2] SUM[1] SUM[0] CO
XFE_OCPC710_carry_7 BUF1S $PINS O=FE_OCPN710_carry_7 I=carry[7]
XFE_OCPC709_carry_11 BUF1S $PINS O=FE_OCPN709_carry_11 I=carry[11]
XFE_OCPC706_carry_12 BUF1S $PINS O=FE_OCPN706_carry_12 I=carry[12]
XFE_OCPC705_carry_10 BUF1S $PINS O=FE_OCPN705_carry_10 I=carry[10]
XFE_OCPC704_carry_13 BUF1S $PINS O=FE_OCPN704_carry_13 I=carry[13]
XFE_RC_1483_0 XOR2HS $PINS O=FE_RN_338_0 I1=B[26] I2=A[26]
XFE_RC_1482_0 XOR2HS $PINS O=SUM[26] I1=FE_RN_338_0 I2=carry[26]
XFE_RC_1467_0 ND2 $PINS O=FE_RN_331_0 I1=B[1] I2=n4
XFE_RC_1466_0 ND2 $PINS O=FE_RN_332_0 I1=A[1] I2=n4
XFE_RC_1465_0 ND2 $PINS O=FE_RN_333_0 I1=A[1] I2=B[1]
XFE_RC_1464_0 ND3 $PINS O=carry[2] I1=FE_RN_333_0 I2=FE_RN_332_0 I3=FE_RN_331_0
XFE_RC_976_0 XOR3 $PINS O=SUM[20] I1=A[20] I2=B[20] I3=carry[20]
XFE_RC_975_0 MAO222P $PINS O=carry[21] A1=carry[20] B1=B[20] C1=A[20]
XFE_RC_764_0 XOR3 $PINS O=SUM[1] I1=A[1] I2=B[1] I3=n4
XFE_RC_727_0 XOR3 $PINS O=SUM[2] I1=A[2] I2=B[2] I3=carry[2]
XFE_RC_726_0 MAO222P $PINS O=carry[3] A1=carry[2] B1=B[2] C1=A[2]
XFE_RC_661_0 XOR3 $PINS O=SUM[17] I1=A[17] I2=B[17] I3=carry[17]
XFE_RC_660_0 MAO222P $PINS O=carry[18] A1=carry[17] B1=B[17] C1=A[17]
XFE_RC_611_0 XOR3 $PINS O=SUM[14] I1=A[14] I2=B[14] I3=carry[14]
XFE_RC_610_0 MAO222P $PINS O=carry[15] A1=carry[14] B1=B[14] C1=A[14]
XFE_RC_579_0 XOR3 $PINS O=SUM[19] I1=A[19] I2=B[19] I3=carry[19]
XFE_RC_578_0 MAO222P $PINS O=carry[20] A1=carry[19] B1=A[19] C1=B[19]
XFE_RC_424_0 XOR3 $PINS O=SUM[21] I1=A[21] I2=B[21] I3=carry[21]
XFE_RC_423_0 MAO222P $PINS O=carry[22] A1=carry[21] B1=B[21] C1=A[21]
XFE_RC_396_0 XOR3 $PINS O=SUM[18] I1=A[18] I2=B[18] I3=carry[18]
XFE_RC_395_0 MAO222P $PINS O=carry[19] A1=carry[18] B1=B[18] C1=A[18]
XFE_RC_394_0 XOR3 $PINS O=SUM[15] I1=A[15] I2=B[15] I3=carry[15]
XFE_RC_393_0 MAO222P $PINS O=carry[16] A1=carry[15] B1=B[15] C1=A[15]
XFE_RC_286_0 XOR3S $PINS O=SUM[16] I1=A[16] I2=B[16] I3=carry[16]
XFE_RC_285_0 MAO222P $PINS O=carry[17] A1=carry[16] B1=B[16] C1=A[16]
XFE_RC_282_0 XOR3 $PINS O=SUM[5] I1=A[5] I2=B[5] I3=carry[5]
XFE_RC_281_0 MAO222P $PINS O=carry[6] A1=carry[5] B1=B[5] C1=A[5]
XFE_RC_280_0 XOR3 $PINS O=SUM[13] I1=A[13] I2=B[13] I3=FE_OCPN704_carry_13
XFE_RC_279_0 MAO222 $PINS O=carry[14] A1=carry[13] B1=B[13] C1=A[13]
XFE_RC_266_0 ND3P $PINS O=carry[9] I1=n30 I2=n29 I3=n31
XFE_RC_211_0 XOR3 $PINS O=SUM[9] I1=A[9] I2=B[9] I3=carry[9]
XFE_RC_210_0 MAO222P $PINS O=carry[10] A1=carry[9] B1=B[9] C1=A[9]
XFE_RC_179_0 ND3HT $PINS O=carry[11] I1=n13 I2=n12 I3=n14
XFE_RC_156_0 ND3P $PINS O=carry[5] I1=n23 I2=n24 I3=n25
XFE_RC_138_0 XOR3 $PINS O=SUM[7] I1=A[7] I2=B[7] I3=FE_OCPN710_carry_7
XFE_RC_137_0 MAO222P $PINS O=carry[8] A1=carry[7] B1=B[7] C1=A[7]
XFE_RC_108_0 ND3P $PINS O=carry[7] I1=n26 I2=n27 I3=n28
XFE_RC_105_0 ND3P $PINS O=carry[13] I1=n10 I2=n11 I3=n9
XU1_23 FA1S $PINS S=SUM[23] CO=carry[24] A=A[23] B=B[23] CI=carry[23]
XU2 ND2 $PINS O=n14 I1=A[10] I2=B[10]
XU4 ND2 $PINS O=n3 I1=A[22] I2=B[22]
XU5 ND2 $PINS O=n20 I1=A[3] I2=B[3]
XU7 XOR3 $PINS O=SUM[22] I1=A[22] I2=B[22] I3=carry[22]
XU8 ND2P $PINS O=n1 I1=carry[22] I2=A[22]
XU9 ND2P $PINS O=n2 I1=carry[22] I2=B[22]
XU10 ND3P $PINS O=carry[23] I1=n2 I2=n1 I3=n3
XU13 ND2 $PINS O=n5 I1=A[11] I2=B[11]
XU15 XOR3 $PINS O=SUM[6] I1=A[6] I2=B[6] I3=carry[6]
XU16 XOR3 $PINS O=SUM[8] I1=A[8] I2=B[8] I3=carry[8]
XU18 XOR2HS $PINS O=n32 I1=A[24] I2=B[24]
XU19 XOR3 $PINS O=SUM[25] I1=A[25] I2=B[25] I3=carry[25]
XU20 AN2 $PINS O=n4 I1=B[0] I2=A[0]
XU21 ND2P $PINS O=n6 I1=carry[11] I2=A[11]
XU22 ND2P $PINS O=n7 I1=carry[11] I2=B[11]
XU23 ND3P $PINS O=carry[12] I1=n7 I2=n6 I3=n5
XU24 XOR2HS $PINS O=n8 I1=A[12] I2=B[12]
XU25 XOR2HS $PINS O=SUM[12] I1=n8 I2=FE_OCPN706_carry_12
XU26 ND2 $PINS O=n9 I1=A[12] I2=B[12]
XU27 ND2 $PINS O=n10 I1=carry[12] I2=A[12]
XU28 ND2 $PINS O=n11 I1=carry[12] I2=B[12]
XU29 XOR3 $PINS O=SUM[10] I1=B[10] I2=A[10] I3=FE_OCPN705_carry_10
XU30 ND2P $PINS O=n12 I1=carry[10] I2=B[10]
XU31 ND2P $PINS O=n13 I1=carry[10] I2=A[10]
XU33 XOR3S $PINS O=SUM[3] I1=A[3] I2=B[3] I3=carry[3]
XU34 ND2 $PINS O=n15 I1=carry[25] I2=A[25]
XU35 ND2 $PINS O=n16 I1=carry[25] I2=B[25]
XU36 ND2 $PINS O=n17 I1=A[25] I2=B[25]
XU37 ND3 $PINS O=carry[26] I1=n16 I2=n15 I3=n17
XU38 ND2P $PINS O=n18 I1=carry[3] I2=A[3]
XU39 ND2P $PINS O=n19 I1=carry[3] I2=B[3]
XU41 XOR3S $PINS O=SUM[4] I1=A[4] I2=B[4] I3=carry[4]
XU43 MAO222 $PINS O=n22 A1=carry[23] B1=B[23] C1=A[23]
XU44 ND2 $PINS O=n31 I1=A[8] I2=B[8]
XU45 ND2 $PINS O=n33 I1=n22 I2=A[24]
XU46 ND2P $PINS O=n23 I1=carry[4] I2=A[4]
XU47 ND2P $PINS O=n24 I1=carry[4] I2=B[4]
XU48 ND2 $PINS O=n25 I1=A[4] I2=B[4]
XU49 ND2P $PINS O=n26 I1=carry[6] I2=A[6]
XU50 ND2P $PINS O=n27 I1=carry[6] I2=B[6]
XU51 ND2 $PINS O=n28 I1=A[6] I2=B[6]
XU52 ND2P $PINS O=n29 I1=carry[8] I2=A[8]
XU53 ND2P $PINS O=n30 I1=carry[8] I2=B[8]
XU54 XOR2HS $PINS O=SUM[24] I1=carry[24] I2=n32
XU55 ND2 $PINS O=n35 I1=A[24] I2=B[24]
XU56 XOR2HS $PINS O=SUM[0] I1=B[0] I2=A[0]
XU1 ND3HT $PINS O=carry[4] I1=n18 I2=n19 I3=n20
XU3 ND3P $PINS O=carry[25] I1=n33 I2=n34 I3=n35
XU6 ND2 $PINS O=n34 I1=n22 I2=B[24]
XU11 XOR3 $PINS O=SUM[11] I1=A[11] I2=B[11] I3=FE_OCPN709_carry_11
.ENDS

.SUBCKT PE_Shift_Add_1 rst_n en clear calc_done stage_sel x_in[16] x_in[15]
+ x_in[14] x_in[13] x_in[12] x_in[11] x_in[10] x_in[9] x_in[8] x_in[7] x_in[6]
+ x_in[5] x_in[4] x_in[3] x_in[2] x_in[1] x_in[0] sign1[1] sign1[0] sign2[1]
+ sign2[0] sign3[1] sign3[0] shf1[3] shf1[2] shf1[1] shf1[0] shf2[3] shf2[2]
+ shf2[1] shf2[0] shf3[3] shf3[2] shf3[1] shf3[0] y_out[16] y_out[15] y_out[14]
+ y_out[13] y_out[12] y_out[11] y_out[10] y_out[9] y_out[8] y_out[7] y_out[6]
+ y_out[5] y_out[4] y_out[3] y_out[2] y_out[1] y_out[0] i_rst_n
+ FE_OFN20_i_rst_n FE_OFN4_i_rst_n FE_OFN1_i_rst_n FE_OFN31_n FE_OFN67_s32_1
+ FE_OFN72_n clk_clone1 clk
XFE_PHC1314_N235 DELC $PINS O=FE_PHN1314_N235 I=N235
XFE_PHC1310_N245 DELB $PINS O=FE_PHN1310_N245 I=N245
XFE_PHC1297_N246 DELB $PINS O=N246 I=FE_PHN1297_N246
XFE_PHC1293_N249 DELB $PINS O=N249 I=FE_PHN1293_N249
XFE_PHC1287_N247 DELB $PINS O=FE_PHN1287_N247 I=N247
XFE_PHC1278_N244 DELB $PINS O=N244 I=FE_PHN1278_N244
XFE_PHC1273_N248 DELB $PINS O=N248 I=FE_PHN1273_N248
XFE_PHC1258_acc_reg_11 DELB $PINS O=FE_PHN1258_acc_reg_11 I=acc_reg[11]
XFE_PHC1231_acc_reg_16 DELB $PINS O=acc_reg[16] I=FE_PHN1231_acc_reg_16
XFE_PHC1070_next_acc_0 DELA $PINS O=FE_PHN1070_next_acc_0 I=next_acc[0]
XFE_PHC1064_acc_reg_25 DELB $PINS O=FE_PHN1064_acc_reg_25 I=acc_reg[25]
XFE_PHC986_acc_reg_12 DELB $PINS O=FE_PHN986_acc_reg_12 I=acc_reg[12]
XFE_PHC981_N238 DELB $PINS O=FE_PHN981_N238 I=N238
XFE_PHC978_N239 DELB $PINS O=FE_PHN978_N239 I=N239
XFE_PHC974_acc_reg_10 DELB $PINS O=FE_PHN974_acc_reg_10 I=acc_reg[10]
XFE_PHC965_N242 DELB $PINS O=FE_PHN965_N242 I=N242
XFE_PHC948_N243 DELB $PINS O=FE_PHN948_N243 I=N243
XFE_PHC927_acc_reg_15 DELB $PINS O=FE_PHN927_acc_reg_15 I=acc_reg[15]
XFE_PHC845_acc_reg_20 DELB $PINS O=FE_PHN845_acc_reg_20 I=acc_reg[20]
XFE_PHC838_acc_reg_19 DELB $PINS O=FE_PHN838_acc_reg_19 I=acc_reg[19]
XFE_PHC811_N251 DELC $PINS O=FE_PHN811_N251 I=N251
XFE_OCPC715_FE_OFN122_mac_in_real_2 BUF1CK $PINS
+ O=FE_OCPN715_FE_OFN122_mac_in_real_2 I=x_in[2]
XFE_RC_1738_0 INV1S $PINS O=FE_RN_460_0 I=shf2[0]
XFE_RC_1737_0 ND2S $PINS O=FE_RN_461_0 I1=term2_in[2] I2=FE_RN_460_0
XFE_RC_1736_0 ND2S $PINS O=FE_RN_462_0 I1=term2_in[1] I2=shf2[0]
XFE_RC_1735_0 ND2 $PINS O=sll_17/ML_int[1][2] I1=FE_RN_462_0 I2=FE_RN_461_0
XFE_RC_1731_0 ND2 $PINS O=FE_RN_456_0 I1=term3_in[0] I2=shf3[0]
XFE_RC_1730_0 INV1S $PINS O=FE_RN_457_0 I=shf3[0]
XFE_RC_1729_0 ND2 $PINS O=FE_RN_458_0 I1=term3_in[1] I2=FE_RN_457_0
XFE_RC_1728_0 ND2 $PINS O=sll_18/ML_int[1][1] I1=FE_RN_458_0 I2=FE_RN_456_0
XFE_RC_1679_0 ND2 $PINS O=FE_RN_430_0 I1=term1_shifted[4] I2=n41
XFE_RC_1678_0 ND2 $PINS O=FE_RN_431_0 I1=N18 I2=FE_OFN255_s31_0
XFE_RC_1677_0 ND2P $PINS O=N45 I1=FE_RN_431_0 I2=FE_RN_430_0
XFE_RC_1667_0 INV1S $PINS O=FE_RN_425_0 I=FE_OFN255_s31_0
XFE_RC_1666_0 INV1S $PINS O=FE_RN_426_0 I=N15
XFE_RC_1665_0 MOAI1 $PINS O=N42 A1=FE_RN_426_0 A2=FE_RN_425_0 B1=n12 B2=n41
XFE_RC_1608_0 ND2 $PINS O=FE_RN_394_0 I1=term2_shifted[3] I2=FE_DBTN23_s32_0
XFE_RC_1607_0 ND2 $PINS O=FE_RN_395_0 I1=N72 I2=sign2[0]
XFE_RC_1606_0 ND2 $PINS O=N99 I1=FE_RN_395_0 I2=FE_RN_394_0
XFE_RC_1605_0 INV1S $PINS O=FE_RN_393_0 I=shf2[1]
XFE_RC_1604_0 AOI22S $PINS O=n9 A1=sll_17/ML_int[1][0] A2=shf2[1]
+ B1=sll_17/ML_int[1][2] B2=FE_RN_393_0
XFE_RC_1590_0 ND2 $PINS O=FE_RN_383_0 I1=term2_shifted[5] I2=FE_DBTN23_s32_0
XFE_RC_1589_0 ND2 $PINS O=FE_RN_384_0 I1=N74 I2=sign2[0]
XFE_RC_1588_0 ND2P $PINS O=N101 I1=FE_RN_384_0 I2=FE_RN_383_0
XFE_RC_1573_0 ND2 $PINS O=FE_RN_372_0 I1=term1_shifted[2] I2=n41
XFE_RC_1572_0 ND2 $PINS O=FE_RN_373_0 I1=N16 I2=FE_OFN255_s31_0
XFE_RC_1571_0 ND2P $PINS O=N43 I1=FE_RN_373_0 I2=FE_RN_372_0
XCTS_ccl_a_INV_CLK_G1_L8_36 INV3CK $PINS O=CTS_10 I=CTS_11
XCTS_ccl_a_INV_CLK_G1_L7_38 INV2CK $PINS O=CTS_11 I=CTS_12
XFE_OCPC707_n69 BUF1S $PINS O=FE_OCPN707_n69 I=n69
XFE_RC_1436_0 ND2S $PINS O=FE_RN_315_0 I1=n73 I2=shf3[2]
XFE_RC_1435_0 INV1S $PINS O=FE_RN_316_0 I=shf3[2]
XFE_RC_1434_0 ND2 $PINS O=FE_RN_317_0 I1=sll_18/ML_int[2][4] I2=FE_RN_316_0
XFE_RC_1433_0 ND2 $PINS O=sll_18/ML_int[3][4] I1=FE_RN_317_0 I2=FE_RN_315_0
XFE_RC_1399_0 INV1S $PINS O=FE_RN_301_0 I=shf1[0]
XFE_RC_1398_0 ND2S $PINS O=FE_RN_302_0 I1=term1_in[3] I2=FE_RN_301_0
XFE_RC_1397_0 ND2 $PINS O=FE_RN_303_0 I1=term1_in[2] I2=shf1[0]
XFE_RC_1396_0 ND2 $PINS O=sll_16/ML_int[1][3] I1=FE_RN_303_0 I2=FE_RN_302_0
XFE_RC_1382_0 AOI22H $PINS O=FE_RN_270_0 A1=n1 A2=n22 B1=N125 B2=sign3[0]
XFE_RC_1377_0 ND2 $PINS O=FE_RN_294_0 I1=sll_16/ML_int[1][0] I2=FE_OFN216_h31_1
XFE_RC_1376_0 INV1S $PINS O=FE_RN_295_0 I=FE_OFN216_h31_1
XFE_RC_1375_0 ND2 $PINS O=FE_RN_296_0 I1=sll_16/ML_int[1][2] I2=FE_RN_295_0
XFE_RC_1374_0 ND2 $PINS O=sll_16/ML_int[2][2] I1=FE_RN_296_0 I2=FE_RN_294_0
XFE_RC_1319_0 INV2 $PINS O=N152 I=FE_RN_270_0
XFE_RC_1225_0 ND2 $PINS O=FE_RN_228_0 I1=N126 I2=sign3[0]
XFE_RC_1224_0 OR3B1 $PINS O=FE_RN_229_0 I1=n71 I2=n3 B1=n22
XFE_RC_1223_0 ND2 $PINS O=N153 I1=FE_RN_229_0 I2=FE_RN_228_0
XFE_RC_1102_0 INV2 $PINS O=n2 I=FE_RN_177_0
XFE_RC_1101_0 MXL2HS $PINS OB=FE_RN_177_0 S=shf1[0] A=term1_in[1] B=term1_in[0]
XFE_RC_954_0 INV2 $PINS O=sll_17/ML_int[2][3] I=FE_RN_135_0
XFE_RC_953_0 MXL2HS $PINS OB=FE_RN_135_0 S=shf2[1] A=sll_17/ML_int[1][3]
+ B=sll_17/ML_int[1][1]
XFE_RC_930_0 INV2 $PINS O=FE_RN_122_0 I=sll_17/ML_int[2][4]
XFE_RC_929_0 MXL2H $PINS OB=sll_17/ML_int[3][4] S=shf2[2] A=FE_RN_122_0 B=n59
XFE_RC_194_0 ND2 $PINS O=FE_RN_30_0 I1=term2_in[0] I2=shf2[0]
XFE_RC_193_0 INV1S $PINS O=FE_RN_31_0 I=shf2[0]
XFE_RC_192_0 ND2S $PINS O=FE_RN_32_0 I1=term2_in[1] I2=FE_RN_31_0
XFE_RC_191_0 ND2P $PINS O=sll_17/ML_int[1][1] I1=FE_RN_32_0 I2=FE_RN_30_0
XFE_RC_81_0 MOAI1H $PINS O=N97 A1=n11 A2=FE_DBTN23_s32_0 B1=term2_shifted[1]
+ B2=FE_DBTN23_s32_0
XFE_RC_9_0 OA12 $PINS O=N151 A1=N124 B1=sign3[0] B2=n22
XFE_OFC557_h32_2 BUF1 $PINS O=FE_OFN329_h32_2 I=shf2[2]
XFE_OFC549_sll_17_ML_int_2__3 INV2 $PINS O=n62 I=sll_17/ML_int[2][3]
XFE_OFC537_s33_1 BUF1 $PINS O=FE_OFN269_s33_1 I=sign3[1]
XFE_OFC519_s32_0 INV2 $PINS O=FE_DBTN23_s32_0 I=sign2[0]
XFE_OFC516_N14 INV1S $PINS O=N14 I=term1_shifted[0]
XFE_OFC487_h33_0 BUF1 $PINS O=FE_OFN304_h33_0 I=shf3[0]
XFE_OFC471_s32_1 BUF1 $PINS O=FE_OFN288_s32_1 I=sign2[1]
XFE_OFC456_s31_1 BUF1 $PINS O=FE_OFN273_s31_1 I=sign1[1]
XFE_OFC439_s31_0 BUF1 $PINS O=FE_OFN256_s31_0 I=FE_OFN255_s31_0
XFE_OFC438_s31_0 BUF1 $PINS O=FE_OFN255_s31_0 I=sign1[0]
XFE_OFC406_h32_0 INV1S $PINS O=FE_OFN235_h32_0 I=shf2[0]
XFE_OFC405_h32_0 BUF1 $PINS O=n24 I=shf2[0]
XFE_OFC375_h33_1 INV1S $PINS O=FE_OFN225_h33_1 I=n17
XFE_OFC371_h33_1 BUF1 $PINS O=n17 I=shf3[1]
XFE_OFC356_h31_1 INV1S $PINS O=FE_OFN216_h31_1 I=n34
XFE_OFC353_h31_1 INV1S $PINS O=n34 I=shf1[1]
XFE_OFC334_h31_0 BUF1 $PINS O=FE_OFN207_h31_0 I=shf1[0]
XFE_OFC327_h32_1 BUF1 $PINS O=FE_OFN204_h32_1 I=shf2[1]
XFE_OFC325_h32_1 INV1S $PINS O=n25 I=shf2[1]
XFE_OFC319_h33_2 BUF1 $PINS O=FE_OFN201_h33_2 I=shf3[2]
XFE_OFC267_h32_3 INV1S $PINS O=FE_OFN186_h32_3 I=n27
XFE_OFC264_h32_3 INV1S $PINS O=n27 I=shf2[3]
XFE_OFC233_s32_0 INV1S $PINS O=FE_OFN169_s32_0 I=FE_DBTN23_s32_0
XFE_OFC228_h33_3 INV1S $PINS O=FE_OFN166_h33_3 I=n19
XFE_OFC226_h33_3 INV1S $PINS O=n19 I=shf3[3]
XFE_OFC208_h31_2 INV1S $PINS O=n36 I=shf1[2]
XFE_OFC205_h31_3 INV1S $PINS O=n38 I=shf1[3]
XFE_OFC189_s33_0 INV1S $PINS O=FE_OFN151_s33_0 I=n22
XFE_OFC187_s33_0 INV2 $PINS O=n22 I=sign3[0]
XFE_OFC143_s31_0 INV2 $PINS O=n41 I=FE_OFN255_s31_0
XU110 AO22 $PINS O=base_val[13] A1=acc_reg[13] A2=FE_OFN72_n B1=clear
+ B2=stage_sel
XU138 AO22P $PINS O=N44 A1=N17 A2=FE_OFN255_s31_0 B1=term1_shifted[3] B2=n41
XU142 AO22 $PINS O=N177 A1=FE_OFN151_s33_0 A2=N150 B1=term3_shifted[26] B2=n22
XU143 AO22 $PINS O=N176 A1=N149 A2=FE_OFN151_s33_0 B1=term3_shifted[25] B2=n22
XU144 AO22 $PINS O=N175 A1=N148 A2=FE_OFN151_s33_0 B1=term3_shifted[24] B2=n22
XU145 AO22 $PINS O=N174 A1=N147 A2=FE_OFN151_s33_0 B1=term3_shifted[23] B2=n22
XU146 AO22 $PINS O=N173 A1=N146 A2=FE_OFN151_s33_0 B1=term3_shifted[22] B2=n22
XU147 AO22 $PINS O=N172 A1=N145 A2=FE_OFN151_s33_0 B1=term3_shifted[21] B2=n22
XU148 AO22 $PINS O=N171 A1=N144 A2=FE_OFN151_s33_0 B1=term3_shifted[20] B2=n22
XU149 AO22 $PINS O=N170 A1=N143 A2=FE_OFN151_s33_0 B1=term3_shifted[19] B2=n22
XU150 AO22 $PINS O=N169 A1=N142 A2=FE_OFN151_s33_0 B1=term3_shifted[18] B2=n22
XU151 AO22 $PINS O=N168 A1=N141 A2=FE_OFN151_s33_0 B1=term3_shifted[17] B2=n22
XU152 AO22 $PINS O=N167 A1=N140 A2=FE_OFN151_s33_0 B1=term3_shifted[16] B2=n22
XU153 AO22 $PINS O=N166 A1=N139 A2=FE_OFN151_s33_0 B1=term3_shifted[15] B2=n22
XU154 AO22 $PINS O=N165 A1=N138 A2=FE_OFN151_s33_0 B1=term3_shifted[14] B2=n22
XU155 AO22 $PINS O=N164 A1=N137 A2=FE_OFN151_s33_0 B1=term3_shifted[13] B2=n22
XU156 AO22 $PINS O=N163 A1=N136 A2=FE_OFN151_s33_0 B1=term3_shifted[12] B2=n22
XU157 AO22 $PINS O=N162 A1=N135 A2=FE_OFN151_s33_0 B1=term3_shifted[11] B2=n22
XU158 AO22 $PINS O=N161 A1=N134 A2=FE_OFN151_s33_0 B1=term3_shifted[10] B2=n22
XU159 AO22 $PINS O=N160 A1=N133 A2=FE_OFN151_s33_0 B1=term3_shifted[9] B2=n22
XU160 AO22 $PINS O=N159 A1=N132 A2=FE_OFN151_s33_0 B1=term3_shifted[8] B2=n22
XU162 AO22 $PINS O=N157 A1=N130 A2=sign3[0] B1=term3_shifted[6] B2=n22
XU164 AO22P $PINS O=N155 A1=N128 A2=sign3[0] B1=term3_shifted[4] B2=n22
XU165 AO22 $PINS O=N154 A1=N127 A2=sign3[0] B1=term3_shifted[3] B2=n22
XU169 AO22 $PINS O=N122 A1=N95 A2=FE_OFN169_s32_0 B1=term2_shifted[26]
+ B2=FE_DBTN23_s32_0
XU170 AO22 $PINS O=N121 A1=N94 A2=FE_OFN169_s32_0 B1=term2_shifted[25]
+ B2=FE_DBTN23_s32_0
XU171 AO22 $PINS O=N120 A1=N93 A2=FE_OFN169_s32_0 B1=term2_shifted[24]
+ B2=FE_DBTN23_s32_0
XU172 AO22 $PINS O=N119 A1=N92 A2=FE_OFN169_s32_0 B1=term2_shifted[23]
+ B2=FE_DBTN23_s32_0
XU174 AO22 $PINS O=N117 A1=N90 A2=FE_OFN169_s32_0 B1=term2_shifted[21]
+ B2=FE_DBTN23_s32_0
XU175 AO22 $PINS O=N116 A1=N89 A2=FE_OFN169_s32_0 B1=term2_shifted[20]
+ B2=FE_DBTN23_s32_0
XU176 AO22 $PINS O=N115 A1=N88 A2=FE_OFN169_s32_0 B1=term2_shifted[19]
+ B2=FE_DBTN23_s32_0
XU177 AO22 $PINS O=N114 A1=N87 A2=FE_OFN169_s32_0 B1=term2_shifted[18]
+ B2=FE_DBTN23_s32_0
XU178 AO22 $PINS O=N113 A1=N86 A2=FE_OFN169_s32_0 B1=term2_shifted[17]
+ B2=FE_DBTN23_s32_0
XU179 AO22 $PINS O=N112 A1=N85 A2=FE_OFN169_s32_0 B1=term2_shifted[16]
+ B2=FE_DBTN23_s32_0
XU180 AO22 $PINS O=N111 A1=N84 A2=FE_OFN169_s32_0 B1=term2_shifted[15]
+ B2=FE_DBTN23_s32_0
XU181 AO22 $PINS O=N110 A1=N83 A2=FE_OFN169_s32_0 B1=term2_shifted[14]
+ B2=FE_DBTN23_s32_0
XU183 AO22 $PINS O=N108 A1=N81 A2=FE_OFN169_s32_0 B1=term2_shifted[12]
+ B2=FE_DBTN23_s32_0
XU184 AO22 $PINS O=N107 A1=N80 A2=FE_OFN169_s32_0 B1=term2_shifted[11]
+ B2=FE_DBTN23_s32_0
XU185 AO22 $PINS O=N106 A1=N79 A2=FE_OFN169_s32_0 B1=term2_shifted[10]
+ B2=FE_DBTN23_s32_0
XU186 AO22 $PINS O=N105 A1=N78 A2=sign2[0] B1=term2_shifted[9]
+ B2=FE_DBTN23_s32_0
XU187 AO22 $PINS O=N104 A1=N77 A2=sign2[0] B1=term2_shifted[8]
+ B2=FE_DBTN23_s32_0
XU188 AO22P $PINS O=N103 A1=N76 A2=sign2[0] B1=term2_shifted[7]
+ B2=FE_DBTN23_s32_0
XU189 AO22 $PINS O=N102 A1=N75 A2=sign2[0] B1=term2_shifted[6]
+ B2=FE_DBTN23_s32_0
XU191 AO22P $PINS O=N100 A1=N73 A2=sign2[0] B1=term2_shifted[4]
+ B2=FE_DBTN23_s32_0
Xsll_18/M1_0_3 MUX2 $PINS O=sll_18/ML_int[1][3] S=shf3[0] A=term3_in[3]
+ B=term3_in[2]
Xsll_18/M1_0_4 MUX2 $PINS O=sll_18/ML_int[1][4] S=FE_OFN304_h33_0 A=term3_in[4]
+ B=term3_in[3]
Xsll_18/M1_0_5 MUX2 $PINS O=sll_18/ML_int[1][5] S=FE_OFN304_h33_0 A=term3_in[5]
+ B=term3_in[4]
Xsll_18/M1_0_6 MUX2 $PINS O=sll_18/ML_int[1][6] S=FE_OFN304_h33_0 A=term3_in[6]
+ B=term3_in[5]
Xsll_18/M1_1_4 MUX2 $PINS O=sll_18/ML_int[2][4] S=n17 A=sll_18/ML_int[1][4]
+ B=sll_18/ML_int[1][2]
Xsll_18/M1_1_5 MUX2 $PINS O=sll_18/ML_int[2][5] S=n17 A=sll_18/ML_int[1][5]
+ B=sll_18/ML_int[1][3]
Xsll_18/M1_1_6 MUX2 $PINS O=sll_18/ML_int[2][6] S=n17 A=sll_18/ML_int[1][6]
+ B=sll_18/ML_int[1][4]
Xsll_18/M1_1_7 MUX2 $PINS O=sll_18/ML_int[2][7] S=n17 A=sll_18/ML_int[1][7]
+ B=sll_18/ML_int[1][5]
Xsll_18/M1_2_5 MUX2 $PINS O=sll_18/ML_int[3][5] S=shf3[2] A=sll_18/ML_int[2][5]
+ B=n74
Xsll_18/M1_2_6 MUX2 $PINS O=sll_18/ML_int[3][6] S=shf3[2] A=sll_18/ML_int[2][6]
+ B=n5
Xsll_18/M1_2_7 MUX2 $PINS O=sll_18/ML_int[3][7] S=shf3[2] A=sll_18/ML_int[2][7]
+ B=sll_18/ML_int[2][3]
Xsll_18/M1_2_8 MUX2 $PINS O=sll_18/ML_int[3][8] S=shf3[2] A=sll_18/ML_int[2][8]
+ B=sll_18/ML_int[2][4]
Xsll_18/M1_2_9 MUX2 $PINS O=sll_18/ML_int[3][9] S=shf3[2] A=sll_18/ML_int[2][9]
+ B=sll_18/ML_int[2][5]
Xsll_18/M1_3_8 MUX2 $PINS O=term3_shifted[8] S=FE_OFN166_h33_3
+ A=sll_18/ML_int[3][8] B=sll_18/ML_int[3][0]
Xsll_18/M1_3_9 MUX2 $PINS O=term3_shifted[9] S=FE_OFN166_h33_3
+ A=sll_18/ML_int[3][9] B=sll_18/ML_int[3][1]
Xsll_18/M1_3_10 MUX2 $PINS O=term3_shifted[10] S=FE_OFN166_h33_3
+ A=sll_18/ML_int[3][10] B=sll_18/ML_int[3][2]
Xsll_18/M1_3_11 MUX2 $PINS O=term3_shifted[11] S=FE_OFN166_h33_3
+ A=sll_18/ML_int[3][11] B=sll_18/ML_int[3][3]
Xsll_18/M1_3_12 MUX2 $PINS O=term3_shifted[12] S=FE_OFN166_h33_3
+ A=sll_18/ML_int[3][12] B=sll_18/ML_int[3][4]
Xsll_18/M1_3_13 MUX2 $PINS O=term3_shifted[13] S=FE_OFN166_h33_3
+ A=sll_18/ML_int[3][13] B=sll_18/ML_int[3][5]
Xsll_18/M1_3_23 MUX2 $PINS O=term3_shifted[23] S=FE_OFN166_h33_3 A=term3_in[26]
+ B=sll_18/ML_int[3][15]
Xsll_17/M1_0_3 MUX2 $PINS O=sll_17/ML_int[1][3] S=shf2[0] A=term2_in[3]
+ B=term2_in[2]
Xsll_17/M1_1_6 MUX2 $PINS O=sll_17/ML_int[2][6] S=FE_OFN204_h32_1
+ A=sll_17/ML_int[1][6] B=sll_17/ML_int[1][4]
Xsll_17/M1_1_7 MUX2 $PINS O=sll_17/ML_int[2][7] S=FE_OFN204_h32_1
+ A=sll_17/ML_int[1][7] B=sll_17/ML_int[1][5]
Xsll_17/M1_2_5 MUX2 $PINS O=sll_17/ML_int[3][5] S=shf2[2] A=sll_17/ML_int[2][5]
+ B=n64
Xsll_17/M1_2_7 MUX2 $PINS O=sll_17/ML_int[3][7] S=shf2[2] A=sll_17/ML_int[2][7]
+ B=sll_17/ML_int[2][3]
Xsll_17/M1_2_8 MUX2 $PINS O=sll_17/ML_int[3][8] S=shf2[2] A=sll_17/ML_int[2][8]
+ B=sll_17/ML_int[2][4]
Xsll_17/M1_2_9 MUX2 $PINS O=sll_17/ML_int[3][9] S=FE_OFN329_h32_2
+ A=sll_17/ML_int[2][9] B=sll_17/ML_int[2][5]
Xsll_17/M1_3_8 MUX2 $PINS O=term2_shifted[8] S=FE_OFN186_h32_3
+ A=sll_17/ML_int[3][8] B=sll_17/ML_int[3][0]
Xsll_17/M1_3_9 MUX2 $PINS O=term2_shifted[9] S=FE_OFN186_h32_3
+ A=sll_17/ML_int[3][9] B=sll_17/ML_int[3][1]
Xsll_17/M1_3_10 MUX2 $PINS O=term2_shifted[10] S=FE_OFN186_h32_3
+ A=sll_17/ML_int[3][10] B=sll_17/ML_int[3][2]
Xsll_17/M1_3_11 MUX2 $PINS O=term2_shifted[11] S=FE_OFN186_h32_3
+ A=sll_17/ML_int[3][11] B=sll_17/ML_int[3][3]
Xsll_17/M1_3_12 MUX2 $PINS O=term2_shifted[12] S=FE_OFN186_h32_3
+ A=sll_17/ML_int[3][12] B=sll_17/ML_int[3][4]
Xsll_17/M1_3_13 MUX2 $PINS O=term2_shifted[13] S=FE_OFN186_h32_3
+ A=sll_17/ML_int[3][13] B=sll_17/ML_int[3][5]
Xsll_17/M1_3_23 MUX2 $PINS O=term2_shifted[23] S=FE_OFN186_h32_3 A=term2_in[26]
+ B=sll_17/ML_int[3][15]
Xsll_16/M1_0_4 MUX2 $PINS O=sll_16/ML_int[1][4] S=shf1[0] A=term1_in[4]
+ B=term1_in[3]
Xsll_16/M1_0_5 MUX2 $PINS O=sll_16/ML_int[1][5] S=shf1[0] A=term1_in[5]
+ B=term1_in[4]
Xsll_16/M1_0_6 MUX2 $PINS O=sll_16/ML_int[1][6] S=FE_OFN207_h31_0 A=term1_in[6]
+ B=term1_in[5]
Xsll_16/M1_0_7 MUX2 $PINS O=sll_16/ML_int[1][7] S=FE_OFN207_h31_0 A=term1_in[7]
+ B=term1_in[6]
Xsll_16/M1_1_3 MUX2 $PINS O=sll_16/ML_int[2][3] S=FE_OFN216_h31_1
+ A=sll_16/ML_int[1][3] B=n2
Xsll_16/M1_1_4 MUX2 $PINS O=sll_16/ML_int[2][4] S=FE_OFN216_h31_1
+ A=sll_16/ML_int[1][4] B=sll_16/ML_int[1][2]
Xsll_16/M1_1_5 MUX2 $PINS O=sll_16/ML_int[2][5] S=FE_OFN216_h31_1
+ A=sll_16/ML_int[1][5] B=sll_16/ML_int[1][3]
Xsll_16/M1_1_6 MUX2 $PINS O=sll_16/ML_int[2][6] S=FE_OFN216_h31_1
+ A=sll_16/ML_int[1][6] B=sll_16/ML_int[1][4]
Xsll_16/M1_1_7 MUX2 $PINS O=sll_16/ML_int[2][7] S=FE_OFN216_h31_1
+ A=sll_16/ML_int[1][7] B=sll_16/ML_int[1][5]
Xsll_16/M1_1_8 MUX2 $PINS O=sll_16/ML_int[2][8] S=FE_OFN216_h31_1
+ A=sll_16/ML_int[1][8] B=sll_16/ML_int[1][6]
Xsll_16/M1_2_4 MUX2 $PINS O=sll_16/ML_int[3][4] S=n36 A=sll_16/ML_int[2][4]
+ B=n53
Xsll_16/M1_2_5 MUX2 $PINS O=sll_16/ML_int[3][5] S=n36 A=sll_16/ML_int[2][5]
+ B=n54
Xsll_16/M1_2_7 MUX2 $PINS O=sll_16/ML_int[3][7] S=n36 A=sll_16/ML_int[2][7]
+ B=sll_16/ML_int[2][3]
Xsll_16/M1_2_8 MUX2 $PINS O=sll_16/ML_int[3][8] S=n36 A=sll_16/ML_int[2][8]
+ B=sll_16/ML_int[2][4]
Xsll_16/M1_2_9 MUX2 $PINS O=sll_16/ML_int[3][9] S=n36 A=sll_16/ML_int[2][9]
+ B=sll_16/ML_int[2][5]
Xsll_16/M1_2_10 MUX2 $PINS O=sll_16/ML_int[3][10] S=n36 A=sll_16/ML_int[2][10]
+ B=sll_16/ML_int[2][6]
Xsll_16/M1_3_8 MUX2 $PINS O=term1_shifted[8] S=n38 A=sll_16/ML_int[3][8]
+ B=sll_16/ML_int[3][0]
Xsll_16/M1_3_9 MUX2 $PINS O=term1_shifted[9] S=n38 A=sll_16/ML_int[3][9]
+ B=sll_16/ML_int[3][1]
Xsll_16/M1_3_10 MUX2 $PINS O=term1_shifted[10] S=n38 A=sll_16/ML_int[3][10]
+ B=sll_16/ML_int[3][2]
Xsll_16/M1_3_11 MUX2 $PINS O=term1_shifted[11] S=n38 A=sll_16/ML_int[3][11]
+ B=sll_16/ML_int[3][3]
Xsll_16/M1_3_12 MUX2 $PINS O=term1_shifted[12] S=n38 A=sll_16/ML_int[3][12]
+ B=sll_16/ML_int[3][4]
Xsll_16/M1_3_13 MUX2 $PINS O=term1_shifted[13] S=n38 A=sll_16/ML_int[3][13]
+ B=sll_16/ML_int[3][5]
Xsll_16/M1_3_14 MUX2 $PINS O=term1_shifted[14] S=n38 A=sll_16/ML_int[3][14]
+ B=sll_16/ML_int[3][6]
Xsll_16/M1_3_23 MUX2 $PINS O=term1_shifted[23] S=n38 A=term1_in[26]
+ B=sll_16/ML_int[3][15]
Xy_out_reg[9] QDFFRBN $PINS Q=y_out[9] D=N244 CK=CTS_10 RB=FE_OFN31_n
Xy_out_reg[8] QDFFRBN $PINS Q=y_out[8] D=FE_PHN948_N243 CK=CTS_10 RB=FE_OFN31_n
Xy_out_reg[7] QDFFRBN $PINS Q=y_out[7] D=FE_PHN965_N242 CK=CTS_10 RB=FE_OFN31_n
Xy_out_reg[6] QDFFRBN $PINS Q=y_out[6] D=N241 CK=CTS_10 RB=FE_OFN31_n
Xy_out_reg[5] QDFFRBN $PINS Q=y_out[5] D=N240 CK=CTS_10 RB=FE_OFN31_n
Xy_out_reg[4] QDFFRBN $PINS Q=y_out[4] D=FE_PHN978_N239 CK=CTS_10 RB=FE_OFN31_n
Xy_out_reg[3] QDFFRBN $PINS Q=y_out[3] D=FE_PHN981_N238 CK=CTS_10 RB=FE_OFN31_n
Xy_out_reg[2] QDFFRBN $PINS Q=y_out[2] D=N237 CK=CTS_10 RB=FE_OFN31_n
Xy_out_reg[1] QDFFRBN $PINS Q=y_out[1] D=N236 CK=CTS_10 RB=FE_OFN20_i_rst_n
Xy_out_reg[0] QDFFRBN $PINS Q=y_out[0] D=FE_PHN1314_N235 CK=CTS_10
+ RB=FE_OFN1_i_rst_n
Xy_out_reg[16] QDFFRBN $PINS Q=y_out[16] D=FE_PHN811_N251 CK=CTS_10
+ RB=FE_OFN31_n
Xy_out_reg[10] QDFFRBN $PINS Q=y_out[10] D=FE_PHN1310_N245 CK=CTS_10 RB=i_rst_n
Xy_out_reg[11] QDFFRBN $PINS Q=y_out[11] D=N246 CK=CTS_10 RB=FE_OFN31_n
Xy_out_reg[12] QDFFRBN $PINS Q=y_out[12] D=FE_PHN1287_N247 CK=CTS_10
+ RB=FE_OFN31_n
Xy_out_reg[14] QDFFRBN $PINS Q=y_out[14] D=N249 CK=CTS_10 RB=i_rst_n
Xy_out_reg[15] QDFFRBN $PINS Q=y_out[15] D=N250 CK=CTS_10 RB=i_rst_n
Xy_out_reg[13] QDFFRBN $PINS Q=y_out[13] D=N248 CK=CTS_10 RB=FE_OFN31_n
Xacc_reg_reg[25] QDFFRBN $PINS Q=acc_reg[25] D=next_acc[25] CK=clk RB=i_rst_n
Xacc_reg_reg[24] QDFFRBN $PINS Q=acc_reg[24] D=next_acc[24] CK=clk RB=i_rst_n
Xacc_reg_reg[23] QDFFRBN $PINS Q=acc_reg[23] D=next_acc[23] CK=clk
+ RB=FE_OFN31_n
Xacc_reg_reg[22] QDFFRBN $PINS Q=acc_reg[22] D=next_acc[22] CK=clk
+ RB=FE_OFN31_n
Xacc_reg_reg[21] QDFFRBN $PINS Q=acc_reg[21] D=next_acc[21] CK=clk
+ RB=FE_OFN31_n
Xacc_reg_reg[20] QDFFRBN $PINS Q=acc_reg[20] D=next_acc[20] CK=clk
+ RB=FE_OFN20_i_rst_n
Xacc_reg_reg[19] QDFFRBN $PINS Q=acc_reg[19] D=next_acc[19] CK=clk
+ RB=FE_OFN20_i_rst_n
Xacc_reg_reg[18] QDFFRBN $PINS Q=acc_reg[18] D=next_acc[18] CK=clk
+ RB=FE_OFN1_i_rst_n
Xacc_reg_reg[17] QDFFRBN $PINS Q=acc_reg[17] D=next_acc[17] CK=clk
+ RB=FE_OFN1_i_rst_n
Xacc_reg_reg[16] QDFFRBN $PINS Q=FE_PHN1231_acc_reg_16 D=next_acc[16] CK=clk
+ RB=FE_OFN1_i_rst_n
Xacc_reg_reg[15] QDFFRBN $PINS Q=acc_reg[15] D=next_acc[15] CK=clk
+ RB=FE_OFN1_i_rst_n
Xacc_reg_reg[14] QDFFRBN $PINS Q=acc_reg[14] D=next_acc[14] CK=clk
+ RB=FE_OFN1_i_rst_n
Xacc_reg_reg[13] QDFFRBN $PINS Q=acc_reg[13] D=next_acc[13] CK=clk
+ RB=FE_OFN1_i_rst_n
Xacc_reg_reg[12] QDFFRBN $PINS Q=acc_reg[12] D=next_acc[12] CK=clk
+ RB=FE_OFN1_i_rst_n
Xacc_reg_reg[11] QDFFRBN $PINS Q=acc_reg[11] D=next_acc[11] CK=clk
+ RB=FE_OFN1_i_rst_n
Xacc_reg_reg[10] QDFFRBN $PINS Q=acc_reg[10] D=next_acc[10] CK=clk
+ RB=FE_OFN1_i_rst_n
Xacc_reg_reg[9] QDFFRBN $PINS Q=acc_reg[9] D=next_acc[9] CK=clk
+ RB=FE_OFN1_i_rst_n
Xacc_reg_reg[8] QDFFRBN $PINS Q=acc_reg[8] D=next_acc[8] CK=clk
+ RB=FE_OFN1_i_rst_n
Xacc_reg_reg[7] QDFFRBN $PINS Q=acc_reg[7] D=next_acc[7] CK=clk
+ RB=FE_OFN1_i_rst_n
Xacc_reg_reg[6] QDFFRBN $PINS Q=acc_reg[6] D=next_acc[6] CK=clk
+ RB=FE_OFN1_i_rst_n
Xacc_reg_reg[5] QDFFRBN $PINS Q=acc_reg[5] D=next_acc[5] CK=clk
+ RB=FE_OFN1_i_rst_n
Xacc_reg_reg[4] QDFFRBN $PINS Q=acc_reg[4] D=next_acc[4] CK=clk
+ RB=FE_OFN1_i_rst_n
Xacc_reg_reg[3] QDFFRBN $PINS Q=acc_reg[3] D=next_acc[3] CK=clk
+ RB=FE_OFN1_i_rst_n
Xacc_reg_reg[2] QDFFRBN $PINS Q=acc_reg[2] D=next_acc[2] CK=clk
+ RB=FE_OFN1_i_rst_n
Xacc_reg_reg[0] QDFFRBN $PINS Q=acc_reg[0] D=FE_PHN1070_next_acc_0 CK=clk
+ RB=FE_OFN4_i_rst_n
Xacc_reg_reg[1] QDFFRBN $PINS Q=acc_reg[1] D=next_acc[1] CK=clk
+ RB=FE_OFN4_i_rst_n
Xacc_reg_reg[26] QDFFRBP $PINS Q=N251 D=next_acc[26] CK=clk RB=i_rst_n
XU16 NR2P $PINS O=term2_shifted[0] I1=n61 I2=n59
XU19 ND3P $PINS O=n59 I1=term2_in[0] I2=FE_OFN235_h32_0 I3=n25
XU20 OR2 $PINS O=n61 I1=shf2[2] I2=shf2[3]
XU21 MUX2 $PINS O=FE_PHN1273_N248 S=stage_sel A=acc_reg[23] B=FE_PHN811_N251
XU22 AN4B1S $PINS O=term1_shifted[0] I1=term1_in[0] I2=FE_RN_301_0 I3=n34
+ B1=n50
XU23 OR2 $PINS O=n71 I1=shf3[2] I2=shf3[3]
XU25 MUX2 $PINS O=N250 S=stage_sel A=FE_PHN1064_acc_reg_25 B=FE_PHN811_N251
XU26 NR2 $PINS O=term2_in[3] I1=sign2[1] I2=x_in[3]
XU27 NR2 $PINS O=n4 I1=shf3[0] I2=n17
XU28 ND2 $PINS O=n48 I1=sll_16/ML_int[1][0] I2=n34
XU29 MUX2 $PINS O=FE_PHN1293_N249 S=stage_sel A=acc_reg[24] B=FE_PHN811_N251
XU30 NR2 $PINS O=term1_in[1] I1=sign1[1] I2=x_in[1]
XU31 NR2 $PINS O=term2_in[2] I1=FE_OFN67_s32_1 I2=x_in[2]
XU32 NR2 $PINS O=term3_shifted[2] I1=n71 I2=n3
XU33 MUX2 $PINS O=N247 S=stage_sel A=acc_reg[22] B=FE_PHN811_N251
XU34 NR2P $PINS O=term1_in[0] I1=sign1[1] I2=x_in[0]
XU37 AN2 $PINS O=sll_16/ML_int[1][0] I1=term1_in[0] I2=FE_RN_301_0
XU38 AN2 $PINS O=sll_17/ML_int[1][0] I1=term2_in[0] I2=FE_OFN235_h32_0
XU39 MOAI1 $PINS O=N41 A1=N14 A2=FE_OFN255_s31_0 B1=term1_shifted[0]
+ B2=FE_OFN255_s31_0
XU41 AN2 $PINS O=n1 I1=sll_18/ML_int[1][1] I2=n6
XU48 MUX2 $PINS O=sll_17/ML_int[2][4] S=shf2[1] A=sll_17/ML_int[1][4]
+ B=sll_17/ML_int[1][2]
XU49 MUX2 $PINS O=sll_17/ML_int[2][5] S=FE_OFN204_h32_1 A=sll_17/ML_int[1][5]
+ B=sll_17/ML_int[1][3]
XU53 MUX2S $PINS O=n68 S=n24 A=term2_in[26] B=term2_in[15]
XU54 MUX2S $PINS O=sll_17/ML_int[1][6] S=n24 A=term2_in[6] B=term2_in[5]
XU56 AO22 $PINS O=N67 A1=FE_OFN256_s31_0 A2=N40 B1=term1_shifted[26] B2=n41
XU57 AO22S $PINS O=N66 A1=N39 A2=FE_OFN256_s31_0 B1=term1_shifted[25] B2=n41
XU58 AO22S $PINS O=N65 A1=N38 A2=FE_OFN256_s31_0 B1=term1_shifted[24] B2=n41
XU59 AO22S $PINS O=N64 A1=N37 A2=FE_OFN256_s31_0 B1=term1_shifted[23] B2=n41
XU60 AO22S $PINS O=N63 A1=N36 A2=FE_OFN256_s31_0 B1=term1_shifted[22] B2=n41
XU61 AO22S $PINS O=N62 A1=N35 A2=FE_OFN256_s31_0 B1=term1_shifted[21] B2=n41
XU62 AO22S $PINS O=N61 A1=N34 A2=FE_OFN256_s31_0 B1=term1_shifted[20] B2=n41
XU63 AO22 $PINS O=N60 A1=N33 A2=FE_OFN256_s31_0 B1=term1_shifted[19] B2=n41
XU64 AO22 $PINS O=N59 A1=N32 A2=FE_OFN256_s31_0 B1=term1_shifted[18] B2=n41
XU65 AO22 $PINS O=N58 A1=N31 A2=FE_OFN256_s31_0 B1=term1_shifted[17] B2=n41
XU66 AO22 $PINS O=N57 A1=N30 A2=FE_OFN256_s31_0 B1=term1_shifted[16] B2=n41
XU67 AO22 $PINS O=N56 A1=N29 A2=FE_OFN256_s31_0 B1=term1_shifted[15] B2=n41
XU68 AO22 $PINS O=N55 A1=N28 A2=FE_OFN256_s31_0 B1=term1_shifted[14] B2=n41
XU69 AO22 $PINS O=N54 A1=N27 A2=FE_OFN255_s31_0 B1=term1_shifted[13] B2=n41
XU70 AO22 $PINS O=N53 A1=N26 A2=FE_OFN255_s31_0 B1=term1_shifted[12] B2=n41
XU71 AO22 $PINS O=N52 A1=N25 A2=FE_OFN255_s31_0 B1=term1_shifted[11] B2=n41
XU72 AO22 $PINS O=N51 A1=N24 A2=FE_OFN255_s31_0 B1=term1_shifted[10] B2=n41
XU73 AO22 $PINS O=N50 A1=N23 A2=FE_OFN255_s31_0 B1=term1_shifted[9] B2=n41
XU74 AO22 $PINS O=N49 A1=N22 A2=FE_OFN255_s31_0 B1=term1_shifted[8] B2=n41
XU75 AO22 $PINS O=N47 A1=N20 A2=FE_OFN255_s31_0 B1=term1_shifted[6] B2=n41
XU78 NR2 $PINS O=term3_in[1] I1=sign3[1] I2=x_in[1]
XU79 NR2 $PINS O=term2_in[1] I1=sign2[1] I2=x_in[1]
XU83 AN2 $PINS O=sll_18/ML_int[1][0] I1=term3_in[0] I2=n16
XU86 NR2 $PINS O=term3_in[2] I1=sign3[1] I2=x_in[2]
XU88 ND2P $PINS O=n49 I1=n2 I2=n34
XU89 ND2 $PINS O=n60 I1=sll_17/ML_int[1][1] I2=n25
XU90 INV2 $PINS O=n51 I=sll_16/ML_int[2][3]
XU91 INV2 $PINS O=n11 I=N70
XU92 AO22P $PINS O=N98 A1=N71 A2=sign2[0] B1=term2_shifted[2]
+ B2=FE_DBTN23_s32_0
XU97 MXL2HS $PINS OB=n3 S=n17 A=sll_18/ML_int[1][2] B=sll_18/ML_int[1][0]
XU99 INV1S $PINS O=n16 I=shf3[0]
XU104 MUX2S $PINS O=sll_17/ML_int[2][2] S=shf2[1] A=sll_17/ML_int[1][2]
+ B=sll_17/ML_int[1][0]
XU105 INV1S $PINS O=n5 I=n3
XU106 MUX2S $PINS O=sll_16/ML_int[3][6] S=n36 A=sll_16/ML_int[2][6]
+ B=sll_16/ML_int[2][2]
XU108 NR2 $PINS O=n6 I1=n71 I2=n17
XU109 MUX2 $PINS O=sll_18/ML_int[2][3] S=n17 A=sll_18/ML_int[1][3]
+ B=sll_18/ML_int[1][1]
XU112 NR2 $PINS O=n7 I1=n61 I2=shf2[1]
XU113 MUX2S $PINS O=sll_17/ML_int[1][5] S=n24 A=term2_in[5] B=term2_in[4]
XU115 MUX2S $PINS O=sll_17/ML_int[3][6] S=shf2[2] A=sll_17/ML_int[2][6]
+ B=sll_17/ML_int[2][2]
XU116 MUX2 $PINS O=sll_18/ML_int[1][2] S=shf3[0] A=term3_in[2] B=term3_in[1]
XU117 AO22S $PINS O=N118 A1=N91 A2=FE_OFN169_s32_0 B1=term2_shifted[22]
+ B2=FE_DBTN23_s32_0
XU119 AO22 $PINS O=N156 A1=N129 A2=sign3[0] B1=term3_shifted[5] B2=n22
XU120 AO22 $PINS O=N46 A1=N19 A2=FE_OFN255_s31_0 B1=term1_shifted[5] B2=n41
XU121 AO22 $PINS O=N48 A1=N21 A2=FE_OFN255_s31_0 B1=term1_shifted[7] B2=n41
XU122 AO22 $PINS O=N158 A1=N131 A2=FE_OFN151_s33_0 B1=term3_shifted[7] B2=n22
XU125 INV1S $PINS O=n73 I=FE_OCPN707_n69
XU126 ND2S $PINS O=n70 I1=sll_18/ML_int[1][1] I2=FE_OFN225_h33_1
XU127 MUX2S $PINS O=sll_18/ML_int[1][7] S=FE_OFN304_h33_0 A=term3_in[7]
+ B=term3_in[6]
XU128 MUX2S $PINS O=sll_17/ML_int[1][7] S=n24 A=term2_in[7] B=term2_in[6]
XU129 MUX2S $PINS O=sll_16/ML_int[1][8] S=FE_OFN207_h31_0 A=term1_in[8]
+ B=term1_in[7]
XU130 MUX2S $PINS O=sll_18/ML_int[2][8] S=n17 A=sll_18/ML_int[1][8]
+ B=sll_18/ML_int[1][6]
XU131 MUX2S $PINS O=sll_18/ML_int[1][8] S=FE_OFN304_h33_0 A=term3_in[8]
+ B=term3_in[7]
XU132 MUX2S $PINS O=sll_17/ML_int[2][8] S=FE_OFN204_h32_1 A=sll_17/ML_int[1][8]
+ B=sll_17/ML_int[1][6]
XU133 MUX2S $PINS O=sll_17/ML_int[1][8] S=n24 A=term2_in[8] B=term2_in[7]
XU134 MUX2S $PINS O=sll_16/ML_int[2][9] S=FE_OFN216_h31_1 A=sll_16/ML_int[1][9]
+ B=sll_16/ML_int[1][7]
XU135 MUX2S $PINS O=sll_16/ML_int[1][9] S=FE_OFN207_h31_0 A=term1_in[9]
+ B=term1_in[8]
XU136 MUX2S $PINS O=sll_18/ML_int[2][9] S=n17 A=sll_18/ML_int[1][9]
+ B=sll_18/ML_int[1][7]
XU137 MUX2S $PINS O=sll_18/ML_int[1][9] S=FE_OFN304_h33_0 A=term3_in[9]
+ B=term3_in[8]
XU139 MUX2S $PINS O=sll_17/ML_int[2][9] S=FE_OFN204_h32_1 A=sll_17/ML_int[1][9]
+ B=sll_17/ML_int[1][7]
XU140 MUX2S $PINS O=sll_17/ML_int[1][9] S=n24 A=term2_in[9] B=term2_in[8]
XU141 MUX2S $PINS O=sll_16/ML_int[2][10] S=FE_OFN216_h31_1
+ A=sll_16/ML_int[1][10] B=sll_16/ML_int[1][8]
XU161 MUX2S $PINS O=sll_16/ML_int[1][10] S=FE_OFN207_h31_0 A=term1_in[10]
+ B=term1_in[9]
XU163 MUX2S $PINS O=sll_18/ML_int[3][10] S=FE_OFN201_h33_2
+ A=sll_18/ML_int[2][10] B=sll_18/ML_int[2][6]
XU166 MUX2S $PINS O=sll_18/ML_int[2][10] S=n17 A=sll_18/ML_int[1][10]
+ B=sll_18/ML_int[1][8]
XU167 MUX2 $PINS O=sll_18/ML_int[1][10] S=FE_OFN304_h33_0 A=term3_in[10]
+ B=term3_in[9]
XU168 MUX2S $PINS O=sll_17/ML_int[3][10] S=shf2[2] A=sll_17/ML_int[2][10]
+ B=sll_17/ML_int[2][6]
XU173 MUX2S $PINS O=sll_17/ML_int[2][10] S=FE_OFN204_h32_1
+ A=sll_17/ML_int[1][10] B=sll_17/ML_int[1][8]
XU182 MUX2S $PINS O=sll_17/ML_int[1][10] S=n24 A=term2_in[10] B=term2_in[9]
XU192 MUX2S $PINS O=sll_16/ML_int[3][11] S=n36 A=sll_16/ML_int[2][11]
+ B=sll_16/ML_int[2][7]
XU193 MUX2S $PINS O=sll_16/ML_int[2][11] S=FE_OFN216_h31_1
+ A=sll_16/ML_int[1][11] B=sll_16/ML_int[1][9]
XU194 MUX2S $PINS O=sll_18/ML_int[3][11] S=FE_OFN201_h33_2
+ A=sll_18/ML_int[2][11] B=sll_18/ML_int[2][7]
XU195 MUX2S $PINS O=sll_18/ML_int[2][11] S=n17 A=sll_18/ML_int[1][11]
+ B=sll_18/ML_int[1][9]
XU196 MUX2S $PINS O=sll_17/ML_int[3][11] S=FE_OFN329_h32_2
+ A=sll_17/ML_int[2][11] B=sll_17/ML_int[2][7]
XU197 MUX2S $PINS O=sll_17/ML_int[2][11] S=FE_OFN204_h32_1
+ A=sll_17/ML_int[1][11] B=sll_17/ML_int[1][9]
XU198 MUX2S $PINS O=sll_16/ML_int[1][11] S=FE_OFN207_h31_0 A=term1_in[11]
+ B=term1_in[10]
XU199 MUX2S $PINS O=sll_18/ML_int[1][11] S=FE_OFN304_h33_0 A=term3_in[11]
+ B=term3_in[10]
XU200 MUX2S $PINS O=sll_17/ML_int[1][11] S=n24 A=term2_in[11] B=term2_in[10]
XU201 MUX2S $PINS O=sll_16/ML_int[3][12] S=n36 A=sll_16/ML_int[2][12]
+ B=sll_16/ML_int[2][8]
XU202 MUX2S $PINS O=sll_16/ML_int[2][12] S=FE_OFN216_h31_1
+ A=sll_16/ML_int[1][12] B=sll_16/ML_int[1][10]
XU203 MUX2S $PINS O=sll_18/ML_int[3][12] S=FE_OFN201_h33_2
+ A=sll_18/ML_int[2][12] B=sll_18/ML_int[2][8]
XU204 MUX2S $PINS O=sll_18/ML_int[2][12] S=n17 A=sll_18/ML_int[1][12]
+ B=sll_18/ML_int[1][10]
XU205 MUX2S $PINS O=sll_17/ML_int[3][12] S=FE_OFN329_h32_2
+ A=sll_17/ML_int[2][12] B=sll_17/ML_int[2][8]
XU206 MUX2S $PINS O=sll_17/ML_int[2][12] S=FE_OFN204_h32_1
+ A=sll_17/ML_int[1][12] B=sll_17/ML_int[1][10]
XU207 MUX2S $PINS O=sll_16/ML_int[1][12] S=FE_OFN207_h31_0 A=term1_in[12]
+ B=term1_in[11]
XU208 MUX2S $PINS O=sll_18/ML_int[1][12] S=FE_OFN304_h33_0 A=term3_in[12]
+ B=term3_in[11]
XU209 MUX2S $PINS O=sll_17/ML_int[1][12] S=n24 A=term2_in[12] B=term2_in[11]
XU210 MUX2S $PINS O=sll_16/ML_int[3][13] S=n36 A=sll_16/ML_int[2][13]
+ B=sll_16/ML_int[2][9]
XU211 MUX2S $PINS O=sll_18/ML_int[3][13] S=FE_OFN201_h33_2
+ A=sll_18/ML_int[2][13] B=sll_18/ML_int[2][9]
XU212 MUX2S $PINS O=sll_17/ML_int[3][13] S=FE_OFN329_h32_2
+ A=sll_17/ML_int[2][13] B=sll_17/ML_int[2][9]
XU213 MUX2S $PINS O=sll_16/ML_int[2][13] S=FE_OFN216_h31_1
+ A=sll_16/ML_int[1][13] B=sll_16/ML_int[1][11]
XU214 MUX2S $PINS O=sll_16/ML_int[1][13] S=FE_OFN207_h31_0 A=term1_in[13]
+ B=term1_in[12]
XU215 MUX2S $PINS O=sll_18/ML_int[1][13] S=FE_OFN304_h33_0 A=term3_in[13]
+ B=term3_in[12]
XU216 MUX2S $PINS O=sll_18/ML_int[2][13] S=n17 A=sll_18/ML_int[1][13]
+ B=sll_18/ML_int[1][11]
XU217 MUX2S $PINS O=sll_17/ML_int[2][13] S=FE_OFN204_h32_1
+ A=sll_17/ML_int[1][13] B=sll_17/ML_int[1][11]
XU218 MUX2S $PINS O=sll_17/ML_int[1][13] S=n24 A=term2_in[13] B=term2_in[12]
XU219 MUX2S $PINS O=sll_16/ML_int[3][14] S=n36 A=sll_16/ML_int[2][14]
+ B=sll_16/ML_int[2][10]
XU220 MUX2S $PINS O=term3_shifted[14] S=FE_OFN166_h33_3 A=sll_18/ML_int[3][14]
+ B=sll_18/ML_int[3][6]
XU221 MUX2S $PINS O=sll_18/ML_int[3][14] S=FE_OFN201_h33_2
+ A=sll_18/ML_int[2][14] B=sll_18/ML_int[2][10]
XU222 MUX2S $PINS O=term2_shifted[14] S=FE_OFN186_h32_3 A=sll_17/ML_int[3][14]
+ B=sll_17/ML_int[3][6]
XU223 MUX2S $PINS O=sll_17/ML_int[3][14] S=FE_OFN329_h32_2
+ A=sll_17/ML_int[2][14] B=sll_17/ML_int[2][10]
XU224 MUX2S $PINS O=sll_16/ML_int[2][14] S=FE_OFN216_h31_1
+ A=sll_16/ML_int[1][14] B=sll_16/ML_int[1][12]
XU225 MUX2S $PINS O=sll_16/ML_int[1][14] S=FE_OFN207_h31_0 A=term1_in[14]
+ B=term1_in[13]
XU226 MUX2S $PINS O=sll_18/ML_int[2][14] S=n17 A=sll_18/ML_int[1][14]
+ B=sll_18/ML_int[1][12]
XU227 MUX2S $PINS O=sll_18/ML_int[1][14] S=FE_OFN304_h33_0 A=term3_in[14]
+ B=term3_in[13]
XU228 MUX2S $PINS O=sll_17/ML_int[2][14] S=FE_OFN204_h32_1
+ A=sll_17/ML_int[1][14] B=sll_17/ML_int[1][12]
XU229 MUX2S $PINS O=sll_17/ML_int[1][14] S=n24 A=term2_in[14] B=term2_in[13]
XU230 MUX2S $PINS O=term1_shifted[16] S=n38 A=sll_16/ML_int[3][16]
+ B=sll_16/ML_int[3][8]
XU231 MUX2S $PINS O=sll_16/ML_int[3][16] S=n36 A=n55 B=sll_16/ML_int[2][12]
XU232 MUX2S $PINS O=term3_shifted[16] S=FE_OFN166_h33_3 A=sll_18/ML_int[3][16]
+ B=sll_18/ML_int[3][8]
XU233 MUX2S $PINS O=n78 S=FE_OFN304_h33_0 A=term3_in[26] B=term3_in[15]
XU234 MUX2S $PINS O=sll_18/ML_int[3][16] S=FE_OFN201_h33_2 A=n75
+ B=sll_18/ML_int[2][12]
XU235 MUX2S $PINS O=n75 S=n17 A=n78 B=sll_18/ML_int[1][14]
XU236 MUX2S $PINS O=term2_shifted[16] S=FE_OFN186_h32_3 A=sll_17/ML_int[3][16]
+ B=sll_17/ML_int[3][8]
XU237 MUX2S $PINS O=sll_17/ML_int[3][16] S=FE_OFN329_h32_2 A=n65
+ B=sll_17/ML_int[2][12]
XU238 MUX2S $PINS O=term1_shifted[15] S=n38 A=sll_16/ML_int[3][15]
+ B=sll_16/ML_int[3][7]
XU239 MUX2S $PINS O=sll_16/ML_int[3][15] S=n36 A=sll_16/ML_int[2][15]
+ B=sll_16/ML_int[2][11]
XU240 MUX2S $PINS O=term3_shifted[15] S=FE_OFN166_h33_3 A=sll_18/ML_int[3][15]
+ B=sll_18/ML_int[3][7]
XU241 MUX2S $PINS O=sll_18/ML_int[3][15] S=FE_OFN201_h33_2
+ A=sll_18/ML_int[2][15] B=sll_18/ML_int[2][11]
XU242 MUX2S $PINS O=term2_shifted[15] S=FE_OFN186_h32_3 A=sll_17/ML_int[3][15]
+ B=sll_17/ML_int[3][7]
XU243 MUX2S $PINS O=sll_17/ML_int[3][15] S=FE_OFN329_h32_2
+ A=sll_17/ML_int[2][15] B=sll_17/ML_int[2][11]
XU244 MUX2S $PINS O=sll_16/ML_int[2][15] S=FE_OFN216_h31_1
+ A=sll_16/ML_int[1][15] B=sll_16/ML_int[1][13]
XU245 MUX2S $PINS O=sll_16/ML_int[1][15] S=FE_OFN207_h31_0 A=term1_in[15]
+ B=term1_in[14]
XU246 MUX2S $PINS O=sll_18/ML_int[2][15] S=n17 A=sll_18/ML_int[1][15]
+ B=sll_18/ML_int[1][13]
XU247 MUX2S $PINS O=sll_18/ML_int[1][15] S=FE_OFN304_h33_0 A=term3_in[15]
+ B=term3_in[14]
XU248 MUX2S $PINS O=sll_17/ML_int[2][15] S=FE_OFN204_h32_1
+ A=sll_17/ML_int[1][15] B=sll_17/ML_int[1][13]
XU249 MUX2S $PINS O=sll_17/ML_int[1][15] S=n24 A=term2_in[15] B=term2_in[14]
XU250 MUX2S $PINS O=term1_shifted[17] S=n38 A=sll_16/ML_int[3][17]
+ B=sll_16/ML_int[3][9]
XU251 MUX2S $PINS O=sll_16/ML_int[3][17] S=n36 A=n56 B=sll_16/ML_int[2][13]
XU252 MUX2S $PINS O=term3_shifted[17] S=FE_OFN166_h33_3 A=sll_18/ML_int[3][17]
+ B=sll_18/ML_int[3][9]
XU253 MUX2S $PINS O=n76 S=n17 A=term3_in[26] B=sll_18/ML_int[1][15]
XU254 MUX2S $PINS O=sll_18/ML_int[3][17] S=FE_OFN201_h33_2 A=n76
+ B=sll_18/ML_int[2][13]
XU255 MUX2S $PINS O=term2_shifted[17] S=FE_OFN186_h32_3 A=sll_17/ML_int[3][17]
+ B=sll_17/ML_int[3][9]
XU256 MUX2S $PINS O=sll_17/ML_int[3][17] S=FE_OFN329_h32_2 A=n66
+ B=sll_17/ML_int[2][13]
XU257 MUX2S $PINS O=term1_shifted[18] S=n38 A=sll_16/ML_int[3][18]
+ B=sll_16/ML_int[3][10]
XU258 MUX2S $PINS O=sll_16/ML_int[3][18] S=n36 A=n57 B=sll_16/ML_int[2][14]
XU259 MUX2S $PINS O=term3_shifted[18] S=FE_OFN166_h33_3 A=sll_18/ML_int[3][18]
+ B=sll_18/ML_int[3][10]
XU260 MUX2S $PINS O=sll_18/ML_int[3][18] S=FE_OFN201_h33_2 A=n77
+ B=sll_18/ML_int[2][14]
XU261 MUX2S $PINS O=n77 S=n17 A=term3_in[26] B=n78
XU262 MUX2S $PINS O=term2_shifted[18] S=FE_OFN186_h32_3 A=sll_17/ML_int[3][18]
+ B=sll_17/ML_int[3][10]
XU263 MUX2S $PINS O=sll_17/ML_int[3][18] S=FE_OFN329_h32_2 A=n67
+ B=sll_17/ML_int[2][14]
XU264 MUX2S $PINS O=term1_shifted[20] S=n38 A=sll_16/ML_int[3][20]
+ B=sll_16/ML_int[3][12]
XU265 MUX2S $PINS O=sll_16/ML_int[3][20] S=n36 A=term1_in[26] B=n55
XU266 MUX2S $PINS O=term1_shifted[19] S=n38 A=sll_16/ML_int[3][19]
+ B=sll_16/ML_int[3][11]
XU267 MUX2S $PINS O=sll_16/ML_int[3][19] S=n36 A=term1_in[26]
+ B=sll_16/ML_int[2][15]
XU268 MUX2S $PINS O=term3_shifted[20] S=FE_OFN166_h33_3 A=sll_18/ML_int[3][20]
+ B=sll_18/ML_int[3][12]
XU269 MUX2S $PINS O=sll_18/ML_int[3][20] S=FE_OFN201_h33_2 A=term3_in[26] B=n75
XU270 MUX2S $PINS O=term3_shifted[19] S=FE_OFN166_h33_3 A=sll_18/ML_int[3][19]
+ B=sll_18/ML_int[3][11]
XU271 MUX2S $PINS O=sll_18/ML_int[3][19] S=FE_OFN201_h33_2 A=term3_in[26]
+ B=sll_18/ML_int[2][15]
XU272 MUX2S $PINS O=term2_shifted[20] S=FE_OFN186_h32_3 A=sll_17/ML_int[3][20]
+ B=sll_17/ML_int[3][12]
XU273 MUX2S $PINS O=sll_17/ML_int[3][20] S=FE_OFN329_h32_2 A=term2_in[26] B=n65
XU274 MUX2S $PINS O=term2_shifted[19] S=FE_OFN186_h32_3 A=sll_17/ML_int[3][19]
+ B=sll_17/ML_int[3][11]
XU275 MUX2S $PINS O=sll_17/ML_int[3][19] S=FE_OFN329_h32_2 A=term2_in[26]
+ B=sll_17/ML_int[2][15]
XU276 MUX2S $PINS O=term1_shifted[21] S=n38 A=sll_16/ML_int[3][21]
+ B=sll_16/ML_int[3][13]
XU277 MUX2S $PINS O=sll_16/ML_int[3][21] S=n36 A=term1_in[26] B=n56
XU278 MUX2S $PINS O=term3_shifted[21] S=FE_OFN166_h33_3 A=sll_18/ML_int[3][21]
+ B=sll_18/ML_int[3][13]
XU279 MUX2S $PINS O=sll_18/ML_int[3][21] S=FE_OFN201_h33_2 A=term3_in[26] B=n76
XU280 MUX2S $PINS O=term2_shifted[21] S=FE_OFN186_h32_3 A=sll_17/ML_int[3][21]
+ B=sll_17/ML_int[3][13]
XU281 MUX2S $PINS O=sll_17/ML_int[3][21] S=FE_OFN329_h32_2 A=term2_in[26] B=n66
XU282 MUX2S $PINS O=term1_shifted[22] S=n38 A=sll_16/ML_int[3][22]
+ B=sll_16/ML_int[3][14]
XU283 MUX2S $PINS O=sll_16/ML_int[3][22] S=n36 A=term1_in[26] B=n57
XU284 MUX2S $PINS O=term3_shifted[22] S=FE_OFN166_h33_3 A=sll_18/ML_int[3][22]
+ B=sll_18/ML_int[3][14]
XU285 MUX2S $PINS O=sll_18/ML_int[3][22] S=FE_OFN201_h33_2 A=term3_in[26] B=n77
XU286 MUX2S $PINS O=term2_shifted[22] S=FE_OFN186_h32_3 A=sll_17/ML_int[3][22]
+ B=sll_17/ML_int[3][14]
XU287 MUX2S $PINS O=sll_17/ML_int[3][22] S=FE_OFN329_h32_2 A=term2_in[26] B=n67
XU288 MUX2S $PINS O=term1_shifted[24] S=n38 A=term1_in[26]
+ B=sll_16/ML_int[3][16]
XU289 MUX2S $PINS O=term3_shifted[24] S=FE_OFN166_h33_3 A=term3_in[26]
+ B=sll_18/ML_int[3][16]
XU290 MUX2S $PINS O=term2_shifted[24] S=FE_OFN186_h32_3 A=term2_in[26]
+ B=sll_17/ML_int[3][16]
XU291 MUX2S $PINS O=term1_shifted[25] S=n38 A=term1_in[26]
+ B=sll_16/ML_int[3][17]
XU292 MUX2S $PINS O=term3_shifted[25] S=FE_OFN166_h33_3 A=term3_in[26]
+ B=sll_18/ML_int[3][17]
XU293 MUX2S $PINS O=term2_shifted[25] S=FE_OFN186_h32_3 A=term2_in[26]
+ B=sll_17/ML_int[3][17]
XU294 MUX2S $PINS O=term1_shifted[26] S=n38 A=term1_in[26]
+ B=sll_16/ML_int[3][18]
XU295 MUX2S $PINS O=term3_shifted[26] S=FE_OFN166_h33_3 A=term3_in[26]
+ B=sll_18/ML_int[3][18]
XU296 MUX2S $PINS O=term2_shifted[26] S=FE_OFN186_h32_3 A=term2_in[26]
+ B=sll_17/ML_int[3][18]
XU298 AN2S $PINS O=base_val[1] I1=acc_reg[1] I2=FE_OFN72_n
XU299 AO22 $PINS O=N109 A1=N82 A2=FE_OFN169_s32_0 B1=term2_shifted[13]
+ B2=FE_DBTN23_s32_0
XU300 AN2S $PINS O=base_val[0] I1=acc_reg[0] I2=FE_OFN72_n
XU301 MUX2S $PINS O=N235 S=stage_sel A=FE_PHN974_acc_reg_10 B=acc_reg[14]
XU302 MUX2S $PINS O=N236 S=stage_sel A=FE_PHN1258_acc_reg_11
+ B=FE_PHN927_acc_reg_15
XU303 MUX2S $PINS O=N237 S=stage_sel A=FE_PHN986_acc_reg_12 B=acc_reg[16]
XU304 MUX2S $PINS O=N238 S=stage_sel A=acc_reg[13] B=acc_reg[17]
XU305 MUX2S $PINS O=N239 S=stage_sel A=acc_reg[14] B=acc_reg[18]
XU306 MUX2S $PINS O=N240 S=stage_sel A=FE_PHN927_acc_reg_15
+ B=FE_PHN838_acc_reg_19
XU307 MUX2S $PINS O=N242 S=stage_sel A=acc_reg[17] B=acc_reg[21]
XU308 MUX2S $PINS O=N245 S=stage_sel A=FE_PHN845_acc_reg_20 B=acc_reg[24]
XU309 MUX2S $PINS O=FE_PHN1297_N246 S=stage_sel A=acc_reg[21]
+ B=FE_PHN1064_acc_reg_25
XU310 INV2 $PINS O=n72 I=sll_18/ML_int[2][3]
XU311 INV1S $PINS O=n53 I=n48
XU313 INV1S $PINS O=n64 I=n60
XU314 NR2 $PINS O=term1_in[4] I1=sign1[1] I2=x_in[4]
XU315 NR2 $PINS O=term2_in[4] I1=sign2[1] I2=x_in[4]
XU316 NR2 $PINS O=term3_in[4] I1=FE_OFN269_s33_1 I2=x_in[4]
XU317 NR2 $PINS O=term1_in[3] I1=sign1[1] I2=x_in[3]
XU318 NR2 $PINS O=term3_in[3] I1=FE_OFN269_s33_1 I2=x_in[3]
XU319 NR2 $PINS O=term1_in[5] I1=sign1[1] I2=x_in[5]
XU320 NR2 $PINS O=term2_in[5] I1=sign2[1] I2=x_in[5]
XU321 NR2 $PINS O=term3_in[5] I1=FE_OFN269_s33_1 I2=x_in[5]
XU322 NR2 $PINS O=term1_in[6] I1=sign1[1] I2=x_in[6]
XU324 NR2 $PINS O=term2_in[6] I1=sign2[1] I2=x_in[6]
XU325 NR2 $PINS O=term3_in[6] I1=FE_OFN269_s33_1 I2=x_in[6]
XU326 NR2 $PINS O=term1_in[7] I1=sign1[1] I2=x_in[7]
XU327 NR2 $PINS O=term2_in[7] I1=sign2[1] I2=x_in[7]
XU328 NR2 $PINS O=term3_in[7] I1=FE_OFN269_s33_1 I2=x_in[7]
XU329 NR2 $PINS O=term1_in[8] I1=sign1[1] I2=x_in[8]
XU330 NR2 $PINS O=term2_in[8] I1=FE_OFN288_s32_1 I2=x_in[8]
XU331 NR2 $PINS O=term3_in[8] I1=FE_OFN269_s33_1 I2=x_in[8]
XU333 NR2 $PINS O=term1_in[9] I1=sign1[1] I2=x_in[9]
XU334 NR2 $PINS O=term2_in[9] I1=FE_OFN288_s32_1 I2=x_in[9]
XU335 NR2 $PINS O=term3_in[9] I1=FE_OFN269_s33_1 I2=x_in[9]
XU336 NR2 $PINS O=term1_in[10] I1=sign1[1] I2=x_in[10]
XU337 NR2 $PINS O=term2_in[10] I1=FE_OFN288_s32_1 I2=x_in[10]
XU338 NR2 $PINS O=term3_in[10] I1=FE_OFN269_s33_1 I2=x_in[10]
XU339 NR2 $PINS O=term1_in[11] I1=sign1[1] I2=x_in[11]
XU340 NR2 $PINS O=term2_in[11] I1=FE_OFN288_s32_1 I2=x_in[11]
XU341 NR2 $PINS O=term3_in[11] I1=FE_OFN269_s33_1 I2=x_in[11]
XU342 NR2 $PINS O=term1_in[12] I1=FE_OFN273_s31_1 I2=x_in[12]
XU343 NR2 $PINS O=term2_in[12] I1=FE_OFN288_s32_1 I2=x_in[12]
XU344 NR2 $PINS O=term3_in[12] I1=FE_OFN269_s33_1 I2=x_in[12]
XU345 NR2 $PINS O=term1_in[13] I1=FE_OFN273_s31_1 I2=n82
XU346 NR2 $PINS O=term2_in[13] I1=FE_OFN288_s32_1 I2=n82
XU347 NR2 $PINS O=term3_in[13] I1=FE_OFN269_s33_1 I2=n82
XU349 NR2 $PINS O=term1_in[14] I1=FE_OFN273_s31_1 I2=n83
XU352 NR2 $PINS O=term2_in[14] I1=FE_OFN288_s32_1 I2=n83
XU353 NR2 $PINS O=term3_in[14] I1=FE_OFN269_s33_1 I2=n83
XU354 NR2 $PINS O=term1_in[15] I1=FE_OFN273_s31_1 I2=n84
XU355 NR2 $PINS O=term2_in[15] I1=FE_OFN288_s32_1 I2=n84
XU356 NR2 $PINS O=term3_in[15] I1=FE_OFN269_s33_1 I2=n84
XU357 NR2 $PINS O=term1_in[26] I1=n85 I2=FE_OFN273_s31_1
XU358 NR2 $PINS O=term2_in[26] I1=n85 I2=FE_OFN288_s32_1
XU359 NR2 $PINS O=term3_in[26] I1=n85 I2=FE_OFN269_s33_1
XU380 INV1S $PINS O=n82 I=x_in[13]
XU381 INV1S $PINS O=n83 I=x_in[14]
XU382 INV1S $PINS O=n84 I=x_in[15]
XU383 INV1S $PINS O=n85 I=x_in[16]
XU384 AN2 $PINS O=base_val[2] I1=acc_reg[2] I2=FE_OFN72_n
XU385 MOAI1S $PINS O=base_val[9] A1=stage_sel A2=FE_OFN72_n B1=acc_reg[9]
+ B2=FE_OFN72_n
XU386 AN2 $PINS O=base_val[10] I1=acc_reg[10] I2=FE_OFN72_n
XU387 AN2 $PINS O=base_val[11] I1=FE_PHN1258_acc_reg_11 I2=FE_OFN72_n
XU388 AN2 $PINS O=base_val[12] I1=acc_reg[12] I2=FE_OFN72_n
XU389 AN2 $PINS O=base_val[14] I1=acc_reg[14] I2=FE_OFN72_n
XU390 AN2 $PINS O=base_val[15] I1=acc_reg[15] I2=FE_OFN72_n
XU391 AN2 $PINS O=base_val[16] I1=acc_reg[16] I2=FE_OFN72_n
XU392 AN2 $PINS O=base_val[17] I1=acc_reg[17] I2=FE_OFN72_n
XU393 AN2 $PINS O=base_val[18] I1=acc_reg[18] I2=FE_OFN72_n
XU394 AN2 $PINS O=base_val[19] I1=acc_reg[19] I2=FE_OFN72_n
XU395 AN2 $PINS O=base_val[20] I1=acc_reg[20] I2=FE_OFN72_n
XU396 AN2 $PINS O=base_val[7] I1=acc_reg[7] I2=FE_OFN72_n
XU397 AN2 $PINS O=base_val[6] I1=acc_reg[6] I2=FE_OFN72_n
XU398 AN2 $PINS O=base_val[21] I1=acc_reg[21] I2=FE_OFN72_n
XU399 AN2 $PINS O=base_val[8] I1=acc_reg[8] I2=FE_OFN72_n
XU400 AN2 $PINS O=base_val[5] I1=acc_reg[5] I2=FE_OFN72_n
XU401 AN2 $PINS O=base_val[22] I1=acc_reg[22] I2=FE_OFN72_n
XU402 AN2 $PINS O=base_val[23] I1=acc_reg[23] I2=FE_OFN72_n
XU403 AN2 $PINS O=base_val[4] I1=acc_reg[4] I2=FE_OFN72_n
XU404 AN2 $PINS O=base_val[24] I1=acc_reg[24] I2=FE_OFN72_n
XU405 AN2 $PINS O=base_val[3] I1=acc_reg[3] I2=FE_OFN72_n
XU406 AN2 $PINS O=base_val[25] I1=FE_PHN1064_acc_reg_25 I2=FE_OFN72_n
XU408 AN2 $PINS O=N234 I1=en I2=calc_done
XU409 AN2 $PINS O=base_val[26] I1=FE_PHN811_N251 I2=FE_OFN72_n
XU411 INV1S $PINS O=n74 I=n70
XU412 NR2T $PINS O=term2_in[0] I1=sign2[1] I2=x_in[0]
XU413 INV1S $PINS O=n54 I=n49
XU414 NR2 $PINS O=sll_16/ML_int[3][0] I1=n36 I2=n48
XU415 NR2 $PINS O=sll_16/ML_int[3][1] I1=n36 I2=n49
XU416 NR2 $PINS O=sll_16/ML_int[3][2] I1=n36 I2=n52
XU417 NR2 $PINS O=sll_16/ML_int[3][3] I1=n36 I2=n51
XU418 ND2 $PINS O=n50 I1=shf1[2] I2=shf1[3]
XU419 NR2P $PINS O=term1_shifted[3] I1=n50 I2=n51
XU420 AN2 $PINS O=term1_shifted[4] I1=sll_16/ML_int[3][4] I2=shf1[3]
XU421 AN2 $PINS O=term1_shifted[5] I1=sll_16/ML_int[3][5] I2=shf1[3]
XU422 AN2 $PINS O=term1_shifted[6] I1=sll_16/ML_int[3][6] I2=shf1[3]
XU423 AN2 $PINS O=term1_shifted[7] I1=sll_16/ML_int[3][7] I2=shf1[3]
XU424 MUX2 $PINS O=n55 S=FE_OFN216_h31_1 A=n58 B=sll_16/ML_int[1][14]
XU425 MUX2 $PINS O=n56 S=FE_OFN216_h31_1 A=term1_in[26] B=sll_16/ML_int[1][15]
XU426 MUX2 $PINS O=n57 S=FE_OFN216_h31_1 A=term1_in[26] B=n58
XU427 MUX2 $PINS O=n58 S=FE_OFN207_h31_0 A=term1_in[26] B=term1_in[15]
XU428 NR2 $PINS O=sll_17/ML_int[3][0] I1=shf2[2] I2=n59
XU429 NR2 $PINS O=sll_17/ML_int[3][1] I1=shf2[2] I2=n60
XU430 NR2 $PINS O=sll_17/ML_int[3][2] I1=shf2[2] I2=n9
XU431 NR2 $PINS O=sll_17/ML_int[3][3] I1=shf2[2] I2=n62
XU432 NR2T $PINS O=term2_shifted[3] I1=n61 I2=n62
XU433 AN2T $PINS O=term2_shifted[4] I1=sll_17/ML_int[3][4] I2=n27
XU434 AN2 $PINS O=term2_shifted[5] I1=sll_17/ML_int[3][5] I2=n27
XU435 AN2 $PINS O=term2_shifted[6] I1=sll_17/ML_int[3][6] I2=n27
XU436 AN2 $PINS O=term2_shifted[7] I1=sll_17/ML_int[3][7] I2=n27
XU437 MUX2 $PINS O=n65 S=FE_OFN204_h32_1 A=n68 B=sll_17/ML_int[1][14]
XU438 MUX2 $PINS O=n66 S=FE_OFN204_h32_1 A=term2_in[26] B=sll_17/ML_int[1][15]
XU439 MUX2 $PINS O=n67 S=FE_OFN204_h32_1 A=term2_in[26] B=n68
XU440 NR2 $PINS O=sll_18/ML_int[3][0] I1=shf3[2] I2=FE_OCPN707_n69
XU441 NR2 $PINS O=sll_18/ML_int[3][1] I1=shf3[2] I2=n70
XU442 NR2 $PINS O=sll_18/ML_int[3][2] I1=shf3[2] I2=n3
XU443 NR2 $PINS O=sll_18/ML_int[3][3] I1=shf3[2] I2=n72
XU444 NR2P $PINS O=term3_shifted[3] I1=n71 I2=n72
XU445 AN2 $PINS O=term3_shifted[4] I1=sll_18/ML_int[3][4] I2=n19
XU446 AN2 $PINS O=term3_shifted[5] I1=sll_18/ML_int[3][5] I2=n19
XU447 AN2 $PINS O=term3_shifted[6] I1=sll_18/ML_int[3][6] I2=n19
XU448 AN2 $PINS O=term3_shifted[7] I1=sll_18/ML_int[3][7] I2=n19
XU449 MUX2 $PINS O=N241 S=stage_sel A=acc_reg[16] B=FE_PHN845_acc_reg_20
XU450 MUX2 $PINS O=N243 S=stage_sel A=acc_reg[18] B=acc_reg[22]
XU451 MUX2 $PINS O=FE_PHN1278_N244 S=stage_sel A=FE_PHN838_acc_reg_19
+ B=acc_reg[23]
XU77 MUX2 $PINS O=sll_17/ML_int[1][4] S=shf2[0] A=term2_in[4] B=term2_in[3]
XU118 MUX2 $PINS O=sll_16/ML_int[1][2] S=shf1[0] A=term1_in[2] B=term1_in[1]
XU4 ND2 $PINS O=n69 I1=n4 I2=term3_in[0]
XU5 NR2P $PINS O=term2_shifted[2] I1=n61 I2=n9
XU10 NR2T $PINS O=term3_in[0] I1=sign3[1] I2=x_in[0]
XU11 INV1S $PINS O=n52 I=sll_16/ML_int[2][2]
XU12 AN2T $PINS O=term2_shifted[1] I1=sll_17/ML_int[1][1] I2=n7
XU17 NR2 $PINS O=term1_in[2] I1=sign1[1] I2=FE_OCPN715_FE_OFN122_mac_in_real_2
XU24 NR2T $PINS O=term1_shifted[2] I1=n50 I2=n52
XU36 NR2T $PINS O=n12 I1=n50 I2=n49
XU52 NR2P $PINS O=term3_shifted[0] I1=n71 I2=n69
Xclk_gate_y_out_reg SNPS_CLOCK_GATE_HIGH_PE_Shift_Add_1 $PINS EN=N234
+ ENCLK=CTS_12 CLK=clk_clone1
Xsub_28_3 PE_Shift_Add_1_DW01_sub_0_DW01_sub_3 $PINS A[26]=net45539
+ A[25]=net45539 A[24]=net45539 A[23]=net45539 A[22]=net45539 A[21]=net45539
+ A[20]=net45539 A[19]=net45539 A[18]=net45539 A[17]=net45539 A[16]=net45539
+ A[15]=net45539 A[14]=net45539 A[13]=net45539 A[12]=net45539 A[11]=net45539
+ A[10]=net45539 A[9]=net45539 A[8]=net45539 A[7]=net45539 A[6]=net45539
+ A[5]=net45539 A[4]=net45539 A[3]=net45539 A[2]=net45539 A[1]=net45539
+ A[0]=net45539 B[26]=term3_shifted[26] B[25]=term3_shifted[25]
+ B[24]=term3_shifted[24] B[23]=term3_shifted[23] B[22]=term3_shifted[22]
+ B[21]=term3_shifted[21] B[20]=term3_shifted[20] B[19]=term3_shifted[19]
+ B[18]=term3_shifted[18] B[17]=term3_shifted[17] B[16]=term3_shifted[16]
+ B[15]=term3_shifted[15] B[14]=term3_shifted[14] B[13]=term3_shifted[13]
+ B[12]=term3_shifted[12] B[11]=term3_shifted[11] B[10]=term3_shifted[10]
+ B[9]=term3_shifted[9] B[8]=term3_shifted[8] B[7]=term3_shifted[7]
+ B[6]=term3_shifted[6] B[5]=term3_shifted[5] B[4]=term3_shifted[4]
+ B[3]=term3_shifted[3] B[2]=term3_shifted[2] B[1]=n1 B[0]=term3_shifted[0]
+ CI=net45539 DIFF[26]=N150 DIFF[25]=N149 DIFF[24]=N148 DIFF[23]=N147
+ DIFF[22]=N146 DIFF[21]=N145 DIFF[20]=N144 DIFF[19]=N143 DIFF[18]=N142
+ DIFF[17]=N141 DIFF[16]=N140 DIFF[15]=N139 DIFF[14]=N138 DIFF[13]=N137
+ DIFF[12]=N136 DIFF[11]=N135 DIFF[10]=N134 DIFF[9]=N133 DIFF[8]=N132
+ DIFF[7]=N131 DIFF[6]=N130 DIFF[5]=N129 DIFF[4]=N128 DIFF[3]=N127 DIFF[2]=N126
+ DIFF[1]=N125 DIFF[0]=N124
Xsub_28_2 PE_Shift_Add_1_DW01_sub_1_DW01_sub_4 $PINS A[26]=net45539
+ A[25]=net45539 A[24]=net45539 A[23]=net45539 A[22]=net45539 A[21]=net45539
+ A[20]=net45539 A[19]=net45539 A[18]=net45539 A[17]=net45539 A[16]=net45539
+ A[15]=net45539 A[14]=net45539 A[13]=net45539 A[12]=net45539 A[11]=net45539
+ A[10]=net45539 A[9]=net45539 A[8]=net45539 A[7]=net45539 A[6]=net45539
+ A[5]=net45539 A[4]=net45539 A[3]=net45539 A[2]=net45539 A[1]=net45539
+ A[0]=net45539 B[26]=term2_shifted[26] B[25]=term2_shifted[25]
+ B[24]=term2_shifted[24] B[23]=term2_shifted[23] B[22]=term2_shifted[22]
+ B[21]=term2_shifted[21] B[20]=term2_shifted[20] B[19]=term2_shifted[19]
+ B[18]=term2_shifted[18] B[17]=term2_shifted[17] B[16]=term2_shifted[16]
+ B[15]=term2_shifted[15] B[14]=term2_shifted[14] B[13]=term2_shifted[13]
+ B[12]=term2_shifted[12] B[11]=term2_shifted[11] B[10]=term2_shifted[10]
+ B[9]=term2_shifted[9] B[8]=term2_shifted[8] B[7]=term2_shifted[7]
+ B[6]=term2_shifted[6] B[5]=term2_shifted[5] B[4]=term2_shifted[4]
+ B[3]=term2_shifted[3] B[2]=term2_shifted[2] B[1]=term2_shifted[1]
+ B[0]=term2_shifted[0] CI=net45539 DIFF[26]=N95 DIFF[25]=N94 DIFF[24]=N93
+ DIFF[23]=N92 DIFF[22]=N91 DIFF[21]=N90 DIFF[20]=N89 DIFF[19]=N88 DIFF[18]=N87
+ DIFF[17]=N86 DIFF[16]=N85 DIFF[15]=N84 DIFF[14]=N83 DIFF[13]=N82 DIFF[12]=N81
+ DIFF[11]=N80 DIFF[10]=N79 DIFF[9]=N78 DIFF[8]=N77 DIFF[7]=N76 DIFF[6]=N75
+ DIFF[5]=N74 DIFF[4]=N73 DIFF[3]=N72 DIFF[2]=N71 DIFF[1]=N70 DIFF[0]=N69
Xsub_28 PE_Shift_Add_1_DW01_sub_2_DW01_sub_5 $PINS A[26]=net45539
+ A[25]=net45539 A[24]=net45539 A[23]=net45539 A[22]=net45539 A[21]=net45539
+ A[20]=net45539 A[19]=net45539 A[18]=net45539 A[17]=net45539 A[16]=net45539
+ A[15]=net45539 A[14]=net45539 A[13]=net45539 A[12]=net45539 A[11]=net45539
+ A[10]=net45539 A[9]=net45539 A[8]=net45539 A[7]=net45539 A[6]=net45539
+ A[5]=net45539 A[4]=net45539 A[3]=net45539 A[2]=net45539 A[1]=net45539
+ A[0]=net45539 B[26]=term1_shifted[26] B[25]=term1_shifted[25]
+ B[24]=term1_shifted[24] B[23]=term1_shifted[23] B[22]=term1_shifted[22]
+ B[21]=term1_shifted[21] B[20]=term1_shifted[20] B[19]=term1_shifted[19]
+ B[18]=term1_shifted[18] B[17]=term1_shifted[17] B[16]=term1_shifted[16]
+ B[15]=term1_shifted[15] B[14]=term1_shifted[14] B[13]=term1_shifted[13]
+ B[12]=term1_shifted[12] B[11]=term1_shifted[11] B[10]=term1_shifted[10]
+ B[9]=term1_shifted[9] B[8]=term1_shifted[8] B[7]=term1_shifted[7]
+ B[6]=term1_shifted[6] B[5]=term1_shifted[5] B[4]=term1_shifted[4]
+ B[3]=term1_shifted[3] B[2]=term1_shifted[2] B[1]=n12 B[0]=term1_shifted[0]
+ CI=net45539 DIFF[26]=N40 DIFF[25]=N39 DIFF[24]=N38 DIFF[23]=N37 DIFF[22]=N36
+ DIFF[21]=N35 DIFF[20]=N34 DIFF[19]=N33 DIFF[18]=N32 DIFF[17]=N31 DIFF[16]=N30
+ DIFF[15]=N29 DIFF[14]=N28 DIFF[13]=N27 DIFF[12]=N26 DIFF[11]=N25 DIFF[10]=N24
+ DIFF[9]=N23 DIFF[8]=N22 DIFF[7]=N21 DIFF[6]=N20 DIFF[5]=N19 DIFF[4]=N18
+ DIFF[3]=N17 DIFF[2]=N16 DIFF[1]=N15 DIFF[0]=FE_UNCONNECTEDZ_0 p1=N14
Xadd_1_root_add_0_root_add_28_3 PE_Shift_Add_1_DW01_add_2_DW01_add_28 $PINS
+ A[26]=N67 A[25]=N66 A[24]=N65 A[23]=N64 A[22]=N63 A[21]=N62 A[20]=N61 A[19]=N60
+ A[18]=N59 A[17]=N58 A[16]=N57 A[15]=N56 A[14]=N55 A[13]=N54 A[12]=N53 A[11]=N52
+ A[10]=N51 A[9]=N50 A[8]=N49 A[7]=N48 A[6]=N47 A[5]=N46 A[4]=N45 A[3]=N44
+ A[2]=N43 A[1]=N42 A[0]=N41 B[26]=N177 B[25]=N176 B[24]=N175 B[23]=N174
+ B[22]=N173 B[21]=N172 B[20]=N171 B[19]=N170 B[18]=N169 B[17]=N168 B[16]=N167
+ B[15]=N166 B[14]=N165 B[13]=N164 B[12]=N163 B[11]=N162 B[10]=N161 B[9]=N160
+ B[8]=N159 B[7]=N158 B[6]=N157 B[5]=N156 B[4]=N155 B[3]=N154 B[2]=N153 B[1]=N152
+ B[0]=N151 CI=net45539 SUM[26]=N204 SUM[25]=N203 SUM[24]=N202 SUM[23]=N201
+ SUM[22]=N200 SUM[21]=N199 SUM[20]=N198 SUM[19]=N197 SUM[18]=N196 SUM[17]=N195
+ SUM[16]=N194 SUM[15]=N193 SUM[14]=N192 SUM[13]=N191 SUM[12]=N190 SUM[11]=N189
+ SUM[10]=N188 SUM[9]=N187 SUM[8]=N186 SUM[7]=N185 SUM[6]=N184 SUM[5]=N183
+ SUM[4]=N182 SUM[3]=N181 SUM[2]=N180 SUM[1]=N179 SUM[0]=N178
Xadd_2_root_add_0_root_add_28_3 PE_Shift_Add_1_DW01_add_1_DW01_add_27 $PINS
+ A[26]=base_val[26] A[25]=base_val[25] A[24]=base_val[24] A[23]=base_val[23]
+ A[22]=base_val[22] A[21]=base_val[21] A[20]=base_val[20] A[19]=base_val[19]
+ A[18]=base_val[18] A[17]=base_val[17] A[16]=base_val[16] A[15]=base_val[15]
+ A[14]=base_val[14] A[13]=base_val[13] A[12]=base_val[12] A[11]=base_val[11]
+ A[10]=base_val[10] A[9]=base_val[9] A[8]=base_val[8] A[7]=base_val[7]
+ A[6]=base_val[6] A[5]=base_val[5] A[4]=base_val[4] A[3]=base_val[3]
+ A[2]=base_val[2] A[1]=base_val[1] A[0]=base_val[0] B[26]=N122 B[25]=N121
+ B[24]=N120 B[23]=N119 B[22]=N118 B[21]=N117 B[20]=N116 B[19]=N115 B[18]=N114
+ B[17]=N113 B[16]=N112 B[15]=N111 B[14]=N110 B[13]=N109 B[12]=N108 B[11]=N107
+ B[10]=N106 B[9]=N105 B[8]=N104 B[7]=N103 B[6]=N102 B[5]=N101 B[4]=N100 B[3]=N99
+ B[2]=N98 B[1]=N97 B[0]=term2_shifted[0] CI=net45539 SUM[26]=N231 SUM[25]=N230
+ SUM[24]=N229 SUM[23]=N228 SUM[22]=N227 SUM[21]=N226 SUM[20]=N225 SUM[19]=N224
+ SUM[18]=N223 SUM[17]=N222 SUM[16]=N221 SUM[15]=N220 SUM[14]=N219 SUM[13]=N218
+ SUM[12]=N217 SUM[11]=N216 SUM[10]=N215 SUM[9]=N214 SUM[8]=N213 SUM[7]=N212
+ SUM[6]=N211 SUM[5]=N210 SUM[4]=N209 SUM[3]=N208 SUM[2]=N207 SUM[1]=N206
+ SUM[0]=N205
Xadd_0_root_add_0_root_add_28_3 PE_Shift_Add_1_DW01_add_0_DW01_add_26 $PINS
+ A[26]=N204 A[25]=N203 A[24]=N202 A[23]=N201 A[22]=N200 A[21]=N199 A[20]=N198
+ A[19]=N197 A[18]=N196 A[17]=N195 A[16]=N194 A[15]=N193 A[14]=N192 A[13]=N191
+ A[12]=N190 A[11]=N189 A[10]=N188 A[9]=N187 A[8]=N186 A[7]=N185 A[6]=N184
+ A[5]=N183 A[4]=N182 A[3]=N181 A[2]=N180 A[1]=N179 A[0]=N178 B[26]=N231
+ B[25]=N230 B[24]=N229 B[23]=N228 B[22]=N227 B[21]=N226 B[20]=N225 B[19]=N224
+ B[18]=N223 B[17]=N222 B[16]=N221 B[15]=N220 B[14]=N219 B[13]=N218 B[12]=N217
+ B[11]=N216 B[10]=N215 B[9]=N214 B[8]=N213 B[7]=N212 B[6]=N211 B[5]=N210
+ B[4]=N209 B[3]=N208 B[2]=N207 B[1]=N206 B[0]=N205 CI=net45539
+ SUM[26]=next_acc[26] SUM[25]=next_acc[25] SUM[24]=next_acc[24]
+ SUM[23]=next_acc[23] SUM[22]=next_acc[22] SUM[21]=next_acc[21]
+ SUM[20]=next_acc[20] SUM[19]=next_acc[19] SUM[18]=next_acc[18]
+ SUM[17]=next_acc[17] SUM[16]=next_acc[16] SUM[15]=next_acc[15]
+ SUM[14]=next_acc[14] SUM[13]=next_acc[13] SUM[12]=next_acc[12]
+ SUM[11]=next_acc[11] SUM[10]=next_acc[10] SUM[9]=next_acc[9] SUM[8]=next_acc[8]
+ SUM[7]=next_acc[7] SUM[6]=next_acc[6] SUM[5]=next_acc[5] SUM[4]=next_acc[4]
+ SUM[3]=next_acc[3] SUM[2]=next_acc[2] SUM[1]=next_acc[1] SUM[0]=next_acc[0]
.ENDS

.SUBCKT SNPS_CLOCK_GATE_HIGH_PE_Shift_Add_0 EN ENCLK CLK_clone1 CLK
*.CONNECT ENCLK net2199
*.CONNECT net2200 EN
XFE_PHC775_net2203 DELC $PINS O=FE_PHN775_net2203 I=net2203
XCTS_cdb_INV_CLK_G0_L7_35 INV1CK $PINS O=CTS_4 I=CLK
Xlatch QDBHN $PINS Q=net2203 D=net2200 CKB=CLK_clone1
Xmain_gate AN2T $PINS O=net2199 I1=FE_PHN775_net2203 I2=CTS_4
.ENDS

.SUBCKT PE_Shift_Add_0_DW01_sub_0 A[26] A[25] A[24] A[23] A[22] A[21] A[20]
+ A[19] A[18] A[17] A[16] A[15] A[14] A[13] A[12] A[11] A[10] A[9] A[8] A[7]
+ A[6] A[5] A[4] A[3] A[2] A[1] A[0] B[26] B[25] B[24] B[23] B[22] B[21] B[20]
+ B[19] B[18] B[17] B[16] B[15] B[14] B[13] B[12] B[11] B[10] B[9] B[8] B[7]
+ B[6] B[5] B[4] B[3] B[2] B[1] B[0] CI DIFF[26] DIFF[25] DIFF[24] DIFF[23]
+ DIFF[22] DIFF[21] DIFF[20] DIFF[19] DIFF[18] DIFF[17] DIFF[16] DIFF[15]
+ DIFF[14] DIFF[13] DIFF[12] DIFF[11] DIFF[10] DIFF[9] DIFF[8] DIFF[7] DIFF[6]
+ DIFF[5] DIFF[4] DIFF[3] DIFF[2] DIFF[1] DIFF[0] CO
*.CONNECT DIFF[0] B[0]
XFE_RC_1622_0 INV1S $PINS O=FE_RN_402_0 I=n1
XFE_RC_1621_0 MXL2HS $PINS OB=DIFF[2] S=n50 A=FE_RN_402_0 B=n1
XFE_RC_1591_0 XOR2HS $PINS O=DIFF[1] I1=DIFF[0] I2=B[1]
XFE_RC_1583_0 INV1S $PINS O=FE_RN_379_0 I=n46
XFE_RC_1582_0 MXL2HS $PINS OB=DIFF[6] S=n22 A=FE_RN_379_0 B=n46
XFE_RC_1454_0 AN2 $PINS O=FE_RN_325_0 I1=n24 I2=n43
XFE_RC_1453_0 AN2 $PINS O=n5 I1=FE_RN_325_0 I2=n44
XFE_OFC679_term3_shifted_3 INV2 $PINS O=n49 I=B[3]
XU4 NR2 $PINS O=n1 I1=B[1] I2=B[0]
XU7 INV1S $PINS O=n48 I=B[4]
XU9 INV2 $PINS O=n47 I=B[5]
XU11 AN2 $PINS O=n3 I1=n2 I2=n49
XU12 AN2T $PINS O=n2 I1=n50 I2=n1
XU13 XOR2HS $PINS O=DIFF[3] I1=n49 I2=n2
XU14 XOR2HS $PINS O=DIFF[8] I1=n44 I2=n24
XU15 XOR2HS $PINS O=DIFF[9] I1=n43 I2=n4
XU16 AN2 $PINS O=n4 I1=n44 I2=n24
XU17 XOR2HS $PINS O=DIFF[10] I1=n42 I2=n5
XU19 XOR2HS $PINS O=DIFF[11] I1=n41 I2=n6
XU20 AN2 $PINS O=n6 I1=n42 I2=n5
XU21 XOR2HS $PINS O=DIFF[12] I1=n40 I2=n7
XU22 AN2 $PINS O=n7 I1=n41 I2=n6
XU23 XOR2HS $PINS O=DIFF[13] I1=n39 I2=n8
XU24 AN2 $PINS O=n8 I1=n40 I2=n7
XU25 XOR2HS $PINS O=DIFF[14] I1=n38 I2=n9
XU26 AN2 $PINS O=n9 I1=n39 I2=n8
XU27 XOR2HS $PINS O=DIFF[15] I1=n37 I2=n10
XU28 AN2 $PINS O=n10 I1=n38 I2=n9
XU29 XOR2HS $PINS O=DIFF[16] I1=n36 I2=n11
XU30 AN2 $PINS O=n11 I1=n37 I2=n10
XU31 XOR2HS $PINS O=DIFF[17] I1=n35 I2=n12
XU32 AN2 $PINS O=n12 I1=n36 I2=n11
XU33 XOR2HS $PINS O=DIFF[18] I1=n34 I2=n13
XU34 AN2 $PINS O=n13 I1=n35 I2=n12
XU35 XOR2HS $PINS O=DIFF[19] I1=n33 I2=n14
XU36 AN2 $PINS O=n14 I1=n34 I2=n13
XU37 XOR2HS $PINS O=DIFF[20] I1=n32 I2=n15
XU38 AN2 $PINS O=n15 I1=n33 I2=n14
XU39 XOR2HS $PINS O=DIFF[21] I1=n31 I2=n16
XU40 AN2 $PINS O=n16 I1=n32 I2=n15
XU41 XOR2HS $PINS O=DIFF[22] I1=n30 I2=n17
XU42 AN2 $PINS O=n17 I1=n31 I2=n16
XU43 XOR2HS $PINS O=DIFF[23] I1=n29 I2=n18
XU44 AN2 $PINS O=n18 I1=n30 I2=n17
XU45 XOR2HS $PINS O=DIFF[24] I1=n28 I2=n19
XU46 AN2 $PINS O=n19 I1=n29 I2=n18
XU47 AN2 $PINS O=n20 I1=n28 I2=n19
XU48 XOR2HS $PINS O=DIFF[25] I1=n27 I2=n20
XU49 XOR2HS $PINS O=DIFF[4] I1=n48 I2=n3
XU50 XOR2HS $PINS O=DIFF[5] I1=n47 I2=n21
XU51 AN2 $PINS O=n21 I1=n48 I2=n3
XU53 AN2T $PINS O=n22 I1=n47 I2=n21
XU54 XOR2HS $PINS O=DIFF[7] I1=n45 I2=n23
XU55 AN2 $PINS O=n23 I1=n46 I2=n22
XU56 AN2T $PINS O=n24 I1=n45 I2=n23
XU57 INV1S $PINS O=n44 I=B[8]
XU58 INV1S $PINS O=n43 I=B[9]
XU59 INV1S $PINS O=n42 I=B[10]
XU60 INV1S $PINS O=n41 I=B[11]
XU61 INV1S $PINS O=n40 I=B[12]
XU62 INV1S $PINS O=n39 I=B[13]
XU63 INV1S $PINS O=n38 I=B[14]
XU64 INV1S $PINS O=n37 I=B[15]
XU65 INV1S $PINS O=n36 I=B[16]
XU66 INV1S $PINS O=n35 I=B[17]
XU67 INV1S $PINS O=n34 I=B[18]
XU68 INV1S $PINS O=n33 I=B[19]
XU69 INV1S $PINS O=n32 I=B[20]
XU70 INV1S $PINS O=n31 I=B[21]
XU71 INV1S $PINS O=n30 I=B[22]
XU72 INV1S $PINS O=n29 I=B[23]
XU73 INV1S $PINS O=n28 I=B[24]
XU74 INV1S $PINS O=n27 I=B[25]
XU75 INV1S $PINS O=n46 I=B[6]
XU76 INV1S $PINS O=n45 I=B[7]
XU77 XOR2HS $PINS O=DIFF[26] I1=B[26] I2=n26
XU78 ND2 $PINS O=n26 I1=n27 I2=n20
XU1 INV2 $PINS O=n50 I=B[2]
.ENDS

.SUBCKT PE_Shift_Add_0_DW01_sub_1 A[26] A[25] A[24] A[23] A[22] A[21] A[20]
+ A[19] A[18] A[17] A[16] A[15] A[14] A[13] A[12] A[11] A[10] A[9] A[8] A[7]
+ A[6] A[5] A[4] A[3] A[2] A[1] A[0] B[26] B[25] B[24] B[23] B[22] B[21] B[20]
+ B[19] B[18] B[17] B[16] B[15] B[14] B[13] B[12] B[11] B[10] B[9] B[8] B[7]
+ B[6] B[5] B[4] B[3] B[2] B[1] B[0] CI DIFF[26] DIFF[25] DIFF[24] DIFF[23]
+ DIFF[22] DIFF[21] DIFF[20] DIFF[19] DIFF[18] DIFF[17] DIFF[16] DIFF[15]
+ DIFF[14] DIFF[13] DIFF[12] DIFF[11] DIFF[10] DIFF[9] DIFF[8] DIFF[7] DIFF[6]
+ DIFF[5] DIFF[4] DIFF[3] DIFF[2] DIFF[1] DIFF[0] CO
*.CONNECT DIFF[0] B[0]
XFE_RC_1275_0 ND2 $PINS O=FE_RN_253_0 I1=B[2] I2=n1
XFE_RC_1274_0 XNR2HS $PINS O=DIFF[3] I1=FE_RN_253_0 I2=n49
XFE_OFC645_term2_shifted_4 INV1S $PINS O=n48 I=B[4]
XU2 NR2 $PINS O=n1 I1=B[1] I2=B[0]
XU3 XOR2HS $PINS O=DIFF[2] I1=n1 I2=B[2]
XU4 XOR2HS $PINS O=DIFF[1] I1=B[0] I2=B[1]
XU5 INV2 $PINS O=n49 I=B[3]
XU8 INV1S $PINS O=n47 I=B[5]
XU10 AN2 $PINS O=n3 I1=n2 I2=n49
XU11 AN2 $PINS O=n4 I1=n44 I2=n24
XU12 AN2 $PINS O=n5 I1=n43 I2=n4
XU13 AN2 $PINS O=n6 I1=n42 I2=n5
XU14 AN2 $PINS O=n7 I1=n41 I2=n6
XU15 AN2 $PINS O=n8 I1=n40 I2=n7
XU16 AN2 $PINS O=n9 I1=n39 I2=n8
XU17 AN2 $PINS O=n10 I1=n38 I2=n9
XU18 AN2 $PINS O=n11 I1=n37 I2=n10
XU19 AN2 $PINS O=n12 I1=n36 I2=n11
XU20 AN2 $PINS O=n13 I1=n35 I2=n12
XU21 AN2 $PINS O=n14 I1=n34 I2=n13
XU22 AN2 $PINS O=n15 I1=n33 I2=n14
XU23 AN2 $PINS O=n16 I1=n32 I2=n15
XU24 AN2 $PINS O=n17 I1=n31 I2=n16
XU25 AN2 $PINS O=n18 I1=n30 I2=n17
XU26 AN2 $PINS O=n19 I1=n29 I2=n18
XU27 AN2 $PINS O=n20 I1=n28 I2=n19
XU28 AN2T $PINS O=n21 I1=n48 I2=n3
XU29 AN2 $PINS O=n22 I1=n47 I2=n21
XU30 AN2 $PINS O=n23 I1=n46 I2=n22
XU31 AN2 $PINS O=n24 I1=n45 I2=n23
XU32 INV1S $PINS O=n44 I=B[8]
XU33 INV1S $PINS O=n43 I=B[9]
XU34 INV1S $PINS O=n42 I=B[10]
XU35 INV1S $PINS O=n41 I=B[11]
XU36 INV1S $PINS O=n40 I=B[12]
XU37 INV1S $PINS O=n39 I=B[13]
XU38 INV1S $PINS O=n38 I=B[14]
XU39 INV1S $PINS O=n37 I=B[15]
XU40 INV1S $PINS O=n36 I=B[16]
XU41 INV1S $PINS O=n35 I=B[17]
XU42 INV1S $PINS O=n34 I=B[18]
XU43 INV1S $PINS O=n33 I=B[19]
XU44 INV1S $PINS O=n32 I=B[20]
XU45 INV1S $PINS O=n31 I=B[21]
XU46 INV1S $PINS O=n30 I=B[22]
XU47 INV1S $PINS O=n29 I=B[23]
XU48 INV1S $PINS O=n28 I=B[24]
XU49 INV1S $PINS O=n27 I=B[25]
XU50 INV1S $PINS O=n46 I=B[6]
XU51 INV1S $PINS O=n45 I=B[7]
XU52 XOR2HS $PINS O=DIFF[26] I1=B[26] I2=n26
XU53 XOR2HS $PINS O=DIFF[9] I1=n43 I2=n4
XU54 XOR2HS $PINS O=DIFF[10] I1=n42 I2=n5
XU55 XOR2HS $PINS O=DIFF[11] I1=n41 I2=n6
XU56 XOR2HS $PINS O=DIFF[12] I1=n40 I2=n7
XU57 XOR2HS $PINS O=DIFF[13] I1=n39 I2=n8
XU58 XOR2HS $PINS O=DIFF[14] I1=n38 I2=n9
XU59 XOR2HS $PINS O=DIFF[15] I1=n37 I2=n10
XU60 XOR2HS $PINS O=DIFF[16] I1=n36 I2=n11
XU61 XOR2HS $PINS O=DIFF[17] I1=n35 I2=n12
XU62 XOR2HS $PINS O=DIFF[18] I1=n34 I2=n13
XU63 XOR2HS $PINS O=DIFF[19] I1=n33 I2=n14
XU64 XOR2HS $PINS O=DIFF[20] I1=n32 I2=n15
XU65 XOR2HS $PINS O=DIFF[21] I1=n31 I2=n16
XU66 XOR2HS $PINS O=DIFF[22] I1=n30 I2=n17
XU67 XOR2HS $PINS O=DIFF[23] I1=n29 I2=n18
XU68 XOR2HS $PINS O=DIFF[24] I1=n28 I2=n19
XU69 XOR2HS $PINS O=DIFF[25] I1=n27 I2=n20
XU70 XOR2HS $PINS O=DIFF[8] I1=n44 I2=n24
XU71 XOR2HS $PINS O=DIFF[7] I1=n45 I2=n23
XU72 XOR2HS $PINS O=DIFF[6] I1=n46 I2=n22
XU73 XOR2HS $PINS O=DIFF[5] I1=n47 I2=n21
XU74 XOR2HS $PINS O=DIFF[4] I1=n3 I2=n48
XU76 ND2 $PINS O=n26 I1=n27 I2=n20
XU6 AN2S $PINS O=n2 I1=B[2] I2=n1
.ENDS

.SUBCKT PE_Shift_Add_0_DW01_sub_2 A[26] A[25] A[24] A[23] A[22] A[21] A[20]
+ A[19] A[18] A[17] A[16] A[15] A[14] A[13] A[12] A[11] A[10] A[9] A[8] A[7]
+ A[6] A[5] A[4] A[3] A[2] A[1] A[0] B[26] B[25] B[24] B[23] B[22] B[21] B[20]
+ B[19] B[18] B[17] B[16] B[15] B[14] B[13] B[12] B[11] B[10] B[9] B[8] B[7]
+ B[6] B[5] B[4] B[3] B[2] B[1] B[0] CI DIFF[26] DIFF[25] DIFF[24] DIFF[23]
+ DIFF[22] DIFF[21] DIFF[20] DIFF[19] DIFF[18] DIFF[17] DIFF[16] DIFF[15]
+ DIFF[14] DIFF[13] DIFF[12] DIFF[11] DIFF[10] DIFF[9] DIFF[8] DIFF[7] DIFF[6]
+ DIFF[5] DIFF[4] DIFF[3] DIFF[2] DIFF[1] DIFF[0] CO
XFE_RC_1531_0 AN2 $PINS O=FE_RN_355_0 I1=n5 I2=n41
XFE_RC_1530_0 AN2 $PINS O=n7 I1=FE_RN_355_0 I2=n42
XFE_RC_1427_0 XOR2HS $PINS O=DIFF[3] I1=n1 I2=n49
XFE_RC_1290_0 ND2 $PINS O=FE_RN_260_0 I1=n51 I2=n52
XFE_RC_1289_0 XOR2HS $PINS O=DIFF[2] I1=FE_RN_260_0 I2=B[2]
XFE_RC_180_0 XOR2HS $PINS O=DIFF[1] I1=n52 I2=n51
XFE_OFC632_term1_shifted_8 INV1S $PINS O=n44 I=B[8]
XFE_OFC620_term1_shifted_4 INV2 $PINS O=n48 I=B[4]
XFE_OFC618_term1_shifted_3 INV2 $PINS O=n49 I=B[3]
XFE_OFC431_N14 INV2 $PINS O=n52 I=B[0]
XU7 XOR2HS $PINS O=DIFF[4] I1=n48 I2=n3
XU9 INV1S $PINS O=n47 I=B[5]
XU11 AN2 $PINS O=n3 I1=n49 I2=n1
XU13 ND2S $PINS O=n26 I1=n27 I2=n20
XU14 AN2 $PINS O=n4 I1=n44 I2=n24
XU15 AN2 $PINS O=n5 I1=n43 I2=n4
XU16 AN2 $PINS O=n6 I1=n42 I2=n5
XU18 AN2 $PINS O=n8 I1=n40 I2=n7
XU19 AN2 $PINS O=n9 I1=n39 I2=n8
XU20 AN2 $PINS O=n10 I1=n38 I2=n9
XU21 AN2 $PINS O=n11 I1=n37 I2=n10
XU22 AN2 $PINS O=n12 I1=n36 I2=n11
XU23 AN2 $PINS O=n13 I1=n35 I2=n12
XU24 AN2 $PINS O=n14 I1=n34 I2=n13
XU25 AN2 $PINS O=n15 I1=n33 I2=n14
XU26 AN2 $PINS O=n16 I1=n32 I2=n15
XU27 AN2 $PINS O=n17 I1=n31 I2=n16
XU28 AN2 $PINS O=n18 I1=n30 I2=n17
XU29 AN2 $PINS O=n19 I1=n29 I2=n18
XU30 AN2 $PINS O=n20 I1=n28 I2=n19
XU31 AN2T $PINS O=n21 I1=n48 I2=n3
XU32 AN2 $PINS O=n22 I1=n47 I2=n21
XU33 AN2 $PINS O=n23 I1=n46 I2=n22
XU34 AN2 $PINS O=n24 I1=n45 I2=n23
XU36 INV1S $PINS O=n43 I=B[9]
XU37 INV1S $PINS O=n42 I=B[10]
XU38 INV1S $PINS O=n41 I=B[11]
XU39 INV1S $PINS O=n40 I=B[12]
XU40 INV1S $PINS O=n39 I=B[13]
XU41 INV1S $PINS O=n38 I=B[14]
XU42 INV1S $PINS O=n37 I=B[15]
XU43 INV1S $PINS O=n36 I=B[16]
XU44 INV1S $PINS O=n35 I=B[17]
XU45 INV1S $PINS O=n34 I=B[18]
XU46 INV1S $PINS O=n33 I=B[19]
XU47 INV1S $PINS O=n32 I=B[20]
XU48 INV1S $PINS O=n31 I=B[21]
XU49 INV1S $PINS O=n30 I=B[22]
XU50 INV1S $PINS O=n29 I=B[23]
XU51 INV1S $PINS O=n28 I=B[24]
XU52 INV1S $PINS O=n27 I=B[25]
XU53 INV1S $PINS O=n46 I=B[6]
XU54 INV1S $PINS O=n45 I=B[7]
XU55 XOR2HS $PINS O=DIFF[12] I1=n40 I2=n7
XU56 XOR2HS $PINS O=DIFF[13] I1=n39 I2=n8
XU57 XOR2HS $PINS O=DIFF[14] I1=n38 I2=n9
XU58 XOR2HS $PINS O=DIFF[15] I1=n37 I2=n10
XU59 XOR2HS $PINS O=DIFF[16] I1=n36 I2=n11
XU60 XOR2HS $PINS O=DIFF[17] I1=n35 I2=n12
XU61 XOR2HS $PINS O=DIFF[18] I1=n34 I2=n13
XU62 XOR2HS $PINS O=DIFF[19] I1=n33 I2=n14
XU63 XOR2HS $PINS O=DIFF[20] I1=n32 I2=n15
XU64 XOR2HS $PINS O=DIFF[21] I1=n31 I2=n16
XU65 XOR2HS $PINS O=DIFF[22] I1=n30 I2=n17
XU66 XOR2HS $PINS O=DIFF[23] I1=n29 I2=n18
XU67 XOR2HS $PINS O=DIFF[24] I1=n28 I2=n19
XU68 XOR2HS $PINS O=DIFF[25] I1=n27 I2=n20
XU69 XOR2HS $PINS O=DIFF[11] I1=n41 I2=n6
XU70 XOR2HS $PINS O=DIFF[10] I1=n42 I2=n5
XU71 XOR2HS $PINS O=DIFF[9] I1=n43 I2=n4
XU72 XOR2HS $PINS O=DIFF[8] I1=n44 I2=n24
XU73 XOR2HS $PINS O=DIFF[7] I1=n45 I2=n23
XU74 XOR2HS $PINS O=DIFF[6] I1=n46 I2=n22
XU75 XOR2HS $PINS O=DIFF[5] I1=n47 I2=n21
XU77 XOR2HS $PINS O=DIFF[26] I1=B[26] I2=n26
XU3 NR3 $PINS O=n1 I1=B[0] I2=B[1] I3=B[2]
XU12 INV3 $PINS O=n51 I=B[1]
.ENDS

.SUBCKT PE_Shift_Add_0_DW01_add_2_DW01_add_16 A[26] A[25] A[24] A[23] A[22]
+ A[21] A[20] A[19] A[18] A[17] A[16] A[15] A[14] A[13] A[12] A[11] A[10] A[9]
+ A[8] A[7] A[6] A[5] A[4] A[3] A[2] A[1] A[0] B[26] B[25] B[24] B[23] B[22]
+ B[21] B[20] B[19] B[18] B[17] B[16] B[15] B[14] B[13] B[12] B[11] B[10] B[9]
+ B[8] B[7] B[6] B[5] B[4] B[3] B[2] B[1] B[0] CI SUM[26] SUM[25] SUM[24]
+ SUM[23] SUM[22] SUM[21] SUM[20] SUM[19] SUM[18] SUM[17] SUM[16] SUM[15]
+ SUM[14] SUM[13] SUM[12] SUM[11] SUM[10] SUM[9] SUM[8] SUM[7] SUM[6] SUM[5]
+ SUM[4] SUM[3] SUM[2] SUM[1] SUM[0] CO
XFE_OCPC713_carry_6 BUF2 $PINS O=FE_OCPN713_carry_6 I=carry[6]
XFE_RC_1656_0 ND2P $PINS O=FE_RN_420_0 I1=FE_RN_87_0 I2=carry[4]
XFE_RC_1655_0 ND2P $PINS O=carry[5] I1=FE_RN_420_0 I2=FE_RN_83_0
XFE_RC_1646_0 ND2 $PINS O=FE_RN_411_0 I1=B[5] I2=A[5]
XFE_RC_1645_0 ND2P $PINS O=FE_RN_412_0 I1=carry[5] I2=A[5]
XFE_RC_1644_0 ND2P $PINS O=FE_RN_413_0 I1=carry[5] I2=B[5]
XFE_RC_1643_0 ND3P $PINS O=carry[6] I1=FE_RN_413_0 I2=FE_RN_412_0
+ I3=FE_RN_411_0
XFE_RC_1577_0 ND3P $PINS O=n16 I1=FE_RN_69_0 I2=FE_RN_68_0 I3=FE_RN_70_0
XFE_RC_1447_0 ND3P $PINS O=carry[4] I1=n17 I2=n19 I3=n18
XFE_RC_1430_0 XOR3 $PINS O=SUM[21] I1=A[21] I2=B[21] I3=carry[21]
XFE_RC_1429_0 MAO222P $PINS O=carry[22] A1=carry[21] B1=B[21] C1=A[21]
XFE_RC_1260_0 MAO222 $PINS O=FE_RN_247_0 A1=A[17] B1=B[17] C1=carry[17]
XFE_RC_1259_0 MAO222P $PINS O=carry[19] A1=FE_RN_247_0 B1=B[18] C1=A[18]
XFE_RC_1080_0 XOR3 $PINS O=SUM[24] I1=A[24] I2=B[24] I3=carry[24]
XFE_RC_1079_0 MAO222P $PINS O=carry[25] A1=carry[24] B1=B[24] C1=A[24]
XFE_RC_1003_0 XOR3 $PINS O=SUM[25] I1=A[25] I2=B[25] I3=carry[25]
XFE_RC_1002_0 MAO222 $PINS O=carry[26] A1=A[25] B1=B[25] C1=carry[25]
XFE_RC_999_0 MAO222 $PINS O=carry[3] A1=A[2] B1=B[2] C1=carry[2]
XFE_RC_998_0 XOR3 $PINS O=SUM[2] I1=A[2] I2=carry[2] I3=B[2]
XFE_RC_967_0 INV2 $PINS O=SUM[26] I=FE_RN_140_0
XFE_RC_966_0 XOR2HS $PINS O=FE_RN_141_0 I1=A[26] I2=B[26]
XFE_RC_965_0 XNR2HS $PINS O=FE_RN_140_0 I1=FE_RN_141_0 I2=carry[26]
XFE_RC_950_0 INV2 $PINS O=FE_RN_87_0 I=FE_RN_133_0
XFE_RC_949_0 NR2P $PINS O=FE_RN_133_0 I1=B[4] I2=A[4]
XFE_RC_866_0 INV1S $PINS O=FE_RN_80_0 I=carry[4]
XFE_RC_865_0 XOR2HS $PINS O=FE_RN_81_0 I1=B[4] I2=A[4]
XFE_RC_864_0 ND2 $PINS O=FE_RN_82_0 I1=FE_RN_81_0 I2=FE_RN_80_0
XFE_RC_863_0 ND2 $PINS O=FE_RN_83_0 I1=A[4] I2=B[4]
XFE_RC_862_0 ND2 $PINS O=FE_RN_84_0 I1=FE_RN_83_0 I2=FE_RN_87_0
XFE_RC_861_0 ND2 $PINS O=FE_RN_85_0 I1=FE_RN_84_0 I2=carry[4]
XFE_RC_860_0 ND2P $PINS O=SUM[4] I1=FE_RN_85_0 I2=FE_RN_82_0
XFE_RC_855_0 ND2 $PINS O=FE_RN_77_0 I1=B[7] I2=A[7]
XFE_RC_854_0 ND2P $PINS O=FE_RN_78_0 I1=carry[7] I2=A[7]
XFE_RC_853_0 ND2P $PINS O=FE_RN_79_0 I1=carry[7] I2=B[7]
XFE_RC_852_0 ND3HT $PINS O=carry[8] I1=FE_RN_79_0 I2=FE_RN_78_0 I3=FE_RN_77_0
XFE_RC_845_0 ND2 $PINS O=FE_RN_71_0 I1=B[8] I2=A[8]
XFE_RC_844_0 ND2P $PINS O=FE_RN_72_0 I1=carry[8] I2=A[8]
XFE_RC_843_0 ND2P $PINS O=FE_RN_73_0 I1=carry[8] I2=B[8]
XFE_RC_842_0 ND3P $PINS O=carry[9] I1=FE_RN_73_0 I2=FE_RN_72_0 I3=FE_RN_71_0
XFE_RC_841_0 ND2 $PINS O=FE_RN_68_0 I1=B[2] I2=carry[2]
XFE_RC_840_0 ND2 $PINS O=FE_RN_69_0 I1=B[2] I2=A[2]
XFE_RC_839_0 ND2 $PINS O=FE_RN_70_0 I1=A[2] I2=carry[2]
XFE_RC_795_0 XOR3 $PINS O=SUM[11] I1=A[11] I2=B[11] I3=carry[11]
XFE_RC_794_0 MAO222P $PINS O=carry[12] A1=carry[11] B1=B[11] C1=A[11]
XFE_RC_715_0 XOR3 $PINS O=SUM[19] I1=A[19] I2=B[19] I3=carry[19]
XFE_RC_714_0 MAO222P $PINS O=carry[20] A1=carry[19] B1=B[19] C1=A[19]
XFE_RC_705_0 XOR3 $PINS O=SUM[15] I1=A[15] I2=B[15] I3=carry[15]
XFE_RC_703_0 XOR3 $PINS O=SUM[20] I1=A[20] I2=B[20] I3=carry[20]
XFE_RC_702_0 MAO222P $PINS O=carry[21] A1=carry[20] B1=B[20] C1=A[20]
XFE_RC_657_0 XOR3 $PINS O=SUM[18] I1=A[18] I2=B[18] I3=carry[18]
XFE_RC_565_0 XOR3 $PINS O=SUM[1] I1=A[1] I2=B[1] I3=carry[1]
XFE_RC_564_0 MAO222 $PINS O=carry[2] A1=A[1] B1=B[1] C1=carry[1]
XFE_RC_563_0 XOR3 $PINS O=SUM[5] I1=A[5] I2=B[5] I3=carry[5]
XFE_RC_527_0 XOR3 $PINS O=SUM[6] I1=A[6] I2=B[6] I3=FE_OCPN713_carry_6
XFE_RC_526_0 MAO222P $PINS O=carry[7] A1=carry[6] B1=B[6] C1=A[6]
XFE_RC_430_0 XOR3 $PINS O=SUM[7] I1=A[7] I2=B[7] I3=carry[7]
XFE_RC_337_0 XOR3 $PINS O=SUM[12] I1=A[12] I2=B[12] I3=carry[12]
XFE_RC_336_0 MAO222P $PINS O=carry[13] A1=carry[12] B1=B[12] C1=A[12]
XFE_RC_335_0 XOR3 $PINS O=SUM[8] I1=A[8] I2=B[8] I3=carry[8]
XFE_RC_268_0 XOR3 $PINS O=SUM[9] I1=A[9] I2=B[9] I3=carry[9]
XFE_RC_267_0 MAO222 $PINS O=carry[10] A1=carry[9] B1=B[9] C1=A[9]
XFE_RC_225_0 XOR3 $PINS O=SUM[10] I1=A[10] I2=B[10] I3=carry[10]
XFE_RC_224_0 MAO222 $PINS O=carry[11] A1=carry[10] B1=B[10] C1=A[10]
XFE_RC_198_0 XOR3 $PINS O=SUM[13] I1=A[13] I2=B[13] I3=carry[13]
XFE_RC_197_0 MAO222P $PINS O=carry[14] A1=carry[13] B1=B[13] C1=A[13]
XU1_17 FA1 $PINS S=SUM[17] CO=carry[18] A=A[17] B=B[17] CI=carry[17]
XU1 ND2 $PINS O=n3 I1=B[14] I2=A[14]
XU5 ND2 $PINS O=n19 I1=n16 I2=B[3]
XU7 XOR3 $PINS O=SUM[14] I1=B[14] I2=A[14] I3=carry[14]
XU8 ND2P $PINS O=n1 I1=carry[14] I2=B[14]
XU9 ND2 $PINS O=n2 I1=carry[14] I2=A[14]
XU10 ND3P $PINS O=carry[15] I1=n2 I2=n1 I3=n3
XU12 ND2 $PINS O=n17 I1=n16 I2=A[3]
XU14 ND3 $PINS O=carry[24] I1=n10 I2=n11 I3=n12
XU15 MAO222 $PINS O=n4 A1=carry[15] B1=B[15] C1=A[15]
XU16 XOR2HS $PINS O=n5 I1=A[22] I2=B[22]
XU17 ND2 $PINS O=n6 I1=carry[22] I2=A[22]
XU18 ND2 $PINS O=n7 I1=carry[22] I2=B[22]
XU19 ND2S $PINS O=n8 I1=A[22] I2=B[22]
XU20 INV1S $PINS O=carry[1] I=n20
XU21 XOR2HS $PINS O=n9 I1=A[23] I2=B[23]
XU22 XOR2HS $PINS O=SUM[23] I1=carry[23] I2=n9
XU23 ND2 $PINS O=n10 I1=carry[23] I2=A[23]
XU24 ND2 $PINS O=n11 I1=carry[23] I2=B[23]
XU25 ND2S $PINS O=n12 I1=A[23] I2=B[23]
XU26 XOR3 $PINS O=SUM[16] I1=B[16] I2=A[16] I3=n4
XU27 ND2 $PINS O=n13 I1=n4 I2=B[16]
XU28 ND2 $PINS O=n14 I1=n4 I2=A[16]
XU29 ND2S $PINS O=n15 I1=B[16] I2=A[16]
XU30 ND2 $PINS O=n18 I1=B[3] I2=A[3]
XU32 XOR2HS $PINS O=SUM[0] I1=B[0] I2=A[0]
XU2 ND2 $PINS O=n20 I1=B[0] I2=A[0]
XU3 ND3P $PINS O=carry[23] I1=n6 I2=n7 I3=n8
XU4 XOR3 $PINS O=SUM[3] I1=A[3] I2=B[3] I3=carry[3]
XU6 XOR2HS $PINS O=SUM[22] I1=carry[22] I2=n5
XU13 ND3P $PINS O=carry[17] I1=n13 I2=n14 I3=n15
.ENDS

.SUBCKT PE_Shift_Add_0_DW01_add_1_DW01_add_15 A[26] A[25] A[24] A[23] A[22]
+ A[21] A[20] A[19] A[18] A[17] A[16] A[15] A[14] A[13] A[12] A[11] A[10] A[9]
+ A[8] A[7] A[6] A[5] A[4] A[3] A[2] A[1] A[0] B[26] B[25] B[24] B[23] B[22]
+ B[21] B[20] B[19] B[18] B[17] B[16] B[15] B[14] B[13] B[12] B[11] B[10] B[9]
+ B[8] B[7] B[6] B[5] B[4] B[3] B[2] B[1] B[0] CI SUM[26] SUM[25] SUM[24]
+ SUM[23] SUM[22] SUM[21] SUM[20] SUM[19] SUM[18] SUM[17] SUM[16] SUM[15]
+ SUM[14] SUM[13] SUM[12] SUM[11] SUM[10] SUM[9] SUM[8] SUM[7] SUM[6] SUM[5]
+ SUM[4] SUM[3] SUM[2] SUM[1] SUM[0] CO
XFE_RC_1697_0 ND2 $PINS O=FE_RN_440_0 I1=B[4] I2=A[4]
XFE_RC_1696_0 ND2 $PINS O=FE_RN_441_0 I1=carry[4] I2=A[4]
XFE_RC_1695_0 ND2 $PINS O=FE_RN_442_0 I1=carry[4] I2=B[4]
XFE_RC_1694_0 ND3P $PINS O=carry[5] I1=FE_RN_442_0 I2=FE_RN_441_0
+ I3=FE_RN_440_0
XFE_RC_1687_0 ND3P $PINS O=carry[2] I1=n5 I2=n7 I3=n6
XFE_RC_1662_0 ND3P $PINS O=carry[3] I1=n9 I2=n11 I3=n10
XFE_RC_1548_0 XOR2HS $PINS O=FE_RN_365_0 I1=A[26] I2=B[26]
XFE_RC_1547_0 XOR2H $PINS O=SUM[26] I1=FE_RN_365_0 I2=carry[26]
XFE_RC_1428_0 XOR2HS $PINS O=SUM[2] I1=carry[2] I2=n8
XFE_RC_1402_0 XOR3 $PINS O=SUM[25] I1=A[25] I2=B[25] I3=carry[25]
XFE_RC_1401_0 MAO222 $PINS O=carry[26] A1=A[25] B1=B[25] C1=carry[25]
XFE_RC_1391_0 ND3HT $PINS O=carry[8] I1=n18 I2=n19 I3=n17
XFE_RC_1059_0 XOR3 $PINS O=SUM[24] I1=A[24] I2=B[24] I3=carry[24]
XFE_RC_1058_0 MAO222P $PINS O=carry[25] A1=carry[24] B1=B[24] C1=A[24]
XFE_RC_990_0 XOR3 $PINS O=SUM[23] I1=A[23] I2=B[23] I3=carry[23]
XFE_RC_989_0 MAO222P $PINS O=carry[24] A1=carry[23] B1=B[23] C1=A[23]
XFE_RC_876_0 ND3 $PINS O=FE_RN_93_0 I1=n22 I2=n23 I3=n21
XFE_RC_875_0 OAI12H $PINS O=FE_RN_43_0 A1=A[9] B1=FE_RN_93_0 B2=B[9]
XFE_RC_770_0 XOR3 $PINS O=SUM[3] I1=A[3] I2=B[3] I3=carry[3]
XFE_RC_769_0 MAO222 $PINS O=carry[4] A1=carry[3] B1=B[3] C1=A[3]
XFE_RC_729_0 XOR3 $PINS O=SUM[21] I1=A[21] I2=B[21] I3=carry[21]
XFE_RC_728_0 MAO222 $PINS O=carry[22] A1=carry[21] B1=B[21] C1=A[21]
XFE_RC_693_0 XOR3 $PINS O=SUM[22] I1=A[22] I2=B[22] I3=carry[22]
XFE_RC_692_0 MAO222 $PINS O=carry[23] A1=carry[22] B1=B[22] C1=A[22]
XFE_RC_649_0 XOR3 $PINS O=SUM[20] I1=A[20] I2=B[20] I3=carry[20]
XFE_RC_648_0 MAO222 $PINS O=carry[21] A1=carry[20] B1=B[20] C1=A[20]
XFE_RC_599_0 XOR3 $PINS O=SUM[12] I1=A[12] I2=B[12] I3=carry[12]
XFE_RC_598_0 MAO222 $PINS O=carry[13] A1=carry[12] B1=B[12] C1=A[12]
XFE_RC_559_0 XOR3 $PINS O=SUM[13] I1=A[13] I2=B[13] I3=carry[13]
XFE_RC_558_0 MAO222 $PINS O=carry[14] A1=carry[13] B1=B[13] C1=A[13]
XFE_RC_517_0 XOR3 $PINS O=SUM[14] I1=A[14] I2=B[14] I3=carry[14]
XFE_RC_516_0 MAO222P $PINS O=carry[15] A1=carry[14] B1=B[14] C1=A[14]
XFE_RC_470_0 ND2 $PINS O=FE_RN_42_0 I1=carry[9] I2=B[9]
XFE_RC_468_0 ND2P $PINS O=carry[10] I1=FE_RN_43_0 I2=FE_RN_42_0
XFE_RC_452_0 XOR3 $PINS O=SUM[15] I1=A[15] I2=B[15] I3=carry[15]
XFE_RC_451_0 MAO222P $PINS O=carry[16] A1=carry[15] B1=B[15] C1=A[15]
XFE_RC_402_0 XOR3 $PINS O=SUM[16] I1=A[16] I2=B[16] I3=carry[16]
XFE_RC_401_0 MAO222P $PINS O=carry[17] A1=carry[16] B1=B[16] C1=A[16]
XFE_RC_307_0 XOR3 $PINS O=SUM[4] I1=A[4] I2=B[4] I3=carry[4]
XFE_RC_301_0 XOR3 $PINS O=SUM[17] I1=A[17] I2=B[17] I3=carry[17]
XFE_RC_300_0 MAO222P $PINS O=carry[18] A1=carry[17] B1=B[17] C1=A[17]
XFE_RC_227_0 XOR3 $PINS O=SUM[5] I1=A[5] I2=B[5] I3=carry[5]
XFE_RC_226_0 MAO222P $PINS O=carry[6] A1=carry[5] B1=B[5] C1=A[5]
XFE_RC_221_0 XOR3 $PINS O=SUM[18] I1=A[18] I2=B[18] I3=carry[18]
XFE_RC_220_0 MAO222P $PINS O=carry[19] A1=carry[18] B1=B[18] C1=A[18]
XFE_RC_155_0 XOR3 $PINS O=SUM[19] I1=A[19] I2=B[19] I3=carry[19]
XFE_RC_154_0 MAO222P $PINS O=carry[20] A1=carry[19] B1=B[19] C1=A[19]
XFE_RC_107_0 XOR3 $PINS O=SUM[6] I1=A[6] I2=B[6] I3=carry[6]
XFE_RC_106_0 MAO222P $PINS O=carry[7] A1=carry[6] B1=B[6] C1=A[6]
XFE_RC_91_0 XOR3 $PINS O=SUM[9] I1=A[9] I2=B[9] I3=carry[9]
XU2 ND3P $PINS O=carry[11] I1=n2 I2=n3 I3=n4
XU3 XOR3 $PINS O=SUM[10] I1=B[10] I2=A[10] I3=carry[10]
XU4 ND2 $PINS O=n2 I1=carry[10] I2=B[10]
XU5 ND2 $PINS O=n3 I1=carry[10] I2=A[10]
XU6 ND2 $PINS O=n4 I1=B[10] I2=A[10]
XU7 ND3 $PINS O=carry[9] I1=n23 I2=n22 I3=n21
XU8 XOR3 $PINS O=SUM[1] I1=A[1] I2=carry[1] I3=B[1]
XU9 INV1S $PINS O=carry[1] I=n27
XU10 ND2 $PINS O=n17 I1=A[7] I2=B[7]
XU14 XOR3 $PINS O=SUM[7] I1=A[7] I2=B[7] I3=carry[7]
XU15 ND2 $PINS O=n5 I1=B[1] I2=A[1]
XU16 ND2 $PINS O=n6 I1=A[1] I2=carry[1]
XU17 ND2 $PINS O=n7 I1=B[1] I2=carry[1]
XU19 XOR2HS $PINS O=n8 I1=A[2] I2=B[2]
XU21 ND2 $PINS O=n9 I1=B[2] I2=A[2]
XU22 ND2 $PINS O=n10 I1=A[2] I2=carry[2]
XU23 ND2 $PINS O=n11 I1=B[2] I2=carry[2]
XU26 XOR2HS $PINS O=n13 I1=B[11] I2=A[11]
XU27 XOR2HS $PINS O=SUM[11] I1=carry[11] I2=n13
XU28 ND2 $PINS O=n14 I1=carry[11] I2=B[11]
XU29 ND2 $PINS O=n15 I1=carry[11] I2=A[11]
XU30 ND2 $PINS O=n16 I1=B[11] I2=A[11]
XU31 ND2 $PINS O=n18 I1=carry[7] I2=A[7]
XU32 ND2 $PINS O=n19 I1=carry[7] I2=B[7]
XU34 XOR2HS $PINS O=n20 I1=A[8] I2=B[8]
XU35 XOR2HS $PINS O=SUM[8] I1=n20 I2=carry[8]
XU36 ND2 $PINS O=n21 I1=B[8] I2=A[8]
XU37 ND2P $PINS O=n22 I1=carry[8] I2=A[8]
XU38 ND2P $PINS O=n23 I1=carry[8] I2=B[8]
XU41 XOR2HS $PINS O=SUM[0] I1=B[0] I2=A[0]
XU42 ND2 $PINS O=n27 I1=B[0] I2=A[0]
XU40 ND3P $PINS O=carry[12] I1=n15 I2=n14 I3=n16
.ENDS

.SUBCKT PE_Shift_Add_0_DW01_add_0_DW01_add_14 A[26] A[25] A[24] A[23] A[22]
+ A[21] A[20] A[19] A[18] A[17] A[16] A[15] A[14] A[13] A[12] A[11] A[10] A[9]
+ A[8] A[7] A[6] A[5] A[4] A[3] A[2] A[1] A[0] B[26] B[25] B[24] B[23] B[22]
+ B[21] B[20] B[19] B[18] B[17] B[16] B[15] B[14] B[13] B[12] B[11] B[10] B[9]
+ B[8] B[7] B[6] B[5] B[4] B[3] B[2] B[1] B[0] CI SUM[26] SUM[25] SUM[24]
+ SUM[23] SUM[22] SUM[21] SUM[20] SUM[19] SUM[18] SUM[17] SUM[16] SUM[15]
+ SUM[14] SUM[13] SUM[12] SUM[11] SUM[10] SUM[9] SUM[8] SUM[7] SUM[6] SUM[5]
+ SUM[4] SUM[3] SUM[2] SUM[1] SUM[0] CO
XFE_PHC1060_next_acc_0 DELB $PINS O=SUM[0] I=FE_PHN1060_next_acc_0
XFE_RC_1691_0 ND2 $PINS O=FE_RN_436_0 I1=A[3] I2=B[3]
XFE_RC_1690_0 ND2 $PINS O=FE_RN_437_0 I1=carry[3] I2=A[3]
XFE_RC_1689_0 ND2 $PINS O=FE_RN_438_0 I1=carry[3] I2=B[3]
XFE_RC_1688_0 ND3P $PINS O=carry[4] I1=FE_RN_438_0 I2=FE_RN_437_0
+ I3=FE_RN_436_0
XFE_RC_1635_0 ND2 $PINS O=FE_RN_404_0 I1=A[4] I2=B[4]
XFE_RC_1634_0 ND2 $PINS O=FE_RN_405_0 I1=carry[4] I2=A[4]
XFE_RC_1633_0 ND2 $PINS O=FE_RN_406_0 I1=carry[4] I2=B[4]
XFE_RC_1632_0 ND3P $PINS O=carry[5] I1=FE_RN_406_0 I2=FE_RN_405_0
+ I3=FE_RN_404_0
XFE_RC_1612_0 ND3HT $PINS O=carry[8] I1=FE_RN_328_0 I2=FE_RN_330_0
+ I3=FE_RN_329_0
XFE_RC_1603_0 ND2 $PINS O=FE_RN_390_0 I1=A[5] I2=B[5]
XFE_RC_1602_0 ND2 $PINS O=FE_RN_391_0 I1=carry[5] I2=A[5]
XFE_RC_1601_0 ND2 $PINS O=FE_RN_392_0 I1=carry[5] I2=B[5]
XFE_RC_1600_0 ND3P $PINS O=carry[6] I1=FE_RN_392_0 I2=FE_RN_391_0
+ I3=FE_RN_390_0
XFE_RC_1587_0 ND2 $PINS O=FE_RN_380_0 I1=A[8] I2=B[8]
XFE_RC_1586_0 ND2P $PINS O=FE_RN_381_0 I1=carry[8] I2=A[8]
XFE_RC_1585_0 ND2P $PINS O=FE_RN_382_0 I1=carry[8] I2=B[8]
XFE_RC_1584_0 ND3P $PINS O=carry[9] I1=FE_RN_382_0 I2=FE_RN_381_0
+ I3=FE_RN_380_0
XFE_RC_1581_0 ND2 $PINS O=FE_RN_376_0 I1=B[1] I2=n4
XFE_RC_1580_0 ND2 $PINS O=FE_RN_377_0 I1=A[1] I2=n4
XFE_RC_1579_0 ND2 $PINS O=FE_RN_378_0 I1=A[1] I2=B[1]
XFE_RC_1578_0 ND3P $PINS O=carry[2] I1=FE_RN_378_0 I2=FE_RN_377_0
+ I3=FE_RN_376_0
XFE_RC_1463_0 ND2P $PINS O=FE_RN_328_0 I1=A[7] I2=B[7]
XFE_RC_1462_0 ND2T $PINS O=FE_RN_329_0 I1=carry[7] I2=B[7]
XFE_RC_1461_0 ND2T $PINS O=FE_RN_330_0 I1=carry[7] I2=A[7]
XFE_RC_1287_0 INV1S $PINS O=FE_RN_259_0 I=A[15]
XFE_RC_1286_0 AO13 $PINS O=n12 A1=FE_RN_259_0 B1=n16 B2=n15 B3=n17
XFE_RC_1173_0 XOR3 $PINS O=SUM[1] I1=A[1] I2=B[1] I3=n4
XFE_RC_814_0 XNR2H $PINS O=FE_RN_55_0 I1=A[26] I2=B[26]
XFE_RC_813_0 XNR2HS $PINS O=SUM[26] I1=carry[26] I2=FE_RN_55_0
XFE_RC_681_0 XOR3 $PINS O=SUM[4] I1=A[4] I2=B[4] I3=carry[4]
XFE_RC_635_0 XOR3 $PINS O=SUM[3] I1=A[3] I2=B[3] I3=carry[3]
XFE_RC_567_0 XOR3 $PINS O=SUM[2] I1=carry[2] I2=B[2] I3=A[2]
XFE_RC_566_0 MAO222P $PINS O=carry[3] A1=A[2] B1=B[2] C1=carry[2]
XFE_RC_533_0 XOR3 $PINS O=SUM[5] I1=A[5] I2=B[5] I3=carry[5]
XFE_RC_482_0 XOR3 $PINS O=SUM[25] I1=A[25] I2=B[25] I3=carry[25]
XFE_RC_481_0 MAO222 $PINS O=carry[26] A1=carry[25] B1=B[25] C1=A[25]
XFE_RC_474_0 XOR3 $PINS O=SUM[6] I1=A[6] I2=B[6] I3=carry[6]
XFE_RC_473_0 MAO222P $PINS O=carry[7] A1=carry[6] B1=B[6] C1=A[6]
XFE_RC_388_0 XOR3 $PINS O=SUM[7] I1=A[7] I2=B[7] I3=carry[7]
XFE_RC_382_0 XOR3 $PINS O=SUM[24] I1=A[24] I2=B[24] I3=carry[24]
XFE_RC_381_0 MAO222P $PINS O=carry[25] A1=carry[24] B1=B[24] C1=A[24]
XFE_RC_278_0 XOR3 $PINS O=SUM[8] I1=A[8] I2=B[8] I3=carry[8]
XFE_RC_186_0 XOR3P $PINS O=SUM[21] I1=A[21] I2=B[21] I3=carry[21]
XFE_RC_185_0 MAO222P $PINS O=carry[22] A1=carry[21] B1=B[21] C1=A[21]
XFE_RC_182_0 XOR3 $PINS O=SUM[9] I1=A[9] I2=B[9] I3=carry[9]
XFE_RC_181_0 MAO222P $PINS O=carry[10] A1=carry[9] B1=B[9] C1=A[9]
XFE_RC_124_0 XOR3T $PINS O=SUM[13] I1=A[13] I2=B[13] I3=carry[13]
XFE_RC_123_0 MAO222P $PINS O=carry[14] A1=carry[13] B1=B[13] C1=A[13]
XFE_RC_117_0 XOR3 $PINS O=SUM[23] I1=A[23] I2=B[23] I3=carry[23]
XFE_RC_116_0 MAO222P $PINS O=carry[24] A1=carry[23] B1=B[23] C1=A[23]
XFE_RC_51_0 XOR3 $PINS O=SUM[22] I1=A[22] I2=B[22] I3=carry[22]
XFE_RC_50_0 MAO222P $PINS O=carry[23] A1=carry[22] B1=B[22] C1=A[22]
XFE_RC_47_0 XOR3P $PINS O=SUM[19] I1=A[19] I2=B[19] I3=carry[19]
XFE_RC_46_0 MAO222 $PINS O=carry[20] A1=carry[19] B1=B[19] C1=A[19]
XFE_RC_37_0 XOR3S $PINS O=SUM[17] I1=A[17] I2=B[17] I3=carry[17]
XFE_RC_36_0 MAO222P $PINS O=carry[18] A1=carry[17] B1=B[17] C1=A[17]
XU2 ND3 $PINS O=carry[19] I1=n22 I2=n21 I3=n23
XU3 XOR3 $PINS O=SUM[10] I1=A[10] I2=B[10] I3=carry[10]
XU4 ND2 $PINS O=n1 I1=carry[10] I2=A[10]
XU5 ND2 $PINS O=n2 I1=carry[10] I2=B[10]
XU6 ND2 $PINS O=n3 I1=A[10] I2=B[10]
XU7 ND3P $PINS O=carry[11] I1=n2 I2=n1 I3=n3
XU8 ND3P $PINS O=carry[21] I1=n24 I2=n25 I3=n26
XU9 ND2 $PINS O=n5 I1=A[11] I2=B[11]
XU10 XOR3 $PINS O=SUM[14] I1=B[14] I2=A[14] I3=carry[14]
XU11 XOR3 $PINS O=SUM[15] I1=A[15] I2=B[15] I3=carry[15]
XU12 XOR3 $PINS O=SUM[16] I1=B[16] I2=A[16] I3=carry[16]
XU13 XOR3 $PINS O=SUM[18] I1=B[18] I2=A[18] I3=carry[18]
XU14 XOR3 $PINS O=SUM[20] I1=A[20] I2=B[20] I3=carry[20]
XU15 AN2 $PINS O=n4 I1=B[0] I2=A[0]
XU16 ND2 $PINS O=n6 I1=carry[11] I2=A[11]
XU17 ND2 $PINS O=n7 I1=carry[11] I2=B[11]
XU18 ND3P $PINS O=carry[12] I1=n7 I2=n6 I3=n5
XU19 XOR2HS $PINS O=n8 I1=A[12] I2=B[12]
XU20 XOR2HS $PINS O=SUM[12] I1=n8 I2=carry[12]
XU21 ND2 $PINS O=n9 I1=A[12] I2=B[12]
XU22 ND2 $PINS O=n10 I1=carry[12] I2=A[12]
XU23 ND2 $PINS O=n11 I1=carry[12] I2=B[12]
XU24 ND3P $PINS O=carry[13] I1=n10 I2=n11 I3=n9
XU26 ND2 $PINS O=n13 I1=carry[15] I2=B[15]
XU27 ND2 $PINS O=n14 I1=A[15] I2=B[15]
XU28 ND3P $PINS O=carry[16] I1=n12 I2=n13 I3=n14
XU29 ND2P $PINS O=n15 I1=carry[14] I2=B[14]
XU30 ND2P $PINS O=n16 I1=carry[14] I2=A[14]
XU31 ND2 $PINS O=n17 I1=B[14] I2=A[14]
XU32 ND3P $PINS O=carry[15] I1=n15 I2=n16 I3=n17
XU33 ND2 $PINS O=n18 I1=carry[16] I2=B[16]
XU34 ND2 $PINS O=n19 I1=carry[16] I2=A[16]
XU35 ND2 $PINS O=n20 I1=B[16] I2=A[16]
XU36 ND3P $PINS O=carry[17] I1=n18 I2=n19 I3=n20
XU37 ND2 $PINS O=n21 I1=carry[18] I2=B[18]
XU38 ND2 $PINS O=n22 I1=carry[18] I2=A[18]
XU39 ND2S $PINS O=n23 I1=B[18] I2=A[18]
XU40 ND2 $PINS O=n24 I1=carry[20] I2=A[20]
XU41 ND2 $PINS O=n25 I1=carry[20] I2=B[20]
XU42 ND2 $PINS O=n26 I1=A[20] I2=B[20]
XU43 XOR2HS $PINS O=FE_PHN1060_next_acc_0 I1=B[0] I2=A[0]
XU1 XOR3 $PINS O=SUM[11] I1=A[11] I2=B[11] I3=carry[11]
.ENDS

.SUBCKT PE_Shift_Add_0 rst_n en clear calc_done stage_sel x_in[16] x_in[15]
+ x_in[14] x_in[13] x_in[12] x_in[11] x_in[10] x_in[9] x_in[8] x_in[7] x_in[6]
+ x_in[5] x_in[4] x_in[3] x_in[2] x_in[1] x_in[0] sign1[1] sign1[0] sign2[1]
+ sign2[0] sign3[1] sign3[0] shf1[3] shf1[2] shf1[1] shf1[0] shf2[3] shf2[2]
+ shf2[1] shf2[0] shf3[3] shf3[2] shf3[1] shf3[0] y_out[16] y_out[15] y_out[14]
+ y_out[13] y_out[12] y_out[11] y_out[10] y_out[9] y_out[8] y_out[7] y_out[6]
+ y_out[5] y_out[4] y_out[3] y_out[2] y_out[1] y_out[0] i_rst_n FE_OFN5_i_rst_n
+ FE_OFN40_FE_DBTN10_n289 FE_OFN66_s32_1 FE_OFN80_n FE_OFN73_n
+ FE_OFN120_mac_in_imag_3 FE_OFN346_mac_in_imag_0 clk_clone3 clk_clone2
+ clk_clone1 clk
XFE_PHC1348_N245 DELB $PINS O=N245 I=FE_PHN1348_N245
XFE_PHC1338_N242 DELB $PINS O=FE_PHN1338_N242 I=N242
XFE_PHC1325_N248 DELB $PINS O=FE_PHN1325_N248 I=N248
XFE_PHC1312_N247 DELB $PINS O=N247 I=FE_PHN1312_N247
XFE_PHC1186_pe_i3_11 DELC $PINS O=y_out[11] I=FE_PHN1186_pe_i3_11
XFE_PHC1163_acc_reg_21 DELB $PINS O=FE_PHN1163_acc_reg_21 I=acc_reg[21]
XFE_PHC999_N236 DELB $PINS O=N236 I=FE_PHN999_N236
XFE_PHC998_N237 DELB $PINS O=FE_PHN998_N237 I=N237
XFE_PHC997_N240 DELB $PINS O=FE_PHN997_N240 I=N240
XFE_PHC996_N235 DELB $PINS O=N235 I=FE_PHN996_N235
XFE_PHC993_N239 DELB $PINS O=N239 I=FE_PHN993_N239
XFE_PHC985_N244 DELB $PINS O=N244 I=FE_PHN985_N244
XFE_PHC983_N238 DELB $PINS O=FE_PHN983_N238 I=N238
XFE_PHC976_N241 DELB $PINS O=N241 I=FE_PHN976_N241
XFE_PHC954_N243 DELB $PINS O=FE_PHN954_N243 I=N243
XFE_PHC936_acc_reg_24 DELB $PINS O=FE_PHN936_acc_reg_24 I=acc_reg[24]
XFE_PHC930_acc_reg_25 DELB $PINS O=FE_PHN930_acc_reg_25 I=acc_reg[25]
XFE_PHC774_pe_i3_1 DELC $PINS O=y_out[1] I=FE_PHN774_pe_i3_1
XFE_PHC770_pe_i3_3 DELC $PINS O=y_out[3] I=FE_PHN770_pe_i3_3
XFE_PHC757_pe_i3_0 DELC $PINS O=y_out[0] I=FE_PHN757_pe_i3_0
XFE_PHC750_pe_i3_8 DELC $PINS O=y_out[8] I=FE_PHN750_pe_i3_8
XFE_PHC746_pe_i3_7 DELC $PINS O=y_out[7] I=FE_PHN746_pe_i3_7
XFE_PHC744_pe_i3_6 DELC $PINS O=y_out[6] I=FE_PHN744_pe_i3_6
XFE_PHC741_pe_i3_5 DELC $PINS O=y_out[5] I=FE_PHN741_pe_i3_5
XFE_PHC731_N251 DELC $PINS O=FE_PHN731_N251 I=N251
XFE_RC_1781_0 AO22 $PINS O=N44 A1=term1_shifted[3] A2=FE_DBTN24_s31_0 B1=N17
+ B2=FE_OFN130_s31_0
XFE_OCPC711_term3_shifted_2 BUF1S $PINS O=FE_OCPN711_term3_shifted_2
+ I=term3_shifted[2]
XFE_RC_1710_0 AO22 $PINS O=N49 A1=term1_shifted[8] A2=FE_DBTN24_s31_0 B1=N22
+ B2=FE_OFN130_s31_0
XFE_RC_1706_0 INV1S $PINS O=FE_RN_445_0 I=shf2[1]
XFE_RC_1705_0 AO22P $PINS O=sll_17/ML_int[2][2] A1=sll_17/ML_int[1][0]
+ A2=shf2[1] B1=sll_17/ML_int[1][2] B2=FE_RN_445_0
XFE_RC_1676_0 AOI22H $PINS O=FE_RN_269_0 A1=term2_shifted[1] A2=FE_OFN167_s32_0
+ B1=N70 B2=sign2[0]
XFE_RC_1661_0 ND2 $PINS O=FE_RN_422_0 I1=term3_shifted[1] I2=n25
XFE_RC_1660_0 ND2 $PINS O=FE_RN_423_0 I1=N125 I2=FE_OFN297_s33_0
XFE_RC_1659_0 ND2 $PINS O=N152 I1=FE_RN_423_0 I2=FE_RN_422_0
XFE_RC_1641_0 ND2S $PINS O=FE_RN_408_0 I1=n8 I2=shf3[2]
XFE_RC_1640_0 INV1S $PINS O=FE_RN_409_0 I=shf3[2]
XFE_RC_1639_0 ND2P $PINS O=FE_RN_410_0 I1=sll_18/ML_int[2][4] I2=FE_RN_409_0
XFE_RC_1638_0 ND2P $PINS O=sll_18/ML_int[3][4] I1=FE_RN_410_0 I2=FE_RN_408_0
XFE_RC_1616_0 ND2 $PINS O=FE_RN_398_0 I1=term1_shifted[6] I2=FE_DBTN24_s31_0
XFE_RC_1615_0 ND2 $PINS O=FE_RN_399_0 I1=N20 I2=FE_OFN130_s31_0
XFE_RC_1614_0 ND2 $PINS O=N47 I1=FE_RN_399_0 I2=FE_RN_398_0
XFE_RC_1611_0 INV1S $PINS O=FE_RN_396_0 I=FE_OFN130_s31_0
XFE_RC_1610_0 INV2 $PINS O=FE_RN_397_0 I=N18
XFE_RC_1609_0 MOAI1H $PINS O=N45 A1=FE_RN_397_0 A2=FE_RN_396_0
+ B1=term1_shifted[4] B2=FE_DBTN24_s31_0
XFE_RC_1599_0 ND2 $PINS O=FE_RN_387_0 I1=sll_16/ML_int[1][0] I2=shf1[1]
XFE_RC_1598_0 INV2 $PINS O=FE_RN_388_0 I=shf1[1]
XFE_RC_1597_0 ND2 $PINS O=FE_RN_389_0 I1=sll_16/ML_int[1][2] I2=FE_RN_388_0
XFE_RC_1596_0 ND2 $PINS O=sll_16/ML_int[2][2] I1=FE_RN_389_0 I2=FE_RN_387_0
XFE_RC_1594_0 ND2 $PINS O=FE_RN_385_0 I1=term1_shifted[7] I2=FE_DBTN24_s31_0
XFE_RC_1593_0 ND2S $PINS O=FE_RN_386_0 I1=N21 I2=FE_OFN130_s31_0
XFE_RC_1592_0 ND2P $PINS O=N48 I1=FE_RN_386_0 I2=FE_RN_385_0
XFE_RC_1576_0 ND2 $PINS O=FE_RN_374_0 I1=term2_shifted[3] I2=FE_OFN167_s32_0
XFE_RC_1575_0 ND2 $PINS O=FE_RN_375_0 I1=N72 I2=sign2[0]
XFE_RC_1574_0 ND2P $PINS O=N99 I1=FE_RN_375_0 I2=FE_RN_374_0
XFE_RC_1476_0 NR2 $PINS O=FE_RN_336_0 I1=shf2[0] I2=sign2[1]
XFE_RC_1475_0 AN2B1S $PINS O=sll_17/ML_int[1][0] I1=FE_RN_336_0
+ B1=FE_OFN346_mac_in_imag_0
XFE_RC_1446_0 ND2S $PINS O=FE_RN_321_0 I1=sll_16/ML_int[1][2] I2=shf1[1]
XFE_RC_1444_0 ND2S $PINS O=FE_RN_323_0 I1=sll_16/ML_int[1][4] I2=FE_RN_388_0
XFE_RC_1443_0 ND2 $PINS O=sll_16/ML_int[2][4] I1=FE_RN_323_0 I2=FE_RN_321_0
XFE_RC_1442_0 ND2S $PINS O=FE_RN_318_0 I1=term3_in[2] I2=shf3[0]
XFE_RC_1441_0 INV1S $PINS O=FE_RN_319_0 I=shf3[0]
XFE_RC_1440_0 ND2S $PINS O=FE_RN_320_0 I1=term3_in[3] I2=FE_RN_319_0
XFE_RC_1439_0 ND2 $PINS O=sll_18/ML_int[1][3] I1=FE_RN_320_0 I2=FE_RN_318_0
XFE_RC_1386_0 INV1S $PINS O=FE_RN_297_0 I=shf2[0]
XFE_RC_1385_0 ND2 $PINS O=FE_RN_298_0 I1=term2_in[1] I2=FE_RN_297_0
XFE_RC_1384_0 ND2 $PINS O=FE_RN_299_0 I1=term2_in[0] I2=shf2[0]
XFE_RC_1383_0 ND2 $PINS O=sll_17/ML_int[1][1] I1=FE_RN_299_0 I2=FE_RN_298_0
XFE_RC_1317_0 INV2 $PINS O=N97 I=FE_RN_269_0
XFE_RC_952_0 INV1S $PINS O=FE_RN_134_0 I=sll_16/ML_int[2][4]
XFE_RC_951_0 MXL2HS $PINS OB=sll_16/ML_int[3][4] S=n47 A=FE_RN_134_0 B=n57
XFE_RC_940_0 INV1S $PINS O=FE_RN_126_0 I=shf3[0]
XFE_RC_939_0 INV1S $PINS O=FE_RN_127_0 I=term3_in[1]
XFE_RC_938_0 INV1S $PINS O=FE_RN_128_0 I=shf3[0]
XFE_RC_937_0 ND2S $PINS O=FE_RN_129_0 I1=term3_in[2] I2=FE_RN_128_0
XFE_RC_936_0 OAI12HS $PINS O=sll_18/ML_int[1][2] A1=FE_RN_129_0 B1=FE_RN_127_0
+ B2=FE_RN_126_0
XFE_RC_922_0 ND2 $PINS O=FE_RN_116_0 I1=term3_shifted[4] I2=n25
XFE_RC_921_0 ND2 $PINS O=FE_RN_117_0 I1=N128 I2=FE_OFN297_s33_0
XFE_RC_920_0 ND2P $PINS O=N155 I1=FE_RN_117_0 I2=FE_RN_116_0
XFE_RC_428_0 INV1S $PINS O=FE_RN_39_0 I=shf3[0]
XFE_RC_427_0 ND2 $PINS O=FE_RN_40_0 I1=term3_in[1] I2=FE_RN_39_0
XFE_RC_426_0 ND2 $PINS O=FE_RN_41_0 I1=term3_in[0] I2=shf3[0]
XFE_RC_425_0 ND2 $PINS O=sll_18/ML_int[1][1] I1=FE_RN_41_0 I2=FE_RN_40_0
XFE_RC_14_0 OA12 $PINS O=N151 A1=N124 B1=FE_OFN297_s33_0 B2=n25
XFE_RC_10_0 OA12 $PINS O=N96 A1=N69 B1=sign2[0] B2=FE_OFN167_s32_0
XFE_RC_2_0 OA12 $PINS O=N41 A1=term1_shifted[0] B1=FE_OFN130_s31_0
+ B2=FE_DBTN24_s31_0
XFE_OFC692_h31_0 BUF1 $PINS O=FE_OFN372_h31_0 I=shf1[0]
XFE_OFC587_sll_16_ML_int_2__3 INV1S $PINS O=n60 I=sll_16/ML_int[2][3]
XFE_OFC558_h32_2 INV1S $PINS O=n33 I=FE_OFN179_h32_2
XFE_OFC556_h32_2 INV1S $PINS O=FE_OFN179_h32_2 I=shf2[2]
XFE_OFC520_s32_0 INV1S $PINS O=FE_OFN167_s32_0 I=sign2[0]
XFE_OFC518_s32_0 BUF1 $PINS O=n39 I=sign2[0]
XFE_OFC486_h33_0 BUF1 $PINS O=FE_OFN303_h33_0 I=shf3[0]
XFE_OFC480_s33_0 BUF1 $PINS O=FE_OFN297_s33_0 I=sign3[0]
XFE_OFC407_h32_0 BUF1 $PINS O=FE_OFN236_h32_0 I=shf2[0]
XFE_OFC374_h33_1 INV1S $PINS O=FE_OFN224_h33_1 I=n18
XFE_OFC370_h33_1 INV1S $PINS O=n18 I=shf3[1]
XFE_OFC355_h31_1 BUF1 $PINS O=FE_OFN215_h31_1 I=shf1[1]
XFE_OFC335_h31_0 INV1S $PINS O=n43 I=shf1[0]
XFE_OFC328_h32_1 BUF1 $PINS O=FE_OFN205_h32_1 I=shf2[1]
XFE_OFC326_h32_1 INV1S $PINS O=n31 I=shf2[1]
XFE_OFC318_h33_2 BUF1 $PINS O=FE_OFN200_h33_2 I=shf3[2]
XFE_OFC317_h33_2 INV1S $PINS O=n20 I=shf3[2]
XFE_OFC316_term2_shifted_2 INV2 $PINS O=FE_DBTN16_term2_shifted_2
+ I=term2_shifted[2]
XFE_OFC266_h32_3 BUF1 $PINS O=FE_OFN185_h32_3 I=shf2[3]
XFE_OFC265_h32_3 INV1S $PINS O=n35 I=shf2[3]
XFE_OFC232_s32_0 INV1S $PINS O=FE_OFN168_s32_0 I=sign2[0]
XFE_OFC227_h33_3 INV1S $PINS O=FE_OFN165_h33_3 I=n22
XFE_OFC225_h33_3 INV1S $PINS O=n22 I=shf3[3]
XFE_OFC209_h31_2 INV1S $PINS O=n47 I=shf1[2]
XFE_OFC206_h31_3 INV1S $PINS O=n49 I=shf1[3]
XFE_OFC188_s33_0 INV1S $PINS O=FE_OFN150_s33_0 I=n25
XFE_OFC186_s33_0 INV2 $PINS O=n25 I=sign3[0]
XFE_OFC145_s31_0 INV1S $PINS O=FE_OFN130_s31_0 I=FE_DBTN24_s31_0
XFE_OFC144_s31_0 INV1S $PINS O=FE_OFN129_s31_0 I=FE_DBTN24_s31_0
XFE_OFC142_s31_0 INV3 $PINS O=FE_DBTN24_s31_0 I=sign1[0]
XU110 AO22 $PINS O=base_val[13] A1=acc_reg[13] A2=FE_OFN80_n B1=clear
+ B2=stage_sel
XU115 AO22 $PINS O=N67 A1=FE_OFN129_s31_0 A2=N40 B1=term1_shifted[26]
+ B2=FE_DBTN24_s31_0
XU116 AO22 $PINS O=N66 A1=N39 A2=FE_OFN129_s31_0 B1=term1_shifted[25]
+ B2=FE_DBTN24_s31_0
XU117 AO22 $PINS O=N65 A1=N38 A2=FE_OFN129_s31_0 B1=term1_shifted[24]
+ B2=FE_DBTN24_s31_0
XU120 AO22 $PINS O=N62 A1=N35 A2=FE_OFN129_s31_0 B1=term1_shifted[21]
+ B2=FE_DBTN24_s31_0
XU121 AO22 $PINS O=N61 A1=N34 A2=FE_OFN129_s31_0 B1=term1_shifted[20]
+ B2=FE_DBTN24_s31_0
XU122 AO22 $PINS O=N60 A1=N33 A2=FE_OFN129_s31_0 B1=term1_shifted[19]
+ B2=FE_DBTN24_s31_0
XU123 AO22 $PINS O=N59 A1=N32 A2=FE_OFN129_s31_0 B1=term1_shifted[18]
+ B2=FE_DBTN24_s31_0
XU124 AO22 $PINS O=N58 A1=N31 A2=FE_OFN129_s31_0 B1=term1_shifted[17]
+ B2=FE_DBTN24_s31_0
XU126 AO22 $PINS O=N56 A1=N29 A2=FE_OFN129_s31_0 B1=term1_shifted[15]
+ B2=FE_DBTN24_s31_0
XU128 AO22 $PINS O=N54 A1=N27 A2=FE_OFN129_s31_0 B1=term1_shifted[13]
+ B2=FE_DBTN24_s31_0
XU129 AO22 $PINS O=N53 A1=N26 A2=FE_OFN129_s31_0 B1=term1_shifted[12]
+ B2=FE_DBTN24_s31_0
XU130 AO22 $PINS O=N52 A1=N25 A2=FE_OFN129_s31_0 B1=term1_shifted[11]
+ B2=FE_DBTN24_s31_0
XU131 AO22 $PINS O=N51 A1=N24 A2=FE_OFN129_s31_0 B1=term1_shifted[10]
+ B2=FE_DBTN24_s31_0
XU132 AO22 $PINS O=N50 A1=N23 A2=FE_OFN130_s31_0 B1=term1_shifted[9]
+ B2=FE_DBTN24_s31_0
XU142 AO22 $PINS O=N177 A1=FE_OFN150_s33_0 A2=N150 B1=term3_shifted[26] B2=n25
XU158 AO22 $PINS O=N161 A1=N134 A2=FE_OFN150_s33_0 B1=term3_shifted[10] B2=n25
XU159 AO22 $PINS O=N160 A1=N133 A2=sign3[0] B1=term3_shifted[9] B2=n25
XU160 AO22 $PINS O=N159 A1=N132 A2=sign3[0] B1=term3_shifted[8] B2=n25
XU161 AO22P $PINS O=N158 A1=N131 A2=sign3[0] B1=term3_shifted[7] B2=n25
XU162 AO22P $PINS O=N157 A1=N130 A2=FE_OFN297_s33_0 B1=term3_shifted[6] B2=n25
XU163 AO22P $PINS O=N156 A1=N129 A2=FE_OFN297_s33_0 B1=term3_shifted[5] B2=n25
Xsll_18/M1_0_4 MUX2 $PINS O=sll_18/ML_int[1][4] S=shf3[0] A=term3_in[4]
+ B=term3_in[3]
Xsll_18/M1_0_6 MUX2 $PINS O=sll_18/ML_int[1][6] S=FE_OFN303_h33_0 A=term3_in[6]
+ B=term3_in[5]
Xsll_18/M1_1_2 MUX2 $PINS O=sll_18/ML_int[2][2] S=FE_OFN224_h33_1
+ A=sll_18/ML_int[1][2] B=sll_18/ML_int[1][0]
Xsll_18/M1_1_3 MUX2 $PINS O=sll_18/ML_int[2][3] S=FE_OFN224_h33_1
+ A=sll_18/ML_int[1][3] B=sll_18/ML_int[1][1]
Xsll_18/M1_1_4 MUX2 $PINS O=sll_18/ML_int[2][4] S=FE_OFN224_h33_1
+ A=sll_18/ML_int[1][4] B=sll_18/ML_int[1][2]
Xsll_18/M1_1_5 MUX2 $PINS O=sll_18/ML_int[2][5] S=FE_OFN224_h33_1
+ A=sll_18/ML_int[1][5] B=sll_18/ML_int[1][3]
Xsll_18/M1_1_6 MUX2 $PINS O=sll_18/ML_int[2][6] S=FE_OFN224_h33_1
+ A=sll_18/ML_int[1][6] B=sll_18/ML_int[1][4]
Xsll_18/M1_1_7 MUX2 $PINS O=sll_18/ML_int[2][7] S=FE_OFN224_h33_1
+ A=sll_18/ML_int[1][7] B=sll_18/ML_int[1][5]
Xsll_18/M1_2_5 MUX2 $PINS O=sll_18/ML_int[3][5] S=shf3[2] A=sll_18/ML_int[2][5]
+ B=n83
Xsll_18/M1_2_6 MUX2 $PINS O=sll_18/ML_int[3][6] S=shf3[2] A=sll_18/ML_int[2][6]
+ B=sll_18/ML_int[2][2]
Xsll_18/M1_2_9 MUX2 $PINS O=sll_18/ML_int[3][9] S=FE_OFN200_h33_2
+ A=sll_18/ML_int[2][9] B=sll_18/ML_int[2][5]
Xsll_18/M1_3_8 MUX2 $PINS O=term3_shifted[8] S=FE_OFN165_h33_3
+ A=sll_18/ML_int[3][8] B=sll_18/ML_int[3][0]
Xsll_18/M1_3_9 MUX2 $PINS O=term3_shifted[9] S=FE_OFN165_h33_3
+ A=sll_18/ML_int[3][9] B=sll_18/ML_int[3][1]
Xsll_18/M1_3_10 MUX2 $PINS O=term3_shifted[10] S=FE_OFN165_h33_3
+ A=sll_18/ML_int[3][10] B=sll_18/ML_int[3][2]
Xsll_18/M1_3_11 MUX2 $PINS O=term3_shifted[11] S=FE_OFN165_h33_3
+ A=sll_18/ML_int[3][11] B=sll_18/ML_int[3][3]
Xsll_18/M1_3_12 MUX2 $PINS O=term3_shifted[12] S=FE_OFN165_h33_3
+ A=sll_18/ML_int[3][12] B=sll_18/ML_int[3][4]
Xsll_18/M1_3_13 MUX2 $PINS O=term3_shifted[13] S=FE_OFN165_h33_3
+ A=sll_18/ML_int[3][13] B=sll_18/ML_int[3][5]
Xsll_18/M1_3_23 MUX2 $PINS O=term3_shifted[23] S=FE_OFN165_h33_3 A=term3_in[26]
+ B=sll_18/ML_int[3][15]
Xsll_17/M1_0_2 MUX2 $PINS O=sll_17/ML_int[1][2] S=shf2[0] A=term2_in[2]
+ B=term2_in[1]
Xsll_17/M1_0_4 MUX2 $PINS O=sll_17/ML_int[1][4] S=shf2[0] A=term2_in[4]
+ B=term2_in[3]
Xsll_17/M1_1_3 MUX2 $PINS O=sll_17/ML_int[2][3] S=shf2[1] A=sll_17/ML_int[1][3]
+ B=sll_17/ML_int[1][1]
Xsll_17/M1_1_4 MUX2 $PINS O=sll_17/ML_int[2][4] S=shf2[1] A=sll_17/ML_int[1][4]
+ B=sll_17/ML_int[1][2]
Xsll_17/M1_1_5 MUX2 $PINS O=sll_17/ML_int[2][5] S=shf2[1] A=sll_17/ML_int[1][5]
+ B=sll_17/ML_int[1][3]
Xsll_17/M1_1_6 MUX2 $PINS O=sll_17/ML_int[2][6] S=FE_OFN205_h32_1
+ A=sll_17/ML_int[1][6] B=sll_17/ML_int[1][4]
Xsll_17/M1_1_7 MUX2 $PINS O=sll_17/ML_int[2][7] S=FE_OFN205_h32_1
+ A=sll_17/ML_int[1][7] B=sll_17/ML_int[1][5]
Xsll_17/M1_2_4 MUX2 $PINS O=sll_17/ML_int[3][4] S=n33 A=sll_17/ML_int[2][4]
+ B=n72
Xsll_17/M1_2_5 MUX2 $PINS O=sll_17/ML_int[3][5] S=n33 A=sll_17/ML_int[2][5]
+ B=n73
Xsll_17/M1_2_7 MUX2 $PINS O=sll_17/ML_int[3][7] S=n33 A=sll_17/ML_int[2][7]
+ B=sll_17/ML_int[2][3]
Xsll_17/M1_2_8 MUX2 $PINS O=sll_17/ML_int[3][8] S=n33 A=sll_17/ML_int[2][8]
+ B=sll_17/ML_int[2][4]
Xsll_17/M1_2_9 MUX2 $PINS O=sll_17/ML_int[3][9] S=n33 A=sll_17/ML_int[2][9]
+ B=sll_17/ML_int[2][5]
Xsll_17/M1_3_8 MUX2 $PINS O=term2_shifted[8] S=shf2[3] A=sll_17/ML_int[3][8]
+ B=sll_17/ML_int[3][0]
Xsll_17/M1_3_9 MUX2 $PINS O=term2_shifted[9] S=shf2[3] A=sll_17/ML_int[3][9]
+ B=sll_17/ML_int[3][1]
Xsll_17/M1_3_10 MUX2 $PINS O=term2_shifted[10] S=shf2[3] A=sll_17/ML_int[3][10]
+ B=sll_17/ML_int[3][2]
Xsll_17/M1_3_11 MUX2 $PINS O=term2_shifted[11] S=shf2[3] A=sll_17/ML_int[3][11]
+ B=sll_17/ML_int[3][3]
Xsll_17/M1_3_12 MUX2 $PINS O=term2_shifted[12] S=shf2[3] A=sll_17/ML_int[3][12]
+ B=sll_17/ML_int[3][4]
Xsll_17/M1_3_13 MUX2 $PINS O=term2_shifted[13] S=FE_OFN185_h32_3
+ A=sll_17/ML_int[3][13] B=sll_17/ML_int[3][5]
Xsll_17/M1_3_23 MUX2 $PINS O=term2_shifted[23] S=FE_OFN185_h32_3 A=term2_in[26]
+ B=sll_17/ML_int[3][15]
Xsll_16/M1_0_3 MUX2 $PINS O=sll_16/ML_int[1][3] S=shf1[0] A=term1_in[3]
+ B=term1_in[2]
Xsll_16/M1_0_4 MUX2 $PINS O=sll_16/ML_int[1][4] S=FE_OFN372_h31_0 A=term1_in[4]
+ B=term1_in[3]
Xsll_16/M1_0_5 MUX2 $PINS O=sll_16/ML_int[1][5] S=FE_OFN372_h31_0 A=term1_in[5]
+ B=term1_in[4]
Xsll_16/M1_0_6 MUX2 $PINS O=sll_16/ML_int[1][6] S=FE_OFN372_h31_0 A=term1_in[6]
+ B=term1_in[5]
Xsll_16/M1_1_5 MUX2 $PINS O=sll_16/ML_int[2][5] S=shf1[1] A=sll_16/ML_int[1][5]
+ B=sll_16/ML_int[1][3]
Xsll_16/M1_1_6 MUX2 $PINS O=sll_16/ML_int[2][6] S=shf1[1] A=sll_16/ML_int[1][6]
+ B=sll_16/ML_int[1][4]
Xsll_16/M1_1_7 MUX2 $PINS O=sll_16/ML_int[2][7] S=FE_OFN215_h31_1
+ A=sll_16/ML_int[1][7] B=sll_16/ML_int[1][5]
Xsll_16/M1_2_5 MUX2 $PINS O=sll_16/ML_int[3][5] S=n47 A=sll_16/ML_int[2][5]
+ B=n5
Xsll_16/M1_2_6 MUX2 $PINS O=sll_16/ML_int[3][6] S=n47 A=sll_16/ML_int[2][6]
+ B=sll_16/ML_int[2][2]
Xsll_16/M1_2_7 MUX2 $PINS O=sll_16/ML_int[3][7] S=n47 A=sll_16/ML_int[2][7]
+ B=sll_16/ML_int[2][3]
Xsll_16/M1_2_8 MUX2 $PINS O=sll_16/ML_int[3][8] S=n47 A=sll_16/ML_int[2][8]
+ B=sll_16/ML_int[2][4]
Xsll_16/M1_2_9 MUX2 $PINS O=sll_16/ML_int[3][9] S=n47 A=sll_16/ML_int[2][9]
+ B=sll_16/ML_int[2][5]
Xsll_16/M1_3_8 MUX2 $PINS O=term1_shifted[8] S=n49 A=sll_16/ML_int[3][8]
+ B=sll_16/ML_int[3][0]
Xsll_16/M1_3_9 MUX2 $PINS O=term1_shifted[9] S=n49 A=sll_16/ML_int[3][9]
+ B=sll_16/ML_int[3][1]
Xsll_16/M1_3_10 MUX2 $PINS O=term1_shifted[10] S=n49 A=sll_16/ML_int[3][10]
+ B=sll_16/ML_int[3][2]
Xsll_16/M1_3_11 MUX2 $PINS O=term1_shifted[11] S=n49 A=sll_16/ML_int[3][11]
+ B=sll_16/ML_int[3][3]
Xsll_16/M1_3_12 MUX2 $PINS O=term1_shifted[12] S=n49 A=sll_16/ML_int[3][12]
+ B=sll_16/ML_int[3][4]
Xsll_16/M1_3_13 MUX2 $PINS O=term1_shifted[13] S=n49 A=sll_16/ML_int[3][13]
+ B=sll_16/ML_int[3][5]
Xsll_16/M1_3_23 MUX2 $PINS O=term1_shifted[23] S=n49 A=term1_in[26]
+ B=sll_16/ML_int[3][15]
Xy_out_reg[9] QDFFRBN $PINS Q=y_out[9] D=N244 CK=net2209 RB=i_rst_n
Xy_out_reg[8] QDFFRBN $PINS Q=FE_PHN750_pe_i3_8 D=FE_PHN954_N243 CK=net2209
+ RB=i_rst_n
Xy_out_reg[7] QDFFRBN $PINS Q=FE_PHN746_pe_i3_7 D=FE_PHN1338_N242 CK=net2209
+ RB=i_rst_n
Xy_out_reg[6] QDFFRBN $PINS Q=FE_PHN744_pe_i3_6 D=N241 CK=net2209 RB=i_rst_n
Xy_out_reg[5] QDFFRBN $PINS Q=FE_PHN741_pe_i3_5 D=FE_PHN997_N240 CK=net2209
+ RB=i_rst_n
Xy_out_reg[4] QDFFRBN $PINS Q=y_out[4] D=N239 CK=net2209 RB=i_rst_n
Xy_out_reg[3] QDFFRBN $PINS Q=FE_PHN770_pe_i3_3 D=FE_PHN983_N238 CK=net2209
+ RB=i_rst_n
Xy_out_reg[2] QDFFRBN $PINS Q=y_out[2] D=FE_PHN998_N237 CK=net2209 RB=i_rst_n
Xy_out_reg[1] QDFFRBN $PINS Q=FE_PHN774_pe_i3_1 D=N236 CK=net2209 RB=i_rst_n
Xy_out_reg[0] QDFFRBN $PINS Q=FE_PHN757_pe_i3_0 D=N235 CK=net2209 RB=i_rst_n
Xy_out_reg[16] QDFFRBN $PINS Q=y_out[16] D=FE_PHN731_N251 CK=net2209 RB=i_rst_n
Xy_out_reg[10] QDFFRBN $PINS Q=y_out[10] D=N245 CK=net2209 RB=i_rst_n
Xy_out_reg[11] QDFFRBN $PINS Q=FE_PHN1186_pe_i3_11 D=N246 CK=net2209 RB=i_rst_n
Xy_out_reg[12] QDFFRBN $PINS Q=y_out[12] D=N247 CK=net2209 RB=i_rst_n
Xy_out_reg[14] QDFFRBN $PINS Q=y_out[14] D=N249 CK=net2209 RB=i_rst_n
Xy_out_reg[15] QDFFRBN $PINS Q=y_out[15] D=N250 CK=net2209 RB=i_rst_n
Xy_out_reg[13] QDFFRBN $PINS Q=y_out[13] D=FE_PHN1325_N248 CK=net2209
+ RB=i_rst_n
Xacc_reg_reg[25] QDFFRBN $PINS Q=acc_reg[25] D=next_acc[25] CK=clk RB=i_rst_n
Xacc_reg_reg[24] QDFFRBN $PINS Q=acc_reg[24] D=next_acc[24] CK=clk
+ RB=FE_OFN5_i_rst_n
Xacc_reg_reg[23] QDFFRBN $PINS Q=acc_reg[23] D=next_acc[23] CK=clk
+ RB=FE_OFN5_i_rst_n
Xacc_reg_reg[22] QDFFRBN $PINS Q=acc_reg[22] D=next_acc[22] CK=clk
+ RB=FE_OFN5_i_rst_n
Xacc_reg_reg[21] QDFFRBN $PINS Q=acc_reg[21] D=next_acc[21] CK=clk RB=i_rst_n
Xacc_reg_reg[20] QDFFRBN $PINS Q=acc_reg[20] D=next_acc[20] CK=clk
+ RB=FE_OFN5_i_rst_n
Xacc_reg_reg[19] QDFFRBN $PINS Q=acc_reg[19] D=next_acc[19] CK=clk RB=i_rst_n
Xacc_reg_reg[18] QDFFRBN $PINS Q=acc_reg[18] D=next_acc[18] CK=clk RB=i_rst_n
Xacc_reg_reg[17] QDFFRBN $PINS Q=acc_reg[17] D=next_acc[17] CK=clk RB=i_rst_n
Xacc_reg_reg[16] QDFFRBN $PINS Q=acc_reg[16] D=next_acc[16] CK=clk
+ RB=FE_OFN5_i_rst_n
Xacc_reg_reg[15] QDFFRBN $PINS Q=acc_reg[15] D=next_acc[15] CK=clk
+ RB=FE_OFN5_i_rst_n
Xacc_reg_reg[14] QDFFRBN $PINS Q=acc_reg[14] D=next_acc[14] CK=clk
+ RB=FE_OFN5_i_rst_n
Xacc_reg_reg[13] QDFFRBN $PINS Q=acc_reg[13] D=next_acc[13] CK=clk
+ RB=FE_OFN5_i_rst_n
Xacc_reg_reg[12] QDFFRBN $PINS Q=acc_reg[12] D=next_acc[12] CK=clk
+ RB=FE_OFN5_i_rst_n
Xacc_reg_reg[11] QDFFRBN $PINS Q=acc_reg[11] D=next_acc[11] CK=clk_clone1
+ RB=FE_OFN5_i_rst_n
Xacc_reg_reg[10] QDFFRBN $PINS Q=acc_reg[10] D=next_acc[10] CK=clk_clone1
+ RB=FE_OFN5_i_rst_n
Xacc_reg_reg[9] QDFFRBN $PINS Q=acc_reg[9] D=next_acc[9] CK=clk_clone1
+ RB=FE_OFN5_i_rst_n
Xacc_reg_reg[8] QDFFRBN $PINS Q=acc_reg[8] D=next_acc[8] CK=clk_clone1
+ RB=FE_OFN5_i_rst_n
Xacc_reg_reg[7] QDFFRBN $PINS Q=acc_reg[7] D=next_acc[7] CK=clk_clone1
+ RB=FE_OFN5_i_rst_n
Xacc_reg_reg[6] QDFFRBN $PINS Q=acc_reg[6] D=next_acc[6] CK=clk_clone1
+ RB=FE_OFN5_i_rst_n
Xacc_reg_reg[5] QDFFRBN $PINS Q=acc_reg[5] D=next_acc[5] CK=clk_clone1
+ RB=FE_OFN5_i_rst_n
Xacc_reg_reg[4] QDFFRBN $PINS Q=acc_reg[4] D=next_acc[4] CK=clk_clone1
+ RB=FE_OFN5_i_rst_n
Xacc_reg_reg[3] QDFFRBN $PINS Q=acc_reg[3] D=next_acc[3] CK=clk_clone1
+ RB=FE_OFN5_i_rst_n
Xacc_reg_reg[2] QDFFRBN $PINS Q=acc_reg[2] D=next_acc[2] CK=clk_clone1
+ RB=FE_OFN5_i_rst_n
Xacc_reg_reg[0] QDFFRBN $PINS Q=acc_reg[0] D=next_acc[0] CK=clk_clone1
+ RB=FE_OFN5_i_rst_n
Xacc_reg_reg[1] QDFFRBN $PINS Q=acc_reg[1] D=next_acc[1] CK=clk_clone1
+ RB=FE_OFN5_i_rst_n
Xacc_reg_reg[26] QDFFRBP $PINS Q=N251 D=next_acc[26] CK=clk RB=FE_OFN5_i_rst_n
XU11 MOAI1H $PINS O=N42 A1=n13 A2=FE_DBTN24_s31_0 B1=term1_shifted[1]
+ B2=FE_DBTN24_s31_0
XU13 AO22P $PINS O=N43 A1=FE_OFN130_s31_0 A2=N16 B1=term1_shifted[2]
+ B2=FE_DBTN24_s31_0
XU23 AO22 $PINS O=N154 A1=N127 A2=FE_OFN297_s33_0 B1=term3_shifted[3] B2=n25
XU25 MUX2 $PINS O=sll_16/ML_int[1][2] S=n43 A=term1_in[1] B=term1_in[2]
XU26 MUX2 $PINS O=N248 S=FE_OFN40_FE_DBTN10_n289 A=acc_reg[23] B=FE_PHN731_N251
XU27 NR2P $PINS O=term1_shifted[0] I1=n59 I2=n57
XU28 NR2 $PINS O=sll_17/ML_int[3][0] I1=n33 I2=n67
XU29 MUX2 $PINS O=N250 S=FE_OFN40_FE_DBTN10_n289 A=FE_PHN930_acc_reg_25
+ B=FE_PHN731_N251
XU30 MUX2 $PINS O=sll_16/ML_int[1][1] S=n43 A=term1_in[0] B=term1_in[1]
XU32 NR2 $PINS O=sll_17/ML_int[3][1] I1=n33 I2=n68
XU33 MUX2 $PINS O=N249 S=FE_OFN40_FE_DBTN10_n289 A=FE_PHN936_acc_reg_24
+ B=FE_PHN731_N251
XU35 OR2 $PINS O=n67 I1=n10 I2=shf2[1]
XU36 INV2 $PINS O=n3 I=sll_16/ML_int[1][1]
XU37 AN2B1T $PINS O=term3_shifted[3] I1=sll_18/ML_int[2][3] B1=n80
XU39 MUX2 $PINS O=FE_PHN1312_N247 S=FE_OFN40_FE_DBTN10_n289 A=acc_reg[22]
+ B=FE_PHN731_N251
XU40 MUX2 $PINS O=sll_18/ML_int[1][5] S=shf3[0] A=term3_in[5] B=term3_in[4]
XU41 MUX2 $PINS O=sll_17/ML_int[1][3] S=shf2[0] A=term2_in[3] B=n9
XU50 ND2S $PINS O=n2 I1=term2_shifted[4] I2=FE_OFN167_s32_0
XU54 NR2 $PINS O=term2_in[4] I1=FE_OFN66_s32_1 I2=x_in[4]
XU55 NR2 $PINS O=term1_in[1] I1=sign1[1] I2=x_in[1]
XU56 NR2 $PINS O=term2_in[0] I1=sign2[1] I2=FE_OFN346_mac_in_imag_0
XU57 AN2S $PINS O=sll_16/ML_int[1][0] I1=term1_in[0] I2=n43
XU58 INV1S $PINS O=n70 I=sll_17/ML_int[2][3]
XU59 INV2 $PINS O=n61 I=sll_16/ML_int[2][2]
XU66 AO22 $PINS O=N55 A1=N28 A2=FE_OFN129_s31_0 B1=term1_shifted[14]
+ B2=FE_DBTN24_s31_0
XU67 ND2 $PINS O=n1 I1=N73 I2=sign2[0]
XU68 ND2P $PINS O=N100 I1=n1 I2=n2
XU69 MUX2 $PINS O=sll_18/ML_int[3][8] S=shf3[2] A=sll_18/ML_int[2][8]
+ B=sll_18/ML_int[2][4]
XU70 MUX2S $PINS O=sll_17/ML_int[1][6] S=FE_OFN236_h32_0 A=term2_in[6]
+ B=term2_in[5]
XU74 AO22P $PINS O=N46 A1=N19 A2=FE_OFN130_s31_0 B1=term1_shifted[5]
+ B2=FE_DBTN24_s31_0
XU76 ND2P $PINS O=n79 I1=sll_18/ML_int[1][1] I2=n18
XU80 NR2 $PINS O=term3_in[0] I1=sign3[1] I2=FE_OFN346_mac_in_imag_0
XU81 NR2 $PINS O=term2_in[1] I1=sign2[1] I2=x_in[1]
XU82 OR2 $PINS O=n11 I1=n69 I2=shf2[1]
XU83 INV2 $PINS O=n71 I=sll_17/ML_int[2][2]
XU84 OR2 $PINS O=n4 I1=n59 I2=shf1[1]
XU87 AO22 $PINS O=N173 A1=N146 A2=FE_OFN150_s33_0 B1=term3_shifted[22] B2=n25
XU89 NR2 $PINS O=term2_in[2] I1=sign2[1] I2=x_in[2]
XU94 INV1S $PINS O=n81 I=sll_18/ML_int[2][3]
XU95 NR2P $PINS O=term1_shifted[3] I1=n59 I2=n60
XU96 INV1S $PINS O=n58 I=n5
XU97 AN2 $PINS O=base_val[11] I1=acc_reg[11] I2=FE_OFN80_n
XU99 AO22 $PINS O=N164 A1=N137 A2=FE_OFN150_s33_0 B1=term3_shifted[13] B2=n25
XU102 MUX2 $PINS O=sll_18/ML_int[3][7] S=shf3[2] A=sll_18/ML_int[2][7]
+ B=sll_18/ML_int[2][3]
XU103 AO22 $PINS O=N153 A1=N126 A2=FE_OFN297_s33_0
+ B1=FE_OCPN711_term3_shifted_2 B2=n25
XU105 NR2P $PINS O=term2_shifted[2] I1=n69 I2=n71
XU107 MUX2S $PINS O=sll_17/ML_int[3][6] S=n33 A=sll_17/ML_int[2][6]
+ B=sll_17/ML_int[2][2]
XU111 INV1S $PINS O=n16 I=shf3[0]
XU114 AO22S $PINS O=N63 A1=N36 A2=FE_OFN129_s31_0 B1=term1_shifted[22]
+ B2=FE_DBTN24_s31_0
XU118 AO22S $PINS O=N64 A1=N37 A2=FE_OFN129_s31_0 B1=term1_shifted[23]
+ B2=FE_DBTN24_s31_0
XU119 NR2 $PINS O=n5 I1=n3 I2=shf1[1]
XU125 AO22 $PINS O=N57 A1=N30 A2=FE_OFN129_s31_0 B1=term1_shifted[16]
+ B2=FE_DBTN24_s31_0
XU135 ND2P $PINS O=n69 I1=FE_OFN179_h32_2 I2=n35
XU136 INV1S $PINS O=n8 I=n78
XU137 NR2 $PINS O=n9 I1=FE_OFN66_s32_1 I2=x_in[2]
XU139 MUX2 $PINS O=sll_16/ML_int[2][3] S=shf1[1] A=sll_16/ML_int[1][3]
+ B=sll_16/ML_int[1][1]
XU140 AO22S $PINS O=N112 A1=N85 A2=sign2[0] B1=term2_shifted[16]
+ B2=FE_OFN168_s32_0
XU141 NR2T $PINS O=term2_shifted[3] I1=n69 I2=n70
XU143 INV2 $PINS O=n13 I=N15
XU145 MUX2S $PINS O=sll_16/ML_int[1][8] S=FE_OFN372_h31_0 A=term1_in[8]
+ B=term1_in[7]
XU146 MUX2S $PINS O=sll_18/ML_int[1][8] S=FE_OFN303_h33_0 A=term3_in[8]
+ B=term3_in[7]
XU147 MUX2S $PINS O=sll_17/ML_int[1][8] S=FE_OFN236_h32_0 A=term2_in[8]
+ B=term2_in[7]
XU148 AN2 $PINS O=base_val[2] I1=acc_reg[2] I2=FE_OFN80_n
XU149 AN2 $PINS O=base_val[3] I1=acc_reg[3] I2=FE_OFN80_n
XU150 AN2 $PINS O=base_val[4] I1=acc_reg[4] I2=FE_OFN80_n
XU151 AN2 $PINS O=base_val[5] I1=acc_reg[5] I2=FE_OFN80_n
XU152 AN2 $PINS O=base_val[0] I1=acc_reg[0] I2=FE_OFN80_n
XU153 MUX2S $PINS O=FE_PHN996_N235 S=FE_OFN40_FE_DBTN10_n289 A=acc_reg[10]
+ B=acc_reg[14]
XU154 MUX2S $PINS O=FE_PHN999_N236 S=FE_OFN40_FE_DBTN10_n289 A=acc_reg[11]
+ B=acc_reg[15]
XU155 MUX2S $PINS O=N237 S=FE_OFN40_FE_DBTN10_n289 A=acc_reg[12] B=acc_reg[16]
XU156 MUX2S $PINS O=N238 S=FE_OFN40_FE_DBTN10_n289 A=acc_reg[13] B=acc_reg[17]
XU157 MUX2S $PINS O=FE_PHN993_N239 S=FE_OFN40_FE_DBTN10_n289 A=acc_reg[14]
+ B=acc_reg[18]
XU165 MUX2S $PINS O=N240 S=FE_OFN40_FE_DBTN10_n289 A=acc_reg[15] B=acc_reg[19]
XU166 MUX2S $PINS O=N242 S=FE_OFN40_FE_DBTN10_n289 A=acc_reg[17]
+ B=FE_PHN1163_acc_reg_21
XU167 MUX2S $PINS O=FE_PHN1348_N245 S=FE_OFN40_FE_DBTN10_n289 A=acc_reg[20]
+ B=FE_PHN936_acc_reg_24
XU168 MUX2S $PINS O=N246 S=FE_OFN40_FE_DBTN10_n289 A=FE_PHN1163_acc_reg_21
+ B=FE_PHN930_acc_reg_25
XU175 MUX2S $PINS O=sll_16/ML_int[1][7] S=FE_OFN372_h31_0 A=term1_in[7]
+ B=term1_in[6]
XU179 MUX2 $PINS O=sll_18/ML_int[1][7] S=FE_OFN303_h33_0 A=term3_in[7]
+ B=term3_in[6]
XU182 MUX2S $PINS O=sll_17/ML_int[1][7] S=FE_OFN236_h32_0 A=term2_in[7]
+ B=term2_in[6]
XU184 MUX2S $PINS O=sll_16/ML_int[2][8] S=FE_OFN215_h31_1 A=sll_16/ML_int[1][8]
+ B=sll_16/ML_int[1][6]
XU190 MUX2 $PINS O=sll_18/ML_int[2][8] S=FE_OFN224_h33_1 A=sll_18/ML_int[1][8]
+ B=sll_18/ML_int[1][6]
XU191 MUX2S $PINS O=sll_17/ML_int[2][8] S=FE_OFN205_h32_1 A=sll_17/ML_int[1][8]
+ B=sll_17/ML_int[1][6]
XU192 MUX2S $PINS O=sll_16/ML_int[2][9] S=FE_OFN215_h31_1 A=sll_16/ML_int[1][9]
+ B=sll_16/ML_int[1][7]
XU193 MUX2S $PINS O=sll_16/ML_int[1][9] S=FE_OFN372_h31_0 A=term1_in[9]
+ B=term1_in[8]
XU194 MUX2S $PINS O=sll_18/ML_int[2][9] S=FE_OFN224_h33_1 A=sll_18/ML_int[1][9]
+ B=sll_18/ML_int[1][7]
XU195 MUX2S $PINS O=sll_18/ML_int[1][9] S=FE_OFN303_h33_0 A=term3_in[9]
+ B=term3_in[8]
XU196 MUX2S $PINS O=sll_17/ML_int[2][9] S=FE_OFN205_h32_1 A=sll_17/ML_int[1][9]
+ B=sll_17/ML_int[1][7]
XU197 MUX2S $PINS O=sll_17/ML_int[1][9] S=FE_OFN236_h32_0 A=term2_in[9]
+ B=term2_in[8]
XU198 MUX2S $PINS O=sll_16/ML_int[3][10] S=n47 A=sll_16/ML_int[2][10]
+ B=sll_16/ML_int[2][6]
XU199 MUX2S $PINS O=sll_16/ML_int[2][10] S=FE_OFN215_h31_1
+ A=sll_16/ML_int[1][10] B=sll_16/ML_int[1][8]
XU200 MUX2S $PINS O=sll_16/ML_int[1][10] S=FE_OFN372_h31_0 A=term1_in[10]
+ B=term1_in[9]
XU201 MUX2S $PINS O=sll_18/ML_int[3][10] S=FE_OFN200_h33_2
+ A=sll_18/ML_int[2][10] B=sll_18/ML_int[2][6]
XU202 MUX2S $PINS O=sll_18/ML_int[2][10] S=FE_OFN224_h33_1
+ A=sll_18/ML_int[1][10] B=sll_18/ML_int[1][8]
XU203 MUX2S $PINS O=sll_18/ML_int[1][10] S=FE_OFN303_h33_0 A=term3_in[10]
+ B=term3_in[9]
XU204 MUX2S $PINS O=sll_17/ML_int[3][10] S=n33 A=sll_17/ML_int[2][10]
+ B=sll_17/ML_int[2][6]
XU205 MUX2S $PINS O=sll_17/ML_int[2][10] S=FE_OFN205_h32_1
+ A=sll_17/ML_int[1][10] B=sll_17/ML_int[1][8]
XU206 MUX2S $PINS O=sll_17/ML_int[1][10] S=FE_OFN236_h32_0 A=term2_in[10]
+ B=term2_in[9]
XU207 MUX2S $PINS O=sll_16/ML_int[3][11] S=n47 A=sll_16/ML_int[2][11]
+ B=sll_16/ML_int[2][7]
XU208 MUX2S $PINS O=sll_16/ML_int[2][11] S=FE_OFN215_h31_1
+ A=sll_16/ML_int[1][11] B=sll_16/ML_int[1][9]
XU209 MUX2S $PINS O=sll_16/ML_int[1][11] S=FE_OFN372_h31_0 A=term1_in[11]
+ B=term1_in[10]
XU210 MUX2S $PINS O=sll_18/ML_int[3][11] S=FE_OFN200_h33_2
+ A=sll_18/ML_int[2][11] B=sll_18/ML_int[2][7]
XU211 MUX2S $PINS O=sll_18/ML_int[2][11] S=FE_OFN224_h33_1
+ A=sll_18/ML_int[1][11] B=sll_18/ML_int[1][9]
XU212 MUX2S $PINS O=sll_18/ML_int[1][11] S=FE_OFN303_h33_0 A=term3_in[11]
+ B=term3_in[10]
XU213 MUX2S $PINS O=sll_17/ML_int[3][11] S=n33 A=sll_17/ML_int[2][11]
+ B=sll_17/ML_int[2][7]
XU214 MUX2S $PINS O=sll_17/ML_int[2][11] S=FE_OFN205_h32_1
+ A=sll_17/ML_int[1][11] B=sll_17/ML_int[1][9]
XU215 MUX2S $PINS O=sll_17/ML_int[1][11] S=FE_OFN236_h32_0 A=term2_in[11]
+ B=term2_in[10]
XU216 MUX2S $PINS O=sll_16/ML_int[3][12] S=n47 A=sll_16/ML_int[2][12]
+ B=sll_16/ML_int[2][8]
XU217 MUX2S $PINS O=sll_16/ML_int[2][12] S=FE_OFN215_h31_1
+ A=sll_16/ML_int[1][12] B=sll_16/ML_int[1][10]
XU218 MUX2S $PINS O=sll_16/ML_int[1][12] S=FE_OFN372_h31_0 A=term1_in[12]
+ B=term1_in[11]
XU219 MUX2S $PINS O=sll_18/ML_int[3][12] S=FE_OFN200_h33_2
+ A=sll_18/ML_int[2][12] B=sll_18/ML_int[2][8]
XU220 MUX2S $PINS O=sll_18/ML_int[2][12] S=FE_OFN224_h33_1
+ A=sll_18/ML_int[1][12] B=sll_18/ML_int[1][10]
XU221 MUX2S $PINS O=sll_18/ML_int[1][12] S=FE_OFN303_h33_0 A=term3_in[12]
+ B=term3_in[11]
XU222 MUX2S $PINS O=sll_17/ML_int[3][12] S=n33 A=sll_17/ML_int[2][12]
+ B=sll_17/ML_int[2][8]
XU223 MUX2S $PINS O=sll_17/ML_int[2][12] S=FE_OFN205_h32_1
+ A=sll_17/ML_int[1][12] B=sll_17/ML_int[1][10]
XU224 MUX2S $PINS O=sll_17/ML_int[1][12] S=FE_OFN236_h32_0 A=term2_in[12]
+ B=term2_in[11]
XU225 MUX2S $PINS O=sll_16/ML_int[3][13] S=n47 A=sll_16/ML_int[2][13]
+ B=sll_16/ML_int[2][9]
XU226 MUX2S $PINS O=sll_16/ML_int[2][13] S=FE_OFN215_h31_1
+ A=sll_16/ML_int[1][13] B=sll_16/ML_int[1][11]
XU227 MUX2S $PINS O=sll_16/ML_int[1][13] S=FE_OFN372_h31_0 A=term1_in[13]
+ B=term1_in[12]
XU228 MUX2S $PINS O=sll_18/ML_int[3][13] S=FE_OFN200_h33_2
+ A=sll_18/ML_int[2][13] B=sll_18/ML_int[2][9]
XU229 MUX2S $PINS O=sll_18/ML_int[2][13] S=FE_OFN224_h33_1
+ A=sll_18/ML_int[1][13] B=sll_18/ML_int[1][11]
XU230 MUX2S $PINS O=sll_18/ML_int[1][13] S=FE_OFN303_h33_0 A=term3_in[13]
+ B=term3_in[12]
XU231 MUX2S $PINS O=sll_17/ML_int[3][13] S=n33 A=sll_17/ML_int[2][13]
+ B=sll_17/ML_int[2][9]
XU232 MUX2S $PINS O=sll_17/ML_int[2][13] S=FE_OFN205_h32_1
+ A=sll_17/ML_int[1][13] B=sll_17/ML_int[1][11]
XU233 MUX2S $PINS O=sll_17/ML_int[1][13] S=FE_OFN236_h32_0 A=term2_in[13]
+ B=term2_in[12]
XU234 MUX2S $PINS O=term1_shifted[14] S=n49 A=sll_16/ML_int[3][14]
+ B=sll_16/ML_int[3][6]
XU235 MUX2S $PINS O=sll_16/ML_int[3][14] S=n47 A=sll_16/ML_int[2][14]
+ B=sll_16/ML_int[2][10]
XU236 MUX2S $PINS O=sll_16/ML_int[2][14] S=FE_OFN215_h31_1
+ A=sll_16/ML_int[1][14] B=sll_16/ML_int[1][12]
XU237 MUX2S $PINS O=sll_16/ML_int[1][14] S=FE_OFN372_h31_0 A=term1_in[14]
+ B=term1_in[13]
XU238 MUX2S $PINS O=term3_shifted[14] S=FE_OFN165_h33_3 A=sll_18/ML_int[3][14]
+ B=sll_18/ML_int[3][6]
XU239 MUX2S $PINS O=sll_18/ML_int[3][14] S=FE_OFN200_h33_2
+ A=sll_18/ML_int[2][14] B=sll_18/ML_int[2][10]
XU240 MUX2S $PINS O=sll_18/ML_int[2][14] S=FE_OFN224_h33_1
+ A=sll_18/ML_int[1][14] B=sll_18/ML_int[1][12]
XU241 MUX2S $PINS O=sll_18/ML_int[1][14] S=FE_OFN303_h33_0 A=term3_in[14]
+ B=term3_in[13]
XU242 MUX2S $PINS O=term2_shifted[14] S=FE_OFN185_h32_3 A=sll_17/ML_int[3][14]
+ B=sll_17/ML_int[3][6]
XU243 MUX2S $PINS O=sll_17/ML_int[3][14] S=n33 A=sll_17/ML_int[2][14]
+ B=sll_17/ML_int[2][10]
XU244 MUX2S $PINS O=sll_17/ML_int[2][14] S=FE_OFN205_h32_1
+ A=sll_17/ML_int[1][14] B=sll_17/ML_int[1][12]
XU245 MUX2S $PINS O=sll_17/ML_int[1][14] S=FE_OFN236_h32_0 A=term2_in[14]
+ B=term2_in[13]
XU246 MUX2S $PINS O=term1_shifted[16] S=n49 A=sll_16/ML_int[3][16]
+ B=sll_16/ML_int[3][8]
XU247 MUX2S $PINS O=sll_16/ML_int[3][16] S=n47 A=n63 B=sll_16/ML_int[2][12]
XU248 MUX2S $PINS O=n63 S=FE_OFN215_h31_1 A=n66 B=sll_16/ML_int[1][14]
XU249 MUX2S $PINS O=term3_shifted[16] S=FE_OFN165_h33_3 A=sll_18/ML_int[3][16]
+ B=sll_18/ML_int[3][8]
XU250 MUX2S $PINS O=sll_18/ML_int[3][16] S=FE_OFN200_h33_2 A=n84
+ B=sll_18/ML_int[2][12]
XU251 MUX2S $PINS O=n84 S=FE_OFN224_h33_1 A=n87 B=sll_18/ML_int[1][14]
XU252 MUX2S $PINS O=term2_shifted[16] S=FE_OFN185_h32_3 A=sll_17/ML_int[3][16]
+ B=sll_17/ML_int[3][8]
XU253 MUX2S $PINS O=sll_17/ML_int[3][16] S=n33 A=n74 B=sll_17/ML_int[2][12]
XU254 MUX2S $PINS O=n74 S=FE_OFN205_h32_1 A=n77 B=sll_17/ML_int[1][14]
XU255 MUX2S $PINS O=term1_shifted[15] S=n49 A=sll_16/ML_int[3][15]
+ B=sll_16/ML_int[3][7]
XU256 MUX2S $PINS O=sll_16/ML_int[3][15] S=n47 A=sll_16/ML_int[2][15]
+ B=sll_16/ML_int[2][11]
XU257 MUX2S $PINS O=sll_16/ML_int[2][15] S=FE_OFN215_h31_1
+ A=sll_16/ML_int[1][15] B=sll_16/ML_int[1][13]
XU258 MUX2S $PINS O=sll_16/ML_int[1][15] S=FE_OFN372_h31_0 A=term1_in[15]
+ B=term1_in[14]
XU259 MUX2S $PINS O=term3_shifted[15] S=FE_OFN165_h33_3 A=sll_18/ML_int[3][15]
+ B=sll_18/ML_int[3][7]
XU260 MUX2S $PINS O=sll_18/ML_int[3][15] S=FE_OFN200_h33_2
+ A=sll_18/ML_int[2][15] B=sll_18/ML_int[2][11]
XU261 MUX2S $PINS O=sll_18/ML_int[2][15] S=FE_OFN224_h33_1
+ A=sll_18/ML_int[1][15] B=sll_18/ML_int[1][13]
XU262 MUX2S $PINS O=sll_18/ML_int[1][15] S=FE_OFN303_h33_0 A=term3_in[15]
+ B=term3_in[14]
XU263 MUX2S $PINS O=term2_shifted[15] S=FE_OFN185_h32_3 A=sll_17/ML_int[3][15]
+ B=sll_17/ML_int[3][7]
XU264 MUX2S $PINS O=sll_17/ML_int[3][15] S=n33 A=sll_17/ML_int[2][15]
+ B=sll_17/ML_int[2][11]
XU265 MUX2S $PINS O=sll_17/ML_int[2][15] S=FE_OFN205_h32_1
+ A=sll_17/ML_int[1][15] B=sll_17/ML_int[1][13]
XU266 MUX2S $PINS O=sll_17/ML_int[1][15] S=FE_OFN236_h32_0 A=term2_in[15]
+ B=term2_in[14]
XU267 MUX2S $PINS O=term1_shifted[17] S=n49 A=sll_16/ML_int[3][17]
+ B=sll_16/ML_int[3][9]
XU268 MUX2S $PINS O=sll_16/ML_int[3][17] S=n47 A=n64 B=sll_16/ML_int[2][13]
XU269 MUX2S $PINS O=term3_shifted[17] S=FE_OFN165_h33_3 A=sll_18/ML_int[3][17]
+ B=sll_18/ML_int[3][9]
XU270 MUX2S $PINS O=sll_18/ML_int[3][17] S=FE_OFN200_h33_2 A=n85
+ B=sll_18/ML_int[2][13]
XU271 MUX2S $PINS O=term2_shifted[17] S=FE_OFN185_h32_3 A=sll_17/ML_int[3][17]
+ B=sll_17/ML_int[3][9]
XU272 MUX2S $PINS O=sll_17/ML_int[3][17] S=n33 A=n75 B=sll_17/ML_int[2][13]
XU273 MUX2S $PINS O=term1_shifted[18] S=n49 A=sll_16/ML_int[3][18]
+ B=sll_16/ML_int[3][10]
XU274 MUX2S $PINS O=sll_16/ML_int[3][18] S=n47 A=n65 B=sll_16/ML_int[2][14]
XU275 MUX2S $PINS O=term3_shifted[18] S=FE_OFN165_h33_3 A=sll_18/ML_int[3][18]
+ B=sll_18/ML_int[3][10]
XU276 MUX2S $PINS O=sll_18/ML_int[3][18] S=FE_OFN200_h33_2 A=n86
+ B=sll_18/ML_int[2][14]
XU277 MUX2S $PINS O=term2_shifted[18] S=FE_OFN185_h32_3 A=sll_17/ML_int[3][18]
+ B=sll_17/ML_int[3][10]
XU278 MUX2S $PINS O=sll_17/ML_int[3][18] S=n33 A=n76 B=sll_17/ML_int[2][14]
XU279 MUX2S $PINS O=term1_shifted[20] S=n49 A=sll_16/ML_int[3][20]
+ B=sll_16/ML_int[3][12]
XU280 MUX2S $PINS O=sll_16/ML_int[3][20] S=n47 A=term1_in[26] B=n63
XU281 MUX2S $PINS O=term1_shifted[19] S=n49 A=sll_16/ML_int[3][19]
+ B=sll_16/ML_int[3][11]
XU282 MUX2S $PINS O=sll_16/ML_int[3][19] S=n47 A=term1_in[26]
+ B=sll_16/ML_int[2][15]
XU283 MUX2S $PINS O=term3_shifted[20] S=FE_OFN165_h33_3 A=sll_18/ML_int[3][20]
+ B=sll_18/ML_int[3][12]
XU284 MUX2S $PINS O=sll_18/ML_int[3][20] S=FE_OFN200_h33_2 A=term3_in[26] B=n84
XU285 MUX2S $PINS O=term3_shifted[19] S=FE_OFN165_h33_3 A=sll_18/ML_int[3][19]
+ B=sll_18/ML_int[3][11]
XU286 MUX2S $PINS O=sll_18/ML_int[3][19] S=FE_OFN200_h33_2 A=term3_in[26]
+ B=sll_18/ML_int[2][15]
XU287 MUX2S $PINS O=term2_shifted[20] S=FE_OFN185_h32_3 A=sll_17/ML_int[3][20]
+ B=sll_17/ML_int[3][12]
XU288 MUX2S $PINS O=sll_17/ML_int[3][20] S=n33 A=term2_in[26] B=n74
XU289 MUX2S $PINS O=term2_shifted[19] S=FE_OFN185_h32_3 A=sll_17/ML_int[3][19]
+ B=sll_17/ML_int[3][11]
XU290 MUX2S $PINS O=sll_17/ML_int[3][19] S=n33 A=term2_in[26]
+ B=sll_17/ML_int[2][15]
XU291 MUX2S $PINS O=term1_shifted[21] S=n49 A=sll_16/ML_int[3][21]
+ B=sll_16/ML_int[3][13]
XU292 MUX2S $PINS O=sll_16/ML_int[3][21] S=n47 A=term1_in[26] B=n64
XU293 MUX2S $PINS O=term2_shifted[21] S=FE_OFN185_h32_3 A=sll_17/ML_int[3][21]
+ B=sll_17/ML_int[3][13]
XU294 MUX2S $PINS O=sll_17/ML_int[3][21] S=n33 A=term2_in[26] B=n75
XU295 MUX2S $PINS O=term3_shifted[21] S=FE_OFN165_h33_3 A=sll_18/ML_int[3][21]
+ B=sll_18/ML_int[3][13]
XU296 MUX2S $PINS O=sll_18/ML_int[3][21] S=FE_OFN200_h33_2 A=term3_in[26] B=n85
XU297 MUX2S $PINS O=term1_shifted[22] S=n49 A=sll_16/ML_int[3][22]
+ B=sll_16/ML_int[3][14]
XU298 MUX2S $PINS O=sll_16/ML_int[3][22] S=n47 A=term1_in[26] B=n65
XU299 MUX2S $PINS O=term2_shifted[22] S=FE_OFN185_h32_3 A=sll_17/ML_int[3][22]
+ B=sll_17/ML_int[3][14]
XU300 MUX2S $PINS O=sll_17/ML_int[3][22] S=n33 A=term2_in[26] B=n76
XU301 MUX2S $PINS O=term3_shifted[22] S=FE_OFN165_h33_3 A=sll_18/ML_int[3][22]
+ B=sll_18/ML_int[3][14]
XU302 MUX2S $PINS O=sll_18/ML_int[3][22] S=FE_OFN200_h33_2 A=term3_in[26] B=n86
XU303 AO22 $PINS O=N162 A1=N135 A2=FE_OFN150_s33_0 B1=term3_shifted[11] B2=n25
XU304 AO22 $PINS O=N163 A1=N136 A2=FE_OFN150_s33_0 B1=term3_shifted[12] B2=n25
XU305 AO22 $PINS O=N165 A1=N138 A2=FE_OFN150_s33_0 B1=term3_shifted[14] B2=n25
XU306 AO22 $PINS O=N166 A1=N139 A2=FE_OFN150_s33_0 B1=term3_shifted[15] B2=n25
XU308 AO22 $PINS O=N167 A1=N140 A2=FE_OFN150_s33_0 B1=term3_shifted[16] B2=n25
XU309 AO22 $PINS O=N168 A1=N141 A2=FE_OFN150_s33_0 B1=term3_shifted[17] B2=n25
XU310 AO22 $PINS O=N169 A1=N142 A2=FE_OFN150_s33_0 B1=term3_shifted[18] B2=n25
XU311 AO22 $PINS O=N170 A1=N143 A2=FE_OFN150_s33_0 B1=term3_shifted[19] B2=n25
XU312 AO22 $PINS O=N171 A1=N144 A2=FE_OFN150_s33_0 B1=term3_shifted[20] B2=n25
XU313 AO22 $PINS O=N172 A1=N145 A2=FE_OFN150_s33_0 B1=term3_shifted[21] B2=n25
XU314 AO22S $PINS O=N174 A1=N147 A2=FE_OFN150_s33_0 B1=term3_shifted[23] B2=n25
XU315 AO22S $PINS O=N175 A1=N148 A2=FE_OFN150_s33_0 B1=term3_shifted[24] B2=n25
XU316 AO22S $PINS O=N176 A1=N149 A2=FE_OFN150_s33_0 B1=term3_shifted[25] B2=n25
XU318 AN2S $PINS O=base_val[6] I1=acc_reg[6] I2=FE_OFN80_n
XU321 INV1S $PINS O=n72 I=n67
XU322 INV1S $PINS O=n73 I=n68
XU323 INV1S $PINS O=n83 I=n79
XU325 NR2 $PINS O=term3_in[4] I1=sign3[1] I2=x_in[4]
XU326 NR2 $PINS O=term1_in[5] I1=sign1[1] I2=x_in[5]
XU327 NR2 $PINS O=term2_in[5] I1=FE_OFN66_s32_1 I2=x_in[5]
XU328 NR2 $PINS O=term3_in[5] I1=sign3[1] I2=x_in[5]
XU329 NR2 $PINS O=term1_in[6] I1=sign1[1] I2=x_in[6]
XU330 NR2 $PINS O=term2_in[6] I1=FE_OFN66_s32_1 I2=x_in[6]
XU331 NR2 $PINS O=term3_in[6] I1=sign3[1] I2=x_in[6]
XU332 NR2 $PINS O=term1_in[7] I1=sign1[1] I2=x_in[7]
XU333 NR2 $PINS O=term2_in[7] I1=FE_OFN66_s32_1 I2=x_in[7]
XU334 NR2 $PINS O=term3_in[7] I1=x_in[7] I2=sign3[1]
XU335 NR2 $PINS O=term1_in[8] I1=sign1[1] I2=x_in[8]
XU337 NR2 $PINS O=term2_in[8] I1=FE_OFN66_s32_1 I2=x_in[8]
XU338 NR2 $PINS O=term3_in[8] I1=sign3[1] I2=x_in[8]
XU341 NR2 $PINS O=term1_in[9] I1=sign1[1] I2=x_in[9]
XU343 NR2 $PINS O=term1_in[10] I1=sign1[1] I2=x_in[10]
XU344 NR2 $PINS O=term2_in[9] I1=FE_OFN66_s32_1 I2=x_in[9]
XU345 NR2 $PINS O=term3_in[9] I1=sign3[1] I2=x_in[9]
XU346 NR2 $PINS O=term2_in[10] I1=FE_OFN66_s32_1 I2=x_in[10]
XU347 NR2 $PINS O=term3_in[10] I1=sign3[1] I2=x_in[10]
XU348 NR2 $PINS O=term1_in[11] I1=sign1[1] I2=x_in[11]
XU349 NR2 $PINS O=term2_in[11] I1=FE_OFN66_s32_1 I2=x_in[11]
XU350 NR2 $PINS O=term3_in[11] I1=sign3[1] I2=x_in[11]
XU351 NR2 $PINS O=term1_in[12] I1=sign1[1] I2=x_in[12]
XU352 NR2 $PINS O=term2_in[12] I1=FE_OFN66_s32_1 I2=x_in[12]
XU353 NR2 $PINS O=term3_in[12] I1=sign3[1] I2=x_in[12]
XU354 NR2 $PINS O=term1_in[13] I1=sign1[1] I2=x_in[13]
XU355 NR2 $PINS O=term2_in[13] I1=FE_OFN66_s32_1 I2=x_in[13]
XU356 NR2 $PINS O=term3_in[13] I1=sign3[1] I2=x_in[13]
XU357 NR2 $PINS O=term1_in[14] I1=sign1[1] I2=n92
XU359 NR2 $PINS O=term2_in[14] I1=FE_OFN66_s32_1 I2=n92
XU360 NR2 $PINS O=term3_in[14] I1=sign3[1] I2=n92
XU363 NR2 $PINS O=term1_in[15] I1=sign1[1] I2=n93
XU364 NR2 $PINS O=term1_in[26] I1=n94 I2=sign1[1]
XU365 NR2 $PINS O=term2_in[15] I1=FE_OFN66_s32_1 I2=n93
XU366 NR2 $PINS O=term3_in[15] I1=sign3[1] I2=n93
XU367 NR2 $PINS O=term2_in[26] I1=n94 I2=FE_OFN66_s32_1
XU368 NR2 $PINS O=term3_in[26] I1=n94 I2=sign3[1]
XU392 INV1S $PINS O=n92 I=x_in[14]
XU393 INV1S $PINS O=n93 I=x_in[15]
XU394 INV1S $PINS O=n94 I=x_in[16]
XU395 AN2 $PINS O=base_val[26] I1=N251 I2=FE_OFN73_n
XU396 AN2 $PINS O=base_val[1] I1=acc_reg[1] I2=FE_OFN80_n
XU397 MOAI1S $PINS O=base_val[9] A1=stage_sel A2=FE_OFN80_n B1=acc_reg[9]
+ B2=FE_OFN80_n
XU398 AN2 $PINS O=base_val[10] I1=acc_reg[10] I2=FE_OFN80_n
XU399 AN2 $PINS O=base_val[12] I1=acc_reg[12] I2=FE_OFN80_n
XU400 AN2 $PINS O=base_val[14] I1=acc_reg[14] I2=FE_OFN73_n
XU401 AN2 $PINS O=base_val[15] I1=acc_reg[15] I2=FE_OFN73_n
XU402 AN2 $PINS O=base_val[16] I1=acc_reg[16] I2=FE_OFN73_n
XU403 AN2 $PINS O=base_val[17] I1=acc_reg[17] I2=FE_OFN73_n
XU404 AN2 $PINS O=base_val[18] I1=acc_reg[18] I2=FE_OFN73_n
XU405 AN2 $PINS O=base_val[19] I1=acc_reg[19] I2=FE_OFN73_n
XU406 AN2 $PINS O=base_val[20] I1=acc_reg[20] I2=FE_OFN73_n
XU407 AN2 $PINS O=base_val[21] I1=FE_PHN1163_acc_reg_21 I2=FE_OFN73_n
XU408 AN2 $PINS O=base_val[22] I1=acc_reg[22] I2=FE_OFN73_n
XU409 AN2 $PINS O=base_val[23] I1=acc_reg[23] I2=FE_OFN73_n
XU410 AN2 $PINS O=base_val[24] I1=acc_reg[24] I2=FE_OFN73_n
XU411 AN2 $PINS O=base_val[25] I1=acc_reg[25] I2=FE_OFN73_n
XU412 AN2 $PINS O=base_val[8] I1=acc_reg[8] I2=FE_OFN80_n
XU413 AN2 $PINS O=base_val[7] I1=acc_reg[7] I2=FE_OFN80_n
XU415 AN2 $PINS O=N234 I1=en I2=calc_done
XU417 NR2 $PINS O=sll_16/ML_int[3][0] I1=n47 I2=n57
XU418 NR2 $PINS O=sll_16/ML_int[3][1] I1=n47 I2=n58
XU419 NR2 $PINS O=sll_16/ML_int[3][2] I1=n47 I2=n61
XU420 NR2 $PINS O=sll_16/ML_int[3][3] I1=n47 I2=n60
XU421 ND2 $PINS O=n59 I1=shf1[2] I2=shf1[3]
XU422 AN2 $PINS O=term1_shifted[4] I1=sll_16/ML_int[3][4] I2=shf1[3]
XU423 AN2 $PINS O=term1_shifted[5] I1=sll_16/ML_int[3][5] I2=shf1[3]
XU424 AN2 $PINS O=term1_shifted[6] I1=sll_16/ML_int[3][6] I2=shf1[3]
XU425 AN2 $PINS O=term1_shifted[7] I1=sll_16/ML_int[3][7] I2=shf1[3]
XU426 MUX2 $PINS O=term1_shifted[24] S=n49 A=term1_in[26]
+ B=sll_16/ML_int[3][16]
XU427 MUX2 $PINS O=term1_shifted[25] S=n49 A=term1_in[26]
+ B=sll_16/ML_int[3][17]
XU428 MUX2 $PINS O=n64 S=FE_OFN215_h31_1 A=term1_in[26] B=sll_16/ML_int[1][15]
XU429 MUX2 $PINS O=term1_shifted[26] S=n49 A=term1_in[26]
+ B=sll_16/ML_int[3][18]
XU430 MUX2 $PINS O=n65 S=FE_OFN215_h31_1 A=term1_in[26] B=n66
XU431 MUX2 $PINS O=n66 S=FE_OFN372_h31_0 A=term1_in[26] B=term1_in[15]
XU432 NR2 $PINS O=sll_17/ML_int[3][2] I1=n33 I2=n71
XU433 NR2 $PINS O=sll_17/ML_int[3][3] I1=n33 I2=n70
XU434 AN2 $PINS O=term2_shifted[4] I1=sll_17/ML_int[3][4] I2=n35
XU435 AN2 $PINS O=term2_shifted[5] I1=sll_17/ML_int[3][5] I2=n35
XU436 AN2 $PINS O=term2_shifted[6] I1=sll_17/ML_int[3][6] I2=n35
XU437 AN2 $PINS O=term2_shifted[7] I1=sll_17/ML_int[3][7] I2=n35
XU438 MUX2 $PINS O=term2_shifted[24] S=FE_OFN185_h32_3 A=term2_in[26]
+ B=sll_17/ML_int[3][16]
XU439 MUX2 $PINS O=term2_shifted[25] S=FE_OFN185_h32_3 A=term2_in[26]
+ B=sll_17/ML_int[3][17]
XU440 MUX2 $PINS O=n75 S=FE_OFN205_h32_1 A=term2_in[26] B=sll_17/ML_int[1][15]
XU441 MUX2 $PINS O=term2_shifted[26] S=FE_OFN185_h32_3 A=term2_in[26]
+ B=sll_17/ML_int[3][18]
XU442 MUX2 $PINS O=n76 S=FE_OFN205_h32_1 A=term2_in[26] B=n77
XU443 MUX2 $PINS O=n77 S=FE_OFN236_h32_0 A=term2_in[26] B=term2_in[15]
XU444 NR2 $PINS O=sll_18/ML_int[3][0] I1=shf3[2] I2=n78
XU445 NR2 $PINS O=sll_18/ML_int[3][1] I1=shf3[2] I2=n79
XU446 NR2 $PINS O=sll_18/ML_int[3][2] I1=shf3[2] I2=n82
XU447 NR2 $PINS O=sll_18/ML_int[3][3] I1=FE_OFN200_h33_2 I2=n81
XU448 ND2P $PINS O=n80 I1=n20 I2=n22
XU449 AN2 $PINS O=term3_shifted[4] I1=sll_18/ML_int[3][4] I2=n22
XU450 AN2 $PINS O=term3_shifted[5] I1=sll_18/ML_int[3][5] I2=n22
XU451 AN2 $PINS O=term3_shifted[6] I1=sll_18/ML_int[3][6] I2=n22
XU452 AN2 $PINS O=term3_shifted[7] I1=sll_18/ML_int[3][7] I2=n22
XU453 MUX2 $PINS O=term3_shifted[24] S=FE_OFN165_h33_3 A=term3_in[26]
+ B=sll_18/ML_int[3][16]
XU454 MUX2 $PINS O=term3_shifted[25] S=FE_OFN165_h33_3 A=term3_in[26]
+ B=sll_18/ML_int[3][17]
XU455 MUX2 $PINS O=n85 S=FE_OFN224_h33_1 A=term3_in[26] B=sll_18/ML_int[1][15]
XU456 MUX2 $PINS O=term3_shifted[26] S=FE_OFN165_h33_3 A=term3_in[26]
+ B=sll_18/ML_int[3][18]
XU457 MUX2 $PINS O=n86 S=FE_OFN224_h33_1 A=term3_in[26] B=n87
XU458 MUX2 $PINS O=n87 S=FE_OFN303_h33_0 A=term3_in[26] B=term3_in[15]
XU459 MUX2 $PINS O=FE_PHN976_N241 S=FE_OFN40_FE_DBTN10_n289 A=acc_reg[16]
+ B=acc_reg[20]
XU460 MUX2 $PINS O=N243 S=FE_OFN40_FE_DBTN10_n289 A=acc_reg[18] B=acc_reg[22]
XU461 MUX2 $PINS O=FE_PHN985_N244 S=FE_OFN40_FE_DBTN10_n289 A=acc_reg[19]
+ B=acc_reg[23]
XU71 MUX2 $PINS O=sll_17/ML_int[1][5] S=FE_OFN236_h32_0 A=term2_in[5]
+ B=term2_in[4]
XU3 NR2 $PINS O=term2_shifted[0] I1=n11 I2=n10
XU4 NR2 $PINS O=term3_in[3] I1=sign3[1] I2=FE_OFN120_mac_in_imag_3
XU7 MOAI1H $PINS O=N98 A1=FE_DBTN16_term2_shifted_2 A2=sign2[0] B1=N71
+ B2=sign2[0]
XU8 NR2P $PINS O=term1_shifted[1] I1=n4 I2=n3
XU10 NR2 $PINS O=term1_in[0] I1=sign1[1] I2=FE_OFN346_mac_in_imag_0
XU12 NR2 $PINS O=term1_in[2] I1=sign1[1] I2=x_in[2]
XU14 NR2 $PINS O=term1_in[3] I1=sign1[1] I2=FE_OFN120_mac_in_imag_3
XU15 NR2 $PINS O=term1_in[4] I1=sign1[1] I2=x_in[4]
XU17 NR2T $PINS O=term2_shifted[1] I1=n69 I2=n68
XU18 ND2P $PINS O=n68 I1=sll_17/ML_int[1][1] I2=n31
XU20 NR2T $PINS O=term3_shifted[2] I1=n80 I2=n82
XU24 INV2 $PINS O=n82 I=sll_18/ML_int[2][2]
XU31 ND3 $PINS O=n57 I1=term1_in[0] I2=n43 I3=FE_RN_388_0
XU42 NR2P $PINS O=term3_shifted[0] I1=n80 I2=n78
XU43 NR2P $PINS O=term1_shifted[2] I1=n59 I2=n61
XU44 AN2 $PINS O=sll_18/ML_int[1][0] I1=term3_in[0] I2=n16
XU45 NR2 $PINS O=term3_in[2] I1=sign3[1] I2=x_in[2]
XU47 ND3 $PINS O=n78 I1=term3_in[0] I2=n16 I3=n18
XU48 NR2P $PINS O=term3_in[1] I1=sign3[1] I2=x_in[1]
XU49 NR2P $PINS O=term3_shifted[1] I1=n80 I2=n79
XU62 NR2 $PINS O=term2_in[3] I1=FE_OFN66_s32_1 I2=FE_OFN120_mac_in_imag_3
XU72 INV1S $PINS O=n10 I=sll_17/ML_int[1][0]
XU85 AO22 $PINS O=N122 A1=N95 A2=n39 B1=term2_shifted[26] B2=FE_OFN168_s32_0
XU92 AO22S $PINS O=N121 A1=N94 A2=n39 B1=term2_shifted[25] B2=FE_OFN168_s32_0
XU98 AO22S $PINS O=N120 A1=N93 A2=n39 B1=term2_shifted[24] B2=FE_OFN168_s32_0
XU100 AO22S $PINS O=N119 A1=N92 A2=n39 B1=term2_shifted[23] B2=FE_OFN168_s32_0
XU106 AO22S $PINS O=N118 A1=N91 A2=n39 B1=term2_shifted[22] B2=FE_OFN168_s32_0
XU112 AO22S $PINS O=N117 A1=N90 A2=n39 B1=term2_shifted[21] B2=FE_OFN168_s32_0
XU127 AO22S $PINS O=N116 A1=N89 A2=n39 B1=term2_shifted[20] B2=FE_OFN168_s32_0
XU138 AO22S $PINS O=N115 A1=N88 A2=n39 B1=term2_shifted[19] B2=FE_OFN168_s32_0
XU169 AO22S $PINS O=N114 A1=N87 A2=n39 B1=term2_shifted[18] B2=FE_OFN168_s32_0
XU170 AO22S $PINS O=N113 A1=N86 A2=sign2[0] B1=term2_shifted[17]
+ B2=FE_OFN168_s32_0
XU171 AO22S $PINS O=N111 A1=N84 A2=sign2[0] B1=term2_shifted[15]
+ B2=FE_OFN168_s32_0
XU172 AO22 $PINS O=N110 A1=N83 A2=sign2[0] B1=term2_shifted[14]
+ B2=FE_OFN168_s32_0
XU173 AO22 $PINS O=N109 A1=N82 A2=sign2[0] B1=term2_shifted[13]
+ B2=FE_OFN168_s32_0
XU174 AO22 $PINS O=N108 A1=N81 A2=sign2[0] B1=term2_shifted[12]
+ B2=FE_OFN168_s32_0
XU176 AO22 $PINS O=N107 A1=N80 A2=sign2[0] B1=term2_shifted[11]
+ B2=FE_OFN168_s32_0
XU177 AO22 $PINS O=N106 A1=N79 A2=sign2[0] B1=term2_shifted[10]
+ B2=FE_OFN168_s32_0
XU178 AO22 $PINS O=N105 A1=N78 A2=sign2[0] B1=term2_shifted[9]
+ B2=FE_OFN168_s32_0
XU180 AO22 $PINS O=N104 A1=N77 A2=sign2[0] B1=term2_shifted[8]
+ B2=FE_OFN168_s32_0
XU181 AO22P $PINS O=N103 A1=N76 A2=sign2[0] B1=term2_shifted[7]
+ B2=FE_OFN167_s32_0
XU183 AO22 $PINS O=N102 A1=N75 A2=sign2[0] B1=term2_shifted[6]
+ B2=FE_OFN167_s32_0
XU185 AO22 $PINS O=N101 A1=N74 A2=sign2[0] B1=term2_shifted[5]
+ B2=FE_OFN167_s32_0
Xclk_gate_y_out_reg SNPS_CLOCK_GATE_HIGH_PE_Shift_Add_0 $PINS EN=N234
+ ENCLK=net2209 CLK_clone1=clk_clone3 CLK=clk_clone2
Xsub_28_3 PE_Shift_Add_0_DW01_sub_0 $PINS A[26]=net45487 A[25]=net45487
+ A[24]=net45487 A[23]=net45487 A[22]=net45487 A[21]=net45487 A[20]=net45487
+ A[19]=net45487 A[18]=net45487 A[17]=net45487 A[16]=net45487 A[15]=net45487
+ A[14]=net45487 A[13]=net45487 A[12]=net45487 A[11]=net45487 A[10]=net45487
+ A[9]=net45487 A[8]=net45487 A[7]=net45487 A[6]=net45487 A[5]=net45487
+ A[4]=net45487 A[3]=net45487 A[2]=net45487 A[1]=net45487 A[0]=net45487
+ B[26]=term3_shifted[26] B[25]=term3_shifted[25] B[24]=term3_shifted[24]
+ B[23]=term3_shifted[23] B[22]=term3_shifted[22] B[21]=term3_shifted[21]
+ B[20]=term3_shifted[20] B[19]=term3_shifted[19] B[18]=term3_shifted[18]
+ B[17]=term3_shifted[17] B[16]=term3_shifted[16] B[15]=term3_shifted[15]
+ B[14]=term3_shifted[14] B[13]=term3_shifted[13] B[12]=term3_shifted[12]
+ B[11]=term3_shifted[11] B[10]=term3_shifted[10] B[9]=term3_shifted[9]
+ B[8]=term3_shifted[8] B[7]=term3_shifted[7] B[6]=term3_shifted[6]
+ B[5]=term3_shifted[5] B[4]=term3_shifted[4] B[3]=term3_shifted[3]
+ B[2]=term3_shifted[2] B[1]=term3_shifted[1] B[0]=term3_shifted[0] CI=net45487
+ DIFF[26]=N150 DIFF[25]=N149 DIFF[24]=N148 DIFF[23]=N147 DIFF[22]=N146
+ DIFF[21]=N145 DIFF[20]=N144 DIFF[19]=N143 DIFF[18]=N142 DIFF[17]=N141
+ DIFF[16]=N140 DIFF[15]=N139 DIFF[14]=N138 DIFF[13]=N137 DIFF[12]=N136
+ DIFF[11]=N135 DIFF[10]=N134 DIFF[9]=N133 DIFF[8]=N132 DIFF[7]=N131 DIFF[6]=N130
+ DIFF[5]=N129 DIFF[4]=N128 DIFF[3]=N127 DIFF[2]=N126 DIFF[1]=N125 DIFF[0]=N124
Xsub_28_2 PE_Shift_Add_0_DW01_sub_1 $PINS A[26]=net45487 A[25]=net45487
+ A[24]=net45487 A[23]=net45487 A[22]=net45487 A[21]=net45487 A[20]=net45487
+ A[19]=net45487 A[18]=net45487 A[17]=net45487 A[16]=net45487 A[15]=net45487
+ A[14]=net45487 A[13]=net45487 A[12]=net45487 A[11]=net45487 A[10]=net45487
+ A[9]=net45487 A[8]=net45487 A[7]=net45487 A[6]=net45487 A[5]=net45487
+ A[4]=net45487 A[3]=net45487 A[2]=net45487 A[1]=net45487 A[0]=net45487
+ B[26]=term2_shifted[26] B[25]=term2_shifted[25] B[24]=term2_shifted[24]
+ B[23]=term2_shifted[23] B[22]=term2_shifted[22] B[21]=term2_shifted[21]
+ B[20]=term2_shifted[20] B[19]=term2_shifted[19] B[18]=term2_shifted[18]
+ B[17]=term2_shifted[17] B[16]=term2_shifted[16] B[15]=term2_shifted[15]
+ B[14]=term2_shifted[14] B[13]=term2_shifted[13] B[12]=term2_shifted[12]
+ B[11]=term2_shifted[11] B[10]=term2_shifted[10] B[9]=term2_shifted[9]
+ B[8]=term2_shifted[8] B[7]=term2_shifted[7] B[6]=term2_shifted[6]
+ B[5]=term2_shifted[5] B[4]=term2_shifted[4] B[3]=term2_shifted[3]
+ B[2]=FE_DBTN16_term2_shifted_2 B[1]=term2_shifted[1] B[0]=term2_shifted[0]
+ CI=net45487 DIFF[26]=N95 DIFF[25]=N94 DIFF[24]=N93 DIFF[23]=N92 DIFF[22]=N91
+ DIFF[21]=N90 DIFF[20]=N89 DIFF[19]=N88 DIFF[18]=N87 DIFF[17]=N86 DIFF[16]=N85
+ DIFF[15]=N84 DIFF[14]=N83 DIFF[13]=N82 DIFF[12]=N81 DIFF[11]=N80 DIFF[10]=N79
+ DIFF[9]=N78 DIFF[8]=N77 DIFF[7]=N76 DIFF[6]=N75 DIFF[5]=N74 DIFF[4]=N73
+ DIFF[3]=N72 DIFF[2]=N71 DIFF[1]=N70 DIFF[0]=N69
Xsub_28 PE_Shift_Add_0_DW01_sub_2 $PINS A[26]=net45487 A[25]=net45487
+ A[24]=net45487 A[23]=net45487 A[22]=net45487 A[21]=net45487 A[20]=net45487
+ A[19]=net45487 A[18]=net45487 A[17]=net45487 A[16]=net45487 A[15]=net45487
+ A[14]=net45487 A[13]=net45487 A[12]=net45487 A[11]=net45487 A[10]=net45487
+ A[9]=net45487 A[8]=net45487 A[7]=net45487 A[6]=net45487 A[5]=net45487
+ A[4]=net45487 A[3]=net45487 A[2]=net45487 A[1]=net45487 A[0]=net45487
+ B[26]=term1_shifted[26] B[25]=term1_shifted[25] B[24]=term1_shifted[24]
+ B[23]=term1_shifted[23] B[22]=term1_shifted[22] B[21]=term1_shifted[21]
+ B[20]=term1_shifted[20] B[19]=term1_shifted[19] B[18]=term1_shifted[18]
+ B[17]=term1_shifted[17] B[16]=term1_shifted[16] B[15]=term1_shifted[15]
+ B[14]=term1_shifted[14] B[13]=term1_shifted[13] B[12]=term1_shifted[12]
+ B[11]=term1_shifted[11] B[10]=term1_shifted[10] B[9]=term1_shifted[9]
+ B[8]=term1_shifted[8] B[7]=term1_shifted[7] B[6]=term1_shifted[6]
+ B[5]=term1_shifted[5] B[4]=term1_shifted[4] B[3]=term1_shifted[3]
+ B[2]=term1_shifted[2] B[1]=term1_shifted[1] B[0]=term1_shifted[0] CI=net45487
+ DIFF[26]=N40 DIFF[25]=N39 DIFF[24]=N38 DIFF[23]=N37 DIFF[22]=N36 DIFF[21]=N35
+ DIFF[20]=N34 DIFF[19]=N33 DIFF[18]=N32 DIFF[17]=N31 DIFF[16]=N30 DIFF[15]=N29
+ DIFF[14]=N28 DIFF[13]=N27 DIFF[12]=N26 DIFF[11]=N25 DIFF[10]=N24 DIFF[9]=N23
+ DIFF[8]=N22 DIFF[7]=N21 DIFF[6]=N20 DIFF[5]=N19 DIFF[4]=N18 DIFF[3]=N17
+ DIFF[2]=N16 DIFF[1]=N15 DIFF[0]=N14
Xadd_1_root_add_0_root_add_28_3 PE_Shift_Add_0_DW01_add_2_DW01_add_16 $PINS
+ A[26]=N67 A[25]=N66 A[24]=N65 A[23]=N64 A[22]=N63 A[21]=N62 A[20]=N61 A[19]=N60
+ A[18]=N59 A[17]=N58 A[16]=N57 A[15]=N56 A[14]=N55 A[13]=N54 A[12]=N53 A[11]=N52
+ A[10]=N51 A[9]=N50 A[8]=N49 A[7]=N48 A[6]=N47 A[5]=N46 A[4]=N45 A[3]=N44
+ A[2]=N43 A[1]=N42 A[0]=N41 B[26]=N177 B[25]=N176 B[24]=N175 B[23]=N174
+ B[22]=N173 B[21]=N172 B[20]=N171 B[19]=N170 B[18]=N169 B[17]=N168 B[16]=N167
+ B[15]=N166 B[14]=N165 B[13]=N164 B[12]=N163 B[11]=N162 B[10]=N161 B[9]=N160
+ B[8]=N159 B[7]=N158 B[6]=N157 B[5]=N156 B[4]=N155 B[3]=N154 B[2]=N153 B[1]=N152
+ B[0]=N151 CI=net45487 SUM[26]=N204 SUM[25]=N203 SUM[24]=N202 SUM[23]=N201
+ SUM[22]=N200 SUM[21]=N199 SUM[20]=N198 SUM[19]=N197 SUM[18]=N196 SUM[17]=N195
+ SUM[16]=N194 SUM[15]=N193 SUM[14]=N192 SUM[13]=N191 SUM[12]=N190 SUM[11]=N189
+ SUM[10]=N188 SUM[9]=N187 SUM[8]=N186 SUM[7]=N185 SUM[6]=N184 SUM[5]=N183
+ SUM[4]=N182 SUM[3]=N181 SUM[2]=N180 SUM[1]=N179 SUM[0]=N178
Xadd_2_root_add_0_root_add_28_3 PE_Shift_Add_0_DW01_add_1_DW01_add_15 $PINS
+ A[26]=base_val[26] A[25]=base_val[25] A[24]=base_val[24] A[23]=base_val[23]
+ A[22]=base_val[22] A[21]=base_val[21] A[20]=base_val[20] A[19]=base_val[19]
+ A[18]=base_val[18] A[17]=base_val[17] A[16]=base_val[16] A[15]=base_val[15]
+ A[14]=base_val[14] A[13]=base_val[13] A[12]=base_val[12] A[11]=base_val[11]
+ A[10]=base_val[10] A[9]=base_val[9] A[8]=base_val[8] A[7]=base_val[7]
+ A[6]=base_val[6] A[5]=base_val[5] A[4]=base_val[4] A[3]=base_val[3]
+ A[2]=base_val[2] A[1]=base_val[1] A[0]=base_val[0] B[26]=N122 B[25]=N121
+ B[24]=N120 B[23]=N119 B[22]=N118 B[21]=N117 B[20]=N116 B[19]=N115 B[18]=N114
+ B[17]=N113 B[16]=N112 B[15]=N111 B[14]=N110 B[13]=N109 B[12]=N108 B[11]=N107
+ B[10]=N106 B[9]=N105 B[8]=N104 B[7]=N103 B[6]=N102 B[5]=N101 B[4]=N100 B[3]=N99
+ B[2]=N98 B[1]=N97 B[0]=N96 CI=net45487 SUM[26]=N231 SUM[25]=N230 SUM[24]=N229
+ SUM[23]=N228 SUM[22]=N227 SUM[21]=N226 SUM[20]=N225 SUM[19]=N224 SUM[18]=N223
+ SUM[17]=N222 SUM[16]=N221 SUM[15]=N220 SUM[14]=N219 SUM[13]=N218 SUM[12]=N217
+ SUM[11]=N216 SUM[10]=N215 SUM[9]=N214 SUM[8]=N213 SUM[7]=N212 SUM[6]=N211
+ SUM[5]=N210 SUM[4]=N209 SUM[3]=N208 SUM[2]=N207 SUM[1]=N206 SUM[0]=N205
Xadd_0_root_add_0_root_add_28_3 PE_Shift_Add_0_DW01_add_0_DW01_add_14 $PINS
+ A[26]=N204 A[25]=N203 A[24]=N202 A[23]=N201 A[22]=N200 A[21]=N199 A[20]=N198
+ A[19]=N197 A[18]=N196 A[17]=N195 A[16]=N194 A[15]=N193 A[14]=N192 A[13]=N191
+ A[12]=N190 A[11]=N189 A[10]=N188 A[9]=N187 A[8]=N186 A[7]=N185 A[6]=N184
+ A[5]=N183 A[4]=N182 A[3]=N181 A[2]=N180 A[1]=N179 A[0]=N178 B[26]=N231
+ B[25]=N230 B[24]=N229 B[23]=N228 B[22]=N227 B[21]=N226 B[20]=N225 B[19]=N224
+ B[18]=N223 B[17]=N222 B[16]=N221 B[15]=N220 B[14]=N219 B[13]=N218 B[12]=N217
+ B[11]=N216 B[10]=N215 B[9]=N214 B[8]=N213 B[7]=N212 B[6]=N211 B[5]=N210
+ B[4]=N209 B[3]=N208 B[2]=N207 B[1]=N206 B[0]=N205 CI=net45487
+ SUM[26]=next_acc[26] SUM[25]=next_acc[25] SUM[24]=next_acc[24]
+ SUM[23]=next_acc[23] SUM[22]=next_acc[22] SUM[21]=next_acc[21]
+ SUM[20]=next_acc[20] SUM[19]=next_acc[19] SUM[18]=next_acc[18]
+ SUM[17]=next_acc[17] SUM[16]=next_acc[16] SUM[15]=next_acc[15]
+ SUM[14]=next_acc[14] SUM[13]=next_acc[13] SUM[12]=next_acc[12]
+ SUM[11]=next_acc[11] SUM[10]=next_acc[10] SUM[9]=next_acc[9] SUM[8]=next_acc[8]
+ SUM[7]=next_acc[7] SUM[6]=next_acc[6] SUM[5]=next_acc[5] SUM[4]=next_acc[4]
+ SUM[3]=next_acc[3] SUM[2]=next_acc[2] SUM[1]=next_acc[1] SUM[0]=next_acc[0]
.ENDS

.SUBCKT DFrFT_MAC rst_n en pe_clear pe_done g_cnt[2] g_cnt[1] g_cnt[0] n_cnt[5]
+ n_cnt[4] n_cnt[3] n_cnt[2] n_cnt[1] n_cnt[0] data_in_r[16] data_in_r[15]
+ data_in_r[14] data_in_r[13] data_in_r[12] data_in_r[11] data_in_r[10]
+ data_in_r[9] data_in_r[8] data_in_r[7] data_in_r[6] data_in_r[5] data_in_r[4]
+ data_in_r[3] data_in_r[2] data_in_r[1] data_in_r[0] data_in_i[16]
+ data_in_i[15] data_in_i[14] data_in_i[13] data_in_i[12] data_in_i[11]
+ data_in_i[10] data_in_i[9] data_in_i[8] data_in_i[7] data_in_i[6]
+ data_in_i[5] data_in_i[4] data_in_i[3] data_in_i[2] data_in_i[1] data_in_i[0]
+ y_out_0_r[16] y_out_0_r[15] y_out_0_r[14] y_out_0_r[13] y_out_0_r[12]
+ y_out_0_r[11] y_out_0_r[10] y_out_0_r[9] y_out_0_r[8] y_out_0_r[7]
+ y_out_0_r[6] y_out_0_r[5] y_out_0_r[4] y_out_0_r[3] y_out_0_r[2] y_out_0_r[1]
+ y_out_0_r[0] y_out_0_i[16] y_out_0_i[15] y_out_0_i[14] y_out_0_i[13]
+ y_out_0_i[12] y_out_0_i[11] y_out_0_i[10] y_out_0_i[9] y_out_0_i[8]
+ y_out_0_i[7] y_out_0_i[6] y_out_0_i[5] y_out_0_i[4] y_out_0_i[3] y_out_0_i[2]
+ y_out_0_i[1] y_out_0_i[0] y_out_1_r[16] y_out_1_r[15] y_out_1_r[14]
+ y_out_1_r[13] y_out_1_r[12] y_out_1_r[11] y_out_1_r[10] y_out_1_r[9]
+ y_out_1_r[8] y_out_1_r[7] y_out_1_r[6] y_out_1_r[5] y_out_1_r[4] y_out_1_r[3]
+ y_out_1_r[2] y_out_1_r[1] y_out_1_r[0] y_out_1_i[16] y_out_1_i[15]
+ y_out_1_i[14] y_out_1_i[13] y_out_1_i[12] y_out_1_i[11] y_out_1_i[10]
+ y_out_1_i[9] y_out_1_i[8] y_out_1_i[7] y_out_1_i[6] y_out_1_i[5] y_out_1_i[4]
+ y_out_1_i[3] y_out_1_i[2] y_out_1_i[1] y_out_1_i[0] y_out_2_r[16]
+ y_out_2_r[15] y_out_2_r[14] y_out_2_r[13] y_out_2_r[12] y_out_2_r[11]
+ y_out_2_r[10] y_out_2_r[9] y_out_2_r[8] y_out_2_r[7] y_out_2_r[6]
+ y_out_2_r[5] y_out_2_r[4] y_out_2_r[3] y_out_2_r[2] y_out_2_r[1] y_out_2_r[0]
+ y_out_2_i[16] y_out_2_i[15] y_out_2_i[14] y_out_2_i[13] y_out_2_i[12]
+ y_out_2_i[11] y_out_2_i[10] y_out_2_i[9] y_out_2_i[8] y_out_2_i[7]
+ y_out_2_i[6] y_out_2_i[5] y_out_2_i[4] y_out_2_i[3] y_out_2_i[2] y_out_2_i[1]
+ y_out_2_i[0] y_out_3_r[16] y_out_3_r[15] y_out_3_r[14] y_out_3_r[13]
+ y_out_3_r[12] y_out_3_r[11] y_out_3_r[10] y_out_3_r[9] y_out_3_r[8]
+ y_out_3_r[7] y_out_3_r[6] y_out_3_r[5] y_out_3_r[4] y_out_3_r[3] y_out_3_r[2]
+ y_out_3_r[1] y_out_3_r[0] y_out_3_i[16] y_out_3_i[15] y_out_3_i[14]
+ y_out_3_i[13] y_out_3_i[12] y_out_3_i[11] y_out_3_i[10] y_out_3_i[9]
+ y_out_3_i[8] y_out_3_i[7] y_out_3_i[6] y_out_3_i[5] y_out_3_i[4] y_out_3_i[3]
+ y_out_3_i[2] y_out_3_i[1] y_out_3_i[0] stage_sel_BAR i_rst_n p1
+ FE_OFN27_i_rst_n FE_OFN21_i_rst_n FE_OFN19_i_rst_n FE_OFN15_i_rst_n
+ FE_OFN9_i_rst_n FE_OFN7_i_rst_n FE_OFN3_i_rst_n FE_OFN0_i_rst_n FE_OFN35_n
+ FE_OFN34_n FE_OFN30_n FE_OFN57_FE_DBTN10_n289 FE_OFN55_FE_DBTN10_n289
+ clk_clone11 clk_clone9 clk_clone8 clk_clone7 clk_clone6 clk_clone10
+ clk_clone5 clk_clone4 clk_clone3 clk_clone2 clk_clone1 clk p2
XCTS_ccl_a_INV_CLK_G0_L9_21 INV12CK $PINS O=CTS_29 I=clk
XCTS_ccl_a_INV_CLK_G0_L9_20 INV12CK $PINS O=CTS_28 I=clk_clone1
XCTS_ccl_a_INV_CLK_G0_L5_5 INV6CK $PINS O=CTS_27 I=clk_clone4
XCTS_ccl_a_INV_CLK_G0_L9_3 INV12CK $PINS O=CTS_26 I=clk_clone7
XCTS_ccl_a_INV_CLK_G0_L9_2 INV12CK $PINS O=CTS_25 I=clk_clone7
XFE_OFC697_h13_3 BUF2 $PINS O=FE_OFN192_h13_3 I=h13[3]
XFE_OFC696_mac_in_imag_9 INV2 $PINS O=FE_OFN343_n I=data_in_i[9]
XFE_OFC694_mac_in_imag_0 INV8 $PINS O=FE_OFN346_mac_in_imag_0 I=data_in_i[0]
XFE_OFC689_mac_in_imag_8 BUF3 $PINS O=FE_OFN369_n I=FE_OFN19_mac_in_imag_8
XFE_OFC676_s01_0 INV1S $PINS O=FE_OFN358_n I=FE_OFN278_s01_0
XFE_OFC652_mac_in_imag_3 INV6 $PINS O=FE_OFN120_mac_in_imag_3 I=data_in_i[3]
XFE_OFC623_s21_0 BUF1 $PINS O=FE_OFN348_n I=FE_OFN152_s21_0
XFE_OFC621_s21_1 BUF2 $PINS O=FE_OFN265_s21_1 I=s21[1]
XFE_OFC607_s13_1 BUF4 $PINS O=FE_OFN282_s13_1 I=s13[1]
XFE_OFC606_mac_in_real_1 INV8 $PINS O=FE_OFN121_mac_in_real_1 I=data_in_r[1]
XFE_OFC604_h13_2 BUF2 $PINS O=FE_OFN259_h13_2 I=h13[2]
XFE_OFC602_mac_in_imag_2 INV8 $PINS O=FE_OFN114_mac_in_imag_2 I=data_in_i[2]
XFE_OFC597_mac_in_imag_7 INV3 $PINS O=FE_OFN345_mac_in_imag_7 I=data_in_i[7]
XFE_OFC559_h23_2 INV2 $PINS O=FE_OFN193_h23_2 I=h23[2]
XFE_OFC553_mac_in_real_3 INV4 $PINS O=FE_OFN116_mac_in_real_3 I=data_in_r[3]
XFE_OFC545_pe_clear_d1 INV2 $PINS O=FE_OFN326_n I=pe_clear
XFE_OFC544_pe_clear_d1 INV2 $PINS O=FE_OFN325_n I=pe_clear
XFE_OFC542_pe_clear_d1 INV2 $PINS O=FE_OFN323_n I=pe_clear
XFE_OFC541_pe_clear_d1 INV2 $PINS O=FE_OFN322_n I=pe_clear
XFE_OFC540_pe_clear_d1 INV1S $PINS O=FE_OFN321_n I=pe_clear
XFE_OFC538_pe_clear_d1 BUF1 $PINS O=FE_OFN319_n I=pe_clear
XFE_OFC536_s33_1 BUF2 $PINS O=FE_OFN318_s33_1 I=s33[1]
XFE_OFC535_mac_in_real_5 INV4 $PINS O=FE_OFN144_mac_in_real_5 I=data_in_r[5]
XFE_OFC522_s22_0 INV2 $PINS O=FE_OFN131_s22_0 I=s22[0]
XFE_OFC517_mac_in_imag_5 INV4 $PINS O=FE_OFN22_mac_in_imag_5 I=data_in_i[5]
XFE_OFC515_mac_in_real_0 INV12 $PINS O=FE_OFN117_mac_in_real_0 I=data_in_r[0]
XFE_OFC509_h22_3 INV2 $PINS O=FE_OFN198_h22_3 I=h22[3]
XFE_OFC505_h22_2 INV1S $PINS O=FE_OFN196_h22_2 I=h22[2]
XFE_OFC491_mac_in_imag_6 INV4 $PINS O=FE_OFN307_mac_in_imag_6 I=data_in_i[6]
XFE_OFC483_h11_0 BUF2 $PINS O=FE_OFN300_h11_0 I=h11[0]
XFE_OFC472_h11_1 BUF2 $PINS O=FE_OFN289_h11_1 I=h11[1]
XFE_OFC470_s32_1 BUF2 $PINS O=FE_OFN287_s32_1 I=s32[1]
XFE_OFC461_s01_0 BUF4 $PINS O=FE_OFN278_s01_0 I=s01[0]
XFE_OFC460_h21_1 BUF2 $PINS O=FE_OFN277_h21_1 I=h21[1]
XFE_OFC459_s12_1 BUF4 $PINS O=FE_OFN276_s12_1 I=s12[1]
XFE_OFC455_s31_1 BUF2 $PINS O=FE_OFN272_s31_1 I=s31[1]
XFE_OFC454_h13_1 BUF2 $PINS O=FE_OFN271_h13_1 I=h13[1]
XFE_OFC451_h21_0 BUF1 $PINS O=FE_OFN268_h21_0 I=h21[0]
XFE_OFC450_s02_1 BUF3 $PINS O=FE_OFN267_s02_1 I=s02[1]
XFE_OFC447_s22_1 BUF2 $PINS O=FE_OFN264_s22_1 I=s22[1]
XFE_OFC446_s23_1 BUF4 $PINS O=FE_OFN263_s23_1 I=s23[1]
XFE_OFC443_s11_0 BUF1 $PINS O=FE_OFN260_s11_0 I=s11[0]
XFE_OFC437_h21_2 BUF2 $PINS O=FE_OFN254_h21_2 I=h21[2]
XFE_OFC429_s11_1 BUF2 $PINS O=FE_OFN248_s11_1 I=s11[1]
XFE_OFC399_h02_0 BUF2 $PINS O=FE_OFN233_h02_0 I=h02[0]
XFE_OFC384_h23_0 BUF6 $PINS O=FE_OFN227_h23_0 I=h23[0]
XFE_OFC357_h23_1 BUF4 $PINS O=FE_OFN217_h23_1 I=h23[1]
XFE_OFC346_h22_0 BUF2 $PINS O=FE_OFN214_h22_0 I=h22[0]
XFE_OFC300_h01_2 BUF2 $PINS O=FE_OFN197_h01_2 I=h01[2]
XFE_OFC295_h11_2 BUF3 $PINS O=FE_OFN195_h11_2 I=h11[2]
XFE_OFC289_h12_2 BUF6 $PINS O=FE_OFN194_h12_2 I=h12[2]
XFE_OFC243_s03_0 BUF3 $PINS O=FE_OFN26_s03_0 I=s03[0]
XFE_OFC222_rom_n_idx_3__0 BUF2 $PINS O=FE_OFN164_rom_n_idx_3__0
+ I=rom_n_idx[3][0]
XFE_OFC217_s13_0 BUF2 $PINS O=FE_OFN28_s13_0 I=s13[0]
XFE_OFC215_h23_3 BUF2 $PINS O=FE_OFN161_h23_3 I=h23[3]
XFE_OFC207_h31_2 INV1S $PINS O=FE_OFN158_h31_2 I=h31[2]
XFE_OFC204_h31_3 INV1S $PINS O=FE_OFN157_h31_3 I=h31[3]
XFE_OFC200_s02_0 BUF4 $PINS O=FE_OFN25_s02_0 I=s02[0]
XFE_OFC198_mac_in_real_12 INV2 $PINS O=FE_OFN155_mac_in_real_12 I=data_in_r[12]
XFE_OFC194_s23_0 BUF2 $PINS O=FE_OFN153_s23_0 I=s23[0]
XFE_OFC191_s21_0 BUF2 $PINS O=FE_OFN152_s21_0 I=s21[0]
XFE_OFC176_mac_in_real_10 INV2 $PINS O=FE_OFN148_mac_in_real_10 I=data_in_r[10]
XFE_OFC168_mac_in_real_9 INV2 $PINS O=FE_OFN143_mac_in_real_9 I=data_in_r[9]
XFE_OFC167_mac_in_real_8 INV2 $PINS O=FE_OFN142_mac_in_real_8 I=data_in_r[8]
XFE_OFC162_mac_in_real_7 INV2 $PINS O=FE_OFN139_mac_in_real_7 I=data_in_r[7]
XFE_OFC157_mac_in_imag_13 INV2 $PINS O=FE_OFN136_mac_in_imag_13 I=data_in_i[13]
XFE_OFC155_mac_in_imag_12 INV2 $PINS O=FE_OFN134_mac_in_imag_12 I=data_in_i[12]
XFE_OFC153_mac_in_real_4 INV6 $PINS O=FE_OFN132_mac_in_real_4 I=data_in_r[4]
XFE_OFC141_mac_in_real_6 INV3 $PINS O=FE_OFN128_mac_in_real_6 I=data_in_r[6]
XFE_OFC131_mac_in_real_2 INV6 $PINS O=FE_OFN122_mac_in_real_2 I=data_in_r[2]
XFE_OFC129_mac_in_imag_8 INV1S $PINS O=FE_OFN19_mac_in_imag_8 I=data_in_i[8]
XFE_OFC124_mac_in_real_11 INV2 $PINS O=FE_OFN119_mac_in_real_11 I=data_in_r[11]
XFE_OFC121_FE_DBTN10_n289 BUF2 $PINS O=FE_OFN33_FE_DBTN10_n289 I=p1
XFE_OFC120_FE_DBTN10_n289 BUF1 $PINS O=FE_OFN34_FE_DBTN10_n289 I=p1
XFE_OFC118_mac_in_imag_1 INV8 $PINS O=FE_OFN115_mac_in_imag_1 I=data_in_i[1]
XFE_OFC113_mac_in_imag_11 INV2 $PINS O=FE_OFN113_mac_in_imag_11 I=data_in_i[11]
XFE_OFC112_mac_in_imag_10 INV2 $PINS O=FE_OFN112_mac_in_imag_10 I=data_in_i[10]
XFE_OFC76_rom_n_idx_3__2 BUF2 $PINS O=FE_OFN76_rom_n_idx_3__2 I=rom_n_idx[3][2]
XFE_OFC39_rom_n_idx_3__3 BUF2 $PINS O=FE_OFN39_rom_n_idx_3__3 I=rom_n_idx[3][3]
XFE_OFC38_rom_k_idx_3__2 BUF2CK $PINS O=FE_OFN38_rom_k_idx_3__2
+ I=rom_k_idx[3][2]
XFE_OFC37_rom_k_idx_3__3 BUF2CK $PINS O=FE_OFN37_rom_k_idx_3__3
+ I=rom_k_idx[3][3]
XFE_OFC36_rom_k_idx_3__4 BUF2CK $PINS O=FE_OFN36_rom_k_idx_3__4
+ I=rom_k_idx[3][4]
XFE_OFC35_rom_n_idx_3__4 BUF1 $PINS O=FE_OFN35_rom_n_idx_3__4 I=rom_n_idx[3][4]
XFE_OFC13_FE_OFN4_i_rst_n BUF3 $PINS O=FE_OFN13_FE_OFN4_i_rst_n
+ I=FE_OFN7_i_rst_n
XU20 ND2 $PINS O=rom_n_idx[3][0] I1=stage_sel_BAR I2=n_cnt[0]
XU21 ND2 $PINS O=rom_k_idx[3][1] I1=FE_OFN33_FE_DBTN10_n289 I2=n_cnt[1]
XU19 INV8 $PINS O=n3 I=data_in_i[4]
XU31 MOAI1S $PINS O=rom_n_idx[3][2] A1=g_cnt[0] A2=stage_sel_BAR
+ B1=stage_sel_BAR B2=n_cnt[2]
XU32 MOAI1S $PINS O=rom_n_idx[3][3] A1=g_cnt[1] A2=stage_sel_BAR
+ B1=stage_sel_BAR B2=n_cnt[3]
XU69 NR2 $PINS O=rom_n_idx[1][1] I1=n_cnt[1] I2=p1
XU70 MOAI1S $PINS O=rom_n_idx[3][4] A1=stage_sel_BAR A2=g_cnt[2]
+ B1=stage_sel_BAR B2=p2
XU80 ND2S $PINS O=rom_n_idx[3][1] I1=stage_sel_BAR I2=n_cnt[1]
XU81 ND2P $PINS O=rom_k_idx[3][0] I1=FE_OFN55_FE_DBTN10_n289 I2=n_cnt[0]
XU87 NR2 $PINS O=rom_n_idx[2][0] I1=n_cnt[0] I2=p1
XU88 NR2P $PINS O=rom_k_idx[1][1] I1=n_cnt[1] I2=stage_sel_BAR
XU89 NR2P $PINS O=rom_k_idx[2][0] I1=n_cnt[0] I2=stage_sel_BAR
XU96 MOAI1S $PINS O=rom_k_idx[3][4] A1=FE_OFN57_FE_DBTN10_n289 A2=g_cnt[2]
+ B1=n_cnt[4] B2=FE_OFN57_FE_DBTN10_n289
XU98 MOAI1S $PINS O=rom_k_idx[3][3] A1=FE_OFN57_FE_DBTN10_n289 A2=g_cnt[1]
+ B1=n_cnt[3] B2=FE_OFN57_FE_DBTN10_n289
XU99 MOAI1S $PINS O=rom_k_idx[3][2] A1=FE_OFN57_FE_DBTN10_n289 A2=g_cnt[0]
+ B1=n_cnt[2] B2=FE_OFN57_FE_DBTN10_n289
Xrom0 ROM_Wrapper_Even_1 $PINS rst_n=rst_n en=en
+ n_in[4]=FE_OFN35_rom_n_idx_3__4 n_in[3]=FE_OFN39_rom_n_idx_3__3
+ n_in[2]=FE_OFN76_rom_n_idx_3__2 n_in[1]=rom_n_idx[1][1] n_in[0]=rom_n_idx[2][0]
+ k_idx[4]=FE_OFN36_rom_k_idx_3__4 k_idx[3]=FE_OFN37_rom_k_idx_3__3
+ k_idx[2]=FE_OFN38_rom_k_idx_3__2 k_idx[1]=rom_k_idx[1][1]
+ k_idx[0]=rom_k_idx[2][0] reg_sign1[1]=s01[1] reg_sign1[0]=s01[0]
+ reg_sign2[1]=s02[1] reg_sign2[0]=s02[0] reg_sign3[1]=s03[1] reg_sign3[0]=s03[0]
+ reg_shift1[3]=h01[3] reg_shift1[2]=h01[2] reg_shift1[1]=h01[1]
+ reg_shift1[0]=h01[0] reg_shift2[3]=h02[3] reg_shift2[2]=h02[2]
+ reg_shift2[1]=h02[1] reg_shift2[0]=h02[0] reg_shift3[3]=h03[3]
+ reg_shift3[2]=h03[2] reg_shift3[1]=h03[1] reg_shift3[0]=h03[0]
+ i_rst_n=FE_OFN13_FE_OFN4_i_rst_n clk=CTS_27
Xrom1 ROM_Wrapper_Odd_1 $PINS rst_n=rst_n en=en n_in[4]=FE_OFN35_rom_n_idx_3__4
+ n_in[3]=FE_OFN39_rom_n_idx_3__3 n_in[2]=FE_OFN76_rom_n_idx_3__2
+ n_in[1]=rom_n_idx[1][1] n_in[0]=FE_OFN164_rom_n_idx_3__0
+ k_idx[4]=FE_OFN36_rom_k_idx_3__4 k_idx[3]=FE_OFN37_rom_k_idx_3__3
+ k_idx[2]=FE_OFN38_rom_k_idx_3__2 k_idx[1]=rom_k_idx[1][1]
+ k_idx[0]=rom_k_idx[3][0] reg_sign1[1]=s11[1] reg_sign1[0]=s11[0]
+ reg_sign2[1]=s12[1] reg_sign2[0]=s12[0] reg_sign3[1]=s13[1] reg_sign3[0]=s13[0]
+ reg_shift1[3]=h11[3] reg_shift1[2]=h11[2] reg_shift1[1]=h11[1]
+ reg_shift1[0]=h11[0] reg_shift2[3]=h12[3] reg_shift2[2]=h12[2]
+ reg_shift2[1]=h12[1] reg_shift2[0]=h12[0] reg_shift3[3]=h13[3]
+ reg_shift3[2]=h13[2] reg_shift3[1]=h13[1] reg_shift3[0]=h13[0]
+ i_rst_n=FE_OFN13_FE_OFN4_i_rst_n FE_OFN13_i_rst_n=FE_OFN9_i_rst_n
+ clk=clk_clone11
Xrom2 ROM_Wrapper_Even_0 $PINS rst_n=rst_n en=en
+ n_in[4]=FE_OFN35_rom_n_idx_3__4 n_in[3]=FE_OFN39_rom_n_idx_3__3
+ n_in[2]=FE_OFN76_rom_n_idx_3__2 n_in[1]=rom_n_idx[3][1] n_in[0]=rom_n_idx[2][0]
+ k_idx[4]=FE_OFN36_rom_k_idx_3__4 k_idx[3]=FE_OFN37_rom_k_idx_3__3
+ k_idx[2]=FE_OFN38_rom_k_idx_3__2 k_idx[1]=rom_k_idx[3][1]
+ k_idx[0]=rom_k_idx[2][0] reg_sign1[1]=s21[1] reg_sign1[0]=s21[0]
+ reg_sign2[1]=s22[1] reg_sign2[0]=s22[0] reg_sign3[1]=s23[1] reg_sign3[0]=s23[0]
+ reg_shift1[3]=h21[3] reg_shift1[2]=h21[2] reg_shift1[1]=h21[1]
+ reg_shift1[0]=h21[0] reg_shift2[3]=h22[3] reg_shift2[2]=h22[2]
+ reg_shift2[1]=h22[1] reg_shift2[0]=h22[0] reg_shift3[3]=h23[3]
+ reg_shift3[2]=h23[2] reg_shift3[1]=h23[1] reg_shift3[0]=h23[0]
+ i_rst_n=FE_OFN7_i_rst_n clk=CTS_27
Xrom3 ROM_Wrapper_Odd_0 $PINS rst_n=rst_n en=en n_in[4]=FE_OFN35_rom_n_idx_3__4
+ n_in[3]=FE_OFN39_rom_n_idx_3__3 n_in[2]=FE_OFN76_rom_n_idx_3__2
+ n_in[1]=rom_n_idx[3][1] n_in[0]=FE_OFN164_rom_n_idx_3__0
+ k_idx[4]=FE_OFN36_rom_k_idx_3__4 k_idx[3]=FE_OFN37_rom_k_idx_3__3
+ k_idx[2]=FE_OFN38_rom_k_idx_3__2 k_idx[1]=rom_k_idx[3][1]
+ k_idx[0]=rom_k_idx[3][0] reg_sign1[1]=s31[1] reg_sign1[0]=s31[0]
+ reg_sign2[1]=s32[1] reg_sign2[0]=s32[0] reg_sign3[1]=s33[1] reg_sign3[0]=s33[0]
+ reg_shift1[3]=h31[3] reg_shift1[2]=h31[2] reg_shift1[1]=h31[1]
+ reg_shift1[0]=h31[0] reg_shift2[3]=h32[3] reg_shift2[2]=h32[2]
+ reg_shift2[1]=h32[1] reg_shift2[0]=h32[0] reg_shift3[3]=h33[3]
+ reg_shift3[2]=h33[2] reg_shift3[1]=h33[1] reg_shift3[0]=h33[0]
+ i_rst_n=FE_OFN3_i_rst_n clk=clk_clone5
Xpe0_r PE_Shift_Add_7 $PINS rst_n=rst_n en=en clear=FE_OFN319_n
+ calc_done=pe_done stage_sel=p1 x_in[16]=data_in_r[16] x_in[15]=data_in_r[15]
+ x_in[14]=data_in_r[14] x_in[13]=data_in_r[13] x_in[12]=FE_OFN155_mac_in_real_12
+ x_in[11]=FE_OFN119_mac_in_real_11 x_in[10]=FE_OFN148_mac_in_real_10
+ x_in[9]=FE_OFN143_mac_in_real_9 x_in[8]=FE_OFN142_mac_in_real_8
+ x_in[7]=FE_OFN139_mac_in_real_7 x_in[6]=FE_OFN128_mac_in_real_6
+ x_in[5]=FE_OFN144_mac_in_real_5 x_in[4]=FE_OFN132_mac_in_real_4
+ x_in[3]=data_in_r[3] x_in[2]=FE_OFN122_mac_in_real_2
+ x_in[1]=FE_OFN121_mac_in_real_1 x_in[0]=FE_OFN117_mac_in_real_0 sign1[1]=s01[1]
+ sign1[0]=FE_OFN278_s01_0 sign2[1]=FE_OFN267_s02_1 sign2[0]=FE_OFN25_s02_0
+ sign3[1]=s03[1] sign3[0]=s03[0] shf1[3]=h01[3] shf1[2]=FE_OFN197_h01_2
+ shf1[1]=h01[1] shf1[0]=h01[0] shf2[3]=h02[3] shf2[2]=h02[2] shf2[1]=h02[1]
+ shf2[0]=FE_OFN233_h02_0 shf3[3]=h03[3] shf3[2]=h03[2] shf3[1]=h03[1]
+ shf3[0]=h03[0] y_out[16]=y_out_0_r[16] y_out[15]=y_out_0_r[15]
+ y_out[14]=y_out_0_r[14] y_out[13]=y_out_0_r[13] y_out[12]=y_out_0_r[12]
+ y_out[11]=y_out_0_r[11] y_out[10]=y_out_0_r[10] y_out[9]=y_out_0_r[9]
+ y_out[8]=y_out_0_r[8] y_out[7]=y_out_0_r[7] y_out[6]=y_out_0_r[6]
+ y_out[5]=y_out_0_r[5] y_out[4]=y_out_0_r[4] y_out[3]=y_out_0_r[3]
+ y_out[2]=y_out_0_r[2] y_out[1]=y_out_0_r[1] y_out[0]=y_out_0_r[0]
+ i_rst_n=FE_OFN35_n FE_OFN12_i_rst_n=FE_OFN9_i_rst_n
+ FE_OFN8_i_rst_n=FE_OFN13_FE_OFN4_i_rst_n
+ FE_OFN39_FE_DBTN10_n289=FE_OFN33_FE_DBTN10_n289 FE_OFN43_s03_0=FE_OFN26_s03_0
+ FE_OFN74_n=FE_OFN323_n FE_OFN70_n=FE_OFN321_n FE_OFN83_n=FE_OFN358_n
+ FE_OFN116_mac_in_real_3=FE_OFN116_mac_in_real_3 clk=CTS_28
+ clk_clone2=clk_clone8 clk_clone1=clk_clone3
Xpe0_i PE_Shift_Add_6 $PINS rst_n=rst_n en=en clear=pe_clear calc_done=pe_done
+ stage_sel=FE_OFN33_FE_DBTN10_n289 x_in[16]=data_in_i[16] x_in[15]=data_in_i[15]
+ x_in[14]=data_in_i[14] x_in[13]=FE_OFN136_mac_in_imag_13
+ x_in[12]=FE_OFN134_mac_in_imag_12 x_in[11]=FE_OFN113_mac_in_imag_11
+ x_in[10]=FE_OFN112_mac_in_imag_10 x_in[9]=FE_OFN343_n x_in[8]=FE_OFN369_n
+ x_in[7]=FE_OFN345_mac_in_imag_7 x_in[6]=FE_OFN307_mac_in_imag_6
+ x_in[5]=FE_OFN22_mac_in_imag_5 x_in[4]=n3 x_in[3]=FE_OFN120_mac_in_imag_3
+ x_in[2]=FE_OFN114_mac_in_imag_2 x_in[1]=FE_OFN115_mac_in_imag_1
+ x_in[0]=FE_OFN346_mac_in_imag_0 sign1[1]=s01[1] sign1[0]=FE_OFN278_s01_0
+ sign2[1]=FE_OFN267_s02_1 sign2[0]=FE_OFN25_s02_0 sign3[1]=s03[1]
+ sign3[0]=FE_OFN26_s03_0 shf1[3]=h01[3] shf1[2]=FE_OFN197_h01_2 shf1[1]=h01[1]
+ shf1[0]=h01[0] shf2[3]=h02[3] shf2[2]=h02[2] shf2[1]=h02[1]
+ shf2[0]=FE_OFN233_h02_0 shf3[3]=h03[3] shf3[2]=h03[2] shf3[1]=h03[1]
+ shf3[0]=h03[0] y_out[16]=y_out_0_i[16] y_out[15]=y_out_0_i[15]
+ y_out[14]=y_out_0_i[14] y_out[13]=y_out_0_i[13] y_out[12]=y_out_0_i[12]
+ y_out[11]=y_out_0_i[11] y_out[10]=y_out_0_i[10] y_out[9]=y_out_0_i[9]
+ y_out[8]=y_out_0_i[8] y_out[7]=y_out_0_i[7] y_out[6]=y_out_0_i[6]
+ y_out[5]=y_out_0_i[5] y_out[4]=y_out_0_i[4] y_out[3]=y_out_0_i[3]
+ y_out[2]=y_out_0_i[2] y_out[1]=y_out_0_i[1] y_out[0]=y_out_0_i[0]
+ i_rst_n=FE_OFN7_i_rst_n FE_OFN29_FE_OFN4_i_rst_n=FE_OFN13_FE_OFN4_i_rst_n
+ FE_OFN45_h02_3=FE_OFN191_h02_3 FE_OFN52_h01_1=h01[1] FE_OFN77_n=FE_OFN325_n
+ FE_OFN68_n=FE_OFN319_n FE_OFN84_n=FE_OFN358_n clk_clone1=CTS_26
+ clk_clone2=clk_clone10 clk=CTS_28
Xpe1_r PE_Shift_Add_5 $PINS rst_n=rst_n en=en clear=pe_clear calc_done=pe_done
+ stage_sel=p1 x_in[16]=data_in_r[16] x_in[15]=data_in_r[15]
+ x_in[14]=data_in_r[14] x_in[13]=data_in_r[13] x_in[12]=FE_OFN155_mac_in_real_12
+ x_in[11]=FE_OFN119_mac_in_real_11 x_in[10]=FE_OFN148_mac_in_real_10
+ x_in[9]=FE_OFN143_mac_in_real_9 x_in[8]=FE_OFN142_mac_in_real_8
+ x_in[7]=FE_OFN139_mac_in_real_7 x_in[6]=FE_OFN128_mac_in_real_6
+ x_in[5]=FE_OFN144_mac_in_real_5 x_in[4]=data_in_r[4] x_in[3]=data_in_r[3]
+ x_in[2]=FE_OFN122_mac_in_real_2 x_in[1]=FE_OFN121_mac_in_real_1
+ x_in[0]=FE_OFN117_mac_in_real_0 sign1[1]=FE_OFN248_s11_1
+ sign1[0]=FE_OFN260_s11_0 sign2[1]=FE_OFN276_s12_1 sign2[0]=s12[0]
+ sign3[1]=FE_OFN282_s13_1 sign3[0]=FE_OFN28_s13_0 shf1[3]=h11[3]
+ shf1[2]=FE_OFN195_h11_2 shf1[1]=FE_OFN289_h11_1 shf1[0]=FE_OFN300_h11_0
+ shf2[3]=h12[3] shf2[2]=FE_OFN194_h12_2 shf2[1]=h12[1] shf2[0]=h12[0]
+ shf3[3]=FE_OFN192_h13_3 shf3[2]=FE_OFN259_h13_2 shf3[1]=FE_OFN271_h13_1
+ shf3[0]=h13[0] y_out[16]=y_out_1_r[16] y_out[15]=y_out_1_r[15]
+ y_out[14]=y_out_1_r[14] y_out[13]=y_out_1_r[13] y_out[12]=y_out_1_r[12]
+ y_out[11]=y_out_1_r[11] y_out[10]=y_out_1_r[10] y_out[9]=y_out_1_r[9]
+ y_out[8]=y_out_1_r[8] y_out[7]=y_out_1_r[7] y_out[6]=y_out_1_r[6]
+ y_out[5]=y_out_1_r[5] y_out[4]=y_out_1_r[4] y_out[3]=y_out_1_r[3]
+ y_out[2]=y_out_1_r[2] y_out[1]=y_out_1_r[1] y_out[0]=y_out_1_r[0]
+ i_rst_n=FE_OFN34_n FE_OFN28_i_rst_n=FE_OFN27_i_rst_n
+ FE_OFN16_i_rst_n=FE_OFN15_i_rst_n FE_OFN10_i_rst_n=FE_OFN9_i_rst_n
+ FE_OFN36_n=FE_OFN35_n FE_OFN38_FE_DBTN10_n289=FE_OFN33_FE_DBTN10_n289
+ FE_OFN56_FE_DBTN10_n289=FE_OFN55_FE_DBTN10_n289 FE_OFN75_n=FE_OFN323_n
+ FE_OFN71_n=FE_OFN321_n FE_OFN69_n=FE_OFN319_n
+ FE_OFN132_mac_in_real_4=FE_OFN132_mac_in_real_4 clk_clone2=clk_clone8
+ clk_clone1=clk_clone3 clk=clk_clone2
Xpe1_i PE_Shift_Add_4 $PINS rst_n=rst_n en=en clear=FE_OFN319_n
+ calc_done=pe_done stage_sel=p1 x_in[16]=data_in_i[16] x_in[15]=data_in_i[15]
+ x_in[14]=data_in_i[14] x_in[13]=FE_OFN136_mac_in_imag_13
+ x_in[12]=FE_OFN134_mac_in_imag_12 x_in[11]=FE_OFN113_mac_in_imag_11
+ x_in[10]=FE_OFN112_mac_in_imag_10 x_in[9]=FE_OFN343_n x_in[8]=FE_OFN369_n
+ x_in[7]=FE_OFN345_mac_in_imag_7 x_in[6]=FE_OFN307_mac_in_imag_6
+ x_in[5]=FE_OFN22_mac_in_imag_5 x_in[4]=n3 x_in[3]=FE_OFN120_mac_in_imag_3
+ x_in[2]=FE_OFN114_mac_in_imag_2 x_in[1]=FE_OFN115_mac_in_imag_1
+ x_in[0]=data_in_i[0] sign1[1]=s11[1] sign1[0]=FE_OFN260_s11_0 sign2[1]=s12[1]
+ sign2[0]=s12[0] sign3[1]=s13[1] sign3[0]=FE_OFN28_s13_0 shf1[3]=h11[3]
+ shf1[2]=FE_OFN195_h11_2 shf1[1]=FE_OFN289_h11_1 shf1[0]=FE_OFN300_h11_0
+ shf2[3]=h12[3] shf2[2]=FE_OFN194_h12_2 shf2[1]=h12[1] shf2[0]=h12[0]
+ shf3[3]=h13[3] shf3[2]=h13[2] shf3[1]=h13[1] shf3[0]=h13[0]
+ y_out[16]=y_out_1_i[16] y_out[15]=y_out_1_i[15] y_out[14]=y_out_1_i[14]
+ y_out[13]=y_out_1_i[13] y_out[12]=y_out_1_i[12] y_out[11]=y_out_1_i[11]
+ y_out[10]=y_out_1_i[10] y_out[9]=y_out_1_i[9] y_out[8]=y_out_1_i[8]
+ y_out[7]=y_out_1_i[7] y_out[6]=y_out_1_i[6] y_out[5]=y_out_1_i[5]
+ y_out[4]=y_out_1_i[4] y_out[3]=y_out_1_i[3] y_out[2]=y_out_1_i[2]
+ y_out[1]=y_out_1_i[1] y_out[0]=y_out_1_i[0] i_rst_n=FE_OFN13_FE_OFN4_i_rst_n
+ FE_OFN11_i_rst_n=FE_OFN9_i_rst_n FE_OFN41_mac_in_imag_3=data_in_i[3]
+ FE_OFN46_h13_3=FE_OFN192_h13_3 FE_OFN50_h13_0=h13[0]
+ FE_OFN54_s11_1=FE_OFN248_s11_1 FE_OFN59_h13_2=FE_OFN259_h13_2
+ FE_OFN62_h13_1=FE_OFN271_h13_1 FE_OFN63_s12_1=FE_OFN276_s12_1
+ FE_OFN65_s13_1=FE_OFN282_s13_1 FE_OFN76_n=FE_OFN323_n
+ FE_OFN346_mac_in_imag_0=FE_OFN346_mac_in_imag_0 clk_clone2=clk_clone8
+ clk_clone1=CTS_27 clk=CTS_28
Xpe2_r PE_Shift_Add_3 $PINS rst_n=rst_n en=en clear=FE_OFN319_n
+ calc_done=pe_done stage_sel=FE_OFN33_FE_DBTN10_n289 x_in[16]=data_in_r[16]
+ x_in[15]=data_in_r[15] x_in[14]=data_in_r[14] x_in[13]=data_in_r[13]
+ x_in[12]=FE_OFN155_mac_in_real_12 x_in[11]=FE_OFN119_mac_in_real_11
+ x_in[10]=FE_OFN148_mac_in_real_10 x_in[9]=FE_OFN143_mac_in_real_9
+ x_in[8]=FE_OFN142_mac_in_real_8 x_in[7]=FE_OFN139_mac_in_real_7
+ x_in[6]=FE_OFN128_mac_in_real_6 x_in[5]=FE_OFN144_mac_in_real_5
+ x_in[4]=FE_OFN132_mac_in_real_4 x_in[3]=FE_OFN116_mac_in_real_3
+ x_in[2]=FE_OFN122_mac_in_real_2 x_in[1]=FE_OFN121_mac_in_real_1
+ x_in[0]=FE_OFN117_mac_in_real_0 sign1[1]=FE_OFN265_s21_1
+ sign1[0]=FE_OFN152_s21_0 sign2[1]=FE_OFN264_s22_1 sign2[0]=FE_OFN131_s22_0
+ sign3[1]=FE_OFN263_s23_1 sign3[0]=FE_OFN153_s23_0 shf1[3]=h21[3]
+ shf1[2]=FE_OFN254_h21_2 shf1[1]=FE_OFN277_h21_1 shf1[0]=FE_OFN268_h21_0
+ shf2[3]=FE_OFN198_h22_3 shf2[2]=FE_OFN196_h22_2 shf2[1]=h22[1]
+ shf2[0]=FE_OFN214_h22_0 shf3[3]=FE_OFN161_h23_3 shf3[2]=FE_OFN193_h23_2
+ shf3[1]=FE_OFN217_h23_1 shf3[0]=FE_OFN227_h23_0 y_out[16]=y_out_2_r[16]
+ y_out[15]=y_out_2_r[15] y_out[14]=y_out_2_r[14] y_out[13]=y_out_2_r[13]
+ y_out[12]=y_out_2_r[12] y_out[11]=y_out_2_r[11] y_out[10]=y_out_2_r[10]
+ y_out[9]=y_out_2_r[9] y_out[8]=y_out_2_r[8] y_out[7]=y_out_2_r[7]
+ y_out[6]=y_out_2_r[6] y_out[5]=y_out_2_r[5] y_out[4]=y_out_2_r[4]
+ y_out[3]=y_out_2_r[3] y_out[2]=y_out_2_r[2] y_out[1]=y_out_2_r[1]
+ y_out[0]=y_out_2_r[0] i_rst_n=FE_OFN3_i_rst_n FE_OFN22_i_rst_n=FE_OFN21_i_rst_n
+ FE_OFN79_n=FE_OFN326_n FE_OFN81_n=FE_OFN348_n clk_clone2=clk_clone10
+ clk_clone1=CTS_25 clk=clk_clone6
Xpe2_i PE_Shift_Add_2 $PINS rst_n=rst_n en=en clear=FE_OFN319_n
+ calc_done=pe_done stage_sel=FE_OFN33_FE_DBTN10_n289 x_in[16]=data_in_i[16]
+ x_in[15]=data_in_i[15] x_in[14]=data_in_i[14] x_in[13]=FE_OFN136_mac_in_imag_13
+ x_in[12]=FE_OFN134_mac_in_imag_12 x_in[11]=FE_OFN113_mac_in_imag_11
+ x_in[10]=FE_OFN112_mac_in_imag_10 x_in[9]=FE_OFN343_n x_in[8]=FE_OFN369_n
+ x_in[7]=FE_OFN345_mac_in_imag_7 x_in[6]=FE_OFN307_mac_in_imag_6
+ x_in[5]=FE_OFN22_mac_in_imag_5 x_in[4]=n3 x_in[3]=FE_OFN120_mac_in_imag_3
+ x_in[2]=FE_OFN114_mac_in_imag_2 x_in[1]=FE_OFN115_mac_in_imag_1
+ x_in[0]=FE_OFN346_mac_in_imag_0 sign1[1]=FE_OFN265_s21_1
+ sign1[0]=FE_OFN152_s21_0 sign2[1]=s22[1] sign2[0]=FE_OFN131_s22_0
+ sign3[1]=FE_OFN263_s23_1 sign3[0]=FE_OFN153_s23_0 shf1[3]=h21[3] shf1[2]=h21[2]
+ shf1[1]=h21[1] shf1[0]=h21[0] shf2[3]=FE_OFN198_h22_3 shf2[2]=h22[2]
+ shf2[1]=h22[1] shf2[0]=FE_OFN214_h22_0 shf3[3]=h23[3] shf3[2]=h23[2]
+ shf3[1]=h23[1] shf3[0]=h23[0] y_out[16]=y_out_2_i[16] y_out[15]=y_out_2_i[15]
+ y_out[14]=y_out_2_i[14] y_out[13]=y_out_2_i[13] y_out[12]=y_out_2_i[12]
+ y_out[11]=y_out_2_i[11] y_out[10]=y_out_2_i[10] y_out[9]=y_out_2_i[9]
+ y_out[8]=y_out_2_i[8] y_out[7]=y_out_2_i[7] y_out[6]=y_out_2_i[6]
+ y_out[5]=y_out_2_i[5] y_out[4]=y_out_2_i[4] y_out[3]=y_out_2_i[3]
+ y_out[2]=y_out_2_i[2] y_out[1]=y_out_2_i[1] y_out[0]=y_out_2_i[0]
+ i_rst_n=FE_OFN7_i_rst_n FE_OFN23_i_rst_n=FE_OFN21_i_rst_n
+ FE_OFN42_h23_3=FE_OFN161_h23_3 FE_OFN44_h21_3=h21[3]
+ FE_OFN47_h23_2=FE_OFN193_h23_2 FE_OFN48_h22_2=FE_OFN196_h22_2
+ FE_OFN49_h23_1=FE_OFN217_h23_1 FE_OFN51_h22_1=h22[1]
+ FE_OFN53_h23_0=FE_OFN227_h23_0 FE_OFN58_h21_2=FE_OFN254_h21_2
+ FE_OFN60_s22_1=FE_OFN264_s22_1 FE_OFN61_h21_0=FE_OFN268_h21_0
+ FE_OFN64_h21_1=FE_OFN277_h21_1 FE_OFN78_n=FE_OFN325_n FE_OFN82_n=FE_OFN348_n
+ clk_clone2=CTS_25 clk_clone1=CTS_26 clk=CTS_27
Xpe3_r PE_Shift_Add_1 $PINS rst_n=rst_n en=en clear=FE_OFN319_n
+ calc_done=pe_done stage_sel=FE_OFN34_FE_DBTN10_n289 x_in[16]=data_in_r[16]
+ x_in[15]=data_in_r[15] x_in[14]=data_in_r[14] x_in[13]=data_in_r[13]
+ x_in[12]=FE_OFN155_mac_in_real_12 x_in[11]=FE_OFN119_mac_in_real_11
+ x_in[10]=FE_OFN148_mac_in_real_10 x_in[9]=FE_OFN143_mac_in_real_9
+ x_in[8]=FE_OFN142_mac_in_real_8 x_in[7]=FE_OFN139_mac_in_real_7
+ x_in[6]=FE_OFN128_mac_in_real_6 x_in[5]=FE_OFN144_mac_in_real_5
+ x_in[4]=FE_OFN132_mac_in_real_4 x_in[3]=FE_OFN116_mac_in_real_3
+ x_in[2]=FE_OFN122_mac_in_real_2 x_in[1]=FE_OFN121_mac_in_real_1
+ x_in[0]=FE_OFN117_mac_in_real_0 sign1[1]=FE_OFN272_s31_1 sign1[0]=s31[0]
+ sign2[1]=s32[1] sign2[0]=s32[0] sign3[1]=FE_OFN318_s33_1 sign3[0]=s33[0]
+ shf1[3]=FE_OFN157_h31_3 shf1[2]=FE_OFN158_h31_2 shf1[1]=h31[1] shf1[0]=h31[0]
+ shf2[3]=h32[3] shf2[2]=h32[2] shf2[1]=h32[1] shf2[0]=h32[0] shf3[3]=h33[3]
+ shf3[2]=h33[2] shf3[1]=h33[1] shf3[0]=h33[0] y_out[16]=y_out_3_r[16]
+ y_out[15]=y_out_3_r[15] y_out[14]=y_out_3_r[14] y_out[13]=y_out_3_r[13]
+ y_out[12]=y_out_3_r[12] y_out[11]=y_out_3_r[11] y_out[10]=y_out_3_r[10]
+ y_out[9]=y_out_3_r[9] y_out[8]=y_out_3_r[8] y_out[7]=y_out_3_r[7]
+ y_out[6]=y_out_3_r[6] y_out[5]=y_out_3_r[5] y_out[4]=y_out_3_r[4]
+ y_out[3]=y_out_3_r[3] y_out[2]=y_out_3_r[2] y_out[1]=y_out_3_r[1]
+ y_out[0]=y_out_3_r[0] i_rst_n=i_rst_n FE_OFN20_i_rst_n=FE_OFN19_i_rst_n
+ FE_OFN4_i_rst_n=FE_OFN3_i_rst_n FE_OFN1_i_rst_n=FE_OFN0_i_rst_n
+ FE_OFN31_n=FE_OFN30_n FE_OFN67_s32_1=FE_OFN287_s32_1 FE_OFN72_n=FE_OFN322_n
+ clk_clone1=clk_clone5 clk=CTS_29
Xpe3_i PE_Shift_Add_0 $PINS rst_n=rst_n en=en clear=FE_OFN319_n
+ calc_done=pe_done stage_sel=FE_OFN33_FE_DBTN10_n289 x_in[16]=data_in_i[16]
+ x_in[15]=data_in_i[15] x_in[14]=data_in_i[14] x_in[13]=FE_OFN136_mac_in_imag_13
+ x_in[12]=FE_OFN134_mac_in_imag_12 x_in[11]=FE_OFN113_mac_in_imag_11
+ x_in[10]=FE_OFN112_mac_in_imag_10 x_in[9]=FE_OFN343_n x_in[8]=FE_OFN369_n
+ x_in[7]=FE_OFN345_mac_in_imag_7 x_in[6]=FE_OFN307_mac_in_imag_6
+ x_in[5]=FE_OFN22_mac_in_imag_5 x_in[4]=n3 x_in[3]=data_in_i[3]
+ x_in[2]=FE_OFN114_mac_in_imag_2 x_in[1]=FE_OFN115_mac_in_imag_1
+ x_in[0]=data_in_i[0] sign1[1]=FE_OFN272_s31_1 sign1[0]=s31[0] sign2[1]=s32[1]
+ sign2[0]=s32[0] sign3[1]=FE_OFN318_s33_1 sign3[0]=s33[0]
+ shf1[3]=FE_OFN157_h31_3 shf1[2]=FE_OFN158_h31_2 shf1[1]=h31[1] shf1[0]=h31[0]
+ shf2[3]=h32[3] shf2[2]=h32[2] shf2[1]=h32[1] shf2[0]=h32[0] shf3[3]=h33[3]
+ shf3[2]=h33[2] shf3[1]=h33[1] shf3[0]=h33[0] y_out[16]=y_out_3_i[16]
+ y_out[15]=y_out_3_i[15] y_out[14]=y_out_3_i[14] y_out[13]=y_out_3_i[13]
+ y_out[12]=y_out_3_i[12] y_out[11]=y_out_3_i[11] y_out[10]=y_out_3_i[10]
+ y_out[9]=y_out_3_i[9] y_out[8]=y_out_3_i[8] y_out[7]=y_out_3_i[7]
+ y_out[6]=y_out_3_i[6] y_out[5]=y_out_3_i[5] y_out[4]=y_out_3_i[4]
+ y_out[3]=y_out_3_i[3] y_out[2]=y_out_3_i[2] y_out[1]=y_out_3_i[1]
+ y_out[0]=y_out_3_i[0] i_rst_n=i_rst_n FE_OFN5_i_rst_n=FE_OFN3_i_rst_n
+ FE_OFN40_FE_DBTN10_n289=FE_OFN34_FE_DBTN10_n289 FE_OFN66_s32_1=FE_OFN287_s32_1
+ FE_OFN80_n=FE_OFN326_n FE_OFN73_n=FE_OFN322_n
+ FE_OFN120_mac_in_imag_3=FE_OFN120_mac_in_imag_3
+ FE_OFN346_mac_in_imag_0=FE_OFN346_mac_in_imag_0 clk_clone3=clk_clone10
+ clk_clone2=clk_clone9 clk_clone1=CTS_25 clk=CTS_29
.ENDS

.SUBCKT SNPS_CLOCK_GATE_HIGH_RegFileDual_DATA_WIDTH34_0 EN ENCLK CLK
*.CONNECT net1870 EN
XFE_PHC901_net1873 DELC $PINS O=net1873 I=FE_PHN901_net1873
Xlatch QDBHN $PINS Q=FE_PHN901_net1873 D=net1870 CKB=CLK
Xmain_gate AN2T $PINS O=ENCLK I1=net1873 I2=CLK
.ENDS

.SUBCKT SNPS_CLOCK_GATE_HIGH_RegFileDual_DATA_WIDTH34_63 EN ENCLK CLK
*.CONNECT net1870 EN
XFE_PHC876_net1873 DELC $PINS O=net1873 I=FE_PHN876_net1873
Xlatch QDBHN $PINS Q=FE_PHN876_net1873 D=net1870 CKB=CLK
Xmain_gate AN2T $PINS O=ENCLK I1=net1873 I2=CLK
.ENDS

.SUBCKT SNPS_CLOCK_GATE_HIGH_RegFileDual_DATA_WIDTH34_62 EN ENCLK CLK
*.CONNECT net1870 EN
XFE_PHC861_net1873 DELC $PINS O=FE_PHN861_net1873 I=net1873
Xlatch QDBHN $PINS Q=net1873 D=net1870 CKB=CLK
Xmain_gate AN2T $PINS O=ENCLK I1=FE_PHN861_net1873 I2=CLK
.ENDS

.SUBCKT SNPS_CLOCK_GATE_HIGH_RegFileDual_DATA_WIDTH34_61 EN ENCLK CLK
*.CONNECT net1870 EN
XFE_PHC896_net1873 DELC $PINS O=FE_PHN896_net1873 I=net1873
Xlatch QDBHN $PINS Q=net1873 D=net1870 CKB=CLK
Xmain_gate AN2T $PINS O=ENCLK I1=FE_PHN896_net1873 I2=CLK
.ENDS

.SUBCKT SNPS_CLOCK_GATE_HIGH_RegFileDual_DATA_WIDTH34_60 EN ENCLK CLK
*.CONNECT net1870 EN
XFE_PHC873_net1873 DELC $PINS O=FE_PHN873_net1873 I=net1873
Xlatch QDBHN $PINS Q=net1873 D=net1870 CKB=CLK
Xmain_gate AN2T $PINS O=ENCLK I1=FE_PHN873_net1873 I2=CLK
.ENDS

.SUBCKT SNPS_CLOCK_GATE_HIGH_RegFileDual_DATA_WIDTH34_59 EN ENCLK CLK
*.CONNECT net1870 EN
XFE_PHC895_net1873 DELC $PINS O=FE_PHN895_net1873 I=net1873
Xlatch QDBHN $PINS Q=net1873 D=net1870 CKB=CLK
Xmain_gate AN2T $PINS O=ENCLK I1=FE_PHN895_net1873 I2=CLK
.ENDS

.SUBCKT SNPS_CLOCK_GATE_HIGH_RegFileDual_DATA_WIDTH34_58 EN ENCLK CLK
*.CONNECT net1870 EN
XFE_PHC904_net1873 DELC $PINS O=FE_PHN904_net1873 I=net1873
Xlatch QDBHN $PINS Q=net1873 D=net1870 CKB=CLK
Xmain_gate AN2T $PINS O=ENCLK I1=FE_PHN904_net1873 I2=CLK
.ENDS

.SUBCKT SNPS_CLOCK_GATE_HIGH_RegFileDual_DATA_WIDTH34_57 EN ENCLK CLK
*.CONNECT net1870 EN
XFE_PHC899_net1873 DELC $PINS O=net1873 I=FE_PHN899_net1873
Xlatch QDBHN $PINS Q=FE_PHN899_net1873 D=net1870 CKB=CLK
Xmain_gate AN2T $PINS O=ENCLK I1=net1873 I2=CLK
.ENDS

.SUBCKT SNPS_CLOCK_GATE_HIGH_RegFileDual_DATA_WIDTH34_56 EN ENCLK CLK
*.CONNECT net1870 EN
XFE_PHC891_net1873 DELC $PINS O=FE_PHN891_net1873 I=net1873
Xlatch QDBHN $PINS Q=net1873 D=net1870 CKB=CLK
Xmain_gate AN2T $PINS O=ENCLK I1=FE_PHN891_net1873 I2=CLK
.ENDS

.SUBCKT SNPS_CLOCK_GATE_HIGH_RegFileDual_DATA_WIDTH34_55 EN ENCLK CLK
*.CONNECT net1870 EN
XFE_PHC887_net1873 DELC $PINS O=FE_PHN887_net1873 I=net1873
Xlatch QDBHN $PINS Q=net1873 D=net1870 CKB=CLK
Xmain_gate AN2T $PINS O=ENCLK I1=FE_PHN887_net1873 I2=CLK
.ENDS

.SUBCKT SNPS_CLOCK_GATE_HIGH_RegFileDual_DATA_WIDTH34_54 EN ENCLK CLK
*.CONNECT net1870 EN
XFE_PHC907_net1873 DELC $PINS O=net1873 I=FE_PHN907_net1873
Xlatch QDBHN $PINS Q=FE_PHN907_net1873 D=net1870 CKB=CLK
Xmain_gate AN2T $PINS O=ENCLK I1=net1873 I2=CLK
.ENDS

.SUBCKT SNPS_CLOCK_GATE_HIGH_RegFileDual_DATA_WIDTH34_53 EN ENCLK CLK
*.CONNECT net1870 EN
XFE_PHC890_net1873 DELC $PINS O=net1873 I=FE_PHN890_net1873
Xlatch QDBHN $PINS Q=FE_PHN890_net1873 D=net1870 CKB=CLK
Xmain_gate AN2T $PINS O=ENCLK I1=net1873 I2=CLK
.ENDS

.SUBCKT SNPS_CLOCK_GATE_HIGH_RegFileDual_DATA_WIDTH34_52 EN ENCLK CLK
*.CONNECT net1870 EN
XFE_PHC881_net1873 DELC $PINS O=FE_PHN881_net1873 I=net1873
Xlatch QDBHN $PINS Q=net1873 D=net1870 CKB=CLK
Xmain_gate AN2T $PINS O=ENCLK I1=FE_PHN881_net1873 I2=CLK
.ENDS

.SUBCKT SNPS_CLOCK_GATE_HIGH_RegFileDual_DATA_WIDTH34_51 EN ENCLK CLK
*.CONNECT net1870 EN
XFE_PHC877_net1873 DELC $PINS O=FE_PHN877_net1873 I=net1873
Xlatch QDBHN $PINS Q=net1873 D=net1870 CKB=CLK
Xmain_gate AN2T $PINS O=ENCLK I1=FE_PHN877_net1873 I2=CLK
.ENDS

.SUBCKT SNPS_CLOCK_GATE_HIGH_RegFileDual_DATA_WIDTH34_50 EN ENCLK CLK
*.CONNECT net1870 EN
XFE_PHC827_net1873 DELC $PINS O=FE_PHN827_net1873 I=net1873
Xlatch QDBHN $PINS Q=net1873 D=net1870 CKB=CLK
Xmain_gate AN2 $PINS O=ENCLK I1=FE_PHN827_net1873 I2=CLK
.ENDS

.SUBCKT SNPS_CLOCK_GATE_HIGH_RegFileDual_DATA_WIDTH34_49 EN ENCLK CLK
*.CONNECT net1870 EN
XFE_PHC815_net1873 DELC $PINS O=FE_PHN815_net1873 I=net1873
Xlatch QDBHN $PINS Q=net1873 D=net1870 CKB=CLK
Xmain_gate AN2 $PINS O=ENCLK I1=FE_PHN815_net1873 I2=CLK
.ENDS

.SUBCKT SNPS_CLOCK_GATE_HIGH_RegFileDual_DATA_WIDTH34_48 EN ENCLK CLK
*.CONNECT net1870 EN
XFE_PHC816_net1873 DELC $PINS O=net1873 I=FE_PHN816_net1873
Xlatch QDBHN $PINS Q=FE_PHN816_net1873 D=net1870 CKB=CLK
Xmain_gate AN2 $PINS O=ENCLK I1=net1873 I2=CLK
.ENDS

.SUBCKT SNPS_CLOCK_GATE_HIGH_RegFileDual_DATA_WIDTH34_47 EN ENCLK CLK
*.CONNECT net1870 EN
XFE_PHC872_net1873 DELC $PINS O=FE_PHN872_net1873 I=net1873
Xlatch QDBHN $PINS Q=net1873 D=net1870 CKB=CLK
Xmain_gate AN2T $PINS O=ENCLK I1=FE_PHN872_net1873 I2=CLK
.ENDS

.SUBCKT SNPS_CLOCK_GATE_HIGH_RegFileDual_DATA_WIDTH34_46 EN ENCLK CLK
*.CONNECT net1870 EN
XFE_PHC823_net1873 DELC $PINS O=FE_PHN823_net1873 I=net1873
Xlatch QDBHN $PINS Q=net1873 D=net1870 CKB=CLK
Xmain_gate AN2 $PINS O=ENCLK I1=FE_PHN823_net1873 I2=CLK
.ENDS

.SUBCKT SNPS_CLOCK_GATE_HIGH_RegFileDual_DATA_WIDTH34_45 EN ENCLK CLK
*.CONNECT net1870 EN
XFE_PHC857_net1873 DELC $PINS O=FE_PHN857_net1873 I=net1873
Xlatch QDBHN $PINS Q=net1873 D=net1870 CKB=CLK
Xmain_gate AN2T $PINS O=ENCLK I1=FE_PHN857_net1873 I2=CLK
.ENDS

.SUBCKT SNPS_CLOCK_GATE_HIGH_RegFileDual_DATA_WIDTH34_44 EN ENCLK CLK
*.CONNECT net1870 EN
XFE_PHC843_net1873 DELC $PINS O=FE_PHN843_net1873 I=net1873
Xlatch QDBHN $PINS Q=net1873 D=net1870 CKB=CLK
Xmain_gate AN2T $PINS O=ENCLK I1=FE_PHN843_net1873 I2=CLK
.ENDS

.SUBCKT SNPS_CLOCK_GATE_HIGH_RegFileDual_DATA_WIDTH34_43 EN ENCLK CLK
*.CONNECT net1870 EN
XFE_PHC831_net1873 DELC $PINS O=FE_PHN831_net1873 I=net1873
Xlatch QDBHN $PINS Q=net1873 D=net1870 CKB=CLK
Xmain_gate AN2 $PINS O=ENCLK I1=FE_PHN831_net1873 I2=CLK
.ENDS

.SUBCKT SNPS_CLOCK_GATE_HIGH_RegFileDual_DATA_WIDTH34_42 EN ENCLK CLK
*.CONNECT net1870 EN
XFE_PHC818_net1873 DELC $PINS O=net1873 I=FE_PHN818_net1873
Xlatch QDBHN $PINS Q=FE_PHN818_net1873 D=net1870 CKB=CLK
Xmain_gate AN2 $PINS O=ENCLK I1=net1873 I2=CLK
.ENDS

.SUBCKT SNPS_CLOCK_GATE_HIGH_RegFileDual_DATA_WIDTH34_41 EN ENCLK CLK
*.CONNECT net1870 EN
XFE_PHC889_net1873 DELC $PINS O=FE_PHN889_net1873 I=net1873
Xlatch QDBHN $PINS Q=net1873 D=net1870 CKB=CLK
Xmain_gate AN2T $PINS O=ENCLK I1=FE_PHN889_net1873 I2=CLK
.ENDS

.SUBCKT SNPS_CLOCK_GATE_HIGH_RegFileDual_DATA_WIDTH34_40 EN ENCLK CLK
*.CONNECT net1870 EN
XFE_PHC879_net1873 DELC $PINS O=FE_PHN879_net1873 I=net1873
Xlatch QDBHN $PINS Q=net1873 D=net1870 CKB=CLK
Xmain_gate AN2T $PINS O=ENCLK I1=FE_PHN879_net1873 I2=CLK
.ENDS

.SUBCKT SNPS_CLOCK_GATE_HIGH_RegFileDual_DATA_WIDTH34_39 EN ENCLK CLK
*.CONNECT net1870 EN
XFE_PHC880_net1873 DELC $PINS O=net1873 I=FE_PHN880_net1873
Xlatch QDBHN $PINS Q=FE_PHN880_net1873 D=net1870 CKB=CLK
Xmain_gate AN2T $PINS O=ENCLK I1=net1873 I2=CLK
.ENDS

.SUBCKT SNPS_CLOCK_GATE_HIGH_RegFileDual_DATA_WIDTH34_38 EN ENCLK CLK
*.CONNECT net1870 EN
XFE_PHC867_net1873 DELC $PINS O=FE_PHN867_net1873 I=net1873
Xlatch QDBHN $PINS Q=net1873 D=net1870 CKB=CLK
Xmain_gate AN2 $PINS O=ENCLK I1=FE_PHN867_net1873 I2=CLK
.ENDS

.SUBCKT SNPS_CLOCK_GATE_HIGH_RegFileDual_DATA_WIDTH34_37 EN ENCLK CLK
*.CONNECT net1870 EN
XFE_PHC840_net1873 DELC $PINS O=FE_PHN840_net1873 I=net1873
Xlatch QDBHN $PINS Q=net1873 D=net1870 CKB=CLK
Xmain_gate AN2 $PINS O=ENCLK I1=FE_PHN840_net1873 I2=CLK
.ENDS

.SUBCKT SNPS_CLOCK_GATE_HIGH_RegFileDual_DATA_WIDTH34_36 EN ENCLK CLK
*.CONNECT net1870 EN
XFE_PHC817_net1873 DELC $PINS O=net1873 I=FE_PHN817_net1873
Xlatch QDBHN $PINS Q=FE_PHN817_net1873 D=net1870 CKB=CLK
Xmain_gate AN2 $PINS O=ENCLK I1=net1873 I2=CLK
.ENDS

.SUBCKT SNPS_CLOCK_GATE_HIGH_RegFileDual_DATA_WIDTH34_35 EN ENCLK CLK
*.CONNECT net1870 EN
XFE_PHC830_net1873 DELC $PINS O=FE_PHN830_net1873 I=net1873
Xlatch QDBHN $PINS Q=net1873 D=net1870 CKB=CLK
Xmain_gate AN2 $PINS O=ENCLK I1=FE_PHN830_net1873 I2=CLK
.ENDS

.SUBCKT SNPS_CLOCK_GATE_HIGH_RegFileDual_DATA_WIDTH34_34 EN ENCLK CLK
*.CONNECT net1870 EN
XFE_PHC844_net1873 DELC $PINS O=FE_PHN844_net1873 I=net1873
Xlatch QDBHN $PINS Q=net1873 D=net1870 CKB=CLK
Xmain_gate AN2T $PINS O=ENCLK I1=FE_PHN844_net1873 I2=CLK
.ENDS

.SUBCKT SNPS_CLOCK_GATE_HIGH_RegFileDual_DATA_WIDTH34_33 EN ENCLK CLK
*.CONNECT net1870 EN
XFE_PHC822_net1873 DELC $PINS O=net1873 I=FE_PHN822_net1873
Xlatch QDBHN $PINS Q=FE_PHN822_net1873 D=net1870 CKB=CLK
Xmain_gate AN2 $PINS O=ENCLK I1=net1873 I2=CLK
.ENDS

.SUBCKT SNPS_CLOCK_GATE_HIGH_RegFileDual_DATA_WIDTH34_32 EN ENCLK CLK
*.CONNECT net1870 EN
XFE_PHC875_net1873 DELC $PINS O=net1873 I=FE_PHN875_net1873
Xlatch QDBHN $PINS Q=FE_PHN875_net1873 D=net1870 CKB=CLK
Xmain_gate AN2T $PINS O=ENCLK I1=net1873 I2=CLK
.ENDS

.SUBCKT SNPS_CLOCK_GATE_HIGH_RegFileDual_DATA_WIDTH34_31 EN ENCLK CLK
*.CONNECT net1870 EN
XFE_PHC886_net1873 DELC $PINS O=net1873 I=FE_PHN886_net1873
Xlatch QDBHN $PINS Q=FE_PHN886_net1873 D=net1870 CKB=CLK
Xmain_gate AN2T $PINS O=ENCLK I1=net1873 I2=CLK
.ENDS

.SUBCKT SNPS_CLOCK_GATE_HIGH_RegFileDual_DATA_WIDTH34_30 EN ENCLK CLK
*.CONNECT net1870 EN
XFE_PHC885_net1873 DELC $PINS O=net1873 I=FE_PHN885_net1873
Xlatch QDBHN $PINS Q=FE_PHN885_net1873 D=net1870 CKB=CLK
Xmain_gate AN2T $PINS O=ENCLK I1=net1873 I2=CLK
.ENDS

.SUBCKT SNPS_CLOCK_GATE_HIGH_RegFileDual_DATA_WIDTH34_29 EN ENCLK CLK
*.CONNECT net1870 EN
XFE_PHC864_net1873 DELC $PINS O=FE_PHN864_net1873 I=net1873
Xlatch QDBHN $PINS Q=net1873 D=net1870 CKB=CLK
Xmain_gate AN2T $PINS O=ENCLK I1=FE_PHN864_net1873 I2=CLK
.ENDS

.SUBCKT SNPS_CLOCK_GATE_HIGH_RegFileDual_DATA_WIDTH34_28 EN ENCLK CLK
*.CONNECT net1870 EN
XFE_PHC841_net1873 DELC $PINS O=net1873 I=FE_PHN841_net1873
Xlatch QDBHN $PINS Q=FE_PHN841_net1873 D=net1870 CKB=CLK
Xmain_gate AN2T $PINS O=ENCLK I1=net1873 I2=CLK
.ENDS

.SUBCKT SNPS_CLOCK_GATE_HIGH_RegFileDual_DATA_WIDTH34_27 EN ENCLK CLK
*.CONNECT net1870 EN
XFE_PHC871_net1873 DELC $PINS O=FE_PHN871_net1873 I=net1873
Xlatch QDBHN $PINS Q=net1873 D=net1870 CKB=CLK
Xmain_gate AN2T $PINS O=ENCLK I1=FE_PHN871_net1873 I2=CLK
.ENDS

.SUBCKT SNPS_CLOCK_GATE_HIGH_RegFileDual_DATA_WIDTH34_26 EN ENCLK CLK
*.CONNECT net1870 EN
XFE_PHC842_net1873 DELC $PINS O=net1873 I=FE_PHN842_net1873
Xlatch QDBHN $PINS Q=FE_PHN842_net1873 D=net1870 CKB=CLK
Xmain_gate AN2T $PINS O=ENCLK I1=net1873 I2=CLK
.ENDS

.SUBCKT SNPS_CLOCK_GATE_HIGH_RegFileDual_DATA_WIDTH34_25 EN ENCLK CLK
*.CONNECT net1870 EN
XFE_PHC858_net1873 DELC $PINS O=FE_PHN858_net1873 I=net1873
Xlatch QDBHN $PINS Q=net1873 D=net1870 CKB=CLK
Xmain_gate AN2T $PINS O=ENCLK I1=FE_PHN858_net1873 I2=CLK
.ENDS

.SUBCKT SNPS_CLOCK_GATE_HIGH_RegFileDual_DATA_WIDTH34_24 EN ENCLK CLK
*.CONNECT net1870 EN
XFE_PHC837_net1873 DELC $PINS O=FE_PHN837_net1873 I=net1873
Xlatch QDBHN $PINS Q=net1873 D=net1870 CKB=CLK
Xmain_gate AN2T $PINS O=ENCLK I1=FE_PHN837_net1873 I2=CLK
.ENDS

.SUBCKT SNPS_CLOCK_GATE_HIGH_RegFileDual_DATA_WIDTH34_23 EN ENCLK CLK
*.CONNECT net1870 EN
XFE_PHC878_net1873 DELC $PINS O=FE_PHN878_net1873 I=net1873
Xlatch QDBHN $PINS Q=net1873 D=net1870 CKB=CLK
Xmain_gate AN2T $PINS O=ENCLK I1=FE_PHN878_net1873 I2=CLK
.ENDS

.SUBCKT SNPS_CLOCK_GATE_HIGH_RegFileDual_DATA_WIDTH34_22 CLK EN ENCLK
+ CLK_clone1
*.CONNECT net1867 CLK
*.CONNECT net1870 EN
XFE_PHC945_net1873 DELC $PINS O=FE_PHN945_net1873 I=net1873
Xlatch QDBHN $PINS Q=net1873 D=net1870 CKB=net1867
Xmain_gate AN2T $PINS O=ENCLK I1=FE_PHN945_net1873 I2=CLK_clone1
.ENDS

.SUBCKT SNPS_CLOCK_GATE_HIGH_RegFileDual_DATA_WIDTH34_21 EN ENCLK CLK
*.CONNECT net1870 EN
XFE_PHC892_net1873 DELC $PINS O=FE_PHN892_net1873 I=net1873
Xlatch QDBHN $PINS Q=net1873 D=net1870 CKB=CLK
Xmain_gate AN2T $PINS O=ENCLK I1=FE_PHN892_net1873 I2=CLK
.ENDS

.SUBCKT SNPS_CLOCK_GATE_HIGH_RegFileDual_DATA_WIDTH34_20 EN ENCLK CLK
*.CONNECT net1870 EN
XFE_PHC846_net1873 DELC $PINS O=FE_PHN846_net1873 I=net1873
Xlatch QDBHN $PINS Q=net1873 D=net1870 CKB=CLK
Xmain_gate AN2T $PINS O=ENCLK I1=FE_PHN846_net1873 I2=CLK
.ENDS

.SUBCKT SNPS_CLOCK_GATE_HIGH_RegFileDual_DATA_WIDTH34_19 EN ENCLK CLK
*.CONNECT net1870 EN
XFE_PHC856_net1873 DELC $PINS O=FE_PHN856_net1873 I=net1873
Xlatch QDBHN $PINS Q=net1873 D=net1870 CKB=CLK
Xmain_gate AN2T $PINS O=ENCLK I1=FE_PHN856_net1873 I2=CLK
.ENDS

.SUBCKT SNPS_CLOCK_GATE_HIGH_RegFileDual_DATA_WIDTH34_18 EN ENCLK CLK
*.CONNECT net1870 EN
XFE_PHC849_net1873 DELC $PINS O=net1873 I=FE_PHN849_net1873
Xlatch QDBHN $PINS Q=FE_PHN849_net1873 D=net1870 CKB=CLK
Xmain_gate AN2 $PINS O=ENCLK I1=net1873 I2=CLK
.ENDS

.SUBCKT SNPS_CLOCK_GATE_HIGH_RegFileDual_DATA_WIDTH34_17 EN ENCLK CLK
*.CONNECT net1870 EN
XFE_PHC882_net1873 DELC $PINS O=FE_PHN882_net1873 I=net1873
Xlatch QDBHN $PINS Q=net1873 D=net1870 CKB=CLK
Xmain_gate AN2T $PINS O=ENCLK I1=FE_PHN882_net1873 I2=CLK
.ENDS

.SUBCKT SNPS_CLOCK_GATE_HIGH_RegFileDual_DATA_WIDTH34_16 EN ENCLK CLK
*.CONNECT net1870 EN
XFE_PHC863_net1873 DELC $PINS O=FE_PHN863_net1873 I=net1873
Xlatch QDBHN $PINS Q=net1873 D=net1870 CKB=CLK
Xmain_gate AN2T $PINS O=ENCLK I1=FE_PHN863_net1873 I2=CLK
.ENDS

.SUBCKT SNPS_CLOCK_GATE_HIGH_RegFileDual_DATA_WIDTH34_15 EN ENCLK CLK
*.CONNECT net1870 EN
XFE_PHC828_net1873 DELC $PINS O=net1873 I=FE_PHN828_net1873
Xlatch QDBHN $PINS Q=FE_PHN828_net1873 D=net1870 CKB=CLK
Xmain_gate AN2 $PINS O=ENCLK I1=net1873 I2=CLK
.ENDS

.SUBCKT SNPS_CLOCK_GATE_HIGH_RegFileDual_DATA_WIDTH34_14 EN ENCLK CLK
*.CONNECT net1870 EN
XFE_PHC848_net1873 DELC $PINS O=net1873 I=FE_PHN848_net1873
Xlatch QDBHN $PINS Q=FE_PHN848_net1873 D=net1870 CKB=CLK
Xmain_gate AN2 $PINS O=ENCLK I1=net1873 I2=CLK
.ENDS

.SUBCKT SNPS_CLOCK_GATE_HIGH_RegFileDual_DATA_WIDTH34_13 EN ENCLK CLK
*.CONNECT net1870 EN
XFE_PHC839_net1873 DELC $PINS O=FE_PHN839_net1873 I=net1873
Xlatch QDBHN $PINS Q=net1873 D=net1870 CKB=CLK
Xmain_gate AN2 $PINS O=ENCLK I1=FE_PHN839_net1873 I2=CLK
.ENDS

.SUBCKT SNPS_CLOCK_GATE_HIGH_RegFileDual_DATA_WIDTH34_12 EN ENCLK CLK
*.CONNECT net1870 EN
XFE_PHC820_net1873 DELC $PINS O=FE_PHN820_net1873 I=net1873
Xlatch QDBHN $PINS Q=net1873 D=net1870 CKB=CLK
Xmain_gate AN2 $PINS O=ENCLK I1=FE_PHN820_net1873 I2=CLK
.ENDS

.SUBCKT SNPS_CLOCK_GATE_HIGH_RegFileDual_DATA_WIDTH34_11 EN ENCLK CLK
*.CONNECT net1870 EN
XFE_PHC903_net1873 DELC $PINS O=FE_PHN903_net1873 I=net1873
Xlatch QDBHN $PINS Q=net1873 D=net1870 CKB=CLK
Xmain_gate AN2T $PINS O=ENCLK I1=FE_PHN903_net1873 I2=CLK
.ENDS

.SUBCKT SNPS_CLOCK_GATE_HIGH_RegFileDual_DATA_WIDTH34_10 EN ENCLK CLK
*.CONNECT net1870 EN
XFE_PHC826_net1873 DELC $PINS O=FE_PHN826_net1873 I=net1873
Xlatch QDBHN $PINS Q=net1873 D=net1870 CKB=CLK
Xmain_gate AN2 $PINS O=ENCLK I1=FE_PHN826_net1873 I2=CLK
.ENDS

.SUBCKT SNPS_CLOCK_GATE_HIGH_RegFileDual_DATA_WIDTH34_9 EN ENCLK CLK
*.CONNECT net1870 EN
XFE_PHC819_net1873 DELC $PINS O=net1873 I=FE_PHN819_net1873
Xlatch QDBHN $PINS Q=FE_PHN819_net1873 D=net1870 CKB=CLK
Xmain_gate AN2 $PINS O=ENCLK I1=net1873 I2=CLK
.ENDS

.SUBCKT SNPS_CLOCK_GATE_HIGH_RegFileDual_DATA_WIDTH34_8 EN ENCLK CLK
*.CONNECT net1870 EN
XFE_PHC884_net1873 DELC $PINS O=FE_PHN884_net1873 I=net1873
Xlatch QDBHN $PINS Q=net1873 D=net1870 CKB=CLK
Xmain_gate AN2T $PINS O=ENCLK I1=FE_PHN884_net1873 I2=CLK
.ENDS

.SUBCKT SNPS_CLOCK_GATE_HIGH_RegFileDual_DATA_WIDTH34_7 EN ENCLK CLK
*.CONNECT net1870 EN
XFE_PHC835_net1873 DELC $PINS O=FE_PHN835_net1873 I=net1873
Xlatch QDBHN $PINS Q=net1873 D=net1870 CKB=CLK
Xmain_gate AN2 $PINS O=ENCLK I1=FE_PHN835_net1873 I2=CLK
.ENDS

.SUBCKT SNPS_CLOCK_GATE_HIGH_RegFileDual_DATA_WIDTH34_6 EN ENCLK CLK
*.CONNECT net1870 EN
XFE_PHC851_net1873 DELC $PINS O=FE_PHN851_net1873 I=net1873
Xlatch QDBHN $PINS Q=net1873 D=net1870 CKB=CLK
Xmain_gate AN2T $PINS O=ENCLK I1=FE_PHN851_net1873 I2=CLK
.ENDS

.SUBCKT SNPS_CLOCK_GATE_HIGH_RegFileDual_DATA_WIDTH34_5 EN ENCLK CLK
*.CONNECT net1870 EN
XFE_PHC855_net1873 DELC $PINS O=FE_PHN855_net1873 I=net1873
Xlatch QDBHN $PINS Q=net1873 D=net1870 CKB=CLK
Xmain_gate AN2 $PINS O=ENCLK I1=FE_PHN855_net1873 I2=CLK
.ENDS

.SUBCKT SNPS_CLOCK_GATE_HIGH_RegFileDual_DATA_WIDTH34_4 EN ENCLK CLK
*.CONNECT net1870 EN
XFE_PHC847_net1873 DELC $PINS O=FE_PHN847_net1873 I=net1873
Xlatch QDBHN $PINS Q=net1873 D=net1870 CKB=CLK
Xmain_gate AN2 $PINS O=ENCLK I1=FE_PHN847_net1873 I2=CLK
.ENDS

.SUBCKT SNPS_CLOCK_GATE_HIGH_RegFileDual_DATA_WIDTH34_3 EN ENCLK CLK
*.CONNECT net1870 EN
XFE_PHC829_net1873 DELC $PINS O=FE_PHN829_net1873 I=net1873
Xlatch QDBHN $PINS Q=net1873 D=net1870 CKB=CLK
Xmain_gate AN2 $PINS O=ENCLK I1=FE_PHN829_net1873 I2=CLK
.ENDS

.SUBCKT SNPS_CLOCK_GATE_HIGH_RegFileDual_DATA_WIDTH34_2 EN ENCLK CLK
*.CONNECT net1870 EN
XFE_PHC883_net1873 DELC $PINS O=FE_PHN883_net1873 I=net1873
Xlatch QDBHN $PINS Q=net1873 D=net1870 CKB=CLK
Xmain_gate AN2 $PINS O=ENCLK I1=FE_PHN883_net1873 I2=CLK
.ENDS

.SUBCKT SNPS_CLOCK_GATE_HIGH_RegFileDual_DATA_WIDTH34_1 EN ENCLK CLK
*.CONNECT net1870 EN
XFE_PHC854_net1873 DELC $PINS O=net1873 I=FE_PHN854_net1873
Xlatch QDBHN $PINS Q=FE_PHN854_net1873 D=net1870 CKB=CLK
Xmain_gate AN2 $PINS O=ENCLK I1=net1873 I2=CLK
.ENDS

.SUBCKT RegFileDual_DATA_WIDTH34 rst_n read_addr_1[4] read_addr_1[3]
+ read_addr_1[2] read_addr_1[1] read_addr_1[0] read_data_1[33] read_data_1[32]
+ read_data_1[31] read_data_1[30] read_data_1[29] read_data_1[28]
+ read_data_1[27] read_data_1[26] read_data_1[25] read_data_1[24]
+ read_data_1[23] read_data_1[22] read_data_1[21] read_data_1[20]
+ read_data_1[19] read_data_1[18] read_data_1[17] read_data_1[16]
+ read_data_1[15] read_data_1[14] read_data_1[13] read_data_1[12]
+ read_data_1[11] read_data_1[10] read_data_1[9] read_data_1[8] read_data_1[7]
+ read_data_1[6] read_data_1[5] read_data_1[4] read_data_1[3] read_data_1[2]
+ read_data_1[1] read_data_1[0] wen1 wen2 write_addr_1[4] write_addr_1[3]
+ write_addr_1[2] write_addr_1[1] write_addr_1[0] write_addr_2[4]
+ write_addr_2[3] write_addr_2[2] write_addr_2[1] write_addr_2[0]
+ write_data_1[33] write_data_1[32] write_data_1[31] write_data_1[30]
+ write_data_1[29] write_data_1[28] write_data_1[27] write_data_1[26]
+ write_data_1[25] write_data_1[24] write_data_1[23] write_data_1[22]
+ write_data_1[21] write_data_1[20] write_data_1[19] write_data_1[18]
+ write_data_1[17] write_data_1[16] write_data_1[15] write_data_1[14]
+ write_data_1[13] write_data_1[12] write_data_1[11] write_data_1[10]
+ write_data_1[9] write_data_1[8] write_data_1[7] write_data_1[6]
+ write_data_1[5] write_data_1[4] write_data_1[3] write_data_1[2]
+ write_data_1[1] write_data_1[0] write_data_2[33] write_data_2[32]
+ write_data_2[31] write_data_2[30] write_data_2[29] write_data_2[28]
+ write_data_2[27] write_data_2[26] write_data_2[25] write_data_2[24]
+ write_data_2[23] write_data_2[22] write_data_2[21] write_data_2[20]
+ write_data_2[19] write_data_2[18] write_data_2[17] write_data_2[16]
+ write_data_2[15] write_data_2[14] write_data_2[13] write_data_2[12]
+ write_data_2[11] write_data_2[10] write_data_2[9] write_data_2[8]
+ write_data_2[7] write_data_2[6] write_data_2[5] write_data_2[4]
+ write_data_2[3] write_data_2[2] write_data_2[1] write_data_2[0] p_1 i_rst_n
+ p1 p2 p3 FE_OFN25_i_rst_n FE_OFN17_i_rst_n FE_OFN14_i_rst_n clk_clone3
+ clk_clone4 clk clk_clone2 clk_clone1
XFE_PHC1530_FE_OFN99_bank_wdata_0__10 BUF3 $PINS
+ O=FE_PHN1530_FE_OFN99_bank_wdata_0__10 I=FE_OFN99_bank_wdata_0__10
XFE_PHC1454_N112 BUF1CK $PINS O=FE_PHN1454_N112 I=N112
XFE_PHC1453_N115 BUF1CK $PINS O=N115 I=FE_PHN1453_N115
XFE_PHC1452_N113 BUF1CK $PINS O=FE_PHN1452_N113 I=N113
XFE_PHC1451_FE_OFN79_bank_wdata_0__31 DELB $PINS
+ O=FE_PHN1451_FE_OFN79_bank_wdata_0__31 I=FE_OFN79_bank_wdata_0__31
XFE_PHC1450_bank_wdata_0_27 DELC $PINS O=FE_PHN1450_bank_wdata_0_27
+ I=bank_wdata[0][27]
XFE_PHC1449_FE_OFN78_bank_wdata_0__32 DELB $PINS O=FE_OFN78_bank_wdata_0__32
+ I=FE_PHN1449_FE_OFN78_bank_wdata_0__32
XFE_PHC1447_bank_wdata_0_24 BUF1CK $PINS O=FE_PHN1447_bank_wdata_0_24
+ I=bank_wdata[0][24]
XFE_PHC1446_FE_OFN80_bank_wdata_0__30 DELB $PINS
+ O=FE_PHN1446_FE_OFN80_bank_wdata_0__30 I=FE_OFN80_bank_wdata_0__30
XFE_PHC1444_N111 BUF1CK $PINS O=FE_PHN1444_N111 I=N111
XFE_PHC1436_bank_wdata_0_22 BUF1CK $PINS O=bank_wdata[0][22]
+ I=FE_PHN1436_bank_wdata_0_22
XFE_PHC1415_FE_OFN82_bank_wdata_0__28 BUF1S $PINS
+ O=FE_PHN1415_FE_OFN82_bank_wdata_0__28 I=FE_OFN82_bank_wdata_0__28
XFE_PHC1411_FE_OFN81_bank_wdata_0__29 BUF1S $PINS
+ O=FE_PHN1411_FE_OFN81_bank_wdata_0__29 I=FE_OFN81_bank_wdata_0__29
XFE_PHC1356_FE_OFN77_bank_wdata_0__33 BUF1S $PINS
+ O=FE_PHN1356_FE_OFN77_bank_wdata_0__33 I=FE_OFN77_bank_wdata_0__33
XFE_PHC1244_bank_mem_1_6_19 BUF1CK $PINS O=FE_PHN1244_bank_mem_1_6_19
+ I=bank_mem_1[6][19]
XFE_PHC1227_bank_mem_1_6_18 BUF1CK $PINS O=FE_PHN1227_bank_mem_1_6_18
+ I=bank_mem_1[6][18]
XFE_PHC1224_bank_mem_1_6_33 BUF1CK $PINS O=FE_PHN1224_bank_mem_1_6_33
+ I=bank_mem_1[6][33]
XFE_PHC1223_n505 BUF1CK $PINS O=FE_PHN1223_n505 I=n505
XFE_PHC1221_bank_mem_1_6_17 BUF1CK $PINS O=FE_PHN1221_bank_mem_1_6_17
+ I=bank_mem_1[6][17]
XFE_PHC1210_n692 BUF1CK $PINS O=FE_PHN1210_n692 I=n692
XFE_PHC1204_n791 BUF1CK $PINS O=FE_PHN1204_n791 I=n791
XFE_PHC1203_n472 BUF1CK $PINS O=FE_PHN1203_n472 I=n472
XFE_PHC1179_n527 BUF1CK $PINS O=n527 I=FE_PHN1179_n527
XFE_PHC1171_bank_wdata_1_15 BUF1CK $PINS O=FE_PHN1171_bank_wdata_1_15
+ I=bank_wdata[1][15]
XFE_PHC1166_bank_wdata_1_12 BUF1CK $PINS O=FE_PHN1166_bank_wdata_1_12
+ I=bank_wdata[1][12]
XFE_PHC1152_FE_OFN90_bank_wdata_0__19 DELB $PINS O=FE_OFN90_bank_wdata_0__19
+ I=FE_PHN1152_FE_OFN90_bank_wdata_0__19
XFE_PHC1151_n714 BUF1CK $PINS O=n714 I=FE_PHN1151_n714
XFE_PHC1141_cor_x_out_1_2 BUF1CK $PINS O=FE_PHN1141_cor_x_out_1_2
+ I=write_data_2[2]
XFE_PHC1133_bank_rdata_1_27 BUF1CK $PINS O=FE_PHN1133_bank_rdata_1_27
+ I=bank_rdata[1][27]
XFE_PHC1128_n703 BUF1CK $PINS O=n703 I=FE_PHN1128_n703
XFE_PHC1124_FE_OFN97_bank_wdata_0__12 DELB $PINS
+ O=FE_PHN1124_FE_OFN97_bank_wdata_0__12 I=FE_OFN97_bank_wdata_0__12
XFE_PHC1112_bank_wdata_0_25 BUF1CK $PINS O=FE_PHN1112_bank_wdata_0_25
+ I=bank_wdata[0][25]
XFE_PHC1093_FE_OFN95_bank_wdata_0__14 DELB $PINS O=FE_OFN95_bank_wdata_0__14
+ I=FE_PHN1093_FE_OFN95_bank_wdata_0__14
XFE_PHC1092_FE_OFN96_bank_wdata_0__13 DELB $PINS
+ O=FE_PHN1092_FE_OFN96_bank_wdata_0__13 I=FE_OFN96_bank_wdata_0__13
XFE_PHC1088_bank_wdata_1_16 BUF1CK $PINS O=FE_PHN1088_bank_wdata_1_16
+ I=bank_wdata[1][16]
XFE_PHC1084_cor_x_out_1_9 BUF1CK $PINS O=FE_PHN1084_cor_x_out_1_9
+ I=write_data_2[9]
XFE_PHC1083_n983 BUF2CK $PINS O=FE_PHN1083_n983 I=n983
XFE_PHC1080_cor_y_out_1_12 DELA $PINS O=FE_PHN1080_cor_y_out_1_12
+ I=write_data_2[29]
XFE_PHC1079_n758 BUF1S $PINS O=n758 I=FE_PHN1079_n758
XFE_PHC1077_n961 BUF1CK $PINS O=FE_PHN1077_n961 I=n961
XFE_PHC1074_FE_OFN91_bank_wdata_0__18 BUF1S $PINS O=FE_OFN91_bank_wdata_0__18
+ I=FE_PHN1074_FE_OFN91_bank_wdata_0__18
XFE_PHC1073_n966 DELB $PINS O=FE_PHN1073_n966 I=n966
XFE_PHC1068_bank_wdata_1_13 BUF1CK $PINS O=FE_PHN1068_bank_wdata_1_13
+ I=bank_wdata[1][13]
XFE_PHC1052_FE_OFN98_bank_wdata_0__11 BUF1S $PINS O=FE_OFN98_bank_wdata_0__11
+ I=FE_PHN1052_FE_OFN98_bank_wdata_0__11
XFE_PHC1048_cor_y_out_1_13 DELA $PINS O=FE_PHN1048_cor_y_out_1_13
+ I=write_data_2[30]
XFE_PHC1020_FE_OFN93_bank_wdata_0__16 BUF1S $PINS O=FE_OFN93_bank_wdata_0__16
+ I=FE_PHN1020_FE_OFN93_bank_wdata_0__16
XFE_PHC1017_FE_OFN94_bank_wdata_0__15 BUF1S $PINS
+ O=FE_PHN1017_FE_OFN94_bank_wdata_0__15 I=FE_OFN94_bank_wdata_0__15
XFE_PHC1008_cor_y_out_1_16 DELA $PINS O=FE_PHN1008_cor_y_out_1_16
+ I=write_data_2[33]
XCTS_ccl_a_INV_CLK_G1_L10_14 INV6CK $PINS O=CTS_782 I=CTS_783
XCTS_ccl_a_INV_CLK_G1_L9_17 INV3CK $PINS O=CTS_783 I=CTS_784
XCTS_ccl_a_INV_CLK_G1_L10_13 INV12CK $PINS O=CTS_779 I=CTS_780
XCTS_ccl_a_INV_CLK_G1_L9_16 INV8CK $PINS O=CTS_780 I=CTS_781
XCTS_ccl_a_INV_CLK_G1_L10_12 INV6CK $PINS O=CTS_776 I=CTS_777
XCTS_ccl_a_INV_CLK_G1_L9_15 INV3CK $PINS O=CTS_777 I=CTS_778
XCTS_ccl_a_INV_CLK_G1_L10_11 INV4CK $PINS O=CTS_773 I=CTS_774
XCTS_ccl_a_INV_CLK_G1_L9_14 INV6CK $PINS O=CTS_774 I=CTS_775
XCTS_ccl_a_INV_CLK_G1_L10_10 INV8CK $PINS O=CTS_770 I=CTS_771
XCTS_ccl_a_INV_CLK_G1_L9_13 INV3CK $PINS O=CTS_771 I=CTS_772
XCTS_ccl_a_INV_CLK_G1_L10_9 INV4CK $PINS O=CTS_767 I=CTS_768
XCTS_ccl_a_INV_CLK_G1_L9_12 INV2CK $PINS O=CTS_768 I=CTS_769
XCTS_ccl_a_INV_CLK_G1_L10_8 INV4CK $PINS O=CTS_764 I=CTS_765
XCTS_ccl_a_INV_CLK_G1_L9_11 INV8CK $PINS O=CTS_765 I=CTS_766
XCTS_ccl_a_INV_CLK_G1_L10_7 INV12CK $PINS O=CTS_761 I=CTS_762
XCTS_ccl_a_INV_CLK_G1_L9_10 INV8CK $PINS O=CTS_762 I=CTS_763
XCTS_ccl_a_INV_CLK_G1_L10_6 INV12CK $PINS O=CTS_758 I=CTS_759
XCTS_ccl_a_INV_CLK_G1_L9_9 INV8CK $PINS O=CTS_759 I=CTS_760
XCTS_ccl_a_INV_CLK_G1_L10_5 INV4CK $PINS O=CTS_755 I=CTS_756
XCTS_ccl_a_INV_CLK_G1_L9_8 INV6CK $PINS O=CTS_756 I=CTS_757
XCTS_ccl_a_INV_CLK_G1_L10_4 INV12CK $PINS O=CTS_752 I=CTS_753
XCTS_ccl_a_INV_CLK_G1_L9_7 INV8CK $PINS O=CTS_753 I=CTS_754
XCTS_ccl_a_INV_CLK_G1_L10_3 INV6CK $PINS O=CTS_749 I=CTS_750
XCTS_ccl_a_INV_CLK_G1_L9_6 INV8CK $PINS O=CTS_750 I=CTS_751
XCTS_ccl_a_INV_CLK_G1_L10_2 INV4CK $PINS O=CTS_746 I=CTS_747
XCTS_ccl_a_INV_CLK_G1_L9_5 INV8CK $PINS O=CTS_747 I=CTS_748
XCTS_ccl_a_INV_CLK_G1_L10_1 INV4CK $PINS O=CTS_743 I=CTS_744
XCTS_ccl_a_INV_CLK_G1_L9_4 INV8CK $PINS O=CTS_744 I=CTS_745
XCTS_ccl_a_INV_CLK_G1_L8_109 INV4CK $PINS O=CTS_739 I=CTS_740
XCTS_ccl_a_INV_CLK_G1_L7_111 INV2CK $PINS O=CTS_740 I=CTS_741
XCTS_ccl_a_INV_CLK_G1_L8_108 INV4CK $PINS O=CTS_736 I=CTS_737
XCTS_ccl_a_INV_CLK_G1_L7_110 INV3CK $PINS O=CTS_737 I=CTS_738
XCTS_ccl_a_INV_CLK_G1_L8_107 INV4CK $PINS O=CTS_733 I=CTS_734
XCTS_ccl_a_INV_CLK_G1_L7_109 INV2CK $PINS O=CTS_734 I=CTS_735
XCTS_ccl_a_INV_CLK_G1_L8_106 INV4CK $PINS O=CTS_730 I=CTS_731
XCTS_ccl_a_INV_CLK_G1_L7_108 INV2CK $PINS O=CTS_731 I=CTS_732
XCTS_ccl_a_INV_CLK_G1_L8_105 INV3CK $PINS O=CTS_727 I=CTS_728
XCTS_ccl_a_INV_CLK_G1_L7_107 INV2CK $PINS O=CTS_728 I=CTS_729
XCTS_ccl_a_INV_CLK_G1_L8_104 INV4CK $PINS O=CTS_724 I=CTS_725
XCTS_ccl_a_INV_CLK_G1_L7_106 INV2CK $PINS O=CTS_725 I=CTS_726
XCTS_ccl_a_INV_CLK_G1_L8_103 INV4CK $PINS O=CTS_721 I=CTS_722
XCTS_ccl_a_INV_CLK_G1_L7_105 INV2CK $PINS O=CTS_722 I=CTS_723
XCTS_ccl_a_INV_CLK_G1_L8_102 INV4CK $PINS O=CTS_718 I=CTS_719
XCTS_ccl_a_INV_CLK_G1_L7_104 INV2CK $PINS O=CTS_719 I=CTS_720
XCTS_ccl_a_INV_CLK_G1_L8_101 INV4CK $PINS O=CTS_715 I=CTS_716
XCTS_ccl_a_INV_CLK_G1_L7_103 INV2CK $PINS O=CTS_716 I=CTS_717
XCTS_ccl_a_INV_CLK_G1_L8_100 INV4CK $PINS O=CTS_712 I=CTS_713
XCTS_ccl_a_INV_CLK_G1_L7_102 INV3CK $PINS O=CTS_713 I=CTS_714
XCTS_ccl_a_INV_CLK_G1_L8_99 INV4CK $PINS O=CTS_709 I=CTS_710
XCTS_ccl_a_INV_CLK_G1_L7_101 INV2CK $PINS O=CTS_710 I=CTS_711
XCTS_ccl_a_INV_CLK_G1_L8_98 INV4CK $PINS O=CTS_706 I=CTS_707
XCTS_ccl_a_INV_CLK_G1_L7_100 INV2CK $PINS O=CTS_707 I=CTS_708
XCTS_ccl_a_INV_CLK_G1_L8_97 INV4CK $PINS O=CTS_703 I=CTS_704
XCTS_ccl_a_INV_CLK_G1_L7_99 INV2CK $PINS O=CTS_704 I=CTS_705
XCTS_ccl_a_INV_CLK_G1_L8_96 INV4CK $PINS O=CTS_700 I=CTS_701
XCTS_ccl_a_INV_CLK_G1_L7_98 INV2CK $PINS O=CTS_701 I=CTS_702
XCTS_ccl_a_INV_CLK_G1_L8_95 INV4CK $PINS O=CTS_697 I=CTS_698
XCTS_ccl_a_INV_CLK_G1_L7_97 INV2CK $PINS O=CTS_698 I=CTS_699
XCTS_ccl_a_INV_CLK_G0_L5_10 INV8CK $PINS O=CTS_742 I=clk_clone2
XCTS_ccl_a_INV_CLK_G1_L8_89 INV6CK $PINS O=CTS_694 I=CTS_695
XCTS_ccl_a_INV_CLK_G1_L7_91 INV2CK $PINS O=CTS_695 I=CTS_696
XCTS_ccl_a_INV_CLK_G1_L8_79 INV3CK $PINS O=CTS_689 I=CTS_690
XCTS_ccl_a_INV_CLK_G1_L7_82 INV2CK $PINS O=CTS_690 I=CTS_691
XCTS_ccl_a_INV_CLK_G1_L8_78 INV6CK $PINS O=CTS_686 I=CTS_687
XCTS_ccl_a_INV_CLK_G1_L7_81 INV3CK $PINS O=CTS_687 I=CTS_688
XCTS_ccl_a_INV_CLK_G1_L8_77 INV6CK $PINS O=CTS_683 I=CTS_684
XCTS_ccl_a_INV_CLK_G1_L7_80 INV3CK $PINS O=CTS_684 I=CTS_685
XCTS_ccl_a_INV_CLK_G1_L8_76 INV6CK $PINS O=CTS_680 I=CTS_681
XCTS_ccl_a_INV_CLK_G1_L7_79 INV3CK $PINS O=CTS_681 I=CTS_682
XCTS_ccl_a_INV_CLK_G1_L8_75 INV4CK $PINS O=CTS_677 I=CTS_678
XCTS_ccl_a_INV_CLK_G1_L7_78 INV2CK $PINS O=CTS_678 I=CTS_679
XCTS_ccl_a_INV_CLK_G1_L8_74 INV6CK $PINS O=CTS_674 I=CTS_675
XCTS_ccl_a_INV_CLK_G1_L7_77 INV2CK $PINS O=CTS_675 I=CTS_676
XCTS_ccl_a_INV_CLK_G1_L8_73 INV4CK $PINS O=CTS_671 I=CTS_672
XCTS_ccl_a_INV_CLK_G1_L7_76 INV2CK $PINS O=CTS_672 I=CTS_673
XCTS_ccl_a_INV_CLK_G1_L8_72 INV4CK $PINS O=CTS_668 I=CTS_669
XCTS_ccl_a_INV_CLK_G1_L7_75 INV2CK $PINS O=CTS_669 I=CTS_670
XCTS_ccl_a_INV_CLK_G1_L8_71 INV4CK $PINS O=CTS_665 I=CTS_666
XCTS_ccl_a_INV_CLK_G1_L7_74 INV2CK $PINS O=CTS_666 I=CTS_667
XCTS_ccl_a_INV_CLK_G1_L8_70 INV6CK $PINS O=CTS_662 I=CTS_663
XCTS_ccl_a_INV_CLK_G1_L7_73 INV2CK $PINS O=CTS_663 I=CTS_664
XCTS_ccl_a_INV_CLK_G1_L8_69 INV4CK $PINS O=CTS_659 I=CTS_660
XCTS_ccl_a_INV_CLK_G1_L7_72 INV2CK $PINS O=CTS_660 I=CTS_661
XCTS_ccl_a_INV_CLK_G1_L8_68 INV6CK $PINS O=CTS_656 I=CTS_657
XCTS_ccl_a_INV_CLK_G1_L7_71 INV3CK $PINS O=CTS_657 I=CTS_658
XCTS_ccl_a_INV_CLK_G1_L8_67 INV4CK $PINS O=CTS_653 I=CTS_654
XCTS_ccl_a_INV_CLK_G1_L7_70 INV2CK $PINS O=CTS_654 I=CTS_655
XCTS_ccl_a_INV_CLK_G1_L8_66 INV4CK $PINS O=CTS_650 I=CTS_651
XCTS_ccl_a_INV_CLK_G1_L7_69 INV2CK $PINS O=CTS_651 I=CTS_652
XCTS_ccl_a_INV_CLK_G1_L8_65 INV6CK $PINS O=CTS_647 I=CTS_648
XCTS_ccl_a_INV_CLK_G1_L7_68 INV2CK $PINS O=CTS_648 I=CTS_649
XCTS_ccl_a_INV_CLK_G1_L8_64 INV6CK $PINS O=CTS_644 I=CTS_645
XCTS_ccl_a_INV_CLK_G1_L7_67 INV2CK $PINS O=CTS_645 I=CTS_646
XCTS_ccl_a_INV_CLK_G1_L8_63 INV4CK $PINS O=CTS_641 I=CTS_642
XCTS_ccl_a_INV_CLK_G1_L7_66 INV2CK $PINS O=CTS_642 I=CTS_643
XCTS_ccl_a_INV_CLK_G0_L5_7 INV8CK $PINS O=CTS_692 I=CTS_693
XCTS_ccl_a_INV_CLK_G1_L8_62 INV3CK $PINS O=CTS_637 I=CTS_638
XCTS_ccl_a_INV_CLK_G1_L7_65 INV2CK $PINS O=CTS_638 I=CTS_639
XCTS_ccl_a_INV_CLK_G1_L8_61 INV4CK $PINS O=CTS_634 I=CTS_635
XCTS_ccl_a_INV_CLK_G1_L7_64 INV2CK $PINS O=CTS_635 I=CTS_636
XCTS_ccl_a_INV_CLK_G1_L8_60 INV6CK $PINS O=CTS_631 I=CTS_632
XCTS_ccl_a_INV_CLK_G1_L7_63 INV2CK $PINS O=CTS_632 I=CTS_633
XCTS_ccl_a_INV_CLK_G1_L8_59 INV4CK $PINS O=CTS_628 I=CTS_629
XCTS_ccl_a_INV_CLK_G1_L7_62 INV2CK $PINS O=CTS_629 I=CTS_630
XCTS_ccl_a_INV_CLK_G1_L8_58 INV4CK $PINS O=CTS_625 I=CTS_626
XCTS_ccl_a_INV_CLK_G1_L7_61 INV2CK $PINS O=CTS_626 I=CTS_627
XCTS_ccl_a_INV_CLK_G1_L8_57 INV6CK $PINS O=CTS_622 I=CTS_623
XCTS_ccl_a_INV_CLK_G1_L7_60 INV2CK $PINS O=CTS_623 I=CTS_624
XCTS_ccl_a_INV_CLK_G1_L8_56 INV6CK $PINS O=CTS_619 I=CTS_620
XCTS_ccl_a_INV_CLK_G1_L7_59 INV2CK $PINS O=CTS_620 I=CTS_621
XCTS_ccl_a_INV_CLK_G1_L8_55 INV4CK $PINS O=CTS_616 I=CTS_617
XCTS_ccl_a_INV_CLK_G1_L7_58 INV2CK $PINS O=CTS_617 I=CTS_618
XCTS_ccl_a_INV_CLK_G1_L8_54 INV4CK $PINS O=CTS_613 I=CTS_614
XCTS_ccl_a_INV_CLK_G1_L7_57 INV2CK $PINS O=CTS_614 I=CTS_615
XCTS_ccl_a_INV_CLK_G1_L8_53 INV4CK $PINS O=CTS_610 I=CTS_611
XCTS_ccl_a_INV_CLK_G1_L7_56 INV2CK $PINS O=CTS_611 I=CTS_612
XCTS_ccl_a_INV_CLK_G1_L8_52 INV6CK $PINS O=CTS_607 I=CTS_608
XCTS_ccl_a_INV_CLK_G1_L7_55 INV2CK $PINS O=CTS_608 I=CTS_609
XCTS_ccl_a_INV_CLK_G1_L8_51 INV4CK $PINS O=CTS_604 I=CTS_605
XCTS_ccl_a_INV_CLK_G1_L7_54 INV2CK $PINS O=CTS_605 I=CTS_606
XCTS_ccl_a_INV_CLK_G1_L8_50 INV4CK $PINS O=CTS_601 I=CTS_602
XCTS_ccl_a_INV_CLK_G1_L7_53 INV2CK $PINS O=CTS_602 I=CTS_603
XCTS_ccl_a_INV_CLK_G1_L8_49 INV4CK $PINS O=CTS_598 I=CTS_599
XCTS_ccl_a_INV_CLK_G1_L7_52 INV2CK $PINS O=CTS_599 I=CTS_600
XCTS_ccl_a_INV_CLK_G1_L8_48 INV4CK $PINS O=CTS_595 I=CTS_596
XCTS_ccl_a_INV_CLK_G1_L7_51 INV2CK $PINS O=CTS_596 I=CTS_597
XCTS_ccl_a_INV_CLK_G1_L8_47 INV4CK $PINS O=CTS_592 I=CTS_593
XCTS_ccl_a_INV_CLK_G1_L7_50 INV2CK $PINS O=CTS_593 I=CTS_594
XCTS_ccl_a_INV_CLK_G1_L8_46 INV4CK $PINS O=CTS_589 I=CTS_590
XCTS_ccl_a_INV_CLK_G1_L7_49 INV2CK $PINS O=CTS_590 I=CTS_591
XCTS_ccl_a_INV_CLK_G0_L5_6 INV8CK $PINS O=CTS_640 I=CTS_693
XCTS_ccl_a_INV_CLK_G0_L4_3 INV12CK $PINS O=CTS_693 I=clk_clone4
XFE_OFC109_bank_wdata_0__0 BUF1 $PINS O=FE_OFN109_bank_wdata_0__0
+ I=bank_wdata[0][0]
XFE_OFC108_bank_wdata_0__1 BUF1 $PINS O=FE_OFN108_bank_wdata_0__1
+ I=bank_wdata[0][1]
XFE_OFC107_bank_wdata_0__2 BUF1 $PINS O=FE_OFN107_bank_wdata_0__2
+ I=bank_wdata[0][2]
XFE_OFC106_bank_wdata_0__3 BUF1 $PINS O=FE_OFN106_bank_wdata_0__3
+ I=bank_wdata[0][3]
XFE_OFC105_bank_wdata_0__4 BUF1 $PINS O=FE_OFN105_bank_wdata_0__4
+ I=bank_wdata[0][4]
XFE_OFC104_bank_wdata_0__5 BUF1 $PINS O=FE_OFN104_bank_wdata_0__5
+ I=bank_wdata[0][5]
XFE_OFC103_bank_wdata_0__6 BUF1 $PINS O=FE_OFN103_bank_wdata_0__6
+ I=bank_wdata[0][6]
XFE_OFC102_bank_wdata_0__7 BUF1 $PINS O=FE_OFN102_bank_wdata_0__7
+ I=bank_wdata[0][7]
XFE_OFC101_bank_wdata_0__8 BUF1 $PINS O=FE_OFN101_bank_wdata_0__8
+ I=bank_wdata[0][8]
XFE_OFC100_bank_wdata_0__9 BUF1 $PINS O=FE_OFN100_bank_wdata_0__9
+ I=bank_wdata[0][9]
XFE_OFC99_bank_wdata_0__10 BUF1 $PINS O=FE_OFN99_bank_wdata_0__10
+ I=bank_wdata[0][10]
XFE_OFC98_bank_wdata_0__11 BUF1 $PINS O=FE_PHN1052_FE_OFN98_bank_wdata_0__11
+ I=bank_wdata[0][11]
XFE_OFC97_bank_wdata_0__12 BUF1 $PINS O=FE_OFN97_bank_wdata_0__12
+ I=bank_wdata[0][12]
XFE_OFC96_bank_wdata_0__13 BUF1 $PINS O=FE_OFN96_bank_wdata_0__13
+ I=bank_wdata[0][13]
XFE_OFC95_bank_wdata_0__14 BUF1 $PINS O=FE_PHN1093_FE_OFN95_bank_wdata_0__14
+ I=bank_wdata[0][14]
XFE_OFC94_bank_wdata_0__15 BUF1 $PINS O=FE_OFN94_bank_wdata_0__15
+ I=bank_wdata[0][15]
XFE_OFC93_bank_wdata_0__16 BUF1 $PINS O=FE_PHN1020_FE_OFN93_bank_wdata_0__16
+ I=bank_wdata[0][16]
XFE_OFC92_bank_wdata_0__17 DELA $PINS O=FE_OFN92_bank_wdata_0__17
+ I=bank_wdata[0][17]
XFE_OFC91_bank_wdata_0__18 BUF1 $PINS O=FE_PHN1074_FE_OFN91_bank_wdata_0__18
+ I=bank_wdata[0][18]
XFE_OFC90_bank_wdata_0__19 BUF1 $PINS O=FE_PHN1152_FE_OFN90_bank_wdata_0__19
+ I=bank_wdata[0][19]
XFE_OFC89_bank_wdata_0__20 BUF1S $PINS O=FE_OFN89_bank_wdata_0__20
+ I=bank_wdata[0][20]
XFE_OFC88_bank_wdata_0__21 DELA $PINS O=FE_OFN88_bank_wdata_0__21
+ I=bank_wdata[0][21]
XFE_OFC87_bank_wdata_0__22 BUF1 $PINS O=FE_OFN87_bank_wdata_0__22
+ I=bank_wdata[0][22]
XFE_OFC86_bank_wdata_0__23 DELA $PINS O=FE_OFN86_bank_wdata_0__23
+ I=bank_wdata[0][23]
XFE_OFC85_bank_wdata_0__24 BUF1 $PINS O=FE_OFN85_bank_wdata_0__24
+ I=FE_PHN1447_bank_wdata_0_24
XFE_OFC84_bank_wdata_0__25 BUF1 $PINS O=FE_OFN84_bank_wdata_0__25
+ I=FE_PHN1112_bank_wdata_0_25
XFE_OFC83_bank_wdata_0__26 DELA $PINS O=FE_OFN83_bank_wdata_0__26
+ I=bank_wdata[0][26]
XFE_OFC82_bank_wdata_0__28 BUF1 $PINS O=FE_OFN82_bank_wdata_0__28
+ I=bank_wdata[0][28]
XFE_OFC81_bank_wdata_0__29 BUF1 $PINS O=FE_OFN81_bank_wdata_0__29
+ I=bank_wdata[0][29]
XFE_OFC80_bank_wdata_0__30 BUF1 $PINS O=FE_OFN80_bank_wdata_0__30
+ I=bank_wdata[0][30]
XFE_OFC79_bank_wdata_0__31 BUF1 $PINS O=FE_OFN79_bank_wdata_0__31
+ I=bank_wdata[0][31]
XFE_OFC78_bank_wdata_0__32 BUF1 $PINS O=FE_PHN1449_FE_OFN78_bank_wdata_0__32
+ I=bank_wdata[0][32]
XFE_OFC77_bank_wdata_0__33 BUF1 $PINS O=FE_OFN77_bank_wdata_0__33
+ I=bank_wdata[0][33]
XFE_OFC75_bank_wdata_1__0 BUF1 $PINS O=FE_OFN75_bank_wdata_1__0
+ I=bank_wdata[1][0]
XFE_OFC74_bank_wdata_1__1 BUF1 $PINS O=FE_OFN74_bank_wdata_1__1
+ I=bank_wdata[1][1]
XFE_OFC73_bank_wdata_1__2 BUF1 $PINS O=FE_OFN73_bank_wdata_1__2
+ I=bank_wdata[1][2]
XFE_OFC72_bank_wdata_1__3 BUF1 $PINS O=FE_OFN72_bank_wdata_1__3
+ I=bank_wdata[1][3]
XFE_OFC71_bank_wdata_1__4 BUF1 $PINS O=FE_OFN71_bank_wdata_1__4
+ I=bank_wdata[1][4]
XFE_OFC70_bank_wdata_1__5 BUF1 $PINS O=FE_OFN70_bank_wdata_1__5
+ I=bank_wdata[1][5]
XFE_OFC69_bank_wdata_1__6 BUF1 $PINS O=FE_OFN69_bank_wdata_1__6
+ I=bank_wdata[1][6]
XFE_OFC68_bank_wdata_1__7 BUF1 $PINS O=FE_OFN68_bank_wdata_1__7
+ I=bank_wdata[1][7]
XFE_OFC67_bank_wdata_1__8 BUF1 $PINS O=FE_OFN67_bank_wdata_1__8
+ I=bank_wdata[1][8]
XFE_OFC66_bank_wdata_1__9 BUF1 $PINS O=FE_OFN66_bank_wdata_1__9
+ I=bank_wdata[1][9]
XFE_OFC65_bank_wdata_1__10 BUF1 $PINS O=FE_OFN65_bank_wdata_1__10
+ I=bank_wdata[1][10]
XFE_OFC64_bank_wdata_1__11 BUF1 $PINS O=FE_OFN64_bank_wdata_1__11
+ I=bank_wdata[1][11]
XFE_OFC63_bank_wdata_1__12 BUF1 $PINS O=FE_OFN63_bank_wdata_1__12
+ I=FE_PHN1166_bank_wdata_1_12
XFE_OFC62_bank_wdata_1__13 BUF1 $PINS O=FE_OFN62_bank_wdata_1__13
+ I=FE_PHN1068_bank_wdata_1_13
XFE_OFC61_bank_wdata_1__14 DELA $PINS O=FE_OFN61_bank_wdata_1__14
+ I=bank_wdata[1][14]
XFE_OFC60_bank_wdata_1__15 BUF1 $PINS O=FE_OFN60_bank_wdata_1__15
+ I=FE_PHN1171_bank_wdata_1_15
XFE_OFC59_bank_wdata_1__16 BUF1 $PINS O=FE_OFN59_bank_wdata_1__16
+ I=FE_PHN1088_bank_wdata_1_16
XFE_OFC58_bank_wdata_1__17 BUF1 $PINS O=FE_OFN58_bank_wdata_1__17
+ I=bank_wdata[1][17]
XFE_OFC57_bank_wdata_1__18 BUF1 $PINS O=FE_OFN57_bank_wdata_1__18
+ I=bank_wdata[1][18]
XFE_OFC56_bank_wdata_1__19 BUF1 $PINS O=FE_OFN56_bank_wdata_1__19
+ I=bank_wdata[1][19]
XFE_OFC55_bank_wdata_1__20 BUF1 $PINS O=FE_OFN55_bank_wdata_1__20
+ I=bank_wdata[1][20]
XFE_OFC54_bank_wdata_1__21 BUF1 $PINS O=FE_OFN54_bank_wdata_1__21
+ I=bank_wdata[1][21]
XFE_OFC53_bank_wdata_1__22 BUF1 $PINS O=FE_OFN53_bank_wdata_1__22
+ I=bank_wdata[1][22]
XFE_OFC52_bank_wdata_1__23 BUF1 $PINS O=FE_OFN52_bank_wdata_1__23
+ I=bank_wdata[1][23]
XFE_OFC51_bank_wdata_1__24 BUF1 $PINS O=FE_OFN51_bank_wdata_1__24
+ I=bank_wdata[1][24]
XFE_OFC50_bank_wdata_1__25 BUF1 $PINS O=FE_OFN50_bank_wdata_1__25
+ I=bank_wdata[1][25]
XFE_OFC49_bank_wdata_1__26 BUF1 $PINS O=FE_OFN49_bank_wdata_1__26
+ I=bank_wdata[1][26]
XFE_OFC48_bank_wdata_1__27 BUF1 $PINS O=FE_OFN48_bank_wdata_1__27
+ I=bank_wdata[1][27]
XFE_OFC47_bank_wdata_1__28 BUF1 $PINS O=FE_OFN47_bank_wdata_1__28
+ I=bank_wdata[1][28]
XFE_OFC46_bank_wdata_1__29 BUF1 $PINS O=FE_OFN46_bank_wdata_1__29
+ I=bank_wdata[1][29]
XFE_OFC45_bank_wdata_1__30 BUF1 $PINS O=FE_OFN45_bank_wdata_1__30
+ I=bank_wdata[1][30]
XFE_OFC44_bank_wdata_1__31 BUF1 $PINS O=FE_OFN44_bank_wdata_1__31
+ I=bank_wdata[1][31]
XFE_OFC43_bank_wdata_1__32 BUF1 $PINS O=FE_OFN43_bank_wdata_1__32
+ I=bank_wdata[1][32]
XFE_OFC42_bank_wdata_1__33 BUF1 $PINS O=FE_OFN42_bank_wdata_1__33
+ I=bank_wdata[1][33]
Xbank_raddr_reg[0][3] QDLHN $PINS Q=N30 D=read_addr_1[4] CK=n122
Xbank_raddr_reg[0][2] QDLHN $PINS Q=N29 D=read_addr_1[3] CK=n122
Xbank_raddr_reg[0][1] QDLHN $PINS Q=N28 D=read_addr_1[2] CK=n122
Xbank_raddr_reg[0][0] QDLHN $PINS Q=N27 D=read_addr_1[1] CK=n122
Xbank_raddr_reg[1][3] QDBHN $PINS Q=N34 D=read_addr_1[4] CKB=n122
Xbank_raddr_reg[1][2] QDBHN $PINS Q=N33 D=read_addr_1[3] CKB=n122
Xbank_raddr_reg[1][1] QDBHN $PINS Q=N32 D=read_addr_1[2] CKB=n122
Xbank_raddr_reg[1][0] QDBHN $PINS Q=N31 D=read_addr_1[1] CKB=n122
XU202 ND2 $PINS O=n89 I1=n95 I2=n96
XU204 ND2 $PINS O=n93 I1=n954 I2=n100
XU205 ND2 $PINS O=n97 I1=n955 I2=n101
XU206 ND2 $PINS O=n98 I1=n101 I2=n96
XU208 ND2 $PINS O=n102 I1=n108 I2=n952
XU209 ND2 $PINS O=n104 I1=n108 I2=n109
XU210 ND2 $PINS O=n110 I1=n112 I2=wen1
XU211 ND2 $PINS O=n103 I1=n951 I2=n950
XU214 ND2 $PINS O=n113 I1=n952 I2=n111
XU215 ND2 $PINS O=n114 I1=n111 I2=n109
XU217 OR2B1 $PINS O=n87 I1=n117 B1=wen2
XU218 AO22 $PINS O=N136 A1=bank_rdata[0][0] A2=n122 B1=bank_rdata[1][0] B2=n943
XU219 AO22 $PINS O=N135 A1=bank_rdata[0][1] A2=n122 B1=bank_rdata[1][1] B2=n943
XU220 AO22 $PINS O=N134 A1=bank_rdata[0][2] A2=n122 B1=bank_rdata[1][2] B2=n943
XU221 AO22 $PINS O=N133 A1=bank_rdata[0][3] A2=n122 B1=bank_rdata[1][3] B2=n943
XU222 AO22 $PINS O=N132 A1=bank_rdata[0][4] A2=n122 B1=bank_rdata[1][4] B2=n943
XU223 AO22 $PINS O=N131 A1=bank_rdata[0][5] A2=n122 B1=bank_rdata[1][5] B2=n943
XU224 AO22 $PINS O=N130 A1=bank_rdata[0][6] A2=n122 B1=bank_rdata[1][6] B2=n943
XU225 AO22 $PINS O=N129 A1=bank_rdata[0][7] A2=n122 B1=bank_rdata[1][7] B2=n943
XU226 AO22 $PINS O=N128 A1=bank_rdata[0][8] A2=n122 B1=bank_rdata[1][8] B2=n943
XU227 AO22 $PINS O=N127 A1=bank_rdata[0][9] A2=n122 B1=bank_rdata[1][9] B2=n943
XU228 AO22 $PINS O=N126 A1=bank_rdata[0][10] A2=n122 B1=bank_rdata[1][10]
+ B2=n943
XU229 AO22 $PINS O=N125 A1=bank_rdata[0][11] A2=n122 B1=bank_rdata[1][11]
+ B2=n943
XU230 AO22 $PINS O=N124 A1=bank_rdata[0][12] A2=n122 B1=bank_rdata[1][12]
+ B2=n943
XU231 AO22 $PINS O=N123 A1=bank_rdata[0][13] A2=n122 B1=bank_rdata[1][13]
+ B2=n943
XU232 AO22 $PINS O=N122 A1=bank_rdata[0][14] A2=n122 B1=bank_rdata[1][14]
+ B2=n943
XU233 AO22 $PINS O=N121 A1=bank_rdata[0][15] A2=n122 B1=bank_rdata[1][15]
+ B2=n943
XU234 AO22 $PINS O=N120 A1=bank_rdata[0][16] A2=n122 B1=bank_rdata[1][16]
+ B2=n943
XU235 AO22 $PINS O=N119 A1=bank_rdata[0][17] A2=n122 B1=bank_rdata[1][17]
+ B2=n943
XU236 AO22 $PINS O=N118 A1=bank_rdata[0][18] A2=n122 B1=bank_rdata[1][18]
+ B2=n943
XU237 AO22 $PINS O=N117 A1=bank_rdata[0][19] A2=n122 B1=bank_rdata[1][19]
+ B2=n943
XU238 AO22 $PINS O=N116 A1=bank_rdata[0][20] A2=n122 B1=bank_rdata[1][20]
+ B2=n943
XU239 AO22 $PINS O=FE_PHN1453_N115 A1=bank_rdata[0][21] A2=n122
+ B1=bank_rdata[1][21] B2=n943
XU240 AO22 $PINS O=N114 A1=bank_rdata[0][22] A2=n122 B1=bank_rdata[1][22]
+ B2=n943
XU241 AO22 $PINS O=N113 A1=bank_rdata[0][23] A2=n122 B1=bank_rdata[1][23]
+ B2=n943
XU242 AO22 $PINS O=N112 A1=bank_rdata[0][24] A2=n122 B1=bank_rdata[1][24]
+ B2=n943
XU243 AO22 $PINS O=N111 A1=bank_rdata[0][25] A2=n122 B1=bank_rdata[1][25]
+ B2=n943
XU244 AO22 $PINS O=N110 A1=bank_rdata[0][26] A2=n122 B1=bank_rdata[1][26]
+ B2=n943
XU245 AO22 $PINS O=N109 A1=bank_rdata[0][27] A2=n122
+ B1=FE_PHN1133_bank_rdata_1_27 B2=n943
XU246 AO22 $PINS O=N108 A1=bank_rdata[0][28] A2=n122 B1=bank_rdata[1][28]
+ B2=n943
XU247 AO22 $PINS O=N107 A1=bank_rdata[0][29] A2=n122 B1=bank_rdata[1][29]
+ B2=n943
XU248 AO22 $PINS O=N106 A1=bank_rdata[0][30] A2=n122 B1=bank_rdata[1][30]
+ B2=n943
XU249 AO22 $PINS O=N105 A1=bank_rdata[0][31] A2=n122 B1=bank_rdata[1][31]
+ B2=n943
XU250 AO22 $PINS O=N104 A1=bank_rdata[0][32] A2=n122 B1=bank_rdata[1][32]
+ B2=n943
XU251 AO22 $PINS O=N103 A1=bank_rdata[0][33] A2=n122 B1=bank_rdata[1][33]
+ B2=n943
XU252 XOR4 $PINS O=n122 I1=read_addr_1[1] I2=read_addr_1[0] I3=n118
+ I4=read_addr_1[2]
XU253 ND2 $PINS O=n91 I1=n955 I2=n95
XU254 ND2 $PINS O=n119 I1=wen1 I2=n1025
XU255 ND2 $PINS O=n90 I1=n953 I2=n954
Xbank_mem_1_reg[4][33] QDFFN $PINS Q=bank_mem_1[4][33]
+ D=FE_OFN42_bank_wdata_1__33 CK=CTS_715
Xbank_mem_1_reg[4][32] QDFFN $PINS Q=bank_mem_1[4][32]
+ D=FE_OFN43_bank_wdata_1__32 CK=CTS_715
Xbank_mem_1_reg[4][31] QDFFN $PINS Q=bank_mem_1[4][31]
+ D=FE_OFN44_bank_wdata_1__31 CK=CTS_715
Xbank_mem_1_reg[4][30] QDFFN $PINS Q=bank_mem_1[4][30]
+ D=FE_OFN45_bank_wdata_1__30 CK=CTS_715
Xbank_mem_1_reg[4][29] QDFFN $PINS Q=bank_mem_1[4][29]
+ D=FE_OFN46_bank_wdata_1__29 CK=CTS_715
Xbank_mem_1_reg[4][28] QDFFN $PINS Q=bank_mem_1[4][28]
+ D=FE_OFN47_bank_wdata_1__28 CK=CTS_715
Xbank_mem_1_reg[4][27] QDFFN $PINS Q=bank_mem_1[4][27]
+ D=FE_OFN48_bank_wdata_1__27 CK=CTS_715
Xbank_mem_1_reg[4][26] QDFFN $PINS Q=bank_mem_1[4][26]
+ D=FE_OFN49_bank_wdata_1__26 CK=CTS_715
Xbank_mem_1_reg[4][25] QDFFN $PINS Q=bank_mem_1[4][25]
+ D=FE_OFN50_bank_wdata_1__25 CK=CTS_715
Xbank_mem_1_reg[4][24] QDFFN $PINS Q=bank_mem_1[4][24]
+ D=FE_OFN51_bank_wdata_1__24 CK=CTS_715
Xbank_mem_1_reg[4][23] QDFFN $PINS Q=bank_mem_1[4][23]
+ D=FE_OFN52_bank_wdata_1__23 CK=CTS_715
Xbank_mem_1_reg[4][22] QDFFN $PINS Q=bank_mem_1[4][22]
+ D=FE_OFN53_bank_wdata_1__22 CK=CTS_715
Xbank_mem_1_reg[4][21] QDFFN $PINS Q=bank_mem_1[4][21]
+ D=FE_OFN54_bank_wdata_1__21 CK=CTS_715
Xbank_mem_1_reg[4][20] QDFFN $PINS Q=bank_mem_1[4][20]
+ D=FE_OFN55_bank_wdata_1__20 CK=CTS_715
Xbank_mem_1_reg[4][19] QDFFN $PINS Q=bank_mem_1[4][19]
+ D=FE_OFN56_bank_wdata_1__19 CK=CTS_715
Xbank_mem_1_reg[4][18] QDFFN $PINS Q=bank_mem_1[4][18]
+ D=FE_OFN57_bank_wdata_1__18 CK=CTS_715
Xbank_mem_1_reg[4][17] QDFFN $PINS Q=bank_mem_1[4][17]
+ D=FE_OFN58_bank_wdata_1__17 CK=CTS_715
Xbank_mem_1_reg[4][16] QDFFN $PINS Q=bank_mem_1[4][16]
+ D=FE_OFN59_bank_wdata_1__16 CK=CTS_712
Xbank_mem_1_reg[4][15] QDFFN $PINS Q=bank_mem_1[4][15]
+ D=FE_OFN60_bank_wdata_1__15 CK=CTS_712
Xbank_mem_1_reg[4][14] QDFFN $PINS Q=bank_mem_1[4][14]
+ D=FE_OFN61_bank_wdata_1__14 CK=CTS_712
Xbank_mem_1_reg[4][13] QDFFN $PINS Q=bank_mem_1[4][13]
+ D=FE_OFN62_bank_wdata_1__13 CK=CTS_712
Xbank_mem_1_reg[4][12] QDFFN $PINS Q=bank_mem_1[4][12]
+ D=FE_OFN63_bank_wdata_1__12 CK=CTS_712
Xbank_mem_1_reg[4][11] QDFFN $PINS Q=bank_mem_1[4][11]
+ D=FE_OFN64_bank_wdata_1__11 CK=CTS_712
Xbank_mem_1_reg[4][10] QDFFN $PINS Q=bank_mem_1[4][10]
+ D=FE_OFN65_bank_wdata_1__10 CK=CTS_712
Xbank_mem_1_reg[4][9] QDFFN $PINS Q=bank_mem_1[4][9] D=FE_OFN66_bank_wdata_1__9
+ CK=CTS_712
Xbank_mem_1_reg[4][8] QDFFN $PINS Q=bank_mem_1[4][8] D=FE_OFN67_bank_wdata_1__8
+ CK=CTS_712
Xbank_mem_1_reg[4][7] QDFFN $PINS Q=bank_mem_1[4][7] D=FE_OFN68_bank_wdata_1__7
+ CK=CTS_712
Xbank_mem_1_reg[4][6] QDFFN $PINS Q=bank_mem_1[4][6] D=FE_OFN69_bank_wdata_1__6
+ CK=CTS_712
Xbank_mem_1_reg[4][5] QDFFN $PINS Q=bank_mem_1[4][5] D=FE_OFN70_bank_wdata_1__5
+ CK=CTS_712
Xbank_mem_1_reg[4][4] QDFFN $PINS Q=bank_mem_1[4][4] D=FE_OFN71_bank_wdata_1__4
+ CK=CTS_712
Xbank_mem_1_reg[4][3] QDFFN $PINS Q=bank_mem_1[4][3] D=FE_OFN72_bank_wdata_1__3
+ CK=CTS_712
Xbank_mem_1_reg[4][2] QDFFN $PINS Q=bank_mem_1[4][2] D=FE_OFN73_bank_wdata_1__2
+ CK=CTS_712
Xbank_mem_1_reg[4][1] QDFFN $PINS Q=bank_mem_1[4][1] D=FE_OFN74_bank_wdata_1__1
+ CK=CTS_712
Xbank_mem_1_reg[4][0] QDFFN $PINS Q=bank_mem_1[4][0] D=FE_OFN75_bank_wdata_1__0
+ CK=CTS_712
Xbank_mem_1_reg[6][33] QDFFN $PINS Q=bank_mem_1[6][33]
+ D=FE_OFN42_bank_wdata_1__33 CK=CTS_703
Xbank_mem_1_reg[6][32] QDFFN $PINS Q=bank_mem_1[6][32]
+ D=FE_OFN43_bank_wdata_1__32 CK=CTS_703
Xbank_mem_1_reg[6][31] QDFFN $PINS Q=bank_mem_1[6][31]
+ D=FE_OFN44_bank_wdata_1__31 CK=CTS_703
Xbank_mem_1_reg[6][30] QDFFN $PINS Q=bank_mem_1[6][30]
+ D=FE_OFN45_bank_wdata_1__30 CK=CTS_703
Xbank_mem_1_reg[6][29] QDFFN $PINS Q=bank_mem_1[6][29]
+ D=FE_OFN46_bank_wdata_1__29 CK=CTS_703
Xbank_mem_1_reg[6][28] QDFFN $PINS Q=bank_mem_1[6][28]
+ D=FE_OFN47_bank_wdata_1__28 CK=CTS_703
Xbank_mem_1_reg[6][27] QDFFN $PINS Q=bank_mem_1[6][27]
+ D=FE_OFN48_bank_wdata_1__27 CK=CTS_703
Xbank_mem_1_reg[6][26] QDFFN $PINS Q=bank_mem_1[6][26]
+ D=FE_OFN49_bank_wdata_1__26 CK=CTS_703
Xbank_mem_1_reg[6][25] QDFFN $PINS Q=bank_mem_1[6][25]
+ D=FE_OFN50_bank_wdata_1__25 CK=CTS_703
Xbank_mem_1_reg[6][24] QDFFN $PINS Q=bank_mem_1[6][24]
+ D=FE_OFN51_bank_wdata_1__24 CK=CTS_703
Xbank_mem_1_reg[6][23] QDFFN $PINS Q=bank_mem_1[6][23]
+ D=FE_OFN52_bank_wdata_1__23 CK=CTS_703
Xbank_mem_1_reg[6][22] QDFFN $PINS Q=bank_mem_1[6][22]
+ D=FE_OFN53_bank_wdata_1__22 CK=CTS_703
Xbank_mem_1_reg[6][21] QDFFN $PINS Q=bank_mem_1[6][21]
+ D=FE_OFN54_bank_wdata_1__21 CK=CTS_703
Xbank_mem_1_reg[6][20] QDFFN $PINS Q=bank_mem_1[6][20]
+ D=FE_OFN55_bank_wdata_1__20 CK=CTS_703
Xbank_mem_1_reg[6][19] QDFFN $PINS Q=bank_mem_1[6][19]
+ D=FE_OFN56_bank_wdata_1__19 CK=CTS_703
Xbank_mem_1_reg[6][18] QDFFN $PINS Q=bank_mem_1[6][18]
+ D=FE_OFN57_bank_wdata_1__18 CK=CTS_703
Xbank_mem_1_reg[6][17] QDFFN $PINS Q=bank_mem_1[6][17]
+ D=FE_OFN58_bank_wdata_1__17 CK=CTS_703
Xbank_mem_1_reg[6][16] QDFFN $PINS Q=bank_mem_1[6][16]
+ D=FE_OFN59_bank_wdata_1__16 CK=CTS_700
Xbank_mem_1_reg[6][15] QDFFN $PINS Q=bank_mem_1[6][15]
+ D=FE_OFN60_bank_wdata_1__15 CK=CTS_700
Xbank_mem_1_reg[6][14] QDFFN $PINS Q=bank_mem_1[6][14]
+ D=FE_OFN61_bank_wdata_1__14 CK=CTS_700
Xbank_mem_1_reg[6][13] QDFFN $PINS Q=bank_mem_1[6][13]
+ D=FE_OFN62_bank_wdata_1__13 CK=CTS_700
Xbank_mem_1_reg[6][12] QDFFN $PINS Q=bank_mem_1[6][12]
+ D=FE_OFN63_bank_wdata_1__12 CK=CTS_700
Xbank_mem_1_reg[6][11] QDFFN $PINS Q=bank_mem_1[6][11]
+ D=FE_OFN64_bank_wdata_1__11 CK=CTS_700
Xbank_mem_1_reg[6][10] QDFFN $PINS Q=bank_mem_1[6][10]
+ D=FE_OFN65_bank_wdata_1__10 CK=CTS_700
Xbank_mem_1_reg[6][9] QDFFN $PINS Q=bank_mem_1[6][9] D=FE_OFN66_bank_wdata_1__9
+ CK=CTS_700
Xbank_mem_1_reg[6][8] QDFFN $PINS Q=bank_mem_1[6][8] D=FE_OFN67_bank_wdata_1__8
+ CK=CTS_700
Xbank_mem_1_reg[6][7] QDFFN $PINS Q=bank_mem_1[6][7] D=FE_OFN68_bank_wdata_1__7
+ CK=CTS_700
Xbank_mem_1_reg[6][6] QDFFN $PINS Q=bank_mem_1[6][6] D=FE_OFN69_bank_wdata_1__6
+ CK=CTS_700
Xbank_mem_1_reg[6][5] QDFFN $PINS Q=bank_mem_1[6][5] D=FE_OFN70_bank_wdata_1__5
+ CK=CTS_700
Xbank_mem_1_reg[6][4] QDFFN $PINS Q=bank_mem_1[6][4] D=FE_OFN71_bank_wdata_1__4
+ CK=CTS_700
Xbank_mem_1_reg[6][3] QDFFN $PINS Q=bank_mem_1[6][3] D=FE_OFN72_bank_wdata_1__3
+ CK=CTS_700
Xbank_mem_1_reg[6][2] QDFFN $PINS Q=bank_mem_1[6][2] D=FE_OFN73_bank_wdata_1__2
+ CK=CTS_700
Xbank_mem_1_reg[6][1] QDFFN $PINS Q=bank_mem_1[6][1] D=FE_OFN74_bank_wdata_1__1
+ CK=CTS_700
Xbank_mem_1_reg[6][0] QDFFN $PINS Q=bank_mem_1[6][0] D=FE_OFN75_bank_wdata_1__0
+ CK=CTS_700
Xbank_mem_1_reg[2][33] QDFFN $PINS Q=bank_mem_1[2][33]
+ D=FE_OFN42_bank_wdata_1__33 CK=CTS_727
Xbank_mem_1_reg[2][32] QDFFN $PINS Q=bank_mem_1[2][32]
+ D=FE_OFN43_bank_wdata_1__32 CK=CTS_727
Xbank_mem_1_reg[2][31] QDFFN $PINS Q=bank_mem_1[2][31]
+ D=FE_OFN44_bank_wdata_1__31 CK=CTS_727
Xbank_mem_1_reg[2][30] QDFFN $PINS Q=bank_mem_1[2][30]
+ D=FE_OFN45_bank_wdata_1__30 CK=CTS_727
Xbank_mem_1_reg[2][29] QDFFN $PINS Q=bank_mem_1[2][29]
+ D=FE_OFN46_bank_wdata_1__29 CK=CTS_727
Xbank_mem_1_reg[2][28] QDFFN $PINS Q=bank_mem_1[2][28]
+ D=FE_OFN47_bank_wdata_1__28 CK=CTS_727
Xbank_mem_1_reg[2][27] QDFFN $PINS Q=bank_mem_1[2][27]
+ D=FE_OFN48_bank_wdata_1__27 CK=CTS_727
Xbank_mem_1_reg[2][26] QDFFN $PINS Q=bank_mem_1[2][26]
+ D=FE_OFN49_bank_wdata_1__26 CK=CTS_727
Xbank_mem_1_reg[2][25] QDFFN $PINS Q=bank_mem_1[2][25]
+ D=FE_OFN50_bank_wdata_1__25 CK=CTS_727
Xbank_mem_1_reg[2][24] QDFFN $PINS Q=bank_mem_1[2][24]
+ D=FE_OFN51_bank_wdata_1__24 CK=CTS_727
Xbank_mem_1_reg[2][23] QDFFN $PINS Q=bank_mem_1[2][23]
+ D=FE_OFN52_bank_wdata_1__23 CK=CTS_727
Xbank_mem_1_reg[2][22] QDFFN $PINS Q=bank_mem_1[2][22]
+ D=FE_OFN53_bank_wdata_1__22 CK=CTS_727
Xbank_mem_1_reg[2][21] QDFFN $PINS Q=bank_mem_1[2][21]
+ D=FE_OFN54_bank_wdata_1__21 CK=CTS_727
Xbank_mem_1_reg[2][20] QDFFN $PINS Q=bank_mem_1[2][20]
+ D=FE_OFN55_bank_wdata_1__20 CK=CTS_727
Xbank_mem_1_reg[2][19] QDFFN $PINS Q=bank_mem_1[2][19]
+ D=FE_OFN56_bank_wdata_1__19 CK=CTS_727
Xbank_mem_1_reg[2][18] QDFFN $PINS Q=bank_mem_1[2][18]
+ D=FE_OFN57_bank_wdata_1__18 CK=CTS_727
Xbank_mem_1_reg[2][17] QDFFN $PINS Q=bank_mem_1[2][17]
+ D=FE_OFN58_bank_wdata_1__17 CK=CTS_727
Xbank_mem_1_reg[2][16] QDFFN $PINS Q=bank_mem_1[2][16]
+ D=FE_OFN59_bank_wdata_1__16 CK=CTS_724
Xbank_mem_1_reg[2][15] QDFFN $PINS Q=bank_mem_1[2][15]
+ D=FE_OFN60_bank_wdata_1__15 CK=CTS_724
Xbank_mem_1_reg[2][14] QDFFN $PINS Q=bank_mem_1[2][14]
+ D=FE_OFN61_bank_wdata_1__14 CK=CTS_724
Xbank_mem_1_reg[2][13] QDFFN $PINS Q=bank_mem_1[2][13]
+ D=FE_OFN62_bank_wdata_1__13 CK=CTS_724
Xbank_mem_1_reg[2][12] QDFFN $PINS Q=bank_mem_1[2][12]
+ D=FE_OFN63_bank_wdata_1__12 CK=CTS_724
Xbank_mem_1_reg[2][11] QDFFN $PINS Q=bank_mem_1[2][11]
+ D=FE_OFN64_bank_wdata_1__11 CK=CTS_724
Xbank_mem_1_reg[2][10] QDFFN $PINS Q=bank_mem_1[2][10]
+ D=FE_OFN65_bank_wdata_1__10 CK=CTS_724
Xbank_mem_1_reg[2][9] QDFFN $PINS Q=bank_mem_1[2][9] D=FE_OFN66_bank_wdata_1__9
+ CK=CTS_724
Xbank_mem_1_reg[2][8] QDFFN $PINS Q=bank_mem_1[2][8] D=FE_OFN67_bank_wdata_1__8
+ CK=CTS_724
Xbank_mem_1_reg[2][7] QDFFN $PINS Q=bank_mem_1[2][7] D=FE_OFN68_bank_wdata_1__7
+ CK=CTS_724
Xbank_mem_1_reg[2][6] QDFFN $PINS Q=bank_mem_1[2][6] D=FE_OFN69_bank_wdata_1__6
+ CK=CTS_724
Xbank_mem_1_reg[2][5] QDFFN $PINS Q=bank_mem_1[2][5] D=FE_OFN70_bank_wdata_1__5
+ CK=CTS_724
Xbank_mem_1_reg[2][4] QDFFN $PINS Q=bank_mem_1[2][4] D=FE_OFN71_bank_wdata_1__4
+ CK=CTS_724
Xbank_mem_1_reg[2][3] QDFFN $PINS Q=bank_mem_1[2][3] D=FE_OFN72_bank_wdata_1__3
+ CK=CTS_724
Xbank_mem_1_reg[2][2] QDFFN $PINS Q=bank_mem_1[2][2] D=FE_OFN73_bank_wdata_1__2
+ CK=CTS_724
Xbank_mem_1_reg[2][1] QDFFN $PINS Q=bank_mem_1[2][1] D=FE_OFN74_bank_wdata_1__1
+ CK=CTS_724
Xbank_mem_1_reg[2][0] QDFFN $PINS Q=bank_mem_1[2][0] D=FE_OFN75_bank_wdata_1__0
+ CK=CTS_724
Xbank_mem_1_reg[7][32] QDFFN $PINS Q=bank_mem_1[7][32]
+ D=FE_OFN43_bank_wdata_1__32 CK=CTS_697
Xbank_mem_1_reg[7][31] QDFFN $PINS Q=bank_mem_1[7][31]
+ D=FE_OFN44_bank_wdata_1__31 CK=CTS_697
Xbank_mem_1_reg[7][30] QDFFN $PINS Q=bank_mem_1[7][30]
+ D=FE_OFN45_bank_wdata_1__30 CK=CTS_697
Xbank_mem_1_reg[7][29] QDFFN $PINS Q=bank_mem_1[7][29]
+ D=FE_OFN46_bank_wdata_1__29 CK=CTS_697
Xbank_mem_1_reg[7][28] QDFFN $PINS Q=bank_mem_1[7][28]
+ D=FE_OFN47_bank_wdata_1__28 CK=CTS_697
Xbank_mem_1_reg[7][27] QDFFN $PINS Q=bank_mem_1[7][27]
+ D=FE_OFN48_bank_wdata_1__27 CK=CTS_697
Xbank_mem_1_reg[7][26] QDFFN $PINS Q=bank_mem_1[7][26]
+ D=FE_OFN49_bank_wdata_1__26 CK=CTS_697
Xbank_mem_1_reg[7][25] QDFFN $PINS Q=bank_mem_1[7][25]
+ D=FE_OFN50_bank_wdata_1__25 CK=CTS_697
Xbank_mem_1_reg[7][24] QDFFN $PINS Q=bank_mem_1[7][24]
+ D=FE_OFN51_bank_wdata_1__24 CK=CTS_697
Xbank_mem_1_reg[7][23] QDFFN $PINS Q=bank_mem_1[7][23]
+ D=FE_OFN52_bank_wdata_1__23 CK=CTS_697
Xbank_mem_1_reg[7][22] QDFFN $PINS Q=bank_mem_1[7][22]
+ D=FE_OFN53_bank_wdata_1__22 CK=CTS_697
Xbank_mem_1_reg[7][21] QDFFN $PINS Q=bank_mem_1[7][21]
+ D=FE_OFN54_bank_wdata_1__21 CK=CTS_697
Xbank_mem_1_reg[7][20] QDFFN $PINS Q=bank_mem_1[7][20]
+ D=FE_OFN55_bank_wdata_1__20 CK=CTS_697
Xbank_mem_1_reg[7][19] QDFFN $PINS Q=bank_mem_1[7][19]
+ D=FE_OFN56_bank_wdata_1__19 CK=CTS_697
Xbank_mem_1_reg[7][18] QDFFN $PINS Q=bank_mem_1[7][18]
+ D=FE_OFN57_bank_wdata_1__18 CK=CTS_697
Xbank_mem_1_reg[7][17] QDFFN $PINS Q=bank_mem_1[7][17]
+ D=FE_OFN58_bank_wdata_1__17 CK=CTS_697
Xbank_mem_1_reg[7][16] QDFFN $PINS Q=bank_mem_1[7][16]
+ D=FE_OFN59_bank_wdata_1__16 CK=CTS_689
Xbank_mem_1_reg[7][15] QDFFN $PINS Q=bank_mem_1[7][15]
+ D=FE_OFN60_bank_wdata_1__15 CK=CTS_689
Xbank_mem_1_reg[7][14] QDFFN $PINS Q=bank_mem_1[7][14]
+ D=FE_OFN61_bank_wdata_1__14 CK=CTS_689
Xbank_mem_1_reg[7][13] QDFFN $PINS Q=bank_mem_1[7][13]
+ D=FE_OFN62_bank_wdata_1__13 CK=CTS_689
Xbank_mem_1_reg[7][12] QDFFN $PINS Q=bank_mem_1[7][12]
+ D=FE_OFN63_bank_wdata_1__12 CK=CTS_689
Xbank_mem_1_reg[7][11] QDFFN $PINS Q=bank_mem_1[7][11]
+ D=FE_OFN64_bank_wdata_1__11 CK=CTS_689
Xbank_mem_1_reg[7][10] QDFFN $PINS Q=bank_mem_1[7][10]
+ D=FE_OFN65_bank_wdata_1__10 CK=CTS_689
Xbank_mem_1_reg[7][9] QDFFN $PINS Q=bank_mem_1[7][9] D=FE_OFN66_bank_wdata_1__9
+ CK=CTS_689
Xbank_mem_1_reg[7][8] QDFFN $PINS Q=bank_mem_1[7][8] D=FE_OFN67_bank_wdata_1__8
+ CK=CTS_689
Xbank_mem_1_reg[7][7] QDFFN $PINS Q=bank_mem_1[7][7] D=FE_OFN68_bank_wdata_1__7
+ CK=CTS_689
Xbank_mem_1_reg[7][6] QDFFN $PINS Q=bank_mem_1[7][6] D=FE_OFN69_bank_wdata_1__6
+ CK=CTS_689
Xbank_mem_1_reg[7][5] QDFFN $PINS Q=bank_mem_1[7][5] D=FE_OFN70_bank_wdata_1__5
+ CK=CTS_689
Xbank_mem_1_reg[7][4] QDFFN $PINS Q=bank_mem_1[7][4] D=FE_OFN71_bank_wdata_1__4
+ CK=CTS_689
Xbank_mem_1_reg[7][3] QDFFN $PINS Q=bank_mem_1[7][3] D=FE_OFN72_bank_wdata_1__3
+ CK=CTS_689
Xbank_mem_1_reg[7][2] QDFFN $PINS Q=bank_mem_1[7][2] D=FE_OFN73_bank_wdata_1__2
+ CK=CTS_689
Xbank_mem_1_reg[7][1] QDFFN $PINS Q=bank_mem_1[7][1] D=FE_OFN74_bank_wdata_1__1
+ CK=CTS_689
Xbank_mem_1_reg[7][0] QDFFN $PINS Q=bank_mem_1[7][0] D=FE_OFN75_bank_wdata_1__0
+ CK=CTS_689
Xbank_mem_1_reg[7][33] QDFFN $PINS Q=bank_mem_1[7][33]
+ D=FE_OFN42_bank_wdata_1__33 CK=CTS_697
Xbank_mem_1_reg[3][33] QDFFN $PINS Q=bank_mem_1[3][33]
+ D=FE_OFN42_bank_wdata_1__33 CK=CTS_721
Xbank_mem_1_reg[3][32] QDFFN $PINS Q=bank_mem_1[3][32]
+ D=FE_OFN43_bank_wdata_1__32 CK=CTS_721
Xbank_mem_1_reg[3][31] QDFFN $PINS Q=bank_mem_1[3][31]
+ D=FE_OFN44_bank_wdata_1__31 CK=CTS_721
Xbank_mem_1_reg[3][30] QDFFN $PINS Q=bank_mem_1[3][30]
+ D=FE_OFN45_bank_wdata_1__30 CK=CTS_721
Xbank_mem_1_reg[3][29] QDFFN $PINS Q=bank_mem_1[3][29]
+ D=FE_OFN46_bank_wdata_1__29 CK=CTS_721
Xbank_mem_1_reg[3][28] QDFFN $PINS Q=bank_mem_1[3][28]
+ D=FE_OFN47_bank_wdata_1__28 CK=CTS_721
Xbank_mem_1_reg[3][27] QDFFN $PINS Q=bank_mem_1[3][27]
+ D=FE_OFN48_bank_wdata_1__27 CK=CTS_721
Xbank_mem_1_reg[3][26] QDFFN $PINS Q=bank_mem_1[3][26]
+ D=FE_OFN49_bank_wdata_1__26 CK=CTS_721
Xbank_mem_1_reg[3][25] QDFFN $PINS Q=bank_mem_1[3][25]
+ D=FE_OFN50_bank_wdata_1__25 CK=CTS_721
Xbank_mem_1_reg[3][24] QDFFN $PINS Q=bank_mem_1[3][24]
+ D=FE_OFN51_bank_wdata_1__24 CK=CTS_721
Xbank_mem_1_reg[3][23] QDFFN $PINS Q=bank_mem_1[3][23]
+ D=FE_OFN52_bank_wdata_1__23 CK=CTS_721
Xbank_mem_1_reg[3][22] QDFFN $PINS Q=bank_mem_1[3][22]
+ D=FE_OFN53_bank_wdata_1__22 CK=CTS_721
Xbank_mem_1_reg[3][21] QDFFN $PINS Q=bank_mem_1[3][21]
+ D=FE_OFN54_bank_wdata_1__21 CK=CTS_721
Xbank_mem_1_reg[3][20] QDFFN $PINS Q=bank_mem_1[3][20]
+ D=FE_OFN55_bank_wdata_1__20 CK=CTS_721
Xbank_mem_1_reg[3][19] QDFFN $PINS Q=bank_mem_1[3][19]
+ D=FE_OFN56_bank_wdata_1__19 CK=CTS_721
Xbank_mem_1_reg[3][18] QDFFN $PINS Q=bank_mem_1[3][18]
+ D=FE_OFN57_bank_wdata_1__18 CK=CTS_721
Xbank_mem_1_reg[3][17] QDFFN $PINS Q=bank_mem_1[3][17]
+ D=FE_OFN58_bank_wdata_1__17 CK=CTS_721
Xbank_mem_1_reg[3][16] QDFFN $PINS Q=bank_mem_1[3][16]
+ D=FE_OFN59_bank_wdata_1__16 CK=CTS_718
Xbank_mem_1_reg[3][15] QDFFN $PINS Q=bank_mem_1[3][15]
+ D=FE_OFN60_bank_wdata_1__15 CK=CTS_718
Xbank_mem_1_reg[3][14] QDFFN $PINS Q=bank_mem_1[3][14]
+ D=FE_OFN61_bank_wdata_1__14 CK=CTS_718
Xbank_mem_1_reg[3][13] QDFFN $PINS Q=bank_mem_1[3][13]
+ D=FE_OFN62_bank_wdata_1__13 CK=CTS_718
Xbank_mem_1_reg[3][12] QDFFN $PINS Q=bank_mem_1[3][12]
+ D=FE_OFN63_bank_wdata_1__12 CK=CTS_718
Xbank_mem_1_reg[3][11] QDFFN $PINS Q=bank_mem_1[3][11]
+ D=FE_OFN64_bank_wdata_1__11 CK=CTS_718
Xbank_mem_1_reg[3][10] QDFFN $PINS Q=bank_mem_1[3][10]
+ D=FE_OFN65_bank_wdata_1__10 CK=CTS_718
Xbank_mem_1_reg[3][9] QDFFN $PINS Q=bank_mem_1[3][9] D=FE_OFN66_bank_wdata_1__9
+ CK=CTS_718
Xbank_mem_1_reg[3][8] QDFFN $PINS Q=bank_mem_1[3][8] D=FE_OFN67_bank_wdata_1__8
+ CK=CTS_718
Xbank_mem_1_reg[3][7] QDFFN $PINS Q=bank_mem_1[3][7] D=FE_OFN68_bank_wdata_1__7
+ CK=CTS_718
Xbank_mem_1_reg[3][6] QDFFN $PINS Q=bank_mem_1[3][6] D=FE_OFN69_bank_wdata_1__6
+ CK=CTS_718
Xbank_mem_1_reg[3][5] QDFFN $PINS Q=bank_mem_1[3][5] D=FE_OFN70_bank_wdata_1__5
+ CK=CTS_718
Xbank_mem_1_reg[3][4] QDFFN $PINS Q=bank_mem_1[3][4] D=FE_OFN71_bank_wdata_1__4
+ CK=CTS_718
Xbank_mem_1_reg[3][3] QDFFN $PINS Q=bank_mem_1[3][3] D=FE_OFN72_bank_wdata_1__3
+ CK=CTS_718
Xbank_mem_1_reg[3][2] QDFFN $PINS Q=bank_mem_1[3][2] D=FE_OFN73_bank_wdata_1__2
+ CK=CTS_718
Xbank_mem_1_reg[3][1] QDFFN $PINS Q=bank_mem_1[3][1] D=FE_OFN74_bank_wdata_1__1
+ CK=CTS_718
Xbank_mem_1_reg[3][0] QDFFN $PINS Q=bank_mem_1[3][0] D=FE_OFN75_bank_wdata_1__0
+ CK=CTS_718
Xbank_mem_1_reg[5][33] QDFFN $PINS Q=bank_mem_1[5][33]
+ D=FE_OFN42_bank_wdata_1__33 CK=CTS_709
Xbank_mem_1_reg[5][32] QDFFN $PINS Q=bank_mem_1[5][32]
+ D=FE_OFN43_bank_wdata_1__32 CK=CTS_709
Xbank_mem_1_reg[5][31] QDFFN $PINS Q=bank_mem_1[5][31]
+ D=FE_OFN44_bank_wdata_1__31 CK=CTS_709
Xbank_mem_1_reg[5][30] QDFFN $PINS Q=bank_mem_1[5][30]
+ D=FE_OFN45_bank_wdata_1__30 CK=CTS_709
Xbank_mem_1_reg[5][29] QDFFN $PINS Q=bank_mem_1[5][29]
+ D=FE_OFN46_bank_wdata_1__29 CK=CTS_709
Xbank_mem_1_reg[5][28] QDFFN $PINS Q=bank_mem_1[5][28]
+ D=FE_OFN47_bank_wdata_1__28 CK=CTS_709
Xbank_mem_1_reg[5][27] QDFFN $PINS Q=bank_mem_1[5][27]
+ D=FE_OFN48_bank_wdata_1__27 CK=CTS_709
Xbank_mem_1_reg[5][26] QDFFN $PINS Q=bank_mem_1[5][26]
+ D=FE_OFN49_bank_wdata_1__26 CK=CTS_709
Xbank_mem_1_reg[5][25] QDFFN $PINS Q=bank_mem_1[5][25]
+ D=FE_OFN50_bank_wdata_1__25 CK=CTS_709
Xbank_mem_1_reg[5][24] QDFFN $PINS Q=bank_mem_1[5][24]
+ D=FE_OFN51_bank_wdata_1__24 CK=CTS_709
Xbank_mem_1_reg[5][23] QDFFN $PINS Q=bank_mem_1[5][23]
+ D=FE_OFN52_bank_wdata_1__23 CK=CTS_709
Xbank_mem_1_reg[5][22] QDFFN $PINS Q=bank_mem_1[5][22]
+ D=FE_OFN53_bank_wdata_1__22 CK=CTS_709
Xbank_mem_1_reg[5][21] QDFFN $PINS Q=bank_mem_1[5][21]
+ D=FE_OFN54_bank_wdata_1__21 CK=CTS_709
Xbank_mem_1_reg[5][20] QDFFN $PINS Q=bank_mem_1[5][20]
+ D=FE_OFN55_bank_wdata_1__20 CK=CTS_709
Xbank_mem_1_reg[5][19] QDFFN $PINS Q=bank_mem_1[5][19]
+ D=FE_OFN56_bank_wdata_1__19 CK=CTS_709
Xbank_mem_1_reg[5][18] QDFFN $PINS Q=bank_mem_1[5][18]
+ D=FE_OFN57_bank_wdata_1__18 CK=CTS_709
Xbank_mem_1_reg[5][17] QDFFN $PINS Q=bank_mem_1[5][17]
+ D=FE_OFN58_bank_wdata_1__17 CK=CTS_709
Xbank_mem_1_reg[5][16] QDFFN $PINS Q=bank_mem_1[5][16]
+ D=FE_OFN59_bank_wdata_1__16 CK=CTS_706
Xbank_mem_1_reg[5][15] QDFFN $PINS Q=bank_mem_1[5][15]
+ D=FE_OFN60_bank_wdata_1__15 CK=CTS_706
Xbank_mem_1_reg[5][14] QDFFN $PINS Q=bank_mem_1[5][14]
+ D=FE_OFN61_bank_wdata_1__14 CK=CTS_706
Xbank_mem_1_reg[5][13] QDFFN $PINS Q=bank_mem_1[5][13]
+ D=FE_OFN62_bank_wdata_1__13 CK=CTS_706
Xbank_mem_1_reg[5][12] QDFFN $PINS Q=bank_mem_1[5][12]
+ D=FE_OFN63_bank_wdata_1__12 CK=CTS_706
Xbank_mem_1_reg[5][11] QDFFN $PINS Q=bank_mem_1[5][11]
+ D=FE_OFN64_bank_wdata_1__11 CK=CTS_706
Xbank_mem_1_reg[5][10] QDFFN $PINS Q=bank_mem_1[5][10]
+ D=FE_OFN65_bank_wdata_1__10 CK=CTS_706
Xbank_mem_1_reg[5][9] QDFFN $PINS Q=bank_mem_1[5][9] D=FE_OFN66_bank_wdata_1__9
+ CK=CTS_706
Xbank_mem_1_reg[5][8] QDFFN $PINS Q=bank_mem_1[5][8] D=FE_OFN67_bank_wdata_1__8
+ CK=CTS_706
Xbank_mem_1_reg[5][7] QDFFN $PINS Q=bank_mem_1[5][7] D=FE_OFN68_bank_wdata_1__7
+ CK=CTS_706
Xbank_mem_1_reg[5][6] QDFFN $PINS Q=bank_mem_1[5][6] D=FE_OFN69_bank_wdata_1__6
+ CK=CTS_706
Xbank_mem_1_reg[5][5] QDFFN $PINS Q=bank_mem_1[5][5] D=FE_OFN70_bank_wdata_1__5
+ CK=CTS_706
Xbank_mem_1_reg[5][4] QDFFN $PINS Q=bank_mem_1[5][4] D=FE_OFN71_bank_wdata_1__4
+ CK=CTS_706
Xbank_mem_1_reg[5][3] QDFFN $PINS Q=bank_mem_1[5][3] D=FE_OFN72_bank_wdata_1__3
+ CK=CTS_706
Xbank_mem_1_reg[5][2] QDFFN $PINS Q=bank_mem_1[5][2] D=FE_OFN73_bank_wdata_1__2
+ CK=CTS_706
Xbank_mem_1_reg[5][1] QDFFN $PINS Q=bank_mem_1[5][1] D=FE_OFN74_bank_wdata_1__1
+ CK=CTS_706
Xbank_mem_1_reg[5][0] QDFFN $PINS Q=bank_mem_1[5][0] D=FE_OFN75_bank_wdata_1__0
+ CK=CTS_706
Xbank_mem_0_reg[4][33] QDFFN $PINS Q=bank_mem_0[4][33]
+ D=FE_PHN1356_FE_OFN77_bank_wdata_0__33 CK=CTS_758
Xbank_mem_0_reg[4][32] QDFFN $PINS Q=bank_mem_0[4][32]
+ D=FE_OFN78_bank_wdata_0__32 CK=CTS_758
Xbank_mem_0_reg[4][31] QDFFN $PINS Q=bank_mem_0[4][31]
+ D=FE_PHN1451_FE_OFN79_bank_wdata_0__31 CK=CTS_758
Xbank_mem_0_reg[4][30] QDFFN $PINS Q=bank_mem_0[4][30]
+ D=FE_PHN1446_FE_OFN80_bank_wdata_0__30 CK=CTS_758
Xbank_mem_0_reg[4][29] QDFFN $PINS Q=bank_mem_0[4][29]
+ D=FE_PHN1411_FE_OFN81_bank_wdata_0__29 CK=CTS_758
Xbank_mem_0_reg[4][28] QDFFN $PINS Q=bank_mem_0[4][28]
+ D=FE_PHN1415_FE_OFN82_bank_wdata_0__28 CK=CTS_758
Xbank_mem_0_reg[4][27] QDFFN $PINS Q=bank_mem_0[4][27]
+ D=FE_PHN1450_bank_wdata_0_27 CK=CTS_758
Xbank_mem_0_reg[4][26] QDFFN $PINS Q=bank_mem_0[4][26]
+ D=FE_OFN83_bank_wdata_0__26 CK=CTS_758
Xbank_mem_0_reg[4][25] QDFFN $PINS Q=bank_mem_0[4][25]
+ D=FE_OFN84_bank_wdata_0__25 CK=CTS_758
Xbank_mem_0_reg[4][24] QDFFN $PINS Q=bank_mem_0[4][24]
+ D=FE_OFN85_bank_wdata_0__24 CK=CTS_758
Xbank_mem_0_reg[4][23] QDFFN $PINS Q=bank_mem_0[4][23]
+ D=FE_OFN86_bank_wdata_0__23 CK=CTS_758
Xbank_mem_0_reg[4][22] QDFFN $PINS Q=bank_mem_0[4][22]
+ D=FE_OFN87_bank_wdata_0__22 CK=CTS_758
Xbank_mem_0_reg[4][21] QDFFN $PINS Q=bank_mem_0[4][21]
+ D=FE_OFN88_bank_wdata_0__21 CK=CTS_758
Xbank_mem_0_reg[4][20] QDFFN $PINS Q=bank_mem_0[4][20]
+ D=FE_OFN89_bank_wdata_0__20 CK=CTS_758
Xbank_mem_0_reg[4][19] QDFFN $PINS Q=bank_mem_0[4][19]
+ D=FE_OFN90_bank_wdata_0__19 CK=CTS_758
Xbank_mem_0_reg[4][18] QDFFN $PINS Q=bank_mem_0[4][18]
+ D=FE_OFN91_bank_wdata_0__18 CK=CTS_758
Xbank_mem_0_reg[4][17] QDFFN $PINS Q=bank_mem_0[4][17]
+ D=FE_OFN92_bank_wdata_0__17 CK=CTS_758
Xbank_mem_0_reg[4][16] QDFFN $PINS Q=bank_mem_0[4][16]
+ D=FE_OFN93_bank_wdata_0__16 CK=CTS_755
Xbank_mem_0_reg[4][15] QDFFN $PINS Q=bank_mem_0[4][15]
+ D=FE_PHN1017_FE_OFN94_bank_wdata_0__15 CK=CTS_755
Xbank_mem_0_reg[4][14] QDFFN $PINS Q=bank_mem_0[4][14]
+ D=FE_OFN95_bank_wdata_0__14 CK=CTS_755
Xbank_mem_0_reg[4][13] QDFFN $PINS Q=bank_mem_0[4][13]
+ D=FE_PHN1092_FE_OFN96_bank_wdata_0__13 CK=CTS_755
Xbank_mem_0_reg[4][12] QDFFN $PINS Q=bank_mem_0[4][12]
+ D=FE_PHN1124_FE_OFN97_bank_wdata_0__12 CK=CTS_755
Xbank_mem_0_reg[4][11] QDFFN $PINS Q=bank_mem_0[4][11]
+ D=FE_OFN98_bank_wdata_0__11 CK=CTS_755
Xbank_mem_0_reg[4][10] QDFFN $PINS Q=bank_mem_0[4][10]
+ D=FE_PHN1530_FE_OFN99_bank_wdata_0__10 CK=CTS_755
Xbank_mem_0_reg[4][9] QDFFN $PINS Q=bank_mem_0[4][9]
+ D=FE_OFN100_bank_wdata_0__9 CK=CTS_755
Xbank_mem_0_reg[4][8] QDFFN $PINS Q=bank_mem_0[4][8]
+ D=FE_OFN101_bank_wdata_0__8 CK=CTS_755
Xbank_mem_0_reg[4][7] QDFFN $PINS Q=bank_mem_0[4][7]
+ D=FE_OFN102_bank_wdata_0__7 CK=CTS_755
Xbank_mem_0_reg[4][6] QDFFN $PINS Q=bank_mem_0[4][6]
+ D=FE_OFN103_bank_wdata_0__6 CK=CTS_755
Xbank_mem_0_reg[4][5] QDFFN $PINS Q=bank_mem_0[4][5]
+ D=FE_OFN104_bank_wdata_0__5 CK=CTS_755
Xbank_mem_0_reg[4][4] QDFFN $PINS Q=bank_mem_0[4][4]
+ D=FE_OFN105_bank_wdata_0__4 CK=CTS_755
Xbank_mem_0_reg[4][3] QDFFN $PINS Q=bank_mem_0[4][3]
+ D=FE_OFN106_bank_wdata_0__3 CK=CTS_755
Xbank_mem_0_reg[4][2] QDFFN $PINS Q=bank_mem_0[4][2]
+ D=FE_OFN107_bank_wdata_0__2 CK=CTS_755
Xbank_mem_0_reg[4][1] QDFFN $PINS Q=bank_mem_0[4][1]
+ D=FE_OFN108_bank_wdata_0__1 CK=CTS_755
Xbank_mem_0_reg[4][0] QDFFN $PINS Q=bank_mem_0[4][0]
+ D=FE_OFN109_bank_wdata_0__0 CK=CTS_755
Xbank_mem_0_reg[6][33] QDFFN $PINS Q=bank_mem_0[6][33]
+ D=FE_PHN1356_FE_OFN77_bank_wdata_0__33 CK=CTS_749
Xbank_mem_0_reg[6][32] QDFFN $PINS Q=bank_mem_0[6][32]
+ D=FE_OFN78_bank_wdata_0__32 CK=CTS_749
Xbank_mem_0_reg[6][31] QDFFN $PINS Q=bank_mem_0[6][31]
+ D=FE_PHN1451_FE_OFN79_bank_wdata_0__31 CK=CTS_749
Xbank_mem_0_reg[6][30] QDFFN $PINS Q=bank_mem_0[6][30]
+ D=FE_PHN1446_FE_OFN80_bank_wdata_0__30 CK=CTS_749
Xbank_mem_0_reg[6][29] QDFFN $PINS Q=bank_mem_0[6][29]
+ D=FE_PHN1411_FE_OFN81_bank_wdata_0__29 CK=CTS_749
Xbank_mem_0_reg[6][28] QDFFN $PINS Q=bank_mem_0[6][28]
+ D=FE_PHN1415_FE_OFN82_bank_wdata_0__28 CK=CTS_749
Xbank_mem_0_reg[6][27] QDFFN $PINS Q=bank_mem_0[6][27]
+ D=FE_PHN1450_bank_wdata_0_27 CK=CTS_749
Xbank_mem_0_reg[6][26] QDFFN $PINS Q=bank_mem_0[6][26]
+ D=FE_OFN83_bank_wdata_0__26 CK=CTS_749
Xbank_mem_0_reg[6][25] QDFFN $PINS Q=bank_mem_0[6][25]
+ D=FE_OFN84_bank_wdata_0__25 CK=CTS_749
Xbank_mem_0_reg[6][24] QDFFN $PINS Q=bank_mem_0[6][24]
+ D=FE_OFN85_bank_wdata_0__24 CK=CTS_749
Xbank_mem_0_reg[6][23] QDFFN $PINS Q=bank_mem_0[6][23]
+ D=FE_OFN86_bank_wdata_0__23 CK=CTS_749
Xbank_mem_0_reg[6][22] QDFFN $PINS Q=bank_mem_0[6][22]
+ D=FE_OFN87_bank_wdata_0__22 CK=CTS_749
Xbank_mem_0_reg[6][21] QDFFN $PINS Q=bank_mem_0[6][21]
+ D=FE_OFN88_bank_wdata_0__21 CK=CTS_749
Xbank_mem_0_reg[6][20] QDFFN $PINS Q=bank_mem_0[6][20]
+ D=FE_OFN89_bank_wdata_0__20 CK=CTS_749
Xbank_mem_0_reg[6][19] QDFFN $PINS Q=bank_mem_0[6][19]
+ D=FE_OFN90_bank_wdata_0__19 CK=CTS_749
Xbank_mem_0_reg[6][18] QDFFN $PINS Q=bank_mem_0[6][18]
+ D=FE_OFN91_bank_wdata_0__18 CK=CTS_749
Xbank_mem_0_reg[6][17] QDFFN $PINS Q=bank_mem_0[6][17]
+ D=FE_OFN92_bank_wdata_0__17 CK=CTS_749
Xbank_mem_0_reg[6][16] QDFFN $PINS Q=bank_mem_0[6][16]
+ D=FE_OFN93_bank_wdata_0__16 CK=CTS_746
Xbank_mem_0_reg[6][15] QDFFN $PINS Q=bank_mem_0[6][15]
+ D=FE_PHN1017_FE_OFN94_bank_wdata_0__15 CK=CTS_746
Xbank_mem_0_reg[6][14] QDFFN $PINS Q=bank_mem_0[6][14]
+ D=FE_OFN95_bank_wdata_0__14 CK=CTS_746
Xbank_mem_0_reg[6][13] QDFFN $PINS Q=bank_mem_0[6][13]
+ D=FE_PHN1092_FE_OFN96_bank_wdata_0__13 CK=CTS_746
Xbank_mem_0_reg[6][12] QDFFN $PINS Q=bank_mem_0[6][12]
+ D=FE_PHN1124_FE_OFN97_bank_wdata_0__12 CK=CTS_746
Xbank_mem_0_reg[6][11] QDFFN $PINS Q=bank_mem_0[6][11]
+ D=FE_OFN98_bank_wdata_0__11 CK=CTS_746
Xbank_mem_0_reg[6][10] QDFFN $PINS Q=bank_mem_0[6][10]
+ D=FE_OFN99_bank_wdata_0__10 CK=CTS_746
Xbank_mem_0_reg[6][9] QDFFN $PINS Q=bank_mem_0[6][9]
+ D=FE_OFN100_bank_wdata_0__9 CK=CTS_746
Xbank_mem_0_reg[6][8] QDFFN $PINS Q=bank_mem_0[6][8]
+ D=FE_OFN101_bank_wdata_0__8 CK=CTS_746
Xbank_mem_0_reg[6][7] QDFFN $PINS Q=bank_mem_0[6][7]
+ D=FE_OFN102_bank_wdata_0__7 CK=CTS_746
Xbank_mem_0_reg[6][6] QDFFN $PINS Q=bank_mem_0[6][6]
+ D=FE_OFN103_bank_wdata_0__6 CK=CTS_746
Xbank_mem_0_reg[6][5] QDFFN $PINS Q=bank_mem_0[6][5]
+ D=FE_OFN104_bank_wdata_0__5 CK=CTS_746
Xbank_mem_0_reg[6][4] QDFFN $PINS Q=bank_mem_0[6][4]
+ D=FE_OFN105_bank_wdata_0__4 CK=CTS_746
Xbank_mem_0_reg[6][3] QDFFN $PINS Q=bank_mem_0[6][3]
+ D=FE_OFN106_bank_wdata_0__3 CK=CTS_746
Xbank_mem_0_reg[6][2] QDFFN $PINS Q=bank_mem_0[6][2]
+ D=FE_OFN107_bank_wdata_0__2 CK=CTS_746
Xbank_mem_0_reg[6][1] QDFFN $PINS Q=bank_mem_0[6][1]
+ D=FE_OFN108_bank_wdata_0__1 CK=CTS_746
Xbank_mem_0_reg[6][0] QDFFN $PINS Q=bank_mem_0[6][0]
+ D=FE_OFN109_bank_wdata_0__0 CK=CTS_746
Xbank_mem_0_reg[2][33] QDFFN $PINS Q=bank_mem_0[2][33]
+ D=FE_PHN1356_FE_OFN77_bank_wdata_0__33 CK=CTS_770
Xbank_mem_0_reg[2][32] QDFFN $PINS Q=bank_mem_0[2][32]
+ D=FE_OFN78_bank_wdata_0__32 CK=CTS_770
Xbank_mem_0_reg[2][31] QDFFN $PINS Q=bank_mem_0[2][31]
+ D=FE_PHN1451_FE_OFN79_bank_wdata_0__31 CK=CTS_770
Xbank_mem_0_reg[2][30] QDFFN $PINS Q=bank_mem_0[2][30]
+ D=FE_PHN1446_FE_OFN80_bank_wdata_0__30 CK=CTS_770
Xbank_mem_0_reg[2][29] QDFFN $PINS Q=bank_mem_0[2][29]
+ D=FE_PHN1411_FE_OFN81_bank_wdata_0__29 CK=CTS_770
Xbank_mem_0_reg[2][28] QDFFN $PINS Q=bank_mem_0[2][28]
+ D=FE_PHN1415_FE_OFN82_bank_wdata_0__28 CK=CTS_770
Xbank_mem_0_reg[2][27] QDFFN $PINS Q=bank_mem_0[2][27]
+ D=FE_PHN1450_bank_wdata_0_27 CK=CTS_770
Xbank_mem_0_reg[2][26] QDFFN $PINS Q=bank_mem_0[2][26]
+ D=FE_OFN83_bank_wdata_0__26 CK=CTS_770
Xbank_mem_0_reg[2][25] QDFFN $PINS Q=bank_mem_0[2][25]
+ D=FE_OFN84_bank_wdata_0__25 CK=CTS_770
Xbank_mem_0_reg[2][24] QDFFN $PINS Q=bank_mem_0[2][24]
+ D=FE_OFN85_bank_wdata_0__24 CK=CTS_770
Xbank_mem_0_reg[2][23] QDFFN $PINS Q=bank_mem_0[2][23]
+ D=FE_OFN86_bank_wdata_0__23 CK=CTS_770
Xbank_mem_0_reg[2][22] QDFFN $PINS Q=bank_mem_0[2][22]
+ D=FE_OFN87_bank_wdata_0__22 CK=CTS_770
Xbank_mem_0_reg[2][21] QDFFN $PINS Q=bank_mem_0[2][21]
+ D=FE_OFN88_bank_wdata_0__21 CK=CTS_770
Xbank_mem_0_reg[2][20] QDFFN $PINS Q=bank_mem_0[2][20]
+ D=FE_OFN89_bank_wdata_0__20 CK=CTS_770
Xbank_mem_0_reg[2][19] QDFFN $PINS Q=bank_mem_0[2][19]
+ D=FE_OFN90_bank_wdata_0__19 CK=CTS_770
Xbank_mem_0_reg[2][18] QDFFN $PINS Q=bank_mem_0[2][18]
+ D=FE_OFN91_bank_wdata_0__18 CK=CTS_770
Xbank_mem_0_reg[2][17] QDFFN $PINS Q=bank_mem_0[2][17]
+ D=FE_OFN92_bank_wdata_0__17 CK=CTS_770
Xbank_mem_0_reg[2][16] QDFFN $PINS Q=bank_mem_0[2][16]
+ D=FE_OFN93_bank_wdata_0__16 CK=CTS_767
Xbank_mem_0_reg[2][15] QDFFN $PINS Q=bank_mem_0[2][15]
+ D=FE_PHN1017_FE_OFN94_bank_wdata_0__15 CK=CTS_767
Xbank_mem_0_reg[2][14] QDFFN $PINS Q=bank_mem_0[2][14]
+ D=FE_OFN95_bank_wdata_0__14 CK=CTS_767
Xbank_mem_0_reg[2][13] QDFFN $PINS Q=bank_mem_0[2][13]
+ D=FE_PHN1092_FE_OFN96_bank_wdata_0__13 CK=CTS_767
Xbank_mem_0_reg[2][12] QDFFN $PINS Q=bank_mem_0[2][12]
+ D=FE_PHN1124_FE_OFN97_bank_wdata_0__12 CK=CTS_767
Xbank_mem_0_reg[2][11] QDFFN $PINS Q=bank_mem_0[2][11]
+ D=FE_OFN98_bank_wdata_0__11 CK=CTS_767
Xbank_mem_0_reg[2][10] QDFFN $PINS Q=bank_mem_0[2][10]
+ D=FE_OFN99_bank_wdata_0__10 CK=CTS_767
Xbank_mem_0_reg[2][9] QDFFN $PINS Q=bank_mem_0[2][9]
+ D=FE_OFN100_bank_wdata_0__9 CK=CTS_767
Xbank_mem_0_reg[2][8] QDFFN $PINS Q=bank_mem_0[2][8]
+ D=FE_OFN101_bank_wdata_0__8 CK=CTS_767
Xbank_mem_0_reg[2][7] QDFFN $PINS Q=bank_mem_0[2][7]
+ D=FE_OFN102_bank_wdata_0__7 CK=CTS_767
Xbank_mem_0_reg[2][6] QDFFN $PINS Q=bank_mem_0[2][6]
+ D=FE_OFN103_bank_wdata_0__6 CK=CTS_767
Xbank_mem_0_reg[2][5] QDFFN $PINS Q=bank_mem_0[2][5]
+ D=FE_OFN104_bank_wdata_0__5 CK=CTS_767
Xbank_mem_0_reg[2][4] QDFFN $PINS Q=bank_mem_0[2][4]
+ D=FE_OFN105_bank_wdata_0__4 CK=CTS_767
Xbank_mem_0_reg[2][3] QDFFN $PINS Q=bank_mem_0[2][3]
+ D=FE_OFN106_bank_wdata_0__3 CK=CTS_767
Xbank_mem_0_reg[2][2] QDFFN $PINS Q=bank_mem_0[2][2]
+ D=FE_OFN107_bank_wdata_0__2 CK=CTS_767
Xbank_mem_0_reg[2][1] QDFFN $PINS Q=bank_mem_0[2][1]
+ D=FE_OFN108_bank_wdata_0__1 CK=CTS_767
Xbank_mem_0_reg[2][0] QDFFN $PINS Q=bank_mem_0[2][0]
+ D=FE_OFN109_bank_wdata_0__0 CK=CTS_767
Xbank_mem_0_reg[7][32] QDFFN $PINS Q=bank_mem_0[7][32]
+ D=FE_OFN78_bank_wdata_0__32 CK=CTS_637
Xbank_mem_0_reg[7][31] QDFFN $PINS Q=bank_mem_0[7][31]
+ D=FE_PHN1451_FE_OFN79_bank_wdata_0__31 CK=CTS_637
Xbank_mem_0_reg[7][30] QDFFN $PINS Q=bank_mem_0[7][30]
+ D=FE_PHN1446_FE_OFN80_bank_wdata_0__30 CK=CTS_637
Xbank_mem_0_reg[7][29] QDFFN $PINS Q=bank_mem_0[7][29]
+ D=FE_PHN1411_FE_OFN81_bank_wdata_0__29 CK=CTS_637
Xbank_mem_0_reg[7][28] QDFFN $PINS Q=bank_mem_0[7][28]
+ D=FE_PHN1415_FE_OFN82_bank_wdata_0__28 CK=CTS_637
Xbank_mem_0_reg[7][27] QDFFN $PINS Q=bank_mem_0[7][27]
+ D=FE_PHN1450_bank_wdata_0_27 CK=CTS_637
Xbank_mem_0_reg[7][26] QDFFN $PINS Q=bank_mem_0[7][26]
+ D=FE_OFN83_bank_wdata_0__26 CK=CTS_637
Xbank_mem_0_reg[7][25] QDFFN $PINS Q=bank_mem_0[7][25]
+ D=FE_OFN84_bank_wdata_0__25 CK=CTS_637
Xbank_mem_0_reg[7][24] QDFFN $PINS Q=bank_mem_0[7][24]
+ D=FE_OFN85_bank_wdata_0__24 CK=CTS_637
Xbank_mem_0_reg[7][23] QDFFN $PINS Q=bank_mem_0[7][23]
+ D=FE_OFN86_bank_wdata_0__23 CK=CTS_637
Xbank_mem_0_reg[7][22] QDFFN $PINS Q=bank_mem_0[7][22]
+ D=FE_OFN87_bank_wdata_0__22 CK=CTS_637
Xbank_mem_0_reg[7][21] QDFFN $PINS Q=bank_mem_0[7][21]
+ D=FE_OFN88_bank_wdata_0__21 CK=CTS_637
Xbank_mem_0_reg[7][20] QDFFN $PINS Q=bank_mem_0[7][20]
+ D=FE_OFN89_bank_wdata_0__20 CK=CTS_637
Xbank_mem_0_reg[7][19] QDFFN $PINS Q=bank_mem_0[7][19]
+ D=FE_OFN90_bank_wdata_0__19 CK=CTS_637
Xbank_mem_0_reg[7][18] QDFFN $PINS Q=bank_mem_0[7][18]
+ D=FE_OFN91_bank_wdata_0__18 CK=CTS_637
Xbank_mem_0_reg[7][17] QDFFN $PINS Q=bank_mem_0[7][17]
+ D=FE_OFN92_bank_wdata_0__17 CK=CTS_637
Xbank_mem_0_reg[7][16] QDFFN $PINS Q=bank_mem_0[7][16]
+ D=FE_OFN93_bank_wdata_0__16 CK=CTS_743
Xbank_mem_0_reg[7][15] QDFFN $PINS Q=bank_mem_0[7][15]
+ D=FE_PHN1017_FE_OFN94_bank_wdata_0__15 CK=CTS_743
Xbank_mem_0_reg[7][14] QDFFN $PINS Q=bank_mem_0[7][14]
+ D=FE_OFN95_bank_wdata_0__14 CK=CTS_743
Xbank_mem_0_reg[7][13] QDFFN $PINS Q=bank_mem_0[7][13]
+ D=FE_PHN1092_FE_OFN96_bank_wdata_0__13 CK=CTS_743
Xbank_mem_0_reg[7][12] QDFFN $PINS Q=bank_mem_0[7][12]
+ D=FE_PHN1124_FE_OFN97_bank_wdata_0__12 CK=CTS_743
Xbank_mem_0_reg[7][11] QDFFN $PINS Q=bank_mem_0[7][11]
+ D=FE_OFN98_bank_wdata_0__11 CK=CTS_743
Xbank_mem_0_reg[7][10] QDFFN $PINS Q=bank_mem_0[7][10]
+ D=FE_OFN99_bank_wdata_0__10 CK=CTS_743
Xbank_mem_0_reg[7][9] QDFFN $PINS Q=bank_mem_0[7][9]
+ D=FE_OFN100_bank_wdata_0__9 CK=CTS_743
Xbank_mem_0_reg[7][8] QDFFN $PINS Q=bank_mem_0[7][8]
+ D=FE_OFN101_bank_wdata_0__8 CK=CTS_743
Xbank_mem_0_reg[7][7] QDFFN $PINS Q=bank_mem_0[7][7]
+ D=FE_OFN102_bank_wdata_0__7 CK=CTS_743
Xbank_mem_0_reg[7][6] QDFFN $PINS Q=bank_mem_0[7][6]
+ D=FE_OFN103_bank_wdata_0__6 CK=CTS_743
Xbank_mem_0_reg[7][5] QDFFN $PINS Q=bank_mem_0[7][5]
+ D=FE_OFN104_bank_wdata_0__5 CK=CTS_743
Xbank_mem_0_reg[7][4] QDFFN $PINS Q=bank_mem_0[7][4]
+ D=FE_OFN105_bank_wdata_0__4 CK=CTS_743
Xbank_mem_0_reg[7][3] QDFFN $PINS Q=bank_mem_0[7][3]
+ D=FE_OFN106_bank_wdata_0__3 CK=CTS_743
Xbank_mem_0_reg[7][2] QDFFN $PINS Q=bank_mem_0[7][2]
+ D=FE_OFN107_bank_wdata_0__2 CK=CTS_743
Xbank_mem_0_reg[7][1] QDFFN $PINS Q=bank_mem_0[7][1]
+ D=FE_OFN108_bank_wdata_0__1 CK=CTS_743
Xbank_mem_0_reg[7][0] QDFFN $PINS Q=bank_mem_0[7][0]
+ D=FE_OFN109_bank_wdata_0__0 CK=CTS_743
Xbank_mem_0_reg[7][33] QDFFN $PINS Q=bank_mem_0[7][33]
+ D=FE_PHN1356_FE_OFN77_bank_wdata_0__33 CK=CTS_637
Xbank_mem_0_reg[3][33] QDFFN $PINS Q=bank_mem_0[3][33]
+ D=FE_PHN1356_FE_OFN77_bank_wdata_0__33 CK=CTS_764
Xbank_mem_0_reg[3][32] QDFFN $PINS Q=bank_mem_0[3][32]
+ D=FE_OFN78_bank_wdata_0__32 CK=CTS_764
Xbank_mem_0_reg[3][31] QDFFN $PINS Q=bank_mem_0[3][31]
+ D=FE_PHN1451_FE_OFN79_bank_wdata_0__31 CK=CTS_764
Xbank_mem_0_reg[3][30] QDFFN $PINS Q=bank_mem_0[3][30]
+ D=FE_PHN1446_FE_OFN80_bank_wdata_0__30 CK=CTS_764
Xbank_mem_0_reg[3][29] QDFFN $PINS Q=bank_mem_0[3][29]
+ D=FE_PHN1411_FE_OFN81_bank_wdata_0__29 CK=CTS_764
Xbank_mem_0_reg[3][28] QDFFN $PINS Q=bank_mem_0[3][28]
+ D=FE_PHN1415_FE_OFN82_bank_wdata_0__28 CK=CTS_764
Xbank_mem_0_reg[3][27] QDFFN $PINS Q=bank_mem_0[3][27]
+ D=FE_PHN1450_bank_wdata_0_27 CK=CTS_764
Xbank_mem_0_reg[3][26] QDFFN $PINS Q=bank_mem_0[3][26]
+ D=FE_OFN83_bank_wdata_0__26 CK=CTS_764
Xbank_mem_0_reg[3][25] QDFFN $PINS Q=bank_mem_0[3][25]
+ D=FE_OFN84_bank_wdata_0__25 CK=CTS_764
Xbank_mem_0_reg[3][24] QDFFN $PINS Q=bank_mem_0[3][24]
+ D=FE_OFN85_bank_wdata_0__24 CK=CTS_764
Xbank_mem_0_reg[3][23] QDFFN $PINS Q=bank_mem_0[3][23]
+ D=FE_OFN86_bank_wdata_0__23 CK=CTS_764
Xbank_mem_0_reg[3][22] QDFFN $PINS Q=bank_mem_0[3][22]
+ D=FE_OFN87_bank_wdata_0__22 CK=CTS_764
Xbank_mem_0_reg[3][21] QDFFN $PINS Q=bank_mem_0[3][21]
+ D=FE_OFN88_bank_wdata_0__21 CK=CTS_764
Xbank_mem_0_reg[3][20] QDFFN $PINS Q=bank_mem_0[3][20]
+ D=FE_OFN89_bank_wdata_0__20 CK=CTS_764
Xbank_mem_0_reg[3][19] QDFFN $PINS Q=bank_mem_0[3][19]
+ D=FE_OFN90_bank_wdata_0__19 CK=CTS_764
Xbank_mem_0_reg[3][18] QDFFN $PINS Q=bank_mem_0[3][18]
+ D=FE_OFN91_bank_wdata_0__18 CK=CTS_764
Xbank_mem_0_reg[3][17] QDFFN $PINS Q=bank_mem_0[3][17]
+ D=FE_OFN92_bank_wdata_0__17 CK=CTS_764
Xbank_mem_0_reg[3][16] QDFFN $PINS Q=bank_mem_0[3][16]
+ D=FE_OFN93_bank_wdata_0__16 CK=CTS_761
Xbank_mem_0_reg[3][15] QDFFN $PINS Q=bank_mem_0[3][15]
+ D=FE_PHN1017_FE_OFN94_bank_wdata_0__15 CK=CTS_761
Xbank_mem_0_reg[3][14] QDFFN $PINS Q=bank_mem_0[3][14]
+ D=FE_OFN95_bank_wdata_0__14 CK=CTS_761
Xbank_mem_0_reg[3][13] QDFFN $PINS Q=bank_mem_0[3][13]
+ D=FE_PHN1092_FE_OFN96_bank_wdata_0__13 CK=CTS_761
Xbank_mem_0_reg[3][12] QDFFN $PINS Q=bank_mem_0[3][12]
+ D=FE_PHN1124_FE_OFN97_bank_wdata_0__12 CK=CTS_761
Xbank_mem_0_reg[3][11] QDFFN $PINS Q=bank_mem_0[3][11]
+ D=FE_OFN98_bank_wdata_0__11 CK=CTS_761
Xbank_mem_0_reg[3][10] QDFFN $PINS Q=bank_mem_0[3][10]
+ D=FE_OFN99_bank_wdata_0__10 CK=CTS_761
Xbank_mem_0_reg[3][9] QDFFN $PINS Q=bank_mem_0[3][9]
+ D=FE_OFN100_bank_wdata_0__9 CK=CTS_761
Xbank_mem_0_reg[3][8] QDFFN $PINS Q=bank_mem_0[3][8]
+ D=FE_OFN101_bank_wdata_0__8 CK=CTS_761
Xbank_mem_0_reg[3][7] QDFFN $PINS Q=bank_mem_0[3][7]
+ D=FE_OFN102_bank_wdata_0__7 CK=CTS_761
Xbank_mem_0_reg[3][6] QDFFN $PINS Q=bank_mem_0[3][6]
+ D=FE_OFN103_bank_wdata_0__6 CK=CTS_761
Xbank_mem_0_reg[3][5] QDFFN $PINS Q=bank_mem_0[3][5]
+ D=FE_OFN104_bank_wdata_0__5 CK=CTS_761
Xbank_mem_0_reg[3][4] QDFFN $PINS Q=bank_mem_0[3][4]
+ D=FE_OFN105_bank_wdata_0__4 CK=CTS_761
Xbank_mem_0_reg[3][3] QDFFN $PINS Q=bank_mem_0[3][3]
+ D=FE_OFN106_bank_wdata_0__3 CK=CTS_761
Xbank_mem_0_reg[3][2] QDFFN $PINS Q=bank_mem_0[3][2]
+ D=FE_OFN107_bank_wdata_0__2 CK=CTS_761
Xbank_mem_0_reg[3][1] QDFFN $PINS Q=bank_mem_0[3][1]
+ D=FE_OFN108_bank_wdata_0__1 CK=CTS_761
Xbank_mem_0_reg[3][0] QDFFN $PINS Q=bank_mem_0[3][0]
+ D=FE_OFN109_bank_wdata_0__0 CK=CTS_761
Xbank_mem_0_reg[5][33] QDFFN $PINS Q=bank_mem_0[5][33]
+ D=FE_PHN1356_FE_OFN77_bank_wdata_0__33 CK=CTS_694
Xbank_mem_0_reg[5][32] QDFFN $PINS Q=bank_mem_0[5][32]
+ D=FE_OFN78_bank_wdata_0__32 CK=CTS_694
Xbank_mem_0_reg[5][31] QDFFN $PINS Q=bank_mem_0[5][31]
+ D=FE_PHN1451_FE_OFN79_bank_wdata_0__31 CK=CTS_694
Xbank_mem_0_reg[5][30] QDFFN $PINS Q=bank_mem_0[5][30]
+ D=FE_PHN1446_FE_OFN80_bank_wdata_0__30 CK=CTS_694
Xbank_mem_0_reg[5][29] QDFFN $PINS Q=bank_mem_0[5][29]
+ D=FE_PHN1411_FE_OFN81_bank_wdata_0__29 CK=CTS_694
Xbank_mem_0_reg[5][28] QDFFN $PINS Q=bank_mem_0[5][28]
+ D=FE_PHN1415_FE_OFN82_bank_wdata_0__28 CK=CTS_694
Xbank_mem_0_reg[5][27] QDFFN $PINS Q=bank_mem_0[5][27]
+ D=FE_PHN1450_bank_wdata_0_27 CK=CTS_694
Xbank_mem_0_reg[5][26] QDFFN $PINS Q=bank_mem_0[5][26]
+ D=FE_OFN83_bank_wdata_0__26 CK=CTS_694
Xbank_mem_0_reg[5][25] QDFFN $PINS Q=bank_mem_0[5][25]
+ D=FE_OFN84_bank_wdata_0__25 CK=CTS_694
Xbank_mem_0_reg[5][24] QDFFN $PINS Q=bank_mem_0[5][24]
+ D=FE_OFN85_bank_wdata_0__24 CK=CTS_694
Xbank_mem_0_reg[5][23] QDFFN $PINS Q=bank_mem_0[5][23]
+ D=FE_OFN86_bank_wdata_0__23 CK=CTS_694
Xbank_mem_0_reg[5][22] QDFFN $PINS Q=bank_mem_0[5][22]
+ D=FE_OFN87_bank_wdata_0__22 CK=CTS_694
Xbank_mem_0_reg[5][21] QDFFN $PINS Q=bank_mem_0[5][21]
+ D=FE_OFN88_bank_wdata_0__21 CK=CTS_694
Xbank_mem_0_reg[5][20] QDFFN $PINS Q=bank_mem_0[5][20]
+ D=FE_OFN89_bank_wdata_0__20 CK=CTS_694
Xbank_mem_0_reg[5][19] QDFFN $PINS Q=bank_mem_0[5][19]
+ D=FE_OFN90_bank_wdata_0__19 CK=CTS_694
Xbank_mem_0_reg[5][18] QDFFN $PINS Q=bank_mem_0[5][18]
+ D=FE_OFN91_bank_wdata_0__18 CK=CTS_694
Xbank_mem_0_reg[5][17] QDFFN $PINS Q=bank_mem_0[5][17]
+ D=FE_OFN92_bank_wdata_0__17 CK=CTS_694
Xbank_mem_0_reg[5][16] QDFFN $PINS Q=bank_mem_0[5][16]
+ D=FE_OFN93_bank_wdata_0__16 CK=CTS_752
Xbank_mem_0_reg[5][15] QDFFN $PINS Q=bank_mem_0[5][15]
+ D=FE_PHN1017_FE_OFN94_bank_wdata_0__15 CK=CTS_752
Xbank_mem_0_reg[5][14] QDFFN $PINS Q=bank_mem_0[5][14]
+ D=FE_OFN95_bank_wdata_0__14 CK=CTS_752
Xbank_mem_0_reg[5][13] QDFFN $PINS Q=bank_mem_0[5][13]
+ D=FE_PHN1092_FE_OFN96_bank_wdata_0__13 CK=CTS_752
Xbank_mem_0_reg[5][12] QDFFN $PINS Q=bank_mem_0[5][12]
+ D=FE_PHN1124_FE_OFN97_bank_wdata_0__12 CK=CTS_752
Xbank_mem_0_reg[5][11] QDFFN $PINS Q=bank_mem_0[5][11]
+ D=FE_OFN98_bank_wdata_0__11 CK=CTS_752
Xbank_mem_0_reg[5][10] QDFFN $PINS Q=bank_mem_0[5][10]
+ D=FE_OFN99_bank_wdata_0__10 CK=CTS_752
Xbank_mem_0_reg[5][9] QDFFN $PINS Q=bank_mem_0[5][9]
+ D=FE_OFN100_bank_wdata_0__9 CK=CTS_752
Xbank_mem_0_reg[5][8] QDFFN $PINS Q=bank_mem_0[5][8]
+ D=FE_OFN101_bank_wdata_0__8 CK=CTS_752
Xbank_mem_0_reg[5][7] QDFFN $PINS Q=bank_mem_0[5][7]
+ D=FE_OFN102_bank_wdata_0__7 CK=CTS_752
Xbank_mem_0_reg[5][6] QDFFN $PINS Q=bank_mem_0[5][6]
+ D=FE_OFN103_bank_wdata_0__6 CK=CTS_752
Xbank_mem_0_reg[5][5] QDFFN $PINS Q=bank_mem_0[5][5]
+ D=FE_OFN104_bank_wdata_0__5 CK=CTS_752
Xbank_mem_0_reg[5][4] QDFFN $PINS Q=bank_mem_0[5][4]
+ D=FE_OFN105_bank_wdata_0__4 CK=CTS_752
Xbank_mem_0_reg[5][3] QDFFN $PINS Q=bank_mem_0[5][3]
+ D=FE_OFN106_bank_wdata_0__3 CK=CTS_752
Xbank_mem_0_reg[5][2] QDFFN $PINS Q=bank_mem_0[5][2]
+ D=FE_OFN107_bank_wdata_0__2 CK=CTS_752
Xbank_mem_0_reg[5][1] QDFFN $PINS Q=bank_mem_0[5][1]
+ D=FE_OFN108_bank_wdata_0__1 CK=CTS_752
Xbank_mem_0_reg[5][0] QDFFN $PINS Q=bank_mem_0[5][0]
+ D=FE_OFN109_bank_wdata_0__0 CK=CTS_752
Xbank_mem_1_reg[0][33] QDFFN $PINS Q=bank_mem_1[0][33]
+ D=FE_OFN42_bank_wdata_1__33 CK=CTS_739
Xbank_mem_1_reg[0][32] QDFFN $PINS Q=bank_mem_1[0][32]
+ D=FE_OFN43_bank_wdata_1__32 CK=CTS_739
Xbank_mem_1_reg[0][31] QDFFN $PINS Q=bank_mem_1[0][31]
+ D=FE_OFN44_bank_wdata_1__31 CK=CTS_739
Xbank_mem_1_reg[0][30] QDFFN $PINS Q=bank_mem_1[0][30]
+ D=FE_OFN45_bank_wdata_1__30 CK=CTS_739
Xbank_mem_1_reg[0][29] QDFFN $PINS Q=bank_mem_1[0][29]
+ D=FE_OFN46_bank_wdata_1__29 CK=CTS_739
Xbank_mem_1_reg[0][28] QDFFN $PINS Q=bank_mem_1[0][28]
+ D=FE_OFN47_bank_wdata_1__28 CK=CTS_739
Xbank_mem_1_reg[0][27] QDFFN $PINS Q=bank_mem_1[0][27]
+ D=FE_OFN48_bank_wdata_1__27 CK=CTS_739
Xbank_mem_1_reg[0][26] QDFFN $PINS Q=bank_mem_1[0][26]
+ D=FE_OFN49_bank_wdata_1__26 CK=CTS_739
Xbank_mem_1_reg[0][25] QDFFN $PINS Q=bank_mem_1[0][25]
+ D=FE_OFN50_bank_wdata_1__25 CK=CTS_739
Xbank_mem_1_reg[0][24] QDFFN $PINS Q=bank_mem_1[0][24]
+ D=FE_OFN51_bank_wdata_1__24 CK=CTS_739
Xbank_mem_1_reg[0][23] QDFFN $PINS Q=bank_mem_1[0][23]
+ D=FE_OFN52_bank_wdata_1__23 CK=CTS_739
Xbank_mem_1_reg[0][22] QDFFN $PINS Q=bank_mem_1[0][22]
+ D=FE_OFN53_bank_wdata_1__22 CK=CTS_739
Xbank_mem_1_reg[0][21] QDFFN $PINS Q=bank_mem_1[0][21]
+ D=FE_OFN54_bank_wdata_1__21 CK=CTS_739
Xbank_mem_1_reg[0][20] QDFFN $PINS Q=bank_mem_1[0][20]
+ D=FE_OFN55_bank_wdata_1__20 CK=CTS_739
Xbank_mem_1_reg[0][19] QDFFN $PINS Q=bank_mem_1[0][19]
+ D=FE_OFN56_bank_wdata_1__19 CK=CTS_739
Xbank_mem_1_reg[0][18] QDFFN $PINS Q=bank_mem_1[0][18]
+ D=FE_OFN57_bank_wdata_1__18 CK=CTS_739
Xbank_mem_1_reg[0][17] QDFFN $PINS Q=bank_mem_1[0][17]
+ D=FE_OFN58_bank_wdata_1__17 CK=CTS_739
Xbank_mem_1_reg[0][16] QDFFN $PINS Q=bank_mem_1[0][16]
+ D=FE_OFN59_bank_wdata_1__16 CK=CTS_736
Xbank_mem_1_reg[0][15] QDFFN $PINS Q=bank_mem_1[0][15]
+ D=FE_OFN60_bank_wdata_1__15 CK=CTS_736
Xbank_mem_1_reg[0][14] QDFFN $PINS Q=bank_mem_1[0][14]
+ D=FE_OFN61_bank_wdata_1__14 CK=CTS_736
Xbank_mem_1_reg[0][13] QDFFN $PINS Q=bank_mem_1[0][13]
+ D=FE_OFN62_bank_wdata_1__13 CK=CTS_736
Xbank_mem_1_reg[0][12] QDFFN $PINS Q=bank_mem_1[0][12]
+ D=FE_OFN63_bank_wdata_1__12 CK=CTS_736
Xbank_mem_1_reg[0][11] QDFFN $PINS Q=bank_mem_1[0][11]
+ D=FE_OFN64_bank_wdata_1__11 CK=CTS_736
Xbank_mem_1_reg[0][10] QDFFN $PINS Q=bank_mem_1[0][10]
+ D=FE_OFN65_bank_wdata_1__10 CK=CTS_736
Xbank_mem_1_reg[0][9] QDFFN $PINS Q=bank_mem_1[0][9] D=FE_OFN66_bank_wdata_1__9
+ CK=CTS_736
Xbank_mem_1_reg[0][8] QDFFN $PINS Q=bank_mem_1[0][8] D=FE_OFN67_bank_wdata_1__8
+ CK=CTS_736
Xbank_mem_1_reg[0][7] QDFFN $PINS Q=bank_mem_1[0][7] D=FE_OFN68_bank_wdata_1__7
+ CK=CTS_736
Xbank_mem_1_reg[0][6] QDFFN $PINS Q=bank_mem_1[0][6] D=FE_OFN69_bank_wdata_1__6
+ CK=CTS_736
Xbank_mem_1_reg[0][5] QDFFN $PINS Q=bank_mem_1[0][5] D=FE_OFN70_bank_wdata_1__5
+ CK=CTS_736
Xbank_mem_1_reg[0][4] QDFFN $PINS Q=bank_mem_1[0][4] D=FE_OFN71_bank_wdata_1__4
+ CK=CTS_736
Xbank_mem_1_reg[0][3] QDFFN $PINS Q=bank_mem_1[0][3] D=FE_OFN72_bank_wdata_1__3
+ CK=CTS_736
Xbank_mem_1_reg[0][2] QDFFN $PINS Q=bank_mem_1[0][2] D=FE_OFN73_bank_wdata_1__2
+ CK=CTS_736
Xbank_mem_1_reg[0][1] QDFFN $PINS Q=bank_mem_1[0][1] D=FE_OFN74_bank_wdata_1__1
+ CK=CTS_736
Xbank_mem_1_reg[0][0] QDFFN $PINS Q=bank_mem_1[0][0] D=FE_OFN75_bank_wdata_1__0
+ CK=CTS_736
Xbank_mem_1_reg[1][33] QDFFN $PINS Q=bank_mem_1[1][33]
+ D=FE_OFN42_bank_wdata_1__33 CK=CTS_733
Xbank_mem_1_reg[1][32] QDFFN $PINS Q=bank_mem_1[1][32]
+ D=FE_OFN43_bank_wdata_1__32 CK=CTS_733
Xbank_mem_1_reg[1][31] QDFFN $PINS Q=bank_mem_1[1][31]
+ D=FE_OFN44_bank_wdata_1__31 CK=CTS_733
Xbank_mem_1_reg[1][30] QDFFN $PINS Q=bank_mem_1[1][30]
+ D=FE_OFN45_bank_wdata_1__30 CK=CTS_733
Xbank_mem_1_reg[1][29] QDFFN $PINS Q=bank_mem_1[1][29]
+ D=FE_OFN46_bank_wdata_1__29 CK=CTS_733
Xbank_mem_1_reg[1][28] QDFFN $PINS Q=bank_mem_1[1][28]
+ D=FE_OFN47_bank_wdata_1__28 CK=CTS_733
Xbank_mem_1_reg[1][27] QDFFN $PINS Q=bank_mem_1[1][27]
+ D=FE_OFN48_bank_wdata_1__27 CK=CTS_733
Xbank_mem_1_reg[1][26] QDFFN $PINS Q=bank_mem_1[1][26]
+ D=FE_OFN49_bank_wdata_1__26 CK=CTS_733
Xbank_mem_1_reg[1][25] QDFFN $PINS Q=bank_mem_1[1][25]
+ D=FE_OFN50_bank_wdata_1__25 CK=CTS_733
Xbank_mem_1_reg[1][24] QDFFN $PINS Q=bank_mem_1[1][24]
+ D=FE_OFN51_bank_wdata_1__24 CK=CTS_733
Xbank_mem_1_reg[1][23] QDFFN $PINS Q=bank_mem_1[1][23]
+ D=FE_OFN52_bank_wdata_1__23 CK=CTS_733
Xbank_mem_1_reg[1][22] QDFFN $PINS Q=bank_mem_1[1][22]
+ D=FE_OFN53_bank_wdata_1__22 CK=CTS_733
Xbank_mem_1_reg[1][21] QDFFN $PINS Q=bank_mem_1[1][21]
+ D=FE_OFN54_bank_wdata_1__21 CK=CTS_733
Xbank_mem_1_reg[1][20] QDFFN $PINS Q=bank_mem_1[1][20]
+ D=FE_OFN55_bank_wdata_1__20 CK=CTS_733
Xbank_mem_1_reg[1][19] QDFFN $PINS Q=bank_mem_1[1][19]
+ D=FE_OFN56_bank_wdata_1__19 CK=CTS_733
Xbank_mem_1_reg[1][18] QDFFN $PINS Q=bank_mem_1[1][18]
+ D=FE_OFN57_bank_wdata_1__18 CK=CTS_733
Xbank_mem_1_reg[1][17] QDFFN $PINS Q=bank_mem_1[1][17]
+ D=FE_OFN58_bank_wdata_1__17 CK=CTS_733
Xbank_mem_1_reg[1][16] QDFFN $PINS Q=bank_mem_1[1][16]
+ D=FE_OFN59_bank_wdata_1__16 CK=CTS_730
Xbank_mem_1_reg[1][15] QDFFN $PINS Q=bank_mem_1[1][15]
+ D=FE_OFN60_bank_wdata_1__15 CK=CTS_730
Xbank_mem_1_reg[1][14] QDFFN $PINS Q=bank_mem_1[1][14]
+ D=FE_OFN61_bank_wdata_1__14 CK=CTS_730
Xbank_mem_1_reg[1][13] QDFFN $PINS Q=bank_mem_1[1][13]
+ D=FE_OFN62_bank_wdata_1__13 CK=CTS_730
Xbank_mem_1_reg[1][12] QDFFN $PINS Q=bank_mem_1[1][12]
+ D=FE_OFN63_bank_wdata_1__12 CK=CTS_730
Xbank_mem_1_reg[1][11] QDFFN $PINS Q=bank_mem_1[1][11]
+ D=FE_OFN64_bank_wdata_1__11 CK=CTS_730
Xbank_mem_1_reg[1][10] QDFFN $PINS Q=bank_mem_1[1][10]
+ D=FE_OFN65_bank_wdata_1__10 CK=CTS_730
Xbank_mem_1_reg[1][9] QDFFN $PINS Q=bank_mem_1[1][9] D=FE_OFN66_bank_wdata_1__9
+ CK=CTS_730
Xbank_mem_1_reg[1][8] QDFFN $PINS Q=bank_mem_1[1][8] D=FE_OFN67_bank_wdata_1__8
+ CK=CTS_730
Xbank_mem_1_reg[1][7] QDFFN $PINS Q=bank_mem_1[1][7] D=FE_OFN68_bank_wdata_1__7
+ CK=CTS_730
Xbank_mem_1_reg[1][6] QDFFN $PINS Q=bank_mem_1[1][6] D=FE_OFN69_bank_wdata_1__6
+ CK=CTS_730
Xbank_mem_1_reg[1][5] QDFFN $PINS Q=bank_mem_1[1][5] D=FE_OFN70_bank_wdata_1__5
+ CK=CTS_730
Xbank_mem_1_reg[1][4] QDFFN $PINS Q=bank_mem_1[1][4] D=FE_OFN71_bank_wdata_1__4
+ CK=CTS_730
Xbank_mem_1_reg[1][3] QDFFN $PINS Q=bank_mem_1[1][3] D=FE_OFN72_bank_wdata_1__3
+ CK=CTS_730
Xbank_mem_1_reg[1][2] QDFFN $PINS Q=bank_mem_1[1][2] D=FE_OFN73_bank_wdata_1__2
+ CK=CTS_730
Xbank_mem_1_reg[1][1] QDFFN $PINS Q=bank_mem_1[1][1] D=FE_OFN74_bank_wdata_1__1
+ CK=CTS_730
Xbank_mem_1_reg[1][0] QDFFN $PINS Q=bank_mem_1[1][0] D=FE_OFN75_bank_wdata_1__0
+ CK=CTS_730
Xbank_mem_0_reg[0][33] QDFFN $PINS Q=bank_mem_0[0][33]
+ D=FE_PHN1356_FE_OFN77_bank_wdata_0__33 CK=CTS_782
Xbank_mem_0_reg[0][32] QDFFN $PINS Q=bank_mem_0[0][32]
+ D=FE_OFN78_bank_wdata_0__32 CK=CTS_782
Xbank_mem_0_reg[0][31] QDFFN $PINS Q=bank_mem_0[0][31]
+ D=FE_PHN1451_FE_OFN79_bank_wdata_0__31 CK=CTS_782
Xbank_mem_0_reg[0][30] QDFFN $PINS Q=bank_mem_0[0][30]
+ D=FE_PHN1446_FE_OFN80_bank_wdata_0__30 CK=CTS_782
Xbank_mem_0_reg[0][29] QDFFN $PINS Q=bank_mem_0[0][29]
+ D=FE_PHN1411_FE_OFN81_bank_wdata_0__29 CK=CTS_782
Xbank_mem_0_reg[0][28] QDFFN $PINS Q=bank_mem_0[0][28]
+ D=FE_PHN1415_FE_OFN82_bank_wdata_0__28 CK=CTS_782
Xbank_mem_0_reg[0][27] QDFFN $PINS Q=bank_mem_0[0][27]
+ D=FE_PHN1450_bank_wdata_0_27 CK=CTS_782
Xbank_mem_0_reg[0][26] QDFFN $PINS Q=bank_mem_0[0][26]
+ D=FE_OFN83_bank_wdata_0__26 CK=CTS_782
Xbank_mem_0_reg[0][25] QDFFN $PINS Q=bank_mem_0[0][25]
+ D=FE_OFN84_bank_wdata_0__25 CK=CTS_782
Xbank_mem_0_reg[0][24] QDFFN $PINS Q=bank_mem_0[0][24]
+ D=FE_OFN85_bank_wdata_0__24 CK=CTS_782
Xbank_mem_0_reg[0][23] QDFFN $PINS Q=bank_mem_0[0][23]
+ D=FE_OFN86_bank_wdata_0__23 CK=CTS_782
Xbank_mem_0_reg[0][22] QDFFN $PINS Q=bank_mem_0[0][22]
+ D=FE_OFN87_bank_wdata_0__22 CK=CTS_782
Xbank_mem_0_reg[0][21] QDFFN $PINS Q=bank_mem_0[0][21]
+ D=FE_OFN88_bank_wdata_0__21 CK=CTS_782
Xbank_mem_0_reg[0][20] QDFFN $PINS Q=bank_mem_0[0][20]
+ D=FE_OFN89_bank_wdata_0__20 CK=CTS_782
Xbank_mem_0_reg[0][19] QDFFN $PINS Q=bank_mem_0[0][19]
+ D=FE_OFN90_bank_wdata_0__19 CK=CTS_782
Xbank_mem_0_reg[0][18] QDFFN $PINS Q=bank_mem_0[0][18]
+ D=FE_OFN91_bank_wdata_0__18 CK=CTS_782
Xbank_mem_0_reg[0][17] QDFFN $PINS Q=bank_mem_0[0][17]
+ D=FE_OFN92_bank_wdata_0__17 CK=CTS_782
Xbank_mem_0_reg[0][16] QDFFN $PINS Q=bank_mem_0[0][16]
+ D=FE_OFN93_bank_wdata_0__16 CK=CTS_779
Xbank_mem_0_reg[0][15] QDFFN $PINS Q=bank_mem_0[0][15]
+ D=FE_PHN1017_FE_OFN94_bank_wdata_0__15 CK=CTS_779
Xbank_mem_0_reg[0][14] QDFFN $PINS Q=bank_mem_0[0][14]
+ D=FE_OFN95_bank_wdata_0__14 CK=CTS_779
Xbank_mem_0_reg[0][13] QDFFN $PINS Q=bank_mem_0[0][13]
+ D=FE_PHN1092_FE_OFN96_bank_wdata_0__13 CK=CTS_779
Xbank_mem_0_reg[0][12] QDFFN $PINS Q=bank_mem_0[0][12]
+ D=FE_PHN1124_FE_OFN97_bank_wdata_0__12 CK=CTS_779
Xbank_mem_0_reg[0][11] QDFFN $PINS Q=bank_mem_0[0][11]
+ D=FE_OFN98_bank_wdata_0__11 CK=CTS_779
Xbank_mem_0_reg[0][10] QDFFN $PINS Q=bank_mem_0[0][10]
+ D=FE_OFN99_bank_wdata_0__10 CK=CTS_779
Xbank_mem_0_reg[0][9] QDFFN $PINS Q=bank_mem_0[0][9]
+ D=FE_OFN100_bank_wdata_0__9 CK=CTS_779
Xbank_mem_0_reg[0][8] QDFFN $PINS Q=bank_mem_0[0][8]
+ D=FE_OFN101_bank_wdata_0__8 CK=CTS_779
Xbank_mem_0_reg[0][7] QDFFN $PINS Q=bank_mem_0[0][7]
+ D=FE_OFN102_bank_wdata_0__7 CK=CTS_779
Xbank_mem_0_reg[0][6] QDFFN $PINS Q=bank_mem_0[0][6]
+ D=FE_OFN103_bank_wdata_0__6 CK=CTS_779
Xbank_mem_0_reg[0][5] QDFFN $PINS Q=bank_mem_0[0][5]
+ D=FE_OFN104_bank_wdata_0__5 CK=CTS_779
Xbank_mem_0_reg[0][4] QDFFN $PINS Q=bank_mem_0[0][4]
+ D=FE_OFN105_bank_wdata_0__4 CK=CTS_779
Xbank_mem_0_reg[0][3] QDFFN $PINS Q=bank_mem_0[0][3]
+ D=FE_OFN106_bank_wdata_0__3 CK=CTS_779
Xbank_mem_0_reg[0][2] QDFFN $PINS Q=bank_mem_0[0][2]
+ D=FE_OFN107_bank_wdata_0__2 CK=CTS_779
Xbank_mem_0_reg[0][1] QDFFN $PINS Q=bank_mem_0[0][1]
+ D=FE_OFN108_bank_wdata_0__1 CK=CTS_779
Xbank_mem_0_reg[0][0] QDFFN $PINS Q=bank_mem_0[0][0]
+ D=FE_OFN109_bank_wdata_0__0 CK=CTS_779
Xbank_mem_0_reg[1][33] QDFFN $PINS Q=bank_mem_0[1][33]
+ D=FE_PHN1356_FE_OFN77_bank_wdata_0__33 CK=CTS_776
Xbank_mem_0_reg[1][32] QDFFN $PINS Q=bank_mem_0[1][32]
+ D=FE_OFN78_bank_wdata_0__32 CK=CTS_776
Xbank_mem_0_reg[1][31] QDFFN $PINS Q=bank_mem_0[1][31]
+ D=FE_PHN1451_FE_OFN79_bank_wdata_0__31 CK=CTS_776
Xbank_mem_0_reg[1][30] QDFFN $PINS Q=bank_mem_0[1][30]
+ D=FE_PHN1446_FE_OFN80_bank_wdata_0__30 CK=CTS_776
Xbank_mem_0_reg[1][29] QDFFN $PINS Q=bank_mem_0[1][29]
+ D=FE_PHN1411_FE_OFN81_bank_wdata_0__29 CK=CTS_776
Xbank_mem_0_reg[1][28] QDFFN $PINS Q=bank_mem_0[1][28]
+ D=FE_PHN1415_FE_OFN82_bank_wdata_0__28 CK=CTS_776
Xbank_mem_0_reg[1][27] QDFFN $PINS Q=bank_mem_0[1][27]
+ D=FE_PHN1450_bank_wdata_0_27 CK=CTS_776
Xbank_mem_0_reg[1][26] QDFFN $PINS Q=bank_mem_0[1][26]
+ D=FE_OFN83_bank_wdata_0__26 CK=CTS_776
Xbank_mem_0_reg[1][25] QDFFN $PINS Q=bank_mem_0[1][25]
+ D=FE_OFN84_bank_wdata_0__25 CK=CTS_776
Xbank_mem_0_reg[1][24] QDFFN $PINS Q=bank_mem_0[1][24]
+ D=FE_OFN85_bank_wdata_0__24 CK=CTS_776
Xbank_mem_0_reg[1][23] QDFFN $PINS Q=bank_mem_0[1][23]
+ D=FE_OFN86_bank_wdata_0__23 CK=CTS_776
Xbank_mem_0_reg[1][22] QDFFN $PINS Q=bank_mem_0[1][22]
+ D=FE_OFN87_bank_wdata_0__22 CK=CTS_776
Xbank_mem_0_reg[1][21] QDFFN $PINS Q=bank_mem_0[1][21]
+ D=FE_OFN88_bank_wdata_0__21 CK=CTS_776
Xbank_mem_0_reg[1][20] QDFFN $PINS Q=bank_mem_0[1][20]
+ D=FE_OFN89_bank_wdata_0__20 CK=CTS_776
Xbank_mem_0_reg[1][19] QDFFN $PINS Q=bank_mem_0[1][19]
+ D=FE_OFN90_bank_wdata_0__19 CK=CTS_776
Xbank_mem_0_reg[1][18] QDFFN $PINS Q=bank_mem_0[1][18]
+ D=FE_OFN91_bank_wdata_0__18 CK=CTS_776
Xbank_mem_0_reg[1][17] QDFFN $PINS Q=bank_mem_0[1][17]
+ D=FE_OFN92_bank_wdata_0__17 CK=CTS_776
Xbank_mem_0_reg[1][16] QDFFN $PINS Q=bank_mem_0[1][16]
+ D=FE_OFN93_bank_wdata_0__16 CK=CTS_773
Xbank_mem_0_reg[1][15] QDFFN $PINS Q=bank_mem_0[1][15]
+ D=FE_PHN1017_FE_OFN94_bank_wdata_0__15 CK=CTS_773
Xbank_mem_0_reg[1][14] QDFFN $PINS Q=bank_mem_0[1][14]
+ D=FE_OFN95_bank_wdata_0__14 CK=CTS_773
Xbank_mem_0_reg[1][13] QDFFN $PINS Q=bank_mem_0[1][13]
+ D=FE_PHN1092_FE_OFN96_bank_wdata_0__13 CK=CTS_773
Xbank_mem_0_reg[1][12] QDFFN $PINS Q=bank_mem_0[1][12]
+ D=FE_PHN1124_FE_OFN97_bank_wdata_0__12 CK=CTS_773
Xbank_mem_0_reg[1][11] QDFFN $PINS Q=bank_mem_0[1][11]
+ D=FE_OFN98_bank_wdata_0__11 CK=CTS_773
Xbank_mem_0_reg[1][10] QDFFN $PINS Q=bank_mem_0[1][10]
+ D=FE_OFN99_bank_wdata_0__10 CK=CTS_773
Xbank_mem_0_reg[1][9] QDFFN $PINS Q=bank_mem_0[1][9]
+ D=FE_OFN100_bank_wdata_0__9 CK=CTS_773
Xbank_mem_0_reg[1][8] QDFFN $PINS Q=bank_mem_0[1][8]
+ D=FE_OFN101_bank_wdata_0__8 CK=CTS_773
Xbank_mem_0_reg[1][7] QDFFN $PINS Q=bank_mem_0[1][7]
+ D=FE_OFN102_bank_wdata_0__7 CK=CTS_773
Xbank_mem_0_reg[1][6] QDFFN $PINS Q=bank_mem_0[1][6]
+ D=FE_OFN103_bank_wdata_0__6 CK=CTS_773
Xbank_mem_0_reg[1][5] QDFFN $PINS Q=bank_mem_0[1][5]
+ D=FE_OFN104_bank_wdata_0__5 CK=CTS_773
Xbank_mem_0_reg[1][4] QDFFN $PINS Q=bank_mem_0[1][4]
+ D=FE_OFN105_bank_wdata_0__4 CK=CTS_773
Xbank_mem_0_reg[1][3] QDFFN $PINS Q=bank_mem_0[1][3]
+ D=FE_OFN106_bank_wdata_0__3 CK=CTS_773
Xbank_mem_0_reg[1][2] QDFFN $PINS Q=bank_mem_0[1][2]
+ D=FE_OFN107_bank_wdata_0__2 CK=CTS_773
Xbank_mem_0_reg[1][1] QDFFN $PINS Q=bank_mem_0[1][1]
+ D=FE_OFN108_bank_wdata_0__1 CK=CTS_773
Xbank_mem_0_reg[1][0] QDFFN $PINS Q=bank_mem_0[1][0]
+ D=FE_OFN109_bank_wdata_0__0 CK=CTS_773
Xbank_mem_1_reg[15][32] QDFFN $PINS Q=bank_mem_1[15][32]
+ D=FE_OFN43_bank_wdata_1__32 CK=CTS_644
Xbank_mem_1_reg[15][31] QDFFN $PINS Q=bank_mem_1[15][31]
+ D=FE_OFN44_bank_wdata_1__31 CK=CTS_644
Xbank_mem_1_reg[15][30] QDFFN $PINS Q=bank_mem_1[15][30]
+ D=FE_OFN45_bank_wdata_1__30 CK=CTS_644
Xbank_mem_1_reg[15][29] QDFFN $PINS Q=bank_mem_1[15][29]
+ D=FE_OFN46_bank_wdata_1__29 CK=CTS_644
Xbank_mem_1_reg[15][28] QDFFN $PINS Q=bank_mem_1[15][28]
+ D=FE_OFN47_bank_wdata_1__28 CK=CTS_644
Xbank_mem_1_reg[15][27] QDFFN $PINS Q=bank_mem_1[15][27]
+ D=FE_OFN48_bank_wdata_1__27 CK=CTS_644
Xbank_mem_1_reg[15][26] QDFFN $PINS Q=bank_mem_1[15][26]
+ D=FE_OFN49_bank_wdata_1__26 CK=CTS_644
Xbank_mem_1_reg[15][25] QDFFN $PINS Q=bank_mem_1[15][25]
+ D=FE_OFN50_bank_wdata_1__25 CK=CTS_644
Xbank_mem_1_reg[15][24] QDFFN $PINS Q=bank_mem_1[15][24]
+ D=FE_OFN51_bank_wdata_1__24 CK=CTS_644
Xbank_mem_1_reg[15][23] QDFFN $PINS Q=bank_mem_1[15][23]
+ D=FE_OFN52_bank_wdata_1__23 CK=CTS_644
Xbank_mem_1_reg[15][22] QDFFN $PINS Q=bank_mem_1[15][22]
+ D=FE_OFN53_bank_wdata_1__22 CK=CTS_644
Xbank_mem_1_reg[15][21] QDFFN $PINS Q=bank_mem_1[15][21]
+ D=FE_OFN54_bank_wdata_1__21 CK=CTS_644
Xbank_mem_1_reg[15][20] QDFFN $PINS Q=bank_mem_1[15][20]
+ D=FE_OFN55_bank_wdata_1__20 CK=CTS_644
Xbank_mem_1_reg[15][19] QDFFN $PINS Q=bank_mem_1[15][19]
+ D=FE_OFN56_bank_wdata_1__19 CK=CTS_644
Xbank_mem_1_reg[15][18] QDFFN $PINS Q=bank_mem_1[15][18]
+ D=FE_OFN57_bank_wdata_1__18 CK=CTS_644
Xbank_mem_1_reg[15][17] QDFFN $PINS Q=bank_mem_1[15][17]
+ D=FE_OFN58_bank_wdata_1__17 CK=CTS_644
Xbank_mem_1_reg[15][16] QDFFN $PINS Q=bank_mem_1[15][16]
+ D=FE_OFN59_bank_wdata_1__16 CK=CTS_641
Xbank_mem_1_reg[15][15] QDFFN $PINS Q=bank_mem_1[15][15]
+ D=FE_OFN60_bank_wdata_1__15 CK=CTS_641
Xbank_mem_1_reg[15][14] QDFFN $PINS Q=bank_mem_1[15][14]
+ D=FE_OFN61_bank_wdata_1__14 CK=CTS_641
Xbank_mem_1_reg[15][13] QDFFN $PINS Q=bank_mem_1[15][13]
+ D=FE_OFN62_bank_wdata_1__13 CK=CTS_641
Xbank_mem_1_reg[15][12] QDFFN $PINS Q=bank_mem_1[15][12]
+ D=FE_OFN63_bank_wdata_1__12 CK=CTS_641
Xbank_mem_1_reg[15][11] QDFFN $PINS Q=bank_mem_1[15][11]
+ D=FE_OFN64_bank_wdata_1__11 CK=CTS_641
Xbank_mem_1_reg[15][10] QDFFN $PINS Q=bank_mem_1[15][10]
+ D=FE_OFN65_bank_wdata_1__10 CK=CTS_641
Xbank_mem_1_reg[15][9] QDFFN $PINS Q=bank_mem_1[15][9]
+ D=FE_OFN66_bank_wdata_1__9 CK=CTS_641
Xbank_mem_1_reg[15][8] QDFFN $PINS Q=bank_mem_1[15][8]
+ D=FE_OFN67_bank_wdata_1__8 CK=CTS_641
Xbank_mem_1_reg[15][7] QDFFN $PINS Q=bank_mem_1[15][7]
+ D=FE_OFN68_bank_wdata_1__7 CK=CTS_641
Xbank_mem_1_reg[15][6] QDFFN $PINS Q=bank_mem_1[15][6]
+ D=FE_OFN69_bank_wdata_1__6 CK=CTS_641
Xbank_mem_1_reg[15][5] QDFFN $PINS Q=bank_mem_1[15][5]
+ D=FE_OFN70_bank_wdata_1__5 CK=CTS_641
Xbank_mem_1_reg[15][4] QDFFN $PINS Q=bank_mem_1[15][4]
+ D=FE_OFN71_bank_wdata_1__4 CK=CTS_641
Xbank_mem_1_reg[15][3] QDFFN $PINS Q=bank_mem_1[15][3]
+ D=FE_OFN72_bank_wdata_1__3 CK=CTS_641
Xbank_mem_1_reg[15][2] QDFFN $PINS Q=bank_mem_1[15][2]
+ D=FE_OFN73_bank_wdata_1__2 CK=CTS_641
Xbank_mem_1_reg[15][1] QDFFN $PINS Q=bank_mem_1[15][1]
+ D=FE_OFN74_bank_wdata_1__1 CK=CTS_641
Xbank_mem_1_reg[15][0] QDFFN $PINS Q=bank_mem_1[15][0]
+ D=FE_OFN75_bank_wdata_1__0 CK=CTS_641
Xbank_mem_1_reg[13][32] QDFFN $PINS Q=bank_mem_1[13][32]
+ D=FE_OFN43_bank_wdata_1__32 CK=CTS_656
Xbank_mem_1_reg[13][31] QDFFN $PINS Q=bank_mem_1[13][31]
+ D=FE_OFN44_bank_wdata_1__31 CK=CTS_656
Xbank_mem_1_reg[13][30] QDFFN $PINS Q=bank_mem_1[13][30]
+ D=FE_OFN45_bank_wdata_1__30 CK=CTS_656
Xbank_mem_1_reg[13][29] QDFFN $PINS Q=bank_mem_1[13][29]
+ D=FE_OFN46_bank_wdata_1__29 CK=CTS_656
Xbank_mem_1_reg[13][28] QDFFN $PINS Q=bank_mem_1[13][28]
+ D=FE_OFN47_bank_wdata_1__28 CK=CTS_656
Xbank_mem_1_reg[13][27] QDFFN $PINS Q=bank_mem_1[13][27]
+ D=FE_OFN48_bank_wdata_1__27 CK=CTS_656
Xbank_mem_1_reg[13][26] QDFFN $PINS Q=bank_mem_1[13][26]
+ D=FE_OFN49_bank_wdata_1__26 CK=CTS_656
Xbank_mem_1_reg[13][25] QDFFN $PINS Q=bank_mem_1[13][25]
+ D=FE_OFN50_bank_wdata_1__25 CK=CTS_656
Xbank_mem_1_reg[13][24] QDFFN $PINS Q=bank_mem_1[13][24]
+ D=FE_OFN51_bank_wdata_1__24 CK=CTS_656
Xbank_mem_1_reg[13][23] QDFFN $PINS Q=bank_mem_1[13][23]
+ D=FE_OFN52_bank_wdata_1__23 CK=CTS_656
Xbank_mem_1_reg[13][22] QDFFN $PINS Q=bank_mem_1[13][22]
+ D=FE_OFN53_bank_wdata_1__22 CK=CTS_656
Xbank_mem_1_reg[13][21] QDFFN $PINS Q=bank_mem_1[13][21]
+ D=FE_OFN54_bank_wdata_1__21 CK=CTS_656
Xbank_mem_1_reg[13][20] QDFFN $PINS Q=bank_mem_1[13][20]
+ D=FE_OFN55_bank_wdata_1__20 CK=CTS_656
Xbank_mem_1_reg[13][19] QDFFN $PINS Q=bank_mem_1[13][19]
+ D=FE_OFN56_bank_wdata_1__19 CK=CTS_656
Xbank_mem_1_reg[13][18] QDFFN $PINS Q=bank_mem_1[13][18]
+ D=FE_OFN57_bank_wdata_1__18 CK=CTS_656
Xbank_mem_1_reg[13][17] QDFFN $PINS Q=bank_mem_1[13][17]
+ D=FE_OFN58_bank_wdata_1__17 CK=CTS_656
Xbank_mem_1_reg[13][16] QDFFN $PINS Q=bank_mem_1[13][16]
+ D=FE_OFN59_bank_wdata_1__16 CK=CTS_653
Xbank_mem_1_reg[13][15] QDFFN $PINS Q=bank_mem_1[13][15]
+ D=FE_OFN60_bank_wdata_1__15 CK=CTS_653
Xbank_mem_1_reg[13][14] QDFFN $PINS Q=bank_mem_1[13][14]
+ D=FE_OFN61_bank_wdata_1__14 CK=CTS_653
Xbank_mem_1_reg[13][13] QDFFN $PINS Q=bank_mem_1[13][13]
+ D=FE_OFN62_bank_wdata_1__13 CK=CTS_653
Xbank_mem_1_reg[13][12] QDFFN $PINS Q=bank_mem_1[13][12]
+ D=FE_OFN63_bank_wdata_1__12 CK=CTS_653
Xbank_mem_1_reg[13][11] QDFFN $PINS Q=bank_mem_1[13][11]
+ D=FE_OFN64_bank_wdata_1__11 CK=CTS_653
Xbank_mem_1_reg[13][10] QDFFN $PINS Q=bank_mem_1[13][10]
+ D=FE_OFN65_bank_wdata_1__10 CK=CTS_653
Xbank_mem_1_reg[13][9] QDFFN $PINS Q=bank_mem_1[13][9]
+ D=FE_OFN66_bank_wdata_1__9 CK=CTS_653
Xbank_mem_1_reg[13][8] QDFFN $PINS Q=bank_mem_1[13][8]
+ D=FE_OFN67_bank_wdata_1__8 CK=CTS_653
Xbank_mem_1_reg[13][7] QDFFN $PINS Q=bank_mem_1[13][7]
+ D=FE_OFN68_bank_wdata_1__7 CK=CTS_653
Xbank_mem_1_reg[13][6] QDFFN $PINS Q=bank_mem_1[13][6]
+ D=FE_OFN69_bank_wdata_1__6 CK=CTS_653
Xbank_mem_1_reg[13][5] QDFFN $PINS Q=bank_mem_1[13][5]
+ D=FE_OFN70_bank_wdata_1__5 CK=CTS_653
Xbank_mem_1_reg[13][4] QDFFN $PINS Q=bank_mem_1[13][4]
+ D=FE_OFN71_bank_wdata_1__4 CK=CTS_653
Xbank_mem_1_reg[13][3] QDFFN $PINS Q=bank_mem_1[13][3]
+ D=FE_OFN72_bank_wdata_1__3 CK=CTS_653
Xbank_mem_1_reg[13][2] QDFFN $PINS Q=bank_mem_1[13][2]
+ D=FE_OFN73_bank_wdata_1__2 CK=CTS_653
Xbank_mem_1_reg[13][1] QDFFN $PINS Q=bank_mem_1[13][1]
+ D=FE_OFN74_bank_wdata_1__1 CK=CTS_653
Xbank_mem_1_reg[13][0] QDFFN $PINS Q=bank_mem_1[13][0]
+ D=FE_OFN75_bank_wdata_1__0 CK=CTS_653
Xbank_mem_1_reg[14][32] QDFFN $PINS Q=bank_mem_1[14][32]
+ D=FE_OFN43_bank_wdata_1__32 CK=CTS_650
Xbank_mem_1_reg[14][31] QDFFN $PINS Q=bank_mem_1[14][31]
+ D=FE_OFN44_bank_wdata_1__31 CK=CTS_650
Xbank_mem_1_reg[14][30] QDFFN $PINS Q=bank_mem_1[14][30]
+ D=FE_OFN45_bank_wdata_1__30 CK=CTS_650
Xbank_mem_1_reg[14][29] QDFFN $PINS Q=bank_mem_1[14][29]
+ D=FE_OFN46_bank_wdata_1__29 CK=CTS_650
Xbank_mem_1_reg[14][28] QDFFN $PINS Q=bank_mem_1[14][28]
+ D=FE_OFN47_bank_wdata_1__28 CK=CTS_650
Xbank_mem_1_reg[14][27] QDFFN $PINS Q=bank_mem_1[14][27]
+ D=FE_OFN48_bank_wdata_1__27 CK=CTS_650
Xbank_mem_1_reg[14][26] QDFFN $PINS Q=bank_mem_1[14][26]
+ D=FE_OFN49_bank_wdata_1__26 CK=CTS_650
Xbank_mem_1_reg[14][25] QDFFN $PINS Q=bank_mem_1[14][25]
+ D=FE_OFN50_bank_wdata_1__25 CK=CTS_650
Xbank_mem_1_reg[14][24] QDFFN $PINS Q=bank_mem_1[14][24]
+ D=FE_OFN51_bank_wdata_1__24 CK=CTS_650
Xbank_mem_1_reg[14][23] QDFFN $PINS Q=bank_mem_1[14][23]
+ D=FE_OFN52_bank_wdata_1__23 CK=CTS_650
Xbank_mem_1_reg[14][22] QDFFN $PINS Q=bank_mem_1[14][22]
+ D=FE_OFN53_bank_wdata_1__22 CK=CTS_650
Xbank_mem_1_reg[14][21] QDFFN $PINS Q=bank_mem_1[14][21]
+ D=FE_OFN54_bank_wdata_1__21 CK=CTS_650
Xbank_mem_1_reg[14][20] QDFFN $PINS Q=bank_mem_1[14][20]
+ D=FE_OFN55_bank_wdata_1__20 CK=CTS_650
Xbank_mem_1_reg[14][19] QDFFN $PINS Q=bank_mem_1[14][19]
+ D=FE_OFN56_bank_wdata_1__19 CK=CTS_650
Xbank_mem_1_reg[14][18] QDFFN $PINS Q=bank_mem_1[14][18]
+ D=FE_OFN57_bank_wdata_1__18 CK=CTS_650
Xbank_mem_1_reg[14][17] QDFFN $PINS Q=bank_mem_1[14][17]
+ D=FE_OFN58_bank_wdata_1__17 CK=CTS_650
Xbank_mem_1_reg[14][16] QDFFN $PINS Q=bank_mem_1[14][16]
+ D=FE_OFN59_bank_wdata_1__16 CK=CTS_647
Xbank_mem_1_reg[14][15] QDFFN $PINS Q=bank_mem_1[14][15]
+ D=FE_OFN60_bank_wdata_1__15 CK=CTS_647
Xbank_mem_1_reg[14][14] QDFFN $PINS Q=bank_mem_1[14][14]
+ D=FE_OFN61_bank_wdata_1__14 CK=CTS_647
Xbank_mem_1_reg[14][13] QDFFN $PINS Q=bank_mem_1[14][13]
+ D=FE_OFN62_bank_wdata_1__13 CK=CTS_647
Xbank_mem_1_reg[14][12] QDFFN $PINS Q=bank_mem_1[14][12]
+ D=FE_OFN63_bank_wdata_1__12 CK=CTS_647
Xbank_mem_1_reg[14][11] QDFFN $PINS Q=bank_mem_1[14][11]
+ D=FE_OFN64_bank_wdata_1__11 CK=CTS_647
Xbank_mem_1_reg[14][10] QDFFN $PINS Q=bank_mem_1[14][10]
+ D=FE_OFN65_bank_wdata_1__10 CK=CTS_647
Xbank_mem_1_reg[14][9] QDFFN $PINS Q=bank_mem_1[14][9]
+ D=FE_OFN66_bank_wdata_1__9 CK=CTS_647
Xbank_mem_1_reg[14][8] QDFFN $PINS Q=bank_mem_1[14][8]
+ D=FE_OFN67_bank_wdata_1__8 CK=CTS_647
Xbank_mem_1_reg[14][7] QDFFN $PINS Q=bank_mem_1[14][7]
+ D=FE_OFN68_bank_wdata_1__7 CK=CTS_647
Xbank_mem_1_reg[14][6] QDFFN $PINS Q=bank_mem_1[14][6]
+ D=FE_OFN69_bank_wdata_1__6 CK=CTS_647
Xbank_mem_1_reg[14][5] QDFFN $PINS Q=bank_mem_1[14][5]
+ D=FE_OFN70_bank_wdata_1__5 CK=CTS_647
Xbank_mem_1_reg[14][4] QDFFN $PINS Q=bank_mem_1[14][4]
+ D=FE_OFN71_bank_wdata_1__4 CK=CTS_647
Xbank_mem_1_reg[14][3] QDFFN $PINS Q=bank_mem_1[14][3]
+ D=FE_OFN72_bank_wdata_1__3 CK=CTS_647
Xbank_mem_1_reg[14][2] QDFFN $PINS Q=bank_mem_1[14][2]
+ D=FE_OFN73_bank_wdata_1__2 CK=CTS_647
Xbank_mem_1_reg[14][1] QDFFN $PINS Q=bank_mem_1[14][1]
+ D=FE_OFN74_bank_wdata_1__1 CK=CTS_647
Xbank_mem_1_reg[14][0] QDFFN $PINS Q=bank_mem_1[14][0]
+ D=FE_OFN75_bank_wdata_1__0 CK=CTS_647
Xbank_mem_1_reg[15][33] QDFFN $PINS Q=bank_mem_1[15][33]
+ D=FE_OFN42_bank_wdata_1__33 CK=CTS_644
Xbank_mem_1_reg[12][32] QDFFN $PINS Q=bank_mem_1[12][32]
+ D=FE_OFN43_bank_wdata_1__32 CK=CTS_662
Xbank_mem_1_reg[12][31] QDFFN $PINS Q=bank_mem_1[12][31]
+ D=FE_OFN44_bank_wdata_1__31 CK=CTS_662
Xbank_mem_1_reg[12][30] QDFFN $PINS Q=bank_mem_1[12][30]
+ D=FE_OFN45_bank_wdata_1__30 CK=CTS_662
Xbank_mem_1_reg[12][29] QDFFN $PINS Q=bank_mem_1[12][29]
+ D=FE_OFN46_bank_wdata_1__29 CK=CTS_662
Xbank_mem_1_reg[12][28] QDFFN $PINS Q=bank_mem_1[12][28]
+ D=FE_OFN47_bank_wdata_1__28 CK=CTS_662
Xbank_mem_1_reg[12][27] QDFFN $PINS Q=bank_mem_1[12][27]
+ D=FE_OFN48_bank_wdata_1__27 CK=CTS_662
Xbank_mem_1_reg[12][26] QDFFN $PINS Q=bank_mem_1[12][26]
+ D=FE_OFN49_bank_wdata_1__26 CK=CTS_662
Xbank_mem_1_reg[12][25] QDFFN $PINS Q=bank_mem_1[12][25]
+ D=FE_OFN50_bank_wdata_1__25 CK=CTS_662
Xbank_mem_1_reg[12][24] QDFFN $PINS Q=bank_mem_1[12][24]
+ D=FE_OFN51_bank_wdata_1__24 CK=CTS_662
Xbank_mem_1_reg[12][23] QDFFN $PINS Q=bank_mem_1[12][23]
+ D=FE_OFN52_bank_wdata_1__23 CK=CTS_662
Xbank_mem_1_reg[12][22] QDFFN $PINS Q=bank_mem_1[12][22]
+ D=FE_OFN53_bank_wdata_1__22 CK=CTS_662
Xbank_mem_1_reg[12][21] QDFFN $PINS Q=bank_mem_1[12][21]
+ D=FE_OFN54_bank_wdata_1__21 CK=CTS_662
Xbank_mem_1_reg[12][20] QDFFN $PINS Q=bank_mem_1[12][20]
+ D=FE_OFN55_bank_wdata_1__20 CK=CTS_662
Xbank_mem_1_reg[12][19] QDFFN $PINS Q=bank_mem_1[12][19]
+ D=FE_OFN56_bank_wdata_1__19 CK=CTS_662
Xbank_mem_1_reg[12][18] QDFFN $PINS Q=bank_mem_1[12][18]
+ D=FE_OFN57_bank_wdata_1__18 CK=CTS_662
Xbank_mem_1_reg[12][17] QDFFN $PINS Q=bank_mem_1[12][17]
+ D=FE_OFN58_bank_wdata_1__17 CK=CTS_662
Xbank_mem_1_reg[12][16] QDFFN $PINS Q=bank_mem_1[12][16]
+ D=FE_OFN59_bank_wdata_1__16 CK=CTS_659
Xbank_mem_1_reg[12][15] QDFFN $PINS Q=bank_mem_1[12][15]
+ D=FE_OFN60_bank_wdata_1__15 CK=CTS_659
Xbank_mem_1_reg[12][14] QDFFN $PINS Q=bank_mem_1[12][14]
+ D=FE_OFN61_bank_wdata_1__14 CK=CTS_659
Xbank_mem_1_reg[12][13] QDFFN $PINS Q=bank_mem_1[12][13]
+ D=FE_OFN62_bank_wdata_1__13 CK=CTS_659
Xbank_mem_1_reg[12][12] QDFFN $PINS Q=bank_mem_1[12][12]
+ D=FE_OFN63_bank_wdata_1__12 CK=CTS_659
Xbank_mem_1_reg[12][11] QDFFN $PINS Q=bank_mem_1[12][11]
+ D=FE_OFN64_bank_wdata_1__11 CK=CTS_659
Xbank_mem_1_reg[12][10] QDFFN $PINS Q=bank_mem_1[12][10]
+ D=FE_OFN65_bank_wdata_1__10 CK=CTS_659
Xbank_mem_1_reg[12][9] QDFFN $PINS Q=bank_mem_1[12][9]
+ D=FE_OFN66_bank_wdata_1__9 CK=CTS_659
Xbank_mem_1_reg[12][8] QDFFN $PINS Q=bank_mem_1[12][8]
+ D=FE_OFN67_bank_wdata_1__8 CK=CTS_659
Xbank_mem_1_reg[12][7] QDFFN $PINS Q=bank_mem_1[12][7]
+ D=FE_OFN68_bank_wdata_1__7 CK=CTS_659
Xbank_mem_1_reg[12][6] QDFFN $PINS Q=bank_mem_1[12][6]
+ D=FE_OFN69_bank_wdata_1__6 CK=CTS_659
Xbank_mem_1_reg[12][5] QDFFN $PINS Q=bank_mem_1[12][5]
+ D=FE_OFN70_bank_wdata_1__5 CK=CTS_659
Xbank_mem_1_reg[12][4] QDFFN $PINS Q=bank_mem_1[12][4]
+ D=FE_OFN71_bank_wdata_1__4 CK=CTS_659
Xbank_mem_1_reg[12][3] QDFFN $PINS Q=bank_mem_1[12][3]
+ D=FE_OFN72_bank_wdata_1__3 CK=CTS_659
Xbank_mem_1_reg[12][2] QDFFN $PINS Q=bank_mem_1[12][2]
+ D=FE_OFN73_bank_wdata_1__2 CK=CTS_659
Xbank_mem_1_reg[12][1] QDFFN $PINS Q=bank_mem_1[12][1]
+ D=FE_OFN74_bank_wdata_1__1 CK=CTS_659
Xbank_mem_1_reg[12][0] QDFFN $PINS Q=bank_mem_1[12][0]
+ D=FE_OFN75_bank_wdata_1__0 CK=CTS_659
Xbank_mem_1_reg[13][33] QDFFN $PINS Q=bank_mem_1[13][33]
+ D=FE_OFN42_bank_wdata_1__33 CK=CTS_656
Xbank_mem_0_reg[15][32] QDFFN $PINS Q=bank_mem_0[15][32]
+ D=FE_OFN78_bank_wdata_0__32 CK=CTS_592
Xbank_mem_0_reg[15][31] QDFFN $PINS Q=bank_mem_0[15][31]
+ D=FE_PHN1451_FE_OFN79_bank_wdata_0__31 CK=CTS_592
Xbank_mem_0_reg[15][30] QDFFN $PINS Q=bank_mem_0[15][30]
+ D=FE_PHN1446_FE_OFN80_bank_wdata_0__30 CK=CTS_592
Xbank_mem_0_reg[15][29] QDFFN $PINS Q=bank_mem_0[15][29]
+ D=FE_PHN1411_FE_OFN81_bank_wdata_0__29 CK=CTS_592
Xbank_mem_0_reg[15][28] QDFFN $PINS Q=bank_mem_0[15][28]
+ D=FE_PHN1415_FE_OFN82_bank_wdata_0__28 CK=CTS_592
Xbank_mem_0_reg[15][27] QDFFN $PINS Q=bank_mem_0[15][27]
+ D=FE_PHN1450_bank_wdata_0_27 CK=CTS_592
Xbank_mem_0_reg[15][26] QDFFN $PINS Q=bank_mem_0[15][26]
+ D=FE_OFN83_bank_wdata_0__26 CK=CTS_592
Xbank_mem_0_reg[15][25] QDFFN $PINS Q=bank_mem_0[15][25]
+ D=FE_OFN84_bank_wdata_0__25 CK=CTS_592
Xbank_mem_0_reg[15][24] QDFFN $PINS Q=bank_mem_0[15][24]
+ D=FE_OFN85_bank_wdata_0__24 CK=CTS_592
Xbank_mem_0_reg[15][23] QDFFN $PINS Q=bank_mem_0[15][23]
+ D=FE_OFN86_bank_wdata_0__23 CK=CTS_592
Xbank_mem_0_reg[15][22] QDFFN $PINS Q=bank_mem_0[15][22]
+ D=FE_OFN87_bank_wdata_0__22 CK=CTS_592
Xbank_mem_0_reg[15][21] QDFFN $PINS Q=bank_mem_0[15][21]
+ D=FE_OFN88_bank_wdata_0__21 CK=CTS_592
Xbank_mem_0_reg[15][20] QDFFN $PINS Q=bank_mem_0[15][20]
+ D=FE_OFN89_bank_wdata_0__20 CK=CTS_592
Xbank_mem_0_reg[15][19] QDFFN $PINS Q=bank_mem_0[15][19]
+ D=FE_OFN90_bank_wdata_0__19 CK=CTS_592
Xbank_mem_0_reg[15][18] QDFFN $PINS Q=bank_mem_0[15][18]
+ D=FE_OFN91_bank_wdata_0__18 CK=CTS_592
Xbank_mem_0_reg[15][17] QDFFN $PINS Q=bank_mem_0[15][17]
+ D=FE_OFN92_bank_wdata_0__17 CK=CTS_592
Xbank_mem_0_reg[15][16] QDFFN $PINS Q=bank_mem_0[15][16]
+ D=FE_OFN93_bank_wdata_0__16 CK=CTS_589
Xbank_mem_0_reg[15][15] QDFFN $PINS Q=bank_mem_0[15][15]
+ D=FE_PHN1017_FE_OFN94_bank_wdata_0__15 CK=CTS_589
Xbank_mem_0_reg[15][14] QDFFN $PINS Q=bank_mem_0[15][14]
+ D=FE_OFN95_bank_wdata_0__14 CK=CTS_589
Xbank_mem_0_reg[15][13] QDFFN $PINS Q=bank_mem_0[15][13]
+ D=FE_PHN1092_FE_OFN96_bank_wdata_0__13 CK=CTS_589
Xbank_mem_0_reg[15][12] QDFFN $PINS Q=bank_mem_0[15][12]
+ D=FE_PHN1124_FE_OFN97_bank_wdata_0__12 CK=CTS_589
Xbank_mem_0_reg[15][11] QDFFN $PINS Q=bank_mem_0[15][11]
+ D=FE_OFN98_bank_wdata_0__11 CK=CTS_589
Xbank_mem_0_reg[15][10] QDFFN $PINS Q=bank_mem_0[15][10]
+ D=FE_OFN99_bank_wdata_0__10 CK=CTS_589
Xbank_mem_0_reg[15][9] QDFFN $PINS Q=bank_mem_0[15][9]
+ D=FE_OFN100_bank_wdata_0__9 CK=CTS_589
Xbank_mem_0_reg[15][8] QDFFN $PINS Q=bank_mem_0[15][8]
+ D=FE_OFN101_bank_wdata_0__8 CK=CTS_589
Xbank_mem_0_reg[15][7] QDFFN $PINS Q=bank_mem_0[15][7]
+ D=FE_OFN102_bank_wdata_0__7 CK=CTS_589
Xbank_mem_0_reg[15][6] QDFFN $PINS Q=bank_mem_0[15][6]
+ D=FE_OFN103_bank_wdata_0__6 CK=CTS_589
Xbank_mem_0_reg[15][5] QDFFN $PINS Q=bank_mem_0[15][5]
+ D=FE_OFN104_bank_wdata_0__5 CK=CTS_589
Xbank_mem_0_reg[15][4] QDFFN $PINS Q=bank_mem_0[15][4]
+ D=FE_OFN105_bank_wdata_0__4 CK=CTS_589
Xbank_mem_0_reg[15][3] QDFFN $PINS Q=bank_mem_0[15][3]
+ D=FE_OFN106_bank_wdata_0__3 CK=CTS_589
Xbank_mem_0_reg[15][2] QDFFN $PINS Q=bank_mem_0[15][2]
+ D=FE_OFN107_bank_wdata_0__2 CK=CTS_589
Xbank_mem_0_reg[15][1] QDFFN $PINS Q=bank_mem_0[15][1]
+ D=FE_OFN108_bank_wdata_0__1 CK=CTS_589
Xbank_mem_0_reg[15][0] QDFFN $PINS Q=bank_mem_0[15][0]
+ D=FE_OFN109_bank_wdata_0__0 CK=CTS_589
Xbank_mem_0_reg[13][32] QDFFN $PINS Q=bank_mem_0[13][32]
+ D=FE_OFN78_bank_wdata_0__32 CK=CTS_604
Xbank_mem_0_reg[13][31] QDFFN $PINS Q=bank_mem_0[13][31]
+ D=FE_PHN1451_FE_OFN79_bank_wdata_0__31 CK=CTS_604
Xbank_mem_0_reg[13][30] QDFFN $PINS Q=bank_mem_0[13][30]
+ D=FE_PHN1446_FE_OFN80_bank_wdata_0__30 CK=CTS_604
Xbank_mem_0_reg[13][29] QDFFN $PINS Q=bank_mem_0[13][29]
+ D=FE_PHN1411_FE_OFN81_bank_wdata_0__29 CK=CTS_604
Xbank_mem_0_reg[13][28] QDFFN $PINS Q=bank_mem_0[13][28]
+ D=FE_PHN1415_FE_OFN82_bank_wdata_0__28 CK=CTS_604
Xbank_mem_0_reg[13][27] QDFFN $PINS Q=bank_mem_0[13][27]
+ D=FE_PHN1450_bank_wdata_0_27 CK=CTS_604
Xbank_mem_0_reg[13][26] QDFFN $PINS Q=bank_mem_0[13][26]
+ D=FE_OFN83_bank_wdata_0__26 CK=CTS_604
Xbank_mem_0_reg[13][25] QDFFN $PINS Q=bank_mem_0[13][25]
+ D=FE_OFN84_bank_wdata_0__25 CK=CTS_604
Xbank_mem_0_reg[13][24] QDFFN $PINS Q=bank_mem_0[13][24]
+ D=FE_OFN85_bank_wdata_0__24 CK=CTS_604
Xbank_mem_0_reg[13][23] QDFFN $PINS Q=bank_mem_0[13][23]
+ D=FE_OFN86_bank_wdata_0__23 CK=CTS_604
Xbank_mem_0_reg[13][22] QDFFN $PINS Q=bank_mem_0[13][22]
+ D=FE_OFN87_bank_wdata_0__22 CK=CTS_604
Xbank_mem_0_reg[13][21] QDFFN $PINS Q=bank_mem_0[13][21]
+ D=FE_OFN88_bank_wdata_0__21 CK=CTS_604
Xbank_mem_0_reg[13][20] QDFFN $PINS Q=bank_mem_0[13][20]
+ D=FE_OFN89_bank_wdata_0__20 CK=CTS_604
Xbank_mem_0_reg[13][19] QDFFN $PINS Q=bank_mem_0[13][19]
+ D=FE_OFN90_bank_wdata_0__19 CK=CTS_604
Xbank_mem_0_reg[13][18] QDFFN $PINS Q=bank_mem_0[13][18]
+ D=FE_OFN91_bank_wdata_0__18 CK=CTS_604
Xbank_mem_0_reg[13][17] QDFFN $PINS Q=bank_mem_0[13][17]
+ D=FE_OFN92_bank_wdata_0__17 CK=CTS_604
Xbank_mem_0_reg[13][16] QDFFN $PINS Q=bank_mem_0[13][16]
+ D=FE_OFN93_bank_wdata_0__16 CK=CTS_601
Xbank_mem_0_reg[13][15] QDFFN $PINS Q=bank_mem_0[13][15]
+ D=FE_PHN1017_FE_OFN94_bank_wdata_0__15 CK=CTS_601
Xbank_mem_0_reg[13][14] QDFFN $PINS Q=bank_mem_0[13][14]
+ D=FE_OFN95_bank_wdata_0__14 CK=CTS_601
Xbank_mem_0_reg[13][13] QDFFN $PINS Q=bank_mem_0[13][13]
+ D=FE_PHN1092_FE_OFN96_bank_wdata_0__13 CK=CTS_601
Xbank_mem_0_reg[13][12] QDFFN $PINS Q=bank_mem_0[13][12]
+ D=FE_PHN1124_FE_OFN97_bank_wdata_0__12 CK=CTS_601
Xbank_mem_0_reg[13][11] QDFFN $PINS Q=bank_mem_0[13][11]
+ D=FE_OFN98_bank_wdata_0__11 CK=CTS_601
Xbank_mem_0_reg[13][10] QDFFN $PINS Q=bank_mem_0[13][10]
+ D=FE_OFN99_bank_wdata_0__10 CK=CTS_601
Xbank_mem_0_reg[13][9] QDFFN $PINS Q=bank_mem_0[13][9]
+ D=FE_OFN100_bank_wdata_0__9 CK=CTS_601
Xbank_mem_0_reg[13][8] QDFFN $PINS Q=bank_mem_0[13][8]
+ D=FE_OFN101_bank_wdata_0__8 CK=CTS_601
Xbank_mem_0_reg[13][7] QDFFN $PINS Q=bank_mem_0[13][7]
+ D=FE_OFN102_bank_wdata_0__7 CK=CTS_601
Xbank_mem_0_reg[13][6] QDFFN $PINS Q=bank_mem_0[13][6]
+ D=FE_OFN103_bank_wdata_0__6 CK=CTS_601
Xbank_mem_0_reg[13][5] QDFFN $PINS Q=bank_mem_0[13][5]
+ D=FE_OFN104_bank_wdata_0__5 CK=CTS_601
Xbank_mem_0_reg[13][4] QDFFN $PINS Q=bank_mem_0[13][4]
+ D=FE_OFN105_bank_wdata_0__4 CK=CTS_601
Xbank_mem_0_reg[13][3] QDFFN $PINS Q=bank_mem_0[13][3]
+ D=FE_OFN106_bank_wdata_0__3 CK=CTS_601
Xbank_mem_0_reg[13][2] QDFFN $PINS Q=bank_mem_0[13][2]
+ D=FE_OFN107_bank_wdata_0__2 CK=CTS_601
Xbank_mem_0_reg[13][1] QDFFN $PINS Q=bank_mem_0[13][1]
+ D=FE_OFN108_bank_wdata_0__1 CK=CTS_601
Xbank_mem_0_reg[13][0] QDFFN $PINS Q=bank_mem_0[13][0]
+ D=FE_OFN109_bank_wdata_0__0 CK=CTS_601
Xbank_mem_1_reg[14][33] QDFFN $PINS Q=bank_mem_1[14][33]
+ D=FE_OFN42_bank_wdata_1__33 CK=CTS_650
Xbank_mem_1_reg[12][33] QDFFN $PINS Q=bank_mem_1[12][33]
+ D=FE_OFN42_bank_wdata_1__33 CK=CTS_662
Xbank_mem_0_reg[14][32] QDFFN $PINS Q=bank_mem_0[14][32]
+ D=FE_OFN78_bank_wdata_0__32 CK=CTS_598
Xbank_mem_0_reg[14][31] QDFFN $PINS Q=bank_mem_0[14][31]
+ D=FE_PHN1451_FE_OFN79_bank_wdata_0__31 CK=CTS_598
Xbank_mem_0_reg[14][30] QDFFN $PINS Q=bank_mem_0[14][30]
+ D=FE_PHN1446_FE_OFN80_bank_wdata_0__30 CK=CTS_598
Xbank_mem_0_reg[14][29] QDFFN $PINS Q=bank_mem_0[14][29]
+ D=FE_PHN1411_FE_OFN81_bank_wdata_0__29 CK=CTS_598
Xbank_mem_0_reg[14][28] QDFFN $PINS Q=bank_mem_0[14][28]
+ D=FE_PHN1415_FE_OFN82_bank_wdata_0__28 CK=CTS_598
Xbank_mem_0_reg[14][27] QDFFN $PINS Q=bank_mem_0[14][27]
+ D=FE_PHN1450_bank_wdata_0_27 CK=CTS_598
Xbank_mem_0_reg[14][26] QDFFN $PINS Q=bank_mem_0[14][26]
+ D=FE_OFN83_bank_wdata_0__26 CK=CTS_598
Xbank_mem_0_reg[14][25] QDFFN $PINS Q=bank_mem_0[14][25]
+ D=FE_OFN84_bank_wdata_0__25 CK=CTS_598
Xbank_mem_0_reg[14][24] QDFFN $PINS Q=bank_mem_0[14][24]
+ D=FE_OFN85_bank_wdata_0__24 CK=CTS_598
Xbank_mem_0_reg[14][23] QDFFN $PINS Q=bank_mem_0[14][23]
+ D=FE_OFN86_bank_wdata_0__23 CK=CTS_598
Xbank_mem_0_reg[14][22] QDFFN $PINS Q=bank_mem_0[14][22]
+ D=FE_OFN87_bank_wdata_0__22 CK=CTS_598
Xbank_mem_0_reg[14][21] QDFFN $PINS Q=bank_mem_0[14][21]
+ D=FE_OFN88_bank_wdata_0__21 CK=CTS_598
Xbank_mem_0_reg[14][20] QDFFN $PINS Q=bank_mem_0[14][20]
+ D=FE_OFN89_bank_wdata_0__20 CK=CTS_598
Xbank_mem_0_reg[14][19] QDFFN $PINS Q=bank_mem_0[14][19]
+ D=FE_OFN90_bank_wdata_0__19 CK=CTS_598
Xbank_mem_0_reg[14][18] QDFFN $PINS Q=bank_mem_0[14][18]
+ D=FE_OFN91_bank_wdata_0__18 CK=CTS_598
Xbank_mem_0_reg[14][17] QDFFN $PINS Q=bank_mem_0[14][17]
+ D=FE_OFN92_bank_wdata_0__17 CK=CTS_598
Xbank_mem_0_reg[14][16] QDFFN $PINS Q=bank_mem_0[14][16]
+ D=FE_OFN93_bank_wdata_0__16 CK=CTS_595
Xbank_mem_0_reg[14][15] QDFFN $PINS Q=bank_mem_0[14][15]
+ D=FE_PHN1017_FE_OFN94_bank_wdata_0__15 CK=CTS_595
Xbank_mem_0_reg[14][14] QDFFN $PINS Q=bank_mem_0[14][14]
+ D=FE_OFN95_bank_wdata_0__14 CK=CTS_595
Xbank_mem_0_reg[14][13] QDFFN $PINS Q=bank_mem_0[14][13]
+ D=FE_PHN1092_FE_OFN96_bank_wdata_0__13 CK=CTS_595
Xbank_mem_0_reg[14][12] QDFFN $PINS Q=bank_mem_0[14][12]
+ D=FE_PHN1124_FE_OFN97_bank_wdata_0__12 CK=CTS_595
Xbank_mem_0_reg[14][11] QDFFN $PINS Q=bank_mem_0[14][11]
+ D=FE_OFN98_bank_wdata_0__11 CK=CTS_595
Xbank_mem_0_reg[14][10] QDFFN $PINS Q=bank_mem_0[14][10]
+ D=FE_OFN99_bank_wdata_0__10 CK=CTS_595
Xbank_mem_0_reg[14][9] QDFFN $PINS Q=bank_mem_0[14][9]
+ D=FE_OFN100_bank_wdata_0__9 CK=CTS_595
Xbank_mem_0_reg[14][8] QDFFN $PINS Q=bank_mem_0[14][8]
+ D=FE_OFN101_bank_wdata_0__8 CK=CTS_595
Xbank_mem_0_reg[14][7] QDFFN $PINS Q=bank_mem_0[14][7]
+ D=FE_OFN102_bank_wdata_0__7 CK=CTS_595
Xbank_mem_0_reg[14][6] QDFFN $PINS Q=bank_mem_0[14][6]
+ D=FE_OFN103_bank_wdata_0__6 CK=CTS_595
Xbank_mem_0_reg[14][5] QDFFN $PINS Q=bank_mem_0[14][5]
+ D=FE_OFN104_bank_wdata_0__5 CK=CTS_595
Xbank_mem_0_reg[14][4] QDFFN $PINS Q=bank_mem_0[14][4]
+ D=FE_OFN105_bank_wdata_0__4 CK=CTS_595
Xbank_mem_0_reg[14][3] QDFFN $PINS Q=bank_mem_0[14][3]
+ D=FE_OFN106_bank_wdata_0__3 CK=CTS_595
Xbank_mem_0_reg[14][2] QDFFN $PINS Q=bank_mem_0[14][2]
+ D=FE_OFN107_bank_wdata_0__2 CK=CTS_595
Xbank_mem_0_reg[14][1] QDFFN $PINS Q=bank_mem_0[14][1]
+ D=FE_OFN108_bank_wdata_0__1 CK=CTS_595
Xbank_mem_0_reg[14][0] QDFFN $PINS Q=bank_mem_0[14][0]
+ D=FE_OFN109_bank_wdata_0__0 CK=CTS_595
Xbank_mem_0_reg[15][33] QDFFN $PINS Q=bank_mem_0[15][33]
+ D=FE_PHN1356_FE_OFN77_bank_wdata_0__33 CK=CTS_592
Xbank_mem_0_reg[12][32] QDFFN $PINS Q=bank_mem_0[12][32]
+ D=FE_OFN78_bank_wdata_0__32 CK=CTS_610
Xbank_mem_0_reg[12][31] QDFFN $PINS Q=bank_mem_0[12][31]
+ D=FE_PHN1451_FE_OFN79_bank_wdata_0__31 CK=CTS_610
Xbank_mem_0_reg[12][30] QDFFN $PINS Q=bank_mem_0[12][30]
+ D=FE_PHN1446_FE_OFN80_bank_wdata_0__30 CK=CTS_610
Xbank_mem_0_reg[12][29] QDFFN $PINS Q=bank_mem_0[12][29]
+ D=FE_PHN1411_FE_OFN81_bank_wdata_0__29 CK=CTS_610
Xbank_mem_0_reg[12][28] QDFFN $PINS Q=bank_mem_0[12][28]
+ D=FE_PHN1415_FE_OFN82_bank_wdata_0__28 CK=CTS_610
Xbank_mem_0_reg[12][27] QDFFN $PINS Q=bank_mem_0[12][27]
+ D=FE_PHN1450_bank_wdata_0_27 CK=CTS_610
Xbank_mem_0_reg[12][26] QDFFN $PINS Q=bank_mem_0[12][26]
+ D=FE_OFN83_bank_wdata_0__26 CK=CTS_610
Xbank_mem_0_reg[12][25] QDFFN $PINS Q=bank_mem_0[12][25]
+ D=FE_OFN84_bank_wdata_0__25 CK=CTS_610
Xbank_mem_0_reg[12][24] QDFFN $PINS Q=bank_mem_0[12][24]
+ D=FE_OFN85_bank_wdata_0__24 CK=CTS_610
Xbank_mem_0_reg[12][23] QDFFN $PINS Q=bank_mem_0[12][23]
+ D=FE_OFN86_bank_wdata_0__23 CK=CTS_610
Xbank_mem_0_reg[12][22] QDFFN $PINS Q=bank_mem_0[12][22]
+ D=FE_OFN87_bank_wdata_0__22 CK=CTS_610
Xbank_mem_0_reg[12][21] QDFFN $PINS Q=bank_mem_0[12][21]
+ D=FE_OFN88_bank_wdata_0__21 CK=CTS_610
Xbank_mem_0_reg[12][20] QDFFN $PINS Q=bank_mem_0[12][20]
+ D=FE_OFN89_bank_wdata_0__20 CK=CTS_610
Xbank_mem_0_reg[12][19] QDFFN $PINS Q=bank_mem_0[12][19]
+ D=FE_OFN90_bank_wdata_0__19 CK=CTS_610
Xbank_mem_0_reg[12][18] QDFFN $PINS Q=bank_mem_0[12][18]
+ D=FE_OFN91_bank_wdata_0__18 CK=CTS_610
Xbank_mem_0_reg[12][17] QDFFN $PINS Q=bank_mem_0[12][17]
+ D=FE_OFN92_bank_wdata_0__17 CK=CTS_610
Xbank_mem_0_reg[12][16] QDFFN $PINS Q=bank_mem_0[12][16]
+ D=FE_OFN93_bank_wdata_0__16 CK=CTS_607
Xbank_mem_0_reg[12][15] QDFFN $PINS Q=bank_mem_0[12][15]
+ D=FE_PHN1017_FE_OFN94_bank_wdata_0__15 CK=CTS_607
Xbank_mem_0_reg[12][14] QDFFN $PINS Q=bank_mem_0[12][14]
+ D=FE_OFN95_bank_wdata_0__14 CK=CTS_607
Xbank_mem_0_reg[12][13] QDFFN $PINS Q=bank_mem_0[12][13]
+ D=FE_PHN1092_FE_OFN96_bank_wdata_0__13 CK=CTS_607
Xbank_mem_0_reg[12][12] QDFFN $PINS Q=bank_mem_0[12][12]
+ D=FE_PHN1124_FE_OFN97_bank_wdata_0__12 CK=CTS_607
Xbank_mem_0_reg[12][11] QDFFN $PINS Q=bank_mem_0[12][11]
+ D=FE_OFN98_bank_wdata_0__11 CK=CTS_607
Xbank_mem_0_reg[12][10] QDFFN $PINS Q=bank_mem_0[12][10]
+ D=FE_OFN99_bank_wdata_0__10 CK=CTS_607
Xbank_mem_0_reg[12][9] QDFFN $PINS Q=bank_mem_0[12][9]
+ D=FE_OFN100_bank_wdata_0__9 CK=CTS_607
Xbank_mem_0_reg[12][8] QDFFN $PINS Q=bank_mem_0[12][8]
+ D=FE_OFN101_bank_wdata_0__8 CK=CTS_607
Xbank_mem_0_reg[12][7] QDFFN $PINS Q=bank_mem_0[12][7]
+ D=FE_OFN102_bank_wdata_0__7 CK=CTS_607
Xbank_mem_0_reg[12][6] QDFFN $PINS Q=bank_mem_0[12][6]
+ D=FE_OFN103_bank_wdata_0__6 CK=CTS_607
Xbank_mem_0_reg[12][5] QDFFN $PINS Q=bank_mem_0[12][5]
+ D=FE_OFN104_bank_wdata_0__5 CK=CTS_607
Xbank_mem_0_reg[12][4] QDFFN $PINS Q=bank_mem_0[12][4]
+ D=FE_OFN105_bank_wdata_0__4 CK=CTS_607
Xbank_mem_0_reg[12][3] QDFFN $PINS Q=bank_mem_0[12][3]
+ D=FE_OFN106_bank_wdata_0__3 CK=CTS_607
Xbank_mem_0_reg[12][2] QDFFN $PINS Q=bank_mem_0[12][2]
+ D=FE_OFN107_bank_wdata_0__2 CK=CTS_607
Xbank_mem_0_reg[12][1] QDFFN $PINS Q=bank_mem_0[12][1]
+ D=FE_OFN108_bank_wdata_0__1 CK=CTS_607
Xbank_mem_0_reg[12][0] QDFFN $PINS Q=bank_mem_0[12][0]
+ D=FE_OFN109_bank_wdata_0__0 CK=CTS_607
Xbank_mem_0_reg[13][33] QDFFN $PINS Q=bank_mem_0[13][33]
+ D=FE_PHN1356_FE_OFN77_bank_wdata_0__33 CK=CTS_604
Xbank_mem_0_reg[14][33] QDFFN $PINS Q=bank_mem_0[14][33]
+ D=FE_PHN1356_FE_OFN77_bank_wdata_0__33 CK=CTS_598
Xbank_mem_0_reg[12][33] QDFFN $PINS Q=bank_mem_0[12][33]
+ D=FE_PHN1356_FE_OFN77_bank_wdata_0__33 CK=CTS_610
Xbank_mem_1_reg[9][32] QDFFN $PINS Q=bank_mem_1[9][32]
+ D=FE_OFN43_bank_wdata_1__32 CK=CTS_680
Xbank_mem_1_reg[9][31] QDFFN $PINS Q=bank_mem_1[9][31]
+ D=FE_OFN44_bank_wdata_1__31 CK=CTS_680
Xbank_mem_1_reg[9][30] QDFFN $PINS Q=bank_mem_1[9][30]
+ D=FE_OFN45_bank_wdata_1__30 CK=CTS_680
Xbank_mem_1_reg[9][29] QDFFN $PINS Q=bank_mem_1[9][29]
+ D=FE_OFN46_bank_wdata_1__29 CK=CTS_680
Xbank_mem_1_reg[9][28] QDFFN $PINS Q=bank_mem_1[9][28]
+ D=FE_OFN47_bank_wdata_1__28 CK=CTS_680
Xbank_mem_1_reg[9][27] QDFFN $PINS Q=bank_mem_1[9][27]
+ D=FE_OFN48_bank_wdata_1__27 CK=CTS_680
Xbank_mem_1_reg[9][26] QDFFN $PINS Q=bank_mem_1[9][26]
+ D=FE_OFN49_bank_wdata_1__26 CK=CTS_680
Xbank_mem_1_reg[9][25] QDFFN $PINS Q=bank_mem_1[9][25]
+ D=FE_OFN50_bank_wdata_1__25 CK=CTS_680
Xbank_mem_1_reg[9][24] QDFFN $PINS Q=bank_mem_1[9][24]
+ D=FE_OFN51_bank_wdata_1__24 CK=CTS_680
Xbank_mem_1_reg[9][23] QDFFN $PINS Q=bank_mem_1[9][23]
+ D=FE_OFN52_bank_wdata_1__23 CK=CTS_680
Xbank_mem_1_reg[9][22] QDFFN $PINS Q=bank_mem_1[9][22]
+ D=FE_OFN53_bank_wdata_1__22 CK=CTS_680
Xbank_mem_1_reg[9][21] QDFFN $PINS Q=bank_mem_1[9][21]
+ D=FE_OFN54_bank_wdata_1__21 CK=CTS_680
Xbank_mem_1_reg[9][20] QDFFN $PINS Q=bank_mem_1[9][20]
+ D=FE_OFN55_bank_wdata_1__20 CK=CTS_680
Xbank_mem_1_reg[9][19] QDFFN $PINS Q=bank_mem_1[9][19]
+ D=FE_OFN56_bank_wdata_1__19 CK=CTS_680
Xbank_mem_1_reg[9][18] QDFFN $PINS Q=bank_mem_1[9][18]
+ D=FE_OFN57_bank_wdata_1__18 CK=CTS_680
Xbank_mem_1_reg[9][17] QDFFN $PINS Q=bank_mem_1[9][17]
+ D=FE_OFN58_bank_wdata_1__17 CK=CTS_680
Xbank_mem_1_reg[9][16] QDFFN $PINS Q=bank_mem_1[9][16]
+ D=FE_OFN59_bank_wdata_1__16 CK=CTS_677
Xbank_mem_1_reg[9][15] QDFFN $PINS Q=bank_mem_1[9][15]
+ D=FE_OFN60_bank_wdata_1__15 CK=CTS_677
Xbank_mem_1_reg[9][14] QDFFN $PINS Q=bank_mem_1[9][14]
+ D=FE_OFN61_bank_wdata_1__14 CK=CTS_677
Xbank_mem_1_reg[9][13] QDFFN $PINS Q=bank_mem_1[9][13]
+ D=FE_OFN62_bank_wdata_1__13 CK=CTS_677
Xbank_mem_1_reg[9][12] QDFFN $PINS Q=bank_mem_1[9][12]
+ D=FE_OFN63_bank_wdata_1__12 CK=CTS_677
Xbank_mem_1_reg[9][11] QDFFN $PINS Q=bank_mem_1[9][11]
+ D=FE_OFN64_bank_wdata_1__11 CK=CTS_677
Xbank_mem_1_reg[9][10] QDFFN $PINS Q=bank_mem_1[9][10]
+ D=FE_OFN65_bank_wdata_1__10 CK=CTS_677
Xbank_mem_1_reg[9][9] QDFFN $PINS Q=bank_mem_1[9][9] D=FE_OFN66_bank_wdata_1__9
+ CK=CTS_677
Xbank_mem_1_reg[9][8] QDFFN $PINS Q=bank_mem_1[9][8] D=FE_OFN67_bank_wdata_1__8
+ CK=CTS_677
Xbank_mem_1_reg[9][7] QDFFN $PINS Q=bank_mem_1[9][7] D=FE_OFN68_bank_wdata_1__7
+ CK=CTS_677
Xbank_mem_1_reg[9][6] QDFFN $PINS Q=bank_mem_1[9][6] D=FE_OFN69_bank_wdata_1__6
+ CK=CTS_677
Xbank_mem_1_reg[9][5] QDFFN $PINS Q=bank_mem_1[9][5] D=FE_OFN70_bank_wdata_1__5
+ CK=CTS_677
Xbank_mem_1_reg[9][4] QDFFN $PINS Q=bank_mem_1[9][4] D=FE_OFN71_bank_wdata_1__4
+ CK=CTS_677
Xbank_mem_1_reg[9][3] QDFFN $PINS Q=bank_mem_1[9][3] D=FE_OFN72_bank_wdata_1__3
+ CK=CTS_677
Xbank_mem_1_reg[9][2] QDFFN $PINS Q=bank_mem_1[9][2] D=FE_OFN73_bank_wdata_1__2
+ CK=CTS_677
Xbank_mem_1_reg[9][1] QDFFN $PINS Q=bank_mem_1[9][1] D=FE_OFN74_bank_wdata_1__1
+ CK=CTS_677
Xbank_mem_1_reg[9][0] QDFFN $PINS Q=bank_mem_1[9][0] D=FE_OFN75_bank_wdata_1__0
+ CK=CTS_677
Xbank_mem_1_reg[11][32] QDFFN $PINS Q=bank_mem_1[11][32]
+ D=FE_OFN43_bank_wdata_1__32 CK=CTS_668
Xbank_mem_1_reg[11][31] QDFFN $PINS Q=bank_mem_1[11][31]
+ D=FE_OFN44_bank_wdata_1__31 CK=CTS_668
Xbank_mem_1_reg[11][30] QDFFN $PINS Q=bank_mem_1[11][30]
+ D=FE_OFN45_bank_wdata_1__30 CK=CTS_668
Xbank_mem_1_reg[11][29] QDFFN $PINS Q=bank_mem_1[11][29]
+ D=FE_OFN46_bank_wdata_1__29 CK=CTS_668
Xbank_mem_1_reg[11][28] QDFFN $PINS Q=bank_mem_1[11][28]
+ D=FE_OFN47_bank_wdata_1__28 CK=CTS_668
Xbank_mem_1_reg[11][27] QDFFN $PINS Q=bank_mem_1[11][27]
+ D=FE_OFN48_bank_wdata_1__27 CK=CTS_668
Xbank_mem_1_reg[11][26] QDFFN $PINS Q=bank_mem_1[11][26]
+ D=FE_OFN49_bank_wdata_1__26 CK=CTS_668
Xbank_mem_1_reg[11][25] QDFFN $PINS Q=bank_mem_1[11][25]
+ D=FE_OFN50_bank_wdata_1__25 CK=CTS_668
Xbank_mem_1_reg[11][24] QDFFN $PINS Q=bank_mem_1[11][24]
+ D=FE_OFN51_bank_wdata_1__24 CK=CTS_668
Xbank_mem_1_reg[11][23] QDFFN $PINS Q=bank_mem_1[11][23]
+ D=FE_OFN52_bank_wdata_1__23 CK=CTS_668
Xbank_mem_1_reg[11][22] QDFFN $PINS Q=bank_mem_1[11][22]
+ D=FE_OFN53_bank_wdata_1__22 CK=CTS_668
Xbank_mem_1_reg[11][21] QDFFN $PINS Q=bank_mem_1[11][21]
+ D=FE_OFN54_bank_wdata_1__21 CK=CTS_668
Xbank_mem_1_reg[11][20] QDFFN $PINS Q=bank_mem_1[11][20]
+ D=FE_OFN55_bank_wdata_1__20 CK=CTS_668
Xbank_mem_1_reg[11][19] QDFFN $PINS Q=bank_mem_1[11][19]
+ D=FE_OFN56_bank_wdata_1__19 CK=CTS_668
Xbank_mem_1_reg[11][18] QDFFN $PINS Q=bank_mem_1[11][18]
+ D=FE_OFN57_bank_wdata_1__18 CK=CTS_668
Xbank_mem_1_reg[11][17] QDFFN $PINS Q=bank_mem_1[11][17]
+ D=FE_OFN58_bank_wdata_1__17 CK=CTS_668
Xbank_mem_1_reg[11][16] QDFFN $PINS Q=bank_mem_1[11][16]
+ D=FE_OFN59_bank_wdata_1__16 CK=CTS_665
Xbank_mem_1_reg[11][15] QDFFN $PINS Q=bank_mem_1[11][15]
+ D=FE_OFN60_bank_wdata_1__15 CK=CTS_665
Xbank_mem_1_reg[11][14] QDFFN $PINS Q=bank_mem_1[11][14]
+ D=FE_OFN61_bank_wdata_1__14 CK=CTS_665
Xbank_mem_1_reg[11][13] QDFFN $PINS Q=bank_mem_1[11][13]
+ D=FE_OFN62_bank_wdata_1__13 CK=CTS_665
Xbank_mem_1_reg[11][12] QDFFN $PINS Q=bank_mem_1[11][12]
+ D=FE_OFN63_bank_wdata_1__12 CK=CTS_665
Xbank_mem_1_reg[11][11] QDFFN $PINS Q=bank_mem_1[11][11]
+ D=FE_OFN64_bank_wdata_1__11 CK=CTS_665
Xbank_mem_1_reg[11][10] QDFFN $PINS Q=bank_mem_1[11][10]
+ D=FE_OFN65_bank_wdata_1__10 CK=CTS_665
Xbank_mem_1_reg[11][9] QDFFN $PINS Q=bank_mem_1[11][9]
+ D=FE_OFN66_bank_wdata_1__9 CK=CTS_665
Xbank_mem_1_reg[11][8] QDFFN $PINS Q=bank_mem_1[11][8]
+ D=FE_OFN67_bank_wdata_1__8 CK=CTS_665
Xbank_mem_1_reg[11][7] QDFFN $PINS Q=bank_mem_1[11][7]
+ D=FE_OFN68_bank_wdata_1__7 CK=CTS_665
Xbank_mem_1_reg[11][6] QDFFN $PINS Q=bank_mem_1[11][6]
+ D=FE_OFN69_bank_wdata_1__6 CK=CTS_665
Xbank_mem_1_reg[11][5] QDFFN $PINS Q=bank_mem_1[11][5]
+ D=FE_OFN70_bank_wdata_1__5 CK=CTS_665
Xbank_mem_1_reg[11][4] QDFFN $PINS Q=bank_mem_1[11][4]
+ D=FE_OFN71_bank_wdata_1__4 CK=CTS_665
Xbank_mem_1_reg[11][3] QDFFN $PINS Q=bank_mem_1[11][3]
+ D=FE_OFN72_bank_wdata_1__3 CK=CTS_665
Xbank_mem_1_reg[11][2] QDFFN $PINS Q=bank_mem_1[11][2]
+ D=FE_OFN73_bank_wdata_1__2 CK=CTS_665
Xbank_mem_1_reg[11][1] QDFFN $PINS Q=bank_mem_1[11][1]
+ D=FE_OFN74_bank_wdata_1__1 CK=CTS_665
Xbank_mem_1_reg[11][0] QDFFN $PINS Q=bank_mem_1[11][0]
+ D=FE_OFN75_bank_wdata_1__0 CK=CTS_665
Xbank_mem_1_reg[8][32] QDFFN $PINS Q=bank_mem_1[8][32]
+ D=FE_OFN43_bank_wdata_1__32 CK=CTS_686
Xbank_mem_1_reg[8][31] QDFFN $PINS Q=bank_mem_1[8][31]
+ D=FE_OFN44_bank_wdata_1__31 CK=CTS_686
Xbank_mem_1_reg[8][30] QDFFN $PINS Q=bank_mem_1[8][30]
+ D=FE_OFN45_bank_wdata_1__30 CK=CTS_686
Xbank_mem_1_reg[8][29] QDFFN $PINS Q=bank_mem_1[8][29]
+ D=FE_OFN46_bank_wdata_1__29 CK=CTS_686
Xbank_mem_1_reg[8][28] QDFFN $PINS Q=bank_mem_1[8][28]
+ D=FE_OFN47_bank_wdata_1__28 CK=CTS_686
Xbank_mem_1_reg[8][27] QDFFN $PINS Q=bank_mem_1[8][27]
+ D=FE_OFN48_bank_wdata_1__27 CK=CTS_686
Xbank_mem_1_reg[8][26] QDFFN $PINS Q=bank_mem_1[8][26]
+ D=FE_OFN49_bank_wdata_1__26 CK=CTS_686
Xbank_mem_1_reg[8][25] QDFFN $PINS Q=bank_mem_1[8][25]
+ D=FE_OFN50_bank_wdata_1__25 CK=CTS_686
Xbank_mem_1_reg[8][24] QDFFN $PINS Q=bank_mem_1[8][24]
+ D=FE_OFN51_bank_wdata_1__24 CK=CTS_686
Xbank_mem_1_reg[8][23] QDFFN $PINS Q=bank_mem_1[8][23]
+ D=FE_OFN52_bank_wdata_1__23 CK=CTS_686
Xbank_mem_1_reg[8][22] QDFFN $PINS Q=bank_mem_1[8][22]
+ D=FE_OFN53_bank_wdata_1__22 CK=CTS_686
Xbank_mem_1_reg[8][21] QDFFN $PINS Q=bank_mem_1[8][21]
+ D=FE_OFN54_bank_wdata_1__21 CK=CTS_686
Xbank_mem_1_reg[8][20] QDFFN $PINS Q=bank_mem_1[8][20]
+ D=FE_OFN55_bank_wdata_1__20 CK=CTS_686
Xbank_mem_1_reg[8][19] QDFFN $PINS Q=bank_mem_1[8][19]
+ D=FE_OFN56_bank_wdata_1__19 CK=CTS_686
Xbank_mem_1_reg[8][18] QDFFN $PINS Q=bank_mem_1[8][18]
+ D=FE_OFN57_bank_wdata_1__18 CK=CTS_686
Xbank_mem_1_reg[8][17] QDFFN $PINS Q=bank_mem_1[8][17]
+ D=FE_OFN58_bank_wdata_1__17 CK=CTS_686
Xbank_mem_1_reg[8][16] QDFFN $PINS Q=bank_mem_1[8][16]
+ D=FE_OFN59_bank_wdata_1__16 CK=CTS_683
Xbank_mem_1_reg[8][15] QDFFN $PINS Q=bank_mem_1[8][15]
+ D=FE_OFN60_bank_wdata_1__15 CK=CTS_683
Xbank_mem_1_reg[8][14] QDFFN $PINS Q=bank_mem_1[8][14]
+ D=FE_OFN61_bank_wdata_1__14 CK=CTS_683
Xbank_mem_1_reg[8][13] QDFFN $PINS Q=bank_mem_1[8][13]
+ D=FE_OFN62_bank_wdata_1__13 CK=CTS_683
Xbank_mem_1_reg[8][12] QDFFN $PINS Q=bank_mem_1[8][12]
+ D=FE_OFN63_bank_wdata_1__12 CK=CTS_683
Xbank_mem_1_reg[8][11] QDFFN $PINS Q=bank_mem_1[8][11]
+ D=FE_OFN64_bank_wdata_1__11 CK=CTS_683
Xbank_mem_1_reg[8][10] QDFFN $PINS Q=bank_mem_1[8][10]
+ D=FE_OFN65_bank_wdata_1__10 CK=CTS_683
Xbank_mem_1_reg[8][9] QDFFN $PINS Q=bank_mem_1[8][9] D=FE_OFN66_bank_wdata_1__9
+ CK=CTS_683
Xbank_mem_1_reg[8][8] QDFFN $PINS Q=bank_mem_1[8][8] D=FE_OFN67_bank_wdata_1__8
+ CK=CTS_683
Xbank_mem_1_reg[8][7] QDFFN $PINS Q=bank_mem_1[8][7] D=FE_OFN68_bank_wdata_1__7
+ CK=CTS_683
Xbank_mem_1_reg[8][6] QDFFN $PINS Q=bank_mem_1[8][6] D=FE_OFN69_bank_wdata_1__6
+ CK=CTS_683
Xbank_mem_1_reg[8][5] QDFFN $PINS Q=bank_mem_1[8][5] D=FE_OFN70_bank_wdata_1__5
+ CK=CTS_683
Xbank_mem_1_reg[8][4] QDFFN $PINS Q=bank_mem_1[8][4] D=FE_OFN71_bank_wdata_1__4
+ CK=CTS_683
Xbank_mem_1_reg[8][3] QDFFN $PINS Q=bank_mem_1[8][3] D=FE_OFN72_bank_wdata_1__3
+ CK=CTS_683
Xbank_mem_1_reg[8][2] QDFFN $PINS Q=bank_mem_1[8][2] D=FE_OFN73_bank_wdata_1__2
+ CK=CTS_683
Xbank_mem_1_reg[8][1] QDFFN $PINS Q=bank_mem_1[8][1] D=FE_OFN74_bank_wdata_1__1
+ CK=CTS_683
Xbank_mem_1_reg[8][0] QDFFN $PINS Q=bank_mem_1[8][0] D=FE_OFN75_bank_wdata_1__0
+ CK=CTS_683
Xbank_mem_1_reg[9][33] QDFFN $PINS Q=bank_mem_1[9][33]
+ D=FE_OFN42_bank_wdata_1__33 CK=CTS_680
Xbank_mem_1_reg[10][32] QDFFN $PINS Q=bank_mem_1[10][32]
+ D=FE_OFN43_bank_wdata_1__32 CK=CTS_674
Xbank_mem_1_reg[10][31] QDFFN $PINS Q=bank_mem_1[10][31]
+ D=FE_OFN44_bank_wdata_1__31 CK=CTS_674
Xbank_mem_1_reg[10][30] QDFFN $PINS Q=bank_mem_1[10][30]
+ D=FE_OFN45_bank_wdata_1__30 CK=CTS_674
Xbank_mem_1_reg[10][29] QDFFN $PINS Q=bank_mem_1[10][29]
+ D=FE_OFN46_bank_wdata_1__29 CK=CTS_674
Xbank_mem_1_reg[10][28] QDFFN $PINS Q=bank_mem_1[10][28]
+ D=FE_OFN47_bank_wdata_1__28 CK=CTS_674
Xbank_mem_1_reg[10][27] QDFFN $PINS Q=bank_mem_1[10][27]
+ D=FE_OFN48_bank_wdata_1__27 CK=CTS_674
Xbank_mem_1_reg[10][26] QDFFN $PINS Q=bank_mem_1[10][26]
+ D=FE_OFN49_bank_wdata_1__26 CK=CTS_674
Xbank_mem_1_reg[10][25] QDFFN $PINS Q=bank_mem_1[10][25]
+ D=FE_OFN50_bank_wdata_1__25 CK=CTS_674
Xbank_mem_1_reg[10][24] QDFFN $PINS Q=bank_mem_1[10][24]
+ D=FE_OFN51_bank_wdata_1__24 CK=CTS_674
Xbank_mem_1_reg[10][23] QDFFN $PINS Q=bank_mem_1[10][23]
+ D=FE_OFN52_bank_wdata_1__23 CK=CTS_674
Xbank_mem_1_reg[10][22] QDFFN $PINS Q=bank_mem_1[10][22]
+ D=FE_OFN53_bank_wdata_1__22 CK=CTS_674
Xbank_mem_1_reg[10][21] QDFFN $PINS Q=bank_mem_1[10][21]
+ D=FE_OFN54_bank_wdata_1__21 CK=CTS_674
Xbank_mem_1_reg[10][20] QDFFN $PINS Q=bank_mem_1[10][20]
+ D=FE_OFN55_bank_wdata_1__20 CK=CTS_674
Xbank_mem_1_reg[10][19] QDFFN $PINS Q=bank_mem_1[10][19]
+ D=FE_OFN56_bank_wdata_1__19 CK=CTS_674
Xbank_mem_1_reg[10][18] QDFFN $PINS Q=bank_mem_1[10][18]
+ D=FE_OFN57_bank_wdata_1__18 CK=CTS_674
Xbank_mem_1_reg[10][17] QDFFN $PINS Q=bank_mem_1[10][17]
+ D=FE_OFN58_bank_wdata_1__17 CK=CTS_674
Xbank_mem_1_reg[10][16] QDFFN $PINS Q=bank_mem_1[10][16]
+ D=FE_OFN59_bank_wdata_1__16 CK=CTS_671
Xbank_mem_1_reg[10][15] QDFFN $PINS Q=bank_mem_1[10][15]
+ D=FE_OFN60_bank_wdata_1__15 CK=CTS_671
Xbank_mem_1_reg[10][14] QDFFN $PINS Q=bank_mem_1[10][14]
+ D=FE_OFN61_bank_wdata_1__14 CK=CTS_671
Xbank_mem_1_reg[10][13] QDFFN $PINS Q=bank_mem_1[10][13]
+ D=FE_OFN62_bank_wdata_1__13 CK=CTS_671
Xbank_mem_1_reg[10][12] QDFFN $PINS Q=bank_mem_1[10][12]
+ D=FE_OFN63_bank_wdata_1__12 CK=CTS_671
Xbank_mem_1_reg[10][11] QDFFN $PINS Q=bank_mem_1[10][11]
+ D=FE_OFN64_bank_wdata_1__11 CK=CTS_671
Xbank_mem_1_reg[10][10] QDFFN $PINS Q=bank_mem_1[10][10]
+ D=FE_OFN65_bank_wdata_1__10 CK=CTS_671
Xbank_mem_1_reg[10][9] QDFFN $PINS Q=bank_mem_1[10][9]
+ D=FE_OFN66_bank_wdata_1__9 CK=CTS_671
Xbank_mem_1_reg[10][8] QDFFN $PINS Q=bank_mem_1[10][8]
+ D=FE_OFN67_bank_wdata_1__8 CK=CTS_671
Xbank_mem_1_reg[10][7] QDFFN $PINS Q=bank_mem_1[10][7]
+ D=FE_OFN68_bank_wdata_1__7 CK=CTS_671
Xbank_mem_1_reg[10][6] QDFFN $PINS Q=bank_mem_1[10][6]
+ D=FE_OFN69_bank_wdata_1__6 CK=CTS_671
Xbank_mem_1_reg[10][5] QDFFN $PINS Q=bank_mem_1[10][5]
+ D=FE_OFN70_bank_wdata_1__5 CK=CTS_671
Xbank_mem_1_reg[10][4] QDFFN $PINS Q=bank_mem_1[10][4]
+ D=FE_OFN71_bank_wdata_1__4 CK=CTS_671
Xbank_mem_1_reg[10][3] QDFFN $PINS Q=bank_mem_1[10][3]
+ D=FE_OFN72_bank_wdata_1__3 CK=CTS_671
Xbank_mem_1_reg[10][2] QDFFN $PINS Q=bank_mem_1[10][2]
+ D=FE_OFN73_bank_wdata_1__2 CK=CTS_671
Xbank_mem_1_reg[10][1] QDFFN $PINS Q=bank_mem_1[10][1]
+ D=FE_OFN74_bank_wdata_1__1 CK=CTS_671
Xbank_mem_1_reg[10][0] QDFFN $PINS Q=bank_mem_1[10][0]
+ D=FE_OFN75_bank_wdata_1__0 CK=CTS_671
Xbank_mem_1_reg[11][33] QDFFN $PINS Q=bank_mem_1[11][33]
+ D=FE_OFN42_bank_wdata_1__33 CK=CTS_668
Xbank_mem_0_reg[9][32] QDFFN $PINS Q=bank_mem_0[9][32]
+ D=FE_OFN78_bank_wdata_0__32 CK=CTS_628
Xbank_mem_0_reg[9][31] QDFFN $PINS Q=bank_mem_0[9][31]
+ D=FE_PHN1451_FE_OFN79_bank_wdata_0__31 CK=CTS_628
Xbank_mem_0_reg[9][30] QDFFN $PINS Q=bank_mem_0[9][30]
+ D=FE_PHN1446_FE_OFN80_bank_wdata_0__30 CK=CTS_628
Xbank_mem_0_reg[9][29] QDFFN $PINS Q=bank_mem_0[9][29]
+ D=FE_PHN1411_FE_OFN81_bank_wdata_0__29 CK=CTS_628
Xbank_mem_0_reg[9][28] QDFFN $PINS Q=bank_mem_0[9][28]
+ D=FE_PHN1415_FE_OFN82_bank_wdata_0__28 CK=CTS_628
Xbank_mem_0_reg[9][27] QDFFN $PINS Q=bank_mem_0[9][27]
+ D=FE_PHN1450_bank_wdata_0_27 CK=CTS_628
Xbank_mem_0_reg[9][26] QDFFN $PINS Q=bank_mem_0[9][26]
+ D=FE_OFN83_bank_wdata_0__26 CK=CTS_628
Xbank_mem_0_reg[9][25] QDFFN $PINS Q=bank_mem_0[9][25]
+ D=FE_OFN84_bank_wdata_0__25 CK=CTS_628
Xbank_mem_0_reg[9][24] QDFFN $PINS Q=bank_mem_0[9][24]
+ D=FE_OFN85_bank_wdata_0__24 CK=CTS_628
Xbank_mem_0_reg[9][23] QDFFN $PINS Q=bank_mem_0[9][23]
+ D=FE_OFN86_bank_wdata_0__23 CK=CTS_628
Xbank_mem_0_reg[9][22] QDFFN $PINS Q=bank_mem_0[9][22]
+ D=FE_OFN87_bank_wdata_0__22 CK=CTS_628
Xbank_mem_0_reg[9][21] QDFFN $PINS Q=bank_mem_0[9][21]
+ D=FE_OFN88_bank_wdata_0__21 CK=CTS_628
Xbank_mem_0_reg[9][20] QDFFN $PINS Q=bank_mem_0[9][20]
+ D=FE_OFN89_bank_wdata_0__20 CK=CTS_628
Xbank_mem_0_reg[9][19] QDFFN $PINS Q=bank_mem_0[9][19]
+ D=FE_OFN90_bank_wdata_0__19 CK=CTS_628
Xbank_mem_0_reg[9][18] QDFFN $PINS Q=bank_mem_0[9][18]
+ D=FE_OFN91_bank_wdata_0__18 CK=CTS_628
Xbank_mem_0_reg[9][17] QDFFN $PINS Q=bank_mem_0[9][17]
+ D=FE_OFN92_bank_wdata_0__17 CK=CTS_628
Xbank_mem_0_reg[9][16] QDFFN $PINS Q=bank_mem_0[9][16]
+ D=FE_OFN93_bank_wdata_0__16 CK=CTS_625
Xbank_mem_0_reg[9][15] QDFFN $PINS Q=bank_mem_0[9][15]
+ D=FE_PHN1017_FE_OFN94_bank_wdata_0__15 CK=CTS_625
Xbank_mem_0_reg[9][14] QDFFN $PINS Q=bank_mem_0[9][14]
+ D=FE_OFN95_bank_wdata_0__14 CK=CTS_625
Xbank_mem_0_reg[9][13] QDFFN $PINS Q=bank_mem_0[9][13]
+ D=FE_PHN1092_FE_OFN96_bank_wdata_0__13 CK=CTS_625
Xbank_mem_0_reg[9][12] QDFFN $PINS Q=bank_mem_0[9][12]
+ D=FE_PHN1124_FE_OFN97_bank_wdata_0__12 CK=CTS_625
Xbank_mem_0_reg[9][11] QDFFN $PINS Q=bank_mem_0[9][11]
+ D=FE_OFN98_bank_wdata_0__11 CK=CTS_625
Xbank_mem_0_reg[9][10] QDFFN $PINS Q=bank_mem_0[9][10]
+ D=FE_OFN99_bank_wdata_0__10 CK=CTS_625
Xbank_mem_0_reg[9][9] QDFFN $PINS Q=bank_mem_0[9][9]
+ D=FE_OFN100_bank_wdata_0__9 CK=CTS_625
Xbank_mem_0_reg[9][8] QDFFN $PINS Q=bank_mem_0[9][8]
+ D=FE_OFN101_bank_wdata_0__8 CK=CTS_625
Xbank_mem_0_reg[9][7] QDFFN $PINS Q=bank_mem_0[9][7]
+ D=FE_OFN102_bank_wdata_0__7 CK=CTS_625
Xbank_mem_0_reg[9][6] QDFFN $PINS Q=bank_mem_0[9][6]
+ D=FE_OFN103_bank_wdata_0__6 CK=CTS_625
Xbank_mem_0_reg[9][5] QDFFN $PINS Q=bank_mem_0[9][5]
+ D=FE_OFN104_bank_wdata_0__5 CK=CTS_625
Xbank_mem_0_reg[9][4] QDFFN $PINS Q=bank_mem_0[9][4]
+ D=FE_OFN105_bank_wdata_0__4 CK=CTS_625
Xbank_mem_0_reg[9][3] QDFFN $PINS Q=bank_mem_0[9][3]
+ D=FE_OFN106_bank_wdata_0__3 CK=CTS_625
Xbank_mem_0_reg[9][2] QDFFN $PINS Q=bank_mem_0[9][2]
+ D=FE_OFN107_bank_wdata_0__2 CK=CTS_625
Xbank_mem_0_reg[9][1] QDFFN $PINS Q=bank_mem_0[9][1]
+ D=FE_OFN108_bank_wdata_0__1 CK=CTS_625
Xbank_mem_0_reg[9][0] QDFFN $PINS Q=bank_mem_0[9][0]
+ D=FE_OFN109_bank_wdata_0__0 CK=CTS_625
Xbank_mem_0_reg[11][32] QDFFN $PINS Q=bank_mem_0[11][32]
+ D=FE_OFN78_bank_wdata_0__32 CK=CTS_616
Xbank_mem_0_reg[11][31] QDFFN $PINS Q=bank_mem_0[11][31]
+ D=FE_PHN1451_FE_OFN79_bank_wdata_0__31 CK=CTS_616
Xbank_mem_0_reg[11][30] QDFFN $PINS Q=bank_mem_0[11][30]
+ D=FE_PHN1446_FE_OFN80_bank_wdata_0__30 CK=CTS_616
Xbank_mem_0_reg[11][29] QDFFN $PINS Q=bank_mem_0[11][29]
+ D=FE_PHN1411_FE_OFN81_bank_wdata_0__29 CK=CTS_616
Xbank_mem_0_reg[11][28] QDFFN $PINS Q=bank_mem_0[11][28]
+ D=FE_PHN1415_FE_OFN82_bank_wdata_0__28 CK=CTS_616
Xbank_mem_0_reg[11][27] QDFFN $PINS Q=bank_mem_0[11][27]
+ D=FE_PHN1450_bank_wdata_0_27 CK=CTS_616
Xbank_mem_0_reg[11][26] QDFFN $PINS Q=bank_mem_0[11][26]
+ D=FE_OFN83_bank_wdata_0__26 CK=CTS_616
Xbank_mem_0_reg[11][25] QDFFN $PINS Q=bank_mem_0[11][25]
+ D=FE_OFN84_bank_wdata_0__25 CK=CTS_616
Xbank_mem_0_reg[11][24] QDFFN $PINS Q=bank_mem_0[11][24]
+ D=FE_OFN85_bank_wdata_0__24 CK=CTS_616
Xbank_mem_0_reg[11][23] QDFFN $PINS Q=bank_mem_0[11][23]
+ D=FE_OFN86_bank_wdata_0__23 CK=CTS_616
Xbank_mem_0_reg[11][22] QDFFN $PINS Q=bank_mem_0[11][22]
+ D=FE_OFN87_bank_wdata_0__22 CK=CTS_616
Xbank_mem_0_reg[11][21] QDFFN $PINS Q=bank_mem_0[11][21]
+ D=FE_OFN88_bank_wdata_0__21 CK=CTS_616
Xbank_mem_0_reg[11][20] QDFFN $PINS Q=bank_mem_0[11][20]
+ D=FE_OFN89_bank_wdata_0__20 CK=CTS_616
Xbank_mem_0_reg[11][19] QDFFN $PINS Q=bank_mem_0[11][19]
+ D=FE_OFN90_bank_wdata_0__19 CK=CTS_616
Xbank_mem_0_reg[11][18] QDFFN $PINS Q=bank_mem_0[11][18]
+ D=FE_OFN91_bank_wdata_0__18 CK=CTS_616
Xbank_mem_0_reg[11][17] QDFFN $PINS Q=bank_mem_0[11][17]
+ D=FE_OFN92_bank_wdata_0__17 CK=CTS_616
Xbank_mem_0_reg[11][16] QDFFN $PINS Q=bank_mem_0[11][16]
+ D=FE_OFN93_bank_wdata_0__16 CK=CTS_613
Xbank_mem_0_reg[11][15] QDFFN $PINS Q=bank_mem_0[11][15]
+ D=FE_PHN1017_FE_OFN94_bank_wdata_0__15 CK=CTS_613
Xbank_mem_0_reg[11][14] QDFFN $PINS Q=bank_mem_0[11][14]
+ D=FE_OFN95_bank_wdata_0__14 CK=CTS_613
Xbank_mem_0_reg[11][13] QDFFN $PINS Q=bank_mem_0[11][13]
+ D=FE_PHN1092_FE_OFN96_bank_wdata_0__13 CK=CTS_613
Xbank_mem_0_reg[11][12] QDFFN $PINS Q=bank_mem_0[11][12]
+ D=FE_PHN1124_FE_OFN97_bank_wdata_0__12 CK=CTS_613
Xbank_mem_0_reg[11][11] QDFFN $PINS Q=bank_mem_0[11][11]
+ D=FE_OFN98_bank_wdata_0__11 CK=CTS_613
Xbank_mem_0_reg[11][10] QDFFN $PINS Q=bank_mem_0[11][10]
+ D=FE_OFN99_bank_wdata_0__10 CK=CTS_613
Xbank_mem_0_reg[11][9] QDFFN $PINS Q=bank_mem_0[11][9]
+ D=FE_OFN100_bank_wdata_0__9 CK=CTS_613
Xbank_mem_0_reg[11][8] QDFFN $PINS Q=bank_mem_0[11][8]
+ D=FE_OFN101_bank_wdata_0__8 CK=CTS_613
Xbank_mem_0_reg[11][7] QDFFN $PINS Q=bank_mem_0[11][7]
+ D=FE_OFN102_bank_wdata_0__7 CK=CTS_613
Xbank_mem_0_reg[11][6] QDFFN $PINS Q=bank_mem_0[11][6]
+ D=FE_OFN103_bank_wdata_0__6 CK=CTS_613
Xbank_mem_0_reg[11][5] QDFFN $PINS Q=bank_mem_0[11][5]
+ D=FE_OFN104_bank_wdata_0__5 CK=CTS_613
Xbank_mem_0_reg[11][4] QDFFN $PINS Q=bank_mem_0[11][4]
+ D=FE_OFN105_bank_wdata_0__4 CK=CTS_613
Xbank_mem_0_reg[11][3] QDFFN $PINS Q=bank_mem_0[11][3]
+ D=FE_OFN106_bank_wdata_0__3 CK=CTS_613
Xbank_mem_0_reg[11][2] QDFFN $PINS Q=bank_mem_0[11][2]
+ D=FE_OFN107_bank_wdata_0__2 CK=CTS_613
Xbank_mem_0_reg[11][1] QDFFN $PINS Q=bank_mem_0[11][1]
+ D=FE_OFN108_bank_wdata_0__1 CK=CTS_613
Xbank_mem_0_reg[11][0] QDFFN $PINS Q=bank_mem_0[11][0]
+ D=FE_OFN109_bank_wdata_0__0 CK=CTS_613
Xbank_mem_1_reg[8][33] QDFFN $PINS Q=bank_mem_1[8][33]
+ D=FE_OFN42_bank_wdata_1__33 CK=CTS_686
Xbank_mem_1_reg[10][33] QDFFN $PINS Q=bank_mem_1[10][33]
+ D=FE_OFN42_bank_wdata_1__33 CK=CTS_674
Xbank_mem_0_reg[8][32] QDFFN $PINS Q=bank_mem_0[8][32]
+ D=FE_OFN78_bank_wdata_0__32 CK=CTS_634
Xbank_mem_0_reg[8][31] QDFFN $PINS Q=bank_mem_0[8][31]
+ D=FE_PHN1451_FE_OFN79_bank_wdata_0__31 CK=CTS_634
Xbank_mem_0_reg[8][30] QDFFN $PINS Q=bank_mem_0[8][30]
+ D=FE_PHN1446_FE_OFN80_bank_wdata_0__30 CK=CTS_634
Xbank_mem_0_reg[8][29] QDFFN $PINS Q=bank_mem_0[8][29]
+ D=FE_PHN1411_FE_OFN81_bank_wdata_0__29 CK=CTS_634
Xbank_mem_0_reg[8][28] QDFFN $PINS Q=bank_mem_0[8][28]
+ D=FE_PHN1415_FE_OFN82_bank_wdata_0__28 CK=CTS_634
Xbank_mem_0_reg[8][27] QDFFN $PINS Q=bank_mem_0[8][27]
+ D=FE_PHN1450_bank_wdata_0_27 CK=CTS_634
Xbank_mem_0_reg[8][26] QDFFN $PINS Q=bank_mem_0[8][26]
+ D=FE_OFN83_bank_wdata_0__26 CK=CTS_634
Xbank_mem_0_reg[8][25] QDFFN $PINS Q=bank_mem_0[8][25]
+ D=FE_OFN84_bank_wdata_0__25 CK=CTS_634
Xbank_mem_0_reg[8][24] QDFFN $PINS Q=bank_mem_0[8][24]
+ D=FE_OFN85_bank_wdata_0__24 CK=CTS_634
Xbank_mem_0_reg[8][23] QDFFN $PINS Q=bank_mem_0[8][23]
+ D=FE_OFN86_bank_wdata_0__23 CK=CTS_634
Xbank_mem_0_reg[8][22] QDFFN $PINS Q=bank_mem_0[8][22]
+ D=FE_OFN87_bank_wdata_0__22 CK=CTS_634
Xbank_mem_0_reg[8][21] QDFFN $PINS Q=bank_mem_0[8][21]
+ D=FE_OFN88_bank_wdata_0__21 CK=CTS_634
Xbank_mem_0_reg[8][20] QDFFN $PINS Q=bank_mem_0[8][20]
+ D=FE_OFN89_bank_wdata_0__20 CK=CTS_634
Xbank_mem_0_reg[8][19] QDFFN $PINS Q=bank_mem_0[8][19]
+ D=FE_OFN90_bank_wdata_0__19 CK=CTS_634
Xbank_mem_0_reg[8][18] QDFFN $PINS Q=bank_mem_0[8][18]
+ D=FE_OFN91_bank_wdata_0__18 CK=CTS_634
Xbank_mem_0_reg[8][17] QDFFN $PINS Q=bank_mem_0[8][17]
+ D=FE_OFN92_bank_wdata_0__17 CK=CTS_634
Xbank_mem_0_reg[8][16] QDFFN $PINS Q=bank_mem_0[8][16]
+ D=FE_OFN93_bank_wdata_0__16 CK=CTS_631
Xbank_mem_0_reg[8][15] QDFFN $PINS Q=bank_mem_0[8][15]
+ D=FE_PHN1017_FE_OFN94_bank_wdata_0__15 CK=CTS_631
Xbank_mem_0_reg[8][14] QDFFN $PINS Q=bank_mem_0[8][14]
+ D=FE_OFN95_bank_wdata_0__14 CK=CTS_631
Xbank_mem_0_reg[8][13] QDFFN $PINS Q=bank_mem_0[8][13]
+ D=FE_PHN1092_FE_OFN96_bank_wdata_0__13 CK=CTS_631
Xbank_mem_0_reg[8][12] QDFFN $PINS Q=bank_mem_0[8][12]
+ D=FE_PHN1124_FE_OFN97_bank_wdata_0__12 CK=CTS_631
Xbank_mem_0_reg[8][11] QDFFN $PINS Q=bank_mem_0[8][11]
+ D=FE_OFN98_bank_wdata_0__11 CK=CTS_631
Xbank_mem_0_reg[8][10] QDFFN $PINS Q=bank_mem_0[8][10]
+ D=FE_OFN99_bank_wdata_0__10 CK=CTS_631
Xbank_mem_0_reg[8][9] QDFFN $PINS Q=bank_mem_0[8][9]
+ D=FE_OFN100_bank_wdata_0__9 CK=CTS_631
Xbank_mem_0_reg[8][8] QDFFN $PINS Q=bank_mem_0[8][8]
+ D=FE_OFN101_bank_wdata_0__8 CK=CTS_631
Xbank_mem_0_reg[8][7] QDFFN $PINS Q=bank_mem_0[8][7]
+ D=FE_OFN102_bank_wdata_0__7 CK=CTS_631
Xbank_mem_0_reg[8][6] QDFFN $PINS Q=bank_mem_0[8][6]
+ D=FE_OFN103_bank_wdata_0__6 CK=CTS_631
Xbank_mem_0_reg[8][5] QDFFN $PINS Q=bank_mem_0[8][5]
+ D=FE_OFN104_bank_wdata_0__5 CK=CTS_631
Xbank_mem_0_reg[8][4] QDFFN $PINS Q=bank_mem_0[8][4]
+ D=FE_OFN105_bank_wdata_0__4 CK=CTS_631
Xbank_mem_0_reg[8][3] QDFFN $PINS Q=bank_mem_0[8][3]
+ D=FE_OFN106_bank_wdata_0__3 CK=CTS_631
Xbank_mem_0_reg[8][2] QDFFN $PINS Q=bank_mem_0[8][2]
+ D=FE_OFN107_bank_wdata_0__2 CK=CTS_631
Xbank_mem_0_reg[8][1] QDFFN $PINS Q=bank_mem_0[8][1]
+ D=FE_OFN108_bank_wdata_0__1 CK=CTS_631
Xbank_mem_0_reg[8][0] QDFFN $PINS Q=bank_mem_0[8][0]
+ D=FE_OFN109_bank_wdata_0__0 CK=CTS_631
Xbank_mem_0_reg[9][33] QDFFN $PINS Q=bank_mem_0[9][33]
+ D=FE_PHN1356_FE_OFN77_bank_wdata_0__33 CK=CTS_628
Xbank_mem_0_reg[10][32] QDFFN $PINS Q=bank_mem_0[10][32]
+ D=FE_OFN78_bank_wdata_0__32 CK=CTS_622
Xbank_mem_0_reg[10][31] QDFFN $PINS Q=bank_mem_0[10][31]
+ D=FE_PHN1451_FE_OFN79_bank_wdata_0__31 CK=CTS_622
Xbank_mem_0_reg[10][30] QDFFN $PINS Q=bank_mem_0[10][30]
+ D=FE_PHN1446_FE_OFN80_bank_wdata_0__30 CK=CTS_622
Xbank_mem_0_reg[10][29] QDFFN $PINS Q=bank_mem_0[10][29]
+ D=FE_PHN1411_FE_OFN81_bank_wdata_0__29 CK=CTS_622
Xbank_mem_0_reg[10][28] QDFFN $PINS Q=bank_mem_0[10][28]
+ D=FE_PHN1415_FE_OFN82_bank_wdata_0__28 CK=CTS_622
Xbank_mem_0_reg[10][27] QDFFN $PINS Q=bank_mem_0[10][27]
+ D=FE_PHN1450_bank_wdata_0_27 CK=CTS_622
Xbank_mem_0_reg[10][26] QDFFN $PINS Q=bank_mem_0[10][26]
+ D=FE_OFN83_bank_wdata_0__26 CK=CTS_622
Xbank_mem_0_reg[10][25] QDFFN $PINS Q=bank_mem_0[10][25]
+ D=FE_OFN84_bank_wdata_0__25 CK=CTS_622
Xbank_mem_0_reg[10][24] QDFFN $PINS Q=bank_mem_0[10][24]
+ D=FE_OFN85_bank_wdata_0__24 CK=CTS_622
Xbank_mem_0_reg[10][23] QDFFN $PINS Q=bank_mem_0[10][23]
+ D=FE_OFN86_bank_wdata_0__23 CK=CTS_622
Xbank_mem_0_reg[10][22] QDFFN $PINS Q=bank_mem_0[10][22]
+ D=FE_OFN87_bank_wdata_0__22 CK=CTS_622
Xbank_mem_0_reg[10][21] QDFFN $PINS Q=bank_mem_0[10][21]
+ D=FE_OFN88_bank_wdata_0__21 CK=CTS_622
Xbank_mem_0_reg[10][20] QDFFN $PINS Q=bank_mem_0[10][20]
+ D=FE_OFN89_bank_wdata_0__20 CK=CTS_622
Xbank_mem_0_reg[10][19] QDFFN $PINS Q=bank_mem_0[10][19]
+ D=FE_OFN90_bank_wdata_0__19 CK=CTS_622
Xbank_mem_0_reg[10][18] QDFFN $PINS Q=bank_mem_0[10][18]
+ D=FE_OFN91_bank_wdata_0__18 CK=CTS_622
Xbank_mem_0_reg[10][17] QDFFN $PINS Q=bank_mem_0[10][17]
+ D=FE_OFN92_bank_wdata_0__17 CK=CTS_622
Xbank_mem_0_reg[10][16] QDFFN $PINS Q=bank_mem_0[10][16]
+ D=FE_OFN93_bank_wdata_0__16 CK=CTS_619
Xbank_mem_0_reg[10][15] QDFFN $PINS Q=bank_mem_0[10][15]
+ D=FE_PHN1017_FE_OFN94_bank_wdata_0__15 CK=CTS_619
Xbank_mem_0_reg[10][14] QDFFN $PINS Q=bank_mem_0[10][14]
+ D=FE_OFN95_bank_wdata_0__14 CK=CTS_619
Xbank_mem_0_reg[10][13] QDFFN $PINS Q=bank_mem_0[10][13]
+ D=FE_PHN1092_FE_OFN96_bank_wdata_0__13 CK=CTS_619
Xbank_mem_0_reg[10][12] QDFFN $PINS Q=bank_mem_0[10][12]
+ D=FE_PHN1124_FE_OFN97_bank_wdata_0__12 CK=CTS_619
Xbank_mem_0_reg[10][11] QDFFN $PINS Q=bank_mem_0[10][11]
+ D=FE_OFN98_bank_wdata_0__11 CK=CTS_619
Xbank_mem_0_reg[10][10] QDFFN $PINS Q=bank_mem_0[10][10]
+ D=FE_OFN99_bank_wdata_0__10 CK=CTS_619
Xbank_mem_0_reg[10][9] QDFFN $PINS Q=bank_mem_0[10][9]
+ D=FE_OFN100_bank_wdata_0__9 CK=CTS_619
Xbank_mem_0_reg[10][8] QDFFN $PINS Q=bank_mem_0[10][8]
+ D=FE_OFN101_bank_wdata_0__8 CK=CTS_619
Xbank_mem_0_reg[10][7] QDFFN $PINS Q=bank_mem_0[10][7]
+ D=FE_OFN102_bank_wdata_0__7 CK=CTS_619
Xbank_mem_0_reg[10][6] QDFFN $PINS Q=bank_mem_0[10][6]
+ D=FE_OFN103_bank_wdata_0__6 CK=CTS_619
Xbank_mem_0_reg[10][5] QDFFN $PINS Q=bank_mem_0[10][5]
+ D=FE_OFN104_bank_wdata_0__5 CK=CTS_619
Xbank_mem_0_reg[10][4] QDFFN $PINS Q=bank_mem_0[10][4]
+ D=FE_OFN105_bank_wdata_0__4 CK=CTS_619
Xbank_mem_0_reg[10][3] QDFFN $PINS Q=bank_mem_0[10][3]
+ D=FE_OFN106_bank_wdata_0__3 CK=CTS_619
Xbank_mem_0_reg[10][2] QDFFN $PINS Q=bank_mem_0[10][2]
+ D=FE_OFN107_bank_wdata_0__2 CK=CTS_619
Xbank_mem_0_reg[10][1] QDFFN $PINS Q=bank_mem_0[10][1]
+ D=FE_OFN108_bank_wdata_0__1 CK=CTS_619
Xbank_mem_0_reg[10][0] QDFFN $PINS Q=bank_mem_0[10][0]
+ D=FE_OFN109_bank_wdata_0__0 CK=CTS_619
Xbank_mem_0_reg[11][33] QDFFN $PINS Q=bank_mem_0[11][33]
+ D=FE_PHN1356_FE_OFN77_bank_wdata_0__33 CK=CTS_616
Xbank_mem_0_reg[8][33] QDFFN $PINS Q=bank_mem_0[8][33]
+ D=FE_PHN1356_FE_OFN77_bank_wdata_0__33 CK=CTS_634
Xbank_mem_0_reg[10][33] QDFFN $PINS Q=bank_mem_0[10][33]
+ D=FE_PHN1356_FE_OFN77_bank_wdata_0__33 CK=CTS_622
Xread_data_1_reg[33] QDFFRBN $PINS Q=read_data_1[33] D=N103 CK=clk
+ RB=FE_OFN25_i_rst_n
Xread_data_1_reg[16] QDFFRBN $PINS Q=read_data_1[16] D=N120 CK=clk
+ RB=FE_OFN25_i_rst_n
Xread_data_1_reg[32] QDFFRBN $PINS Q=read_data_1[32] D=N104 CK=clk RB=i_rst_n
Xread_data_1_reg[15] QDFFRBN $PINS Q=read_data_1[15] D=N121 CK=clk
+ RB=FE_OFN25_i_rst_n
Xread_data_1_reg[14] QDFFRBN $PINS Q=read_data_1[14] D=N122 CK=clk
+ RB=FE_OFN25_i_rst_n
Xread_data_1_reg[31] QDFFRBN $PINS Q=read_data_1[31] D=N105 CK=clk
+ RB=FE_OFN25_i_rst_n
Xread_data_1_reg[13] QDFFRBN $PINS Q=read_data_1[13] D=N123 CK=clk
+ RB=FE_OFN25_i_rst_n
Xread_data_1_reg[30] QDFFRBN $PINS Q=read_data_1[30] D=N106 CK=clk
+ RB=FE_OFN25_i_rst_n
Xread_data_1_reg[12] QDFFRBN $PINS Q=read_data_1[12] D=N124 CK=clk
+ RB=FE_OFN25_i_rst_n
Xread_data_1_reg[29] QDFFRBN $PINS Q=read_data_1[29] D=N107 CK=clk RB=i_rst_n
Xread_data_1_reg[28] QDFFRBN $PINS Q=read_data_1[28] D=N108 CK=clk RB=i_rst_n
Xread_data_1_reg[11] QDFFRBN $PINS Q=read_data_1[11] D=N125 CK=clk
+ RB=FE_OFN25_i_rst_n
Xread_data_1_reg[10] QDFFRBN $PINS Q=read_data_1[10] D=N126 CK=clk
+ RB=FE_OFN25_i_rst_n
Xread_data_1_reg[27] QDFFRBN $PINS Q=read_data_1[27] D=N109 CK=clk RB=i_rst_n
Xread_data_1_reg[9] QDFFRBN $PINS Q=read_data_1[9] D=N127 CK=clk
+ RB=FE_OFN25_i_rst_n
Xread_data_1_reg[25] QDFFRBN $PINS Q=read_data_1[25] D=FE_PHN1444_N111 CK=clk
+ RB=FE_OFN25_i_rst_n
Xread_data_1_reg[8] QDFFRBN $PINS Q=read_data_1[8] D=N128 CK=clk
+ RB=FE_OFN25_i_rst_n
Xread_data_1_reg[7] QDFFRBN $PINS Q=read_data_1[7] D=N129 CK=clk
+ RB=FE_OFN25_i_rst_n
Xread_data_1_reg[23] QDFFRBN $PINS Q=read_data_1[23] D=FE_PHN1452_N113 CK=clk
+ RB=FE_OFN25_i_rst_n
Xread_data_1_reg[6] QDFFRBN $PINS Q=read_data_1[6] D=N130 CK=clk
+ RB=FE_OFN25_i_rst_n
Xread_data_1_reg[22] QDFFRBN $PINS Q=read_data_1[22] D=N114 CK=clk
+ RB=FE_OFN25_i_rst_n
Xread_data_1_reg[5] QDFFRBN $PINS Q=read_data_1[5] D=N131 CK=clk
+ RB=FE_OFN25_i_rst_n
Xread_data_1_reg[21] QDFFRBN $PINS Q=read_data_1[21] D=N115 CK=clk
+ RB=FE_OFN25_i_rst_n
Xread_data_1_reg[20] QDFFRBN $PINS Q=read_data_1[20] D=N116 CK=clk
+ RB=FE_OFN17_i_rst_n
Xread_data_1_reg[4] QDFFRBN $PINS Q=read_data_1[4] D=N132 CK=clk
+ RB=FE_OFN25_i_rst_n
Xread_data_1_reg[3] QDFFRBN $PINS Q=read_data_1[3] D=N133 CK=clk
+ RB=FE_OFN25_i_rst_n
Xread_data_1_reg[2] QDFFRBN $PINS Q=read_data_1[2] D=N134 CK=clk
+ RB=FE_OFN25_i_rst_n
Xread_data_1_reg[1] QDFFRBN $PINS Q=read_data_1[1] D=N135 CK=clk
+ RB=FE_OFN25_i_rst_n
Xread_data_1_reg[26] QDFFRBN $PINS Q=read_data_1[26] D=N110 CK=clk
+ RB=FE_OFN25_i_rst_n
Xread_data_1_reg[24] QDFFRBN $PINS Q=read_data_1[24] D=FE_PHN1454_N112 CK=clk
+ RB=FE_OFN25_i_rst_n
Xread_data_1_reg[19] QDFFRBN $PINS Q=read_data_1[19] D=N117 CK=clk
+ RB=FE_OFN17_i_rst_n
Xread_data_1_reg[18] QDFFRBN $PINS Q=read_data_1[18] D=N118 CK=clk
+ RB=FE_OFN17_i_rst_n
Xread_data_1_reg[17] QDFFRBN $PINS Q=read_data_1[17] D=N119 CK=clk
+ RB=FE_OFN14_i_rst_n
Xread_data_1_reg[0] QDFFRBN $PINS Q=read_data_1[0] D=N136 CK=clk
+ RB=FE_OFN25_i_rst_n
XU5 ND2P $PINS O=n85 I1=wen2 I2=n117
XU6 ND2S $PINS O=n92 I1=n953 I2=n99
XU7 ND2S $PINS O=n94 I1=n99 I2=n100
XU10 ND2S $PINS O=n105 I1=n951 I2=n115
XU11 ND2S $PINS O=n106 I1=n950 I2=n116
XU12 ND2S $PINS O=n107 I1=n115 I2=n116
XU14 XNR2HS $PINS O=n112 I1=p_1 I2=n1
XU15 XNR2HS $PINS O=n1 I1=n120 I2=write_addr_1[2]
XU17 INV1S $PINS O=n952 I=n109
XU18 NR2 $PINS O=N58 I1=n103 I2=n114
XU19 NR2 $PINS O=N59 I1=n103 I2=n113
XU20 NR2 $PINS O=N54 I1=n106 I2=n114
XU21 NR2 $PINS O=N55 I1=n106 I2=n113
XU22 NR2 $PINS O=N56 I1=n105 I2=n114
XU23 NR2 $PINS O=N57 I1=n105 I2=n113
XU24 NR2 $PINS O=N53 I1=n107 I2=n113
XU25 NR2 $PINS O=N52 I1=n107 I2=n114
XU26 NR2 $PINS O=N91 I1=n90 I2=n98
XU27 NR2 $PINS O=N92 I1=n90 I2=n97
XU28 INV1S $PINS O=n955 I=n96
XU29 NR2 $PINS O=N87 I1=n93 I2=n98
XU30 NR2 $PINS O=N88 I1=n93 I2=n97
XU31 NR2 $PINS O=N89 I1=n92 I2=n98
XU32 NR2 $PINS O=N90 I1=n92 I2=n97
XU33 NR2 $PINS O=N86 I1=n94 I2=n97
XU34 NR2 $PINS O=N85 I1=n94 I2=n98
XU40 OAI22S $PINS O=n109 A1=p_1 A2=n87 B1=p_1 B2=n88
XU41 NR2 $PINS O=N61 I1=n102 I2=n107
XU42 NR2 $PINS O=N65 I1=n102 I2=n105
XU43 NR2 $PINS O=N63 I1=n102 I2=n106
XU44 NR2 $PINS O=N67 I1=n102 I2=n103
XU45 NR2 $PINS O=N66 I1=n103 I2=n104
XU46 INV1S $PINS O=n950 I=n115
XU47 INV1S $PINS O=n951 I=n116
XU48 NR2 $PINS O=N60 I1=n104 I2=n107
XU49 NR2 $PINS O=N64 I1=n104 I2=n105
XU50 NR2 $PINS O=N62 I1=n104 I2=n106
XU51 NR2 $PINS O=N100 I1=n90 I2=n91
XU52 INV1S $PINS O=n954 I=n99
XU53 NR2 $PINS O=N93 I1=n89 I2=n94
XU54 NR2 $PINS O=N97 I1=n89 I2=n92
XU55 NR2 $PINS O=N95 I1=n89 I2=n93
XU56 NR2 $PINS O=N99 I1=n89 I2=n90
XU57 INV1S $PINS O=n953 I=n100
XU58 OAI22S $PINS O=n96 A1=p_1 A2=n85 B1=p_1 B2=n86
XU59 NR2 $PINS O=N94 I1=n91 I2=n94
XU60 NR2 $PINS O=N98 I1=n91 I2=n92
XU61 NR2 $PINS O=N96 I1=n91 I2=n93
XU62 INV1S $PINS O=n943 I=n122
XU88 OAI22S $PINS O=n115 A1=p1 A2=n87 B1=p1 B2=n88
XU89 OAI22S $PINS O=n116 A1=p2 A2=n87 B1=p2 B2=n88
XU90 OAI22S $PINS O=n111 A1=p3 A2=n87 B1=p3 B2=n88
XU91 OAI22S $PINS O=n99 A1=p1 A2=n85 B1=p1 B2=n86
XU92 OAI22S $PINS O=n101 A1=p3 A2=n85 B1=p3 B2=n86
XU93 OAI22S $PINS O=n100 A1=p2 A2=n85 B1=p2 B2=n86
XU94 INV1S $PINS O=n1025 I=n112
XU96 OAI22S $PINS O=bank_wdata[0][1] A1=n974 A2=n87 B1=n1008 B2=n88
XU98 OAI22S $PINS O=bank_wdata[0][2] A1=n975 A2=n87 B1=n1009 B2=n88
XU100 OAI22S $PINS O=bank_wdata[0][3] A1=n976 A2=n87 B1=n1010 B2=n88
XU102 OAI22S $PINS O=bank_wdata[0][4] A1=n977 A2=n87 B1=n1011 B2=n88
XU104 OAI22S $PINS O=bank_wdata[0][16] A1=n989 A2=n87 B1=n1023 B2=n88
XU106 OAI22S $PINS O=bank_wdata[0][17] A1=n956 A2=n87 B1=n990 B2=n88
XU108 OAI22S $PINS O=bank_wdata[0][18] A1=n957 A2=n87 B1=n991 B2=n88
XU110 OAI22S $PINS O=bank_wdata[0][19] A1=n958 A2=n87 B1=n992 B2=n88
XU112 OAI22S $PINS O=bank_wdata[0][20] A1=n959 A2=n87 B1=n993 B2=n88
XU114 OAI22S $PINS O=bank_wdata[0][21] A1=n960 A2=n87 B1=n994 B2=n88
XU116 OAI22S $PINS O=FE_PHN1436_bank_wdata_0_22 A1=FE_PHN1077_n961 A2=n87
+ B1=n995 B2=n88
XU118 OAI22S $PINS O=bank_wdata[0][23] A1=n962 A2=n87 B1=n996 B2=n88
XU120 OAI22S $PINS O=bank_wdata[0][24] A1=n963 A2=n87 B1=n997 B2=n88
XU122 OAI22S $PINS O=bank_wdata[0][25] A1=n964 A2=n87 B1=n998 B2=n88
XU124 OAI22S $PINS O=bank_wdata[0][26] A1=n965 A2=n87 B1=n999 B2=n88
XU126 OAI22S $PINS O=bank_wdata[0][27] A1=FE_PHN1073_n966 A2=n87 B1=n1000
+ B2=n88
XU128 OAI22S $PINS O=bank_wdata[0][28] A1=n967 A2=n87 B1=n1001 B2=n88
XU130 OAI22S $PINS O=bank_wdata[0][29] A1=n968 A2=n87 B1=n1002 B2=n88
XU132 OAI22S $PINS O=bank_wdata[0][30] A1=n969 A2=n87 B1=n1003 B2=n88
XU134 OAI22S $PINS O=bank_wdata[0][31] A1=n970 A2=n87 B1=n1004 B2=n88
XU136 OAI22S $PINS O=bank_wdata[0][32] A1=n971 A2=n87 B1=n1005 B2=n88
XU138 OAI22S $PINS O=bank_wdata[0][33] A1=n972 A2=n87 B1=n1006 B2=n88
XU140 OAI22S $PINS O=bank_wdata[0][0] A1=n973 A2=n87 B1=n1007 B2=n88
XU142 OAI22S $PINS O=bank_wdata[0][10] A1=FE_PHN1083_n983 A2=n87 B1=n1017
+ B2=n88
XU144 OAI22S $PINS O=bank_wdata[0][11] A1=n984 A2=n87 B1=n1018 B2=n88
XU146 OAI22S $PINS O=bank_wdata[0][12] A1=n985 A2=n87 B1=n1019 B2=n88
XU148 OAI22S $PINS O=bank_wdata[0][13] A1=n986 A2=n87 B1=n1020 B2=n88
XU150 OAI22S $PINS O=bank_wdata[0][14] A1=n987 A2=n87 B1=n1021 B2=n88
XU152 OAI22S $PINS O=bank_wdata[0][15] A1=n988 A2=n87 B1=n1022 B2=n88
XU154 OAI22S $PINS O=bank_wdata[0][5] A1=n978 A2=n87 B1=n1012 B2=n88
XU156 OAI22S $PINS O=bank_wdata[0][6] A1=n979 A2=n87 B1=n1013 B2=n88
XU158 OAI22S $PINS O=bank_wdata[0][7] A1=n980 A2=n87 B1=n1014 B2=n88
XU160 OAI22S $PINS O=bank_wdata[0][8] A1=n981 A2=n87 B1=n1015 B2=n88
XU162 OAI22S $PINS O=bank_wdata[0][9] A1=n982 A2=n87 B1=n1016 B2=n88
XU164 OAI22S $PINS O=bank_wdata[1][1] A1=n85 A2=n974 B1=n86 B2=n1008
XU166 OAI22S $PINS O=bank_wdata[1][2] A1=n85 A2=n975 B1=n86 B2=n1009
XU168 OAI22S $PINS O=bank_wdata[1][3] A1=n85 A2=n976 B1=n86 B2=n1010
XU170 OAI22S $PINS O=bank_wdata[1][4] A1=n85 A2=n977 B1=n86 B2=n1011
XU172 OAI22S $PINS O=bank_wdata[1][5] A1=n85 A2=n978 B1=n86 B2=n1012
XU174 OAI22S $PINS O=bank_wdata[1][6] A1=n85 A2=n979 B1=n86 B2=n1013
XU176 OAI22S $PINS O=bank_wdata[1][16] A1=n85 A2=n989 B1=n86 B2=n1023
XU178 OAI22S $PINS O=bank_wdata[1][17] A1=n85 A2=n956 B1=n86 B2=n990
XU180 OAI22S $PINS O=bank_wdata[1][18] A1=n85 A2=n957 B1=n86 B2=n991
XU182 OAI22S $PINS O=bank_wdata[1][19] A1=n85 A2=n958 B1=n86 B2=n992
XU184 OAI22S $PINS O=bank_wdata[1][20] A1=n85 A2=n959 B1=n86 B2=n993
XU186 OAI22S $PINS O=bank_wdata[1][21] A1=n85 A2=n960 B1=n86 B2=n994
XU188 OAI22S $PINS O=bank_wdata[1][22] A1=n85 A2=n961 B1=n86 B2=n995
XU190 OAI22S $PINS O=bank_wdata[1][23] A1=n85 A2=n962 B1=n86 B2=n996
XU192 OAI22S $PINS O=bank_wdata[1][24] A1=n85 A2=n963 B1=n86 B2=n997
XU194 OAI22S $PINS O=bank_wdata[1][25] A1=n85 A2=n964 B1=n86 B2=n998
XU196 OAI22S $PINS O=bank_wdata[1][26] A1=n85 A2=n965 B1=n86 B2=n999
XU198 OAI22S $PINS O=bank_wdata[1][27] A1=n85 A2=FE_PHN1073_n966 B1=n86
+ B2=n1000
XU200 OAI22S $PINS O=bank_wdata[1][28] A1=n85 A2=n967 B1=n86 B2=n1001
XU203 OAI22S $PINS O=bank_wdata[1][29] A1=n85 A2=n968 B1=n86 B2=n1002
XU212 OAI22S $PINS O=bank_wdata[1][30] A1=n85 A2=n969 B1=n86 B2=n1003
XU216 OAI22S $PINS O=bank_wdata[1][31] A1=n85 A2=n970 B1=n86 B2=n1004
XU257 OAI22S $PINS O=bank_wdata[1][32] A1=n85 A2=n971 B1=n86 B2=n1005
XU259 OAI22S $PINS O=bank_wdata[1][33] A1=n85 A2=n972 B1=n86 B2=n1006
XU261 OAI22S $PINS O=bank_wdata[1][0] A1=n85 A2=n973 B1=n86 B2=n1007
XU263 OAI22S $PINS O=bank_wdata[1][10] A1=n85 A2=n983 B1=n86 B2=n1017
XU265 OAI22S $PINS O=bank_wdata[1][11] A1=n85 A2=n984 B1=n86 B2=n1018
XU267 OAI22S $PINS O=bank_wdata[1][12] A1=n85 A2=n985 B1=n86 B2=n1019
XU269 OAI22S $PINS O=bank_wdata[1][13] A1=n85 A2=n986 B1=n86 B2=n1020
XU271 OAI22S $PINS O=bank_wdata[1][14] A1=n85 A2=n987 B1=n86 B2=n1021
XU273 OAI22S $PINS O=bank_wdata[1][15] A1=n85 A2=n988 B1=n86 B2=n1022
XU275 OAI22S $PINS O=bank_wdata[1][7] A1=n85 A2=n980 B1=n86 B2=n1014
XU277 OAI22S $PINS O=bank_wdata[1][8] A1=n85 A2=n981 B1=n86 B2=n1015
XU279 OAI22S $PINS O=bank_wdata[1][9] A1=n85 A2=n982 B1=n86 B2=n1016
XU281 XNR2HS $PINS O=n118 I1=read_addr_1[4] I2=read_addr_1[3]
XU288 ND3P $PINS O=n88 I1=wen1 I2=n87 I3=n112
XU289 XNR2HS $PINS O=n117 I1=p_1 I2=n1028
XU290 XOR2HS $PINS O=n1028 I1=n120 I2=p1
XU292 AOI12HS $PINS O=n108 A1=n111 B1=n87 B2=n110
XU293 ND3P $PINS O=n86 I1=n1025 I2=n85 I3=wen1
XU294 AOI12HS $PINS O=n95 A1=n101 B1=n85 B2=n119
XU296 XOR2HS $PINS O=n120 I1=write_addr_1[4] I2=write_addr_1[3]
XU299 INV1S $PINS O=n1008 I=write_data_1[1]
XU300 INV1S $PINS O=n1009 I=write_data_1[2]
XU301 INV1S $PINS O=n1010 I=write_data_1[3]
XU302 INV1S $PINS O=n1011 I=write_data_1[4]
XU303 INV1S $PINS O=n1023 I=write_data_1[16]
XU304 INV1S $PINS O=n990 I=write_data_1[17]
XU305 INV1S $PINS O=n991 I=write_data_1[18]
XU306 INV1S $PINS O=n992 I=write_data_1[19]
XU307 INV1S $PINS O=n993 I=write_data_1[20]
XU308 INV1S $PINS O=n994 I=write_data_1[21]
XU309 INV1S $PINS O=n995 I=write_data_1[22]
XU310 INV1S $PINS O=n996 I=write_data_1[23]
XU311 INV1S $PINS O=n997 I=write_data_1[24]
XU312 INV1S $PINS O=n998 I=write_data_1[25]
XU313 INV1S $PINS O=n999 I=write_data_1[26]
XU314 INV1S $PINS O=n1000 I=write_data_1[27]
XU315 INV1S $PINS O=n1001 I=write_data_1[28]
XU316 INV1S $PINS O=n1002 I=write_data_1[29]
XU317 INV1S $PINS O=n1003 I=write_data_1[30]
XU318 INV1S $PINS O=n1004 I=write_data_1[31]
XU319 INV1S $PINS O=n1005 I=write_data_1[32]
XU320 INV1S $PINS O=n1006 I=write_data_1[33]
XU321 INV1S $PINS O=n1007 I=write_data_1[0]
XU322 INV1S $PINS O=n1017 I=write_data_1[10]
XU323 INV1S $PINS O=n1018 I=write_data_1[11]
XU324 INV1S $PINS O=n1019 I=write_data_1[12]
XU325 INV1S $PINS O=n1020 I=write_data_1[13]
XU326 INV1S $PINS O=n1021 I=write_data_1[14]
XU327 INV1S $PINS O=n1022 I=write_data_1[15]
XU328 INV1S $PINS O=n1012 I=write_data_1[5]
XU329 INV1S $PINS O=n1013 I=write_data_1[6]
XU330 INV1S $PINS O=n1014 I=write_data_1[7]
XU331 INV1S $PINS O=n1015 I=write_data_1[8]
XU332 INV1S $PINS O=n1016 I=write_data_1[9]
XU333 INV1S $PINS O=n973 I=write_data_2[0]
XU334 INV1S $PINS O=n974 I=write_data_2[1]
XU335 INV1S $PINS O=n975 I=FE_PHN1141_cor_x_out_1_2
XU336 INV1S $PINS O=n976 I=write_data_2[3]
XU337 INV1S $PINS O=n977 I=write_data_2[4]
XU338 INV1S $PINS O=n983 I=write_data_2[10]
XU339 INV1S $PINS O=n984 I=write_data_2[11]
XU340 INV1S $PINS O=n985 I=write_data_2[12]
XU341 INV1S $PINS O=n986 I=write_data_2[13]
XU342 INV1S $PINS O=n987 I=write_data_2[14]
XU343 INV1S $PINS O=n988 I=write_data_2[15]
XU344 INV1S $PINS O=n989 I=write_data_2[16]
XU345 INV1S $PINS O=n956 I=write_data_2[17]
XU346 INV1S $PINS O=n957 I=write_data_2[18]
XU347 INV1S $PINS O=n958 I=write_data_2[19]
XU348 INV1S $PINS O=n959 I=write_data_2[20]
XU349 INV1S $PINS O=n960 I=write_data_2[21]
XU350 INV1S $PINS O=n961 I=write_data_2[22]
XU351 INV1S $PINS O=n962 I=write_data_2[23]
XU352 INV1S $PINS O=n963 I=write_data_2[24]
XU353 INV1S $PINS O=n964 I=write_data_2[25]
XU354 INV1S $PINS O=n965 I=write_data_2[26]
XU355 INV1S $PINS O=n966 I=write_data_2[27]
XU356 INV1S $PINS O=n967 I=write_data_2[28]
XU357 INV1S $PINS O=n968 I=FE_PHN1080_cor_y_out_1_12
XU358 INV1S $PINS O=n969 I=FE_PHN1048_cor_y_out_1_13
XU359 INV1S $PINS O=n970 I=write_data_2[31]
XU360 INV1S $PINS O=n971 I=write_data_2[32]
XU361 INV1S $PINS O=n972 I=FE_PHN1008_cor_y_out_1_16
XU362 INV1S $PINS O=n978 I=write_data_2[5]
XU363 INV1S $PINS O=n979 I=write_data_2[6]
XU364 INV1S $PINS O=n980 I=write_data_2[7]
XU365 INV1S $PINS O=n981 I=write_data_2[8]
XU366 INV1S $PINS O=n982 I=FE_PHN1084_cor_x_out_1_9
XU367 INV1S $PINS O=n854 I=N33
XU368 INV1S $PINS O=n438 I=N29
XU369 INV1S $PINS O=n853 I=N32
XU370 INV1S $PINS O=n437 I=N28
XU371 INV1S $PINS O=n852 I=N31
XU372 INV1S $PINS O=n436 I=N27
XU373 NR2 $PINS O=n9 I1=n438 I2=N30
XU374 NR2 $PINS O=n8 I1=n437 I2=n436
XU375 AN2 $PINS O=n423 I1=n9 I2=n8
XU376 NR2 $PINS O=n12 I1=n437 I2=N27
XU377 AN2P $PINS O=n410 I1=n12 I2=N29
XU378 AN2 $PINS O=n409 I1=N29 I2=n8
XU379 AOI22S $PINS O=n6 A1=bank_mem_0[14][0] A2=n410 B1=bank_mem_0[15][0]
+ B2=n409
XU380 NR2 $PINS O=n11 I1=N27 I2=N28
XU381 AN2P $PINS O=n412 I1=n11 I2=N29
XU382 NR2 $PINS O=n10 I1=n436 I2=N28
XU383 AN2 $PINS O=n411 I1=n10 I2=N29
XU384 AOI22S $PINS O=n5 A1=bank_mem_0[12][0] A2=n412 B1=bank_mem_0[13][0]
+ B2=n411
XU385 AN2P $PINS O=n414 I1=n12 I2=n438
XU386 AN2 $PINS O=n413 I1=n8 I2=n438
XU387 AOI22S $PINS O=n3 A1=bank_mem_0[10][0] A2=n414 B1=bank_mem_0[11][0]
+ B2=n413
XU388 AN2P $PINS O=n416 I1=n11 I2=n438
XU389 AN2 $PINS O=n415 I1=n10 I2=n438
XU390 AOI22S $PINS O=n2 A1=bank_mem_0[8][0] A2=n416 B1=bank_mem_0[9][0] B2=n415
XU391 AN2 $PINS O=n4 I1=n3 I2=n2
XU392 ND3 $PINS O=n7 I1=n6 I2=n5 I3=n4
XU393 AOI22S $PINS O=n17 A1=bank_mem_0[7][0] A2=n423 B1=n7 B2=N30
XU394 AN2P $PINS O=n425 I1=n9 I2=n10
XU395 AN2P $PINS O=n424 I1=n9 I2=n12
XU396 AOI22S $PINS O=n16 A1=bank_mem_0[5][0] A2=n425 B1=bank_mem_0[6][0]
+ B2=n424
XU397 NR2 $PINS O=n13 I1=N29 I2=N30
XU398 AN2P $PINS O=n427 I1=n13 I2=n8
XU399 AN2P $PINS O=n426 I1=n9 I2=n11
XU400 AOI22S $PINS O=n15 A1=bank_mem_0[3][0] A2=n427 B1=bank_mem_0[4][0]
+ B2=n426
XU401 AN2 $PINS O=n430 I1=n13 I2=n10
XU402 AN2 $PINS O=n429 I1=n13 I2=n11
XU403 AN2 $PINS O=n428 I1=n13 I2=n12
XU404 AO222 $PINS O=n14 A1=bank_mem_0[1][0] A2=n430 B1=bank_mem_0[0][0] B2=n429
+ C1=bank_mem_0[2][0] C2=n428
XU405 AN4B1S $PINS O=n18 I1=n17 I2=n16 I3=n15 B1=n14
XU406 INV1S $PINS O=bank_rdata[0][0] I=n18
XU407 AOI22S $PINS O=n23 A1=bank_mem_0[14][1] A2=n410 B1=bank_mem_0[15][1]
+ B2=n409
XU408 AOI22S $PINS O=n22 A1=bank_mem_0[12][1] A2=n412 B1=bank_mem_0[13][1]
+ B2=n411
XU409 AOI22S $PINS O=n20 A1=bank_mem_0[10][1] A2=n414 B1=bank_mem_0[11][1]
+ B2=n413
XU410 AOI22S $PINS O=n19 A1=bank_mem_0[8][1] A2=n416 B1=bank_mem_0[9][1]
+ B2=n415
XU411 AN2 $PINS O=n21 I1=n20 I2=n19
XU412 ND3 $PINS O=n24 I1=n23 I2=n22 I3=n21
XU413 AOI22S $PINS O=n28 A1=bank_mem_0[7][1] A2=n423 B1=n24 B2=N30
XU414 AOI22S $PINS O=n27 A1=bank_mem_0[5][1] A2=n425 B1=bank_mem_0[6][1]
+ B2=n424
XU415 AOI22S $PINS O=n26 A1=bank_mem_0[3][1] A2=n427 B1=bank_mem_0[4][1]
+ B2=n426
XU416 AO222 $PINS O=n25 A1=bank_mem_0[1][1] A2=n430 B1=bank_mem_0[0][1] B2=n429
+ C1=bank_mem_0[2][1] C2=n428
XU417 AN4B1S $PINS O=n29 I1=n28 I2=n27 I3=n26 B1=n25
XU418 INV1S $PINS O=bank_rdata[0][1] I=n29
XU419 AOI22S $PINS O=n34 A1=bank_mem_0[14][2] A2=n410 B1=bank_mem_0[15][2]
+ B2=n409
XU420 AOI22S $PINS O=n33 A1=bank_mem_0[12][2] A2=n412 B1=bank_mem_0[13][2]
+ B2=n411
XU421 AOI22S $PINS O=n31 A1=bank_mem_0[10][2] A2=n414 B1=bank_mem_0[11][2]
+ B2=n413
XU422 AOI22S $PINS O=n30 A1=bank_mem_0[8][2] A2=n416 B1=bank_mem_0[9][2]
+ B2=n415
XU423 AN2 $PINS O=n32 I1=n31 I2=n30
XU424 ND3 $PINS O=n35 I1=n34 I2=n33 I3=n32
XU425 AOI22S $PINS O=n39 A1=bank_mem_0[7][2] A2=n423 B1=n35 B2=N30
XU426 AOI22S $PINS O=n38 A1=bank_mem_0[5][2] A2=n425 B1=bank_mem_0[6][2]
+ B2=n424
XU427 AOI22S $PINS O=n37 A1=bank_mem_0[3][2] A2=n427 B1=bank_mem_0[4][2]
+ B2=n426
XU428 AO222 $PINS O=n36 A1=bank_mem_0[1][2] A2=n430 B1=bank_mem_0[0][2] B2=n429
+ C1=bank_mem_0[2][2] C2=n428
XU429 AN4B1S $PINS O=n40 I1=n39 I2=n38 I3=n37 B1=n36
XU430 INV1S $PINS O=bank_rdata[0][2] I=n40
XU431 AOI22S $PINS O=n45 A1=bank_mem_0[14][3] A2=n410 B1=bank_mem_0[15][3]
+ B2=n409
XU432 AOI22S $PINS O=n44 A1=bank_mem_0[12][3] A2=n412 B1=bank_mem_0[13][3]
+ B2=n411
XU433 AOI22S $PINS O=n42 A1=bank_mem_0[10][3] A2=n414 B1=bank_mem_0[11][3]
+ B2=n413
XU434 AOI22S $PINS O=n41 A1=bank_mem_0[8][3] A2=n416 B1=bank_mem_0[9][3]
+ B2=n415
XU435 AN2 $PINS O=n43 I1=n42 I2=n41
XU436 ND3 $PINS O=n46 I1=n45 I2=n44 I3=n43
XU437 AOI22S $PINS O=n50 A1=bank_mem_0[7][3] A2=n423 B1=n46 B2=N30
XU438 AOI22S $PINS O=n49 A1=bank_mem_0[5][3] A2=n425 B1=bank_mem_0[6][3]
+ B2=n424
XU439 AOI22S $PINS O=n48 A1=bank_mem_0[3][3] A2=n427 B1=bank_mem_0[4][3]
+ B2=n426
XU440 AO222 $PINS O=n47 A1=bank_mem_0[1][3] A2=n430 B1=bank_mem_0[0][3] B2=n429
+ C1=bank_mem_0[2][3] C2=n428
XU441 AN4B1S $PINS O=n51 I1=n50 I2=n49 I3=n48 B1=n47
XU442 INV1S $PINS O=bank_rdata[0][3] I=n51
XU443 AOI22S $PINS O=n56 A1=bank_mem_0[14][4] A2=n410 B1=bank_mem_0[15][4]
+ B2=n409
XU444 AOI22S $PINS O=n55 A1=bank_mem_0[12][4] A2=n412 B1=bank_mem_0[13][4]
+ B2=n411
XU445 AOI22S $PINS O=n53 A1=bank_mem_0[10][4] A2=n414 B1=bank_mem_0[11][4]
+ B2=n413
XU446 AOI22S $PINS O=n52 A1=bank_mem_0[8][4] A2=n416 B1=bank_mem_0[9][4]
+ B2=n415
XU447 AN2 $PINS O=n54 I1=n53 I2=n52
XU448 ND3 $PINS O=n57 I1=n56 I2=n55 I3=n54
XU449 AOI22S $PINS O=n61 A1=bank_mem_0[7][4] A2=n423 B1=n57 B2=N30
XU450 AOI22S $PINS O=n60 A1=bank_mem_0[5][4] A2=n425 B1=bank_mem_0[6][4]
+ B2=n424
XU451 AOI22S $PINS O=n59 A1=bank_mem_0[3][4] A2=n427 B1=bank_mem_0[4][4]
+ B2=n426
XU452 AO222 $PINS O=n58 A1=bank_mem_0[1][4] A2=n430 B1=bank_mem_0[0][4] B2=n429
+ C1=bank_mem_0[2][4] C2=n428
XU453 AN4B1S $PINS O=n62 I1=n61 I2=n60 I3=n59 B1=n58
XU454 INV1S $PINS O=bank_rdata[0][4] I=n62
XU455 AOI22S $PINS O=n67 A1=bank_mem_0[14][5] A2=n410 B1=bank_mem_0[15][5]
+ B2=n409
XU456 AOI22S $PINS O=n66 A1=bank_mem_0[12][5] A2=n412 B1=bank_mem_0[13][5]
+ B2=n411
XU457 AOI22S $PINS O=n64 A1=bank_mem_0[10][5] A2=n414 B1=bank_mem_0[11][5]
+ B2=n413
XU458 AOI22S $PINS O=n63 A1=bank_mem_0[8][5] A2=n416 B1=bank_mem_0[9][5]
+ B2=n415
XU459 AN2 $PINS O=n65 I1=n64 I2=n63
XU460 ND3 $PINS O=n68 I1=n67 I2=n66 I3=n65
XU461 AOI22S $PINS O=n72 A1=bank_mem_0[7][5] A2=n423 B1=n68 B2=N30
XU462 AOI22S $PINS O=n71 A1=bank_mem_0[5][5] A2=n425 B1=bank_mem_0[6][5]
+ B2=n424
XU463 AOI22S $PINS O=n70 A1=bank_mem_0[3][5] A2=n427 B1=bank_mem_0[4][5]
+ B2=n426
XU464 AO222 $PINS O=n69 A1=bank_mem_0[1][5] A2=n430 B1=bank_mem_0[0][5] B2=n429
+ C1=bank_mem_0[2][5] C2=n428
XU465 AN4B1S $PINS O=n73 I1=n72 I2=n71 I3=n70 B1=n69
XU466 INV1S $PINS O=bank_rdata[0][5] I=n73
XU467 AOI22S $PINS O=n78 A1=bank_mem_0[14][6] A2=n410 B1=bank_mem_0[15][6]
+ B2=n409
XU468 AOI22S $PINS O=n77 A1=bank_mem_0[12][6] A2=n412 B1=bank_mem_0[13][6]
+ B2=n411
XU469 AOI22S $PINS O=n75 A1=bank_mem_0[10][6] A2=n414 B1=bank_mem_0[11][6]
+ B2=n413
XU470 AOI22S $PINS O=n74 A1=bank_mem_0[8][6] A2=n416 B1=bank_mem_0[9][6]
+ B2=n415
XU471 AN2 $PINS O=n76 I1=n75 I2=n74
XU472 ND3 $PINS O=n79 I1=n78 I2=n77 I3=n76
XU473 AOI22S $PINS O=n83 A1=bank_mem_0[7][6] A2=n423 B1=n79 B2=N30
XU474 AOI22S $PINS O=n82 A1=bank_mem_0[5][6] A2=n425 B1=bank_mem_0[6][6]
+ B2=n424
XU475 AOI22S $PINS O=n81 A1=bank_mem_0[3][6] A2=n427 B1=bank_mem_0[4][6]
+ B2=n426
XU476 AO222 $PINS O=n80 A1=bank_mem_0[1][6] A2=n430 B1=bank_mem_0[0][6] B2=n429
+ C1=bank_mem_0[2][6] C2=n428
XU477 AN4B1S $PINS O=n84 I1=n83 I2=n82 I3=n81 B1=n80
XU478 INV1S $PINS O=bank_rdata[0][6] I=n84
XU479 AOI22S $PINS O=n127 A1=bank_mem_0[14][7] A2=n410 B1=bank_mem_0[15][7]
+ B2=n409
XU480 AOI22S $PINS O=n126 A1=bank_mem_0[12][7] A2=n412 B1=bank_mem_0[13][7]
+ B2=n411
XU481 AOI22S $PINS O=n124 A1=bank_mem_0[10][7] A2=n414 B1=bank_mem_0[11][7]
+ B2=n413
XU482 AOI22S $PINS O=n123 A1=bank_mem_0[8][7] A2=n416 B1=bank_mem_0[9][7]
+ B2=n415
XU483 AN2 $PINS O=n125 I1=n124 I2=n123
XU484 ND3 $PINS O=n128 I1=n127 I2=n126 I3=n125
XU485 AOI22S $PINS O=n132 A1=bank_mem_0[7][7] A2=n423 B1=n128 B2=N30
XU486 AOI22S $PINS O=n131 A1=bank_mem_0[5][7] A2=n425 B1=bank_mem_0[6][7]
+ B2=n424
XU487 AOI22S $PINS O=n130 A1=bank_mem_0[3][7] A2=n427 B1=bank_mem_0[4][7]
+ B2=n426
XU488 AO222 $PINS O=n129 A1=bank_mem_0[1][7] A2=n430 B1=bank_mem_0[0][7]
+ B2=n429 C1=bank_mem_0[2][7] C2=n428
XU489 AN4B1S $PINS O=n133 I1=n132 I2=n131 I3=n130 B1=n129
XU490 INV1S $PINS O=bank_rdata[0][7] I=n133
XU491 AOI22S $PINS O=n138 A1=bank_mem_0[14][8] A2=n410 B1=bank_mem_0[15][8]
+ B2=n409
XU492 AOI22S $PINS O=n137 A1=bank_mem_0[12][8] A2=n412 B1=bank_mem_0[13][8]
+ B2=n411
XU493 AOI22S $PINS O=n135 A1=bank_mem_0[10][8] A2=n414 B1=bank_mem_0[11][8]
+ B2=n413
XU494 AOI22S $PINS O=n134 A1=bank_mem_0[8][8] A2=n416 B1=bank_mem_0[9][8]
+ B2=n415
XU495 AN2 $PINS O=n136 I1=n135 I2=n134
XU496 ND3 $PINS O=n139 I1=n138 I2=n137 I3=n136
XU497 AOI22S $PINS O=n143 A1=bank_mem_0[7][8] A2=n423 B1=n139 B2=N30
XU498 AOI22S $PINS O=n142 A1=bank_mem_0[5][8] A2=n425 B1=bank_mem_0[6][8]
+ B2=n424
XU499 AOI22S $PINS O=n141 A1=bank_mem_0[3][8] A2=n427 B1=bank_mem_0[4][8]
+ B2=n426
XU500 AO222 $PINS O=n140 A1=bank_mem_0[1][8] A2=n430 B1=bank_mem_0[0][8]
+ B2=n429 C1=bank_mem_0[2][8] C2=n428
XU501 AN4B1S $PINS O=n144 I1=n143 I2=n142 I3=n141 B1=n140
XU502 INV1S $PINS O=bank_rdata[0][8] I=n144
XU503 AOI22S $PINS O=n149 A1=bank_mem_0[14][9] A2=n410 B1=bank_mem_0[15][9]
+ B2=n409
XU504 AOI22S $PINS O=n148 A1=bank_mem_0[12][9] A2=n412 B1=bank_mem_0[13][9]
+ B2=n411
XU505 AOI22S $PINS O=n146 A1=bank_mem_0[10][9] A2=n414 B1=bank_mem_0[11][9]
+ B2=n413
XU506 AOI22S $PINS O=n145 A1=bank_mem_0[8][9] A2=n416 B1=bank_mem_0[9][9]
+ B2=n415
XU507 AN2 $PINS O=n147 I1=n146 I2=n145
XU508 ND3 $PINS O=n150 I1=n149 I2=n148 I3=n147
XU509 AOI22S $PINS O=n154 A1=bank_mem_0[7][9] A2=n423 B1=n150 B2=N30
XU510 AOI22S $PINS O=n153 A1=bank_mem_0[5][9] A2=n425 B1=bank_mem_0[6][9]
+ B2=n424
XU511 AOI22S $PINS O=n152 A1=bank_mem_0[3][9] A2=n427 B1=bank_mem_0[4][9]
+ B2=n426
XU512 AO222 $PINS O=n151 A1=bank_mem_0[1][9] A2=n430 B1=bank_mem_0[0][9]
+ B2=n429 C1=bank_mem_0[2][9] C2=n428
XU513 AN4B1S $PINS O=n155 I1=n154 I2=n153 I3=n152 B1=n151
XU514 INV1S $PINS O=bank_rdata[0][9] I=n155
XU515 AOI22S $PINS O=n160 A1=bank_mem_0[14][10] A2=n410 B1=bank_mem_0[15][10]
+ B2=n409
XU516 AOI22S $PINS O=n159 A1=bank_mem_0[12][10] A2=n412 B1=bank_mem_0[13][10]
+ B2=n411
XU517 AOI22S $PINS O=n157 A1=bank_mem_0[10][10] A2=n414 B1=bank_mem_0[11][10]
+ B2=n413
XU518 AOI22S $PINS O=n156 A1=bank_mem_0[8][10] A2=n416 B1=bank_mem_0[9][10]
+ B2=n415
XU519 AN2 $PINS O=n158 I1=n157 I2=n156
XU520 ND3 $PINS O=n161 I1=n160 I2=n159 I3=n158
XU521 AOI22S $PINS O=n165 A1=bank_mem_0[7][10] A2=n423 B1=n161 B2=N30
XU522 AOI22S $PINS O=n164 A1=bank_mem_0[5][10] A2=n425 B1=bank_mem_0[6][10]
+ B2=n424
XU523 AOI22S $PINS O=n163 A1=bank_mem_0[3][10] A2=n427 B1=bank_mem_0[4][10]
+ B2=n426
XU524 AO222 $PINS O=n162 A1=bank_mem_0[1][10] A2=n430 B1=bank_mem_0[0][10]
+ B2=n429 C1=bank_mem_0[2][10] C2=n428
XU525 AN4B1S $PINS O=n166 I1=n165 I2=n164 I3=n163 B1=n162
XU526 INV1S $PINS O=bank_rdata[0][10] I=n166
XU527 AOI22S $PINS O=n171 A1=bank_mem_0[14][11] A2=n410 B1=bank_mem_0[15][11]
+ B2=n409
XU528 AOI22S $PINS O=n170 A1=bank_mem_0[12][11] A2=n412 B1=bank_mem_0[13][11]
+ B2=n411
XU529 AOI22S $PINS O=n168 A1=bank_mem_0[10][11] A2=n414 B1=bank_mem_0[11][11]
+ B2=n413
XU530 AOI22S $PINS O=n167 A1=bank_mem_0[8][11] A2=n416 B1=bank_mem_0[9][11]
+ B2=n415
XU531 AN2 $PINS O=n169 I1=n168 I2=n167
XU532 ND3 $PINS O=n172 I1=n171 I2=n170 I3=n169
XU533 AOI22S $PINS O=n176 A1=bank_mem_0[7][11] A2=n423 B1=n172 B2=N30
XU534 AOI22S $PINS O=n175 A1=bank_mem_0[5][11] A2=n425 B1=bank_mem_0[6][11]
+ B2=n424
XU535 AOI22S $PINS O=n174 A1=bank_mem_0[3][11] A2=n427 B1=bank_mem_0[4][11]
+ B2=n426
XU536 AO222 $PINS O=n173 A1=bank_mem_0[1][11] A2=n430 B1=bank_mem_0[0][11]
+ B2=n429 C1=bank_mem_0[2][11] C2=n428
XU537 AN4B1S $PINS O=n177 I1=n176 I2=n175 I3=n174 B1=n173
XU538 INV1S $PINS O=bank_rdata[0][11] I=n177
XU539 AOI22S $PINS O=n182 A1=bank_mem_0[14][12] A2=n410 B1=bank_mem_0[15][12]
+ B2=n409
XU540 AOI22S $PINS O=n181 A1=bank_mem_0[12][12] A2=n412 B1=bank_mem_0[13][12]
+ B2=n411
XU541 AOI22S $PINS O=n179 A1=bank_mem_0[10][12] A2=n414 B1=bank_mem_0[11][12]
+ B2=n413
XU542 AOI22S $PINS O=n178 A1=bank_mem_0[8][12] A2=n416 B1=bank_mem_0[9][12]
+ B2=n415
XU543 AN2 $PINS O=n180 I1=n179 I2=n178
XU544 ND3 $PINS O=n183 I1=n182 I2=n181 I3=n180
XU545 AOI22S $PINS O=n187 A1=bank_mem_0[7][12] A2=n423 B1=n183 B2=N30
XU546 AOI22S $PINS O=n186 A1=bank_mem_0[5][12] A2=n425 B1=bank_mem_0[6][12]
+ B2=n424
XU547 AOI22S $PINS O=n185 A1=bank_mem_0[3][12] A2=n427 B1=bank_mem_0[4][12]
+ B2=n426
XU548 AO222 $PINS O=n184 A1=bank_mem_0[1][12] A2=n430 B1=bank_mem_0[0][12]
+ B2=n429 C1=bank_mem_0[2][12] C2=n428
XU549 AN4B1S $PINS O=n188 I1=n187 I2=n186 I3=n185 B1=n184
XU550 INV1S $PINS O=bank_rdata[0][12] I=n188
XU551 AOI22S $PINS O=n193 A1=bank_mem_0[14][13] A2=n410 B1=bank_mem_0[15][13]
+ B2=n409
XU552 AOI22S $PINS O=n192 A1=bank_mem_0[12][13] A2=n412 B1=bank_mem_0[13][13]
+ B2=n411
XU553 AOI22S $PINS O=n190 A1=bank_mem_0[10][13] A2=n414 B1=bank_mem_0[11][13]
+ B2=n413
XU554 AOI22S $PINS O=n189 A1=bank_mem_0[8][13] A2=n416 B1=bank_mem_0[9][13]
+ B2=n415
XU555 AN2 $PINS O=n191 I1=n190 I2=n189
XU556 ND3 $PINS O=n194 I1=n193 I2=n192 I3=n191
XU557 AOI22S $PINS O=n198 A1=bank_mem_0[7][13] A2=n423 B1=n194 B2=N30
XU558 AOI22S $PINS O=n197 A1=bank_mem_0[5][13] A2=n425 B1=bank_mem_0[6][13]
+ B2=n424
XU559 AOI22S $PINS O=n196 A1=bank_mem_0[3][13] A2=n427 B1=bank_mem_0[4][13]
+ B2=n426
XU560 AO222 $PINS O=n195 A1=bank_mem_0[1][13] A2=n430 B1=bank_mem_0[0][13]
+ B2=n429 C1=bank_mem_0[2][13] C2=n428
XU561 AN4B1S $PINS O=n199 I1=n198 I2=n197 I3=n196 B1=n195
XU562 INV1S $PINS O=bank_rdata[0][13] I=n199
XU563 AOI22S $PINS O=n204 A1=bank_mem_0[14][14] A2=n410 B1=bank_mem_0[15][14]
+ B2=n409
XU564 AOI22S $PINS O=n203 A1=bank_mem_0[12][14] A2=n412 B1=bank_mem_0[13][14]
+ B2=n411
XU565 AOI22S $PINS O=n201 A1=bank_mem_0[10][14] A2=n414 B1=bank_mem_0[11][14]
+ B2=n413
XU566 AOI22S $PINS O=n200 A1=bank_mem_0[8][14] A2=n416 B1=bank_mem_0[9][14]
+ B2=n415
XU567 AN2 $PINS O=n202 I1=n201 I2=n200
XU568 ND3 $PINS O=n205 I1=n204 I2=n203 I3=n202
XU569 AOI22S $PINS O=n209 A1=bank_mem_0[7][14] A2=n423 B1=n205 B2=N30
XU570 AOI22S $PINS O=n208 A1=bank_mem_0[5][14] A2=n425 B1=bank_mem_0[6][14]
+ B2=n424
XU571 AOI22S $PINS O=n207 A1=bank_mem_0[3][14] A2=n427 B1=bank_mem_0[4][14]
+ B2=n426
XU572 AO222 $PINS O=n206 A1=bank_mem_0[1][14] A2=n430 B1=bank_mem_0[0][14]
+ B2=n429 C1=bank_mem_0[2][14] C2=n428
XU573 AN4B1S $PINS O=n210 I1=n209 I2=n208 I3=n207 B1=n206
XU574 INV1S $PINS O=bank_rdata[0][14] I=n210
XU575 AOI22S $PINS O=n215 A1=bank_mem_0[14][15] A2=n410 B1=bank_mem_0[15][15]
+ B2=n409
XU576 AOI22S $PINS O=n214 A1=bank_mem_0[12][15] A2=n412 B1=bank_mem_0[13][15]
+ B2=n411
XU577 AOI22S $PINS O=n212 A1=bank_mem_0[10][15] A2=n414 B1=bank_mem_0[11][15]
+ B2=n413
XU578 AOI22S $PINS O=n211 A1=bank_mem_0[8][15] A2=n416 B1=bank_mem_0[9][15]
+ B2=n415
XU579 AN2 $PINS O=n213 I1=n212 I2=n211
XU580 ND3 $PINS O=n216 I1=n215 I2=n214 I3=n213
XU581 AOI22S $PINS O=n220 A1=bank_mem_0[7][15] A2=n423 B1=n216 B2=N30
XU582 AOI22S $PINS O=n219 A1=bank_mem_0[5][15] A2=n425 B1=bank_mem_0[6][15]
+ B2=n424
XU583 AOI22S $PINS O=n218 A1=bank_mem_0[3][15] A2=n427 B1=bank_mem_0[4][15]
+ B2=n426
XU584 AO222 $PINS O=n217 A1=bank_mem_0[1][15] A2=n430 B1=bank_mem_0[0][15]
+ B2=n429 C1=bank_mem_0[2][15] C2=n428
XU585 AN4B1S $PINS O=n221 I1=n220 I2=n219 I3=n218 B1=n217
XU586 INV1S $PINS O=bank_rdata[0][15] I=n221
XU587 AOI22S $PINS O=n226 A1=bank_mem_0[14][16] A2=n410 B1=bank_mem_0[15][16]
+ B2=n409
XU588 AOI22S $PINS O=n225 A1=bank_mem_0[12][16] A2=n412 B1=bank_mem_0[13][16]
+ B2=n411
XU589 AOI22S $PINS O=n223 A1=bank_mem_0[10][16] A2=n414 B1=bank_mem_0[11][16]
+ B2=n413
XU590 AOI22S $PINS O=n222 A1=bank_mem_0[8][16] A2=n416 B1=bank_mem_0[9][16]
+ B2=n415
XU591 AN2 $PINS O=n224 I1=n223 I2=n222
XU592 ND3 $PINS O=n227 I1=n226 I2=n225 I3=n224
XU593 AOI22S $PINS O=n231 A1=bank_mem_0[7][16] A2=n423 B1=n227 B2=N30
XU594 AOI22S $PINS O=n230 A1=bank_mem_0[5][16] A2=n425 B1=bank_mem_0[6][16]
+ B2=n424
XU595 AOI22S $PINS O=n229 A1=bank_mem_0[3][16] A2=n427 B1=bank_mem_0[4][16]
+ B2=n426
XU596 AO222 $PINS O=n228 A1=bank_mem_0[1][16] A2=n430 B1=bank_mem_0[0][16]
+ B2=n429 C1=bank_mem_0[2][16] C2=n428
XU597 AN4B1S $PINS O=n232 I1=n231 I2=n230 I3=n229 B1=n228
XU598 INV1S $PINS O=bank_rdata[0][16] I=n232
XU599 AOI22S $PINS O=n237 A1=bank_mem_0[14][17] A2=n410 B1=bank_mem_0[15][17]
+ B2=n409
XU600 AOI22S $PINS O=n236 A1=bank_mem_0[12][17] A2=n412 B1=bank_mem_0[13][17]
+ B2=n411
XU601 AOI22S $PINS O=n234 A1=bank_mem_0[10][17] A2=n414 B1=bank_mem_0[11][17]
+ B2=n413
XU602 AOI22S $PINS O=n233 A1=bank_mem_0[8][17] A2=n416 B1=bank_mem_0[9][17]
+ B2=n415
XU603 AN2 $PINS O=n235 I1=n234 I2=n233
XU604 ND3 $PINS O=n238 I1=n237 I2=n236 I3=n235
XU605 AOI22S $PINS O=n242 A1=bank_mem_0[7][17] A2=n423 B1=n238 B2=N30
XU606 AOI22S $PINS O=n241 A1=bank_mem_0[5][17] A2=n425 B1=bank_mem_0[6][17]
+ B2=n424
XU607 AOI22S $PINS O=n240 A1=bank_mem_0[3][17] A2=n427 B1=bank_mem_0[4][17]
+ B2=n426
XU608 AO222 $PINS O=n239 A1=bank_mem_0[1][17] A2=n430 B1=bank_mem_0[0][17]
+ B2=n429 C1=bank_mem_0[2][17] C2=n428
XU609 AN4B1S $PINS O=n243 I1=n242 I2=n241 I3=n240 B1=n239
XU610 INV1S $PINS O=bank_rdata[0][17] I=n243
XU611 AOI22S $PINS O=n248 A1=bank_mem_0[14][18] A2=n410 B1=bank_mem_0[15][18]
+ B2=n409
XU612 AOI22S $PINS O=n247 A1=bank_mem_0[12][18] A2=n412 B1=bank_mem_0[13][18]
+ B2=n411
XU613 AOI22S $PINS O=n245 A1=bank_mem_0[10][18] A2=n414 B1=bank_mem_0[11][18]
+ B2=n413
XU614 AOI22S $PINS O=n244 A1=bank_mem_0[8][18] A2=n416 B1=bank_mem_0[9][18]
+ B2=n415
XU615 AN2 $PINS O=n246 I1=n245 I2=n244
XU616 ND3 $PINS O=n249 I1=n248 I2=n247 I3=n246
XU617 AOI22S $PINS O=n253 A1=bank_mem_0[7][18] A2=n423 B1=n249 B2=N30
XU618 AOI22S $PINS O=n252 A1=bank_mem_0[5][18] A2=n425 B1=bank_mem_0[6][18]
+ B2=n424
XU619 AOI22S $PINS O=n251 A1=bank_mem_0[3][18] A2=n427 B1=bank_mem_0[4][18]
+ B2=n426
XU620 AO222 $PINS O=n250 A1=bank_mem_0[1][18] A2=n430 B1=bank_mem_0[0][18]
+ B2=n429 C1=bank_mem_0[2][18] C2=n428
XU621 AN4B1S $PINS O=n254 I1=n253 I2=n252 I3=n251 B1=n250
XU622 INV1S $PINS O=bank_rdata[0][18] I=n254
XU623 AOI22S $PINS O=n259 A1=bank_mem_0[14][19] A2=n410 B1=bank_mem_0[15][19]
+ B2=n409
XU624 AOI22S $PINS O=n258 A1=bank_mem_0[12][19] A2=n412 B1=bank_mem_0[13][19]
+ B2=n411
XU625 AOI22S $PINS O=n256 A1=bank_mem_0[10][19] A2=n414 B1=bank_mem_0[11][19]
+ B2=n413
XU626 AOI22S $PINS O=n255 A1=bank_mem_0[8][19] A2=n416 B1=bank_mem_0[9][19]
+ B2=n415
XU627 AN2 $PINS O=n257 I1=n256 I2=n255
XU628 ND3 $PINS O=n260 I1=n259 I2=n258 I3=n257
XU629 AOI22S $PINS O=n264 A1=bank_mem_0[7][19] A2=n423 B1=n260 B2=N30
XU630 AOI22S $PINS O=n263 A1=bank_mem_0[5][19] A2=n425 B1=bank_mem_0[6][19]
+ B2=n424
XU631 AOI22S $PINS O=n262 A1=bank_mem_0[3][19] A2=n427 B1=bank_mem_0[4][19]
+ B2=n426
XU632 AO222 $PINS O=n261 A1=bank_mem_0[1][19] A2=n430 B1=bank_mem_0[0][19]
+ B2=n429 C1=bank_mem_0[2][19] C2=n428
XU633 AN4B1S $PINS O=n265 I1=n264 I2=n263 I3=n262 B1=n261
XU634 INV1S $PINS O=bank_rdata[0][19] I=n265
XU635 AOI22S $PINS O=n270 A1=bank_mem_0[14][20] A2=n410 B1=bank_mem_0[15][20]
+ B2=n409
XU636 AOI22S $PINS O=n269 A1=bank_mem_0[12][20] A2=n412 B1=bank_mem_0[13][20]
+ B2=n411
XU637 AOI22S $PINS O=n267 A1=bank_mem_0[10][20] A2=n414 B1=bank_mem_0[11][20]
+ B2=n413
XU638 AOI22S $PINS O=n266 A1=bank_mem_0[8][20] A2=n416 B1=bank_mem_0[9][20]
+ B2=n415
XU639 AN2 $PINS O=n268 I1=n267 I2=n266
XU640 ND3 $PINS O=n271 I1=n270 I2=n269 I3=n268
XU641 AOI22S $PINS O=n275 A1=bank_mem_0[7][20] A2=n423 B1=n271 B2=N30
XU642 AOI22S $PINS O=n274 A1=bank_mem_0[5][20] A2=n425 B1=bank_mem_0[6][20]
+ B2=n424
XU643 AOI22S $PINS O=n273 A1=bank_mem_0[3][20] A2=n427 B1=bank_mem_0[4][20]
+ B2=n426
XU644 AO222 $PINS O=n272 A1=bank_mem_0[1][20] A2=n430 B1=bank_mem_0[0][20]
+ B2=n429 C1=bank_mem_0[2][20] C2=n428
XU645 AN4B1S $PINS O=n276 I1=n275 I2=n274 I3=n273 B1=n272
XU646 INV1S $PINS O=bank_rdata[0][20] I=n276
XU647 AOI22S $PINS O=n281 A1=bank_mem_0[14][21] A2=n410 B1=bank_mem_0[15][21]
+ B2=n409
XU648 AOI22S $PINS O=n280 A1=bank_mem_0[12][21] A2=n412 B1=bank_mem_0[13][21]
+ B2=n411
XU649 AOI22S $PINS O=n278 A1=bank_mem_0[10][21] A2=n414 B1=bank_mem_0[11][21]
+ B2=n413
XU650 AOI22S $PINS O=n277 A1=bank_mem_0[8][21] A2=n416 B1=bank_mem_0[9][21]
+ B2=n415
XU651 AN2 $PINS O=n279 I1=n278 I2=n277
XU652 ND3 $PINS O=n282 I1=n281 I2=n280 I3=n279
XU653 AOI22S $PINS O=n286 A1=bank_mem_0[7][21] A2=n423 B1=n282 B2=N30
XU654 AOI22S $PINS O=n285 A1=bank_mem_0[5][21] A2=n425 B1=bank_mem_0[6][21]
+ B2=n424
XU655 AOI22S $PINS O=n284 A1=bank_mem_0[3][21] A2=n427 B1=bank_mem_0[4][21]
+ B2=n426
XU656 AO222 $PINS O=n283 A1=bank_mem_0[1][21] A2=n430 B1=bank_mem_0[0][21]
+ B2=n429 C1=bank_mem_0[2][21] C2=n428
XU657 AN4B1S $PINS O=n287 I1=n286 I2=n285 I3=n284 B1=n283
XU658 INV1S $PINS O=bank_rdata[0][21] I=n287
XU659 AOI22S $PINS O=n292 A1=bank_mem_0[14][22] A2=n410 B1=bank_mem_0[15][22]
+ B2=n409
XU660 AOI22S $PINS O=n291 A1=bank_mem_0[12][22] A2=n412 B1=bank_mem_0[13][22]
+ B2=n411
XU661 AOI22S $PINS O=n289 A1=bank_mem_0[10][22] A2=n414 B1=bank_mem_0[11][22]
+ B2=n413
XU662 AOI22S $PINS O=n288 A1=bank_mem_0[8][22] A2=n416 B1=bank_mem_0[9][22]
+ B2=n415
XU663 AN2 $PINS O=n290 I1=n289 I2=n288
XU664 ND3 $PINS O=n293 I1=n292 I2=n291 I3=n290
XU665 AOI22S $PINS O=n297 A1=bank_mem_0[7][22] A2=n423 B1=n293 B2=N30
XU666 AOI22S $PINS O=n296 A1=bank_mem_0[5][22] A2=n425 B1=bank_mem_0[6][22]
+ B2=n424
XU667 AOI22S $PINS O=n295 A1=bank_mem_0[3][22] A2=n427 B1=bank_mem_0[4][22]
+ B2=n426
XU668 AO222 $PINS O=n294 A1=bank_mem_0[1][22] A2=n430 B1=bank_mem_0[0][22]
+ B2=n429 C1=bank_mem_0[2][22] C2=n428
XU669 AN4B1S $PINS O=n298 I1=n297 I2=n296 I3=n295 B1=n294
XU670 INV1S $PINS O=bank_rdata[0][22] I=n298
XU671 AOI22S $PINS O=n303 A1=bank_mem_0[14][23] A2=n410 B1=bank_mem_0[15][23]
+ B2=n409
XU672 AOI22S $PINS O=n302 A1=bank_mem_0[12][23] A2=n412 B1=bank_mem_0[13][23]
+ B2=n411
XU673 AOI22S $PINS O=n300 A1=bank_mem_0[10][23] A2=n414 B1=bank_mem_0[11][23]
+ B2=n413
XU674 AOI22S $PINS O=n299 A1=bank_mem_0[8][23] A2=n416 B1=bank_mem_0[9][23]
+ B2=n415
XU675 AN2 $PINS O=n301 I1=n300 I2=n299
XU676 ND3 $PINS O=n304 I1=n303 I2=n302 I3=n301
XU677 AOI22S $PINS O=n308 A1=bank_mem_0[7][23] A2=n423 B1=n304 B2=N30
XU678 AOI22S $PINS O=n307 A1=bank_mem_0[5][23] A2=n425 B1=bank_mem_0[6][23]
+ B2=n424
XU679 AOI22S $PINS O=n306 A1=bank_mem_0[3][23] A2=n427 B1=bank_mem_0[4][23]
+ B2=n426
XU680 AO222 $PINS O=n305 A1=bank_mem_0[1][23] A2=n430 B1=bank_mem_0[0][23]
+ B2=n429 C1=bank_mem_0[2][23] C2=n428
XU681 AN4B1S $PINS O=n309 I1=n308 I2=n307 I3=n306 B1=n305
XU682 INV1S $PINS O=bank_rdata[0][23] I=n309
XU683 AOI22S $PINS O=n314 A1=bank_mem_0[14][24] A2=n410 B1=bank_mem_0[15][24]
+ B2=n409
XU684 AOI22S $PINS O=n313 A1=bank_mem_0[12][24] A2=n412 B1=bank_mem_0[13][24]
+ B2=n411
XU685 AOI22S $PINS O=n311 A1=bank_mem_0[10][24] A2=n414 B1=bank_mem_0[11][24]
+ B2=n413
XU686 AOI22S $PINS O=n310 A1=bank_mem_0[8][24] A2=n416 B1=bank_mem_0[9][24]
+ B2=n415
XU687 AN2 $PINS O=n312 I1=n311 I2=n310
XU688 ND3 $PINS O=n315 I1=n314 I2=n313 I3=n312
XU689 AOI22S $PINS O=n319 A1=bank_mem_0[7][24] A2=n423 B1=n315 B2=N30
XU690 AOI22S $PINS O=n318 A1=bank_mem_0[5][24] A2=n425 B1=bank_mem_0[6][24]
+ B2=n424
XU691 AOI22S $PINS O=n317 A1=bank_mem_0[3][24] A2=n427 B1=bank_mem_0[4][24]
+ B2=n426
XU692 AO222 $PINS O=n316 A1=bank_mem_0[1][24] A2=n430 B1=bank_mem_0[0][24]
+ B2=n429 C1=bank_mem_0[2][24] C2=n428
XU693 AN4B1S $PINS O=n320 I1=n319 I2=n318 I3=n317 B1=n316
XU694 INV1S $PINS O=bank_rdata[0][24] I=n320
XU695 AOI22S $PINS O=n325 A1=bank_mem_0[14][25] A2=n410 B1=bank_mem_0[15][25]
+ B2=n409
XU696 AOI22S $PINS O=n324 A1=bank_mem_0[12][25] A2=n412 B1=bank_mem_0[13][25]
+ B2=n411
XU697 AOI22S $PINS O=n322 A1=bank_mem_0[10][25] A2=n414 B1=bank_mem_0[11][25]
+ B2=n413
XU698 AOI22S $PINS O=n321 A1=bank_mem_0[8][25] A2=n416 B1=bank_mem_0[9][25]
+ B2=n415
XU699 AN2 $PINS O=n323 I1=n322 I2=n321
XU700 ND3 $PINS O=n326 I1=n325 I2=n324 I3=n323
XU701 AOI22S $PINS O=n330 A1=bank_mem_0[7][25] A2=n423 B1=n326 B2=N30
XU702 AOI22S $PINS O=n329 A1=bank_mem_0[5][25] A2=n425 B1=bank_mem_0[6][25]
+ B2=n424
XU703 AOI22S $PINS O=n328 A1=bank_mem_0[3][25] A2=n427 B1=bank_mem_0[4][25]
+ B2=n426
XU704 AO222 $PINS O=n327 A1=bank_mem_0[1][25] A2=n430 B1=bank_mem_0[0][25]
+ B2=n429 C1=bank_mem_0[2][25] C2=n428
XU705 AN4B1S $PINS O=n331 I1=n330 I2=n329 I3=n328 B1=n327
XU706 INV1S $PINS O=bank_rdata[0][25] I=n331
XU707 AOI22S $PINS O=n336 A1=bank_mem_0[14][26] A2=n410 B1=bank_mem_0[15][26]
+ B2=n409
XU708 AOI22S $PINS O=n335 A1=bank_mem_0[12][26] A2=n412 B1=bank_mem_0[13][26]
+ B2=n411
XU709 AOI22S $PINS O=n333 A1=bank_mem_0[10][26] A2=n414 B1=bank_mem_0[11][26]
+ B2=n413
XU710 AOI22S $PINS O=n332 A1=bank_mem_0[8][26] A2=n416 B1=bank_mem_0[9][26]
+ B2=n415
XU711 AN2 $PINS O=n334 I1=n333 I2=n332
XU712 ND3 $PINS O=n337 I1=n336 I2=n335 I3=n334
XU713 AOI22S $PINS O=n341 A1=bank_mem_0[7][26] A2=n423 B1=n337 B2=N30
XU714 AOI22S $PINS O=n340 A1=bank_mem_0[5][26] A2=n425 B1=bank_mem_0[6][26]
+ B2=n424
XU715 AOI22S $PINS O=n339 A1=bank_mem_0[3][26] A2=n427 B1=bank_mem_0[4][26]
+ B2=n426
XU716 AO222 $PINS O=n338 A1=bank_mem_0[1][26] A2=n430 B1=bank_mem_0[0][26]
+ B2=n429 C1=bank_mem_0[2][26] C2=n428
XU717 AN4B1S $PINS O=n342 I1=n341 I2=n340 I3=n339 B1=n338
XU718 INV1S $PINS O=bank_rdata[0][26] I=n342
XU719 AOI22S $PINS O=n347 A1=bank_mem_0[14][27] A2=n410 B1=bank_mem_0[15][27]
+ B2=n409
XU720 AOI22S $PINS O=n346 A1=bank_mem_0[12][27] A2=n412 B1=bank_mem_0[13][27]
+ B2=n411
XU721 AOI22S $PINS O=n344 A1=bank_mem_0[10][27] A2=n414 B1=bank_mem_0[11][27]
+ B2=n413
XU722 AOI22S $PINS O=n343 A1=bank_mem_0[8][27] A2=n416 B1=bank_mem_0[9][27]
+ B2=n415
XU723 AN2 $PINS O=n345 I1=n344 I2=n343
XU724 ND3 $PINS O=n348 I1=n347 I2=n346 I3=n345
XU725 AOI22S $PINS O=n352 A1=bank_mem_0[7][27] A2=n423 B1=n348 B2=N30
XU726 AOI22S $PINS O=n351 A1=bank_mem_0[5][27] A2=n425 B1=bank_mem_0[6][27]
+ B2=n424
XU727 AOI22S $PINS O=n350 A1=bank_mem_0[3][27] A2=n427 B1=bank_mem_0[4][27]
+ B2=n426
XU728 AO222 $PINS O=n349 A1=bank_mem_0[1][27] A2=n430 B1=bank_mem_0[0][27]
+ B2=n429 C1=bank_mem_0[2][27] C2=n428
XU729 AN4B1S $PINS O=n353 I1=n352 I2=n351 I3=n350 B1=n349
XU730 INV1S $PINS O=bank_rdata[0][27] I=n353
XU731 AOI22S $PINS O=n358 A1=bank_mem_0[14][28] A2=n410 B1=bank_mem_0[15][28]
+ B2=n409
XU732 AOI22S $PINS O=n357 A1=bank_mem_0[12][28] A2=n412 B1=bank_mem_0[13][28]
+ B2=n411
XU733 AOI22S $PINS O=n355 A1=bank_mem_0[10][28] A2=n414 B1=bank_mem_0[11][28]
+ B2=n413
XU734 AOI22S $PINS O=n354 A1=bank_mem_0[8][28] A2=n416 B1=bank_mem_0[9][28]
+ B2=n415
XU735 AN2 $PINS O=n356 I1=n355 I2=n354
XU736 ND3 $PINS O=n359 I1=n358 I2=n357 I3=n356
XU737 AOI22S $PINS O=n363 A1=bank_mem_0[7][28] A2=n423 B1=n359 B2=N30
XU738 AOI22S $PINS O=n362 A1=bank_mem_0[5][28] A2=n425 B1=bank_mem_0[6][28]
+ B2=n424
XU739 AOI22S $PINS O=n361 A1=bank_mem_0[3][28] A2=n427 B1=bank_mem_0[4][28]
+ B2=n426
XU740 AO222 $PINS O=n360 A1=bank_mem_0[1][28] A2=n430 B1=bank_mem_0[0][28]
+ B2=n429 C1=bank_mem_0[2][28] C2=n428
XU741 AN4B1S $PINS O=n364 I1=n363 I2=n362 I3=n361 B1=n360
XU742 INV1S $PINS O=bank_rdata[0][28] I=n364
XU743 AOI22S $PINS O=n369 A1=bank_mem_0[14][29] A2=n410 B1=bank_mem_0[15][29]
+ B2=n409
XU744 AOI22S $PINS O=n368 A1=bank_mem_0[12][29] A2=n412 B1=bank_mem_0[13][29]
+ B2=n411
XU745 AOI22S $PINS O=n366 A1=bank_mem_0[10][29] A2=n414 B1=bank_mem_0[11][29]
+ B2=n413
XU746 AOI22S $PINS O=n365 A1=bank_mem_0[8][29] A2=n416 B1=bank_mem_0[9][29]
+ B2=n415
XU747 AN2 $PINS O=n367 I1=n366 I2=n365
XU748 ND3 $PINS O=n370 I1=n369 I2=n368 I3=n367
XU749 AOI22S $PINS O=n374 A1=bank_mem_0[7][29] A2=n423 B1=n370 B2=N30
XU750 AOI22S $PINS O=n373 A1=bank_mem_0[5][29] A2=n425 B1=bank_mem_0[6][29]
+ B2=n424
XU751 AOI22S $PINS O=n372 A1=bank_mem_0[3][29] A2=n427 B1=bank_mem_0[4][29]
+ B2=n426
XU752 AO222 $PINS O=n371 A1=bank_mem_0[1][29] A2=n430 B1=bank_mem_0[0][29]
+ B2=n429 C1=bank_mem_0[2][29] C2=n428
XU753 AN4B1S $PINS O=n375 I1=n374 I2=n373 I3=n372 B1=n371
XU754 INV1S $PINS O=bank_rdata[0][29] I=n375
XU755 AOI22S $PINS O=n380 A1=bank_mem_0[14][30] A2=n410 B1=bank_mem_0[15][30]
+ B2=n409
XU756 AOI22S $PINS O=n379 A1=bank_mem_0[12][30] A2=n412 B1=bank_mem_0[13][30]
+ B2=n411
XU757 AOI22S $PINS O=n377 A1=bank_mem_0[10][30] A2=n414 B1=bank_mem_0[11][30]
+ B2=n413
XU758 AOI22S $PINS O=n376 A1=bank_mem_0[8][30] A2=n416 B1=bank_mem_0[9][30]
+ B2=n415
XU759 AN2 $PINS O=n378 I1=n377 I2=n376
XU760 ND3 $PINS O=n381 I1=n380 I2=n379 I3=n378
XU761 AOI22S $PINS O=n385 A1=bank_mem_0[7][30] A2=n423 B1=n381 B2=N30
XU762 AOI22S $PINS O=n384 A1=bank_mem_0[5][30] A2=n425 B1=bank_mem_0[6][30]
+ B2=n424
XU763 AOI22S $PINS O=n383 A1=bank_mem_0[3][30] A2=n427 B1=bank_mem_0[4][30]
+ B2=n426
XU764 AO222 $PINS O=n382 A1=bank_mem_0[1][30] A2=n430 B1=bank_mem_0[0][30]
+ B2=n429 C1=bank_mem_0[2][30] C2=n428
XU765 AN4B1S $PINS O=n386 I1=n385 I2=n384 I3=n383 B1=n382
XU766 INV1S $PINS O=bank_rdata[0][30] I=n386
XU767 AOI22S $PINS O=n391 A1=bank_mem_0[14][31] A2=n410 B1=bank_mem_0[15][31]
+ B2=n409
XU768 AOI22S $PINS O=n390 A1=bank_mem_0[12][31] A2=n412 B1=bank_mem_0[13][31]
+ B2=n411
XU769 AOI22S $PINS O=n388 A1=bank_mem_0[10][31] A2=n414 B1=bank_mem_0[11][31]
+ B2=n413
XU770 AOI22S $PINS O=n387 A1=bank_mem_0[8][31] A2=n416 B1=bank_mem_0[9][31]
+ B2=n415
XU771 AN2 $PINS O=n389 I1=n388 I2=n387
XU772 ND3 $PINS O=n392 I1=n391 I2=n390 I3=n389
XU773 AOI22S $PINS O=n396 A1=bank_mem_0[7][31] A2=n423 B1=n392 B2=N30
XU774 AOI22S $PINS O=n395 A1=bank_mem_0[5][31] A2=n425 B1=bank_mem_0[6][31]
+ B2=n424
XU775 AOI22S $PINS O=n394 A1=bank_mem_0[3][31] A2=n427 B1=bank_mem_0[4][31]
+ B2=n426
XU776 AO222 $PINS O=n393 A1=bank_mem_0[1][31] A2=n430 B1=bank_mem_0[0][31]
+ B2=n429 C1=bank_mem_0[2][31] C2=n428
XU777 AN4B1S $PINS O=n397 I1=n396 I2=n395 I3=n394 B1=n393
XU778 INV1S $PINS O=bank_rdata[0][31] I=n397
XU779 AOI22S $PINS O=n402 A1=bank_mem_0[14][32] A2=n410 B1=bank_mem_0[15][32]
+ B2=n409
XU780 AOI22S $PINS O=n401 A1=bank_mem_0[12][32] A2=n412 B1=bank_mem_0[13][32]
+ B2=n411
XU781 AOI22S $PINS O=n399 A1=bank_mem_0[10][32] A2=n414 B1=bank_mem_0[11][32]
+ B2=n413
XU782 AOI22S $PINS O=n398 A1=bank_mem_0[8][32] A2=n416 B1=bank_mem_0[9][32]
+ B2=n415
XU783 AN2 $PINS O=n400 I1=n399 I2=n398
XU784 ND3 $PINS O=n403 I1=n402 I2=n401 I3=n400
XU785 AOI22S $PINS O=n407 A1=bank_mem_0[7][32] A2=n423 B1=n403 B2=N30
XU786 AOI22S $PINS O=n406 A1=bank_mem_0[5][32] A2=n425 B1=bank_mem_0[6][32]
+ B2=n424
XU787 AOI22S $PINS O=n405 A1=bank_mem_0[3][32] A2=n427 B1=bank_mem_0[4][32]
+ B2=n426
XU788 AO222 $PINS O=n404 A1=bank_mem_0[1][32] A2=n430 B1=bank_mem_0[0][32]
+ B2=n429 C1=bank_mem_0[2][32] C2=n428
XU789 AN4B1S $PINS O=n408 I1=n407 I2=n406 I3=n405 B1=n404
XU790 INV1S $PINS O=bank_rdata[0][32] I=n408
XU791 AOI22S $PINS O=n421 A1=bank_mem_0[14][33] A2=n410 B1=bank_mem_0[15][33]
+ B2=n409
XU792 AOI22S $PINS O=n420 A1=bank_mem_0[12][33] A2=n412 B1=bank_mem_0[13][33]
+ B2=n411
XU793 AOI22S $PINS O=n418 A1=bank_mem_0[10][33] A2=n414 B1=bank_mem_0[11][33]
+ B2=n413
XU794 AOI22S $PINS O=n417 A1=bank_mem_0[8][33] A2=n416 B1=bank_mem_0[9][33]
+ B2=n415
XU795 AN2 $PINS O=n419 I1=n418 I2=n417
XU796 ND3 $PINS O=n422 I1=n421 I2=n420 I3=n419
XU797 AOI22S $PINS O=n434 A1=bank_mem_0[7][33] A2=n423 B1=N30 B2=n422
XU798 AOI22S $PINS O=n433 A1=bank_mem_0[5][33] A2=n425 B1=bank_mem_0[6][33]
+ B2=n424
XU799 AOI22S $PINS O=n432 A1=bank_mem_0[3][33] A2=n427 B1=bank_mem_0[4][33]
+ B2=n426
XU800 AO222 $PINS O=n431 A1=bank_mem_0[1][33] A2=n430 B1=bank_mem_0[0][33]
+ B2=n429 C1=bank_mem_0[2][33] C2=n428
XU801 AN4B1S $PINS O=n435 I1=n434 I2=n433 I3=n432 B1=n431
XU802 INV1S $PINS O=bank_rdata[0][33] I=n435
XU803 NR2 $PINS O=n463 I1=n854 I2=N34
XU804 NR2 $PINS O=n462 I1=n853 I2=n852
XU805 AN2 $PINS O=n839 I1=n463 I2=n462
XU806 NR2 $PINS O=n466 I1=n853 I2=N31
XU807 AN2P $PINS O=n826 I1=n466 I2=N33
XU808 AN2P $PINS O=n825 I1=N33 I2=n462
XU809 AOI22S $PINS O=n460 A1=bank_mem_1[14][0] A2=n826 B1=bank_mem_1[15][0]
+ B2=n825
XU810 NR2 $PINS O=n465 I1=N31 I2=N32
XU811 AN2P $PINS O=n828 I1=n465 I2=N33
XU812 NR2 $PINS O=n464 I1=n852 I2=N32
XU813 AN2 $PINS O=n827 I1=n464 I2=N33
XU814 AOI22S $PINS O=n459 A1=bank_mem_1[12][0] A2=n828 B1=bank_mem_1[13][0]
+ B2=n827
XU815 AN2P $PINS O=n830 I1=n466 I2=n854
XU816 AN2P $PINS O=n829 I1=n462 I2=n854
XU817 AOI22S $PINS O=n457 A1=bank_mem_1[10][0] A2=n830 B1=bank_mem_1[11][0]
+ B2=n829
XU818 AN2P $PINS O=n832 I1=n465 I2=n854
XU819 AN2 $PINS O=n831 I1=n464 I2=n854
XU820 AOI22S $PINS O=n456 A1=bank_mem_1[8][0] A2=n832 B1=bank_mem_1[9][0]
+ B2=n831
XU821 AN2 $PINS O=n458 I1=n457 I2=n456
XU822 ND3 $PINS O=n461 I1=n460 I2=n459 I3=n458
XU823 AOI22S $PINS O=n471 A1=bank_mem_1[7][0] A2=n839 B1=n461 B2=N34
XU824 AN2P $PINS O=n841 I1=n463 I2=n464
XU825 AN2 $PINS O=n840 I1=n463 I2=n466
XU826 AOI22S $PINS O=n470 A1=bank_mem_1[5][0] A2=n841 B1=bank_mem_1[6][0]
+ B2=n840
XU827 NR2 $PINS O=n467 I1=N33 I2=N34
XU828 AN2P $PINS O=n843 I1=n467 I2=n462
XU829 AN2 $PINS O=n842 I1=n463 I2=n465
XU830 AOI22S $PINS O=n469 A1=bank_mem_1[3][0] A2=n843 B1=bank_mem_1[4][0]
+ B2=n842
XU831 AN2 $PINS O=n846 I1=n467 I2=n464
XU832 AN2 $PINS O=n845 I1=n467 I2=n465
XU833 AN2 $PINS O=n844 I1=n467 I2=n466
XU834 AO222 $PINS O=n468 A1=bank_mem_1[1][0] A2=n846 B1=bank_mem_1[0][0]
+ B2=n845 C1=bank_mem_1[2][0] C2=n844
XU835 AN4B1S $PINS O=n472 I1=n471 I2=n470 I3=n469 B1=n468
XU836 INV1S $PINS O=bank_rdata[1][0] I=FE_PHN1203_n472
XU837 AOI22S $PINS O=n477 A1=bank_mem_1[14][1] A2=n826 B1=bank_mem_1[15][1]
+ B2=n825
XU838 AOI22S $PINS O=n476 A1=bank_mem_1[12][1] A2=n828 B1=bank_mem_1[13][1]
+ B2=n827
XU839 AOI22S $PINS O=n474 A1=bank_mem_1[10][1] A2=n830 B1=bank_mem_1[11][1]
+ B2=n829
XU840 AOI22S $PINS O=n473 A1=bank_mem_1[8][1] A2=n832 B1=bank_mem_1[9][1]
+ B2=n831
XU841 AN2 $PINS O=n475 I1=n474 I2=n473
XU842 ND3 $PINS O=n478 I1=n477 I2=n476 I3=n475
XU843 AOI22S $PINS O=n482 A1=bank_mem_1[7][1] A2=n839 B1=n478 B2=N34
XU844 AOI22S $PINS O=n481 A1=bank_mem_1[5][1] A2=n841 B1=bank_mem_1[6][1]
+ B2=n840
XU845 AOI22S $PINS O=n480 A1=bank_mem_1[3][1] A2=n843 B1=bank_mem_1[4][1]
+ B2=n842
XU846 AO222 $PINS O=n479 A1=bank_mem_1[1][1] A2=n846 B1=bank_mem_1[0][1]
+ B2=n845 C1=bank_mem_1[2][1] C2=n844
XU847 AN4B1S $PINS O=n483 I1=n482 I2=n481 I3=n480 B1=n479
XU848 INV1S $PINS O=bank_rdata[1][1] I=n483
XU849 AOI22S $PINS O=n488 A1=bank_mem_1[14][2] A2=n826 B1=bank_mem_1[15][2]
+ B2=n825
XU850 AOI22S $PINS O=n487 A1=bank_mem_1[12][2] A2=n828 B1=bank_mem_1[13][2]
+ B2=n827
XU851 AOI22S $PINS O=n485 A1=bank_mem_1[10][2] A2=n830 B1=bank_mem_1[11][2]
+ B2=n829
XU852 AOI22S $PINS O=n484 A1=bank_mem_1[8][2] A2=n832 B1=bank_mem_1[9][2]
+ B2=n831
XU853 AN2 $PINS O=n486 I1=n485 I2=n484
XU854 ND3 $PINS O=n489 I1=n488 I2=n487 I3=n486
XU855 AOI22S $PINS O=n493 A1=bank_mem_1[7][2] A2=n839 B1=n489 B2=N34
XU856 AOI22S $PINS O=n492 A1=bank_mem_1[5][2] A2=n841 B1=bank_mem_1[6][2]
+ B2=n840
XU857 AOI22S $PINS O=n491 A1=bank_mem_1[3][2] A2=n843 B1=bank_mem_1[4][2]
+ B2=n842
XU858 AO222 $PINS O=n490 A1=bank_mem_1[1][2] A2=n846 B1=bank_mem_1[0][2]
+ B2=n845 C1=bank_mem_1[2][2] C2=n844
XU859 AN4B1S $PINS O=n494 I1=n493 I2=n492 I3=n491 B1=n490
XU860 INV1S $PINS O=bank_rdata[1][2] I=n494
XU861 AOI22S $PINS O=n499 A1=bank_mem_1[14][3] A2=n826 B1=bank_mem_1[15][3]
+ B2=n825
XU862 AOI22S $PINS O=n498 A1=bank_mem_1[12][3] A2=n828 B1=bank_mem_1[13][3]
+ B2=n827
XU863 AOI22S $PINS O=n496 A1=bank_mem_1[10][3] A2=n830 B1=bank_mem_1[11][3]
+ B2=n829
XU864 AOI22S $PINS O=n495 A1=bank_mem_1[8][3] A2=n832 B1=bank_mem_1[9][3]
+ B2=n831
XU865 AN2 $PINS O=n497 I1=n496 I2=n495
XU866 ND3 $PINS O=n500 I1=n499 I2=n498 I3=n497
XU867 AOI22S $PINS O=n504 A1=bank_mem_1[7][3] A2=n839 B1=n500 B2=N34
XU868 AOI22S $PINS O=n503 A1=bank_mem_1[5][3] A2=n841 B1=bank_mem_1[6][3]
+ B2=n840
XU869 AOI22S $PINS O=n502 A1=bank_mem_1[3][3] A2=n843 B1=bank_mem_1[4][3]
+ B2=n842
XU870 AO222 $PINS O=n501 A1=bank_mem_1[1][3] A2=n846 B1=bank_mem_1[0][3]
+ B2=n845 C1=bank_mem_1[2][3] C2=n844
XU871 AN4B1S $PINS O=n505 I1=n504 I2=n503 I3=n502 B1=n501
XU872 INV1S $PINS O=bank_rdata[1][3] I=FE_PHN1223_n505
XU873 AOI22S $PINS O=n510 A1=bank_mem_1[14][4] A2=n826 B1=bank_mem_1[15][4]
+ B2=n825
XU874 AOI22S $PINS O=n509 A1=bank_mem_1[12][4] A2=n828 B1=bank_mem_1[13][4]
+ B2=n827
XU875 AOI22S $PINS O=n507 A1=bank_mem_1[10][4] A2=n830 B1=bank_mem_1[11][4]
+ B2=n829
XU876 AOI22S $PINS O=n506 A1=bank_mem_1[8][4] A2=n832 B1=bank_mem_1[9][4]
+ B2=n831
XU877 AN2 $PINS O=n508 I1=n507 I2=n506
XU878 ND3 $PINS O=n511 I1=n510 I2=n509 I3=n508
XU879 AOI22S $PINS O=n515 A1=bank_mem_1[7][4] A2=n839 B1=n511 B2=N34
XU880 AOI22S $PINS O=n514 A1=bank_mem_1[5][4] A2=n841 B1=bank_mem_1[6][4]
+ B2=n840
XU881 AOI22S $PINS O=n513 A1=bank_mem_1[3][4] A2=n843 B1=bank_mem_1[4][4]
+ B2=n842
XU882 AO222 $PINS O=n512 A1=bank_mem_1[1][4] A2=n846 B1=bank_mem_1[0][4]
+ B2=n845 C1=bank_mem_1[2][4] C2=n844
XU883 AN4B1S $PINS O=n516 I1=n515 I2=n514 I3=n513 B1=n512
XU884 INV1S $PINS O=bank_rdata[1][4] I=n516
XU885 AOI22S $PINS O=n521 A1=bank_mem_1[14][5] A2=n826 B1=bank_mem_1[15][5]
+ B2=n825
XU886 AOI22S $PINS O=n520 A1=bank_mem_1[12][5] A2=n828 B1=bank_mem_1[13][5]
+ B2=n827
XU887 AOI22S $PINS O=n518 A1=bank_mem_1[10][5] A2=n830 B1=bank_mem_1[11][5]
+ B2=n829
XU888 AOI22S $PINS O=n517 A1=bank_mem_1[8][5] A2=n832 B1=bank_mem_1[9][5]
+ B2=n831
XU889 AN2 $PINS O=n519 I1=n518 I2=n517
XU890 ND3 $PINS O=n522 I1=n521 I2=n520 I3=n519
XU891 AOI22S $PINS O=n526 A1=bank_mem_1[7][5] A2=n839 B1=n522 B2=N34
XU892 AOI22S $PINS O=n525 A1=bank_mem_1[5][5] A2=n841 B1=bank_mem_1[6][5]
+ B2=n840
XU893 AOI22S $PINS O=n524 A1=bank_mem_1[3][5] A2=n843 B1=bank_mem_1[4][5]
+ B2=n842
XU894 AO222 $PINS O=n523 A1=bank_mem_1[1][5] A2=n846 B1=bank_mem_1[0][5]
+ B2=n845 C1=bank_mem_1[2][5] C2=n844
XU895 AN4B1S $PINS O=FE_PHN1179_n527 I1=n526 I2=n525 I3=n524 B1=n523
XU896 INV1S $PINS O=bank_rdata[1][5] I=n527
XU897 AOI22S $PINS O=n532 A1=bank_mem_1[14][6] A2=n826 B1=bank_mem_1[15][6]
+ B2=n825
XU898 AOI22S $PINS O=n531 A1=bank_mem_1[12][6] A2=n828 B1=bank_mem_1[13][6]
+ B2=n827
XU899 AOI22S $PINS O=n529 A1=bank_mem_1[10][6] A2=n830 B1=bank_mem_1[11][6]
+ B2=n829
XU900 AOI22S $PINS O=n528 A1=bank_mem_1[8][6] A2=n832 B1=bank_mem_1[9][6]
+ B2=n831
XU901 AN2 $PINS O=n530 I1=n529 I2=n528
XU902 ND3 $PINS O=n533 I1=n532 I2=n531 I3=n530
XU903 AOI22S $PINS O=n537 A1=bank_mem_1[7][6] A2=n839 B1=n533 B2=N34
XU904 AOI22S $PINS O=n536 A1=bank_mem_1[5][6] A2=n841 B1=bank_mem_1[6][6]
+ B2=n840
XU905 AOI22S $PINS O=n535 A1=bank_mem_1[3][6] A2=n843 B1=bank_mem_1[4][6]
+ B2=n842
XU906 AO222 $PINS O=n534 A1=bank_mem_1[1][6] A2=n846 B1=bank_mem_1[0][6]
+ B2=n845 C1=bank_mem_1[2][6] C2=n844
XU907 AN4B1S $PINS O=n538 I1=n537 I2=n536 I3=n535 B1=n534
XU908 INV1S $PINS O=bank_rdata[1][6] I=n538
XU909 AOI22S $PINS O=n543 A1=bank_mem_1[14][7] A2=n826 B1=bank_mem_1[15][7]
+ B2=n825
XU910 AOI22S $PINS O=n542 A1=bank_mem_1[12][7] A2=n828 B1=bank_mem_1[13][7]
+ B2=n827
XU911 AOI22S $PINS O=n540 A1=bank_mem_1[10][7] A2=n830 B1=bank_mem_1[11][7]
+ B2=n829
XU912 AOI22S $PINS O=n539 A1=bank_mem_1[8][7] A2=n832 B1=bank_mem_1[9][7]
+ B2=n831
XU913 AN2 $PINS O=n541 I1=n540 I2=n539
XU914 ND3 $PINS O=n544 I1=n543 I2=n542 I3=n541
XU915 AOI22S $PINS O=n548 A1=bank_mem_1[7][7] A2=n839 B1=n544 B2=N34
XU916 AOI22S $PINS O=n547 A1=bank_mem_1[5][7] A2=n841 B1=bank_mem_1[6][7]
+ B2=n840
XU917 AOI22S $PINS O=n546 A1=bank_mem_1[3][7] A2=n843 B1=bank_mem_1[4][7]
+ B2=n842
XU918 AO222 $PINS O=n545 A1=bank_mem_1[1][7] A2=n846 B1=bank_mem_1[0][7]
+ B2=n845 C1=bank_mem_1[2][7] C2=n844
XU919 AN4B1S $PINS O=n549 I1=n548 I2=n547 I3=n546 B1=n545
XU920 INV1S $PINS O=bank_rdata[1][7] I=n549
XU921 AOI22S $PINS O=n554 A1=bank_mem_1[14][8] A2=n826 B1=bank_mem_1[15][8]
+ B2=n825
XU922 AOI22S $PINS O=n553 A1=bank_mem_1[12][8] A2=n828 B1=bank_mem_1[13][8]
+ B2=n827
XU923 AOI22S $PINS O=n551 A1=bank_mem_1[10][8] A2=n830 B1=bank_mem_1[11][8]
+ B2=n829
XU924 AOI22S $PINS O=n550 A1=bank_mem_1[8][8] A2=n832 B1=bank_mem_1[9][8]
+ B2=n831
XU925 AN2 $PINS O=n552 I1=n551 I2=n550
XU926 ND3 $PINS O=n555 I1=n554 I2=n553 I3=n552
XU927 AOI22S $PINS O=n559 A1=bank_mem_1[7][8] A2=n839 B1=n555 B2=N34
XU928 AOI22S $PINS O=n558 A1=bank_mem_1[5][8] A2=n841 B1=bank_mem_1[6][8]
+ B2=n840
XU929 AOI22S $PINS O=n557 A1=bank_mem_1[3][8] A2=n843 B1=bank_mem_1[4][8]
+ B2=n842
XU930 AO222 $PINS O=n556 A1=bank_mem_1[1][8] A2=n846 B1=bank_mem_1[0][8]
+ B2=n845 C1=bank_mem_1[2][8] C2=n844
XU931 AN4B1S $PINS O=n560 I1=n559 I2=n558 I3=n557 B1=n556
XU932 INV1S $PINS O=bank_rdata[1][8] I=n560
XU933 AOI22S $PINS O=n565 A1=bank_mem_1[14][9] A2=n826 B1=bank_mem_1[15][9]
+ B2=n825
XU934 AOI22S $PINS O=n564 A1=bank_mem_1[12][9] A2=n828 B1=bank_mem_1[13][9]
+ B2=n827
XU935 AOI22S $PINS O=n562 A1=bank_mem_1[10][9] A2=n830 B1=bank_mem_1[11][9]
+ B2=n829
XU936 AOI22S $PINS O=n561 A1=bank_mem_1[8][9] A2=n832 B1=bank_mem_1[9][9]
+ B2=n831
XU937 AN2 $PINS O=n563 I1=n562 I2=n561
XU938 ND3 $PINS O=n566 I1=n565 I2=n564 I3=n563
XU939 AOI22S $PINS O=n570 A1=bank_mem_1[7][9] A2=n839 B1=n566 B2=N34
XU940 AOI22S $PINS O=n569 A1=bank_mem_1[5][9] A2=n841 B1=bank_mem_1[6][9]
+ B2=n840
XU941 AOI22S $PINS O=n568 A1=bank_mem_1[3][9] A2=n843 B1=bank_mem_1[4][9]
+ B2=n842
XU942 AO222 $PINS O=n567 A1=bank_mem_1[1][9] A2=n846 B1=bank_mem_1[0][9]
+ B2=n845 C1=bank_mem_1[2][9] C2=n844
XU943 AN4B1S $PINS O=n571 I1=n570 I2=n569 I3=n568 B1=n567
XU944 INV1S $PINS O=bank_rdata[1][9] I=n571
XU945 AOI22S $PINS O=n576 A1=bank_mem_1[14][10] A2=n826 B1=bank_mem_1[15][10]
+ B2=n825
XU946 AOI22S $PINS O=n575 A1=bank_mem_1[12][10] A2=n828 B1=bank_mem_1[13][10]
+ B2=n827
XU947 AOI22S $PINS O=n573 A1=bank_mem_1[10][10] A2=n830 B1=bank_mem_1[11][10]
+ B2=n829
XU948 AOI22S $PINS O=n572 A1=bank_mem_1[8][10] A2=n832 B1=bank_mem_1[9][10]
+ B2=n831
XU949 AN2 $PINS O=n574 I1=n573 I2=n572
XU950 ND3 $PINS O=n577 I1=n576 I2=n575 I3=n574
XU951 AOI22S $PINS O=n581 A1=bank_mem_1[7][10] A2=n839 B1=n577 B2=N34
XU952 AOI22S $PINS O=n580 A1=bank_mem_1[5][10] A2=n841 B1=bank_mem_1[6][10]
+ B2=n840
XU953 AOI22S $PINS O=n579 A1=bank_mem_1[3][10] A2=n843 B1=bank_mem_1[4][10]
+ B2=n842
XU954 AO222 $PINS O=n578 A1=bank_mem_1[1][10] A2=n846 B1=bank_mem_1[0][10]
+ B2=n845 C1=bank_mem_1[2][10] C2=n844
XU955 AN4B1S $PINS O=n582 I1=n581 I2=n580 I3=n579 B1=n578
XU956 INV1S $PINS O=bank_rdata[1][10] I=n582
XU957 AOI22S $PINS O=n587 A1=bank_mem_1[14][11] A2=n826 B1=bank_mem_1[15][11]
+ B2=n825
XU958 AOI22S $PINS O=n586 A1=bank_mem_1[12][11] A2=n828 B1=bank_mem_1[13][11]
+ B2=n827
XU959 AOI22S $PINS O=n584 A1=bank_mem_1[10][11] A2=n830 B1=bank_mem_1[11][11]
+ B2=n829
XU960 AOI22S $PINS O=n583 A1=bank_mem_1[8][11] A2=n832 B1=bank_mem_1[9][11]
+ B2=n831
XU961 AN2 $PINS O=n585 I1=n584 I2=n583
XU962 ND3 $PINS O=n588 I1=n587 I2=n586 I3=n585
XU963 AOI22S $PINS O=n592 A1=bank_mem_1[7][11] A2=n839 B1=n588 B2=N34
XU964 AOI22S $PINS O=n591 A1=bank_mem_1[5][11] A2=n841 B1=bank_mem_1[6][11]
+ B2=n840
XU965 AOI22S $PINS O=n590 A1=bank_mem_1[3][11] A2=n843 B1=bank_mem_1[4][11]
+ B2=n842
XU966 AO222 $PINS O=n589 A1=bank_mem_1[1][11] A2=n846 B1=bank_mem_1[0][11]
+ B2=n845 C1=bank_mem_1[2][11] C2=n844
XU967 AN4B1S $PINS O=n593 I1=n592 I2=n591 I3=n590 B1=n589
XU968 INV1S $PINS O=bank_rdata[1][11] I=n593
XU969 AOI22S $PINS O=n598 A1=bank_mem_1[14][12] A2=n826 B1=bank_mem_1[15][12]
+ B2=n825
XU970 AOI22S $PINS O=n597 A1=bank_mem_1[12][12] A2=n828 B1=bank_mem_1[13][12]
+ B2=n827
XU971 AOI22S $PINS O=n595 A1=bank_mem_1[10][12] A2=n830 B1=bank_mem_1[11][12]
+ B2=n829
XU972 AOI22S $PINS O=n594 A1=bank_mem_1[8][12] A2=n832 B1=bank_mem_1[9][12]
+ B2=n831
XU973 AN2 $PINS O=n596 I1=n595 I2=n594
XU974 ND3 $PINS O=n599 I1=n598 I2=n597 I3=n596
XU975 AOI22S $PINS O=n603 A1=bank_mem_1[7][12] A2=n839 B1=n599 B2=N34
XU976 AOI22S $PINS O=n602 A1=bank_mem_1[5][12] A2=n841 B1=bank_mem_1[6][12]
+ B2=n840
XU977 AOI22S $PINS O=n601 A1=bank_mem_1[3][12] A2=n843 B1=bank_mem_1[4][12]
+ B2=n842
XU978 AO222 $PINS O=n600 A1=bank_mem_1[1][12] A2=n846 B1=bank_mem_1[0][12]
+ B2=n845 C1=bank_mem_1[2][12] C2=n844
XU979 AN4B1S $PINS O=n604 I1=n603 I2=n602 I3=n601 B1=n600
XU980 INV1S $PINS O=bank_rdata[1][12] I=n604
XU981 AOI22S $PINS O=n609 A1=bank_mem_1[14][13] A2=n826 B1=bank_mem_1[15][13]
+ B2=n825
XU982 AOI22S $PINS O=n608 A1=bank_mem_1[12][13] A2=n828 B1=bank_mem_1[13][13]
+ B2=n827
XU983 AOI22S $PINS O=n606 A1=bank_mem_1[10][13] A2=n830 B1=bank_mem_1[11][13]
+ B2=n829
XU984 AOI22S $PINS O=n605 A1=bank_mem_1[8][13] A2=n832 B1=bank_mem_1[9][13]
+ B2=n831
XU985 AN2 $PINS O=n607 I1=n606 I2=n605
XU986 ND3 $PINS O=n610 I1=n609 I2=n608 I3=n607
XU987 AOI22S $PINS O=n614 A1=bank_mem_1[7][13] A2=n839 B1=n610 B2=N34
XU988 AOI22S $PINS O=n613 A1=bank_mem_1[5][13] A2=n841 B1=bank_mem_1[6][13]
+ B2=n840
XU989 AOI22S $PINS O=n612 A1=bank_mem_1[3][13] A2=n843 B1=bank_mem_1[4][13]
+ B2=n842
XU990 AO222 $PINS O=n611 A1=bank_mem_1[1][13] A2=n846 B1=bank_mem_1[0][13]
+ B2=n845 C1=bank_mem_1[2][13] C2=n844
XU991 AN4B1S $PINS O=n615 I1=n614 I2=n613 I3=n612 B1=n611
XU992 INV1S $PINS O=bank_rdata[1][13] I=n615
XU993 AOI22S $PINS O=n620 A1=bank_mem_1[14][14] A2=n826 B1=bank_mem_1[15][14]
+ B2=n825
XU994 AOI22S $PINS O=n619 A1=bank_mem_1[12][14] A2=n828 B1=bank_mem_1[13][14]
+ B2=n827
XU995 AOI22S $PINS O=n617 A1=bank_mem_1[10][14] A2=n830 B1=bank_mem_1[11][14]
+ B2=n829
XU996 AOI22S $PINS O=n616 A1=bank_mem_1[8][14] A2=n832 B1=bank_mem_1[9][14]
+ B2=n831
XU997 AN2 $PINS O=n618 I1=n617 I2=n616
XU998 ND3 $PINS O=n621 I1=n620 I2=n619 I3=n618
XU999 AOI22S $PINS O=n625 A1=bank_mem_1[7][14] A2=n839 B1=n621 B2=N34
XU1000 AOI22S $PINS O=n624 A1=bank_mem_1[5][14] A2=n841 B1=bank_mem_1[6][14]
+ B2=n840
XU1001 AOI22S $PINS O=n623 A1=bank_mem_1[3][14] A2=n843 B1=bank_mem_1[4][14]
+ B2=n842
XU1002 AO222 $PINS O=n622 A1=bank_mem_1[1][14] A2=n846 B1=bank_mem_1[0][14]
+ B2=n845 C1=bank_mem_1[2][14] C2=n844
XU1003 AN4B1S $PINS O=n626 I1=n625 I2=n624 I3=n623 B1=n622
XU1004 INV1S $PINS O=bank_rdata[1][14] I=n626
XU1005 AOI22S $PINS O=n631 A1=bank_mem_1[14][15] A2=n826 B1=bank_mem_1[15][15]
+ B2=n825
XU1006 AOI22S $PINS O=n630 A1=bank_mem_1[12][15] A2=n828 B1=bank_mem_1[13][15]
+ B2=n827
XU1007 AOI22S $PINS O=n628 A1=bank_mem_1[10][15] A2=n830 B1=bank_mem_1[11][15]
+ B2=n829
XU1008 AOI22S $PINS O=n627 A1=bank_mem_1[8][15] A2=n832 B1=bank_mem_1[9][15]
+ B2=n831
XU1009 AN2 $PINS O=n629 I1=n628 I2=n627
XU1010 ND3 $PINS O=n632 I1=n631 I2=n630 I3=n629
XU1011 AOI22S $PINS O=n636 A1=bank_mem_1[7][15] A2=n839 B1=n632 B2=N34
XU1012 AOI22S $PINS O=n635 A1=bank_mem_1[5][15] A2=n841 B1=bank_mem_1[6][15]
+ B2=n840
XU1013 AOI22S $PINS O=n634 A1=bank_mem_1[3][15] A2=n843 B1=bank_mem_1[4][15]
+ B2=n842
XU1014 AO222 $PINS O=n633 A1=bank_mem_1[1][15] A2=n846 B1=bank_mem_1[0][15]
+ B2=n845 C1=bank_mem_1[2][15] C2=n844
XU1015 AN4B1S $PINS O=n637 I1=n636 I2=n635 I3=n634 B1=n633
XU1016 INV1S $PINS O=bank_rdata[1][15] I=n637
XU1017 AOI22S $PINS O=n642 A1=bank_mem_1[14][16] A2=n826 B1=bank_mem_1[15][16]
+ B2=n825
XU1018 AOI22S $PINS O=n641 A1=bank_mem_1[12][16] A2=n828 B1=bank_mem_1[13][16]
+ B2=n827
XU1019 AOI22S $PINS O=n639 A1=bank_mem_1[10][16] A2=n830 B1=bank_mem_1[11][16]
+ B2=n829
XU1020 AOI22S $PINS O=n638 A1=bank_mem_1[8][16] A2=n832 B1=bank_mem_1[9][16]
+ B2=n831
XU1021 AN2 $PINS O=n640 I1=n639 I2=n638
XU1022 ND3 $PINS O=n643 I1=n642 I2=n641 I3=n640
XU1023 AOI22S $PINS O=n647 A1=bank_mem_1[7][16] A2=n839 B1=n643 B2=N34
XU1024 AOI22S $PINS O=n646 A1=bank_mem_1[5][16] A2=n841 B1=bank_mem_1[6][16]
+ B2=n840
XU1025 AOI22S $PINS O=n645 A1=bank_mem_1[3][16] A2=n843 B1=bank_mem_1[4][16]
+ B2=n842
XU1026 AO222 $PINS O=n644 A1=bank_mem_1[1][16] A2=n846 B1=bank_mem_1[0][16]
+ B2=n845 C1=bank_mem_1[2][16] C2=n844
XU1027 AN4B1S $PINS O=n648 I1=n647 I2=n646 I3=n645 B1=n644
XU1028 INV1S $PINS O=bank_rdata[1][16] I=n648
XU1029 AOI22S $PINS O=n653 A1=bank_mem_1[14][17] A2=n826 B1=bank_mem_1[15][17]
+ B2=n825
XU1030 AOI22S $PINS O=n652 A1=bank_mem_1[12][17] A2=n828 B1=bank_mem_1[13][17]
+ B2=n827
XU1031 AOI22S $PINS O=n650 A1=bank_mem_1[10][17] A2=n830 B1=bank_mem_1[11][17]
+ B2=n829
XU1032 AOI22S $PINS O=n649 A1=bank_mem_1[8][17] A2=n832 B1=bank_mem_1[9][17]
+ B2=n831
XU1033 AN2 $PINS O=n651 I1=n650 I2=n649
XU1034 ND3 $PINS O=n654 I1=n653 I2=n652 I3=n651
XU1035 AOI22S $PINS O=n658 A1=bank_mem_1[7][17] A2=n839 B1=n654 B2=N34
XU1036 AOI22S $PINS O=n657 A1=bank_mem_1[5][17] A2=n841
+ B1=FE_PHN1221_bank_mem_1_6_17 B2=n840
XU1037 AOI22S $PINS O=n656 A1=bank_mem_1[3][17] A2=n843 B1=bank_mem_1[4][17]
+ B2=n842
XU1038 AO222 $PINS O=n655 A1=bank_mem_1[1][17] A2=n846 B1=bank_mem_1[0][17]
+ B2=n845 C1=bank_mem_1[2][17] C2=n844
XU1039 AN4B1S $PINS O=n659 I1=n658 I2=n657 I3=n656 B1=n655
XU1040 INV1S $PINS O=bank_rdata[1][17] I=n659
XU1041 AOI22S $PINS O=n664 A1=bank_mem_1[14][18] A2=n826 B1=bank_mem_1[15][18]
+ B2=n825
XU1042 AOI22S $PINS O=n663 A1=bank_mem_1[12][18] A2=n828 B1=bank_mem_1[13][18]
+ B2=n827
XU1043 AOI22S $PINS O=n661 A1=bank_mem_1[10][18] A2=n830 B1=bank_mem_1[11][18]
+ B2=n829
XU1044 AOI22S $PINS O=n660 A1=bank_mem_1[8][18] A2=n832 B1=bank_mem_1[9][18]
+ B2=n831
XU1045 AN2 $PINS O=n662 I1=n661 I2=n660
XU1046 ND3 $PINS O=n665 I1=n664 I2=n663 I3=n662
XU1047 AOI22S $PINS O=n669 A1=bank_mem_1[7][18] A2=n839 B1=n665 B2=N34
XU1048 AOI22S $PINS O=n668 A1=bank_mem_1[5][18] A2=n841
+ B1=FE_PHN1227_bank_mem_1_6_18 B2=n840
XU1049 AOI22S $PINS O=n667 A1=bank_mem_1[3][18] A2=n843 B1=bank_mem_1[4][18]
+ B2=n842
XU1050 AO222 $PINS O=n666 A1=bank_mem_1[1][18] A2=n846 B1=bank_mem_1[0][18]
+ B2=n845 C1=bank_mem_1[2][18] C2=n844
XU1051 AN4B1S $PINS O=n670 I1=n669 I2=n668 I3=n667 B1=n666
XU1052 INV1S $PINS O=bank_rdata[1][18] I=n670
XU1053 AOI22S $PINS O=n675 A1=bank_mem_1[14][19] A2=n826 B1=bank_mem_1[15][19]
+ B2=n825
XU1054 AOI22S $PINS O=n674 A1=bank_mem_1[12][19] A2=n828 B1=bank_mem_1[13][19]
+ B2=n827
XU1055 AOI22S $PINS O=n672 A1=bank_mem_1[10][19] A2=n830 B1=bank_mem_1[11][19]
+ B2=n829
XU1056 AOI22S $PINS O=n671 A1=bank_mem_1[8][19] A2=n832 B1=bank_mem_1[9][19]
+ B2=n831
XU1057 AN2 $PINS O=n673 I1=n672 I2=n671
XU1058 ND3 $PINS O=n676 I1=n675 I2=n674 I3=n673
XU1059 AOI22S $PINS O=n680 A1=bank_mem_1[7][19] A2=n839 B1=n676 B2=N34
XU1060 AOI22S $PINS O=n679 A1=bank_mem_1[5][19] A2=n841
+ B1=FE_PHN1244_bank_mem_1_6_19 B2=n840
XU1061 AOI22S $PINS O=n678 A1=bank_mem_1[3][19] A2=n843 B1=bank_mem_1[4][19]
+ B2=n842
XU1062 AO222 $PINS O=n677 A1=bank_mem_1[1][19] A2=n846 B1=bank_mem_1[0][19]
+ B2=n845 C1=bank_mem_1[2][19] C2=n844
XU1063 AN4B1S $PINS O=n681 I1=n680 I2=n679 I3=n678 B1=n677
XU1064 INV1S $PINS O=bank_rdata[1][19] I=n681
XU1065 AOI22S $PINS O=n686 A1=bank_mem_1[14][20] A2=n826 B1=bank_mem_1[15][20]
+ B2=n825
XU1066 AOI22S $PINS O=n685 A1=bank_mem_1[12][20] A2=n828 B1=bank_mem_1[13][20]
+ B2=n827
XU1067 AOI22S $PINS O=n683 A1=bank_mem_1[10][20] A2=n830 B1=bank_mem_1[11][20]
+ B2=n829
XU1068 AOI22S $PINS O=n682 A1=bank_mem_1[8][20] A2=n832 B1=bank_mem_1[9][20]
+ B2=n831
XU1069 AN2 $PINS O=n684 I1=n683 I2=n682
XU1070 ND3 $PINS O=n687 I1=n686 I2=n685 I3=n684
XU1071 AOI22S $PINS O=n691 A1=bank_mem_1[7][20] A2=n839 B1=n687 B2=N34
XU1072 AOI22S $PINS O=n690 A1=bank_mem_1[5][20] A2=n841 B1=bank_mem_1[6][20]
+ B2=n840
XU1073 AOI22S $PINS O=n689 A1=bank_mem_1[3][20] A2=n843 B1=bank_mem_1[4][20]
+ B2=n842
XU1074 AO222 $PINS O=n688 A1=bank_mem_1[1][20] A2=n846 B1=bank_mem_1[0][20]
+ B2=n845 C1=bank_mem_1[2][20] C2=n844
XU1075 AN4B1S $PINS O=n692 I1=n691 I2=n690 I3=n689 B1=n688
XU1076 INV1S $PINS O=bank_rdata[1][20] I=FE_PHN1210_n692
XU1077 AOI22S $PINS O=n697 A1=bank_mem_1[14][21] A2=n826 B1=bank_mem_1[15][21]
+ B2=n825
XU1078 AOI22S $PINS O=n696 A1=bank_mem_1[12][21] A2=n828 B1=bank_mem_1[13][21]
+ B2=n827
XU1079 AOI22S $PINS O=n694 A1=bank_mem_1[10][21] A2=n830 B1=bank_mem_1[11][21]
+ B2=n829
XU1080 AOI22S $PINS O=n693 A1=bank_mem_1[8][21] A2=n832 B1=bank_mem_1[9][21]
+ B2=n831
XU1081 AN2 $PINS O=n695 I1=n694 I2=n693
XU1082 ND3 $PINS O=n698 I1=n697 I2=n696 I3=n695
XU1083 AOI22S $PINS O=n702 A1=bank_mem_1[7][21] A2=n839 B1=n698 B2=N34
XU1084 AOI22S $PINS O=n701 A1=bank_mem_1[5][21] A2=n841 B1=bank_mem_1[6][21]
+ B2=n840
XU1085 AOI22S $PINS O=n700 A1=bank_mem_1[3][21] A2=n843 B1=bank_mem_1[4][21]
+ B2=n842
XU1086 AO222 $PINS O=n699 A1=bank_mem_1[1][21] A2=n846 B1=bank_mem_1[0][21]
+ B2=n845 C1=bank_mem_1[2][21] C2=n844
XU1087 AN4B1S $PINS O=FE_PHN1128_n703 I1=n702 I2=n701 I3=n700 B1=n699
XU1088 INV1S $PINS O=bank_rdata[1][21] I=n703
XU1089 AOI22S $PINS O=n708 A1=bank_mem_1[14][22] A2=n826 B1=bank_mem_1[15][22]
+ B2=n825
XU1090 AOI22S $PINS O=n707 A1=bank_mem_1[12][22] A2=n828 B1=bank_mem_1[13][22]
+ B2=n827
XU1091 AOI22S $PINS O=n705 A1=bank_mem_1[10][22] A2=n830 B1=bank_mem_1[11][22]
+ B2=n829
XU1092 AOI22S $PINS O=n704 A1=bank_mem_1[8][22] A2=n832 B1=bank_mem_1[9][22]
+ B2=n831
XU1093 AN2 $PINS O=n706 I1=n705 I2=n704
XU1094 ND3 $PINS O=n709 I1=n708 I2=n707 I3=n706
XU1095 AOI22S $PINS O=n713 A1=bank_mem_1[7][22] A2=n839 B1=n709 B2=N34
XU1096 AOI22S $PINS O=n712 A1=bank_mem_1[5][22] A2=n841 B1=bank_mem_1[6][22]
+ B2=n840
XU1097 AOI22S $PINS O=n711 A1=bank_mem_1[3][22] A2=n843 B1=bank_mem_1[4][22]
+ B2=n842
XU1098 AO222 $PINS O=n710 A1=bank_mem_1[1][22] A2=n846 B1=bank_mem_1[0][22]
+ B2=n845 C1=bank_mem_1[2][22] C2=n844
XU1099 AN4B1S $PINS O=FE_PHN1151_n714 I1=n713 I2=n712 I3=n711 B1=n710
XU1100 INV1S $PINS O=bank_rdata[1][22] I=n714
XU1101 AOI22S $PINS O=n719 A1=bank_mem_1[14][23] A2=n826 B1=bank_mem_1[15][23]
+ B2=n825
XU1102 AOI22S $PINS O=n718 A1=bank_mem_1[12][23] A2=n828 B1=bank_mem_1[13][23]
+ B2=n827
XU1103 AOI22S $PINS O=n716 A1=bank_mem_1[10][23] A2=n830 B1=bank_mem_1[11][23]
+ B2=n829
XU1104 AOI22S $PINS O=n715 A1=bank_mem_1[8][23] A2=n832 B1=bank_mem_1[9][23]
+ B2=n831
XU1105 AN2 $PINS O=n717 I1=n716 I2=n715
XU1106 ND3 $PINS O=n720 I1=n719 I2=n718 I3=n717
XU1107 AOI22S $PINS O=n724 A1=bank_mem_1[7][23] A2=n839 B1=n720 B2=N34
XU1108 AOI22S $PINS O=n723 A1=bank_mem_1[5][23] A2=n841 B1=bank_mem_1[6][23]
+ B2=n840
XU1109 AOI22S $PINS O=n722 A1=bank_mem_1[3][23] A2=n843 B1=bank_mem_1[4][23]
+ B2=n842
XU1110 AO222 $PINS O=n721 A1=bank_mem_1[1][23] A2=n846 B1=bank_mem_1[0][23]
+ B2=n845 C1=bank_mem_1[2][23] C2=n844
XU1111 AN4B1S $PINS O=n725 I1=n724 I2=n723 I3=n722 B1=n721
XU1112 INV1S $PINS O=bank_rdata[1][23] I=n725
XU1113 AOI22S $PINS O=n730 A1=bank_mem_1[14][24] A2=n826 B1=bank_mem_1[15][24]
+ B2=n825
XU1114 AOI22S $PINS O=n729 A1=bank_mem_1[12][24] A2=n828 B1=bank_mem_1[13][24]
+ B2=n827
XU1115 AOI22S $PINS O=n727 A1=bank_mem_1[10][24] A2=n830 B1=bank_mem_1[11][24]
+ B2=n829
XU1116 AOI22S $PINS O=n726 A1=bank_mem_1[8][24] A2=n832 B1=bank_mem_1[9][24]
+ B2=n831
XU1117 AN2 $PINS O=n728 I1=n727 I2=n726
XU1118 ND3 $PINS O=n731 I1=n730 I2=n729 I3=n728
XU1119 AOI22S $PINS O=n735 A1=bank_mem_1[7][24] A2=n839 B1=n731 B2=N34
XU1120 AOI22S $PINS O=n734 A1=bank_mem_1[5][24] A2=n841 B1=bank_mem_1[6][24]
+ B2=n840
XU1121 AOI22S $PINS O=n733 A1=bank_mem_1[3][24] A2=n843 B1=bank_mem_1[4][24]
+ B2=n842
XU1122 AO222 $PINS O=n732 A1=bank_mem_1[1][24] A2=n846 B1=bank_mem_1[0][24]
+ B2=n845 C1=bank_mem_1[2][24] C2=n844
XU1123 AN4B1S $PINS O=n736 I1=n735 I2=n734 I3=n733 B1=n732
XU1124 INV1S $PINS O=bank_rdata[1][24] I=n736
XU1125 AOI22S $PINS O=n741 A1=bank_mem_1[14][25] A2=n826 B1=bank_mem_1[15][25]
+ B2=n825
XU1126 AOI22S $PINS O=n740 A1=bank_mem_1[12][25] A2=n828 B1=bank_mem_1[13][25]
+ B2=n827
XU1127 AOI22S $PINS O=n738 A1=bank_mem_1[10][25] A2=n830 B1=bank_mem_1[11][25]
+ B2=n829
XU1128 AOI22S $PINS O=n737 A1=bank_mem_1[8][25] A2=n832 B1=bank_mem_1[9][25]
+ B2=n831
XU1129 AN2 $PINS O=n739 I1=n738 I2=n737
XU1130 ND3 $PINS O=n742 I1=n741 I2=n740 I3=n739
XU1131 AOI22S $PINS O=n746 A1=bank_mem_1[7][25] A2=n839 B1=n742 B2=N34
XU1132 AOI22S $PINS O=n745 A1=bank_mem_1[5][25] A2=n841 B1=bank_mem_1[6][25]
+ B2=n840
XU1133 AOI22S $PINS O=n744 A1=bank_mem_1[3][25] A2=n843 B1=bank_mem_1[4][25]
+ B2=n842
XU1134 AO222 $PINS O=n743 A1=bank_mem_1[1][25] A2=n846 B1=bank_mem_1[0][25]
+ B2=n845 C1=bank_mem_1[2][25] C2=n844
XU1135 AN4B1S $PINS O=n747 I1=n746 I2=n745 I3=n744 B1=n743
XU1136 INV1S $PINS O=bank_rdata[1][25] I=n747
XU1137 AOI22S $PINS O=n752 A1=bank_mem_1[14][26] A2=n826 B1=bank_mem_1[15][26]
+ B2=n825
XU1138 AOI22S $PINS O=n751 A1=bank_mem_1[12][26] A2=n828 B1=bank_mem_1[13][26]
+ B2=n827
XU1139 AOI22S $PINS O=n749 A1=bank_mem_1[10][26] A2=n830 B1=bank_mem_1[11][26]
+ B2=n829
XU1140 AOI22S $PINS O=n748 A1=bank_mem_1[8][26] A2=n832 B1=bank_mem_1[9][26]
+ B2=n831
XU1141 AN2 $PINS O=n750 I1=n749 I2=n748
XU1142 ND3 $PINS O=n753 I1=n752 I2=n751 I3=n750
XU1143 AOI22S $PINS O=n757 A1=bank_mem_1[7][26] A2=n839 B1=n753 B2=N34
XU1144 AOI22S $PINS O=n756 A1=bank_mem_1[5][26] A2=n841 B1=bank_mem_1[6][26]
+ B2=n840
XU1145 AOI22S $PINS O=n755 A1=bank_mem_1[3][26] A2=n843 B1=bank_mem_1[4][26]
+ B2=n842
XU1146 AO222 $PINS O=n754 A1=bank_mem_1[1][26] A2=n846 B1=bank_mem_1[0][26]
+ B2=n845 C1=bank_mem_1[2][26] C2=n844
XU1147 AN4B1S $PINS O=FE_PHN1079_n758 I1=n757 I2=n756 I3=n755 B1=n754
XU1148 INV1S $PINS O=bank_rdata[1][26] I=n758
XU1149 AOI22S $PINS O=n763 A1=bank_mem_1[14][27] A2=n826 B1=bank_mem_1[15][27]
+ B2=n825
XU1150 AOI22S $PINS O=n762 A1=bank_mem_1[12][27] A2=n828 B1=bank_mem_1[13][27]
+ B2=n827
XU1151 AOI22S $PINS O=n760 A1=bank_mem_1[10][27] A2=n830 B1=bank_mem_1[11][27]
+ B2=n829
XU1152 AOI22S $PINS O=n759 A1=bank_mem_1[8][27] A2=n832 B1=bank_mem_1[9][27]
+ B2=n831
XU1153 AN2 $PINS O=n761 I1=n760 I2=n759
XU1154 ND3 $PINS O=n764 I1=n763 I2=n762 I3=n761
XU1155 AOI22S $PINS O=n768 A1=bank_mem_1[7][27] A2=n839 B1=n764 B2=N34
XU1156 AOI22S $PINS O=n767 A1=bank_mem_1[5][27] A2=n841 B1=bank_mem_1[6][27]
+ B2=n840
XU1157 AOI22S $PINS O=n766 A1=bank_mem_1[3][27] A2=n843 B1=bank_mem_1[4][27]
+ B2=n842
XU1158 AO222 $PINS O=n765 A1=bank_mem_1[1][27] A2=n846 B1=bank_mem_1[0][27]
+ B2=n845 C1=bank_mem_1[2][27] C2=n844
XU1159 AN4B1S $PINS O=n769 I1=n768 I2=n767 I3=n766 B1=n765
XU1160 INV1S $PINS O=bank_rdata[1][27] I=n769
XU1161 AOI22S $PINS O=n774 A1=bank_mem_1[14][28] A2=n826 B1=bank_mem_1[15][28]
+ B2=n825
XU1162 AOI22S $PINS O=n773 A1=bank_mem_1[12][28] A2=n828 B1=bank_mem_1[13][28]
+ B2=n827
XU1163 AOI22S $PINS O=n771 A1=bank_mem_1[10][28] A2=n830 B1=bank_mem_1[11][28]
+ B2=n829
XU1164 AOI22S $PINS O=n770 A1=bank_mem_1[8][28] A2=n832 B1=bank_mem_1[9][28]
+ B2=n831
XU1165 AN2 $PINS O=n772 I1=n771 I2=n770
XU1166 ND3 $PINS O=n775 I1=n774 I2=n773 I3=n772
XU1167 AOI22S $PINS O=n779 A1=bank_mem_1[7][28] A2=n839 B1=n775 B2=N34
XU1168 AOI22S $PINS O=n778 A1=bank_mem_1[5][28] A2=n841 B1=bank_mem_1[6][28]
+ B2=n840
XU1169 AOI22S $PINS O=n777 A1=bank_mem_1[3][28] A2=n843 B1=bank_mem_1[4][28]
+ B2=n842
XU1170 AO222 $PINS O=n776 A1=bank_mem_1[1][28] A2=n846 B1=bank_mem_1[0][28]
+ B2=n845 C1=bank_mem_1[2][28] C2=n844
XU1171 AN4B1S $PINS O=n780 I1=n779 I2=n778 I3=n777 B1=n776
XU1172 INV1S $PINS O=bank_rdata[1][28] I=n780
XU1173 AOI22S $PINS O=n785 A1=bank_mem_1[14][29] A2=n826 B1=bank_mem_1[15][29]
+ B2=n825
XU1174 AOI22S $PINS O=n784 A1=bank_mem_1[12][29] A2=n828 B1=bank_mem_1[13][29]
+ B2=n827
XU1175 AOI22S $PINS O=n782 A1=bank_mem_1[10][29] A2=n830 B1=bank_mem_1[11][29]
+ B2=n829
XU1176 AOI22S $PINS O=n781 A1=bank_mem_1[8][29] A2=n832 B1=bank_mem_1[9][29]
+ B2=n831
XU1177 AN2 $PINS O=n783 I1=n782 I2=n781
XU1178 ND3 $PINS O=n786 I1=n785 I2=n784 I3=n783
XU1179 AOI22S $PINS O=n790 A1=bank_mem_1[7][29] A2=n839 B1=n786 B2=N34
XU1180 AOI22S $PINS O=n789 A1=bank_mem_1[5][29] A2=n841 B1=bank_mem_1[6][29]
+ B2=n840
XU1181 AOI22S $PINS O=n788 A1=bank_mem_1[3][29] A2=n843 B1=bank_mem_1[4][29]
+ B2=n842
XU1182 AO222 $PINS O=n787 A1=bank_mem_1[1][29] A2=n846 B1=bank_mem_1[0][29]
+ B2=n845 C1=bank_mem_1[2][29] C2=n844
XU1183 AN4B1S $PINS O=n791 I1=n790 I2=n789 I3=n788 B1=n787
XU1184 INV1S $PINS O=bank_rdata[1][29] I=FE_PHN1204_n791
XU1185 AOI22S $PINS O=n796 A1=bank_mem_1[14][30] A2=n826 B1=bank_mem_1[15][30]
+ B2=n825
XU1186 AOI22S $PINS O=n795 A1=bank_mem_1[12][30] A2=n828 B1=bank_mem_1[13][30]
+ B2=n827
XU1187 AOI22S $PINS O=n793 A1=bank_mem_1[10][30] A2=n830 B1=bank_mem_1[11][30]
+ B2=n829
XU1188 AOI22S $PINS O=n792 A1=bank_mem_1[8][30] A2=n832 B1=bank_mem_1[9][30]
+ B2=n831
XU1189 AN2 $PINS O=n794 I1=n793 I2=n792
XU1190 ND3 $PINS O=n797 I1=n796 I2=n795 I3=n794
XU1191 AOI22S $PINS O=n801 A1=bank_mem_1[7][30] A2=n839 B1=n797 B2=N34
XU1192 AOI22S $PINS O=n800 A1=bank_mem_1[5][30] A2=n841 B1=bank_mem_1[6][30]
+ B2=n840
XU1193 AOI22S $PINS O=n799 A1=bank_mem_1[3][30] A2=n843 B1=bank_mem_1[4][30]
+ B2=n842
XU1194 AO222 $PINS O=n798 A1=bank_mem_1[1][30] A2=n846 B1=bank_mem_1[0][30]
+ B2=n845 C1=bank_mem_1[2][30] C2=n844
XU1195 AN4B1S $PINS O=n802 I1=n801 I2=n800 I3=n799 B1=n798
XU1196 INV1S $PINS O=bank_rdata[1][30] I=n802
XU1197 AOI22S $PINS O=n807 A1=bank_mem_1[14][31] A2=n826 B1=bank_mem_1[15][31]
+ B2=n825
XU1198 AOI22S $PINS O=n806 A1=bank_mem_1[12][31] A2=n828 B1=bank_mem_1[13][31]
+ B2=n827
XU1199 AOI22S $PINS O=n804 A1=bank_mem_1[10][31] A2=n830 B1=bank_mem_1[11][31]
+ B2=n829
XU1200 AOI22S $PINS O=n803 A1=bank_mem_1[8][31] A2=n832 B1=bank_mem_1[9][31]
+ B2=n831
XU1201 AN2 $PINS O=n805 I1=n804 I2=n803
XU1202 ND3 $PINS O=n808 I1=n807 I2=n806 I3=n805
XU1203 AOI22S $PINS O=n812 A1=bank_mem_1[7][31] A2=n839 B1=n808 B2=N34
XU1204 AOI22S $PINS O=n811 A1=bank_mem_1[5][31] A2=n841 B1=bank_mem_1[6][31]
+ B2=n840
XU1205 AOI22S $PINS O=n810 A1=bank_mem_1[3][31] A2=n843 B1=bank_mem_1[4][31]
+ B2=n842
XU1206 AO222 $PINS O=n809 A1=bank_mem_1[1][31] A2=n846 B1=bank_mem_1[0][31]
+ B2=n845 C1=bank_mem_1[2][31] C2=n844
XU1207 AN4B1S $PINS O=n813 I1=n812 I2=n811 I3=n810 B1=n809
XU1208 INV1S $PINS O=bank_rdata[1][31] I=n813
XU1209 AOI22S $PINS O=n818 A1=bank_mem_1[14][32] A2=n826 B1=bank_mem_1[15][32]
+ B2=n825
XU1210 AOI22S $PINS O=n817 A1=bank_mem_1[12][32] A2=n828 B1=bank_mem_1[13][32]
+ B2=n827
XU1211 AOI22S $PINS O=n815 A1=bank_mem_1[10][32] A2=n830 B1=bank_mem_1[11][32]
+ B2=n829
XU1212 AOI22S $PINS O=n814 A1=bank_mem_1[8][32] A2=n832 B1=bank_mem_1[9][32]
+ B2=n831
XU1213 AN2 $PINS O=n816 I1=n815 I2=n814
XU1214 ND3 $PINS O=n819 I1=n818 I2=n817 I3=n816
XU1215 AOI22S $PINS O=n823 A1=bank_mem_1[7][32] A2=n839 B1=n819 B2=N34
XU1216 AOI22S $PINS O=n822 A1=bank_mem_1[5][32] A2=n841 B1=bank_mem_1[6][32]
+ B2=n840
XU1217 AOI22S $PINS O=n821 A1=bank_mem_1[3][32] A2=n843 B1=bank_mem_1[4][32]
+ B2=n842
XU1218 AO222 $PINS O=n820 A1=bank_mem_1[1][32] A2=n846 B1=bank_mem_1[0][32]
+ B2=n845 C1=bank_mem_1[2][32] C2=n844
XU1219 AN4B1S $PINS O=n824 I1=n823 I2=n822 I3=n821 B1=n820
XU1220 INV1S $PINS O=bank_rdata[1][32] I=n824
XU1221 AOI22S $PINS O=n837 A1=bank_mem_1[14][33] A2=n826 B1=bank_mem_1[15][33]
+ B2=n825
XU1222 AOI22S $PINS O=n836 A1=bank_mem_1[12][33] A2=n828 B1=bank_mem_1[13][33]
+ B2=n827
XU1223 AOI22S $PINS O=n834 A1=bank_mem_1[10][33] A2=n830 B1=bank_mem_1[11][33]
+ B2=n829
XU1224 AOI22S $PINS O=n833 A1=bank_mem_1[8][33] A2=n832 B1=bank_mem_1[9][33]
+ B2=n831
XU1225 AN2 $PINS O=n835 I1=n834 I2=n833
XU1226 ND3 $PINS O=n838 I1=n837 I2=n836 I3=n835
XU1227 AOI22S $PINS O=n850 A1=bank_mem_1[7][33] A2=n839 B1=N34 B2=n838
XU1228 AOI22S $PINS O=n849 A1=bank_mem_1[5][33] A2=n841
+ B1=FE_PHN1224_bank_mem_1_6_33 B2=n840
XU1229 AOI22S $PINS O=n848 A1=bank_mem_1[3][33] A2=n843 B1=bank_mem_1[4][33]
+ B2=n842
XU1230 AO222 $PINS O=n847 A1=bank_mem_1[1][33] A2=n846 B1=bank_mem_1[0][33]
+ B2=n845 C1=bank_mem_1[2][33] C2=n844
XU1231 AN4B1S $PINS O=n851 I1=n850 I2=n849 I3=n848 B1=n847
XU1232 INV1S $PINS O=bank_rdata[1][33] I=n851
Xclk_gate_bank_mem_1_reg[0] SNPS_CLOCK_GATE_HIGH_RegFileDual_DATA_WIDTH34_0
+ $PINS EN=N100 ENCLK=CTS_741 CLK=CTS_742
Xclk_gate_bank_mem_1_reg[0]_0 SNPS_CLOCK_GATE_HIGH_RegFileDual_DATA_WIDTH34_63
+ $PINS EN=N100 ENCLK=CTS_738 CLK=CTS_742
Xclk_gate_bank_mem_1_reg[1] SNPS_CLOCK_GATE_HIGH_RegFileDual_DATA_WIDTH34_62
+ $PINS EN=N99 ENCLK=CTS_735 CLK=CTS_742
Xclk_gate_bank_mem_1_reg[1]_0 SNPS_CLOCK_GATE_HIGH_RegFileDual_DATA_WIDTH34_61
+ $PINS EN=N99 ENCLK=CTS_732 CLK=CTS_742
Xclk_gate_bank_mem_1_reg[2] SNPS_CLOCK_GATE_HIGH_RegFileDual_DATA_WIDTH34_60
+ $PINS EN=N98 ENCLK=CTS_729 CLK=CTS_742
Xclk_gate_bank_mem_1_reg[2]_0 SNPS_CLOCK_GATE_HIGH_RegFileDual_DATA_WIDTH34_59
+ $PINS EN=N98 ENCLK=CTS_726 CLK=CTS_742
Xclk_gate_bank_mem_1_reg[3] SNPS_CLOCK_GATE_HIGH_RegFileDual_DATA_WIDTH34_58
+ $PINS EN=N97 ENCLK=CTS_723 CLK=CTS_742
Xclk_gate_bank_mem_1_reg[3]_0 SNPS_CLOCK_GATE_HIGH_RegFileDual_DATA_WIDTH34_57
+ $PINS EN=N97 ENCLK=CTS_720 CLK=CTS_742
Xclk_gate_bank_mem_1_reg[4] SNPS_CLOCK_GATE_HIGH_RegFileDual_DATA_WIDTH34_56
+ $PINS EN=N96 ENCLK=CTS_717 CLK=CTS_742
Xclk_gate_bank_mem_1_reg[4]_0 SNPS_CLOCK_GATE_HIGH_RegFileDual_DATA_WIDTH34_55
+ $PINS EN=N96 ENCLK=CTS_714 CLK=CTS_742
Xclk_gate_bank_mem_1_reg[5] SNPS_CLOCK_GATE_HIGH_RegFileDual_DATA_WIDTH34_54
+ $PINS EN=N95 ENCLK=CTS_711 CLK=CTS_742
Xclk_gate_bank_mem_1_reg[5]_0 SNPS_CLOCK_GATE_HIGH_RegFileDual_DATA_WIDTH34_53
+ $PINS EN=N95 ENCLK=CTS_708 CLK=CTS_742
Xclk_gate_bank_mem_1_reg[6] SNPS_CLOCK_GATE_HIGH_RegFileDual_DATA_WIDTH34_52
+ $PINS EN=N94 ENCLK=CTS_705 CLK=CTS_742
Xclk_gate_bank_mem_1_reg[6]_0 SNPS_CLOCK_GATE_HIGH_RegFileDual_DATA_WIDTH34_51
+ $PINS EN=N94 ENCLK=CTS_702 CLK=CTS_742
Xclk_gate_bank_mem_1_reg[7] SNPS_CLOCK_GATE_HIGH_RegFileDual_DATA_WIDTH34_50
+ $PINS EN=N93 ENCLK=CTS_699 CLK=CTS_742
Xclk_gate_bank_mem_1_reg[7]_0 SNPS_CLOCK_GATE_HIGH_RegFileDual_DATA_WIDTH34_49
+ $PINS EN=N93 ENCLK=CTS_691 CLK=CTS_692
Xclk_gate_bank_mem_1_reg[8] SNPS_CLOCK_GATE_HIGH_RegFileDual_DATA_WIDTH34_48
+ $PINS EN=N92 ENCLK=CTS_688 CLK=CTS_692
Xclk_gate_bank_mem_1_reg[8]_0 SNPS_CLOCK_GATE_HIGH_RegFileDual_DATA_WIDTH34_47
+ $PINS EN=N92 ENCLK=CTS_685 CLK=CTS_692
Xclk_gate_bank_mem_1_reg[9] SNPS_CLOCK_GATE_HIGH_RegFileDual_DATA_WIDTH34_46
+ $PINS EN=N91 ENCLK=CTS_682 CLK=CTS_692
Xclk_gate_bank_mem_1_reg[9]_0 SNPS_CLOCK_GATE_HIGH_RegFileDual_DATA_WIDTH34_45
+ $PINS EN=N91 ENCLK=CTS_679 CLK=CTS_692
Xclk_gate_bank_mem_1_reg[10] SNPS_CLOCK_GATE_HIGH_RegFileDual_DATA_WIDTH34_44
+ $PINS EN=N90 ENCLK=CTS_676 CLK=CTS_692
Xclk_gate_bank_mem_1_reg[10]_0 SNPS_CLOCK_GATE_HIGH_RegFileDual_DATA_WIDTH34_43
+ $PINS EN=N90 ENCLK=CTS_673 CLK=CTS_692
Xclk_gate_bank_mem_1_reg[11] SNPS_CLOCK_GATE_HIGH_RegFileDual_DATA_WIDTH34_42
+ $PINS EN=N89 ENCLK=CTS_670 CLK=CTS_692
Xclk_gate_bank_mem_1_reg[11]_0 SNPS_CLOCK_GATE_HIGH_RegFileDual_DATA_WIDTH34_41
+ $PINS EN=N89 ENCLK=CTS_667 CLK=CTS_692
Xclk_gate_bank_mem_1_reg[12] SNPS_CLOCK_GATE_HIGH_RegFileDual_DATA_WIDTH34_40
+ $PINS EN=N88 ENCLK=CTS_664 CLK=CTS_692
Xclk_gate_bank_mem_1_reg[12]_0 SNPS_CLOCK_GATE_HIGH_RegFileDual_DATA_WIDTH34_39
+ $PINS EN=N88 ENCLK=CTS_661 CLK=CTS_692
Xclk_gate_bank_mem_1_reg[13] SNPS_CLOCK_GATE_HIGH_RegFileDual_DATA_WIDTH34_38
+ $PINS EN=N87 ENCLK=CTS_658 CLK=CTS_692
Xclk_gate_bank_mem_1_reg[13]_0 SNPS_CLOCK_GATE_HIGH_RegFileDual_DATA_WIDTH34_37
+ $PINS EN=N87 ENCLK=CTS_655 CLK=CTS_692
Xclk_gate_bank_mem_1_reg[14] SNPS_CLOCK_GATE_HIGH_RegFileDual_DATA_WIDTH34_36
+ $PINS EN=N86 ENCLK=CTS_652 CLK=CTS_692
Xclk_gate_bank_mem_1_reg[14]_0 SNPS_CLOCK_GATE_HIGH_RegFileDual_DATA_WIDTH34_35
+ $PINS EN=N86 ENCLK=CTS_649 CLK=CTS_692
Xclk_gate_bank_mem_1_reg[15] SNPS_CLOCK_GATE_HIGH_RegFileDual_DATA_WIDTH34_34
+ $PINS EN=N85 ENCLK=CTS_646 CLK=CTS_692
Xclk_gate_bank_mem_1_reg[15]_0 SNPS_CLOCK_GATE_HIGH_RegFileDual_DATA_WIDTH34_33
+ $PINS EN=N85 ENCLK=CTS_643 CLK=CTS_692
Xclk_gate_bank_mem_0_reg[0] SNPS_CLOCK_GATE_HIGH_RegFileDual_DATA_WIDTH34_32
+ $PINS EN=N67 ENCLK=CTS_784 CLK=clk_clone1
Xclk_gate_bank_mem_0_reg[0]_0 SNPS_CLOCK_GATE_HIGH_RegFileDual_DATA_WIDTH34_31
+ $PINS EN=N67 ENCLK=CTS_781 CLK=clk_clone1
Xclk_gate_bank_mem_0_reg[1] SNPS_CLOCK_GATE_HIGH_RegFileDual_DATA_WIDTH34_30
+ $PINS EN=N66 ENCLK=CTS_778 CLK=clk_clone1
Xclk_gate_bank_mem_0_reg[1]_0 SNPS_CLOCK_GATE_HIGH_RegFileDual_DATA_WIDTH34_29
+ $PINS EN=N66 ENCLK=CTS_775 CLK=clk_clone1
Xclk_gate_bank_mem_0_reg[2] SNPS_CLOCK_GATE_HIGH_RegFileDual_DATA_WIDTH34_28
+ $PINS EN=N65 ENCLK=CTS_772 CLK=clk_clone1
Xclk_gate_bank_mem_0_reg[2]_0 SNPS_CLOCK_GATE_HIGH_RegFileDual_DATA_WIDTH34_27
+ $PINS EN=N65 ENCLK=CTS_769 CLK=clk_clone1
Xclk_gate_bank_mem_0_reg[3] SNPS_CLOCK_GATE_HIGH_RegFileDual_DATA_WIDTH34_26
+ $PINS EN=N64 ENCLK=CTS_766 CLK=clk_clone1
Xclk_gate_bank_mem_0_reg[3]_0 SNPS_CLOCK_GATE_HIGH_RegFileDual_DATA_WIDTH34_25
+ $PINS EN=N64 ENCLK=CTS_763 CLK=clk_clone1
Xclk_gate_bank_mem_0_reg[4] SNPS_CLOCK_GATE_HIGH_RegFileDual_DATA_WIDTH34_24
+ $PINS EN=N63 ENCLK=CTS_760 CLK=clk_clone1
Xclk_gate_bank_mem_0_reg[4]_0 SNPS_CLOCK_GATE_HIGH_RegFileDual_DATA_WIDTH34_23
+ $PINS EN=N63 ENCLK=CTS_757 CLK=clk_clone1
Xclk_gate_bank_mem_0_reg[5] SNPS_CLOCK_GATE_HIGH_RegFileDual_DATA_WIDTH34_22
+ $PINS CLK=clk_clone1 EN=N62 ENCLK=CTS_696 CLK_clone1=clk_clone3
Xclk_gate_bank_mem_0_reg[5]_0 SNPS_CLOCK_GATE_HIGH_RegFileDual_DATA_WIDTH34_21
+ $PINS EN=N62 ENCLK=CTS_754 CLK=clk_clone1
Xclk_gate_bank_mem_0_reg[6] SNPS_CLOCK_GATE_HIGH_RegFileDual_DATA_WIDTH34_20
+ $PINS EN=N61 ENCLK=CTS_751 CLK=clk_clone1
Xclk_gate_bank_mem_0_reg[6]_0 SNPS_CLOCK_GATE_HIGH_RegFileDual_DATA_WIDTH34_19
+ $PINS EN=N61 ENCLK=CTS_748 CLK=clk_clone1
Xclk_gate_bank_mem_0_reg[7] SNPS_CLOCK_GATE_HIGH_RegFileDual_DATA_WIDTH34_18
+ $PINS EN=N60 ENCLK=CTS_639 CLK=CTS_640
Xclk_gate_bank_mem_0_reg[7]_0 SNPS_CLOCK_GATE_HIGH_RegFileDual_DATA_WIDTH34_17
+ $PINS EN=N60 ENCLK=CTS_745 CLK=clk_clone1
Xclk_gate_bank_mem_0_reg[8] SNPS_CLOCK_GATE_HIGH_RegFileDual_DATA_WIDTH34_16
+ $PINS EN=N59 ENCLK=CTS_636 CLK=CTS_640
Xclk_gate_bank_mem_0_reg[8]_0 SNPS_CLOCK_GATE_HIGH_RegFileDual_DATA_WIDTH34_15
+ $PINS EN=N59 ENCLK=CTS_633 CLK=CTS_640
Xclk_gate_bank_mem_0_reg[9] SNPS_CLOCK_GATE_HIGH_RegFileDual_DATA_WIDTH34_14
+ $PINS EN=N58 ENCLK=CTS_630 CLK=CTS_640
Xclk_gate_bank_mem_0_reg[9]_0 SNPS_CLOCK_GATE_HIGH_RegFileDual_DATA_WIDTH34_13
+ $PINS EN=N58 ENCLK=CTS_627 CLK=CTS_640
Xclk_gate_bank_mem_0_reg[10] SNPS_CLOCK_GATE_HIGH_RegFileDual_DATA_WIDTH34_12
+ $PINS EN=N57 ENCLK=CTS_624 CLK=CTS_640
Xclk_gate_bank_mem_0_reg[10]_0 SNPS_CLOCK_GATE_HIGH_RegFileDual_DATA_WIDTH34_11
+ $PINS EN=N57 ENCLK=CTS_621 CLK=CTS_640
Xclk_gate_bank_mem_0_reg[11] SNPS_CLOCK_GATE_HIGH_RegFileDual_DATA_WIDTH34_10
+ $PINS EN=N56 ENCLK=CTS_618 CLK=CTS_640
Xclk_gate_bank_mem_0_reg[11]_0 SNPS_CLOCK_GATE_HIGH_RegFileDual_DATA_WIDTH34_9
+ $PINS EN=N56 ENCLK=CTS_615 CLK=CTS_640
Xclk_gate_bank_mem_0_reg[12] SNPS_CLOCK_GATE_HIGH_RegFileDual_DATA_WIDTH34_8
+ $PINS EN=N55 ENCLK=CTS_612 CLK=CTS_640
Xclk_gate_bank_mem_0_reg[12]_0 SNPS_CLOCK_GATE_HIGH_RegFileDual_DATA_WIDTH34_7
+ $PINS EN=N55 ENCLK=CTS_609 CLK=CTS_640
Xclk_gate_bank_mem_0_reg[13] SNPS_CLOCK_GATE_HIGH_RegFileDual_DATA_WIDTH34_6
+ $PINS EN=N54 ENCLK=CTS_606 CLK=CTS_640
Xclk_gate_bank_mem_0_reg[13]_0 SNPS_CLOCK_GATE_HIGH_RegFileDual_DATA_WIDTH34_5
+ $PINS EN=N54 ENCLK=CTS_603 CLK=CTS_640
Xclk_gate_bank_mem_0_reg[14] SNPS_CLOCK_GATE_HIGH_RegFileDual_DATA_WIDTH34_4
+ $PINS EN=N53 ENCLK=CTS_600 CLK=CTS_640
Xclk_gate_bank_mem_0_reg[14]_0 SNPS_CLOCK_GATE_HIGH_RegFileDual_DATA_WIDTH34_3
+ $PINS EN=N53 ENCLK=CTS_597 CLK=CTS_640
Xclk_gate_bank_mem_0_reg[15] SNPS_CLOCK_GATE_HIGH_RegFileDual_DATA_WIDTH34_2
+ $PINS EN=N52 ENCLK=CTS_594 CLK=CTS_640
Xclk_gate_bank_mem_0_reg[15]_0 SNPS_CLOCK_GATE_HIGH_RegFileDual_DATA_WIDTH34_1
+ $PINS EN=N52 ENCLK=CTS_591 CLK=CTS_640
.ENDS

.SUBCKT SNPS_CLOCK_GATE_HIGH_RegFileDual_DATA_WIDTH22_0 EN ENCLK CLK
*.CONNECT net1700 EN
XFE_PHC932_net1703 DELC $PINS O=FE_PHN932_net1703 I=net1703
Xlatch QDBHN $PINS Q=net1703 D=net1700 CKB=CLK
Xmain_gate AN2T $PINS O=ENCLK I1=FE_PHN932_net1703 I2=CLK
.ENDS

.SUBCKT SNPS_CLOCK_GATE_HIGH_RegFileDual_DATA_WIDTH22_31 EN ENCLK CLK
*.CONNECT net1700 EN
XFE_PHC928_net1703 DELC $PINS O=net1703 I=FE_PHN928_net1703
Xlatch QDBHN $PINS Q=FE_PHN928_net1703 D=net1700 CKB=CLK
Xmain_gate AN2T $PINS O=ENCLK I1=net1703 I2=CLK
.ENDS

.SUBCKT SNPS_CLOCK_GATE_HIGH_RegFileDual_DATA_WIDTH22_30 EN ENCLK CLK
*.CONNECT net1700 EN
XFE_PHC918_net1703 DELC $PINS O=FE_PHN918_net1703 I=net1703
Xlatch QDBHN $PINS Q=net1703 D=net1700 CKB=CLK
Xmain_gate AN2T $PINS O=ENCLK I1=FE_PHN918_net1703 I2=CLK
.ENDS

.SUBCKT SNPS_CLOCK_GATE_HIGH_RegFileDual_DATA_WIDTH22_29 EN ENCLK CLK
*.CONNECT net1700 EN
XFE_PHC908_net1703 DELC $PINS O=FE_PHN908_net1703 I=net1703
Xlatch QDBHN $PINS Q=net1703 D=net1700 CKB=CLK
Xmain_gate AN2T $PINS O=ENCLK I1=FE_PHN908_net1703 I2=CLK
.ENDS

.SUBCKT SNPS_CLOCK_GATE_HIGH_RegFileDual_DATA_WIDTH22_28 EN ENCLK CLK
*.CONNECT net1700 EN
XFE_PHC925_net1703 DELC $PINS O=net1703 I=FE_PHN925_net1703
Xlatch QDBHN $PINS Q=FE_PHN925_net1703 D=net1700 CKB=CLK
Xmain_gate AN2T $PINS O=ENCLK I1=net1703 I2=CLK
.ENDS

.SUBCKT SNPS_CLOCK_GATE_HIGH_RegFileDual_DATA_WIDTH22_27 EN ENCLK CLK
*.CONNECT net1700 EN
XFE_PHC898_net1703 DELC $PINS O=net1703 I=FE_PHN898_net1703
Xlatch QDBHN $PINS Q=FE_PHN898_net1703 D=net1700 CKB=CLK
Xmain_gate AN2T $PINS O=ENCLK I1=net1703 I2=CLK
.ENDS

.SUBCKT SNPS_CLOCK_GATE_HIGH_RegFileDual_DATA_WIDTH22_26 EN ENCLK CLK
*.CONNECT net1700 EN
XFE_PHC910_net1703 DELC $PINS O=FE_PHN910_net1703 I=net1703
Xlatch QDBHN $PINS Q=net1703 D=net1700 CKB=CLK
Xmain_gate AN2T $PINS O=ENCLK I1=FE_PHN910_net1703 I2=CLK
.ENDS

.SUBCKT SNPS_CLOCK_GATE_HIGH_RegFileDual_DATA_WIDTH22_25 EN ENCLK CLK
*.CONNECT net1700 EN
XFE_PHC917_net1703 DELC $PINS O=FE_PHN917_net1703 I=net1703
Xlatch QDBHN $PINS Q=net1703 D=net1700 CKB=CLK
Xmain_gate AN2T $PINS O=ENCLK I1=FE_PHN917_net1703 I2=CLK
.ENDS

.SUBCKT SNPS_CLOCK_GATE_HIGH_RegFileDual_DATA_WIDTH22_24 EN ENCLK CLK
*.CONNECT net1700 EN
XFE_PHC923_net1703 DELC $PINS O=FE_PHN923_net1703 I=net1703
Xlatch QDBHN $PINS Q=net1703 D=net1700 CKB=CLK
Xmain_gate AN2T $PINS O=ENCLK I1=FE_PHN923_net1703 I2=CLK
.ENDS

.SUBCKT SNPS_CLOCK_GATE_HIGH_RegFileDual_DATA_WIDTH22_23 EN ENCLK CLK
*.CONNECT net1700 EN
XFE_PHC915_net1703 DELC $PINS O=FE_PHN915_net1703 I=net1703
Xlatch QDBHN $PINS Q=net1703 D=net1700 CKB=CLK
Xmain_gate AN2T $PINS O=ENCLK I1=FE_PHN915_net1703 I2=CLK
.ENDS

.SUBCKT SNPS_CLOCK_GATE_HIGH_RegFileDual_DATA_WIDTH22_22 EN ENCLK CLK
*.CONNECT net1700 EN
XFE_PHC912_net1703 DELC $PINS O=FE_PHN912_net1703 I=net1703
Xlatch QDBHN $PINS Q=net1703 D=net1700 CKB=CLK
Xmain_gate AN2T $PINS O=ENCLK I1=FE_PHN912_net1703 I2=CLK
.ENDS

.SUBCKT SNPS_CLOCK_GATE_HIGH_RegFileDual_DATA_WIDTH22_21 EN ENCLK CLK
*.CONNECT net1700 EN
XFE_PHC905_net1703 DELC $PINS O=FE_PHN905_net1703 I=net1703
Xlatch QDBHN $PINS Q=net1703 D=net1700 CKB=CLK
Xmain_gate AN2T $PINS O=ENCLK I1=FE_PHN905_net1703 I2=CLK
.ENDS

.SUBCKT SNPS_CLOCK_GATE_HIGH_RegFileDual_DATA_WIDTH22_20 EN ENCLK CLK
*.CONNECT net1700 EN
XFE_PHC914_net1703 DELC $PINS O=FE_PHN914_net1703 I=net1703
Xlatch QDBHN $PINS Q=net1703 D=net1700 CKB=CLK
Xmain_gate AN2T $PINS O=ENCLK I1=FE_PHN914_net1703 I2=CLK
.ENDS

.SUBCKT SNPS_CLOCK_GATE_HIGH_RegFileDual_DATA_WIDTH22_19 EN ENCLK CLK
*.CONNECT net1700 EN
XFE_PHC921_net1703 DELC $PINS O=FE_PHN921_net1703 I=net1703
Xlatch QDBHN $PINS Q=net1703 D=net1700 CKB=CLK
Xmain_gate AN2T $PINS O=ENCLK I1=FE_PHN921_net1703 I2=CLK
.ENDS

.SUBCKT SNPS_CLOCK_GATE_HIGH_RegFileDual_DATA_WIDTH22_18 EN ENCLK CLK
*.CONNECT net1700 EN
XFE_PHC911_net1703 DELC $PINS O=FE_PHN911_net1703 I=net1703
Xlatch QDBHN $PINS Q=net1703 D=net1700 CKB=CLK
Xmain_gate AN2T $PINS O=ENCLK I1=FE_PHN911_net1703 I2=CLK
.ENDS

.SUBCKT SNPS_CLOCK_GATE_HIGH_RegFileDual_DATA_WIDTH22_17 EN ENCLK CLK
*.CONNECT net1700 EN
XFE_PHC924_net1703 DELC $PINS O=FE_PHN924_net1703 I=net1703
Xlatch QDBHN $PINS Q=net1703 D=net1700 CKB=CLK
Xmain_gate AN2T $PINS O=ENCLK I1=FE_PHN924_net1703 I2=CLK
.ENDS

.SUBCKT SNPS_CLOCK_GATE_HIGH_RegFileDual_DATA_WIDTH22_16 EN ENCLK CLK
*.CONNECT net1700 EN
XFE_PHC1505_net1703 BUF1CK $PINS O=FE_PHN1505_net1703 I=FE_PHN1031_net1703
XFE_PHC1031_net1703 DELB $PINS O=FE_PHN1031_net1703 I=net1703
Xlatch QDBHN $PINS Q=net1703 D=net1700 CKB=CLK
Xmain_gate AN2T $PINS O=ENCLK I1=FE_PHN1505_net1703 I2=CLK
.ENDS

.SUBCKT SNPS_CLOCK_GATE_HIGH_RegFileDual_DATA_WIDTH22_15 EN ENCLK CLK
*.CONNECT net1700 EN
XFE_PHC1495_net1703 BUF1CK $PINS O=FE_PHN1495_net1703 I=net1703
XFE_PHC1033_net1703 DELB $PINS O=FE_PHN1033_net1703 I=FE_PHN1495_net1703
Xlatch QDBHN $PINS Q=net1703 D=net1700 CKB=CLK
Xmain_gate AN2T $PINS O=ENCLK I1=FE_PHN1033_net1703 I2=CLK
.ENDS

.SUBCKT SNPS_CLOCK_GATE_HIGH_RegFileDual_DATA_WIDTH22_14 EN ENCLK CLK
*.CONNECT net1700 EN
XFE_PHC1503_net1703 BUF1CK $PINS O=FE_PHN1503_net1703 I=FE_PHN1029_net1703
XFE_PHC1029_net1703 DELB $PINS O=FE_PHN1029_net1703 I=net1703
Xlatch QDBHN $PINS Q=net1703 D=net1700 CKB=CLK
Xmain_gate AN2T $PINS O=ENCLK I1=FE_PHN1503_net1703 I2=CLK
.ENDS

.SUBCKT SNPS_CLOCK_GATE_HIGH_RegFileDual_DATA_WIDTH22_13 EN ENCLK CLK
*.CONNECT net1700 EN
XFE_PHC1501_net1703 BUF1CK $PINS O=FE_PHN1041_net1703 I=FE_PHN1501_net1703
XFE_PHC1041_net1703 DELB $PINS O=net1703 I=FE_PHN1041_net1703
Xlatch QDBHN $PINS Q=FE_PHN1501_net1703 D=net1700 CKB=CLK
Xmain_gate AN2T $PINS O=ENCLK I1=net1703 I2=CLK
.ENDS

.SUBCKT SNPS_CLOCK_GATE_HIGH_RegFileDual_DATA_WIDTH22_12 EN ENCLK CLK
*.CONNECT net1700 EN
XFE_PHC1496_net1703 BUF1CK $PINS O=FE_PHN1044_net1703 I=FE_PHN1496_net1703
XFE_PHC1044_net1703 DELB $PINS O=net1703 I=FE_PHN1044_net1703
Xlatch QDBHN $PINS Q=FE_PHN1496_net1703 D=net1700 CKB=CLK
Xmain_gate AN2T $PINS O=ENCLK I1=net1703 I2=CLK
.ENDS

.SUBCKT SNPS_CLOCK_GATE_HIGH_RegFileDual_DATA_WIDTH22_11 EN ENCLK CLK
*.CONNECT net1700 EN
XFE_PHC1509_net1703 BUF1CK $PINS O=FE_PHN1043_net1703 I=FE_PHN1509_net1703
XFE_PHC1043_net1703 DELB $PINS O=net1703 I=FE_PHN1043_net1703
Xlatch QDBHN $PINS Q=FE_PHN1509_net1703 D=net1700 CKB=CLK
Xmain_gate AN2T $PINS O=ENCLK I1=net1703 I2=CLK
.ENDS

.SUBCKT SNPS_CLOCK_GATE_HIGH_RegFileDual_DATA_WIDTH22_10 EN ENCLK CLK
*.CONNECT net1700 EN
XFE_PHC1493_net1703 BUF1CK $PINS O=FE_PHN1038_net1703 I=FE_PHN1493_net1703
XFE_PHC1038_net1703 DELB $PINS O=net1703 I=FE_PHN1038_net1703
Xlatch QDBHN $PINS Q=FE_PHN1493_net1703 D=net1700 CKB=CLK
Xmain_gate AN2T $PINS O=ENCLK I1=net1703 I2=CLK
.ENDS

.SUBCKT SNPS_CLOCK_GATE_HIGH_RegFileDual_DATA_WIDTH22_9 EN ENCLK CLK
*.CONNECT net1700 EN
XFE_PHC1511_net1703 BUF1CK $PINS O=FE_PHN1511_net1703 I=FE_PHN1045_net1703
XFE_PHC1045_net1703 DELB $PINS O=FE_PHN1045_net1703 I=net1703
Xlatch QDBHN $PINS Q=net1703 D=net1700 CKB=CLK
Xmain_gate AN2T $PINS O=ENCLK I1=FE_PHN1511_net1703 I2=CLK
.ENDS

.SUBCKT SNPS_CLOCK_GATE_HIGH_RegFileDual_DATA_WIDTH22_8 EN ENCLK CLK
*.CONNECT net1700 EN
XFE_PHC1499_net1703 BUF1CK $PINS O=FE_PHN1499_net1703 I=net1703
XFE_PHC1027_net1703 DELB $PINS O=FE_PHN1027_net1703 I=FE_PHN1499_net1703
Xlatch QDBHN $PINS Q=net1703 D=net1700 CKB=CLK
Xmain_gate AN2T $PINS O=ENCLK I1=FE_PHN1027_net1703 I2=CLK
.ENDS

.SUBCKT SNPS_CLOCK_GATE_HIGH_RegFileDual_DATA_WIDTH22_7 EN ENCLK CLK
*.CONNECT net1700 EN
XFE_PHC1497_net1703 BUF1CK $PINS O=FE_PHN1497_net1703 I=FE_PHN1025_net1703
XFE_PHC1025_net1703 DELB $PINS O=FE_PHN1025_net1703 I=net1703
Xlatch QDBHN $PINS Q=net1703 D=net1700 CKB=CLK
Xmain_gate AN2T $PINS O=ENCLK I1=FE_PHN1497_net1703 I2=CLK
.ENDS

.SUBCKT SNPS_CLOCK_GATE_HIGH_RegFileDual_DATA_WIDTH22_6 EN ENCLK CLK
*.CONNECT net1700 EN
XFE_PHC1504_net1703 BUF1CK $PINS O=FE_PHN1504_net1703 I=net1703
XFE_PHC1030_net1703 DELB $PINS O=FE_PHN1030_net1703 I=FE_PHN1504_net1703
Xlatch QDBHN $PINS Q=net1703 D=net1700 CKB=CLK
Xmain_gate AN2T $PINS O=ENCLK I1=FE_PHN1030_net1703 I2=CLK
.ENDS

.SUBCKT SNPS_CLOCK_GATE_HIGH_RegFileDual_DATA_WIDTH22_5 EN ENCLK CLK
*.CONNECT net1700 EN
XFE_PHC1494_net1703 BUF1CK $PINS O=net1703 I=FE_PHN1494_net1703
XFE_PHC1021_net1703 DELB $PINS O=FE_PHN1021_net1703 I=net1703
Xlatch QDBHN $PINS Q=FE_PHN1494_net1703 D=net1700 CKB=CLK
Xmain_gate AN2T $PINS O=ENCLK I1=FE_PHN1021_net1703 I2=CLK
.ENDS

.SUBCKT SNPS_CLOCK_GATE_HIGH_RegFileDual_DATA_WIDTH22_4 EN ENCLK CLK
*.CONNECT net1700 EN
XFE_PHC1506_net1703 BUF1CK $PINS O=FE_PHN1506_net1703 I=FE_PHN1028_net1703
XFE_PHC1028_net1703 DELB $PINS O=FE_PHN1028_net1703 I=net1703
Xlatch QDBHN $PINS Q=net1703 D=net1700 CKB=CLK
Xmain_gate AN2T $PINS O=ENCLK I1=FE_PHN1506_net1703 I2=CLK
.ENDS

.SUBCKT SNPS_CLOCK_GATE_HIGH_RegFileDual_DATA_WIDTH22_3 EN ENCLK CLK
*.CONNECT net1700 EN
XFE_PHC1498_net1703 BUF1CK $PINS O=FE_PHN1498_net1703 I=net1703
XFE_PHC1036_net1703 DELB $PINS O=FE_PHN1036_net1703 I=FE_PHN1498_net1703
Xlatch QDBHN $PINS Q=net1703 D=net1700 CKB=CLK
Xmain_gate AN2T $PINS O=ENCLK I1=FE_PHN1036_net1703 I2=CLK
.ENDS

.SUBCKT SNPS_CLOCK_GATE_HIGH_RegFileDual_DATA_WIDTH22_2 EN ENCLK CLK
*.CONNECT net1700 EN
XFE_PHC1502_net1703 BUF1CK $PINS O=FE_PHN1502_net1703 I=net1703
XFE_PHC1032_net1703 DELB $PINS O=FE_PHN1032_net1703 I=FE_PHN1502_net1703
Xlatch QDBHN $PINS Q=net1703 D=net1700 CKB=CLK
Xmain_gate AN2T $PINS O=ENCLK I1=FE_PHN1032_net1703 I2=CLK
.ENDS

.SUBCKT SNPS_CLOCK_GATE_HIGH_RegFileDual_DATA_WIDTH22_1 EN ENCLK CLK
*.CONNECT net1700 EN
XFE_PHC1491_net1703 BUF1CK $PINS O=FE_PHN1491_net1703 I=net1703
XFE_PHC1022_net1703 DELB $PINS O=FE_PHN1022_net1703 I=FE_PHN1491_net1703
Xlatch QDBHN $PINS Q=net1703 D=net1700 CKB=CLK
Xmain_gate AN2T $PINS O=ENCLK I1=FE_PHN1022_net1703 I2=CLK
.ENDS

.SUBCKT RegFileDual_DATA_WIDTH22 read_addr_1[4] read_addr_1[3] read_addr_1[2]
+ read_addr_1[1] read_addr_1[0] read_data_1[21] read_data_1[20] read_data_1[19]
+ read_data_1[18] read_data_1[17] read_data_1[16] read_data_1[15]
+ read_data_1[14] read_data_1[13] read_data_1[12] read_data_1[11]
+ read_data_1[10] read_data_1[9] read_data_1[8] read_data_1[7] read_data_1[6]
+ read_data_1[5] read_data_1[4] read_data_1[3] read_data_1[2] read_data_1[1]
+ read_data_1[0] wen1 wen2 write_addr_1[4] write_addr_1[3] write_addr_1[2]
+ write_addr_1[1] write_addr_1[0] write_addr_2[4] write_addr_2[3]
+ write_addr_2[2] write_addr_2[1] write_addr_2[0] write_data_1[21]
+ write_data_1[20] write_data_1[19] write_data_1[18] write_data_1[17]
+ write_data_1[16] write_data_1[15] write_data_1[14] write_data_1[13]
+ write_data_1[12] write_data_1[11] write_data_1[10] write_data_1[9]
+ write_data_1[8] write_data_1[7] write_data_1[6] write_data_1[5]
+ write_data_1[4] write_data_1[3] write_data_1[2] write_data_1[1]
+ write_data_1[0] write_data_2[21] write_data_2[20] write_data_2[19]
+ write_data_2[18] write_data_2[17] write_data_2[16] write_data_2[15]
+ write_data_2[14] write_data_2[13] write_data_2[12] write_data_2[11]
+ write_data_2[10] write_data_2[9] write_data_2[8] write_data_2[7]
+ write_data_2[6] write_data_2[5] write_data_2[4] write_data_2[3]
+ write_data_2[2] write_data_2[1] write_data_2[0] rst_n p_1 i_rst_n
+ FE_OFN26_i_rst_n clk_clone3 clk_clone2 clk_clone1 clk
XFE_PHC1534_N111 BUF1S $PINS O=FE_PHN1534_N111 I=N111
XFE_PHC1471_n616 BUF1CK $PINS O=FE_PHN1471_n616 I=n616
XFE_PHC1469_n614 BUF1CK $PINS O=FE_PHN1469_n614 I=n614
XFE_PHC1463_n608 BUF1S $PINS O=FE_PHN1463_n608 I=n608
XFE_PHC1457_n615 BUF3 $PINS O=FE_PHN1457_n615 I=n615
XFE_PHC1455_n607 BUF3 $PINS O=FE_PHN1455_n607 I=n607
XFE_PHC1448_n617 BUF1S $PINS O=FE_PHN1448_n617 I=n617
XFE_PHC1438_N111 BUF1S $PINS O=FE_PHN1438_N111 I=FE_PHN1534_N111
XFE_PHC1407_N104 DELB $PINS O=FE_PHN1407_N104 I=N104
XFE_PHC1405_N106 DELB $PINS O=FE_PHN1405_N106 I=N106
XFE_PHC1404_N105 DELB $PINS O=FE_PHN1404_N105 I=N105
XFE_PHC1403_N124 DELB $PINS O=N124 I=FE_PHN1403_N124
XFE_PHC1402_N103 DELB $PINS O=FE_PHN1402_N103 I=N103
XFE_PHC1401_N116 DELB $PINS O=FE_PHN1401_N116 I=N116
XFE_PHC1393_N110 DELB $PINS O=FE_PHN1393_N110 I=N110
XFE_PHC1392_N113 DELB $PINS O=FE_PHN1392_N113 I=N113
XFE_PHC1389_N120 DELB $PINS O=N120 I=FE_PHN1389_N120
XFE_PHC1387_N117 DELB $PINS O=N117 I=FE_PHN1387_N117
XFE_PHC1378_N122 DELB $PINS O=N122 I=FE_PHN1378_N122
XFE_PHC1376_N108 DELB $PINS O=FE_PHN1376_N108 I=N108
XFE_PHC1375_N112 DELB $PINS O=N112 I=FE_PHN1375_N112
XFE_PHC1370_N123 DELB $PINS O=N123 I=FE_PHN1370_N123
XFE_PHC1369_N119 DELB $PINS O=FE_PHN1369_N119 I=N119
XFE_PHC1368_N121 DELB $PINS O=FE_PHN1368_N121 I=N121
XFE_PHC1365_N107 DELB $PINS O=N107 I=FE_PHN1365_N107
XFE_PHC1361_N109 DELB $PINS O=FE_PHN1361_N109 I=N109
XFE_PHC1360_N114 DELB $PINS O=FE_PHN1360_N114 I=N114
XFE_PHC1359_N115 DELB $PINS O=N115 I=FE_PHN1359_N115
XFE_PHC1354_N118 DELB $PINS O=N118 I=FE_PHN1354_N118
XFE_PHC1042_bank_rdata_1_19 DELB $PINS O=FE_PHN1042_bank_rdata_1_19
+ I=bank_rdata[1][19]
XFE_PHC1040_bank_rdata_1_0 DELB $PINS O=FE_PHN1040_bank_rdata_1_0
+ I=bank_rdata[1][0]
XFE_PHC1039_bank_rdata_1_8 DELB $PINS O=FE_PHN1039_bank_rdata_1_8
+ I=bank_rdata[1][8]
XFE_PHC1024_bank_rdata_1_4 DELB $PINS O=bank_rdata[1][4]
+ I=FE_PHN1024_bank_rdata_1_4
XFE_PHC1023_bank_rdata_1_7 DELB $PINS O=FE_PHN1023_bank_rdata_1_7
+ I=bank_rdata[1][7]
XFE_PHC1018_bank_rdata_1_2 DELB $PINS O=bank_rdata[1][2]
+ I=FE_PHN1018_bank_rdata_1_2
XFE_PHC1016_bank_rdata_1_12 DELB $PINS O=FE_PHN1016_bank_rdata_1_12
+ I=bank_rdata[1][12]
XFE_PHC1015_bank_rdata_1_16 DELB $PINS O=bank_rdata[1][16]
+ I=FE_PHN1015_bank_rdata_1_16
XFE_PHC1012_bank_rdata_1_1 DELB $PINS O=FE_PHN1012_bank_rdata_1_1
+ I=bank_rdata[1][1]
XFE_PHC1010_bank_rdata_1_17 DELB $PINS O=FE_PHN1010_bank_rdata_1_17
+ I=bank_rdata[1][17]
XFE_PHC1007_bank_rdata_1_10 DELB $PINS O=FE_PHN1007_bank_rdata_1_10
+ I=bank_rdata[1][10]
XFE_PHC1005_bank_rdata_1_9 DELB $PINS O=FE_PHN1005_bank_rdata_1_9
+ I=bank_rdata[1][9]
XFE_PHC1002_bank_rdata_1_6 DELB $PINS O=bank_rdata[1][6]
+ I=FE_PHN1002_bank_rdata_1_6
XCTS_ccl_a_INV_CLK_G1_L8_33 INV6CK $PINS O=CTS_388 I=CTS_389
XCTS_ccl_a_INV_CLK_G1_L7_33 INV3CK $PINS O=CTS_389 I=CTS_390
XCTS_ccl_a_INV_CLK_G1_L8_32 INV6CK $PINS O=CTS_385 I=CTS_386
XCTS_ccl_a_INV_CLK_G1_L7_32 INV3CK $PINS O=CTS_386 I=CTS_387
XCTS_ccl_a_INV_CLK_G1_L8_31 INV6CK $PINS O=CTS_382 I=CTS_383
XCTS_ccl_a_INV_CLK_G1_L7_31 INV3CK $PINS O=CTS_383 I=CTS_384
XCTS_ccl_a_INV_CLK_G1_L8_30 INV6CK $PINS O=CTS_379 I=CTS_380
XCTS_ccl_a_INV_CLK_G1_L7_30 INV3CK $PINS O=CTS_380 I=CTS_381
XCTS_ccl_a_INV_CLK_G1_L8_29 INV6CK $PINS O=CTS_376 I=CTS_377
XCTS_ccl_a_INV_CLK_G1_L7_29 INV3CK $PINS O=CTS_377 I=CTS_378
XCTS_ccl_a_INV_CLK_G1_L8_28 INV6CK $PINS O=CTS_373 I=CTS_374
XCTS_ccl_a_INV_CLK_G1_L7_28 INV4CK $PINS O=CTS_374 I=CTS_375
XCTS_ccl_a_INV_CLK_G1_L8_27 INV6CK $PINS O=CTS_370 I=CTS_371
XCTS_ccl_a_INV_CLK_G1_L7_27 INV3CK $PINS O=CTS_371 I=CTS_372
XCTS_ccl_a_INV_CLK_G1_L8_26 INV6CK $PINS O=CTS_367 I=CTS_368
XCTS_ccl_a_INV_CLK_G1_L7_26 INV4CK $PINS O=CTS_368 I=CTS_369
XCTS_ccl_a_INV_CLK_G1_L8_25 INV6CK $PINS O=CTS_364 I=CTS_365
XCTS_ccl_a_INV_CLK_G1_L7_25 INV4CK $PINS O=CTS_365 I=CTS_366
XCTS_ccl_a_INV_CLK_G1_L8_24 INV6CK $PINS O=CTS_361 I=CTS_362
XCTS_ccl_a_INV_CLK_G1_L7_24 INV3CK $PINS O=CTS_362 I=CTS_363
XCTS_ccl_a_INV_CLK_G1_L8_23 INV6CK $PINS O=CTS_358 I=CTS_359
XCTS_ccl_a_INV_CLK_G1_L7_23 INV3CK $PINS O=CTS_359 I=CTS_360
XCTS_ccl_a_INV_CLK_G1_L8_22 INV6CK $PINS O=CTS_355 I=CTS_356
XCTS_ccl_a_INV_CLK_G1_L7_22 INV4CK $PINS O=CTS_356 I=CTS_357
XCTS_ccl_a_INV_CLK_G1_L8_21 INV6CK $PINS O=CTS_352 I=CTS_353
XCTS_ccl_a_INV_CLK_G1_L7_21 INV3CK $PINS O=CTS_353 I=CTS_354
XCTS_ccl_a_INV_CLK_G1_L8_20 INV6CK $PINS O=CTS_349 I=CTS_350
XCTS_ccl_a_INV_CLK_G1_L7_20 INV3CK $PINS O=CTS_350 I=CTS_351
XCTS_ccl_a_INV_CLK_G1_L8_19 INV6CK $PINS O=CTS_346 I=CTS_347
XCTS_ccl_a_INV_CLK_G1_L7_19 INV3CK $PINS O=CTS_347 I=CTS_348
XCTS_ccl_a_INV_CLK_G1_L8_18 INV6CK $PINS O=CTS_343 I=CTS_344
XCTS_ccl_a_INV_CLK_G1_L7_18 INV3CK $PINS O=CTS_344 I=CTS_345
XCTS_ccl_a_INV_CLK_G0_L5_2 INV8CK $PINS O=CTS_391 I=clk_clone2
XCTS_ccl_a_INV_CLK_G1_L8_16 INV6CK $PINS O=CTS_340 I=CTS_341
XCTS_ccl_a_INV_CLK_G1_L7_16 INV3CK $PINS O=CTS_341 I=CTS_342
XCTS_ccl_a_INV_CLK_G1_L8_15 INV6CK $PINS O=CTS_337 I=CTS_338
XCTS_ccl_a_INV_CLK_G1_L7_15 INV3CK $PINS O=CTS_338 I=CTS_339
XCTS_ccl_a_INV_CLK_G1_L8_14 INV6CK $PINS O=CTS_334 I=CTS_335
XCTS_ccl_a_INV_CLK_G1_L7_14 INV3CK $PINS O=CTS_335 I=CTS_336
XCTS_ccl_a_INV_CLK_G1_L8_13 INV6CK $PINS O=CTS_331 I=CTS_332
XCTS_ccl_a_INV_CLK_G1_L7_13 INV3CK $PINS O=CTS_332 I=CTS_333
XCTS_ccl_a_INV_CLK_G1_L8_12 INV6CK $PINS O=CTS_328 I=CTS_329
XCTS_ccl_a_INV_CLK_G1_L7_12 INV3CK $PINS O=CTS_329 I=CTS_330
XCTS_ccl_a_INV_CLK_G1_L8_11 INV6CK $PINS O=CTS_325 I=CTS_326
XCTS_ccl_a_INV_CLK_G1_L7_11 INV3CK $PINS O=CTS_326 I=CTS_327
XCTS_ccl_a_INV_CLK_G1_L8_10 INV6CK $PINS O=CTS_322 I=CTS_323
XCTS_ccl_a_INV_CLK_G1_L7_10 INV2CK $PINS O=CTS_323 I=CTS_324
XCTS_ccl_a_INV_CLK_G1_L8_9 INV6CK $PINS O=CTS_319 I=CTS_320
XCTS_ccl_a_INV_CLK_G1_L7_9 INV3CK $PINS O=CTS_320 I=CTS_321
XCTS_ccl_a_INV_CLK_G1_L8_8 INV6CK $PINS O=CTS_316 I=CTS_317
XCTS_ccl_a_INV_CLK_G1_L7_8 INV2CK $PINS O=CTS_317 I=CTS_318
XCTS_ccl_a_INV_CLK_G1_L8_7 INV6CK $PINS O=CTS_313 I=CTS_314
XCTS_ccl_a_INV_CLK_G1_L7_7 INV3CK $PINS O=CTS_314 I=CTS_315
XCTS_ccl_a_INV_CLK_G1_L8_6 INV6CK $PINS O=CTS_310 I=CTS_311
XCTS_ccl_a_INV_CLK_G1_L7_6 INV3CK $PINS O=CTS_311 I=CTS_312
XCTS_ccl_a_INV_CLK_G1_L8_5 INV6CK $PINS O=CTS_307 I=CTS_308
XCTS_ccl_a_INV_CLK_G1_L7_5 INV2CK $PINS O=CTS_308 I=CTS_309
XCTS_ccl_a_INV_CLK_G1_L8_4 INV6CK $PINS O=CTS_304 I=CTS_305
XCTS_ccl_a_INV_CLK_G1_L7_4 INV3CK $PINS O=CTS_305 I=CTS_306
XCTS_ccl_a_INV_CLK_G1_L8_3 INV6CK $PINS O=CTS_301 I=CTS_302
XCTS_ccl_a_INV_CLK_G1_L7_3 INV3CK $PINS O=CTS_302 I=CTS_303
XCTS_ccl_a_INV_CLK_G1_L8_2 INV6CK $PINS O=CTS_298 I=CTS_299
XCTS_ccl_a_INV_CLK_G1_L7_2 INV3CK $PINS O=CTS_299 I=CTS_300
XCTS_ccl_a_INV_CLK_G1_L8_1 INV6CK $PINS O=CTS_295 I=CTS_296
XCTS_ccl_a_INV_CLK_G1_L7_1 INV2CK $PINS O=CTS_296 I=CTS_297
Xbank_raddr_reg[0][3] QDLHN $PINS Q=N30 D=read_addr_1[4] CK=n98
Xbank_raddr_reg[0][2] QDLHN $PINS Q=N29 D=read_addr_1[3] CK=n98
Xbank_raddr_reg[0][1] QDLHN $PINS Q=N28 D=read_addr_1[2] CK=n98
Xbank_raddr_reg[0][0] QDLHN $PINS Q=N27 D=read_addr_1[1] CK=n98
Xbank_raddr_reg[1][3] QDBHN $PINS Q=N34 D=read_addr_1[4] CKB=n98
Xbank_raddr_reg[1][2] QDBHN $PINS Q=N33 D=read_addr_1[3] CKB=n98
Xbank_raddr_reg[1][1] QDBHN $PINS Q=N32 D=read_addr_1[2] CKB=n98
Xbank_raddr_reg[1][0] QDBHN $PINS Q=N31 D=read_addr_1[1] CKB=n98
XU154 ND2 $PINS O=n65 I1=n71 I2=n72
XU155 ND2 $PINS O=n68 I1=n640 I2=n75
XU156 ND2 $PINS O=n69 I1=n641 I2=n76
XU157 ND2 $PINS O=n73 I1=n642 I2=n77
XU158 ND2 $PINS O=n74 I1=n77 I2=n72
XU159 ND2 $PINS O=n70 I1=n75 I2=n76
XU160 ND2 $PINS O=n78 I1=n84 I2=n646
XU161 ND2 $PINS O=n80 I1=n84 I2=n85
XU162 ND2 $PINS O=n86 I1=n88 I2=wen1
XU164 ND2 $PINS O=n81 I1=n645 I2=n91
XU167 ND2 $PINS O=n90 I1=n87 I2=n85
XU168 ND2 $PINS O=n83 I1=n91 I2=n92
XU169 OR2B1 $PINS O=n63 I1=n93 B1=wen2
XU170 AO22 $PINS O=FE_PHN1403_N124 A1=bank_rdata[0][0] A2=n98
+ B1=FE_PHN1040_bank_rdata_1_0 B2=n589
XU171 AO22 $PINS O=FE_PHN1370_N123 A1=bank_rdata[0][1] A2=n98
+ B1=FE_PHN1012_bank_rdata_1_1 B2=n589
XU172 AO22 $PINS O=FE_PHN1378_N122 A1=bank_rdata[0][2] A2=n98
+ B1=bank_rdata[1][2] B2=n589
XU173 AO22 $PINS O=N121 A1=bank_rdata[0][3] A2=n98 B1=bank_rdata[1][3] B2=n589
XU174 AO22 $PINS O=FE_PHN1389_N120 A1=bank_rdata[0][4] A2=n98
+ B1=bank_rdata[1][4] B2=n589
XU175 AO22 $PINS O=N119 A1=bank_rdata[0][5] A2=n98 B1=bank_rdata[1][5] B2=n589
XU176 AO22 $PINS O=FE_PHN1354_N118 A1=bank_rdata[0][6] A2=n98
+ B1=bank_rdata[1][6] B2=n589
XU177 AO22 $PINS O=FE_PHN1387_N117 A1=bank_rdata[0][7] A2=n98
+ B1=FE_PHN1023_bank_rdata_1_7 B2=n589
XU178 AO22 $PINS O=N116 A1=bank_rdata[0][8] A2=n98 B1=FE_PHN1039_bank_rdata_1_8
+ B2=n589
XU179 AO22 $PINS O=FE_PHN1359_N115 A1=bank_rdata[0][9] A2=n98
+ B1=FE_PHN1005_bank_rdata_1_9 B2=n589
XU180 AO22 $PINS O=N114 A1=bank_rdata[0][10] A2=n98
+ B1=FE_PHN1007_bank_rdata_1_10 B2=n589
XU181 AO22 $PINS O=N113 A1=bank_rdata[0][11] A2=n98 B1=bank_rdata[1][11]
+ B2=n589
XU182 AO22 $PINS O=FE_PHN1375_N112 A1=bank_rdata[0][12] A2=n98
+ B1=FE_PHN1016_bank_rdata_1_12 B2=n589
XU183 AO22 $PINS O=N111 A1=bank_rdata[0][13] A2=n98 B1=bank_rdata[1][13]
+ B2=n589
XU184 AO22 $PINS O=N110 A1=bank_rdata[0][14] A2=n98 B1=bank_rdata[1][14]
+ B2=n589
XU185 AO22 $PINS O=N109 A1=bank_rdata[0][15] A2=n98 B1=bank_rdata[1][15]
+ B2=n589
XU186 AO22 $PINS O=N108 A1=bank_rdata[0][16] A2=n98 B1=bank_rdata[1][16]
+ B2=n589
XU187 AO22 $PINS O=FE_PHN1365_N107 A1=bank_rdata[0][17] A2=n98
+ B1=FE_PHN1010_bank_rdata_1_17 B2=n589
XU188 AO22 $PINS O=N106 A1=bank_rdata[0][18] A2=n98 B1=bank_rdata[1][18]
+ B2=n589
XU189 AO22 $PINS O=N105 A1=bank_rdata[0][19] A2=n98
+ B1=FE_PHN1042_bank_rdata_1_19 B2=n589
XU190 AO22 $PINS O=N104 A1=bank_rdata[0][20] A2=n98 B1=bank_rdata[1][20]
+ B2=n589
XU191 AO22 $PINS O=N103 A1=bank_rdata[0][21] A2=n98 B1=bank_rdata[1][21]
+ B2=n589
XU192 XOR4 $PINS O=n98 I1=read_addr_1[1] I2=read_addr_1[0] I3=n94
+ I4=read_addr_1[2]
XU193 ND2 $PINS O=n67 I1=n642 I2=n71
XU194 ND2 $PINS O=n95 I1=wen1 I2=n643
XU195 ND2 $PINS O=n66 I1=n640 I2=n641
XU196 XOR4 $PINS O=n88 I1=write_addr_1[2] I2=n96 I3=n651 I4=write_addr_1[0]
XU198 XOR4 $PINS O=n93 I1=n649 I2=n97 I3=p_1 I4=write_addr_2[0]
Xbank_mem_1_reg[6][21] QDFFN $PINS Q=bank_mem_1[6][21] D=bank_wdata[1][21]
+ CK=CTS_370
Xbank_mem_1_reg[6][20] QDFFN $PINS Q=bank_mem_1[6][20] D=bank_wdata[1][20]
+ CK=CTS_370
Xbank_mem_1_reg[6][19] QDFFN $PINS Q=bank_mem_1[6][19] D=bank_wdata[1][19]
+ CK=CTS_370
Xbank_mem_1_reg[6][18] QDFFN $PINS Q=bank_mem_1[6][18] D=bank_wdata[1][18]
+ CK=CTS_370
Xbank_mem_1_reg[6][17] QDFFN $PINS Q=bank_mem_1[6][17] D=bank_wdata[1][17]
+ CK=CTS_370
Xbank_mem_1_reg[6][16] QDFFN $PINS Q=bank_mem_1[6][16] D=bank_wdata[1][16]
+ CK=CTS_370
Xbank_mem_1_reg[6][15] QDFFN $PINS Q=bank_mem_1[6][15] D=bank_wdata[1][15]
+ CK=CTS_370
Xbank_mem_1_reg[6][14] QDFFN $PINS Q=bank_mem_1[6][14] D=bank_wdata[1][14]
+ CK=CTS_370
Xbank_mem_1_reg[6][13] QDFFN $PINS Q=bank_mem_1[6][13] D=bank_wdata[1][13]
+ CK=CTS_370
Xbank_mem_1_reg[6][12] QDFFN $PINS Q=bank_mem_1[6][12] D=bank_wdata[1][12]
+ CK=CTS_370
Xbank_mem_1_reg[6][11] QDFFN $PINS Q=bank_mem_1[6][11] D=bank_wdata[1][11]
+ CK=CTS_370
Xbank_mem_1_reg[6][10] QDFFN $PINS Q=bank_mem_1[6][10] D=bank_wdata[1][10]
+ CK=CTS_370
Xbank_mem_1_reg[6][9] QDFFN $PINS Q=bank_mem_1[6][9] D=bank_wdata[1][9]
+ CK=CTS_370
Xbank_mem_1_reg[6][8] QDFFN $PINS Q=bank_mem_1[6][8] D=bank_wdata[1][8]
+ CK=CTS_370
Xbank_mem_1_reg[6][7] QDFFN $PINS Q=bank_mem_1[6][7] D=bank_wdata[1][7]
+ CK=CTS_370
Xbank_mem_1_reg[6][6] QDFFN $PINS Q=bank_mem_1[6][6] D=bank_wdata[1][6]
+ CK=CTS_370
Xbank_mem_1_reg[6][5] QDFFN $PINS Q=bank_mem_1[6][5] D=bank_wdata[1][5]
+ CK=CTS_370
Xbank_mem_1_reg[6][4] QDFFN $PINS Q=bank_mem_1[6][4] D=bank_wdata[1][4]
+ CK=CTS_370
Xbank_mem_1_reg[6][3] QDFFN $PINS Q=bank_mem_1[6][3] D=bank_wdata[1][3]
+ CK=CTS_370
Xbank_mem_1_reg[6][2] QDFFN $PINS Q=bank_mem_1[6][2] D=bank_wdata[1][2]
+ CK=CTS_370
Xbank_mem_1_reg[6][1] QDFFN $PINS Q=bank_mem_1[6][1] D=bank_wdata[1][1]
+ CK=CTS_370
Xbank_mem_1_reg[6][0] QDFFN $PINS Q=bank_mem_1[6][0] D=bank_wdata[1][0]
+ CK=CTS_370
Xbank_mem_1_reg[7][20] QDFFN $PINS Q=bank_mem_1[7][20] D=bank_wdata[1][20]
+ CK=CTS_367
Xbank_mem_1_reg[7][19] QDFFN $PINS Q=bank_mem_1[7][19] D=bank_wdata[1][19]
+ CK=CTS_367
Xbank_mem_1_reg[7][18] QDFFN $PINS Q=bank_mem_1[7][18] D=bank_wdata[1][18]
+ CK=CTS_367
Xbank_mem_1_reg[7][17] QDFFN $PINS Q=bank_mem_1[7][17] D=bank_wdata[1][17]
+ CK=CTS_367
Xbank_mem_1_reg[7][16] QDFFN $PINS Q=bank_mem_1[7][16] D=bank_wdata[1][16]
+ CK=CTS_367
Xbank_mem_1_reg[7][15] QDFFN $PINS Q=bank_mem_1[7][15] D=bank_wdata[1][15]
+ CK=CTS_367
Xbank_mem_1_reg[7][14] QDFFN $PINS Q=bank_mem_1[7][14] D=bank_wdata[1][14]
+ CK=CTS_367
Xbank_mem_1_reg[7][13] QDFFN $PINS Q=bank_mem_1[7][13] D=bank_wdata[1][13]
+ CK=CTS_367
Xbank_mem_1_reg[7][12] QDFFN $PINS Q=bank_mem_1[7][12] D=bank_wdata[1][12]
+ CK=CTS_367
Xbank_mem_1_reg[7][11] QDFFN $PINS Q=bank_mem_1[7][11] D=bank_wdata[1][11]
+ CK=CTS_367
Xbank_mem_1_reg[7][10] QDFFN $PINS Q=bank_mem_1[7][10] D=bank_wdata[1][10]
+ CK=CTS_367
Xbank_mem_1_reg[7][9] QDFFN $PINS Q=bank_mem_1[7][9] D=bank_wdata[1][9]
+ CK=CTS_367
Xbank_mem_1_reg[7][8] QDFFN $PINS Q=bank_mem_1[7][8] D=bank_wdata[1][8]
+ CK=CTS_367
Xbank_mem_1_reg[7][7] QDFFN $PINS Q=bank_mem_1[7][7] D=bank_wdata[1][7]
+ CK=CTS_367
Xbank_mem_1_reg[7][6] QDFFN $PINS Q=bank_mem_1[7][6] D=bank_wdata[1][6]
+ CK=CTS_367
Xbank_mem_1_reg[7][5] QDFFN $PINS Q=bank_mem_1[7][5] D=bank_wdata[1][5]
+ CK=CTS_367
Xbank_mem_1_reg[7][4] QDFFN $PINS Q=bank_mem_1[7][4] D=bank_wdata[1][4]
+ CK=CTS_367
Xbank_mem_1_reg[7][3] QDFFN $PINS Q=bank_mem_1[7][3] D=bank_wdata[1][3]
+ CK=CTS_367
Xbank_mem_1_reg[7][2] QDFFN $PINS Q=bank_mem_1[7][2] D=bank_wdata[1][2]
+ CK=CTS_367
Xbank_mem_1_reg[7][1] QDFFN $PINS Q=bank_mem_1[7][1] D=bank_wdata[1][1]
+ CK=CTS_367
Xbank_mem_1_reg[7][0] QDFFN $PINS Q=bank_mem_1[7][0] D=bank_wdata[1][0]
+ CK=CTS_367
Xbank_mem_1_reg[7][21] QDFFN $PINS Q=bank_mem_1[7][21] D=bank_wdata[1][21]
+ CK=CTS_367
Xbank_mem_1_reg[5][21] QDFFN $PINS Q=bank_mem_1[5][21] D=bank_wdata[1][21]
+ CK=CTS_373
Xbank_mem_1_reg[5][20] QDFFN $PINS Q=bank_mem_1[5][20] D=bank_wdata[1][20]
+ CK=CTS_373
Xbank_mem_1_reg[5][19] QDFFN $PINS Q=bank_mem_1[5][19] D=bank_wdata[1][19]
+ CK=CTS_373
Xbank_mem_1_reg[5][18] QDFFN $PINS Q=bank_mem_1[5][18] D=bank_wdata[1][18]
+ CK=CTS_373
Xbank_mem_1_reg[5][17] QDFFN $PINS Q=bank_mem_1[5][17] D=bank_wdata[1][17]
+ CK=CTS_373
Xbank_mem_1_reg[5][16] QDFFN $PINS Q=bank_mem_1[5][16] D=bank_wdata[1][16]
+ CK=CTS_373
Xbank_mem_1_reg[5][15] QDFFN $PINS Q=bank_mem_1[5][15] D=bank_wdata[1][15]
+ CK=CTS_373
Xbank_mem_1_reg[5][14] QDFFN $PINS Q=bank_mem_1[5][14] D=bank_wdata[1][14]
+ CK=CTS_373
Xbank_mem_1_reg[5][13] QDFFN $PINS Q=bank_mem_1[5][13] D=bank_wdata[1][13]
+ CK=CTS_373
Xbank_mem_1_reg[5][12] QDFFN $PINS Q=bank_mem_1[5][12] D=bank_wdata[1][12]
+ CK=CTS_373
Xbank_mem_1_reg[5][11] QDFFN $PINS Q=bank_mem_1[5][11] D=bank_wdata[1][11]
+ CK=CTS_373
Xbank_mem_1_reg[5][10] QDFFN $PINS Q=bank_mem_1[5][10] D=bank_wdata[1][10]
+ CK=CTS_373
Xbank_mem_1_reg[5][9] QDFFN $PINS Q=bank_mem_1[5][9] D=bank_wdata[1][9]
+ CK=CTS_373
Xbank_mem_1_reg[5][8] QDFFN $PINS Q=bank_mem_1[5][8] D=bank_wdata[1][8]
+ CK=CTS_373
Xbank_mem_1_reg[5][7] QDFFN $PINS Q=bank_mem_1[5][7] D=bank_wdata[1][7]
+ CK=CTS_373
Xbank_mem_1_reg[5][6] QDFFN $PINS Q=bank_mem_1[5][6] D=bank_wdata[1][6]
+ CK=CTS_373
Xbank_mem_1_reg[5][5] QDFFN $PINS Q=bank_mem_1[5][5] D=bank_wdata[1][5]
+ CK=CTS_373
Xbank_mem_1_reg[5][4] QDFFN $PINS Q=bank_mem_1[5][4] D=bank_wdata[1][4]
+ CK=CTS_373
Xbank_mem_1_reg[5][3] QDFFN $PINS Q=bank_mem_1[5][3] D=bank_wdata[1][3]
+ CK=CTS_373
Xbank_mem_1_reg[5][2] QDFFN $PINS Q=bank_mem_1[5][2] D=bank_wdata[1][2]
+ CK=CTS_373
Xbank_mem_1_reg[5][1] QDFFN $PINS Q=bank_mem_1[5][1] D=bank_wdata[1][1]
+ CK=CTS_373
Xbank_mem_1_reg[5][0] QDFFN $PINS Q=bank_mem_1[5][0] D=bank_wdata[1][0]
+ CK=CTS_373
Xbank_mem_0_reg[6][21] QDFFN $PINS Q=bank_mem_0[6][21] D=bank_wdata[0][21]
+ CK=CTS_322
Xbank_mem_0_reg[6][20] QDFFN $PINS Q=bank_mem_0[6][20] D=bank_wdata[0][20]
+ CK=CTS_322
Xbank_mem_0_reg[6][19] QDFFN $PINS Q=bank_mem_0[6][19] D=bank_wdata[0][19]
+ CK=CTS_322
Xbank_mem_0_reg[6][18] QDFFN $PINS Q=bank_mem_0[6][18] D=bank_wdata[0][18]
+ CK=CTS_322
Xbank_mem_0_reg[6][17] QDFFN $PINS Q=bank_mem_0[6][17] D=bank_wdata[0][17]
+ CK=CTS_322
Xbank_mem_0_reg[6][16] QDFFN $PINS Q=bank_mem_0[6][16] D=bank_wdata[0][16]
+ CK=CTS_322
Xbank_mem_0_reg[6][15] QDFFN $PINS Q=bank_mem_0[6][15] D=bank_wdata[0][15]
+ CK=CTS_322
Xbank_mem_0_reg[6][14] QDFFN $PINS Q=bank_mem_0[6][14] D=bank_wdata[0][14]
+ CK=CTS_322
Xbank_mem_0_reg[6][13] QDFFN $PINS Q=bank_mem_0[6][13] D=bank_wdata[0][13]
+ CK=CTS_322
Xbank_mem_0_reg[6][12] QDFFN $PINS Q=bank_mem_0[6][12] D=bank_wdata[0][12]
+ CK=CTS_322
Xbank_mem_0_reg[6][11] QDFFN $PINS Q=bank_mem_0[6][11] D=bank_wdata[0][11]
+ CK=CTS_322
Xbank_mem_0_reg[6][10] QDFFN $PINS Q=bank_mem_0[6][10] D=bank_wdata[0][10]
+ CK=CTS_322
Xbank_mem_0_reg[6][9] QDFFN $PINS Q=bank_mem_0[6][9] D=bank_wdata[0][9]
+ CK=CTS_322
Xbank_mem_0_reg[6][8] QDFFN $PINS Q=bank_mem_0[6][8] D=bank_wdata[0][8]
+ CK=CTS_322
Xbank_mem_0_reg[6][7] QDFFN $PINS Q=bank_mem_0[6][7] D=bank_wdata[0][7]
+ CK=CTS_322
Xbank_mem_0_reg[6][6] QDFFN $PINS Q=bank_mem_0[6][6] D=bank_wdata[0][6]
+ CK=CTS_322
Xbank_mem_0_reg[6][5] QDFFN $PINS Q=bank_mem_0[6][5] D=bank_wdata[0][5]
+ CK=CTS_322
Xbank_mem_0_reg[6][4] QDFFN $PINS Q=bank_mem_0[6][4] D=bank_wdata[0][4]
+ CK=CTS_322
Xbank_mem_0_reg[6][3] QDFFN $PINS Q=bank_mem_0[6][3] D=bank_wdata[0][3]
+ CK=CTS_322
Xbank_mem_0_reg[6][2] QDFFN $PINS Q=bank_mem_0[6][2] D=bank_wdata[0][2]
+ CK=CTS_322
Xbank_mem_0_reg[6][1] QDFFN $PINS Q=bank_mem_0[6][1] D=bank_wdata[0][1]
+ CK=CTS_322
Xbank_mem_0_reg[6][0] QDFFN $PINS Q=bank_mem_0[6][0] D=bank_wdata[0][0]
+ CK=CTS_322
Xbank_mem_0_reg[7][20] QDFFN $PINS Q=bank_mem_0[7][20] D=bank_wdata[0][20]
+ CK=CTS_319
Xbank_mem_0_reg[7][19] QDFFN $PINS Q=bank_mem_0[7][19] D=bank_wdata[0][19]
+ CK=CTS_319
Xbank_mem_0_reg[7][18] QDFFN $PINS Q=bank_mem_0[7][18] D=bank_wdata[0][18]
+ CK=CTS_319
Xbank_mem_0_reg[7][17] QDFFN $PINS Q=bank_mem_0[7][17] D=bank_wdata[0][17]
+ CK=CTS_319
Xbank_mem_0_reg[7][16] QDFFN $PINS Q=bank_mem_0[7][16] D=bank_wdata[0][16]
+ CK=CTS_319
Xbank_mem_0_reg[7][15] QDFFN $PINS Q=bank_mem_0[7][15] D=bank_wdata[0][15]
+ CK=CTS_319
Xbank_mem_0_reg[7][14] QDFFN $PINS Q=bank_mem_0[7][14] D=bank_wdata[0][14]
+ CK=CTS_319
Xbank_mem_0_reg[7][13] QDFFN $PINS Q=bank_mem_0[7][13] D=bank_wdata[0][13]
+ CK=CTS_319
Xbank_mem_0_reg[7][12] QDFFN $PINS Q=bank_mem_0[7][12] D=bank_wdata[0][12]
+ CK=CTS_319
Xbank_mem_0_reg[7][11] QDFFN $PINS Q=bank_mem_0[7][11] D=bank_wdata[0][11]
+ CK=CTS_319
Xbank_mem_0_reg[7][10] QDFFN $PINS Q=bank_mem_0[7][10] D=bank_wdata[0][10]
+ CK=CTS_319
Xbank_mem_0_reg[7][9] QDFFN $PINS Q=bank_mem_0[7][9] D=bank_wdata[0][9]
+ CK=CTS_319
Xbank_mem_0_reg[7][8] QDFFN $PINS Q=bank_mem_0[7][8] D=bank_wdata[0][8]
+ CK=CTS_319
Xbank_mem_0_reg[7][7] QDFFN $PINS Q=bank_mem_0[7][7] D=bank_wdata[0][7]
+ CK=CTS_319
Xbank_mem_0_reg[7][6] QDFFN $PINS Q=bank_mem_0[7][6] D=bank_wdata[0][6]
+ CK=CTS_319
Xbank_mem_0_reg[7][5] QDFFN $PINS Q=bank_mem_0[7][5] D=bank_wdata[0][5]
+ CK=CTS_319
Xbank_mem_0_reg[7][4] QDFFN $PINS Q=bank_mem_0[7][4] D=bank_wdata[0][4]
+ CK=CTS_319
Xbank_mem_0_reg[7][3] QDFFN $PINS Q=bank_mem_0[7][3] D=bank_wdata[0][3]
+ CK=CTS_319
Xbank_mem_0_reg[7][2] QDFFN $PINS Q=bank_mem_0[7][2] D=bank_wdata[0][2]
+ CK=CTS_319
Xbank_mem_0_reg[7][1] QDFFN $PINS Q=bank_mem_0[7][1] D=bank_wdata[0][1]
+ CK=CTS_319
Xbank_mem_0_reg[7][0] QDFFN $PINS Q=bank_mem_0[7][0] D=bank_wdata[0][0]
+ CK=CTS_319
Xbank_mem_0_reg[7][21] QDFFN $PINS Q=bank_mem_0[7][21] D=bank_wdata[0][21]
+ CK=CTS_319
Xbank_mem_0_reg[5][21] QDFFN $PINS Q=bank_mem_0[5][21] D=bank_wdata[0][21]
+ CK=CTS_325
Xbank_mem_0_reg[5][20] QDFFN $PINS Q=bank_mem_0[5][20] D=bank_wdata[0][20]
+ CK=CTS_325
Xbank_mem_0_reg[5][19] QDFFN $PINS Q=bank_mem_0[5][19] D=bank_wdata[0][19]
+ CK=CTS_325
Xbank_mem_0_reg[5][18] QDFFN $PINS Q=bank_mem_0[5][18] D=bank_wdata[0][18]
+ CK=CTS_325
Xbank_mem_0_reg[5][17] QDFFN $PINS Q=bank_mem_0[5][17] D=bank_wdata[0][17]
+ CK=CTS_325
Xbank_mem_0_reg[5][16] QDFFN $PINS Q=bank_mem_0[5][16] D=bank_wdata[0][16]
+ CK=CTS_325
Xbank_mem_0_reg[5][15] QDFFN $PINS Q=bank_mem_0[5][15] D=bank_wdata[0][15]
+ CK=CTS_325
Xbank_mem_0_reg[5][14] QDFFN $PINS Q=bank_mem_0[5][14] D=bank_wdata[0][14]
+ CK=CTS_325
Xbank_mem_0_reg[5][13] QDFFN $PINS Q=bank_mem_0[5][13] D=bank_wdata[0][13]
+ CK=CTS_325
Xbank_mem_0_reg[5][12] QDFFN $PINS Q=bank_mem_0[5][12] D=bank_wdata[0][12]
+ CK=CTS_325
Xbank_mem_0_reg[5][11] QDFFN $PINS Q=bank_mem_0[5][11] D=bank_wdata[0][11]
+ CK=CTS_325
Xbank_mem_0_reg[5][10] QDFFN $PINS Q=bank_mem_0[5][10] D=bank_wdata[0][10]
+ CK=CTS_325
Xbank_mem_0_reg[5][9] QDFFN $PINS Q=bank_mem_0[5][9] D=bank_wdata[0][9]
+ CK=CTS_325
Xbank_mem_0_reg[5][8] QDFFN $PINS Q=bank_mem_0[5][8] D=bank_wdata[0][8]
+ CK=CTS_325
Xbank_mem_0_reg[5][7] QDFFN $PINS Q=bank_mem_0[5][7] D=bank_wdata[0][7]
+ CK=CTS_325
Xbank_mem_0_reg[5][6] QDFFN $PINS Q=bank_mem_0[5][6] D=bank_wdata[0][6]
+ CK=CTS_325
Xbank_mem_0_reg[5][5] QDFFN $PINS Q=bank_mem_0[5][5] D=bank_wdata[0][5]
+ CK=CTS_325
Xbank_mem_0_reg[5][4] QDFFN $PINS Q=bank_mem_0[5][4] D=bank_wdata[0][4]
+ CK=CTS_325
Xbank_mem_0_reg[5][3] QDFFN $PINS Q=bank_mem_0[5][3] D=bank_wdata[0][3]
+ CK=CTS_325
Xbank_mem_0_reg[5][2] QDFFN $PINS Q=bank_mem_0[5][2] D=bank_wdata[0][2]
+ CK=CTS_325
Xbank_mem_0_reg[5][1] QDFFN $PINS Q=bank_mem_0[5][1] D=bank_wdata[0][1]
+ CK=CTS_325
Xbank_mem_0_reg[5][0] QDFFN $PINS Q=bank_mem_0[5][0] D=bank_wdata[0][0]
+ CK=CTS_325
Xbank_mem_1_reg[3][21] QDFFN $PINS Q=bank_mem_1[3][21] D=bank_wdata[1][21]
+ CK=CTS_379
Xbank_mem_1_reg[3][20] QDFFN $PINS Q=bank_mem_1[3][20] D=bank_wdata[1][20]
+ CK=CTS_379
Xbank_mem_1_reg[3][19] QDFFN $PINS Q=bank_mem_1[3][19] D=bank_wdata[1][19]
+ CK=CTS_379
Xbank_mem_1_reg[3][18] QDFFN $PINS Q=bank_mem_1[3][18] D=bank_wdata[1][18]
+ CK=CTS_379
Xbank_mem_1_reg[3][17] QDFFN $PINS Q=bank_mem_1[3][17] D=bank_wdata[1][17]
+ CK=CTS_379
Xbank_mem_1_reg[3][16] QDFFN $PINS Q=bank_mem_1[3][16] D=bank_wdata[1][16]
+ CK=CTS_379
Xbank_mem_1_reg[3][15] QDFFN $PINS Q=bank_mem_1[3][15] D=bank_wdata[1][15]
+ CK=CTS_379
Xbank_mem_1_reg[3][14] QDFFN $PINS Q=bank_mem_1[3][14] D=bank_wdata[1][14]
+ CK=CTS_379
Xbank_mem_1_reg[3][13] QDFFN $PINS Q=bank_mem_1[3][13] D=bank_wdata[1][13]
+ CK=CTS_379
Xbank_mem_1_reg[3][12] QDFFN $PINS Q=bank_mem_1[3][12] D=bank_wdata[1][12]
+ CK=CTS_379
Xbank_mem_1_reg[3][11] QDFFN $PINS Q=bank_mem_1[3][11] D=bank_wdata[1][11]
+ CK=CTS_379
Xbank_mem_1_reg[3][10] QDFFN $PINS Q=bank_mem_1[3][10] D=bank_wdata[1][10]
+ CK=CTS_379
Xbank_mem_1_reg[3][9] QDFFN $PINS Q=bank_mem_1[3][9] D=bank_wdata[1][9]
+ CK=CTS_379
Xbank_mem_1_reg[3][8] QDFFN $PINS Q=bank_mem_1[3][8] D=bank_wdata[1][8]
+ CK=CTS_379
Xbank_mem_1_reg[3][7] QDFFN $PINS Q=bank_mem_1[3][7] D=bank_wdata[1][7]
+ CK=CTS_379
Xbank_mem_1_reg[3][6] QDFFN $PINS Q=bank_mem_1[3][6] D=bank_wdata[1][6]
+ CK=CTS_379
Xbank_mem_1_reg[3][5] QDFFN $PINS Q=bank_mem_1[3][5] D=bank_wdata[1][5]
+ CK=CTS_379
Xbank_mem_1_reg[3][4] QDFFN $PINS Q=bank_mem_1[3][4] D=bank_wdata[1][4]
+ CK=CTS_379
Xbank_mem_1_reg[3][3] QDFFN $PINS Q=bank_mem_1[3][3] D=bank_wdata[1][3]
+ CK=CTS_379
Xbank_mem_1_reg[3][2] QDFFN $PINS Q=bank_mem_1[3][2] D=bank_wdata[1][2]
+ CK=CTS_379
Xbank_mem_1_reg[3][1] QDFFN $PINS Q=bank_mem_1[3][1] D=bank_wdata[1][1]
+ CK=CTS_379
Xbank_mem_1_reg[3][0] QDFFN $PINS Q=bank_mem_1[3][0] D=bank_wdata[1][0]
+ CK=CTS_379
Xbank_mem_0_reg[3][21] QDFFN $PINS Q=bank_mem_0[3][21] D=bank_wdata[0][21]
+ CK=CTS_331
Xbank_mem_0_reg[3][20] QDFFN $PINS Q=bank_mem_0[3][20] D=bank_wdata[0][20]
+ CK=CTS_331
Xbank_mem_0_reg[3][19] QDFFN $PINS Q=bank_mem_0[3][19] D=bank_wdata[0][19]
+ CK=CTS_331
Xbank_mem_0_reg[3][18] QDFFN $PINS Q=bank_mem_0[3][18] D=bank_wdata[0][18]
+ CK=CTS_331
Xbank_mem_0_reg[3][17] QDFFN $PINS Q=bank_mem_0[3][17] D=bank_wdata[0][17]
+ CK=CTS_331
Xbank_mem_0_reg[3][16] QDFFN $PINS Q=bank_mem_0[3][16] D=bank_wdata[0][16]
+ CK=CTS_331
Xbank_mem_0_reg[3][15] QDFFN $PINS Q=bank_mem_0[3][15] D=bank_wdata[0][15]
+ CK=CTS_331
Xbank_mem_0_reg[3][14] QDFFN $PINS Q=bank_mem_0[3][14] D=bank_wdata[0][14]
+ CK=CTS_331
Xbank_mem_0_reg[3][13] QDFFN $PINS Q=bank_mem_0[3][13] D=bank_wdata[0][13]
+ CK=CTS_331
Xbank_mem_0_reg[3][12] QDFFN $PINS Q=bank_mem_0[3][12] D=bank_wdata[0][12]
+ CK=CTS_331
Xbank_mem_0_reg[3][11] QDFFN $PINS Q=bank_mem_0[3][11] D=bank_wdata[0][11]
+ CK=CTS_331
Xbank_mem_0_reg[3][10] QDFFN $PINS Q=bank_mem_0[3][10] D=bank_wdata[0][10]
+ CK=CTS_331
Xbank_mem_0_reg[3][9] QDFFN $PINS Q=bank_mem_0[3][9] D=bank_wdata[0][9]
+ CK=CTS_331
Xbank_mem_0_reg[3][8] QDFFN $PINS Q=bank_mem_0[3][8] D=bank_wdata[0][8]
+ CK=CTS_331
Xbank_mem_0_reg[3][7] QDFFN $PINS Q=bank_mem_0[3][7] D=bank_wdata[0][7]
+ CK=CTS_331
Xbank_mem_0_reg[3][6] QDFFN $PINS Q=bank_mem_0[3][6] D=bank_wdata[0][6]
+ CK=CTS_331
Xbank_mem_0_reg[3][5] QDFFN $PINS Q=bank_mem_0[3][5] D=bank_wdata[0][5]
+ CK=CTS_331
Xbank_mem_0_reg[3][4] QDFFN $PINS Q=bank_mem_0[3][4] D=bank_wdata[0][4]
+ CK=CTS_331
Xbank_mem_0_reg[3][3] QDFFN $PINS Q=bank_mem_0[3][3] D=bank_wdata[0][3]
+ CK=CTS_331
Xbank_mem_0_reg[3][2] QDFFN $PINS Q=bank_mem_0[3][2] D=bank_wdata[0][2]
+ CK=CTS_331
Xbank_mem_0_reg[3][1] QDFFN $PINS Q=bank_mem_0[3][1] D=bank_wdata[0][1]
+ CK=CTS_331
Xbank_mem_0_reg[3][0] QDFFN $PINS Q=bank_mem_0[3][0] D=bank_wdata[0][0]
+ CK=CTS_331
Xbank_mem_1_reg[4][21] QDFFN $PINS Q=bank_mem_1[4][21] D=bank_wdata[1][21]
+ CK=CTS_376
Xbank_mem_1_reg[4][20] QDFFN $PINS Q=bank_mem_1[4][20] D=bank_wdata[1][20]
+ CK=CTS_376
Xbank_mem_1_reg[4][19] QDFFN $PINS Q=bank_mem_1[4][19] D=bank_wdata[1][19]
+ CK=CTS_376
Xbank_mem_1_reg[4][18] QDFFN $PINS Q=bank_mem_1[4][18] D=bank_wdata[1][18]
+ CK=CTS_376
Xbank_mem_1_reg[4][17] QDFFN $PINS Q=bank_mem_1[4][17] D=bank_wdata[1][17]
+ CK=CTS_376
Xbank_mem_1_reg[4][16] QDFFN $PINS Q=bank_mem_1[4][16] D=bank_wdata[1][16]
+ CK=CTS_376
Xbank_mem_1_reg[4][15] QDFFN $PINS Q=bank_mem_1[4][15] D=bank_wdata[1][15]
+ CK=CTS_376
Xbank_mem_1_reg[4][14] QDFFN $PINS Q=bank_mem_1[4][14] D=bank_wdata[1][14]
+ CK=CTS_376
Xbank_mem_1_reg[4][13] QDFFN $PINS Q=bank_mem_1[4][13] D=bank_wdata[1][13]
+ CK=CTS_376
Xbank_mem_1_reg[4][12] QDFFN $PINS Q=bank_mem_1[4][12] D=bank_wdata[1][12]
+ CK=CTS_376
Xbank_mem_1_reg[4][11] QDFFN $PINS Q=bank_mem_1[4][11] D=bank_wdata[1][11]
+ CK=CTS_376
Xbank_mem_1_reg[4][10] QDFFN $PINS Q=bank_mem_1[4][10] D=bank_wdata[1][10]
+ CK=CTS_376
Xbank_mem_1_reg[4][9] QDFFN $PINS Q=bank_mem_1[4][9] D=bank_wdata[1][9]
+ CK=CTS_376
Xbank_mem_1_reg[4][8] QDFFN $PINS Q=bank_mem_1[4][8] D=bank_wdata[1][8]
+ CK=CTS_376
Xbank_mem_1_reg[4][7] QDFFN $PINS Q=bank_mem_1[4][7] D=bank_wdata[1][7]
+ CK=CTS_376
Xbank_mem_1_reg[4][6] QDFFN $PINS Q=bank_mem_1[4][6] D=bank_wdata[1][6]
+ CK=CTS_376
Xbank_mem_1_reg[4][5] QDFFN $PINS Q=bank_mem_1[4][5] D=bank_wdata[1][5]
+ CK=CTS_376
Xbank_mem_1_reg[4][4] QDFFN $PINS Q=bank_mem_1[4][4] D=bank_wdata[1][4]
+ CK=CTS_376
Xbank_mem_1_reg[4][3] QDFFN $PINS Q=bank_mem_1[4][3] D=bank_wdata[1][3]
+ CK=CTS_376
Xbank_mem_1_reg[4][2] QDFFN $PINS Q=bank_mem_1[4][2] D=bank_wdata[1][2]
+ CK=CTS_376
Xbank_mem_1_reg[4][1] QDFFN $PINS Q=bank_mem_1[4][1] D=bank_wdata[1][1]
+ CK=CTS_376
Xbank_mem_1_reg[4][0] QDFFN $PINS Q=bank_mem_1[4][0] D=bank_wdata[1][0]
+ CK=CTS_376
Xbank_mem_1_reg[2][21] QDFFN $PINS Q=bank_mem_1[2][21] D=bank_wdata[1][21]
+ CK=CTS_382
Xbank_mem_1_reg[2][20] QDFFN $PINS Q=bank_mem_1[2][20] D=bank_wdata[1][20]
+ CK=CTS_382
Xbank_mem_1_reg[2][19] QDFFN $PINS Q=bank_mem_1[2][19] D=bank_wdata[1][19]
+ CK=CTS_382
Xbank_mem_1_reg[2][18] QDFFN $PINS Q=bank_mem_1[2][18] D=bank_wdata[1][18]
+ CK=CTS_382
Xbank_mem_1_reg[2][17] QDFFN $PINS Q=bank_mem_1[2][17] D=bank_wdata[1][17]
+ CK=CTS_382
Xbank_mem_1_reg[2][16] QDFFN $PINS Q=bank_mem_1[2][16] D=bank_wdata[1][16]
+ CK=CTS_382
Xbank_mem_1_reg[2][15] QDFFN $PINS Q=bank_mem_1[2][15] D=bank_wdata[1][15]
+ CK=CTS_382
Xbank_mem_1_reg[2][14] QDFFN $PINS Q=bank_mem_1[2][14] D=bank_wdata[1][14]
+ CK=CTS_382
Xbank_mem_1_reg[2][13] QDFFN $PINS Q=bank_mem_1[2][13] D=bank_wdata[1][13]
+ CK=CTS_382
Xbank_mem_1_reg[2][12] QDFFN $PINS Q=bank_mem_1[2][12] D=bank_wdata[1][12]
+ CK=CTS_382
Xbank_mem_1_reg[2][11] QDFFN $PINS Q=bank_mem_1[2][11] D=bank_wdata[1][11]
+ CK=CTS_382
Xbank_mem_1_reg[2][10] QDFFN $PINS Q=bank_mem_1[2][10] D=bank_wdata[1][10]
+ CK=CTS_382
Xbank_mem_1_reg[2][9] QDFFN $PINS Q=bank_mem_1[2][9] D=bank_wdata[1][9]
+ CK=CTS_382
Xbank_mem_1_reg[2][8] QDFFN $PINS Q=bank_mem_1[2][8] D=bank_wdata[1][8]
+ CK=CTS_382
Xbank_mem_1_reg[2][7] QDFFN $PINS Q=bank_mem_1[2][7] D=bank_wdata[1][7]
+ CK=CTS_382
Xbank_mem_1_reg[2][6] QDFFN $PINS Q=bank_mem_1[2][6] D=bank_wdata[1][6]
+ CK=CTS_382
Xbank_mem_1_reg[2][5] QDFFN $PINS Q=bank_mem_1[2][5] D=bank_wdata[1][5]
+ CK=CTS_382
Xbank_mem_1_reg[2][4] QDFFN $PINS Q=bank_mem_1[2][4] D=bank_wdata[1][4]
+ CK=CTS_382
Xbank_mem_1_reg[2][3] QDFFN $PINS Q=bank_mem_1[2][3] D=bank_wdata[1][3]
+ CK=CTS_382
Xbank_mem_1_reg[2][2] QDFFN $PINS Q=bank_mem_1[2][2] D=bank_wdata[1][2]
+ CK=CTS_382
Xbank_mem_1_reg[2][1] QDFFN $PINS Q=bank_mem_1[2][1] D=bank_wdata[1][1]
+ CK=CTS_382
Xbank_mem_1_reg[2][0] QDFFN $PINS Q=bank_mem_1[2][0] D=bank_wdata[1][0]
+ CK=CTS_382
Xbank_mem_0_reg[4][21] QDFFN $PINS Q=bank_mem_0[4][21] D=bank_wdata[0][21]
+ CK=CTS_328
Xbank_mem_0_reg[4][20] QDFFN $PINS Q=bank_mem_0[4][20] D=bank_wdata[0][20]
+ CK=CTS_328
Xbank_mem_0_reg[4][19] QDFFN $PINS Q=bank_mem_0[4][19] D=bank_wdata[0][19]
+ CK=CTS_328
Xbank_mem_0_reg[4][18] QDFFN $PINS Q=bank_mem_0[4][18] D=bank_wdata[0][18]
+ CK=CTS_328
Xbank_mem_0_reg[4][17] QDFFN $PINS Q=bank_mem_0[4][17] D=bank_wdata[0][17]
+ CK=CTS_328
Xbank_mem_0_reg[4][16] QDFFN $PINS Q=bank_mem_0[4][16] D=bank_wdata[0][16]
+ CK=CTS_328
Xbank_mem_0_reg[4][15] QDFFN $PINS Q=bank_mem_0[4][15] D=bank_wdata[0][15]
+ CK=CTS_328
Xbank_mem_0_reg[4][14] QDFFN $PINS Q=bank_mem_0[4][14] D=bank_wdata[0][14]
+ CK=CTS_328
Xbank_mem_0_reg[4][13] QDFFN $PINS Q=bank_mem_0[4][13] D=bank_wdata[0][13]
+ CK=CTS_328
Xbank_mem_0_reg[4][12] QDFFN $PINS Q=bank_mem_0[4][12] D=bank_wdata[0][12]
+ CK=CTS_328
Xbank_mem_0_reg[4][11] QDFFN $PINS Q=bank_mem_0[4][11] D=bank_wdata[0][11]
+ CK=CTS_328
Xbank_mem_0_reg[4][10] QDFFN $PINS Q=bank_mem_0[4][10] D=bank_wdata[0][10]
+ CK=CTS_328
Xbank_mem_0_reg[4][9] QDFFN $PINS Q=bank_mem_0[4][9] D=bank_wdata[0][9]
+ CK=CTS_328
Xbank_mem_0_reg[4][8] QDFFN $PINS Q=bank_mem_0[4][8] D=bank_wdata[0][8]
+ CK=CTS_328
Xbank_mem_0_reg[4][7] QDFFN $PINS Q=bank_mem_0[4][7] D=bank_wdata[0][7]
+ CK=CTS_328
Xbank_mem_0_reg[4][6] QDFFN $PINS Q=bank_mem_0[4][6] D=bank_wdata[0][6]
+ CK=CTS_328
Xbank_mem_0_reg[4][5] QDFFN $PINS Q=bank_mem_0[4][5] D=bank_wdata[0][5]
+ CK=CTS_328
Xbank_mem_0_reg[4][4] QDFFN $PINS Q=bank_mem_0[4][4] D=bank_wdata[0][4]
+ CK=CTS_328
Xbank_mem_0_reg[4][3] QDFFN $PINS Q=bank_mem_0[4][3] D=bank_wdata[0][3]
+ CK=CTS_328
Xbank_mem_0_reg[4][2] QDFFN $PINS Q=bank_mem_0[4][2] D=bank_wdata[0][2]
+ CK=CTS_328
Xbank_mem_0_reg[4][1] QDFFN $PINS Q=bank_mem_0[4][1] D=bank_wdata[0][1]
+ CK=CTS_328
Xbank_mem_0_reg[4][0] QDFFN $PINS Q=bank_mem_0[4][0] D=bank_wdata[0][0]
+ CK=CTS_328
Xbank_mem_1_reg[15][20] QDFFN $PINS Q=bank_mem_1[15][20] D=bank_wdata[1][20]
+ CK=CTS_343
Xbank_mem_1_reg[15][19] QDFFN $PINS Q=bank_mem_1[15][19] D=bank_wdata[1][19]
+ CK=CTS_343
Xbank_mem_1_reg[15][18] QDFFN $PINS Q=bank_mem_1[15][18] D=bank_wdata[1][18]
+ CK=CTS_343
Xbank_mem_1_reg[15][17] QDFFN $PINS Q=bank_mem_1[15][17] D=bank_wdata[1][17]
+ CK=CTS_343
Xbank_mem_1_reg[15][16] QDFFN $PINS Q=bank_mem_1[15][16] D=bank_wdata[1][16]
+ CK=CTS_343
Xbank_mem_1_reg[15][15] QDFFN $PINS Q=bank_mem_1[15][15] D=bank_wdata[1][15]
+ CK=CTS_343
Xbank_mem_1_reg[15][14] QDFFN $PINS Q=bank_mem_1[15][14] D=bank_wdata[1][14]
+ CK=CTS_343
Xbank_mem_1_reg[15][13] QDFFN $PINS Q=bank_mem_1[15][13] D=bank_wdata[1][13]
+ CK=CTS_343
Xbank_mem_1_reg[15][12] QDFFN $PINS Q=bank_mem_1[15][12] D=bank_wdata[1][12]
+ CK=CTS_343
Xbank_mem_1_reg[15][11] QDFFN $PINS Q=bank_mem_1[15][11] D=bank_wdata[1][11]
+ CK=CTS_343
Xbank_mem_1_reg[15][10] QDFFN $PINS Q=bank_mem_1[15][10] D=bank_wdata[1][10]
+ CK=CTS_343
Xbank_mem_1_reg[15][9] QDFFN $PINS Q=bank_mem_1[15][9] D=bank_wdata[1][9]
+ CK=CTS_343
Xbank_mem_1_reg[15][8] QDFFN $PINS Q=bank_mem_1[15][8] D=bank_wdata[1][8]
+ CK=CTS_343
Xbank_mem_1_reg[15][7] QDFFN $PINS Q=bank_mem_1[15][7] D=bank_wdata[1][7]
+ CK=CTS_343
Xbank_mem_1_reg[15][6] QDFFN $PINS Q=bank_mem_1[15][6] D=bank_wdata[1][6]
+ CK=CTS_343
Xbank_mem_1_reg[15][5] QDFFN $PINS Q=bank_mem_1[15][5] D=bank_wdata[1][5]
+ CK=CTS_343
Xbank_mem_1_reg[15][4] QDFFN $PINS Q=bank_mem_1[15][4] D=bank_wdata[1][4]
+ CK=CTS_343
Xbank_mem_1_reg[15][3] QDFFN $PINS Q=bank_mem_1[15][3] D=bank_wdata[1][3]
+ CK=CTS_343
Xbank_mem_1_reg[15][2] QDFFN $PINS Q=bank_mem_1[15][2] D=bank_wdata[1][2]
+ CK=CTS_343
Xbank_mem_1_reg[15][1] QDFFN $PINS Q=bank_mem_1[15][1] D=bank_wdata[1][1]
+ CK=CTS_343
Xbank_mem_1_reg[15][0] QDFFN $PINS Q=bank_mem_1[15][0] D=bank_wdata[1][0]
+ CK=CTS_343
Xbank_mem_1_reg[13][20] QDFFN $PINS Q=bank_mem_1[13][20] D=bank_wdata[1][20]
+ CK=CTS_349
Xbank_mem_1_reg[13][19] QDFFN $PINS Q=bank_mem_1[13][19] D=bank_wdata[1][19]
+ CK=CTS_349
Xbank_mem_1_reg[13][18] QDFFN $PINS Q=bank_mem_1[13][18] D=bank_wdata[1][18]
+ CK=CTS_349
Xbank_mem_1_reg[13][17] QDFFN $PINS Q=bank_mem_1[13][17] D=bank_wdata[1][17]
+ CK=CTS_349
Xbank_mem_1_reg[13][16] QDFFN $PINS Q=bank_mem_1[13][16] D=bank_wdata[1][16]
+ CK=CTS_349
Xbank_mem_1_reg[13][15] QDFFN $PINS Q=bank_mem_1[13][15] D=bank_wdata[1][15]
+ CK=CTS_349
Xbank_mem_1_reg[13][14] QDFFN $PINS Q=bank_mem_1[13][14] D=bank_wdata[1][14]
+ CK=CTS_349
Xbank_mem_1_reg[13][13] QDFFN $PINS Q=bank_mem_1[13][13] D=bank_wdata[1][13]
+ CK=CTS_349
Xbank_mem_1_reg[13][12] QDFFN $PINS Q=bank_mem_1[13][12] D=bank_wdata[1][12]
+ CK=CTS_349
Xbank_mem_1_reg[13][11] QDFFN $PINS Q=bank_mem_1[13][11] D=bank_wdata[1][11]
+ CK=CTS_349
Xbank_mem_1_reg[13][10] QDFFN $PINS Q=bank_mem_1[13][10] D=bank_wdata[1][10]
+ CK=CTS_349
Xbank_mem_1_reg[13][9] QDFFN $PINS Q=bank_mem_1[13][9] D=bank_wdata[1][9]
+ CK=CTS_349
Xbank_mem_1_reg[13][8] QDFFN $PINS Q=bank_mem_1[13][8] D=bank_wdata[1][8]
+ CK=CTS_349
Xbank_mem_1_reg[13][7] QDFFN $PINS Q=bank_mem_1[13][7] D=bank_wdata[1][7]
+ CK=CTS_349
Xbank_mem_1_reg[13][6] QDFFN $PINS Q=bank_mem_1[13][6] D=bank_wdata[1][6]
+ CK=CTS_349
Xbank_mem_1_reg[13][5] QDFFN $PINS Q=bank_mem_1[13][5] D=bank_wdata[1][5]
+ CK=CTS_349
Xbank_mem_1_reg[13][4] QDFFN $PINS Q=bank_mem_1[13][4] D=bank_wdata[1][4]
+ CK=CTS_349
Xbank_mem_1_reg[13][3] QDFFN $PINS Q=bank_mem_1[13][3] D=bank_wdata[1][3]
+ CK=CTS_349
Xbank_mem_1_reg[13][2] QDFFN $PINS Q=bank_mem_1[13][2] D=bank_wdata[1][2]
+ CK=CTS_349
Xbank_mem_1_reg[13][1] QDFFN $PINS Q=bank_mem_1[13][1] D=bank_wdata[1][1]
+ CK=CTS_349
Xbank_mem_1_reg[13][0] QDFFN $PINS Q=bank_mem_1[13][0] D=bank_wdata[1][0]
+ CK=CTS_349
Xbank_mem_0_reg[2][21] QDFFN $PINS Q=bank_mem_0[2][21] D=bank_wdata[0][21]
+ CK=CTS_334
Xbank_mem_0_reg[2][20] QDFFN $PINS Q=bank_mem_0[2][20] D=bank_wdata[0][20]
+ CK=CTS_334
Xbank_mem_0_reg[2][19] QDFFN $PINS Q=bank_mem_0[2][19] D=bank_wdata[0][19]
+ CK=CTS_334
Xbank_mem_0_reg[2][18] QDFFN $PINS Q=bank_mem_0[2][18] D=bank_wdata[0][18]
+ CK=CTS_334
Xbank_mem_0_reg[2][17] QDFFN $PINS Q=bank_mem_0[2][17] D=bank_wdata[0][17]
+ CK=CTS_334
Xbank_mem_0_reg[2][16] QDFFN $PINS Q=bank_mem_0[2][16] D=bank_wdata[0][16]
+ CK=CTS_334
Xbank_mem_0_reg[2][15] QDFFN $PINS Q=bank_mem_0[2][15] D=bank_wdata[0][15]
+ CK=CTS_334
Xbank_mem_0_reg[2][14] QDFFN $PINS Q=bank_mem_0[2][14] D=bank_wdata[0][14]
+ CK=CTS_334
Xbank_mem_0_reg[2][13] QDFFN $PINS Q=bank_mem_0[2][13] D=bank_wdata[0][13]
+ CK=CTS_334
Xbank_mem_0_reg[2][12] QDFFN $PINS Q=bank_mem_0[2][12] D=bank_wdata[0][12]
+ CK=CTS_334
Xbank_mem_0_reg[2][11] QDFFN $PINS Q=bank_mem_0[2][11] D=bank_wdata[0][11]
+ CK=CTS_334
Xbank_mem_0_reg[2][10] QDFFN $PINS Q=bank_mem_0[2][10] D=bank_wdata[0][10]
+ CK=CTS_334
Xbank_mem_0_reg[2][9] QDFFN $PINS Q=bank_mem_0[2][9] D=bank_wdata[0][9]
+ CK=CTS_334
Xbank_mem_0_reg[2][8] QDFFN $PINS Q=bank_mem_0[2][8] D=bank_wdata[0][8]
+ CK=CTS_334
Xbank_mem_0_reg[2][7] QDFFN $PINS Q=bank_mem_0[2][7] D=bank_wdata[0][7]
+ CK=CTS_334
Xbank_mem_0_reg[2][6] QDFFN $PINS Q=bank_mem_0[2][6] D=bank_wdata[0][6]
+ CK=CTS_334
Xbank_mem_0_reg[2][5] QDFFN $PINS Q=bank_mem_0[2][5] D=bank_wdata[0][5]
+ CK=CTS_334
Xbank_mem_0_reg[2][4] QDFFN $PINS Q=bank_mem_0[2][4] D=bank_wdata[0][4]
+ CK=CTS_334
Xbank_mem_0_reg[2][3] QDFFN $PINS Q=bank_mem_0[2][3] D=bank_wdata[0][3]
+ CK=CTS_334
Xbank_mem_0_reg[2][2] QDFFN $PINS Q=bank_mem_0[2][2] D=bank_wdata[0][2]
+ CK=CTS_334
Xbank_mem_0_reg[2][1] QDFFN $PINS Q=bank_mem_0[2][1] D=bank_wdata[0][1]
+ CK=CTS_334
Xbank_mem_0_reg[2][0] QDFFN $PINS Q=bank_mem_0[2][0] D=bank_wdata[0][0]
+ CK=CTS_334
Xbank_mem_1_reg[14][20] QDFFN $PINS Q=bank_mem_1[14][20] D=bank_wdata[1][20]
+ CK=CTS_346
Xbank_mem_1_reg[14][19] QDFFN $PINS Q=bank_mem_1[14][19] D=bank_wdata[1][19]
+ CK=CTS_346
Xbank_mem_1_reg[14][18] QDFFN $PINS Q=bank_mem_1[14][18] D=bank_wdata[1][18]
+ CK=CTS_346
Xbank_mem_1_reg[14][17] QDFFN $PINS Q=bank_mem_1[14][17] D=bank_wdata[1][17]
+ CK=CTS_346
Xbank_mem_1_reg[14][16] QDFFN $PINS Q=bank_mem_1[14][16] D=bank_wdata[1][16]
+ CK=CTS_346
Xbank_mem_1_reg[14][15] QDFFN $PINS Q=bank_mem_1[14][15] D=bank_wdata[1][15]
+ CK=CTS_346
Xbank_mem_1_reg[14][14] QDFFN $PINS Q=bank_mem_1[14][14] D=bank_wdata[1][14]
+ CK=CTS_346
Xbank_mem_1_reg[14][13] QDFFN $PINS Q=bank_mem_1[14][13] D=bank_wdata[1][13]
+ CK=CTS_346
Xbank_mem_1_reg[14][12] QDFFN $PINS Q=bank_mem_1[14][12] D=bank_wdata[1][12]
+ CK=CTS_346
Xbank_mem_1_reg[14][11] QDFFN $PINS Q=bank_mem_1[14][11] D=bank_wdata[1][11]
+ CK=CTS_346
Xbank_mem_1_reg[14][10] QDFFN $PINS Q=bank_mem_1[14][10] D=bank_wdata[1][10]
+ CK=CTS_346
Xbank_mem_1_reg[14][9] QDFFN $PINS Q=bank_mem_1[14][9] D=bank_wdata[1][9]
+ CK=CTS_346
Xbank_mem_1_reg[14][8] QDFFN $PINS Q=bank_mem_1[14][8] D=bank_wdata[1][8]
+ CK=CTS_346
Xbank_mem_1_reg[14][7] QDFFN $PINS Q=bank_mem_1[14][7] D=bank_wdata[1][7]
+ CK=CTS_346
Xbank_mem_1_reg[14][6] QDFFN $PINS Q=bank_mem_1[14][6] D=bank_wdata[1][6]
+ CK=CTS_346
Xbank_mem_1_reg[14][5] QDFFN $PINS Q=bank_mem_1[14][5] D=bank_wdata[1][5]
+ CK=CTS_346
Xbank_mem_1_reg[14][4] QDFFN $PINS Q=bank_mem_1[14][4] D=bank_wdata[1][4]
+ CK=CTS_346
Xbank_mem_1_reg[14][3] QDFFN $PINS Q=bank_mem_1[14][3] D=bank_wdata[1][3]
+ CK=CTS_346
Xbank_mem_1_reg[14][2] QDFFN $PINS Q=bank_mem_1[14][2] D=bank_wdata[1][2]
+ CK=CTS_346
Xbank_mem_1_reg[14][1] QDFFN $PINS Q=bank_mem_1[14][1] D=bank_wdata[1][1]
+ CK=CTS_346
Xbank_mem_1_reg[14][0] QDFFN $PINS Q=bank_mem_1[14][0] D=bank_wdata[1][0]
+ CK=CTS_346
Xbank_mem_1_reg[15][21] QDFFN $PINS Q=bank_mem_1[15][21] D=bank_wdata[1][21]
+ CK=CTS_343
Xbank_mem_1_reg[12][20] QDFFN $PINS Q=bank_mem_1[12][20] D=bank_wdata[1][20]
+ CK=CTS_352
Xbank_mem_1_reg[12][19] QDFFN $PINS Q=bank_mem_1[12][19] D=bank_wdata[1][19]
+ CK=CTS_352
Xbank_mem_1_reg[12][18] QDFFN $PINS Q=bank_mem_1[12][18] D=bank_wdata[1][18]
+ CK=CTS_352
Xbank_mem_1_reg[12][17] QDFFN $PINS Q=bank_mem_1[12][17] D=bank_wdata[1][17]
+ CK=CTS_352
Xbank_mem_1_reg[12][16] QDFFN $PINS Q=bank_mem_1[12][16] D=bank_wdata[1][16]
+ CK=CTS_352
Xbank_mem_1_reg[12][15] QDFFN $PINS Q=bank_mem_1[12][15] D=bank_wdata[1][15]
+ CK=CTS_352
Xbank_mem_1_reg[12][14] QDFFN $PINS Q=bank_mem_1[12][14] D=bank_wdata[1][14]
+ CK=CTS_352
Xbank_mem_1_reg[12][13] QDFFN $PINS Q=bank_mem_1[12][13] D=bank_wdata[1][13]
+ CK=CTS_352
Xbank_mem_1_reg[12][12] QDFFN $PINS Q=bank_mem_1[12][12] D=bank_wdata[1][12]
+ CK=CTS_352
Xbank_mem_1_reg[12][11] QDFFN $PINS Q=bank_mem_1[12][11] D=bank_wdata[1][11]
+ CK=CTS_352
Xbank_mem_1_reg[12][10] QDFFN $PINS Q=bank_mem_1[12][10] D=bank_wdata[1][10]
+ CK=CTS_352
Xbank_mem_1_reg[12][9] QDFFN $PINS Q=bank_mem_1[12][9] D=bank_wdata[1][9]
+ CK=CTS_352
Xbank_mem_1_reg[12][8] QDFFN $PINS Q=bank_mem_1[12][8] D=bank_wdata[1][8]
+ CK=CTS_352
Xbank_mem_1_reg[12][7] QDFFN $PINS Q=bank_mem_1[12][7] D=bank_wdata[1][7]
+ CK=CTS_352
Xbank_mem_1_reg[12][6] QDFFN $PINS Q=bank_mem_1[12][6] D=bank_wdata[1][6]
+ CK=CTS_352
Xbank_mem_1_reg[12][5] QDFFN $PINS Q=bank_mem_1[12][5] D=bank_wdata[1][5]
+ CK=CTS_352
Xbank_mem_1_reg[12][4] QDFFN $PINS Q=bank_mem_1[12][4] D=bank_wdata[1][4]
+ CK=CTS_352
Xbank_mem_1_reg[12][3] QDFFN $PINS Q=bank_mem_1[12][3] D=bank_wdata[1][3]
+ CK=CTS_352
Xbank_mem_1_reg[12][2] QDFFN $PINS Q=bank_mem_1[12][2] D=bank_wdata[1][2]
+ CK=CTS_352
Xbank_mem_1_reg[12][1] QDFFN $PINS Q=bank_mem_1[12][1] D=bank_wdata[1][1]
+ CK=CTS_352
Xbank_mem_1_reg[12][0] QDFFN $PINS Q=bank_mem_1[12][0] D=bank_wdata[1][0]
+ CK=CTS_352
Xbank_mem_1_reg[13][21] QDFFN $PINS Q=bank_mem_1[13][21] D=bank_wdata[1][21]
+ CK=CTS_349
Xbank_mem_0_reg[15][20] QDFFN $PINS Q=bank_mem_0[15][20] D=bank_wdata[0][20]
+ CK=CTS_295
Xbank_mem_0_reg[15][19] QDFFN $PINS Q=bank_mem_0[15][19] D=bank_wdata[0][19]
+ CK=CTS_295
Xbank_mem_0_reg[15][18] QDFFN $PINS Q=bank_mem_0[15][18] D=bank_wdata[0][18]
+ CK=CTS_295
Xbank_mem_0_reg[15][17] QDFFN $PINS Q=bank_mem_0[15][17] D=bank_wdata[0][17]
+ CK=CTS_295
Xbank_mem_0_reg[15][16] QDFFN $PINS Q=bank_mem_0[15][16] D=bank_wdata[0][16]
+ CK=CTS_295
Xbank_mem_0_reg[15][15] QDFFN $PINS Q=bank_mem_0[15][15] D=bank_wdata[0][15]
+ CK=CTS_295
Xbank_mem_0_reg[15][14] QDFFN $PINS Q=bank_mem_0[15][14] D=bank_wdata[0][14]
+ CK=CTS_295
Xbank_mem_0_reg[15][13] QDFFN $PINS Q=bank_mem_0[15][13] D=bank_wdata[0][13]
+ CK=CTS_295
Xbank_mem_0_reg[15][12] QDFFN $PINS Q=bank_mem_0[15][12] D=bank_wdata[0][12]
+ CK=CTS_295
Xbank_mem_0_reg[15][11] QDFFN $PINS Q=bank_mem_0[15][11] D=bank_wdata[0][11]
+ CK=CTS_295
Xbank_mem_0_reg[15][10] QDFFN $PINS Q=bank_mem_0[15][10] D=bank_wdata[0][10]
+ CK=CTS_295
Xbank_mem_0_reg[15][9] QDFFN $PINS Q=bank_mem_0[15][9] D=bank_wdata[0][9]
+ CK=CTS_295
Xbank_mem_0_reg[15][8] QDFFN $PINS Q=bank_mem_0[15][8] D=bank_wdata[0][8]
+ CK=CTS_295
Xbank_mem_0_reg[15][7] QDFFN $PINS Q=bank_mem_0[15][7] D=bank_wdata[0][7]
+ CK=CTS_295
Xbank_mem_0_reg[15][6] QDFFN $PINS Q=bank_mem_0[15][6] D=bank_wdata[0][6]
+ CK=CTS_295
Xbank_mem_0_reg[15][5] QDFFN $PINS Q=bank_mem_0[15][5] D=bank_wdata[0][5]
+ CK=CTS_295
Xbank_mem_0_reg[15][4] QDFFN $PINS Q=bank_mem_0[15][4] D=bank_wdata[0][4]
+ CK=CTS_295
Xbank_mem_0_reg[15][3] QDFFN $PINS Q=bank_mem_0[15][3] D=bank_wdata[0][3]
+ CK=CTS_295
Xbank_mem_0_reg[15][2] QDFFN $PINS Q=bank_mem_0[15][2] D=bank_wdata[0][2]
+ CK=CTS_295
Xbank_mem_0_reg[15][1] QDFFN $PINS Q=bank_mem_0[15][1] D=bank_wdata[0][1]
+ CK=CTS_295
Xbank_mem_0_reg[15][0] QDFFN $PINS Q=bank_mem_0[15][0] D=bank_wdata[0][0]
+ CK=CTS_295
Xbank_mem_0_reg[13][20] QDFFN $PINS Q=bank_mem_0[13][20] D=bank_wdata[0][20]
+ CK=CTS_301
Xbank_mem_0_reg[13][19] QDFFN $PINS Q=bank_mem_0[13][19] D=bank_wdata[0][19]
+ CK=CTS_301
Xbank_mem_0_reg[13][18] QDFFN $PINS Q=bank_mem_0[13][18] D=bank_wdata[0][18]
+ CK=CTS_301
Xbank_mem_0_reg[13][17] QDFFN $PINS Q=bank_mem_0[13][17] D=bank_wdata[0][17]
+ CK=CTS_301
Xbank_mem_0_reg[13][16] QDFFN $PINS Q=bank_mem_0[13][16] D=bank_wdata[0][16]
+ CK=CTS_301
Xbank_mem_0_reg[13][15] QDFFN $PINS Q=bank_mem_0[13][15] D=bank_wdata[0][15]
+ CK=CTS_301
Xbank_mem_0_reg[13][14] QDFFN $PINS Q=bank_mem_0[13][14] D=bank_wdata[0][14]
+ CK=CTS_301
Xbank_mem_0_reg[13][13] QDFFN $PINS Q=bank_mem_0[13][13] D=bank_wdata[0][13]
+ CK=CTS_301
Xbank_mem_0_reg[13][12] QDFFN $PINS Q=bank_mem_0[13][12] D=bank_wdata[0][12]
+ CK=CTS_301
Xbank_mem_0_reg[13][11] QDFFN $PINS Q=bank_mem_0[13][11] D=bank_wdata[0][11]
+ CK=CTS_301
Xbank_mem_0_reg[13][10] QDFFN $PINS Q=bank_mem_0[13][10] D=bank_wdata[0][10]
+ CK=CTS_301
Xbank_mem_0_reg[13][9] QDFFN $PINS Q=bank_mem_0[13][9] D=bank_wdata[0][9]
+ CK=CTS_301
Xbank_mem_0_reg[13][8] QDFFN $PINS Q=bank_mem_0[13][8] D=bank_wdata[0][8]
+ CK=CTS_301
Xbank_mem_0_reg[13][7] QDFFN $PINS Q=bank_mem_0[13][7] D=bank_wdata[0][7]
+ CK=CTS_301
Xbank_mem_0_reg[13][6] QDFFN $PINS Q=bank_mem_0[13][6] D=bank_wdata[0][6]
+ CK=CTS_301
Xbank_mem_0_reg[13][5] QDFFN $PINS Q=bank_mem_0[13][5] D=bank_wdata[0][5]
+ CK=CTS_301
Xbank_mem_0_reg[13][4] QDFFN $PINS Q=bank_mem_0[13][4] D=bank_wdata[0][4]
+ CK=CTS_301
Xbank_mem_0_reg[13][3] QDFFN $PINS Q=bank_mem_0[13][3] D=bank_wdata[0][3]
+ CK=CTS_301
Xbank_mem_0_reg[13][2] QDFFN $PINS Q=bank_mem_0[13][2] D=bank_wdata[0][2]
+ CK=CTS_301
Xbank_mem_0_reg[13][1] QDFFN $PINS Q=bank_mem_0[13][1] D=bank_wdata[0][1]
+ CK=CTS_301
Xbank_mem_0_reg[13][0] QDFFN $PINS Q=bank_mem_0[13][0] D=bank_wdata[0][0]
+ CK=CTS_301
Xbank_mem_1_reg[14][21] QDFFN $PINS Q=bank_mem_1[14][21] D=bank_wdata[1][21]
+ CK=CTS_346
Xbank_mem_1_reg[12][21] QDFFN $PINS Q=bank_mem_1[12][21] D=bank_wdata[1][21]
+ CK=CTS_352
Xbank_mem_1_reg[0][21] QDFFN $PINS Q=bank_mem_1[0][21] D=bank_wdata[1][21]
+ CK=CTS_388
Xbank_mem_1_reg[0][20] QDFFN $PINS Q=bank_mem_1[0][20] D=bank_wdata[1][20]
+ CK=CTS_388
Xbank_mem_1_reg[0][19] QDFFN $PINS Q=bank_mem_1[0][19] D=bank_wdata[1][19]
+ CK=CTS_388
Xbank_mem_1_reg[0][18] QDFFN $PINS Q=bank_mem_1[0][18] D=bank_wdata[1][18]
+ CK=CTS_388
Xbank_mem_1_reg[0][17] QDFFN $PINS Q=bank_mem_1[0][17] D=bank_wdata[1][17]
+ CK=CTS_388
Xbank_mem_1_reg[0][16] QDFFN $PINS Q=bank_mem_1[0][16] D=bank_wdata[1][16]
+ CK=CTS_388
Xbank_mem_1_reg[0][15] QDFFN $PINS Q=bank_mem_1[0][15] D=bank_wdata[1][15]
+ CK=CTS_388
Xbank_mem_1_reg[0][14] QDFFN $PINS Q=bank_mem_1[0][14] D=bank_wdata[1][14]
+ CK=CTS_388
Xbank_mem_1_reg[0][13] QDFFN $PINS Q=bank_mem_1[0][13] D=bank_wdata[1][13]
+ CK=CTS_388
Xbank_mem_1_reg[0][12] QDFFN $PINS Q=bank_mem_1[0][12] D=bank_wdata[1][12]
+ CK=CTS_388
Xbank_mem_1_reg[0][11] QDFFN $PINS Q=bank_mem_1[0][11] D=bank_wdata[1][11]
+ CK=CTS_388
Xbank_mem_1_reg[0][10] QDFFN $PINS Q=bank_mem_1[0][10] D=bank_wdata[1][10]
+ CK=CTS_388
Xbank_mem_1_reg[0][9] QDFFN $PINS Q=bank_mem_1[0][9] D=bank_wdata[1][9]
+ CK=CTS_388
Xbank_mem_1_reg[0][8] QDFFN $PINS Q=bank_mem_1[0][8] D=bank_wdata[1][8]
+ CK=CTS_388
Xbank_mem_1_reg[0][7] QDFFN $PINS Q=bank_mem_1[0][7] D=bank_wdata[1][7]
+ CK=CTS_388
Xbank_mem_1_reg[0][6] QDFFN $PINS Q=bank_mem_1[0][6] D=bank_wdata[1][6]
+ CK=CTS_388
Xbank_mem_1_reg[0][5] QDFFN $PINS Q=bank_mem_1[0][5] D=bank_wdata[1][5]
+ CK=CTS_388
Xbank_mem_1_reg[0][4] QDFFN $PINS Q=bank_mem_1[0][4] D=bank_wdata[1][4]
+ CK=CTS_388
Xbank_mem_1_reg[0][3] QDFFN $PINS Q=bank_mem_1[0][3] D=bank_wdata[1][3]
+ CK=CTS_388
Xbank_mem_1_reg[0][2] QDFFN $PINS Q=bank_mem_1[0][2] D=bank_wdata[1][2]
+ CK=CTS_388
Xbank_mem_1_reg[0][1] QDFFN $PINS Q=bank_mem_1[0][1] D=bank_wdata[1][1]
+ CK=CTS_388
Xbank_mem_1_reg[0][0] QDFFN $PINS Q=bank_mem_1[0][0] D=bank_wdata[1][0]
+ CK=CTS_388
Xbank_mem_0_reg[14][20] QDFFN $PINS Q=bank_mem_0[14][20] D=bank_wdata[0][20]
+ CK=CTS_298
Xbank_mem_0_reg[14][19] QDFFN $PINS Q=bank_mem_0[14][19] D=bank_wdata[0][19]
+ CK=CTS_298
Xbank_mem_0_reg[14][18] QDFFN $PINS Q=bank_mem_0[14][18] D=bank_wdata[0][18]
+ CK=CTS_298
Xbank_mem_0_reg[14][17] QDFFN $PINS Q=bank_mem_0[14][17] D=bank_wdata[0][17]
+ CK=CTS_298
Xbank_mem_0_reg[14][16] QDFFN $PINS Q=bank_mem_0[14][16] D=bank_wdata[0][16]
+ CK=CTS_298
Xbank_mem_0_reg[14][15] QDFFN $PINS Q=bank_mem_0[14][15] D=bank_wdata[0][15]
+ CK=CTS_298
Xbank_mem_0_reg[14][14] QDFFN $PINS Q=bank_mem_0[14][14] D=bank_wdata[0][14]
+ CK=CTS_298
Xbank_mem_0_reg[14][13] QDFFN $PINS Q=bank_mem_0[14][13] D=bank_wdata[0][13]
+ CK=CTS_298
Xbank_mem_0_reg[14][12] QDFFN $PINS Q=bank_mem_0[14][12] D=bank_wdata[0][12]
+ CK=CTS_298
Xbank_mem_0_reg[14][11] QDFFN $PINS Q=bank_mem_0[14][11] D=bank_wdata[0][11]
+ CK=CTS_298
Xbank_mem_0_reg[14][10] QDFFN $PINS Q=bank_mem_0[14][10] D=bank_wdata[0][10]
+ CK=CTS_298
Xbank_mem_0_reg[14][9] QDFFN $PINS Q=bank_mem_0[14][9] D=bank_wdata[0][9]
+ CK=CTS_298
Xbank_mem_0_reg[14][8] QDFFN $PINS Q=bank_mem_0[14][8] D=bank_wdata[0][8]
+ CK=CTS_298
Xbank_mem_0_reg[14][7] QDFFN $PINS Q=bank_mem_0[14][7] D=bank_wdata[0][7]
+ CK=CTS_298
Xbank_mem_0_reg[14][6] QDFFN $PINS Q=bank_mem_0[14][6] D=bank_wdata[0][6]
+ CK=CTS_298
Xbank_mem_0_reg[14][5] QDFFN $PINS Q=bank_mem_0[14][5] D=bank_wdata[0][5]
+ CK=CTS_298
Xbank_mem_0_reg[14][4] QDFFN $PINS Q=bank_mem_0[14][4] D=bank_wdata[0][4]
+ CK=CTS_298
Xbank_mem_0_reg[14][3] QDFFN $PINS Q=bank_mem_0[14][3] D=bank_wdata[0][3]
+ CK=CTS_298
Xbank_mem_0_reg[14][2] QDFFN $PINS Q=bank_mem_0[14][2] D=bank_wdata[0][2]
+ CK=CTS_298
Xbank_mem_0_reg[14][1] QDFFN $PINS Q=bank_mem_0[14][1] D=bank_wdata[0][1]
+ CK=CTS_298
Xbank_mem_0_reg[14][0] QDFFN $PINS Q=bank_mem_0[14][0] D=bank_wdata[0][0]
+ CK=CTS_298
Xbank_mem_0_reg[15][21] QDFFN $PINS Q=bank_mem_0[15][21] D=bank_wdata[0][21]
+ CK=CTS_295
Xbank_mem_0_reg[12][20] QDFFN $PINS Q=bank_mem_0[12][20] D=bank_wdata[0][20]
+ CK=CTS_304
Xbank_mem_0_reg[12][19] QDFFN $PINS Q=bank_mem_0[12][19] D=bank_wdata[0][19]
+ CK=CTS_304
Xbank_mem_0_reg[12][18] QDFFN $PINS Q=bank_mem_0[12][18] D=bank_wdata[0][18]
+ CK=CTS_304
Xbank_mem_0_reg[12][17] QDFFN $PINS Q=bank_mem_0[12][17] D=bank_wdata[0][17]
+ CK=CTS_304
Xbank_mem_0_reg[12][16] QDFFN $PINS Q=bank_mem_0[12][16] D=bank_wdata[0][16]
+ CK=CTS_304
Xbank_mem_0_reg[12][15] QDFFN $PINS Q=bank_mem_0[12][15] D=bank_wdata[0][15]
+ CK=CTS_304
Xbank_mem_0_reg[12][14] QDFFN $PINS Q=bank_mem_0[12][14] D=bank_wdata[0][14]
+ CK=CTS_304
Xbank_mem_0_reg[12][13] QDFFN $PINS Q=bank_mem_0[12][13] D=bank_wdata[0][13]
+ CK=CTS_304
Xbank_mem_0_reg[12][12] QDFFN $PINS Q=bank_mem_0[12][12] D=bank_wdata[0][12]
+ CK=CTS_304
Xbank_mem_0_reg[12][11] QDFFN $PINS Q=bank_mem_0[12][11] D=bank_wdata[0][11]
+ CK=CTS_304
Xbank_mem_0_reg[12][10] QDFFN $PINS Q=bank_mem_0[12][10] D=bank_wdata[0][10]
+ CK=CTS_304
Xbank_mem_0_reg[12][9] QDFFN $PINS Q=bank_mem_0[12][9] D=bank_wdata[0][9]
+ CK=CTS_304
Xbank_mem_0_reg[12][8] QDFFN $PINS Q=bank_mem_0[12][8] D=bank_wdata[0][8]
+ CK=CTS_304
Xbank_mem_0_reg[12][7] QDFFN $PINS Q=bank_mem_0[12][7] D=bank_wdata[0][7]
+ CK=CTS_304
Xbank_mem_0_reg[12][6] QDFFN $PINS Q=bank_mem_0[12][6] D=bank_wdata[0][6]
+ CK=CTS_304
Xbank_mem_0_reg[12][5] QDFFN $PINS Q=bank_mem_0[12][5] D=bank_wdata[0][5]
+ CK=CTS_304
Xbank_mem_0_reg[12][4] QDFFN $PINS Q=bank_mem_0[12][4] D=bank_wdata[0][4]
+ CK=CTS_304
Xbank_mem_0_reg[12][3] QDFFN $PINS Q=bank_mem_0[12][3] D=bank_wdata[0][3]
+ CK=CTS_304
Xbank_mem_0_reg[12][2] QDFFN $PINS Q=bank_mem_0[12][2] D=bank_wdata[0][2]
+ CK=CTS_304
Xbank_mem_0_reg[12][1] QDFFN $PINS Q=bank_mem_0[12][1] D=bank_wdata[0][1]
+ CK=CTS_304
Xbank_mem_0_reg[12][0] QDFFN $PINS Q=bank_mem_0[12][0] D=bank_wdata[0][0]
+ CK=CTS_304
Xbank_mem_0_reg[13][21] QDFFN $PINS Q=bank_mem_0[13][21] D=bank_wdata[0][21]
+ CK=CTS_301
Xbank_mem_1_reg[1][21] QDFFN $PINS Q=bank_mem_1[1][21] D=bank_wdata[1][21]
+ CK=CTS_385
Xbank_mem_1_reg[1][20] QDFFN $PINS Q=bank_mem_1[1][20] D=bank_wdata[1][20]
+ CK=CTS_385
Xbank_mem_1_reg[1][19] QDFFN $PINS Q=bank_mem_1[1][19] D=bank_wdata[1][19]
+ CK=CTS_385
Xbank_mem_1_reg[1][18] QDFFN $PINS Q=bank_mem_1[1][18] D=bank_wdata[1][18]
+ CK=CTS_385
Xbank_mem_1_reg[1][17] QDFFN $PINS Q=bank_mem_1[1][17] D=bank_wdata[1][17]
+ CK=CTS_385
Xbank_mem_1_reg[1][16] QDFFN $PINS Q=bank_mem_1[1][16] D=bank_wdata[1][16]
+ CK=CTS_385
Xbank_mem_1_reg[1][15] QDFFN $PINS Q=bank_mem_1[1][15] D=bank_wdata[1][15]
+ CK=CTS_385
Xbank_mem_1_reg[1][14] QDFFN $PINS Q=bank_mem_1[1][14] D=bank_wdata[1][14]
+ CK=CTS_385
Xbank_mem_1_reg[1][13] QDFFN $PINS Q=bank_mem_1[1][13] D=bank_wdata[1][13]
+ CK=CTS_385
Xbank_mem_1_reg[1][12] QDFFN $PINS Q=bank_mem_1[1][12] D=bank_wdata[1][12]
+ CK=CTS_385
Xbank_mem_1_reg[1][11] QDFFN $PINS Q=bank_mem_1[1][11] D=bank_wdata[1][11]
+ CK=CTS_385
Xbank_mem_1_reg[1][10] QDFFN $PINS Q=bank_mem_1[1][10] D=bank_wdata[1][10]
+ CK=CTS_385
Xbank_mem_1_reg[1][9] QDFFN $PINS Q=bank_mem_1[1][9] D=bank_wdata[1][9]
+ CK=CTS_385
Xbank_mem_1_reg[1][8] QDFFN $PINS Q=bank_mem_1[1][8] D=bank_wdata[1][8]
+ CK=CTS_385
Xbank_mem_1_reg[1][7] QDFFN $PINS Q=bank_mem_1[1][7] D=bank_wdata[1][7]
+ CK=CTS_385
Xbank_mem_1_reg[1][6] QDFFN $PINS Q=bank_mem_1[1][6] D=bank_wdata[1][6]
+ CK=CTS_385
Xbank_mem_1_reg[1][5] QDFFN $PINS Q=bank_mem_1[1][5] D=bank_wdata[1][5]
+ CK=CTS_385
Xbank_mem_1_reg[1][4] QDFFN $PINS Q=bank_mem_1[1][4] D=bank_wdata[1][4]
+ CK=CTS_385
Xbank_mem_1_reg[1][3] QDFFN $PINS Q=bank_mem_1[1][3] D=bank_wdata[1][3]
+ CK=CTS_385
Xbank_mem_1_reg[1][2] QDFFN $PINS Q=bank_mem_1[1][2] D=bank_wdata[1][2]
+ CK=CTS_385
Xbank_mem_1_reg[1][1] QDFFN $PINS Q=bank_mem_1[1][1] D=bank_wdata[1][1]
+ CK=CTS_385
Xbank_mem_1_reg[1][0] QDFFN $PINS Q=bank_mem_1[1][0] D=bank_wdata[1][0]
+ CK=CTS_385
Xbank_mem_0_reg[14][21] QDFFN $PINS Q=bank_mem_0[14][21] D=bank_wdata[0][21]
+ CK=CTS_298
Xbank_mem_0_reg[12][21] QDFFN $PINS Q=bank_mem_0[12][21] D=bank_wdata[0][21]
+ CK=CTS_304
Xbank_mem_0_reg[0][21] QDFFN $PINS Q=bank_mem_0[0][21] D=bank_wdata[0][21]
+ CK=CTS_340
Xbank_mem_0_reg[0][20] QDFFN $PINS Q=bank_mem_0[0][20] D=bank_wdata[0][20]
+ CK=CTS_340
Xbank_mem_0_reg[0][19] QDFFN $PINS Q=bank_mem_0[0][19] D=bank_wdata[0][19]
+ CK=CTS_340
Xbank_mem_0_reg[0][18] QDFFN $PINS Q=bank_mem_0[0][18] D=bank_wdata[0][18]
+ CK=CTS_340
Xbank_mem_0_reg[0][17] QDFFN $PINS Q=bank_mem_0[0][17] D=bank_wdata[0][17]
+ CK=CTS_340
Xbank_mem_0_reg[0][16] QDFFN $PINS Q=bank_mem_0[0][16] D=bank_wdata[0][16]
+ CK=CTS_340
Xbank_mem_0_reg[0][15] QDFFN $PINS Q=bank_mem_0[0][15] D=bank_wdata[0][15]
+ CK=CTS_340
Xbank_mem_0_reg[0][14] QDFFN $PINS Q=bank_mem_0[0][14] D=bank_wdata[0][14]
+ CK=CTS_340
Xbank_mem_0_reg[0][13] QDFFN $PINS Q=bank_mem_0[0][13] D=bank_wdata[0][13]
+ CK=CTS_340
Xbank_mem_0_reg[0][12] QDFFN $PINS Q=bank_mem_0[0][12] D=bank_wdata[0][12]
+ CK=CTS_340
Xbank_mem_0_reg[0][11] QDFFN $PINS Q=bank_mem_0[0][11] D=bank_wdata[0][11]
+ CK=CTS_340
Xbank_mem_0_reg[0][10] QDFFN $PINS Q=bank_mem_0[0][10] D=bank_wdata[0][10]
+ CK=CTS_340
Xbank_mem_0_reg[0][9] QDFFN $PINS Q=bank_mem_0[0][9] D=bank_wdata[0][9]
+ CK=CTS_340
Xbank_mem_0_reg[0][8] QDFFN $PINS Q=bank_mem_0[0][8] D=bank_wdata[0][8]
+ CK=CTS_340
Xbank_mem_0_reg[0][7] QDFFN $PINS Q=bank_mem_0[0][7] D=bank_wdata[0][7]
+ CK=CTS_340
Xbank_mem_0_reg[0][6] QDFFN $PINS Q=bank_mem_0[0][6] D=bank_wdata[0][6]
+ CK=CTS_340
Xbank_mem_0_reg[0][5] QDFFN $PINS Q=bank_mem_0[0][5] D=bank_wdata[0][5]
+ CK=CTS_340
Xbank_mem_0_reg[0][4] QDFFN $PINS Q=bank_mem_0[0][4] D=bank_wdata[0][4]
+ CK=CTS_340
Xbank_mem_0_reg[0][3] QDFFN $PINS Q=bank_mem_0[0][3] D=bank_wdata[0][3]
+ CK=CTS_340
Xbank_mem_0_reg[0][2] QDFFN $PINS Q=bank_mem_0[0][2] D=bank_wdata[0][2]
+ CK=CTS_340
Xbank_mem_0_reg[0][1] QDFFN $PINS Q=bank_mem_0[0][1] D=bank_wdata[0][1]
+ CK=CTS_340
Xbank_mem_0_reg[0][0] QDFFN $PINS Q=bank_mem_0[0][0] D=bank_wdata[0][0]
+ CK=CTS_340
Xbank_mem_0_reg[1][21] QDFFN $PINS Q=bank_mem_0[1][21] D=bank_wdata[0][21]
+ CK=CTS_337
Xbank_mem_0_reg[1][20] QDFFN $PINS Q=bank_mem_0[1][20] D=bank_wdata[0][20]
+ CK=CTS_337
Xbank_mem_0_reg[1][19] QDFFN $PINS Q=bank_mem_0[1][19] D=bank_wdata[0][19]
+ CK=CTS_337
Xbank_mem_0_reg[1][18] QDFFN $PINS Q=bank_mem_0[1][18] D=bank_wdata[0][18]
+ CK=CTS_337
Xbank_mem_0_reg[1][17] QDFFN $PINS Q=bank_mem_0[1][17] D=bank_wdata[0][17]
+ CK=CTS_337
Xbank_mem_0_reg[1][16] QDFFN $PINS Q=bank_mem_0[1][16] D=bank_wdata[0][16]
+ CK=CTS_337
Xbank_mem_0_reg[1][15] QDFFN $PINS Q=bank_mem_0[1][15] D=bank_wdata[0][15]
+ CK=CTS_337
Xbank_mem_0_reg[1][14] QDFFN $PINS Q=bank_mem_0[1][14] D=bank_wdata[0][14]
+ CK=CTS_337
Xbank_mem_0_reg[1][13] QDFFN $PINS Q=bank_mem_0[1][13] D=bank_wdata[0][13]
+ CK=CTS_337
Xbank_mem_0_reg[1][12] QDFFN $PINS Q=bank_mem_0[1][12] D=bank_wdata[0][12]
+ CK=CTS_337
Xbank_mem_0_reg[1][11] QDFFN $PINS Q=bank_mem_0[1][11] D=bank_wdata[0][11]
+ CK=CTS_337
Xbank_mem_0_reg[1][10] QDFFN $PINS Q=bank_mem_0[1][10] D=bank_wdata[0][10]
+ CK=CTS_337
Xbank_mem_0_reg[1][9] QDFFN $PINS Q=bank_mem_0[1][9] D=bank_wdata[0][9]
+ CK=CTS_337
Xbank_mem_0_reg[1][8] QDFFN $PINS Q=bank_mem_0[1][8] D=bank_wdata[0][8]
+ CK=CTS_337
Xbank_mem_0_reg[1][7] QDFFN $PINS Q=bank_mem_0[1][7] D=bank_wdata[0][7]
+ CK=CTS_337
Xbank_mem_0_reg[1][6] QDFFN $PINS Q=bank_mem_0[1][6] D=bank_wdata[0][6]
+ CK=CTS_337
Xbank_mem_0_reg[1][5] QDFFN $PINS Q=bank_mem_0[1][5] D=bank_wdata[0][5]
+ CK=CTS_337
Xbank_mem_0_reg[1][4] QDFFN $PINS Q=bank_mem_0[1][4] D=bank_wdata[0][4]
+ CK=CTS_337
Xbank_mem_0_reg[1][3] QDFFN $PINS Q=bank_mem_0[1][3] D=bank_wdata[0][3]
+ CK=CTS_337
Xbank_mem_0_reg[1][2] QDFFN $PINS Q=bank_mem_0[1][2] D=bank_wdata[0][2]
+ CK=CTS_337
Xbank_mem_0_reg[1][1] QDFFN $PINS Q=bank_mem_0[1][1] D=bank_wdata[0][1]
+ CK=CTS_337
Xbank_mem_0_reg[1][0] QDFFN $PINS Q=bank_mem_0[1][0] D=bank_wdata[0][0]
+ CK=CTS_337
Xbank_mem_1_reg[9][20] QDFFN $PINS Q=bank_mem_1[9][20] D=bank_wdata[1][20]
+ CK=CTS_361
Xbank_mem_1_reg[9][19] QDFFN $PINS Q=bank_mem_1[9][19] D=bank_wdata[1][19]
+ CK=CTS_361
Xbank_mem_1_reg[9][18] QDFFN $PINS Q=bank_mem_1[9][18] D=bank_wdata[1][18]
+ CK=CTS_361
Xbank_mem_1_reg[9][17] QDFFN $PINS Q=bank_mem_1[9][17] D=bank_wdata[1][17]
+ CK=CTS_361
Xbank_mem_1_reg[9][16] QDFFN $PINS Q=bank_mem_1[9][16] D=bank_wdata[1][16]
+ CK=CTS_361
Xbank_mem_1_reg[9][15] QDFFN $PINS Q=bank_mem_1[9][15] D=bank_wdata[1][15]
+ CK=CTS_361
Xbank_mem_1_reg[9][14] QDFFN $PINS Q=bank_mem_1[9][14] D=bank_wdata[1][14]
+ CK=CTS_361
Xbank_mem_1_reg[9][13] QDFFN $PINS Q=bank_mem_1[9][13] D=bank_wdata[1][13]
+ CK=CTS_361
Xbank_mem_1_reg[9][12] QDFFN $PINS Q=bank_mem_1[9][12] D=bank_wdata[1][12]
+ CK=CTS_361
Xbank_mem_1_reg[9][11] QDFFN $PINS Q=bank_mem_1[9][11] D=bank_wdata[1][11]
+ CK=CTS_361
Xbank_mem_1_reg[9][10] QDFFN $PINS Q=bank_mem_1[9][10] D=bank_wdata[1][10]
+ CK=CTS_361
Xbank_mem_1_reg[9][9] QDFFN $PINS Q=bank_mem_1[9][9] D=bank_wdata[1][9]
+ CK=CTS_361
Xbank_mem_1_reg[9][8] QDFFN $PINS Q=bank_mem_1[9][8] D=bank_wdata[1][8]
+ CK=CTS_361
Xbank_mem_1_reg[9][7] QDFFN $PINS Q=bank_mem_1[9][7] D=bank_wdata[1][7]
+ CK=CTS_361
Xbank_mem_1_reg[9][6] QDFFN $PINS Q=bank_mem_1[9][6] D=bank_wdata[1][6]
+ CK=CTS_361
Xbank_mem_1_reg[9][5] QDFFN $PINS Q=bank_mem_1[9][5] D=bank_wdata[1][5]
+ CK=CTS_361
Xbank_mem_1_reg[9][4] QDFFN $PINS Q=bank_mem_1[9][4] D=bank_wdata[1][4]
+ CK=CTS_361
Xbank_mem_1_reg[9][3] QDFFN $PINS Q=bank_mem_1[9][3] D=bank_wdata[1][3]
+ CK=CTS_361
Xbank_mem_1_reg[9][2] QDFFN $PINS Q=bank_mem_1[9][2] D=bank_wdata[1][2]
+ CK=CTS_361
Xbank_mem_1_reg[9][1] QDFFN $PINS Q=bank_mem_1[9][1] D=bank_wdata[1][1]
+ CK=CTS_361
Xbank_mem_1_reg[9][0] QDFFN $PINS Q=bank_mem_1[9][0] D=bank_wdata[1][0]
+ CK=CTS_361
Xbank_mem_1_reg[11][20] QDFFN $PINS Q=bank_mem_1[11][20] D=bank_wdata[1][20]
+ CK=CTS_355
Xbank_mem_1_reg[11][19] QDFFN $PINS Q=bank_mem_1[11][19] D=bank_wdata[1][19]
+ CK=CTS_355
Xbank_mem_1_reg[11][18] QDFFN $PINS Q=bank_mem_1[11][18] D=bank_wdata[1][18]
+ CK=CTS_355
Xbank_mem_1_reg[11][17] QDFFN $PINS Q=bank_mem_1[11][17] D=bank_wdata[1][17]
+ CK=CTS_355
Xbank_mem_1_reg[11][16] QDFFN $PINS Q=bank_mem_1[11][16] D=bank_wdata[1][16]
+ CK=CTS_355
Xbank_mem_1_reg[11][15] QDFFN $PINS Q=bank_mem_1[11][15] D=bank_wdata[1][15]
+ CK=CTS_355
Xbank_mem_1_reg[11][14] QDFFN $PINS Q=bank_mem_1[11][14] D=bank_wdata[1][14]
+ CK=CTS_355
Xbank_mem_1_reg[11][13] QDFFN $PINS Q=bank_mem_1[11][13] D=bank_wdata[1][13]
+ CK=CTS_355
Xbank_mem_1_reg[11][12] QDFFN $PINS Q=bank_mem_1[11][12] D=bank_wdata[1][12]
+ CK=CTS_355
Xbank_mem_1_reg[11][11] QDFFN $PINS Q=bank_mem_1[11][11] D=bank_wdata[1][11]
+ CK=CTS_355
Xbank_mem_1_reg[11][10] QDFFN $PINS Q=bank_mem_1[11][10] D=bank_wdata[1][10]
+ CK=CTS_355
Xbank_mem_1_reg[11][9] QDFFN $PINS Q=bank_mem_1[11][9] D=bank_wdata[1][9]
+ CK=CTS_355
Xbank_mem_1_reg[11][8] QDFFN $PINS Q=bank_mem_1[11][8] D=bank_wdata[1][8]
+ CK=CTS_355
Xbank_mem_1_reg[11][7] QDFFN $PINS Q=bank_mem_1[11][7] D=bank_wdata[1][7]
+ CK=CTS_355
Xbank_mem_1_reg[11][6] QDFFN $PINS Q=bank_mem_1[11][6] D=bank_wdata[1][6]
+ CK=CTS_355
Xbank_mem_1_reg[11][5] QDFFN $PINS Q=bank_mem_1[11][5] D=bank_wdata[1][5]
+ CK=CTS_355
Xbank_mem_1_reg[11][4] QDFFN $PINS Q=bank_mem_1[11][4] D=bank_wdata[1][4]
+ CK=CTS_355
Xbank_mem_1_reg[11][3] QDFFN $PINS Q=bank_mem_1[11][3] D=bank_wdata[1][3]
+ CK=CTS_355
Xbank_mem_1_reg[11][2] QDFFN $PINS Q=bank_mem_1[11][2] D=bank_wdata[1][2]
+ CK=CTS_355
Xbank_mem_1_reg[11][1] QDFFN $PINS Q=bank_mem_1[11][1] D=bank_wdata[1][1]
+ CK=CTS_355
Xbank_mem_1_reg[11][0] QDFFN $PINS Q=bank_mem_1[11][0] D=bank_wdata[1][0]
+ CK=CTS_355
Xbank_mem_1_reg[8][20] QDFFN $PINS Q=bank_mem_1[8][20] D=bank_wdata[1][20]
+ CK=CTS_364
Xbank_mem_1_reg[8][19] QDFFN $PINS Q=bank_mem_1[8][19] D=bank_wdata[1][19]
+ CK=CTS_364
Xbank_mem_1_reg[8][18] QDFFN $PINS Q=bank_mem_1[8][18] D=bank_wdata[1][18]
+ CK=CTS_364
Xbank_mem_1_reg[8][17] QDFFN $PINS Q=bank_mem_1[8][17] D=bank_wdata[1][17]
+ CK=CTS_364
Xbank_mem_1_reg[8][16] QDFFN $PINS Q=bank_mem_1[8][16] D=bank_wdata[1][16]
+ CK=CTS_364
Xbank_mem_1_reg[8][15] QDFFN $PINS Q=bank_mem_1[8][15] D=bank_wdata[1][15]
+ CK=CTS_364
Xbank_mem_1_reg[8][14] QDFFN $PINS Q=bank_mem_1[8][14] D=bank_wdata[1][14]
+ CK=CTS_364
Xbank_mem_1_reg[8][13] QDFFN $PINS Q=bank_mem_1[8][13] D=bank_wdata[1][13]
+ CK=CTS_364
Xbank_mem_1_reg[8][12] QDFFN $PINS Q=bank_mem_1[8][12] D=bank_wdata[1][12]
+ CK=CTS_364
Xbank_mem_1_reg[8][11] QDFFN $PINS Q=bank_mem_1[8][11] D=bank_wdata[1][11]
+ CK=CTS_364
Xbank_mem_1_reg[8][10] QDFFN $PINS Q=bank_mem_1[8][10] D=bank_wdata[1][10]
+ CK=CTS_364
Xbank_mem_1_reg[8][9] QDFFN $PINS Q=bank_mem_1[8][9] D=bank_wdata[1][9]
+ CK=CTS_364
Xbank_mem_1_reg[8][8] QDFFN $PINS Q=bank_mem_1[8][8] D=bank_wdata[1][8]
+ CK=CTS_364
Xbank_mem_1_reg[8][7] QDFFN $PINS Q=bank_mem_1[8][7] D=bank_wdata[1][7]
+ CK=CTS_364
Xbank_mem_1_reg[8][6] QDFFN $PINS Q=bank_mem_1[8][6] D=bank_wdata[1][6]
+ CK=CTS_364
Xbank_mem_1_reg[8][5] QDFFN $PINS Q=bank_mem_1[8][5] D=bank_wdata[1][5]
+ CK=CTS_364
Xbank_mem_1_reg[8][4] QDFFN $PINS Q=bank_mem_1[8][4] D=bank_wdata[1][4]
+ CK=CTS_364
Xbank_mem_1_reg[8][3] QDFFN $PINS Q=bank_mem_1[8][3] D=bank_wdata[1][3]
+ CK=CTS_364
Xbank_mem_1_reg[8][2] QDFFN $PINS Q=bank_mem_1[8][2] D=bank_wdata[1][2]
+ CK=CTS_364
Xbank_mem_1_reg[8][1] QDFFN $PINS Q=bank_mem_1[8][1] D=bank_wdata[1][1]
+ CK=CTS_364
Xbank_mem_1_reg[8][0] QDFFN $PINS Q=bank_mem_1[8][0] D=bank_wdata[1][0]
+ CK=CTS_364
Xbank_mem_1_reg[9][21] QDFFN $PINS Q=bank_mem_1[9][21] D=bank_wdata[1][21]
+ CK=CTS_361
Xbank_mem_1_reg[10][20] QDFFN $PINS Q=bank_mem_1[10][20] D=bank_wdata[1][20]
+ CK=CTS_358
Xbank_mem_1_reg[10][19] QDFFN $PINS Q=bank_mem_1[10][19] D=bank_wdata[1][19]
+ CK=CTS_358
Xbank_mem_1_reg[10][18] QDFFN $PINS Q=bank_mem_1[10][18] D=bank_wdata[1][18]
+ CK=CTS_358
Xbank_mem_1_reg[10][17] QDFFN $PINS Q=bank_mem_1[10][17] D=bank_wdata[1][17]
+ CK=CTS_358
Xbank_mem_1_reg[10][16] QDFFN $PINS Q=bank_mem_1[10][16] D=bank_wdata[1][16]
+ CK=CTS_358
Xbank_mem_1_reg[10][15] QDFFN $PINS Q=bank_mem_1[10][15] D=bank_wdata[1][15]
+ CK=CTS_358
Xbank_mem_1_reg[10][14] QDFFN $PINS Q=bank_mem_1[10][14] D=bank_wdata[1][14]
+ CK=CTS_358
Xbank_mem_1_reg[10][13] QDFFN $PINS Q=bank_mem_1[10][13] D=bank_wdata[1][13]
+ CK=CTS_358
Xbank_mem_1_reg[10][12] QDFFN $PINS Q=bank_mem_1[10][12] D=bank_wdata[1][12]
+ CK=CTS_358
Xbank_mem_1_reg[10][11] QDFFN $PINS Q=bank_mem_1[10][11] D=bank_wdata[1][11]
+ CK=CTS_358
Xbank_mem_1_reg[10][10] QDFFN $PINS Q=bank_mem_1[10][10] D=bank_wdata[1][10]
+ CK=CTS_358
Xbank_mem_1_reg[10][9] QDFFN $PINS Q=bank_mem_1[10][9] D=bank_wdata[1][9]
+ CK=CTS_358
Xbank_mem_1_reg[10][8] QDFFN $PINS Q=bank_mem_1[10][8] D=bank_wdata[1][8]
+ CK=CTS_358
Xbank_mem_1_reg[10][7] QDFFN $PINS Q=bank_mem_1[10][7] D=bank_wdata[1][7]
+ CK=CTS_358
Xbank_mem_1_reg[10][6] QDFFN $PINS Q=bank_mem_1[10][6] D=bank_wdata[1][6]
+ CK=CTS_358
Xbank_mem_1_reg[10][5] QDFFN $PINS Q=bank_mem_1[10][5] D=bank_wdata[1][5]
+ CK=CTS_358
Xbank_mem_1_reg[10][4] QDFFN $PINS Q=bank_mem_1[10][4] D=bank_wdata[1][4]
+ CK=CTS_358
Xbank_mem_1_reg[10][3] QDFFN $PINS Q=bank_mem_1[10][3] D=bank_wdata[1][3]
+ CK=CTS_358
Xbank_mem_1_reg[10][2] QDFFN $PINS Q=bank_mem_1[10][2] D=bank_wdata[1][2]
+ CK=CTS_358
Xbank_mem_1_reg[10][1] QDFFN $PINS Q=bank_mem_1[10][1] D=bank_wdata[1][1]
+ CK=CTS_358
Xbank_mem_1_reg[10][0] QDFFN $PINS Q=bank_mem_1[10][0] D=bank_wdata[1][0]
+ CK=CTS_358
Xbank_mem_1_reg[11][21] QDFFN $PINS Q=bank_mem_1[11][21] D=bank_wdata[1][21]
+ CK=CTS_355
Xbank_mem_0_reg[9][20] QDFFN $PINS Q=bank_mem_0[9][20] D=bank_wdata[0][20]
+ CK=CTS_313
Xbank_mem_0_reg[9][19] QDFFN $PINS Q=bank_mem_0[9][19] D=bank_wdata[0][19]
+ CK=CTS_313
Xbank_mem_0_reg[9][18] QDFFN $PINS Q=bank_mem_0[9][18] D=bank_wdata[0][18]
+ CK=CTS_313
Xbank_mem_0_reg[9][17] QDFFN $PINS Q=bank_mem_0[9][17] D=bank_wdata[0][17]
+ CK=CTS_313
Xbank_mem_0_reg[9][16] QDFFN $PINS Q=bank_mem_0[9][16] D=bank_wdata[0][16]
+ CK=CTS_313
Xbank_mem_0_reg[9][15] QDFFN $PINS Q=bank_mem_0[9][15] D=bank_wdata[0][15]
+ CK=CTS_313
Xbank_mem_0_reg[9][14] QDFFN $PINS Q=bank_mem_0[9][14] D=bank_wdata[0][14]
+ CK=CTS_313
Xbank_mem_0_reg[9][13] QDFFN $PINS Q=bank_mem_0[9][13] D=bank_wdata[0][13]
+ CK=CTS_313
Xbank_mem_0_reg[9][12] QDFFN $PINS Q=bank_mem_0[9][12] D=bank_wdata[0][12]
+ CK=CTS_313
Xbank_mem_0_reg[9][11] QDFFN $PINS Q=bank_mem_0[9][11] D=bank_wdata[0][11]
+ CK=CTS_313
Xbank_mem_0_reg[9][10] QDFFN $PINS Q=bank_mem_0[9][10] D=bank_wdata[0][10]
+ CK=CTS_313
Xbank_mem_0_reg[9][9] QDFFN $PINS Q=bank_mem_0[9][9] D=bank_wdata[0][9]
+ CK=CTS_313
Xbank_mem_0_reg[9][8] QDFFN $PINS Q=bank_mem_0[9][8] D=bank_wdata[0][8]
+ CK=CTS_313
Xbank_mem_0_reg[9][7] QDFFN $PINS Q=bank_mem_0[9][7] D=bank_wdata[0][7]
+ CK=CTS_313
Xbank_mem_0_reg[9][6] QDFFN $PINS Q=bank_mem_0[9][6] D=bank_wdata[0][6]
+ CK=CTS_313
Xbank_mem_0_reg[9][5] QDFFN $PINS Q=bank_mem_0[9][5] D=bank_wdata[0][5]
+ CK=CTS_313
Xbank_mem_0_reg[9][4] QDFFN $PINS Q=bank_mem_0[9][4] D=bank_wdata[0][4]
+ CK=CTS_313
Xbank_mem_0_reg[9][3] QDFFN $PINS Q=bank_mem_0[9][3] D=bank_wdata[0][3]
+ CK=CTS_313
Xbank_mem_0_reg[9][2] QDFFN $PINS Q=bank_mem_0[9][2] D=bank_wdata[0][2]
+ CK=CTS_313
Xbank_mem_0_reg[9][1] QDFFN $PINS Q=bank_mem_0[9][1] D=bank_wdata[0][1]
+ CK=CTS_313
Xbank_mem_0_reg[9][0] QDFFN $PINS Q=bank_mem_0[9][0] D=bank_wdata[0][0]
+ CK=CTS_313
Xbank_mem_0_reg[11][20] QDFFN $PINS Q=bank_mem_0[11][20] D=bank_wdata[0][20]
+ CK=CTS_307
Xbank_mem_0_reg[11][19] QDFFN $PINS Q=bank_mem_0[11][19] D=bank_wdata[0][19]
+ CK=CTS_307
Xbank_mem_0_reg[11][18] QDFFN $PINS Q=bank_mem_0[11][18] D=bank_wdata[0][18]
+ CK=CTS_307
Xbank_mem_0_reg[11][17] QDFFN $PINS Q=bank_mem_0[11][17] D=bank_wdata[0][17]
+ CK=CTS_307
Xbank_mem_0_reg[11][16] QDFFN $PINS Q=bank_mem_0[11][16] D=bank_wdata[0][16]
+ CK=CTS_307
Xbank_mem_0_reg[11][15] QDFFN $PINS Q=bank_mem_0[11][15] D=bank_wdata[0][15]
+ CK=CTS_307
Xbank_mem_0_reg[11][14] QDFFN $PINS Q=bank_mem_0[11][14] D=bank_wdata[0][14]
+ CK=CTS_307
Xbank_mem_0_reg[11][13] QDFFN $PINS Q=bank_mem_0[11][13] D=bank_wdata[0][13]
+ CK=CTS_307
Xbank_mem_0_reg[11][12] QDFFN $PINS Q=bank_mem_0[11][12] D=bank_wdata[0][12]
+ CK=CTS_307
Xbank_mem_0_reg[11][11] QDFFN $PINS Q=bank_mem_0[11][11] D=bank_wdata[0][11]
+ CK=CTS_307
Xbank_mem_0_reg[11][10] QDFFN $PINS Q=bank_mem_0[11][10] D=bank_wdata[0][10]
+ CK=CTS_307
Xbank_mem_0_reg[11][9] QDFFN $PINS Q=bank_mem_0[11][9] D=bank_wdata[0][9]
+ CK=CTS_307
Xbank_mem_0_reg[11][8] QDFFN $PINS Q=bank_mem_0[11][8] D=bank_wdata[0][8]
+ CK=CTS_307
Xbank_mem_0_reg[11][7] QDFFN $PINS Q=bank_mem_0[11][7] D=bank_wdata[0][7]
+ CK=CTS_307
Xbank_mem_0_reg[11][6] QDFFN $PINS Q=bank_mem_0[11][6] D=bank_wdata[0][6]
+ CK=CTS_307
Xbank_mem_0_reg[11][5] QDFFN $PINS Q=bank_mem_0[11][5] D=bank_wdata[0][5]
+ CK=CTS_307
Xbank_mem_0_reg[11][4] QDFFN $PINS Q=bank_mem_0[11][4] D=bank_wdata[0][4]
+ CK=CTS_307
Xbank_mem_0_reg[11][3] QDFFN $PINS Q=bank_mem_0[11][3] D=bank_wdata[0][3]
+ CK=CTS_307
Xbank_mem_0_reg[11][2] QDFFN $PINS Q=bank_mem_0[11][2] D=bank_wdata[0][2]
+ CK=CTS_307
Xbank_mem_0_reg[11][1] QDFFN $PINS Q=bank_mem_0[11][1] D=bank_wdata[0][1]
+ CK=CTS_307
Xbank_mem_0_reg[11][0] QDFFN $PINS Q=bank_mem_0[11][0] D=bank_wdata[0][0]
+ CK=CTS_307
Xbank_mem_1_reg[8][21] QDFFN $PINS Q=bank_mem_1[8][21] D=bank_wdata[1][21]
+ CK=CTS_364
Xbank_mem_1_reg[10][21] QDFFN $PINS Q=bank_mem_1[10][21] D=bank_wdata[1][21]
+ CK=CTS_358
Xbank_mem_0_reg[8][20] QDFFN $PINS Q=bank_mem_0[8][20] D=bank_wdata[0][20]
+ CK=CTS_316
Xbank_mem_0_reg[8][19] QDFFN $PINS Q=bank_mem_0[8][19] D=bank_wdata[0][19]
+ CK=CTS_316
Xbank_mem_0_reg[8][18] QDFFN $PINS Q=bank_mem_0[8][18] D=bank_wdata[0][18]
+ CK=CTS_316
Xbank_mem_0_reg[8][17] QDFFN $PINS Q=bank_mem_0[8][17] D=bank_wdata[0][17]
+ CK=CTS_316
Xbank_mem_0_reg[8][16] QDFFN $PINS Q=bank_mem_0[8][16] D=bank_wdata[0][16]
+ CK=CTS_316
Xbank_mem_0_reg[8][15] QDFFN $PINS Q=bank_mem_0[8][15] D=bank_wdata[0][15]
+ CK=CTS_316
Xbank_mem_0_reg[8][14] QDFFN $PINS Q=bank_mem_0[8][14] D=bank_wdata[0][14]
+ CK=CTS_316
Xbank_mem_0_reg[8][13] QDFFN $PINS Q=bank_mem_0[8][13] D=bank_wdata[0][13]
+ CK=CTS_316
Xbank_mem_0_reg[8][12] QDFFN $PINS Q=bank_mem_0[8][12] D=bank_wdata[0][12]
+ CK=CTS_316
Xbank_mem_0_reg[8][11] QDFFN $PINS Q=bank_mem_0[8][11] D=bank_wdata[0][11]
+ CK=CTS_316
Xbank_mem_0_reg[8][10] QDFFN $PINS Q=bank_mem_0[8][10] D=bank_wdata[0][10]
+ CK=CTS_316
Xbank_mem_0_reg[8][9] QDFFN $PINS Q=bank_mem_0[8][9] D=bank_wdata[0][9]
+ CK=CTS_316
Xbank_mem_0_reg[8][8] QDFFN $PINS Q=bank_mem_0[8][8] D=bank_wdata[0][8]
+ CK=CTS_316
Xbank_mem_0_reg[8][7] QDFFN $PINS Q=bank_mem_0[8][7] D=bank_wdata[0][7]
+ CK=CTS_316
Xbank_mem_0_reg[8][6] QDFFN $PINS Q=bank_mem_0[8][6] D=bank_wdata[0][6]
+ CK=CTS_316
Xbank_mem_0_reg[8][5] QDFFN $PINS Q=bank_mem_0[8][5] D=bank_wdata[0][5]
+ CK=CTS_316
Xbank_mem_0_reg[8][4] QDFFN $PINS Q=bank_mem_0[8][4] D=bank_wdata[0][4]
+ CK=CTS_316
Xbank_mem_0_reg[8][3] QDFFN $PINS Q=bank_mem_0[8][3] D=bank_wdata[0][3]
+ CK=CTS_316
Xbank_mem_0_reg[8][2] QDFFN $PINS Q=bank_mem_0[8][2] D=bank_wdata[0][2]
+ CK=CTS_316
Xbank_mem_0_reg[8][1] QDFFN $PINS Q=bank_mem_0[8][1] D=bank_wdata[0][1]
+ CK=CTS_316
Xbank_mem_0_reg[8][0] QDFFN $PINS Q=bank_mem_0[8][0] D=bank_wdata[0][0]
+ CK=CTS_316
Xbank_mem_0_reg[9][21] QDFFN $PINS Q=bank_mem_0[9][21] D=bank_wdata[0][21]
+ CK=CTS_313
Xbank_mem_0_reg[10][20] QDFFN $PINS Q=bank_mem_0[10][20] D=bank_wdata[0][20]
+ CK=CTS_310
Xbank_mem_0_reg[10][19] QDFFN $PINS Q=bank_mem_0[10][19] D=bank_wdata[0][19]
+ CK=CTS_310
Xbank_mem_0_reg[10][18] QDFFN $PINS Q=bank_mem_0[10][18] D=bank_wdata[0][18]
+ CK=CTS_310
Xbank_mem_0_reg[10][17] QDFFN $PINS Q=bank_mem_0[10][17] D=bank_wdata[0][17]
+ CK=CTS_310
Xbank_mem_0_reg[10][16] QDFFN $PINS Q=bank_mem_0[10][16] D=bank_wdata[0][16]
+ CK=CTS_310
Xbank_mem_0_reg[10][15] QDFFN $PINS Q=bank_mem_0[10][15] D=bank_wdata[0][15]
+ CK=CTS_310
Xbank_mem_0_reg[10][14] QDFFN $PINS Q=bank_mem_0[10][14] D=bank_wdata[0][14]
+ CK=CTS_310
Xbank_mem_0_reg[10][13] QDFFN $PINS Q=bank_mem_0[10][13] D=bank_wdata[0][13]
+ CK=CTS_310
Xbank_mem_0_reg[10][12] QDFFN $PINS Q=bank_mem_0[10][12] D=bank_wdata[0][12]
+ CK=CTS_310
Xbank_mem_0_reg[10][11] QDFFN $PINS Q=bank_mem_0[10][11] D=bank_wdata[0][11]
+ CK=CTS_310
Xbank_mem_0_reg[10][10] QDFFN $PINS Q=bank_mem_0[10][10] D=bank_wdata[0][10]
+ CK=CTS_310
Xbank_mem_0_reg[10][9] QDFFN $PINS Q=bank_mem_0[10][9] D=bank_wdata[0][9]
+ CK=CTS_310
Xbank_mem_0_reg[10][8] QDFFN $PINS Q=bank_mem_0[10][8] D=bank_wdata[0][8]
+ CK=CTS_310
Xbank_mem_0_reg[10][7] QDFFN $PINS Q=bank_mem_0[10][7] D=bank_wdata[0][7]
+ CK=CTS_310
Xbank_mem_0_reg[10][6] QDFFN $PINS Q=bank_mem_0[10][6] D=bank_wdata[0][6]
+ CK=CTS_310
Xbank_mem_0_reg[10][5] QDFFN $PINS Q=bank_mem_0[10][5] D=bank_wdata[0][5]
+ CK=CTS_310
Xbank_mem_0_reg[10][4] QDFFN $PINS Q=bank_mem_0[10][4] D=bank_wdata[0][4]
+ CK=CTS_310
Xbank_mem_0_reg[10][3] QDFFN $PINS Q=bank_mem_0[10][3] D=bank_wdata[0][3]
+ CK=CTS_310
Xbank_mem_0_reg[10][2] QDFFN $PINS Q=bank_mem_0[10][2] D=bank_wdata[0][2]
+ CK=CTS_310
Xbank_mem_0_reg[10][1] QDFFN $PINS Q=bank_mem_0[10][1] D=bank_wdata[0][1]
+ CK=CTS_310
Xbank_mem_0_reg[10][0] QDFFN $PINS Q=bank_mem_0[10][0] D=bank_wdata[0][0]
+ CK=CTS_310
Xbank_mem_0_reg[11][21] QDFFN $PINS Q=bank_mem_0[11][21] D=bank_wdata[0][21]
+ CK=CTS_307
Xbank_mem_0_reg[8][21] QDFFN $PINS Q=bank_mem_0[8][21] D=bank_wdata[0][21]
+ CK=CTS_316
Xbank_mem_0_reg[10][21] QDFFN $PINS Q=bank_mem_0[10][21] D=bank_wdata[0][21]
+ CK=CTS_310
Xread_data_1_reg[9] QDFFRBN $PINS Q=read_data_1[9] D=N115 CK=clk_clone1
+ RB=FE_OFN26_i_rst_n
Xread_data_1_reg[20] QDFFRBN $PINS Q=read_data_1[20] D=FE_PHN1407_N104 CK=clk
+ RB=FE_OFN26_i_rst_n
Xread_data_1_reg[10] QDFFRBN $PINS Q=read_data_1[10] D=FE_PHN1360_N114
+ CK=clk_clone1 RB=FE_OFN26_i_rst_n
Xread_data_1_reg[21] QDFFRBN $PINS Q=read_data_1[21] D=FE_PHN1402_N103 CK=clk
+ RB=FE_OFN26_i_rst_n
Xread_data_1_reg[8] QDFFRBN $PINS Q=read_data_1[8] D=FE_PHN1401_N116 CK=clk
+ RB=FE_OFN26_i_rst_n
Xread_data_1_reg[19] QDFFRBN $PINS Q=read_data_1[19] D=FE_PHN1404_N105 CK=clk
+ RB=FE_OFN26_i_rst_n
Xread_data_1_reg[7] QDFFRBN $PINS Q=read_data_1[7] D=N117 CK=clk
+ RB=FE_OFN26_i_rst_n
Xread_data_1_reg[18] QDFFRBN $PINS Q=read_data_1[18] D=FE_PHN1405_N106 CK=clk
+ RB=FE_OFN26_i_rst_n
Xread_data_1_reg[6] QDFFRBN $PINS Q=read_data_1[6] D=N118 CK=clk_clone1
+ RB=FE_OFN26_i_rst_n
Xread_data_1_reg[17] QDFFRBN $PINS Q=read_data_1[17] D=N107 CK=clk_clone1
+ RB=i_rst_n
Xread_data_1_reg[5] QDFFRBN $PINS Q=read_data_1[5] D=FE_PHN1369_N119
+ CK=clk_clone1 RB=i_rst_n
Xread_data_1_reg[16] QDFFRBN $PINS Q=read_data_1[16] D=FE_PHN1376_N108
+ CK=clk_clone1 RB=i_rst_n
Xread_data_1_reg[4] QDFFRBN $PINS Q=read_data_1[4] D=N120 CK=clk_clone1
+ RB=i_rst_n
Xread_data_1_reg[15] QDFFRBN $PINS Q=read_data_1[15] D=FE_PHN1361_N109
+ CK=clk_clone1 RB=i_rst_n
Xread_data_1_reg[14] QDFFRBN $PINS Q=read_data_1[14] D=FE_PHN1393_N110
+ CK=clk_clone1 RB=i_rst_n
Xread_data_1_reg[3] QDFFRBN $PINS Q=read_data_1[3] D=FE_PHN1368_N121
+ CK=clk_clone1 RB=i_rst_n
Xread_data_1_reg[2] QDFFRBN $PINS Q=read_data_1[2] D=N122 CK=clk_clone1
+ RB=i_rst_n
Xread_data_1_reg[1] QDFFRBN $PINS Q=read_data_1[1] D=N123 CK=clk_clone1
+ RB=i_rst_n
Xread_data_1_reg[12] QDFFRBN $PINS Q=read_data_1[12] D=N112 CK=clk_clone1
+ RB=i_rst_n
Xread_data_1_reg[13] QDFFRBN $PINS Q=read_data_1[13] D=FE_PHN1438_N111
+ CK=clk_clone1 RB=i_rst_n
Xread_data_1_reg[11] QDFFRBN $PINS Q=read_data_1[11] D=FE_PHN1392_N113
+ CK=clk_clone1 RB=FE_OFN26_i_rst_n
Xread_data_1_reg[0] QDFFRBN $PINS Q=read_data_1[0] D=N124 CK=clk_clone1
+ RB=i_rst_n
XU5 ND2P $PINS O=n9 I1=wen2 I2=n93
XU7 AN2 $PINS O=n1 I1=n18 I2=n309
XU8 AN2 $PINS O=n2 I1=n326 I2=n580
XU9 AN2 $PINS O=n3 I1=n17 I2=n309
XU10 AN2 $PINS O=n4 I1=n325 I2=n580
XU11 AN2 $PINS O=n5 I1=n19 I2=n20
XU12 AN2 $PINS O=n6 I1=n19 I2=n16
XU13 AN2 $PINS O=n7 I1=n327 I2=n328
XU14 AN2 $PINS O=n8 I1=n327 I2=n324
XU15 ND2S $PINS O=n89 I1=n646 I2=n87
XU16 ND2S $PINS O=n82 I1=n644 I2=n92
XU19 INV1S $PINS O=n649 I=write_addr_2[2]
XU20 NR2 $PINS O=N67 I1=n78 I2=n79
XU21 NR2 $PINS O=N65 I1=n78 I2=n81
XU22 NR2 $PINS O=N63 I1=n78 I2=n82
XU23 NR2 $PINS O=N61 I1=n78 I2=n83
XU24 NR2 $PINS O=N98 I1=n67 I2=n68
XU25 NR2 $PINS O=N96 I1=n67 I2=n69
XU26 NR2 $PINS O=N94 I1=n67 I2=n70
XU27 NR2 $PINS O=N92 I1=n66 I2=n73
XU28 NR2 $PINS O=N59 I1=n79 I2=n89
XU29 NR2 $PINS O=N100 I1=n66 I2=n67
XU30 NR2 $PINS O=N90 I1=n68 I2=n73
XU31 NR2 $PINS O=N57 I1=n81 I2=n89
XU32 NR2 $PINS O=N88 I1=n69 I2=n73
XU33 NR2 $PINS O=N86 I1=n70 I2=n73
XU34 NR2 $PINS O=N55 I1=n82 I2=n89
XU35 NR2 $PINS O=N53 I1=n83 I2=n89
XU36 NR2 $PINS O=N99 I1=n65 I2=n66
XU37 NR2 $PINS O=N97 I1=n65 I2=n68
XU38 NR2 $PINS O=N95 I1=n65 I2=n69
XU39 NR2 $PINS O=N93 I1=n65 I2=n70
XU40 NR2 $PINS O=N64 I1=n80 I2=n81
XU41 NR2 $PINS O=N62 I1=n80 I2=n82
XU42 NR2 $PINS O=N60 I1=n80 I2=n83
XU43 NR2 $PINS O=N91 I1=n66 I2=n74
XU44 NR2 $PINS O=N66 I1=n79 I2=n80
XU45 NR2 $PINS O=N58 I1=n79 I2=n90
XU46 NR2 $PINS O=N89 I1=n68 I2=n74
XU47 NR2 $PINS O=N56 I1=n81 I2=n90
XU48 NR2 $PINS O=N87 I1=n69 I2=n74
XU49 NR2 $PINS O=N85 I1=n70 I2=n74
XU50 NR2 $PINS O=N54 I1=n82 I2=n90
XU51 NR2 $PINS O=N52 I1=n83 I2=n90
XU52 INV1S $PINS O=n641 I=n75
XU53 INV1S $PINS O=n644 I=n91
XU54 INV1S $PINS O=n645 I=n92
XU55 INV1S $PINS O=n640 I=n76
XU57 OAI22S $PINS O=n87 A1=n652 A2=n63 B1=n653 B2=n64
XU58 OAI22S $PINS O=n77 A1=n652 A2=n9 B1=n653 B2=n62
XU59 OAI22S $PINS O=n92 A1=n647 A2=n63 B1=n648 B2=n64
XU60 OAI22S $PINS O=n76 A1=n647 A2=n9 B1=n648 B2=n62
XU61 OAI22S $PINS O=n75 A1=n649 A2=n9 B1=n650 B2=n62
XU62 OAI22S $PINS O=n91 A1=n649 A2=n63 B1=n650 B2=n64
XU63 ND3P $PINS O=n64 I1=wen1 I2=n63 I3=n88
XU64 ND3P $PINS O=n62 I1=n643 I2=n9 I3=wen1
XU66 AOI12HS $PINS O=n71 A1=n77 B1=n9 B2=n95
XU67 AOI12HS $PINS O=n84 A1=n87 B1=n63 B2=n86
XU68 INV1S $PINS O=n646 I=n85
XU69 INV1S $PINS O=n642 I=n72
XU70 INV1S $PINS O=n643 I=n88
XU72 OAI22S $PINS O=n85 A1=p_1 A2=n63 B1=n651 B2=n64
XU73 OAI22S $PINS O=n72 A1=p_1 A2=n9 B1=n651 B2=n62
XU74 XOR2HS $PINS O=n97 I1=write_addr_2[4] I2=write_addr_2[3]
XU75 XOR2HS $PINS O=n96 I1=write_addr_1[4] I2=write_addr_1[3]
XU76 INV1S $PINS O=n648 I=write_addr_1[3]
XU77 INV1S $PINS O=n653 I=write_addr_1[4]
XU78 INV1S $PINS O=n650 I=write_addr_1[2]
XU79 INV1S $PINS O=n647 I=write_addr_2[3]
XU80 INV1S $PINS O=n652 I=write_addr_2[4]
XU81 OAI22H $PINS O=bank_wdata[0][1] A1=n609 A2=n63 B1=n631 B2=n64
XU82 OAI22H $PINS O=bank_wdata[0][2] A1=n610 A2=n63 B1=n632 B2=n64
XU83 OAI22H $PINS O=bank_wdata[0][3] A1=n611 A2=n63 B1=n633 B2=n64
XU84 OAI22H $PINS O=bank_wdata[0][4] A1=n612 A2=n63 B1=n634 B2=n64
XU85 OAI22H $PINS O=bank_wdata[0][5] A1=n613 A2=n63 B1=n635 B2=n64
XU86 OAI22H $PINS O=bank_wdata[0][6] A1=FE_PHN1469_n614 A2=n63 B1=n636 B2=n64
XU87 OAI22H $PINS O=bank_wdata[0][7] A1=n615 A2=n63 B1=n637 B2=n64
XU88 OAI22H $PINS O=bank_wdata[0][8] A1=n616 A2=n63 B1=n638 B2=n64
XU89 OAI22H $PINS O=bank_wdata[0][9] A1=FE_PHN1448_n617 A2=n63 B1=n639 B2=n64
XU90 OAI22H $PINS O=bank_wdata[0][10] A1=FE_PHN1463_n608 A2=n63 B1=n630 B2=n64
XU91 OAI22H $PINS O=bank_wdata[0][11] A1=n596 A2=n63 B1=n618 B2=n64
XU92 OAI22H $PINS O=bank_wdata[0][12] A1=n597 A2=n63 B1=n619 B2=n64
XU93 OAI22H $PINS O=bank_wdata[0][13] A1=n598 A2=n63 B1=n620 B2=n64
XU94 OAI22H $PINS O=bank_wdata[0][14] A1=n599 A2=n63 B1=n621 B2=n64
XU95 OAI22H $PINS O=bank_wdata[0][15] A1=n600 A2=n63 B1=n622 B2=n64
XU96 OAI22H $PINS O=bank_wdata[0][16] A1=n601 A2=n63 B1=n623 B2=n64
XU97 OAI22H $PINS O=bank_wdata[0][17] A1=n602 A2=n63 B1=n624 B2=n64
XU98 OAI22H $PINS O=bank_wdata[0][18] A1=n603 A2=n63 B1=n625 B2=n64
XU99 OAI22H $PINS O=bank_wdata[0][19] A1=n604 A2=n63 B1=n626 B2=n64
XU100 OAI22H $PINS O=bank_wdata[0][20] A1=n605 A2=n63 B1=n627 B2=n64
XU101 OAI22H $PINS O=bank_wdata[0][21] A1=n606 A2=n63 B1=n628 B2=n64
XU102 OAI22H $PINS O=bank_wdata[0][0] A1=n607 A2=n63 B1=n629 B2=n64
XU103 OAI22H $PINS O=bank_wdata[1][1] A1=n9 A2=n609 B1=n62 B2=n631
XU104 OAI22H $PINS O=bank_wdata[1][2] A1=n9 A2=n610 B1=n62 B2=n632
XU105 OAI22H $PINS O=bank_wdata[1][3] A1=n9 A2=n611 B1=n62 B2=n633
XU106 OAI22H $PINS O=bank_wdata[1][4] A1=n9 A2=n612 B1=n62 B2=n634
XU107 OAI22H $PINS O=bank_wdata[1][5] A1=n9 A2=n613 B1=n62 B2=n635
XU108 OAI22H $PINS O=bank_wdata[1][6] A1=n9 A2=FE_PHN1469_n614 B1=n62 B2=n636
XU109 OAI22H $PINS O=bank_wdata[1][16] A1=n9 A2=n601 B1=n62 B2=n623
XU110 OAI22H $PINS O=bank_wdata[1][17] A1=n9 A2=n602 B1=n62 B2=n624
XU111 OAI22H $PINS O=bank_wdata[1][18] A1=n9 A2=n603 B1=n62 B2=n625
XU112 OAI22H $PINS O=bank_wdata[1][19] A1=n9 A2=n604 B1=n62 B2=n626
XU113 OAI22H $PINS O=bank_wdata[1][20] A1=n9 A2=n605 B1=n62 B2=n627
XU114 OAI22H $PINS O=bank_wdata[1][21] A1=n9 A2=n606 B1=n62 B2=n628
XU115 OAI22H $PINS O=bank_wdata[1][10] A1=n9 A2=FE_PHN1463_n608 B1=n62 B2=n630
XU116 OAI22H $PINS O=bank_wdata[1][11] A1=n9 A2=n596 B1=n62 B2=n618
XU117 OAI22H $PINS O=bank_wdata[1][12] A1=n9 A2=n597 B1=n62 B2=n619
XU118 OAI22H $PINS O=bank_wdata[1][13] A1=n9 A2=n598 B1=n62 B2=n620
XU119 OAI22H $PINS O=bank_wdata[1][14] A1=n9 A2=n599 B1=n62 B2=n621
XU120 OAI22H $PINS O=bank_wdata[1][15] A1=n9 A2=n600 B1=n62 B2=n622
XU121 OAI22H $PINS O=bank_wdata[1][0] A1=n9 A2=FE_PHN1455_n607 B1=n62 B2=n629
XU122 OAI22H $PINS O=bank_wdata[1][7] A1=n9 A2=FE_PHN1457_n615 B1=n62 B2=n637
XU123 OAI22H $PINS O=bank_wdata[1][8] A1=n9 A2=FE_PHN1471_n616 B1=n62 B2=n638
XU124 OAI22H $PINS O=bank_wdata[1][9] A1=n9 A2=FE_PHN1448_n617 B1=n62 B2=n639
XU125 INV1S $PINS O=n589 I=n98
XU126 XNR2HS $PINS O=n94 I1=read_addr_1[4] I2=read_addr_1[3]
XU129 AN2 $PINS O=n298 I1=n21 I2=n18
XU130 AN2 $PINS O=n569 I1=n329 I2=n326
XU133 AN2 $PINS O=n301 I1=n19 I2=n18
XU134 AN2 $PINS O=n572 I1=n327 I2=n326
XU137 AN2 $PINS O=n297 I1=n21 I2=n17
XU138 AN2 $PINS O=n568 I1=n329 I2=n325
XU140 AN2 $PINS O=n571 I1=n329 I2=n328
XU142 AN2 $PINS O=n300 I1=n21 I2=n20
XU143 AN2 $PINS O=n288 I1=n20 I2=n309
XU144 AN2 $PINS O=n559 I1=n328 I2=n580
XU145 AN2 $PINS O=n296 I1=n19 I2=n17
XU146 AN2 $PINS O=n567 I1=n327 I2=n325
XU147 AN2 $PINS O=n289 I1=n16 I2=n309
XU148 AN2 $PINS O=n560 I1=n324 I2=n580
XU149 AN2 $PINS O=n299 I1=n21 I2=n16
XU150 AN2 $PINS O=n570 I1=n329 I2=n324
XU151 INV1S $PINS O=n651 I=write_addr_1[1]
XU152 INV1S $PINS O=n631 I=write_data_1[1]
XU153 INV1S $PINS O=n632 I=write_data_1[2]
XU163 INV1S $PINS O=n633 I=write_data_1[3]
XU165 INV1S $PINS O=n634 I=write_data_1[4]
XU166 INV1S $PINS O=n635 I=write_data_1[5]
XU197 INV1S $PINS O=n636 I=write_data_1[6]
XU199 INV1S $PINS O=n637 I=write_data_1[7]
XU200 INV1S $PINS O=n638 I=write_data_1[8]
XU201 INV1S $PINS O=n639 I=write_data_1[9]
XU202 INV1S $PINS O=n618 I=write_data_1[11]
XU203 INV1S $PINS O=n619 I=write_data_1[12]
XU204 INV1S $PINS O=n620 I=write_data_1[13]
XU205 INV1S $PINS O=n621 I=write_data_1[14]
XU206 INV1S $PINS O=n622 I=write_data_1[15]
XU207 INV1S $PINS O=n623 I=write_data_1[16]
XU208 INV1S $PINS O=n624 I=write_data_1[17]
XU209 INV1S $PINS O=n625 I=write_data_1[18]
XU210 INV1S $PINS O=n626 I=write_data_1[19]
XU211 INV1S $PINS O=n627 I=write_data_1[20]
XU212 INV1S $PINS O=n629 I=write_data_1[0]
XU213 INV1S $PINS O=n608 I=write_data_2[10]
XU214 INV1S $PINS O=n606 I=write_data_2[21]
XU215 INV1S $PINS O=n630 I=write_data_1[10]
XU216 INV1S $PINS O=n628 I=write_data_1[21]
XU217 INV1S $PINS O=n609 I=write_data_2[1]
XU218 INV1S $PINS O=n610 I=write_data_2[2]
XU219 INV1S $PINS O=n611 I=write_data_2[3]
XU220 INV1S $PINS O=n612 I=write_data_2[4]
XU221 INV1S $PINS O=n613 I=write_data_2[5]
XU222 INV1S $PINS O=n614 I=write_data_2[6]
XU223 INV1S $PINS O=n615 I=write_data_2[7]
XU224 INV1S $PINS O=n616 I=write_data_2[8]
XU225 INV1S $PINS O=n617 I=write_data_2[9]
XU226 INV1S $PINS O=n601 I=write_data_2[16]
XU227 INV1S $PINS O=n602 I=write_data_2[17]
XU228 INV1S $PINS O=n603 I=write_data_2[18]
XU229 INV1S $PINS O=n604 I=write_data_2[19]
XU230 INV1S $PINS O=n605 I=write_data_2[20]
XU231 INV1S $PINS O=n607 I=write_data_2[0]
XU232 INV1S $PINS O=n596 I=write_data_2[11]
XU233 INV1S $PINS O=n597 I=write_data_2[12]
XU234 INV1S $PINS O=n598 I=write_data_2[13]
XU235 INV1S $PINS O=n599 I=write_data_2[14]
XU236 INV1S $PINS O=n600 I=write_data_2[15]
XU239 AN2 $PINS O=n287 I1=n18 I2=N29
XU240 AN2 $PINS O=n558 I1=n326 I2=N33
XU242 AN2 $PINS O=n556 I1=n325 I2=N33
XU244 AN2 $PINS O=n285 I1=n17 I2=N29
XU247 AN2 $PINS O=n284 I1=N29 I2=n20
XU248 AN2 $PINS O=n555 I1=N33 I2=n328
XU251 AN2 $PINS O=n286 I1=n16 I2=N29
XU252 AN2 $PINS O=n557 I1=n324 I2=N33
XU253 INV1S $PINS O=n580 I=N33
XU254 INV1S $PINS O=n309 I=N29
XU255 INV1S $PINS O=n579 I=N32
XU256 INV1S $PINS O=n308 I=N28
XU257 INV1S $PINS O=n578 I=N31
XU258 INV1S $PINS O=n307 I=N27
XU259 NR2 $PINS O=n19 I1=n309 I2=N30
XU260 NR2 $PINS O=n20 I1=n308 I2=n307
XU261 NR2 $PINS O=n17 I1=n308 I2=N27
XU262 AOI22S $PINS O=n14 A1=bank_mem_0[14][0] A2=n285 B1=bank_mem_0[15][0]
+ B2=n284
XU263 NR2 $PINS O=n18 I1=N27 I2=N28
XU264 NR2 $PINS O=n16 I1=n307 I2=N28
XU265 AOI22S $PINS O=n13 A1=bank_mem_0[12][0] A2=n287 B1=bank_mem_0[13][0]
+ B2=n286
XU266 AOI22S $PINS O=n11 A1=bank_mem_0[10][0] A2=n3 B1=bank_mem_0[11][0]
+ B2=n288
XU267 AOI22S $PINS O=n10 A1=bank_mem_0[8][0] A2=n1 B1=bank_mem_0[9][0] B2=n289
XU268 AN2 $PINS O=n12 I1=n11 I2=n10
XU269 ND3 $PINS O=n15 I1=n14 I2=n13 I3=n12
XU270 AOI22S $PINS O=n26 A1=bank_mem_0[7][0] A2=n5 B1=n15 B2=N30
XU271 AOI22S $PINS O=n25 A1=bank_mem_0[5][0] A2=n6 B1=bank_mem_0[6][0] B2=n296
XU272 NR2 $PINS O=n21 I1=N29 I2=N30
XU273 AO222 $PINS O=n23 A1=bank_mem_0[1][0] A2=n299 B1=bank_mem_0[0][0] B2=n298
+ C1=bank_mem_0[2][0] C2=n297
XU274 AO22 $PINS O=n22 A1=bank_mem_0[4][0] A2=n301 B1=bank_mem_0[3][0] B2=n300
XU275 NR2 $PINS O=n24 I1=n23 I2=n22
XU276 ND3 $PINS O=bank_rdata[0][0] I1=n26 I2=n25 I3=n24
XU277 AOI22S $PINS O=n31 A1=bank_mem_0[14][1] A2=n285 B1=bank_mem_0[15][1]
+ B2=n284
XU278 AOI22S $PINS O=n30 A1=bank_mem_0[12][1] A2=n287 B1=bank_mem_0[13][1]
+ B2=n286
XU279 AOI22S $PINS O=n28 A1=bank_mem_0[10][1] A2=n3 B1=bank_mem_0[11][1]
+ B2=n288
XU280 AOI22S $PINS O=n27 A1=bank_mem_0[8][1] A2=n1 B1=bank_mem_0[9][1] B2=n289
XU281 AN2 $PINS O=n29 I1=n28 I2=n27
XU282 ND3 $PINS O=n32 I1=n31 I2=n30 I3=n29
XU283 AOI22S $PINS O=n37 A1=bank_mem_0[7][1] A2=n5 B1=n32 B2=N30
XU284 AOI22S $PINS O=n36 A1=bank_mem_0[5][1] A2=n6 B1=bank_mem_0[6][1] B2=n296
XU285 AO222 $PINS O=n34 A1=bank_mem_0[1][1] A2=n299 B1=bank_mem_0[0][1] B2=n298
+ C1=bank_mem_0[2][1] C2=n297
XU286 AO22 $PINS O=n33 A1=bank_mem_0[4][1] A2=n301 B1=bank_mem_0[3][1] B2=n300
XU287 NR2 $PINS O=n35 I1=n34 I2=n33
XU288 ND3 $PINS O=bank_rdata[0][1] I1=n37 I2=n36 I3=n35
XU289 AOI22S $PINS O=n42 A1=bank_mem_0[14][2] A2=n285 B1=bank_mem_0[15][2]
+ B2=n284
XU290 AOI22S $PINS O=n41 A1=bank_mem_0[12][2] A2=n287 B1=bank_mem_0[13][2]
+ B2=n286
XU291 AOI22S $PINS O=n39 A1=bank_mem_0[10][2] A2=n3 B1=bank_mem_0[11][2]
+ B2=n288
XU292 AOI22S $PINS O=n38 A1=bank_mem_0[8][2] A2=n1 B1=bank_mem_0[9][2] B2=n289
XU293 AN2 $PINS O=n40 I1=n39 I2=n38
XU294 ND3 $PINS O=n43 I1=n42 I2=n41 I3=n40
XU295 AOI22S $PINS O=n48 A1=bank_mem_0[7][2] A2=n5 B1=n43 B2=N30
XU296 AOI22S $PINS O=n47 A1=bank_mem_0[5][2] A2=n6 B1=bank_mem_0[6][2] B2=n296
XU297 AO222 $PINS O=n45 A1=bank_mem_0[1][2] A2=n299 B1=bank_mem_0[0][2] B2=n298
+ C1=bank_mem_0[2][2] C2=n297
XU298 AO22 $PINS O=n44 A1=bank_mem_0[4][2] A2=n301 B1=bank_mem_0[3][2] B2=n300
XU299 NR2 $PINS O=n46 I1=n45 I2=n44
XU300 ND3 $PINS O=bank_rdata[0][2] I1=n48 I2=n47 I3=n46
XU301 AOI22S $PINS O=n53 A1=bank_mem_0[14][3] A2=n285 B1=bank_mem_0[15][3]
+ B2=n284
XU302 AOI22S $PINS O=n52 A1=bank_mem_0[12][3] A2=n287 B1=bank_mem_0[13][3]
+ B2=n286
XU303 AOI22S $PINS O=n50 A1=bank_mem_0[10][3] A2=n3 B1=bank_mem_0[11][3]
+ B2=n288
XU304 AOI22S $PINS O=n49 A1=bank_mem_0[8][3] A2=n1 B1=bank_mem_0[9][3] B2=n289
XU305 AN2 $PINS O=n51 I1=n50 I2=n49
XU306 ND3 $PINS O=n54 I1=n53 I2=n52 I3=n51
XU307 AOI22S $PINS O=n59 A1=bank_mem_0[7][3] A2=n5 B1=n54 B2=N30
XU308 AOI22S $PINS O=n58 A1=bank_mem_0[5][3] A2=n6 B1=bank_mem_0[6][3] B2=n296
XU309 AO222 $PINS O=n56 A1=bank_mem_0[1][3] A2=n299 B1=bank_mem_0[0][3] B2=n298
+ C1=bank_mem_0[2][3] C2=n297
XU310 AO22 $PINS O=n55 A1=bank_mem_0[4][3] A2=n301 B1=bank_mem_0[3][3] B2=n300
XU311 NR2 $PINS O=n57 I1=n56 I2=n55
XU312 ND3 $PINS O=bank_rdata[0][3] I1=n59 I2=n58 I3=n57
XU313 AOI22S $PINS O=n101 A1=bank_mem_0[14][4] A2=n285 B1=bank_mem_0[15][4]
+ B2=n284
XU314 AOI22S $PINS O=n100 A1=bank_mem_0[12][4] A2=n287 B1=bank_mem_0[13][4]
+ B2=n286
XU315 AOI22S $PINS O=n61 A1=bank_mem_0[10][4] A2=n3 B1=bank_mem_0[11][4]
+ B2=n288
XU316 AOI22S $PINS O=n60 A1=bank_mem_0[8][4] A2=n1 B1=bank_mem_0[9][4] B2=n289
XU317 AN2 $PINS O=n99 I1=n61 I2=n60
XU318 ND3 $PINS O=n102 I1=n101 I2=n100 I3=n99
XU319 AOI22S $PINS O=n107 A1=bank_mem_0[7][4] A2=n5 B1=n102 B2=N30
XU320 AOI22S $PINS O=n106 A1=bank_mem_0[5][4] A2=n6 B1=bank_mem_0[6][4] B2=n296
XU321 AO222 $PINS O=n104 A1=bank_mem_0[1][4] A2=n299 B1=bank_mem_0[0][4]
+ B2=n298 C1=bank_mem_0[2][4] C2=n297
XU322 AO22 $PINS O=n103 A1=bank_mem_0[4][4] A2=n301 B1=bank_mem_0[3][4] B2=n300
XU323 NR2 $PINS O=n105 I1=n104 I2=n103
XU324 ND3 $PINS O=bank_rdata[0][4] I1=n107 I2=n106 I3=n105
XU325 AOI22S $PINS O=n112 A1=bank_mem_0[14][5] A2=n285 B1=bank_mem_0[15][5]
+ B2=n284
XU326 AOI22S $PINS O=n111 A1=bank_mem_0[12][5] A2=n287 B1=bank_mem_0[13][5]
+ B2=n286
XU327 AOI22S $PINS O=n109 A1=bank_mem_0[10][5] A2=n3 B1=bank_mem_0[11][5]
+ B2=n288
XU328 AOI22S $PINS O=n108 A1=bank_mem_0[8][5] A2=n1 B1=bank_mem_0[9][5] B2=n289
XU329 AN2 $PINS O=n110 I1=n109 I2=n108
XU330 ND3 $PINS O=n113 I1=n112 I2=n111 I3=n110
XU331 AOI22S $PINS O=n118 A1=bank_mem_0[7][5] A2=n5 B1=n113 B2=N30
XU332 AOI22S $PINS O=n117 A1=bank_mem_0[5][5] A2=n6 B1=bank_mem_0[6][5] B2=n296
XU333 AO222 $PINS O=n115 A1=bank_mem_0[1][5] A2=n299 B1=bank_mem_0[0][5]
+ B2=n298 C1=bank_mem_0[2][5] C2=n297
XU334 AO22 $PINS O=n114 A1=bank_mem_0[4][5] A2=n301 B1=bank_mem_0[3][5] B2=n300
XU335 NR2 $PINS O=n116 I1=n115 I2=n114
XU336 ND3 $PINS O=bank_rdata[0][5] I1=n118 I2=n117 I3=n116
XU337 AOI22S $PINS O=n123 A1=bank_mem_0[14][6] A2=n285 B1=bank_mem_0[15][6]
+ B2=n284
XU338 AOI22S $PINS O=n122 A1=bank_mem_0[12][6] A2=n287 B1=bank_mem_0[13][6]
+ B2=n286
XU339 AOI22S $PINS O=n120 A1=bank_mem_0[10][6] A2=n3 B1=bank_mem_0[11][6]
+ B2=n288
XU340 AOI22S $PINS O=n119 A1=bank_mem_0[8][6] A2=n1 B1=bank_mem_0[9][6] B2=n289
XU341 AN2 $PINS O=n121 I1=n120 I2=n119
XU342 ND3 $PINS O=n124 I1=n123 I2=n122 I3=n121
XU343 AOI22S $PINS O=n129 A1=bank_mem_0[7][6] A2=n5 B1=n124 B2=N30
XU344 AOI22S $PINS O=n128 A1=bank_mem_0[5][6] A2=n6 B1=bank_mem_0[6][6] B2=n296
XU345 AO222 $PINS O=n126 A1=bank_mem_0[1][6] A2=n299 B1=bank_mem_0[0][6]
+ B2=n298 C1=bank_mem_0[2][6] C2=n297
XU346 AO22 $PINS O=n125 A1=bank_mem_0[4][6] A2=n301 B1=bank_mem_0[3][6] B2=n300
XU347 NR2 $PINS O=n127 I1=n126 I2=n125
XU348 ND3 $PINS O=bank_rdata[0][6] I1=n129 I2=n128 I3=n127
XU349 AOI22S $PINS O=n134 A1=bank_mem_0[14][7] A2=n285 B1=bank_mem_0[15][7]
+ B2=n284
XU350 AOI22S $PINS O=n133 A1=bank_mem_0[12][7] A2=n287 B1=bank_mem_0[13][7]
+ B2=n286
XU351 AOI22S $PINS O=n131 A1=bank_mem_0[10][7] A2=n3 B1=bank_mem_0[11][7]
+ B2=n288
XU352 AOI22S $PINS O=n130 A1=bank_mem_0[8][7] A2=n1 B1=bank_mem_0[9][7] B2=n289
XU353 AN2 $PINS O=n132 I1=n131 I2=n130
XU354 ND3 $PINS O=n135 I1=n134 I2=n133 I3=n132
XU355 AOI22S $PINS O=n140 A1=bank_mem_0[7][7] A2=n5 B1=n135 B2=N30
XU356 AOI22S $PINS O=n139 A1=bank_mem_0[5][7] A2=n6 B1=bank_mem_0[6][7] B2=n296
XU357 AO222 $PINS O=n137 A1=bank_mem_0[1][7] A2=n299 B1=bank_mem_0[0][7]
+ B2=n298 C1=bank_mem_0[2][7] C2=n297
XU358 AO22 $PINS O=n136 A1=bank_mem_0[4][7] A2=n301 B1=bank_mem_0[3][7] B2=n300
XU359 NR2 $PINS O=n138 I1=n137 I2=n136
XU360 ND3 $PINS O=bank_rdata[0][7] I1=n140 I2=n139 I3=n138
XU361 AOI22S $PINS O=n145 A1=bank_mem_0[14][8] A2=n285 B1=bank_mem_0[15][8]
+ B2=n284
XU362 AOI22S $PINS O=n144 A1=bank_mem_0[12][8] A2=n287 B1=bank_mem_0[13][8]
+ B2=n286
XU363 AOI22S $PINS O=n142 A1=bank_mem_0[10][8] A2=n3 B1=bank_mem_0[11][8]
+ B2=n288
XU364 AOI22S $PINS O=n141 A1=bank_mem_0[8][8] A2=n1 B1=bank_mem_0[9][8] B2=n289
XU365 AN2 $PINS O=n143 I1=n142 I2=n141
XU366 ND3 $PINS O=n146 I1=n145 I2=n144 I3=n143
XU367 AOI22S $PINS O=n151 A1=bank_mem_0[7][8] A2=n5 B1=n146 B2=N30
XU368 AOI22S $PINS O=n150 A1=bank_mem_0[5][8] A2=n6 B1=bank_mem_0[6][8] B2=n296
XU369 AO222 $PINS O=n148 A1=bank_mem_0[1][8] A2=n299 B1=bank_mem_0[0][8]
+ B2=n298 C1=bank_mem_0[2][8] C2=n297
XU370 AO22 $PINS O=n147 A1=bank_mem_0[4][8] A2=n301 B1=bank_mem_0[3][8] B2=n300
XU371 NR2 $PINS O=n149 I1=n148 I2=n147
XU372 ND3 $PINS O=bank_rdata[0][8] I1=n151 I2=n150 I3=n149
XU373 AOI22S $PINS O=n156 A1=bank_mem_0[14][9] A2=n285 B1=bank_mem_0[15][9]
+ B2=n284
XU374 AOI22S $PINS O=n155 A1=bank_mem_0[12][9] A2=n287 B1=bank_mem_0[13][9]
+ B2=n286
XU375 AOI22S $PINS O=n153 A1=bank_mem_0[10][9] A2=n3 B1=bank_mem_0[11][9]
+ B2=n288
XU376 AOI22S $PINS O=n152 A1=bank_mem_0[8][9] A2=n1 B1=bank_mem_0[9][9] B2=n289
XU377 AN2 $PINS O=n154 I1=n153 I2=n152
XU378 ND3 $PINS O=n157 I1=n156 I2=n155 I3=n154
XU379 AOI22S $PINS O=n162 A1=bank_mem_0[7][9] A2=n5 B1=n157 B2=N30
XU380 AOI22S $PINS O=n161 A1=bank_mem_0[5][9] A2=n6 B1=bank_mem_0[6][9] B2=n296
XU381 AO222 $PINS O=n159 A1=bank_mem_0[1][9] A2=n299 B1=bank_mem_0[0][9]
+ B2=n298 C1=bank_mem_0[2][9] C2=n297
XU382 AO22 $PINS O=n158 A1=bank_mem_0[4][9] A2=n301 B1=bank_mem_0[3][9] B2=n300
XU383 NR2 $PINS O=n160 I1=n159 I2=n158
XU384 ND3 $PINS O=bank_rdata[0][9] I1=n162 I2=n161 I3=n160
XU385 AOI22S $PINS O=n167 A1=bank_mem_0[14][10] A2=n285 B1=bank_mem_0[15][10]
+ B2=n284
XU386 AOI22S $PINS O=n166 A1=bank_mem_0[12][10] A2=n287 B1=bank_mem_0[13][10]
+ B2=n286
XU387 AOI22S $PINS O=n164 A1=bank_mem_0[10][10] A2=n3 B1=bank_mem_0[11][10]
+ B2=n288
XU388 AOI22S $PINS O=n163 A1=bank_mem_0[8][10] A2=n1 B1=bank_mem_0[9][10]
+ B2=n289
XU389 AN2 $PINS O=n165 I1=n164 I2=n163
XU390 ND3 $PINS O=n168 I1=n167 I2=n166 I3=n165
XU391 AOI22S $PINS O=n173 A1=bank_mem_0[7][10] A2=n5 B1=n168 B2=N30
XU392 AOI22S $PINS O=n172 A1=bank_mem_0[5][10] A2=n6 B1=bank_mem_0[6][10]
+ B2=n296
XU393 AO222 $PINS O=n170 A1=bank_mem_0[1][10] A2=n299 B1=bank_mem_0[0][10]
+ B2=n298 C1=bank_mem_0[2][10] C2=n297
XU394 AO22 $PINS O=n169 A1=bank_mem_0[4][10] A2=n301 B1=bank_mem_0[3][10]
+ B2=n300
XU395 NR2 $PINS O=n171 I1=n170 I2=n169
XU396 ND3 $PINS O=bank_rdata[0][10] I1=n173 I2=n172 I3=n171
XU397 AOI22S $PINS O=n178 A1=bank_mem_0[14][11] A2=n285 B1=bank_mem_0[15][11]
+ B2=n284
XU398 AOI22S $PINS O=n177 A1=bank_mem_0[12][11] A2=n287 B1=bank_mem_0[13][11]
+ B2=n286
XU399 AOI22S $PINS O=n175 A1=bank_mem_0[10][11] A2=n3 B1=bank_mem_0[11][11]
+ B2=n288
XU400 AOI22S $PINS O=n174 A1=bank_mem_0[8][11] A2=n1 B1=bank_mem_0[9][11]
+ B2=n289
XU401 AN2 $PINS O=n176 I1=n175 I2=n174
XU402 ND3 $PINS O=n179 I1=n178 I2=n177 I3=n176
XU403 AOI22S $PINS O=n184 A1=bank_mem_0[7][11] A2=n5 B1=n179 B2=N30
XU404 AOI22S $PINS O=n183 A1=bank_mem_0[5][11] A2=n6 B1=bank_mem_0[6][11]
+ B2=n296
XU405 AO222 $PINS O=n181 A1=bank_mem_0[1][11] A2=n299 B1=bank_mem_0[0][11]
+ B2=n298 C1=bank_mem_0[2][11] C2=n297
XU406 AO22 $PINS O=n180 A1=bank_mem_0[4][11] A2=n301 B1=bank_mem_0[3][11]
+ B2=n300
XU407 NR2 $PINS O=n182 I1=n181 I2=n180
XU408 ND3 $PINS O=bank_rdata[0][11] I1=n184 I2=n183 I3=n182
XU409 AOI22S $PINS O=n189 A1=bank_mem_0[14][12] A2=n285 B1=bank_mem_0[15][12]
+ B2=n284
XU410 AOI22S $PINS O=n188 A1=bank_mem_0[12][12] A2=n287 B1=bank_mem_0[13][12]
+ B2=n286
XU411 AOI22S $PINS O=n186 A1=bank_mem_0[10][12] A2=n3 B1=bank_mem_0[11][12]
+ B2=n288
XU412 AOI22S $PINS O=n185 A1=bank_mem_0[8][12] A2=n1 B1=bank_mem_0[9][12]
+ B2=n289
XU413 AN2 $PINS O=n187 I1=n186 I2=n185
XU414 ND3 $PINS O=n190 I1=n189 I2=n188 I3=n187
XU415 AOI22S $PINS O=n195 A1=bank_mem_0[7][12] A2=n5 B1=n190 B2=N30
XU416 AOI22S $PINS O=n194 A1=bank_mem_0[5][12] A2=n6 B1=bank_mem_0[6][12]
+ B2=n296
XU417 AO222 $PINS O=n192 A1=bank_mem_0[1][12] A2=n299 B1=bank_mem_0[0][12]
+ B2=n298 C1=bank_mem_0[2][12] C2=n297
XU418 AO22 $PINS O=n191 A1=bank_mem_0[4][12] A2=n301 B1=bank_mem_0[3][12]
+ B2=n300
XU419 NR2 $PINS O=n193 I1=n192 I2=n191
XU420 ND3 $PINS O=bank_rdata[0][12] I1=n195 I2=n194 I3=n193
XU421 AOI22S $PINS O=n200 A1=bank_mem_0[14][13] A2=n285 B1=bank_mem_0[15][13]
+ B2=n284
XU422 AOI22S $PINS O=n199 A1=bank_mem_0[12][13] A2=n287 B1=bank_mem_0[13][13]
+ B2=n286
XU423 AOI22S $PINS O=n197 A1=bank_mem_0[10][13] A2=n3 B1=bank_mem_0[11][13]
+ B2=n288
XU424 AOI22S $PINS O=n196 A1=bank_mem_0[8][13] A2=n1 B1=bank_mem_0[9][13]
+ B2=n289
XU425 AN2 $PINS O=n198 I1=n197 I2=n196
XU426 ND3 $PINS O=n201 I1=n200 I2=n199 I3=n198
XU427 AOI22S $PINS O=n206 A1=bank_mem_0[7][13] A2=n5 B1=n201 B2=N30
XU428 AOI22S $PINS O=n205 A1=bank_mem_0[5][13] A2=n6 B1=bank_mem_0[6][13]
+ B2=n296
XU429 AO222 $PINS O=n203 A1=bank_mem_0[1][13] A2=n299 B1=bank_mem_0[0][13]
+ B2=n298 C1=bank_mem_0[2][13] C2=n297
XU430 AO22 $PINS O=n202 A1=bank_mem_0[4][13] A2=n301 B1=bank_mem_0[3][13]
+ B2=n300
XU431 NR2 $PINS O=n204 I1=n203 I2=n202
XU432 ND3 $PINS O=bank_rdata[0][13] I1=n206 I2=n205 I3=n204
XU433 AOI22S $PINS O=n211 A1=bank_mem_0[14][14] A2=n285 B1=bank_mem_0[15][14]
+ B2=n284
XU434 AOI22S $PINS O=n210 A1=bank_mem_0[12][14] A2=n287 B1=bank_mem_0[13][14]
+ B2=n286
XU435 AOI22S $PINS O=n208 A1=bank_mem_0[10][14] A2=n3 B1=bank_mem_0[11][14]
+ B2=n288
XU436 AOI22S $PINS O=n207 A1=bank_mem_0[8][14] A2=n1 B1=bank_mem_0[9][14]
+ B2=n289
XU437 AN2 $PINS O=n209 I1=n208 I2=n207
XU438 ND3 $PINS O=n212 I1=n211 I2=n210 I3=n209
XU439 AOI22S $PINS O=n217 A1=bank_mem_0[7][14] A2=n5 B1=n212 B2=N30
XU440 AOI22S $PINS O=n216 A1=bank_mem_0[5][14] A2=n6 B1=bank_mem_0[6][14]
+ B2=n296
XU441 AO222 $PINS O=n214 A1=bank_mem_0[1][14] A2=n299 B1=bank_mem_0[0][14]
+ B2=n298 C1=bank_mem_0[2][14] C2=n297
XU442 AO22 $PINS O=n213 A1=bank_mem_0[4][14] A2=n301 B1=bank_mem_0[3][14]
+ B2=n300
XU443 NR2 $PINS O=n215 I1=n214 I2=n213
XU444 ND3 $PINS O=bank_rdata[0][14] I1=n217 I2=n216 I3=n215
XU445 AOI22S $PINS O=n222 A1=bank_mem_0[14][15] A2=n285 B1=bank_mem_0[15][15]
+ B2=n284
XU446 AOI22S $PINS O=n221 A1=bank_mem_0[12][15] A2=n287 B1=bank_mem_0[13][15]
+ B2=n286
XU447 AOI22S $PINS O=n219 A1=bank_mem_0[10][15] A2=n3 B1=bank_mem_0[11][15]
+ B2=n288
XU448 AOI22S $PINS O=n218 A1=bank_mem_0[8][15] A2=n1 B1=bank_mem_0[9][15]
+ B2=n289
XU449 AN2 $PINS O=n220 I1=n219 I2=n218
XU450 ND3 $PINS O=n223 I1=n222 I2=n221 I3=n220
XU451 AOI22S $PINS O=n228 A1=bank_mem_0[7][15] A2=n5 B1=n223 B2=N30
XU452 AOI22S $PINS O=n227 A1=bank_mem_0[5][15] A2=n6 B1=bank_mem_0[6][15]
+ B2=n296
XU453 AO222 $PINS O=n225 A1=bank_mem_0[1][15] A2=n299 B1=bank_mem_0[0][15]
+ B2=n298 C1=bank_mem_0[2][15] C2=n297
XU454 AO22 $PINS O=n224 A1=bank_mem_0[4][15] A2=n301 B1=bank_mem_0[3][15]
+ B2=n300
XU455 NR2 $PINS O=n226 I1=n225 I2=n224
XU456 ND3 $PINS O=bank_rdata[0][15] I1=n228 I2=n227 I3=n226
XU457 AOI22S $PINS O=n233 A1=bank_mem_0[14][16] A2=n285 B1=bank_mem_0[15][16]
+ B2=n284
XU458 AOI22S $PINS O=n232 A1=bank_mem_0[12][16] A2=n287 B1=bank_mem_0[13][16]
+ B2=n286
XU459 AOI22S $PINS O=n230 A1=bank_mem_0[10][16] A2=n3 B1=bank_mem_0[11][16]
+ B2=n288
XU460 AOI22S $PINS O=n229 A1=bank_mem_0[8][16] A2=n1 B1=bank_mem_0[9][16]
+ B2=n289
XU461 AN2 $PINS O=n231 I1=n230 I2=n229
XU462 ND3 $PINS O=n234 I1=n233 I2=n232 I3=n231
XU463 AOI22S $PINS O=n239 A1=bank_mem_0[7][16] A2=n5 B1=n234 B2=N30
XU464 AOI22S $PINS O=n238 A1=bank_mem_0[5][16] A2=n6 B1=bank_mem_0[6][16]
+ B2=n296
XU465 AO222 $PINS O=n236 A1=bank_mem_0[1][16] A2=n299 B1=bank_mem_0[0][16]
+ B2=n298 C1=bank_mem_0[2][16] C2=n297
XU466 AO22 $PINS O=n235 A1=bank_mem_0[4][16] A2=n301 B1=bank_mem_0[3][16]
+ B2=n300
XU467 NR2 $PINS O=n237 I1=n236 I2=n235
XU468 ND3 $PINS O=bank_rdata[0][16] I1=n239 I2=n238 I3=n237
XU469 AOI22S $PINS O=n244 A1=bank_mem_0[14][17] A2=n285 B1=bank_mem_0[15][17]
+ B2=n284
XU470 AOI22S $PINS O=n243 A1=bank_mem_0[12][17] A2=n287 B1=bank_mem_0[13][17]
+ B2=n286
XU471 AOI22S $PINS O=n241 A1=bank_mem_0[10][17] A2=n3 B1=bank_mem_0[11][17]
+ B2=n288
XU472 AOI22S $PINS O=n240 A1=bank_mem_0[8][17] A2=n1 B1=bank_mem_0[9][17]
+ B2=n289
XU473 AN2 $PINS O=n242 I1=n241 I2=n240
XU474 ND3 $PINS O=n245 I1=n244 I2=n243 I3=n242
XU475 AOI22S $PINS O=n250 A1=bank_mem_0[7][17] A2=n5 B1=n245 B2=N30
XU476 AOI22S $PINS O=n249 A1=bank_mem_0[5][17] A2=n6 B1=bank_mem_0[6][17]
+ B2=n296
XU477 AO222 $PINS O=n247 A1=bank_mem_0[1][17] A2=n299 B1=bank_mem_0[0][17]
+ B2=n298 C1=bank_mem_0[2][17] C2=n297
XU478 AO22 $PINS O=n246 A1=bank_mem_0[4][17] A2=n301 B1=bank_mem_0[3][17]
+ B2=n300
XU479 NR2 $PINS O=n248 I1=n247 I2=n246
XU480 ND3 $PINS O=bank_rdata[0][17] I1=n250 I2=n249 I3=n248
XU481 AOI22S $PINS O=n255 A1=bank_mem_0[14][18] A2=n285 B1=bank_mem_0[15][18]
+ B2=n284
XU482 AOI22S $PINS O=n254 A1=bank_mem_0[12][18] A2=n287 B1=bank_mem_0[13][18]
+ B2=n286
XU483 AOI22S $PINS O=n252 A1=bank_mem_0[10][18] A2=n3 B1=bank_mem_0[11][18]
+ B2=n288
XU484 AOI22S $PINS O=n251 A1=bank_mem_0[8][18] A2=n1 B1=bank_mem_0[9][18]
+ B2=n289
XU485 AN2 $PINS O=n253 I1=n252 I2=n251
XU486 ND3 $PINS O=n256 I1=n255 I2=n254 I3=n253
XU487 AOI22S $PINS O=n261 A1=bank_mem_0[7][18] A2=n5 B1=n256 B2=N30
XU488 AOI22S $PINS O=n260 A1=bank_mem_0[5][18] A2=n6 B1=bank_mem_0[6][18]
+ B2=n296
XU489 AO222 $PINS O=n258 A1=bank_mem_0[1][18] A2=n299 B1=bank_mem_0[0][18]
+ B2=n298 C1=bank_mem_0[2][18] C2=n297
XU490 AO22 $PINS O=n257 A1=bank_mem_0[4][18] A2=n301 B1=bank_mem_0[3][18]
+ B2=n300
XU491 NR2 $PINS O=n259 I1=n258 I2=n257
XU492 ND3 $PINS O=bank_rdata[0][18] I1=n261 I2=n260 I3=n259
XU493 AOI22S $PINS O=n266 A1=bank_mem_0[14][19] A2=n285 B1=bank_mem_0[15][19]
+ B2=n284
XU494 AOI22S $PINS O=n265 A1=bank_mem_0[12][19] A2=n287 B1=bank_mem_0[13][19]
+ B2=n286
XU495 AOI22S $PINS O=n263 A1=bank_mem_0[10][19] A2=n3 B1=bank_mem_0[11][19]
+ B2=n288
XU496 AOI22S $PINS O=n262 A1=bank_mem_0[8][19] A2=n1 B1=bank_mem_0[9][19]
+ B2=n289
XU497 AN2 $PINS O=n264 I1=n263 I2=n262
XU498 ND3 $PINS O=n267 I1=n266 I2=n265 I3=n264
XU499 AOI22S $PINS O=n272 A1=bank_mem_0[7][19] A2=n5 B1=n267 B2=N30
XU500 AOI22S $PINS O=n271 A1=bank_mem_0[5][19] A2=n6 B1=bank_mem_0[6][19]
+ B2=n296
XU501 AO222 $PINS O=n269 A1=bank_mem_0[1][19] A2=n299 B1=bank_mem_0[0][19]
+ B2=n298 C1=bank_mem_0[2][19] C2=n297
XU502 AO22 $PINS O=n268 A1=bank_mem_0[4][19] A2=n301 B1=bank_mem_0[3][19]
+ B2=n300
XU503 NR2 $PINS O=n270 I1=n269 I2=n268
XU504 ND3 $PINS O=bank_rdata[0][19] I1=n272 I2=n271 I3=n270
XU505 AOI22S $PINS O=n277 A1=bank_mem_0[14][20] A2=n285 B1=bank_mem_0[15][20]
+ B2=n284
XU506 AOI22S $PINS O=n276 A1=bank_mem_0[12][20] A2=n287 B1=bank_mem_0[13][20]
+ B2=n286
XU507 AOI22S $PINS O=n274 A1=bank_mem_0[10][20] A2=n3 B1=bank_mem_0[11][20]
+ B2=n288
XU508 AOI22S $PINS O=n273 A1=bank_mem_0[8][20] A2=n1 B1=bank_mem_0[9][20]
+ B2=n289
XU509 AN2 $PINS O=n275 I1=n274 I2=n273
XU510 ND3 $PINS O=n278 I1=n277 I2=n276 I3=n275
XU511 AOI22S $PINS O=n283 A1=bank_mem_0[7][20] A2=n5 B1=n278 B2=N30
XU512 AOI22S $PINS O=n282 A1=bank_mem_0[5][20] A2=n6 B1=bank_mem_0[6][20]
+ B2=n296
XU513 AO222 $PINS O=n280 A1=bank_mem_0[1][20] A2=n299 B1=bank_mem_0[0][20]
+ B2=n298 C1=bank_mem_0[2][20] C2=n297
XU514 AO22 $PINS O=n279 A1=bank_mem_0[4][20] A2=n301 B1=bank_mem_0[3][20]
+ B2=n300
XU515 NR2 $PINS O=n281 I1=n280 I2=n279
XU516 ND3 $PINS O=bank_rdata[0][20] I1=n283 I2=n282 I3=n281
XU517 AOI22S $PINS O=n294 A1=bank_mem_0[14][21] A2=n285 B1=bank_mem_0[15][21]
+ B2=n284
XU518 AOI22S $PINS O=n293 A1=bank_mem_0[12][21] A2=n287 B1=bank_mem_0[13][21]
+ B2=n286
XU519 AOI22S $PINS O=n291 A1=bank_mem_0[10][21] A2=n3 B1=bank_mem_0[11][21]
+ B2=n288
XU520 AOI22S $PINS O=n290 A1=bank_mem_0[8][21] A2=n1 B1=bank_mem_0[9][21]
+ B2=n289
XU521 AN2 $PINS O=n292 I1=n291 I2=n290
XU522 ND3 $PINS O=n295 I1=n294 I2=n293 I3=n292
XU523 AOI22S $PINS O=n306 A1=bank_mem_0[7][21] A2=n5 B1=N30 B2=n295
XU524 AOI22S $PINS O=n305 A1=bank_mem_0[5][21] A2=n6 B1=bank_mem_0[6][21]
+ B2=n296
XU525 AO222 $PINS O=n303 A1=bank_mem_0[1][21] A2=n299 B1=bank_mem_0[0][21]
+ B2=n298 C1=bank_mem_0[2][21] C2=n297
XU526 AO22 $PINS O=n302 A1=bank_mem_0[4][21] A2=n301 B1=bank_mem_0[3][21]
+ B2=n300
XU527 NR2 $PINS O=n304 I1=n303 I2=n302
XU528 ND3 $PINS O=bank_rdata[0][21] I1=n306 I2=n305 I3=n304
XU529 NR2 $PINS O=n327 I1=n580 I2=N34
XU530 NR2 $PINS O=n328 I1=n579 I2=n578
XU531 NR2 $PINS O=n325 I1=n579 I2=N31
XU532 AOI22S $PINS O=n322 A1=bank_mem_1[14][0] A2=n556 B1=bank_mem_1[15][0]
+ B2=n555
XU533 NR2 $PINS O=n326 I1=N31 I2=N32
XU534 NR2 $PINS O=n324 I1=n578 I2=N32
XU535 AOI22S $PINS O=n321 A1=bank_mem_1[12][0] A2=n558 B1=bank_mem_1[13][0]
+ B2=n557
XU536 AOI22S $PINS O=n319 A1=bank_mem_1[10][0] A2=n4 B1=bank_mem_1[11][0]
+ B2=n559
XU537 AOI22S $PINS O=n318 A1=bank_mem_1[8][0] A2=n2 B1=bank_mem_1[9][0] B2=n560
XU538 AN2 $PINS O=n320 I1=n319 I2=n318
XU539 ND3 $PINS O=n323 I1=n322 I2=n321 I3=n320
XU540 AOI22S $PINS O=n334 A1=bank_mem_1[7][0] A2=n7 B1=n323 B2=N34
XU541 AOI22S $PINS O=n333 A1=bank_mem_1[5][0] A2=n8 B1=bank_mem_1[6][0] B2=n567
XU542 NR2 $PINS O=n329 I1=N33 I2=N34
XU543 AO222 $PINS O=n331 A1=bank_mem_1[1][0] A2=n570 B1=bank_mem_1[0][0]
+ B2=n569 C1=bank_mem_1[2][0] C2=n568
XU544 AO22 $PINS O=n330 A1=bank_mem_1[4][0] A2=n572 B1=bank_mem_1[3][0] B2=n571
XU545 NR2 $PINS O=n332 I1=n331 I2=n330
XU546 ND3 $PINS O=bank_rdata[1][0] I1=n334 I2=n333 I3=n332
XU547 AOI22S $PINS O=n339 A1=bank_mem_1[14][1] A2=n556 B1=bank_mem_1[15][1]
+ B2=n555
XU548 AOI22S $PINS O=n338 A1=bank_mem_1[12][1] A2=n558 B1=bank_mem_1[13][1]
+ B2=n557
XU549 AOI22S $PINS O=n336 A1=bank_mem_1[10][1] A2=n4 B1=bank_mem_1[11][1]
+ B2=n559
XU550 AOI22S $PINS O=n335 A1=bank_mem_1[8][1] A2=n2 B1=bank_mem_1[9][1] B2=n560
XU551 AN2 $PINS O=n337 I1=n336 I2=n335
XU552 ND3 $PINS O=n340 I1=n339 I2=n338 I3=n337
XU553 AOI22S $PINS O=n345 A1=bank_mem_1[7][1] A2=n7 B1=n340 B2=N34
XU554 AOI22S $PINS O=n344 A1=bank_mem_1[5][1] A2=n8 B1=bank_mem_1[6][1] B2=n567
XU555 AO222 $PINS O=n342 A1=bank_mem_1[1][1] A2=n570 B1=bank_mem_1[0][1]
+ B2=n569 C1=bank_mem_1[2][1] C2=n568
XU556 AO22 $PINS O=n341 A1=bank_mem_1[4][1] A2=n572 B1=bank_mem_1[3][1] B2=n571
XU557 NR2 $PINS O=n343 I1=n342 I2=n341
XU558 ND3 $PINS O=bank_rdata[1][1] I1=n345 I2=n344 I3=n343
XU559 AOI22S $PINS O=n350 A1=bank_mem_1[14][2] A2=n556 B1=bank_mem_1[15][2]
+ B2=n555
XU560 AOI22S $PINS O=n349 A1=bank_mem_1[12][2] A2=n558 B1=bank_mem_1[13][2]
+ B2=n557
XU561 AOI22S $PINS O=n347 A1=bank_mem_1[10][2] A2=n4 B1=bank_mem_1[11][2]
+ B2=n559
XU562 AOI22S $PINS O=n346 A1=bank_mem_1[8][2] A2=n2 B1=bank_mem_1[9][2] B2=n560
XU563 AN2 $PINS O=n348 I1=n347 I2=n346
XU564 ND3 $PINS O=n351 I1=n350 I2=n349 I3=n348
XU565 AOI22S $PINS O=n356 A1=bank_mem_1[7][2] A2=n7 B1=n351 B2=N34
XU566 AOI22S $PINS O=n355 A1=bank_mem_1[5][2] A2=n8 B1=bank_mem_1[6][2] B2=n567
XU567 AO222 $PINS O=n353 A1=bank_mem_1[1][2] A2=n570 B1=bank_mem_1[0][2]
+ B2=n569 C1=bank_mem_1[2][2] C2=n568
XU568 AO22 $PINS O=n352 A1=bank_mem_1[4][2] A2=n572 B1=bank_mem_1[3][2] B2=n571
XU569 NR2 $PINS O=n354 I1=n353 I2=n352
XU570 ND3 $PINS O=FE_PHN1018_bank_rdata_1_2 I1=n356 I2=n355 I3=n354
XU571 AOI22S $PINS O=n361 A1=bank_mem_1[14][3] A2=n556 B1=bank_mem_1[15][3]
+ B2=n555
XU572 AOI22S $PINS O=n360 A1=bank_mem_1[12][3] A2=n558 B1=bank_mem_1[13][3]
+ B2=n557
XU573 AOI22S $PINS O=n358 A1=bank_mem_1[10][3] A2=n4 B1=bank_mem_1[11][3]
+ B2=n559
XU574 AOI22S $PINS O=n357 A1=bank_mem_1[8][3] A2=n2 B1=bank_mem_1[9][3] B2=n560
XU575 AN2 $PINS O=n359 I1=n358 I2=n357
XU576 ND3 $PINS O=n362 I1=n361 I2=n360 I3=n359
XU577 AOI22S $PINS O=n367 A1=bank_mem_1[7][3] A2=n7 B1=n362 B2=N34
XU578 AOI22S $PINS O=n366 A1=bank_mem_1[5][3] A2=n8 B1=bank_mem_1[6][3] B2=n567
XU579 AO222 $PINS O=n364 A1=bank_mem_1[1][3] A2=n570 B1=bank_mem_1[0][3]
+ B2=n569 C1=bank_mem_1[2][3] C2=n568
XU580 AO22 $PINS O=n363 A1=bank_mem_1[4][3] A2=n572 B1=bank_mem_1[3][3] B2=n571
XU581 NR2 $PINS O=n365 I1=n364 I2=n363
XU582 ND3 $PINS O=bank_rdata[1][3] I1=n367 I2=n366 I3=n365
XU583 AOI22S $PINS O=n372 A1=bank_mem_1[14][4] A2=n556 B1=bank_mem_1[15][4]
+ B2=n555
XU584 AOI22S $PINS O=n371 A1=bank_mem_1[12][4] A2=n558 B1=bank_mem_1[13][4]
+ B2=n557
XU585 AOI22S $PINS O=n369 A1=bank_mem_1[10][4] A2=n4 B1=bank_mem_1[11][4]
+ B2=n559
XU586 AOI22S $PINS O=n368 A1=bank_mem_1[8][4] A2=n2 B1=bank_mem_1[9][4] B2=n560
XU587 AN2 $PINS O=n370 I1=n369 I2=n368
XU588 ND3 $PINS O=n373 I1=n372 I2=n371 I3=n370
XU589 AOI22S $PINS O=n378 A1=bank_mem_1[7][4] A2=n7 B1=n373 B2=N34
XU590 AOI22S $PINS O=n377 A1=bank_mem_1[5][4] A2=n8 B1=bank_mem_1[6][4] B2=n567
XU591 AO222 $PINS O=n375 A1=bank_mem_1[1][4] A2=n570 B1=bank_mem_1[0][4]
+ B2=n569 C1=bank_mem_1[2][4] C2=n568
XU592 AO22 $PINS O=n374 A1=bank_mem_1[4][4] A2=n572 B1=bank_mem_1[3][4] B2=n571
XU593 NR2 $PINS O=n376 I1=n375 I2=n374
XU594 ND3 $PINS O=FE_PHN1024_bank_rdata_1_4 I1=n378 I2=n377 I3=n376
XU595 AOI22S $PINS O=n383 A1=bank_mem_1[14][5] A2=n556 B1=bank_mem_1[15][5]
+ B2=n555
XU596 AOI22S $PINS O=n382 A1=bank_mem_1[12][5] A2=n558 B1=bank_mem_1[13][5]
+ B2=n557
XU597 AOI22S $PINS O=n380 A1=bank_mem_1[10][5] A2=n4 B1=bank_mem_1[11][5]
+ B2=n559
XU598 AOI22S $PINS O=n379 A1=bank_mem_1[8][5] A2=n2 B1=bank_mem_1[9][5] B2=n560
XU599 AN2 $PINS O=n381 I1=n380 I2=n379
XU600 ND3 $PINS O=n384 I1=n383 I2=n382 I3=n381
XU601 AOI22S $PINS O=n389 A1=bank_mem_1[7][5] A2=n7 B1=n384 B2=N34
XU602 AOI22S $PINS O=n388 A1=bank_mem_1[5][5] A2=n8 B1=bank_mem_1[6][5] B2=n567
XU603 AO222 $PINS O=n386 A1=bank_mem_1[1][5] A2=n570 B1=bank_mem_1[0][5]
+ B2=n569 C1=bank_mem_1[2][5] C2=n568
XU604 AO22 $PINS O=n385 A1=bank_mem_1[4][5] A2=n572 B1=bank_mem_1[3][5] B2=n571
XU605 NR2 $PINS O=n387 I1=n386 I2=n385
XU606 ND3 $PINS O=bank_rdata[1][5] I1=n389 I2=n388 I3=n387
XU607 AOI22S $PINS O=n394 A1=bank_mem_1[14][6] A2=n556 B1=bank_mem_1[15][6]
+ B2=n555
XU608 AOI22S $PINS O=n393 A1=bank_mem_1[12][6] A2=n558 B1=bank_mem_1[13][6]
+ B2=n557
XU609 AOI22S $PINS O=n391 A1=bank_mem_1[10][6] A2=n4 B1=bank_mem_1[11][6]
+ B2=n559
XU610 AOI22S $PINS O=n390 A1=bank_mem_1[8][6] A2=n2 B1=bank_mem_1[9][6] B2=n560
XU611 AN2 $PINS O=n392 I1=n391 I2=n390
XU612 ND3 $PINS O=n395 I1=n394 I2=n393 I3=n392
XU613 AOI22S $PINS O=n400 A1=bank_mem_1[7][6] A2=n7 B1=n395 B2=N34
XU614 AOI22S $PINS O=n399 A1=bank_mem_1[5][6] A2=n8 B1=bank_mem_1[6][6] B2=n567
XU615 AO222 $PINS O=n397 A1=bank_mem_1[1][6] A2=n570 B1=bank_mem_1[0][6]
+ B2=n569 C1=bank_mem_1[2][6] C2=n568
XU616 AO22 $PINS O=n396 A1=bank_mem_1[4][6] A2=n572 B1=bank_mem_1[3][6] B2=n571
XU617 NR2 $PINS O=n398 I1=n397 I2=n396
XU618 ND3 $PINS O=FE_PHN1002_bank_rdata_1_6 I1=n400 I2=n399 I3=n398
XU619 AOI22S $PINS O=n405 A1=bank_mem_1[14][7] A2=n556 B1=bank_mem_1[15][7]
+ B2=n555
XU620 AOI22S $PINS O=n404 A1=bank_mem_1[12][7] A2=n558 B1=bank_mem_1[13][7]
+ B2=n557
XU621 AOI22S $PINS O=n402 A1=bank_mem_1[10][7] A2=n4 B1=bank_mem_1[11][7]
+ B2=n559
XU622 AOI22S $PINS O=n401 A1=bank_mem_1[8][7] A2=n2 B1=bank_mem_1[9][7] B2=n560
XU623 AN2 $PINS O=n403 I1=n402 I2=n401
XU624 ND3 $PINS O=n406 I1=n405 I2=n404 I3=n403
XU625 AOI22S $PINS O=n411 A1=bank_mem_1[7][7] A2=n7 B1=n406 B2=N34
XU626 AOI22S $PINS O=n410 A1=bank_mem_1[5][7] A2=n8 B1=bank_mem_1[6][7] B2=n567
XU627 AO222 $PINS O=n408 A1=bank_mem_1[1][7] A2=n570 B1=bank_mem_1[0][7]
+ B2=n569 C1=bank_mem_1[2][7] C2=n568
XU628 AO22 $PINS O=n407 A1=bank_mem_1[4][7] A2=n572 B1=bank_mem_1[3][7] B2=n571
XU629 NR2 $PINS O=n409 I1=n408 I2=n407
XU630 ND3 $PINS O=bank_rdata[1][7] I1=n411 I2=n410 I3=n409
XU631 AOI22S $PINS O=n416 A1=bank_mem_1[14][8] A2=n556 B1=bank_mem_1[15][8]
+ B2=n555
XU632 AOI22S $PINS O=n415 A1=bank_mem_1[12][8] A2=n558 B1=bank_mem_1[13][8]
+ B2=n557
XU633 AOI22S $PINS O=n413 A1=bank_mem_1[10][8] A2=n4 B1=bank_mem_1[11][8]
+ B2=n559
XU634 AOI22S $PINS O=n412 A1=bank_mem_1[8][8] A2=n2 B1=bank_mem_1[9][8] B2=n560
XU635 AN2 $PINS O=n414 I1=n413 I2=n412
XU636 ND3 $PINS O=n417 I1=n416 I2=n415 I3=n414
XU637 AOI22S $PINS O=n422 A1=bank_mem_1[7][8] A2=n7 B1=n417 B2=N34
XU638 AOI22S $PINS O=n421 A1=bank_mem_1[5][8] A2=n8 B1=bank_mem_1[6][8] B2=n567
XU639 AO222 $PINS O=n419 A1=bank_mem_1[1][8] A2=n570 B1=bank_mem_1[0][8]
+ B2=n569 C1=bank_mem_1[2][8] C2=n568
XU640 AO22 $PINS O=n418 A1=bank_mem_1[4][8] A2=n572 B1=bank_mem_1[3][8] B2=n571
XU641 NR2 $PINS O=n420 I1=n419 I2=n418
XU642 ND3 $PINS O=bank_rdata[1][8] I1=n422 I2=n421 I3=n420
XU643 AOI22S $PINS O=n427 A1=bank_mem_1[14][9] A2=n556 B1=bank_mem_1[15][9]
+ B2=n555
XU644 AOI22S $PINS O=n426 A1=bank_mem_1[12][9] A2=n558 B1=bank_mem_1[13][9]
+ B2=n557
XU645 AOI22S $PINS O=n424 A1=bank_mem_1[10][9] A2=n4 B1=bank_mem_1[11][9]
+ B2=n559
XU646 AOI22S $PINS O=n423 A1=bank_mem_1[8][9] A2=n2 B1=bank_mem_1[9][9] B2=n560
XU647 AN2 $PINS O=n425 I1=n424 I2=n423
XU648 ND3 $PINS O=n428 I1=n427 I2=n426 I3=n425
XU649 AOI22S $PINS O=n433 A1=bank_mem_1[7][9] A2=n7 B1=n428 B2=N34
XU650 AOI22S $PINS O=n432 A1=bank_mem_1[5][9] A2=n8 B1=bank_mem_1[6][9] B2=n567
XU651 AO222 $PINS O=n430 A1=bank_mem_1[1][9] A2=n570 B1=bank_mem_1[0][9]
+ B2=n569 C1=bank_mem_1[2][9] C2=n568
XU652 AO22 $PINS O=n429 A1=bank_mem_1[4][9] A2=n572 B1=bank_mem_1[3][9] B2=n571
XU653 NR2 $PINS O=n431 I1=n430 I2=n429
XU654 ND3 $PINS O=bank_rdata[1][9] I1=n433 I2=n432 I3=n431
XU655 AOI22S $PINS O=n438 A1=bank_mem_1[14][10] A2=n556 B1=bank_mem_1[15][10]
+ B2=n555
XU656 AOI22S $PINS O=n437 A1=bank_mem_1[12][10] A2=n558 B1=bank_mem_1[13][10]
+ B2=n557
XU657 AOI22S $PINS O=n435 A1=bank_mem_1[10][10] A2=n4 B1=bank_mem_1[11][10]
+ B2=n559
XU658 AOI22S $PINS O=n434 A1=bank_mem_1[8][10] A2=n2 B1=bank_mem_1[9][10]
+ B2=n560
XU659 AN2 $PINS O=n436 I1=n435 I2=n434
XU660 ND3 $PINS O=n439 I1=n438 I2=n437 I3=n436
XU661 AOI22S $PINS O=n444 A1=bank_mem_1[7][10] A2=n7 B1=n439 B2=N34
XU662 AOI22S $PINS O=n443 A1=bank_mem_1[5][10] A2=n8 B1=bank_mem_1[6][10]
+ B2=n567
XU663 AO222 $PINS O=n441 A1=bank_mem_1[1][10] A2=n570 B1=bank_mem_1[0][10]
+ B2=n569 C1=bank_mem_1[2][10] C2=n568
XU664 AO22 $PINS O=n440 A1=bank_mem_1[4][10] A2=n572 B1=bank_mem_1[3][10]
+ B2=n571
XU665 NR2 $PINS O=n442 I1=n441 I2=n440
XU666 ND3 $PINS O=bank_rdata[1][10] I1=n444 I2=n443 I3=n442
XU667 AOI22S $PINS O=n449 A1=bank_mem_1[14][11] A2=n556 B1=bank_mem_1[15][11]
+ B2=n555
XU668 AOI22S $PINS O=n448 A1=bank_mem_1[12][11] A2=n558 B1=bank_mem_1[13][11]
+ B2=n557
XU669 AOI22S $PINS O=n446 A1=bank_mem_1[10][11] A2=n4 B1=bank_mem_1[11][11]
+ B2=n559
XU670 AOI22S $PINS O=n445 A1=bank_mem_1[8][11] A2=n2 B1=bank_mem_1[9][11]
+ B2=n560
XU671 AN2 $PINS O=n447 I1=n446 I2=n445
XU672 ND3 $PINS O=n450 I1=n449 I2=n448 I3=n447
XU673 AOI22S $PINS O=n455 A1=bank_mem_1[7][11] A2=n7 B1=n450 B2=N34
XU674 AOI22S $PINS O=n454 A1=bank_mem_1[5][11] A2=n8 B1=bank_mem_1[6][11]
+ B2=n567
XU675 AO222 $PINS O=n452 A1=bank_mem_1[1][11] A2=n570 B1=bank_mem_1[0][11]
+ B2=n569 C1=bank_mem_1[2][11] C2=n568
XU676 AO22 $PINS O=n451 A1=bank_mem_1[4][11] A2=n572 B1=bank_mem_1[3][11]
+ B2=n571
XU677 NR2 $PINS O=n453 I1=n452 I2=n451
XU678 ND3 $PINS O=bank_rdata[1][11] I1=n455 I2=n454 I3=n453
XU679 AOI22S $PINS O=n460 A1=bank_mem_1[14][12] A2=n556 B1=bank_mem_1[15][12]
+ B2=n555
XU680 AOI22S $PINS O=n459 A1=bank_mem_1[12][12] A2=n558 B1=bank_mem_1[13][12]
+ B2=n557
XU681 AOI22S $PINS O=n457 A1=bank_mem_1[10][12] A2=n4 B1=bank_mem_1[11][12]
+ B2=n559
XU682 AOI22S $PINS O=n456 A1=bank_mem_1[8][12] A2=n2 B1=bank_mem_1[9][12]
+ B2=n560
XU683 AN2 $PINS O=n458 I1=n457 I2=n456
XU684 ND3 $PINS O=n461 I1=n460 I2=n459 I3=n458
XU685 AOI22S $PINS O=n466 A1=bank_mem_1[7][12] A2=n7 B1=n461 B2=N34
XU686 AOI22S $PINS O=n465 A1=bank_mem_1[5][12] A2=n8 B1=bank_mem_1[6][12]
+ B2=n567
XU687 AO222 $PINS O=n463 A1=bank_mem_1[1][12] A2=n570 B1=bank_mem_1[0][12]
+ B2=n569 C1=bank_mem_1[2][12] C2=n568
XU688 AO22 $PINS O=n462 A1=bank_mem_1[4][12] A2=n572 B1=bank_mem_1[3][12]
+ B2=n571
XU689 NR2 $PINS O=n464 I1=n463 I2=n462
XU690 ND3 $PINS O=bank_rdata[1][12] I1=n466 I2=n465 I3=n464
XU691 AOI22S $PINS O=n471 A1=bank_mem_1[14][13] A2=n556 B1=bank_mem_1[15][13]
+ B2=n555
XU692 AOI22S $PINS O=n470 A1=bank_mem_1[12][13] A2=n558 B1=bank_mem_1[13][13]
+ B2=n557
XU693 AOI22S $PINS O=n468 A1=bank_mem_1[10][13] A2=n4 B1=bank_mem_1[11][13]
+ B2=n559
XU694 AOI22S $PINS O=n467 A1=bank_mem_1[8][13] A2=n2 B1=bank_mem_1[9][13]
+ B2=n560
XU695 AN2 $PINS O=n469 I1=n468 I2=n467
XU696 ND3 $PINS O=n472 I1=n471 I2=n470 I3=n469
XU697 AOI22S $PINS O=n477 A1=bank_mem_1[7][13] A2=n7 B1=n472 B2=N34
XU698 AOI22S $PINS O=n476 A1=bank_mem_1[5][13] A2=n8 B1=bank_mem_1[6][13]
+ B2=n567
XU699 AO222 $PINS O=n474 A1=bank_mem_1[1][13] A2=n570 B1=bank_mem_1[0][13]
+ B2=n569 C1=bank_mem_1[2][13] C2=n568
XU700 AO22 $PINS O=n473 A1=bank_mem_1[4][13] A2=n572 B1=bank_mem_1[3][13]
+ B2=n571
XU701 NR2 $PINS O=n475 I1=n474 I2=n473
XU702 ND3 $PINS O=bank_rdata[1][13] I1=n477 I2=n476 I3=n475
XU703 AOI22S $PINS O=n482 A1=bank_mem_1[14][14] A2=n556 B1=bank_mem_1[15][14]
+ B2=n555
XU704 AOI22S $PINS O=n481 A1=bank_mem_1[12][14] A2=n558 B1=bank_mem_1[13][14]
+ B2=n557
XU705 AOI22S $PINS O=n479 A1=bank_mem_1[10][14] A2=n4 B1=bank_mem_1[11][14]
+ B2=n559
XU706 AOI22S $PINS O=n478 A1=bank_mem_1[8][14] A2=n2 B1=bank_mem_1[9][14]
+ B2=n560
XU707 AN2 $PINS O=n480 I1=n479 I2=n478
XU708 ND3 $PINS O=n483 I1=n482 I2=n481 I3=n480
XU709 AOI22S $PINS O=n488 A1=bank_mem_1[7][14] A2=n7 B1=n483 B2=N34
XU710 AOI22S $PINS O=n487 A1=bank_mem_1[5][14] A2=n8 B1=bank_mem_1[6][14]
+ B2=n567
XU711 AO222 $PINS O=n485 A1=bank_mem_1[1][14] A2=n570 B1=bank_mem_1[0][14]
+ B2=n569 C1=bank_mem_1[2][14] C2=n568
XU712 AO22 $PINS O=n484 A1=bank_mem_1[4][14] A2=n572 B1=bank_mem_1[3][14]
+ B2=n571
XU713 NR2 $PINS O=n486 I1=n485 I2=n484
XU714 ND3 $PINS O=bank_rdata[1][14] I1=n488 I2=n487 I3=n486
XU715 AOI22S $PINS O=n493 A1=bank_mem_1[14][15] A2=n556 B1=bank_mem_1[15][15]
+ B2=n555
XU716 AOI22S $PINS O=n492 A1=bank_mem_1[12][15] A2=n558 B1=bank_mem_1[13][15]
+ B2=n557
XU717 AOI22S $PINS O=n490 A1=bank_mem_1[10][15] A2=n4 B1=bank_mem_1[11][15]
+ B2=n559
XU718 AOI22S $PINS O=n489 A1=bank_mem_1[8][15] A2=n2 B1=bank_mem_1[9][15]
+ B2=n560
XU719 AN2 $PINS O=n491 I1=n490 I2=n489
XU720 ND3 $PINS O=n494 I1=n493 I2=n492 I3=n491
XU721 AOI22S $PINS O=n499 A1=bank_mem_1[7][15] A2=n7 B1=n494 B2=N34
XU722 AOI22S $PINS O=n498 A1=bank_mem_1[5][15] A2=n8 B1=bank_mem_1[6][15]
+ B2=n567
XU723 AO222 $PINS O=n496 A1=bank_mem_1[1][15] A2=n570 B1=bank_mem_1[0][15]
+ B2=n569 C1=bank_mem_1[2][15] C2=n568
XU724 AO22 $PINS O=n495 A1=bank_mem_1[4][15] A2=n572 B1=bank_mem_1[3][15]
+ B2=n571
XU725 NR2 $PINS O=n497 I1=n496 I2=n495
XU726 ND3 $PINS O=bank_rdata[1][15] I1=n499 I2=n498 I3=n497
XU727 AOI22S $PINS O=n504 A1=bank_mem_1[14][16] A2=n556 B1=bank_mem_1[15][16]
+ B2=n555
XU728 AOI22S $PINS O=n503 A1=bank_mem_1[12][16] A2=n558 B1=bank_mem_1[13][16]
+ B2=n557
XU729 AOI22S $PINS O=n501 A1=bank_mem_1[10][16] A2=n4 B1=bank_mem_1[11][16]
+ B2=n559
XU730 AOI22S $PINS O=n500 A1=bank_mem_1[8][16] A2=n2 B1=bank_mem_1[9][16]
+ B2=n560
XU731 AN2 $PINS O=n502 I1=n501 I2=n500
XU732 ND3 $PINS O=n505 I1=n504 I2=n503 I3=n502
XU733 AOI22S $PINS O=n510 A1=bank_mem_1[7][16] A2=n7 B1=n505 B2=N34
XU734 AOI22S $PINS O=n509 A1=bank_mem_1[5][16] A2=n8 B1=bank_mem_1[6][16]
+ B2=n567
XU735 AO222 $PINS O=n507 A1=bank_mem_1[1][16] A2=n570 B1=bank_mem_1[0][16]
+ B2=n569 C1=bank_mem_1[2][16] C2=n568
XU736 AO22 $PINS O=n506 A1=bank_mem_1[4][16] A2=n572 B1=bank_mem_1[3][16]
+ B2=n571
XU737 NR2 $PINS O=n508 I1=n507 I2=n506
XU738 ND3 $PINS O=FE_PHN1015_bank_rdata_1_16 I1=n510 I2=n509 I3=n508
XU739 AOI22S $PINS O=n515 A1=bank_mem_1[14][17] A2=n556 B1=bank_mem_1[15][17]
+ B2=n555
XU740 AOI22S $PINS O=n514 A1=bank_mem_1[12][17] A2=n558 B1=bank_mem_1[13][17]
+ B2=n557
XU741 AOI22S $PINS O=n512 A1=bank_mem_1[10][17] A2=n4 B1=bank_mem_1[11][17]
+ B2=n559
XU742 AOI22S $PINS O=n511 A1=bank_mem_1[8][17] A2=n2 B1=bank_mem_1[9][17]
+ B2=n560
XU743 AN2 $PINS O=n513 I1=n512 I2=n511
XU744 ND3 $PINS O=n516 I1=n515 I2=n514 I3=n513
XU745 AOI22S $PINS O=n521 A1=bank_mem_1[7][17] A2=n7 B1=n516 B2=N34
XU746 AOI22S $PINS O=n520 A1=bank_mem_1[5][17] A2=n8 B1=bank_mem_1[6][17]
+ B2=n567
XU747 AO222 $PINS O=n518 A1=bank_mem_1[1][17] A2=n570 B1=bank_mem_1[0][17]
+ B2=n569 C1=bank_mem_1[2][17] C2=n568
XU748 AO22 $PINS O=n517 A1=bank_mem_1[4][17] A2=n572 B1=bank_mem_1[3][17]
+ B2=n571
XU749 NR2 $PINS O=n519 I1=n518 I2=n517
XU750 ND3 $PINS O=bank_rdata[1][17] I1=n521 I2=n520 I3=n519
XU751 AOI22S $PINS O=n526 A1=bank_mem_1[14][18] A2=n556 B1=bank_mem_1[15][18]
+ B2=n555
XU752 AOI22S $PINS O=n525 A1=bank_mem_1[12][18] A2=n558 B1=bank_mem_1[13][18]
+ B2=n557
XU753 AOI22S $PINS O=n523 A1=bank_mem_1[10][18] A2=n4 B1=bank_mem_1[11][18]
+ B2=n559
XU754 AOI22S $PINS O=n522 A1=bank_mem_1[8][18] A2=n2 B1=bank_mem_1[9][18]
+ B2=n560
XU755 AN2 $PINS O=n524 I1=n523 I2=n522
XU756 ND3 $PINS O=n527 I1=n526 I2=n525 I3=n524
XU757 AOI22S $PINS O=n532 A1=bank_mem_1[7][18] A2=n7 B1=n527 B2=N34
XU758 AOI22S $PINS O=n531 A1=bank_mem_1[5][18] A2=n8 B1=bank_mem_1[6][18]
+ B2=n567
XU759 AO222 $PINS O=n529 A1=bank_mem_1[1][18] A2=n570 B1=bank_mem_1[0][18]
+ B2=n569 C1=bank_mem_1[2][18] C2=n568
XU760 AO22 $PINS O=n528 A1=bank_mem_1[4][18] A2=n572 B1=bank_mem_1[3][18]
+ B2=n571
XU761 NR2 $PINS O=n530 I1=n529 I2=n528
XU762 ND3 $PINS O=bank_rdata[1][18] I1=n532 I2=n531 I3=n530
XU763 AOI22S $PINS O=n537 A1=bank_mem_1[14][19] A2=n556 B1=bank_mem_1[15][19]
+ B2=n555
XU764 AOI22S $PINS O=n536 A1=bank_mem_1[12][19] A2=n558 B1=bank_mem_1[13][19]
+ B2=n557
XU765 AOI22S $PINS O=n534 A1=bank_mem_1[10][19] A2=n4 B1=bank_mem_1[11][19]
+ B2=n559
XU766 AOI22S $PINS O=n533 A1=bank_mem_1[8][19] A2=n2 B1=bank_mem_1[9][19]
+ B2=n560
XU767 AN2 $PINS O=n535 I1=n534 I2=n533
XU768 ND3 $PINS O=n538 I1=n537 I2=n536 I3=n535
XU769 AOI22S $PINS O=n543 A1=bank_mem_1[7][19] A2=n7 B1=n538 B2=N34
XU770 AOI22S $PINS O=n542 A1=bank_mem_1[5][19] A2=n8 B1=bank_mem_1[6][19]
+ B2=n567
XU771 AO222 $PINS O=n540 A1=bank_mem_1[1][19] A2=n570 B1=bank_mem_1[0][19]
+ B2=n569 C1=bank_mem_1[2][19] C2=n568
XU772 AO22 $PINS O=n539 A1=bank_mem_1[4][19] A2=n572 B1=bank_mem_1[3][19]
+ B2=n571
XU773 NR2 $PINS O=n541 I1=n540 I2=n539
XU774 ND3 $PINS O=bank_rdata[1][19] I1=n543 I2=n542 I3=n541
XU775 AOI22S $PINS O=n548 A1=bank_mem_1[14][20] A2=n556 B1=bank_mem_1[15][20]
+ B2=n555
XU776 AOI22S $PINS O=n547 A1=bank_mem_1[12][20] A2=n558 B1=bank_mem_1[13][20]
+ B2=n557
XU777 AOI22S $PINS O=n545 A1=bank_mem_1[10][20] A2=n4 B1=bank_mem_1[11][20]
+ B2=n559
XU778 AOI22S $PINS O=n544 A1=bank_mem_1[8][20] A2=n2 B1=bank_mem_1[9][20]
+ B2=n560
XU779 AN2 $PINS O=n546 I1=n545 I2=n544
XU780 ND3 $PINS O=n549 I1=n548 I2=n547 I3=n546
XU781 AOI22S $PINS O=n554 A1=bank_mem_1[7][20] A2=n7 B1=n549 B2=N34
XU782 AOI22S $PINS O=n553 A1=bank_mem_1[5][20] A2=n8 B1=bank_mem_1[6][20]
+ B2=n567
XU783 AO222 $PINS O=n551 A1=bank_mem_1[1][20] A2=n570 B1=bank_mem_1[0][20]
+ B2=n569 C1=bank_mem_1[2][20] C2=n568
XU784 AO22 $PINS O=n550 A1=bank_mem_1[4][20] A2=n572 B1=bank_mem_1[3][20]
+ B2=n571
XU785 NR2 $PINS O=n552 I1=n551 I2=n550
XU786 ND3 $PINS O=bank_rdata[1][20] I1=n554 I2=n553 I3=n552
XU787 AOI22S $PINS O=n565 A1=bank_mem_1[14][21] A2=n556 B1=bank_mem_1[15][21]
+ B2=n555
XU788 AOI22S $PINS O=n564 A1=bank_mem_1[12][21] A2=n558 B1=bank_mem_1[13][21]
+ B2=n557
XU789 AOI22S $PINS O=n562 A1=bank_mem_1[10][21] A2=n4 B1=bank_mem_1[11][21]
+ B2=n559
XU790 AOI22S $PINS O=n561 A1=bank_mem_1[8][21] A2=n2 B1=bank_mem_1[9][21]
+ B2=n560
XU791 AN2 $PINS O=n563 I1=n562 I2=n561
XU792 ND3 $PINS O=n566 I1=n565 I2=n564 I3=n563
XU793 AOI22S $PINS O=n577 A1=bank_mem_1[7][21] A2=n7 B1=N34 B2=n566
XU794 AOI22S $PINS O=n576 A1=bank_mem_1[5][21] A2=n8 B1=bank_mem_1[6][21]
+ B2=n567
XU795 AO222 $PINS O=n574 A1=bank_mem_1[1][21] A2=n570 B1=bank_mem_1[0][21]
+ B2=n569 C1=bank_mem_1[2][21] C2=n568
XU796 AO22 $PINS O=n573 A1=bank_mem_1[4][21] A2=n572 B1=bank_mem_1[3][21]
+ B2=n571
XU797 NR2 $PINS O=n575 I1=n574 I2=n573
XU798 ND3 $PINS O=bank_rdata[1][21] I1=n577 I2=n576 I3=n575
XU3 ND2 $PINS O=n79 I1=n645 I2=n644
Xclk_gate_bank_mem_1_reg[0] SNPS_CLOCK_GATE_HIGH_RegFileDual_DATA_WIDTH22_0
+ $PINS EN=N100 ENCLK=CTS_390 CLK=CTS_391
Xclk_gate_bank_mem_1_reg[1] SNPS_CLOCK_GATE_HIGH_RegFileDual_DATA_WIDTH22_31
+ $PINS EN=N99 ENCLK=CTS_387 CLK=CTS_391
Xclk_gate_bank_mem_1_reg[2] SNPS_CLOCK_GATE_HIGH_RegFileDual_DATA_WIDTH22_30
+ $PINS EN=N98 ENCLK=CTS_384 CLK=CTS_391
Xclk_gate_bank_mem_1_reg[3] SNPS_CLOCK_GATE_HIGH_RegFileDual_DATA_WIDTH22_29
+ $PINS EN=N97 ENCLK=CTS_381 CLK=CTS_391
Xclk_gate_bank_mem_1_reg[4] SNPS_CLOCK_GATE_HIGH_RegFileDual_DATA_WIDTH22_28
+ $PINS EN=N96 ENCLK=CTS_378 CLK=CTS_391
Xclk_gate_bank_mem_1_reg[5] SNPS_CLOCK_GATE_HIGH_RegFileDual_DATA_WIDTH22_27
+ $PINS EN=N95 ENCLK=CTS_375 CLK=CTS_391
Xclk_gate_bank_mem_1_reg[6] SNPS_CLOCK_GATE_HIGH_RegFileDual_DATA_WIDTH22_26
+ $PINS EN=N94 ENCLK=CTS_372 CLK=CTS_391
Xclk_gate_bank_mem_1_reg[7] SNPS_CLOCK_GATE_HIGH_RegFileDual_DATA_WIDTH22_25
+ $PINS EN=N93 ENCLK=CTS_369 CLK=CTS_391
Xclk_gate_bank_mem_1_reg[8] SNPS_CLOCK_GATE_HIGH_RegFileDual_DATA_WIDTH22_24
+ $PINS EN=N92 ENCLK=CTS_366 CLK=CTS_391
Xclk_gate_bank_mem_1_reg[9] SNPS_CLOCK_GATE_HIGH_RegFileDual_DATA_WIDTH22_23
+ $PINS EN=N91 ENCLK=CTS_363 CLK=CTS_391
Xclk_gate_bank_mem_1_reg[10] SNPS_CLOCK_GATE_HIGH_RegFileDual_DATA_WIDTH22_22
+ $PINS EN=N90 ENCLK=CTS_360 CLK=CTS_391
Xclk_gate_bank_mem_1_reg[11] SNPS_CLOCK_GATE_HIGH_RegFileDual_DATA_WIDTH22_21
+ $PINS EN=N89 ENCLK=CTS_357 CLK=CTS_391
Xclk_gate_bank_mem_1_reg[12] SNPS_CLOCK_GATE_HIGH_RegFileDual_DATA_WIDTH22_20
+ $PINS EN=N88 ENCLK=CTS_354 CLK=CTS_391
Xclk_gate_bank_mem_1_reg[13] SNPS_CLOCK_GATE_HIGH_RegFileDual_DATA_WIDTH22_19
+ $PINS EN=N87 ENCLK=CTS_351 CLK=CTS_391
Xclk_gate_bank_mem_1_reg[14] SNPS_CLOCK_GATE_HIGH_RegFileDual_DATA_WIDTH22_18
+ $PINS EN=N86 ENCLK=CTS_348 CLK=CTS_391
Xclk_gate_bank_mem_1_reg[15] SNPS_CLOCK_GATE_HIGH_RegFileDual_DATA_WIDTH22_17
+ $PINS EN=N85 ENCLK=CTS_345 CLK=CTS_391
Xclk_gate_bank_mem_0_reg[0] SNPS_CLOCK_GATE_HIGH_RegFileDual_DATA_WIDTH22_16
+ $PINS EN=N67 ENCLK=CTS_342 CLK=clk_clone3
Xclk_gate_bank_mem_0_reg[1] SNPS_CLOCK_GATE_HIGH_RegFileDual_DATA_WIDTH22_15
+ $PINS EN=N66 ENCLK=CTS_339 CLK=clk_clone3
Xclk_gate_bank_mem_0_reg[2] SNPS_CLOCK_GATE_HIGH_RegFileDual_DATA_WIDTH22_14
+ $PINS EN=N65 ENCLK=CTS_336 CLK=clk_clone3
Xclk_gate_bank_mem_0_reg[3] SNPS_CLOCK_GATE_HIGH_RegFileDual_DATA_WIDTH22_13
+ $PINS EN=N64 ENCLK=CTS_333 CLK=clk_clone3
Xclk_gate_bank_mem_0_reg[4] SNPS_CLOCK_GATE_HIGH_RegFileDual_DATA_WIDTH22_12
+ $PINS EN=N63 ENCLK=CTS_330 CLK=clk_clone3
Xclk_gate_bank_mem_0_reg[5] SNPS_CLOCK_GATE_HIGH_RegFileDual_DATA_WIDTH22_11
+ $PINS EN=N62 ENCLK=CTS_327 CLK=clk_clone3
Xclk_gate_bank_mem_0_reg[6] SNPS_CLOCK_GATE_HIGH_RegFileDual_DATA_WIDTH22_10
+ $PINS EN=N61 ENCLK=CTS_324 CLK=clk_clone3
Xclk_gate_bank_mem_0_reg[7] SNPS_CLOCK_GATE_HIGH_RegFileDual_DATA_WIDTH22_9
+ $PINS EN=N60 ENCLK=CTS_321 CLK=clk_clone3
Xclk_gate_bank_mem_0_reg[8] SNPS_CLOCK_GATE_HIGH_RegFileDual_DATA_WIDTH22_8
+ $PINS EN=N59 ENCLK=CTS_318 CLK=clk_clone3
Xclk_gate_bank_mem_0_reg[9] SNPS_CLOCK_GATE_HIGH_RegFileDual_DATA_WIDTH22_7
+ $PINS EN=N58 ENCLK=CTS_315 CLK=clk_clone3
Xclk_gate_bank_mem_0_reg[10] SNPS_CLOCK_GATE_HIGH_RegFileDual_DATA_WIDTH22_6
+ $PINS EN=N57 ENCLK=CTS_312 CLK=clk_clone3
Xclk_gate_bank_mem_0_reg[11] SNPS_CLOCK_GATE_HIGH_RegFileDual_DATA_WIDTH22_5
+ $PINS EN=N56 ENCLK=CTS_309 CLK=clk_clone3
Xclk_gate_bank_mem_0_reg[12] SNPS_CLOCK_GATE_HIGH_RegFileDual_DATA_WIDTH22_4
+ $PINS EN=N55 ENCLK=CTS_306 CLK=clk_clone3
Xclk_gate_bank_mem_0_reg[13] SNPS_CLOCK_GATE_HIGH_RegFileDual_DATA_WIDTH22_3
+ $PINS EN=N54 ENCLK=CTS_303 CLK=clk_clone3
Xclk_gate_bank_mem_0_reg[14] SNPS_CLOCK_GATE_HIGH_RegFileDual_DATA_WIDTH22_2
+ $PINS EN=N53 ENCLK=CTS_300 CLK=clk_clone3
Xclk_gate_bank_mem_0_reg[15] SNPS_CLOCK_GATE_HIGH_RegFileDual_DATA_WIDTH22_1
+ $PINS EN=N52 ENCLK=CTS_297 CLK=clk_clone3
.ENDS

.SUBCKT SNPS_CLOCK_GATE_HIGH_CHIP_0 EN ENCLK CLK
*.CONNECT ENCLK net1634
*.CONNECT net1635 EN
XFE_PHC834_net1638 DELC $PINS O=FE_PHN834_net1638 I=net1638
Xlatch QDBHN $PINS Q=net1638 D=net1635 CKB=CLK
Xmain_gate AN2P $PINS O=net1634 I1=FE_PHN834_net1638 I2=CLK
.ENDS

.SUBCKT SNPS_CLOCK_GATE_HIGH_CHIP_10 EN ENCLK CLK
*.CONNECT net1635 EN
XFE_PHC902_net1638 DELC $PINS O=FE_PHN902_net1638 I=net1638
Xlatch QDBHN $PINS Q=net1638 D=net1635 CKB=CLK
Xmain_gate AN2T $PINS O=ENCLK I1=FE_PHN902_net1638 I2=CLK
.ENDS

.SUBCKT SNPS_CLOCK_GATE_HIGH_CHIP_9 EN ENCLK CLK
*.CONNECT net1635 EN
XFE_PHC919_net1638 DELC $PINS O=FE_PHN919_net1638 I=net1638
Xlatch QDBHN $PINS Q=net1638 D=net1635 CKB=CLK
Xmain_gate AN2T $PINS O=ENCLK I1=FE_PHN919_net1638 I2=CLK
.ENDS

.SUBCKT SNPS_CLOCK_GATE_HIGH_CHIP_8 EN ENCLK CLK
*.CONNECT net1635 EN
XFE_PHC922_net1638 DELC $PINS O=FE_PHN922_net1638 I=net1638
Xlatch QDBHN $PINS Q=net1638 D=net1635 CKB=CLK
Xmain_gate AN2T $PINS O=ENCLK I1=FE_PHN922_net1638 I2=CLK
.ENDS

.SUBCKT SNPS_CLOCK_GATE_HIGH_CHIP_7 EN ENCLK CLK
*.CONNECT net1635 EN
XFE_PHC931_net1638 DELC $PINS O=FE_PHN931_net1638 I=net1638
Xlatch QDBHN $PINS Q=net1638 D=net1635 CKB=CLK
Xmain_gate AN2T $PINS O=ENCLK I1=FE_PHN931_net1638 I2=CLK
.ENDS

.SUBCKT SNPS_CLOCK_GATE_HIGH_CHIP_6 EN ENCLK CLK
*.CONNECT net1635 EN
XFE_PHC916_net1638 DELC $PINS O=net1638 I=FE_PHN916_net1638
Xlatch QDBHN $PINS Q=FE_PHN916_net1638 D=net1635 CKB=CLK
Xmain_gate AN2T $PINS O=ENCLK I1=net1638 I2=CLK
.ENDS

.SUBCKT SNPS_CLOCK_GATE_HIGH_CHIP_5 EN ENCLK CLK
*.CONNECT net1635 EN
XFE_PHC909_net1638 DELC $PINS O=FE_PHN909_net1638 I=net1638
Xlatch QDBHN $PINS Q=net1638 D=net1635 CKB=CLK
Xmain_gate AN2T $PINS O=ENCLK I1=FE_PHN909_net1638 I2=CLK
.ENDS

.SUBCKT SNPS_CLOCK_GATE_HIGH_CHIP_4 EN ENCLK CLK
*.CONNECT net1635 EN
XFE_PHC906_net1638 DELC $PINS O=FE_PHN906_net1638 I=net1638
Xlatch QDBHN $PINS Q=net1638 D=net1635 CKB=CLK
Xmain_gate AN2T $PINS O=ENCLK I1=FE_PHN906_net1638 I2=CLK
.ENDS

.SUBCKT SNPS_CLOCK_GATE_HIGH_CHIP_3 EN ENCLK CLK
*.CONNECT ENCLK net1634
*.CONNECT net1635 EN
XFE_PHC866_net1638 DELC $PINS O=FE_PHN866_net1638 I=net1638
Xlatch QDBHN $PINS Q=net1638 D=net1635 CKB=CLK
Xmain_gate AN2P $PINS O=net1634 I1=FE_PHN866_net1638 I2=CLK
.ENDS

.SUBCKT SNPS_CLOCK_GATE_HIGH_CHIP_2 EN ENCLK CLK
*.CONNECT ENCLK net1634
*.CONNECT net1635 EN
XFE_PHC850_net1638 DELC $PINS O=FE_PHN850_net1638 I=net1638
Xlatch QDBHN $PINS Q=net1638 D=net1635 CKB=CLK
Xmain_gate AN2P $PINS O=net1634 I1=FE_PHN850_net1638 I2=CLK
.ENDS

.SUBCKT SNPS_CLOCK_GATE_HIGH_CHIP_1 EN ENCLK CLK
*.CONNECT ENCLK net1634
*.CONNECT net1635 EN
XFE_PHC913_net1638 DELC $PINS O=FE_PHN913_net1638 I=net1638
Xlatch QDBHN $PINS Q=net1638 D=net1635 CKB=CLK
Xmain_gate AN2T $PINS O=net1634 I1=FE_PHN913_net1638 I2=CLK
.ENDS

.SUBCKT CHIP_DW01_inc_1_DW01_inc_3 A[8] A[7] A[6] A[5] A[4] A[3] A[2] A[1] A[0]
+ SUM[8] SUM[7] SUM[6] SUM[5] SUM[4] SUM[3] SUM[2] SUM[1] SUM[0]
XU1_1_7 HA1 $PINS S=SUM[7] C=carry[8] A=A[7] B=carry[7]
XU1_1_6 HA1 $PINS S=SUM[6] C=carry[7] A=A[6] B=carry[6]
XU1_1_5 HA1 $PINS S=SUM[5] C=carry[6] A=A[5] B=carry[5]
XU1_1_4 HA1 $PINS S=SUM[4] C=carry[5] A=A[4] B=carry[4]
XU1_1_3 HA1 $PINS S=SUM[3] C=carry[4] A=A[3] B=carry[3]
XU1_1_2 HA1 $PINS S=SUM[2] C=carry[3] A=A[2] B=carry[2]
XU1_1_1 HA1 $PINS S=SUM[1] C=carry[2] A=A[1] B=A[0]
XU1 XOR2HS $PINS O=SUM[8] I1=carry[8] I2=A[8]
.ENDS

.SUBCKT CHIP_DW02_mult_1 A[5] A[4] A[3] A[2] A[1] A[0] B[7] B[6] B[5] B[4] B[3]
+ B[2] B[1] B[0] TC PRODUCT[13] PRODUCT[12] PRODUCT[11] PRODUCT[10] PRODUCT[9]
+ PRODUCT[8] PRODUCT[7] PRODUCT[6] PRODUCT[5] PRODUCT[4] PRODUCT[3] PRODUCT[2]
+ PRODUCT[1] PRODUCT[0]
XS2_2_5 XOR3 $PINS O=SUMB[2][5] I1=ab[2][5] I2=n8 I3=SUMB[1][6]
XS2_3_4 XOR3 $PINS O=SUMB[3][4] I1=ab[3][4] I2=CARRYB[2][4] I3=SUMB[2][5]
XS2_2_4 FA1S $PINS S=SUMB[2][4] CO=CARRYB[2][4] A=ab[2][4] B=n2 CI=SUMB[1][5]
XS1_2_0 FA1S $PINS S=PRODUCT[2] CO=CARRYB[2][0] A=ab[2][0] B=n6 CI=SUMB[1][1]
XS2_3_3 FA1S $PINS S=SUMB[3][3] CO=CARRYB[3][3] A=ab[3][3] B=CARRYB[2][3]
+ CI=SUMB[2][4]
XS2_2_3 FA1S $PINS S=SUMB[2][3] CO=CARRYB[2][3] A=ab[2][3] B=n3 CI=SUMB[1][4]
XS2_4_2 FA1S $PINS S=SUMB[4][2] CO=CARRYB[4][2] A=ab[4][2] B=CARRYB[3][2]
+ CI=SUMB[3][3]
XS2_3_2 FA1S $PINS S=SUMB[3][2] CO=CARRYB[3][2] A=ab[3][2] B=CARRYB[2][2]
+ CI=SUMB[2][3]
XS2_4_3 XOR3 $PINS O=SUMB[4][3] I1=ab[4][3] I2=CARRYB[3][3] I3=SUMB[3][4]
XS4_2 XOR3 $PINS O=SUMB[5][2] I1=ab[5][2] I2=CARRYB[4][2] I3=SUMB[4][3]
XS2_2_2 FA1S $PINS S=SUMB[2][2] CO=CARRYB[2][2] A=ab[2][2] B=n4 CI=SUMB[1][3]
XS2_4_1 FA1S $PINS S=SUMB[4][1] CO=CARRYB[4][1] A=ab[4][1] B=CARRYB[3][1]
+ CI=SUMB[3][2]
XS2_3_1 FA1S $PINS S=SUMB[3][1] CO=CARRYB[3][1] A=ab[3][1] B=CARRYB[2][1]
+ CI=SUMB[2][2]
XS4_1 FA1S $PINS S=SUMB[5][1] CO=CARRYB[5][1] A=ab[5][1] B=CARRYB[4][1]
+ CI=SUMB[4][2]
XS2_2_1 FA1S $PINS S=SUMB[2][1] CO=CARRYB[2][1] A=ab[2][1] B=n5 CI=SUMB[1][2]
XS1_4_0 FA1S $PINS S=PRODUCT[4] CO=CARRYB[4][0] A=ab[4][0] B=CARRYB[3][0]
+ CI=SUMB[3][1]
XS1_3_0 FA1S $PINS S=PRODUCT[3] CO=CARRYB[3][0] A=ab[3][0] B=CARRYB[2][0]
+ CI=SUMB[2][1]
XS4_0 FA1S $PINS S=PRODUCT[5] CO=CARRYB[5][0] A=ab[5][0] B=CARRYB[4][0]
+ CI=SUMB[4][1]
XU2 XOR3 $PINS O=PRODUCT[7] I1=CARRYB[5][1] I2=SUMB[5][2] I3=n7
XU3 AN2 $PINS O=n2 I1=ab[0][5] I2=ab[1][4]
XU4 AN2 $PINS O=n3 I1=ab[0][4] I2=ab[1][3]
XU5 AN2 $PINS O=n4 I1=ab[0][3] I2=ab[1][2]
XU6 AN2 $PINS O=n5 I1=ab[0][2] I2=ab[1][1]
XU7 AN2 $PINS O=n6 I1=ab[0][1] I2=ab[1][0]
XU8 INV1S $PINS O=n20 I=A[1]
XU9 AN2 $PINS O=n7 I1=SUMB[5][1] I2=CARRYB[5][0]
XU10 XOR2HS $PINS O=PRODUCT[6] I1=CARRYB[5][0] I2=SUMB[5][1]
XU11 AN2 $PINS O=n8 I1=ab[0][6] I2=ab[1][5]
XU12 XOR2HS $PINS O=PRODUCT[1] I1=ab[1][0] I2=ab[0][1]
XU13 XOR2HS $PINS O=SUMB[1][2] I1=ab[1][2] I2=ab[0][3]
XU14 XOR2HS $PINS O=SUMB[1][3] I1=ab[1][3] I2=ab[0][4]
XU15 XOR2HS $PINS O=SUMB[1][4] I1=ab[1][4] I2=ab[0][5]
XU16 XOR2HS $PINS O=SUMB[1][1] I1=ab[1][1] I2=ab[0][2]
XU17 XOR2HS $PINS O=SUMB[1][5] I1=ab[1][5] I2=ab[0][6]
XU18 INV1S $PINS O=n19 I=A[2]
XU19 XOR2HS $PINS O=SUMB[1][6] I1=ab[1][6] I2=ab[0][7]
XU20 INV1S $PINS O=n18 I=A[3]
XU21 INV1S $PINS O=n17 I=A[4]
XU22 INV1S $PINS O=n9 I=B[7]
XU23 INV1S $PINS O=n14 I=B[2]
XU24 INV1S $PINS O=n15 I=B[1]
XU25 INV1S $PINS O=n13 I=B[3]
XU26 INV1S $PINS O=n12 I=B[4]
XU27 INV1S $PINS O=n11 I=B[5]
XU28 INV1S $PINS O=n16 I=B[0]
XU29 INV1S $PINS O=n10 I=B[6]
XU30 NR2 $PINS O=ab[5][2] I1=A[0] I2=n14
XU31 NR2 $PINS O=ab[5][1] I1=A[0] I2=n15
XU32 NR2 $PINS O=ab[5][0] I1=A[0] I2=n16
XU33 NR2 $PINS O=ab[4][3] I1=n13 I2=n17
XU34 NR2 $PINS O=ab[4][2] I1=n14 I2=n17
XU35 NR2 $PINS O=ab[4][1] I1=n15 I2=n17
XU36 NR2 $PINS O=ab[4][0] I1=n16 I2=n17
XU37 NR2 $PINS O=ab[3][4] I1=n12 I2=n18
XU38 NR2 $PINS O=ab[3][3] I1=n13 I2=n18
XU39 NR2 $PINS O=ab[3][2] I1=n14 I2=n18
XU40 NR2 $PINS O=ab[3][1] I1=n15 I2=n18
XU41 NR2 $PINS O=ab[3][0] I1=n16 I2=n18
XU42 NR2 $PINS O=ab[2][5] I1=n11 I2=n19
XU43 NR2 $PINS O=ab[2][4] I1=n12 I2=n19
XU44 NR2 $PINS O=ab[2][3] I1=n13 I2=n19
XU45 NR2 $PINS O=ab[2][2] I1=n14 I2=n19
XU46 NR2 $PINS O=ab[2][1] I1=n15 I2=n19
XU47 NR2 $PINS O=ab[2][0] I1=n16 I2=n19
XU48 NR2 $PINS O=ab[1][6] I1=n10 I2=n20
XU49 NR2 $PINS O=ab[1][5] I1=n11 I2=n20
XU50 NR2 $PINS O=ab[1][4] I1=n12 I2=n20
XU51 NR2 $PINS O=ab[1][3] I1=n13 I2=n20
XU52 NR2 $PINS O=ab[1][2] I1=n14 I2=n20
XU53 NR2 $PINS O=ab[1][1] I1=n15 I2=n20
XU54 NR2 $PINS O=ab[1][0] I1=n16 I2=n20
XU55 NR2 $PINS O=ab[0][7] I1=A[5] I2=n9
XU56 NR2 $PINS O=ab[0][6] I1=A[5] I2=n10
XU57 NR2 $PINS O=ab[0][5] I1=A[5] I2=n11
XU58 NR2 $PINS O=ab[0][4] I1=A[5] I2=n12
XU59 NR2 $PINS O=ab[0][3] I1=A[5] I2=n13
XU60 NR2 $PINS O=ab[0][2] I1=A[5] I2=n14
XU61 NR2 $PINS O=ab[0][1] I1=A[5] I2=n15
XU62 NR2 $PINS O=PRODUCT[0] I1=A[5] I2=n16
.ENDS

.SUBCKT CHIP_DW02_mult_0 A[7] A[6] A[5] A[4] A[3] A[2] A[1] A[0] B[4] B[3] B[2]
+ B[1] B[0] TC PRODUCT[12] PRODUCT[11] PRODUCT[10] PRODUCT[9] PRODUCT[8]
+ PRODUCT[7] PRODUCT[6] PRODUCT[5] PRODUCT[4] PRODUCT[3] PRODUCT[2] PRODUCT[1]
+ PRODUCT[0] n253
*.CONNECT PRODUCT[1] ab[0][1]
XS3_3_3 FA1S $PINS S=SUMB[3][3] CO=CARRYB[3][3] A=ab[3][3] B=CARRYB[2][3]
+ CI=ab[2][4]
XS3_4_3 XOR3 $PINS O=SUMB[4][3] I1=ab[4][3] I2=CARRYB[3][3] I3=ab[3][4]
XS2_5_2 XOR3 $PINS O=SUMB[5][2] I1=ab[5][2] I2=CARRYB[4][2] I3=SUMB[4][3]
XS2_2_2 FA1S $PINS S=SUMB[2][2] CO=CARRYB[2][2] A=ab[2][2] B=n3 CI=SUMB[1][3]
XS2_3_2 FA1S $PINS S=SUMB[3][2] CO=CARRYB[3][2] A=ab[3][2] B=CARRYB[2][2]
+ CI=SUMB[2][3]
XS2_4_2 FA1S $PINS S=SUMB[4][2] CO=CARRYB[4][2] A=ab[4][2] B=CARRYB[3][2]
+ CI=SUMB[3][3]
XS3_2_3 FA1S $PINS S=SUMB[2][3] CO=CARRYB[2][3] A=ab[2][3] B=n4 CI=ab[1][4]
XS2_6_1 XOR3 $PINS O=PRODUCT[7] I1=ab[6][1] I2=CARRYB[5][1] I3=SUMB[5][2]
XS2_2_1 FA1S $PINS S=PRODUCT[3] CO=CARRYB[2][1] A=ab[2][1] B=n2 CI=SUMB[1][2]
XS2_5_1 FA1S $PINS S=PRODUCT[6] CO=CARRYB[5][1] A=ab[5][1] B=CARRYB[4][1]
+ CI=SUMB[4][2]
XS2_4_1 FA1S $PINS S=PRODUCT[5] CO=CARRYB[4][1] A=ab[4][1] B=CARRYB[3][1]
+ CI=SUMB[3][2]
XS2_3_1 FA1S $PINS S=PRODUCT[4] CO=CARRYB[3][1] A=ab[3][1] B=CARRYB[2][1]
+ CI=SUMB[2][2]
XU2 AN2 $PINS O=n2 I1=ab[0][2] I2=ab[1][1]
XU3 AN2 $PINS O=n3 I1=ab[0][3] I2=ab[1][2]
XU4 AN2 $PINS O=n4 I1=ab[0][4] I2=ab[1][3]
XU6 XOR2HS $PINS O=PRODUCT[2] I1=ab[1][1] I2=ab[0][2]
XU7 XOR2HS $PINS O=SUMB[1][2] I1=ab[1][2] I2=ab[0][3]
XU8 XOR2HS $PINS O=SUMB[1][3] I1=ab[1][3] I2=ab[0][4]
XU12 INV1S $PINS O=n12 I=A[0]
XU13 INV1S $PINS O=n11 I=A[1]
XU14 INV1S $PINS O=n10 I=A[2]
XU15 INV1S $PINS O=n9 I=A[3]
XU16 INV1S $PINS O=n8 I=A[4]
XU17 INV1S $PINS O=n6 I=A[6]
XU18 INV1S $PINS O=n7 I=A[5]
XU19 NR2 $PINS O=ab[6][1] I1=n253 I2=n6
XU20 NR2 $PINS O=ab[5][2] I1=B[2] I2=n7
XU21 NR2 $PINS O=ab[5][1] I1=n253 I2=n7
XU22 NR2 $PINS O=ab[4][3] I1=B[3] I2=n8
XU23 NR2 $PINS O=ab[4][2] I1=B[2] I2=n8
XU24 NR2 $PINS O=ab[4][1] I1=n253 I2=n8
XU25 NR2 $PINS O=ab[3][4] I1=B[4] I2=n9
XU26 NR2 $PINS O=ab[3][3] I1=B[3] I2=n9
XU27 NR2 $PINS O=ab[3][2] I1=B[2] I2=n9
XU28 NR2 $PINS O=ab[3][1] I1=n253 I2=n9
XU29 NR2 $PINS O=ab[2][4] I1=B[4] I2=n10
XU30 NR2 $PINS O=ab[2][3] I1=B[3] I2=n10
XU31 NR2 $PINS O=ab[2][2] I1=B[2] I2=n10
XU32 NR2 $PINS O=ab[2][1] I1=n253 I2=n10
XU33 NR2 $PINS O=ab[1][4] I1=B[4] I2=n11
XU34 NR2 $PINS O=ab[1][3] I1=B[3] I2=n11
XU35 NR2 $PINS O=ab[1][2] I1=B[2] I2=n11
XU36 NR2 $PINS O=ab[1][1] I1=n253 I2=n11
XU37 NR2 $PINS O=ab[0][4] I1=B[4] I2=n12
XU38 NR2 $PINS O=ab[0][3] I1=B[3] I2=n12
XU39 NR2 $PINS O=ab[0][2] I1=B[2] I2=n12
XU40 NR2 $PINS O=ab[0][1] I1=n253 I2=n12
.ENDS

.SUBCKT CHIP_core clk rst_n i_valid i_ready o_ready o_valid i_data[21]
+ i_data[20] i_data[19] i_data[18] i_data[17] i_data[16] i_data[15] i_data[14]
+ i_data[13] i_data[12] i_data[11] i_data[10] i_data[9] i_data[8] i_data[7]
+ i_data[6] i_data[5] i_data[4] i_data[3] i_data[2] i_data[1] i_data[0]
+ o_data[10] o_data[9] o_data[8] o_data[7] o_data[6] o_data[5] o_data[4]
+ o_data[3] o_data[2] o_data[1] o_data[0]
XFE_PHC1532_o_counter_r_0 BUF1CK $PINS O=FE_PHN1532_o_counter_r_0
+ I=o_counter_r[0]
XFE_PHC1529_pe_i2_11 BUF1CK $PINS O=FE_PHN1529_pe_i2_11 I=pe_i2[11]
XFE_PHC1525_n259 BUF1CK $PINS O=FE_PHN1525_n259 I=n259
XFE_PHC1521_c_buf_r_3_3 BUF1CK $PINS O=FE_PHN1521_c_buf_r_3_3 I=c_buf_r[3][3]
XFE_PHC1517_pe_r2_10 BUF1CK $PINS O=FE_PHN1517_pe_r2_10 I=pe_r2[10]
XFE_PHC1470_rf_io_wdata_2_2 BUF1CK $PINS O=FE_PHN1470_rf_io_wdata_2_2
+ I=rf_io_wdata_2[2]
XFE_PHC1468_c_in_i_0_3 DELB $PINS O=FE_PHN1468_c_in_i_0_3 I=c_in_i_0[3]
XFE_PHC1467_c_in_i_1_8 BUF1S $PINS O=FE_PHN1467_c_in_i_1_8 I=c_in_i_1[8]
XFE_PHC1466_c_in_r_0_10 BUF1S $PINS O=c_in_r_0[10] I=FE_PHN1466_c_in_r_0_10
XFE_PHC1465_rf_io_wdata_2_4 BUF1CK $PINS O=FE_PHN1465_rf_io_wdata_2_4
+ I=rf_io_wdata_2[4]
XFE_PHC1464_c_in_i_1_7 DELB $PINS O=FE_PHN1464_c_in_i_1_7 I=c_in_i_1[7]
XFE_PHC1462_c_in_i_1_9 DELB $PINS O=FE_PHN1462_c_in_i_1_9 I=c_in_i_1[9]
XFE_PHC1461_c_in_r_0_5 DELB $PINS O=c_in_r_0[5] I=FE_PHN1461_c_in_r_0_5
XFE_PHC1460_c_in_r_0_8 DELB $PINS O=c_in_r_0[8] I=FE_PHN1460_c_in_r_0_8
XFE_PHC1459_c_in_r_0_7 DELB $PINS O=c_in_r_0[7] I=FE_PHN1459_c_in_r_0_7
XFE_PHC1458_c_in_r_0_0 DELB $PINS O=c_in_r_0[0] I=FE_PHN1458_c_in_r_0_0
XFE_PHC1456_c_in_i_0_14 DELB $PINS O=FE_PHN1456_c_in_i_0_14 I=c_in_i_0[14]
XFE_PHC1437_N47 DELA $PINS O=N47 I=FE_PHN1437_N47
XFE_PHC1430_c_in_r_0_16 DELA $PINS O=c_in_r_0[16] I=FE_PHN1430_c_in_r_0_16
XFE_PHC1428_counter_w_1 DELB $PINS O=FE_PHN1428_counter_w_1 I=counter_w[1]
XFE_PHC1414_counter_w_2 DELB $PINS O=FE_PHN1414_counter_w_2 I=counter_w[2]
XFE_PHC1400_pe_done_d2 DELB $PINS O=FE_PHN1400_pe_done_d2 I=pe_done_d2
XFE_PHC1399_counter_w_3 DELB $PINS O=FE_PHN1399_counter_w_3 I=counter_w[3]
XFE_PHC1385_n284 DELB $PINS O=n284 I=FE_PHN1385_n284
XFE_PHC1384_c_in_r_1_16 DELB $PINS O=FE_PHN1384_c_in_r_1_16 I=c_in_r_1[16]
XFE_PHC1379_counter_w_6 DELB $PINS O=FE_PHN1379_counter_w_6 I=counter_w[6]
XFE_PHC1364_counter_w_7 DELB $PINS O=FE_PHN1364_counter_w_7 I=counter_w[7]
XFE_PHC1362_N155 DELB $PINS O=FE_PHN1362_N155 I=N155
XFE_PHC1351_N117 DELB $PINS O=FE_PHN1351_N117 I=N117
XFE_PHC1344_N118 DELB $PINS O=FE_PHN1344_N118 I=N118
XFE_PHC1342_N116 DELB $PINS O=FE_PHN1342_N116 I=N116
XFE_PHC1335_N115 DELB $PINS O=FE_PHN1335_N115 I=N115
XFE_PHC1334_N120 DELB $PINS O=FE_PHN1334_N120 I=N120
XFE_PHC1323_N48 DELC $PINS O=N48 I=FE_PHN1323_N48
XFE_PHC1317_N119 DELB $PINS O=FE_PHN1317_N119 I=N119
XFE_PHC1304_counter_w_8 DELC $PINS O=counter_w[8] I=FE_PHN1304_counter_w_8
XFE_PHC1294_key_w_3 DELB $PINS O=FE_PHN1294_key_w_3 I=key_w[3]
XFE_PHC1290_o_counter_w_5 DELC $PINS O=o_counter_w[5]
+ I=FE_PHN1290_o_counter_w_5
XFE_PHC1285_key_w_1 DELB $PINS O=key_w[1] I=FE_PHN1285_key_w_1
XFE_PHC1283_key_w_4 DELB $PINS O=FE_PHN1283_key_w_4 I=key_w[4]
XFE_PHC1282_key_w_0 DELB $PINS O=FE_PHN1282_key_w_0 I=key_w[0]
XFE_PHC1280_o_counter_w_4 DELC $PINS O=FE_PHN1280_o_counter_w_4
+ I=o_counter_w[4]
XFE_PHC1279_key_w_5 DELB $PINS O=key_w[5] I=FE_PHN1279_key_w_5
XFE_PHC1277_n281 DELB $PINS O=n281 I=FE_PHN1277_n281
XFE_PHC1274_key_w_2 DELB $PINS O=FE_PHN1274_key_w_2 I=key_w[2]
XFE_PHC1271_key_w_6 DELB $PINS O=FE_PHN1271_key_w_6 I=key_w[6]
XFE_PHC1269_o_counter_w_2 DELC $PINS O=o_counter_w[2]
+ I=FE_PHN1269_o_counter_w_2
XFE_PHC1268_o_counter_w_3 DELC $PINS O=o_counter_w[3]
+ I=FE_PHN1268_o_counter_w_3
XFE_PHC1267_key_w_7 DELC $PINS O=key_w[7] I=FE_PHN1267_key_w_7
XFE_PHC1266_n282 DELC $PINS O=FE_PHN1266_n282 I=n282
XFE_PHC1265_n280 DELC $PINS O=n280 I=FE_PHN1265_n280
XFE_PHC1264_current_n_4 DELB $PINS O=FE_PHN1264_current_n_4 I=current_n[4]
XFE_PHC1263_current_g_2 DELC $PINS O=FE_PHN1263_current_g_2 I=current_g[2]
XFE_PHC1262_current_g_1 DELC $PINS O=current_g[1] I=FE_PHN1262_current_g_1
XFE_PHC1261_current_g_0 DELC $PINS O=current_g[0] I=FE_PHN1261_current_g_0
XFE_PHC1260_key_r_0 DELB $PINS O=FE_PHN1260_key_r_0 I=key_r[0]
XFE_PHC1257_g_cnt_d3_2 DELC $PINS O=g_cnt_d3[2] I=FE_PHN1257_g_cnt_d3_2
XFE_PHC1256_g_cnt_d3_1 DELC $PINS O=g_cnt_d3[1] I=FE_PHN1256_g_cnt_d3_1
XFE_PHC1255_g_cnt_d3_0 DELC $PINS O=g_cnt_d3[0] I=FE_PHN1255_g_cnt_d3_0
XFE_PHC1254_pe_r1_10 DELC $PINS O=FE_PHN1254_pe_r1_10 I=pe_r1[10]
XFE_PHC1250_pe_r1_16 DELC $PINS O=FE_PHN1250_pe_r1_16 I=pe_r1[16]
XFE_PHC1241_pe_r0_12 DELC $PINS O=FE_PHN1241_pe_r0_12 I=pe_r0[12]
XFE_PHC1240_pe_r0_15 DELC $PINS O=FE_PHN1240_pe_r0_15 I=pe_r0[15]
XFE_PHC1239_pe_r0_11 DELC $PINS O=FE_PHN1239_pe_r0_11 I=pe_r0[11]
XFE_PHC1238_n315 DELB $PINS O=FE_PHN1238_n315 I=n315
XFE_PHC1229_o_counter_r_0 BUF1S $PINS O=FE_PHN1229_o_counter_r_0
+ I=FE_PHN1532_o_counter_r_0
XFE_PHC1222_o_counter_r_1 DELC $PINS O=FE_PHN1222_o_counter_r_1
+ I=o_counter_r[1]
XFE_PHC1217_c_in_r_1_3 BUF1S $PINS O=FE_PHN1217_c_in_r_1_3 I=c_in_r_1[3]
XFE_PHC1214_c_buf_i_3_2 BUF1CK $PINS O=FE_PHN1214_c_buf_i_3_2 I=c_buf_i[3][2]
XFE_PHC1212_c_in_r_1_9 DELB $PINS O=FE_PHN1212_c_in_r_1_9 I=c_in_r_1[9]
XFE_PHC1211_c_in_r_1_6 BUF1S $PINS O=FE_PHN1211_c_in_r_1_6 I=c_in_r_1[6]
XFE_PHC1209_c_in_r_1_8 BUF1S $PINS O=FE_PHN1209_c_in_r_1_8 I=c_in_r_1[8]
XFE_PHC1208_c_in_r_1_7 DELA $PINS O=c_in_r_1[7] I=FE_PHN1208_c_in_r_1_7
XFE_PHC1207_pe_r3_15 DELC $PINS O=FE_PHN1207_pe_r3_15 I=pe_r3[15]
XFE_PHC1205_pe_i1_5 DELC $PINS O=FE_PHN1205_pe_i1_5 I=pe_i1[5]
XFE_PHC1202_pe_r3_14 DELC $PINS O=FE_PHN1202_pe_r3_14 I=pe_r3[14]
XFE_PHC1201_pe_i0_10 DELC $PINS O=FE_PHN1201_pe_i0_10 I=pe_i0[10]
XFE_PHC1200_c_in_i_1_6 DELA $PINS O=FE_PHN1200_c_in_i_1_6 I=c_in_i_1[6]
XFE_PHC1199_pe_i1_0 DELC $PINS O=FE_PHN1199_pe_i1_0 I=pe_i1[0]
XFE_PHC1198_pe_i0_1 DELC $PINS O=FE_PHN1198_pe_i0_1 I=pe_i0[1]
XFE_PHC1197_pe_r0_0 DELC $PINS O=FE_PHN1197_pe_r0_0 I=pe_r0[0]
XFE_PHC1194_pe_r1_7 DELC $PINS O=FE_PHN1194_pe_r1_7 I=pe_r1[7]
XFE_PHC1189_pe_r1_4 DELC $PINS O=FE_PHN1189_pe_r1_4 I=pe_r1[4]
XFE_PHC1187_c_in_i_0_4 DELB $PINS O=c_in_i_0[4] I=FE_PHN1187_c_in_i_0_4
XFE_PHC1185_pe_i3_13 DELC $PINS O=FE_PHN1185_pe_i3_13 I=pe_i3[13]
XFE_PHC1184_pe_i2_15 DELC $PINS O=FE_PHN1184_pe_i2_15 I=pe_i2[15]
XFE_PHC1181_pe_r1_0 DELC $PINS O=FE_PHN1181_pe_r1_0 I=pe_r1[0]
XFE_PHC1180_c_in_r_1_4 BUF1S $PINS O=FE_PHN1180_c_in_r_1_4 I=c_in_r_1[4]
XFE_PHC1178_c_in_i_0_10 DELB $PINS O=FE_PHN1178_c_in_i_0_10 I=c_in_i_0[10]
XFE_PHC1175_c_in_r_0_11 BUF1S $PINS O=c_in_r_0[11] I=FE_PHN1175_c_in_r_0_11
XFE_PHC1174_c_in_r_1_5 BUF1S $PINS O=FE_PHN1174_c_in_r_1_5 I=c_in_r_1[5]
XFE_PHC1173_c_buf_i_0_3 DELA $PINS O=c_buf_i[0][3] I=FE_PHN1173_c_buf_i_0_3
XFE_PHC1170_n259 BUF1S $PINS O=FE_PHN1170_n259 I=FE_PHN1525_n259
XFE_PHC1169_pe_i3_10 DELC $PINS O=FE_PHN1169_pe_i3_10 I=pe_i3[10]
XFE_PHC1164_c_in_i_1_10 DELB $PINS O=FE_PHN1164_c_in_i_1_10 I=c_in_i_1[10]
XFE_PHC1162_c_buf_r_0_4 DELB $PINS O=c_buf_r[0][4] I=FE_PHN1162_c_buf_r_0_4
XFE_PHC1161_pe_i2_10 DELC $PINS O=FE_PHN1161_pe_i2_10 I=pe_i2[10]
XFE_PHC1158_pe_r2_12 DELC $PINS O=FE_PHN1158_pe_r2_12 I=pe_r2[12]
XFE_PHC1155_pe_i2_11 DELC $PINS O=FE_PHN1155_pe_i2_11 I=pe_i2[11]
XFE_PHC1154_pe_r3_16 DELC $PINS O=FE_PHN1154_pe_r3_16 I=pe_r3[16]
XFE_PHC1153_c_buf_r_0_7 DELB $PINS O=c_buf_r[0][7] I=FE_PHN1153_c_buf_r_0_7
XFE_PHC1150_c_buf_r_2_4 DELB $PINS O=c_buf_r[2][4] I=FE_PHN1150_c_buf_r_2_4
XFE_PHC1148_c_in_i_1_11 DELB $PINS O=FE_PHN1148_c_in_i_1_11 I=c_in_i_1[11]
XFE_PHC1146_c_in_i_1_12 DELB $PINS O=FE_PHN1146_c_in_i_1_12 I=c_in_i_1[12]
XFE_PHC1145_c_buf_r_0_8 DELB $PINS O=c_buf_r[0][8] I=FE_PHN1145_c_buf_r_0_8
XFE_PHC1144_c_buf_r_0_0 DELA $PINS O=c_buf_r[0][0] I=FE_PHN1144_c_buf_r_0_0
XFE_PHC1143_cor_x_out_1_1 BUF1CK $PINS O=FE_PHN1143_cor_x_out_1_1
+ I=cor_x_out[1][1]
XFE_PHC1140_c_buf_r_0_10 DELB $PINS O=FE_PHN1140_c_buf_r_0_10 I=c_buf_r[0][10]
XFE_PHC1138_c_buf_r_2_5 DELB $PINS O=FE_PHN1138_c_buf_r_2_5 I=c_buf_r[2][5]
XFE_PHC1137_pe_r3_11 DELC $PINS O=FE_PHN1137_pe_r3_11 I=pe_r3[11]
XFE_PHC1135_pe_r3_13 DELC $PINS O=FE_PHN1135_pe_r3_13 I=pe_r3[13]
XFE_PHC1134_c_in_r_1_13 DELB $PINS O=FE_PHN1134_c_in_r_1_13 I=c_in_r_1[13]
XFE_PHC1132_c_buf_i_1_8 BUF1S $PINS O=FE_PHN1132_c_buf_i_1_8 I=c_buf_i[1][8]
XFE_PHC1131_pe_i3_12 DELC $PINS O=FE_PHN1131_pe_i3_12 I=pe_i3[12]
XFE_PHC1130_c_buf_i_1_7 BUF1S $PINS O=c_buf_i[1][7] I=FE_PHN1130_c_buf_i_1_7
XFE_PHC1129_cor_y_out_1_7 BUF1CK $PINS O=FE_PHN1129_cor_y_out_1_7
+ I=cor_y_out[1][7]
XFE_PHC1126_pe_i3_15 DELC $PINS O=FE_PHN1126_pe_i3_15 I=pe_i3[15]
XFE_PHC1125_pe_r2_10 DELC $PINS O=FE_PHN1125_pe_r2_10 I=pe_r2[10]
XFE_PHC1123_cor_x_out_1_6 BUF1CK $PINS O=FE_PHN1123_cor_x_out_1_6
+ I=cor_x_out[1][6]
XFE_PHC1122_pe_i3_14 DELC $PINS O=FE_PHN1122_pe_i3_14 I=pe_i3[14]
XFE_PHC1121_pe_r2_15 DELC $PINS O=FE_PHN1121_pe_r2_15 I=pe_r2[15]
XFE_PHC1120_pe_r2_11 DELC $PINS O=FE_PHN1120_pe_r2_11 I=pe_r2[11]
XFE_PHC1118_c_buf_r_0_13 DELA $PINS O=FE_PHN1118_c_buf_r_0_13 I=c_buf_r[0][13]
XFE_PHC1117_c_buf_i_1_9 BUF1S $PINS O=FE_PHN1117_c_buf_i_1_9 I=c_buf_i[1][9]
XFE_PHC1116_pe_r2_14 DELC $PINS O=FE_PHN1116_pe_r2_14 I=pe_r2[14]
XFE_PHC1114_pe_r2_13 DELC $PINS O=FE_PHN1114_pe_r2_13 I=pe_r2[13]
XFE_PHC1110_pe_i2_13 DELC $PINS O=FE_PHN1110_pe_i2_13 I=pe_i2[13]
XFE_PHC1109_c_in_r_1_14 DELB $PINS O=FE_PHN1109_c_in_r_1_14 I=c_in_r_1[14]
XFE_PHC1107_c_in_i_1_13 DELB $PINS O=FE_PHN1107_c_in_i_1_13 I=c_in_i_1[13]
XFE_PHC1106_cor_x_out_1_7 BUF1CK $PINS O=FE_PHN1106_cor_x_out_1_7
+ I=cor_x_out[1][7]
XFE_PHC1103_c_buf_r_3_12 DELB $PINS O=c_buf_r[3][12] I=FE_PHN1103_c_buf_r_3_12
XFE_PHC1102_c_buf_r_0_14 DELA $PINS O=c_buf_r[0][14] I=FE_PHN1102_c_buf_r_0_14
XFE_PHC1100_c_buf_r_2_13 DELB $PINS O=c_buf_r[2][13] I=FE_PHN1100_c_buf_r_2_13
XFE_PHC1096_c_in_i_0_16 DELB $PINS O=FE_PHN1096_c_in_i_0_16 I=c_in_i_0[16]
XFE_PHC1094_pe_i3_16 DELC $PINS O=FE_PHN1094_pe_i3_16 I=pe_i3[16]
XFE_PHC1091_c_in_i_1_14 DELB $PINS O=FE_PHN1091_c_in_i_1_14 I=c_in_i_1[14]
XFE_PHC1090_c_buf_r_2_14 DELB $PINS O=c_buf_r[2][14] I=FE_PHN1090_c_buf_r_2_14
XFE_PHC1089_c_buf_r_1_12 BUF1S $PINS O=FE_PHN1089_c_buf_r_1_12 I=c_buf_r[1][12]
XFE_PHC1086_cor_y_out_1_15 BUF1S $PINS O=FE_PHN1086_cor_y_out_1_15
+ I=cor_y_out[1][15]
XFE_PHC1085_c_buf_i_0_14 BUF1S $PINS O=FE_PHN1085_c_buf_i_0_14 I=c_buf_i[0][14]
XFE_PHC1078_c_in_i_1_15 DELB $PINS O=FE_PHN1078_c_in_i_1_15 I=c_in_i_1[15]
XFE_PHC1063_cor_y_out_1_11 BUF1S $PINS O=FE_PHN1063_cor_y_out_1_11
+ I=cor_y_out[1][11]
XFE_PHC1062_c_buf_r_3_15 DELB $PINS O=c_buf_r[3][15] I=FE_PHN1062_c_buf_r_3_15
XFE_PHC1054_N63 DELB $PINS O=FE_PHN1054_N63 I=N63
XFE_PHC1047_c_buf_r_1_15 BUF1S $PINS O=FE_PHN1047_c_buf_r_1_15 I=c_buf_r[1][15]
XFE_PHC1037_c_in_i_1_16 DELB $PINS O=FE_PHN1037_c_in_i_1_16 I=c_in_i_1[16]
XFE_PHC1035_c_buf_r_0_16 DELA $PINS O=c_buf_r[0][16] I=FE_PHN1035_c_buf_r_0_16
XFE_PHC956_pe_r3_10 DELC $PINS O=FE_PHN956_pe_r3_10 I=pe_r3[10]
XFE_PHC953_pe_r3_12 DELC $PINS O=FE_PHN953_pe_r3_12 I=pe_r3[12]
XFE_PHC944_pe_r1_2 DELC $PINS O=FE_PHN944_pe_r1_2 I=pe_r1[2]
XFE_PHC943_c_buf_r_1_16 BUF1S $PINS O=c_buf_r[1][16] I=FE_PHN943_c_buf_r_1_16
XFE_PHC929_pe_done_d1 DELC $PINS O=FE_PHN929_pe_done_d1 I=pe_done_d1
XFE_PHC813_pe_r3_2 DELC $PINS O=FE_PHN813_pe_r3_2 I=pe_r3[2]
XFE_PHC812_pe_r3_1 DELC $PINS O=FE_PHN812_pe_r3_1 I=pe_r3[1]
XFE_PHC810_pe_r3_3 DELC $PINS O=FE_PHN810_pe_r3_3 I=pe_r3[3]
XFE_PHC809_pe_r3_7 DELC $PINS O=FE_PHN809_pe_r3_7 I=pe_r3[7]
XFE_PHC808_pe_r3_4 DELC $PINS O=FE_PHN808_pe_r3_4 I=pe_r3[4]
XFE_PHC807_pe_i1_12 DELC $PINS O=FE_PHN807_pe_i1_12 I=pe_i1[12]
XFE_PHC806_pe_r3_9 DELC $PINS O=FE_PHN806_pe_r3_9 I=pe_r3[9]
XFE_PHC805_pe_i1_4 DELC $PINS O=FE_PHN805_pe_i1_4 I=pe_i1[4]
XFE_PHC804_pe_r3_0 DELC $PINS O=FE_PHN804_pe_r3_0 I=pe_r3[0]
XFE_PHC803_pe_i1_10 DELC $PINS O=FE_PHN803_pe_i1_10 I=pe_i1[10]
XFE_PHC801_pe_i1_11 DELC $PINS O=FE_PHN801_pe_i1_11 I=pe_i1[11]
XFE_PHC800_pe_r3_5 DELC $PINS O=FE_PHN800_pe_r3_5 I=pe_r3[5]
XFE_PHC799_pe_r3_8 DELC $PINS O=FE_PHN799_pe_r3_8 I=pe_r3[8]
XFE_PHC798_pe_i1_3 DELC $PINS O=FE_PHN798_pe_i1_3 I=pe_i1[3]
XFE_PHC797_pe_i1_16 DELC $PINS O=FE_PHN797_pe_i1_16 I=pe_i1[16]
XFE_PHC796_pe_r0_10 DELC $PINS O=FE_PHN796_pe_r0_10 I=pe_r0[10]
XFE_PHC795_pe_i1_15 DELC $PINS O=FE_PHN795_pe_i1_15 I=pe_i1[15]
XFE_PHC794_pe_i0_0 DELC $PINS O=FE_PHN794_pe_i0_0 I=pe_i0[0]
XFE_PHC793_pe_r3_6 DELC $PINS O=FE_PHN793_pe_r3_6 I=pe_r3[6]
XFE_PHC792_pe_i0_9 DELC $PINS O=FE_PHN792_pe_i0_9 I=pe_i0[9]
XFE_PHC791_pe_i1_13 DELC $PINS O=FE_PHN791_pe_i1_13 I=pe_i1[13]
XFE_PHC790_pe_i1_9 DELC $PINS O=FE_PHN790_pe_i1_9 I=pe_i1[9]
XFE_PHC789_pe_i1_6 DELC $PINS O=FE_PHN789_pe_i1_6 I=pe_i1[6]
XFE_PHC788_pe_r2_2 DELC $PINS O=FE_PHN788_pe_r2_2 I=pe_r2[2]
XFE_PHC787_pe_i1_8 DELC $PINS O=FE_PHN787_pe_i1_8 I=pe_i1[8]
XFE_PHC786_pe_i1_14 DELC $PINS O=FE_PHN786_pe_i1_14 I=pe_i1[14]
XFE_PHC785_pe_i1_2 DELC $PINS O=FE_PHN785_pe_i1_2 I=pe_i1[2]
XFE_PHC784_pe_r0_14 DELC $PINS O=FE_PHN784_pe_r0_14 I=pe_r0[14]
XFE_PHC783_pe_r0_13 DELC $PINS O=FE_PHN783_pe_r0_13 I=pe_r0[13]
XFE_PHC782_pe_r2_3 DELC $PINS O=FE_PHN782_pe_r2_3 I=pe_r2[3]
XFE_PHC781_pe_r0_5 DELC $PINS O=FE_PHN781_pe_r0_5 I=pe_r0[5]
XFE_PHC780_pe_i1_7 DELC $PINS O=FE_PHN780_pe_i1_7 I=pe_i1[7]
XFE_PHC779_pe_r2_1 DELC $PINS O=FE_PHN779_pe_r2_1 I=pe_r2[1]
XFE_PHC778_pe_r0_16 DELC $PINS O=FE_PHN778_pe_r0_16 I=pe_r0[16]
XFE_PHC777_pe_r0_1 DELC $PINS O=FE_PHN777_pe_r0_1 I=pe_r0[1]
XFE_PHC776_pe_i1_1 DELC $PINS O=FE_PHN776_pe_i1_1 I=pe_i1[1]
XFE_PHC773_pe_r1_13 DELC $PINS O=FE_PHN773_pe_r1_13 I=pe_r1[13]
XFE_PHC772_pe_r0_2 DELC $PINS O=FE_PHN772_pe_r0_2 I=pe_r0[2]
XFE_PHC771_pe_r1_14 DELC $PINS O=FE_PHN771_pe_r1_14 I=pe_r1[14]
XFE_PHC769_pe_r0_6 DELC $PINS O=FE_PHN769_pe_r0_6 I=pe_r0[6]
XFE_PHC768_pe_r2_0 DELC $PINS O=FE_PHN768_pe_r2_0 I=pe_r2[0]
XFE_PHC767_pe_i0_4 DELC $PINS O=FE_PHN767_pe_i0_4 I=pe_i0[4]
XFE_PHC766_pe_i0_8 DELC $PINS O=FE_PHN766_pe_i0_8 I=pe_i0[8]
XFE_PHC765_pe_i0_12 DELC $PINS O=FE_PHN765_pe_i0_12 I=pe_i0[12]
XFE_PHC764_pe_r0_4 DELC $PINS O=FE_PHN764_pe_r0_4 I=pe_r0[4]
XFE_PHC763_pe_i0_14 DELC $PINS O=FE_PHN763_pe_i0_14 I=pe_i0[14]
XFE_PHC762_pe_r0_7 DELC $PINS O=FE_PHN762_pe_r0_7 I=pe_r0[7]
XFE_PHC761_pe_r2_5 DELC $PINS O=FE_PHN761_pe_r2_5 I=pe_r2[5]
XFE_PHC760_pe_i0_3 DELC $PINS O=FE_PHN760_pe_i0_3 I=pe_i0[3]
XFE_PHC759_pe_i0_16 DELC $PINS O=FE_PHN759_pe_i0_16 I=pe_i0[16]
XFE_PHC758_pe_r0_3 DELC $PINS O=FE_PHN758_pe_r0_3 I=pe_r0[3]
XFE_PHC756_pe_i0_15 DELC $PINS O=FE_PHN756_pe_i0_15 I=pe_i0[15]
XFE_PHC755_pe_r0_8 DELC $PINS O=FE_PHN755_pe_r0_8 I=pe_r0[8]
XFE_PHC754_pe_i0_2 DELC $PINS O=FE_PHN754_pe_i0_2 I=pe_i0[2]
XFE_PHC753_pe_i0_13 DELC $PINS O=FE_PHN753_pe_i0_13 I=pe_i0[13]
XFE_PHC752_pe_i3_2 DELC $PINS O=FE_PHN752_pe_i3_2 I=pe_i3[2]
XFE_PHC751_pe_i0_6 DELC $PINS O=FE_PHN751_pe_i0_6 I=pe_i0[6]
XFE_PHC749_pe_i0_11 DELC $PINS O=FE_PHN749_pe_i0_11 I=pe_i0[11]
XFE_PHC748_pe_r2_7 DELC $PINS O=FE_PHN748_pe_r2_7 I=pe_r2[7]
XFE_PHC747_pe_i0_7 DELC $PINS O=FE_PHN747_pe_i0_7 I=pe_i0[7]
XFE_PHC745_pe_i0_5 DELC $PINS O=FE_PHN745_pe_i0_5 I=pe_i0[5]
XFE_PHC742_pe_i3_4 DELC $PINS O=FE_PHN742_pe_i3_4 I=pe_i3[4]
XFE_PHC740_pe_r2_4 DELC $PINS O=FE_PHN740_pe_r2_4 I=pe_r2[4]
XFE_PHC738_pe_i3_9 DELC $PINS O=FE_PHN738_pe_i3_9 I=pe_i3[9]
XFE_PHC737_g_cnt_d1_0 DELC $PINS O=FE_PHN737_g_cnt_d1_0 I=g_cnt_d1[0]
XFE_PHC736_g_cnt_d2_2 DELC $PINS O=FE_PHN736_g_cnt_d2_2 I=g_cnt_d2[2]
XFE_PHC735_g_cnt_d1_1 DELC $PINS O=FE_PHN735_g_cnt_d1_1 I=g_cnt_d1[1]
XFE_PHC734_g_cnt_d2_0 DELC $PINS O=g_cnt_d2[0] I=FE_PHN734_g_cnt_d2_0
XFE_PHC733_g_cnt_d1_2 DELC $PINS O=FE_PHN733_g_cnt_d1_2 I=g_cnt_d1[2]
XFE_PHC732_g_cnt_d2_1 DELC $PINS O=FE_PHN732_g_cnt_d2_1 I=g_cnt_d2[1]
XFE_PHC730_pe_r2_6 DELC $PINS O=FE_PHN730_pe_r2_6 I=pe_r2[6]
XFE_PHC729_pe_r2_8 DELC $PINS O=FE_PHN729_pe_r2_8 I=pe_r2[8]
XFE_PHC726_pe_i2_0 DELC $PINS O=FE_PHN726_pe_i2_0 I=pe_i2[0]
XFE_PHC725_pe_i2_1 DELC $PINS O=FE_PHN725_pe_i2_1 I=pe_i2[1]
XFE_PHC724_pe_i2_2 DELC $PINS O=FE_PHN724_pe_i2_2 I=pe_i2[2]
XFE_PHC722_pe_i2_9 DELC $PINS O=FE_PHN722_pe_i2_9 I=pe_i2[9]
XFE_PHC716_pe_i2_7 DELC $PINS O=FE_PHN716_pe_i2_7 I=pe_i2[7]
XFE_RC_1721_0 INV1S $PINS O=FE_RN_452_0 I=rf_d_rdata_1[22]
XFE_RC_1720_0 INV1S $PINS O=FE_RN_453_0 I=FE_OFN284_n239
XFE_RC_1719_0 MXL2HS $PINS OB=mac_in_imag[5] S=FE_RN_453_0 A=FE_RN_452_0 B=n420
XCTS_cpc_drv_INV_CLK_G0_L7_112 INV12CK $PINS O=CTS_182 I=CTS_183
XCTS_cpc_drv_INV_CLK_G0_L6_4 INV12CK $PINS O=CTS_183 I=CTS_171
XCTS_ccl_a_INV_CLK_G0_L9_22 INV12CK $PINS O=CTS_174 I=CTS_175
XCTS_ccl_a_INV_CLK_G0_L8_111 INV12CK $PINS O=CTS_175 I=CTS_176
XCTS_ccl_a_INV_CLK_G0_L9_19 INV12CK $PINS O=CTS_172 I=CTS_173
XCTS_ccl_a_INV_CLK_G0_L8_110 INV8CK $PINS O=CTS_173 I=CTS_176
XCTS_ccl_a_INV_CLK_G0_L7_113 INV8CK $PINS O=CTS_176 I=CTS_177
XCTS_cdb_INV_CLK_G0_L6_5 INV4CK $PINS O=CTS_177 I=CTS_178
XCTS_cdb_INV_CLK_G0_L5_12 INV6CK $PINS O=CTS_178 I=CTS_179
XCTS_ccl_a_INV_CLK_G0_L5_11 INV12CK $PINS O=CTS_171 I=CTS_179
XCTS_ccl_a_INV_CLK_G1_L8_88 INV6CK $PINS O=CTS_167 I=CTS_168
XCTS_ccl_a_INV_CLK_G1_L7_90 INV3CK $PINS O=CTS_168 I=CTS_169
XCTS_ccl_a_INV_CLK_G1_L8_87 INV8CK $PINS O=CTS_164 I=CTS_165
XCTS_ccl_a_INV_CLK_G1_L7_89 INV3CK $PINS O=CTS_165 I=CTS_166
XCTS_ccl_a_INV_CLK_G1_L8_86 INV6CK $PINS O=CTS_161 I=CTS_162
XCTS_ccl_a_INV_CLK_G1_L7_88 INV2CK $PINS O=CTS_162 I=CTS_163
XCTS_ccl_a_INV_CLK_G1_L8_85 INV6CK $PINS O=CTS_158 I=CTS_159
XCTS_ccl_a_INV_CLK_G1_L7_87 INV2CK $PINS O=CTS_159 I=CTS_160
XCTS_ccl_a_INV_CLK_G1_L8_84 INV6CK $PINS O=CTS_155 I=CTS_156
XCTS_ccl_a_INV_CLK_G1_L7_86 INV3CK $PINS O=CTS_156 I=CTS_157
XCTS_ccl_a_INV_CLK_G1_L8_83 INV6CK $PINS O=CTS_152 I=CTS_153
XCTS_ccl_a_INV_CLK_G1_L7_85 INV3CK $PINS O=CTS_153 I=CTS_154
XCTS_ccl_a_INV_CLK_G1_L8_82 INV4CK $PINS O=CTS_149 I=CTS_150
XCTS_ccl_a_INV_CLK_G1_L7_84 INV2CK $PINS O=CTS_150 I=CTS_151
XCTS_ccl_a_INV_CLK_G0_L5_9 INV8CK $PINS O=CTS_170 I=CTS_179
XCTS_ccl_a_INV_CLK_G0_L4_5 INV12CK $PINS O=CTS_179 I=CTS_180
XCTS_ccl_a_INV_CLK_G0_L3_3 INV12CK $PINS O=CTS_180 I=CTS_181
XCTS_ccl_a_INV_CLK_G0_L3_2 INV12CK $PINS O=CTS_148 I=CTS_181
XCTS_ccl_a_INV_CLK_G0_L7_44 INV2CK $PINS O=CTS_143 I=CTS_144
XCTS_ccl_a_INV_CLK_G0_L6_3 INV4CK $PINS O=CTS_144 I=CTS_145
XCTS_ccl_a_INV_CLK_G0_L5_4 INV12CK $PINS O=CTS_145 I=CTS_146
XCTS_ccl_a_INV_CLK_G0_L9_1 INV12CK $PINS O=CTS_138 I=CTS_139
XCTS_ccl_a_INV_CLK_G0_L8_35 INV12CK $PINS O=CTS_139 I=CTS_140
XCTS_cdb_INV_CLK_G0_L7_36 INV4CK $PINS O=CTS_140 I=CTS_141
XCTS_cdb_INV_CLK_G0_L6_2 INV6CK $PINS O=CTS_141 I=CTS_142
XCTS_cdb_INV_CLK_G0_L6_1 INV2CK $PINS O=CTS_137 I=CTS_142
XCTS_ccl_a_INV_CLK_G0_L5_3 INV6CK $PINS O=CTS_142 I=CTS_146
XCTS_ccl_a_INV_CLK_G0_L4_2 INV8CK $PINS O=CTS_146 I=CTS_147
XCTS_ccl_a_INV_CLK_G0_L5_1 INV12CK $PINS O=CTS_135 I=CTS_136
XCTS_ccl_a_INV_CLK_G0_L4_1 INV12CK $PINS O=CTS_136 I=CTS_147
XCTS_ccl_a_INV_CLK_G0_L3_1 INV12CK $PINS O=CTS_147 I=CTS_181
XCTS_ccl_INV_CLK_G0_L2_1 INV12CK $PINS O=CTS_181 I=clk
XFE_RC_1481_0 AO22P $PINS O=mac_in_real[3] A1=n337 A2=rf_d_rdata_1[3] B1=n348
+ B2=mac_in_real_s1[3]
XFE_RC_1126_0 INV3 $PINS O=n289 I=FE_RN_186_0
XFE_RC_1125_0 AN3 $PINS O=FE_RN_186_0 I1=n449 I2=state_r[0] I3=n314
XFE_RC_933_0 INV1S $PINS O=FE_RN_123_0 I=rf_d_rdata_1[21]
XFE_RC_932_0 INV4 $PINS O=FE_RN_124_0 I=FE_OFN285_n239
XFE_RC_931_0 MXL2HP $PINS OB=mac_in_imag[4] S=FE_RN_124_0 A=FE_RN_123_0 B=n421
XFE_OFC601_mac_in_imag_s1_4 INV2 $PINS O=n421 I=mac_in_imag_s1[4]
XFE_OFC468_n239 BUF3 $PINS O=FE_OFN285_n239 I=n239
XFE_OFC467_n239 BUF12CK $PINS O=FE_OFN284_n239 I=n239
XFE_OFC436_FE_DBTN10_n289 BUF1 $PINS O=FE_OFN253_FE_DBTN10_n289
+ I=FE_OFN252_FE_DBTN10_n289
XFE_OFC435_FE_DBTN10_n289 BUF1 $PINS O=FE_OFN252_FE_DBTN10_n289
+ I=FE_DBTN10_n289
XFE_OFC381_mac_in_imag_s1_7 INV1S $PINS O=n418 I=mac_in_imag_s1[7]
XFE_OFC376_mac_in_imag_s1_16 INV1S $PINS O=n415 I=mac_in_imag_s1_16
XFE_OFC360_mac_in_imag_s1_8 INV1S $PINS O=n417 I=mac_in_imag_s1[8]
XFE_OFC349_mac_in_imag_s1_1 INV2 $PINS O=n424 I=mac_in_imag_s1[1]
XFE_OFC314_mac_in_imag_s1_5 INV2 $PINS O=n420 I=mac_in_imag_s1[5]
XFE_OFC307_mac_in_imag_s1_2 INV2 $PINS O=n423 I=mac_in_imag_s1[2]
XFE_OFC302_mac_in_imag_s1_6 INV1S $PINS O=n419 I=mac_in_imag_s1[6]
XFE_OFC292_mac_in_imag_s1_0 INV2 $PINS O=n425 I=mac_in_imag_s1[0]
XFE_OFC174_current_n_1 INV1S $PINS O=FE_OFN146_current_n_1
+ I=FE_DBTN5_current_n_1
XFE_OFC173_current_n_1 INV2 $PINS O=FE_DBTN5_current_n_1 I=current_n[1]
XFE_OFC136_n253 INV2 $PINS O=FE_OFN125_n253 I=n253
XFE_OFC135_n253 INV1S $PINS O=FE_OFN124_n253 I=n253
XFE_OFC134_n253 BUF1 $PINS O=FE_DBTN11_n253 I=n253
XFE_OFC133_n253 BUF1 $PINS O=FE_OFN17_n253 I=n253
XFE_OFC32_i_rst_n BUF2CK $PINS O=FE_OFN32_n I=FE_OFN31_n
XFE_OFC31_i_rst_n BUF2CK $PINS O=FE_OFN31_n I=FE_OFN30_n
XFE_OFC30_i_rst_n BUF3 $PINS O=FE_OFN30_n I=FE_OFN1_i_rst_n
XFE_OFC12_i_rst_n INV3 $PINS O=FE_OFN12_i_rst_n I=FE_OFN11_i_rst_n
XFE_OFC11_i_rst_n INV1S $PINS O=FE_OFN11_i_rst_n I=FE_OFN6_i_rst_n
XFE_OFC9_i_rst_n BUF2 $PINS O=FE_OFN9_i_rst_n I=FE_OFN4_i_rst_n
XFE_OFC8_i_rst_n BUF1 $PINS O=FE_OFN8_i_rst_n I=FE_OFN30_n
XFE_OFC7_i_rst_n BUF1 $PINS O=FE_OFN7_i_rst_n I=FE_OFN32_n
XFE_OFC6_i_rst_n BUF1 $PINS O=FE_OFN6_i_rst_n I=FE_OFN31_n
XFE_OFC5_i_rst_n INV4 $PINS O=FE_OFN5_i_rst_n I=FE_OFN0_i_rst_n
XFE_OFC4_i_rst_n INV4 $PINS O=FE_OFN4_i_rst_n I=FE_OFN0_i_rst_n
XFE_OFC3_i_rst_n INV4 $PINS O=FE_OFN3_i_rst_n I=FE_OFN0_i_rst_n
XFE_OFC2_i_rst_n INV3 $PINS O=FE_OFN2_i_rst_n I=FE_OFN0_i_rst_n
XFE_OFC1_i_rst_n INV3 $PINS O=FE_OFN1_i_rst_n I=FE_OFN0_i_rst_n
XFE_OFC0_i_rst_n INV2 $PINS O=FE_OFN0_i_rst_n I=rst_n
XFE_DBTC12_current_n_0 INV1S $PINS O=FE_DBTN12_current_n_0 I=current_n[0]
XFE_DBTC10_n289 INV3 $PINS O=FE_DBTN10_n289 I=n289
XFE_DBTC9_n291 INV2 $PINS O=FE_DBTN9_n291 I=n291
XFE_DBTC8_phase_1_8 INV1S $PINS O=FE_DBTN8_phase_1_8 I=phase_1[8]
XFE_DBTC7_phase_0_9 INV1S $PINS O=FE_DBTN7_phase_0_9 I=phase_0[9]
XFE_DBTC6_current_g_0 INV1S $PINS O=FE_DBTN6_current_g_0 I=current_g[0]
XFE_DBTC4_current_g_1 INV1S $PINS O=FE_DBTN4_current_g_1 I=current_g[1]
XFE_DBTC3_current_g_2 INV1S $PINS O=FE_DBTN3_current_g_2
+ I=FE_PHN1263_current_g_2
XFE_DBTC2_c_group_idx_2 INV1S $PINS O=FE_DBTN2_c_group_idx_2 I=c_group_idx[2]
XFE_DBTC1_c_group_idx_1 INV1S $PINS O=FE_DBTN1_c_group_idx_1 I=c_group_idx[1]
XFE_DBTC0_c_group_idx_0 INV1S $PINS O=FE_DBTN0_c_group_idx_0 I=c_group_idx[0]
XU280 ND2 $PINS O=n132 I1=delayed_out3[9] I2=n431
XU281 ND2 $PINS O=n130 I1=pe_r1[9] I2=n133
XU282 ND2 $PINS O=n135 I1=delayed_out3[8] I2=n431
XU283 ND2 $PINS O=n134 I1=pe_r1[8] I2=n133
XU284 ND2 $PINS O=n137 I1=delayed_out3[7] I2=n431
XU285 ND2 $PINS O=n136 I1=FE_PHN1194_pe_r1_7 I2=n133
XU286 ND2 $PINS O=n139 I1=delayed_out3[6] I2=n431
XU287 ND2 $PINS O=n138 I1=pe_r1[6] I2=n133
XU288 ND2 $PINS O=n141 I1=delayed_out3[5] I2=n431
XU289 ND2 $PINS O=n140 I1=pe_r1[5] I2=n133
XU290 ND2 $PINS O=n143 I1=delayed_out3[4] I2=n431
XU291 ND2 $PINS O=n142 I1=FE_PHN1189_pe_r1_4 I2=n133
XU292 ND2 $PINS O=n145 I1=delayed_out3[3] I2=n431
XU293 ND2 $PINS O=n144 I1=pe_r1[3] I2=n133
XU294 ND2 $PINS O=n147 I1=delayed_out3[2] I2=n431
XU295 ND2 $PINS O=n146 I1=pe_r1[2] I2=n133
XU296 AO222 $PINS O=rf_io_wdata_2[21] A1=pe_i1[10] A2=n148 B1=n149 B2=N278
+ C1=delayed_out3[21] C2=n431
XU297 ND2 $PINS O=n153 I1=delayed_out3[20] I2=n431
XU298 ND2 $PINS O=n151 I1=pe_i1[9] I2=n148
XU299 ND2 $PINS O=n155 I1=delayed_out3[1] I2=n431
XU300 ND2 $PINS O=n154 I1=pe_r1[1] I2=n133
XU301 ND2 $PINS O=n157 I1=delayed_out3[19] I2=n431
XU302 ND2 $PINS O=n156 I1=pe_i1[8] I2=n148
XU303 ND2 $PINS O=n159 I1=delayed_out3[18] I2=n431
XU304 ND2 $PINS O=n158 I1=pe_i1[7] I2=n148
XU305 ND2 $PINS O=n161 I1=delayed_out3[17] I2=n431
XU306 ND2 $PINS O=n160 I1=pe_i1[6] I2=n148
XU307 ND2 $PINS O=n163 I1=delayed_out3[16] I2=n431
XU308 ND2 $PINS O=n162 I1=FE_PHN1205_pe_i1_5 I2=n148
XU309 ND2 $PINS O=n165 I1=delayed_out3[15] I2=n431
XU310 ND2 $PINS O=n164 I1=pe_i1[4] I2=n148
XU311 ND2 $PINS O=n167 I1=delayed_out3[14] I2=n431
XU312 ND2 $PINS O=n166 I1=pe_i1[3] I2=n148
XU313 ND2 $PINS O=n169 I1=delayed_out3[13] I2=n431
XU314 ND2 $PINS O=n168 I1=pe_i1[2] I2=n148
XU315 ND2 $PINS O=n171 I1=delayed_out3[12] I2=n431
XU316 ND2 $PINS O=n170 I1=pe_i1[1] I2=n148
XU317 ND2 $PINS O=n173 I1=delayed_out3[11] I2=n431
XU319 ND2 $PINS O=n172 I1=FE_PHN1199_pe_i1_0 I2=n148
XU320 AO222 $PINS O=rf_io_wdata_2[10] A1=FE_PHN1254_pe_r1_10 A2=n133 B1=n174
+ B2=N293 C1=delayed_out3[10] C2=n431
XU321 ND2 $PINS O=n176 I1=delayed_out3[0] I2=n431
XU323 ND2 $PINS O=n175 I1=FE_PHN1181_pe_r1_0 I2=n133
XU324 ND2 $PINS O=n177 I1=pe_r0[9] I2=n180
XU325 ND2 $PINS O=n181 I1=pe_r0[8] I2=n180
XU326 ND2 $PINS O=n183 I1=pe_r0[7] I2=n180
XU327 ND2 $PINS O=n185 I1=pe_r0[6] I2=n180
XU328 ND2 $PINS O=n187 I1=pe_r0[5] I2=n180
XU329 ND2 $PINS O=n189 I1=pe_r0[4] I2=n180
XU330 ND2 $PINS O=n191 I1=pe_r0[3] I2=n180
XU331 ND2 $PINS O=n193 I1=pe_r0[2] I2=n180
XU333 ND2 $PINS O=n195 I1=FE_PHN1201_pe_i0_10 I2=n198
XU334 ND2 $PINS O=n199 I1=pe_i0[9] I2=n198
XU335 ND2 $PINS O=n202 I1=pe_r0[1] I2=n180
XU336 ND2 $PINS O=n204 I1=pe_i0[8] I2=n198
XU337 ND2 $PINS O=n206 I1=pe_i0[7] I2=n198
XU338 ND2 $PINS O=n208 I1=pe_i0[6] I2=n198
XU339 ND2 $PINS O=n210 I1=pe_i0[5] I2=n198
XU340 ND2 $PINS O=n212 I1=pe_i0[4] I2=n198
XU341 ND2 $PINS O=n214 I1=pe_i0[3] I2=n198
XU342 ND2 $PINS O=n216 I1=pe_i0[2] I2=n198
XU343 ND2 $PINS O=n218 I1=FE_PHN1198_pe_i0_1 I2=n198
XU345 ND2 $PINS O=n220 I1=pe_i0[0] I2=n198
XU347 ND2 $PINS O=n222 I1=pe_r0[10] I2=n180
XU349 ND2 $PINS O=n225 I1=FE_PHN1197_pe_r0_0 I2=n180
XU351 AO12 $PINS O=rf_io_waddr_1[3] A1=rf_io_waddr_2[3] B1=current_n[3]
+ B2=FE_DBTN9_n291
XU352 AO22 $PINS O=rf_io_waddr_2[3] A1=n433 A2=g_cnt_d3[1] B1=n431
+ B2=delayed_mac_group[1]
XU355 AO12 $PINS O=rf_io_waddr_1[1] A1=n431 B1=FE_DBTN9_n291
+ B2=FE_OFN146_current_n_1
XU357 ND2 $PINS O=n229 I1=n230 I2=n442
XU359 AO12 $PINS O=FE_PHN1277_n281 A1=n426 B1=c_state[1] B2=n235
XU360 OA112 $PINS O=n243 A1=FE_OFN285_n239 B1=n244 C1=n434 C2=n289
XU361 ND2 $PINS O=n285 I1=n234 I2=n244
XU362 ND2 $PINS O=n244 I1=n249 I2=n230
XU373 AO12 $PINS O=mac_in_real[16] A1=n250 B1=rf_d_rdata_1[16]
+ B2=FE_OFN284_n239
XU374 AO12 $PINS O=mac_in_real[15] A1=n250 B1=rf_d_rdata_1[15]
+ B2=FE_OFN285_n239
XU375 AO12 $PINS O=mac_in_real[14] A1=n250 B1=rf_d_rdata_1[14]
+ B2=FE_OFN285_n239
XU376 AO12 $PINS O=mac_in_real[13] A1=n250 B1=rf_d_rdata_1[13]
+ B2=FE_OFN285_n239
XU377 AO12 $PINS O=mac_in_real[12] A1=n250 B1=rf_d_rdata_1[12]
+ B2=FE_OFN285_n239
XU379 AO12 $PINS O=mac_in_real[10] A1=n250 B1=rf_d_rdata_1[10]
+ B2=FE_OFN285_n239
XU381 AO12 $PINS O=mac_in_imag[16] A1=n251 B1=rf_d_rdata_1[33]
+ B2=FE_OFN285_n239
XU382 AO12 $PINS O=mac_in_imag[15] A1=n251 B1=rf_d_rdata_1[32]
+ B2=FE_OFN285_n239
XU384 AO12 $PINS O=mac_in_imag[13] A1=n251 B1=rf_d_rdata_1[30]
+ B2=FE_OFN285_n239
XU386 AO12 $PINS O=mac_in_imag[11] A1=n251 B1=rf_d_rdata_1[28]
+ B2=FE_OFN284_n239
XU387 AO12 $PINS O=mac_in_imag[10] A1=n251 B1=rf_d_rdata_1[27]
+ B2=FE_OFN285_n239
XU398 AO22 $PINS O=c_in_r_1[8] A1=c_buf_r[1][8] A2=n253 B1=c_buf_r[3][8]
+ B2=FE_OFN125_n253
XU399 AO22 $PINS O=FE_PHN1208_c_in_r_1_7 A1=c_buf_r[1][7] A2=n253
+ B1=c_buf_r[3][7] B2=FE_OFN125_n253
XU400 AO22 $PINS O=c_in_r_1[6] A1=c_buf_r[1][6] A2=n253 B1=c_buf_r[3][6]
+ B2=FE_OFN125_n253
XU401 AO22 $PINS O=c_in_r_1[5] A1=c_buf_r[1][5] A2=n253 B1=c_buf_r[3][5]
+ B2=FE_OFN125_n253
XU402 AO22 $PINS O=c_in_r_1[4] A1=c_buf_r[1][4] A2=n253 B1=c_buf_r[3][4]
+ B2=FE_OFN125_n253
XU403 AO22 $PINS O=c_in_r_1[3] A1=c_buf_r[1][3] A2=n253
+ B1=FE_PHN1521_c_buf_r_3_3 B2=FE_OFN125_n253
XU404 AO22 $PINS O=c_in_r_1[2] A1=c_buf_r[1][2] A2=n253 B1=c_buf_r[3][2]
+ B2=FE_OFN125_n253
XU405 AO22 $PINS O=c_in_r_1[1] A1=c_buf_r[1][1] A2=n253 B1=c_buf_r[3][1]
+ B2=FE_OFN125_n253
XU406 AO22 $PINS O=c_in_r_1[16] A1=c_buf_r[1][16] A2=FE_OFN17_n253
+ B1=c_buf_r[3][16] B2=FE_OFN125_n253
XU407 AO22 $PINS O=c_in_r_1[15] A1=FE_PHN1047_c_buf_r_1_15 A2=FE_OFN17_n253
+ B1=c_buf_r[3][15] B2=FE_OFN125_n253
XU408 AO22 $PINS O=c_in_r_1[14] A1=c_buf_r[1][14] A2=FE_OFN17_n253
+ B1=c_buf_r[3][14] B2=FE_OFN125_n253
XU409 AO22 $PINS O=c_in_r_1[13] A1=c_buf_r[1][13] A2=FE_OFN17_n253
+ B1=c_buf_r[3][13] B2=FE_OFN125_n253
XU410 AO22 $PINS O=c_in_r_1[12] A1=FE_PHN1089_c_buf_r_1_12 A2=FE_OFN17_n253
+ B1=c_buf_r[3][12] B2=FE_OFN125_n253
XU411 AO22 $PINS O=c_in_r_1[11] A1=c_buf_r[1][11] A2=FE_OFN17_n253
+ B1=c_buf_r[3][11] B2=FE_OFN125_n253
XU412 AO22 $PINS O=c_in_r_1[10] A1=c_buf_r[1][10] A2=FE_OFN17_n253
+ B1=c_buf_r[3][10] B2=FE_OFN125_n253
XU413 AO22 $PINS O=c_in_r_1[0] A1=c_buf_r[1][0] A2=n253 B1=c_buf_r[3][0]
+ B2=FE_OFN125_n253
XU414 AO22 $PINS O=c_in_r_0[9] A1=c_buf_r[0][9] A2=FE_DBTN11_n253
+ B1=c_buf_r[2][9] B2=FE_OFN124_n253
XU415 AO22 $PINS O=FE_PHN1460_c_in_r_0_8 A1=c_buf_r[0][8] A2=FE_DBTN11_n253
+ B1=c_buf_r[2][8] B2=FE_OFN124_n253
XU416 AO22 $PINS O=FE_PHN1459_c_in_r_0_7 A1=c_buf_r[0][7] A2=FE_DBTN11_n253
+ B1=c_buf_r[2][7] B2=FE_OFN124_n253
XU417 AO22 $PINS O=c_in_r_0[6] A1=c_buf_r[0][6] A2=FE_DBTN11_n253
+ B1=c_buf_r[2][6] B2=FE_OFN124_n253
XU418 AO22 $PINS O=FE_PHN1461_c_in_r_0_5 A1=c_buf_r[0][5] A2=FE_DBTN11_n253
+ B1=FE_PHN1138_c_buf_r_2_5 B2=FE_OFN124_n253
XU419 AO22 $PINS O=c_in_r_0[4] A1=c_buf_r[0][4] A2=FE_DBTN11_n253
+ B1=c_buf_r[2][4] B2=FE_OFN124_n253
XU420 AO22 $PINS O=c_in_r_0[3] A1=c_buf_r[0][3] A2=FE_DBTN11_n253
+ B1=c_buf_r[2][3] B2=FE_OFN124_n253
XU421 AO22 $PINS O=c_in_r_0[2] A1=c_buf_r[0][2] A2=FE_DBTN11_n253
+ B1=c_buf_r[2][2] B2=FE_OFN124_n253
XU422 AO22 $PINS O=c_in_r_0[1] A1=c_buf_r[0][1] A2=FE_DBTN11_n253
+ B1=c_buf_r[2][1] B2=FE_OFN124_n253
XU423 AO22 $PINS O=FE_PHN1430_c_in_r_0_16 A1=c_buf_r[0][16] A2=FE_DBTN11_n253
+ B1=c_buf_r[2][16] B2=FE_OFN124_n253
XU424 AO22 $PINS O=c_in_r_0[15] A1=c_buf_r[0][15] A2=FE_DBTN11_n253
+ B1=c_buf_r[2][15] B2=FE_OFN124_n253
XU425 AO22 $PINS O=c_in_r_0[14] A1=c_buf_r[0][14] A2=FE_DBTN11_n253
+ B1=c_buf_r[2][14] B2=FE_OFN124_n253
XU426 AO22 $PINS O=c_in_r_0[13] A1=FE_PHN1118_c_buf_r_0_13 A2=FE_DBTN11_n253
+ B1=c_buf_r[2][13] B2=FE_OFN124_n253
XU427 AO22 $PINS O=c_in_r_0[12] A1=c_buf_r[0][12] A2=FE_DBTN11_n253
+ B1=c_buf_r[2][12] B2=FE_OFN124_n253
XU428 AO22 $PINS O=FE_PHN1175_c_in_r_0_11 A1=c_buf_r[0][11] A2=FE_DBTN11_n253
+ B1=c_buf_r[2][11] B2=FE_OFN124_n253
XU429 AO22 $PINS O=FE_PHN1466_c_in_r_0_10 A1=FE_PHN1140_c_buf_r_0_10
+ A2=FE_DBTN11_n253 B1=c_buf_r[2][10] B2=FE_OFN124_n253
XU430 AO22 $PINS O=FE_PHN1458_c_in_r_0_0 A1=c_buf_r[0][0] A2=FE_DBTN11_n253
+ B1=c_buf_r[2][0] B2=FE_OFN124_n253
XU431 AO22 $PINS O=c_in_i_1[9] A1=FE_PHN1117_c_buf_i_1_9 A2=n253
+ B1=c_buf_i[3][9] B2=FE_OFN125_n253
XU432 AO22 $PINS O=c_in_i_1[8] A1=FE_PHN1132_c_buf_i_1_8 A2=n253
+ B1=c_buf_i[3][8] B2=FE_OFN125_n253
XU433 AO22 $PINS O=c_in_i_1[7] A1=c_buf_i[1][7] A2=n253 B1=c_buf_i[3][7]
+ B2=FE_OFN125_n253
XU434 AO22 $PINS O=c_in_i_1[6] A1=c_buf_i[1][6] A2=n253 B1=c_buf_i[3][6]
+ B2=FE_OFN125_n253
XU435 AO22 $PINS O=c_in_i_1[5] A1=c_buf_i[1][5] A2=n253 B1=c_buf_i[3][5]
+ B2=FE_OFN125_n253
XU450 AO22 $PINS O=c_in_i_0[7] A1=c_buf_i[0][7] A2=FE_DBTN11_n253
+ B1=c_buf_i[2][7] B2=FE_OFN124_n253
XU465 ND2 $PINS O=N63 I1=n236 I2=n237
XU467 AN3B2S $PINS O=N438 I1=N445 B1=mac_en B2=FE_DBTN9_n291
XU468 ND2P $PINS O=mac_en I1=FE_OFN284_n239 I2=n289
XU469 AN2B1S $PINS O=N445 I1=n230 B1=n240
XU471 ND2 $PINS O=n150 I1=mac_valid_out_r I2=FE_OFN252_FE_DBTN10_n289
XU472 AO12 $PINS O=N154 A1=N141 B1=FE_PHN806_pe_r3_9 B2=n273
XU473 AO12 $PINS O=N153 A1=N141 B1=FE_PHN799_pe_r3_8 B2=n273
XU474 AO12 $PINS O=N152 A1=N141 B1=FE_PHN809_pe_r3_7 B2=n273
XU475 AO12 $PINS O=N151 A1=N141 B1=FE_PHN793_pe_r3_6 B2=n273
XU476 AO12 $PINS O=N150 A1=N141 B1=FE_PHN800_pe_r3_5 B2=n273
XU477 AO12 $PINS O=N149 A1=N141 B1=FE_PHN808_pe_r3_4 B2=n273
XU478 AO12 $PINS O=N148 A1=N141 B1=FE_PHN810_pe_r3_3 B2=n273
XU479 AO12 $PINS O=N147 A1=N141 B1=FE_PHN813_pe_r3_2 B2=n273
XU480 AO12 $PINS O=N146 A1=N141 B1=FE_PHN812_pe_r3_1 B2=n273
XU481 AO12 $PINS O=N145 A1=N141 B1=FE_PHN804_pe_r3_0 B2=n273
XU482 AO12 $PINS O=N139 A1=N126 B1=FE_PHN738_pe_i3_9 B2=n274
XU483 AO12 $PINS O=N138 A1=N126 B1=pe_i3[8] B2=n274
XU484 AO12 $PINS O=N137 A1=N126 B1=pe_i3[7] B2=n274
XU485 AO12 $PINS O=N136 A1=N126 B1=pe_i3[6] B2=n274
XU486 AO12 $PINS O=N135 A1=N126 B1=pe_i3[5] B2=n274
XU487 AO12 $PINS O=N134 A1=N126 B1=FE_PHN742_pe_i3_4 B2=n274
XU488 AO12 $PINS O=N133 A1=N126 B1=pe_i3[3] B2=n274
XU489 AO12 $PINS O=N132 A1=N126 B1=FE_PHN752_pe_i3_2 B2=n274
XU490 AO12 $PINS O=N131 A1=N126 B1=pe_i3[1] B2=n274
XU491 AO12 $PINS O=N130 A1=N126 B1=pe_i3[0] B2=n274
XU492 AO12 $PINS O=N124 A1=N111 B1=pe_r2[9] B2=n275
XU493 AO12 $PINS O=N123 A1=N111 B1=FE_PHN729_pe_r2_8 B2=n275
XU494 AO12 $PINS O=N122 A1=N111 B1=FE_PHN748_pe_r2_7 B2=n275
XU495 AO12 $PINS O=N121 A1=N111 B1=FE_PHN730_pe_r2_6 B2=n275
XU496 AO12 $PINS O=N120 A1=N111 B1=FE_PHN761_pe_r2_5 B2=n275
XU497 AO12 $PINS O=N119 A1=N111 B1=FE_PHN740_pe_r2_4 B2=n275
XU498 AO12 $PINS O=N118 A1=N111 B1=FE_PHN782_pe_r2_3 B2=n275
XU499 AO12 $PINS O=N117 A1=N111 B1=FE_PHN788_pe_r2_2 B2=n275
XU500 AO12 $PINS O=N116 A1=N111 B1=FE_PHN779_pe_r2_1 B2=n275
XU501 AO12 $PINS O=N115 A1=N111 B1=FE_PHN768_pe_r2_0 B2=n275
XU502 AO12 $PINS O=N109 A1=N96 B1=FE_PHN722_pe_i2_9 B2=n276
XU503 AO12 $PINS O=N108 A1=N96 B1=pe_i2[8] B2=n276
XU504 AO12 $PINS O=N107 A1=N96 B1=FE_PHN716_pe_i2_7 B2=n276
XU505 AO12 $PINS O=N106 A1=N96 B1=pe_i2[6] B2=n276
XU506 AO12 $PINS O=N105 A1=N96 B1=pe_i2[5] B2=n276
XU507 AO12 $PINS O=N104 A1=N96 B1=pe_i2[4] B2=n276
XU508 AO12 $PINS O=N103 A1=N96 B1=pe_i2[3] B2=n276
XU509 AO12 $PINS O=N102 A1=N96 B1=FE_PHN724_pe_i2_2 B2=n276
XU510 AO12 $PINS O=N101 A1=N96 B1=FE_PHN725_pe_i2_1 B2=n276
XU511 AO12 $PINS O=N100 A1=N96 B1=FE_PHN726_pe_i2_0 B2=n276
Xr175/U1_1_1 HA1 $PINS S=N392 C=r175/carry[2] A=FE_PHN1222_o_counter_r_1
+ B=FE_PHN1229_o_counter_r_0
Xr175/U1_1_2 HA1 $PINS S=N393 C=r175/carry[3] A=o_counter_r[2] B=r175/carry[2]
Xr175/U1_1_3 HA1 $PINS S=N394 C=r175/carry[4] A=o_counter_r[3] B=r175/carry[3]
Xr175/U1_1_4 HA1 $PINS S=N395 C=r175/carry[5] A=o_counter_r[4] B=r175/carry[4]
Xpe_done_d1_reg QDFFRBN $PINS Q=pe_done_d1 D=N48 CK=CTS_172 RB=FE_OFN7_i_rst_n
Xdelayed_out3_reg[21] QDFFN $PINS Q=delayed_out3[21] D=N140 CK=CTS_149
Xdelayed_out3_reg[10] QDFFN $PINS Q=delayed_out3[10] D=FE_PHN1362_N155
+ CK=CTS_149
Xdelayed_out3_reg[15] QDFFN $PINS Q=delayed_out3[15] D=N134 CK=CTS_149
Xdelayed_out3_reg[14] QDFFN $PINS Q=delayed_out3[14] D=N133 CK=CTS_149
Xdelayed_out3_reg[13] QDFFN $PINS Q=delayed_out3[13] D=N132 CK=CTS_149
Xdelayed_out3_reg[12] QDFFN $PINS Q=delayed_out3[12] D=N131 CK=CTS_149
Xdelayed_out3_reg[11] QDFFN $PINS Q=delayed_out3[11] D=N130 CK=CTS_149
Xdelayed_out3_reg[0] QDFFN $PINS Q=delayed_out3[0] D=N145 CK=CTS_149
Xdelayed_out3_reg[20] QDFFN $PINS Q=delayed_out3[20] D=N139 CK=CTS_149
Xdelayed_out3_reg[19] QDFFN $PINS Q=delayed_out3[19] D=N138 CK=CTS_149
Xdelayed_out3_reg[18] QDFFN $PINS Q=delayed_out3[18] D=N137 CK=CTS_149
Xdelayed_out3_reg[17] QDFFN $PINS Q=delayed_out3[17] D=N136 CK=CTS_149
Xdelayed_out3_reg[16] QDFFN $PINS Q=delayed_out3[16] D=N135 CK=CTS_149
Xdelayed_out3_reg[9] QDFFN $PINS Q=delayed_out3[9] D=N154 CK=CTS_149
Xdelayed_out3_reg[8] QDFFN $PINS Q=delayed_out3[8] D=N153 CK=CTS_149
Xdelayed_out3_reg[7] QDFFN $PINS Q=delayed_out3[7] D=N152 CK=CTS_149
Xdelayed_out3_reg[6] QDFFN $PINS Q=delayed_out3[6] D=N151 CK=CTS_149
Xdelayed_out3_reg[5] QDFFN $PINS Q=delayed_out3[5] D=N150 CK=CTS_149
Xdelayed_out3_reg[4] QDFFN $PINS Q=delayed_out3[4] D=N149 CK=CTS_149
Xdelayed_out3_reg[3] QDFFN $PINS Q=delayed_out3[3] D=N148 CK=CTS_149
Xdelayed_out3_reg[2] QDFFN $PINS Q=delayed_out3[2] D=N147 CK=CTS_149
Xdelayed_out3_reg[1] QDFFN $PINS Q=delayed_out3[1] D=N146 CK=CTS_149
Xdelayed_out2_reg[0] QDFFN $PINS Q=delayed_out2[0] D=FE_PHN1335_N115 CK=CTS_149
Xdelayed_out2_reg[20] QDFFN $PINS Q=delayed_out2[20] D=N109 CK=CTS_152
Xdelayed_out2_reg[19] QDFFN $PINS Q=delayed_out2[19] D=N108 CK=CTS_152
Xdelayed_out2_reg[18] QDFFN $PINS Q=delayed_out2[18] D=N107 CK=CTS_152
Xdelayed_out2_reg[17] QDFFN $PINS Q=delayed_out2[17] D=N106 CK=CTS_152
Xdelayed_out2_reg[16] QDFFN $PINS Q=delayed_out2[16] D=N105 CK=CTS_152
Xdelayed_out2_reg[15] QDFFN $PINS Q=delayed_out2[15] D=N104 CK=CTS_152
Xdelayed_out2_reg[14] QDFFN $PINS Q=delayed_out2[14] D=N103 CK=CTS_152
Xdelayed_out2_reg[13] QDFFN $PINS Q=delayed_out2[13] D=N102 CK=CTS_152
Xdelayed_out2_reg[12] QDFFN $PINS Q=delayed_out2[12] D=N101 CK=CTS_152
Xdelayed_out2_reg[11] QDFFN $PINS Q=delayed_out2[11] D=N100 CK=CTS_152
Xdelayed_out2_reg[21] QDFFN $PINS Q=delayed_out2[21] D=N110 CK=CTS_152
Xdelayed_out2_reg[9] QDFFN $PINS Q=delayed_out2[9] D=N124 CK=CTS_152
Xdelayed_out2_reg[8] QDFFN $PINS Q=delayed_out2[8] D=N123 CK=CTS_152
Xdelayed_out2_reg[7] QDFFN $PINS Q=delayed_out2[7] D=N122 CK=CTS_152
Xdelayed_out2_reg[6] QDFFN $PINS Q=delayed_out2[6] D=N121 CK=CTS_152
Xdelayed_out2_reg[5] QDFFN $PINS Q=delayed_out2[5] D=FE_PHN1334_N120 CK=CTS_152
Xdelayed_out2_reg[4] QDFFN $PINS Q=delayed_out2[4] D=FE_PHN1317_N119 CK=CTS_152
Xdelayed_out2_reg[3] QDFFN $PINS Q=delayed_out2[3] D=FE_PHN1344_N118 CK=CTS_152
Xdelayed_out2_reg[2] QDFFN $PINS Q=delayed_out2[2] D=FE_PHN1351_N117 CK=CTS_152
Xdelayed_out2_reg[1] QDFFN $PINS Q=delayed_out2[1] D=FE_PHN1342_N116 CK=CTS_152
Xdelayed_out2_reg[10] QDFFN $PINS Q=delayed_out2[10] D=N125 CK=CTS_152
Xc_buf_i_reg[3][16] QDFFN $PINS Q=c_buf_i[3][16] D=FE_PHN1094_pe_i3_16
+ CK=CTS_164
Xc_buf_r_reg[3][16] QDFFN $PINS Q=c_buf_r[3][16] D=FE_PHN1154_pe_r3_16
+ CK=CTS_155
Xc_buf_i_reg[2][16] QDFFN $PINS Q=c_buf_i[2][16] D=pe_i2[16] CK=CTS_164
Xc_buf_r_reg[2][16] QDFFN $PINS Q=c_buf_r[2][16] D=pe_r2[16] CK=CTS_158
Xc_buf_i_reg[1][16] QDFFN $PINS Q=c_buf_i[1][16] D=FE_PHN797_pe_i1_16
+ CK=CTS_167
Xc_buf_r_reg[1][16] QDFFN $PINS Q=FE_PHN943_c_buf_r_1_16 D=FE_PHN1250_pe_r1_16
+ CK=CTS_158
Xc_buf_i_reg[0][16] QDFFN $PINS Q=c_buf_i[0][16] D=FE_PHN759_pe_i0_16
+ CK=CTS_167
Xc_buf_r_reg[0][16] QDFFN $PINS Q=FE_PHN1035_c_buf_r_0_16 D=FE_PHN778_pe_r0_16
+ CK=CTS_161
Xc_buf_i_reg[3][15] QDFFN $PINS Q=c_buf_i[3][15] D=FE_PHN1126_pe_i3_15
+ CK=CTS_164
Xc_buf_r_reg[3][15] QDFFN $PINS Q=FE_PHN1062_c_buf_r_3_15 D=FE_PHN1207_pe_r3_15
+ CK=CTS_155
Xc_buf_i_reg[2][15] QDFFN $PINS Q=c_buf_i[2][15] D=FE_PHN1184_pe_i2_15
+ CK=CTS_164
Xc_buf_r_reg[2][15] QDFFN $PINS Q=c_buf_r[2][15] D=FE_PHN1121_pe_r2_15
+ CK=CTS_158
Xc_buf_i_reg[1][15] QDFFN $PINS Q=c_buf_i[1][15] D=FE_PHN795_pe_i1_15
+ CK=CTS_167
Xc_buf_r_reg[1][15] QDFFN $PINS Q=c_buf_r[1][15] D=pe_r1[15] CK=CTS_158
Xc_buf_i_reg[0][15] QDFFN $PINS Q=c_buf_i[0][15] D=FE_PHN756_pe_i0_15
+ CK=CTS_167
Xc_buf_r_reg[0][15] QDFFN $PINS Q=c_buf_r[0][15] D=FE_PHN1240_pe_r0_15
+ CK=CTS_161
Xcounter_r_reg[8] QDFFRBN $PINS Q=counter_r[8] D=counter_w[8] CK=net1694
+ RB=FE_OFN6_i_rst_n
Xc_buf_i_reg[3][14] QDFFN $PINS Q=c_buf_i[3][14] D=FE_PHN1122_pe_i3_14
+ CK=CTS_164
Xc_buf_r_reg[3][14] QDFFN $PINS Q=c_buf_r[3][14] D=FE_PHN1202_pe_r3_14
+ CK=CTS_155
Xc_buf_i_reg[2][14] QDFFN $PINS Q=c_buf_i[2][14] D=pe_i2[14] CK=CTS_164
Xc_buf_r_reg[2][14] QDFFN $PINS Q=FE_PHN1090_c_buf_r_2_14 D=FE_PHN1116_pe_r2_14
+ CK=CTS_158
Xc_buf_i_reg[1][14] QDFFN $PINS Q=c_buf_i[1][14] D=FE_PHN786_pe_i1_14
+ CK=CTS_167
Xc_buf_r_reg[1][14] QDFFN $PINS Q=c_buf_r[1][14] D=FE_PHN771_pe_r1_14
+ CK=CTS_158
Xc_buf_i_reg[0][14] QDFFN $PINS Q=c_buf_i[0][14] D=FE_PHN763_pe_i0_14
+ CK=CTS_167
Xc_buf_r_reg[0][14] QDFFN $PINS Q=FE_PHN1102_c_buf_r_0_14 D=FE_PHN784_pe_r0_14
+ CK=CTS_161
Xc_buf_i_reg[3][13] QDFFN $PINS Q=c_buf_i[3][13] D=FE_PHN1185_pe_i3_13
+ CK=CTS_164
Xc_buf_r_reg[3][13] QDFFN $PINS Q=c_buf_r[3][13] D=FE_PHN1135_pe_r3_13
+ CK=CTS_155
Xc_buf_i_reg[2][13] QDFFN $PINS Q=c_buf_i[2][13] D=FE_PHN1110_pe_i2_13
+ CK=CTS_164
Xc_buf_r_reg[2][13] QDFFN $PINS Q=FE_PHN1100_c_buf_r_2_13 D=FE_PHN1114_pe_r2_13
+ CK=CTS_158
Xc_buf_i_reg[1][13] QDFFN $PINS Q=c_buf_i[1][13] D=FE_PHN791_pe_i1_13
+ CK=CTS_167
Xc_buf_r_reg[1][13] QDFFN $PINS Q=c_buf_r[1][13] D=FE_PHN773_pe_r1_13
+ CK=CTS_158
Xc_buf_i_reg[0][13] QDFFN $PINS Q=c_buf_i[0][13] D=FE_PHN753_pe_i0_13
+ CK=CTS_167
Xc_buf_r_reg[0][13] QDFFN $PINS Q=c_buf_r[0][13] D=FE_PHN783_pe_r0_13
+ CK=CTS_161
Xc_buf_i_reg[3][12] QDFFN $PINS Q=c_buf_i[3][12] D=FE_PHN1131_pe_i3_12
+ CK=CTS_161
Xc_buf_r_reg[3][12] QDFFN $PINS Q=FE_PHN1103_c_buf_r_3_12 D=FE_PHN953_pe_r3_12
+ CK=CTS_155
Xc_buf_i_reg[2][12] QDFFN $PINS Q=c_buf_i[2][12] D=pe_i2[12] CK=CTS_164
Xc_buf_r_reg[2][12] QDFFN $PINS Q=c_buf_r[2][12] D=FE_PHN1158_pe_r2_12
+ CK=CTS_158
Xc_buf_i_reg[1][12] QDFFN $PINS Q=c_buf_i[1][12] D=FE_PHN807_pe_i1_12
+ CK=CTS_167
Xc_buf_r_reg[1][12] QDFFN $PINS Q=c_buf_r[1][12] D=pe_r1[12] CK=CTS_158
Xc_buf_i_reg[0][12] QDFFN $PINS Q=c_buf_i[0][12] D=FE_PHN765_pe_i0_12
+ CK=CTS_167
Xc_buf_r_reg[0][12] QDFFN $PINS Q=c_buf_r[0][12] D=FE_PHN1241_pe_r0_12
+ CK=CTS_161
Xc_buf_i_reg[3][11] QDFFN $PINS Q=c_buf_i[3][11] D=pe_i3[11] CK=CTS_161
Xc_buf_r_reg[3][11] QDFFN $PINS Q=c_buf_r[3][11] D=FE_PHN1137_pe_r3_11
+ CK=CTS_155
Xc_buf_i_reg[2][11] QDFFN $PINS Q=c_buf_i[2][11] D=FE_PHN1155_pe_i2_11
+ CK=CTS_164
Xc_buf_r_reg[2][11] QDFFN $PINS Q=c_buf_r[2][11] D=FE_PHN1120_pe_r2_11
+ CK=CTS_158
Xc_buf_i_reg[1][11] QDFFN $PINS Q=c_buf_i[1][11] D=FE_PHN801_pe_i1_11
+ CK=CTS_167
Xc_buf_r_reg[1][11] QDFFN $PINS Q=c_buf_r[1][11] D=pe_r1[11] CK=CTS_158
Xc_buf_i_reg[0][11] QDFFN $PINS Q=c_buf_i[0][11] D=FE_PHN749_pe_i0_11
+ CK=CTS_167
Xc_buf_r_reg[0][11] QDFFN $PINS Q=c_buf_r[0][11] D=FE_PHN1239_pe_r0_11
+ CK=CTS_161
Xc_buf_i_reg[3][10] QDFFN $PINS Q=c_buf_i[3][10] D=FE_PHN1169_pe_i3_10
+ CK=CTS_161
Xc_buf_r_reg[3][10] QDFFN $PINS Q=c_buf_r[3][10] D=FE_PHN956_pe_r3_10
+ CK=CTS_155
Xc_buf_i_reg[2][10] QDFFN $PINS Q=c_buf_i[2][10] D=FE_PHN1161_pe_i2_10
+ CK=CTS_164
Xc_buf_r_reg[2][10] QDFFN $PINS Q=c_buf_r[2][10] D=FE_PHN1125_pe_r2_10
+ CK=CTS_158
Xc_buf_i_reg[1][10] QDFFN $PINS Q=c_buf_i[1][10] D=FE_PHN803_pe_i1_10
+ CK=CTS_167
Xc_buf_r_reg[1][10] QDFFN $PINS Q=c_buf_r[1][10] D=FE_PHN1254_pe_r1_10
+ CK=CTS_158
Xc_buf_i_reg[0][10] QDFFN $PINS Q=c_buf_i[0][10] D=FE_PHN1201_pe_i0_10
+ CK=CTS_167
Xc_buf_r_reg[0][10] QDFFN $PINS Q=c_buf_r[0][10] D=FE_PHN796_pe_r0_10
+ CK=CTS_161
Xc_buf_i_reg[3][9] QDFFN $PINS Q=c_buf_i[3][9] D=FE_PHN738_pe_i3_9 CK=CTS_161
Xc_buf_r_reg[3][9] QDFFN $PINS Q=c_buf_r[3][9] D=FE_PHN806_pe_r3_9 CK=CTS_155
Xc_buf_i_reg[2][9] QDFFN $PINS Q=c_buf_i[2][9] D=FE_PHN722_pe_i2_9 CK=CTS_164
Xc_buf_r_reg[2][9] QDFFN $PINS Q=c_buf_r[2][9] D=pe_r2[9] CK=CTS_155
Xc_buf_i_reg[1][9] QDFFN $PINS Q=c_buf_i[1][9] D=FE_PHN790_pe_i1_9 CK=CTS_167
Xc_buf_r_reg[1][9] QDFFN $PINS Q=c_buf_r[1][9] D=pe_r1[9] CK=CTS_158
Xc_buf_i_reg[0][9] QDFFN $PINS Q=c_buf_i[0][9] D=FE_PHN792_pe_i0_9 CK=CTS_167
Xc_buf_r_reg[0][9] QDFFN $PINS Q=c_buf_r[0][9] D=pe_r0[9] CK=CTS_161
Xc_buf_i_reg[3][8] QDFFN $PINS Q=c_buf_i[3][8] D=pe_i3[8] CK=CTS_161
Xc_buf_r_reg[3][8] QDFFN $PINS Q=c_buf_r[3][8] D=FE_PHN799_pe_r3_8 CK=CTS_155
Xc_buf_i_reg[2][8] QDFFN $PINS Q=c_buf_i[2][8] D=pe_i2[8] CK=CTS_164
Xc_buf_r_reg[2][8] QDFFN $PINS Q=c_buf_r[2][8] D=FE_PHN729_pe_r2_8 CK=CTS_155
Xc_buf_i_reg[1][8] QDFFN $PINS Q=c_buf_i[1][8] D=FE_PHN787_pe_i1_8 CK=CTS_167
Xc_buf_r_reg[1][8] QDFFN $PINS Q=c_buf_r[1][8] D=pe_r1[8] CK=CTS_158
Xc_buf_i_reg[0][8] QDFFN $PINS Q=c_buf_i[0][8] D=FE_PHN766_pe_i0_8 CK=CTS_167
Xc_buf_r_reg[0][8] QDFFN $PINS Q=FE_PHN1145_c_buf_r_0_8 D=FE_PHN755_pe_r0_8
+ CK=CTS_161
Xc_buf_i_reg[3][7] QDFFN $PINS Q=c_buf_i[3][7] D=pe_i3[7] CK=CTS_161
Xc_buf_r_reg[3][7] QDFFN $PINS Q=c_buf_r[3][7] D=FE_PHN809_pe_r3_7 CK=CTS_155
Xc_buf_i_reg[2][7] QDFFN $PINS Q=c_buf_i[2][7] D=FE_PHN716_pe_i2_7 CK=CTS_164
Xc_buf_r_reg[2][7] QDFFN $PINS Q=c_buf_r[2][7] D=FE_PHN748_pe_r2_7 CK=CTS_155
Xc_buf_i_reg[1][7] QDFFN $PINS Q=FE_PHN1130_c_buf_i_1_7 D=FE_PHN780_pe_i1_7
+ CK=CTS_167
Xc_buf_r_reg[1][7] QDFFN $PINS Q=c_buf_r[1][7] D=FE_PHN1194_pe_r1_7 CK=CTS_158
Xc_buf_i_reg[0][7] QDFFN $PINS Q=c_buf_i[0][7] D=FE_PHN747_pe_i0_7 CK=CTS_167
Xc_buf_r_reg[0][7] QDFFN $PINS Q=FE_PHN1153_c_buf_r_0_7 D=FE_PHN762_pe_r0_7
+ CK=CTS_161
Xc_buf_i_reg[3][6] QDFFN $PINS Q=c_buf_i[3][6] D=pe_i3[6] CK=CTS_161
Xc_buf_r_reg[3][6] QDFFN $PINS Q=c_buf_r[3][6] D=FE_PHN793_pe_r3_6 CK=CTS_155
Xc_buf_i_reg[2][6] QDFFN $PINS Q=c_buf_i[2][6] D=pe_i2[6] CK=CTS_164
Xc_buf_r_reg[2][6] QDFFN $PINS Q=c_buf_r[2][6] D=FE_PHN730_pe_r2_6 CK=CTS_155
Xc_buf_i_reg[1][6] QDFFN $PINS Q=c_buf_i[1][6] D=FE_PHN789_pe_i1_6 CK=CTS_167
Xc_buf_r_reg[1][6] QDFFN $PINS Q=c_buf_r[1][6] D=pe_r1[6] CK=CTS_158
Xc_buf_i_reg[0][6] QDFFN $PINS Q=c_buf_i[0][6] D=FE_PHN751_pe_i0_6 CK=CTS_167
Xc_buf_r_reg[0][6] QDFFN $PINS Q=c_buf_r[0][6] D=FE_PHN769_pe_r0_6 CK=CTS_161
Xc_buf_i_reg[3][5] QDFFN $PINS Q=c_buf_i[3][5] D=pe_i3[5] CK=CTS_161
Xc_buf_r_reg[3][5] QDFFN $PINS Q=c_buf_r[3][5] D=FE_PHN800_pe_r3_5 CK=CTS_155
Xc_buf_i_reg[2][5] QDFFN $PINS Q=c_buf_i[2][5] D=pe_i2[5] CK=CTS_164
Xc_buf_r_reg[2][5] QDFFN $PINS Q=c_buf_r[2][5] D=FE_PHN761_pe_r2_5 CK=CTS_155
Xc_buf_i_reg[1][5] QDFFN $PINS Q=c_buf_i[1][5] D=FE_PHN1205_pe_i1_5 CK=CTS_164
Xc_buf_r_reg[1][5] QDFFN $PINS Q=c_buf_r[1][5] D=pe_r1[5] CK=CTS_158
Xc_buf_i_reg[0][5] QDFFN $PINS Q=c_buf_i[0][5] D=FE_PHN745_pe_i0_5 CK=CTS_167
Xc_buf_r_reg[0][5] QDFFN $PINS Q=c_buf_r[0][5] D=FE_PHN781_pe_r0_5 CK=CTS_161
Xc_buf_i_reg[3][4] QDFFN $PINS Q=c_buf_i[3][4] D=FE_PHN742_pe_i3_4 CK=CTS_161
Xc_buf_r_reg[3][4] QDFFN $PINS Q=c_buf_r[3][4] D=FE_PHN808_pe_r3_4 CK=CTS_155
Xc_buf_i_reg[2][4] QDFFN $PINS Q=c_buf_i[2][4] D=pe_i2[4] CK=CTS_164
Xc_buf_r_reg[2][4] QDFFN $PINS Q=FE_PHN1150_c_buf_r_2_4 D=FE_PHN740_pe_r2_4
+ CK=CTS_155
Xc_buf_i_reg[1][4] QDFFN $PINS Q=c_buf_i[1][4] D=FE_PHN805_pe_i1_4 CK=CTS_164
Xc_buf_r_reg[1][4] QDFFN $PINS Q=c_buf_r[1][4] D=FE_PHN1189_pe_r1_4 CK=CTS_158
Xc_buf_i_reg[0][4] QDFFN $PINS Q=c_buf_i[0][4] D=FE_PHN767_pe_i0_4 CK=CTS_167
Xc_buf_r_reg[0][4] QDFFN $PINS Q=FE_PHN1162_c_buf_r_0_4 D=FE_PHN764_pe_r0_4
+ CK=CTS_161
Xc_buf_i_reg[3][3] QDFFN $PINS Q=c_buf_i[3][3] D=pe_i3[3] CK=CTS_161
Xc_buf_r_reg[3][3] QDFFN $PINS Q=c_buf_r[3][3] D=FE_PHN810_pe_r3_3 CK=CTS_155
Xc_buf_i_reg[2][3] QDFFN $PINS Q=c_buf_i[2][3] D=pe_i2[3] CK=CTS_164
Xc_buf_r_reg[2][3] QDFFN $PINS Q=c_buf_r[2][3] D=FE_PHN782_pe_r2_3 CK=CTS_155
Xc_buf_i_reg[1][3] QDFFN $PINS Q=c_buf_i[1][3] D=FE_PHN798_pe_i1_3 CK=CTS_164
Xc_buf_r_reg[1][3] QDFFN $PINS Q=c_buf_r[1][3] D=pe_r1[3] CK=CTS_158
Xc_buf_i_reg[0][3] QDFFN $PINS Q=FE_PHN1173_c_buf_i_0_3 D=FE_PHN760_pe_i0_3
+ CK=CTS_167
Xc_buf_r_reg[0][3] QDFFN $PINS Q=c_buf_r[0][3] D=FE_PHN758_pe_r0_3 CK=CTS_161
Xc_buf_i_reg[3][2] QDFFN $PINS Q=c_buf_i[3][2] D=FE_PHN752_pe_i3_2 CK=CTS_161
Xc_buf_r_reg[3][2] QDFFN $PINS Q=c_buf_r[3][2] D=FE_PHN813_pe_r3_2 CK=CTS_155
Xc_buf_i_reg[2][2] QDFFN $PINS Q=c_buf_i[2][2] D=FE_PHN724_pe_i2_2 CK=CTS_164
Xc_buf_r_reg[2][2] QDFFN $PINS Q=c_buf_r[2][2] D=FE_PHN788_pe_r2_2 CK=CTS_155
Xc_buf_i_reg[1][2] QDFFN $PINS Q=c_buf_i[1][2] D=FE_PHN785_pe_i1_2 CK=CTS_164
Xc_buf_r_reg[1][2] QDFFN $PINS Q=c_buf_r[1][2] D=FE_PHN944_pe_r1_2 CK=CTS_158
Xc_buf_i_reg[0][2] QDFFN $PINS Q=c_buf_i[0][2] D=FE_PHN754_pe_i0_2 CK=CTS_167
Xc_buf_r_reg[0][2] QDFFN $PINS Q=c_buf_r[0][2] D=FE_PHN772_pe_r0_2 CK=CTS_158
Xkey_r_reg[7] QDFFRBN $PINS Q=key_r[7] D=key_w[7] CK=net1689 RB=FE_OFN1_i_rst_n
Xc_buf_i_reg[3][1] QDFFN $PINS Q=c_buf_i[3][1] D=pe_i3[1] CK=CTS_161
Xc_buf_r_reg[3][1] QDFFN $PINS Q=c_buf_r[3][1] D=FE_PHN812_pe_r3_1 CK=CTS_155
Xc_buf_i_reg[2][1] QDFFN $PINS Q=c_buf_i[2][1] D=FE_PHN725_pe_i2_1 CK=CTS_164
Xc_buf_r_reg[2][1] QDFFN $PINS Q=c_buf_r[2][1] D=FE_PHN779_pe_r2_1 CK=CTS_155
Xc_buf_i_reg[1][1] QDFFN $PINS Q=c_buf_i[1][1] D=FE_PHN776_pe_i1_1 CK=CTS_164
Xc_buf_r_reg[1][1] QDFFN $PINS Q=c_buf_r[1][1] D=pe_r1[1] CK=CTS_158
Xc_buf_i_reg[0][1] QDFFN $PINS Q=c_buf_i[0][1] D=FE_PHN1198_pe_i0_1 CK=CTS_167
Xc_buf_r_reg[0][1] QDFFN $PINS Q=c_buf_r[0][1] D=FE_PHN777_pe_r0_1 CK=CTS_158
Xc_buf_i_reg[3][0] QDFFN $PINS Q=c_buf_i[3][0] D=pe_i3[0] CK=CTS_161
Xc_buf_r_reg[3][0] QDFFN $PINS Q=c_buf_r[3][0] D=FE_PHN804_pe_r3_0 CK=CTS_155
Xc_buf_i_reg[2][0] QDFFN $PINS Q=c_buf_i[2][0] D=FE_PHN726_pe_i2_0 CK=CTS_164
Xc_buf_r_reg[2][0] QDFFN $PINS Q=c_buf_r[2][0] D=FE_PHN768_pe_r2_0 CK=CTS_155
Xc_buf_i_reg[1][0] QDFFN $PINS Q=c_buf_i[1][0] D=FE_PHN1199_pe_i1_0 CK=CTS_164
Xc_buf_r_reg[1][0] QDFFN $PINS Q=c_buf_r[1][0] D=FE_PHN1181_pe_r1_0 CK=CTS_158
Xc_buf_i_reg[0][0] QDFFN $PINS Q=c_buf_i[0][0] D=FE_PHN794_pe_i0_0 CK=CTS_167
Xc_buf_r_reg[0][0] QDFFN $PINS Q=FE_PHN1144_c_buf_r_0_0 D=FE_PHN1197_pe_r0_0
+ CK=CTS_158
Xkey_r_reg[6] QDFFRBN $PINS Q=key_r[6] D=FE_PHN1271_key_w_6 CK=net1689
+ RB=FE_OFN1_i_rst_n
Xkey_r_reg[5] QDFFRBN $PINS Q=key_r[5] D=key_w[5] CK=net1689 RB=FE_OFN1_i_rst_n
Xkey_r_reg[4] QDFFRBN $PINS Q=key_r[4] D=FE_PHN1283_key_w_4 CK=net1689
+ RB=FE_OFN1_i_rst_n
Xkey_r_reg[0] QDFFRBN $PINS Q=key_r[0] D=FE_PHN1282_key_w_0 CK=net1689
+ RB=FE_OFN1_i_rst_n
Xkey_r_reg[3] QDFFRBN $PINS Q=key_r[3] D=FE_PHN1294_key_w_3 CK=net1689
+ RB=FE_OFN1_i_rst_n
Xkey_r_reg[1] QDFFRBN $PINS Q=key_r[1] D=key_w[1] CK=net1689 RB=FE_OFN1_i_rst_n
Xkey_r_reg[2] QDFFRBN $PINS Q=key_r[2] D=FE_PHN1274_key_w_2 CK=net1689
+ RB=FE_OFN1_i_rst_n
Xpe_done_d2_reg QDFFRBN $PINS Q=pe_done_d2 D=N50 CK=CTS_172 RB=FE_OFN32_n
Xc_start_reg QDFFRBN $PINS Q=c_start D=FE_PHN1054_N63 CK=CTS_174 RB=FE_OFN31_n
Xcounter_r_reg[7] QDFFRBN $PINS Q=current_g[2] D=FE_PHN1364_counter_w_7
+ CK=net1694 RB=FE_OFN6_i_rst_n
Xcounter_r_reg[5] QDFFRBN $PINS Q=FE_PHN1261_current_g_0 D=counter_w[5]
+ CK=net1694 RB=FE_OFN12_i_rst_n
Xcounter_r_reg[6] QDFFRBN $PINS Q=FE_PHN1262_current_g_1
+ D=FE_PHN1379_counter_w_6 CK=net1694 RB=FE_OFN6_i_rst_n
Xo_counter_r_reg[2] QDFFRBN $PINS Q=o_counter_r[2] D=o_counter_w[2] CK=net1684
+ RB=FE_OFN12_i_rst_n
Xo_counter_r_reg[5] QDFFRBN $PINS Q=o_counter_r[5] D=o_counter_w[5] CK=net1684
+ RB=FE_OFN12_i_rst_n
Xo_counter_r_reg[1] QDFFRBN $PINS Q=o_counter_r[1] D=o_counter_w[1] CK=net1684
+ RB=FE_OFN12_i_rst_n
Xo_counter_r_reg[4] QDFFRBN $PINS Q=o_counter_r[4] D=FE_PHN1280_o_counter_w_4
+ CK=net1684 RB=FE_OFN12_i_rst_n
Xo_state_r_reg QDFFRBN $PINS Q=o_valid D=n284 CK=CTS_172 RB=FE_OFN12_i_rst_n
Xo_counter_r_reg[3] QDFFRBN $PINS Q=o_counter_r[3] D=o_counter_w[3] CK=net1684
+ RB=FE_OFN12_i_rst_n
Xo_counter_r_reg[0] QDFFRBN $PINS Q=o_counter_r[0] D=o_counter_w[0] CK=net1684
+ RB=FE_OFN12_i_rst_n
Xcounter_r_reg[2] QDFFRBN $PINS Q=current_n[2] D=FE_PHN1414_counter_w_2
+ CK=net1694 RB=FE_OFN12_i_rst_n
Xcounter_r_reg[4] QDFFRBN $PINS Q=current_n[4] D=counter_w[4] CK=net1694
+ RB=FE_OFN12_i_rst_n
Xcounter_r_reg[3] QDFFRBN $PINS Q=current_n[3] D=FE_PHN1399_counter_w_3
+ CK=net1694 RB=FE_OFN12_i_rst_n
Xcounter_r_reg[0] QDFFRBN $PINS Q=current_n[0] D=counter_w[0] CK=net1694
+ RB=FE_OFN12_i_rst_n
Xcounter_r_reg[1] QDFFRBN $PINS Q=current_n[1] D=FE_PHN1428_counter_w_1
+ CK=net1694 RB=FE_OFN12_i_rst_n
Xdelayed_mac_group_reg[0] QDFFN $PINS Q=delayed_mac_group[0] D=g_cnt_d3[0]
+ CK=CTS_152
Xg_cnt_d3_reg[2] QDFFRBN $PINS Q=FE_PHN1257_g_cnt_d3_2 D=FE_PHN736_g_cnt_d2_2
+ CK=net1644 RB=FE_OFN6_i_rst_n
Xg_cnt_d3_reg[0] QDFFRBN $PINS Q=FE_PHN1255_g_cnt_d3_0 D=g_cnt_d2[0] CK=net1644
+ RB=FE_OFN6_i_rst_n
Xdelayed_mac_group_reg[1] QDFFN $PINS Q=delayed_mac_group[1] D=g_cnt_d3[1]
+ CK=CTS_152
Xdelayed_mac_group_reg[2] DFFN $PINS QB=n84 D=g_cnt_d3[2] CK=CTS_152
Xg_cnt_d3_reg[1] QDFFRBN $PINS Q=FE_PHN1256_g_cnt_d3_1 D=FE_PHN732_g_cnt_d2_1
+ CK=net1644 RB=FE_OFN6_i_rst_n
Xc_group_idx_reg[1] QDFFRBN $PINS Q=c_group_idx[1] D=n278 CK=CTS_174
+ RB=FE_OFN12_i_rst_n
Xc_group_idx_reg[2] QDFFRBN $PINS Q=c_group_idx[2] D=n277 CK=CTS_174
+ RB=FE_OFN31_n
Xc_group_idx_reg[0] QDFFRBN $PINS Q=c_group_idx[0] D=n279 CK=CTS_174
+ RB=FE_OFN12_i_rst_n
Xc_state_reg[1] QDFFRBN $PINS Q=c_state[1] D=n281 CK=CTS_174 RB=FE_OFN7_i_rst_n
Xc_state_reg[0] QDFFRBN $PINS Q=c_state[0] D=n280 CK=CTS_174 RB=FE_OFN31_n
Xrf_io_write_delay_reg QDFFRBN $PINS Q=rf_io_write_delay D=n433 CK=CTS_172
+ RB=FE_OFN12_i_rst_n
Xmac_valid_out_r_reg QDFFRBN $PINS Q=mac_valid_out_r D=N51 CK=CTS_138
+ RB=FE_OFN32_n
Xg_cnt_d1_reg[0] QDFFRBN $PINS Q=g_cnt_d1[0] D=current_g[0] CK=net1644
+ RB=FE_OFN12_i_rst_n
Xg_cnt_d2_reg[0] QDFFRBN $PINS Q=FE_PHN734_g_cnt_d2_0 D=FE_PHN737_g_cnt_d1_0
+ CK=net1644 RB=FE_OFN6_i_rst_n
Xg_cnt_d1_reg[1] QDFFRBN $PINS Q=g_cnt_d1[1] D=current_g[1] CK=net1644
+ RB=FE_OFN12_i_rst_n
Xg_cnt_d2_reg[1] QDFFRBN $PINS Q=g_cnt_d2[1] D=FE_PHN735_g_cnt_d1_1 CK=net1644
+ RB=FE_OFN12_i_rst_n
Xg_cnt_d1_reg[2] QDFFRBN $PINS Q=g_cnt_d1[2] D=FE_PHN1263_current_g_2
+ CK=net1644 RB=FE_OFN6_i_rst_n
Xg_cnt_d2_reg[2] QDFFRBN $PINS Q=g_cnt_d2[2] D=FE_PHN733_g_cnt_d1_2 CK=net1644
+ RB=FE_OFN6_i_rst_n
Xstate_r_reg[2] DFFRBP $PINS Q=n320 QB=n319 D=n285 CK=CTS_143 RB=FE_OFN31_n
Xpe_clear_d1_reg QDFFRBP $PINS Q=pe_clear_d1 D=N47 CK=CTS_172
+ RB=FE_OFN12_i_rst_n
Xstate_r_reg[0] QDFFRBP $PINS Q=state_r[0] D=FE_PHN1266_n282 CK=CTS_143
+ RB=FE_OFN7_i_rst_n
XU518 MOAI1H $PINS O=mac_in_imag[1] A1=n337 A2=n424 B1=n337 B2=rf_d_rdata_1[18]
XU520 INV1S $PINS O=n148 I=n286
XU521 MUX2 $PINS O=key_w[0] S=n252 A=FE_PHN1260_key_r_0 B=i_data[0]
XU522 AO22 $PINS O=rf_io_waddr_2[2] A1=g_cnt_d3[0] A2=n433
+ B1=delayed_mac_group[0] B2=n431
XU523 ND2S $PINS O=n234 I1=n434 I2=FE_OFN253_FE_DBTN10_n289
XU524 MUX2 $PINS O=key_w[4] S=n252 A=key_r[4] B=i_data[4]
XU525 OR3B2S $PINS O=n223 I1=N262 B1=n433 B2=N263
XU526 AN4B1S $PINS O=n242 I1=FE_OFN146_current_n_1 I2=current_n[0] I3=n268
+ B1=n266
XU527 MUX2 $PINS O=FE_PHN1279_key_w_5 S=n252 A=key_r[5] B=i_data[5]
XU528 AOI22S $PINS O=n205 A1=delayed_out2[19] A2=n431 B1=FE_DBTN9_n291
+ B2=i_data[19]
XU529 ND3S $PINS O=n230 I1=n448 I2=n321 I3=FE_PHN1238_n315
XU530 MUX2 $PINS O=key_w[6] S=n252 A=key_r[6] B=i_data[6]
XU531 ND2 $PINS O=n228 I1=FE_OFN252_FE_DBTN10_n289 I2=n227
XU532 NR2 $PINS O=sub_149/carry[10] I1=phase_1[8] I2=N85
XU533 NR2 $PINS O=sub_148/carry[11] I1=phase_0[9] I2=N78
XU534 OR3B2S $PINS O=n196 I1=N247 B1=n433 B2=N248
XU535 MUX2 $PINS O=FE_PHN1267_key_w_7 S=n252 A=key_r[7] B=i_data[7]
XU544 MOAI1 $PINS O=mac_in_imag[6] A1=FE_OFN285_n239 A2=n419
+ B1=rf_d_rdata_1[23] B2=FE_OFN285_n239
XU545 ND2P $PINS O=mac_in_real[5] I1=n325 I2=n326
XU549 INV2 $PINS O=n422 I=mac_in_imag_s1[3]
XU554 OR2S $PINS O=n291 I1=n256 I2=n448
XU555 INV1S $PINS O=n441 I=FE_PHN1532_o_counter_r_0
XU558 MOAI1 $PINS O=o_data[0] A1=n425 A2=n441 B1=n441 B2=mac_in_real_s1[0]
XU561 MOAI1S $PINS O=o_data[10] A1=n415 A2=n441 B1=n441 B2=mac_in_real_s1_16
XU564 MOAI1S $PINS O=o_data[1] A1=n424 A2=n441 B1=n441 B2=mac_in_real_s1[1]
XU567 MOAI1 $PINS O=o_data[2] A1=n423 A2=n441 B1=n441 B2=mac_in_real_s1[2]
XU570 MOAI1 $PINS O=o_data[3] A1=n422 A2=n441 B1=n441 B2=mac_in_real_s1[3]
XU573 MOAI1 $PINS O=o_data[4] A1=n421 A2=n441 B1=n441 B2=mac_in_real_s1[4]
XU576 MOAI1 $PINS O=o_data[5] A1=n420 A2=n441 B1=n441 B2=mac_in_real_s1[5]
XU579 MOAI1 $PINS O=o_data[6] A1=n419 A2=n441 B1=n441 B2=mac_in_real_s1[6]
XU582 MOAI1 $PINS O=o_data[7] A1=n418 A2=n441 B1=n441 B2=mac_in_real_s1[7]
XU585 MOAI1 $PINS O=o_data[8] A1=n417 A2=n441 B1=n441 B2=mac_in_real_s1[8]
XU588 MOAI1 $PINS O=o_data[9] A1=n441 A2=n416 B1=n441 B2=mac_in_real_s1[9]
XU593 ND2S $PINS O=n326 I1=mac_in_real_s1[5] I2=n348
XU594 ND2S $PINS O=n236 I1=n348 I2=mac_valid_out_r
XU595 INV1S $PINS O=n321 I=n319
XU596 ND2S $PINS O=n256 I1=n315 I2=n319
XU597 MOAI1H $PINS O=mac_in_imag[3] A1=FE_OFN284_n239 A2=n422 B1=FE_OFN284_n239
+ B2=rf_d_rdata_1[20]
XU598 MOAI1HT $PINS O=mac_in_imag[0] A1=n337 A2=n425 B1=FE_OFN284_n239
+ B2=rf_d_rdata_1[17]
XU599 AO22 $PINS O=mac_in_real[4] A1=FE_OFN284_n239 A2=rf_d_rdata_1[4]
+ B1=mac_in_real_s1[4] B2=n348
XU600 AO22P $PINS O=mac_in_real[0] A1=rf_d_rdata_1[0] A2=n337 B1=n348
+ B2=mac_in_real_s1[0]
XU601 AO12 $PINS O=mac_in_imag[14] A1=n251 B1=rf_d_rdata_1[31]
+ B2=FE_OFN285_n239
XU602 AO12 $PINS O=mac_in_imag[12] A1=n251 B1=rf_d_rdata_1[29]
+ B2=FE_OFN285_n239
XU603 AO12S $PINS O=mac_in_real[11] A1=n250 B1=rf_d_rdata_1[11]
+ B2=FE_OFN285_n239
XU604 AO22 $PINS O=mac_in_real[9] A1=rf_d_rdata_1[9] A2=FE_OFN285_n239
+ B1=mac_in_real_s1[9] B2=n348
XU605 AO22 $PINS O=mac_in_real[8] A1=rf_d_rdata_1[8] A2=FE_OFN284_n239
+ B1=mac_in_real_s1[8] B2=n348
XU606 AO22 $PINS O=mac_in_real[7] A1=rf_d_rdata_1[7] A2=FE_OFN285_n239
+ B1=mac_in_real_s1[7] B2=n348
XU607 AO22 $PINS O=mac_in_real[6] A1=rf_d_rdata_1[6] A2=FE_OFN284_n239
+ B1=mac_in_real_s1[6] B2=n348
XU608 ND2 $PINS O=n325 I1=rf_d_rdata_1[5] I2=FE_OFN285_n239
XU610 NR2 $PINS O=i_ready I1=n255 I2=n256
XU614 MOAI1S $PINS O=mac_in_imag[7] A1=n418 A2=FE_OFN285_n239
+ B1=rf_d_rdata_1[24] B2=FE_OFN285_n239
XU617 MOAI1S $PINS O=mac_in_imag[9] A1=n416 A2=FE_OFN285_n239
+ B1=rf_d_rdata_1[26] B2=FE_OFN285_n239
XU619 INV1S $PINS O=n433 I=n150
XU620 ND2S $PINS O=n329 I1=N262 I2=n433
XU624 OR3S $PINS O=n334 I1=N292 I2=N293 I3=n150
XU625 OR3S $PINS O=n335 I1=N262 I2=N263 I3=n150
XU627 AO22P $PINS O=mac_in_real[1] A1=n337 A2=rf_d_rdata_1[1] B1=n348
+ B2=mac_in_real_s1[1]
XU630 ND3 $PINS O=k_ord_1[0] I1=c_group_idx[2] I2=FE_OFN125_n253 I3=n254
XU632 AO22S $PINS O=c_in_i_1[0] A1=c_buf_i[1][0] A2=FE_OFN17_n253
+ B1=c_buf_i[3][0] B2=FE_OFN125_n253
XU633 AO22S $PINS O=c_in_i_0[0] A1=c_buf_i[0][0] A2=FE_DBTN11_n253
+ B1=c_buf_i[2][0] B2=FE_OFN124_n253
XU634 AO22S $PINS O=c_in_i_1[1] A1=c_buf_i[1][1] A2=n253 B1=c_buf_i[3][1]
+ B2=FE_OFN125_n253
XU635 AO22S $PINS O=c_in_i_0[1] A1=c_buf_i[0][1] A2=FE_DBTN11_n253
+ B1=c_buf_i[2][1] B2=FE_OFN124_n253
XU636 AO22S $PINS O=c_in_i_1[2] A1=c_buf_i[1][2] A2=n253
+ B1=FE_PHN1214_c_buf_i_3_2 B2=FE_OFN125_n253
XU637 AO22S $PINS O=c_in_i_0[2] A1=c_buf_i[0][2] A2=FE_DBTN11_n253
+ B1=c_buf_i[2][2] B2=FE_OFN124_n253
XU638 AO22S $PINS O=c_in_i_1[3] A1=c_buf_i[1][3] A2=n253 B1=c_buf_i[3][3]
+ B2=FE_OFN125_n253
XU639 AO22S $PINS O=c_in_i_0[3] A1=c_buf_i[0][3] A2=FE_DBTN11_n253
+ B1=c_buf_i[2][3] B2=FE_OFN124_n253
XU640 AO22S $PINS O=c_in_i_1[4] A1=c_buf_i[1][4] A2=n253 B1=c_buf_i[3][4]
+ B2=FE_OFN125_n253
XU641 AO22S $PINS O=FE_PHN1187_c_in_i_0_4 A1=c_buf_i[0][4] A2=FE_DBTN11_n253
+ B1=c_buf_i[2][4] B2=FE_OFN124_n253
XU642 AO22S $PINS O=c_in_i_0[5] A1=c_buf_i[0][5] A2=FE_DBTN11_n253
+ B1=c_buf_i[2][5] B2=FE_OFN124_n253
XU643 AO22S $PINS O=c_in_i_0[6] A1=c_buf_i[0][6] A2=FE_DBTN11_n253
+ B1=c_buf_i[2][6] B2=FE_OFN124_n253
XU644 AO22S $PINS O=c_in_i_0[8] A1=c_buf_i[0][8] A2=FE_DBTN11_n253
+ B1=c_buf_i[2][8] B2=FE_OFN124_n253
XU645 AO22S $PINS O=c_in_i_0[9] A1=c_buf_i[0][9] A2=FE_DBTN11_n253
+ B1=c_buf_i[2][9] B2=FE_OFN124_n253
XU646 AO22S $PINS O=c_in_r_1[9] A1=c_buf_r[1][9] A2=n253 B1=c_buf_r[3][9]
+ B2=FE_OFN125_n253
XU647 AO22S $PINS O=c_in_i_1[10] A1=c_buf_i[1][10] A2=FE_OFN17_n253
+ B1=c_buf_i[3][10] B2=FE_OFN125_n253
XU648 AO22S $PINS O=c_in_i_0[10] A1=c_buf_i[0][10] A2=FE_DBTN11_n253
+ B1=c_buf_i[2][10] B2=FE_OFN124_n253
XU649 AO22S $PINS O=c_in_i_1[11] A1=c_buf_i[1][11] A2=FE_OFN17_n253
+ B1=c_buf_i[3][11] B2=FE_OFN125_n253
XU650 AO22S $PINS O=c_in_i_0[11] A1=c_buf_i[0][11] A2=FE_DBTN11_n253
+ B1=c_buf_i[2][11] B2=FE_OFN124_n253
XU651 AO22S $PINS O=c_in_i_1[12] A1=c_buf_i[1][12] A2=FE_OFN17_n253
+ B1=c_buf_i[3][12] B2=FE_OFN125_n253
XU652 AO22S $PINS O=c_in_i_0[12] A1=c_buf_i[0][12] A2=FE_DBTN11_n253
+ B1=c_buf_i[2][12] B2=FE_OFN124_n253
XU653 AO22S $PINS O=c_in_i_1[13] A1=c_buf_i[1][13] A2=FE_OFN17_n253
+ B1=c_buf_i[3][13] B2=FE_OFN125_n253
XU654 AO22S $PINS O=c_in_i_0[13] A1=c_buf_i[0][13] A2=FE_DBTN11_n253
+ B1=c_buf_i[2][13] B2=FE_OFN124_n253
XU655 AO22S $PINS O=c_in_i_1[14] A1=c_buf_i[1][14] A2=FE_OFN17_n253
+ B1=c_buf_i[3][14] B2=FE_OFN125_n253
XU656 AO22S $PINS O=c_in_i_0[14] A1=FE_PHN1085_c_buf_i_0_14 A2=FE_DBTN11_n253
+ B1=c_buf_i[2][14] B2=FE_OFN124_n253
XU657 AO22S $PINS O=c_in_i_1[15] A1=c_buf_i[1][15] A2=FE_OFN17_n253
+ B1=c_buf_i[3][15] B2=FE_OFN125_n253
XU658 AO22S $PINS O=c_in_i_0[15] A1=c_buf_i[0][15] A2=FE_DBTN11_n253
+ B1=c_buf_i[2][15] B2=FE_OFN124_n253
XU659 AO22S $PINS O=c_in_i_1[16] A1=c_buf_i[1][16] A2=FE_OFN17_n253
+ B1=c_buf_i[3][16] B2=FE_OFN125_n253
XU660 AO22S $PINS O=c_in_i_0[16] A1=c_buf_i[0][16] A2=FE_DBTN11_n253
+ B1=c_buf_i[2][16] B2=FE_OFN124_n253
XU661 AO12S $PINS O=FE_PHN1265_n280 A1=n432 B1=c_state[0] B2=n235
XU667 INV2 $PINS O=n431 I=n228
XU668 INV1S $PINS O=n362 I=N91
XU669 NR2 $PINS O=k_ord_1[1] I1=n457 I2=n253
XU670 INV1S $PINS O=n360 I=N89
XU671 INV1S $PINS O=n361 I=N90
XU672 INV1S $PINS O=n359 I=N88
XU673 INV1S $PINS O=n358 I=N87
XU674 INV1S $PINS O=n357 I=N86
XU675 INV1S $PINS O=n356 I=N85
XU677 INV1S $PINS O=n368 I=N82
XU680 INV1S $PINS O=n367 I=N81
XU682 INV1S $PINS O=n366 I=N80
XU683 INV1S $PINS O=n365 I=N79
XU684 INV1S $PINS O=n364 I=N78
XU685 INV1S $PINS O=n439 I=n249
XU687 NR2 $PINS O=rf_io_waddr_1[0] I1=n291 I2=FE_DBTN12_current_n_0
XU688 NR2 $PINS O=n251 I1=FE_OFN285_n239 I2=n415
XU689 OR2 $PINS O=rf_io_wen_1 I1=rf_io_wen_2 I2=FE_DBTN9_n291
XU690 ND3 $PINS O=N432 I1=n271 I2=n428 I3=o_valid
XU691 ND3S $PINS O=n271 I1=FE_OFN285_n239 I2=n230 I3=n272
XU692 NR2 $PINS O=n272 I1=n252 I2=FE_DBTN9_n291
XU693 NR2 $PINS O=N157 I1=n354 I2=n150
XU694 INV1S $PINS O=n442 I=o_valid
XU695 NR2 $PINS O=N69 I1=n236 I2=n354
XU696 INV1S $PINS O=n457 I=k_ord_1[0]
XU697 NR2 $PINS O=k_ord_1[2] I1=n457 I2=FE_DBTN0_c_group_idx_0
XU698 NR2 $PINS O=k_ord_1[3] I1=n457 I2=FE_DBTN1_c_group_idx_1
XU699 INV1S $PINS O=n369 I=N83
XU700 NR2 $PINS O=k_ord_1[4] I1=n457 I2=FE_DBTN2_c_group_idx_2
XU701 NR3 $PINS O=n249 I1=n252 I2=mac_en I3=FE_DBTN9_n291
XU702 INV1S $PINS O=n430 I=n241
XU703 OA12 $PINS O=n238 A1=n243 B1=n242 B2=n291
XU704 MOAI1 $PINS O=rf_io_raddr_1[3] A1=n451 A2=n229 B1=o_valid B2=N395
XU705 MOAI1 $PINS O=rf_io_raddr_1[4] A1=n452 A2=n229 B1=N396 B2=o_valid
XU706 MOAI1S $PINS O=rf_io_raddr_1[0] A1=FE_DBTN12_current_n_0 A2=n229
+ B1=o_valid B2=N392
XU707 MOAI1S $PINS O=n283 A1=n243 A2=FE_PHN1238_n315 B1=FE_DBTN9_n291 B2=n242
XU708 AOI13HS $PINS O=n257 A1=n249 B1=FE_OFN253_FE_DBTN10_n289
+ B2=FE_PHN1170_n259 B3=n260
XU709 MOAI1S $PINS O=counter_w[7] A1=n257 A2=FE_DBTN3_current_g_2 B1=N190
+ B2=n258
XU710 MOAI1S $PINS O=counter_w[6] A1=n257 A2=FE_DBTN4_current_g_1 B1=N189
+ B2=n258
XU711 MOAI1S $PINS O=counter_w[5] A1=n257 A2=FE_DBTN6_current_g_0 B1=N188
+ B2=n258
XU712 INV1S $PINS O=n133 I=n334
XU713 MOAI1 $PINS O=rf_io_raddr_1[2] A1=n450 A2=n229 B1=o_valid B2=N394
XU714 INV1S $PINS O=n180 I=n335
XU715 INV1S $PINS O=n198 I=n336
XU716 MOAI1S $PINS O=counter_w[1] A1=FE_DBTN5_current_n_1 A2=n439 B1=N184
+ B2=n258
XU717 MOAI1S $PINS O=counter_w[4] A1=n452 A2=n439 B1=N187 B2=n258
XU718 MOAI1S $PINS O=counter_w[2] A1=n450 A2=n439 B1=N185 B2=n258
XU719 MOAI1S $PINS O=counter_w[3] A1=n451 A2=n439 B1=N186 B2=n258
XU720 MOAI1 $PINS O=rf_io_raddr_1[1] A1=FE_DBTN5_current_n_1 A2=n229 B1=o_valid
+ B2=N393
XU721 INV1S $PINS O=n438 I=n252
XU722 NR2 $PINS O=rf_d_raddr_1[4] I1=n289 I2=n452
XU723 NR2 $PINS O=rf_d_raddr_1[0] I1=n289 I2=FE_DBTN12_current_n_0
XU724 NR2 $PINS O=rf_d_raddr_1[3] I1=n289 I2=n451
XU725 NR2 $PINS O=rf_d_raddr_1[2] I1=n289 I2=n450
XU726 NR2 $PINS O=rf_d_raddr_1[1] I1=n289 I2=FE_DBTN5_current_n_1
XU727 INV1S $PINS O=n432 I=n236
XU728 AN4B1S $PINS O=FE_PHN1437_N47 I1=FE_DBTN12_current_n_0
+ I2=FE_DBTN5_current_n_1 I3=mac_en B1=n270
XU729 ND3 $PINS O=n270 I1=n451 I2=n452 I3=n450
XU730 OAI222S $PINS O=n258 A1=n242 A2=n291 B1=n241 B2=FE_OFN285_n239 C1=n289
+ C2=n261
XU731 OR2 $PINS O=n261 I1=n260 I2=n434
XU732 ND3 $PINS O=n232 I1=n234 I2=n428 I3=o_valid
XU733 MOAI1S $PINS O=FE_PHN1290_o_counter_w_5 A1=n232 A2=n447 B1=N396 B2=n233
XU734 MOAI1S $PINS O=o_counter_w[4] A1=n232 A2=n446 B1=N395 B2=n233
XU735 ND3 $PINS O=n266 I1=FE_DBTN4_current_g_1 I2=FE_DBTN3_current_g_2
+ I3=FE_DBTN6_current_g_0
XU736 NR2 $PINS O=n233 I1=n428 I2=n442
XU737 NR2 $PINS O=n275 I1=N111 I2=N112
XU738 NR2 $PINS O=n276 I1=N96 I2=N97
XU739 NR2 $PINS O=n273 I1=N141 I2=N142
XU740 NR2 $PINS O=n274 I1=N126 I2=N127
XU741 INV1S $PINS O=n434 I=FE_PHN1170_n259
XU742 NR2 $PINS O=n241 I1=n263 I2=FE_DBTN5_current_n_1
XU743 NR2 $PINS O=n248 I1=n447 I2=n446
XU747 MOAI1S $PINS O=rf_io_waddr_2[4] A1=n228 A2=n84 B1=n433 B2=g_cnt_d3[2]
XU748 MOAI1S $PINS O=mac_in_imag[8] A1=n417 A2=FE_OFN285_n239
+ B1=rf_d_rdata_1[25] B2=FE_OFN285_n239
XU749 INV1S $PINS O=n435 I=rf_io_write_delay
XU750 NR2 $PINS O=n227 I1=n435 I2=mac_valid_out_r
XU751 AN2 $PINS O=n250 I1=n348 I2=mac_in_real_s1_16
XU752 NR2T $PINS O=n253 I1=n460 I2=c_state[1]
XU753 INV1S $PINS O=n460 I=c_state[0]
XU756 INV1S $PINS O=n416 I=mac_in_imag_s1[9]
XU757 OA12S $PINS O=n240 A1=n252 B1=n427 B2=n255
XU758 INV1S $PINS O=n427 I=i_valid
XU760 NR2 $PINS O=n255 I1=N43 I2=n442
XU761 INV1S $PINS O=n354 I=FE_OFN32_n
XU762 NR2 $PINS O=n254 I1=FE_DBTN1_c_group_idx_1 I2=FE_DBTN0_c_group_idx_0
XU763 INV1S $PINS O=n428 I=o_ready
XU767 MOAI1S $PINS O=FE_PHN1304_counter_w_8 A1=n257 A2=n455 B1=N191 B2=n258
XU768 ND3 $PINS O=rf_io_wdata_1[1] I1=n202 I2=n329 I3=n203
XU769 AOI22S $PINS O=n203 A1=i_data[1] A2=FE_DBTN9_n291 B1=delayed_out2[1]
+ B2=n431
XU770 ND3 $PINS O=rf_io_wdata_1[2] I1=n193 I2=n329 I3=n194
XU771 AOI22S $PINS O=n194 A1=i_data[2] A2=FE_DBTN9_n291 B1=delayed_out2[2]
+ B2=n431
XU772 ND3 $PINS O=rf_io_wdata_1[3] I1=n191 I2=n329 I3=n192
XU773 AOI22S $PINS O=n192 A1=i_data[3] A2=FE_DBTN9_n291 B1=delayed_out2[3]
+ B2=n431
XU774 ND3 $PINS O=rf_io_wdata_1[4] I1=n189 I2=n329 I3=n190
XU775 AOI22S $PINS O=n190 A1=i_data[4] A2=FE_DBTN9_n291 B1=delayed_out2[4]
+ B2=n431
XU776 ND3 $PINS O=rf_io_wdata_1[5] I1=n187 I2=n329 I3=n188
XU777 AOI22S $PINS O=n188 A1=i_data[5] A2=FE_DBTN9_n291 B1=delayed_out2[5]
+ B2=n431
XU778 ND3 $PINS O=rf_io_wdata_1[6] I1=n185 I2=n329 I3=n186
XU779 AOI22S $PINS O=n186 A1=i_data[6] A2=FE_DBTN9_n291 B1=delayed_out2[6]
+ B2=n431
XU780 ND3 $PINS O=rf_io_wdata_1[7] I1=n183 I2=n329 I3=n184
XU781 AOI22S $PINS O=n184 A1=i_data[7] A2=FE_DBTN9_n291 B1=delayed_out2[7]
+ B2=n431
XU782 ND3 $PINS O=rf_io_wdata_1[8] I1=n181 I2=n329 I3=n182
XU783 AOI22S $PINS O=n182 A1=i_data[8] A2=FE_DBTN9_n291 B1=delayed_out2[8]
+ B2=n431
XU784 ND3 $PINS O=rf_io_wdata_1[9] I1=n177 I2=n329 I3=n179
XU785 AOI22S $PINS O=n179 A1=i_data[9] A2=FE_DBTN9_n291 B1=delayed_out2[9]
+ B2=n431
XU786 ND3 $PINS O=rf_io_wdata_1[11] I1=n220 I2=n330 I3=n221
XU787 AOI22S $PINS O=n221 A1=i_data[11] A2=FE_DBTN9_n291 B1=delayed_out2[11]
+ B2=n431
XU788 ND3 $PINS O=rf_io_wdata_1[12] I1=n218 I2=n330 I3=n219
XU789 AOI22S $PINS O=n219 A1=i_data[12] A2=FE_DBTN9_n291 B1=delayed_out2[12]
+ B2=n431
XU790 ND3 $PINS O=rf_io_wdata_1[13] I1=n216 I2=n330 I3=n217
XU791 AOI22S $PINS O=n217 A1=i_data[13] A2=FE_DBTN9_n291 B1=delayed_out2[13]
+ B2=n431
XU792 ND3 $PINS O=rf_io_wdata_1[14] I1=n214 I2=n330 I3=n215
XU793 AOI22S $PINS O=n215 A1=i_data[14] A2=FE_DBTN9_n291 B1=delayed_out2[14]
+ B2=n431
XU794 ND3 $PINS O=rf_io_wdata_1[15] I1=n212 I2=n330 I3=n213
XU795 AOI22S $PINS O=n213 A1=i_data[15] A2=FE_DBTN9_n291 B1=delayed_out2[15]
+ B2=n431
XU796 ND3 $PINS O=rf_io_wdata_1[16] I1=n210 I2=n330 I3=n211
XU797 AOI22S $PINS O=n211 A1=i_data[16] A2=FE_DBTN9_n291 B1=delayed_out2[16]
+ B2=n431
XU798 ND3 $PINS O=rf_io_wdata_1[17] I1=n208 I2=n330 I3=n209
XU799 AOI22S $PINS O=n209 A1=i_data[17] A2=FE_DBTN9_n291 B1=delayed_out2[17]
+ B2=n431
XU800 ND3 $PINS O=rf_io_wdata_1[18] I1=n206 I2=n330 I3=n207
XU801 AOI22S $PINS O=n207 A1=i_data[18] A2=FE_DBTN9_n291 B1=delayed_out2[18]
+ B2=n431
XU802 ND3 $PINS O=rf_io_wdata_1[19] I1=n204 I2=n330 I3=n205
XU803 ND3 $PINS O=rf_io_wdata_1[20] I1=n199 I2=n330 I3=n201
XU804 AOI22S $PINS O=n201 A1=i_data[20] A2=FE_DBTN9_n291 B1=delayed_out2[20]
+ B2=n431
XU805 ND3 $PINS O=rf_io_wdata_1[0] I1=n225 I2=n329 I3=n226
XU806 AOI22S $PINS O=n226 A1=i_data[0] A2=FE_DBTN9_n291 B1=delayed_out2[0]
+ B2=n431
XU807 NR2 $PINS O=n174 I1=N292 I2=n150
XU808 NR2 $PINS O=n149 I1=N277 I2=n150
XU809 ND3 $PINS O=rf_io_wdata_1[10] I1=n222 I2=n223 I3=n224
XU810 AOI22S $PINS O=n224 A1=i_data[10] A2=FE_DBTN9_n291 B1=delayed_out2[10]
+ B2=n431
XU811 ND3 $PINS O=rf_io_wdata_1[21] I1=n195 I2=n196 I3=n197
XU812 AOI22S $PINS O=n197 A1=i_data[21] A2=FE_DBTN9_n291 B1=delayed_out2[21]
+ B2=n431
XU813 ND3 $PINS O=rf_io_wdata_2[1] I1=n154 I2=n331 I3=n155
XU814 ND3 $PINS O=rf_io_wdata_2[2] I1=n146 I2=n331 I3=n147
XU815 ND3 $PINS O=rf_io_wdata_2[3] I1=n144 I2=n331 I3=n145
XU816 ND3 $PINS O=rf_io_wdata_2[4] I1=n142 I2=n331 I3=n143
XU817 ND3 $PINS O=rf_io_wdata_2[5] I1=n140 I2=n331 I3=n141
XU818 ND3 $PINS O=rf_io_wdata_2[6] I1=n138 I2=n331 I3=n139
XU819 ND3 $PINS O=rf_io_wdata_2[7] I1=n136 I2=n331 I3=n137
XU820 ND3 $PINS O=rf_io_wdata_2[8] I1=n134 I2=n331 I3=n135
XU821 ND3 $PINS O=rf_io_wdata_2[9] I1=n130 I2=n331 I3=n132
XU822 ND3 $PINS O=rf_io_wdata_2[16] I1=n162 I2=n332 I3=n163
XU823 ND3 $PINS O=rf_io_wdata_2[17] I1=n160 I2=n332 I3=n161
XU824 ND3 $PINS O=rf_io_wdata_2[18] I1=n158 I2=n332 I3=n159
XU825 ND3 $PINS O=rf_io_wdata_2[19] I1=n156 I2=n332 I3=n157
XU826 ND3 $PINS O=rf_io_wdata_2[20] I1=n151 I2=n332 I3=n153
XU827 ND3 $PINS O=rf_io_wdata_2[0] I1=n175 I2=n331 I3=n176
XU828 ND3 $PINS O=rf_io_wdata_2[11] I1=n172 I2=n332 I3=n173
XU829 ND3 $PINS O=rf_io_wdata_2[12] I1=n170 I2=n332 I3=n171
XU830 ND3 $PINS O=rf_io_wdata_2[13] I1=n168 I2=n332 I3=n169
XU831 ND3 $PINS O=rf_io_wdata_2[14] I1=n166 I2=n332 I3=n167
XU832 ND3 $PINS O=rf_io_wdata_2[15] I1=n164 I2=n332 I3=n165
XU833 MOAI1S $PINS O=counter_w[0] A1=FE_DBTN12_current_n_0 A2=n439
+ B1=FE_DBTN12_current_n_0 B2=n258
XU834 INV1S $PINS O=n452 I=FE_PHN1264_current_n_4
XU835 INV1S $PINS O=n375 I=FE_PHN1254_pe_r1_10
XU836 INV1S $PINS O=n380 I=pe_i1[10]
XU837 INV1S $PINS O=n451 I=current_n[3]
XU838 INV1S $PINS O=n450 I=current_n[2]
XU840 INV1S $PINS O=n390 I=pe_i0[10]
XU841 INV1S $PINS O=n385 I=pe_r0[10]
XU842 AOI12HS $PINS O=n235 A1=N63 B1=n460 B2=cordic_valid_out[0]
XU843 ND3 $PINS O=n237 I1=n253 I2=n236 I3=cordic_valid_out[0]
XU844 INV1S $PINS O=n426 I=n237
XU845 AN4B1S $PINS O=FE_PHN1323_N48 I1=FE_PHN1264_current_n_4 I2=mac_en
+ I3=current_n[3] B1=n269
XU846 ND3 $PINS O=n269 I1=FE_OFN146_current_n_1 I2=current_n[2] I3=current_n[0]
XU847 MOAI1S $PINS O=n279 A1=n432 A2=FE_DBTN0_c_group_idx_0 B1=n432
+ B2=g_cnt_d3[0]
XU848 MOAI1S $PINS O=n278 A1=n432 A2=FE_DBTN1_c_group_idx_1 B1=n432
+ B2=g_cnt_d3[1]
XU849 MOAI1S $PINS O=n277 A1=n432 A2=FE_DBTN2_c_group_idx_2 B1=n432
+ B2=g_cnt_d3[2]
XU850 AN2 $PINS O=N51 I1=FE_PHN1400_pe_done_d2 I2=mac_en
XU851 AN2 $PINS O=N50 I1=FE_PHN929_pe_done_d1 I2=mac_en
XU852 MOAI1S $PINS O=FE_PHN1268_o_counter_w_3 A1=n232 A2=n445 B1=N394 B2=n233
XU853 INV1S $PINS O=n445 I=o_counter_r[3]
XU854 MOAI1S $PINS O=FE_PHN1269_o_counter_w_2 A1=n232 A2=n444 B1=N393 B2=n233
XU855 INV1S $PINS O=n444 I=o_counter_r[2]
XU856 MOAI1S $PINS O=o_counter_w[1] A1=n232 A2=n443 B1=N392 B2=n233
XU857 INV1S $PINS O=n443 I=FE_PHN1222_o_counter_r_1
XU858 MOAI1S $PINS O=o_counter_w[0] A1=n441 A2=n232 B1=n441 B2=n233
XU859 AN4B1S $PINS O=n268 I1=current_n[2] I2=current_n[3] I3=n455 B1=n452
XU860 ND3 $PINS O=n263 I1=n264 I2=counter_r[8] I3=n265
XU861 NR3 $PINS O=n265 I1=current_n[2] I2=FE_PHN1264_current_n_4
+ I3=current_n[3]
XU862 NR2 $PINS O=n264 I1=current_n[0] I2=n266
XU863 NR2 $PINS O=n260 I1=n263 I2=FE_OFN146_current_n_1
XU867 XNR2HS $PINS O=FE_PHN1385_n284 I1=n245 I2=n442
XU868 OAI22S $PINS O=n245 A1=n246 A2=n247 B1=o_valid B2=n230
XU869 ND3 $PINS O=n247 I1=o_counter_r[2] I2=o_counter_r[3]
+ I3=FE_PHN1222_o_counter_r_1
XU870 ND3 $PINS O=n246 I1=FE_PHN1229_o_counter_r_0 I2=o_valid I3=n248
XU871 AOI13HS $PINS O=N111 A1=pe_r2[16] B1=n404 B2=n405 B3=n403
XU872 INV1S $PINS O=n405 I=FE_PHN1517_pe_r2_10
XU873 AOI13HS $PINS O=N96 A1=pe_i2[16] B1=n409 B2=n410 B3=n408
XU874 INV1S $PINS O=n410 I=FE_PHN1161_pe_i2_10
XU875 AOI13HS $PINS O=N141 A1=FE_PHN1154_pe_r3_16 B1=n394 B2=n395 B3=n393
XU876 INV1S $PINS O=n395 I=pe_r3[10]
XU877 AOI13HS $PINS O=N126 A1=FE_PHN1094_pe_i3_16 B1=n399 B2=n400 B3=n398
XU878 INV1S $PINS O=n400 I=FE_PHN1169_pe_i3_10
XU879 MOAI1S $PINS O=N125 A1=N111 A2=n414 B1=FE_PHN1125_pe_r2_10 B2=n275
XU880 INV1S $PINS O=n414 I=N112
XU881 MOAI1S $PINS O=N110 A1=N96 A2=n413 B1=FE_PHN1161_pe_i2_10 B2=n276
XU882 INV1S $PINS O=n413 I=N97
XU883 MOAI1S $PINS O=N155 A1=N141 A2=n412 B1=FE_PHN956_pe_r3_10 B2=n273
XU884 INV1S $PINS O=n412 I=N142
XU885 MOAI1S $PINS O=N140 A1=N126 A2=n411 B1=FE_PHN1169_pe_i3_10 B2=n274
XU886 INV1S $PINS O=n411 I=N127
XU887 INV1S $PINS O=n455 I=counter_r[8]
XU888 ND3 $PINS O=n259 I1=delayed_mac_group[0] I2=delayed_mac_group[1] I3=n262
XU889 NR2 $PINS O=n262 I1=n435 I2=n84
XU890 INV1S $PINS O=n447 I=o_counter_r[5]
XU891 INV1S $PINS O=n446 I=o_counter_r[4]
XU894 ND3HT $PINS O=n337 I1=n448 I2=n449 I3=n314
XU895 OAI222S $PINS O=n282 A1=n238 A2=n448 B1=n239 B2=n430 C1=n240 C2=n438
XU896 NR2 $PINS O=n252 I1=n256 I2=state_r[0]
XU897 XOR2HS $PINS O=phase_1[15] I1=n362 I2=sub_149/carry[15]
XU898 AN2 $PINS O=sub_149/carry[15] I1=sub_149/carry[14] I2=n361
XU899 XOR2HS $PINS O=phase_1[14] I1=n361 I2=sub_149/carry[14]
XU900 AN2 $PINS O=sub_149/carry[14] I1=sub_149/carry[13] I2=n360
XU901 XOR2HS $PINS O=phase_1[13] I1=n360 I2=sub_149/carry[13]
XU902 AN2 $PINS O=sub_149/carry[13] I1=sub_149/carry[12] I2=n359
XU903 XOR2HS $PINS O=phase_1[12] I1=n359 I2=sub_149/carry[12]
XU904 AN2 $PINS O=sub_149/carry[12] I1=sub_149/carry[11] I2=n358
XU905 XOR2HS $PINS O=phase_1[11] I1=n358 I2=sub_149/carry[11]
XU906 AN2 $PINS O=sub_149/carry[11] I1=sub_149/carry[10] I2=n357
XU907 XOR2HS $PINS O=phase_1[10] I1=n357 I2=sub_149/carry[10]
XU908 XOR2HS $PINS O=phase_1[9] I1=n356 I2=FE_DBTN8_phase_1_8
XU909 XOR2HS $PINS O=phase_0[15] I1=n369 I2=sub_148/carry[15]
XU910 AN2 $PINS O=sub_148/carry[15] I1=sub_148/carry[14] I2=n368
XU911 XOR2HS $PINS O=phase_0[14] I1=n368 I2=sub_148/carry[14]
XU912 AN2 $PINS O=sub_148/carry[14] I1=sub_148/carry[13] I2=n367
XU913 XOR2HS $PINS O=phase_0[13] I1=n367 I2=sub_148/carry[13]
XU914 AN2 $PINS O=sub_148/carry[13] I1=sub_148/carry[12] I2=n366
XU915 XOR2HS $PINS O=phase_0[12] I1=n366 I2=sub_148/carry[12]
XU916 AN2 $PINS O=sub_148/carry[12] I1=sub_148/carry[11] I2=n365
XU917 XOR2HS $PINS O=phase_0[11] I1=n365 I2=sub_148/carry[11]
XU918 XOR2HS $PINS O=phase_0[10] I1=n364 I2=FE_DBTN7_phase_0_9
XU919 XOR2HS $PINS O=N396 I1=r175/carry[5] I2=o_counter_r[5]
XU920 AN3 $PINS O=n370 I1=o_counter_r[4] I2=o_counter_r[3]
+ I3=FE_PHN1229_o_counter_r_0
XU921 AO13S $PINS O=N43 A1=o_counter_r[5] B1=o_counter_r[2]
+ B2=FE_PHN1222_o_counter_r_1 B3=n370
XU922 ND3 $PINS O=n372 I1=pe_r1[13] I2=FE_PHN1254_pe_r1_10 I3=pe_r1[14]
XU923 ND3 $PINS O=n371 I1=pe_r1[11] I2=pe_r1[15] I3=pe_r1[12]
XU924 OA12 $PINS O=N293 A1=FE_PHN1250_pe_r1_16 B1=n372 B2=n371
XU925 NR2 $PINS O=n374 I1=pe_r1[12] I2=pe_r1[11]
XU926 NR3 $PINS O=n373 I1=pe_r1[13] I2=pe_r1[15] I3=pe_r1[14]
XU927 AOI13HS $PINS O=N292 A1=FE_PHN1250_pe_r1_16 B1=n374 B2=n375 B3=n373
XU928 ND3 $PINS O=n377 I1=pe_i1[13] I2=pe_i1[10] I3=pe_i1[14]
XU929 ND3 $PINS O=n376 I1=pe_i1[11] I2=pe_i1[15] I3=pe_i1[12]
XU930 OA12 $PINS O=N278 A1=pe_i1[16] B1=n377 B2=n376
XU931 NR2 $PINS O=n379 I1=pe_i1[12] I2=pe_i1[11]
XU932 NR3 $PINS O=n378 I1=pe_i1[13] I2=pe_i1[15] I3=pe_i1[14]
XU933 AOI13HS $PINS O=N277 A1=pe_i1[16] B1=n379 B2=n380 B3=n378
XU934 ND3 $PINS O=n382 I1=pe_r0[13] I2=pe_r0[10] I3=pe_r0[14]
XU935 ND3 $PINS O=n381 I1=FE_PHN1239_pe_r0_11 I2=FE_PHN1240_pe_r0_15
+ I3=FE_PHN1241_pe_r0_12
XU936 OA12 $PINS O=N263 A1=pe_r0[16] B1=n382 B2=n381
XU937 NR2 $PINS O=n384 I1=pe_r0[12] I2=pe_r0[11]
XU938 NR3 $PINS O=n383 I1=pe_r0[13] I2=pe_r0[15] I3=pe_r0[14]
XU939 AOI13HS $PINS O=N262 A1=pe_r0[16] B1=n384 B2=n385 B3=n383
XU940 ND3 $PINS O=n387 I1=pe_i0[13] I2=pe_i0[10] I3=pe_i0[14]
XU941 ND3 $PINS O=n386 I1=pe_i0[11] I2=pe_i0[15] I3=pe_i0[12]
XU942 OA12 $PINS O=N248 A1=pe_i0[16] B1=n387 B2=n386
XU943 NR2 $PINS O=n389 I1=pe_i0[12] I2=pe_i0[11]
XU944 NR3 $PINS O=n388 I1=pe_i0[13] I2=pe_i0[15] I3=pe_i0[14]
XU945 AOI13HS $PINS O=N247 A1=pe_i0[16] B1=n389 B2=n390 B3=n388
XU946 ND3 $PINS O=n392 I1=FE_PHN1135_pe_r3_13 I2=pe_r3[10]
+ I3=FE_PHN1202_pe_r3_14
XU947 ND3 $PINS O=n391 I1=FE_PHN1137_pe_r3_11 I2=FE_PHN1207_pe_r3_15
+ I3=pe_r3[12]
XU948 OA12 $PINS O=N142 A1=FE_PHN1154_pe_r3_16 B1=n392 B2=n391
XU949 NR2 $PINS O=n394 I1=pe_r3[12] I2=pe_r3[11]
XU950 NR3 $PINS O=n393 I1=pe_r3[13] I2=FE_PHN1207_pe_r3_15
+ I3=FE_PHN1202_pe_r3_14
XU951 ND3 $PINS O=n397 I1=FE_PHN1185_pe_i3_13 I2=FE_PHN1169_pe_i3_10
+ I3=FE_PHN1122_pe_i3_14
XU952 ND3 $PINS O=n396 I1=pe_i3[11] I2=FE_PHN1126_pe_i3_15
+ I3=FE_PHN1131_pe_i3_12
XU953 OA12 $PINS O=N127 A1=FE_PHN1094_pe_i3_16 B1=n397 B2=n396
XU954 NR2 $PINS O=n399 I1=pe_i3[12] I2=pe_i3[11]
XU955 NR3 $PINS O=n398 I1=FE_PHN1185_pe_i3_13 I2=pe_i3[15] I3=pe_i3[14]
XU956 ND3 $PINS O=n402 I1=FE_PHN1114_pe_r2_13 I2=FE_PHN1125_pe_r2_10
+ I3=FE_PHN1116_pe_r2_14
XU957 ND3 $PINS O=n401 I1=FE_PHN1120_pe_r2_11 I2=FE_PHN1121_pe_r2_15
+ I3=FE_PHN1158_pe_r2_12
XU958 OA12 $PINS O=N112 A1=pe_r2[16] B1=n402 B2=n401
XU959 NR2 $PINS O=n404 I1=pe_r2[12] I2=pe_r2[11]
XU960 NR3 $PINS O=n403 I1=pe_r2[13] I2=pe_r2[15] I3=pe_r2[14]
XU961 ND3 $PINS O=n407 I1=FE_PHN1110_pe_i2_13 I2=FE_PHN1161_pe_i2_10
+ I3=pe_i2[14]
XU962 ND3 $PINS O=n406 I1=FE_PHN1155_pe_i2_11 I2=FE_PHN1184_pe_i2_15
+ I3=pe_i2[12]
XU963 OA12 $PINS O=N97 A1=pe_i2[16] B1=n407 B2=n406
XU964 NR2 $PINS O=n409 I1=pe_i2[12] I2=FE_PHN1529_pe_i2_11
XU965 NR3 $PINS O=n408 I1=pe_i2[13] I2=FE_PHN1184_pe_i2_15 I3=pe_i2[14]
Xstate_r_reg[1] DFFRBP $PINS Q=n314 QB=n315 D=n283 CK=CTS_143 RB=FE_OFN31_n
XU513 INV4 $PINS O=n449 I=n320
XU515 INV8 $PINS O=n348 I=FE_OFN284_n239
XU517 ND2S $PINS O=n331 I1=n433 I2=N292
XU519 OA12S $PINS O=rf_io_wen_2 A1=FE_OFN252_FE_DBTN10_n289 B1=mac_valid_out_r
+ B2=n227
XU537 ND2S $PINS O=n330 I1=n433 I2=N247
XU539 ND2S $PINS O=n332 I1=n433 I2=N277
XU540 MUX2 $PINS O=key_w[2] S=n252 A=key_r[2] B=i_data[2]
XU541 AO12S $PINS O=rf_io_waddr_1[2] A1=rf_io_waddr_2[2] B1=current_n[2]
+ B2=FE_DBTN9_n291
XU589 OR3S $PINS O=n336 I1=N247 I2=N248 I3=n150
XU611 MUX2 $PINS O=FE_PHN1285_key_w_1 S=n252 A=key_r[1] B=i_data[1]
XU612 AO12S $PINS O=rf_io_waddr_1[4] A1=rf_io_waddr_2[4]
+ B1=FE_PHN1264_current_n_4 B2=FE_DBTN9_n291
XU613 ND3HT $PINS O=n239 I1=n448 I2=n449 I3=n314
XU621 OR3S $PINS O=n286 I1=N277 I2=N278 I3=n150
XU622 MUX2 $PINS O=key_w[3] S=n252 A=key_r[3] B=i_data[3]
XU623 INV4 $PINS O=n448 I=state_r[0]
XU629 AO22P $PINS O=mac_in_real[2] A1=n337 A2=rf_d_rdata_1[2] B1=n348
+ B2=mac_in_real_s1[2]
XU966 MOAI1H $PINS O=mac_in_imag[2] A1=FE_OFN284_n239 A2=n423 B1=n337
+ B2=rf_d_rdata_1[19]
Xcordic0 cordic_rotation_1 $PINS rst_n=FE_UNCONNECTED_1 valid_in=c_start
+ valid_out=cordic_valid_out[0] x_in[16]=c_in_r_0[16] x_in[15]=c_in_r_0[15]
+ x_in[14]=c_in_r_0[14] x_in[13]=c_in_r_0[13] x_in[12]=c_in_r_0[12]
+ x_in[11]=c_in_r_0[11] x_in[10]=c_in_r_0[10] x_in[9]=c_in_r_0[9]
+ x_in[8]=c_in_r_0[8] x_in[7]=c_in_r_0[7] x_in[6]=c_in_r_0[6] x_in[5]=c_in_r_0[5]
+ x_in[4]=c_in_r_0[4] x_in[3]=c_in_r_0[3] x_in[2]=c_in_r_0[2] x_in[1]=c_in_r_0[1]
+ x_in[0]=c_in_r_0[0] y_in[16]=FE_PHN1096_c_in_i_0_16 y_in[15]=c_in_i_0[15]
+ y_in[14]=FE_PHN1456_c_in_i_0_14 y_in[13]=c_in_i_0[13] y_in[12]=c_in_i_0[12]
+ y_in[11]=c_in_i_0[11] y_in[10]=FE_PHN1178_c_in_i_0_10 y_in[9]=c_in_i_0[9]
+ y_in[8]=c_in_i_0[8] y_in[7]=c_in_i_0[7] y_in[6]=c_in_i_0[6] y_in[5]=c_in_i_0[5]
+ y_in[4]=c_in_i_0[4] y_in[3]=FE_PHN1468_c_in_i_0_3 y_in[2]=c_in_i_0[2]
+ y_in[1]=c_in_i_0[1] y_in[0]=c_in_i_0[0] phase_in[15]=phase_0[15]
+ phase_in[14]=phase_0[14] phase_in[13]=phase_0[13] phase_in[12]=phase_0[12]
+ phase_in[11]=phase_0[11] phase_in[10]=phase_0[10] phase_in[9]=phase_0[9]
+ phase_in[8]=n461 phase_in[7]=n461 phase_in[6]=n461 phase_in[5]=n461
+ phase_in[4]=n461 phase_in[3]=n461 phase_in[2]=n461 phase_in[1]=n461
+ phase_in[0]=n461 x_out[16]=cor_x_out[0][16] x_out[15]=cor_x_out[0][15]
+ x_out[14]=cor_x_out[0][14] x_out[13]=cor_x_out[0][13]
+ x_out[12]=cor_x_out[0][12] x_out[11]=cor_x_out[0][11]
+ x_out[10]=cor_x_out[0][10] x_out[9]=cor_x_out[0][9] x_out[8]=cor_x_out[0][8]
+ x_out[7]=cor_x_out[0][7] x_out[6]=cor_x_out[0][6] x_out[5]=cor_x_out[0][5]
+ x_out[4]=cor_x_out[0][4] x_out[3]=cor_x_out[0][3] x_out[2]=cor_x_out[0][2]
+ x_out[1]=cor_x_out[0][1] x_out[0]=cor_x_out[0][0] y_out[16]=cor_y_out[0][16]
+ y_out[15]=cor_y_out[0][15] y_out[14]=cor_y_out[0][14]
+ y_out[13]=cor_y_out[0][13] y_out[12]=cor_y_out[0][12]
+ y_out[11]=cor_y_out[0][11] y_out[10]=cor_y_out[0][10] y_out[9]=cor_y_out[0][9]
+ y_out[8]=cor_y_out[0][8] y_out[7]=cor_y_out[0][7] y_out[6]=cor_y_out[0][6]
+ y_out[5]=cor_y_out[0][5] y_out[4]=cor_y_out[0][4] y_out[3]=cor_y_out[0][3]
+ y_out[2]=cor_y_out[0][2] y_out[1]=cor_y_out[0][1] y_out[0]=cor_y_out[0][0]
+ i_rst_n=FE_OFN1_i_rst_n p1=FE_DBTN7_phase_0_9 FE_OFN24_i_rst_n=FE_OFN9_i_rst_n
+ FE_OFN6_i_rst_n=FE_OFN3_i_rst_n FE_OFN37_n=FE_OFN32_n FE_OFN33_n=FE_OFN31_n
+ clk=CTS_174 clk_clone4=CTS_142 clk_clone3=CTS_145 clk_clone2=CTS_170
+ clk_clone1=CTS_182
Xcordic1 cordic_rotation_0 $PINS valid_in=c_start valid_out=cordic_valid_out[1]
+ x_in[16]=FE_PHN1384_c_in_r_1_16 x_in[15]=c_in_r_1[15]
+ x_in[14]=FE_PHN1109_c_in_r_1_14 x_in[13]=FE_PHN1134_c_in_r_1_13
+ x_in[12]=c_in_r_1[12] x_in[11]=c_in_r_1[11] x_in[10]=c_in_r_1[10]
+ x_in[9]=FE_PHN1212_c_in_r_1_9 x_in[8]=FE_PHN1209_c_in_r_1_8 x_in[7]=c_in_r_1[7]
+ x_in[6]=FE_PHN1211_c_in_r_1_6 x_in[5]=FE_PHN1174_c_in_r_1_5
+ x_in[4]=FE_PHN1180_c_in_r_1_4 x_in[3]=FE_PHN1217_c_in_r_1_3 x_in[2]=c_in_r_1[2]
+ x_in[1]=c_in_r_1[1] x_in[0]=c_in_r_1[0] y_in[16]=FE_PHN1037_c_in_i_1_16
+ y_in[15]=FE_PHN1078_c_in_i_1_15 y_in[14]=FE_PHN1091_c_in_i_1_14
+ y_in[13]=FE_PHN1107_c_in_i_1_13 y_in[12]=FE_PHN1146_c_in_i_1_12
+ y_in[11]=FE_PHN1148_c_in_i_1_11 y_in[10]=FE_PHN1164_c_in_i_1_10
+ y_in[9]=FE_PHN1462_c_in_i_1_9 y_in[8]=FE_PHN1467_c_in_i_1_8
+ y_in[7]=FE_PHN1464_c_in_i_1_7 y_in[6]=FE_PHN1200_c_in_i_1_6 y_in[5]=c_in_i_1[5]
+ y_in[4]=c_in_i_1[4] y_in[3]=c_in_i_1[3] y_in[2]=c_in_i_1[2] y_in[1]=c_in_i_1[1]
+ y_in[0]=c_in_i_1[0] phase_in[15]=phase_1[15] phase_in[14]=phase_1[14]
+ phase_in[13]=phase_1[13] phase_in[12]=phase_1[12] phase_in[11]=phase_1[11]
+ phase_in[10]=phase_1[10] phase_in[9]=phase_1[9] phase_in[8]=phase_1[8]
+ phase_in[7]=n461 phase_in[6]=n461 phase_in[5]=n461 phase_in[4]=n461
+ phase_in[3]=n461 phase_in[2]=n461 phase_in[1]=n461 phase_in[0]=n461
+ x_out[16]=cor_x_out[1][16] x_out[15]=cor_x_out[1][15]
+ x_out[14]=cor_x_out[1][14] x_out[13]=cor_x_out[1][13]
+ x_out[12]=cor_x_out[1][12] x_out[11]=cor_x_out[1][11]
+ x_out[10]=cor_x_out[1][10] x_out[9]=cor_x_out[1][9] x_out[8]=cor_x_out[1][8]
+ x_out[7]=cor_x_out[1][7] x_out[6]=cor_x_out[1][6] x_out[5]=cor_x_out[1][5]
+ x_out[4]=cor_x_out[1][4] x_out[3]=cor_x_out[1][3] x_out[2]=cor_x_out[1][2]
+ x_out[1]=cor_x_out[1][1] x_out[0]=cor_x_out[1][0] y_out[16]=cor_y_out[1][16]
+ y_out[15]=cor_y_out[1][15] y_out[14]=cor_y_out[1][14]
+ y_out[13]=cor_y_out[1][13] y_out[12]=cor_y_out[1][12]
+ y_out[11]=cor_y_out[1][11] y_out[10]=cor_y_out[1][10] y_out[9]=cor_y_out[1][9]
+ y_out[8]=cor_y_out[1][8] y_out[7]=cor_y_out[1][7] y_out[6]=cor_y_out[1][6]
+ y_out[5]=cor_y_out[1][5] y_out[4]=cor_y_out[1][4] y_out[3]=cor_y_out[1][3]
+ y_out[2]=cor_y_out[1][2] y_out[1]=cor_y_out[1][1] y_out[0]=cor_y_out[1][0]
+ rst_n=FE_UNCONNECTED_2 i_rst_n=FE_OFN30_n p1=FE_DBTN8_phase_1_8
+ FE_OFN18_i_rst_n=FE_OFN8_i_rst_n FE_OFN2_i_rst_n=FE_OFN2_i_rst_n
+ FE_OFN32_n=FE_OFN31_n clk=CTS_174 clk_clone3=CTS_145 clk_clone2=CTS_148
+ clk_clone1=CTS_170
Xmac DFrFT_MAC $PINS rst_n=FE_UNCONNECTED_1 en=mac_en pe_clear=pe_clear_d1
+ pe_done=pe_done_d2 g_cnt[2]=FE_DBTN3_current_g_2 g_cnt[1]=FE_DBTN4_current_g_1
+ g_cnt[0]=FE_DBTN6_current_g_0 n_cnt[5]=n461 n_cnt[4]=current_n[4]
+ n_cnt[3]=current_n[3] n_cnt[2]=current_n[2] n_cnt[1]=FE_DBTN5_current_n_1
+ n_cnt[0]=FE_DBTN12_current_n_0 data_in_r[16]=mac_in_real[16]
+ data_in_r[15]=mac_in_real[15] data_in_r[14]=mac_in_real[14]
+ data_in_r[13]=mac_in_real[13] data_in_r[12]=mac_in_real[12]
+ data_in_r[11]=mac_in_real[11] data_in_r[10]=mac_in_real[10]
+ data_in_r[9]=mac_in_real[9] data_in_r[8]=mac_in_real[8]
+ data_in_r[7]=mac_in_real[7] data_in_r[6]=mac_in_real[6]
+ data_in_r[5]=mac_in_real[5] data_in_r[4]=mac_in_real[4]
+ data_in_r[3]=mac_in_real[3] data_in_r[2]=mac_in_real[2]
+ data_in_r[1]=mac_in_real[1] data_in_r[0]=mac_in_real[0]
+ data_in_i[16]=mac_in_imag[16] data_in_i[15]=mac_in_imag[15]
+ data_in_i[14]=mac_in_imag[14] data_in_i[13]=mac_in_imag[13]
+ data_in_i[12]=mac_in_imag[12] data_in_i[11]=mac_in_imag[11]
+ data_in_i[10]=mac_in_imag[10] data_in_i[9]=mac_in_imag[9]
+ data_in_i[8]=mac_in_imag[8] data_in_i[7]=mac_in_imag[7]
+ data_in_i[6]=mac_in_imag[6] data_in_i[5]=mac_in_imag[5]
+ data_in_i[4]=mac_in_imag[4] data_in_i[3]=mac_in_imag[3]
+ data_in_i[2]=mac_in_imag[2] data_in_i[1]=mac_in_imag[1]
+ data_in_i[0]=mac_in_imag[0] y_out_0_r[16]=pe_r0[16] y_out_0_r[15]=pe_r0[15]
+ y_out_0_r[14]=pe_r0[14] y_out_0_r[13]=pe_r0[13] y_out_0_r[12]=pe_r0[12]
+ y_out_0_r[11]=pe_r0[11] y_out_0_r[10]=pe_r0[10] y_out_0_r[9]=pe_r0[9]
+ y_out_0_r[8]=pe_r0[8] y_out_0_r[7]=pe_r0[7] y_out_0_r[6]=pe_r0[6]
+ y_out_0_r[5]=pe_r0[5] y_out_0_r[4]=pe_r0[4] y_out_0_r[3]=pe_r0[3]
+ y_out_0_r[2]=pe_r0[2] y_out_0_r[1]=pe_r0[1] y_out_0_r[0]=pe_r0[0]
+ y_out_0_i[16]=pe_i0[16] y_out_0_i[15]=pe_i0[15] y_out_0_i[14]=pe_i0[14]
+ y_out_0_i[13]=pe_i0[13] y_out_0_i[12]=pe_i0[12] y_out_0_i[11]=pe_i0[11]
+ y_out_0_i[10]=pe_i0[10] y_out_0_i[9]=pe_i0[9] y_out_0_i[8]=pe_i0[8]
+ y_out_0_i[7]=pe_i0[7] y_out_0_i[6]=pe_i0[6] y_out_0_i[5]=pe_i0[5]
+ y_out_0_i[4]=pe_i0[4] y_out_0_i[3]=pe_i0[3] y_out_0_i[2]=pe_i0[2]
+ y_out_0_i[1]=pe_i0[1] y_out_0_i[0]=pe_i0[0] y_out_1_r[16]=pe_r1[16]
+ y_out_1_r[15]=pe_r1[15] y_out_1_r[14]=pe_r1[14] y_out_1_r[13]=pe_r1[13]
+ y_out_1_r[12]=pe_r1[12] y_out_1_r[11]=pe_r1[11] y_out_1_r[10]=pe_r1[10]
+ y_out_1_r[9]=pe_r1[9] y_out_1_r[8]=pe_r1[8] y_out_1_r[7]=pe_r1[7]
+ y_out_1_r[6]=pe_r1[6] y_out_1_r[5]=pe_r1[5] y_out_1_r[4]=pe_r1[4]
+ y_out_1_r[3]=pe_r1[3] y_out_1_r[2]=pe_r1[2] y_out_1_r[1]=pe_r1[1]
+ y_out_1_r[0]=pe_r1[0] y_out_1_i[16]=pe_i1[16] y_out_1_i[15]=pe_i1[15]
+ y_out_1_i[14]=pe_i1[14] y_out_1_i[13]=pe_i1[13] y_out_1_i[12]=pe_i1[12]
+ y_out_1_i[11]=pe_i1[11] y_out_1_i[10]=pe_i1[10] y_out_1_i[9]=pe_i1[9]
+ y_out_1_i[8]=pe_i1[8] y_out_1_i[7]=pe_i1[7] y_out_1_i[6]=pe_i1[6]
+ y_out_1_i[5]=pe_i1[5] y_out_1_i[4]=pe_i1[4] y_out_1_i[3]=pe_i1[3]
+ y_out_1_i[2]=pe_i1[2] y_out_1_i[1]=pe_i1[1] y_out_1_i[0]=pe_i1[0]
+ y_out_2_r[16]=pe_r2[16] y_out_2_r[15]=pe_r2[15] y_out_2_r[14]=pe_r2[14]
+ y_out_2_r[13]=pe_r2[13] y_out_2_r[12]=pe_r2[12] y_out_2_r[11]=pe_r2[11]
+ y_out_2_r[10]=pe_r2[10] y_out_2_r[9]=pe_r2[9] y_out_2_r[8]=pe_r2[8]
+ y_out_2_r[7]=pe_r2[7] y_out_2_r[6]=pe_r2[6] y_out_2_r[5]=pe_r2[5]
+ y_out_2_r[4]=pe_r2[4] y_out_2_r[3]=pe_r2[3] y_out_2_r[2]=pe_r2[2]
+ y_out_2_r[1]=pe_r2[1] y_out_2_r[0]=pe_r2[0] y_out_2_i[16]=pe_i2[16]
+ y_out_2_i[15]=pe_i2[15] y_out_2_i[14]=pe_i2[14] y_out_2_i[13]=pe_i2[13]
+ y_out_2_i[12]=pe_i2[12] y_out_2_i[11]=pe_i2[11] y_out_2_i[10]=pe_i2[10]
+ y_out_2_i[9]=pe_i2[9] y_out_2_i[8]=pe_i2[8] y_out_2_i[7]=pe_i2[7]
+ y_out_2_i[6]=pe_i2[6] y_out_2_i[5]=pe_i2[5] y_out_2_i[4]=pe_i2[4]
+ y_out_2_i[3]=pe_i2[3] y_out_2_i[2]=pe_i2[2] y_out_2_i[1]=pe_i2[1]
+ y_out_2_i[0]=pe_i2[0] y_out_3_r[16]=pe_r3[16] y_out_3_r[15]=pe_r3[15]
+ y_out_3_r[14]=pe_r3[14] y_out_3_r[13]=pe_r3[13] y_out_3_r[12]=pe_r3[12]
+ y_out_3_r[11]=pe_r3[11] y_out_3_r[10]=pe_r3[10] y_out_3_r[9]=pe_r3[9]
+ y_out_3_r[8]=pe_r3[8] y_out_3_r[7]=pe_r3[7] y_out_3_r[6]=pe_r3[6]
+ y_out_3_r[5]=pe_r3[5] y_out_3_r[4]=pe_r3[4] y_out_3_r[3]=pe_r3[3]
+ y_out_3_r[2]=pe_r3[2] y_out_3_r[1]=pe_r3[1] y_out_3_r[0]=pe_r3[0]
+ y_out_3_i[16]=pe_i3[16] y_out_3_i[15]=pe_i3[15] y_out_3_i[14]=pe_i3[14]
+ y_out_3_i[13]=pe_i3[13] y_out_3_i[12]=pe_i3[12] y_out_3_i[11]=pe_i3[11]
+ y_out_3_i[10]=pe_i3[10] y_out_3_i[9]=pe_i3[9] y_out_3_i[8]=pe_i3[8]
+ y_out_3_i[7]=pe_i3[7] y_out_3_i[6]=pe_i3[6] y_out_3_i[5]=pe_i3[5]
+ y_out_3_i[4]=pe_i3[4] y_out_3_i[3]=pe_i3[3] y_out_3_i[2]=pe_i3[2]
+ y_out_3_i[1]=pe_i3[1] y_out_3_i[0]=pe_i3[0] stage_sel_BAR=n289
+ i_rst_n=FE_OFN1_i_rst_n p1=FE_DBTN10_n289 FE_OFN27_i_rst_n=FE_OFN12_i_rst_n
+ FE_OFN21_i_rst_n=FE_OFN9_i_rst_n FE_OFN19_i_rst_n=FE_OFN8_i_rst_n
+ FE_OFN15_i_rst_n=FE_OFN7_i_rst_n FE_OFN9_i_rst_n=FE_OFN5_i_rst_n
+ FE_OFN7_i_rst_n=FE_OFN4_i_rst_n FE_OFN3_i_rst_n=FE_OFN3_i_rst_n
+ FE_OFN0_i_rst_n=FE_OFN2_i_rst_n FE_OFN35_n=FE_OFN32_n FE_OFN34_n=FE_OFN31_n
+ FE_OFN30_n=FE_OFN30_n FE_OFN57_FE_DBTN10_n289=FE_OFN253_FE_DBTN10_n289
+ FE_OFN55_FE_DBTN10_n289=FE_OFN252_FE_DBTN10_n289 clk_clone11=CTS_135
+ clk_clone9=CTS_137 clk_clone8=CTS_138 clk_clone7=CTS_139 clk_clone6=CTS_141
+ clk_clone10=CTS_142 clk_clone5=CTS_145 clk_clone4=CTS_146 clk_clone3=CTS_170
+ clk_clone2=CTS_172 clk_clone1=CTS_173 clk=CTS_175 p2=FE_PHN1264_current_n_4
Xrf_data RegFileDual_DATA_WIDTH34 $PINS rst_n=FE_UNCONNECTED_1
+ read_addr_1[4]=rf_d_raddr_1[4] read_addr_1[3]=rf_d_raddr_1[3]
+ read_addr_1[2]=rf_d_raddr_1[2] read_addr_1[1]=rf_d_raddr_1[1]
+ read_addr_1[0]=rf_d_raddr_1[0] read_data_1[33]=rf_d_rdata_1[33]
+ read_data_1[32]=rf_d_rdata_1[32] read_data_1[31]=rf_d_rdata_1[31]
+ read_data_1[30]=rf_d_rdata_1[30] read_data_1[29]=rf_d_rdata_1[29]
+ read_data_1[28]=rf_d_rdata_1[28] read_data_1[27]=rf_d_rdata_1[27]
+ read_data_1[26]=rf_d_rdata_1[26] read_data_1[25]=rf_d_rdata_1[25]
+ read_data_1[24]=rf_d_rdata_1[24] read_data_1[23]=rf_d_rdata_1[23]
+ read_data_1[22]=rf_d_rdata_1[22] read_data_1[21]=rf_d_rdata_1[21]
+ read_data_1[20]=rf_d_rdata_1[20] read_data_1[19]=rf_d_rdata_1[19]
+ read_data_1[18]=rf_d_rdata_1[18] read_data_1[17]=rf_d_rdata_1[17]
+ read_data_1[16]=rf_d_rdata_1[16] read_data_1[15]=rf_d_rdata_1[15]
+ read_data_1[14]=rf_d_rdata_1[14] read_data_1[13]=rf_d_rdata_1[13]
+ read_data_1[12]=rf_d_rdata_1[12] read_data_1[11]=rf_d_rdata_1[11]
+ read_data_1[10]=rf_d_rdata_1[10] read_data_1[9]=rf_d_rdata_1[9]
+ read_data_1[8]=rf_d_rdata_1[8] read_data_1[7]=rf_d_rdata_1[7]
+ read_data_1[6]=rf_d_rdata_1[6] read_data_1[5]=rf_d_rdata_1[5]
+ read_data_1[4]=rf_d_rdata_1[4] read_data_1[3]=rf_d_rdata_1[3]
+ read_data_1[2]=rf_d_rdata_1[2] read_data_1[1]=rf_d_rdata_1[1]
+ read_data_1[0]=rf_d_rdata_1[0] wen1=cordic_valid_out[0]
+ wen2=cordic_valid_out[1] write_addr_1[4]=c_group_idx[2]
+ write_addr_1[3]=c_group_idx[1] write_addr_1[2]=c_group_idx[0]
+ write_addr_1[1]=FE_DBTN11_n253 write_addr_1[0]=n461
+ write_addr_2[4]=c_group_idx[2] write_addr_2[3]=c_group_idx[1]
+ write_addr_2[2]=n461 write_addr_2[1]=n461 write_addr_2[0]=*Logic1*
+ write_data_1[33]=cor_y_out[0][16] write_data_1[32]=cor_y_out[0][15]
+ write_data_1[31]=cor_y_out[0][14] write_data_1[30]=cor_y_out[0][13]
+ write_data_1[29]=cor_y_out[0][12] write_data_1[28]=cor_y_out[0][11]
+ write_data_1[27]=cor_y_out[0][10] write_data_1[26]=cor_y_out[0][9]
+ write_data_1[25]=cor_y_out[0][8] write_data_1[24]=cor_y_out[0][7]
+ write_data_1[23]=cor_y_out[0][6] write_data_1[22]=cor_y_out[0][5]
+ write_data_1[21]=cor_y_out[0][4] write_data_1[20]=cor_y_out[0][3]
+ write_data_1[19]=cor_y_out[0][2] write_data_1[18]=cor_y_out[0][1]
+ write_data_1[17]=cor_y_out[0][0] write_data_1[16]=cor_x_out[0][16]
+ write_data_1[15]=cor_x_out[0][15] write_data_1[14]=cor_x_out[0][14]
+ write_data_1[13]=cor_x_out[0][13] write_data_1[12]=cor_x_out[0][12]
+ write_data_1[11]=cor_x_out[0][11] write_data_1[10]=cor_x_out[0][10]
+ write_data_1[9]=cor_x_out[0][9] write_data_1[8]=cor_x_out[0][8]
+ write_data_1[7]=cor_x_out[0][7] write_data_1[6]=cor_x_out[0][6]
+ write_data_1[5]=cor_x_out[0][5] write_data_1[4]=cor_x_out[0][4]
+ write_data_1[3]=cor_x_out[0][3] write_data_1[2]=cor_x_out[0][2]
+ write_data_1[1]=cor_x_out[0][1] write_data_1[0]=cor_x_out[0][0]
+ write_data_2[33]=cor_y_out[1][16] write_data_2[32]=FE_PHN1086_cor_y_out_1_15
+ write_data_2[31]=cor_y_out[1][14] write_data_2[30]=cor_y_out[1][13]
+ write_data_2[29]=cor_y_out[1][12] write_data_2[28]=FE_PHN1063_cor_y_out_1_11
+ write_data_2[27]=cor_y_out[1][10] write_data_2[26]=cor_y_out[1][9]
+ write_data_2[25]=cor_y_out[1][8] write_data_2[24]=FE_PHN1129_cor_y_out_1_7
+ write_data_2[23]=cor_y_out[1][6] write_data_2[22]=cor_y_out[1][5]
+ write_data_2[21]=cor_y_out[1][4] write_data_2[20]=cor_y_out[1][3]
+ write_data_2[19]=cor_y_out[1][2] write_data_2[18]=cor_y_out[1][1]
+ write_data_2[17]=cor_y_out[1][0] write_data_2[16]=cor_x_out[1][16]
+ write_data_2[15]=cor_x_out[1][15] write_data_2[14]=cor_x_out[1][14]
+ write_data_2[13]=cor_x_out[1][13] write_data_2[12]=cor_x_out[1][12]
+ write_data_2[11]=cor_x_out[1][11] write_data_2[10]=cor_x_out[1][10]
+ write_data_2[9]=cor_x_out[1][9] write_data_2[8]=cor_x_out[1][8]
+ write_data_2[7]=FE_PHN1106_cor_x_out_1_7
+ write_data_2[6]=FE_PHN1123_cor_x_out_1_6 write_data_2[5]=cor_x_out[1][5]
+ write_data_2[4]=cor_x_out[1][4] write_data_2[3]=cor_x_out[1][3]
+ write_data_2[2]=cor_x_out[1][2] write_data_2[1]=FE_PHN1143_cor_x_out_1_1
+ write_data_2[0]=cor_x_out[1][0] p_1=n253 i_rst_n=FE_OFN31_n
+ p1=FE_DBTN0_c_group_idx_0 p2=FE_DBTN1_c_group_idx_1 p3=FE_DBTN2_c_group_idx_2
+ FE_OFN25_i_rst_n=FE_OFN12_i_rst_n FE_OFN17_i_rst_n=FE_OFN7_i_rst_n
+ FE_OFN14_i_rst_n=FE_OFN6_i_rst_n clk_clone3=CTS_170 clk_clone4=CTS_148
+ clk=CTS_174 clk_clone2=CTS_179 clk_clone1=CTS_182
Xrf_io RegFileDual_DATA_WIDTH22 $PINS read_addr_1[4]=rf_io_raddr_1[4]
+ read_addr_1[3]=rf_io_raddr_1[3] read_addr_1[2]=rf_io_raddr_1[2]
+ read_addr_1[1]=rf_io_raddr_1[1] read_addr_1[0]=rf_io_raddr_1[0]
+ read_data_1[21]=mac_in_imag_s1_16 read_data_1[20]=mac_in_imag_s1[9]
+ read_data_1[19]=mac_in_imag_s1[8] read_data_1[18]=mac_in_imag_s1[7]
+ read_data_1[17]=mac_in_imag_s1[6] read_data_1[16]=mac_in_imag_s1[5]
+ read_data_1[15]=mac_in_imag_s1[4] read_data_1[14]=mac_in_imag_s1[3]
+ read_data_1[13]=mac_in_imag_s1[2] read_data_1[12]=mac_in_imag_s1[1]
+ read_data_1[11]=mac_in_imag_s1[0] read_data_1[10]=mac_in_real_s1_16
+ read_data_1[9]=mac_in_real_s1[9] read_data_1[8]=mac_in_real_s1[8]
+ read_data_1[7]=mac_in_real_s1[7] read_data_1[6]=mac_in_real_s1[6]
+ read_data_1[5]=mac_in_real_s1[5] read_data_1[4]=mac_in_real_s1[4]
+ read_data_1[3]=mac_in_real_s1[3] read_data_1[2]=mac_in_real_s1[2]
+ read_data_1[1]=mac_in_real_s1[1] read_data_1[0]=mac_in_real_s1[0]
+ wen1=rf_io_wen_1 wen2=rf_io_wen_2 write_addr_1[4]=rf_io_waddr_1[4]
+ write_addr_1[3]=rf_io_waddr_1[3] write_addr_1[2]=rf_io_waddr_1[2]
+ write_addr_1[1]=rf_io_waddr_1[1] write_addr_1[0]=rf_io_waddr_1[0]
+ write_addr_2[4]=rf_io_waddr_2[4] write_addr_2[3]=rf_io_waddr_2[3]
+ write_addr_2[2]=rf_io_waddr_2[2] write_addr_2[1]=n431
+ write_addr_2[0]=rf_io_wen_2 write_data_1[21]=rf_io_wdata_1[21]
+ write_data_1[20]=rf_io_wdata_1[20] write_data_1[19]=rf_io_wdata_1[19]
+ write_data_1[18]=rf_io_wdata_1[18] write_data_1[17]=rf_io_wdata_1[17]
+ write_data_1[16]=rf_io_wdata_1[16] write_data_1[15]=rf_io_wdata_1[15]
+ write_data_1[14]=rf_io_wdata_1[14] write_data_1[13]=rf_io_wdata_1[13]
+ write_data_1[12]=rf_io_wdata_1[12] write_data_1[11]=rf_io_wdata_1[11]
+ write_data_1[10]=rf_io_wdata_1[10] write_data_1[9]=rf_io_wdata_1[9]
+ write_data_1[8]=rf_io_wdata_1[8] write_data_1[7]=rf_io_wdata_1[7]
+ write_data_1[6]=rf_io_wdata_1[6] write_data_1[5]=rf_io_wdata_1[5]
+ write_data_1[4]=rf_io_wdata_1[4] write_data_1[3]=rf_io_wdata_1[3]
+ write_data_1[2]=rf_io_wdata_1[2] write_data_1[1]=rf_io_wdata_1[1]
+ write_data_1[0]=rf_io_wdata_1[0] write_data_2[21]=rf_io_wdata_2[21]
+ write_data_2[20]=rf_io_wdata_2[20] write_data_2[19]=rf_io_wdata_2[19]
+ write_data_2[18]=rf_io_wdata_2[18] write_data_2[17]=rf_io_wdata_2[17]
+ write_data_2[16]=rf_io_wdata_2[16] write_data_2[15]=rf_io_wdata_2[15]
+ write_data_2[14]=rf_io_wdata_2[14] write_data_2[13]=rf_io_wdata_2[13]
+ write_data_2[12]=rf_io_wdata_2[12] write_data_2[11]=rf_io_wdata_2[11]
+ write_data_2[10]=rf_io_wdata_2[10] write_data_2[9]=rf_io_wdata_2[9]
+ write_data_2[8]=rf_io_wdata_2[8] write_data_2[7]=rf_io_wdata_2[7]
+ write_data_2[6]=rf_io_wdata_2[6] write_data_2[5]=rf_io_wdata_2[5]
+ write_data_2[4]=FE_PHN1465_rf_io_wdata_2_4 write_data_2[3]=rf_io_wdata_2[3]
+ write_data_2[2]=FE_PHN1470_rf_io_wdata_2_2 write_data_2[1]=rf_io_wdata_2[1]
+ write_data_2[0]=rf_io_wdata_2[0] rst_n=FE_UNCONNECTED_2 p_1=n228
+ i_rst_n=FE_OFN5_i_rst_n FE_OFN26_i_rst_n=FE_OFN12_i_rst_n clk_clone3=CTS_135
+ clk_clone2=CTS_136 clk_clone1=CTS_172 clk=CTS_174
Xclk_gate_g_cnt_d2_reg SNPS_CLOCK_GATE_HIGH_CHIP_0 $PINS EN=mac_en
+ ENCLK=net1644 CLK=CTS_176
Xclk_gate_c_buf_i_reg[0] SNPS_CLOCK_GATE_HIGH_CHIP_10 $PINS EN=N69
+ ENCLK=CTS_169 CLK=CTS_170
Xclk_gate_c_buf_i_reg[1] SNPS_CLOCK_GATE_HIGH_CHIP_9 $PINS EN=N69 ENCLK=CTS_166
+ CLK=CTS_170
Xclk_gate_c_buf_i_reg[3] SNPS_CLOCK_GATE_HIGH_CHIP_8 $PINS EN=N69 ENCLK=CTS_163
+ CLK=CTS_170
Xclk_gate_c_buf_r_reg[0] SNPS_CLOCK_GATE_HIGH_CHIP_7 $PINS EN=N69 ENCLK=CTS_160
+ CLK=CTS_170
Xclk_gate_c_buf_r_reg[2] SNPS_CLOCK_GATE_HIGH_CHIP_6 $PINS EN=N69 ENCLK=CTS_157
+ CLK=CTS_170
Xclk_gate_delayed_mac_group_reg SNPS_CLOCK_GATE_HIGH_CHIP_5 $PINS EN=N157
+ ENCLK=CTS_154 CLK=CTS_170
Xclk_gate_delayed_out2_reg SNPS_CLOCK_GATE_HIGH_CHIP_4 $PINS EN=N157
+ ENCLK=CTS_151 CLK=CTS_170
Xclk_gate_o_counter_r_reg SNPS_CLOCK_GATE_HIGH_CHIP_3 $PINS EN=N432
+ ENCLK=net1684 CLK=CTS_176
Xclk_gate_key_r_reg SNPS_CLOCK_GATE_HIGH_CHIP_2 $PINS EN=N438 ENCLK=net1689
+ CLK=CTS_176
Xclk_gate_counter_r_reg SNPS_CLOCK_GATE_HIGH_CHIP_1 $PINS EN=N445 ENCLK=net1694
+ CLK=CTS_176
Xr166 CHIP_DW01_inc_1_DW01_inc_3 $PINS A[8]=counter_r[8]
+ A[7]=FE_PHN1263_current_g_2 A[6]=current_g[1] A[5]=current_g[0]
+ A[4]=FE_PHN1264_current_n_4 A[3]=current_n[3] A[2]=current_n[2]
+ A[1]=FE_OFN146_current_n_1 A[0]=current_n[0] SUM[8]=N191 SUM[7]=N190
+ SUM[6]=N189 SUM[5]=N188 SUM[4]=N187 SUM[3]=N186 SUM[2]=N185 SUM[1]=N184
+ SUM[0]=FE_UNCONNECTED_3
Xmult_149 CHIP_DW02_mult_1 $PINS A[5]=n457 A[4]=k_ord_1[4] A[3]=k_ord_1[3]
+ A[2]=k_ord_1[2] A[1]=k_ord_1[1] A[0]=k_ord_1[0] B[7]=key_r[7] B[6]=key_r[6]
+ B[5]=key_r[5] B[4]=key_r[4] B[3]=key_r[3] B[2]=key_r[2] B[1]=key_r[1]
+ B[0]=FE_PHN1260_key_r_0 TC=n461 PRODUCT[13]=SYNOPSYS_UNCONNECTED__0
+ PRODUCT[12]=SYNOPSYS_UNCONNECTED__1 PRODUCT[11]=SYNOPSYS_UNCONNECTED__2
+ PRODUCT[10]=SYNOPSYS_UNCONNECTED__3 PRODUCT[9]=SYNOPSYS_UNCONNECTED__4
+ PRODUCT[8]=SYNOPSYS_UNCONNECTED__5 PRODUCT[7]=N91 PRODUCT[6]=N90 PRODUCT[5]=N89
+ PRODUCT[4]=N88 PRODUCT[3]=N87 PRODUCT[2]=N86 PRODUCT[1]=N85
+ PRODUCT[0]=phase_1[8]
Xmult_148 CHIP_DW02_mult_0 $PINS A[7]=key_r[7] A[6]=key_r[6] A[5]=key_r[5]
+ A[4]=key_r[4] A[3]=key_r[3] A[2]=key_r[2] A[1]=key_r[1] A[0]=FE_PHN1260_key_r_0
+ B[4]=FE_DBTN2_c_group_idx_2 B[3]=FE_DBTN1_c_group_idx_1
+ B[2]=FE_DBTN0_c_group_idx_0 B[1]=FE_DBTN11_n253 B[0]=n461 TC=n461
+ PRODUCT[12]=SYNOPSYS_UNCONNECTED__6 PRODUCT[11]=SYNOPSYS_UNCONNECTED__7
+ PRODUCT[10]=SYNOPSYS_UNCONNECTED__8 PRODUCT[9]=SYNOPSYS_UNCONNECTED__9
+ PRODUCT[8]=SYNOPSYS_UNCONNECTED__10 PRODUCT[7]=N83 PRODUCT[6]=N82
+ PRODUCT[5]=N81 PRODUCT[4]=N80 PRODUCT[3]=N79 PRODUCT[2]=N78
+ PRODUCT[1]=phase_0[9] PRODUCT[0]=SYNOPSYS_UNCONNECTED__11 n253=FE_OFN17_n253
.ENDS

.SUBCKT CHIP clk rst_n i_valid i_ready o_ready o_valid i_data[21] i_data[20]
+ i_data[19] i_data[18] i_data[17] i_data[16] i_data[15] i_data[14] i_data[13]
+ i_data[12] i_data[11] i_data[10] i_data[9] i_data[8] i_data[7] i_data[6]
+ i_data[5] i_data[4] i_data[3] i_data[2] i_data[1] i_data[0] o_data[10]
+ o_data[9] o_data[8] o_data[7] o_data[6] o_data[5] o_data[4] o_data[3]
+ o_data[2] o_data[1] o_data[0]
XFE_OFC111_n_logic0 BUF2CK $PINS O=FE_OFN111_n_logic0 I=n_logic0
XFE_OFC110_i_o_data_1 BUF1 $PINS O=FE_OFN110_i_o_data_1 I=i_o_data[1]
XFE_OFC16_i_o_data_10 BUF1 $PINS O=FE_OFN16_i_o_data_10 I=i_o_data[10]
XFE_OFC15_n_logic0 BUF2 $PINS O=FE_OFN15_n_logic0 I=FE_OFN111_n_logic0
XFE_OFC14_n_logic0 BUF2 $PINS O=FE_OFN14_n_logic0 I=n_logic0
XU_TIE0 TIE0 $PINS O=n_logic0
XU_TIE1 TIE1 $PINS O=n_logic1
Xipad_clk XMD $PINS O=i_clk I=clk PU=FE_OFN15_n_logic0 PD=FE_OFN15_n_logic0
+ SMT=FE_OFN15_n_logic0
Xipad_rst_n XMD $PINS O=i_rst_n I=rst_n PU=FE_OFN15_n_logic0
+ PD=FE_OFN15_n_logic0 SMT=FE_OFN15_n_logic0
Xipad_i_valid XMD $PINS O=i_i_valid I=i_valid PU=FE_OFN15_n_logic0
+ PD=FE_OFN15_n_logic0 SMT=FE_OFN15_n_logic0
Xipad_o_ready XMD $PINS O=i_o_ready I=o_ready PU=FE_OFN15_n_logic0
+ PD=FE_OFN15_n_logic0 SMT=FE_OFN15_n_logic0
Xipad_i_data_0 XMD $PINS O=i_i_data[0] I=i_data[0] PU=FE_OFN15_n_logic0
+ PD=FE_OFN15_n_logic0 SMT=FE_OFN15_n_logic0
Xipad_i_data_1 XMD $PINS O=i_i_data[1] I=i_data[1] PU=FE_OFN15_n_logic0
+ PD=FE_OFN15_n_logic0 SMT=FE_OFN15_n_logic0
Xipad_i_data_2 XMD $PINS O=i_i_data[2] I=i_data[2] PU=FE_OFN15_n_logic0
+ PD=FE_OFN15_n_logic0 SMT=FE_OFN15_n_logic0
Xipad_i_data_3 XMD $PINS O=i_i_data[3] I=i_data[3] PU=FE_OFN15_n_logic0
+ PD=FE_OFN15_n_logic0 SMT=FE_OFN15_n_logic0
Xipad_i_data_4 XMD $PINS O=i_i_data[4] I=i_data[4] PU=FE_OFN15_n_logic0
+ PD=FE_OFN15_n_logic0 SMT=FE_OFN15_n_logic0
Xipad_i_data_5 XMD $PINS O=i_i_data[5] I=i_data[5] PU=FE_OFN15_n_logic0
+ PD=FE_OFN15_n_logic0 SMT=FE_OFN15_n_logic0
Xipad_i_data_6 XMD $PINS O=i_i_data[6] I=i_data[6] PU=FE_OFN14_n_logic0
+ PD=FE_OFN14_n_logic0 SMT=FE_OFN14_n_logic0
Xipad_i_data_7 XMD $PINS O=i_i_data[7] I=i_data[7] PU=FE_OFN14_n_logic0
+ PD=FE_OFN14_n_logic0 SMT=FE_OFN14_n_logic0
Xipad_i_data_8 XMD $PINS O=i_i_data[8] I=i_data[8] PU=FE_OFN14_n_logic0
+ PD=FE_OFN14_n_logic0 SMT=FE_OFN14_n_logic0
Xipad_i_data_9 XMD $PINS O=i_i_data[9] I=i_data[9] PU=FE_OFN14_n_logic0
+ PD=FE_OFN14_n_logic0 SMT=FE_OFN14_n_logic0
Xipad_i_data_10 XMD $PINS O=i_i_data[10] I=i_data[10] PU=FE_OFN14_n_logic0
+ PD=FE_OFN14_n_logic0 SMT=FE_OFN14_n_logic0
Xipad_i_data_11 XMD $PINS O=i_i_data[11] I=i_data[11] PU=FE_OFN14_n_logic0
+ PD=FE_OFN14_n_logic0 SMT=FE_OFN14_n_logic0
Xipad_i_data_12 XMD $PINS O=i_i_data[12] I=i_data[12] PU=FE_OFN14_n_logic0
+ PD=FE_OFN14_n_logic0 SMT=FE_OFN14_n_logic0
Xipad_i_data_13 XMD $PINS O=i_i_data[13] I=i_data[13] PU=FE_OFN14_n_logic0
+ PD=FE_OFN14_n_logic0 SMT=FE_OFN14_n_logic0
Xipad_i_data_14 XMD $PINS O=i_i_data[14] I=i_data[14] PU=FE_OFN14_n_logic0
+ PD=FE_OFN14_n_logic0 SMT=FE_OFN14_n_logic0
Xipad_i_data_15 XMD $PINS O=i_i_data[15] I=i_data[15] PU=FE_OFN14_n_logic0
+ PD=FE_OFN14_n_logic0 SMT=FE_OFN14_n_logic0
Xipad_i_data_16 XMD $PINS O=i_i_data[16] I=i_data[16] PU=FE_OFN14_n_logic0
+ PD=FE_OFN14_n_logic0 SMT=FE_OFN14_n_logic0
Xipad_i_data_17 XMD $PINS O=i_i_data[17] I=i_data[17] PU=FE_OFN14_n_logic0
+ PD=FE_OFN14_n_logic0 SMT=FE_OFN14_n_logic0
Xipad_i_data_18 XMD $PINS O=i_i_data[18] I=i_data[18] PU=FE_OFN14_n_logic0
+ PD=FE_OFN14_n_logic0 SMT=FE_OFN14_n_logic0
Xipad_i_data_19 XMD $PINS O=i_i_data[19] I=i_data[19] PU=FE_OFN14_n_logic0
+ PD=FE_OFN14_n_logic0 SMT=FE_OFN14_n_logic0
Xipad_i_data_20 XMD $PINS O=i_i_data[20] I=i_data[20] PU=n_logic0 PD=n_logic0
+ SMT=n_logic0
Xipad_i_data_21 XMD $PINS O=i_i_data[21] I=i_data[21] PU=n_logic0 PD=n_logic0
+ SMT=n_logic0
Xopad_i_ready YA2GSD $PINS O=i_ready I=i_i_ready E=n_logic1 E2=n_logic0
+ E4=n_logic0 E8=n_logic0 SR=n_logic0
Xopad_o_valid YA2GSD $PINS O=o_valid I=i_o_valid E=n_logic1 E2=n_logic0
+ E4=n_logic0 E8=n_logic0 SR=n_logic0
Xopad_o_data_0 YA2GSD $PINS O=o_data[0] I=i_o_data[0] E=n_logic1 E2=n_logic0
+ E4=n_logic0 E8=n_logic0 SR=n_logic0
Xopad_o_data_1 YA2GSD $PINS O=o_data[1] I=FE_OFN110_i_o_data_1 E=n_logic1
+ E2=n_logic0 E4=n_logic0 E8=n_logic0 SR=n_logic0
Xopad_o_data_2 YA2GSD $PINS O=o_data[2] I=i_o_data[2] E=n_logic1 E2=n_logic0
+ E4=n_logic0 E8=n_logic0 SR=n_logic0
Xopad_o_data_3 YA2GSD $PINS O=o_data[3] I=i_o_data[3] E=n_logic1 E2=n_logic0
+ E4=n_logic0 E8=n_logic0 SR=n_logic0
Xopad_o_data_4 YA2GSD $PINS O=o_data[4] I=i_o_data[4] E=n_logic1
+ E2=FE_OFN111_n_logic0 E4=FE_OFN111_n_logic0 E8=FE_OFN111_n_logic0
+ SR=FE_OFN111_n_logic0
Xopad_o_data_5 YA2GSD $PINS O=o_data[5] I=i_o_data[5] E=n_logic1
+ E2=FE_OFN111_n_logic0 E4=FE_OFN111_n_logic0 E8=FE_OFN111_n_logic0
+ SR=FE_OFN111_n_logic0
Xopad_o_data_6 YA2GSD $PINS O=o_data[6] I=i_o_data[6] E=n_logic1
+ E2=FE_OFN111_n_logic0 E4=FE_OFN111_n_logic0 E8=FE_OFN111_n_logic0
+ SR=FE_OFN111_n_logic0
Xopad_o_data_7 YA2GSD $PINS O=o_data[7] I=i_o_data[7] E=n_logic1
+ E2=FE_OFN111_n_logic0 E4=FE_OFN111_n_logic0 E8=FE_OFN111_n_logic0
+ SR=FE_OFN111_n_logic0
Xopad_o_data_8 YA2GSD $PINS O=o_data[8] I=i_o_data[8] E=n_logic1
+ E2=FE_OFN111_n_logic0 E4=FE_OFN111_n_logic0 E8=FE_OFN111_n_logic0
+ SR=FE_OFN111_n_logic0
Xopad_o_data_9 YA2GSD $PINS O=o_data[9] I=i_o_data[9] E=n_logic1
+ E2=FE_OFN15_n_logic0 E4=FE_OFN15_n_logic0 E8=FE_OFN15_n_logic0
+ SR=FE_OFN15_n_logic0
Xopad_o_data_10 YA2GSD $PINS O=o_data[10] I=FE_OFN16_i_o_data_10 E=n_logic1
+ E2=FE_OFN15_n_logic0 E4=FE_OFN15_n_logic0 E8=FE_OFN15_n_logic0
+ SR=FE_OFN15_n_logic0
XU_CORE CHIP_core $PINS clk=i_clk rst_n=i_rst_n i_valid=i_i_valid
+ i_ready=i_i_ready o_ready=i_o_ready o_valid=i_o_valid i_data[21]=i_i_data[21]
+ i_data[20]=i_i_data[20] i_data[19]=i_i_data[19] i_data[18]=i_i_data[18]
+ i_data[17]=i_i_data[17] i_data[16]=i_i_data[16] i_data[15]=i_i_data[15]
+ i_data[14]=i_i_data[14] i_data[13]=i_i_data[13] i_data[12]=i_i_data[12]
+ i_data[11]=i_i_data[11] i_data[10]=i_i_data[10] i_data[9]=i_i_data[9]
+ i_data[8]=i_i_data[8] i_data[7]=i_i_data[7] i_data[6]=i_i_data[6]
+ i_data[5]=i_i_data[5] i_data[4]=i_i_data[4] i_data[3]=i_i_data[3]
+ i_data[2]=i_i_data[2] i_data[1]=i_i_data[1] i_data[0]=i_i_data[0]
+ o_data[10]=i_o_data[10] o_data[9]=i_o_data[9] o_data[8]=i_o_data[8]
+ o_data[7]=i_o_data[7] o_data[6]=i_o_data[6] o_data[5]=i_o_data[5]
+ o_data[4]=i_o_data[4] o_data[3]=i_o_data[3] o_data[2]=i_o_data[2]
+ o_data[1]=i_o_data[1] o_data[0]=i_o_data[0]
.ENDS

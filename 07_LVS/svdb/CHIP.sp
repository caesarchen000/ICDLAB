* SPICE NETLIST
***************************************

.SUBCKT L POS NEG SUB
.ENDS
***************************************
.SUBCKT YA2GSD O E2 E8 E4 I SR E
** N=8 EP=7 IP=0 FDC=0
.ENDS
***************************************
.SUBCKT ICV_1 1 2 3 4 5
** N=5 EP=5 IP=8 FDC=0
X0 1 2 2 2 3 2 4 YA2GSD $T=0 0 0 0 $X=2850 $Y=0
.ENDS
***************************************
.SUBCKT XMD I SMT PU PD O
** N=6 EP=5 IP=0 FDC=0
.ENDS
***************************************
.SUBCKT ICV_2 1 8 9 10 11 12 13 14 15 16 17 18 25 26 27 28 43
** N=62 EP=17 IP=42 FDC=0
X0 8 1 1 1 16 XMD $T=249310 1307720 0 180 $X=189540 $Y=1168220
X1 9 1 1 1 27 XMD $T=358490 1307720 0 180 $X=298720 $Y=1168220
X2 10 1 1 1 17 XMD $T=467670 1307720 0 180 $X=407900 $Y=1168220
X3 11 1 1 1 18 XMD $T=576850 1307720 0 180 $X=517080 $Y=1168220
X4 12 13 13 13 28 XMD $T=686030 1307720 0 180 $X=626260 $Y=1168220
X5 14 13 13 13 25 XMD $T=1013570 1307720 0 180 $X=953800 $Y=1168220
X6 15 13 13 13 26 XMD $T=1122750 1307720 0 180 $X=1062980 $Y=1168220
.ENDS
***************************************
.SUBCKT QDFFN D CK Q GND VCC
** N=6 EP=5 IP=0 FDC=0
.ENDS
***************************************
.SUBCKT AOI22S A1 B1 O B2 GND A2 VCC
** N=8 EP=7 IP=0 FDC=0
.ENDS
***************************************
.SUBCKT AN2 I1 I2 GND VCC O
** N=6 EP=5 IP=0 FDC=0
.ENDS
***************************************
.SUBCKT INV6CK I O GND VCC
** N=5 EP=4 IP=0 FDC=0
.ENDS
***************************************
.SUBCKT INV4CK I O GND VCC
** N=5 EP=4 IP=0 FDC=0
.ENDS
***************************************
.SUBCKT QDBHN CKB D GND VCC Q
** N=6 EP=5 IP=0 FDC=0
.ENDS
***************************************
.SUBCKT INV2CK I O GND VCC
** N=5 EP=4 IP=0 FDC=0
.ENDS
***************************************
.SUBCKT AN2T I1 I2 O GND VCC
** N=6 EP=5 IP=0 FDC=0
.ENDS
***************************************
.SUBCKT DELC I GND VCC O
** N=5 EP=4 IP=0 FDC=0
.ENDS
***************************************
.SUBCKT INV1S I VCC O GND
** N=5 EP=4 IP=0 FDC=0
.ENDS
***************************************
.SUBCKT ND3 I3 GND I2 O VCC I1
** N=7 EP=6 IP=0 FDC=0
.ENDS
***************************************
.SUBCKT ND3S I3 GND I2 O I1 VCC
** N=7 EP=6 IP=0 FDC=0
.ENDS
***************************************
.SUBCKT AN4B1S I3 I2 I1 VCC B1 GND O
** N=8 EP=7 IP=0 FDC=0
.ENDS
***************************************
.SUBCKT OA222 A2 A1 B2 B1 C2 C1 GND VCC O
** N=10 EP=9 IP=0 FDC=0
.ENDS
***************************************
.SUBCKT NR2 I1 VCC O I2 GND
** N=6 EP=5 IP=0 FDC=0
.ENDS
***************************************
.SUBCKT NR3 I1 VCC I2 I3 O GND
** N=7 EP=6 IP=0 FDC=0
.ENDS
***************************************
.SUBCKT MOAI1S B1 B2 GND A1 A2 O VCC
** N=8 EP=7 IP=0 FDC=0
.ENDS
***************************************
.SUBCKT OA112 A1 B1 C1 C2 VCC GND O
** N=8 EP=7 IP=0 FDC=0
.ENDS
***************************************
.SUBCKT ND2 I1 O I2 GND VCC
** N=6 EP=5 IP=0 FDC=0
.ENDS
***************************************
.SUBCKT AO12 B2 B1 A1 GND VCC O
** N=7 EP=6 IP=0 FDC=0
.ENDS
***************************************
.SUBCKT MAOI1S B1 B2 A1 A2 VCC GND O
** N=8 EP=7 IP=0 FDC=0
.ENDS
***************************************
.SUBCKT OA222S A2 A1 B2 B1 C2 C1 VCC GND O
** N=10 EP=9 IP=0 FDC=0
.ENDS
***************************************
.SUBCKT ND2S I1 O I2 VCC GND
** N=6 EP=5 IP=0 FDC=0
.ENDS
***************************************
.SUBCKT OAI222S C1 C2 GND B1 B2 VCC A1 O A2
** N=10 EP=9 IP=0 FDC=0
.ENDS
***************************************
.SUBCKT OAI112HS C2 C1 GND B1 O A1 VCC
** N=8 EP=7 IP=0 FDC=0
.ENDS
***************************************
.SUBCKT OAI22S B2 GND B1 A2 O A1 VCC
** N=8 EP=7 IP=0 FDC=0
.ENDS
***************************************
.SUBCKT OA22S A1 A2 B1 B2 VCC GND O
** N=8 EP=7 IP=0 FDC=0
.ENDS
***************************************
.SUBCKT AOI12HS B2 B1 VCC A1 GND O
** N=7 EP=6 IP=0 FDC=0
.ENDS
***************************************
.SUBCKT MAOI1 B1 B2 A1 A2 VCC GND O
** N=8 EP=7 IP=0 FDC=0
.ENDS
***************************************
.SUBCKT AN3B2S I1 B2 VCC B1 GND O
** N=7 EP=6 IP=0 FDC=0
.ENDS
***************************************
.SUBCKT OAI12HS B2 B1 GND A1 VCC O
** N=7 EP=6 IP=0 FDC=0
.ENDS
***************************************
.SUBCKT AO222 C1 C2 B2 B1 A1 A2 GND VCC O
** N=10 EP=9 IP=0 FDC=0
.ENDS
***************************************
.SUBCKT INV2 I O GND VCC
** N=5 EP=4 IP=0 FDC=0
.ENDS
***************************************
.SUBCKT NR2P I1 VCC I2 GND O
** N=6 EP=5 IP=0 FDC=0
.ENDS
***************************************
.SUBCKT OR3B2 I1 B1 VCC O B2 GND
** N=7 EP=6 IP=0 FDC=0
.ENDS
***************************************
.SUBCKT AN3 I1 I2 I3 VCC GND O
** N=7 EP=6 IP=0 FDC=0
.ENDS
***************************************
.SUBCKT OA22 A1 A2 B1 B2 VCC GND O
** N=8 EP=7 IP=0 FDC=0
.ENDS
***************************************
.SUBCKT AN3S I1 I2 I3 GND VCC O
** N=7 EP=6 IP=0 FDC=0
.ENDS
***************************************
.SUBCKT INV12CK I O GND VCC
** N=5 EP=4 IP=0 FDC=0
.ENDS
***************************************
.SUBCKT ICV_3 1 2 4 5 6 7 8 9 10 11 12 13 14 15 16 17 18 19 20 21
+ 22 23 24 25 26 27 28 29 30 31 32 33 34 35 36 37 38 39 40 41
+ 42 43 44 45 46 47 48 49 50 51 52 53 54 55 56 57 58 59 60 61
+ 62 63 64 65 66 67 68 69 70 71 72 73 74 75 76 77 78 79 80 81
+ 82 83 84 85 86 87 88 89 90 91 92 93 94 95 96 97 98 99 100 101
+ 102 103 104 105 106 107 108 109 110 111 112 113 114 115 116 117 118 119 120 121
+ 122 123 124 125 126 127 128 129 130 131 132 133 134 135 136 137 138 139 140 141
+ 142 143 144 145 146 147 148 149 150 151 152 153 154 155 156 157 158 159 160 161
+ 162 163 164 165 166 167 168 169 170 171 172 173 174 175 176 177 178 179 180 181
+ 182 183 184 185 186 187 188 189 190 191 192 193 194 195 196 197 198 199 200 201
+ 202 203 204 205 206 207 208 209 210 211 212 213 214 215 216 217 218 219 220 221
+ 222 223 224 225 226 227 228 229 230 231 232 233 234 235 236 237 238 239 240 241
+ 242 243 244 245 246 247 248 249 250 251 252 253 254 255 256 257 258 259 260 261
+ 262 263 264 265 266 267 268 269 270 271 272 273 274 275 276 277 278 279 280 281
+ 282 283 284 285 286 287 288 289 290 291 292 293 294 295 296 297 298 299 300 301
+ 302 303 304 305 306 307 308 309 310 311 312 313 314 315 316 317 318 319 320 321
+ 322 323 324 325 326 327 328 329 330 331 332 333 334 335 336 337 338 339 340 341
+ 342 343 344 345 346 347 348 349 350 351 352 353 354 355 356 357 358 359 360 361
+ 363 364 365 366 368 369 370 371 372 373 374 376 377 378 379 380 381 382 383 384
+ 385 386 387 388 389 390 391 392 393 394 395 397 398 399 400 401 402 403 405 406
+ 407 408 410 411 412 413 414 415 416 417 418 419 420 421 422 423 424 425 426 427
+ 428 429 430 431 432 433 434 435 436 437 438 439 440 441 442 443 444 445 446 447
+ 448 449 450 451 452 453 454 455 456 457 458 459 470 486
** N=780 EP=454 IP=3334 FDC=0
X0 457 458 458 458 459 458 470 YA2GSD $T=1309440 1058590 0 90 $X=1169940 $Y=1061440
X1 335 334 654 1 2 QDFFN $T=651620 1072400 0 180 $X=641080 $Y=1066980
X2 337 334 655 1 2 QDFFN $T=654100 1082480 0 180 $X=643560 $Y=1077060
X3 338 336 333 1 2 QDFFN $T=655340 1062320 1 180 $X=644800 $Y=1061940
X4 335 336 658 1 2 QDFFN $T=655960 1072400 0 0 $X=655960 $Y=1072020
X5 337 336 660 1 2 QDFFN $T=661540 1082480 0 0 $X=661540 $Y=1082100
X6 335 344 663 1 2 QDFFN $T=673320 1072400 0 0 $X=673320 $Y=1072020
X7 337 351 664 1 2 QDFFN $T=695020 1082480 1 180 $X=684480 $Y=1082100
X8 337 344 666 1 2 QDFFN $T=685100 1072400 0 0 $X=685100 $Y=1072020
X9 350 336 353 1 2 QDFFN $T=688820 1062320 1 0 $X=688820 $Y=1056900
X10 335 351 662 1 2 QDFFN $T=699360 1072400 0 180 $X=688820 $Y=1066980
X11 352 351 669 1 2 QDFFN $T=696880 1082480 0 0 $X=696880 $Y=1082100
X12 352 344 667 1 2 QDFFN $T=708660 1072400 1 180 $X=698120 $Y=1072020
X13 354 336 671 1 2 QDFFN $T=701220 1062320 1 0 $X=701220 $Y=1056900
X14 352 334 672 1 2 QDFFN $T=702460 1062320 0 0 $X=702460 $Y=1061940
X15 352 336 674 1 2 QDFFN $T=709900 1082480 0 0 $X=709900 $Y=1082100
X16 356 344 677 1 2 QDFFN $T=710520 1072400 0 0 $X=710520 $Y=1072020
X17 354 334 673 1 2 QDFFN $T=725400 1062320 1 180 $X=714860 $Y=1061940
X18 358 336 360 1 2 QDFFN $T=721060 1062320 1 0 $X=721060 $Y=1056900
X19 356 351 682 1 2 QDFFN $T=722300 1082480 1 0 $X=722300 $Y=1077060
X20 363 336 675 1 2 QDFFN $T=740900 1082480 1 180 $X=730360 $Y=1082100
X21 356 336 681 1 2 QDFFN $T=742140 1072400 1 180 $X=731600 $Y=1072020
X22 358 344 364 1 2 QDFFN $T=732220 1062320 1 0 $X=732220 $Y=1056900
X23 356 334 683 1 2 QDFFN $T=747720 1062320 1 180 $X=737180 $Y=1061940
X24 363 344 685 1 2 QDFFN $T=737180 1072400 1 0 $X=737180 $Y=1066980
X25 365 344 366 1 2 QDFFN $T=742760 1062320 1 0 $X=742760 $Y=1056900
X26 363 334 678 1 2 QDFFN $T=755160 1082480 1 180 $X=744620 $Y=1082100
X27 365 336 369 1 2 QDFFN $T=749580 1062320 0 0 $X=749580 $Y=1061940
X28 363 351 686 1 2 QDFFN $T=751440 1082480 1 0 $X=751440 $Y=1077060
X29 365 334 370 1 2 QDFFN $T=753300 1062320 1 0 $X=753300 $Y=1056900
X30 368 351 688 1 2 QDFFN $T=755780 1072400 0 0 $X=755780 $Y=1072020
X31 368 334 689 1 2 QDFFN $T=757020 1082480 0 0 $X=757020 $Y=1082100
X32 371 336 373 1 2 QDFFN $T=763840 1062320 1 0 $X=763840 $Y=1056900
X33 368 336 690 1 2 QDFFN $T=779960 1082480 1 180 $X=769420 $Y=1082100
X34 374 351 694 1 2 QDFFN $T=773760 1072400 1 0 $X=773760 $Y=1066980
X35 374 336 695 1 2 QDFFN $T=774380 1082480 1 0 $X=774380 $Y=1077060
X36 371 334 376 1 2 QDFFN $T=785540 1062320 0 180 $X=775000 $Y=1056900
X37 368 344 692 1 2 QDFFN $T=788640 1072400 1 180 $X=778100 $Y=1072020
X38 374 334 701 1 2 QDFFN $T=782440 1082480 0 0 $X=782440 $Y=1082100
X39 374 344 699 1 2 QDFFN $T=790500 1062320 1 0 $X=790500 $Y=1056900
X40 378 351 705 1 2 QDFFN $T=794840 1072400 1 0 $X=794840 $Y=1066980
X41 378 336 704 1 2 QDFFN $T=796080 1082480 0 0 $X=796080 $Y=1082100
X42 382 334 384 1 2 QDFFN $T=807240 1062320 0 0 $X=807240 $Y=1061940
X43 378 334 709 1 2 QDFFN $T=810340 1082480 0 0 $X=810340 $Y=1082100
X44 378 344 706 1 2 QDFFN $T=812200 1072400 0 0 $X=812200 $Y=1072020
X45 390 386 710 1 2 QDFFN $T=830800 1082480 0 180 $X=820260 $Y=1077060
X46 390 389 711 1 2 QDFFN $T=837620 1072400 1 180 $X=827080 $Y=1072020
X47 390 391 712 1 2 QDFFN $T=841960 1072400 0 180 $X=831420 $Y=1066980
X48 387 388 393 1 2 QDFFN $T=832040 1062320 1 0 $X=832040 $Y=1056900
X49 390 388 713 1 2 QDFFN $T=842580 1082480 1 180 $X=832040 $Y=1082100
X50 392 389 716 1 2 QDFFN $T=839480 1072400 0 0 $X=839480 $Y=1072020
X51 387 391 400 1 2 QDFFN $T=845060 1062320 1 0 $X=845060 $Y=1056900
X52 392 388 720 1 2 QDFFN $T=847540 1082480 0 0 $X=847540 $Y=1082100
X53 392 386 719 1 2 QDFFN $T=851260 1072400 0 0 $X=851260 $Y=1072020
X54 392 391 718 1 2 QDFFN $T=866140 1062320 1 180 $X=855600 $Y=1061940
X55 401 388 725 1 2 QDFFN $T=860560 1082480 0 0 $X=860560 $Y=1082100
X56 401 386 722 1 2 QDFFN $T=875440 1082480 0 180 $X=864900 $Y=1077060
X57 401 391 726 1 2 QDFFN $T=866760 1072400 1 0 $X=866760 $Y=1066980
X58 408 386 727 1 2 QDFFN $T=884120 1082480 1 180 $X=873580 $Y=1082100
X59 407 388 729 1 2 QDFFN $T=876680 1072400 0 0 $X=876680 $Y=1072020
X60 407 386 728 1 2 QDFFN $T=889700 1062320 0 180 $X=879160 $Y=1056900
X61 408 388 730 1 2 QDFFN $T=879160 1082480 1 0 $X=879160 $Y=1077060
X62 408 391 734 1 2 QDFFN $T=885360 1082480 0 0 $X=885360 $Y=1082100
X63 407 391 732 1 2 QDFFN $T=887840 1072400 1 0 $X=887840 $Y=1066980
X64 407 389 733 1 2 QDFFN $T=905200 1062320 0 180 $X=894660 $Y=1056900
X65 408 389 736 1 2 QDFFN $T=898380 1072400 0 0 $X=898380 $Y=1072020
X66 412 391 415 1 2 QDFFN $T=900860 1072400 1 0 $X=900860 $Y=1066980
X67 412 389 417 1 2 QDFFN $T=905200 1062320 0 0 $X=905200 $Y=1061940
X68 414 388 738 1 2 QDFFN $T=908920 1082480 0 0 $X=908920 $Y=1082100
X69 414 386 737 1 2 QDFFN $T=921320 1082480 0 180 $X=910780 $Y=1077060
X70 412 388 743 1 2 QDFFN $T=916360 1062320 0 0 $X=916360 $Y=1061940
X71 414 391 742 1 2 QDFFN $T=933720 1082480 1 180 $X=923180 $Y=1082100
X72 414 389 744 1 2 QDFFN $T=939300 1072400 1 180 $X=928760 $Y=1072020
X73 422 391 746 1 2 QDFFN $T=930620 1062320 0 0 $X=930620 $Y=1061940
X74 426 391 745 1 2 QDFFN $T=946120 1082480 1 180 $X=935580 $Y=1082100
X75 426 389 747 1 2 QDFFN $T=954180 1082480 0 180 $X=943640 $Y=1077060
X76 422 388 753 1 2 QDFFN $T=944880 1062320 0 0 $X=944880 $Y=1061940
X77 426 388 754 1 2 QDFFN $T=949220 1082480 0 0 $X=949220 $Y=1082100
X78 426 386 752 1 2 QDFFN $T=958520 1082480 1 0 $X=958520 $Y=1077060
X79 428 429 755 1 2 QDFFN $T=959760 1072400 0 0 $X=959760 $Y=1072020
X80 428 430 756 1 2 QDFFN $T=961000 1062320 0 0 $X=961000 $Y=1061940
X81 428 435 758 1 2 QDFFN $T=974020 1082480 1 0 $X=974020 $Y=1077060
X82 428 436 757 1 2 QDFFN $T=975260 1062320 0 0 $X=975260 $Y=1061940
X83 440 435 761 1 2 QDFFN $T=985800 1082480 1 0 $X=985800 $Y=1077060
X84 440 430 762 1 2 QDFFN $T=987660 1062320 0 0 $X=987660 $Y=1061940
X85 440 436 763 1 2 QDFFN $T=988900 1072400 1 0 $X=988900 $Y=1066980
X86 442 430 444 1 2 QDFFN $T=998200 1062320 1 0 $X=998200 $Y=1056900
X87 442 435 764 1 2 QDFFN $T=998820 1082480 1 0 $X=998820 $Y=1077060
X88 442 436 765 1 2 QDFFN $T=1000060 1062320 0 0 $X=1000060 $Y=1061940
X89 446 429 445 1 2 QDFFN $T=1019280 1062320 0 180 $X=1008740 $Y=1056900
X90 446 435 767 1 2 QDFFN $T=1011220 1082480 1 0 $X=1011220 $Y=1077060
X91 446 436 766 1 2 QDFFN $T=1023620 1062320 1 180 $X=1013080 $Y=1061940
X92 446 430 448 1 2 QDFFN $T=1029820 1062320 0 180 $X=1019280 $Y=1056900
X93 449 436 768 1 2 QDFFN $T=1024240 1072400 0 0 $X=1024240 $Y=1072020
X94 449 429 770 1 2 QDFFN $T=1029820 1062320 1 0 $X=1029820 $Y=1056900
X95 449 435 772 1 2 QDFFN $T=1037260 1082480 1 0 $X=1037260 $Y=1077060
X96 452 430 773 1 2 QDFFN $T=1049040 1062320 0 0 $X=1049040 $Y=1061940
X97 453 436 774 1 2 QDFFN $T=1052140 1072400 0 0 $X=1052140 $Y=1072020
X98 453 435 776 1 2 QDFFN $T=1067640 1072400 0 0 $X=1067640 $Y=1072020
X99 453 430 779 1 2 QDFFN $T=1076940 1062320 0 0 $X=1076940 $Y=1061940
X100 453 429 778 1 2 QDFFN $T=1076940 1072400 1 0 $X=1076940 $Y=1066980
X101 12 81 79 514 1 520 2 AOI22S $T=311860 1082480 0 0 $X=311860 $Y=1082100
X102 94 97 95 523 1 527 2 AOI22S $T=329220 1062320 0 0 $X=329220 $Y=1061940
X103 122 94 121 537 1 538 2 AOI22S $T=354640 1062320 0 0 $X=354640 $Y=1061940
X104 122 94 525 540 1 129 2 AOI22S $T=355880 1062320 1 0 $X=355880 $Y=1056900
X105 205 195 590 207 1 209 2 AOI22S $T=504060 1062320 1 180 $X=500340 $Y=1061940
X106 251 249 611 152 1 217 2 AOI22S $T=535060 1062320 1 180 $X=531340 $Y=1061940
X107 231 299 642 634 1 628 2 AOI22S $T=582800 1082480 1 180 $X=579080 $Y=1082100
X108 292 231 302 218 1 640 2 AOI22S $T=584660 1072400 0 180 $X=580940 $Y=1066980
X109 309 290 648 297 1 300 2 AOI22S $T=604500 1072400 0 0 $X=604500 $Y=1072020
X110 285 300 650 310 1 299 2 AOI22S $T=606980 1072400 1 0 $X=606980 $Y=1066980
X111 654 658 656 339 1 341 2 AOI22S $T=664020 1072400 1 0 $X=664020 $Y=1066980
X112 655 660 659 339 1 341 2 AOI22S $T=665260 1082480 1 0 $X=665260 $Y=1077060
X113 662 663 657 349 1 348 2 AOI22S $T=679520 1062320 0 0 $X=679520 $Y=1061940
X114 346 347 661 349 1 348 2 AOI22S $T=680140 1062320 1 0 $X=680140 $Y=1056900
X115 664 666 665 349 1 348 2 AOI22S $T=689440 1082480 1 0 $X=689440 $Y=1077060
X116 669 667 668 349 1 348 2 AOI22S $T=703080 1082480 0 180 $X=699360 $Y=1077060
X117 673 671 357 339 1 341 2 AOI22S $T=714860 1062320 1 0 $X=714860 $Y=1056900
X118 672 674 670 339 1 341 2 AOI22S $T=714860 1082480 1 0 $X=714860 $Y=1077060
X119 678 675 680 339 1 341 2 AOI22S $T=726020 1082480 1 180 $X=722300 $Y=1082100
X120 682 677 676 349 1 348 2 AOI22S $T=728500 1072400 0 180 $X=724780 $Y=1066980
X121 683 681 679 339 1 341 2 AOI22S $T=733460 1062320 1 180 $X=729740 $Y=1061940
X122 686 685 684 349 1 348 2 AOI22S $T=747720 1082480 0 180 $X=744000 $Y=1077060
X123 689 690 687 339 1 341 2 AOI22S $T=766320 1082480 1 0 $X=766320 $Y=1077060
X124 688 692 691 349 1 348 2 AOI22S $T=770660 1072400 0 0 $X=770660 $Y=1072020
X125 694 699 698 349 1 348 2 AOI22S $T=789260 1072400 1 0 $X=789260 $Y=1066980
X126 701 695 702 339 1 341 2 AOI22S $T=793600 1082480 0 180 $X=789880 $Y=1077060
X127 705 706 707 349 1 348 2 AOI22S $T=809100 1072400 0 180 $X=805380 $Y=1066980
X128 709 704 703 339 1 341 2 AOI22S $T=810340 1082480 0 180 $X=806620 $Y=1077060
X129 713 710 714 349 1 348 2 AOI22S $T=835140 1082480 1 0 $X=835140 $Y=1077060
X130 711 712 715 339 1 398 2 AOI22S $T=842580 1072400 1 0 $X=842580 $Y=1066980
X131 716 718 717 339 1 398 2 AOI22S $T=850640 1072400 1 0 $X=850640 $Y=1066980
X132 720 719 721 349 1 348 2 AOI22S $T=858700 1082480 0 180 $X=854980 $Y=1077060
X133 725 722 724 349 1 348 2 AOI22S $T=871100 1072400 1 180 $X=867380 $Y=1072020
X134 406 726 723 339 1 398 2 AOI22S $T=872960 1062320 1 0 $X=872960 $Y=1056900
X135 729 728 410 349 1 348 2 AOI22S $T=885360 1062320 1 180 $X=881640 $Y=1061940
X136 733 732 411 339 1 398 2 AOI22S $T=896520 1062320 1 180 $X=892800 $Y=1061940
X137 730 727 731 349 1 348 2 AOI22S $T=893420 1082480 1 0 $X=893420 $Y=1077060
X138 736 734 735 339 1 398 2 AOI22S $T=905200 1082480 0 180 $X=901480 $Y=1077060
X139 738 737 739 416 1 348 2 AOI22S $T=916980 1072400 1 180 $X=913260 $Y=1072020
X140 743 420 740 416 1 348 2 AOI22S $T=924420 1062320 1 0 $X=924420 $Y=1056900
X141 744 742 741 339 1 398 2 AOI22S $T=929380 1082480 0 180 $X=925660 $Y=1077060
X142 423 746 748 339 1 398 2 AOI22S $T=938060 1062320 0 180 $X=934340 $Y=1056900
X143 747 745 749 339 1 398 2 AOI22S $T=939300 1082480 0 180 $X=935580 $Y=1077060
X144 753 427 750 416 1 348 2 AOI22S $T=952940 1062320 0 180 $X=949220 $Y=1056900
X145 754 752 751 416 1 348 2 AOI22S $T=954800 1072400 1 180 $X=951080 $Y=1072020
X146 756 755 433 432 1 431 2 AOI22S $T=969060 1062320 0 180 $X=965340 $Y=1056900
X147 757 758 434 438 1 439 2 AOI22S $T=978360 1072400 1 0 $X=978360 $Y=1066980
X148 762 441 759 432 1 431 2 AOI22S $T=993860 1062320 0 180 $X=990140 $Y=1056900
X149 763 761 760 438 1 439 2 AOI22S $T=994480 1072400 1 180 $X=990760 $Y=1072020
X150 765 764 443 438 1 439 2 AOI22S $T=1006260 1072400 1 180 $X=1002540 $Y=1072020
X151 766 767 447 438 1 439 2 AOI22S $T=1016180 1072400 1 0 $X=1016180 $Y=1066980
X152 768 772 769 438 1 439 2 AOI22S $T=1039120 1072400 1 0 $X=1039120 $Y=1066980
X153 450 770 771 432 1 431 2 AOI22S $T=1040980 1062320 1 0 $X=1040980 $Y=1056900
X154 773 454 455 432 1 431 2 AOI22S $T=1056480 1062320 0 180 $X=1052760 $Y=1056900
X155 774 776 775 438 1 439 2 AOI22S $T=1061440 1072400 1 0 $X=1061440 $Y=1066980
X156 779 778 777 432 1 431 2 AOI22S $T=1080040 1062320 0 180 $X=1076320 $Y=1056900
X157 35 41 1 2 46 AN2 $T=274040 1062320 1 0 $X=274040 $Y=1056900
X158 491 46 1 2 11 AN2 $T=275280 1062320 0 0 $X=275280 $Y=1061940
X159 53 495 1 2 56 AN2 $T=283960 1062320 1 0 $X=283960 $Y=1056900
X160 29 63 1 2 516 AN2 $T=313720 1072400 0 0 $X=313720 $Y=1072020
X161 131 7 1 2 539 AN2 $T=362080 1072400 0 180 $X=359600 $Y=1066980
X162 190 584 1 2 222 AN2 $T=498480 1072400 0 180 $X=496000 $Y=1066980
X163 657 656 1 2 340 AN2 $T=665880 1062320 1 0 $X=665880 $Y=1056900
X164 661 343 1 2 345 AN2 $T=672700 1062320 1 0 $X=672700 $Y=1056900
X165 665 659 1 2 342 AN2 $T=682620 1082480 0 180 $X=680140 $Y=1077060
X166 668 670 1 2 355 AN2 $T=708040 1082480 1 0 $X=708040 $Y=1077060
X167 676 679 1 2 359 AN2 $T=727260 1062320 0 0 $X=727260 $Y=1061940
X168 684 680 1 2 361 AN2 $T=739040 1082480 0 180 $X=736560 $Y=1077060
X169 691 687 1 2 372 AN2 $T=771280 1072400 0 180 $X=768800 $Y=1066980
X170 698 702 1 2 379 AN2 $T=792980 1072400 0 0 $X=792980 $Y=1072020
X171 707 703 1 2 381 AN2 $T=805380 1062320 0 180 $X=802900 $Y=1056900
X172 394 395 1 2 397 AN2 $T=842580 1062320 1 0 $X=842580 $Y=1056900
X173 714 715 1 2 399 AN2 $T=845060 1082480 1 0 $X=845060 $Y=1077060
X174 721 717 1 2 403 AN2 $T=861180 1072400 1 0 $X=861180 $Y=1066980
X175 724 723 1 2 405 AN2 $T=870480 1062320 0 180 $X=868000 $Y=1056900
X176 731 735 1 2 413 AN2 $T=902100 1082480 1 180 $X=899620 $Y=1082100
X177 740 419 1 2 418 AN2 $T=920700 1062320 0 180 $X=918220 $Y=1056900
X178 739 741 1 2 421 AN2 $T=923180 1072400 0 0 $X=923180 $Y=1072020
X179 751 749 1 2 425 AN2 $T=944260 1072400 1 180 $X=941780 $Y=1072020
X180 750 748 1 2 424 AN2 $T=945500 1062320 0 180 $X=943020 $Y=1056900
X181 760 759 1 2 437 AN2 $T=983940 1062320 0 180 $X=981460 $Y=1056900
X182 769 771 1 2 451 AN2 $T=1039740 1062320 0 0 $X=1039740 $Y=1061940
X183 775 777 1 2 456 AN2 $T=1067640 1062320 0 0 $X=1067640 $Y=1061940
X184 4 487 1 2 INV6CK $T=220720 1082480 0 0 $X=220720 $Y=1082100
X185 383 708 1 2 INV6CK $T=814060 1062320 0 180 $X=808480 $Y=1056900
X186 402 391 1 2 INV6CK $T=861800 1062320 0 180 $X=856220 $Y=1056900
X187 693 336 1 2 INV4CK $T=781200 1062320 0 0 $X=781200 $Y=1061940
X188 708 334 1 2 INV4CK $T=810340 1072400 1 0 $X=810340 $Y=1066980
X189 385 344 1 2 INV4CK $T=825840 1062320 0 180 $X=822120 $Y=1056900
X190 377 380 1 2 696 QDBHN $T=796700 1072400 0 0 $X=796700 $Y=1072020
X191 700 693 1 2 INV2CK $T=794840 1062320 0 0 $X=794840 $Y=1061940
X192 697 377 700 1 2 AN2T $T=788640 1072400 0 0 $X=788640 $Y=1072020
X193 696 1 2 697 DELC $T=784920 1082480 1 0 $X=784920 $Y=1077060
X194 13 2 12 1 INV1S $T=245520 1072400 1 180 $X=244280 $Y=1072020
X195 488 2 15 1 INV1S $T=244900 1062320 1 0 $X=244900 $Y=1056900
X196 18 2 16 1 INV1S $T=249240 1062320 1 180 $X=248000 $Y=1061940
X197 21 2 17 1 INV1S $T=249860 1062320 0 180 $X=248620 $Y=1056900
X198 31 2 28 1 INV1S $T=259780 1062320 0 180 $X=258540 $Y=1056900
X199 491 2 489 1 INV1S $T=263500 1082480 0 180 $X=262260 $Y=1077060
X200 29 2 493 1 INV1S $T=264120 1072400 0 0 $X=264120 $Y=1072020
X201 490 2 33 1 INV1S $T=264120 1082480 0 0 $X=264120 $Y=1082100
X202 44 2 39 1 INV1S $T=274040 1062320 1 180 $X=272800 $Y=1061940
X203 23 2 500 1 INV1S $T=274660 1072400 1 0 $X=274660 $Y=1066980
X204 50 2 26 1 INV1S $T=279620 1062320 0 0 $X=279620 $Y=1061940
X205 54 2 501 1 INV1S $T=282100 1082480 0 180 $X=280860 $Y=1077060
X206 30 2 503 1 INV1S $T=285200 1082480 1 0 $X=285200 $Y=1077060
X207 496 2 506 1 INV1S $T=293260 1082480 0 0 $X=293260 $Y=1082100
X208 38 2 74 1 INV1S $T=306280 1062320 1 0 $X=306280 $Y=1056900
X209 83 2 27 1 INV1S $T=318060 1082480 0 180 $X=316820 $Y=1077060
X210 43 2 81 1 INV1S $T=329840 1082480 1 180 $X=328600 $Y=1082100
X211 7 2 527 1 INV1S $T=367660 1072400 0 0 $X=367660 $Y=1072020
X212 536 2 133 1 INV1S $T=368280 1082480 0 0 $X=368280 $Y=1082100
X213 47 2 542 1 INV1S $T=373240 1082480 0 0 $X=373240 $Y=1082100
X214 134 2 118 1 INV1S $T=382540 1082480 0 180 $X=381300 $Y=1077060
X215 73 2 102 1 INV1S $T=393700 1082480 1 0 $X=393700 $Y=1077060
X216 124 2 509 1 INV1S $T=398040 1072400 0 0 $X=398040 $Y=1072020
X217 136 2 141 1 INV1S $T=403620 1062320 1 0 $X=403620 $Y=1056900
X218 145 2 76 1 INV1S $T=406100 1062320 1 180 $X=404860 $Y=1061940
X219 150 2 548 1 INV1S $T=419740 1062320 0 180 $X=418500 $Y=1056900
X220 550 2 551 1 INV1S $T=426560 1082480 1 0 $X=426560 $Y=1077060
X221 167 2 147 1 INV1S $T=434620 1082480 0 180 $X=433380 $Y=1077060
X222 168 2 155 1 INV1S $T=438960 1062320 0 0 $X=438960 $Y=1061940
X223 175 2 176 1 INV1S $T=444540 1072400 0 0 $X=444540 $Y=1072020
X224 161 2 183 1 INV1S $T=452600 1062320 0 0 $X=452600 $Y=1061940
X225 184 2 189 1 INV1S $T=455700 1062320 1 0 $X=455700 $Y=1056900
X226 162 2 200 1 INV1S $T=466860 1082480 0 0 $X=466860 $Y=1082100
X227 206 2 205 1 INV1S $T=474920 1082480 0 180 $X=473680 $Y=1077060
X228 190 2 201 1 INV1S $T=478020 1072400 0 0 $X=478020 $Y=1072020
X229 558 2 217 1 INV1S $T=487940 1072400 0 0 $X=487940 $Y=1072020
X230 181 2 218 1 INV1S $T=488560 1082480 0 0 $X=488560 $Y=1082100
X231 577 2 221 1 INV1S $T=494140 1082480 1 180 $X=492900 $Y=1082100
X232 224 2 588 1 INV1S $T=499720 1072400 1 0 $X=499720 $Y=1066980
X233 215 2 592 1 INV1S $T=503440 1082480 0 0 $X=503440 $Y=1082100
X234 198 2 595 1 INV1S $T=513360 1082480 0 0 $X=513360 $Y=1082100
X235 207 2 235 1 INV1S $T=518320 1062320 0 180 $X=517080 $Y=1056900
X236 211 2 238 1 INV1S $T=519560 1062320 1 180 $X=518320 $Y=1061940
X237 607 2 193 1 INV1S $T=526380 1072400 1 180 $X=525140 $Y=1072020
X238 253 2 245 1 INV1S $T=537540 1062320 1 0 $X=537540 $Y=1056900
X239 249 2 225 1 INV1S $T=538780 1082480 1 0 $X=538780 $Y=1077060
X240 251 2 223 1 INV1S $T=559860 1082480 1 0 $X=559860 $Y=1077060
X241 261 2 285 1 INV1S $T=566060 1072400 1 0 $X=566060 $Y=1066980
X242 303 2 634 1 INV1S $T=588380 1082480 1 180 $X=587140 $Y=1082100
X243 300 2 268 1 INV1S $T=593960 1072400 0 180 $X=592720 $Y=1066980
X244 319 2 306 1 INV1S $T=610700 1082480 1 0 $X=610700 $Y=1077060
X245 290 2 327 1 INV1S $T=634880 1072400 1 180 $X=633640 $Y=1072020
X246 329 2 332 1 INV1S $T=636120 1082480 0 0 $X=636120 $Y=1082100
X247 71 1 63 69 2 492 ND3 $T=300080 1062320 1 180 $X=297600 $Y=1061940
X248 504 1 21 514 2 500 ND3 $T=305660 1082480 0 0 $X=305660 $Y=1082100
X249 29 1 50 522 2 83 ND3 $T=318680 1072400 1 0 $X=318680 $Y=1066980
X250 519 1 516 520 2 86 ND3 $T=320540 1082480 0 0 $X=320540 $Y=1082100
X251 500 1 104 523 2 54 ND3 $T=336040 1072400 0 180 $X=333560 $Y=1066980
X252 38 1 105 530 2 46 ND3 $T=336660 1062320 1 0 $X=336660 $Y=1056900
X253 534 1 125 538 2 116 ND3 $T=355260 1072400 1 0 $X=355260 $Y=1066980
X254 109 1 131 547 2 124 ND3 $T=388740 1072400 0 0 $X=388740 $Y=1072020
X255 164 1 168 559 2 167 ND3 $T=435860 1062320 1 0 $X=435860 $Y=1056900
X256 563 1 185 560 2 184 ND3 $T=453220 1062320 0 180 $X=450740 $Y=1056900
X257 194 1 191 571 2 562 ND3 $T=458800 1062320 1 180 $X=456320 $Y=1061940
X258 161 1 188 572 2 199 ND3 $T=462520 1062320 0 0 $X=462520 $Y=1061940
X259 576 1 579 208 2 185 ND3 $T=482980 1062320 1 0 $X=482980 $Y=1056900
X260 161 1 206 583 2 196 ND3 $T=491660 1082480 1 0 $X=491660 $Y=1077060
X261 644 1 633 301 2 304 ND3 $T=586520 1072400 0 0 $X=586520 $Y=1072020
X262 319 1 268 637 2 260 ND3 $T=593960 1082480 0 180 $X=591480 $Y=1077060
X263 244 1 317 326 2 650 ND3 $T=605120 1062320 1 0 $X=605120 $Y=1056900
X264 627 1 619 328 2 330 ND3 $T=631780 1062320 0 0 $X=631780 $Y=1061940
X265 29 1 18 23 7 2 ND3S $T=256060 1062320 1 180 $X=253580 $Y=1061940
X266 498 1 491 45 47 2 ND3S $T=272800 1082480 0 0 $X=272800 $Y=1082100
X267 52 1 51 48 491 2 ND3S $T=281480 1062320 0 180 $X=279000 $Y=1056900
X268 73 1 18 511 50 2 ND3S $T=306280 1072400 1 0 $X=306280 $Y=1066980
X269 86 1 44 84 516 2 ND3S $T=323020 1082480 0 180 $X=320540 $Y=1077060
X270 545 1 120 130 47 2 ND3S $T=367040 1072400 0 180 $X=364560 $Y=1066980
X271 558 1 167 555 164 2 ND3S $T=436480 1072400 0 180 $X=434000 $Y=1066980
X272 156 1 192 566 197 2 ND3S $T=465620 1062320 0 180 $X=463140 $Y=1056900
X273 575 1 577 550 213 2 ND3S $T=481740 1082480 1 0 $X=481740 $Y=1077060
X274 175 1 220 216 182 2 ND3S $T=491040 1062320 0 180 $X=488560 $Y=1056900
X275 578 1 161 224 577 2 ND3S $T=491660 1072400 0 0 $X=491660 $Y=1072020
X276 581 1 215 596 558 2 ND3S $T=505300 1082480 1 0 $X=505300 $Y=1077060
X277 653 1 635 331 609 2 ND3S $T=624960 1082480 0 180 $X=622480 $Y=1077060
X278 30 19 490 2 27 1 25 AN4B1S $T=260400 1072400 0 180 $X=256060 $Y=1066980
X279 30 29 492 2 34 1 36 AN4B1S $T=261640 1062320 0 0 $X=261640 $Y=1061940
X280 35 18 21 2 33 1 32 AN4B1S $T=267220 1062320 0 180 $X=262880 $Y=1056900
X281 35 44 496 2 42 1 494 AN4B1S $T=275280 1072400 1 180 $X=270940 $Y=1072020
X282 30 495 492 2 501 1 499 AN4B1S $T=279000 1072400 0 0 $X=279000 $Y=1072020
X283 504 62 496 2 17 1 66 AN4B1S $T=292640 1062320 1 0 $X=292640 $Y=1056900
X284 502 504 54 2 61 1 510 AN4B1S $T=297600 1082480 0 0 $X=297600 $Y=1082100
X285 44 63 19 2 76 1 513 AN4B1S $T=306900 1072400 0 0 $X=306900 $Y=1072020
X286 24 44 78 2 80 1 515 AN4B1S $T=310620 1062320 1 0 $X=310620 $Y=1056900
X287 51 87 7 2 70 1 521 AN4B1S $T=326120 1062320 0 180 $X=321780 $Y=1056900
X288 525 99 98 2 507 1 92 AN4B1S $T=333560 1062320 0 180 $X=329220 $Y=1056900
X289 96 500 54 2 102 1 526 AN4B1S $T=331080 1082480 1 0 $X=331080 $Y=1077060
X290 120 116 51 2 506 1 112 AN4B1S $T=352160 1062320 1 180 $X=347820 $Y=1061940
X291 139 73 141 2 142 1 544 AN4B1S $T=384400 1062320 1 0 $X=384400 $Y=1056900
X292 141 51 125 2 143 1 546 AN4B1S $T=397420 1062320 0 180 $X=393080 $Y=1056900
X293 175 558 172 2 553 1 552 AN4B1S $T=442680 1082480 0 180 $X=438340 $Y=1077060
X294 182 181 179 2 163 1 554 AN4B1S $T=450740 1082480 0 180 $X=446400 $Y=1077060
X295 174 185 187 2 186 1 561 AN4B1S $T=453220 1072400 0 0 $X=453220 $Y=1072020
X296 194 188 196 2 171 1 567 AN4B1S $T=460660 1072400 1 0 $X=460660 $Y=1066980
X297 168 179 191 2 201 1 570 AN4B1S $T=467480 1072400 1 0 $X=467480 $Y=1066980
X298 206 179 210 2 147 1 568 AN4B1S $T=474920 1072400 1 0 $X=474920 $Y=1066980
X299 220 151 578 2 159 1 585 AN4B1S $T=492280 1062320 0 0 $X=492280 $Y=1061940
X300 577 170 215 2 586 1 591 AN4B1S $T=497860 1082480 1 0 $X=497860 $Y=1077060
X301 558 232 215 2 180 1 598 AN4B1S $T=508400 1072400 0 0 $X=508400 $Y=1072020
X302 579 232 156 2 236 1 599 AN4B1S $T=511500 1062320 0 0 $X=511500 $Y=1061940
X303 169 198 604 2 189 1 601 AN4B1S $T=521420 1082480 1 180 $X=517080 $Y=1082100
X304 615 617 271 2 608 1 275 AN4B1S $T=551800 1072400 0 0 $X=551800 $Y=1072020
X305 622 623 281 2 624 1 627 AN4B1S $T=558620 1072400 1 0 $X=558620 $Y=1066980
X306 621 630 632 2 287 1 288 AN4B1S $T=567300 1062320 1 0 $X=567300 $Y=1056900
X307 638 641 642 2 620 1 644 AN4B1S $T=582800 1082480 1 0 $X=582800 $Y=1077060
X308 590 648 308 2 646 1 311 AN4B1S $T=595200 1072400 1 0 $X=595200 $Y=1066980
X309 651 593 321 2 647 1 320 AN4B1S $T=621240 1072400 1 180 $X=616900 $Y=1072020
X310 322 324 325 2 326 1 653 AN4B1S $T=621860 1062320 0 0 $X=621860 $Y=1061940
X311 31 499 13 497 43 494 1 2 37 OA222 $T=275900 1082480 0 180 $X=270320 $Y=1077060
X312 89 546 64 66 132 544 1 2 127 OA222 $T=369520 1062320 0 180 $X=363940 $Y=1056900
X313 157 551 160 552 162 554 1 2 556 OA222 $T=427180 1082480 0 0 $X=427180 $Y=1082100
X314 157 561 162 557 160 564 1 2 565 OA222 $T=448880 1082480 0 0 $X=448880 $Y=1082100
X315 157 568 160 570 162 567 1 2 574 OA222 $T=466860 1072400 0 0 $X=466860 $Y=1072020
X316 223 585 225 588 227 584 1 2 593 OA222 $T=498480 1072400 0 0 $X=498480 $Y=1072020
X317 241 172 169 605 196 238 1 2 609 OA222 $T=523900 1082480 1 0 $X=523900 $Y=1077060
X318 232 241 247 607 250 600 1 2 252 OA222 $T=530720 1072400 1 0 $X=530720 $Y=1066980
X319 190 235 250 172 146 238 1 2 615 OA222 $T=533200 1072400 0 0 $X=533200 $Y=1072020
X320 227 190 187 238 225 168 1 2 259 OA222 $T=540640 1072400 1 0 $X=540640 $Y=1066980
X321 268 258 170 225 227 598 1 2 617 OA222 $T=548080 1072400 1 180 $X=542500 $Y=1072020
X322 556 228 245 613 261 264 1 2 621 OA222 $T=544980 1082480 0 0 $X=544980 $Y=1082100
X323 262 267 266 263 574 228 1 2 257 OA222 $T=551800 1062320 0 180 $X=546220 $Y=1056900
X324 261 269 264 270 227 604 1 2 623 OA222 $T=549940 1072400 1 0 $X=549940 $Y=1066980
X325 167 242 225 629 240 232 1 2 635 OA222 $T=565440 1082480 1 0 $X=565440 $Y=1077060
X326 284 298 268 293 223 610 1 2 630 OA222 $T=580320 1062320 0 180 $X=574740 $Y=1056900
X327 327 303 652 323 260 639 1 2 651 OA222 $T=625580 1072400 0 180 $X=620000 $Y=1066980
X328 5 2 6 8 1 NR2 $T=232500 1062320 0 0 $X=232500 $Y=1061940
X329 16 2 488 9 1 NR2 $T=244900 1072400 0 180 $X=243040 $Y=1066980
X330 16 2 19 22 1 NR2 $T=249240 1072400 1 0 $X=249240 $Y=1066980
X331 20 2 490 9 1 NR2 $T=252340 1082480 1 180 $X=250480 $Y=1082100
X332 23 2 14 489 1 NR2 $T=254820 1072400 1 180 $X=252960 $Y=1072020
X333 9 2 24 26 1 NR2 $T=253580 1062320 1 0 $X=253580 $Y=1056900
X334 39 2 491 34 1 NR2 $T=267840 1072400 0 180 $X=265980 $Y=1066980
X335 22 2 41 17 1 NR2 $T=269080 1062320 0 0 $X=269080 $Y=1061940
X336 40 2 38 34 1 NR2 $T=271560 1062320 0 180 $X=269700 $Y=1056900
X337 40 2 495 22 1 NR2 $T=272180 1072400 0 180 $X=270320 $Y=1066980
X338 9 2 49 493 1 NR2 $T=277760 1072400 1 0 $X=277760 $Y=1066980
X339 9 2 502 22 1 NR2 $T=283960 1072400 0 180 $X=282100 $Y=1066980
X340 34 2 63 26 1 NR2 $T=283340 1062320 0 0 $X=283340 $Y=1061940
X341 26 2 60 503 1 NR2 $T=288300 1072400 0 180 $X=286440 $Y=1066980
X342 59 2 30 55 1 NR2 $T=288300 1072400 1 180 $X=286440 $Y=1072020
X343 8 2 53 58 1 NR2 $T=290160 1062320 0 180 $X=288300 $Y=1056900
X344 503 2 505 506 1 NR2 $T=289540 1082480 1 0 $X=289540 $Y=1077060
X345 39 2 504 59 1 NR2 $T=292020 1072400 0 180 $X=290160 $Y=1066980
X346 8 2 496 61 1 NR2 $T=290780 1072400 0 0 $X=290780 $Y=1072020
X347 509 2 492 58 1 NR2 $T=295740 1062320 1 180 $X=293880 $Y=1061940
X348 20 2 44 67 1 NR2 $T=294500 1082480 1 0 $X=294500 $Y=1077060
X349 501 2 71 55 1 NR2 $T=303800 1072400 0 180 $X=301940 $Y=1066980
X350 16 2 51 58 1 NR2 $T=318680 1062320 0 0 $X=318680 $Y=1061940
X351 20 2 85 55 1 NR2 $T=325500 1072400 1 180 $X=323640 $Y=1072020
X352 61 2 83 93 1 NR2 $T=325500 1082480 1 0 $X=325500 $Y=1077060
X353 20 2 96 26 1 NR2 $T=329220 1072400 1 180 $X=327360 $Y=1072020
X354 509 2 100 16 1 NR2 $T=331080 1072400 0 180 $X=329220 $Y=1066980
X355 9 2 528 111 1 NR2 $T=338520 1082480 0 0 $X=338520 $Y=1082100
X356 93 2 531 33 1 NR2 $T=342860 1082480 1 0 $X=342860 $Y=1077060
X357 117 2 529 489 1 NR2 $T=348440 1072400 1 180 $X=346580 $Y=1072020
X358 59 2 533 67 1 NR2 $T=350920 1082480 1 180 $X=349060 $Y=1082100
X359 8 2 124 93 1 NR2 $T=351540 1072400 0 0 $X=351540 $Y=1072020
X360 33 2 541 542 1 NR2 $T=358980 1082480 0 0 $X=358980 $Y=1082100
X361 20 2 543 61 1 NR2 $T=363320 1082480 0 0 $X=363320 $Y=1082100
X362 118 2 545 140 1 NR2 $T=372000 1072400 1 0 $X=372000 $Y=1066980
X363 527 2 72 40 1 NR2 $T=372620 1072400 0 0 $X=372620 $Y=1072020
X364 542 2 137 136 1 NR2 $T=376960 1062320 0 0 $X=376960 $Y=1061940
X365 136 2 135 40 1 NR2 $T=380060 1062320 0 180 $X=378200 $Y=1056900
X366 118 2 109 40 1 NR2 $T=381920 1072400 1 180 $X=380060 $Y=1072020
X367 140 2 139 527 1 NR2 $T=383160 1062320 1 180 $X=381300 $Y=1061940
X368 42 2 47 102 1 NR2 $T=387500 1082480 1 0 $X=387500 $Y=1077060
X369 509 2 144 102 1 NR2 $T=398040 1072400 0 180 $X=396180 $Y=1066980
X370 61 2 73 40 1 NR2 $T=403000 1082480 0 180 $X=401140 $Y=1077060
X371 509 2 145 61 1 NR2 $T=405480 1072400 1 180 $X=403620 $Y=1072020
X372 548 2 151 147 1 NR2 $T=414780 1062320 0 0 $X=414780 $Y=1061940
X373 166 2 161 159 1 NR2 $T=431520 1062320 1 180 $X=429660 $Y=1061940
X374 147 2 557 171 1 NR2 $T=429660 1072400 0 0 $X=429660 $Y=1072020
X375 163 2 165 148 1 NR2 $T=434000 1062320 0 180 $X=432140 $Y=1056900
X376 171 2 175 154 1 NR2 $T=440820 1072400 0 0 $X=440820 $Y=1072020
X377 176 2 174 166 1 NR2 $T=444540 1062320 1 180 $X=442680 $Y=1061940
X378 183 2 179 176 1 NR2 $T=450120 1072400 1 180 $X=448260 $Y=1072020
X379 186 2 563 183 1 NR2 $T=453840 1072400 0 180 $X=451980 $Y=1066980
X380 163 2 188 193 1 NR2 $T=456320 1072400 1 0 $X=456320 $Y=1066980
X381 195 2 191 147 1 NR2 $T=462520 1072400 1 180 $X=460660 $Y=1072020
X382 155 2 569 566 1 NR2 $T=466240 1082480 1 0 $X=466240 $Y=1077060
X383 154 2 198 147 1 NR2 $T=468100 1062320 1 0 $X=468100 $Y=1056900
X384 204 2 185 152 1 NR2 $T=471820 1082480 0 180 $X=469960 $Y=1077060
X385 195 2 558 204 1 NR2 $T=477400 1082480 1 0 $X=477400 $Y=1077060
X386 154 2 576 212 1 NR2 $T=478020 1062320 1 0 $X=478020 $Y=1056900
X387 204 2 575 189 1 NR2 $T=480500 1082480 0 0 $X=480500 $Y=1082100
X388 186 2 578 201 1 NR2 $T=482980 1072400 1 180 $X=481120 $Y=1072020
X389 166 2 213 205 1 NR2 $T=482980 1072400 1 0 $X=482980 $Y=1066980
X390 163 2 577 214 1 NR2 $T=486700 1072400 1 180 $X=484840 $Y=1072020
X391 183 2 215 212 1 NR2 $T=488560 1062320 1 180 $X=486700 $Y=1061940
X392 163 2 581 205 1 NR2 $T=486700 1082480 1 0 $X=486700 $Y=1077060
X393 219 2 579 166 1 NR2 $T=493520 1062320 1 0 $X=493520 $Y=1056900
X394 589 2 244 239 1 NR2 $T=520800 1062320 1 0 $X=520800 $Y=1056900
X395 217 2 604 193 1 NR2 $T=521420 1072400 0 0 $X=521420 $Y=1072020
X396 166 2 610 152 1 NR2 $T=527620 1062320 1 0 $X=527620 $Y=1056900
X397 155 2 607 205 1 NR2 $T=528240 1072400 0 0 $X=528240 $Y=1072020
X398 183 2 613 595 1 NR2 $T=535060 1082480 0 0 $X=535060 $Y=1082100
X399 205 2 614 254 1 NR2 $T=538160 1062320 0 0 $X=538160 $Y=1061940
X400 218 2 616 595 1 NR2 $T=541260 1082480 1 180 $X=539400 $Y=1082100
X401 603 2 619 265 1 NR2 $T=545600 1062320 0 0 $X=545600 $Y=1061940
X402 152 2 629 628 1 NR2 $T=567300 1082480 0 0 $X=567300 $Y=1082100
X403 626 2 633 631 1 NR2 $T=569160 1072400 0 0 $X=569160 $Y=1072020
X404 297 2 625 634 1 NR2 $T=574120 1082480 1 180 $X=572260 $Y=1082100
X405 295 2 639 292 1 NR2 $T=578460 1072400 0 180 $X=576600 $Y=1066980
X406 307 2 645 310 1 NR2 $T=596440 1062320 1 0 $X=596440 $Y=1056900
X407 309 2 312 315 1 NR2 $T=600160 1062320 1 0 $X=600160 $Y=1056900
X408 580 2 316 314 1 NR2 $T=602020 1072400 1 0 $X=602020 $Y=1066980
X409 290 2 267 300 1 NR2 $T=611320 1062320 0 0 $X=611320 $Y=1061940
X410 310 2 652 296 1 NR2 $T=615660 1062320 0 0 $X=615660 $Y=1061940
X411 503 2 9 501 498 1 NR3 $T=287060 1082480 1 180 $X=283960 $Y=1082100
X412 501 2 59 61 57 1 NR3 $T=287680 1062320 0 0 $X=287680 $Y=1061940
X413 511 2 501 39 517 1 NR3 $T=308760 1062320 1 180 $X=305660 $Y=1061940
X414 522 2 88 42 518 1 NR3 $T=323640 1072400 1 0 $X=323640 $Y=1066980
X415 33 2 59 27 519 1 NR3 $T=333560 1082480 0 0 $X=333560 $Y=1082100
X416 61 2 58 527 103 1 NR3 $T=335420 1062320 0 0 $X=335420 $Y=1061940
X417 113 2 532 524 108 1 NR3 $T=345340 1062320 0 180 $X=342240 $Y=1056900
X418 27 2 118 527 534 1 NR3 $T=349680 1072400 1 0 $X=349680 $Y=1066980
X419 536 2 493 123 535 1 NR3 $T=353400 1082480 0 0 $X=353400 $Y=1082100
X420 555 2 149 148 549 1 NR3 $T=419740 1072400 0 180 $X=416640 $Y=1066980
X421 550 2 155 154 153 1 NR3 $T=426560 1062320 1 180 $X=423460 $Y=1061940
X422 553 2 159 548 158 1 NR3 $T=430900 1062320 0 180 $X=427800 $Y=1056900
X423 559 2 177 560 178 1 NR3 $T=445160 1062320 1 0 $X=445160 $Y=1056900
X424 176 2 159 180 562 1 NR3 $T=447020 1062320 0 0 $X=447020 $Y=1061940
X425 553 2 195 566 564 1 NR3 $T=460660 1082480 1 0 $X=460660 $Y=1077060
X426 208 2 147 201 202 1 NR3 $T=475540 1062320 0 180 $X=472440 $Y=1056900
X427 583 2 221 586 587 1 NR3 $T=497240 1082480 0 0 $X=497240 $Y=1082100
X428 582 2 592 177 594 1 NR3 $T=506540 1072400 0 180 $X=503440 $Y=1066980
X429 230 2 592 595 597 1 NR3 $T=506540 1082480 0 0 $X=506540 $Y=1082100
X430 209 2 207 211 605 1 NR3 $T=523280 1072400 0 180 $X=520180 $Y=1066980
X431 618 2 255 612 256 1 NR3 $T=543120 1062320 0 180 $X=540020 $Y=1056900
X432 313 2 602 649 318 1 NR3 $T=601400 1082480 1 0 $X=601400 $Y=1077060
X433 97 530 1 51 64 532 2 MOAI1S $T=341000 1062320 0 0 $X=341000 $Y=1061940
X434 122 119 1 521 31 114 2 MOAI1S $T=352160 1062320 0 180 $X=348440 $Y=1056900
X435 200 573 1 569 160 203 2 MOAI1S $T=475540 1082480 1 180 $X=471820 $Y=1082100
X436 249 586 1 260 262 620 2 MOAI1S $T=545600 1082480 1 0 $X=545600 $Y=1077060
X437 251 596 1 272 261 278 2 MOAI1S $T=552420 1082480 1 0 $X=552420 $Y=1077060
X438 251 566 1 273 276 283 2 MOAI1S $T=554900 1062320 1 0 $X=554900 $Y=1056900
X439 292 290 1 607 223 631 2 MOAI1S $T=573500 1072400 0 180 $X=569780 $Y=1066980
X440 204 636 1 289 639 646 2 MOAI1S $T=578460 1072400 0 0 $X=578460 $Y=1072020
X441 299 285 1 228 305 647 2 MOAI1S $T=597060 1072400 1 180 $X=593340 $Y=1072020
X442 306 309 1 587 225 649 2 MOAI1S $T=597060 1082480 0 0 $X=597060 $Y=1082100
X443 280 611 264 284 2 1 286 OA112 $T=562340 1062320 0 0 $X=562340 $Y=1061940
X444 277 643 645 272 2 1 641 OA112 $T=593340 1062320 1 180 $X=588380 $Y=1061940
X445 18 540 134 1 2 ND2 $T=373240 1062320 0 0 $X=373240 $Y=1061940
X446 134 536 131 1 2 ND2 $T=374480 1082480 1 0 $X=374480 $Y=1077060
X447 174 173 170 1 2 ND2 $T=442680 1062320 0 180 $X=440820 $Y=1056900
X448 181 553 190 1 2 ND2 $T=455080 1082480 1 0 $X=455080 $Y=1077060
X449 181 573 215 1 2 ND2 $T=484840 1082480 0 0 $X=484840 $Y=1082100
X450 581 234 172 1 2 ND2 $T=510880 1082480 1 0 $X=510880 $Y=1077060
X451 223 606 242 1 2 ND2 $T=527620 1072400 0 180 $X=525760 $Y=1066980
X452 232 586 190 1 2 ND2 $T=536300 1082480 0 180 $X=534440 $Y=1077060
X453 196 254 187 1 2 ND2 $T=541260 1062320 0 0 $X=541260 $Y=1061940
X454 225 636 240 1 2 ND2 $T=574740 1072400 1 180 $X=572880 $Y=1072020
X455 296 280 300 1 2 ND2 $T=579080 1062320 0 0 $X=579080 $Y=1061940
X456 289 640 272 1 2 ND2 $T=587760 1072400 1 0 $X=587760 $Y=1066980
X457 502 104 43 1 2 107 AO12 $T=338520 1072400 1 0 $X=338520 $Y=1066980
X458 150 579 227 1 2 237 AO12 $T=510880 1062320 1 0 $X=510880 $Y=1056900
X459 291 258 267 1 2 643 AO12 $T=582800 1062320 0 0 $X=582800 $Y=1061940
X460 242 179 294 637 2 1 638 MAOI1S $T=574740 1082480 1 0 $X=574740 $Y=1077060
X461 192 247 289 291 227 179 2 1 632 OA222S $T=570400 1062320 0 0 $X=570400 $Y=1061940
X462 488 5 11 2 1 ND2S $T=239320 1062320 1 0 $X=239320 $Y=1056900
X463 150 582 232 2 1 ND2S $T=507160 1062320 0 0 $X=507160 $Y=1061940
X464 169 628 206 2 1 ND2S $T=564820 1082480 1 180 $X=562960 $Y=1082100
X465 510 64 1 512 13 2 513 75 31 OAI222S $T=306900 1082480 1 0 $X=306900 $Y=1077060
X466 528 89 1 529 43 2 531 106 64 OAI222S $T=337900 1072400 0 0 $X=337900 $Y=1072020
X467 539 82 1 541 128 2 543 126 31 OAI222S $T=357740 1072400 0 0 $X=357740 $Y=1072020
X468 172 223 1 594 235 2 599 603 225 OAI222S $T=510260 1072400 1 0 $X=510260 $Y=1066980
X469 601 245 1 228 565 2 185 608 223 OAI222S $T=530720 1082480 1 180 $X=525140 $Y=1082100
X470 597 227 1 282 273 2 228 626 279 OAI222S $T=564820 1072400 1 180 $X=559240 $Y=1072020
X471 64 505 1 65 507 508 2 OAI112HS $T=294500 1072400 0 0 $X=294500 $Y=1072020
X472 245 614 1 277 624 280 2 OAI112HS $T=556140 1062320 0 0 $X=556140 $Y=1061940
X473 31 1 517 89 90 91 2 OAI22S $T=323020 1062320 0 0 $X=323020 $Y=1061940
X474 43 1 101 31 524 526 2 OAI22S $T=331700 1072400 0 0 $X=331700 $Y=1072020
X475 223 1 578 226 589 228 2 OAI22S $T=499100 1062320 1 0 $X=499100 $Y=1056900
X476 238 1 549 235 602 591 2 OAI22S $T=519560 1082480 0 180 $X=515840 $Y=1077060
X477 223 1 616 274 618 625 2 OAI22S $T=554900 1082480 0 0 $X=554900 $Y=1082100
X478 240 197 192 242 2 1 622 OA22S $T=549940 1062320 0 0 $X=549940 $Y=1061940
X479 610 248 2 247 1 612 AOI12HS $T=531960 1062320 1 0 $X=531960 $Y=1056900
X480 240 243 155 606 2 1 246 MAOI1 $T=524520 1062320 0 0 $X=524520 $Y=1061940
X481 72 493 2 70 1 497 AN3B2S $T=303180 1082480 0 180 $X=299460 $Y=1077060
X482 116 42 2 547 1 138 AN3B2S $T=389980 1072400 0 180 $X=386260 $Y=1066980
X483 194 219 2 582 1 584 AN3B2S $T=490420 1072400 1 0 $X=490420 $Y=1066980
X484 604 189 2 173 1 600 AN3B2S $T=518940 1072400 1 180 $X=515220 $Y=1072020
X485 70 509 1 12 2 508 OAI12HS $T=301320 1072400 0 0 $X=301320 $Y=1072020
X486 229 582 1 231 2 233 OAI12HS $T=505300 1062320 1 0 $X=505300 $Y=1056900
X487 571 207 209 572 560 211 1 2 580 AO222 $T=474920 1062320 0 0 $X=474920 $Y=1061940
X488 51 42 1 2 INV2 $T=368280 1062320 0 0 $X=368280 $Y=1061940
X489 146 152 1 2 INV2 $T=414780 1072400 0 0 $X=414780 $Y=1072020
X490 169 159 1 2 INV2 $T=437100 1062320 1 180 $X=435240 $Y=1061940
X491 192 154 1 2 INV2 $T=458800 1062320 1 0 $X=458800 $Y=1056900
X492 8 2 9 1 7 NR2P $T=236840 1072400 1 0 $X=236840 $Y=1066980
X493 147 2 152 1 156 NR2P $T=425320 1062320 0 180 $X=421600 $Y=1056900
X494 88 109 2 110 500 1 OR3B2 $T=347200 1072400 0 180 $X=343480 $Y=1066980
X495 111 533 2 115 535 1 OR3B2 $T=346580 1082480 1 0 $X=346580 $Y=1077060
X496 117 120 2 537 116 1 OR3B2 $T=360840 1062320 0 0 $X=360840 $Y=1061940
X497 85 72 516 2 1 512 AN3 $T=321160 1072400 1 180 $X=317440 $Y=1072020
X498 518 82 515 64 2 1 77 OA22 $T=316200 1072400 0 180 $X=311860 $Y=1066980
X499 504 72 41 1 2 68 AN3S $T=303180 1062320 0 180 $X=299460 $Y=1056900
X500 487 10 1 2 INV12CK $T=234360 1082480 0 0 $X=234360 $Y=1082100
.ENDS
***************************************
.SUBCKT BUF2CK I O GND VCC
** N=5 EP=4 IP=0 FDC=0
.ENDS
***************************************
.SUBCKT ICV_4 1 2 3 4 5 6 7 8 9
** N=9 EP=9 IP=12 FDC=0
X0 1 2 3 4 5 QDFFN $T=0 0 0 0 $X=0 $Y=-380
X1 6 7 8 4 5 QDFFN $T=10540 0 0 0 $X=10540 $Y=-380
.ENDS
***************************************
.SUBCKT INV3CK I GND VCC O
** N=5 EP=4 IP=0 FDC=0
.ENDS
***************************************
.SUBCKT BUF1CK I GND VCC O
** N=5 EP=4 IP=0 FDC=0
.ENDS
***************************************
.SUBCKT ICV_5 1 2 3 4 5 6 7 8 9
** N=9 EP=9 IP=12 FDC=0
X0 1 2 3 4 5 QDFFN $T=0 0 1 180 $X=-10540 $Y=-380
X1 6 7 8 4 5 QDFFN $T=0 0 0 0 $X=0 $Y=-380
.ENDS
***************************************
.SUBCKT BUF1S I GND VCC O
** N=5 EP=4 IP=0 FDC=0
.ENDS
***************************************
.SUBCKT ICV_6 1 2 3 4 5 6 7 8 9
** N=9 EP=9 IP=12 FDC=0
X0 1 2 3 4 5 QDFFN $T=0 0 0 0 $X=0 $Y=-380
X1 6 7 8 4 5 QDFFN $T=21080 0 1 180 $X=10540 $Y=-380
.ENDS
***************************************
.SUBCKT DELB I GND VCC O
** N=5 EP=4 IP=0 FDC=0
.ENDS
***************************************
.SUBCKT BUF1 I VCC GND O
** N=5 EP=4 IP=0 FDC=0
.ENDS
***************************************
.SUBCKT BUF3 I VCC GND O
** N=5 EP=4 IP=0 FDC=0
.ENDS
***************************************
.SUBCKT INV8CK I O GND VCC
** N=5 EP=4 IP=0 FDC=0
.ENDS
***************************************
.SUBCKT AO22 O A2 A1 VCC B1 B2 GND
** N=8 EP=7 IP=0 FDC=0
.ENDS
***************************************
.SUBCKT MXL2HS B S OB A VCC GND
** N=7 EP=6 IP=0 FDC=0
.ENDS
***************************************
.SUBCKT DELA I GND VCC O
** N=5 EP=4 IP=0 FDC=0
.ENDS
***************************************
.SUBCKT QDFFRBN D CK RB VCC GND Q
** N=7 EP=6 IP=0 FDC=0
.ENDS
***************************************
.SUBCKT QDFFRBP D CK RB Q GND VCC
** N=7 EP=6 IP=0 FDC=0
.ENDS
***************************************
.SUBCKT XOR4 I1 I2 O I3 VCC GND I4
** N=8 EP=7 IP=0 FDC=0
.ENDS
***************************************
.SUBCKT BUF12CK I GND VCC O
** N=5 EP=4 IP=0 FDC=0
.ENDS
***************************************
.SUBCKT BUF2 I O GND VCC
** N=5 EP=4 IP=0 FDC=0
.ENDS
***************************************
.SUBCKT BUF6 I O GND VCC
** N=5 EP=4 IP=0 FDC=0
.ENDS
***************************************
.SUBCKT INV3 I O GND VCC
** N=5 EP=4 IP=0 FDC=0
.ENDS
***************************************
.SUBCKT BUF4 I O GND VCC
** N=5 EP=4 IP=0 FDC=0
.ENDS
***************************************
.SUBCKT DFFSBN D CK SB Q GND VCC QB
** N=8 EP=7 IP=0 FDC=0
.ENDS
***************************************
.SUBCKT OR3 I3 I2 I1 VCC GND O
** N=7 EP=6 IP=0 FDC=0
.ENDS
***************************************
.SUBCKT FA1S CO VCC A B CI GND S
** N=8 EP=7 IP=0 FDC=0
.ENDS
***************************************
.SUBCKT XNR2HS I1 I2 O VCC GND
** N=6 EP=5 IP=0 FDC=0
.ENDS
***************************************
.SUBCKT XOR2HS I1 I2 O VCC GND
** N=6 EP=5 IP=0 FDC=0
.ENDS
***************************************
.SUBCKT OA112S A1 B1 C1 C2 VCC GND O
** N=8 EP=7 IP=0 FDC=0
.ENDS
***************************************
.SUBCKT OA12 B2 B1 A1 GND VCC O
** N=7 EP=6 IP=0 FDC=0
.ENDS
***************************************
.SUBCKT OR2 I2 I1 VCC GND O
** N=6 EP=5 IP=0 FDC=0
.ENDS
***************************************
.SUBCKT OR3S I3 I2 I1 VCC GND O
** N=7 EP=6 IP=0 FDC=0
.ENDS
***************************************
.SUBCKT OR2S I2 I1 VCC GND O
** N=6 EP=5 IP=0 FDC=0
.ENDS
***************************************
.SUBCKT OA12S B2 B1 A1 VCC GND O
** N=7 EP=6 IP=0 FDC=0
.ENDS
***************************************
.SUBCKT OA13S B3 B2 B1 A1 GND VCC O
** N=8 EP=7 IP=0 FDC=0
.ENDS
***************************************
.SUBCKT AO13S B3 B2 B1 A1 GND VCC O
** N=8 EP=7 IP=0 FDC=0
.ENDS
***************************************
.SUBCKT AOI13HS B3 O B2 B1 VCC A1 GND
** N=8 EP=7 IP=0 FDC=0
.ENDS
***************************************
.SUBCKT AO112 O C2 C1 VCC B1 GND A1
** N=8 EP=7 IP=0 FDC=0
.ENDS
***************************************
.SUBCKT MOAI1 B1 B2 GND A1 O A2 VCC
** N=8 EP=7 IP=0 FDC=0
.ENDS
***************************************
.SUBCKT OA13 B3 B2 B1 A1 VCC GND O
** N=8 EP=7 IP=0 FDC=0
.ENDS
***************************************
.SUBCKT AN2S I1 I2 GND O VCC
** N=6 EP=5 IP=0 FDC=0
.ENDS
***************************************
.SUBCKT MUX2 B S VCC GND O A
** N=7 EP=6 IP=0 FDC=0
.ENDS
***************************************
.SUBCKT AO12S B2 B1 A1 GND VCC O
** N=7 EP=6 IP=0 FDC=0
.ENDS
***************************************
.SUBCKT AN4S I1 I2 I4 I3 VCC GND O
** N=8 EP=7 IP=0 FDC=0
.ENDS
***************************************
.SUBCKT AN3B1 B1 I2 I1 GND VCC O
** N=7 EP=6 IP=0 FDC=0
.ENDS
***************************************
.SUBCKT AN2B1S I1 VCC B1 O GND
** N=6 EP=5 IP=0 FDC=0
.ENDS
***************************************
.SUBCKT OR3B2S I1 B1 VCC O B2 GND
** N=7 EP=6 IP=0 FDC=0
.ENDS
***************************************
.SUBCKT ICV_7 1 2 3 4 5 6 7 8 9 10 11 12 13 14 15 16 17 18 19 20
+ 21 22 23 24 25 26 27 28 29 30 31 32 33 34 35 36 37 38 39 40
+ 41 42 43 44 45 46 47 48 49 50 51 52 53 54 55 56 57 58 59 60
+ 61 62 63 64 65 66 67 68 69 70 71 72 73 74 75 76 77 78 79 80
+ 81 82 83 84 85 86 87 88 89 90 91 92 93 94 95 96 97 98 99 100
+ 101 102 103 104 105 106 107 108 109 110 111 112 113 114 115 116 117 118 119 120
+ 121 122 123 124 125 126 127 128 129 130 131 132 133 134 135 136 137 138 139 140
+ 141 142 143 144 145 146 147 148 149 150 151 152 153 154 155 156 157 158 159 160
+ 161 162 163 164 165 166 167 168 169 170 171 172 173 174 175 176 177 178 179 180
+ 181 182 183 184 185 186 187 188 189 190 191 192 193 194 195 196 197 198 199 200
+ 201 202 203 204 205 206 207 208 209 210 211 212 213 214 215 216 217 218 219 220
+ 221 222 223 224 225 226 227 228 229 230 231 232 233 234 235 236 237 238 239 240
+ 241 242 243 244 245 246 247 248 249 250 251 252 253 254 255 256 257 258 259 260
+ 261 262 263 264 265 266 267 268 269 270 271 272 273 274 275 276 277 278 279 280
+ 281 282 283 284 285 286 287 288 289 290 291 292 293 294 295 296 297 298 299 300
+ 301 302 303 304 305 306 307 308 309 310 311 312 313 314 315 316 317 318 319 320
+ 321 322 323 324 325 326 327 328 329 330 331 332 333 334 335 336 337 338 339 340
+ 341 342 343 344 345 346 347 348 349 350 351 352 353 354 355 356 357 358 359 360
+ 361 362 363 364 365 366 367 368 369 370 371 372 373 374 375 376 377 378 379 380
+ 381 382 383 384 385 386 387 388 389 390 391 392 393 394 395 396 397 398 399 400
+ 401 402 403 404 405 406 407 408 409 410 411 412 413 414 415 416 417 418 419 420
+ 421 422 423 424 425 426 427 428 429 430 431 432 433 434 435 436 437 438 439 440
+ 441 442 443 444 445 446 447 448 449 450 451 452 453 454 455 456 457 458 459 460
+ 461 462 463 464 465 466 467 468 469 470 471 472 473 474 475 476 477 478 479 480
+ 481 482 483 484 485 486 487 488 489 490 491 492 493 494 495 496 497 498 499 500
+ 501 502 503 504 505 506 507 508 509 510 511 512 513 514 515 516 517 518 519 520
+ 521 522 523 524 525 526 527 528 529 530 531 532 533 534 535 536 537 538 539 540
+ 541 542 543 544 545 546 547 548 549 550 551 552 553 554 555 556 557 558 559 560
+ 561 562 563 564 565 566 567 568 569 570 571 572 573 574 575 576 577 578 579 580
+ 581 582 583 584 585 586 587 588 589 590 591 592 593 594 595 596 597 598 599 600
+ 601 602 603 604 605 606 607 608 609 610 611 612 613 614 615 616 617 618 619 620
+ 621 622 623 624 625 626 627 628 629 630 631 632 633 634 635 636 637 638 639 640
+ 641 642 643 644 645 646 647 648 649 650 651 652 653 654 655 656 657 658 659 660
+ 661 662 663 664 665 666 667 668 669 670 671 672 673 674 675 676 677 678 679 680
+ 681 682 683 684 685 686 687 688 689 690 691 692 693 694 695 696 697 698 699 700
+ 701 702 703 704 705 706 707 708 709 710 711 712 713 714 715 716 717 718 719 720
+ 721 722 723 724 725 726 727 728 729 730 731 732 733 734 735 736 737 738 739 740
+ 741 742 743 744 745 746 747 748 749 750 751 752 753 754 755 756 757 758 759 760
+ 761 762 763 764 765 766 767 768 769 770 771 772 773 774 775 776 777 778 779 780
+ 781 782 783 784 785 786 787 788 789 790 791 792 793 794 795 796 797 798 799 800
+ 801 802 803 804 805 806 807 808 809 810 811 812 813 814 815 816 817 818 819 820
+ 821 822 823 824 825 826 827 828 829 830 831 832 833 834 835 836 837 838 839 840
+ 841 842 843 844 845 846 847 848 849 850 851 852 853 854 855 856 857 858 859 860
+ 861 862 863 864 865 866 867 868 869 870 871 872 873 874 875 876 877 878 879 880
+ 881 882 883 884 885 886 887 888 889 890 891 892 893 894 895 896 897 898 899 900
+ 901 902 903 904 905 906 907 908 909 910 911 912 913 914 915 916 917 918 919 920
+ 921 922 923 924 925 926 927 928 929 930 931 932 933 934 935 936 937 938 939 940
+ 941 942 943 944 945 946 947 948 949 950 951 952 953 954 955 956 957 958 959 960
+ 961 962 963 964 965 966 967 968 969 970 971 972 973 974 975 976 977 978 979 980
+ 981 982 983 984 985 986 987 988 989 990 991 992 993 994 995 996 997 998 999 1000
+ 1001 1002 1003 1008 1021
** N=4409 EP=1005 IP=25766 FDC=0
X0 1001 1002 1002 1002 1003 1002 1008 YA2GSD $T=1309440 949580 0 90 $X=1169940 $Y=952430
X1 644 645 2895 1 2 QDFFN $T=652860 1052240 1 180 $X=642320 $Y=1051860
X2 2927 2923 2898 1 2 QDFFN $T=654100 991760 1 180 $X=643560 $Y=991380
X3 650 2923 2915 1 2 QDFFN $T=657820 1001840 1 180 $X=647280 $Y=1001460
X4 651 2923 2916 1 2 QDFFN $T=658440 1022000 0 180 $X=647900 $Y=1016580
X5 2909 645 2934 1 2 QDFFN $T=649140 1042160 0 0 $X=649140 $Y=1041780
X6 644 2923 2944 1 2 QDFFN $T=649760 1032080 0 0 $X=649760 $Y=1031700
X7 2927 2931 2949 1 2 QDFFN $T=654720 991760 0 0 $X=654720 $Y=991380
X8 651 2931 2951 1 2 QDFFN $T=655340 1011920 0 0 $X=655340 $Y=1011540
X9 650 2931 2946 1 2 QDFFN $T=655960 1011920 1 0 $X=655960 $Y=1006500
X10 644 2931 2954 1 2 QDFFN $T=656580 1032080 1 0 $X=656580 $Y=1026660
X11 2909 656 2962 1 2 QDFFN $T=657200 1052240 1 0 $X=657200 $Y=1046820
X12 2927 2939 2971 1 2 QDFFN $T=658440 971600 1 0 $X=658440 $Y=966180
X13 644 2939 2986 1 2 QDFFN $T=664020 951440 1 0 $X=664020 $Y=946020
X14 2927 2988 2957 1 2 QDFFN $T=677040 981680 1 180 $X=666500 $Y=981300
X15 650 2988 2956 1 2 QDFFN $T=677040 1001840 0 180 $X=666500 $Y=996420
X16 651 2988 2958 1 2 QDFFN $T=677660 1011920 1 180 $X=667120 $Y=1011540
X17 689 2939 2967 1 2 QDFFN $T=679520 931280 0 180 $X=668980 $Y=925860
X18 644 2930 3001 1 2 QDFFN $T=668980 941360 1 0 $X=668980 $Y=935940
X19 2927 2975 2993 1 2 QDFFN $T=669600 971600 0 0 $X=669600 $Y=971220
X20 690 2930 2982 1 2 QDFFN $T=682620 911120 0 180 $X=672080 $Y=905700
X21 644 2975 3007 1 2 QDFFN $T=673320 931280 0 0 $X=673320 $Y=930900
X22 644 685 696 1 2 QDFFN $T=673940 1052240 0 0 $X=673940 $Y=1051860
X23 2909 685 3008 1 2 QDFFN $T=675800 1042160 1 0 $X=675800 $Y=1036740
X24 644 2988 3015 1 2 QDFFN $T=676420 1032080 1 0 $X=676420 $Y=1026660
X25 644 2999 3026 1 2 QDFFN $T=677040 991760 1 0 $X=677040 $Y=986340
X26 689 2930 2994 1 2 QDFFN $T=688200 921200 0 180 $X=677660 $Y=915780
X27 2927 3016 2973 1 2 QDFFN $T=688200 991760 1 180 $X=677660 $Y=991380
X28 650 3016 2992 1 2 QDFFN $T=688200 1001840 0 180 $X=677660 $Y=996420
X29 2927 2999 3022 1 2 QDFFN $T=678280 981680 0 0 $X=678280 $Y=981300
X30 687 3016 3000 1 2 QDFFN $T=688820 1011920 1 180 $X=678280 $Y=1011540
X31 687 2930 3018 1 2 QDFFN $T=680140 961520 0 0 $X=680140 $Y=961140
X32 651 3016 2978 1 2 QDFFN $T=690680 1011920 0 180 $X=680140 $Y=1006500
X33 687 2931 3027 1 2 QDFFN $T=680140 1032080 0 0 $X=680140 $Y=1031700
X34 690 2939 3024 1 2 QDFFN $T=680760 901040 0 0 $X=680760 $Y=900660
X35 689 2975 2996 1 2 QDFFN $T=691300 931280 0 180 $X=680760 $Y=925860
X36 692 2930 3034 1 2 QDFFN $T=680760 941360 1 0 $X=680760 $Y=935940
X37 687 2939 3010 1 2 QDFFN $T=691920 961520 0 180 $X=681380 $Y=956100
X38 687 2975 3020 1 2 QDFFN $T=681380 971600 0 0 $X=681380 $Y=971220
X39 692 2939 3014 1 2 QDFFN $T=694400 951440 0 180 $X=683860 $Y=946020
X40 692 2975 3039 1 2 QDFFN $T=684480 931280 0 0 $X=684480 $Y=930900
X41 687 685 3052 1 2 QDFFN $T=684480 1052240 1 0 $X=684480 $Y=1046820
X42 644 3016 3005 1 2 QDFFN $T=695640 1022000 0 180 $X=685100 $Y=1016580
X43 644 704 699 1 2 QDFFN $T=696260 1052240 1 180 $X=685720 $Y=1051860
X44 2927 704 3003 1 2 QDFFN $T=697500 1042160 1 180 $X=686960 $Y=1041780
X45 650 2999 3047 1 2 QDFFN $T=687580 1001840 0 0 $X=687580 $Y=1001460
X46 687 2923 3023 1 2 QDFFN $T=698740 1042160 0 180 $X=688200 $Y=1036740
X47 701 2939 3045 1 2 QDFFN $T=690680 921200 1 0 $X=690680 $Y=915780
X48 701 2975 3059 1 2 QDFFN $T=691300 921200 0 0 $X=691300 $Y=920820
X49 651 2930 3053 1 2 QDFFN $T=691300 961520 0 0 $X=691300 $Y=961140
X50 687 2988 3032 1 2 QDFFN $T=702460 1011920 0 180 $X=691920 $Y=1006500
X51 690 2975 3033 1 2 QDFFN $T=703080 901040 1 180 $X=692540 $Y=900660
X52 692 3042 3076 1 2 QDFFN $T=692540 941360 1 0 $X=692540 $Y=935940
X53 687 2999 3077 1 2 QDFFN $T=692540 981680 1 0 $X=692540 $Y=976260
X54 692 2931 3071 1 2 QDFFN $T=692540 1032080 0 0 $X=692540 $Y=1031700
X55 651 2975 3058 1 2 QDFFN $T=693160 971600 0 0 $X=693160 $Y=971220
X56 651 2939 3043 1 2 QDFFN $T=704320 961520 0 180 $X=693780 $Y=956100
X57 644 3042 3084 1 2 QDFFN $T=695640 951440 1 0 $X=695640 $Y=946020
X58 701 2930 3051 1 2 QDFFN $T=706800 931280 1 180 $X=696260 $Y=930900
X59 692 2999 3094 1 2 QDFFN $T=697500 991760 0 0 $X=697500 $Y=991380
X60 692 2988 3096 1 2 QDFFN $T=698740 1011920 0 0 $X=698740 $Y=1011540
X61 705 2975 3098 1 2 QDFFN $T=699360 901040 1 0 $X=699360 $Y=895620
X62 651 2999 3095 1 2 QDFFN $T=699360 1001840 0 0 $X=699360 $Y=1001460
X63 692 2923 3063 1 2 QDFFN $T=711760 1042160 0 180 $X=701220 $Y=1036740
X64 701 3042 3111 1 2 QDFFN $T=702460 921200 0 0 $X=702460 $Y=920820
X65 705 2930 3091 1 2 QDFFN $T=703080 921200 1 0 $X=703080 $Y=915780
X66 705 2939 3075 1 2 QDFFN $T=714240 901040 1 180 $X=703700 $Y=900660
X67 687 704 3062 1 2 QDFFN $T=714240 1052240 0 180 $X=703700 $Y=1046820
X68 705 2988 3121 1 2 QDFFN $T=704320 1011920 1 0 $X=704320 $Y=1006500
X69 705 2931 3130 1 2 QDFFN $T=704320 1032080 0 0 $X=704320 $Y=1031700
X70 687 3042 3129 1 2 QDFFN $T=704940 981680 1 0 $X=704940 $Y=976260
X71 644 3104 3088 1 2 QDFFN $T=716100 961520 0 180 $X=705560 $Y=956100
X72 687 645 3068 1 2 QDFFN $T=716100 1052240 1 180 $X=705560 $Y=1051860
X73 2927 3042 3127 1 2 QDFFN $T=706800 971600 1 0 $X=706800 $Y=966180
X74 701 3104 3119 1 2 QDFFN $T=708040 931280 0 0 $X=708040 $Y=930900
X75 692 3104 3097 1 2 QDFFN $T=718580 941360 0 180 $X=708040 $Y=935940
X76 692 3016 3083 1 2 QDFFN $T=720440 1022000 0 180 $X=709900 $Y=1016580
X77 705 2999 3106 1 2 QDFFN $T=721680 1001840 1 180 $X=711140 $Y=1001460
X78 705 704 3149 1 2 QDFFN $T=711760 1042160 0 0 $X=711760 $Y=1041780
X79 705 2923 3122 1 2 QDFFN $T=724160 1042160 0 180 $X=713620 $Y=1036740
X80 705 3042 3126 1 2 QDFFN $T=725400 901040 1 180 $X=714860 $Y=900660
X81 650 3042 3178 1 2 QDFFN $T=716720 951440 1 0 $X=716720 $Y=946020
X82 651 3042 3168 1 2 QDFFN $T=716720 981680 1 0 $X=716720 $Y=976260
X83 701 2931 3170 1 2 QDFFN $T=716720 1032080 0 0 $X=716720 $Y=1031700
X84 650 3104 3172 1 2 QDFFN $T=717340 961520 0 0 $X=717340 $Y=961140
X85 705 685 3167 1 2 QDFFN $T=717960 1052240 0 0 $X=717960 $Y=1051860
X86 2927 3104 3117 1 2 QDFFN $T=729120 971600 0 180 $X=718580 $Y=966180
X87 705 3104 3138 1 2 QDFFN $T=729740 911120 0 180 $X=719200 $Y=905700
X88 689 3104 3162 1 2 QDFFN $T=732840 921200 1 180 $X=722300 $Y=920820
X89 701 2988 3161 1 2 QDFFN $T=732840 1001840 1 180 $X=722300 $Y=1001460
X90 701 645 3200 1 2 QDFFN $T=724160 1042160 0 0 $X=724160 $Y=1041780
X91 689 2931 3177 1 2 QDFFN $T=736560 1022000 0 180 $X=726020 $Y=1016580
X92 701 2923 3174 1 2 QDFFN $T=736560 1042160 0 180 $X=726020 $Y=1036740
X93 650 3188 3186 1 2 QDFFN $T=738420 951440 1 180 $X=727880 $Y=951060
X94 689 2923 3180 1 2 QDFFN $T=738420 1032080 0 180 $X=727880 $Y=1026660
X95 650 3217 3190 1 2 QDFFN $T=739660 961520 1 180 $X=729120 $Y=961140
X96 651 3217 3194 1 2 QDFFN $T=740900 991760 0 180 $X=730360 $Y=986340
X97 701 3188 3229 1 2 QDFFN $T=730980 941360 1 0 $X=730980 $Y=935940
X98 689 3042 3201 1 2 QDFFN $T=742140 911120 0 180 $X=731600 $Y=905700
X99 689 2999 3205 1 2 QDFFN $T=744000 1001840 0 180 $X=733460 $Y=996420
X100 701 704 3226 1 2 QDFFN $T=733460 1052240 1 0 $X=733460 $Y=1046820
X101 689 2988 3252 1 2 QDFFN $T=735320 1011920 1 0 $X=735320 $Y=1006500
X102 690 2923 3244 1 2 QDFFN $T=736560 1042160 0 0 $X=736560 $Y=1041780
X103 690 2931 3254 1 2 QDFFN $T=738420 1032080 0 0 $X=738420 $Y=1031700
X104 705 3188 3263 1 2 QDFFN $T=739040 931280 1 0 $X=739040 $Y=925860
X105 687 3217 3224 1 2 QDFFN $T=750200 981680 1 180 $X=739660 $Y=981300
X106 690 2988 3230 1 2 QDFFN $T=751440 1022000 1 180 $X=740900 $Y=1021620
X107 689 3188 3266 1 2 QDFFN $T=741520 931280 0 0 $X=741520 $Y=930900
X108 644 3217 3215 1 2 QDFFN $T=752680 951440 1 180 $X=742140 $Y=951060
X109 690 2999 3237 1 2 QDFFN $T=752680 991760 0 180 $X=742140 $Y=986340
X110 736 3016 3282 1 2 QDFFN $T=742140 1022000 1 0 $X=742140 $Y=1016580
X111 687 3188 3228 1 2 QDFFN $T=753300 981680 0 180 $X=742760 $Y=976260
X112 690 3104 3276 1 2 QDFFN $T=744000 911120 1 0 $X=744000 $Y=905700
X113 736 3042 3278 1 2 QDFFN $T=744000 971600 0 0 $X=744000 $Y=971220
X114 692 3217 3239 1 2 QDFFN $T=755780 951440 0 180 $X=745240 $Y=946020
X115 737 3016 3295 1 2 QDFFN $T=745240 1001840 1 0 $X=745240 $Y=996420
X116 736 704 3255 1 2 QDFFN $T=755780 1052240 0 180 $X=745240 $Y=1046820
X117 736 2999 3286 1 2 QDFFN $T=745860 991760 0 0 $X=745860 $Y=991380
X118 736 2931 3284 1 2 QDFFN $T=746480 1032080 1 0 $X=746480 $Y=1026660
X119 701 3217 3238 1 2 QDFFN $T=758880 941360 1 180 $X=748340 $Y=940980
X120 736 2923 3277 1 2 QDFFN $T=748340 1042160 0 0 $X=748340 $Y=1041780
X121 736 2939 3303 1 2 QDFFN $T=751440 941360 1 0 $X=751440 $Y=935940
X122 736 3104 3272 1 2 QDFFN $T=761980 961520 1 180 $X=751440 $Y=961140
X123 736 3217 3299 1 2 QDFFN $T=751440 981680 0 0 $X=751440 $Y=981300
X124 747 3016 3308 1 2 QDFFN $T=752680 1011920 0 0 $X=752680 $Y=1011540
X125 736 2988 3300 1 2 QDFFN $T=752680 1022000 0 0 $X=752680 $Y=1021620
X126 690 3217 3302 1 2 QDFFN $T=753920 921200 1 0 $X=753920 $Y=915780
X127 736 3188 3307 1 2 QDFFN $T=754540 981680 1 0 $X=754540 $Y=976260
X128 690 3188 3316 1 2 QDFFN $T=755160 931280 0 0 $X=755160 $Y=930900
X129 690 3042 3280 1 2 QDFFN $T=766940 911120 1 180 $X=756400 $Y=910740
X130 737 704 3325 1 2 QDFFN $T=757020 1052240 1 0 $X=757020 $Y=1046820
X131 737 2931 3340 1 2 QDFFN $T=761360 991760 0 0 $X=761360 $Y=991380
X132 747 2999 3312 1 2 QDFFN $T=773140 981680 1 180 $X=762600 $Y=981300
X133 747 3217 3351 1 2 QDFFN $T=763220 931280 1 0 $X=763220 $Y=925860
X134 737 2930 3357 1 2 QDFFN $T=763220 941360 1 0 $X=763220 $Y=935940
X135 737 3042 3353 1 2 QDFFN $T=763220 971600 0 0 $X=763220 $Y=971220
X136 3342 2931 3320 1 2 QDFFN $T=775000 1011920 1 180 $X=764460 $Y=1011540
X137 747 3104 3360 1 2 QDFFN $T=765700 921200 1 0 $X=765700 $Y=915780
X138 737 3188 3356 1 2 QDFFN $T=766320 981680 1 0 $X=766320 $Y=976260
X139 747 2988 3315 1 2 QDFFN $T=776860 1022000 0 180 $X=766320 $Y=1016580
X140 747 3042 3366 1 2 QDFFN $T=768180 911120 0 0 $X=768180 $Y=910740
X141 737 685 3331 1 2 QDFFN $T=778720 1052240 0 180 $X=768180 $Y=1046820
X142 747 3188 3373 1 2 QDFFN $T=770040 931280 0 0 $X=770040 $Y=930900
X143 767 2931 3387 1 2 QDFFN $T=771280 1032080 1 0 $X=771280 $Y=1026660
X144 737 2999 3388 1 2 QDFFN $T=773140 991760 0 0 $X=773140 $Y=991380
X145 737 3217 3354 1 2 QDFFN $T=784300 981680 1 180 $X=773760 $Y=981300
X146 3342 704 3401 1 2 QDFFN $T=773760 1042160 0 0 $X=773760 $Y=1041780
X147 747 2975 3355 1 2 QDFFN $T=784920 890960 0 180 $X=774380 $Y=885540
X148 767 2975 3397 1 2 QDFFN $T=775000 951440 0 0 $X=775000 $Y=951060
X149 767 2988 3405 1 2 QDFFN $T=775620 1022000 0 0 $X=775620 $Y=1021620
X150 3342 3016 3407 1 2 QDFFN $T=777480 1001840 1 0 $X=777480 $Y=996420
X151 767 3188 3414 1 2 QDFFN $T=778720 981680 1 0 $X=778720 $Y=976260
X152 767 3016 3413 1 2 QDFFN $T=779960 1022000 1 0 $X=779960 $Y=1016580
X153 3342 2930 3432 1 2 QDFFN $T=781200 921200 1 0 $X=781200 $Y=915780
X154 767 3042 3417 1 2 QDFFN $T=781200 971600 0 0 $X=781200 $Y=971220
X155 767 2930 3416 1 2 QDFFN $T=782440 941360 0 0 $X=782440 $Y=940980
X156 778 3104 3394 1 2 QDFFN $T=792980 961520 0 180 $X=782440 $Y=956100
X157 767 2923 3419 1 2 QDFFN $T=782440 1032080 0 0 $X=782440 $Y=1031700
X158 3342 3217 3396 1 2 QDFFN $T=795460 931280 0 180 $X=784920 $Y=925860
X159 3342 3188 3406 1 2 QDFFN $T=795460 941360 0 180 $X=784920 $Y=935940
X160 767 3217 3436 1 2 QDFFN $T=785540 981680 0 0 $X=785540 $Y=981300
X161 3342 2999 3404 1 2 QDFFN $T=796080 991760 0 180 $X=785540 $Y=986340
X162 3342 2923 3347 1 2 QDFFN $T=796080 1011920 0 180 $X=785540 $Y=1006500
X163 3342 685 3423 1 2 QDFFN $T=785540 1042160 0 0 $X=785540 $Y=1041780
X164 767 2999 3438 1 2 QDFFN $T=786780 991760 0 0 $X=786780 $Y=991380
X165 3342 2988 3410 1 2 QDFFN $T=797940 1001840 1 180 $X=787400 $Y=1001460
X166 3342 2975 3420 1 2 QDFFN $T=799180 901040 0 180 $X=788640 $Y=895620
X167 778 704 3451 1 2 QDFFN $T=789260 1052240 1 0 $X=789260 $Y=1046820
X168 3342 2939 3441 1 2 QDFFN $T=790500 911120 1 0 $X=790500 $Y=905700
X169 779 2975 3456 1 2 QDFFN $T=791740 951440 0 0 $X=791740 $Y=951060
X170 779 3016 3462 1 2 QDFFN $T=792360 1022000 1 0 $X=792360 $Y=1016580
X171 3342 3042 3440 1 2 QDFFN $T=792980 921200 0 0 $X=792980 $Y=920820
X172 779 3042 3457 1 2 QDFFN $T=792980 931280 0 0 $X=792980 $Y=930900
X173 778 3042 3472 1 2 QDFFN $T=792980 971600 0 0 $X=792980 $Y=971220
X174 779 2931 3469 1 2 QDFFN $T=794220 1032080 0 0 $X=794220 $Y=1031700
X175 778 2975 3470 1 2 QDFFN $T=795460 961520 1 0 $X=795460 $Y=956100
X176 778 3016 3491 1 2 QDFFN $T=795460 1001840 1 0 $X=795460 $Y=996420
X177 779 3104 3468 1 2 QDFFN $T=796080 931280 1 0 $X=796080 $Y=925860
X178 3342 3104 3435 1 2 QDFFN $T=796700 911120 0 0 $X=796700 $Y=910740
X179 779 2930 3481 1 2 QDFFN $T=796700 941360 0 0 $X=796700 $Y=940980
X180 778 2999 3474 1 2 QDFFN $T=796700 981680 0 0 $X=796700 $Y=981300
X181 779 2988 3465 1 2 QDFFN $T=796700 1011920 1 0 $X=796700 $Y=1006500
X182 779 2923 3444 1 2 QDFFN $T=807240 1042160 0 180 $X=796700 $Y=1036740
X183 767 2939 3427 1 2 QDFFN $T=798560 951440 1 0 $X=798560 $Y=946020
X184 779 2999 3493 1 2 QDFFN $T=798560 991760 0 0 $X=798560 $Y=991380
X185 778 3217 3483 1 2 QDFFN $T=799180 981680 1 0 $X=799180 $Y=976260
X186 778 2931 3461 1 2 QDFFN $T=803520 1022000 0 0 $X=803520 $Y=1021620
X187 779 3217 3513 1 2 QDFFN $T=804760 921200 0 0 $X=804760 $Y=920820
X188 778 2923 3455 1 2 QDFFN $T=805380 1032080 0 0 $X=805380 $Y=1031700
X189 779 3188 3522 1 2 QDFFN $T=806620 931280 0 0 $X=806620 $Y=930900
X190 778 2988 3500 1 2 QDFFN $T=808480 1011920 1 0 $X=808480 $Y=1006500
X191 778 2939 3534 1 2 QDFFN $T=811580 971600 1 0 $X=811580 $Y=966180
X192 778 3188 3488 1 2 QDFFN $T=811580 971600 0 0 $X=811580 $Y=971220
X193 778 2930 3529 1 2 QDFFN $T=814060 961520 1 0 $X=814060 $Y=956100
X194 824 822 3544 1 2 QDFFN $T=834520 1052240 1 180 $X=823980 $Y=1051860
X195 3583 828 3548 1 2 QDFFN $T=835760 1042160 0 180 $X=825220 $Y=1036740
X196 3583 3590 3562 1 2 QDFFN $T=838240 1011920 0 180 $X=827700 $Y=1006500
X197 824 3590 3563 1 2 QDFFN $T=838240 1032080 0 180 $X=827700 $Y=1026660
X198 3583 822 3571 1 2 QDFFN $T=840720 1052240 0 180 $X=830180 $Y=1046820
X199 824 3584 3604 1 2 QDFFN $T=832660 880880 0 0 $X=832660 $Y=880500
X200 3583 829 3619 1 2 QDFFN $T=833900 941360 1 0 $X=833900 $Y=935940
X201 824 3599 3586 1 2 QDFFN $T=844440 1032080 1 180 $X=833900 $Y=1031700
X202 3583 3584 3624 1 2 QDFFN $T=838240 931280 0 0 $X=838240 $Y=930900
X203 831 830 3637 1 2 QDFFN $T=838240 951440 1 0 $X=838240 $Y=946020
X204 3583 830 3639 1 2 QDFFN $T=840100 941360 0 0 $X=840100 $Y=940980
X205 3583 845 3649 1 2 QDFFN $T=843820 921200 0 0 $X=843820 $Y=920820
X206 3583 846 3638 1 2 QDFFN $T=843820 1052240 1 0 $X=843820 $Y=1046820
X207 824 3607 3622 1 2 QDFFN $T=854980 1032080 1 180 $X=844440 $Y=1031700
X208 824 845 3656 1 2 QDFFN $T=845060 901040 1 0 $X=845060 $Y=895620
X209 831 3616 3623 1 2 QDFFN $T=855600 961520 0 180 $X=845060 $Y=956100
X210 833 3616 3667 1 2 QDFFN $T=866140 961520 0 180 $X=855600 $Y=956100
X211 831 866 3660 1 2 QDFFN $T=867380 951440 0 180 $X=856840 $Y=946020
X212 842 3599 3672 1 2 QDFFN $T=867380 971600 0 180 $X=856840 $Y=966180
X213 824 854 3664 1 2 QDFFN $T=867380 1052240 1 180 $X=856840 $Y=1051860
X214 3583 3607 3680 1 2 QDFFN $T=869860 1022000 0 180 $X=859320 $Y=1016580
X215 842 3590 3668 1 2 QDFFN $T=870480 981680 0 180 $X=859940 $Y=976260
X216 842 3584 3655 1 2 QDFFN $T=871100 890960 0 180 $X=860560 $Y=885540
X217 831 873 3657 1 2 QDFFN $T=871100 941360 0 180 $X=860560 $Y=935940
X218 842 854 3663 1 2 QDFFN $T=874200 1022000 1 180 $X=863660 $Y=1021620
X219 864 3616 3727 1 2 QDFFN $T=864280 951440 0 0 $X=864280 $Y=951060
X220 3583 866 3750 1 2 QDFFN $T=868620 951440 1 0 $X=868620 $Y=946020
X221 842 846 3654 1 2 QDFFN $T=879160 1011920 1 180 $X=868620 $Y=1011540
X222 864 854 874 1 2 QDFFN $T=879160 1052240 1 180 $X=868620 $Y=1051860
X223 824 866 3716 1 2 QDFFN $T=881020 901040 0 180 $X=870480 $Y=895620
X224 833 866 3715 1 2 QDFFN $T=881020 901040 1 180 $X=870480 $Y=900660
X225 3720 866 3749 1 2 QDFFN $T=870480 941360 0 0 $X=870480 $Y=940980
X226 864 3584 876 1 2 QDFFN $T=881640 890960 0 180 $X=871100 $Y=885540
X227 824 873 3722 1 2 QDFFN $T=884120 890960 1 180 $X=873580 $Y=890580
X228 877 866 3765 1 2 QDFFN $T=875440 911120 1 0 $X=875440 $Y=905700
X229 3720 873 3740 1 2 QDFFN $T=887220 931280 0 180 $X=876680 $Y=925860
X230 864 3599 3742 1 2 QDFFN $T=887220 1052240 0 180 $X=876680 $Y=1046820
X231 867 3601 3725 1 2 QDFFN $T=887840 1001840 0 180 $X=877300 $Y=996420
X232 3720 845 3771 1 2 QDFFN $T=877920 921200 0 0 $X=877920 $Y=920820
X233 864 3590 3744 1 2 QDFFN $T=889700 1052240 1 180 $X=879160 $Y=1051860
X234 877 3607 3779 1 2 QDFFN $T=880400 1042160 1 0 $X=880400 $Y=1036740
X235 877 873 3753 1 2 QDFFN $T=891560 901040 0 180 $X=881020 $Y=895620
X236 867 829 880 1 2 QDFFN $T=892180 890960 0 180 $X=881640 $Y=885540
X237 3720 828 3782 1 2 QDFFN $T=881640 1011920 1 0 $X=881640 $Y=1006500
X238 3720 829 3757 1 2 QDFFN $T=892800 941360 1 180 $X=882260 $Y=940980
X239 877 3590 3785 1 2 QDFFN $T=882260 1042160 0 0 $X=882260 $Y=1041780
X240 3720 844 3760 1 2 QDFFN $T=894040 921200 0 180 $X=883500 $Y=915780
X241 867 3584 883 1 2 QDFFN $T=894660 890960 1 180 $X=884120 $Y=890580
X242 877 3601 3798 1 2 QDFFN $T=884120 1032080 0 0 $X=884120 $Y=1031700
X243 3720 3616 3786 1 2 QDFFN $T=887220 961520 1 0 $X=887220 $Y=956100
X244 885 866 3812 1 2 QDFFN $T=888460 941360 1 0 $X=888460 $Y=935940
X245 877 830 3778 1 2 QDFFN $T=900240 911120 1 180 $X=889700 $Y=910740
X246 885 3616 3815 1 2 QDFFN $T=890320 961520 0 0 $X=890320 $Y=961140
X247 885 845 3817 1 2 QDFFN $T=890940 931280 1 0 $X=890940 $Y=925860
X248 894 829 3787 1 2 QDFFN $T=902720 890960 0 180 $X=892180 $Y=885540
X249 885 873 3820 1 2 QDFFN $T=892180 921200 0 0 $X=892180 $Y=920820
X250 877 3616 3801 1 2 QDFFN $T=892180 971600 1 0 $X=892180 $Y=966180
X251 885 3584 3780 1 2 QDFFN $T=904580 941360 1 180 $X=894040 $Y=940980
X252 894 3584 3792 1 2 QDFFN $T=905200 890960 1 180 $X=894660 $Y=890580
X253 885 844 3826 1 2 QDFFN $T=894660 921200 1 0 $X=894660 $Y=915780
X254 877 3584 3794 1 2 QDFFN $T=906440 911120 0 180 $X=895900 $Y=905700
X255 885 830 3795 1 2 QDFFN $T=896520 951440 1 0 $X=896520 $Y=946020
X256 885 3590 3837 1 2 QDFFN $T=896520 1052240 0 0 $X=896520 $Y=1051860
X257 885 3601 3806 1 2 QDFFN $T=908300 1022000 1 180 $X=897760 $Y=1021620
X258 885 3607 3811 1 2 QDFFN $T=909540 1032080 1 180 $X=899000 $Y=1031700
X259 890 844 3847 1 2 QDFFN $T=901480 911120 0 0 $X=901480 $Y=910740
X260 890 3616 3849 1 2 QDFFN $T=902100 961520 0 0 $X=902100 $Y=961140
X261 877 845 3814 1 2 QDFFN $T=902720 901040 0 0 $X=902720 $Y=900660
X262 890 829 3844 1 2 QDFFN $T=903340 961520 1 0 $X=903340 $Y=956100
X263 895 830 3840 1 2 QDFFN $T=903960 880880 0 0 $X=903960 $Y=880500
X264 890 3599 3822 1 2 QDFFN $T=914500 971600 1 180 $X=903960 $Y=971220
X265 890 828 3831 1 2 QDFFN $T=904580 1011920 0 0 $X=904580 $Y=1011540
X266 895 3584 3828 1 2 QDFFN $T=915740 890960 1 180 $X=905200 $Y=890580
X267 890 3584 3830 1 2 QDFFN $T=916360 941360 1 180 $X=905820 $Y=940980
X268 895 3607 3859 1 2 QDFFN $T=905820 1032080 1 0 $X=905820 $Y=1026660
X269 906 3584 3834 1 2 QDFFN $T=917600 911120 0 180 $X=907060 $Y=905700
X270 890 866 3865 1 2 QDFFN $T=908300 931280 1 0 $X=908300 $Y=925860
X271 895 3599 3843 1 2 QDFFN $T=918840 1042160 1 180 $X=908300 $Y=1041780
X272 895 3590 3855 1 2 QDFFN $T=908300 1052240 1 0 $X=908300 $Y=1046820
X273 895 3601 3868 1 2 QDFFN $T=908920 1022000 0 0 $X=908920 $Y=1021620
X274 3845 3590 3872 1 2 QDFFN $T=909540 981680 0 0 $X=909540 $Y=981300
X275 890 845 3846 1 2 QDFFN $T=920700 921200 1 180 $X=910160 $Y=920820
X276 901 829 3886 1 2 QDFFN $T=913880 890960 1 0 $X=913880 $Y=885540
X277 901 3584 3879 1 2 QDFFN $T=914500 901040 1 0 $X=914500 $Y=895620
X278 3845 844 3883 1 2 QDFFN $T=914500 921200 1 0 $X=914500 $Y=915780
X279 895 3616 3857 1 2 QDFFN $T=925660 961520 0 180 $X=915120 $Y=956100
X280 3845 828 3900 1 2 QDFFN $T=915740 1011920 1 0 $X=915740 $Y=1006500
X281 908 3584 3864 1 2 QDFFN $T=927520 890960 1 180 $X=916980 $Y=890580
X282 906 829 3866 1 2 QDFFN $T=928140 901040 1 180 $X=917600 $Y=900660
X283 3845 3584 3862 1 2 QDFFN $T=928140 941360 1 180 $X=917600 $Y=940980
X284 3845 3616 3890 1 2 QDFFN $T=917600 971600 1 0 $X=917600 $Y=966180
X285 906 830 3870 1 2 QDFFN $T=928760 911120 0 180 $X=918220 $Y=905700
X286 3845 854 3896 1 2 QDFFN $T=918220 1022000 1 0 $X=918220 $Y=1016580
X287 908 3607 3892 1 2 QDFFN $T=918220 1042160 1 0 $X=918220 $Y=1036740
X288 890 873 3869 1 2 QDFFN $T=920080 931280 1 0 $X=920080 $Y=925860
X289 908 3601 3873 1 2 QDFFN $T=930620 1022000 1 180 $X=920080 $Y=1021620
X290 908 3590 3905 1 2 QDFFN $T=920080 1052240 1 0 $X=920080 $Y=1046820
X291 895 822 916 1 2 QDFFN $T=921320 1052240 0 0 $X=921320 $Y=1051860
X292 901 3607 3922 1 2 QDFFN $T=922560 1042160 0 0 $X=922560 $Y=1041780
X293 3845 3599 3880 1 2 QDFFN $T=934340 971600 1 180 $X=923800 $Y=971220
X294 906 844 3891 1 2 QDFFN $T=937440 901040 0 180 $X=926900 $Y=895620
X295 3845 866 3928 1 2 QDFFN $T=926900 951440 1 0 $X=926900 $Y=946020
X296 3845 830 3871 1 2 QDFFN $T=926900 951440 0 0 $X=926900 $Y=951060
X297 901 830 3901 1 2 QDFFN $T=928140 890960 0 0 $X=928140 $Y=890580
X298 906 3607 3933 1 2 QDFFN $T=929380 1032080 0 0 $X=929380 $Y=1031700
X299 906 845 3923 1 2 QDFFN $T=930000 911120 1 0 $X=930000 $Y=905700
X300 906 3601 3904 1 2 QDFFN $T=940540 1022000 0 180 $X=930000 $Y=1016580
X301 908 845 925 1 2 QDFFN $T=930620 880880 0 0 $X=930620 $Y=880500
X302 3907 845 3895 1 2 QDFFN $T=931240 931280 1 0 $X=931240 $Y=925860
X303 3845 873 3920 1 2 QDFFN $T=931860 941360 1 0 $X=931860 $Y=935940
X304 908 3599 3926 1 2 QDFFN $T=932480 1052240 1 0 $X=932480 $Y=1046820
X305 906 873 3897 1 2 QDFFN $T=933720 921200 1 0 $X=933720 $Y=915780
X306 908 3616 3921 1 2 QDFFN $T=934960 961520 1 0 $X=934960 $Y=956100
X307 901 3616 3918 1 2 QDFFN $T=946120 961520 1 180 $X=935580 $Y=961140
X308 906 3616 3929 1 2 QDFFN $T=946120 971600 1 180 $X=935580 $Y=971220
X309 894 3599 3912 1 2 QDFFN $T=946120 981680 0 180 $X=935580 $Y=976260
X310 894 846 3931 1 2 QDFFN $T=946740 1011920 1 180 $X=936200 $Y=1011540
X311 901 854 920 1 2 QDFFN $T=946740 1052240 1 180 $X=936200 $Y=1051860
X312 894 828 3934 1 2 QDFFN $T=947360 1001840 0 180 $X=936820 $Y=996420
X313 921 3938 3950 1 2 QDFFN $T=938060 951440 0 0 $X=938060 $Y=951060
X314 901 3601 3924 1 2 QDFFN $T=948600 1042160 0 180 $X=938060 $Y=1036740
X315 3502 926 3953 1 2 QDFFN $T=938680 901040 1 0 $X=938680 $Y=895620
X316 815 3938 3954 1 2 QDFFN $T=938680 951440 1 0 $X=938680 $Y=946020
X317 923 926 3956 1 2 QDFFN $T=939300 941360 0 0 $X=939300 $Y=940980
X318 815 926 3968 1 2 QDFFN $T=939920 911120 0 0 $X=939920 $Y=910740
X319 799 928 3955 1 2 QDFFN $T=940540 890960 0 0 $X=940540 $Y=890580
X320 906 3590 3949 1 2 QDFFN $T=941160 1032080 0 0 $X=941160 $Y=1031700
X321 799 926 3964 1 2 QDFFN $T=941780 880880 0 0 $X=941780 $Y=880500
X322 894 854 3940 1 2 QDFFN $T=952320 1022000 0 180 $X=941780 $Y=1016580
X323 923 928 3941 1 2 QDFFN $T=952940 931280 0 180 $X=942400 $Y=925860
X324 3502 928 3971 1 2 QDFFN $T=944260 911120 1 0 $X=944260 $Y=905700
X325 901 3590 3951 1 2 QDFFN $T=944880 1052240 1 0 $X=944880 $Y=1046820
X326 921 3944 3989 1 2 QDFFN $T=946740 971600 1 0 $X=946740 $Y=966180
X327 923 3944 4000 1 2 QDFFN $T=946740 981680 1 0 $X=946740 $Y=976260
X328 894 822 3936 1 2 QDFFN $T=957900 1001840 0 180 $X=947360 $Y=996420
X329 3952 3947 3995 1 2 QDFFN $T=947980 1011920 0 0 $X=947980 $Y=1011540
X330 906 3599 3945 1 2 QDFFN $T=947980 1022000 0 0 $X=947980 $Y=1021620
X331 901 3599 3946 1 2 QDFFN $T=949220 1042160 0 0 $X=949220 $Y=1041780
X332 815 3944 4004 1 2 QDFFN $T=949840 1001840 0 0 $X=949840 $Y=1001460
X333 901 822 937 1 2 QDFFN $T=949840 1052240 0 0 $X=949840 $Y=1051860
X334 3952 934 4011 1 2 QDFFN $T=950460 1042160 1 0 $X=950460 $Y=1036740
X335 3502 934 4013 1 2 QDFFN $T=952940 1032080 0 0 $X=952940 $Y=1031700
X336 799 935 4012 1 2 QDFFN $T=953560 880880 0 0 $X=953560 $Y=880500
X337 3952 926 3976 1 2 QDFFN $T=964100 931280 0 180 $X=953560 $Y=925860
X338 921 934 4016 1 2 QDFFN $T=953560 1022000 1 0 $X=953560 $Y=1016580
X339 3502 935 4023 1 2 QDFFN $T=956040 890960 0 0 $X=956040 $Y=890580
X340 815 935 4030 1 2 QDFFN $T=956660 911120 1 0 $X=956660 $Y=905700
X341 815 938 4019 1 2 QDFFN $T=957900 921200 1 0 $X=957900 $Y=915780
X342 921 3947 3996 1 2 QDFFN $T=968440 971600 1 180 $X=957900 $Y=971220
X343 815 4010 3997 1 2 QDFFN $T=968440 1001840 0 180 $X=957900 $Y=996420
X344 923 3947 4001 1 2 QDFFN $T=969060 991760 0 180 $X=958520 $Y=986340
X345 3952 939 4029 1 2 QDFFN $T=958520 1052240 1 0 $X=958520 $Y=1046820
X346 923 938 4006 1 2 QDFFN $T=969680 941360 1 180 $X=959140 $Y=940980
X347 921 939 4047 1 2 QDFFN $T=959760 1022000 0 0 $X=959760 $Y=1021620
X348 3502 939 4052 1 2 QDFFN $T=964100 1042160 1 0 $X=964100 $Y=1036740
X349 799 945 4061 1 2 QDFFN $T=964720 880880 0 0 $X=964720 $Y=880500
X350 815 4055 4024 1 2 QDFFN $T=975260 1011920 0 180 $X=964720 $Y=1006500
X351 815 959 4041 1 2 QDFFN $T=977740 911120 1 180 $X=967200 $Y=910740
X352 3502 938 4033 1 2 QDFFN $T=978980 890960 1 180 $X=968440 $Y=890580
X353 3952 959 4053 1 2 QDFFN $T=979600 921200 0 180 $X=969060 $Y=915780
X354 3952 3938 4046 1 2 QDFFN $T=980220 951440 1 180 $X=969680 $Y=951060
X355 951 926 4076 1 2 QDFFN $T=970300 931280 0 0 $X=970300 $Y=930900
X356 3502 945 4082 1 2 QDFFN $T=971540 901040 1 0 $X=971540 $Y=895620
X357 799 3947 4095 1 2 QDFFN $T=972160 971600 0 0 $X=972160 $Y=971220
X358 815 945 4075 1 2 QDFFN $T=972780 911120 1 0 $X=972780 $Y=905700
X359 3502 963 4062 1 2 QDFFN $T=983320 1042160 1 180 $X=972780 $Y=1041780
X360 3952 938 4057 1 2 QDFFN $T=983940 941360 1 180 $X=973400 $Y=940980
X361 799 4010 4092 1 2 QDFFN $T=974020 991760 1 0 $X=974020 $Y=986340
X362 3952 961 4080 1 2 QDFFN $T=974020 1052240 0 0 $X=974020 $Y=1051860
X363 921 961 4100 1 2 QDFFN $T=974640 1022000 1 0 $X=974640 $Y=1016580
X364 921 963 4099 1 2 QDFFN $T=975260 1022000 0 0 $X=975260 $Y=1021620
X365 799 946 4069 1 2 QDFFN $T=987040 880880 1 180 $X=976500 $Y=880500
X366 3502 961 4067 1 2 QDFFN $T=977120 1032080 1 0 $X=977120 $Y=1026660
X367 923 945 4108 1 2 QDFFN $T=978360 921200 0 0 $X=978360 $Y=920820
X368 3502 946 4113 1 2 QDFFN $T=980220 890960 1 0 $X=980220 $Y=885540
X369 951 3938 4079 1 2 QDFFN $T=990760 961520 0 180 $X=980220 $Y=956100
X370 3502 959 4103 1 2 QDFFN $T=982700 901040 1 0 $X=982700 $Y=895620
X371 951 938 4105 1 2 QDFFN $T=983320 951440 1 0 $X=983320 $Y=946020
X372 923 959 4124 1 2 QDFFN $T=983940 911120 0 0 $X=983940 $Y=910740
X373 799 3944 4128 1 2 QDFFN $T=984560 971600 1 0 $X=984560 $Y=966180
X374 951 935 4101 1 2 QDFFN $T=985180 941360 1 0 $X=985180 $Y=935940
X375 799 939 4131 1 2 QDFFN $T=985800 1032080 0 0 $X=985800 $Y=1031700
X376 923 939 972 1 2 QDFFN $T=986420 1052240 0 0 $X=986420 $Y=1051860
X377 799 961 4121 1 2 QDFFN $T=988900 1022000 1 0 $X=988900 $Y=1016580
X378 798 938 4130 1 2 QDFFN $T=989520 880880 0 0 $X=989520 $Y=880500
X379 798 928 4141 1 2 QDFFN $T=992000 911120 1 0 $X=992000 $Y=905700
X380 3691 935 4155 1 2 QDFFN $T=993240 941360 0 0 $X=993240 $Y=940980
X381 798 963 4160 1 2 QDFFN $T=993860 1032080 1 0 $X=993860 $Y=1026660
X382 951 945 4165 1 2 QDFFN $T=995100 921200 0 0 $X=995100 $Y=920820
X383 951 3947 4140 1 2 QDFFN $T=1008740 971600 1 180 $X=998200 $Y=971220
X384 951 939 4177 1 2 QDFFN $T=999440 1052240 1 0 $X=999440 $Y=1046820
X385 951 946 4186 1 2 QDFFN $T=1000680 911120 0 0 $X=1000680 $Y=910740
X386 798 959 4185 1 2 QDFFN $T=1001300 890960 1 0 $X=1001300 $Y=885540
X387 798 934 4152 1 2 QDFFN $T=1011840 1042160 0 180 $X=1001300 $Y=1036740
X388 798 946 4193 1 2 QDFFN $T=1003160 880880 0 0 $X=1003160 $Y=880500
X389 808 963 4194 1 2 QDFFN $T=1005020 1022000 0 0 $X=1005020 $Y=1021620
X390 798 961 4153 1 2 QDFFN $T=1017420 1011920 1 180 $X=1006880 $Y=1011540
X391 3691 946 4178 1 2 QDFFN $T=1018660 921200 0 180 $X=1008120 $Y=915780
X392 808 3938 4212 1 2 QDFFN $T=1008120 951440 0 0 $X=1008120 $Y=951060
X393 968 935 4208 1 2 QDFFN $T=1009360 941360 0 0 $X=1009360 $Y=940980
X394 798 3947 4191 1 2 QDFFN $T=1009360 971600 0 0 $X=1009360 $Y=971220
X395 798 4055 4209 1 2 QDFFN $T=1009360 991760 1 0 $X=1009360 $Y=986340
X396 968 4010 4184 1 2 QDFFN $T=1020520 1011920 0 180 $X=1009980 $Y=1006500
X397 3691 945 4196 1 2 QDFFN $T=1011840 921200 0 0 $X=1011840 $Y=920820
X398 808 934 4192 1 2 QDFFN $T=1014320 1032080 1 0 $X=1014320 $Y=1026660
X399 808 938 4200 1 2 QDFFN $T=1026100 880880 1 180 $X=1015560 $Y=880500
X400 968 945 4211 1 2 QDFFN $T=1029200 921200 0 180 $X=1018660 $Y=915780
X401 968 3938 4216 1 2 QDFFN $T=1019280 961520 1 0 $X=1019280 $Y=956100
X402 968 3947 4230 1 2 QDFFN $T=1019900 1022000 1 0 $X=1019900 $Y=1016580
X403 808 3947 4217 1 2 QDFFN $T=1031060 971600 0 180 $X=1020520 $Y=966180
X404 808 3944 4215 1 2 QDFFN $T=1031060 971600 1 180 $X=1020520 $Y=971220
X405 968 938 4225 1 2 QDFFN $T=1021760 951440 1 0 $X=1021760 $Y=946020
X406 808 959 4255 1 2 QDFFN $T=1024240 890960 1 0 $X=1024240 $Y=885540
X407 3691 4010 4254 1 2 QDFFN $T=1026100 991760 1 0 $X=1026100 $Y=986340
X408 808 928 4236 1 2 QDFFN $T=1037260 911120 0 180 $X=1026720 $Y=905700
X409 968 959 4232 1 2 QDFFN $T=1037880 911120 1 180 $X=1027340 $Y=910740
X410 983 3947 4266 1 2 QDFFN $T=1027340 1011920 0 0 $X=1027340 $Y=1011540
X411 808 945 4250 1 2 QDFFN $T=1027960 880880 0 0 $X=1027960 $Y=880500
X412 808 946 4259 1 2 QDFFN $T=1030440 901040 1 0 $X=1030440 $Y=895620
X413 808 961 4235 1 2 QDFFN $T=1040980 1022000 1 180 $X=1030440 $Y=1021620
X414 983 3938 4273 1 2 QDFFN $T=1031680 961520 0 0 $X=1031680 $Y=961140
X415 3691 4055 4249 1 2 QDFFN $T=1042840 971600 0 180 $X=1032300 $Y=966180
X416 3691 3938 4257 1 2 QDFFN $T=1033540 961520 1 0 $X=1033540 $Y=956100
X417 983 3944 4270 1 2 QDFFN $T=1033540 1011920 1 0 $X=1033540 $Y=1006500
X418 3691 961 4286 1 2 QDFFN $T=1034160 1032080 0 0 $X=1034160 $Y=1031700
X419 3691 963 4282 1 2 QDFFN $T=1034160 1042160 1 0 $X=1034160 $Y=1036740
X420 983 938 4292 1 2 QDFFN $T=1036020 951440 1 0 $X=1036020 $Y=946020
X421 983 946 4289 1 2 QDFFN $T=1036640 921200 1 0 $X=1036640 $Y=915780
X422 3691 3947 4262 1 2 QDFFN $T=1049040 981680 1 180 $X=1038500 $Y=981300
X423 987 928 4281 1 2 QDFFN $T=1039120 890960 0 0 $X=1039120 $Y=890580
X424 987 926 4294 1 2 QDFFN $T=1039120 911120 1 0 $X=1039120 $Y=905700
X425 983 4010 4269 1 2 QDFFN $T=1039120 991760 1 0 $X=1039120 $Y=986340
X426 987 938 4302 1 2 QDFFN $T=1040360 880880 0 0 $X=1040360 $Y=880500
X427 3691 3944 4258 1 2 QDFFN $T=1050900 971600 1 180 $X=1040360 $Y=971220
X428 789 935 4304 1 2 QDFFN $T=1042840 941360 1 0 $X=1042840 $Y=935940
X429 3557 963 4309 1 2 QDFFN $T=1044080 1032080 1 0 $X=1044080 $Y=1026660
X430 992 3947 4313 1 2 QDFFN $T=1044700 971600 1 0 $X=1044700 $Y=966180
X431 805 3947 4303 1 2 QDFFN $T=1044700 1022000 1 0 $X=1044700 $Y=1016580
X432 805 4010 4316 1 2 QDFFN $T=1045320 1001840 1 0 $X=1045320 $Y=996420
X433 805 3944 4285 1 2 QDFFN $T=1055860 1001840 1 180 $X=1045320 $Y=1001460
X434 987 3938 4322 1 2 QDFFN $T=1045940 961520 1 0 $X=1045940 $Y=956100
X435 789 3947 4314 1 2 QDFFN $T=1045940 981680 1 0 $X=1045940 $Y=976260
X436 805 961 4287 1 2 QDFFN $T=1056480 1042160 0 180 $X=1045940 $Y=1036740
X437 805 946 4328 1 2 QDFFN $T=1048420 921200 1 0 $X=1048420 $Y=915780
X438 789 938 4312 1 2 QDFFN $T=1049040 951440 1 0 $X=1049040 $Y=946020
X439 987 3944 4333 1 2 QDFFN $T=1049040 991760 0 0 $X=1049040 $Y=991380
X440 992 963 4334 1 2 QDFFN $T=1050280 1022000 0 0 $X=1050280 $Y=1021620
X441 987 3947 4324 1 2 QDFFN $T=1050900 981680 0 0 $X=1050900 $Y=981300
X442 987 959 4320 1 2 QDFFN $T=1051520 890960 0 0 $X=1051520 $Y=890580
X443 3557 935 4317 1 2 QDFFN $T=1052140 880880 0 0 $X=1052140 $Y=880500
X444 992 3944 4306 1 2 QDFFN $T=1062680 961520 1 180 $X=1052140 $Y=961140
X445 3557 3947 4342 1 2 QDFFN $T=1052760 971600 0 0 $X=1052760 $Y=971220
X446 3557 961 4331 1 2 QDFFN $T=1053380 1032080 0 0 $X=1053380 $Y=1031700
X447 3557 938 4311 1 2 QDFFN $T=1067020 890960 0 180 $X=1056480 $Y=885540
X448 789 3944 4359 1 2 QDFFN $T=1057100 1001840 1 0 $X=1057100 $Y=996420
X449 992 961 4351 1 2 QDFFN $T=1057100 1022000 1 0 $X=1057100 $Y=1016580
X450 987 961 4360 1 2 QDFFN $T=1058340 1042160 1 0 $X=1058340 $Y=1036740
X451 987 963 4369 1 2 QDFFN $T=1060820 1052240 0 0 $X=1060820 $Y=1051860
X452 805 938 4327 1 2 QDFFN $T=1063300 941360 1 0 $X=1063300 $Y=935940
X453 805 3938 4346 1 2 QDFFN $T=1074460 961520 0 180 $X=1063920 $Y=956100
X454 3557 946 4382 1 2 QDFFN $T=1064540 901040 0 0 $X=1064540 $Y=900660
X455 992 946 1000 1 2 QDFFN $T=1065160 880880 0 0 $X=1065160 $Y=880500
X456 3557 3944 4363 1 2 QDFFN $T=1065160 971600 0 0 $X=1065160 $Y=971220
X457 805 4055 4343 1 2 QDFFN $T=1075700 1011920 0 180 $X=1065160 $Y=1006500
X458 3557 934 4388 1 2 QDFFN $T=1067020 1032080 0 0 $X=1067020 $Y=1031700
X459 3557 959 4365 1 2 QDFFN $T=1067640 890960 1 0 $X=1067640 $Y=885540
X460 805 928 4371 1 2 QDFFN $T=1069500 931280 1 0 $X=1069500 $Y=925860
X461 789 4010 4396 1 2 QDFFN $T=1070120 1001840 0 0 $X=1070120 $Y=1001460
X462 987 4055 4393 1 2 QDFFN $T=1071360 991760 0 0 $X=1071360 $Y=991380
X463 3557 4055 4386 1 2 QDFFN $T=1072600 981680 1 0 $X=1072600 $Y=976260
X464 987 945 4315 1 2 QDFFN $T=1073840 911120 1 0 $X=1073840 $Y=905700
X465 987 939 4390 1 2 QDFFN $T=1075080 1052240 1 0 $X=1075080 $Y=1046820
X466 805 926 4379 1 2 QDFFN $T=1075700 941360 1 0 $X=1075700 $Y=935940
X467 992 4010 4392 1 2 QDFFN $T=1076320 961520 0 0 $X=1076320 $Y=961140
X468 992 934 4380 1 2 QDFFN $T=1076940 1022000 1 0 $X=1076940 $Y=1016580
X469 3557 928 4391 1 2 QDFFN $T=1077560 880880 0 0 $X=1077560 $Y=880500
X470 3557 926 4399 1 2 QDFFN $T=1077560 901040 1 0 $X=1077560 $Y=895620
X471 3557 945 4361 1 2 QDFFN $T=1077560 901040 0 0 $X=1077560 $Y=900660
X472 789 945 4366 1 2 QDFFN $T=1077560 911120 0 0 $X=1077560 $Y=910740
X473 789 928 4397 1 2 QDFFN $T=1077560 921200 0 0 $X=1077560 $Y=920820
X474 789 926 4400 1 2 QDFFN $T=1077560 931280 0 0 $X=1077560 $Y=930900
X475 789 3938 4378 1 2 QDFFN $T=1077560 941360 0 0 $X=1077560 $Y=940980
X476 992 3938 4383 1 2 QDFFN $T=1077560 951440 1 0 $X=1077560 $Y=946020
X477 3557 3938 4384 1 2 QDFFN $T=1077560 951440 0 0 $X=1077560 $Y=951060
X478 992 4055 4401 1 2 QDFFN $T=1077560 971600 0 0 $X=1077560 $Y=971220
X479 3557 4010 4375 1 2 QDFFN $T=1077560 981680 0 0 $X=1077560 $Y=981300
X480 987 4010 4398 1 2 QDFFN $T=1077560 991760 1 0 $X=1077560 $Y=986340
X481 789 4055 4395 1 2 QDFFN $T=1077560 1011920 1 0 $X=1077560 $Y=1006500
X482 992 939 4372 1 2 QDFFN $T=1077560 1011920 0 0 $X=1077560 $Y=1011540
X483 3557 939 4373 1 2 QDFFN $T=1077560 1032080 1 0 $X=1077560 $Y=1026660
X484 987 934 4402 1 2 QDFFN $T=1077560 1042160 1 0 $X=1077560 $Y=1036740
X485 1031 1032 1099 1023 1 1033 2 AOI22S $T=226300 961520 1 180 $X=222580 $Y=961140
X486 1027 1034 1043 1037 1 1033 2 AOI22S $T=226300 981680 0 180 $X=222580 $Y=976260
X487 1029 1040 1038 1065 1 1070 2 AOI22S $T=223200 1011920 0 0 $X=223200 $Y=1011540
X488 1102 22 1119 1153 1 1023 2 AOI22S $T=239320 981680 0 0 $X=239320 $Y=981300
X489 1185 1136 1139 1120 1 1134 2 AOI22S $T=243660 921200 1 180 $X=239940 $Y=920820
X490 31 28 1093 15 1 1138 2 AOI22S $T=244900 1052240 1 180 $X=241180 $Y=1051860
X491 1031 1034 1178 1070 1 1042 2 AOI22S $T=246760 931280 1 180 $X=243040 $Y=930900
X492 1183 1108 1189 1027 1 1102 2 AOI22S $T=250480 991760 0 180 $X=246760 $Y=986340
X493 1175 1172 1180 1037 1 1123 2 AOI22S $T=251100 991760 1 180 $X=247380 $Y=991380
X494 1032 1153 1166 35 1 1148 2 AOI22S $T=248620 941360 1 0 $X=248620 $Y=935940
X495 31 1163 1167 1206 1 1192 2 AOI22S $T=249240 1022000 0 0 $X=249240 $Y=1021620
X496 1258 1194 1114 40 1 1190 2 AOI22S $T=254200 890960 0 180 $X=250480 $Y=885540
X497 31 1193 1207 1107 1 1218 2 AOI22S $T=253580 971600 0 0 $X=253580 $Y=971220
X498 44 1027 1204 1065 1 28 2 AOI22S $T=254820 1001840 1 0 $X=254820 $Y=996420
X499 1262 1205 1248 1042 1 1297 2 AOI22S $T=263500 931280 1 0 $X=263500 $Y=925860
X500 1251 1034 1249 1183 1 1274 2 AOI22S $T=263500 941360 0 0 $X=263500 $Y=940980
X501 1175 1153 1244 57 1 1288 2 AOI22S $T=263500 951440 1 0 $X=263500 $Y=946020
X502 1153 1102 1243 1042 1 59 2 AOI22S $T=263500 991760 1 0 $X=263500 $Y=986340
X503 55 58 1237 60 1 1280 2 AOI22S $T=264120 880880 0 0 $X=264120 $Y=880500
X504 1214 1108 1265 1102 1 1288 2 AOI22S $T=264120 941360 1 0 $X=264120 $Y=935940
X505 1286 69 1256 1312 1 1198 2 AOI22S $T=269080 1011920 0 0 $X=269080 $Y=1011540
X506 1172 31 1301 1324 1 1330 2 AOI22S $T=272180 1032080 0 0 $X=272180 $Y=1031700
X507 1312 1322 1279 1343 1 78 2 AOI22S $T=272180 1042160 0 0 $X=272180 $Y=1041780
X508 1312 1109 1308 1083 1 1333 2 AOI22S $T=272800 991760 0 0 $X=272800 $Y=991380
X509 1361 58 84 83 1 55 2 AOI22S $T=279620 880880 1 180 $X=275900 $Y=880500
X510 1322 1073 1338 1036 1 1202 2 AOI22S $T=275900 1011920 0 0 $X=275900 $Y=1011540
X511 1374 1175 1270 1341 1 1352 2 AOI22S $T=281480 931280 1 180 $X=277760 $Y=930900
X512 1058 1322 1376 1231 1 1074 2 AOI22S $T=284580 991760 0 180 $X=280860 $Y=986340
X513 1262 5 1397 57 1 1367 2 AOI22S $T=285200 941360 1 180 $X=281480 $Y=940980
X514 1175 22 1384 1312 1 1042 2 AOI22S $T=284580 991760 0 0 $X=284580 $Y=991380
X515 1058 1262 1411 1421 1 1288 2 AOI22S $T=289540 931280 0 0 $X=289540 $Y=930900
X516 1312 1153 1414 26 1 23 2 AOI22S $T=290160 1011920 1 0 $X=290160 $Y=1006500
X517 1444 1073 1439 1140 1 1435 2 AOI22S $T=295740 941360 0 180 $X=292020 $Y=935940
X518 1431 44 1428 1251 1 1444 2 AOI22S $T=293260 941360 0 0 $X=293260 $Y=940980
X519 1262 113 1472 5 1 1431 2 AOI22S $T=300080 941360 0 0 $X=300080 $Y=940980
X520 1489 1444 1259 1449 1 1494 2 AOI22S $T=303180 941360 1 0 $X=303180 $Y=935940
X521 136 28 143 109 1 120 2 AOI22S $T=310620 1052240 1 180 $X=306900 $Y=1051860
X522 136 28 1525 1518 1 1500 2 AOI22S $T=311860 1052240 0 180 $X=308140 $Y=1046820
X523 1042 31 1454 1548 1 1528 2 AOI22S $T=309380 1001840 1 0 $X=309380 $Y=996420
X524 1362 1175 1545 1286 1 1374 2 AOI22S $T=316200 941360 0 0 $X=316200 $Y=940980
X525 28 59 1577 5 1 1547 2 AOI22S $T=319920 1001840 0 180 $X=316200 $Y=996420
X526 28 1042 1535 1175 1 153 2 AOI22S $T=317440 991760 0 0 $X=317440 $Y=991380
X527 1636 136 1121 1617 1 168 2 AOI22S $T=332940 1042160 1 180 $X=329220 $Y=1041780
X528 23 1420 1595 168 1 1251 2 AOI22S $T=330460 1011920 1 0 $X=330460 $Y=1006500
X529 1322 1640 1657 1670 1 189 2 AOI22S $T=341000 1042160 0 0 $X=341000 $Y=1041780
X530 1312 192 1674 1692 1 1706 2 AOI22S $T=347200 1032080 0 0 $X=347200 $Y=1031700
X531 1163 1374 1696 1404 1 1744 2 AOI22S $T=350300 961520 0 0 $X=350300 $Y=961140
X532 1163 1640 1309 202 1 1725 2 AOI22S $T=353400 1022000 0 0 $X=353400 $Y=1021620
X533 1299 192 1677 1767 1 1771 2 AOI22S $T=365180 1022000 0 0 $X=365180 $Y=1021620
X534 5 1640 1760 1231 1 1779 2 AOI22S $T=368280 991760 0 0 $X=368280 $Y=991380
X535 1251 1198 1764 1619 1 1787 2 AOI22S $T=370760 961520 0 0 $X=370760 $Y=961140
X536 1299 1640 1752 1832 1 1823 2 AOI22S $T=385020 1022000 1 0 $X=385020 $Y=1016580
X537 1826 1843 1842 1840 1 1816 2 AOI22S $T=388120 931280 1 0 $X=388120 $Y=925860
X538 296 284 1962 1953 1 1912 2 AOI22S $T=428420 1011920 1 180 $X=424700 $Y=1011540
X539 1991 265 302 300 1 1941 2 AOI22S $T=434620 901040 1 180 $X=430900 $Y=900660
X540 1974 284 1982 1953 1 1993 2 AOI22S $T=432140 1011920 1 0 $X=432140 $Y=1006500
X541 2013 2015 2016 2045 1 2043 2 AOI22S $T=438960 1001840 0 0 $X=438960 $Y=1001460
X542 223 2038 2072 229 1 2033 2 AOI22S $T=446400 951440 1 180 $X=442680 $Y=951060
X543 2022 2013 2062 2007 1 2048 2 AOI22S $T=448260 1052240 1 180 $X=444540 $Y=1051860
X544 2022 269 2066 2054 1 296 2 AOI22S $T=449500 1011920 0 180 $X=445780 $Y=1006500
X545 2001 2071 2064 2015 1 2054 2 AOI22S $T=448880 1011920 0 0 $X=448880 $Y=1011540
X546 1993 1912 2081 350 1 278 2 AOI22S $T=453220 1022000 0 180 $X=449500 $Y=1016580
X547 343 2101 2123 2076 1 2091 2 AOI22S $T=458180 931280 0 180 $X=454460 $Y=925860
X548 296 386 2084 2071 1 1912 2 AOI22S $T=465620 1052240 0 180 $X=461900 $Y=1046820
X549 375 355 2122 2069 1 2146 2 AOI22S $T=462520 921200 0 0 $X=462520 $Y=920820
X550 2116 2105 2128 2078 1 2144 2 AOI22S $T=462520 941360 0 0 $X=462520 $Y=940980
X551 2159 377 2148 2151 1 2117 2 AOI22S $T=468720 921200 0 180 $X=465000 $Y=915780
X552 2010 1993 2176 2153 1 2150 2 AOI22S $T=468720 991760 1 180 $X=465000 $Y=991380
X553 2175 370 2191 2129 1 2006 2 AOI22S $T=470580 971600 0 180 $X=466860 $Y=966180
X554 375 2178 2181 2171 1 2170 2 AOI22S $T=471820 911120 0 180 $X=468100 $Y=905700
X555 406 402 410 2131 1 2190 2 AOI22S $T=475540 1042160 1 180 $X=471820 $Y=1041780
X556 394 2198 2180 2202 1 2209 2 AOI22S $T=472440 1011920 1 0 $X=472440 $Y=1006500
X557 2054 401 2193 2053 1 2140 2 AOI22S $T=473060 1001840 1 0 $X=473060 $Y=996420
X558 2038 2205 2200 2090 1 2206 2 AOI22S $T=473680 961520 0 0 $X=473680 $Y=961140
X559 2178 369 2204 375 1 413 2 AOI22S $T=475540 911120 0 0 $X=475540 $Y=910740
X560 2101 2216 2182 430 1 407 2 AOI22S $T=476160 921200 0 0 $X=476160 $Y=920820
X561 2054 2022 1955 2235 1 2245 2 AOI22S $T=479880 1001840 0 0 $X=479880 $Y=1001460
X562 2059 424 2257 328 1 2101 2 AOI22S $T=484840 931280 0 180 $X=481120 $Y=925860
X563 413 424 2346 328 1 2216 2 AOI22S $T=484840 941360 0 180 $X=481120 $Y=935940
X564 2071 386 353 426 1 2013 2 AOI22S $T=482980 1052240 1 0 $X=482980 $Y=1046820
X565 2289 2165 2273 2134 1 2078 2 AOI22S $T=490420 951440 0 180 $X=486700 $Y=946020
X566 2159 323 434 396 1 409 2 AOI22S $T=487320 880880 0 0 $X=487320 $Y=880500
X567 446 376 442 2282 1 2271 2 AOI22S $T=494140 890960 0 180 $X=490420 $Y=885540
X568 396 446 445 345 1 2292 2 AOI22S $T=493520 880880 0 0 $X=493520 $Y=880500
X569 402 452 2331 2310 1 2277 2 AOI22S $T=500960 1022000 0 180 $X=497240 $Y=1016580
X570 408 2296 2096 2321 1 2347 2 AOI22S $T=499100 921200 1 0 $X=499100 $Y=915780
X571 347 345 2357 2296 1 375 2 AOI22S $T=505920 921200 1 180 $X=502200 $Y=920820
X572 2343 369 468 396 1 409 2 AOI22S $T=507160 880880 1 180 $X=503440 $Y=880500
X573 450 471 2377 2322 1 2278 2 AOI22S $T=510880 1042160 0 180 $X=507160 $Y=1036740
X574 2198 1995 470 402 1 2353 2 AOI22S $T=508400 1022000 1 0 $X=508400 $Y=1016580
X575 2380 461 2373 473 1 2362 2 AOI22S $T=512740 1011920 1 180 $X=509020 $Y=1011540
X576 409 475 476 2369 1 2363 2 AOI22S $T=513360 880880 1 180 $X=509640 $Y=880500
X577 2380 406 2383 2312 1 2368 2 AOI22S $T=513360 1032080 1 180 $X=509640 $Y=1031700
X578 2359 402 2388 2071 1 2270 2 AOI22S $T=515220 1022000 1 180 $X=511500 $Y=1021620
X579 394 378 2375 2359 1 2380 2 AOI22S $T=511500 1032080 1 0 $X=511500 $Y=1026660
X580 461 452 2406 426 1 2389 2 AOI22S $T=518320 1042160 0 180 $X=514600 $Y=1036740
X581 2001 450 2420 440 1 461 2 AOI22S $T=518940 1022000 0 180 $X=515220 $Y=1016580
X582 2281 2316 2408 270 1 2013 2 AOI22S $T=519560 1022000 1 180 $X=515840 $Y=1021620
X583 409 482 481 2403 1 2412 2 AOI22S $T=516460 880880 0 0 $X=516460 $Y=880500
X584 2414 450 2444 401 1 284 2 AOI22S $T=523900 1011920 1 180 $X=520180 $Y=1011540
X585 2119 2428 2424 422 1 2359 2 AOI22S $T=521420 1001840 0 0 $X=521420 $Y=1001460
X586 281 406 2450 296 1 2414 2 AOI22S $T=525140 1022000 1 180 $X=521420 $Y=1021620
X587 270 269 2435 2359 1 2380 2 AOI22S $T=522660 1001840 1 0 $X=522660 $Y=996420
X588 2166 347 487 495 1 497 2 AOI22S $T=523280 880880 0 0 $X=523280 $Y=880500
X589 397 495 2437 2451 1 2447 2 AOI22S $T=523280 890960 0 0 $X=523280 $Y=890580
X590 2010 498 2487 2355 1 2247 2 AOI22S $T=527620 971600 0 180 $X=523900 $Y=966180
X591 2380 440 2462 2428 1 350 2 AOI22S $T=528240 1032080 1 180 $X=524520 $Y=1031700
X592 2359 296 2473 2380 1 2001 2 AOI22S $T=530100 1011920 1 180 $X=526380 $Y=1011540
X593 2010 2071 2461 2316 1 2353 2 AOI22S $T=530720 1032080 0 180 $X=527000 $Y=1026660
X594 343 345 503 2166 1 356 2 AOI22S $T=528860 880880 0 0 $X=528860 $Y=880500
X595 2316 2001 2459 471 1 354 2 AOI22S $T=529480 1042160 1 0 $X=529480 $Y=1036740
X596 475 446 515 2430 1 2464 2 AOI22S $T=535060 901040 0 180 $X=531340 $Y=895620
X597 382 2166 513 2343 1 408 2 AOI22S $T=535060 880880 0 0 $X=535060 $Y=880500
X598 347 397 523 348 1 482 2 AOI22S $T=544360 880880 0 0 $X=544360 $Y=880500
X599 2610 492 2621 1995 1 2603 2 AOI22S $T=561720 991760 1 180 $X=558000 $Y=991380
X600 2518 552 2532 2521 1 2611 2 AOI22S $T=562960 1042160 1 180 $X=559240 $Y=1041780
X601 2359 2638 2660 2635 1 563 2 AOI22S $T=569780 1042160 1 180 $X=566060 $Y=1041780
X602 2644 269 570 492 1 2635 2 AOI22S $T=572260 1052240 1 180 $X=568540 $Y=1051860
X603 2546 2656 2632 2620 1 2603 2 AOI22S $T=574120 991760 1 180 $X=570400 $Y=991380
X604 345 511 2646 494 1 408 2 AOI22S $T=571640 911120 1 0 $X=571640 $Y=905700
X605 2428 498 2673 2659 1 1990 2 AOI22S $T=575360 1001840 1 180 $X=571640 $Y=1001460
X606 2546 498 2578 2654 1 552 2 AOI22S $T=572880 1001840 1 0 $X=572880 $Y=996420
X607 2553 296 2684 471 1 2661 2 AOI22S $T=576600 1022000 1 180 $X=572880 $Y=1021620
X608 2178 408 2669 2666 1 2662 2 AOI22S $T=577220 911120 1 180 $X=573500 $Y=910740
X609 413 511 2679 345 1 2216 2 AOI22S $T=577220 931280 0 180 $X=573500 $Y=925860
X610 573 2205 2658 2645 1 2670 2 AOI22S $T=573500 981680 1 0 $X=573500 $Y=976260
X611 528 1992 584 482 1 475 2 AOI22S $T=582180 890960 1 180 $X=578460 $Y=890580
X612 552 2205 2523 2654 1 2553 2 AOI22S $T=578460 1001840 0 0 $X=578460 $Y=1001460
X613 471 2656 2692 2685 1 2466 2 AOI22S $T=583420 1022000 1 180 $X=579700 $Y=1021620
X614 1960 586 2696 2694 1 2134 2 AOI22S $T=584040 971600 0 180 $X=580320 $Y=966180
X615 593 573 2625 549 1 2553 2 AOI22S $T=584660 1011920 0 180 $X=580940 $Y=1006500
X616 281 576 2697 2702 1 471 2 AOI22S $T=582180 1042160 0 0 $X=582180 $Y=1041780
X617 2614 2205 2713 2709 1 2719 2 AOI22S $T=587140 961520 0 0 $X=587140 $Y=961140
X618 2039 2727 2720 604 1 2428 2 AOI22S $T=592100 1032080 0 0 $X=592100 $Y=1031700
X619 2039 2518 2747 2620 1 2428 2 AOI22S $T=598300 1032080 0 180 $X=594580 $Y=1026660
X620 2620 2353 2712 1953 1 2546 2 AOI22S $T=598920 991760 1 180 $X=595200 $Y=991380
X621 2546 2610 2786 2620 1 2694 2 AOI22S $T=607600 991760 0 0 $X=607600 $Y=991380
X622 552 491 2784 2656 1 2518 2 AOI22S $T=607600 1042160 1 0 $X=607600 $Y=1036740
X623 2656 2620 2779 586 1 576 2 AOI22S $T=611940 1001840 1 180 $X=608220 $Y=1001460
X624 536 562 618 2794 1 2694 2 AOI22S $T=612560 1052240 1 180 $X=608840 $Y=1051860
X625 2656 549 2812 2620 1 552 2 AOI22S $T=615040 1011920 1 180 $X=611320 $Y=1011540
X626 2516 572 2820 536 1 2654 2 AOI22S $T=615040 1032080 1 180 $X=611320 $Y=1031700
X627 2281 549 2807 2614 1 1922 2 AOI22S $T=611940 1001840 1 0 $X=611940 $Y=996420
X628 572 603 2813 2654 1 604 2 AOI22S $T=618140 1042160 0 180 $X=614420 $Y=1036740
X629 603 2610 2823 2205 1 549 2 AOI22S $T=618760 991760 1 180 $X=615040 $Y=991380
X630 2644 498 2729 2518 1 2656 2 AOI22S $T=620000 981680 1 180 $X=616280 $Y=981300
X631 2630 572 2742 549 1 2518 2 AOI22S $T=616280 991760 1 0 $X=616280 $Y=986340
X632 562 576 622 2839 1 2659 2 AOI22S $T=616900 1052240 0 0 $X=616900 $Y=1051860
X633 2644 498 2647 549 1 2553 2 AOI22S $T=618140 1011920 0 0 $X=618140 $Y=1011540
X634 2656 386 2848 2353 1 593 2 AOI22S $T=623720 1042160 1 180 $X=620000 $Y=1041780
X635 2630 1922 2857 2353 1 2654 2 AOI22S $T=623720 1052240 0 180 $X=620000 $Y=1046820
X636 498 2644 2833 2610 1 2546 2 AOI22S $T=622480 991760 0 0 $X=622480 $Y=991380
X637 2630 2638 2828 2839 1 2656 2 AOI22S $T=622480 1042160 1 0 $X=622480 $Y=1036740
X638 2638 2518 2845 2630 1 2656 2 AOI22S $T=627440 991760 0 180 $X=623720 $Y=986340
X639 2546 2518 2830 603 1 576 2 AOI22S $T=628060 981680 1 180 $X=624340 $Y=981300
X640 549 2518 2854 572 1 2630 2 AOI22S $T=628680 1011920 0 180 $X=624960 $Y=1006500
X641 2911 2920 2940 611 1 615 2 AOI22S $T=657200 880880 1 180 $X=653480 $Y=880500
X642 2949 2898 2983 2937 1 2935 2 AOI22S $T=662160 991760 0 180 $X=658440 $Y=986340
X643 2946 2915 2950 2937 1 2935 2 AOI22S $T=663400 1001840 0 180 $X=659680 $Y=996420
X644 2951 2916 2952 2937 1 2935 2 AOI22S $T=665880 1022000 0 180 $X=662160 $Y=1016580
X645 2895 662 661 663 1 672 2 AOI22S $T=662780 1052240 0 0 $X=662780 $Y=1051860
X646 2954 2944 2955 2937 1 2935 2 AOI22S $T=665260 1032080 0 0 $X=665260 $Y=1031700
X647 2934 2962 2959 663 1 672 2 AOI22S $T=667120 1042160 0 0 $X=667120 $Y=1041780
X648 2957 2973 2965 2981 1 2979 2 AOI22S $T=669600 991760 0 0 $X=669600 $Y=991380
X649 2958 2978 2974 2981 1 2979 2 AOI22S $T=670840 1022000 1 0 $X=670840 $Y=1016580
X650 2956 2992 2963 2981 1 2979 2 AOI22S $T=674560 1001840 0 0 $X=674560 $Y=1001460
X651 3015 3005 3002 2981 1 2979 2 AOI22S $T=682000 1022000 0 180 $X=678280 $Y=1016580
X652 3003 3008 2985 694 1 695 2 AOI22S $T=679520 1042160 0 0 $X=679520 $Y=1041780
X653 3022 2977 3029 3035 1 3037 2 AOI22S $T=690680 981680 0 0 $X=690680 $Y=981300
X654 3028 2989 3030 3035 1 3037 2 AOI22S $T=690680 991760 0 0 $X=690680 $Y=991380
X655 3027 3023 3031 2937 1 2935 2 AOI22S $T=690680 1032080 1 0 $X=690680 $Y=1026660
X656 3046 2964 3044 3035 1 3037 2 AOI22S $T=695640 1001840 0 180 $X=691920 $Y=996420
X657 3032 3000 3036 2981 1 2979 2 AOI22S $T=691920 1011920 0 0 $X=691920 $Y=1011540
X658 3062 3052 3065 694 1 695 2 AOI22S $T=701220 1052240 0 180 $X=697500 $Y=1046820
X659 3071 3063 3079 2937 1 2935 2 AOI22S $T=703080 1032080 0 180 $X=699360 $Y=1026660
X660 3068 706 3064 663 1 672 2 AOI22S $T=703080 1052240 1 180 $X=699360 $Y=1051860
X661 3077 3066 3073 3035 1 3037 2 AOI22S $T=704320 981680 1 180 $X=700600 $Y=981300
X662 3090 3035 3082 2976 1 3037 2 AOI22S $T=705560 1001840 0 180 $X=701840 $Y=996420
X663 3096 3083 3103 2981 1 2979 2 AOI22S $T=707420 1022000 0 180 $X=703700 $Y=1016580
X664 3076 3097 3093 3107 1 3112 2 AOI22S $T=709280 941360 0 0 $X=709280 $Y=940980
X665 3084 3088 3060 3107 1 3112 2 AOI22S $T=709280 951440 0 0 $X=709280 $Y=951060
X666 3127 3117 3089 3107 1 3112 2 AOI22S $T=714860 961520 1 180 $X=711140 $Y=961140
X667 3129 3120 3092 3107 1 3112 2 AOI22S $T=715480 971600 1 180 $X=711760 $Y=971220
X668 3110 3101 3113 3035 1 3037 2 AOI22S $T=711760 991760 0 0 $X=711760 $Y=991380
X669 3106 3118 3114 3035 1 3037 2 AOI22S $T=711760 1001840 1 0 $X=711760 $Y=996420
X670 3111 3119 3116 3107 1 3112 2 AOI22S $T=712380 931280 1 0 $X=712380 $Y=925860
X671 3130 3122 3147 2937 1 2935 2 AOI22S $T=716100 1032080 0 180 $X=712380 $Y=1026660
X672 3126 3138 3136 3107 1 3112 2 AOI22S $T=716720 911120 0 0 $X=716720 $Y=910740
X673 3121 3140 3135 2981 1 2979 2 AOI22S $T=717340 1011920 1 0 $X=717340 $Y=1006500
X674 3151 3164 3158 3035 1 3037 2 AOI22S $T=721680 1001840 1 0 $X=721680 $Y=996420
X675 3149 3167 3134 694 1 695 2 AOI22S $T=722300 1052240 1 0 $X=722300 $Y=1046820
X676 3178 3172 3144 3107 1 3112 2 AOI22S $T=727260 961520 0 180 $X=723540 $Y=956100
X677 3168 3173 3146 3107 1 3112 2 AOI22S $T=724160 971600 0 0 $X=724160 $Y=971220
X678 3161 3154 3169 2981 1 2979 2 AOI22S $T=724160 1011920 1 0 $X=724160 $Y=1006500
X679 3170 3174 3165 2937 1 2935 2 AOI22S $T=724160 1022000 0 0 $X=724160 $Y=1021620
X680 3201 3162 3184 3107 1 3112 2 AOI22S $T=728500 911120 1 180 $X=724780 $Y=910740
X681 3187 3194 3160 3206 1 3211 2 AOI22S $T=730360 971600 0 0 $X=730360 $Y=971220
X682 3177 3180 3195 2937 1 2935 2 AOI22S $T=730360 1022000 0 0 $X=730360 $Y=1021620
X683 3186 3190 3159 3206 1 3211 2 AOI22S $T=730980 961520 1 0 $X=730980 $Y=956100
X684 3200 727 3193 663 1 672 2 AOI22S $T=731600 1052240 0 0 $X=731600 $Y=1051860
X685 3205 3209 3197 3035 1 3037 2 AOI22S $T=732220 991760 0 0 $X=732220 $Y=991380
X686 3263 3204 3152 3206 1 3211 2 AOI22S $T=739040 921200 1 180 $X=735320 $Y=920820
X687 3212 3215 3070 3206 1 3211 2 AOI22S $T=735320 951440 1 0 $X=735320 $Y=946020
X688 3230 3222 3218 2981 1 2979 2 AOI22S $T=740280 1022000 0 180 $X=736560 $Y=1016580
X689 3228 3224 3108 3206 1 3211 2 AOI22S $T=740900 971600 1 180 $X=737180 $Y=971220
X690 3220 3225 3100 3206 1 3211 2 AOI22S $T=738420 961520 1 0 $X=738420 $Y=956100
X691 3249 3216 3253 3035 1 3037 2 AOI22S $T=744000 991760 1 180 $X=740280 $Y=991380
X692 3226 735 3207 694 1 695 2 AOI22S $T=740280 1052240 0 0 $X=740280 $Y=1051860
X693 3254 3244 3231 2937 1 2935 2 AOI22S $T=744620 1032080 0 180 $X=740900 $Y=1026660
X694 3229 3238 3175 3206 1 3211 2 AOI22S $T=741520 941360 1 0 $X=741520 $Y=935940
X695 3221 3239 3128 3206 1 3211 2 AOI22S $T=741520 951440 1 0 $X=741520 $Y=946020
X696 3252 3258 3208 2981 1 2979 2 AOI22S $T=745860 1011920 1 0 $X=745860 $Y=1006500
X697 3255 742 3264 694 1 695 2 AOI22S $T=748340 1052240 0 0 $X=748340 $Y=1051860
X698 3266 3268 3210 3206 1 3211 2 AOI22S $T=749580 921200 0 0 $X=749580 $Y=920820
X699 3280 3276 3262 3107 1 3112 2 AOI22S $T=755160 911120 1 180 $X=751440 $Y=910740
X700 3284 3277 3309 2937 1 2935 2 AOI22S $T=755160 1032080 1 180 $X=751440 $Y=1031700
X701 3278 3272 3281 3107 1 3112 2 AOI22S $T=754540 971600 1 0 $X=754540 $Y=966180
X702 3300 3282 3297 2981 1 2979 2 AOI22S $T=758260 1022000 0 180 $X=754540 $Y=1016580
X703 3286 3293 3290 3035 1 3037 2 AOI22S $T=756400 991760 1 0 $X=756400 $Y=986340
X704 3307 3299 3306 3206 1 3211 2 AOI22S $T=761360 971600 1 180 $X=757640 $Y=971220
X705 3289 3295 3296 2981 1 2979 2 AOI22S $T=758260 1001840 1 0 $X=758260 $Y=996420
X706 3316 3302 3265 3206 1 3211 2 AOI22S $T=762600 921200 1 180 $X=758880 $Y=920820
X707 3315 3308 3319 2981 1 2979 2 AOI22S $T=763840 1022000 0 180 $X=760120 $Y=1016580
X708 755 756 3288 663 1 672 2 AOI22S $T=760120 1052240 0 0 $X=760120 $Y=1051860
X709 3326 3328 3338 2937 1 2935 2 AOI22S $T=768800 1032080 0 180 $X=765080 $Y=1026660
X710 3312 3332 3322 3035 1 3037 2 AOI22S $T=766940 991760 1 0 $X=766940 $Y=986340
X711 764 762 3314 663 1 672 2 AOI22S $T=770660 1052240 1 180 $X=766940 $Y=1051860
X712 3325 3331 3329 694 1 695 2 AOI22S $T=768180 1042160 0 0 $X=768180 $Y=1041780
X713 3353 3341 3361 3107 1 3112 2 AOI22S $T=773760 971600 0 180 $X=770040 $Y=966180
X714 3320 3347 3346 2937 1 2935 2 AOI22S $T=770660 1011920 1 0 $X=770660 $Y=1006500
X715 3340 3336 3339 2937 1 2935 2 AOI22S $T=771280 1001840 0 0 $X=771280 $Y=1001460
X716 3373 3364 3376 3206 1 3211 2 AOI22S $T=778720 921200 1 180 $X=775000 $Y=920820
X717 3356 3354 3358 3206 1 3211 2 AOI22S $T=775000 971600 0 0 $X=775000 $Y=971220
X718 3388 3335 3370 3035 1 3037 2 AOI22S $T=779340 991760 0 180 $X=775620 $Y=986340
X719 3366 3360 3369 3107 1 3112 2 AOI22S $T=777480 921200 1 0 $X=777480 $Y=915780
X720 3404 3382 3400 3035 1 3037 2 AOI22S $T=785540 991760 0 180 $X=781820 $Y=986340
X721 3385 3390 3381 663 1 672 2 AOI22S $T=785540 1052240 0 180 $X=781820 $Y=1046820
X722 3417 3389 3431 3107 1 3112 2 AOI22S $T=787400 961520 1 180 $X=783680 $Y=961140
X723 3410 3407 3380 2981 1 2979 2 AOI22S $T=787400 1001840 1 180 $X=783680 $Y=1001460
X724 3406 3396 3425 3206 1 3211 2 AOI22S $T=789880 931280 1 180 $X=786160 $Y=930900
X725 3405 3413 3411 2981 1 2979 2 AOI22S $T=786780 1022000 0 0 $X=786780 $Y=1021620
X726 3387 3419 3418 2937 1 2935 2 AOI22S $T=788020 1032080 1 0 $X=788020 $Y=1026660
X727 3401 3423 3384 694 1 695 2 AOI22S $T=788640 1042160 1 0 $X=788640 $Y=1036740
X728 3438 3428 3430 3035 1 3037 2 AOI22S $T=793600 1001840 0 180 $X=789880 $Y=996420
X729 3440 3435 3415 3107 1 3112 2 AOI22S $T=795460 921200 0 180 $X=791740 $Y=915780
X730 3414 3436 3434 3206 1 3211 2 AOI22S $T=792360 981680 1 0 $X=792360 $Y=976260
X731 3461 3455 3458 2937 1 2935 2 AOI22S $T=803520 1022000 1 180 $X=799800 $Y=1021620
X732 3469 3444 3442 2937 1 2935 2 AOI22S $T=805380 1032080 0 180 $X=801660 $Y=1026660
X733 3457 3468 3463 3107 1 3112 2 AOI22S $T=803520 941360 1 0 $X=803520 $Y=935940
X734 3451 3471 3467 694 1 695 2 AOI22S $T=803520 1052240 1 0 $X=803520 $Y=1046820
X735 3465 3462 3450 2981 1 2979 2 AOI22S $T=804140 1022000 1 0 $X=804140 $Y=1016580
X736 3472 3394 3475 3107 1 3112 2 AOI22S $T=806000 961520 1 0 $X=806000 $Y=956100
X737 3488 3483 3489 3206 1 3211 2 AOI22S $T=809720 971600 0 180 $X=806000 $Y=966180
X738 3493 3448 3499 3035 1 3037 2 AOI22S $T=809720 991760 0 180 $X=806000 $Y=986340
X739 3500 3491 3497 2981 1 2979 2 AOI22S $T=811580 1001840 1 180 $X=807860 $Y=1001460
X740 3474 3490 3485 3035 1 3037 2 AOI22S $T=808480 981680 0 0 $X=808480 $Y=981300
X741 811 3505 3480 663 1 672 2 AOI22S $T=819640 1042160 1 180 $X=815920 $Y=1041780
X742 3522 3513 3509 3206 1 3211 2 AOI22S $T=819020 931280 0 0 $X=819020 $Y=930900
X743 3548 3571 3577 694 1 695 2 AOI22S $T=832040 1042160 0 0 $X=832040 $Y=1041780
X744 839 3544 838 694 1 695 2 AOI22S $T=840720 1052240 1 180 $X=837000 $Y=1051860
X745 3562 3576 3596 2937 1 2935 2 AOI22S $T=838240 1011920 1 0 $X=838240 $Y=1006500
X746 3563 3586 3595 2937 1 2935 2 AOI22S $T=838240 1032080 1 0 $X=838240 $Y=1026660
X747 3591 3606 3605 3581 1 3561 2 AOI22S $T=841340 961520 0 0 $X=841340 $Y=961140
X748 3623 3636 3632 3581 1 3561 2 AOI22S $T=847540 961520 0 0 $X=847540 $Y=961140
X749 3588 3579 3633 3645 1 3597 2 AOI22S $T=847540 991760 0 0 $X=847540 $Y=991380
X750 3631 3638 3598 663 1 819 2 AOI22S $T=851260 1042160 0 180 $X=847540 $Y=1036740
X751 3621 3625 3640 3593 1 2935 2 AOI22S $T=850020 981680 0 0 $X=850020 $Y=981300
X752 3622 3642 3618 3645 1 3597 2 AOI22S $T=850020 1032080 1 0 $X=850020 $Y=1026660
X753 3660 3657 3659 850 1 826 2 AOI22S $T=856220 941360 1 180 $X=852500 $Y=940980
X754 3663 3654 3658 663 1 819 2 AOI22S $T=856220 1022000 1 180 $X=852500 $Y=1021620
X755 3664 852 855 663 1 819 2 AOI22S $T=856220 1052240 1 180 $X=852500 $Y=1051860
X756 3679 3665 3676 3645 1 3597 2 AOI22S $T=859320 991760 0 180 $X=855600 $Y=986340
X757 3680 3652 3608 3645 1 3597 2 AOI22S $T=859320 1011920 0 180 $X=855600 $Y=1006500
X758 3671 3611 3681 3581 1 3561 2 AOI22S $T=859940 961520 1 180 $X=856220 $Y=961140
X759 3668 3672 3669 3593 1 3587 2 AOI22S $T=856220 981680 1 0 $X=856220 $Y=976260
X760 3698 3693 3662 848 1 3582 2 AOI22S $T=864280 1001840 1 180 $X=860560 $Y=1001460
X761 3667 3694 3688 3581 1 3561 2 AOI22S $T=864900 961520 1 180 $X=861180 $Y=961140
X762 3656 3697 3690 840 1 857 2 AOI22S $T=862420 901040 1 0 $X=862420 $Y=895620
X763 3649 3648 3675 840 1 857 2 AOI22S $T=863660 931280 1 0 $X=863660 $Y=925860
X764 3699 3707 3706 840 1 857 2 AOI22S $T=864900 911120 0 0 $X=864900 $Y=910740
X765 3627 3677 865 3581 1 3561 2 AOI22S $T=864900 961520 0 0 $X=864900 $Y=961140
X766 3718 3710 3714 3645 1 3597 2 AOI22S $T=869860 1032080 0 180 $X=866140 $Y=1026660
X767 3715 3719 3692 850 1 826 2 AOI22S $T=869240 911120 1 0 $X=869240 $Y=905700
X768 3716 3722 3701 850 1 826 2 AOI22S $T=869860 890960 0 0 $X=869860 $Y=890580
X769 3702 3721 3712 3645 1 3597 2 AOI22S $T=870480 1042160 0 0 $X=870480 $Y=1041780
X770 3731 3711 3728 3593 1 3587 2 AOI22S $T=874820 981680 1 180 $X=871100 $Y=981300
X771 3723 3725 3724 3645 1 3597 2 AOI22S $T=871100 991760 0 0 $X=871100 $Y=991380
X772 3708 3726 3682 840 1 857 2 AOI22S $T=872340 931280 1 0 $X=872340 $Y=925860
X773 3750 3729 3670 850 1 826 2 AOI22S $T=876060 931280 1 180 $X=872340 $Y=930900
X774 3737 3705 3717 2937 1 2935 2 AOI22S $T=877920 1042160 1 180 $X=874200 $Y=1041780
X775 3749 3740 3756 850 1 826 2 AOI22S $T=881640 941360 0 180 $X=877920 $Y=935940
X776 3744 3742 3745 2937 1 2935 2 AOI22S $T=878540 1042160 0 0 $X=878540 $Y=1041780
X777 3727 3741 879 3581 1 3561 2 AOI22S $T=882880 961520 1 180 $X=879160 $Y=961140
X778 3748 3738 3739 848 1 3582 2 AOI22S $T=879780 1011920 0 0 $X=879780 $Y=1011540
X779 3758 3752 3736 3574 1 819 2 AOI22S $T=883500 1022000 1 180 $X=879780 $Y=1021620
X780 3765 3753 3776 850 1 826 2 AOI22S $T=886600 901040 1 180 $X=882880 $Y=900660
X781 3735 3751 881 3581 1 3561 2 AOI22S $T=882880 971600 0 0 $X=882880 $Y=971220
X782 3763 3768 3761 3645 1 3597 2 AOI22S $T=884740 991760 0 0 $X=884740 $Y=991380
X783 3771 3760 3759 840 1 857 2 AOI22S $T=888460 921200 0 0 $X=888460 $Y=920820
X784 3786 3770 3764 3581 1 3561 2 AOI22S $T=892180 971600 0 180 $X=888460 $Y=966180
X785 3781 3769 3772 3593 1 3587 2 AOI22S $T=892180 981680 1 0 $X=892180 $Y=976260
X786 3782 3791 3789 848 1 3582 2 AOI22S $T=892180 1011920 1 0 $X=892180 $Y=1006500
X787 3785 3796 3790 2937 1 2935 2 AOI22S $T=892800 1042160 0 0 $X=892800 $Y=1041780
X788 3823 3799 3777 3574 1 819 2 AOI22S $T=897140 1011920 1 180 $X=893420 $Y=1011540
X789 3779 3798 3797 3645 1 3597 2 AOI22S $T=894660 1032080 0 0 $X=894660 $Y=1031700
X790 3801 3804 3784 3581 1 3561 2 AOI22S $T=895900 981680 1 0 $X=895900 $Y=976260
X791 3814 3807 3803 840 1 857 2 AOI22S $T=900860 901040 1 180 $X=897140 $Y=900660
X792 3811 3806 3809 3645 1 3597 2 AOI22S $T=900860 1032080 1 0 $X=900860 $Y=1026660
X793 3815 3813 3818 3581 1 3561 2 AOI22S $T=902720 971600 1 0 $X=902720 $Y=966180
X794 3837 3824 3816 2937 1 2935 2 AOI22S $T=906440 1042160 1 180 $X=902720 $Y=1041780
X795 3831 3827 3810 848 1 3582 2 AOI22S $T=907060 1011920 0 180 $X=903340 $Y=1006500
X796 3817 3826 3825 840 1 857 2 AOI22S $T=903960 921200 0 0 $X=903960 $Y=920820
X797 3839 3822 3832 3593 1 3587 2 AOI22S $T=907680 991760 0 180 $X=903960 $Y=986340
X798 3812 3820 3819 850 1 826 2 AOI22S $T=904580 931280 1 0 $X=904580 $Y=925860
X799 3838 3841 3829 3645 1 3597 2 AOI22S $T=907680 991760 0 0 $X=907680 $Y=991380
X800 3846 3847 3842 840 1 857 2 AOI22S $T=912020 921200 0 180 $X=908300 $Y=915780
X801 3849 3821 3850 3581 1 3561 2 AOI22S $T=910160 971600 1 0 $X=910160 $Y=966180
X802 3855 3843 3856 2937 1 2935 2 AOI22S $T=913880 1042160 0 180 $X=910160 $Y=1036740
X803 3836 3854 3808 3574 1 819 2 AOI22S $T=911400 1011920 1 0 $X=911400 $Y=1006500
X804 902 898 909 663 1 819 2 AOI22S $T=915120 1052240 1 180 $X=911400 $Y=1051860
X805 3857 3858 899 3581 1 3561 2 AOI22S $T=915120 961520 0 0 $X=915120 $Y=961140
X806 3863 3867 904 3581 1 3561 2 AOI22S $T=916980 971600 0 0 $X=916980 $Y=971220
X807 3865 3869 3848 850 1 826 2 AOI22S $T=917600 941360 1 0 $X=917600 $Y=935940
X808 3859 3868 3861 3645 1 3597 2 AOI22S $T=917600 1032080 0 0 $X=917600 $Y=1031700
X809 3890 3881 3888 3581 1 3561 2 AOI22S $T=926280 961520 1 180 $X=922560 $Y=961140
X810 3872 3880 3874 3593 1 3587 2 AOI22S $T=922560 981680 1 0 $X=922560 $Y=976260
X811 3895 3883 3884 840 1 857 2 AOI22S $T=926900 921200 1 180 $X=923180 $Y=920820
X812 3878 3882 3876 3645 1 3597 2 AOI22S $T=923180 991760 1 0 $X=923180 $Y=986340
X813 3892 3873 3885 3645 1 3597 2 AOI22S $T=926900 1032080 1 180 $X=923180 $Y=1031700
X814 3906 3897 3914 850 1 826 2 AOI22S $T=931240 921200 0 180 $X=927520 $Y=915780
X815 3900 3877 3902 848 1 3582 2 AOI22S $T=931860 1001840 1 180 $X=928140 $Y=1001460
X816 3921 3898 917 3581 1 3561 2 AOI22S $T=932480 961520 0 180 $X=928760 $Y=956100
X817 3923 3891 3919 840 1 857 2 AOI22S $T=933100 901040 1 180 $X=929380 $Y=900660
X818 3918 3911 918 3581 1 3561 2 AOI22S $T=933720 961520 1 180 $X=930000 $Y=961140
X819 3913 3912 3893 3593 1 3587 2 AOI22S $T=933720 981680 0 180 $X=930000 $Y=976260
X820 3896 3909 3903 3574 1 819 2 AOI22S $T=930000 1011920 1 0 $X=930000 $Y=1006500
X821 3929 3916 3910 3581 1 3561 2 AOI22S $T=934340 971600 0 180 $X=930620 $Y=966180
X822 3928 3920 3887 850 1 826 2 AOI22S $T=935580 941360 1 180 $X=931860 $Y=940980
X823 3933 3904 3937 3645 1 3597 2 AOI22S $T=936200 1022000 1 180 $X=932480 $Y=1021620
X824 3922 3924 3935 3645 1 3597 2 AOI22S $T=936820 1042160 0 180 $X=933100 $Y=1036740
X825 3932 3925 3899 3645 1 3597 2 AOI22S $T=937440 991760 0 180 $X=933720 $Y=986340
X826 3905 3926 3915 2937 1 2935 2 AOI22S $T=934340 1042160 0 0 $X=934340 $Y=1041780
X827 3940 3931 3927 3574 1 819 2 AOI22S $T=939920 1011920 0 180 $X=936200 $Y=1006500
X828 3934 3936 3930 848 1 3582 2 AOI22S $T=940540 1001840 1 180 $X=936820 $Y=1001460
X829 3949 3945 3942 2937 1 2935 2 AOI22S $T=946740 1022000 1 180 $X=943020 $Y=1021620
X830 3951 3946 3943 2937 1 2935 2 AOI22S $T=947360 1042160 1 180 $X=943640 $Y=1041780
X831 3956 3941 3961 930 1 929 2 AOI22S $T=949220 941360 0 180 $X=945500 $Y=935940
X832 3964 3955 3966 930 1 929 2 AOI22S $T=950460 890960 0 180 $X=946740 $Y=885540
X833 3983 3972 3974 933 1 932 2 AOI22S $T=954180 961520 0 180 $X=950460 $Y=956100
X834 3953 3971 3967 930 1 929 2 AOI22S $T=951080 901040 1 0 $X=951080 $Y=895620
X835 3954 3978 3962 933 1 932 2 AOI22S $T=952320 951440 1 0 $X=952320 $Y=946020
X836 3950 3979 931 933 1 932 2 AOI22S $T=952320 951440 0 0 $X=952320 $Y=951060
X837 3968 3965 3973 930 1 929 2 AOI22S $T=954180 921200 1 0 $X=954180 $Y=915780
X838 3976 3969 3987 930 1 929 2 AOI22S $T=954800 931280 0 0 $X=954800 $Y=930900
X839 3989 3996 4007 940 1 941 2 AOI22S $T=959140 971600 1 0 $X=959140 $Y=966180
X840 4004 3975 4009 940 1 941 2 AOI22S $T=960380 1001840 0 0 $X=960380 $Y=1001460
X841 4028 4017 3999 933 1 932 2 AOI22S $T=965340 961520 0 180 $X=961620 $Y=956100
X842 4021 3995 4050 940 1 941 2 AOI22S $T=965340 1011920 1 180 $X=961620 $Y=1011540
X843 4012 943 3984 944 1 942 2 AOI22S $T=962240 890960 1 0 $X=962240 $Y=885540
X844 4030 4019 3981 944 1 942 2 AOI22S $T=965960 911120 1 180 $X=962240 $Y=910740
X845 4025 4006 3970 944 1 942 2 AOI22S $T=965960 931280 1 180 $X=962240 $Y=930900
X846 4000 4001 4018 940 1 941 2 AOI22S $T=962860 981680 0 0 $X=962860 $Y=981300
X847 4011 4029 4027 949 1 947 2 AOI22S $T=964720 1042160 0 0 $X=964720 $Y=1041780
X848 4023 4033 3994 944 1 942 2 AOI22S $T=965340 901040 1 0 $X=965340 $Y=895620
X849 3982 3992 4040 940 1 941 2 AOI22S $T=967200 991760 0 0 $X=967200 $Y=991380
X850 4016 4047 4044 949 1 947 2 AOI22S $T=967820 1022000 1 0 $X=967820 $Y=1016580
X851 4046 4051 4039 933 1 932 2 AOI22S $T=968440 971600 0 0 $X=968440 $Y=971220
X852 4013 4052 4042 949 1 947 2 AOI22S $T=968440 1032080 0 0 $X=968440 $Y=1031700
X853 4032 4057 4038 944 1 942 2 AOI22S $T=969680 941360 0 0 $X=969680 $Y=940980
X854 4036 4058 4022 958 1 960 2 AOI22S $T=972780 971600 1 0 $X=972780 $Y=966180
X855 4062 4067 4065 962 1 964 2 AOI22S $T=974640 1032080 0 0 $X=974640 $Y=1031700
X856 4024 3997 4031 958 1 960 2 AOI22S $T=975260 1011920 1 0 $X=975260 $Y=1006500
X857 4072 4049 4078 958 1 960 2 AOI22S $T=982080 991760 1 180 $X=978360 $Y=991380
X858 4123 4080 4068 962 1 964 2 AOI22S $T=983320 1052240 0 180 $X=979600 $Y=1046820
X859 4076 4084 4081 930 1 929 2 AOI22S $T=980840 931280 0 0 $X=980840 $Y=930900
X860 4104 4087 3988 933 1 932 2 AOI22S $T=984560 951440 1 180 $X=980840 $Y=951060
X861 4098 4092 4096 958 1 960 2 AOI22S $T=984560 991760 1 0 $X=984560 $Y=986340
X862 4101 4105 4091 944 1 942 2 AOI22S $T=985180 931280 0 0 $X=985180 $Y=930900
X863 4099 4100 4064 962 1 964 2 AOI22S $T=988900 1022000 0 180 $X=985180 $Y=1016580
X864 4110 4117 4056 958 1 960 2 AOI22S $T=989520 1001840 1 0 $X=989520 $Y=996420
X865 4126 4121 4122 962 1 964 2 AOI22S $T=993860 1032080 0 180 $X=990140 $Y=1026660
X866 4133 4132 4094 958 1 960 2 AOI22S $T=996960 1001840 0 180 $X=993240 $Y=996420
X867 970 4130 4129 944 1 942 2 AOI22S $T=993860 890960 1 0 $X=993860 $Y=885540
X868 4128 4095 4089 940 1 941 2 AOI22S $T=994480 971600 0 0 $X=994480 $Y=971220
X869 4079 933 4088 4139 1 932 2 AOI22S $T=995720 961520 0 0 $X=995720 $Y=961140
X870 4150 4141 4143 930 1 929 2 AOI22S $T=1001300 901040 1 180 $X=997580 $Y=900660
X871 4155 4118 4149 944 1 942 2 AOI22S $T=1001920 931280 1 180 $X=998200 $Y=930900
X872 4160 4153 4158 962 1 964 2 AOI22S $T=1003780 1022000 0 180 $X=1000060 $Y=1016580
X873 4114 4131 4119 949 1 947 2 AOI22S $T=1000680 1032080 0 0 $X=1000680 $Y=1031700
X874 4152 4159 4164 949 1 947 2 AOI22S $T=1005020 1022000 1 180 $X=1001300 $Y=1021620
X875 4144 4140 4151 940 1 941 2 AOI22S $T=1002540 981680 1 0 $X=1002540 $Y=976260
X876 4156 4145 4162 930 1 929 2 AOI22S $T=1004400 931280 0 0 $X=1004400 $Y=930900
X877 4175 4173 4157 933 1 932 2 AOI22S $T=1008120 951440 0 180 $X=1004400 $Y=946020
X878 4176 4135 4137 958 1 960 2 AOI22S $T=1009980 981680 0 180 $X=1006260 $Y=976260
X879 978 4177 4154 949 1 947 2 AOI22S $T=1009980 1052240 1 180 $X=1006260 $Y=1051860
X880 4174 4184 4195 958 1 960 2 AOI22S $T=1011840 1001840 1 180 $X=1008120 $Y=1001460
X881 4203 4191 4181 940 1 941 2 AOI22S $T=1015560 981680 0 180 $X=1011840 $Y=976260
X882 4192 4198 4197 949 1 947 2 AOI22S $T=1014320 1032080 0 0 $X=1014320 $Y=1031700
X883 981 979 4201 949 1 947 2 AOI22S $T=1018660 1052240 1 180 $X=1014940 $Y=1051860
X884 982 4200 4224 944 1 942 2 AOI22S $T=1020520 890960 0 180 $X=1016800 $Y=885540
X885 4218 4206 4187 930 1 929 2 AOI22S $T=1022380 931280 0 180 $X=1018660 $Y=925860
X886 4209 4202 4188 958 1 960 2 AOI22S $T=1019900 991760 1 0 $X=1019900 $Y=986340
X887 4216 4213 4182 933 1 932 2 AOI22S $T=1021140 951440 0 0 $X=1021140 $Y=951060
X888 4208 4225 4183 944 1 942 2 AOI22S $T=1021760 941360 0 0 $X=1021760 $Y=940980
X889 4239 4228 4233 958 1 960 2 AOI22S $T=1025480 991760 1 180 $X=1021760 $Y=991380
X890 4215 4217 4226 940 1 941 2 AOI22S $T=1022380 981680 0 0 $X=1022380 $Y=981300
X891 4219 4230 4214 940 1 941 2 AOI22S $T=1023620 1011920 0 0 $X=1023620 $Y=1011540
X892 4242 4236 4238 930 1 929 2 AOI22S $T=1028580 901040 0 180 $X=1024860 $Y=895620
X893 4194 4235 4205 962 1 964 2 AOI22S $T=1024860 1032080 1 0 $X=1024860 $Y=1026660
X894 4243 4245 4246 949 1 947 2 AOI22S $T=1031680 1032080 1 180 $X=1027960 $Y=1031700
X895 4212 4234 4229 933 1 932 2 AOI22S $T=1029820 961520 1 0 $X=1029820 $Y=956100
X896 4257 4256 4168 933 1 932 2 AOI22S $T=1036020 951440 0 180 $X=1032300 $Y=946020
X897 4249 4254 4251 958 1 960 2 AOI22S $T=1032300 981680 0 0 $X=1032300 $Y=981300
X898 4270 4266 4268 940 1 941 2 AOI22S $T=1041600 1011920 1 180 $X=1037880 $Y=1011540
X899 4258 4262 4253 940 1 941 2 AOI22S $T=1039120 981680 1 0 $X=1039120 $Y=976260
X900 4273 4272 4275 933 1 932 2 AOI22S $T=1043460 951440 1 180 $X=1039740 $Y=951060
X901 4267 4269 4263 958 1 960 2 AOI22S $T=1039740 991760 0 0 $X=1039740 $Y=991380
X902 4294 4281 4291 930 1 929 2 AOI22S $T=1047180 901040 0 180 $X=1043460 $Y=895620
X903 4293 4295 4296 930 1 929 2 AOI22S $T=1047800 931280 1 0 $X=1047800 $Y=925860
X904 4282 4286 4244 962 1 964 2 AOI22S $T=1047800 1032080 0 0 $X=1047800 $Y=1031700
X905 4283 4287 4299 962 1 964 2 AOI22S $T=1048420 1042160 0 0 $X=1048420 $Y=1041780
X906 994 4302 4280 944 1 942 2 AOI22S $T=1049040 890960 1 0 $X=1049040 $Y=885540
X907 4285 4303 4300 940 1 941 2 AOI22S $T=1049040 1011920 0 0 $X=1049040 $Y=1011540
X908 4317 4311 4318 944 1 942 2 AOI22S $T=1056480 890960 0 180 $X=1052760 $Y=885540
X909 4248 4292 4305 944 1 942 2 AOI22S $T=1053380 941360 1 0 $X=1053380 $Y=935940
X910 4304 4312 4319 944 1 942 2 AOI22S $T=1057100 941360 1 180 $X=1053380 $Y=940980
X911 4333 4324 4357 940 1 941 2 AOI22S $T=1058960 991760 0 180 $X=1055240 $Y=986340
X912 4271 4327 4329 944 1 942 2 AOI22S $T=1059580 931280 1 180 $X=1055860 $Y=930900
X913 4306 4313 4323 940 1 941 2 AOI22S $T=1056480 971600 1 0 $X=1056480 $Y=966180
X914 4309 4331 4330 962 1 964 2 AOI22S $T=1057720 1032080 1 0 $X=1057720 $Y=1026660
X915 4322 4336 4279 933 1 932 2 AOI22S $T=1059580 951440 0 0 $X=1059580 $Y=951060
X916 4343 4316 4353 958 1 960 2 AOI22S $T=1063300 1001840 1 180 $X=1059580 $Y=1001460
X917 4346 4338 4325 933 1 932 2 AOI22S $T=1063920 951440 0 180 $X=1060200 $Y=946020
X918 4363 4342 4350 940 1 941 2 AOI22S $T=1066400 981680 0 180 $X=1062680 $Y=976260
X919 4359 4314 4364 940 1 941 2 AOI22S $T=1067640 991760 1 180 $X=1063920 $Y=991380
X920 4334 4351 4339 962 1 964 2 AOI22S $T=1063920 1022000 0 0 $X=1063920 $Y=1021620
X921 4369 4360 4381 962 1 964 2 AOI22S $T=1069500 1042160 1 180 $X=1065780 $Y=1041780
X922 4378 4367 4349 933 1 932 2 AOI22S $T=1072600 941360 1 180 $X=1068880 $Y=940980
X923 4383 4368 999 933 1 932 2 AOI22S $T=1072600 951440 0 180 $X=1068880 $Y=946020
X924 4384 4354 4356 933 1 932 2 AOI22S $T=1073220 951440 1 180 $X=1069500 $Y=951060
X925 4379 4371 4332 930 1 929 2 AOI22S $T=1074460 931280 1 180 $X=1070740 $Y=930900
X926 4380 4372 4374 949 1 947 2 AOI22S $T=1074460 1022000 0 180 $X=1070740 $Y=1016580
X927 4388 4373 4347 949 1 947 2 AOI22S $T=1074460 1032080 0 180 $X=1070740 $Y=1026660
X928 4386 4375 4362 958 1 960 2 AOI22S $T=1075080 981680 1 180 $X=1071360 $Y=981300
X929 4402 4390 4376 949 1 947 2 AOI22S $T=1081900 1042160 1 180 $X=1078180 $Y=1041780
X930 4399 4391 4377 930 1 929 2 AOI22S $T=1082520 890960 1 180 $X=1078800 $Y=890580
X931 4401 4392 4389 958 1 960 2 AOI22S $T=1082520 971600 0 180 $X=1078800 $Y=966180
X932 4400 4397 4358 930 1 929 2 AOI22S $T=1086860 931280 0 180 $X=1083140 $Y=925860
X933 4393 4398 4387 958 1 960 2 AOI22S $T=1084380 991760 0 0 $X=1084380 $Y=991380
X934 4395 4396 4394 958 1 960 2 AOI22S $T=1084380 1001840 0 0 $X=1084380 $Y=1001460
X935 1028 1035 1 2 1067 AN2 $T=222580 1032080 1 0 $X=222580 $Y=1026660
X936 1180 1189 1 2 1188 AN2 $T=250480 981680 0 0 $X=250480 $Y=981300
X937 1384 1389 1 2 1398 AN2 $T=285200 981680 1 0 $X=285200 $Y=976260
X938 1428 1397 1 2 1375 AN2 $T=290780 941360 1 180 $X=288300 $Y=940980
X939 1263 1371 1 2 1441 AN2 $T=291400 911120 1 0 $X=291400 $Y=905700
X940 1260 1451 1 2 1424 AN2 $T=298220 1032080 1 180 $X=295740 $Y=1031700
X941 121 76 1 2 111 AN2 $T=301940 890960 1 180 $X=299460 $Y=890580
X942 1472 1457 1 2 1490 AN2 $T=301320 951440 1 0 $X=301320 $Y=946020
X943 1372 1529 1 2 1437 AN2 $T=312480 921200 0 180 $X=310000 $Y=915780
X944 1272 1273 1 2 1536 AN2 $T=312480 1001840 0 0 $X=312480 $Y=1001460
X945 39 1541 1 2 1544 AN2 $T=313100 1052240 1 0 $X=313100 $Y=1046820
X946 1570 1372 1 2 1471 AN2 $T=316200 911120 0 180 $X=313720 $Y=905700
X947 1595 1567 1 2 1150 AN2 $T=323020 971600 0 180 $X=320540 $Y=966180
X948 164 88 1 2 1628 AN2 $T=332320 1022000 1 0 $X=332320 $Y=1016580
X949 1642 1702 1 2 1600 AN2 $T=352160 1042160 0 180 $X=349680 $Y=1036740
X950 1714 1584 1 2 1707 AN2 $T=356500 941360 1 180 $X=354020 $Y=940980
X951 211 1731 1 2 1630 AN2 $T=359600 951440 1 180 $X=357120 $Y=951060
X952 1711 1733 1 2 1374 AN2 $T=360220 951440 0 180 $X=357740 $Y=946020
X953 1731 1748 1 2 1637 AN2 $T=363320 951440 0 180 $X=360840 $Y=946020
X954 1759 1671 1 2 1720 AN2 $T=365180 921200 1 180 $X=362700 $Y=920820
X955 1321 1751 1 2 1782 AN2 $T=369520 1042160 0 0 $X=369520 $Y=1041780
X956 223 229 1 2 1817 AN2 $T=385020 901040 0 180 $X=382540 $Y=895620
X957 1846 229 1 2 1742 AN2 $T=389980 961520 0 180 $X=387500 $Y=956100
X958 1846 1785 1 2 1755 AN2 $T=392460 951440 0 180 $X=389980 $Y=946020
X959 1708 1705 1 2 1876 AN2 $T=398040 951440 1 0 $X=398040 $Y=946020
X960 1886 1699 1 2 1870 AN2 $T=411060 981680 1 180 $X=408580 $Y=981300
X961 1946 1949 1 2 1976 AN2 $T=424080 931280 0 0 $X=424080 $Y=930900
X962 283 1987 1 2 299 AN2 $T=434620 890960 0 180 $X=432140 $Y=885540
X963 223 229 1 2 1996 AN2 $T=433380 951440 0 0 $X=433380 $Y=951060
X964 1976 1959 1 2 2020 AN2 $T=435240 941360 0 0 $X=435240 $Y=940980
X965 2008 2002 1 2 1906 AN2 $T=437720 1022000 0 180 $X=435240 $Y=1016580
X966 303 2025 1 2 2035 AN2 $T=441440 931280 1 0 $X=441440 $Y=925860
X967 324 1985 1 2 2042 AN2 $T=441440 1001840 1 0 $X=441440 $Y=996420
X968 287 2051 1 2 2067 AN2 $T=445780 1032080 1 0 $X=445780 $Y=1026660
X969 2115 371 1 2 1978 AN2 $T=460040 1042160 0 180 $X=457560 $Y=1036740
X970 2156 2136 1 2 2197 AN2 $T=471200 991760 0 0 $X=471200 $Y=991380
X971 2083 2210 1 2 412 AN2 $T=474920 921200 1 0 $X=474920 $Y=915780
X972 2111 2177 1 2 2229 AN2 $T=476160 971600 0 0 $X=476160 $Y=971220
X973 2286 2129 1 2 2365 AN2 $T=505300 961520 1 0 $X=505300 $Y=956100
X974 2418 211 1 2 2384 AN2 $T=520180 951440 0 0 $X=520180 $Y=951060
X975 2418 2392 1 2 2381 AN2 $T=524520 951440 0 0 $X=524520 $Y=951060
X976 2455 2392 1 2 2358 AN2 $T=528240 951440 1 0 $X=528240 $Y=946020
X977 2302 2440 1 2 2187 AN2 $T=531340 931280 0 180 $X=528860 $Y=925860
X978 2455 211 1 2 2417 AN2 $T=530720 951440 0 0 $X=530720 $Y=951060
X979 344 2479 1 2 2248 AN2 $T=533820 901040 1 180 $X=531340 $Y=900660
X980 2525 2522 1 2 2426 AN2 $T=541880 931280 0 180 $X=539400 $Y=925860
X981 342 556 1 2 2449 AN2 $T=563580 941360 0 180 $X=561100 $Y=935940
X982 596 2712 1 2 2700 AN2 $T=588380 991760 1 180 $X=585900 $Y=991380
X983 2671 2629 1 2 2745 AN2 $T=595820 1001840 0 0 $X=595820 $Y=1001460
X984 627 2859 1 2 2834 AN2 $T=632400 921200 1 180 $X=629920 $Y=920820
X985 2985 2959 1 2 2968 AN2 $T=672080 1042160 0 180 $X=669600 $Y=1036740
X986 3065 3064 1 2 3055 AN2 $T=702460 1042160 1 180 $X=699980 $Y=1041780
X987 3134 716 1 2 3141 AN2 $T=716720 1052240 1 0 $X=716720 $Y=1046820
X988 3207 3193 1 2 3171 AN2 $T=731600 1052240 0 180 $X=729120 $Y=1046820
X989 3264 3288 1 2 3291 AN2 $T=755780 1052240 0 0 $X=755780 $Y=1051860
X990 3329 3314 1 2 3310 AN2 $T=764460 1042160 1 180 $X=761980 $Y=1041780
X991 3384 3381 1 2 3374 AN2 $T=781200 1042160 0 180 $X=778720 $Y=1036740
X992 3467 3480 1 2 3484 AN2 $T=806000 1042160 0 0 $X=806000 $Y=1041780
X993 3543 3540 1 2 3206 AN2 $T=824600 971600 1 180 $X=822120 $Y=971220
X994 3540 813 1 2 2979 AN2 $T=825220 1001840 0 180 $X=822740 $Y=996420
X995 3559 3540 1 2 2972 AN2 $T=826460 961520 1 180 $X=823980 $Y=961140
X996 3540 3550 1 2 819 AN2 $T=825220 1001840 1 0 $X=825220 $Y=996420
X997 3543 3560 1 2 3112 AN2 $T=828940 971600 0 180 $X=826460 $Y=966180
X998 3559 3560 1 2 2984 AN2 $T=827700 961520 0 0 $X=827700 $Y=961140
X999 3543 3567 1 2 3561 AN2 $T=830180 981680 0 180 $X=827700 $Y=976260
X1000 3560 813 1 2 2981 AN2 $T=827700 1001840 1 0 $X=827700 $Y=996420
X1001 3543 3572 1 2 3107 AN2 $T=830180 981680 1 0 $X=830180 $Y=976260
X1002 3560 3550 1 2 3574 AN2 $T=830180 1001840 1 0 $X=830180 $Y=996420
X1003 3572 3550 1 2 3582 AN2 $T=830800 991760 1 0 $X=830800 $Y=986340
X1004 3559 3572 1 2 2970 AN2 $T=834520 961520 1 180 $X=832040 $Y=961140
X1005 3559 3567 1 2 3211 AN2 $T=833280 971600 1 0 $X=833280 $Y=966180
X1006 3572 813 1 2 3587 AN2 $T=833280 981680 0 0 $X=833280 $Y=981300
X1007 813 3567 1 2 3593 AN2 $T=835760 981680 0 0 $X=835760 $Y=981300
X1008 3577 3598 1 2 3602 AN2 $T=838860 1042160 1 0 $X=838860 $Y=1036740
X1009 3567 3550 1 2 848 AN2 $T=844440 1001840 0 0 $X=844440 $Y=1001460
X1010 3662 3658 1 2 3653 AN2 $T=856220 1001840 0 180 $X=853740 $Y=996420
X1011 3739 3736 1 2 3733 AN2 $T=877300 1001840 1 180 $X=874820 $Y=1001460
X1012 3789 3777 1 2 3762 AN2 $T=890320 1001840 1 180 $X=887840 $Y=1001460
X1013 886 888 1 2 3783 AN2 $T=890940 1052240 0 0 $X=890940 $Y=1051860
X1014 3810 3808 1 2 3805 AN2 $T=900240 1001840 1 180 $X=897760 $Y=1001460
X1015 3902 3903 1 2 3889 AN2 $T=931860 1001840 0 0 $X=931860 $Y=1001460
X1016 3930 3927 1 2 3908 AN2 $T=936820 1001840 1 180 $X=934340 $Y=1001460
X1017 953 948 1 2 4020 AN2 $T=968440 1052240 1 180 $X=965960 $Y=1051860
X1018 4064 4044 1 2 4015 AN2 $T=974640 1022000 0 180 $X=972160 $Y=1016580
X1019 4065 4042 1 2 4059 AN2 $T=974640 1022000 1 180 $X=972160 $Y=1021620
X1020 4068 4027 1 2 4037 AN2 $T=974640 1052240 0 180 $X=972160 $Y=1046820
X1021 4122 4119 1 2 4085 AN2 $T=992620 1022000 1 180 $X=990140 $Y=1021620
X1022 975 4154 1 2 4146 AN2 $T=1003160 1052240 1 180 $X=1000680 $Y=1051860
X1023 4158 4164 1 2 4170 AN2 $T=1003780 1011920 0 0 $X=1003780 $Y=1011540
X1024 980 4201 1 2 4189 AN2 $T=1017420 1052240 0 180 $X=1014940 $Y=1046820
X1025 4205 4197 1 2 4199 AN2 $T=1018040 1022000 1 180 $X=1015560 $Y=1021620
X1026 4244 4246 1 2 4247 AN2 $T=1029200 1032080 1 0 $X=1029200 $Y=1026660
X1027 4299 996 1 2 4337 AN2 $T=1058340 1052240 1 0 $X=1058340 $Y=1046820
X1028 4330 4347 1 2 4341 AN2 $T=1063920 1032080 1 0 $X=1063920 $Y=1026660
X1029 4339 4374 1 2 4348 AN2 $T=1073840 1022000 1 180 $X=1071360 $Y=1021620
X1030 4381 4376 1 2 4355 AN2 $T=1074460 1042160 0 180 $X=1071980 $Y=1036740
X1031 3398 2939 1 2 INV6CK $T=799180 901040 1 180 $X=793600 $Y=900660
X1032 787 3042 1 2 INV6CK $T=801040 921200 0 180 $X=795460 $Y=915780
X1033 3464 3104 1 2 INV6CK $T=820260 951440 0 0 $X=820260 $Y=951060
X1034 856 830 1 2 INV6CK $T=856220 880880 1 180 $X=850640 $Y=880500
X1035 849 829 1 2 INV6CK $T=850640 890960 0 0 $X=850640 $Y=890580
X1036 853 3674 1 2 INV6CK $T=854360 991760 0 0 $X=854360 $Y=991380
X1037 3704 828 1 2 INV6CK $T=864280 1001840 0 0 $X=864280 $Y=1001460
X1038 3615 854 1 2 INV6CK $T=875440 1032080 0 180 $X=869860 $Y=1026660
X1039 3743 822 1 2 INV6CK $T=877920 1001840 0 0 $X=877920 $Y=1001460
X1040 3594 3601 1 2 INV6CK $T=883500 1022000 0 0 $X=883500 $Y=1021620
X1041 3773 3732 1 2 INV6CK $T=888460 981680 0 0 $X=888460 $Y=981300
X1042 3614 3607 1 2 INV6CK $T=928140 1001840 1 180 $X=922560 $Y=1001460
X1043 4045 938 1 2 INV6CK $T=968440 961520 1 0 $X=968440 $Y=956100
X1044 4169 946 1 2 INV6CK $T=1006260 921200 0 180 $X=1000680 $Y=915780
X1045 4003 3938 1 2 INV6CK $T=1007500 971600 0 180 $X=1001920 $Y=966180
X1046 4120 928 1 2 INV6CK $T=1012460 931280 0 180 $X=1006880 $Y=925860
X1047 4109 926 1 2 INV6CK $T=1017420 941360 0 180 $X=1011840 $Y=935940
X1048 4221 959 1 2 INV6CK $T=1023000 901040 0 180 $X=1017420 $Y=895620
X1049 4142 934 1 2 INV6CK $T=1018040 1032080 0 0 $X=1018040 $Y=1031700
X1050 4210 945 1 2 INV6CK $T=1045940 931280 0 180 $X=1040360 $Y=925860
X1051 3372 2930 1 2 INV4CK $T=780580 911120 0 0 $X=780580 $Y=910740
X1052 3377 2988 1 2 INV4CK $T=780580 1011920 0 0 $X=780580 $Y=1011540
X1053 3439 2923 1 2 INV4CK $T=794220 1011920 0 0 $X=794220 $Y=1011540
X1054 3333 2999 1 2 INV4CK $T=799800 991760 0 180 $X=796080 $Y=986340
X1055 3447 3016 1 2 INV4CK $T=797940 1001840 0 0 $X=797940 $Y=1001460
X1056 3445 2975 1 2 INV4CK $T=810960 911120 0 180 $X=807240 $Y=905700
X1057 3495 3217 1 2 INV4CK $T=810960 931280 0 180 $X=807240 $Y=925860
X1058 3507 3188 1 2 INV4CK $T=812820 941360 0 180 $X=809100 $Y=935940
X1059 834 3584 1 2 INV4CK $T=837000 890960 0 0 $X=837000 $Y=890580
X1060 3592 3594 1 2 INV4CK $T=837620 961520 0 0 $X=837620 $Y=961140
X1061 3732 3590 1 2 INV4CK $T=874820 981680 0 0 $X=874820 $Y=981300
X1062 3835 3743 1 2 INV4CK $T=912640 991760 0 180 $X=908920 $Y=986340
X1063 3993 935 1 2 INV4CK $T=958520 961520 0 180 $X=954800 $Y=956100
X1064 4066 4055 1 2 INV4CK $T=974640 991760 0 0 $X=974640 $Y=991380
X1065 3958 3944 1 2 INV4CK $T=984560 971600 0 0 $X=984560 $Y=971220
X1066 4125 4010 1 2 INV4CK $T=993860 1011920 1 180 $X=990140 $Y=1011540
X1067 4166 939 1 2 INV4CK $T=1004400 1042160 0 0 $X=1004400 $Y=1041780
X1068 4106 3947 1 2 INV4CK $T=1015560 981680 1 180 $X=1011840 $Y=981300
X1069 4207 961 1 2 INV4CK $T=1018040 1022000 0 0 $X=1018040 $Y=1021620
X1070 4223 963 1 2 INV4CK $T=1034780 1042160 0 0 $X=1034780 $Y=1041780
X1071 244 252 1 2 1851 QDBHN $T=401760 880880 0 0 $X=401760 $Y=880500
X1072 244 252 1 2 3025 QDBHN $T=682000 941360 0 0 $X=682000 $Y=940980
X1073 759 3327 1 2 3345 QDBHN $T=764460 901040 0 0 $X=764460 $Y=900660
X1074 777 3409 1 2 3367 QDBHN $T=788640 1042160 0 180 $X=781200 $Y=1036740
X1075 777 3433 1 2 3379 QDBHN $T=796080 951440 0 180 $X=788640 $Y=946020
X1076 759 3437 1 2 3446 QDBHN $T=791120 880880 0 0 $X=791120 $Y=880500
X1077 759 3327 1 2 3482 QDBHN $T=815300 880880 1 180 $X=807860 $Y=880500
X1078 777 3501 1 2 3519 QDBHN $T=808480 1042160 0 0 $X=808480 $Y=1041780
X1079 759 800 1 2 3479 QDBHN $T=809100 961520 0 0 $X=809100 $Y=961140
X1080 759 804 1 2 3521 QDBHN $T=823980 901040 1 180 $X=816540 $Y=900660
X1081 721 713 1 2 3545 QDBHN $T=817780 880880 0 0 $X=817780 $Y=880500
X1082 759 3437 1 2 3520 QDBHN $T=825220 890960 0 180 $X=817780 $Y=885540
X1083 777 3541 1 2 3527 QDBHN $T=820880 1011920 0 0 $X=820880 $Y=1011540
X1084 777 3532 1 2 3568 QDBHN $T=822120 1022000 0 0 $X=822120 $Y=1021620
X1085 721 708 1 2 3546 QDBHN $T=823980 890960 0 0 $X=823980 $Y=890580
X1086 759 812 1 2 818 QDBHN $T=833900 901040 1 180 $X=826460 $Y=900660
X1087 777 3566 1 2 3589 QDBHN $T=828940 991760 0 0 $X=828940 $Y=991380
X1088 759 832 1 2 3603 QDBHN $T=833900 921200 1 0 $X=833900 $Y=915780
X1089 777 3533 1 2 3610 QDBHN $T=835760 971600 0 0 $X=835760 $Y=971220
X1090 721 843 1 2 3581 QDBHN $T=843200 880880 0 0 $X=843200 $Y=880500
X1091 759 3433 1 2 3630 QDBHN $T=857460 921200 0 180 $X=850020 $Y=915780
X1092 777 3541 1 2 3678 QDBHN $T=850020 1001840 0 0 $X=850020 $Y=1001460
X1093 777 3535 1 2 3696 QDBHN $T=856220 1011920 0 0 $X=856220 $Y=1011540
X1094 777 810 1 2 3687 QDBHN $T=856220 1022000 0 0 $X=856220 $Y=1021620
X1095 777 3533 1 2 3686 QDBHN $T=856840 951440 0 0 $X=856840 $Y=951060
X1096 777 3501 1 2 3700 QDBHN $T=871720 1042160 0 180 $X=864280 $Y=1036740
X1097 759 796 1 2 3747 QDBHN $T=872340 880880 0 0 $X=872340 $Y=880500
X1098 777 3566 1 2 3730 QDBHN $T=875440 951440 0 0 $X=875440 $Y=951060
X1099 777 3409 1 2 3793 QDBHN $T=886600 971600 0 0 $X=886600 $Y=971220
X1100 777 3532 1 2 3802 QDBHN $T=903340 1011920 0 180 $X=895900 $Y=1006500
X1101 777 3535 1 2 3661 QDBHN $T=896520 971600 0 0 $X=896520 $Y=971220
X1102 3917 927 1 2 3960 QDBHN $T=939300 991760 0 0 $X=939300 $Y=991380
X1103 3917 936 1 2 4014 QDBHN $T=955420 981680 0 0 $X=955420 $Y=981300
X1104 3917 950 1 2 4026 QDBHN $T=972780 971600 0 180 $X=965340 $Y=966180
X1105 3917 955 1 2 4074 QDBHN $T=970920 1011920 0 0 $X=970920 $Y=1011540
X1106 3917 966 1 2 4102 QDBHN $T=978360 1032080 0 0 $X=978360 $Y=1031700
X1107 3917 967 1 2 4112 QDBHN $T=982080 991760 0 0 $X=982080 $Y=991380
X1108 3917 969 1 2 4090 QDBHN $T=988900 931280 0 0 $X=988900 $Y=930900
X1109 3917 971 1 2 4138 QDBHN $T=991380 1001840 0 0 $X=991380 $Y=1001460
X1110 3917 973 1 2 4127 QDBHN $T=1001300 951440 0 180 $X=993860 $Y=946020
X1111 3917 974 1 2 4172 QDBHN $T=998820 941360 1 0 $X=998820 $Y=935940
X1112 3917 976 1 2 4167 QDBHN $T=1004400 1032080 1 0 $X=1004400 $Y=1026660
X1113 3917 985 1 2 4237 QDBHN $T=1036640 921200 0 180 $X=1029200 $Y=915780
X1114 3917 984 1 2 4231 QDBHN $T=1029200 1052240 0 0 $X=1029200 $Y=1051860
X1115 3917 990 1 2 4297 QDBHN $T=1041600 1011920 0 0 $X=1041600 $Y=1011540
X1116 3917 991 1 2 4276 QDBHN $T=1042220 961520 0 0 $X=1042220 $Y=961140
X1117 3917 997 1 2 4277 QDBHN $T=1057100 941360 0 0 $X=1057100 $Y=940980
X1118 1868 1780 1 2 INV2CK $T=412920 890960 0 0 $X=412920 $Y=890580
X1119 2998 2926 1 2 INV2CK $T=693160 951440 0 0 $X=693160 $Y=951060
X1120 3274 3198 1 2 INV2CK $T=766940 880880 0 0 $X=766940 $Y=880500
X1121 3334 3333 1 2 INV2CK $T=769420 951440 0 180 $X=766940 $Y=946020
X1122 3368 3372 1 2 INV2CK $T=778100 890960 0 0 $X=778100 $Y=890580
X1123 3492 3495 1 2 INV2CK $T=822740 931280 0 0 $X=822740 $Y=930900
X1124 3555 3507 1 2 INV2CK $T=827080 911120 0 0 $X=827080 $Y=910740
X1125 3617 3643 1 2 INV2CK $T=863660 931280 0 180 $X=861180 $Y=925860
X1126 4008 4066 1 2 INV2CK $T=984560 981680 0 0 $X=984560 $Y=981300
X1127 4220 4223 1 2 INV2CK $T=1023620 1042160 1 180 $X=1021140 $Y=1041780
X1128 1857 244 1868 1 2 AN2T $T=394940 890960 0 0 $X=394940 $Y=890580
X1129 2990 244 2998 1 2 AN2T $T=675180 951440 0 0 $X=675180 $Y=951060
X1130 740 244 3274 1 2 AN2T $T=748960 880880 0 0 $X=748960 $Y=880500
X1131 3359 759 3368 1 2 AN2T $T=775620 901040 0 0 $X=775620 $Y=900660
X1132 3402 759 3334 1 2 AN2T $T=784920 951440 0 180 $X=780580 $Y=946020
X1133 3392 777 3429 1 2 AN2T $T=796700 1042160 0 180 $X=792360 $Y=1036740
X1134 3466 777 788 1 2 AN2T $T=804760 1042160 1 180 $X=800420 $Y=1041780
X1135 3459 777 3460 1 2 AN2T $T=802280 951440 0 0 $X=802280 $Y=951060
X1136 3512 759 3492 1 2 AN2T $T=813440 921200 0 180 $X=809100 $Y=915780
X1137 3510 777 3496 1 2 AN2T $T=812820 1001840 0 0 $X=812820 $Y=1001460
X1138 3547 777 3536 1 2 AN2T $T=825220 991760 1 180 $X=820880 $Y=991380
X1139 3537 777 3553 1 2 AN2T $T=822120 1032080 0 0 $X=822120 $Y=1031700
X1140 3551 759 3555 1 2 AN2T $T=825840 921200 0 0 $X=825840 $Y=920820
X1141 3552 777 3549 1 2 AN2T $T=825840 981680 0 0 $X=825840 $Y=981300
X1142 3530 759 825 1 2 AN2T $T=828940 890960 1 0 $X=828940 $Y=885540
X1143 3628 759 3617 1 2 AN2T $T=847540 931280 0 180 $X=843200 $Y=925860
X1144 3613 777 3600 1 2 AN2T $T=843200 981680 0 0 $X=843200 $Y=981300
X1145 3634 777 3585 1 2 AN2T $T=848160 1011920 0 0 $X=848160 $Y=1011540
X1146 3635 777 3647 1 2 AN2T $T=848160 1022000 0 0 $X=848160 $Y=1021620
X1147 3644 777 3592 1 2 AN2T $T=851260 971600 0 0 $X=851260 $Y=971220
X1148 3695 777 3609 1 2 AN2T $T=860560 1042160 0 180 $X=856220 $Y=1036740
X1149 3703 759 868 1 2 AN2T $T=864280 880880 0 0 $X=864280 $Y=880500
X1150 3734 777 3713 1 2 AN2T $T=872340 971600 1 180 $X=868000 $Y=971220
X1151 3683 777 3684 1 2 AN2T $T=868620 961520 0 0 $X=868620 $Y=961140
X1152 3746 777 3773 1 2 AN2T $T=885360 961520 0 0 $X=885360 $Y=961140
X1153 3852 777 3835 1 2 AN2T $T=911400 1011920 0 180 $X=907060 $Y=1006500
X1154 3963 3917 3957 1 2 AN2T $T=950460 991760 0 0 $X=950460 $Y=991380
X1155 3991 3917 4008 1 2 AN2T $T=956660 991760 0 0 $X=956660 $Y=991380
X1156 4034 3917 4054 1 2 AN2T $T=966580 981680 0 0 $X=966580 $Y=981300
X1157 4035 3917 3998 1 2 AN2T $T=966580 1001840 0 0 $X=966580 $Y=1001460
X1158 4048 3917 4002 1 2 AN2T $T=969060 951440 1 0 $X=969060 $Y=946020
X1159 4071 3917 4077 1 2 AN2T $T=976500 941360 1 0 $X=976500 $Y=935940
X1160 4070 3917 4073 1 2 AN2T $T=976500 971600 1 0 $X=976500 $Y=966180
X1161 4086 3917 4097 1 2 AN2T $T=982080 1011920 0 0 $X=982080 $Y=1011540
X1162 4115 3917 4107 1 2 AN2T $T=990140 1022000 1 180 $X=985800 $Y=1021620
X1163 4111 3917 4116 1 2 AN2T $T=988900 921200 0 0 $X=988900 $Y=920820
X1164 4147 3917 4136 1 2 AN2T $T=1000680 1032080 1 180 $X=996340 $Y=1031700
X1165 4241 3917 4220 1 2 AN2T $T=1025480 1052240 1 180 $X=1021140 $Y=1051860
X1166 4222 3917 4204 1 2 AN2T $T=1022380 931280 1 0 $X=1022380 $Y=925860
X1167 4265 3917 4252 1 2 AN2T $T=1039740 951440 1 180 $X=1035400 $Y=951060
X1168 4274 3917 4284 1 2 AN2T $T=1041600 1022000 0 0 $X=1041600 $Y=1021620
X1169 4298 3917 4308 1 2 AN2T $T=1049040 941360 0 0 $X=1049040 $Y=940980
X1170 1851 1 2 1857 DELC $T=393080 880880 0 0 $X=393080 $Y=880500
X1171 2841 1 2 2859 DELC $T=636120 941360 1 0 $X=636120 $Y=935940
X1172 3025 1 2 2990 DELC $T=688200 951440 0 0 $X=688200 $Y=951060
X1173 750 1 2 753 DELC $T=753920 890960 1 0 $X=753920 $Y=885540
X1174 3367 1 2 3392 DELC $T=777480 1032080 0 0 $X=777480 $Y=1031700
X1175 3345 1 2 3359 DELC $T=779960 901040 0 0 $X=779960 $Y=900660
X1176 3379 1 2 3402 DELC $T=779960 941360 1 0 $X=779960 $Y=935940
X1177 3446 1 2 794 DELC $T=801660 901040 1 0 $X=801660 $Y=895620
X1178 3479 1 2 3459 DELC $T=806620 951440 0 0 $X=806620 $Y=951060
X1179 3482 1 2 807 DELC $T=810960 901040 1 0 $X=810960 $Y=895620
X1180 3520 1 2 3530 DELC $T=815920 901040 1 0 $X=815920 $Y=895620
X1181 3521 1 2 3512 DELC $T=815920 921200 1 0 $X=815920 $Y=915780
X1182 3527 1 2 3510 DELC $T=817160 1001840 0 0 $X=817160 $Y=1001460
X1183 3519 1 2 3466 DELC $T=819640 1042160 0 0 $X=819640 $Y=1041780
X1184 3568 1 2 3537 DELC $T=829560 1022000 0 0 $X=829560 $Y=1021620
X1185 3589 1 2 3547 DELC $T=835760 1001840 0 0 $X=835760 $Y=1001460
X1186 3603 1 2 3551 DELC $T=841340 921200 1 0 $X=841340 $Y=915780
X1187 3610 1 2 3552 DELC $T=843200 971600 0 0 $X=843200 $Y=971220
X1188 3630 1 2 3628 DELC $T=847540 931280 1 0 $X=847540 $Y=925860
X1189 3661 1 2 3683 DELC $T=855600 971600 0 0 $X=855600 $Y=971220
X1190 3678 1 2 3613 DELC $T=859940 991760 0 0 $X=859940 $Y=991380
X1191 3686 1 2 3644 DELC $T=860560 971600 0 0 $X=860560 $Y=971220
X1192 3687 1 2 3635 DELC $T=861180 1032080 1 0 $X=861180 $Y=1026660
X1193 3696 1 2 3634 DELC $T=863660 1011920 0 0 $X=863660 $Y=1011540
X1194 3700 1 2 3695 DELC $T=871720 1042160 1 0 $X=871720 $Y=1036740
X1195 3730 1 2 3746 DELC $T=874200 961520 0 0 $X=874200 $Y=961140
X1196 3747 1 2 3703 DELC $T=879780 880880 0 0 $X=879780 $Y=880500
X1197 3793 1 2 3734 DELC $T=894040 981680 0 0 $X=894040 $Y=981300
X1198 3802 1 2 3852 DELC $T=910780 1001840 1 0 $X=910780 $Y=996420
X1199 3960 1 2 3963 DELC $T=961000 991760 0 0 $X=961000 $Y=991380
X1200 4014 1 2 3991 DELC $T=969060 991760 1 0 $X=969060 $Y=986340
X1201 4026 1 2 4070 DELC $T=975260 961520 1 0 $X=975260 $Y=956100
X1202 4074 1 2 4086 DELC $T=980220 1011920 1 0 $X=980220 $Y=1006500
X1203 4090 1 2 4111 DELC $T=985180 901040 0 0 $X=985180 $Y=900660
X1204 4112 1 2 4034 DELC $T=989520 991760 0 0 $X=989520 $Y=991380
X1205 4102 1 2 4115 DELC $T=992620 1022000 0 0 $X=992620 $Y=1021620
X1206 4127 1 2 4048 DELC $T=993860 951440 0 0 $X=993860 $Y=951060
X1207 4138 1 2 4035 DELC $T=998820 1001840 0 0 $X=998820 $Y=1001460
X1208 4167 1 2 4147 DELC $T=1004400 1032080 0 0 $X=1004400 $Y=1031700
X1209 4172 1 2 4071 DELC $T=1008120 951440 1 0 $X=1008120 $Y=946020
X1210 4231 1 2 4241 DELC $T=1024860 1042160 0 0 $X=1024860 $Y=1041780
X1211 4237 1 2 4222 DELC $T=1026720 931280 1 0 $X=1026720 $Y=925860
X1212 4276 1 2 4265 DELC $T=1043460 951440 0 0 $X=1043460 $Y=951060
X1213 4277 1 2 4298 DELC $T=1044080 941360 0 0 $X=1044080 $Y=940980
X1214 4297 1 2 4274 DELC $T=1052760 1011920 0 0 $X=1052760 $Y=1011540
X1215 1022 2 1023 1 INV1S $T=223200 971600 0 180 $X=221960 $Y=966180
X1216 1024 2 1027 1 INV1S $T=221960 991760 1 0 $X=221960 $Y=986340
X1217 1041 2 1031 1 INV1S $T=224440 931280 1 180 $X=223200 $Y=930900
X1218 1035 2 1033 1 INV1S $T=226300 971600 0 180 $X=225060 $Y=966180
X1219 1050 2 1061 1 INV1S $T=227540 1022000 1 0 $X=227540 $Y=1016580
X1220 1069 2 1091 1 INV1S $T=229400 991760 1 0 $X=229400 $Y=986340
X1221 1073 2 1078 1 INV1S $T=230640 961520 1 0 $X=230640 $Y=956100
X1222 1077 2 1032 1 INV1S $T=232500 1001840 0 0 $X=232500 $Y=1001460
X1223 1074 2 1101 1 INV1S $T=233120 951440 1 0 $X=233120 $Y=946020
X1224 1047 2 1102 1 INV1S $T=236840 951440 1 0 $X=236840 $Y=946020
X1225 1115 2 1108 1 INV1S $T=238080 1011920 0 180 $X=236840 $Y=1006500
X1226 1123 2 1097 1 INV1S $T=238700 991760 0 0 $X=238700 $Y=991380
X1227 1059 2 1109 1 INV1S $T=239320 1011920 0 0 $X=239320 $Y=1011540
X1228 1122 2 1042 1 INV1S $T=241800 951440 0 180 $X=240560 $Y=946020
X1229 1120 2 1146 1 INV1S $T=240560 1001840 1 0 $X=240560 $Y=996420
X1230 1083 2 1081 1 INV1S $T=246140 941360 1 180 $X=244900 $Y=940980
X1231 1071 2 1163 1 INV1S $T=244900 1022000 0 0 $X=244900 $Y=1021620
X1232 29 2 7 1 INV1S $T=245520 890960 0 0 $X=245520 $Y=890580
X1233 1116 2 1172 1 INV1S $T=246140 961520 0 0 $X=246140 $Y=961140
X1234 1162 2 1174 1 INV1S $T=247380 1042160 0 0 $X=247380 $Y=1041780
X1235 1183 2 1095 1 INV1S $T=249860 951440 0 180 $X=248620 $Y=946020
X1236 1105 2 1205 1 INV1S $T=250480 931280 1 0 $X=250480 $Y=925860
X1237 1176 2 1195 1 INV1S $T=250480 1001840 1 0 $X=250480 $Y=996420
X1238 1191 2 1197 1 INV1S $T=251720 971600 1 0 $X=251720 $Y=966180
X1239 1215 2 1058 1 INV1S $T=255440 941360 1 0 $X=255440 $Y=935940
X1240 1202 2 1228 1 INV1S $T=257300 1032080 0 0 $X=257300 $Y=1031700
X1241 1046 2 1214 1 INV1S $T=260400 961520 1 180 $X=259160 $Y=961140
X1242 1209 2 1034 1 INV1S $T=261020 951440 1 0 $X=261020 $Y=946020
X1243 1112 2 1193 1 INV1S $T=263500 971600 0 180 $X=262260 $Y=966180
X1244 1273 2 1070 1 INV1S $T=268460 1001840 1 180 $X=267220 $Y=1001460
X1245 18 2 1312 1 INV1S $T=268460 1042160 0 0 $X=268460 $Y=1041780
X1246 1286 2 1094 1 INV1S $T=270940 941360 0 0 $X=270940 $Y=940980
X1247 1303 2 1293 1 INV1S $T=277140 921200 1 0 $X=277140 $Y=915780
X1248 8 2 1299 1 INV1S $T=279620 1032080 0 0 $X=279620 $Y=1031700
X1249 1362 2 1388 1 INV1S $T=280860 921200 1 0 $X=280860 $Y=915780
X1250 1366 2 1377 1 INV1S $T=283960 1032080 0 0 $X=283960 $Y=1031700
X1251 1348 2 89 1 INV1S $T=284580 901040 1 0 $X=284580 $Y=895620
X1252 1416 2 22 1 INV1S $T=287680 1022000 0 180 $X=286440 $Y=1016580
X1253 1262 2 1281 1 INV1S $T=287680 931280 1 0 $X=287680 $Y=925860
X1254 1432 2 97 1 INV1S $T=290780 890960 0 180 $X=289540 $Y=885540
X1255 1381 2 109 1 INV1S $T=291400 1052240 0 0 $X=291400 $Y=1051860
X1256 1339 2 113 1 INV1S $T=293260 1042160 1 0 $X=293260 $Y=1036740
X1257 1409 2 19 1 INV1S $T=293260 1052240 1 0 $X=293260 $Y=1046820
X1258 1431 2 1379 1 INV1S $T=296360 931280 1 180 $X=295120 $Y=930900
X1259 1465 2 1235 1 INV1S $T=299460 961520 0 180 $X=298220 $Y=956100
X1260 108 2 1322 1 INV1S $T=300080 1042160 0 0 $X=300080 $Y=1041780
X1261 1486 2 1413 1 INV1S $T=302560 911120 0 180 $X=301320 $Y=905700
X1262 1444 2 1326 1 INV1S $T=301320 931280 0 0 $X=301320 $Y=930900
X1263 126 2 67 1 INV1S $T=304420 890960 0 180 $X=303180 $Y=885540
X1264 1515 2 1489 1 INV1S $T=309380 951440 0 180 $X=308140 $Y=946020
X1265 1361 2 1523 1 INV1S $T=309380 890960 0 0 $X=309380 $Y=890580
X1266 1516 2 1288 1 INV1S $T=310620 941360 0 180 $X=309380 $Y=935940
X1267 1537 2 1351 1 INV1S $T=314340 921200 0 180 $X=313100 $Y=915780
X1268 1374 2 1266 1 INV1S $T=314960 941360 1 0 $X=314960 $Y=935940
X1269 1575 2 102 1 INV1S $T=324880 1022000 1 180 $X=323640 $Y=1021620
X1270 1609 2 1578 1 INV1S $T=326740 1042160 1 180 $X=325500 $Y=1041780
X1271 1601 2 1573 1 INV1S $T=327360 921200 1 180 $X=326120 $Y=920820
X1272 1571 2 59 1 INV1S $T=327980 1001840 0 180 $X=326740 $Y=996420
X1273 166 2 1572 1 INV1S $T=329840 880880 1 180 $X=328600 $Y=880500
X1274 1610 2 1391 1 INV1S $T=329840 1001840 1 180 $X=328600 $Y=1001460
X1275 1144 2 100 1 INV1S $T=330460 1032080 0 0 $X=330460 $Y=1031700
X1276 1553 2 1625 1 INV1S $T=331080 931280 1 0 $X=331080 $Y=925860
X1277 175 2 23 1 INV1S $T=336660 1011920 1 180 $X=335420 $Y=1011540
X1278 1629 2 1611 1 INV1S $T=336660 911120 0 0 $X=336660 $Y=910740
X1279 1645 2 1586 1 INV1S $T=338520 931280 0 180 $X=337280 $Y=925860
X1280 1587 2 1647 1 INV1S $T=337280 941360 0 0 $X=337280 $Y=940980
X1281 1484 2 1175 1 INV1S $T=338520 961520 0 180 $X=337280 $Y=956100
X1282 177 2 1614 1 INV1S $T=338520 880880 0 0 $X=338520 $Y=880500
X1283 1212 2 1552 1 INV1S $T=340380 931280 0 0 $X=340380 $Y=930900
X1284 1347 2 1251 1 INV1S $T=341620 961520 1 180 $X=340380 $Y=961140
X1285 1555 2 1417 1 INV1S $T=342240 921200 0 0 $X=342240 $Y=920820
X1286 1187 2 1651 1 INV1S $T=343480 961520 0 0 $X=343480 $Y=961140
X1287 1671 2 1603 1 INV1S $T=345340 931280 0 180 $X=344100 $Y=925860
X1288 1597 2 1684 1 INV1S $T=344720 921200 1 0 $X=344720 $Y=915780
X1289 1564 2 1619 1 INV1S $T=347820 931280 0 0 $X=347820 $Y=930900
X1290 160 2 1541 1 INV1S $T=349060 1052240 1 0 $X=349060 $Y=1046820
X1291 144 2 158 1 INV1S $T=352780 880880 1 180 $X=351540 $Y=880500
X1292 1542 2 1560 1 INV1S $T=352160 971600 0 0 $X=352160 $Y=971220
X1293 1558 2 116 1 INV1S $T=355260 880880 0 0 $X=355260 $Y=880500
X1294 1068 2 1198 1 INV1S $T=357740 971600 1 0 $X=357740 $Y=966180
X1295 1225 2 1685 1 INV1S $T=358980 921200 0 0 $X=358980 $Y=920820
X1296 1211 2 153 1 INV1S $T=360220 1052240 1 180 $X=358980 $Y=1051860
X1297 1463 2 179 1 INV1S $T=360840 1032080 0 0 $X=360840 $Y=1031700
X1298 1177 2 5 1 INV1S $T=361460 981680 0 0 $X=361460 $Y=981300
X1299 164 2 38 1 INV1S $T=362700 1001840 1 0 $X=362700 $Y=996420
X1300 172 2 151 1 INV1S $T=365180 880880 1 180 $X=363940 $Y=880500
X1301 1285 2 1153 1 INV1S $T=365800 981680 0 0 $X=365800 $Y=981300
X1302 107 2 192 1 INV1S $T=372000 1022000 1 180 $X=370760 $Y=1021620
X1303 1405 2 1679 1 INV1S $T=372620 1042160 0 180 $X=371380 $Y=1036740
X1304 1510 2 168 1 INV1S $T=372000 1011920 0 0 $X=372000 $Y=1011540
X1305 48 2 219 1 INV1S $T=373240 1052240 1 180 $X=372000 $Y=1051860
X1306 1743 2 1799 1 INV1S $T=376340 971600 1 0 $X=376340 $Y=966180
X1307 224 2 1726 1 INV1S $T=380060 921200 1 180 $X=378820 $Y=920820
X1308 1321 2 1255 1 INV1S $T=379440 1001840 1 0 $X=379440 $Y=996420
X1309 1815 2 1699 1 INV1S $T=381300 911120 1 180 $X=380060 $Y=910740
X1310 1475 2 1733 1 INV1S $T=380060 931280 1 0 $X=380060 $Y=925860
X1311 215 2 1786 1 INV1S $T=381300 961520 1 0 $X=381300 $Y=956100
X1312 196 2 1298 1 INV1S $T=382540 991760 1 180 $X=381300 $Y=991380
X1313 1605 2 1626 1 INV1S $T=382540 1001840 1 0 $X=382540 $Y=996420
X1314 162 2 1640 1 INV1S $T=383160 991760 1 0 $X=383160 $Y=986340
X1315 223 2 1814 1 INV1S $T=383780 931280 1 0 $X=383780 $Y=925860
X1316 211 2 1748 1 INV1S $T=385640 961520 0 180 $X=384400 $Y=956100
X1317 230 2 1829 1 INV1S $T=385020 901040 0 0 $X=385020 $Y=900660
X1318 1834 2 1697 1 INV1S $T=386880 1032080 0 0 $X=386880 $Y=1031700
X1319 238 2 1860 1 INV1S $T=392460 911120 0 0 $X=392460 $Y=910740
X1320 1855 2 1669 1 INV1S $T=394320 961520 1 180 $X=393080 $Y=961140
X1321 1161 2 69 1 INV1S $T=394940 1032080 1 0 $X=394940 $Y=1026660
X1322 242 2 1845 1 INV1S $T=395560 921200 0 0 $X=395560 $Y=920820
X1323 245 2 1761 1 INV1S $T=396800 1052240 0 180 $X=395560 $Y=1046820
X1324 1862 2 1646 1 INV1S $T=398040 991760 1 180 $X=396800 $Y=991380
X1325 235 2 1873 1 INV1S $T=399280 890960 0 0 $X=399280 $Y=890580
X1326 1260 2 1818 1 INV1S $T=399280 1022000 1 0 $X=399280 $Y=1016580
X1327 1749 2 1816 1 INV1S $T=401140 951440 1 180 $X=399900 $Y=951060
X1328 1833 2 1859 1 INV1S $T=401140 961520 1 180 $X=399900 $Y=961140
X1329 243 2 1885 1 INV1S $T=401140 890960 0 0 $X=401140 $Y=890580
X1330 1491 2 1712 1 INV1S $T=403000 1011920 0 180 $X=401760 $Y=1006500
X1331 229 2 1785 1 INV1S $T=404240 941360 0 180 $X=403000 $Y=935940
X1332 1708 2 1881 1 INV1S $T=403000 961520 0 0 $X=403000 $Y=961140
X1333 1557 2 251 1 INV1S $T=404860 1042160 1 180 $X=403620 $Y=1041780
X1334 1856 2 1642 1 INV1S $T=404240 1032080 1 0 $X=404240 $Y=1026660
X1335 1813 2 1778 1 INV1S $T=404860 971600 0 0 $X=404860 $Y=971220
X1336 232 2 1887 1 INV1S $T=405480 921200 1 0 $X=405480 $Y=915780
X1337 238 2 1871 1 INV1S $T=407960 921200 1 180 $X=406720 $Y=920820
X1338 1831 2 1867 1 INV1S $T=408580 971600 0 0 $X=408580 $Y=971220
X1339 1242 2 1231 1 INV1S $T=410440 1011920 0 0 $X=410440 $Y=1011540
X1340 1644 2 1420 1 INV1S $T=412300 1011920 0 180 $X=411060 $Y=1006500
X1341 1872 2 256 1 INV1S $T=412920 890960 1 180 $X=411680 $Y=890580
X1342 1911 2 260 1 INV1S $T=416020 1042160 1 180 $X=414780 $Y=1041780
X1343 243 2 1926 1 INV1S $T=416020 951440 0 0 $X=416020 $Y=951060
X1344 1923 2 258 1 INV1S $T=417880 1042160 0 180 $X=416640 $Y=1036740
X1345 1916 2 1914 1 INV1S $T=417880 1052240 1 180 $X=416640 $Y=1051860
X1346 242 2 1932 1 INV1S $T=417260 951440 1 0 $X=417260 $Y=946020
X1347 237 2 1897 1 INV1S $T=419120 931280 1 180 $X=417880 $Y=930900
X1348 249 2 271 1 INV1S $T=418500 880880 0 0 $X=418500 $Y=880500
X1349 265 2 272 1 INV1S $T=418500 901040 1 0 $X=418500 $Y=895620
X1350 237 2 1900 1 INV1S $T=420360 901040 1 180 $X=419120 $Y=900660
X1351 1930 2 1929 1 INV1S $T=420980 1001840 0 180 $X=419740 $Y=996420
X1352 1864 2 1948 1 INV1S $T=420360 921200 1 0 $X=420360 $Y=915780
X1353 232 2 1899 1 INV1S $T=422220 921200 1 180 $X=420980 $Y=920820
X1354 1943 2 1942 1 INV1S $T=423460 971600 1 180 $X=422220 $Y=971220
X1355 262 2 1941 1 INV1S $T=422840 911120 1 0 $X=422840 $Y=905700
X1356 1919 2 1922 1 INV1S $T=423460 1001840 1 0 $X=423460 $Y=996420
X1357 250 2 280 1 INV1S $T=424080 890960 0 0 $X=424080 $Y=890580
X1358 232 2 1959 1 INV1S $T=424700 921200 0 0 $X=424700 $Y=920820
X1359 1940 2 283 1 INV1S $T=425940 890960 1 0 $X=425940 $Y=885540
X1360 1913 2 1912 1 INV1S $T=425940 1001840 0 0 $X=425940 $Y=1001460
X1361 289 2 282 1 INV1S $T=427180 1052240 1 180 $X=425940 $Y=1051860
X1362 276 2 300 1 INV1S $T=427180 911120 0 0 $X=427180 $Y=910740
X1363 238 2 1949 1 INV1S $T=430280 931280 0 180 $X=429040 $Y=925860
X1364 1972 2 1953 1 INV1S $T=430280 971600 1 180 $X=429040 $Y=971220
X1365 1974 2 261 1 INV1S $T=430900 1001840 1 180 $X=429660 $Y=1001460
X1366 303 2 1992 1 INV1S $T=433380 921200 0 0 $X=433380 $Y=920820
X1367 1952 2 2015 1 INV1S $T=435860 1001840 0 0 $X=435860 $Y=1001460
X1368 2003 2 2006 1 INV1S $T=437720 961520 0 0 $X=437720 $Y=961140
X1369 2004 2 1993 1 INV1S $T=437720 991760 1 0 $X=437720 $Y=986340
X1370 2018 2 293 1 INV1S $T=440200 1032080 0 180 $X=438960 $Y=1026660
X1371 1980 2 2027 1 INV1S $T=441440 971600 1 0 $X=441440 $Y=966180
X1372 285 2 2013 1 INV1S $T=442060 1032080 1 0 $X=442060 $Y=1026660
X1373 259 2 2049 1 INV1S $T=443920 890960 1 0 $X=443920 $Y=885540
X1374 2001 2 316 1 INV1S $T=443920 1042160 1 0 $X=443920 $Y=1036740
X1375 237 2 2026 1 INV1S $T=446400 931280 0 0 $X=446400 $Y=930900
X1376 351 2 343 1 INV1S $T=450120 911120 0 180 $X=448880 $Y=905700
X1377 249 2 2047 1 INV1S $T=450120 951440 0 180 $X=448880 $Y=946020
X1378 325 2 2022 1 INV1S $T=450120 1042160 1 180 $X=448880 $Y=1041780
X1379 337 2 345 1 INV1S $T=450120 931280 0 0 $X=450120 $Y=930900
X1380 229 2 2082 1 INV1S $T=453840 951440 0 180 $X=452600 $Y=946020
X1381 1964 2 2090 1 INV1S $T=452600 961520 0 0 $X=452600 $Y=961140
X1382 2055 2 357 1 INV1S $T=455080 1042160 1 180 $X=453840 $Y=1041780
X1383 339 2 2083 1 INV1S $T=454460 921200 0 0 $X=454460 $Y=920820
X1384 341 2 2101 1 INV1S $T=455700 931280 0 0 $X=455700 $Y=930900
X1385 324 2 367 1 INV1S $T=456940 981680 0 0 $X=456940 $Y=981300
X1386 363 2 328 1 INV1S $T=458800 941360 0 180 $X=457560 $Y=935940
X1387 1998 2 2111 1 INV1S $T=457560 971600 1 0 $X=457560 $Y=966180
X1388 332 2 377 1 INV1S $T=458180 901040 1 0 $X=458180 $Y=895620
X1389 364 2 375 1 INV1S $T=458800 880880 0 0 $X=458800 $Y=880500
X1390 2021 2 2129 1 INV1S $T=460040 961520 0 0 $X=460040 $Y=961140
X1391 2057 2 355 1 INV1S $T=461280 921200 1 0 $X=461280 $Y=915780
X1392 2086 2 2134 1 INV1S $T=461900 951440 1 0 $X=461900 $Y=946020
X1393 2097 2 378 1 INV1S $T=463140 971600 1 180 $X=461900 $Y=971220
X1394 344 2 2159 1 INV1S $T=465620 890960 0 0 $X=465620 $Y=890580
X1395 2039 2 2156 1 INV1S $T=470580 991760 0 180 $X=469340 $Y=986340
X1396 2173 2 2183 1 INV1S $T=469960 951440 0 0 $X=469960 $Y=951060
X1397 2078 2 2144 1 INV1S $T=473060 941360 0 0 $X=473060 $Y=940980
X1398 2196 2 2135 1 INV1S $T=473680 951440 0 0 $X=473680 $Y=951060
X1399 2120 2 2219 1 INV1S $T=474300 1052240 1 0 $X=474300 $Y=1046820
X1400 2023 2 2220 1 INV1S $T=479260 890960 1 180 $X=478020 $Y=890580
X1401 349 2 401 1 INV1S $T=479260 1001840 1 0 $X=479260 $Y=996420
X1402 1958 2 2010 1 INV1S $T=480500 991760 1 0 $X=480500 $Y=986340
X1403 2093 2 2239 1 INV1S $T=481120 1001840 1 0 $X=481120 $Y=996420
X1404 348 2 425 1 INV1S $T=482980 890960 1 0 $X=482980 $Y=885540
X1405 327 2 427 1 INV1S $T=484220 880880 0 0 $X=484220 $Y=880500
X1406 2090 2 2238 1 INV1S $T=484220 961520 0 0 $X=484220 $Y=961140
X1407 428 2 2251 1 INV1S $T=484840 1052240 0 0 $X=484840 $Y=1051860
X1408 322 2 2071 1 INV1S $T=485460 991760 1 0 $X=485460 $Y=986340
X1409 419 2 416 1 INV1S $T=486080 890960 1 0 $X=486080 $Y=885540
X1410 2049 2 2259 1 INV1S $T=486080 901040 1 0 $X=486080 $Y=895620
X1411 2247 2 432 1 INV1S $T=486700 1011920 0 0 $X=486700 $Y=1011540
X1412 2243 2 2207 1 INV1S $T=487320 921200 0 0 $X=487320 $Y=920820
X1413 440 2 266 1 INV1S $T=491040 1022000 0 180 $X=489800 $Y=1016580
X1414 385 2 2246 1 INV1S $T=492280 941360 1 180 $X=491040 $Y=940980
X1415 2242 2 2252 1 INV1S $T=491040 961520 1 0 $X=491040 $Y=956100
X1416 393 2 2296 1 INV1S $T=491660 931280 1 0 $X=491660 $Y=925860
X1417 2261 2 2198 1 INV1S $T=491660 991760 0 0 $X=491660 $Y=991380
X1418 1999 2 439 1 INV1S $T=491660 1042160 0 0 $X=491660 $Y=1041780
X1419 395 2 2270 1 INV1S $T=492900 1032080 1 0 $X=492900 $Y=1026660
X1420 2163 2 1990 1 INV1S $T=496000 1011920 0 180 $X=494760 $Y=1006500
X1421 2002 2 426 1 INV1S $T=496000 1042160 0 180 $X=494760 $Y=1036740
X1422 455 2 2292 1 INV1S $T=497860 890960 0 180 $X=496620 $Y=885540
X1423 2059 2 453 1 INV1S $T=496620 931280 1 0 $X=496620 $Y=925860
X1424 2330 2 2299 1 INV1S $T=504060 961520 0 180 $X=502820 $Y=956100
X1425 1937 2 2054 1 INV1S $T=504060 1001840 1 180 $X=502820 $Y=1001460
X1426 2291 2 340 1 INV1S $T=505920 1042160 1 180 $X=504680 $Y=1041780
X1427 2119 2 390 1 INV1S $T=505300 1001840 0 0 $X=505300 $Y=1001460
X1428 223 2 2329 1 INV1S $T=506540 951440 0 0 $X=506540 $Y=951060
X1429 2355 2 2201 1 INV1S $T=508400 971600 1 0 $X=508400 $Y=966180
X1430 2379 2 2366 1 INV1S $T=513360 961520 0 0 $X=513360 $Y=961140
X1431 2371 2 479 1 INV1S $T=513980 901040 0 0 $X=513980 $Y=900660
X1432 2234 2 2404 1 INV1S $T=516460 961520 1 0 $X=516460 $Y=956100
X1433 2359 2 2394 1 INV1S $T=517700 991760 1 180 $X=516460 $Y=991380
X1434 269 2 474 1 INV1S $T=517080 1001840 0 0 $X=517080 $Y=1001460
X1435 2431 2 2205 1 INV1S $T=523280 971600 0 180 $X=522040 $Y=966180
X1436 2414 2 489 1 INV1S $T=522040 1022000 1 0 $X=522040 $Y=1016580
X1437 2316 2 465 1 INV1S $T=523280 1042160 0 180 $X=522040 $Y=1036740
X1438 406 2 499 1 INV1S $T=522660 1032080 1 0 $X=522660 $Y=1026660
X1439 2440 2 494 1 INV1S $T=523900 901040 1 0 $X=523900 $Y=895620
X1440 2380 2 2465 1 INV1S $T=527000 991760 0 0 $X=527000 $Y=991380
X1441 2260 2 2139 1 INV1S $T=527620 951440 0 0 $X=527620 $Y=951060
X1442 2353 2 2478 1 INV1S $T=531340 991760 1 0 $X=531340 $Y=986340
X1443 438 2 2216 1 INV1S $T=531960 941360 0 0 $X=531960 $Y=940980
X1444 211 2 2392 1 INV1S $T=533820 951440 1 0 $X=533820 $Y=946020
X1445 441 2 2481 1 INV1S $T=536300 911120 0 180 $X=535060 $Y=905700
X1446 2166 2 509 1 INV1S $T=536920 890960 0 180 $X=535680 $Y=885540
X1447 2497 2 2482 1 INV1S $T=537540 901040 1 180 $X=536300 $Y=900660
X1448 2428 2 478 1 INV1S $T=536300 1001840 0 0 $X=536300 $Y=1001460
X1449 518 2 2434 1 INV1S $T=541880 951440 0 180 $X=540640 $Y=946020
X1450 522 2 2517 1 INV1S $T=540640 971600 0 0 $X=540640 $Y=971220
X1451 2460 2 1995 1 INV1S $T=540640 1022000 1 0 $X=540640 $Y=1016580
X1452 2399 2 2378 1 INV1S $T=542500 931280 0 0 $X=542500 $Y=930900
X1453 389 2 360 1 INV1S $T=544360 941360 1 180 $X=543120 $Y=940980
X1454 2558 2 2501 1 INV1S $T=544980 951440 0 180 $X=543740 $Y=946020
X1455 2501 2 317 1 INV1S $T=545600 931280 0 0 $X=545600 $Y=930900
X1456 2268 2 2493 1 INV1S $T=546220 971600 1 0 $X=546220 $Y=966180
X1457 2256 2 2531 1 INV1S $T=548700 890960 1 180 $X=547460 $Y=890580
X1458 347 2 458 1 INV1S $T=549320 911120 0 0 $X=549320 $Y=910740
X1459 2409 2 2472 1 INV1S $T=550560 890960 0 0 $X=550560 $Y=890580
X1460 2350 2 521 1 INV1S $T=551180 921200 1 0 $X=551180 $Y=915780
X1461 2293 2 2576 1 INV1S $T=554280 951440 0 180 $X=553040 $Y=946020
X1462 318 2 407 1 INV1S $T=555520 901040 0 180 $X=554280 $Y=895620
X1463 2188 2 2241 1 INV1S $T=554280 921200 0 0 $X=554280 $Y=920820
X1464 2529 2 547 1 INV1S $T=555520 880880 0 0 $X=555520 $Y=880500
X1465 2602 2 2391 1 INV1S $T=557380 901040 0 180 $X=556140 $Y=895620
X1466 290 2 429 1 INV1S $T=557380 880880 0 0 $X=557380 $Y=880500
X1467 331 2 2343 1 INV1S $T=557380 901040 0 0 $X=557380 $Y=900660
X1468 2468 2 471 1 INV1S $T=560480 1001840 1 180 $X=559240 $Y=1001460
X1469 2445 2 507 1 INV1S $T=561720 880880 1 180 $X=560480 $Y=880500
X1470 2413 2 497 1 INV1S $T=565440 931280 1 180 $X=564200 $Y=930900
X1471 2591 2 2603 1 INV1S $T=565440 991760 1 180 $X=564200 $Y=991380
X1472 449 2 2568 1 INV1S $T=567300 931280 1 180 $X=566060 $Y=930900
X1473 2281 2 2622 1 INV1S $T=567300 991760 0 0 $X=567300 $Y=991380
X1474 2548 2 2630 1 INV1S $T=567920 991760 1 0 $X=567920 $Y=986340
X1475 381 2 511 1 INV1S $T=569160 931280 1 0 $X=569160 $Y=925860
X1476 384 2 408 1 INV1S $T=570400 931280 1 180 $X=569160 $Y=930900
X1477 313 2 528 1 INV1S $T=574740 890960 0 0 $X=574740 $Y=890580
X1478 2475 2 2659 1 INV1S $T=574740 991760 0 0 $X=574740 $Y=991380
X1479 2470 2 578 1 INV1S $T=577220 951440 0 0 $X=577220 $Y=951060
X1480 373 2 2178 1 INV1S $T=580320 921200 1 180 $X=579080 $Y=920820
X1481 446 2 583 1 INV1S $T=580320 880880 0 0 $X=580320 $Y=880500
X1482 2643 2 2507 1 INV1S $T=584660 901040 1 180 $X=583420 $Y=900660
X1483 2477 2 2707 1 INV1S $T=584040 951440 1 0 $X=584040 $Y=946020
X1484 460 2 2638 1 INV1S $T=584660 971600 1 0 $X=584660 $Y=966180
X1485 334 2 424 1 INV1S $T=588380 911120 1 0 $X=588380 $Y=905700
X1486 2608 2 2668 1 INV1S $T=590240 941360 0 180 $X=589000 $Y=935940
X1487 2698 2 2717 1 INV1S $T=589620 1001840 0 0 $X=589620 $Y=1001460
X1488 530 2 593 1 INV1S $T=589620 1022000 1 0 $X=589620 $Y=1016580
X1489 2572 2 2620 1 INV1S $T=591480 1001840 1 0 $X=591480 $Y=996420
X1490 2590 2 2694 1 INV1S $T=592100 961520 1 0 $X=592100 $Y=956100
X1491 482 2 506 1 INV1S $T=594580 890960 0 180 $X=593340 $Y=885540
X1492 2592 2 2733 1 INV1S $T=593340 1001840 0 0 $X=593340 $Y=1001460
X1493 2518 2 544 1 INV1S $T=594580 1042160 1 180 $X=593340 $Y=1041780
X1494 2613 2 576 1 INV1S $T=595200 951440 0 180 $X=593960 $Y=946020
X1495 2564 2 573 1 INV1S $T=595820 981680 0 180 $X=594580 $Y=976260
X1496 2663 2 444 1 INV1S $T=596440 901040 0 180 $X=595200 $Y=895620
X1497 2654 2 545 1 INV1S $T=597680 971600 0 180 $X=596440 $Y=966180
X1498 2671 2 586 1 INV1S $T=596440 971600 0 0 $X=596440 $Y=971220
X1499 467 2 2439 1 INV1S $T=598920 921200 0 180 $X=597680 $Y=915780
X1500 2593 2 2656 1 INV1S $T=600160 991760 1 0 $X=600160 $Y=986340
X1501 2546 2 508 1 INV1S $T=602640 971600 0 180 $X=601400 $Y=966180
X1502 2562 2 603 1 INV1S $T=601400 1001840 1 0 $X=601400 $Y=996420
X1503 609 2 2774 1 INV1S $T=602020 890960 1 0 $X=602020 $Y=885540
X1504 2526 2 2516 1 INV1S $T=602020 1032080 1 0 $X=602020 $Y=1026660
X1505 2549 2 552 1 INV1S $T=604500 1001840 1 0 $X=604500 $Y=996420
X1506 2585 2 2614 1 INV1S $T=605120 971600 1 0 $X=605120 $Y=966180
X1507 613 2 2787 1 INV1S $T=608220 941360 1 180 $X=606980 $Y=940980
X1508 527 2 2727 1 INV1S $T=606980 1001840 1 0 $X=606980 $Y=996420
X1509 602 2 2702 1 INV1S $T=608220 1042160 1 180 $X=606980 $Y=1041780
X1510 2569 2 562 1 INV1S $T=610080 951440 1 180 $X=608840 $Y=951060
X1511 2761 2 2794 1 INV1S $T=610080 1052240 1 0 $X=610080 $Y=1046820
X1512 550 2 572 1 INV1S $T=612560 951440 0 0 $X=612560 $Y=951060
X1513 620 2 2811 1 INV1S $T=614420 911120 0 0 $X=614420 $Y=910740
X1514 2509 2 2644 1 INV1S $T=617520 951440 1 180 $X=616280 $Y=951060
X1515 2553 2 526 1 INV1S $T=618140 971600 1 180 $X=616900 $Y=971220
X1516 2556 2 498 1 INV1S $T=620620 961520 0 180 $X=619380 $Y=956100
X1517 533 2 2839 1 INV1S $T=625580 1052240 1 180 $X=624340 $Y=1051860
X1518 626 2 2843 1 INV1S $T=624960 901040 0 0 $X=624960 $Y=900660
X1519 2859 2 2847 1 INV1S $T=627440 931280 1 180 $X=626200 $Y=930900
X1520 632 2 2868 1 INV1S $T=633020 890960 0 0 $X=633020 $Y=890580
X1521 633 2 2873 1 INV1S $T=633640 890960 1 0 $X=633640 $Y=885540
X1522 2610 2 525 1 INV1S $T=634880 981680 0 180 $X=633640 $Y=976260
X1523 627 2 2880 1 INV1S $T=634260 921200 1 0 $X=634260 $Y=915780
X1524 639 2 2881 1 INV1S $T=641700 921200 0 180 $X=640460 $Y=915780
X1525 665 2 670 1 INV1S $T=667120 911120 1 0 $X=667120 $Y=905700
X1526 673 2 674 1 INV1S $T=668980 911120 0 0 $X=668980 $Y=910740
X1527 681 2 684 1 INV1S $T=677040 901040 1 180 $X=675800 $Y=900660
X1528 2997 2 3013 1 INV1S $T=679520 890960 1 0 $X=679520 $Y=885540
X1529 3019 2 3021 1 INV1S $T=686960 890960 0 0 $X=686960 $Y=890580
X1530 3056 2 3061 1 INV1S $T=699980 890960 1 0 $X=699980 $Y=885540
X1531 3054 2 3067 1 INV1S $T=701840 890960 1 0 $X=701840 $Y=885540
X1532 3086 2 3099 1 INV1S $T=706180 951440 1 0 $X=706180 $Y=946020
X1533 3085 2 709 1 INV1S $T=707420 890960 1 0 $X=707420 $Y=885540
X1534 3078 2 3124 1 INV1S $T=713620 901040 1 0 $X=713620 $Y=895620
X1535 3057 2 3148 1 INV1S $T=719820 941360 0 0 $X=719820 $Y=940980
X1536 3069 2 3166 1 INV1S $T=723540 941360 0 0 $X=723540 $Y=940980
X1537 3145 2 3176 1 INV1S $T=726020 941360 0 0 $X=726020 $Y=940980
X1538 3150 2 3181 1 INV1S $T=727260 901040 0 0 $X=727260 $Y=900660
X1539 3137 2 3163 1 INV1S $T=728500 951440 1 0 $X=728500 $Y=946020
X1540 3183 2 3196 1 INV1S $T=730360 901040 0 0 $X=730360 $Y=900660
X1541 3179 2 3203 1 INV1S $T=730360 911120 1 0 $X=730360 $Y=905700
X1542 3105 2 3139 1 INV1S $T=732220 951440 1 0 $X=732220 $Y=946020
X1543 3132 2 3233 1 INV1S $T=740280 901040 0 0 $X=740280 $Y=900660
X1544 3234 2 3236 1 INV1S $T=741520 880880 0 0 $X=741520 $Y=880500
X1545 3087 2 3241 1 INV1S $T=742140 890960 0 0 $X=742140 $Y=890580
X1546 3232 2 3242 1 INV1S $T=742140 901040 0 0 $X=742140 $Y=900660
X1547 3245 2 3243 1 INV1S $T=744000 911120 1 180 $X=742760 $Y=910740
X1548 734 2 3250 1 INV1S $T=744000 890960 1 0 $X=744000 $Y=885540
X1549 3235 2 3251 1 INV1S $T=744000 890960 0 0 $X=744000 $Y=890580
X1550 3256 2 3267 1 INV1S $T=747100 890960 0 0 $X=747100 $Y=890580
X1551 3131 2 3261 1 INV1S $T=747720 890960 1 0 $X=747720 $Y=885540
X1552 3269 2 3185 1 INV1S $T=751440 941360 0 180 $X=750200 $Y=935940
X1553 3378 2 3324 1 INV1S $T=780580 880880 1 180 $X=779340 $Y=880500
X1554 3383 2 3156 1 INV1S $T=781200 941360 1 180 $X=779960 $Y=940980
X1555 3422 2 3452 1 INV1S $T=798560 961520 0 0 $X=798560 $Y=961140
X1556 3337 2 3473 1 INV1S $T=805380 890960 1 0 $X=805380 $Y=885540
X1557 3453 2 3477 1 INV1S $T=806000 890960 0 0 $X=806000 $Y=890580
X1558 3476 2 795 1 INV1S $T=806620 890960 1 0 $X=806620 $Y=885540
X1559 803 2 3503 1 INV1S $T=814060 911120 0 180 $X=812820 $Y=905700
X1560 802 2 3514 1 INV1S $T=813440 901040 0 0 $X=813440 $Y=900660
X1561 806 2 3524 1 INV1S $T=820880 901040 1 0 $X=820880 $Y=895620
X1562 3395 2 3542 1 INV1S $T=823360 931280 1 0 $X=823360 $Y=925860
X1563 813 2 3550 1 INV1S $T=824600 981680 0 0 $X=824600 $Y=981300
X1564 3546 2 3565 1 INV1S $T=827700 951440 0 0 $X=827700 $Y=951060
X1565 3570 2 3214 1 INV1S $T=830180 941360 0 180 $X=828940 $Y=935940
X1566 3580 2 3189 1 INV1S $T=831420 931280 0 180 $X=830180 $Y=925860
X1567 3545 2 3573 1 INV1S $T=830180 951440 0 0 $X=830180 $Y=951060
X1568 3641 2 3259 1 INV1S $T=851260 931280 1 180 $X=850020 $Y=930900
X1569 3646 2 3155 1 INV1S $T=852500 931280 1 180 $X=851260 $Y=930900
X1570 3939 2 3202 1 INV1S $T=939300 890960 0 180 $X=938060 $Y=885540
X1571 3980 2 3213 1 INV1S $T=942400 901040 1 180 $X=941160 $Y=900660
X1572 3948 2 3247 1 INV1S $T=943020 890960 0 180 $X=941780 $Y=885540
X1573 3985 2 3556 1 INV1S $T=954800 890960 1 180 $X=953560 $Y=890580
X1574 3323 2 951 1 INV1S $T=969680 911120 1 0 $X=969680 $Y=905700
X1575 986 2 3569 1 INV1S $T=1037260 890960 0 180 $X=1036020 $Y=885540
X1576 4264 2 3578 1 INV1S $T=1040980 890960 0 180 $X=1039740 $Y=885540
X1577 4290 2 3575 1 INV1S $T=1047800 931280 0 180 $X=1046560 $Y=925860
X1578 4307 2 3538 1 INV1S $T=1053380 931280 0 180 $X=1052140 $Y=925860
X1579 1030 1 1047 1036 2 1062 ND3 $T=224440 951440 1 0 $X=224440 $Y=946020
X1580 1048 1 1053 1056 2 1093 ND3 $T=226300 1052240 1 0 $X=226300 $Y=1046820
X1581 1025 1 1057 1080 2 1126 ND3 $T=226920 921200 0 0 $X=226920 $Y=920820
X1582 1090 1 1072 1118 2 1064 ND3 $T=231260 981680 1 180 $X=228780 $Y=981300
X1583 1100 1 1043 1117 2 1119 ND3 $T=234360 981680 0 0 $X=234360 $Y=981300
X1584 1129 1 1094 1123 2 1061 ND3 $T=239320 991760 0 180 $X=236840 $Y=986340
X1585 1133 1 1142 1127 2 1156 ND3 $T=241800 961520 0 0 $X=241800 $Y=961140
X1586 1097 1 1101 1120 2 1115 ND3 $T=244280 991760 1 180 $X=241800 $Y=991380
X1587 6 1 1144 1138 2 1161 ND3 $T=241800 1052240 1 0 $X=241800 $Y=1046820
X1588 1160 1 1115 1037 2 1129 ND3 $T=246760 1001840 0 180 $X=244280 $Y=996420
X1589 1212 1 1200 1130 2 1193 ND3 $T=254200 921200 0 180 $X=251720 $Y=915780
X1590 1031 1 1200 1220 2 1212 ND3 $T=252340 921200 0 0 $X=252340 $Y=920820
X1591 1237 1 61 46 2 1203 ND3 $T=256060 901040 0 180 $X=253580 $Y=895620
X1592 52 1 1233 1103 2 45 ND3 $T=259780 880880 1 180 $X=257300 $Y=880500
X1593 7 1 1233 1203 2 52 ND3 $T=258540 890960 0 0 $X=258540 $Y=890580
X1594 1247 1 1240 1236 2 1159 ND3 $T=261640 1001840 1 180 $X=259160 $Y=1001460
X1595 1270 1 53 1245 2 1220 ND3 $T=263500 921200 1 180 $X=261020 $Y=920820
X1596 1239 1 1207 1278 2 1099 ND3 $T=261020 971600 0 0 $X=261020 $Y=971220
X1597 1196 1 1246 1276 2 1254 ND3 $T=261020 981680 1 0 $X=261020 $Y=976260
X1598 1261 1 1147 1271 2 1277 ND3 $T=264120 1032080 1 0 $X=264120 $Y=1026660
X1599 1241 1 1307 1295 2 1314 ND3 $T=270940 911120 0 0 $X=270940 $Y=910740
X1600 1300 1 1305 1323 2 1317 ND3 $T=270940 1001840 1 0 $X=270940 $Y=996420
X1601 81 1 82 1402 2 96 ND3 $T=275900 890960 1 0 $X=275900 $Y=885540
X1602 1381 1 93 1287 2 88 ND3 $T=282100 1052240 1 180 $X=279620 $Y=1051860
X1603 1164 1 1365 1363 2 1188 ND3 $T=282720 981680 0 180 $X=280240 $Y=976260
X1604 91 1 1161 1380 2 1339 ND3 $T=282720 1052240 0 180 $X=280240 $Y=1046820
X1605 1319 1 1320 1373 2 1350 ND3 $T=282100 911120 0 0 $X=282100 $Y=910740
X1606 1388 1 1379 1367 2 1320 ND3 $T=285200 931280 0 180 $X=282720 $Y=925860
X1607 90 1 94 1190 2 97 ND3 $T=283340 890960 0 0 $X=283340 $Y=890580
X1608 1359 1 1386 1134 2 1413 ND3 $T=284580 921200 0 0 $X=284580 $Y=920820
X1609 1414 1 1378 1408 2 1377 ND3 $T=287060 1011920 0 180 $X=284580 $Y=1006500
X1610 1377 1 1406 1364 2 1342 ND3 $T=287680 991760 1 0 $X=287680 $Y=986340
X1611 89 1 82 1429 2 96 ND3 $T=288920 890960 0 0 $X=288920 $Y=890580
X1612 1419 1 1417 1297 2 1410 ND3 $T=291400 911120 1 180 $X=288920 $Y=910740
X1613 1387 1 1423 1448 2 1411 ND3 $T=290780 1001840 1 0 $X=290780 $Y=996420
X1614 1439 1 1305 1447 2 1195 ND3 $T=295120 971600 0 0 $X=295120 $Y=971220
X1615 1454 1 1305 1452 2 1412 ND3 $T=298220 991760 1 180 $X=295740 $Y=991380
X1616 1471 1 1419 1421 2 1441 ND3 $T=298840 911120 0 180 $X=296360 $Y=905700
X1617 1469 1 1459 1453 2 1450 ND3 $T=299460 1011920 1 180 $X=296980 $Y=1011540
X1618 50 1 1409 1477 2 1339 ND3 $T=296980 1042160 1 0 $X=296980 $Y=1036740
X1619 1182 1 1466 1442 2 1440 ND3 $T=300080 981680 0 180 $X=297600 $Y=976260
X1620 114 1 116 117 2 122 ND3 $T=298220 880880 0 0 $X=298220 $Y=880500
X1621 1351 1 1350 1479 2 1437 ND3 $T=299460 921200 1 0 $X=299460 $Y=915780
X1622 1437 1 1445 1514 2 1410 ND3 $T=305660 921200 1 0 $X=305660 $Y=915780
X1623 1523 1 67 129 2 82 ND3 $T=309380 890960 0 180 $X=306900 $Y=885540
X1624 1517 1 1520 1492 2 1346 ND3 $T=309380 971600 0 180 $X=306900 $Y=966180
X1625 1293 1 1320 1509 2 1350 ND3 $T=310000 911120 1 180 $X=307520 $Y=910740
X1626 1526 1 1329 1476 2 1519 ND3 $T=308140 961520 0 0 $X=308140 $Y=961140
X1627 1234 1 1353 1527 2 1535 ND3 $T=308760 981680 1 0 $X=308760 $Y=976260
X1628 140 1 96 1501 2 131 ND3 $T=313100 880880 1 180 $X=310620 $Y=880500
X1629 1523 1 115 141 2 96 ND3 $T=312480 890960 1 0 $X=312480 $Y=885540
X1630 1538 1 80 1547 2 105 ND3 $T=314340 1022000 1 0 $X=314340 $Y=1016580
X1631 1559 1 1436 1580 2 1376 ND3 $T=317440 981680 1 180 $X=314960 $Y=981300
X1632 1544 1 1242 1343 2 1211 ND3 $T=314960 1042160 0 0 $X=314960 $Y=1041780
X1633 1388 1 1445 1553 2 1350 ND3 $T=316820 911120 0 0 $X=316820 $Y=910740
X1634 1562 1 1569 1550 2 1576 ND3 $T=319920 981680 0 0 $X=319920 $Y=981300
X1635 1529 1 1417 1583 2 1570 ND3 $T=324880 921200 0 180 $X=322400 $Y=915780
X1636 36 1 1605 1608 2 105 ND3 $T=328600 1022000 1 180 $X=326120 $Y=1021620
X1637 1632 1 1612 1579 2 1522 ND3 $T=334800 961520 1 180 $X=332320 $Y=961140
X1638 1643 1 1601 1200 2 1634 ND3 $T=335420 921200 0 180 $X=332940 $Y=915780
X1639 174 1 166 1233 2 169 ND3 $T=336040 880880 1 180 $X=333560 $Y=880500
X1640 1674 1 1305 1668 2 183 ND3 $T=344100 1032080 1 180 $X=341620 $Y=1031700
X1641 1382 1 1446 1672 2 185 ND3 $T=342240 971600 1 0 $X=342240 $Y=966180
X1642 1667 1 1038 1656 2 1677 ND3 $T=342240 1022000 0 0 $X=342240 $Y=1021620
X1643 1665 1 1673 1680 2 1480 ND3 $T=342860 991760 1 0 $X=342860 $Y=986340
X1644 1339 1 1298 187 2 1609 ND3 $T=344100 1052240 1 0 $X=344100 $Y=1046820
X1645 1700 1 1696 1689 2 1683 ND3 $T=350920 971600 0 180 $X=348440 $Y=966180
X1646 1467 1 1693 1703 2 1473 ND3 $T=348440 991760 1 0 $X=348440 $Y=986340
X1647 1721 1 1719 1704 2 1354 ND3 $T=356500 981680 0 180 $X=354020 $Y=976260
X1648 205 1 204 1670 2 171 ND3 $T=356500 1052240 1 180 $X=354020 $Y=1051860
X1649 1743 1 1726 10 2 1664 ND3 $T=358360 971600 1 180 $X=355880 $Y=971220
X1650 175 1 1298 1737 2 1211 ND3 $T=358360 991760 0 0 $X=358360 $Y=991380
X1651 1749 1 1726 1177 2 1649 ND3 $T=362080 981680 0 180 $X=359600 $Y=976260
X1652 1701 1 1697 1725 2 1713 ND3 $T=360220 1022000 0 0 $X=360220 $Y=1021620
X1653 1746 1 1525 1631 2 1752 ND3 $T=361460 1022000 1 0 $X=361460 $Y=1016580
X1654 1664 1 1726 1285 2 1749 ND3 $T=364560 971600 1 0 $X=364560 $Y=966180
X1655 1758 1 1768 1736 2 1773 ND3 $T=366420 931280 0 0 $X=366420 $Y=930900
X1656 1743 1 1726 66 2 1649 ND3 $T=369520 971600 0 0 $X=369520 $Y=971220
X1657 1742 1 1786 1296 2 1748 ND3 $T=374480 961520 0 180 $X=372000 $Y=956100
X1658 1755 1 1786 1405 2 211 ND3 $T=373860 981680 0 0 $X=373860 $Y=981300
X1659 222 1 1802 1698 2 1542 ND3 $T=377580 1022000 1 180 $X=375100 $Y=1021620
X1660 1811 1 1748 1071 2 1664 ND3 $T=379440 961520 0 180 $X=376960 $Y=956100
X1661 1811 1 1748 1311 2 1649 ND3 $T=379440 961520 1 180 $X=376960 $Y=961140
X1662 1817 1 211 1804 2 215 ND3 $T=380680 901040 1 180 $X=378200 $Y=900660
X1663 1819 1 48 1772 2 1741 ND3 $T=380680 1032080 1 180 $X=378200 $Y=1031700
X1664 1742 1 1786 1510 2 211 ND3 $T=380060 981680 0 0 $X=380060 $Y=981300
X1665 1811 1 1649 162 2 211 ND3 $T=381300 971600 0 0 $X=381300 $Y=971220
X1666 1811 1 211 107 2 1664 ND3 $T=385020 971600 1 0 $X=385020 $Y=966180
X1667 1697 1 216 1788 2 181 ND3 $T=389980 1032080 0 0 $X=389980 $Y=1031700
X1668 1475 1 1699 1321 2 1855 ND3 $T=391840 971600 1 0 $X=391840 $Y=966180
X1669 1838 1 181 241 2 240 ND3 $T=394320 1052240 1 180 $X=391840 $Y=1051860
X1670 1842 1 1861 1810 2 1866 ND3 $T=396180 931280 1 0 $X=396180 $Y=925860
X1671 1852 1 1733 1861 2 1865 ND3 $T=396180 931280 0 0 $X=396180 $Y=930900
X1672 1889 1 200 1662 2 1761 ND3 $T=398660 1042160 0 180 $X=396180 $Y=1036740
X1673 1876 1 1816 1866 2 1740 ND3 $T=400520 941360 0 180 $X=398040 $Y=935940
X1674 253 1 1260 1832 2 1802 ND3 $T=402380 1052240 1 180 $X=399900 $Y=1051860
X1675 181 1 1491 1882 2 1599 ND3 $T=403000 1001840 0 0 $X=403000 $Y=1001460
X1676 1878 1 1644 1790 2 1599 ND3 $T=406720 1032080 1 180 $X=404240 $Y=1031700
X1677 181 1 1321 1896 2 227 ND3 $T=407960 1052240 1 0 $X=407960 $Y=1046820
X1678 1892 1 1867 1144 2 1833 ND3 $T=413540 991760 1 180 $X=411060 $Y=991380
X1679 1925 1 261 1917 2 1910 ND3 $T=417880 1011920 0 180 $X=415400 $Y=1006500
X1680 1904 1 266 1915 2 268 ND3 $T=416020 1022000 1 0 $X=416020 $Y=1016580
X1681 1936 1 1944 1960 2 1955 ND3 $T=422220 981680 0 0 $X=422220 $Y=981300
X1682 1950 1 287 1934 2 1965 ND3 $T=425940 1011920 1 0 $X=425940 $Y=1006500
X1683 1996 1 211 2037 2 215 ND3 $T=435860 951440 1 0 $X=435860 $Y=946020
X1684 2112 1 2055 2032 2 2100 ND3 $T=459420 1011920 1 180 $X=456940 $Y=1011540
X1685 2125 1 308 2131 2 1939 ND3 $T=460660 1032080 0 180 $X=458180 $Y=1026660
X1686 384 1 385 374 2 389 ND3 $T=463140 880880 0 0 $X=463140 $Y=880500
X1687 358 1 1918 2190 2 2149 ND3 $T=466860 1042160 0 0 $X=466860 $Y=1041780
X1688 2161 1 2179 388 2 2181 ND3 $T=469340 931280 0 0 $X=469340 $Y=930900
X1689 320 1 290 2185 2 411 ND3 $T=479260 901040 0 180 $X=476780 $Y=895620
X1690 2240 1 2055 2226 2 297 ND3 $T=481120 1042160 1 180 $X=478640 $Y=1041780
X1691 2269 1 266 2245 2 2055 ND3 $T=484220 1022000 0 180 $X=481740 $Y=1016580
X1692 2248 1 331 2164 2 318 ND3 $T=484840 901040 1 180 $X=482360 $Y=900660
X1693 431 1 425 2170 2 2188 ND3 $T=484840 911120 0 180 $X=482360 $Y=905700
X1694 2284 1 2188 2295 2 2280 ND3 $T=492900 911120 0 0 $X=492900 $Y=910740
X1695 2305 1 342 2244 2 447 ND3 $T=497240 941360 0 180 $X=494760 $Y=935940
X1696 454 1 305 2294 2 329 ND3 $T=497240 1052240 1 180 $X=494760 $Y=1051860
X1697 2240 1 305 2312 2 2287 ND3 $T=495380 1032080 0 0 $X=495380 $Y=1031700
X1698 2334 1 453 2258 2 2317 ND3 $T=502200 941360 1 180 $X=499720 $Y=940980
X1699 419 1 2049 2342 2 458 ND3 $T=500340 890960 1 0 $X=500340 $Y=885540
X1700 2163 1 432 464 2 316 ND3 $T=502200 1011920 1 0 $X=502200 $Y=1006500
X1701 2376 1 425 2263 2 2350 ND3 $T=510880 941360 1 180 $X=508400 $Y=940980
X1702 2387 1 1923 2389 2 486 ND3 $T=516460 1042160 0 0 $X=516460 $Y=1041780
X1703 491 1 2416 2401 2 2268 ND3 $T=519560 971600 1 180 $X=517080 $Y=971220
X1704 2377 1 2401 2429 2 485 ND3 $T=517700 1052240 1 0 $X=517700 $Y=1046820
X1705 2443 1 399 2430 2 2184 ND3 $T=524520 921200 1 180 $X=522040 $Y=920820
X1706 2425 1 2233 2416 2 2446 ND3 $T=523280 961520 1 0 $X=523280 $Y=956100
X1707 285 1 1930 2456 2 1919 ND3 $T=527620 981680 1 180 $X=525140 $Y=981300
X1708 2458 1 2450 2457 2 2420 ND3 $T=527620 1022000 0 180 $X=525140 $Y=1016580
X1709 2437 1 519 524 2 2524 ND3 $T=538780 890960 1 0 $X=538780 $Y=885540
X1710 2495 1 2517 2512 2 2527 ND3 $T=539400 1032080 1 0 $X=539400 $Y=1026660
X1711 2540 1 2543 2497 2 437 ND3 $T=543740 901040 0 0 $X=543740 $Y=900660
X1712 2574 1 531 2575 2 2567 ND3 $T=545600 1032080 1 0 $X=545600 $Y=1026660
X1713 2286 1 2201 2598 2 2234 ND3 $T=547460 961520 1 0 $X=547460 $Y=956100
X1714 2552 1 2561 2570 2 2571 ND3 $T=548700 1001840 0 0 $X=548700 $Y=1001460
X1715 2617 1 437 2589 2 2350 ND3 $T=560480 921200 1 180 $X=558000 $Y=920820
X1716 2588 1 2382 554 2 2527 ND3 $T=559240 1032080 0 0 $X=559240 $Y=1031700
X1717 2560 1 2212 2606 2 2599 ND3 $T=562960 931280 1 180 $X=560480 $Y=930900
X1718 2649 1 2549 2627 2 541 ND3 $T=570400 981680 0 180 $X=567920 $Y=976260
X1719 2651 1 2373 2698 2 2693 ND3 $T=579080 1001840 1 0 $X=579080 $Y=996420
X1720 2701 1 2688 2706 2 2704 ND3 $T=585280 1001840 0 0 $X=585280 $Y=1001460
X1721 2496 1 2705 2716 2 2714 ND3 $T=585900 981680 0 0 $X=585900 $Y=981300
X1722 2471 1 2674 2726 2 2720 ND3 $T=589000 1042160 0 0 $X=589000 $Y=1041780
X1723 2736 1 2653 2735 2 2728 ND3 $T=596440 961520 1 180 $X=593960 $Y=961140
X1724 2741 1 467 605 2 574 ND3 $T=597680 880880 0 0 $X=597680 $Y=880500
X1725 2770 1 2740 2738 2 2747 ND3 $T=602020 1022000 1 180 $X=599540 $Y=1021620
X1726 2822 1 2536 2814 2 619 ND3 $T=616280 1042160 1 180 $X=613800 $Y=1041780
X1727 2734 1 2607 2840 2 2851 ND3 $T=621860 971600 0 0 $X=621860 $Y=971220
X1728 2848 1 540 2878 2 2408 ND3 $T=628060 1042160 0 0 $X=628060 $Y=1041780
X1729 2545 1 631 2867 2 2866 ND3 $T=630540 1052240 1 0 $X=630540 $Y=1046820
X1730 630 1 2758 2860 2 2842 ND3 $T=632400 1011920 1 0 $X=632400 $Y=1006500
X1731 2854 1 2830 2884 2 2604 ND3 $T=632400 1011920 0 0 $X=632400 $Y=1011540
X1732 2436 1 2815 2888 2 2914 ND3 $T=637980 991760 1 0 $X=637980 $Y=986340
X1733 2854 1 2647 2871 2 2807 ND3 $T=639840 1011920 1 0 $X=639840 $Y=1006500
X1734 2537 1 2753 2906 2 2896 ND3 $T=641080 1022000 1 0 $X=641080 $Y=1016580
X1735 637 1 642 2891 2 2904 ND3 $T=642940 1052240 1 0 $X=642940 $Y=1046820
X1736 643 1 2827 2905 2 2921 ND3 $T=649140 1011920 1 0 $X=649140 $Y=1006500
X1737 654 1 2929 2925 2 2936 ND3 $T=657200 1042160 1 0 $X=657200 $Y=1036740
X1738 668 1 2963 2964 2 2950 ND3 $T=667740 1001840 0 0 $X=667740 $Y=1001460
X1739 2968 1 2965 2977 2 2983 ND3 $T=670840 991760 1 0 $X=670840 $Y=986340
X1740 680 1 2974 2976 2 2952 ND3 $T=673320 1022000 1 180 $X=670840 $Y=1021620
X1741 686 1 3002 2989 2 2955 ND3 $T=676420 1032080 1 180 $X=673940 $Y=1031700
X1742 3055 1 3036 3066 2 3031 ND3 $T=700600 1022000 0 180 $X=698120 $Y=1016580
X1743 711 1 3103 3101 2 3079 ND3 $T=709280 1032080 0 180 $X=706800 $Y=1026660
X1744 3141 1 3135 3118 2 3147 ND3 $T=718580 1022000 0 0 $X=718580 $Y=1021620
X1745 3171 1 3169 3164 2 3165 ND3 $T=725400 1022000 0 180 $X=722920 $Y=1016580
X1746 729 1 3208 3209 2 3195 ND3 $T=734080 1011920 0 180 $X=731600 $Y=1006500
X1747 730 1 3218 3216 2 3231 ND3 $T=736560 1022000 0 0 $X=736560 $Y=1021620
X1748 3291 1 3297 3293 2 3309 ND3 $T=758880 1032080 1 0 $X=758880 $Y=1026660
X1749 3310 1 3296 3335 2 3339 ND3 $T=765700 1001840 0 0 $X=765700 $Y=1001460
X1750 766 1 3319 3332 2 3338 ND3 $T=770660 1022000 1 180 $X=768180 $Y=1021620
X1751 3374 1 3380 3382 2 3346 ND3 $T=781200 1001840 1 180 $X=778720 $Y=1001460
X1752 784 1 3411 3428 2 3418 ND3 $T=795460 1022000 1 180 $X=792980 $Y=1021620
X1753 786 1 3450 3448 2 3442 ND3 $T=799800 1022000 1 180 $X=797320 $Y=1021620
X1754 3484 1 3497 3490 2 3458 ND3 $T=811580 1022000 0 180 $X=809100 $Y=1016580
X1755 3602 1 3608 3606 2 3596 ND3 $T=841960 1011920 1 0 $X=841960 $Y=1006500
X1756 841 1 3618 3611 2 3595 ND3 $T=843820 1032080 1 0 $X=843820 $Y=1026660
X1757 847 1 3633 3636 2 3640 ND3 $T=847540 981680 0 0 $X=847540 $Y=981300
X1758 3653 1 3676 3677 2 3669 ND3 $T=857460 981680 0 0 $X=857460 $Y=981300
X1759 872 1 3712 3694 2 3717 ND3 $T=868000 1042160 0 0 $X=868000 $Y=1041780
X1760 878 1 3714 3741 2 3745 ND3 $T=876060 1032080 0 0 $X=876060 $Y=1031700
X1761 3733 1 3724 3751 2 3728 ND3 $T=880400 991760 1 0 $X=880400 $Y=986340
X1762 3762 1 3761 3770 2 3772 ND3 $T=885980 981680 0 0 $X=885980 $Y=981300
X1763 3783 1 3797 3804 2 3790 ND3 $T=893420 1042160 1 0 $X=893420 $Y=1036740
X1764 891 1 3809 3813 2 3816 ND3 $T=898380 1042160 0 0 $X=898380 $Y=1041780
X1765 3805 1 3829 3821 2 3832 ND3 $T=905200 991760 0 0 $X=905200 $Y=991380
X1766 907 1 3861 3858 2 3856 ND3 $T=917600 1042160 0 180 $X=915120 $Y=1036740
X1767 3889 1 3876 3881 2 3874 ND3 $T=925660 981680 1 180 $X=923180 $Y=981300
X1768 3908 1 3899 3867 2 3893 ND3 $T=931240 981680 1 180 $X=928760 $Y=981300
X1769 913 1 3885 3898 2 3915 ND3 $T=928760 1042160 1 0 $X=928760 $Y=1036740
X1770 922 1 3937 3916 2 3942 ND3 $T=938060 1022000 0 0 $X=938060 $Y=1021620
X1771 924 1 3935 3911 2 3943 ND3 $T=939300 1042160 0 0 $X=939300 $Y=1041780
X1772 4015 1 4007 3979 2 4022 ND3 $T=962860 971600 1 0 $X=962860 $Y=966180
X1773 4020 1 4009 3978 2 4031 ND3 $T=964100 1001840 0 0 $X=964100 $Y=1001460
X1774 4037 1 4050 4051 2 4056 ND3 $T=968440 1011920 0 0 $X=968440 $Y=1011540
X1775 4059 1 4040 4017 2 4078 ND3 $T=970920 981680 0 0 $X=970920 $Y=981300
X1776 965 1 4018 3972 2 4094 ND3 $T=980840 1001840 0 0 $X=980840 $Y=1001460
X1777 4085 1 4089 4087 2 4096 ND3 $T=982080 981680 0 0 $X=982080 $Y=981300
X1778 4146 1 4151 4139 2 4137 ND3 $T=1000680 981680 1 180 $X=998200 $Y=981300
X1779 4170 1 4181 4173 2 4188 ND3 $T=1008120 981680 0 0 $X=1008120 $Y=981300
X1780 4189 1 4214 4213 2 4195 ND3 $T=1021760 1001840 1 180 $X=1019280 $Y=1001460
X1781 4199 1 4226 4234 2 4233 ND3 $T=1023620 991760 1 0 $X=1023620 $Y=986340
X1782 4247 1 4253 4256 2 4251 ND3 $T=1032300 981680 1 0 $X=1032300 $Y=976260
X1783 989 1 4268 4272 2 4263 ND3 $T=1042220 1001840 0 180 $X=1039740 $Y=996420
X1784 4337 1 4300 4338 2 4353 ND3 $T=1058960 1011920 0 0 $X=1058960 $Y=1011540
X1785 4341 1 4350 4354 2 4362 ND3 $T=1064540 981680 0 0 $X=1064540 $Y=981300
X1786 4355 1 4357 4336 2 4387 ND3 $T=1065780 991760 1 0 $X=1065780 $Y=986340
X1787 4348 1 4323 4368 2 4389 ND3 $T=1066400 971600 1 0 $X=1066400 $Y=966180
X1788 998 1 4364 4367 2 4394 ND3 $T=1071360 1001840 1 0 $X=1071360 $Y=996420
X1789 99 1 98 1218 1292 2 ND3S $T=286440 1022000 1 180 $X=283960 $Y=1021620
X1790 1554 1 1557 1548 1339 2 ND3S $T=319300 1001840 1 180 $X=316820 $Y=1001460
X1791 1609 1 1211 1591 33 2 ND3S $T=332320 1052240 0 180 $X=329840 $Y=1046820
X1792 1658 1 1327 1618 1598 2 ND3S $T=338520 971600 0 180 $X=336040 $Y=966180
X1793 1339 1 1144 1666 1416 2 ND3S $T=345340 1011920 0 180 $X=342860 $Y=1006500
X1794 207 1 1609 1162 1605 2 ND3S $T=357740 1042160 0 180 $X=355260 $Y=1036740
X1795 1225 1 1785 1798 1726 2 ND3S $T=374480 931280 1 180 $X=372000 $Y=930900
X1796 224 1 1804 1478 1828 2 ND3S $T=376340 911120 1 0 $X=376340 $Y=905700
X1797 1802 1 1211 233 33 2 ND3S $T=384400 1052240 0 0 $X=384400 $Y=1051860
X1798 198 1 1144 1835 1702 2 ND3S $T=386260 1001840 1 0 $X=386260 $Y=996420
X1799 1844 1 1813 1211 1833 2 ND3S $T=389360 981680 1 180 $X=386880 $Y=981300
X1800 1609 1 1211 1847 1409 2 ND3S $T=389360 1042160 1 180 $X=386880 $Y=1041780
X1801 1616 1 1837 1575 1833 2 ND3S $T=394320 991760 1 180 $X=391840 $Y=991380
X1802 1833 1 1699 1161 1837 2 ND3S $T=392460 1001840 1 0 $X=392460 $Y=996420
X1803 1838 1 119 1854 17 2 ND3S $T=395560 1042160 1 180 $X=393080 $Y=1041780
X1804 1870 1 1867 1609 1813 2 ND3S $T=397420 991760 0 180 $X=394940 $Y=986340
X1805 1870 1 1867 1702 1778 2 ND3S $T=399900 981680 1 180 $X=397420 $Y=981300
X1806 1886 1 1837 1260 1616 2 ND3S $T=405480 1001840 0 180 $X=403000 $Y=996420
X1807 1870 1 1831 1644 1813 2 ND3S $T=406100 981680 1 180 $X=403620 $Y=981300
X1808 1892 1 1867 216 1886 2 ND3S $T=407960 991760 1 180 $X=405480 $Y=991380
X1809 1892 1 1831 1599 1886 2 ND3S $T=411060 991760 0 180 $X=408580 $Y=986340
X1810 224 1 1867 1893 1778 2 ND3S $T=411060 941360 0 0 $X=411060 $Y=940980
X1811 98 1 1644 1895 1599 2 ND3S $T=411680 1032080 0 0 $X=411680 $Y=1031700
X1812 290 1 272 1979 300 2 ND3S $T=428420 921200 0 0 $X=428420 $Y=920820
X1813 2040 1 324 2017 315 2 ND3S $T=442060 1011920 0 180 $X=439580 $Y=1006500
X1814 249 1 2037 2058 1931 2 ND3S $T=443300 951440 1 0 $X=443300 $Y=946020
X1815 362 1 317 2104 2088 2 ND3S $T=456320 901040 0 180 $X=453840 $Y=895620
X1816 2132 1 372 2120 1911 2 ND3S $T=460040 1042160 1 180 $X=457560 $Y=1041780
X1817 2144 1 2147 2162 229 2 ND3S $T=464380 951440 1 0 $X=464380 $Y=946020
X1818 372 1 2134 2133 2129 2 ND3S $T=468100 971600 1 180 $X=465620 $Y=971220
X1819 2136 1 273 2174 2018 2 ND3S $T=468720 1022000 1 180 $X=466240 $Y=1021620
X1820 2115 1 309 2218 372 2 ND3S $T=473060 1042160 1 0 $X=473060 $Y=1036740
X1821 411 1 303 2267 317 2 ND3S $T=483600 921200 1 0 $X=483600 $Y=915780
X1822 2287 1 315 2274 2249 2 ND3S $T=491660 1001840 0 180 $X=489180 $Y=996420
X1823 2210 1 2293 2301 2243 2 ND3S $T=495380 921200 0 180 $X=492900 $Y=915780
X1824 2097 1 372 2308 2040 2 ND3S $T=496620 991760 1 0 $X=496620 $Y=986340
X1825 1923 1 1999 2318 273 2 ND3S $T=497240 1032080 1 0 $X=497240 $Y=1026660
X1826 467 1 441 2323 2293 2 ND3S $T=503440 901040 0 180 $X=500960 $Y=895620
X1827 2338 1 289 2368 2154 2 ND3S $T=504680 1032080 0 0 $X=504680 $Y=1031700
X1828 2364 1 449 2363 448 2 ND3S $T=512120 890960 0 180 $X=509640 $Y=885540
X1829 2390 1 331 2369 362 2 ND3S $T=514600 901040 0 180 $X=512120 $Y=895620
X1830 317 1 2049 2421 2057 2 ND3S $T=517080 901040 0 0 $X=517080 $Y=900660
X1831 2445 1 2356 2464 2340 2 ND3S $T=528860 911120 0 0 $X=528860 $Y=910740
X1832 2390 1 2188 2476 2413 2 ND3S $T=530720 921200 1 0 $X=530720 $Y=915780
X1833 2525 1 334 517 290 2 ND3S $T=540640 911120 0 180 $X=538160 $Y=905700
X1834 2534 1 290 2529 2399 2 ND3S $T=544360 911120 0 0 $X=544360 $Y=910740
X1835 427 1 334 2581 331 2 ND3S $T=554900 901040 1 180 $X=552420 $Y=900660
X1836 2413 1 2522 2615 399 2 ND3S $T=562960 921200 0 180 $X=560480 $Y=915780
X1837 449 1 290 560 425 2 ND3S $T=566060 880880 1 180 $X=563580 $Y=880500
X1838 2519 1 2413 2256 2643 2 ND3S $T=567300 901040 1 0 $X=567300 $Y=895620
X1839 2413 1 313 2677 303 2 ND3S $T=572880 901040 1 0 $X=572880 $Y=895620
X1840 2530 1 2622 2709 2475 2 ND3S $T=573500 961520 0 0 $X=573500 $Y=961140
X1841 2682 1 2409 597 2663 2 ND3S $T=585280 890960 0 0 $X=585280 $Y=890580
X1842 2718 1 2643 2608 594 2 ND3S $T=590240 901040 1 180 $X=587760 $Y=900660
X1843 2663 1 331 2731 427 2 ND3S $T=596440 901040 1 180 $X=593960 $Y=900660
X1844 2798 1 2367 2778 2687 2 ND3S $T=606980 1022000 1 180 $X=604500 $Y=1021620
X1845 2807 1 2492 2816 2779 2 ND3S $T=614420 1011920 0 180 $X=611940 $Y=1006500
X1846 2910 1 2547 2893 2835 2 ND3S $T=646660 981680 0 180 $X=644180 $Y=976260
X1847 1114 16 1103 2 14 1 9 AN4B1S $T=238080 890960 0 180 $X=233740 $Y=885540
X1848 1139 1104 1130 2 1125 1 1057 AN4B1S $T=242420 921200 0 180 $X=238080 $Y=915780
X1849 1152 1167 1165 2 1176 1 1182 AN4B1S $T=246140 1001840 0 0 $X=246140 $Y=1001460
X1850 1201 1169 1170 2 1216 1 1229 AN4B1S $T=253580 951440 0 0 $X=253580 $Y=951060
X1851 50 47 1171 2 43 1 1217 AN4B1S $T=259160 1052240 1 180 $X=254820 $Y=1051860
X1852 1171 1161 50 2 1238 1 1269 AN4B1S $T=257920 1042160 1 0 $X=257920 $Y=1036740
X1853 1283 1259 1166 2 1245 1 1241 AN4B1S $T=265360 911120 1 180 $X=261020 $Y=910740
X1854 64 1113 1257 2 1253 1 1261 AN4B1S $T=265980 1042160 1 180 $X=261640 $Y=1041780
X1855 1248 1249 1265 2 1267 1 1283 AN4B1S $T=264120 931280 0 0 $X=264120 $Y=930900
X1856 1294 63 1279 2 1079 1 1247 AN4B1S $T=269080 1032080 1 180 $X=264740 $Y=1031700
X1857 1184 1301 1306 2 1310 1 1329 AN4B1S $T=269700 1032080 1 0 $X=269700 $Y=1026660
X1858 1339 47 1331 2 74 1 1181 AN4B1S $T=277140 1052240 1 180 $X=272800 $Y=1051860
X1859 73 77 79 2 1335 1 1307 AN4B1S $T=273420 911120 0 0 $X=273420 $Y=910740
X1860 1353 1337 1208 2 1316 1 1314 AN4B1S $T=278380 961520 1 180 $X=274040 $Y=961140
X1861 1368 1208 1290 2 1127 1 1346 AN4B1S $T=280240 971600 0 180 $X=275900 $Y=966180
X1862 1365 1349 1254 2 1219 1 1354 AN4B1S $T=283340 981680 1 180 $X=279000 $Y=981300
X1863 1383 1375 1370 2 1336 1 1186 AN4B1S $T=285200 951440 1 180 $X=280860 $Y=951060
X1864 1425 1407 1197 2 1336 1 1394 AN4B1S $T=290780 981680 1 180 $X=286440 $Y=981300
X1865 1438 80 1416 2 23 1 1369 AN4B1S $T=292640 1032080 0 180 $X=288300 $Y=1026660
X1866 50 88 1331 2 70 1 1443 AN4B1S $T=288920 1022000 0 0 $X=288920 $Y=1021620
X1867 1418 1195 1430 2 1433 1 1446 AN4B1S $T=290780 961520 0 0 $X=290780 $Y=961140
X1868 1394 1342 1378 2 1442 1 1473 AN4B1S $T=293260 991760 1 0 $X=293260 $Y=986340
X1869 36 17 93 2 120 1 1483 AN4B1S $T=299460 1052240 0 0 $X=299460 $Y=1051860
X1870 1371 1417 1410 2 1479 1 1470 AN4B1S $T=304420 911120 1 180 $X=300080 $Y=910740
X1871 1413 1320 1386 2 1449 1 1497 AN4B1S $T=300080 921200 0 0 $X=300080 $Y=920820
X1872 1490 1455 1284 2 1318 1 1480 AN4B1S $T=305660 991760 0 180 $X=301320 $Y=986340
X1873 1503 1252 1464 2 125 1 1469 AN4B1S $T=306900 1011920 0 180 $X=302560 $Y=1006500
X1874 76 116 122 2 1501 1 1415 AN4B1S $T=303180 880880 0 0 $X=303180 $Y=880500
X1875 1505 1502 1512 2 134 1 1517 AN4B1S $T=307520 1011920 0 0 $X=307520 $Y=1011540
X1876 1540 1545 145 2 1117 1 1526 AN4B1S $T=314340 981680 1 0 $X=314340 $Y=976260
X1877 1371 1359 1529 2 1555 1 1556 AN4B1S $T=315580 921200 0 0 $X=315580 $Y=920820
X1878 76 90 149 2 1558 1 154 AN4B1S $T=316200 880880 0 0 $X=316200 $Y=880500
X1879 1549 1401 1563 2 152 1 1562 AN4B1S $T=317440 1032080 0 0 $X=317440 $Y=1031700
X1880 1024 1059 1594 2 1036 1 1584 AN4B1S $T=327980 951440 0 180 $X=323640 $Y=946020
X1881 17 147 1600 2 1578 1 165 AN4B1S $T=324880 1042160 1 0 $X=324880 $Y=1036740
X1882 1425 1607 1535 2 1551 1 1593 AN4B1S $T=329840 981680 1 180 $X=325500 $Y=981300
X1883 1624 1383 1606 2 1580 1 1598 AN4B1S $T=330460 971600 1 180 $X=326120 $Y=971220
X1884 1610 1298 164 2 1608 1 1474 AN4B1S $T=331080 1022000 0 180 $X=326740 $Y=1016580
X1885 1633 1590 1639 2 1323 1 1659 AN4B1S $T=334180 991760 0 0 $X=334180 $Y=991380
X1886 1678 1530 1508 2 1627 1 1654 AN4B1S $T=343480 981680 1 180 $X=339140 $Y=981300
X1887 91 17 1605 2 1666 1 1661 AN4B1S $T=339760 1011920 0 0 $X=339760 $Y=1011540
X1888 1582 1577 1657 2 1676 1 1673 AN4B1S $T=341620 991760 0 0 $X=341620 $Y=991380
X1889 1710 1570 1445 2 1225 1 1694 AN4B1S $T=352160 921200 0 180 $X=347820 $Y=915780
X1890 1498 207 1642 2 153 1 1762 AN4B1S $T=360220 1042160 1 0 $X=360220 $Y=1036740
X1891 1542 1642 1761 2 1488 1 1533 AN4B1S $T=368280 1032080 1 180 $X=363940 $Y=1031700
X1892 17 1211 1260 2 202 1 1757 AN4B1S $T=368280 1052240 1 180 $X=363940 $Y=1051860
X1893 1754 1760 1764 2 1766 1 1758 AN4B1S $T=364560 961520 0 0 $X=364560 $Y=961140
X1894 209 1409 213 2 1488 1 1756 AN4B1S $T=369520 1032080 0 180 $X=365180 $Y=1026660
X1895 1802 33 1575 2 1255 1 1777 AN4B1S $T=376960 1001840 0 180 $X=372620 $Y=996420
X1896 216 1542 1702 2 69 1 1739 AN4B1S $T=374480 1011920 0 0 $X=374480 $Y=1011540
X1897 127 1242 227 2 228 1 1803 AN4B1S $T=378820 1011920 1 0 $X=378820 $Y=1006500
X1898 1702 1242 1599 2 220 1 1808 AN4B1S $T=383780 1042160 1 180 $X=379440 $Y=1041780
X1899 207 1599 1260 2 1796 1 1805 AN4B1S $T=380680 1052240 1 0 $X=380680 $Y=1046820
X1900 1802 1609 98 2 1823 1 1784 AN4B1S $T=381920 1011920 0 0 $X=381920 $Y=1011540
X1901 234 1802 1761 2 1847 1 1783 AN4B1S $T=388740 1052240 1 0 $X=388740 $Y=1046820
X1902 1911 1916 1918 2 269 1 1910 AN4B1S $T=416020 1052240 1 0 $X=416020 $Y=1046820
X1903 297 268 286 2 260 1 1957 AN4B1S $T=429040 1042160 1 180 $X=424700 $Y=1041780
X1904 1947 1963 1962 2 1971 1 1983 AN4B1S $T=427180 1022000 1 0 $X=427180 $Y=1016580
X1905 1967 1908 1982 2 1988 1 310 AN4B1S $T=431520 1011920 0 0 $X=431520 $Y=1011540
X1906 1918 1999 289 2 1990 1 1968 AN4B1S $T=437100 1042160 1 180 $X=432760 $Y=1041780
X1907 2011 312 307 2 1997 1 306 AN4B1S $T=438340 880880 1 180 $X=434000 $Y=880500
X1908 297 1999 308 2 2001 1 1956 AN4B1S $T=434000 1042160 1 0 $X=434000 $Y=1036740
X1909 317 272 300 2 1992 1 2005 AN4B1S $T=439580 921200 1 180 $X=435240 $Y=920820
X1910 1985 2018 2029 2 281 1 2030 AN4B1S $T=440820 1022000 1 0 $X=440820 $Y=1016580
X1911 329 308 1939 2 2039 1 1933 AN4B1S $T=442060 991760 1 0 $X=442060 $Y=986340
X1912 322 1999 1985 2 335 1 2028 AN4B1S $T=442060 1042160 0 0 $X=442060 $Y=1041780
X1913 330 287 2055 2 340 1 2061 AN4B1S $T=445160 1052240 1 0 $X=445160 $Y=1046820
X1914 2075 1984 2064 2 2034 1 2052 AN4B1S $T=451980 1032080 1 180 $X=447640 $Y=1031700
X1915 2099 2080 2016 2 2070 1 2065 AN4B1S $T=453840 991760 0 180 $X=449500 $Y=986340
X1916 2066 2081 2074 2 2087 1 2099 AN4B1S $T=451360 1001840 0 0 $X=451360 $Y=1001460
X1917 2062 353 2084 2 2012 1 2106 AN4B1S $T=451360 1052240 0 0 $X=451360 $Y=1051860
X1918 2103 359 2089 2 2069 1 2046 AN4B1S $T=456940 911120 0 180 $X=452600 $Y=905700
X1919 2107 2068 2096 2 2041 1 2095 AN4B1S $T=458180 911120 1 180 $X=453840 $Y=910740
X1920 2148 2123 2122 2 2121 1 2124 AN4B1S $T=463760 931280 1 180 $X=459420 $Y=930900
X1921 380 381 379 2 377 1 2103 AN4B1S $T=464380 911120 0 180 $X=460040 $Y=905700
X1922 344 2049 342 2 2104 1 2142 AN4B1S $T=466860 901040 0 180 $X=462520 $Y=895620
X1923 2124 2138 2143 2 2145 1 392 AN4B1S $T=462520 901040 0 0 $X=462520 $Y=900660
X1924 2100 2149 2127 2 2093 1 2036 AN4B1S $T=467480 1032080 0 180 $X=463140 $Y=1026660
X1925 315 2134 2129 2 367 1 2152 AN4B1S $T=468720 981680 1 180 $X=464380 $Y=981300
X1926 2163 289 2154 2 1974 1 2112 AN4B1S $T=468720 1011920 0 180 $X=464380 $Y=1006500
X1927 390 316 2156 2 1989 1 2192 AN4B1S $T=466240 1001840 1 0 $X=466240 $Y=996420
X1928 273 2177 395 2 340 1 2169 AN4B1S $T=471820 1052240 0 180 $X=467480 $Y=1046820
X1929 2204 2182 2157 2 2172 1 2107 AN4B1S $T=472440 911120 1 180 $X=468100 $Y=910740
X1930 318 399 2184 2 339 1 2160 AN4B1S $T=473680 921200 1 180 $X=469340 $Y=920820
X1931 2180 2176 2193 2 404 1 2217 AN4B1S $T=471820 1001840 0 0 $X=471820 $Y=1001460
X1932 352 2100 1918 2 270 1 2223 AN4B1S $T=473680 1032080 0 0 $X=473680 $Y=1031700
X1933 2222 2213 1928 2 2053 1 2199 AN4B1S $T=478640 991760 0 180 $X=474300 $Y=986340
X1934 2220 414 415 2 2230 1 420 AN4B1S $T=478020 890960 1 0 $X=478020 $Y=885540
X1935 2085 274 2158 2 2198 1 2222 AN4B1S $T=482360 991760 1 180 $X=478020 $Y=991380
X1936 2217 2214 2236 2 2237 1 2254 AN4B1S $T=479880 1011920 1 0 $X=479880 $Y=1006500
X1937 2025 2243 2031 2 429 1 2262 AN4B1S $T=482980 931280 0 0 $X=482980 $Y=930900
X1938 2002 432 433 2 1995 1 2275 AN4B1S $T=485460 1022000 0 0 $X=485460 $Y=1021620
X1939 2149 287 329 2 2270 1 2232 AN4B1S $T=485460 1032080 1 0 $X=485460 $Y=1026660
X1940 361 432 287 2 2274 1 2266 AN4B1S $T=486700 1001840 0 0 $X=486700 $Y=1001460
X1941 419 449 448 2 2059 1 2284 AN4B1S $T=497860 890960 1 180 $X=493520 $Y=890580
X1942 2290 2307 2300 2 2208 1 2320 AN4B1S $T=496620 971600 1 0 $X=496620 $Y=966180
X1943 427 458 2083 2 2283 1 456 AN4B1S $T=502820 911120 1 180 $X=498480 $Y=910740
X1944 273 349 2127 2 293 1 2336 AN4B1S $T=498480 1052240 1 0 $X=498480 $Y=1046820
X1945 2340 342 318 2 2292 1 2313 AN4B1S $T=503440 901040 1 180 $X=499100 $Y=900660
X1946 2341 2345 2346 2 2288 1 2337 AN4B1S $T=504680 931280 0 0 $X=504680 $Y=930900
X1947 2371 2280 2356 2 2343 1 2314 AN4B1S $T=510880 911120 0 180 $X=506540 $Y=905700
X1948 2239 2366 474 2 2328 1 2385 AN4B1S $T=509020 1001840 0 0 $X=509020 $Y=1001460
X1949 273 329 2291 2 383 1 2393 AN4B1S $T=510260 1052240 0 0 $X=510260 $Y=1051860
X1950 2280 2340 2126 2 2023 1 2395 AN4B1S $T=512740 911120 0 0 $X=512740 $Y=910740
X1951 2293 1987 455 2 2391 1 2398 AN4B1S $T=513360 911120 1 0 $X=513360 $Y=905700
X1952 2413 441 399 2 347 1 2360 AN4B1S $T=518940 931280 0 180 $X=514600 $Y=925860
X1953 2407 2396 2257 2 2324 1 480 AN4B1S $T=518940 931280 1 180 $X=514600 $Y=930900
X1954 2413 2350 2212 2 2378 1 2354 AN4B1S $T=519560 941360 0 180 $X=515220 $Y=935940
X1955 2293 2057 2126 2 2207 1 2423 AN4B1S $T=516460 890960 0 0 $X=516460 $Y=890580
X1956 2383 2402 2406 2 2411 1 2436 AN4B1S $T=516460 1032080 0 0 $X=516460 $Y=1031700
X1957 2440 2049 2409 2 443 1 2186 AN4B1S $T=521420 901040 0 180 $X=517080 $Y=895620
X1958 2287 2097 2460 2 2466 1 2463 AN4B1S $T=527620 1022000 0 0 $X=527620 $Y=1021620
X1959 2474 2467 2357 2 2427 1 500 AN4B1S $T=532580 931280 1 180 $X=528240 $Y=930900
X1960 2191 2478 508 2 2355 1 2502 AN4B1S $T=530720 961520 0 0 $X=530720 $Y=961140
X1961 2356 441 449 2 416 1 2484 AN4B1S $T=536920 941360 0 180 $X=532580 $Y=935940
X1962 2487 2485 2349 2 2498 1 2504 AN4B1S $T=535060 961520 1 0 $X=535060 $Y=956100
X1963 337 441 2025 2 2501 1 2438 AN4B1S $T=535680 931280 0 0 $X=535680 $Y=930900
X1964 2399 518 2356 2 369 1 2317 AN4B1S $T=540640 941360 1 180 $X=536300 $Y=940980
X1965 514 2361 2506 2 2513 1 2537 AN4B1S $T=536920 1052240 0 0 $X=536920 $Y=1051860
X1966 2532 2503 2388 2 2512 1 2496 AN4B1S $T=542500 1022000 1 180 $X=538160 $Y=1021620
X1967 2049 2332 2519 2 407 1 2538 AN4B1S $T=538780 901040 1 0 $X=538780 $Y=895620
X1968 534 2544 2488 2 2429 1 2545 AN4B1S $T=548700 1052240 1 180 $X=544360 $Y=1051860
X1969 2573 342 2188 2 2391 1 532 AN4B1S $T=551180 911120 0 180 $X=546840 $Y=905700
X1970 2473 2555 2566 2 2570 1 2574 AN4B1S $T=547460 1011920 0 0 $X=547460 $Y=1011540
X1971 2595 2588 2500 2 2586 1 2580 AN4B1S $T=556760 1032080 1 180 $X=552420 $Y=1031700
X1972 2293 318 2602 2 521 1 551 AN4B1S $T=556760 890960 1 0 $X=556760 $Y=885540
X1973 334 542 2212 2 2159 1 2600 AN4B1S $T=562960 911120 0 180 $X=558620 $Y=905700
X1974 2618 530 2624 2 2627 1 2494 AN4B1S $T=562340 951440 0 0 $X=562340 $Y=951060
X1975 2543 415 449 2 494 1 2639 AN4B1S $T=562960 890960 1 0 $X=562960 $Y=885540
X1976 2057 2371 542 2 2568 1 2637 AN4B1S $T=562960 931280 1 0 $X=562960 $Y=925860
X1977 313 542 477 2 2343 1 2626 AN4B1S $T=568540 901040 1 180 $X=564200 $Y=900660
X1978 2560 2522 303 2 369 1 2628 AN4B1S $T=569780 921200 0 180 $X=565440 $Y=915780
X1979 2477 530 2509 2 2620 1 568 AN4B1S $T=566060 951440 1 0 $X=566060 $Y=946020
X1980 318 2445 565 2 521 1 564 AN4B1S $T=567300 880880 0 0 $X=567300 $Y=880500
X1981 2573 437 453 2 2241 1 2631 AN4B1S $T=572260 921200 1 180 $X=567920 $Y=920820
X1982 2667 2526 568 2 2627 1 2264 AN4B1S $T=574120 951440 1 180 $X=569780 $Y=951060
X1983 2673 2505 2658 2 2655 1 2648 AN4B1S $T=575360 991760 0 180 $X=571020 $Y=986340
X1984 317 2663 337 2 2582 1 2664 AN4B1S $T=572880 931280 0 0 $X=572880 $Y=930900
X1985 2669 2646 2679 2 2683 1 588 AN4B1S $T=576600 921200 1 0 $X=576600 $Y=915780
X1986 2663 415 2409 2 2207 1 580 AN4B1S $T=582800 890960 0 180 $X=578460 $Y=885540
X1987 2672 2678 2692 2 2686 1 2701 AN4B1S $T=579080 1032080 1 0 $X=579080 $Y=1026660
X1988 2594 2710 2700 2 2698 1 2704 AN4B1S $T=589000 1001840 0 180 $X=584660 $Y=996420
X1989 2713 2520 2696 2 2715 1 2734 AN4B1S $T=587760 971600 1 0 $X=587760 $Y=966180
X1990 2634 591 2717 2 2716 1 598 AN4B1S $T=587760 1011920 1 0 $X=587760 $Y=1006500
X1991 2643 458 2409 2 581 1 2723 AN4B1S $T=588380 901040 1 0 $X=588380 $Y=895620
X1992 2594 2514 2729 2 2716 1 2728 AN4B1S $T=591480 981680 0 0 $X=591480 $Y=981300
X1993 2597 2725 2733 2 2738 1 2753 AN4B1S $T=592720 1022000 0 0 $X=592720 $Y=1021620
X1994 2754 2621 2742 2 2722 1 2736 AN4B1S $T=598920 991760 0 180 $X=594580 $Y=986340
X1995 2748 2767 2759 2 612 1 2780 AN4B1S $T=600780 1052240 0 0 $X=600780 $Y=1051860
X1996 2634 2779 2681 2 2788 1 2783 AN4B1S $T=604500 1011920 1 0 $X=604500 $Y=1006500
X1997 2783 2789 2535 2 2738 1 2798 AN4B1S $T=605740 1032080 1 0 $X=605740 $Y=1026660
X1998 2820 2681 2823 2 2551 1 2822 AN4B1S $T=618760 1022000 1 0 $X=618760 $Y=1016580
X1999 2605 2830 2821 2 2788 1 2851 AN4B1S $T=623720 981680 1 0 $X=623720 $Y=976260
X2000 2833 628 2789 2 2797 1 2842 AN4B1S $T=628060 1022000 1 180 $X=623720 $Y=1021620
X2001 2690 2820 2849 2 2680 1 2866 AN4B1S $T=630540 1032080 1 0 $X=630540 $Y=1026660
X2002 2845 2865 2712 2 2511 1 2876 AN4B1S $T=631160 991760 0 0 $X=631160 $Y=991380
X2003 2862 2849 2857 2 635 1 636 AN4B1S $T=631780 1052240 0 0 $X=631780 $Y=1051860
X2004 2862 2461 2640 2 2814 1 2936 AN4B1S $T=641700 1042160 1 0 $X=641700 $Y=1036740
X2005 2821 2640 2845 2 2894 1 2914 AN4B1S $T=644180 1001840 1 0 $X=644180 $Y=996420
X2006 3070 3060 3030 2 3011 1 3057 AN4B1S $T=702460 941360 1 180 $X=698120 $Y=940980
X2007 3100 3089 3029 2 3004 1 3069 AN4B1S $T=708040 961520 1 180 $X=703700 $Y=961140
X2008 3108 3092 3073 2 3040 1 3080 AN4B1S $T=709900 971600 1 180 $X=705560 $Y=971220
X2009 3128 3093 3113 2 3050 1 3105 AN4B1S $T=714860 951440 0 180 $X=710520 $Y=946020
X2010 3152 3136 3114 2 3133 1 3125 AN4B1S $T=720440 921200 1 180 $X=716100 $Y=920820
X2011 3159 3144 3044 2 2991 1 3137 AN4B1S $T=721680 961520 0 180 $X=717340 $Y=956100
X2012 3160 3146 3082 2 3081 1 3145 AN4B1S $T=722300 971600 1 180 $X=717960 $Y=971220
X2013 3175 3116 3158 2 3102 1 3150 AN4B1S $T=725400 931280 0 180 $X=721060 $Y=925860
X2014 3210 3184 3197 2 3006 1 3179 AN4B1S $T=734080 931280 0 180 $X=729740 $Y=925860
X2015 3265 3262 3253 2 3115 1 3245 AN4B1S $T=750200 911120 1 180 $X=745860 $Y=910740
X2016 3306 3281 3290 2 3318 1 3321 AN4B1S $T=761980 971600 1 0 $X=761980 $Y=966180
X2017 3358 3361 3370 2 3350 1 3386 AN4B1S $T=776860 971600 1 0 $X=776860 $Y=966180
X2018 3376 3369 3322 2 3391 1 3395 AN4B1S $T=779960 921200 0 0 $X=779960 $Y=920820
X2019 3425 3415 3400 2 3412 1 775 AN4B1S $T=790500 921200 1 180 $X=786160 $Y=920820
X2020 3434 3431 3430 2 3408 1 3424 AN4B1S $T=794840 971600 0 180 $X=790500 $Y=966180
X2021 3509 3463 3499 2 3487 1 3498 AN4B1S $T=813440 941360 1 180 $X=809100 $Y=940980
X2022 3489 3475 3485 2 3506 1 3504 AN4B1S $T=809720 961520 1 0 $X=809720 $Y=956100
X2023 3675 3670 3605 2 3650 1 851 AN4B1S $T=858700 941360 0 180 $X=854360 $Y=935940
X2024 3682 3659 3632 2 3666 1 860 AN4B1S $T=860560 941360 1 180 $X=856220 $Y=940980
X2025 3706 3692 3688 2 3673 1 863 AN4B1S $T=864280 911120 0 180 $X=859940 $Y=905700
X2026 3690 3701 3681 2 3685 1 870 AN4B1S $T=863040 890960 0 0 $X=863040 $Y=890580
X2027 3759 3756 3764 2 3766 1 884 AN4B1S $T=883500 941360 1 0 $X=883500 $Y=935940
X2028 3803 3776 3784 2 3774 1 887 AN4B1S $T=894040 901040 1 180 $X=889700 $Y=900660
X2029 3825 3819 3818 2 3800 1 892 AN4B1S $T=905820 941360 0 180 $X=901480 $Y=935940
X2030 3842 3848 3850 2 3853 1 900 AN4B1S $T=908920 941360 1 0 $X=908920 $Y=935940
X2031 3884 3887 3888 2 3875 1 915 AN4B1S $T=925040 941360 1 0 $X=925040 $Y=935940
X2032 3919 3914 3910 2 3894 1 914 AN4B1S $T=934340 911120 1 180 $X=930000 $Y=910740
X2033 3961 3970 3974 2 3977 1 3570 AN4B1S $T=951080 941360 1 0 $X=951080 $Y=935940
X2034 3973 3981 3962 2 3986 1 3980 AN4B1S $T=952940 911120 0 0 $X=952940 $Y=910740
X2035 3966 3984 3988 2 3990 1 3939 AN4B1S $T=954180 890960 1 0 $X=954180 $Y=885540
X2036 3967 3994 3999 2 4005 1 3948 AN4B1S $T=957280 901040 1 0 $X=957280 $Y=895620
X2037 3987 4038 4039 2 4043 1 3646 AN4B1S $T=965960 931280 0 0 $X=965960 $Y=930900
X2038 4081 4091 4088 2 4083 1 3269 AN4B1S $T=985180 941360 0 180 $X=980840 $Y=935940
X2039 4143 4129 4157 2 4163 1 4161 AN4B1S $T=1001300 901040 1 0 $X=1001300 $Y=895620
X2040 4162 4149 4168 2 4171 1 3383 AN4B1S $T=1003780 941360 0 0 $X=1003780 $Y=940980
X2041 4187 4183 4182 2 4180 1 3641 AN4B1S $T=1011840 941360 0 180 $X=1007500 $Y=935940
X2042 4238 4224 4229 2 4227 1 4148 AN4B1S $T=1026720 890960 1 180 $X=1022380 $Y=890580
X2043 4291 4280 4279 2 4278 1 988 AN4B1S $T=1047180 890960 0 180 $X=1042840 $Y=885540
X2044 4296 4305 4275 2 4301 1 3580 AN4B1S $T=1054620 931280 1 180 $X=1050280 $Y=930900
X2045 4332 4329 4325 2 4321 1 4326 AN4B1S $T=1060200 931280 0 180 $X=1055860 $Y=925860
X2046 4358 4319 4349 2 4345 1 4310 AN4B1S $T=1067640 931280 0 180 $X=1063300 $Y=925860
X2047 4377 4318 4356 2 4352 1 4261 AN4B1S $T=1068880 890960 1 180 $X=1064540 $Y=890580
X2048 1112 1091 1078 1063 8 1085 1 2 1072 OA222 $T=236220 991760 1 180 $X=230640 $Y=991380
X2049 1077 1076 1088 1022 10 12 1 2 1113 OA222 $T=230640 1022000 1 0 $X=230640 $Y=1016580
X2050 1047 1054 1078 1068 1116 1122 1 2 1145 OA222 $T=234980 961520 1 0 $X=234980 $Y=956100
X2051 1095 1068 1101 1045 1115 1135 1 2 1152 OA222 $T=238700 1001840 0 0 $X=238700 $Y=1001460
X2052 1077 1129 1177 39 1081 1024 1 2 1179 OA222 $T=254820 1011920 1 180 $X=249240 $Y=1011540
X2053 1211 1071 1215 1149 34 8 1 2 1239 OA222 $T=254820 991760 0 0 $X=254820 $Y=991380
X2054 1071 48 1215 1221 1157 1129 1 2 1252 OA222 $T=256060 1011920 1 0 $X=256060 $Y=1006500
X2055 66 62 1116 1272 8 56 1 2 1257 OA222 $T=268460 1052240 0 180 $X=262880 $Y=1046820
X2056 1326 1263 1112 1129 1285 50 1 2 1275 OA222 $T=271560 971600 0 180 $X=265980 $Y=966180
X2057 1298 1311 1122 1268 1041 1332 1 2 1334 OA222 $T=270940 991760 1 0 $X=270940 $Y=986340
X2058 1281 1350 1081 1066 1078 1187 1 2 1290 OA222 $T=281480 961520 0 180 $X=275900 $Y=956100
X2059 1105 1101 1177 85 1281 1351 1 2 1294 OA222 $T=282720 1032080 0 180 $X=277140 $Y=1026660
X2060 1041 1101 1095 1066 1078 1024 1 2 1399 OA222 $T=281480 961520 0 0 $X=281480 $Y=961140
X2061 1024 1094 1386 1326 1379 1266 1 2 1418 OA222 $T=285200 951440 1 0 $X=285200 $Y=946020
X2062 10 101 1105 1035 8 1395 1 2 1387 OA222 $T=290780 1042160 0 180 $X=285200 $Y=1036740
X2063 1386 1266 1094 1289 1405 1400 1 2 1389 OA222 $T=292020 971600 1 180 $X=286440 $Y=971220
X2064 107 1424 8 103 1047 1385 1 2 1401 OA222 $T=293260 1032080 1 180 $X=287680 $Y=1031700
X2065 1326 1320 1285 105 1372 1281 1 2 1383 OA222 $T=288920 951440 0 0 $X=288920 $Y=951060
X2066 1293 1281 1379 1326 1041 1101 1 2 1464 OA222 $T=293880 951440 1 0 $X=293880 $Y=946020
X2067 1484 1101 1081 1209 1350 1326 1 2 1457 OA222 $T=303800 951440 1 180 $X=298220 $Y=951060
X2068 1339 8 1105 1101 34 1285 1 2 1458 OA222 $T=303800 971600 0 180 $X=298220 $Y=966180
X2069 8 118 37 119 1285 1483 1 2 1508 OA222 $T=298220 1052240 1 0 $X=298220 $Y=1046820
X2070 1371 1326 1285 91 1105 1465 1 2 1466 OA222 $T=304420 961520 1 180 $X=298840 $Y=961140
X2071 8 93 1491 107 1321 18 1 2 1365 OA222 $T=305660 981680 1 180 $X=300080 $Y=981300
X2072 1047 1160 1071 1485 18 1438 1 2 1495 OA222 $T=300080 1032080 1 0 $X=300080 $Y=1026660
X2073 1094 1311 1326 1511 1266 1497 1 2 1530 OA222 $T=305660 931280 0 0 $X=305660 $Y=930900
X2074 1510 135 10 133 1209 1403 1 2 1504 OA222 $T=312480 1022000 0 180 $X=306900 $Y=1016580
X2075 1529 1281 1209 1515 1105 1516 1 2 1505 OA222 $T=313100 951440 1 180 $X=307520 $Y=951060
X2076 8 36 1071 1451 1285 1456 1 2 1512 OA222 $T=313720 1032080 1 180 $X=308140 $Y=1031700
X2077 1105 1097 18 1507 107 1533 1 2 1540 OA222 $T=308140 1042160 1 0 $X=308140 $Y=1036740
X2078 1405 1409 1177 1331 1281 1441 1 2 1546 OA222 $T=309380 991760 1 0 $X=309380 $Y=986340
X2079 1405 1539 1116 1536 1510 1531 1 2 1503 OA222 $T=315580 1011920 0 180 $X=310000 $Y=1006500
X2080 1339 8 1350 1266 1077 1094 1 2 1567 OA222 $T=312480 971600 1 0 $X=312480 $Y=966180
X2081 1115 1187 1266 1441 107 1542 1 2 1532 OA222 $T=318680 971600 1 180 $X=313100 $Y=971220
X2082 18 36 1081 1291 107 1451 1 2 1590 OA222 $T=319300 1022000 1 0 $X=319300 $Y=1016580
X2083 1211 1405 1024 1273 1599 1510 1 2 1565 OA222 $T=330460 991760 1 180 $X=324880 $Y=991380
X2084 37 167 1116 1589 1071 1602 1 2 1563 OA222 $T=331080 1032080 0 180 $X=325500 $Y=1026660
X2085 1281 1625 1177 1628 1211 1635 1 2 1633 OA222 $T=331080 1001840 1 0 $X=331080 $Y=996420
X2086 1115 1066 1047 1465 1405 1642 1 2 1639 OA222 $T=332940 981680 1 0 $X=332940 $Y=976260
X2087 1510 1646 1115 1638 10 1622 1 2 1559 OA222 $T=339140 991760 0 180 $X=333560 $Y=986340
X2088 175 1652 18 180 1405 1600 1 2 1667 OA222 $T=337280 1042160 1 0 $X=337280 $Y=1036740
X2089 1081 1041 1575 1690 107 1697 1 2 1700 OA222 $T=345960 1001840 0 0 $X=345960 $Y=1001460
X2090 1061 1068 1405 1718 162 1713 1 2 199 OA222 $T=358360 1022000 0 180 $X=352780 $Y=1016580
X2091 1669 1584 8 1727 1311 1694 1 2 1754 OA222 $T=357740 961520 1 0 $X=357740 $Y=956100
X2092 1061 1291 1510 1739 1071 209 1 2 1746 OA222 $T=357740 1011920 0 0 $X=357740 $Y=1011540
X2093 1405 1757 108 1592 1510 1751 1 2 1048 OA222 $T=367040 1052240 0 180 $X=361460 $Y=1046820
X2094 1321 162 1071 1803 1298 66 1 2 1678 OA222 $T=380060 991760 0 180 $X=374480 $Y=986340
X2095 261 1928 1930 1935 1937 277 1 2 1947 OA222 $T=417880 1022000 0 0 $X=417880 $Y=1021620
X2096 1919 1950 285 1956 1958 1957 1 2 1963 OA222 $T=424080 1042160 1 0 $X=424080 $Y=1036740
X2097 1913 288 1958 291 1919 1968 1 2 1984 OA222 $T=425320 1052240 1 0 $X=425320 $Y=1046820
X2098 2004 1939 1977 1975 1972 1970 1 2 1944 OA222 $T=434000 991760 0 180 $X=428420 $Y=986340
X2099 1937 1985 1958 1978 1930 1973 1 2 1967 OA222 $T=434620 1022000 1 180 $X=429040 $Y=1021620
X2100 1869 2046 336 333 332 2031 1 2 2011 OA222 $T=447020 880880 1 180 $X=441440 $Y=880500
X2101 1972 358 274 2067 1930 2009 1 2 2075 OA222 $T=456320 1032080 0 180 $X=450740 $Y=1026660
X2102 1952 2102 1919 2109 1930 2112 1 2 2114 OA222 $T=455080 1011920 1 0 $X=455080 $Y=1006500
X2103 2139 2047 2072 2003 2129 2135 1 2 2118 OA222 $T=466860 951440 1 180 $X=461280 $Y=951060
X2104 341 2184 2203 2195 363 2189 1 2 2179 OA222 $T=476780 941360 0 180 $X=471200 $Y=935940
X2105 1930 2232 285 2225 1919 2223 1 2 2214 OA222 $T=482360 1022000 1 180 $X=476780 $Y=1021620
X2106 2224 2199 2264 2268 2261 2029 1 2 2290 OA222 $T=485460 971600 0 0 $X=485460 $Y=971220
X2107 393 2272 389 2279 385 2284 1 2 2215 OA222 $T=487940 911120 1 0 $X=487940 $Y=905700
X2108 460 2298 1952 2309 2004 2229 1 2 2300 OA222 $T=501580 971600 1 180 $X=496000 $Y=971220
X2109 385 2313 384 2319 389 2314 1 2 2138 OA222 $T=503440 911120 0 180 $X=497860 $Y=905700
X2110 453 2089 385 2325 364 2332 1 2 2341 OA222 $T=499100 931280 1 0 $X=499100 $Y=925860
X2111 459 349 462 2336 465 2251 1 2 2361 OA222 $T=500960 1052240 0 0 $X=500960 $Y=1051860
X2112 389 2305 384 2360 351 2354 1 2 2345 OA222 $T=512120 941360 0 180 $X=506540 $Y=935940
X2113 478 2385 2394 2192 2097 483 1 2 2402 OA222 $T=513980 1001840 1 0 $X=513980 $Y=996420
X2114 364 2025 351 2426 385 2441 1 2 2407 OA222 $T=520180 931280 1 0 $X=520180 $Y=925860
X2115 363 2445 381 2449 385 2454 1 2 2474 OA222 $T=523900 941360 0 0 $X=523900 $Y=940980
X2116 499 2463 504 2219 489 2393 1 2 2488 OA222 $T=528240 1052240 0 0 $X=528240 $Y=1051860
X2117 505 2057 506 2423 509 2482 1 2 512 OA222 $T=530100 890960 0 0 $X=530100 $Y=890580
X2118 2465 289 2493 2494 2394 308 1 2 2520 OA222 $T=534440 991760 1 0 $X=534440 $Y=986340
X2119 499 266 462 2051 2097 504 1 2 2536 OA222 $T=534440 1042160 0 0 $X=534440 $Y=1041780
X2120 505 2538 472 2531 509 2479 1 2 520 OA222 $T=544980 890960 1 180 $X=539400 $Y=890580
X2121 525 2539 2465 2386 2394 2197 1 2 2505 OA222 $T=544980 991760 1 180 $X=539400 $Y=991380
X2122 438 2554 351 2541 389 2484 1 2 2467 OA222 $T=547460 941360 0 180 $X=541880 $Y=935940
X2123 525 2556 478 322 527 2565 1 2 2567 OA222 $T=544360 1022000 0 0 $X=544360 $Y=1021620
X2124 544 2480 478 417 529 2557 1 2 2544 OA222 $T=549940 1052240 0 180 $X=544360 $Y=1046820
X2125 2569 2365 2233 2577 2234 2583 1 2 2307 OA222 $T=549320 951440 0 0 $X=549320 $Y=951060
X2126 2564 508 266 2468 526 530 1 2 2584 OA222 $T=549320 991760 0 0 $X=549320 $Y=991380
X2127 545 2569 529 2509 541 525 1 2 2506 OA222 $T=557380 1052240 1 180 $X=551800 $Y=1051860
X2128 2548 525 526 2590 2478 1972 1 2 2605 OA222 $T=553040 991760 1 0 $X=553040 $Y=986340
X2129 2585 545 305 2468 2253 2431 1 2 2612 OA222 $T=554900 981680 1 0 $X=554900 $Y=976260
X2130 544 2569 2585 546 2622 1913 1 2 2634 OA222 $T=559860 1011920 1 0 $X=559860 $Y=1006500
X2131 527 2493 459 2269 529 2548 1 2 2687 OA222 $T=559860 1022000 1 0 $X=559860 $Y=1016580
X2132 541 2629 530 537 2564 2563 1 2 2619 OA222 $T=567300 981680 1 180 $X=561720 $Y=981300
X2133 474 459 305 489 2622 1913 1 2 2640 OA222 $T=562340 1011920 0 0 $X=562340 $Y=1011540
X2134 384 2626 373 2600 381 2628 1 2 557 OA222 $T=571020 911120 1 180 $X=565440 $Y=910740
X2135 384 2631 381 2642 373 2665 1 2 575 OA222 $T=570400 941360 0 0 $X=570400 $Y=940980
X2136 2633 533 465 2419 529 2652 1 2 2678 OA222 $T=570400 1032080 0 0 $X=570400 $Y=1031700
X2137 384 2668 373 2664 381 2637 1 2 566 OA222 $T=577220 941360 0 180 $X=571640 $Y=935940
X2138 1930 2622 529 541 545 2549 1 2 2681 OA222 $T=571640 1011920 0 0 $X=571640 $Y=1011540
X2139 533 2590 544 2569 590 2509 1 2 587 OA222 $T=589000 1052240 0 180 $X=583420 $Y=1046820
X2140 2613 2744 545 2752 508 2757 1 2 2767 OA222 $T=595820 961520 1 0 $X=595820 $Y=956100
X2141 2585 533 527 2565 2572 2745 1 2 2739 OA222 $T=601400 1011920 0 180 $X=595820 $Y=1006500
X2142 550 2601 525 463 2526 2629 1 2 2835 OA222 $T=614420 981680 1 0 $X=614420 $Y=976260
X2143 1034 2 1063 1027 1 NR2 $T=223820 991760 1 180 $X=221960 $Y=991380
X2144 1027 2 1045 1032 1 NR2 $T=221960 1001840 0 0 $X=221960 $Y=1001460
X2145 1023 2 1028 1042 1 NR2 $T=222580 971600 0 0 $X=222580 $Y=971220
X2146 1032 2 1030 1031 1 NR2 $T=223200 941360 1 0 $X=223200 $Y=935940
X2147 1033 2 1054 1042 1 NR2 $T=223820 961520 1 0 $X=223820 $Y=956100
X2148 1069 2 1049 1042 1 NR2 $T=226920 991760 0 180 $X=225060 $Y=986340
X2149 1074 2 1022 1050 1 NR2 $T=227540 1001840 0 180 $X=225680 $Y=996420
X2150 1058 2 1062 1034 1 NR2 $T=228160 941360 1 180 $X=226300 $Y=940980
X2151 3 2 11 7 1 NR2 $T=227540 880880 0 0 $X=227540 $Y=880500
X2152 1037 2 1060 1069 1 NR2 $T=227540 1001840 0 0 $X=227540 $Y=1001460
X2153 1050 2 1098 1042 1 NR2 $T=229400 931280 1 0 $X=229400 $Y=925860
X2154 1083 2 1076 1070 1 NR2 $T=231260 1011920 1 180 $X=229400 $Y=1011540
X2155 1058 2 1087 1032 1 NR2 $T=230020 931280 0 0 $X=230020 $Y=930900
X2156 1034 2 1088 1109 1 NR2 $T=233740 1022000 0 0 $X=233740 $Y=1021620
X2157 13 2 21 24 1 NR2 $T=235600 880880 0 0 $X=235600 $Y=880500
X2158 19 2 1110 15 1 NR2 $T=238080 1052240 0 180 $X=236220 $Y=1046820
X2159 1042 2 1129 1073 1 NR2 $T=237460 951440 0 0 $X=237460 $Y=951060
X2160 1154 2 1147 1124 1 NR2 $T=241800 1032080 0 180 $X=239940 $Y=1026660
X2161 26 2 1085 19 1 NR2 $T=242420 1022000 0 180 $X=240560 $Y=1016580
X2162 1109 2 1135 1058 1 NR2 $T=241800 991760 1 0 $X=241800 $Y=986340
X2163 1023 2 1149 1108 1 NR2 $T=243040 961520 1 0 $X=243040 $Y=956100
X2164 1073 2 1092 1083 1 NR2 $T=243660 1011920 0 0 $X=243660 $Y=1011540
X2165 1141 2 1156 1168 1 NR2 $T=244900 951440 1 0 $X=244900 $Y=946020
X2166 1074 2 1160 1083 1 NR2 $T=245520 1011920 1 0 $X=245520 $Y=1006500
X2167 41 2 1131 1138 1 NR2 $T=250480 1052240 0 180 $X=248620 $Y=1046820
X2168 38 2 1171 26 1 NR2 $T=251720 1052240 1 180 $X=249860 $Y=1051860
X2169 1205 2 1157 1175 1 NR2 $T=252340 931280 1 180 $X=250480 $Y=930900
X2170 1109 2 1039 1198 1 NR2 $T=251100 1011920 1 0 $X=251100 $Y=1006500
X2171 1122 2 1176 1039 1 NR2 $T=253580 1001840 1 180 $X=251720 $Y=1001460
X2172 1172 2 1128 1210 1 NR2 $T=252960 1032080 1 0 $X=252960 $Y=1026660
X2173 1191 2 1230 1219 1 NR2 $T=255440 961520 0 0 $X=255440 $Y=961140
X2174 1205 2 1222 1193 1 NR2 $T=257300 931280 0 0 $X=257300 $Y=930900
X2175 1070 2 1221 1065 1 NR2 $T=259780 1011920 1 180 $X=257920 $Y=1011540
X2176 1102 2 1250 1034 1 NR2 $T=259780 941360 1 0 $X=259780 $Y=935940
X2177 1108 2 1273 1183 1 NR2 $T=261020 1001840 1 0 $X=261020 $Y=996420
X2178 1255 2 50 22 1 NR2 $T=264120 1022000 0 180 $X=262260 $Y=1016580
X2179 1058 2 1268 1027 1 NR2 $T=263500 991760 0 0 $X=263500 $Y=991380
X2180 1109 2 1291 1027 1 NR2 $T=266600 1011920 0 180 $X=264740 $Y=1006500
X2181 54 2 1292 1255 1 NR2 $T=264740 1022000 0 0 $X=264740 $Y=1021620
X2182 1193 2 1289 1102 1 NR2 $T=268460 971600 1 180 $X=266600 $Y=971220
X2183 1286 2 1232 1074 1 NR2 $T=270940 1001840 0 0 $X=270940 $Y=1001460
X2184 1266 2 1216 1320 1 NR2 $T=272800 951440 0 0 $X=272800 $Y=951060
X2185 1073 2 1332 1108 1 NR2 $T=276520 1011920 0 180 $X=274660 $Y=1006500
X2186 1303 2 1325 1358 1 NR2 $T=276520 911120 1 0 $X=276520 $Y=905700
X2187 1288 2 1344 1074 1 NR2 $T=276520 951440 0 0 $X=276520 $Y=951060
X2188 1348 2 81 1361 1 NR2 $T=277760 901040 1 0 $X=277760 $Y=895620
X2189 1303 2 1319 1362 1 NR2 $T=277760 921200 0 0 $X=277760 $Y=920820
X2190 1050 2 1385 1108 1 NR2 $T=282100 1011920 0 0 $X=282100 $Y=1011540
X2191 44 2 1340 1391 1 NR2 $T=283340 1001840 1 0 $X=283340 $Y=996420
X2192 1274 2 93 59 1 NR2 $T=283340 1001840 0 0 $X=283340 $Y=1001460
X2193 100 2 1381 26 1 NR2 $T=287060 1052240 1 180 $X=285200 $Y=1051860
X2194 1108 2 1403 1286 1 NR2 $T=285820 1011920 0 0 $X=285820 $Y=1011540
X2195 1420 2 1400 102 1 NR2 $T=291400 1011920 1 180 $X=289540 $Y=1011540
X2196 26 2 91 1391 1 NR2 $T=293260 1011920 0 0 $X=293260 $Y=1011540
X2197 1348 2 1282 1462 1 NR2 $T=293880 901040 1 0 $X=293880 $Y=895620
X2198 1373 2 1359 1431 1 NR2 $T=295120 921200 0 0 $X=295120 $Y=920820
X2199 102 2 1438 113 1 NR2 $T=295120 1032080 1 0 $X=295120 $Y=1026660
X2200 113 2 1456 26 1 NR2 $T=296980 1052240 1 180 $X=295120 $Y=1051860
X2201 41 2 1422 1463 1 NR2 $T=296360 1042160 0 0 $X=296360 $Y=1041780
X2202 1311 2 1262 1475 1 NR2 $T=298220 931280 1 0 $X=298220 $Y=925860
X2203 1296 2 1444 1475 1 NR2 $T=298840 941360 1 0 $X=298840 $Y=935940
X2204 1073 2 1482 1235 1 NR2 $T=303180 961520 0 180 $X=301320 $Y=956100
X2205 1402 2 90 126 1 NR2 $T=302560 890960 0 0 $X=302560 $Y=890580
X2206 1489 2 1272 1286 1 NR2 $T=305660 951440 1 0 $X=305660 $Y=946020
X2207 1524 2 1520 1496 1 NR2 $T=311240 991760 1 180 $X=309380 $Y=991380
X2208 70 2 1539 139 1 NR2 $T=311240 1042160 0 0 $X=311240 $Y=1041780
X2209 1286 2 1516 1083 1 NR2 $T=311860 951440 1 0 $X=311860 $Y=946020
X2210 1074 2 1465 1183 1 NR2 $T=314960 961520 0 0 $X=314960 $Y=961140
X2211 1073 2 1515 1074 1 NR2 $T=317440 951440 1 180 $X=315580 $Y=951060
X2212 43 2 1554 19 1 NR2 $T=316200 1042160 1 0 $X=316200 $Y=1036740
X2213 148 2 1348 151 1 NR2 $T=316820 890960 0 0 $X=316820 $Y=890580
X2214 144 2 1361 151 1 NR2 $T=317440 890960 1 0 $X=317440 $Y=885540
X2215 1552 2 1083 1564 1 NR2 $T=318060 941360 1 0 $X=318060 $Y=935940
X2216 100 2 1451 1578 1 NR2 $T=320540 1042160 1 0 $X=320540 $Y=1036740
X2217 1564 2 1362 1581 1 NR2 $T=321160 931280 0 0 $X=321160 $Y=930900
X2218 1552 2 1074 1586 1 NR2 $T=321780 941360 1 0 $X=321780 $Y=935940
X2219 1586 2 1303 1581 1 NR2 $T=324260 921200 1 180 $X=322400 $Y=920820
X2220 59 2 1331 1391 1 NR2 $T=324260 1011920 0 180 $X=322400 $Y=1006500
X2221 1183 2 1589 1042 1 NR2 $T=324880 1001840 0 180 $X=323020 $Y=996420
X2222 1552 2 1073 1597 1 NR2 $T=324880 931280 0 0 $X=324880 $Y=930900
X2223 1601 2 1183 1552 1 NR2 $T=327360 941360 0 180 $X=325500 $Y=935940
X2224 70 2 161 1391 1 NR2 $T=326120 1011920 1 0 $X=326120 $Y=1006500
X2225 1588 2 1604 1620 1 NR2 $T=327980 961520 0 0 $X=327980 $Y=961140
X2226 1626 2 135 1255 1 NR2 $T=332940 1022000 1 180 $X=331080 $Y=1021620
X2227 1391 2 1622 100 1 NR2 $T=331700 1001840 0 0 $X=331700 $Y=1001460
X2228 136 2 1635 1640 1 NR2 $T=332320 1042160 1 0 $X=332320 $Y=1036740
X2229 1629 2 1615 1475 1 NR2 $T=334800 931280 1 180 $X=332940 $Y=930900
X2230 1463 2 1498 100 1 NR2 $T=333560 1032080 0 0 $X=333560 $Y=1031700
X2231 1626 2 88 23 1 NR2 $T=334180 1032080 1 0 $X=334180 $Y=1026660
X2232 1641 2 1566 1653 1 NR2 $T=336660 931280 0 0 $X=336660 $Y=930900
X2233 1651 2 1638 1175 1 NR2 $T=339140 961520 1 180 $X=337280 $Y=961140
X2234 100 2 1602 182 1 NR2 $T=337280 1032080 0 0 $X=337280 $Y=1031700
X2235 1225 2 1643 1603 1 NR2 $T=339140 921200 1 0 $X=339140 $Y=915780
X2236 1684 2 1634 1611 1 NR2 $T=341620 911120 1 180 $X=339760 $Y=910740
X2237 5 2 1652 1153 1 NR2 $T=341620 1001840 0 180 $X=339760 $Y=996420
X2238 1581 2 1431 1669 1 NR2 $T=340380 931280 1 0 $X=340380 $Y=925860
X2239 188 2 169 1614 1 NR2 $T=344100 880880 1 180 $X=342240 $Y=880500
X2240 1616 2 1212 1475 1 NR2 $T=344100 931280 0 0 $X=344100 $Y=930900
X2241 1552 2 1286 1685 1 NR2 $T=344100 941360 0 0 $X=344100 $Y=940980
X2242 1597 2 1686 1475 1 NR2 $T=348440 961520 1 180 $X=346580 $Y=961140
X2243 1712 2 1485 186 1 NR2 $T=348440 1032080 0 180 $X=346580 $Y=1026660
X2244 1669 2 1555 1616 1 NR2 $T=347820 931280 1 0 $X=347820 $Y=925860
X2245 1417 2 196 1475 1 NR2 $T=351540 931280 1 0 $X=351540 $Y=925860
X2246 1560 2 1713 1420 1 NR2 $T=353400 991760 1 0 $X=353400 $Y=986340
X2247 153 2 1605 69 1 NR2 $T=353400 1011920 0 0 $X=353400 $Y=1011540
X2248 1198 2 1714 1651 1 NR2 $T=355880 971600 0 180 $X=354020 $Y=966180
X2249 1514 2 1715 1728 1 NR2 $T=354640 921200 1 0 $X=354640 $Y=915780
X2250 1163 2 1690 1640 1 NR2 $T=354640 1001840 0 0 $X=354640 $Y=1001460
X2251 203 2 1718 1730 1 NR2 $T=355260 1032080 1 0 $X=355260 $Y=1026660
X2252 1722 2 1719 1734 1 NR2 $T=357740 981680 0 0 $X=357740 $Y=981300
X2253 208 2 1558 172 1 NR2 $T=359600 880880 0 0 $X=359600 $Y=880500
X2254 1738 2 1773 1747 1 NR2 $T=361460 931280 0 0 $X=361460 $Y=930900
X2255 1671 2 1750 1475 1 NR2 $T=363320 941360 0 0 $X=363320 $Y=940980
X2256 1729 2 1768 1770 1 NR2 $T=365180 941360 1 0 $X=365180 $Y=935940
X2257 1726 2 1731 215 1 NR2 $T=365180 951440 0 0 $X=365180 $Y=951060
X2258 1645 2 1763 1619 1 NR2 $T=367040 931280 1 0 $X=367040 $Y=925860
X2259 1772 2 1751 1356 1 NR2 $T=368900 1042160 0 180 $X=367040 $Y=1036740
X2260 1679 2 1781 1163 1 NR2 $T=369520 1011920 0 180 $X=367660 $Y=1006500
X2261 1685 2 1774 1475 1 NR2 $T=369520 951440 1 0 $X=369520 $Y=946020
X2262 1778 2 1645 1745 1 NR2 $T=371380 931280 1 0 $X=371380 $Y=925860
X2263 1785 2 1623 223 1 NR2 $T=373240 951440 1 0 $X=373240 $Y=946020
X2264 1799 2 1663 1726 1 NR2 $T=375100 951440 1 180 $X=373240 $Y=951060
X2265 1796 2 1792 1772 1 NR2 $T=376340 1042160 0 180 $X=374480 $Y=1036740
X2266 1778 2 1225 1759 1 NR2 $T=375100 931280 1 0 $X=375100 $Y=925860
X2267 1807 2 1240 1776 1 NR2 $T=378200 1001840 1 180 $X=376340 $Y=1001460
X2268 1786 2 1743 211 1 NR2 $T=381300 971600 0 180 $X=379440 $Y=966180
X2269 1818 2 1542 19 1 NR2 $T=381920 1022000 0 180 $X=380060 $Y=1016580
X2270 1814 2 1649 229 1 NR2 $T=381920 951440 1 0 $X=381920 $Y=946020
X2271 1786 2 1749 1748 1 NR2 $T=381920 961520 0 0 $X=381920 $Y=961140
X2272 1816 2 1682 1726 1 NR2 $T=383160 951440 0 0 $X=383160 $Y=951060
X2273 1785 2 1822 1816 1 NR2 $T=386260 941360 0 180 $X=384400 $Y=935940
X2274 1626 2 1821 1730 1 NR2 $T=385020 1032080 1 0 $X=385020 $Y=1026660
X2275 1785 2 1664 1814 1 NR2 $T=387500 951440 0 180 $X=385640 $Y=946020
X2276 1669 2 1843 1475 1 NR2 $T=389360 961520 0 0 $X=389360 $Y=961140
X2277 215 2 1811 224 1 NR2 $T=391840 961520 1 0 $X=391840 $Y=956100
X2278 1831 2 1844 1616 1 NR2 $T=393700 981680 1 180 $X=391840 $Y=981300
X2279 1745 2 1852 1816 1 NR2 $T=394940 941360 0 180 $X=393080 $Y=935940
X2280 1867 2 1793 1708 1 NR2 $T=396180 941360 1 180 $X=394320 $Y=940980
X2281 243 2 1877 235 1 NR2 $T=398040 901040 0 180 $X=396180 $Y=895620
X2282 1745 2 1855 1813 1 NR2 $T=396800 971600 1 0 $X=396800 $Y=966180
X2283 1231 2 213 1712 1 NR2 $T=401140 1032080 0 180 $X=399280 $Y=1026660
X2284 1856 2 1802 1420 1 NR2 $T=399900 1011920 0 0 $X=399900 $Y=1011540
X2285 1867 2 1837 1813 1 NR2 $T=402380 971600 1 180 $X=400520 $Y=971220
X2286 223 2 1705 229 1 NR2 $T=403000 961520 0 180 $X=401140 $Y=956100
X2287 223 2 1846 224 1 NR2 $T=406720 941360 1 0 $X=406720 $Y=935940
X2288 1881 2 1806 1831 1 NR2 $T=406720 961520 0 0 $X=406720 $Y=961140
X2289 254 2 1869 257 1 NR2 $T=409200 880880 0 0 $X=409200 $Y=880500
X2290 1231 2 1878 69 1 NR2 $T=411060 1022000 1 180 $X=409200 $Y=1021620
X2291 1420 2 205 1818 1 NR2 $T=411680 1022000 0 180 $X=409820 $Y=1016580
X2292 1796 2 1889 1895 1 NR2 $T=409820 1042160 1 0 $X=409820 $Y=1036740
X2293 1475 2 1833 1708 1 NR2 $T=412300 961520 1 180 $X=410440 $Y=961140
X2294 1881 2 1886 1475 1 NR2 $T=410440 971600 1 0 $X=410440 $Y=966180
X2295 1699 2 1892 1778 1 NR2 $T=412300 981680 1 0 $X=412300 $Y=976260
X2296 267 2 257 1872 1 NR2 $T=415400 880880 1 180 $X=413540 $Y=880500
X2297 250 2 263 1872 1 NR2 $T=415400 890960 0 0 $X=415400 $Y=890580
X2298 1924 2 1936 1927 1 NR2 $T=418500 991760 1 0 $X=418500 $Y=986340
X2299 262 2 276 1864 1 NR2 $T=419120 911120 0 0 $X=419120 $Y=910740
X2300 269 2 1923 278 1 NR2 $T=419120 1042160 0 0 $X=419120 $Y=1041780
X2301 243 2 1946 242 1 NR2 $T=422220 941360 1 180 $X=420360 $Y=940980
X2302 284 2 1925 270 1 NR2 $T=422220 1011920 0 180 $X=420360 $Y=1006500
X2303 1920 2 279 275 1 NR2 $T=422840 880880 1 180 $X=420980 $Y=880500
X2304 280 2 1920 1941 1 NR2 $T=423460 901040 0 180 $X=421600 $Y=895620
X2305 269 2 1935 1945 1 NR2 $T=421600 1022000 1 0 $X=421600 $Y=1016580
X2306 1948 2 1951 262 1 NR2 $T=424700 911120 1 180 $X=422840 $Y=910740
X2307 1948 2 1940 1941 1 NR2 $T=424080 921200 1 0 $X=424080 $Y=915780
X2308 283 2 294 280 1 NR2 $T=425320 880880 0 0 $X=425320 $Y=880500
X2309 1941 2 1954 1864 1 NR2 $T=427800 911120 0 180 $X=425940 $Y=905700
X2310 1989 2 1950 260 1 NR2 $T=427800 1032080 0 180 $X=425940 $Y=1026660
X2311 256 2 1961 250 1 NR2 $T=426560 890960 0 0 $X=426560 $Y=890580
X2312 1945 2 1970 293 1 NR2 $T=427180 991760 0 0 $X=427180 $Y=991380
X2313 294 2 292 1981 1 NR2 $T=429040 880880 0 0 $X=429040 $Y=880500
X2314 1942 2 1994 2003 1 NR2 $T=430900 961520 0 0 $X=430900 $Y=961140
X2315 1995 2 1973 258 1 NR2 $T=432760 1032080 1 180 $X=430900 $Y=1031700
X2316 282 2 1985 278 1 NR2 $T=433380 1052240 1 180 $X=431520 $Y=1051860
X2317 1942 2 1998 2006 1 NR2 $T=432140 981680 1 0 $X=432140 $Y=976260
X2318 1993 2 1928 1912 1 NR2 $T=434620 1001840 1 180 $X=432760 $Y=1001460
X2319 265 2 301 1872 1 NR2 $T=434000 890960 0 0 $X=434000 $Y=890580
X2320 2003 2 2021 1943 1 NR2 $T=435860 961520 0 180 $X=434000 $Y=956100
X2321 281 2 2009 1990 1 NR2 $T=435240 1032080 1 0 $X=435240 $Y=1026660
X2322 2006 2 2000 1943 1 NR2 $T=437720 971600 1 180 $X=435860 $Y=971220
X2323 2013 2 1977 2010 1 NR2 $T=439580 991760 1 180 $X=437720 $Y=991380
X2324 280 2 2024 1872 1 NR2 $T=438340 901040 1 0 $X=438340 $Y=895620
X2325 311 2 327 256 1 NR2 $T=440200 890960 1 0 $X=440200 $Y=885540
X2326 298 2 2023 1872 1 NR2 $T=443300 890960 1 180 $X=441440 $Y=890580
X2327 323 2 2060 327 1 NR2 $T=442060 921200 0 0 $X=442060 $Y=920820
X2328 2027 2 2014 1964 1 NR2 $T=442680 961520 0 0 $X=442680 $Y=961140
X2329 338 2 2059 1872 1 NR2 $T=447640 890960 1 180 $X=445780 $Y=890580
X2330 1922 2 2063 2053 1 NR2 $T=445780 1001840 1 0 $X=445780 $Y=996420
X2331 256 2 339 321 1 NR2 $T=448880 890960 0 180 $X=447020 $Y=885540
X2332 1964 2 2038 1980 1 NR2 $T=448260 961520 0 0 $X=448260 $Y=961140
X2333 256 2 348 298 1 NR2 $T=451360 890960 1 180 $X=449500 $Y=890580
X2334 2077 2 2068 2056 1 NR2 $T=451360 911120 1 180 $X=449500 $Y=910740
X2335 2023 2 1987 348 1 NR2 $T=450120 901040 1 0 $X=450120 $Y=895620
X2336 284 2 352 2001 1 NR2 $T=450120 1042160 1 0 $X=450120 $Y=1036740
X2337 295 2 347 256 1 NR2 $T=452600 890960 0 180 $X=450740 $Y=885540
X2338 355 2 2088 1992 1 NR2 $T=452600 901040 1 180 $X=450740 $Y=900660
X2339 350 2 1999 304 1 NR2 $T=452600 1022000 1 180 $X=450740 $Y=1021620
X2340 360 2 2050 2069 1 NR2 $T=455080 921200 0 180 $X=453220 $Y=915780
X2341 2090 2 2079 1980 1 NR2 $T=455080 971600 0 180 $X=453220 $Y=966180
X2342 1995 2 1911 366 1 NR2 $T=453220 1052240 1 0 $X=453220 $Y=1046820
X2343 2086 2 2116 2118 1 NR2 $T=453840 941360 0 0 $X=453840 $Y=940980
X2344 354 2 1918 2093 1 NR2 $T=453840 1042160 1 0 $X=453840 $Y=1036740
X2345 2049 2 356 265 1 NR2 $T=456320 890960 0 180 $X=454460 $Y=885540
X2346 2093 2 268 1974 1 NR2 $T=456320 1022000 1 180 $X=454460 $Y=1021620
X2347 2090 2 2098 2006 1 NR2 $T=456320 961520 0 0 $X=456320 $Y=961140
X2348 2094 2 2080 2108 1 NR2 $T=456320 991760 0 0 $X=456320 $Y=991380
X2349 1995 2 1939 2119 1 NR2 $T=457560 1001840 1 0 $X=457560 $Y=996420
X2350 2093 2 2125 270 1 NR2 $T=458180 1022000 0 0 $X=458180 $Y=1021620
X2351 2001 2 2055 366 1 NR2 $T=458180 1052240 1 0 $X=458180 $Y=1046820
X2352 332 2 376 265 1 NR2 $T=458800 890960 0 0 $X=458800 $Y=890580
X2353 378 2 2113 2119 1 NR2 $T=461900 981680 1 180 $X=460040 $Y=981300
X2354 1945 2 2127 270 1 NR2 $T=463140 1001840 0 180 $X=461280 $Y=996420
X2355 2071 2 2136 278 1 NR2 $T=462520 1011920 0 0 $X=462520 $Y=1011540
X2356 383 2 2132 2140 1 NR2 $T=462520 1042160 0 0 $X=462520 $Y=1041780
X2357 350 2 2018 394 1 NR2 $T=464380 1022000 1 0 $X=464380 $Y=1016580
X2358 380 2 2166 265 1 NR2 $T=466240 890960 1 0 $X=466240 $Y=885540
X2359 2155 2 2161 2167 1 NR2 $T=466240 941360 1 0 $X=466240 $Y=935940
X2360 269 2 2100 378 1 NR2 $T=466240 1011920 0 0 $X=466240 $Y=1011540
X2361 341 2 396 265 1 NR2 $T=468100 880880 0 0 $X=468100 $Y=880500
X2362 2139 2 2173 1980 1 NR2 $T=468100 961520 1 0 $X=468100 $Y=956100
X2363 269 2 395 1974 1 NR2 $T=468100 1022000 1 0 $X=468100 $Y=1016580
X2364 379 2 397 265 1 NR2 $T=471820 890960 0 180 $X=469960 $Y=885540
X2365 1990 2 2029 401 1 NR2 $T=470580 1011920 0 0 $X=470580 $Y=1011540
X2366 370 2 2137 1980 1 NR2 $T=473060 971600 1 180 $X=471200 $Y=971220
X2367 2201 2 1974 1980 1 NR2 $T=473060 981680 1 180 $X=471200 $Y=981300
X2368 378 2 2002 394 1 NR2 $T=471200 1022000 0 0 $X=471200 $Y=1021620
X2369 407 2 403 347 1 NR2 $T=474300 880880 1 180 $X=472440 $Y=880500
X2370 2047 2 2196 2082 1 NR2 $T=472440 961520 1 0 $X=472440 $Y=956100
X2371 348 2 2189 2207 1 NR2 $T=473060 931280 1 0 $X=473060 $Y=925860
X2372 2220 2 382 265 1 NR2 $T=475540 890960 0 180 $X=473680 $Y=885540
X2373 408 2 2203 343 1 NR2 $T=476160 931280 1 180 $X=474300 $Y=930900
X2374 2093 2 2177 1945 1 NR2 $T=476780 981680 1 180 $X=474920 $Y=981300
X2375 363 2 409 265 1 NR2 $T=476160 880880 0 0 $X=476160 $Y=880500
X2376 2047 2 2211 229 1 NR2 $T=476160 961520 1 0 $X=476160 $Y=956100
X2377 416 2 2031 355 1 NR2 $T=478640 931280 0 180 $X=476780 $Y=925860
X2378 2082 2 2228 249 1 NR2 $T=476780 951440 0 0 $X=476780 $Y=951060
X2379 401 2 368 2001 1 NR2 $T=476780 1052240 0 0 $X=476780 $Y=1051860
X2380 378 2 417 1974 1 NR2 $T=479260 1022000 0 180 $X=477400 $Y=1016580
X2381 2101 2 2089 2216 1 NR2 $T=478640 931280 0 0 $X=478640 $Y=930900
X2382 345 2 2210 407 1 NR2 $T=481120 921200 0 180 $X=479260 $Y=915780
X2383 2233 2 2093 1980 1 NR2 $T=481120 981680 0 180 $X=479260 $Y=976260
X2384 393 2 423 265 1 NR2 $T=480500 880880 0 0 $X=480500 $Y=880500
X2385 424 2 362 407 1 NR2 $T=482360 890960 1 180 $X=480500 $Y=890580
X2386 229 2 2242 249 1 NR2 $T=482360 951440 1 180 $X=480500 $Y=951060
X2387 370 2 2224 2173 1 NR2 $T=480500 961520 1 0 $X=480500 $Y=956100
X2388 2027 2 2039 2234 1 NR2 $T=482980 971600 1 180 $X=481120 $Y=971220
X2389 422 2 1916 296 1 NR2 $T=482980 1052240 1 180 $X=481120 $Y=1051860
X2390 1992 2 419 345 1 NR2 $T=483600 901040 0 180 $X=481740 $Y=895620
X2391 2027 2 1945 2233 1 NR2 $T=484220 981680 1 180 $X=482360 $Y=981300
X2392 2256 2 411 424 1 NR2 $T=486700 890960 1 180 $X=484840 $Y=890580
X2393 401 2 2249 367 1 NR2 $T=484840 1001840 1 0 $X=484840 $Y=996420
X2394 2129 2 2260 2238 1 NR2 $T=487320 961520 0 0 $X=487320 $Y=961140
X2395 2027 2 2268 370 1 NR2 $T=487320 971600 1 0 $X=487320 $Y=966180
X2396 430 2 441 2259 1 NR2 $T=487940 931280 1 0 $X=487940 $Y=925860
X2397 439 2 2149 1995 1 NR2 $T=489800 1042160 1 180 $X=487940 $Y=1041780
X2398 430 2 2243 2159 1 NR2 $T=488560 921200 1 0 $X=488560 $Y=915780
X2399 2270 2 308 422 1 NR2 $T=489800 1032080 0 0 $X=489800 $Y=1031700
X2400 304 2 2291 2071 1 NR2 $T=489800 1052240 1 0 $X=489800 $Y=1046820
X2401 443 2 2184 327 1 NR2 $T=492280 921200 1 180 $X=490420 $Y=920820
X2402 2286 2 2119 2027 1 NR2 $T=492280 981680 1 180 $X=490420 $Y=981300
X2403 426 2 2265 354 1 NR2 $T=492900 1042160 0 180 $X=491040 $Y=1036740
X2404 2292 2 399 444 1 NR2 $T=494760 901040 0 180 $X=492900 $Y=895620
X2405 284 2 2287 278 1 NR2 $T=492900 1011920 0 0 $X=492900 $Y=1011540
X2406 2285 2 2001 2027 1 NR2 $T=493520 981680 1 0 $X=493520 $Y=976260
X2407 367 2 1965 281 1 NR2 $T=493520 1001840 0 0 $X=493520 $Y=1001460
X2408 2231 2 2311 2303 1 NR2 $T=494140 951440 1 0 $X=494140 $Y=946020
X2409 426 2 2051 281 1 NR2 $T=494140 1042160 0 0 $X=494140 $Y=1041780
X2410 369 2 2280 323 1 NR2 $T=496620 901040 1 180 $X=494760 $Y=900660
X2411 1992 2 447 429 1 NR2 $T=495380 941360 0 0 $X=495380 $Y=940980
X2412 2098 2 2298 2260 1 NR2 $T=495380 961520 0 0 $X=495380 $Y=961140
X2413 2299 2 2247 2027 1 NR2 $T=496620 981680 1 0 $X=496620 $Y=976260
X2414 451 2 2040 284 1 NR2 $T=496620 1011920 0 0 $X=496620 $Y=1011540
X2415 369 2 455 2059 1 NR2 $T=497240 901040 1 0 $X=497240 $Y=895620
X2416 367 2 2163 2071 1 NR2 $T=497860 1011920 1 0 $X=497860 $Y=1006500
X2417 438 2 446 265 1 NR2 $T=499720 880880 0 0 $X=499720 $Y=880500
X2418 369 2 2325 348 1 NR2 $T=499720 931280 0 0 $X=499720 $Y=930900
X2419 1937 2 461 370 1 NR2 $T=500340 1011920 0 0 $X=500340 $Y=1011540
X2420 354 2 2154 281 1 NR2 $T=502200 1032080 1 180 $X=500340 $Y=1031700
X2421 2085 2 2316 370 1 NR2 $T=500960 991760 1 0 $X=500960 $Y=986340
X2422 2330 2 2309 457 1 NR2 $T=503440 981680 0 180 $X=501580 $Y=976260
X2423 436 2 2338 378 1 NR2 $T=502200 1042160 1 0 $X=502200 $Y=1036740
X2424 2329 2 2206 2078 1 NR2 $T=502820 951440 0 0 $X=502820 $Y=951060
X2425 1930 2 406 370 1 NR2 $T=505300 1022000 1 180 $X=503440 $Y=1021620
X2426 424 2 2334 2343 1 NR2 $T=504060 941360 0 0 $X=504060 $Y=940980
X2427 2129 2 2355 2090 1 NR2 $T=504060 971600 1 0 $X=504060 $Y=966180
X2428 1913 2 402 370 1 NR2 $T=505920 1022000 0 180 $X=504060 $Y=1016580
X2429 2261 2 452 370 1 NR2 $T=504680 991760 0 0 $X=504680 $Y=991380
X2430 2239 2 2281 370 1 NR2 $T=504680 1001840 1 0 $X=504680 $Y=996420
X2431 2351 2 466 2339 1 NR2 $T=507160 890960 0 180 $X=505300 $Y=885540
X2432 2111 2 2330 2090 1 NR2 $T=507160 961520 1 180 $X=505300 $Y=961140
X2433 432 2 2353 370 1 NR2 $T=507160 1011920 1 0 $X=507160 $Y=1006500
X2434 2348 2 2367 2304 1 NR2 $T=507160 1022000 0 0 $X=507160 $Y=1021620
X2435 2004 2 2359 370 1 NR2 $T=508400 991760 0 0 $X=508400 $Y=991380
X2436 2158 2 450 370 1 NR2 $T=510260 1001840 0 180 $X=508400 $Y=996420
X2437 2023 2 2350 2059 1 NR2 $T=509020 921200 1 0 $X=509020 $Y=915780
X2438 2111 2 2379 2238 1 NR2 $T=510880 961520 1 180 $X=509020 $Y=961140
X2439 348 2 2126 2343 1 NR2 $T=509640 921200 0 0 $X=509640 $Y=920820
X2440 2078 2 2370 223 1 NR2 $T=509640 951440 0 0 $X=509640 $Y=951060
X2441 323 2 477 2059 1 NR2 $T=512120 901040 1 180 $X=510260 $Y=900660
X2442 2283 2 2305 2378 1 NR2 $T=510880 931280 0 0 $X=510880 $Y=930900
X2443 350 2 2387 426 1 NR2 $T=512120 1042160 0 0 $X=512120 $Y=1041780
X2444 2374 2 2372 2329 1 NR2 $T=512740 961520 1 0 $X=512740 $Y=956100
X2445 278 2 2386 2001 1 NR2 $T=512740 991760 0 0 $X=512740 $Y=991380
X2446 2374 2 2315 223 1 NR2 $T=513360 951440 0 0 $X=513360 $Y=951060
X2447 479 2 2364 323 1 NR2 $T=514600 890960 1 0 $X=514600 $Y=885540
X2448 1919 2 2414 370 1 NR2 $T=517700 1011920 1 180 $X=515840 $Y=1011540
X2449 2329 2 2418 215 1 NR2 $T=517080 951440 0 0 $X=517080 $Y=951060
X2450 2071 2 2419 2227 1 NR2 $T=520180 1032080 0 180 $X=518320 $Y=1026660
X2451 2330 2 2446 2404 1 NR2 $T=519560 961520 1 0 $X=519560 $Y=956100
X2452 1972 2 2380 370 1 NR2 $T=519560 991760 0 0 $X=519560 $Y=991380
X2453 1952 2 2428 370 1 NR2 $T=521420 1011920 0 180 $X=519560 $Y=1006500
X2454 215 2 2455 223 1 NR2 $T=522660 951440 0 180 $X=520800 $Y=946020
X2455 401 2 486 2071 1 NR2 $T=520800 1042160 0 0 $X=520800 $Y=1041780
X2456 497 2 448 429 1 NR2 $T=524520 890960 0 180 $X=522660 $Y=885540
X2457 2023 2 2443 2343 1 NR2 $T=522660 921200 1 0 $X=522660 $Y=915780
X2458 1958 2 492 370 1 NR2 $T=523280 991760 0 0 $X=523280 $Y=991380
X2459 323 2 2440 2159 1 NR2 $T=523900 911120 0 0 $X=523900 $Y=910740
X2460 278 2 2448 281 1 NR2 $T=524520 1042160 0 0 $X=524520 $Y=1041780
X2461 345 2 501 2352 1 NR2 $T=528240 890960 0 180 $X=526380 $Y=885540
X2462 497 2 2356 2023 1 NR2 $T=528240 921200 0 180 $X=526380 $Y=915780
X2463 443 2 2441 2439 1 NR2 $T=528860 921200 1 180 $X=527000 $Y=920820
X2464 2453 2 2213 2456 1 NR2 $T=527000 991760 1 0 $X=527000 $Y=986340
X2465 429 2 2454 416 1 NR2 $T=527620 941360 1 0 $X=527620 $Y=935940
X2466 494 2 2110 497 1 NR2 $T=530100 911120 0 180 $X=528240 $Y=905700
X2467 2071 2 2460 2001 1 NR2 $T=531960 1022000 0 180 $X=530100 $Y=1016580
X2468 2481 2 2340 443 1 NR2 $T=533820 911120 0 180 $X=531960 $Y=905700
X2469 2397 2 522 2431 1 NR2 $T=536920 971600 0 0 $X=536920 $Y=971220
X2470 521 2 2534 2146 1 NR2 $T=542500 921200 0 180 $X=540640 $Y=915780
X2471 2493 2 2518 2299 1 NR2 $T=543120 981680 1 180 $X=541260 $Y=981300
X2472 2493 2 2546 2285 1 NR2 $T=544360 971600 0 180 $X=542500 $Y=966180
X2473 429 2 2540 355 1 NR2 $T=543120 911120 1 0 $X=543120 $Y=905700
X2474 424 2 2371 347 1 NR2 $T=543740 931280 1 0 $X=543740 $Y=925860
X2475 443 2 2399 528 1 NR2 $T=544360 921200 1 0 $X=544360 $Y=915780
X2476 2434 2 2293 429 1 NR2 $T=544980 941360 0 0 $X=544980 $Y=940980
X2477 369 2 2558 429 1 NR2 $T=546840 951440 1 0 $X=546840 $Y=946020
X2478 347 2 2188 528 1 NR2 $T=549320 921200 0 180 $X=547460 $Y=915780
X2479 355 2 2560 347 1 NR2 $T=547460 931280 1 0 $X=547460 $Y=925860
X2480 2481 2 2543 348 1 NR2 $T=548080 901040 0 0 $X=548080 $Y=900660
X2481 2568 2 2025 407 1 NR2 $T=549940 931280 1 180 $X=548080 $Y=930900
X2482 2493 2 2553 2233 1 NR2 $T=549320 971600 0 0 $X=549320 $Y=971220
X2483 2493 2 536 2201 1 NR2 $T=551180 981680 1 180 $X=549320 $Y=981300
X2484 444 2 518 413 1 NR2 $T=550560 901040 1 0 $X=550560 $Y=895620
X2485 2576 2 2332 2343 1 NR2 $T=552420 941360 1 180 $X=550560 $Y=940980
X2486 2501 2 2573 348 1 NR2 $T=553040 931280 0 180 $X=551180 $Y=925860
X2487 348 2 2413 407 1 NR2 $T=551180 931280 0 0 $X=551180 $Y=930900
X2488 1992 2 2212 2343 1 NR2 $T=554280 941360 0 0 $X=554280 $Y=940980
X2489 497 2 542 2501 1 NR2 $T=556760 931280 0 180 $X=554900 $Y=925860
X2490 369 2 467 407 1 NR2 $T=558000 911120 1 180 $X=556140 $Y=910740
X2491 2493 2 2610 2234 1 NR2 $T=558620 971600 0 180 $X=556760 $Y=966180
X2492 429 2 2445 2343 1 NR2 $T=558000 941360 0 0 $X=558000 $Y=940980
X2493 497 2 2409 355 1 NR2 $T=560480 931280 0 180 $X=558620 $Y=925860
X2494 2259 2 2602 345 1 NR2 $T=559240 901040 1 0 $X=559240 $Y=895620
X2495 2335 2 2607 2616 1 NR2 $T=559860 971600 0 0 $X=559860 $Y=971220
X2496 2610 2 537 2518 1 NR2 $T=559860 991760 1 0 $X=559860 $Y=986340
X2497 494 2 556 429 1 NR2 $T=562340 901040 1 180 $X=560480 $Y=900660
X2498 2614 2 543 2620 1 NR2 $T=560480 1032080 1 0 $X=560480 $Y=1026660
X2499 2493 2 2654 2366 1 NR2 $T=561720 961520 0 0 $X=561720 $Y=961140
X2500 2241 2 2519 2159 1 NR2 $T=564820 901040 0 180 $X=562960 $Y=895620
X2501 2241 2 2617 497 1 NR2 $T=562960 921200 0 0 $X=562960 $Y=920820
X2502 2614 2 2633 2516 1 NR2 $T=564820 1042160 0 180 $X=562960 $Y=1036740
X2503 2630 2 561 552 1 NR2 $T=564820 1052240 0 180 $X=562960 $Y=1046820
X2504 2343 2 2642 369 1 NR2 $T=563580 941360 0 0 $X=563580 $Y=940980
X2505 2614 2 2591 491 1 NR2 $T=564200 1032080 1 0 $X=564200 $Y=1026660
X2506 2343 2 449 413 1 NR2 $T=566680 941360 1 0 $X=566680 $Y=935940
X2507 2644 2 2652 2627 1 NR2 $T=569780 1032080 0 180 $X=567920 $Y=1026660
X2508 2452 2 2653 2650 1 NR2 $T=569780 961520 1 0 $X=569780 $Y=956100
X2509 355 2 574 345 1 NR2 $T=573500 880880 0 0 $X=573500 $Y=880500
X2510 572 2 2577 576 1 NR2 $T=573500 951440 1 0 $X=573500 $Y=946020
X2511 572 2 2470 498 1 NR2 $T=573500 961520 1 0 $X=573500 $Y=956100
X2512 323 2 437 413 1 NR2 $T=575360 921200 0 0 $X=575360 $Y=920820
X2513 2546 2 2563 2656 1 NR2 $T=577220 991760 1 0 $X=577220 $Y=986340
X2514 2614 2 2480 562 1 NR2 $T=577840 961520 1 0 $X=577840 $Y=956100
X2515 578 2 2539 2685 1 NR2 $T=577840 991760 0 0 $X=577840 $Y=991380
X2516 2638 2 2477 576 1 NR2 $T=580320 951440 0 180 $X=578460 $Y=946020
X2517 2676 2 2688 585 1 NR2 $T=578460 1052240 1 0 $X=578460 $Y=1046820
X2518 2568 2 2643 2259 1 NR2 $T=580940 911120 0 180 $X=579080 $Y=905700
X2519 2553 2 2475 2654 1 NR2 $T=582180 971600 1 180 $X=580320 $Y=971220
X2520 2691 2 2566 2703 1 NR2 $T=580320 1011920 0 0 $X=580320 $Y=1011540
X2521 2610 2 582 549 1 NR2 $T=584040 991760 1 180 $X=582180 $Y=991380
X2522 2614 2 577 498 1 NR2 $T=585280 1052240 1 180 $X=583420 $Y=1051860
X2523 2568 2 2682 528 1 NR2 $T=584040 901040 1 0 $X=584040 $Y=895620
X2524 1992 2 2663 323 1 NR2 $T=584040 921200 0 0 $X=584040 $Y=920820
X2525 471 2 2711 2428 1 NR2 $T=586520 1032080 0 0 $X=586520 $Y=1031700
X2526 2707 2 2732 2694 1 NR2 $T=587140 951440 0 0 $X=587140 $Y=951060
X2527 424 2 2695 560 1 NR2 $T=590240 931280 1 180 $X=588380 $Y=930900
X2528 603 2 2583 2707 1 NR2 $T=590240 951440 0 180 $X=588380 $Y=946020
X2529 2568 2 2708 2439 1 NR2 $T=591480 921200 1 180 $X=589620 $Y=920820
X2530 573 2 2649 2727 1 NR2 $T=590860 981680 1 0 $X=590860 $Y=976260
X2531 2630 2 2590 603 1 NR2 $T=590860 991760 1 0 $X=590860 $Y=986340
X2532 2568 2 2522 430 1 NR2 $T=592720 931280 1 0 $X=592720 $Y=925860
X2533 323 2 2718 521 1 NR2 $T=593340 921200 1 0 $X=593340 $Y=915780
X2534 603 2 2557 593 1 NR2 $T=596440 1042160 0 0 $X=596440 $Y=1041780
X2535 430 2 2741 494 1 NR2 $T=598920 890960 0 180 $X=597060 $Y=885540
X2536 2764 2 2705 2751 1 NR2 $T=600780 981680 1 180 $X=598920 $Y=981300
X2537 2546 2 2671 2654 1 NR2 $T=601400 971600 1 180 $X=599540 $Y=971220
X2538 603 2 2752 2644 1 NR2 $T=600780 951440 0 0 $X=600780 $Y=951060
X2539 549 2 2773 2659 1 NR2 $T=603880 991760 1 180 $X=602020 $Y=991380
X2540 2553 2 2601 2656 1 NR2 $T=602640 981680 0 0 $X=602640 $Y=981300
X2541 2610 2 2744 2553 1 NR2 $T=605740 961520 1 180 $X=603880 $Y=961140
X2542 562 2 2757 2694 1 NR2 $T=607600 961520 0 180 $X=605740 $Y=956100
X2543 593 2 2785 2727 1 NR2 $T=606980 981680 0 0 $X=606980 $Y=981300
X2544 2702 2 2565 2794 1 NR2 $T=606980 1052240 1 0 $X=606980 $Y=1046820
X2545 2546 2 2803 2636 1 NR2 $T=610080 971600 0 180 $X=608220 $Y=966180
X2546 2659 2 2761 2518 1 NR2 $T=611320 1042160 1 180 $X=609460 $Y=1041780
X2547 549 2 2629 2518 1 NR2 $T=612560 981680 1 180 $X=610700 $Y=981300
X2548 2746 2 2815 2806 1 NR2 $T=610700 991760 1 0 $X=610700 $Y=986340
X2549 2553 2 2805 2819 1 NR2 $T=612560 961520 0 0 $X=612560 $Y=961140
X2550 2644 2 463 2516 1 NR2 $T=615660 1052240 0 180 $X=613800 $Y=1046820
X2551 2839 2 602 2656 1 NR2 $T=620620 1032080 1 180 $X=618760 $Y=1031700
X2552 2623 2 2861 2853 1 NR2 $T=628060 1001840 0 0 $X=628060 $Y=1001460
X2553 2546 2 569 2610 1 NR2 $T=631160 971600 0 0 $X=631160 $Y=971220
X2554 549 2 2877 2553 1 NR2 $T=636120 1001840 1 0 $X=636120 $Y=996420
X2555 3494 2 796 3486 1 NR2 $T=810960 901040 0 180 $X=809100 $Y=895620
X2556 3516 2 804 3486 1 NR2 $T=815920 921200 0 180 $X=814060 $Y=915780
X2557 3518 2 3501 3525 1 NR2 $T=815300 1022000 0 0 $X=815300 $Y=1021620
X2558 3517 2 3535 3523 1 NR2 $T=818400 981680 0 0 $X=818400 $Y=981300
X2559 3518 2 810 3523 1 NR2 $T=818400 1022000 0 0 $X=818400 $Y=1021620
X2560 3516 2 812 3531 1 NR2 $T=819020 921200 0 0 $X=819020 $Y=920820
X2561 3518 2 3327 3516 1 NR2 $T=819640 911120 0 0 $X=819640 $Y=910740
X2562 3494 2 3437 3518 1 NR2 $T=821500 941360 1 180 $X=819640 $Y=940980
X2563 3531 2 3532 3523 1 NR2 $T=822120 1022000 1 180 $X=820260 $Y=1021620
X2564 3486 2 3533 3523 1 NR2 $T=824600 1011920 0 180 $X=822740 $Y=1006500
X2565 3516 2 800 3517 1 NR2 $T=823980 901040 0 0 $X=823980 $Y=900660
X2566 3546 2 3540 3545 1 NR2 $T=824600 961520 1 0 $X=824600 $Y=956100
X2567 3517 2 3566 3525 1 NR2 $T=825220 991760 0 0 $X=825220 $Y=991380
X2568 3494 2 832 3531 1 NR2 $T=825840 931280 0 0 $X=825840 $Y=930900
X2569 3494 2 3433 3517 1 NR2 $T=827700 951440 1 180 $X=825840 $Y=951060
X2570 3531 2 3409 3525 1 NR2 $T=828320 1022000 0 180 $X=826460 $Y=1016580
X2571 3565 2 3560 3545 1 NR2 $T=828940 961520 0 180 $X=827080 $Y=956100
X2572 3486 2 3541 3525 1 NR2 $T=828940 1001840 0 0 $X=828940 $Y=1001460
X2573 3550 2 3543 3035 1 NR2 $T=830180 981680 0 0 $X=830180 $Y=981300
X2574 3573 2 3567 3565 1 NR2 $T=832660 961520 0 180 $X=830800 $Y=956100
X2575 813 2 3559 3035 1 NR2 $T=834520 971600 1 180 $X=832660 $Y=971220
X2576 3573 2 3572 3546 1 NR2 $T=835140 951440 1 180 $X=833280 $Y=951060
X2577 1056 2 1051 1026 1025 1 NR3 $T=228160 1042160 1 180 $X=225060 $Y=1041780
X2578 1106 2 1052 1127 1100 1 NR3 $T=235600 981680 1 0 $X=235600 $Y=976260
X2579 1151 2 1143 1137 1133 1 NR3 $T=244280 971600 0 180 $X=241180 $Y=966180
X2580 1173 2 1044 1118 1159 1 NR3 $T=248620 981680 1 180 $X=245520 $Y=981300
X2581 1162 2 1202 43 1075 1 NR3 $T=252340 1042160 0 0 $X=252340 $Y=1041780
X2582 1315 2 1304 1199 1327 1 NR3 $T=273420 971600 1 180 $X=270320 $Y=971220
X2583 1086 2 1357 1360 1378 1 NR3 $T=278380 1011920 1 0 $X=278380 $Y=1006500
X2584 1278 2 1364 1363 1382 1 NR3 $T=280240 971600 0 0 $X=280240 $Y=971220
X2585 1380 2 43 1238 1395 1 NR3 $T=283960 1042160 0 0 $X=283960 $Y=1041780
X2586 1427 2 1392 1390 1126 1 NR3 $T=288300 941360 0 180 $X=285200 $Y=935940
X2587 1429 2 110 1432 112 1 NR3 $T=292640 890960 1 0 $X=292640 $Y=885540
X2588 1448 2 1452 1355 1467 1 NR3 $T=296360 1001840 1 0 $X=296360 $Y=996420
X2589 1408 2 1318 1468 1450 1 NR3 $T=296980 1011920 1 0 $X=296980 $Y=1006500
X2590 1426 2 1460 1461 1459 1 NR3 $T=296980 1022000 1 0 $X=296980 $Y=1016580
X2591 1499 2 1216 1481 1502 1 NR3 $T=305040 1022000 0 180 $X=301940 $Y=1016580
X2592 1509 2 1514 1486 1511 1 NR3 $T=308140 911120 1 0 $X=308140 $Y=905700
X2593 1527 2 1118 1506 1522 1 NR3 $T=311860 981680 1 180 $X=308760 $Y=981300
X2594 1513 2 1521 1543 1519 1 NR3 $T=309380 961520 1 0 $X=309380 $Y=956100
X2595 1583 2 1537 1553 1561 1 NR3 $T=319920 921200 0 180 $X=316820 $Y=915780
X2596 1343 2 70 1578 1592 1 NR3 $T=319920 1042160 0 0 $X=319920 $Y=1041780
X2597 1574 2 1580 1551 1576 1 NR3 $T=321160 981680 1 0 $X=321160 $Y=976260
X2598 1494 2 1175 1587 1594 1 NR3 $T=322400 941360 0 0 $X=322400 $Y=940980
X2599 1591 2 44 160 1534 1 NR3 $T=324260 1052240 0 0 $X=324260 $Y=1051860
X2600 1613 2 1596 1226 1612 1 NR3 $T=327980 1032080 1 180 $X=324880 $Y=1031700
X2601 1631 2 1585 1568 1632 1 NR3 $T=334800 961520 0 180 $X=331700 $Y=956100
X2602 1656 2 1650 1648 1665 1 NR3 $T=340380 1011920 0 180 $X=337280 $Y=1006500
X2603 1621 2 190 1691 1693 1 NR3 $T=346580 1022000 1 0 $X=346580 $Y=1016580
X2604 1689 2 1447 193 1658 1 NR3 $T=347820 971600 0 0 $X=347820 $Y=971220
X2605 1626 2 1712 182 1701 1 NR3 $T=353400 1032080 0 180 $X=350300 $Y=1026660
X2606 1668 2 1723 1695 1721 1 NR3 $T=355260 1011920 1 0 $X=355260 $Y=1006500
X2607 1737 2 38 203 1727 1 NR3 $T=360220 991760 0 180 $X=357120 $Y=986340
X2608 1790 2 219 1796 1753 1 NR3 $T=373860 1042160 0 0 $X=373860 $Y=1041780
X2609 1854 2 1834 1796 1839 1 NR3 $T=393080 1042160 0 180 $X=389980 $Y=1036740
X2610 1818 2 1231 1856 1838 1 NR3 $T=393080 1022000 0 0 $X=393080 $Y=1021620
X2611 1778 2 1867 1859 1836 1 NR3 $T=394940 971600 0 0 $X=394940 $Y=971220
X2612 1882 2 1463 1862 1858 1 NR3 $T=395560 1001840 0 0 $X=395560 $Y=1001460
X2613 1856 2 1712 251 1819 1 NR3 $T=396180 1032080 0 0 $X=396180 $Y=1031700
X2614 1813 2 1831 1699 1883 1 NR3 $T=404860 991760 0 180 $X=401760 $Y=986340
X2615 1895 2 1463 139 1824 1 NR3 $T=404860 1042160 0 180 $X=401760 $Y=1036740
X2616 1917 2 304 281 1975 1 NR3 $T=432140 991760 0 0 $X=432140 $Y=991380
X2617 1989 2 2119 1990 2102 1 NR3 $T=458800 1001840 0 0 $X=458800 $Y=1001460
X2618 2130 2 2019 2141 391 1 NR3 $T=461900 1052240 0 0 $X=461900 $Y=1051860
X2619 2120 2 269 387 2109 1 NR3 $T=462520 1032080 0 0 $X=462520 $Y=1031700
X2620 383 2 1995 2140 2115 1 NR3 $T=470580 1042160 0 180 $X=467480 $Y=1036740
X2621 401 2 284 2194 2008 1 NR3 $T=471820 1022000 1 0 $X=471820 $Y=1016580
X2622 422 2 2093 2227 2225 1 NR3 $T=482980 1032080 0 180 $X=479880 $Y=1026660
X2623 422 2 304 383 2240 1 NR3 $T=482980 1042160 0 0 $X=482980 $Y=1041780
X2624 2283 2 327 416 2272 1 NR3 $T=490420 911120 1 180 $X=487320 $Y=910740
X2625 435 2 436 426 400 1 NR3 $T=487940 1052240 0 0 $X=487940 $Y=1051860
X2626 2258 2 2259 429 2195 1 NR3 $T=488560 941360 1 0 $X=488560 $Y=935940
X2627 444 2 2023 2352 2319 1 NR3 $T=505920 901040 0 0 $X=505920 $Y=900660
X2628 2221 2 2415 2433 490 1 NR3 $T=518940 911120 0 0 $X=518940 $Y=910740
X2629 2421 2 479 494 2432 1 NR3 $T=522660 901040 0 0 $X=522660 $Y=900660
X2630 2342 2 2472 507 510 1 NR3 $T=530100 890960 1 0 $X=530100 $Y=885540
X2631 2469 2 2442 2483 2492 1 NR3 $T=531960 1011920 1 0 $X=531960 $Y=1006500
X2632 2497 2 2343 2159 2422 1 NR3 $T=536920 911120 1 180 $X=533820 $Y=910740
X2633 355 2 424 2486 2302 1 NR3 $T=533820 931280 1 0 $X=533820 $Y=925860
X2634 444 2 2259 521 2390 1 NR3 $T=538780 901040 0 0 $X=538780 $Y=900660
X2635 2529 2 369 2507 2279 1 NR3 $T=541880 911120 1 180 $X=538780 $Y=910740
X2636 521 2 443 2146 2525 1 NR3 $T=542500 921200 1 180 $X=539400 $Y=920820
X2637 2490 2 522 2533 2547 1 NR3 $T=540640 981680 1 0 $X=540640 $Y=976260
X2638 2582 2 407 2576 538 1 NR3 $T=553660 941360 0 180 $X=550560 $Y=935940
X2639 2559 2 2472 2391 2596 1 NR3 $T=553040 890960 0 0 $X=553040 $Y=890580
X2640 2581 2 2391 2589 2554 1 NR3 $T=553040 911120 1 0 $X=553040 $Y=905700
X2641 2521 2 2518 536 548 1 NR3 $T=553660 1042160 0 0 $X=553660 $Y=1041780
X2642 2501 2 407 2207 2599 1 NR3 $T=554900 931280 0 0 $X=554900 $Y=930900
X2643 2608 2 424 429 2541 1 NR3 $T=559240 941360 0 180 $X=556140 $Y=935940
X2644 2677 2 2507 581 579 1 NR3 $T=577840 901040 0 0 $X=577840 $Y=900660
X2645 2582 2 1992 560 2665 1 NR3 $T=580320 941360 0 0 $X=580320 $Y=940980
X2646 552 2 2644 2694 600 1 NR3 $T=587140 1052240 0 0 $X=587140 $Y=1051860
X2647 2731 2 2378 2439 2724 1 NR3 $T=593340 911120 1 0 $X=593340 $Y=905700
X2648 2793 2 2797 2810 2770 1 NR3 $T=609460 1022000 0 0 $X=609460 $Y=1021620
X2649 2816 2 2810 2777 2827 1 NR3 $T=615040 1001840 0 0 $X=615040 $Y=1001460
X2650 2528 2 2884 2726 2862 1 NR3 $T=630540 1042160 1 0 $X=630540 $Y=1036740
X2651 2878 2 2641 2762 2892 1 NR3 $T=635500 1042160 0 0 $X=635500 $Y=1041780
X2652 2899 2 2907 2297 2910 1 NR3 $T=645420 981680 0 0 $X=645420 $Y=981300
X2653 2900 2 2870 2457 2921 1 NR3 $T=647900 1011920 0 0 $X=647900 $Y=1011540
X2654 1042 1027 1 1068 1078 1096 2 MOAI1S $T=229400 981680 1 0 $X=229400 $Y=976260
X2655 1033 1102 1 17 8 1137 2 MOAI1S $T=234360 971600 0 0 $X=234360 $Y=971220
X2656 5 23 1 1035 1068 1124 2 MOAI1S $T=242420 1022000 1 180 $X=238700 $Y=1021620
X2657 1163 1158 1 1062 1095 1141 2 MOAI1S $T=246140 951440 1 180 $X=242420 $Y=951060
X2658 1102 1107 1 1049 1116 1199 2 MOAI1S $T=246760 971600 0 0 $X=246760 $Y=971220
X2659 1235 1031 1 1222 1115 1168 2 MOAI1S $T=259780 941360 1 180 $X=256060 $Y=940980
X2660 1251 59 1 1266 1263 1052 2 MOAI1S $T=266600 961520 0 180 $X=262880 $Y=956100
X2661 1299 1287 1 1269 1177 1267 2 MOAI1S $T=269080 1042160 0 180 $X=265360 $Y=1036740
X2662 1042 1214 1 1266 1293 1143 2 MOAI1S $T=265980 951440 0 0 $X=265980 $Y=951060
X2663 1286 1210 1 1298 1296 1328 2 MOAI1S $T=267840 1022000 1 0 $X=267840 $Y=1016580
X2664 1042 1214 1 1094 1215 1304 2 MOAI1S $T=269080 961520 1 0 $X=269080 $Y=956100
X2665 1193 1108 1 1319 1266 1336 2 MOAI1S $T=271560 941360 1 0 $X=271560 $Y=935940
X2666 1058 1148 1 1359 1266 1390 2 MOAI1S $T=278380 941360 1 0 $X=278380 $Y=935940
X2667 35 1322 1 1422 107 1433 2 MOAI1S $T=289540 1042160 0 0 $X=289540 $Y=1041780
X2668 31 124 1 1273 1209 1506 2 MOAI1S $T=302560 1001840 0 0 $X=302560 $Y=1001460
X2669 109 1299 1 1068 1332 1521 2 MOAI1S $T=308760 1032080 1 0 $X=308760 $Y=1026660
X2670 1560 1163 1 1515 1077 1543 2 MOAI1S $T=319300 961520 0 180 $X=315580 $Y=956100
X2671 1153 157 1 1112 1122 1596 2 MOAI1S $T=322400 1001840 0 0 $X=322400 $Y=1001460
X2672 1251 59 1 1281 1570 1620 2 MOAI1S $T=327360 951440 0 0 $X=327360 $Y=951060
X2673 1679 1662 1 1024 1049 1335 2 MOAI1S $T=342860 1032080 0 180 $X=339140 $Y=1026660
X2674 192 1698 1 1681 66 1468 2 MOAI1S $T=350920 1022000 1 180 $X=347200 $Y=1021620
X2675 1626 1163 1 1077 1061 1722 2 MOAI1S $T=351540 1001840 1 0 $X=351540 $Y=996420
X2676 202 1679 1 201 1510 1253 2 MOAI1S $T=356500 1042160 1 180 $X=352780 $Y=1041780
X2677 1711 1732 1 1714 1745 1747 2 MOAI1S $T=358980 941360 0 0 $X=358980 $Y=940980
X2678 1153 38 1 1405 1609 1734 2 MOAI1S $T=362700 991760 1 0 $X=362700 $Y=986340
X2679 1153 1775 1 1409 66 1766 2 MOAI1S $T=368900 981680 1 0 $X=368900 $Y=976260
X2680 1772 168 1 1784 162 1691 2 MOAI1S $T=371380 1022000 1 0 $X=371380 $Y=1016580
X2681 168 1795 1 1781 1702 1723 2 MOAI1S $T=376340 1011920 0 180 $X=372620 $Y=1006500
X2682 1679 1788 1 162 222 1310 2 MOAI1S $T=372620 1032080 1 0 $X=372620 $Y=1026660
X2683 1814 1728 1 229 1710 1826 2 MOAI1S $T=380680 921200 1 0 $X=380680 $Y=915780
X2684 230 1828 1 1829 1828 1815 2 MOAI1S $T=388740 911120 1 180 $X=385020 $Y=910740
X2685 1875 247 1 1860 247 1864 2 MOAI1S $T=401760 911120 1 180 $X=398040 $Y=910740
X2686 224 223 1 1846 1785 1865 2 MOAI1S $T=406100 931280 1 180 $X=402380 $Y=930900
X2687 1909 1778 1 1831 1846 1888 2 MOAI1S $T=414160 951440 0 180 $X=410440 $Y=946020
X2688 1905 247 1 1900 247 254 2 MOAI1S $T=414780 901040 0 180 $X=411060 $Y=895620
X2689 264 259 1 223 1902 255 2 MOAI1S $T=415400 890960 0 180 $X=411680 $Y=885540
X2690 1921 1931 1 1932 1931 1964 2 MOAI1S $T=419120 961520 0 0 $X=419120 $Y=961140
X2691 1969 1931 1 1949 1931 1943 2 MOAI1S $T=429040 951440 0 180 $X=425320 $Y=946020
X2692 328 1966 1 2005 314 1997 2 MOAI1S $T=440820 911120 1 180 $X=437100 $Y=910740
X2693 326 1922 1 319 1958 2012 2 MOAI1S $T=442060 1052240 1 180 $X=438340 $Y=1051860
X2694 2027 229 1 1964 2047 2033 2 MOAI1S $T=442680 961520 1 0 $X=442680 $Y=956100
X2695 2044 1931 1 2026 1931 2086 2 MOAI1S $T=445780 941360 1 0 $X=445780 $Y=935940
X2696 2069 345 1 2060 341 2056 2 MOAI1S $T=450740 931280 0 180 $X=447020 $Y=925860
X2697 2082 304 1 223 2092 2105 2 MOAI1S $T=452600 951440 0 0 $X=452600 $Y=951060
X2698 2053 2071 1 2113 2004 2108 2 MOAI1S $T=461900 991760 0 180 $X=458180 $Y=986340
X2699 2101 382 1 265 2095 365 2 MOAI1S $T=463760 890960 0 180 $X=460040 $Y=885540
X2700 2027 2021 1 2047 2139 2147 2 MOAI1S $T=461280 961520 1 0 $X=461280 $Y=956100
X2701 1953 2168 1 2152 2073 2208 2 MOAI1S $T=469340 981680 1 0 $X=469340 $Y=976260
X2702 1993 2281 1 370 2065 2297 2 MOAI1S $T=490420 991760 1 0 $X=490420 $Y=986340
X2703 2316 2318 1 370 1983 2304 2 MOAI1S $T=500960 1022000 1 180 $X=497240 $Y=1021620
X2704 2166 2323 1 265 2337 2339 2 MOAI1S $T=500960 890960 0 0 $X=500960 $Y=890580
X2705 357 406 1 2338 469 2348 2 MOAI1S $T=503440 1032080 1 0 $X=503440 $Y=1026660
X2706 2241 475 1 2364 472 2351 2 MOAI1S $T=512740 890960 1 180 $X=509020 $Y=890580
X2707 296 492 1 1916 489 488 2 MOAI1S $T=524520 1052240 1 180 $X=520800 $Y=1051860
X2708 2353 2456 1 2470 508 2490 2 MOAI1S $T=529480 981680 0 0 $X=529480 $Y=981300
X2709 2010 2281 1 2562 533 539 2 MOAI1S $T=545600 1032080 0 0 $X=545600 $Y=1031700
X2710 562 2636 1 2040 2468 2616 2 MOAI1S $T=568540 971600 1 180 $X=564820 $Y=971220
X2711 562 2636 1 545 541 2650 2 MOAI1S $T=566680 971600 1 0 $X=566680 $Y=966180
X2712 2659 572 1 370 2052 2686 2 MOAI1S $T=582800 1032080 1 180 $X=579080 $Y=1031700
X2713 511 2699 1 2695 373 2121 2 MOAI1S $T=584660 931280 1 180 $X=580940 $Y=930900
X2714 2281 2453 1 2549 582 2722 2 MOAI1S $T=584660 991760 1 0 $X=584660 $Y=986340
X2715 589 360 1 2708 351 2683 2 MOAI1S $T=585280 921200 1 0 $X=585280 $Y=915780
X2716 2654 593 1 2564 525 2751 2 MOAI1S $T=602640 981680 0 180 $X=598920 $Y=976260
X2717 573 2518 1 469 316 2762 2 MOAI1S $T=603880 1042160 1 180 $X=600160 $Y=1041780
X2718 2353 2054 1 2745 550 2777 2 MOAI1S $T=600780 1001840 0 0 $X=600780 $Y=1001460
X2719 573 2654 1 2549 590 2793 2 MOAI1S $T=603880 1022000 1 0 $X=603880 $Y=1016580
X2720 586 2727 1 2601 2526 2764 2 MOAI1S $T=610080 981680 0 180 $X=606360 $Y=976260
X2721 2205 2657 1 2556 526 2806 2 MOAI1S $T=607600 971600 0 0 $X=607600 $Y=971220
X2722 2819 2644 1 2803 2556 2788 2 MOAI1S $T=616900 971600 0 180 $X=613180 $Y=966180
X2723 549 2614 1 2509 533 2853 2 MOAI1S $T=621240 1001840 0 0 $X=621240 $Y=1001460
X2724 2638 2546 1 2556 525 2856 2 MOAI1S $T=621240 1032080 1 0 $X=621240 $Y=1026660
X2725 2546 2630 1 2509 533 2864 2 MOAI1S $T=624960 1032080 0 0 $X=624960 $Y=1031700
X2726 2638 549 1 527 569 2907 2 MOAI1S $T=635500 981680 0 0 $X=635500 $Y=981300
X2727 1104 1111 1098 1041 2 1 1132 OA112 $T=235600 931280 1 0 $X=235600 $Y=925860
X2728 16 32 30 29 2 1 27 OA112 $T=248000 880880 1 180 $X=243040 $Y=880500
X2729 1084 1256 1101 1059 2 1 1284 OA112 $T=261640 1011920 0 0 $X=261640 $Y=1011540
X2730 1337 1334 1177 1321 2 1 1254 OA112 $T=277140 981680 0 180 $X=272180 $Y=976260
X2731 1170 1393 1326 1371 2 1 1164 OA112 $T=288300 971600 0 180 $X=283340 $Y=966180
X2732 1375 1436 10 1321 2 1 1368 OA112 $T=295120 971600 0 180 $X=290160 $Y=966180
X2733 1398 1227 1409 108 2 1 1440 OA112 $T=290160 981680 1 0 $X=290160 $Y=976260
X2734 1399 1458 93 1347 2 1 1493 OA112 $T=299460 971600 0 0 $X=299460 $Y=971220
X2735 1399 1565 1177 1575 2 1 1569 OA112 $T=318060 991760 1 0 $X=318060 $Y=986340
X2736 1490 1414 162 1599 2 1 1606 OA112 $T=325500 991760 1 0 $X=325500 $Y=986340
X2737 2382 502 2448 504 2 1 2471 OA112 $T=526380 1042160 0 0 $X=526380 $Y=1041780
X2738 2523 2424 2526 525 2 1 2552 OA112 $T=540640 1001840 0 0 $X=540640 $Y=1001460
X2739 2597 2566 2526 529 2 1 2458 OA112 $T=558000 1022000 0 180 $X=553040 $Y=1016580
X2740 2473 2444 2526 2593 2 1 2604 OA112 $T=554280 1011920 0 0 $X=554280 $Y=1011540
X2741 2578 2632 2431 2478 2 1 2651 OA112 $T=565440 1001840 1 0 $X=565440 $Y=996420
X2742 2625 2697 2431 525 2 1 2675 OA112 $T=581560 1042160 1 0 $X=581560 $Y=1036740
X2743 2700 2489 460 508 2 1 2714 OA112 $T=583420 971600 0 0 $X=583420 $Y=971220
X2744 2517 2375 2711 329 2 1 2730 OA112 $T=585900 1032080 1 0 $X=585900 $Y=1026660
X2745 2729 2739 2478 1937 2 1 2758 OA112 $T=594580 1001840 1 0 $X=594580 $Y=996420
X2746 2492 2813 2526 508 2 1 2789 OA112 $T=616280 1032080 0 180 $X=611320 $Y=1026660
X2747 2729 2830 2569 525 2 1 2852 OA112 $T=619380 1001840 1 0 $X=619380 $Y=996420
X2748 1024 1040 1046 1 2 ND2 $T=221960 1022000 1 0 $X=221960 $Y=1016580
X2749 1039 1029 1041 1 2 ND2 $T=223820 1011920 1 0 $X=223820 $Y=1006500
X2750 1094 1069 1095 1 2 ND2 $T=233120 991760 1 0 $X=233120 $Y=986340
X2751 1032 1084 1108 1 2 ND2 $T=234360 1011920 0 0 $X=234360 $Y=1011540
X2752 1087 1140 1105 1 2 ND2 $T=236840 941360 1 0 $X=236840 $Y=935940
X2753 1035 1107 1095 1 2 ND2 $T=238700 961520 1 180 $X=236840 $Y=961140
X2754 1149 1148 1122 1 2 ND2 $T=243040 941360 1 180 $X=241180 $Y=940980
X2755 1157 1136 1041 1 2 ND2 $T=244900 931280 1 0 $X=244900 $Y=925860
X2756 42 1194 29 1 2 ND2 $T=252960 880880 0 0 $X=252960 $Y=880500
X2757 1077 1210 1209 1 2 ND2 $T=252960 1022000 1 0 $X=252960 $Y=1016580
X2758 1232 1065 1122 1 2 ND2 $T=257300 1001840 1 180 $X=255440 $Y=1001460
X2759 1211 1192 34 1 2 ND2 $T=256060 1022000 0 0 $X=256060 $Y=1021620
X2760 1228 1158 1242 1 2 ND2 $T=259780 1032080 1 0 $X=259780 $Y=1026660
X2761 1228 1206 1260 1 2 ND2 $T=260400 1032080 0 0 $X=260400 $Y=1031700
X2762 1255 1104 1251 1 2 ND2 $T=262880 1001840 0 0 $X=262880 $Y=1001460
X2763 68 1258 65 1 2 ND2 $T=269080 890960 1 180 $X=267220 $Y=890580
X2764 1281 1185 1326 1 2 ND2 $T=267220 921200 0 0 $X=267220 $Y=920820
X2765 1214 1305 1070 1 2 ND2 $T=269700 991760 1 180 $X=267840 $Y=991380
X2766 67 1280 76 1 2 ND2 $T=270940 890960 1 0 $X=270940 $Y=885540
X2767 1178 1318 1302 1 2 ND2 $T=274660 931280 1 180 $X=272800 $Y=930900
X2768 1078 1341 1095 1 2 ND2 $T=276520 951440 0 180 $X=274660 $Y=946020
X2769 1344 1330 1115 1 2 ND2 $T=277760 971600 1 180 $X=275900 $Y=971220
X2770 87 1333 34 1 2 ND2 $T=279620 991760 0 0 $X=279620 $Y=991380
X2771 1255 1349 28 1 2 ND2 $T=281480 1001840 0 180 $X=279620 $Y=996420
X2772 1372 1358 1263 1 2 ND2 $T=282720 911120 0 180 $X=280860 $Y=905700
X2773 1379 1352 1371 1 2 ND2 $T=285200 931280 0 0 $X=285200 $Y=930900
X2774 1391 1393 1153 1 2 ND2 $T=287060 1001840 1 0 $X=287060 $Y=996420
X2775 1372 1435 1410 1 2 ND2 $T=292640 931280 0 180 $X=290780 $Y=925860
X2776 1420 1407 1163 1 2 ND2 $T=290780 991760 0 0 $X=290780 $Y=991380
X2777 111 1432 116 1 2 ND2 $T=293880 880880 0 0 $X=293880 $Y=880500
X2778 1437 1449 1379 1 2 ND2 $T=296360 931280 0 180 $X=294500 $Y=925860
X2779 123 1500 48 1 2 ND2 $T=302560 1042160 0 0 $X=302560 $Y=1041780
X2780 1441 1486 1417 1 2 ND2 $T=305660 911120 0 180 $X=303800 $Y=905700
X2781 128 1462 121 1 2 ND2 $T=307520 890960 1 180 $X=305660 $Y=890580
X2782 1116 1494 1046 1 2 ND2 $T=305660 961520 1 0 $X=305660 $Y=956100
X2783 1209 1528 1112 1 2 ND2 $T=310620 1001840 1 180 $X=308760 $Y=1001460
X2784 1386 1537 1293 1 2 ND2 $T=314340 911120 1 180 $X=312480 $Y=910740
X2785 1546 1551 1504 1 2 ND2 $T=314960 991760 1 180 $X=313100 $Y=991380
X2786 1456 150 1571 1 2 ND2 $T=317440 1052240 0 0 $X=317440 $Y=1051860
X2787 105 1238 1575 1 2 ND2 $T=319920 1022000 0 0 $X=319920 $Y=1021620
X2788 1572 96 151 1 2 ND2 $T=321160 890960 1 0 $X=321160 $Y=885540
X2789 1573 1350 1581 1 2 ND2 $T=321160 911120 0 0 $X=321160 $Y=910740
X2790 1222 1587 1066 1 2 ND2 $T=327980 941360 0 0 $X=327980 $Y=940980
X2791 1603 1529 1581 1 2 ND2 $T=329840 921200 0 0 $X=329840 $Y=920820
X2792 1623 1059 1637 1 2 ND2 $T=331080 951440 1 0 $X=331080 $Y=946020
X2793 1630 1116 1623 1 2 ND2 $T=334180 951440 0 0 $X=334180 $Y=951060
X2794 171 1617 1339 1 2 ND2 $T=334180 1052240 0 0 $X=334180 $Y=1051860
X2795 1637 1215 1649 1 2 ND2 $T=335420 951440 1 0 $X=335420 $Y=946020
X2796 1557 1636 179 1 2 ND2 $T=336040 1042160 0 0 $X=336040 $Y=1041780
X2797 1645 1320 1581 1 2 ND2 $T=337280 921200 0 0 $X=337280 $Y=920820
X2798 1630 1209 1649 1 2 ND2 $T=338520 951440 0 0 $X=338520 $Y=951060
X2799 1664 1024 1637 1 2 ND2 $T=341000 951440 0 180 $X=339140 $Y=946020
X2800 1630 1046 1664 1 2 ND2 $T=340380 961520 1 0 $X=340380 $Y=956100
X2801 1663 1484 1623 1 2 ND2 $T=342240 951440 0 0 $X=342240 $Y=951060
X2802 1663 1047 1664 1 2 ND2 $T=342860 951440 1 0 $X=342860 $Y=946020
X2803 1664 1347 1682 1 2 ND2 $T=344720 961520 1 0 $X=344720 $Y=956100
X2804 1682 1187 1649 1 2 ND2 $T=345960 951440 0 0 $X=345960 $Y=951060
X2805 1654 1687 1659 1 2 ND2 $T=347820 981680 1 180 $X=345960 $Y=981300
X2806 1663 1041 1649 1 2 ND2 $T=347200 951440 1 0 $X=347200 $Y=946020
X2807 119 186 1702 1 2 ND2 $T=347820 1042160 0 0 $X=347820 $Y=1041780
X2808 1682 1068 1623 1 2 ND2 $T=349060 961520 1 0 $X=349060 $Y=956100
X2809 1663 1105 1705 1 2 ND2 $T=350300 951440 0 0 $X=350300 $Y=951060
X2810 196 1170 1711 1 2 ND2 $T=350920 951440 1 0 $X=350920 $Y=946020
X2811 1630 1077 1705 1 2 ND2 $T=353400 951440 0 0 $X=353400 $Y=951060
X2812 200 1706 87 1 2 ND2 $T=353400 1032080 0 0 $X=353400 $Y=1031700
X2813 1705 1066 1637 1 2 ND2 $T=354640 951440 1 0 $X=354640 $Y=946020
X2814 1705 1112 1682 1 2 ND2 $T=354640 961520 1 0 $X=354640 $Y=956100
X2815 1475 1716 1417 1 2 ND2 $T=357740 921200 1 180 $X=355880 $Y=920820
X2816 1242 1356 1609 1 2 ND2 $T=358980 1032080 1 180 $X=357120 $Y=1031700
X2817 1575 1735 164 1 2 ND2 $T=360840 1001840 1 180 $X=358980 $Y=1001460
X2818 1742 8 1749 1 2 ND2 $T=360840 971600 1 0 $X=360840 $Y=966180
X2819 1743 18 1742 1 2 ND2 $T=360840 971600 0 0 $X=360840 $Y=971220
X2820 1755 108 1743 1 2 ND2 $T=364560 971600 0 0 $X=364560 $Y=971220
X2821 1755 37 1749 1 2 ND2 $T=364560 981680 1 0 $X=364560 $Y=976260
X2822 1557 1202 216 1 2 ND2 $T=366420 1011920 0 0 $X=366420 $Y=1011540
X2823 1774 1339 1616 1 2 ND2 $T=368900 981680 0 0 $X=368900 $Y=981300
X2824 204 225 1599 1 2 ND2 $T=379440 1052240 0 0 $X=379440 $Y=1051860
X2825 98 1795 1242 1 2 ND2 $T=380680 1001840 0 0 $X=380680 $Y=1001460
X2826 1838 1744 1609 1 2 ND2 $T=387500 991760 0 180 $X=385640 $Y=986340
X2827 1726 1840 1848 1 2 ND2 $T=388740 941360 1 0 $X=388740 $Y=935940
X2828 1321 228 216 1 2 ND2 $T=389360 1011920 0 0 $X=389360 $Y=1011540
X2829 1836 33 1699 1 2 ND2 $T=389980 981680 1 0 $X=389980 $Y=976260
X2830 1644 1730 216 1 2 ND2 $T=389980 1032080 1 0 $X=389980 $Y=1026660
X2831 1161 210 1491 1 2 ND2 $T=394320 1011920 0 180 $X=392460 $Y=1006500
X2832 1575 1823 1161 1 2 ND2 $T=394320 1011920 0 0 $X=394320 $Y=1011540
X2833 1859 1787 1699 1 2 ND2 $T=396180 961520 0 0 $X=396180 $Y=961140
X2834 1609 1463 216 1 2 ND2 $T=396800 1011920 1 0 $X=396800 $Y=1006500
X2835 1702 1862 1260 1 2 ND2 $T=397420 1001840 1 0 $X=397420 $Y=996420
X2836 213 245 1702 1 2 ND2 $T=400520 1042160 1 180 $X=398660 $Y=1041780
X2837 1870 227 1837 1 2 ND2 $T=400520 991760 0 0 $X=400520 $Y=991380
X2838 1878 1767 1642 1 2 ND2 $T=403620 1022000 1 0 $X=403620 $Y=1016580
X2839 1749 1848 223 1 2 ND2 $T=405480 961520 1 0 $X=405480 $Y=956100
X2840 227 1856 1599 1 2 ND2 $T=405480 1011920 0 0 $X=405480 $Y=1011540
X2841 1883 1557 1833 1 2 ND2 $T=406720 1011920 1 0 $X=406720 $Y=1006500
X2842 1883 1242 1886 1 2 ND2 $T=408580 1001840 1 0 $X=408580 $Y=996420
X2843 1321 1796 1609 1 2 ND2 $T=409200 1042160 0 0 $X=409200 $Y=1041780
X2844 263 303 1951 1 2 ND2 $T=432140 911120 0 180 $X=430280 $Y=905700
X2845 309 2007 287 1 2 ND2 $T=436480 1052240 1 180 $X=434620 $Y=1051860
X2846 263 318 1954 1 2 ND2 $T=438340 901040 1 180 $X=436480 $Y=900660
X2847 2024 320 1951 1 2 ND2 $T=439580 911120 0 180 $X=437720 $Y=905700
X2848 2024 334 1940 1 2 ND2 $T=443920 911120 1 180 $X=442060 $Y=910740
X2849 1961 331 1940 1 2 ND2 $T=444540 901040 0 180 $X=442680 $Y=895620
X2850 2038 324 1994 1 2 ND2 $T=445780 971600 1 180 $X=443920 $Y=971220
X2851 2038 329 2000 1 2 ND2 $T=445780 981680 0 180 $X=443920 $Y=976260
X2852 325 2053 1937 1 2 ND2 $T=446400 981680 1 180 $X=444540 $Y=981300
X2853 324 2043 316 1 2 ND2 $T=445780 1001840 0 0 $X=445780 $Y=1001460
X2854 1961 342 1954 1 2 ND2 $T=448260 901040 0 180 $X=446400 $Y=895620
X2855 1923 2045 2055 1 2 ND2 $T=446400 1022000 0 0 $X=446400 $Y=1021620
X2856 215 2078 211 1 2 ND2 $T=451360 941360 1 180 $X=449500 $Y=940980
X2857 2060 2076 2083 1 2 ND2 $T=450740 921200 0 0 $X=450740 $Y=920820
X2858 2079 2097 1994 1 2 ND2 $T=455080 981680 0 180 $X=453220 $Y=976260
X2859 314 2117 363 1 2 ND2 $T=459420 921200 0 180 $X=457560 $Y=915780
X2860 373 2069 364 1 2 ND2 $T=459420 921200 1 180 $X=457560 $Y=920820
X2861 2014 372 1994 1 2 ND2 $T=459420 971600 1 180 $X=457560 $Y=971220
X2862 266 2140 324 1 2 ND2 $T=464380 1022000 1 180 $X=462520 $Y=1021620
X2863 2113 2153 2156 1 2 ND2 $T=465000 991760 1 0 $X=465000 $Y=986340
X2864 2188 2151 320 1 2 ND2 $T=473060 921200 0 180 $X=471200 $Y=915780
X2865 2211 1972 2206 1 2 ND2 $T=476780 971600 0 180 $X=474920 $Y=966180
X2866 2073 2209 1972 1 2 ND2 $T=474920 991760 0 0 $X=474920 $Y=991380
X2867 2173 2253 370 1 2 ND2 $T=485460 971600 0 180 $X=483600 $Y=966180
X2868 2126 2282 344 1 2 ND2 $T=490420 890960 1 180 $X=488560 $Y=890580
X2869 2280 2271 427 1 2 ND2 $T=491040 901040 0 180 $X=489180 $Y=895620
X2870 2100 2277 390 1 2 ND2 $T=489180 1011920 0 0 $X=489180 $Y=1011540
X2871 2127 2310 361 1 2 ND2 $T=494760 1022000 0 180 $X=492900 $Y=1016580
X2872 2315 325 2211 1 2 ND2 $T=498480 981680 1 180 $X=496620 $Y=981300
X2873 2135 2306 2329 1 2 ND2 $T=498480 951440 0 0 $X=498480 $Y=951060
X2874 2127 457 346 1 2 ND2 $T=500340 1001840 1 0 $X=500340 $Y=996420
X2875 266 2362 316 1 2 ND2 $T=505920 1011920 1 180 $X=504060 $Y=1011540
X2876 467 2321 2188 1 2 ND2 $T=505300 911120 0 0 $X=505300 $Y=910740
X2877 2211 2004 2358 1 2 ND2 $T=505300 971600 0 0 $X=505300 $Y=971220
X2878 2315 2085 2196 1 2 ND2 $T=505300 981680 1 0 $X=505300 $Y=976260
X2879 2022 484 2134 1 2 ND2 $T=507780 1052240 1 0 $X=507780 $Y=1046820
X2880 2372 2158 2211 1 2 ND2 $T=510260 981680 1 180 $X=508400 $Y=981300
X2881 2211 2261 2370 1 2 ND2 $T=509020 981680 1 0 $X=509020 $Y=976260
X2882 2196 1952 2358 1 2 ND2 $T=509640 971600 0 0 $X=509640 $Y=971220
X2883 2242 460 2358 1 2 ND2 $T=510880 971600 1 0 $X=510880 $Y=966180
X2884 2196 274 2384 1 2 ND2 $T=512120 991760 1 0 $X=512120 $Y=986340
X2885 2196 2073 2370 1 2 ND2 $T=512740 981680 1 0 $X=512740 $Y=976260
X2886 2381 1913 2211 1 2 ND2 $T=514600 981680 1 180 $X=512740 $Y=981300
X2887 2137 2397 2379 1 2 ND2 $T=515840 971600 0 180 $X=513980 $Y=966180
X2888 2137 2400 2404 1 2 ND2 $T=515840 961520 0 0 $X=515840 $Y=961140
X2889 2372 1937 2196 1 2 ND2 $T=515840 991760 1 0 $X=515840 $Y=986340
X2890 2417 1919 2211 1 2 ND2 $T=518320 981680 1 180 $X=516460 $Y=981300
X2891 215 2374 2392 1 2 ND2 $T=517080 951440 1 0 $X=517080 $Y=946020
X2892 425 2412 458 1 2 ND2 $T=518940 890960 1 0 $X=518940 $Y=885540
X2893 2417 1958 2196 1 2 ND2 $T=521420 991760 0 180 $X=519560 $Y=986340
X2894 2211 285 2384 1 2 ND2 $T=520180 981680 0 0 $X=520180 $Y=981300
X2895 2381 1930 2196 1 2 ND2 $T=525140 981680 0 180 $X=523280 $Y=976260
X2896 1952 2453 1958 1 2 ND2 $T=525140 991760 0 180 $X=523280 $Y=986340
X2897 2013 496 2134 1 2 ND2 $T=523280 1052240 1 0 $X=523280 $Y=1046820
X2898 2196 2431 2206 1 2 ND2 $T=525140 961520 0 0 $X=525140 $Y=961140
X2899 2504 2508 2320 1 2 ND2 $T=538780 951440 0 180 $X=536920 $Y=946020
X2900 2381 2509 2242 1 2 ND2 $T=541260 951440 0 0 $X=541260 $Y=951060
X2901 2417 2548 2242 1 2 ND2 $T=543740 991760 0 180 $X=541880 $Y=986340
X2902 361 2550 346 1 2 ND2 $T=542500 1011920 1 0 $X=542500 $Y=1006500
X2903 2381 2526 2228 1 2 ND2 $T=543120 961520 1 0 $X=543120 $Y=956100
X2904 2315 527 2242 1 2 ND2 $T=546840 981680 1 180 $X=544980 $Y=981300
X2905 2315 530 2228 1 2 ND2 $T=547460 951440 1 180 $X=545600 $Y=951060
X2906 2417 2549 2228 1 2 ND2 $T=546220 981680 1 0 $X=546220 $Y=976260
X2907 2206 2569 2228 1 2 ND2 $T=549320 951440 1 0 $X=549320 $Y=946020
X2908 2384 2564 2228 1 2 ND2 $T=551180 981680 0 180 $X=549320 $Y=976260
X2909 2206 2556 2242 1 2 ND2 $T=549940 961520 0 0 $X=549940 $Y=961140
X2910 2384 2562 2242 1 2 ND2 $T=551800 981680 0 0 $X=551800 $Y=981300
X2911 2268 2593 2260 1 2 ND2 $T=554900 961520 1 180 $X=553040 $Y=961140
X2912 2372 2585 2242 1 2 ND2 $T=554900 971600 1 180 $X=553040 $Y=971220
X2913 2372 541 2228 1 2 ND2 $T=553660 971600 1 0 $X=553660 $Y=966180
X2914 2358 2613 2228 1 2 ND2 $T=555520 951440 1 0 $X=555520 $Y=946020
X2915 2268 2609 2416 1 2 ND2 $T=557380 961520 1 0 $X=557380 $Y=956100
X2916 2268 546 2598 1 2 ND2 $T=557380 961520 0 0 $X=557380 $Y=961140
X2917 2228 550 2370 1 2 ND2 $T=558000 951440 0 0 $X=558000 $Y=951060
X2918 545 2521 2593 1 2 ND2 $T=558000 1042160 1 0 $X=558000 $Y=1036740
X2919 543 2611 550 1 2 ND2 $T=559860 1052240 1 0 $X=559860 $Y=1046820
X2920 2620 2624 2416 1 2 ND2 $T=562960 951440 0 180 $X=561100 $Y=946020
X2921 2614 2618 2598 1 2 ND2 $T=562960 961520 0 180 $X=561100 $Y=956100
X2922 2612 2592 2619 1 2 ND2 $T=563580 981680 1 0 $X=563580 $Y=976260
X2923 2242 2572 2370 1 2 ND2 $T=564200 991760 1 0 $X=564200 $Y=986340
X2924 2530 2645 2400 1 2 ND2 $T=567300 961520 0 180 $X=565440 $Y=956100
X2925 508 2635 529 1 2 ND2 $T=567300 1052240 1 0 $X=567300 $Y=1046820
X2926 541 2661 2431 1 2 ND2 $T=570400 1022000 1 180 $X=568540 $Y=1021620
X2927 2560 2662 320 1 2 ND2 $T=573500 921200 0 180 $X=571640 $Y=915780
X2928 2682 2403 337 1 2 ND2 $T=578460 880880 1 180 $X=576600 $Y=880500
X2929 2671 2670 2593 1 2 ND2 $T=576600 971600 0 0 $X=576600 $Y=971220
X2930 582 2689 526 1 2 ND2 $T=580320 981680 0 0 $X=580320 $Y=981300
X2931 2371 2582 344 1 2 ND2 $T=580940 931280 1 0 $X=580940 $Y=925860
X2932 2590 2685 2613 1 2 ND2 $T=581560 961520 1 0 $X=581560 $Y=956100
X2933 2178 592 272 1 2 ND2 $T=582180 880880 0 0 $X=582180 $Y=880500
X2934 2573 589 458 1 2 ND2 $T=584660 911120 1 0 $X=584660 $Y=905700
X2935 415 581 344 1 2 ND2 $T=588380 890960 0 180 $X=586520 $Y=885540
X2936 2371 2699 2409 1 2 ND2 $T=586520 931280 1 0 $X=586520 $Y=925860
X2937 2610 2710 2727 1 2 ND2 $T=590240 991760 0 0 $X=590240 $Y=991380
X2938 2761 2719 2593 1 2 ND2 $T=600780 961520 1 180 $X=598920 $Y=961140
X2939 536 599 2620 1 2 ND2 $T=598920 1032080 0 0 $X=598920 $Y=1031700
X2940 2761 2636 525 1 2 ND2 $T=603260 971600 0 0 $X=603260 $Y=971220
X2941 2812 2810 2331 1 2 ND2 $T=614420 1022000 0 0 $X=614420 $Y=1021620
X2942 2828 2797 2684 1 2 ND2 $T=621240 1022000 1 180 $X=619380 $Y=1021620
X2943 602 2819 569 1 2 ND2 $T=621860 971600 1 0 $X=621860 $Y=966180
X2944 627 2832 2847 1 2 ND2 $T=624960 931280 1 0 $X=624960 $Y=925860
X2945 603 2865 2553 1 2 ND2 $T=631160 991760 1 0 $X=631160 $Y=986340
X2946 2892 2894 2780 1 2 ND2 $T=642940 1042160 0 0 $X=642940 $Y=1041780
X2947 3503 3486 802 1 2 ND2 $T=811580 901040 0 0 $X=811580 $Y=900660
X2948 3508 3494 806 1 2 ND2 $T=813440 890960 1 0 $X=813440 $Y=885540
X2949 3514 3518 3503 1 2 ND2 $T=815920 911120 0 180 $X=814060 $Y=905700
X2950 3524 3516 3508 1 2 ND2 $T=816540 890960 1 180 $X=814680 $Y=890580
X2951 801 3523 806 1 2 ND2 $T=817780 880880 1 180 $X=815920 $Y=880500
X2952 3524 3525 801 1 2 ND2 $T=816540 890960 0 0 $X=816540 $Y=890580
X2953 1054 1081 1105 1 2 1111 AO12 $T=233740 941360 0 0 $X=233740 $Y=940980
X2954 36 34 1177 1 2 1165 AO12 $T=251100 1022000 0 180 $X=247380 $Y=1016580
X2955 1268 1112 1273 1 2 1317 AO12 $T=264740 1001840 1 0 $X=264740 $Y=996420
X2956 1187 1066 1122 1 2 53 AO12 $T=269080 951440 1 0 $X=269080 $Y=946020
X2957 1371 1372 1266 1 2 1412 AO12 $T=285200 961520 1 0 $X=285200 $Y=956100
X2958 1413 1419 1281 1 2 1430 AO12 $T=289540 921200 0 0 $X=289540 $Y=920820
X2959 1597 1685 1135 1 2 1709 AO12 $T=348440 941360 0 0 $X=348440 $Y=940980
X2960 1810 1791 1789 1 2 1765 AO12 $T=376340 911120 1 180 $X=372620 $Y=910740
X2961 1801 1791 1789 1 2 1724 AO12 $T=376960 921200 0 180 $X=373240 $Y=915780
X2962 2021 2252 2260 1 2 2276 AO12 $T=484840 961520 1 0 $X=484840 $Y=956100
X2963 469 462 2287 1 2 2495 AO12 $T=533820 1032080 1 0 $X=533820 $Y=1026660
X2964 2293 2543 509 1 2 2524 AO12 $T=546840 890960 0 180 $X=543120 $Y=885540
X2965 8 6 5 4 2 1 1053 MAOI1S $T=232500 1052240 1 180 $X=227540 $Y=1051860
X2966 18 98 1281 1351 10 147 2 1 1549 OA222S $T=322400 1032080 0 180 $X=316820 $Y=1026660
X2967 274 1906 1919 1910 1913 1904 2 1 1908 OA222S $T=420360 1011920 1 180 $X=414780 $Y=1011540
X2968 2085 322 2299 463 1913 1999 2 1 2349 OA222S $T=500960 981680 0 0 $X=500960 $Y=981300
X2969 381 2187 389 2317 438 2376 2 1 2396 OA222S $T=513980 941360 0 0 $X=513980 $Y=940980
X2970 2139 2470 2111 2477 2285 2480 2 1 2485 OA222S $T=529480 961520 1 0 $X=529480 $Y=956100
X2971 2431 2475 478 261 462 315 2 1 2491 OA222S $T=530100 1001840 1 0 $X=530100 $Y=996420
X2972 266 2468 390 478 2478 2073 2 1 2499 OA222S $T=530720 991760 0 0 $X=530720 $Y=991380
X2973 526 2556 489 2460 2158 2478 2 1 2579 OA222S $T=545600 1022000 1 0 $X=545600 $Y=1016580
X2974 526 2564 465 316 325 2478 2 1 540 OA222S $T=546220 1042160 1 0 $X=546220 $Y=1036740
X2975 372 469 266 483 526 2572 2 1 2597 OA222S $T=546220 1042160 0 0 $X=546220 $Y=1041780
X2976 1340 1274 1321 2 1 ND2S $T=277760 1001840 0 180 $X=275900 $Y=996420
X2977 158 121 151 2 1 ND2S $T=322400 890960 1 180 $X=320540 $Y=890580
X2978 1573 1386 1616 2 1 ND2S $T=324880 911120 0 0 $X=324880 $Y=910740
X2979 1572 94 172 2 1 ND2S $T=325500 890960 1 0 $X=325500 $Y=885540
X2980 1603 1410 1616 2 1 ND2S $T=327980 921200 1 0 $X=327980 $Y=915780
X2981 1611 1372 1616 2 1 ND2S $T=328600 911120 0 0 $X=328600 $Y=910740
X2982 1614 76 151 2 1 ND2S $T=329220 890960 1 0 $X=329220 $Y=885540
X2983 1615 1610 1581 2 1 ND2S $T=331080 931280 1 180 $X=329220 $Y=930900
X2984 1615 34 1616 2 1 ND2S $T=329220 941360 1 0 $X=329220 $Y=935940
X2985 1611 1371 1581 2 1 ND2S $T=332320 911120 0 0 $X=332320 $Y=910740
X2986 1614 128 172 2 1 ND2S $T=332940 890960 1 0 $X=332940 $Y=885540
X2987 1619 1263 1581 2 1 ND2S $T=334800 931280 1 0 $X=334800 $Y=925860
X2988 1684 1445 1581 2 1 ND2S $T=345340 911120 1 180 $X=343480 $Y=910740
X2989 1686 1416 1616 2 1 ND2S $T=343480 1001840 1 0 $X=343480 $Y=996420
X2990 119 1488 1144 2 1 ND2S $T=347820 1042160 0 180 $X=345960 $Y=1036740
X2991 188 115 151 2 1 ND2S $T=347200 880880 0 0 $X=347200 $Y=880500
X2992 1686 1571 1699 2 1 ND2S $T=347200 1001840 1 0 $X=347200 $Y=996420
X2993 1684 1570 1616 2 1 ND2S $T=347820 911120 0 0 $X=347820 $Y=910740
X2994 1750 175 1699 2 1 ND2S $T=362700 991760 0 0 $X=362700 $Y=991380
X2995 1750 164 1616 2 1 ND2S $T=366420 1001840 1 0 $X=366420 $Y=996420
X2996 1575 1771 87 2 1 ND2S $T=368280 1022000 0 180 $X=366420 $Y=1016580
X2997 1793 1564 1778 2 1 ND2S $T=369520 941360 1 0 $X=369520 $Y=935940
X2998 1774 87 1699 2 1 ND2S $T=369520 991760 1 0 $X=369520 $Y=986340
X2999 1806 1629 1778 2 1 ND2S $T=373240 941360 0 0 $X=373240 $Y=940980
X3000 127 220 1321 2 1 ND2S $T=375720 1052240 0 0 $X=375720 $Y=1051860
X3001 1793 1601 1813 2 1 ND2S $T=376960 941360 1 0 $X=376960 $Y=935940
X3002 1806 1671 1813 2 1 ND2S $T=377580 951440 1 0 $X=377580 $Y=946020
X3003 1708 1759 1831 2 1 ND2S $T=382540 921200 0 0 $X=382540 $Y=920820
X3004 33 1834 1702 2 1 ND2S $T=385020 1032080 1 180 $X=383160 $Y=1031700
X3005 1837 1597 1708 2 1 ND2S $T=387500 961520 1 180 $X=385640 $Y=961140
X3006 1616 1409 1836 2 1 ND2S $T=386260 981680 1 0 $X=386260 $Y=976260
X3007 1843 1491 1699 2 1 ND2S $T=389980 991760 1 0 $X=389980 $Y=986340
X3008 1867 1745 1881 2 1 ND2S $T=401760 971600 1 0 $X=401760 $Y=966180
X3009 1961 290 1951 2 1 ND2S $T=428420 901040 1 180 $X=426560 $Y=900660
X3010 1951 295 250 2 1 ND2S $T=431520 890960 0 180 $X=429660 $Y=885540
X3011 250 298 1954 2 1 ND2S $T=430280 901040 1 0 $X=430280 $Y=895620
X3012 263 313 1940 2 1 ND2S $T=435860 911120 0 180 $X=434000 $Y=905700
X3013 2014 287 2000 2 1 ND2S $T=434620 981680 0 0 $X=434620 $Y=981300
X3014 1951 311 280 2 1 ND2S $T=436480 890960 1 0 $X=436480 $Y=885540
X3015 1954 321 280 2 1 ND2S $T=439580 890960 1 180 $X=437720 $Y=890580
X3016 2014 305 1998 2 1 ND2S $T=438960 981680 1 0 $X=438960 $Y=976260
X3017 2021 322 2014 2 1 ND2S $T=441440 981680 1 180 $X=439580 $Y=981300
X3018 2024 344 1954 2 1 ND2S $T=442680 901040 1 180 $X=440820 $Y=900660
X3019 276 337 1961 2 1 ND2S $T=446400 911120 0 180 $X=444540 $Y=905700
X3020 2024 2057 276 2 1 ND2S $T=447640 911120 1 180 $X=445780 $Y=910740
X3021 2038 346 1998 2 1 ND2S $T=450120 971600 0 180 $X=448260 $Y=966180
X3022 2079 349 2021 2 1 ND2S $T=450740 981680 1 180 $X=448880 $Y=981300
X3023 2079 309 1998 2 1 ND2S $T=451360 981680 0 180 $X=449500 $Y=976260
X3024 2079 361 2000 2 1 ND2S $T=454460 981680 1 180 $X=452600 $Y=981300
X3025 368 2048 2097 2 1 ND2S $T=458180 1052240 0 0 $X=458180 $Y=1051860
X3026 2127 2150 324 2 1 ND2S $T=461900 991760 1 180 $X=460040 $Y=991380
X3027 2126 2091 303 2 1 ND2S $T=461280 931280 1 0 $X=461280 $Y=925860
X3028 2126 1981 313 2 1 ND2S $T=461900 890960 0 0 $X=461900 $Y=890580
X3029 395 1989 1918 2 1 ND2S $T=469960 1032080 0 0 $X=469960 $Y=1031700
X3030 2055 2202 2097 2 1 ND2S $T=474920 1011920 0 0 $X=474920 $Y=1011540
X3031 418 2227 2055 2 1 ND2S $T=480500 1052240 0 180 $X=478640 $Y=1046820
X3032 2000 2234 2090 2 1 ND2S $T=481120 971600 0 180 $X=479260 $Y=966180
X3033 2238 2233 2000 2 1 ND2S $T=481740 961520 1 180 $X=479880 $Y=961140
X3034 425 2146 303 2 1 ND2S $T=484220 921200 1 180 $X=482360 $Y=920820
X3035 2265 2278 2149 2 1 ND2S $T=489180 1042160 0 180 $X=487320 $Y=1036740
X3036 1994 2285 2238 2 1 ND2S $T=491660 961520 0 0 $X=491660 $Y=961140
X3037 1994 2286 2090 2 1 ND2S $T=491660 971600 1 0 $X=491660 $Y=966180
X3038 2002 2322 309 2 1 ND2S $T=497860 1042160 1 0 $X=497860 $Y=1036740
X3039 303 2347 458 2 1 ND2S $T=505300 921200 1 0 $X=505300 $Y=915780
X3040 455 2283 2356 2 1 ND2S $T=509020 911120 0 0 $X=509020 $Y=910740
X3041 2137 2410 2330 2 1 ND2S $T=518320 971600 1 0 $X=518320 $Y=966180
X3042 2440 2451 334 2 1 ND2S $T=526380 901040 1 0 $X=526380 $Y=895620
X3043 2110 2447 2340 2 1 ND2S $T=527620 901040 0 0 $X=527620 $Y=900660
X3044 289 2466 315 2 1 ND2S $T=536300 1022000 1 180 $X=534440 $Y=1021620
X3045 542 2352 2188 2 1 ND2S $T=553660 911120 1 180 $X=551800 $Y=910740
X3046 2293 2559 415 2 1 ND2S $T=552420 890960 1 0 $X=552420 $Y=885540
X3047 334 2666 342 2 1 ND2S $T=580320 911120 0 0 $X=580320 $Y=910740
X3048 803 3517 802 2 1 ND2S $T=816540 901040 1 180 $X=814680 $Y=900660
X3049 3514 3531 803 2 1 ND2S $T=825220 911120 0 180 $X=823360 $Y=905700
X3050 1097 1047 1 1075 1071 2 1067 1051 1046 OAI222S $T=233740 1032080 1 180 $X=228160 $Y=1031700
X3051 1110 18 1 1060 1128 2 1131 1125 10 OAI222S $T=236220 1042160 0 0 $X=236220 $Y=1041780
X3052 1067 1046 1 1174 1071 2 1181 1154 37 OAI222S $T=246140 1032080 0 0 $X=246140 $Y=1031700
X3053 1232 1046 1 1340 1347 2 1292 1355 1177 OAI222S $T=274660 1001840 0 0 $X=274660 $Y=1001460
X3054 1415 68 1 95 29 2 65 92 89 OAI222S $T=288300 880880 1 180 $X=282720 $Y=880500
X3055 98 108 1 1112 1078 2 1122 1426 1077 OAI222S $T=294500 1001840 1 180 $X=288920 $Y=1001460
X3056 104 1285 1 1437 1281 2 105 1427 1347 OAI222S $T=291400 961520 1 0 $X=291400 $Y=956100
X3057 1510 1491 1 1146 1484 2 1060 1496 1116 OAI222S $T=306280 991760 1 180 $X=300700 $Y=991380
X3058 1470 1281 1 1516 1041 2 1326 1513 1293 OAI222S $T=307520 941360 0 0 $X=307520 $Y=940980
X3059 1266 1350 1 1556 1326 2 1561 1568 1281 OAI222S $T=315580 931280 1 0 $X=315580 $Y=925860
X3060 1465 1105 1 1332 1059 2 1187 1588 1095 OAI222S $T=326120 961520 1 180 $X=320540 $Y=961140
X3061 1068 1115 1 1095 1105 2 105 1585 1347 OAI222S $T=328600 961520 0 180 $X=323020 $Y=956100
X3062 18 1610 1 1273 1066 2 1149 1315 1024 OAI222S $T=332320 971600 0 180 $X=326740 $Y=966180
X3063 1416 108 1 1149 1116 2 1285 1621 1339 OAI222S $T=332940 1011920 1 180 $X=327360 $Y=1011540
X3064 1634 1215 1 1250 1586 2 1647 1641 1564 OAI222S $T=334180 941360 1 0 $X=334180 $Y=935940
X3065 1281 1371 1 179 1071 2 1484 1650 1115 OAI222S $T=336660 1001840 0 0 $X=336660 $Y=1001460
X3066 176 10 1 1049 1077 2 1661 1648 37 OAI222S $T=337900 1022000 1 0 $X=337900 $Y=1016580
X3067 1187 1597 1 1222 1671 2 1685 1653 1105 OAI222S $T=342860 941360 1 0 $X=342860 $Y=935940
X3068 1212 1707 1 1715 1296 2 1720 1738 1066 OAI222S $T=352160 931280 0 0 $X=352160 $Y=930900
X3069 1741 1405 1 1541 108 2 1753 1613 107 OAI222S $T=360220 1042160 0 0 $X=360220 $Y=1041780
X3070 1071 1609 1 1756 1405 2 1285 1776 1339 OAI222S $T=372620 1001840 1 180 $X=367040 $Y=1001460
X3071 1805 1405 1 1762 162 2 1783 218 1510 OAI222S $T=376960 1052240 0 180 $X=371380 $Y=1046820
X3072 226 1405 1 1808 107 2 1824 1524 162 OAI222S $T=380680 1042160 1 0 $X=380680 $Y=1036740
X3073 1858 1510 1 1839 107 2 1830 1807 162 OAI222S $T=391220 1001840 1 180 $X=385640 $Y=1001460
X3074 286 1913 1 1928 316 2 1911 2019 285 OAI222S $T=435860 1052240 1 0 $X=435860 $Y=1046820
X3075 2169 1958 1 398 325 2 400 2141 274 OAI222S $T=468100 1052240 0 0 $X=468100 $Y=1051860
X3076 2252 2299 1 2111 2306 2 223 2289 2327 OAI222S $T=494760 961520 1 0 $X=494760 $Y=956100
X3077 2212 438 1 2089 458 2 2399 2415 384 OAI222S $T=513980 921200 1 0 $X=513980 $Y=915780
X3078 2398 351 1 2422 373 2 2432 2433 381 OAI222S $T=519560 911120 1 0 $X=519560 $Y=905700
X3079 2410 2431 1 499 1965 2 462 2442 493 OAI222S $T=529480 1011920 0 180 $X=523900 $Y=1006500
X3080 2163 2394 1 2465 346 2 395 2469 478 OAI222S $T=528860 1001840 0 0 $X=528860 $Y=1001460
X3081 2286 2526 1 2366 2509 2 2502 2498 2431 OAI222S $T=543120 961520 1 180 $X=537540 $Y=961140
X3082 2465 287 1 543 545 2 2591 2586 2593 OAI222S $T=551800 1032080 1 0 $X=551800 $Y=1026660
X3083 544 530 1 2601 2572 2 2468 2623 346 OAI222S $T=568540 1001840 1 180 $X=562960 $Y=1001460
X3084 569 460 1 1923 465 2 2601 2641 2548 OAI222S $T=573500 1042160 0 180 $X=567920 $Y=1036740
X3085 337 505 1 2596 506 2 2639 571 472 OAI222S $T=575360 890960 0 180 $X=569780 $Y=885540
X3086 463 508 1 2563 2549 2 2480 2655 2671 OAI222S $T=571020 981680 0 0 $X=571020 $Y=981300
X3087 2061 469 1 569 2431 2 2671 2676 2569 OAI222S $T=573500 1042160 0 0 $X=573500 $Y=1041780
X3088 545 530 1 2431 2622 2 2526 2691 526 OAI222S $T=585900 1022000 0 180 $X=580320 $Y=1016580
X3089 544 2585 1 2564 529 2 2593 2703 2562 OAI222S $T=585280 1011920 0 0 $X=585280 $Y=1011540
X3090 2509 590 1 2564 529 2 2572 2746 2593 OAI222S $T=600160 1022000 0 180 $X=594580 $Y=1016580
X3091 2572 545 1 2593 2562 2 2564 610 525 OAI222S $T=597680 1042160 1 0 $X=597680 $Y=1036740
X3092 2761 2569 1 2629 2562 2 607 606 469 OAI222S $T=603880 1052240 0 180 $X=598300 $Y=1046820
X3093 1068 1054 1 1082 1044 1155 2 OAI112HS $T=229400 971600 1 0 $X=229400 $Y=966180
X3094 1046 1092 1 1084 1079 1055 2 OAI112HS $T=234980 1032080 0 180 $X=230640 $Y=1026660
X3095 1024 1022 1 1150 1151 1164 2 OAI112HS $T=241180 981680 1 0 $X=241180 $Y=976260
X3096 33 8 1 1188 1173 1196 2 OAI112HS $T=248620 981680 1 0 $X=248620 $Y=976260
X3097 1298 1296 1 1275 1219 1243 2 OAI112HS $T=270940 981680 1 180 $X=266600 $Y=981300
X3098 66 1181 1 1309 1316 1246 2 OAI112HS $T=269700 1022000 0 0 $X=269700 $Y=1021620
X3099 18 80 1 1338 1360 1284 2 OAI112HS $T=274660 1022000 1 0 $X=274660 $Y=1016580
X3100 1644 1510 1 1624 1627 1234 2 OAI112HS $T=336660 981680 1 180 $X=332320 $Y=981300
X3101 1187 1708 1 1716 1729 1709 2 OAI112HS $T=352160 941360 1 0 $X=352160 $Y=935940
X3102 1699 1759 1 1733 1728 1685 2 OAI112HS $T=365180 921200 1 0 $X=365180 $Y=915780
X3103 1745 1475 1 221 1775 33 2 OAI112HS $T=378200 971600 1 180 $X=373860 $Y=971220
X3104 1759 223 1 1812 1820 1798 2 OAI112HS $T=377580 931280 0 0 $X=377580 $Y=930900
X3105 1740 1848 1 1890 1827 1893 2 OAI112HS $T=403620 941360 0 0 $X=403620 $Y=940980
X3106 329 1972 1 2114 2130 2081 2 OAI112HS $T=456940 1022000 1 0 $X=456940 $Y=1016580
X3107 2200 2003 1 2183 2165 2162 2 OAI112HS $T=473680 951440 0 180 $X=469340 $Y=946020
X3108 318 363 1 2215 2221 2182 2 OAI112HS $T=474920 911120 1 0 $X=474920 $Y=905700
X3109 269 2071 1 386 2500 2134 2 OAI112HS $T=531340 1032080 0 0 $X=531340 $Y=1031700
X3110 285 2478 1 2459 2528 2535 2 OAI112HS $T=538160 1032080 0 0 $X=538160 $Y=1031700
X3111 525 2549 1 2435 2511 2499 2 OAI112HS $T=543120 1001840 0 180 $X=538780 $Y=996420
X3112 2097 2468 1 2515 2551 2542 2 OAI112HS $T=539400 1011920 0 0 $X=539400 $Y=1011540
X3113 309 2468 1 2605 2587 2625 2 OAI112HS $T=558620 1001840 1 0 $X=558620 $Y=996420
X3114 545 558 1 555 2411 553 2 OAI112HS $T=565440 1052240 1 180 $X=561100 $Y=1051860
X3115 526 2569 1 2542 2680 2523 2 OAI112HS $T=574120 1011920 1 0 $X=574120 $Y=1006500
X3116 2732 602 1 2517 2715 599 2 OAI112HS $T=593960 971600 1 180 $X=589620 $Y=971220
X3117 527 2877 1 2852 2870 2405 2 OAI112HS $T=637360 1001840 1 180 $X=633020 $Y=1001460
X3118 677 675 1 671 2942 2940 2 OAI112HS $T=672080 880880 1 180 $X=667740 $Y=880500
X3119 1041 1 1061 1045 1086 1081 2 OAI22S $T=229400 1011920 1 0 $X=229400 $Y=1006500
X3120 1094 1 1187 1101 1191 1066 2 OAI22S $T=249860 961520 0 0 $X=249860 $Y=961140
X3121 1177 1 1217 18 1226 49 2 OAI22S $T=254820 1052240 1 0 $X=254820 $Y=1046820
X3122 1177 1 1443 8 1461 1474 2 OAI22S $T=295740 1022000 0 0 $X=295740 $Y=1021620
X3123 1484 1 1482 108 1106 1534 2 OAI22S $T=306280 971600 0 0 $X=306280 $Y=971220
X3124 1690 1 1491 37 1695 161 2 OAI22S $T=352160 1011920 0 180 $X=348440 $Y=1006500
X3125 1112 1 1763 1071 1770 1777 2 OAI22S $T=366420 961520 1 0 $X=366420 $Y=956100
X3126 107 1 1782 162 1392 1792 2 OAI22S $T=371380 1032080 0 0 $X=371380 $Y=1031700
X3127 1510 1 1800 1298 1676 1311 2 OAI22S $T=378200 991760 1 180 $X=374480 $Y=991380
X3128 246 1 1869 1872 248 249 2 OAI22S $T=398040 880880 0 0 $X=398040 $Y=880500
X3129 1952 1 1933 274 1927 1906 2 OAI22S $T=422220 991760 1 180 $X=418500 $Y=991380
X3130 2008 1 274 325 1971 2030 2 OAI22S $T=439580 1022000 0 0 $X=439580 $Y=1021620
X3131 325 1 2028 285 2034 2036 2 OAI22S $T=440820 1032080 0 0 $X=440820 $Y=1031700
X3132 313 1 2050 314 2041 2035 2 OAI22S $T=447640 921200 0 180 $X=443920 $Y=915780
X3133 346 1 2063 2073 2070 2042 2 OAI22S $T=453220 991760 1 180 $X=449500 $Y=991380
X3134 363 1 2110 332 2077 2088 2 OAI22S $T=460040 901040 1 180 $X=456320 $Y=900660
X3135 1930 1 286 2158 2087 2163 2 OAI22S $T=465000 1001840 0 0 $X=465000 $Y=1001460
X3136 393 1 2160 381 2167 2187 2 OAI22S $T=466240 931280 1 0 $X=466240 $Y=925860
X3137 379 1 2186 380 2145 2142 2 OAI22S $T=473680 901040 0 180 $X=469960 $Y=895620
X3138 385 1 2212 379 2172 419 2 OAI22S $T=475540 901040 0 0 $X=475540 $Y=900660
X3139 2144 1 2224 1980 2231 249 2 OAI22S $T=478020 951440 1 0 $X=478020 $Y=946020
X3140 1972 1 2265 2261 2094 2249 2 OAI22S $T=489180 991760 1 180 $X=485460 $Y=991380
X3141 2158 1 2275 2085 2237 2266 2 OAI22S $T=491040 1011920 0 180 $X=487320 $Y=1006500
X3142 2302 1 381 373 2288 2262 2 OAI22S $T=495380 931280 1 180 $X=491660 $Y=930900
X3143 373 1 2438 384 2427 2395 2 OAI22S $T=525760 931280 1 180 $X=522040 $Y=930900
X3144 2254 1 370 2253 2452 2431 2 OAI22S $T=524520 971600 0 0 $X=524520 $Y=971220
X3145 505 1 2519 2646 567 265 2 OAI22S $T=567920 890960 0 0 $X=567920 $Y=890580
X3146 583 1 2724 506 601 2723 2 OAI22S $T=593960 890960 1 180 $X=590240 $Y=890580
X3147 3242 1 738 3250 3260 744 2 OAI22S $T=745860 901040 0 0 $X=745860 $Y=900660
X3148 3251 1 738 739 3248 744 2 OAI22S $T=746480 901040 1 0 $X=746480 $Y=895620
X3149 3261 1 738 745 3275 744 2 OAI22S $T=750200 890960 0 0 $X=750200 $Y=890580
X3150 3196 1 738 746 3227 744 2 OAI22S $T=755160 901040 1 180 $X=751440 $Y=900660
X3151 3267 1 738 748 3279 744 2 OAI22S $T=752060 901040 1 0 $X=752060 $Y=895620
X3152 3061 1 738 749 3257 744 2 OAI22S $T=757020 880880 1 180 $X=753300 $Y=880500
X3153 754 1 3261 752 3287 745 2 OAI22S $T=759500 890960 1 180 $X=755780 $Y=890580
X3154 754 1 3242 752 3292 3250 2 OAI22S $T=760740 901040 1 180 $X=757020 $Y=900660
X3155 754 1 3267 752 3301 748 2 OAI22S $T=758260 901040 1 0 $X=758260 $Y=895620
X3156 754 1 3061 752 3304 749 2 OAI22S $T=764460 890960 0 180 $X=760740 $Y=885540
X3157 754 1 3196 752 3313 746 2 OAI22S $T=760740 901040 0 0 $X=760740 $Y=900660
X3158 3241 1 738 3324 3298 744 2 OAI22S $T=764460 901040 1 0 $X=764460 $Y=895620
X3159 3013 1 738 761 3305 744 2 OAI22S $T=770660 890960 0 180 $X=766940 $Y=885540
X3160 768 1 738 765 3330 744 2 OAI22S $T=773140 880880 1 180 $X=769420 $Y=880500
X3161 754 1 3124 752 3343 763 2 OAI22S $T=773760 901040 0 180 $X=770040 $Y=895620
X3162 754 1 3013 752 3344 761 2 OAI22S $T=774380 890960 0 180 $X=770660 $Y=885540
X3163 3124 1 738 763 3285 744 2 OAI22S $T=775620 901040 1 180 $X=771900 $Y=900660
X3164 754 1 3241 752 3362 3324 2 OAI22S $T=773760 901040 1 0 $X=773760 $Y=895620
X3165 754 1 771 752 770 769 2 OAI22S $T=778720 880880 1 180 $X=775000 $Y=880500
X3166 3067 1 738 774 3399 744 2 OAI22S $T=788640 890960 0 180 $X=784920 $Y=885540
X3167 3021 1 738 776 3363 744 2 OAI22S $T=784920 901040 1 0 $X=784920 $Y=895620
X3168 771 1 738 769 3403 744 2 OAI22S $T=787400 880880 0 0 $X=787400 $Y=880500
X3169 754 1 3067 752 3426 774 2 OAI22S $T=788640 890960 1 0 $X=788640 $Y=885540
X3170 754 1 3021 752 3421 776 2 OAI22S $T=792360 890960 1 180 $X=788640 $Y=890580
X3171 754 1 709 752 782 780 2 OAI22S $T=796080 890960 0 180 $X=792360 $Y=885540
X3172 754 1 3236 752 3449 785 2 OAI22S $T=796080 890960 1 0 $X=796080 $Y=885540
X3173 3236 1 738 785 3454 744 2 OAI22S $T=799800 890960 1 0 $X=799800 $Y=885540
X3174 1652 17 1112 1344 2 1 1683 OA22S $T=341620 981680 1 0 $X=341620 $Y=976260
X3175 1177 1144 198 108 2 1 1425 OA22S $T=354640 991760 1 180 $X=350300 $Y=991380
X3176 2057 380 334 351 2 1 2157 OA22S $T=460660 911120 0 0 $X=460660 $Y=910740
X3177 2400 2431 2478 2261 2 1 2489 OA22S $T=531340 971600 0 0 $X=531340 $Y=971220
X3178 2098 2242 2 2330 1 2327 AOI12HS $T=499100 961520 0 0 $X=499100 $Y=961140
X3179 593 549 2 2511 1 628 AOI12HS $T=625580 1022000 1 0 $X=625580 $Y=1016580
X3180 797 744 2 801 1 3508 AOI12HS $T=809100 890960 1 0 $X=809100 $Y=885540
X3181 1149 1059 1198 1107 2 1 1208 MAOI1 $T=260400 971600 0 180 $X=255440 $Y=966180
X3182 2564 537 471 2550 2 1 2561 MAOI1 $T=551800 1011920 0 180 $X=546840 $Y=1006500
X3183 2601 2649 562 2689 2 1 2693 MAOI1 $T=584040 981680 0 180 $X=579080 $Y=976260
X3184 1227 1223 2 1213 1 1090 AN3B2S $T=259160 981680 1 180 $X=255440 $Y=981300
X3185 1243 1223 2 1096 1 1264 AN3B2S $T=260400 981680 0 0 $X=260400 $Y=981300
X3186 1290 1106 2 1276 1 1277 AN3B2S $T=269700 981680 0 180 $X=265980 $Y=976260
X3187 123 1488 2 1477 1 1507 AN3B2S $T=301940 1042160 1 0 $X=301940 $Y=1036740
X3188 1755 215 2 211 1 1711 AN3B2S $T=370760 941360 1 180 $X=367040 $Y=940980
X3189 1713 228 2 1835 1 1830 AN3B2S $T=389980 1011920 0 180 $X=386260 $Y=1006500
X3190 205 245 2 1896 1 1800 AN3B2S $T=412300 1052240 1 180 $X=408580 $Y=1051860
X3191 1939 1914 2 258 1 1904 AN3B2S $T=422840 1032080 1 180 $X=419120 $Y=1031700
X3192 2184 2434 2 2439 1 2376 AN3B2S $T=522040 941360 1 0 $X=522040 $Y=935940
X3193 2560 2481 2 2559 1 2479 AN3B2S $T=548700 901040 0 180 $X=544980 $Y=895620
X3194 2480 578 2 2694 1 2667 AN3B2S $T=580320 951440 0 0 $X=580320 $Y=951060
X3195 2833 2575 2 2871 1 2896 AN3B2S $T=631780 1022000 0 0 $X=631780 $Y=1021620
X3196 2579 2864 2 2872 1 2904 AN3B2S $T=642320 1032080 0 0 $X=642320 $Y=1031700
X3197 2408 2457 2 2856 1 2929 AN3B2S $T=644180 1032080 1 0 $X=644180 $Y=1026660
X3198 1065 1050 1 1034 2 1055 OAI12HS $T=229400 1022000 1 180 $X=225680 $Y=1021620
X3199 1083 1108 1 1172 2 1169 OAI12HS $T=251100 951440 1 180 $X=247380 $Y=951060
X3200 1274 70 1 1251 2 1300 OAI12HS $T=272800 1011920 0 180 $X=269080 $Y=1006500
X3201 1285 86 1 1305 2 1345 OAI12HS $T=278380 1042160 0 0 $X=278380 $Y=1041780
X3202 1797 1726 1 1716 2 1789 OAI12HS $T=376340 921200 1 180 $X=372620 $Y=920820
X3203 2333 2128 1 2311 2 2326 OAI12HS $T=503440 951440 0 180 $X=499720 $Y=946020
X3204 2333 2273 1 2311 2 2344 OAI12HS $T=509640 951440 0 180 $X=505920 $Y=946020
X3205 2392 215 1 2374 2 2333 OAI12HS $T=515220 951440 0 180 $X=511500 $Y=946020
X3206 1981 2559 1 495 2 535 OAI12HS $T=547460 890960 1 0 $X=547460 $Y=885540
X3207 491 2630 1 549 2 2595 OAI12HS $T=563580 1032080 0 0 $X=563580 $Y=1031700
X3208 1163 1231 1058 1070 1065 1214 1 2 1213 AO222 $T=260400 991760 0 180 $X=254200 $Y=986340
X3209 1833 1827 196 1822 1820 1816 1 2 1801 AO222 $T=387500 941360 1 180 $X=381300 $Y=940980
X3210 1912 1915 1917 1922 1929 1934 1 2 1924 AO222 $T=416020 1001840 0 0 $X=416020 $Y=1001460
X3211 2013 2032 1995 2015 2022 2017 1 2 1988 AO222 $T=445160 1011920 1 180 $X=438960 $Y=1011540
X3212 2164 397 376 2185 2171 2166 1 2 405 AO222 $T=469340 890960 0 0 $X=469340 $Y=890580
X3213 2013 2226 2174 2022 386 2194 1 2 2255 AO222 $T=478020 1042160 1 0 $X=478020 $Y=1036740
X3214 2216 2263 2258 360 2246 2244 1 2 2155 AO222 $T=489180 941360 1 180 $X=482980 $Y=940980
X3215 408 2295 443 2296 2178 2267 1 2 2324 AO222 $T=494140 921200 0 0 $X=494140 $Y=920820
X3216 2294 450 452 2308 2235 2316 1 2 2335 AO222 $T=495380 991760 0 0 $X=495380 $Y=991380
X3217 408 2476 2301 2178 511 2486 1 2 516 AO222 $T=530720 921200 0 0 $X=530720 $Y=920820
X3218 492 2218 2134 2255 2516 2521 1 2 2513 AO222 $T=536300 1042160 1 0 $X=536300 $Y=1036740
X3219 2606 482 475 2615 2589 446 1 2 559 AO222 $T=559240 890960 0 0 $X=559240 $Y=890580
X3220 2966 2970 2972 2948 2980 2984 1 2 2991 AO222 $T=668980 951440 0 0 $X=668980 $Y=951060
X3221 2971 2970 2972 2960 2993 2984 1 2 3004 AO222 $T=672700 971600 1 0 $X=672700 $Y=966180
X3222 2967 2970 2972 2994 2996 2984 1 2 3006 AO222 $T=674560 921200 0 0 $X=674560 $Y=920820
X3223 2986 2970 2972 3001 3007 2984 1 2 3011 AO222 $T=677040 951440 1 0 $X=677040 $Y=946020
X3224 3010 2970 2972 3018 3020 2984 1 2 3040 AO222 $T=683860 971600 1 0 $X=683860 $Y=966180
X3225 3024 2970 2972 2982 3033 2984 1 2 3115 AO222 $T=688200 911120 0 0 $X=688200 $Y=910740
X3226 3014 2970 2972 3034 3039 2984 1 2 3050 AO222 $T=689440 941360 0 0 $X=689440 $Y=940980
X3227 3043 2970 2972 3053 3058 2984 1 2 3081 AO222 $T=696260 971600 1 0 $X=696260 $Y=966180
X3228 3049 2970 2972 3051 3059 2984 1 2 3102 AO222 $T=696880 931280 1 0 $X=696880 $Y=925860
X3229 3075 2970 2972 3091 3098 2984 1 2 3133 AO222 $T=705560 911120 1 0 $X=705560 $Y=905700
X3230 3303 2970 2972 3311 3317 2984 1 2 3318 AO222 $T=760740 951440 1 0 $X=760740 $Y=946020
X3231 3371 2970 2972 3357 3352 2984 1 2 3350 AO222 $T=780580 951440 0 180 $X=774380 $Y=946020
X3232 3393 2970 2972 3348 3355 2984 1 2 3391 AO222 $T=790500 911120 0 180 $X=784300 $Y=905700
X3233 3427 2970 2972 3416 3397 2984 1 2 3408 AO222 $T=791740 951440 1 180 $X=785540 $Y=951060
X3234 3441 2970 2972 3432 3420 2984 1 2 3412 AO222 $T=796700 911120 1 180 $X=790500 $Y=910740
X3235 3515 2970 2972 3481 3456 2984 1 2 3487 AO222 $T=815300 951440 0 180 $X=809100 $Y=946020
X3236 3534 2970 2972 3529 3470 2984 1 2 3506 AO222 $T=822740 961520 1 180 $X=816540 $Y=961140
X3237 3624 836 816 3619 3639 827 1 2 3650 AO222 $T=846300 941360 1 0 $X=846300 $Y=935940
X3238 3626 836 816 3564 3629 827 1 2 3673 AO222 $T=848780 911120 1 0 $X=848780 $Y=905700
X3239 3620 836 816 3554 3637 827 1 2 3666 AO222 $T=850640 951440 1 0 $X=850640 $Y=946020
X3240 3655 836 816 858 859 827 1 2 862 AO222 $T=854360 890960 1 0 $X=854360 $Y=885540
X3241 3604 836 816 3651 3612 827 1 2 3685 AO222 $T=855600 901040 1 0 $X=855600 $Y=895620
X3242 3755 836 816 3757 3767 827 1 2 3766 AO222 $T=882260 951440 1 0 $X=882260 $Y=946020
X3243 3794 836 816 3775 3778 827 1 2 3774 AO222 $T=894040 911120 0 180 $X=887840 $Y=905700
X3244 3780 836 816 3788 3795 827 1 2 3800 AO222 $T=890320 951440 1 0 $X=890320 $Y=946020
X3245 3792 836 816 3787 889 827 1 2 893 AO222 $T=893420 880880 0 0 $X=893420 $Y=880500
X3246 3828 836 816 3833 3840 827 1 2 897 AO222 $T=905200 890960 1 0 $X=905200 $Y=885540
X3247 3830 836 816 3844 3851 827 1 2 3853 AO222 $T=907060 951440 1 0 $X=907060 $Y=946020
X3248 3834 836 816 3866 3870 827 1 2 3894 AO222 $T=916360 911120 0 0 $X=916360 $Y=910740
X3249 3862 836 816 3860 3871 827 1 2 3875 AO222 $T=916980 951440 1 0 $X=916980 $Y=946020
X3250 3864 836 816 910 911 827 1 2 912 AO222 $T=919460 880880 0 0 $X=919460 $Y=880500
X3251 3879 836 816 3886 3901 827 1 2 919 AO222 $T=926900 890960 1 0 $X=926900 $Y=885540
X3252 4069 957 956 954 4061 952 1 2 3990 AO222 $T=976500 890960 0 180 $X=970300 $Y=885540
X3253 4063 957 956 4053 4060 952 1 2 4043 AO222 $T=978360 921200 1 180 $X=972160 $Y=920820
X3254 4093 957 956 4041 4075 952 1 2 3986 AO222 $T=983940 911120 1 180 $X=977740 $Y=910740
X3255 4113 957 956 4103 4082 952 1 2 4005 AO222 $T=988900 890960 1 180 $X=982700 $Y=890580
X3256 4134 957 956 4124 4108 952 1 2 3977 AO222 $T=1000680 911120 1 180 $X=994480 $Y=910740
X3257 4186 957 956 4179 4165 952 1 2 4083 AO222 $T=1011840 921200 1 180 $X=1005640 $Y=920820
X3258 4193 957 956 4185 977 952 1 2 4163 AO222 $T=1013700 901040 0 180 $X=1007500 $Y=895620
X3259 4178 957 956 4190 4196 952 1 2 4171 AO222 $T=1011220 911120 0 0 $X=1011220 $Y=910740
X3260 4240 957 956 4232 4211 952 1 2 4180 AO222 $T=1028580 921200 1 180 $X=1022380 $Y=920820
X3261 4259 957 956 4255 4250 952 1 2 4227 AO222 $T=1037260 890960 1 180 $X=1031060 $Y=890580
X3262 4289 957 956 4288 4260 952 1 2 4301 AO222 $T=1055860 921200 1 180 $X=1049660 $Y=920820
X3263 4335 957 956 4320 4315 952 1 2 4278 AO222 $T=1060200 901040 0 180 $X=1054000 $Y=895620
X3264 4328 957 956 4340 4344 952 1 2 4321 AO222 $T=1060820 921200 1 0 $X=1060820 $Y=915780
X3265 4382 957 956 4365 4361 952 1 2 4352 AO222 $T=1073840 901040 0 180 $X=1067640 $Y=895620
X3266 4385 957 956 4370 4366 952 1 2 4345 AO222 $T=1075080 911120 1 180 $X=1068880 $Y=910740
X3267 1224 51 1 2 INV2 $T=257920 901040 1 180 $X=256060 $Y=900660
X3268 1396 106 1 2 INV2 $T=287680 901040 0 0 $X=287680 $Y=900660
X3269 137 138 1 2 INV2 $T=311860 901040 1 0 $X=311860 $Y=895620
X3270 137 142 1 2 INV2 $T=314340 901040 1 0 $X=314340 $Y=895620
X3271 1675 195 1 2 INV2 $T=349060 901040 1 0 $X=349060 $Y=895620
X3272 173 194 1 2 INV2 $T=349680 890960 1 0 $X=349680 $Y=885540
X3273 173 197 1 2 INV2 $T=351540 890960 1 0 $X=351540 $Y=885540
X3274 1688 206 1 2 INV2 $T=353400 890960 1 0 $X=353400 $Y=885540
X3275 1699 1616 1 2 INV2 $T=365800 911120 0 0 $X=365800 $Y=910740
X3276 320 323 1 2 INV2 $T=440200 931280 0 180 $X=438340 $Y=925860
X3277 342 413 1 2 INV2 $T=517080 911120 0 0 $X=517080 $Y=910740
X3278 647 648 1 2 INV2 $T=654720 961520 0 180 $X=652860 $Y=956100
X3279 2901 657 1 2 INV2 $T=657820 901040 0 0 $X=657820 $Y=900660
X3280 673 669 1 2 INV2 $T=668980 911120 1 180 $X=667120 $Y=910740
X3281 2961 678 1 2 INV2 $T=670840 971600 1 0 $X=670840 $Y=966180
X3282 653 683 1 2 INV2 $T=675800 901040 1 180 $X=673940 $Y=900660
X3283 2943 693 1 2 INV2 $T=678900 890960 0 0 $X=678900 $Y=890580
X3284 1914 2 281 1 273 NR2P $T=422840 1052240 1 180 $X=419120 $Y=1051860
X3285 338 2 256 1 369 NR2P $T=457560 890960 1 180 $X=453840 $Y=890580
X3286 2201 2 2027 1 269 NR2P $T=484840 981680 0 0 $X=484840 $Y=981300
X3287 2493 2 2286 1 549 NR2P $T=558620 981680 1 180 $X=554900 $Y=981300
X3288 1358 1388 2 1404 1386 1 OR3B2 $T=285820 911120 1 0 $X=285820 $Y=905700
X3289 1462 1523 2 146 94 1 OR3B2 $T=311240 890960 0 0 $X=311240 $Y=890580
X3290 1442 1582 2 1574 1150 1 OR3B2 $T=320540 971600 0 0 $X=320540 $Y=971220
X3291 1843 1144 2 1779 1605 1 OR3B2 $T=389360 991760 1 180 $X=385640 $Y=991380
X3292 2645 569 2 2657 2510 1 OR3B2 $T=574740 971600 1 180 $X=571020 $Y=971220
X3293 2575 2461 2 2872 2690 1 OR3B2 $T=636740 1032080 1 180 $X=633020 $Y=1031700
X3294 2551 2604 2 2900 2579 1 OR3B2 $T=638600 1011920 0 0 $X=638600 $Y=1011540
X3295 1121 1104 1084 2 1 1142 AN3 $T=239320 1011920 1 0 $X=239320 $Y=1006500
X3296 1179 1132 1186 2 1 1196 AN3 $T=249240 941360 0 0 $X=249240 $Y=940980
X3297 1204 1197 1145 2 1 1234 AN3 $T=255440 981680 1 0 $X=255440 $Y=976260
X3298 1230 1244 1229 2 1 1246 AN3 $T=260400 951440 0 0 $X=260400 $Y=951060
X3299 1308 1313 1264 2 1 1342 AN3 $T=272800 981680 0 0 $X=272800 $Y=981300
X3300 93 1409 88 2 1 101 AN3 $T=287680 1052240 1 0 $X=287680 $Y=1046820
X3301 1406 1398 1246 2 1 1455 AN3 $T=293260 981680 0 0 $X=293260 $Y=981300
X3302 1532 1495 1493 2 1 1406 AN3 $T=306280 981680 0 180 $X=302560 $Y=976260
X3303 1456 147 1416 2 1 1538 AN3 $T=318680 1022000 1 180 $X=314960 $Y=1021620
X3304 1593 1604 163 2 1 1624 AN3 $T=326120 981680 1 0 $X=326120 $Y=976260
X3305 178 1298 181 2 1 176 AN3 $T=338520 1052240 1 0 $X=338520 $Y=1046820
X3306 1821 1542 1697 2 1 1741 AN3 $T=383160 1032080 0 180 $X=379440 $Y=1026660
X3307 1863 1699 1853 2 1 1797 AN3 $T=398040 951440 1 180 $X=394320 $Y=951060
X3308 2287 432 277 2 1 2269 AN3 $T=495380 1022000 1 180 $X=491660 $Y=1021620
X3309 362 2049 2332 2 1 431 AN3 $T=505920 901040 1 0 $X=505920 $Y=895620
X3310 2366 2286 2285 2 1 2425 AN3 $T=519560 961520 0 0 $X=519560 $Y=961140
X3311 2584 2491 2580 2 1 2594 AN3 $T=553040 1001840 1 0 $X=553040 $Y=996420
X3312 2462 2660 2675 2 1 2690 AN3 $T=575360 1042160 1 0 $X=575360 $Y=1036740
X3313 2786 2784 2730 2 1 2535 AN3 $T=608220 1032080 1 180 $X=604500 $Y=1031700
X3314 2876 2861 2648 2 1 2849 AN3 $T=631780 1001840 0 180 $X=628060 $Y=996420
X3315 1059 1028 1066 1022 2 1 1082 OA22 $T=227540 971600 0 0 $X=227540 $Y=971220
X3316 1101 1087 1081 1047 2 1 1064 OA22 $T=234360 951440 1 180 $X=230020 $Y=951060
X3317 1046 1092 10 1171 2 1 1184 OA22 $T=245520 1032080 1 0 $X=245520 $Y=1026660
X3318 1095 1215 1209 1129 2 1 1201 OA22 $T=257300 951440 0 180 $X=252960 $Y=946020
X3319 1281 1320 1105 1094 2 1 1302 OA22 $T=275280 931280 0 180 $X=270940 $Y=925860
X3320 1215 1081 1319 1326 2 1 1337 OA22 $T=274040 941360 0 0 $X=274040 $Y=940980
X3321 1369 66 1059 1061 2 1 1306 OA22 $T=281480 1022000 1 180 $X=277140 $Y=1021620
X3322 1350 1326 1078 1047 2 1 1370 OA22 $T=278380 951440 1 0 $X=278380 $Y=946020
X3323 1405 1498 1484 1160 2 1 1423 OA22 $T=306280 1001840 0 180 $X=301940 $Y=996420
X3324 1281 1410 1326 1386 2 1 1436 OA22 $T=307520 931280 1 0 $X=307520 $Y=925860
X3325 1566 1552 1351 1266 2 1 1353 OA22 $T=318680 931280 1 180 $X=314340 $Y=930900
X3326 1281 1529 1112 1095 2 1 1582 OA22 $T=319920 951440 0 0 $X=319920 $Y=951060
X3327 1733 1664 1669 1749 2 1 1853 OA22 $T=388120 951440 0 0 $X=388120 $Y=951060
X3328 349 2085 309 1958 2 1 2074 OA22 $T=455080 1001840 0 180 $X=450740 $Y=996420
X3329 1952 2100 1913 421 2 1 2236 OA22 $T=479260 1011920 0 0 $X=479260 $Y=1011540
X3330 393 2280 438 437 2 1 2143 OA22 $T=492280 901040 1 180 $X=487940 $Y=900660
X3331 2468 421 2465 309 2 1 2503 OA22 $T=532580 1011920 0 0 $X=532580 $Y=1011540
X3332 499 417 462 309 2 1 2515 OA22 $T=534440 1022000 1 0 $X=534440 $Y=1016580
X3333 530 2563 266 2465 2 1 2571 OA22 $T=546220 991760 1 0 $X=546220 $Y=986340
X3334 508 2557 526 2591 2 1 2672 OA22 $T=572260 1032080 1 0 $X=572260 $Y=1026660
X3335 525 2480 489 261 2 1 2674 OA22 $T=572260 1052240 1 0 $X=572260 $Y=1046820
X3336 316 2711 529 2557 2 1 2740 OA22 $T=590240 1042160 1 0 $X=590240 $Y=1036740
X3337 370 2106 2629 2572 2 1 2748 OA22 $T=591480 1052240 1 0 $X=591480 $Y=1046820
X3338 590 558 529 577 2 1 2759 OA22 $T=593340 1052240 0 0 $X=593340 $Y=1051860
X3339 2773 2562 2629 2785 2 1 2754 OA22 $T=603880 991760 1 0 $X=603880 $Y=986340
X3340 2805 2526 550 2609 2 1 2821 OA22 $T=611940 961520 1 0 $X=611940 $Y=956100
X3341 739 752 3251 754 2 1 3323 OA22 $T=761360 890960 0 0 $X=761360 $Y=890580
X3342 2253 2478 2410 1 2 2530 AN3S $T=536920 971600 1 0 $X=536920 $Y=966180
X3343 691 698 1 2 INV12CK $T=680760 921200 0 0 $X=680760 $Y=920820
X3344 3443 704 1 2 INV12CK $T=801660 1032080 0 180 $X=791740 $Y=1026660
X3345 3709 3754 1 2 INV12CK $T=874820 991760 0 0 $X=874820 $Y=991380
X3346 3754 777 1 2 INV12CK $T=888460 991760 0 0 $X=888460 $Y=991380
X3347 4326 4307 1 2 BUF2CK $T=1060200 931280 1 0 $X=1060200 $Y=925860
X3348 650 2930 2948 1 2 650 2939 2966 1021 ICV_4 $T=654720 961520 1 0 $X=654720 $Y=956100
X3349 2927 2930 2960 1 2 650 2975 2980 1021 ICV_4 $T=659060 961520 0 0 $X=659060 $Y=961140
X3350 690 3016 3222 1 2 689 3016 3258 1021 ICV_4 $T=731600 1011920 0 0 $X=731600 $Y=1011540
X3351 737 2988 3289 1 2 737 2923 3336 1021 ICV_4 $T=749580 1011920 1 0 $X=749580 $Y=1006500
X3352 736 2975 3317 1 2 737 2975 3352 1021 ICV_4 $T=753920 951440 0 0 $X=753920 $Y=951060
X3353 736 2930 3311 1 2 737 2939 3371 1021 ICV_4 $T=758880 941360 0 0 $X=758880 $Y=940980
X3354 737 3104 3341 1 2 767 3104 3389 1021 ICV_4 $T=761360 961520 1 0 $X=761360 $Y=956100
X3355 747 2930 3348 1 2 747 2939 3393 1021 ICV_4 $T=763220 911120 1 0 $X=763220 $Y=905700
X3356 778 656 3505 1 2 778 685 3471 1021 ICV_4 $T=801660 1052240 0 0 $X=801660 $Y=1051860
X3357 824 830 3612 1 2 824 829 3651 1021 ICV_4 $T=833280 890960 1 0 $X=833280 $Y=885540
X3358 833 3584 3626 1 2 824 844 3697 1021 ICV_4 $T=836380 901040 0 0 $X=836380 $Y=900660
X3359 3583 844 3648 1 2 833 845 3699 1021 ICV_4 $T=843820 911120 0 0 $X=843820 $Y=910740
X3360 833 3607 3702 1 2 864 3601 3710 1021 ICV_4 $T=854980 1032080 0 0 $X=854980 $Y=1031700
X3361 833 3599 3705 1 2 833 3590 3737 1021 ICV_4 $T=855600 1052240 1 0 $X=855600 $Y=1046820
X3362 842 822 3693 1 2 867 822 3738 1021 ICV_4 $T=856220 1001840 1 0 $X=856220 $Y=996420
X3363 831 845 3708 1 2 3583 873 3729 1021 ICV_4 $T=856840 921200 0 0 $X=856840 $Y=920820
X3364 842 828 3698 1 2 867 828 3748 1021 ICV_4 $T=860560 1011920 1 0 $X=860560 $Y=1006500
X3365 867 3616 3735 1 2 3720 3584 3755 1021 ICV_4 $T=866140 961520 1 0 $X=866140 $Y=956100
X3366 867 3590 3731 1 2 3720 3590 3781 1021 ICV_4 $T=870480 981680 1 0 $X=870480 $Y=976260
X3367 3720 830 3767 1 2 885 829 3788 1021 ICV_4 $T=882880 951440 0 0 $X=882880 $Y=951060
X3368 3720 3601 3768 1 2 3720 3607 3763 1021 ICV_4 $T=882880 991760 1 0 $X=882880 $Y=986340
X3369 877 3599 3796 1 2 885 3599 3824 1021 ICV_4 $T=887220 1052240 1 0 $X=887220 $Y=1046820
X3370 3720 822 3791 1 2 890 3607 3838 1021 ICV_4 $T=887840 1001840 1 0 $X=887840 $Y=996420
X3371 877 844 3807 1 2 895 829 3833 1021 ICV_4 $T=891560 901040 1 0 $X=891560 $Y=895620
X3372 890 3590 3839 1 2 894 3616 3863 1021 ICV_4 $T=899620 981680 1 0 $X=899620 $Y=976260
X3373 890 822 3827 1 2 3845 822 3877 1021 ICV_4 $T=901480 1001840 0 0 $X=901480 $Y=1001460
X3374 3845 3607 3878 1 2 894 3607 3932 1021 ICV_4 $T=915740 1001840 1 0 $X=915740 $Y=996420
X3375 906 866 3906 1 2 815 928 3965 1021 ICV_4 $T=930000 921200 0 0 $X=930000 $Y=920820
X3376 815 3947 3975 1 2 3952 3944 4021 1021 ICV_4 $T=943640 1011920 1 0 $X=943640 $Y=1006500
X3377 923 3938 3983 1 2 3502 3938 4028 1021 ICV_4 $T=946120 961520 0 0 $X=946120 $Y=961140
X3378 3952 946 4063 1 2 951 928 4084 1021 ICV_4 $T=964720 931280 1 0 $X=964720 $Y=925860
X3379 3502 4055 4072 1 2 3952 4055 4110 1021 ICV_4 $T=968440 1001840 1 0 $X=968440 $Y=996420
X3380 815 946 4093 1 2 3691 928 4145 1021 ICV_4 $T=979600 921200 1 0 $X=979600 $Y=915780
X3381 799 934 4114 1 2 799 963 4126 1021 ICV_4 $T=980220 1042160 1 0 $X=980220 $Y=1036740
X3382 799 4055 4098 1 2 3952 4010 4117 1021 ICV_4 $T=981460 981680 1 0 $X=981460 $Y=976260
X3383 3952 963 4123 1 2 798 939 4159 1021 ICV_4 $T=983320 1042160 0 0 $X=983320 $Y=1041780
X3384 923 4055 4133 1 2 923 4010 4132 1021 ICV_4 $T=985180 1011920 1 0 $X=985180 $Y=1006500
X3385 923 946 4134 1 2 3691 926 4156 1021 ICV_4 $T=985800 931280 1 0 $X=985800 $Y=925860
X3386 951 4010 4135 1 2 951 4055 4176 1021 ICV_4 $T=988280 991760 1 0 $X=988280 $Y=986340
X3387 968 4055 4174 1 2 798 4010 4202 1021 ICV_4 $T=996960 1001840 1 0 $X=996960 $Y=996420
X3388 968 928 4206 1 2 968 946 4240 1021 ICV_4 $T=1008120 931280 0 0 $X=1008120 $Y=930900
X3389 808 939 4198 1 2 3691 939 4245 1021 ICV_4 $T=1011840 1042160 1 0 $X=1011840 $Y=1036740
X3390 3691 934 4243 1 2 805 963 4283 1021 ICV_4 $T=1019900 1052240 1 0 $X=1019900 $Y=1046820
X3391 983 935 4248 1 2 805 935 4271 1021 ICV_4 $T=1021760 941360 1 0 $X=1021760 $Y=935940
X3392 983 945 4260 1 2 983 928 4295 1021 ICV_4 $T=1028580 921200 0 0 $X=1028580 $Y=920820
X3393 983 934 993 1 2 805 939 995 1021 ICV_4 $T=1036640 1052240 0 0 $X=1036640 $Y=1051860
X3394 983 959 4288 1 2 805 959 4340 1021 ICV_4 $T=1037880 911120 0 0 $X=1037880 $Y=910740
X3395 987 946 4335 1 2 789 959 4370 1021 ICV_4 $T=1050900 911120 1 0 $X=1050900 $Y=905700
X3396 805 945 4344 1 2 789 946 4385 1021 ICV_4 $T=1055860 921200 0 0 $X=1055860 $Y=920820
X3397 1780 1 2 1089 INV3CK $T=372620 901040 0 180 $X=369520 $Y=895620
X3398 2926 1 2 2826 INV3CK $T=654100 951440 0 0 $X=654100 $Y=951060
X3399 3198 1 2 664 INV3CK $T=731600 880880 0 0 $X=731600 $Y=880500
X3400 3460 1 2 3464 INV3CK $T=802280 961520 0 0 $X=802280 $Y=961140
X3401 3536 1 2 3511 INV3CK $T=830800 1001840 0 0 $X=830800 $Y=1001460
X3402 3585 1 2 3439 INV3CK $T=834520 1011920 0 0 $X=834520 $Y=1011540
X3403 3553 1 2 835 INV3CK $T=838860 1042160 0 180 $X=835760 $Y=1036740
X3404 3643 1 2 3616 INV3CK $T=851260 961520 0 0 $X=851260 $Y=961140
X3405 3713 1 2 3704 INV3CK $T=871100 991760 1 180 $X=868000 $Y=991380
X3406 3647 1 2 875 INV3CK $T=872960 1022000 0 180 $X=869860 $Y=1016580
X3407 3957 1 2 3958 INV3CK $T=948600 971600 0 0 $X=948600 $Y=971220
X3408 3998 1 2 4003 INV3CK $T=958520 1011920 0 0 $X=958520 $Y=1011540
X3409 4002 1 2 3993 INV3CK $T=959140 931280 0 0 $X=959140 $Y=930900
X3410 4097 1 2 4106 INV3CK $T=984560 1001840 0 0 $X=984560 $Y=1001460
X3411 4073 1 2 4109 INV3CK $T=987040 941360 0 0 $X=987040 $Y=940980
X3412 4077 1 2 4045 INV3CK $T=987040 951440 0 0 $X=987040 $Y=951060
X3413 4116 1 2 4120 INV3CK $T=990140 901040 0 0 $X=990140 $Y=900660
X3414 4054 1 2 4125 INV3CK $T=995100 981680 0 0 $X=995100 $Y=981300
X3415 4136 1 2 4142 INV3CK $T=997580 1052240 0 0 $X=997580 $Y=1051860
X3416 4107 1 2 4166 INV3CK $T=1006880 1022000 0 180 $X=1003780 $Y=1016580
X3417 4204 1 2 4210 INV3CK $T=1017420 911120 0 0 $X=1017420 $Y=910740
X3418 4252 1 2 4169 INV3CK $T=1032920 941360 0 0 $X=1032920 $Y=940980
X3419 4308 1 2 4221 INV3CK $T=1053380 951440 0 0 $X=1053380 $Y=951060
X3420 4284 1 2 4207 INV3CK $T=1057720 1032080 0 180 $X=1054620 $Y=1026660
X3421 2756 1 2 2763 BUF1CK $T=598920 911120 1 0 $X=598920 $Y=905700
X3422 3026 1 2 3028 BUF1CK $T=688200 991760 0 0 $X=688200 $Y=991380
X3423 3045 1 2 3049 BUF1CK $T=694400 931280 1 0 $X=694400 $Y=925860
X3424 3047 1 2 3046 BUF1CK $T=695640 1001840 1 0 $X=695640 $Y=996420
X3425 3094 1 2 3110 BUF1CK $T=709280 991760 0 0 $X=709280 $Y=991380
X3426 3142 1 2 3151 BUF1CK $T=719200 991760 0 0 $X=719200 $Y=991380
X3427 3148 1 2 3153 BUF1CK $T=721060 941360 0 0 $X=721060 $Y=940980
X3428 3237 1 2 3249 BUF1CK $T=752680 991760 1 0 $X=752680 $Y=986340
X3429 3351 1 2 3364 BUF1CK $T=773760 931280 1 0 $X=773760 $Y=925860
X3430 4261 1 2 4264 BUF1CK $T=1037260 890960 1 0 $X=1037260 $Y=885540
X3431 4310 1 2 4290 BUF1CK $T=1053380 931280 1 0 $X=1053380 $Y=925860
X3432 689 3217 3268 1 2 705 3217 3204 1021 ICV_5 $T=742140 921200 0 180 $X=731600 $Y=915780
X3433 833 830 3629 1 2 833 829 3564 1021 ICV_5 $T=838240 911120 0 180 $X=827700 $Y=905700
X3434 824 3601 3642 1 2 3583 3599 3576 1021 ICV_5 $T=842580 1022000 0 180 $X=832040 $Y=1016580
X3435 3583 3601 3652 1 2 831 3601 3579 1021 ICV_5 $T=843200 1001840 0 180 $X=832660 $Y=996420
X3436 842 3601 3665 1 2 831 3607 3588 1021 ICV_5 $T=845060 991760 0 180 $X=834520 $Y=986340
X3437 824 3616 3671 1 2 3583 3616 3591 1021 ICV_5 $T=846300 971600 0 180 $X=835760 $Y=966180
X3438 833 3601 3721 1 2 3583 854 3631 1021 ICV_5 $T=857460 1042160 1 180 $X=846920 $Y=1041780
X3439 867 3607 3723 1 2 842 3607 3679 1021 ICV_5 $T=869860 991760 0 180 $X=859320 $Y=986340
X3440 3720 3599 3769 1 2 867 3599 3711 1021 ICV_5 $T=877920 971600 0 180 $X=867380 $Y=966180
X3441 877 829 3775 1 2 833 844 3707 1021 ICV_5 $T=879160 911120 1 180 $X=868620 $Y=910740
X3442 3720 846 3799 1 2 864 3607 3718 1021 ICV_5 $T=890320 1032080 0 180 $X=879780 $Y=1026660
X3443 3845 3601 3882 1 2 890 3601 3841 1021 ICV_5 $T=921940 991760 1 180 $X=911400 $Y=991380
X3444 3845 846 3909 1 2 890 846 3854 1021 ICV_5 $T=925660 1011920 1 180 $X=915120 $Y=1011540
X3445 3502 3944 3982 1 2 894 3590 3913 1021 ICV_5 $T=941780 981680 1 180 $X=931240 $Y=981300
X3446 3502 3947 3992 1 2 894 3601 3925 1021 ICV_5 $T=947980 991760 0 180 $X=937440 $Y=986340
X3447 3952 945 4060 1 2 3952 928 3969 1021 ICV_5 $T=961620 921200 1 180 $X=951080 $Y=920820
X3448 799 3938 4104 1 2 921 4055 4036 1021 ICV_5 $T=977740 961520 1 180 $X=967200 $Y=961140
X3449 798 3938 4175 1 2 3691 938 4118 1021 ICV_5 $T=1001300 961520 0 180 $X=990760 $Y=956100
X3450 798 3944 4203 1 2 951 3944 4144 1021 ICV_5 $T=1009980 961520 1 180 $X=999440 $Y=961140
X3451 808 926 4242 1 2 798 926 4150 1021 ICV_5 $T=1018660 901040 1 180 $X=1008120 $Y=900660
X3452 983 4055 4267 1 2 968 3944 4219 1021 ICV_5 $T=1032300 1001840 1 180 $X=1021760 $Y=1001460
X3453 983 926 4293 1 2 968 926 4218 1021 ICV_5 $T=1039740 931280 1 180 $X=1029200 $Y=930900
X3454 1794 1 2 231 BUF1S $T=384400 880880 0 0 $X=384400 $Y=880500
X3455 2800 1 2 2790 BUF1S $T=611320 911120 0 0 $X=611320 $Y=910740
X3456 3048 1 2 3054 BUF1S $T=696880 890960 1 0 $X=696880 $Y=885540
X3457 3072 1 2 3085 BUF1S $T=703700 890960 1 0 $X=703700 $Y=885540
X3458 3074 1 2 3087 BUF1S $T=703700 890960 0 0 $X=703700 $Y=890580
X3459 3095 1 2 3090 BUF1S $T=708040 1001840 1 0 $X=708040 $Y=996420
X3460 3125 1 2 3132 BUF1S $T=713620 921200 0 0 $X=713620 $Y=920820
X3461 3143 1 2 720 BUF1S $T=718580 931280 1 0 $X=718580 $Y=925860
X3462 3199 1 2 728 BUF1S $T=731600 901040 0 0 $X=731600 $Y=900660
X3463 3223 1 2 650 BUF1S $T=739040 951440 1 0 $X=739040 $Y=946020
X3464 3246 1 2 689 BUF1S $T=743380 901040 0 0 $X=743380 $Y=900660
X3465 3271 1 2 2927 BUF1S $T=752060 971600 1 0 $X=752060 $Y=966180
X3466 3270 1 2 687 BUF1S $T=754540 971600 0 0 $X=754540 $Y=971220
X3467 3283 1 2 692 BUF1S $T=755780 951440 1 0 $X=755780 $Y=946020
X3468 3294 1 2 701 BUF1S $T=758260 931280 1 0 $X=758260 $Y=925860
X3469 3321 1 2 3337 BUF1S $T=766320 971600 1 0 $X=766320 $Y=966180
X3470 3349 1 2 747 BUF1S $T=773140 890960 0 0 $X=773140 $Y=890580
X3471 3365 1 2 737 BUF1S $T=776240 941360 1 0 $X=776240 $Y=935940
X3472 3424 1 2 3453 BUF1S $T=794840 971600 1 0 $X=794840 $Y=966180
X3473 783 1 2 767 BUF1S $T=798560 880880 0 0 $X=798560 $Y=880500
X3474 3526 1 2 809 BUF1S $T=816540 921200 0 0 $X=816540 $Y=920820
X3475 861 1 2 831 BUF1S $T=858080 921200 1 0 $X=858080 $Y=915780
X3476 869 1 2 3583 BUF1S $T=866760 911120 1 0 $X=866760 $Y=905700
X3477 871 1 2 3720 BUF1S $T=868000 901040 0 0 $X=868000 $Y=900660
X3478 882 1 2 833 BUF1S $T=884740 880880 0 0 $X=884740 $Y=880500
X3479 896 1 2 885 BUF1S $T=902720 890960 1 0 $X=902720 $Y=885540
X3480 905 1 2 906 BUF1S $T=916980 880880 0 0 $X=916980 $Y=880500
X3481 3959 1 2 3952 BUF1S $T=951700 921200 1 0 $X=951700 $Y=915780
X3482 4148 1 2 3985 BUF1S $T=1000680 890960 0 0 $X=1000680 $Y=890580
X3483 3558 1 2 983 BUF1S $T=1024860 911120 0 0 $X=1024860 $Y=910740
X3484 687 3104 3120 1 2 701 2999 3142 1021 ICV_6 $T=708040 991760 1 0 $X=708040 $Y=986340
X3485 705 3016 3140 1 2 701 3016 3154 1021 ICV_6 $T=710520 1011920 0 0 $X=710520 $Y=1011540
X3486 651 3104 3173 1 2 651 3188 3187 1021 ICV_6 $T=718580 981680 0 0 $X=718580 $Y=981300
X3487 644 3188 3212 1 2 692 3188 3221 1021 ICV_6 $T=727260 941360 0 0 $X=727260 $Y=940980
X3488 2927 3188 3220 1 2 2927 3217 3225 1021 ICV_6 $T=730980 971600 1 0 $X=730980 $Y=966180
X3489 747 2931 3326 1 2 747 2923 3328 1021 ICV_6 $T=757640 1042160 1 0 $X=757640 $Y=1036740
X3490 3342 645 3385 1 2 3342 656 3390 1021 ICV_6 $T=770660 1052240 0 0 $X=770660 $Y=1051860
X3491 779 2939 3515 1 2 831 829 3554 1021 ICV_6 $T=815300 951440 1 0 $X=815300 $Y=946020
X3492 831 3590 3621 1 2 831 3599 3625 1021 ICV_6 $T=835140 981680 1 0 $X=835140 $Y=976260
X3493 831 3584 3620 1 2 842 3616 3627 1021 ICV_6 $T=835760 951440 0 0 $X=835760 $Y=951060
X3494 831 844 3726 1 2 833 873 3719 1021 ICV_6 $T=862420 921200 1 0 $X=862420 $Y=915780
X3495 867 854 3758 1 2 867 846 3752 1021 ICV_6 $T=872960 1022000 1 0 $X=872960 $Y=1016580
X3496 3720 854 3823 1 2 890 854 3836 1021 ICV_6 $T=896520 1022000 1 0 $X=896520 $Y=1016580
X3497 890 830 3851 1 2 3845 829 3860 1021 ICV_6 $T=905200 951440 0 0 $X=905200 $Y=951060
X3498 923 935 4025 1 2 3952 935 4032 1021 ICV_6 $T=955420 941360 1 0 $X=955420 $Y=935940
X3499 3502 4010 4049 1 2 921 4010 4058 1021 ICV_6 $T=959760 981680 1 0 $X=959760 $Y=976260
X3500 951 959 4179 1 2 3691 959 4190 1021 ICV_6 $T=1005020 911120 1 0 $X=1005020 $Y=905700
X3501 808 4055 4239 1 2 808 4010 4228 1021 ICV_6 $T=1018040 1001840 1 0 $X=1018040 $Y=996420
X3502 2765 1 2 614 DELB $T=602640 880880 0 0 $X=602640 $Y=880500
X3503 2795 1 2 2802 DELB $T=610700 931280 1 0 $X=610700 $Y=925860
X3504 2772 1 2 2769 DELB $T=613180 921200 1 0 $X=613180 $Y=915780
X3505 2824 1 2 2831 DELB $T=619380 901040 1 0 $X=619380 $Y=895620
X3506 2837 1 2 2855 DELB $T=626200 901040 0 0 $X=626200 $Y=900660
X3507 2917 1 2 2887 DELB $T=648520 880880 0 0 $X=648520 $Y=880500
X3508 2908 1 2 2883 DELB $T=648520 890960 0 0 $X=648520 $Y=890580
X3509 2919 1 2 2886 DELB $T=649760 911120 1 0 $X=649760 $Y=905700
X3510 655 1 2 2953 DELB $T=659060 890960 0 0 $X=659060 $Y=890580
X3511 676 1 2 2969 DELB $T=670220 911120 0 0 $X=670220 $Y=910740
X3512 697 1 2 3012 DELB $T=683240 911120 0 0 $X=683240 $Y=910740
X3513 700 1 2 3017 DELB $T=685720 911120 1 0 $X=685720 $Y=905700
X3514 710 1 2 3038 DELB $T=708660 890960 1 0 $X=708660 $Y=885540
X3515 3219 1 2 651 DELB $T=737800 981680 1 0 $X=737800 $Y=976260
X3516 3273 1 2 644 DELB $T=752060 931280 1 0 $X=752060 $Y=925860
X3517 3478 1 2 799 DELB $T=806620 901040 0 0 $X=806620 $Y=900660
X3518 3504 1 2 3528 DELB $T=811580 951440 0 0 $X=811580 $Y=951060
X3519 4161 1 2 3539 DELB $T=1003160 890960 0 0 $X=1003160 $Y=890580
X3520 20 2 1 130 BUF1 $T=316820 901040 1 0 $X=316820 $Y=895620
X3521 1699 2 1 1581 BUF1 $T=362080 911120 1 180 $X=359600 $Y=910740
X3522 254 2 1 265 BUF1 $T=414780 901040 1 0 $X=414780 $Y=895620
X3523 2086 2 1 370 BUF1 $T=456940 951440 1 0 $X=456940 $Y=946020
X3524 2247 2 1 304 BUF1 $T=484220 1011920 0 0 $X=484220 $Y=1011540
X3525 1945 2 1 440 BUF1 $T=497240 1001840 1 0 $X=497240 $Y=996420
X3526 20 2 1 2791 BUF1 $T=610080 951440 1 0 $X=610080 $Y=946020
X3527 3123 2 1 721 BUF1 $T=738420 890960 1 0 $X=738420 $Y=885540
X3528 3227 2 1 3223 BUF1 $T=741520 951440 1 180 $X=739040 $Y=951060
X3529 3257 2 1 705 BUF1 $T=744000 901040 0 180 $X=741520 $Y=895620
X3530 3248 2 1 3219 BUF1 $T=745860 961520 0 180 $X=743380 $Y=956100
X3531 3260 2 1 3271 BUF1 $T=747100 961520 1 0 $X=747100 $Y=956100
X3532 3275 2 1 3273 BUF1 $T=754540 931280 1 180 $X=752060 $Y=930900
X3533 3279 2 1 3270 BUF1 $T=754540 961520 0 180 $X=752060 $Y=956100
X3534 751 2 1 3246 BUF1 $T=757640 911120 0 180 $X=755160 $Y=905700
X3535 3285 2 1 3283 BUF1 $T=757640 921200 1 180 $X=755160 $Y=920820
X3536 3298 2 1 3294 BUF1 $T=760740 911120 0 180 $X=758260 $Y=905700
X3537 3305 2 1 690 BUF1 $T=763220 911120 0 180 $X=760740 $Y=905700
X3538 3330 2 1 736 BUF1 $T=768800 931280 1 180 $X=766320 $Y=930900
X3539 3363 2 1 3349 BUF1 $T=778100 890960 1 180 $X=775620 $Y=890580
X3540 3375 2 1 3342 BUF1 $T=778720 901040 1 0 $X=778720 $Y=895620
X3541 3399 2 1 3365 BUF1 $T=783060 931280 1 180 $X=780580 $Y=930900
X3542 3426 2 1 789 BUF1 $T=799180 901040 1 0 $X=799180 $Y=895620
X3543 3454 2 1 778 BUF1 $T=801660 880880 0 0 $X=801660 $Y=880500
X3544 791 2 1 779 BUF1 $T=803520 890960 0 0 $X=803520 $Y=890580
X3545 793 2 1 3478 BUF1 $T=805380 880880 0 0 $X=805380 $Y=880500
X3546 3449 2 1 798 BUF1 $T=807240 890960 0 0 $X=807240 $Y=890580
X3547 3344 2 1 3502 BUF1 $T=809720 890960 0 0 $X=809720 $Y=890580
X3548 3421 2 1 805 BUF1 $T=812200 890960 0 0 $X=812200 $Y=890580
X3549 3304 2 1 808 BUF1 $T=815300 890960 1 0 $X=815300 $Y=885540
X3550 2972 2 1 816 BUF1 $T=821500 941360 0 0 $X=821500 $Y=940980
X3551 3362 2 1 815 BUF1 $T=822120 901040 1 0 $X=822120 $Y=895620
X3552 819 2 1 672 BUF1 $T=827080 1052240 0 180 $X=824600 $Y=1046820
X3553 817 2 1 3557 BUF1 $T=825220 880880 0 0 $X=825220 $Y=880500
X3554 3313 2 1 3558 BUF1 $T=825220 911120 1 0 $X=825220 $Y=905700
X3555 3561 2 1 3037 BUF1 $T=827700 981680 0 180 $X=825220 $Y=976260
X3556 3112 2 1 826 BUF1 $T=831420 941360 1 0 $X=831420 $Y=935940
X3557 2984 2 1 827 BUF1 $T=831420 941360 0 0 $X=831420 $Y=940980
X3558 3581 2 1 3035 BUF1 $T=835140 981680 0 180 $X=832660 $Y=976260
X3559 2970 2 1 836 BUF1 $T=834520 941360 0 0 $X=834520 $Y=940980
X3560 2979 2 1 3597 BUF1 $T=836380 991760 0 0 $X=836380 $Y=991380
X3561 3593 2 1 2937 BUF1 $T=840720 981680 1 180 $X=838240 $Y=981300
X3562 3206 2 1 840 BUF1 $T=840720 921200 0 0 $X=840720 $Y=920820
X3563 3587 2 1 2935 BUF1 $T=840720 981680 0 0 $X=840720 $Y=981300
X3564 3582 2 1 695 BUF1 $T=845060 1042160 0 180 $X=842580 $Y=1036740
X3565 848 2 1 694 BUF1 $T=851880 1052240 1 180 $X=849400 $Y=1051860
X3566 2981 2 1 3645 BUF1 $T=851260 991760 0 0 $X=851260 $Y=991380
X3567 3107 2 1 850 BUF1 $T=852500 931280 0 0 $X=852500 $Y=930900
X3568 3211 2 1 857 BUF1 $T=854360 921200 0 0 $X=854360 $Y=920820
X3569 3287 2 1 3691 BUF1 $T=857460 901040 0 0 $X=857460 $Y=900660
X3570 3574 2 1 663 BUF1 $T=896520 1022000 0 180 $X=894040 $Y=1016580
X3571 903 2 1 3845 BUF1 $T=914500 901040 0 0 $X=914500 $Y=900660
X3572 3343 2 1 923 BUF1 $T=936200 901040 0 0 $X=936200 $Y=900660
X3573 3292 2 1 3959 BUF1 $T=947360 921200 1 0 $X=947360 $Y=915780
X3574 3301 2 1 968 BUF1 $T=987040 911120 1 0 $X=987040 $Y=905700
X3575 1809 2 1 214 BUF3 $T=370760 880880 1 180 $X=367040 $Y=880500
X3576 2875 2 1 712 BUF3 $T=706800 890960 0 0 $X=706800 $Y=890580
X3577 3845 2 1 3907 BUF3 $T=931240 931280 0 0 $X=931240 $Y=930900
X3578 772 3398 1 2 INV8CK $T=780580 880880 0 0 $X=780580 $Y=880500
X3579 3429 3443 1 2 INV8CK $T=791740 1052240 0 0 $X=791740 $Y=1051860
X3580 781 3445 1 2 INV8CK $T=792360 890960 0 0 $X=792360 $Y=890580
X3581 3511 2931 1 2 INV8CK $T=812820 1032080 0 180 $X=806000 $Y=1026660
X3582 3496 3377 1 2 INV8CK $T=810340 1011920 0 0 $X=810340 $Y=1011540
X3583 3549 3447 1 2 INV8CK $T=825220 971600 0 0 $X=825220 $Y=971220
X3584 3600 3614 1 2 INV8CK $T=840720 991760 0 0 $X=840720 $Y=991380
X3585 3609 3615 1 2 INV8CK $T=842580 1052240 0 0 $X=842580 $Y=1051860
X3586 3684 3689 1 2 INV8CK $T=860560 941360 0 0 $X=860560 $Y=940980
X3587 3674 3709 1 2 INV8CK $T=861180 981680 0 0 $X=861180 $Y=981300
X3588 3689 3599 1 2 INV8CK $T=882880 971600 1 180 $X=876060 $Y=971220
X3589 3674 3917 1 2 INV8CK $T=933720 991760 0 180 $X=926900 $Y=986340
X3590 1357 210 1163 2 1153 1735 1 AO22 $T=365180 1011920 0 180 $X=360220 $Y=1006500
X3591 2756 611 2749 2 2737 615 1 AO22 $T=601400 911120 1 0 $X=601400 $Y=905700
X3592 2772 611 2743 2 2750 615 1 AO22 $T=602640 931280 1 0 $X=602640 $Y=925860
X3593 2765 611 2792 2 2781 615 1 AO22 $T=607600 880880 0 0 $X=607600 $Y=880500
X3594 2795 611 2804 2 2809 615 1 AO22 $T=615660 931280 1 0 $X=615660 $Y=925860
X3595 2801 611 2825 2 2838 615 1 AO22 $T=620000 921200 1 0 $X=620000 $Y=915780
X3596 2824 611 2844 2 2850 615 1 AO22 $T=624340 901040 1 0 $X=624340 $Y=895620
X3597 2879 611 2874 2 2869 615 1 AO22 $T=637360 931280 0 180 $X=632400 $Y=925860
X3598 2941 611 2918 2 2922 615 1 AO22 $T=656580 921200 0 180 $X=651620 $Y=915780
X3599 2932 611 2897 2 2912 615 1 AO22 $T=658440 890960 1 180 $X=653480 $Y=890580
X3600 722 721 3156 2 3153 719 1 AO22 $T=724780 941360 0 180 $X=719820 $Y=935940
X3601 3143 721 3155 2 3166 719 1 AO22 $T=720440 931280 0 0 $X=720440 $Y=930900
X3602 3192 721 3185 2 3176 719 1 AO22 $T=730980 941360 0 180 $X=726020 $Y=935940
X3603 726 721 3189 2 3182 719 1 AO22 $T=732220 931280 1 180 $X=727260 $Y=930900
X3604 725 3123 3202 2 3203 719 1 AO22 $T=730360 890960 1 0 $X=730360 $Y=885540
X3605 3199 721 3213 2 3181 719 1 AO22 $T=739040 901040 1 180 $X=734080 $Y=900660
X3606 733 721 3214 2 3157 719 1 AO22 $T=739040 931280 0 180 $X=734080 $Y=925860
X3607 3240 3123 3247 2 3243 719 1 AO22 $T=742760 880880 0 0 $X=742760 $Y=880500
X3608 743 721 3259 2 3099 719 1 AO22 $T=750200 941360 0 180 $X=745240 $Y=935940
X3609 3526 721 3538 2 3542 719 1 AO22 $T=820880 921200 0 0 $X=820880 $Y=920820
X3610 820 721 3556 2 3233 719 1 AO22 $T=829560 901040 0 180 $X=824600 $Y=895620
X3611 823 721 3569 2 3477 719 1 AO22 $T=832660 880880 1 180 $X=827700 $Y=880500
X3612 837 721 3575 2 3452 719 1 AO22 $T=835140 921200 1 180 $X=830180 $Y=920820
X3613 821 721 3578 2 3473 719 1 AO22 $T=831420 890960 0 0 $X=831420 $Y=890580
X3614 3528 719 814 3539 2 1 MXL2HS $T=818400 890960 0 0 $X=818400 $Y=890580
X3615 2987 1 2 2997 DELA $T=673940 880880 0 0 $X=673940 $Y=880500
X3616 3009 1 2 3019 DELA $T=682000 890960 0 0 $X=682000 $Y=890580
X3617 2995 1 2 3056 DELA $T=694400 901040 1 0 $X=694400 $Y=895620
X3618 3041 1 2 3078 DELA $T=700600 911120 1 0 $X=700600 $Y=905700
X3619 3080 1 2 3086 DELA $T=707420 981680 0 0 $X=707420 $Y=981300
X3620 3109 1 2 3131 DELA $T=711140 890960 0 0 $X=711140 $Y=890580
X3621 3139 1 2 3157 DELA $T=717960 951440 0 0 $X=717960 $Y=951060
X3622 3163 1 2 3182 DELA $T=722920 951440 0 0 $X=722920 $Y=951060
X3623 3192 1 2 3191 DELA $T=732220 931280 0 0 $X=732220 $Y=930900
X3624 731 1 2 3234 DELA $T=736560 880880 0 0 $X=736560 $Y=880500
X3625 741 1 2 3256 DELA $T=748960 890960 1 0 $X=748960 $Y=885540
X3626 3240 1 2 757 DELA $T=757020 880880 0 0 $X=757020 $Y=880500
X3627 758 1 2 760 DELA $T=761980 880880 0 0 $X=761980 $Y=880500
X3628 773 1 2 3378 DELA $T=780580 890960 0 0 $X=780580 $Y=890580
X3629 3386 1 2 3422 DELA $T=781200 971600 1 0 $X=781200 $Y=966180
X3630 3403 1 2 3375 DELA $T=784920 901040 0 0 $X=784920 $Y=900660
X3631 790 1 2 792 DELA $T=801040 901040 0 0 $X=801040 $Y=900660
X3632 3498 1 2 3476 DELA $T=813440 941360 0 0 $X=813440 $Y=940980
X3633 1295 1089 20 2 1 1224 QDFFRBN $T=270320 911120 0 180 $X=258540 $Y=905700
X3634 1236 1089 20 2 1 75 QDFFRBN $T=262880 901040 0 0 $X=262880 $Y=900660
X3635 1271 1089 20 2 1 1396 QDFFRBN $T=275280 901040 0 0 $X=275280 $Y=900660
X3636 1492 1089 20 2 1 1434 QDFFRBN $T=305040 901040 1 180 $X=293260 $Y=900660
X3637 1476 1089 130 2 1 137 QDFFRBN $T=300080 901040 1 0 $X=300080 $Y=895620
X3638 1550 1089 130 2 1 1675 QDFFRBN $T=316200 901040 0 0 $X=316200 $Y=900660
X3639 1618 1089 130 2 1 1660 QDFFRBN $T=329840 911120 1 0 $X=329840 $Y=905700
X3640 1487 1089 130 2 1 1688 QDFFRBN $T=334800 901040 1 0 $X=334800 $Y=895620
X3641 1672 1089 130 2 1 173 QDFFRBN $T=347820 890960 0 180 $X=336040 $Y=885540
X3642 1687 1089 130 2 1 184 QDFFRBN $T=355880 901040 1 180 $X=344100 $Y=900660
X3643 1717 1089 130 2 1 1794 QDFFRBN $T=358980 890960 1 0 $X=358980 $Y=885540
X3644 2763 608 2791 2 1 2800 QDFFRBN $T=599540 911120 0 0 $X=599540 $Y=910740
X3645 2769 608 616 2 1 2796 QDFFRBN $T=601400 921200 1 0 $X=601400 $Y=915780
X3646 2831 608 616 2 1 2799 QDFFRBN $T=622480 901040 1 180 $X=610700 $Y=900660
X3647 2801 608 616 2 1 2837 QDFFRBN $T=610700 911120 1 0 $X=610700 $Y=905700
X3648 2802 608 2791 2 1 2818 QDFFRBN $T=610700 941360 1 0 $X=610700 $Y=935940
X3649 2778 2826 2791 2 1 2863 QDFFRBN $T=618140 951440 1 0 $X=618140 $Y=946020
X3650 2766 2826 2791 2 1 2875 QDFFRBN $T=621240 941360 0 0 $X=621240 $Y=940980
X3651 625 2826 2791 2 1 2882 QDFFRBN $T=623100 951440 0 0 $X=623100 $Y=951060
X3652 2879 608 2791 2 1 2841 QDFFRBN $T=636120 941360 0 180 $X=624340 $Y=935940
X3653 2860 2826 2791 2 1 2901 QDFFRBN $T=629300 971600 1 0 $X=629300 $Y=966180
X3654 634 2826 2791 2 1 2903 QDFFRBN $T=633640 951440 1 0 $X=633640 $Y=946020
X3655 2867 2826 2791 2 1 2913 QDFFRBN $T=636740 941360 0 0 $X=636740 $Y=940980
X3656 2721 2826 2791 2 1 2928 QDFFRBN $T=639220 931280 0 0 $X=639220 $Y=930900
X3657 2893 2826 2791 2 1 647 QDFFRBN $T=641080 961520 1 0 $X=641080 $Y=956100
X3658 2888 2826 2791 2 1 2924 QDFFRBN $T=641700 951440 0 0 $X=641700 $Y=951060
X3659 2905 2826 2791 2 1 2933 QDFFRBN $T=645420 971600 1 0 $X=645420 $Y=966180
X3660 2932 652 616 2 1 2908 QDFFRBN $T=659060 901040 0 180 $X=647280 $Y=895620
X3661 2941 652 616 2 1 2919 QDFFRBN $T=662160 911120 1 180 $X=650380 $Y=910740
X3662 2755 2826 2791 2 1 2943 QDFFRBN $T=651620 931280 1 0 $X=651620 $Y=925860
X3663 2906 2826 2791 2 1 660 QDFFRBN $T=651620 981680 0 0 $X=651620 $Y=981300
X3664 2942 652 616 2 1 2917 QDFFRBN $T=664020 890960 0 180 $X=652240 $Y=885540
X3665 2925 2826 2791 2 1 2961 QDFFRBN $T=653480 981680 1 0 $X=653480 $Y=976260
X3666 2953 664 616 2 1 2995 QDFFRBN $T=664020 890960 0 0 $X=664020 $Y=890580
X3667 666 664 616 2 1 2987 QDFFRBN $T=665880 890960 1 0 $X=665880 $Y=885540
X3668 2969 664 616 2 1 3009 QDFFRBN $T=668980 901040 1 0 $X=668980 $Y=895620
X3669 688 664 616 2 1 702 QDFFRBN $T=678900 880880 0 0 $X=678900 $Y=880500
X3670 3012 664 616 2 1 3041 QDFFRBN $T=682620 901040 1 0 $X=682620 $Y=895620
X3671 3017 664 616 2 1 3048 QDFFRBN $T=685100 890960 1 0 $X=685100 $Y=885540
X3672 3038 664 616 2 1 3072 QDFFRBN $T=691920 880880 0 0 $X=691920 $Y=880500
X3673 703 664 616 2 1 3074 QDFFRBN $T=691920 890960 0 0 $X=691920 $Y=890580
X3674 715 664 616 2 1 3109 QDFFRBN $T=716100 890960 0 0 $X=716100 $Y=890580
X3675 715 664 616 2 1 3183 QDFFRBN $T=716100 901040 1 0 $X=716100 $Y=895620
X3676 3191 723 616 2 1 718 QDFFRBN $T=731600 880880 1 180 $X=719820 $Y=880500
X3677 715 664 732 2 1 3235 QDFFRBN $T=729120 890960 0 0 $X=729120 $Y=890580
X3678 715 664 732 2 1 3232 QDFFRBN $T=729740 901040 1 0 $X=729740 $Y=895620
X3679 1080 1089 20 25 1 2 QDFFRBP $T=231880 901040 0 0 $X=231880 $Y=900660
X3680 1579 1089 130 170 1 2 QDFFRBP $T=321780 901040 1 0 $X=321780 $Y=895620
X3681 1655 1089 130 159 1 2 QDFFRBP $T=337900 890960 1 180 $X=325500 $Y=890580
X3682 1704 1089 130 212 1 2 QDFFRBP $T=351540 890960 0 0 $X=351540 $Y=890580
X3683 2840 2826 2791 638 1 2 QDFFRBP $T=624340 961520 1 0 $X=624340 $Y=956100
X3684 2891 2826 2791 646 1 2 QDFFRBP $T=639840 971600 0 0 $X=639840 $Y=971220
X3685 724 723 616 714 1 2 QDFFRBP $T=728500 890960 0 180 $X=716100 $Y=885540
X3686 708 707 3123 717 2 1 713 XOR4 $T=704940 880880 0 0 $X=704940 $Y=880500
X3687 2924 1 2 673 BUF12CK $T=663400 921200 1 0 $X=663400 $Y=915780
X3688 2927 1 2 2909 BUF12CK $T=679520 1022000 0 0 $X=679520 $Y=1021620
X3689 1660 191 1 2 BUF2 $T=341000 890960 0 0 $X=341000 $Y=890580
X3690 2791 616 1 2 BUF2 $T=647900 921200 1 180 $X=644800 $Y=920820
X3691 2882 649 1 2 BUF2 $T=650380 921200 0 0 $X=650380 $Y=920820
X3692 2903 653 1 2 BUF2 $T=654720 901040 0 0 $X=654720 $Y=900660
X3693 2933 658 1 2 BUF2 $T=659060 921200 0 0 $X=659060 $Y=920820
X3694 2863 665 1 2 BUF2 $T=664020 911120 1 0 $X=664020 $Y=905700
X3695 2938 679 1 2 BUF2 $T=664020 931280 0 0 $X=664020 $Y=930900
X3696 2913 681 1 2 BUF2 $T=667740 901040 0 0 $X=667740 $Y=900660
X3697 2945 682 1 2 BUF6 $T=667120 921200 0 0 $X=667120 $Y=920820
X3698 1434 132 1 2 INV3 $T=306280 901040 0 0 $X=306280 $Y=900660
X3699 2928 667 1 2 INV3 $T=664640 901040 1 180 $X=662160 $Y=900660
X3700 1769 236 1 2 BUF4 $T=375720 890960 1 0 $X=375720 $Y=885540
X3701 2947 659 1 2 BUF4 $T=664640 901040 0 180 $X=660300 $Y=895620
X3702 1724 1089 130 1769 1 2 4404 DFFSBN $T=356500 901040 1 0 $X=356500 $Y=895620
X3703 1736 1089 130 217 1 2 4405 DFFSBN $T=359600 901040 0 0 $X=359600 $Y=900660
X3704 1765 1089 130 1809 1 2 4406 DFFSBN $T=367660 890960 0 0 $X=367660 $Y=890580
X3705 2508 2826 2791 2938 1 2 4407 DFFSBN $T=649140 951440 1 0 $X=649140 $Y=946020
X3706 2344 2826 2791 2945 1 2 4408 DFFSBN $T=652240 941360 0 0 $X=652240 $Y=940980
X3707 2326 2826 2791 2947 1 2 4409 DFFSBN $T=652860 941360 1 0 $X=652860 $Y=935940
X3708 1813 1859 1848 2 1 1863 OR3 $T=395560 961520 1 0 $X=395560 $Y=956100
X3709 345 348 2164 2 1 2171 OR3 $T=473060 901040 1 180 $X=469340 $Y=900660
X3710 327 2241 2146 2 1 2230 OR3 $T=485460 911120 1 180 $X=481740 $Y=910740
X3711 387 1990 2227 2 1 2194 OR3 $T=488560 1032080 1 180 $X=484840 $Y=1031700
X3712 2071 1945 2294 2 1 2235 OR3 $T=497240 1001840 0 180 $X=493520 $Y=996420
X3713 2119 357 2140 2 1 2328 OR3 $T=497240 1001840 0 0 $X=497240 $Y=1001460
X3714 2507 416 2352 2 1 2486 OR3 $T=538780 921200 0 180 $X=535060 $Y=915780
X3715 2894 2870 2814 2 1 2899 OR3 $T=641080 1001840 0 0 $X=641080 $Y=1001460
X3716 2768 2 2790 609 2760 1 2737 FA1S $T=606980 890960 1 180 $X=595200 $Y=890580
X3717 2771 2 2796 2787 2776 1 2743 FA1S $T=608220 931280 1 180 $X=596440 $Y=930900
X3718 2775 2 2790 2774 2771 1 2749 FA1S $T=609460 901040 0 180 $X=597680 $Y=895620
X3719 2760 2 2796 613 2782 1 2750 FA1S $T=609460 921200 1 180 $X=597680 $Y=920820
X3720 2808 2 617 621 2768 1 2781 FA1S $T=617520 890960 0 180 $X=605740 $Y=885540
X3721 2817 2 617 623 2775 1 2792 FA1S $T=620000 890960 1 180 $X=608220 $Y=890580
X3722 2776 2 2818 2811 2832 1 2804 FA1S $T=623720 931280 1 180 $X=611940 $Y=930900
X3723 2782 2 2818 620 2834 1 2809 FA1S $T=624960 921200 1 180 $X=613180 $Y=920820
X3724 2836 2 2799 629 2808 1 2850 FA1S $T=618140 880880 0 0 $X=618140 $Y=880500
X3725 2829 2 2799 624 2817 1 2844 FA1S $T=619380 890960 1 0 $X=619380 $Y=885540
X3726 2846 2 2855 2843 2829 1 2825 FA1S $T=631160 911120 1 180 $X=619380 $Y=910740
X3727 2858 2 2855 626 2836 1 2838 FA1S $T=624960 911120 1 0 $X=624960 $Y=905700
X3728 2885 2 2883 2868 2890 1 2897 FA1S $T=633020 901040 1 0 $X=633020 $Y=895620
X3729 2890 2 2886 2881 2846 1 2918 FA1S $T=635500 911120 0 0 $X=635500 $Y=910740
X3730 640 2 2887 633 2889 1 2911 FA1S $T=636740 880880 0 0 $X=636740 $Y=880500
X3731 2889 2 2883 632 2902 1 2912 FA1S $T=636740 890960 0 0 $X=636740 $Y=890580
X3732 641 2 2887 2873 2885 1 2920 FA1S $T=637980 890960 1 0 $X=637980 $Y=885540
X3733 2902 2 2886 639 2858 1 2922 FA1S $T=640460 901040 0 0 $X=640460 $Y=900660
X3734 1453 1478 1487 2 1 XNR2HS $T=299460 1011920 0 0 $X=299460 $Y=1011540
X3735 1680 1478 1717 2 1 XNR2HS $T=351540 911120 0 0 $X=351540 $Y=910740
X3736 1703 1478 1655 2 1 XNR2HS $T=352160 911120 1 0 $X=352160 $Y=905700
X3737 595 2058 2721 2 1 XNR2HS $T=586520 941360 0 0 $X=586520 $Y=940980
X3738 2735 2058 2755 2 1 XNR2HS $T=595820 941360 1 0 $X=595820 $Y=935940
X3739 2706 2058 2766 2 1 XNR2HS $T=597680 951440 1 0 $X=597680 $Y=946020
X3740 2880 2859 2874 2 1 XNR2HS $T=635500 921200 0 0 $X=635500 $Y=920820
X3741 1845 1829 1841 2 1 XOR2HS $T=393080 921200 0 180 $X=387500 $Y=915780
X3742 1871 1874 1879 2 1 XOR2HS $T=399280 921200 0 0 $X=399280 $Y=920820
X3743 1860 1877 1875 2 1 XOR2HS $T=405480 901040 1 180 $X=399900 $Y=900660
X3744 1873 1885 1884 2 1 XOR2HS $T=406100 890960 1 0 $X=406100 $Y=885540
X3745 1887 1891 1898 2 1 XOR2HS $T=407960 921200 1 0 $X=407960 $Y=915780
X3746 1899 1880 1894 2 1 XOR2HS $T=413540 921200 1 180 $X=407960 $Y=920820
X3747 1897 1907 1901 2 1 XOR2HS $T=416640 941360 0 180 $X=411060 $Y=935940
X3748 1900 1903 1905 2 1 XOR2HS $T=411680 901040 0 0 $X=411680 $Y=900660
X3749 1932 1926 1921 2 1 XOR2HS $T=422840 971600 0 180 $X=417260 $Y=966180
X3750 1949 1946 1969 2 1 XOR2HS $T=425940 941360 0 0 $X=425940 $Y=940980
X3751 1959 1976 1986 2 1 XOR2HS $T=437720 931280 0 180 $X=432140 $Y=925860
X3752 2026 2020 2044 2 1 XOR2HS $T=441440 941360 0 0 $X=441440 $Y=940980
X3753 627 2859 2869 2 1 XOR2HS $T=630540 931280 0 0 $X=630540 $Y=930900
X3754 2578 2499 526 2548 2 1 2555 OA112S $T=550560 1001840 0 180 $X=545600 $Y=996420
X3755 591 470 526 2562 2 1 2725 OA112S $T=586520 1022000 0 0 $X=586520 $Y=1021620
X3756 1187 1035 1170 1 2 1155 OA12 $T=249860 971600 0 180 $X=246140 $Y=966180
X3757 65 1282 61 1 2 72 OA12 $T=266600 901040 1 0 $X=266600 $Y=895620
X3758 1326 1325 53 1 2 1313 OA12 $T=276520 921200 0 180 $X=272800 $Y=915780
X3759 158 1572 52 1 2 156 OA12 $T=326740 880880 1 180 $X=323020 $Y=880500
X3760 1619 1573 1212 1 2 1050 OA12 $T=328600 931280 0 180 $X=324880 $Y=925860
X3761 1748 215 1799 1 2 1791 OA12 $T=380680 951440 1 180 $X=376960 $Y=951060
X3762 2546 2553 2205 1 2 2533 OA12 $T=547460 971600 1 180 $X=543740 $Y=971220
X3763 1952 2622 2647 1 2 2542 OA12 $T=567920 1011920 1 0 $X=567920 $Y=1006500
X3764 1629 1552 2 1 1122 OR2 $T=334800 941360 1 180 $X=332320 $Y=940980
X3765 1671 1552 2 1 1115 OR2 $T=342860 941360 1 180 $X=340380 $Y=940980
X3766 1702 108 2 1 1607 OR2 $T=352160 981680 1 180 $X=349680 $Y=981300
X3767 153 1730 2 1 1692 OR2 $T=362080 1032080 0 180 $X=359600 $Y=1026660
X3768 238 232 2 1 1825 OR2 $T=387500 890960 1 180 $X=385020 $Y=890580
X3769 238 232 2 1 1849 OR2 $T=389360 901040 1 0 $X=389360 $Y=895620
X3770 238 232 2 1 1850 OR2 $T=390600 890960 0 0 $X=390600 $Y=890580
X3771 238 232 2 1 1938 OR2 $T=419120 931280 1 0 $X=419120 $Y=925860
X3772 370 2073 2 1 2468 OR2 $T=527000 981680 1 0 $X=527000 $Y=976260
X3773 2431 2410 2 1 2527 OR2 $T=537540 1011920 1 0 $X=537540 $Y=1006500
X3774 2601 2585 2 1 2382 OR2 $T=556760 1011920 0 180 $X=554280 $Y=1006500
X3775 2572 546 2 1 2588 OR2 $T=554280 1042160 1 0 $X=554280 $Y=1036740
X3776 2570 2592 2587 2 1 2483 OR3S $T=557380 1001840 1 180 $X=553660 $Y=1001460
X3777 57 1488 2 1 1518 OR2S $T=306280 1042160 0 0 $X=306280 $Y=1041780
X3778 1892 1831 2 1 1740 OR2S $T=407960 971600 0 180 $X=405480 $Y=966180
X3779 301 1961 2 1 1991 OR2S $T=436480 901040 0 180 $X=434000 $Y=895620
X3780 2137 2014 2 1 2175 OR2S $T=463140 961520 0 0 $X=463140 $Y=961140
X3781 2073 2478 2 1 2514 OR2S $T=536300 981680 0 0 $X=536300 $Y=981300
X3782 1238 70 5 2 1 1481 OA12S $T=305040 1022000 1 180 $X=301320 $Y=1021620
X3783 1699 1685 1733 2 1 1710 OA12S $T=362700 921200 0 180 $X=358980 $Y=915780
X3784 2097 370 2397 2 1 2510 OA12S $T=531340 981680 1 0 $X=531340 $Y=976260
X3785 1825 230 235 237 1 2 239 OA13S $T=386880 880880 0 0 $X=386880 $Y=880500
X3786 1849 230 242 237 1 2 1828 OA13S $T=391840 911120 1 0 $X=391840 $Y=905700
X3787 274 370 2154 2382 1 2 2405 OA13S $T=511500 1011920 1 0 $X=511500 $Y=1006500
X3788 2206 2134 2276 2250 1 2 2303 AO13S $T=491040 951440 0 0 $X=491040 $Y=951060
X3789 1031 1227 1225 1212 2 1052 1 AOI13HS $T=259160 931280 0 180 $X=255440 $Y=925860
X3790 127 1460 85 105 2 37 1 AOI13HS $T=304420 1032080 1 180 $X=300700 $Y=1031700
X3791 1697 1499 1575 179 2 108 1 AOI13HS $T=350920 1011920 1 180 $X=347200 $Y=1011540
X3792 1755 1812 1708 1813 2 1475 1 AOI13HS $T=388740 931280 0 0 $X=388740 $Y=930900
X3793 1749 1890 1888 229 2 1251 1 AOI13HS $T=407340 951440 1 180 $X=403620 $Y=951060
X3794 1920 1902 264 1872 2 1940 1 AOI13HS $T=419120 890960 1 0 $X=419120 $Y=885540
X3795 2098 2092 2082 1980 2 1998 1 AOI13HS $T=456320 961520 0 180 $X=452600 $Y=956100
X3796 2173 2250 229 223 2 2134 1 AOI13HS $T=484840 951440 0 0 $X=484840 $Y=951060
X3797 1026 1027 1037 2 1044 1 1052 AO112 $T=221960 981680 0 0 $X=221960 $Y=981300
X3798 1366 1322 1356 2 1328 1 1345 AO112 $T=282100 1042160 0 180 $X=277140 $Y=1036740
X3799 1732 1708 1740 2 1449 1 1475 AO112 $T=358980 941360 1 0 $X=358980 $Y=935940
X3800 1966 1941 263 2 1979 1 323 AO112 $T=429040 921200 1 0 $X=429040 $Y=915780
X3801 2168 2006 2038 2 2133 1 378 AO112 $T=466240 981680 0 180 $X=461280 $Y=976260
X3802 1841 1828 1 1845 1813 1828 2 MOAI1 $T=388120 921200 0 0 $X=388120 $Y=920820
X3803 1884 247 1 1873 250 247 2 MOAI1 $T=406100 890960 0 180 $X=401760 $Y=885540
X3804 243 247 1 1885 1872 247 2 MOAI1 $T=402380 901040 1 0 $X=402380 $Y=895620
X3805 1879 1828 1 1871 1831 1828 2 MOAI1 $T=402380 931280 1 0 $X=402380 $Y=925860
X3806 1901 1828 1 1897 1475 1828 2 MOAI1 $T=414160 931280 1 180 $X=409820 $Y=930900
X3807 1894 1828 1 1899 1708 1828 2 MOAI1 $T=414780 931280 0 180 $X=410440 $Y=925860
X3808 243 1931 1 1926 1980 1931 2 MOAI1 $T=422840 951440 0 0 $X=422840 $Y=951060
X3809 1986 1931 1 1959 2003 1931 2 MOAI1 $T=432760 931280 0 0 $X=432760 $Y=930900
X3810 1850 243 235 237 2 1 247 OA13 $T=394940 890960 1 0 $X=394940 $Y=885540
X3811 1938 243 242 237 2 1 1931 OA13 $T=420980 941360 1 0 $X=420980 $Y=935940
X3812 1491 1554 1 1531 2 AN2S $T=320540 1011920 0 180 $X=318060 $Y=1006500
X3813 1829 1845 1 1874 2 AN2S $T=395560 921200 1 0 $X=395560 $Y=915780
X3814 1874 1871 1 1880 2 AN2S $T=401140 921200 1 0 $X=401140 $Y=915780
X3815 1891 1887 1 1903 2 AN2S $T=406100 911120 1 0 $X=406100 $Y=905700
X3816 1877 1860 1 1891 2 AN2S $T=407340 901040 0 0 $X=407340 $Y=900660
X3817 1880 1899 1 1907 2 AN2S $T=415400 921200 0 0 $X=415400 $Y=920820
X3818 1898 247 2 1 262 232 MUX2 $T=411680 911120 0 0 $X=411680 $Y=910740
X3819 1163 19 1216 1 2 1223 AO12S $T=256680 1022000 1 0 $X=256680 $Y=1016580
X3820 223 1699 224 1 2 1909 AO12S $T=409200 961520 1 0 $X=409200 $Y=956100
X3821 1456 1557 36 101 2 1 155 AN4S $T=317440 1052240 1 0 $X=317440 $Y=1046820
X3822 1416 164 1331 127 2 1 1681 AN4S $T=334800 1022000 0 0 $X=334800 $Y=1021620
X3823 1373 1386 1445 1 2 1419 AN3B1 $T=293260 911120 0 0 $X=293260 $Y=910740
X3824 1402 94 115 1 2 114 AN3B1 $T=301320 890960 0 180 $X=296360 $Y=885540
X3825 1332 2 1286 1035 1 AN2B1S $T=282100 1022000 1 0 $X=282100 $Y=1016580
X3826 1238 71 2 1324 1331 1 OR3B2S $T=271560 1042160 1 0 $X=271560 $Y=1036740
.ENDS
***************************************
.SUBCKT ICV_8 1 2 3 4 5 6 7 8 9
** N=9 EP=9 IP=12 FDC=0
X0 1 2 3 4 5 QDFFN $T=-10540 0 0 0 $X=-10540 $Y=-380
X1 6 7 8 4 5 QDFFN $T=0 0 0 0 $X=0 $Y=-380
.ENDS
***************************************
.SUBCKT QDLHN CK D GND VCC Q
** N=6 EP=5 IP=0 FDC=0
.ENDS
***************************************
.SUBCKT FA1 S B VCC A CI GND CO
** N=8 EP=7 IP=0 FDC=0
.ENDS
***************************************
.SUBCKT INV1CK O I GND VCC
** N=5 EP=4 IP=0 FDC=0
.ENDS
***************************************
.SUBCKT XOR3S I2 I1 I3 VCC GND O
** N=7 EP=6 IP=0 FDC=0
.ENDS
***************************************
.SUBCKT ND3P I1 O I2 I3 GND VCC
** N=7 EP=6 IP=0 FDC=0
.ENDS
***************************************
.SUBCKT OR2P I2 I1 O GND VCC
** N=6 EP=5 IP=0 FDC=0
.ENDS
***************************************
.SUBCKT OR2B1S I1 B1 GND O VCC
** N=6 EP=5 IP=0 FDC=0
.ENDS
***************************************
.SUBCKT DFFRBN D CK RB Q GND VCC QB
** N=8 EP=7 IP=0 FDC=0
.ENDS
***************************************
.SUBCKT ICV_9 1 2 3 4 5 6 7 8 9
** N=9 EP=9 IP=12 FDC=0
X0 1 2 3 4 5 ND2 $T=0 0 0 0 $X=0 $Y=-380
X1 6 7 8 4 5 ND2 $T=1860 0 0 0 $X=1860 $Y=-380
.ENDS
***************************************
.SUBCKT BUF6CK I GND O VCC
** N=5 EP=4 IP=0 FDC=0
.ENDS
***************************************
.SUBCKT XOR3 I2 I1 I3 VCC GND O
** N=7 EP=6 IP=0 FDC=0
.ENDS
***************************************
.SUBCKT AN2B1 I1 O B1 GND VCC
** N=6 EP=5 IP=0 FDC=0
.ENDS
***************************************
.SUBCKT NR2T O I2 GND I1 VCC
** N=6 EP=5 IP=0 FDC=0
.ENDS
***************************************
.SUBCKT AO222S C1 C2 B2 B1 A1 A2 GND VCC O
** N=10 EP=9 IP=0 FDC=0
.ENDS
***************************************
.SUBCKT MOAI1H B1 B2 GND A1 O A2 VCC
** N=8 EP=7 IP=0 FDC=0
.ENDS
***************************************
.SUBCKT AOI22H A2 A1 VCC B1 O B2 GND
** N=8 EP=7 IP=0 FDC=0
.ENDS
***************************************
.SUBCKT ND2P I2 GND I1 O VCC
** N=6 EP=5 IP=0 FDC=0
.ENDS
***************************************
.SUBCKT XNR3 I2 I1 I3 VCC GND O
** N=7 EP=6 IP=0 FDC=0
.ENDS
***************************************
.SUBCKT MAO222 B1 A1 C1 GND VCC O
** N=7 EP=6 IP=0 FDC=0
.ENDS
***************************************
.SUBCKT ND3HT I3 GND I2 I1 VCC O
** N=7 EP=6 IP=0 FDC=0
.ENDS
***************************************
.SUBCKT OR2T I2 I1 GND O VCC
** N=6 EP=5 IP=0 FDC=0
.ENDS
***************************************
.SUBCKT OAI12H B2 B1 GND A1 O VCC
** N=7 EP=6 IP=0 FDC=0
.ENDS
***************************************
.SUBCKT AO22S O A2 A1 VCC B1 B2 GND
** N=8 EP=7 IP=0 FDC=0
.ENDS
***************************************
.SUBCKT MUX2S B S VCC A GND O
** N=7 EP=6 IP=0 FDC=0
.ENDS
***************************************
.SUBCKT ND2T I2 GND I1 O VCC
** N=6 EP=5 IP=0 FDC=0
.ENDS
***************************************
.SUBCKT QDFFRBS D CK RB VCC GND Q
** N=7 EP=6 IP=0 FDC=0
.ENDS
***************************************
.SUBCKT NR2F I1 VCC GND I2 O
** N=6 EP=5 IP=0 FDC=0
.ENDS
***************************************
.SUBCKT ICV_10 1 2 3 4 5 6 7 8 9 10 11 12 13 14 15 16 17 18 19 20
+ 21 22 23 24 25 26 27 28 29 30 31 32 33 34 35 36 37 38 39 40
+ 41 42 43 44 45 46 47 48 49 50 51 52 53 54 55 56 57 58 59 60
+ 61 62 63 64 65 66 67 68 69 70 71 72 73 74 75 76 77 78 79 80
+ 81 82 83 84 85 86 87 88 89 90 91 92 93 94 95 96 97 98 99 100
+ 101 102 103 104 105 106 107 108 109 110 111 112 113 114 115 116 117 118 119 120
+ 121 122 123 124 125 126 127 128 129 130 131 132 133 134 135 136 137 138 139 140
+ 141 142 143 144 145 146 147 148 149 150 151 152 153 154 155 156 157 158 159 160
+ 161 162 163 164 165 166 167 168 169 170 171 172 173 174 175 176 177 178 179 180
+ 181 182 183 184 185 186 187 188 189 190 191 192 193 194 195 196 197 198 199 200
+ 201 202 203 204 205 206 207 208 209 210 211 212 213 214 215 216 217 218 219 220
+ 221 222 223 224 225 226 227 228 229 230 231 232 233 234 235 236 237 238 239 240
+ 241 242 243 244 245 246 247 248 249 250 251 252 253 254 255 256 257 258 259 260
+ 261 262 263 264 265 266 267 268 269 270 271 272 273 274 275 276 277 278 279 280
+ 281 282 283 284 285 286 287 288 289 290 291 292 293 294 295 296 297 298 299 300
+ 301 302 303 304 305 306 307 308 309 310 311 312 313 314 315 316 317 318 319 320
+ 321 322 323 324 325 326 327 328 329 330 331 332 333 334 335 336 337 338 339 340
+ 341 342 343 344 345 346 347 348 349 350 351 352 353 354 355 356 357 358 359 360
+ 361 362 363 364 365 366 367 368 369 370 371 372 373 374 375 376 377 378 379 380
+ 381 382 383 384 385 386 387 388 389 390 391 392 393 394 395 396 397 398 399 400
+ 401 402 403 404 405 406 407 408 409 410 411 412 413 414 415 416 417 418 419 420
+ 421 422 423 424 425 426 427 428 429 430 431 432 433 434 435 436 437 438 439 440
+ 441 442 443 444 445 446 447 448 449 450 451 452 453 454 455 456 457 458 459 460
+ 461 462 463 464 465 466 467 468 469 470 471 472 473 474 475 476 477 478 479 480
+ 481 482 483 484 485 486 487 488 489 490 491 492 493 494 495 496 497 498 499 500
+ 501 502 503 504 505 506 507 508 509 510 511 512 513 514 515 516 517 518 519 520
+ 521 522 523 524 525 526 527 528 529 530 531 532 533 534 535 536 537 538 539 540
+ 541 542 543 544 545 546 547 548 549 550 551 552 553 554 555 556 557 558 559 560
+ 561 562 563 564 565 566 567 568 569 570 571 572 573 574 575 576 577 578 579 580
+ 581 582 583 584 585 586 587 588 589 590 591 592 593 594 595 596 597 598 599 600
+ 601 602 603 604 605 606 607 608 609 610 611 612 613 614 615 616 617 618 619 620
+ 621 622 623 624 625 626 627 628 629 630 631 632 633 634 635 636 637 638 639 640
+ 641 642 643 644 645 646 647 648 649 650 651 652 653 654 655 656 657 658 659 660
+ 661 662 663 664 665 666 667 668 669 670 671 672 673 674 675 676 677 678 679 680
+ 681 682 683 684 685 686 687 688 689 690 691 692 693 694 695 696 697 698 699 700
+ 701 702 703 704 705 706 707 708 709 710 711 712 713 714 715 716 717 718 719 720
+ 721 722 723 724 725 726 727 728 729 730 731 732 733 734 735 736 737 738 739 740
+ 741 742 743 744 745 746 747 748 749 750 751 752 753 754 755 756 757 758 759 760
+ 761 762 763 764 765 766 767 768 769 770 771 772 773 774 775 776 777 778 779 780
+ 781 782 783 784 785 786 787 788 789 790 791 792 793 794 795 796 797 798 799 800
+ 801 802 803 804 805 806 807 808 809 810 811 812 813 814 815 816 817 818 819 820
+ 821 822 823 824 825 826 827 828 829 830 831 832 833 834 835 836 837 838 839 840
+ 841 842 843 844 845 846 847 848 849 850 851 852 853 854 855 856 857 858 859 860
+ 861 862 863 864 865 866 867 868 869 870 871 872 873 874 875 876 877 878 879 880
+ 881 882 883 884 885 886 887 888 889 890 891 892 893 894 895 896 897 898 899 900
+ 901 902 903 904 905 906 907 908 909 910 911 912 913 914 915 916 917 918 919 920
+ 921 922 923 924 925 926 927 928 929 930 931 932 933 934 935 936 937 938 939 940
+ 941 942 943 944 945 946 947 948 949 950 951 952 953 954 955 956 957 958 959 960
+ 961 962 963 964 965 966 967 968 969 970 971 972 973 974 975 976 977 978 979 980
+ 981 982 983 984 985 986 987 988 989 990 991 992 993 994 995 996 997 998 999 1000
+ 1001 1002 1003 1004 1005 1006 1007 1008 1009 1010 1011 1012 1013 1014 1015 1016 1017 1018 1019 1020
+ 1021 1022 1023 1024 1025 1026 1027 1028 1029 1030 1031 1032 1033 1034 1035 1036 1037 1038 1039 1040
+ 1041 1042 1043 1044 1045 1046 1047 1048 1050 1051 1052 1059 1093
** N=5510 EP=1053 IP=31429 FDC=0
X0 1051 1050 1050 1050 1052 1050 1059 YA2GSD $T=1309440 731560 0 90 $X=1169940 $Y=734410
X1 822 826 4695 1 2 QDFFN $T=840100 860720 0 0 $X=840100 $Y=860340
X2 822 830 839 1 2 QDFFN $T=846920 880880 1 0 $X=846920 $Y=875460
X3 822 842 4700 1 2 QDFFN $T=860560 850640 1 180 $X=850020 $Y=850260
X4 822 850 837 1 2 QDFFN $T=866140 870800 0 180 $X=855600 $Y=865380
X5 822 856 4735 1 2 QDFFN $T=871100 850640 0 180 $X=860560 $Y=845220
X6 838 830 4793 1 2 QDFFN $T=860560 880880 1 0 $X=860560 $Y=875460
X7 838 829 4811 1 2 QDFFN $T=867380 860720 1 0 $X=867380 $Y=855300
X8 890 850 4854 1 2 QDFFN $T=895900 870800 1 180 $X=885360 $Y=870420
X9 890 826 4878 1 2 QDFFN $T=887220 870800 1 0 $X=887220 $Y=865380
X10 890 829 4874 1 2 QDFFN $T=898380 860720 0 180 $X=887840 $Y=855300
X11 890 856 4839 1 2 QDFFN $T=899620 840560 0 180 $X=889080 $Y=835140
X12 895 842 4918 1 2 QDFFN $T=892180 850640 1 0 $X=892180 $Y=845220
X13 895 826 4919 1 2 QDFFN $T=892180 860720 0 0 $X=892180 $Y=860340
X14 895 856 4933 1 2 QDFFN $T=895280 840560 0 0 $X=895280 $Y=840180
X15 895 829 4963 1 2 QDFFN $T=898380 860720 1 0 $X=898380 $Y=855300
X16 916 842 4939 1 2 QDFFN $T=914500 850640 0 180 $X=903960 $Y=845220
X17 916 856 4948 1 2 QDFFN $T=916360 840560 1 180 $X=905820 $Y=840180
X18 916 826 5010 1 2 QDFFN $T=907680 870800 1 0 $X=907680 $Y=865380
X19 4870 919 5012 1 2 QDFFN $T=908920 800240 0 0 $X=908920 $Y=799860
X20 4803 919 5013 1 2 QDFFN $T=909540 790160 1 0 $X=909540 $Y=784740
X21 4903 919 5017 1 2 QDFFN $T=910160 800240 1 0 $X=910160 $Y=794820
X22 4903 4997 5026 1 2 QDFFN $T=912020 790160 0 0 $X=912020 $Y=789780
X23 925 919 5033 1 2 QDFFN $T=913260 729680 1 0 $X=913260 $Y=724260
X24 4992 919 5036 1 2 QDFFN $T=913260 749840 1 0 $X=913260 $Y=744420
X25 4996 4997 5034 1 2 QDFFN $T=913880 749840 0 0 $X=913880 $Y=749460
X26 4996 919 5038 1 2 QDFFN $T=913880 759920 0 0 $X=913880 $Y=759540
X27 916 829 5001 1 2 QDFFN $T=925040 860720 0 180 $X=914500 $Y=855300
X28 5002 4997 5053 1 2 QDFFN $T=915740 810320 0 0 $X=915740 $Y=809940
X29 914 842 5032 1 2 QDFFN $T=915740 850640 1 0 $X=915740 $Y=845220
X30 4992 4997 5042 1 2 QDFFN $T=916360 739760 1 0 $X=916360 $Y=734340
X31 4900 4997 5004 1 2 QDFFN $T=927520 770000 1 180 $X=916980 $Y=769620
X32 914 850 947 1 2 QDFFN $T=916980 870800 0 0 $X=916980 $Y=870420
X33 937 4997 5067 1 2 QDFFN $T=918840 709520 0 0 $X=918840 $Y=709140
X34 925 4997 5058 1 2 QDFFN $T=920080 719600 0 0 $X=920080 $Y=719220
X35 4896 4997 5064 1 2 QDFFN $T=920080 830480 0 0 $X=920080 $Y=830100
X36 938 826 5087 1 2 QDFFN $T=920700 860720 0 0 $X=920700 $Y=860340
X37 4870 4997 5021 1 2 QDFFN $T=932480 810320 0 180 $X=921940 $Y=804900
X38 4870 945 5080 1 2 QDFFN $T=923180 800240 0 0 $X=923180 $Y=799860
X39 5002 919 5085 1 2 QDFFN $T=923800 820400 1 0 $X=923800 $Y=814980
X40 5002 945 5082 1 2 QDFFN $T=924420 830480 1 0 $X=924420 $Y=825060
X41 4896 945 5088 1 2 QDFFN $T=925660 840560 1 0 $X=925660 $Y=835140
X42 4996 955 5052 1 2 QDFFN $T=936820 749840 0 180 $X=926280 $Y=744420
X43 4900 945 5057 1 2 QDFFN $T=938060 790160 0 180 $X=927520 $Y=784740
X44 938 842 5062 1 2 QDFFN $T=938680 850640 0 180 $X=928140 $Y=845220
X45 4992 955 5107 1 2 QDFFN $T=928760 739760 0 0 $X=928760 $Y=739380
X46 937 919 5066 1 2 QDFFN $T=939920 699440 1 180 $X=929380 $Y=699060
X47 925 955 5068 1 2 QDFFN $T=939920 719600 0 180 $X=929380 $Y=714180
X48 925 945 5072 1 2 QDFFN $T=940540 709520 1 180 $X=930000 $Y=709140
X49 4803 945 5109 1 2 QDFFN $T=931240 780080 1 0 $X=931240 $Y=774660
X50 4896 919 5110 1 2 QDFFN $T=931240 830480 0 0 $X=931240 $Y=830100
X51 4992 945 5106 1 2 QDFFN $T=931860 739760 1 0 $X=931860 $Y=734340
X52 914 829 5077 1 2 QDFFN $T=931860 870800 1 0 $X=931860 $Y=865380
X53 4870 955 5084 1 2 QDFFN $T=944260 810320 0 180 $X=933720 $Y=804900
X54 938 829 5090 1 2 QDFFN $T=934340 860720 1 0 $X=934340 $Y=855300
X55 4896 955 5100 1 2 QDFFN $T=947980 840560 1 180 $X=937440 $Y=840180
X56 954 4997 5124 1 2 QDFFN $T=938680 709520 1 0 $X=938680 $Y=704100
X57 4903 955 5094 1 2 QDFFN $T=949220 800240 0 180 $X=938680 $Y=794820
X58 925 5113 5141 1 2 QDFFN $T=939300 729680 0 0 $X=939300 $Y=729300
X59 954 5137 5111 1 2 QDFFN $T=951080 719600 1 180 $X=940540 $Y=719220
X60 962 965 5133 1 2 QDFFN $T=940540 860720 0 0 $X=940540 $Y=860340
X61 962 966 5147 1 2 QDFFN $T=940540 880880 1 0 $X=940540 $Y=875460
X62 954 5113 5149 1 2 QDFFN $T=941160 729680 1 0 $X=941160 $Y=724260
X63 5002 5113 5154 1 2 QDFFN $T=941780 820400 1 0 $X=941780 $Y=814980
X64 4992 5113 5168 1 2 QDFFN $T=943640 739760 1 0 $X=943640 $Y=734340
X65 4996 5137 5163 1 2 QDFFN $T=945500 749840 1 0 $X=945500 $Y=744420
X66 4803 5113 5167 1 2 QDFFN $T=946120 780080 1 0 $X=946120 $Y=774660
X67 4903 5137 5170 1 2 QDFFN $T=947980 790160 0 0 $X=947980 $Y=789780
X68 4896 5137 5142 1 2 QDFFN $T=959140 840560 1 180 $X=948600 $Y=840180
X69 948 4997 980 1 2 QDFFN $T=949220 699440 0 0 $X=949220 $Y=699060
X70 954 5091 5148 1 2 QDFFN $T=961000 709520 0 180 $X=950460 $Y=704100
X71 5002 5137 5171 1 2 QDFFN $T=950460 820400 0 0 $X=950460 $Y=820020
X72 4896 5113 5153 1 2 QDFFN $T=961000 830480 1 180 $X=950460 $Y=830100
X73 937 5113 5181 1 2 QDFFN $T=951080 719600 0 0 $X=951080 $Y=719220
X74 962 974 5175 1 2 QDFFN $T=951080 870800 0 0 $X=951080 $Y=870420
X75 962 978 5179 1 2 QDFFN $T=952320 860720 0 0 $X=952320 $Y=860340
X76 973 978 986 1 2 QDFFN $T=952320 880880 1 0 $X=952320 $Y=875460
X77 4996 5113 5189 1 2 QDFFN $T=954800 759920 1 0 $X=954800 $Y=754500
X78 4992 5091 5172 1 2 QDFFN $T=967200 739760 0 180 $X=956660 $Y=734340
X79 4985 955 5192 1 2 QDFFN $T=956660 840560 1 0 $X=956660 $Y=835140
X80 925 5091 5162 1 2 QDFFN $T=968440 729680 0 180 $X=957900 $Y=724260
X81 4985 5137 5208 1 2 QDFFN $T=958520 810320 1 0 $X=958520 $Y=804900
X82 4985 945 5198 1 2 QDFFN $T=959140 830480 1 0 $X=959140 $Y=825060
X83 939 4997 994 1 2 QDFFN $T=960380 699440 0 0 $X=960380 $Y=699060
X84 937 5091 5180 1 2 QDFFN $T=970920 709520 1 180 $X=960380 $Y=709140
X85 4985 919 5209 1 2 QDFFN $T=960380 810320 0 0 $X=960380 $Y=809940
X86 4985 4997 5211 1 2 QDFFN $T=961620 820400 1 0 $X=961620 $Y=814980
X87 5074 955 5184 1 2 QDFFN $T=974020 749840 1 180 $X=963480 $Y=749460
X88 962 988 5214 1 2 QDFFN $T=964100 880880 1 0 $X=964100 $Y=875460
X89 962 996 5188 1 2 QDFFN $T=975260 870800 0 180 $X=964720 $Y=865380
X90 948 5091 5215 1 2 QDFFN $T=967200 739760 1 0 $X=967200 $Y=734340
X91 5005 955 5217 1 2 QDFFN $T=967820 840560 1 0 $X=967820 $Y=835140
X92 948 5113 5226 1 2 QDFFN $T=968440 739760 0 0 $X=968440 $Y=739380
X93 5074 5113 5213 1 2 QDFFN $T=969060 770000 0 0 $X=969060 $Y=769620
X94 4900 5113 5201 1 2 QDFFN $T=979600 780080 0 180 $X=969060 $Y=774660
X95 937 5137 5182 1 2 QDFFN $T=980220 719600 0 180 $X=969680 $Y=714180
X96 5005 945 5230 1 2 QDFFN $T=970300 830480 1 0 $X=970300 $Y=825060
X97 5005 5137 5206 1 2 QDFFN $T=981460 810320 1 180 $X=970920 $Y=809940
X98 984 4997 1009 1 2 QDFFN $T=972780 699440 0 0 $X=972780 $Y=699060
X99 5074 4997 5250 1 2 QDFFN $T=974020 749840 0 0 $X=974020 $Y=749460
X100 962 1008 5196 1 2 QDFFN $T=984560 870800 1 180 $X=974020 $Y=870420
X101 973 1008 1001 1 2 QDFFN $T=985800 880880 0 180 $X=975260 $Y=875460
X102 4900 5137 5186 1 2 QDFFN $T=987660 780080 1 180 $X=977120 $Y=779700
X103 5005 4997 5249 1 2 QDFFN $T=978360 820400 1 0 $X=978360 $Y=814980
X104 939 5137 5229 1 2 QDFFN $T=989520 739760 1 180 $X=978980 $Y=739380
X105 5005 5113 5233 1 2 QDFFN $T=990140 800240 1 180 $X=979600 $Y=799860
X106 939 5113 5238 1 2 QDFFN $T=991380 739760 0 180 $X=980840 $Y=734340
X107 984 5091 5232 1 2 QDFFN $T=992000 709520 0 180 $X=981460 $Y=704100
X108 984 5137 5228 1 2 QDFFN $T=992620 719600 0 180 $X=982080 $Y=714180
X109 5005 919 5245 1 2 QDFFN $T=992620 810320 1 180 $X=982080 $Y=809940
X110 5074 919 5241 1 2 QDFFN $T=994480 759920 1 180 $X=983940 $Y=759540
X111 954 1016 1011 1 2 QDFFN $T=995100 699440 1 180 $X=984560 $Y=699060
X112 4985 1016 5261 1 2 QDFFN $T=1000060 820400 0 180 $X=989520 $Y=814980
X113 925 1016 5263 1 2 QDFFN $T=1000680 719600 1 180 $X=990140 $Y=719220
X114 4992 1016 5272 1 2 QDFFN $T=990760 739760 0 0 $X=990760 $Y=739380
X115 5005 1016 5292 1 2 QDFFN $T=991380 830480 1 0 $X=991380 $Y=825060
X116 939 5091 5236 1 2 QDFFN $T=992620 739760 1 0 $X=992620 $Y=734340
X117 4903 1016 5243 1 2 QDFFN $T=1003160 780080 1 180 $X=992620 $Y=779700
X118 1022 974 1015 1 2 QDFFN $T=1003160 880880 0 180 $X=992620 $Y=875460
X119 939 1016 5265 1 2 QDFFN $T=1003780 709520 0 180 $X=993240 $Y=704100
X120 939 1021 5315 1 2 QDFFN $T=995100 719600 1 0 $X=995100 $Y=714180
X121 4896 1016 5275 1 2 QDFFN $T=1006260 830480 1 180 $X=995720 $Y=830100
X122 984 1016 1024 1 2 QDFFN $T=996340 699440 0 0 $X=996340 $Y=699060
X123 4803 1016 5283 1 2 QDFFN $T=1006880 759920 1 180 $X=996340 $Y=759540
X124 925 1020 5318 1 2 QDFFN $T=1000060 729680 1 0 $X=1000060 $Y=724260
X125 939 1020 5314 1 2 QDFFN $T=1000680 709520 0 0 $X=1000680 $Y=709140
X126 5005 1021 5324 1 2 QDFFN $T=1001300 820400 1 0 $X=1001300 $Y=814980
X127 925 1021 5325 1 2 QDFFN $T=1002540 719600 0 0 $X=1002540 $Y=719220
X128 4992 1021 5295 1 2 QDFFN $T=1013080 739760 1 180 $X=1002540 $Y=739380
X129 5005 1020 5322 1 2 QDFFN $T=1003160 830480 1 0 $X=1003160 $Y=825060
X130 4992 1020 5297 1 2 QDFFN $T=1014940 729680 1 180 $X=1004400 $Y=729300
X131 5002 1020 5328 1 2 QDFFN $T=1004400 810320 1 0 $X=1004400 $Y=804900
X132 984 5326 5305 1 2 QDFFN $T=1015560 709520 0 180 $X=1005020 $Y=704100
X133 1022 996 1025 1 2 QDFFN $T=1015560 880880 0 180 $X=1005020 $Y=875460
X134 5002 1021 5349 1 2 QDFFN $T=1006260 810320 0 0 $X=1006260 $Y=809940
X135 5074 1020 5339 1 2 QDFFN $T=1006880 759920 0 0 $X=1006880 $Y=759540
X136 4900 1016 5269 1 2 QDFFN $T=1017420 790160 1 180 $X=1006880 $Y=789780
X137 4900 1021 5298 1 2 QDFFN $T=1010600 800240 1 0 $X=1010600 $Y=794820
X138 4896 1020 5363 1 2 QDFFN $T=1010600 840560 1 0 $X=1010600 $Y=835140
X139 4803 1021 5329 1 2 QDFFN $T=1011220 770000 1 0 $X=1011220 $Y=764580
X140 4985 1021 5345 1 2 QDFFN $T=1012460 820400 1 0 $X=1012460 $Y=814980
X141 948 5331 5346 1 2 QDFFN $T=1013080 709520 0 0 $X=1013080 $Y=709140
X142 4992 5331 5364 1 2 QDFFN $T=1013080 739760 0 0 $X=1013080 $Y=739380
X143 939 5326 5359 1 2 QDFFN $T=1014320 719600 0 0 $X=1014320 $Y=719220
X144 4985 1020 5334 1 2 QDFFN $T=1026100 830480 0 180 $X=1015560 $Y=825060
X145 948 5326 5341 1 2 QDFFN $T=1027340 709520 0 180 $X=1016800 $Y=704100
X146 4992 5326 5368 1 2 QDFFN $T=1016800 729680 0 0 $X=1016800 $Y=729300
X147 4903 1021 5365 1 2 QDFFN $T=1016800 790160 1 0 $X=1016800 $Y=784740
X148 1032 974 1031 1 2 QDFFN $T=1027960 880880 0 180 $X=1017420 $Y=875460
X149 4803 5326 5340 1 2 QDFFN $T=1029820 780080 0 180 $X=1019280 $Y=774660
X150 4896 1021 5366 1 2 QDFFN $T=1019900 830480 0 0 $X=1019900 $Y=830100
X151 4870 1021 5336 1 2 QDFFN $T=1031680 800240 0 180 $X=1021140 $Y=794820
X152 4803 5331 5344 1 2 QDFFN $T=1032300 770000 0 180 $X=1021760 $Y=764580
X153 5355 5331 5395 1 2 QDFFN $T=1022380 820400 0 0 $X=1022380 $Y=820020
X154 5002 5331 5379 1 2 QDFFN $T=1023000 810320 1 0 $X=1023000 $Y=804900
X155 984 5331 5321 1 2 QDFFN $T=1034780 699440 1 180 $X=1024240 $Y=699060
X156 5002 5326 5391 1 2 QDFFN $T=1024240 820400 1 0 $X=1024240 $Y=814980
X157 937 5331 5389 1 2 QDFFN $T=1025480 709520 0 0 $X=1025480 $Y=709140
X158 939 5331 5371 1 2 QDFFN $T=1036640 719600 1 180 $X=1026100 $Y=719220
X159 4870 5331 5370 1 2 QDFFN $T=1036640 790160 1 180 $X=1026100 $Y=789780
X160 4996 1021 5361 1 2 QDFFN $T=1026720 749840 0 0 $X=1026720 $Y=749460
X161 5005 5326 5398 1 2 QDFFN $T=1027340 830480 1 0 $X=1027340 $Y=825060
X162 925 5326 5400 1 2 QDFFN $T=1028580 739760 1 0 $X=1028580 $Y=734340
X163 4996 5326 5408 1 2 QDFFN $T=1031060 739760 0 0 $X=1031060 $Y=739380
X164 4896 5326 5390 1 2 QDFFN $T=1042840 830480 1 180 $X=1032300 $Y=830100
X165 954 5326 5410 1 2 QDFFN $T=1034160 719600 1 0 $X=1034160 $Y=714180
X166 4870 5326 5386 1 2 QDFFN $T=1045320 800240 1 180 $X=1034780 $Y=799860
X167 4985 5331 5397 1 2 QDFFN $T=1045320 810320 0 180 $X=1034780 $Y=804900
X168 4985 5326 5396 1 2 QDFFN $T=1045940 810320 1 180 $X=1035400 $Y=809940
X169 937 5326 5392 1 2 QDFFN $T=1047180 709520 0 180 $X=1036640 $Y=704100
X170 954 5331 5404 1 2 QDFFN $T=1047800 709520 1 180 $X=1037260 $Y=709140
X171 925 5331 5387 1 2 QDFFN $T=1047800 729680 0 180 $X=1037260 $Y=724260
X172 4803 5418 5403 1 2 QDFFN $T=1047800 770000 1 180 $X=1037260 $Y=769620
X173 4900 5331 5378 1 2 QDFFN $T=1047800 790160 1 180 $X=1037260 $Y=789780
X174 4900 5326 5385 1 2 QDFFN $T=1048420 780080 1 180 $X=1037880 $Y=779700
X175 4896 5331 5399 1 2 QDFFN $T=1048420 840560 1 180 $X=1037880 $Y=840180
X176 4996 5331 5401 1 2 QDFFN $T=1050280 749840 1 180 $X=1039740 $Y=749460
X177 806 974 1040 1 2 QDFFN $T=1039740 880880 1 0 $X=1039740 $Y=875460
X178 5074 5331 5376 1 2 QDFFN $T=1051520 759920 0 180 $X=1040980 $Y=754500
X179 925 5418 5411 1 2 QDFFN $T=1052140 739760 1 180 $X=1041600 $Y=739380
X180 984 1037 5429 1 2 QDFFN $T=1044080 699440 0 0 $X=1044080 $Y=699060
X181 5074 1038 5428 1 2 QDFFN $T=1044080 770000 1 0 $X=1044080 $Y=764580
X182 4896 5418 5419 1 2 QDFFN $T=1055860 820400 1 180 $X=1045320 $Y=820020
X183 984 5418 5440 1 2 QDFFN $T=1045940 719600 1 0 $X=1045940 $Y=714180
X184 4900 5418 5438 1 2 QDFFN $T=1046560 810320 1 0 $X=1046560 $Y=804900
X185 4896 1037 5423 1 2 QDFFN $T=1057100 830480 0 180 $X=1046560 $Y=825060
X186 5002 1038 5439 1 2 QDFFN $T=1047180 810320 0 0 $X=1047180 $Y=809940
X187 4985 5418 5442 1 2 QDFFN $T=1048420 820400 1 0 $X=1048420 $Y=814980
X188 925 1042 5426 1 2 QDFFN $T=1059580 719600 1 180 $X=1049040 $Y=719220
X189 5074 5418 5450 1 2 QDFFN $T=1050900 749840 1 0 $X=1050900 $Y=744420
X190 816 978 5431 1 2 QDFFN $T=1061440 870800 1 180 $X=1050900 $Y=870420
X191 925 1037 5420 1 2 QDFFN $T=1062060 739760 0 180 $X=1051520 $Y=734340
X192 5074 1037 5445 1 2 QDFFN $T=1052140 739760 0 0 $X=1052140 $Y=739380
X193 4803 1042 5446 1 2 QDFFN $T=1052760 780080 1 0 $X=1052760 $Y=774660
X194 4896 1042 5436 1 2 QDFFN $T=1063300 850640 0 180 $X=1052760 $Y=845220
X195 816 974 5454 1 2 QDFFN $T=1052760 870800 1 0 $X=1052760 $Y=865380
X196 948 5418 5452 1 2 QDFFN $T=1053380 709520 0 0 $X=1053380 $Y=709140
X197 925 1038 5432 1 2 QDFFN $T=1063920 729680 0 180 $X=1053380 $Y=724260
X198 5074 1042 5433 1 2 QDFFN $T=1054620 759920 0 0 $X=1054620 $Y=759540
X199 4896 1038 5435 1 2 QDFFN $T=1065160 840560 0 180 $X=1054620 $Y=835140
X200 948 1037 5444 1 2 QDFFN $T=1055860 699440 0 0 $X=1055860 $Y=699060
X201 939 1042 5463 1 2 QDFFN $T=1058340 719600 1 0 $X=1058340 $Y=714180
X202 5002 1042 5443 1 2 QDFFN $T=1068880 810320 0 180 $X=1058340 $Y=804900
X203 4985 1038 5471 1 2 QDFFN $T=1058960 830480 1 0 $X=1058960 $Y=825060
X204 4985 1037 5456 1 2 QDFFN $T=1059580 820400 1 0 $X=1059580 $Y=814980
X205 4985 1042 5484 1 2 QDFFN $T=1063300 840560 0 0 $X=1063300 $Y=840180
X206 4996 1037 5464 1 2 QDFFN $T=1063920 739760 1 0 $X=1063920 $Y=734340
X207 4996 5418 5478 1 2 QDFFN $T=1064540 739760 0 0 $X=1064540 $Y=739380
X208 816 1008 5472 1 2 QDFFN $T=1064540 870800 1 0 $X=1064540 $Y=865380
X209 937 5418 5461 1 2 QDFFN $T=1076320 709520 1 180 $X=1065780 $Y=709140
X210 939 1038 5457 1 2 QDFFN $T=1076320 729680 0 180 $X=1065780 $Y=724260
X211 4996 1042 5474 1 2 QDFFN $T=1065780 759920 1 0 $X=1065780 $Y=754500
X212 4870 1038 5489 1 2 QDFFN $T=1067020 790160 0 0 $X=1067020 $Y=789780
X213 4870 1042 5480 1 2 QDFFN $T=1067020 800240 0 0 $X=1067020 $Y=799860
X214 937 1037 5460 1 2 QDFFN $T=1078180 699440 1 180 $X=1067640 $Y=699060
X215 4996 1038 5488 1 2 QDFFN $T=1071360 770000 1 0 $X=1071360 $Y=764580
X216 5005 5418 5497 1 2 QDFFN $T=1071360 820400 0 0 $X=1071360 $Y=820020
X217 4903 1038 5499 1 2 QDFFN $T=1074460 780080 0 0 $X=1074460 $Y=779700
X218 5005 1042 5485 1 2 QDFFN $T=1074460 850640 1 0 $X=1074460 $Y=845220
X219 5002 5418 5500 1 2 QDFFN $T=1076320 810320 0 0 $X=1076320 $Y=809940
X220 5002 1037 5492 1 2 QDFFN $T=1076940 810320 1 0 $X=1076940 $Y=804900
X221 5005 1038 5506 1 2 QDFFN $T=1076940 840560 0 0 $X=1076940 $Y=840180
X222 816 965 5493 1 2 QDFFN $T=1076940 870800 1 0 $X=1076940 $Y=865380
X223 816 966 5508 1 2 QDFFN $T=1076940 870800 0 0 $X=1076940 $Y=870420
X224 954 5418 5509 1 2 QDFFN $T=1077560 709520 0 0 $X=1077560 $Y=709140
X225 939 5418 5501 1 2 QDFFN $T=1077560 719600 1 0 $X=1077560 $Y=714180
X226 939 1037 5495 1 2 QDFFN $T=1077560 729680 1 0 $X=1077560 $Y=724260
X227 4992 1037 5498 1 2 QDFFN $T=1077560 739760 1 0 $X=1077560 $Y=734340
X228 4992 5418 5502 1 2 QDFFN $T=1077560 749840 1 0 $X=1077560 $Y=744420
X229 4992 1042 5481 1 2 QDFFN $T=1077560 759920 1 0 $X=1077560 $Y=754500
X230 4992 1038 5507 1 2 QDFFN $T=1077560 759920 0 0 $X=1077560 $Y=759540
X231 4903 1042 5504 1 2 QDFFN $T=1077560 780080 1 0 $X=1077560 $Y=774660
X232 4870 5418 5505 1 2 QDFFN $T=1077560 790160 1 0 $X=1077560 $Y=784740
X233 4870 1037 5496 1 2 QDFFN $T=1077560 800240 1 0 $X=1077560 $Y=794820
X234 5005 1037 5503 1 2 QDFFN $T=1077560 830480 1 0 $X=1077560 $Y=825060
X235 816 996 5467 1 2 QDFFN $T=1077560 880880 1 0 $X=1077560 $Y=875460
X236 1160 1153 1159 1143 1 1142 2 AOI22S $T=227540 749840 1 180 $X=223820 $Y=749460
X237 1158 1108 1144 1171 1 9 2 AOI22S $T=225680 850640 1 0 $X=225680 $Y=845220
X238 15 3 1180 1170 1 9 2 AOI22S $T=230020 870800 1 180 $X=226300 $Y=870420
X239 14 1189 1193 1171 1 1166 2 AOI22S $T=231260 840560 1 180 $X=227540 $Y=840180
X240 1207 1201 1204 1192 1 1161 2 AOI22S $T=232500 810320 0 180 $X=228780 $Y=804900
X241 1279 1207 1251 1266 1 1250 2 AOI22S $T=241180 739760 1 180 $X=237460 $Y=739380
X242 1248 1167 1261 1158 1 1290 2 AOI22S $T=238080 850640 1 0 $X=238080 $Y=845220
X243 1265 1273 1259 1225 1 1306 2 AOI22S $T=238700 780080 1 0 $X=238700 $Y=774660
X244 1189 1265 1294 1329 1 1318 2 AOI22S $T=242420 790160 1 0 $X=242420 $Y=784740
X245 1290 1337 1162 1332 1 1170 2 AOI22S $T=248620 860720 0 180 $X=244900 $Y=855300
X246 1384 1142 1364 1249 1 1350 2 AOI22S $T=252340 709520 1 180 $X=248620 $Y=709140
X247 1265 1107 1414 1335 1 1387 2 AOI22S $T=256680 800240 0 180 $X=252960 $Y=794820
X248 35 1389 1272 1279 1 1381 2 AOI22S $T=252960 800240 0 0 $X=252960 $Y=799860
X249 15 1108 1423 1109 1 21 2 AOI22S $T=258540 870800 0 180 $X=254820 $Y=865380
X250 1107 1404 1388 1233 1 1533 2 AOI22S $T=255440 729680 1 0 $X=255440 $Y=724260
X251 1265 40 1372 1336 1 1418 2 AOI22S $T=255440 820400 1 0 $X=255440 $Y=814980
X252 3 1332 1430 1408 1 1394 2 AOI22S $T=259780 860720 0 180 $X=256060 $Y=855300
X253 1243 1158 1410 1141 1 1273 2 AOI22S $T=256680 820400 0 0 $X=256680 $Y=820020
X254 1279 1332 1449 1396 1 1358 2 AOI22S $T=264120 790160 1 180 $X=260400 $Y=789780
X255 1332 1290 1438 21 1 1486 2 AOI22S $T=262260 860720 1 0 $X=262260 $Y=855300
X256 1279 1384 1458 1466 1 1470 2 AOI22S $T=263500 739760 1 0 $X=263500 $Y=734340
X257 1207 1404 1504 1478 1 1476 2 AOI22S $T=269700 739760 1 180 $X=265980 $Y=739380
X258 1532 1510 1506 1141 1 1109 2 AOI22S $T=274040 820400 1 180 $X=270320 $Y=820020
X259 1545 1384 1497 65 1 1503 2 AOI22S $T=274660 729680 1 180 $X=270940 $Y=729300
X260 1142 1369 1546 1541 1 1495 2 AOI22S $T=279000 770000 0 180 $X=275280 $Y=764580
X261 1279 1117 1534 1150 1 1559 2 AOI22S $T=276520 840560 1 0 $X=276520 $Y=835140
X262 14 1332 1484 1429 1 1577 2 AOI22S $T=279000 850640 0 0 $X=279000 $Y=850260
X263 1566 1431 1552 21 1 77 2 AOI22S $T=279620 880880 1 0 $X=279620 $Y=875460
X264 1149 1207 1596 1483 1 1264 2 AOI22S $T=283960 820400 1 180 $X=280240 $Y=820020
X265 1464 1167 1576 1290 1 1577 2 AOI22S $T=282100 870800 1 0 $X=282100 $Y=865380
X266 1358 76 1615 1142 1 1393 2 AOI22S $T=287680 790160 1 180 $X=283960 $Y=789780
X267 1384 1142 1597 1601 1 1622 2 AOI22S $T=284580 709520 0 0 $X=284580 $Y=709140
X268 14 1337 1590 1279 1 21 2 AOI22S $T=284580 830480 0 0 $X=284580 $Y=830100
X269 1393 1108 1570 1248 1 1611 2 AOI22S $T=284580 860720 1 0 $X=284580 $Y=855300
X270 1153 1273 1630 1602 1 1595 2 AOI22S $T=288920 749840 0 180 $X=285200 $Y=744420
X271 1153 1273 1604 1286 1 1617 2 AOI22S $T=286440 749840 0 0 $X=286440 $Y=749460
X272 1273 21 1607 14 1 1390 2 AOI22S $T=286440 810320 0 0 $X=286440 $Y=809940
X273 1273 1486 1575 1369 1 1638 2 AOI22S $T=287060 770000 1 0 $X=287060 $Y=764580
X274 1149 1566 1627 1656 1 1577 2 AOI22S $T=290160 870800 0 0 $X=290160 $Y=870420
X275 1265 1153 1403 1666 1 1651 2 AOI22S $T=292020 749840 1 0 $X=292020 $Y=744420
X276 21 1265 1689 1631 1 1642 2 AOI22S $T=296980 810320 1 180 $X=293260 $Y=809940
X277 1545 1404 1670 1687 1 1692 2 AOI22S $T=300080 729680 1 0 $X=300080 $Y=724260
X278 1566 1369 1701 1429 1 98 2 AOI22S $T=305660 850640 0 0 $X=305660 $Y=850260
X279 1724 1201 1719 1386 1 1711 2 AOI22S $T=311240 860720 1 180 $X=307520 $Y=860340
X280 1634 1724 1434 1672 1 1759 2 AOI22S $T=309380 860720 1 0 $X=309380 $Y=855300
X281 102 1243 1716 1393 1 1724 2 AOI22S $T=312480 850640 0 0 $X=312480 $Y=850260
X282 1566 1688 1731 1369 1 102 2 AOI22S $T=313100 850640 1 0 $X=313100 $Y=845220
X283 1107 111 1769 112 1 1774 2 AOI22S $T=319920 860720 1 0 $X=319920 $Y=855300
X284 1369 1404 1895 1483 1 1904 2 AOI22S $T=347820 780080 1 0 $X=347820 $Y=774660
X285 1393 1381 1900 141 1 1925 2 AOI22S $T=349060 810320 1 0 $X=349060 $Y=804900
X286 2009 1907 2102 2093 1 2007 2 AOI22S $T=384400 810320 1 0 $X=384400 $Y=804900
X287 2134 2195 2190 200 1 188 2 AOI22S $T=398040 719600 1 0 $X=398040 $Y=714180
X288 2235 207 2223 2194 1 204 2 AOI22S $T=405480 860720 0 180 $X=401760 $Y=855300
X289 2295 2242 2271 219 1 2194 2 AOI22S $T=413540 850640 0 180 $X=409820 $Y=845220
X290 167 222 2266 2014 1 2273 2 AOI22S $T=410440 870800 0 0 $X=410440 $Y=870420
X291 222 2361 2209 249 1 2311 2 AOI22S $T=425320 870800 1 0 $X=425320 $Y=865380
X292 286 2530 2520 2454 1 266 2 AOI22S $T=450120 870800 1 180 $X=446400 $Y=870420
X293 2670 2361 2680 2570 1 2644 2 AOI22S $T=468720 840560 0 180 $X=465000 $Y=835140
X294 2488 2361 2647 2658 1 2671 2 AOI22S $T=465620 820400 0 0 $X=465620 $Y=820020
X295 328 2739 2712 2496 1 219 2 AOI22S $T=474920 830480 1 0 $X=474920 $Y=825060
X296 2543 2676 2725 2457 1 2418 2 AOI22S $T=481740 800240 0 180 $X=478020 $Y=794820
X297 2901 2439 2762 2561 1 2676 2 AOI22S $T=484220 780080 1 180 $X=480500 $Y=779700
X298 347 2530 2759 2782 1 353 2 AOI22S $T=482360 840560 1 0 $X=482360 $Y=835140
X299 2398 298 2812 351 1 2543 2 AOI22S $T=486700 830480 1 180 $X=482980 $Y=830100
X300 2809 2534 2817 2563 1 2676 2 AOI22S $T=489180 830480 0 180 $X=485460 $Y=825060
X301 2809 2361 2826 2649 1 2529 2 AOI22S $T=490420 810320 0 180 $X=486700 $Y=804900
X302 360 347 2814 356 1 342 2 AOI22S $T=490420 880880 0 180 $X=486700 $Y=875460
X303 2543 2532 2825 2398 1 2496 2 AOI22S $T=491040 820400 1 180 $X=487320 $Y=820020
X304 2505 2530 2806 2676 1 2563 2 AOI22S $T=491660 800240 0 180 $X=487940 $Y=794820
X305 2457 2532 2843 2361 1 2561 2 AOI22S $T=491660 800240 1 180 $X=487940 $Y=799860
X306 333 359 2819 347 1 357 2 AOI22S $T=491660 870800 1 180 $X=487940 $Y=870420
X307 2543 2563 2823 2398 1 2852 2 AOI22S $T=490420 830480 0 0 $X=490420 $Y=830100
X308 371 2676 2869 2398 1 347 2 AOI22S $T=495380 790160 1 180 $X=491660 $Y=789780
X309 2532 2839 2764 372 1 2852 2 AOI22S $T=492280 840560 0 0 $X=492280 $Y=840180
X310 2563 2561 2845 2398 1 2809 2 AOI22S $T=493520 790160 1 0 $X=493520 $Y=784740
X311 2543 2530 2828 2649 1 2809 2 AOI22S $T=493520 810320 0 0 $X=493520 $Y=809940
X312 361 372 2841 377 1 298 2 AOI22S $T=493520 880880 1 0 $X=493520 $Y=875460
X313 2530 2505 2867 2532 1 2543 2 AOI22S $T=498480 800240 0 180 $X=494760 $Y=794820
X314 371 2681 2850 2858 1 347 2 AOI22S $T=494760 800240 0 0 $X=494760 $Y=799860
X315 345 2563 2902 2638 1 2875 2 AOI22S $T=501580 830480 0 180 $X=497860 $Y=825060
X316 2403 2676 2899 2901 1 2563 2 AOI22S $T=504060 780080 1 180 $X=500340 $Y=779700
X317 2439 2457 2924 2649 1 2858 2 AOI22S $T=505300 800240 1 0 $X=505300 $Y=794820
X318 2563 2398 2963 2739 1 2418 2 AOI22S $T=510260 780080 1 180 $X=506540 $Y=779700
X319 2670 345 2953 401 1 3000 2 AOI22S $T=510260 830480 1 0 $X=510260 $Y=825060
X320 2505 2530 2930 2561 1 2529 2 AOI22S $T=511500 790160 0 0 $X=511500 $Y=789780
X321 2983 2992 3006 2584 1 2584 2 AOI22S $T=516460 729680 1 0 $X=516460 $Y=724260
X322 342 413 3034 333 1 409 2 AOI22S $T=520800 870800 1 180 $X=517080 $Y=870420
X323 2529 413 3019 345 1 3044 2 AOI22S $T=518320 840560 1 0 $X=518320 $Y=835140
X324 2702 2670 2774 2561 1 2529 2 AOI22S $T=522660 830480 1 180 $X=518940 $Y=830100
X325 305 2561 2990 2488 1 423 2 AOI22S $T=523900 820400 1 0 $X=523900 $Y=814980
X326 2901 2403 3035 3071 1 2563 2 AOI22S $T=525760 790160 1 0 $X=525760 $Y=784740
X327 3072 2439 3032 2619 1 2649 2 AOI22S $T=532580 810320 0 180 $X=528860 $Y=804900
X328 342 2403 3042 3121 1 3082 2 AOI22S $T=528860 840560 0 0 $X=528860 $Y=840180
X329 2619 2455 3097 3084 1 2496 2 AOI22S $T=536300 810320 1 180 $X=532580 $Y=809940
X330 2563 445 3091 298 1 2702 2 AOI22S $T=534440 830480 1 0 $X=534440 $Y=825060
X331 443 2418 3038 3073 1 345 2 AOI22S $T=535060 840560 1 0 $X=535060 $Y=835140
X332 443 418 3110 413 1 3131 2 AOI22S $T=538160 870800 0 0 $X=538160 $Y=870420
X333 2561 2676 3083 2439 1 2901 2 AOI22S $T=538780 780080 0 0 $X=538780 $Y=779700
X334 2901 423 3128 298 1 2649 2 AOI22S $T=542500 820400 0 180 $X=538780 $Y=814980
X335 2505 444 3139 2839 1 3121 2 AOI22S $T=544360 840560 1 180 $X=540640 $Y=840180
X336 2455 2418 3161 3071 1 2782 2 AOI22S $T=544980 800240 0 180 $X=541260 $Y=794820
X337 3103 3106 3133 461 1 457 2 AOI22S $T=544360 770000 1 0 $X=544360 $Y=764580
X338 3131 454 3112 466 1 459 2 AOI22S $T=544980 870800 0 0 $X=544980 $Y=870420
X339 3126 3145 3143 461 1 457 2 AOI22S $T=546220 749840 1 0 $X=546220 $Y=744420
X340 2534 2619 3155 2809 1 2739 2 AOI22S $T=548700 830480 0 0 $X=548700 $Y=830100
X341 3156 3144 3163 461 1 457 2 AOI22S $T=550560 749840 0 0 $X=550560 $Y=749460
X342 2676 2809 2855 3096 1 3182 2 AOI22S $T=551180 840560 0 0 $X=551180 $Y=840180
X343 3192 3169 3142 461 1 457 2 AOI22S $T=555520 719600 1 180 $X=551800 $Y=719220
X344 345 2739 3171 3129 1 3186 2 AOI22S $T=551800 830480 1 0 $X=551800 $Y=825060
X345 3173 3154 472 461 1 457 2 AOI22S $T=553040 699440 0 0 $X=553040 $Y=699060
X346 3224 3175 3176 461 1 457 2 AOI22S $T=559860 709520 1 180 $X=556140 $Y=709140
X347 3217 3191 484 461 1 457 2 AOI22S $T=561100 699440 0 0 $X=561100 $Y=699060
X348 3170 3197 3213 461 1 457 2 AOI22S $T=561720 780080 1 0 $X=561720 $Y=774660
X349 2702 2561 3275 2439 1 2619 2 AOI22S $T=572260 830480 0 180 $X=568540 $Y=825060
X350 3246 3254 3295 461 1 457 2 AOI22S $T=574120 800240 0 0 $X=574120 $Y=799860
X351 3338 3352 3362 461 1 457 2 AOI22S $T=584660 800240 0 0 $X=584660 $Y=799860
X352 454 526 3240 413 1 356 2 AOI22S $T=588380 860720 1 0 $X=588380 $Y=855300
X353 411 526 2965 536 1 533 2 AOI22S $T=590860 880880 1 0 $X=590860 $Y=875460
X354 3410 3423 3419 461 1 457 2 AOI22S $T=597060 810320 1 0 $X=597060 $Y=804900
X355 3467 3479 548 461 1 551 2 AOI22S $T=611320 699440 0 0 $X=611320 $Y=699060
X356 3483 3484 3499 461 1 457 2 AOI22S $T=615660 810320 0 180 $X=611940 $Y=804900
X357 3563 3545 3500 3577 1 3572 2 AOI22S $T=631160 759920 0 0 $X=631160 $Y=759540
X358 580 573 3553 3577 1 3563 2 AOI22S $T=636740 770000 0 180 $X=633020 $Y=764580
X359 3571 3560 3565 579 1 457 2 AOI22S $T=633020 810320 0 0 $X=633020 $Y=809940
X360 3562 3590 3559 3272 1 3577 2 AOI22S $T=635500 739760 0 0 $X=635500 $Y=739380
X361 3577 3272 3620 3638 1 3614 2 AOI22S $T=642320 739760 0 0 $X=642320 $Y=739380
X362 3654 3635 3613 559 1 457 2 AOI22S $T=646040 850640 1 180 $X=642320 $Y=850260
X363 3572 3590 3595 3577 1 3551 2 AOI22S $T=642940 759920 0 0 $X=642940 $Y=759540
X364 576 587 3619 3272 1 3577 2 AOI22S $T=642940 780080 0 0 $X=642940 $Y=779700
X365 3609 3638 3605 3584 1 3546 2 AOI22S $T=643560 770000 0 0 $X=643560 $Y=769620
X366 3626 3637 3576 559 1 457 2 AOI22S $T=644180 830480 0 0 $X=644180 $Y=830100
X367 3658 3646 3596 579 1 457 2 AOI22S $T=648520 820400 0 180 $X=644800 $Y=814980
X368 3629 3652 3639 579 1 551 2 AOI22S $T=646040 800240 0 0 $X=646040 $Y=799860
X369 589 590 3657 3584 1 3546 2 AOI22S $T=651620 780080 0 180 $X=647900 $Y=774660
X370 580 587 3666 3577 1 3551 2 AOI22S $T=651620 790160 0 180 $X=647900 $Y=784740
X371 3641 3655 3660 559 1 457 2 AOI22S $T=648520 870800 0 0 $X=648520 $Y=870420
X372 3258 3207 3650 3614 1 3638 2 AOI22S $T=649140 729680 0 0 $X=649140 $Y=729300
X373 580 590 3681 3207 1 3258 2 AOI22S $T=652860 749840 0 180 $X=649140 $Y=744420
X374 584 590 3691 3272 1 3577 2 AOI22S $T=652860 780080 1 180 $X=649140 $Y=779700
X375 3647 3668 3645 559 1 457 2 AOI22S $T=649760 840560 0 0 $X=649760 $Y=840180
X376 3659 3648 3644 559 1 457 2 AOI22S $T=651000 860720 0 0 $X=651000 $Y=860340
X377 3609 3572 3611 3584 1 3634 2 AOI22S $T=652860 770000 1 0 $X=652860 $Y=764580
X378 589 580 3687 3584 1 3634 2 AOI22S $T=657200 780080 0 180 $X=653480 $Y=774660
X379 590 584 3694 3207 1 3258 2 AOI22S $T=658440 749840 1 180 $X=654720 $Y=749460
X380 3258 3207 3684 3638 1 3572 2 AOI22S $T=655340 729680 0 0 $X=655340 $Y=729300
X381 3609 3259 3689 3614 1 3669 2 AOI22S $T=655340 739760 1 0 $X=655340 $Y=734340
X382 589 584 3716 3259 1 3669 2 AOI22S $T=660300 749840 0 180 $X=656580 $Y=744420
X383 3706 3706 3685 3705 1 3724 2 AOI22S $T=659060 840560 1 0 $X=659060 $Y=835140
X384 3714 3702 3696 579 1 551 2 AOI22S $T=661540 800240 0 0 $X=661540 $Y=799860
X385 3720 3720 3699 3705 1 3724 2 AOI22S $T=661540 850640 1 0 $X=661540 $Y=845220
X386 3748 3737 3686 579 1 551 2 AOI22S $T=666500 759920 0 180 $X=662780 $Y=754500
X387 3758 3741 3729 579 1 551 2 AOI22S $T=667120 770000 0 180 $X=663400 $Y=764580
X388 3733 3733 3700 3705 1 3724 2 AOI22S $T=663400 870800 0 0 $X=663400 $Y=870420
X389 3736 3739 3734 579 1 551 2 AOI22S $T=664020 790160 1 0 $X=664020 $Y=784740
X390 3746 3746 3731 3705 1 3724 2 AOI22S $T=668360 860720 0 180 $X=664640 $Y=855300
X391 3749 3749 3740 3705 1 3724 2 AOI22S $T=668980 840560 0 180 $X=665260 $Y=835140
X392 3762 3753 3743 579 1 551 2 AOI22S $T=670220 719600 1 180 $X=666500 $Y=719220
X393 3764 3757 3738 579 1 551 2 AOI22S $T=671460 739760 1 180 $X=667740 $Y=739380
X394 3760 3760 3715 3705 1 3724 2 AOI22S $T=671460 870800 0 180 $X=667740 $Y=865380
X395 3780 3768 3742 551 1 579 2 AOI22S $T=673320 709520 1 180 $X=669600 $Y=709140
X396 3779 3779 614 3705 1 3724 2 AOI22S $T=674560 870800 1 180 $X=670840 $Y=870420
X397 3820 3800 3713 579 1 551 2 AOI22S $T=678900 739760 0 180 $X=675180 $Y=734340
X398 644 3985 3975 3988 1 649 2 AOI22S $T=707420 719600 0 0 $X=707420 $Y=719220
X399 4002 3990 3996 3988 1 649 2 AOI22S $T=711760 729680 1 0 $X=711760 $Y=724260
X400 4011 3992 4014 3988 1 649 2 AOI22S $T=713000 709520 0 0 $X=713000 $Y=709140
X401 4002 3979 4016 3988 1 649 2 AOI22S $T=713000 729680 0 0 $X=713000 $Y=729300
X402 4070 4077 4042 668 1 670 2 AOI22S $T=722920 729680 1 0 $X=722920 $Y=724260
X403 4047 4084 4059 668 1 670 2 AOI22S $T=725400 739760 0 0 $X=725400 $Y=739380
X404 4069 4050 4051 668 1 670 2 AOI22S $T=726640 719600 1 0 $X=726640 $Y=714180
X405 4132 4119 4108 668 1 670 2 AOI22S $T=736560 759920 1 180 $X=732840 $Y=759540
X406 4131 4124 685 668 1 670 2 AOI22S $T=737180 709520 1 180 $X=733460 $Y=709140
X407 682 4138 681 668 1 670 2 AOI22S $T=735940 699440 0 0 $X=735940 $Y=699060
X408 4176 4152 4046 668 1 670 2 AOI22S $T=741520 709520 1 180 $X=737800 $Y=709140
X409 4161 4146 4153 670 1 668 2 AOI22S $T=740900 770000 0 0 $X=740900 $Y=769620
X410 4136 4110 4168 668 1 670 2 AOI22S $T=742140 739760 0 0 $X=742140 $Y=739380
X411 4160 4160 4173 4180 1 4200 2 AOI22S $T=744000 800240 1 0 $X=744000 $Y=794820
X412 4086 4086 4189 4180 1 4200 2 AOI22S $T=746480 830480 1 0 $X=746480 $Y=825060
X413 4165 4165 4203 4180 1 4200 2 AOI22S $T=748960 820400 0 0 $X=748960 $Y=820020
X414 4164 4164 4207 4180 1 4200 2 AOI22S $T=749580 790160 0 0 $X=749580 $Y=789780
X415 4205 4211 4210 668 1 670 2 AOI22S $T=750820 739760 0 0 $X=750820 $Y=739380
X416 4185 4185 4232 4180 1 4200 2 AOI22S $T=755160 800240 1 180 $X=751440 $Y=799860
X417 4145 4145 4218 4180 1 4200 2 AOI22S $T=752680 810320 0 0 $X=752680 $Y=809940
X418 4130 4130 4243 4180 1 4200 2 AOI22S $T=756400 820400 0 180 $X=752680 $Y=814980
X419 4154 4154 4254 4180 1 4200 2 AOI22S $T=758880 800240 0 180 $X=755160 $Y=794820
X420 4276 4251 4222 668 1 670 2 AOI22S $T=763220 780080 1 180 $X=759500 $Y=779700
X421 4272 4257 4209 668 1 670 2 AOI22S $T=763220 790160 1 180 $X=759500 $Y=789780
X422 4249 4275 4270 668 1 670 2 AOI22S $T=763840 749840 1 0 $X=763840 $Y=744420
X423 4252 4278 4230 668 1 670 2 AOI22S $T=763840 770000 1 0 $X=763840 $Y=764580
X424 4327 4334 4236 744 1 742 2 AOI22S $T=775000 830480 1 0 $X=775000 $Y=825060
X425 717 743 4350 4298 1 4318 2 AOI22S $T=779340 749840 1 180 $X=775620 $Y=749460
X426 4364 4300 4354 744 1 742 2 AOI22S $T=780580 820400 1 180 $X=776860 $Y=820020
X427 4369 739 4374 4356 1 4298 2 AOI22S $T=781820 749840 0 180 $X=778100 $Y=744420
X428 4353 4339 4357 744 1 742 2 AOI22S $T=778720 810320 1 0 $X=778720 $Y=804900
X429 4171 4263 4366 739 1 4369 2 AOI22S $T=781820 739760 1 0 $X=781820 $Y=734340
X430 4188 4318 4376 4383 1 4386 2 AOI22S $T=782440 759920 0 0 $X=782440 $Y=759540
X431 717 743 4392 4318 1 4140 2 AOI22S $T=787400 770000 1 180 $X=783680 $Y=769620
X432 4140 4263 4391 4369 1 4408 2 AOI22S $T=786160 749840 0 0 $X=786160 $Y=749460
X433 4422 4081 4418 4369 1 4140 2 AOI22S $T=791120 739760 0 180 $X=787400 $Y=734340
X434 4188 4140 4404 4383 1 4415 2 AOI22S $T=787400 759920 1 0 $X=787400 $Y=754500
X435 4188 735 4401 4298 1 4423 2 AOI22S $T=788020 770000 1 0 $X=788020 $Y=764580
X436 4405 4411 4317 668 1 670 2 AOI22S $T=788020 790160 1 0 $X=788020 $Y=784740
X437 4389 4377 4256 668 1 670 2 AOI22S $T=788640 780080 1 0 $X=788640 $Y=774660
X438 4417 4427 4193 744 1 742 2 AOI22S $T=790500 810320 0 0 $X=790500 $Y=809940
X439 4490 4522 4525 735 1 4423 2 AOI22S $T=813440 770000 0 180 $X=809720 $Y=764580
X440 4554 4522 4535 743 1 717 2 AOI22S $T=819020 759920 0 180 $X=815300 $Y=754500
X441 4560 4554 4518 743 1 717 2 AOI22S $T=819020 770000 0 180 $X=815300 $Y=764580
X442 4560 4574 4587 4369 1 4422 2 AOI22S $T=823360 739760 1 180 $X=819640 $Y=739380
X443 4490 4560 4578 4509 1 4415 2 AOI22S $T=823980 759920 1 180 $X=820260 $Y=759540
X444 4560 4584 4595 4369 1 4408 2 AOI22S $T=825220 749840 1 180 $X=821500 $Y=749460
X445 4602 4584 4598 739 1 4369 2 AOI22S $T=828940 739760 0 180 $X=825220 $Y=734340
X446 4490 4554 4608 4509 1 4386 2 AOI22S $T=829560 759920 0 180 $X=825840 $Y=754500
X447 4522 4554 4593 739 1 4369 2 AOI22S $T=830180 749840 1 180 $X=826460 $Y=749460
X448 4647 4644 4658 744 1 742 2 AOI22S $T=841960 759920 0 0 $X=841960 $Y=759540
X449 4652 4670 4665 744 1 742 2 AOI22S $T=844440 770000 0 0 $X=844440 $Y=769620
X450 4655 4676 4675 744 1 742 2 AOI22S $T=845680 759920 1 0 $X=845680 $Y=754500
X451 4664 4689 4685 744 1 742 2 AOI22S $T=848160 749840 1 0 $X=848160 $Y=744420
X452 4705 4723 4718 744 1 742 2 AOI22S $T=854980 739760 1 0 $X=854980 $Y=734340
X453 4735 4700 4710 846 1 848 2 AOI22S $T=860560 850640 0 0 $X=860560 $Y=850260
X454 4695 4727 4715 847 1 849 2 AOI22S $T=860560 860720 0 0 $X=860560 $Y=860340
X455 4729 4751 4746 744 1 742 2 AOI22S $T=861800 699440 0 0 $X=861800 $Y=699060
X456 4740 4761 4759 744 1 742 2 AOI22S $T=865520 719600 0 0 $X=865520 $Y=719220
X457 4733 4763 4769 744 1 742 2 AOI22S $T=867380 739760 0 0 $X=867380 $Y=739380
X458 4716 4774 4772 744 1 742 2 AOI22S $T=868000 729680 1 0 $X=868000 $Y=724260
X459 4713 4783 4775 744 1 742 2 AOI22S $T=870480 709520 1 0 $X=870480 $Y=704100
X460 4717 4780 4776 744 1 742 2 AOI22S $T=871100 719600 1 0 $X=871100 $Y=714180
X461 4789 4760 4792 846 1 848 2 AOI22S $T=871100 850640 1 0 $X=871100 $Y=845220
X462 4802 4811 4795 847 1 849 2 AOI22S $T=874200 870800 1 0 $X=874200 $Y=865380
X463 4839 4848 4847 846 1 848 2 AOI22S $T=881020 850640 0 0 $X=881020 $Y=850260
X464 4878 4874 4872 847 1 849 2 AOI22S $T=890320 860720 1 180 $X=886600 $Y=860340
X465 4933 4918 4932 846 1 848 2 AOI22S $T=903340 850640 1 180 $X=899620 $Y=850260
X466 4948 4939 4952 846 1 848 2 AOI22S $T=906440 850640 0 0 $X=906440 $Y=850260
X467 4919 4963 4946 847 1 849 2 AOI22S $T=906440 860720 0 0 $X=906440 $Y=860340
X468 5007 5004 5006 931 1 930 2 AOI22S $T=918220 780080 0 180 $X=914500 $Y=774660
X469 5010 5001 5009 847 1 849 2 AOI22S $T=918220 860720 1 180 $X=914500 $Y=860340
X470 5012 5021 5020 931 1 930 2 AOI22S $T=919460 800240 0 0 $X=919460 $Y=799860
X471 5047 5032 5048 846 1 848 2 AOI22S $T=924420 850640 1 180 $X=920700 $Y=850260
X472 5036 5042 5055 931 1 930 2 AOI22S $T=926900 739760 1 180 $X=923180 $Y=739380
X473 5038 5034 5056 931 1 930 2 AOI22S $T=927520 759920 0 180 $X=923800 $Y=754500
X474 5033 5058 5054 931 1 930 2 AOI22S $T=927520 729680 1 0 $X=927520 $Y=724260
X475 5076 5062 5070 846 1 848 2 AOI22S $T=931240 850640 1 180 $X=927520 $Y=850260
X476 5013 5051 5060 931 1 930 2 AOI22S $T=928140 780080 0 0 $X=928140 $Y=779700
X477 5017 5026 5031 931 1 930 2 AOI22S $T=928140 800240 1 0 $X=928140 $Y=794820
X478 5050 5052 5071 957 1 959 2 AOI22S $T=930000 759920 1 0 $X=930000 $Y=754500
X479 963 5077 5073 847 1 849 2 AOI22S $T=933720 870800 1 180 $X=930000 $Y=870420
X480 5085 5053 5081 931 1 930 2 AOI22S $T=934960 810320 1 180 $X=931240 $Y=809940
X481 5066 5067 958 931 1 930 2 AOI22S $T=931860 709520 1 0 $X=931860 $Y=704100
X482 5087 5090 5079 847 1 849 2 AOI22S $T=937440 860720 1 180 $X=933720 $Y=860340
X483 5072 5068 5086 957 1 959 2 AOI22S $T=934340 729680 1 0 $X=934340 $Y=724260
X484 5135 5094 5037 957 1 959 2 AOI22S $T=938060 790160 1 180 $X=934340 $Y=789780
X485 5080 5084 5089 957 1 959 2 AOI22S $T=934960 800240 1 0 $X=934960 $Y=794820
X486 5082 5099 5092 957 1 959 2 AOI22S $T=936200 820400 1 0 $X=936200 $Y=814980
X487 5088 5100 5104 957 1 959 2 AOI22S $T=938060 840560 1 0 $X=938060 $Y=835140
X488 5106 5107 5108 957 1 959 2 AOI22S $T=939300 739760 0 0 $X=939300 $Y=739380
X489 5057 5098 5059 957 1 959 2 AOI22S $T=941780 770000 0 0 $X=941780 $Y=769620
X490 968 5124 969 931 1 930 2 AOI22S $T=946120 699440 1 180 $X=942400 $Y=699060
X491 5110 5064 5120 931 1 930 2 AOI22S $T=943640 830480 0 0 $X=943640 $Y=830100
X492 5147 5133 5146 970 1 967 2 AOI22S $T=948600 870800 1 180 $X=944880 $Y=870420
X493 5109 5143 5117 957 1 959 2 AOI22S $T=951080 770000 0 180 $X=947360 $Y=764580
X494 5175 5179 5159 979 1 981 2 AOI22S $T=958520 870800 1 0 $X=958520 $Y=865380
X495 5198 5192 5193 957 1 959 2 AOI22S $T=967820 830480 1 180 $X=964100 $Y=830100
X496 5199 5184 5195 957 1 959 2 AOI22S $T=969060 759920 0 180 $X=965340 $Y=754500
X497 5230 5217 5220 957 1 959 2 AOI22S $T=976500 830480 1 180 $X=972780 $Y=830100
X498 5209 5211 5197 931 1 930 2 AOI22S $T=973400 820400 1 0 $X=973400 $Y=814980
X499 5243 5247 5039 897 1 1010 2 AOI22S $T=982080 790160 1 0 $X=982080 $Y=784740
X500 5245 5249 5239 931 1 930 2 AOI22S $T=985800 820400 1 180 $X=982080 $Y=820020
X501 5241 5250 5242 931 1 930 2 AOI22S $T=988900 759920 0 180 $X=985180 $Y=754500
X502 5269 5264 5063 897 1 1010 2 AOI22S $T=992620 780080 1 180 $X=988900 $Y=779700
X503 5272 5267 5115 897 1 1010 2 AOI22S $T=993860 749840 0 180 $X=990140 $Y=744420
X504 5262 5268 5145 897 1 1010 2 AOI22S $T=990760 800240 0 0 $X=990760 $Y=799860
X505 5265 5270 5207 897 1 1010 2 AOI22S $T=992000 709520 0 0 $X=992000 $Y=709140
X506 5263 5271 5093 897 1 1010 2 AOI22S $T=992000 729680 1 0 $X=992000 $Y=724260
X507 5261 5273 5191 897 1 1010 2 AOI22S $T=992620 820400 0 0 $X=992620 $Y=820020
X508 5251 5279 5102 897 1 1010 2 AOI22S $T=997580 749840 0 180 $X=993860 $Y=744420
X509 5283 5282 5122 897 1 1010 2 AOI22S $T=998200 770000 0 180 $X=994480 $Y=764580
X510 5278 5281 5127 897 1 1010 2 AOI22S $T=995100 840560 1 0 $X=995100 $Y=835140
X511 5280 5285 5227 897 1 1010 2 AOI22S $T=1000060 759920 0 180 $X=996340 $Y=754500
X512 5277 5287 5096 897 1 1010 2 AOI22S $T=997580 810320 0 0 $X=997580 $Y=809940
X513 5292 5289 5218 897 1 1010 2 AOI22S $T=1003160 820400 1 180 $X=999440 $Y=820020
X514 5307 5298 5302 1023 1 999 2 AOI22S $T=1006260 790160 0 180 $X=1002540 $Y=784740
X515 5297 5295 5300 1023 1 999 2 AOI22S $T=1004400 739760 1 0 $X=1004400 $Y=734340
X516 5314 5315 5319 1023 1 999 2 AOI22S $T=1009360 719600 1 0 $X=1009360 $Y=714180
X517 5305 5321 1026 5323 1 5335 2 AOI22S $T=1009980 699440 0 0 $X=1009980 $Y=699060
X518 5322 5324 5313 1023 1 999 2 AOI22S $T=1011220 820400 0 0 $X=1011220 $Y=820020
X519 5327 5329 5306 1023 1 999 2 AOI22S $T=1016180 770000 1 180 $X=1012460 $Y=769620
X520 5339 5332 5367 1023 1 999 2 AOI22S $T=1017420 759920 0 180 $X=1013700 $Y=754500
X521 5318 5325 5330 1023 1 999 2 AOI22S $T=1014320 729680 1 0 $X=1014320 $Y=724260
X522 5296 5336 5333 1023 1 999 2 AOI22S $T=1014940 810320 1 0 $X=1014940 $Y=804900
X523 5340 5344 5299 5323 1 5335 2 AOI22S $T=1016800 770000 0 0 $X=1016800 $Y=769620
X524 5334 5345 5342 1023 1 999 2 AOI22S $T=1016800 820400 0 0 $X=1016800 $Y=820020
X525 5341 5346 1030 5323 1 5335 2 AOI22S $T=1017420 699440 0 0 $X=1017420 $Y=699060
X526 5328 5349 5348 1023 1 999 2 AOI22S $T=1018660 810320 1 0 $X=1018660 $Y=804900
X527 5369 5361 5394 1023 1 999 2 AOI22S $T=1026720 749840 0 180 $X=1023000 $Y=744420
X528 5363 5366 5383 1023 1 999 2 AOI22S $T=1027340 840560 0 180 $X=1023620 $Y=835140
X529 5358 5365 5362 1023 1 999 2 AOI22S $T=1024240 780080 0 0 $X=1024240 $Y=779700
X530 5359 5371 5356 5323 1 5335 2 AOI22S $T=1025480 719600 1 0 $X=1025480 $Y=714180
X531 5368 5364 5347 5323 1 5335 2 AOI22S $T=1026720 739760 0 0 $X=1026720 $Y=739380
X532 5380 5376 5373 5323 1 5335 2 AOI22S $T=1031060 759920 0 180 $X=1027340 $Y=754500
X533 5385 5378 5382 5323 1 5335 2 AOI22S $T=1032300 790160 0 180 $X=1028580 $Y=784740
X534 5386 5370 5374 5323 1 5335 2 AOI22S $T=1032300 800240 1 180 $X=1028580 $Y=799860
X535 5391 5379 5354 5323 1 5335 2 AOI22S $T=1032300 810320 1 180 $X=1028580 $Y=809940
X536 5392 5389 1033 5323 1 5335 2 AOI22S $T=1034160 709520 0 180 $X=1030440 $Y=704100
X537 5400 5387 5377 5323 1 5335 2 AOI22S $T=1034160 729680 0 180 $X=1030440 $Y=724260
X538 5372 5388 5384 5323 1 5335 2 AOI22S $T=1031680 770000 0 0 $X=1031680 $Y=769620
X539 5408 5401 5405 5323 1 5335 2 AOI22S $T=1038500 749840 0 180 $X=1034780 $Y=744420
X540 5390 5399 5393 5323 1 5335 2 AOI22S $T=1034780 840560 1 0 $X=1034780 $Y=835140
X541 5398 5395 5304 5323 1 5335 2 AOI22S $T=1035400 820400 0 0 $X=1035400 $Y=820020
X542 5396 5397 5406 5323 1 5335 2 AOI22S $T=1040360 820400 0 180 $X=1036640 $Y=814980
X543 5410 5404 1036 5323 1 5335 2 AOI22S $T=1040980 699440 1 180 $X=1037260 $Y=699060
X544 5411 5420 5417 5421 1 5407 2 AOI22S $T=1045320 739760 1 0 $X=1045320 $Y=734340
X545 5432 5426 5412 1039 1 1006 2 AOI22S $T=1050900 729680 1 180 $X=1047180 $Y=729300
X546 5403 5413 5427 5421 1 5407 2 AOI22S $T=1048420 790160 1 0 $X=1048420 $Y=784740
X547 5419 5423 5424 5421 1 5407 2 AOI22S $T=1048420 840560 1 0 $X=1048420 $Y=835140
X548 5440 5429 1041 5421 1 5407 2 AOI22S $T=1053380 709520 0 180 $X=1049660 $Y=704100
X549 5438 5434 5425 5421 1 5407 2 AOI22S $T=1054000 790160 1 180 $X=1050280 $Y=789780
X550 5428 5433 5430 1039 1 1006 2 AOI22S $T=1050900 759920 0 0 $X=1050900 $Y=759540
X551 5435 5436 5414 1039 1 1006 2 AOI22S $T=1053380 840560 0 0 $X=1053380 $Y=840180
X552 5454 5431 5459 979 1 981 2 AOI22S $T=1057100 860720 1 180 $X=1053380 $Y=860340
X553 5452 5444 1043 5421 1 5407 2 AOI22S $T=1061440 709520 0 180 $X=1057720 $Y=704100
X554 5450 5445 5441 5421 1 5407 2 AOI22S $T=1061440 759920 0 180 $X=1057720 $Y=754500
X555 5449 5446 5437 1039 1 1006 2 AOI22S $T=1061440 770000 0 180 $X=1057720 $Y=764580
X556 5455 5448 5422 1039 1 1006 2 AOI22S $T=1062680 800240 0 180 $X=1058960 $Y=794820
X557 5439 5443 5451 1039 1 1006 2 AOI22S $T=1061440 810320 0 0 $X=1061440 $Y=809940
X558 5442 5456 5453 5421 1 5407 2 AOI22S $T=1063920 820400 0 0 $X=1063920 $Y=820020
X559 5461 5460 1045 5421 1 5407 2 AOI22S $T=1068260 709520 0 180 $X=1064540 $Y=704100
X560 5457 5463 5477 1039 1 1006 2 AOI22S $T=1069500 719600 1 180 $X=1065780 $Y=719220
X561 5478 5464 5466 5421 1 5407 2 AOI22S $T=1069500 749840 0 180 $X=1065780 $Y=744420
X562 5488 5474 5462 1039 1 1006 2 AOI22S $T=1072600 759920 1 180 $X=1068880 $Y=759540
X563 5479 5476 5473 5421 1 5407 2 AOI22S $T=1074460 780080 1 180 $X=1070740 $Y=779700
X564 5489 5480 5468 1039 1 1006 2 AOI22S $T=1075700 800240 0 180 $X=1071980 $Y=794820
X565 5507 5481 5486 1039 1 1006 2 AOI22S $T=1076320 749840 1 180 $X=1072600 $Y=749460
X566 5506 5485 5482 1039 1 1006 2 AOI22S $T=1076940 850640 1 180 $X=1073220 $Y=850260
X567 5471 5484 5447 1039 1 1006 2 AOI22S $T=1073840 830480 0 0 $X=1073840 $Y=830100
X568 5500 5492 5483 5421 1 5407 2 AOI22S $T=1080660 820400 0 180 $X=1076940 $Y=814980
X569 5508 5493 5494 970 1 967 2 AOI22S $T=1081900 860720 0 180 $X=1078180 $Y=855300
X570 5501 5495 5487 5421 1 5407 2 AOI22S $T=1084380 719600 1 180 $X=1080660 $Y=719220
X571 5505 5496 5475 5421 1 5407 2 AOI22S $T=1084380 790160 1 180 $X=1080660 $Y=789780
X572 5502 5498 5491 5421 1 5407 2 AOI22S $T=1085000 739760 1 180 $X=1081280 $Y=739380
X573 5509 1047 1048 5421 1 5407 2 AOI22S $T=1085620 699440 1 180 $X=1081900 $Y=699060
X574 5497 5503 5490 5421 1 5407 2 AOI22S $T=1088100 820400 1 180 $X=1084380 $Y=820020
X575 5499 5504 5465 1039 1 1006 2 AOI22S $T=1088720 780080 1 180 $X=1085000 $Y=779700
X576 1197 1176 1 2 1165 AN2 $T=229400 790160 1 180 $X=226920 $Y=789780
X577 1252 1257 1 2 1247 AN2 $T=239320 729680 1 180 $X=236840 $Y=729300
X578 1193 1261 1 2 1268 AN2 $T=237460 840560 0 0 $X=237460 $Y=840180
X579 29 1296 1 2 1333 AN2 $T=252340 709520 0 180 $X=249860 $Y=704100
X580 1229 1417 1 2 1428 AN2 $T=257300 770000 1 0 $X=257300 $Y=764580
X581 52 1353 1 2 1493 AN2 $T=265360 759920 1 0 $X=265360 $Y=754500
X582 1321 1480 1 2 1461 AN2 $T=268460 790160 1 180 $X=265980 $Y=789780
X583 1590 1572 1 2 1523 AN2 $T=282100 830480 1 180 $X=279620 $Y=830100
X584 1615 1645 1 2 1289 AN2 $T=293260 840560 1 0 $X=293260 $Y=835140
X585 1693 94 1 2 1682 AN2 $T=305040 880880 0 180 $X=302560 $Y=875460
X586 1716 1701 1 2 1608 AN2 $T=307520 860720 0 180 $X=305040 $Y=855300
X587 94 89 1 2 96 AN2 $T=306280 880880 1 0 $X=306280 $Y=875460
X588 1731 1720 1 2 1544 AN2 $T=311240 840560 1 180 $X=308760 $Y=840180
X589 1368 1585 1 2 1739 AN2 $T=317440 770000 0 0 $X=317440 $Y=769620
X590 1307 1764 1 2 1417 AN2 $T=325500 759920 0 0 $X=325500 $Y=759540
X591 1779 1618 1 2 1799 AN2 $T=325500 780080 0 0 $X=325500 $Y=779700
X592 1342 1802 1 2 1797 AN2 $T=330460 800240 0 180 $X=327980 $Y=794820
X593 74 7 1 2 1835 AN2 $T=334180 739760 1 0 $X=334180 $Y=734340
X594 1218 1305 1 2 1869 AN2 $T=341000 749840 1 0 $X=341000 $Y=744420
X595 1871 1794 1 2 1889 AN2 $T=344100 850640 0 0 $X=344100 $Y=850260
X596 1880 1866 1 2 1914 AN2 $T=350300 719600 0 0 $X=350300 $Y=719220
X597 147 1929 1 2 1778 AN2 $T=355260 840560 1 180 $X=352780 $Y=840180
X598 1947 1931 1 2 1923 AN2 $T=355880 749840 1 180 $X=353400 $Y=749460
X599 1929 1959 1 2 1829 AN2 $T=359600 840560 1 180 $X=357120 $Y=840180
X600 1926 1934 1 2 111 AN2 $T=360840 860720 0 180 $X=358360 $Y=855300
X601 1979 1843 1 2 1901 AN2 $T=364560 860720 0 180 $X=362080 $Y=855300
X602 2003 1991 1 2 1947 AN2 $T=366420 749840 1 180 $X=363940 $Y=749460
X603 1998 1906 1 2 2018 AN2 $T=367660 739760 0 0 $X=367660 $Y=739380
X604 1971 1875 1 2 1957 AN2 $T=370140 780080 0 180 $X=367660 $Y=774660
X605 1921 1906 1 2 2033 AN2 $T=371380 739760 0 0 $X=371380 $Y=739380
X606 2027 2030 1 2 2040 AN2 $T=372620 709520 0 0 $X=372620 $Y=709140
X607 2036 2040 1 2 171 AN2 $T=378200 709520 0 180 $X=375720 $Y=704100
X608 2054 2061 1 2 2072 AN2 $T=376340 719600 0 0 $X=376340 $Y=719220
X609 2083 2072 1 2 2030 AN2 $T=380060 719600 0 180 $X=377580 $Y=714180
X610 2062 2075 1 2 2061 AN2 $T=380680 729680 1 180 $X=378200 $Y=729300
X611 2055 2073 1 2 2075 AN2 $T=378200 739760 1 0 $X=378200 $Y=734340
X612 2077 2022 1 2 1856 AN2 $T=387500 840560 0 180 $X=385020 $Y=835140
X613 1974 1848 1 2 2119 AN2 $T=386260 820400 0 0 $X=386260 $Y=820020
X614 2077 2014 1 2 1899 AN2 $T=389360 830480 1 180 $X=386880 $Y=830100
X615 167 2014 1 2 2152 AN2 $T=401140 840560 1 180 $X=398660 $Y=840180
X616 167 2014 1 2 2226 AN2 $T=401760 830480 0 0 $X=401760 $Y=830100
X617 2175 2180 1 2 2237 AN2 $T=403000 749840 1 0 $X=403000 $Y=744420
X618 2225 2112 1 2 2211 AN2 $T=404860 780080 1 0 $X=404860 $Y=774660
X619 2251 186 1 2 2231 AN2 $T=408580 729680 1 180 $X=406100 $Y=729300
X620 2290 186 1 2 2269 AN2 $T=416020 729680 1 180 $X=413540 $Y=729300
X621 2272 229 1 2 2291 AN2 $T=413540 800240 0 0 $X=413540 $Y=799860
X622 2281 2298 1 2 2305 AN2 $T=416020 749840 1 0 $X=416020 $Y=744420
X623 2265 229 1 2 2317 AN2 $T=417260 800240 0 0 $X=417260 $Y=799860
X624 2315 186 1 2 2287 AN2 $T=420360 729680 1 180 $X=417880 $Y=729300
X625 2254 229 1 2 2323 AN2 $T=419120 790160 0 0 $X=419120 $Y=789780
X626 2318 2305 1 2 2331 AN2 $T=420360 749840 1 0 $X=420360 $Y=744420
X627 2267 186 1 2 2332 AN2 $T=421600 729680 1 0 $X=421600 $Y=724260
X628 2326 229 1 2 2337 AN2 $T=421600 780080 0 0 $X=421600 $Y=779700
X629 2327 229 1 2 2339 AN2 $T=421600 800240 0 0 $X=421600 $Y=799860
X630 2324 147 1 2 2341 AN2 $T=422220 830480 1 0 $X=422220 $Y=825060
X631 2309 229 1 2 2352 AN2 $T=422840 770000 0 0 $X=422840 $Y=769620
X632 2329 2263 1 2 2364 AN2 $T=424700 820400 0 0 $X=424700 $Y=820020
X633 2329 147 1 2 2371 AN2 $T=425320 820400 1 0 $X=425320 $Y=814980
X634 2373 2368 1 2 244 AN2 $T=428420 709520 0 180 $X=425940 $Y=704100
X635 2324 2263 1 2 2375 AN2 $T=425940 830480 1 0 $X=425940 $Y=825060
X636 2349 2359 1 2 2379 AN2 $T=426560 719600 1 0 $X=426560 $Y=714180
X637 2360 2380 1 2 2359 AN2 $T=429660 729680 1 180 $X=427180 $Y=729300
X638 2351 2345 1 2 2380 AN2 $T=427180 739760 1 0 $X=427180 $Y=734340
X639 2393 2379 1 2 2404 AN2 $T=430280 719600 1 0 $X=430280 $Y=714180
X640 2412 2404 1 2 2373 AN2 $T=434000 709520 1 180 $X=431520 $Y=709140
X641 248 220 1 2 2440 AN2 $T=435240 860720 0 0 $X=435240 $Y=860340
X642 2546 2554 1 2 2589 AN2 $T=456320 770000 1 0 $X=456320 $Y=764580
X643 2565 2573 1 2 2602 AN2 $T=458800 719600 0 0 $X=458800 $Y=719220
X644 2586 2580 1 2 2629 AN2 $T=462520 749840 0 0 $X=462520 $Y=749460
X645 2612 2608 1 2 2606 AN2 $T=463140 770000 0 0 $X=463140 $Y=769620
X646 2641 300 1 2 2598 AN2 $T=466240 739760 1 180 $X=463760 $Y=739380
X647 2668 229 1 2 2621 AN2 $T=469960 780080 1 180 $X=467480 $Y=779700
X648 2692 300 1 2 2659 AN2 $T=471820 739760 1 180 $X=469340 $Y=739380
X649 2733 300 1 2 2698 AN2 $T=479260 749840 0 180 $X=476780 $Y=744420
X650 2770 229 1 2 2719 AN2 $T=483600 770000 0 180 $X=481120 $Y=764580
X651 2777 2785 1 2 2794 AN2 $T=483600 729680 0 0 $X=483600 $Y=729300
X652 2768 2786 1 2 2785 AN2 $T=483600 739760 1 0 $X=483600 $Y=734340
X653 2789 2794 1 2 2807 AN2 $T=486700 719600 0 0 $X=486700 $Y=719220
X654 2808 2754 1 2 2786 AN2 $T=489180 749840 1 180 $X=486700 $Y=749460
X655 2807 2816 1 2 2798 AN2 $T=491040 719600 0 180 $X=488560 $Y=714180
X656 2882 229 1 2 2792 AN2 $T=499720 770000 0 180 $X=497240 $Y=764580
X657 2662 2718 1 2 2978 AN2 $T=522040 830480 0 180 $X=519560 $Y=825060
X658 424 229 1 2 2831 AN2 $T=525760 739760 0 180 $X=523280 $Y=734340
X659 429 229 1 2 3029 AN2 $T=527620 739760 1 180 $X=525140 $Y=739380
X660 435 229 1 2 2891 AN2 $T=532580 709520 0 180 $X=530100 $Y=704100
X661 438 229 1 2 2938 AN2 $T=533820 709520 1 180 $X=531340 $Y=709140
X662 451 229 1 2 2893 AN2 $T=544360 729680 1 180 $X=541880 $Y=729300
X663 3104 3116 1 2 3136 AN2 $T=541880 759920 1 0 $X=541880 $Y=754500
X664 3152 456 1 2 3231 AN2 $T=567920 729680 1 180 $X=565440 $Y=729300
X665 3378 3340 1 2 3421 AN2 $T=595820 820400 0 0 $X=595820 $Y=820020
X666 3421 3432 1 2 3459 AN2 $T=603880 820400 0 0 $X=603880 $Y=820020
X667 3487 553 1 2 3395 AN2 $T=614420 850640 0 0 $X=614420 $Y=850260
X668 3459 3297 1 2 3515 AN2 $T=618760 820400 0 0 $X=618760 $Y=820020
X669 3336 3349 1 2 3523 AN2 $T=621860 759920 0 0 $X=621860 $Y=759540
X670 3523 3358 1 2 3527 AN2 $T=626200 759920 0 180 $X=623720 $Y=754500
X671 3557 3440 1 2 457 AN2 $T=630540 840560 1 180 $X=628060 $Y=840180
X672 3518 3427 1 2 3529 AN2 $T=630540 860720 1 180 $X=628060 $Y=860340
X673 3515 3348 1 2 3561 AN2 $T=628680 820400 0 0 $X=628680 $Y=820020
X674 3582 3324 1 2 3616 AN2 $T=641080 729680 0 0 $X=641080 $Y=729300
X675 3561 3506 1 2 3698 AN2 $T=655960 820400 1 0 $X=655960 $Y=814980
X676 600 3711 1 2 3705 AN2 $T=661540 830480 1 180 $X=659060 $Y=830100
X677 600 3720 1 2 3724 AN2 $T=665260 840560 1 180 $X=662780 $Y=840180
X678 3698 3505 1 2 3747 AN2 $T=664640 810320 0 0 $X=664640 $Y=809940
X679 500 3651 1 2 3793 AN2 $T=670220 770000 1 0 $X=670220 $Y=764580
X680 3788 3674 1 2 3766 AN2 $T=675180 810320 1 180 $X=672700 $Y=809940
X681 3789 3787 1 2 3777 AN2 $T=675180 830480 1 180 $X=672700 $Y=830100
X682 3806 580 1 2 3771 AN2 $T=677660 800240 0 180 $X=675180 $Y=794820
X683 3747 3545 1 2 3788 AN2 $T=675180 820400 1 0 $X=675180 $Y=814980
X684 3793 3414 1 2 3814 AN2 $T=675800 770000 1 0 $X=675800 $Y=764580
X685 3794 584 1 2 3808 AN2 $T=675800 780080 0 0 $X=675800 $Y=779700
X686 3809 3572 1 2 3797 AN2 $T=678900 800240 1 180 $X=676420 $Y=799860
X687 3815 3805 1 2 3799 AN2 $T=678900 860720 1 180 $X=676420 $Y=860340
X688 3798 3802 1 2 3789 AN2 $T=677040 840560 0 0 $X=677040 $Y=840180
X689 3766 3590 1 2 3816 AN2 $T=678280 810320 1 0 $X=678280 $Y=804900
X690 3808 590 1 2 3806 AN2 $T=678900 790160 1 0 $X=678900 $Y=784740
X691 3799 3817 1 2 3798 AN2 $T=681380 850640 1 0 $X=681380 $Y=845220
X692 3832 3638 1 2 3809 AN2 $T=684480 810320 0 180 $X=682000 $Y=804900
X693 3814 3633 1 2 3847 AN2 $T=683240 759920 0 0 $X=683240 $Y=759540
X694 3837 3566 1 2 3828 AN2 $T=685720 770000 1 180 $X=683240 $Y=769620
X695 3828 573 1 2 3844 AN2 $T=683240 780080 1 0 $X=683240 $Y=774660
X696 3816 3614 1 2 3832 AN2 $T=687580 810320 0 180 $X=685100 $Y=804900
X697 3841 587 1 2 3794 AN2 $T=688200 780080 1 180 $X=685720 $Y=779700
X698 3865 554 1 2 3837 AN2 $T=689440 770000 0 180 $X=686960 $Y=764580
X699 3844 576 1 2 3841 AN2 $T=690060 790160 0 180 $X=687580 $Y=784740
X700 3847 3511 1 2 3865 AN2 $T=688200 759920 0 0 $X=688200 $Y=759540
X701 3867 3872 1 2 3877 AN2 $T=690060 860720 0 0 $X=690060 $Y=860340
X702 3879 3880 1 2 3897 AN2 $T=691300 800240 1 0 $X=691300 $Y=794820
X703 3912 3918 1 2 3934 AN2 $T=698120 780080 1 0 $X=698120 $Y=774660
X704 641 642 1 2 3956 AN2 $T=699980 699440 0 0 $X=699980 $Y=699060
X705 3903 3925 1 2 3953 AN2 $T=700600 739760 0 0 $X=700600 $Y=739380
X706 3967 3945 1 2 3936 AN2 $T=703080 860720 0 180 $X=700600 $Y=855300
X707 3921 3915 1 2 3951 AN2 $T=701840 770000 1 0 $X=701840 $Y=764580
X708 3900 3948 1 2 3962 AN2 $T=702460 749840 0 0 $X=702460 $Y=749460
X709 3950 3958 1 2 3969 AN2 $T=703080 719600 0 0 $X=703080 $Y=719220
X710 3956 3968 1 2 3950 AN2 $T=706180 709520 1 180 $X=703700 $Y=709140
X711 3932 3935 1 2 3964 AN2 $T=706800 810320 0 180 $X=704320 $Y=804900
X712 3972 3973 1 2 3991 AN2 $T=710520 850640 0 0 $X=710520 $Y=850260
X713 4064 4074 1 2 4089 AN2 $T=724780 790160 1 0 $X=724780 $Y=784740
X714 4113 4096 1 2 4100 AN2 $T=733460 810320 0 180 $X=730980 $Y=804900
X715 4102 4093 1 2 4113 AN2 $T=730980 810320 0 0 $X=730980 $Y=809940
X716 4100 4101 1 2 4118 AN2 $T=732220 800240 0 0 $X=732220 $Y=799860
X717 4118 4112 1 2 4123 AN2 $T=734080 800240 1 0 $X=734080 $Y=794820
X718 4123 4126 1 2 4147 AN2 $T=735940 790160 0 0 $X=735940 $Y=789780
X719 3988 4163 1 2 4180 AN2 $T=744000 800240 0 0 $X=744000 $Y=799860
X720 3988 4185 1 2 4200 AN2 $T=750200 810320 1 0 $X=750200 $Y=804900
X721 4226 679 1 2 4215 AN2 $T=757020 729680 0 180 $X=754540 $Y=724260
X722 4231 4129 1 2 4246 AN2 $T=756400 719600 1 0 $X=756400 $Y=714180
X723 4215 4079 1 2 4242 AN2 $T=756400 840560 0 0 $X=756400 $Y=840180
X724 713 712 1 2 4231 AN2 $T=759500 709520 0 180 $X=757020 $Y=704100
X725 4246 4237 1 2 4226 AN2 $T=760120 729680 0 180 $X=757640 $Y=724260
X726 4282 4140 1 2 4224 AN2 $T=765700 840560 0 180 $X=763220 $Y=835140
X727 4289 4283 1 2 4305 AN2 $T=772520 840560 1 0 $X=772520 $Y=835140
X728 4340 4318 1 2 4282 AN2 $T=776860 830480 1 180 $X=774380 $Y=830100
X729 4305 4295 1 2 4360 AN2 $T=775620 840560 0 0 $X=775620 $Y=840180
X730 4360 4171 1 2 4379 AN2 $T=779340 840560 0 0 $X=779340 $Y=840180
X731 4379 4263 1 2 4390 AN2 $T=783060 840560 0 0 $X=783060 $Y=840180
X732 4390 4298 1 2 4340 AN2 $T=786160 840560 0 180 $X=783680 $Y=835140
X733 4293 4432 1 2 742 AN2 $T=792360 800240 1 0 $X=792360 $Y=794820
X734 4455 553 1 2 4448 AN2 $T=802900 790160 0 180 $X=800420 $Y=784740
X735 4436 762 1 2 4443 AN2 $T=804140 739760 0 180 $X=801660 $Y=734340
X736 4441 737 1 2 4434 AN2 $T=801660 749840 0 0 $X=801660 $Y=749460
X737 749 748 1 2 4436 AN2 $T=805380 739760 1 0 $X=805380 $Y=734340
X738 4452 4511 1 2 4620 AN2 $T=831420 810320 1 0 $X=831420 $Y=804900
X739 4662 4558 1 2 4667 AN2 $T=843200 780080 0 0 $X=843200 $Y=779700
X740 4619 4629 1 2 4666 AN2 $T=843200 800240 0 0 $X=843200 $Y=799860
X741 4753 4560 1 2 4767 AN2 $T=864280 770000 0 0 $X=864280 $Y=769620
X742 4809 4522 1 2 4787 AN2 $T=873580 749840 1 180 $X=871100 $Y=749460
X743 864 865 1 2 872 AN2 $T=872340 699440 0 0 $X=872340 $Y=699060
X744 872 825 1 2 4820 AN2 $T=875440 699440 0 0 $X=875440 $Y=699060
X745 4787 4554 1 2 4753 AN2 $T=875440 770000 0 0 $X=875440 $Y=769620
X746 4837 4584 1 2 4809 AN2 $T=880400 739760 1 180 $X=877920 $Y=739380
X747 4820 823 1 2 4875 AN2 $T=885360 699440 0 0 $X=885360 $Y=699060
X748 4869 4609 1 2 4880 AN2 $T=888460 719600 0 0 $X=888460 $Y=719220
X749 4883 4602 1 2 4837 AN2 $T=892800 739760 0 180 $X=890320 $Y=734340
X750 4875 815 1 2 4869 AN2 $T=894660 709520 1 180 $X=892180 $Y=709140
X751 4891 4574 1 2 4883 AN2 $T=894660 729680 1 180 $X=892180 $Y=729300
X752 4880 4650 1 2 4891 AN2 $T=893420 729680 1 0 $X=893420 $Y=724260
X753 4942 4558 1 2 4927 AN2 $T=905200 770000 0 180 $X=902720 $Y=764580
X754 4975 4558 1 2 4893 AN2 $T=910160 780080 1 0 $X=910160 $Y=774660
X755 5030 4558 1 2 5019 AN2 $T=922560 790160 0 180 $X=920080 $Y=784740
X756 5041 4558 1 2 5040 AN2 $T=924420 749840 0 0 $X=924420 $Y=749460
X757 5103 4558 1 2 5061 AN2 $T=936200 800240 1 180 $X=933720 $Y=799860
X758 5118 4558 1 2 5128 AN2 $T=943020 739760 0 0 $X=943020 $Y=739380
X759 5129 4558 1 2 5131 AN2 $T=944880 749840 0 0 $X=944880 $Y=749460
X760 5157 5112 1 2 930 AN2 $T=950460 850640 1 180 $X=947980 $Y=850260
X761 5157 5126 1 2 5139 AN2 $T=952320 860720 0 180 $X=949840 $Y=855300
X762 5157 5123 1 2 5155 AN2 $T=951700 850640 1 0 $X=951700 $Y=845220
X763 5157 5136 1 2 5152 AN2 $T=951700 850640 0 0 $X=951700 $Y=850260
X764 5165 5112 1 2 975 AN2 $T=956660 860720 0 180 $X=954180 $Y=855300
X765 5165 5123 1 2 979 AN2 $T=955420 850640 1 0 $X=955420 $Y=845220
X766 5165 5136 1 2 931 AN2 $T=956040 850640 0 0 $X=956040 $Y=850260
X767 5165 5126 1 2 981 AN2 $T=957900 860720 1 0 $X=957900 $Y=855300
X768 5126 4693 1 2 985 AN2 $T=960380 860720 1 0 $X=960380 $Y=855300
X769 5126 5194 1 2 990 AN2 $T=965960 860720 1 0 $X=965960 $Y=855300
X770 4693 5112 1 2 997 AN2 $T=971540 860720 1 0 $X=971540 $Y=855300
X771 5136 4693 1 2 999 AN2 $T=973400 840560 0 0 $X=973400 $Y=840180
X772 5123 4693 1 2 1000 AN2 $T=973400 850640 0 0 $X=973400 $Y=850260
X773 5112 5194 1 2 1004 AN2 $T=974640 860720 1 0 $X=974640 $Y=855300
X774 5221 4558 1 2 5223 AN2 $T=978980 749840 0 180 $X=976500 $Y=744420
X775 5136 5194 1 2 1006 AN2 $T=976500 840560 0 0 $X=976500 $Y=840180
X776 5123 5194 1 2 5407 AN2 $T=977120 850640 1 0 $X=977120 $Y=845220
X777 5240 4558 1 2 5231 AN2 $T=982080 800240 0 180 $X=979600 $Y=794820
X778 5246 4558 1 2 5202 AN2 $T=982700 759920 1 0 $X=982700 $Y=754500
X779 5266 4558 1 2 5252 AN2 $T=988280 790160 0 180 $X=985800 $Y=784740
X780 5288 4558 1 2 5293 AN2 $T=1000060 800240 1 0 $X=1000060 $Y=794820
X781 5301 4558 1 2 5290 AN2 $T=1003780 749840 0 180 $X=1001300 $Y=744420
X782 5308 4558 1 2 5310 AN2 $T=1006260 800240 1 0 $X=1006260 $Y=794820
X783 5353 4558 1 2 5350 AN2 $T=1022380 739760 0 180 $X=1019900 $Y=734340
X784 5417 5412 1 2 5375 AN2 $T=1044080 729680 1 180 $X=1041600 $Y=729300
X785 5424 5414 1 2 5381 AN2 $T=1045320 840560 0 180 $X=1042840 $Y=835140
X786 5425 5422 1 2 5409 AN2 $T=1048420 790160 0 180 $X=1045940 $Y=784740
X787 5441 5430 1 2 5360 AN2 $T=1054000 759920 0 180 $X=1051520 $Y=754500
X788 5427 5437 1 2 5320 AN2 $T=1057100 770000 0 180 $X=1054620 $Y=764580
X789 5453 5447 1 2 5416 AN2 $T=1060820 820400 1 180 $X=1058340 $Y=820020
X790 5466 5462 1 2 5402 AN2 $T=1067640 749840 1 180 $X=1065160 $Y=749460
X791 5473 5465 1 2 5415 AN2 $T=1068880 780080 1 180 $X=1066400 $Y=779700
X792 5475 5468 1 2 5357 AN2 $T=1069500 800240 0 180 $X=1067020 $Y=794820
X793 5483 5451 1 2 5351 AN2 $T=1073220 810320 1 180 $X=1070740 $Y=809940
X794 5487 5477 1 2 5343 AN2 $T=1074460 719600 0 180 $X=1071980 $Y=714180
X795 5490 5482 1 2 5317 AN2 $T=1075700 830480 0 180 $X=1073220 $Y=825060
X796 5491 5486 1 2 5338 AN2 $T=1076940 749840 0 180 $X=1074460 $Y=744420
X797 3444 452 1 2 INV6CK $T=603260 830480 0 0 $X=603260 $Y=830100
X798 3722 467 1 2 INV6CK $T=661540 830480 0 0 $X=661540 $Y=830100
X799 3776 3444 1 2 INV6CK $T=686340 820400 0 0 $X=686340 $Y=820020
X800 4407 652 1 2 INV6CK $T=809100 830480 0 180 $X=803520 $Y=825060
X801 4571 774 1 2 INV6CK $T=838860 800240 1 180 $X=833280 $Y=799860
X802 4497 826 1 2 INV6CK $T=842580 850640 1 180 $X=837000 $Y=850260
X803 4895 4997 1 2 INV6CK $T=931860 780080 0 0 $X=931860 $Y=779700
X804 5132 5091 1 2 INV6CK $T=957280 800240 0 180 $X=951700 $Y=794820
X805 5065 5137 1 2 INV6CK $T=964720 790160 0 180 $X=959140 $Y=784740
X806 5078 5113 1 2 INV6CK $T=977120 810320 0 180 $X=971540 $Y=804900
X807 4701 829 1 2 INV4CK $T=850640 860720 0 0 $X=850640 $Y=860340
X808 4754 842 1 2 INV4CK $T=864280 850640 0 0 $X=864280 $Y=850260
X809 4749 856 1 2 INV4CK $T=881640 850640 0 180 $X=877920 $Y=845220
X810 5011 919 1 2 INV4CK $T=918220 780080 1 0 $X=918220 $Y=774660
X811 4937 955 1 2 INV4CK $T=943020 759920 1 180 $X=939300 $Y=759540
X812 5045 945 1 2 INV4CK $T=943640 719600 0 180 $X=939920 $Y=714180
X813 5203 1021 1 2 INV4CK $T=1003780 759920 1 0 $X=1003780 $Y=754500
X814 5160 1016 1 2 INV4CK $T=1017420 759920 0 0 $X=1017420 $Y=759540
X815 5224 1020 1 2 INV4CK $T=1023000 749840 0 180 $X=1019280 $Y=744420
X816 5276 5326 1 2 INV4CK $T=1027960 780080 0 0 $X=1027960 $Y=779700
X817 5237 5331 1 2 INV4CK $T=1031060 759920 1 0 $X=1031060 $Y=754500
X818 5352 1038 1 2 INV4CK $T=1047800 770000 0 0 $X=1047800 $Y=769620
X819 5337 5418 1 2 INV4CK $T=1053380 780080 1 180 $X=1049660 $Y=779700
X820 5294 1042 1 2 INV4CK $T=1065160 770000 0 180 $X=1061440 $Y=764580
X821 5312 1037 1 2 INV4CK $T=1063300 780080 1 0 $X=1063300 $Y=774660
X822 553 3524 1 2 3542 QDBHN $T=620620 850640 0 0 $X=620620 $Y=850260
X823 609 3568 1 2 3810 QDBHN $T=675180 810320 0 0 $X=675180 $Y=809940
X824 609 3568 1 2 3853 QDBHN $T=680760 840560 0 0 $X=680760 $Y=840180
X825 553 4220 1 2 4204 QDBHN $T=757020 860720 0 180 $X=749580 $Y=855300
X826 609 3583 1 2 4198 QDBHN $T=755780 870800 0 0 $X=755780 $Y=870420
X827 746 741 1 2 4313 QDBHN $T=779960 870800 1 180 $X=772520 $Y=870420
X828 609 4445 1 2 4416 QDBHN $T=799800 840560 0 180 $X=792360 $Y=835140
X829 746 767 1 2 4470 QDBHN $T=794220 850640 0 0 $X=794220 $Y=850260
X830 609 4445 1 2 4529 QDBHN $T=806000 810320 0 0 $X=806000 $Y=809940
X831 553 4440 1 2 4439 QDBHN $T=814060 790160 0 180 $X=806620 $Y=784740
X832 746 785 1 2 4474 QDBHN $T=806620 870800 0 0 $X=806620 $Y=870420
X833 746 789 1 2 4533 QDBHN $T=807860 840560 0 0 $X=807860 $Y=840180
X834 4558 3583 1 2 4592 QDBHN $T=817780 820400 0 0 $X=817780 $Y=820020
X835 809 646 1 2 814 QDBHN $T=840720 870800 1 180 $X=833280 $Y=870420
X836 4558 4220 1 2 4726 QDBHN $T=849400 780080 0 0 $X=849400 $Y=779700
X837 746 883 1 2 4827 QDBHN $T=885360 860720 0 180 $X=877920 $Y=855300
X838 4558 915 1 2 4930 QDBHN $T=910160 759920 0 180 $X=902720 $Y=754500
X839 4558 928 1 2 4974 QDBHN $T=917600 770000 0 180 $X=910160 $Y=764580
X840 4558 944 1 2 5023 QDBHN $T=928140 800240 0 180 $X=920700 $Y=794820
X841 4558 950 1 2 5075 QDBHN $T=924420 759920 0 0 $X=924420 $Y=759540
X842 4558 960 1 2 5114 QDBHN $T=933720 749840 0 0 $X=933720 $Y=749460
X843 4558 964 1 2 5134 QDBHN $T=939920 800240 0 0 $X=939920 $Y=799860
X844 4558 976 1 2 5174 QDBHN $T=951080 749840 0 0 $X=951080 $Y=749460
X845 4558 982 1 2 5183 QDBHN $T=957280 739760 0 0 $X=957280 $Y=739380
X846 4558 995 1 2 5200 QDBHN $T=975880 800240 0 180 $X=968440 $Y=794820
X847 4558 1012 1 2 5210 QDBHN $T=990140 749840 0 180 $X=982700 $Y=744420
X848 4558 1017 1 2 5256 QDBHN $T=996340 759920 0 180 $X=988900 $Y=754500
X849 4558 1018 1 2 5259 QDBHN $T=996340 800240 0 180 $X=988900 $Y=794820
X850 4558 1019 1 2 5257 QDBHN $T=999440 790160 0 180 $X=992000 $Y=784740
X851 4558 1027 1 2 5309 QDBHN $T=1013700 790160 0 180 $X=1006260 $Y=784740
X852 4558 1028 1 2 5311 QDBHN $T=1014940 749840 0 180 $X=1007500 $Y=744420
X853 4558 1029 1 2 5316 QDBHN $T=1016180 739760 0 180 $X=1008740 $Y=734340
X854 3028 2714 1 2 INV2CK $T=520800 749840 1 180 $X=518320 $Y=749460
X855 3790 3722 1 2 INV2CK $T=675180 830480 0 0 $X=675180 $Y=830100
X856 4494 4497 1 2 INV2CK $T=805380 850640 0 0 $X=805380 $Y=850260
X857 4586 4589 1 2 INV2CK $T=823360 830480 0 0 $X=823360 $Y=830100
X858 4568 819 1 2 INV2CK $T=839480 870800 0 180 $X=837000 $Y=865380
X859 4569 820 1 2 INV2CK $T=839480 880880 0 180 $X=837000 $Y=875460
X860 4567 4701 1 2 INV2CK $T=853120 850640 0 180 $X=850640 $Y=845220
X861 831 833 1 2 INV2CK $T=850640 870800 0 0 $X=850640 $Y=870420
X862 845 4749 1 2 INV2CK $T=861800 870800 0 0 $X=861800 $Y=870420
X863 4755 4754 1 2 INV2CK $T=864280 860720 0 0 $X=864280 $Y=860340
X864 4893 4895 1 2 INV2CK $T=896520 780080 0 0 $X=896520 $Y=779700
X865 4927 4937 1 2 INV2CK $T=905820 749840 0 180 $X=903340 $Y=744420
X866 5040 5045 1 2 INV2CK $T=924420 729680 0 0 $X=924420 $Y=729300
X867 5061 5065 1 2 INV2CK $T=928760 810320 0 0 $X=928760 $Y=809940
X868 5019 5078 1 2 INV2CK $T=931860 790160 0 0 $X=931860 $Y=789780
X869 5131 5132 1 2 INV2CK $T=945500 770000 0 0 $X=945500 $Y=769620
X870 5128 5160 1 2 INV2CK $T=952940 759920 0 0 $X=952940 $Y=759540
X871 5156 5011 1 2 INV2CK $T=956040 770000 0 0 $X=956040 $Y=769620
X872 5202 5203 1 2 INV2CK $T=969060 759920 1 0 $X=969060 $Y=754500
X873 5223 5224 1 2 INV2CK $T=977740 770000 0 180 $X=975260 $Y=764580
X874 5231 5237 1 2 INV2CK $T=982080 780080 0 180 $X=979600 $Y=774660
X875 5252 5276 1 2 INV2CK $T=995720 780080 0 180 $X=993240 $Y=774660
X876 5290 5294 1 2 INV2CK $T=1003780 770000 0 180 $X=1001300 $Y=764580
X877 5310 5312 1 2 INV2CK $T=1006880 780080 1 0 $X=1006880 $Y=774660
X878 5293 5337 1 2 INV2CK $T=1015560 800240 0 0 $X=1015560 $Y=799860
X879 5350 5352 1 2 INV2CK $T=1023000 729680 0 180 $X=1020520 $Y=724260
X880 1916 1923 1933 1 2 AN2T $T=352160 759920 1 0 $X=352160 $Y=754500
X881 1970 1906 1977 1 2 AN2T $T=367040 739760 1 180 $X=362700 $Y=739380
X882 2001 1933 2013 1 2 AN2T $T=366420 759920 0 0 $X=366420 $Y=759540
X883 1990 1906 2025 1 2 AN2T $T=372000 729680 0 0 $X=372000 $Y=729300
X884 2017 2013 2058 1 2 AN2T $T=374480 770000 0 0 $X=374480 $Y=769620
X885 2058 2069 2078 1 2 AN2T $T=376960 770000 1 0 $X=376960 $Y=764580
X886 2076 2078 2074 1 2 AN2T $T=380060 759920 1 0 $X=380060 $Y=754500
X887 2043 2074 2073 1 2 AN2T $T=381920 749840 1 0 $X=381920 $Y=744420
X888 2123 2138 2134 1 2 AN2T $T=389360 709520 0 0 $X=389360 $Y=709140
X889 2165 2129 2187 1 2 AN2T $T=393700 729680 0 0 $X=393700 $Y=729300
X890 2203 2187 2180 1 2 AN2T $T=402380 729680 1 180 $X=398040 $Y=729300
X891 2259 2257 2244 1 2 AN2T $T=411680 739760 0 180 $X=407340 $Y=734340
X892 2248 2237 2257 1 2 AN2T $T=409200 739760 0 0 $X=409200 $Y=739380
X893 2321 2244 2298 1 2 AN2T $T=421600 739760 0 180 $X=417260 $Y=734340
X894 2362 2331 2345 1 2 AN2T $T=426560 739760 0 0 $X=426560 $Y=739380
X895 2616 2606 2580 1 2 AN2T $T=463140 759920 0 180 $X=458800 $Y=754500
X896 2587 2589 2608 1 2 AN2T $T=460040 770000 1 0 $X=460040 $Y=764580
X897 2642 300 2617 1 2 AN2T $T=466240 749840 0 180 $X=461900 $Y=744420
X898 2633 2629 2665 1 2 AN2T $T=465000 759920 1 0 $X=465000 $Y=754500
X899 2716 2665 2746 1 2 AN2T $T=474920 759920 1 0 $X=474920 $Y=754500
X900 2745 2746 2754 1 2 AN2T $T=477400 749840 0 0 $X=477400 $Y=749460
X901 2775 2765 343 1 2 AN2T $T=484220 709520 0 180 $X=479880 $Y=704100
X902 2803 2798 2765 1 2 AN2T $T=488560 709520 1 180 $X=484220 $Y=709140
X903 3756 609 3776 1 2 AN2T $T=668360 820400 0 0 $X=668360 $Y=820020
X904 3778 609 3790 1 2 AN2T $T=672700 840560 0 0 $X=672700 $Y=840180
X905 4228 553 4182 1 2 AN2T $T=765080 860720 0 180 $X=760740 $Y=855300
X906 4373 746 757 1 2 AN2T $T=783680 870800 0 0 $X=783680 $Y=870420
X907 4424 609 4395 1 2 AN2T $T=789880 830480 0 180 $X=785540 $Y=825060
X908 763 746 766 1 2 AN2T $T=789880 870800 0 0 $X=789880 $Y=870420
X909 4476 746 4454 1 2 AN2T $T=802900 870800 1 180 $X=798560 $Y=870420
X910 4537 746 4564 1 2 AN2T $T=817160 810320 0 0 $X=817160 $Y=809940
X911 4562 746 4567 1 2 AN2T $T=823360 840560 1 180 $X=819020 $Y=840180
X912 4545 746 4494 1 2 AN2T $T=819020 850640 0 0 $X=819020 $Y=850260
X913 804 746 4568 1 2 AN2T $T=823360 870800 0 180 $X=819020 $Y=865380
X914 4583 746 4569 1 2 AN2T $T=823360 880880 0 180 $X=819020 $Y=875460
X915 4604 746 4586 1 2 AN2T $T=828940 820400 0 0 $X=828940 $Y=820020
X916 4821 746 4755 1 2 AN2T $T=877920 870800 1 0 $X=877920 $Y=865380
X917 5144 4558 5156 1 2 AN2T $T=949220 739760 0 0 $X=949220 $Y=739380
X918 3367 1 2 3385 DELC $T=585900 850640 1 0 $X=585900 $Y=845220
X919 3457 1 2 3386 DELC $T=606980 860720 1 0 $X=606980 $Y=855300
X920 3441 1 2 3430 DELC $T=608840 850640 0 0 $X=608840 $Y=850260
X921 507 1 2 3511 DELC $T=615660 770000 1 0 $X=615660 $Y=764580
X922 3492 1 2 3525 DELC $T=623720 840560 1 0 $X=623720 $Y=835140
X923 560 1 2 3566 DELC $T=626200 770000 1 0 $X=626200 $Y=764580
X924 3542 1 2 3487 DELC $T=627440 850640 1 0 $X=627440 $Y=845220
X925 505 1 2 3633 DELC $T=629300 749840 0 0 $X=629300 $Y=749460
X926 3552 1 2 3524 DELC $T=630540 840560 0 0 $X=630540 $Y=840180
X927 3580 1 2 3440 DELC $T=634880 860720 0 0 $X=634880 $Y=860340
X928 497 1 2 3651 DELC $T=642940 780080 1 0 $X=642940 $Y=774660
X929 3810 1 2 3756 DELC $T=678280 820400 0 0 $X=678280 $Y=820020
X930 3851 1 2 3849 DELC $T=687580 699440 0 0 $X=687580 $Y=699060
X931 3855 1 2 3909 DELC $T=688200 790160 0 0 $X=688200 $Y=789780
X932 3853 1 2 3778 DELC $T=688200 840560 0 0 $X=688200 $Y=840180
X933 3890 1 2 3917 DELC $T=692540 729680 1 0 $X=692540 $Y=724260
X934 3898 1 2 3842 DELC $T=694400 719600 0 0 $X=694400 $Y=719220
X935 3906 1 2 3902 DELC $T=695640 719600 1 0 $X=695640 $Y=714180
X936 3881 1 2 3970 DELC $T=700600 780080 1 0 $X=700600 $Y=774660
X937 3926 1 2 3933 DELC $T=701840 709520 1 0 $X=701840 $Y=704100
X938 3875 1 2 3994 DELC $T=705560 780080 1 0 $X=705560 $Y=774660
X939 3826 1 2 4049 DELC $T=709280 790160 1 0 $X=709280 $Y=784740
X940 4017 1 2 4034 DELC $T=713620 840560 0 0 $X=713620 $Y=840180
X941 3840 1 2 4054 DELC $T=716100 800240 1 0 $X=716100 $Y=794820
X942 4044 1 2 4075 DELC $T=719200 860720 1 0 $X=719200 $Y=855300
X943 676 1 2 4129 DELC $T=730360 719600 1 0 $X=730360 $Y=714180
X944 4098 1 2 4122 DELC $T=730360 850640 0 0 $X=730360 $Y=850260
X945 4184 1 2 4171 DELC $T=745860 739760 0 0 $X=745860 $Y=739380
X946 4199 1 2 4208 DELC $T=748960 749840 0 0 $X=748960 $Y=749460
X947 4198 1 2 705 DELC $T=748960 880880 1 0 $X=748960 $Y=875460
X948 4204 1 2 4228 DELC $T=749580 840560 0 0 $X=749580 $Y=840180
X949 4195 1 2 4188 DELC $T=753300 780080 0 0 $X=753300 $Y=779700
X950 4225 1 2 4263 DELC $T=759500 739760 1 0 $X=759500 $Y=734340
X951 4081 1 2 4295 DELC $T=764460 739760 1 0 $X=764460 $Y=734340
X952 4062 1 2 4283 DELC $T=767560 790160 1 0 $X=767560 $Y=784740
X953 4294 1 2 4298 DELC $T=772520 729680 1 0 $X=772520 $Y=724260
X954 4287 1 2 4318 DELC $T=777480 759920 1 0 $X=777480 $Y=754500
X955 4313 1 2 4373 DELC $T=777480 860720 1 0 $X=777480 $Y=855300
X956 4416 1 2 4424 DELC $T=789880 850640 1 0 $X=789880 $Y=845220
X957 4426 1 2 4440 DELC $T=791120 790160 0 0 $X=791120 $Y=789780
X958 4439 1 2 4455 DELC $T=795460 790160 1 0 $X=795460 $Y=784740
X959 4444 1 2 4467 DELC $T=796080 790160 0 0 $X=796080 $Y=789780
X960 4474 1 2 4476 DELC $T=802280 860720 1 0 $X=802280 $Y=855300
X961 4514 1 2 4537 DELC $T=809720 830480 1 0 $X=809720 $Y=825060
X962 4470 1 2 4545 DELC $T=810340 850640 0 0 $X=810340 $Y=850260
X963 4533 1 2 4562 DELC $T=813440 850640 1 0 $X=813440 $Y=845220
X964 807 1 2 4583 DELC $T=825840 880880 1 0 $X=825840 $Y=875460
X965 4603 1 2 4604 DELC $T=828320 830480 0 0 $X=828320 $Y=830100
X966 4726 1 2 4662 DELC $T=856220 790160 0 0 $X=856220 $Y=789780
X967 4719 1 2 4764 DELC $T=865520 810320 1 0 $X=865520 $Y=804900
X968 4827 1 2 4821 DELC $T=882260 870800 1 0 $X=882260 $Y=865380
X969 4838 1 2 4903 DELC $T=894660 850640 0 0 $X=894660 $Y=850260
X970 4930 1 2 4942 DELC $T=915120 759920 1 0 $X=915120 $Y=754500
X971 4974 1 2 4975 DELC $T=921940 780080 1 0 $X=921940 $Y=774660
X972 5023 1 2 5030 DELC $T=922560 790160 1 0 $X=922560 $Y=784740
X973 4873 1 2 4992 DELC $T=926900 749840 0 0 $X=926900 $Y=749460
X974 4851 1 2 5074 DELC $T=926900 790160 0 0 $X=926900 $Y=789780
X975 4856 1 2 5002 DELC $T=931240 820400 0 0 $X=931240 $Y=820020
X976 5027 1 2 4996 DELC $T=931860 770000 0 0 $X=931860 $Y=769620
X977 5075 1 2 5041 DELC $T=933100 759920 0 0 $X=933100 $Y=759540
X978 5114 1 2 5118 DELC $T=943020 759920 0 0 $X=943020 $Y=759540
X979 5134 1 2 5103 DELC $T=946740 810320 1 0 $X=946740 $Y=804900
X980 4986 1 2 984 DELC $T=957280 719600 1 0 $X=957280 $Y=714180
X981 5174 1 2 5129 DELC $T=958520 749840 0 0 $X=958520 $Y=749460
X982 5183 1 2 5144 DELC $T=964100 759920 0 0 $X=964100 $Y=759540
X983 5210 1 2 5221 DELC $T=971540 749840 1 0 $X=971540 $Y=744420
X984 5200 1 2 5240 DELC $T=977120 790160 1 0 $X=977120 $Y=784740
X985 5257 1 2 5266 DELC $T=988280 780080 1 0 $X=988280 $Y=774660
X986 5256 1 2 5246 DELC $T=988900 770000 1 0 $X=988900 $Y=764580
X987 5259 1 2 5288 DELC $T=1001300 810320 0 0 $X=1001300 $Y=809940
X988 5311 1 2 5301 DELC $T=1007500 759920 1 0 $X=1007500 $Y=754500
X989 5309 1 2 5308 DELC $T=1009360 780080 1 0 $X=1009360 $Y=774660
X990 5316 1 2 5353 DELC $T=1022380 739760 1 0 $X=1022380 $Y=734340
X991 1105 2 3 1 INV1S $T=223200 850640 0 180 $X=221960 $Y=845220
X992 1186 2 1123 1 INV1S $T=224440 729680 1 180 $X=223200 $Y=729300
X993 1161 2 1118 1 INV1S $T=225680 790160 1 180 $X=224440 $Y=789780
X994 6 2 1116 1 INV1S $T=224440 830480 0 0 $X=224440 $Y=830100
X995 1146 2 1173 1 INV1S $T=225060 780080 0 0 $X=225060 $Y=779700
X996 1157 2 1153 1 INV1S $T=228160 759920 0 180 $X=226920 $Y=754500
X997 1166 2 1178 1 INV1S $T=226920 820400 1 0 $X=226920 $Y=814980
X998 1191 2 1107 1 INV1S $T=229400 800240 0 180 $X=228160 $Y=794820
X999 1181 2 1142 1 INV1S $T=230640 719600 1 180 $X=229400 $Y=719220
X1000 1209 2 1182 1 INV1S $T=231260 759920 0 180 $X=230020 $Y=754500
X1001 1221 2 1189 1 INV1S $T=231260 820400 0 180 $X=230020 $Y=814980
X1002 1176 2 9 1 INV1S $T=231260 850640 1 180 $X=230020 $Y=850260
X1003 1229 2 1175 1 INV1S $T=232500 749840 1 180 $X=231260 $Y=749460
X1004 1222 2 1158 1 INV1S $T=232500 850640 0 180 $X=231260 $Y=845220
X1005 1223 2 1207 1 INV1S $T=233120 739760 0 0 $X=233120 $Y=739380
X1006 18 2 1152 1 INV1S $T=234980 719600 1 180 $X=233740 $Y=719220
X1007 1208 2 1117 1 INV1S $T=235600 830480 0 0 $X=235600 $Y=830100
X1008 1147 2 1170 1 INV1S $T=236840 870800 0 180 $X=235600 $Y=865380
X1009 1262 2 1231 1 INV1S $T=237460 860720 1 180 $X=236220 $Y=860340
X1010 1246 2 1257 1 INV1S $T=236840 719600 0 0 $X=236840 $Y=719220
X1011 20 2 1254 1 INV1S $T=236840 810320 0 0 $X=236840 $Y=809940
X1012 1237 2 1256 1 INV1S $T=236840 840560 1 0 $X=236840 $Y=835140
X1013 1239 2 1265 1 INV1S $T=238080 770000 1 0 $X=238080 $Y=764580
X1014 1183 2 1167 1 INV1S $T=238700 870800 1 0 $X=238700 $Y=865380
X1015 1205 2 1290 1 INV1S $T=239940 870800 0 0 $X=239940 $Y=870420
X1016 1238 2 1279 1 INV1S $T=244280 739760 1 180 $X=243040 $Y=739380
X1017 1264 2 1263 1 INV1S $T=243660 870800 0 0 $X=243660 $Y=870420
X1018 1150 2 1300 1 INV1S $T=245520 880880 1 0 $X=245520 $Y=875460
X1019 1345 2 1273 1 INV1S $T=248620 780080 0 180 $X=247380 $Y=774660
X1020 1248 2 1148 1 INV1S $T=248000 860720 0 0 $X=248000 $Y=860340
X1021 1304 2 1108 1 INV1S $T=248620 850640 0 0 $X=248620 $Y=850260
X1022 1201 2 1374 1 INV1S $T=250480 860720 0 0 $X=250480 $Y=860340
X1023 1399 2 1409 1 INV1S $T=256060 749840 0 0 $X=256060 $Y=749460
X1024 1405 2 1408 1 INV1S $T=257300 790160 0 0 $X=257300 $Y=789780
X1025 45 2 1154 1 INV1S $T=259780 719600 0 180 $X=258540 $Y=714180
X1026 1432 2 1420 1 INV1S $T=260400 840560 0 180 $X=259160 $Y=835140
X1027 1195 2 1445 1 INV1S $T=261020 759920 0 0 $X=261020 $Y=759540
X1028 39 2 48 1 INV1S $T=262260 699440 0 0 $X=262260 $Y=699060
X1029 1280 2 1429 1 INV1S $T=262260 749840 1 0 $X=262260 $Y=744420
X1030 1480 2 1109 1 INV1S $T=268460 820400 1 0 $X=268460 $Y=814980
X1031 1479 2 59 1 INV1S $T=269080 699440 0 0 $X=269080 $Y=699060
X1032 1368 2 1501 1 INV1S $T=274040 739760 1 180 $X=272800 $Y=739380
X1033 1174 2 1464 1 INV1S $T=274660 850640 0 0 $X=274660 $Y=850260
X1034 1402 2 21 1 INV1S $T=274660 860720 1 0 $X=274660 $Y=855300
X1035 1536 2 1190 1 INV1S $T=276520 759920 0 180 $X=275280 $Y=754500
X1036 1357 2 1431 1 INV1S $T=275900 880880 1 0 $X=275900 $Y=875460
X1037 1407 2 40 1 INV1S $T=279000 840560 1 180 $X=277760 $Y=840180
X1038 1348 2 1149 1 INV1S $T=281480 870800 0 0 $X=281480 $Y=870420
X1039 1525 2 1584 1 INV1S $T=282720 719600 0 0 $X=282720 $Y=719220
X1040 1566 2 61 1 INV1S $T=285820 880880 1 0 $X=285820 $Y=875460
X1041 1573 2 1286 1 INV1S $T=286440 770000 0 0 $X=286440 $Y=769620
X1042 35 2 1199 1 INV1S $T=286440 860720 0 0 $X=286440 $Y=860340
X1043 81 2 1577 1 INV1S $T=288920 870800 0 180 $X=287680 $Y=865380
X1044 1628 2 1145 1 INV1S $T=291400 739760 0 180 $X=290160 $Y=734340
X1045 1555 2 1636 1 INV1S $T=291400 820400 0 0 $X=291400 $Y=820020
X1046 1648 2 1634 1 INV1S $T=293880 860720 1 180 $X=292640 $Y=860340
X1047 1520 2 1637 1 INV1S $T=294500 739760 1 180 $X=293260 $Y=739380
X1048 1502 2 1411 1 INV1S $T=294500 729680 1 0 $X=294500 $Y=724260
X1049 1659 2 1200 1 INV1S $T=298840 759920 0 180 $X=297600 $Y=754500
X1050 79 2 1488 1 INV1S $T=298220 709520 1 0 $X=298220 $Y=704100
X1051 1657 2 1358 1 INV1S $T=299460 759920 1 180 $X=298220 $Y=759540
X1052 1243 2 1492 1 INV1S $T=298840 759920 1 0 $X=298840 $Y=754500
X1053 1277 2 1545 1 INV1S $T=301320 749840 1 180 $X=300080 $Y=749460
X1054 1494 2 1389 1 INV1S $T=302560 729680 1 180 $X=301320 $Y=729300
X1055 1685 2 1243 1 INV1S $T=305040 830480 0 0 $X=305040 $Y=830100
X1056 1342 2 1699 1 INV1S $T=306280 709520 1 0 $X=306280 $Y=704100
X1057 1305 2 1495 1 INV1S $T=307520 729680 0 180 $X=306280 $Y=724260
X1058 1679 2 1375 1 INV1S $T=306900 770000 0 0 $X=306900 $Y=769620
X1059 1649 2 82 1 INV1S $T=309380 699440 1 180 $X=308140 $Y=699060
X1060 1427 2 1688 1 INV1S $T=308760 780080 0 0 $X=308760 $Y=779700
X1061 1725 2 1406 1 INV1S $T=310620 709520 0 180 $X=309380 $Y=704100
X1062 1567 2 1326 1 INV1S $T=310000 739760 0 0 $X=310000 $Y=739380
X1063 1371 2 1396 1 INV1S $T=310620 780080 1 0 $X=310620 $Y=774660
X1064 1640 2 103 1 INV1S $T=312480 880880 1 0 $X=312480 $Y=875460
X1065 28 2 1384 1 INV1S $T=313100 709520 0 0 $X=313100 $Y=709140
X1066 1472 2 1586 1 INV1S $T=313100 729680 1 0 $X=313100 $Y=724260
X1067 1281 2 1311 1 INV1S $T=314960 729680 1 0 $X=314960 $Y=724260
X1068 1643 2 1337 1 INV1S $T=316200 780080 1 180 $X=314960 $Y=779700
X1069 1724 2 56 1 INV1S $T=318680 870800 0 180 $X=317440 $Y=865380
X1070 1664 2 1761 1 INV1S $T=321780 719600 0 0 $X=321780 $Y=719220
X1071 1444 2 1617 1 INV1S $T=322400 759920 0 0 $X=322400 $Y=759540
X1072 1206 2 14 1 INV1S $T=323640 840560 0 0 $X=323640 $Y=840180
X1073 111 2 1419 1 INV1S $T=324880 860720 1 180 $X=323640 $Y=860340
X1074 105 2 1795 1 INV1S $T=326740 870800 0 0 $X=326740 $Y=870420
X1075 1295 2 1390 1 INV1S $T=331700 729680 0 180 $X=330460 $Y=724260
X1076 1784 2 1798 1 INV1S $T=331080 709520 1 0 $X=331080 $Y=704100
X1077 1800 2 1815 1 INV1S $T=332320 870800 1 0 $X=332320 $Y=865380
X1078 121 2 1814 1 INV1S $T=334180 709520 1 180 $X=332940 $Y=709140
X1079 1806 2 101 1 INV1S $T=334800 880880 0 180 $X=333560 $Y=875460
X1080 121 2 124 1 INV1S $T=335420 709520 1 180 $X=334180 $Y=709140
X1081 121 2 127 1 INV1S $T=336660 709520 1 180 $X=335420 $Y=709140
X1082 121 2 129 1 INV1S $T=337900 709520 1 180 $X=336660 $Y=709140
X1083 1825 2 1738 1 INV1S $T=338520 820400 0 180 $X=337280 $Y=814980
X1084 121 2 1847 1 INV1S $T=337900 709520 0 0 $X=337900 $Y=709140
X1085 1258 2 1850 1 INV1S $T=338520 739760 1 0 $X=338520 $Y=734340
X1086 121 2 1849 1 INV1S $T=340380 709520 1 180 $X=339140 $Y=709140
X1087 1843 2 1775 1 INV1S $T=340380 880880 0 180 $X=339140 $Y=875460
X1088 1425 2 1836 1 INV1S $T=341000 840560 0 180 $X=339760 $Y=835140
X1089 131 2 1866 1 INV1S $T=340380 719600 0 0 $X=340380 $Y=719220
X1090 1808 2 1486 1 INV1S $T=341620 780080 0 180 $X=340380 $Y=774660
X1091 50 2 1740 1 INV1S $T=341620 870800 1 180 $X=340380 $Y=870420
X1092 1293 2 1320 1 INV1S $T=343480 739760 0 180 $X=342240 $Y=734340
X1093 1287 2 1253 1 INV1S $T=342240 820400 0 0 $X=342240 $Y=820020
X1094 1866 2 1874 1 INV1S $T=345340 719600 1 180 $X=344100 $Y=719220
X1095 33 2 1404 1 INV1S $T=344100 739760 0 0 $X=344100 $Y=739380
X1096 1288 2 1369 1 INV1S $T=345340 820400 0 180 $X=344100 $Y=814980
X1097 115 2 1883 1 INV1S $T=345340 719600 0 0 $X=345340 $Y=719220
X1098 1779 2 1346 1 INV1S $T=345340 759920 0 0 $X=345340 $Y=759540
X1099 1313 2 1381 1 INV1S $T=345340 830480 0 0 $X=345340 $Y=830100
X1100 1809 2 142 1 INV1S $T=346580 870800 1 0 $X=346580 $Y=865380
X1101 4 2 1483 1 INV1S $T=349680 729680 1 180 $X=348440 $Y=729300
X1102 140 2 139 1 INV1S $T=349680 729680 0 0 $X=349680 $Y=729300
X1103 1253 2 29 1 INV1S $T=350920 749840 0 0 $X=350920 $Y=749460
X1104 1177 2 90 1 INV1S $T=352160 759920 0 180 $X=350920 $Y=754500
X1105 1451 2 1837 1 INV1S $T=350920 870800 1 0 $X=350920 $Y=865380
X1106 1729 2 1393 1 INV1S $T=351540 830480 1 0 $X=351540 $Y=825060
X1107 139 2 1922 1 INV1S $T=352780 729680 0 0 $X=352780 $Y=729300
X1108 1457 2 1332 1 INV1S $T=354020 830480 1 180 $X=352780 $Y=830100
X1109 143 2 1906 1 INV1S $T=355260 739760 0 180 $X=354020 $Y=734340
X1110 1700 2 1413 1 INV1S $T=357120 770000 0 180 $X=355880 $Y=764580
X1111 1932 2 1945 1 INV1S $T=358360 719600 1 180 $X=357120 $Y=719220
X1112 1942 2 1956 1 INV1S $T=357120 729680 1 0 $X=357120 $Y=724260
X1113 1956 2 1927 1 INV1S $T=358360 729680 1 0 $X=358360 $Y=724260
X1114 1902 2 1966 1 INV1S $T=359600 719600 1 0 $X=359600 $Y=714180
X1115 139 2 1985 1 INV1S $T=362700 729680 0 0 $X=362700 $Y=729300
X1116 1984 2 1953 1 INV1S $T=363940 770000 1 180 $X=362700 $Y=769620
X1117 155 2 156 1 INV1S $T=363320 709520 0 0 $X=363320 $Y=709140
X1118 1884 2 2002 1 INV1S $T=364560 820400 0 0 $X=364560 $Y=820020
X1119 147 2 1959 1 INV1S $T=365800 840560 1 180 $X=364560 $Y=840180
X1120 159 2 1950 1 INV1S $T=368900 830480 0 180 $X=367660 $Y=825060
X1121 1986 2 133 1 INV1S $T=368280 810320 1 0 $X=368280 $Y=804900
X1122 2018 2 2017 1 INV1S $T=370760 770000 1 0 $X=370760 $Y=764580
X1123 2015 2 2027 1 INV1S $T=371380 709520 0 0 $X=371380 $Y=709140
X1124 1982 2 169 1 INV1S $T=372000 699440 0 0 $X=372000 $Y=699060
X1125 2024 2 2036 1 INV1S $T=372000 709520 1 0 $X=372000 $Y=704100
X1126 1980 2 2010 1 INV1S $T=373860 800240 0 180 $X=372620 $Y=794820
X1127 2042 2 2043 1 INV1S $T=375100 719600 0 0 $X=375100 $Y=719220
X1128 1975 2 2060 1 INV1S $T=375100 780080 0 0 $X=375100 $Y=779700
X1129 2020 2 2055 1 INV1S $T=375720 739760 0 0 $X=375720 $Y=739380
X1130 170 2 1891 1 INV1S $T=376960 850640 1 180 $X=375720 $Y=850260
X1131 167 2 2019 1 INV1S $T=376960 870800 0 180 $X=375720 $Y=865380
X1132 2041 2 2054 1 INV1S $T=376340 729680 1 0 $X=376340 $Y=724260
X1133 1936 2 2062 1 INV1S $T=376340 729680 0 0 $X=376340 $Y=729300
X1134 2065 2 2076 1 INV1S $T=377580 759920 1 0 $X=377580 $Y=754500
X1135 2033 2 2069 1 INV1S $T=377580 759920 0 0 $X=377580 $Y=759540
X1136 1984 2 2034 1 INV1S $T=380060 770000 1 180 $X=378820 $Y=769620
X1137 2045 2 1980 1 INV1S $T=380060 860720 1 180 $X=378820 $Y=860340
X1138 1989 2 1920 1 INV1S $T=380680 800240 0 180 $X=379440 $Y=794820
X1139 117 2 1875 1 INV1S $T=380060 850640 0 0 $X=380060 $Y=850260
X1140 1974 2 2057 1 INV1S $T=381920 800240 1 180 $X=380680 $Y=799860
X1141 2060 2 2094 1 INV1S $T=381300 780080 0 0 $X=381300 $Y=779700
X1142 2047 2 2083 1 INV1S $T=383160 719600 0 180 $X=381920 $Y=714180
X1143 1885 2 2007 1 INV1S $T=381920 820400 0 0 $X=381920 $Y=820020
X1144 1951 2 2051 1 INV1S $T=383780 800240 0 180 $X=382540 $Y=794820
X1145 1762 2 1934 1 INV1S $T=382540 860720 0 0 $X=382540 $Y=860340
X1146 178 2 180 1 INV1S $T=384400 719600 1 0 $X=384400 $Y=714180
X1147 179 2 2070 1 INV1S $T=386880 880880 0 180 $X=385640 $Y=875460
X1148 177 2 2113 1 INV1S $T=386260 749840 1 0 $X=386260 $Y=744420
X1149 156 2 175 1 INV1S $T=390600 699440 1 180 $X=389360 $Y=699060
X1150 184 2 2080 1 INV1S $T=389360 880880 1 0 $X=389360 $Y=875460
X1151 165 2 185 1 INV1S $T=393700 699440 1 180 $X=392460 $Y=699060
X1152 188 2 2153 1 INV1S $T=394320 719600 0 180 $X=393080 $Y=714180
X1153 191 2 2138 1 INV1S $T=394940 709520 0 180 $X=393700 $Y=704100
X1154 2014 2 2022 1 INV1S $T=394320 840560 1 0 $X=394320 $Y=835140
X1155 194 2 2095 1 INV1S $T=396800 850640 0 180 $X=395560 $Y=845220
X1156 197 2 2086 1 INV1S $T=396800 860720 1 180 $X=395560 $Y=860340
X1157 180 2 193 1 INV1S $T=396180 719600 0 0 $X=396180 $Y=719220
X1158 201 2 2125 1 INV1S $T=398660 860720 0 180 $X=397420 $Y=855300
X1159 2193 2 2186 1 INV1S $T=401760 780080 1 180 $X=400520 $Y=779700
X1160 2211 2 2215 1 INV1S $T=404860 780080 0 180 $X=403620 $Y=774660
X1161 2194 2 204 1 INV1S $T=406100 860720 1 180 $X=404860 $Y=860340
X1162 2195 2 2250 1 INV1S $T=406720 709520 0 0 $X=406720 $Y=709140
X1163 212 2 2217 1 INV1S $T=407960 870800 1 180 $X=406720 $Y=870420
X1164 2128 2 2249 1 INV1S $T=407960 719600 0 0 $X=407960 $Y=719220
X1165 2269 2 2259 1 INV1S $T=411680 729680 1 180 $X=410440 $Y=729300
X1166 147 2 2263 1 INV1S $T=412920 830480 0 180 $X=411680 $Y=825060
X1167 2287 2 2281 1 INV1S $T=415400 749840 0 180 $X=414160 $Y=744420
X1168 2224 2 2307 1 INV1S $T=414780 719600 1 0 $X=414780 $Y=714180
X1169 167 2 2301 1 INV1S $T=415400 830480 1 0 $X=415400 $Y=825060
X1170 2302 2 2262 1 INV1S $T=417880 870800 0 180 $X=416640 $Y=865380
X1171 232 2 228 1 INV1S $T=419740 860720 1 180 $X=418500 $Y=860340
X1172 2014 2 236 1 INV1S $T=420360 840560 0 0 $X=420360 $Y=840180
X1173 2332 2 2321 1 INV1S $T=422840 729680 1 180 $X=421600 $Y=729300
X1174 2323 2 2294 1 INV1S $T=422840 790160 1 180 $X=421600 $Y=789780
X1175 2328 2 2299 1 INV1S $T=421600 850640 0 0 $X=421600 $Y=850260
X1176 2212 2 2260 1 INV1S $T=424080 780080 0 180 $X=422840 $Y=774660
X1177 2312 2 2318 1 INV1S $T=425320 749840 1 180 $X=424080 $Y=749460
X1178 2350 2 2360 1 INV1S $T=425320 729680 0 0 $X=425320 $Y=729300
X1179 2343 2 245 1 INV1S $T=425320 860720 0 0 $X=425320 $Y=860340
X1180 2337 2 2363 1 INV1S $T=425940 780080 0 0 $X=425940 $Y=779700
X1181 2334 2 2362 1 INV1S $T=427800 749840 0 180 $X=426560 $Y=744420
X1182 254 2 2368 1 INV1S $T=428420 699440 0 0 $X=428420 $Y=699060
X1183 2374 2 2349 1 INV1S $T=429660 719600 1 180 $X=428420 $Y=719220
X1184 241 2 2358 1 INV1S $T=428420 860720 0 0 $X=428420 $Y=860340
X1185 2383 2 2393 1 INV1S $T=429040 719600 1 0 $X=429040 $Y=714180
X1186 2354 2 2403 1 INV1S $T=429660 820400 0 0 $X=429660 $Y=820020
X1187 2385 2 2398 1 INV1S $T=430280 820400 1 0 $X=430280 $Y=814980
X1188 2348 2 2351 1 INV1S $T=431520 739760 1 0 $X=431520 $Y=734340
X1189 2417 2 2413 1 INV1S $T=434620 820400 1 180 $X=433380 $Y=820020
X1190 2347 2 2412 1 INV1S $T=435240 709520 0 180 $X=434000 $Y=704100
X1191 265 2 2401 1 INV1S $T=436480 860720 0 180 $X=435240 $Y=855300
X1192 2415 2 2402 1 INV1S $T=436480 770000 0 0 $X=436480 $Y=769620
X1193 2395 2 2418 1 INV1S $T=437100 810320 0 0 $X=437100 $Y=809940
X1194 263 2 264 1 INV1S $T=440200 709520 1 0 $X=440200 $Y=704100
X1195 2437 2 2439 1 INV1S $T=440200 810320 1 0 $X=440200 $Y=804900
X1196 2402 2 2450 1 INV1S $T=442680 770000 1 180 $X=441440 $Y=769620
X1197 2422 2 2455 1 INV1S $T=442060 800240 0 0 $X=442060 $Y=799860
X1198 2485 2 2492 1 INV1S $T=443300 709520 0 0 $X=443300 $Y=709140
X1199 277 2 2477 1 INV1S $T=444540 770000 1 0 $X=444540 $Y=764580
X1200 2454 2 280 1 INV1S $T=445160 870800 1 0 $X=445160 $Y=865380
X1201 2463 2 2505 1 INV1S $T=445780 800240 0 0 $X=445780 $Y=799860
X1202 2486 2 2515 1 INV1S $T=446400 770000 1 0 $X=446400 $Y=764580
X1203 2448 2 2519 1 INV1S $T=447020 709520 1 0 $X=447020 $Y=704100
X1204 2543 2 2470 1 INV1S $T=449500 820400 0 180 $X=448260 $Y=814980
X1205 279 2 2540 1 INV1S $T=448880 860720 1 0 $X=448880 $Y=855300
X1206 2481 2 2361 1 INV1S $T=449500 860720 0 0 $X=449500 $Y=860340
X1207 2449 2 2512 1 INV1S $T=451980 820400 1 180 $X=450740 $Y=820020
X1208 288 2 2573 1 INV1S $T=451360 729680 1 0 $X=451360 $Y=724260
X1209 2553 2 2530 1 INV1S $T=453220 810320 1 180 $X=451980 $Y=809940
X1210 2554 2 2527 1 INV1S $T=455080 770000 0 180 $X=453840 $Y=764580
X1211 2529 2 2578 1 INV1S $T=453840 810320 1 0 $X=453840 $Y=804900
X1212 290 2 296 1 INV1S $T=455700 729680 0 0 $X=455700 $Y=729300
X1213 2559 2 2534 1 INV1S $T=455700 830480 1 0 $X=455700 $Y=825060
X1214 298 2 2464 1 INV1S $T=457560 860720 1 0 $X=457560 $Y=855300
X1215 2598 2 2586 1 INV1S $T=459420 749840 0 180 $X=458180 $Y=744420
X1216 2591 2 2594 1 INV1S $T=458800 729680 1 0 $X=458800 $Y=724260
X1217 2588 2 2488 1 INV1S $T=460660 820400 1 180 $X=459420 $Y=820020
X1218 2599 2 2612 1 INV1S $T=461900 770000 0 0 $X=461900 $Y=769620
X1219 296 2 2615 1 INV1S $T=462520 729680 0 0 $X=462520 $Y=729300
X1220 2532 2 2620 1 INV1S $T=462520 800240 1 0 $X=462520 $Y=794820
X1221 2624 2 2496 1 INV1S $T=463760 820400 1 180 $X=462520 $Y=820020
X1222 2625 2 2457 1 INV1S $T=466860 800240 0 180 $X=465620 $Y=794820
X1223 2649 2 2508 1 INV1S $T=466860 850640 1 180 $X=465620 $Y=850260
X1224 296 2 2664 1 INV1S $T=466240 729680 0 0 $X=466240 $Y=729300
X1225 305 2 2663 1 INV1S $T=466860 870800 1 0 $X=466860 $Y=865380
X1226 2659 2 2633 1 INV1S $T=469340 739760 1 180 $X=468100 $Y=739380
X1227 2604 2 2681 1 INV1S $T=468720 800240 1 0 $X=468720 $Y=794820
X1228 2407 2 2702 1 INV1S $T=471820 830480 1 0 $X=471820 $Y=825060
X1229 2707 2 2653 1 INV1S $T=473680 759920 1 180 $X=472440 $Y=759540
X1230 2610 2 2726 1 INV1S $T=474300 719600 0 0 $X=474300 $Y=719220
X1231 2698 2 2716 1 INV1S $T=475540 749840 1 180 $X=474300 $Y=749460
X1232 2701 2 2727 1 INV1S $T=474300 780080 1 0 $X=474300 $Y=774660
X1233 2541 2 2728 1 INV1S $T=474920 729680 1 0 $X=474920 $Y=724260
X1234 2537 2 2736 1 INV1S $T=475540 749840 1 0 $X=475540 $Y=744420
X1235 333 2 2724 1 INV1S $T=478020 880880 1 0 $X=478020 $Y=875460
X1236 277 2 340 1 INV1S $T=478640 709520 1 0 $X=478640 $Y=704100
X1237 2563 2 2682 1 INV1S $T=478640 830480 0 0 $X=478640 $Y=830100
X1238 300 2 323 1 INV1S $T=479260 719600 1 0 $X=479260 $Y=714180
X1239 2744 2 2745 1 INV1S $T=479260 749840 1 0 $X=479260 $Y=744420
X1240 2622 2 2670 1 INV1S $T=479260 810320 0 0 $X=479260 $Y=809940
X1241 342 2 2732 1 INV1S $T=479880 880880 1 0 $X=479880 $Y=875460
X1242 2766 2 2777 1 INV1S $T=482360 729680 0 0 $X=482360 $Y=729300
X1243 2755 2 2768 1 INV1S $T=482980 749840 1 0 $X=482980 $Y=744420
X1244 2662 2 2739 1 INV1S $T=482980 830480 1 0 $X=482980 $Y=825060
X1245 345 2 2600 1 INV1S $T=484220 840560 1 180 $X=482980 $Y=840180
X1246 2776 2 2789 1 INV1S $T=483600 729680 1 0 $X=483600 $Y=724260
X1247 2781 2 2775 1 INV1S $T=484220 709520 1 0 $X=484220 $Y=704100
X1248 2518 2 2743 1 INV1S $T=484840 860720 1 0 $X=484840 $Y=855300
X1249 347 2 2784 1 INV1S $T=487320 870800 1 180 $X=486080 $Y=870420
X1250 2677 2 2782 1 INV1S $T=487940 840560 0 0 $X=487940 $Y=840180
X1251 2763 2 2803 1 INV1S $T=488560 709520 0 0 $X=488560 $Y=709140
X1252 2788 2 2808 1 INV1S $T=488560 749840 1 0 $X=488560 $Y=744420
X1253 2593 2 2809 1 INV1S $T=491040 810320 1 180 $X=489800 $Y=809940
X1254 340 2 363 1 INV1S $T=491040 709520 1 0 $X=491040 $Y=704100
X1255 363 2 365 1 INV1S $T=493520 709520 0 180 $X=492280 $Y=704100
X1256 2799 2 2816 1 INV1S $T=494140 719600 0 180 $X=492900 $Y=714180
X1257 2864 2 2852 1 INV1S $T=497860 840560 1 180 $X=496620 $Y=840180
X1258 2851 2 2888 1 INV1S $T=499100 820400 1 0 $X=499100 $Y=814980
X1259 2723 2 2913 1 INV1S $T=501580 770000 0 0 $X=501580 $Y=769620
X1260 2714 2 2860 1 INV1S $T=504060 739760 1 180 $X=502820 $Y=739380
X1261 2949 2 2932 1 INV1S $T=509020 739760 0 180 $X=507780 $Y=734340
X1262 2711 2 2951 1 INV1S $T=507780 739760 0 0 $X=507780 $Y=739380
X1263 2623 2 2901 1 INV1S $T=509640 840560 0 180 $X=508400 $Y=835140
X1264 2966 2 2975 1 INV1S $T=510880 739760 1 0 $X=510880 $Y=734340
X1265 2835 2 2987 1 INV1S $T=512740 759920 0 0 $X=512740 $Y=759540
X1266 2974 2 372 1 INV1S $T=513360 880880 1 0 $X=513360 $Y=875460
X1267 2684 2 3073 1 INV1S $T=530100 820400 1 0 $X=530100 $Y=814980
X1268 2421 2 3072 1 INV1S $T=533200 850640 1 180 $X=531960 $Y=850260
X1269 2672 2 3084 1 INV1S $T=536300 810320 0 180 $X=535060 $Y=804900
X1270 444 2 406 1 INV1S $T=535060 880880 1 0 $X=535060 $Y=875460
X1271 3116 2 3088 1 INV1S $T=538780 759920 0 180 $X=537540 $Y=754500
X1272 3010 2 3071 1 INV1S $T=537540 800240 1 0 $X=537540 $Y=794820
X1273 3104 2 3114 1 INV1S $T=544980 749840 1 180 $X=543740 $Y=749460
X1274 2690 2 3129 1 INV1S $T=543740 830480 1 0 $X=543740 $Y=825060
X1275 3131 2 2980 1 INV1S $T=543740 870800 1 0 $X=543740 $Y=865380
X1276 3152 2 3141 1 INV1S $T=548080 709520 0 180 $X=546840 $Y=704100
X1277 2839 2 3168 1 INV1S $T=552420 860720 0 0 $X=552420 $Y=860340
X1278 456 2 3194 1 INV1S $T=554900 739760 1 0 $X=554900 $Y=734340
X1279 3200 2 3146 1 INV1S $T=558000 759920 1 180 $X=556760 $Y=759540
X1280 3157 2 3149 1 INV1S $T=558620 780080 0 180 $X=557380 $Y=774660
X1281 2561 2 2912 1 INV1S $T=558620 810320 0 180 $X=557380 $Y=804900
X1282 3219 2 3222 1 INV1S $T=561100 759920 0 0 $X=561100 $Y=759540
X1283 3165 2 3232 1 INV1S $T=563580 739760 1 0 $X=563580 $Y=734340
X1284 2619 2 2906 1 INV1S $T=566680 830480 1 0 $X=566680 $Y=825060
X1285 491 2 3283 1 INV1S $T=567300 770000 1 0 $X=567300 $Y=764580
X1286 500 2 3262 1 INV1S $T=570400 780080 0 180 $X=569160 $Y=774660
X1287 3268 2 3237 1 INV1S $T=571020 729680 1 180 $X=569780 $Y=729300
X1288 3264 2 3230 1 INV1S $T=571640 719600 1 180 $X=570400 $Y=719220
X1289 3248 2 3225 1 INV1S $T=574120 790160 0 180 $X=572880 $Y=784740
X1290 2566 2 2858 1 INV1S $T=574120 810320 1 180 $X=572880 $Y=809940
X1291 2676 2 2995 1 INV1S $T=574120 820400 0 0 $X=574120 $Y=820020
X1292 3296 2 3298 1 INV1S $T=574740 790160 1 0 $X=574740 $Y=784740
X1293 3193 2 3318 1 INV1S $T=577840 739760 0 0 $X=577840 $Y=739380
X1294 418 2 2928 1 INV1S $T=580320 870800 0 0 $X=580320 $Y=870420
X1295 3290 2 3244 1 INV1S $T=582180 709520 1 180 $X=580940 $Y=709140
X1296 3273 2 3363 1 INV1S $T=584040 749840 0 0 $X=584040 $Y=749460
X1297 3371 2 3364 1 INV1S $T=587140 709520 0 180 $X=585900 $Y=704100
X1298 3343 2 3332 1 INV1S $T=589000 770000 0 180 $X=587760 $Y=764580
X1299 3388 2 530 1 INV1S $T=591480 709520 0 180 $X=590240 $Y=704100
X1300 497 2 3382 1 INV1S $T=591480 770000 1 0 $X=591480 $Y=764580
X1301 3399 2 3278 1 INV1S $T=592720 830480 1 180 $X=591480 $Y=830100
X1302 526 2 395 1 INV1S $T=593340 860720 1 180 $X=592100 $Y=860340
X1303 3340 2 3392 1 INV1S $T=593340 749840 0 0 $X=593340 $Y=749460
X1304 3397 2 3389 1 INV1S $T=595200 800240 1 180 $X=593960 $Y=799860
X1305 454 2 397 1 INV1S $T=596440 860720 1 180 $X=595200 $Y=860340
X1306 3430 2 3402 1 INV1S $T=598300 850640 1 180 $X=597060 $Y=850260
X1307 3370 2 357 1 INV1S $T=597060 870800 0 0 $X=597060 $Y=870420
X1308 3411 2 3434 1 INV1S $T=603880 860720 1 180 $X=602640 $Y=860340
X1309 3443 2 543 1 INV1S $T=603260 699440 0 0 $X=603260 $Y=699060
X1310 3446 2 3417 1 INV1S $T=603880 830480 1 0 $X=603880 $Y=825060
X1311 3432 2 3314 1 INV1S $T=606360 759920 0 180 $X=605120 $Y=754500
X1312 3461 2 3452 1 INV1S $T=607600 810320 0 180 $X=606360 $Y=804900
X1313 3473 2 546 1 INV1S $T=609460 699440 1 180 $X=608220 $Y=699060
X1314 3297 2 3351 1 INV1S $T=610700 759920 0 180 $X=609460 $Y=754500
X1315 505 2 3333 1 INV1S $T=611320 759920 1 180 $X=610080 $Y=759540
X1316 3348 2 3365 1 INV1S $T=610700 759920 1 0 $X=610700 $Y=754500
X1317 554 2 3344 1 INV1S $T=614420 759920 0 180 $X=613180 $Y=754500
X1318 507 2 3341 1 INV1S $T=614420 759920 1 180 $X=613180 $Y=759540
X1319 3506 2 3339 1 INV1S $T=616280 749840 0 180 $X=615040 $Y=744420
X1320 555 2 557 1 INV1S $T=615660 880880 1 0 $X=615660 $Y=875460
X1321 3510 2 3493 1 INV1S $T=620000 709520 1 180 $X=618760 $Y=709140
X1322 3440 2 3447 1 INV1S $T=621240 840560 1 180 $X=620000 $Y=840180
X1323 564 2 562 1 INV1S $T=621860 880880 0 180 $X=620620 $Y=875460
X1324 3505 2 3354 1 INV1S $T=621860 749840 0 0 $X=621860 $Y=749460
X1325 3517 2 3521 1 INV1S $T=621860 810320 1 0 $X=621860 $Y=804900
X1326 3519 2 563 1 INV1S $T=624960 709520 1 180 $X=623720 $Y=709140
X1327 3496 2 3539 1 INV1S $T=625580 840560 0 0 $X=625580 $Y=840180
X1328 3358 2 3563 1 INV1S $T=628060 759920 1 0 $X=628060 $Y=754500
X1329 3550 2 569 1 INV1S $T=629920 709520 0 180 $X=628680 $Y=704100
X1330 3350 2 3584 1 INV1S $T=628680 770000 0 0 $X=628680 $Y=769620
X1331 3545 2 3368 1 INV1S $T=629920 749840 1 0 $X=629920 $Y=744420
X1332 573 2 3373 1 INV1S $T=631780 780080 1 180 $X=630540 $Y=779700
X1333 3562 2 3396 1 INV1S $T=633020 739760 1 180 $X=631780 $Y=739380
X1334 576 2 3404 1 INV1S $T=633020 790160 1 180 $X=631780 $Y=789780
X1335 3556 2 3537 1 INV1S $T=633020 800240 1 180 $X=631780 $Y=799860
X1336 3539 2 3518 1 INV1S $T=634880 860720 1 180 $X=633640 $Y=860340
X1337 3566 2 3355 1 INV1S $T=638600 780080 0 180 $X=637360 $Y=774660
X1338 3258 2 3589 1 INV1S $T=638600 850640 1 180 $X=637360 $Y=850260
X1339 3609 2 3526 1 INV1S $T=639840 719600 1 180 $X=638600 $Y=719220
X1340 3614 2 3418 1 INV1S $T=640460 739760 0 180 $X=639220 $Y=734340
X1341 3585 2 3594 1 INV1S $T=640460 709520 0 0 $X=640460 $Y=709140
X1342 584 2 3435 1 INV1S $T=643560 790160 0 180 $X=642320 $Y=784740
X1343 3628 2 3636 1 INV1S $T=643560 709520 0 0 $X=643560 $Y=709140
X1344 3590 2 3425 1 INV1S $T=644800 739760 0 180 $X=643560 $Y=734340
X1345 587 2 3413 1 INV1S $T=645420 790160 0 180 $X=644180 $Y=784740
X1346 3573 2 3577 1 INV1S $T=646040 770000 0 180 $X=644800 $Y=764580
X1347 3638 2 3458 1 INV1S $T=646660 729680 1 180 $X=645420 $Y=729300
X1348 590 2 3477 1 INV1S $T=650380 759920 1 180 $X=649140 $Y=759540
X1349 589 2 3514 1 INV1S $T=650380 770000 0 180 $X=649140 $Y=764580
X1350 580 2 3491 1 INV1S $T=652240 759920 0 180 $X=651000 $Y=754500
X1351 3672 2 3675 1 INV1S $T=652240 709520 1 0 $X=652240 $Y=704100
X1352 3603 2 3677 1 INV1S $T=652240 800240 0 0 $X=652240 $Y=799860
X1353 3706 2 3690 1 INV1S $T=657200 840560 0 180 $X=655960 $Y=835140
X1354 3572 2 3490 1 INV1S $T=659060 719600 1 180 $X=657820 $Y=719220
X1355 3733 2 3721 1 INV1S $T=664020 880880 0 180 $X=662780 $Y=875460
X1356 3735 2 3754 1 INV1S $T=665260 749840 0 0 $X=665260 $Y=749460
X1357 3667 2 3759 1 INV1S $T=667740 800240 0 0 $X=667740 $Y=799860
X1358 3746 2 3744 1 INV1S $T=668980 850640 1 180 $X=667740 $Y=850260
X1359 3697 2 3770 1 INV1S $T=670840 790160 1 0 $X=670840 $Y=784740
X1360 3749 2 3745 1 INV1S $T=672700 830480 1 180 $X=671460 $Y=830100
X1361 3642 2 3783 1 INV1S $T=672080 739760 0 0 $X=672080 $Y=739380
X1362 3711 2 3720 1 INV1S $T=672080 840560 1 0 $X=672080 $Y=835140
X1363 3612 2 3773 1 INV1S $T=673320 780080 1 0 $X=673320 $Y=774660
X1364 3760 2 3774 1 INV1S $T=675800 870800 0 180 $X=674560 $Y=865380
X1365 3779 2 610 1 INV1S $T=675800 880880 0 180 $X=674560 $Y=875460
X1366 3795 2 3786 1 INV1S $T=676420 820400 1 180 $X=675180 $Y=820020
X1367 3622 2 616 1 INV1S $T=677040 699440 0 0 $X=677040 $Y=699060
X1368 3804 2 3787 1 INV1S $T=678900 840560 1 0 $X=678900 $Y=835140
X1369 3813 2 3802 1 INV1S $T=680140 850640 0 180 $X=678900 $Y=845220
X1370 3712 2 3811 1 INV1S $T=679520 759920 0 0 $X=679520 $Y=759540
X1371 3823 2 3805 1 INV1S $T=682620 860720 1 180 $X=681380 $Y=860340
X1372 3829 2 3817 1 INV1S $T=683860 850640 1 180 $X=682620 $Y=850260
X1373 3821 2 3767 1 INV1S $T=683860 870800 1 180 $X=682620 $Y=870420
X1374 3842 2 3838 1 INV1S $T=686340 820400 1 180 $X=685100 $Y=820020
X1375 3679 2 3830 1 INV1S $T=685720 719600 0 0 $X=685720 $Y=719220
X1376 3851 2 3835 1 INV1S $T=687580 749840 0 180 $X=686340 $Y=744420
X1377 629 2 3854 1 INV1S $T=689440 739760 1 180 $X=688200 $Y=739380
X1378 3851 2 3884 1 INV1S $T=689440 749840 0 0 $X=689440 $Y=749460
X1379 628 2 3876 1 INV1S $T=690060 709520 0 0 $X=690060 $Y=709140
X1380 629 2 3887 1 INV1S $T=690060 739760 0 0 $X=690060 $Y=739380
X1381 3892 2 3888 1 INV1S $T=693160 759920 1 0 $X=693160 $Y=754500
X1382 631 2 3901 1 INV1S $T=693160 770000 0 0 $X=693160 $Y=769620
X1383 3891 2 632 1 INV1S $T=693160 880880 1 0 $X=693160 $Y=875460
X1384 3842 2 3899 1 INV1S $T=693780 810320 0 0 $X=693780 $Y=809940
X1385 631 2 3916 1 INV1S $T=695020 810320 1 0 $X=695020 $Y=804900
X1386 3926 2 3862 1 INV1S $T=697500 820400 0 180 $X=696260 $Y=814980
X1387 3911 2 3946 1 INV1S $T=697500 880880 1 0 $X=697500 $Y=875460
X1388 3926 2 3924 1 INV1S $T=700600 759920 0 180 $X=699360 $Y=754500
X1389 3890 2 3870 1 INV1S $T=702460 810320 1 180 $X=701220 $Y=809940
X1390 3906 2 3913 1 INV1S $T=701840 800240 0 0 $X=701840 $Y=799860
X1391 3906 2 3919 1 INV1S $T=701840 830480 0 0 $X=701840 $Y=830100
X1392 648 2 3961 1 INV1S $T=705560 729680 0 180 $X=704320 $Y=724260
X1393 3890 2 3894 1 INV1S $T=704320 790160 1 0 $X=704320 $Y=784740
X1394 644 2 3958 1 INV1S $T=704940 719600 1 0 $X=704940 $Y=714180
X1395 3974 2 3943 1 INV1S $T=706180 820400 0 180 $X=704940 $Y=814980
X1396 651 2 3968 1 INV1S $T=709900 709520 0 180 $X=708660 $Y=704100
X1397 4013 2 3987 1 INV1S $T=712380 820400 0 180 $X=711140 $Y=814980
X1398 4005 2 653 1 INV1S $T=711760 880880 1 0 $X=711760 $Y=875460
X1399 4021 2 4025 1 INV1S $T=714240 870800 0 0 $X=714240 $Y=870420
X1400 4036 2 4026 1 INV1S $T=717960 810320 1 180 $X=716720 $Y=809940
X1401 661 2 4037 1 INV1S $T=718580 830480 0 0 $X=718580 $Y=830100
X1402 4053 2 3885 1 INV1S $T=721680 810320 1 180 $X=720440 $Y=809940
X1403 4057 2 4078 1 INV1S $T=723540 840560 0 0 $X=723540 $Y=840180
X1404 4031 2 4096 1 INV1S $T=725400 810320 1 0 $X=725400 $Y=804900
X1405 4087 2 4090 1 INV1S $T=726020 840560 0 0 $X=726020 $Y=840180
X1406 4024 2 4093 1 INV1S $T=727880 810320 0 0 $X=727880 $Y=809940
X1407 4088 2 3965 1 INV1S $T=729740 820400 1 180 $X=728500 $Y=820020
X1408 4092 2 4101 1 INV1S $T=729120 800240 0 0 $X=729120 $Y=799860
X1409 4117 2 4095 1 INV1S $T=730980 759920 0 180 $X=729740 $Y=754500
X1410 4099 2 4112 1 INV1S $T=730980 790160 0 0 $X=730980 $Y=789780
X1411 4106 2 3984 1 INV1S $T=732220 830480 0 180 $X=730980 $Y=825060
X1412 4104 2 4126 1 INV1S $T=733460 790160 0 0 $X=733460 $Y=789780
X1413 4121 2 649 1 INV1S $T=735320 780080 1 180 $X=734080 $Y=779700
X1414 4128 2 4083 1 INV1S $T=735940 739760 1 180 $X=734700 $Y=739380
X1415 4115 2 4144 1 INV1S $T=734700 790160 1 0 $X=734700 $Y=784740
X1416 3910 2 4150 1 INV1S $T=736560 810320 0 0 $X=736560 $Y=809940
X1417 4086 2 4156 1 INV1S $T=740900 830480 1 0 $X=740900 $Y=825060
X1418 693 2 690 1 INV1S $T=743380 699440 1 180 $X=742140 $Y=699060
X1419 4097 2 4114 1 INV1S $T=744620 729680 0 180 $X=743380 $Y=724260
X1420 4165 2 4186 1 INV1S $T=744620 820400 0 0 $X=744620 $Y=820020
X1421 4177 2 4187 1 INV1S $T=748340 749840 1 180 $X=747100 $Y=749460
X1422 4163 2 4185 1 INV1S $T=747100 810320 1 0 $X=747100 $Y=804900
X1423 4137 2 702 1 INV1S $T=747100 880880 1 0 $X=747100 $Y=875460
X1424 4164 2 4192 1 INV1S $T=748960 790160 0 180 $X=747720 $Y=784740
X1425 4160 2 4190 1 INV1S $T=747720 800240 0 0 $X=747720 $Y=799860
X1426 4194 2 3858 1 INV1S $T=748960 830480 0 0 $X=748960 $Y=830100
X1427 4158 2 4157 1 INV1S $T=752060 719600 0 180 $X=750820 $Y=714180
X1428 4221 2 4183 1 INV1S $T=753920 709520 0 180 $X=752680 $Y=704100
X1429 4219 2 4212 1 INV1S $T=755160 749840 1 180 $X=753920 $Y=749460
X1430 4145 2 4233 1 INV1S $T=753920 810320 1 0 $X=753920 $Y=804900
X1431 4172 2 706 1 INV1S $T=753920 880880 1 0 $X=753920 $Y=875460
X1432 4240 2 4196 1 INV1S $T=757020 759920 1 180 $X=755780 $Y=759540
X1433 4154 2 4248 1 INV1S $T=757640 800240 0 0 $X=757640 $Y=799860
X1434 4130 2 4258 1 INV1S $T=760120 820400 1 0 $X=760120 $Y=814980
X1435 713 2 718 1 INV1S $T=760740 699440 0 0 $X=760740 $Y=699060
X1436 4261 2 715 1 INV1S $T=762600 860720 1 180 $X=761360 $Y=860340
X1437 679 2 721 1 INV1S $T=762600 719600 1 0 $X=762600 $Y=714180
X1438 4250 2 722 1 INV1S $T=765080 870800 0 0 $X=765080 $Y=870420
X1439 4129 2 724 1 INV1S $T=765700 709520 0 0 $X=765700 $Y=709140
X1440 4079 2 728 1 INV1S $T=765700 719600 1 0 $X=765700 $Y=714180
X1441 725 2 727 1 INV1S $T=766320 870800 0 0 $X=766320 $Y=870420
X1442 4290 2 729 1 INV1S $T=767560 870800 0 0 $X=767560 $Y=870420
X1443 4291 2 730 1 INV1S $T=767560 880880 1 0 $X=767560 $Y=875460
X1444 4294 2 4303 1 INV1S $T=769420 739760 1 0 $X=769420 $Y=734340
X1445 4081 2 4308 1 INV1S $T=769420 749840 1 0 $X=769420 $Y=744420
X1446 4237 2 732 1 INV1S $T=771280 719600 0 0 $X=771280 $Y=719220
X1447 4062 2 733 1 INV1S $T=771280 729680 0 0 $X=771280 $Y=729300
X1448 4312 2 710 1 INV1S $T=773140 870800 0 180 $X=771900 $Y=865380
X1449 4324 2 4314 1 INV1S $T=773760 749840 1 180 $X=772520 $Y=749460
X1450 4338 2 736 1 INV1S $T=774380 870800 0 180 $X=773140 $Y=865380
X1451 4336 2 4323 1 INV1S $T=775620 759920 1 180 $X=774380 $Y=759540
X1452 4321 2 740 1 INV1S $T=774380 860720 0 0 $X=774380 $Y=860340
X1453 4318 2 4347 1 INV1S $T=778100 759920 0 0 $X=778100 $Y=759540
X1454 4140 2 4326 1 INV1S $T=781200 749840 1 180 $X=779960 $Y=749460
X1455 4171 2 4361 1 INV1S $T=782440 729680 0 0 $X=782440 $Y=729300
X1456 4263 2 4382 1 INV1S $T=783680 749840 1 0 $X=783680 $Y=744420
X1457 4388 2 4362 1 INV1S $T=785540 830480 0 180 $X=784300 $Y=825060
X1458 4397 2 4398 1 INV1S $T=786780 840560 1 0 $X=786780 $Y=835140
X1459 717 2 4413 1 INV1S $T=790500 800240 1 180 $X=789260 $Y=799860
X1460 756 2 4383 1 INV1S $T=791120 759920 1 180 $X=789880 $Y=759540
X1461 4381 2 764 1 INV1S $T=789880 880880 1 0 $X=789880 $Y=875460
X1462 4425 2 765 1 INV1S $T=791120 880880 1 0 $X=791120 $Y=875460
X1463 4431 2 758 1 INV1S $T=792360 880880 1 0 $X=792360 $Y=875460
X1464 4188 2 4433 1 INV1S $T=792980 770000 1 0 $X=792980 $Y=764580
X1465 4432 2 4273 1 INV1S $T=797320 810320 0 180 $X=796080 $Y=804900
X1466 4403 2 4452 1 INV1S $T=798560 810320 1 0 $X=798560 $Y=804900
X1467 4466 2 779 1 INV1S $T=802900 870800 1 0 $X=802900 $Y=865380
X1468 4477 2 781 1 INV1S $T=802900 880880 1 0 $X=802900 $Y=875460
X1469 747 2 4369 1 INV1S $T=803520 759920 0 0 $X=803520 $Y=759540
X1470 4464 2 4479 1 INV1S $T=804140 820400 0 0 $X=804140 $Y=820020
X1471 4505 2 4403 1 INV1S $T=808480 810320 0 180 $X=807240 $Y=804900
X1472 4430 2 4498 1 INV1S $T=808480 870800 0 180 $X=807240 $Y=865380
X1473 4490 2 4484 1 INV1S $T=814680 759920 1 180 $X=813440 $Y=759540
X1474 4501 2 4546 1 INV1S $T=814060 790160 0 0 $X=814060 $Y=789780
X1475 4503 2 4541 1 INV1S $T=815920 830480 0 180 $X=814680 $Y=825060
X1476 4546 2 4547 1 INV1S $T=815300 790160 0 0 $X=815300 $Y=789780
X1477 4524 2 4552 1 INV1S $T=817780 790160 1 180 $X=816540 $Y=789780
X1478 762 2 4422 1 INV1S $T=817160 739760 0 0 $X=817160 $Y=739380
X1479 4522 2 4507 1 INV1S $T=819640 749840 1 180 $X=818400 $Y=749460
X1480 756 2 4509 1 INV1S $T=820880 770000 1 0 $X=820880 $Y=764580
X1481 4580 2 4582 1 INV1S $T=822120 830480 0 0 $X=822120 $Y=830100
X1482 4560 2 4468 1 INV1S $T=823360 770000 1 0 $X=823360 $Y=764580
X1483 4584 2 4506 1 INV1S $T=826460 739760 1 180 $X=825220 $Y=739380
X1484 4554 2 4488 1 INV1S $T=825220 770000 1 0 $X=825220 $Y=764580
X1485 809 2 750 1 INV1S $T=828320 860720 1 0 $X=828320 $Y=855300
X1486 4602 2 4472 1 INV1S $T=832040 739760 0 180 $X=830800 $Y=734340
X1487 4614 2 787 1 INV1S $T=832660 780080 0 180 $X=831420 $Y=774660
X1488 4574 2 4480 1 INV1S $T=833900 739760 1 0 $X=833900 $Y=734340
X1489 4585 2 4613 1 INV1S $T=833900 810320 0 0 $X=833900 $Y=809940
X1490 4610 2 4637 1 INV1S $T=835760 820400 0 0 $X=835760 $Y=820020
X1491 4458 2 4645 1 INV1S $T=836380 780080 1 0 $X=836380 $Y=774660
X1492 815 2 792 1 INV1S $T=840100 709520 1 180 $X=838860 $Y=709140
X1493 4609 2 780 1 INV1S $T=840100 719600 0 180 $X=838860 $Y=714180
X1494 4619 2 4626 1 INV1S $T=838860 800240 0 0 $X=838860 $Y=799860
X1495 4406 2 4657 1 INV1S $T=840720 749840 1 0 $X=840720 $Y=744420
X1496 4629 2 4653 1 INV1S $T=842580 810320 0 180 $X=841340 $Y=804900
X1497 4544 2 4659 1 INV1S $T=841960 840560 1 0 $X=841960 $Y=835140
X1498 4437 2 4661 1 INV1S $T=842580 759920 1 0 $X=842580 $Y=754500
X1499 4399 2 4682 1 INV1S $T=843200 719600 1 0 $X=843200 $Y=714180
X1500 4650 2 782 1 INV1S $T=845060 729680 0 180 $X=843820 $Y=724260
X1501 4461 2 4684 1 INV1S $T=843820 749840 1 0 $X=843820 $Y=744420
X1502 4672 2 4679 1 INV1S $T=846300 790160 1 0 $X=846300 $Y=784740
X1503 4384 2 4688 1 INV1S $T=847540 729680 1 0 $X=847540 $Y=724260
X1504 4359 2 4696 1 INV1S $T=849400 719600 1 0 $X=849400 $Y=714180
X1505 4548 2 4699 1 INV1S $T=850020 810320 0 0 $X=850020 $Y=809940
X1506 4419 2 4712 1 INV1S $T=853740 739760 1 0 $X=853740 $Y=734340
X1507 4532 2 4732 1 INV1S $T=858080 699440 0 0 $X=858080 $Y=699060
X1508 4508 2 4762 1 INV1S $T=862420 739760 0 0 $X=862420 $Y=739380
X1509 4752 2 4758 1 INV1S $T=863660 780080 1 0 $X=863660 $Y=774660
X1510 4756 2 4770 1 INV1S $T=865520 800240 1 0 $X=865520 $Y=794820
X1511 853 2 4786 1 INV1S $T=867380 820400 0 0 $X=867380 $Y=820020
X1512 4707 2 4778 1 INV1S $T=868000 790160 0 0 $X=868000 $Y=789780
X1513 4734 2 4779 1 INV1S $T=869240 800240 1 0 $X=869240 $Y=794820
X1514 4768 2 4788 1 INV1S $T=870480 800240 1 0 $X=870480 $Y=794820
X1515 4791 2 4813 1 INV1S $T=871720 800240 1 0 $X=871720 $Y=794820
X1516 860 2 4798 1 INV1S $T=871720 830480 0 0 $X=871720 $Y=830100
X1517 4797 2 4784 1 INV1S $T=874200 780080 1 0 $X=874200 $Y=774660
X1518 871 2 4812 1 INV1S $T=874820 830480 1 0 $X=874820 $Y=825060
X1519 874 2 4818 1 INV1S $T=876060 830480 1 0 $X=876060 $Y=825060
X1520 4830 2 4825 1 INV1S $T=879160 830480 0 180 $X=877920 $Y=825060
X1521 4743 2 4843 1 INV1S $T=879160 770000 0 0 $X=879160 $Y=769620
X1522 4841 2 4819 1 INV1S $T=881640 830480 0 180 $X=880400 $Y=825060
X1523 4846 2 4858 1 INV1S $T=881640 820400 1 0 $X=881640 $Y=814980
X1524 4849 2 4826 1 INV1S $T=883500 770000 1 180 $X=882260 $Y=769620
X1525 4822 2 4853 1 INV1S $T=882260 830480 0 0 $X=882260 $Y=830100
X1526 889 2 4862 1 INV1S $T=885360 840560 1 0 $X=885360 $Y=835140
X1527 4867 2 4864 1 INV1S $T=886600 810320 1 0 $X=886600 $Y=804900
X1528 4877 2 4860 1 INV1S $T=889700 770000 1 0 $X=889700 $Y=764580
X1529 4857 2 4887 1 INV1S $T=889700 830480 1 0 $X=889700 $Y=825060
X1530 4886 2 4868 1 INV1S $T=892180 759920 1 180 $X=890940 $Y=759540
X1531 4898 2 4894 1 INV1S $T=899000 820400 0 180 $X=897760 $Y=814980
X1532 4899 2 4902 1 INV1S $T=898380 749840 0 0 $X=898380 $Y=749460
X1533 4892 2 4917 1 INV1S $T=900860 790160 1 0 $X=900860 $Y=784740
X1534 4915 2 4923 1 INV1S $T=901480 770000 0 0 $X=901480 $Y=769620
X1535 4916 2 4931 1 INV1S $T=901480 780080 0 0 $X=901480 $Y=779700
X1536 4938 2 4925 1 INV1S $T=904580 820400 0 180 $X=903340 $Y=814980
X1537 4912 2 4947 1 INV1S $T=903960 790160 1 0 $X=903960 $Y=784740
X1538 4935 2 4943 1 INV1S $T=904580 770000 0 0 $X=904580 $Y=769620
X1539 4940 2 4950 1 INV1S $T=905200 759920 0 0 $X=905200 $Y=759540
X1540 4941 2 4969 1 INV1S $T=905200 810320 0 0 $X=905200 $Y=809940
X1541 4958 2 4913 1 INV1S $T=907060 790160 1 180 $X=905820 $Y=789780
X1542 4955 2 4945 1 INV1S $T=907680 830480 0 180 $X=906440 $Y=825060
X1543 4965 2 4910 1 INV1S $T=908300 800240 0 180 $X=907060 $Y=794820
X1544 917 2 4949 1 INV1S $T=908920 840560 0 180 $X=907680 $Y=835140
X1545 4980 2 4936 1 INV1S $T=911400 749840 1 180 $X=910160 $Y=749460
X1546 4979 2 4957 1 INV1S $T=910780 749840 1 0 $X=910780 $Y=744420
X1547 4982 2 4960 1 INV1S $T=912020 719600 0 0 $X=912020 $Y=719220
X1548 4988 2 4961 1 INV1S $T=913260 739760 1 180 $X=912020 $Y=739380
X1549 4907 2 4987 1 INV1S $T=912020 840560 1 0 $X=912020 $Y=835140
X1550 4993 2 4920 1 INV1S $T=913880 749840 1 180 $X=912640 $Y=749460
X1551 4989 2 4984 1 INV1S $T=912640 820400 1 0 $X=912640 $Y=814980
X1552 5000 2 4951 1 INV1S $T=915120 759920 0 180 $X=913880 $Y=754500
X1553 4978 2 4973 1 INV1S $T=914500 719600 1 0 $X=914500 $Y=714180
X1554 5003 2 4959 1 INV1S $T=916360 820400 0 180 $X=915120 $Y=814980
X1555 5025 2 4956 1 INV1S $T=918840 739760 1 180 $X=917600 $Y=739380
X1556 5015 2 4881 1 INV1S $T=919460 820400 0 180 $X=918220 $Y=814980
X1557 5024 2 4991 1 INV1S $T=921320 840560 0 180 $X=920080 $Y=835140
X1558 5035 2 5014 1 INV1S $T=922560 820400 0 180 $X=921320 $Y=814980
X1559 940 2 5018 1 INV1S $T=924420 840560 0 180 $X=923180 $Y=835140
X1560 5044 2 946 1 INV1S $T=926900 709520 0 180 $X=925660 $Y=704100
X1561 4646 2 5083 1 INV1S $T=933100 850640 0 0 $X=933100 $Y=850260
X1562 4694 2 5101 1 INV1S $T=935580 850640 0 0 $X=935580 $Y=850260
X1563 4693 2 5194 1 INV1S $T=969680 860720 1 0 $X=969680 $Y=855300
X1564 4976 2 5244 1 INV1S $T=981460 860720 1 0 $X=981460 $Y=855300
X1565 4534 2 5284 1 INV1S $T=996340 860720 0 0 $X=996340 $Y=860340
X1566 4810 2 5291 1 INV1S $T=998820 860720 0 0 $X=998820 $Y=860340
X1567 5469 2 4663 1 INV1S $T=1068880 860720 1 0 $X=1068880 $Y=855300
X1568 1098 1 1110 5 2 1129 ND3 $T=221960 770000 0 0 $X=221960 $Y=769620
X1569 1113 1 1144 1125 2 1162 ND3 $T=221960 840560 0 0 $X=221960 $Y=840180
X1570 1134 1 1127 1114 2 1104 ND3 $T=224440 860720 0 180 $X=221960 $Y=855300
X1571 1115 1 1095 8 2 1140 ND3 $T=222580 739760 0 0 $X=222580 $Y=739380
X1572 1198 1 1183 1171 2 1187 ND3 $T=230020 830480 0 180 $X=227540 $Y=825060
X1573 1187 1 1199 1166 2 1116 ND3 $T=230020 830480 1 180 $X=227540 $Y=830100
X1574 1202 1 1210 12 2 1151 ND3 $T=230640 770000 1 180 $X=228160 $Y=769620
X1575 19 1 1205 1192 2 1139 ND3 $T=234980 880880 0 180 $X=232500 $Y=875460
X1576 1178 1 1263 20 2 1183 ND3 $T=236840 820400 0 180 $X=234360 $Y=814980
X1577 1138 1 22 23 2 1276 ND3 $T=236220 790160 1 0 $X=236220 $Y=784740
X1578 1247 1 4 1266 2 1295 ND3 $T=236840 729680 1 0 $X=236840 $Y=724260
X1579 1283 1 1271 1156 2 1259 ND3 $T=240560 770000 1 180 $X=238080 $Y=769620
X1580 1308 1 1275 1331 2 1268 ND3 $T=244280 830480 0 180 $X=241800 $Y=825060
X1581 1260 1 1340 1122 2 1323 ND3 $T=248000 820400 1 180 $X=245520 $Y=820020
X1582 1385 1 1372 1391 2 1180 ND3 $T=252960 810320 1 180 $X=250480 $Y=809940
X1583 1397 1 1365 1227 2 1361 ND3 $T=255440 830480 0 180 $X=252960 $Y=825060
X1584 1406 1 1218 1355 2 38 ND3 $T=256680 719600 0 180 $X=254200 $Y=714180
X1585 1426 1 1218 1216 2 39 ND3 $T=259780 699440 1 180 $X=257300 $Y=699060
X1586 1427 1 1413 1412 2 1293 ND3 $T=259780 749840 0 180 $X=257300 $Y=744420
X1587 1424 1 1359 42 2 1415 ND3 $T=261020 739760 0 180 $X=258540 $Y=734340
X1588 1481 1 1452 1350 2 1217 ND3 $T=264740 709520 1 180 $X=262260 $Y=709140
X1589 1458 1 1471 1101 2 1489 ND3 $T=265360 749840 1 0 $X=265360 $Y=744420
X1590 1377 1 1472 1306 2 1494 ND3 $T=265360 780080 1 0 $X=265360 $Y=774660
X1591 1449 1 1474 1475 2 1409 ND3 $T=265360 800240 0 0 $X=265360 $Y=799860
X1592 1452 1 1487 1478 2 1416 ND3 $T=269080 719600 1 180 $X=266600 $Y=719220
X1593 1409 1 1496 1436 2 1505 ND3 $T=268460 810320 1 0 $X=268460 $Y=804900
X1594 1477 1 1498 62 2 1512 ND3 $T=269700 790160 1 0 $X=269700 $Y=784740
X1595 1522 1 1506 1508 2 1497 ND3 $T=272800 759920 0 180 $X=270320 $Y=754500
X1596 1526 1 1528 70 2 1519 ND3 $T=274040 759920 0 0 $X=274040 $Y=759540
X1597 1368 1 1536 1547 2 1427 ND3 $T=275280 749840 1 0 $X=275280 $Y=744420
X1598 1529 1 1354 72 2 1554 ND3 $T=275280 790160 1 0 $X=275280 $Y=784740
X1599 1368 1 1492 1398 2 1567 ND3 $T=276520 739760 0 0 $X=276520 $Y=739380
X1600 1535 1 1406 1533 2 1579 ND3 $T=279000 709520 0 0 $X=279000 $Y=709140
X1601 1561 1 1585 1588 2 1349 ND3 $T=284580 759920 0 180 $X=282100 $Y=754500
X1602 1599 1 1594 1580 2 1558 ND3 $T=285820 820400 0 180 $X=283340 $Y=814980
X1603 1573 1 1307 1571 2 1618 ND3 $T=284580 780080 1 0 $X=284580 $Y=774660
X1604 1490 1 1517 1606 2 1607 ND3 $T=285820 810320 1 0 $X=285820 $Y=804900
X1605 1629 1 1630 1675 2 1670 ND3 $T=296360 729680 0 0 $X=296360 $Y=729300
X1606 1683 1 1371 1666 2 1445 ND3 $T=300700 749840 0 180 $X=298220 $Y=744420
X1607 1445 1 1657 1541 2 1659 ND3 $T=300700 770000 0 180 $X=298220 $Y=764580
X1608 1691 1 1678 1662 2 1596 ND3 $T=301320 820400 0 180 $X=298840 $Y=814980
X1609 1682 1 88 1656 2 91 ND3 $T=301320 880880 0 180 $X=298840 $Y=875460
X1610 1659 1 1494 1673 2 1427 ND3 $T=301940 780080 0 180 $X=299460 $Y=774660
X1611 92 1 1342 1687 2 95 ND3 $T=301320 699440 0 0 $X=301320 $Y=699060
X1612 1677 1 1695 1708 2 1627 ND3 $T=302560 800240 0 0 $X=302560 $Y=799860
X1613 1704 1 1209 1638 2 1585 ND3 $T=305660 770000 0 180 $X=303180 $Y=764580
X1614 1714 1 1709 97 2 1589 ND3 $T=308140 739760 1 180 $X=305660 $Y=739380
X1615 1719 1 1471 1727 2 1636 ND3 $T=311240 830480 1 180 $X=308760 $Y=830100
X1616 1689 1 1471 1712 2 1736 ND3 $T=309380 810320 0 0 $X=309380 $Y=809940
X1617 96 1 100 99 2 93 ND3 $T=309380 880880 1 0 $X=309380 $Y=875460
X1618 1370 1 95 1743 2 1520 ND3 $T=312480 729680 1 180 $X=310000 $Y=729300
X1619 1746 1 1739 1651 2 1733 ND3 $T=314340 749840 0 180 $X=311860 $Y=744420
X1620 1750 1 38 1751 2 1761 ND3 $T=315580 729680 0 0 $X=315580 $Y=729300
X1621 1767 1 1471 1763 2 1773 ND3 $T=318060 820400 0 0 $X=318060 $Y=820020
X1622 89 1 109 1758 2 1693 ND3 $T=320540 880880 0 180 $X=318060 $Y=875460
X1623 1760 1 1728 113 2 1605 ND3 $T=319300 800240 1 0 $X=319300 $Y=794820
X1624 1756 1 1769 1770 2 1776 ND3 $T=319920 810320 0 0 $X=319920 $Y=809940
X1625 1702 1 1628 1833 2 1585 ND3 $T=334180 780080 0 180 $X=331700 $Y=774660
X1626 1444 1 1779 1842 2 1417 ND3 $T=336040 770000 1 0 $X=336040 $Y=764580
X1627 1844 1 1887 134 2 1684 ND3 $T=344720 800240 0 180 $X=342240 $Y=794820
X1628 1446 1 1650 135 2 1878 ND3 $T=344100 780080 0 0 $X=344100 $Y=779700
X1629 1885 1 1891 1288 2 1786 ND3 $T=346580 810320 1 180 $X=344100 $Y=809940
X1630 1884 1 1891 1157 2 1820 ND3 $T=348440 820400 1 180 $X=345960 $Y=820020
X1631 1820 1 1891 1457 2 1885 ND3 $T=348440 830480 0 180 $X=345960 $Y=825060
X1632 1866 1 1883 1903 2 1880 ND3 $T=346580 729680 1 0 $X=346580 $Y=724260
X1633 1884 1 1891 1345 2 1786 ND3 $T=349060 810320 0 0 $X=349060 $Y=809940
X1634 1657 1 1413 1912 2 1295 ND3 $T=354020 770000 0 180 $X=351540 $Y=764580
X1635 1955 1 147 28 2 1820 ND3 $T=354640 820400 0 180 $X=352160 $Y=814980
X1636 1899 1 1950 1181 2 147 ND3 $T=356500 810320 1 180 $X=354020 $Y=809940
X1637 1913 1 1937 148 2 1948 ND3 $T=354640 800240 1 0 $X=354640 $Y=794820
X1638 1955 1 1786 33 2 147 ND3 $T=357740 810320 0 180 $X=355260 $Y=804900
X1639 1955 1 1959 1619 2 1786 ND3 $T=358360 830480 0 180 $X=355880 $Y=825060
X1640 1899 1 1950 1435 2 1959 ND3 $T=356500 830480 0 0 $X=356500 $Y=830100
X1641 1955 1 1959 1191 2 1820 ND3 $T=360220 820400 0 180 $X=357740 $Y=814980
X1642 1856 1 1950 18 2 147 ND3 $T=362080 810320 1 180 $X=359600 $Y=809940
X1643 2006 1 1980 1472 2 1951 ND3 $T=367660 780080 0 180 $X=365180 $Y=774660
X1644 2119 1 2007 2144 2 1997 ND3 $T=388740 820400 0 180 $X=386260 $Y=814980
X1645 2152 1 147 2141 2 159 ND3 $T=392460 840560 1 180 $X=389980 $Y=840180
X1646 2102 1 2179 2032 2 2144 ND3 $T=394940 810320 0 180 $X=392460 $Y=804900
X1647 2158 1 1934 2179 2 2173 ND3 $T=394940 820400 0 0 $X=394940 $Y=820020
X1648 204 1 2227 2229 2 2014 ND3 $T=404860 880880 1 0 $X=404860 $Y=875460
X1649 2226 1 147 2268 2 159 ND3 $T=406100 840560 1 0 $X=406100 $Y=835140
X1650 2386 1 259 2409 2 2392 ND3 $T=431520 850640 0 0 $X=431520 $Y=850260
X1651 2534 1 2409 281 2 279 ND3 $T=448260 850640 1 180 $X=445780 $Y=850260
X1652 2595 1 2593 2458 2 2559 ND3 $T=460040 820400 0 180 $X=457560 $Y=814980
X1653 2760 1 2767 2795 2 2793 ND3 $T=482360 820400 1 0 $X=482360 $Y=814980
X1654 2790 1 2780 2773 2 2750 ND3 $T=484840 850640 0 180 $X=482360 $Y=845220
X1655 2751 1 2631 2813 2 2797 ND3 $T=487320 780080 0 0 $X=487320 $Y=779700
X1656 2863 1 376 2851 2 2661 ND3 $T=496000 820400 1 180 $X=493520 $Y=820020
X1657 2915 1 2883 2885 2 2869 ND3 $T=500340 780080 0 180 $X=497860 $Y=774660
X1658 2879 1 2743 2840 2 2918 ND3 $T=498480 860720 1 0 $X=498480 $Y=855300
X1659 2873 1 2870 383 2 2898 ND3 $T=499100 790160 0 0 $X=499100 $Y=789780
X1660 2954 1 2947 2923 2 2871 ND3 $T=508400 820400 0 180 $X=505920 $Y=814980
X1661 3083 1 2930 3067 2 2990 ND3 $T=528860 780080 1 180 $X=526380 $Y=779700
X1662 3013 1 3061 3063 2 3069 ND3 $T=526380 850640 1 0 $X=526380 $Y=845220
X1663 3089 1 3033 436 2 3053 ND3 $T=535060 780080 0 180 $X=532580 $Y=774660
X1664 3083 1 2725 3137 2 3093 ND3 $T=533200 790160 1 0 $X=533200 $Y=784740
X1665 3077 1 3016 439 2 3074 ND3 $T=536300 770000 1 180 $X=533820 $Y=769620
X1666 3091 1 3020 3109 2 450 ND3 $T=537540 830480 0 0 $X=537540 $Y=830100
X1667 3099 1 3110 3115 2 453 ND3 $T=540020 860720 0 0 $X=540020 $Y=860340
X1668 3164 1 3022 465 2 3132 ND3 $T=548700 780080 1 180 $X=546220 $Y=779700
X1669 3158 1 3150 3153 2 2850 ND3 $T=550560 800240 1 180 $X=548080 $Y=799860
X1670 3122 1 3026 3185 2 2918 ND3 $T=553040 850640 1 180 $X=550560 $Y=850260
X1671 3196 1 3180 470 2 3040 ND3 $T=554900 810320 0 180 $X=552420 $Y=804900
X1672 3214 1 3020 3188 2 3155 ND3 $T=558000 830480 1 180 $X=555520 $Y=830100
X1673 3012 1 3212 3147 2 3208 ND3 $T=559240 800240 0 0 $X=559240 $Y=799860
X1674 3241 1 3245 3104 2 3235 ND3 $T=566680 759920 1 180 $X=564200 $Y=759540
X1675 3260 1 3134 495 2 3233 ND3 $T=566680 800240 0 180 $X=564200 $Y=794820
X1676 3228 1 3242 488 2 3101 ND3 $T=566680 800240 1 180 $X=564200 $Y=799860
X1677 3252 1 3255 3152 2 3271 ND3 $T=567300 739760 1 0 $X=567300 $Y=734340
X1678 3279 1 3263 496 2 3256 ND3 $T=570400 810320 1 180 $X=567920 $Y=809940
X1679 3281 1 3285 3268 2 3293 ND3 $T=572260 729680 0 0 $X=572260 $Y=729300
X1680 3302 1 3308 3157 2 3286 ND3 $T=575360 780080 0 180 $X=572880 $Y=774660
X1681 3303 1 3305 3264 2 3322 ND3 $T=575980 729680 1 0 $X=575980 $Y=724260
X1682 3310 1 3313 3248 2 3393 ND3 $T=577840 790160 1 0 $X=577840 $Y=784740
X1683 3329 1 3325 3319 2 3011 ND3 $T=580940 820400 1 180 $X=578460 $Y=820020
X1684 3334 1 3330 3290 2 3317 ND3 $T=581560 719600 1 180 $X=579080 $Y=719220
X1685 3309 1 3335 3200 2 3347 ND3 $T=580320 759920 1 0 $X=580320 $Y=754500
X1686 3377 1 3383 3296 2 3403 ND3 $T=592720 790160 1 0 $X=592720 $Y=784740
X1687 3405 1 3428 523 2 3431 ND3 $T=598920 719600 1 0 $X=598920 $Y=714180
X1688 3422 1 3424 3397 2 3438 ND3 $T=600160 800240 1 0 $X=600160 $Y=794820
X1689 3439 1 3401 3336 2 3429 ND3 $T=602640 830480 0 180 $X=600160 $Y=825060
X1690 3448 1 3451 3388 2 3445 ND3 $T=606360 719600 0 180 $X=603880 $Y=714180
X1691 3453 1 3455 3461 2 3471 ND3 $T=606980 780080 0 0 $X=606980 $Y=779700
X1692 3439 1 3442 3449 2 3401 ND3 $T=606980 840560 1 0 $X=606980 $Y=835140
X1693 3466 1 3434 3427 2 3417 ND3 $T=609460 860720 1 180 $X=606980 $Y=860340
X1694 3478 1 3470 3371 2 3480 ND3 $T=608220 719600 0 0 $X=608220 $Y=719220
X1695 3446 1 3442 3221 2 3460 ND3 $T=613180 830480 0 0 $X=613180 $Y=830100
X1696 3446 1 3429 3349 2 3460 ND3 $T=614420 830480 1 0 $X=614420 $Y=825060
X1697 3509 1 3508 3473 2 3500 ND3 $T=620000 729680 1 180 $X=617520 $Y=729300
X1698 3503 1 3507 3517 2 3501 ND3 $T=618140 790160 0 0 $X=618140 $Y=789780
X1699 3513 1 3520 3443 2 3534 ND3 $T=621860 719600 0 0 $X=621860 $Y=719220
X1700 3529 1 3528 565 2 3489 ND3 $T=624960 870800 0 180 $X=622480 $Y=865380
X1701 3533 1 3538 3510 2 3559 ND3 $T=625580 739760 0 0 $X=625580 $Y=739380
X1702 3516 1 3536 3556 2 3553 ND3 $T=626820 759920 0 0 $X=626820 $Y=759540
X1703 3463 1 3518 575 2 3221 ND3 $T=629920 870800 1 0 $X=629920 $Y=865380
X1704 3608 1 3605 3519 2 3595 ND3 $T=640460 759920 1 180 $X=637980 $Y=759540
X1705 3587 1 3547 3603 2 3619 ND3 $T=637980 780080 0 0 $X=637980 $Y=779700
X1706 3597 1 3611 3550 2 3620 ND3 $T=639840 749840 1 0 $X=639840 $Y=744420
X1707 3649 1 3657 3667 2 3666 ND3 $T=647900 790160 0 0 $X=647900 $Y=789780
X1708 3574 1 3687 3697 2 3691 ND3 $T=654720 790160 1 0 $X=654720 $Y=784740
X1709 3749 1 3720 3761 2 3763 ND3 $T=672700 840560 1 180 $X=670220 $Y=840180
X1710 3769 1 3774 3763 2 3721 ND3 $T=671460 860720 1 0 $X=671460 $Y=855300
X1711 4066 1 661 4061 2 619 ND3 $T=722920 850640 1 180 $X=720440 $Y=850260
X1712 4190 1 4186 4181 2 4156 ND3 $T=747720 820400 0 180 $X=745240 $Y=814980
X1713 4258 1 4248 4213 2 4233 ND3 $T=761360 810320 1 180 $X=758880 $Y=809940
X1714 4349 1 4352 4359 2 4366 ND3 $T=778100 729680 0 0 $X=778100 $Y=729300
X1715 4343 1 4358 745 2 4371 ND3 $T=778720 709520 0 0 $X=778720 $Y=709140
X1716 4367 1 4376 4384 2 4391 ND3 $T=783060 749840 0 0 $X=783060 $Y=749460
X1717 4331 1 4396 4399 2 4418 ND3 $T=786160 729680 0 0 $X=786160 $Y=729300
X1718 4400 1 4404 4419 2 4374 ND3 $T=787400 749840 1 0 $X=787400 $Y=744420
X1719 4315 1 4450 776 2 4451 ND3 $T=797940 699440 0 0 $X=797940 $Y=699060
X1720 4328 1 4385 778 2 4429 ND3 $T=802280 719600 1 0 $X=802280 $Y=714180
X1721 4329 1 4478 4532 2 4483 ND3 $T=802280 719600 0 0 $X=802280 $Y=719220
X1722 4292 1 707 711 2 4498 ND3 $T=804140 870800 0 0 $X=804140 $Y=870420
X1723 4515 1 4452 4397 2 753 ND3 $T=807860 820400 0 180 $X=805380 $Y=814980
X1724 4523 1 4513 4221 2 4463 ND3 $T=810960 719600 1 180 $X=808480 $Y=719220
X1725 4430 1 4487 716 2 4292 ND3 $T=811580 860720 1 180 $X=809100 $Y=860340
X1726 4539 1 4516 791 2 4531 ND3 $T=813440 709520 1 180 $X=810960 $Y=709140
X1727 4559 1 4542 693 2 4565 ND3 $T=818400 719600 0 180 $X=815920 $Y=714180
X1728 4528 1 4501 749 2 4500 ND3 $T=815920 790160 1 0 $X=815920 $Y=784740
X1729 4510 1 4579 748 2 4500 ND3 $T=819020 770000 1 180 $X=816540 $Y=769620
X1730 4566 1 4536 4158 2 4587 ND3 $T=819640 739760 1 0 $X=819640 $Y=734340
X1731 4510 1 4469 753 2 4579 ND3 $T=819640 780080 1 0 $X=819640 $Y=774660
X1732 4590 1 4555 801 2 4570 ND3 $T=822740 699440 1 180 $X=820260 $Y=699060
X1733 4563 1 4578 4117 2 4593 ND3 $T=821500 759920 1 0 $X=821500 $Y=754500
X1734 4500 1 4561 762 2 4579 ND3 $T=824600 770000 1 180 $X=822120 $Y=769620
X1735 4581 1 4551 4097 2 4598 ND3 $T=822740 729680 0 0 $X=822740 $Y=729300
X1736 4605 1 4608 4128 2 4595 ND3 $T=829560 749840 0 180 $X=827080 $Y=744420
X1737 4499 1 4561 4511 2 4530 ND3 $T=828940 800240 0 0 $X=828940 $Y=799860
X1738 4620 1 4599 4619 2 4526 ND3 $T=833900 810320 1 180 $X=831420 $Y=809940
X1739 4627 1 4519 4614 2 4499 ND3 $T=835140 780080 1 180 $X=832660 $Y=779700
X1740 5320 1 5306 5282 2 5299 ND3 $T=1006880 770000 1 180 $X=1004400 $Y=769620
X1741 5317 1 5313 5289 2 5304 ND3 $T=1008740 820400 1 180 $X=1006260 $Y=820020
X1742 5338 1 5300 5267 2 5347 ND3 $T=1016800 749840 1 0 $X=1016800 $Y=744420
X1743 5343 1 5319 5270 2 5356 ND3 $T=1017420 719600 1 0 $X=1017420 $Y=714180
X1744 5351 1 5348 5287 2 5354 ND3 $T=1020520 810320 0 0 $X=1020520 $Y=809940
X1745 5357 1 5333 5268 2 5374 ND3 $T=1023000 800240 0 0 $X=1023000 $Y=799860
X1746 5375 1 5330 5271 2 5377 ND3 $T=1023620 729680 1 0 $X=1023620 $Y=724260
X1747 5360 1 5367 5285 2 5373 ND3 $T=1024860 759920 1 0 $X=1024860 $Y=754500
X1748 5381 1 5383 5281 2 5393 ND3 $T=1030440 840560 1 0 $X=1030440 $Y=835140
X1749 5415 1 5362 5247 2 5384 ND3 $T=1034780 790160 0 180 $X=1032300 $Y=784740
X1750 5402 1 5394 5279 2 5405 ND3 $T=1037260 749840 0 0 $X=1037260 $Y=749460
X1751 5409 1 5302 5264 2 5382 ND3 $T=1042220 790160 0 180 $X=1039740 $Y=784740
X1752 5416 1 5342 5273 2 5406 ND3 $T=1043460 820400 1 180 $X=1040980 $Y=820020
X1753 1194 1 10 1225 1229 2 ND3S $T=230020 759920 0 0 $X=230020 $Y=759540
X1754 1242 1 1241 24 1215 2 ND3S $T=236840 719600 0 180 $X=234360 $Y=714180
X1755 1228 1 1229 1250 1258 2 ND3S $T=236220 749840 1 0 $X=236220 $Y=744420
X1756 1293 1 1295 1236 1281 2 ND3S $T=243660 770000 0 180 $X=241180 $Y=764580
X1757 1368 1 1281 1195 1305 2 ND3S $T=255440 770000 0 180 $X=252960 $Y=764580
X1758 1462 1 1154 1233 1258 2 ND3S $T=258540 709520 1 180 $X=256060 $Y=709140
X1759 1578 1 1293 1146 1628 2 ND3S $T=285820 729680 1 0 $X=285820 $Y=724260
X1760 1516 1 1177 1631 1427 2 ND3S $T=290160 780080 1 0 $X=290160 $Y=774660
X1761 1655 1 1593 83 1633 2 ND3S $T=293880 810320 0 180 $X=291400 $Y=804900
X1762 1426 1 1472 1653 7 2 ND3S $T=293260 719600 1 0 $X=293260 $Y=714180
X1763 1427 1 1472 1652 1643 2 ND3S $T=293260 759920 0 0 $X=293260 $Y=759540
X1764 1649 1 1281 1690 1492 2 ND3S $T=303180 739760 0 180 $X=300700 $Y=734340
X1765 1697 1 10 1418 1715 2 ND3S $T=305660 790160 0 0 $X=305660 $Y=789780
X1766 1733 1 1280 1741 1739 2 ND3S $T=317440 770000 0 180 $X=314960 $Y=764580
X1767 1750 1 1649 1755 1305 2 ND3S $T=319920 719600 0 180 $X=317440 $Y=714180
X1768 95 1 1295 1812 1281 2 ND3S $T=338520 729680 1 180 $X=336040 $Y=729300
X1769 1293 1 1295 1832 1536 2 ND3S $T=344100 729680 0 180 $X=341620 $Y=724260
X1770 1951 1 1875 1494 1963 2 ND3S $T=357740 770000 0 0 $X=357740 $Y=769620
X1771 1971 1 1963 1342 117 2 ND3S $T=360840 790160 0 180 $X=358360 $Y=784740
X1772 117 1 1963 1502 1951 2 ND3S $T=362700 800240 0 180 $X=360220 $Y=794820
X1773 1762 1 1875 1287 1986 2 ND3S $T=360220 810320 1 0 $X=360220 $Y=804900
X1774 2006 1 1980 1218 1971 2 ND3S $T=363940 780080 0 180 $X=361460 $Y=774660
X1775 1957 1 1980 7 1920 2 ND3S $T=364560 780080 1 180 $X=362080 $Y=779700
X1776 2012 1 1989 1295 1951 2 ND3S $T=367660 790160 1 180 $X=365180 $Y=789780
X1777 1957 1 1980 1293 1989 2 ND3S $T=368900 770000 1 180 $X=366420 $Y=769620
X1778 1957 1 2010 47 1989 2 ND3S $T=369520 780080 1 180 $X=367040 $Y=779700
X1779 2006 1 2010 85 1971 2 ND3S $T=370140 790160 0 180 $X=367660 $Y=784740
X1780 1451 1 2022 2039 1891 2 ND3S $T=370760 850640 0 0 $X=370760 $Y=850260
X1781 170 1 1980 2066 1920 2 ND3S $T=376340 820400 0 0 $X=376340 $Y=820020
X1782 170 1 2141 176 172 2 ND3S $T=386260 840560 1 180 $X=383780 $Y=840180
X1783 216 1 2268 2270 225 2 ND3S $T=410440 840560 1 0 $X=410440 $Y=835140
X1784 248 1 280 2500 265 2 ND3S $T=447020 850640 0 180 $X=444540 $Y=845220
X1785 2575 1 2663 2658 2677 2 ND3S $T=466860 860720 0 0 $X=466860 $Y=860340
X1786 2656 1 2579 315 2678 2 ND3S $T=468720 790160 1 0 $X=468720 $Y=784740
X1787 2729 1 2737 341 2720 2 ND3S $T=476160 780080 0 0 $X=476160 $Y=779700
X1788 2990 1 2900 2989 2963 2 ND3S $T=512740 780080 1 180 $X=510260 $Y=779700
X1789 2971 1 403 404 2985 2 ND3S $T=512740 770000 0 0 $X=512740 $Y=769620
X1790 3203 1 3270 492 3265 2 ND3S $T=569780 800240 1 0 $X=569780 $Y=794820
X1791 2566 1 2906 3327 2578 2 ND3S $T=574120 830480 1 0 $X=574120 $Y=825060
X1792 3429 1 3417 3468 3460 2 ND3S $T=608840 830480 1 0 $X=608840 $Y=825060
X1793 3466 1 3434 3497 3446 2 ND3S $T=613180 860720 0 0 $X=613180 $Y=860340
X1794 3411 1 3401 3496 3446 2 ND3S $T=616900 840560 1 0 $X=616900 $Y=835140
X1795 3489 1 3449 566 3463 2 ND3S $T=622480 870800 0 0 $X=622480 $Y=870420
X1796 3528 1 3449 564 3221 2 ND3S $T=624960 880880 1 0 $X=624960 $Y=875460
X1797 4065 1 664 4053 4088 2 ND3S $T=722300 820400 1 0 $X=722300 $Y=814980
X1798 4519 1 4501 4505 4510 2 ND3S $T=811580 810320 0 180 $X=809100 $Y=804900
X1799 4526 1 4368 4503 4515 2 ND3S $T=812820 820400 0 180 $X=810340 $Y=814980
X1800 4599 1 4368 4580 753 2 ND3S $T=827700 820400 1 180 $X=825220 $Y=820020
X1801 4499 1 4530 4502 4510 2 ND3S $T=828940 800240 1 180 $X=826460 $Y=799860
X1802 1155 1137 1128 2 1121 1 1098 AN4B1S $T=226300 770000 0 180 $X=221960 $Y=764580
X1803 1196 1179 1112 2 1114 1 1151 AN4B1S $T=230640 820400 1 180 $X=226300 $Y=820020
X1804 1154 1217 10 2 1123 1 1185 AN4B1S $T=234980 729680 1 180 $X=230640 $Y=729300
X1805 1270 1255 1251 2 1094 1 1242 AN4B1S $T=239940 749840 1 180 $X=235600 $Y=749460
X1806 1252 1280 1267 2 1286 1 1302 AN4B1S $T=239320 759920 1 0 $X=239320 $Y=754500
X1807 1307 1280 1186 2 1163 1 1297 AN4B1S $T=245520 749840 0 180 $X=241180 $Y=744420
X1808 1284 1294 1322 2 1328 1 1354 AN4B1S $T=243660 780080 0 0 $X=243660 $Y=779700
X1809 1275 1299 1323 2 1330 1 1140 AN4B1S $T=243660 810320 0 0 $X=243660 $Y=809940
X1810 1305 1295 1342 2 1233 1 1325 AN4B1S $T=249860 719600 1 180 $X=245520 $Y=719220
X1811 1209 1353 1349 2 1200 1 1343 AN4B1S $T=251720 759920 0 180 $X=247380 $Y=754500
X1812 1209 1368 1349 2 1358 1 1339 AN4B1S $T=253580 759920 1 180 $X=249240 $Y=759540
X1813 1403 1364 1367 2 1301 1 1359 AN4B1S $T=254820 739760 0 180 $X=250480 $Y=734340
X1814 1307 1281 1371 2 1375 1 1315 AN4B1S $T=251720 770000 0 0 $X=251720 $Y=769620
X1815 1366 1291 1382 2 1392 1 1401 AN4B1S $T=252340 840560 1 0 $X=252340 $Y=835140
X1816 1517 1380 1179 2 1400 1 1415 AN4B1S $T=260400 810320 1 180 $X=256060 $Y=809940
X1817 1447 1434 1430 2 44 1 1424 AN4B1S $T=262880 860720 1 180 $X=258540 $Y=860340
X1818 1427 1444 1454 2 1195 1 1211 AN4B1S $T=266600 770000 0 180 $X=262260 $Y=764580
X1819 1443 1450 1463 2 1351 1 1477 AN4B1S $T=262880 790160 1 0 $X=262880 $Y=784740
X1820 1544 1537 1214 2 1500 1 1519 AN4B1S $T=277760 800240 1 180 $X=273420 $Y=799860
X1821 1565 75 1546 2 1125 1 1529 AN4B1S $T=280240 800240 0 180 $X=275900 $Y=794820
X1822 1520 74 59 2 1553 1 1557 AN4B1S $T=276520 719600 0 0 $X=276520 $Y=719220
X1823 1538 1414 1549 2 1555 1 1599 AN4B1S $T=276520 820400 1 0 $X=276520 $Y=814980
X1824 1584 1536 1217 2 1553 1 1540 AN4B1S $T=282100 729680 0 180 $X=277760 $Y=724260
X1825 1274 1494 1368 2 1482 1 1562 AN4B1S $T=282100 780080 0 180 $X=277760 $Y=774660
X1826 1542 1560 1420 2 1564 1 1563 AN4B1S $T=277760 810320 1 0 $X=277760 $Y=804900
X1827 1583 1575 1504 2 1568 1 1528 AN4B1S $T=283340 759920 1 180 $X=279000 $Y=759540
X1828 1368 1444 1274 2 1163 1 1587 AN4B1S $T=279620 770000 0 0 $X=279620 $Y=769620
X1829 1563 1505 1474 2 1580 1 1589 AN4B1S $T=279620 810320 0 0 $X=279620 $Y=809940
X1830 1552 1570 1576 2 1551 1 1447 AN4B1S $T=279620 860720 0 0 $X=279620 $Y=860340
X1831 1623 1608 1598 2 1564 1 1324 AN4B1S $T=288920 850640 0 180 $X=284580 $Y=845220
X1832 1597 1603 1604 2 1511 1 1625 AN4B1S $T=285820 739760 0 0 $X=285820 $Y=739380
X1833 1218 1520 7 2 1389 1 1616 AN4B1S $T=287680 719600 0 0 $X=287680 $Y=719220
X1834 1542 1620 1607 2 1632 1 1644 AN4B1S $T=288920 800240 1 0 $X=288920 $Y=794820
X1835 1621 1548 1635 2 1639 1 1202 AN4B1S $T=290160 770000 0 0 $X=290160 $Y=769620
X1836 1646 1209 1643 2 1358 1 1395 AN4B1S $T=296360 780080 1 180 $X=292020 $Y=779700
X1837 1659 1305 1628 2 1652 1 1312 AN4B1S $T=297600 759920 0 180 $X=293260 $Y=754500
X1838 1669 1636 1658 2 1459 1 1650 AN4B1S $T=299460 830480 1 180 $X=295120 $Y=830100
X1839 1681 1623 1668 2 1662 1 1633 AN4B1S $T=301320 810320 0 180 $X=296980 $Y=804900
X1840 86 66 84 2 1672 1 1654 AN4B1S $T=296980 870800 0 0 $X=296980 $Y=870420
X1841 1209 1702 1679 2 1326 1 1707 AN4B1S $T=304420 780080 1 0 $X=304420 $Y=774660
X1842 1665 1683 1659 2 90 1 1734 AN4B1S $T=306280 749840 0 0 $X=306280 $Y=749460
X1843 95 1293 10 2 1692 1 1686 AN4B1S $T=311240 709520 1 180 $X=306900 $Y=709140
X1844 1735 1445 1659 2 82 1 1710 AN4B1S $T=312480 770000 0 180 $X=308140 $Y=764580
X1845 1280 1585 1702 2 55 1 1745 AN4B1S $T=316820 759920 1 180 $X=312480 $Y=759540
X1846 1683 1696 1186 2 1396 1 1768 AN4B1S $T=316820 749840 1 0 $X=316820 $Y=744420
X1847 1368 1618 1454 2 1311 1 1783 AN4B1S $T=318680 780080 0 0 $X=318680 $Y=779700
X1848 10 1618 1305 2 1521 1 1753 AN4B1S $T=324880 739760 1 180 $X=320540 $Y=739380
X1849 1761 10 1452 2 1771 1 1782 AN4B1S $T=326740 729680 0 180 $X=322400 $Y=724260
X1850 1702 1305 1307 2 1617 1 1777 AN4B1S $T=327360 749840 1 180 $X=323020 $Y=749460
X1851 1578 85 1342 2 108 1 1807 AN4B1S $T=325500 709520 0 0 $X=325500 $Y=709140
X1852 1747 1578 74 2 1390 1 1811 AN4B1S $T=325500 719600 0 0 $X=325500 $Y=719220
X1853 1222 1208 1804 2 1192 1 1794 AN4B1S $T=331700 850640 1 180 $X=327360 $Y=850260
X1854 1824 1663 1805 2 1671 1 1801 AN4B1S $T=332940 749840 0 180 $X=328600 $Y=744420
X1855 1578 1649 1761 2 1812 1 1780 AN4B1S $T=329220 729680 0 0 $X=329220 $Y=729300
X1856 1816 1819 1827 2 1763 1 1826 AN4B1S $T=332940 810320 0 0 $X=332940 $Y=809940
X1857 1258 95 59 2 1832 1 1834 AN4B1S $T=334180 729680 1 0 $X=334180 $Y=724260
X1858 1305 1567 1835 2 1320 1 1853 AN4B1S $T=336660 739760 0 0 $X=336660 $Y=739380
X1859 1864 1830 1772 2 1841 1 1844 AN4B1S $T=341000 790160 0 180 $X=336660 $Y=784740
X1860 1825 1413 1779 2 1833 1 1822 AN4B1S $T=341620 780080 1 180 $X=337280 $Y=779700
X1861 1894 1693 100 2 1451 1 1882 AN4B1S $T=348440 870800 1 180 $X=344100 $Y=870420
X1862 1278 4 79 2 1664 1 1893 AN4B1S $T=345960 739760 1 0 $X=345960 $Y=734340
X1863 95 1281 1502 2 1253 1 1917 AN4B1S $T=347820 759920 0 0 $X=347820 $Y=759540
X1864 1892 1895 1900 2 1905 1 1913 AN4B1S $T=347820 800240 1 0 $X=347820 $Y=794820
X1865 2417 2407 2463 2 2398 1 2502 AN4B1S $T=438340 830480 1 0 $X=438340 $Y=825060
X1866 2487 2407 2447 2 2458 1 2442 AN4B1S $T=442680 830480 1 180 $X=438340 $Y=830100
X1867 267 2464 2470 2 2454 1 2469 AN4B1S $T=438960 860720 1 0 $X=438960 $Y=855300
X1868 2520 2480 2478 2 2453 1 2467 AN4B1S $T=444540 870800 1 180 $X=440200 $Y=870420
X1869 2493 2421 2502 2 2458 1 283 AN4B1S $T=445780 830480 1 0 $X=445780 $Y=825060
X1870 2647 2706 2712 2 2721 1 2729 AN4B1S $T=471820 820400 1 0 $X=471820 $Y=814980
X1871 2731 2725 2528 2 2597 1 2720 AN4B1S $T=476780 790160 1 180 $X=472440 $Y=789780
X1872 2759 2747 2680 2 2722 1 2730 AN4B1S $T=479880 840560 0 180 $X=475540 $Y=835140
X1873 2779 2764 2762 2 2643 1 2751 AN4B1S $T=484220 790160 0 180 $X=479880 $Y=784740
X1874 2820 2804 2806 2 2795 1 2797 AN4B1S $T=491040 820400 0 180 $X=486700 $Y=814980
X1875 2855 2847 373 2 2840 1 2760 AN4B1S $T=496620 860720 0 180 $X=492280 $Y=855300
X1876 2820 2827 2757 2 2851 1 2871 AN4B1S $T=492900 820400 1 0 $X=492900 $Y=814980
X1877 2899 2907 2812 2 2917 1 2935 AN4B1S $T=501580 800240 0 0 $X=501580 $Y=799860
X1878 2914 2922 2902 2 2929 1 2954 AN4B1S $T=503440 830480 1 0 $X=503440 $Y=825060
X1879 2528 2926 2899 2 2934 1 2898 AN4B1S $T=504060 790160 1 0 $X=504060 $Y=784740
X1880 402 2936 2965 2 2956 1 2873 AN4B1S $T=512120 880880 0 180 $X=507780 $Y=875460
X1881 393 270 2974 2 2875 1 3005 AN4B1S $T=509640 870800 0 0 $X=509640 $Y=870420
X1882 2997 2968 2859 2 2885 1 2971 AN4B1S $T=515220 780080 0 180 $X=510880 $Y=774660
X1883 2948 2977 2888 2 2795 1 3011 AN4B1S $T=510880 820400 1 0 $X=510880 $Y=814980
X1884 2948 2963 2927 2 2597 1 2997 AN4B1S $T=511500 790160 1 0 $X=511500 $Y=784740
X1885 2867 2998 2968 2 2921 1 3053 AN4B1S $T=517700 780080 1 0 $X=517700 $Y=774660
X1886 3032 2927 2843 2 3003 1 3012 AN4B1S $T=522040 800240 1 180 $X=517700 $Y=799860
X1887 3034 2876 3008 2 2773 1 3013 AN4B1S $T=522040 850640 0 180 $X=517700 $Y=845220
X1888 3058 3027 2913 2 2885 1 3016 AN4B1S $T=522660 770000 1 180 $X=518320 $Y=769620
X1889 3050 3032 2982 2 2964 1 3040 AN4B1S $T=527000 810320 0 180 $X=522660 $Y=804900
X1890 3100 441 3087 2 3086 1 3077 AN4B1S $T=536920 860720 1 180 $X=532580 $Y=860340
X1891 3108 447 3097 2 3090 1 3089 AN4B1S $T=538780 820400 0 180 $X=534440 $Y=814980
X1892 3130 3122 3120 2 2904 1 2818 AN4B1S $T=543740 860720 0 180 $X=539400 $Y=855300
X1893 3166 422 2926 2 3147 1 3233 AN4B1S $T=552420 790160 0 0 $X=552420 $Y=789780
X1894 3166 2982 3128 2 3188 1 3256 AN4B1S $T=552420 800240 0 0 $X=552420 $Y=799860
X1895 3161 2841 2998 2 3188 1 3203 AN4B1S $T=553040 800240 1 0 $X=553040 $Y=794820
X1896 3189 3190 3202 2 480 1 3196 AN4B1S $T=556140 860720 1 0 $X=556140 $Y=855300
X1897 3226 2490 3210 2 3201 1 3209 AN4B1S $T=562340 810320 1 180 $X=558000 $Y=809940
X1898 3236 3243 3238 2 3185 1 3228 AN4B1S $T=567300 840560 1 180 $X=562960 $Y=840180
X1899 3291 3280 3199 2 3276 1 3164 AN4B1S $T=574120 870800 0 180 $X=569780 $Y=865380
X1900 3307 3267 508 2 3261 1 3279 AN4B1S $T=577220 850640 1 180 $X=572880 $Y=850260
X1901 521 3275 3139 2 3300 1 3260 AN4B1S $T=582800 840560 0 180 $X=578460 $Y=835140
X1902 3320 3287 3171 2 3311 1 3329 AN4B1S $T=580940 820400 0 0 $X=580940 $Y=820020
X1903 4715 4710 835 2 834 1 4703 AN4B1S $T=855600 870800 0 180 $X=851260 $Y=865380
X1904 4795 4792 878 2 4831 1 4829 AN4B1S $T=876680 850640 0 0 $X=876680 $Y=850260
X1905 4872 4847 882 2 4844 1 4822 AN4B1S $T=884740 860720 1 180 $X=880400 $Y=860340
X1906 4946 4932 908 2 907 1 4907 AN4B1S $T=905200 870800 0 180 $X=900860 $Y=865380
X1907 5009 4952 927 2 926 1 4990 AN4B1S $T=916980 850640 1 180 $X=912640 $Y=850260
X1908 5031 5037 5039 2 5043 1 5049 AN4B1S $T=922560 790160 0 0 $X=922560 $Y=789780
X1909 5073 5048 943 2 941 1 5028 AN4B1S $T=927520 870800 0 180 $X=923180 $Y=865380
X1910 5006 5059 5063 2 5069 1 4834 AN4B1S $T=927520 770000 0 0 $X=927520 $Y=769620
X1911 5079 5070 953 2 952 1 951 AN4B1S $T=931860 860720 0 180 $X=927520 $Y=855300
X1912 5054 5086 5093 2 5095 1 5025 AN4B1S $T=934340 729680 0 0 $X=934340 $Y=729300
X1913 5081 5092 5096 2 5097 1 5015 AN4B1S $T=934960 810320 0 0 $X=934960 $Y=809940
X1914 5056 5071 5102 2 5105 1 4911 AN4B1S $T=936820 749840 1 0 $X=936820 $Y=744420
X1915 5055 5108 5115 2 5121 1 5119 AN4B1S $T=941160 749840 1 0 $X=941160 $Y=744420
X1916 5060 5117 5122 2 5125 1 4714 AN4B1S $T=941780 780080 1 0 $X=941780 $Y=774660
X1917 5120 5104 5127 2 5130 1 5024 AN4B1S $T=943020 840560 1 0 $X=943020 $Y=835140
X1918 5020 5089 5145 2 5151 1 4965 AN4B1S $T=947980 800240 0 0 $X=947980 $Y=799860
X1919 5146 5159 977 2 5164 1 4370 AN4B1S $T=952320 870800 1 0 $X=952320 $Y=865380
X1920 5197 5193 5191 2 5187 1 5185 AN4B1S $T=968440 820400 1 180 $X=964100 $Y=820020
X1921 998 993 5207 2 5205 1 5022 AN4B1S $T=973400 709520 0 180 $X=969060 $Y=704100
X1922 5239 5220 5218 2 5216 1 5035 AN4B1S $T=977740 820400 1 180 $X=973400 $Y=820020
X1923 5242 5195 5227 2 5219 1 5000 AN4B1S $T=978980 759920 0 180 $X=974640 $Y=754500
X1924 5494 5459 1044 2 5458 1 5470 AN4B1S $T=1071360 860720 1 180 $X=1067020 $Y=860340
X1925 1105 1132 1097 1147 1157 1164 1 2 1137 OA222 $T=222580 810320 1 0 $X=222580 $Y=804900
X1926 1277 1307 25 28 1287 1238 1 2 1275 OA222 $T=245520 810320 0 180 $X=239940 $Y=804900
X1927 1105 1187 1288 1252 1300 1222 1 2 1309 OA222 $T=239940 820400 1 0 $X=239940 $Y=814980
X1928 1181 1267 1157 1235 1304 1316 1 2 1334 OA222 $T=240560 790160 0 0 $X=240560 $Y=789780
X1929 18 1325 1223 1317 1181 1296 1 2 1283 OA222 $T=248000 719600 0 180 $X=242420 $Y=714180
X1930 1345 1339 1221 1321 1277 1315 1 2 1128 OA222 $T=248620 770000 1 180 $X=243040 $Y=769620
X1931 1345 1343 1239 1327 1157 1297 1 2 1255 OA222 $T=249240 749840 1 180 $X=243660 $Y=749460
X1932 1295 1191 1348 1282 1371 1277 1 2 1385 OA222 $T=248620 810320 1 0 $X=248620 $Y=804900
X1933 1407 1256 1374 1378 1277 1376 1 2 1365 OA222 $T=256680 830480 1 180 $X=251100 $Y=830100
X1934 1205 27 1374 1313 1221 1402 1 2 1422 OA222 $T=252340 850640 1 0 $X=252340 $Y=845220
X1935 56 53 1407 1187 1457 1368 1 2 1442 OA222 $T=267220 840560 0 180 $X=261640 $Y=835140
X1936 18 1473 1221 1461 1181 1455 1 2 1443 OA222 $T=267840 780080 1 180 $X=262260 $Y=779700
X1937 1191 52 1348 1441 46 1187 1 2 1450 OA222 $T=268460 820400 0 180 $X=262880 $Y=814980
X1938 49 61 58 56 43 1263 1 2 1463 OA222 $T=272180 880880 0 180 $X=266600 $Y=875460
X1939 1148 1313 1263 1421 1183 1518 1 2 1538 OA222 $T=270940 840560 1 0 $X=270940 $Y=835140
X1940 61 71 1300 1240 1374 1425 1 2 1112 OA222 $T=277140 860720 1 180 $X=271560 $Y=860340
X1941 1357 1178 1238 1543 28 1557 1 2 1565 OA222 $T=275280 790160 0 0 $X=275280 $Y=789780
X1942 1116 1313 18 1591 33 1579 1 2 1603 OA222 $T=281480 739760 1 0 $X=281480 $Y=734340
X1943 1116 1556 1181 1616 1191 1584 1 2 1629 OA222 $T=285820 729680 0 0 $X=285820 $Y=729300
X1944 1427 1277 71 1419 1105 1199 1 2 1645 OA222 $T=285820 840560 0 0 $X=285820 $Y=840180
X1945 84 1419 1199 1574 18 1581 1 2 1572 OA222 $T=292020 840560 0 180 $X=286440 $Y=835140
X1946 1413 1619 1402 1626 43 1614 1 2 1373 OA222 $T=293880 830480 0 180 $X=288300 $Y=825060
X1947 1205 1198 1191 1624 1238 1646 1 2 1660 OA222 $T=290160 790160 0 0 $X=290160 $Y=789780
X1948 89 61 1304 1648 1357 81 1 2 1621 OA222 $T=296980 850640 0 180 $X=291400 $Y=845220
X1949 1199 1619 56 87 1419 1654 1 2 1663 OA222 $T=291400 870800 1 0 $X=291400 $Y=865380
X1950 1222 1199 84 56 58 1419 1 2 1669 OA222 $T=292020 860720 1 0 $X=292020 $Y=855300
X1951 1157 1696 1357 1176 1277 1667 1 2 1677 OA222 $T=305660 790160 0 180 $X=300080 $Y=784740
X1952 63 56 1457 1659 1357 1262 1 2 1594 OA222 $T=305660 820400 1 180 $X=300080 $Y=820020
X1953 1183 1425 1419 91 28 1520 1 2 1713 OA222 $T=301320 840560 1 0 $X=301320 $Y=835140
X1954 56 66 1457 1585 94 61 1 2 1623 OA222 $T=306900 840560 1 180 $X=301320 $Y=840180
X1955 18 1536 1288 1454 61 91 1 2 1661 OA222 $T=310000 800240 0 180 $X=304420 $Y=794820
X1956 1239 1735 1221 1749 1191 1723 1 2 1772 OA222 $T=314340 790160 1 0 $X=314340 $Y=784740
X1957 1206 1263 1300 1304 71 56 1 2 1720 OA222 $T=321780 840560 1 180 $X=316200 $Y=840180
X1958 1357 1263 1288 1764 61 103 1 2 1270 OA222 $T=323640 790160 1 180 $X=318060 $Y=789780
X1959 1300 43 1502 1766 28 1406 1 2 1756 OA222 $T=323640 810320 0 180 $X=318060 $Y=804900
X1960 33 1782 1238 1768 28 1780 1 2 1155 OA222 $T=327980 739760 0 180 $X=322400 $Y=734340
X1961 1181 1798 1183 1788 1157 1785 1 2 1691 OA222 $T=329840 810320 1 180 $X=324260 $Y=809940
X1962 1427 1277 1357 1263 1371 1457 1 2 1781 OA222 $T=329840 830480 0 180 $X=324260 $Y=825060
X1963 43 1263 1148 1240 1374 1222 1 2 1792 OA222 $T=324260 830480 0 0 $X=324260 $Y=830100
X1964 1277 1702 1191 1802 1457 1726 1 2 1635 OA222 $T=332320 770000 0 180 $X=326740 $Y=764580
X1965 1238 1702 1300 1556 28 1802 1 2 1819 OA222 $T=326740 810320 1 0 $X=326740 $Y=804900
X1966 28 1797 1277 1493 1205 1789 1 2 1830 OA222 $T=327360 790160 0 0 $X=327360 $Y=789780
X1967 61 1795 1288 1799 1295 1791 1 2 1816 OA222 $T=327360 800240 0 0 $X=327360 $Y=799860
X1968 1183 1240 1205 1262 18 74 1 2 1827 OA222 $T=329220 820400 1 0 $X=329220 $Y=814980
X1969 1277 1817 1239 1649 1457 1777 1 2 1805 OA222 $T=335420 749840 1 180 $X=329840 $Y=749460
X1970 1657 1851 1238 1796 18 1835 1 2 1522 OA222 $T=341000 759920 0 180 $X=335420 $Y=754500
X1971 1295 18 1222 1480 85 1181 1 2 1868 OA222 $T=336040 810320 1 0 $X=336040 $Y=804900
X1972 133 1794 1277 1876 1619 1882 1 2 1892 OA222 $T=342240 850640 1 0 $X=342240 $Y=845220
X1973 29 33 1191 1893 1413 1345 1 2 1824 OA222 $T=352160 749840 0 180 $X=346580 $Y=744420
X1974 228 224 2266 205 220 2262 1 2 2243 OA222 $T=414780 860720 1 180 $X=409200 $Y=860340
X1975 2354 247 250 252 255 256 1 2 262 OA222 $T=425320 880880 1 0 $X=425320 $Y=875460
X1976 2422 2440 259 2410 265 2435 1 2 261 OA222 $T=440820 840560 1 180 $X=435240 $Y=840180
X1977 2395 2516 2508 2495 2470 2499 1 2 2490 OA222 $T=448880 810320 1 180 $X=443300 $Y=809940
X1978 2623 2620 2578 2624 2464 287 1 2 2731 OA222 $T=470580 850640 0 0 $X=470580 $Y=850260
X1979 2559 2718 2407 2713 2622 2703 1 2 2686 OA222 $T=476780 840560 1 180 $X=471200 $Y=840180
X1980 2437 2693 2620 2690 2421 2718 1 2 2678 OA222 $T=478020 800240 1 180 $X=472440 $Y=799860
X1981 2620 2675 2724 324 2732 330 1 2 2747 OA222 $T=472440 860720 0 0 $X=472440 $Y=860340
X1982 2724 336 2540 2442 2732 329 1 2 2706 OA222 $T=479880 870800 0 180 $X=474300 $Y=865380
X1983 2481 2677 2784 370 369 366 1 2 2815 OA222 $T=496620 860720 1 180 $X=491040 $Y=860340
X1984 2784 386 2732 389 270 391 1 2 2936 OA222 $T=499720 880880 1 0 $X=499720 $Y=875460
X1985 311 2663 2906 2559 2508 2593 1 2 2927 OA222 $T=500340 840560 0 0 $X=500340 $Y=840180
X1986 2604 2540 397 398 2906 2623 1 2 2985 OA222 $T=507160 860720 1 0 $X=507160 $Y=855300
X1987 2995 2422 2588 2513 2663 319 1 2 2948 OA222 $T=513980 840560 1 180 $X=508400 $Y=840180
X1988 2620 2553 2784 317 2604 3018 1 2 3069 OA222 $T=524520 850640 0 0 $X=524520 $Y=850260
X1989 3075 3010 416 425 2906 2601 1 2 2922 OA222 $T=530720 830480 0 180 $X=525140 $Y=825060
X1990 2912 2690 3127 2684 2578 2758 1 2 3108 OA222 $T=544980 810320 0 180 $X=539400 $Y=804900
X1991 2928 3005 3168 474 2980 476 1 2 3202 OA222 $T=553040 870800 1 0 $X=553040 $Y=865380
X1992 3218 3010 2604 3206 479 274 1 2 3189 OA222 $T=562340 850640 0 180 $X=556760 $Y=845220
X1993 416 348 370 391 395 338 1 2 3208 OA222 $T=566680 870800 0 180 $X=561100 $Y=865380
X1994 2928 321 369 487 270 3168 1 2 3212 OA222 $T=567920 870800 1 180 $X=562340 $Y=870420
X1995 2559 2713 2513 2407 416 494 1 2 3267 OA222 $T=564200 850640 0 0 $X=564200 $Y=850260
X1996 498 274 3168 3215 2559 2513 1 2 3236 OA222 $T=569780 860720 1 180 $X=564200 $Y=860340
X1997 2784 317 358 3292 485 391 1 2 3265 OA222 $T=577220 870800 1 180 $X=571640 $Y=870420
X1998 2906 2354 392 395 416 514 1 2 3280 OA222 $T=573500 860720 0 0 $X=573500 $Y=860340
X1999 348 369 2928 317 380 391 1 2 3291 OA222 $T=584040 870800 0 180 $X=578460 $Y=865380
X2000 3283 3357 3355 3349 3344 3336 1 2 3235 OA222 $T=585280 770000 0 180 $X=579700 $Y=764580
X2001 301 3346 395 3374 528 406 1 2 3270 OA222 $T=593340 850640 1 180 $X=587760 $Y=850260
X2002 3365 3358 3392 3350 3314 3337 1 2 3255 OA222 $T=593960 729680 1 180 $X=588380 $Y=729300
X2003 3341 3358 3382 3350 3332 3337 1 2 3245 OA222 $T=600160 759920 1 180 $X=594580 $Y=759540
X2004 1103 2 1110 1130 1 NR2 $T=221340 780080 0 0 $X=221340 $Y=779700
X2005 1108 2 1097 1117 1 NR2 $T=221340 830480 0 0 $X=221340 $Y=830100
X2006 1102 2 1095 1136 1 NR2 $T=221960 759920 0 0 $X=221960 $Y=759540
X2007 1150 2 1132 1109 1 NR2 $T=223820 810320 1 180 $X=221960 $Y=809940
X2008 1096 2 1104 1126 1 NR2 $T=221960 870800 1 0 $X=221960 $Y=865380
X2009 1152 2 1120 1107 1 NR2 $T=224440 729680 0 180 $X=222580 $Y=724260
X2010 1149 2 1139 1108 1 NR2 $T=225680 880880 0 180 $X=223820 $Y=875460
X2011 1201 2 1169 1150 1 NR2 $T=227540 810320 1 180 $X=225680 $Y=809940
X2012 1182 2 1172 1123 1 NR2 $T=229400 739760 1 180 $X=227540 $Y=739380
X2013 1195 2 1164 1175 1 NR2 $T=230020 770000 0 180 $X=228160 $Y=764580
X2014 26 2 1285 1175 1 NR2 $T=231260 739760 0 180 $X=229400 $Y=734340
X2015 1189 2 1226 1213 1 NR2 $T=231260 800240 1 0 $X=231260 $Y=794820
X2016 16 2 1210 1224 1 NR2 $T=231880 770000 1 0 $X=231880 $Y=764580
X2017 1171 2 1230 1237 1 NR2 $T=231880 830480 1 0 $X=231880 $Y=825060
X2018 1201 2 1212 1231 1 NR2 $T=232500 860720 1 0 $X=232500 $Y=855300
X2019 1243 2 1235 1182 1 NR2 $T=235600 759920 0 180 $X=233740 $Y=754500
X2020 1190 2 1252 1243 1 NR2 $T=233740 770000 0 0 $X=233740 $Y=769620
X2021 21 2 1187 1201 1 NR2 $T=235600 840560 1 180 $X=233740 $Y=840180
X2022 1190 2 1234 1225 1 NR2 $T=234360 780080 1 0 $X=234360 $Y=774660
X2023 1170 2 1197 21 1 NR2 $T=234360 850640 1 0 $X=234360 $Y=845220
X2024 1264 2 1147 6 1 NR2 $T=237460 870800 1 180 $X=235600 $Y=870420
X2025 1145 2 1267 1253 1 NR2 $T=236220 759920 0 0 $X=236220 $Y=759540
X2026 1237 2 1298 21 1 NR2 $T=238080 830480 1 0 $X=238080 $Y=825060
X2027 1264 2 1262 1248 1 NR2 $T=238700 860720 0 0 $X=238700 $Y=860340
X2028 6 2 30 21 1 NR2 $T=240560 880880 1 0 $X=240560 $Y=875460
X2029 1170 2 1282 1167 1 NR2 $T=242420 870800 1 0 $X=242420 $Y=865380
X2030 36 2 1296 1303 1 NR2 $T=245520 709520 0 180 $X=243660 $Y=704100
X2031 1326 2 1219 1306 1 NR2 $T=245520 780080 0 180 $X=243660 $Y=774660
X2032 1167 2 1316 35 1 NR2 $T=245520 800240 0 0 $X=245520 $Y=799860
X2033 1149 2 1341 3 1 NR2 $T=246760 870800 0 0 $X=246760 $Y=870420
X2034 1190 2 1383 1379 1 NR2 $T=251720 719600 0 0 $X=251720 $Y=719220
X2035 1390 2 1356 1375 1 NR2 $T=254200 749840 1 180 $X=252340 $Y=749460
X2036 1108 2 1378 1158 1 NR2 $T=252340 840560 0 0 $X=252340 $Y=840180
X2037 1396 2 1376 1190 1 NR2 $T=255440 790160 1 180 $X=253580 $Y=789780
X2038 1389 2 1353 1337 1 NR2 $T=254820 759920 1 0 $X=254820 $Y=754500
X2039 1411 2 39 1390 1 NR2 $T=257300 719600 1 180 $X=255440 $Y=719220
X2040 1311 2 1405 1190 1 NR2 $T=258540 780080 0 180 $X=256680 $Y=774660
X2041 1431 2 1203 40 1 NR2 $T=258540 880880 0 180 $X=256680 $Y=875460
X2042 1158 2 1421 3 1 NR2 $T=257920 840560 0 0 $X=257920 $Y=840180
X2043 1429 2 1229 1358 1 NR2 $T=260400 759920 0 180 $X=258540 $Y=754500
X2044 1326 2 1433 45 1 NR2 $T=259160 719600 0 0 $X=259160 $Y=719220
X2045 1346 2 1274 1396 1 NR2 $T=259780 770000 0 0 $X=259780 $Y=769620
X2046 1362 2 1377 1411 1 NR2 $T=261020 780080 1 0 $X=261020 $Y=774660
X2047 1109 2 1441 1141 1 NR2 $T=262880 820400 0 180 $X=261020 $Y=814980
X2048 1431 2 46 14 1 NR2 $T=261020 880880 1 0 $X=261020 $Y=875460
X2049 48 2 1416 1311 1 NR2 $T=263500 729680 1 180 $X=261640 $Y=729300
X2050 1389 2 1444 1358 1 NR2 $T=261640 759920 1 0 $X=261640 $Y=754500
X2051 1432 2 1465 1330 1 NR2 $T=261640 850640 1 0 $X=261640 $Y=845220
X2052 1311 2 1473 55 1 NR2 $T=264120 759920 0 0 $X=264120 $Y=759540
X2053 1488 2 1462 1479 1 NR2 $T=269080 709520 0 180 $X=267220 $Y=704100
X2054 1190 2 1467 1501 1 NR2 $T=269700 749840 0 0 $X=269700 $Y=749460
X2055 1117 2 1518 1149 1 NR2 $T=269700 830480 0 0 $X=269700 $Y=830100
X2056 1419 2 1392 66 1 NR2 $T=270940 850640 0 0 $X=270940 $Y=850260
X2057 1145 2 1513 1439 1 NR2 $T=273420 709520 0 180 $X=271560 $Y=704100
X2058 1483 2 68 1389 1 NR2 $T=272180 699440 0 0 $X=272180 $Y=699060
X2059 1163 2 1516 1190 1 NR2 $T=273420 780080 1 0 $X=273420 $Y=774660
X2060 1117 2 1524 1381 1 NR2 $T=275280 830480 1 180 $X=273420 $Y=830100
X2061 1483 2 1217 73 1 NR2 $T=276520 699440 0 0 $X=276520 $Y=699060
X2062 1550 2 1241 1527 1 NR2 $T=278380 719600 0 180 $X=276520 $Y=714180
X2063 1117 2 1556 1158 1 NR2 $T=276520 820400 0 0 $X=276520 $Y=820020
X2064 1402 2 1555 1524 1 NR2 $T=278380 830480 0 180 $X=276520 $Y=825060
X2065 1495 2 1531 1389 1 NR2 $T=278380 759920 1 0 $X=278380 $Y=754500
X2066 1488 2 1426 1389 1 NR2 $T=280240 699440 0 0 $X=280240 $Y=699060
X2067 1411 2 52 1586 1 NR2 $T=280240 719600 1 0 $X=280240 $Y=714180
X2068 76 2 1581 1411 1 NR2 $T=280240 790160 1 0 $X=280240 $Y=784740
X2069 1577 2 1352 1264 1 NR2 $T=282100 860720 0 180 $X=280240 $Y=855300
X2070 48 2 1349 1586 1 NR2 $T=281480 739760 0 0 $X=281480 $Y=739380
X2071 1253 2 1368 1337 1 NR2 $T=281480 840560 1 0 $X=281480 $Y=835140
X2072 40 2 1574 1290 1 NR2 $T=281480 840560 0 0 $X=281480 $Y=840180
X2073 1479 2 1578 1495 1 NR2 $T=282100 709520 1 0 $X=282100 $Y=704100
X2074 1586 2 1573 1396 1 NR2 $T=283960 770000 0 180 $X=282100 $Y=764580
X2075 1290 2 1609 1108 1 NR2 $T=283960 870800 0 0 $X=283960 $Y=870420
X2076 1200 2 1561 1486 1 NR2 $T=286440 759920 1 0 $X=286440 $Y=754500
X2077 1149 2 1626 1158 1 NR2 $T=288300 820400 1 180 $X=286440 $Y=820020
X2078 82 2 1591 1439 1 NR2 $T=290160 719600 0 180 $X=288300 $Y=714180
X2079 35 2 81 1150 1 NR2 $T=288300 870800 0 0 $X=288300 $Y=870420
X2080 1634 2 1321 35 1 NR2 $T=290780 860720 1 180 $X=288920 $Y=860340
X2081 1163 2 1258 82 1 NR2 $T=290160 699440 0 0 $X=290160 $Y=699060
X2082 73 2 1624 1379 1 NR2 $T=290160 709520 1 0 $X=290160 $Y=704100
X2083 1145 2 1618 1358 1 NR2 $T=290160 759920 1 0 $X=290160 $Y=754500
X2084 1390 2 1628 1389 1 NR2 $T=290780 729680 1 0 $X=290780 $Y=724260
X2085 1637 2 1579 76 1 NR2 $T=293260 739760 1 0 $X=293260 $Y=734340
X2086 1358 2 1585 1243 1 NR2 $T=293880 770000 1 0 $X=293880 $Y=764580
X2087 1664 2 1487 1389 1 NR2 $T=296980 709520 1 180 $X=295120 $Y=709140
X2088 1201 2 1648 1264 1 NR2 $T=295740 860720 0 0 $X=295740 $Y=860340
X2089 90 2 1649 1389 1 NR2 $T=298220 699440 1 180 $X=296360 $Y=699060
X2090 1411 2 1186 90 1 NR2 $T=296360 739760 1 0 $X=296360 $Y=734340
X2091 35 2 1647 1264 1 NR2 $T=298840 830480 0 180 $X=296980 $Y=825060
X2092 1201 2 1614 1167 1 NR2 $T=296980 850640 1 0 $X=296980 $Y=845220
X2093 1411 2 1646 1688 1 NR2 $T=298840 780080 0 0 $X=298840 $Y=779700
X2094 1346 2 1679 1190 1 NR2 $T=301940 770000 1 180 $X=300080 $Y=769620
X2095 1264 2 1198 1150 1 NR2 $T=300700 830480 1 0 $X=300700 $Y=825060
X2096 1674 2 1676 1694 1 NR2 $T=300700 850640 0 0 $X=300700 $Y=850260
X2097 1190 2 1665 1337 1 NR2 $T=301320 759920 1 0 $X=301320 $Y=754500
X2098 1346 2 1280 1688 1 NR2 $T=301940 759920 0 0 $X=301940 $Y=759540
X2099 76 2 1452 1699 1 NR2 $T=302560 709520 1 0 $X=302560 $Y=704100
X2100 1700 2 1514 1688 1 NR2 $T=304420 749840 1 180 $X=302560 $Y=749460
X2101 1699 2 1520 1190 1 NR2 $T=305040 719600 0 180 $X=303180 $Y=714180
X2102 1700 2 1209 1486 1 NR2 $T=305040 770000 1 180 $X=303180 $Y=769620
X2103 1429 2 1683 1700 1 NR2 $T=307520 749840 1 0 $X=307520 $Y=744420
X2104 1586 2 1723 1488 1 NR2 $T=311240 729680 0 180 $X=309380 $Y=724260
X2105 1346 2 1735 1243 1 NR2 $T=310000 770000 0 0 $X=310000 $Y=769620
X2106 1396 2 1659 1738 1 NR2 $T=311240 780080 0 0 $X=311240 $Y=779700
X2107 1740 2 1264 101 1 NR2 $T=313720 870800 1 180 $X=311860 $Y=870420
X2108 1611 2 1307 1486 1 NR2 $T=312480 820400 1 0 $X=312480 $Y=814980
X2109 1375 2 1715 1253 1 NR2 $T=313100 780080 1 0 $X=313100 $Y=774660
X2110 1740 2 1150 104 1 NR2 $T=313100 870800 1 0 $X=313100 $Y=865380
X2111 1311 2 1702 1337 1 NR2 $T=313720 770000 0 0 $X=313720 $Y=769620
X2112 1243 2 1730 1738 1 NR2 $T=313720 830480 0 0 $X=313720 $Y=830100
X2113 1248 2 1749 21 1 NR2 $T=316820 830480 0 180 $X=314960 $Y=825060
X2114 1619 2 1566 1762 1 NR2 $T=316200 860720 0 0 $X=316200 $Y=860340
X2115 1311 2 1733 1738 1 NR2 $T=316820 780080 1 0 $X=316820 $Y=774660
X2116 45 2 1747 1586 1 NR2 $T=319300 719600 1 180 $X=317440 $Y=719220
X2117 1688 2 1726 1396 1 NR2 $T=318680 759920 0 0 $X=318680 $Y=759540
X2118 1337 2 1764 1396 1 NR2 $T=319300 759920 1 0 $X=319300 $Y=754500
X2119 1435 2 1724 1762 1 NR2 $T=319920 860720 0 0 $X=319920 $Y=860340
X2120 1107 2 1766 1404 1 NR2 $T=321160 770000 0 0 $X=321160 $Y=769620
X2121 1167 2 1480 1248 1 NR2 $T=322400 820400 0 0 $X=322400 $Y=820020
X2122 1486 2 1454 1738 1 NR2 $T=324260 800240 1 0 $X=324260 $Y=794820
X2123 1153 2 1791 1404 1 NR2 $T=325500 770000 0 0 $X=325500 $Y=769620
X2124 6 2 1789 1167 1 NR2 $T=327980 820400 1 180 $X=326120 $Y=820020
X2125 118 2 1248 1740 1 NR2 $T=328600 860720 1 180 $X=326740 $Y=860340
X2126 90 2 1567 1390 1 NR2 $T=327980 739760 0 0 $X=327980 $Y=739380
X2127 1738 2 1785 1586 1 NR2 $T=327980 780080 1 0 $X=327980 $Y=774660
X2128 1740 2 1201 1809 1 NR2 $T=328600 870800 1 0 $X=328600 $Y=865380
X2129 1586 2 1802 1320 1 NR2 $T=330460 739760 1 0 $X=330460 $Y=734340
X2130 1740 2 35 1837 1 NR2 $T=332320 860720 1 0 $X=332320 $Y=855300
X2131 1836 2 1788 14 1 NR2 $T=334800 830480 1 180 $X=332940 $Y=830100
X2132 1823 2 1793 1831 1 NR2 $T=334800 870800 1 0 $X=334800 $Y=865380
X2133 1451 2 128 1775 1 NR2 $T=336040 880880 1 0 $X=336040 $Y=875460
X2134 1375 2 1858 1850 1 NR2 $T=337900 749840 0 0 $X=337900 $Y=749460
X2135 132 2 1852 1762 1 NR2 $T=340380 850640 0 0 $X=340380 $Y=850260
X2136 1850 2 1370 1664 1 NR2 $T=341620 729680 0 0 $X=341620 $Y=729300
X2137 114 2 102 133 1 NR2 $T=342240 880880 1 0 $X=342240 $Y=875460
X2138 1837 2 1839 1762 1 NR2 $T=344720 840560 0 180 $X=342860 $Y=835140
X2139 117 2 50 1762 1 NR2 $T=344720 870800 0 180 $X=342860 $Y=865380
X2140 1369 2 1851 1332 1 NR2 $T=343480 770000 0 0 $X=343480 $Y=769620
X2141 1346 2 1796 1486 1 NR2 $T=345960 759920 0 180 $X=344100 $Y=754500
X2142 1809 2 1879 1762 1 NR2 $T=344720 790160 0 0 $X=344720 $Y=789780
X2143 136 2 1857 138 1 NR2 $T=345960 709520 1 0 $X=345960 $Y=704100
X2144 1381 2 1871 1836 1 NR2 $T=348440 840560 0 180 $X=346580 $Y=835140
X2145 1346 2 1888 90 1 NR2 $T=347200 759920 1 0 $X=347200 $Y=754500
X2146 1806 2 1898 141 1 NR2 $T=348440 850640 0 0 $X=348440 $Y=850260
X2147 139 2 1909 1915 1 NR2 $T=350920 729680 0 0 $X=350920 $Y=729300
X2148 1920 2 1806 1911 1 NR2 $T=353400 850640 1 180 $X=351540 $Y=850260
X2149 99 2 1896 1968 1 NR2 $T=351540 870800 0 0 $X=351540 $Y=870420
X2150 1930 2 1941 1915 1 NR2 $T=355260 749840 0 180 $X=353400 $Y=744420
X2151 1908 2 1948 1939 1 NR2 $T=354640 860720 1 0 $X=354640 $Y=855300
X2152 1843 2 1928 1762 1 NR2 $T=357120 860720 1 180 $X=355260 $Y=860340
X2153 109 2 1700 1762 1 NR2 $T=357740 850640 0 180 $X=355880 $Y=845220
X2154 1954 2 1937 1919 1 NR2 $T=358360 800240 1 180 $X=356500 $Y=799860
X2155 139 2 1967 1942 1 NR2 $T=359600 739760 0 180 $X=357740 $Y=734340
X2156 1950 2 1885 1959 1 NR2 $T=362700 830480 0 180 $X=360840 $Y=825060
X2157 1980 2 1963 1989 1 NR2 $T=363320 790160 1 0 $X=363320 $Y=784740
X2158 1950 2 1884 147 1 NR2 $T=363320 820400 1 0 $X=363320 $Y=814980
X2159 1911 2 1986 1989 1 NR2 $T=364560 810320 1 0 $X=364560 $Y=804900
X2160 2002 2 1790 1891 1 NR2 $T=366420 840560 1 0 $X=366420 $Y=835140
X2161 1920 2 1451 1979 1 NR2 $T=366420 860720 1 0 $X=366420 $Y=855300
X2162 139 2 2008 1993 1 NR2 $T=368900 729680 0 180 $X=367040 $Y=724260
X2163 1891 2 1929 159 1 NR2 $T=367040 840560 0 0 $X=367040 $Y=840180
X2164 1980 2 1938 1974 1 NR2 $T=369520 860720 1 180 $X=367660 $Y=860340
X2165 139 2 2016 1983 1 NR2 $T=368280 719600 0 0 $X=368280 $Y=719220
X2166 2019 2 1786 2014 1 NR2 $T=371380 850640 0 180 $X=369520 $Y=845220
X2167 2010 2 2012 117 1 NR2 $T=372000 790160 1 180 $X=370140 $Y=789780
X2168 2007 2 1881 1891 1 NR2 $T=370140 840560 1 0 $X=370140 $Y=835140
X2169 159 2 1955 170 1 NR2 $T=371380 820400 0 0 $X=371380 $Y=820020
X2170 2022 2 1803 167 1 NR2 $T=371380 840560 0 0 $X=371380 $Y=840180
X2171 1875 2 2006 1920 1 NR2 $T=372620 790160 1 0 $X=372620 $Y=784740
X2172 2022 2 1820 2019 1 NR2 $T=373240 850640 1 0 $X=373240 $Y=845220
X2173 2022 2 1996 2007 1 NR2 $T=374480 840560 1 0 $X=374480 $Y=835140
X2174 2057 2 1962 2045 1 NR2 $T=376960 860720 1 180 $X=375100 $Y=860340
X2175 133 2 1907 1762 1 NR2 $T=375720 810320 1 0 $X=375720 $Y=804900
X2176 2070 2 174 172 1 NR2 $T=378820 880880 0 180 $X=376960 $Y=875460
X2177 2057 2 1971 1762 1 NR2 $T=381920 790160 0 0 $X=381920 $Y=789780
X2178 1762 2 1951 1974 1 NR2 $T=385020 800240 0 0 $X=385020 $Y=799860
X2179 167 2 1848 2014 1 NR2 $T=389980 840560 1 0 $X=389980 $Y=835140
X2180 1911 2 2158 2007 1 NR2 $T=394320 820400 0 180 $X=392460 $Y=814980
X2181 189 2 184 195 1 NR2 $T=393700 880880 1 0 $X=393700 $Y=875460
X2182 167 2 2077 170 1 NR2 $T=396180 830480 1 180 $X=394320 $Y=830100
X2183 198 2 179 195 1 NR2 $T=399280 870800 1 180 $X=397420 $Y=870420
X2184 198 2 170 2205 1 NR2 $T=400520 850640 1 0 $X=400520 $Y=845220
X2185 189 2 2014 2205 1 NR2 $T=401760 840560 1 0 $X=401760 $Y=835140
X2186 193 2 2236 2219 1 NR2 $T=406720 719600 1 180 $X=404860 $Y=719220
X2187 211 2 2238 2241 1 NR2 $T=405480 850640 1 0 $X=405480 $Y=845220
X2188 2234 2 2222 2215 1 NR2 $T=406100 780080 0 0 $X=406100 $Y=779700
X2189 218 2 2235 2243 1 NR2 $T=409820 860720 0 180 $X=407960 $Y=855300
X2190 193 2 2289 2128 1 NR2 $T=412300 729680 0 180 $X=410440 $Y=724260
X2191 193 2 2274 2206 1 NR2 $T=414160 719600 0 180 $X=412300 $Y=714180
X2192 193 2 2280 2224 1 NR2 $T=413540 719600 0 0 $X=413540 $Y=719220
X2193 2194 2 2284 2282 1 NR2 $T=416020 830480 1 180 $X=414160 $Y=830100
X2194 2301 2 2311 2194 1 NR2 $T=417880 840560 0 180 $X=416020 $Y=835140
X2195 2301 2 2324 159 1 NR2 $T=418500 830480 1 0 $X=418500 $Y=825060
X2196 2247 2 2310 2301 1 NR2 $T=420360 830480 1 180 $X=418500 $Y=830100
X2197 224 2 2302 236 1 NR2 $T=418500 870800 0 0 $X=418500 $Y=870420
X2198 159 2 2329 2282 1 NR2 $T=420360 820400 1 0 $X=420360 $Y=814980
X2199 220 2 232 223 1 NR2 $T=420360 870800 1 0 $X=420360 $Y=865380
X2200 240 2 2343 223 1 NR2 $T=423460 860720 1 180 $X=421600 $Y=860340
X2201 224 2 2342 2014 1 NR2 $T=422220 870800 0 0 $X=422220 $Y=870420
X2202 2247 2 2357 2282 1 NR2 $T=422840 830480 0 0 $X=422840 $Y=830100
X2203 2014 2 2328 216 1 NR2 $T=422840 840560 1 0 $X=422840 $Y=835140
X2204 236 2 2367 216 1 NR2 $T=426560 840560 0 0 $X=426560 $Y=840180
X2205 241 2 2392 2401 1 NR2 $T=427800 860720 1 0 $X=427800 $Y=855300
X2206 2403 2 2417 2418 1 NR2 $T=434000 820400 1 0 $X=434000 $Y=814980
X2207 2439 2 2410 2418 1 NR2 $T=435860 830480 0 180 $X=434000 $Y=825060
X2208 2358 2 266 221 1 NR2 $T=434620 870800 0 0 $X=434620 $Y=870420
X2209 2457 2 2435 2413 1 NR2 $T=438960 820400 1 180 $X=437100 $Y=820020
X2210 220 2 2454 249 1 NR2 $T=438340 880880 1 0 $X=438340 $Y=875460
X2211 2488 2 2466 2455 1 NR2 $T=440820 820400 0 180 $X=438960 $Y=814980
X2212 2413 2 2473 2496 1 NR2 $T=440820 820400 0 0 $X=440820 $Y=820020
X2213 2457 2 2495 2505 1 NR2 $T=443920 810320 1 0 $X=443920 $Y=804900
X2214 2455 2 2499 2496 1 NR2 $T=444540 820400 1 0 $X=444540 $Y=814980
X2215 2423 2 2518 2481 1 NR2 $T=445160 860720 1 0 $X=445160 $Y=855300
X2216 221 2 279 274 1 NR2 $T=447640 880880 1 0 $X=447640 $Y=875460
X2217 2099 2 2533 2519 1 NR2 $T=448260 709520 1 0 $X=448260 $Y=704100
X2218 2532 2 2516 2529 1 NR2 $T=450120 810320 0 180 $X=448260 $Y=804900
X2219 2540 2 2529 259 1 NR2 $T=450120 840560 1 180 $X=448260 $Y=840180
X2220 2542 2 2498 2531 1 NR2 $T=451360 729680 1 180 $X=449500 $Y=729300
X2221 2540 2 2532 265 1 NR2 $T=451360 850640 0 180 $X=449500 $Y=845220
X2222 2529 2 2552 2569 1 NR2 $T=451360 800240 1 0 $X=451360 $Y=794820
X2223 2540 2 2543 251 1 NR2 $T=453840 840560 1 180 $X=451980 $Y=840180
X2224 2439 2 2449 2530 1 NR2 $T=452600 830480 1 0 $X=452600 $Y=825060
X2225 2540 2 2563 228 1 NR2 $T=454460 850640 0 180 $X=452600 $Y=845220
X2226 2543 2 2566 2532 1 NR2 $T=454460 800240 0 0 $X=454460 $Y=799860
X2227 2567 2 295 293 1 NR2 $T=455700 880880 1 0 $X=455700 $Y=875460
X2228 291 2 2591 2531 1 NR2 $T=458800 729680 1 180 $X=456940 $Y=729300
X2229 2543 2 2583 2592 1 NR2 $T=457560 800240 0 0 $X=457560 $Y=799860
X2230 292 2 2582 138 1 NR2 $T=460040 699440 1 180 $X=458180 $Y=699060
X2231 2505 2 2601 2458 1 NR2 $T=460660 830480 0 180 $X=458800 $Y=825060
X2232 2540 2 2619 280 1 NR2 $T=461280 840560 1 180 $X=459420 $Y=840180
X2233 2549 2 2610 291 1 NR2 $T=460040 729680 1 0 $X=460040 $Y=724260
X2234 2532 2 2636 2561 1 NR2 $T=463140 800240 1 180 $X=461280 $Y=799860
X2235 2609 2 2631 2576 1 NR2 $T=463140 810320 0 0 $X=463140 $Y=809940
X2236 296 2 2699 2605 1 NR2 $T=467480 739760 0 180 $X=465620 $Y=734340
X2237 2543 2 2662 2649 1 NR2 $T=466240 830480 1 0 $X=466240 $Y=825060
X2238 2540 2 2649 245 1 NR2 $T=468100 860720 0 180 $X=466240 $Y=855300
X2239 2529 2 2677 2649 1 NR2 $T=466860 840560 0 0 $X=466860 $Y=840180
X2240 2670 2 2595 2681 1 NR2 $T=468100 810320 1 0 $X=468100 $Y=804900
X2241 2512 2 2675 2638 1 NR2 $T=468100 830480 1 0 $X=468100 $Y=825060
X2242 2540 2 2676 2358 1 NR2 $T=468100 850640 1 0 $X=468100 $Y=845220
X2243 296 2 2691 2637 1 NR2 $T=473060 729680 1 180 $X=471200 $Y=729300
X2244 2543 2 2703 2563 1 NR2 $T=471200 840560 1 0 $X=471200 $Y=835140
X2245 296 2 2710 2594 1 NR2 $T=474920 729680 0 180 $X=473060 $Y=724260
X2246 2529 2 2693 2563 1 NR2 $T=473060 800240 1 0 $X=473060 $Y=794820
X2247 327 2 2737 2738 1 NR2 $T=474920 810320 1 0 $X=474920 $Y=804900
X2248 296 2 2753 2726 1 NR2 $T=479260 719600 1 180 $X=477400 $Y=719220
X2249 2532 2 2713 2676 1 NR2 $T=479880 840560 0 0 $X=479880 $Y=840180
X2250 2512 2 2758 2670 1 NR2 $T=480500 830480 1 0 $X=480500 $Y=825060
X2251 2752 2 2767 2772 1 NR2 $T=482360 810320 1 0 $X=482360 $Y=804900
X2252 278 2 345 274 1 NR2 $T=484840 880880 0 180 $X=482980 $Y=875460
X2253 2702 2 2771 2681 1 NR2 $T=485460 800240 0 180 $X=483600 $Y=794820
X2254 2735 2 2787 2736 1 NR2 $T=487320 739760 1 180 $X=485460 $Y=739380
X2255 2561 2 2756 2782 1 NR2 $T=488560 790160 1 180 $X=486700 $Y=789780
X2256 345 2 2801 347 1 NR2 $T=488560 840560 1 0 $X=488560 $Y=835140
X2257 2488 2 2864 2534 1 NR2 $T=496620 830480 0 0 $X=496620 $Y=830100
X2258 2878 2 2870 2618 1 NR2 $T=499100 810320 0 180 $X=497240 $Y=804900
X2259 2488 2 2884 2398 1 NR2 $T=502200 830480 1 180 $X=500340 $Y=830100
X2260 2901 2 2624 2457 1 NR2 $T=504060 820400 0 180 $X=502200 $Y=814980
X2261 2979 2 2946 2988 1 NR2 $T=512120 810320 0 0 $X=512120 $Y=809940
X2262 2942 2 3008 2994 1 NR2 $T=513980 850640 1 0 $X=513980 $Y=845220
X2263 408 2 2974 409 1 NR2 $T=515840 880880 1 0 $X=515840 $Y=875460
X2264 2561 2 3037 2529 1 NR2 $T=518320 790160 1 0 $X=518320 $Y=784740
X2265 299 2 411 274 1 NR2 $T=519560 880880 1 0 $X=519560 $Y=875460
X2266 311 2 418 274 1 NR2 $T=523900 870800 0 0 $X=523900 $Y=870420
X2267 427 2 3070 2205 1 NR2 $T=529480 770000 1 0 $X=529480 $Y=764580
X2268 3071 2 2684 2563 1 NR2 $T=531340 790160 1 180 $X=529480 $Y=789780
X2269 289 2 2839 274 1 NR2 $T=529480 870800 0 0 $X=529480 $Y=870420
X2270 2488 2 3075 3072 1 NR2 $T=530100 820400 0 0 $X=530100 $Y=820020
X2271 3073 2 3018 3084 1 NR2 $T=532580 820400 1 0 $X=532580 $Y=814980
X2272 401 2 3080 440 1 NR2 $T=533200 870800 0 0 $X=533200 $Y=870420
X2273 2505 2 2690 3072 1 NR2 $T=538780 800240 1 180 $X=536920 $Y=799860
X2274 2782 2 2672 2676 1 NR2 $T=540640 800240 0 0 $X=540640 $Y=799860
X2275 2439 2 3105 3129 1 NR2 $T=540640 830480 1 0 $X=540640 $Y=825060
X2276 310 2 3131 274 1 NR2 $T=543120 880880 1 0 $X=543120 $Y=875460
X2277 2809 2 3127 2418 1 NR2 $T=546220 800240 1 180 $X=544360 $Y=799860
X2278 2702 2 3135 2455 1 NR2 $T=546220 820400 0 180 $X=544360 $Y=814980
X2279 359 2 3076 413 1 NR2 $T=546840 880880 1 0 $X=546840 $Y=875460
X2280 2457 2 2903 2702 1 NR2 $T=549320 830480 0 180 $X=547460 $Y=825060
X2281 2457 2 3167 2809 1 NR2 $T=548700 810320 1 0 $X=548700 $Y=804900
X2282 3138 2 2947 3174 1 NR2 $T=549940 840560 1 0 $X=549940 $Y=835140
X2283 359 2 399 469 1 NR2 $T=550560 880880 1 0 $X=550560 $Y=875460
X2284 473 2 3172 443 1 NR2 $T=554280 880880 1 0 $X=554280 $Y=875460
X2285 483 2 3214 3179 1 NR2 $T=558000 860720 1 180 $X=556140 $Y=860340
X2286 2901 2 3218 2809 1 NR2 $T=559860 840560 0 180 $X=558000 $Y=835140
X2287 477 2 3215 440 1 NR2 $T=558000 880880 1 0 $X=558000 $Y=875460
X2288 2561 2 2718 2676 1 NR2 $T=561720 800240 0 180 $X=559860 $Y=794820
X2289 2488 2 3205 2530 1 NR2 $T=562960 820400 1 0 $X=562960 $Y=814980
X2290 2561 2 3010 2619 1 NR2 $T=563580 810320 1 0 $X=563580 $Y=804900
X2291 3253 2 3241 3234 1 NR2 $T=566680 759920 0 180 $X=564820 $Y=754500
X2292 489 2 3242 3181 1 NR2 $T=564820 810320 0 0 $X=564820 $Y=809940
X2293 469 2 3249 3082 1 NR2 $T=567920 880880 0 180 $X=566060 $Y=875460
X2294 3251 2 3252 3229 1 NR2 $T=568540 739760 1 180 $X=566680 $Y=739380
X2295 504 2 3263 3085 1 NR2 $T=571020 840560 0 180 $X=569160 $Y=835140
X2296 3282 2 3281 3301 1 NR2 $T=572260 739760 1 0 $X=572260 $Y=734340
X2297 3269 2 3309 3294 1 NR2 $T=574740 759920 0 0 $X=574740 $Y=759540
X2298 3306 2 3302 3288 1 NR2 $T=577220 770000 1 180 $X=575360 $Y=769620
X2299 3315 2 3310 3289 1 NR2 $T=577220 780080 1 180 $X=575360 $Y=779700
X2300 3299 2 3303 3323 1 NR2 $T=576600 729680 0 0 $X=576600 $Y=729300
X2301 3057 2 3325 3380 1 NR2 $T=586520 830480 0 0 $X=586520 $Y=830100
X2302 413 2 3374 3186 1 NR2 $T=589620 840560 1 180 $X=587760 $Y=840180
X2303 459 2 3370 469 1 NR2 $T=590240 870800 1 180 $X=588380 $Y=870420
X2304 3375 2 3377 3379 1 NR2 $T=589000 780080 0 0 $X=589000 $Y=779700
X2305 3356 2 3334 3391 1 NR2 $T=590240 749840 1 0 $X=590240 $Y=744420
X2306 356 2 494 357 1 NR2 $T=592100 870800 0 0 $X=592100 $Y=870420
X2307 3408 2 3405 3420 1 NR2 $T=596440 749840 0 0 $X=596440 $Y=749460
X2308 3426 2 3422 3433 1 NR2 $T=598920 770000 0 0 $X=598920 $Y=769620
X2309 3429 2 3416 3417 1 NR2 $T=600780 840560 0 180 $X=598920 $Y=835140
X2310 3437 2 3453 3436 1 NR2 $T=602020 780080 0 0 $X=602020 $Y=779700
X2311 3406 2 3448 3454 1 NR2 $T=603880 749840 1 0 $X=603880 $Y=744420
X2312 3462 2 3478 3464 1 NR2 $T=608840 749840 1 0 $X=608840 $Y=744420
X2313 3466 2 3460 3411 1 NR2 $T=612560 840560 1 0 $X=612560 $Y=835140
X2314 3465 2 3513 3485 1 NR2 $T=613180 729680 0 0 $X=613180 $Y=729300
X2315 3463 2 3488 3429 1 NR2 $T=615040 820400 0 0 $X=615040 $Y=820020
X2316 3474 2 3516 3498 1 NR2 $T=617520 759920 0 0 $X=617520 $Y=759540
X2317 3472 2 3503 3481 1 NR2 $T=617520 780080 1 0 $X=617520 $Y=774660
X2318 3494 2 3509 3486 1 NR2 $T=620620 739760 0 0 $X=620620 $Y=739380
X2319 3522 2 3533 3530 1 NR2 $T=626200 749840 1 0 $X=626200 $Y=744420
X2320 3497 2 3551 3429 1 NR2 $T=628060 810320 1 180 $X=626200 $Y=809940
X2321 3544 2 3587 3578 1 NR2 $T=633640 780080 0 0 $X=633640 $Y=779700
X2322 3447 2 559 3557 1 NR2 $T=634880 840560 1 0 $X=634880 $Y=835140
X2323 3569 2 3608 3604 1 NR2 $T=639220 759920 1 0 $X=639220 $Y=754500
X2324 3634 2 3582 3584 1 NR2 $T=642320 770000 0 180 $X=640460 $Y=764580
X2325 3610 2 3649 3579 1 NR2 $T=644800 790160 0 0 $X=644800 $Y=789780
X2326 3669 2 3632 3258 1 NR2 $T=651000 739760 1 0 $X=651000 $Y=734340
X2327 3779 2 3815 3821 1 NR2 $T=677660 870800 0 0 $X=677660 $Y=870420
X2328 619 2 3831 3835 1 NR2 $T=683240 820400 0 0 $X=683240 $Y=820020
X2329 619 2 3779 3838 1 NR2 $T=683240 860720 0 0 $X=683240 $Y=860340
X2330 619 2 3863 3862 1 NR2 $T=685100 830480 0 0 $X=685100 $Y=830100
X2331 619 2 3850 3854 1 NR2 $T=685720 749840 0 0 $X=685720 $Y=749460
X2332 619 2 3871 3870 1 NR2 $T=685720 850640 0 0 $X=685720 $Y=850260
X2333 3858 2 3867 3838 1 NR2 $T=688820 860720 1 180 $X=686960 $Y=860340
X2334 3885 2 3892 619 1 NR2 $T=691920 759920 0 180 $X=690060 $Y=754500
X2335 3884 2 3925 3888 1 NR2 $T=691920 749840 0 0 $X=691920 $Y=749460
X2336 3885 2 3879 3894 1 NR2 $T=691920 790160 1 0 $X=691920 $Y=784740
X2337 3885 2 3903 3887 1 NR2 $T=694400 739760 1 180 $X=692540 $Y=739380
X2338 3913 2 3880 3888 1 NR2 $T=694400 800240 1 180 $X=692540 $Y=799860
X2339 3885 2 3914 3876 1 NR2 $T=695020 739760 0 180 $X=693160 $Y=734340
X2340 619 2 3905 3916 1 NR2 $T=693160 840560 0 0 $X=693160 $Y=840180
X2341 619 2 3872 3919 1 NR2 $T=693160 870800 1 0 $X=693160 $Y=865380
X2342 198 2 635 636 1 NR2 $T=693160 870800 0 0 $X=693160 $Y=870420
X2343 3885 2 3912 3901 1 NR2 $T=693780 780080 1 0 $X=693780 $Y=774660
X2344 3858 2 3893 3835 1 NR2 $T=696260 820400 0 180 $X=694400 $Y=814980
X2345 636 2 633 189 1 NR2 $T=696260 860720 1 180 $X=694400 $Y=860340
X2346 3885 2 3900 3884 1 NR2 $T=695020 749840 1 0 $X=695020 $Y=744420
X2347 3894 2 3918 3888 1 NR2 $T=695020 780080 0 0 $X=695020 $Y=779700
X2348 3887 2 3928 3888 1 NR2 $T=696260 739760 0 0 $X=696260 $Y=739380
X2349 3885 2 3921 3924 1 NR2 $T=696260 759920 1 0 $X=696260 $Y=754500
X2350 3901 2 3915 3888 1 NR2 $T=698120 770000 1 180 $X=696260 $Y=769620
X2351 3913 2 3923 3943 1 NR2 $T=697500 800240 0 0 $X=697500 $Y=799860
X2352 3924 2 3948 3888 1 NR2 $T=700600 749840 1 180 $X=698740 $Y=749460
X2353 3858 2 3908 3916 1 NR2 $T=698740 840560 0 0 $X=698740 $Y=840180
X2354 3858 2 3944 3870 1 NR2 $T=698740 850640 1 0 $X=698740 $Y=845220
X2355 636 2 640 639 1 NR2 $T=701220 719600 1 180 $X=699360 $Y=719220
X2356 3899 2 3935 3888 1 NR2 $T=701220 810320 0 180 $X=699360 $Y=804900
X2357 3899 2 3957 3943 1 NR2 $T=700600 820400 1 0 $X=700600 $Y=814980
X2358 3858 2 3945 3919 1 NR2 $T=700600 860720 0 0 $X=700600 $Y=860340
X2359 3894 2 3954 3943 1 NR2 $T=702460 790160 1 0 $X=702460 $Y=784740
X2360 3965 2 3977 3870 1 NR2 $T=704940 840560 1 180 $X=703080 $Y=840180
X2361 3858 2 3955 3862 1 NR2 $T=705560 840560 0 180 $X=703700 $Y=835140
X2362 3965 2 3966 3916 1 NR2 $T=706180 830480 0 180 $X=704320 $Y=825060
X2363 645 2 647 636 1 NR2 $T=704940 699440 0 0 $X=704940 $Y=699060
X2364 3884 2 3978 3943 1 NR2 $T=704940 749840 1 0 $X=704940 $Y=744420
X2365 3984 2 3967 3838 1 NR2 $T=706800 860720 1 180 $X=704940 $Y=860340
X2366 3901 2 3963 3943 1 NR2 $T=707420 770000 0 180 $X=705560 $Y=764580
X2367 3965 2 3972 3838 1 NR2 $T=707420 860720 0 180 $X=705560 $Y=855300
X2368 3924 2 3989 3943 1 NR2 $T=708040 749840 1 180 $X=706180 $Y=749460
X2369 3894 2 3986 3987 1 NR2 $T=707420 790160 1 0 $X=707420 $Y=784740
X2370 3885 2 3974 3858 1 NR2 $T=709280 820400 0 180 $X=707420 $Y=814980
X2371 4002 2 3990 3969 1 NR2 $T=709900 729680 0 180 $X=708040 $Y=724260
X2372 3984 2 3983 3870 1 NR2 $T=709900 840560 1 180 $X=708040 $Y=840180
X2373 3924 2 4015 3987 1 NR2 $T=708660 759920 1 0 $X=708660 $Y=754500
X2374 3899 2 4000 3987 1 NR2 $T=708660 810320 1 0 $X=708660 $Y=804900
X2375 3984 2 4009 3862 1 NR2 $T=710520 830480 0 180 $X=708660 $Y=825060
X2376 3901 2 3999 3987 1 NR2 $T=711760 770000 0 180 $X=709900 $Y=764580
X2377 3913 2 3980 3987 1 NR2 $T=711760 800240 0 180 $X=709900 $Y=794820
X2378 3984 2 3973 3919 1 NR2 $T=710520 860720 1 0 $X=710520 $Y=855300
X2379 3901 2 4018 4026 1 NR2 $T=712380 780080 1 0 $X=712380 $Y=774660
X2380 3885 2 3932 3913 1 NR2 $T=713000 810320 1 0 $X=713000 $Y=804900
X2381 3913 2 4023 4026 1 NR2 $T=714240 800240 1 0 $X=714240 $Y=794820
X2382 3885 2 4013 3984 1 NR2 $T=714240 820400 1 0 $X=714240 $Y=814980
X2383 3984 2 4022 3916 1 NR2 $T=716100 830480 0 180 $X=714240 $Y=825060
X2384 3894 2 4028 4026 1 NR2 $T=717340 780080 0 180 $X=715480 $Y=774660
X2385 3965 2 4029 3919 1 NR2 $T=717340 850640 1 180 $X=715480 $Y=850260
X2386 3899 2 4033 4026 1 NR2 $T=719200 810320 0 180 $X=717340 $Y=804900
X2387 3885 2 4036 3965 1 NR2 $T=717960 820400 1 0 $X=717960 $Y=814980
X2388 4053 2 4043 3894 1 NR2 $T=721060 780080 0 180 $X=719200 $Y=774660
X2389 4053 2 4041 3913 1 NR2 $T=722920 790160 0 180 $X=721060 $Y=784740
X2390 4053 2 4080 3899 1 NR2 $T=721060 810320 1 0 $X=721060 $Y=804900
X2391 3885 2 4086 3899 1 NR2 $T=723540 810320 0 0 $X=723540 $Y=809940
X2392 3984 2 4065 3858 1 NR2 $T=726020 820400 1 180 $X=724160 $Y=820020
X2393 4086 2 4102 3910 1 NR2 $T=727880 820400 1 0 $X=727880 $Y=814980
X2394 4304 2 4315 4286 1 NR2 $T=771900 709520 0 180 $X=770040 $Y=704100
X2395 4341 2 4328 4306 1 NR2 $T=775000 719600 0 180 $X=773140 $Y=714180
X2396 4322 2 4329 4302 1 NR2 $T=775000 719600 1 180 $X=773140 $Y=719220
X2397 4372 2 4331 4307 1 NR2 $T=775620 729680 1 180 $X=773760 $Y=729300
X2398 4325 2 4343 4309 1 NR2 $T=776240 709520 1 180 $X=774380 $Y=709140
X2399 4330 2 4349 4310 1 NR2 $T=778100 739760 1 0 $X=778100 $Y=734340
X2400 4342 2 4367 4355 1 NR2 $T=778100 739760 0 0 $X=778100 $Y=739380
X2401 4423 2 4447 717 1 NR2 $T=796080 770000 1 180 $X=794220 $Y=769620
X2402 4415 2 4441 4509 1 NR2 $T=807240 759920 0 0 $X=807240 $Y=759540
X2403 4502 2 4408 4500 1 NR2 $T=807860 780080 1 0 $X=807860 $Y=774660
X2404 4515 2 4543 4500 1 NR2 $T=813440 780080 0 0 $X=813440 $Y=779700
X2405 4577 2 4559 4591 1 NR2 $T=822120 719600 1 0 $X=822120 $Y=714180
X2406 4499 2 4579 4519 1 NR2 $T=823360 780080 0 0 $X=823360 $Y=779700
X2407 4500 2 4627 4561 1 NR2 $T=827700 780080 0 0 $X=827700 $Y=779700
X2408 4611 2 4523 4616 1 NR2 $T=830800 719600 0 0 $X=830800 $Y=719220
X2409 4596 2 4581 4623 1 NR2 $T=832660 729680 0 0 $X=832660 $Y=729300
X2410 4606 2 4539 4632 1 NR2 $T=834520 699440 0 0 $X=834520 $Y=699060
X2411 4607 2 4590 4633 1 NR2 $T=834520 709520 1 0 $X=834520 $Y=704100
X2412 4617 2 4566 4634 1 NR2 $T=834520 729680 1 0 $X=834520 $Y=724260
X2413 4628 2 4605 4622 1 NR2 $T=837620 749840 1 0 $X=837620 $Y=744420
X2414 5101 2 5112 5083 1 NR2 $T=938680 850640 0 0 $X=938680 $Y=850260
X2415 5101 2 5123 4646 1 NR2 $T=941160 850640 1 0 $X=941160 $Y=845220
X2416 5083 2 5126 4694 1 NR2 $T=941780 850640 0 0 $X=941780 $Y=850260
X2417 4646 2 5136 4694 1 NR2 $T=946740 850640 0 180 $X=944880 $Y=845220
X2418 4693 2 5157 972 1 NR2 $T=947980 850640 1 0 $X=947980 $Y=845220
X2419 5194 2 5165 972 1 NR2 $T=964720 850640 1 180 $X=962860 $Y=850260
X2420 5248 2 928 5260 1 NR2 $T=987660 850640 0 0 $X=987660 $Y=850260
X2421 5235 2 950 5260 1 NR2 $T=987660 860720 1 0 $X=987660 $Y=855300
X2422 5248 2 915 5274 1 NR2 $T=991380 860720 1 0 $X=991380 $Y=855300
X2423 5235 2 982 5286 1 NR2 $T=995100 860720 1 0 $X=995100 $Y=855300
X2424 5248 2 944 5286 1 NR2 $T=998820 850640 0 0 $X=998820 $Y=850260
X2425 5248 2 976 5303 1 NR2 $T=1001920 850640 0 0 $X=1001920 $Y=850260
X2426 5303 2 964 5235 1 NR2 $T=1006260 850640 0 0 $X=1006260 $Y=850260
X2427 5235 2 960 5274 1 NR2 $T=1007500 860720 1 0 $X=1007500 $Y=855300
X2428 5260 2 1012 5255 1 NR2 $T=1015560 860720 0 0 $X=1015560 $Y=860340
X2429 5260 2 1017 5254 1 NR2 $T=1016800 870800 1 0 $X=1016800 $Y=865380
X2430 5274 2 995 5254 1 NR2 $T=1022380 860720 1 0 $X=1022380 $Y=855300
X2431 5274 2 1019 5255 1 NR2 $T=1023000 850640 0 0 $X=1023000 $Y=850260
X2432 5303 2 1028 5254 1 NR2 $T=1027960 860720 1 0 $X=1027960 $Y=855300
X2433 5303 2 1029 5255 1 NR2 $T=1033540 860720 1 0 $X=1033540 $Y=855300
X2434 5286 2 1018 5255 1 NR2 $T=1040360 850640 1 180 $X=1038500 $Y=850260
X2435 5286 2 1027 5254 1 NR2 $T=1040360 860720 1 0 $X=1040360 $Y=855300
X2436 1106 2 1124 1114 1113 1 NR3 $T=221960 840560 1 0 $X=221960 $Y=835140
X2437 1101 2 1100 1135 1115 1 NR3 $T=222580 739760 1 0 $X=222580 $Y=734340
X2438 1156 2 1184 1131 1138 1 NR3 $T=225680 790160 0 180 $X=222580 $Y=784740
X2439 1146 2 1161 1163 1168 1 NR3 $T=228780 780080 0 180 $X=225680 $Y=774660
X2440 1182 2 1190 1200 1228 1 NR3 $T=228780 749840 1 0 $X=228780 $Y=744420
X2441 1244 2 1188 1227 1215 1 NR3 $T=236220 820400 1 180 $X=233120 $Y=820020
X2442 1236 2 1243 1246 1232 1 NR3 $T=234980 770000 1 0 $X=234980 $Y=764580
X2443 1292 2 1310 1314 1134 1 NR3 $T=242420 860720 0 0 $X=242420 $Y=860340
X2444 1266 2 1311 1320 1317 1 NR3 $T=243040 729680 1 0 $X=243040 $Y=724260
X2445 1347 2 1344 1360 1276 1 NR3 $T=248620 790160 0 0 $X=248620 $Y=789780
X2446 1398 2 1412 1163 1338 1 NR3 $T=256680 739760 1 180 $X=253580 $Y=739380
X2447 1391 2 1436 1331 1446 1 NR3 $T=259780 810320 1 0 $X=259780 $Y=804900
X2448 1437 2 1460 1220 1474 1 NR3 $T=262880 810320 1 0 $X=262880 $Y=804900
X2449 1326 2 1488 1495 1481 1 NR3 $T=267220 709520 0 0 $X=267220 $Y=709140
X2450 1508 2 1491 1319 1526 1 NR3 $T=271560 759920 1 180 $X=268460 $Y=759540
X2451 1475 2 1500 1509 1512 1 NR3 $T=270320 790160 0 0 $X=270320 $Y=789780
X2452 1525 2 1501 67 1530 1 NR3 $T=274660 719600 0 180 $X=271560 $Y=714180
X2453 1515 2 1392 1539 1548 1 NR3 $T=274040 770000 0 0 $X=274040 $Y=769620
X2454 1145 2 73 1488 1535 1 NR3 $T=279000 709520 0 180 $X=275900 $Y=704100
X2455 1606 2 1227 1592 1605 1 NR3 $T=286440 800240 1 180 $X=283340 $Y=799860
X2456 78 2 1612 1600 1554 1 NR3 $T=283960 790160 1 0 $X=283960 $Y=784740
X2457 1613 2 1582 1363 1593 1 NR3 $T=287060 830480 0 180 $X=283960 $Y=825060
X2458 1673 2 1163 1482 1667 1 NR3 $T=297600 780080 0 180 $X=294500 $Y=774660
X2459 1641 2 1662 1632 1684 1 NR3 $T=296360 800240 0 0 $X=296360 $Y=799860
X2460 90 2 1586 1495 1278 1 NR3 $T=298840 719600 0 0 $X=298840 $Y=719220
X2461 1690 2 1200 1429 1703 1 NR3 $T=302560 749840 1 0 $X=302560 $Y=744420
X2462 1200 2 1700 90 1697 1 NR3 $T=305040 759920 1 0 $X=305040 $Y=754500
X2463 1708 2 1712 1717 1714 1 NR3 $T=306900 810320 1 0 $X=306900 $Y=804900
X2464 1453 2 1718 1705 1728 1 NR3 $T=308140 790160 1 0 $X=308140 $Y=784740
X2465 1732 2 1722 1706 1709 1 NR3 $T=312480 739760 0 180 $X=309380 $Y=734340
X2466 1375 2 1700 1326 1746 1 NR3 $T=315580 749840 1 180 $X=312480 $Y=749460
X2467 1770 2 1727 1752 1655 1 NR3 $T=314340 810320 0 0 $X=314340 $Y=809940
X2468 1758 2 1640 105 1754 1 NR3 $T=317440 880880 0 180 $X=314340 $Y=875460
X2469 1699 2 1483 106 1750 1 NR3 $T=314960 699440 0 0 $X=314960 $Y=699060
X2470 1755 2 1725 108 1721 1 NR3 $T=317440 709520 1 0 $X=317440 $Y=704100
X2471 1675 2 1765 1757 1760 1 NR3 $T=318060 830480 0 0 $X=318060 $Y=830100
X2472 107 2 45 1784 1744 1 NR3 $T=323020 699440 0 0 $X=323020 $Y=699060
X2473 1759 2 14 1800 1804 1 NR3 $T=326740 860720 1 0 $X=326740 $Y=855300
X2474 1818 2 1810 1813 1498 1 NR3 $T=334180 790160 0 180 $X=331080 $Y=784740
X2475 1838 2 1867 1855 1878 1 NR3 $T=341620 770000 1 0 $X=341620 $Y=764580
X2476 1912 2 1346 82 1876 1 NR3 $T=349680 770000 0 180 $X=346580 $Y=764580
X2477 1989 2 2010 1875 1924 1 NR3 $T=372000 780080 0 0 $X=372000 $Y=779700
X2478 1920 2 1980 2051 2011 1 NR3 $T=374480 800240 1 0 $X=374480 $Y=794820
X2479 2556 2 2518 2564 2579 1 NR3 $T=456940 820400 1 180 $X=453840 $Y=820020
X2480 2648 2 2632 309 2656 1 NR3 $T=466860 790160 0 180 $X=463760 $Y=784740
X2481 2862 2 2890 2865 2900 1 NR3 $T=499100 860720 0 0 $X=499100 $Y=860340
X2482 2910 2 2921 2962 2915 1 NR3 $T=503440 780080 1 0 $X=503440 $Y=774660
X2483 2989 2 2962 3002 3022 1 NR3 $T=514600 780080 0 0 $X=514600 $Y=779700
X2484 3062 2 2518 3065 3061 1 NR3 $T=527000 860720 1 0 $X=527000 $Y=855300
X2485 3095 2 3056 3115 3132 1 NR3 $T=539400 790160 1 0 $X=539400 $Y=784740
X2486 2809 2 2505 2496 3124 1 NR3 $T=544980 820400 1 180 $X=541880 $Y=820020
X2487 3030 2 3137 3153 3166 1 NR3 $T=546840 800240 1 0 $X=546840 $Y=794820
X2488 3096 2 2676 2619 3206 1 NR3 $T=557380 840560 0 0 $X=557380 $Y=840180
X2489 3109 2 3078 3227 3216 1 NR3 $T=560480 830480 1 0 $X=560480 $Y=825060
X2490 3051 2 501 3277 3180 1 NR3 $T=569160 820400 1 0 $X=569160 $Y=814980
X2491 418 2 411 377 3292 1 NR3 $T=579700 880880 1 0 $X=579700 $Y=875460
X2492 3447 2 3442 3518 3583 1 NR3 $T=636740 850640 1 180 $X=633640 $Y=850260
X2493 3746 2 3779 3706 3769 1 NR3 $T=670840 850640 0 0 $X=670840 $Y=850260
X2494 4273 2 4469 4452 4220 1 NR3 $T=803520 810320 0 180 $X=800420 $Y=804900
X2495 1145 1107 1 1105 1116 1102 2 MOAI1S $T=225680 759920 0 180 $X=221960 $Y=754500
X2496 1107 1111 1 1139 1148 1096 2 MOAI1S $T=222580 850640 0 0 $X=222580 $Y=850260
X2497 1142 1119 1 1120 7 1100 2 MOAI1S $T=227540 719600 0 180 $X=223820 $Y=714180
X2498 1233 1152 1 1185 1181 1121 2 MOAI1S $T=231880 729680 0 180 $X=228160 $Y=724260
X2499 1231 15 1 1203 1183 1126 2 MOAI1S $T=233740 870800 0 180 $X=230020 $Y=865380
X2500 9 1290 1 1305 1277 1314 2 MOAI1S $T=241800 850640 0 0 $X=241800 $Y=850260
X2501 1152 32 1 1222 1298 1301 2 MOAI1S $T=246760 739760 0 180 $X=243040 $Y=734340
X2502 1332 1346 1 18 1293 1136 2 MOAI1S $T=249860 770000 0 180 $X=246140 $Y=764580
X2503 1290 1336 1 1298 1221 1363 2 MOAI1S $T=246760 830480 1 0 $X=246760 $Y=825060
X2504 1152 1355 1 33 1370 1328 2 MOAI1S $T=249240 729680 0 0 $X=249240 $Y=729300
X2505 1369 1358 1 1176 1313 1130 2 MOAI1S $T=252960 790160 0 180 $X=249240 $Y=784740
X2506 1149 1394 1 41 1419 1360 2 MOAI1S $T=255440 870800 0 0 $X=255440 $Y=870420
X2507 35 1213 1 1413 1435 1440 2 MOAI1S $T=258540 800240 0 0 $X=258540 $Y=799860
X2508 1408 1207 1 1433 28 1459 2 MOAI1S $T=259160 800240 1 0 $X=259160 $Y=794820
X2509 21 1464 1 1419 49 1310 2 MOAI1S $T=265980 870800 1 180 $X=262260 $Y=870420
X2510 21 1158 1 1313 1374 1485 2 MOAI1S $T=264740 850640 0 0 $X=264740 $Y=850260
X2511 1393 1486 1 1419 53 1124 2 MOAI1S $T=269080 860720 1 180 $X=265360 $Y=860340
X2512 40 1167 1 60 1419 1564 2 MOAI1S $T=275280 870800 0 0 $X=275280 $Y=870420
X2513 1545 1571 1 1562 1288 1551 2 MOAI1S $T=282100 780080 1 180 $X=278380 $Y=779700
X2514 21 1464 1 1199 1348 1582 2 MOAI1S $T=278380 850640 1 0 $X=278380 $Y=845220
X2515 1265 1588 1 1480 1304 1592 2 MOAI1S $T=282720 800240 1 0 $X=282720 $Y=794820
X2516 1286 1545 1 1313 1614 1612 2 MOAI1S $T=285200 780080 0 0 $X=285200 $Y=779700
X2517 1637 1107 1 1648 1105 1600 2 MOAI1S $T=293260 790160 1 0 $X=293260 $Y=784740
X2518 36 1142 1 1686 33 1706 2 MOAI1S $T=300080 709520 0 0 $X=300080 $Y=709140
X2519 1393 1486 1 61 1693 1694 2 MOAI1S $T=300080 860720 1 0 $X=300080 $Y=855300
X2520 1332 1741 1 1407 1402 1718 2 MOAI1S $T=314960 790160 1 180 $X=311240 $Y=789780
X2521 1384 1743 1 1748 1345 1509 2 MOAI1S $T=313720 739760 0 0 $X=313720 $Y=739380
X2522 1384 1751 1 1753 1345 1722 2 MOAI1S $T=314960 739760 1 0 $X=314960 $Y=734340
X2523 1369 1842 1 10 1238 1867 2 MOAI1S $T=337280 770000 0 0 $X=337280 $Y=769620
X2524 1332 1918 1 1536 1345 1905 2 MOAI1S $T=353400 790160 1 180 $X=349680 $Y=789780
X2525 1926 1961 1 1871 1911 1939 2 MOAI1S $T=360840 850640 1 180 $X=357120 $Y=850260
X2526 2019 1968 1 2014 1894 2009 2 MOAI1S $T=371380 870800 0 180 $X=367660 $Y=865380
X2527 2048 1920 1 2045 2077 2084 2 MOAI1S $T=376960 840560 0 0 $X=376960 $Y=840180
X2528 2104 172 1 2086 172 2045 2 MOAI1S $T=383780 870800 0 180 $X=380060 $Y=865380
X2529 170 167 1 2077 2022 2173 2 MOAI1S $T=398660 830480 0 180 $X=394940 $Y=825060
X2530 221 2014 1 223 224 2273 2 MOAI1S $T=411060 880880 1 0 $X=411060 $Y=875460
X2531 221 235 1 224 228 2227 2 MOAI1S $T=421600 880880 0 180 $X=417880 $Y=875460
X2532 298 293 1 2449 2470 2556 2 MOAI1S $T=456940 830480 1 180 $X=453220 $Y=830100
X2533 2569 2505 1 2583 2553 2597 2 MOAI1S $T=455700 800240 1 0 $X=455700 $Y=794820
X2534 2455 2592 1 2508 2559 2576 2 MOAI1S $T=460040 810320 1 180 $X=456320 $Y=809940
X2535 2361 2572 1 2553 2578 2618 2 MOAI1S $T=458180 810320 1 0 $X=458180 $Y=804900
X2536 2403 2561 1 2604 2566 2632 2 MOAI1S $T=459420 790160 0 0 $X=459420 $Y=789780
X2537 305 2567 1 2593 2636 2643 2 MOAI1S $T=462520 820400 1 0 $X=462520 $Y=814980
X2538 2455 2592 1 322 2600 2738 2 MOAI1S $T=472440 810320 0 0 $X=472440 $Y=809940
X2539 2739 2681 1 2693 2421 2752 2 MOAI1S $T=476780 810320 1 0 $X=476780 $Y=804900
X2540 2649 2702 1 2622 2620 2772 2 MOAI1S $T=486700 810320 1 180 $X=482980 $Y=809940
X2541 2670 2649 1 2593 2912 2910 2 MOAI1S $T=500340 810320 1 0 $X=500340 $Y=804900
X2542 298 400 1 2978 2437 3002 2 MOAI1S $T=510260 820400 0 0 $X=510260 $Y=820020
X2543 2561 2488 1 2463 3010 2988 2 MOAI1S $T=520180 810320 1 180 $X=516460 $Y=809940
X2544 3052 229 1 195 229 2889 2 MOAI1S $T=521420 770000 0 180 $X=517700 $Y=764580
X2545 2782 2439 1 274 419 2929 2 MOAI1S $T=527620 820400 1 180 $X=523900 $Y=820020
X2546 2403 2543 1 2553 2620 3068 2 MOAI1S $T=525760 800240 1 0 $X=525760 $Y=794820
X2547 433 195 1 195 426 3060 2 MOAI1S $T=530720 759920 1 180 $X=527000 $Y=759540
X2548 286 305 1 2625 3010 3085 2 MOAI1S $T=528860 840560 1 0 $X=528860 $Y=835140
X2549 2543 2901 1 2463 3010 3081 2 MOAI1S $T=530720 800240 0 0 $X=530720 $Y=799860
X2550 2739 2534 1 274 442 3090 2 MOAI1S $T=538160 820400 1 180 $X=534440 $Y=820020
X2551 432 195 1 195 427 3048 2 MOAI1S $T=541880 770000 0 180 $X=538160 $Y=764580
X2552 413 2839 1 463 2980 3179 2 MOAI1S $T=547460 870800 1 0 $X=547460 $Y=865380
X2553 454 481 1 2620 2884 3201 2 MOAI1S $T=560480 850640 1 180 $X=556760 $Y=850260
X2554 3207 3148 1 3221 3222 3229 2 MOAI1S $T=559860 739760 0 0 $X=559860 $Y=739380
X2555 3207 3177 1 3221 3232 3234 2 MOAI1S $T=561100 749840 0 0 $X=561100 $Y=749460
X2556 3258 497 1 3266 3262 3289 2 MOAI1S $T=568540 780080 0 0 $X=568540 $Y=779700
X2557 3258 491 1 3266 3232 3294 2 MOAI1S $T=569160 759920 0 0 $X=569160 $Y=759540
X2558 3258 500 1 3266 3283 3288 2 MOAI1S $T=569780 770000 0 0 $X=569780 $Y=769620
X2559 3258 3193 1 3266 3222 3301 2 MOAI1S $T=571020 739760 0 0 $X=571020 $Y=739380
X2560 2670 2676 1 395 392 3227 2 MOAI1S $T=575360 830480 1 180 $X=571640 $Y=830100
X2561 454 511 1 2995 2559 3174 2 MOAI1S $T=577220 860720 0 180 $X=573500 $Y=855300
X2562 2858 2702 1 512 395 3277 2 MOAI1S $T=574740 820400 1 0 $X=574740 $Y=814980
X2563 3258 3273 1 3266 3318 3323 2 MOAI1S $T=576600 749840 1 0 $X=576600 $Y=744420
X2564 519 3326 1 2508 2758 3300 2 MOAI1S $T=580940 840560 1 180 $X=577220 $Y=840180
X2565 526 522 1 2578 3218 3311 2 MOAI1S $T=584660 860720 0 180 $X=580940 $Y=855300
X2566 3258 3340 1 3266 3363 3391 2 MOAI1S $T=587140 749840 0 0 $X=587140 $Y=749460
X2567 2670 2561 1 3370 397 3380 2 MOAI1S $T=587140 840560 1 0 $X=587140 $Y=835140
X2568 3258 3343 1 3266 3382 3379 2 MOAI1S $T=587760 759920 0 0 $X=587760 $Y=759540
X2569 3258 3432 1 3266 3392 3420 2 MOAI1S $T=601400 759920 0 180 $X=597680 $Y=754500
X2570 3258 3297 1 3266 3314 3454 2 MOAI1S $T=602020 749840 0 0 $X=602020 $Y=749460
X2571 3440 3278 1 3450 3442 3457 2 MOAI1S $T=603260 840560 0 0 $X=603260 $Y=840180
X2572 3258 507 1 3266 3333 3436 2 MOAI1S $T=607600 759920 1 180 $X=603880 $Y=759540
X2573 3258 505 1 3266 3332 3433 2 MOAI1S $T=607600 770000 1 180 $X=603880 $Y=769620
X2574 3439 3440 1 3417 3430 3367 2 MOAI1S $T=608840 850640 0 180 $X=605120 $Y=845220
X2575 3258 3348 1 3266 3351 3464 2 MOAI1S $T=611940 749840 1 180 $X=608220 $Y=749460
X2576 3506 3258 1 3266 3365 3485 2 MOAI1S $T=617520 739760 1 180 $X=613800 $Y=739380
X2577 3258 554 1 3266 3341 3481 2 MOAI1S $T=618140 770000 1 180 $X=614420 $Y=769620
X2578 3258 3505 1 3339 3266 3486 2 MOAI1S $T=619380 749840 1 180 $X=615660 $Y=749460
X2579 3258 560 1 3266 3344 3498 2 MOAI1S $T=620620 759920 0 180 $X=616900 $Y=754500
X2580 3259 3506 1 3331 3490 3522 2 MOAI1S $T=619380 749840 1 0 $X=619380 $Y=744420
X2581 3259 554 1 3331 3491 3544 2 MOAI1S $T=622480 780080 1 0 $X=622480 $Y=774660
X2582 3258 3545 1 3266 3354 3530 2 MOAI1S $T=629300 749840 1 180 $X=625580 $Y=749460
X2583 3562 3258 1 3368 3266 3604 2 MOAI1S $T=632400 759920 1 0 $X=632400 $Y=754500
X2584 3614 3272 1 3312 3354 3569 2 MOAI1S $T=636740 749840 0 180 $X=633020 $Y=744420
X2585 3258 576 1 3266 3373 3579 2 MOAI1S $T=638600 790160 1 180 $X=634880 $Y=789780
X2586 3258 573 1 3266 3355 3578 2 MOAI1S $T=639220 790160 0 180 $X=635500 $Y=784740
X2587 3272 584 1 3312 3355 3610 2 MOAI1S $T=643560 790160 1 180 $X=639840 $Y=789780
X2588 589 3663 1 3312 3491 3679 2 MOAI1S $T=649760 729680 1 0 $X=649760 $Y=724260
X2589 3609 3663 1 3312 3490 595 2 MOAI1S $T=652240 719600 0 0 $X=652240 $Y=719220
X2590 4037 662 1 4037 3965 4032 2 MOAI1S $T=721060 820400 1 180 $X=717340 $Y=820020
X2591 4037 665 1 4037 3858 4091 2 MOAI1S $T=722300 830480 0 0 $X=722300 $Y=830100
X2592 4037 675 1 4037 3984 4109 2 MOAI1S $T=729120 830480 0 0 $X=729120 $Y=830100
X2593 717 4129 1 723 726 4286 2 MOAI1S $T=764460 699440 0 0 $X=764460 $Y=699060
X2594 4079 717 1 723 721 4302 2 MOAI1S $T=765080 719600 0 0 $X=765080 $Y=719220
X2595 717 4062 1 728 723 4307 2 MOAI1S $T=765700 729680 1 0 $X=765700 $Y=724260
X2596 717 679 1 723 732 4306 2 MOAI1S $T=768180 719600 1 0 $X=768180 $Y=714180
X2597 717 4081 1 723 733 4310 2 MOAI1S $T=768180 739760 0 0 $X=768180 $Y=739380
X2598 717 4237 1 723 724 4309 2 MOAI1S $T=768800 709520 0 0 $X=768800 $Y=709140
X2599 735 4079 1 738 4326 4330 2 MOAI1S $T=772520 739760 1 0 $X=772520 $Y=734340
X2600 4171 717 1 4308 723 4355 2 MOAI1S $T=772520 749840 1 0 $X=772520 $Y=744420
X2601 4294 739 1 734 733 4342 2 MOAI1S $T=773760 739760 0 0 $X=773760 $Y=739380
X2602 4188 4438 1 734 4326 4458 2 MOAI1S $T=794840 780080 1 0 $X=794840 $Y=774660
X2603 4490 4438 1 734 4468 4240 2 MOAI1S $T=806000 770000 1 180 $X=802280 $Y=769620
X2604 4432 787 1 4486 4469 4496 2 MOAI1S $T=810960 780080 1 180 $X=807240 $Y=779700
X2605 4528 4432 1 4561 4524 4575 2 MOAI1S $T=817160 800240 1 0 $X=817160 $Y=794820
X2606 735 4609 1 738 4468 4596 2 MOAI1S $T=830800 729680 1 180 $X=827080 $Y=729300
X2607 739 4522 1 734 782 4628 2 MOAI1S $T=831420 749840 1 0 $X=831420 $Y=744420
X2608 717 815 1 723 783 4591 2 MOAI1S $T=837000 719600 0 180 $X=833280 $Y=714180
X2609 717 4609 1 723 792 4616 2 MOAI1S $T=838240 719600 1 180 $X=834520 $Y=719220
X2610 717 4602 1 723 4480 4622 2 MOAI1S $T=838240 739760 1 180 $X=834520 $Y=739380
X2611 717 4574 1 723 782 4623 2 MOAI1S $T=840100 729680 1 180 $X=836380 $Y=729300
X2612 717 823 1 723 790 4633 2 MOAI1S $T=841960 709520 0 180 $X=838240 $Y=704100
X2613 717 4650 1 723 780 4634 2 MOAI1S $T=841960 729680 0 180 $X=838240 $Y=724260
X2614 717 825 1 723 786 4632 2 MOAI1S $T=842580 699440 1 180 $X=838860 $Y=699060
X2615 1133 1272 1263 1208 2 1 1214 OA112 $T=238080 800240 0 0 $X=238080 $Y=799860
X2616 1380 1373 1288 1287 2 1 1323 OA112 $T=253580 820400 0 180 $X=248620 $Y=814980
X2617 1523 1448 1536 1223 2 1 1558 OA112 $T=274660 810320 0 0 $X=274660 $Y=809940
X2618 1544 1449 33 85 2 1 1668 OA112 $T=289540 800240 0 0 $X=289540 $Y=799860
X2619 1608 1678 1157 1287 2 1 1196 OA112 $T=304420 830480 1 0 $X=304420 $Y=825060
X2620 1382 1737 56 63 2 1 1308 OA112 $T=314340 840560 0 180 $X=309380 $Y=835140
X2621 1792 1781 1307 1729 2 1 1698 OA112 $T=326740 820400 0 180 $X=321780 $Y=814980
X2622 1792 1868 1288 1502 2 1 1887 OA112 $T=342240 800240 0 0 $X=342240 $Y=799860
X2623 2757 2577 2354 2470 2 1 2793 OA112 $T=480500 820400 0 0 $X=480500 $Y=820020
X2624 2743 355 2801 358 2 1 2829 OA112 $T=486080 850640 1 0 $X=486080 $Y=845220
X2625 2826 2814 2421 2620 2 1 2790 OA112 $T=491660 850640 1 180 $X=486700 $Y=850260
X2626 2828 2823 2481 2464 2 1 2863 OA112 $T=492900 840560 1 0 $X=492900 $Y=835140
X2627 2900 2924 2421 2470 2 1 2968 OA112 $T=504060 790160 0 0 $X=504060 $Y=789780
X2628 2806 3017 2464 299 2 1 3033 OA112 $T=517080 820400 1 0 $X=517080 $Y=814980
X2629 2806 2725 2422 2620 2 1 3054 OA112 $T=517700 800240 1 0 $X=517700 $Y=794820
X2630 2774 3038 2481 2620 2 1 3046 OA112 $T=520800 840560 0 0 $X=520800 $Y=840180
X2631 3058 3008 2421 2906 2 1 3099 OA112 $T=531960 850640 1 0 $X=531960 $Y=845220
X2632 3034 3112 2421 2682 2 1 3093 OA112 $T=541260 850640 1 180 $X=536300 $Y=850260
X2633 3026 3183 3172 3168 2 1 3158 OA112 $T=555520 870800 1 180 $X=550560 $Y=870420
X2634 3140 3240 2513 2437 2 1 2977 OA112 $T=566680 840560 0 180 $X=561720 $Y=835140
X2635 2749 3257 3167 2995 2 1 3287 OA112 $T=568540 820400 0 0 $X=568540 $Y=820020
X2636 1118 1111 4 1 2 ND2 $T=223200 790160 1 180 $X=221340 $Y=789780
X2637 1177 1160 1154 1 2 ND2 $T=227540 759920 1 180 $X=225680 $Y=759540
X2638 3 1133 1167 1 2 ND2 $T=225680 870800 1 0 $X=225680 $Y=865380
X2639 10 1119 4 1 2 ND2 $T=228780 709520 0 0 $X=228780 $Y=709140
X2640 1177 1161 1218 1 2 ND2 $T=230640 780080 1 0 $X=230640 $Y=774660
X2641 1199 1237 1148 1 2 ND2 $T=233120 840560 1 0 $X=233120 $Y=835140
X2642 1253 1299 1273 1 2 ND2 $T=241180 810320 1 180 $X=239320 $Y=809940
X2643 1105 1213 1304 1 2 ND2 $T=241800 800240 1 0 $X=241800 $Y=794820
X2644 4 1303 1293 1 2 ND2 $T=244900 709520 1 180 $X=243040 $Y=709140
X2645 1118 1335 1342 1 2 ND2 $T=246140 800240 1 0 $X=246140 $Y=794820
X2646 1176 1336 1148 1 2 ND2 $T=248000 840560 0 180 $X=246140 $Y=835140
X2647 1352 1318 1183 1 2 ND2 $T=249240 800240 0 0 $X=249240 $Y=799860
X2648 1295 1387 1371 1 2 ND2 $T=249860 800240 1 0 $X=249860 $Y=794820
X2649 1253 11 1393 1 2 ND2 $T=251100 860720 1 0 $X=251100 $Y=855300
X2650 1341 1386 1357 1 2 ND2 $T=252960 870800 1 180 $X=251100 $Y=870420
X2651 1282 1394 1402 1 2 ND2 $T=254200 860720 0 0 $X=254200 $Y=860340
X2652 1416 1143 1427 1 2 ND2 $T=257920 729680 0 0 $X=257920 $Y=729300
X2653 47 1439 1218 1 2 ND2 $T=262880 709520 1 0 $X=262880 $Y=704100
X2654 1217 1479 7 1 2 ND2 $T=267220 699440 1 180 $X=265360 $Y=699060
X2655 39 1470 1492 1 2 ND2 $T=265980 729680 0 0 $X=265980 $Y=729300
X2656 1374 54 1148 1 2 ND2 $T=266600 870800 1 0 $X=266600 $Y=865380
X2657 1464 1471 1109 1 2 ND2 $T=269700 830480 1 0 $X=269700 $Y=825060
X2658 1423 1500 1507 1 2 ND2 $T=270320 870800 1 0 $X=270320 $Y=865380
X2659 1222 1510 1174 1 2 ND2 $T=271560 820400 1 0 $X=271560 $Y=814980
X2660 1524 1532 43 1 2 ND2 $T=274660 830480 0 180 $X=272800 $Y=825060
X2661 76 1560 1107 1 2 ND2 $T=280240 800240 1 180 $X=278380 $Y=799860
X2662 1561 1595 52 1 2 ND2 $T=283960 749840 1 180 $X=282100 $Y=749460
X2663 79 1525 1218 1 2 ND2 $T=284580 719600 1 0 $X=284580 $Y=714180
X2664 1281 1601 79 1 2 ND2 $T=286440 709520 1 0 $X=286440 $Y=704100
X2665 84 1640 49 1 2 ND2 $T=290780 880880 0 180 $X=288920 $Y=875460
X2666 1487 1622 85 1 2 ND2 $T=291400 709520 0 0 $X=291400 $Y=709140
X2667 1649 1379 7 1 2 ND2 $T=295740 709520 0 180 $X=293880 $Y=704100
X2668 1647 1141 1402 1 2 ND2 $T=293880 820400 0 0 $X=293880 $Y=820020
X2669 1304 1642 1407 1 2 ND2 $T=294500 820400 1 0 $X=294500 $Y=814980
X2670 1661 1632 1334 1 2 ND2 $T=296980 800240 0 180 $X=295120 $Y=794820
X2671 1585 1482 1502 1 2 ND2 $T=296360 770000 0 0 $X=296360 $Y=769620
X2672 1685 1559 1371 1 2 ND2 $T=301320 830480 0 0 $X=301320 $Y=830100
X2673 96 1672 58 1 2 ND2 $T=305660 870800 1 180 $X=303800 $Y=870420
X2674 1502 1692 1494 1 2 ND2 $T=305040 729680 0 0 $X=305040 $Y=729300
X2675 94 1711 93 1 2 ND2 $T=308140 870800 0 0 $X=308140 $Y=870420
X2676 1738 1737 1332 1 2 ND2 $T=312480 840560 0 0 $X=312480 $Y=840180
X2677 1221 1759 1174 1 2 ND2 $T=321160 850640 0 180 $X=319300 $Y=845220
X2678 1494 1771 25 1 2 ND2 $T=322400 729680 1 180 $X=320540 $Y=729300
X2679 1293 45 1218 1 2 ND2 $T=324260 719600 0 180 $X=322400 $Y=714180
X2680 1775 89 114 1 2 ND2 $T=322400 880880 1 0 $X=322400 $Y=875460
X2681 1778 1304 1786 1 2 ND2 $T=323020 850640 1 0 $X=323020 $Y=845220
X2682 7 1784 1342 1 2 ND2 $T=326120 709520 0 180 $X=324260 $Y=704100
X2683 1750 1774 1293 1 2 ND2 $T=324880 729680 0 0 $X=324880 $Y=729300
X2684 1790 1206 1803 1 2 ND2 $T=326740 840560 0 0 $X=326740 $Y=840180
X2685 1778 1221 1803 1 2 ND2 $T=326740 850640 1 0 $X=326740 $Y=845220
X2686 29 108 1293 1 2 ND2 $T=327360 719600 1 0 $X=327360 $Y=714180
X2687 1726 1521 1808 1 2 ND2 $T=329220 759920 0 0 $X=329220 $Y=759540
X2688 1806 66 114 1 2 ND2 $T=329840 880880 1 0 $X=329840 $Y=875460
X2689 1790 43 1786 1 2 ND2 $T=330460 840560 0 0 $X=330460 $Y=840180
X2690 1778 1174 1820 1 2 ND2 $T=330460 850640 1 0 $X=330460 $Y=845220
X2691 1203 1800 1240 1 2 ND2 $T=330460 860720 0 0 $X=330460 $Y=860340
X2692 1801 122 1826 1 2 ND2 $T=331700 739760 0 0 $X=331700 $Y=739380
X2693 1790 1205 1820 1 2 ND2 $T=332320 840560 1 0 $X=332320 $Y=835140
X2694 1803 1208 1829 1 2 ND2 $T=334180 840560 0 0 $X=334180 $Y=840180
X2695 1829 1348 1786 1 2 ND2 $T=334800 850640 1 0 $X=334800 $Y=845220
X2696 1790 1357 1848 1 2 ND2 $T=336040 840560 1 0 $X=336040 $Y=835140
X2697 1502 1787 1779 1 2 ND2 $T=336660 780080 1 0 $X=336660 $Y=774660
X2698 1839 1427 117 1 2 ND2 $T=337280 830480 0 0 $X=337280 $Y=830100
X2699 1778 1105 1848 1 2 ND2 $T=337900 840560 0 0 $X=337900 $Y=840180
X2700 1820 1222 1829 1 2 ND2 $T=338520 850640 1 0 $X=338520 $Y=845220
X2701 1856 1239 1885 1 2 ND2 $T=339760 810320 0 0 $X=339760 $Y=809940
X2702 1854 1863 1865 1 2 ND2 $T=340380 719600 1 0 $X=340380 $Y=714180
X2703 1857 1870 121 1 2 ND2 $T=342860 709520 0 180 $X=341000 $Y=704100
X2704 1848 1240 1829 1 2 ND2 $T=341620 840560 0 0 $X=341620 $Y=840180
X2705 1873 1865 121 1 2 ND2 $T=344100 719600 0 180 $X=342240 $Y=714180
X2706 1860 1872 1870 1 2 ND2 $T=344720 709520 0 180 $X=342860 $Y=704100
X2707 1880 1886 1874 1 2 ND2 $T=345960 719600 0 180 $X=344100 $Y=714180
X2708 1856 1223 1884 1 2 ND2 $T=344720 810320 1 0 $X=344720 $Y=804900
X2709 29 1664 1218 1 2 ND2 $T=347200 729680 1 180 $X=345340 $Y=729300
X2710 1881 1313 1803 1 2 ND2 $T=345340 840560 0 0 $X=345340 $Y=840180
X2711 1897 1890 1886 1 2 ND2 $T=347820 719600 0 180 $X=345960 $Y=714180
X2712 1873 1897 1866 1 2 ND2 $T=347820 719600 1 0 $X=347820 $Y=714180
X2713 1884 1238 1899 1 2 ND2 $T=347820 820400 1 0 $X=347820 $Y=814980
X2714 1899 1277 1885 1 2 ND2 $T=349060 830480 0 0 $X=349060 $Y=830100
X2715 1848 1407 1881 1 2 ND2 $T=349060 840560 0 0 $X=349060 $Y=840180
X2716 1820 1729 1881 1 2 ND2 $T=349680 840560 1 0 $X=349680 $Y=835140
X2717 140 1930 1906 1 2 ND2 $T=352160 739760 1 180 $X=350300 $Y=739380
X2718 1700 1382 1926 1 2 ND2 $T=350920 850640 1 0 $X=350920 $Y=845220
X2719 1924 1177 1951 1 2 ND2 $T=353400 770000 0 0 $X=353400 $Y=769620
X2720 1924 4 1971 1 2 ND2 $T=357740 780080 0 0 $X=357740 $Y=779700
X2721 1914 1965 1932 1 2 ND2 $T=360220 719600 1 180 $X=358360 $Y=719220
X2722 1762 1964 109 1 2 ND2 $T=361460 850640 0 180 $X=359600 $Y=845220
X2723 1943 1969 1965 1 2 ND2 $T=362080 719600 1 180 $X=360220 $Y=719220
X2724 1881 1425 1786 1 2 ND2 $T=362700 840560 1 180 $X=360840 $Y=840180
X2725 1976 1972 1978 1 2 ND2 $T=364560 759920 0 180 $X=362700 $Y=754500
X2726 1977 1981 1984 1 2 ND2 $T=362700 770000 1 0 $X=362700 $Y=764580
X2727 2011 1281 1875 1 2 ND2 $T=368280 800240 0 0 $X=368280 $Y=799860
X2728 1999 2021 1984 1 2 ND2 $T=372000 759920 0 180 $X=370140 $Y=754500
X2729 2051 1925 1875 1 2 ND2 $T=373240 800240 1 180 $X=371380 $Y=799860
X2730 2035 2046 1984 1 2 ND2 $T=373860 780080 1 0 $X=373860 $Y=774660
X2731 2023 2038 1978 1 2 ND2 $T=375720 759920 1 0 $X=375720 $Y=754500
X2732 1891 2093 2044 1 2 ND2 $T=380060 810320 1 0 $X=380060 $Y=804900
X2733 1885 2044 167 1 2 ND2 $T=381920 830480 1 0 $X=381920 $Y=825060
X2734 2085 2049 1978 1 2 ND2 $T=386260 759920 0 180 $X=384400 $Y=754500
X2735 2096 2115 2031 1 2 ND2 $T=387500 780080 1 180 $X=385640 $Y=779700
X2736 2050 2110 2114 1 2 ND2 $T=386260 770000 1 0 $X=386260 $Y=764580
X2737 2092 2121 2000 1 2 ND2 $T=389980 770000 0 180 $X=388120 $Y=764580
X2738 2050 2149 2127 1 2 ND2 $T=391220 770000 0 0 $X=391220 $Y=769620
X2739 2145 2126 2170 1 2 ND2 $T=391220 800240 0 0 $X=391220 $Y=799860
X2740 2092 2148 2159 1 2 ND2 $T=391840 759920 0 0 $X=391840 $Y=759540
X2741 2156 2142 2113 1 2 ND2 $T=392460 739760 0 0 $X=392460 $Y=739380
X2742 2151 2143 2170 1 2 ND2 $T=394320 800240 1 0 $X=394320 $Y=794820
X2743 2159 2162 2000 1 2 ND2 $T=394940 770000 1 0 $X=394940 $Y=764580
X2744 2150 2184 2122 1 2 ND2 $T=397420 790160 1 180 $X=395560 $Y=789780
X2745 159 2194 147 1 2 ND2 $T=399280 840560 0 180 $X=397420 $Y=835140
X2746 2200 2199 2113 1 2 ND2 $T=399900 739760 1 180 $X=398040 $Y=739380
X2747 2204 2185 2154 1 2 ND2 $T=400520 780080 1 180 $X=398660 $Y=779700
X2748 2184 2196 2131 1 2 ND2 $T=398660 790160 1 0 $X=398660 $Y=784740
X2749 2192 2208 2113 1 2 ND2 $T=401140 749840 0 180 $X=399280 $Y=744420
X2750 195 196 189 1 2 ND2 $T=399280 880880 1 0 $X=399280 $Y=875460
X2751 2211 2183 2212 1 2 ND2 $T=401760 780080 1 0 $X=401760 $Y=774660
X2752 2205 203 198 1 2 ND2 $T=402380 870800 0 0 $X=402380 $Y=870420
X2753 2168 2232 2233 1 2 ND2 $T=404860 759920 0 0 $X=404860 $Y=759540
X2754 2231 2221 2113 1 2 ND2 $T=407960 749840 0 0 $X=407960 $Y=749460
X2755 212 2276 218 1 2 ND2 $T=413540 860720 0 180 $X=411680 $Y=855300
X2756 2269 2279 2113 1 2 ND2 $T=413540 739760 0 0 $X=413540 $Y=739380
X2757 2262 2325 2301 1 2 ND2 $T=419120 850640 0 180 $X=417260 $Y=845220
X2758 2308 2246 2316 1 2 ND2 $T=418500 749840 1 0 $X=418500 $Y=744420
X2759 2288 2297 2100 1 2 ND2 $T=419120 739760 0 0 $X=419120 $Y=739380
X2760 159 2247 2263 1 2 ND2 $T=419120 820400 0 0 $X=419120 $Y=820020
X2761 2294 2286 2300 1 2 ND2 $T=419740 780080 0 0 $X=419740 $Y=779700
X2762 2340 2338 2353 1 2 ND2 $T=424080 780080 0 0 $X=424080 $Y=779700
X2763 2322 2372 2296 1 2 ND2 $T=427180 800240 1 180 $X=425320 $Y=799860
X2764 2302 250 2364 1 2 ND2 $T=428420 870800 1 180 $X=426560 $Y=870420
X2765 2363 2377 2369 1 2 ND2 $T=429040 780080 1 180 $X=427180 $Y=779700
X2766 2378 2388 2296 1 2 ND2 $T=429040 810320 0 180 $X=427180 $Y=804900
X2767 2328 2385 2284 1 2 ND2 $T=429040 830480 1 180 $X=427180 $Y=830100
X2768 2323 2397 2300 1 2 ND2 $T=430900 780080 1 180 $X=429040 $Y=779700
X2769 2334 2396 2113 1 2 ND2 $T=432140 749840 1 180 $X=430280 $Y=749460
X2770 2303 2344 2335 1 2 ND2 $T=430280 770000 1 0 $X=430280 $Y=764580
X2771 2364 2395 2367 1 2 ND2 $T=432140 830480 0 180 $X=430280 $Y=825060
X2772 2357 2407 2367 1 2 ND2 $T=432140 830480 1 180 $X=430280 $Y=830100
X2773 2328 2354 2364 1 2 ND2 $T=430280 840560 1 0 $X=430280 $Y=835140
X2774 2311 2422 2367 1 2 ND2 $T=432760 840560 1 180 $X=430900 $Y=840180
X2775 2342 255 2364 1 2 ND2 $T=432760 870800 1 180 $X=430900 $Y=870420
X2776 260 2414 2401 1 2 ND2 $T=433380 860720 0 180 $X=431520 $Y=855300
X2777 260 2423 2343 1 2 ND2 $T=433380 860720 1 180 $X=431520 $Y=860340
X2778 2399 2416 2100 1 2 ND2 $T=434000 749840 1 180 $X=432140 $Y=749460
X2779 2370 2411 2339 1 2 ND2 $T=434620 790160 1 180 $X=432760 $Y=789780
X2780 2322 2400 2378 1 2 ND2 $T=432760 810320 1 0 $X=432760 $Y=804900
X2781 2381 2415 2352 1 2 ND2 $T=435240 780080 0 180 $X=433380 $Y=774660
X2782 2416 2420 2396 1 2 ND2 $T=435860 749840 1 180 $X=434000 $Y=749460
X2783 2398 2447 2409 1 2 ND2 $T=435860 830480 1 180 $X=434000 $Y=830100
X2784 2375 2421 2367 1 2 ND2 $T=435860 840560 0 180 $X=434000 $Y=835140
X2785 2394 2430 2382 1 2 ND2 $T=436480 790160 0 180 $X=434620 $Y=784740
X2786 2302 278 2284 1 2 ND2 $T=437720 870800 0 180 $X=435860 $Y=865380
X2787 2433 2476 2436 1 2 ND2 $T=439580 719600 1 180 $X=437720 $Y=719220
X2788 2425 2462 2339 1 2 ND2 $T=439580 800240 0 180 $X=437720 $Y=794820
X2789 2367 2437 2284 1 2 ND2 $T=439580 840560 0 180 $X=437720 $Y=835140
X2790 2365 2459 2355 1 2 ND2 $T=440200 759920 0 180 $X=438340 $Y=754500
X2791 269 268 187 1 2 ND2 $T=440820 699440 1 180 $X=438960 $Y=699060
X2792 2342 272 2284 1 2 ND2 $T=440820 860720 1 180 $X=438960 $Y=860340
X2793 2474 2475 2482 1 2 ND2 $T=442060 719600 0 180 $X=440200 $Y=714180
X2794 2063 2484 2420 1 2 ND2 $T=442060 759920 0 180 $X=440200 $Y=754500
X2795 276 2472 187 1 2 ND2 $T=442680 699440 1 180 $X=440820 $Y=699060
X2796 2429 2483 2427 1 2 ND2 $T=440820 739760 0 0 $X=440820 $Y=739380
X2797 2375 2463 2328 1 2 ND2 $T=440820 840560 1 0 $X=440820 $Y=835140
X2798 271 2432 2485 1 2 ND2 $T=441440 709520 1 0 $X=441440 $Y=704100
X2799 2467 275 273 1 2 ND2 $T=444540 880880 0 180 $X=442680 $Y=875460
X2800 2132 2504 2436 1 2 ND2 $T=445160 719600 1 180 $X=443300 $Y=719220
X2801 2460 2511 2291 1 2 ND2 $T=445780 790160 1 180 $X=443920 $Y=789780
X2802 2488 2487 2500 1 2 ND2 $T=444540 830480 0 0 $X=444540 $Y=830100
X2803 279 2513 2500 1 2 ND2 $T=446400 840560 1 180 $X=444540 $Y=840180
X2804 2448 2474 2099 1 2 ND2 $T=445160 709520 1 0 $X=445160 $Y=704100
X2805 2485 2522 282 1 2 ND2 $T=448260 699440 1 180 $X=446400 $Y=699060
X2806 2507 2536 2291 1 2 ND2 $T=449500 800240 0 180 $X=447640 $Y=794820
X2807 279 2525 2409 1 2 ND2 $T=449500 830480 1 180 $X=447640 $Y=830100
X2808 2302 2481 2311 1 2 ND2 $T=449500 870800 0 180 $X=447640 $Y=865380
X2809 2460 2555 2507 1 2 ND2 $T=450120 790160 1 180 $X=448260 $Y=789780
X2810 2389 2551 2408 1 2 ND2 $T=451360 780080 1 180 $X=449500 $Y=779700
X2811 2514 2548 2132 1 2 ND2 $T=452600 719600 0 180 $X=450740 $Y=714180
X2812 2389 2547 2538 1 2 ND2 $T=452600 780080 0 180 $X=450740 $Y=774660
X2813 2310 2559 2367 1 2 ND2 $T=453220 840560 0 180 $X=451360 $Y=835140
X2814 2311 2553 2328 1 2 ND2 $T=453220 850640 1 180 $X=451360 $Y=850260
X2815 2342 287 2311 1 2 ND2 $T=453840 870800 0 180 $X=451980 $Y=865380
X2816 250 2567 289 1 2 ND2 $T=453840 880880 0 180 $X=451980 $Y=875460
X2817 2408 2558 2538 1 2 ND2 $T=452600 780080 0 0 $X=452600 $Y=779700
X2818 2371 289 2302 1 2 ND2 $T=452600 870800 0 0 $X=452600 $Y=870420
X2819 290 2560 300 1 2 ND2 $T=453840 739760 1 0 $X=453840 $Y=734340
X2820 2575 2570 2414 1 2 ND2 $T=456940 850640 1 180 $X=455080 $Y=850260
X2821 2310 299 2302 1 2 ND2 $T=457560 870800 0 180 $X=455700 $Y=865380
X2822 2565 2531 2573 1 2 ND2 $T=456320 729680 1 0 $X=456320 $Y=724260
X2823 2302 297 2341 1 2 ND2 $T=458180 870800 1 180 $X=456320 $Y=870420
X2824 2371 2593 2367 1 2 ND2 $T=459420 830480 0 0 $X=459420 $Y=830100
X2825 2357 2604 2328 1 2 ND2 $T=461280 850640 1 180 $X=459420 $Y=850260
X2826 2310 302 2342 1 2 ND2 $T=461280 870800 0 180 $X=459420 $Y=865380
X2827 2357 303 2342 1 2 ND2 $T=461280 870800 1 180 $X=459420 $Y=870420
X2828 2598 2544 2477 1 2 ND2 $T=460040 749840 1 0 $X=460040 $Y=744420
X2829 2357 304 2302 1 2 ND2 $T=461900 880880 0 180 $X=460040 $Y=875460
X2830 2310 2588 2328 1 2 ND2 $T=460660 840560 1 0 $X=460660 $Y=835140
X2831 2607 2510 2477 1 2 ND2 $T=461280 759920 0 0 $X=461280 $Y=759540
X2832 2371 2623 2328 1 2 ND2 $T=464380 850640 1 180 $X=462520 $Y=850260
X2833 2627 2626 306 1 2 ND2 $T=465000 719600 1 180 $X=463140 $Y=719220
X2834 2617 2630 2477 1 2 ND2 $T=465000 759920 1 180 $X=463140 $Y=759540
X2835 2624 2638 2395 1 2 ND2 $T=465000 830480 0 180 $X=463140 $Y=825060
X2836 2341 2622 2367 1 2 ND2 $T=465000 840560 1 180 $X=463140 $Y=840180
X2837 2375 311 2302 1 2 ND2 $T=465000 870800 0 180 $X=463140 $Y=865380
X2838 2342 307 2341 1 2 ND2 $T=463140 870800 0 0 $X=463140 $Y=870420
X2839 2341 2625 2328 1 2 ND2 $T=465620 830480 1 180 $X=463760 $Y=830100
X2840 2371 310 2342 1 2 ND2 $T=464380 880880 1 0 $X=464380 $Y=875460
X2841 2571 2646 2635 1 2 ND2 $T=465620 780080 0 0 $X=465620 $Y=779700
X2842 2614 2651 291 1 2 ND2 $T=466240 709520 0 0 $X=466240 $Y=709140
X2843 2659 2660 2477 1 2 ND2 $T=468100 749840 0 180 $X=466240 $Y=744420
X2844 2639 2669 314 1 2 ND2 $T=468720 719600 0 180 $X=466860 $Y=714180
X2845 2662 2644 2682 1 2 ND2 $T=467480 830480 0 0 $X=467480 $Y=830100
X2846 2672 2671 2682 1 2 ND2 $T=468100 820400 1 0 $X=468100 $Y=814980
X2847 2669 2679 2651 1 2 ND2 $T=470580 719600 0 180 $X=468720 $Y=714180
X2848 2673 2628 2664 1 2 ND2 $T=469340 729680 1 0 $X=469340 $Y=724260
X2849 2581 2688 2667 1 2 ND2 $T=471200 770000 1 180 $X=469340 $Y=769620
X2850 2698 2704 2477 1 2 ND2 $T=472440 749840 1 180 $X=470580 $Y=749460
X2851 2375 319 2342 1 2 ND2 $T=472440 870800 0 180 $X=470580 $Y=865380
X2852 2674 2683 277 1 2 ND2 $T=471820 749840 1 0 $X=471820 $Y=744420
X2853 2655 2723 2686 1 2 ND2 $T=473680 850640 0 180 $X=471820 $Y=845220
X2854 2715 2705 2704 1 2 ND2 $T=474300 749840 1 180 $X=472440 $Y=749460
X2855 2654 2708 2701 1 2 ND2 $T=474300 780080 0 180 $X=472440 $Y=774660
X2856 2707 2696 2486 1 2 ND2 $T=474920 770000 0 0 $X=474920 $Y=769620
X2857 2687 2715 2740 1 2 ND2 $T=475540 749840 0 0 $X=475540 $Y=749460
X2858 2741 2734 2727 1 2 ND2 $T=477400 780080 0 180 $X=475540 $Y=774660
X2859 2708 2742 2734 1 2 ND2 $T=478640 770000 1 180 $X=476780 $Y=769620
X2860 348 2761 352 1 2 ND2 $T=482360 870800 0 0 $X=482360 $Y=870420
X2861 2833 2834 2824 1 2 ND2 $T=492900 739760 0 180 $X=491040 $Y=734340
X2862 2695 2822 2796 1 2 ND2 $T=492280 759920 0 0 $X=492280 $Y=759540
X2863 2532 2827 2681 1 2 ND2 $T=493520 810320 1 0 $X=493520 $Y=804900
X2864 2845 2962 375 1 2 ND2 $T=496620 780080 0 180 $X=494760 $Y=774660
X2865 336 2875 366 1 2 ND2 $T=498480 870800 1 0 $X=498480 $Y=865380
X2866 382 381 385 1 2 ND2 $T=499100 699440 0 0 $X=499100 $Y=699060
X2867 2881 2892 2880 1 2 ND2 $T=500960 719600 0 180 $X=499100 $Y=714180
X2868 2895 2897 2886 1 2 ND2 $T=502200 709520 1 180 $X=500340 $Y=709140
X2869 2457 2907 2529 1 2 ND2 $T=502200 800240 0 180 $X=500340 $Y=794820
X2870 378 387 385 1 2 ND2 $T=502820 699440 1 180 $X=500960 $Y=699060
X2871 2849 2896 2854 1 2 ND2 $T=500960 749840 1 0 $X=500960 $Y=744420
X2872 2830 2925 2887 1 2 ND2 $T=505300 759920 0 180 $X=503440 $Y=754500
X2873 2506 2937 2844 1 2 ND2 $T=507160 759920 1 180 $X=505300 $Y=759540
X2874 2958 2960 2541 1 2 ND2 $T=510880 719600 1 180 $X=509020 $Y=719220
X2875 2957 2961 2967 1 2 ND2 $T=509020 739760 1 0 $X=509020 $Y=734340
X2876 2958 2972 2949 1 2 ND2 $T=512740 719600 1 180 $X=510880 $Y=719220
X2877 2541 2991 2949 1 2 ND2 $T=514600 719600 1 180 $X=512740 $Y=719220
X2878 2992 2999 2983 1 2 ND2 $T=514600 729680 0 180 $X=512740 $Y=724260
X2879 2444 410 2976 1 2 ND2 $T=517700 699440 1 180 $X=515840 $Y=699060
X2880 2508 3000 2995 1 2 ND2 $T=515840 830480 1 0 $X=515840 $Y=825060
X2881 2949 3007 2541 1 2 ND2 $T=518320 729680 1 180 $X=516460 $Y=729300
X2882 2944 2973 2905 1 2 ND2 $T=518320 749840 1 0 $X=518320 $Y=744420
X2883 3015 3009 2996 1 2 ND2 $T=520800 759920 0 180 $X=518940 $Y=754500
X2884 3023 3025 3001 1 2 ND2 $T=519560 719600 0 0 $X=519560 $Y=719220
X2885 3024 3031 2983 1 2 ND2 $T=522040 729680 0 180 $X=520180 $Y=724260
X2886 3035 2921 3019 1 2 ND2 $T=522660 780080 1 180 $X=520800 $Y=779700
X2887 2559 3044 2481 1 2 ND2 $T=524520 840560 1 0 $X=524520 $Y=835140
X2888 2517 3014 3023 1 2 ND2 $T=526380 709520 0 0 $X=526380 $Y=709140
X2889 3104 3107 3088 1 2 ND2 $T=536300 759920 1 180 $X=534440 $Y=759540
X2890 3125 3123 3142 1 2 ND2 $T=542500 719600 0 0 $X=542500 $Y=719220
X2891 464 3162 3143 1 2 ND2 $T=549320 729680 1 180 $X=547460 $Y=729300
X2892 460 3151 3176 1 2 ND2 $T=549940 709520 0 0 $X=549940 $Y=709140
X2893 468 3159 3133 1 2 ND2 $T=552420 759920 1 180 $X=550560 $Y=759540
X2894 2884 3182 2437 1 2 ND2 $T=554280 840560 1 0 $X=554280 $Y=835140
X2895 475 3187 3163 1 2 ND2 $T=557380 749840 1 180 $X=555520 $Y=749460
X2896 3152 3220 3194 1 2 ND2 $T=561100 739760 0 180 $X=559240 $Y=734340
X2897 3216 2934 3209 1 2 ND2 $T=560480 810320 1 0 $X=560480 $Y=804900
X2898 490 3247 3223 1 2 ND2 $T=566060 770000 0 180 $X=564200 $Y=764580
X2899 3345 3353 3295 1 2 ND2 $T=582180 800240 1 180 $X=580320 $Y=799860
X2900 395 3326 528 1 2 ND2 $T=584040 840560 0 0 $X=584040 $Y=840180
X2901 524 3346 219 1 2 ND2 $T=585900 870800 1 180 $X=584040 $Y=870420
X2902 3381 3398 3362 1 2 ND2 $T=592100 800240 1 180 $X=590240 $Y=799860
X2903 397 3387 3346 1 2 ND2 $T=595200 870800 1 0 $X=595200 $Y=865380
X2904 544 3366 3419 1 2 ND2 $T=604500 810320 0 180 $X=602640 $Y=804900
X2905 556 3504 3499 1 2 ND2 $T=617520 810320 1 0 $X=617520 $Y=804900
X2906 3527 3546 3331 1 2 ND2 $T=624340 770000 1 180 $X=622480 $Y=769620
X2907 3539 3357 3442 1 2 ND2 $T=627440 830480 1 180 $X=625580 $Y=830100
X2908 3555 3552 3549 1 2 ND2 $T=629920 850640 1 180 $X=628060 $Y=850260
X2909 570 3541 3565 1 2 ND2 $T=629920 810320 0 0 $X=629920 $Y=809940
X2910 3447 3568 3555 1 2 ND2 $T=632400 850640 1 0 $X=632400 $Y=845220
X2911 3575 3585 3592 1 2 ND2 $T=634260 719600 0 0 $X=634260 $Y=719220
X2912 3623 3631 3591 1 2 ND2 $T=641080 830480 1 180 $X=639220 $Y=830100
X2913 3621 3555 3447 1 2 ND2 $T=641080 840560 0 180 $X=639220 $Y=835140
X2914 3588 3612 3617 1 2 ND2 $T=639840 780080 1 0 $X=639840 $Y=774660
X2915 585 3570 3639 1 2 ND2 $T=642320 800240 0 0 $X=642320 $Y=799860
X2916 3650 3628 3630 1 2 ND2 $T=647900 729680 0 180 $X=646040 $Y=724260
X2917 3616 3669 3573 1 2 ND2 $T=649140 739760 0 180 $X=647280 $Y=734340
X2918 3632 3663 3266 1 2 ND2 $T=650380 719600 1 180 $X=648520 $Y=719220
X2919 592 3682 3686 1 2 ND2 $T=654100 759920 1 0 $X=654100 $Y=754500
X2920 3684 3672 3689 1 2 ND2 $T=655340 729680 1 0 $X=655340 $Y=724260
X2921 3673 3701 3696 1 2 ND2 $T=655960 800240 0 0 $X=655960 $Y=799860
X2922 3694 3712 3661 1 2 ND2 $T=659680 759920 0 180 $X=657820 $Y=754500
X2923 3704 3730 3734 1 2 ND2 $T=659060 790160 1 0 $X=659060 $Y=784740
X2924 597 3717 3713 1 2 ND2 $T=659680 729680 1 0 $X=659680 $Y=724260
X2925 3707 3719 3729 1 2 ND2 $T=659680 770000 1 0 $X=659680 $Y=764580
X2926 601 3725 3743 1 2 ND2 $T=661540 719600 0 0 $X=661540 $Y=719220
X2927 3681 3735 3716 1 2 ND2 $T=663400 749840 0 180 $X=661540 $Y=744420
X2928 603 3688 3742 1 2 ND2 $T=662780 709520 0 0 $X=662780 $Y=709140
X2929 3732 3718 3738 1 2 ND2 $T=663400 739760 0 0 $X=663400 $Y=739380
X2930 3711 3755 3745 1 2 ND2 $T=670220 840560 1 0 $X=670220 $Y=835140
X2931 657 4030 4042 1 2 ND2 $T=717960 729680 1 0 $X=717960 $Y=724260
X2932 660 3839 4046 1 2 ND2 $T=718580 709520 1 0 $X=718580 $Y=704100
X2933 658 3852 4051 1 2 ND2 $T=719200 709520 0 0 $X=719200 $Y=709140
X2934 656 3997 4059 1 2 ND2 $T=719200 739760 0 0 $X=719200 $Y=739380
X2935 661 4055 4057 1 2 ND2 $T=719820 850640 1 0 $X=719820 $Y=845220
X2936 4016 4082 4108 1 2 ND2 $T=726640 759920 0 0 $X=726640 $Y=759540
X2937 3996 4125 4153 1 2 ND2 $T=734700 780080 1 0 $X=734700 $Y=774660
X2938 4127 4111 4155 1 2 ND2 $T=738420 719600 0 0 $X=738420 $Y=719220
X2939 696 4149 4168 1 2 ND2 $T=744620 729680 1 0 $X=744620 $Y=724260
X2940 4163 4169 4192 1 2 ND2 $T=744620 790160 0 0 $X=744620 $Y=789780
X2941 703 4174 4210 1 2 ND2 $T=749580 729680 1 0 $X=749580 $Y=724260
X2942 3975 4229 4230 1 2 ND2 $T=754540 739760 0 0 $X=754540 $Y=739380
X2943 4014 4238 4270 1 2 ND2 $T=761980 729680 1 0 $X=761980 $Y=724260
X2944 3621 4159 4273 1 2 ND2 $T=762600 810320 1 0 $X=762600 $Y=804900
X2945 4271 4316 4299 1 2 ND2 $T=772520 780080 0 0 $X=772520 $Y=779700
X2946 4392 4406 4401 1 2 ND2 $T=786160 759920 0 0 $X=786160 $Y=759540
X2947 4434 4423 747 1 2 ND2 $T=796700 770000 1 0 $X=796700 $Y=764580
X2948 4273 4445 4159 1 2 ND2 $T=796700 800240 1 0 $X=796700 $Y=794820
X2949 4447 4438 4368 1 2 ND2 $T=797940 770000 0 0 $X=797940 $Y=769620
X2950 4350 4461 4446 1 2 ND2 $T=801040 749840 1 180 $X=799180 $Y=749460
X2951 4457 4508 4453 1 2 ND2 $T=802280 739760 1 180 $X=800420 $Y=739380
X2952 4159 4426 4459 1 2 ND2 $T=802280 800240 0 180 $X=800420 $Y=794820
X2953 4403 4485 4469 1 2 ND2 $T=804760 780080 1 0 $X=804760 $Y=774660
X2954 4504 4177 4489 1 2 ND2 $T=807860 749840 1 180 $X=806000 $Y=749460
X2955 4292 784 4498 1 2 ND2 $T=806000 880880 1 0 $X=806000 $Y=875460
X2956 4475 4517 4449 1 2 ND2 $T=810340 850640 0 180 $X=808480 $Y=845220
X2957 4430 4512 4292 1 2 ND2 $T=810340 850640 1 180 $X=808480 $Y=850260
X2958 4518 4324 4525 1 2 ND2 $T=810340 759920 0 0 $X=810340 $Y=759540
X2959 4535 4219 4481 1 2 ND2 $T=812820 759920 0 180 $X=810960 $Y=754500
X2960 4443 4386 738 1 2 ND2 $T=814060 749840 1 0 $X=814060 $Y=744420
X2961 4499 4515 4528 1 2 ND2 $T=814060 790160 1 0 $X=814060 $Y=784740
X2962 4619 4648 4653 1 2 ND2 $T=839480 810320 1 0 $X=839480 $Y=804900
X2963 836 4730 4665 1 2 ND2 $T=854980 770000 0 180 $X=853120 $Y=764580
X2964 851 4741 4658 1 2 ND2 $T=865520 749840 1 180 $X=863660 $Y=749460
X2965 854 855 4746 1 2 ND2 $T=868620 699440 1 180 $X=866760 $Y=699060
X2966 858 4773 4675 1 2 ND2 $T=869240 759920 0 180 $X=867380 $Y=754500
X2967 857 4794 4685 1 2 ND2 $T=869860 749840 0 180 $X=868000 $Y=744420
X2968 859 862 4775 1 2 ND2 $T=869860 699440 0 0 $X=869860 $Y=699060
X2969 866 4799 4776 1 2 ND2 $T=873580 709520 1 180 $X=871720 $Y=709140
X2970 869 4833 4772 1 2 ND2 $T=875440 729680 0 180 $X=873580 $Y=724260
X2971 870 4808 4769 1 2 ND2 $T=875440 739760 1 180 $X=873580 $Y=739380
X2972 875 4823 4718 1 2 ND2 $T=877300 729680 1 180 $X=875440 $Y=729300
X2973 879 4702 4759 1 2 ND2 $T=878540 719600 1 0 $X=878540 $Y=714180
X2974 4884 5235 4976 1 2 ND2 $T=980220 860720 0 180 $X=978360 $Y=855300
X2975 5244 5255 4550 1 2 ND2 $T=985800 850640 1 180 $X=983940 $Y=850260
X2976 4550 5254 4976 1 2 ND2 $T=985800 860720 0 180 $X=983940 $Y=855300
X2977 4810 5274 4534 1 2 ND2 $T=993240 860720 0 0 $X=993240 $Y=860340
X2978 5284 5303 5291 1 2 ND2 $T=1004400 860720 0 180 $X=1002540 $Y=855300
X2979 27 1300 1357 1 2 34 AO12 $T=253580 880880 0 180 $X=249860 $Y=875460
X2980 1425 1240 1402 1 2 64 AO12 $T=268460 860720 1 0 $X=268460 $Y=855300
X2981 86 88 61 1 2 1658 AO12 $T=293880 880880 1 0 $X=293880 $Y=875460
X2982 1665 1657 1157 1 2 1489 AO12 $T=298840 749840 1 180 $X=295120 $Y=749460
X2983 63 94 1419 1 2 1736 AO12 $T=308760 850640 1 0 $X=308760 $Y=845220
X2984 1702 1371 1288 1 2 1549 AO12 $T=315580 810320 0 180 $X=311860 $Y=804900
X2985 1626 1407 1480 1 2 1773 AO12 $T=318060 830480 1 0 $X=318060 $Y=825060
X2986 1809 1837 1518 1 2 1946 AO12 $T=353400 840560 1 0 $X=353400 $Y=835140
X2987 2005 1995 1992 1 2 157 AO12 $T=367660 810320 1 180 $X=363940 $Y=809940
X2988 2032 1995 1992 1 2 164 AO12 $T=373860 810320 1 180 $X=370140 $Y=809940
X2989 179 172 174 1 2 117 AO12 $T=382540 880880 0 180 $X=378820 $Y=875460
X2990 235 2299 232 1 2 2292 AO12 $T=419120 860720 0 180 $X=415400 $Y=855300
X2991 395 369 393 1 2 2879 AO12 $T=507780 870800 1 180 $X=504060 $Y=870420
X2992 432 2205 3070 1 2 201 AO12 $T=531340 770000 1 0 $X=531340 $Y=764580
X2993 4085 4107 4078 1 2 4044 AO12 $T=733460 850640 1 0 $X=733460 $Y=845220
X2994 1277 1377 1369 1362 2 1 1271 MAOI1S $T=254820 780080 0 180 $X=249860 $Y=774660
X2995 3346 503 2530 3327 2 1 3320 MAOI1S $T=584040 830480 1 180 $X=579080 $Y=830100
X2996 528 531 459 3387 2 1 3183 MAOI1S $T=587760 870800 1 0 $X=587760 $Y=865380
X2997 1238 10 61 103 1157 1567 2 1 1864 OA222S $T=336660 790160 0 0 $X=336660 $Y=789780
X2998 228 2449 240 2417 251 2466 2 1 2480 OA222S $T=436480 850640 1 0 $X=436480 $Y=845220
X2999 2588 2508 301 2600 2276 2481 2 1 2655 OA222S $T=457560 850640 1 0 $X=457560 $Y=845220
X3000 304 317 2358 2690 319 320 2 1 2478 OA222S $T=468720 870800 0 0 $X=468720 $Y=870420
X3001 2622 2470 321 2600 2578 2407 2 1 2748 OA222S $T=471200 860720 1 0 $X=471200 $Y=855300
X3002 321 2600 350 2784 2464 278 2 1 2802 OA222S $T=481740 870800 1 0 $X=481740 $Y=865380
X3003 406 397 301 2980 2663 319 2 1 2926 OA222S $T=515220 860720 1 180 $X=509640 $Y=860340
X3004 2578 2553 2980 2974 302 2464 2 1 3043 OA222S $T=515220 850640 0 0 $X=515220 $Y=850260
X3005 2588 3010 2604 3018 2385 2978 2 1 3017 OA222S $T=516460 820400 0 0 $X=516460 $Y=820020
X3006 2578 2622 416 392 303 2464 2 1 3020 OA222S $T=524520 860720 0 180 $X=518940 $Y=855300
X3007 2508 2422 2906 2463 2559 2620 2 1 3087 OA222S $T=548700 850640 0 180 $X=543120 $Y=845220
X3008 3010 2624 2995 2422 2912 2463 2 1 3199 OA222S $T=548080 820400 0 0 $X=548080 $Y=820020
X3009 2995 2466 2784 414 2906 2903 2 1 3190 OA222S $T=548700 860720 1 0 $X=548700 $Y=855300
X3010 2437 2636 2906 3205 397 3076 2 1 3243 OA222S $T=561720 830480 0 0 $X=561720 $Y=830100
X3011 513 2980 2508 3124 416 503 2 1 3238 OA222S $T=575980 850640 0 180 $X=570400 $Y=845220
X3012 513 395 321 391 2578 2385 2 1 3058 OA222S $T=584660 850640 0 180 $X=579080 $Y=845220
X3013 3355 3358 3333 3350 3341 3337 2 1 3308 OA222S $T=585280 780080 1 180 $X=579700 $Y=779700
X3014 3358 3339 3314 3350 3351 3337 2 1 3285 OA222S $T=585900 729680 0 180 $X=580320 $Y=724260
X3015 3318 3357 3349 3354 3336 3339 2 1 3271 OA222S $T=585900 729680 1 180 $X=580320 $Y=729300
X3016 3358 3368 3365 3350 3339 3337 2 1 3330 OA222S $T=588380 719600 1 180 $X=582800 $Y=719220
X3017 3373 3358 3341 3350 3344 3337 2 1 3313 OA222S $T=589620 790160 1 180 $X=584040 $Y=789780
X3018 406 2784 2980 3370 2928 3361 2 1 3100 OA222S $T=589620 860720 1 180 $X=584040 $Y=860340
X3019 3262 3357 3373 3349 3355 3336 2 1 3347 OA222S $T=590240 770000 1 180 $X=584660 $Y=769620
X3020 3363 3357 3349 3368 3336 3354 2 1 3293 OA222S $T=592100 739760 0 180 $X=586520 $Y=734340
X3021 3358 3354 3351 3350 3365 3337 2 1 3305 OA222S $T=592720 729680 0 180 $X=587140 $Y=724260
X3022 3344 3358 3332 3350 3333 3337 2 1 3335 OA222S $T=593340 759920 0 180 $X=587760 $Y=754500
X3023 3404 3358 3344 3350 3355 3337 2 1 3383 OA222S $T=595820 790160 1 180 $X=590240 $Y=789780
X3024 3358 3396 3339 3350 3354 3337 2 1 3428 OA222S $T=590860 719600 0 0 $X=590860 $Y=719220
X3025 3382 3357 3404 3349 3373 3336 2 1 3286 OA222S $T=597680 770000 1 180 $X=592100 $Y=769620
X3026 3332 3357 3413 3349 3404 3336 2 1 3393 OA222S $T=598920 780080 1 180 $X=593340 $Y=779700
X3027 3351 3412 3349 3418 3336 3425 2 1 3431 OA222S $T=595200 729680 1 0 $X=595200 $Y=724260
X3028 3392 3412 3349 3396 3336 3368 2 1 3322 OA222S $T=600780 739760 0 180 $X=595200 $Y=734340
X3029 3314 3412 3349 3425 3336 3396 2 1 3317 OA222S $T=603260 729680 1 180 $X=597680 $Y=729300
X3030 3333 3357 3435 3349 3413 3336 2 1 3403 OA222S $T=603880 790160 0 180 $X=598300 $Y=784740
X3031 3413 3358 3355 3350 3373 3337 2 1 3424 OA222S $T=604500 790160 1 180 $X=598920 $Y=789780
X3032 3358 3425 3354 3350 3368 3337 2 1 3451 OA222S $T=600160 719600 0 0 $X=600160 $Y=719220
X3033 3365 3412 3349 3458 3336 3418 2 1 3445 OA222S $T=610080 729680 0 180 $X=604500 $Y=724260
X3034 3435 3358 3373 3350 3404 3337 2 1 3455 OA222S $T=611940 790160 1 180 $X=606360 $Y=789780
X3035 3341 3357 3477 3349 3435 3336 2 1 3438 OA222S $T=613800 790160 0 180 $X=608220 $Y=784740
X3036 3344 3357 3491 3349 3477 3336 2 1 3471 OA222S $T=618140 780080 1 180 $X=612560 $Y=779700
X3037 3358 3418 3368 3350 3396 3337 2 1 3470 OA222S $T=618760 719600 1 180 $X=613180 $Y=719220
X3038 3339 3412 3349 3490 3336 3458 2 1 3480 OA222S $T=618760 729680 0 180 $X=613180 $Y=724260
X3039 3355 3357 3514 3349 3491 3336 2 1 3501 OA222S $T=623100 790160 0 180 $X=617520 $Y=784740
X3040 3435 3337 3514 3523 3413 3350 2 1 3536 OA222S $T=620620 770000 1 0 $X=620620 $Y=764580
X3041 3354 3412 3349 3526 3336 3490 2 1 3534 OA222S $T=621240 729680 1 0 $X=621240 $Y=724260
X3042 3458 3337 3526 3527 3418 3350 2 1 3538 OA222S $T=622480 739760 1 0 $X=622480 $Y=734340
X3043 3477 3337 3514 3527 3435 3350 2 1 3547 OA222S $T=622480 780080 0 0 $X=622480 $Y=779700
X3044 3337 3418 3526 3523 3425 3350 2 1 3508 OA222S $T=629300 729680 1 180 $X=623720 $Y=729300
X3045 3477 3358 3404 3350 3413 3337 2 1 3507 OA222S $T=629300 790160 1 180 $X=623720 $Y=789780
X3046 3358 3458 3396 3350 3425 3337 2 1 3520 OA222S $T=631780 719600 1 180 $X=626200 $Y=719220
X3047 3404 3266 3373 3312 3413 3221 2 1 3574 OA222S $T=626820 790160 1 0 $X=626820 $Y=784740
X3048 3413 3266 3404 3312 3435 3221 2 1 3588 OA222S $T=628680 780080 1 0 $X=628680 $Y=774660
X3049 3266 3425 3312 3396 3221 3418 2 1 3575 OA222S $T=629920 729680 1 0 $X=629920 $Y=724260
X3050 3266 3396 3368 3312 3221 3425 2 1 3597 OA222S $T=631160 739760 1 0 $X=631160 $Y=734340
X3051 3490 3324 3526 3582 3573 3458 2 1 3592 OA222S $T=633020 729680 0 0 $X=633020 $Y=729300
X3052 3491 3324 3514 3582 3477 3573 2 1 3617 OA222S $T=636120 770000 0 0 $X=636120 $Y=769620
X3053 3312 3425 3526 3616 3490 3573 2 1 3630 OA222S $T=638600 729680 1 0 $X=638600 $Y=724260
X3054 3413 3312 3514 3616 3491 3573 2 1 3661 OA222S $T=643560 759920 1 0 $X=643560 $Y=754500
X3055 718 747 748 4308 749 733 2 1 755 OA222S $T=780580 699440 0 0 $X=780580 $Y=699060
X3056 723 4361 4308 734 753 4382 2 1 4400 OA222S $T=782440 739760 0 0 $X=782440 $Y=739380
X3057 726 747 748 4361 749 4308 2 1 760 OA222S $T=783680 709520 1 0 $X=783680 $Y=704100
X3058 762 4382 733 756 4308 752 2 1 4358 OA222S $T=789880 709520 1 180 $X=784300 $Y=709140
X3059 762 4303 4308 756 4361 752 2 1 4385 OA222S $T=790500 719600 0 180 $X=784920 $Y=714180
X3060 721 747 748 4347 749 4303 2 1 4371 OA222S $T=790500 719600 1 180 $X=784920 $Y=719220
X3061 728 747 748 4326 749 4347 2 1 4429 OA222S $T=786160 729680 1 0 $X=786160 $Y=724260
X3062 762 4308 721 756 728 752 2 1 768 OA222S $T=789260 699440 0 0 $X=789260 $Y=699060
X3063 723 4382 734 4361 753 4303 2 1 4457 OA222S $T=791740 739760 0 0 $X=791740 $Y=739380
X3064 734 4382 4433 4434 4326 747 2 1 4446 OA222S $T=791740 749840 0 0 $X=791740 $Y=749460
X3065 752 4303 4433 4436 4382 756 2 1 4396 OA222S $T=797940 729680 1 180 $X=792360 $Y=729300
X3066 762 4361 728 756 733 752 2 1 4450 OA222S $T=792980 709520 1 0 $X=792980 $Y=704100
X3067 724 747 748 4382 749 4361 2 1 772 OA222S $T=793600 709520 0 0 $X=793600 $Y=709140
X3068 732 747 748 4303 749 4382 2 1 4451 OA222S $T=793600 719600 1 0 $X=793600 $Y=714180
X3069 762 4347 4361 756 4382 752 2 1 4478 OA222S $T=793600 719600 0 0 $X=793600 $Y=719220
X3070 4347 752 4433 4443 4303 756 2 1 4352 OA222S $T=799180 739760 0 180 $X=793600 $Y=734340
X3071 4326 737 4433 4441 747 4347 2 1 4453 OA222S $T=793600 749840 1 0 $X=793600 $Y=744420
X3072 733 747 748 4433 749 4326 2 1 4483 OA222S $T=795460 729680 1 0 $X=795460 $Y=724260
X3073 786 747 4472 748 4480 749 2 1 771 OA222S $T=807240 709520 0 180 $X=801660 $Y=704100
X3074 782 747 4484 748 4468 749 2 1 4463 OA222S $T=807240 729680 1 180 $X=801660 $Y=729300
X3075 4472 762 780 756 782 752 2 1 4516 OA222S $T=802280 709520 0 0 $X=802280 $Y=709140
X3076 4506 734 4484 4434 4468 747 2 1 4481 OA222S $T=809100 759920 0 180 $X=803520 $Y=754500
X3077 788 747 4480 748 782 749 2 1 773 OA222S $T=809720 699440 1 180 $X=804140 $Y=699060
X3078 4488 762 4472 756 4506 752 2 1 4513 OA222S $T=805380 729680 1 0 $X=805380 $Y=724260
X3079 4468 737 4484 4441 4488 747 2 1 4489 OA222S $T=810960 749840 0 180 $X=805380 $Y=744420
X3080 783 747 4507 748 4506 749 2 1 4531 OA222S $T=807240 719600 1 0 $X=807240 $Y=714180
X3081 4507 752 4484 4436 4506 756 2 1 4536 OA222S $T=809100 729680 0 0 $X=809100 $Y=729300
X3082 4488 752 4484 4443 4507 756 2 1 4551 OA222S $T=809720 739760 0 0 $X=809720 $Y=739380
X3083 4506 723 4472 734 4507 753 2 1 4504 OA222S $T=815920 749840 1 180 $X=810340 $Y=749460
X3084 790 747 4506 748 4472 749 2 1 797 OA222S $T=810960 709520 1 0 $X=810960 $Y=704100
X3085 4480 762 792 756 780 752 2 1 798 OA222S $T=813440 699440 0 0 $X=813440 $Y=699060
X3086 4507 762 4480 756 4472 752 2 1 4542 OA222S $T=820260 719600 1 180 $X=814680 $Y=719220
X3087 792 747 4488 748 4507 749 2 1 4570 OA222S $T=814680 729680 1 0 $X=814680 $Y=724260
X3088 780 747 4468 748 4488 749 2 1 4565 OA222S $T=814680 729680 0 0 $X=814680 $Y=729300
X3089 4506 762 782 756 4480 752 2 1 4555 OA222S $T=822740 709520 1 180 $X=817160 $Y=709140
X3090 4472 723 4480 734 4506 753 2 1 4563 OA222S $T=824600 749840 0 180 $X=819020 $Y=744420
X3091 1278 26 29 2 1 ND2S $T=240560 719600 0 0 $X=240560 $Y=719220
X3092 1405 1362 1428 2 1 ND2S $T=257300 780080 0 0 $X=257300 $Y=779700
X3093 1502 1503 1492 2 1 ND2S $T=272180 739760 0 180 $X=270320 $Y=734340
X3094 1649 1553 1472 2 1 ND2S $T=295120 719600 0 0 $X=295120 $Y=719220
X3095 1730 1611 1287 2 1 ND2S $T=313100 830480 0 180 $X=311240 $Y=825060
X3096 1281 1725 7 2 1 ND2S $T=314340 709520 0 180 $X=312480 $Y=704100
X3097 1775 93 117 2 1 ND2S $T=326120 880880 1 0 $X=326120 $Y=875460
X3098 123 1821 1814 2 1 ND2S $T=334800 699440 1 180 $X=332940 $Y=699060
X3099 1857 1854 1847 2 1 ND2S $T=340380 719600 0 180 $X=338520 $Y=714180
X3100 1859 1860 1849 2 1 ND2S $T=341000 709520 0 180 $X=339140 $Y=704100
X3101 1852 1371 117 2 1 ND2S $T=339140 830480 1 0 $X=339140 $Y=825060
X3102 1839 1685 1875 2 1 ND2S $T=341000 830480 0 0 $X=341000 $Y=830100
X3103 1852 1825 1875 2 1 ND2S $T=342240 830480 1 0 $X=342240 $Y=825060
X3104 1879 1643 117 2 1 ND2S $T=342860 790160 1 0 $X=342860 $Y=784740
X3105 1879 1808 1875 2 1 ND2S $T=346580 790160 1 0 $X=346580 $Y=784740
X3106 142 1693 117 2 1 ND2S $T=347200 880880 1 0 $X=347200 $Y=875460
X3107 1907 25 1875 2 1 ND2S $T=350300 790160 1 0 $X=350300 $Y=784740
X3108 1928 1657 1875 2 1 ND2S $T=354020 780080 0 0 $X=354020 $Y=779700
X3109 1928 1779 117 2 1 ND2S $T=354020 790160 1 0 $X=354020 $Y=784740
X3110 1863 1943 1945 2 1 ND2S $T=355260 719600 0 0 $X=355260 $Y=719220
X3111 1938 104 1920 2 1 ND2S $T=355260 870800 1 0 $X=355260 $Y=865380
X3112 1962 132 1920 2 1 ND2S $T=359600 860720 0 0 $X=359600 $Y=860340
X3113 1963 1809 1974 2 1 ND2S $T=360220 800240 0 0 $X=360220 $Y=799860
X3114 1938 118 1989 2 1 ND2S $T=360840 870800 1 0 $X=360840 $Y=865380
X3115 1962 1843 1989 2 1 ND2S $T=363320 860720 0 0 $X=363320 $Y=860340
X3116 117 1536 2011 2 1 ND2S $T=364560 800240 0 0 $X=364560 $Y=799860
X3117 1974 1979 2045 2 1 ND2S $T=371380 860720 0 0 $X=371380 $Y=860340
X3118 1980 1911 2057 2 1 ND2S $T=376340 800240 0 0 $X=376340 $Y=799860
X3119 2205 202 189 2 1 ND2S $T=401760 860720 1 180 $X=399900 $Y=860340
X3120 209 2230 208 2 1 ND2S $T=406720 709520 1 180 $X=404860 $Y=709140
X3121 195 216 198 2 1 ND2S $T=407340 840560 1 180 $X=405480 $Y=840180
X3122 2337 2353 2369 2 1 ND2S $T=429040 790160 1 0 $X=429040 $Y=784740
X3123 260 2424 241 2 1 ND2S $T=433380 870800 0 180 $X=431520 $Y=865380
X3124 2155 2456 2427 2 1 ND2S $T=437720 739760 0 180 $X=435860 $Y=734340
X3125 2489 2443 2492 2 1 ND2S $T=443300 709520 1 0 $X=443300 $Y=704100
X3126 2628 2642 2645 2 1 ND2S $T=464380 729680 1 0 $X=464380 $Y=724260
X3127 2636 2657 2578 2 1 ND2S $T=466240 810320 0 180 $X=464380 $Y=804900
X3128 2684 2569 2566 2 1 ND2S $T=470580 790160 1 180 $X=468720 $Y=789780
X3129 2653 2667 2515 2 1 ND2S $T=472440 780080 0 180 $X=470580 $Y=774660
X3130 2672 2592 2620 2 1 ND2S $T=471820 810320 1 0 $X=471820 $Y=804900
X3131 2619 2749 2398 2 1 ND2S $T=478640 820400 1 0 $X=478640 $Y=814980
X3132 2891 2868 2872 2 1 ND2S $T=500340 709520 0 180 $X=498480 $Y=704100
X3133 2874 2877 2893 2 1 ND2S $T=499720 719600 0 0 $X=499720 $Y=719220
X3134 3006 3001 2999 2 1 ND2S $T=516460 729680 0 180 $X=514600 $Y=724260
X3135 2470 3121 2906 2 1 ND2S $T=535680 840560 0 0 $X=535680 $Y=840180
X3136 2508 3096 2682 2 1 ND2S $T=541260 850640 0 180 $X=539400 $Y=845220
X3137 2418 3140 2619 2 1 ND2S $T=546220 840560 0 0 $X=546220 $Y=840180
X3138 485 3082 370 2 1 ND2S $T=561720 880880 1 0 $X=561720 $Y=875460
X3139 358 3186 352 2 1 ND2S $T=574740 840560 0 180 $X=572880 $Y=835140
X3140 3440 3441 3434 2 1 ND2S $T=602640 850640 1 180 $X=600780 $Y=850260
X3141 3466 3463 3439 2 1 ND2S $T=608840 850640 1 180 $X=606980 $Y=850260
X3142 3427 577 3449 2 1 ND2S $T=629920 870800 0 0 $X=629920 $Y=870420
X3143 4120 4143 4155 2 1 ND2S $T=737180 729680 1 0 $X=737180 $Y=724260
X3144 679 4155 4158 2 1 ND2S $T=739040 729680 1 0 $X=739040 $Y=724260
X3145 4511 4388 4368 2 1 ND2S $T=809720 820400 0 180 $X=807860 $Y=814980
X3146 4432 4573 4530 2 1 ND2S $T=820880 810320 1 0 $X=820880 $Y=804900
X3147 5244 5248 4884 2 1 ND2S $T=982700 850640 1 180 $X=980840 $Y=850260
X3148 5284 5286 4810 2 1 ND2S $T=1000680 860720 0 180 $X=998820 $Y=855300
X3149 5291 5260 4534 2 1 ND2S $T=1003160 860720 1 180 $X=1001300 $Y=860340
X3150 1178 1205 1 1168 1191 2 1165 1184 1174 OAI222S $T=233740 790160 0 180 $X=228160 $Y=784740
X3151 1165 1174 1 1173 1191 2 1211 1103 1239 OAI222S $T=228780 780080 0 0 $X=228780 $Y=779700
X3152 1234 1238 1 1230 1226 2 1219 17 1157 OAI222S $T=237460 790160 1 180 $X=231880 $Y=789780
X3153 1181 25 1 1254 1206 2 1230 1224 1221 OAI222S $T=240560 800240 0 180 $X=234980 $Y=794820
X3154 1194 1157 1 1298 1105 2 1312 1319 1239 OAI222S $T=240560 759920 0 0 $X=240560 $Y=759540
X3155 1383 33 1 1285 1157 2 1356 1351 1238 OAI222S $T=254200 749840 0 180 $X=248620 $Y=744420
X3156 57 18 1 1257 1223 2 51 1453 28 OAI222S $T=268460 719600 0 180 $X=262880 $Y=714180
X3157 61 63 1 1154 1191 2 1206 1491 1183 OAI222S $T=273420 800240 1 180 $X=267840 $Y=799860
X3158 1191 1293 1 1540 18 2 1457 1527 1427 OAI222S $T=279620 739760 0 180 $X=274040 $Y=734340
X3159 1262 1357 1 1614 1208 2 1425 1674 1148 OAI222S $T=300080 850640 1 0 $X=300080 $Y=845220
X3160 1428 1457 1 96 61 2 1585 1347 1729 OAI222S $T=303800 820400 1 0 $X=303800 $Y=814980
X3161 1744 1181 1 1721 28 2 1680 1550 33 OAI222S $T=313720 719600 0 180 $X=308140 $Y=714180
X3162 1647 1174 1 1730 1729 2 1715 1717 1288 OAI222S $T=309380 820400 0 0 $X=309380 $Y=820020
X3163 1734 1238 1 1742 1239 2 1745 1639 1345 OAI222S $T=311240 759920 1 0 $X=311240 $Y=754500
X3164 1313 1183 1 1148 1357 2 1585 1765 1729 OAI222S $T=317440 840560 1 0 $X=317440 $Y=835140
X3165 1419 71 1 110 56 2 1754 1757 61 OAI222S $T=323020 870800 1 180 $X=317440 $Y=870420
X3166 1643 1223 1 1282 1221 2 1457 1732 1427 OAI222S $T=322400 790160 1 0 $X=322400 $Y=784740
X3167 1238 1825 1 1480 1240 2 1282 1613 1222 OAI222S $T=336040 830480 0 180 $X=330460 $Y=825060
X3168 126 1348 1 1609 101 2 1815 1823 104 OAI222S $T=336660 870800 1 180 $X=331080 $Y=870420
X3169 1807 18 1 1811 33 2 1834 1838 1181 OAI222S $T=332940 719600 1 0 $X=332940 $Y=714180
X3170 10 1223 1 1407 1374 2 1402 1818 1105 OAI222S $T=338520 800240 0 180 $X=332940 $Y=794820
X3171 1425 1809 1 1203 1843 2 1837 1831 1357 OAI222S $T=341620 860720 1 180 $X=336040 $Y=860340
X3172 1869 1223 1 1858 1277 2 1888 1752 1345 OAI222S $T=342860 749840 0 0 $X=342860 $Y=749460
X3173 50 1889 1 1896 1435 2 1901 1908 1240 OAI222S $T=345960 860720 0 0 $X=345960 $Y=860340
X3174 2299 2358 1 240 2325 2 2282 2295 2320 OAI222S $T=427800 850640 0 180 $X=422220 $Y=845220
X3175 248 2421 1 245 2463 2 2469 2453 2481 OAI222S $T=437100 850640 0 0 $X=437100 $Y=850260
X3176 2690 2470 1 2703 2593 2 2466 2722 2662 OAI222S $T=476780 830480 1 180 $X=471200 $Y=830100
X3177 384 2732 1 2724 352 2 379 2862 2784 OAI222S $T=501580 870800 1 180 $X=496000 $Y=870420
X3178 2724 380 1 2884 2508 2 2864 2904 2682 OAI222S $T=497860 850640 0 0 $X=497860 $Y=850260
X3179 2463 2912 1 2622 2906 2 2385 2878 2682 OAI222S $T=502820 810320 0 0 $X=502820 $Y=809940
X3180 2424 2481 1 2928 394 2 369 2890 399 OAI222S $T=502820 870800 1 0 $X=502820 $Y=865380
X3181 2508 2407 1 2481 2663 2 2421 2942 2578 OAI222S $T=512120 850640 0 180 $X=506540 $Y=845220
X3182 2995 2407 1 2693 2385 2 2600 2979 352 OAI222S $T=515840 840560 0 180 $X=510260 $Y=835140
X3183 2995 2588 1 2622 2906 2 2682 2994 2625 OAI222S $T=516460 830480 1 180 $X=510880 $Y=830100
X3184 2385 2508 1 2682 2625 2 2622 3051 2620 OAI222S $T=529480 810320 1 180 $X=523900 $Y=809940
X3185 428 416 1 2502 2620 2 274 3057 420 OAI222S $T=530720 860720 1 180 $X=525140 $Y=860340
X3186 2566 2354 1 431 416 2 2693 3078 2623 OAI222S $T=534440 830480 1 180 $X=528860 $Y=830100
X3187 455 395 1 2566 2481 2 2662 3138 2422 OAI222S $T=547460 840560 0 180 $X=541880 $Y=835140
X3188 2672 2422 1 2718 2625 2 471 3181 395 OAI222S $T=549320 810320 0 0 $X=549320 $Y=809940
X3189 499 3168 1 274 506 2 364 3276 397 OAI222S $T=570400 880880 1 0 $X=570400 $Y=875460
X3190 3339 3331 1 3324 3314 2 3312 3299 3222 OAI222S $T=582800 739760 0 180 $X=577220 $Y=734340
X3191 3331 3344 1 3324 3332 2 3312 3306 3232 OAI222S $T=584660 759920 1 180 $X=579080 $Y=759540
X3192 3331 3355 1 3324 3333 2 3312 3315 3283 OAI222S $T=584660 780080 0 180 $X=579080 $Y=774660
X3193 3331 3354 1 3324 3351 2 3312 3356 3318 OAI222S $T=587760 749840 0 180 $X=582180 $Y=744420
X3194 3331 3373 1 3324 3341 2 3312 3375 3262 OAI222S $T=594580 780080 0 180 $X=589000 $Y=774660
X3195 3396 3331 1 3324 3339 2 3312 3406 3392 OAI222S $T=600780 739760 1 180 $X=595200 $Y=739380
X3196 3331 3368 1 3324 3365 2 3312 3408 3363 OAI222S $T=600780 749840 0 180 $X=595200 $Y=744420
X3197 3331 3404 1 3324 3344 2 3312 3426 3382 OAI222S $T=604500 770000 0 180 $X=598920 $Y=764580
X3198 3331 3413 1 3324 3355 2 3312 3437 3332 OAI222S $T=600160 780080 1 0 $X=600160 $Y=774660
X3199 3425 3331 1 3324 3354 2 3312 3462 3314 OAI222S $T=610080 739760 1 180 $X=604500 $Y=739380
X3200 3418 3331 1 3324 3368 2 3312 3465 3351 OAI222S $T=610700 739760 0 180 $X=605120 $Y=734340
X3201 3331 3435 1 3324 3373 2 3312 3472 3333 OAI222S $T=614420 780080 0 180 $X=608840 $Y=774660
X3202 3331 3477 1 3324 3404 2 3312 3474 3341 OAI222S $T=615040 770000 0 180 $X=609460 $Y=764580
X3203 3458 3331 1 3396 3324 2 3312 3494 3365 OAI222S $T=619380 739760 0 180 $X=613800 $Y=734340
X3204 3490 3266 1 3632 3526 2 3458 3622 3312 OAI222S $T=647280 719600 1 180 $X=641700 $Y=719220
X3205 3266 3491 1 3632 3514 2 3312 3642 3477 OAI222S $T=651000 749840 1 180 $X=645420 $Y=749460
X3206 738 4308 1 737 721 2 734 4304 718 OAI222S $T=776860 699440 1 180 $X=771280 $Y=699060
X3207 4361 738 1 737 728 2 734 4325 726 OAI222S $T=779960 709520 0 180 $X=774380 $Y=704100
X3208 4382 738 1 737 733 2 734 4341 724 OAI222S $T=781820 719600 0 180 $X=776240 $Y=714180
X3209 4303 738 1 737 4308 2 734 4322 732 OAI222S $T=776240 719600 0 0 $X=776240 $Y=719220
X3210 4347 738 1 4361 737 2 734 4372 721 OAI222S $T=777480 729680 1 0 $X=777480 $Y=724260
X3211 4326 723 1 4447 4433 2 4347 4437 734 OAI222S $T=800420 759920 1 180 $X=794840 $Y=759540
X3212 4368 4468 1 4447 4484 2 734 4336 4488 OAI222S $T=801040 770000 1 0 $X=801040 $Y=764580
X3213 738 4507 1 737 4480 2 734 4611 783 OAI222S $T=823360 719600 0 0 $X=823360 $Y=719220
X3214 738 4488 1 737 4472 2 734 4617 792 OAI222S $T=824600 729680 1 0 $X=824600 $Y=724260
X3215 738 4480 1 737 792 2 734 4606 788 OAI222S $T=831420 699440 1 180 $X=825840 $Y=699060
X3216 738 4506 1 737 782 2 734 4577 790 OAI222S $T=825840 719600 1 0 $X=825840 $Y=714180
X3217 738 4472 1 737 780 2 734 4607 786 OAI222S $T=832040 709520 0 180 $X=826460 $Y=704100
X3218 1174 1169 1 1133 1094 1099 2 OAI112HS $T=226300 800240 1 180 $X=221960 $Y=799860
X3219 1238 1209 1 1204 1220 1214 2 OAI112HS $T=236840 810320 0 180 $X=232500 $Y=804900
X3220 1313 27 1 1269 1188 1245 2 OAI112HS $T=241800 860720 0 180 $X=237460 $Y=855300
X3221 1281 1277 1 1268 1244 1260 2 OAI112HS $T=242420 820400 1 180 $X=238080 $Y=820020
X3222 1222 1147 1 1289 1292 1308 2 OAI112HS $T=239320 840560 1 0 $X=239320 $Y=835140
X3223 1345 1211 1 1388 1400 1340 2 OAI112HS $T=259780 790160 0 180 $X=255440 $Y=784740
X3224 1413 1435 1 1442 1330 1438 2 OAI112HS $T=265360 840560 1 180 $X=261020 $Y=840180
X3225 1238 1172 1 64 1511 1569 2 OAI112HS $T=269700 749840 1 0 $X=269700 $Y=744420
X3226 47 1181 1 1681 1671 1490 2 OAI112HS $T=303180 790160 1 180 $X=298840 $Y=789780
X3227 1911 1762 1 1531 1918 1281 2 OAI112HS $T=360840 790160 1 180 $X=356500 $Y=789780
X3228 1425 1974 1 1964 1954 1946 2 OAI112HS $T=363940 840560 0 180 $X=359600 $Y=835140
X3229 114 1979 1 1934 1968 1837 2 OAI112HS $T=364560 880880 0 180 $X=360220 $Y=875460
X3230 1979 167 1 2029 2004 2039 2 OAI112HS $T=370760 860720 1 0 $X=370760 $Y=855300
X3231 1997 2044 1 2053 1988 2066 2 OAI112HS $T=373860 830480 0 0 $X=373860 $Y=830100
X3232 2209 205 1 2217 2242 2229 2 OAI112HS $T=401140 870800 1 0 $X=401140 $Y=865380
X3233 2473 2684 1 2743 2721 2749 2 OAI112HS $T=474920 820400 0 0 $X=474920 $Y=820020
X3234 338 2600 1 2731 2783 2774 2 OAI112HS $T=479260 860720 1 0 $X=479260 $Y=855300
X3235 2620 2593 1 390 2917 2802 2 OAI112HS $T=500340 850640 1 0 $X=500340 $Y=845220
X3236 2578 2422 1 2955 2964 2826 2 OAI112HS $T=513360 800240 1 180 $X=509020 $Y=799860
X3237 270 2600 1 2986 3003 2955 2 OAI112HS $T=510880 870800 1 0 $X=510880 $Y=865380
X3238 307 2464 1 415 3030 2859 2 OAI112HS $T=517700 860720 0 0 $X=517700 $Y=860340
X3239 2604 3037 1 3054 3056 3059 2 OAI112HS $T=522660 790160 0 0 $X=522660 $Y=789780
X3240 444 408 1 445 3120 219 2 OAI112HS $T=537540 880880 1 0 $X=537540 $Y=875460
X3241 2508 3135 1 3140 2956 462 2 OAI112HS $T=543740 850640 0 0 $X=543740 $Y=850260
X3242 3168 3249 1 2749 3261 3140 2 OAI112HS $T=565440 850640 1 0 $X=565440 $Y=845220
X3243 3442 3439 1 3221 540 3427 2 OAI112HS $T=604500 870800 0 180 $X=600160 $Y=865380
X3244 3434 3442 1 3449 545 3463 2 OAI112HS $T=602020 870800 0 0 $X=602020 $Y=870420
X3245 3442 3417 1 3475 552 3463 2 OAI112HS $T=608220 870800 1 0 $X=608220 $Y=865380
X3246 3434 3442 1 3489 555 3518 2 OAI112HS $T=612560 870800 0 0 $X=612560 $Y=870420
X3247 3690 594 1 3685 3683 3607 2 OAI112HS $T=658440 830480 1 180 $X=654100 $Y=830100
X3248 594 3720 1 3699 3692 3670 2 OAI112HS $T=660300 840560 1 180 $X=655960 $Y=840180
X3249 3721 594 1 3700 3693 3660 2 OAI112HS $T=660300 870800 1 180 $X=655960 $Y=870420
X3250 3774 594 1 3715 3708 3671 2 OAI112HS $T=663400 860720 1 180 $X=659060 $Y=860340
X3251 3744 594 1 3731 3709 3640 2 OAI112HS $T=666500 850640 1 180 $X=662160 $Y=850260
X3252 594 3745 1 3740 3727 3625 2 OAI112HS $T=668360 820400 1 180 $X=664020 $Y=820020
X3253 4213 4181 1 4164 4167 4185 2 OAI112HS $T=750200 810320 1 180 $X=745860 $Y=809940
X3254 4190 4121 1 4173 4179 4216 2 OAI112HS $T=748960 780080 0 0 $X=748960 $Y=779700
X3255 4121 4192 1 4207 4235 4227 2 OAI112HS $T=751440 790160 1 0 $X=751440 $Y=784740
X3256 4156 4121 1 4189 4253 4244 2 OAI112HS $T=753920 830480 1 0 $X=753920 $Y=825060
X3257 4186 4121 1 4203 4274 4265 2 OAI112HS $T=756400 820400 0 0 $X=756400 $Y=820020
X3258 4121 4185 1 4232 4264 4223 2 OAI112HS $T=757640 810320 1 0 $X=757640 $Y=804900
X3259 4248 4121 1 4254 4284 4279 2 OAI112HS $T=760740 800240 1 0 $X=760740 $Y=794820
X3260 4233 4121 1 4218 4277 4281 2 OAI112HS $T=762600 810320 0 0 $X=762600 $Y=809940
X3261 4258 4121 1 4243 4285 4214 2 OAI112HS $T=763840 820400 1 0 $X=763840 $Y=814980
X3262 4469 4528 1 753 4544 4511 2 OAI112HS $T=811580 810320 1 0 $X=811580 $Y=804900
X3263 4530 4469 1 4368 4548 4515 2 OAI112HS $T=812820 820400 1 0 $X=812820 $Y=814980
X3264 4469 4561 1 4588 4585 4515 2 OAI112HS $T=827080 810320 0 180 $X=822740 $Y=804900
X3265 4530 4469 1 4526 4610 4452 2 OAI112HS $T=825220 810320 0 0 $X=825220 $Y=809940
X3266 1206 1 1212 1223 1106 1232 2 OAI22S $T=231260 810320 0 0 $X=231260 $Y=809940
X3267 28 1 1333 33 1344 37 2 OAI22S $T=245520 699440 0 0 $X=245520 $Y=699060
X3268 43 1 1116 1421 1437 1300 2 OAI22S $T=258540 830480 0 0 $X=258540 $Y=830100
X3269 1199 1 1425 1263 1432 1240 2 OAI22S $T=258540 850640 0 0 $X=258540 $Y=850260
X3270 1181 1 1610 1413 1568 1619 2 OAI22S $T=286440 759920 0 0 $X=286440 $Y=759540
X3271 1288 1 1587 1238 1705 1707 2 OAI22S $T=303180 780080 0 0 $X=303180 $Y=779700
X3272 1766 1 25 1239 1135 1733 2 OAI22S $T=321160 749840 1 180 $X=317440 $Y=749460
X3273 1288 1 1783 1277 1813 1822 2 OAI22S $T=330460 780080 0 0 $X=330460 $Y=779700
X3274 1345 1 1703 33 1841 1853 2 OAI22S $T=335420 749840 1 0 $X=335420 $Y=744420
X3275 1157 1 1840 1345 1855 1710 2 OAI22S $T=342860 759920 1 180 $X=339140 $Y=759540
X3276 1407 1 1898 1191 1919 1917 2 OAI22S $T=350300 800240 0 0 $X=350300 $Y=799860
X3277 308 1 274 2276 2609 2481 2 OAI22S $T=464380 860720 1 180 $X=460660 $Y=860340
X3278 397 1 3080 2470 3062 3105 2 OAI22S $T=532580 860720 1 0 $X=532580 $Y=855300
X3279 3447 1 3496 3401 3492 3456 2 OAI22S $T=618760 840560 1 180 $X=615040 $Y=840180
X3280 3946 1 711 710 709 707 2 OAI22S $T=759500 880880 0 180 $X=755780 $Y=875460
X3281 716 1 3946 719 720 710 2 OAI22S $T=761980 880880 1 0 $X=761980 $Y=875460
X3282 716 1 653 719 731 727 2 OAI22S $T=772520 870800 1 180 $X=768800 $Y=870420
X3283 754 1 711 758 761 707 2 OAI22S $T=786160 880880 1 0 $X=786160 $Y=875460
X3284 716 1 4025 719 769 770 2 OAI22S $T=795460 880880 1 0 $X=795460 $Y=875460
X3285 4025 1 711 770 775 707 2 OAI22S $T=799180 880880 1 0 $X=799180 $Y=875460
X3286 4273 1 4452 4501 4444 4495 2 OAI22S $T=804760 800240 0 0 $X=804760 $Y=799860
X3287 4527 1 3984 4487 4534 3984 2 OAI22S $T=816540 860720 0 180 $X=812820 $Y=855300
X3288 4538 1 3965 707 793 3965 2 OAI22S $T=814060 870800 0 0 $X=814060 $Y=870420
X3289 4527 1 3965 4487 4550 3965 2 OAI22S $T=819020 850640 1 180 $X=815300 $Y=850260
X3290 4538 1 3984 707 795 3984 2 OAI22S $T=815300 870800 1 0 $X=815300 $Y=865380
X3291 4538 1 619 707 796 619 2 OAI22S $T=815300 880880 1 0 $X=815300 $Y=875460
X3292 4538 1 3858 707 800 3858 2 OAI22S $T=821500 870800 1 180 $X=817780 $Y=870420
X3293 4758 1 4538 4784 4771 4517 2 OAI22S $T=869240 780080 0 0 $X=869240 $Y=779700
X3294 4770 1 4538 4788 4766 4517 2 OAI22S $T=869240 800240 0 0 $X=869240 $Y=799860
X3295 4527 1 4758 4487 4803 4784 2 OAI22S $T=876680 780080 1 180 $X=872960 $Y=779700
X3296 4527 1 3858 4487 4810 3858 2 OAI22S $T=877920 860720 1 180 $X=874200 $Y=860340
X3297 4779 1 4538 4813 4804 4517 2 OAI22S $T=878540 800240 1 180 $X=874820 $Y=799860
X3298 4825 1 4538 4819 4815 4517 2 OAI22S $T=879160 830480 1 180 $X=875440 $Y=830100
X3299 4679 1 4538 4826 4790 4517 2 OAI22S $T=880400 780080 1 180 $X=876680 $Y=779700
X3300 4527 1 4779 4487 4824 4813 2 OAI22S $T=880400 800240 0 180 $X=876680 $Y=794820
X3301 4829 1 809 4834 4141 841 2 OAI22S $T=877920 780080 1 0 $X=877920 $Y=774660
X3302 4527 1 4770 4487 4838 4788 2 OAI22S $T=883500 800240 1 180 $X=879780 $Y=799860
X3303 4527 1 4679 4487 4851 4826 2 OAI22S $T=886600 780080 1 180 $X=882880 $Y=779700
X3304 4527 1 4825 4487 4856 4819 2 OAI22S $T=887220 830480 0 180 $X=883500 $Y=825060
X3305 4843 1 4538 4860 4866 4517 2 OAI22S $T=884120 780080 1 0 $X=884120 $Y=774660
X3306 4527 1 4858 4487 4870 4864 2 OAI22S $T=884740 810320 0 0 $X=884740 $Y=809940
X3307 4858 1 4538 4864 4871 4517 2 OAI22S $T=884740 820400 1 0 $X=884740 $Y=814980
X3308 4527 1 4778 4487 891 4868 2 OAI22S $T=885360 759920 0 0 $X=885360 $Y=759540
X3309 4778 1 4538 4868 4816 4517 2 OAI22S $T=885360 790160 1 0 $X=885360 $Y=784740
X3310 4527 1 4843 4487 4873 4860 2 OAI22S $T=885980 770000 0 0 $X=885980 $Y=769620
X3311 4887 1 4538 4894 4889 4517 2 OAI22S $T=895280 830480 0 0 $X=895280 $Y=830100
X3312 4527 1 4887 4487 4896 4894 2 OAI22S $T=900240 830480 0 180 $X=896520 $Y=825060
X3313 4945 1 4538 4925 4921 4517 2 OAI22S $T=905200 830480 0 180 $X=901480 $Y=825060
X3314 4923 1 4538 4936 4944 4517 2 OAI22S $T=902720 780080 1 0 $X=902720 $Y=774660
X3315 4943 1 4538 4960 4928 4517 2 OAI22S $T=905820 770000 0 0 $X=905820 $Y=769620
X3316 4947 1 4538 4961 4914 4517 2 OAI22S $T=905820 790160 1 0 $X=905820 $Y=784740
X3317 4527 1 4917 4487 4966 4902 2 OAI22S $T=906440 759920 0 0 $X=906440 $Y=759540
X3318 4527 1 4923 4487 4967 4936 2 OAI22S $T=906440 770000 1 0 $X=906440 $Y=764580
X3319 4931 1 4538 4957 4953 4517 2 OAI22S $T=910160 780080 0 180 $X=906440 $Y=774660
X3320 4917 1 4538 4902 4971 4517 2 OAI22S $T=908300 790160 0 0 $X=908300 $Y=789780
X3321 4527 1 4931 4487 4977 4957 2 OAI22S $T=913260 770000 1 180 $X=909540 $Y=769620
X3322 4969 1 4538 4984 923 4517 2 OAI22S $T=909540 810320 0 0 $X=909540 $Y=809940
X3323 4527 1 619 4487 4976 619 2 OAI22S $T=913260 860720 0 180 $X=909540 $Y=855300
X3324 4527 1 4947 4487 4986 4961 2 OAI22S $T=910160 759920 1 0 $X=910160 $Y=754500
X3325 4527 1 4950 4487 4981 4973 2 OAI22S $T=913880 759920 1 180 $X=910160 $Y=759540
X3326 4527 1 4945 4487 4985 4925 2 OAI22S $T=914500 830480 0 180 $X=910780 $Y=825060
X3327 4950 1 4538 4973 4999 4517 2 OAI22S $T=916980 770000 1 180 $X=913260 $Y=769620
X3328 4527 1 4969 4487 5005 4984 2 OAI22S $T=919460 810320 0 180 $X=915740 $Y=804900
X3329 4527 1 4943 4487 5027 4960 2 OAI22S $T=924420 770000 0 180 $X=920700 $Y=764580
X3330 1288 1472 1426 1223 2 1 1542 OA22S $T=270320 780080 0 0 $X=270320 $Y=779700
X3331 1851 1305 1407 1352 2 1 1776 OA22S $T=340380 800240 1 180 $X=336040 $Y=799860
X3332 2414 2481 2464 272 2 1 2577 OA22S $T=452600 860720 0 0 $X=452600 $Y=860340
X3333 2600 364 2724 338 2 1 2847 OA22S $T=490420 870800 1 0 $X=490420 $Y=865380
X3334 392 2801 2906 2903 2 1 2883 OA22S $T=505300 840560 0 180 $X=500960 $Y=835140
X3335 2470 2903 2578 2864 2 1 2914 OA22S $T=508400 830480 1 180 $X=504060 $Y=830100
X3336 2928 414 369 338 2 1 2986 OA22S $T=521420 870800 0 180 $X=517080 $Y=865380
X3337 2620 2466 2980 370 2 1 3150 OA22S $T=544360 860720 1 0 $X=544360 $Y=855300
X3338 2212 2215 2 2222 1 2178 AOI12HS $T=401760 780080 0 0 $X=401760 $Y=779700
X3339 2099 2519 2 2533 1 2509 AOI12HS $T=448880 709520 0 0 $X=448880 $Y=709140
X3340 2735 2736 2 2787 1 2791 AOI12HS $T=488560 749840 0 180 $X=484220 $Y=744420
X3341 2702 2561 2 2917 1 2998 AOI12HS $T=515840 800240 0 180 $X=511500 $Y=794820
X3342 3076 379 2 2980 1 3065 AOI12HS $T=531960 870800 0 180 $X=527620 $Y=865380
X3343 3761 3755 2 3555 1 600 AOI12HS $T=670220 840560 1 180 $X=665880 $Y=840180
X3344 4066 4090 2 4068 1 4085 AOI12HS $T=731600 850640 0 180 $X=727260 $Y=845220
X3345 4167 4169 2 4159 1 3988 AOI12HS $T=745240 810320 0 180 $X=740900 $Y=804900
X3346 4512 4487 2 4550 1 4884 AOI12HS $T=887220 850640 0 0 $X=887220 $Y=850260
X3347 1282 1208 1381 1336 2 1 1179 MAOI1 $T=250480 820400 0 0 $X=250480 $Y=820020
X3348 2693 2595 2455 2657 2 1 2661 MAOI1 $T=471820 810320 1 180 $X=466860 $Y=809940
X3349 2622 2713 345 2761 2 1 2780 MAOI1 $T=479260 850640 0 0 $X=479260 $Y=850260
X3350 1112 1106 2 1122 1 1129 AN3B2S $T=221340 820400 1 0 $X=221340 $Y=814980
X3351 1217 1163 2 1216 1 13 AN3B2S $T=235600 699440 1 180 $X=231880 $Y=699060
X3352 1448 1469 2 1456 1 1397 AN3B2S $T=267840 830480 1 180 $X=264120 $Y=830100
X3353 1438 1469 2 1485 1 1499 AN3B2S $T=265980 850640 1 0 $X=265980 $Y=845220
X3354 1531 1501 2 1521 1 1327 AN3B2S $T=276520 749840 1 180 $X=272800 $Y=749460
X3355 1561 1553 2 1547 1 1543 AN3B2S $T=280860 749840 1 180 $X=277140 $Y=749460
X3356 1452 1479 2 80 1 1610 AN3B2S $T=283960 699440 0 0 $X=283960 $Y=699060
X3357 1579 1664 2 1653 1 1680 AN3B2S $T=297600 719600 1 0 $X=297600 $Y=714180
X3358 1856 159 2 147 1 1926 AN3B2S $T=367660 850640 0 180 $X=363940 $Y=845220
X3359 2466 2512 2 2496 1 2493 AN3B2S $T=448880 820400 1 180 $X=445160 $Y=820020
X3360 2867 3063 2 3067 1 3074 AN3B2S $T=526380 780080 1 0 $X=526380 $Y=774660
X3361 3043 3081 2 3041 1 3101 AN3B2S $T=531960 800240 1 0 $X=531960 $Y=794820
X3362 450 3115 2 3068 1 3134 AN3B2S $T=540640 790160 0 0 $X=540640 $Y=789780
X3363 494 527 2 525 1 3361 AN3B2S $T=588380 880880 0 180 $X=584660 $Y=875460
X3364 1141 6 1 1108 2 1099 OAI12HS $T=225060 820400 1 180 $X=221340 $Y=820020
X3365 1150 1167 1 1189 2 1291 OAI12HS $T=245520 840560 1 180 $X=241800 $Y=840180
X3366 1457 1467 1 1471 2 1468 OAI12HS $T=264740 749840 0 0 $X=264740 $Y=749460
X3367 1521 48 1 1265 2 1569 OAI12HS $T=279620 749840 1 0 $X=279620 $Y=744420
X3368 1611 1311 1 1393 2 1767 OAI12HS $T=316200 820400 1 0 $X=316200 $Y=814980
X3369 2028 1891 1 1964 2 1992 OAI12HS $T=373240 820400 0 180 $X=369520 $Y=814980
X3370 2034 2043 1 2049 2 2063 OAI12HS $T=373860 749840 0 0 $X=373860 $Y=749460
X3371 2154 2178 1 2185 2 2189 OAI12HS $T=394940 780080 0 0 $X=394940 $Y=779700
X3372 2255 2223 1 2238 2 213 OAI12HS $T=409820 830480 0 180 $X=406100 $Y=825060
X3373 2260 2215 1 2201 2 2204 OAI12HS $T=411060 780080 0 180 $X=407340 $Y=774660
X3374 2255 2271 1 2238 2 215 OAI12HS $T=411060 820400 0 180 $X=407340 $Y=814980
X3375 214 2250 1 2230 2 2275 OAI12HS $T=407960 709520 0 0 $X=407960 $Y=709140
X3376 2263 159 1 2247 2 2255 OAI12HS $T=411680 820400 1 180 $X=407960 $Y=820020
X3377 2300 2294 1 2286 2 2293 OAI12HS $T=417880 790160 0 180 $X=414160 $Y=784740
X3378 2337 2369 1 2402 2 2340 OAI12HS $T=429660 780080 1 0 $X=429660 $Y=774660
X3379 187 276 1 2472 2 2489 OAI12HS $T=442680 699440 0 0 $X=442680 $Y=699060
X3380 2515 2653 1 2667 2 2654 OAI12HS $T=465620 770000 0 0 $X=465620 $Y=769620
X3381 2860 2736 1 2842 2 2849 OAI12HS $T=497240 749840 0 180 $X=493520 $Y=744420
X3382 2866 2791 1 2896 2 2911 OAI12HS $T=506540 749840 0 180 $X=502820 $Y=744420
X3383 2728 2932 1 2943 2 2952 OAI12HS $T=505300 729680 1 0 $X=505300 $Y=724260
X3384 2996 3004 1 3009 2 2993 OAI12HS $T=514600 749840 1 0 $X=514600 $Y=744420
X3385 2951 2987 1 2959 2 3015 OAI12HS $T=515220 759920 1 0 $X=515220 $Y=754500
X3386 2534 2901 1 2561 2 3130 OAI12HS $T=541880 830480 0 0 $X=541880 $Y=830100
X3387 3518 3442 1 3440 2 3549 OAI12HS $T=629920 850640 0 0 $X=629920 $Y=850260
X3388 4166 4135 1 4139 2 4152 OAI12HS $T=742140 719600 0 0 $X=742140 $Y=719220
X3389 4452 4469 1 4432 2 4459 OAI12HS $T=802280 800240 1 180 $X=798560 $Y=799860
X3390 1107 1483 1149 1109 1141 1464 1 2 1456 AO222 $T=269700 820400 1 180 $X=263500 $Y=820020
X3391 1951 1988 1700 1996 2004 2007 1 2 2005 AO222 $T=363320 830480 0 0 $X=363320 $Y=830100
X3392 2839 449 219 448 3072 3096 1 2 3086 AO222 $T=540640 870800 0 180 $X=534440 $Y=865380
X3393 863 867 868 4793 4817 877 1 2 4831 AO222 $T=872960 880880 1 0 $X=872960 $Y=875460
X3394 892 867 868 888 4854 877 1 2 4844 AO222 $T=888460 880880 0 180 $X=882260 $Y=875460
X3395 5149 5155 5152 5148 5111 5139 1 2 971 AO222 $T=953560 709520 1 180 $X=947360 $Y=709140
X3396 5153 5155 5152 5138 5142 5139 1 2 5130 AO222 $T=954800 840560 0 180 $X=948600 $Y=835140
X3397 5141 5155 5152 5162 5158 5139 1 2 5095 AO222 $T=957900 729680 0 180 $X=951700 $Y=724260
X3398 5173 5155 5152 5166 5161 5139 1 2 5151 AO222 $T=958520 800240 1 180 $X=952320 $Y=799860
X3399 5154 5155 5152 5140 5171 5139 1 2 5097 AO222 $T=953560 820400 1 0 $X=953560 $Y=814980
X3400 5168 5155 5152 5172 5150 5139 1 2 5121 AO222 $T=962240 749840 0 180 $X=956040 $Y=744420
X3401 5167 5155 5152 5178 5176 5139 1 2 5125 AO222 $T=962860 780080 0 180 $X=956660 $Y=774660
X3402 5177 5155 5152 5169 5170 5139 1 2 5043 AO222 $T=964720 790160 1 180 $X=958520 $Y=789780
X3403 5181 5155 5152 5180 5182 5139 1 2 983 AO222 $T=967820 719600 1 180 $X=961620 $Y=719220
X3404 5189 5155 5152 5116 5163 5139 1 2 5105 AO222 $T=968440 749840 0 180 $X=962240 $Y=744420
X3405 5201 5155 5152 5190 5186 5139 1 2 5069 AO222 $T=969060 780080 0 180 $X=962860 $Y=774660
X3406 5214 991 989 5196 5188 987 1 2 5164 AO222 $T=970920 870800 1 180 $X=964720 $Y=870420
X3407 5226 5155 5152 5215 5212 5139 1 2 992 AO222 $T=977120 729680 1 180 $X=970920 $Y=729300
X3408 5213 5155 5152 5222 5225 5139 1 2 5219 AO222 $T=974020 759920 0 0 $X=974020 $Y=759540
X3409 5258 5155 5152 5232 5228 5139 1 2 1003 AO222 $T=983320 709520 1 180 $X=977120 $Y=709140
X3410 5233 5155 5152 5234 5206 5139 1 2 5216 AO222 $T=983320 810320 0 180 $X=977120 $Y=804900
X3411 5238 5155 5152 5236 5229 5139 1 2 5205 AO222 $T=983940 729680 1 180 $X=977740 $Y=729300
X3412 5253 5155 5152 5204 5208 5139 1 2 5187 AO222 $T=988280 800240 0 180 $X=982080 $Y=794820
X3413 1046 991 989 5472 5467 987 1 2 5458 AO222 $T=1072600 870800 1 180 $X=1066400 $Y=870420
X3414 10 1163 1 2 INV2 $T=227540 709520 0 180 $X=225680 $Y=704100
X3415 1877 1915 1 2 INV2 $T=354020 709520 0 0 $X=354020 $Y=709140
X3416 1941 1931 1 2 INV2 $T=357120 749840 1 0 $X=357120 $Y=744420
X3417 1977 1916 1 2 INV2 $T=362700 759920 1 180 $X=360840 $Y=759540
X3418 1969 1993 1 2 INV2 $T=363940 729680 1 0 $X=363940 $Y=724260
X3419 1999 2003 1 2 INV2 $T=368280 749840 1 180 $X=366420 $Y=749460
X3420 155 1978 1 2 INV2 $T=367040 770000 1 0 $X=367040 $Y=764580
X3421 2025 2001 1 2 INV2 $T=372620 759920 1 180 $X=370760 $Y=759540
X3422 2035 2079 1 2 INV2 $T=376960 780080 0 0 $X=376960 $Y=779700
X3423 2124 2129 1 2 INV2 $T=389360 729680 1 180 $X=387500 $Y=729300
X3424 2115 2114 1 2 INV2 $T=387500 780080 0 0 $X=387500 $Y=779700
X3425 2156 2165 1 2 INV2 $T=392460 729680 1 180 $X=390600 $Y=729300
X3426 2169 2166 1 2 INV2 $T=394940 780080 1 180 $X=393080 $Y=779700
X3427 2192 2175 1 2 INV2 $T=399280 749840 0 180 $X=397420 $Y=744420
X3428 2216 2219 1 2 INV2 $T=403000 719600 1 180 $X=401140 $Y=719220
X3429 2200 2203 1 2 INV2 $T=404240 729680 1 180 $X=402380 $Y=729300
X3430 2190 2216 1 2 INV2 $T=405480 719600 1 0 $X=405480 $Y=714180
X3431 2231 2248 1 2 INV2 $T=407340 739760 0 0 $X=407340 $Y=739380
X3432 2253 2206 1 2 INV2 $T=414160 709520 1 0 $X=414160 $Y=704100
X3433 2524 2546 1 2 INV2 $T=448260 770000 1 0 $X=448260 $Y=764580
X3434 2535 2501 1 2 INV2 $T=450740 780080 0 180 $X=448880 $Y=774660
X3435 284 285 1 2 INV2 $T=450120 709520 1 0 $X=450120 $Y=704100
X3436 2498 2554 1 2 INV2 $T=451980 770000 1 0 $X=451980 $Y=764580
X3437 2596 2587 1 2 INV2 $T=461280 759920 1 180 $X=459420 $Y=759540
X3438 2611 2605 1 2 INV2 $T=462520 729680 1 180 $X=460660 $Y=729300
X3439 2614 2549 1 2 INV2 $T=463140 719600 1 180 $X=461280 $Y=719220
X3440 2617 2616 1 2 INV2 $T=463140 759920 1 0 $X=463140 $Y=754500
X3441 2613 2614 1 2 INV2 $T=465000 719600 1 0 $X=465000 $Y=714180
X3442 2679 2637 1 2 INV2 $T=470580 729680 1 180 $X=468720 $Y=729300
X3443 2697 2711 1 2 INV2 $T=471820 739760 0 0 $X=471820 $Y=739380
X3444 3278 3331 1 2 INV2 $T=579080 770000 0 0 $X=579080 $Y=769620
X3445 3272 3324 1 2 INV2 $T=609460 770000 0 0 $X=609460 $Y=769620
X3446 3488 3350 1 2 INV2 $T=615040 790160 0 0 $X=615040 $Y=789780
X3447 3429 3442 1 2 INV2 $T=621860 830480 0 0 $X=621860 $Y=830100
X3448 3259 3312 1 2 INV2 $T=624960 820400 1 0 $X=624960 $Y=814980
X3449 3449 3207 1 2 INV2 $T=638600 820400 1 0 $X=638600 $Y=814980
X3450 735 734 1 2 INV2 $T=790500 770000 0 0 $X=790500 $Y=769620
X3451 4368 743 1 2 INV2 $T=795460 780080 1 180 $X=793600 $Y=779700
X3452 4500 4469 1 2 INV2 $T=810960 780080 0 0 $X=810960 $Y=779700
X3453 4543 756 1 2 INV2 $T=814680 780080 1 0 $X=814680 $Y=774660
X3454 739 737 1 2 INV2 $T=828320 739760 0 0 $X=828320 $Y=739380
X3455 4510 4561 1 2 INV2 $T=830180 790160 1 0 $X=830180 $Y=784740
X3456 787 738 1 2 INV2 $T=832660 739760 1 180 $X=830800 $Y=739380
X3457 4519 4530 1 2 INV2 $T=831420 800240 0 0 $X=831420 $Y=799860
X3458 1411 2 1190 1 1305 NR2P $T=304420 719600 0 0 $X=304420 $Y=719220
X3459 1311 2 1586 1 10 NR2P $T=317440 729680 1 0 $X=317440 $Y=724260
X3460 136 2 137 1 1859 NR2P $T=344100 699440 0 0 $X=344100 $Y=699060
X3461 136 2 150 1 1880 NR2P $T=355880 719600 1 0 $X=355880 $Y=714180
X3462 1930 2 1903 1 1975 NR2P $T=362080 739760 1 180 $X=358360 $Y=739380
X3463 136 2 162 1 1873 NR2P $T=367040 719600 1 0 $X=367040 $Y=714180
X3464 2035 2 1975 1 1991 NR2P $T=380060 749840 0 180 $X=376340 $Y=744420
X3465 160 2 150 1 2123 NR2P $T=389360 709520 1 180 $X=385640 $Y=709140
X3466 2146 2 2128 1 2124 NR2P $T=389980 729680 1 0 $X=389980 $Y=724260
X3467 160 2 137 1 190 NR2P $T=399280 699440 1 180 $X=395560 $Y=699060
X3468 160 2 162 1 2174 NR2P $T=400520 709520 0 180 $X=396800 $Y=704100
X3469 2146 2 2206 1 2192 NR2P $T=401140 719600 1 180 $X=397420 $Y=719220
X3470 2146 2 2219 1 2200 NR2P $T=404860 729680 0 180 $X=401140 $Y=724260
X3471 160 2 138 1 2202 NR2P $T=405480 709520 0 180 $X=401760 $Y=704100
X3472 2545 2 2549 1 2524 NR2P $T=449500 759920 1 0 $X=449500 $Y=754500
X3473 2540 2 248 1 2561 NR2P $T=458800 840560 1 180 $X=455080 $Y=840180
X3474 292 2 162 1 2603 NR2P $T=461900 709520 1 180 $X=458180 $Y=709140
X3475 2560 2 2637 1 2599 NR2P $T=463140 739760 0 180 $X=459420 $Y=734340
X3476 4090 2 4107 1 619 NR2P $T=732220 840560 1 180 $X=728500 $Y=840180
X3477 4273 2 4293 1 744 NR2P $T=791740 800240 0 0 $X=791740 $Y=799860
X3478 4530 2 4510 1 4528 NR2P $T=815300 800240 0 0 $X=815300 $Y=799860
X3479 4511 2 4500 1 739 NR2P $T=827080 770000 1 0 $X=827080 $Y=764580
X3480 26 1154 2 1249 1217 1 OR3B2 $T=239320 709520 0 180 $X=235600 $Y=704100
X3481 1412 1426 2 1476 1445 1 OR3B2 $T=259780 739760 0 0 $X=259780 $Y=739380
X3482 1379 1514 2 1246 1530 1 OR3B2 $T=270940 719600 0 0 $X=270940 $Y=719220
X3483 1580 1583 2 1641 1289 1 OR3B2 $T=288300 820400 1 0 $X=288300 $Y=814980
X3484 1907 1472 2 1904 1628 1 OR3B2 $T=352160 780080 1 180 $X=348440 $Y=779700
X3485 2570 2566 2 2572 2526 1 OR3B2 $T=458800 840560 0 180 $X=455080 $Y=835140
X3486 3063 422 2 3041 3050 1 OR3B2 $T=528240 800240 1 180 $X=524520 $Y=799860
X3487 3003 3093 2 3095 3043 1 OR3B2 $T=537540 790160 1 180 $X=533820 $Y=789780
X3488 577 3221 2 574 3497 1 OR3B2 $T=634260 880880 0 180 $X=630540 $Y=875460
X3489 3555 3761 2 594 3755 1 OR3B2 $T=667740 850640 1 0 $X=667740 $Y=845220
X3490 4159 4167 2 4121 4169 1 OR3B2 $T=740280 810320 0 0 $X=740280 $Y=809940
X3491 4388 753 2 4464 4502 1 OR3B2 $T=803520 810320 1 0 $X=803520 $Y=804900
X3492 1159 11 1133 2 1 1127 AN3 $T=230640 860720 0 180 $X=226920 $Y=855300
X3493 1309 31 1324 2 1 1260 AN3 $T=243660 850640 1 0 $X=243660 $Y=845220
X3494 1417 1413 38 2 1 1194 AN3 $T=259780 759920 1 180 $X=256060 $Y=759540
X3495 1410 1420 1422 2 1 1490 AN3 $T=257300 830480 1 0 $X=257300 $Y=825060
X3496 1465 1484 1401 2 1 1340 AN3 $T=266600 840560 0 0 $X=266600 $Y=840180
X3497 1534 69 1499 2 1 1505 AN3 $T=275280 850640 0 180 $X=271560 $Y=845220
X3498 1513 1520 1406 2 1 57 AN3 $T=272800 709520 0 0 $X=272800 $Y=709140
X3499 1496 1523 1340 2 1 1537 AN3 $T=272800 810320 1 0 $X=272800 $Y=804900
X3500 1644 1676 1625 2 1 1681 AN3 $T=298840 800240 1 0 $X=298840 $Y=794820
X3501 1713 1660 1698 2 1 1496 AN3 $T=306900 810320 1 180 $X=303180 $Y=809940
X3502 1726 1567 1643 2 1 1704 AN3 $T=310000 759920 1 180 $X=306280 $Y=759540
X3503 1307 1536 1618 2 1 1696 AN3 $T=323020 749840 1 0 $X=323020 $Y=744420
X3504 1796 1531 1739 2 1 1742 AN3 $T=326740 759920 0 180 $X=323020 $Y=754500
X3505 2082 1875 2052 2 1 2028 AN3 $T=378820 810320 1 180 $X=375100 $Y=809940
X3506 245 248 251 2 1 2386 AN3 $T=425940 850640 0 0 $X=425940 $Y=850260
X3507 2748 2815 2818 2 1 2820 AN3 $T=488560 860720 1 0 $X=488560 $Y=855300
X3508 2825 2817 2829 2 1 2859 AN3 $T=491040 830480 1 0 $X=491040 $Y=825060
X3509 2935 2946 2730 2 1 2982 AN3 $T=506540 810320 1 0 $X=506540 $Y=804900
X3510 2819 3042 3046 2 1 3050 AN3 $T=522040 850640 1 0 $X=522040 $Y=845220
X3511 3417 3442 3460 2 1 3259 AN3 $T=605120 830480 1 0 $X=605120 $Y=825060
X3512 3427 3221 3497 2 1 3475 AN3 $T=619380 870800 0 180 $X=615660 $Y=865380
X3513 3460 3446 3442 2 1 3258 AN3 $T=616900 830480 0 0 $X=616900 $Y=830100
X3514 4579 4510 4469 2 1 717 AN3 $T=821500 780080 1 180 $X=817780 $Y=779700
X3515 4511 753 4502 2 1 4588 AN3 $T=821500 810320 0 0 $X=821500 $Y=809940
X3516 4579 4561 4469 2 1 735 AN3 $T=825220 780080 1 0 $X=825220 $Y=774660
X3517 1208 1197 1240 1147 2 1 1269 OA22 $T=233740 850640 0 0 $X=233740 $Y=850260
X3518 1174 1169 1157 1274 2 1 1284 OA22 $T=237460 780080 0 0 $X=237460 $Y=779700
X3519 1263 1341 1300 1205 2 1 1361 OA22 $T=246140 870800 1 0 $X=246140 $Y=865380
X3520 1338 1223 1302 1238 2 1 1367 OA22 $T=246760 739760 0 0 $X=246760 $Y=739380
X3521 1148 1348 1304 1187 2 1 1366 OA22 $T=247380 840560 0 0 $X=247380 $Y=840180
X3522 1395 1345 1208 1116 2 1 1322 OA22 $T=254820 780080 1 180 $X=250480 $Y=779700
X3523 1348 1300 60 56 2 1 1380 OA22 $T=272800 870800 1 180 $X=268460 $Y=870420
X3524 61 66 1357 1199 2 1 1507 OA22 $T=279000 870800 0 180 $X=274660 $Y=865380
X3525 71 56 1374 1205 2 1 1598 OA22 $T=289540 850640 1 180 $X=285200 $Y=850260
X3526 61 89 1407 1148 2 1 1583 OA22 $T=299460 840560 1 180 $X=295120 $Y=840180
X3527 61 93 56 84 2 1 1678 OA22 $T=304420 870800 0 180 $X=300080 $Y=865380
X3528 18 1747 1206 1198 2 1 1695 OA22 $T=316820 800240 0 180 $X=312480 $Y=794820
X3529 1793 1740 103 1419 2 1 1517 OA22 $T=325500 870800 0 180 $X=321160 $Y=865380
X3530 1934 1820 133 1885 2 1 2052 OA22 $T=374480 820400 1 0 $X=374480 $Y=814980
X3531 2552 2421 2437 2525 2 1 2528 OA22 $T=452600 800240 1 180 $X=448260 $Y=799860
X3532 2407 2703 321 2724 2 1 2750 OA22 $T=475540 850640 1 0 $X=475540 $Y=845220
X3533 2756 2625 2718 2771 2 1 2779 OA22 $T=480500 790160 0 0 $X=480500 $Y=789780
X3534 2912 3135 2906 3205 2 1 3210 OA22 $T=556140 820400 1 0 $X=556140 $Y=814980
X3535 274 482 2718 2385 2 1 3226 OA22 $T=558620 820400 0 0 $X=558620 $Y=820020
X3536 528 321 513 3346 2 1 3307 OA22 $T=584660 850640 1 180 $X=580320 $Y=850260
X3537 1683 1531 1764 1 2 1817 AN3S $T=329220 759920 1 0 $X=329220 $Y=754500
X3538 2276 2464 2424 1 2 2575 AN3S $T=451980 860720 1 0 $X=451980 $Y=855300
X3539 4630 4558 1 2 INV12CK $T=846920 790160 1 180 $X=837000 $Y=789780
X3540 817 4630 1 2 INV12CK $T=837000 820400 0 0 $X=837000 $Y=820020
X3541 818 817 1 2 INV12CK $T=837000 840560 0 0 $X=837000 $Y=840180
X3542 4656 4722 1 2 INV12CK $T=847540 830480 0 0 $X=847540 $Y=830100
X3543 4722 746 1 2 INV12CK $T=861180 830480 0 0 $X=861180 $Y=830100
X3544 4871 4865 1 2 BUF2CK $T=889080 850640 1 0 $X=889080 $Y=845220
X3545 4889 895 1 2 BUF2CK $T=893420 830480 1 0 $X=893420 $Y=825060
X3546 4972 5008 1 2 BUF2CK $T=915740 719600 1 0 $X=915740 $Y=714180
X3547 1034 1035 1 2 BUF2CK $T=1036640 880880 1 0 $X=1036640 $Y=875460
X3548 5470 5469 1 2 BUF2CK $T=1070120 860720 1 0 $X=1070120 $Y=855300
X3549 822 829 4727 1 2 838 842 4760 1093 ICV_4 $T=846300 860720 1 0 $X=846300 $Y=855300
X3550 838 826 4802 1 2 838 850 4817 1093 ICV_4 $T=864280 870800 0 0 $X=864280 $Y=870420
X3551 895 850 911 1 2 914 830 932 1093 ICV_4 $T=895900 870800 0 0 $X=895900 $Y=870420
X3552 4900 919 5007 1 2 4803 4997 5051 1093 ICV_4 $T=907060 780080 0 0 $X=907060 $Y=779700
X3553 914 856 5047 1 2 938 856 5076 1093 ICV_4 $T=916360 840560 0 0 $X=916360 $Y=840180
X3554 4996 5091 5116 1 2 4803 955 5143 1093 ICV_4 $T=933720 759920 1 0 $X=933720 $Y=754500
X3555 4903 945 5135 1 2 4903 5113 5177 1093 ICV_4 $T=938060 790160 1 0 $X=938060 $Y=784740
X3556 5002 5091 5140 1 2 4870 5091 5166 1093 ICV_4 $T=939300 810320 0 0 $X=939300 $Y=809940
X3557 4803 5137 5176 1 2 5074 945 5199 1093 ICV_4 $T=951080 770000 1 0 $X=951080 $Y=764580
X3558 948 5137 5212 1 2 984 5113 5258 1093 ICV_4 $T=968440 729680 1 0 $X=968440 $Y=724260
X3559 4870 1020 5296 1 2 4900 1020 5307 1093 ICV_4 $T=994480 800240 0 0 $X=994480 $Y=799860
X3560 4803 1020 5327 1 2 4903 1020 5358 1093 ICV_4 $T=1003160 780080 0 0 $X=1003160 $Y=779700
X3561 5074 1021 5332 1 2 4996 1020 5369 1093 ICV_4 $T=1005640 749840 0 0 $X=1005640 $Y=749460
X3562 4900 1037 5434 1 2 4900 1038 5455 1093 ICV_4 $T=1045320 800240 0 0 $X=1045320 $Y=799860
X3563 4900 1042 5448 1 2 4903 1037 5476 1093 ICV_4 $T=1054000 790160 1 0 $X=1054000 $Y=784740
X3564 4803 1038 5449 1 2 4903 5418 5479 1093 ICV_4 $T=1057720 770000 0 0 $X=1057720 $Y=769620
X3565 4395 1 2 4407 INV3CK $T=789880 820400 0 180 $X=786780 $Y=814980
X3566 4589 1 2 4635 INV3CK $T=855600 820400 0 0 $X=855600 $Y=820020
X3567 4698 1 2 4785 INV3CK $T=870480 790160 0 0 $X=870480 $Y=789780
X3568 115 1 2 1932 BUF1CK $T=352780 719600 0 0 $X=352780 $Y=719220
X3569 2596 1 2 2607 BUF1CK $T=460040 749840 0 0 $X=460040 $Y=749460
X3570 3213 1 2 3223 BUF1CK $T=559240 780080 1 0 $X=559240 $Y=774660
X3571 516 1 2 3343 BUF1CK $T=579700 699440 0 0 $X=579700 $Y=699060
X3572 517 1 2 3345 BUF1CK $T=579700 800240 1 0 $X=579700 $Y=794820
X3573 3369 1 2 3273 BUF1CK $T=585900 820400 0 0 $X=585900 $Y=820020
X3574 3398 1 2 3372 BUF1CK $T=595200 800240 0 0 $X=595200 $Y=799860
X3575 591 1 2 3673 BUF1CK $T=651000 749840 0 0 $X=651000 $Y=749460
X3576 596 1 2 3707 BUF1CK $T=657200 770000 1 0 $X=657200 $Y=764580
X3577 599 1 2 3704 BUF1CK $T=659060 709520 0 0 $X=659060 $Y=709140
X3578 605 1 2 3732 BUF1CK $T=665260 739760 0 0 $X=665260 $Y=739380
X3579 3505 1 2 3751 BUF1CK $T=665260 800240 0 0 $X=665260 $Y=799860
X3580 3609 1 2 3792 BUF1CK $T=672700 780080 0 0 $X=672700 $Y=779700
X3581 3997 1 2 4006 BUF1CK $T=710520 729680 0 0 $X=710520 $Y=729300
X3582 4030 1 2 3998 BUF1CK $T=715480 729680 1 0 $X=715480 $Y=724260
X3583 4056 1 2 4062 BUF1CK $T=720440 729680 1 0 $X=720440 $Y=724260
X3584 4072 1 2 4081 BUF1CK $T=722920 739760 0 0 $X=722920 $Y=739380
X3585 4259 1 2 4239 BUF1CK $T=764460 770000 0 0 $X=764460 $Y=769620
X3586 4267 1 2 4269 BUF1CK $T=768180 780080 1 0 $X=768180 $Y=774660
X3587 4529 1 2 4514 BUF1CK $T=813440 810320 0 0 $X=813440 $Y=809940
X3588 4592 1 2 4603 BUF1CK $T=833280 820400 0 0 $X=833280 $Y=820020
X3589 4744 1 2 4752 BUF1CK $T=861180 780080 1 0 $X=861180 $Y=774660
X3590 4799 1 2 4805 BUF1CK $T=874200 709520 1 0 $X=874200 $Y=704100
X3591 4924 1 2 4941 BUF1CK $T=902720 810320 0 0 $X=902720 $Y=809940
X3592 4922 1 2 4935 BUF1CK $T=904580 780080 0 0 $X=904580 $Y=779700
X3593 5049 1 2 4958 BUF1CK $T=931860 800240 1 0 $X=931860 $Y=794820
X3594 5119 1 2 4993 BUF1CK $T=942400 749840 0 0 $X=942400 $Y=749460
X3595 5185 1 2 5003 BUF1CK $T=968440 820400 0 0 $X=968440 $Y=820020
X3596 5275 1 2 5278 BUF1CK $T=993240 830480 0 0 $X=993240 $Y=830100
X3597 1903 1 2 1942 BUF1S $T=360220 729680 0 0 $X=360220 $Y=729300
X3598 1902 1 2 1983 BUF1S $T=361460 729680 1 0 $X=361460 $Y=724260
X3599 2176 1 2 2224 BUF1S $T=403000 719600 1 0 $X=403000 $Y=714180
X3600 2212 1 2 2234 BUF1S $T=408580 790160 1 0 $X=408580 $Y=784740
X3601 2168 1 2 2313 BUF1S $T=417260 759920 1 0 $X=417260 $Y=754500
X3602 2258 1 2 2336 BUF1S $T=421600 759920 0 0 $X=421600 $Y=759540
X3603 2338 1 2 2306 BUF1S $T=423460 790160 0 0 $X=423460 $Y=789780
X3604 2370 1 2 2384 BUF1S $T=427180 800240 1 0 $X=427180 $Y=794820
X3605 2394 1 2 2314 BUF1S $T=429660 800240 1 0 $X=429660 $Y=794820
X3606 2460 1 2 2434 BUF1S $T=439580 800240 1 0 $X=439580 $Y=794820
X3607 2425 1 2 2461 BUF1S $T=443300 800240 0 0 $X=443300 $Y=799860
X3608 2365 1 2 2497 BUF1S $T=447020 759920 1 0 $X=447020 $Y=754500
X3609 2611 1 2 2640 BUF1S $T=463760 729680 0 0 $X=463760 $Y=729300
X3610 2581 1 2 2701 BUF1S $T=473680 780080 0 0 $X=473680 $Y=779700
X3611 2695 1 2 2861 BUF1S $T=494760 770000 1 0 $X=494760 $Y=764580
X3612 2854 1 2 2866 BUF1S $T=495380 739760 0 0 $X=495380 $Y=739380
X3613 405 1 2 407 BUF1S $T=513980 709520 1 0 $X=513980 $Y=704100
X3614 2970 1 2 2996 BUF1S $T=520800 759920 1 0 $X=520800 $Y=754500
X3615 3021 1 2 3047 BUF1S $T=522040 709520 1 0 $X=522040 $Y=704100
X3616 3024 1 2 3064 BUF1S $T=525140 719600 0 0 $X=525140 $Y=719220
X3617 2584 1 2 3092 BUF1S $T=533200 729680 1 0 $X=533200 $Y=724260
X3618 2983 1 2 3102 BUF1S $T=535680 729680 1 0 $X=535680 $Y=724260
X3619 3098 1 2 3106 BUF1S $T=535680 780080 1 0 $X=535680 $Y=774660
X3620 3219 1 2 3160 BUF1S $T=561720 770000 1 0 $X=561720 $Y=764580
X3621 3353 1 2 3342 BUF1S $T=582180 800240 0 0 $X=582180 $Y=799860
X3622 529 1 2 3381 BUF1S $T=588380 719600 0 0 $X=588380 $Y=719220
X3623 3562 1 2 3674 BUF1S $T=651000 770000 0 0 $X=651000 $Y=769620
X3624 3701 1 2 3678 BUF1S $T=657820 800240 0 0 $X=657820 $Y=799860
X3625 3775 1 2 3614 BUF1S $T=672700 739760 1 0 $X=672700 $Y=734340
X3626 3781 1 2 3638 BUF1S $T=673940 729680 1 0 $X=673940 $Y=724260
X3627 3873 1 2 3891 BUF1S $T=690680 880880 1 0 $X=690680 $Y=875460
X3628 634 1 2 3911 BUF1S $T=694400 880880 1 0 $X=694400 $Y=875460
X3629 3860 1 2 638 BUF1S $T=695640 870800 0 0 $X=695640 $Y=870420
X3630 673 1 2 4076 BUF1S $T=728500 880880 1 0 $X=728500 $Y=875460
X3631 4296 1 2 4321 BUF1S $T=771900 840560 0 0 $X=771900 $Y=840180
X3632 4260 1 2 4261 BUF1S $T=774380 850640 0 0 $X=774380 $Y=850260
X3633 4365 1 2 4381 BUF1S $T=779960 870800 0 0 $X=779960 $Y=870420
X3634 4414 1 2 4431 BUF1S $T=794220 870800 0 0 $X=794220 $Y=870420
X3635 4465 1 2 4435 BUF1S $T=801660 820400 1 0 $X=801660 $Y=814980
X3636 4462 1 2 4465 BUF1S $T=801660 830480 0 0 $X=801660 $Y=830100
X3637 4493 1 2 4460 BUF1S $T=804760 840560 0 0 $X=804760 $Y=840180
X3638 4410 1 2 4425 BUF1S $T=807860 880880 1 0 $X=807860 $Y=875460
X3639 4521 1 2 4553 BUF1S $T=815300 840560 0 0 $X=815300 $Y=840180
X3640 4687 1 2 4560 BUF1S $T=848160 770000 0 0 $X=848160 $Y=769620
X3641 4724 1 2 843 BUF1S $T=859320 699440 0 0 $X=859320 $Y=699060
X3642 4745 1 2 4768 BUF1S $T=865520 790160 0 0 $X=865520 $Y=789780
X3643 4805 1 2 4828 BUF1S $T=873580 709520 0 0 $X=873580 $Y=709140
X3644 4835 1 2 884 BUF1S $T=879780 880880 1 0 $X=879780 $Y=875460
X3645 4842 1 2 4846 BUF1S $T=881640 810320 0 0 $X=881640 $Y=809940
X3646 4855 1 2 4849 BUF1S $T=883500 770000 0 0 $X=883500 $Y=769620
X3647 4863 1 2 4584 BUF1S $T=887840 739760 1 0 $X=887840 $Y=734340
X3648 4861 1 2 4900 BUF1S $T=895900 790160 0 0 $X=895900 $Y=789780
X3649 4897 1 2 903 BUF1S $T=897140 729680 1 0 $X=897140 $Y=724260
X3650 4928 1 2 902 BUF1S $T=903340 830480 1 180 $X=900860 $Y=830100
X3651 4926 1 2 909 BUF1S $T=902100 709520 0 0 $X=902100 $Y=709140
X3652 4964 1 2 4955 BUF1S $T=908920 820400 0 0 $X=908920 $Y=820020
X3653 4970 1 2 4980 BUF1S $T=909540 739760 0 0 $X=909540 $Y=739380
X3654 4968 1 2 924 BUF1S $T=911400 719600 1 0 $X=911400 $Y=714180
X3655 4983 1 2 4982 BUF1S $T=913260 719600 0 0 $X=913260 $Y=719220
X3656 4994 1 2 4988 BUF1S $T=913260 739760 0 0 $X=913260 $Y=739380
X3657 4966 1 2 939 BUF1S $T=920700 759920 1 0 $X=920700 $Y=754500
X3658 4981 1 2 948 BUF1S $T=923800 749840 1 0 $X=923800 $Y=744420
X3659 4977 1 2 954 BUF1S $T=928140 739760 1 0 $X=928140 $Y=734340
X3660 2283 1 2 2225 DELB $T=414160 790160 0 0 $X=414160 $Y=789780
X3661 3113 1 2 3116 DELB $T=539400 739760 0 0 $X=539400 $Y=739380
X3662 3123 1 2 3118 DELB $T=541880 729680 1 0 $X=541880 $Y=724260
X3663 458 1 2 3125 DELB $T=546840 719600 0 0 $X=546840 $Y=719220
X3664 3151 1 2 3117 DELB $T=548700 729680 1 0 $X=548700 $Y=724260
X3665 478 1 2 486 DELB $T=558000 719600 0 0 $X=558000 $Y=719220
X3666 3390 1 2 3340 DELB $T=590860 810320 0 0 $X=590860 $Y=809940
X3667 3343 1 2 3414 DELB $T=592720 770000 1 0 $X=592720 $Y=764580
X3668 3273 1 2 3378 DELB $T=597680 830480 0 0 $X=597680 $Y=830100
X3669 3400 1 2 3432 DELB $T=603260 800240 1 0 $X=603260 $Y=794820
X3670 3532 1 2 571 DELB $T=624960 870800 1 0 $X=624960 $Y=865380
X3671 3535 1 2 3558 DELB $T=624960 870800 0 0 $X=624960 $Y=870420
X3672 3576 1 2 3607 DELB $T=634260 830480 0 0 $X=634260 $Y=830100
X3673 3596 1 2 3625 DELB $T=638600 810320 1 0 $X=638600 $Y=804900
X3674 3613 1 2 3640 DELB $T=641080 860720 0 0 $X=641080 $Y=860340
X3675 3644 1 2 3671 DELB $T=646040 860720 0 0 $X=646040 $Y=860340
X3676 3645 1 2 3670 DELB $T=646660 820400 0 0 $X=646660 $Y=820020
X3677 3653 1 2 3586 DELB $T=649140 870800 1 0 $X=649140 $Y=865380
X3678 612 1 2 615 DELB $T=672080 699440 0 0 $X=672080 $Y=699060
X3679 617 1 2 589 DELB $T=678280 699440 0 0 $X=678280 $Y=699060
X3680 3825 1 2 3859 DELB $T=682620 759920 1 0 $X=682620 $Y=754500
X3681 3827 1 2 626 DELB $T=683240 870800 1 0 $X=683240 $Y=865380
X3682 3839 1 2 3864 DELB $T=685100 709520 0 0 $X=685100 $Y=709140
X3683 3752 1 2 3889 DELB $T=688200 870800 1 0 $X=688200 $Y=865380
X3684 3882 1 2 3929 DELB $T=693780 830480 0 0 $X=693780 $Y=830100
X3685 4020 1 2 4040 DELB $T=714240 860720 1 0 $X=714240 $Y=855300
X3686 4032 1 2 4045 DELB $T=718580 840560 0 0 $X=718580 $Y=840180
X3687 4055 1 2 4068 DELB $T=721680 850640 1 0 $X=721680 $Y=845220
X3688 4061 1 2 4057 DELB $T=722920 850640 0 0 $X=722920 $Y=850260
X3689 4109 1 2 4105 DELB $T=732220 840560 0 0 $X=732220 $Y=840180
X3690 4141 1 2 692 DELB $T=737180 739760 0 0 $X=737180 $Y=739380
X3691 4091 1 2 4133 DELB $T=737180 840560 0 0 $X=737180 $Y=840180
X3692 4178 1 2 4201 DELB $T=744620 840560 0 0 $X=744620 $Y=840180
X3693 4193 1 2 4214 DELB $T=747720 820400 1 0 $X=747720 $Y=814980
X3694 4209 1 2 4223 DELB $T=750200 800240 1 0 $X=750200 $Y=794820
X3695 697 1 2 4237 DELB $T=751440 719600 0 0 $X=751440 $Y=719220
X3696 4222 1 2 4227 DELB $T=754540 790160 0 0 $X=754540 $Y=789780
X3697 4236 1 2 4244 DELB $T=758260 840560 1 0 $X=758260 $Y=835140
X3698 4256 1 2 4216 DELB $T=760740 780080 1 0 $X=760740 $Y=774660
X3699 4292 1 2 4066 DELB $T=767560 840560 1 0 $X=767560 $Y=835140
X3700 4317 1 2 4279 DELB $T=773140 790160 1 0 $X=773140 $Y=784740
X3701 4354 1 2 4265 DELB $T=778720 830480 1 0 $X=778720 $Y=825060
X3702 4357 1 2 4281 DELB $T=781200 820400 1 0 $X=781200 $Y=814980
X3703 4332 1 2 4293 DELB $T=782440 810320 1 0 $X=782440 $Y=804900
X3704 4242 1 2 4289 DELB $T=782440 860720 1 0 $X=782440 $Y=855300
X3705 4496 1 2 4442 DELB $T=806000 770000 0 0 $X=806000 $Y=769620
X3706 4557 1 2 4576 DELB $T=823360 840560 0 0 $X=823360 $Y=840180
X3707 4575 1 2 4572 DELB $T=824600 770000 0 0 $X=824600 $Y=769620
X3708 4573 1 2 4524 DELB $T=831420 790160 0 0 $X=831420 $Y=789780
X3709 4615 1 2 4612 DELB $T=832040 840560 0 0 $X=832040 $Y=840180
X3710 4625 1 2 4643 DELB $T=834520 770000 1 0 $X=834520 $Y=764580
X3711 4669 1 2 4692 DELB $T=845060 810320 0 0 $X=845060 $Y=809940
X3712 4702 1 2 4725 DELB $T=851260 719600 1 0 $X=851260 $Y=714180
X3713 4750 1 2 4490 DELB $T=862420 759920 1 0 $X=862420 $Y=754500
X3714 4748 1 2 4765 DELB $T=862420 820400 0 0 $X=862420 $Y=820020
X3715 4742 1 2 4554 DELB $T=865520 749840 0 0 $X=865520 $Y=749460
X3716 4720 1 2 4801 DELB $T=869240 840560 0 0 $X=869240 $Y=840180
X3717 4782 1 2 4650 DELB $T=870480 729680 0 0 $X=870480 $Y=729300
X3718 4807 1 2 4840 DELB $T=876680 749840 0 0 $X=876680 $Y=749460
X3719 4845 1 2 4522 DELB $T=881640 749840 0 0 $X=881640 $Y=749460
X3720 4796 1 2 838 DELB $T=884120 850640 1 0 $X=884120 $Y=845220
X3721 4852 1 2 4867 DELB $T=886600 800240 1 0 $X=886600 $Y=794820
X3722 4832 1 2 4850 DELB $T=891560 780080 0 0 $X=891560 $Y=779700
X3723 4888 1 2 4898 DELB $T=893420 800240 1 0 $X=893420 $Y=794820
X3724 4876 1 2 4901 DELB $T=894660 719600 1 0 $X=894660 $Y=714180
X3725 4885 1 2 4574 DELB $T=897140 749840 1 0 $X=897140 $Y=744420
X3726 4904 1 2 4908 DELB $T=901480 739760 0 0 $X=901480 $Y=739380
X3727 4929 1 2 916 DELB $T=902720 840560 1 0 $X=902720 $Y=835140
X3728 4879 1 2 4602 DELB $T=915120 729680 0 0 $X=915120 $Y=729300
X3729 4962 1 2 914 DELB $T=921320 820400 0 0 $X=921320 $Y=820020
X3730 5016 1 2 938 DELB $T=926280 820400 0 0 $X=926280 $Y=820020
X3731 5046 1 2 956 DELB $T=926900 709520 1 0 $X=926900 $Y=704100
X3732 4890 1 2 4909 DELB $T=930620 719600 0 0 $X=930620 $Y=719220
X3733 4905 1 2 4934 DELB $T=935580 719600 0 0 $X=935580 $Y=719220
X3734 5029 1 2 4998 DELB $T=940540 709520 0 0 $X=940540 $Y=709140
X3735 1002 1 2 1007 DELB $T=976500 709520 1 0 $X=976500 $Y=704100
X3736 155 2 1 1984 BUF1 $T=363940 770000 0 0 $X=363940 $Y=769620
X3737 177 2 1 2100 BUF1 $T=383160 749840 0 0 $X=383160 $Y=749460
X3738 2092 2 1 2101 BUF1 $T=383160 780080 0 0 $X=383160 $Y=779700
X3739 181 2 1 183 BUF1 $T=386880 719600 1 0 $X=386880 $Y=714180
X3740 2282 2 1 167 BUF1 $T=412920 830480 1 180 $X=410440 $Y=830100
X3741 277 2 1 2740 BUF1 $T=480500 749840 1 0 $X=480500 $Y=744420
X3742 3048 2 1 159 BUF1 $T=525760 770000 0 180 $X=523280 $Y=764580
X3743 3060 2 1 147 BUF1 $T=527620 770000 0 0 $X=527620 $Y=769620
X3744 537 2 1 3376 BUF1 $T=600160 860720 1 180 $X=597680 $Y=860340
X3745 3357 2 1 3412 BUF1 $T=610080 729680 1 180 $X=607600 $Y=729300
X3746 3468 2 1 3358 BUF1 $T=610080 810320 0 180 $X=607600 $Y=804900
X3747 559 2 1 461 BUF1 $T=620620 820400 0 180 $X=618140 $Y=814980
X3748 3357 2 1 3573 BUF1 $T=631160 770000 0 0 $X=631160 $Y=769620
X3749 457 2 1 551 BUF1 $T=637980 800240 0 0 $X=637980 $Y=799860
X3750 559 2 1 579 BUF1 $T=641700 820400 1 0 $X=641700 $Y=814980
X3751 3988 2 1 650 BUF1 $T=716100 709520 0 180 $X=713620 $Y=704100
X3752 537 2 1 4142 BUF1 $T=735320 860720 0 0 $X=735320 $Y=860340
X3753 3376 2 1 677 BUF1 $T=759500 860720 0 180 $X=757020 $Y=855300
X3754 742 2 1 670 BUF1 $T=780580 790160 0 180 $X=778100 $Y=784740
X3755 744 2 1 668 BUF1 $T=787400 790160 0 180 $X=784920 $Y=784740
X3756 4485 2 1 747 BUF1 $T=804140 780080 0 180 $X=801660 $Y=774660
X3757 719 2 1 4487 BUF1 $T=802900 850640 0 0 $X=802900 $Y=850260
X3758 4517 2 1 707 BUF1 $T=809720 870800 1 0 $X=809720 $Y=865380
X3759 716 2 1 4527 BUF1 $T=810340 860720 1 0 $X=810340 $Y=855300
X3760 711 2 1 4538 BUF1 $T=810340 880880 1 0 $X=810340 $Y=875460
X3761 805 2 1 806 BUF1 $T=823360 880880 1 0 $X=823360 $Y=875460
X3762 769 2 1 816 BUF1 $T=834520 880880 1 0 $X=834520 $Y=875460
X3763 4142 2 1 4711 BUF1 $T=859320 790160 1 0 $X=859320 $Y=784740
X3764 750 2 1 841 BUF1 $T=862420 840560 1 0 $X=862420 $Y=835140
X3765 4766 2 1 852 BUF1 $T=868000 840560 0 180 $X=865520 $Y=835140
X3766 4771 2 1 822 BUF1 $T=868000 840560 1 0 $X=868000 $Y=835140
X3767 4790 2 1 861 BUF1 $T=872960 840560 0 180 $X=870480 $Y=835140
X3768 4804 2 1 4796 BUF1 $T=875440 840560 0 180 $X=872960 $Y=835140
X3769 4816 2 1 873 BUF1 $T=877920 840560 0 180 $X=875440 $Y=835140
X3770 4815 2 1 880 BUF1 $T=879160 830480 0 0 $X=879160 $Y=830100
X3771 4824 2 1 4861 BUF1 $T=880400 800240 1 0 $X=880400 $Y=794820
X3772 4142 2 1 887 BUF1 $T=882880 719600 1 0 $X=882880 $Y=714180
X3773 4865 2 1 890 BUF1 $T=885360 830480 0 0 $X=885360 $Y=830100
X3774 4866 2 1 4835 BUF1 $T=889080 840560 0 180 $X=886600 $Y=835140
X3775 4914 2 1 905 BUF1 $T=902100 840560 0 180 $X=899620 $Y=835140
X3776 4944 2 1 4929 BUF1 $T=907060 830480 1 180 $X=904580 $Y=830100
X3777 4921 2 1 922 BUF1 $T=907680 830480 1 0 $X=907680 $Y=825060
X3778 4953 2 1 4962 BUF1 $T=910160 830480 1 180 $X=907680 $Y=830100
X3779 4971 2 1 935 BUF1 $T=915740 840560 1 0 $X=915740 $Y=835140
X3780 4967 2 1 937 BUF1 $T=916360 719600 0 0 $X=916360 $Y=719220
X3781 4999 2 1 5016 BUF1 $T=916360 830480 0 0 $X=916360 $Y=830100
X3782 961 2 1 962 BUF1 $T=936820 880880 1 0 $X=936820 $Y=875460
X3783 931 2 1 970 BUF1 $T=944880 850640 0 0 $X=944880 $Y=850260
X3784 930 2 1 967 BUF1 $T=949220 860720 0 180 $X=946740 $Y=855300
X3785 981 2 1 959 BUF1 $T=959140 850640 1 0 $X=959140 $Y=845220
X3786 979 2 1 957 BUF1 $T=960380 840560 0 0 $X=960380 $Y=840180
X3787 897 2 1 972 BUF1 $T=965960 840560 1 180 $X=963480 $Y=840180
X3788 5139 2 1 987 BUF1 $T=963480 860720 1 0 $X=963480 $Y=855300
X3789 5152 2 1 989 BUF1 $T=963480 860720 0 0 $X=963480 $Y=860340
X3790 5155 2 1 991 BUF1 $T=967200 860720 0 0 $X=967200 $Y=860340
X3791 1006 2 1 1005 BUF1 $T=979600 850640 1 180 $X=977120 $Y=850260
X3792 999 2 1 1013 BUF1 $T=982700 870800 1 0 $X=982700 $Y=865380
X3793 5407 2 1 1014 BUF1 $T=988900 850640 1 0 $X=988900 $Y=845220
X3794 975 2 1 1010 BUF1 $T=990760 840560 0 0 $X=990760 $Y=840180
X3795 985 2 1 1023 BUF1 $T=1001920 850640 1 0 $X=1001920 $Y=845220
X3796 1000 2 1 5335 BUF1 $T=1009360 850640 0 0 $X=1009360 $Y=850260
X3797 997 2 1 5323 BUF1 $T=1026720 850640 0 0 $X=1026720 $Y=850260
X3798 1004 2 1 5421 BUF1 $T=1042840 850640 0 0 $X=1042840 $Y=850260
X3799 990 2 1 1039 BUF1 $T=1054000 850640 0 0 $X=1054000 $Y=850260
X3800 168 2 1 160 BUF3 $T=370760 880880 0 180 $X=367040 $Y=875460
X3801 5005 2 1 5355 BUF3 $T=1023000 810320 0 0 $X=1023000 $Y=809940
X3802 4454 777 1 2 INV8CK $T=802280 860720 0 0 $X=802280 $Y=860340
X3803 4564 4571 1 2 INV8CK $T=819640 800240 0 0 $X=819640 $Y=799860
X3804 4630 609 1 2 INV8CK $T=835140 810320 0 0 $X=835140 $Y=809940
X3805 4630 4656 1 2 INV8CK $T=837000 830480 0 0 $X=837000 $Y=830100
X3806 1460 1771 1107 2 1332 1787 1 AO22 $T=320540 780080 1 0 $X=320540 $Y=774660
X3807 2056 1978 2026 2 2018 1984 1 AO22 $T=376960 770000 0 180 $X=372000 $Y=764580
X3808 2064 1984 2025 2 1994 1978 1 AO22 $T=377580 759920 1 180 $X=372620 $Y=759540
X3809 2099 156 2071 2 2015 1984 1 AO22 $T=385640 709520 1 180 $X=380680 $Y=709140
X3810 182 156 2067 2 1982 175 1 AO22 $T=386260 699440 1 180 $X=381300 $Y=699060
X3811 2105 1984 2033 2 2089 1978 1 AO22 $T=386260 770000 0 180 $X=381300 $Y=764580
X3812 2117 1978 2087 2 2041 1984 1 AO22 $T=388740 729680 0 180 $X=383780 $Y=724260
X3813 2118 1978 2098 2 2020 1984 1 AO22 $T=388740 739760 1 180 $X=383780 $Y=739380
X3814 2132 1978 2091 2 2047 1984 1 AO22 $T=390600 719600 1 180 $X=385640 $Y=719220
X3815 2139 1978 2088 2 2065 1984 1 AO22 $T=391220 759920 0 180 $X=386260 $Y=754500
X3816 187 156 2090 2 2024 175 1 AO22 $T=391840 709520 0 180 $X=386880 $Y=704100
X3817 2155 1978 2097 2 1936 1984 1 AO22 $T=392460 739760 0 180 $X=387500 $Y=734340
X3818 2335 2100 2285 2 2287 2113 1 AO22 $T=424080 749840 1 180 $X=419120 $Y=749460
X3819 2355 2100 2333 2 2312 2113 1 AO22 $T=430280 749840 1 180 $X=425320 $Y=749460
X3820 2427 2100 2405 2 2350 2113 1 AO22 $T=435240 729680 1 180 $X=430280 $Y=729300
X3821 2426 2100 2376 2 2374 2113 1 AO22 $T=435860 729680 0 180 $X=430900 $Y=724260
X3822 2428 2100 2330 2 2348 2113 1 AO22 $T=435860 739760 1 180 $X=430900 $Y=739380
X3823 2436 264 2419 2 2383 2113 1 AO22 $T=437720 719600 0 180 $X=432760 $Y=714180
X3824 2448 264 2445 2 2347 263 1 AO22 $T=440200 709520 0 180 $X=435240 $Y=704100
X3825 2796 2740 2769 2 2744 2477 1 AO22 $T=486700 749840 1 180 $X=481740 $Y=749460
X3826 2824 2740 2805 2 2766 2477 1 AO22 $T=491040 739760 0 180 $X=486080 $Y=734340
X3827 374 363 367 2 362 340 1 AO22 $T=495380 699440 1 180 $X=490420 $Y=699060
X3828 2874 2740 2811 2 2776 2477 1 AO22 $T=497860 729680 0 180 $X=492900 $Y=724260
X3829 2872 363 2810 2 2781 340 1 AO22 $T=498480 709520 0 180 $X=493520 $Y=704100
X3830 2887 2740 2837 2 2788 2477 1 AO22 $T=499720 749840 1 180 $X=494760 $Y=749460
X3831 2886 2740 2838 2 2763 340 1 AO22 $T=500340 709520 1 180 $X=495380 $Y=709140
X3832 2905 2740 2821 2 2755 2477 1 AO22 $T=502820 739760 1 180 $X=497860 $Y=739380
X3833 4420 744 4428 2 4482 742 1 AO22 $T=811580 840560 1 0 $X=811580 $Y=835140
X3834 4493 744 4492 2 4491 742 1 AO22 $T=816540 840560 1 0 $X=816540 $Y=835140
X3835 4557 744 4549 2 4556 742 1 AO22 $T=817160 830480 0 0 $X=817160 $Y=830100
X3836 4615 744 4631 2 4601 742 1 AO22 $T=838240 840560 0 180 $X=833280 $Y=835140
X3837 4671 809 4663 2 827 750 1 AO22 $T=846300 860720 0 180 $X=841340 $Y=855300
X3838 4669 744 4704 2 4708 742 1 AO22 $T=850020 820400 0 0 $X=850020 $Y=820020
X3839 4719 744 4640 2 4690 742 1 AO22 $T=856220 800240 1 180 $X=851260 $Y=799860
X3840 4720 744 4709 2 4706 742 1 AO22 $T=856220 810320 1 180 $X=851260 $Y=809940
X3841 4748 744 4651 2 4728 742 1 AO22 $T=863040 810320 0 180 $X=858080 $Y=804900
X3842 893 809 4881 2 4862 841 1 AO22 $T=889700 820400 1 0 $X=889700 $Y=814980
X3843 900 809 4910 2 4853 841 1 AO22 $T=898380 800240 1 0 $X=898380 $Y=794820
X3844 4897 809 4913 2 4818 841 1 AO22 $T=899000 790160 0 0 $X=899000 $Y=789780
X3845 4926 809 4920 2 4798 841 1 AO22 $T=904580 749840 1 180 $X=899620 $Y=749460
X3846 4968 809 4951 2 4786 841 1 AO22 $T=909540 749840 1 180 $X=904580 $Y=749460
X3847 4972 809 4959 2 4949 841 1 AO22 $T=910160 820400 0 180 $X=905200 $Y=814980
X3848 912 809 4956 2 4812 841 1 AO22 $T=905820 749840 1 0 $X=905820 $Y=744420
X3849 929 809 4991 2 4987 841 1 AO22 $T=915740 830480 1 180 $X=910780 $Y=830100
X3850 933 809 5014 2 5018 841 1 AO22 $T=916980 830480 1 0 $X=916980 $Y=825060
X3851 2060 2079 2081 2094 2 1 MXL2HS $T=380060 790160 1 0 $X=380060 $Y=784740
X3852 2554 2546 2535 2527 2 1 MXL2HS $T=453220 770000 1 180 $X=447640 $Y=769620
X3853 751 750 4178 4370 2 1 MXL2HS $T=786160 880880 0 180 $X=780580 $Y=875460
X3854 4703 841 4724 4714 2 1 MXL2HS $T=859940 780080 0 180 $X=854360 $Y=774660
X3855 899 841 904 4911 2 1 MXL2HS $T=895900 759920 1 0 $X=895900 $Y=754500
X3856 913 841 918 921 2 1 MXL2HS $T=905820 699440 0 0 $X=905820 $Y=699060
X3857 4990 841 934 936 2 1 MXL2HS $T=913880 699440 0 0 $X=913880 $Y=699060
X3858 942 841 5029 5022 2 1 MXL2HS $T=925660 719600 0 180 $X=920080 $Y=714180
X3859 5028 841 5046 949 2 1 MXL2HS $T=922560 699440 0 0 $X=922560 $Y=699060
X3860 3187 1 2 3178 DELA $T=554900 729680 1 0 $X=554900 $Y=724260
X3861 3366 1 2 3384 DELA $T=585900 810320 0 0 $X=585900 $Y=809940
X3862 3504 1 2 3495 DELA $T=619380 800240 1 0 $X=619380 $Y=794820
X3863 3541 1 2 3540 DELA $T=627440 830480 1 0 $X=627440 $Y=825060
X3864 3570 1 2 3615 DELA $T=633020 800240 0 0 $X=633020 $Y=799860
X3865 3688 1 2 3723 DELA $T=655960 719600 1 0 $X=655960 $Y=714180
X3866 3682 1 2 3676 DELA $T=658440 749840 0 0 $X=658440 $Y=749460
X3867 3725 1 2 3728 DELA $T=676420 729680 1 0 $X=676420 $Y=724260
X3868 3852 1 2 3883 DELA $T=687580 729680 1 0 $X=687580 $Y=724260
X3869 651 1 2 4011 DELA $T=711140 699440 0 0 $X=711140 $Y=699060
X3870 4010 1 2 4005 DELA $T=715480 870800 0 0 $X=715480 $Y=870420
X3871 654 1 2 663 DELA $T=716100 699440 0 0 $X=716100 $Y=699060
X3872 4001 1 2 4021 DELA $T=720440 870800 0 0 $X=720440 $Y=870420
X3873 674 1 2 4067 DELA $T=729120 739760 0 0 $X=729120 $Y=739380
X3874 688 1 2 691 DELA $T=737180 870800 0 0 $X=737180 $Y=870420
X3875 4287 1 2 4356 DELA $T=782440 759920 1 0 $X=782440 $Y=754500
X3876 4471 1 2 4477 DELA $T=811580 860720 0 0 $X=811580 $Y=860340
X3877 4781 1 2 4797 DELA $T=870480 759920 1 0 $X=870480 $Y=754500
X3878 4800 1 2 4791 DELA $T=873580 790160 0 0 $X=873580 $Y=789780
X3879 4814 1 2 4841 DELA $T=876680 820400 1 0 $X=876680 $Y=814980
X3880 4836 1 2 4857 DELA $T=880400 840560 1 0 $X=880400 $Y=835140
X3881 4859 1 2 4877 DELA $T=886600 749840 0 0 $X=886600 $Y=749460
X3882 4882 1 2 4886 DELA $T=891560 749840 0 0 $X=891560 $Y=749460
X3883 4954 1 2 4938 DELA $T=911400 820400 0 0 $X=911400 $Y=820020
X3884 4995 1 2 4989 DELA $T=916360 820400 0 0 $X=916360 $Y=820020
X3885 2188 199 210 2 1 2265 QDFFRBN $T=397420 810320 1 0 $X=397420 $Y=804900
X3886 2191 199 210 2 1 2254 QDFFRBN $T=398040 800240 1 0 $X=398040 $Y=794820
X3887 2197 199 210 2 1 2272 QDFFRBN $T=398660 810320 0 0 $X=398660 $Y=809940
X3888 2189 199 227 2 1 2326 QDFFRBN $T=411060 780080 1 0 $X=411060 $Y=774660
X3889 2261 199 210 2 1 2327 QDFFRBN $T=412920 810320 1 0 $X=412920 $Y=804900
X3890 2494 199 227 2 1 2668 QDFFRBN $T=451980 790160 1 0 $X=451980 $Y=784740
X3891 2742 199 227 2 1 2770 QDFFRBN $T=477400 780080 1 0 $X=477400 $Y=774660
X3892 2778 199 227 2 1 2882 QDFFRBN $T=487940 770000 0 0 $X=487940 $Y=769620
X3893 2993 199 227 2 1 3052 QDFFRBN $T=513980 759920 0 0 $X=513980 $Y=759540
X3894 3049 199 227 2 1 424 QDFFRBN $T=527620 739760 1 0 $X=527620 $Y=734340
X3895 2961 199 227 2 1 451 QDFFRBN $T=528240 729680 0 0 $X=528240 $Y=729300
X3896 2911 199 227 2 1 429 QDFFRBN $T=531960 749840 0 0 $X=531960 $Y=749460
X3897 3111 199 227 2 1 430 QDFFRBN $T=544360 699440 1 180 $X=532580 $Y=699060
X3898 3066 199 227 2 1 435 QDFFRBN $T=533820 709520 1 0 $X=533820 $Y=704100
X3899 3094 199 227 2 1 438 QDFFRBN $T=535060 709520 0 0 $X=535060 $Y=709140
X3900 3117 452 227 2 1 3165 QDFFRBN $T=540020 719600 1 0 $X=540020 $Y=714180
X3901 3118 452 227 2 1 3177 QDFFRBN $T=540640 739760 1 0 $X=540640 $Y=734340
X3902 3162 467 227 2 1 3113 QDFFRBN $T=556140 739760 1 180 $X=544360 $Y=739380
X3903 3159 467 227 2 1 3219 QDFFRBN $T=549940 770000 1 0 $X=549940 $Y=764580
X3904 3178 467 227 2 1 3148 QDFFRBN $T=553040 749840 1 0 $X=553040 $Y=744420
X3905 3247 467 227 2 1 3193 QDFFRBN $T=567300 770000 1 180 $X=555520 $Y=769620
X3906 3342 467 3376 2 1 3369 QDFFRBN $T=580940 820400 1 0 $X=580940 $Y=814980
X3907 3372 467 535 2 1 3390 QDFFRBN $T=587140 830480 1 0 $X=587140 $Y=825060
X3908 3386 3395 535 2 1 3429 QDFFRBN $T=590240 840560 0 0 $X=590240 $Y=840180
X3909 3384 467 3376 2 1 3400 QDFFRBN $T=605120 820400 0 180 $X=593340 $Y=814980
X3910 541 452 535 2 1 550 QDFFRBN $T=600780 880880 1 0 $X=600780 $Y=875460
X3911 3495 467 3376 2 1 3297 QDFFRBN $T=618140 820400 0 180 $X=606360 $Y=814980
X3912 3524 452 535 2 1 3580 QDFFRBN $T=623100 860720 1 0 $X=623100 $Y=855300
X3913 3540 467 3376 2 1 3348 QDFFRBN $T=626820 820400 1 0 $X=626820 $Y=814980
X3914 3615 467 3376 2 1 3506 QDFFRBN $T=640460 810320 0 0 $X=640460 $Y=809940
X3915 3692 467 535 2 1 3557 QDFFRBN $T=660300 850640 0 180 $X=648520 $Y=845220
X3916 3709 467 535 2 1 3581 QDFFRBN $T=660920 850640 1 180 $X=649140 $Y=850260
X3917 3693 467 535 2 1 3653 QDFFRBN $T=660920 880880 0 180 $X=649140 $Y=875460
X3918 3708 467 535 2 1 3600 QDFFRBN $T=662160 860720 0 180 $X=650380 $Y=855300
X3919 3727 467 3376 2 1 3623 QDFFRBN $T=663400 820400 1 180 $X=651620 $Y=820020
X3920 3730 467 3376 2 1 3545 QDFFRBN $T=664020 790160 1 180 $X=652240 $Y=789780
X3921 3683 467 3376 2 1 3567 QDFFRBN $T=664020 830480 0 180 $X=652240 $Y=825060
X3922 3676 467 3376 2 1 3590 QDFFRBN $T=652860 759920 0 0 $X=652860 $Y=759540
X3923 3678 467 3376 2 1 3505 QDFFRBN $T=652860 810320 0 0 $X=652860 $Y=809940
X3924 3719 467 3376 2 1 3562 QDFFRBN $T=665260 770000 1 180 $X=653480 $Y=769620
X3925 3723 467 608 2 1 3609 QDFFRBN $T=660920 719600 1 0 $X=660920 $Y=714180
X3926 3717 467 608 2 1 3781 QDFFRBN $T=660920 729680 0 0 $X=660920 $Y=729300
X3927 3718 467 608 2 1 3775 QDFFRBN $T=660920 739760 1 0 $X=660920 $Y=734340
X3928 3728 467 608 2 1 3572 QDFFRBN $T=662160 729680 1 0 $X=662160 $Y=724260
X3929 3803 618 608 2 1 3851 QDFFRBN $T=677040 709520 1 0 $X=677040 $Y=704100
X3930 3394 620 535 2 1 3873 QDFFRBN $T=678900 880880 1 0 $X=678900 $Y=875460
X3931 3843 618 608 2 1 3898 QDFFRBN $T=685720 729680 0 0 $X=685720 $Y=729300
X3932 3874 618 608 2 1 3926 QDFFRBN $T=690060 709520 1 0 $X=690060 $Y=704100
X3933 3878 618 608 2 1 3906 QDFFRBN $T=691920 709520 0 0 $X=691920 $Y=709140
X3934 3920 618 608 2 1 3890 QDFFRBN $T=697500 729680 0 0 $X=697500 $Y=729300
X3935 3889 620 3376 2 1 4001 QDFFRBN $T=698120 870800 1 0 $X=698120 $Y=865380
X3936 3558 620 535 2 1 4010 QDFFRBN $T=698120 870800 0 0 $X=698120 $Y=870420
X3937 3998 652 608 2 1 4056 QDFFRBN $T=711140 719600 0 0 $X=711140 $Y=719220
X3938 4006 652 608 2 1 4072 QDFFRBN $T=711140 739760 1 0 $X=711140 $Y=734340
X3939 4068 659 3376 2 1 3621 QDFFRBN $T=724160 840560 0 180 $X=712380 $Y=835140
X3940 3929 620 3376 2 1 667 QDFFRBN $T=712380 870800 1 0 $X=712380 $Y=865380
X3941 3883 652 608 2 1 4079 QDFFRBN $T=713620 719600 1 0 $X=713620 $Y=714180
X3942 655 659 535 2 1 672 QDFFRBN $T=716720 880880 1 0 $X=716720 $Y=875460
X3943 4045 659 3376 2 1 4088 QDFFRBN $T=718580 830480 1 0 $X=718580 $Y=825060
X3944 3864 652 608 2 1 679 QDFFRBN $T=721680 709520 0 0 $X=721680 $Y=709140
X3945 4067 652 608 2 1 676 QDFFRBN $T=722300 699440 0 0 $X=722300 $Y=699060
X3946 4076 659 3376 2 1 680 QDFFRBN $T=723540 860720 0 0 $X=723540 $Y=860340
X3947 678 659 3376 2 1 666 QDFFRBN $T=735940 860720 0 180 $X=724160 $Y=855300
X3948 4082 652 677 2 1 4140 QDFFRBN $T=724780 770000 1 0 $X=724780 $Y=764580
X3949 683 659 3376 2 1 669 QDFFRBN $T=736560 870800 0 180 $X=724780 $Y=865380
X3950 686 659 3376 2 1 671 QDFFRBN $T=737180 870800 1 180 $X=725400 $Y=870420
X3951 4105 659 3376 2 1 4106 QDFFRBN $T=730980 820400 0 0 $X=730980 $Y=820020
X3952 4034 659 3376 2 1 4087 QDFFRBN $T=742760 840560 0 180 $X=730980 $Y=835140
X3953 638 620 677 2 1 699 QDFFRBN $T=730980 880880 1 0 $X=730980 $Y=875460
X3954 4125 652 677 2 1 4195 QDFFRBN $T=735320 780080 0 0 $X=735320 $Y=779700
X3955 4133 659 3376 2 1 4194 QDFFRBN $T=735320 830480 0 0 $X=735320 $Y=830100
X3956 698 659 3376 2 1 684 QDFFRBN $T=747100 850640 1 180 $X=735320 $Y=850260
X3957 701 4182 677 2 1 4137 QDFFRBN $T=748340 870800 0 180 $X=736560 $Y=865380
X3958 4149 652 608 2 1 4184 QDFFRBN $T=737800 729680 0 0 $X=737800 $Y=729300
X3959 700 659 3376 2 1 687 QDFFRBN $T=749580 860720 0 180 $X=737800 $Y=855300
X3960 701 4182 4142 2 1 689 QDFFRBN $T=749580 860720 1 180 $X=737800 $Y=860340
X3961 4075 659 3376 2 1 4107 QDFFRBN $T=750200 850640 0 180 $X=738420 $Y=845220
X3962 4174 652 608 2 1 4225 QDFFRBN $T=743380 739760 1 0 $X=743380 $Y=734340
X3963 4201 659 3376 2 1 694 QDFFRBN $T=755160 840560 0 180 $X=743380 $Y=835140
X3964 701 4182 677 2 1 4172 QDFFRBN $T=755160 870800 1 180 $X=743380 $Y=870420
X3965 4179 652 677 2 1 4247 QDFFRBN $T=745240 780080 1 0 $X=745240 $Y=774660
X3966 701 4182 4142 2 1 4250 QDFFRBN $T=748340 870800 1 0 $X=748340 $Y=865380
X3967 4122 4182 3376 2 1 4260 QDFFRBN $T=748960 850640 0 0 $X=748960 $Y=850260
X3968 4208 4182 3376 2 1 714 QDFFRBN $T=749580 860720 0 0 $X=749580 $Y=860340
X3969 4235 652 677 2 1 4271 QDFFRBN $T=755780 790160 1 0 $X=755780 $Y=784740
X3970 4229 652 608 2 1 4287 QDFFRBN $T=756400 739760 0 0 $X=756400 $Y=739380
X3971 4238 652 608 2 1 4294 QDFFRBN $T=757020 729680 0 0 $X=757020 $Y=729300
X3972 4239 4182 677 2 1 4296 QDFFRBN $T=757020 850640 1 0 $X=757020 $Y=845220
X3973 4253 652 677 2 1 4319 QDFFRBN $T=759500 830480 1 0 $X=759500 $Y=825060
X3974 701 4182 4142 2 1 4291 QDFFRBN $T=760120 870800 1 0 $X=760120 $Y=865380
X3975 4264 652 677 2 1 4332 QDFFRBN $T=761980 800240 0 0 $X=761980 $Y=799860
X3976 4262 4182 677 2 1 4312 QDFFRBN $T=762600 850640 0 0 $X=762600 $Y=850260
X3977 4269 4182 677 2 1 4290 QDFFRBN $T=762600 860720 0 0 $X=762600 $Y=860340
X3978 4274 652 677 2 1 4333 QDFFRBN $T=763220 820400 0 0 $X=763220 $Y=820020
X3979 4277 652 677 2 1 4348 QDFFRBN $T=764460 810320 1 0 $X=764460 $Y=804900
X3980 4040 4182 677 2 1 4338 QDFFRBN $T=765700 860720 1 0 $X=765700 $Y=855300
X3981 4284 652 677 2 1 4345 QDFFRBN $T=766320 800240 1 0 $X=766320 $Y=794820
X3982 4285 652 677 2 1 4351 QDFFRBN $T=766940 810320 0 0 $X=766940 $Y=809940
X3983 4297 4182 677 2 1 4365 QDFFRBN $T=768800 880880 1 0 $X=768800 $Y=875460
X3984 4320 4182 677 2 1 4414 QDFFRBN $T=775620 860720 0 0 $X=775620 $Y=860340
X3985 4344 4182 677 2 1 759 QDFFRBN $T=776860 850640 0 0 $X=776860 $Y=850260
X3986 4337 4182 677 2 1 4410 QDFFRBN $T=777480 870800 1 0 $X=777480 $Y=865380
X3987 4420 652 677 2 1 4462 QDFFRBN $T=789880 830480 0 0 $X=789880 $Y=830100
X3988 4421 4182 677 2 1 4471 QDFFRBN $T=789880 870800 1 0 $X=789880 $Y=865380
X3989 3583 659 677 2 1 4292 QDFFRBN $T=790500 860720 1 0 $X=790500 $Y=855300
X3990 4301 4182 677 2 1 4466 QDFFRBN $T=790500 860720 0 0 $X=790500 $Y=860340
X3991 4220 659 677 2 1 4475 QDFFRBN $T=792980 840560 0 0 $X=792980 $Y=840180
X3992 4442 4448 4142 2 1 4500 QDFFRBN $T=795460 780080 0 0 $X=795460 $Y=779700
X3993 4460 774 4142 2 1 4521 QDFFRBN $T=799800 840560 1 0 $X=799800 $Y=835140
X3994 794 659 4142 2 1 808 QDFFRBN $T=816540 860720 1 0 $X=816540 $Y=855300
X3995 4552 4448 4142 2 1 4519 QDFFRBN $T=818400 790160 1 0 $X=818400 $Y=784740
X3996 799 659 4142 2 1 810 QDFFRBN $T=818400 850640 1 0 $X=818400 $Y=845220
X3997 4572 4448 4142 2 1 4510 QDFFRBN $T=819640 790160 0 0 $X=819640 $Y=789780
X3998 802 659 4142 2 1 812 QDFFRBN $T=820880 860720 0 0 $X=820880 $Y=860340
X3999 4576 774 4142 2 1 4600 QDFFRBN $T=821500 840560 1 0 $X=821500 $Y=835140
X4000 803 659 4142 2 1 813 QDFFRBN $T=821500 870800 0 0 $X=821500 $Y=870420
X4001 4440 774 4142 2 1 4432 QDFFRBN $T=835140 800240 0 180 $X=823360 $Y=794820
X4002 811 659 4142 2 1 824 QDFFRBN $T=829560 860720 1 0 $X=829560 $Y=855300
X4003 4612 774 4142 2 1 4641 QDFFRBN $T=830180 850640 1 0 $X=830180 $Y=845220
X4004 3859 4635 4142 2 1 4672 QDFFRBN $T=834520 790160 1 0 $X=834520 $Y=784740
X4005 4054 4635 4142 2 1 4707 QDFFRBN $T=838240 800240 1 0 $X=838240 $Y=794820
X4006 821 659 4142 2 1 832 QDFFRBN $T=839480 870800 1 0 $X=839480 $Y=865380
X4007 4671 659 4142 2 1 844 QDFFRBN $T=846920 840560 0 0 $X=846920 $Y=840180
X4008 3796 4635 4711 2 1 4734 QDFFRBN $T=847540 790160 1 0 $X=847540 $Y=784740
X4009 4741 774 4711 2 1 4687 QDFFRBN $T=862420 759920 0 180 $X=850640 $Y=754500
X4010 3833 4635 4711 2 1 4743 QDFFRBN $T=850640 770000 0 0 $X=850640 $Y=769620
X4011 4692 774 4142 2 1 4736 QDFFRBN $T=850640 840560 1 0 $X=850640 $Y=835140
X4012 4049 4635 4142 2 1 4756 QDFFRBN $T=853120 800240 1 0 $X=853120 $Y=794820
X4013 4730 774 4711 2 1 4750 QDFFRBN $T=856220 770000 1 0 $X=856220 $Y=764580
X4014 4764 774 4711 2 1 4629 QDFFRBN $T=868000 800240 1 180 $X=856220 $Y=799860
X4015 4765 774 4711 2 1 4642 QDFFRBN $T=868000 810320 1 180 $X=856220 $Y=809940
X4016 3818 4635 4711 2 1 4744 QDFFRBN $T=857460 780080 0 0 $X=857460 $Y=779700
X4017 4773 774 4711 2 1 4742 QDFFRBN $T=873580 759920 1 180 $X=861800 $Y=759540
X4018 4643 4785 4711 2 1 4745 QDFFRBN $T=873580 790160 0 180 $X=861800 $Y=784740
X4019 4801 774 4142 2 1 4686 QDFFRBN $T=876060 820400 0 180 $X=864280 $Y=814980
X4020 3784 4635 4711 2 1 4842 QDFFRBN $T=869860 810320 0 0 $X=869860 $Y=809940
X4021 4777 4785 4711 2 1 4814 QDFFRBN $T=870480 810320 1 0 $X=870480 $Y=804900
X4022 4794 774 4711 2 1 4845 QDFFRBN $T=871720 749840 1 0 $X=871720 $Y=744420
X4023 3784 4635 4711 2 1 4830 QDFFRBN $T=872340 820400 0 0 $X=872340 $Y=820020
X4024 4725 774 4142 2 1 4782 QDFFRBN $T=873580 719600 0 0 $X=873580 $Y=719220
X4025 885 4785 4711 2 1 4781 QDFFRBN $T=885360 759920 1 180 $X=873580 $Y=759540
X4026 886 4785 4711 2 1 4800 QDFFRBN $T=885360 790160 0 180 $X=873580 $Y=784740
X4027 4808 774 4142 2 1 4863 QDFFRBN $T=874820 739760 1 0 $X=874820 $Y=734340
X4028 876 774 887 2 1 815 QDFFRBN $T=876680 709520 1 0 $X=876680 $Y=704100
X4029 4806 4785 4711 2 1 4855 QDFFRBN $T=876680 770000 1 0 $X=876680 $Y=764580
X4030 4828 774 4142 2 1 4609 QDFFRBN $T=877300 709520 0 0 $X=877300 $Y=709140
X4031 4833 774 4142 2 1 4885 QDFFRBN $T=878540 729680 1 0 $X=878540 $Y=724260
X4032 4823 774 4142 2 1 4879 QDFFRBN $T=878540 729680 0 0 $X=878540 $Y=729300
X4033 4850 4785 4711 2 1 4882 QDFFRBN $T=882880 759920 1 0 $X=882880 $Y=754500
X4034 4777 4785 4711 2 1 4852 QDFFRBN $T=895280 800240 1 180 $X=883500 $Y=799860
X4035 3909 4635 4711 2 1 4892 QDFFRBN $T=884120 790160 0 0 $X=884120 $Y=789780
X4036 3784 4635 4711 2 1 4836 QDFFRBN $T=896520 820400 1 180 $X=884740 $Y=820020
X4037 898 4785 4711 2 1 4859 QDFFRBN $T=897140 749840 0 180 $X=885360 $Y=744420
X4038 4777 4785 4711 2 1 4888 QDFFRBN $T=888460 810320 1 0 $X=888460 $Y=804900
X4039 3970 4635 4711 2 1 4912 QDFFRBN $T=889080 790160 1 0 $X=889080 $Y=784740
X4040 4840 4785 887 2 1 4899 QDFFRBN $T=889700 739760 0 0 $X=889700 $Y=739380
X4041 3868 4635 4711 2 1 4915 QDFFRBN $T=889700 770000 0 0 $X=889700 $Y=769620
X4042 3994 4635 4711 2 1 4916 QDFFRBN $T=889700 780080 1 0 $X=889700 $Y=774660
X4043 906 659 887 2 1 894 QDFFRBN $T=902720 699440 1 180 $X=890940 $Y=699060
X4044 3895 4635 4711 2 1 4922 QDFFRBN $T=890940 770000 1 0 $X=890940 $Y=764580
X4045 3784 4635 4711 2 1 4924 QDFFRBN $T=890940 810320 0 0 $X=890940 $Y=809940
X4046 3904 4635 4711 2 1 4940 QDFFRBN $T=893420 759920 0 0 $X=893420 $Y=759540
X4047 4777 4785 4711 2 1 4954 QDFFRBN $T=895900 800240 0 0 $X=895900 $Y=799860
X4048 3784 4635 4711 2 1 4964 QDFFRBN $T=897140 820400 0 0 $X=897140 $Y=820020
X4049 901 659 887 2 1 920 QDFFRBN $T=898380 709520 1 0 $X=898380 $Y=704100
X4050 4901 4785 887 2 1 4983 QDFFRBN $T=898380 719600 0 0 $X=898380 $Y=719220
X4051 4908 4785 887 2 1 4978 QDFFRBN $T=899620 719600 1 0 $X=899620 $Y=714180
X4052 4909 4785 887 2 1 4970 QDFFRBN $T=899620 729680 1 0 $X=899620 $Y=724260
X4053 4777 4785 4711 2 1 4995 QDFFRBN $T=901480 810320 1 0 $X=901480 $Y=804900
X4054 4934 4785 887 2 1 4979 QDFFRBN $T=903340 729680 0 0 $X=903340 $Y=729300
X4055 4906 4785 887 2 1 4994 QDFFRBN $T=903340 739760 1 0 $X=903340 $Y=734340
X4056 5008 659 887 2 1 910 QDFFRBN $T=916360 709520 1 180 $X=904580 $Y=709140
X4057 4998 659 887 2 1 5044 QDFFRBN $T=913880 709520 1 0 $X=913880 $Y=704100
X4058 3385 3395 535 3446 1 2 QDFFRBP $T=590860 850640 1 0 $X=590860 $Y=845220
X4059 3402 3395 535 3411 1 2 QDFFRBP $T=594580 860720 1 0 $X=594580 $Y=855300
X4060 131 121 1 2 BUF2 $T=335420 719600 1 180 $X=332320 $Y=719220
X4061 210 227 1 2 BUF2 $T=411060 790160 1 0 $X=411060 $Y=784740
X4062 288 284 1 2 BUF2 $T=455080 709520 0 180 $X=451980 $Y=704100
X4063 2714 2735 1 2 BUF2 $T=473680 739760 1 0 $X=473680 $Y=734340
X4064 434 2205 1 2 BUF2 $T=533820 759920 1 0 $X=533820 $Y=754500
X4065 3449 3266 1 2 BUF2 $T=637360 810320 0 0 $X=637360 $Y=809940
X4066 4368 723 1 2 BUF2 $T=782440 759920 1 180 $X=779340 $Y=759540
X4067 1989 2051 2044 2 1 2082 OR3 $T=384400 820400 0 180 $X=380680 $Y=814980
X4068 2934 3056 3147 2 1 2648 OR3 $T=549940 790160 1 180 $X=546220 $Y=789780
X4069 3079 2 3092 3102 3064 1 3111 FA1S $T=527620 719600 0 0 $X=527620 $Y=719220
X4070 3119 2 3148 3146 3107 1 3156 FA1S $T=538160 759920 0 0 $X=538160 $Y=759540
X4071 3204 2 3177 3237 3220 1 3169 FA1S $T=564200 729680 1 180 $X=552420 $Y=729300
X4072 3211 2 3165 3230 3204 1 3175 FA1S $T=564820 719600 0 180 $X=553040 $Y=714180
X4073 509 2 500 515 3284 1 493 FA1S $T=579700 699440 1 180 $X=567920 $Y=699060
X4074 3316 2 500 523 3321 1 502 FA1S $T=584040 709520 0 180 $X=572260 $Y=704100
X4075 3512 2 3297 3521 3476 1 3483 FA1S $T=624960 810320 1 180 $X=613180 $Y=809940
X4076 561 2 554 3493 558 1 3479 FA1S $T=615660 699440 0 0 $X=615660 $Y=699060
X4077 3548 2 3348 3537 3512 1 3571 FA1S $T=623720 810320 1 0 $X=623720 $Y=804900
X4078 3554 2 573 3550 3543 1 581 FA1S $T=626200 709520 0 0 $X=626200 $Y=709140
X4079 3591 2 3567 3259 3598 1 3626 FA1S $T=632400 830480 1 0 $X=632400 $Y=825060
X4080 3593 2 3567 3312 3606 1 3637 FA1S $T=633020 820400 0 0 $X=633020 $Y=820020
X4081 3602 2 3586 3539 582 1 3641 FA1S $T=634260 870800 0 0 $X=634260 $Y=870420
X4082 3598 2 3581 3207 3618 1 3654 FA1S $T=635500 840560 0 0 $X=635500 $Y=840180
X4083 3606 2 3581 3449 3599 1 3635 FA1S $T=635500 850640 1 0 $X=635500 $Y=845220
X4084 3599 2 3600 3589 3601 1 3648 FA1S $T=635500 870800 1 0 $X=635500 $Y=865380
X4085 3601 2 3586 3518 583 1 3655 FA1S $T=635500 880880 1 0 $X=635500 $Y=875460
X4086 3618 2 3600 3258 3602 1 3659 FA1S $T=636740 860720 1 0 $X=636740 $Y=855300
X4087 3656 2 587 3628 3627 1 593 FA1S $T=643560 719600 1 0 $X=643560 $Y=714180
X4088 3664 2 3506 3603 3643 1 3652 FA1S $T=646040 800240 1 0 $X=646040 $Y=794820
X4089 3680 2 584 3672 3656 1 588 FA1S $T=659060 709520 1 180 $X=647280 $Y=709140
X4090 3703 2 590 3622 3680 1 606 FA1S $T=654720 709520 1 0 $X=654720 $Y=704100
X4091 3726 2 3674 3612 3695 1 3741 FA1S $T=657820 780080 1 0 $X=657820 $Y=774660
X4092 604 2 580 595 3703 1 611 FA1S $T=659060 699440 0 0 $X=659060 $Y=699060
X4093 3772 2 3590 3712 3726 1 3737 FA1S $T=677660 759920 1 180 $X=665880 $Y=759540
X4094 3782 2 3614 3735 3772 1 3757 FA1S $T=668980 749840 0 0 $X=668980 $Y=749460
X4095 3785 2 3590 3811 3750 1 3748 FA1S $T=669600 759920 1 0 $X=669600 $Y=754500
X4096 3807 2 3572 3830 3824 1 3762 FA1S $T=685100 719600 1 180 $X=673320 $Y=719220
X4097 3791 2 3572 3679 3812 1 3753 FA1S $T=685720 729680 1 180 $X=673940 $Y=729300
X4098 3812 2 3638 3642 3782 1 3800 FA1S $T=674560 739760 0 0 $X=674560 $Y=739380
X4099 3822 2 3614 3754 3785 1 3764 FA1S $T=686340 749840 0 180 $X=674560 $Y=744420
X4100 3836 2 3831 3845 3848 1 3804 FA1S $T=689440 830480 0 180 $X=677660 $Y=825060
X4101 3845 2 3863 3869 3856 1 3813 FA1S $T=691920 840560 0 180 $X=680140 $Y=835140
X4102 3824 2 3638 3783 3822 1 3820 FA1S $T=681380 739760 1 0 $X=681380 $Y=734340
X4103 3846 2 3871 3877 3857 1 3823 FA1S $T=694400 860720 0 180 $X=682620 $Y=855300
X4104 3869 2 3905 3846 3866 1 3829 FA1S $T=696260 850640 0 180 $X=684480 $Y=845220
X4105 3886 2 3955 3930 3927 1 3848 FA1S $T=701220 830480 0 180 $X=689440 $Y=825060
X4106 3896 2 3944 3936 3939 1 3866 FA1S $T=703080 850640 1 180 $X=691300 $Y=850260
X4107 3930 2 3908 3896 3938 1 3856 FA1S $T=703700 840560 0 180 $X=691920 $Y=835140
X4108 3952 2 3980 3922 3960 1 3907 FA1S $T=707420 790160 1 180 $X=695640 $Y=789780
X4109 3922 2 3923 3897 3931 1 3982 FA1S $T=695640 800240 1 0 $X=695640 $Y=794820
X4110 3949 2 3954 3934 3937 1 3960 FA1S $T=698120 770000 0 0 $X=698120 $Y=769620
X4111 3959 2 3986 3949 3940 1 3995 FA1S $T=699360 780080 0 0 $X=699360 $Y=779700
X4112 3981 2 3963 3951 3971 1 3940 FA1S $T=712380 759920 1 180 $X=700600 $Y=759540
X4113 3976 2 3957 3964 3861 1 4024 FA1S $T=703700 810320 0 0 $X=703700 $Y=809940
X4114 3993 2 4000 3976 3982 1 4031 FA1S $T=705560 800240 0 0 $X=705560 $Y=799860
X4115 4008 2 4022 4019 3977 1 3927 FA1S $T=717340 830480 1 180 $X=705560 $Y=830100
X4116 4003 2 3989 3962 3942 1 4038 FA1S $T=707420 749840 1 0 $X=707420 $Y=744420
X4117 4004 2 4023 3952 3995 1 4039 FA1S $T=707420 790160 0 0 $X=707420 $Y=789780
X4118 4019 2 3983 3991 4029 1 3938 FA1S $T=719200 850640 0 180 $X=707420 $Y=845220
X4119 4027 2 4041 4004 4007 1 4064 FA1S $T=711140 780080 0 0 $X=711140 $Y=779700
X4120 4012 2 3999 3981 4038 1 4060 FA1S $T=713000 759920 0 0 $X=713000 $Y=759540
X4121 4048 2 4028 3959 4060 1 4007 FA1S $T=724780 770000 1 180 $X=713000 $Y=769620
X4122 4058 2 4033 3993 3907 1 4092 FA1S $T=717340 800240 0 0 $X=717340 $Y=799860
X4123 4074 2 4080 4058 4039 1 4099 FA1S $T=719200 790160 0 0 $X=719200 $Y=789780
X4124 4094 2 4079 4114 4103 1 4069 FA1S $T=734700 719600 1 180 $X=722920 $Y=719220
X4125 4170 2 4171 4187 4148 1 4136 FA1S $T=748340 749840 0 180 $X=736560 $Y=744420
X4126 4151 2 4140 4196 4202 1 4132 FA1S $T=752060 759920 1 180 $X=740280 $Y=759540
X4127 4135 2 4237 4221 4217 1 4124 FA1S $T=756400 709520 1 180 $X=744620 $Y=709140
X4128 4234 2 4263 4212 4170 1 4205 FA1S $T=761360 749840 0 180 $X=749580 $Y=744420
X4129 4197 2 4140 4240 4241 1 4119 FA1S $T=761980 770000 0 180 $X=750200 $Y=764580
X4130 4245 2 4263 4219 4206 1 4211 FA1S $T=763840 759920 0 180 $X=752060 $Y=754500
X4131 4280 2 4298 4314 4234 1 4249 FA1S $T=771280 749840 1 180 $X=759500 $Y=749460
X4132 4202 2 4318 4323 4280 1 4252 FA1S $T=771900 759920 1 180 $X=760120 $Y=759540
X4133 4311 2 4298 4324 4245 1 4275 FA1S $T=777480 759920 0 180 $X=765700 $Y=754500
X4134 4335 2 4333 4362 4346 1 4300 FA1S $T=781200 820400 0 180 $X=769420 $Y=814980
X4135 4266 2 4247 734 4380 1 4377 FA1S $T=770040 770000 0 0 $X=770040 $Y=769620
X4136 4299 2 4247 735 4363 1 4389 FA1S $T=773760 780080 1 0 $X=773760 $Y=774660
X4137 4375 2 4348 4413 4387 1 4339 FA1S $T=788640 800240 1 180 $X=776860 $Y=799860
X4138 4363 2 4345 743 4393 1 4405 FA1S $T=777480 780080 0 0 $X=777480 $Y=779700
X4139 4346 2 4319 4398 4394 1 4334 FA1S $T=789880 830480 1 180 $X=778100 $Y=830100
X4140 4378 2 4351 4403 4412 1 4417 FA1S $T=778720 810320 0 0 $X=778720 $Y=809940
X4141 4380 2 4345 4368 4375 1 4411 FA1S $T=779340 790160 0 0 $X=779340 $Y=789780
X4142 4393 2 4348 717 4378 1 4353 FA1S $T=791120 800240 0 180 $X=779340 $Y=794820
X4143 4402 2 4319 4397 4409 1 4327 FA1S $T=792360 820400 1 180 $X=780580 $Y=820020
X4144 4387 2 4351 4452 4335 1 4427 FA1S $T=789880 820400 1 0 $X=789880 $Y=814980
X4145 4394 2 4435 4479 4456 1 4428 FA1S $T=803520 830480 0 180 $X=791740 $Y=825060
X4146 4409 2 4435 4464 4473 1 4482 FA1S $T=792360 820400 0 0 $X=792360 $Y=820020
X4147 4412 2 4333 4388 4402 1 4364 FA1S $T=794220 810320 0 0 $X=794220 $Y=809940
X4148 4473 2 4553 4503 4540 1 4491 FA1S $T=817160 820400 1 180 $X=805380 $Y=820020
X4149 4456 2 4553 4541 4520 1 4492 FA1S $T=817160 830480 1 180 $X=805380 $Y=830100
X4150 4520 2 4600 4582 4594 1 4549 FA1S $T=827700 830480 0 180 $X=815920 $Y=825060
X4151 4540 2 4600 4580 4597 1 4556 FA1S $T=828940 820400 0 180 $X=817160 $Y=814980
X4152 4597 2 4641 4610 4638 1 4601 FA1S $T=839480 830480 0 180 $X=827700 $Y=825060
X4153 4618 2 4560 4458 4624 1 4647 FA1S $T=828320 759920 0 0 $X=828320 $Y=759540
X4154 4621 2 4642 4613 4648 1 4651 FA1S $T=828940 820400 1 0 $X=828940 $Y=814980
X4155 4624 2 4554 4437 4636 1 4655 FA1S $T=830180 759920 1 0 $X=830180 $Y=754500
X4156 4636 2 4522 4406 4654 1 4664 FA1S $T=832040 749840 0 0 $X=832040 $Y=749460
X4157 4677 2 4560 4645 4683 1 4644 FA1S $T=851260 770000 0 180 $X=839480 $Y=764580
X4158 4594 2 4641 4637 4681 1 4631 FA1S $T=851260 830480 0 180 $X=839480 $Y=825060
X4159 4668 2 4686 4548 4680 1 4706 FA1S $T=840720 820400 1 0 $X=840720 $Y=814980
X4160 4660 2 4574 4419 4674 1 4716 FA1S $T=841340 729680 0 0 $X=841340 $Y=729300
X4161 4680 2 4642 4585 4666 1 4728 FA1S $T=842580 810320 1 0 $X=842580 $Y=804900
X4162 4678 2 815 4399 4691 1 4713 FA1S $T=843820 709520 1 0 $X=843820 $Y=704100
X4163 4691 2 823 4532 828 1 4729 FA1S $T=845060 699440 0 0 $X=845060 $Y=699060
X4164 4721 2 4686 4699 4621 1 4709 FA1S $T=851260 830480 1 0 $X=851260 $Y=825060
X4165 4638 2 4736 4544 4668 1 4708 FA1S $T=852500 820400 1 0 $X=852500 $Y=814980
X4166 4731 2 4584 4684 4757 1 4763 FA1S $T=853740 749840 1 0 $X=853740 $Y=744420
X4167 4737 2 823 4732 840 1 4751 FA1S $T=856220 709520 1 0 $X=856220 $Y=704100
X4168 4738 2 4609 4696 4747 1 4780 FA1S $T=856220 719600 1 0 $X=856220 $Y=714180
X4169 4739 2 4574 4712 4697 1 4774 FA1S $T=856840 729680 0 0 $X=856840 $Y=729300
X4170 4747 2 815 4682 4737 1 4783 FA1S $T=858080 709520 0 0 $X=858080 $Y=709140
X4171 4681 2 4736 4659 4721 1 4704 FA1S $T=863040 830480 1 0 $X=863040 $Y=825060
X4172 2193 2169 2218 2 1 XNR2HS $T=400520 790160 1 0 $X=400520 $Y=784740
X4173 2813 2270 368 2 1 XNR2HS $T=489180 780080 1 0 $X=489180 $Y=774660
X4174 2923 2270 396 2 1 XNR2HS $T=504060 770000 0 0 $X=504060 $Y=769620
X4175 2711 2835 3004 2 1 XNR2HS $T=512740 749840 0 0 $X=512740 $Y=749460
X4176 3114 3116 3126 2 1 XNR2HS $T=538780 749840 1 0 $X=538780 $Y=744420
X4177 3141 456 3154 2 1 XNR2HS $T=545600 699440 0 0 $X=545600 $Y=699060
X4178 3319 2270 510 2 1 XNR2HS $T=580320 810320 1 180 $X=574740 $Y=809940
X4179 3557 3631 3647 2 1 XNR2HS $T=642940 840560 1 0 $X=642940 $Y=835140
X4180 3623 3593 3646 2 1 XNR2HS $T=651000 830480 0 180 $X=645420 $Y=825060
X4181 3557 3662 3668 2 1 XNR2HS $T=648520 840560 1 0 $X=648520 $Y=835140
X4182 647 646 643 2 1 XNR2HS $T=708040 880880 0 180 $X=702460 $Y=875460
X4183 4158 679 4166 2 1 XNR2HS $T=745860 719600 0 0 $X=745860 $Y=719220
X4184 4134 4194 4255 2 1 XNR2HS $T=757020 830480 0 0 $X=757020 $Y=830100
X4185 4271 4266 4251 2 1 XNR2HS $T=764460 770000 1 180 $X=758880 $Y=769620
X4186 4293 4288 4257 2 1 XNR2HS $T=769420 790160 1 180 $X=763840 $Y=789780
X4187 4293 4316 4272 2 1 XNR2HS $T=775000 790160 1 180 $X=769420 $Y=789780
X4188 619 4255 4430 2 1 XNR2HS $T=788640 850640 0 0 $X=788640 $Y=850260
X4189 619 4268 4449 2 1 XNR2HS $T=794840 850640 1 0 $X=794840 $Y=845220
X4190 4626 4629 4640 2 1 XNR2HS $T=833900 810320 1 0 $X=833900 $Y=804900
X4191 1923 1916 1952 2 1 XOR2HS $T=354020 759920 0 0 $X=354020 $Y=759540
X4192 1947 1931 1976 2 1 XOR2HS $T=358360 749840 0 0 $X=358360 $Y=749460
X4193 2001 1933 1994 2 1 XOR2HS $T=370140 759920 0 180 $X=364560 $Y=754500
X4194 1991 2003 2023 2 1 XOR2HS $T=368280 749840 0 0 $X=368280 $Y=749460
X4195 2017 2013 2026 2 1 XOR2HS $T=368900 770000 0 0 $X=368900 $Y=769620
X4196 169 171 2067 2 1 XOR2HS $T=374480 699440 0 0 $X=374480 $Y=699060
X4197 2027 2030 2071 2 1 XOR2HS $T=375100 709520 0 0 $X=375100 $Y=709140
X4198 2043 2074 2085 2 1 XOR2HS $T=377580 749840 0 0 $X=377580 $Y=749460
X4199 2054 2061 2087 2 1 XOR2HS $T=378200 729680 1 0 $X=378200 $Y=724260
X4200 2076 2078 2088 2 1 XOR2HS $T=378820 759920 0 0 $X=378820 $Y=759540
X4201 2036 2040 2090 2 1 XOR2HS $T=379440 709520 1 0 $X=379440 $Y=704100
X4202 2083 2072 2091 2 1 XOR2HS $T=380060 719600 0 0 $X=380060 $Y=719220
X4203 2069 2058 2089 2 1 XOR2HS $T=380060 770000 0 0 $X=380060 $Y=769620
X4204 2062 2075 2097 2 1 XOR2HS $T=381300 729680 0 0 $X=381300 $Y=729300
X4205 2055 2073 2098 2 1 XOR2HS $T=381300 739760 1 0 $X=381300 $Y=734340
X4206 2031 2096 2112 2 1 XOR2HS $T=383160 780080 1 0 $X=383160 $Y=774660
X4207 2080 2070 2068 2 1 XOR2HS $T=389360 870800 1 180 $X=383780 $Y=870420
X4208 2125 2120 2103 2 1 XOR2HS $T=389980 860720 0 180 $X=384400 $Y=855300
X4209 2050 2127 2111 2 1 XOR2HS $T=391220 770000 1 180 $X=385640 $Y=769620
X4210 2086 2133 2104 2 1 XOR2HS $T=391840 870800 0 180 $X=386260 $Y=865380
X4211 2114 2111 2154 2 1 XOR2HS $T=388740 780080 1 0 $X=388740 $Y=774660
X4212 2095 2157 2116 2 1 XOR2HS $T=394320 850640 1 180 $X=388740 $Y=850260
X4213 2180 2175 2108 2 1 XOR2HS $T=397420 749840 0 180 $X=391840 $Y=744420
X4214 2129 2165 2177 2 1 XOR2HS $T=393080 739760 1 0 $X=393080 $Y=734340
X4215 2187 2203 2213 2 1 XOR2HS $T=398660 739760 1 0 $X=398660 $Y=734340
X4216 2225 2112 2214 2 1 XOR2HS $T=407340 770000 1 180 $X=401760 $Y=769620
X4217 2237 2248 2264 2 1 XOR2HS $T=407340 749840 1 0 $X=407340 $Y=744420
X4218 2259 2257 2288 2 1 XOR2HS $T=411680 739760 1 0 $X=411680 $Y=734340
X4219 2281 2298 2285 2 1 XOR2HS $T=419120 749840 1 180 $X=413540 $Y=749460
X4220 2293 2306 2193 2 1 XOR2HS $T=419740 780080 1 180 $X=414160 $Y=779700
X4221 2318 2305 2333 2 1 XOR2HS $T=419740 759920 1 0 $X=419740 $Y=754500
X4222 2351 2345 2330 2 1 XOR2HS $T=426560 739760 1 180 $X=420980 $Y=739380
X4223 2321 2244 2346 2 1 XOR2HS $T=421600 739760 1 0 $X=421600 $Y=734340
X4224 2381 2352 2283 2 1 XOR2HS $T=429660 780080 0 180 $X=424080 $Y=774660
X4225 2349 2359 2376 2 1 XOR2HS $T=424700 729680 1 0 $X=424700 $Y=724260
X4226 2384 2390 2319 2 1 XOR2HS $T=431520 790160 1 180 $X=425940 $Y=789780
X4227 2362 2331 2399 2 1 XOR2HS $T=427800 749840 1 0 $X=427800 $Y=744420
X4228 2368 2373 258 2 1 XOR2HS $T=428420 709520 1 0 $X=428420 $Y=704100
X4229 2393 2379 2419 2 1 XOR2HS $T=430900 719600 0 0 $X=430900 $Y=719220
X4230 2434 2431 2378 2 1 XOR2HS $T=437720 800240 0 180 $X=432140 $Y=794820
X4231 2412 2404 2445 2 1 XOR2HS $T=434000 709520 0 0 $X=434000 $Y=709140
X4232 2461 2339 2390 2 1 XOR2HS $T=440820 800240 1 180 $X=435240 $Y=799860
X4233 2360 2380 2405 2 1 XOR2HS $T=435860 729680 0 0 $X=435860 $Y=729300
X4234 2408 2479 2494 2 1 XOR2HS $T=440820 790160 1 0 $X=440820 $Y=784740
X4235 2507 2291 2431 2 1 XOR2HS $T=447640 800240 0 180 $X=442060 $Y=794820
X4236 2389 2538 2479 2 1 XOR2HS $T=451980 790160 0 180 $X=446400 $Y=784740
X4237 2586 2580 2562 2 1 XOR2HS $T=458800 759920 0 180 $X=453220 $Y=754500
X4238 2589 2587 2550 2 1 XOR2HS $T=459420 759920 1 180 $X=453840 $Y=759540
X4239 2612 2608 2590 2 1 XOR2HS $T=463140 780080 0 180 $X=457560 $Y=774660
X4240 2606 2616 2666 2 1 XOR2HS $T=464380 770000 1 0 $X=464380 $Y=764580
X4241 2633 2629 2674 2 1 XOR2HS $T=465000 749840 0 0 $X=465000 $Y=749460
X4242 2716 2665 2687 2 1 XOR2HS $T=474920 759920 0 180 $X=469340 $Y=754500
X4243 2486 2707 2741 2 1 XOR2HS $T=478640 770000 0 0 $X=478640 $Y=769620
X4244 2745 2746 2769 2 1 XOR2HS $T=479260 759920 1 0 $X=479260 $Y=754500
X4245 2775 2765 2810 2 1 XOR2HS $T=485460 709520 1 0 $X=485460 $Y=704100
X4246 2789 2794 2811 2 1 XOR2HS $T=485460 729680 1 0 $X=485460 $Y=724260
X4247 2777 2785 2805 2 1 XOR2HS $T=486080 729680 0 0 $X=486080 $Y=729300
X4248 2768 2786 2821 2 1 XOR2HS $T=487320 739760 0 0 $X=487320 $Y=739380
X4249 2816 2807 2836 2 1 XOR2HS $T=489180 719600 0 0 $X=489180 $Y=719220
X4250 2808 2754 2837 2 1 XOR2HS $T=489180 749840 0 0 $X=489180 $Y=749460
X4251 2803 2798 2838 2 1 XOR2HS $T=489800 709520 0 0 $X=489800 $Y=709140
X4252 2874 2893 2909 2 1 XOR2HS $T=499100 729680 0 0 $X=499100 $Y=729300
X4253 2872 2891 2931 2 1 XOR2HS $T=502820 699440 0 0 $X=502820 $Y=699060
X4254 2848 2909 2949 2 1 XOR2HS $T=504680 729680 0 0 $X=504680 $Y=729300
X4255 2919 2931 2976 2 1 XOR2HS $T=508400 699440 0 0 $X=508400 $Y=699060
X4256 2541 2949 2969 2 1 XOR2HS $T=518320 729680 0 0 $X=518320 $Y=729300
X4257 2444 2976 3055 2 1 XOR2HS $T=523280 699440 0 0 $X=523280 $Y=699060
X4258 3055 3047 3066 2 1 XOR2HS $T=524520 709520 1 0 $X=524520 $Y=704100
X4259 3104 3116 3145 2 1 XOR2HS $T=544980 749840 0 0 $X=544980 $Y=749460
X4260 3152 456 3173 2 1 XOR2HS $T=549320 709520 1 0 $X=549320 $Y=704100
X4261 3340 3378 3394 2 1 XOR2HS $T=588380 820400 0 0 $X=588380 $Y=820020
X4262 3432 3421 547 2 1 XOR2HS $T=607600 820400 0 0 $X=607600 $Y=820020
X4263 3297 3459 3532 2 1 XOR2HS $T=621240 830480 1 0 $X=621240 $Y=825060
X4264 3348 3515 3535 2 1 XOR2HS $T=621860 820400 0 0 $X=621860 $Y=820020
X4265 3623 3591 3658 2 1 XOR2HS $T=649760 820400 1 0 $X=649760 $Y=814980
X4266 3506 3561 602 2 1 XOR2HS $T=658440 820400 1 0 $X=658440 $Y=814980
X4267 3505 3698 3752 2 1 XOR2HS $T=664020 820400 1 0 $X=664020 $Y=814980
X4268 3767 610 3733 2 1 XOR2HS $T=672080 880880 0 180 $X=666500 $Y=875460
X4269 3590 3766 607 2 1 XOR2HS $T=672700 810320 1 180 $X=667120 $Y=809940
X4270 3545 3747 613 2 1 XOR2HS $T=669600 820400 1 0 $X=669600 $Y=814980
X4271 3786 3777 3711 2 1 XOR2HS $T=675180 830480 0 180 $X=669600 $Y=825060
X4272 589 3771 3784 2 1 XOR2HS $T=670220 800240 0 0 $X=670220 $Y=799860
X4273 3651 500 3796 2 1 XOR2HS $T=672700 790160 1 0 $X=672700 $Y=784740
X4274 3802 3798 3706 2 1 XOR2HS $T=678280 850640 0 180 $X=672700 $Y=845220
X4275 3787 3789 3749 2 1 XOR2HS $T=678900 840560 0 180 $X=673320 $Y=835140
X4276 3817 3799 3746 2 1 XOR2HS $T=681380 860720 0 180 $X=675800 $Y=855300
X4277 3414 3793 3818 2 1 XOR2HS $T=677040 780080 1 0 $X=677040 $Y=774660
X4278 3805 3815 3760 2 1 XOR2HS $T=682620 870800 0 180 $X=677040 $Y=865380
X4279 3674 3788 621 2 1 XOR2HS $T=677660 820400 1 0 $X=677660 $Y=814980
X4280 590 3808 3825 2 1 XOR2HS $T=678900 780080 0 0 $X=678900 $Y=779700
X4281 580 3806 3826 2 1 XOR2HS $T=678900 800240 1 0 $X=678900 $Y=794820
X4282 3572 3809 622 2 1 XOR2HS $T=679520 800240 0 0 $X=679520 $Y=799860
X4283 3633 3814 3833 2 1 XOR2HS $T=680760 770000 1 0 $X=680760 $Y=764580
X4284 584 3794 3840 2 1 XOR2HS $T=682000 790160 1 0 $X=682000 $Y=784740
X4285 3638 3832 3827 2 1 XOR2HS $T=682620 810320 0 0 $X=682620 $Y=809940
X4286 587 3841 3855 2 1 XOR2HS $T=684480 800240 1 0 $X=684480 $Y=794820
X4287 3792 3797 3860 2 1 XOR2HS $T=685720 800240 0 0 $X=685720 $Y=799860
X4288 3872 3867 3821 2 1 XOR2HS $T=691300 870800 1 180 $X=685720 $Y=870420
X4289 3566 3837 3868 2 1 XOR2HS $T=686340 770000 0 0 $X=686340 $Y=769620
X4290 573 3828 3875 2 1 XOR2HS $T=686960 780080 1 0 $X=686960 $Y=774660
X4291 576 3844 3881 2 1 XOR2HS $T=688200 780080 0 0 $X=688200 $Y=779700
X4292 3880 3879 3861 2 1 XOR2HS $T=693780 810320 0 180 $X=688200 $Y=804900
X4293 3614 3816 3882 2 1 XOR2HS $T=688200 810320 0 0 $X=688200 $Y=809940
X4294 554 3865 3895 2 1 XOR2HS $T=690060 770000 1 0 $X=690060 $Y=764580
X4295 3511 3847 3904 2 1 XOR2HS $T=691920 759920 0 0 $X=691920 $Y=759540
X4296 3935 3932 3910 2 1 XOR2HS $T=700600 810320 1 180 $X=695020 $Y=809940
X4297 3915 3921 3937 2 1 XOR2HS $T=696260 770000 1 0 $X=696260 $Y=764580
X4298 3918 3912 3931 2 1 XOR2HS $T=696260 790160 1 0 $X=696260 $Y=784740
X4299 3928 3914 3941 2 1 XOR2HS $T=697500 739760 1 0 $X=697500 $Y=734340
X4300 3925 3903 3942 2 1 XOR2HS $T=697500 749840 1 0 $X=697500 $Y=744420
X4301 3948 3900 3971 2 1 XOR2HS $T=701840 759920 1 0 $X=701840 $Y=754500
X4302 3973 3972 3939 2 1 XOR2HS $T=707420 850640 0 180 $X=701840 $Y=845220
X4303 3961 3969 3979 2 1 XOR2HS $T=703700 739760 1 0 $X=703700 $Y=734340
X4304 3968 3956 3992 2 1 XOR2HS $T=706180 709520 0 0 $X=706180 $Y=709140
X4305 3958 3950 3985 2 1 XOR2HS $T=707420 719600 1 0 $X=707420 $Y=714180
X4306 3945 3967 3857 2 1 XOR2HS $T=709900 860720 0 0 $X=709900 $Y=860340
X4307 4074 4064 4104 2 1 XOR2HS $T=727880 790160 1 0 $X=727880 $Y=784740
X4308 4093 4102 4130 2 1 XOR2HS $T=732220 820400 1 0 $X=732220 $Y=814980
X4309 4088 4106 4134 2 1 XOR2HS $T=732840 830480 1 0 $X=732840 $Y=825060
X4310 4096 4113 4145 2 1 XOR2HS $T=734080 810320 1 0 $X=734080 $Y=804900
X4311 4101 4100 4154 2 1 XOR2HS $T=735940 800240 0 0 $X=735940 $Y=799860
X4312 4112 4118 4160 2 1 XOR2HS $T=737180 800240 1 0 $X=737180 $Y=794820
X4313 4144 4147 4163 2 1 XOR2HS $T=738420 790160 1 0 $X=738420 $Y=784740
X4314 4126 4123 4164 2 1 XOR2HS $T=738420 790160 0 0 $X=738420 $Y=789780
X4315 4150 4156 4165 2 1 XOR2HS $T=738420 820400 1 0 $X=738420 $Y=814980
X4316 4188 4224 704 2 1 XOR2HS $T=756400 830480 1 180 $X=750820 $Y=830100
X4317 4079 4215 4098 2 1 XOR2HS $T=756400 850640 0 180 $X=750820 $Y=845220
X4318 679 4226 4199 2 1 XOR2HS $T=757020 729680 1 180 $X=751440 $Y=729300
X4319 4237 4246 4259 2 1 XOR2HS $T=758260 719600 0 0 $X=758260 $Y=719220
X4320 4129 4231 4262 2 1 XOR2HS $T=758880 709520 0 0 $X=758880 $Y=709140
X4321 4134 3858 4268 2 1 XOR2HS $T=759500 840560 0 0 $X=759500 $Y=840180
X4322 712 713 4267 2 1 XOR2HS $T=767560 709520 0 180 $X=761980 $Y=704100
X4323 4271 4299 4276 2 1 XOR2HS $T=771280 780080 1 180 $X=765700 $Y=779700
X4324 4140 4282 4020 2 1 XOR2HS $T=771900 830480 1 180 $X=766320 $Y=830100
X4325 4283 4289 4301 2 1 XOR2HS $T=766320 840560 0 0 $X=766320 $Y=840180
X4326 4295 4305 4320 2 1 XOR2HS $T=770040 850640 1 0 $X=770040 $Y=845220
X4327 4171 4360 4337 2 1 XOR2HS $T=781200 850640 0 180 $X=775620 $Y=845220
X4328 4318 4340 4344 2 1 XOR2HS $T=781820 840560 0 180 $X=776240 $Y=835140
X4329 4263 4379 4297 2 1 XOR2HS $T=786780 850640 0 180 $X=781200 $Y=845220
X4330 4298 4390 4421 2 1 XOR2HS $T=786780 840560 0 0 $X=786780 $Y=840180
X4331 4619 4629 4690 2 1 XOR2HS $T=845680 800240 0 0 $X=845680 $Y=799860
X4332 4490 4767 4777 2 1 XOR2HS $T=866140 780080 1 0 $X=866140 $Y=774660
X4333 4560 4753 4625 2 1 XOR2HS $T=868000 770000 0 0 $X=868000 $Y=769620
X4334 4554 4787 4806 2 1 XOR2HS $T=871100 770000 1 0 $X=871100 $Y=764580
X4335 4522 4809 4832 2 1 XOR2HS $T=875440 759920 1 0 $X=875440 $Y=754500
X4336 865 864 881 2 1 XOR2HS $T=878540 699440 0 0 $X=878540 $Y=699060
X4337 4584 4837 4807 2 1 XOR2HS $T=882260 739760 0 0 $X=882260 $Y=739380
X4338 4609 4869 4876 2 1 XOR2HS $T=885980 719600 1 0 $X=885980 $Y=714180
X4339 823 4820 896 2 1 XOR2HS $T=889700 709520 1 0 $X=889700 $Y=704100
X4340 4650 4880 4890 2 1 XOR2HS $T=891560 719600 0 0 $X=891560 $Y=719220
X4341 815 4875 4904 2 1 XOR2HS $T=895900 709520 0 0 $X=895900 $Y=709140
X4342 4574 4891 4905 2 1 XOR2HS $T=895900 729680 0 0 $X=895900 $Y=729300
X4343 4602 4883 4906 2 1 XOR2HS $T=895900 739760 1 0 $X=895900 $Y=734340
X4344 2828 2802 2578 2623 2 1 2876 OA112S $T=492900 850640 1 0 $X=492900 $Y=845220
X4345 2977 2841 2578 2625 2 1 3027 OA112S $T=515840 810320 1 0 $X=515840 $Y=804900
X4346 1425 1176 1382 1 2 1245 OA12 $T=255440 850640 1 180 $X=251720 $Y=850260
X4347 1959 159 2002 1 2 1995 OA12 $T=367040 820400 0 0 $X=367040 $Y=820020
X4348 1984 1978 1975 1 2 2031 OA12 $T=370140 780080 1 0 $X=370140 $Y=774660
X4349 2113 177 2124 1 2 2096 OA12 $T=391840 749840 0 180 $X=388120 $Y=744420
X4350 270 274 2423 1 2 2526 OA12 $T=442060 860720 0 0 $X=442060 $Y=860340
X4351 2477 277 2498 1 2 2381 OA12 $T=442680 770000 0 0 $X=442680 $Y=769620
X4352 2543 2529 2361 1 2 2564 OA12 $T=451360 820400 1 0 $X=451360 $Y=814980
X4353 250 2663 2930 1 2 2955 OA12 $T=504060 860720 0 0 $X=504060 $Y=860340
X4354 1390 1439 2 1 1466 OR2 $T=262260 719600 0 0 $X=262260 $Y=719220
X4355 7 1223 2 1 1620 OR2 $T=288300 790160 1 0 $X=288300 $Y=784740
X4356 132 1740 2 1 1402 OR2 $T=338520 850640 1 180 $X=336040 $Y=850260
X4357 1843 1740 2 1 1183 OR2 $T=341000 870800 0 180 $X=338520 $Y=865380
X4358 1927 1922 2 1 1940 OR2 $T=354020 729680 0 0 $X=354020 $Y=729300
X4359 1931 1953 2 1 1944 OR2 $T=358980 759920 0 180 $X=356500 $Y=754500
X4360 2218 2131 2 1 2240 OR2 $T=406100 790160 1 0 $X=406100 $Y=784740
X4361 2448 2099 2 1 2482 OR2 $T=437720 719600 1 0 $X=437720 $Y=714180
X4362 2594 2615 2 1 2645 OR2 $T=461900 729680 1 0 $X=461900 $Y=724260
X4363 2537 2714 2 1 2842 OR2 $T=492900 739760 0 0 $X=492900 $Y=739380
X4364 2481 2424 2 1 2918 OR2 $T=503440 860720 1 0 $X=503440 $Y=855300
X4365 2693 2588 2 1 3026 OR2 $T=517080 840560 0 0 $X=517080 $Y=840180
X4366 2385 2513 2 1 3122 OR2 $T=553660 850640 0 180 $X=551180 $Y=845220
X4367 3623 3593 2 1 3662 OR2 $T=652240 830480 1 180 $X=649760 $Y=830100
X4368 679 4158 2 1 4120 OR2 $T=740900 729680 1 0 $X=740900 $Y=724260
X4369 4271 4266 2 1 4288 OR2 $T=765700 780080 1 0 $X=765700 $Y=774660
X4370 2773 2723 2783 2 1 2865 OR3S $T=492280 850640 0 0 $X=492280 $Y=850260
X4371 1429 1553 2 1 1602 OR2S $T=293880 749840 1 180 $X=291400 $Y=749460
X4372 2006 2010 2 1 1997 OR2S $T=376340 790160 1 0 $X=376340 $Y=784740
X4373 291 2560 2 1 2545 OR2S $T=455080 749840 1 180 $X=452600 $Y=749460
X4374 291 2560 2 1 2542 OR2S $T=455700 729680 1 180 $X=453220 $Y=729300
X4375 278 2464 2 1 2804 OR2S $T=486080 860720 1 0 $X=486080 $Y=855300
X4376 3551 3546 2 1 3634 OR2S $T=648520 770000 0 0 $X=648520 $Y=769620
X4377 4408 4386 2 1 4415 OR2S $T=816540 759920 0 0 $X=816540 $Y=759540
X4378 1482 1311 1369 2 1 1539 OA12S $T=268460 770000 0 0 $X=268460 $Y=769620
X4379 114 1837 1934 2 1 1894 OA12S $T=353400 880880 1 0 $X=353400 $Y=875460
X4380 3447 3446 3430 2 1 3456 OA12S $T=603260 850640 0 0 $X=603260 $Y=850260
X4381 3447 3466 3456 2 1 3450 OA12S $T=612560 840560 1 180 $X=608840 $Y=840180
X4382 4273 4499 4495 2 1 4486 OA12S $T=808480 800240 0 180 $X=804760 $Y=794820
X4383 4273 4510 4524 2 1 4495 OA12S $T=814680 800240 1 180 $X=810960 $Y=799860
X4384 297 274 421 3026 1 2 3059 OA13S $T=523280 880880 1 0 $X=523280 $Y=875460
X4385 3442 3446 3411 3497 1 2 3528 OA13S $T=620000 860720 0 0 $X=620000 $Y=860340
X4386 4469 4510 4519 4502 1 2 4599 OA13S $T=831420 810320 0 180 $X=827080 $Y=804900
X4387 2311 219 2292 2256 1 2 2241 AO13S $T=419120 850640 1 180 $X=414780 $Y=850260
X4388 15 1448 1451 50 2 1124 1 AOI13HS $T=261640 870800 1 0 $X=261640 $Y=865380
X4389 1406 1515 1502 1154 2 1223 1 AOI13HS $T=272800 770000 0 180 $X=269080 $Y=764580
X4390 1278 1810 1764 1585 2 1239 1 AOI13HS $T=330460 770000 0 0 $X=330460 $Y=769620
X4391 1856 2029 1974 1989 2 1762 1 AOI13HS $T=378820 860720 1 0 $X=378820 $Y=855300
X4392 1885 2053 2084 2014 2 1393 1 AOI13HS $T=380060 830480 0 0 $X=380060 $Y=830100
X4393 212 2256 2014 167 2 219 1 AOI13HS $T=408580 850640 0 0 $X=408580 $Y=850260
X4394 2328 2320 205 223 2 241 1 AOI13HS $T=421600 860720 1 0 $X=421600 $Y=855300
X4395 3466 3489 3446 3411 2 3258 1 AOI13HS $T=616280 860720 1 0 $X=616280 $Y=855300
X4396 4499 4526 4510 4519 2 717 1 AOI13HS $T=814680 800240 0 180 $X=810960 $Y=794820
X4397 1131 1158 1171 2 1188 1 1124 AO112 $T=226300 840560 1 0 $X=226300 $Y=835140
X4398 1399 1207 1303 2 1440 1 1468 AO112 $T=258540 749840 0 0 $X=258540 $Y=749460
X4399 1961 1974 1997 2 1672 1 1762 AO112 $T=363940 850640 0 0 $X=363940 $Y=850260
X4400 2068 172 1 2080 1989 172 2 MOAI1 $T=377580 870800 0 0 $X=377580 $Y=870420
X4401 2116 172 1 2095 1974 172 2 MOAI1 $T=387500 850640 1 180 $X=383160 $Y=850260
X4402 2103 172 1 2125 1762 172 2 MOAI1 $T=386880 860720 0 0 $X=386880 $Y=860340
X4403 2475 2491 1 2509 2517 2491 2 MOAI1 $T=444540 709520 0 0 $X=444540 $Y=709140
X4404 446 195 1 195 2282 437 2 MOAI1 $T=537540 749840 0 180 $X=533200 $Y=744420
X4405 434 446 1 434 197 437 2 MOAI1 $T=538780 739760 1 180 $X=534440 $Y=739380
X4406 25 1516 1 1455 2 AN2S $T=272180 780080 0 180 $X=269700 $Y=774660
X4407 2070 2080 1 2133 2 AN2S $T=391220 870800 0 0 $X=391220 $Y=870420
X4408 2157 2095 1 2120 2 AN2S $T=394320 860720 0 180 $X=391840 $Y=855300
X4409 2133 2086 1 2157 2 AN2S $T=393700 870800 1 0 $X=393700 $Y=865380
X4410 2953 2812 1 2757 2 AN2S $T=500960 820400 1 180 $X=498480 $Y=820020
X4411 116 115 2 1 119 120 MUX2 $T=327360 699440 0 0 $X=327360 $Y=699060
X4412 125 115 2 1 1845 130 MUX2 $T=334800 699440 0 0 $X=334800 $Y=699060
X4413 1846 115 2 1 1828 125 MUX2 $T=339140 709520 0 180 $X=334800 $Y=704100
X4414 1872 115 2 1 1861 116 MUX2 $T=344720 709520 1 180 $X=340380 $Y=709140
X4415 1890 115 2 1 1877 1872 MUX2 $T=349060 709520 1 180 $X=344720 $Y=709140
X4416 119 139 2 1 1910 144 MUX2 $T=347820 699440 0 0 $X=347820 $Y=699060
X4417 1877 139 2 1 1921 119 MUX2 $T=349680 709520 0 0 $X=349680 $Y=709140
X4418 1863 115 2 1 1935 1846 MUX2 $T=351540 719600 1 0 $X=351540 $Y=714180
X4419 1909 143 2 1 1936 1910 MUX2 $T=351540 729680 1 0 $X=351540 $Y=724260
X4420 1861 139 2 1 153 152 MUX2 $T=355260 709520 1 0 $X=355260 $Y=704100
X4421 1935 139 2 1 1949 1845 MUX2 $T=361460 709520 1 180 $X=357120 $Y=709140
X4422 1828 139 2 1 1987 158 MUX2 $T=360840 709520 1 0 $X=360840 $Y=704100
X4423 1966 139 2 1 1990 1861 MUX2 $T=361460 719600 1 0 $X=361460 $Y=714180
X4424 1967 143 2 1 2065 1949 MUX2 $T=361460 739760 1 0 $X=361460 $Y=734340
X4425 1969 139 2 1 1998 1828 MUX2 $T=362080 719600 0 0 $X=362080 $Y=719220
X4426 1921 143 2 1 2024 163 MUX2 $T=365800 709520 1 0 $X=365800 $Y=704100
X4427 1998 143 2 1 2015 166 MUX2 $T=365800 709520 0 0 $X=365800 $Y=709140
X4428 2008 143 2 1 2020 1987 MUX2 $T=367660 729680 0 0 $X=367660 $Y=729300
X4429 2016 143 2 1 2042 153 MUX2 $T=370760 719600 0 0 $X=370760 $Y=719220
X4430 1970 143 2 1 2041 146 MUX2 $T=370760 729680 1 0 $X=370760 $Y=724260
X4431 1990 143 2 1 2047 173 MUX2 $T=372000 719600 1 0 $X=372000 $Y=714180
X4432 2202 191 2 1 2220 190 MUX2 $T=399900 699440 0 0 $X=399900 $Y=699060
X4433 209 188 2 1 2252 217 MUX2 $T=405480 699440 0 0 $X=405480 $Y=699060
X4434 2167 188 2 1 2253 2220 MUX2 $T=405480 709520 1 0 $X=405480 $Y=704100
X4435 2249 193 2 1 2251 2275 MUX2 $T=409200 719600 0 0 $X=409200 $Y=719220
X4436 2220 188 2 1 2277 226 MUX2 $T=409820 709520 1 0 $X=409820 $Y=704100
X4437 2252 193 2 1 230 231 MUX2 $T=411680 699440 0 0 $X=411680 $Y=699060
X4438 2275 193 2 1 233 234 MUX2 $T=414160 709520 0 0 $X=414160 $Y=709140
X4439 2289 183 2 1 2312 233 MUX2 $T=415400 719600 0 0 $X=415400 $Y=719220
X4440 2277 193 2 1 238 239 MUX2 $T=417260 699440 0 0 $X=417260 $Y=699060
X4441 2253 193 2 1 2315 237 MUX2 $T=417260 709520 1 0 $X=417260 $Y=704100
X4442 2307 193 2 1 2290 2277 MUX2 $T=418500 709520 0 0 $X=418500 $Y=709140
X4443 2280 183 2 1 2334 238 MUX2 $T=419740 719600 0 0 $X=419740 $Y=719220
X4444 2267 183 2 1 2347 242 MUX2 $T=421600 709520 1 0 $X=421600 $Y=704100
X4445 2236 183 2 1 2348 230 MUX2 $T=421600 719600 1 0 $X=421600 $Y=714180
X4446 2274 183 2 1 2350 246 MUX2 $T=422840 709520 0 0 $X=422840 $Y=709140
X4447 2251 183 2 1 2374 253 MUX2 $T=424080 719600 0 0 $X=424080 $Y=719220
X4448 2290 183 2 1 2383 257 MUX2 $T=427180 709520 0 0 $X=427180 $Y=709140
X4449 2582 284 2 1 2639 313 MUX2 $T=461900 709520 1 0 $X=461900 $Y=704100
X4450 2603 284 2 1 2627 2582 MUX2 $T=461900 709520 0 0 $X=461900 $Y=709140
X4451 2627 291 2 1 2673 312 MUX2 $T=468100 709520 0 0 $X=468100 $Y=709140
X4452 2610 296 2 1 2641 2694 MUX2 $T=469340 719600 0 0 $X=469340 $Y=719220
X4453 2640 296 2 1 2692 2685 MUX2 $T=470580 719600 1 0 $X=470580 $Y=714180
X4454 2685 296 2 1 325 326 MUX2 $T=471200 699440 0 0 $X=471200 $Y=699060
X4455 2673 296 2 1 331 332 MUX2 $T=473060 709520 0 0 $X=473060 $Y=709140
X4456 2694 296 2 1 335 334 MUX2 $T=473680 709520 1 0 $X=473680 $Y=704100
X4457 2710 323 2 1 2744 331 MUX2 $T=473680 729680 0 0 $X=473680 $Y=729300
X4458 2679 296 2 1 2733 337 MUX2 $T=474920 719600 1 0 $X=474920 $Y=714180
X4459 2699 323 2 1 2755 325 MUX2 $T=476780 739760 1 0 $X=476780 $Y=734340
X4460 2642 323 2 1 2776 346 MUX2 $T=477400 729680 1 0 $X=477400 $Y=724260
X4461 2692 323 2 1 2763 349 MUX2 $T=478020 709520 0 0 $X=478020 $Y=709140
X4462 2691 323 2 1 2766 344 MUX2 $T=478020 729680 0 0 $X=478020 $Y=729300
X4463 2753 323 2 1 2788 335 MUX2 $T=481120 719600 0 0 $X=481120 $Y=719220
X4464 2641 323 2 1 2799 354 MUX2 $T=482980 719600 1 0 $X=482980 $Y=714180
X4465 3849 624 2 1 3803 623 MUX2 $T=687580 699440 1 180 $X=683240 $Y=699060
X4466 3842 624 2 1 3843 625 MUX2 $T=693780 719600 1 180 $X=689440 $Y=719220
X4467 3902 624 2 1 3878 627 MUX2 $T=695640 719600 0 180 $X=691300 $Y=714180
X4468 3933 624 2 1 3874 630 MUX2 $T=696880 699440 1 180 $X=692540 $Y=699060
X4469 3917 624 2 1 3920 637 MUX2 $T=701840 729680 0 180 $X=697500 $Y=724260
X4470 1107 1190 1392 1 2 1469 AO12S $T=264740 800240 1 0 $X=264740 $Y=794820
X4471 167 1875 170 1 2 2048 AO12S $T=380680 850640 0 180 $X=376960 $Y=845220
X4472 3124 2354 3010 1 2 3257 AO12S $T=564820 820400 0 0 $X=564820 $Y=820020
X4473 4085 4087 4037 1 2 4017 AO12S $T=725400 840560 1 0 $X=725400 $Y=835140
X4474 1643 1779 1454 1278 2 1 1748 AN4S $T=324880 770000 0 180 $X=319920 $Y=764580
X4475 1726 1177 1702 1696 2 1 1840 AN4S $T=332320 759920 0 0 $X=332320 $Y=759540
X4476 1614 2 35 1176 1 AN2B1S $T=296980 840560 1 0 $X=296980 $Y=835140
X4477 1482 1280 2 1329 1454 1 OR3B2S $T=267220 770000 1 180 $X=263500 $Y=769620
X4478 3401 3411 2 3399 3416 1 OR3B2S $T=593960 830480 0 0 $X=593960 $Y=830100
X4479 890 842 4848 1 2 838 856 4789 1093 ICV_8 $T=884740 840560 1 180 $X=874200 $Y=840180
X4480 4900 955 5098 1 2 4996 945 5050 1093 ICV_8 $T=936820 770000 0 180 $X=926280 $Y=764580
X4481 4896 5091 5138 1 2 5002 955 5099 1093 ICV_8 $T=947360 830480 0 180 $X=936820 $Y=825060
X4482 925 5137 5158 1 2 4992 5137 5150 1093 ICV_8 $T=960380 729680 1 180 $X=949840 $Y=729300
X4483 4803 5091 5178 1 2 4903 5091 5169 1093 ICV_8 $T=966580 780080 1 180 $X=956040 $Y=779700
X4484 4985 5091 5204 1 2 4870 5137 5161 1093 ICV_8 $T=969060 800240 1 180 $X=958520 $Y=799860
X4485 4900 5091 5190 1 2 4870 5113 5173 1093 ICV_8 $T=975260 790160 1 180 $X=964720 $Y=789780
X4486 5074 5091 5222 1 2 5074 5137 5225 1093 ICV_8 $T=990140 770000 1 180 $X=979600 $Y=769620
X4487 5002 1016 5277 1 2 5005 5091 5234 1093 ICV_8 $T=993860 810320 0 180 $X=983320 $Y=804900
X4488 5074 1016 5280 1 2 4996 1016 5251 1093 ICV_8 $T=995100 749840 1 180 $X=984560 $Y=749460
X4489 4870 1016 5262 1 2 4985 5113 5253 1093 ICV_8 $T=996340 790160 1 180 $X=985800 $Y=789780
X4490 5074 5326 5380 1 2 4903 5326 5372 1093 ICV_8 $T=1037880 759920 1 180 $X=1027340 $Y=759540
X4491 4803 1037 5413 1 2 4903 5331 5388 1093 ICV_8 $T=1042220 780080 0 180 $X=1031680 $Y=774660
X4492 809 633 1 2 4646 QDLHN $T=832660 860720 0 0 $X=832660 $Y=860340
X4493 809 640 1 2 4694 QDLHN $T=841960 850640 1 0 $X=841960 $Y=845220
X4494 809 646 1 2 4693 QDLHN $T=843200 840560 1 0 $X=843200 $Y=835140
X4495 809 647 1 2 897 QDLHN $T=887840 830480 0 0 $X=887840 $Y=830100
X4496 2261 2319 2 2239 2163 1 2296 FA1 $T=410440 800240 1 0 $X=410440 $Y=794820
X4497 2537 2428 2 2118 2503 1 2429 FA1 $T=450740 749840 0 180 $X=435240 $Y=744420
X4498 2541 2426 2 2117 2465 1 2433 FA1 $T=451360 729680 0 180 $X=435860 $Y=724260
X4499 3049 2940 2 2585 2941 1 2958 FA1 $T=524520 739760 1 180 $X=509020 $Y=739380
X4500 3103 3149 2 3160 3119 1 3184 FA1 $T=538160 770000 0 0 $X=538160 $Y=769620
X4501 3098 3157 2 3160 3198 1 3195 FA1 $T=538160 780080 1 0 $X=538160 $Y=774660
X4502 3144 3200 2 3148 3136 1 3198 FA1 $T=546840 759920 1 0 $X=546840 $Y=754500
X4503 3170 3225 2 3193 3184 1 3250 FA1 $T=552420 780080 0 0 $X=552420 $Y=779700
X4504 3191 3244 2 491 3211 1 3284 FA1 $T=555520 709520 1 0 $X=555520 $Y=704100
X4505 3197 3248 2 3193 3195 1 3274 FA1 $T=556140 790160 1 0 $X=556140 $Y=784740
X4506 3192 3268 2 3177 3231 1 3304 FA1 $T=560480 729680 1 0 $X=560480 $Y=724260
X4507 3217 3290 2 491 3239 1 3321 FA1 $T=563580 709520 0 0 $X=563580 $Y=709140
X4508 3224 3264 2 3165 3304 1 3239 FA1 $T=580320 719600 0 180 $X=564820 $Y=714180
X4509 3246 3298 2 3273 3250 1 3328 FA1 $T=565440 810320 1 0 $X=565440 $Y=804900
X4510 3254 3296 2 3273 3274 1 3359 FA1 $T=568540 790160 0 0 $X=568540 $Y=789780
X4511 518 3388 2 497 3316 1 3407 FA1 $T=580940 719600 1 0 $X=580940 $Y=714180
X4512 3338 3389 2 3340 3328 1 3409 FA1 $T=580940 810320 1 0 $X=580940 $Y=804900
X4513 539 3364 2 3343 534 1 520 FA1 $T=597680 699440 1 180 $X=582180 $Y=699060
X4514 3352 3397 2 3340 3359 1 3415 FA1 $T=582180 800240 1 0 $X=582180 $Y=794820
X4515 538 3371 2 3343 3407 1 3360 FA1 $T=600160 709520 1 180 $X=584660 $Y=709140
X4516 532 3443 2 505 3360 1 3469 FA1 $T=593960 709520 1 0 $X=593960 $Y=704100
X4517 3410 3452 2 3432 3409 1 3476 FA1 $T=595820 810320 0 0 $X=595820 $Y=809940
X4518 3423 3461 2 3432 3415 1 3482 FA1 $T=598300 800240 0 0 $X=598300 $Y=799860
X4519 542 3473 2 507 3469 1 3502 FA1 $T=602020 709520 0 0 $X=602020 $Y=709140
X4520 3467 3510 2 554 3502 1 3531 FA1 $T=609460 719600 1 0 $X=609460 $Y=714180
X4521 549 3519 2 560 3531 1 3543 FA1 $T=611940 709520 1 0 $X=611940 $Y=704100
X4522 3484 3517 2 3297 3482 1 3564 FA1 $T=615040 800240 0 0 $X=615040 $Y=799860
X4523 567 3585 2 576 3554 1 3627 FA1 $T=626200 719600 1 0 $X=626200 $Y=714180
X4524 568 3594 2 576 572 1 3624 FA1 $T=628060 699440 0 0 $X=628060 $Y=699060
X4525 3560 3556 2 3348 3564 1 3643 FA1 $T=630540 800240 1 0 $X=630540 $Y=794820
X4526 578 3636 2 587 3624 1 3665 FA1 $T=634260 709520 1 0 $X=634260 $Y=704100
X4527 586 3675 2 584 3665 1 598 FA1 $T=643560 699440 0 0 $X=643560 $Y=699060
X4528 3629 3677 2 3506 3548 1 3710 FA1 $T=643560 810320 1 0 $X=643560 $Y=804900
X4529 3739 3697 2 3545 3765 1 3695 FA1 $T=672700 780080 1 180 $X=657200 $Y=779700
X4530 3702 3667 2 3751 3664 1 3765 FA1 $T=658440 800240 1 0 $X=658440 $Y=794820
X4531 3714 3759 2 3505 3710 1 3801 FA1 $T=660920 810320 1 0 $X=660920 $Y=804900
X4532 3736 3770 2 3545 3801 1 3819 FA1 $T=665260 790160 0 0 $X=665260 $Y=789780
X4533 3758 3773 2 3674 3819 1 3750 FA1 $T=682620 770000 1 180 $X=667120 $Y=769620
X4534 4047 4095 2 4081 4052 1 4148 FA1 $T=719820 749840 1 0 $X=719820 $Y=744420
X4535 4050 4097 2 4079 4111 1 4116 FA1 $T=720440 709520 1 0 $X=720440 $Y=704100
X4536 4070 4083 2 4062 4094 1 4052 FA1 $T=735940 729680 1 180 $X=720440 $Y=729300
X4537 4077 4128 2 4062 4116 1 4162 FA1 $T=725400 739760 1 0 $X=725400 $Y=734340
X4538 4084 4117 2 4081 4162 1 4175 FA1 $T=725400 749840 0 0 $X=725400 $Y=749460
X4539 4110 4177 2 4171 4175 1 4206 FA1 $T=734700 759920 1 0 $X=734700 $Y=754500
X4540 4176 4157 2 679 4191 1 4103 FA1 $T=750820 719600 0 180 $X=735320 $Y=714180
X4541 4131 4183 2 697 695 1 4191 FA1 $T=735940 709520 1 0 $X=735940 $Y=704100
X4542 4138 693 2 4129 708 1 4217 FA1 $T=743380 699440 0 0 $X=743380 $Y=699060
X4543 4278 4336 2 4318 4311 1 4241 FA1 $T=769420 770000 1 0 $X=769420 $Y=764580
X4544 4705 4508 2 4602 4660 1 4639 FA1 $T=852500 739760 0 180 $X=837000 $Y=734340
X4545 4717 4359 2 4609 4678 1 4649 FA1 $T=856220 709520 1 180 $X=840720 $Y=709140
X4546 4733 4461 2 4584 4639 1 4654 FA1 $T=856840 739760 1 180 $X=841340 $Y=739380
X4547 4740 4384 2 4650 4649 1 4674 FA1 $T=861800 719600 1 180 $X=846300 $Y=719220
X4548 4689 4657 2 4522 4731 1 4673 FA1 $T=861800 749840 1 180 $X=846300 $Y=749460
X4549 4676 4661 2 4554 4673 1 4683 FA1 $T=846300 759920 0 0 $X=846300 $Y=759540
X4550 4761 4688 2 4650 4738 1 4697 FA1 $T=866140 729680 0 180 $X=850640 $Y=724260
X4551 4723 4762 2 4602 4739 1 4757 FA1 $T=858700 739760 1 0 $X=858700 $Y=734340
X4552 4698 4667 1 2 INV1CK $T=850640 790160 0 0 $X=850640 $Y=789780
X4553 3679 3609 3791 2 1 3780 XOR3S $T=685100 709520 1 180 $X=673940 $Y=709140
X4554 3830 3609 3807 2 1 3768 XOR3S $T=688200 719600 0 180 $X=677040 $Y=714180
X4555 4196 4188 4151 2 1 4146 XOR3S $T=748960 770000 0 180 $X=737800 $Y=764580
X4556 4240 4188 4197 2 1 4161 XOR3S $T=758260 770000 1 180 $X=747100 $Y=769620
X4557 4458 4490 4618 2 1 4652 XOR3S $T=830180 770000 0 0 $X=830180 $Y=769620
X4558 4645 4490 4677 2 1 4670 XOR3S $T=839480 780080 1 0 $X=839480 $Y=774660
X4559 2126 2163 2140 2143 1 2 ND3P $T=387500 800240 1 0 $X=387500 $Y=794820
X4560 2148 2168 2121 2162 1 2 ND3P $T=389980 770000 1 0 $X=389980 $Y=764580
X4561 2110 2181 2149 2182 1 2 ND3P $T=396800 770000 0 0 $X=396800 $Y=769620
X4562 2388 2408 2372 2400 1 2 ND3P $T=427800 800240 0 0 $X=427800 $Y=799860
X4563 2411 2460 2441 2462 1 2 ND3P $T=438340 790160 0 0 $X=438340 $Y=789780
X4564 2483 2465 2521 2456 1 2 ND3P $T=445160 739760 0 180 $X=440200 $Y=734340
X4565 2452 2503 2471 2484 1 2 ND3P $T=440820 749840 0 0 $X=440820 $Y=749460
X4566 2476 2491 2548 2504 1 2 ND3P $T=450740 719600 0 180 $X=445780 $Y=714180
X4567 2551 2581 2558 2547 1 2 ND3P $T=452600 780080 1 0 $X=452600 $Y=774660
X4568 2511 2571 2555 2536 1 2 ND3P $T=452600 790160 0 0 $X=452600 $Y=789780
X4569 2857 2881 2853 2877 1 2 ND3P $T=494760 719600 0 0 $X=494760 $Y=719220
X4570 2945 2970 2933 2937 1 2 ND3P $T=507160 759920 0 0 $X=507160 $Y=759540
X4571 2960 3024 2972 2991 1 2 ND3P $T=514600 719600 0 0 $X=514600 $Y=719220
X4572 4528 4368 4469 4547 1 2 ND3P $T=815920 810320 1 0 $X=815920 $Y=804900
X4573 2835 2711 2959 1 2 OR2P $T=509020 759920 1 0 $X=509020 $Y=754500
X4574 3429 3497 3337 1 2 OR2P $T=621240 820400 1 0 $X=621240 $Y=814980
X4575 4500 4502 752 1 2 OR2P $T=814680 780080 0 180 $X=810960 $Y=774660
X4576 4449 4475 1 719 2 OR2B1S $T=801660 850640 1 0 $X=801660 $Y=845220
X4577 3525 3395 535 3466 1 2 3401 DFFRBN $T=624960 850640 0 180 $X=611940 $Y=845220
X4578 4467 4448 4142 4499 1 2 4501 DFFRBN $T=801040 790160 0 0 $X=801040 $Y=789780
X4579 1821 1846 1862 1 2 1859 1862 121 1093 ICV_9 $T=339140 699440 0 0 $X=339140 $Y=699060
X4580 1957 79 1963 1 2 1952 1973 1978 1093 ICV_9 $T=358980 770000 1 0 $X=358980 $Y=764580
X4581 2164 2167 2171 1 2 2174 2164 192 1093 ICV_9 $T=393700 709520 0 0 $X=393700 $Y=709140
X4582 2109 2161 2136 1 2 2181 2147 2160 1093 ICV_9 $T=394940 759920 1 0 $X=394940 $Y=754500
X4583 2123 2171 191 1 2 2198 2195 2207 1093 ICV_9 $T=397420 709520 0 0 $X=397420 $Y=709140
X4584 2169 2150 2193 1 2 2196 2191 2240 1093 ICV_9 $T=397420 790160 0 0 $X=397420 $Y=789780
X4585 2202 2198 206 1 2 2174 2207 191 1093 ICV_9 $T=401140 709520 0 0 $X=401140 $Y=709140
X4586 2332 2316 2113 1 2 2346 2308 2100 1093 ICV_9 $T=422840 749840 1 0 $X=422840 $Y=744420
X4587 2590 2574 277 1 2 2599 2568 2477 1093 ICV_9 $T=458180 770000 0 0 $X=458180 $Y=769620
X4588 2626 2611 2650 1 2 2602 2650 291 1093 ICV_9 $T=465000 719600 0 0 $X=465000 $Y=719220
X4589 2835 2939 2711 1 2 2959 2950 2970 1093 ICV_9 $T=507160 749840 0 0 $X=507160 $Y=749460
X4590 2952 2957 2966 1 2 2969 2967 2975 1093 ICV_9 $T=509020 729680 1 0 $X=509020 $Y=724260
X4591 2943 2984 2966 1 2 2984 2992 3007 1093 ICV_9 $T=512120 739760 1 0 $X=512120 $Y=734340
X4592 4120 4127 4135 1 2 4135 4139 4143 1093 ICV_9 $T=734700 719600 0 0 $X=734700 $Y=719220
X4593 648 1 4002 2 BUF6CK $T=726640 729680 1 0 $X=726640 $Y=724260
X4594 2136 1960 2109 2 1 2151 XOR3 $T=393700 759920 0 0 $X=393700 $Y=759540
X4595 2159 2000 2101 2 1 2239 XOR3 $T=396800 770000 1 0 $X=396800 $Y=764580
X4596 2160 2037 2181 2 1 2131 XOR3 $T=398660 759920 1 0 $X=398660 $Y=754500
X4597 2170 2151 2145 2 1 2188 XOR3 $T=410440 800240 1 180 $X=399280 $Y=799860
X4598 2233 2064 2313 2 1 2322 XOR3 $T=410440 759920 0 0 $X=410440 $Y=759540
X4599 2378 2322 2296 2 1 2197 XOR3 $T=425940 810320 1 180 $X=414780 $Y=809940
X4600 2382 2317 2314 2 1 2170 XOR3 $T=429040 790160 0 180 $X=417880 $Y=784740
X4601 2246 2056 2336 2 1 2389 XOR3 $T=419120 770000 1 0 $X=419120 $Y=764580
X4602 2335 2105 2303 2 1 2486 XOR3 $T=432140 770000 1 0 $X=432140 $Y=764580
X4603 2355 2139 2497 2 1 2506 XOR3 $T=435240 759920 0 0 $X=435240 $Y=759540
X4604 2436 2132 2514 2 1 2584 XOR3 $T=447020 719600 0 0 $X=447020 $Y=719220
X4605 2427 2155 2539 2 1 2585 XOR3 $T=447020 739760 0 0 $X=447020 $Y=739380
X4606 2635 2621 2571 2 1 2538 XOR3 $T=465620 780080 1 180 $X=454460 $Y=779700
X4607 2705 2719 2709 2 1 2707 XOR3 $T=477400 759920 0 0 $X=477400 $Y=759540
X4608 2844 2506 2717 2 1 2778 XOR3 $T=494760 770000 0 180 $X=483600 $Y=764580
X4609 2887 2889 2830 2 1 2835 XOR3 $T=503440 759920 0 180 $X=492280 $Y=754500
X4610 2796 2792 2861 2 1 2844 XOR3 $T=494140 759920 0 0 $X=494140 $Y=759540
X4611 2824 2831 2833 2 1 2940 XOR3 $T=496620 739760 1 0 $X=496620 $Y=734340
X4612 2880 388 2881 2 1 2983 XOR3 $T=504680 719600 1 0 $X=504680 $Y=714180
X4613 2886 2938 2895 2 1 3023 XOR3 $T=505920 709520 0 0 $X=505920 $Y=709140
X4614 3023 2517 3079 2 1 3094 XOR3 $T=527620 719600 1 0 $X=527620 $Y=714180
X4615 3836 3850 3834 2 1 3795 XOR3 $T=694400 820400 0 180 $X=683240 $Y=814980
X4616 3886 3893 3947 2 1 3834 XOR3 $T=691920 820400 0 0 $X=691920 $Y=820020
X4617 4008 4009 3966 2 1 3947 XOR3 $T=714860 820400 1 180 $X=703700 $Y=820020
X4618 3953 3978 3941 2 1 4035 XOR3 $T=706180 739760 0 0 $X=706180 $Y=739380
X4619 4003 4015 4035 2 1 4063 XOR3 $T=712380 749840 0 0 $X=712380 $Y=749460
X4620 4012 4018 4063 2 1 4073 XOR3 $T=713000 770000 1 0 $X=713000 $Y=764580
X4621 4048 4043 4073 2 1 4071 XOR3 $T=721060 780080 1 0 $X=721060 $Y=774660
X4622 4071 4027 4089 2 1 4115 XOR3 $T=722920 780080 0 0 $X=722920 $Y=779700
X4623 3411 3439 3446 1 2 AN2B1 $T=601400 840560 1 0 $X=601400 $Y=835140
X4624 1999 1993 1 1930 2 NR2T $T=369520 749840 0 180 $X=364560 $Y=744420
X4625 2156 2176 1 2146 2 NR2T $T=395560 729680 1 0 $X=395560 $Y=724260
X4626 2565 150 1 292 2 NR2T $T=457560 719600 0 180 $X=452600 $Y=714180
X4627 2596 2605 1 2560 2 NR2T $T=463760 739760 1 180 $X=458800 $Y=739380
X4628 3272 3429 1 3427 2 NR2T $T=603880 820400 1 180 $X=598920 $Y=820020
X4629 505 3278 3272 500 456 3259 1 2 3253 AO222S $T=573500 749840 0 180 $X=567300 $Y=744420
X4630 3297 3278 3272 3273 3116 3259 1 2 3251 AO222S $T=574120 749840 1 180 $X=567920 $Y=749460
X4631 3278 507 497 3272 3259 3177 1 2 3269 AO222S $T=576600 759920 0 180 $X=570400 $Y=754500
X4632 3278 3348 3340 3272 3259 3148 1 2 3282 AO222S $T=584040 749840 1 180 $X=577840 $Y=749460
X4633 2524 2477 1 2501 2369 2477 2 MOAI1H $T=448880 780080 0 180 $X=441440 $Y=774660
X4634 434 433 1 426 194 2205 2 MOAI1H $T=533820 759920 0 180 $X=526380 $Y=754500
X4635 2136 1960 2 2109 2107 1960 1 AOI22H $T=391840 759920 1 180 $X=384400 $Y=759540
X4636 2160 2037 2 2181 2135 2037 1 AOI22H $T=393080 749840 0 0 $X=393080 $Y=749460
X4637 2246 2056 2 2258 2278 2056 1 AOI22H $T=407960 770000 1 0 $X=407960 $Y=764580
X4638 2233 2064 2 2168 2245 2064 1 AOI22H $T=417260 759920 0 180 $X=409820 $Y=754500
X4639 2355 2139 2 2365 2391 2139 1 AOI22H $T=425320 759920 1 0 $X=425320 $Y=754500
X4640 2335 2105 2 2303 2356 2105 1 AOI22H $T=435240 759920 1 180 $X=427800 $Y=759540
X4641 2317 2382 2 2394 2451 2317 1 AOI22H $T=444540 780080 1 180 $X=437100 $Y=779700
X4642 288 2565 2 2603 2613 2573 1 AOI22H $T=457560 719600 1 0 $X=457560 $Y=714180
X4643 2621 2635 2 2571 2634 2621 1 AOI22H $T=470580 780080 0 180 $X=463140 $Y=774660
X4644 2719 2705 2 2709 2689 2719 1 AOI22H $T=473680 770000 1 0 $X=473680 $Y=764580
X4645 2792 2796 2 2695 2800 2792 1 AOI22H $T=492280 759920 0 180 $X=484840 $Y=754500
X4646 2831 2824 2 2833 2846 2831 1 AOI22H $T=491660 729680 0 0 $X=491660 $Y=729300
X4647 2889 2887 2 2830 2920 2889 1 AOI22H $T=499720 749840 0 0 $X=499720 $Y=749460
X4648 388 2880 2 2881 2908 388 1 AOI22H $T=501580 719600 0 0 $X=501580 $Y=719220
X4649 2938 2886 2 2895 2916 2938 1 AOI22H $T=506540 709520 1 0 $X=506540 $Y=704100
X4650 3029 2905 2 2944 2981 3029 1 AOI22H $T=527620 749840 0 180 $X=520180 $Y=744420
X4651 2584 2983 2 3024 3045 2584 1 AOI22H $T=533200 729680 0 180 $X=525760 $Y=724260
X4652 1883 1 1890 1902 2 ND2P $T=350300 719600 1 180 $X=346580 $Y=719220
X4653 1940 1 1958 1970 2 ND2P $T=356500 729680 0 0 $X=356500 $Y=729300
X4654 1944 1 1972 1960 2 ND2P $T=362700 759920 0 180 $X=358980 $Y=754500
X4655 1981 1 1973 2000 2 ND2P $T=362700 759920 0 0 $X=362700 $Y=759540
X4656 1985 1 1935 1958 2 ND2P $T=363940 729680 0 0 $X=363940 $Y=729300
X4657 2038 1 2021 2037 2 ND2P $T=375720 759920 0 180 $X=372000 $Y=754500
X4658 2046 1 2059 2050 2 ND2P $T=379440 780080 0 180 $X=375720 $Y=774660
X4659 1978 1 2081 2059 2 ND2P $T=383160 780080 0 180 $X=379440 $Y=774660
X4660 2100 1 2108 2106 2 ND2P $T=389360 749840 1 180 $X=385640 $Y=749460
X4661 2131 1 2122 2137 2 ND2P $T=391220 790160 0 180 $X=387500 $Y=784740
X4662 2142 1 2130 2127 2 ND2P $T=392460 739760 1 180 $X=388740 $Y=739380
X4663 2153 1 2134 2128 2 ND2P $T=393080 719600 0 180 $X=389360 $Y=714180
X4664 2147 1 2135 2109 2 ND2P $T=393080 749840 1 180 $X=389360 $Y=749460
X4665 2150 1 2137 2145 2 ND2P $T=393080 780080 1 180 $X=389360 $Y=779700
X4666 186 1 180 2146 2 ND2P $T=391220 719600 0 0 $X=391220 $Y=719220
X4667 2161 1 2107 2092 2 ND2P $T=394940 759920 0 180 $X=391220 $Y=754500
X4668 2151 1 2145 2140 2 ND2P $T=391220 790160 1 0 $X=391220 $Y=784740
X4669 2127 1 2114 2182 2 ND2P $T=396800 770000 1 180 $X=393080 $Y=769620
X4670 2153 1 2167 2176 2 ND2P $T=394320 719600 1 0 $X=394320 $Y=714180
X4671 2100 1 2177 2130 2 ND2P $T=394320 739760 0 0 $X=394320 $Y=739380
X4672 2183 1 2172 2169 2 ND2P $T=398040 780080 0 180 $X=394320 $Y=774660
X4673 2186 1 2166 2122 2 ND2P $T=398660 790160 0 180 $X=394940 $Y=784740
X4674 2154 1 2201 2172 2 ND2P $T=398040 780080 1 0 $X=398040 $Y=774660
X4675 2199 1 2210 2160 2 ND2P $T=399900 739760 0 0 $X=399900 $Y=739380
X4676 2208 1 2106 2136 2 ND2P $T=400520 749840 0 0 $X=400520 $Y=749460
X4677 2100 1 2213 2210 2 ND2P $T=403620 739760 0 0 $X=403620 $Y=739380
X4678 2221 1 2228 2159 2 ND2P $T=404240 749840 0 0 $X=404240 $Y=749460
X4679 2232 1 2245 2258 2 ND2P $T=406720 759920 0 0 $X=406720 $Y=759540
X4680 2100 1 2264 2228 2 ND2P $T=409820 749840 0 0 $X=409820 $Y=749460
X4681 2279 1 2297 2233 2 ND2P $T=419120 739760 1 180 $X=415400 $Y=739380
X4682 2304 1 2278 2303 2 ND2P $T=419120 770000 0 180 $X=415400 $Y=764580
X4683 2246 1 2258 2304 2 ND2P $T=419120 770000 0 0 $X=419120 $Y=769620
X4684 2344 1 2356 2365 2 ND2P $T=424080 759920 0 0 $X=424080 $Y=759540
X4685 2366 1 2377 2387 2 ND2P $T=426560 770000 0 0 $X=426560 $Y=769620
X4686 2397 1 2406 2394 2 ND2P $T=430900 790160 1 0 $X=430900 $Y=784740
X4687 2425 1 2370 2441 2 ND2P $T=434620 790160 0 0 $X=434620 $Y=789780
X4688 2443 1 2432 2444 2 ND2P $T=438960 699440 1 180 $X=435240 $Y=699060
X4689 2420 1 2438 2452 2 ND2P $T=439580 739760 1 180 $X=435860 $Y=739380
X4690 2063 1 2438 2471 2 ND2P $T=439580 749840 1 180 $X=435860 $Y=749460
X4691 2430 1 2451 2370 2 ND2P $T=436480 790160 1 0 $X=436480 $Y=784740
X4692 2450 1 2387 2446 2 ND2P $T=437720 770000 0 0 $X=437720 $Y=769620
X4693 2474 1 2468 2485 2 ND2P $T=443300 709520 1 180 $X=439580 $Y=709140
X4694 2482 1 2491 2468 2 ND2P $T=442060 719600 1 0 $X=442060 $Y=714180
X4695 2510 1 2523 2300 2 ND2P $T=446400 759920 0 0 $X=446400 $Y=759540
X4696 268 1 2522 294 2 ND2P $T=448260 699440 0 0 $X=448260 $Y=699060
X4697 2155 1 2539 2521 2 ND2P $T=453220 739760 0 180 $X=449500 $Y=734340
X4698 277 1 2550 2523 2 ND2P $T=450120 759920 0 0 $X=450120 $Y=759540
X4699 2544 1 2557 2507 2 ND2P $T=450740 749840 1 0 $X=450740 $Y=744420
X4700 277 1 2562 2557 2 ND2P $T=454460 749840 1 0 $X=454460 $Y=744420
X4701 2568 1 2574 2382 2 ND2P $T=454460 770000 0 0 $X=454460 $Y=769620
X4702 2630 1 2652 2425 2 ND2P $T=465000 759920 0 0 $X=465000 $Y=759540
X4703 2660 1 2683 2635 2 ND2P $T=468100 749840 1 0 $X=468100 $Y=744420
X4704 277 1 2666 2652 2 ND2P $T=468720 759920 0 0 $X=468720 $Y=759540
X4705 2700 1 2689 2695 2 ND2P $T=473680 770000 0 180 $X=469960 $Y=764580
X4706 2646 1 2634 2709 2 ND2P $T=473680 780080 1 180 $X=469960 $Y=779700
X4707 2696 1 2688 2717 2 ND2P $T=471200 770000 0 0 $X=471200 $Y=769620
X4708 2705 1 2709 2700 2 ND2P $T=473680 759920 0 0 $X=473680 $Y=759540
X4709 2822 1 2800 2830 2 ND2P $T=492280 759920 1 180 $X=488560 $Y=759540
X4710 2735 1 2537 2832 2 ND2P $T=493520 749840 0 180 $X=489800 $Y=744420
X4711 2834 1 2846 2848 2 ND2P $T=492900 739760 1 0 $X=492900 $Y=734340
X4712 2868 1 2856 378 2 ND2P $T=499100 699440 1 180 $X=495380 $Y=699060
X4713 2854 1 2842 2894 2 ND2P $T=500960 749840 0 180 $X=497240 $Y=744420
X4714 2874 1 2848 2853 2 ND2P $T=497860 729680 1 0 $X=497860 $Y=724260
X4715 2892 1 2908 2895 2 ND2P $T=500960 719600 1 0 $X=500960 $Y=714180
X4716 2893 1 2848 2857 2 ND2P $T=501580 729680 1 0 $X=501580 $Y=724260
X4717 2897 1 2916 2919 2 ND2P $T=502200 709520 0 0 $X=502200 $Y=709140
X4718 2844 1 2717 2933 2 ND2P $T=505920 770000 0 180 $X=502200 $Y=764580
X4719 2832 1 2894 2941 2 ND2P $T=507780 739760 1 180 $X=504060 $Y=739380
X4720 2925 1 2920 2944 2 ND2P $T=509020 759920 0 180 $X=505300 $Y=754500
X4721 2939 1 2950 2854 2 ND2P $T=506540 749840 1 0 $X=506540 $Y=744420
X4722 2506 1 2717 2945 2 ND2P $T=510880 770000 0 180 $X=507160 $Y=764580
X4723 2973 1 2981 2833 2 ND2P $T=510880 749840 1 0 $X=510880 $Y=744420
X4724 2444 1 3021 412 2 ND2P $T=518320 709520 1 0 $X=518320 $Y=704100
X4725 2976 1 3021 417 2 ND2P $T=522660 699440 1 180 $X=518940 $Y=699060
X4726 3036 1 2517 3039 2 ND2P $T=521420 719600 0 0 $X=521420 $Y=719220
X4727 3031 1 3045 3036 2 ND2P $T=522040 729680 1 0 $X=522040 $Y=724260
X4728 2420 2063 2438 2 1 2697 XNR3 $T=474300 739760 0 0 $X=474300 $Y=739380
X4729 2905 3029 2944 2 1 3028 XNR3 $T=531960 749840 1 180 $X=520800 $Y=749460
X4730 2426 2465 2117 1 2 2514 MAO222 $T=442680 729680 0 0 $X=442680 $Y=729300
X4731 2428 2503 2118 1 2 2539 MAO222 $T=445780 749840 0 0 $X=445780 $Y=749460
X4732 2940 2585 2941 1 2 2966 MAO222 $T=522660 739760 0 180 $X=517700 $Y=734340
X4733 3014 1 3025 3039 2 3021 ND3HT $T=517080 719600 1 0 $X=517080 $Y=714180
X4734 2211 2212 1 2201 2 OR2T $T=407960 780080 0 0 $X=407960 $Y=779700
X4735 2369 2363 1 2366 2 OR2T $T=430280 770000 0 0 $X=430280 $Y=769620
X4736 2949 2541 1 2943 2 OR2T $T=516460 729680 1 180 $X=510260 $Y=729300
X4737 2323 2300 1 2338 2406 2 OAI12H $T=430900 780080 0 0 $X=430900 $Y=779700
X4738 2450 2387 1 2446 2212 2 OAI12H $T=441440 780080 0 180 $X=435240 $Y=774660
X4739 2891 2872 1 2919 2856 2 OAI12H $T=500340 709520 1 0 $X=500340 $Y=704100
X4740 2880 2740 2836 2 2799 2477 1 AO22S $T=499100 719600 0 180 $X=494140 $Y=714180
X4741 1845 139 2 145 1 146 MUX2S $T=349680 709520 1 0 $X=349680 $Y=704100
X4742 1910 143 2 149 1 151 MUX2S $T=354020 699440 0 0 $X=354020 $Y=699060
X4743 1949 143 2 154 1 1982 MUX2S $T=359600 699440 0 0 $X=359600 $Y=699060
X4744 1987 143 2 161 1 165 MUX2S $T=365180 699440 0 0 $X=365180 $Y=699060
X4745 2216 193 2 2252 1 2267 MUX2S $T=407340 719600 1 0 $X=407340 $Y=714180
X4746 2315 183 2 243 1 254 MUX2S $T=422840 699440 0 0 $X=422840 $Y=699060
X4747 312 291 2 316 1 2685 MUX2S $T=465620 699440 0 0 $X=465620 $Y=699060
X4748 2639 291 2 318 1 2694 MUX2S $T=467480 709520 1 0 $X=467480 $Y=704100
X4749 2733 323 2 339 1 2781 MUX2S $T=476780 699440 0 0 $X=476780 $Y=699060
X4750 2391 1 2459 2438 2 ND2T $T=442060 759920 1 0 $X=442060 $Y=754500
X4751 2214 199 227 2 1 2309 QDFFRBS $T=407340 770000 0 0 $X=407340 $Y=769620
X4752 1930 2 1 1902 2035 NR2F $T=369520 749840 1 0 $X=369520 $Y=744420
.ENDS
***************************************
.SUBCKT XOR2H I1 I2 O GND VCC
** N=6 EP=5 IP=0 FDC=0
.ENDS
***************************************
.SUBCKT AO22P O A2 A1 VCC B1 B2 GND
** N=8 EP=7 IP=0 FDC=0
.ENDS
***************************************
.SUBCKT INV4 I O GND VCC
** N=5 EP=4 IP=0 FDC=0
.ENDS
***************************************
.SUBCKT INV12 O I GND VCC
** N=5 EP=4 IP=0 FDC=0
.ENDS
***************************************
.SUBCKT MXL2H B S OB A GND VCC
** N=7 EP=6 IP=0 FDC=0
.ENDS
***************************************
.SUBCKT MXL2HF B S OB A GND VCC
** N=7 EP=6 IP=0 FDC=0
.ENDS
***************************************
.SUBCKT MAO222S B1 A1 C1 GND VCC O
** N=7 EP=6 IP=0 FDC=0
.ENDS
***************************************
.SUBCKT MXL2HT B S OB A GND VCC
** N=7 EP=6 IP=0 FDC=0
.ENDS
***************************************
.SUBCKT AO22T O A2 A1 VCC B1 B2 GND
** N=8 EP=7 IP=0 FDC=0
.ENDS
***************************************
.SUBCKT AOI22HT A2 A1 VCC B1 O B2 GND
** N=8 EP=7 IP=0 FDC=0
.ENDS
***************************************
.SUBCKT INV6 I O GND VCC
** N=5 EP=4 IP=0 FDC=0
.ENDS
***************************************
.SUBCKT INV8 O I GND VCC
** N=5 EP=4 IP=0 FDC=0
.ENDS
***************************************
.SUBCKT ND2F I2 I1 VCC O GND
** N=6 EP=5 IP=0 FDC=0
.ENDS
***************************************
.SUBCKT OR2B1T B1 I1 GND O VCC
** N=6 EP=5 IP=0 FDC=0
.ENDS
***************************************
.SUBCKT MOAI1HP B2 B1 GND A1 O A2 VCC
** N=8 EP=7 IP=0 FDC=0
.ENDS
***************************************
.SUBCKT QDFFRBT D CK RB GND VCC Q
** N=7 EP=6 IP=0 FDC=0
.ENDS
***************************************
.SUBCKT AN2P I1 I2 O GND VCC
** N=6 EP=5 IP=0 FDC=0
.ENDS
***************************************
.SUBCKT HA1 A B C GND VCC S
** N=7 EP=6 IP=0 FDC=0
.ENDS
***************************************
.SUBCKT BUF4CK I GND O VCC
** N=5 EP=4 IP=0 FDC=0
.ENDS
***************************************
.SUBCKT ICV_11 1 2 3 4 5 6 7 8 9 10 11
** N=11 EP=11 IP=14 FDC=0
X0 1 2 3 4 5 6 MUX2S $T=0 0 0 0 $X=0 $Y=-380
X1 7 8 3 9 5 10 MUX2S $T=4960 0 0 0 $X=4960 $Y=-380
.ENDS
***************************************
.SUBCKT AOI22HP A2 A1 VCC B1 O B2 GND
** N=8 EP=7 IP=0 FDC=0
.ENDS
***************************************
.SUBCKT XOR3P I2 I1 I3 O GND VCC
** N=7 EP=6 IP=0 FDC=0
.ENDS
***************************************
.SUBCKT AN2B1T B1 I1 O GND VCC
** N=6 EP=5 IP=0 FDC=0
.ENDS
***************************************
.SUBCKT MAO222P A1 B1 C1 O GND VCC
** N=7 EP=6 IP=0 FDC=0
.ENDS
***************************************
.SUBCKT ICV_12 1 2 3 4 5 6 7 8 9 10 11 12 13 14 15 16 17 18 19 20
+ 21 22 23 24 25 26 27 28 29 30 31 32 33 34 35 36 37 38 39 40
+ 41 42 43 44 45 46 47 48 49 50 51 52 53 54 55 56 57 58 59 60
+ 61 62 63 64 65 66 67 68 69 70 71 72 73 74 75 76 77 78 79 80
+ 81 82 83 84 85 86 87 88 89 90 91 92 93 94 95 96 97 98 99 100
+ 101 102 103 104 105 106 107 108 109 110 111 112 113 114 115 116 117 118 119 120
+ 121 122 123 124 125 126 127 128 129 130 131 132 133 134 135 136 137 138 139 140
+ 141 142 143 144 145 146 147 148 149 150 151 152 153 154 155 156 157 158 159 160
+ 161 162 163 164 165 166 167 168 169 170 171 172 173 174 175 176 177 178 179 180
+ 181 182 183 184 185 186 187 188 189 190 191 192 193 194 195 196 197 198 199 200
+ 201 202 203 204 205 206 207 208 209 210 211 212 213 214 215 216 217 218 219 220
+ 221 222 223 224 225 226 227 228 229 230 231 232 233 234 235 236 237 238 239 240
+ 241 242 243 244 245 246 247 248 249 250 251 252 253 254 255 256 257 258 259 260
+ 261 262 263 264 265 266 267 268 269 270 271 272 273 274 275 276 277 278 279 280
+ 281 282 283 284 285 286 287 288 289 290 291 292 293 294 295 296 297 298 299 300
+ 301 302 303 304 305 306 307 308 309 310 311 312 313 314 315 316 317 318 319 320
+ 321 322 323 324 325 326 327 328 329 330 331 332 333 334 335 336 337 338 339 340
+ 341 342 343 344 345 346 347 348 349 350 351 352 353 354 355 356 357 358 359 360
+ 361 362 363 364 365 366 367 368 369 370 371 372 373 374 375 376 377 378 379 380
+ 381 382 383 384 385 386 387 388 389 390 391 392 393 394 395 396 397 398 399 400
+ 401 402 403 404 405 406 407 408 409 410 411 412 413 414 415 416 417 418 419 420
+ 421 422 423 424 425 426 427 428 429 430 431 432 433 434 435 436 437 438 439 440
+ 441 442 443 444 445 446 447 448 449 450 451 452 453 454 455 456 457 458 459 460
+ 461 462 463 464 465 466 467 468 469 470 471 472 473 474 475 476 477 478 479 480
+ 481 482 483 484 485 486 487 488 489 490 491 492 493 494 495 496 497 498 499 500
+ 501 502 503 504 505 506 507 508 509 510 511 512 513 514 515 516 517 518 519 520
+ 521 522 523 524 525 526 527 528 529 530 531 532 533 534 535 536 537 538 539 540
+ 541 542 543 544 545 546 547 548 549 550 551 552 553 554 555 556 557 558 559 560
+ 561 562 563 564 565 566 567 568 569 570 571 572 573 574 575 576 577 578 579 580
+ 581 582 583 584 585 586 587 588 589 590 591 592 593 594 595 596 597 598 599 600
+ 601 602 603 604 605 606 607 608 609 610 611 612 613 614 615 616 617 618 619 620
+ 621 622 623 624 625 626 627 628 629 630 631 632 633 634 635 636 637 638 639 640
+ 641 642 643 644 645 646 647 648 649 650 651 652 653 654 655 656 657 658 659 660
+ 661 662 663 664 665 666 667 668 669 670 671 672 673 674 675 676 677 678 679 680
+ 681 682 683 684 685 686 687 688 689 690 691 692 693 694 695 696 697 698 699 700
+ 701 702 703 704 705 706 707 708 709 710 711 712 713 714 715 716 717 718 719 720
+ 721 722 723 724 725 726 727 728 729 730 731 732 733 734 735 736 737 738 739 740
+ 741 742 743 744 745 746 747 748 749 750 751 752 753 754 755 756 757 758 759 760
+ 761 762 763 764 765 766 767 768 769 770 771 772 773 774 775 776 777 778 779 780
+ 781 782 783 784 785 786 787 788 789 790 791 792 793 794 795 796 797 798 799 800
+ 801 802 803 804 805 806 807 808 809 810 811 812 813 814 815 816 817 818 819 820
+ 821 822 823 824 825 826 827 828 829 830 831 832 833 834 835 836 837 838 839 840
+ 841 842 843 844 845 846 847 848 849 850 851 852 853 854 855 856 857 858 859 860
+ 861 862 863 864 865 866 867 868 869 870 871 872 873 874 875 876 877 878 879 880
+ 881 882 883 884 885 886 887 888 889 890 891 892 893 894 895 896 897 898 899 900
+ 901 902 903 904 905 906 907 908 909 910 911 912 913 914 915 916 917 918 919 920
+ 921 922 923 924 925 926 927 928 929 930 931 932 933 934 935 936 937 938 939 940
+ 941 942 943 944 945 946 947 948 949 950 951 952 953 954 955 956 957 958 959 960
+ 961 962 963 1023
** N=3377 EP=964 IP=17532 FDC=0
X0 2053 343 332 1 2 QDFFN $T=559860 608720 1 180 $X=549320 $Y=608340
X1 2008 343 2046 1 2 QDFFN $T=566060 618800 0 180 $X=555520 $Y=613380
X2 2089 343 2067 1 2 QDFFN $T=574740 608720 0 180 $X=564200 $Y=603300
X3 2075 343 2115 1 2 QDFFN $T=570400 638960 0 0 $X=570400 $Y=638580
X4 2095 343 2120 1 2 QDFFN $T=575360 638960 1 0 $X=575360 $Y=633540
X5 2124 343 2099 1 2 QDFFN $T=586520 608720 0 180 $X=575980 $Y=603300
X6 2082 343 2130 1 2 QDFFN $T=580320 618800 1 0 $X=580320 $Y=613380
X7 2104 343 2154 1 2 QDFFN $T=587140 608720 1 0 $X=587140 $Y=603300
X8 2065 343 2158 1 2 QDFFN $T=587760 638960 0 0 $X=587760 $Y=638580
X9 1985 343 2160 1 2 QDFFN $T=591480 638960 1 0 $X=591480 $Y=633540
X10 2105 343 2170 1 2 QDFFN $T=593960 628880 0 0 $X=593960 $Y=628500
X11 2116 343 2169 1 2 QDFFN $T=595200 618800 1 0 $X=595200 $Y=613380
X12 2110 343 2175 1 2 QDFFN $T=595200 618800 0 0 $X=595200 $Y=618420
X13 2142 395 2181 1 2 QDFFN $T=598920 608720 1 0 $X=598920 $Y=603300
X14 2092 343 2199 1 2 QDFFN $T=608220 638960 1 0 $X=608220 $Y=633540
X15 2196 343 2203 1 2 QDFFN $T=625580 618800 1 180 $X=615040 $Y=618420
X16 2202 343 2236 1 2 QDFFN $T=622480 628880 1 0 $X=622480 $Y=623460
X17 443 395 2253 1 2 QDFFN $T=632400 608720 1 0 $X=632400 $Y=603300
X18 2235 343 2260 1 2 QDFFN $T=632400 618800 0 0 $X=632400 $Y=618420
X19 2224 462 472 1 2 QDFFN $T=645420 608720 1 0 $X=645420 $Y=603300
X20 844 842 3044 1 2 QDFFN $T=941160 679280 0 180 $X=930620 $Y=673860
X21 844 845 3046 1 2 QDFFN $T=943020 689360 0 180 $X=932480 $Y=683940
X22 843 846 852 1 2 QDFFN $T=938680 689360 0 0 $X=938680 $Y=688980
X23 843 845 3089 1 2 QDFFN $T=942400 679280 0 0 $X=942400 $Y=678900
X24 843 842 3095 1 2 QDFFN $T=943020 679280 1 0 $X=943020 $Y=673860
X25 856 846 3092 1 2 QDFFN $T=961620 689360 1 180 $X=951080 $Y=688980
X26 856 845 3117 1 2 QDFFN $T=954180 679280 0 0 $X=954180 $Y=678900
X27 856 842 3111 1 2 QDFFN $T=955420 679280 1 0 $X=955420 $Y=673860
X28 867 846 3146 1 2 QDFFN $T=964100 689360 0 0 $X=964100 $Y=688980
X29 867 845 3136 1 2 QDFFN $T=965960 679280 0 0 $X=965960 $Y=678900
X30 867 842 3135 1 2 QDFFN $T=979600 679280 0 180 $X=969060 $Y=673860
X31 877 846 3168 1 2 QDFFN $T=975880 689360 0 0 $X=975880 $Y=688980
X32 877 845 3153 1 2 QDFFN $T=978360 679280 0 0 $X=978360 $Y=678900
X33 877 842 3160 1 2 QDFFN $T=980840 669200 0 0 $X=980840 $Y=668820
X34 844 894 3164 1 2 QDFFN $T=993860 689360 0 180 $X=983320 $Y=683940
X35 856 894 3198 1 2 QDFFN $T=991380 679280 1 0 $X=991380 $Y=673860
X36 877 897 3217 1 2 QDFFN $T=993860 689360 0 0 $X=993860 $Y=688980
X37 877 898 3215 1 2 QDFFN $T=996340 679280 0 0 $X=996340 $Y=678900
X38 856 897 3240 1 2 QDFFN $T=1008120 679280 1 0 $X=1008120 $Y=673860
X39 856 898 3251 1 2 QDFFN $T=1010600 679280 0 0 $X=1010600 $Y=678900
X40 843 897 3257 1 2 QDFFN $T=1019900 699440 1 0 $X=1019900 $Y=694020
X41 844 897 3256 1 2 QDFFN $T=1020520 679280 1 0 $X=1020520 $Y=673860
X42 844 898 3271 1 2 QDFFN $T=1042220 679280 0 180 $X=1031680 $Y=673860
X43 843 898 3261 1 2 QDFFN $T=1042220 689360 0 180 $X=1031680 $Y=683940
X44 877 931 3308 1 2 QDFFN $T=1042220 679280 1 0 $X=1042220 $Y=673860
X45 877 932 3322 1 2 QDFFN $T=1044700 679280 0 0 $X=1044700 $Y=678900
X46 856 931 3340 1 2 QDFFN $T=1055860 679280 1 0 $X=1055860 $Y=673860
X47 856 932 3350 1 2 QDFFN $T=1057100 689360 1 0 $X=1057100 $Y=683940
X48 844 931 3353 1 2 QDFFN $T=1077560 669200 0 180 $X=1067020 $Y=663780
X49 844 932 3357 1 2 QDFFN $T=1081900 679280 1 180 $X=1071360 $Y=678900
X50 843 931 3370 1 2 QDFFN $T=1073220 679280 1 0 $X=1073220 $Y=673860
X51 843 932 3371 1 2 QDFFN $T=1076320 689360 1 0 $X=1076320 $Y=683940
X52 843 959 962 1 2 QDFFN $T=1077560 699440 1 0 $X=1077560 $Y=694020
X53 333 2030 1987 2033 1 2034 2 AOI22S $T=549940 659120 0 0 $X=549940 $Y=658740
X54 329 2016 334 2033 1 2034 2 AOI22S $T=550560 669200 0 0 $X=550560 $Y=668820
X55 2031 2036 2032 2033 1 2034 2 AOI22S $T=551180 689360 1 0 $X=551180 $Y=683940
X56 2042 2042 339 2033 1 2034 2 AOI22S $T=556760 679280 0 180 $X=553040 $Y=673860
X57 347 2054 2051 2033 1 2034 2 AOI22S $T=559860 669200 0 0 $X=559860 $Y=668820
X58 2055 2057 348 2033 1 2034 2 AOI22S $T=559860 689360 1 0 $X=559860 $Y=683940
X59 2073 2077 2078 2033 1 2034 2 AOI22S $T=568540 669200 0 0 $X=568540 $Y=668820
X60 2070 2085 354 2033 1 2034 2 AOI22S $T=569780 659120 0 0 $X=569780 $Y=658740
X61 355 358 2087 360 1 361 2 AOI22S $T=571020 699440 1 0 $X=571020 $Y=694020
X62 2086 2103 364 2033 1 2034 2 AOI22S $T=577220 659120 1 0 $X=577220 $Y=653700
X63 2093 2107 2097 2033 1 2034 2 AOI22S $T=577220 679280 1 0 $X=577220 $Y=673860
X64 365 2109 2106 360 1 361 2 AOI22S $T=578460 689360 0 0 $X=578460 $Y=688980
X65 2129 2119 374 2033 1 2034 2 AOI22S $T=587760 649040 1 180 $X=584040 $Y=648660
X66 2113 2126 2121 2033 1 2034 2 AOI22S $T=585280 659120 1 0 $X=585280 $Y=653700
X67 2131 2127 2139 2033 1 2034 2 AOI22S $T=589000 679280 0 180 $X=585280 $Y=673860
X68 383 2148 2137 360 1 387 2 AOI22S $T=592720 689360 0 0 $X=592720 $Y=688980
X69 2145 2149 382 2033 1 2034 2 AOI22S $T=593340 659120 1 0 $X=593340 $Y=653700
X70 2132 2150 2147 2033 1 2034 2 AOI22S $T=593340 679280 1 0 $X=593340 $Y=673860
X71 393 394 2153 360 1 387 2 AOI22S $T=599540 689360 0 0 $X=599540 $Y=688980
X72 392 2166 2164 2033 1 2034 2 AOI22S $T=601400 659120 0 0 $X=601400 $Y=658740
X73 2173 2168 403 2033 1 2034 2 AOI22S $T=605740 649040 1 180 $X=602020 $Y=648660
X74 400 2156 2167 360 1 387 2 AOI22S $T=605740 689360 0 0 $X=605740 $Y=688980
X75 396 2172 2178 2033 1 2034 2 AOI22S $T=606360 679280 1 0 $X=606360 $Y=673860
X76 2159 2186 2184 2033 1 2034 2 AOI22S $T=609460 669200 0 0 $X=609460 $Y=668820
X77 2204 2198 416 2033 1 2034 2 AOI22S $T=617520 649040 0 180 $X=613800 $Y=643620
X78 407 2200 2211 2033 1 2034 2 AOI22S $T=616900 659120 0 0 $X=616900 $Y=658740
X79 420 2187 2209 426 1 387 2 AOI22S $T=618760 689360 1 0 $X=618760 $Y=683940
X80 2201 2215 2214 2033 1 2034 2 AOI22S $T=620000 669200 0 0 $X=620000 $Y=668820
X81 425 2219 2216 2033 1 2034 2 AOI22S $T=622480 659120 0 0 $X=622480 $Y=658740
X82 431 436 2231 426 1 387 2 AOI22S $T=626200 689360 0 0 $X=626200 $Y=688980
X83 2233 2221 440 2033 1 2243 2 AOI22S $T=629920 638960 0 0 $X=629920 $Y=638580
X84 2240 2238 441 2033 1 2243 2 AOI22S $T=630540 659120 1 0 $X=630540 $Y=653700
X85 434 2241 2242 2033 1 2034 2 AOI22S $T=630540 669200 0 0 $X=630540 $Y=668820
X86 2205 2258 447 2033 1 2243 2 AOI22S $T=636740 638960 0 0 $X=636740 $Y=638580
X87 2247 2254 449 2033 1 2243 2 AOI22S $T=636740 659120 0 0 $X=636740 $Y=658740
X88 2251 2257 2261 2033 1 2034 2 AOI22S $T=640460 669200 1 180 $X=636740 $Y=668820
X89 451 2265 2234 426 1 387 2 AOI22S $T=639220 689360 0 0 $X=639220 $Y=688980
X90 2180 2268 453 456 1 2243 2 AOI22S $T=641080 649040 0 0 $X=641080 $Y=648660
X91 466 458 2272 426 1 387 2 AOI22S $T=646040 699440 0 180 $X=642320 $Y=694020
X92 2267 2274 457 2033 1 2243 2 AOI22S $T=643560 638960 0 0 $X=643560 $Y=638580
X93 2251 2275 2273 2033 1 2034 2 AOI22S $T=643560 669200 0 0 $X=643560 $Y=668820
X94 459 461 2250 426 1 387 2 AOI22S $T=646040 689360 0 0 $X=646040 $Y=688980
X95 2290 2287 473 456 1 2243 2 AOI22S $T=654720 659120 0 180 $X=651000 $Y=653700
X96 2276 2285 470 456 1 2243 2 AOI22S $T=651000 669200 1 0 $X=651000 $Y=663780
X97 2193 2288 475 456 1 2034 2 AOI22S $T=655960 679280 0 180 $X=652240 $Y=673860
X98 2193 2301 481 456 1 2034 2 AOI22S $T=661540 679280 0 180 $X=657820 $Y=673860
X99 490 2303 2297 426 1 387 2 AOI22S $T=662160 689360 1 180 $X=658440 $Y=688980
X100 2302 2323 2319 426 1 387 2 AOI22S $T=665260 689360 1 0 $X=665260 $Y=683940
X101 498 2331 2327 426 1 387 2 AOI22S $T=671460 689360 1 180 $X=667740 $Y=688980
X102 2408 2415 532 533 1 2435 2 AOI22S $T=708040 679280 0 0 $X=708040 $Y=678900
X103 2349 2416 531 533 1 537 2 AOI22S $T=708040 699440 1 0 $X=708040 $Y=694020
X104 2441 2428 539 533 1 2435 2 AOI22S $T=714240 679280 1 0 $X=714240 $Y=673860
X105 554 2446 550 533 1 2435 2 AOI22S $T=718580 669200 1 180 $X=714860 $Y=668820
X106 538 2431 540 533 1 2435 2 AOI22S $T=716100 689360 1 0 $X=716100 $Y=683940
X107 543 2452 548 533 1 2435 2 AOI22S $T=717960 659120 0 0 $X=717960 $Y=658740
X108 551 2443 2454 533 1 2435 2 AOI22S $T=719820 638960 0 0 $X=719820 $Y=638580
X109 559 2455 2459 533 1 2435 2 AOI22S $T=724780 649040 0 180 $X=721060 $Y=643620
X110 563 2468 2466 533 1 2435 2 AOI22S $T=726020 659120 1 0 $X=726020 $Y=653700
X111 573 2481 2483 533 1 2435 2 AOI22S $T=733460 659120 0 180 $X=729740 $Y=653700
X112 2497 2507 2492 590 1 589 2 AOI22S $T=737180 679280 1 0 $X=737180 $Y=673860
X113 2518 2512 2477 590 1 589 2 AOI22S $T=741520 689360 0 180 $X=737800 $Y=683940
X114 592 2519 2500 533 1 2435 2 AOI22S $T=740280 659120 0 0 $X=740280 $Y=658740
X115 2537 2525 2529 590 1 589 2 AOI22S $T=745240 669200 1 180 $X=741520 $Y=668820
X116 595 2536 2530 533 1 2435 2 AOI22S $T=744000 659120 0 0 $X=744000 $Y=658740
X117 601 2568 2553 533 1 2435 2 AOI22S $T=753300 649040 0 0 $X=753300 $Y=648660
X118 603 603 2577 533 1 2435 2 AOI22S $T=756400 659120 1 0 $X=756400 $Y=653700
X119 2590 2586 2549 590 1 589 2 AOI22S $T=762600 669200 0 180 $X=758880 $Y=663780
X120 2641 2636 2558 590 1 589 2 AOI22S $T=778100 659120 1 180 $X=774380 $Y=658740
X121 2645 2637 2583 590 1 589 2 AOI22S $T=778720 659120 0 180 $X=775000 $Y=653700
X122 2691 2674 2699 590 1 589 2 AOI22S $T=794840 659120 0 180 $X=791120 $Y=653700
X123 2673 2702 2701 590 1 589 2 AOI22S $T=796080 669200 1 0 $X=796080 $Y=663780
X124 667 667 2710 533 1 2435 2 AOI22S $T=800420 659120 1 0 $X=800420 $Y=653700
X125 2732 2737 2744 590 1 589 2 AOI22S $T=809100 669200 0 180 $X=805380 $Y=663780
X126 675 2734 2738 533 1 2435 2 AOI22S $T=810340 659120 0 180 $X=806620 $Y=653700
X127 681 2758 2761 533 1 2435 2 AOI22S $T=816540 659120 0 180 $X=812820 $Y=653700
X128 689 2766 2789 533 1 2435 2 AOI22S $T=825840 659120 0 180 $X=822120 $Y=653700
X129 2784 2787 2795 690 1 691 2 AOI22S $T=825220 679280 0 0 $X=825220 $Y=678900
X130 709 2839 2836 533 1 2435 2 AOI22S $T=840100 669200 1 0 $X=840100 $Y=663780
X131 2822 2832 2841 690 1 691 2 AOI22S $T=840720 679280 1 0 $X=840720 $Y=673860
X132 2850 2853 2849 722 1 723 2 AOI22S $T=846920 649040 0 0 $X=846920 $Y=648660
X133 726 2855 2870 533 1 2435 2 AOI22S $T=853120 669200 0 180 $X=849400 $Y=663780
X134 2863 2865 2866 690 1 691 2 AOI22S $T=851880 679280 1 0 $X=851880 $Y=673860
X135 737 2895 738 533 1 2435 2 AOI22S $T=859320 659120 1 0 $X=859320 $Y=653700
X136 2879 2898 2892 690 1 691 2 AOI22S $T=859320 689360 0 0 $X=859320 $Y=688980
X137 733 2887 2897 533 1 2435 2 AOI22S $T=860560 659120 0 0 $X=860560 $Y=658740
X138 744 2911 741 533 1 2435 2 AOI22S $T=864900 689360 0 0 $X=864900 $Y=688980
X139 744 2909 745 533 1 2435 2 AOI22S $T=864900 699440 1 0 $X=864900 $Y=694020
X140 751 2916 750 533 1 2435 2 AOI22S $T=870480 659120 0 180 $X=866760 $Y=653700
X141 747 2918 749 533 1 2435 2 AOI22S $T=868620 669200 1 0 $X=868620 $Y=663780
X142 758 2924 755 533 1 2435 2 AOI22S $T=874200 659120 0 180 $X=870480 $Y=653700
X143 2941 2930 760 533 1 2435 2 AOI22S $T=876060 659120 1 180 $X=872340 $Y=658740
X144 769 2932 763 533 1 2435 2 AOI22S $T=877300 679280 0 180 $X=873580 $Y=673860
X145 2946 2935 762 533 1 2435 2 AOI22S $T=877920 669200 0 180 $X=874200 $Y=663780
X146 2945 2949 764 533 1 2435 2 AOI22S $T=877920 679280 0 0 $X=877920 $Y=678900
X147 765 2953 770 533 1 2435 2 AOI22S $T=879160 689360 0 0 $X=879160 $Y=688980
X148 3044 3046 3049 840 1 836 2 AOI22S $T=931240 689360 0 0 $X=931240 $Y=688980
X149 3095 3089 3083 840 1 836 2 AOI22S $T=951080 689360 0 180 $X=947360 $Y=683940
X150 3092 857 3102 858 1 859 2 AOI22S $T=954180 699440 1 0 $X=954180 $Y=694020
X151 3111 3117 3112 840 1 836 2 AOI22S $T=962240 689360 1 0 $X=962240 $Y=683940
X152 3135 3136 868 840 1 836 2 AOI22S $T=969680 689360 1 0 $X=969680 $Y=683940
X153 3146 873 875 858 1 859 2 AOI22S $T=973400 699440 0 180 $X=969680 $Y=694020
X154 3160 3153 3154 840 1 836 2 AOI22S $T=980220 689360 0 180 $X=976500 $Y=683940
X155 3168 884 885 858 1 859 2 AOI22S $T=985180 699440 0 180 $X=981460 $Y=694020
X156 3164 3176 3059 892 1 893 2 AOI22S $T=987660 689360 0 0 $X=987660 $Y=688980
X157 890 3179 3085 892 1 893 2 AOI22S $T=988280 699440 1 0 $X=988280 $Y=694020
X158 3198 3192 3118 892 1 893 2 AOI22S $T=998200 699440 0 180 $X=994480 $Y=694020
X159 905 3205 880 892 1 893 2 AOI22S $T=1003780 699440 0 180 $X=1000060 $Y=694020
X160 3215 3217 3219 917 1 909 2 AOI22S $T=1008120 689360 0 0 $X=1008120 $Y=688980
X161 3251 3240 3242 917 1 909 2 AOI22S $T=1019900 689360 1 180 $X=1016180 $Y=688980
X162 3271 3256 3276 917 1 909 2 AOI22S $T=1027960 679280 1 180 $X=1024240 $Y=678900
X163 3261 3257 3268 917 1 909 2 AOI22S $T=1027960 689360 0 180 $X=1024240 $Y=683940
X164 3322 3308 3300 935 1 934 2 AOI22S $T=1050900 689360 1 180 $X=1047180 $Y=688980
X165 3335 3333 3324 3342 1 3342 2 AOI22S $T=1059580 608720 0 0 $X=1059580 $Y=608340
X166 3350 3340 3319 935 1 934 2 AOI22S $T=1063300 689360 1 180 $X=1059580 $Y=688980
X167 3357 3353 3355 935 1 934 2 AOI22S $T=1069500 689360 0 0 $X=1069500 $Y=688980
X168 3371 3370 3362 935 1 934 2 AOI22S $T=1083140 689360 1 180 $X=1079420 $Y=688980
X169 1096 1095 1 2 1080 AN2 $T=243660 638960 1 180 $X=241180 $Y=638580
X170 1138 1124 1 2 1154 AN2 $T=261020 628880 1 0 $X=261020 $Y=623460
X171 1171 1154 1 2 1186 AN2 $T=270940 628880 1 0 $X=270940 $Y=623460
X172 1195 1188 1 2 1094 AN2 $T=278380 628880 1 180 $X=275900 $Y=628500
X173 1182 1172 1 2 1196 AN2 $T=276520 649040 0 0 $X=276520 $Y=648660
X174 1198 1188 1 2 1127 AN2 $T=279620 618800 1 180 $X=277140 $Y=618420
X175 1187 1186 1 2 1205 AN2 $T=280240 618800 1 0 $X=280240 $Y=613380
X176 1206 1188 1 2 1098 AN2 $T=283960 628880 0 180 $X=281480 $Y=623460
X177 1208 1188 1 2 1152 AN2 $T=285200 618800 1 180 $X=282720 $Y=618420
X178 1203 1205 1 2 1220 AN2 $T=283960 618800 1 0 $X=283960 $Y=613380
X179 1255 83 1 2 1155 AN2 $T=293260 659120 1 180 $X=290780 $Y=658740
X180 1240 83 1 2 1109 AN2 $T=293260 669200 0 180 $X=290780 $Y=663780
X181 1235 1220 1 2 1252 AN2 $T=294500 608720 1 0 $X=294500 $Y=603300
X182 1283 83 1 2 1079 AN2 $T=301320 659120 1 180 $X=298840 $Y=658740
X183 1261 1209 1 2 1278 AN2 $T=301940 659120 1 0 $X=301940 $Y=653700
X184 1285 1252 1 2 1298 AN2 $T=308140 608720 0 0 $X=308140 $Y=608340
X185 1315 1297 1 2 1330 AN2 $T=319920 659120 1 0 $X=319920 $Y=653700
X186 1337 1330 1 2 1358 AN2 $T=327980 649040 1 0 $X=327980 $Y=643620
X187 1348 1340 1 2 1370 AN2 $T=331700 608720 1 0 $X=331700 $Y=603300
X188 1340 1385 1 2 1419 AN2 $T=349680 608720 1 0 $X=349680 $Y=603300
X189 1419 1348 1 2 164 AN2 $T=352160 608720 1 0 $X=352160 $Y=603300
X190 1442 164 1 2 1469 AN2 $T=369520 608720 1 0 $X=369520 $Y=603300
X191 1465 1463 1 2 1481 AN2 $T=371380 669200 1 0 $X=371380 $Y=663780
X192 1483 1474 1 2 1463 AN2 $T=373860 669200 1 180 $X=371380 $Y=668820
X193 193 191 1 2 1475 AN2 $T=375720 699440 0 180 $X=373240 $Y=694020
X194 1478 1487 1 2 1474 AN2 $T=374480 679280 1 0 $X=374480 $Y=673860
X195 1475 1468 1 2 1500 AN2 $T=378820 699440 1 0 $X=378820 $Y=694020
X196 1488 1481 1 2 1509 AN2 $T=382540 669200 1 0 $X=382540 $Y=663780
X197 201 1500 1 2 1517 AN2 $T=386260 689360 1 0 $X=386260 $Y=683940
X198 1496 1469 1 2 1519 AN2 $T=386880 608720 1 0 $X=386880 $Y=603300
X199 1498 1503 1 2 1487 AN2 $T=387500 679280 1 0 $X=387500 $Y=673860
X200 1508 1381 1 2 1523 AN2 $T=388740 638960 1 0 $X=388740 $Y=633540
X201 1533 1517 1 2 1503 AN2 $T=391220 679280 1 180 $X=388740 $Y=678900
X202 1537 1523 1 2 1559 AN2 $T=396180 638960 1 0 $X=396180 $Y=633540
X203 1539 1519 1 2 1553 AN2 $T=396800 608720 1 0 $X=396800 $Y=603300
X204 1555 1553 1 2 1570 AN2 $T=400520 608720 0 0 $X=400520 $Y=608340
X205 1578 1579 1 2 1521 AN2 $T=406720 618800 1 180 $X=404240 $Y=618420
X206 1565 1559 1 2 1583 AN2 $T=404240 638960 1 0 $X=404240 $Y=633540
X207 1577 1570 1 2 1603 AN2 $T=408580 608720 0 0 $X=408580 $Y=608340
X208 1586 1583 1 2 1597 AN2 $T=409820 628880 0 0 $X=409820 $Y=628500
X209 1598 1601 1 2 1604 AN2 $T=411680 638960 1 0 $X=411680 $Y=633540
X210 1607 1608 1 2 1579 AN2 $T=416020 618800 1 180 $X=413540 $Y=618420
X211 1588 1597 1 2 1601 AN2 $T=413540 628880 0 0 $X=413540 $Y=628500
X212 1613 1603 1 2 1624 AN2 $T=418500 608720 0 0 $X=418500 $Y=608340
X213 1640 1624 1 2 1608 AN2 $T=426560 618800 0 180 $X=424080 $Y=613380
X214 1623 1604 1 2 1648 AN2 $T=424700 638960 0 0 $X=424700 $Y=638580
X215 236 1642 1 2 1650 AN2 $T=427180 699440 1 0 $X=427180 $Y=694020
X216 1647 1650 1 2 1634 AN2 $T=430280 689360 1 0 $X=430280 $Y=683940
X217 1654 1648 1 2 1658 AN2 $T=430900 628880 0 0 $X=430900 $Y=628500
X218 1670 1664 1 2 1662 AN2 $T=434000 669200 0 180 $X=431520 $Y=663780
X219 1644 1645 1 2 1664 AN2 $T=431520 669200 0 0 $X=431520 $Y=668820
X220 1669 1662 1 2 1673 AN2 $T=433380 659120 0 0 $X=433380 $Y=658740
X221 1671 1672 1 2 1678 AN2 $T=435240 638960 1 0 $X=435240 $Y=633540
X222 1685 1673 1 2 1672 AN2 $T=437720 649040 1 180 $X=435240 $Y=648660
X223 1704 1678 1 2 1722 AN2 $T=444540 638960 1 0 $X=444540 $Y=633540
X224 1826 286 1 2 1802 AN2 $T=481740 608720 1 180 $X=479260 $Y=608340
X225 1819 1807 1 2 1787 AN2 $T=482980 618800 1 180 $X=480500 $Y=618420
X226 1801 1804 1 2 1811 AN2 $T=480500 669200 0 0 $X=480500 $Y=668820
X227 1806 287 1 2 1813 AN2 $T=481120 689360 0 0 $X=481120 $Y=688980
X228 1825 1822 1 2 1804 AN2 $T=486080 679280 1 180 $X=483600 $Y=678900
X229 1818 1813 1 2 1822 AN2 $T=484220 689360 1 0 $X=484220 $Y=683940
X230 1831 1835 1 2 1807 AN2 $T=490420 638960 0 180 $X=487940 $Y=633540
X231 1829 1845 1 2 1835 AN2 $T=491660 649040 0 180 $X=489180 $Y=643620
X232 1837 1843 1 2 1845 AN2 $T=489180 649040 0 0 $X=489180 $Y=648660
X233 1830 1811 1 2 1843 AN2 $T=489180 659120 0 0 $X=489180 $Y=658740
X234 1972 286 1 2 1931 AN2 $T=520800 638960 0 180 $X=518320 $Y=633540
X235 1975 286 1 2 1930 AN2 $T=521420 618800 0 180 $X=518940 $Y=613380
X236 1969 286 1 2 1916 AN2 $T=521420 628880 0 180 $X=518940 $Y=623460
X237 1986 286 1 2 1911 AN2 $T=533200 649040 1 180 $X=530720 $Y=648660
X238 1995 286 1 2 1906 AN2 $T=533820 659120 1 180 $X=531340 $Y=658740
X239 1994 286 1 2 1971 AN2 $T=533820 689360 1 180 $X=531340 $Y=688980
X240 1990 286 1 2 1937 AN2 $T=534440 649040 0 180 $X=531960 $Y=643620
X241 1988 286 1 2 1957 AN2 $T=543120 679280 0 180 $X=540640 $Y=673860
X242 2004 286 1 2 299 AN2 $T=542500 699440 1 0 $X=542500 $Y=694020
X243 2009 286 1 2 1983 AN2 $T=545600 679280 0 180 $X=543120 $Y=673860
X244 338 331 1 2 2023 AN2 $T=550560 608720 0 180 $X=548080 $Y=603300
X245 2029 2039 1 2 2049 AN2 $T=554900 669200 1 0 $X=554900 $Y=663780
X246 2049 2063 1 2 2074 AN2 $T=564820 669200 1 0 $X=564820 $Y=663780
X247 2079 2083 1 2 2102 AN2 $T=573500 649040 1 0 $X=573500 $Y=643620
X248 2074 2076 1 2 2098 AN2 $T=574120 669200 0 0 $X=574120 $Y=668820
X249 2098 2100 1 2 2111 AN2 $T=577220 659120 0 0 $X=577220 $Y=658740
X250 2102 2108 1 2 2114 AN2 $T=579700 649040 1 0 $X=579700 $Y=643620
X251 2111 2117 1 2 2123 AN2 $T=583420 659120 0 0 $X=583420 $Y=658740
X252 2123 2134 1 2 2144 AN2 $T=590240 659120 0 0 $X=590240 $Y=658740
X253 2114 2128 1 2 2152 AN2 $T=591480 649040 1 0 $X=591480 $Y=643620
X254 2144 2151 1 2 2161 AN2 $T=597060 659120 0 0 $X=597060 $Y=658740
X255 2152 2155 1 2 2165 AN2 $T=598920 649040 1 0 $X=598920 $Y=643620
X256 2161 2163 1 2 2177 AN2 $T=603880 669200 1 0 $X=603880 $Y=663780
X257 2177 2182 1 2 2174 AN2 $T=610080 659120 0 180 $X=607600 $Y=653700
X258 2174 2162 1 2 2188 AN2 $T=608840 649040 0 0 $X=608840 $Y=648660
X259 2165 2179 1 2 2194 AN2 $T=609460 638960 0 0 $X=609460 $Y=638580
X260 2188 2190 1 2 2208 AN2 $T=613180 649040 0 0 $X=613180 $Y=648660
X261 2208 2210 1 2 2212 AN2 $T=616900 649040 0 0 $X=616900 $Y=648660
X262 2194 2207 1 2 2213 AN2 $T=618760 638960 0 0 $X=618760 $Y=638580
X263 2213 2217 1 2 2227 AN2 $T=623100 638960 1 0 $X=623100 $Y=633540
X264 2212 2206 1 2 2228 AN2 $T=623720 669200 1 0 $X=623720 $Y=663780
X265 2226 2225 1 2 2237 AN2 $T=627440 649040 1 0 $X=627440 $Y=643620
X266 2245 2244 1 2 2226 AN2 $T=633640 638960 0 180 $X=631160 $Y=633540
X267 2228 2232 1 2 2259 AN2 $T=633640 669200 1 0 $X=633640 $Y=663780
X268 2237 2246 1 2 2255 AN2 $T=634880 649040 1 0 $X=634880 $Y=643620
X269 2227 2263 1 2 2245 AN2 $T=640460 628880 1 180 $X=637980 $Y=628500
X270 2249 338 1 2 2269 AN2 $T=644180 618800 0 180 $X=641700 $Y=613380
X271 2255 2264 1 2 2282 AN2 $T=647900 649040 1 0 $X=647900 $Y=643620
X272 2277 2278 1 2 2281 AN2 $T=648520 669200 1 0 $X=648520 $Y=663780
X273 2282 2280 1 2 2277 AN2 $T=651620 649040 1 180 $X=649140 $Y=648660
X274 2342 2364 1 2 2374 AN2 $T=684480 649040 0 0 $X=684480 $Y=648660
X275 515 513 1 2 2368 AN2 $T=688200 638960 1 180 $X=685720 $Y=638580
X276 2407 2403 1 2 2420 AN2 $T=702460 679280 0 0 $X=702460 $Y=678900
X277 2420 2419 1 2 527 AN2 $T=706180 689360 1 180 $X=703700 $Y=688980
X278 2424 2422 1 2 2407 AN2 $T=708660 669200 1 180 $X=706180 $Y=668820
X279 2437 2432 1 2 2424 AN2 $T=713000 669200 0 180 $X=710520 $Y=663780
X280 2445 2442 1 2 2437 AN2 $T=716100 659120 0 180 $X=713620 $Y=653700
X281 2449 2450 1 2 2445 AN2 $T=725400 628880 1 180 $X=722920 $Y=628500
X282 2461 2462 1 2 2449 AN2 $T=727880 638960 0 180 $X=725400 $Y=633540
X283 2473 2464 1 2 2461 AN2 $T=730360 638960 1 180 $X=727880 $Y=638580
X284 2496 2486 1 2 2473 AN2 $T=735940 649040 0 180 $X=733460 $Y=643620
X285 2510 2506 1 2 2496 AN2 $T=740900 649040 0 180 $X=738420 $Y=643620
X286 2526 2524 1 2 2502 AN2 $T=744000 638960 1 180 $X=741520 $Y=638580
X287 2535 2527 1 2 2510 AN2 $T=746480 649040 0 180 $X=744000 $Y=643620
X288 600 2540 1 2 2521 AN2 $T=747720 608720 1 180 $X=745240 $Y=608340
X289 2538 2534 1 2 2524 AN2 $T=747720 628880 1 180 $X=745240 $Y=628500
X290 2543 2541 1 2 2534 AN2 $T=748340 618800 1 180 $X=745860 $Y=618420
X291 2551 2552 1 2 2541 AN2 $T=752060 618800 1 180 $X=749580 $Y=618420
X292 607 606 1 2 2540 AN2 $T=754540 608720 1 180 $X=752060 $Y=608340
X293 2580 2576 1 2 2552 AN2 $T=757640 628880 0 180 $X=755160 $Y=623460
X294 2610 2605 1 2 2576 AN2 $T=767560 628880 0 180 $X=765080 $Y=623460
X295 2646 2644 1 2 2605 AN2 $T=779340 628880 0 180 $X=776860 $Y=623460
X296 2655 2630 1 2 2640 AN2 $T=784300 679280 0 180 $X=781820 $Y=673860
X297 2662 2669 1 2 2680 AN2 $T=786160 679280 0 0 $X=786160 $Y=678900
X298 2683 2678 1 2 2644 AN2 $T=789880 618800 1 180 $X=787400 $Y=618420
X299 2725 2717 1 2 2678 AN2 $T=801660 638960 0 180 $X=799180 $Y=633540
X300 2736 2739 1 2 2717 AN2 $T=806000 618800 0 0 $X=806000 $Y=618420
X301 2757 2754 1 2 2739 AN2 $T=814680 618800 1 180 $X=812200 $Y=618420
X302 2751 2764 1 2 2774 AN2 $T=818400 659120 1 0 $X=818400 $Y=653700
X303 2786 2778 1 2 2754 AN2 $T=822740 618800 1 180 $X=820260 $Y=618420
X304 2774 2780 1 2 2814 AN2 $T=827700 659120 0 0 $X=827700 $Y=658740
X305 2812 2806 1 2 2778 AN2 $T=832040 618800 1 180 $X=829560 $Y=618420
X306 2827 2824 1 2 2806 AN2 $T=838860 618800 1 180 $X=836380 $Y=618420
X307 2814 2833 1 2 2840 AN2 $T=839480 659120 1 0 $X=839480 $Y=653700
X308 2851 2848 1 2 2824 AN2 $T=846300 618800 0 180 $X=843820 $Y=613380
X309 2840 2864 1 2 2872 AN2 $T=852500 659120 1 0 $X=852500 $Y=653700
X310 2889 2882 1 2 2848 AN2 $T=858080 618800 0 180 $X=855600 $Y=613380
X311 2872 2873 1 2 2891 AN2 $T=856840 659120 1 0 $X=856840 $Y=653700
X312 2908 2905 1 2 2882 AN2 $T=864900 618800 1 180 $X=862420 $Y=618420
X313 2891 2907 1 2 2900 AN2 $T=865520 659120 0 180 $X=863040 $Y=653700
X314 2900 2901 1 2 2910 AN2 $T=864280 649040 1 0 $X=864280 $Y=643620
X315 2912 748 1 2 743 AN2 $T=868000 608720 1 0 $X=868000 $Y=603300
X316 2925 2920 1 2 2905 AN2 $T=871720 618800 1 180 $X=869240 $Y=618420
X317 2741 2929 1 2 2926 AN2 $T=873580 628880 1 0 $X=873580 $Y=623460
X318 2910 2923 1 2 2940 AN2 $T=873580 649040 1 0 $X=873580 $Y=643620
X319 2803 2929 1 2 2944 AN2 $T=874820 628880 0 0 $X=874820 $Y=628500
X320 2815 2929 1 2 2938 AN2 $T=874820 638960 0 0 $X=874820 $Y=638580
X321 2942 2937 1 2 2920 AN2 $T=877920 618800 1 180 $X=875440 $Y=618420
X322 2743 2929 1 2 2951 AN2 $T=877300 628880 1 0 $X=877300 $Y=623460
X323 2940 2934 1 2 2957 AN2 $T=881640 649040 0 0 $X=881640 $Y=648660
X324 2956 2959 1 2 2937 AN2 $T=884740 638960 0 180 $X=882260 $Y=633540
X325 2964 2939 1 2 2921 AN2 $T=885980 689360 0 180 $X=883500 $Y=683940
X326 2957 2936 1 2 2962 AN2 $T=885360 659120 1 0 $X=885360 $Y=653700
X327 2962 2952 1 2 2961 AN2 $T=887840 659120 0 0 $X=887840 $Y=658740
X328 2961 2954 1 2 2975 AN2 $T=888460 669200 0 0 $X=888460 $Y=668820
X329 2850 774 1 2 2978 AN2 $T=890320 649040 1 0 $X=890320 $Y=643620
X330 2975 2973 1 2 2964 AN2 $T=891560 689360 1 0 $X=891560 $Y=683940
X331 2967 2977 1 2 2992 AN2 $T=895900 618800 0 0 $X=895900 $Y=618420
X332 2990 2992 1 2 3001 AN2 $T=903340 628880 1 0 $X=903340 $Y=623460
X333 3035 3034 1 2 3007 AN2 $T=925040 628880 1 180 $X=922560 $Y=628500
X334 3047 3041 1 2 3034 AN2 $T=930620 628880 1 180 $X=928140 $Y=628500
X335 3064 3063 1 2 3041 AN2 $T=939300 628880 1 180 $X=936820 $Y=628500
X336 3075 3078 1 2 3063 AN2 $T=947360 628880 1 180 $X=944880 $Y=628500
X337 3106 3104 1 2 3078 AN2 $T=957280 628880 1 180 $X=954800 $Y=628500
X338 3123 3124 1 2 3104 AN2 $T=965960 628880 1 180 $X=963480 $Y=628500
X339 3152 3138 1 2 3124 AN2 $T=972780 638960 0 180 $X=970300 $Y=633540
X340 3167 3166 1 2 3138 AN2 $T=985180 638960 0 0 $X=985180 $Y=638580
X341 3186 3189 1 2 3166 AN2 $T=996960 638960 0 180 $X=994480 $Y=633540
X342 3195 3196 1 2 3201 AN2 $T=998820 618800 1 0 $X=998820 $Y=613380
X343 3190 3200 1 2 3199 AN2 $T=1002540 669200 0 180 $X=1000060 $Y=663780
X344 3214 3212 1 2 3189 AN2 $T=1006880 638960 0 180 $X=1004400 $Y=633540
X345 3197 2929 1 2 3225 AN2 $T=1006260 638960 0 0 $X=1006260 $Y=638580
X346 3224 3223 1 2 3212 AN2 $T=1010600 628880 1 180 $X=1008120 $Y=628500
X347 3207 2929 1 2 3232 AN2 $T=1011220 649040 1 0 $X=1011220 $Y=643620
X348 3218 2929 1 2 3235 AN2 $T=1011840 638960 0 0 $X=1011840 $Y=638580
X349 3209 2929 1 2 3234 AN2 $T=1012460 628880 0 0 $X=1012460 $Y=628500
X350 918 913 1 2 3253 AN2 $T=1019280 608720 0 0 $X=1019280 $Y=608340
X351 3296 3291 1 2 3270 AN2 $T=1042220 649040 0 180 $X=1039740 $Y=643620
X352 936 3300 1 2 3226 AN2 $T=1045940 699440 0 180 $X=1043460 $Y=694020
X353 3306 3304 1 2 3291 AN2 $T=1047180 659120 1 180 $X=1044700 $Y=658740
X354 3303 3302 1 2 3307 AN2 $T=1045940 608720 0 0 $X=1045940 $Y=608340
X355 944 3319 1 2 3238 AN2 $T=1054620 699440 0 180 $X=1052140 $Y=694020
X356 3311 3316 1 2 3332 AN2 $T=1052760 638960 0 0 $X=1052760 $Y=638580
X357 3330 3301 1 2 3316 AN2 $T=1056480 649040 1 180 $X=1054000 $Y=648660
X358 3348 3341 1 2 3304 AN2 $T=1062680 659120 1 180 $X=1060200 $Y=658740
X359 951 3355 1 2 3305 AN2 $T=1071360 699440 0 180 $X=1068880 $Y=694020
X360 953 3362 1 2 3292 AN2 $T=1075700 699440 0 180 $X=1073220 $Y=694020
X361 3361 3364 1 2 3367 AN2 $T=1079420 638960 0 0 $X=1079420 $Y=638580
X362 3369 3367 1 2 3341 AN2 $T=1083140 659120 0 180 $X=1080660 $Y=653700
X363 3368 3307 1 2 961 AN2 $T=1081280 618800 1 0 $X=1081280 $Y=613380
X364 958 961 1 2 963 AN2 $T=1085620 608720 0 0 $X=1085620 $Y=608340
X365 2429 2405 1 2 INV6CK $T=711140 628880 1 0 $X=711140 $Y=623460
X366 2440 2402 1 2 INV6CK $T=718580 628880 1 0 $X=718580 $Y=623460
X367 342 270 1 2 INV4CK $T=558000 608720 0 180 $X=554280 $Y=603300
X368 356 2023 1 2 2118 QDBHN $T=577840 618800 0 0 $X=577840 $Y=618420
X369 356 2356 1 2 2344 QDBHN $T=685720 628880 0 180 $X=678280 $Y=623460
X370 356 2397 1 2 2387 QDBHN $T=699980 689360 0 180 $X=692540 $Y=683940
X371 356 338 1 2 2392 QDBHN $T=693160 659120 0 0 $X=693160 $Y=658740
X372 1674 1711 1 2 INV2CK $T=442680 669200 0 0 $X=442680 $Y=668820
X373 1053 1041 1033 1 2 AN2T $T=227540 679280 0 180 $X=223200 $Y=673860
X374 1086 1085 1093 1 2 AN2T $T=238700 628880 0 0 $X=238700 $Y=628500
X375 1082 1078 1111 1 2 AN2T $T=241180 659120 0 0 $X=241180 $Y=658740
X376 1116 1093 1124 1 2 AN2T $T=251100 628880 1 0 $X=251100 $Y=623460
X377 1107 1111 1128 1 2 AN2T $T=251100 669200 1 0 $X=251100 $Y=663780
X378 1147 1141 1108 1 2 AN2T $T=261640 628880 1 180 $X=257300 $Y=628500
X379 1142 1143 1119 1 2 AN2T $T=261640 689360 0 180 $X=257300 $Y=683940
X380 1144 1128 1165 1 2 AN2T $T=262880 669200 1 0 $X=262880 $Y=663780
X381 1181 1165 1172 1 2 AN2T $T=273420 669200 0 180 $X=269080 $Y=663780
X382 1194 1196 1207 1 2 AN2T $T=280240 649040 0 0 $X=280240 $Y=648660
X383 1216 1207 1209 1 2 AN2T $T=288920 659120 0 180 $X=284580 $Y=653700
X384 1247 83 1036 1 2 AN2T $T=295740 669200 1 180 $X=291400 $Y=668820
X385 1275 1266 1217 1 2 AN2T $T=303180 638960 0 180 $X=298840 $Y=633540
X386 1284 1278 1297 1 2 AN2T $T=306900 649040 0 0 $X=306900 $Y=648660
X387 1318 1298 1340 1 2 AN2T $T=320540 608720 0 0 $X=320540 $Y=608340
X388 1366 1358 1381 1 2 AN2T $T=334180 638960 0 0 $X=334180 $Y=638580
X389 1635 1634 1645 1 2 AN2T $T=424700 689360 1 0 $X=424700 $Y=683940
X390 2081 356 1993 1 2 AN2T $T=569780 618800 0 0 $X=569780 $Y=618420
X391 2347 356 2283 1 2 AN2T $T=677040 628880 0 180 $X=672700 $Y=623460
X392 702 529 2823 1 2 AN2T $T=834520 659120 0 0 $X=834520 $Y=658740
X393 721 2430 2821 1 2 AN2T $T=848780 638960 1 180 $X=844440 $Y=638580
X394 2995 3001 2974 1 2 AN2T $T=903960 638960 1 0 $X=903960 $Y=633540
X395 3248 3246 3264 1 2 AN2T $T=1025480 638960 1 0 $X=1025480 $Y=633540
X396 3273 3270 3246 1 2 AN2T $T=1032920 649040 0 180 $X=1028580 $Y=643620
X397 3265 3264 3223 1 2 AN2T $T=1029820 628880 0 0 $X=1029820 $Y=628500
X398 3278 3281 3290 1 2 AN2T $T=1037880 608720 0 0 $X=1037880 $Y=608340
X399 3315 3332 3364 1 2 AN2T $T=1063300 628880 0 0 $X=1063300 $Y=628500
X400 271 1 2 279 DELC $T=474300 608720 0 0 $X=474300 $Y=608340
X401 1917 1 2 1936 DELC $T=507160 608720 1 0 $X=507160 $Y=603300
X402 1960 1 2 1974 DELC $T=518320 618800 0 0 $X=518320 $Y=618420
X403 1970 1 2 1981 DELC $T=520800 649040 0 0 $X=520800 $Y=648660
X404 1976 1 2 1985 DELC $T=523280 618800 0 0 $X=523280 $Y=618420
X405 1982 1 2 1989 DELC $T=525760 649040 0 0 $X=525760 $Y=648660
X406 1820 1 2 1996 DELC $T=528240 618800 0 0 $X=528240 $Y=618420
X407 1991 1 2 1999 DELC $T=530720 659120 1 0 $X=530720 $Y=653700
X408 1992 1 2 1998 DELC $T=531960 628880 0 0 $X=531960 $Y=628500
X409 1997 1 2 2003 DELC $T=533200 689360 1 0 $X=533200 $Y=683940
X410 2000 1 2 2008 DELC $T=535680 659120 1 0 $X=535680 $Y=653700
X411 2001 1 2 2002 DELC $T=536920 628880 1 0 $X=536920 $Y=623460
X412 2005 1 2 2024 DELC $T=543120 628880 0 0 $X=543120 $Y=628500
X413 2013 1 2 2026 DELC $T=544360 608720 0 0 $X=544360 $Y=608340
X414 2021 1 2 2018 DELC $T=546840 638960 1 0 $X=546840 $Y=633540
X415 2010 1 2 2027 DELC $T=546840 689360 0 0 $X=546840 $Y=688980
X416 2022 1 2 2035 DELC $T=548080 679280 0 0 $X=548080 $Y=678900
X417 2011 1 2 2044 DELC $T=549320 618800 1 0 $X=549320 $Y=613380
X418 2037 1 2 2053 DELC $T=553040 638960 1 0 $X=553040 $Y=633540
X419 2019 1 2 2040 DELC $T=554280 669200 0 0 $X=554280 $Y=668820
X420 2047 1 2 2052 DELC $T=556760 679280 0 0 $X=556760 $Y=678900
X421 2048 1 2 2062 DELC $T=558620 628880 1 0 $X=558620 $Y=623460
X422 2050 1 2 2065 DELC $T=559240 608720 1 0 $X=559240 $Y=603300
X423 2006 1 2 2058 DELC $T=563580 628880 1 0 $X=563580 $Y=623460
X424 2061 1 2 2075 DELC $T=563580 669200 0 0 $X=563580 $Y=668820
X425 2045 1 2 2082 DELC $T=565440 638960 0 0 $X=565440 $Y=638580
X426 2080 1 2 2092 DELC $T=569780 608720 0 0 $X=569780 $Y=608340
X427 2015 1 2 2090 DELC $T=569780 628880 1 0 $X=569780 $Y=623460
X428 2069 1 2 2089 DELC $T=571020 649040 0 0 $X=571020 $Y=648660
X429 2056 1 2 2104 DELC $T=572880 628880 0 0 $X=572880 $Y=628500
X430 2084 1 2 2105 DELC $T=573500 669200 1 0 $X=573500 $Y=663780
X431 2088 1 2 2116 DELC $T=577840 628880 0 0 $X=577840 $Y=628500
X432 367 1 2 372 DELC $T=580320 608720 0 0 $X=580320 $Y=608340
X433 2112 1 2 375 DELC $T=582180 689360 0 0 $X=582180 $Y=688980
X434 2118 1 2 2081 DELC $T=582800 628880 0 0 $X=582800 $Y=628500
X435 2091 1 2 2095 DELC $T=587760 649040 0 0 $X=587760 $Y=648660
X436 377 1 2 2142 DELC $T=588380 628880 1 0 $X=588380 $Y=623460
X437 385 1 2 390 DELC $T=593340 628880 1 0 $X=593340 $Y=623460
X438 391 1 2 398 DELC $T=598300 628880 1 0 $X=598300 $Y=623460
X439 2025 1 2 2196 DELC $T=608220 618800 0 0 $X=608220 $Y=618420
X440 410 1 2 418 DELC $T=613180 618800 1 0 $X=613180 $Y=613380
X441 419 1 2 429 DELC $T=618140 618800 1 0 $X=618140 $Y=613380
X442 2218 1 2 438 DELC $T=623100 699440 1 0 $X=623100 $Y=694020
X443 1978 1 2 2235 DELC $T=624960 618800 1 0 $X=624960 $Y=613380
X444 2239 1 2 2249 DELC $T=629920 618800 1 0 $X=629920 $Y=613380
X445 2291 1 2 2300 DELC $T=655340 659120 1 0 $X=655340 $Y=653700
X446 2271 1 2 2293 DELC $T=659060 628880 1 0 $X=659060 $Y=623460
X447 2306 1 2 489 DELC $T=660300 689360 1 0 $X=660300 $Y=683940
X448 483 1 2 2320 DELC $T=661540 679280 1 0 $X=661540 $Y=673860
X449 2316 1 2 2315 DELC $T=664640 649040 1 0 $X=664640 $Y=643620
X450 2332 1 2 503 DELC $T=670220 638960 0 0 $X=670220 $Y=638580
X451 2344 1 2 2347 DELC $T=674560 618800 1 0 $X=674560 $Y=613380
X452 2354 1 2 2346 DELC $T=682620 649040 1 0 $X=682620 $Y=643620
X453 2358 1 2 499 DELC $T=689440 638960 0 0 $X=689440 $Y=638580
X454 2389 1 2 2370 DELC $T=694400 608720 0 0 $X=694400 $Y=608340
X455 2387 1 2 2384 DELC $T=694400 679280 0 0 $X=694400 $Y=678900
X456 2392 1 2 2369 DELC $T=695020 649040 0 0 $X=695020 $Y=648660
X457 521 1 2 2375 DELC $T=695020 669200 0 0 $X=695020 $Y=668820
X458 2304 1 2 331 DELC $T=698120 608720 1 0 $X=698120 $Y=603300
X459 2366 1 2 2399 DELC $T=699980 649040 0 0 $X=699980 $Y=648660
X460 2381 1 2 2367 DELC $T=699980 669200 0 0 $X=699980 $Y=668820
X461 522 1 2 2378 DELC $T=699980 689360 1 0 $X=699980 $Y=683940
X462 2386 1 2 2385 DELC $T=703700 659120 1 0 $X=703700 $Y=653700
X463 2418 1 2 2417 DELC $T=704940 649040 0 0 $X=704940 $Y=648660
X464 2410 1 2 2414 DELC $T=708660 659120 1 0 $X=708660 $Y=653700
X465 2426 1 2 2425 DELC $T=709280 638960 1 0 $X=709280 $Y=633540
X466 2436 1 2 544 DELC $T=713000 649040 0 0 $X=713000 $Y=648660
X467 2453 1 2 570 DELC $T=725400 649040 0 0 $X=725400 $Y=648660
X468 2484 1 2 580 DELC $T=732220 679280 1 0 $X=732220 $Y=673860
X469 2427 1 2 585 DELC $T=733460 659120 1 0 $X=733460 $Y=653700
X470 811 1 2 816 DELC $T=912020 689360 1 0 $X=912020 $Y=683940
X471 1033 2 1037 1 INV1S $T=223200 659120 1 0 $X=223200 $Y=653700
X472 8 2 9 1 INV1S $T=224440 628880 1 0 $X=224440 $Y=623460
X473 1045 2 1068 1 INV1S $T=231880 638960 1 0 $X=231880 $Y=633540
X474 1069 2 1041 1 INV1S $T=237460 679280 1 0 $X=237460 $Y=673860
X475 1079 2 1082 1 INV1S $T=242420 659120 0 180 $X=241180 $Y=653700
X476 1098 2 1086 1 INV1S $T=244280 628880 1 180 $X=243040 $Y=628500
X477 1108 2 1090 1 INV1S $T=244900 638960 0 180 $X=243660 $Y=633540
X478 1109 2 1107 1 INV1S $T=248000 669200 0 180 $X=246760 $Y=663780
X479 1120 2 1114 1 INV1S $T=252340 679280 1 180 $X=251100 $Y=678900
X480 1127 2 1116 1 INV1S $T=256680 618800 1 180 $X=255440 $Y=618420
X481 1152 2 1138 1 INV1S $T=260400 618800 1 180 $X=259160 $Y=618420
X482 1139 2 1148 1 INV1S $T=259780 638960 0 0 $X=259780 $Y=638580
X483 1151 2 1153 1 INV1S $T=264740 638960 1 180 $X=263500 $Y=638580
X484 1155 2 1144 1 INV1S $T=264740 659120 1 180 $X=263500 $Y=658740
X485 10 2 1081 1 INV1S $T=267220 649040 1 180 $X=265980 $Y=648660
X486 54 2 49 1 INV1S $T=270320 699440 0 180 $X=269080 $Y=694020
X487 1157 2 1171 1 INV1S $T=275900 618800 1 180 $X=274660 $Y=618420
X488 1167 2 1182 1 INV1S $T=274660 659120 1 0 $X=274660 $Y=653700
X489 1169 2 1181 1 INV1S $T=275900 669200 1 180 $X=274660 $Y=668820
X490 1190 2 1203 1 INV1S $T=277760 608720 0 0 $X=277760 $Y=608340
X491 1185 2 1187 1 INV1S $T=277760 618800 1 0 $X=277760 $Y=613380
X492 81 2 44 1 INV1S $T=284580 689360 1 180 $X=283340 $Y=688980
X493 1212 2 1194 1 INV1S $T=285820 649040 1 180 $X=284580 $Y=648660
X494 1215 2 1188 1 INV1S $T=286440 628880 1 180 $X=285200 $Y=628500
X495 63 2 1218 1 INV1S $T=286440 628880 0 0 $X=286440 $Y=628500
X496 1204 2 1222 1 INV1S $T=288300 628880 1 0 $X=288300 $Y=623460
X497 78 2 76 1 INV1S $T=289540 638960 1 180 $X=288300 $Y=638580
X498 1222 2 1232 1 INV1S $T=291400 628880 1 0 $X=291400 $Y=623460
X499 1218 2 1233 1 INV1S $T=291400 628880 0 0 $X=291400 $Y=628500
X500 1231 2 1216 1 INV1S $T=292640 649040 0 180 $X=291400 $Y=643620
X501 1232 2 1238 1 INV1S $T=292640 628880 1 0 $X=292640 $Y=623460
X502 1233 2 1236 1 INV1S $T=292640 628880 0 0 $X=292640 $Y=628500
X503 87 2 75 1 INV1S $T=293880 689360 1 180 $X=292640 $Y=688980
X504 1170 2 1243 1 INV1S $T=293260 679280 1 0 $X=293260 $Y=673860
X505 88 2 86 1 INV1S $T=295740 649040 0 180 $X=294500 $Y=643620
X506 1180 2 1249 1 INV1S $T=295120 628880 0 0 $X=295120 $Y=628500
X507 1218 2 1257 1 INV1S $T=296360 628880 0 0 $X=296360 $Y=628500
X508 1253 2 1261 1 INV1S $T=296360 659120 1 0 $X=296360 $Y=653700
X509 39 2 90 1 INV1S $T=296360 689360 0 0 $X=296360 $Y=688980
X510 92 2 1235 1 INV1S $T=298840 608720 0 180 $X=297600 $Y=603300
X511 93 2 1239 1 INV1S $T=300080 638960 1 180 $X=298840 $Y=638580
X512 70 2 94 1 INV1S $T=300080 608720 1 0 $X=300080 $Y=603300
X513 95 2 1285 1 INV1S $T=301320 608720 0 0 $X=301320 $Y=608340
X514 1189 2 1260 1 INV1S $T=302560 618800 1 180 $X=301320 $Y=618420
X515 1177 2 1271 1 INV1S $T=301320 669200 1 0 $X=301320 $Y=663780
X516 99 2 1266 1 INV1S $T=304420 638960 1 180 $X=303180 $Y=638580
X517 1286 2 1284 1 INV1S $T=306900 649040 1 180 $X=305660 $Y=648660
X518 73 2 58 1 INV1S $T=305660 699440 1 0 $X=305660 $Y=694020
X519 96 2 1267 1 INV1S $T=306900 679280 1 0 $X=306900 $Y=673860
X520 1267 2 1276 1 INV1S $T=309380 679280 0 180 $X=308140 $Y=673860
X521 106 2 1309 1 INV1S $T=313100 679280 0 0 $X=313100 $Y=678900
X522 106 2 1313 1 INV1S $T=314340 679280 0 0 $X=314340 $Y=678900
X523 1214 2 1223 1 INV1S $T=314960 638960 0 0 $X=314960 $Y=638580
X524 106 2 1323 1 INV1S $T=315580 679280 0 0 $X=315580 $Y=678900
X525 110 2 111 1 INV1S $T=316820 649040 1 0 $X=316820 $Y=643620
X526 1305 2 1315 1 INV1S $T=317440 649040 0 0 $X=317440 $Y=648660
X527 1303 2 1318 1 INV1S $T=318060 608720 0 0 $X=318060 $Y=608340
X528 66 2 83 1 INV1S $T=318680 699440 1 0 $X=318680 $Y=694020
X529 1292 2 119 1 INV1S $T=321160 699440 0 180 $X=319920 $Y=694020
X530 1282 2 1334 1 INV1S $T=323640 679280 0 180 $X=322400 $Y=673860
X531 1344 2 1348 1 INV1S $T=324880 608720 0 0 $X=324880 $Y=608340
X532 1333 2 1337 1 INV1S $T=325500 649040 1 0 $X=325500 $Y=643620
X533 135 2 1359 1 INV1S $T=329220 608720 1 0 $X=329220 $Y=603300
X534 1359 2 138 1 INV1S $T=330460 608720 1 0 $X=330460 $Y=603300
X535 1354 2 1366 1 INV1S $T=331080 649040 1 0 $X=331080 $Y=643620
X536 1366 2 1368 1 INV1S $T=332320 649040 1 0 $X=332320 $Y=643620
X537 1292 2 141 1 INV1S $T=333560 689360 0 180 $X=332320 $Y=683940
X538 144 2 145 1 INV1S $T=334180 608720 1 0 $X=334180 $Y=603300
X539 1292 2 148 1 INV1S $T=338520 689360 0 0 $X=338520 $Y=688980
X540 124 2 150 1 INV1S $T=339140 638960 0 0 $X=339140 $Y=638580
X541 1397 2 1385 1 INV1S $T=346580 608720 1 180 $X=345340 $Y=608340
X542 24 2 70 1 INV1S $T=354640 608720 1 0 $X=354640 $Y=603300
X543 165 2 1442 1 INV1S $T=360840 608720 1 0 $X=360840 $Y=603300
X544 1453 2 1465 1 INV1S $T=369520 669200 1 0 $X=369520 $Y=663780
X545 1460 2 1468 1 INV1S $T=369520 699440 1 0 $X=369520 $Y=694020
X546 1466 2 1478 1 INV1S $T=372620 679280 0 0 $X=372620 $Y=678900
X547 1450 2 1488 1 INV1S $T=374480 669200 1 0 $X=374480 $Y=663780
X548 1480 2 1483 1 INV1S $T=379440 679280 0 180 $X=378200 $Y=673860
X549 1471 2 1496 1 INV1S $T=380060 608720 1 0 $X=380060 $Y=603300
X550 198 2 194 1 INV1S $T=381300 628880 1 180 $X=380060 $Y=628500
X551 1470 2 1498 1 INV1S $T=380680 669200 0 0 $X=380680 $Y=668820
X552 199 2 197 1 INV1S $T=382540 628880 1 0 $X=382540 $Y=623460
X553 1505 2 1508 1 INV1S $T=384400 638960 0 0 $X=384400 $Y=638580
X554 1214 2 1518 1 INV1S $T=388120 638960 0 0 $X=388120 $Y=638580
X555 1507 2 1534 1 INV1S $T=391220 608720 0 0 $X=391220 $Y=608340
X556 203 2 1533 1 INV1S $T=391220 689360 1 0 $X=391220 $Y=683940
X557 1456 2 1525 1 INV1S $T=391840 669200 1 0 $X=391840 $Y=663780
X558 1537 2 1531 1 INV1S $T=393700 638960 0 180 $X=392460 $Y=633540
X559 1533 2 1551 1 INV1S $T=392460 689360 1 0 $X=392460 $Y=683940
X560 1541 2 1537 1 INV1S $T=394940 638960 0 180 $X=393700 $Y=633540
X561 10 2 209 1 INV1S $T=394940 669200 0 0 $X=394940 $Y=668820
X562 208 2 1544 1 INV1S $T=394940 689360 0 0 $X=394940 $Y=688980
X563 202 2 1539 1 INV1S $T=396180 608720 0 0 $X=396180 $Y=608340
X564 174 2 1555 1 INV1S $T=398660 608720 0 0 $X=398660 $Y=608340
X565 1494 2 1565 1 INV1S $T=401760 638960 1 0 $X=401760 $Y=633540
X566 1529 2 1582 1 INV1S $T=403000 669200 0 0 $X=403000 $Y=668820
X567 184 2 1577 1 INV1S $T=404860 608720 1 0 $X=404860 $Y=603300
X568 1522 2 1578 1 INV1S $T=404860 608720 0 0 $X=404860 $Y=608340
X569 1497 2 1586 1 INV1S $T=407960 638960 1 0 $X=407960 $Y=633540
X570 1547 2 1588 1 INV1S $T=408580 628880 1 0 $X=408580 $Y=623460
X571 1556 2 1598 1 INV1S $T=409820 638960 1 0 $X=409820 $Y=633540
X572 1527 2 1607 1 INV1S $T=414160 618800 1 0 $X=414160 $Y=613380
X573 195 2 1613 1 INV1S $T=414780 608720 0 0 $X=414780 $Y=608340
X574 1566 2 1623 1 INV1S $T=421600 638960 0 0 $X=421600 $Y=638580
X575 1633 2 1635 1 INV1S $T=427180 679280 0 180 $X=425940 $Y=673860
X576 1637 2 1642 1 INV1S $T=425940 699440 1 0 $X=425940 $Y=694020
X577 200 2 1640 1 INV1S $T=428420 618800 1 0 $X=428420 $Y=613380
X578 1585 2 1654 1 INV1S $T=428420 638960 1 0 $X=428420 $Y=633540
X579 1638 2 1644 1 INV1S $T=430280 679280 0 180 $X=429040 $Y=673860
X580 1639 2 1647 1 INV1S $T=429040 689360 1 0 $X=429040 $Y=683940
X581 1580 2 1652 1 INV1S $T=433380 628880 0 180 $X=432140 $Y=623460
X582 1659 2 1669 1 INV1S $T=432140 659120 0 0 $X=432140 $Y=658740
X583 1568 2 1697 1 INV1S $T=434000 618800 1 0 $X=434000 $Y=613380
X584 1668 2 1671 1 INV1S $T=434000 649040 1 0 $X=434000 $Y=643620
X585 1660 2 1670 1 INV1S $T=435240 669200 1 180 $X=434000 $Y=668820
X586 1663 2 1675 1 INV1S $T=435860 628880 1 0 $X=435860 $Y=623460
X587 1679 2 1685 1 INV1S $T=440200 649040 1 180 $X=438960 $Y=648660
X588 1694 2 1688 1 INV1S $T=440200 689360 0 180 $X=438960 $Y=683940
X589 244 2 246 1 INV1S $T=442060 699440 1 0 $X=442060 $Y=694020
X590 1651 2 1704 1 INV1S $T=443300 638960 1 0 $X=443300 $Y=633540
X591 1646 2 1719 1 INV1S $T=445160 608720 0 0 $X=445160 $Y=608340
X592 1727 2 1720 1 INV1S $T=447640 679280 0 180 $X=446400 $Y=673860
X593 1716 2 1712 1 INV1S $T=448260 679280 1 180 $X=447020 $Y=678900
X594 1734 2 1724 1 INV1S $T=448880 679280 0 180 $X=447640 $Y=673860
X595 1676 2 1736 1 INV1S $T=448260 679280 0 0 $X=448260 $Y=678900
X596 1692 2 1740 1 INV1S $T=451360 669200 0 0 $X=451360 $Y=668820
X597 1794 2 1776 1 INV1S $T=474300 628880 0 180 $X=473060 $Y=623460
X598 1798 2 1801 1 INV1S $T=477400 679280 1 0 $X=477400 $Y=673860
X599 284 2 1806 1 INV1S $T=479880 699440 1 0 $X=479880 $Y=694020
X600 1816 2 1818 1 INV1S $T=485460 689360 1 180 $X=484220 $Y=688980
X601 288 2 290 1 INV1S $T=486700 608720 0 180 $X=485460 $Y=603300
X602 1812 2 1825 1 INV1S $T=486080 679280 0 0 $X=486080 $Y=678900
X603 288 2 291 1 INV1S $T=486700 608720 1 0 $X=486700 $Y=603300
X604 1823 2 1819 1 INV1S $T=486700 628880 1 0 $X=486700 $Y=623460
X605 1828 2 1829 1 INV1S $T=486700 649040 1 0 $X=486700 $Y=643620
X606 1827 2 1831 1 INV1S $T=487320 638960 0 0 $X=487320 $Y=638580
X607 1832 2 1837 1 INV1S $T=487940 649040 0 0 $X=487940 $Y=648660
X608 1817 2 1838 1 INV1S $T=489800 669200 1 180 $X=488560 $Y=668820
X609 1833 2 1830 1 INV1S $T=492280 659120 0 180 $X=491040 $Y=653700
X610 1842 2 1878 1 INV1S $T=495380 669200 1 0 $X=495380 $Y=663780
X611 1906 2 1898 1 INV1S $T=504680 659120 1 180 $X=503440 $Y=658740
X612 1849 2 1922 1 INV1S $T=508400 689360 1 0 $X=508400 $Y=683940
X613 1946 2 1949 1 INV1S $T=515220 669200 1 0 $X=515220 $Y=663780
X614 1961 2 1963 1 INV1S $T=518320 689360 0 0 $X=518320 $Y=688980
X615 313 2 286 1 INV1S $T=523900 628880 0 180 $X=522660 $Y=623460
X616 312 2 311 1 INV1S $T=525760 608720 0 180 $X=524520 $Y=603300
X617 1957 2 1939 1 INV1S $T=526380 679280 0 180 $X=525140 $Y=673860
X618 312 2 316 1 INV1S $T=525760 608720 1 0 $X=525760 $Y=603300
X619 312 2 318 1 INV1S $T=527000 608720 1 0 $X=527000 $Y=603300
X620 1983 2 1924 1 INV1S $T=529480 679280 0 180 $X=528240 $Y=673860
X621 1971 2 1980 1 INV1S $T=531340 689360 1 180 $X=530100 $Y=688980
X622 329 2 2012 1 INV1S $T=546220 669200 1 180 $X=544980 $Y=668820
X623 299 2 1882 1 INV1S $T=544980 699440 1 0 $X=544980 $Y=694020
X624 2028 2 2014 1 INV1S $T=549320 679280 0 180 $X=548080 $Y=673860
X625 333 2 2039 1 INV1S $T=552420 669200 1 0 $X=552420 $Y=663780
X626 347 2 2063 1 INV1S $T=563580 659120 0 0 $X=563580 $Y=658740
X627 2042 2 2064 1 INV1S $T=567300 679280 0 180 $X=566060 $Y=673860
X628 2073 2 2076 1 INV1S $T=567300 659120 0 0 $X=567300 $Y=658740
X629 2055 2 2066 1 INV1S $T=568540 679280 1 0 $X=568540 $Y=673860
X630 2070 2 2083 1 INV1S $T=569780 649040 0 0 $X=569780 $Y=648660
X631 2093 2 2100 1 INV1S $T=574740 659120 0 0 $X=574740 $Y=658740
X632 2086 2 2108 1 INV1S $T=577840 649040 1 0 $X=577840 $Y=643620
X633 2113 2 2117 1 INV1S $T=580940 659120 0 0 $X=580940 $Y=658740
X634 2131 2 2134 1 INV1S $T=587760 659120 0 0 $X=587760 $Y=658740
X635 380 2 378 1 INV1S $T=589000 689360 1 180 $X=587760 $Y=688980
X636 2129 2 2128 1 INV1S $T=588380 649040 1 0 $X=588380 $Y=643620
X637 2092 2 2135 1 INV1S $T=593340 618800 0 180 $X=592100 $Y=613380
X638 2132 2 2151 1 INV1S $T=593960 659120 0 0 $X=593960 $Y=658740
X639 2145 2 2155 1 INV1S $T=596440 649040 1 0 $X=596440 $Y=643620
X640 392 2 2162 1 INV1S $T=599540 659120 1 0 $X=599540 $Y=653700
X641 396 2 2163 1 INV1S $T=600780 669200 1 0 $X=600780 $Y=663780
X642 2173 2 2179 1 INV1S $T=606360 638960 0 0 $X=606360 $Y=638580
X643 2159 2 2182 1 INV1S $T=608220 669200 1 0 $X=608220 $Y=663780
X644 407 2 2190 1 INV1S $T=610080 649040 1 0 $X=610080 $Y=643620
X645 2133 2 2195 1 INV1S $T=611940 618800 1 0 $X=611940 $Y=613380
X646 411 2 2206 1 INV1S $T=615040 669200 1 0 $X=615040 $Y=663780
X647 2204 2 2207 1 INV1S $T=619380 638960 1 0 $X=619380 $Y=633540
X648 425 2 2210 1 INV1S $T=620000 649040 1 0 $X=620000 $Y=643620
X649 2136 2 2225 1 INV1S $T=624340 649040 1 0 $X=624340 $Y=643620
X650 434 2 2232 1 INV1S $T=626820 659120 1 0 $X=626820 $Y=653700
X651 2233 2 2217 1 INV1S $T=629300 638960 0 180 $X=628060 $Y=633540
X652 2125 2 2246 1 INV1S $T=631780 649040 1 0 $X=631780 $Y=643620
X653 2205 2 2244 1 INV1S $T=633640 628880 0 0 $X=633640 $Y=628500
X654 2180 2 2264 1 INV1S $T=638600 649040 1 0 $X=638600 $Y=643620
X655 452 2 2266 1 INV1S $T=643560 659120 0 180 $X=642320 $Y=653700
X656 2267 2 2263 1 INV1S $T=644180 628880 1 180 $X=642940 $Y=628500
X657 2276 2 2278 1 INV1S $T=645420 659120 0 0 $X=645420 $Y=658740
X658 2171 2 2280 1 INV1S $T=652240 649040 1 0 $X=652240 $Y=643620
X659 2193 2 2292 1 INV1S $T=654100 669200 0 0 $X=654100 $Y=668820
X660 2300 2 476 1 INV1S $T=659060 659120 1 180 $X=657820 $Y=658740
X661 480 2 2243 1 INV1S $T=660300 669200 0 180 $X=659060 $Y=663780
X662 2315 2 484 1 INV1S $T=664020 669200 1 180 $X=662780 $Y=668820
X663 477 2 488 1 INV1S $T=664640 608720 1 180 $X=663400 $Y=608340
X664 479 2 485 1 INV1S $T=675180 649040 0 0 $X=675180 $Y=648660
X665 467 2 2353 1 INV1S $T=678900 699440 1 0 $X=678900 $Y=694020
X666 503 2 494 1 INV1S $T=680760 649040 1 180 $X=679520 $Y=648660
X667 2346 2 2335 1 INV1S $T=680140 679280 1 0 $X=680140 $Y=673860
X668 471 2 487 1 INV1S $T=689440 638960 1 180 $X=688200 $Y=638580
X669 513 2 519 1 INV1S $T=692540 618800 1 180 $X=691300 $Y=618420
X670 2382 2 2365 1 INV1S $T=692540 628880 1 180 $X=691300 $Y=628500
X671 517 2 2390 1 INV1S $T=695640 638960 0 180 $X=694400 $Y=633540
X672 518 2 2394 1 INV1S $T=696260 618800 0 0 $X=696260 $Y=618420
X673 2398 2 2391 1 INV1S $T=698740 618800 1 180 $X=697500 $Y=618420
X674 2400 2 524 1 INV1S $T=698740 628880 0 180 $X=697500 $Y=623460
X675 525 2 2403 1 INV1S $T=697500 679280 1 0 $X=697500 $Y=673860
X676 502 2 526 1 INV1S $T=698120 699440 1 0 $X=698120 $Y=694020
X677 2405 2 2406 1 INV1S $T=704320 618800 0 0 $X=704320 $Y=618420
X678 530 2 2419 1 INV1S $T=705560 689360 1 0 $X=705560 $Y=683940
X679 536 2 2422 1 INV1S $T=711760 669200 1 180 $X=710520 $Y=668820
X680 543 2 2442 1 INV1S $T=717960 649040 0 0 $X=717960 $Y=648660
X681 551 2 2450 1 INV1S $T=720440 628880 0 0 $X=720440 $Y=628500
X682 554 2 2432 1 INV1S $T=721680 669200 0 180 $X=720440 $Y=663780
X683 563 2 2464 1 INV1S $T=724780 649040 1 0 $X=724780 $Y=643620
X684 559 2 2462 1 INV1S $T=726020 638960 0 0 $X=726020 $Y=638580
X685 573 2 2486 1 INV1S $T=732220 649040 1 0 $X=732220 $Y=643620
X686 507 2 2373 1 INV1S $T=736560 628880 1 0 $X=736560 $Y=623460
X687 2501 2 2516 1 INV1S $T=739660 638960 1 0 $X=739660 $Y=633540
X688 2514 2 2501 1 INV1S $T=742140 638960 0 180 $X=740900 $Y=633540
X689 592 2 2506 1 INV1S $T=742760 649040 0 180 $X=741520 $Y=643620
X690 598 2 2515 1 INV1S $T=744000 608720 0 180 $X=742760 $Y=603300
X691 595 2 2527 1 INV1S $T=742760 649040 1 0 $X=742760 $Y=643620
X692 2533 2 2526 1 INV1S $T=744620 638960 0 0 $X=744620 $Y=638580
X693 602 2 2498 1 INV1S $T=745860 699440 0 180 $X=744620 $Y=694020
X694 2513 2 2538 1 INV1S $T=748340 628880 0 180 $X=747100 $Y=623460
X695 2546 2 2542 1 INV1S $T=748960 679280 1 180 $X=747720 $Y=678900
X696 2522 2 2543 1 INV1S $T=748340 618800 0 0 $X=748340 $Y=618420
X697 601 2 2559 1 INV1S $T=751440 649040 1 0 $X=751440 $Y=643620
X698 2560 2 2551 1 INV1S $T=753300 618800 1 180 $X=752060 $Y=618420
X699 603 2 2567 1 INV1S $T=753920 649040 1 0 $X=753920 $Y=643620
X700 2570 2 2561 1 INV1S $T=761360 679280 0 180 $X=760120 $Y=673860
X701 610 2 2532 1 INV1S $T=761360 689360 0 180 $X=760120 $Y=683940
X702 2572 2 2580 1 INV1S $T=761980 628880 1 180 $X=760740 $Y=628500
X703 2531 2 2599 1 INV1S $T=763840 689360 1 0 $X=763840 $Y=683940
X704 2556 2 2612 1 INV1S $T=766940 679280 0 0 $X=766940 $Y=678900
X705 599 2 623 1 INV1S $T=768800 699440 0 180 $X=767560 $Y=694020
X706 2609 2 2610 1 INV1S $T=775000 628880 0 180 $X=773760 $Y=623460
X707 2614 2 2619 1 INV1S $T=775620 669200 1 180 $X=774380 $Y=668820
X708 2655 2 2659 1 INV1S $T=780580 659120 1 0 $X=780580 $Y=653700
X709 2651 2 2646 1 INV1S $T=782440 618800 1 180 $X=781200 $Y=618420
X710 2662 2 2660 1 INV1S $T=783680 669200 0 180 $X=782440 $Y=663780
X711 2630 2 2663 1 INV1S $T=784920 669200 0 0 $X=784920 $Y=668820
X712 2669 2 2671 1 INV1S $T=784920 679280 1 0 $X=784920 $Y=673860
X713 2677 2 2683 1 INV1S $T=791120 618800 1 180 $X=789880 $Y=618420
X714 2689 2 2693 1 INV1S $T=792360 669200 0 0 $X=792360 $Y=668820
X715 667 2 2726 1 INV1S $T=800420 649040 0 0 $X=800420 $Y=648660
X716 2721 2 2725 1 INV1S $T=802900 628880 0 180 $X=801660 $Y=623460
X717 2728 2 2736 1 INV1S $T=803520 618800 0 0 $X=803520 $Y=618420
X718 2722 2 2731 1 INV1S $T=803520 679280 1 0 $X=803520 $Y=673860
X719 675 2 2729 1 INV1S $T=809720 649040 1 180 $X=808480 $Y=648660
X720 2755 2 2757 1 INV1S $T=815300 628880 1 0 $X=815300 $Y=623460
X721 681 2 2764 1 INV1S $T=815300 649040 1 0 $X=815300 $Y=643620
X722 2765 2 2752 1 INV1S $T=817160 679280 0 0 $X=817160 $Y=678900
X723 2788 2 2776 1 INV1S $T=823360 689360 0 180 $X=822120 $Y=683940
X724 2785 2 2786 1 INV1S $T=824600 628880 0 180 $X=823360 $Y=623460
X725 689 2 2780 1 INV1S $T=826460 649040 0 0 $X=826460 $Y=648660
X726 693 2 694 1 INV1S $T=828940 608720 0 0 $X=828940 $Y=608340
X727 629 2 2817 1 INV1S $T=833900 608720 1 0 $X=833900 $Y=603300
X728 2804 2 2812 1 INV1S $T=835140 618800 1 180 $X=833900 $Y=618420
X729 704 2 670 1 INV1S $T=835140 689360 1 180 $X=833900 $Y=688980
X730 2799 2 2820 1 INV1S $T=837000 628880 1 180 $X=835760 $Y=628500
X731 707 2 708 1 INV1S $T=838240 608720 0 0 $X=838240 $Y=608340
X732 709 2 2833 1 INV1S $T=838860 659120 0 0 $X=838860 $Y=658740
X733 2713 2 2813 1 INV1S $T=838860 679280 1 0 $X=838860 $Y=673860
X734 699 2 679 1 INV1S $T=838860 689360 0 0 $X=838860 $Y=688980
X735 711 2 2837 1 INV1S $T=840100 689360 0 0 $X=840100 $Y=688980
X736 2819 2 2827 1 INV1S $T=841960 618800 1 180 $X=840720 $Y=618420
X737 698 2 705 1 INV1S $T=843820 699440 0 180 $X=842580 $Y=694020
X738 615 2 2847 1 INV1S $T=846920 608720 1 180 $X=845680 $Y=608340
X739 717 2 672 1 INV1S $T=846920 699440 0 180 $X=845680 $Y=694020
X740 2857 2 2851 1 INV1S $T=848780 618800 0 180 $X=847540 $Y=613380
X741 720 2 2860 1 INV1S $T=848160 679280 1 0 $X=848160 $Y=673860
X742 719 2 2861 1 INV1S $T=848780 699440 1 0 $X=848780 $Y=694020
X743 726 2 2864 1 INV1S $T=851260 659120 1 0 $X=851260 $Y=653700
X744 727 2 729 1 INV1S $T=852500 608720 0 0 $X=852500 $Y=608340
X745 733 2 2873 1 INV1S $T=855600 659120 1 0 $X=855600 $Y=653700
X746 2883 2 2871 1 INV1S $T=857460 638960 1 180 $X=856220 $Y=638580
X747 625 2 2885 1 INV1S $T=858700 638960 0 180 $X=857460 $Y=633540
X748 2894 2 2874 1 INV1S $T=858700 638960 1 180 $X=857460 $Y=638580
X749 2896 2 2889 1 INV1S $T=859940 618800 1 180 $X=858700 $Y=618420
X750 740 2 739 1 INV1S $T=861180 608720 1 180 $X=859940 $Y=608340
X751 2889 2 2899 1 INV1S $T=859940 618800 0 0 $X=859940 $Y=618420
X752 630 2 2893 1 INV1S $T=861800 638960 0 180 $X=860560 $Y=633540
X753 737 2 2901 1 INV1S $T=860560 638960 0 0 $X=860560 $Y=638580
X754 743 2 742 1 INV1S $T=865520 608720 0 180 $X=864280 $Y=603300
X755 2880 2 2912 1 INV1S $T=865520 608720 1 0 $X=865520 $Y=603300
X756 2914 2 2908 1 INV1S $T=866760 618800 1 180 $X=865520 $Y=618420
X757 747 2 2907 1 INV1S $T=866760 659120 0 180 $X=865520 $Y=653700
X758 2886 2 2922 1 INV1S $T=871100 628880 1 0 $X=871100 $Y=623460
X759 751 2 2923 1 INV1S $T=871100 638960 0 0 $X=871100 $Y=638580
X760 2926 2 2925 1 INV1S $T=874200 618800 1 180 $X=872960 $Y=618420
X761 2929 2 2802 1 INV1S $T=874200 638960 0 180 $X=872960 $Y=633540
X762 744 2 2927 1 INV1S $T=872960 689360 0 0 $X=872960 $Y=688980
X763 759 2 2936 1 INV1S $T=874200 659120 1 0 $X=874200 $Y=653700
X764 758 2 2934 1 INV1S $T=874820 649040 0 0 $X=874820 $Y=648660
X765 765 2 2939 1 INV1S $T=877300 689360 1 0 $X=877300 $Y=683940
X766 766 2 2952 1 INV1S $T=877920 659120 0 0 $X=877920 $Y=658740
X767 2944 2 2956 1 INV1S $T=878540 638960 1 0 $X=878540 $Y=633540
X768 769 2 2954 1 INV1S $T=879780 669200 1 0 $X=879780 $Y=663780
X769 2951 2 2942 1 INV1S $T=882260 628880 1 0 $X=882260 $Y=623460
X770 2945 2 2973 1 INV1S $T=885980 679280 0 0 $X=885980 $Y=678900
X771 2974 2 2969 1 INV1S $T=890320 638960 1 180 $X=889080 $Y=638580
X772 785 2 791 1 INV1S $T=892180 608720 0 0 $X=892180 $Y=608340
X773 786 2 789 1 INV1S $T=893420 618800 1 0 $X=893420 $Y=613380
X774 2984 2 2977 1 INV1S $T=894660 618800 1 180 $X=893420 $Y=618420
X775 792 2 2999 1 INV1S $T=896520 669200 0 0 $X=896520 $Y=668820
X776 796 2 779 1 INV1S $T=899000 608720 0 180 $X=897760 $Y=603300
X777 588 2 2947 1 INV1S $T=899620 638960 1 0 $X=899620 $Y=633540
X778 2947 2 2958 1 INV1S $T=900240 628880 1 0 $X=900240 $Y=623460
X779 613 2 2988 1 INV1S $T=901480 649040 0 180 $X=900240 $Y=643620
X780 3005 2 3008 1 INV1S $T=908920 699440 1 0 $X=908920 $Y=694020
X781 199 2 814 1 INV1S $T=910780 638960 1 0 $X=910780 $Y=633540
X782 3017 2 3019 1 INV1S $T=914500 679280 0 0 $X=914500 $Y=678900
X783 3027 2 3024 1 INV1S $T=917600 669200 0 180 $X=916360 $Y=663780
X784 3020 2 3023 1 INV1S $T=917600 669200 1 180 $X=916360 $Y=668820
X785 3026 2 3014 1 INV1S $T=920700 638960 0 180 $X=919460 $Y=633540
X786 3036 2 3035 1 INV1S $T=925660 638960 0 180 $X=924420 $Y=633540
X787 198 2 833 1 INV1S $T=924420 649040 1 0 $X=924420 $Y=643620
X788 3003 2 3029 1 INV1S $T=926280 608720 0 0 $X=926280 $Y=608340
X789 3053 2 3047 1 INV1S $T=934340 628880 1 180 $X=933100 $Y=628500
X790 3070 2 3064 1 INV1S $T=941160 638960 0 180 $X=939920 $Y=633540
X791 847 2 848 1 INV1S $T=943020 618800 0 0 $X=943020 $Y=618420
X792 3076 2 3075 1 INV1S $T=944880 628880 0 180 $X=943640 $Y=623460
X793 3100 2 3106 1 INV1S $T=956040 638960 1 0 $X=956040 $Y=633540
X794 864 2 862 1 INV1S $T=961000 618800 1 180 $X=959760 $Y=618420
X795 3128 2 3123 1 INV1S $T=970300 628880 0 0 $X=970300 $Y=628500
X796 874 2 872 1 INV1S $T=972160 628880 0 180 $X=970920 $Y=623460
X797 3137 2 3152 1 INV1S $T=976500 638960 0 0 $X=976500 $Y=638580
X798 3150 2 3167 1 INV1S $T=980220 638960 0 0 $X=980220 $Y=638580
X799 887 2 888 1 INV1S $T=984560 628880 1 0 $X=984560 $Y=623460
X800 3113 2 863 1 INV1S $T=988900 608720 0 180 $X=987660 $Y=603300
X801 3169 2 3186 1 INV1S $T=988900 638960 1 0 $X=988900 $Y=633540
X802 629 2 3196 1 INV1S $T=995720 608720 0 0 $X=995720 $Y=608340
X803 625 2 3200 1 INV1S $T=998200 669200 0 0 $X=998200 $Y=668820
X804 903 2 901 1 INV1S $T=1003160 618800 1 180 $X=1001920 $Y=618420
X805 3194 2 3214 1 INV1S $T=1002540 638960 0 0 $X=1002540 $Y=638580
X806 630 2 3210 1 INV1S $T=1007500 669200 1 180 $X=1006260 $Y=668820
X807 3193 2 3224 1 INV1S $T=1009980 628880 1 0 $X=1009980 $Y=623460
X808 3229 2 3221 1 INV1S $T=1011220 669200 0 180 $X=1009980 $Y=663780
X809 911 2 913 1 INV1S $T=1011220 608720 0 0 $X=1011220 $Y=608340
X810 3211 2 3228 1 INV1S $T=1014940 659120 0 180 $X=1013700 $Y=653700
X811 3208 2 3248 1 INV1S $T=1016800 638960 0 0 $X=1016800 $Y=638580
X812 3239 2 3243 1 INV1S $T=1020520 618800 0 180 $X=1019280 $Y=613380
X813 3249 2 3265 1 INV1S $T=1021760 628880 0 0 $X=1021760 $Y=628500
X814 588 2 3140 1 INV1S $T=1026720 618800 1 180 $X=1025480 $Y=618420
X815 907 2 3260 1 INV1S $T=1026720 618800 0 0 $X=1026720 $Y=618420
X816 3272 2 3277 1 INV1S $T=1034780 659120 0 180 $X=1033540 $Y=653700
X817 3262 2 3273 1 INV1S $T=1037880 649040 1 180 $X=1036640 $Y=648660
X818 3287 2 3283 1 INV1S $T=1039120 628880 0 180 $X=1037880 $Y=623460
X819 588 2 3289 1 INV1S $T=1038500 628880 0 0 $X=1038500 $Y=628500
X820 3241 2 3306 1 INV1S $T=1040980 669200 1 0 $X=1040980 $Y=663780
X821 3244 2 3296 1 INV1S $T=1045320 649040 1 0 $X=1045320 $Y=643620
X822 924 2 3303 1 INV1S $T=1049040 608720 1 0 $X=1049040 $Y=603300
X823 3234 2 3315 1 INV1S $T=1049040 628880 0 0 $X=1049040 $Y=628500
X824 3235 2 3311 1 INV1S $T=1049040 649040 1 0 $X=1049040 $Y=643620
X825 3275 2 3330 1 INV1S $T=1057720 649040 1 180 $X=1056480 $Y=648660
X826 3286 2 3334 1 INV1S $T=1057720 618800 0 0 $X=1057720 $Y=618420
X827 3310 2 3347 1 INV1S $T=1067020 618800 0 180 $X=1065780 $Y=613380
X828 947 2 948 1 INV1S $T=1065780 649040 1 0 $X=1065780 $Y=643620
X829 945 2 949 1 INV1S $T=1066400 628880 1 0 $X=1066400 $Y=623460
X830 3252 2 3348 1 INV1S $T=1066400 659120 0 0 $X=1066400 $Y=658740
X831 3225 2 3361 1 INV1S $T=1067020 638960 1 0 $X=1067020 $Y=633540
X832 3313 2 3349 1 INV1S $T=1067640 649040 0 0 $X=1067640 $Y=648660
X833 952 2 955 1 INV1S $T=1076940 608720 0 0 $X=1076940 $Y=608340
X834 957 2 958 1 INV1S $T=1078180 608720 1 0 $X=1078180 $Y=603300
X835 3253 2 3368 1 INV1S $T=1078180 618800 1 0 $X=1078180 $Y=613380
X836 3232 2 3369 1 INV1S $T=1080660 649040 1 0 $X=1080660 $Y=643620
X837 3369 2 3365 1 INV1S $T=1083140 649040 0 180 $X=1081900 $Y=643620
X838 1042 1 1035 4 2 1027 ND3 $T=224440 608720 1 180 $X=221960 $Y=608340
X839 1060 1 1070 1062 2 1057 ND3 $T=233120 638960 1 180 $X=230640 $Y=638580
X840 1076 1 1074 1052 2 1067 ND3 $T=234980 649040 0 180 $X=232500 $Y=643620
X841 1126 1 35 34 2 38 ND3 $T=255440 699440 1 0 $X=255440 $Y=694020
X842 55 1 39 1184 2 18 ND3 $T=275280 689360 0 0 $X=275280 $Y=688980
X843 1202 1 54 29 2 60 ND3 $T=280240 699440 0 180 $X=277760 $Y=694020
X844 74 1 68 71 2 72 ND3 $T=283340 699440 1 0 $X=283340 $Y=694020
X845 74 1 87 112 2 18 ND3 $T=316200 699440 1 0 $X=316200 $Y=694020
X846 2075 1 1985 2096 2 2095 ND3 $T=574740 628880 1 0 $X=574740 $Y=623460
X847 2065 1 2092 2122 2 2105 ND3 $T=584040 628880 0 180 $X=581560 $Y=623460
X848 493 1 491 492 2 2325 ND3 $T=665260 608720 0 0 $X=665260 $Y=608340
X849 499 1 471 2311 2 477 ND3 $T=670220 618800 0 180 $X=667740 $Y=613380
X850 493 1 491 495 2 2334 ND3 $T=668360 608720 0 0 $X=668360 $Y=608340
X851 513 1 2421 2294 2 515 ND3 $T=708660 628880 1 180 $X=706180 $Y=628500
X852 2398 1 2405 2458 2 2402 ND3 $T=720440 618800 0 0 $X=720440 $Y=618420
X853 2657 1 2661 2662 2 2668 ND3 $T=781820 679280 0 0 $X=781820 $Y=678900
X854 2623 1 2686 2689 2 656 ND3 $T=789880 679280 0 0 $X=789880 $Y=678900
X855 2694 1 2698 2722 2 659 ND3 $T=794220 679280 0 0 $X=794220 $Y=678900
X856 2626 1 660 2713 2 665 ND3 $T=796700 699440 1 0 $X=796700 $Y=694020
X857 2714 1 2709 2570 2 662 ND3 $T=800420 679280 1 180 $X=797940 $Y=678900
X858 2730 1 2727 2614 2 668 ND3 $T=804140 679280 1 180 $X=801660 $Y=678900
X859 2769 1 684 2546 2 682 ND3 $T=818400 689360 1 180 $X=815920 $Y=688980
X860 3210 1 3200 3211 2 3190 ND3 $T=1004400 669200 1 180 $X=1001920 $Y=668820
X861 3226 1 3219 3205 2 906 ND3 $T=1008740 699440 0 180 $X=1006260 $Y=694020
X862 3238 1 3242 3192 2 912 ND3 $T=1014940 699440 0 180 $X=1012460 $Y=694020
X863 3305 1 3276 3176 2 927 ND3 $T=1034780 689360 1 180 $X=1032300 $Y=688980
X864 3292 1 3268 3179 2 929 ND3 $T=1039740 699440 0 180 $X=1037260 $Y=694020
X865 41 1 39 1137 18 2 ND3S $T=262880 689360 1 180 $X=260400 $Y=688980
X866 2368 1 518 2325 2371 2 ND3S $T=688820 618800 0 0 $X=688820 $Y=618420
X867 2406 1 2391 518 2402 2 ND3S $T=701220 618800 1 180 $X=698740 $Y=618420
X868 7 17 18 2 20 1 1066 AN4B1S $T=232500 689360 0 0 $X=232500 $Y=688980
X869 479 338 2293 2 2311 1 2298 AN4B1S $T=660300 618800 1 0 $X=660300 $Y=613380
X870 494 484 476 2 2335 1 2342 AN4B1S $T=668980 669200 0 0 $X=668980 $Y=668820
X871 479 477 499 2 487 1 2351 AN4B1S $T=679520 618800 1 0 $X=679520 $Y=613380
X872 485 488 474 2 471 1 2364 AN4B1S $T=695020 649040 1 180 $X=690680 $Y=648660
X873 835 3049 3059 2 838 1 837 AN4B1S $T=934340 699440 1 0 $X=934340 $Y=694020
X874 851 3083 3085 2 854 1 853 AN4B1S $T=946120 699440 1 0 $X=946120 $Y=694020
X875 3102 3112 3118 2 866 1 3043 AN4B1S $T=961620 699440 1 0 $X=961620 $Y=694020
X876 881 3154 880 2 879 1 876 AN4B1S $T=980220 699440 0 180 $X=975880 $Y=694020
X877 655 653 623 652 643 651 1 2 2661 OA222 $T=789880 689360 1 180 $X=784300 $Y=688980
X878 2776 644 674 646 676 648 1 2 2740 OA222 $T=814060 699440 0 180 $X=808480 $Y=694020
X879 669 653 679 652 672 651 1 2 2742 OA222 $T=815920 689360 0 180 $X=810340 $Y=683940
X880 1036 2 1078 1037 1 NR2 $T=230640 659120 0 180 $X=228780 $Y=653700
X881 1094 2 1085 1090 1 NR2 $T=241800 638960 0 180 $X=239940 $Y=633540
X882 33 2 32 29 1 NR2 $T=250480 699440 0 180 $X=248620 $Y=694020
X883 33 2 1126 1137 1 NR2 $T=254820 689360 0 0 $X=254820 $Y=688980
X884 1151 2 1141 1139 1 NR2 $T=262260 638960 0 180 $X=260400 $Y=633540
X885 65 2 1201 1177 1 NR2 $T=282100 659120 1 180 $X=280240 $Y=658740
X886 65 2 1199 1170 1 NR2 $T=283340 679280 0 180 $X=281480 $Y=673860
X887 65 2 1221 1183 1 NR2 $T=285200 669200 0 0 $X=285200 $Y=668820
X888 1218 2 1211 1204 1 NR2 $T=287680 628880 0 180 $X=285820 $Y=623460
X889 65 2 1210 1197 1 NR2 $T=287060 679280 0 0 $X=287060 $Y=678900
X890 1218 2 1219 1180 1 NR2 $T=287680 628880 0 0 $X=287680 $Y=628500
X891 77 2 74 82 1 NR2 $T=288300 699440 1 0 $X=288300 $Y=694020
X892 1218 2 1227 1176 1 NR2 $T=291400 628880 0 180 $X=289540 $Y=623460
X893 77 2 81 79 1 NR2 $T=292640 699440 1 0 $X=292640 $Y=694020
X894 1218 2 1248 1260 1 NR2 $T=297600 618800 0 0 $X=297600 $Y=618420
X895 73 2 98 90 1 NR2 $T=301940 699440 0 180 $X=300080 $Y=694020
X896 109 2 1312 108 1 NR2 $T=316200 669200 0 180 $X=314340 $Y=663780
X897 109 2 1320 113 1 NR2 $T=316820 659120 0 0 $X=316820 $Y=658740
X898 105 2 1322 113 1 NR2 $T=319920 638960 1 0 $X=319920 $Y=633540
X899 105 2 1317 118 1 NR2 $T=321780 679280 1 180 $X=319920 $Y=678900
X900 109 2 1324 127 1 NR2 $T=320540 659120 0 0 $X=320540 $Y=658740
X901 105 2 1329 128 1 NR2 $T=321160 689360 1 0 $X=321160 $Y=683940
X902 122 2 125 108 1 NR2 $T=321780 608720 1 0 $X=321780 $Y=603300
X903 105 2 1345 127 1 NR2 $T=321780 628880 0 0 $X=321780 $Y=628500
X904 105 2 1290 126 1 NR2 $T=322400 638960 1 0 $X=322400 $Y=633540
X905 105 2 1325 130 1 NR2 $T=323640 679280 0 0 $X=323640 $Y=678900
X906 122 2 129 126 1 NR2 $T=325500 618800 1 0 $X=325500 $Y=613380
X907 105 2 1349 136 1 NR2 $T=326740 638960 1 0 $X=326740 $Y=633540
X908 105 2 1350 134 1 NR2 $T=326740 679280 1 0 $X=326740 $Y=673860
X909 105 2 1351 137 1 NR2 $T=328600 689360 0 0 $X=328600 $Y=688980
X910 105 2 1360 143 1 NR2 $T=331080 679280 1 0 $X=331080 $Y=673860
X911 105 2 140 139 1 NR2 $T=332940 689360 1 180 $X=331080 $Y=688980
X912 109 2 1372 146 1 NR2 $T=333560 659120 0 0 $X=333560 $Y=658740
X913 105 2 1365 146 1 NR2 $T=334800 638960 1 0 $X=334800 $Y=633540
X914 105 2 1373 147 1 NR2 $T=335420 679280 1 0 $X=335420 $Y=673860
X915 105 2 1379 151 1 NR2 $T=338520 638960 1 0 $X=338520 $Y=633540
X916 109 2 1386 152 1 NR2 $T=340380 638960 0 0 $X=340380 $Y=638580
X917 109 2 1377 151 1 NR2 $T=341620 659120 1 0 $X=341620 $Y=653700
X918 105 2 1392 152 1 NR2 $T=342240 638960 1 0 $X=342240 $Y=633540
X919 105 2 1402 158 1 NR2 $T=345960 628880 0 0 $X=345960 $Y=628500
X920 1400 2 1396 158 1 NR2 $T=346580 638960 0 0 $X=346580 $Y=638580
X921 105 2 1417 163 1 NR2 $T=349680 628880 0 0 $X=349680 $Y=628500
X922 1400 2 1412 163 1 NR2 $T=350920 638960 0 0 $X=350920 $Y=638580
X923 1399 2 1384 161 1 NR2 $T=352780 669200 0 180 $X=350920 $Y=663780
X924 1399 2 1425 168 1 NR2 $T=353400 628880 0 0 $X=353400 $Y=628500
X925 1400 2 1422 168 1 NR2 $T=354640 638960 0 0 $X=354640 $Y=638580
X926 1399 2 1393 169 1 NR2 $T=355260 669200 1 0 $X=355260 $Y=663780
X927 1399 2 1439 172 1 NR2 $T=357120 628880 0 0 $X=357120 $Y=628500
X928 171 2 1427 1399 1 NR2 $T=357740 659120 0 0 $X=357740 $Y=658740
X929 1399 2 1407 173 1 NR2 $T=357740 669200 1 0 $X=357740 $Y=663780
X930 1400 2 1435 172 1 NR2 $T=358360 638960 0 0 $X=358360 $Y=638580
X931 1399 2 1416 177 1 NR2 $T=360840 669200 1 0 $X=360840 $Y=663780
X932 1399 2 1443 182 1 NR2 $T=362080 638960 0 0 $X=362080 $Y=638580
X933 1455 2 1445 182 1 NR2 $T=368280 638960 1 180 $X=366420 $Y=638580
X934 1399 2 1458 187 1 NR2 $T=370140 638960 0 0 $X=370140 $Y=638580
X935 1455 2 1461 187 1 NR2 $T=375720 638960 1 180 $X=373860 $Y=638580
X936 1399 2 1479 194 1 NR2 $T=376340 628880 0 0 $X=376340 $Y=628500
X937 1455 2 1482 194 1 NR2 $T=379440 638960 1 180 $X=377580 $Y=638580
X938 197 2 1441 1399 1 NR2 $T=381300 628880 0 180 $X=379440 $Y=623460
X939 197 2 1476 1455 1 NR2 $T=381300 638960 0 0 $X=381300 $Y=638580
X940 109 2 1548 134 1 NR2 $T=398660 669200 1 180 $X=396800 $Y=668820
X941 109 2 1564 137 1 NR2 $T=399280 689360 1 180 $X=397420 $Y=688980
X942 109 2 1567 130 1 NR2 $T=399900 669200 0 0 $X=399900 $Y=668820
X943 109 2 1563 118 1 NR2 $T=400520 679280 1 0 $X=400520 $Y=673860
X944 109 2 1569 128 1 NR2 $T=400520 689360 1 0 $X=400520 $Y=683940
X945 109 2 1558 139 1 NR2 $T=400520 699440 1 0 $X=400520 $Y=694020
X946 109 2 1572 139 1 NR2 $T=401760 689360 0 0 $X=401760 $Y=688980
X947 1455 2 1574 161 1 NR2 $T=402380 659120 1 0 $X=402380 $Y=653700
X948 109 2 1575 147 1 NR2 $T=402380 659120 0 0 $X=402380 $Y=658740
X949 109 2 1576 143 1 NR2 $T=403000 669200 1 0 $X=403000 $Y=663780
X950 1455 2 1584 169 1 NR2 $T=404860 649040 0 0 $X=404860 $Y=648660
X951 1455 2 1596 173 1 NR2 $T=408580 638960 0 0 $X=408580 $Y=638580
X952 1455 2 1614 177 1 NR2 $T=412300 638960 0 0 $X=412300 $Y=638580
X953 171 2 1618 1455 1 NR2 $T=422220 649040 0 180 $X=420360 $Y=643620
X954 122 2 1750 137 1 NR2 $T=458180 689360 1 180 $X=456320 $Y=688980
X955 1756 2 1753 147 1 NR2 $T=458800 659120 1 180 $X=456940 $Y=658740
X956 1756 2 1752 134 1 NR2 $T=459420 669200 1 180 $X=457560 $Y=668820
X957 122 2 1758 128 1 NR2 $T=458800 689360 1 0 $X=458800 $Y=683940
X958 1756 2 1761 130 1 NR2 $T=459420 669200 0 0 $X=459420 $Y=668820
X959 122 2 1757 118 1 NR2 $T=459420 679280 0 0 $X=459420 $Y=678900
X960 1756 2 1763 161 1 NR2 $T=460660 659120 1 0 $X=460660 $Y=653700
X961 1756 2 1764 143 1 NR2 $T=460660 659120 0 0 $X=460660 $Y=658740
X962 1756 2 1771 169 1 NR2 $T=463140 649040 1 0 $X=463140 $Y=643620
X963 171 2 1773 1756 1 NR2 $T=465000 638960 1 0 $X=465000 $Y=633540
X964 1756 2 1781 177 1 NR2 $T=466240 638960 0 0 $X=466240 $Y=638580
X965 1756 2 1782 173 1 NR2 $T=468100 638960 1 0 $X=468100 $Y=633540
X966 1836 2 1966 1939 1 NR2 $T=518320 669200 1 0 $X=518320 $Y=663780
X967 1849 2 1984 1924 1 NR2 $T=526380 679280 1 0 $X=526380 $Y=673860
X968 2028 2 2029 329 1 NR2 $T=549940 669200 0 180 $X=548080 $Y=663780
X969 2068 2 2079 2055 1 NR2 $T=566680 659120 1 0 $X=566680 $Y=653700
X970 2075 2 2101 2095 1 NR2 $T=574740 618800 0 0 $X=574740 $Y=618420
X971 2143 2 2185 2133 1 NR2 $T=606980 618800 1 0 $X=606980 $Y=613380
X972 2248 2 2257 2259 1 NR2 $T=639840 669200 0 180 $X=637980 $Y=663780
X973 2193 2 2288 2281 1 NR2 $T=650380 669200 0 0 $X=650380 $Y=668820
X974 2396 2 2356 2394 1 NR2 $T=697500 638960 0 180 $X=695640 $Y=633540
X975 523 2 2396 515 1 NR2 $T=696260 699440 1 0 $X=696260 $Y=694020
X976 509 2 534 487 1 NR2 $T=711760 649040 1 180 $X=709900 $Y=648660
X977 2448 2 2421 336 1 NR2 $T=718580 628880 0 180 $X=716720 $Y=623460
X978 603 2 2535 601 1 NR2 $T=748960 649040 0 180 $X=747100 $Y=643620
X979 171 2 614 615 1 NR2 $T=760740 608720 0 180 $X=758880 $Y=603300
X980 615 2 2571 177 1 NR2 $T=760740 608720 0 0 $X=760740 $Y=608340
X981 171 2 2544 2588 1 NR2 $T=760740 649040 1 0 $X=760740 $Y=643620
X982 615 2 2596 173 1 NR2 $T=762600 608720 0 0 $X=762600 $Y=608340
X983 2588 2 2603 177 1 NR2 $T=764460 649040 1 180 $X=762600 $Y=648660
X984 2588 2 2615 173 1 NR2 $T=769420 649040 1 180 $X=767560 $Y=648660
X985 2628 2 2626 2607 1 NR2 $T=771900 699440 0 180 $X=770040 $Y=694020
X986 2635 2 2623 2621 1 NR2 $T=775000 689360 0 180 $X=773140 $Y=683940
X987 615 2 2631 169 1 NR2 $T=774380 608720 0 0 $X=774380 $Y=608340
X988 2588 2 2633 169 1 NR2 $T=776240 649040 1 180 $X=774380 $Y=648660
X989 2647 2 2657 2656 1 NR2 $T=778720 679280 0 0 $X=778720 $Y=678900
X990 2588 2 2649 161 1 NR2 $T=782440 649040 1 180 $X=780580 $Y=648660
X991 615 2 2658 161 1 NR2 $T=781820 618800 1 0 $X=781820 $Y=613380
X992 2642 2 2694 2608 1 NR2 $T=782440 689360 1 0 $X=782440 $Y=683940
X993 615 2 2672 147 1 NR2 $T=783680 618800 1 0 $X=783680 $Y=613380
X994 2588 2 2667 147 1 NR2 $T=785540 649040 1 180 $X=783680 $Y=648660
X995 2588 2 2679 143 1 NR2 $T=788640 649040 0 0 $X=788640 $Y=648660
X996 615 2 2690 143 1 NR2 $T=791120 618800 1 0 $X=791120 $Y=613380
X997 616 2 2688 134 1 NR2 $T=793600 649040 0 0 $X=793600 $Y=648660
X998 615 2 2704 134 1 NR2 $T=799800 608720 1 180 $X=797940 $Y=608340
X999 615 2 2715 130 1 NR2 $T=799800 608720 0 0 $X=799800 $Y=608340
X1000 616 2 2687 130 1 NR2 $T=802280 649040 1 0 $X=802280 $Y=643620
X1001 667 2 2751 675 1 NR2 $T=810960 649040 0 0 $X=810960 $Y=648660
X1002 615 2 2745 118 1 NR2 $T=811580 608720 0 0 $X=811580 $Y=608340
X1003 616 2 2749 118 1 NR2 $T=811580 649040 1 0 $X=811580 $Y=643620
X1004 2759 2 2735 2756 1 NR2 $T=815920 679280 1 180 $X=814060 $Y=678900
X1005 615 2 2760 128 1 NR2 $T=816540 618800 1 0 $X=816540 $Y=613380
X1006 616 2 2767 128 1 NR2 $T=817160 649040 1 0 $X=817160 $Y=643620
X1007 2768 2 2730 2773 1 NR2 $T=819020 689360 1 0 $X=819020 $Y=683940
X1008 615 2 2772 137 1 NR2 $T=825220 608720 1 180 $X=823360 $Y=608340
X1009 615 2 2798 568 1 NR2 $T=824600 618800 1 0 $X=824600 $Y=613380
X1010 2790 2 2714 2801 1 NR2 $T=824600 689360 1 0 $X=824600 $Y=683940
X1011 616 2 2797 137 1 NR2 $T=825840 638960 0 0 $X=825840 $Y=638580
X1012 616 2 2809 568 1 NR2 $T=830800 628880 1 180 $X=828940 $Y=628500
X1013 615 2 2793 257 1 NR2 $T=830800 608720 0 0 $X=830800 $Y=608340
X1014 2794 2 2769 2811 1 NR2 $T=830800 699440 1 0 $X=830800 $Y=694020
X1015 616 2 2808 139 1 NR2 $T=833900 638960 0 180 $X=832040 $Y=633540
X1016 616 2 2816 257 1 NR2 $T=834520 638960 0 0 $X=834520 $Y=638580
X1017 615 2 2810 706 1 NR2 $T=836380 608720 1 0 $X=836380 $Y=603300
X1018 616 2 2846 706 1 NR2 $T=845060 618800 1 180 $X=843200 $Y=618420
X1019 613 2 2831 2834 1 NR2 $T=843820 628880 0 0 $X=843820 $Y=628500
X1020 616 2 2859 572 1 NR2 $T=846920 618800 0 0 $X=846920 $Y=618420
X1021 2853 2 2451 725 1 NR2 $T=849400 659120 1 0 $X=849400 $Y=653700
X1022 613 2 2881 2878 1 NR2 $T=854980 628880 1 0 $X=854980 $Y=623460
X1023 613 2 2904 2894 1 NR2 $T=863040 638960 0 0 $X=863040 $Y=638580
X1024 613 2 2913 2919 1 NR2 $T=867380 628880 1 0 $X=867380 $Y=623460
X1025 744 2 2909 2921 1 NR2 $T=869860 689360 0 0 $X=869860 $Y=688980
X1026 2938 2 2959 2969 1 NR2 $T=885360 638960 0 0 $X=885360 $Y=638580
X1027 813 2 827 187 1 NR2 $T=923800 608720 1 0 $X=923800 $Y=603300
X1028 814 2 3038 616 1 NR2 $T=926280 638960 1 0 $X=926280 $Y=633540
X1029 616 2 3042 187 1 NR2 $T=929380 659120 1 180 $X=927520 $Y=658740
X1030 813 2 3045 182 1 NR2 $T=930000 618800 1 0 $X=930000 $Y=613380
X1031 813 2 834 833 1 NR2 $T=931240 608720 1 0 $X=931240 $Y=603300
X1032 616 2 3057 182 1 NR2 $T=934340 669200 0 180 $X=932480 $Y=663780
X1033 616 2 3052 833 1 NR2 $T=933100 649040 1 0 $X=933100 $Y=643620
X1034 813 2 3055 172 1 NR2 $T=934340 618800 1 0 $X=934340 $Y=613380
X1035 616 2 3062 172 1 NR2 $T=939300 669200 0 180 $X=937440 $Y=663780
X1036 813 2 3074 168 1 NR2 $T=943640 608720 0 0 $X=943640 $Y=608340
X1037 616 2 3077 168 1 NR2 $T=946740 669200 1 180 $X=944880 $Y=668820
X1038 813 2 3094 163 1 NR2 $T=952940 618800 1 0 $X=952940 $Y=613380
X1039 616 2 3097 163 1 NR2 $T=956660 669200 0 180 $X=954800 $Y=663780
X1040 813 2 3103 158 1 NR2 $T=956660 618800 1 0 $X=956660 $Y=613380
X1041 616 2 3116 158 1 NR2 $T=961620 638960 0 180 $X=959760 $Y=633540
X1042 813 2 3115 152 1 NR2 $T=961000 618800 1 0 $X=961000 $Y=613380
X1043 813 2 3130 151 1 NR2 $T=964720 618800 1 0 $X=964720 $Y=613380
X1044 616 2 3129 152 1 NR2 $T=966580 638960 0 180 $X=964720 $Y=633540
X1045 616 2 3127 151 1 NR2 $T=967200 659120 1 180 $X=965340 $Y=658740
X1046 813 2 3139 146 1 NR2 $T=974020 618800 0 0 $X=974020 $Y=618420
X1047 616 2 3147 146 1 NR2 $T=977740 659120 1 180 $X=975880 $Y=658740
X1048 813 2 3151 136 1 NR2 $T=977740 618800 0 0 $X=977740 $Y=618420
X1049 616 2 3156 136 1 NR2 $T=982080 659120 1 180 $X=980220 $Y=658740
X1050 813 2 3161 127 1 NR2 $T=983320 618800 1 180 $X=981460 $Y=618420
X1051 616 2 3165 113 1 NR2 $T=983940 649040 1 0 $X=983940 $Y=643620
X1052 813 2 3170 113 1 NR2 $T=987660 618800 1 180 $X=985800 $Y=618420
X1053 813 2 3183 108 1 NR2 $T=989520 618800 0 0 $X=989520 $Y=618420
X1054 616 2 3180 108 1 NR2 $T=993860 638960 1 180 $X=992000 $Y=638580
X1055 813 2 3177 126 1 NR2 $T=993240 618800 0 0 $X=993240 $Y=618420
X1056 616 2 3191 126 1 NR2 $T=995720 649040 0 180 $X=993860 $Y=643620
X1057 813 2 3195 896 1 NR2 $T=996340 618800 0 180 $X=994480 $Y=613380
X1058 907 2 910 908 1 NR2 $T=1008740 608720 1 0 $X=1008740 $Y=603300
X1059 613 2 3230 3229 1 NR2 $T=1009980 669200 0 0 $X=1009980 $Y=668820
X1060 613 2 3233 3231 1 NR2 $T=1013080 649040 0 0 $X=1013080 $Y=648660
X1061 613 2 3237 3211 1 NR2 $T=1020520 659120 1 180 $X=1018660 $Y=658740
X1062 613 2 3250 3245 1 NR2 $T=1020520 649040 0 0 $X=1020520 $Y=648660
X1063 907 2 921 3254 1 NR2 $T=1023000 618800 1 0 $X=1023000 $Y=613380
X1064 3255 2 3272 3211 1 NR2 $T=1029200 659120 0 180 $X=1027340 $Y=653700
X1065 922 2 924 919 1 NR2 $T=1031060 608720 1 0 $X=1031060 $Y=603300
X1066 925 2 3302 3285 1 NR2 $T=1046560 608720 0 180 $X=1044700 $Y=603300
X1067 3258 2 3301 3299 1 NR2 $T=1046560 649040 1 180 $X=1044700 $Y=648660
X1068 1137 2 42 44 1071 1 NR3 $T=261640 699440 1 0 $X=261640 $Y=694020
X1069 1184 2 49 33 48 1 NR3 $T=270320 689360 1 180 $X=267220 $Y=688980
X1070 73 2 75 79 1202 1 NR3 $T=287060 689360 0 0 $X=287060 $Y=688980
X1071 2105 2 1985 2065 2140 1 NR3 $T=590860 628880 1 180 $X=587760 $Y=628500
X1072 2346 2 2315 2300 2350 1 NR3 $T=680140 659120 0 180 $X=677040 $Y=653700
X1073 2092 2185 1 2143 2195 409 2 MOAI1S $T=610080 608720 0 0 $X=610080 $Y=608340
X1074 474 2299 1 474 2294 2289 2 MOAI1S $T=660300 618800 1 180 $X=656580 $Y=618420
X1075 2313 2299 1 2309 476 2305 2 MOAI1S $T=664020 659120 0 180 $X=660300 $Y=653700
X1076 2314 2299 1 485 2294 2296 2 MOAI1S $T=664640 649040 0 180 $X=660920 $Y=643620
X1077 2310 2299 1 487 2294 2295 2 MOAI1S $T=661540 638960 1 0 $X=661540 $Y=633540
X1078 2324 2299 1 2309 484 2312 2 MOAI1S $T=666500 669200 0 180 $X=662780 $Y=663780
X1079 2328 2299 1 488 2294 2286 2 MOAI1S $T=668980 628880 0 180 $X=665260 $Y=623460
X1080 2330 2299 1 497 2294 2338 2 MOAI1S $T=668980 628880 1 0 $X=668980 $Y=623460
X1081 2339 2299 1 2309 494 2329 2 MOAI1S $T=673320 649040 0 180 $X=669600 $Y=643620
X1082 2348 2299 1 2309 2335 2343 2 MOAI1S $T=678900 669200 1 0 $X=678900 $Y=663780
X1083 2373 516 1 2373 495 2337 2 MOAI1S $T=689440 608720 1 180 $X=685720 $Y=608340
X1084 519 2355 1 2388 2391 2389 2 MOAI1S $T=692540 618800 0 0 $X=692540 $Y=618420
X1085 618 599 1 620 621 2607 2 MOAI1S $T=761980 699440 1 0 $X=761980 $Y=694020
X1086 618 580 1 620 2599 2608 2 MOAI1S $T=762600 689360 0 0 $X=762600 $Y=688980
X1087 618 2531 1 620 2612 2621 2 MOAI1S $T=766940 689360 1 0 $X=766940 $Y=683940
X1088 639 2589 1 642 2612 2656 2 MOAI1S $T=776860 689360 1 0 $X=776860 $Y=683940
X1089 639 2705 1 642 2752 2756 2 MOAI1S $T=810340 679280 0 0 $X=810340 $Y=678900
X1090 618 2788 1 620 2752 2773 2 MOAI1S $T=823980 679280 1 180 $X=820260 $Y=678900
X1091 618 698 1 620 2776 2801 2 MOAI1S $T=832660 689360 1 180 $X=828940 $Y=688980
X1092 618 699 1 620 705 2811 2 MOAI1S $T=840100 699440 0 180 $X=836380 $Y=694020
X1093 2373 774 1 725 2373 2970 2 MOAI1S $T=884120 649040 1 0 $X=884120 $Y=643620
X1094 806 535 1 797 535 2997 2 MOAI1S $T=906440 638960 1 180 $X=902720 $Y=638580
X1095 1034 1024 1025 1 2 ND2 $T=222580 618800 0 180 $X=220720 $Y=613380
X1096 1026 1028 1029 1 2 ND2 $T=220720 628880 0 0 $X=220720 $Y=628500
X1097 4 5 3 1 2 ND2 $T=222580 608720 1 0 $X=222580 $Y=603300
X1098 1036 1044 1033 1 2 ND2 $T=225680 669200 1 180 $X=223820 $Y=668820
X1099 1034 1031 1039 1 2 ND2 $T=226300 618800 0 180 $X=224440 $Y=613380
X1100 1052 1057 1046 1 2 ND2 $T=228780 638960 1 180 $X=226920 $Y=638580
X1101 1048 1055 10 1 2 ND2 $T=227540 669200 1 0 $X=227540 $Y=663780
X1102 1059 1056 1049 1 2 ND2 $T=229400 669200 1 180 $X=227540 $Y=668820
X1103 11 1035 6 1 2 ND2 $T=230020 618800 0 180 $X=228160 $Y=613380
X1104 12 1042 6 1 2 ND2 $T=230640 608720 0 180 $X=228780 $Y=603300
X1105 1052 1060 1050 1 2 ND2 $T=232500 649040 0 180 $X=230640 $Y=643620
X1106 1036 1064 1081 1 2 ND2 $T=233120 669200 1 0 $X=233120 $Y=663780
X1107 11 1027 12 1 2 ND2 $T=236220 608720 1 180 $X=234360 $Y=608340
X1108 1043 1054 1068 1 2 ND2 $T=234360 628880 0 0 $X=234360 $Y=628500
X1109 1050 1070 1046 1 2 ND2 $T=236220 638960 0 0 $X=236220 $Y=638580
X1110 1080 1076 1084 1 2 ND2 $T=238700 649040 1 0 $X=238700 $Y=643620
X1111 1051 1103 1087 1 2 ND2 $T=241800 608720 1 180 $X=239940 $Y=608340
X1112 1051 1100 1089 1 2 ND2 $T=241180 618800 1 0 $X=241180 $Y=613380
X1113 1089 1115 1087 1 2 ND2 $T=247380 618800 0 180 $X=245520 $Y=613380
X1114 1112 1106 1117 1 2 ND2 $T=248000 628880 0 0 $X=248000 $Y=628500
X1115 1113 1091 10 1 2 ND2 $T=248620 669200 0 0 $X=248620 $Y=668820
X1116 1104 1087 1110 1 2 ND2 $T=249240 649040 0 0 $X=249240 $Y=648660
X1117 1094 1101 24 1 2 ND2 $T=251100 628880 0 0 $X=251100 $Y=628500
X1118 1094 1118 1108 1 2 ND2 $T=254200 628880 0 0 $X=254200 $Y=628500
X1119 1130 1131 10 1 2 ND2 $T=256680 659120 0 180 $X=254820 $Y=653700
X1120 1129 1123 1117 1 2 ND2 $T=256060 649040 1 0 $X=256060 $Y=643620
X1121 1134 1136 10 1 2 ND2 $T=258540 669200 1 180 $X=256680 $Y=668820
X1122 31 1145 28 1 2 ND2 $T=261020 608720 0 180 $X=259160 $Y=603300
X1123 1155 1133 1081 1 2 ND2 $T=262260 659120 0 180 $X=260400 $Y=653700
X1124 1152 1150 24 1 2 ND2 $T=262880 618800 1 0 $X=262880 $Y=613380
X1125 1160 1161 1117 1 2 ND2 $T=266600 649040 0 180 $X=264740 $Y=643620
X1126 52 51 46 1 2 ND2 $T=269700 608720 1 180 $X=267840 $Y=608340
X1127 55 53 58 1 2 ND2 $T=272800 699440 1 0 $X=272800 $Y=694020
X1128 63 1179 1188 1 2 ND2 $T=280240 638960 1 0 $X=280240 $Y=633540
X1129 1224 1228 1214 1 2 ND2 $T=291400 638960 1 180 $X=289540 $Y=638580
X1130 1231 1237 1223 1 2 ND2 $T=293260 638960 1 180 $X=291400 $Y=638580
X1131 1242 1234 1214 1 2 ND2 $T=294500 649040 0 180 $X=292640 $Y=643620
X1132 1228 78 1237 1 2 ND2 $T=295120 638960 1 180 $X=293260 $Y=638580
X1133 1281 1230 1263 1 2 ND2 $T=301940 669200 1 180 $X=300080 $Y=668820
X1134 1279 1281 1267 1 2 ND2 $T=306280 669200 0 0 $X=306280 $Y=668820
X1135 1290 1287 103 1 2 ND2 $T=306900 638960 1 0 $X=306900 $Y=633540
X1136 72 73 18 1 2 ND2 $T=310000 699440 1 0 $X=310000 $Y=694020
X1137 1312 1316 1309 1 2 ND2 $T=316200 679280 0 180 $X=314340 $Y=673860
X1138 121 120 117 1 2 ND2 $T=321780 608720 0 180 $X=319920 $Y=603300
X1139 1328 1314 1327 1 2 ND2 $T=321780 628880 1 180 $X=319920 $Y=628500
X1140 1333 1339 1223 1 2 ND2 $T=323020 638960 1 180 $X=321160 $Y=638580
X1141 1336 1304 1342 1 2 ND2 $T=323020 628880 1 0 $X=323020 $Y=623460
X1142 1341 124 1339 1 2 ND2 $T=324880 638960 1 180 $X=323020 $Y=638580
X1143 1326 1341 1214 1 2 ND2 $T=326740 638960 1 180 $X=324880 $Y=638580
X1144 1349 1336 133 1 2 ND2 $T=326740 628880 1 0 $X=326740 $Y=623460
X1145 181 179 176 1 2 ND2 $T=363940 608720 0 180 $X=362080 $Y=603300
X1146 1510 1520 188 1 2 ND2 $T=389360 669200 1 180 $X=387500 $Y=668820
X1147 1470 1526 196 1 2 ND2 $T=391220 669200 1 180 $X=389360 $Y=668820
X1148 1525 1538 1509 1 2 ND2 $T=395560 669200 0 180 $X=393700 $Y=663780
X1149 1554 212 1571 1 2 ND2 $T=402380 699440 1 0 $X=402380 $Y=694020
X1150 1652 1630 1658 1 2 ND2 $T=429040 628880 1 0 $X=429040 $Y=623460
X1151 1660 1677 209 1 2 ND2 $T=437100 669200 1 180 $X=435240 $Y=668820
X1152 1686 1689 1504 1 2 ND2 $T=439580 689360 1 180 $X=437720 $Y=688980
X1153 1681 1683 238 1 2 ND2 $T=442680 669200 1 180 $X=440820 $Y=668820
X1154 1709 1710 1693 1 2 ND2 $T=444540 669200 0 180 $X=442680 $Y=663780
X1155 249 1708 1680 1 2 ND2 $T=445160 689360 1 180 $X=443300 $Y=688980
X1156 1675 1725 1722 1 2 ND2 $T=444540 628880 1 0 $X=444540 $Y=623460
X1157 1723 1714 1731 1 2 ND2 $T=446400 659120 0 0 $X=446400 $Y=658740
X1158 250 1737 249 1 2 ND2 $T=450740 689360 1 180 $X=448880 $Y=688980
X1159 1703 252 251 1 2 ND2 $T=452600 608720 0 180 $X=450740 $Y=603300
X1160 1731 1742 1715 1 2 ND2 $T=452600 659120 1 180 $X=450740 $Y=658740
X1161 1703 253 254 1 2 ND2 $T=456320 608720 1 0 $X=456320 $Y=603300
X1162 1776 1780 1787 1 2 ND2 $T=468100 618800 0 0 $X=468100 $Y=618420
X1163 1710 1859 1869 1 2 ND2 $T=493520 669200 1 0 $X=493520 $Y=663780
X1164 1848 1886 1762 1 2 ND2 $T=494760 628880 0 0 $X=494760 $Y=628500
X1165 1880 1869 1885 1 2 ND2 $T=496620 669200 1 0 $X=496620 $Y=663780
X1166 1766 1889 1868 1 2 ND2 $T=497240 638960 0 0 $X=497240 $Y=638580
X1167 1847 1853 1860 1 2 ND2 $T=497240 679280 0 0 $X=497240 $Y=678900
X1168 1884 1880 1905 1 2 ND2 $T=497860 659120 0 0 $X=497860 $Y=658740
X1169 1898 1892 1878 1 2 ND2 $T=500340 669200 0 180 $X=498480 $Y=663780
X1170 1906 1897 1842 1 2 ND2 $T=502200 669200 0 180 $X=500340 $Y=663780
X1171 1892 1908 1905 1 2 ND2 $T=501580 659120 0 0 $X=501580 $Y=658740
X1172 296 1910 1874 1 2 ND2 $T=505920 689360 1 180 $X=504060 $Y=688980
X1173 1904 1899 1890 1 2 ND2 $T=504680 608720 0 0 $X=504680 $Y=608340
X1174 299 302 297 1 2 ND2 $T=509020 699440 0 180 $X=507160 $Y=694020
X1175 1924 1925 1922 1 2 ND2 $T=510260 679280 0 180 $X=508400 $Y=673860
X1176 1925 1926 1928 1 2 ND2 $T=510260 679280 1 0 $X=510260 $Y=673860
X1177 1946 1938 1934 1 2 ND2 $T=515220 669200 0 0 $X=515220 $Y=668820
X1178 1957 1933 1836 1 2 ND2 $T=518320 669200 0 180 $X=516460 $Y=663780
X1179 1935 1943 1961 1 2 ND2 $T=516460 689360 0 0 $X=516460 $Y=688980
X1180 1942 1956 1928 1 2 ND2 $T=520180 679280 1 180 $X=518320 $Y=678900
X1181 1971 1951 1851 1 2 ND2 $T=521420 689360 1 180 $X=519560 $Y=688980
X1182 1844 1968 1973 1 2 ND2 $T=520180 679280 0 0 $X=520180 $Y=678900
X1183 1745 1962 1973 1 2 ND2 $T=523280 679280 1 0 $X=523280 $Y=673860
X1184 1983 1947 1849 1 2 ND2 $T=525140 689360 0 180 $X=523280 $Y=683940
X1185 2032 2020 337 1 2 ND2 $T=551800 689360 0 0 $X=551800 $Y=688980
X1186 2051 341 340 1 2 ND2 $T=558000 689360 1 180 $X=556140 $Y=688980
X1187 2078 2072 2094 1 2 ND2 $T=571640 679280 1 0 $X=571640 $Y=673860
X1188 2097 2059 2106 1 2 ND2 $T=575980 689360 0 0 $X=575980 $Y=688980
X1189 2139 2138 2141 1 2 ND2 $T=592100 679280 0 0 $X=592100 $Y=678900
X1190 2121 2146 2153 1 2 ND2 $T=594580 689360 1 0 $X=594580 $Y=683940
X1191 2147 2157 2167 1 2 ND2 $T=600160 679280 1 0 $X=600160 $Y=673860
X1192 2178 2191 414 1 2 ND2 $T=613800 689360 1 0 $X=613800 $Y=683940
X1193 2184 2197 2209 1 2 ND2 $T=615660 669200 0 0 $X=615660 $Y=668820
X1194 2211 2222 2231 1 2 ND2 $T=625580 689360 1 0 $X=625580 $Y=683940
X1195 2164 2229 2234 1 2 ND2 $T=626200 669200 0 0 $X=626200 $Y=668820
X1196 2214 2252 2250 1 2 ND2 $T=634260 689360 0 0 $X=634260 $Y=688980
X1197 2216 2270 2272 1 2 ND2 $T=641700 669200 0 0 $X=641700 $Y=668820
X1198 2242 2284 2297 1 2 ND2 $T=652860 689360 0 0 $X=652860 $Y=688980
X1199 2261 2333 2319 1 2 ND2 $T=664020 679280 0 0 $X=664020 $Y=678900
X1200 2273 2318 2327 1 2 ND2 $T=665260 669200 0 0 $X=665260 $Y=668820
X1201 2372 2361 517 1 2 ND2 $T=686960 628880 0 0 $X=686960 $Y=628500
X1202 2374 2372 497 1 2 ND2 $T=688200 638960 1 0 $X=688200 $Y=633540
X1203 2334 2376 2379 1 2 ND2 $T=689440 628880 0 0 $X=689440 $Y=628500
X1204 2374 2382 499 1 2 ND2 $T=692540 638960 0 180 $X=690680 $Y=633540
X1205 524 515 2401 1 2 ND2 $T=708660 628880 0 0 $X=708660 $Y=628500
X1206 2454 549 561 1 2 ND2 $T=721680 689360 0 0 $X=721680 $Y=688980
X1207 562 2475 2438 1 2 ND2 $T=724780 608720 0 0 $X=724780 $Y=608340
X1208 2459 564 569 1 2 ND2 $T=726020 689360 0 0 $X=726020 $Y=688980
X1209 2469 2471 2405 1 2 ND2 $T=728500 628880 1 180 $X=726640 $Y=628500
X1210 2466 2479 2477 1 2 ND2 $T=729120 679280 0 0 $X=729120 $Y=678900
X1211 2483 2487 2492 1 2 ND2 $T=731600 679280 0 0 $X=731600 $Y=678900
X1212 2500 2504 2503 1 2 ND2 $T=735940 659120 0 0 $X=735940 $Y=658740
X1213 2501 2493 2502 1 2 ND2 $T=737800 638960 1 0 $X=737800 $Y=633540
X1214 2515 2505 2521 1 2 ND2 $T=740280 608720 1 0 $X=740280 $Y=603300
X1215 2530 2548 2549 1 2 ND2 $T=748960 659120 0 0 $X=748960 $Y=658740
X1216 2553 2547 2558 1 2 ND2 $T=750820 649040 0 0 $X=750820 $Y=648660
X1217 2579 2587 2485 1 2 ND2 $T=757640 618800 1 0 $X=757640 $Y=613380
X1218 2563 2569 2485 1 2 ND2 $T=758880 618800 0 0 $X=758880 $Y=618420
X1219 2587 619 2575 1 2 ND2 $T=761360 618800 1 0 $X=761360 $Y=613380
X1220 2577 2600 2598 1 2 ND2 $T=765080 659120 1 0 $X=765080 $Y=653700
X1221 2618 2624 2485 1 2 ND2 $T=769420 618800 1 0 $X=769420 $Y=613380
X1222 2655 2638 2663 1 2 ND2 $T=779960 669200 0 0 $X=779960 $Y=668820
X1223 2662 2682 2671 1 2 ND2 $T=791120 669200 1 180 $X=789260 $Y=668820
X1224 2710 2712 2699 1 2 ND2 $T=798560 659120 0 180 $X=796700 $Y=653700
X1225 2738 2724 2701 1 2 ND2 $T=803520 669200 0 180 $X=801660 $Y=663780
X1226 2761 2763 2744 1 2 ND2 $T=815920 659120 1 180 $X=814060 $Y=658740
X1227 2789 2796 2795 1 2 ND2 $T=823980 659120 0 0 $X=823980 $Y=658740
X1228 2830 712 2842 1 2 ND2 $T=840100 608720 1 0 $X=840100 $Y=603300
X1229 716 2842 629 1 2 ND2 $T=843820 608720 0 180 $X=841960 $Y=603300
X1230 2770 2844 715 1 2 ND2 $T=844440 638960 1 180 $X=842580 $Y=638580
X1231 2836 2856 2841 1 2 ND2 $T=848160 669200 0 180 $X=846300 $Y=663780
X1232 2852 2835 2867 1 2 ND2 $T=854360 628880 0 180 $X=852500 $Y=623460
X1233 2885 2883 2859 1 2 ND2 $T=857460 638960 0 180 $X=855600 $Y=633540
X1234 2870 2888 2866 1 2 ND2 $T=857460 679280 0 180 $X=855600 $Y=673860
X1235 2897 2884 2892 1 2 ND2 $T=860560 679280 0 180 $X=858700 $Y=673860
X1236 2880 2928 748 1 2 ND2 $T=872340 608720 0 180 $X=870480 $Y=603300
X1237 3088 847 3079 1 2 ND2 $T=947980 618800 1 180 $X=946120 $Y=618420
X1238 3091 3088 3003 1 2 ND2 $T=951700 618800 1 180 $X=949840 $Y=618420
X1239 3180 3181 625 1 2 ND2 $T=990760 649040 1 180 $X=988900 $Y=648660
X1240 3163 3182 3181 1 2 ND2 $T=992620 649040 1 180 $X=990760 $Y=648660
X1241 3184 3188 895 1 2 ND2 $T=995100 659120 0 180 $X=993240 $Y=653700
X1242 3188 3204 3202 1 2 ND2 $T=1003160 659120 0 180 $X=1001300 $Y=653700
X1243 3284 3287 3295 1 2 ND2 $T=1040360 628880 1 0 $X=1040360 $Y=623460
X1244 925 3297 771 1 2 ND2 $T=1045940 608720 1 180 $X=1044080 $Y=608340
X1245 3258 3309 3289 1 2 ND2 $T=1048420 649040 1 180 $X=1046560 $Y=648660
X1246 3323 3329 3317 1 2 ND2 $T=1054620 628880 1 0 $X=1054620 $Y=623460
X1247 3321 940 941 1 2 ND2 $T=1055240 608720 1 0 $X=1055240 $Y=603300
X1248 3310 3323 3313 1 2 ND2 $T=1055860 618800 0 0 $X=1055860 $Y=618420
X1249 3333 3327 3335 1 2 ND2 $T=1057720 608720 0 0 $X=1057720 $Y=608340
X1250 3329 3337 3286 1 2 ND2 $T=1058960 618800 0 0 $X=1058960 $Y=618420
X1251 3232 3352 3289 1 2 ND2 $T=1067020 649040 1 0 $X=1067020 $Y=643620
X1252 2185 2026 2143 1 2 412 AO12 $T=610700 608720 1 0 $X=610700 $Y=603300
X1253 2185 2104 2143 1 2 422 AO12 $T=616280 608720 1 0 $X=616280 $Y=603300
X1254 2185 2082 2143 1 2 415 AO12 $T=620000 608720 1 180 $X=616280 $Y=608340
X1255 2185 2053 2143 1 2 433 AO12 $T=621860 608720 1 0 $X=621860 $Y=603300
X1256 2185 2008 2143 1 2 2224 AO12 $T=621860 608720 0 0 $X=621860 $Y=608340
X1257 2185 2062 2143 1 2 437 AO12 $T=631160 618800 1 180 $X=627440 $Y=618420
X1258 2185 2089 2143 1 2 442 AO12 $T=628060 608720 1 0 $X=628060 $Y=603300
X1259 2185 2116 2143 1 2 445 AO12 $T=628060 608720 0 0 $X=628060 $Y=608340
X1260 2185 2196 2143 1 2 455 AO12 $T=634880 608720 0 0 $X=634880 $Y=608340
X1261 2185 2235 2143 1 2 450 AO12 $T=634880 618800 1 0 $X=634880 $Y=613380
X1262 529 575 2451 1 2 2474 AO12 $T=735320 659120 1 180 $X=731600 $Y=658740
X1263 2983 2980 2978 1 2 2976 AO12 $T=895280 659120 1 180 $X=891560 $Y=658740
X1264 2983 2993 2978 1 2 2989 AO12 $T=900240 659120 1 180 $X=896520 $Y=658740
X1265 2983 2998 2978 1 2 3000 AO12 $T=899620 669200 1 0 $X=899620 $Y=663780
X1266 2983 3004 2978 1 2 199 AO12 $T=908300 659120 0 180 $X=904580 $Y=653700
X1267 2983 799 2978 1 2 3006 AO12 $T=904580 669200 1 0 $X=904580 $Y=663780
X1268 535 3010 2978 1 2 198 AO12 $T=912020 659120 0 180 $X=908300 $Y=653700
X1269 2983 3011 2978 1 2 3012 AO12 $T=908920 669200 1 0 $X=908920 $Y=663780
X1270 2599 644 646 636 648 645 2 1 2668 OA222S $T=781820 699440 1 0 $X=781820 $Y=694020
X1271 653 636 640 652 655 651 2 1 2698 OA222S $T=789260 699440 1 0 $X=789260 $Y=694020
X1272 653 645 643 652 640 651 2 1 2686 OA222S $T=797940 689360 1 180 $X=792360 $Y=688980
X1273 674 653 670 652 669 651 2 1 2709 OA222S $T=806620 699440 0 180 $X=801040 $Y=694020
X1274 676 653 672 652 670 651 2 1 2727 OA222S $T=807240 689360 1 180 $X=801660 $Y=688980
X1275 1102 1088 1081 2 1 ND2S $T=242420 669200 1 180 $X=240560 $Y=668820
X1276 1139 1122 24 2 1 ND2S $T=257920 638960 1 180 $X=256060 $Y=638580
X1277 1149 1146 1081 2 1 ND2S $T=262260 669200 0 0 $X=262260 $Y=668820
X1278 1238 1244 1236 2 1 ND2S $T=293880 628880 1 0 $X=293880 $Y=623460
X1279 1259 1195 1244 2 1 ND2S $T=295740 628880 1 0 $X=295740 $Y=623460
X1280 1256 1259 1257 2 1 ND2S $T=297600 628880 1 0 $X=297600 $Y=623460
X1281 1270 1274 1276 2 1 ND2S $T=301940 679280 0 0 $X=301940 $Y=678900
X1282 1296 1263 1276 2 1 ND2S $T=310000 669200 1 180 $X=308140 $Y=668820
X1283 1322 1327 99 2 1 ND2S $T=318060 628880 0 0 $X=318060 $Y=628500
X1284 1345 1342 1346 2 1 ND2S $T=324880 628880 1 0 $X=324880 $Y=623460
X1285 1345 1328 131 2 1 ND2S $T=325500 628880 0 0 $X=325500 $Y=628500
X1286 1534 1535 1521 2 1 ND2S $T=391840 618800 0 180 $X=389980 $Y=613380
X1287 1558 1554 1323 2 1 ND2S $T=400520 699440 0 180 $X=398660 $Y=694020
X1288 213 1571 1560 2 1 ND2S $T=404240 699440 1 0 $X=404240 $Y=694020
X1289 241 243 245 2 1 ND2S $T=440200 699440 1 0 $X=440200 $Y=694020
X1290 1883 1888 1730 2 1 ND2S $T=498480 649040 1 180 $X=496620 $Y=648660
X1291 1897 1884 1892 2 1 ND2S $T=499720 659120 0 0 $X=499720 $Y=658740
X1292 1947 1942 1925 2 1 ND2S $T=515220 689360 0 180 $X=513360 $Y=683940
X1293 2363 2334 336 2 1 ND2S $T=686340 628880 1 180 $X=684480 $Y=628500
X1294 524 513 2433 2 1 ND2S $T=711140 628880 0 0 $X=711140 $Y=628500
X1295 2572 2575 2499 2 1 ND2S $T=755780 618800 1 0 $X=755780 $Y=613380
X1296 2609 2616 2602 2 1 ND2S $T=767560 618800 1 0 $X=767560 $Y=613380
X1297 2810 2830 2817 2 1 ND2S $T=840100 608720 0 180 $X=838240 $Y=603300
X1298 2846 2852 718 2 1 ND2S $T=848160 628880 0 180 $X=846300 $Y=623460
X1299 2859 2867 625 2 1 ND2S $T=852500 628880 0 180 $X=850640 $Y=623460
X1300 2874 2869 613 2 1 ND2S $T=854360 638960 1 180 $X=852500 $Y=638580
X1301 3014 3013 3007 2 1 ND2S $T=912640 628880 0 180 $X=910780 $Y=623460
X1302 3076 3079 3029 2 1 ND2S $T=946120 618800 1 180 $X=944260 $Y=618420
X1303 3165 3163 883 2 1 ND2S $T=984560 649040 1 180 $X=982700 $Y=648660
X1304 3199 3202 630 2 1 ND2S $T=1001300 659120 0 180 $X=999440 $Y=653700
X1305 3344 3343 3334 2 1 ND2S $T=1063920 628880 0 180 $X=1062060 $Y=623460
X1306 3354 3359 588 2 1 ND2S $T=1068880 649040 1 0 $X=1068880 $Y=643620
X1307 13 15 1 1066 16 2 1071 19 25 OAI222S $T=230020 699440 1 0 $X=230020 $Y=694020
X1308 327 2361 1 2365 2371 2 2355 2299 513 OAI222S $T=683240 618800 0 0 $X=683240 $Y=618420
X1309 2396 515 1 2371 2382 2 2395 2404 2401 OAI222S $T=704940 628880 1 180 $X=699360 $Y=628500
X1310 635 636 1 637 640 2 641 2628 2599 OAI222S $T=774380 699440 1 0 $X=774380 $Y=694020
X1311 645 635 1 637 643 2 641 2642 2612 OAI222S $T=782440 689360 1 180 $X=776860 $Y=688980
X1312 635 676 1 637 672 2 641 2790 2752 OAI222S $T=826460 689360 1 180 $X=820880 $Y=688980
X1313 635 674 1 637 670 2 641 2794 2776 OAI222S $T=827700 699440 0 180 $X=822120 $Y=694020
X1314 297 1882 2 1907 1 1867 AOI12HS $T=499720 699440 1 0 $X=499720 $Y=694020
X1315 1836 1957 2 1949 1 1967 AOI12HS $T=521420 669200 1 180 $X=517080 $Y=668820
X1316 1851 1971 2 1963 1 1929 AOI12HS $T=523280 689360 0 180 $X=518940 $Y=683940
X1317 1836 1939 2 1966 1 1977 AOI12HS $T=520180 669200 1 0 $X=520180 $Y=663780
X1318 1849 1924 2 1984 1 1950 AOI12HS $T=524520 679280 0 0 $X=524520 $Y=678900
X1319 1557 1711 1711 1557 2 1 1748 MAOI1 $T=452600 669200 0 0 $X=452600 $Y=668820
X1320 2356 519 2 338 1 2397 AN3B2S $T=698740 638960 0 0 $X=698740 $Y=638580
X1321 1036 1033 1 1044 2 1048 OAI12HS $T=223820 669200 1 0 $X=223820 $Y=663780
X1322 1108 1094 1 1118 2 1112 OAI12HS $T=247380 638960 1 0 $X=247380 $Y=633540
X1323 1313 1334 1 1316 2 1270 OAI12HS $T=319920 679280 0 180 $X=316200 $Y=673860
X1324 1740 1582 1 1742 2 1746 OAI12HS $T=452600 659120 0 0 $X=452600 $Y=658740
X1325 1878 1898 1 1908 2 1913 OAI12HS $T=502200 669200 1 0 $X=502200 $Y=663780
X1326 1928 1950 1 1956 2 1860 OAI12HS $T=515220 689360 1 0 $X=515220 $Y=683940
X1327 748 2880 1 2928 2 2943 OAI12HS $T=874200 608720 1 0 $X=874200 $Y=603300
X1328 1119 1097 1 2 INV2 $T=248620 689360 0 180 $X=246760 $Y=683940
X1329 1102 1120 1 2 INV2 $T=252340 679280 0 0 $X=252340 $Y=678900
X1330 1149 1142 1 2 INV2 $T=262880 679280 1 0 $X=262880 $Y=673860
X1331 1105 1143 1 2 INV2 $T=262880 689360 1 0 $X=262880 $Y=683940
X1332 24 1117 1 2 INV2 $T=269080 628880 1 180 $X=267220 $Y=628500
X1333 1125 1164 1 2 INV2 $T=270320 638960 0 0 $X=270320 $Y=638580
X1334 1163 1147 1 2 INV2 $T=272800 628880 0 0 $X=272800 $Y=628500
X1335 1229 1176 1 2 INV2 $T=291400 628880 1 180 $X=289540 $Y=628500
X1336 1230 1183 1 2 INV2 $T=291400 669200 1 180 $X=289540 $Y=668820
X1337 1250 1197 1 2 INV2 $T=293880 679280 1 180 $X=292020 $Y=678900
X1338 327 319 1 2 INV2 $T=547460 628880 1 0 $X=547460 $Y=623460
X1339 2293 474 1 2 INV2 $T=656580 618800 1 180 $X=654720 $Y=618420
X1340 432 423 1 2 INV2 $T=670220 618800 1 180 $X=668360 $Y=618420
X1341 499 497 1 2 INV2 $T=673940 618800 0 180 $X=672080 $Y=613380
X1342 2411 528 1 2 INV2 $T=703700 689360 1 180 $X=701840 $Y=688980
X1343 2421 338 1 2 INV2 $T=706180 638960 0 180 $X=704320 $Y=633540
X1344 2447 171 1 2 INV2 $T=717960 659120 0 180 $X=716100 $Y=653700
X1345 2463 169 1 2 INV2 $T=724780 669200 1 0 $X=724780 $Y=663780
X1346 2470 173 1 2 INV2 $T=728500 669200 0 180 $X=726640 $Y=663780
X1347 2474 143 1 2 INV2 $T=729740 659120 0 0 $X=729740 $Y=658740
X1348 2482 147 1 2 INV2 $T=731600 669200 0 180 $X=729740 $Y=663780
X1349 2511 161 1 2 INV2 $T=739660 659120 1 180 $X=737800 $Y=658740
X1350 2707 134 1 2 INV2 $T=798560 649040 1 180 $X=796700 $Y=648660
X1351 2771 130 1 2 INV2 $T=819640 649040 1 0 $X=819640 $Y=643620
X1352 2779 2834 1 2 INV2 $T=840100 628880 1 0 $X=840100 $Y=623460
X1353 2849 2825 1 2 INV2 $T=846920 649040 1 180 $X=845060 $Y=648660
X1354 2843 2862 1 2 INV2 $T=848160 628880 1 0 $X=848160 $Y=623460
X1355 754 753 1 2 INV2 $T=872960 618800 0 180 $X=871100 $Y=613380
X1356 605 2929 1 2 INV2 $T=877300 649040 1 0 $X=877300 $Y=643620
X1357 2943 2960 1 2 INV2 $T=878540 608720 1 0 $X=878540 $Y=603300
X1358 2963 2967 1 2 INV2 $T=885980 618800 0 0 $X=885980 $Y=618420
X1359 2976 163 1 2 INV2 $T=890940 659120 0 180 $X=889080 $Y=653700
X1360 2972 2966 1 2 INV2 $T=891560 618800 1 0 $X=891560 $Y=613380
X1361 2982 2979 1 2 INV2 $T=894040 699440 0 180 $X=892180 $Y=694020
X1362 2989 172 1 2 INV2 $T=897140 659120 0 180 $X=895280 $Y=653700
X1363 2985 2990 1 2 INV2 $T=896520 628880 1 0 $X=896520 $Y=623460
X1364 2986 2995 1 2 INV2 $T=896520 638960 1 0 $X=896520 $Y=633540
X1365 2997 158 1 2 INV2 $T=900860 638960 1 180 $X=899000 $Y=638580
X1366 3000 168 1 2 INV2 $T=903340 659120 1 180 $X=901480 $Y=658740
X1367 3006 182 1 2 INV2 $T=913880 669200 1 0 $X=913880 $Y=663780
X1368 3016 3021 1 2 INV2 $T=915120 659120 1 0 $X=915120 $Y=653700
X1369 3032 821 1 2 INV2 $T=923180 669200 1 180 $X=921320 $Y=668820
X1370 3012 187 1 2 INV2 $T=923180 659120 0 0 $X=923180 $Y=658740
X1371 617 3113 1 2 INV2 $T=962240 618800 0 0 $X=962240 $Y=618420
X1372 3204 3231 1 2 INV2 $T=1009360 649040 0 0 $X=1009360 $Y=648660
X1373 3206 3227 1 2 INV2 $T=1009980 659120 0 0 $X=1009980 $Y=658740
X1374 914 919 1 2 INV2 $T=1016180 608720 1 0 $X=1016180 $Y=603300
X1375 3220 3245 1 2 INV2 $T=1016800 649040 0 0 $X=1016800 $Y=648660
X1376 3266 3278 1 2 INV2 $T=1033540 618800 0 180 $X=1031680 $Y=613380
X1377 3263 3281 1 2 INV2 $T=1034160 608720 0 0 $X=1034160 $Y=608340
X1378 1102 2 1097 1 1053 NR2P $T=243040 679280 1 0 $X=243040 $Y=673860
X1379 1179 2 1176 1 1139 NR2P $T=270320 638960 1 0 $X=270320 $Y=633540
X1380 1179 2 1180 1 1168 NR2P $T=272800 638960 0 0 $X=272800 $Y=638580
X1381 1175 2 1183 1 1069 NR2P $T=274040 679280 1 0 $X=274040 $Y=673860
X1382 105 2 107 1 1275 NR2P $T=311240 638960 0 0 $X=311240 $Y=638580
X1383 109 2 107 1 1299 NR2P $T=316200 638960 0 0 $X=316200 $Y=638580
X1384 109 2 126 1 1282 NR2P $T=328600 669200 1 0 $X=328600 $Y=663780
X1385 109 2 136 1 1331 NR2P $T=329840 659120 0 0 $X=329840 $Y=658740
X1386 122 2 139 1 1754 NR2P $T=454460 689360 1 0 $X=454460 $Y=683940
X1387 724 2 572 1 728 NR2P $T=848160 608720 1 0 $X=848160 $Y=603300
X1388 2968 2 2886 1 2963 NR2P $T=884740 628880 1 0 $X=884740 $Y=623460
X1389 2968 2 2834 1 2986 NR2P $T=896520 638960 0 180 $X=892800 $Y=633540
X1390 2883 2 2981 1 2984 NR2P $T=894660 638960 0 0 $X=894660 $Y=638580
X1391 616 2 896 1 3190 NR2P $T=996960 618800 0 0 $X=996960 $Y=618420
X1392 724 2 896 1 900 NR2P $T=998200 608720 1 0 $X=998200 $Y=603300
X1393 3255 2 3231 1 3258 NR2P $T=1027960 649040 1 180 $X=1024240 $Y=648660
X1394 3227 2 3259 1 3267 NR2P $T=1030440 659120 1 180 $X=1026720 $Y=658740
X1395 3255 2 3245 1 3275 NR2P $T=1031680 649040 1 180 $X=1027960 $Y=648660
X1396 330 301 1 2 INV12CK $T=549320 649040 0 180 $X=539400 $Y=643620
X1397 99 1346 1 2 BUF2CK $T=338520 628880 1 0 $X=338520 $Y=623460
X1398 525 2408 1 2 BUF2CK $T=699360 679280 0 0 $X=699360 $Y=678900
X1399 1820 1 2 1826 BUF1CK $T=484220 618800 1 0 $X=484220 $Y=613380
X1400 2041 1 2 2045 BUF1CK $T=553660 649040 0 0 $X=553660 $Y=648660
X1401 2038 1 2 2037 BUF1CK $T=553660 659120 0 0 $X=553660 $Y=658740
X1402 2031 1 2 2036 BUF1CK $T=553660 689360 0 0 $X=553660 $Y=688980
X1403 2087 1 2 2094 BUF1CK $T=572880 689360 0 0 $X=572880 $Y=688980
X1404 2090 1 2 2110 BUF1CK $T=577220 628880 1 0 $X=577220 $Y=623460
X1405 2026 1 2 2124 BUF1CK $T=590240 608720 0 0 $X=590240 $Y=608340
X1406 2137 1 2 2141 BUF1CK $T=590240 689360 0 0 $X=590240 $Y=688980
X1407 406 1 2 2176 BUF1CK $T=608840 679280 0 0 $X=608840 $Y=678900
X1408 411 1 2 2201 BUF1CK $T=612560 669200 1 0 $X=612560 $Y=663780
X1409 2062 1 2 2202 BUF1CK $T=613180 628880 1 0 $X=613180 $Y=623460
X1410 2220 1 2 430 BUF1CK $T=623100 689360 1 0 $X=623100 $Y=683940
X1411 2248 1 2 2251 BUF1CK $T=634260 669200 0 0 $X=634260 $Y=668820
X1412 2336 1 2 2291 BUF1CK $T=672080 649040 0 0 $X=672080 $Y=648660
X1413 2315 1 2 2357 BUF1CK $T=680760 669200 0 0 $X=680760 $Y=668820
X1414 2360 1 2 2366 BUF1CK $T=682620 669200 1 0 $X=682620 $Y=663780
X1415 2377 1 2 2381 BUF1CK $T=688820 679280 1 0 $X=688820 $Y=673860
X1416 2383 1 2 2386 BUF1CK $T=690680 659120 0 0 $X=690680 $Y=658740
X1417 503 1 2 2393 BUF1CK $T=693780 649040 1 0 $X=693780 $Y=643620
X1418 2409 1 2 2410 BUF1CK $T=701220 659120 0 0 $X=701220 $Y=658740
X1419 2423 1 2 2418 BUF1CK $T=706800 638960 1 0 $X=706800 $Y=633540
X1420 536 1 2 2439 BUF1CK $T=711760 679280 1 0 $X=711760 $Y=673860
X1421 2444 1 2 2426 BUF1CK $T=716100 638960 0 0 $X=716100 $Y=638580
X1422 2439 1 2 2441 BUF1CK $T=717960 679280 1 0 $X=717960 $Y=673860
X1423 2604 1 2 2586 BUF1CK $T=768180 679280 0 0 $X=768180 $Y=678900
X1424 2643 1 2 2647 BUF1CK $T=778720 679280 1 0 $X=778720 $Y=673860
X1425 766 1 2 2946 BUF1CK $T=881020 669200 1 0 $X=881020 $Y=663780
X1426 759 1 2 2941 BUF1CK $T=882880 659120 1 0 $X=882880 $Y=653700
X1427 1052 1 2 1047 BUF1S $T=228160 649040 1 0 $X=228160 $Y=643620
X1428 1034 1 2 1072 BUF1S $T=231880 608720 0 0 $X=231880 $Y=608340
X1429 1062 1 2 1030 BUF1S $T=233120 638960 0 0 $X=233120 $Y=638580
X1430 31 1 2 1135 BUF1S $T=257300 608720 0 0 $X=257300 $Y=608340
X1431 47 1 2 1193 BUF1S $T=280860 608720 1 0 $X=280860 $Y=603300
X1432 1716 1 2 1735 BUF1S $T=446400 689360 1 0 $X=446400 $Y=683940
X1433 1715 1 2 1705 BUF1S $T=450740 659120 1 180 $X=448260 $Y=658740
X1434 251 1 2 1768 BUF1S $T=463760 608720 1 0 $X=463760 $Y=603300
X1435 1847 1 2 1881 BUF1S $T=494760 679280 0 0 $X=494760 $Y=678900
X1436 1848 1 2 1912 BUF1S $T=503440 628880 0 0 $X=503440 $Y=628500
X1437 1873 1 2 1915 BUF1S $T=504060 638960 0 0 $X=504060 $Y=638580
X1438 1879 1 2 1918 BUF1S $T=512120 669200 1 180 $X=509640 $Y=668820
X1439 1901 1 2 1944 BUF1S $T=512120 679280 1 0 $X=512120 $Y=673860
X1440 1865 1 2 1955 BUF1S $T=515220 659120 1 0 $X=515220 $Y=653700
X1441 1891 1 2 1952 BUF1S $T=518320 649040 0 0 $X=518320 $Y=648660
X1442 1844 1 2 1979 BUF1S $T=522040 679280 0 0 $X=522040 $Y=678900
X1443 335 1 2 2028 BUF1S $T=549940 669200 1 0 $X=549940 $Y=663780
X1444 2028 1 2 2031 BUF1S $T=553040 679280 0 0 $X=553040 $Y=678900
X1445 351 1 2 2068 BUF1S $T=562960 638960 0 0 $X=562960 $Y=638580
X1446 2068 1 2 2042 BUF1S $T=564820 659120 0 0 $X=564820 $Y=658740
X1447 2252 1 2 2256 BUF1S $T=636120 689360 0 0 $X=636120 $Y=688980
X1448 2440 1 2 2433 BUF1S $T=713000 628880 0 0 $X=713000 $Y=628500
X1449 529 1 2 2371 BUF1S $T=717960 628880 1 180 $X=715480 $Y=628500
X1450 2402 1 2 2401 BUF1S $T=717960 628880 0 0 $X=717960 $Y=628500
X1451 2430 1 2 555 BUF1S $T=718580 608720 1 0 $X=718580 $Y=603300
X1452 2430 1 2 2448 BUF1S $T=722920 618800 0 0 $X=722920 $Y=618420
X1453 529 1 2 2465 BUF1S $T=729120 659120 1 180 $X=726640 $Y=658740
X1454 2440 1 2 2469 BUF1S $T=728500 628880 0 0 $X=728500 $Y=628500
X1455 2886 1 2 2919 BUF1S $T=868620 628880 0 0 $X=868620 $Y=628500
X1456 2883 1 2 2915 BUF1S $T=872340 638960 0 0 $X=872340 $Y=638580
X1457 823 1 2 3033 BUF1S $T=923180 689360 1 0 $X=923180 $Y=683940
X1458 3222 1 2 908 BUF1S $T=1008740 608720 0 0 $X=1008740 $Y=608340
X1459 3239 1 2 3254 BUF1S $T=1020520 618800 1 0 $X=1020520 $Y=613380
X1460 3333 1 2 3360 BUF1S $T=1074460 608720 0 0 $X=1074460 $Y=608340
X1461 37 1 2 45 DELB $T=260400 608720 0 0 $X=260400 $Y=608340
X1462 1987 1 2 320 DELB $T=528240 689360 1 0 $X=528240 $Y=683940
X1463 2043 1 2 345 DELB $T=554900 689360 1 0 $X=554900 $Y=683940
X1464 2060 1 2 2070 DELB $T=561720 679280 0 0 $X=561720 $Y=678900
X1465 2071 1 2 2086 DELB $T=566680 679280 0 0 $X=566680 $Y=678900
X1466 357 1 2 2093 DELB $T=571640 679280 0 0 $X=571640 $Y=678900
X1467 366 1 2 2073 DELB $T=578460 669200 1 0 $X=578460 $Y=663780
X1468 371 1 2 2132 DELB $T=583420 669200 1 0 $X=583420 $Y=663780
X1469 379 1 2 2131 DELB $T=588380 669200 1 0 $X=588380 $Y=663780
X1470 384 1 2 2159 DELB $T=593340 669200 1 0 $X=593340 $Y=663780
X1471 2191 1 2 2192 DELB $T=611940 699440 1 0 $X=611940 $Y=694020
X1472 417 1 2 2113 DELB $T=616280 659120 1 0 $X=616280 $Y=653700
X1473 2229 1 2 2230 DELB $T=636740 679280 0 0 $X=636740 $Y=678900
X1474 2270 1 2 2262 DELB $T=641700 679280 0 0 $X=641700 $Y=678900
X1475 2189 1 2 2276 DELB $T=645420 659120 1 0 $X=645420 $Y=653700
X1476 463 1 2 471 DELB $T=649760 638960 0 0 $X=649760 $Y=638580
X1477 2284 1 2 2279 DELB $T=651620 689360 1 0 $X=651620 $Y=683940
X1478 2171 1 2 2290 DELB $T=653480 649040 1 0 $X=653480 $Y=643620
X1479 454 1 2 477 DELB $T=654100 628880 1 0 $X=654100 $Y=623460
X1480 460 1 2 479 DELB $T=654720 638960 0 0 $X=654720 $Y=638580
X1481 501 1 2 505 DELB $T=673320 649040 1 0 $X=673320 $Y=643620
X1482 2390 1 2 2363 DELB $T=697500 638960 1 0 $X=697500 $Y=633540
X1483 2404 1 2 2478 DELB $T=725400 618800 1 0 $X=725400 $Y=613380
X1484 2479 1 2 2460 DELB $T=738420 659120 1 0 $X=738420 $Y=653700
X1485 2494 1 2 599 DELB $T=741520 689360 1 0 $X=741520 $Y=683940
X1486 2583 1 2 2598 DELB $T=760120 659120 1 0 $X=760120 $Y=653700
X1487 2600 1 2 2594 DELB $T=768800 669200 0 0 $X=768800 $Y=668820
X1488 2664 1 2 2669 DELB $T=784300 659120 0 0 $X=784300 $Y=658740
X1489 2763 1 2 2748 DELB $T=819020 649040 0 0 $X=819020 $Y=648660
X1490 2796 1 2 2800 DELB $T=825220 649040 1 0 $X=825220 $Y=643620
X1491 2884 1 2 2902 DELB $T=856840 679280 0 0 $X=856840 $Y=678900
X1492 2888 1 2 2890 DELB $T=860560 679280 1 0 $X=860560 $Y=673860
X1493 2856 1 2 2876 DELB $T=869860 669200 0 0 $X=869860 $Y=668820
X1494 2931 1 2 768 DELB $T=874200 689360 0 0 $X=874200 $Y=688980
X1495 761 1 2 2945 DELB $T=874820 669200 0 0 $X=874820 $Y=668820
X1496 767 1 2 2950 DELB $T=878540 689360 1 0 $X=878540 $Y=683940
X1497 772 1 2 782 DELB $T=882880 689360 0 0 $X=882880 $Y=688980
X1498 778 1 2 784 DELB $T=885980 689360 1 0 $X=885980 $Y=683940
X1499 790 1 2 794 DELB $T=894040 689360 1 0 $X=894040 $Y=683940
X1500 795 1 2 802 DELB $T=902100 689360 1 0 $X=902100 $Y=683940
X1501 805 1 2 3002 DELB $T=907680 689360 0 0 $X=907680 $Y=688980
X1502 824 1 2 3028 DELB $T=924420 689360 0 0 $X=924420 $Y=688980
X1503 3040 1 2 3056 DELB $T=935580 669200 0 0 $X=935580 $Y=668820
X1504 93 2 1 1383 BUF1 $T=336040 689360 0 0 $X=336040 $Y=688980
X1505 106 2 1 1374 BUF1 $T=337280 679280 1 0 $X=337280 $Y=673860
X1506 105 2 1 1399 BUF1 $T=342240 669200 1 0 $X=342240 $Y=663780
X1507 109 2 1 1400 BUF1 $T=343480 638960 0 0 $X=343480 $Y=638580
X1508 65 2 1 1362 BUF1 $T=346580 669200 1 0 $X=346580 $Y=663780
X1509 93 2 1 1389 BUF1 $T=348440 679280 0 0 $X=348440 $Y=678900
X1510 188 2 1 192 BUF1 $T=383780 659120 0 0 $X=383780 $Y=658740
X1511 66 2 1 1532 BUF1 $T=390600 649040 0 0 $X=390600 $Y=648660
X1512 10 2 1 1214 BUF1 $T=394940 659120 0 180 $X=392460 $Y=653700
X1513 106 2 1 1560 BUF1 $T=396800 689360 1 0 $X=396800 $Y=683940
X1514 109 2 1 1455 BUF1 $T=401140 649040 0 0 $X=401140 $Y=648660
X1515 1292 2 1 1590 BUF1 $T=407960 669200 0 0 $X=407960 $Y=668820
X1516 122 2 1 1756 BUF1 $T=457560 628880 0 0 $X=457560 $Y=628500
X1517 263 2 1 1774 BUF1 $T=466860 689360 1 0 $X=466860 $Y=683940
X1518 293 2 1 283 BUF1 $T=491660 608720 0 180 $X=489180 $Y=603300
X1519 319 2 1 317 BUF1 $T=529480 628880 0 180 $X=527000 $Y=623460
X1520 423 2 1 350 BUF1 $T=621240 628880 1 180 $X=618760 $Y=628500
X1521 432 2 1 346 BUF1 $T=624340 628880 1 180 $X=621860 $Y=628500
X1522 293 2 1 427 BUF1 $T=629920 689360 1 0 $X=629920 $Y=683940
X1523 456 2 1 2033 BUF1 $T=649760 669200 1 180 $X=647280 $Y=668820
X1524 2243 2 1 2034 BUF1 $T=655960 669200 1 0 $X=655960 $Y=663780
X1525 427 2 1 511 BUF1 $T=682620 689360 1 0 $X=682620 $Y=683940
X1526 327 2 1 509 BUF1 $T=685720 628880 1 0 $X=685720 $Y=623460
X1527 588 2 1 2485 BUF1 $T=737800 628880 1 0 $X=737800 $Y=623460
X1528 605 2 1 2557 BUF1 $T=752060 638960 0 0 $X=752060 $Y=638580
X1529 613 2 1 2581 BUF1 $T=757020 638960 0 0 $X=757020 $Y=638580
X1530 616 2 1 2588 BUF1 $T=760120 649040 0 0 $X=760120 $Y=648660
X1531 2602 2 1 2499 BUF1 $T=767560 618800 0 180 $X=765080 $Y=613380
X1532 625 2 1 2611 BUF1 $T=768180 659120 1 0 $X=768180 $Y=653700
X1533 630 2 1 2622 BUF1 $T=770660 638960 0 0 $X=770660 $Y=638580
X1534 629 2 1 2782 BUF1 $T=825220 608720 0 0 $X=825220 $Y=608340
X1535 2947 2 1 2602 BUF1 $T=880400 608720 1 180 $X=877920 $Y=608340
X1536 535 2 1 2983 BUF1 $T=904580 659120 0 180 $X=902100 $Y=653700
X1537 2958 2 1 3003 BUF1 $T=903340 618800 1 0 $X=903340 $Y=613380
X1538 630 2 1 3072 BUF1 $T=940540 669200 0 0 $X=940540 $Y=668820
X1539 613 2 1 3081 BUF1 $T=947980 638960 1 180 $X=945500 $Y=638580
X1540 2970 2 1 928 BUF1 $T=1019900 669200 0 0 $X=1019900 $Y=668820
X1541 3336 2 1 3363 BUF1 $T=1073840 618800 0 0 $X=1073840 $Y=618420
X1542 529 2 1 2853 BUF3 $T=841960 659120 1 0 $X=841960 $Y=653700
X1543 1025 24 1098 2 1092 1117 1 AO22 $T=244900 628880 1 0 $X=244900 $Y=623460
X1544 1089 1117 1121 2 1127 24 1 AO22 $T=252960 618800 1 0 $X=252960 $Y=613380
X1545 52 1117 1159 2 1157 24 1 AO22 $T=269080 618800 1 180 $X=264120 $Y=618420
X1546 1058 1117 1158 2 1163 24 1 AO22 $T=264120 638960 1 0 $X=264120 $Y=633540
X1547 1162 10 1173 2 1167 1081 1 AO22 $T=272180 659120 0 180 $X=267220 $Y=653700
X1548 46 10 1174 2 1169 1081 1 AO22 $T=272800 669200 1 180 $X=267840 $Y=668820
X1549 1156 1117 1178 2 1185 24 1 AO22 $T=271560 608720 0 0 $X=271560 $Y=608340
X1550 67 70 1213 2 1190 24 1 AO22 $T=283960 608720 1 0 $X=283960 $Y=603300
X1551 69 1214 1200 2 1212 1223 1 AO22 $T=284580 649040 1 0 $X=284580 $Y=643620
X1552 100 1214 1272 2 1286 1223 1 AO22 $T=306280 638960 0 0 $X=306280 $Y=638580
X1553 102 70 1301 2 1303 94 1 AO22 $T=310000 608720 1 0 $X=310000 $Y=603300
X1554 110 1214 1300 2 1305 1223 1 AO22 $T=316820 649040 0 180 $X=311860 $Y=643620
X1555 135 70 1347 2 1344 94 1 AO22 $T=329220 608720 0 180 $X=324260 $Y=603300
X1556 144 70 1375 2 1397 94 1 AO22 $T=341000 608720 1 0 $X=341000 $Y=603300
X1557 167 94 165 2 1437 70 1 AO22 $T=355880 608720 1 0 $X=355880 $Y=603300
X1558 1473 188 1454 2 1453 196 1 AO22 $T=372000 659120 0 0 $X=372000 $Y=658740
X1559 190 94 1471 2 1489 192 1 AO22 $T=380060 608720 0 180 $X=375100 $Y=603300
X1560 1501 192 1495 2 1450 196 1 AO22 $T=383160 659120 1 180 $X=378200 $Y=658740
X1561 1504 188 1485 2 1460 196 1 AO22 $T=383160 689360 1 180 $X=378200 $Y=688980
X1562 1512 188 1493 2 1480 196 1 AO22 $T=385020 679280 0 180 $X=380060 $Y=673860
X1563 1513 188 1492 2 1466 196 1 AO22 $T=385640 679280 1 180 $X=380680 $Y=678900
X1564 1540 192 1515 2 1456 196 1 AO22 $T=393080 659120 1 180 $X=388120 $Y=658740
X1565 1542 188 1516 2 206 196 1 AO22 $T=395560 699440 0 180 $X=390600 $Y=694020
X1566 1562 1550 192 2 1449 196 1 AO22 $T=399900 659120 1 180 $X=394940 $Y=658740
X1567 210 1214 1552 2 1494 1518 1 AO22 $T=401760 628880 0 180 $X=396800 $Y=623460
X1568 1581 192 1546 2 1507 94 1 AO22 $T=403620 618800 0 180 $X=398660 $Y=613380
X1569 1568 1545 192 2 1530 94 1 AO22 $T=403620 618800 1 180 $X=398660 $Y=618420
X1570 214 1214 1573 2 1497 1518 1 AO22 $T=407960 628880 0 180 $X=403000 $Y=623460
X1571 1600 192 1592 2 1522 94 1 AO22 $T=412920 618800 0 180 $X=407960 $Y=613380
X1572 230 1214 1605 2 1547 1518 1 AO22 $T=422220 628880 0 180 $X=417260 $Y=623460
X1573 234 1214 1616 2 1556 1518 1 AO22 $T=422220 628880 1 180 $X=417260 $Y=628500
X1574 1628 192 1619 2 1527 94 1 AO22 $T=422840 618800 0 180 $X=417880 $Y=613380
X1575 1646 1636 1214 2 1561 1518 1 AO22 $T=428420 618800 1 180 $X=423460 $Y=618420
X1576 1653 1214 1631 2 1566 1518 1 AO22 $T=429660 628880 1 180 $X=424700 $Y=628500
X1577 1674 238 1656 2 1638 209 1 AO22 $T=436480 679280 0 180 $X=431520 $Y=673860
X1578 1676 238 1626 2 1633 209 1 AO22 $T=437100 679280 1 180 $X=432140 $Y=678900
X1579 1684 1214 1666 2 1585 1518 1 AO22 $T=438960 628880 1 180 $X=434000 $Y=628500
X1580 1686 238 1657 2 1639 209 1 AO22 $T=438960 689360 0 180 $X=434000 $Y=683940
X1581 244 238 240 2 239 209 1 AO22 $T=440200 699440 0 180 $X=435240 $Y=694020
X1582 1700 1214 1665 2 1580 1518 1 AO22 $T=441440 618800 1 180 $X=436480 $Y=618420
X1583 1706 1214 1698 2 1663 1518 1 AO22 $T=443300 628880 0 180 $X=438340 $Y=623460
X1584 1733 1214 1687 2 1651 1518 1 AO22 $T=445780 628880 1 180 $X=440820 $Y=628500
X1585 1717 1214 1701 2 1679 1518 1 AO22 $T=446400 649040 1 180 $X=441440 $Y=648660
X1586 1718 238 1691 2 1659 209 1 AO22 $T=446400 659120 1 180 $X=441440 $Y=658740
X1587 1741 1214 1690 2 1668 1518 1 AO22 $T=447020 649040 0 180 $X=442060 $Y=643620
X1588 1729 1721 1214 2 1643 1518 1 AO22 $T=448260 618800 1 180 $X=443300 $Y=618420
X1589 1810 285 1784 2 1775 278 1 AO22 $T=482360 618800 0 180 $X=477400 $Y=613380
X1590 1849 285 1840 2 1812 278 1 AO22 $T=491660 689360 0 180 $X=486700 $Y=683940
X1591 1856 285 1846 2 1827 278 1 AO22 $T=493520 638960 1 180 $X=488560 $Y=638580
X1592 1876 285 1861 2 1828 278 1 AO22 $T=496620 649040 1 180 $X=491660 $Y=648660
X1593 1877 285 1864 2 1832 278 1 AO22 $T=496620 659120 1 180 $X=491660 $Y=658740
X1594 1894 285 1839 2 1823 278 1 AO22 $T=497240 628880 0 180 $X=492280 $Y=623460
X1595 308 286 310 2 313 317 1 AO22 $T=522660 638960 1 0 $X=522660 $Y=633540
X1596 2204 350 2203 2 421 346 1 AO22 $T=615660 628880 1 0 $X=615660 $Y=623460
X1597 584 2485 2508 2 2513 2499 1 AO22 $T=737180 618800 0 0 $X=737180 $Y=618420
X1598 597 2499 2522 2 2517 2485 1 AO22 $T=744620 618800 0 180 $X=739660 $Y=613380
X1599 638 2485 2634 2 2651 2602 1 AO22 $T=776860 618800 1 0 $X=776860 $Y=613380
X1600 650 2485 2676 2 2677 2602 1 AO22 $T=785540 618800 1 0 $X=785540 $Y=613380
X1601 661 2485 2711 2 2721 2602 1 AO22 $T=797940 618800 0 0 $X=797940 $Y=618420
X1602 664 2485 2720 2 2728 2602 1 AO22 $T=799180 618800 1 0 $X=799180 $Y=613380
X1603 685 588 2777 2 2785 2602 1 AO22 $T=819640 618800 1 0 $X=819640 $Y=613380
X1604 693 2602 2804 2 2818 588 1 AO22 $T=832660 608720 0 0 $X=832660 $Y=608340
X1605 707 588 2838 2 2819 2602 1 AO22 $T=840100 608720 0 0 $X=840100 $Y=608340
X1606 727 2602 2857 2 2854 588 1 AO22 $T=852500 608720 1 180 $X=847540 $Y=608340
X1607 2792 2850 730 2 732 2853 1 AO22 $T=852500 649040 1 0 $X=852500 $Y=643620
X1608 740 588 2917 2 2914 2602 1 AO22 $T=867380 608720 0 0 $X=867380 $Y=608340
X1609 756 588 2933 2 2926 2602 1 AO22 $T=872960 608720 0 0 $X=872960 $Y=608340
X1610 773 2958 2948 2 2944 2947 1 AO22 $T=884740 628880 1 180 $X=879780 $Y=628500
X1611 776 2958 2971 2 2938 2947 1 AO22 $T=887220 628880 0 0 $X=887220 $Y=628500
X1612 786 2947 2985 2 2991 588 1 AO22 $T=894660 618800 1 0 $X=894660 $Y=613380
X1613 787 2958 2987 2 2986 2947 1 AO22 $T=894660 628880 0 0 $X=894660 $Y=628500
X1614 822 3003 3030 2 3036 3029 1 AO22 $T=921940 618800 1 0 $X=921940 $Y=613380
X1615 887 3003 3158 2 3150 3140 1 AO22 $T=984560 628880 0 180 $X=979600 $Y=623460
X1616 889 3003 3174 2 3169 3140 1 AO22 $T=987040 628880 1 0 $X=987040 $Y=623460
X1617 902 3003 3203 2 3194 3140 1 AO22 $T=1002540 628880 1 0 $X=1002540 $Y=623460
X1618 903 3003 3213 2 3193 3140 1 AO22 $T=1003160 618800 0 0 $X=1003160 $Y=618420
X1619 920 588 3236 2 3208 3140 1 AO22 $T=1021140 628880 0 180 $X=1016180 $Y=623460
X1620 916 588 3247 2 3249 3140 1 AO22 $T=1018040 618800 0 0 $X=1018040 $Y=618420
X1621 926 588 3282 2 3262 3289 1 AO22 $T=1036020 638960 1 0 $X=1036020 $Y=633540
X1622 3279 588 3280 2 3267 3289 1 AO22 $T=1036020 659120 1 0 $X=1036020 $Y=653700
X1623 930 3289 3244 2 3298 588 1 AO22 $T=1041600 628880 0 0 $X=1041600 $Y=628500
X1624 3320 588 3312 2 3234 3289 1 AO22 $T=1054620 628880 0 180 $X=1049660 $Y=623460
X1625 939 588 3318 2 3241 3289 1 AO22 $T=1055860 669200 0 180 $X=1050900 $Y=663780
X1626 3342 588 3326 2 3235 3289 1 AO22 $T=1063300 638960 1 180 $X=1058340 $Y=638580
X1627 3346 588 3339 2 3275 3289 1 AO22 $T=1064540 649040 1 180 $X=1059580 $Y=648660
X1628 946 3289 3252 2 3351 588 1 AO22 $T=1063920 659120 1 0 $X=1063920 $Y=653700
X1629 950 588 3358 2 3225 3289 1 AO22 $T=1068260 628880 1 0 $X=1068260 $Y=623460
X1630 3335 771 3253 2 3366 923 1 AO22 $T=1076320 618800 0 0 $X=1076320 $Y=618420
X1631 1120 1119 1113 1114 2 1 MXL2HS $T=253580 679280 0 180 $X=248000 $Y=673860
X1632 1366 1358 1357 1368 2 1 MXL2HS $T=333560 649040 1 0 $X=333560 $Y=643620
X1633 1537 1523 1536 1531 2 1 MXL2HS $T=396800 628880 1 180 $X=391220 $Y=628500
X1634 1533 1517 1543 1551 2 1 MXL2HS $T=393700 679280 0 0 $X=393700 $Y=678900
X1635 1738 1735 1745 1748 2 1 MXL2HS $T=451980 679280 1 0 $X=451980 $Y=673860
X1636 1929 1935 1895 1948 2 1 MXL2HS $T=510880 689360 0 0 $X=510880 $Y=688980
X1637 1967 1934 1973 1977 2 1 MXL2HS $T=521420 669200 0 0 $X=521420 $Y=668820
X1638 2501 2502 2509 2516 2 1 MXL2HS $T=735940 638960 0 0 $X=735940 $Y=638580
X1639 2889 2882 2903 2899 2 1 MXL2HS $T=859940 618800 1 0 $X=859940 $Y=613380
X1640 3023 535 3015 808 2 1 MXL2HS $T=917600 649040 0 180 $X=912020 $Y=643620
X1641 3019 535 3027 817 2 1 MXL2HS $T=923180 659120 1 180 $X=917600 $Y=658740
X1642 825 2983 3031 820 2 1 MXL2HS $T=926280 649040 1 180 $X=920700 $Y=648660
X1643 826 829 3040 3043 2 1 MXL2HS $T=925040 699440 1 0 $X=925040 $Y=694020
X1644 3369 3367 3354 3365 2 1 MXL2HS $T=1083140 649040 1 180 $X=1077560 $Y=648660
X1645 2125 1 2 2247 DELA $T=629920 659120 0 0 $X=629920 $Y=658740
X1646 2136 1 2 2240 DELA $T=634260 659120 1 0 $X=634260 $Y=653700
X1647 502 1 2 2349 DELA $T=673940 699440 1 0 $X=673940 $Y=694020
X1648 2529 1 2 2503 DELA $T=743380 659120 1 0 $X=743380 $Y=653700
X1649 2487 1 2 2456 DELA $T=748340 659120 1 0 $X=748340 $Y=653700
X1650 2548 1 2 2539 DELA $T=760740 618800 0 0 $X=760740 $Y=618420
X1651 2547 1 2 2554 DELA $T=763840 669200 0 0 $X=763840 $Y=668820
X1652 2504 1 2 2490 DELA $T=768800 638960 1 0 $X=768800 $Y=633540
X1653 2705 1 2 2703 DELA $T=797320 689360 1 0 $X=797320 $Y=683940
X1654 775 1 2 2965 DELA $T=885360 679280 1 0 $X=885360 $Y=673860
X1655 788 1 2 2994 DELA $T=893420 679280 1 0 $X=893420 $Y=673860
X1656 804 1 2 810 DELA $T=907060 689360 1 0 $X=907060 $Y=683940
X1657 831 1 2 3037 DELA $T=927520 679280 0 0 $X=927520 $Y=678900
X1658 267 270 283 2 1 288 QDFFRBN $T=471820 608720 1 0 $X=471820 $Y=603300
X1659 304 270 283 2 1 309 QDFFRBN $T=512120 608720 1 0 $X=512120 $Y=603300
X1660 1954 301 314 2 1 1972 QDFFRBN $T=517700 638960 0 0 $X=517700 $Y=638580
X1661 1958 301 314 2 1 1990 QDFFRBN $T=517700 649040 1 0 $X=517700 $Y=643620
X1662 1959 301 315 2 1 1986 QDFFRBN $T=517700 659120 1 0 $X=517700 $Y=653700
X1663 1964 301 314 2 1 1975 QDFFRBN $T=518320 608720 0 0 $X=518320 $Y=608340
X1664 1965 301 314 2 1 1969 QDFFRBN $T=518320 628880 0 0 $X=518320 $Y=628500
X1665 1998 1993 314 2 1 1978 QDFFRBN $T=536300 618800 0 180 $X=524520 $Y=613380
X1666 1923 301 315 2 1 1995 QDFFRBN $T=524520 669200 1 0 $X=524520 $Y=663780
X1667 1920 301 315 2 1 2004 QDFFRBN $T=527620 699440 1 0 $X=527620 $Y=694020
X1668 323 270 283 2 1 312 QDFFRBN $T=540020 608720 0 180 $X=528240 $Y=603300
X1669 2007 301 315 2 1 1988 QDFFRBN $T=541260 669200 1 180 $X=529480 $Y=668820
X1670 1919 301 315 2 1 2009 QDFFRBN $T=530100 679280 0 0 $X=530100 $Y=678900
X1671 1981 1993 314 2 1 2013 QDFFRBN $T=531960 608720 0 0 $X=531960 $Y=608340
X1672 1996 1993 314 2 1 2015 QDFFRBN $T=533200 618800 0 0 $X=533200 $Y=618420
X1673 2002 1993 314 2 1 2025 QDFFRBN $T=536920 618800 1 0 $X=536920 $Y=613380
X1674 2017 301 315 2 1 1994 QDFFRBN $T=549940 689360 0 180 $X=538160 $Y=683940
X1675 1999 1993 315 2 1 2000 QDFFRBN $T=540640 659120 1 0 $X=540640 $Y=653700
X1676 2003 1993 314 2 1 2038 QDFFRBN $T=541880 649040 0 0 $X=541880 $Y=648660
X1677 2018 1993 314 2 1 2048 QDFFRBN $T=546220 618800 0 0 $X=546220 $Y=618420
X1678 2020 328 315 2 1 2043 QDFFRBN $T=546220 699440 1 0 $X=546220 $Y=694020
X1679 2027 1993 314 2 1 1976 QDFFRBN $T=548080 628880 0 0 $X=548080 $Y=628500
X1680 1989 1993 314 2 1 2056 QDFFRBN $T=549320 649040 1 0 $X=549320 $Y=643620
X1681 1974 1993 314 2 1 2061 QDFFRBN $T=551180 638960 0 0 $X=551180 $Y=638580
X1682 2040 1993 315 2 1 2069 QDFFRBN $T=553660 659120 1 0 $X=553660 $Y=653700
X1683 2035 1993 314 2 1 2041 QDFFRBN $T=556140 649040 0 0 $X=556140 $Y=648660
X1684 2052 1993 314 2 1 2050 QDFFRBN $T=558000 618800 0 0 $X=558000 $Y=618420
X1685 344 328 315 2 1 353 QDFFRBN $T=558000 699440 1 0 $X=558000 $Y=694020
X1686 1936 1993 314 2 1 2084 QDFFRBN $T=559860 628880 0 0 $X=559860 $Y=628500
X1687 2058 1993 314 2 1 2088 QDFFRBN $T=561100 649040 1 0 $X=561100 $Y=643620
X1688 2059 328 315 2 1 359 QDFFRBN $T=561100 689360 0 0 $X=561100 $Y=688980
X1689 2024 1993 314 2 1 2091 QDFFRBN $T=561720 638960 1 0 $X=561720 $Y=633540
X1690 2072 328 315 2 1 2112 QDFFRBN $T=566680 689360 1 0 $X=566680 $Y=683940
X1691 2044 1993 314 2 1 2080 QDFFRBN $T=567300 618800 1 0 $X=567300 $Y=613380
X1692 2138 328 315 2 1 363 QDFFRBN $T=588380 679280 1 180 $X=576600 $Y=678900
X1693 2146 328 315 2 1 369 QDFFRBN $T=593340 689360 0 180 $X=581560 $Y=683940
X1694 2157 328 293 2 1 406 QDFFRBN $T=597060 679280 0 0 $X=597060 $Y=678900
X1695 2192 328 293 2 1 2218 QDFFRBN $T=611320 679280 0 0 $X=611320 $Y=678900
X1696 2197 328 427 2 1 2220 QDFFRBN $T=612560 679280 1 0 $X=612560 $Y=673860
X1697 2222 328 427 2 1 448 QDFFRBN $T=624960 679280 0 0 $X=624960 $Y=678900
X1698 2230 328 427 2 1 446 QDFFRBN $T=626200 679280 1 0 $X=626200 $Y=673860
X1699 2256 328 427 2 1 464 QDFFRBN $T=636120 689360 1 0 $X=636120 $Y=683940
X1700 2262 328 427 2 1 468 QDFFRBN $T=638600 679280 1 0 $X=638600 $Y=673860
X1701 2286 2283 427 2 1 454 QDFFRBN $T=654100 628880 0 180 $X=642320 $Y=623460
X1702 2289 2283 427 2 1 2271 QDFFRBN $T=654720 618800 1 180 $X=642940 $Y=618420
X1703 2298 301 427 2 1 2239 QDFFRBN $T=658440 618800 0 180 $X=646660 $Y=613380
X1704 2295 2283 427 2 1 463 QDFFRBN $T=659060 628880 1 180 $X=647280 $Y=628500
X1705 2296 2283 427 2 1 460 QDFFRBN $T=659060 638960 0 180 $X=647280 $Y=633540
X1706 2269 301 427 2 1 2304 QDFFRBN $T=649140 608720 0 0 $X=649140 $Y=608340
X1707 2279 328 427 2 1 482 QDFFRBN $T=649760 679280 0 0 $X=649760 $Y=678900
X1708 2305 2283 427 2 1 2336 QDFFRBN $T=660300 649040 0 0 $X=660300 $Y=648660
X1709 2312 2283 427 2 1 2316 QDFFRBN $T=662160 659120 0 0 $X=662160 $Y=658740
X1710 2318 328 427 2 1 2306 QDFFRBN $T=666500 679280 1 0 $X=666500 $Y=673860
X1711 2329 2283 427 2 1 2332 QDFFRBN $T=667740 638960 1 0 $X=667740 $Y=633540
X1712 2333 328 427 2 1 506 QDFFRBN $T=669600 679280 0 0 $X=669600 $Y=678900
X1713 2337 500 465 2 1 507 QDFFRBN $T=671460 608720 0 0 $X=671460 $Y=608340
X1714 2338 2283 427 2 1 2358 QDFFRBN $T=671460 628880 0 0 $X=671460 $Y=628500
X1715 2343 2283 427 2 1 2354 QDFFRBN $T=673940 659120 0 0 $X=673940 $Y=658740
X1716 504 500 465 2 1 514 QDFFRBN $T=676420 608720 1 0 $X=676420 $Y=603300
X1717 2300 2352 427 2 1 2383 QDFFRBN $T=680140 659120 1 0 $X=680140 $Y=653700
X1718 2359 510 427 2 1 521 QDFFRBN $T=682620 679280 0 0 $X=682620 $Y=678900
X1719 2357 2352 427 2 1 2377 QDFFRBN $T=683240 669200 0 0 $X=683240 $Y=668820
X1720 2362 510 511 2 1 522 QDFFRBN $T=683860 699440 1 0 $X=683860 $Y=694020
X1721 2367 2352 427 2 1 2360 QDFFRBN $T=685100 669200 1 0 $X=685100 $Y=663780
X1722 2380 510 511 2 1 483 QDFFRBN $T=690060 689360 0 0 $X=690060 $Y=688980
X1723 2385 2352 427 2 1 2409 QDFFRBN $T=691920 659120 1 0 $X=691920 $Y=653700
X1724 2393 2352 427 2 1 2423 QDFFRBN $T=696260 649040 1 0 $X=696260 $Y=643620
X1725 2399 2352 427 2 1 2427 QDFFRBN $T=697500 669200 1 0 $X=697500 $Y=663780
X1726 2414 2352 427 2 1 2436 QDFFRBN $T=703700 659120 0 0 $X=703700 $Y=658740
X1727 2417 2352 427 2 1 2444 QDFFRBN $T=704320 638960 0 0 $X=704320 $Y=638580
X1728 541 301 511 2 1 2411 QDFFRBN $T=717960 689360 1 180 $X=706180 $Y=688980
X1729 2425 2352 427 2 1 2453 QDFFRBN $T=708660 649040 1 0 $X=708660 $Y=643620
X1730 560 301 511 2 1 2434 QDFFRBN $T=726020 679280 1 180 $X=714240 $Y=678900
X1731 542 546 511 2 1 566 QDFFRBN $T=716100 699440 1 0 $X=716100 $Y=694020
X1732 2456 546 511 2 1 2484 QDFFRBN $T=720440 679280 1 0 $X=720440 $Y=673860
X1733 2460 546 511 2 1 2494 QDFFRBN $T=722920 689360 1 0 $X=722920 $Y=683940
X1734 2490 546 511 2 1 2531 QDFFRBN $T=732840 669200 1 0 $X=732840 $Y=663780
X1735 2539 546 511 2 1 2556 QDFFRBN $T=745860 669200 1 0 $X=745860 $Y=663780
X1736 2554 546 511 2 1 2589 QDFFRBN $T=750820 659120 0 0 $X=750820 $Y=658740
X1737 2594 546 511 2 1 2630 QDFFRBN $T=762600 659120 0 0 $X=762600 $Y=658740
X1738 2712 663 657 2 1 2664 QDFFRBN $T=801040 659120 1 180 $X=789260 $Y=658740
X1739 2724 663 657 2 1 2705 QDFFRBN $T=801040 659120 0 0 $X=801040 $Y=658740
X1740 2748 663 657 2 1 2765 QDFFRBN $T=810960 669200 1 0 $X=810960 $Y=663780
X1741 2800 663 657 2 1 2788 QDFFRBN $T=827080 669200 1 0 $X=827080 $Y=663780
X1742 2876 663 657 2 1 698 QDFFRBN $T=854980 669200 1 0 $X=854980 $Y=663780
X1743 2890 663 657 2 1 699 QDFFRBN $T=858080 669200 0 0 $X=858080 $Y=668820
X1744 2902 663 657 2 1 717 QDFFRBN $T=861800 679280 0 0 $X=861800 $Y=678900
X1745 2950 663 657 2 1 704 QDFFRBN $T=878540 699440 1 0 $X=878540 $Y=694020
X1746 2965 781 657 2 1 2993 QDFFRBN $T=884740 669200 1 0 $X=884740 $Y=663780
X1747 798 781 657 2 1 2982 QDFFRBN $T=906440 699440 0 180 $X=894660 $Y=694020
X1748 801 781 657 2 1 2980 QDFFRBN $T=907680 689360 1 180 $X=895900 $Y=688980
X1749 793 781 657 2 1 2998 QDFFRBN $T=898380 679280 1 0 $X=898380 $Y=673860
X1750 2994 781 657 2 1 3004 QDFFRBN $T=898380 679280 0 0 $X=898380 $Y=678900
X1751 3002 781 657 2 1 3020 QDFFRBN $T=904580 669200 0 0 $X=904580 $Y=668820
X1752 3028 781 657 2 1 3005 QDFFRBN $T=921940 699440 0 180 $X=910160 $Y=694020
X1753 3033 781 657 2 1 3011 QDFFRBN $T=924420 689360 1 180 $X=912640 $Y=688980
X1754 3037 781 657 2 1 3010 QDFFRBN $T=926900 679280 0 180 $X=915120 $Y=673860
X1755 828 781 657 2 1 3017 QDFFRBN $T=927520 679280 1 180 $X=915740 $Y=678900
X1756 3056 781 657 2 1 3032 QDFFRBN $T=935580 669200 1 180 $X=923800 $Y=668820
X1757 2376 301 465 2429 1 2 QDFFRBP $T=698740 628880 1 0 $X=698740 $Y=623460
X1758 2478 301 427 2440 1 2 QDFFRBP $T=736560 628880 0 180 $X=724160 $Y=623460
X1759 2413 1 2 529 BUF12CK $T=701220 608720 0 0 $X=701220 $Y=608340
X1760 2412 1 2 535 BUF12CK $T=706180 608720 1 0 $X=706180 $Y=603300
X1761 3021 1 2 136 BUF12CK $T=916980 659120 1 0 $X=916980 $Y=653700
X1762 91 1215 1 2 BUF2 $T=293880 689360 0 180 $X=290780 $Y=683940
X1763 1292 207 1 2 BUF2 $T=386260 689360 0 0 $X=386260 $Y=688980
X1764 283 314 1 2 BUF2 $T=544980 608720 0 180 $X=541880 $Y=603300
X1765 319 336 1 2 BUF2 $T=550560 628880 1 0 $X=550560 $Y=623460
X1766 293 465 1 2 BUF2 $T=642940 608720 0 0 $X=642940 $Y=608340
X1767 537 2435 1 2 BUF2 $T=711760 699440 1 0 $X=711760 $Y=694020
X1768 611 629 1 2 BUF2 $T=766320 618800 0 0 $X=766320 $Y=618420
X1769 615 813 1 2 BUF2 $T=906440 608720 1 0 $X=906440 $Y=603300
X1770 3310 3356 1 2 BUF2 $T=1073220 628880 1 0 $X=1073220 $Y=623460
X1771 2430 2850 1 2 BUF6 $T=843820 649040 1 0 $X=843820 $Y=643620
X1772 3024 146 1 2 BUF6 $T=921320 669200 1 0 $X=921320 $Y=663780
X1773 96 1292 1 2 INV3 $T=305040 689360 0 0 $X=305040 $Y=688980
X1774 2868 2878 1 2 INV3 $T=859940 628880 0 0 $X=859940 $Y=628500
X1775 3015 151 1 2 INV3 $T=914500 659120 0 180 $X=912020 $Y=653700
X1776 3031 152 1 2 INV3 $T=921940 649040 1 0 $X=921940 $Y=643620
X1777 3290 3285 1 2 INV3 $T=1046560 608720 1 0 $X=1046560 $Y=603300
X1778 444 2 446 439 2223 1 2265 FA1S $T=628060 699440 1 0 $X=628060 $Y=694020
X1779 2317 2 482 496 486 1 2303 FA1S $T=660300 699440 1 0 $X=660300 $Y=694020
X1780 2340 2 489 2353 2317 1 2331 FA1S $T=673940 689360 0 0 $X=673940 $Y=688980
X1781 2520 2 580 2532 2523 1 2497 FA1S $T=746480 679280 1 180 $X=734700 $Y=678900
X1782 2562 2 2531 2546 2550 1 2525 FA1S $T=758260 689360 0 180 $X=746480 $Y=683940
X1783 608 2 599 602 2574 1 2512 FA1S $T=759500 699440 0 180 $X=747720 $Y=694020
X1784 2706 2 2703 2693 2682 1 2702 FA1S $T=793600 669200 0 0 $X=793600 $Y=668820
X1785 2845 2 699 711 2858 1 2863 FA1S $T=838860 689360 1 0 $X=838860 $Y=683940
X1786 734 2 717 2861 2906 1 2898 FA1S $T=851880 699440 1 0 $X=851880 $Y=694020
X1787 1168 1164 1160 2 1 XNR2HS $T=272180 649040 1 0 $X=272180 $Y=643620
X1788 59 57 56 2 1 XNR2HS $T=277760 689360 0 180 $X=272180 $Y=683940
X1789 61 57 64 2 1 XNR2HS $T=277760 689360 1 0 $X=277760 $Y=683940
X1790 101 57 104 2 1 XNR2HS $T=308760 689360 0 0 $X=308760 $Y=688980
X1791 1851 1971 1948 2 1 XNR2HS $T=527000 689360 1 180 $X=521420 $Y=688980
X1792 2659 2630 2645 2 1 XNR2HS $T=783060 659120 1 0 $X=783060 $Y=653700
X1793 2660 2669 2674 2 1 XNR2HS $T=783680 669200 1 0 $X=783680 $Y=663780
X1794 2938 2974 2971 2 1 XNR2HS $T=892180 638960 0 180 $X=886600 $Y=633540
X1795 3267 3277 3280 2 1 XNR2HS $T=1032300 659120 0 0 $X=1032300 $Y=658740
X1796 1029 1026 1043 2 1 XOR2HS $T=222580 628880 0 0 $X=222580 $Y=628500
X1797 1047 1040 6 2 1 XOR2HS $T=228160 649040 0 180 $X=222580 $Y=643620
X1798 1050 1046 1040 2 1 XOR2HS $T=229400 649040 1 180 $X=223820 $Y=648660
X1799 1041 1053 1063 2 1 XOR2HS $T=229400 679280 1 0 $X=229400 $Y=673860
X1800 1051 1073 14 2 1 XOR2HS $T=235600 618800 0 180 $X=230020 $Y=613380
X1801 1082 1078 1075 2 1 XOR2HS $T=238700 659120 1 180 $X=233120 $Y=658740
X1802 1089 1087 1073 2 1 XOR2HS $T=241180 618800 0 180 $X=235600 $Y=613380
X1803 1085 1086 1092 2 1 XOR2HS $T=238080 628880 1 0 $X=238080 $Y=623460
X1804 1095 1096 27 2 1 XOR2HS $T=244280 638960 0 0 $X=244280 $Y=638580
X1805 1116 1093 1121 2 1 XOR2HS $T=248620 618800 0 0 $X=248620 $Y=618420
X1806 1107 1111 1099 2 1 XOR2HS $T=249240 659120 0 0 $X=249240 $Y=658740
X1807 1138 1124 1132 2 1 XOR2HS $T=261020 628880 0 180 $X=255440 $Y=623460
X1808 1144 1128 1130 2 1 XOR2HS $T=261640 659120 1 180 $X=256060 $Y=658740
X1809 1143 1142 1134 2 1 XOR2HS $T=261640 679280 0 180 $X=256060 $Y=673860
X1810 1153 1148 1129 2 1 XOR2HS $T=264740 649040 0 180 $X=259160 $Y=643620
X1811 1141 1147 1158 2 1 XOR2HS $T=261640 628880 0 0 $X=261640 $Y=628500
X1812 1171 1154 1159 2 1 XOR2HS $T=270320 628880 0 180 $X=264740 $Y=623460
X1813 1182 1172 1173 2 1 XOR2HS $T=275280 649040 1 180 $X=269700 $Y=648660
X1814 1187 1186 1178 2 1 XOR2HS $T=276520 618800 0 180 $X=270940 $Y=613380
X1815 1181 1165 1174 2 1 XOR2HS $T=272180 659120 0 0 $X=272180 $Y=658740
X1816 1194 1196 1200 2 1 XOR2HS $T=278380 649040 1 0 $X=278380 $Y=643620
X1817 1203 1205 1213 2 1 XOR2HS $T=283340 608720 0 0 $X=283340 $Y=608340
X1818 1216 1207 1224 2 1 XOR2HS $T=285820 649040 0 0 $X=285820 $Y=648660
X1819 1235 1220 80 2 1 XOR2HS $T=294500 608720 0 180 $X=288920 $Y=603300
X1820 1261 1209 1242 2 1 XOR2HS $T=300700 649040 1 180 $X=295120 $Y=648660
X1821 1284 1278 1272 2 1 XOR2HS $T=306900 649040 0 180 $X=301320 $Y=643620
X1822 1285 1252 97 2 1 XOR2HS $T=307520 608720 0 180 $X=301940 $Y=603300
X1823 1315 1297 1300 2 1 XOR2HS $T=316820 649040 1 180 $X=311240 $Y=648660
X1824 1318 1298 1301 2 1 XOR2HS $T=317440 608720 1 180 $X=311860 $Y=608340
X1825 1337 1330 1326 2 1 XOR2HS $T=324260 649040 0 180 $X=318680 $Y=643620
X1826 1348 1340 1347 2 1 XOR2HS $T=332940 608720 1 180 $X=327360 $Y=608340
X1827 1385 1370 1375 2 1 XOR2HS $T=341000 608720 0 180 $X=335420 $Y=603300
X1828 1442 164 1437 2 1 XOR2HS $T=369520 608720 0 180 $X=363940 $Y=603300
X1829 1465 1463 1454 2 1 XOR2HS $T=371380 659120 1 180 $X=365800 $Y=658740
X1830 1468 1475 1485 2 1 XOR2HS $T=371380 689360 0 0 $X=371380 $Y=688980
X1831 1478 1487 1492 2 1 XOR2HS $T=374480 689360 1 0 $X=374480 $Y=683940
X1832 1483 1474 1493 2 1 XOR2HS $T=375100 669200 0 0 $X=375100 $Y=668820
X1833 1488 1481 1495 2 1 XOR2HS $T=376340 669200 1 0 $X=376340 $Y=663780
X1834 1496 1469 1489 2 1 XOR2HS $T=386880 608720 0 180 $X=381300 $Y=603300
X1835 1508 1381 1502 2 1 XOR2HS $T=387500 628880 1 180 $X=381920 $Y=628500
X1836 1498 1503 1510 2 1 XOR2HS $T=381920 669200 0 0 $X=381920 $Y=668820
X1837 201 1500 1516 2 1 XOR2HS $T=383780 699440 1 0 $X=383780 $Y=694020
X1838 1525 1509 1515 2 1 XOR2HS $T=391840 669200 0 180 $X=386260 $Y=663780
X1839 1539 1519 205 2 1 XOR2HS $T=395560 608720 0 180 $X=389980 $Y=603300
X1840 1530 1535 1545 2 1 XOR2HS $T=392460 618800 0 0 $X=392460 $Y=618420
X1841 1534 1521 1546 2 1 XOR2HS $T=393080 618800 1 0 $X=393080 $Y=613380
X1842 1449 1538 1550 2 1 XOR2HS $T=396180 669200 1 0 $X=396180 $Y=663780
X1843 1565 1559 1552 2 1 XOR2HS $T=403000 628880 1 180 $X=397420 $Y=628500
X1844 1555 1553 211 2 1 XOR2HS $T=399280 608720 1 0 $X=399280 $Y=603300
X1845 1586 1583 1573 2 1 XOR2HS $T=409200 628880 1 180 $X=403620 $Y=628500
X1846 1577 1570 216 2 1 XOR2HS $T=406100 608720 1 0 $X=406100 $Y=603300
X1847 1578 1579 1592 2 1 XOR2HS $T=407340 618800 0 0 $X=407340 $Y=618420
X1848 1588 1597 1605 2 1 XOR2HS $T=410440 628880 1 0 $X=410440 $Y=623460
X1849 1613 1603 218 2 1 XOR2HS $T=417260 608720 0 180 $X=411680 $Y=603300
X1850 1598 1601 1616 2 1 XOR2HS $T=414160 638960 1 0 $X=414160 $Y=633540
X1851 1607 1608 1619 2 1 XOR2HS $T=416640 618800 0 0 $X=416640 $Y=618420
X1852 1623 1604 1631 2 1 XOR2HS $T=420360 638960 1 0 $X=420360 $Y=633540
X1853 1635 1634 1626 2 1 XOR2HS $T=426560 679280 1 180 $X=420980 $Y=678900
X1854 1640 1624 233 2 1 XOR2HS $T=427800 608720 1 180 $X=422220 $Y=608340
X1855 1561 1630 1636 2 1 XOR2HS $T=422220 628880 1 0 $X=422220 $Y=623460
X1856 1644 1645 1656 2 1 XOR2HS $T=426560 679280 0 0 $X=426560 $Y=678900
X1857 1647 1650 1657 2 1 XOR2HS $T=427180 689360 0 0 $X=427180 $Y=688980
X1858 1652 1658 1665 2 1 XOR2HS $T=429660 618800 0 0 $X=429660 $Y=618420
X1859 1654 1648 1666 2 1 XOR2HS $T=429660 638960 0 0 $X=429660 $Y=638580
X1860 1642 236 1667 2 1 XOR2HS $T=429660 699440 1 0 $X=429660 $Y=694020
X1861 1670 1664 1681 2 1 XOR2HS $T=434000 669200 1 0 $X=434000 $Y=663780
X1862 1671 1672 1690 2 1 XOR2HS $T=435860 649040 1 0 $X=435860 $Y=643620
X1863 1669 1662 1691 2 1 XOR2HS $T=435860 659120 0 0 $X=435860 $Y=658740
X1864 1694 1695 1682 2 1 XOR2HS $T=442060 679280 0 180 $X=436480 $Y=673860
X1865 1542 1676 1695 2 1 XOR2HS $T=437100 679280 0 0 $X=437100 $Y=678900
X1866 1704 1678 1687 2 1 XOR2HS $T=443300 638960 0 180 $X=437720 $Y=633540
X1867 1685 1673 1701 2 1 XOR2HS $T=437720 659120 1 0 $X=437720 $Y=653700
X1868 1675 1722 1698 2 1 XOR2HS $T=447640 628880 1 0 $X=447640 $Y=623460
X1869 1643 1725 1721 2 1 XOR2HS $T=448260 618800 0 0 $X=448260 $Y=618420
X1870 1504 1686 1743 2 1 XOR2HS $T=448880 689360 1 0 $X=448880 $Y=683940
X1871 1692 1529 1699 2 1 XOR2HS $T=451980 669200 1 0 $X=451980 $Y=663780
X1872 1702 1743 1747 2 1 XOR2HS $T=452600 679280 0 0 $X=452600 $Y=678900
X1873 1703 254 1760 2 1 XOR2HS $T=458180 608720 1 0 $X=458180 $Y=603300
X1874 1760 1768 264 2 1 XOR2HS $T=466240 608720 1 0 $X=466240 $Y=603300
X1875 1775 1780 1784 2 1 XOR2HS $T=467480 618800 1 0 $X=467480 $Y=613380
X1876 1776 1787 1795 2 1 XOR2HS $T=472440 618800 0 0 $X=472440 $Y=618420
X1877 1801 1804 1809 2 1 XOR2HS $T=478640 679280 1 0 $X=478640 $Y=673860
X1878 1806 287 289 2 1 XOR2HS $T=481120 699440 1 0 $X=481120 $Y=694020
X1879 1830 1811 1817 2 1 XOR2HS $T=488560 669200 1 180 $X=482980 $Y=668820
X1880 1819 1807 1839 2 1 XOR2HS $T=485460 628880 0 0 $X=485460 $Y=628500
X1881 1818 1813 1834 2 1 XOR2HS $T=485460 689360 0 0 $X=485460 $Y=688980
X1882 1770 1854 1866 2 1 XOR2HS $T=491040 618800 1 0 $X=491040 $Y=613380
X1883 1825 1822 1840 2 1 XOR2HS $T=491660 689360 1 0 $X=491660 $Y=683940
X1884 1829 1845 1861 2 1 XOR2HS $T=492280 649040 1 0 $X=492280 $Y=643620
X1885 1831 1835 1846 2 1 XOR2HS $T=492900 638960 1 0 $X=492900 $Y=633540
X1886 1837 1843 1864 2 1 XOR2HS $T=494140 659120 1 0 $X=494140 $Y=653700
X1887 1893 1866 1909 2 1 XOR2HS $T=499720 618800 0 0 $X=499720 $Y=618420
X1888 1842 1906 1914 2 1 XOR2HS $T=505920 669200 1 0 $X=505920 $Y=663780
X1889 2012 2014 2016 2 1 XOR2HS $T=542500 679280 0 0 $X=542500 $Y=678900
X1890 2039 2029 2030 2 1 XOR2HS $T=556760 659120 0 0 $X=556760 $Y=658740
X1891 2063 2049 2054 2 1 XOR2HS $T=564200 669200 0 180 $X=558620 $Y=663780
X1892 2066 2064 2057 2 1 XOR2HS $T=565440 679280 0 180 $X=559860 $Y=673860
X1893 2076 2074 2077 2 1 XOR2HS $T=573500 669200 0 180 $X=567920 $Y=663780
X1894 2083 2079 2085 2 1 XOR2HS $T=575980 659120 0 180 $X=570400 $Y=653700
X1895 2108 2102 2103 2 1 XOR2HS $T=581560 649040 1 180 $X=575980 $Y=648660
X1896 2100 2098 2107 2 1 XOR2HS $T=577220 669200 0 0 $X=577220 $Y=668820
X1897 2128 2114 2119 2 1 XOR2HS $T=588380 649040 0 180 $X=582800 $Y=643620
X1898 2117 2111 2126 2 1 XOR2HS $T=583420 669200 0 0 $X=583420 $Y=668820
X1899 2134 2123 2127 2 1 XOR2HS $T=589000 669200 0 0 $X=589000 $Y=668820
X1900 2155 2152 2149 2 1 XOR2HS $T=598920 649040 1 180 $X=593340 $Y=648660
X1901 2151 2144 2150 2 1 XOR2HS $T=595200 669200 0 0 $X=595200 $Y=668820
X1902 2163 2161 2172 2 1 XOR2HS $T=601400 669200 0 0 $X=601400 $Y=668820
X1903 2162 2174 2166 2 1 XOR2HS $T=607600 659120 0 180 $X=602020 $Y=653700
X1904 2179 2165 2168 2 1 XOR2HS $T=608840 649040 0 180 $X=603260 $Y=643620
X1905 2182 2177 2186 2 1 XOR2HS $T=609460 659120 0 0 $X=609460 $Y=658740
X1906 2190 2188 2200 2 1 XOR2HS $T=610700 659120 1 0 $X=610700 $Y=653700
X1907 2207 2194 2198 2 1 XOR2HS $T=618140 638960 1 180 $X=612560 $Y=638580
X1908 2206 2212 2215 2 1 XOR2HS $T=617520 669200 1 0 $X=617520 $Y=663780
X1909 2210 2208 2219 2 1 XOR2HS $T=620620 649040 0 0 $X=620620 $Y=648660
X1910 2217 2213 2221 2 1 XOR2HS $T=621860 638960 0 0 $X=621860 $Y=638580
X1911 2225 2226 2238 2 1 XOR2HS $T=626820 649040 0 0 $X=626820 $Y=648660
X1912 2232 2228 2241 2 1 XOR2HS $T=627440 669200 1 0 $X=627440 $Y=663780
X1913 2246 2237 2254 2 1 XOR2HS $T=633020 649040 0 0 $X=633020 $Y=648660
X1914 2244 2245 2258 2 1 XOR2HS $T=634260 638960 1 0 $X=634260 $Y=633540
X1915 2263 2227 2274 2 1 XOR2HS $T=640460 638960 1 0 $X=640460 $Y=633540
X1916 2264 2255 2268 2 1 XOR2HS $T=646040 649040 0 180 $X=640460 $Y=643620
X1917 2266 2259 2275 2 1 XOR2HS $T=640460 669200 1 0 $X=640460 $Y=663780
X1918 2278 2277 2285 2 1 XOR2HS $T=648520 659120 0 0 $X=648520 $Y=658740
X1919 2280 2282 2287 2 1 XOR2HS $T=653480 649040 0 0 $X=653480 $Y=648660
X1920 2292 2281 2301 2 1 XOR2HS $T=655960 669200 0 0 $X=655960 $Y=668820
X1921 2345 2346 2348 2 1 XOR2HS $T=674560 669200 0 0 $X=674560 $Y=668820
X1922 2403 2407 2415 2 1 XOR2HS $T=700600 679280 1 0 $X=700600 $Y=673860
X1923 526 527 2416 2 1 XOR2HS $T=700600 699440 1 0 $X=700600 $Y=694020
X1924 2422 2424 2428 2 1 XOR2HS $T=706180 679280 1 0 $X=706180 $Y=673860
X1925 2419 2420 2431 2 1 XOR2HS $T=708040 689360 1 0 $X=708040 $Y=683940
X1926 2432 2437 2446 2 1 XOR2HS $T=713620 669200 1 0 $X=713620 $Y=663780
X1927 2450 2449 2443 2 1 XOR2HS $T=719820 638960 0 180 $X=714240 $Y=633540
X1928 2462 2461 2455 2 1 XOR2HS $T=725400 638960 0 180 $X=719820 $Y=633540
X1929 2442 2445 2452 2 1 XOR2HS $T=719820 649040 0 0 $X=719820 $Y=648660
X1930 2464 2473 2468 2 1 XOR2HS $T=732220 649040 0 180 $X=726640 $Y=643620
X1931 2491 2493 2480 2 1 XOR2HS $T=735940 638960 1 180 $X=730360 $Y=638580
X1932 2486 2496 2481 2 1 XOR2HS $T=736560 649040 1 180 $X=730980 $Y=648660
X1933 591 2505 579 2 1 XOR2HS $T=740280 608720 0 180 $X=734700 $Y=603300
X1934 2506 2510 2519 2 1 XOR2HS $T=737800 649040 0 0 $X=737800 $Y=648660
X1935 2515 2521 593 2 1 XOR2HS $T=745240 608720 1 180 $X=739660 $Y=608340
X1936 2538 2534 2508 2 1 XOR2HS $T=747100 628880 0 180 $X=741520 $Y=623460
X1937 2527 2535 2536 2 1 XOR2HS $T=744000 649040 0 0 $X=744000 $Y=648660
X1938 2543 2541 2517 2 1 XOR2HS $T=750200 618800 0 180 $X=744620 $Y=613380
X1939 2526 2524 2528 2 1 XOR2HS $T=745860 638960 0 0 $X=745860 $Y=638580
X1940 600 2540 604 2 1 XOR2HS $T=746480 608720 1 0 $X=746480 $Y=603300
X1941 2551 2552 2563 2 1 XOR2HS $T=750200 618800 1 0 $X=750200 $Y=613380
X1942 607 606 612 2 1 XOR2HS $T=753300 608720 1 0 $X=753300 $Y=603300
X1943 2559 2567 2568 2 1 XOR2HS $T=755160 649040 1 0 $X=755160 $Y=643620
X1944 2580 2576 2579 2 1 XOR2HS $T=758260 628880 1 0 $X=758260 $Y=623460
X1945 2610 2605 2618 2 1 XOR2HS $T=768180 628880 1 0 $X=768180 $Y=623460
X1946 2646 2644 2634 2 1 XOR2HS $T=779960 618800 1 180 $X=774380 $Y=618420
X1947 2655 2630 2637 2 1 XOR2HS $T=783680 659120 1 180 $X=778100 $Y=658740
X1948 2662 2669 2691 2 1 XOR2HS $T=789260 669200 1 0 $X=789260 $Y=663780
X1949 2683 2678 2676 2 1 XOR2HS $T=791740 618800 0 0 $X=791740 $Y=618420
X1950 2725 2717 2711 2 1 XOR2HS $T=801660 628880 0 0 $X=801660 $Y=628500
X1951 2729 2726 2734 2 1 XOR2HS $T=802280 649040 0 0 $X=802280 $Y=648660
X1952 2736 2739 2720 2 1 XOR2HS $T=805380 618800 1 0 $X=805380 $Y=613380
X1953 2764 2751 2758 2 1 XOR2HS $T=819020 649040 1 180 $X=813440 $Y=648660
X1954 2757 2754 2750 2 1 XOR2HS $T=814680 618800 0 0 $X=814680 $Y=618420
X1955 2780 2774 2766 2 1 XOR2HS $T=822740 659120 1 180 $X=817160 $Y=658740
X1956 2786 2778 2777 2 1 XOR2HS $T=823360 618800 0 0 $X=823360 $Y=618420
X1957 2812 2806 2818 2 1 XOR2HS $T=832040 618800 1 0 $X=832040 $Y=613380
X1958 2827 2824 2838 2 1 XOR2HS $T=837620 618800 1 0 $X=837620 $Y=613380
X1959 2833 2814 2839 2 1 XOR2HS $T=841340 659120 0 0 $X=841340 $Y=658740
X1960 2864 2840 2855 2 1 XOR2HS $T=853120 659120 1 180 $X=847540 $Y=658740
X1961 2851 2848 2854 2 1 XOR2HS $T=849400 618800 1 0 $X=849400 $Y=613380
X1962 2873 2872 2887 2 1 XOR2HS $T=853740 659120 0 0 $X=853740 $Y=658740
X1963 2901 2900 2895 2 1 XOR2HS $T=863660 649040 0 180 $X=858080 $Y=643620
X1964 2908 2905 2917 2 1 XOR2HS $T=865520 618800 1 0 $X=865520 $Y=613380
X1965 2907 2891 2918 2 1 XOR2HS $T=865520 659120 0 0 $X=865520 $Y=658740
X1966 2923 2910 2916 2 1 XOR2HS $T=872960 649040 0 180 $X=867380 $Y=643620
X1967 2927 2921 2911 2 1 XOR2HS $T=875440 689360 0 180 $X=869860 $Y=683940
X1968 717 757 2931 2 1 XOR2HS $T=871720 699440 1 0 $X=871720 $Y=694020
X1969 2925 2920 2933 2 1 XOR2HS $T=872960 618800 1 0 $X=872960 $Y=613380
X1970 2934 2940 2924 2 1 XOR2HS $T=881640 649040 1 180 $X=876060 $Y=648660
X1971 2936 2957 2930 2 1 XOR2HS $T=882880 659120 0 180 $X=877300 $Y=653700
X1972 2942 2937 2955 2 1 XOR2HS $T=877920 618800 0 0 $X=877920 $Y=618420
X1973 2956 2959 2948 2 1 XOR2HS $T=883500 638960 1 180 $X=877920 $Y=638580
X1974 2954 2961 2932 2 1 XOR2HS $T=885360 669200 1 180 $X=879780 $Y=668820
X1975 2952 2962 2935 2 1 XOR2HS $T=885980 659120 1 180 $X=880400 $Y=658740
X1976 2977 2967 2972 2 1 XOR2HS $T=893420 618800 1 180 $X=887840 $Y=618420
X1977 2939 2964 2953 2 1 XOR2HS $T=887840 689360 0 0 $X=887840 $Y=688980
X1978 2973 2975 2949 2 1 XOR2HS $T=889700 679280 0 0 $X=889700 $Y=678900
X1979 2990 2992 2991 2 1 XOR2HS $T=903960 618800 1 180 $X=898380 $Y=618420
X1980 2995 3001 2987 2 1 XOR2HS $T=906440 628880 1 180 $X=900860 $Y=628500
X1981 3014 3007 3009 2 1 XOR2HS $T=914500 628880 1 180 $X=908920 $Y=628500
X1982 3025 3013 3018 2 1 XOR2HS $T=919460 618800 1 180 $X=913880 $Y=618420
X1983 3035 3034 3030 2 1 XOR2HS $T=925660 618800 1 180 $X=920080 $Y=618420
X1984 3047 3041 3039 2 1 XOR2HS $T=932480 628880 0 180 $X=926900 $Y=623460
X1985 3064 3063 3058 2 1 XOR2HS $T=939920 628880 0 180 $X=934340 $Y=623460
X1986 3075 3078 3091 2 1 XOR2HS $T=947360 628880 1 0 $X=947360 $Y=623460
X1987 3106 3104 3105 2 1 XOR2HS $T=956040 628880 1 0 $X=956040 $Y=623460
X1988 3123 3124 3132 2 1 XOR2HS $T=964100 628880 1 0 $X=964100 $Y=623460
X1989 3152 3138 3145 2 1 XOR2HS $T=979600 628880 1 180 $X=974020 $Y=628500
X1990 3167 3166 3158 2 1 XOR2HS $T=986420 638960 0 180 $X=980840 $Y=633540
X1991 3186 3189 3174 2 1 XOR2HS $T=994480 628880 1 0 $X=994480 $Y=623460
X1992 3214 3212 3203 2 1 XOR2HS $T=1006260 628880 1 180 $X=1000680 $Y=628500
X1993 3224 3223 3213 2 1 XOR2HS $T=1009980 618800 0 0 $X=1009980 $Y=618420
X1994 3248 3246 3236 2 1 XOR2HS $T=1021140 628880 1 180 $X=1015560 $Y=628500
X1995 3265 3264 3247 2 1 XOR2HS $T=1030440 628880 0 180 $X=1024860 $Y=623460
X1996 3273 3270 3282 2 1 XOR2HS $T=1032920 649040 1 0 $X=1032920 $Y=643620
X1997 3281 3278 3269 2 1 XOR2HS $T=1040360 618800 0 180 $X=1034780 $Y=613380
X1998 3284 3295 933 2 1 XOR2HS $T=1044080 628880 1 0 $X=1044080 $Y=623460
X1999 3296 3291 3298 2 1 XOR2HS $T=1044700 638960 0 0 $X=1044700 $Y=638580
X2000 3303 3302 938 2 1 XOR2HS $T=1048420 608720 0 0 $X=1048420 $Y=608340
X2001 3306 3304 3318 2 1 XOR2HS $T=1050900 659120 0 0 $X=1050900 $Y=658740
X2002 3311 3316 3326 2 1 XOR2HS $T=1051520 649040 1 0 $X=1051520 $Y=643620
X2003 3315 3332 3312 2 1 XOR2HS $T=1059580 628880 1 180 $X=1054000 $Y=628500
X2004 3330 3301 3339 2 1 XOR2HS $T=1057720 649040 1 0 $X=1057720 $Y=643620
X2005 3313 3356 3344 2 1 XOR2HS $T=1068260 618800 0 0 $X=1068260 $Y=618420
X2006 3348 3341 3351 2 1 XOR2HS $T=1071360 659120 0 0 $X=1071360 $Y=658740
X2007 3361 3364 3358 2 1 XOR2HS $T=1076940 628880 0 0 $X=1076940 $Y=628500
X2008 958 961 960 2 1 XOR2HS $T=1086240 608720 0 180 $X=1080660 $Y=603300
X2009 3307 3368 3366 2 1 XOR2HS $T=1082520 618800 0 0 $X=1082520 $Y=618420
X2010 2371 2379 2363 327 2 1 2388 OA112S $T=688820 628880 1 0 $X=688820 $Y=623460
X2011 1081 10 1105 1 2 1095 OA12 $T=248000 659120 0 180 $X=244280 $Y=653700
X2012 24 1117 1125 1 2 1096 OA12 $T=252340 638960 1 0 $X=252340 $Y=633540
X2013 2096 2122 2110 1 2 2133 OA12 $T=585280 618800 0 0 $X=585280 $Y=618420
X2014 513 2355 2388 1 2 2395 OA12 $T=693780 628880 1 0 $X=693780 $Y=623460
X2015 2947 588 2984 1 2 800 OA12 $T=899620 618800 1 0 $X=899620 $Y=613380
X2016 771 923 3263 1 2 3284 OA12 $T=1032920 628880 1 0 $X=1032920 $Y=623460
X2017 3289 588 3272 1 2 3295 OA12 $T=1039740 649040 0 0 $X=1039740 $Y=648660
X2018 66 65 2 1 1175 OR2 $T=283340 679280 1 180 $X=280860 $Y=678900
X2019 190 189 2 1 186 OR2 $T=374480 608720 0 180 $X=372000 $Y=603300
X2020 1529 1692 2 1 1731 OR2 $T=450740 669200 0 180 $X=448260 $Y=663780
X2021 2394 2294 2 1 2379 OR2 $T=696880 628880 1 180 $X=694400 $Y=628500
X2022 630 2915 2 1 2894 OR2 $T=869240 638960 1 180 $X=866760 $Y=638580
X2023 630 2968 2 1 2981 OR2 $T=891560 638960 0 0 $X=891560 $Y=638580
X2024 630 3227 2 1 3229 OR2 $T=1016180 669200 0 180 $X=1013700 $Y=663780
X2025 605 613 2 1 3255 OR2 $T=1021760 659120 0 0 $X=1021760 $Y=658740
X2026 630 3255 2 1 3259 OR2 $T=1023620 659120 1 0 $X=1023620 $Y=653700
X2027 3272 3267 2 1 3299 OR2 $T=1042840 659120 1 0 $X=1042840 $Y=653700
X2028 3349 3347 2 1 3345 OR2 $T=1066400 628880 0 180 $X=1063920 $Y=623460
X2029 2406 2398 2 1 2400 OR2S $T=704320 618800 1 180 $X=701840 $Y=618420
X2030 2372 2363 509 2294 1 2 2309 OA13S $T=686960 638960 0 180 $X=682620 $Y=633540
X2031 2140 2143 2135 2101 2 2110 1 AOI13HS $T=592720 618800 1 180 $X=589000 $Y=618420
X2032 1674 1557 1 1712 1715 1720 2 MOAI1 $T=442060 679280 1 0 $X=442060 $Y=673860
X2033 1676 1542 1 1688 1716 1724 2 MOAI1 $T=442680 679280 0 0 $X=442680 $Y=678900
X2034 1833 278 1 1838 1842 292 2 MOAI1 $T=492900 669200 0 180 $X=488560 $Y=663780
X2035 294 295 1 1867 1874 295 2 MOAI1 $T=492280 699440 1 0 $X=492280 $Y=694020
X2036 2793 629 1 688 687 2782 2 MOAI1 $T=826460 608720 0 180 $X=822120 $Y=603300
X2037 630 2835 1 2820 2779 630 2 MOAI1 $T=842580 628880 1 180 $X=838240 $Y=628500
X2038 2880 771 1 2960 780 771 2 MOAI1 $T=880400 608720 0 0 $X=880400 $Y=608340
X2039 2963 2947 1 2966 783 2947 2 MOAI1 $T=884120 618800 1 0 $X=884120 $Y=613380
X2040 507 703 1 507 803 797 2 MOAI1 $T=903340 649040 1 0 $X=903340 $Y=643620
X2041 730 507 1 507 809 808 2 MOAI1 $T=907680 649040 1 0 $X=907680 $Y=643620
X2042 695 507 1 507 819 820 2 MOAI1 $T=917600 649040 1 0 $X=917600 $Y=643620
X2043 1201 66 2 1 1167 1191 MUX2 $T=282720 659120 0 180 $X=278380 $Y=653700
X2044 1199 66 2 1 1169 1192 MUX2 $T=282720 669200 1 180 $X=278380 $Y=668820
X2045 1210 66 2 1 1212 1225 MUX2 $T=284580 669200 1 0 $X=284580 $Y=663780
X2046 1211 1215 2 1 1157 1226 MUX2 $T=285820 618800 0 0 $X=285820 $Y=618420
X2047 1219 1215 2 1 1185 1241 MUX2 $T=290160 618800 1 0 $X=290160 $Y=613380
X2048 1221 66 2 1 1231 1246 MUX2 $T=290160 659120 1 0 $X=290160 $Y=653700
X2049 1227 1215 2 1 1190 1251 MUX2 $T=291400 618800 0 0 $X=291400 $Y=618420
X2050 1247 66 2 1 1253 1262 MUX2 $T=295120 669200 1 0 $X=295120 $Y=663780
X2051 1248 1215 2 1 92 1268 MUX2 $T=295740 618800 1 0 $X=295740 $Y=613380
X2052 1250 65 2 1 1240 1264 MUX2 $T=295740 669200 0 0 $X=295740 $Y=668820
X2053 1243 65 2 1 1247 1269 MUX2 $T=296980 679280 1 0 $X=296980 $Y=673860
X2054 1217 93 2 1 1229 1273 MUX2 $T=298840 628880 0 0 $X=298840 $Y=628500
X2055 1249 1218 2 1 1206 1280 MUX2 $T=300700 628880 1 0 $X=300700 $Y=623460
X2056 1195 1215 2 1 95 1288 MUX2 $T=303180 618800 1 0 $X=303180 $Y=613380
X2057 1189 1218 2 1 1208 1289 MUX2 $T=303180 618800 0 0 $X=303180 $Y=618420
X2058 1271 65 2 1 1283 1291 MUX2 $T=303800 669200 1 0 $X=303800 $Y=663780
X2059 1245 93 2 1 1189 1293 MUX2 $T=304420 628880 0 0 $X=304420 $Y=628500
X2060 1229 1218 2 1 1198 1294 MUX2 $T=305040 628880 1 0 $X=305040 $Y=623460
X2061 1283 66 2 1 1286 1310 MUX2 $T=305040 659120 1 0 $X=305040 $Y=653700
X2062 1299 106 2 1 1279 1282 MUX2 $T=309380 679280 1 180 $X=305040 $Y=678900
X2063 1206 1215 2 1 1303 1302 MUX2 $T=308760 618800 1 0 $X=308760 $Y=613380
X2064 1293 93 2 1 1280 1304 MUX2 $T=308760 618800 0 0 $X=308760 $Y=618420
X2065 1273 93 2 1 1256 1314 MUX2 $T=309380 628880 1 0 $X=309380 $Y=623460
X2066 1290 99 2 1 1273 1295 MUX2 $T=313720 628880 1 180 $X=309380 $Y=628500
X2067 1230 65 2 1 1255 1306 MUX2 $T=309380 669200 1 0 $X=309380 $Y=663780
X2068 1269 65 2 1 1192 1307 MUX2 $T=310000 669200 0 0 $X=310000 $Y=668820
X2069 1270 1267 2 1 1269 1308 MUX2 $T=310000 679280 1 0 $X=310000 $Y=673860
X2070 1240 66 2 1 1305 1311 MUX2 $T=310620 659120 0 0 $X=310620 $Y=658740
X2071 1280 1218 2 1 1241 1321 MUX2 $T=313720 618800 1 0 $X=313720 $Y=613380
X2072 1295 99 2 1 1293 1322 MUX2 $T=313720 628880 0 0 $X=313720 $Y=628500
X2073 1317 99 2 1 116 1325 MUX2 $T=315580 689360 1 0 $X=315580 $Y=683940
X2074 1314 93 2 1 1294 1332 MUX2 $T=318680 628880 1 0 $X=318680 $Y=623460
X2075 1329 99 2 1 115 1317 MUX2 $T=323020 689360 1 180 $X=318680 $Y=688980
X2076 1198 1215 2 1 1344 1343 MUX2 $T=319300 618800 1 0 $X=319300 $Y=613380
X2077 1294 1218 2 1 1251 1335 MUX2 $T=319300 618800 0 0 $X=319300 $Y=618420
X2078 1320 106 2 1 1308 1324 MUX2 $T=319920 669200 0 0 $X=319920 $Y=668820
X2079 1351 99 2 1 123 1329 MUX2 $T=327360 689360 1 180 $X=323020 $Y=688980
X2080 1255 66 2 1 1333 1353 MUX2 $T=323640 649040 0 0 $X=323640 $Y=648660
X2081 1304 93 2 1 1289 1352 MUX2 $T=324260 618800 0 0 $X=324260 $Y=618420
X2082 1338 1292 2 1 1306 1355 MUX2 $T=324260 659120 1 0 $X=324260 $Y=653700
X2083 1296 1292 2 1 1291 1338 MUX2 $T=324260 669200 1 0 $X=324260 $Y=663780
X2084 1308 1292 2 1 1264 1356 MUX2 $T=325500 669200 0 0 $X=325500 $Y=668820
X2085 1289 1218 2 1 1268 1364 MUX2 $T=328600 618800 1 0 $X=328600 $Y=613380
X2086 1349 99 2 1 1332 1365 MUX2 $T=328600 628880 0 0 $X=328600 $Y=628500
X2087 1332 93 2 1 1319 1367 MUX2 $T=329220 628880 1 0 $X=329220 $Y=623460
X2088 1192 66 2 1 1354 1369 MUX2 $T=329220 649040 0 0 $X=329220 $Y=648660
X2089 140 99 2 1 132 1351 MUX2 $T=333560 699440 0 180 $X=329220 $Y=694020
X2090 1291 1362 2 1 1191 1371 MUX2 $T=330460 659120 1 0 $X=330460 $Y=653700
X2091 1331 106 2 1 1356 1372 MUX2 $T=331080 669200 0 0 $X=331080 $Y=668820
X2092 1367 93 2 1 1335 1376 MUX2 $T=332940 618800 0 0 $X=332940 $Y=618420
X2093 1319 1218 2 1 1288 1380 MUX2 $T=333560 618800 1 0 $X=333560 $Y=613380
X2094 1365 1346 2 1 1352 1379 MUX2 $T=333560 628880 1 0 $X=333560 $Y=623460
X2095 1306 1362 2 1 1246 1382 MUX2 $T=334180 649040 0 0 $X=334180 $Y=648660
X2096 115 93 2 1 149 1361 MUX2 $T=335420 699440 1 0 $X=335420 $Y=694020
X2097 1377 1374 2 1 1387 1386 MUX2 $T=336660 659120 1 0 $X=336660 $Y=653700
X2098 1372 1374 2 1 1355 1377 MUX2 $T=336660 659120 0 0 $X=336660 $Y=658740
X2099 1356 1292 2 1 1307 1387 MUX2 $T=336660 669200 1 0 $X=336660 $Y=663780
X2100 1352 93 2 1 1321 1391 MUX2 $T=337280 618800 0 0 $X=337280 $Y=618420
X2101 1321 1218 2 1 1302 1398 MUX2 $T=338520 608720 0 0 $X=338520 $Y=608340
X2102 1379 99 2 1 1367 1392 MUX2 $T=338520 628880 0 0 $X=338520 $Y=628500
X2103 1355 1292 2 1 1371 1394 MUX2 $T=339140 649040 0 0 $X=339140 $Y=648660
X2104 1386 1374 2 1 1394 1396 MUX2 $T=339760 649040 1 0 $X=339760 $Y=643620
X2105 1264 1362 2 1 1225 1401 MUX2 $T=342240 659120 0 0 $X=342240 $Y=658740
X2106 1208 1215 2 1 1397 1404 MUX2 $T=342860 618800 1 0 $X=342860 $Y=613380
X2107 1391 93 2 1 1364 1405 MUX2 $T=342860 618800 0 0 $X=342860 $Y=618420
X2108 1392 1346 2 1 1391 1402 MUX2 $T=343480 628880 1 0 $X=343480 $Y=623460
X2109 1396 1374 2 1 1409 1412 MUX2 $T=344720 649040 1 0 $X=344720 $Y=643620
X2110 1394 1292 2 1 1382 1411 MUX2 $T=344720 649040 0 0 $X=344720 $Y=648660
X2111 1387 1292 2 1 1401 1409 MUX2 $T=344720 659120 1 0 $X=344720 $Y=653700
X2112 1307 1362 2 1 1262 1418 MUX2 $T=347200 659120 0 0 $X=347200 $Y=658740
X2113 1402 1346 2 1 1376 1417 MUX2 $T=348440 628880 1 0 $X=348440 $Y=623460
X2114 1226 1215 2 1 165 1426 MUX2 $T=349680 608720 0 0 $X=349680 $Y=608340
X2115 1371 1362 2 1 1310 1423 MUX2 $T=349680 649040 0 0 $X=349680 $Y=648660
X2116 1410 1389 2 1 1429 1427 MUX2 $T=350920 689360 0 0 $X=350920 $Y=688980
X2117 1420 1389 2 1 1433 1427 MUX2 $T=354020 679280 1 0 $X=354020 $Y=673860
X2118 1416 99 2 1 1420 1427 MUX2 $T=360220 669200 1 180 $X=355880 $Y=668820
X2119 1452 93 2 1 1430 1447 MUX2 $T=368280 628880 0 180 $X=363940 $Y=623460
X2120 1446 1292 2 1 1436 1462 MUX2 $T=365800 659120 1 0 $X=365800 $Y=653700
X2121 162 1215 2 1 1453 1427 MUX2 $T=370760 669200 1 180 $X=366420 $Y=668820
X2122 1434 93 2 1 1467 1441 MUX2 $T=367660 618800 0 0 $X=367660 $Y=618420
X2123 1241 1215 2 1 1471 1472 MUX2 $T=368280 608720 0 0 $X=368280 $Y=608340
X2124 1447 93 2 1 1477 1441 MUX2 $T=368900 628880 1 0 $X=368900 $Y=623460
X2125 1479 1346 2 1 1447 1441 MUX2 $T=373860 628880 1 0 $X=373860 $Y=623460
X2126 1482 1374 2 1 1462 1476 MUX2 $T=376340 649040 1 0 $X=376340 $Y=643620
X2127 1191 66 2 1 1505 1506 MUX2 $T=380680 649040 0 0 $X=380680 $Y=648660
X2128 1459 1292 2 1 1514 1476 MUX2 $T=381300 649040 1 0 $X=381300 $Y=643620
X2129 1462 1292 2 1 1511 1476 MUX2 $T=381920 659120 1 0 $X=381920 $Y=653700
X2130 1353 1532 2 1 1566 1476 MUX2 $T=397420 649040 1 0 $X=397420 $Y=643620
X2131 1569 1560 2 1 1591 1563 MUX2 $T=404240 689360 1 0 $X=404240 $Y=683940
X2132 1564 1560 2 1 215 1569 MUX2 $T=404860 689360 0 0 $X=404860 $Y=688980
X2133 1576 1560 2 1 1595 1575 MUX2 $T=405480 659120 0 0 $X=405480 $Y=658740
X2134 1572 1560 2 1 217 1564 MUX2 $T=406720 699440 1 0 $X=406720 $Y=694020
X2135 215 207 2 1 221 1587 MUX2 $T=409820 689360 0 0 $X=409820 $Y=688980
X2136 1593 207 2 1 1610 1595 MUX2 $T=411060 669200 0 0 $X=411060 $Y=668820
X2137 217 207 2 1 223 1591 MUX2 $T=412300 699440 1 0 $X=412300 $Y=694020
X2138 1614 1560 2 1 1617 1618 MUX2 $T=416020 638960 0 0 $X=416020 $Y=638580
X2139 1606 1590 2 1 1621 1618 MUX2 $T=416640 659120 0 0 $X=416640 $Y=658740
X2140 1617 1590 2 1 1627 1618 MUX2 $T=418500 649040 0 0 $X=418500 $Y=648660
X2141 235 1532 2 1 1668 1618 MUX2 $T=429660 649040 0 0 $X=429660 $Y=648660
X2142 1754 256 2 1 258 1750 MUX2 $T=458180 689360 0 0 $X=458180 $Y=688980
X2143 1758 256 2 1 1769 1757 MUX2 $T=461900 689360 1 0 $X=461900 $Y=683940
X2144 1750 256 2 1 261 1758 MUX2 $T=462520 689360 0 0 $X=462520 $Y=688980
X2145 259 256 2 1 262 1754 MUX2 $T=462520 699440 1 0 $X=462520 $Y=694020
X2146 1781 256 2 1 1793 1773 MUX2 $T=469960 638960 0 0 $X=469960 $Y=638580
X2147 1789 1774 2 1 1800 1773 MUX2 $T=474920 659120 1 0 $X=474920 $Y=653700
X2148 1793 1774 2 1 1808 1773 MUX2 $T=476780 649040 1 0 $X=476780 $Y=643620
X2149 275 273 2 1 1827 1773 MUX2 $T=481120 638960 0 0 $X=481120 $Y=638580
X2150 1972 317 2 1 1992 1988 MUX2 $T=528860 638960 1 0 $X=528860 $Y=633540
X2151 1996 317 2 1 1917 1972 MUX2 $T=535680 628880 0 180 $X=531340 $Y=623460
X2152 1995 319 2 1 2006 2004 MUX2 $T=535060 649040 1 0 $X=535060 $Y=643620
X2153 1996 319 2 1 2010 1975 MUX2 $T=546220 628880 0 180 $X=541880 $Y=623460
X2154 1996 319 2 1 1960 1990 MUX2 $T=541880 638960 1 0 $X=541880 $Y=633540
X2155 1990 319 2 1 2021 2009 MUX2 $T=542500 638960 0 0 $X=542500 $Y=638580
X2156 1996 336 2 1 2047 1969 MUX2 $T=554280 628880 1 0 $X=554280 $Y=623460
X2157 2375 515 2 1 2359 508 MUX2 $T=688820 679280 0 180 $X=684480 $Y=673860
X2158 2378 515 2 1 2362 512 MUX2 $T=690060 689360 1 180 $X=685720 $Y=688980
X2159 2320 515 2 1 2380 520 MUX2 $T=695640 679280 0 180 $X=691300 $Y=673860
X2160 2555 2557 2 1 2491 2544 MUX2 $T=752060 638960 0 180 $X=747720 $Y=633540
X2161 2565 2557 2 1 2513 2544 MUX2 $T=753300 628880 0 180 $X=748960 $Y=623460
X2162 2566 2557 2 1 2514 2544 MUX2 $T=755160 628880 1 180 $X=750820 $Y=628500
X2163 2578 2557 2 1 2533 2544 MUX2 $T=757020 638960 0 180 $X=752680 $Y=633540
X2164 2571 611 2 1 2584 614 MUX2 $T=755780 608720 0 0 $X=755780 $Y=608340
X2165 2582 2557 2 1 2522 2573 MUX2 $T=760120 628880 1 180 $X=755780 $Y=628500
X2166 2584 617 2 1 622 614 MUX2 $T=763220 608720 1 0 $X=763220 $Y=603300
X2167 2603 2611 2 1 2595 2544 MUX2 $T=767560 649040 0 180 $X=763220 $Y=643620
X2168 2595 2622 2 1 2585 2544 MUX2 $T=770040 638960 1 180 $X=765700 $Y=638580
X2169 2617 617 2 1 624 2584 MUX2 $T=772520 608720 0 180 $X=768180 $Y=603300
X2170 2625 2622 2 1 2613 2595 MUX2 $T=773140 649040 0 180 $X=768800 $Y=643620
X2171 2627 2622 2 1 2629 2544 MUX2 $T=778100 638960 1 180 $X=773760 $Y=638580
X2172 2708 617 2 1 658 2675 MUX2 $T=799800 608720 0 180 $X=795460 $Y=603300
X2173 2716 2581 2 1 2665 2684 MUX2 $T=800420 628880 0 180 $X=796080 $Y=623460
X2174 2718 2622 2 1 2696 2697 MUX2 $T=801040 638960 1 180 $X=796700 $Y=638580
X2175 2741 2557 2 1 2728 2565 MUX2 $T=808480 628880 0 180 $X=804140 $Y=623460
X2176 2749 625 2 1 2719 2687 MUX2 $T=809720 649040 0 180 $X=805380 $Y=643620
X2177 2746 630 2 1 2733 2719 MUX2 $T=810960 638960 1 180 $X=806620 $Y=638580
X2178 2753 613 2 1 2681 2700 MUX2 $T=811580 638960 0 180 $X=807240 $Y=633540
X2179 2743 2557 2 1 2755 2582 MUX2 $T=809720 628880 1 0 $X=809720 $Y=623460
X2180 2760 629 2 1 677 2745 MUX2 $T=814680 608720 0 180 $X=810340 $Y=603300
X2181 2767 625 2 1 2718 2749 MUX2 $T=815920 638960 1 180 $X=811580 $Y=638580
X2182 2762 630 2 1 2716 2718 MUX2 $T=816540 628880 1 180 $X=812200 $Y=628500
X2183 2772 2782 2 1 680 2760 MUX2 $T=822120 608720 1 180 $X=817780 $Y=608340
X2184 2779 613 2 1 2741 2716 MUX2 $T=822120 628880 0 180 $X=817780 $Y=623460
X2185 2781 613 2 1 2695 2696 MUX2 $T=822120 628880 1 180 $X=817780 $Y=628500
X2186 2797 625 2 1 2746 2767 MUX2 $T=824600 638960 1 180 $X=820260 $Y=638580
X2187 2791 630 2 1 2753 2746 MUX2 $T=825220 638960 0 180 $X=820880 $Y=633540
X2188 2799 630 2 1 2781 2762 MUX2 $T=827700 628880 1 180 $X=823360 $Y=628500
X2189 2803 2802 2 1 2785 2620 MUX2 $T=830180 628880 0 180 $X=825840 $Y=623460
X2190 2808 625 2 1 2762 2797 MUX2 $T=830800 638960 0 180 $X=826460 $Y=633540
X2191 2798 2782 2 1 697 2793 MUX2 $T=827080 618800 1 0 $X=827080 $Y=613380
X2192 2810 629 2 1 692 2798 MUX2 $T=832660 608720 0 180 $X=828320 $Y=603300
X2193 2809 625 2 1 2799 2816 MUX2 $T=831420 628880 0 0 $X=831420 $Y=628500
X2194 2816 625 2 1 2791 2808 MUX2 $T=838860 638960 0 180 $X=834520 $Y=633540
X2195 2831 2802 2 1 2819 2665 MUX2 $T=840100 628880 0 180 $X=835760 $Y=623460
X2196 2843 630 2 1 2770 2791 MUX2 $T=844440 638960 0 180 $X=840100 $Y=633540
X2197 2846 625 2 1 2843 2809 MUX2 $T=846300 628880 0 180 $X=841960 $Y=623460
X2198 2868 613 2 1 2743 2753 MUX2 $T=851260 628880 1 180 $X=846920 $Y=628500
X2199 2881 2802 2 1 2857 2681 MUX2 $T=854980 618800 1 180 $X=850640 $Y=618420
X2200 2913 2802 2 1 2896 2695 MUX2 $T=866140 628880 0 180 $X=861800 $Y=623460
X2201 2904 2802 2 1 2914 2747 MUX2 $T=863040 638960 1 0 $X=863040 $Y=633540
X2202 2922 613 2 1 2803 2781 MUX2 $T=872960 638960 0 180 $X=868620 $Y=633540
X2203 3052 625 2 1 3068 3038 MUX2 $T=933720 659120 1 0 $X=933720 $Y=653700
X2204 3068 3072 2 1 3061 3038 MUX2 $T=941160 649040 0 180 $X=936820 $Y=643620
X2205 3048 3072 2 1 3066 3068 MUX2 $T=944260 659120 0 180 $X=939920 $Y=653700
X2206 3054 3072 2 1 3087 3038 MUX2 $T=944880 649040 0 0 $X=944880 $Y=648660
X2207 3103 629 2 1 855 3094 MUX2 $T=956660 608720 1 180 $X=952320 $Y=608340
X2208 3115 629 2 1 3108 3103 MUX2 $T=962240 608720 1 180 $X=957900 $Y=608340
X2209 3114 3072 2 1 3109 3086 MUX2 $T=962240 669200 1 180 $X=957900 $Y=668820
X2210 3116 625 2 1 3110 3097 MUX2 $T=963480 669200 0 180 $X=959140 $Y=663780
X2211 3119 3072 2 1 3107 3110 MUX2 $T=964100 659120 1 180 $X=959760 $Y=658740
X2212 3108 863 2 1 869 3080 MUX2 $T=961620 608720 1 0 $X=961620 $Y=603300
X2213 3130 629 2 1 865 3115 MUX2 $T=967820 608720 1 180 $X=963480 $Y=608340
X2214 3134 3081 2 1 3096 3099 MUX2 $T=968440 659120 0 180 $X=964100 $Y=653700
X2215 3120 3072 2 1 3134 3114 MUX2 $T=964100 669200 0 0 $X=964100 $Y=668820
X2216 3129 625 2 1 3114 3116 MUX2 $T=969060 669200 0 180 $X=964720 $Y=663780
X2217 3141 3081 2 1 3131 3109 MUX2 $T=971540 649040 1 180 $X=967200 $Y=648660
X2218 3139 629 2 1 3133 3130 MUX2 $T=972780 618800 0 180 $X=968440 $Y=613380
X2219 3133 863 2 1 870 3108 MUX2 $T=973400 608720 1 180 $X=969060 $Y=608340
X2220 3127 625 2 1 3119 3129 MUX2 $T=973400 659120 1 180 $X=969060 $Y=658740
X2221 3144 3081 2 1 3122 3098 MUX2 $T=974640 659120 0 180 $X=970300 $Y=653700
X2222 3142 863 2 1 871 865 MUX2 $T=975260 608720 0 180 $X=970920 $Y=603300
X2223 3147 625 2 1 3120 3127 MUX2 $T=975260 669200 0 180 $X=970920 $Y=663780
X2224 3151 629 2 1 3142 3139 MUX2 $T=977740 618800 0 180 $X=973400 $Y=613380
X2225 3148 613 2 1 3143 3107 MUX2 $T=977740 649040 1 180 $X=973400 $Y=648660
X2226 3149 630 2 1 3144 3119 MUX2 $T=980220 659120 0 180 $X=975880 $Y=653700
X2227 3156 625 2 1 3149 3147 MUX2 $T=981460 669200 0 180 $X=977120 $Y=663780
X2228 3155 863 2 1 878 3133 MUX2 $T=982080 608720 1 180 $X=977740 $Y=608340
X2229 3157 605 2 1 3150 3051 MUX2 $T=982080 649040 0 180 $X=977740 $Y=643620
X2230 3161 629 2 1 3155 3151 MUX2 $T=983320 618800 0 180 $X=978980 $Y=613380
X2231 3171 630 2 1 3148 3149 MUX2 $T=985800 659120 0 180 $X=981460 $Y=653700
X2232 3162 863 2 1 882 3142 MUX2 $T=986420 608720 0 180 $X=982080 $Y=603300
X2233 3173 863 2 1 886 3155 MUX2 $T=988280 608720 1 180 $X=983940 $Y=608340
X2234 3170 629 2 1 3162 3161 MUX2 $T=988280 618800 0 180 $X=983940 $Y=613380
X2235 3159 625 2 1 3175 3156 MUX2 $T=983940 659120 0 0 $X=983940 $Y=658740
X2236 3175 630 2 1 3141 3120 MUX2 $T=988280 669200 0 180 $X=983940 $Y=663780
X2237 3165 625 2 1 3171 3159 MUX2 $T=984560 649040 0 0 $X=984560 $Y=648660
X2238 3187 605 2 1 3169 3065 MUX2 $T=992000 649040 0 180 $X=987660 $Y=643620
X2239 3184 630 2 1 3172 3171 MUX2 $T=992000 659120 0 180 $X=987660 $Y=653700
X2240 3185 863 2 1 891 3162 MUX2 $T=993240 608720 0 180 $X=988900 $Y=603300
X2241 3177 629 2 1 3185 3183 MUX2 $T=989520 608720 0 0 $X=989520 $Y=608340
X2242 3183 629 2 1 3173 3170 MUX2 $T=993860 618800 0 180 $X=989520 $Y=613380
X2243 3182 630 2 1 3178 3175 MUX2 $T=993860 659120 1 180 $X=989520 $Y=658740
X2244 3178 613 2 1 3157 3134 MUX2 $T=995720 669200 1 180 $X=991380 $Y=668820
X2245 3191 625 2 1 3184 3180 MUX2 $T=997580 649040 1 180 $X=993240 $Y=648660
X2246 3172 613 2 1 3187 3144 MUX2 $T=999440 659120 0 180 $X=995100 $Y=653700
X2247 3190 625 2 1 3206 3191 MUX2 $T=995720 659120 0 0 $X=995720 $Y=658740
X2248 3197 605 2 1 3193 3084 MUX2 $T=1000680 638960 1 180 $X=996340 $Y=638580
X2249 3207 605 2 1 3194 3060 MUX2 $T=1001920 649040 0 180 $X=997580 $Y=643620
X2250 3201 863 2 1 899 3185 MUX2 $T=1003160 608720 1 180 $X=998820 $Y=608340
X2251 3195 629 2 1 3216 3177 MUX2 $T=1001920 618800 1 0 $X=1001920 $Y=613380
X2252 3206 630 2 1 3220 3182 MUX2 $T=1002540 659120 0 0 $X=1002540 $Y=658740
X2253 3218 605 2 1 3208 3122 MUX2 $T=1008740 649040 0 180 $X=1004400 $Y=643620
X2254 3220 613 2 1 3207 3141 MUX2 $T=1008740 649040 1 180 $X=1004400 $Y=648660
X2255 3221 613 2 1 3209 3178 MUX2 $T=1008740 669200 0 180 $X=1004400 $Y=663780
X2256 3216 863 2 1 914 3173 MUX2 $T=1007500 618800 1 0 $X=1007500 $Y=613380
X2257 3228 613 2 1 3218 3172 MUX2 $T=1011840 659120 0 180 $X=1007500 $Y=653700
X2258 3209 605 2 1 3249 3096 MUX2 $T=1011220 638960 1 0 $X=1011220 $Y=633540
X2259 3230 605 2 1 3241 3157 MUX2 $T=1013080 669200 0 0 $X=1013080 $Y=668820
X2260 3243 907 2 1 915 886 MUX2 $T=1018660 608720 1 180 $X=1014320 $Y=608340
X2261 3233 605 2 1 3244 3143 MUX2 $T=1014940 649040 1 0 $X=1014940 $Y=643620
X2262 3237 605 2 1 3252 3187 MUX2 $T=1018040 659120 1 0 $X=1018040 $Y=653700
X2263 3250 605 2 1 3262 3131 MUX2 $T=1021140 649040 1 0 $X=1021140 $Y=643620
X2264 529 552 2451 1 2 2447 AO12S $T=721680 659120 0 180 $X=717960 $Y=653700
X2265 2465 557 2451 1 2 2457 AO12S $T=724780 669200 1 180 $X=721060 $Y=668820
X2266 529 558 2451 1 2 2463 AO12S $T=722300 659120 0 0 $X=722300 $Y=658740
X2267 2465 565 2451 1 2 2470 AO12S $T=725400 669200 0 0 $X=725400 $Y=668820
X2268 2465 576 2451 1 2 2482 AO12S $T=735320 669200 1 180 $X=731600 $Y=668820
X2269 2465 581 2451 1 2 2511 AO12S $T=735320 669200 0 0 $X=735320 $Y=668820
X2270 2293 503 2351 2350 2 1 2355 AN4S $T=678280 618800 0 0 $X=678280 $Y=618420
X2271 1557 2 1711 1732 1 AN2B1S $T=445160 669200 0 0 $X=445160 $Y=668820
X2272 1727 2 1732 1738 1 AN2B1S $T=448260 669200 0 0 $X=448260 $Y=668820
X2273 299 2 297 1907 1 AN2B1S $T=507160 699440 0 180 $X=504060 $Y=694020
X2274 26 21 2 1083 23 1 12 FA1 $T=248000 608720 0 180 $X=232500 $Y=603300
X2275 247 1653 2 1628 242 1 1649 FA1 $T=443920 608720 0 180 $X=428420 $Y=603300
X2276 237 1684 2 1600 1649 1 1707 FA1 $T=428420 608720 0 0 $X=428420 $Y=608340
X2277 1703 1700 2 1581 1707 1 1751 FA1 $T=442060 618800 1 0 $X=442060 $Y=613380
X2278 1755 1718 2 1513 1746 1 1713 FA1 $T=459420 659120 0 180 $X=443920 $Y=653700
X2279 1766 1741 2 1473 1759 1 1726 FA1 $T=463140 638960 1 180 $X=447640 $Y=638580
X2280 1730 1717 2 1512 1713 1 1759 FA1 $T=447640 649040 0 0 $X=447640 $Y=648660
X2281 1783 1706 2 1540 1739 1 1744 FA1 $T=469960 628880 0 180 $X=454460 $Y=623460
X2282 1890 1814 2 1930 1902 1 1872 FA1 $T=499720 618800 1 0 $X=499720 $Y=613380
X2283 1921 1877 2 1911 1913 1 1896 FA1 $T=515220 659120 0 180 $X=499720 $Y=653700
X2284 1868 1856 2 1931 1945 1 1940 FA1 $T=500340 638960 1 0 $X=500340 $Y=633540
X2285 1855 1894 2 1916 1940 1 1902 FA1 $T=516460 628880 0 180 $X=500960 $Y=623460
X2286 1883 1876 2 1937 1896 1 1945 FA1 $T=501580 649040 1 0 $X=501580 $Y=643620
X2287 2109 381 2 359 368 1 386 FA1 $T=578460 699440 1 0 $X=578460 $Y=694020
X2288 2148 402 2 363 388 1 2183 FA1 $T=595200 699440 1 0 $X=595200 $Y=694020
X2289 2156 405 2 2176 2183 1 408 FA1 $T=597060 689360 1 0 $X=597060 $Y=683940
X2290 2187 428 2 430 424 1 2223 FA1 $T=610700 689360 0 0 $X=610700 $Y=688980
X2291 567 586 2 583 2472 1 596 FA1 $T=727880 699440 1 0 $X=727880 $Y=694020
X2292 2518 2498 2 2494 2520 1 2472 FA1 $T=745240 689360 1 180 $X=729740 $Y=688980
X2293 2537 2542 2 2531 2545 1 2523 FA1 $T=757640 679280 0 180 $X=742140 $Y=673860
X2294 2507 610 2 580 2562 1 2574 FA1 $T=745240 689360 0 0 $X=745240 $Y=688980
X2295 2590 2561 2 2556 2591 1 2545 FA1 $T=763840 669200 1 180 $X=748340 $Y=668820
X2296 2604 2570 2 2556 2593 1 2550 FA1 $T=765700 679280 1 180 $X=750200 $Y=678900
X2297 2636 2614 2 2589 2640 1 2593 FA1 $T=778720 679280 0 180 $X=763220 $Y=673860
X2298 2641 2619 2 2589 2638 1 2591 FA1 $T=779960 669200 0 180 $X=764460 $Y=663780
X2299 2673 2689 2 2703 2680 1 2723 FA1 $T=786160 679280 1 0 $X=786160 $Y=673860
X2300 2732 2722 2 2765 2723 1 2775 FA1 $T=805380 679280 1 0 $X=805380 $Y=673860
X2301 2737 2731 2 2765 2706 1 2783 FA1 $T=806000 669200 0 0 $X=806000 $Y=668820
X2302 2784 2713 2 2788 2775 1 2828 FA1 $T=822120 679280 1 0 $X=822120 $Y=673860
X2303 2787 2813 2 2788 2783 1 2829 FA1 $T=822740 669200 0 0 $X=822740 $Y=668820
X2304 2822 720 2 698 2828 1 2858 FA1 $T=837000 679280 0 0 $X=837000 $Y=678900
X2305 2832 2860 2 698 2829 1 2875 FA1 $T=839480 669200 0 0 $X=839480 $Y=668820
X2306 2879 719 2 717 2845 1 714 FA1 $T=856840 689360 1 180 $X=841340 $Y=688980
X2307 2865 2837 2 699 2875 1 2906 FA1 $T=851880 689360 1 0 $X=851880 $Y=683940
X2308 177 2457 1 2 INV1CK $T=722920 669200 1 0 $X=722920 $Y=663780
X2309 467 469 478 2 1 2302 XOR3S $T=649140 699440 1 0 $X=649140 $Y=694020
X2310 2353 469 2340 2 1 2323 XOR3S $T=682620 689360 0 180 $X=671460 $Y=683940
X2311 1031 1051 1024 1038 1 2 ND3P $T=220720 618800 0 0 $X=220720 $Y=618420
X2312 1100 31 1103 1115 1 2 ND3P $T=245520 608720 0 0 $X=245520 $Y=608340
X2313 1737 1702 1728 1708 1 2 ND3P $T=455700 689360 1 180 $X=450740 $Y=688980
X2314 1850 1865 1857 1859 1 2 ND3P $T=489800 669200 0 0 $X=489800 $Y=668820
X2315 1852 1904 1886 1858 1 2 ND3P $T=498480 628880 0 0 $X=498480 $Y=628500
X2316 1863 1848 1875 1889 1 2 ND3P $T=499100 638960 0 0 $X=499100 $Y=638580
X2317 1900 1873 1887 1888 1 2 ND3P $T=507160 649040 1 180 $X=502200 $Y=648660
X2318 1941 1891 1927 1932 1 2 ND3P $T=516460 659120 1 180 $X=511500 $Y=658740
X2319 1968 1879 1953 1962 1 2 ND3P $T=523280 679280 0 180 $X=518320 $Y=673860
X2320 2740 2655 2742 2735 1 2 ND3P $T=810340 679280 1 180 $X=805380 $Y=678900
X2321 3325 3333 3328 3331 1 2 ND3P $T=1053380 618800 1 0 $X=1053380 $Y=613380
X2322 1168 1164 1 1151 2 OR2B1S $T=269080 638960 1 180 $X=265980 $Y=638580
X2323 1705 1699 1 1693 2 OR2B1S $T=442680 669200 0 180 $X=439580 $Y=663780
X2324 248 246 1 245 2 OR2B1S $T=443300 699440 1 0 $X=443300 $Y=694020
X2325 1557 1711 1 1727 2 OR2B1S $T=451980 679280 0 180 $X=448880 $Y=673860
X2326 1542 1736 1 1734 2 OR2B1S $T=449500 679280 0 0 $X=449500 $Y=678900
X2327 297 1882 1 298 2 OR2B1S $T=496620 699440 1 0 $X=496620 $Y=694020
X2328 1905 1914 1 1885 2 OR2B1S $T=507780 659120 1 180 $X=504680 $Y=658740
X2329 1836 1939 1 1946 2 OR2B1S $T=512120 669200 0 0 $X=512120 $Y=668820
X2330 1851 1980 1 1961 2 OR2B1S $T=527000 699440 0 180 $X=523900 $Y=694020
X2331 1063 1059 10 1 2 1069 1049 1081 1023 ICV_9 $T=231260 669200 0 0 $X=231260 $Y=668820
X2332 1075 1065 10 1 2 1079 1061 1081 1023 ICV_9 $T=234360 649040 0 0 $X=234360 $Y=648660
X2333 1077 1067 1080 1 2 1077 1074 1084 1023 ICV_9 $T=234980 649040 1 0 $X=234980 $Y=643620
X2334 1099 1104 10 1 2 1109 1110 1081 1023 ICV_9 $T=245520 649040 0 0 $X=245520 $Y=648660
X2335 1132 1140 1117 1 2 1140 30 1150 1023 ICV_9 $T=259160 618800 1 0 $X=259160 $Y=613380
X2336 1161 1084 1166 1 2 1168 1166 24 1023 ICV_9 $T=266600 649040 1 0 $X=266600 $Y=643620
X2337 1234 88 1254 1 2 1253 1254 1223 1023 ICV_9 $T=295740 649040 1 0 $X=295740 $Y=643620
X2338 1258 1250 1274 1 2 1265 1258 1267 1023 ICV_9 $T=298220 679280 0 0 $X=298220 $Y=678900
X2339 1275 1277 99 1 2 1277 1245 1287 1023 ICV_9 $T=303180 638960 1 0 $X=303180 $Y=633540
X2340 1714 1709 1705 1 2 1529 1723 1692 1023 ICV_9 $T=444540 669200 1 0 $X=444540 $Y=663780
X2341 1848 1852 1855 1 2 1855 1858 1762 1023 ICV_9 $T=491040 628880 0 0 $X=491040 $Y=628500
X2342 1873 1863 1868 1 2 1873 1875 1766 1023 ICV_9 $T=493520 638960 0 0 $X=493520 $Y=638580
X2343 1710 1850 1879 1 2 1869 1857 1879 1023 ICV_9 $T=494760 669200 0 0 $X=494760 $Y=668820
X2344 1865 1941 1755 1 2 1755 1932 1921 1023 ICV_9 $T=516460 659120 0 0 $X=516460 $Y=658740
X2345 2560 2564 2499 1 2 2569 609 2564 1023 ICV_9 $T=753300 618800 0 0 $X=753300 $Y=618420
X2346 3132 3126 3003 1 2 3128 3121 3140 1023 ICV_9 $T=967820 618800 0 0 $X=967820 $Y=618420
X2347 3336 3325 3346 1 2 3346 3328 942 1023 ICV_9 $T=1062060 618800 1 0 $X=1062060 $Y=613380
X2348 1056 1058 1030 2 1 3 XOR3 $T=231880 638960 0 180 $X=220720 $Y=633540
X2349 1039 1025 1072 2 1 22 XOR3 $T=230020 618800 0 0 $X=230020 $Y=618420
X2350 1077 1084 1080 2 1 1083 XOR3 $T=251720 649040 0 180 $X=240560 $Y=643620
X2351 28 30 1135 2 1 36 XOR3 $T=248000 608720 1 0 $X=248000 $Y=603300
X2352 1162 1156 1193 2 1 62 XOR3 $T=269700 608720 1 0 $X=269700 $Y=603300
X2353 1680 249 250 2 1 1749 XOR3 $T=446400 699440 1 0 $X=446400 $Y=694020
X2354 1719 1697 1751 2 1 255 XOR3 $T=447640 608720 0 0 $X=447640 $Y=608340
X2355 1729 1562 1744 2 1 1770 XOR3 $T=454460 618800 0 0 $X=454460 $Y=618420
X2356 1810 1802 1872 2 1 1854 XOR3 $T=486080 618800 0 0 $X=486080 $Y=618420
X2357 1860 1682 1881 2 1 1919 XOR3 $T=497240 679280 1 0 $X=497240 $Y=673860
X2358 1874 1749 300 2 1 1920 XOR3 $T=497240 689360 1 0 $X=497240 $Y=683940
X2359 1869 1710 1918 2 1 1923 XOR3 $T=498480 669200 0 0 $X=498480 $Y=668820
X2360 1855 1762 1912 2 1 1965 XOR3 $T=505920 628880 0 0 $X=505920 $Y=628500
X2361 1890 1783 1904 2 1 1964 XOR3 $T=506540 608720 0 0 $X=506540 $Y=608340
X2362 1868 1766 1915 2 1 1954 XOR3 $T=506540 638960 0 0 $X=506540 $Y=638580
X2363 1883 1730 1952 2 1 1958 XOR3 $T=507160 649040 0 0 $X=507160 $Y=648660
X2364 1921 1755 1955 2 1 1959 XOR3 $T=520180 659120 0 0 $X=520180 $Y=658740
X2365 1973 1745 1979 2 1 2007 XOR3 $T=529480 679280 1 0 $X=529480 $Y=673860
X2366 1895 1747 1944 2 1 2017 XOR3 $T=535680 689360 0 0 $X=535680 $Y=688980
X2367 3274 3279 3283 2 1 937 XOR3 $T=1038500 618800 0 0 $X=1038500 $Y=618420
X2368 3335 3342 3360 2 1 952 XOR3 $T=1063300 608720 0 0 $X=1063300 $Y=608340
X2369 941 3320 3321 2 1 954 XOR3 $T=1064540 608720 1 0 $X=1064540 $Y=603300
X2370 942 3346 3363 2 1 956 XOR3 $T=1067020 618800 1 0 $X=1067020 $Y=613380
X2371 2847 716 572 1 2 AN2B1 $T=843820 608720 1 0 $X=843820 $Y=603300
X2372 1105 1170 1 1175 2 NR2T $T=265980 679280 0 0 $X=265980 $Y=678900
X2373 1149 1177 1 1175 2 NR2T $T=267840 679280 1 0 $X=267840 $Y=673860
X2374 1102 1175 1 1197 2 NR2T $T=274660 679280 0 0 $X=274660 $Y=678900
X2375 1125 1204 1 1179 2 NR2T $T=279000 638960 0 0 $X=279000 $Y=638580
X2376 1295 108 1 105 2 NR2T $T=313100 638960 1 0 $X=313100 $Y=633540
X2377 259 257 1 122 2 NR2T $T=462520 699440 0 180 $X=457560 $Y=694020
X2378 2880 731 1 735 2 NR2T $T=859940 608720 1 180 $X=854980 $Y=608340
X2379 2985 2968 1 2878 2 NR2T $T=895900 628880 0 180 $X=890940 $Y=623460
X2380 3159 127 1 616 2 NR2T $T=977740 649040 0 0 $X=977740 $Y=648660
X2381 3263 3222 1 922 2 NR2T $T=1028580 608720 1 180 $X=1023620 $Y=608340
X2382 3266 3239 1 922 2 NR2T $T=1031680 618800 0 180 $X=1026720 $Y=613380
X2383 627 628 599 631 632 2589 1 2 2635 AO222S $T=768800 689360 0 0 $X=768800 $Y=688980
X2384 566 627 631 580 2630 632 1 2 2643 AO222S $T=770660 679280 0 0 $X=770660 $Y=678900
X2385 627 701 699 631 632 2705 1 2 2768 AO222S $T=835760 689360 0 180 $X=829560 $Y=683940
X2386 704 627 631 698 2669 632 1 2 2759 AO222S $T=836380 679280 1 180 $X=830180 $Y=678900
X2387 2871 630 1 2862 2868 630 2 MOAI1H $T=855600 638960 0 180 $X=848160 $Y=633540
X2388 1860 1682 2 1847 1841 1682 1 AOI22H $T=494760 679280 1 180 $X=487320 $Y=678900
X2389 1783 1890 2 1904 1903 1783 1 AOI22H $T=497240 608720 0 0 $X=497240 $Y=608340
X2390 3320 941 2 3321 943 3320 1 AOI22H $T=1064540 608720 0 180 $X=1057100 $Y=603300
X2391 1028 1 1032 1034 2 ND2P $T=220720 628880 1 0 $X=220720 $Y=623460
X2392 1039 1 1025 1038 2 ND2P $T=228160 608720 0 0 $X=228160 $Y=608340
X2393 1064 1 1055 1026 2 ND2P $T=233120 669200 0 180 $X=229400 $Y=663780
X2394 1061 1 1065 1039 2 ND2P $T=230640 649040 0 0 $X=230640 $Y=648660
X2395 1088 1 1091 1046 2 ND2P $T=239320 669200 1 0 $X=239320 $Y=663780
X2396 1101 1 1106 1029 2 ND2P $T=244280 628880 0 0 $X=244280 $Y=628500
X2397 1122 1 1123 1050 2 ND2P $T=251100 638960 0 0 $X=251100 $Y=638580
X2398 1133 1 1131 28 2 ND2P $T=256680 659120 1 0 $X=256680 $Y=653700
X2399 1146 1 1136 1077 2 ND2P $T=260400 669200 0 180 $X=256680 $Y=663780
X2400 1145 1 40 43 2 ND2P $T=264740 608720 0 180 $X=261020 $Y=603300
X2401 1239 1 1217 1204 2 ND2P $T=289540 638960 0 180 $X=285820 $Y=633540
X2402 84 1 85 89 2 ND2P $T=292640 608720 0 0 $X=292640 $Y=608340
X2403 1239 1 1245 1180 2 ND2P $T=293260 638960 1 0 $X=293260 $Y=633540
X2404 96 1 1265 1170 2 ND2P $T=303180 689360 0 180 $X=299460 $Y=683940
X2405 96 1 1279 1177 2 ND2P $T=302560 679280 1 0 $X=302560 $Y=673860
X2406 154 1 157 160 2 ND2P $T=345960 608720 1 0 $X=345960 $Y=603300
X2407 1526 1 1520 1529 2 ND2P $T=394940 669200 1 180 $X=391220 $Y=668820
X2408 1677 1 1683 1692 2 ND2P $T=440820 669200 1 180 $X=437100 $Y=668820
X2409 1689 1 1696 1694 2 ND2P $T=439580 689360 0 0 $X=439580 $Y=688980
X2410 1680 1 250 1728 2 ND2P $T=448880 689360 1 180 $X=445160 $Y=688980
X2411 1853 1 1841 1844 2 ND2P $T=493520 679280 0 180 $X=489800 $Y=673860
X2412 1862 1 1871 1847 2 ND2P $T=493520 679280 1 0 $X=493520 $Y=673860
X2413 1730 1 1891 1887 2 ND2P $T=501580 649040 0 180 $X=497860 $Y=643620
X2414 1883 1 1891 1900 2 ND2P $T=502200 649040 1 180 $X=498480 $Y=648660
X2415 1895 1 1901 1862 2 ND2P $T=499100 679280 0 0 $X=499100 $Y=678900
X2416 1899 1 1903 1893 2 ND2P $T=499720 608720 1 0 $X=499720 $Y=603300
X2417 1921 1 1865 1927 2 ND2P $T=507780 659120 0 0 $X=507780 $Y=658740
X2418 302 1 303 1935 2 ND2P $T=512740 699440 0 180 $X=509020 $Y=694020
X2419 1947 1 1926 1934 2 ND2P $T=513360 689360 0 180 $X=509640 $Y=683940
X2420 1933 1 1938 1905 2 ND2P $T=511500 669200 1 0 $X=511500 $Y=663780
X2421 1951 1 1943 1928 2 ND2P $T=516460 699440 0 180 $X=512740 $Y=694020
X2422 1745 1 1844 1953 2 ND2P $T=518320 679280 0 180 $X=514600 $Y=673860
X2423 574 1 2430 2489 2 ND2P $T=734080 608720 0 180 $X=730360 $Y=603300
X2424 577 1 2438 2488 2 ND2P $T=733460 618800 0 0 $X=733460 $Y=618420
X2425 2616 1 2624 634 2 ND2P $T=773140 618800 1 0 $X=773140 $Y=613380
X2426 2869 1 2844 2815 2 ND2P $T=852500 638960 1 180 $X=848780 $Y=638580
X2427 2893 1 2835 2886 2 ND2P $T=860560 628880 0 180 $X=856840 $Y=623460
X2428 2929 1 2988 2968 2 ND2P $T=894660 649040 1 0 $X=894660 $Y=643620
X2429 3121 1 3126 864 2 ND2P $T=964100 618800 0 0 $X=964100 $Y=618420
X2430 3113 1 3201 3222 2 ND2P $T=1008740 608720 1 180 $X=1005020 $Y=608340
X2431 3113 1 3216 3239 2 ND2P $T=1017420 618800 0 180 $X=1013700 $Y=613380
X2432 913 1 3260 922 2 ND2P $T=1032920 608720 1 180 $X=1029200 $Y=608340
X2433 588 1 3294 3288 2 ND2P $T=1040980 638960 0 0 $X=1040980 $Y=638580
X2434 3309 1 3288 3313 2 ND2P $T=1054000 649040 1 180 $X=1050280 $Y=648660
X2435 3327 1 3324 3321 2 ND2P $T=1057720 608720 1 180 $X=1054000 $Y=608340
X2436 3317 1 3286 3338 2 ND2P $T=1057100 628880 1 0 $X=1057100 $Y=623460
X2437 942 1 3336 3331 2 ND2P $T=1058340 618800 1 0 $X=1058340 $Y=613380
X2438 3343 1 3337 945 2 ND2P $T=1064540 618800 1 180 $X=1060820 $Y=618420
X2439 3338 1 3345 3336 2 ND2P $T=1064540 618800 0 0 $X=1064540 $Y=618420
X2440 3352 1 3359 947 2 ND2P $T=1072600 649040 1 0 $X=1072600 $Y=643620
X2441 1162 47 1156 1 2 50 MAO222 $T=264740 608720 1 0 $X=264740 $Y=603300
X2442 1733 1501 1726 1 2 1739 MAO222 $T=447020 638960 1 0 $X=447020 $Y=633540
X2443 3274 3279 3283 1 2 3286 MAO222 $T=1033540 618800 0 0 $X=1033540 $Y=618420
X2444 305 1 306 307 2 296 ND3HT $T=516460 699440 1 0 $X=516460 $Y=694020
X2445 2398 1 2402 2405 2 2412 ND3HT $T=707420 618800 0 180 $X=699980 $Y=613380
X2446 2398 1 2405 2402 2 2413 ND3HT $T=705560 618800 0 0 $X=705560 $Y=618420
X2447 2398 1 2405 2402 2 2438 ND3HT $T=720440 618800 1 180 $X=713000 $Y=618420
X2448 2823 2821 1 2807 2 OR2T $T=839480 659120 0 180 $X=833280 $Y=653700
X2449 3310 3313 1 3317 2 OR2T $T=1049660 618800 0 0 $X=1049660 $Y=618420
X2450 1026 1029 1 1045 1032 2 OAI12H $T=231880 628880 0 180 $X=225680 $Y=623460
X2451 1068 1043 1 1054 8 2 OAI12H $T=234360 628880 1 180 $X=228160 $Y=628500
X2452 1504 1686 1 1702 1696 2 OAI12H $T=446400 689360 0 180 $X=440200 $Y=683940
X2453 1680 238 1667 2 1637 209 1 AO22S $T=437720 689360 1 180 $X=432760 $Y=688980
X2454 1814 285 1795 2 1794 278 1 AO22S $T=483600 628880 1 180 $X=478640 $Y=628500
X2455 2055 350 2046 2 349 346 1 AO22S $T=564820 608720 1 180 $X=559860 $Y=608340
X2456 2060 350 2067 2 352 346 1 AO22S $T=569780 608720 1 180 $X=564820 $Y=608340
X2457 2071 350 2099 2 362 346 1 AO22S $T=579700 608720 1 180 $X=574740 $Y=608340
X2458 2125 350 2115 2 370 346 1 AO22S $T=587140 638960 1 180 $X=582180 $Y=638580
X2459 2129 350 2130 2 373 346 1 AO22S $T=590240 608720 1 180 $X=585280 $Y=608340
X2460 2136 350 2120 2 376 346 1 AO22S $T=590860 638960 0 180 $X=585900 $Y=633540
X2461 2145 350 2154 2 389 346 1 AO22S $T=594580 608720 0 0 $X=594580 $Y=608340
X2462 2171 350 2158 2 397 346 1 AO22S $T=605120 638960 1 180 $X=600160 $Y=638580
X2463 2173 350 2169 2 399 346 1 AO22S $T=606980 608720 1 180 $X=602020 $Y=608340
X2464 2180 350 2170 2 401 346 1 AO22S $T=607600 638960 0 180 $X=602640 $Y=633540
X2465 2189 350 2160 2 404 346 1 AO22S $T=610700 628880 1 180 $X=605740 $Y=628500
X2466 2193 350 2175 2 2181 346 1 AO22S $T=612560 628880 0 180 $X=607600 $Y=623460
X2467 2205 350 2199 2 413 346 1 AO22S $T=616900 628880 1 180 $X=611940 $Y=628500
X2468 2233 423 2236 2 435 432 1 AO22S $T=631160 628880 1 180 $X=626200 $Y=628500
X2469 2267 423 2260 2 2253 432 1 AO22S $T=640460 628880 0 180 $X=635500 $Y=623460
X2470 571 2480 2485 2 2491 2499 1 AO22S $T=730980 628880 0 0 $X=730980 $Y=628500
X2471 582 2485 2509 2 2514 2499 1 AO22S $T=737180 628880 0 0 $X=737180 $Y=628500
X2472 594 2485 2528 2 2533 2499 1 AO22S $T=742140 638960 1 0 $X=742140 $Y=633540
X2473 678 588 2750 2 2755 2602 1 AO22S $T=810960 618800 1 0 $X=810960 $Y=613380
X2474 2771 2430 695 2 696 529 1 AO22S $T=828320 638960 0 0 $X=828320 $Y=638580
X2475 2707 2430 703 2 700 529 1 AO22S $T=837620 649040 0 180 $X=832660 $Y=643620
X2476 812 3018 3003 2 3025 3029 1 AO22S $T=914500 608720 1 0 $X=914500 $Y=603300
X2477 815 3003 3009 2 3026 3029 1 AO22S $T=914500 628880 1 0 $X=914500 $Y=623460
X2478 832 3003 3039 2 3053 3029 1 AO22S $T=930000 618800 0 0 $X=930000 $Y=618420
X2479 841 3003 3058 2 3070 3029 1 AO22S $T=937440 618800 0 0 $X=937440 $Y=618420
X2480 860 3003 3105 2 3100 3029 1 AO22S $T=958520 618800 1 180 $X=953560 $Y=618420
X2481 1256 1218 2 1319 1 1226 MUX2S $T=313720 618800 0 0 $X=313720 $Y=618420
X2482 1312 106 2 1320 1 1296 MUX2S $T=314340 669200 0 0 $X=314340 $Y=668820
X2483 1324 106 2 1331 1 1338 MUX2S $T=319300 669200 1 0 $X=319300 $Y=663780
X2484 1325 99 2 1350 1 1361 MUX2S $T=326740 689360 1 0 $X=326740 $Y=683940
X2485 1350 99 2 1360 1 1363 MUX2S $T=327360 679280 0 0 $X=327360 $Y=678900
X2486 116 1383 2 1363 1 153 MUX2S $T=336660 689360 1 0 $X=336660 $Y=683940
X2487 1335 1218 2 1388 1 1343 MUX2S $T=337900 618800 1 0 $X=337900 $Y=613380
X2488 1384 99 2 1393 1 1395 MUX2S $T=339140 669200 0 0 $X=339140 $Y=668820
X2489 1378 1383 2 1395 1 1408 MUX2S $T=340380 689360 0 0 $X=340380 $Y=688980
X2490 1361 1389 2 1378 1 155 MUX2S $T=341000 699440 1 0 $X=341000 $Y=694020
X2491 1363 1383 2 1390 1 156 MUX2S $T=342240 679280 0 0 $X=342240 $Y=678900
X2492 1390 93 2 1403 1 1406 MUX2S $T=343480 679280 1 0 $X=343480 $Y=673860
X2493 1393 99 2 1407 1 1403 MUX2S $T=344720 669200 0 0 $X=344720 $Y=668820
X2494 1395 93 2 1410 1 1413 MUX2S $T=345960 689360 1 0 $X=345960 $Y=683940
X2495 155 159 2 1413 1 162 MUX2S $T=346580 699440 1 0 $X=346580 $Y=694020
X2496 1403 93 2 1420 1 1424 MUX2S $T=349060 679280 1 0 $X=349060 $Y=673860
X2497 1409 1292 2 1421 1 1418 MUX2S $T=349680 659120 1 0 $X=349680 $Y=653700
X2498 1407 99 2 1416 1 1410 MUX2S $T=354640 669200 1 180 $X=350300 $Y=668820
X2499 1401 1362 2 1428 1 1311 MUX2S $T=352160 659120 0 0 $X=352160 $Y=658740
X2500 1413 159 2 1427 1 170 MUX2S $T=352160 699440 1 0 $X=352160 $Y=694020
X2501 1382 1362 2 1432 1 1353 MUX2S $T=354640 649040 0 0 $X=354640 $Y=648660
X2502 1418 1362 2 1436 1 1369 MUX2S $T=355260 659120 1 0 $X=355260 $Y=653700
X2503 1268 1215 2 1438 1 174 MUX2S $T=356500 608720 0 0 $X=356500 $Y=608340
X2504 1414 1218 2 1441 1 1438 MUX2S $T=357740 618800 1 0 $X=357740 $Y=613380
X2505 1431 93 2 1434 1 1414 MUX2S $T=362080 618800 1 180 $X=357740 $Y=618420
X2506 149 159 2 1408 1 180 MUX2S $T=357740 699440 1 0 $X=357740 $Y=694020
X2507 1421 1292 2 1446 1 1428 MUX2S $T=360840 659120 1 0 $X=360840 $Y=653700
X2508 175 1215 2 1427 1 1449 MUX2S $T=360840 659120 0 0 $X=360840 $Y=658740
X2509 166 1215 2 1427 1 1450 MUX2S $T=360840 669200 0 0 $X=360840 $Y=668820
X2510 1288 1215 2 1448 1 184 MUX2S $T=362080 608720 0 0 $X=362080 $Y=608340
X2511 1415 93 2 1452 1 1388 MUX2S $T=362700 618800 0 0 $X=362700 $Y=618420
X2512 178 91 2 1440 1 1460 MUX2S $T=363320 699440 1 0 $X=363320 $Y=694020
X2513 1440 1215 2 1427 1 1456 MUX2S $T=363940 669200 1 0 $X=363940 $Y=663780
X2514 180 91 2 1451 1 1466 MUX2S $T=366420 689360 0 0 $X=366420 $Y=688980
X2515 183 1215 2 1457 1 1480 MUX2S $T=368900 679280 1 0 $X=368900 $Y=673860
X2516 1432 1362 2 1476 1 1484 MUX2S $T=370140 649040 0 0 $X=370140 $Y=648660
X2517 1458 1346 2 1479 1 1434 MUX2S $T=370760 628880 0 0 $X=370760 $Y=628500
X2518 1461 1374 2 1482 1 1459 MUX2S $T=371380 649040 1 0 $X=371380 $Y=643620
X2519 1467 159 2 1441 1 1491 MUX2S $T=373240 618800 1 0 $X=373240 $Y=613380
X2520 1302 1215 2 1491 1 195 MUX2S $T=373860 608720 0 0 $X=373860 $Y=608340
X2521 1246 66 2 1484 1 1494 MUX2S $T=375720 649040 0 0 $X=375720 $Y=648660
X2522 1343 1215 2 1499 1 200 MUX2S $T=378820 618800 1 0 $X=378820 $Y=613380
X2523 1472 1215 2 1441 1 1507 MUX2S $T=379440 608720 0 0 $X=379440 $Y=608340
X2524 1404 1215 2 1441 1 1527 MUX2S $T=384400 618800 1 0 $X=384400 $Y=613380
X2525 1426 1215 2 1441 1 1522 MUX2S $T=385640 608720 0 0 $X=385640 $Y=608340
X2526 1423 1362 2 1514 1 1506 MUX2S $T=385640 649040 0 0 $X=385640 $Y=648660
X2527 1428 1362 2 1511 1 1528 MUX2S $T=386880 659120 1 0 $X=386880 $Y=653700
X2528 1225 1532 2 1528 1 1541 MUX2S $T=390600 638960 0 0 $X=390600 $Y=638580
X2529 1311 1532 2 1549 1 1556 MUX2S $T=394940 649040 0 0 $X=394940 $Y=648660
X2530 1528 1532 2 1476 1 1561 MUX2S $T=396180 638960 0 0 $X=396180 $Y=638580
X2531 1511 1544 2 1476 1 1549 MUX2S $T=396180 659120 1 0 $X=396180 $Y=653700
X2532 1506 1532 2 1476 1 1580 MUX2S $T=402380 638960 0 0 $X=402380 $Y=638580
X2533 1369 1532 2 1476 1 1585 MUX2S $T=403000 649040 1 0 $X=403000 $Y=643620
X2534 1563 1560 2 1567 1 1587 MUX2S $T=403620 679280 0 0 $X=403620 $Y=678900
X2535 1575 1560 2 1574 1 1589 MUX2S $T=405480 659120 1 0 $X=405480 $Y=653700
X2536 1567 1560 2 1548 1 1593 MUX2S $T=406100 679280 1 0 $X=406100 $Y=673860
X2537 1584 1560 2 1596 1 1602 MUX2S $T=408580 649040 1 0 $X=408580 $Y=643620
X2538 1587 207 2 1599 1 219 MUX2S $T=409200 679280 0 0 $X=409200 $Y=678900
X2539 1591 207 2 1593 1 220 MUX2S $T=409820 689360 1 0 $X=409820 $Y=683940
X2540 1594 1590 2 1606 1 1609 MUX2S $T=411060 659120 1 0 $X=411060 $Y=653700
X2541 1595 1292 2 1594 1 1612 MUX2S $T=411060 659120 0 0 $X=411060 $Y=658740
X2542 1596 1560 2 1614 1 1606 MUX2S $T=414160 649040 1 0 $X=414160 $Y=643620
X2543 219 1544 2 1615 1 225 MUX2S $T=414780 679280 1 0 $X=414780 $Y=673860
X2544 221 1544 2 1611 1 226 MUX2S $T=415400 689360 0 0 $X=415400 $Y=688980
X2545 1602 1590 2 1617 1 1620 MUX2S $T=416640 659120 1 0 $X=416640 $Y=653700
X2546 1611 1544 2 1620 1 1625 MUX2S $T=417260 669200 1 0 $X=417260 $Y=663780
X2547 223 222 2 1610 1 229 MUX2S $T=417260 699440 1 0 $X=417260 $Y=694020
X2548 1610 1544 2 1609 1 235 MUX2S $T=420360 679280 1 0 $X=420360 $Y=673860
X2549 228 232 2 1632 1 1639 MUX2S $T=420980 689360 0 0 $X=420980 $Y=688980
X2550 231 232 2 1625 1 1637 MUX2S $T=421600 699440 1 0 $X=421600 $Y=694020
X2551 1615 1544 2 1627 1 1629 MUX2S $T=422220 659120 1 0 $X=422220 $Y=653700
X2552 1620 1544 2 1618 1 1641 MUX2S $T=422840 669200 1 0 $X=422840 $Y=663780
X2553 1625 1532 2 1618 1 1651 MUX2S $T=424080 649040 0 0 $X=424080 $Y=648660
X2554 224 1532 2 1655 1 1659 MUX2S $T=427180 669200 1 0 $X=427180 $Y=663780
X2555 226 1532 2 1641 1 1660 MUX2S $T=427180 669200 0 0 $X=427180 $Y=668820
X2556 1757 256 2 1761 1 1765 MUX2S $T=460040 679280 1 0 $X=460040 $Y=673860
X2557 1752 256 2 1764 1 1767 MUX2S $T=462520 669200 1 0 $X=462520 $Y=663780
X2558 1763 256 2 1771 1 1779 MUX2S $T=463760 649040 0 0 $X=463760 $Y=648660
X2559 1753 256 2 1763 1 1777 MUX2S $T=464380 659120 1 0 $X=464380 $Y=653700
X2560 1764 256 2 1753 1 1778 MUX2S $T=464380 659120 0 0 $X=464380 $Y=658740
X2561 1765 1774 2 1767 1 260 MUX2S $T=468720 679280 0 180 $X=464380 $Y=673860
X2562 258 263 2 1769 1 266 MUX2S $T=466860 699440 1 0 $X=466860 $Y=694020
X2563 1767 1774 2 1777 1 1790 MUX2S $T=468100 669200 1 0 $X=468100 $Y=663780
X2564 260 265 2 1788 1 268 MUX2S $T=468720 679280 1 0 $X=468720 $Y=673860
X2565 261 1774 2 1765 1 272 MUX2S $T=468720 689360 0 0 $X=468720 $Y=688980
X2566 1777 1774 2 1785 1 1788 MUX2S $T=469340 649040 0 0 $X=469340 $Y=648660
X2567 1779 1774 2 1789 1 1791 MUX2S $T=469960 659120 1 0 $X=469960 $Y=653700
X2568 1769 1774 2 1772 1 274 MUX2S $T=470580 689360 1 0 $X=470580 $Y=683940
X2569 266 265 2 1786 1 269 MUX2S $T=471200 699440 1 0 $X=471200 $Y=694020
X2570 1786 265 2 1791 1 275 MUX2S $T=471820 669200 0 0 $X=471820 $Y=668820
X2571 269 273 2 1796 1 1798 MUX2S $T=473060 679280 1 0 $X=473060 $Y=673860
X2572 1790 265 2 1797 1 1799 MUX2S $T=473680 669200 1 0 $X=473680 $Y=663780
X2573 272 265 2 1790 1 282 MUX2S $T=474300 689360 0 0 $X=474300 $Y=688980
X2574 1805 273 2 1773 1 1775 MUX2S $T=479260 638960 0 180 $X=474920 $Y=633540
X2575 1785 1774 2 1793 1 1797 MUX2S $T=474920 649040 0 0 $X=474920 $Y=648660
X2576 274 265 2 1792 1 280 MUX2S $T=474920 679280 0 0 $X=474920 $Y=678900
X2577 1803 273 2 1773 1 1794 MUX2S $T=479880 638960 1 180 $X=475540 $Y=638580
X2578 276 273 2 1799 1 284 MUX2S $T=475540 699440 1 0 $X=475540 $Y=694020
X2579 1791 265 2 1773 1 1796 MUX2S $T=476160 669200 0 0 $X=476160 $Y=668820
X2580 1788 265 2 1808 1 1805 MUX2S $T=479260 649040 0 0 $X=479260 $Y=648660
X2581 281 273 2 1805 1 1812 MUX2S $T=479260 679280 0 0 $X=479260 $Y=678900
X2582 1797 265 2 1773 1 1815 MUX2S $T=479880 669200 1 0 $X=479880 $Y=663780
X2583 277 273 2 1803 1 1816 MUX2S $T=479880 689360 1 0 $X=479880 $Y=683940
X2584 1800 265 2 1773 1 1821 MUX2S $T=480500 659120 1 0 $X=480500 $Y=653700
X2585 1799 273 2 1773 1 1823 MUX2S $T=481740 638960 1 0 $X=481740 $Y=633540
X2586 1808 265 2 1773 1 1824 MUX2S $T=481740 649040 1 0 $X=481740 $Y=643620
X2587 268 273 2 1824 1 1828 MUX2S $T=483600 649040 0 0 $X=483600 $Y=648660
X2588 282 273 2 1815 1 1833 MUX2S $T=484220 669200 1 0 $X=484220 $Y=663780
X2589 280 273 2 1821 1 1832 MUX2S $T=486080 659120 1 0 $X=486080 $Y=653700
X2590 1994 317 2 310 1 1970 MUX2S $T=535060 638960 1 180 $X=530720 $Y=638580
X2591 1975 319 2 1986 1 2005 MUX2S $T=534440 638960 1 0 $X=534440 $Y=633540
X2592 321 319 2 324 1 1991 MUX2S $T=535680 659120 0 0 $X=535680 $Y=658740
X2593 1986 317 2 1994 1 2001 MUX2S $T=536300 638960 0 0 $X=536300 $Y=638580
X2594 1988 319 2 321 1 1982 MUX2S $T=536300 649040 0 0 $X=536300 $Y=648660
X2595 1969 317 2 1995 1 2011 MUX2S $T=536920 628880 0 0 $X=536920 $Y=628500
X2596 2009 319 2 322 1 2022 MUX2S $T=541880 659120 0 0 $X=541880 $Y=658740
X2597 2585 2581 2 2544 1 2573 MUX2S $T=762600 638960 0 180 $X=758260 $Y=633540
X2598 2597 2581 2 2585 1 2555 MUX2S $T=764460 638960 1 180 $X=760120 $Y=638580
X2599 2601 2557 2 2592 1 2572 MUX2S $T=766320 628880 1 180 $X=761980 $Y=628500
X2600 2613 2581 2 2544 1 2592 MUX2S $T=768800 638960 0 180 $X=764460 $Y=633540
X2601 2596 611 2 2571 1 626 MUX2S $T=765080 608720 0 0 $X=765080 $Y=608340
X2602 2620 2557 2 2606 1 2560 MUX2S $T=770660 628880 1 180 $X=766320 $Y=628500
X2603 2631 629 2 2596 1 2617 MUX2S $T=773760 608720 1 180 $X=769420 $Y=608340
X2604 2615 2611 2 2603 1 2627 MUX2S $T=769420 649040 0 0 $X=769420 $Y=648660
X2605 2629 2581 2 2544 1 2606 MUX2S $T=775000 628880 1 180 $X=770660 $Y=628500
X2606 2648 617 2 2617 1 633 MUX2S $T=777480 608720 0 180 $X=773140 $Y=603300
X2607 2649 2611 2 2633 1 2632 MUX2S $T=778720 649040 0 180 $X=774380 $Y=643620
X2608 2650 2581 2 2629 1 2566 MUX2S $T=779340 628880 1 180 $X=775000 $Y=628500
X2609 2632 2622 2 2627 1 2653 MUX2S $T=775620 638960 1 0 $X=775620 $Y=633540
X2610 2633 2611 2 2615 1 2625 MUX2S $T=776240 649040 0 0 $X=776240 $Y=648660
X2611 2658 629 2 2631 1 2639 MUX2S $T=781200 608720 1 180 $X=776860 $Y=608340
X2612 2654 2622 2 2625 1 2597 MUX2S $T=783680 638960 1 180 $X=779340 $Y=638580
X2613 2653 2581 2 2544 1 2652 MUX2S $T=784300 628880 1 180 $X=779960 $Y=628500
X2614 2667 2611 2 2649 1 2654 MUX2S $T=784300 649040 0 180 $X=779960 $Y=643620
X2615 2639 617 2 626 1 647 MUX2S $T=780580 608720 1 0 $X=780580 $Y=603300
X2616 2665 2557 2 2652 1 2609 MUX2S $T=784920 628880 0 180 $X=780580 $Y=623460
X2617 2666 2622 2 2632 1 2650 MUX2S $T=784920 638960 0 180 $X=780580 $Y=633540
X2618 2672 629 2 2658 1 2648 MUX2S $T=786780 608720 1 180 $X=782440 $Y=608340
X2619 2675 617 2 2639 1 649 MUX2S $T=789880 608720 0 180 $X=785540 $Y=603300
X2620 2681 2557 2 2555 1 2651 MUX2S $T=789880 628880 0 180 $X=785540 $Y=623460
X2621 2684 2581 2 2653 1 2565 MUX2S $T=789880 628880 1 180 $X=785540 $Y=628500
X2622 2685 2622 2 2654 1 2670 MUX2S $T=789880 638960 1 180 $X=785540 $Y=638580
X2623 2679 2611 2 2667 1 2666 MUX2S $T=789880 649040 0 180 $X=785540 $Y=643620
X2624 2670 2581 2 2613 1 2578 MUX2S $T=790500 638960 0 180 $X=786160 $Y=633540
X2625 2690 629 2 2672 1 2675 MUX2S $T=792360 608720 1 180 $X=788020 $Y=608340
X2626 2692 617 2 2648 1 654 MUX2S $T=795460 608720 0 180 $X=791120 $Y=603300
X2627 2695 2557 2 2566 1 2677 MUX2S $T=795460 628880 0 180 $X=791120 $Y=623460
X2628 2696 2581 2 2650 1 2620 MUX2S $T=795460 628880 1 180 $X=791120 $Y=628500
X2629 2697 2622 2 2666 1 2684 MUX2S $T=795460 638960 0 180 $X=791120 $Y=633540
X2630 2687 2611 2 2688 1 2697 MUX2S $T=791120 638960 0 0 $X=791120 $Y=638580
X2631 2688 2611 2 2679 1 2685 MUX2S $T=791120 649040 1 0 $X=791120 $Y=643620
X2632 2704 629 2 2690 1 2692 MUX2S $T=797320 608720 1 180 $X=792980 $Y=608340
X2633 2700 2581 2 2597 1 2582 MUX2S $T=800420 628880 1 180 $X=796080 $Y=628500
X2634 2719 2622 2 2685 1 2700 MUX2S $T=801040 649040 0 180 $X=796700 $Y=643620
X2635 671 617 2 2692 1 666 MUX2S $T=804760 608720 0 180 $X=800420 $Y=603300
X2636 2733 613 2 2670 1 2601 MUX2S $T=806000 638960 1 180 $X=801660 $Y=638580
X2637 2715 629 2 2704 1 2708 MUX2S $T=806620 608720 1 180 $X=802280 $Y=608340
X2638 677 617 2 2708 1 673 MUX2S $T=809720 608720 0 180 $X=805380 $Y=603300
X2639 2745 629 2 2715 1 671 MUX2S $T=810960 608720 1 180 $X=806620 $Y=608340
X2640 2747 2557 2 2578 1 2721 MUX2S $T=811580 628880 1 180 $X=807240 $Y=628500
X2641 2770 613 2 2733 1 2747 MUX2S $T=820260 638960 0 180 $X=815920 $Y=633540
X2642 683 629 2 2772 1 686 MUX2S $T=817160 608720 1 0 $X=817160 $Y=603300
X2643 2815 2802 2 2601 1 2804 MUX2S $T=834520 628880 0 180 $X=830180 $Y=623460
X2644 3051 605 2 3038 1 3026 MUX2S $T=930620 649040 1 180 $X=926280 $Y=648660
X2645 3045 629 2 827 1 830 MUX2S $T=931240 608720 0 180 $X=926900 $Y=603300
X2646 3050 605 2 3038 1 3025 MUX2S $T=932480 638960 0 180 $X=928140 $Y=633540
X2647 3042 625 2 3052 1 3054 MUX2S $T=929380 659120 1 0 $X=929380 $Y=653700
X2648 3057 625 2 3042 1 3048 MUX2S $T=935580 659120 1 180 $X=931240 $Y=658740
X2649 3060 605 2 3038 1 3053 MUX2S $T=937440 638960 0 180 $X=933100 $Y=633540
X2650 3055 629 2 3045 1 3069 MUX2S $T=934960 608720 1 0 $X=934960 $Y=603300
X2651 3065 605 2 3038 1 3036 MUX2S $T=939300 638960 1 180 $X=934960 $Y=638580
X2652 3062 625 2 3057 1 3073 MUX2S $T=936820 659120 0 0 $X=936820 $Y=658740
X2653 3074 629 2 3055 1 839 MUX2S $T=942400 608720 1 180 $X=938060 $Y=608340
X2654 3061 3081 2 3038 1 3067 MUX2S $T=944260 638960 1 180 $X=939920 $Y=638580
X2655 3069 617 2 849 1 850 MUX2S $T=941160 608720 1 0 $X=941160 $Y=603300
X2656 3077 625 2 3062 1 3071 MUX2S $T=945500 669200 0 180 $X=941160 $Y=663780
X2657 3071 3072 2 3048 1 3082 MUX2S $T=942400 659120 0 0 $X=942400 $Y=658740
X2658 3084 605 2 3067 1 3070 MUX2S $T=947360 638960 0 180 $X=943020 $Y=633540
X2659 3082 3081 2 3061 1 3050 MUX2S $T=947360 649040 0 180 $X=943020 $Y=643620
X2660 3080 617 2 3069 1 861 MUX2S $T=947360 608720 1 0 $X=947360 $Y=603300
X2661 3094 629 2 3074 1 3080 MUX2S $T=951700 608720 1 180 $X=947360 $Y=608340
X2662 3073 3072 2 3054 1 3093 MUX2S $T=947980 659120 1 0 $X=947980 $Y=653700
X2663 3086 3072 2 3073 1 3099 MUX2S $T=947980 669200 1 0 $X=947980 $Y=663780
X2664 3087 3081 2 3038 1 3090 MUX2S $T=948600 649040 1 0 $X=948600 $Y=643620
X2665 3097 625 2 3077 1 3086 MUX2S $T=952940 669200 1 180 $X=948600 $Y=668820
X2666 3096 605 2 3090 1 3076 MUX2S $T=953560 638960 0 180 $X=949220 $Y=633540
X2667 3099 3081 2 3087 1 3051 MUX2S $T=953560 649040 1 180 $X=949220 $Y=648660
X2668 3107 3081 2 3082 1 3084 MUX2S $T=957280 659120 0 180 $X=952940 $Y=653700
X2669 3110 3072 2 3071 1 3098 MUX2S $T=957900 659120 1 180 $X=953560 $Y=658740
X2670 3122 605 2 3101 1 3100 MUX2S $T=958520 638960 1 180 $X=954180 $Y=638580
X2671 3066 3081 2 3038 1 3101 MUX2S $T=959140 649040 1 180 $X=954800 $Y=648660
X2672 3098 3081 2 3066 1 3065 MUX2S $T=962860 659120 0 180 $X=958520 $Y=653700
X2673 3093 3081 2 3038 1 3125 MUX2S $T=960380 649040 1 0 $X=960380 $Y=643620
X2674 3109 3081 2 3093 1 3060 MUX2S $T=965340 649040 1 180 $X=961000 $Y=648660
X2675 3131 605 2 3125 1 3128 MUX2S $T=970300 649040 0 180 $X=965960 $Y=643620
X2676 3143 605 2 3050 1 3137 MUX2S $T=976500 649040 0 180 $X=972160 $Y=643620
X2677 3204 613 2 3148 1 3197 MUX2S $T=1003160 649040 1 180 $X=998820 $Y=648660
X2678 899 907 2 882 1 904 MUX2S $T=1007500 608720 0 180 $X=1003160 $Y=603300
X2679 1870 1 1910 1901 2 ND2T $T=505920 689360 0 0 $X=505920 $Y=688980
X2680 547 1 529 545 2 ND2T $T=718580 608720 1 180 $X=713620 $Y=608340
X2681 2475 1 2489 2467 2 ND2T $T=729740 608720 0 0 $X=729740 $Y=608340
X2682 578 1 587 2495 2 ND2T $T=734700 608720 0 0 $X=734700 $Y=608340
X2683 923 1 3293 3314 2 ND2T $T=1050900 618800 0 180 $X=1045940 $Y=613380
X2684 3297 1 3314 3310 2 ND2T $T=1050280 608720 1 0 $X=1050280 $Y=603300
X2685 1909 301 283 2 1 1820 QDFFRBS $T=505300 618800 0 0 $X=505300 $Y=618420
X2686 925 3285 3293 1 2 XOR2H $T=1036020 608720 1 0 $X=1036020 $Y=603300
X2687 3258 3299 3294 1 2 XOR2H $T=1047180 659120 1 0 $X=1047180 $Y=653700
X2688 142 1214 1357 2 1354 1223 1 AO22P $T=332940 638960 1 180 $X=327360 $Y=638580
X2689 189 1214 1502 2 1505 1518 1 AO22P $T=384400 628880 1 0 $X=384400 $Y=623460
X2690 204 1214 1536 2 1541 1518 1 AO22P $T=391220 628880 1 0 $X=391220 $Y=623460
X2691 1557 188 1543 2 203 196 1 AO22P $T=398660 679280 0 180 $X=393080 $Y=673860
X2692 1836 278 1798 2 1809 285 1 AO22P $T=489800 679280 0 180 $X=484220 $Y=673860
X2693 1851 278 1816 2 1834 285 1 AO22P $T=492280 699440 0 180 $X=486700 $Y=694020
X2694 2826 2430 710 2 713 529 1 AO22P $T=837620 649040 1 0 $X=837620 $Y=643620
X2695 754 2958 2955 2 2951 2602 1 AO22P $T=884120 618800 0 180 $X=878540 $Y=613380
X2696 874 3003 3145 2 3137 3140 1 AO22P $T=972160 628880 1 0 $X=972160 $Y=623460
X2697 3274 3269 923 2 3266 771 1 AO22P $T=1033540 618800 1 180 $X=1027960 $Y=618420
X2698 114 107 1 2 INV4 $T=318060 608720 0 180 $X=314960 $Y=603300
X2699 2413 2430 1 2 INV4 $T=708040 618800 1 0 $X=708040 $Y=613380
X2700 2438 587 1 2 INV4 $T=736560 618800 1 0 $X=736560 $Y=613380
X2701 2792 118 1 2 INV4 $T=825220 649040 0 180 $X=822120 $Y=643620
X2702 114 896 1 2 INV4 $T=993240 608720 1 0 $X=993240 $Y=603300
X2703 568 2467 1 2 INV12 $T=728500 608720 0 180 $X=721060 $Y=603300
X2704 572 2476 1 2 INV12 $T=727880 638960 1 0 $X=727880 $Y=633540
X2705 139 2807 1 2 INV12 $T=833280 659120 0 180 $X=825840 $Y=653700
X2706 137 2805 1 2 INV12 $T=828940 649040 0 0 $X=828940 $Y=648660
X2707 257 2826 1 2 INV12 $T=836380 649040 0 0 $X=836380 $Y=648660
X2708 127 2996 1 2 INV12 $T=904580 659120 0 0 $X=904580 $Y=658740
X2709 108 3022 1 2 INV12 $T=914500 618800 1 0 $X=914500 $Y=613380
X2710 3008 535 3016 807 1 2 MXL2H $T=920700 649040 1 180 $X=912020 $Y=648660
X2711 2979 535 3022 818 1 2 MXL2HF $T=894660 608720 0 0 $X=894660 $Y=608340
X2712 783 780 779 1 2 785 MAO222S $T=887220 608720 0 0 $X=887220 $Y=608340
X2713 777 2850 2996 2999 1 2 MXL2HT $T=884120 649040 0 0 $X=884120 $Y=648660
X2714 746 588 2903 2 2896 2602 1 AO22T $T=867380 608720 1 180 $X=861180 $Y=608340
X2715 736 2850 2 2853 2877 752 1 AOI22HT $T=855600 649040 0 0 $X=855600 $Y=648660
X2716 2877 2805 1 2 INV6 $T=855600 649040 1 180 $X=850640 $Y=648660
X2717 128 2825 1 2 INV8 $T=836380 638960 0 0 $X=836380 $Y=638580
X2718 2488 2495 2 2476 1 ND2F $T=730360 618800 1 0 $X=730360 $Y=613380
X2719 2398 2471 1 327 2 OR2B1T $T=726020 618800 0 0 $X=726020 $Y=618420
X2720 2434 2438 1 553 556 2458 2 MOAI1HP $T=712380 618800 1 0 $X=712380 $Y=613380
X2721 2370 301 465 1 2 2398 QDFFRBT $T=686340 618800 1 0 $X=686340 $Y=613380
X2722 2384 356 510 1 2 AN2P $T=688820 689360 0 180 $X=685100 $Y=683940
X2723 2369 356 2352 1 2 AN2P $T=685720 659120 0 0 $X=685720 $Y=658740
X2724 477 2307 2321 1 2 2328 HA1 $T=660300 618800 0 0 $X=660300 $Y=618420
X2725 479 2308 2322 1 2 2314 HA1 $T=660300 638960 0 0 $X=660300 $Y=638580
X2726 471 2321 2308 1 2 2310 HA1 $T=669600 628880 1 180 $X=661540 $Y=628500
X2727 2300 2341 2326 1 2 2313 HA1 $T=674560 659120 0 180 $X=666500 $Y=653700
X2728 2315 2326 2345 1 2 2324 HA1 $T=668360 669200 1 0 $X=668360 $Y=663780
X2729 499 2293 2307 1 2 2330 HA1 $T=678280 618800 1 180 $X=670220 $Y=618420
X2730 503 2322 2341 1 2 2339 HA1 $T=683240 638960 1 180 $X=675180 $Y=638580
X2731 452 1 2248 2 BUF4CK $T=640460 659120 0 0 $X=640460 $Y=658740
X2732 1360 99 2 1373 1 1378 1373 99 1384 1390 1023 ICV_11 $T=332940 679280 0 0 $X=332940 $Y=678900
X2733 1364 1218 2 1414 1 1404 1380 1218 1430 1426 1023 ICV_11 $T=347820 618800 1 0 $X=347820 $Y=613380
X2734 1376 93 2 1415 1 1380 1405 93 1431 1398 1023 ICV_11 $T=347820 618800 0 0 $X=347820 $Y=618420
X2735 1412 1374 2 1422 1 1411 1422 1374 1435 1421 1023 ICV_11 $T=350300 649040 1 0 $X=350300 $Y=643620
X2736 156 159 2 1424 1 166 1424 159 1427 1464 1023 ICV_11 $T=351540 679280 0 0 $X=351540 $Y=678900
X2737 1417 1346 2 1425 1 1405 1425 1346 1439 1415 1023 ICV_11 $T=353400 628880 1 0 $X=353400 $Y=623460
X2738 1408 159 2 1429 1 1440 1429 159 1427 1451 1023 ICV_11 $T=356500 689360 0 0 $X=356500 $Y=688980
X2739 1406 159 2 1433 1 175 1433 159 1427 1457 1023 ICV_11 $T=358980 679280 1 0 $X=358980 $Y=673860
X2740 1439 1346 2 1443 1 1431 1443 1346 1458 1452 1023 ICV_11 $T=360220 628880 0 0 $X=360220 $Y=628500
X2741 1411 1292 2 1444 1 1423 1444 1292 1459 1432 1023 ICV_11 $T=360220 649040 0 0 $X=360220 $Y=648660
X2742 1435 1374 2 1445 1 1444 1445 1374 1461 1446 1023 ICV_11 $T=360840 649040 1 0 $X=360840 $Y=643620
X2743 153 159 2 1406 1 183 185 91 1464 1470 1023 ICV_11 $T=362080 689360 1 0 $X=362080 $Y=683940
X2744 1430 159 2 1441 1 1448 1398 159 1467 1472 1023 ICV_11 $T=363320 618800 1 0 $X=363320 $Y=613380
X2745 1436 1362 2 1476 1 1486 1262 66 1486 1497 1023 ICV_11 $T=371380 659120 1 0 $X=371380 $Y=653700
X2746 1388 159 2 1477 1 1490 1477 159 1441 1499 1023 ICV_11 $T=372620 618800 0 0 $X=372620 $Y=618420
X2747 1251 1215 2 1490 1 202 1490 1215 1441 1530 1023 ICV_11 $T=382540 618800 0 0 $X=382540 $Y=618420
X2748 1514 1362 2 1476 1 1524 1310 1532 1524 1547 1023 ICV_11 $T=386880 649040 1 0 $X=386880 $Y=643620
X2749 1548 1560 2 1576 1 1599 1599 1292 1589 1611 1023 ICV_11 $T=406720 669200 1 0 $X=406720 $Y=663780
X2750 1574 1560 2 1584 1 1594 1589 1590 1602 1615 1023 ICV_11 $T=407960 649040 0 0 $X=407960 $Y=648660
X2751 220 1544 2 1612 1 224 227 232 1629 1633 1023 ICV_11 $T=415400 689360 1 0 $X=415400 $Y=683940
X2752 1609 1544 2 1618 1 1622 229 1532 1622 1638 1023 ICV_11 $T=416640 669200 0 0 $X=416640 $Y=668820
X2753 1612 1544 2 1621 1 1632 1621 1544 1618 1655 1023 ICV_11 $T=422220 659120 0 0 $X=422220 $Y=658740
X2754 1629 1532 2 1618 1 1643 1632 1532 1618 1663 1023 ICV_11 $T=423460 649040 1 0 $X=423460 $Y=643620
X2755 1627 1544 2 1618 1 1661 225 1532 1661 1679 1023 ICV_11 $T=427800 659120 1 0 $X=427800 $Y=653700
X2756 1761 256 2 1752 1 1772 1772 1774 1778 1786 1023 ICV_11 $T=462520 669200 0 0 $X=462520 $Y=668820
X2757 1771 256 2 1782 1 1785 1782 256 1781 1789 1023 ICV_11 $T=466860 649040 1 0 $X=466860 $Y=643620
X2758 1778 1774 2 1779 1 1792 1792 265 1800 1803 1023 ICV_11 $T=469960 659120 0 0 $X=469960 $Y=658740
X2759 322 319 2 325 1 1997 2004 319 326 2019 1023 ICV_11 $T=536300 669200 1 0 $X=536300 $Y=663780
X2760 1874 1749 2 296 1870 1749 1 AOI22HP $T=504060 689360 1 180 $X=491040 $Y=688980
X2761 1747 1895 2 1901 1871 1747 1 AOI22HP $T=515840 679280 1 180 $X=502820 $Y=678900
X2762 1733 1501 1726 1762 1 2 XOR3P $T=452600 638960 1 0 $X=452600 $Y=633540
X2763 1179 1189 1163 1 2 AN2B1T $T=280240 638960 0 180 $X=274660 $Y=633540
X2764 106 1299 1265 1 2 AN2B1T $T=314960 689360 0 180 $X=309380 $Y=683940
X2765 1062 1056 1058 1045 1 2 MAO222P $T=233740 638960 1 0 $X=233740 $Y=633540
.ENDS
***************************************
.SUBCKT NR3HP O I3 I2 I1 GND VCC
** N=7 EP=6 IP=0 FDC=0
.ENDS
***************************************
.SUBCKT AOI12H B2 B1 VCC O A1 GND
** N=7 EP=6 IP=0 FDC=0
.ENDS
***************************************
.SUBCKT ICV_13 1 2 3 4 5 6 7
** N=7 EP=7 IP=10 FDC=0
X0 1 2 3 4 DELC $T=0 0 0 0 $X=0 $Y=-380
X1 5 2 3 6 DELC $T=4960 0 0 0 $X=4960 $Y=-380
.ENDS
***************************************
.SUBCKT XOR3T I2 I1 I3 GND VCC O
** N=7 EP=6 IP=0 FDC=0
.ENDS
***************************************
.SUBCKT DFFN D CK Q GND VCC QB
** N=7 EP=6 IP=0 FDC=0
.ENDS
***************************************
.SUBCKT OR2B1 B1 I1 GND VCC O
** N=6 EP=5 IP=0 FDC=0
.ENDS
***************************************
.SUBCKT OA12P B2 B1 A1 O GND VCC
** N=7 EP=6 IP=0 FDC=0
.ENDS
***************************************
.SUBCKT ICV_14 1 2 3 4 5 6 7 8 9 10 11 12 13 14 15 16 17 18 19 20
+ 21 22 23 24 25 26 27 28 29 30 31 32 33 34 35 36 37 38 39 40
+ 41 42 43 44 45 46 47 48 49 50 51 52 53 54 55 56 57 58 59 60
+ 61 62 63 64 65 66 67 68 69 70 71 72 73 74 75 76 77 78 79 80
+ 81 82 83 84 85 86 87 88 89 90 91 92 93 94 95 96 97 98 99 100
+ 101 102 103 104 105 106 107 108 109 110 111 112 113 114 115 116 117 118 119 120
+ 121 122 123 124 125 126 127 128 129 130 131 132 133 134 135 136 137 138 139 140
+ 141 142 143 144 145 146 147 148 149 150 151 152 153 154 155 156 157 158 159 160
+ 161 162 163 164 165 166 167 168 169 170 171 172 173 174 175 176 177 178 179 180
+ 181 182 183 184 185 186 187 188 189 190 191 192 193 194 195 196 197 198 199 200
+ 201 202 203 204 205 206 207 208 209 210 211 212 213 214 215 216 217 218 219 220
+ 221 222 223 224 225 226 227 228 229 230 231 232 233 234 235 236 237 238 239 240
+ 241 242 243 244 245 246 247 248 249 250 251 252 253 254 255 256 257 258 259 260
+ 261 262 263 264 265 266 267 268 269 270 271 272 273 274 275 276 277 278 279 280
+ 281 282 283 284 285 286 287 288 289 290 291 292 293 294 295 296 297 298 299 300
+ 301 302 303 304 305 306 307 308 309 310 311 312 313 314 315 316 317 318 319 320
+ 321 322 323 324 325 326 327 328 329 330 331 332 333 334 335 336 337 338 339 340
+ 341 342 343 344 345 346 347 348 349 350 351 352 353 354 355 356 357 358 359 360
+ 361 362 363 364 365 366 367 368 369 370 371 372 373 374 375 376 377 378 379 380
+ 381 382 383 384 385 386 387 388 389 390 391 392 393 394 395 396 397 398 399 400
+ 401 402 403 404 405 406 407 408 409 410 411 412 413 414 415 416 417 418 419 420
+ 421 422 423 424 425 426 427 428 429 430 431 432 433 434 435 436 437 438 439 440
+ 441 442 443 444 445 446 447 448 449 450 451 452 453 454 455 456 457 458 459 460
+ 461 462 463 464 465 466 467 468 469 470 471 472 473 474 475 476 477 478 479 480
+ 481 482 483 484 485 486 487 488 489 490 491 492 493 494 495 496 497 498 499 500
+ 501 502 503 504 505 506 507 508 509 510 511 512 513 514 515 516 517 518 519 520
+ 521 522 523 524 525 526 527 528 529 530 531 532 533 534 535 536 537 538 539 540
+ 541 542 543 544 545 546 547 548 549 550 551 552 553 554 555 556 557 558 559 560
+ 561 562 563 564 565 566 567 568 569 570 571 572 573 574 575 576 577 578 579 580
+ 581 582 583 584 585 586 587 588 589 590 591 592 593 594 595 596 597 598 599 600
+ 601 602 603 604 605 606 607 608 609 610 611 612 613 614 615 616 617 618 619 620
+ 621 622 623 624 625 626 627 628 629 630 631 632 633 634 635 636 637 638 639 640
+ 641 642 643 644 645 646 647 648 649 650 651 652 653 654 655 656 657 658 659 660
+ 661 662 663 664 665 666 667 668 669 670 671 672 673 674 675 676 677 678 679 680
+ 681 682 683 684 685 686 687 688 689 690 691 692 693 694 695 696 697 698 699 700
+ 701 702 703 704 705 706 707 708 709 710 711 712 713 714 715 716 717 718 719 720
+ 721 722 723 724 725 726 727 728 729 730 731 732 733 734 735 736 737 738 739 740
+ 741 742 743 744 745 746 747 748 749 750 751 752 753 754 755 756 757 758 759 760
+ 761 762 763 764 765 766 767 768 769 770 771 772 773 774 775 776 777 778 779 780
+ 781 782 783 784 785 786 787 788 789 790 791 792 793 794 795 796 797 798 799 800
+ 801 802 803 804 805 806 807 808 809 810 811 812 813 814 815 816 817 818 819 820
+ 821 822 823 824 825 826 827 828 829 830 831 832 833 834 835 836 837 838 839 840
+ 841 842 843 844 845 846 847 848 849 850 851 852 853 854 855 856 857 858 859 860
+ 861 862 863 864 865 866 867 868 869 870 871 872 873 874 875 876 877 878 879 880
+ 881 882 883 884 885 886 887 888 889 890 891 892 893 894 895 896 897 898 899 900
+ 901 902 903 904 905 906 907 908 909 910 911 912 913 914 915 916 917 918 919 920
+ 921 922 923 924 925 926 927 928 929 930 931 932 933 934 935 936 937 938 939 940
+ 999
** N=3510 EP=941 IP=17702 FDC=0
X0 1888 280 1933 1 2 QDFFN $T=523280 588560 0 0 $X=523280 $Y=588180
X1 1910 281 1926 1 2 QDFFN $T=525140 538160 0 0 $X=525140 $Y=537780
X2 1869 280 1929 1 2 QDFFN $T=525140 558320 0 0 $X=525140 $Y=557940
X3 1870 280 1934 1 2 QDFFN $T=525140 598640 1 0 $X=525140 $Y=593220
X4 1908 281 1932 1 2 QDFFN $T=526380 548240 1 0 $X=526380 $Y=542820
X5 1867 281 1935 1 2 QDFFN $T=527000 558320 1 0 $X=527000 $Y=552900
X6 1917 281 1936 1 2 QDFFN $T=527620 538160 1 0 $X=527620 $Y=532740
X7 1861 280 1941 1 2 QDFFN $T=529480 568400 1 0 $X=529480 $Y=562980
X8 1921 280 1947 1 2 QDFFN $T=529480 578480 0 0 $X=529480 $Y=578100
X9 1914 281 1940 1 2 QDFFN $T=530720 528080 1 0 $X=530720 $Y=522660
X10 1891 280 1938 1 2 QDFFN $T=533200 568400 0 0 $X=533200 $Y=568020
X11 1951 296 1931 1 2 QDFFN $T=546220 548240 1 180 $X=535680 $Y=547860
X12 1858 280 1930 1 2 QDFFN $T=546840 538160 1 180 $X=536300 $Y=537780
X13 1915 281 1950 1 2 QDFFN $T=537540 548240 1 0 $X=537540 $Y=542820
X14 1939 280 1958 1 2 QDFFN $T=540020 528080 0 0 $X=540020 $Y=527700
X15 1944 280 1962 1 2 QDFFN $T=541880 528080 1 0 $X=541880 $Y=522660
X16 1873 280 1966 1 2 QDFFN $T=543740 578480 1 0 $X=543740 $Y=573060
X17 1963 296 1955 1 2 QDFFN $T=557380 558320 0 180 $X=546840 $Y=552900
X18 1900 296 1956 1 2 QDFFN $T=558000 538160 1 180 $X=547460 $Y=537780
X19 1884 296 1970 1 2 QDFFN $T=549320 548240 1 0 $X=549320 $Y=542820
X20 314 281 1964 1 2 QDFFN $T=562340 528080 1 180 $X=551800 $Y=527700
X21 1975 313 306 1 2 QDFFN $T=562340 598640 0 180 $X=551800 $Y=593220
X22 1961 296 1983 1 2 QDFFN $T=553040 568400 0 0 $X=553040 $Y=568020
X23 309 281 1980 1 2 QDFFN $T=553660 528080 1 0 $X=553660 $Y=522660
X24 1979 313 1967 1 2 QDFFN $T=564200 578480 1 180 $X=553660 $Y=578100
X25 1887 296 1982 1 2 QDFFN $T=555520 558320 0 0 $X=555520 $Y=557940
X26 1871 281 1972 1 2 QDFFN $T=569160 538160 1 180 $X=558620 $Y=537780
X27 1974 296 1989 1 2 QDFFN $T=561100 548240 1 0 $X=561100 $Y=542820
X28 316 281 1987 1 2 QDFFN $T=563580 528080 0 0 $X=563580 $Y=527700
X29 319 281 1990 1 2 QDFFN $T=564820 518000 0 0 $X=564820 $Y=517620
X30 1841 281 1981 1 2 QDFFN $T=575360 528080 0 180 $X=564820 $Y=522660
X31 1969 296 1993 1 2 QDFFN $T=565440 558320 1 0 $X=565440 $Y=552900
X32 1984 313 334 1 2 QDFFN $T=566060 598640 0 0 $X=566060 $Y=598260
X33 2001 313 327 1 2 QDFFN $T=577840 598640 0 180 $X=567300 $Y=593220
X34 1973 296 2007 1 2 QDFFN $T=570400 568400 1 0 $X=570400 $Y=562980
X35 1864 281 1995 1 2 QDFFN $T=585900 538160 0 180 $X=575360 $Y=532740
X36 1907 296 2013 1 2 QDFFN $T=575980 558320 1 0 $X=575980 $Y=552900
X37 2003 313 350 1 2 QDFFN $T=579080 588560 0 0 $X=579080 $Y=588180
X38 2004 313 348 1 2 QDFFN $T=579080 598640 1 0 $X=579080 $Y=593220
X39 355 281 2010 1 2 QDFFN $T=592720 538160 1 180 $X=582180 $Y=537780
X40 1997 346 2032 1 2 QDFFN $T=585280 548240 1 0 $X=585280 $Y=542820
X41 2012 346 2033 1 2 QDFFN $T=585900 548240 0 0 $X=585900 $Y=547860
X42 1991 346 2034 1 2 QDFFN $T=585900 568400 1 0 $X=585900 $Y=562980
X43 1971 346 2038 1 2 QDFFN $T=586520 558320 1 0 $X=586520 $Y=552900
X44 361 313 349 1 2 QDFFN $T=598920 598640 1 180 $X=588380 $Y=598260
X45 2020 313 369 1 2 QDFFN $T=589620 588560 1 0 $X=589620 $Y=583140
X46 351 313 363 1 2 QDFFN $T=590240 598640 1 0 $X=590240 $Y=593220
X47 2025 313 364 1 2 QDFFN $T=591480 588560 0 0 $X=591480 $Y=588180
X48 2028 313 370 1 2 QDFFN $T=592720 578480 1 0 $X=592720 $Y=573060
X49 2008 346 2059 1 2 QDFFN $T=595200 538160 0 0 $X=595200 $Y=537780
X50 2006 346 2061 1 2 QDFFN $T=595820 558320 0 0 $X=595820 $Y=557940
X51 2011 346 2068 1 2 QDFFN $T=596440 548240 0 0 $X=596440 $Y=547860
X52 1999 346 2065 1 2 QDFFN $T=596440 568400 1 0 $X=596440 $Y=562980
X53 362 313 378 1 2 QDFFN $T=598920 598640 0 0 $X=598920 $Y=598260
X54 366 313 382 1 2 QDFFN $T=600780 598640 1 0 $X=600780 $Y=593220
X55 372 346 2080 1 2 QDFFN $T=603880 588560 0 0 $X=603880 $Y=588180
X56 381 313 404 1 2 QDFFN $T=609460 598640 0 0 $X=609460 $Y=598260
X57 384 346 2069 1 2 QDFFN $T=611320 598640 1 0 $X=611320 $Y=593220
X58 400 346 2100 1 2 QDFFN $T=618140 588560 1 0 $X=618140 $Y=583140
X59 2051 346 2113 1 2 QDFFN $T=618760 558320 1 0 $X=618760 $Y=552900
X60 2097 313 421 1 2 QDFFN $T=620620 598640 0 0 $X=620620 $Y=598260
X61 407 346 2109 1 2 QDFFN $T=621860 598640 1 0 $X=621860 $Y=593220
X62 418 346 2128 1 2 QDFFN $T=628060 588560 0 0 $X=628060 $Y=588180
X63 437 346 2115 1 2 QDFFN $T=639220 588560 0 180 $X=628680 $Y=583140
X64 1976 346 2130 1 2 QDFFN $T=629300 558320 1 0 $X=629300 $Y=552900
X65 428 346 2138 1 2 QDFFN $T=632400 598640 1 0 $X=632400 $Y=593220
X66 439 346 2146 1 2 QDFFN $T=640460 588560 1 0 $X=640460 $Y=583140
X67 444 346 2150 1 2 QDFFN $T=642940 598640 1 0 $X=642940 $Y=593220
X68 1992 459 2136 1 2 QDFFN $T=655340 538160 1 180 $X=644800 $Y=537780
X69 448 346 2143 1 2 QDFFN $T=645420 588560 0 0 $X=645420 $Y=588180
X70 2153 313 2169 1 2 QDFFN $T=654720 558320 0 0 $X=654720 $Y=557940
X71 2157 313 2173 1 2 QDFFN $T=656580 528080 0 0 $X=656580 $Y=527700
X72 2162 313 2191 1 2 QDFFN $T=660920 548240 0 0 $X=660920 $Y=547860
X73 2171 313 2196 1 2 QDFFN $T=665260 558320 0 0 $X=665260 $Y=557940
X74 2175 313 2199 1 2 QDFFN $T=667120 538160 0 0 $X=667120 $Y=537780
X75 2178 313 2212 1 2 QDFFN $T=672080 538160 1 0 $X=672080 $Y=532740
X76 2220 443 2192 1 2 QDFFN $T=686340 558320 1 180 $X=675800 $Y=557940
X77 2223 281 2203 1 2 QDFFN $T=688200 538160 1 180 $X=677660 $Y=537780
X78 2213 313 2231 1 2 QDFFN $T=683240 528080 1 0 $X=683240 $Y=522660
X79 2229 443 2214 1 2 QDFFN $T=695640 548240 1 180 $X=685100 $Y=547860
X80 2236 443 2221 1 2 QDFFN $T=696880 558320 1 180 $X=686340 $Y=557940
X81 2241 443 2225 1 2 QDFFN $T=698740 538160 1 180 $X=688200 $Y=537780
X82 2243 281 2218 1 2 QDFFN $T=699980 528080 1 180 $X=689440 $Y=527700
X83 2246 459 2216 1 2 QDFFN $T=701220 518000 0 180 $X=690680 $Y=512580
X84 527 346 2252 1 2 QDFFN $T=697500 598640 1 0 $X=697500 $Y=593220
X85 2244 281 2238 1 2 QDFFN $T=709280 528080 0 180 $X=698740 $Y=522660
X86 533 346 2260 1 2 QDFFN $T=698740 588560 0 0 $X=698740 $Y=588180
X87 555 281 2263 1 2 QDFFN $T=717960 518000 0 180 $X=707420 $Y=512580
X88 1310 1301 1345 1348 1 1341 2 AOI22S $T=322400 538160 1 0 $X=322400 $Y=532740
X89 2074 2038 2071 374 1 2063 2 AOI22S $T=608840 528080 1 180 $X=605120 $Y=527700
X90 380 2069 2073 374 1 2063 2 AOI22S $T=609460 578480 1 180 $X=605740 $Y=578100
X91 2058 2034 2062 374 1 2063 2 AOI22S $T=606360 558320 0 0 $X=606360 $Y=557940
X92 2053 2065 2067 374 1 2063 2 AOI22S $T=606980 568400 1 0 $X=606980 $Y=562980
X93 2075 2061 2070 374 1 2063 2 AOI22S $T=610700 548240 1 0 $X=610700 $Y=542820
X94 2030 2033 2050 374 1 2063 2 AOI22S $T=610700 558320 1 0 $X=610700 $Y=552900
X95 375 2080 2079 374 1 2063 2 AOI22S $T=610700 558320 0 0 $X=610700 $Y=557940
X96 397 2100 2101 374 1 2063 2 AOI22S $T=623720 578480 0 180 $X=620000 $Y=573060
X97 2122 2068 2110 374 1 2063 2 AOI22S $T=627440 528080 1 180 $X=623720 $Y=527700
X98 410 2109 2107 374 1 2063 2 AOI22S $T=628060 558320 1 180 $X=624340 $Y=557940
X99 2111 2032 2112 374 1 2063 2 AOI22S $T=626820 548240 0 0 $X=626820 $Y=547860
X100 2124 2113 2121 374 1 2063 2 AOI22S $T=634880 548240 1 180 $X=631160 $Y=547860
X101 389 2115 2120 374 1 2063 2 AOI22S $T=631780 578480 1 0 $X=631780 $Y=573060
X102 390 2128 2119 374 1 2063 2 AOI22S $T=635500 578480 0 0 $X=635500 $Y=578100
X103 2132 2059 2118 374 1 2063 2 AOI22S $T=639840 538160 0 180 $X=636120 $Y=532740
X104 2133 2136 2129 374 1 2063 2 AOI22S $T=639840 538160 1 0 $X=639840 $Y=532740
X105 2126 2130 2123 374 1 2063 2 AOI22S $T=639840 558320 1 0 $X=639840 $Y=552900
X106 445 2138 2137 374 1 2063 2 AOI22S $T=644180 578480 0 180 $X=640460 $Y=573060
X107 373 2143 2134 374 1 2063 2 AOI22S $T=646660 578480 1 0 $X=646660 $Y=573060
X108 452 2146 2141 374 1 2063 2 AOI22S $T=649140 578480 0 0 $X=649140 $Y=578100
X109 464 458 2152 374 1 2063 2 AOI22S $T=654100 578480 0 180 $X=650380 $Y=573060
X110 401 2150 2147 374 1 2063 2 AOI22S $T=652860 578480 0 0 $X=652860 $Y=578100
X111 2664 2638 2658 672 1 634 2 AOI22S $T=830180 588560 1 180 $X=826460 $Y=588180
X112 3401 3418 3409 3405 1 3405 2 AOI22S $T=1056480 518000 0 0 $X=1056480 $Y=517620
X113 1027 1030 1 2 1035 AN2 $T=231260 588560 0 0 $X=231260 $Y=588180
X114 1031 1030 1 2 1038 AN2 $T=232500 588560 1 0 $X=232500 $Y=583140
X115 1033 1030 1 2 1051 AN2 $T=234360 568400 1 0 $X=234360 $Y=562980
X116 1034 1030 1 2 1050 AN2 $T=236840 558320 0 0 $X=236840 $Y=557940
X117 1047 1030 1 2 1063 AN2 $T=239320 548240 0 0 $X=239320 $Y=547860
X118 1046 1030 1 2 1052 AN2 $T=239320 598640 1 0 $X=239320 $Y=593220
X119 25 28 1 2 1089 AN2 $T=249240 518000 1 0 $X=249240 $Y=512580
X120 1110 37 1 2 35 AN2 $T=258540 598640 1 180 $X=256060 $Y=598260
X121 36 1089 1 2 1125 AN2 $T=259780 518000 1 0 $X=259780 $Y=512580
X122 1109 1106 1 2 1124 AN2 $T=260400 568400 1 0 $X=260400 $Y=562980
X123 1115 1030 1 2 1082 AN2 $T=261020 538160 0 0 $X=261020 $Y=537780
X124 1113 1118 1 2 1106 AN2 $T=263500 578480 1 180 $X=261020 $Y=578100
X125 1129 1125 1 2 43 AN2 $T=264120 518000 1 0 $X=264120 $Y=512580
X126 1127 1124 1 2 1134 AN2 $T=264740 568400 0 0 $X=264740 $Y=568020
X127 1147 1143 1 2 1118 AN2 $T=270320 568400 1 180 $X=267840 $Y=568020
X128 1157 1030 1 2 1139 AN2 $T=273420 538160 0 0 $X=273420 $Y=537780
X129 1155 1134 1 2 1171 AN2 $T=277140 568400 1 0 $X=277140 $Y=562980
X130 1170 1169 1 2 1135 AN2 $T=280860 588560 0 180 $X=278380 $Y=583140
X131 1191 64 1 2 1112 AN2 $T=285200 568400 1 180 $X=282720 $Y=568020
X132 1194 1171 1 2 1223 AN2 $T=288300 568400 1 0 $X=288300 $Y=562980
X133 1228 64 1 2 1117 AN2 $T=293260 568400 1 180 $X=290780 $Y=568020
X134 1225 1223 1 2 1238 AN2 $T=293260 558320 0 0 $X=293260 $Y=557940
X135 1235 1030 1 2 1211 AN2 $T=297600 538160 0 180 $X=295120 $Y=532740
X136 1248 64 1 2 1159 AN2 $T=297600 568400 1 180 $X=295120 $Y=568020
X137 1245 1238 1 2 1251 AN2 $T=296980 558320 0 0 $X=296980 $Y=557940
X138 1256 64 1 2 1105 AN2 $T=301320 568400 1 180 $X=298840 $Y=568020
X139 1278 1030 1 2 1285 AN2 $T=306900 548240 1 0 $X=306900 $Y=542820
X140 1291 1251 1 2 1312 AN2 $T=313720 558320 0 0 $X=313720 $Y=557940
X141 1320 1030 1 2 1329 AN2 $T=316820 548240 1 0 $X=316820 $Y=542820
X142 1344 1312 1 2 1362 AN2 $T=327360 558320 0 0 $X=327360 $Y=557940
X143 1356 119 1 2 1354 AN2 $T=332320 588560 1 180 $X=329840 $Y=588180
X144 1388 1362 1 2 1391 AN2 $T=336660 558320 0 0 $X=336660 $Y=557940
X145 1380 1362 1 2 1401 AN2 $T=337280 568400 1 0 $X=337280 $Y=562980
X146 1454 1391 1 2 1482 AN2 $T=357120 568400 1 0 $X=357120 $Y=562980
X147 1427 1380 1 2 1388 AN2 $T=363320 558320 0 0 $X=363320 $Y=557940
X148 1470 1030 1 2 1435 AN2 $T=367040 538160 0 180 $X=364560 $Y=532740
X149 1499 1030 1 2 1445 AN2 $T=367040 548240 0 180 $X=364560 $Y=542820
X150 1506 1030 1 2 1469 AN2 $T=369520 548240 0 180 $X=367040 $Y=542820
X151 1496 1482 1 2 1507 AN2 $T=367040 558320 0 0 $X=367040 $Y=557940
X152 1526 156 1 2 1534 AN2 $T=371380 538160 0 0 $X=371380 $Y=537780
X153 1537 1507 1 2 1553 AN2 $T=375100 558320 0 0 $X=375100 $Y=557940
X154 1520 162 1 2 1508 AN2 $T=385020 528080 1 180 $X=382540 $Y=527700
X155 1580 1030 1 2 1549 AN2 $T=387500 538160 1 180 $X=385020 $Y=537780
X156 1572 1553 1 2 1582 AN2 $T=385640 558320 0 0 $X=385640 $Y=557940
X157 1591 162 1 2 1560 AN2 $T=396180 528080 1 180 $X=393700 $Y=527700
X158 1581 1582 1 2 1631 AN2 $T=397420 558320 0 0 $X=397420 $Y=557940
X159 1653 1030 1 2 1623 AN2 $T=401140 538160 1 180 $X=398660 $Y=537780
X160 1632 1641 1 2 1654 AN2 $T=402380 578480 1 0 $X=402380 $Y=573060
X161 1661 162 1 2 1634 AN2 $T=406100 528080 1 180 $X=403620 $Y=527700
X162 1650 1631 1 2 1655 AN2 $T=403620 558320 0 0 $X=403620 $Y=557940
X163 1660 1655 1 2 1641 AN2 $T=407340 568400 0 180 $X=404860 $Y=562980
X164 1636 1654 1 2 1664 AN2 $T=406100 578480 1 0 $X=406100 $Y=573060
X165 1677 162 1 2 178 AN2 $T=414780 528080 1 180 $X=412300 $Y=527700
X166 1669 1664 1 2 1676 AN2 $T=414160 578480 0 0 $X=414160 $Y=578100
X167 1687 1030 1 2 1647 AN2 $T=419120 548240 1 180 $X=416640 $Y=547860
X168 1736 162 1 2 188 AN2 $T=433380 528080 0 180 $X=430900 $Y=522660
X169 196 162 1 2 193 AN2 $T=440820 518000 1 180 $X=438340 $Y=517620
X170 1755 1030 1 2 1716 AN2 $T=445160 558320 0 180 $X=442680 $Y=552900
X171 1747 1030 1 2 1743 AN2 $T=447020 568400 0 180 $X=444540 $Y=562980
X172 1766 1030 1 2 1753 AN2 $T=450120 558320 1 180 $X=447640 $Y=557940
X173 1772 1030 1 2 1730 AN2 $T=453840 568400 0 180 $X=451360 $Y=562980
X174 1794 1030 1 2 1778 AN2 $T=463140 578480 0 180 $X=460660 $Y=573060
X175 224 1030 1 2 1764 AN2 $T=468720 578480 1 180 $X=466240 $Y=578100
X176 1801 1030 1 2 1795 AN2 $T=469340 588560 0 180 $X=466860 $Y=583140
X177 1846 254 1 2 1856 AN2 $T=496620 518000 1 0 $X=496620 $Y=512580
X178 161 261 1 2 1863 AN2 $T=506540 588560 1 180 $X=504060 $Y=588180
X179 161 261 1 2 260 AN2 $T=507160 518000 1 180 $X=504680 $Y=517620
X180 161 261 1 2 1852 AN2 $T=510260 538160 0 180 $X=507780 $Y=532740
X181 301 299 1 2 1953 AN2 $T=548700 518000 0 180 $X=546220 $Y=512580
X182 1954 156 1 2 1957 AN2 $T=546220 588560 0 0 $X=546220 $Y=588180
X183 1948 1953 1 2 1924 AN2 $T=549940 518000 1 180 $X=547460 $Y=517620
X184 353 356 1 2 357 AN2 $T=592100 518000 1 0 $X=592100 $Y=512580
X185 2018 356 1 2 2045 AN2 $T=604500 518000 1 180 $X=602020 $Y=517620
X186 429 356 1 2 402 AN2 $T=633640 518000 0 180 $X=631160 $Y=512580
X187 2135 359 1 2 2139 AN2 $T=641080 588560 0 0 $X=641080 $Y=588180
X188 457 356 1 2 2105 AN2 $T=651620 518000 1 180 $X=649140 $Y=517620
X189 2063 532 1 2 536 AN2 $T=697500 578480 0 0 $X=697500 $Y=578100
X190 161 261 1 2 539 AN2 $T=701220 518000 1 0 $X=701220 $Y=512580
X191 261 161 1 2 2235 AN2 $T=703700 558320 1 180 $X=701220 $Y=557940
X192 2275 569 1 2 2298 AN2 $T=722920 538160 0 0 $X=722920 $Y=537780
X193 2271 569 1 2 2305 AN2 $T=726640 528080 0 0 $X=726640 $Y=527700
X194 2291 569 1 2 2302 AN2 $T=727880 518000 1 0 $X=727880 $Y=512580
X195 567 569 1 2 2318 AN2 $T=729740 528080 0 0 $X=729740 $Y=527700
X196 559 569 1 2 2347 AN2 $T=742140 518000 1 0 $X=742140 $Y=512580
X197 561 569 1 2 589 AN2 $T=744620 518000 1 0 $X=744620 $Y=512580
X198 566 569 1 2 2381 AN2 $T=750200 528080 0 0 $X=750200 $Y=527700
X199 2380 2383 1 2 598 AN2 $T=753300 598640 1 0 $X=753300 $Y=593220
X200 2400 2397 1 2 2383 AN2 $T=759500 588560 1 180 $X=757020 $Y=588180
X201 2413 2414 1 2 2397 AN2 $T=764460 588560 1 180 $X=761980 $Y=588180
X202 2427 2424 1 2 2438 AN2 $T=766940 528080 0 0 $X=766940 $Y=527700
X203 2448 2447 1 2 2414 AN2 $T=771280 578480 1 180 $X=768800 $Y=578100
X204 2464 2462 1 2 2424 AN2 $T=774380 528080 1 180 $X=771900 $Y=527700
X205 2487 2494 1 2 2462 AN2 $T=783060 528080 1 180 $X=780580 $Y=527700
X206 2506 2504 1 2 2494 AN2 $T=785540 528080 1 180 $X=783060 $Y=527700
X207 2499 2496 1 2 2447 AN2 $T=783060 588560 1 0 $X=783060 $Y=583140
X208 2497 622 1 2 2504 AN2 $T=783680 518000 1 0 $X=783680 $Y=512580
X209 2492 2512 1 2 2496 AN2 $T=788020 578480 1 180 $X=785540 $Y=578100
X210 2515 2523 1 2 2512 AN2 $T=789260 578480 0 0 $X=789260 $Y=578100
X211 2550 2546 1 2 2523 AN2 $T=797320 588560 0 180 $X=794840 $Y=583140
X212 2599 2605 1 2 2546 AN2 $T=811580 588560 1 0 $X=811580 $Y=583140
X213 2625 2623 1 2 655 AN2 $T=819020 518000 0 180 $X=816540 $Y=512580
X214 2629 2624 1 2 2605 AN2 $T=819020 578480 1 180 $X=816540 $Y=578100
X215 2650 2648 1 2 2624 AN2 $T=827080 578480 0 180 $X=824600 $Y=573060
X216 2676 2672 1 2 2648 AN2 $T=833280 578480 0 180 $X=830800 $Y=573060
X217 677 681 1 2 2623 AN2 $T=833900 518000 0 180 $X=831420 $Y=512580
X218 687 2678 1 2 2679 AN2 $T=837620 538160 0 180 $X=835140 $Y=532740
X219 691 692 1 2 681 AN2 $T=838240 518000 1 0 $X=838240 $Y=512580
X220 2704 2703 1 2 2672 AN2 $T=842580 578480 0 180 $X=840100 $Y=573060
X221 2693 2714 1 2 2703 AN2 $T=845060 568400 1 180 $X=842580 $Y=568020
X222 697 2717 1 2 2712 AN2 $T=845680 598640 1 180 $X=843200 $Y=598260
X223 2621 2716 1 2 2722 AN2 $T=843820 588560 1 0 $X=843820 $Y=583140
X224 695 696 1 2 692 AN2 $T=846920 518000 0 180 $X=844440 $Y=512580
X225 2583 2716 1 2 2745 AN2 $T=846920 578480 0 0 $X=846920 $Y=578100
X226 2735 2737 1 2 701 AN2 $T=848160 518000 1 0 $X=848160 $Y=512580
X227 2641 659 1 2 2746 AN2 $T=848160 528080 0 0 $X=848160 $Y=527700
X228 2666 659 1 2 2753 AN2 $T=850640 518000 0 0 $X=850640 $Y=517620
X229 2656 659 1 2 2754 AN2 $T=850640 528080 0 0 $X=850640 $Y=527700
X230 2626 2716 1 2 2758 AN2 $T=850640 578480 0 0 $X=850640 $Y=578100
X231 2769 2764 1 2 2737 AN2 $T=855600 518000 1 180 $X=853120 $Y=517620
X232 2767 2766 1 2 2714 AN2 $T=856220 568400 1 180 $X=853740 $Y=568020
X233 2781 2791 1 2 2766 AN2 $T=860560 578480 0 180 $X=858080 $Y=573060
X234 2761 2782 1 2 2791 AN2 $T=859320 578480 0 0 $X=859320 $Y=578100
X235 2803 2801 1 2 2782 AN2 $T=864280 578480 1 180 $X=861800 $Y=578100
X236 2799 2800 1 2 2809 AN2 $T=861800 588560 0 0 $X=861800 $Y=588180
X237 2813 2809 1 2 2801 AN2 $T=868000 588560 0 180 $X=865520 $Y=583140
X238 2823 2826 1 2 2835 AN2 $T=870480 528080 0 0 $X=870480 $Y=527700
X239 2837 2833 1 2 2787 AN2 $T=873580 528080 0 180 $X=871100 $Y=522660
X240 2851 2835 1 2 2833 AN2 $T=876060 528080 1 180 $X=873580 $Y=527700
X241 2834 2838 1 2 2826 AN2 $T=874200 538160 0 0 $X=874200 $Y=537780
X242 2899 716 1 2 2880 AN2 $T=886600 538160 1 180 $X=884120 $Y=537780
X243 2930 716 1 2 2893 AN2 $T=899620 578480 1 180 $X=897140 $Y=578100
X244 2937 716 1 2 2878 AN2 $T=900240 528080 1 180 $X=897760 $Y=527700
X245 2941 716 1 2 2909 AN2 $T=902720 518000 1 180 $X=900240 $Y=517620
X246 2943 716 1 2 2921 AN2 $T=903960 578480 1 180 $X=901480 $Y=578100
X247 2959 716 1 2 2885 AN2 $T=907680 558320 0 180 $X=905200 $Y=552900
X248 2958 2956 1 2 2953 AN2 $T=908300 578480 1 180 $X=905820 $Y=578100
X249 3001 2998 1 2 2988 AN2 $T=923800 588560 1 180 $X=921320 $Y=588180
X250 3017 3014 1 2 2998 AN2 $T=931240 578480 1 180 $X=928760 $Y=578100
X251 789 797 1 2 3020 AN2 $T=930620 518000 1 0 $X=930620 $Y=512580
X252 788 797 1 2 3013 AN2 $T=933100 528080 1 0 $X=933100 $Y=522660
X253 3023 797 1 2 3030 AN2 $T=933720 548240 1 0 $X=933720 $Y=542820
X254 3033 3032 1 2 3014 AN2 $T=937440 578480 1 180 $X=934960 $Y=578100
X255 3029 3036 1 2 3068 AN2 $T=939300 528080 1 0 $X=939300 $Y=522660
X256 3076 3062 1 2 3032 AN2 $T=944880 578480 0 180 $X=942400 $Y=573060
X257 3082 3068 1 2 3071 AN2 $T=948600 528080 0 180 $X=946120 $Y=522660
X258 813 812 1 2 3036 AN2 $T=951080 518000 0 180 $X=948600 $Y=512580
X259 3095 3091 1 2 3062 AN2 $T=955420 578480 0 180 $X=952940 $Y=573060
X260 3106 3100 1 2 3091 AN2 $T=957280 588560 0 180 $X=954800 $Y=583140
X261 828 825 1 2 821 AN2 $T=962860 518000 0 180 $X=960380 $Y=512580
X262 833 832 1 2 825 AN2 $T=969680 518000 0 180 $X=967200 $Y=512580
X263 3150 3147 1 2 3100 AN2 $T=970300 588560 0 180 $X=967820 $Y=583140
X264 842 839 1 2 832 AN2 $T=976500 518000 0 180 $X=974020 $Y=512580
X265 3190 3178 1 2 3147 AN2 $T=979600 588560 1 180 $X=977120 $Y=588180
X266 3198 847 1 2 839 AN2 $T=983320 518000 0 180 $X=980840 $Y=512580
X267 3203 3206 1 2 3178 AN2 $T=987660 588560 1 180 $X=985180 $Y=588180
X268 3232 3224 1 2 3206 AN2 $T=995100 588560 1 180 $X=992620 $Y=588180
X269 3236 3245 1 2 866 AN2 $T=1000060 518000 0 0 $X=1000060 $Y=517620
X270 3254 3251 1 2 3224 AN2 $T=1002540 588560 0 180 $X=1000060 $Y=583140
X271 3268 3269 1 2 3251 AN2 $T=1008740 588560 0 180 $X=1006260 $Y=583140
X272 869 871 1 2 3245 AN2 $T=1009980 518000 0 180 $X=1007500 $Y=512580
X273 878 877 1 2 871 AN2 $T=1014320 518000 0 180 $X=1011840 $Y=512580
X274 3287 3285 1 2 3269 AN2 $T=1015560 588560 0 180 $X=1013080 $Y=583140
X275 3229 659 1 2 881 AN2 $T=1014320 518000 0 0 $X=1014320 $Y=517620
X276 3242 659 1 2 3298 AN2 $T=1018040 518000 0 0 $X=1018040 $Y=517620
X277 3246 659 1 2 3299 AN2 $T=1018040 538160 1 0 $X=1018040 $Y=532740
X278 3247 659 1 2 3297 AN2 $T=1018660 528080 0 0 $X=1018660 $Y=527700
X279 3309 3305 1 2 877 AN2 $T=1024240 518000 1 180 $X=1021760 $Y=517620
X280 3303 3306 1 2 3311 AN2 $T=1022380 538160 1 0 $X=1022380 $Y=532740
X281 875 886 1 2 887 AN2 $T=1022380 598640 0 0 $X=1022380 $Y=598260
X282 3313 3316 1 2 3318 AN2 $T=1025480 528080 1 0 $X=1025480 $Y=522660
X283 3310 3318 1 2 3305 AN2 $T=1027960 528080 1 180 $X=1025480 $Y=527700
X284 3248 886 1 2 3320 AN2 $T=1025480 588560 0 0 $X=1025480 $Y=588180
X285 3314 3319 1 2 3285 AN2 $T=1027340 578480 0 0 $X=1027340 $Y=578100
X286 3312 797 1 2 3335 AN2 $T=1029200 558320 1 0 $X=1029200 $Y=552900
X287 3342 3338 1 2 3319 AN2 $T=1034780 588560 0 180 $X=1032300 $Y=583140
X288 870 886 1 2 3343 AN2 $T=1032300 598640 1 0 $X=1032300 $Y=593220
X289 897 898 1 2 3316 AN2 $T=1037880 518000 1 0 $X=1037880 $Y=512580
X290 3356 899 1 2 3345 AN2 $T=1040360 568400 0 180 $X=1037880 $Y=562980
X291 3339 3335 1 2 3368 AN2 $T=1038500 548240 0 0 $X=1038500 $Y=547860
X292 3363 3358 1 2 3338 AN2 $T=1040980 588560 1 180 $X=1038500 $Y=588180
X293 3336 3311 1 2 3364 AN2 $T=1039740 538160 1 0 $X=1039740 $Y=532740
X294 3366 3364 1 2 3374 AN2 $T=1043460 528080 0 0 $X=1043460 $Y=527700
X295 3376 3374 1 2 3383 AN2 $T=1045940 528080 1 0 $X=1045940 $Y=522660
X296 3371 3383 1 2 906 AN2 $T=1047180 518000 1 0 $X=1047180 $Y=512580
X297 3420 797 1 2 3362 AN2 $T=1057720 558320 1 180 $X=1055240 $Y=557940
X298 3436 797 1 2 3390 AN2 $T=1063920 558320 1 180 $X=1061440 $Y=557940
X299 3455 797 1 2 3429 AN2 $T=1067640 528080 1 180 $X=1065160 $Y=527700
X300 3483 797 1 2 3437 AN2 $T=1071980 558320 1 180 $X=1069500 $Y=557940
X301 3471 797 1 2 3389 AN2 $T=1072600 538160 1 180 $X=1070120 $Y=537780
X302 3491 939 1 2 3492 AN2 $T=1084380 598640 1 0 $X=1084380 $Y=593220
X303 3494 797 1 2 3405 AN2 $T=1087480 518000 0 180 $X=1085000 $Y=512580
X304 1788 204 1 2 INV6CK $T=459420 528080 0 180 $X=453840 $Y=522660
X305 2104 359 1 2 INV6CK $T=638600 558320 0 0 $X=638600 $Y=557940
X306 2046 313 1 2 INV6CK $T=644800 578480 1 180 $X=639220 $Y=578100
X307 453 443 1 2 INV6CK $T=647280 568400 1 180 $X=641700 $Y=568020
X308 460 281 1 2 INV6CK $T=654100 538160 0 180 $X=648520 $Y=532740
X309 2154 346 1 2 INV6CK $T=660920 578480 0 180 $X=655340 $Y=573060
X310 2056 459 1 2 INV6CK $T=662160 538160 1 0 $X=662160 $Y=532740
X311 156 161 1 2 1540 QDBHN $T=377580 538160 0 0 $X=377580 $Y=537780
X312 1788 1852 1 2 1829 QDBHN $T=496000 568400 0 0 $X=496000 $Y=568020
X313 1788 1863 1 2 1876 QDBHN $T=522040 568400 0 0 $X=522040 $Y=568020
X314 156 161 1 2 1946 QDBHN $T=552420 588560 0 0 $X=552420 $Y=588180
X315 359 2029 1 2 2021 QDBHN $T=597060 538160 0 180 $X=589620 $Y=532740
X316 359 377 1 2 2049 QDBHN $T=610700 558320 0 180 $X=603260 $Y=552900
X317 1788 386 1 2 2091 QDBHN $T=609460 578480 0 0 $X=609460 $Y=578100
X318 359 377 1 2 2088 QDBHN $T=622480 538160 0 180 $X=615040 $Y=532740
X319 359 377 1 2 392 QDBHN $T=623100 518000 1 180 $X=615660 $Y=517620
X320 359 377 1 2 2127 QDBHN $T=642940 518000 1 180 $X=635500 $Y=517620
X321 359 2029 1 2 2144 QDBHN $T=641080 598640 0 0 $X=641080 $Y=598260
X322 405 470 1 2 2151 QDBHN $T=660920 588560 0 180 $X=653480 $Y=583140
X323 359 477 1 2 471 QDBHN $T=665880 518000 0 180 $X=658440 $Y=512580
X324 1534 1491 1 2 INV2CK $T=372620 528080 0 0 $X=372620 $Y=527700
X325 1957 320 1 2 INV2CK $T=564200 588560 0 0 $X=564200 $Y=588180
X326 2060 2056 1 2 INV2CK $T=605120 518000 0 180 $X=602640 $Y=512580
X327 2072 2116 1 2 INV2CK $T=629300 538160 0 0 $X=629300 $Y=537780
X328 2658 2663 1 2 INV2CK $T=833900 588560 0 0 $X=833900 $Y=588180
X329 2706 2715 1 2 INV2CK $T=842580 538160 0 0 $X=842580 $Y=537780
X330 720 722 1 2 INV2CK $T=868000 528080 1 0 $X=868000 $Y=522660
X331 2946 2955 1 2 INV2CK $T=907680 568400 0 180 $X=905200 $Y=562980
X332 1114 1102 1040 1 2 AN2T $T=259780 588560 0 180 $X=255440 $Y=583140
X333 1318 1311 1302 1 2 AN2T $T=316820 598640 0 180 $X=312480 $Y=593220
X334 1830 1788 1792 1 2 AN2T $T=487940 568400 0 0 $X=487940 $Y=568020
X335 1886 1788 1831 1 2 AN2T $T=513980 568400 0 0 $X=513980 $Y=568020
X336 2047 359 2040 1 2 AN2T $T=600780 548240 0 180 $X=596440 $Y=542820
X337 2048 359 2060 1 2 AN2T $T=600780 538160 1 0 $X=600780 $Y=532740
X338 2066 1788 2054 1 2 AN2T $T=606360 568400 0 0 $X=606360 $Y=568020
X339 2078 359 2072 1 2 AN2T $T=611320 538160 0 180 $X=606980 $Y=532740
X340 2096 359 396 1 2 AN2T $T=621240 528080 0 180 $X=616900 $Y=522660
X341 423 359 415 1 2 AN2T $T=631160 518000 0 180 $X=626820 $Y=512580
X342 2663 2716 2750 1 2 AN2T $T=848780 588560 1 0 $X=848780 $Y=583140
X343 2682 659 2763 1 2 AN2T $T=851260 538160 1 0 $X=851260 $Y=532740
X344 2795 2787 2764 1 2 AN2T $T=860560 528080 1 180 $X=856220 $Y=527700
X345 2900 2825 2838 1 2 AN2T $T=889700 548240 1 180 $X=885360 $Y=547860
X346 3474 3484 3358 1 2 AN2T $T=1079420 578480 1 180 $X=1075080 $Y=578100
X347 3493 3492 3484 1 2 AN2T $T=1088720 578480 0 180 $X=1084380 $Y=573060
X348 1540 1 2 1526 DELC $T=375100 528080 0 0 $X=375100 $Y=527700
X349 1748 1 2 1759 DELC $T=442680 528080 0 0 $X=442680 $Y=527700
X350 199 1 2 1762 DELC $T=443920 518000 1 0 $X=443920 $Y=512580
X351 1773 1 2 1784 DELC $T=453220 568400 0 0 $X=453220 $Y=568020
X352 1780 1 2 1789 DELC $T=456940 558320 1 0 $X=456940 $Y=552900
X353 1790 1 2 1799 DELC $T=460040 578480 0 0 $X=460040 $Y=578100
X354 1803 1 2 1810 DELC $T=469340 588560 1 0 $X=469340 $Y=583140
X355 1816 1 2 1801 DELC $T=479260 588560 0 0 $X=479260 $Y=588180
X356 1777 1 2 1823 DELC $T=479880 548240 1 0 $X=479880 $Y=542820
X357 1829 1 2 1830 DELC $T=487940 558320 1 0 $X=487940 $Y=552900
X358 1818 1 2 1828 DELC $T=489180 588560 0 0 $X=489180 $Y=588180
X359 1813 1 2 1841 DELC $T=491040 518000 0 0 $X=491040 $Y=517620
X360 1779 1 2 1851 DELC $T=493520 558320 1 0 $X=493520 $Y=552900
X361 1847 1 2 1858 DELC $T=496620 528080 0 0 $X=496620 $Y=527700
X362 1857 1 2 1864 DELC $T=499720 518000 0 0 $X=499720 $Y=517620
X363 258 1 2 1867 DELC $T=502820 538160 1 0 $X=502820 $Y=532740
X364 1843 1 2 1869 DELC $T=503440 578480 0 0 $X=503440 $Y=578100
X365 1872 1 2 1884 DELC $T=508400 538160 0 0 $X=508400 $Y=537780
X366 1854 1 2 1888 DELC $T=508400 588560 1 0 $X=508400 $Y=583140
X367 1882 1 2 1891 DELC $T=511500 578480 0 0 $X=511500 $Y=578100
X368 1834 1 2 1908 DELC $T=522040 578480 1 0 $X=522040 $Y=573060
X369 1821 1 2 1915 DELC $T=522660 518000 1 0 $X=522660 $Y=512580
X370 1911 1 2 1928 DELC $T=526380 548240 0 0 $X=526380 $Y=547860
X371 1880 1 2 1921 DELC $T=530720 578480 1 0 $X=530720 $Y=573060
X372 1800 1 2 1917 DELC $T=531960 528080 0 0 $X=531960 $Y=527700
X373 1946 1 2 1954 DELC $T=541880 598640 1 0 $X=541880 $Y=593220
X374 1916 1 2 1959 DELC $T=551800 588560 1 0 $X=551800 $Y=583140
X375 1905 1 2 1973 DELC $T=554280 578480 1 0 $X=554280 $Y=573060
X376 1844 1 2 1975 DELC $T=559860 588560 1 0 $X=559860 $Y=583140
X377 315 1 2 1939 DELC $T=562340 538160 1 0 $X=562340 $Y=532740
X378 1848 1 2 1979 DELC $T=564200 578480 0 0 $X=564200 $Y=578100
X379 1819 1 2 1984 DELC $T=566680 588560 0 0 $X=566680 $Y=588180
X380 1986 1 2 1991 DELC $T=570400 538160 1 0 $X=570400 $Y=532740
X381 1977 1 2 1999 DELC $T=572260 568400 0 0 $X=572260 $Y=568020
X382 1836 1 2 2003 DELC $T=574120 588560 0 0 $X=574120 $Y=588180
X383 1826 1 2 2001 DELC $T=574740 578480 0 0 $X=574740 $Y=578100
X384 1837 1 2 2004 DELC $T=579080 588560 1 0 $X=579080 $Y=583140
X385 1820 1 2 2020 DELC $T=584660 588560 1 0 $X=584660 $Y=583140
X386 1824 1 2 2025 DELC $T=587760 578480 0 0 $X=587760 $Y=578100
X387 1985 1 2 2051 DELC $T=597060 558320 1 0 $X=597060 $Y=552900
X388 1822 1 2 2028 DELC $T=599540 568400 0 0 $X=599540 $Y=568020
X389 2091 1 2 2066 DELC $T=615660 568400 0 0 $X=615660 $Y=568020
X390 2088 1 2 2078 DELC $T=624960 538160 1 0 $X=624960 $Y=532740
X391 2127 1 2 2096 DELC $T=635500 538160 0 0 $X=635500 $Y=537780
X392 2018 1 2 451 DELC $T=643560 538160 1 0 $X=643560 $Y=532740
X393 447 1 2 2131 DELC $T=644180 558320 0 0 $X=644180 $Y=557940
X394 2144 1 2 2135 DELC $T=648520 598640 0 0 $X=648520 $Y=598260
X395 456 1 2 462 DELC $T=650380 528080 1 0 $X=650380 $Y=522660
X396 2145 1 2 2153 DELC $T=654100 538160 1 0 $X=654100 $Y=532740
X397 483 1 2 454 DELC $T=667740 518000 0 0 $X=667740 $Y=517620
X398 2165 1 2 2162 DELC $T=668980 548240 1 0 $X=668980 $Y=542820
X399 2151 1 2 2170 DELC $T=670840 578480 0 0 $X=670840 $Y=578100
X400 2180 1 2 2160 DELC $T=670840 598640 1 0 $X=670840 $Y=593220
X401 2189 1 2 2164 DELC $T=672700 568400 1 0 $X=672700 $Y=562980
X402 489 1 2 497 DELC $T=673940 558320 1 0 $X=673940 $Y=552900
X403 492 1 2 2178 DELC $T=674560 548240 0 0 $X=674560 $Y=547860
X404 490 1 2 498 DELC $T=675180 518000 0 0 $X=675180 $Y=517620
X405 488 1 2 2213 DELC $T=678280 528080 1 0 $X=678280 $Y=522660
X406 2205 1 2 2197 DELC $T=679520 568400 1 0 $X=679520 $Y=562980
X407 2207 1 2 2171 DELC $T=680760 548240 1 0 $X=680760 $Y=542820
X408 2204 1 2 508 DELC $T=680760 598640 0 0 $X=680760 $Y=598260
X409 507 1 2 513 DELC $T=685100 518000 1 0 $X=685100 $Y=512580
X410 2222 1 2 2223 DELC $T=688200 538160 1 0 $X=688200 $Y=532740
X411 2224 1 2 2184 DELC $T=688200 588560 1 0 $X=688200 $Y=583140
X412 2230 1 2 2220 DELC $T=691300 558320 1 0 $X=691300 $Y=552900
X413 2265 1 2 2276 DELC $T=711760 578480 0 0 $X=711760 $Y=578100
X414 565 1 2 573 DELC $T=721060 518000 1 0 $X=721060 $Y=512580
X415 2283 1 2 2275 DELC $T=724160 548240 0 0 $X=724160 $Y=547860
X416 2301 1 2 2271 DELC $T=735940 558320 1 0 $X=735940 $Y=552900
X417 2288 1 2 2251 DELC $T=737800 578480 1 0 $X=737800 $Y=573060
X418 580 1 2 587 DELC $T=739660 518000 0 0 $X=739660 $Y=517620
X419 2286 1 2 2277 DELC $T=758260 538160 1 0 $X=758260 $Y=532740
X420 2279 1 2 2274 DELC $T=769420 528080 1 0 $X=769420 $Y=522660
X421 3003 1 2 794 DELC $T=925040 528080 1 0 $X=925040 $Y=522660
X422 1006 2 1016 1 INV1S $T=226300 598640 1 0 $X=226300 $Y=593220
X423 1042 2 1028 1 INV1S $T=236220 568400 1 180 $X=234980 $Y=568020
X424 1011 2 1042 1 INV1S $T=237460 568400 1 180 $X=236220 $Y=568020
X425 1105 2 1109 1 INV1S $T=260400 568400 0 180 $X=259160 $Y=562980
X426 1117 2 1113 1 INV1S $T=266600 578480 1 180 $X=265360 $Y=578100
X427 46 2 1129 1 INV1S $T=267840 518000 1 0 $X=267840 $Y=512580
X428 1112 2 1127 1 INV1S $T=269700 558320 1 180 $X=268460 $Y=557940
X429 1127 2 1137 1 INV1S $T=269700 558320 0 0 $X=269700 $Y=557940
X430 1159 2 1155 1 INV1S $T=274660 568400 1 0 $X=274660 $Y=562980
X431 42 2 1111 1 INV1S $T=282720 578480 1 0 $X=282720 $Y=573060
X432 1177 2 1181 1 INV1S $T=282720 598640 0 0 $X=282720 $Y=598260
X433 1190 2 1194 1 INV1S $T=287060 568400 0 0 $X=287060 $Y=568020
X434 1199 2 1225 1 INV1S $T=292640 568400 1 0 $X=292640 $Y=562980
X435 1207 2 1220 1 INV1S $T=295740 598640 1 180 $X=294500 $Y=598260
X436 1241 2 1218 1 INV1S $T=296980 598640 1 180 $X=295740 $Y=598260
X437 75 2 76 1 INV1S $T=296360 528080 1 0 $X=296360 $Y=522660
X438 1202 2 1247 1 INV1S $T=296980 598640 1 0 $X=296980 $Y=593220
X439 75 2 80 1 INV1S $T=297600 528080 1 0 $X=297600 $Y=522660
X440 1253 2 1245 1 INV1S $T=300700 558320 1 180 $X=299460 $Y=557940
X441 1222 2 1257 1 INV1S $T=300700 538160 0 0 $X=300700 $Y=537780
X442 1227 2 1254 1 INV1S $T=302560 548240 1 180 $X=301320 $Y=547860
X443 69 2 1262 1 INV1S $T=301940 598640 1 0 $X=301940 $Y=593220
X444 1236 2 1270 1 INV1S $T=304420 538160 0 0 $X=304420 $Y=537780
X445 64 2 1258 1 INV1S $T=306280 588560 0 180 $X=305040 $Y=583140
X446 1079 2 1271 1 INV1S $T=306280 568400 1 0 $X=306280 $Y=562980
X447 1195 2 1269 1 INV1S $T=306280 588560 1 0 $X=306280 $Y=583140
X448 1274 2 1291 1 INV1S $T=312480 558320 1 180 $X=311240 $Y=557940
X449 1304 2 1229 1 INV1S $T=312480 568400 1 180 $X=311240 $Y=568020
X450 98 2 1298 1 INV1S $T=313100 578480 1 180 $X=311860 $Y=578100
X451 1301 2 1306 1 INV1S $T=313100 588560 0 0 $X=313100 $Y=588180
X452 1267 2 1289 1 INV1S $T=314960 548240 1 180 $X=313720 $Y=547860
X453 1301 2 1310 1 INV1S $T=314340 588560 0 0 $X=314340 $Y=588180
X454 1226 2 1313 1 INV1S $T=314960 568400 1 0 $X=314960 $Y=562980
X455 1246 2 1317 1 INV1S $T=315580 588560 1 0 $X=315580 $Y=583140
X456 1326 2 1311 1 INV1S $T=318060 598640 0 180 $X=316820 $Y=593220
X457 1308 2 1344 1 INV1S $T=324260 558320 0 0 $X=324260 $Y=557940
X458 103 2 1356 1 INV1S $T=325500 598640 1 0 $X=325500 $Y=593220
X459 1341 2 1343 1 INV1S $T=326740 548240 1 0 $X=326740 $Y=542820
X460 1341 2 1348 1 INV1S $T=327980 548240 1 0 $X=327980 $Y=542820
X461 94 2 1323 1 INV1S $T=332940 578480 1 0 $X=332940 $Y=573060
X462 1361 2 1380 1 INV1S $T=334800 568400 1 0 $X=334800 $Y=562980
X463 1367 2 1374 1 INV1S $T=334800 598640 1 0 $X=334800 $Y=593220
X464 1371 2 1379 1 INV1S $T=341620 548240 0 180 $X=340380 $Y=542820
X465 1347 2 1413 1 INV1S $T=341620 538160 1 0 $X=341620 $Y=532740
X466 1372 2 1427 1 INV1S $T=344100 568400 0 0 $X=344100 $Y=568020
X467 1422 2 1423 1 INV1S $T=347820 538160 0 180 $X=346580 $Y=532740
X468 1441 2 1446 1 INV1S $T=350920 598640 0 0 $X=350920 $Y=598260
X469 1451 2 1452 1 INV1S $T=352160 558320 1 0 $X=352160 $Y=552900
X470 1456 2 1454 1 INV1S $T=354020 568400 0 0 $X=354020 $Y=568020
X471 1445 2 1419 1 INV1S $T=355880 548240 0 180 $X=354640 $Y=542820
X472 1469 2 1467 1 INV1S $T=357120 548240 0 180 $X=355880 $Y=542820
X473 1463 2 1476 1 INV1S $T=357120 558320 1 0 $X=357120 $Y=552900
X474 1435 2 1431 1 INV1S $T=358980 528080 1 180 $X=357740 $Y=527700
X475 1493 2 1496 1 INV1S $T=362080 558320 0 0 $X=362080 $Y=557940
X476 1505 2 1547 1 INV1S $T=375100 598640 0 0 $X=375100 $Y=598260
X477 1549 2 1552 1 INV1S $T=376340 538160 0 0 $X=376340 $Y=537780
X478 155 2 1555 1 INV1S $T=376340 598640 0 0 $X=376340 $Y=598260
X479 1561 2 1537 1 INV1S $T=380680 568400 0 180 $X=379440 $Y=562980
X480 1574 2 1572 1 INV1S $T=385640 558320 1 180 $X=384400 $Y=557940
X481 1533 2 1581 1 INV1S $T=385640 568400 1 0 $X=385640 $Y=562980
X482 1536 2 1586 1 INV1S $T=387500 538160 0 0 $X=387500 $Y=537780
X483 1531 2 1539 1 INV1S $T=388740 518000 1 0 $X=388740 $Y=512580
X484 1567 2 1597 1 INV1S $T=391840 588560 1 180 $X=390600 $Y=588180
X485 1592 2 1601 1 INV1S $T=392460 548240 1 180 $X=391220 $Y=547860
X486 1569 2 1607 1 INV1S $T=394320 548240 0 0 $X=394320 $Y=547860
X487 1623 2 1627 1 INV1S $T=397420 538160 0 0 $X=397420 $Y=537780
X488 1626 2 1632 1 INV1S $T=398040 578480 0 0 $X=398040 $Y=578100
X489 1610 2 1636 1 INV1S $T=399900 578480 1 0 $X=399900 $Y=573060
X490 1554 2 1650 1 INV1S $T=403620 568400 1 0 $X=403620 $Y=562980
X491 1583 2 1660 1 INV1S $T=407960 568400 1 0 $X=407960 $Y=562980
X492 1629 2 1671 1 INV1S $T=409820 578480 1 0 $X=409820 $Y=573060
X493 178 2 175 1 INV1S $T=412300 528080 1 180 $X=411060 $Y=527700
X494 1628 2 1669 1 INV1S $T=411680 578480 0 0 $X=411680 $Y=578100
X495 1647 2 1662 1 INV1S $T=416640 558320 0 180 $X=415400 $Y=552900
X496 193 2 192 1 INV1S $T=438340 518000 1 180 $X=437100 $Y=517620
X497 191 2 1030 1 INV1S $T=442680 538160 1 180 $X=441440 $Y=537780
X498 1716 2 1729 1 INV1S $T=442680 558320 0 180 $X=441440 $Y=552900
X499 250 2 249 1 INV1S $T=492900 598640 1 180 $X=491660 $Y=598260
X500 252 2 1846 1 INV1S $T=495380 518000 1 0 $X=495380 $Y=512580
X501 269 2 1874 1 INV1S $T=514600 518000 0 180 $X=513360 $Y=512580
X502 270 2 268 1 INV1S $T=514600 598640 1 180 $X=513360 $Y=598260
X503 270 2 272 1 INV1S $T=514600 598640 0 0 $X=514600 $Y=598260
X504 1835 2 1894 1 INV1S $T=515220 528080 0 0 $X=515220 $Y=527700
X505 270 2 274 1 INV1S $T=515840 598640 0 0 $X=515840 $Y=598260
X506 270 2 276 1 INV1S $T=517080 598640 0 0 $X=517080 $Y=598260
X507 1873 2 1896 1 INV1S $T=522040 578480 0 180 $X=520800 $Y=573060
X508 266 2 282 1 INV1S $T=527620 518000 1 0 $X=527620 $Y=512580
X509 283 2 1922 1 INV1S $T=530100 518000 1 0 $X=530100 $Y=512580
X510 294 2 1948 1 INV1S $T=543740 518000 1 0 $X=543740 $Y=512580
X511 1923 2 1965 1 INV1S $T=550560 568400 0 0 $X=550560 $Y=568020
X512 333 2 337 1 INV1S $T=576600 588560 1 0 $X=576600 $Y=583140
X513 333 2 339 1 INV1S $T=577840 588560 1 0 $X=577840 $Y=583140
X514 336 2 342 1 INV1S $T=579700 578480 1 0 $X=579700 $Y=573060
X515 336 2 344 1 INV1S $T=582180 578480 1 0 $X=582180 $Y=573060
X516 336 2 352 1 INV1S $T=590240 578480 1 0 $X=590240 $Y=573060
X517 255 2 2016 1 INV1S $T=593960 578480 1 180 $X=592720 $Y=578100
X518 2077 2 2023 1 INV1S $T=611320 528080 0 180 $X=610080 $Y=522660
X519 2090 2 2085 1 INV1S $T=615660 568400 1 0 $X=615660 $Y=562980
X520 472 2 2161 1 INV1S $T=660920 598640 1 180 $X=659680 $Y=598260
X521 2102 2 475 1 INV1S $T=660920 538160 1 0 $X=660920 $Y=532740
X522 385 2 399 1 INV1S $T=662780 578480 1 0 $X=662780 $Y=573060
X523 2183 2 2185 1 INV1S $T=669600 598640 1 0 $X=669600 $Y=593220
X524 2148 2 2188 1 INV1S $T=670840 578480 1 0 $X=670840 $Y=573060
X525 488 2 2206 1 INV1S $T=681380 518000 1 180 $X=680140 $Y=517620
X526 2210 2 2209 1 INV1S $T=682620 588560 1 180 $X=681380 $Y=588180
X527 502 2 503 1 INV1S $T=682000 518000 1 0 $X=682000 $Y=512580
X528 505 2 2202 1 INV1S $T=684480 598640 0 180 $X=683240 $Y=593220
X529 2184 2 2208 1 INV1S $T=686960 578480 1 180 $X=685720 $Y=578100
X530 523 2 2219 1 INV1S $T=695640 568400 0 180 $X=694400 $Y=562980
X531 2245 2 2253 1 INV1S $T=700600 568400 0 0 $X=700600 $Y=568020
X532 2242 2 2249 1 INV1S $T=702460 518000 0 0 $X=702460 $Y=517620
X533 2244 2 2250 1 INV1S $T=704320 528080 1 180 $X=703080 $Y=527700
X534 2291 2 2295 1 INV1S $T=724160 548240 1 180 $X=722920 $Y=547860
X535 2318 2 2339 1 INV1S $T=739660 528080 1 0 $X=739660 $Y=522660
X536 2331 2 2335 1 INV1S $T=743380 528080 1 180 $X=742140 $Y=527700
X537 2345 2 2348 1 INV1S $T=745240 538160 1 180 $X=744000 $Y=537780
X538 585 2 2323 1 INV1S $T=744000 598640 1 0 $X=744000 $Y=593220
X539 2343 2 588 1 INV1S $T=745240 598640 0 0 $X=745240 $Y=598260
X540 2350 2 2369 1 INV1S $T=749580 568400 1 0 $X=749580 $Y=562980
X541 2364 2 2380 1 INV1S $T=752060 598640 1 0 $X=752060 $Y=593220
X542 2366 2 594 1 INV1S $T=752060 598640 0 0 $X=752060 $Y=598260
X543 599 2 2389 1 INV1S $T=757640 568400 1 180 $X=756400 $Y=568020
X544 2396 2 2395 1 INV1S $T=759500 558320 1 180 $X=758260 $Y=557940
X545 2402 2 2403 1 INV1S $T=759500 558320 0 0 $X=759500 $Y=557940
X546 2382 2 2400 1 INV1S $T=759500 588560 0 0 $X=759500 $Y=588180
X547 601 2 2402 1 INV1S $T=761980 558320 1 180 $X=760740 $Y=557940
X548 2400 2 2394 1 INV1S $T=761980 588560 1 180 $X=760740 $Y=588180
X549 2408 2 2386 1 INV1S $T=763220 568400 0 0 $X=763220 $Y=568020
X550 2435 2 2425 1 INV1S $T=768180 548240 1 180 $X=766940 $Y=547860
X551 2432 2 2413 1 INV1S $T=768800 588560 0 180 $X=767560 $Y=583140
X552 2430 2 2427 1 INV1S $T=769420 528080 0 180 $X=768180 $Y=522660
X553 2453 2 2416 1 INV1S $T=770040 558320 1 180 $X=768800 $Y=557940
X554 2445 2 2443 1 INV1S $T=772520 538160 0 180 $X=771280 $Y=532740
X555 2450 2 2457 1 INV1S $T=771280 568400 1 0 $X=771280 $Y=562980
X556 613 2 2463 1 INV1S $T=773140 568400 0 0 $X=773140 $Y=568020
X557 2452 2 2464 1 INV1S $T=774380 518000 0 0 $X=774380 $Y=517620
X558 603 2 608 1 INV1S $T=774380 538160 1 0 $X=774380 $Y=532740
X559 2448 2 2465 1 INV1S $T=775000 588560 1 0 $X=775000 $Y=583140
X560 2468 2 2448 1 INV1S $T=777480 588560 0 180 $X=776240 $Y=583140
X561 2474 2 2487 1 INV1S $T=779340 538160 1 0 $X=779340 $Y=532740
X562 2491 2 2492 1 INV1S $T=780580 578480 1 0 $X=780580 $Y=573060
X563 2492 2 2505 1 INV1S $T=781820 578480 1 0 $X=781820 $Y=573060
X564 2482 2 2499 1 INV1S $T=781820 588560 1 0 $X=781820 $Y=583140
X565 2501 2 2507 1 INV1S $T=784920 568400 0 0 $X=784920 $Y=568020
X566 2486 2 2506 1 INV1S $T=785540 528080 0 0 $X=785540 $Y=527700
X567 2508 2 2515 1 INV1S $T=785540 588560 1 0 $X=785540 $Y=583140
X568 2469 2 2497 1 INV1S $T=788020 518000 0 180 $X=786780 $Y=512580
X569 2529 2 2537 1 INV1S $T=793600 558320 1 0 $X=793600 $Y=552900
X570 2544 2 2536 1 INV1S $T=796080 578480 0 180 $X=794840 $Y=573060
X571 636 2 2541 1 INV1S $T=797940 578480 0 180 $X=796700 $Y=573060
X572 2552 2 2544 1 INV1S $T=797940 578480 1 180 $X=796700 $Y=578100
X573 2553 2 2550 1 INV1S $T=797940 588560 1 180 $X=796700 $Y=588180
X574 633 2 2548 1 INV1S $T=797940 558320 0 0 $X=797940 $Y=557940
X575 635 2 640 1 INV1S $T=799800 518000 1 0 $X=799800 $Y=512580
X576 2590 2 2599 1 INV1S $T=810340 588560 1 0 $X=810340 $Y=583140
X577 652 2 2598 1 INV1S $T=812200 578480 0 180 $X=810960 $Y=573060
X578 2603 2 2606 1 INV1S $T=812200 558320 1 0 $X=812200 $Y=552900
X579 656 2 653 1 INV1S $T=814680 518000 0 180 $X=813440 $Y=512580
X580 2613 2 2527 1 INV1S $T=815920 538160 1 180 $X=814680 $Y=537780
X581 2616 2 2613 1 INV1S $T=816540 538160 0 180 $X=815300 $Y=532740
X582 2637 2 2608 1 INV1S $T=817780 568400 1 180 $X=816540 $Y=568020
X583 2608 2 2614 1 INV1S $T=817780 578480 0 180 $X=816540 $Y=573060
X584 659 2 2525 1 INV1S $T=817780 518000 0 0 $X=817780 $Y=517620
X585 662 2 603 1 INV1S $T=820260 518000 0 180 $X=819020 $Y=512580
X586 2611 2 2629 1 INV1S $T=819020 588560 1 0 $X=819020 $Y=583140
X587 664 2 665 1 INV1S $T=821500 598640 0 0 $X=821500 $Y=598260
X588 2651 2 2643 1 INV1S $T=826460 558320 0 180 $X=825220 $Y=552900
X589 670 2 2625 1 INV1S $T=827080 518000 0 180 $X=825840 $Y=512580
X590 2668 2 2649 1 INV1S $T=828320 588560 0 180 $X=827080 $Y=583140
X591 2642 2 2655 1 INV1S $T=827700 568400 0 0 $X=827700 $Y=568020
X592 674 2 677 1 INV1S $T=828320 518000 1 0 $X=828320 $Y=512580
X593 2636 2 2650 1 INV1S $T=828940 578480 1 0 $X=828940 $Y=573060
X594 2673 2 2671 1 INV1S $T=833280 568400 1 180 $X=832040 $Y=568020
X595 2681 2 2676 1 INV1S $T=836380 578480 1 180 $X=835140 $Y=578100
X596 680 2 691 1 INV1S $T=835760 518000 1 0 $X=835760 $Y=512580
X597 659 2 2669 1 INV1S $T=837000 518000 1 180 $X=835760 $Y=517620
X598 2680 2 2693 1 INV1S $T=837000 578480 0 0 $X=837000 $Y=578100
X599 2520 2 2692 1 INV1S $T=837620 538160 1 0 $X=837620 $Y=532740
X600 2688 2 2689 1 INV1S $T=837620 558320 1 0 $X=837620 $Y=552900
X601 687 2 2520 1 INV1S $T=840720 538160 1 0 $X=840720 $Y=532740
X602 689 2 695 1 INV1S $T=841960 518000 1 0 $X=841960 $Y=512580
X603 2664 2 2705 1 INV1S $T=843200 588560 1 180 $X=841960 $Y=588180
X604 2698 2 2709 1 INV1S $T=844440 528080 1 180 $X=843200 $Y=527700
X605 2713 2 2704 1 INV1S $T=845060 578480 1 180 $X=843820 $Y=578100
X606 2693 2 2721 1 INV1S $T=846920 568400 0 180 $X=845680 $Y=562980
X607 693 2 2735 1 INV1S $T=846920 518000 1 0 $X=846920 $Y=512580
X608 2732 2 2731 1 INV1S $T=848780 538160 0 180 $X=847540 $Y=532740
X609 600 2 2716 1 INV1S $T=847540 588560 1 0 $X=847540 $Y=583140
X610 2747 2 2743 1 INV1S $T=851260 548240 1 180 $X=850020 $Y=547860
X611 702 2 2717 1 INV1S $T=851880 598640 1 180 $X=850640 $Y=598260
X612 2742 2 2757 1 INV1S $T=854360 578480 0 180 $X=853120 $Y=573060
X613 2722 2 2761 1 INV1S $T=853120 588560 1 0 $X=853120 $Y=583140
X614 2711 2 2767 1 INV1S $T=854360 578480 1 0 $X=854360 $Y=573060
X615 2748 2 2769 1 INV1S $T=856840 518000 1 180 $X=855600 $Y=517620
X616 2332 2 2751 1 INV1S $T=855600 588560 0 0 $X=855600 $Y=588180
X617 620 2 2772 1 INV1S $T=857460 548240 0 180 $X=856220 $Y=542820
X618 2745 2 2781 1 INV1S $T=856840 578480 1 0 $X=856840 $Y=573060
X619 2746 2 2795 1 INV1S $T=859320 528080 1 0 $X=859320 $Y=522660
X620 714 2 713 1 INV1S $T=863040 518000 0 180 $X=861800 $Y=512580
X621 2758 2 2803 1 INV1S $T=863660 588560 1 0 $X=863660 $Y=583140
X622 2771 2 721 1 INV1S $T=864900 598640 0 0 $X=864900 $Y=598260
X623 669 2 712 1 INV1S $T=865520 528080 0 0 $X=865520 $Y=527700
X624 2798 2 2794 1 INV1S $T=866760 558320 1 180 $X=865520 $Y=557940
X625 2814 2 2818 1 INV1S $T=868000 568400 1 0 $X=868000 $Y=562980
X626 2784 2 2819 1 INV1S $T=869860 598640 1 180 $X=868620 $Y=598260
X627 2783 2 2822 1 INV1S $T=869240 588560 1 0 $X=869240 $Y=583140
X628 2753 2 2837 1 INV1S $T=873580 518000 0 0 $X=873580 $Y=517620
X629 718 2 729 1 INV1S $T=874200 518000 1 0 $X=874200 $Y=512580
X630 2857 2 2853 1 INV1S $T=878540 588560 0 180 $X=877300 $Y=583140
X631 2754 2 2851 1 INV1S $T=877920 528080 0 0 $X=877920 $Y=527700
X632 2844 2 2862 1 INV1S $T=878540 548240 1 0 $X=878540 $Y=542820
X633 2817 2 741 1 INV1S $T=881640 558320 0 0 $X=881640 $Y=557940
X634 745 2 2879 1 INV1S $T=883500 518000 0 0 $X=883500 $Y=517620
X635 747 2 749 1 INV1S $T=883500 568400 0 0 $X=883500 $Y=568020
X636 2807 2 2870 1 INV1S $T=885360 548240 1 180 $X=884120 $Y=547860
X637 756 2 755 1 INV1S $T=891560 518000 1 180 $X=890320 $Y=517620
X638 736 2 758 1 INV1S $T=894040 578480 1 180 $X=892800 $Y=578100
X639 2942 2 2945 1 INV1S $T=902720 538160 0 0 $X=902720 $Y=537780
X640 2980 2 2986 1 INV1S $T=916980 518000 1 0 $X=916980 $Y=512580
X641 2973 2 2983 1 INV1S $T=917600 598640 0 0 $X=917600 $Y=598260
X642 3009 2 3001 1 INV1S $T=927520 588560 0 180 $X=926280 $Y=583140
X643 2964 2 2976 1 INV1S $T=930000 588560 0 180 $X=928760 $Y=583140
X644 3021 2 3017 1 INV1S $T=933100 578480 1 180 $X=931860 $Y=578100
X645 799 2 3029 1 INV1S $T=933720 518000 1 0 $X=933720 $Y=512580
X646 585 2 2964 1 INV1S $T=934960 588560 0 180 $X=933720 $Y=583140
X647 3049 2 3033 1 INV1S $T=941160 578480 1 180 $X=939920 $Y=578100
X648 3034 2 3055 1 INV1S $T=943640 568400 0 180 $X=942400 $Y=562980
X649 3060 2 3065 1 INV1S $T=943640 568400 0 0 $X=943640 $Y=568020
X650 669 2 807 1 INV1S $T=944260 518000 1 0 $X=944260 $Y=512580
X651 3078 2 3064 1 INV1S $T=948600 538160 0 180 $X=947360 $Y=532740
X652 3079 2 3076 1 INV1S $T=949840 588560 0 180 $X=948600 $Y=583140
X653 3073 2 3082 1 INV1S $T=951700 528080 0 180 $X=950460 $Y=522660
X654 815 2 813 1 INV1S $T=954800 518000 0 180 $X=953560 $Y=512580
X655 816 2 818 1 INV1S $T=956660 518000 1 0 $X=956660 $Y=512580
X656 3112 2 3104 1 INV1S $T=959140 578480 1 0 $X=959140 $Y=573060
X657 659 2 3089 1 INV1S $T=962240 518000 1 180 $X=961000 $Y=517620
X658 3086 2 3095 1 INV1S $T=962240 578480 1 180 $X=961000 $Y=578100
X659 830 2 828 1 INV1S $T=965340 518000 0 180 $X=964100 $Y=512580
X660 3118 2 3106 1 INV1S $T=967200 588560 0 180 $X=965960 $Y=583140
X661 3143 2 3099 1 INV1S $T=969680 578480 1 180 $X=968440 $Y=578100
X662 837 2 833 1 INV1S $T=972160 518000 0 180 $X=970920 $Y=512580
X663 3099 2 3155 1 INV1S $T=972160 578480 0 0 $X=972160 $Y=578100
X664 3168 2 3150 1 INV1S $T=975880 588560 1 180 $X=974640 $Y=588180
X665 3114 2 3129 1 INV1S $T=975260 568400 0 0 $X=975260 $Y=568020
X666 3148 2 3128 1 INV1S $T=977740 568400 1 180 $X=976500 $Y=568020
X667 840 2 842 1 INV1S $T=978980 518000 0 180 $X=977740 $Y=512580
X668 3172 2 3183 1 INV1S $T=978980 568400 1 0 $X=978980 $Y=562980
X669 2964 2 3175 1 INV1S $T=978980 578480 0 0 $X=978980 $Y=578100
X670 687 2 3121 1 INV1S $T=982080 538160 0 180 $X=980840 $Y=532740
X671 3170 2 3190 1 INV1S $T=982700 588560 1 180 $X=981460 $Y=588180
X672 3185 2 3197 1 INV1S $T=982700 558320 0 0 $X=982700 $Y=557940
X673 3160 2 3195 1 INV1S $T=982700 578480 1 0 $X=982700 $Y=573060
X674 849 2 850 1 INV1S $T=984560 518000 1 0 $X=984560 $Y=512580
X675 3195 2 3205 1 INV1S $T=985180 578480 1 0 $X=985180 $Y=573060
X676 3201 2 3198 1 INV1S $T=987660 528080 0 180 $X=986420 $Y=522660
X677 3214 2 3203 1 INV1S $T=990760 588560 1 180 $X=989520 $Y=588180
X678 659 2 3219 1 INV1S $T=992000 538160 1 0 $X=992000 $Y=532740
X679 857 2 3236 1 INV1S $T=996340 518000 1 0 $X=996340 $Y=512580
X680 3228 2 3232 1 INV1S $T=996960 588560 1 0 $X=996960 $Y=583140
X681 3233 2 3250 1 INV1S $T=1000060 578480 1 0 $X=1000060 $Y=573060
X682 3250 2 3253 1 INV1S $T=1001300 578480 1 0 $X=1001300 $Y=573060
X683 3255 2 3254 1 INV1S $T=1004400 588560 0 180 $X=1003160 $Y=583140
X684 860 2 869 1 INV1S $T=1005020 518000 1 0 $X=1005020 $Y=512580
X685 3263 2 3258 1 INV1S $T=1006260 528080 1 180 $X=1005020 $Y=527700
X686 3266 2 3259 1 INV1S $T=1006260 538160 0 180 $X=1005020 $Y=532740
X687 3270 2 3268 1 INV1S $T=1011220 588560 0 180 $X=1009980 $Y=583140
X688 876 2 3283 1 INV1S $T=1012460 598640 0 0 $X=1012460 $Y=598260
X689 882 2 878 1 INV1S $T=1016800 518000 0 180 $X=1015560 $Y=512580
X690 3280 2 3295 1 INV1S $T=1015560 548240 0 0 $X=1015560 $Y=547860
X691 3284 2 3287 1 INV1S $T=1016800 588560 1 0 $X=1016800 $Y=583140
X692 3279 2 3309 1 INV1S $T=1018660 518000 1 0 $X=1018660 $Y=512580
X693 3267 2 3313 1 INV1S $T=1022380 528080 1 0 $X=1022380 $Y=522660
X694 3289 2 3310 1 INV1S $T=1022380 528080 0 0 $X=1022380 $Y=527700
X695 3301 2 3303 1 INV1S $T=1022380 538160 0 0 $X=1022380 $Y=537780
X696 3302 2 3314 1 INV1S $T=1023620 588560 1 0 $X=1023620 $Y=583140
X697 886 2 3187 1 INV1S $T=1026100 598640 0 180 $X=1024860 $Y=593220
X698 3300 2 3336 1 INV1S $T=1032300 538160 1 0 $X=1032300 $Y=532740
X699 3344 2 3342 1 INV1S $T=1035400 588560 0 0 $X=1035400 $Y=588180
X700 669 2 890 1 INV1S $T=1036640 548240 1 0 $X=1036640 $Y=542820
X701 3345 2 3352 1 INV1S $T=1036640 568400 1 0 $X=1036640 $Y=562980
X702 3353 2 3357 1 INV1S $T=1040360 558320 0 0 $X=1040360 $Y=557940
X703 585 2 900 1 INV1S $T=1042220 598640 1 180 $X=1040980 $Y=598260
X704 3299 2 3366 1 INV1S $T=1042220 538160 1 0 $X=1042220 $Y=532740
X705 881 2 904 1 INV1S $T=1042840 518000 1 0 $X=1042840 $Y=512580
X706 3298 2 3371 1 INV1S $T=1042840 528080 1 0 $X=1042840 $Y=522660
X707 3294 2 3363 1 INV1S $T=1044700 598640 0 180 $X=1043460 $Y=593220
X708 3329 2 3377 1 INV1S $T=1045320 538160 0 0 $X=1045320 $Y=537780
X709 3297 2 3376 1 INV1S $T=1047180 528080 0 0 $X=1047180 $Y=527700
X710 3352 2 3378 1 INV1S $T=1049040 568400 0 180 $X=1047800 $Y=562980
X711 3410 2 3421 1 INV1S $T=1059580 598640 1 180 $X=1058340 $Y=598260
X712 3411 2 3434 1 INV1S $T=1060820 548240 0 0 $X=1060820 $Y=547860
X713 3387 2 3448 1 INV1S $T=1063920 578480 1 0 $X=1063920 $Y=573060
X714 926 2 928 1 INV1S $T=1068260 518000 0 0 $X=1068260 $Y=517620
X715 3265 2 3474 1 INV1S $T=1073220 578480 0 0 $X=1073220 $Y=578100
X716 3408 2 3480 1 INV1S $T=1075080 588560 0 0 $X=1075080 $Y=588180
X717 3480 2 3470 1 INV1S $T=1076320 588560 0 0 $X=1076320 $Y=588180
X718 3486 2 936 1 INV1S $T=1079420 578480 0 0 $X=1079420 $Y=578100
X719 3343 2 3489 1 INV1S $T=1081280 598640 0 0 $X=1081280 $Y=598260
X720 3320 2 3493 1 INV1S $T=1085620 588560 1 0 $X=1085620 $Y=583140
X721 3493 2 3490 1 INV1S $T=1088100 588560 0 180 $X=1086860 $Y=583140
X722 1022 1 1008 1006 2 10 ND3 $T=221340 598640 1 0 $X=221340 $Y=593220
X723 1094 1 1096 1091 2 1098 ND3 $T=252960 548240 1 0 $X=252960 $Y=542820
X724 66 1 1200 72 2 1213 ND3 $T=286440 518000 1 0 $X=286440 $Y=512580
X725 212 1 1782 1793 2 210 ND3 $T=458180 598640 1 180 $X=455700 $Y=598260
X726 1809 1 1835 1909 2 1862 ND3 $T=520800 528080 1 0 $X=520800 $Y=522660
X727 1870 1 1873 1919 2 1888 ND3 $T=525760 578480 1 180 $X=523280 $Y=578100
X728 258 1 1821 1913 2 1834 ND3 $T=523900 518000 0 0 $X=523900 $Y=517620
X729 1861 1 1921 1918 2 1869 ND3 $T=531960 568400 1 180 $X=529480 $Y=568020
X730 1836 1 1824 2014 2 1837 ND3 $T=582800 568400 1 0 $X=582800 $Y=562980
X731 243 1 255 2019 2 1820 ND3 $T=587760 568400 0 0 $X=587760 $Y=568020
X732 2050 1 2055 365 2 2037 ND3 $T=602640 528080 1 180 $X=600160 $Y=527700
X733 2062 1 2055 371 2 2039 ND3 $T=602640 528080 0 0 $X=602640 $Y=527700
X734 2067 1 2055 376 2 2057 ND3 $T=607600 528080 0 180 $X=605120 $Y=522660
X735 2070 1 2055 379 2 2027 ND3 $T=607600 528080 1 0 $X=607600 $Y=522660
X736 2073 1 2093 394 2 2087 ND3 $T=618760 558320 0 180 $X=616280 $Y=552900
X737 2079 1 2094 2102 2 2083 ND3 $T=620620 568400 1 0 $X=620620 $Y=562980
X738 2107 1 2093 409 2 2095 ND3 $T=624340 548240 1 180 $X=621860 $Y=547860
X739 2071 1 2098 408 2 2044 ND3 $T=622480 538160 1 0 $X=622480 $Y=532740
X740 2101 1 2093 416 2 2103 ND3 $T=626820 568400 1 0 $X=626820 $Y=562980
X741 2112 1 2055 417 2 2043 ND3 $T=629920 528080 1 180 $X=627440 $Y=527700
X742 2118 1 2055 425 2 2031 ND3 $T=632400 528080 1 180 $X=629920 $Y=527700
X743 2119 1 2093 422 2 2108 ND3 $T=632400 568400 0 180 $X=629920 $Y=562980
X744 2110 1 2055 427 2 2036 ND3 $T=631160 538160 1 0 $X=631160 $Y=532740
X745 2123 1 2055 430 2 2024 ND3 $T=634880 528080 1 180 $X=632400 $Y=527700
X746 2121 1 2055 435 2 2082 ND3 $T=636120 538160 0 180 $X=633640 $Y=532740
X747 2120 1 2093 433 2 2125 ND3 $T=635500 578480 1 0 $X=635500 $Y=573060
X748 2129 1 2055 434 2 2041 ND3 $T=638600 528080 0 180 $X=636120 $Y=522660
X749 2137 1 2093 438 2 2117 ND3 $T=640460 568400 1 180 $X=637980 $Y=568020
X750 2134 1 2093 436 2 2114 ND3 $T=640460 578480 0 180 $X=637980 $Y=573060
X751 2141 1 2093 449 2 2106 ND3 $T=646660 578480 0 180 $X=644180 $Y=573060
X752 2147 1 2093 455 2 2081 ND3 $T=651000 568400 0 180 $X=648520 $Y=562980
X753 2152 1 2093 467 2 2099 ND3 $T=653480 568400 0 180 $X=651000 $Y=562980
X754 478 1 476 468 2 474 ND3 $T=663400 598640 1 180 $X=660920 $Y=598260
X755 2155 1 2145 2176 2 2178 ND3 $T=667120 528080 0 0 $X=667120 $Y=527700
X756 2184 1 2183 2174 2 2148 ND3 $T=670840 578480 0 180 $X=668360 $Y=573060
X757 2171 1 488 2193 2 2165 ND3 $T=675180 528080 1 180 $X=672700 $Y=527700
X758 2198 1 472 2179 2 495 ND3 $T=675800 598640 1 0 $X=675800 $Y=593220
X759 2223 1 2220 2234 2 2233 ND3 $T=693160 538160 1 0 $X=693160 $Y=532740
X760 2239 1 2244 2237 2 2228 ND3 $T=701220 538160 1 180 $X=698740 $Y=537780
X761 2261 1 2260 542 2 2252 ND3 $T=706800 588560 0 180 $X=704320 $Y=583140
X762 2587 1 2581 2564 2 2579 ND3 $T=808480 568400 1 180 $X=806000 $Y=568020
X763 2995 1 778 2965 2 779 ND3 $T=918220 518000 1 0 $X=918220 $Y=512580
X764 161 465 466 2 468 1 2156 AN4B1S $T=655340 598640 0 0 $X=655340 $Y=598260
X765 67 2 1224 1220 1 NR2 $T=292020 598640 1 0 $X=292020 $Y=593220
X766 1214 2 1174 1246 1 NR2 $T=296360 588560 1 0 $X=296360 $Y=583140
X767 1263 2 1264 1221 1 NR2 $T=302560 578480 0 180 $X=300700 $Y=573060
X768 1263 2 1259 1226 1 NR2 $T=302560 568400 1 0 $X=302560 $Y=562980
X769 1263 2 1261 1268 1 NR2 $T=303180 588560 1 0 $X=303180 $Y=583140
X770 1263 2 1286 1229 1 NR2 $T=308760 568400 0 0 $X=308760 $Y=568020
X771 103 2 1382 126 1 NR2 $T=336040 598640 1 0 $X=336040 $Y=593220
X772 103 2 1399 127 1 NR2 $T=337900 598640 1 0 $X=337900 $Y=593220
X773 103 2 1420 131 1 NR2 $T=343480 598640 1 0 $X=343480 $Y=593220
X774 103 2 1439 135 1 NR2 $T=347200 598640 1 0 $X=347200 $Y=593220
X775 1426 2 1440 1419 1 NR2 $T=350300 558320 1 0 $X=350300 $Y=552900
X776 103 2 1460 140 1 NR2 $T=352780 598640 1 0 $X=352780 $Y=593220
X777 103 2 1477 146 1 NR2 $T=356500 598640 1 0 $X=356500 $Y=593220
X778 103 2 1488 149 1 NR2 $T=362700 598640 1 0 $X=362700 $Y=593220
X779 103 2 1498 150 1 NR2 $T=367040 598640 0 180 $X=365180 $Y=593220
X780 103 2 1503 151 1 NR2 $T=368900 598640 0 180 $X=367040 $Y=593220
X781 1475 2 1500 1467 1 NR2 $T=368280 548240 0 0 $X=368280 $Y=547860
X782 103 2 1518 153 1 NR2 $T=368900 598640 1 0 $X=368900 $Y=593220
X783 103 2 1543 160 1 NR2 $T=378200 598640 1 0 $X=378200 $Y=593220
X784 164 2 1509 103 1 NR2 $T=391840 588560 0 0 $X=391840 $Y=588180
X785 1689 2 1742 1729 1 NR2 $T=424700 568400 1 0 $X=424700 $Y=562980
X786 258 2 1901 1834 1 NR2 $T=523900 538160 1 0 $X=523900 $Y=532740
X787 1861 2 1899 1869 1 NR2 $T=529480 568400 0 180 $X=527620 $Y=562980
X788 1895 2 1949 1923 1 NR2 $T=546220 568400 0 0 $X=546220 $Y=568020
X789 1836 2 2000 1837 1 NR2 $T=577840 578480 1 0 $X=577840 $Y=573060
X790 481 2 480 2161 1 NR2 $T=665880 598640 1 180 $X=664020 $Y=598260
X791 2155 2 2190 2178 1 NR2 $T=672080 528080 1 0 $X=672080 $Y=522660
X792 2202 2 2198 2209 1 NR2 $T=678900 588560 0 0 $X=678900 $Y=588180
X793 501 2 2215 385 1 NR2 $T=683240 518000 1 0 $X=683240 $Y=512580
X794 2219 2 2029 385 1 NR2 $T=686340 568400 0 180 $X=684480 $Y=562980
X795 510 2 377 2219 1 NR2 $T=687580 568400 1 180 $X=685720 $Y=568020
X796 2223 2 2248 2233 1 NR2 $T=699360 538160 1 0 $X=699360 $Y=532740
X797 2253 2 2261 2259 1 NR2 $T=704320 568400 0 0 $X=704320 $Y=568020
X798 2253 2 2257 2258 1 NR2 $T=706180 568400 0 0 $X=706180 $Y=568020
X799 540 2 543 2242 1 NR2 $T=709280 518000 1 180 $X=707420 $Y=517620
X800 2436 2 2433 607 1 NR2 $T=768180 548240 0 180 $X=766320 $Y=542820
X801 2436 2 2442 609 1 NR2 $T=770040 548240 0 180 $X=768180 $Y=542820
X802 611 2 2454 2436 1 NR2 $T=770040 548240 1 0 $X=770040 $Y=542820
X803 2436 2 2473 619 1 NR2 $T=778720 548240 1 180 $X=776860 $Y=547860
X804 2436 2 2500 621 1 NR2 $T=783060 548240 1 180 $X=781200 $Y=547860
X805 2436 2 2509 626 1 NR2 $T=788020 558320 0 180 $X=786160 $Y=552900
X806 624 2 2510 2507 1 NR2 $T=788020 558320 0 0 $X=788020 $Y=557940
X807 2436 2 2540 631 1 NR2 $T=794840 548240 1 180 $X=792980 $Y=547860
X808 2436 2 2556 638 1 NR2 $T=800420 558320 0 180 $X=798560 $Y=552900
X809 2436 2 2573 642 1 NR2 $T=801040 558320 1 0 $X=801040 $Y=552900
X810 615 2 2591 650 1 NR2 $T=809720 548240 0 0 $X=809720 $Y=547860
X811 615 2 2618 661 1 NR2 $T=820260 548240 1 180 $X=818400 $Y=547860
X812 615 2 2630 666 1 NR2 $T=821500 548240 0 0 $X=821500 $Y=547860
X813 615 2 2645 673 1 NR2 $T=826460 548240 0 0 $X=826460 $Y=547860
X814 615 2 2657 678 1 NR2 $T=829560 558320 1 0 $X=829560 $Y=552900
X815 634 2 2670 2668 1 NR2 $T=830800 588560 1 0 $X=830800 $Y=583140
X816 615 2 2661 682 1 NR2 $T=831420 558320 1 0 $X=831420 $Y=552900
X817 615 2 2674 545 1 NR2 $T=835140 558320 1 0 $X=835140 $Y=552900
X818 634 2 2690 2691 1 NR2 $T=840100 588560 1 180 $X=838240 $Y=588180
X819 634 2 2696 2705 1 NR2 $T=840100 588560 1 0 $X=840100 $Y=583140
X820 2520 2 2700 2701 1 NR2 $T=841340 528080 0 0 $X=841340 $Y=527700
X821 2520 2 2707 2709 1 NR2 $T=841960 528080 1 0 $X=841960 $Y=522660
X822 2715 2 2678 660 1 NR2 $T=845680 538160 0 180 $X=843820 $Y=532740
X823 2730 2 2664 618 1 NR2 $T=846920 598640 0 180 $X=845060 $Y=593220
X824 2520 2 2727 2732 1 NR2 $T=846300 528080 0 0 $X=846300 $Y=527700
X825 634 2 2744 2738 1 NR2 $T=851880 588560 1 180 $X=850020 $Y=588180
X826 2784 2 2800 717 1 NR2 $T=862420 598640 0 0 $X=862420 $Y=598260
X827 2786 2 2825 2807 1 NR2 $T=868620 548240 1 0 $X=868620 $Y=542820
X828 786 2 3004 781 1 NR2 $T=925660 598640 1 180 $X=923800 $Y=598260
X829 615 2 3027 153 1 NR2 $T=934960 548240 1 180 $X=933100 $Y=547860
X830 615 2 3026 801 1 NR2 $T=936820 558320 0 180 $X=934960 $Y=552900
X831 615 2 3046 150 1 NR2 $T=938680 548240 1 180 $X=936820 $Y=547860
X832 786 2 3038 615 1 NR2 $T=936820 558320 0 0 $X=936820 $Y=557940
X833 615 2 3043 151 1 NR2 $T=941160 558320 0 180 $X=939300 $Y=552900
X834 615 2 3083 149 1 NR2 $T=949840 558320 0 180 $X=947980 $Y=552900
X835 615 2 3097 146 1 NR2 $T=957280 558320 0 180 $X=955420 $Y=552900
X836 615 2 3117 140 1 NR2 $T=963480 558320 0 180 $X=961620 $Y=552900
X837 615 2 3136 135 1 NR2 $T=967200 558320 0 180 $X=965340 $Y=552900
X838 615 2 3140 131 1 NR2 $T=969060 558320 0 180 $X=967200 $Y=552900
X839 615 2 3158 127 1 NR2 $T=973400 558320 0 0 $X=973400 $Y=557940
X840 615 2 3180 126 1 NR2 $T=978980 558320 0 0 $X=978980 $Y=557940
X841 615 2 3196 118 1 NR2 $T=985800 558320 0 180 $X=983940 $Y=552900
X842 615 2 3207 851 1 NR2 $T=987660 558320 0 180 $X=985800 $Y=552900
X843 615 2 3226 574 1 NR2 $T=995720 558320 1 180 $X=993860 $Y=557940
X844 3121 2 3264 3263 1 NR2 $T=1007500 528080 0 180 $X=1005640 $Y=522660
X845 3121 2 3275 3266 1 NR2 $T=1010600 538160 0 180 $X=1008740 $Y=532740
X846 3121 2 3271 3276 1 NR2 $T=1009360 528080 1 0 $X=1009360 $Y=522660
X847 3121 2 3281 3252 1 NR2 $T=1012460 538160 1 0 $X=1012460 $Y=532740
X848 3215 2 3301 3252 1 NR2 $T=1020520 548240 0 180 $X=1018660 $Y=542820
X849 634 2 3296 884 1 NR2 $T=1019280 598640 0 0 $X=1019280 $Y=598260
X850 3292 2 3306 3280 1 NR2 $T=1027960 548240 0 180 $X=1026100 $Y=542820
X851 634 2 3325 3326 1 NR2 $T=1027960 598640 1 0 $X=1027960 $Y=593220
X852 1854 2 1880 1870 1892 1 NR3 $T=513360 588560 1 0 $X=513360 $Y=583140
X853 1862 2 1821 1809 1898 1 NR3 $T=518320 528080 0 180 $X=515220 $Y=522660
X854 1820 2 1824 243 2015 1 NR3 $T=587140 578480 1 180 $X=584040 $Y=578100
X855 2165 2 2145 2171 2187 1 NR3 $T=672700 528080 1 180 $X=669600 $Y=527700
X856 2228 2 2220 2239 2254 1 NR3 $T=701840 538160 0 0 $X=701840 $Y=537780
X857 1180 1030 1 60 1030 1160 2 MOAI1S $T=283960 538160 0 180 $X=280240 $Y=532740
X858 1873 1949 1 1895 1965 1971 2 MOAI1S $T=551180 568400 1 0 $X=551180 $Y=562980
X859 2194 480 1 485 2185 2180 2 MOAI1S $T=673320 588560 0 180 $X=669600 $Y=583140
X860 2186 480 1 485 2188 2189 2 MOAI1S $T=676420 578480 0 180 $X=672700 $Y=573060
X861 2200 480 1 485 2208 2201 2 MOAI1S $T=678280 578480 0 0 $X=678280 $Y=578100
X862 2211 480 1 485 2202 2204 2 MOAI1S $T=682620 598640 0 180 $X=678900 $Y=593220
X863 2217 480 1 485 2209 2205 2 MOAI1S $T=685720 578480 1 180 $X=682000 $Y=578100
X864 472 2200 1 466 2227 519 2 MOAI1S $T=688820 578480 1 0 $X=688820 $Y=573060
X865 2244 543 1 540 2249 2246 2 MOAI1S $T=707420 518000 1 180 $X=703700 $Y=517620
X866 399 531 1 546 2259 548 2 MOAI1S $T=708040 568400 0 0 $X=708040 $Y=568020
X867 1002 1001 1006 1 2 ND2 $T=220720 568400 0 0 $X=220720 $Y=568020
X868 5 1008 1019 1 2 ND2 $T=221960 588560 0 0 $X=221960 $Y=588180
X869 11 1017 1010 1 2 ND2 $T=224440 548240 1 180 $X=222580 $Y=547860
X870 1007 1020 1006 1 2 ND2 $T=226920 568400 1 180 $X=225060 $Y=568020
X871 1025 1010 1020 1 2 ND2 $T=226920 578480 1 0 $X=226920 $Y=573060
X872 14 1022 1019 1 2 ND2 $T=226920 588560 0 0 $X=226920 $Y=588180
X873 1032 1024 1010 1 2 ND2 $T=230640 548240 1 180 $X=228780 $Y=547860
X874 16 1043 1026 1 2 ND2 $T=235600 538160 1 180 $X=233740 $Y=537780
X875 1029 1054 1026 1 2 ND2 $T=235600 548240 0 180 $X=233740 $Y=542820
X876 11 1018 1032 1 2 ND2 $T=236220 548240 1 180 $X=234360 $Y=547860
X877 1056 1061 1051 1 2 ND2 $T=241800 568400 0 180 $X=239940 $Y=562980
X878 1041 1060 1037 1 2 ND2 $T=243040 588560 1 180 $X=241180 $Y=588180
X879 1040 1049 1045 1 2 ND2 $T=242420 588560 1 0 $X=242420 $Y=583140
X880 1067 1071 1063 1 2 ND2 $T=244900 548240 1 180 $X=243040 $Y=547860
X881 1058 1078 1073 1 2 ND2 $T=244280 578480 1 0 $X=244280 $Y=573060
X882 1038 1068 1058 1 2 ND2 $T=249860 578480 0 180 $X=248000 $Y=573060
X883 1056 1080 1090 1 2 ND2 $T=249240 568400 1 0 $X=249240 $Y=562980
X884 1081 1083 1063 1 2 ND2 $T=252340 548240 0 180 $X=250480 $Y=542820
X885 1038 1075 1073 1 2 ND2 $T=251100 578480 0 0 $X=251100 $Y=578100
X886 1051 1065 1090 1 2 ND2 $T=251720 568400 1 0 $X=251720 $Y=562980
X887 1092 1088 1086 1 2 ND2 $T=252340 558320 1 0 $X=252340 $Y=552900
X888 1066 1098 1076 1 2 ND2 $T=255440 538160 1 180 $X=253580 $Y=537780
X889 1076 1096 33 1 2 ND2 $T=253580 548240 0 0 $X=253580 $Y=547860
X890 1066 1094 33 1 2 ND2 $T=257300 538160 0 0 $X=257300 $Y=537780
X891 1117 1107 1111 1 2 ND2 $T=259780 568400 0 0 $X=259780 $Y=568020
X892 1121 1128 1079 1 2 ND2 $T=261020 558320 0 0 $X=261020 $Y=557940
X893 41 1142 45 1 2 ND2 $T=268460 598640 1 180 $X=266600 $Y=598260
X894 1144 1119 1111 1 2 ND2 $T=269080 588560 0 180 $X=267220 $Y=583140
X895 41 1154 48 1 2 ND2 $T=272180 598640 1 180 $X=270320 $Y=598260
X896 1087 1158 1136 1 2 ND2 $T=272800 558320 1 0 $X=272800 $Y=552900
X897 56 1164 53 1 2 ND2 $T=279620 598640 0 180 $X=277760 $Y=593220
X898 1136 1167 1139 1 2 ND2 $T=282720 558320 1 180 $X=280860 $Y=557940
X899 56 1173 54 1 2 ND2 $T=280860 598640 0 0 $X=280860 $Y=598260
X900 1174 1150 1111 1 2 ND2 $T=281480 588560 1 0 $X=281480 $Y=583140
X901 1133 1178 1166 1 2 ND2 $T=282100 558320 1 0 $X=282100 $Y=552900
X902 1116 1184 1146 1 2 ND2 $T=284580 548240 0 180 $X=282720 $Y=542820
X903 1187 1189 1182 1 2 ND2 $T=285820 598640 1 180 $X=283960 $Y=598260
X904 1186 1192 1193 1 2 ND2 $T=284580 548240 0 0 $X=284580 $Y=547860
X905 1198 1195 1185 1 2 ND2 $T=286440 588560 1 180 $X=284580 $Y=588180
X906 1196 1187 1176 1 2 ND2 $T=286440 598640 0 180 $X=284580 $Y=593220
X907 1208 1200 62 1 2 ND2 $T=287060 518000 1 180 $X=285200 $Y=517620
X908 1189 1202 1203 1 2 ND2 $T=286440 598640 1 0 $X=286440 $Y=593220
X909 1201 1198 1212 1 2 ND2 $T=288300 588560 0 0 $X=288300 $Y=588180
X910 1207 1196 67 1 2 ND2 $T=288300 598640 0 0 $X=288300 $Y=598260
X911 1208 1213 70 1 2 ND2 $T=289540 518000 0 0 $X=289540 $Y=517620
X912 1202 1233 1227 1 2 ND2 $T=292640 538160 0 0 $X=292640 $Y=537780
X913 1237 1236 1233 1 2 ND2 $T=296360 538160 1 180 $X=294500 $Y=537780
X914 74 1210 1241 1 2 ND2 $T=294500 588560 0 0 $X=294500 $Y=588180
X915 1232 1237 1219 1 2 ND2 $T=296360 538160 0 0 $X=296360 $Y=537780
X916 1276 1273 1236 1 2 ND2 $T=307520 538160 1 180 $X=305660 $Y=537780
X917 1281 1275 86 1 2 ND2 $T=307520 598640 0 180 $X=305660 $Y=593220
X918 1195 1284 1267 1 2 ND2 $T=307520 528080 0 0 $X=307520 $Y=527700
X919 94 1214 64 1 2 ND2 $T=307520 588560 1 0 $X=307520 $Y=583140
X920 1281 1297 88 1 2 ND2 $T=310000 598640 0 180 $X=308140 $Y=593220
X921 88 1293 86 1 2 ND2 $T=310000 598640 1 180 $X=308140 $Y=598260
X922 1333 1305 1322 1 2 ND2 $T=315580 588560 0 0 $X=315580 $Y=588180
X923 101 1325 1321 1 2 ND2 $T=318680 598640 1 180 $X=316820 $Y=598260
X924 1328 1332 1327 1 2 ND2 $T=320540 548240 1 180 $X=318680 $Y=547860
X925 1301 1316 1341 1 2 ND2 $T=320540 538160 1 0 $X=320540 $Y=532740
X926 1306 1319 1343 1 2 ND2 $T=321160 528080 0 0 $X=321160 $Y=527700
X927 106 110 104 1 2 ND2 $T=323640 598640 0 180 $X=321780 $Y=593220
X928 1346 1340 1355 1 2 ND2 $T=323020 548240 1 0 $X=323020 $Y=542820
X929 111 1349 1321 1 2 ND2 $T=323640 598640 1 0 $X=323640 $Y=593220
X930 1349 1367 1365 1 2 ND2 $T=331700 598640 1 180 $X=329840 $Y=598260
X931 1372 1373 1271 1 2 ND2 $T=332940 558320 0 180 $X=331080 $Y=552900
X932 1377 1385 1280 1 2 ND2 $T=334800 558320 0 180 $X=332940 $Y=552900
X933 1331 1386 1387 1 2 ND2 $T=335420 548240 0 0 $X=335420 $Y=547860
X934 1367 1381 1384 1 2 ND2 $T=336040 528080 0 0 $X=336040 $Y=527700
X935 1381 1389 1392 1 2 ND2 $T=336660 538160 0 0 $X=336660 $Y=537780
X936 1385 1394 1373 1 2 ND2 $T=338520 558320 0 180 $X=336660 $Y=552900
X937 1402 1398 1396 1 2 ND2 $T=341000 558320 1 180 $X=339140 $Y=557940
X938 1404 1400 1383 1 2 ND2 $T=341620 538160 0 180 $X=339760 $Y=532740
X939 1342 1404 1392 1 2 ND2 $T=342240 538160 1 180 $X=340380 $Y=537780
X940 1396 1412 1397 1 2 ND2 $T=342240 558320 0 180 $X=340380 $Y=552900
X941 1390 1408 1387 1 2 ND2 $T=341000 548240 0 0 $X=341000 $Y=547860
X942 1408 1415 1331 1 2 ND2 $T=341620 548240 1 0 $X=341620 $Y=542820
X943 1393 1417 1414 1 2 ND2 $T=344720 538160 0 180 $X=342860 $Y=532740
X944 1407 1414 1413 1 2 ND2 $T=346580 538160 0 180 $X=344720 $Y=532740
X945 1430 1434 1423 1 2 ND2 $T=346580 538160 1 180 $X=344720 $Y=537780
X946 125 1429 124 1 2 ND2 $T=347200 598640 0 180 $X=345340 $Y=593220
X947 1438 1437 1434 1 2 ND2 $T=348440 538160 1 180 $X=346580 $Y=537780
X948 1444 1438 1422 1 2 ND2 $T=350300 538160 1 180 $X=348440 $Y=537780
X949 1418 1443 1441 1 2 ND2 $T=350920 548240 0 180 $X=349060 $Y=542820
X950 1445 1402 1426 1 2 ND2 $T=349680 558320 0 0 $X=349680 $Y=557940
X951 141 142 139 1 2 ND2 $T=356500 598640 1 180 $X=354640 $Y=598260
X952 1469 1464 1475 1 2 ND2 $T=358360 558320 1 0 $X=358360 $Y=552900
X953 148 1489 1450 1 2 ND2 $T=362700 598640 0 180 $X=360840 $Y=593220
X954 1468 1478 1485 1 2 ND2 $T=362700 538160 1 0 $X=362700 $Y=532740
X955 1481 1522 1511 1 2 ND2 $T=371380 548240 0 180 $X=369520 $Y=542820
X956 155 1519 1505 1 2 ND2 $T=370760 598640 1 0 $X=370760 $Y=593220
X957 1524 1527 1525 1 2 ND2 $T=371380 518000 1 0 $X=371380 $Y=512580
X958 1514 1524 1532 1 2 ND2 $T=371380 528080 1 0 $X=371380 $Y=522660
X959 1538 1529 1462 1 2 ND2 $T=375100 558320 0 180 $X=373240 $Y=552900
X960 1527 1559 1558 1 2 ND2 $T=376960 528080 1 0 $X=376960 $Y=522660
X961 1562 1538 1541 1 2 ND2 $T=378820 558320 1 0 $X=378820 $Y=552900
X962 1563 1566 1512 1 2 ND2 $T=379440 588560 0 0 $X=379440 $Y=588180
X963 1551 1563 1568 1 2 ND2 $T=380060 598640 1 0 $X=380060 $Y=593220
X964 1533 1593 1271 1 2 ND2 $T=389980 558320 1 180 $X=388120 $Y=557940
X965 1589 1525 1596 1 2 ND2 $T=389360 518000 0 0 $X=389360 $Y=517620
X966 1588 1598 1577 1 2 ND2 $T=391220 548240 1 180 $X=389360 $Y=547860
X967 1611 1605 1280 1 2 ND2 $T=391840 558320 1 180 $X=389980 $Y=557940
X968 1598 1602 1600 1 2 ND2 $T=393080 548240 0 180 $X=391220 $Y=542820
X969 1603 1596 1369 1 2 ND2 $T=391840 528080 1 0 $X=391840 $Y=522660
X970 1602 1608 1614 1 2 ND2 $T=392460 538160 0 0 $X=392460 $Y=537780
X971 1612 1592 1609 1 2 ND2 $T=394940 548240 0 180 $X=393080 $Y=542820
X972 1618 1609 1569 1 2 ND2 $T=395560 558320 0 180 $X=393700 $Y=552900
X973 1605 1616 1593 1 2 ND2 $T=395560 558320 1 180 $X=393700 $Y=557940
X974 167 1604 85 1 2 ND2 $T=394320 598640 0 0 $X=394320 $Y=598260
X975 1569 1621 1620 1 2 ND2 $T=395560 558320 1 0 $X=395560 $Y=552900
X976 1638 1618 1620 1 2 ND2 $T=399280 558320 0 180 $X=397420 $Y=552900
X977 1640 1635 1633 1 2 ND2 $T=401760 558320 1 180 $X=399900 $Y=557940
X978 1635 1646 1645 1 2 ND2 $T=401140 558320 1 0 $X=401140 $Y=552900
X979 1633 1643 1645 1 2 ND2 $T=401760 558320 0 0 $X=401760 $Y=557940
X980 1595 1649 1648 1 2 ND2 $T=402380 548240 1 0 $X=402380 $Y=542820
X981 1424 1666 177 1 2 ND2 $T=411680 528080 0 180 $X=409820 $Y=522660
X982 1675 1667 177 1 2 ND2 $T=414780 518000 0 180 $X=412920 $Y=512580
X983 1675 1670 1424 1 2 ND2 $T=418500 518000 1 180 $X=416640 $Y=517620
X984 1554 1688 1271 1 2 ND2 $T=418500 558320 0 180 $X=416640 $Y=552900
X985 1659 1697 1692 1 2 ND2 $T=419120 548240 1 0 $X=419120 $Y=542820
X986 1672 1683 1280 1 2 ND2 $T=420980 558320 1 180 $X=419120 $Y=557940
X987 184 1682 182 1 2 ND2 $T=421600 518000 0 180 $X=419740 $Y=512580
X988 182 1690 185 1 2 ND2 $T=421600 518000 1 0 $X=421600 $Y=512580
X989 1710 1714 1657 1 2 ND2 $T=424080 558320 0 180 $X=422220 $Y=552900
X990 1691 1712 1704 1 2 ND2 $T=424080 578480 1 180 $X=422220 $Y=578100
X991 1716 1709 1689 1 2 ND2 $T=424700 568400 0 180 $X=422840 $Y=562980
X992 1717 1724 1715 1 2 ND2 $T=427180 588560 1 180 $X=425320 $Y=588180
X993 1708 1700 1693 1 2 ND2 $T=426560 548240 0 0 $X=426560 $Y=547860
X994 1709 1718 1710 1 2 ND2 $T=426560 558320 0 0 $X=426560 $Y=557940
X995 194 1745 1732 1 2 ND2 $T=438960 598640 0 180 $X=437100 $Y=593220
X996 194 1757 1754 1 2 ND2 $T=447020 598640 0 0 $X=447020 $Y=598260
X997 213 1782 203 1 2 ND2 $T=461900 598640 0 0 $X=461900 $Y=598260
X998 1874 265 1856 1 2 ND2 $T=511500 518000 0 180 $X=509640 $Y=512580
X999 1922 1925 1924 1 2 ND2 $T=530720 518000 0 0 $X=530720 $Y=517620
X1000 332 1998 329 1 2 ND2 $T=578460 518000 1 0 $X=578460 $Y=512580
X1001 315 2024 2023 1 2 ND2 $T=588380 528080 0 0 $X=588380 $Y=527700
X1002 319 2027 2023 1 2 ND2 $T=590240 528080 1 0 $X=590240 $Y=522660
X1003 314 2031 2023 1 2 ND2 $T=592100 528080 0 0 $X=592100 $Y=527700
X1004 309 2036 2023 1 2 ND2 $T=593960 528080 1 0 $X=593960 $Y=522660
X1005 355 2037 2023 1 2 ND2 $T=595820 528080 0 0 $X=595820 $Y=527700
X1006 311 2041 2023 1 2 ND2 $T=599540 528080 0 180 $X=597680 $Y=522660
X1007 316 2043 2023 1 2 ND2 $T=598300 528080 0 0 $X=598300 $Y=527700
X1008 1841 2057 2023 1 2 ND2 $T=604500 528080 0 180 $X=602640 $Y=522660
X1009 2042 2064 367 1 2 ND2 $T=606980 518000 0 180 $X=605120 $Y=512580
X1010 1858 2082 2023 1 2 ND2 $T=611320 538160 1 0 $X=611320 $Y=532740
X1011 229 2081 2085 1 2 ND2 $T=611940 568400 0 0 $X=611940 $Y=568020
X1012 255 2083 2085 1 2 ND2 $T=613180 568400 1 0 $X=613180 $Y=562980
X1013 1819 2087 2085 1 2 ND2 $T=614420 558320 1 0 $X=614420 $Y=552900
X1014 2076 2089 393 1 2 ND2 $T=615040 528080 1 0 $X=615040 $Y=522660
X1015 398 2092 395 1 2 ND2 $T=618760 518000 0 180 $X=616900 $Y=512580
X1016 234 2095 2085 1 2 ND2 $T=620000 548240 0 0 $X=620000 $Y=547860
X1017 1844 2099 2085 1 2 ND2 $T=620620 568400 0 0 $X=620620 $Y=568020
X1018 2076 2084 402 1 2 ND2 $T=621240 528080 1 0 $X=621240 $Y=522660
X1019 1848 2117 2085 1 2 ND2 $T=629920 578480 1 0 $X=629920 $Y=573060
X1020 1849 2125 2085 1 2 ND2 $T=634260 568400 0 180 $X=632400 $Y=562980
X1021 419 431 426 1 2 ND2 $T=633640 518000 1 0 $X=633640 $Y=512580
X1022 482 2227 2161 1 2 ND2 $T=689440 598640 1 180 $X=687580 $Y=598260
X1023 446 385 2258 1 2 ND2 $T=711760 568400 0 180 $X=709900 $Y=562980
X1024 2309 2303 2313 1 2 ND2 $T=734080 568400 0 0 $X=734080 $Y=568020
X1025 2316 2327 2326 1 2 ND2 $T=735320 568400 1 0 $X=735320 $Y=562980
X1026 2318 2321 2331 1 2 ND2 $T=737800 528080 1 0 $X=737800 $Y=522660
X1027 2337 2325 2345 1 2 ND2 $T=742140 538160 0 0 $X=742140 $Y=537780
X1028 2338 2333 586 1 2 ND2 $T=742140 588560 1 0 $X=742140 $Y=583140
X1029 2344 2315 2345 1 2 ND2 $T=743380 528080 0 0 $X=743380 $Y=527700
X1030 2338 2330 2351 1 2 ND2 $T=744000 578480 0 0 $X=744000 $Y=578100
X1031 2356 2355 2350 1 2 ND2 $T=746480 568400 1 180 $X=744620 $Y=568020
X1032 2354 2346 2342 1 2 ND2 $T=747100 558320 0 180 $X=745240 $Y=552900
X1033 2365 2360 2372 1 2 ND2 $T=748960 548240 1 0 $X=748960 $Y=542820
X1034 2367 2349 590 1 2 ND2 $T=749580 578480 0 0 $X=749580 $Y=578100
X1035 2356 2371 2349 1 2 ND2 $T=752060 578480 0 180 $X=750200 $Y=573060
X1036 2371 2377 2350 1 2 ND2 $T=752680 568400 0 180 $X=750820 $Y=562980
X1037 2369 2378 2379 1 2 ND2 $T=751440 568400 0 0 $X=751440 $Y=568020
X1038 2347 2362 2387 1 2 ND2 $T=752060 518000 0 0 $X=752060 $Y=517620
X1039 2377 2352 2378 1 2 ND2 $T=752680 558320 0 0 $X=752680 $Y=557940
X1040 596 2363 597 1 2 ND2 $T=754540 518000 1 0 $X=754540 $Y=512580
X1041 2391 2361 2396 1 2 ND2 $T=755780 568400 1 0 $X=755780 $Y=562980
X1042 2393 2385 2396 1 2 ND2 $T=757020 558320 1 0 $X=757020 $Y=552900
X1043 2408 2407 599 1 2 ND2 $T=761360 568400 0 0 $X=761360 $Y=568020
X1044 2415 2419 2425 1 2 ND2 $T=763840 548240 0 0 $X=763840 $Y=547860
X1045 2428 604 2419 1 2 ND2 $T=766320 548240 0 180 $X=764460 $Y=542820
X1046 605 2418 606 1 2 ND2 $T=765080 518000 1 0 $X=765080 $Y=512580
X1047 606 2404 589 1 2 ND2 $T=765700 518000 0 0 $X=765700 $Y=517620
X1048 2429 2417 2437 1 2 ND2 $T=765700 568400 1 0 $X=765700 $Y=562980
X1049 2435 2405 2439 1 2 ND2 $T=766940 558320 0 0 $X=766940 $Y=557940
X1050 612 2409 589 1 2 ND2 $T=769420 518000 0 180 $X=767560 $Y=512580
X1051 2451 2428 2435 1 2 ND2 $T=770660 548240 1 180 $X=768800 $Y=547860
X1052 2444 2429 2449 1 2 ND2 $T=768800 568400 1 0 $X=768800 $Y=562980
X1053 2443 2460 2438 1 2 ND2 $T=771900 538160 1 180 $X=770040 $Y=537780
X1054 2450 2444 613 1 2 ND2 $T=770660 568400 0 0 $X=770660 $Y=568020
X1055 2453 2455 601 1 2 ND2 $T=771280 558320 1 0 $X=771280 $Y=552900
X1056 2476 2481 2484 1 2 ND2 $T=778100 558320 1 0 $X=778100 $Y=552900
X1057 2501 2483 624 1 2 ND2 $T=783060 568400 0 0 $X=783060 $Y=568020
X1058 2531 2521 2529 1 2 ND2 $T=791740 558320 0 0 $X=791740 $Y=557940
X1059 2539 2529 2532 1 2 ND2 $T=793600 568400 1 180 $X=791740 $Y=568020
X1060 633 2528 2538 1 2 ND2 $T=793600 568400 0 0 $X=793600 $Y=568020
X1061 636 2569 2552 1 2 ND2 $T=802900 578480 0 180 $X=801040 $Y=573060
X1062 2569 2568 2557 1 2 ND2 $T=802900 578480 1 0 $X=802900 $Y=573060
X1063 2571 2581 648 1 2 ND2 $T=806620 568400 1 0 $X=806620 $Y=562980
X1064 2580 2587 648 1 2 ND2 $T=807860 578480 1 0 $X=807860 $Y=573060
X1065 2571 2579 2580 1 2 ND2 $T=808480 568400 0 0 $X=808480 $Y=568020
X1066 2604 2595 2603 1 2 ND2 $T=812200 568400 1 0 $X=812200 $Y=562980
X1067 2608 2612 652 1 2 ND2 $T=816540 568400 0 180 $X=814680 $Y=562980
X1068 2627 2620 2603 1 2 ND2 $T=819020 558320 1 0 $X=819020 $Y=552900
X1069 2631 2588 2643 1 2 ND2 $T=822740 558320 1 0 $X=822740 $Y=552900
X1070 2652 2594 2651 1 2 ND2 $T=827700 558320 1 0 $X=827700 $Y=552900
X1071 2654 2665 2651 1 2 ND2 $T=829560 558320 0 0 $X=829560 $Y=557940
X1072 2675 2651 2683 1 2 ND2 $T=833280 568400 1 0 $X=833280 $Y=562980
X1073 2660 2684 684 1 2 ND2 $T=835760 548240 1 180 $X=833900 $Y=547860
X1074 2677 2695 2689 1 2 ND2 $T=837000 548240 0 0 $X=837000 $Y=547860
X1075 2684 2686 2699 1 2 ND2 $T=838860 538160 0 0 $X=838860 $Y=537780
X1076 2710 2702 2688 1 2 ND2 $T=843200 558320 1 0 $X=843200 $Y=552900
X1077 2697 2682 2723 1 2 ND2 $T=844440 528080 0 0 $X=844440 $Y=527700
X1078 2734 2729 2719 1 2 ND2 $T=846920 538160 1 180 $X=845060 $Y=537780
X1079 697 2730 2717 1 2 ND2 $T=846920 598640 0 0 $X=846920 $Y=598260
X1080 2728 2740 2639 1 2 ND2 $T=848780 568400 1 0 $X=848780 $Y=562980
X1081 2749 2752 2747 1 2 ND2 $T=851880 548240 0 0 $X=851880 $Y=547860
X1082 2736 2776 2760 1 2 ND2 $T=855600 538160 1 180 $X=853740 $Y=537780
X1083 699 2759 2772 1 2 ND2 $T=854360 548240 1 0 $X=854360 $Y=542820
X1084 2722 2775 2332 1 2 ND2 $T=856220 588560 0 180 $X=854360 $Y=583140
X1085 2770 2747 2778 1 2 ND2 $T=855600 558320 0 0 $X=855600 $Y=557940
X1086 2789 2783 2775 1 2 ND2 $T=858080 588560 0 180 $X=856220 $Y=583140
X1087 2774 2770 2785 1 2 ND2 $T=856840 558320 1 0 $X=856840 $Y=552900
X1088 687 2780 659 1 2 ND2 $T=861180 538160 0 180 $X=859320 $Y=532740
X1089 2765 2789 2639 1 2 ND2 $T=861800 588560 0 180 $X=859940 $Y=583140
X1090 2798 2811 715 1 2 ND2 $T=866140 568400 1 0 $X=866140 $Y=562980
X1091 2814 2802 2808 1 2 ND2 $T=870480 558320 1 180 $X=868620 $Y=557940
X1092 2812 2832 2814 1 2 ND2 $T=871100 558320 0 180 $X=869240 $Y=552900
X1093 2753 2831 662 1 2 ND2 $T=873580 518000 1 180 $X=871720 $Y=517620
X1094 2806 2829 2818 1 2 ND2 $T=872340 558320 0 0 $X=872340 $Y=557940
X1095 2846 2848 2831 1 2 ND2 $T=876680 518000 1 180 $X=874820 $Y=517620
X1096 2783 2845 727 1 2 ND2 $T=877300 568400 1 180 $X=875440 $Y=568020
X1097 2786 2852 669 1 2 ND2 $T=877920 558320 0 180 $X=876060 $Y=552900
X1098 2855 2846 712 1 2 ND2 $T=878540 518000 1 180 $X=876680 $Y=517620
X1099 2850 2860 2857 1 2 ND2 $T=877300 568400 0 0 $X=877300 $Y=568020
X1100 2859 2861 712 1 2 ND2 $T=879780 558320 0 180 $X=877920 $Y=552900
X1101 2854 2875 740 1 2 ND2 $T=883500 518000 1 180 $X=881640 $Y=517620
X1102 2881 2877 2873 1 2 ND2 $T=884740 598640 0 180 $X=882880 $Y=593220
X1103 2875 2883 745 1 2 ND2 $T=883500 518000 1 0 $X=883500 $Y=512580
X1104 2865 2886 2882 1 2 ND2 $T=886600 518000 1 180 $X=884740 $Y=517620
X1105 2889 2890 2885 1 2 ND2 $T=887220 558320 0 180 $X=885360 $Y=552900
X1106 2872 2894 2885 1 2 ND2 $T=888460 558320 1 180 $X=886600 $Y=557940
X1107 2905 2912 2888 1 2 ND2 $T=890320 528080 0 180 $X=888460 $Y=522660
X1108 2889 2903 2917 1 2 ND2 $T=892180 558320 1 0 $X=892180 $Y=552900
X1109 753 2892 2873 1 2 ND2 $T=892180 588560 0 0 $X=892180 $Y=588180
X1110 2910 756 2883 1 2 ND2 $T=892800 518000 1 0 $X=892800 $Y=512580
X1111 2887 2907 2921 1 2 ND2 $T=893420 578480 1 0 $X=893420 $Y=573060
X1112 760 2901 2920 1 2 ND2 $T=895280 598640 1 180 $X=893420 $Y=598260
X1113 2932 2906 2919 1 2 ND2 $T=897140 548240 1 180 $X=895280 $Y=547860
X1114 2923 2926 2905 1 2 ND2 $T=895900 538160 1 0 $X=895900 $Y=532740
X1115 2932 2913 2925 1 2 ND2 $T=897140 548240 0 0 $X=897140 $Y=547860
X1116 2919 2915 2925 1 2 ND2 $T=897760 538160 0 0 $X=897760 $Y=537780
X1117 2936 2939 757 1 2 ND2 $T=899620 588560 0 0 $X=899620 $Y=588180
X1118 2923 2924 2888 1 2 ND2 $T=900860 528080 1 0 $X=900860 $Y=522660
X1119 2874 766 768 1 2 ND2 $T=902720 598640 0 0 $X=902720 $Y=598260
X1120 2954 2944 2928 1 2 ND2 $T=907060 548240 1 180 $X=905200 $Y=547860
X1121 2965 2963 2972 1 2 ND2 $T=909540 518000 0 0 $X=909540 $Y=517620
X1122 2928 2952 2934 1 2 ND2 $T=909540 558320 1 0 $X=909540 $Y=552900
X1123 2955 2972 771 1 2 ND2 $T=913260 518000 1 180 $X=911400 $Y=517620
X1124 2954 2947 2934 1 2 ND2 $T=914500 558320 0 180 $X=912640 $Y=552900
X1125 2979 2982 2985 1 2 ND2 $T=915740 528080 1 0 $X=915740 $Y=522660
X1126 2989 2985 2986 1 2 ND2 $T=919460 528080 0 180 $X=917600 $Y=522660
X1127 780 2995 782 1 2 ND2 $T=921940 518000 1 0 $X=921940 $Y=512580
X1128 790 2999 3016 1 2 ND2 $T=927520 568400 0 0 $X=927520 $Y=568020
X1129 3040 3041 3039 1 2 ND2 $T=938680 558320 0 0 $X=938680 $Y=557940
X1130 3041 805 3045 1 2 ND2 $T=938680 568400 1 0 $X=938680 $Y=562980
X1131 3054 3056 3034 1 2 ND2 $T=943640 558320 0 180 $X=941780 $Y=552900
X1132 3060 3047 809 1 2 ND2 $T=943640 558320 1 0 $X=943640 $Y=552900
X1133 3099 3096 819 1 2 ND2 $T=956040 578480 1 0 $X=956040 $Y=573060
X1134 3112 3132 826 1 2 ND2 $T=965960 568400 0 180 $X=964100 $Y=562980
X1135 3133 3142 3149 1 2 ND2 $T=969060 558320 1 0 $X=969060 $Y=552900
X1136 3177 3173 3172 1 2 ND2 $T=978980 568400 0 180 $X=977120 $Y=562980
X1137 3173 844 3174 1 2 ND2 $T=979600 568400 1 180 $X=977740 $Y=568020
X1138 3185 3169 3191 1 2 ND2 $T=980840 558320 0 0 $X=980840 $Y=557940
X1139 687 3215 659 1 2 ND2 $T=988280 548240 0 180 $X=986420 $Y=542820
X1140 3186 3210 3172 1 2 ND2 $T=988280 578480 0 180 $X=986420 $Y=573060
X1141 3233 3230 859 1 2 ND2 $T=996960 568400 0 180 $X=995100 $Y=562980
X1142 3230 3234 3238 1 2 ND2 $T=996340 568400 0 0 $X=996340 $Y=568020
X1143 3240 3235 3221 1 2 ND2 $T=998820 568400 0 180 $X=996960 $Y=562980
X1144 3239 3249 3238 1 2 ND2 $T=998200 558320 0 0 $X=998200 $Y=557940
X1145 3241 3221 861 1 2 ND2 $T=998200 578480 1 0 $X=998200 $Y=573060
X1146 3240 3227 3243 1 2 ND2 $T=1000680 568400 0 180 $X=998820 $Y=562980
X1147 880 3286 3278 1 2 ND2 $T=1016180 558320 1 180 $X=1014320 $Y=557940
X1148 3304 3293 880 1 2 ND2 $T=1021140 558320 1 180 $X=1019280 $Y=557940
X1149 3282 3290 3278 1 2 ND2 $T=1021140 568400 0 0 $X=1021140 $Y=568020
X1150 3292 3322 669 1 2 ND2 $T=1027340 548240 0 0 $X=1027340 $Y=547860
X1151 3328 3327 3315 1 2 ND2 $T=1030440 578480 0 0 $X=1030440 $Y=578100
X1152 893 3324 3315 1 2 ND2 $T=1034780 568400 1 180 $X=1032920 $Y=568020
X1153 3337 3331 893 1 2 ND2 $T=1032920 578480 1 0 $X=1032920 $Y=573060
X1154 3346 3347 3341 1 2 ND2 $T=1036640 578480 0 180 $X=1034780 $Y=573060
X1155 3345 3346 3353 1 2 ND2 $T=1036020 568400 0 0 $X=1036020 $Y=568020
X1156 3341 3351 896 1 2 ND2 $T=1038500 578480 0 180 $X=1036640 $Y=573060
X1157 3347 3359 896 1 2 ND2 $T=1040360 568400 1 0 $X=1040360 $Y=562980
X1158 3349 3372 3368 1 2 ND2 $T=1045940 548240 1 180 $X=1044080 $Y=547860
X1159 3349 3375 3362 1 2 ND2 $T=1047180 548240 0 0 $X=1047180 $Y=547860
X1160 3394 3385 3370 1 2 ND2 $T=1051520 538160 0 180 $X=1049660 $Y=532740
X1161 3396 3395 3388 1 2 ND2 $T=1050900 588560 0 0 $X=1050900 $Y=588180
X1162 3380 3404 3397 1 2 ND2 $T=1053380 538160 0 180 $X=1051520 $Y=532740
X1163 3390 3403 3386 1 2 ND2 $T=1054000 558320 0 180 $X=1052140 $Y=552900
X1164 3396 3392 907 1 2 ND2 $T=1053380 578480 0 0 $X=1053380 $Y=578100
X1165 3352 3399 3353 1 2 ND2 $T=1054000 578480 1 0 $X=1054000 $Y=573060
X1166 3414 3415 3402 1 2 ND2 $T=1057720 588560 0 180 $X=1055860 $Y=583140
X1167 3412 3419 3348 1 2 ND2 $T=1058340 548240 0 180 $X=1056480 $Y=542820
X1168 3408 3414 912 1 2 ND2 $T=1057720 588560 1 0 $X=1057720 $Y=583140
X1169 3415 3426 3417 1 2 ND2 $T=1059580 598640 0 180 $X=1057720 $Y=593220
X1170 3418 3442 3401 1 2 ND2 $T=1058960 528080 0 0 $X=1058960 $Y=527700
X1171 3444 3438 3424 1 2 ND2 $T=1063920 578480 0 180 $X=1062060 $Y=573060
X1172 3438 3446 3387 1 2 ND2 $T=1064540 568400 1 180 $X=1062680 $Y=568020
X1173 3411 3444 3435 1 2 ND2 $T=1063300 578480 0 0 $X=1063300 $Y=578100
X1174 3416 3431 3449 1 2 ND2 $T=1063300 598640 0 0 $X=1063300 $Y=598260
X1175 3459 3460 3445 1 2 ND2 $T=1070120 528080 0 180 $X=1068260 $Y=522660
X1176 3466 3454 3472 1 2 ND2 $T=1070120 568400 0 0 $X=1070120 $Y=568020
X1177 3432 3481 3461 1 2 ND2 $T=1075700 548240 0 0 $X=1075700 $Y=547860
X1178 933 3465 3472 1 2 ND2 $T=1080040 568400 0 180 $X=1078180 $Y=562980
X1179 3466 3456 933 1 2 ND2 $T=1086240 568400 1 0 $X=1086240 $Y=562980
X1180 1949 1959 1895 1 2 1977 AO12 $T=558000 568400 1 0 $X=558000 $Y=562980
X1181 1949 1963 1895 1 2 1976 AO12 $T=559240 558320 1 0 $X=559240 $Y=552900
X1182 1949 1951 1895 1 2 1985 AO12 $T=562340 548240 0 0 $X=562340 $Y=547860
X1183 1949 1973 1895 1 2 1986 AO12 $T=567920 558320 0 0 $X=567920 $Y=557940
X1184 1949 1900 1895 1 2 1992 AO12 $T=571020 538160 0 0 $X=571020 $Y=537780
X1185 1949 1928 1895 1 2 1997 AO12 $T=574120 548240 1 0 $X=574120 $Y=542820
X1186 1949 1969 1895 1 2 2006 AO12 $T=575980 548240 0 0 $X=575980 $Y=547860
X1187 1949 1884 1895 1 2 2008 AO12 $T=576600 538160 0 0 $X=576600 $Y=537780
X1188 1949 1887 1895 1 2 2011 AO12 $T=579700 548240 1 0 $X=579700 $Y=542820
X1189 1949 1907 1895 1 2 2012 AO12 $T=581560 548240 0 0 $X=581560 $Y=547860
X1190 511 2063 374 1 2 516 AO12 $T=687580 578480 0 0 $X=687580 $Y=578100
X1191 2063 547 548 1 2 551 AO12 $T=709280 558320 1 0 $X=709280 $Y=552900
X1192 2063 552 534 1 2 554 AO12 $T=713000 588560 1 0 $X=713000 $Y=583140
X1193 2063 556 549 1 2 562 AO12 $T=716720 588560 1 0 $X=716720 $Y=583140
X1194 16 1059 1029 2 1 ND2S $T=239320 528080 0 0 $X=239320 $Y=527700
X1195 54 1168 53 2 1 ND2S $T=280860 598640 1 180 $X=279000 $Y=598260
X1196 1210 1201 1217 2 1 ND2S $T=288920 588560 1 0 $X=288920 $Y=583140
X1197 71 1217 1218 2 1 ND2S $T=292020 588560 1 180 $X=290160 $Y=588180
X1198 1249 1185 1262 2 1 ND2S $T=298220 578480 0 0 $X=298220 $Y=578100
X1199 1318 1322 1326 2 1 ND2S $T=317440 588560 0 0 $X=317440 $Y=588180
X1200 1307 1266 1188 2 1 ND2S $T=318060 518000 0 0 $X=318060 $Y=517620
X1201 102 1333 105 2 1 ND2S $T=319300 588560 0 0 $X=319300 $Y=588180
X1202 1389 1393 1347 2 1 ND2S $T=338520 538160 0 0 $X=338520 $Y=537780
X1203 1397 1409 1398 2 1 ND2S $T=341000 558320 0 0 $X=341000 $Y=557940
X1204 1435 1390 1394 2 1 ND2S $T=347200 548240 1 0 $X=347200 $Y=542820
X1205 157 1530 158 2 1 ND2S $T=373240 598640 0 0 $X=373240 $Y=598260
X1206 1549 1562 1564 2 1 ND2S $T=382540 558320 0 0 $X=382540 $Y=557940
X1207 1576 1568 163 2 1 ND2S $T=385640 598640 1 0 $X=385640 $Y=593220
X1208 1613 1612 1607 2 1 ND2S $T=394320 548240 1 180 $X=392460 $Y=547860
X1209 1622 1614 1586 2 1 ND2S $T=396180 538160 1 180 $X=394320 $Y=537780
X1210 1623 1638 1617 2 1 ND2S $T=399280 558320 1 0 $X=399280 $Y=552900
X1211 1627 1637 1617 2 1 ND2S $T=402380 548240 0 180 $X=400520 $Y=542820
X1212 1647 1640 1616 2 1 ND2S $T=403620 568400 0 180 $X=401760 $Y=562980
X1213 1671 1678 1676 2 1 ND2S $T=412920 588560 0 0 $X=412920 $Y=588180
X1214 2017 2093 399 2 1 ND2S $T=622480 568400 0 0 $X=622480 $Y=568020
X1215 1897 2055 399 2 1 ND2S $T=623100 528080 1 0 $X=623100 $Y=522660
X1216 446 546 2257 2 1 ND2S $T=709900 568400 0 180 $X=708040 $Y=562980
X1217 550 510 2258 2 1 ND2S $T=712380 588560 1 180 $X=710520 $Y=588180
X1218 2275 2278 446 2 1 ND2S $T=721060 548240 0 0 $X=721060 $Y=547860
X1219 2322 2328 2348 2 1 ND2S $T=740280 538160 0 0 $X=740280 $Y=537780
X1220 2351 2324 586 2 1 ND2S $T=745240 588560 1 180 $X=743380 $Y=588180
X1221 2390 2392 2395 2 1 ND2S $T=756400 558320 0 0 $X=756400 $Y=557940
X1222 2391 2393 2407 2 1 ND2S $T=758880 568400 1 0 $X=758880 $Y=562980
X1223 2416 2422 601 2 1 ND2S $T=768800 558320 1 0 $X=768800 $Y=552900
X1224 2455 2451 2439 2 1 ND2S $T=771900 548240 0 0 $X=771900 $Y=547860
X1225 2524 2484 2528 2 1 ND2S $T=788640 568400 1 0 $X=788640 $Y=562980
X1226 2522 2524 2529 2 1 ND2S $T=789880 558320 0 0 $X=789880 $Y=557940
X1227 2530 2517 2537 2 1 ND2S $T=791740 558320 1 0 $X=791740 $Y=552900
X1228 2609 2610 2606 2 1 ND2S $T=815300 558320 0 180 $X=813440 $Y=552900
X1229 2628 2627 2604 2 1 ND2S $T=820260 568400 0 180 $X=818400 $Y=562980
X1230 2637 2628 652 2 1 ND2S $T=821500 568400 1 180 $X=819640 $Y=568020
X1231 667 2653 2642 2 1 ND2S $T=827700 558320 1 180 $X=825840 $Y=557940
X1232 2653 2652 2654 2 1 ND2S $T=827700 558320 0 0 $X=827700 $Y=557940
X1233 2685 2675 2688 2 1 ND2S $T=836380 568400 1 0 $X=836380 $Y=562980
X1234 2667 2697 2692 2 1 ND2S $T=840720 538160 0 180 $X=838860 $Y=532740
X1235 688 2708 2673 2 1 ND2S $T=843200 558320 1 180 $X=841340 $Y=557940
X1236 2731 2723 2520 2 1 ND2S $T=847540 538160 0 180 $X=845680 $Y=532740
X1237 2736 2719 660 2 1 ND2S $T=848780 538160 1 180 $X=846920 $Y=537780
X1238 2725 2741 2743 2 1 ND2S $T=848160 548240 0 0 $X=848160 $Y=547860
X1239 2739 2733 2747 2 1 ND2S $T=848780 558320 0 0 $X=848780 $Y=557940
X1240 2779 2778 707 2 1 ND2S $T=857460 558320 0 0 $X=857460 $Y=557940
X1241 2808 2812 2811 2 1 ND2S $T=868620 558320 1 180 $X=866760 $Y=557940
X1242 2867 2866 2853 2 1 ND2S $T=881640 578480 1 180 $X=879780 $Y=578100
X1243 742 2854 2868 2 1 ND2S $T=883500 518000 0 180 $X=881640 $Y=512580
X1244 735 2891 2868 2 1 ND2S $T=887220 518000 0 180 $X=885360 $Y=512580
X1245 2896 2910 2879 2 1 ND2S $T=892800 518000 0 180 $X=890940 $Y=512580
X1246 2927 2931 761 2 1 ND2S $T=897140 598640 1 180 $X=895280 $Y=598260
X1247 2983 2978 2988 2 1 ND2S $T=916360 598640 1 0 $X=916360 $Y=593220
X1248 3047 3040 3054 2 1 ND2S $T=940540 558320 0 0 $X=940540 $Y=557940
X1249 3048 3045 3055 2 1 ND2S $T=940540 568400 1 0 $X=940540 $Y=562980
X1250 3064 3053 3071 2 1 ND2S $T=944260 538160 0 0 $X=944260 $Y=537780
X1251 3123 3127 3129 2 1 ND2S $T=962240 568400 1 0 $X=962240 $Y=562980
X1252 3132 3133 3111 2 1 ND2S $T=965340 558320 0 180 $X=963480 $Y=552900
X1253 3165 3166 841 2 1 ND2S $T=975260 568400 1 0 $X=975260 $Y=562980
X1254 3181 3174 3183 2 1 ND2S $T=978980 578480 1 0 $X=978980 $Y=573060
X1255 3186 3177 3192 2 1 ND2S $T=980840 578480 1 0 $X=980840 $Y=573060
X1256 3160 3192 848 2 1 ND2S $T=982700 568400 1 0 $X=982700 $Y=562980
X1257 3195 3202 848 2 1 ND2S $T=984560 568400 1 0 $X=984560 $Y=562980
X1258 3368 3367 3362 2 1 ND2S $T=1044080 548240 0 180 $X=1042220 $Y=542820
X1259 3381 3387 3351 2 1 ND2S $T=1050280 578480 0 180 $X=1048420 $Y=573060
X1260 907 3384 3388 2 1 ND2S $T=1050900 588560 1 180 $X=1049040 $Y=588180
X1261 3428 3425 3421 2 1 ND2S $T=1060200 588560 1 180 $X=1058340 $Y=588180
X1262 3446 3391 3451 2 1 ND2S $T=1064540 568400 0 0 $X=1064540 $Y=568020
X1263 3452 3451 3448 2 1 ND2S $T=1067020 578480 1 180 $X=1065160 $Y=578100
X1264 1222 1250 1 1204 1254 2 1257 1243 1232 OAI222S $T=297600 538160 1 0 $X=297600 $Y=532740
X1265 1270 1276 1 1265 1282 2 1289 1290 1294 OAI222S $T=305660 538160 1 0 $X=305660 $Y=532740
X1266 1547 1 1550 1544 1528 1505 2 OAI22S $T=378200 598640 0 180 $X=374480 $Y=593220
X1267 482 1 472 2174 2163 2179 2 OAI22S $T=665260 598640 1 0 $X=665260 $Y=593220
X1268 1426 1419 2 1440 1 1432 AOI12HS $T=345960 558320 1 0 $X=345960 $Y=552900
X1269 1475 1469 2 1476 1 1480 AOI12HS $T=364560 558320 0 180 $X=360220 $Y=552900
X1270 1475 1467 2 1500 1 1495 AOI12HS $T=363940 548240 0 0 $X=363940 $Y=547860
X1271 158 157 2 1555 1 1550 AOI12HS $T=381920 598640 1 180 $X=377580 $Y=598260
X1272 1689 1729 2 1742 1 1723 AOI12HS $T=436480 558320 1 0 $X=436480 $Y=552900
X1273 624 2507 2 2510 1 2495 AOI12HS $T=783680 558320 0 0 $X=783680 $Y=557940
X1274 841 3165 2 3197 1 3204 AOI12HS $T=988280 558320 1 180 $X=983940 $Y=557940
X1275 1394 1431 1431 1394 2 1 1433 MAOI1 $T=351540 548240 1 180 $X=346580 $Y=547860
X1276 1564 1552 1552 1564 2 1 1516 MAOI1 $T=380680 548240 0 0 $X=380680 $Y=547860
X1277 1616 1662 1662 1616 2 1 1663 MAOI1 $T=410440 558320 1 0 $X=410440 $Y=552900
X1278 1224 1215 1 1181 2 1203 OAI12HS $T=292020 598640 0 180 $X=288300 $Y=593220
X1279 1303 1345 1 1330 2 1370 OAI12HS $T=326120 538160 1 0 $X=326120 $Y=532740
X1280 128 129 1 130 2 1416 OAI12HS $T=339760 598640 1 0 $X=339760 $Y=593220
X1281 1433 1331 1 1415 2 1371 OAI12HS $T=347200 548240 0 180 $X=343480 $Y=542820
X1282 1432 1397 1 1409 2 1418 OAI12HS $T=345960 558320 0 0 $X=345960 $Y=557940
X1283 1446 1452 1 1425 2 1444 OAI12HS $T=350920 548240 1 0 $X=350920 $Y=542820
X1284 1450 1483 1 1489 2 1473 OAI12HS $T=362080 598640 0 0 $X=362080 $Y=598260
X1285 1462 1516 1 1529 2 1511 OAI12HS $T=369520 558320 1 0 $X=369520 $Y=552900
X1286 1573 1570 1 1566 2 1567 OAI12HS $T=385020 588560 1 180 $X=381300 $Y=588180
X1287 1617 1627 1 1637 2 1613 OAI12HS $T=399280 548240 0 0 $X=399280 $Y=547860
X1288 1645 1663 1 1646 2 1648 OAI12HS $T=406720 558320 1 0 $X=406720 $Y=552900
X1289 2295 446 1 2278 2 2265 OAI12HS $T=721060 548240 1 180 $X=717340 $Y=547860
X1290 2335 2339 1 2344 2 2337 OAI12HS $T=741520 528080 1 0 $X=741520 $Y=522660
X1291 2387 2347 1 2399 2 2368 OAI12HS $T=756400 518000 1 0 $X=756400 $Y=512580
X1292 601 2416 1 2422 2 2415 OAI12HS $T=762600 558320 1 0 $X=762600 $Y=552900
X1293 2545 2548 1 2522 2 2531 OAI12HS $T=798560 558320 0 180 $X=794840 $Y=552900
X1294 652 2608 1 2612 2 2609 OAI12HS $T=819640 558320 1 180 $X=815920 $Y=557940
X1295 2751 2693 1 2740 2 2779 OAI12HS $T=851880 568400 1 0 $X=851880 $Y=562980
X1296 2868 735 1 2891 2 2896 OAI12HS $T=887220 518000 1 0 $X=887220 $Y=512580
X1297 760 2920 1 2901 2 2936 OAI12HS $T=899000 598640 1 0 $X=899000 $Y=593220
X1298 771 2955 1 2972 2 2975 OAI12HS $T=915740 528080 0 180 $X=912020 $Y=522660
X1299 819 3099 1 3096 2 3102 OAI12HS $T=958520 568400 1 180 $X=954800 $Y=568020
X1300 826 3104 1 3116 2 3123 OAI12HS $T=964720 558320 1 180 $X=961000 $Y=557940
X1301 848 3195 1 3202 2 3181 OAI12HS $T=982080 568400 0 0 $X=982080 $Y=568020
X1302 3353 3352 1 3399 2 3369 OAI12HS $T=1050280 578480 1 0 $X=1050280 $Y=573060
X1303 2216 374 496 2215 488 503 1 2 514 AO222 $T=684480 518000 0 0 $X=684480 $Y=517620
X1304 1135 1138 1 2 INV2 $T=269700 588560 1 180 $X=267840 $Y=588180
X1305 1144 1132 1 2 INV2 $T=269080 588560 1 0 $X=269080 $Y=583140
X1306 1148 1143 1 2 INV2 $T=278380 568400 1 180 $X=276520 $Y=568020
X1307 1131 1170 1 2 INV2 $T=285200 578480 0 0 $X=285200 $Y=578100
X1308 1240 1169 1 2 INV2 $T=296360 588560 0 180 $X=294500 $Y=583140
X1309 1295 1221 1 2 INV2 $T=311240 578480 0 180 $X=309380 $Y=573060
X1310 250 251 1 2 INV2 $T=492900 598640 0 0 $X=492900 $Y=598260
X1311 1942 287 1 2 INV2 $T=538780 598640 0 180 $X=536920 $Y=593220
X1312 1945 303 1 2 INV2 $T=549940 588560 1 0 $X=549940 $Y=583140
X1313 2009 340 1 2 INV2 $T=581560 578480 1 180 $X=579700 $Y=578100
X1314 2538 2545 1 2 INV2 $T=795460 568400 0 0 $X=795460 $Y=568020
X1315 2562 639 1 2 INV2 $T=801660 558320 1 180 $X=799800 $Y=557940
X1316 2634 2691 1 2 INV2 $T=836380 588560 0 0 $X=836380 $Y=588180
X1317 686 690 1 2 INV2 $T=840100 598640 0 0 $X=840100 $Y=598260
X1318 2686 2701 1 2 INV2 $T=840720 538160 0 0 $X=840720 $Y=537780
X1319 2694 2738 1 2 INV2 $T=848160 598640 1 0 $X=848160 $Y=593220
X1320 2759 2736 1 2 INV2 $T=853740 538160 1 180 $X=851880 $Y=537780
X1321 2774 2773 1 2 INV2 $T=856840 548240 1 180 $X=854980 $Y=547860
X1322 2768 2799 1 2 INV2 $T=859320 588560 0 0 $X=859320 $Y=588180
X1323 585 2639 1 2 INV2 $T=859320 598640 1 0 $X=859320 $Y=593220
X1324 660 2760 1 2 INV2 $T=866760 548240 1 0 $X=866760 $Y=542820
X1325 2763 2823 1 2 INV2 $T=868620 528080 0 0 $X=868620 $Y=527700
X1326 2750 2813 1 2 INV2 $T=869240 588560 0 0 $X=869240 $Y=588180
X1327 2788 2834 1 2 INV2 $T=871720 538160 0 0 $X=871720 $Y=537780
X1328 2907 2898 1 2 INV2 $T=891560 568400 1 180 $X=889700 $Y=568020
X1329 2856 2920 1 2 INV2 $T=897140 598640 0 0 $X=897140 $Y=598260
X1330 2916 2935 1 2 INV2 $T=899000 548240 0 0 $X=899000 $Y=547860
X1331 3244 3261 1 2 INV2 $T=1005020 558320 1 0 $X=1005020 $Y=552900
X1332 3237 3276 1 2 INV2 $T=1009980 538160 0 0 $X=1009980 $Y=537780
X1333 889 3326 1 2 INV2 $T=1027340 598640 0 0 $X=1027340 $Y=598260
X1334 1144 2 1138 1 1147 NR2P $T=272180 578480 0 0 $X=272180 $Y=578100
X1335 1214 2 1229 1 1148 NR2P $T=293260 578480 1 0 $X=293260 $Y=573060
X1336 103 2 100 1 1318 NR2P $T=318060 598640 1 0 $X=318060 $Y=593220
X1337 103 2 118 1 1364 NR2P $T=329840 598640 1 0 $X=329840 $Y=593220
X1338 466 2 517 1 2063 NR2P $T=691300 578480 0 0 $X=691300 $Y=578100
X1339 679 2 673 1 664 NR2P $T=830180 588560 0 0 $X=830180 $Y=588180
X1340 2762 2 2691 1 2768 NR2P $T=855600 588560 1 180 $X=851880 $Y=588180
X1341 2730 2 2777 1 2771 NR2P $T=857460 598640 1 180 $X=853740 $Y=598260
X1342 2762 2 2738 1 2784 NR2P $T=858080 598640 0 180 $X=854360 $Y=593220
X1343 2780 2 2701 1 2788 NR2P $T=855600 538160 1 0 $X=855600 $Y=532740
X1344 2780 2 2776 1 2807 NR2P $T=866760 548240 0 180 $X=863040 $Y=542820
X1345 615 2 856 1 3225 NR2P $T=994480 588560 0 180 $X=990760 $Y=583140
X1346 3261 2 3277 1 3280 NR2P $T=1011220 558320 0 180 $X=1007500 $Y=552900
X1347 3215 2 3276 1 3300 NR2P $T=1019900 538160 1 180 $X=1016180 $Y=537780
X1348 895 2 3326 1 894 NR2P $T=1039120 598640 1 180 $X=1035400 $Y=598260
X1349 1897 399 2 2098 1920 1 OR3B2 $T=623720 528080 1 180 $X=620000 $Y=527700
X1350 204 9 1 2 INV12CK $T=450120 528080 0 180 $X=440200 $Y=522660
X1351 2104 156 1 2 INV12CK $T=624340 548240 0 180 $X=614420 $Y=542820
X1352 2086 1788 1 2 INV12CK $T=614420 558320 0 0 $X=614420 $Y=557940
X1353 2086 413 1 2 INV12CK $T=618140 588560 0 0 $X=618140 $Y=588180
X1354 2086 405 1 2 INV12CK $T=620620 578480 0 0 $X=620620 $Y=578100
X1355 156 2086 1 2 INV12CK $T=624340 568400 0 0 $X=624340 $Y=568020
X1356 469 2104 1 2 INV12CK $T=658440 548240 0 180 $X=648520 $Y=542820
X1357 773 769 1 2 INV12CK $T=913260 578480 0 0 $X=913260 $Y=578100
X1358 1097 195 1 2 BUF2CK $T=434000 528080 0 0 $X=434000 $Y=527700
X1359 1906 1889 1 2 BUF2CK $T=538160 538160 1 0 $X=538160 $Y=532740
X1360 1491 1 2 8 INV3CK $T=362080 528080 0 180 $X=358980 $Y=522660
X1361 2040 1 2 2046 INV3CK $T=602640 528080 0 180 $X=599540 $Y=522660
X1362 2139 1 2 2154 INV3CK $T=656580 598640 0 180 $X=653480 $Y=593220
X1363 564 1 2 537 INV3CK $T=721060 518000 0 180 $X=717960 $Y=512580
X1364 1014 1 2 1013 BUF1CK $T=222580 528080 0 0 $X=222580 $Y=527700
X1365 1036 1 2 1012 BUF1CK $T=236220 578480 1 0 $X=236220 $Y=573060
X1366 1510 1 2 1520 BUF1CK $T=368900 528080 1 0 $X=368900 $Y=522660
X1367 1796 1 2 1800 BUF1CK $T=465000 538160 1 0 $X=465000 $Y=532740
X1368 1801 1 2 1805 BUF1CK $T=469340 578480 0 0 $X=469340 $Y=578100
X1369 1808 1 2 1809 BUF1CK $T=471820 538160 1 0 $X=471820 $Y=532740
X1370 1812 1 2 1813 BUF1CK $T=474300 528080 1 0 $X=474300 $Y=522660
X1371 1839 1 2 1843 BUF1CK $T=493520 568400 0 0 $X=493520 $Y=568020
X1372 1806 1 2 1847 BUF1CK $T=496000 518000 0 0 $X=496000 $Y=517620
X1373 1850 1 2 1854 BUF1CK $T=496620 588560 0 0 $X=496620 $Y=588180
X1374 1833 1 2 1862 BUF1CK $T=501580 528080 0 0 $X=501580 $Y=527700
X1375 1859 1 2 1857 BUF1CK $T=502200 528080 1 0 $X=502200 $Y=522660
X1376 1840 1 2 262 BUF1CK $T=506540 518000 1 0 $X=506540 $Y=512580
X1377 1860 1 2 1880 BUF1CK $T=508400 578480 0 0 $X=508400 $Y=578100
X1378 1868 1 2 1872 BUF1CK $T=509640 548240 1 0 $X=509640 $Y=542820
X1379 1881 1 2 1865 BUF1CK $T=510260 558320 1 0 $X=510260 $Y=552900
X1380 1890 1 2 1882 BUF1CK $T=518320 568400 0 0 $X=518320 $Y=568020
X1381 1959 1 2 1961 BUF1CK $T=548080 568400 0 0 $X=548080 $Y=568020
X1382 1928 1 2 1974 BUF1CK $T=559860 548240 0 0 $X=559860 $Y=547860
X1383 2172 1 2 2168 BUF1CK $T=667740 538160 1 0 $X=667740 $Y=532740
X1384 2228 1 2 2229 BUF1CK $T=688820 558320 1 0 $X=688820 $Y=552900
X1385 2239 1 2 2236 BUF1CK $T=696880 558320 0 0 $X=696880 $Y=557940
X1386 2233 1 2 2243 BUF1CK $T=699980 528080 0 0 $X=699980 $Y=527700
X1387 2240 1 2 2241 BUF1CK $T=704940 538160 1 0 $X=704940 $Y=532740
X1388 2946 1 2 2950 BUF1CK $T=902720 568400 1 0 $X=902720 $Y=562980
X1389 3003 1 2 3023 BUF1CK $T=931240 548240 1 0 $X=931240 $Y=542820
X1390 3239 1 2 3274 BUF1CK $T=1011220 558320 0 0 $X=1011220 $Y=557940
X1391 3458 1 2 3452 BUF1CK $T=1074460 578480 1 0 $X=1074460 $Y=573060
X1392 7 1 2 1015 BUF1S $T=222580 568400 0 0 $X=222580 $Y=568020
X1393 1026 1 2 1021 BUF1S $T=228160 538160 0 0 $X=228160 $Y=537780
X1394 1091 1 2 1093 BUF1S $T=251100 538160 0 0 $X=251100 $Y=537780
X1395 1092 1 2 1095 BUF1S $T=251100 548240 0 0 $X=251100 $Y=547860
X1396 1087 1 2 1104 BUF1S $T=255440 548240 0 0 $X=255440 $Y=547860
X1397 41 1 2 1130 BUF1S $T=264120 598640 0 0 $X=264120 $Y=598260
X1398 1133 1 2 1140 BUF1S $T=266600 558320 1 0 $X=266600 $Y=552900
X1399 56 1 2 1161 BUF1S $T=275280 598640 1 0 $X=275280 $Y=593220
X1400 1177 1 2 1182 BUF1S $T=282100 598640 1 0 $X=282100 $Y=593220
X1401 1116 1 2 1172 BUF1S $T=284580 538160 0 0 $X=284580 $Y=537780
X1402 1206 1 2 1216 BUF1S $T=288300 548240 1 0 $X=288300 $Y=542820
X1403 1219 1 2 1222 BUF1S $T=290160 538160 0 0 $X=290160 $Y=537780
X1404 1186 1 2 1239 BUF1S $T=293880 568400 1 0 $X=293880 $Y=562980
X1405 69 1 2 1212 BUF1S $T=298220 598640 1 0 $X=298220 $Y=593220
X1406 1246 1 2 1268 BUF1S $T=309380 588560 1 0 $X=309380 $Y=583140
X1407 1236 1 2 1282 BUF1S $T=310000 538160 0 0 $X=310000 $Y=537780
X1408 1342 1 2 1347 BUF1S $T=321780 538160 0 0 $X=321780 $Y=537780
X1409 1371 1 2 1384 BUF1S $T=331700 538160 0 0 $X=331700 $Y=537780
X1410 1400 1 2 1422 BUF1S $T=342240 538160 0 0 $X=342240 $Y=537780
X1411 1418 1 2 1451 BUF1S $T=351540 558320 0 0 $X=351540 $Y=557940
X1412 1481 1 2 1545 BUF1S $T=373860 538160 0 0 $X=373860 $Y=537780
X1413 1536 1 2 1600 BUF1S $T=388740 548240 1 0 $X=388740 $Y=542820
X1414 1603 1 2 1644 BUF1S $T=406720 518000 1 180 $X=404240 $Y=517620
X1415 1595 1 2 1681 BUF1S $T=414160 548240 0 0 $X=414160 $Y=547860
X1416 1642 1 2 1685 BUF1S $T=414780 588560 0 0 $X=414780 $Y=588180
X1417 1675 1 2 1696 BUF1S $T=418500 518000 0 0 $X=418500 $Y=517620
X1418 1717 1 2 1707 BUF1S $T=425320 588560 1 180 $X=422840 $Y=588180
X1419 1659 1 2 1725 BUF1S $T=425320 538160 0 0 $X=425320 $Y=537780
X1420 1691 1 2 1731 BUF1S $T=427800 578480 0 0 $X=427800 $Y=578100
X1421 1708 1 2 1737 BUF1S $T=429040 558320 1 0 $X=429040 $Y=552900
X1422 1732 1 2 1768 BUF1S $T=448260 598640 1 0 $X=448260 $Y=593220
X1423 2309 1 2 2289 BUF1S $T=731600 568400 0 0 $X=731600 $Y=568020
X1424 2320 1 2 2314 BUF1S $T=735940 558320 0 180 $X=733460 $Y=552900
X1425 2354 1 2 2374 BUF1S $T=748340 558320 1 0 $X=748340 $Y=552900
X1426 2365 1 2 2373 BUF1S $T=748960 548240 0 0 $X=748960 $Y=547860
X1427 2729 1 2 2698 BUF1S $T=848780 538160 1 0 $X=848780 $Y=532740
X1428 2776 1 2 2732 BUF1S $T=857460 548240 1 0 $X=857460 $Y=542820
X1429 714 1 2 718 BUF1S $T=864900 538160 1 0 $X=864900 $Y=532740
X1430 719 1 2 2817 BUF1S $T=866760 558320 1 0 $X=866760 $Y=552900
X1431 734 1 2 738 BUF1S $T=879160 558320 0 0 $X=879160 $Y=557940
X1432 739 1 2 746 BUF1S $T=881020 538160 0 0 $X=881020 $Y=537780
X1433 762 1 2 763 BUF1S $T=897760 568400 1 0 $X=897760 $Y=562980
X1434 2923 1 2 2938 BUF1S $T=898380 528080 1 0 $X=898380 $Y=522660
X1435 2932 1 2 2942 BUF1S $T=903960 538160 0 0 $X=903960 $Y=537780
X1436 2965 1 2 2980 BUF1S $T=914500 518000 1 0 $X=914500 $Y=512580
X1437 3034 1 2 3039 BUF1S $T=936820 558320 1 0 $X=936820 $Y=552900
X1438 3114 1 2 3149 BUF1S $T=972780 568400 1 0 $X=972780 $Y=562980
X1439 915 1 2 3435 BUF1S $T=1059580 578480 1 0 $X=1059580 $Y=573060
X1440 3418 1 2 3440 BUF1S $T=1060820 518000 0 0 $X=1060820 $Y=517620
X1441 3380 1 2 3447 BUF1S $T=1062680 528080 0 0 $X=1062680 $Y=527700
X1442 3394 1 2 3427 BUF1S $T=1063300 558320 1 0 $X=1063300 $Y=552900
X1443 3412 1 2 3457 BUF1S $T=1066400 558320 1 0 $X=1066400 $Y=552900
X1444 3461 1 2 3467 BUF1S $T=1068880 558320 1 0 $X=1068880 $Y=552900
X1445 3459 1 2 3473 BUF1S $T=1071980 518000 0 0 $X=1071980 $Y=517620
X1446 931 1 2 3486 BUF1S $T=1076320 588560 1 0 $X=1076320 $Y=583140
X1447 924 1 2 3482 BUF1S $T=1078180 518000 1 0 $X=1078180 $Y=512580
X1448 3468 1 2 3495 BUF1S $T=1080040 538160 0 0 $X=1080040 $Y=537780
X1449 1100 1 2 1110 DELB $T=257920 578480 1 0 $X=257920 $Y=573060
X1450 1740 1 2 1749 DELB $T=438960 518000 1 0 $X=438960 $Y=512580
X1451 1750 1 2 1761 DELB $T=443300 568400 0 0 $X=443300 $Y=568020
X1452 201 1 2 1765 DELB $T=445160 558320 1 0 $X=445160 $Y=552900
X1453 1763 1 2 1771 DELB $T=448260 568400 0 0 $X=448260 $Y=568020
X1454 1735 1 2 1785 DELB $T=453840 518000 1 0 $X=453840 $Y=512580
X1455 1767 1 2 1804 DELB $T=465620 558320 1 0 $X=465620 $Y=552900
X1456 1770 1 2 1815 DELB $T=473680 548240 1 0 $X=473680 $Y=542820
X1457 1769 1 2 1817 DELB $T=474300 588560 1 0 $X=474300 $Y=583140
X1458 1776 1 2 1827 DELB $T=482360 558320 1 0 $X=482360 $Y=552900
X1459 1798 1 2 1832 DELB $T=484220 588560 0 0 $X=484220 $Y=588180
X1460 1734 1 2 1845 DELB $T=491660 528080 0 0 $X=491660 $Y=527700
X1461 1760 1 2 1855 DELB $T=496000 538160 1 0 $X=496000 $Y=532740
X1462 1791 1 2 1885 DELB $T=510260 528080 1 0 $X=510260 $Y=522660
X1463 1786 1 2 1893 DELB $T=516460 578480 0 0 $X=516460 $Y=578100
X1464 1960 1 2 330 DELB $T=569160 578480 0 0 $X=569160 $Y=578100
X1465 2158 1 2 2182 DELB $T=689440 598640 0 0 $X=689440 $Y=598260
X1466 728 1 2 733 DELB $T=874200 558320 0 0 $X=874200 $Y=557940
X1467 750 1 2 752 DELB $T=884740 568400 0 0 $X=884740 $Y=568020
X1468 2951 1 2 2958 DELB $T=906440 598640 0 0 $X=906440 $Y=598260
X1469 3350 1 2 3356 DELB $T=1039120 558320 1 0 $X=1039120 $Y=552900
X1470 15 2 1 1097 BUF1 $T=249860 518000 0 0 $X=249860 $Y=517620
X1471 42 2 1 1079 BUF1 $T=279000 578480 1 0 $X=279000 $Y=573060
X1472 42 2 1 1280 BUF1 $T=314340 568400 0 0 $X=314340 $Y=568020
X1473 99 2 1 1326 BUF1 $T=317440 588560 1 0 $X=317440 $Y=583140
X1474 1323 2 1 1263 BUF1 $T=336660 568400 1 180 $X=334180 $Y=568020
X1475 98 2 1 1411 BUF1 $T=339760 588560 1 0 $X=339760 $Y=583140
X1476 1512 2 1 1573 BUF1 $T=387500 598640 1 0 $X=387500 $Y=593220
X1477 60 2 1 198 BUF1 $T=440200 528080 0 0 $X=440200 $Y=527700
X1478 219 2 1 1811 BUF1 $T=501580 588560 1 180 $X=499100 $Y=588180
X1479 461 2 1 412 BUF1 $T=654100 558320 1 180 $X=651620 $Y=557940
X1480 486 2 1 500 BUF1 $T=678900 558320 1 0 $X=678900 $Y=552900
X1481 491 2 1 504 BUF1 $T=682000 558320 1 0 $X=682000 $Y=552900
X1482 461 2 1 523 BUF1 $T=701840 568400 0 0 $X=701840 $Y=568020
X1483 2399 2 1 2388 BUF1 $T=760120 528080 1 0 $X=760120 $Y=522660
X1484 615 2 1 2436 BUF1 $T=773760 548240 0 0 $X=773760 $Y=547860
X1485 620 2 1 2489 BUF1 $T=778720 548240 0 0 $X=778720 $Y=547860
X1486 634 2 1 2446 BUF1 $T=794220 598640 1 0 $X=794220 $Y=593220
X1487 660 2 1 2616 BUF1 $T=817780 538160 0 0 $X=817780 $Y=537780
X1488 669 2 1 662 BUF1 $T=825840 518000 1 180 $X=823360 $Y=517620
X1489 585 2 1 2332 BUF1 $T=859320 588560 1 180 $X=856840 $Y=588180
X1490 716 2 1 569 BUF1 $T=864280 528080 1 180 $X=861800 $Y=527700
X1491 2779 2 1 2796 BUF1 $T=861800 558320 1 0 $X=861800 $Y=552900
X1492 2848 2 1 2868 BUF1 $T=879160 518000 1 0 $X=879160 $Y=512580
X1493 461 2 1 776 BUF1 $T=915740 558320 1 0 $X=915740 $Y=552900
X1494 634 2 1 3063 BUF1 $T=949220 588560 1 180 $X=946740 $Y=588180
X1495 3410 2 1 3417 BUF1 $T=1055240 598640 1 0 $X=1055240 $Y=593220
X1496 1877 2 1 1875 BUF3 $T=510880 548240 0 0 $X=510880 $Y=547860
X1497 1788 358 1 2 INV8CK $T=592720 568400 0 0 $X=592720 $Y=568020
X1498 2116 280 1 2 INV8CK $T=634880 528080 0 0 $X=634880 $Y=527700
X1499 442 296 1 2 INV8CK $T=641700 548240 1 180 $X=634880 $Y=547860
X1500 499 469 1 2 INV8CK $T=680760 548240 0 180 $X=673940 $Y=542820
X1501 413 773 1 2 INV8CK $T=913260 568400 0 0 $X=913260 $Y=568020
X1502 1086 1079 1145 2 1159 1111 1 AO22 $T=270940 558320 0 0 $X=270940 $Y=557940
X1503 1188 59 1156 2 46 57 1 AO22 $T=281480 518000 0 180 $X=276520 $Y=512580
X1504 1136 1079 1179 2 1190 1111 1 AO22 $T=282720 558320 0 0 $X=282720 $Y=557940
X1505 1166 1079 1197 2 1199 1111 1 AO22 $T=283960 558320 1 0 $X=283960 $Y=552900
X1506 1207 78 81 2 83 85 1 AO22 $T=296980 598640 0 0 $X=296980 $Y=598260
X1507 70 84 1234 2 87 91 1 AO22 $T=300080 518000 1 0 $X=300080 $Y=512580
X1508 1193 1079 1252 2 1253 1271 1 AO22 $T=300700 558320 0 0 $X=300700 $Y=557940
X1509 1241 78 89 2 90 85 1 AO22 $T=301940 598640 0 0 $X=301940 $Y=598260
X1510 1292 1280 1277 2 1274 1271 1 AO22 $T=310000 558320 0 180 $X=305040 $Y=552900
X1511 1307 84 1287 2 97 91 1 AO22 $T=318060 518000 0 180 $X=313100 $Y=512580
X1512 1327 1280 1314 2 1308 1271 1 AO22 $T=318680 558320 0 180 $X=313720 $Y=552900
X1513 1353 84 109 2 108 91 1 AO22 $T=325500 518000 0 180 $X=320540 $Y=512580
X1514 1355 1280 1360 2 1361 1271 1 AO22 $T=326120 558320 1 0 $X=326120 $Y=552900
X1515 1426 1280 1466 2 1456 1271 1 AO22 $T=354020 558320 0 0 $X=354020 $Y=557940
X1516 1475 1280 1501 2 1493 1271 1 AO22 $T=369520 558320 0 180 $X=364560 $Y=552900
X1517 1564 1280 1517 2 1561 1271 1 AO22 $T=382540 558320 1 180 $X=377580 $Y=557940
X1518 1617 1280 1585 2 1574 1271 1 AO22 $T=393700 568400 0 180 $X=388740 $Y=562980
X1519 1619 166 171 2 170 85 1 AO22 $T=402380 598640 1 180 $X=397420 $Y=598260
X1520 1651 1280 1639 2 1610 1271 1 AO22 $T=403620 568400 1 180 $X=398660 $Y=568020
X1521 1630 166 174 2 173 85 1 AO22 $T=410440 598640 1 180 $X=405480 $Y=598260
X1522 1668 1280 1652 2 1626 1271 1 AO22 $T=412300 588560 0 180 $X=407340 $Y=583140
X1523 1686 166 180 2 179 85 1 AO22 $T=417880 598640 1 180 $X=412920 $Y=598260
X1524 1701 1280 1674 2 1583 1271 1 AO22 $T=421600 568400 0 180 $X=416640 $Y=562980
X1525 1703 1280 1684 2 1629 1271 1 AO22 $T=422220 578480 1 180 $X=417260 $Y=578100
X1526 1706 1280 1698 2 1624 1271 1 AO22 $T=423460 588560 0 180 $X=418500 $Y=583140
X1527 1711 1280 1680 2 1628 1271 1 AO22 $T=424080 568400 1 180 $X=419120 $Y=568020
X1528 1713 166 186 2 183 85 1 AO22 $T=424080 598640 1 180 $X=419120 $Y=598260
X1529 1351 1030 1728 2 191 60 1 AO22 $T=434000 538160 0 0 $X=434000 $Y=537780
X1530 1903 277 275 2 273 271 1 AO22 $T=520180 518000 0 180 $X=515220 $Y=512580
X1531 1904 275 1883 2 269 271 1 AO22 $T=520800 518000 1 180 $X=515840 $Y=517620
X1532 1943 291 1927 2 283 282 1 AO22 $T=542500 518000 0 180 $X=537540 $Y=512580
X1533 293 290 1929 2 1932 288 1 AO22 $T=543120 558320 1 180 $X=538160 $Y=557940
X1534 298 290 1933 2 1926 288 1 AO22 $T=543120 588560 1 180 $X=538160 $Y=588180
X1535 297 290 1931 2 1930 288 1 AO22 $T=544360 558320 0 180 $X=539400 $Y=552900
X1536 1952 1937 291 2 286 282 1 AO22 $T=545600 518000 1 180 $X=540640 $Y=517620
X1537 1960 290 1941 2 1935 288 1 AO22 $T=547460 568400 0 180 $X=542500 $Y=562980
X1538 302 290 1947 2 1950 288 1 AO22 $T=549320 578480 1 180 $X=544360 $Y=578100
X1539 304 290 1934 2 1940 288 1 AO22 $T=551800 598640 0 180 $X=546840 $Y=593220
X1540 300 290 1956 2 1962 288 1 AO22 $T=547460 548240 0 0 $X=547460 $Y=547860
X1541 305 290 1955 2 1958 288 1 AO22 $T=552420 558320 1 180 $X=547460 $Y=557940
X1542 312 290 1970 2 1964 288 1 AO22 $T=559860 548240 1 180 $X=554900 $Y=547860
X1543 317 290 1966 2 1972 288 1 AO22 $T=564200 578480 0 180 $X=559240 $Y=573060
X1544 326 290 1982 2 1980 288 1 AO22 $T=568540 568400 0 180 $X=563580 $Y=562980
X1545 328 290 1983 2 1981 288 1 AO22 $T=572260 568400 1 180 $X=567300 $Y=568020
X1546 331 290 1989 2 1987 288 1 AO22 $T=573500 548240 1 180 $X=568540 $Y=547860
X1547 341 290 1993 2 1990 288 1 AO22 $T=578460 558320 1 180 $X=573500 $Y=557940
X1548 345 290 2007 2 1995 288 1 AO22 $T=583420 568400 1 180 $X=578460 $Y=568020
X1549 347 290 2013 2 2010 288 1 AO22 $T=587760 558320 1 180 $X=582800 $Y=557940
X1550 558 504 2263 2 553 500 1 AO22 $T=718580 518000 1 180 $X=713620 $Y=517620
X1551 2367 2323 2375 2 2382 2332 1 AO22 $T=750820 588560 1 0 $X=750820 $Y=583140
X1552 2304 603 2410 2 2430 608 1 AO22 $T=763220 528080 1 0 $X=763220 $Y=522660
X1553 2408 2323 2423 2 2432 2332 1 AO22 $T=763220 578480 1 0 $X=763220 $Y=573060
X1554 2308 603 2426 2 2445 608 1 AO22 $T=766320 538160 1 0 $X=766320 $Y=532740
X1555 2331 608 2452 2 2456 603 1 AO22 $T=769420 518000 0 0 $X=769420 $Y=517620
X1556 2453 2323 2461 2 2468 2332 1 AO22 $T=771900 578480 0 0 $X=771900 $Y=578100
X1557 2299 603 2470 2 2458 608 1 AO22 $T=773760 538160 0 0 $X=773760 $Y=537780
X1558 2376 603 2472 2 2474 608 1 AO22 $T=775000 528080 0 0 $X=775000 $Y=527700
X1559 2450 2323 2477 2 2482 2332 1 AO22 $T=775620 578480 1 0 $X=775620 $Y=573060
X1560 2387 603 2480 2 2486 608 1 AO22 $T=776860 518000 0 0 $X=776860 $Y=517620
X1561 2538 2323 2534 2 2508 2332 1 AO22 $T=796700 578480 1 180 $X=791740 $Y=578100
X1562 2552 2323 2560 2 2553 2332 1 AO22 $T=803520 588560 0 180 $X=798560 $Y=583140
X1563 2580 2323 2584 2 2590 2332 1 AO22 $T=806000 578480 0 0 $X=806000 $Y=578100
X1564 2637 2639 2635 2 2611 2332 1 AO22 $T=823980 578480 0 180 $X=819020 $Y=573060
X1565 2642 2639 2640 2 2636 2332 1 AO22 $T=825220 568400 0 180 $X=820260 $Y=562980
X1566 2673 2639 2687 2 2681 2332 1 AO22 $T=840720 568400 1 180 $X=835760 $Y=568020
X1567 2742 2639 2726 2 2713 2332 1 AO22 $T=853120 578480 0 180 $X=848160 $Y=573060
X1568 2798 2639 2790 2 2711 2332 1 AO22 $T=861800 568400 1 180 $X=856840 $Y=568020
X1569 2792 712 2756 2 2748 662 1 AO22 $T=863660 518000 1 180 $X=858700 $Y=517620
X1570 724 712 2805 2 2746 662 1 AO22 $T=869860 518000 1 180 $X=864900 $Y=517620
X1571 2821 2639 2804 2 2745 2332 1 AO22 $T=871100 578480 0 180 $X=866140 $Y=573060
X1572 2864 712 2816 2 2763 669 1 AO22 $T=879780 538160 0 180 $X=874820 $Y=532740
X1573 2873 2639 2810 2 2768 585 1 AO22 $T=882880 588560 1 180 $X=877920 $Y=588180
X1574 2882 712 2871 2 2754 669 1 AO22 $T=884740 528080 0 180 $X=879780 $Y=522660
X1575 3035 807 3042 2 3058 808 1 AO22 $T=940540 538160 1 0 $X=940540 $Y=532740
X1576 3037 807 3067 2 3073 808 1 AO22 $T=943640 518000 0 0 $X=943640 $Y=517620
X1577 3011 807 3074 2 3078 808 1 AO22 $T=944880 528080 0 0 $X=944880 $Y=527700
X1578 3060 2964 3075 2 3079 2976 1 AO22 $T=944880 568400 0 0 $X=944880 $Y=568020
X1579 3112 2964 3124 2 3118 2976 1 AO22 $T=965340 578480 0 180 $X=960380 $Y=573060
X1580 827 3128 3102 2 3134 3148 1 AO22 $T=962240 568400 0 0 $X=962240 $Y=568020
X1581 3143 2964 3163 2 3168 3175 1 AO22 $T=973400 578480 0 0 $X=973400 $Y=578100
X1582 3160 2964 3167 2 3170 3175 1 AO22 $T=974020 578480 1 0 $X=974020 $Y=573060
X1583 845 807 3194 2 3201 808 1 AO22 $T=981460 518000 0 0 $X=981460 $Y=517620
X1584 3165 2964 3211 2 3214 3175 1 AO22 $T=988280 578480 1 0 $X=988280 $Y=573060
X1585 3241 2964 3231 2 3228 3175 1 AO22 $T=998200 578480 0 180 $X=993240 $Y=573060
X1586 3233 2964 3262 2 3255 3175 1 AO22 $T=1007500 578480 0 180 $X=1002540 $Y=573060
X1587 3278 2964 3273 2 3270 3175 1 AO22 $T=1012460 578480 0 180 $X=1007500 $Y=573060
X1588 3291 2964 3288 2 3284 3175 1 AO22 $T=1019280 578480 1 180 $X=1014320 $Y=578100
X1589 3315 2964 3308 2 3302 3175 1 AO22 $T=1026100 578480 1 180 $X=1021140 $Y=578100
X1590 3329 669 3301 2 3321 890 1 AO22 $T=1031680 538160 1 180 $X=1026720 $Y=537780
X1591 892 890 3323 2 3279 669 1 AO22 $T=1031680 518000 1 0 $X=1031680 $Y=512580
X1592 3348 669 3300 2 3334 890 1 AO22 $T=1036640 538160 1 180 $X=1031680 $Y=537780
X1593 901 890 3330 2 3267 669 1 AO22 $T=1040360 528080 0 180 $X=1035400 $Y=522660
X1594 902 890 3333 2 3289 669 1 AO22 $T=1040980 528080 1 180 $X=1036020 $Y=527700
X1595 3361 900 3354 2 3344 585 1 AO22 $T=1041600 598640 0 180 $X=1036640 $Y=593220
X1596 3370 669 3299 2 3355 890 1 AO22 $T=1043460 538160 1 180 $X=1038500 $Y=537780
X1597 3388 900 3379 2 3294 585 1 AO22 $T=1049660 598640 0 180 $X=1044700 $Y=593220
X1598 3401 890 3393 2 3298 669 1 AO22 $T=1053380 528080 0 180 $X=1048420 $Y=522660
X1599 911 900 909 2 908 585 1 AO22 $T=1054620 598640 1 180 $X=1049660 $Y=598260
X1600 3397 669 3297 2 3398 890 1 AO22 $T=1058960 528080 1 180 $X=1054000 $Y=527700
X1601 3443 900 3462 2 3265 585 1 AO22 $T=1067020 578480 0 0 $X=1067020 $Y=578100
X1602 932 900 935 2 887 585 1 AO22 $T=1076320 598640 0 0 $X=1076320 $Y=598260
X1603 3449 900 3485 2 3343 585 1 AO22 $T=1076940 598640 1 0 $X=1076940 $Y=593220
X1604 3408 900 3487 2 3320 585 1 AO22 $T=1077560 588560 0 0 $X=1077560 $Y=588180
X1605 1127 1124 1121 1137 2 1 MXL2HS $T=262880 568400 1 0 $X=262880 $Y=562980
X1606 1270 1269 1294 1282 2 1 MXL2HS $T=311240 538160 1 0 $X=311240 $Y=532740
X1607 1480 1428 1485 1495 2 1 MXL2HS $T=358360 548240 0 0 $X=358360 $Y=547860
X1608 2400 2397 2375 2394 2 1 MXL2HS $T=761980 588560 0 180 $X=756400 $Y=583140
X1609 2448 2447 2461 2465 2 1 MXL2HS $T=769420 588560 1 0 $X=769420 $Y=583140
X1610 2492 2512 2518 2505 2 1 MXL2HS $T=786160 568400 0 0 $X=786160 $Y=568020
X1611 2538 633 2530 2545 2 1 MXL2HS $T=792360 568400 1 0 $X=792360 $Y=562980
X1612 2693 2714 2728 2721 2 1 MXL2HS $T=850640 568400 1 180 $X=845060 $Y=568020
X1613 2807 2786 2859 2870 2 1 MXL2HS $T=877300 548240 0 0 $X=877300 $Y=547860
X1614 2856 751 2927 2920 2 1 MXL2HS $T=893420 598640 1 0 $X=893420 $Y=593220
X1615 772 2950 2989 771 2 1 MXL2HS $T=919460 528080 1 0 $X=919460 $Y=522660
X1616 3204 3191 855 3217 2 1 MXL2HS $T=989520 568400 1 0 $X=989520 $Y=562980
X1617 3244 660 3252 3222 2 1 MXL2HS $T=1006260 548240 1 180 $X=1000680 $Y=547860
X1618 3329 3423 3411 3377 2 1 MXL2HS $T=1060820 548240 1 180 $X=1055240 $Y=547860
X1619 929 3478 3488 937 2 1 MXL2HS $T=1077560 548240 0 0 $X=1077560 $Y=547860
X1620 3493 3492 3487 3490 2 1 MXL2HS $T=1088100 578480 1 180 $X=1082520 $Y=578100
X1621 4 8 15 2 1 19 QDFFRBN $T=221340 518000 1 0 $X=221340 $Y=512580
X1622 6 8 15 2 1 17 QDFFRBN $T=221340 518000 0 0 $X=221340 $Y=517620
X1623 1000 9 15 2 1 1033 QDFFRBN $T=221340 568400 1 0 $X=221340 $Y=562980
X1624 1013 9 15 2 1 1047 QDFFRBN $T=221960 538160 1 0 $X=221960 $Y=532740
X1625 1004 9 15 2 1 1034 QDFFRBN $T=221960 558320 0 0 $X=221960 $Y=557940
X1626 1005 9 15 2 1 1031 QDFFRBN $T=224440 578480 0 0 $X=224440 $Y=578100
X1627 1044 9 15 2 1 1027 QDFFRBN $T=239320 598640 0 180 $X=227540 $Y=593220
X1628 20 8 15 2 1 23 QDFFRBN $T=234360 528080 1 0 $X=234360 $Y=522660
X1629 21 8 15 2 1 26 QDFFRBN $T=235600 518000 1 0 $X=235600 $Y=512580
X1630 24 9 15 2 1 1046 QDFFRBN $T=248620 598640 1 180 $X=236840 $Y=598260
X1631 1072 9 1097 2 1 1115 QDFFRBN $T=246140 528080 1 0 $X=246140 $Y=522660
X1632 38 9 15 2 1 1085 QDFFRBN $T=261640 598640 0 180 $X=249860 $Y=593220
X1633 34 8 1097 2 1 44 QDFFRBN $T=255440 518000 0 0 $X=255440 $Y=517620
X1634 49 8 1097 2 1 39 QDFFRBN $T=272180 528080 1 180 $X=260400 $Y=527700
X1635 1123 9 1097 2 1 1157 QDFFRBN $T=261640 538160 1 0 $X=261640 $Y=532740
X1636 58 8 1097 2 1 47 QDFFRBN $T=280240 518000 1 180 $X=268460 $Y=517620
X1637 1151 9 1097 2 1 1180 QDFFRBN $T=272180 528080 0 0 $X=272180 $Y=527700
X1638 52 8 1097 2 1 63 QDFFRBN $T=272800 528080 1 0 $X=272800 $Y=522660
X1639 1183 9 1097 2 1 1235 QDFFRBN $T=283960 528080 0 0 $X=283960 $Y=527700
X1640 65 8 1097 2 1 75 QDFFRBN $T=284580 528080 1 0 $X=284580 $Y=522660
X1641 1243 9 1097 2 1 1278 QDFFRBN $T=295740 528080 0 0 $X=295740 $Y=527700
X1642 95 8 1097 2 1 82 QDFFRBN $T=310620 528080 0 180 $X=298840 $Y=522660
X1643 1290 9 1097 2 1 1320 QDFFRBN $T=309380 528080 0 0 $X=309380 $Y=527700
X1644 123 8 1097 2 1 136 QDFFRBN $T=335420 518000 0 0 $X=335420 $Y=517620
X1645 1417 9 1097 2 1 1470 QDFFRBN $T=345960 528080 0 0 $X=345960 $Y=527700
X1646 133 8 1097 2 1 145 QDFFRBN $T=346580 518000 1 0 $X=346580 $Y=512580
X1647 134 8 1097 2 1 144 QDFFRBN $T=347200 528080 1 0 $X=347200 $Y=522660
X1648 1437 9 1097 2 1 1499 QDFFRBN $T=367040 538160 1 0 $X=367040 $Y=532740
X1649 1559 9 1097 2 1 1591 QDFFRBN $T=378820 528080 1 0 $X=378820 $Y=522660
X1650 1521 9 1097 2 1 1506 QDFFRBN $T=378820 538160 1 0 $X=378820 $Y=532740
X1651 1575 9 1097 2 1 1580 QDFFRBN $T=390600 538160 1 0 $X=390600 $Y=532740
X1652 1615 9 1097 2 1 1661 QDFFRBN $T=393700 528080 1 0 $X=393700 $Y=522660
X1653 1608 9 1097 2 1 1653 QDFFRBN $T=403000 538160 1 0 $X=403000 $Y=532740
X1654 1658 9 1097 2 1 1687 QDFFRBN $T=406100 538160 0 0 $X=406100 $Y=537780
X1655 1370 9 1097 2 1 1728 QDFFRBN $T=416640 538160 1 0 $X=416640 $Y=532740
X1656 1726 9 1097 2 1 1677 QDFFRBN $T=429660 528080 1 180 $X=417880 $Y=527700
X1657 1719 9 1097 2 1 1736 QDFFRBN $T=424700 518000 0 0 $X=424700 $Y=517620
X1658 1733 9 195 2 1 1747 QDFFRBN $T=430900 588560 1 0 $X=430900 $Y=583140
X1659 1739 9 195 2 1 1755 QDFFRBN $T=437720 548240 1 0 $X=437720 $Y=542820
X1660 1741 9 195 2 1 1766 QDFFRBN $T=439580 548240 0 0 $X=439580 $Y=547860
X1661 1746 9 195 2 1 1772 QDFFRBN $T=442680 588560 1 0 $X=442680 $Y=583140
X1662 208 209 195 2 1 1796 QDFFRBN $T=451980 518000 0 0 $X=451980 $Y=517620
X1663 1783 9 219 2 1 1794 QDFFRBN $T=456320 588560 0 0 $X=456320 $Y=588180
X1664 214 209 195 2 1 1806 QDFFRBN $T=458800 518000 1 0 $X=458800 $Y=512580
X1665 1759 1792 195 2 1 226 QDFFRBN $T=458800 548240 0 0 $X=458800 $Y=547860
X1666 1789 1792 195 2 1 1807 QDFFRBN $T=458800 558320 0 0 $X=458800 $Y=557940
X1667 1775 1792 195 2 1 229 QDFFRBN $T=459420 548240 1 0 $X=459420 $Y=542820
X1668 216 209 195 2 1 1808 QDFFRBN $T=462520 528080 1 0 $X=462520 $Y=522660
X1669 220 209 195 2 1 1812 QDFFRBN $T=465620 518000 0 0 $X=465620 $Y=517620
X1670 1762 1792 195 2 1 234 QDFFRBN $T=466240 528080 0 0 $X=466240 $Y=527700
X1671 221 223 219 2 1 231 QDFFRBN $T=466240 598640 0 0 $X=466240 $Y=598260
X1672 1787 1792 1811 2 1 238 QDFFRBN $T=468720 568400 1 0 $X=468720 $Y=562980
X1673 1749 1792 1811 2 1 1819 QDFFRBN $T=469340 538160 0 0 $X=469340 $Y=537780
X1674 227 1792 1811 2 1 1820 QDFFRBN $T=470580 558320 1 0 $X=470580 $Y=552900
X1675 228 209 195 2 1 1821 QDFFRBN $T=471820 518000 1 0 $X=471820 $Y=512580
X1676 1761 1792 1811 2 1 243 QDFFRBN $T=471820 568400 0 0 $X=471820 $Y=568020
X1677 1765 1792 195 2 1 1822 QDFFRBN $T=472440 548240 0 0 $X=472440 $Y=547860
X1678 1771 1792 1811 2 1 1824 QDFFRBN $T=472440 558320 0 0 $X=472440 $Y=557940
X1679 230 1792 1811 2 1 1826 QDFFRBN $T=474300 538160 1 0 $X=474300 $Y=532740
X1680 232 209 195 2 1 1833 QDFFRBN $T=476780 528080 1 0 $X=476780 $Y=522660
X1681 235 225 195 2 1 245 QDFFRBN $T=478020 578480 0 0 $X=478020 $Y=578100
X1682 237 209 195 2 1 1834 QDFFRBN $T=479260 518000 0 0 $X=479260 $Y=517620
X1683 239 209 195 2 1 1835 QDFFRBN $T=479880 528080 0 0 $X=479880 $Y=527700
X1684 1799 1792 1811 2 1 1836 QDFFRBN $T=479880 578480 1 0 $X=479880 $Y=573060
X1685 1817 1792 1811 2 1 1837 QDFFRBN $T=480500 568400 1 0 $X=480500 $Y=562980
X1686 241 1792 1811 2 1 1844 QDFFRBN $T=482980 538160 0 0 $X=482980 $Y=537780
X1687 242 209 195 2 1 1840 QDFFRBN $T=483600 518000 1 0 $X=483600 $Y=512580
X1688 1825 1792 1811 2 1 1849 QDFFRBN $T=484840 548240 1 0 $X=484840 $Y=542820
X1689 244 1792 1811 2 1 1848 QDFFRBN $T=485460 548240 0 0 $X=485460 $Y=547860
X1690 1827 1792 1811 2 1 255 QDFFRBN $T=485460 558320 0 0 $X=485460 $Y=557940
X1691 1828 1831 219 2 1 1850 QDFFRBN $T=486700 588560 1 0 $X=486700 $Y=583140
X1692 247 209 195 2 1 1859 QDFFRBN $T=490420 528080 1 0 $X=490420 $Y=522660
X1693 1814 1831 1811 2 1 1860 QDFFRBN $T=491040 578480 0 0 $X=491040 $Y=578100
X1694 257 225 1811 2 1 248 QDFFRBN $T=503440 578480 0 180 $X=491660 $Y=573060
X1695 1784 1831 1811 2 1 1839 QDFFRBN $T=492280 568400 1 0 $X=492280 $Y=562980
X1696 264 225 219 2 1 250 QDFFRBN $T=506540 598640 1 180 $X=494760 $Y=598260
X1697 253 225 219 2 1 266 QDFFRBN $T=495380 598640 1 0 $X=495380 $Y=593220
X1698 1842 1831 1811 2 1 1868 QDFFRBN $T=496620 538160 0 0 $X=496620 $Y=537780
X1699 1855 1831 1811 2 1 1877 QDFFRBN $T=497860 548240 1 0 $X=497860 $Y=542820
X1700 256 1831 1811 2 1 1878 QDFFRBN $T=498480 558320 1 0 $X=498480 $Y=552900
X1701 1851 1831 1811 2 1 1881 QDFFRBN $T=498480 558320 0 0 $X=498480 $Y=557940
X1702 1845 1831 1811 2 1 1879 QDFFRBN $T=499100 548240 0 0 $X=499100 $Y=547860
X1703 1805 1831 1811 2 1 1890 QDFFRBN $T=503440 578480 1 0 $X=503440 $Y=573060
X1704 1832 1831 1811 2 1 1853 QDFFRBN $T=504060 568400 1 0 $X=504060 $Y=562980
X1705 1810 1831 219 2 1 1866 QDFFRBN $T=509640 588560 0 0 $X=509640 $Y=588180
X1706 1785 1831 1811 2 1 1906 QDFFRBN $T=511500 538160 1 0 $X=511500 $Y=532740
X1707 1804 1831 1811 2 1 1905 QDFFRBN $T=511500 558320 0 0 $X=511500 $Y=557940
X1708 267 225 1811 2 1 275 QDFFRBN $T=511500 598640 1 0 $X=511500 $Y=593220
X1709 1885 1831 1811 2 1 1911 QDFFRBN $T=512740 548240 1 0 $X=512740 $Y=542820
X1710 1823 1831 1811 2 1 1902 QDFFRBN $T=512740 558320 1 0 $X=512740 $Y=552900
X1711 1815 1831 1811 2 1 1912 QDFFRBN $T=514600 548240 0 0 $X=514600 $Y=547860
X1712 1893 1831 1811 2 1 1916 QDFFRBN $T=515840 568400 1 0 $X=515840 $Y=562980
X1713 285 225 289 2 1 1945 QDFFRBN $T=530720 598640 0 0 $X=530720 $Y=598260
X1714 307 225 219 2 1 1942 QDFFRBN $T=554280 598640 1 180 $X=542500 $Y=598260
X1715 310 225 289 2 1 322 QDFFRBN $T=554280 598640 0 0 $X=554280 $Y=598260
X1716 321 225 289 2 1 333 QDFFRBN $T=564820 588560 1 0 $X=564820 $Y=583140
X1717 323 225 289 2 1 336 QDFFRBN $T=566060 578480 1 0 $X=566060 $Y=573060
X1718 335 225 289 2 1 2009 QDFFRBN $T=576600 598640 0 0 $X=576600 $Y=598260
X1719 2005 338 289 2 1 353 QDFFRBN $T=580320 518000 1 0 $X=580320 $Y=512580
X1720 373 2054 289 2 1 2030 QDFFRBN $T=605740 578480 1 180 $X=593960 $Y=578100
X1721 389 2054 289 2 1 2053 QDFFRBN $T=615660 578480 0 180 $X=603880 $Y=573060
X1722 390 2054 289 2 1 2058 QDFFRBN $T=615660 588560 0 180 $X=603880 $Y=583140
X1723 375 2054 289 2 1 2074 QDFFRBN $T=605740 538160 0 0 $X=605740 $Y=537780
X1724 401 2054 289 2 1 2075 QDFFRBN $T=620000 548240 1 180 $X=608220 $Y=547860
X1725 397 2054 412 2 1 2111 QDFFRBN $T=617520 538160 0 0 $X=617520 $Y=537780
X1726 410 2054 412 2 1 2122 QDFFRBN $T=624340 548240 1 0 $X=624340 $Y=542820
X1727 452 2054 412 2 1 2126 QDFFRBN $T=646660 568400 0 180 $X=634880 $Y=562980
X1728 380 2054 412 2 1 2132 QDFFRBN $T=636120 548240 1 0 $X=636120 $Y=542820
X1729 2131 440 412 2 1 2145 QDFFRBN $T=638600 528080 1 0 $X=638600 $Y=522660
X1730 464 2054 412 2 1 2124 QDFFRBN $T=655340 558320 0 180 $X=643560 $Y=552900
X1731 2140 440 412 2 1 2155 QDFFRBN $T=644800 528080 0 0 $X=644800 $Y=527700
X1732 445 2054 412 2 1 2133 QDFFRBN $T=656580 548240 1 180 $X=644800 $Y=547860
X1733 2142 338 412 2 1 457 QDFFRBN $T=646660 518000 1 0 $X=646660 $Y=512580
X1734 2149 440 412 2 1 2165 QDFFRBN $T=651620 518000 0 0 $X=651620 $Y=517620
X1735 2164 473 461 2 1 2148 QDFFRBN $T=663400 568400 1 180 $X=651620 $Y=568020
X1736 451 440 412 2 1 2172 QDFFRBN $T=655340 538160 0 0 $X=655340 $Y=537780
X1737 2160 473 461 2 1 2183 QDFFRBN $T=659060 578480 0 0 $X=659060 $Y=578100
X1738 2182 223 494 2 1 472 QDFFRBN $T=668980 598640 0 0 $X=668980 $Y=598260
X1739 2177 440 412 2 1 2207 QDFFRBN $T=670220 518000 1 0 $X=670220 $Y=512580
X1740 2197 473 461 2 1 2210 QDFFRBN $T=675180 588560 1 0 $X=675180 $Y=583140
X1741 2201 473 461 2 1 2224 QDFFRBN $T=677040 578480 1 0 $X=677040 $Y=573060
X1742 399 338 523 2 1 2245 QDFFRBN $T=688820 568400 0 0 $X=688820 $Y=568020
X1743 2251 537 523 2 1 2232 QDFFRBN $T=704940 548240 0 180 $X=693160 $Y=542820
X1744 2235 338 523 2 1 2258 QDFFRBN $T=695640 568400 1 0 $X=695640 $Y=562980
X1745 2262 537 523 2 1 2230 QDFFRBN $T=708040 558320 0 180 $X=696260 $Y=552900
X1746 2274 537 523 2 1 2255 QDFFRBN $T=716720 528080 1 180 $X=704940 $Y=527700
X1747 2275 537 523 2 1 2256 QDFFRBN $T=716720 538160 1 180 $X=704940 $Y=537780
X1748 2276 537 523 2 1 2247 QDFFRBN $T=717340 548240 1 180 $X=705560 $Y=547860
X1749 2277 537 523 2 1 2222 QDFFRBN $T=719200 538160 0 180 $X=707420 $Y=532740
X1750 2284 537 523 2 1 2264 QDFFRBN $T=721060 528080 0 180 $X=709280 $Y=522660
X1751 2267 338 523 2 1 2291 QDFFRBN $T=710520 558320 0 0 $X=710520 $Y=557940
X1752 2270 338 523 2 1 2301 QDFFRBN $T=712380 568400 0 0 $X=712380 $Y=568020
X1753 2310 338 523 2 1 567 QDFFRBN $T=735320 548240 0 180 $X=723540 $Y=542820
X1754 582 338 523 2 1 561 QDFFRBN $T=742140 518000 0 180 $X=730360 $Y=512580
X1755 2353 338 523 2 1 559 QDFFRBN $T=747100 548240 0 180 $X=735320 $Y=542820
X1756 2412 338 523 2 1 566 QDFFRBN $T=764460 538160 1 180 $X=752680 $Y=537780
X1757 2960 769 765 2 1 2930 QDFFRBN $T=909540 578480 0 180 $X=897760 $Y=573060
X1758 2969 770 767 2 1 2937 QDFFRBN $T=912020 528080 1 180 $X=900240 $Y=527700
X1759 2957 770 767 2 1 2941 QDFFRBN $T=913880 518000 0 180 $X=902100 $Y=512580
X1760 2984 770 767 2 1 2899 QDFFRBN $T=918220 548240 0 180 $X=906440 $Y=542820
X1761 2922 770 767 2 1 2959 QDFFRBN $T=922560 558320 1 180 $X=910780 $Y=557940
X1762 2982 770 767 2 1 789 QDFFRBN $T=915120 518000 0 0 $X=915120 $Y=517620
X1763 2971 770 767 2 1 788 QDFFRBN $T=915740 528080 0 0 $X=915740 $Y=527700
X1764 3340 770 776 2 1 3312 QDFFRBN $T=1036020 558320 1 180 $X=1024240 $Y=557940
X1765 3391 770 776 2 1 3436 QDFFRBN $T=1049040 568400 0 0 $X=1049040 $Y=568020
X1766 3360 770 776 2 1 3420 QDFFRBN $T=1050280 568400 1 0 $X=1050280 $Y=562980
X1767 3477 770 776 2 1 3494 QDFFRBN $T=1074460 518000 0 0 $X=1074460 $Y=517620
X1768 3496 770 776 2 1 3455 QDFFRBN $T=1088720 528080 1 180 $X=1076940 $Y=527700
X1769 3488 770 776 2 1 3471 QDFFRBN $T=1088720 548240 0 180 $X=1076940 $Y=542820
X1770 3497 770 776 2 1 3483 QDFFRBN $T=1088720 558320 0 180 $X=1076940 $Y=552900
X1771 96 8 1097 116 1 2 QDFFRBP $T=310620 528080 1 0 $X=310620 $Y=522660
X1772 284 225 219 270 1 2 QDFFRBP $T=530720 598640 1 180 $X=518320 $Y=598260
X1773 2156 223 461 191 1 2 QDFFRBP $T=655960 588560 0 0 $X=655960 $Y=588180
X1774 1421 1441 1 2 BUF2 $T=347820 598640 0 0 $X=347820 $Y=598260
X1775 1838 263 1 2 BUF2 $T=505920 528080 1 0 $X=505920 $Y=522660
X1776 2820 2900 1 2 INV3 $T=897140 548240 1 0 $X=897140 $Y=542820
X1777 122 8 1097 112 1 2 3504 DFFSBN $T=336040 528080 1 180 $X=323020 $Y=527700
X1778 132 8 1097 121 1 2 3505 DFFSBN $T=344720 528080 0 180 $X=331700 $Y=522660
X1779 143 8 1097 152 1 2 3506 DFFSBN $T=357120 518000 0 0 $X=357120 $Y=517620
X1780 217 225 1811 233 1 2 3507 DFFSBN $T=466860 578480 1 0 $X=466860 $Y=573060
X1781 236 225 1811 246 1 2 3508 DFFSBN $T=478640 598640 0 0 $X=478640 $Y=598260
X1782 240 225 1811 1838 1 2 3509 DFFSBN $T=481740 598640 1 0 $X=481740 $Y=593220
X1783 1307 1188 1350 2 1 XNR2HS $T=321160 518000 0 0 $X=321160 $Y=517620
X1784 1296 1350 1369 2 1 XNR2HS $T=327980 518000 0 0 $X=327980 $Y=517620
X1785 124 125 1395 2 1 XNR2HS $T=335420 598640 0 0 $X=335420 $Y=598260
X1786 1453 1459 1465 2 1 XNR2HS $T=351540 518000 0 0 $X=351540 $Y=517620
X1787 139 141 1483 2 1 XNR2HS $T=356500 598640 0 0 $X=356500 $Y=598260
X1788 147 1484 1453 2 1 XNR2HS $T=362700 538160 0 180 $X=357120 $Y=532740
X1789 158 157 1544 2 1 XNR2HS $T=383780 598640 0 0 $X=383780 $Y=598260
X1790 163 1576 1570 2 1 XNR2HS $T=390600 588560 1 180 $X=385020 $Y=588180
X1791 2163 2161 2158 2 1 XNR2HS $T=662160 598640 0 180 $X=656580 $Y=593220
X1792 707 2796 2827 2 1 XNR2HS $T=871720 548240 0 0 $X=871720 $Y=547860
X1793 841 3165 3217 2 1 XNR2HS $T=988280 558320 0 0 $X=988280 $Y=557940
X1794 861 3241 3260 2 1 XNR2HS $T=1000680 568400 0 0 $X=1000680 $Y=568020
X1795 859 3233 3272 2 1 XNR2HS $T=1006260 568400 1 0 $X=1006260 $Y=562980
X1796 3295 3292 3307 2 1 XNR2HS $T=1019900 548240 0 0 $X=1019900 $Y=547860
X1797 1023 1021 1014 2 1 XOR2HS $T=227540 538160 1 180 $X=221960 $Y=537780
X1798 16 1029 1023 2 1 XOR2HS $T=233120 528080 1 180 $X=227540 $Y=527700
X1799 1015 1011 1036 2 1 XOR2HS $T=230640 578480 1 0 $X=230640 $Y=573060
X1800 1056 1057 1011 2 1 XOR2HS $T=243040 568400 1 180 $X=237460 $Y=568020
X1801 1064 1062 1029 2 1 XOR2HS $T=244900 538160 1 180 $X=239320 $Y=537780
X1802 1081 1063 1062 2 1 XOR2HS $T=251100 538160 1 180 $X=245520 $Y=537780
X1803 1051 1090 1057 2 1 XOR2HS $T=256060 568400 1 180 $X=250480 $Y=568020
X1804 36 1089 32 2 1 XOR2HS $T=258540 518000 0 180 $X=252960 $Y=512580
X1805 1109 1106 1077 2 1 XOR2HS $T=259160 568400 0 180 $X=253580 $Y=562980
X1806 1118 1113 1101 2 1 XOR2HS $T=261020 578480 1 180 $X=255440 $Y=578100
X1807 1114 1102 1100 2 1 XOR2HS $T=262260 588560 1 180 $X=256680 $Y=588180
X1808 1110 37 40 2 1 XOR2HS $T=258540 598640 0 0 $X=258540 $Y=598260
X1809 1135 1132 1126 2 1 XOR2HS $T=267840 588560 1 180 $X=262260 $Y=588180
X1810 1155 1134 1145 2 1 XOR2HS $T=274040 568400 0 180 $X=268460 $Y=562980
X1811 1129 1125 1156 2 1 XOR2HS $T=269700 518000 1 0 $X=269700 $Y=512580
X1812 54 53 1149 2 1 XOR2HS $T=275280 588560 1 180 $X=269700 $Y=588180
X1813 1147 1143 1141 2 1 XOR2HS $T=270940 568400 0 0 $X=270940 $Y=568020
X1814 1161 1149 1165 2 1 XOR2HS $T=275280 588560 0 0 $X=275280 $Y=588180
X1815 1194 1171 1179 2 1 XOR2HS $T=287060 568400 0 180 $X=281480 $Y=562980
X1816 1169 1170 1163 2 1 XOR2HS $T=288920 588560 0 180 $X=283340 $Y=583140
X1817 1222 1202 1204 2 1 XOR2HS $T=292640 538160 0 180 $X=287060 $Y=532740
X1818 1225 1223 1197 2 1 XOR2HS $T=293260 558320 1 180 $X=287680 $Y=557940
X1819 70 62 1242 2 1 XOR2HS $T=292640 518000 0 0 $X=292640 $Y=517620
X1820 79 77 1234 2 1 XOR2HS $T=299460 518000 0 180 $X=293880 $Y=512580
X1821 1245 1238 1252 2 1 XOR2HS $T=296360 558320 1 0 $X=296360 $Y=552900
X1822 1241 74 1249 2 1 XOR2HS $T=296360 588560 0 0 $X=296360 $Y=588180
X1823 1208 1242 1260 2 1 XOR2HS $T=298220 518000 0 0 $X=298220 $Y=517620
X1824 92 93 1287 2 1 XOR2HS $T=305660 518000 1 0 $X=305660 $Y=512580
X1825 1291 1251 1277 2 1 XOR2HS $T=311240 558320 1 180 $X=305660 $Y=557940
X1826 1344 1312 1314 2 1 XOR2HS $T=323640 558320 1 180 $X=318060 $Y=557940
X1827 104 106 1352 2 1 XOR2HS $T=321160 598640 0 0 $X=321160 $Y=598260
X1828 1380 1362 1360 2 1 XOR2HS $T=336660 558320 1 180 $X=331080 $Y=557940
X1829 1384 1367 1407 2 1 XOR2HS $T=337900 528080 0 0 $X=337900 $Y=527700
X1830 1427 1401 1377 2 1 XOR2HS $T=346580 568400 0 180 $X=341000 $Y=562980
X1831 1441 1451 1430 2 1 XOR2HS $T=353400 538160 0 180 $X=347820 $Y=532740
X1832 1454 1391 1466 2 1 XOR2HS $T=351540 568400 1 0 $X=351540 $Y=562980
X1833 1496 1482 1501 2 1 XOR2HS $T=371380 568400 0 180 $X=365800 $Y=562980
X1834 1537 1507 1517 2 1 XOR2HS $T=375100 558320 1 180 $X=369520 $Y=557940
X1835 1260 1531 1557 2 1 XOR2HS $T=380060 518000 0 0 $X=380060 $Y=517620
X1836 1572 1553 1585 2 1 XOR2HS $T=384400 558320 1 0 $X=384400 $Y=552900
X1837 1592 1567 1622 2 1 XOR2HS $T=394940 548240 1 0 $X=394940 $Y=542820
X1838 1581 1582 1611 2 1 XOR2HS $T=395560 568400 1 0 $X=395560 $Y=562980
X1839 1632 1641 1652 2 1 XOR2HS $T=400520 578480 0 0 $X=400520 $Y=578100
X1840 1636 1654 1639 2 1 XOR2HS $T=404860 568400 0 0 $X=404860 $Y=568020
X1841 1650 1631 1672 2 1 XOR2HS $T=409820 558320 0 0 $X=409820 $Y=557940
X1842 1660 1655 1674 2 1 XOR2HS $T=410440 568400 1 0 $X=410440 $Y=562980
X1843 1669 1664 1680 2 1 XOR2HS $T=412300 568400 0 0 $X=412300 $Y=568020
X1844 1671 1676 1684 2 1 XOR2HS $T=412920 588560 1 0 $X=412920 $Y=583140
X1845 1624 1678 1698 2 1 XOR2HS $T=417260 588560 0 0 $X=417260 $Y=588180
X1846 1846 254 259 2 1 XOR2HS $T=500960 518000 1 0 $X=500960 $Y=512580
X1847 1874 1856 1883 2 1 XOR2HS $T=508400 518000 0 0 $X=508400 $Y=517620
X1848 1922 1924 1927 2 1 XOR2HS $T=531340 518000 1 0 $X=531340 $Y=512580
X1849 286 1925 1937 2 1 XOR2HS $T=535060 518000 0 0 $X=535060 $Y=517620
X1850 1948 1953 308 2 1 XOR2HS $T=549940 518000 1 0 $X=549940 $Y=512580
X1851 2226 505 2211 2 1 XOR2HS $T=690060 598640 0 180 $X=684480 $Y=593220
X1852 2331 2318 2322 2 1 XOR2HS $T=741520 528080 1 180 $X=735940 $Y=527700
X1853 2338 2336 2329 2 1 XOR2HS $T=743380 568400 1 180 $X=737800 $Y=568020
X1854 2351 586 2336 2 1 XOR2HS $T=745240 588560 1 0 $X=745240 $Y=583140
X1855 2380 2383 2359 2 1 XOR2HS $T=755780 588560 1 180 $X=750200 $Y=588180
X1856 590 2367 2379 2 1 XOR2HS $T=752060 578480 1 0 $X=752060 $Y=573060
X1857 2384 2388 2372 2 1 XOR2HS $T=753920 528080 0 0 $X=753920 $Y=527700
X1858 2387 2347 2384 2 1 XOR2HS $T=754540 528080 1 0 $X=754540 $Y=522660
X1859 599 2408 2390 2 1 XOR2HS $T=763220 578480 0 180 $X=757640 $Y=573060
X1860 2427 2424 2410 2 1 XOR2HS $T=766940 528080 1 180 $X=761360 $Y=527700
X1861 2413 2414 2423 2 1 XOR2HS $T=761980 588560 1 0 $X=761980 $Y=583140
X1862 2443 2438 2426 2 1 XOR2HS $T=770040 538160 1 180 $X=764460 $Y=537780
X1863 613 2450 2431 2 1 XOR2HS $T=773760 578480 0 180 $X=768180 $Y=573060
X1864 2458 2460 2470 2 1 XOR2HS $T=771900 548240 1 0 $X=771900 $Y=542820
X1865 2464 2462 2456 2 1 XOR2HS $T=774380 528080 1 0 $X=774380 $Y=522660
X1866 2497 622 2466 2 1 XOR2HS $T=783680 518000 0 180 $X=778100 $Y=512580
X1867 2499 2496 2477 2 1 XOR2HS $T=783680 578480 1 180 $X=778100 $Y=578100
X1868 2487 2494 2472 2 1 XOR2HS $T=780580 538160 1 0 $X=780580 $Y=532740
X1869 2506 2504 2480 2 1 XOR2HS $T=788020 518000 1 180 $X=782440 $Y=517620
X1870 2515 2523 2534 2 1 XOR2HS $T=788640 588560 1 0 $X=788640 $Y=583140
X1871 2552 636 2572 2 1 XOR2HS $T=800420 578480 0 0 $X=800420 $Y=578100
X1872 640 644 646 2 1 XOR2HS $T=801660 518000 1 0 $X=801660 $Y=512580
X1873 2550 2546 2560 2 1 XOR2HS $T=804760 588560 1 0 $X=804760 $Y=583140
X1874 2599 2605 2584 2 1 XOR2HS $T=810960 578480 0 0 $X=810960 $Y=578100
X1875 2642 667 2631 2 1 XOR2HS $T=825220 558320 1 180 $X=819640 $Y=557940
X1876 2625 2623 668 2 1 XOR2HS $T=820260 518000 1 0 $X=820260 $Y=512580
X1877 2629 2624 2635 2 1 XOR2HS $T=820880 588560 1 0 $X=820880 $Y=583140
X1878 2650 2648 2640 2 1 XOR2HS $T=827700 568400 1 180 $X=822120 $Y=568020
X1879 2673 688 2677 2 1 XOR2HS $T=838240 558320 1 180 $X=832660 $Y=557940
X1880 2676 2672 2687 2 1 XOR2HS $T=833900 578480 1 0 $X=833900 $Y=573060
X1881 2704 2703 2726 2 1 XOR2HS $T=842580 578480 1 0 $X=842580 $Y=573060
X1882 2742 700 2725 2 1 XOR2HS $T=850640 558320 0 180 $X=845060 $Y=552900
X1883 2735 2737 705 2 1 XOR2HS $T=850640 518000 1 0 $X=850640 $Y=512580
X1884 2769 2764 2756 2 1 XOR2HS $T=857460 528080 0 180 $X=851880 $Y=522660
X1885 2761 2782 2765 2 1 XOR2HS $T=859320 578480 1 180 $X=853740 $Y=578100
X1886 2767 2766 2790 2 1 XOR2HS $T=858080 568400 1 0 $X=858080 $Y=562980
X1887 2781 2791 2804 2 1 XOR2HS $T=860560 578480 1 0 $X=860560 $Y=573060
X1888 2795 2787 2805 2 1 XOR2HS $T=861180 528080 1 0 $X=861180 $Y=522660
X1889 715 2798 2806 2 1 XOR2HS $T=861800 568400 0 0 $X=861800 $Y=568020
X1890 2799 2800 2810 2 1 XOR2HS $T=862420 598640 1 0 $X=862420 $Y=593220
X1891 2803 2801 2815 2 1 XOR2HS $T=864280 578480 0 0 $X=864280 $Y=578100
X1892 2826 2823 2816 2 1 XOR2HS $T=872960 538160 0 180 $X=867380 $Y=532740
X1893 723 2819 2830 2 1 XOR2HS $T=868000 598640 1 0 $X=868000 $Y=593220
X1894 2813 2809 2841 2 1 XOR2HS $T=871720 588560 0 0 $X=871720 $Y=588180
X1895 2834 2838 2844 2 1 XOR2HS $T=872340 548240 1 0 $X=872340 $Y=542820
X1896 2837 2833 2855 2 1 XOR2HS $T=874200 528080 1 0 $X=874200 $Y=522660
X1897 2851 2835 2871 2 1 XOR2HS $T=879160 528080 0 0 $X=879160 $Y=527700
X1898 727 2783 2867 2 1 XOR2HS $T=882880 578480 1 0 $X=882880 $Y=573060
X1899 2825 2900 2916 2 1 XOR2HS $T=889700 548240 0 0 $X=889700 $Y=547860
X1900 2873 753 2929 2 1 XOR2HS $T=894040 588560 0 0 $X=894040 $Y=588180
X1901 2904 2929 2934 2 1 XOR2HS $T=895280 588560 1 0 $X=895280 $Y=583140
X1902 756 736 764 2 1 XOR2HS $T=896520 518000 1 0 $X=896520 $Y=512580
X1903 2887 2921 2951 2 1 XOR2HS $T=901480 588560 1 0 $X=901480 $Y=583140
X1904 2905 2888 2948 2 1 XOR2HS $T=902720 528080 1 0 $X=902720 $Y=522660
X1905 2948 2938 2957 2 1 XOR2HS $T=903960 518000 0 0 $X=903960 $Y=517620
X1906 768 2874 2956 2 1 XOR2HS $T=905200 598640 1 0 $X=905200 $Y=593220
X1907 2958 2956 2970 2 1 XOR2HS $T=907060 588560 1 0 $X=907060 $Y=583140
X1908 2981 2978 2974 2 1 XOR2HS $T=916360 598640 0 180 $X=910780 $Y=593220
X1909 2983 2988 2966 2 1 XOR2HS $T=918220 598640 1 0 $X=918220 $Y=593220
X1910 3001 2998 3006 2 1 XOR2HS $T=923180 578480 0 0 $X=923180 $Y=578100
X1911 3017 3014 3024 2 1 XOR2HS $T=930000 578480 1 0 $X=930000 $Y=573060
X1912 3033 3032 3044 2 1 XOR2HS $T=936200 578480 1 0 $X=936200 $Y=573060
X1913 3029 3036 806 2 1 XOR2HS $T=936820 518000 1 0 $X=936820 $Y=512580
X1914 3058 3053 3042 2 1 XOR2HS $T=943640 538160 1 180 $X=938060 $Y=537780
X1915 3076 3062 3075 2 1 XOR2HS $T=951700 578480 1 180 $X=946120 $Y=578100
X1916 3064 3071 3074 2 1 XOR2HS $T=947360 538160 0 0 $X=947360 $Y=537780
X1917 3082 3068 3067 2 1 XOR2HS $T=948600 518000 0 0 $X=948600 $Y=517620
X1918 809 3060 3048 2 1 XOR2HS $T=949220 558320 0 0 $X=949220 $Y=557940
X1919 3095 3091 3085 2 1 XOR2HS $T=957280 578480 1 180 $X=951700 $Y=578100
X1920 3106 3100 3124 2 1 XOR2HS $T=959140 588560 1 0 $X=959140 $Y=583140
X1921 3150 3147 3163 2 1 XOR2HS $T=971540 588560 1 0 $X=971540 $Y=583140
X1922 3190 3178 3167 2 1 XOR2HS $T=983940 588560 0 180 $X=978360 $Y=583140
X1923 3203 3206 3211 2 1 XOR2HS $T=984560 588560 1 0 $X=984560 $Y=583140
X1924 3198 847 3194 2 1 XOR2HS $T=988280 518000 0 0 $X=988280 $Y=517620
X1925 3232 3224 3231 2 1 XOR2HS $T=1000680 578480 1 180 $X=995100 $Y=578100
X1926 3236 3245 865 2 1 XOR2HS $T=998200 518000 1 0 $X=998200 $Y=512580
X1927 3254 3251 3262 2 1 XOR2HS $T=1001300 578480 0 0 $X=1001300 $Y=578100
X1928 3268 3269 3273 2 1 XOR2HS $T=1006880 578480 0 0 $X=1006880 $Y=578100
X1929 3287 3285 3288 2 1 XOR2HS $T=1018040 588560 1 0 $X=1018040 $Y=583140
X1930 3309 3305 3323 2 1 XOR2HS $T=1024860 518000 1 0 $X=1024860 $Y=512580
X1931 3303 3306 3321 2 1 XOR2HS $T=1025480 538160 1 0 $X=1025480 $Y=532740
X1932 3314 3319 3308 2 1 XOR2HS $T=1026100 588560 1 0 $X=1026100 $Y=583140
X1933 3313 3316 3330 2 1 XOR2HS $T=1028580 528080 1 0 $X=1028580 $Y=522660
X1934 3310 3318 3333 2 1 XOR2HS $T=1029200 528080 0 0 $X=1029200 $Y=527700
X1935 3339 3335 3350 2 1 XOR2HS $T=1033540 558320 1 0 $X=1033540 $Y=552900
X1936 3336 3311 3334 2 1 XOR2HS $T=1039740 538160 0 180 $X=1034160 $Y=532740
X1937 3342 3338 3354 2 1 XOR2HS $T=1035400 588560 1 0 $X=1035400 $Y=583140
X1938 3356 899 3340 2 1 XOR2HS $T=1042220 568400 1 0 $X=1042220 $Y=562980
X1939 3363 3358 3379 2 1 XOR2HS $T=1042840 588560 0 0 $X=1042840 $Y=588180
X1940 3364 3366 3355 2 1 XOR2HS $T=1044080 538160 1 0 $X=1044080 $Y=532740
X1941 3376 3374 3398 2 1 XOR2HS $T=1048420 528080 0 0 $X=1048420 $Y=527700
X1942 907 3388 3400 2 1 XOR2HS $T=1049660 598640 1 0 $X=1049660 $Y=593220
X1943 3371 3383 3393 2 1 XOR2HS $T=1051520 518000 1 0 $X=1051520 $Y=512580
X1944 3396 3400 916 2 1 XOR2HS $T=1055240 578480 0 0 $X=1055240 $Y=578100
X1945 3386 3390 3423 2 1 XOR2HS $T=1057720 558320 1 0 $X=1057720 $Y=552900
X1946 912 3408 3428 2 1 XOR2HS $T=1065780 588560 1 180 $X=1060200 $Y=588180
X1947 3435 3411 3458 2 1 XOR2HS $T=1065160 578480 1 0 $X=1065160 $Y=573060
X1948 3467 3432 3478 2 1 XOR2HS $T=1071360 558320 1 0 $X=1071360 $Y=552900
X1949 3474 3484 3462 2 1 XOR2HS $T=1076940 578480 1 0 $X=1076940 $Y=573060
X1950 3489 940 3485 2 1 XOR2HS $T=1088720 598640 1 180 $X=1083140 $Y=598260
X1951 1913 1909 1800 1 2 1920 OA12 $T=525760 528080 1 0 $X=525760 $Y=522660
X1952 1918 1919 1891 1 2 1923 OA12 $T=527000 578480 1 0 $X=527000 $Y=573060
X1953 2014 2019 238 1 2 2026 OA12 $T=587760 558320 0 0 $X=587760 $Y=557940
X1954 2176 2193 2168 1 2 496 OA12 $T=675180 528080 0 0 $X=675180 $Y=527700
X1955 2234 2237 2240 1 2 2242 OA12 $T=695640 538160 1 0 $X=695640 $Y=532740
X1956 585 2639 2771 1 2 2874 OA12 $T=879160 598640 1 0 $X=879160 $Y=593220
X1957 669 712 2807 1 2 2887 OA12 $T=882880 558320 0 0 $X=882880 $Y=557940
X1958 669 890 3280 1 2 3339 OA12 $T=1029200 548240 1 0 $X=1029200 $Y=542820
X1959 1011 7 2 1 1007 OR2 $T=224440 578480 1 0 $X=224440 $Y=573060
X1960 1207 67 2 1 1176 OR2 $T=288300 598640 1 180 $X=285820 $Y=598260
X1961 68 1220 2 1 73 OR2 $T=290160 598640 0 0 $X=290160 $Y=598260
X1962 71 1218 2 1 1230 OR2 $T=292020 588560 0 0 $X=292020 $Y=588180
X1963 1202 1227 2 1 1232 OR2 $T=292640 538160 1 0 $X=292640 $Y=532740
X1964 1247 1227 2 1 1250 OR2 $T=298220 538160 0 0 $X=298220 $Y=537780
X1965 1269 1267 2 1 1265 OR2 $T=305660 538160 0 180 $X=303180 $Y=532740
X1966 1195 1267 2 1 1276 OR2 $T=307520 538160 0 0 $X=307520 $Y=537780
X1967 106 104 2 1 101 OR2 $T=321160 598640 1 180 $X=318680 $Y=598260
X1968 1374 1379 2 1 1383 OR2 $T=334180 538160 1 0 $X=334180 $Y=532740
X1969 125 124 2 1 130 OR2 $T=341000 598640 0 0 $X=341000 $Y=598260
X1970 1418 1421 2 1 1425 OR2 $T=343480 528080 0 0 $X=343480 $Y=527700
X1971 141 139 2 1 138 OR2 $T=354640 598640 1 180 $X=352160 $Y=598260
X1972 2063 544 2 1 572 OR2 $T=723540 528080 0 0 $X=723540 $Y=527700
X1973 2367 590 2 1 2356 OR2 $T=749580 578480 1 180 $X=747100 $Y=578100
X1974 2389 2386 2 1 2358 OR2 $T=755780 568400 1 180 $X=753300 $Y=568020
X1975 2450 613 2 1 2449 OR2 $T=775620 568400 0 0 $X=775620 $Y=568020
X1976 2495 2484 2 1 2488 OR2 $T=782440 558320 0 180 $X=779960 $Y=552900
X1977 636 2552 2 1 2557 OR2 $T=797940 578480 0 0 $X=797940 $Y=578100
X1978 667 2642 2 1 2654 OR2 $T=825220 568400 1 0 $X=825220 $Y=562980
X1979 2655 675 2 1 2659 OR2 $T=829560 568400 0 0 $X=829560 $Y=568020
X1980 2671 685 2 1 2683 OR2 $T=833280 568400 0 0 $X=833280 $Y=568020
X1981 618 690 2 1 2668 OR2 $T=838860 598640 1 180 $X=836380 $Y=598260
X1982 688 2673 2 1 2685 OR2 $T=838240 568400 1 0 $X=838240 $Y=562980
X1983 2757 703 2 1 2720 OR2 $T=853120 568400 1 180 $X=850640 $Y=568020
X1984 600 634 2 1 2762 OR2 $T=851260 598640 1 0 $X=851260 $Y=593220
X1985 700 2742 2 1 2739 OR2 $T=854360 558320 1 180 $X=851880 $Y=557940
X1986 618 2762 2 1 2777 OR2 $T=859940 598640 1 180 $X=857460 $Y=598260
X1987 2779 707 2 1 2774 OR2 $T=861180 558320 0 180 $X=858700 $Y=552900
X1988 618 2762 2 1 708 OR2 $T=862420 598640 1 180 $X=859940 $Y=598260
X1989 660 2780 2 1 2797 OR2 $T=863040 548240 0 180 $X=860560 $Y=542820
X1990 2798 715 2 1 2808 OR2 $T=863660 568400 1 0 $X=863660 $Y=562980
X1991 2822 726 2 1 2836 OR2 $T=871100 578480 1 0 $X=871100 $Y=573060
X1992 2783 727 2 1 2842 OR2 $T=872960 568400 0 0 $X=872960 $Y=568020
X1993 811 3065 2 1 3066 OR2 $T=945500 558320 1 0 $X=945500 $Y=552900
X1994 3104 817 2 1 3094 OR2 $T=957280 558320 1 180 $X=954800 $Y=557940
X1995 3165 841 2 1 3185 OR2 $T=980220 568400 1 0 $X=980220 $Y=562980
X1996 3233 859 2 1 3238 OR2 $T=995720 558320 0 0 $X=995720 $Y=557940
X1997 3241 861 2 1 3240 OR2 $T=1000680 568400 1 180 $X=998200 $Y=568020
X1998 660 3215 2 1 3277 OR2 $T=1009360 548240 0 0 $X=1009360 $Y=547860
X1999 3408 912 2 1 3402 OR2 $T=1055860 588560 0 180 $X=1053380 $Y=583140
X2000 920 3434 2 1 3441 OR2 $T=1060820 578480 0 0 $X=1060820 $Y=578100
X2001 385 1920 1897 2 1 2077 OR3S $T=611320 528080 1 0 $X=611320 $Y=522660
X2002 385 2026 2017 2 1 2090 OR3S $T=615660 578480 1 0 $X=615660 $Y=573060
X2003 660 3261 2 1 3263 OR2S $T=1004400 558320 0 0 $X=1004400 $Y=557940
X2004 2257 2258 446 2 1 544 OA12S $T=704320 558320 0 0 $X=704320 $Y=557940
X2005 1892 1895 1896 1899 2 1891 1 AOI13HS $T=516460 578480 1 0 $X=516460 $Y=573060
X2006 1898 1897 1894 1901 2 1800 1 AOI13HS $T=518320 528080 0 0 $X=518320 $Y=527700
X2007 2015 2017 2016 2000 2 238 1 AOI13HS $T=588380 578480 0 180 $X=584660 $Y=573060
X2008 2187 501 2206 2190 2 2168 1 AOI13HS $T=682620 528080 1 180 $X=678900 $Y=527700
X2009 2254 540 2250 2248 2 2240 1 AOI13HS $T=704940 538160 0 180 $X=701220 $Y=532740
X2010 1416 120 1 1395 1421 120 2 MOAI1 $T=343480 598640 0 0 $X=343480 $Y=598260
X2011 1718 1657 1 1723 1692 1657 2 MOAI1 $T=424700 558320 1 0 $X=424700 $Y=552900
X2012 2211 472 1 476 521 2227 2 MOAI1 $T=691300 598640 1 0 $X=691300 $Y=593220
X2013 472 2217 1 474 526 2227 2 MOAI1 $T=691920 588560 0 0 $X=691920 $Y=588180
X2014 472 2186 1 465 528 2227 2 MOAI1 $T=693160 578480 1 0 $X=693160 $Y=573060
X2015 472 2194 1 478 525 2227 2 MOAI1 $T=693780 588560 1 0 $X=693780 $Y=583140
X2016 2788 669 1 669 2863 2862 2 MOAI1 $T=876680 538160 0 0 $X=876680 $Y=537780
X2017 2820 669 1 2935 2889 669 2 MOAI1 $T=900860 548240 0 0 $X=900860 $Y=547860
X2018 3235 3243 1 3243 872 3260 2 MOAI1 $T=1006260 568400 0 0 $X=1006260 $Y=568020
X2019 3234 3239 1 3272 873 3274 2 MOAI1 $T=1006880 558320 0 0 $X=1006880 $Y=557940
X2020 1085 1030 1 1102 2 AN2S $T=254200 588560 0 0 $X=254200 $Y=588180
X2021 3489 938 1 3491 2 AN2S $T=1081900 598640 1 0 $X=1081900 $Y=593220
X2022 1259 1258 2 1 1190 1244 MUX2 $T=300700 568400 0 180 $X=296360 $Y=562980
X2023 1261 1258 2 1 1199 1279 MUX2 $T=302560 568400 0 0 $X=302560 $Y=568020
X2024 1264 1258 2 1 1253 1283 MUX2 $T=303800 578480 1 0 $X=303800 $Y=573060
X2025 1286 1258 2 1 1274 1300 MUX2 $T=308760 568400 1 0 $X=308760 $Y=562980
X2026 1313 1323 2 1 1228 1336 MUX2 $T=317440 568400 1 0 $X=317440 $Y=562980
X2027 1317 1323 2 1 1256 1337 MUX2 $T=317440 568400 0 0 $X=317440 $Y=568020
X2028 1305 98 2 1 1304 1338 MUX2 $T=317440 578480 0 0 $X=317440 $Y=578100
X2029 1302 98 2 1 1295 1339 MUX2 $T=318060 578480 1 0 $X=318060 $Y=573060
X2030 102 99 2 1 1339 107 MUX2 $T=325500 588560 0 180 $X=321160 $Y=583140
X2031 107 99 2 1 1338 1354 MUX2 $T=321160 588560 0 0 $X=321160 $Y=588180
X2032 1228 1258 2 1 1308 1357 MUX2 $T=323020 568400 1 0 $X=323020 $Y=562980
X2033 1339 98 2 1 1336 1359 MUX2 $T=323020 578480 0 0 $X=323020 $Y=578100
X2034 1338 98 2 1 1337 1363 MUX2 $T=325500 588560 1 0 $X=325500 $Y=583140
X2035 1354 99 2 1 1359 1364 MUX2 $T=325500 588560 0 0 $X=325500 $Y=588180
X2036 1336 1323 2 1 1244 1375 MUX2 $T=328600 568400 1 0 $X=328600 $Y=562980
X2037 1256 1258 2 1 1361 1376 MUX2 $T=328600 568400 0 0 $X=328600 $Y=568020
X2038 1359 98 2 1 1368 1378 MUX2 $T=330460 588560 1 0 $X=330460 $Y=583140
X2039 1364 99 2 1 1363 1382 MUX2 $T=332320 588560 0 0 $X=332320 $Y=588180
X2040 1363 98 2 1 1358 1406 MUX2 $T=335420 588560 1 0 $X=335420 $Y=583140
X2041 1368 1323 2 1 1283 1403 MUX2 $T=336660 578480 0 0 $X=336660 $Y=578100
X2042 1382 99 2 1 1378 1399 MUX2 $T=336660 588560 0 0 $X=336660 $Y=588180
X2043 1337 1323 2 1 1279 1410 MUX2 $T=337900 578480 1 0 $X=337900 $Y=573060
X2044 1399 99 2 1 1406 1420 MUX2 $T=341000 588560 0 0 $X=341000 $Y=588180
X2045 1406 1411 2 1 1410 1457 MUX2 $T=342240 578480 0 0 $X=342240 $Y=578100
X2046 1378 1411 2 1 1375 1442 MUX2 $T=342860 588560 1 0 $X=342860 $Y=583140
X2047 1191 1258 2 1 1372 1436 MUX2 $T=343480 578480 1 0 $X=343480 $Y=573060
X2048 1420 99 2 1 1442 1439 MUX2 $T=345340 588560 0 0 $X=345340 $Y=588180
X2049 1375 1263 2 1 1357 1447 MUX2 $T=347200 568400 1 0 $X=347200 $Y=562980
X2050 1410 1263 2 1 1376 1455 MUX2 $T=348440 578480 1 0 $X=348440 $Y=573060
X2051 1439 99 2 1 1457 1460 MUX2 $T=349680 588560 0 0 $X=349680 $Y=588180
X2052 1442 1411 2 1 1403 1461 MUX2 $T=350300 588560 1 0 $X=350300 $Y=583140
X2053 1457 1411 2 1 1405 1471 MUX2 $T=353400 578480 1 0 $X=353400 $Y=573060
X2054 1460 99 2 1 1461 1477 MUX2 $T=354020 588560 0 0 $X=354020 $Y=588180
X2055 1461 1411 2 1 1447 1487 MUX2 $T=354640 578480 0 0 $X=354640 $Y=578100
X2056 1244 1258 2 1 1493 1492 MUX2 $T=361460 568400 1 0 $X=361460 $Y=562980
X2057 1543 99 2 1 1523 1509 MUX2 $T=376960 588560 1 0 $X=376960 $Y=583140
X2058 1279 1258 2 1 1561 1565 MUX2 $T=377580 568400 0 0 $X=377580 $Y=568020
X2059 1449 1258 2 1 1610 1509 MUX2 $T=388740 568400 0 0 $X=388740 $Y=568020
X2060 206 198 2 1 1758 202 MUX2 $T=451360 518000 1 180 $X=447020 $Y=517620
X2061 1772 60 2 1 1767 1653 MUX2 $T=454460 558320 1 180 $X=450120 $Y=557940
X2062 1787 60 2 1 1763 1591 MUX2 $T=455080 538160 0 180 $X=450740 $Y=532740
X2063 1755 60 2 1 1770 1506 MUX2 $T=455700 548240 1 180 $X=451360 $Y=547860
X2064 1736 198 2 1 1780 215 MUX2 $T=456320 528080 0 0 $X=456320 $Y=527700
X2065 1747 60 2 1 1786 1687 MUX2 $T=462520 568400 1 180 $X=458180 $Y=568020
X2066 1787 60 2 1 1790 1736 MUX2 $T=463760 538160 0 180 $X=459420 $Y=532740
X2067 1677 198 2 1 1797 218 MUX2 $T=460660 528080 0 0 $X=460660 $Y=527700
X2068 1787 60 2 1 1750 1661 MUX2 $T=466240 538160 1 180 $X=461900 $Y=537780
X2069 1805 60 2 1 1798 1772 MUX2 $T=469960 568400 1 180 $X=465620 $Y=568020
X2070 1787 60 2 1 222 1677 MUX2 $T=471820 538160 0 180 $X=467480 $Y=532740
X2071 1801 60 2 1 1814 224 MUX2 $T=471820 578480 0 0 $X=471820 $Y=578100
X2072 1801 60 2 1 1803 1794 MUX2 $T=476160 588560 1 180 $X=471820 $Y=588180
X2073 1801 60 2 1 1818 1747 MUX2 $T=483600 588560 0 180 $X=479260 $Y=583140
X2074 451 446 2 1 2140 454 MUX2 $T=644800 518000 0 0 $X=644800 $Y=517620
X2075 451 446 2 1 2159 457 MUX2 $T=667740 518000 1 180 $X=663400 $Y=517620
X2076 451 446 2 1 2166 429 MUX2 $T=665880 518000 1 0 $X=665880 $Y=512580
X2077 2275 446 2 1 2262 2271 MUX2 $T=717960 558320 0 180 $X=713620 $Y=552900
X2078 2275 446 2 1 2286 566 MUX2 $T=717340 538160 0 0 $X=717340 $Y=537780
X2079 2275 446 2 1 2288 567 MUX2 $T=717340 548240 1 0 $X=717340 $Y=542820
X2080 2398 600 2 1 583 595 MUX2 $T=758260 598640 1 180 $X=753920 $Y=598260
X2081 2406 600 2 1 2343 595 MUX2 $T=761360 598640 0 180 $X=757020 $Y=593220
X2082 2420 600 2 1 579 595 MUX2 $T=763840 598640 1 180 $X=759500 $Y=598260
X2083 2434 600 2 1 2366 595 MUX2 $T=765700 598640 0 180 $X=761360 $Y=593220
X2084 2440 600 2 1 2364 2421 MUX2 $T=768800 588560 1 180 $X=764460 $Y=588180
X2085 2478 600 2 1 2382 2467 MUX2 $T=778720 588560 1 180 $X=774380 $Y=588180
X2086 617 618 2 1 2479 595 MUX2 $T=775620 598640 0 0 $X=775620 $Y=598260
X2087 2433 2489 2 1 2513 2454 MUX2 $T=784920 538160 0 0 $X=784920 $Y=537780
X2088 2526 2525 2 1 2458 2454 MUX2 $T=791120 538160 0 180 $X=786780 $Y=532740
X2089 2547 2525 2 1 2430 2454 MUX2 $T=791740 528080 0 180 $X=787400 $Y=522660
X2090 2498 2527 2 1 2514 2513 MUX2 $T=791740 548240 0 180 $X=787400 $Y=542820
X2091 2513 2527 2 1 2533 2454 MUX2 $T=791740 538160 0 0 $X=791740 $Y=537780
X2092 2559 2525 2 1 2474 2549 MUX2 $T=801040 538160 0 180 $X=796700 $Y=532740
X2093 2570 2525 2 1 2445 2454 MUX2 $T=804140 528080 1 180 $X=799800 $Y=527700
X2094 2578 2525 2 1 2452 2454 MUX2 $T=806620 528080 0 180 $X=802280 $Y=522660
X2095 2502 2527 2 1 2574 2454 MUX2 $T=802900 538160 0 0 $X=802900 $Y=537780
X2096 2593 2446 2 1 2503 637 MUX2 $T=810340 598640 0 180 $X=806000 $Y=593220
X2097 2597 2525 2 1 2486 2582 MUX2 $T=811580 528080 1 180 $X=807240 $Y=527700
X2098 654 618 2 1 2592 651 MUX2 $T=815300 598640 1 180 $X=810960 $Y=598260
X2099 2621 600 2 1 2590 2440 MUX2 $T=815920 588560 1 180 $X=811580 $Y=588180
X2100 2615 2446 2 1 2519 645 MUX2 $T=815920 598640 0 180 $X=811580 $Y=593220
X2101 2618 620 2 1 2602 2591 MUX2 $T=816540 548240 1 180 $X=812200 $Y=547860
X2102 2626 600 2 1 2611 2478 MUX2 $T=819020 588560 0 180 $X=814680 $Y=583140
X2103 2630 620 2 1 2619 2618 MUX2 $T=820880 548240 0 180 $X=816540 $Y=542820
X2104 663 618 2 1 2575 658 MUX2 $T=820880 598640 1 180 $X=816540 $Y=598260
X2105 2634 634 2 1 2583 2575 MUX2 $T=821500 598640 0 180 $X=817160 $Y=593220
X2106 2619 2616 2 1 2622 2577 MUX2 $T=822120 538160 0 180 $X=817780 $Y=532740
X2107 2638 634 2 1 2542 2592 MUX2 $T=822120 588560 1 180 $X=817780 $Y=588180
X2108 2633 660 2 1 2632 2602 MUX2 $T=825220 538160 1 180 $X=820880 $Y=537780
X2109 2645 620 2 1 2633 2630 MUX2 $T=825220 548240 0 180 $X=820880 $Y=542820
X2110 2649 634 2 1 2626 2615 MUX2 $T=826460 588560 1 180 $X=822120 $Y=588180
X2111 2647 2520 2 1 2596 2617 MUX2 $T=827080 528080 0 180 $X=822740 $Y=522660
X2112 2644 2520 2 1 2551 2607 MUX2 $T=827080 528080 1 180 $X=822740 $Y=527700
X2113 671 618 2 1 2593 654 MUX2 $T=827700 598640 0 180 $X=823360 $Y=593220
X2114 676 618 2 1 2615 663 MUX2 $T=828320 598640 1 180 $X=823980 $Y=598260
X2115 2646 2616 2 1 2644 2619 MUX2 $T=828940 538160 0 180 $X=824600 $Y=532740
X2116 2657 620 2 1 2646 2645 MUX2 $T=829560 548240 0 180 $X=825220 $Y=542820
X2117 2660 660 2 1 2647 2633 MUX2 $T=830180 538160 1 180 $X=825840 $Y=537780
X2118 2666 2669 2 1 670 2559 MUX2 $T=830800 518000 1 180 $X=826460 $Y=517620
X2119 2656 2669 2 1 674 2597 MUX2 $T=832660 528080 0 180 $X=828320 $Y=522660
X2120 2667 2520 2 1 2567 2622 MUX2 $T=832660 528080 1 180 $X=828320 $Y=527700
X2121 2678 2520 2 1 2656 2647 MUX2 $T=833280 538160 0 180 $X=828940 $Y=532740
X2122 2674 620 2 1 2662 2661 MUX2 $T=833900 548240 0 180 $X=829560 $Y=542820
X2123 2661 620 2 1 2660 2657 MUX2 $T=833900 548240 1 180 $X=829560 $Y=547860
X2124 683 618 2 1 2638 671 MUX2 $T=833900 598640 0 180 $X=829560 $Y=593220
X2125 2662 660 2 1 2667 2646 MUX2 $T=834520 538160 1 180 $X=830180 $Y=537780
X2126 2670 600 2 1 2680 2519 MUX2 $T=830800 578480 0 0 $X=830800 $Y=578100
X2127 686 618 2 1 2634 676 MUX2 $T=835140 598640 1 180 $X=830800 $Y=598260
X2128 2682 2669 2 1 680 2555 MUX2 $T=835760 518000 1 180 $X=831420 $Y=517620
X2129 2679 2669 2 1 693 2596 MUX2 $T=834520 528080 1 0 $X=834520 $Y=522660
X2130 2690 600 2 1 2681 2493 MUX2 $T=838860 588560 0 180 $X=834520 $Y=583140
X2131 2698 2520 2 1 2666 2644 MUX2 $T=839480 528080 1 180 $X=835140 $Y=527700
X2132 2694 634 2 1 2621 2593 MUX2 $T=839480 598640 0 180 $X=835140 $Y=593220
X2133 2700 2669 2 1 689 2601 MUX2 $T=841960 518000 1 180 $X=837620 $Y=517620
X2134 2696 600 2 1 2711 2542 MUX2 $T=839480 578480 0 0 $X=839480 $Y=578100
X2135 2712 618 2 1 2694 683 MUX2 $T=844440 598640 0 180 $X=840100 $Y=593220
X2136 2707 2669 2 1 698 2551 MUX2 $T=843820 518000 0 0 $X=843820 $Y=517620
X2137 2744 600 2 1 2713 2503 MUX2 $T=848780 588560 1 180 $X=844440 $Y=588180
X2138 2727 2669 2 1 2748 2567 MUX2 $T=846300 528080 1 0 $X=846300 $Y=522660
X2139 3018 600 2 1 2981 3004 MUX2 $T=930620 588560 1 180 $X=926280 $Y=588180
X2140 3019 600 2 1 2973 3004 MUX2 $T=931240 598640 0 180 $X=926900 $Y=593220
X2141 3025 600 2 1 3009 3004 MUX2 $T=935580 588560 1 180 $X=931240 $Y=588180
X2142 798 702 2 1 3028 3004 MUX2 $T=931860 598640 1 0 $X=931860 $Y=593220
X2143 3052 600 2 1 3021 3004 MUX2 $T=941160 588560 0 180 $X=936820 $Y=583140
X2144 3028 618 2 1 3050 3004 MUX2 $T=936820 588560 0 0 $X=936820 $Y=588180
X2145 804 618 2 1 3051 3028 MUX2 $T=937440 598640 1 0 $X=937440 $Y=593220
X2146 802 618 2 1 3080 3004 MUX2 $T=943020 598640 0 0 $X=943020 $Y=598260
X2147 3026 620 2 1 3087 3038 MUX2 $T=948600 548240 1 0 $X=948600 $Y=542820
X2148 3087 660 2 1 3108 3038 MUX2 $T=953560 538160 0 0 $X=953560 $Y=537780
X2149 3077 660 2 1 3110 3087 MUX2 $T=954180 548240 1 0 $X=954180 $Y=542820
X2150 823 618 2 1 3092 814 MUX2 $T=959760 598640 1 180 $X=955420 $Y=598260
X2151 3113 3089 2 1 799 3038 MUX2 $T=960380 518000 1 180 $X=956040 $Y=517620
X2152 3117 620 2 1 3103 3097 MUX2 $T=961620 558320 0 180 $X=957280 $Y=552900
X2153 3136 620 2 1 3125 3117 MUX2 $T=967200 548240 1 180 $X=962860 $Y=547860
X2154 3084 660 2 1 3154 3038 MUX2 $T=964100 538160 1 0 $X=964100 $Y=532740
X2155 836 3063 2 1 3088 820 MUX2 $T=970920 598640 1 180 $X=966580 $Y=598260
X2156 3140 620 2 1 3138 3136 MUX2 $T=971540 548240 1 180 $X=967200 $Y=547860
X2157 3125 660 2 1 3159 3090 MUX2 $T=970300 548240 1 0 $X=970300 $Y=542820
X2158 3158 620 2 1 3151 3140 MUX2 $T=975260 558320 0 180 $X=970920 $Y=552900
X2159 838 3063 2 1 3152 834 MUX2 $T=975260 598640 0 180 $X=970920 $Y=593220
X2160 3138 660 2 1 3144 3103 MUX2 $T=975880 548240 1 180 $X=971540 $Y=547860
X2161 843 3063 2 1 3120 3131 MUX2 $T=976500 598640 1 180 $X=972160 $Y=598260
X2162 3171 3121 2 1 3137 3122 MUX2 $T=978360 538160 0 180 $X=974020 $Y=532740
X2163 3180 620 2 1 3164 3158 MUX2 $T=979600 558320 0 180 $X=975260 $Y=552900
X2164 3184 3121 2 1 3156 3146 MUX2 $T=980220 538160 1 180 $X=975880 $Y=537780
X2165 3151 660 2 1 3184 3125 MUX2 $T=975880 548240 1 0 $X=975880 $Y=542820
X2166 3164 660 2 1 3171 3138 MUX2 $T=981460 548240 1 180 $X=977120 $Y=547860
X2167 846 634 2 1 3176 3092 MUX2 $T=982080 598640 1 180 $X=977740 $Y=598260
X2168 3196 620 2 1 3182 3180 MUX2 $T=983940 558320 0 180 $X=979600 $Y=552900
X2169 3182 660 2 1 3189 3151 MUX2 $T=985800 548240 0 180 $X=981460 $Y=542820
X2170 3193 3121 2 1 3179 3144 MUX2 $T=986420 538160 1 180 $X=982080 $Y=537780
X2171 3209 660 2 1 3193 3164 MUX2 $T=987040 548240 1 180 $X=982700 $Y=547860
X2172 3199 3187 2 1 3170 3019 MUX2 $T=987660 598640 0 180 $X=983320 $Y=593220
X2173 853 634 2 1 3199 836 MUX2 $T=988280 598640 1 180 $X=983940 $Y=598260
X2174 3213 3121 2 1 3200 3171 MUX2 $T=990760 538160 0 180 $X=986420 $Y=532740
X2175 3208 3219 2 1 3201 3098 MUX2 $T=992000 528080 1 180 $X=987660 $Y=527700
X2176 3216 3121 2 1 3208 3184 MUX2 $T=992000 538160 1 180 $X=987660 $Y=537780
X2177 3207 620 2 1 3209 3196 MUX2 $T=992000 558320 0 180 $X=987660 $Y=552900
X2178 3200 3219 2 1 849 3115 MUX2 $T=993240 528080 0 180 $X=988900 $Y=522660
X2179 3222 660 2 1 3213 3209 MUX2 $T=993240 548240 1 180 $X=988900 $Y=547860
X2180 3223 3187 2 1 3214 3025 MUX2 $T=993240 598640 0 180 $X=988900 $Y=593220
X2181 3218 660 2 1 3216 3182 MUX2 $T=995720 548240 0 180 $X=991380 $Y=542820
X2182 3225 620 2 1 3218 3207 MUX2 $T=996340 558320 0 180 $X=992000 $Y=552900
X2183 3242 3219 2 1 857 3119 MUX2 $T=998200 528080 0 180 $X=993860 $Y=522660
X2184 3220 3121 2 1 3242 3193 MUX2 $T=993860 538160 0 0 $X=993860 $Y=537780
X2185 3237 3121 2 1 3229 3189 MUX2 $T=998820 538160 0 180 $X=994480 $Y=532740
X2186 3226 620 2 1 3222 3225 MUX2 $T=1000680 558320 0 180 $X=996340 $Y=552900
X2187 3248 3187 2 1 3228 3052 MUX2 $T=1000680 588560 1 180 $X=996340 $Y=588180
X2188 3256 660 2 1 3237 3218 MUX2 $T=1001920 548240 0 180 $X=997580 $Y=542820
X2189 3247 3219 2 1 860 3156 MUX2 $T=1003780 528080 0 180 $X=999440 $Y=522660
X2190 3258 3121 2 1 3246 3213 MUX2 $T=1003780 528080 1 180 $X=999440 $Y=527700
X2191 3259 3121 2 1 3247 3216 MUX2 $T=1003780 538160 0 180 $X=999440 $Y=532740
X2192 863 620 2 1 3256 3226 MUX2 $T=1000680 558320 1 0 $X=1000680 $Y=552900
X2193 868 634 2 1 3248 838 MUX2 $T=1005640 598640 1 180 $X=1001300 $Y=598260
X2194 870 3187 2 1 3255 3072 MUX2 $T=1006260 588560 1 180 $X=1001920 $Y=588180
X2195 3264 3219 2 1 867 3200 MUX2 $T=1008120 518000 1 180 $X=1003780 $Y=517620
X2196 874 3187 2 1 3265 3223 MUX2 $T=1011220 598640 1 180 $X=1006880 $Y=598260
X2197 3275 3219 2 1 3267 3208 MUX2 $T=1011840 528080 1 180 $X=1007500 $Y=527700
X2198 875 3187 2 1 3270 3088 MUX2 $T=1012460 588560 1 180 $X=1008120 $Y=588180
X2199 3271 3219 2 1 3279 3188 MUX2 $T=1008740 518000 0 0 $X=1008740 $Y=517620
X2200 3246 3219 2 1 882 3137 MUX2 $T=1012460 528080 1 0 $X=1012460 $Y=522660
X2201 3281 3219 2 1 3289 3179 MUX2 $T=1013080 528080 0 0 $X=1013080 $Y=527700
X2202 3283 634 2 1 883 854 MUX2 $T=1013080 598640 1 0 $X=1013080 $Y=593220
X2203 883 3187 2 1 3284 3120 MUX2 $T=1018040 588560 1 180 $X=1013700 $Y=588180
X2204 885 3187 2 1 3294 3199 MUX2 $T=1023000 598640 0 180 $X=1018660 $Y=593220
X2205 3296 3187 2 1 3302 3152 MUX2 $T=1019280 588560 0 0 $X=1019280 $Y=588180
X2206 3325 3187 2 1 3344 3176 MUX2 $T=1029820 588560 0 0 $X=1029820 $Y=588180
X2207 67 2 1207 1215 1 AN2B1S $T=296980 598640 0 180 $X=293880 $Y=593220
X2208 784 2 785 787 1 AN2B1S $T=923800 518000 1 0 $X=923800 $Y=512580
X2209 2017 399 2 2094 2026 1 OR3B2S $T=620620 568400 0 180 $X=616900 $Y=562980
X2210 1032 1055 2 1050 1039 1 1067 FA1 $T=233120 558320 1 0 $X=233120 $Y=552900
X2211 1531 159 2 1560 1579 1 1490 FA1 $T=388740 518000 0 180 $X=373240 $Y=512580
X2212 1594 172 2 1634 176 1 1579 FA1 $T=412920 518000 0 180 $X=397420 $Y=512580
X2213 1704 1668 2 1730 1738 1 1720 FA1 $T=440820 568400 1 180 $X=425320 $Y=568020
X2214 1702 190 2 1713 1695 1 197 FA1 $T=425320 598640 0 0 $X=425320 $Y=598260
X2215 1715 1651 2 1743 1720 1 1751 FA1 $T=428420 578480 1 0 $X=428420 $Y=573060
X2216 1693 1701 2 1753 1722 1 1738 FA1 $T=432140 558320 0 0 $X=432140 $Y=557940
X2217 213 1703 2 1764 1781 1 1752 FA1 $T=458800 578480 1 180 $X=443300 $Y=578100
X2218 1754 1711 2 1778 1751 1 1781 FA1 $T=443920 578480 1 0 $X=443920 $Y=573060
X2219 1988 1943 2 1904 325 1 1968 FA1 $T=571020 518000 0 180 $X=555520 $Y=512580
X2220 2268 2292 2 571 2300 1 2294 FA1 $T=712380 588560 0 0 $X=712380 $Y=588180
X2221 2266 2308 2 2305 2293 1 2319 FA1 $T=720440 538160 1 0 $X=720440 $Y=532740
X2222 2313 2304 2 2302 2317 1 2293 FA1 $T=738420 518000 1 180 $X=722920 $Y=517620
X2223 2342 2376 2 2381 2370 1 2345 FA1 $T=742760 538160 1 0 $X=742760 $Y=532740
X2224 2914 743 2 744 754 1 2858 FA1 $T=893420 598640 1 180 $X=877920 $Y=598260
X2225 2919 748 2 2849 2895 1 2847 FA1 $T=894040 588560 0 180 $X=878540 $Y=583140
X2226 2925 2864 2 2878 2869 1 2865 FA1 $T=895900 538160 0 180 $X=880400 $Y=532740
X2227 2928 2880 2 2863 2911 1 2869 FA1 $T=897140 548240 0 180 $X=881640 $Y=542820
X2228 2933 2876 2 2893 2898 1 2872 FA1 $T=897760 568400 0 180 $X=882260 $Y=562980
X2229 2960 2933 2 2914 2953 1 2918 FA1 $T=908920 568400 1 180 $X=893420 $Y=568020
X2230 2922 2949 2 2940 2918 1 2954 FA1 $T=895280 558320 0 0 $X=895280 $Y=557940
X2231 2946 2987 2 777 2993 1 2996 FA1 $T=907680 568400 1 0 $X=907680 $Y=562980
X2232 2991 2961 2 775 2996 1 2967 FA1 $T=925040 578480 0 180 $X=909540 $Y=573060
X2233 2971 2992 2 2991 2962 1 2994 FA1 $T=910780 538160 1 0 $X=910780 $Y=532740
X2234 783 3022 2 800 3031 1 3012 FA1 $T=923180 568400 1 0 $X=923180 $Y=562980
X2235 772 3037 2 3020 796 1 3015 FA1 $T=928140 518000 0 0 $X=928140 $Y=517620
X2236 891 3291 2 879 3317 1 3282 FA1 $T=1027960 578480 0 180 $X=1012460 $Y=573060
X2237 910 3361 2 903 3373 1 3328 FA1 $T=1051520 578480 1 180 $X=1036020 $Y=578100
X2238 1019 14 5 2 1 1005 XOR3S $T=232500 588560 0 180 $X=221340 $Y=583140
X2239 33 1066 1076 2 1 1072 XOR3S $T=256680 538160 0 180 $X=245520 $Y=532740
X2240 1706 1795 1752 2 1 1774 XOR3S $T=465620 588560 0 180 $X=454460 $Y=583140
X2241 368 2045 354 2 1 2022 XOR3S $T=602020 518000 1 180 $X=590860 $Y=517620
X2242 1018 1026 1017 1024 1 2 ND3P $T=223200 548240 1 0 $X=223200 $Y=542820
X2243 1054 1066 1043 1059 1 2 ND3P $T=238080 538160 1 0 $X=238080 $Y=532740
X2244 1061 1039 1080 1065 1 2 ND3P $T=248000 568400 0 180 $X=243040 $Y=562980
X2245 1068 1056 1075 1078 1 2 ND3P $T=243040 568400 0 0 $X=243040 $Y=568020
X2246 1071 1092 1070 1083 1 2 ND3P $T=246140 548240 0 0 $X=246140 $Y=547860
X2247 1154 51 1142 55 1 2 ND3P $T=279000 598640 1 180 $X=274040 $Y=598260
X2248 1158 1133 1152 1167 1 2 ND3P $T=275900 558320 0 0 $X=275900 $Y=557940
X2249 1173 1177 1164 1168 1 2 ND3P $T=279620 578480 0 0 $X=279620 $Y=578100
X2250 1272 1208 1288 1266 1 2 ND3P $T=308760 518000 1 180 $X=303800 $Y=517620
X2251 1275 1321 1297 1293 1 2 ND3P $T=311860 598640 0 0 $X=311860 $Y=598260
X2252 1670 1603 1667 1666 1 2 ND3P $T=415400 518000 1 180 $X=410440 $Y=517620
X2253 1682 1675 1679 1690 1 2 ND3P $T=414780 518000 1 0 $X=414780 $Y=512580
X2254 1745 203 1756 1757 1 2 ND3P $T=442680 598640 1 0 $X=442680 $Y=593220
X2255 2035 332 2052 2064 1 2 ND3P $T=611940 518000 0 180 $X=606980 $Y=512580
X2256 2084 383 2089 387 1 2 ND3P $T=616900 518000 0 180 $X=611940 $Y=512580
X2257 2330 2285 2333 2324 1 2 ND3P $T=741520 578480 1 180 $X=736560 $Y=578100
X2258 2409 2399 2418 2404 1 2 ND3P $T=765080 518000 0 180 $X=760120 $Y=512580
X2259 2884 2895 2877 2892 1 2 ND3P $T=883500 588560 0 0 $X=883500 $Y=588180
X2260 2894 2911 2890 2903 1 2 ND3P $T=887220 558320 1 0 $X=887220 $Y=552900
X2261 2906 2923 2913 2915 1 2 ND3P $T=889700 538160 0 0 $X=889700 $Y=537780
X2262 2924 759 2926 2912 1 2 ND3P $T=898380 528080 0 180 $X=893420 $Y=522660
X2263 2944 2932 2947 2952 1 2 ND3P $T=901480 548240 1 0 $X=901480 $Y=542820
X2264 3002 2993 3005 2999 1 2 ND3P $T=927520 558320 1 180 $X=922560 $Y=557940
X2265 3290 3239 3293 3286 1 2 ND3P $T=1019900 568400 0 180 $X=1014940 $Y=562980
X2266 3327 3317 3331 3324 1 2 ND3P $T=1032920 578480 0 180 $X=1027960 $Y=573060
X2267 3375 3386 3372 3367 1 2 ND3P $T=1044080 548240 1 0 $X=1044080 $Y=542820
X2268 3392 3373 3395 3384 1 2 ND3P $T=1052760 588560 0 180 $X=1047800 $Y=583140
X2269 3456 3461 3454 3465 1 2 ND3P $T=1066400 568400 1 0 $X=1066400 $Y=562980
X2270 3411 915 3424 1 2 OR2P $T=1055860 578480 1 0 $X=1055860 $Y=573060
X2271 13 1028 1 1025 2 OR2B1S $T=226920 568400 0 0 $X=226920 $Y=568020
X2272 1321 1352 1 1365 2 OR2B1S $T=326740 598640 1 0 $X=326740 $Y=593220
X2273 115 117 1 1366 2 OR2B1S $T=326740 598640 0 0 $X=326740 $Y=598260
X2274 1367 1379 1 1392 2 OR2B1S $T=336660 538160 1 0 $X=336660 $Y=532740
X2275 1426 1419 1 1396 2 OR2B1S $T=345960 558320 1 180 $X=342860 $Y=557940
X2276 1475 1467 1 1463 2 OR2B1S $T=358360 548240 1 180 $X=355260 $Y=547860
X2277 1260 1539 1 1514 2 OR2B1S $T=373860 518000 0 0 $X=373860 $Y=517620
X2278 1525 1557 1 1558 2 OR2B1S $T=376960 518000 0 0 $X=376960 $Y=517620
X2279 1564 1552 1 1541 2 OR2B1S $T=380680 548240 1 180 $X=377580 $Y=547860
X2280 1616 1662 1 1633 2 OR2B1S $T=409200 558320 1 180 $X=406100 $Y=557940
X2281 1689 1729 1 1710 2 OR2B1S $T=431520 558320 1 180 $X=428420 $Y=557940
X2282 2331 2339 1 2344 2 OR2B1S $T=745860 528080 1 0 $X=745860 $Y=522660
X2283 599 2386 1 2391 2 OR2B1S $T=761360 568400 1 180 $X=758260 $Y=568020
X2284 2416 2403 1 2401 2 OR2B1S $T=763840 558320 0 0 $X=763840 $Y=557940
X2285 2437 2431 1 2411 2 OR2B1S $T=768180 568400 1 180 $X=765080 $Y=568020
X2286 601 2416 1 2439 2 OR2B1S $T=773140 558320 1 0 $X=773140 $Y=552900
X2287 624 2507 1 2485 2 OR2B1S $T=788640 568400 0 180 $X=785540 $Y=562980
X2288 2541 2536 1 2532 2 OR2B1S $T=794840 578480 0 180 $X=791740 $Y=573060
X2289 633 2545 1 2522 2 OR2B1S $T=797320 568400 0 0 $X=797320 $Y=568020
X2290 2564 2572 1 2565 2 OR2B1S $T=806000 568400 0 180 $X=802900 $Y=562980
X2291 652 2608 1 2604 2 OR2B1S $T=815920 568400 1 180 $X=812820 $Y=568020
X2292 2598 2614 1 2589 2 OR2B1S $T=813440 578480 1 0 $X=813440 $Y=573060
X2293 620 2674 1 2718 2 OR2B1S $T=833900 548240 1 0 $X=833900 $Y=542820
X2294 660 2662 1 2734 2 OR2B1S $T=851880 538160 1 180 $X=848780 $Y=537780
X2295 2848 735 1 740 2 OR2B1S $T=878540 518000 0 0 $X=878540 $Y=517620
X2296 809 3065 1 3054 2 OR2B1S $T=949220 558320 1 180 $X=946120 $Y=557940
X2297 826 3104 1 3111 2 OR2B1S $T=967820 558320 1 180 $X=964720 $Y=557940
X2298 819 3099 1 3139 2 OR2B1S $T=972780 568400 0 180 $X=969680 $Y=562980
X2299 835 3155 1 3157 2 OR2B1S $T=970920 578480 1 0 $X=970920 $Y=573060
X2300 852 3205 1 3212 2 OR2B1S $T=985800 568400 0 0 $X=985800 $Y=568020
X2301 848 3195 1 3186 2 OR2B1S $T=986420 568400 1 0 $X=986420 $Y=562980
X2302 864 3253 1 3257 2 OR2B1S $T=1001300 558320 0 0 $X=1001300 $Y=557940
X2303 896 3369 1 3365 2 OR2B1S $T=1042220 578480 1 0 $X=1042220 $Y=573060
X2304 3357 3378 1 3381 2 OR2B1S $T=1045320 578480 1 0 $X=1045320 $Y=573060
X2305 927 3470 1 3453 2 OR2B1S $T=1069500 588560 0 0 $X=1069500 $Y=588180
X2306 1003 1002 1007 1 2 1011 1003 1015 999 ICV_9 $T=220720 578480 1 0 $X=220720 $Y=573060
X2307 1001 1000 1009 1 2 1012 1009 1016 999 ICV_9 $T=220720 578480 0 0 $X=220720 $Y=578100
X2308 1069 1055 1074 1 2 1077 1069 1079 999 ICV_9 $T=244900 558320 0 0 $X=244900 $Y=557940
X2309 1099 1090 1107 1 2 1101 1099 1079 999 ICV_9 $T=256060 568400 0 0 $X=256060 $Y=568020
X2310 1105 1074 1111 1 2 1112 1120 1111 999 ICV_9 $T=257300 558320 0 0 $X=257300 $Y=557940
X2311 1316 1315 1319 1 2 1324 1342 1316 999 ICV_9 $T=316200 538160 0 0 $X=316200 $Y=537780
X2312 1319 1324 1303 1 2 1315 1330 1303 999 ICV_9 $T=316820 538160 1 0 $X=316820 $Y=532740
X2313 1514 1515 1525 1 2 1531 1532 1260 999 ICV_9 $T=370140 518000 0 0 $X=370140 $Y=517620
X2314 1567 1588 1592 1 2 1597 1577 1601 999 ICV_9 $T=388740 538160 0 0 $X=388740 $Y=537780
X2315 1599 1576 1604 1 2 165 1599 166 999 ICV_9 $T=390600 598640 0 0 $X=390600 $Y=598260
X2316 1864 2039 2023 1 2 1871 2044 2023 999 ICV_9 $T=597060 538160 1 0 $X=597060 $Y=532740
X2317 1822 2103 2085 1 2 1807 2108 2085 999 ICV_9 $T=623100 568400 1 0 $X=623100 $Y=562980
X2318 1826 2106 2085 1 2 226 2114 2085 999 ICV_9 $T=624340 578480 1 0 $X=624340 $Y=573060
X2319 2485 2476 2483 1 2 2485 2490 2484 999 ICV_9 $T=779340 568400 1 0 $X=779340 $Y=562980
X2320 2557 2539 2564 1 2 2568 2558 2564 999 ICV_9 $T=800420 568400 0 0 $X=800420 $Y=568020
X2321 2685 2710 2708 1 2 2720 2688 2733 999 ICV_9 $T=843200 558320 0 0 $X=843200 $Y=557940
X2322 2706 2699 660 1 2 699 2724 620 999 ICV_9 $T=846920 548240 1 0 $X=846920 $Y=542820
X2323 2739 2749 2755 1 2 700 2755 2742 999 ICV_9 $T=851260 558320 1 0 $X=851260 $Y=552900
X2324 2784 2828 585 1 2 2830 2839 2639 999 ICV_9 $T=870480 598640 0 0 $X=870480 $Y=598260
X2325 2845 2850 2842 1 2 2842 2843 2857 999 ICV_9 $T=877300 578480 1 0 $X=877300 $Y=573060
X2326 2881 2884 753 1 2 2902 2904 2908 999 ICV_9 $T=888460 588560 0 0 $X=888460 $Y=588180
X2327 2901 2902 757 1 2 751 2908 2856 999 ICV_9 $T=889700 598640 1 0 $X=889700 $Y=593220
X2328 2950 2968 772 1 2 2975 2979 2980 999 ICV_9 $T=912020 528080 0 0 $X=912020 $Y=527700
X2329 3007 782 792 1 2 793 3007 795 999 ICV_9 $T=926900 518000 1 0 $X=926900 $Y=512580
X2330 2997 3005 790 1 2 3012 3002 3016 999 ICV_9 $T=927520 558320 0 0 $X=927520 $Y=557940
X2331 3111 3109 3114 1 2 3104 3116 826 999 ICV_9 $T=958520 568400 0 0 $X=958520 $Y=568020
X2332 3135 3134 3139 1 2 3143 3135 819 999 ICV_9 $T=965960 568400 1 0 $X=965960 $Y=562980
X2333 3142 831 3127 1 2 3139 3153 3148 999 ICV_9 $T=967820 558320 0 0 $X=967820 $Y=557940
X2334 3352 3341 3357 1 2 3359 3360 3365 999 ICV_9 $T=1038500 578480 1 0 $X=1038500 $Y=573060
X2335 1032 11 1010 2 1 1004 XOR3 $T=233120 558320 0 180 $X=221960 $Y=552900
X2336 1073 1038 1058 2 1 1019 XOR3 $T=251100 578480 1 180 $X=239940 $Y=578100
X2337 1037 1035 1041 2 1 18 XOR3 $T=243040 588560 0 0 $X=243040 $Y=588180
X2338 1045 1052 1040 2 1 22 XOR3 $T=255440 588560 0 180 $X=244280 $Y=583140
X2339 1086 1082 1095 2 1 1076 XOR3 $T=265360 558320 0 180 $X=254200 $Y=552900
X2340 1139 1136 1104 2 1 1108 XOR3 $T=269080 548240 1 180 $X=257920 $Y=547860
X2341 1108 1103 1093 2 1 1123 XOR3 $T=260400 548240 1 0 $X=260400 $Y=542820
X2342 48 45 1130 2 1 1103 XOR3 $T=274040 598640 0 180 $X=262880 $Y=593220
X2343 1166 1160 1140 2 1 1146 XOR3 $T=280860 548240 1 180 $X=269700 $Y=547860
X2344 1146 50 1172 2 1 1151 XOR3 $T=271560 548240 1 0 $X=271560 $Y=542820
X2345 1193 1211 1239 2 1 1255 XOR3 $T=290160 548240 0 0 $X=290160 $Y=547860
X2346 1255 1165 1216 2 1 1183 XOR3 $T=301940 548240 0 180 $X=290780 $Y=542820
X2347 86 88 1281 2 1 1301 XOR3 $T=301940 588560 0 0 $X=301940 $Y=588180
X2348 1292 1285 1209 2 1 1227 XOR3 $T=313720 548240 1 180 $X=302560 $Y=547860
X2349 1327 1329 1328 2 1 1267 XOR3 $T=335420 548240 1 180 $X=324260 $Y=547860
X2350 1355 1351 1346 2 1 1341 XOR3 $T=340380 548240 0 180 $X=329220 $Y=542820
X2351 114 1353 113 2 1 1424 XOR3 $T=331080 518000 1 0 $X=331080 $Y=512580
X2352 154 1508 1490 2 1 1484 XOR3 $T=371380 518000 0 180 $X=360220 $Y=512580
X2353 1485 1473 1468 2 1 1521 XOR3 $T=360220 538160 0 0 $X=360220 $Y=537780
X2354 1511 1528 1545 2 1 1575 XOR3 $T=375100 548240 1 0 $X=375100 $Y=542820
X2355 1369 1594 1644 2 1 1615 XOR3 $T=393080 518000 0 0 $X=393080 $Y=517620
X2356 168 1619 1587 2 1 1665 XOR3 $T=399280 588560 0 0 $X=399280 $Y=588180
X2357 1648 1665 1681 2 1 1658 XOR3 $T=407960 548240 1 0 $X=407960 $Y=542820
X2358 177 1424 1696 2 1 1726 XOR3 $T=415400 528080 1 0 $X=415400 $Y=522660
X2359 181 1686 1685 2 1 1699 XOR3 $T=420360 598640 1 0 $X=420360 $Y=593220
X2360 185 182 189 2 1 1719 XOR3 $T=423460 518000 1 0 $X=423460 $Y=512580
X2361 1692 1673 1725 2 1 1739 XOR3 $T=424700 548240 1 0 $X=424700 $Y=542820
X2362 1693 1699 1737 2 1 1741 XOR3 $T=428420 548240 0 0 $X=428420 $Y=547860
X2363 1704 1702 1731 2 1 1746 XOR3 $T=430280 578480 0 0 $X=430280 $Y=578100
X2364 1715 187 1707 2 1 1733 XOR3 $T=442060 588560 1 180 $X=430900 $Y=588180
X2365 1754 194 1768 2 1 1783 XOR3 $T=443920 588560 0 0 $X=443920 $Y=588180
X2366 1774 211 1793 2 1 1802 XOR3 $T=454460 598640 1 0 $X=454460 $Y=593220
X2367 1952 1903 1968 2 1 1978 XOR3 $T=551800 518000 0 0 $X=551800 $Y=517620
X2368 2022 1978 2002 2 1 1996 XOR3 $T=590240 528080 0 180 $X=579080 $Y=522660
X2369 329 1988 343 2 1 2005 XOR3 $T=590860 518000 1 180 $X=579700 $Y=517620
X2370 2042 367 388 2 1 391 XOR3 $T=604500 518000 0 0 $X=604500 $Y=517620
X2371 402 393 2076 2 1 2042 XOR3 $T=620000 528080 1 180 $X=608840 $Y=527700
X2372 411 2105 414 2 1 395 XOR3 $T=624960 528080 1 0 $X=624960 $Y=522660
X2373 395 398 450 2 1 2142 XOR3 $T=635500 518000 1 0 $X=635500 $Y=512580
X2374 2313 2307 2289 2 1 2267 XOR3 $T=731600 568400 0 180 $X=720440 $Y=562980
X2375 2311 575 2294 2 1 2290 XOR3 $T=732840 598640 0 180 $X=721680 $Y=593220
X2376 2282 560 2285 2 1 2316 XOR3 $T=722300 578480 0 0 $X=722300 $Y=578100
X2377 2290 2312 2272 2 1 2296 XOR3 $T=735320 558320 1 180 $X=724160 $Y=557940
X2378 2299 2298 2319 2 1 2312 XOR3 $T=725400 538160 0 0 $X=725400 $Y=537780
X2379 2297 570 2287 2 1 2307 XOR3 $T=727260 588560 1 0 $X=727260 $Y=583140
X2380 2326 2316 2314 2 1 2310 XOR3 $T=743380 548240 1 180 $X=732220 $Y=547860
X2381 2372 2352 2373 2 1 2353 XOR3 $T=750820 548240 1 0 $X=750820 $Y=542820
X2382 2342 2329 2374 2 1 2412 XOR3 $T=751440 548240 0 0 $X=751440 $Y=547860
X2383 2792 710 709 2 1 714 XOR3 $T=863040 518000 1 0 $X=863040 $Y=512580
X2384 2821 725 2824 2 1 737 XOR3 $T=869860 568400 1 0 $X=869860 $Y=562980
X2385 2840 732 2847 2 1 2905 XOR3 $T=881640 578480 0 0 $X=881640 $Y=578100
X2386 2882 2909 2865 2 1 2888 XOR3 $T=897760 528080 1 180 $X=886600 $Y=527700
X2387 2885 2917 2889 2 1 2949 XOR3 $T=894040 558320 1 0 $X=894040 $Y=552900
X2388 2934 2928 2954 2 1 2984 XOR3 $T=907060 548240 0 0 $X=907060 $Y=547860
X2389 2977 774 2967 2 1 3000 XOR3 $T=912640 588560 1 0 $X=912640 $Y=583140
X2390 3008 3000 2994 2 1 2990 XOR3 $T=931240 548240 0 180 $X=920080 $Y=542820
X2391 3016 790 2997 2 1 780 XOR3 $T=932480 558320 0 180 $X=921320 $Y=552900
X2392 3035 3030 3010 2 1 3008 XOR3 $T=938060 538160 0 180 $X=926900 $Y=532740
X2393 3011 3013 3015 2 1 2992 XOR3 $T=932480 528080 0 0 $X=932480 $Y=527700
X2394 3070 810 3061 2 1 822 XOR3 $T=948600 568400 1 0 $X=948600 $Y=562980
X2395 3278 880 3304 2 1 888 XOR3 $T=1014940 558320 1 0 $X=1014940 $Y=552900
X2396 3315 893 3337 2 1 905 XOR3 $T=1037880 568400 0 0 $X=1037880 $Y=568020
X2397 3362 3368 3349 2 1 3353 XOR3 $T=1041600 558320 0 0 $X=1041600 $Y=557940
X2398 3370 3389 3427 2 1 3432 XOR3 $T=1050280 538160 0 0 $X=1050280 $Y=537780
X2399 3401 3405 3440 2 1 3445 XOR3 $T=1053380 528080 1 0 $X=1053380 $Y=522660
X2400 3397 3429 3447 2 1 3464 XOR3 $T=1058960 538160 1 0 $X=1058960 $Y=532740
X2401 3348 3437 3457 2 1 3472 XOR3 $T=1062060 548240 1 0 $X=1062060 $Y=542820
X2402 3443 923 3439 2 1 931 XOR3 $T=1065160 588560 1 0 $X=1065160 $Y=583140
X2403 3449 922 3416 2 1 3463 XOR3 $T=1065160 598640 0 0 $X=1065160 $Y=598260
X2404 921 918 3482 2 1 934 XOR3 $T=1067020 518000 1 0 $X=1067020 $Y=512580
X2405 3445 3463 3473 2 1 3477 XOR3 $T=1073840 528080 1 0 $X=1073840 $Y=522660
X2406 3472 933 3466 2 1 3497 XOR3 $T=1076320 568400 0 0 $X=1076320 $Y=568020
X2407 3464 930 3495 2 1 3496 XOR3 $T=1077560 538160 1 0 $X=1077560 $Y=532740
X2408 1144 1221 1 1214 2 NR2T $T=288300 578480 1 0 $X=288300 $Y=573060
X2409 1240 1246 1 1214 2 NR2T $T=298220 588560 1 0 $X=298220 $Y=583140
X2410 2786 2715 1 2797 2 NR2T $T=857460 538160 0 0 $X=857460 $Y=537780
X2411 3292 3266 1 3215 2 NR2T $T=1013080 548240 1 0 $X=1013080 $Y=542820
X2412 1082 1086 2 1092 1084 1082 1 AOI22H $T=248620 558320 0 0 $X=248620 $Y=557940
X2413 27 29 2 30 31 29 1 AOI22H $T=248620 598640 0 0 $X=248620 $Y=598260
X2414 1160 1166 2 1133 1162 1160 1 AOI22H $T=282100 558320 0 180 $X=274660 $Y=552900
X2415 50 1146 2 1116 1175 50 1 AOI22H $T=277140 538160 0 0 $X=277140 $Y=537780
X2416 1211 1193 2 1186 1205 1211 1 AOI22H $T=288920 558320 1 0 $X=288920 $Y=552900
X2417 1285 1292 2 1209 1309 1285 1 AOI22H $T=309380 548240 1 0 $X=309380 $Y=542820
X2418 1329 1327 2 1328 1335 1329 1 AOI22H $T=326120 558320 0 180 $X=318680 $Y=552900
X2419 1351 1355 2 1346 1334 1351 1 AOI22H $T=324260 538160 0 0 $X=324260 $Y=537780
X2420 1473 1485 2 1468 1472 1473 1 AOI22H $T=364560 548240 0 180 $X=357120 $Y=542820
X2421 1511 1528 2 1481 1535 1528 1 AOI22H $T=370140 548240 0 0 $X=370140 $Y=547860
X2422 1369 1594 2 1603 1589 1594 1 AOI22H $T=397420 518000 0 180 $X=389980 $Y=512580
X2423 1648 1665 2 1595 1656 1665 1 AOI22H $T=406720 548240 0 0 $X=406720 $Y=547860
X2424 1673 1692 2 1659 1705 1673 1 AOI22H $T=417880 538160 0 0 $X=417880 $Y=537780
X2425 1693 1699 2 1708 1694 1699 1 AOI22H $T=419120 548240 0 0 $X=419120 $Y=547860
X2426 1702 1704 2 1691 1721 1702 1 AOI22H $T=420980 578480 1 0 $X=420980 $Y=573060
X2427 1715 187 2 1717 1727 187 1 AOI22H $T=423460 588560 1 0 $X=423460 $Y=583140
X2428 1988 329 2 332 1994 1988 1 AOI22H $T=571020 518000 1 0 $X=571020 $Y=512580
X2429 2313 2307 2 2309 2306 2307 1 AOI22H $T=737800 578480 0 180 $X=730360 $Y=573060
X2430 2372 2352 2 2365 2357 2352 1 AOI22H $T=752680 538160 1 180 $X=745240 $Y=537780
X2431 2342 2329 2 2354 2340 2329 1 AOI22H $T=752680 558320 1 180 $X=745240 $Y=557940
X2432 2909 2882 2 2865 2897 2909 1 AOI22H $T=899000 518000 1 180 $X=891560 $Y=517620
X2433 3389 3370 2 3394 3382 3389 1 AOI22H $T=1049040 548240 1 0 $X=1049040 $Y=542820
X2434 3429 3397 2 3380 3413 3429 1 AOI22H $T=1061440 538160 0 0 $X=1061440 $Y=537780
X2435 3437 3348 2 3412 3430 3437 1 AOI22H $T=1062060 548240 0 0 $X=1062060 $Y=547860
X2436 922 3449 2 3416 3433 922 1 AOI22H $T=1070740 598640 0 180 $X=1063300 $Y=593220
X2437 3463 3445 2 3459 3469 3463 1 AOI22H $T=1076940 528080 1 180 $X=1069500 $Y=527700
X2438 3464 930 2 3468 3479 930 1 AOI22H $T=1072600 538160 0 0 $X=1072600 $Y=537780
X2439 1049 1 1048 1037 2 ND2P $T=239940 578480 1 180 $X=236220 $Y=578100
X2440 1060 1 1053 1058 2 ND2P $T=243040 598640 1 0 $X=243040 $Y=593220
X2441 1081 1 1064 1070 2 ND2P $T=249860 548240 0 180 $X=246140 $Y=542820
X2442 1088 1 1084 1087 2 ND2P $T=252340 558320 0 180 $X=248620 $Y=552900
X2443 1119 1 1122 1041 2 ND2P $T=259780 588560 1 0 $X=259780 $Y=583140
X2444 42 1 1126 1122 2 ND2P $T=267220 588560 0 180 $X=263500 $Y=583140
X2445 1120 1 1128 1081 2 ND2P $T=264740 558320 0 0 $X=264740 $Y=557940
X2446 1139 1 1087 1152 2 ND2P $T=272800 558320 0 180 $X=269080 $Y=552900
X2447 1150 1 1153 1045 2 ND2P $T=270940 588560 1 0 $X=270940 $Y=583140
X2448 42 1 1163 1153 2 ND2P $T=274660 588560 1 0 $X=274660 $Y=583140
X2449 1178 1 1162 1186 2 ND2P $T=284580 548240 1 180 $X=280860 $Y=547860
X2450 1177 1 1176 61 2 ND2P $T=284580 588560 1 180 $X=280860 $Y=588180
X2451 1184 1 1175 1206 2 ND2P $T=288300 548240 0 180 $X=284580 $Y=542820
X2452 1192 1 1205 1209 2 ND2P $T=286440 548240 0 0 $X=286440 $Y=547860
X2453 69 1 1217 1231 2 ND2P $T=290780 588560 1 0 $X=290780 $Y=583140
X2454 1231 1 1230 1281 2 ND2P $T=297600 578480 1 180 $X=293880 $Y=578100
X2455 1188 1 1296 1272 2 ND2P $T=313720 518000 1 180 $X=310000 $Y=517620
X2456 1292 1 1209 1299 2 ND2P $T=310000 558320 1 0 $X=310000 $Y=552900
X2457 1298 1 1305 1246 2 ND2P $T=311860 588560 1 0 $X=311860 $Y=583140
X2458 1284 1 1273 1303 2 ND2P $T=316200 538160 1 180 $X=312480 $Y=537780
X2459 1307 1 1296 1288 2 ND2P $T=313720 518000 0 0 $X=313720 $Y=517620
X2460 1299 1 1309 1328 2 ND2P $T=318680 548240 1 180 $X=314960 $Y=547860
X2461 1340 1 1334 1331 2 ND2P $T=323020 548240 0 180 $X=319300 $Y=542820
X2462 1332 1 1335 1346 2 ND2P $T=320540 548240 0 0 $X=320540 $Y=547860
X2463 1366 1 1325 120 2 ND2P $T=335420 598640 1 180 $X=331700 $Y=598260
X2464 1390 1 1386 1397 2 ND2P $T=337280 548240 0 0 $X=337280 $Y=547860
X2465 1402 1 1412 1428 2 ND2P $T=345960 558320 0 180 $X=342240 $Y=552900
X2466 1429 1 137 1450 2 ND2P $T=352780 598640 0 180 $X=349060 $Y=593220
X2467 1443 1 1448 1468 2 ND2P $T=354020 538160 1 180 $X=350300 $Y=537780
X2468 1464 1 1458 1462 2 ND2P $T=355260 548240 1 180 $X=351540 $Y=547860
X2469 1425 1 1400 1448 2 ND2P $T=353400 538160 1 0 $X=353400 $Y=532740
X2470 1463 1 1428 1458 2 ND2P $T=353400 558320 1 0 $X=353400 $Y=552900
X2471 1450 1 138 1474 2 ND2P $T=354640 588560 1 0 $X=354640 $Y=583140
X2472 1478 1 1472 1481 2 ND2P $T=360220 538160 1 180 $X=356500 $Y=537780
X2473 142 1 1474 1505 2 ND2P $T=369520 598640 1 180 $X=365800 $Y=598260
X2474 1530 1 1519 1512 2 ND2P $T=373240 598640 1 180 $X=369520 $Y=598260
X2475 1522 1 1535 1536 2 ND2P $T=371380 548240 1 0 $X=371380 $Y=542820
X2476 1532 1 1515 1459 2 ND2P $T=373240 528080 1 0 $X=373240 $Y=522660
X2477 1541 1 1462 1556 2 ND2P $T=375100 558320 1 0 $X=375100 $Y=552900
X2478 1512 1 1551 1548 2 ND2P $T=379440 588560 1 180 $X=375720 $Y=588180
X2479 1562 1 1556 1569 2 ND2P $T=384400 558320 0 180 $X=380680 $Y=552900
X2480 1568 1 1548 1587 2 ND2P $T=385640 598640 0 180 $X=381920 $Y=593220
X2481 1577 1 1536 1584 2 ND2P $T=385640 548240 0 0 $X=385640 $Y=547860
X2482 1588 1 1584 1595 2 ND2P $T=393700 558320 0 180 $X=389980 $Y=552900
X2483 1638 1 1621 1645 2 ND2P $T=403000 548240 0 0 $X=403000 $Y=547860
X2484 1640 1 1643 1657 2 ND2P $T=406720 558320 0 180 $X=403000 $Y=552900
X2485 1649 1 1656 1659 2 ND2P $T=404240 548240 1 0 $X=404240 $Y=542820
X2486 1688 1 1683 1689 2 ND2P $T=419120 558320 1 180 $X=415400 $Y=557940
X2487 1700 1 1694 1691 2 ND2P $T=422220 558320 0 180 $X=418500 $Y=552900
X2488 185 1 184 1679 2 ND2P $T=420980 518000 0 0 $X=420980 $Y=517620
X2489 1697 1 1705 1708 2 ND2P $T=420980 548240 1 0 $X=420980 $Y=542820
X2490 1709 1 1714 1722 2 ND2P $T=426560 558320 1 180 $X=422840 $Y=557940
X2491 1712 1 1721 1717 2 ND2P $T=424080 578480 0 0 $X=424080 $Y=578100
X2492 1724 1 1727 1732 2 ND2P $T=430900 588560 1 180 $X=427180 $Y=588180
X2493 1732 1 1754 1756 2 ND2P $T=450740 598640 1 0 $X=450740 $Y=593220
X2494 1998 1 1994 2002 2 ND2P $T=579080 518000 1 180 $X=575360 $Y=517620
X2495 2042 1 360 2035 2 ND2P $T=598920 518000 0 180 $X=595200 $Y=512580
X2496 367 1 360 2052 2 ND2P $T=602640 518000 0 180 $X=598920 $Y=512580
X2497 419 1 420 424 2 ND2P $T=628060 518000 0 0 $X=628060 $Y=517620
X2498 426 1 420 432 2 ND2P $T=631780 518000 0 0 $X=631780 $Y=517620
X2499 2303 1 2306 2269 2 ND2P $T=727260 568400 0 0 $X=727260 $Y=568020
X2500 2321 1 2315 2317 2 ND2P $T=736560 528080 0 180 $X=732840 $Y=522660
X2501 576 1 577 2280 2 ND2P $T=732840 598640 1 0 $X=732840 $Y=593220
X2502 2328 1 2325 2326 2 ND2P $T=740280 538160 0 180 $X=736560 $Y=532740
X2503 2326 1 2320 2334 2 ND2P $T=741520 558320 1 180 $X=737800 $Y=557940
X2504 2346 1 2340 2320 2 ND2P $T=745240 558320 0 180 $X=741520 $Y=552900
X2505 2316 1 2320 2341 2 ND2P $T=741520 558320 0 0 $X=741520 $Y=557940
X2506 2349 1 2355 2338 2 ND2P $T=744000 578480 1 0 $X=744000 $Y=573060
X2507 2360 1 2357 2354 2 ND2P $T=748960 548240 1 180 $X=745240 $Y=547860
X2508 2358 1 2361 2350 2 ND2P $T=745860 568400 1 0 $X=745860 $Y=562980
X2509 2362 1 2368 2370 2 ND2P $T=748340 518000 0 0 $X=748340 $Y=517620
X2510 2392 1 2385 597 2 ND2P $T=756400 558320 0 180 $X=752680 $Y=552900
X2511 2401 1 2405 2396 2 ND2P $T=758880 558320 1 0 $X=758880 $Y=552900
X2512 2411 1 2417 602 2 ND2P $T=761980 568400 1 0 $X=761980 $Y=562980
X2513 2437 1 2449 2471 2 ND2P $T=775000 568400 1 0 $X=775000 $Y=562980
X2514 2483 1 2490 2437 2 ND2P $T=778720 568400 0 0 $X=778720 $Y=568020
X2515 2481 1 2488 623 2 ND2P $T=786160 558320 0 180 $X=782440 $Y=552900
X2516 2517 1 2521 628 2 ND2P $T=788020 558320 1 0 $X=788020 $Y=552900
X2517 2565 1 2558 641 2 ND2P $T=802900 568400 0 180 $X=799180 $Y=562980
X2518 2588 1 2594 649 2 ND2P $T=808480 558320 1 0 $X=808480 $Y=552900
X2519 2589 1 2595 2571 2 ND2P $T=808480 568400 1 0 $X=808480 $Y=562980
X2520 2610 1 2620 657 2 ND2P $T=815300 558320 1 0 $X=815300 $Y=552900
X2521 2659 1 2665 2603 2 ND2P $T=828940 568400 1 0 $X=828940 $Y=562980
X2522 2695 1 2702 694 2 ND2P $T=839480 558320 1 0 $X=839480 $Y=552900
X2523 2724 1 2718 2706 2 ND2P $T=847540 548240 1 180 $X=843820 $Y=547860
X2524 2741 1 2752 704 2 ND2P $T=850640 548240 1 0 $X=850640 $Y=542820
X2525 2829 1 2832 720 2 ND2P $T=872340 558320 1 0 $X=872340 $Y=552900
X2526 2836 1 2843 2824 2 ND2P $T=873580 578480 1 0 $X=873580 $Y=573060
X2527 2828 1 2839 2856 2 ND2P $T=877920 598640 1 180 $X=874200 $Y=598260
X2528 2854 1 731 730 2 ND2P $T=879160 518000 0 180 $X=875440 $Y=512580
X2529 2866 1 2860 736 2 ND2P $T=882880 568400 1 180 $X=879160 $Y=568020
X2530 2852 1 2861 2876 2 ND2P $T=883500 558320 0 180 $X=879780 $Y=552900
X2531 2886 1 2897 745 2 ND2P $T=886600 518000 0 0 $X=886600 $Y=517620
X2532 2931 1 2939 2940 2 ND2P $T=899000 598640 0 0 $X=899000 $Y=598260
X2533 2968 1 2963 2962 2 ND2P $T=912020 528080 0 180 $X=908300 $Y=522660
X2534 3066 1 3056 3031 2 ND2P $T=946120 558320 1 180 $X=942400 $Y=557940
X2535 3094 1 3109 3061 2 ND2P $T=961000 558320 1 180 $X=957280 $Y=557940
X2536 3153 1 3157 3114 2 ND2P $T=971540 568400 0 0 $X=971540 $Y=568020
X2537 3166 1 3169 3172 2 ND2P $T=975260 558320 0 0 $X=975260 $Y=557940
X2538 3212 1 3210 3148 2 ND2P $T=988900 568400 0 0 $X=988900 $Y=568020
X2539 3221 1 3227 3191 2 ND2P $T=992620 568400 0 0 $X=992620 $Y=568020
X2540 3257 1 3249 3243 2 ND2P $T=1002540 568400 1 0 $X=1002540 $Y=562980
X2541 2760 1 3256 3266 2 ND2P $T=1003160 548240 1 0 $X=1003160 $Y=542820
X2542 890 1 3307 3332 2 ND2P $T=1032920 548240 1 180 $X=1029200 $Y=547860
X2543 3322 1 3332 3349 2 ND2P $T=1036640 548240 1 180 $X=1032920 $Y=547860
X2544 3385 1 3382 3380 2 ND2P $T=1050280 538160 1 180 $X=1046560 $Y=537780
X2545 3403 1 3406 3412 2 ND2P $T=1057720 558320 0 180 $X=1054000 $Y=552900
X2546 3410 1 3402 3407 2 ND2P $T=1058340 588560 1 180 $X=1054620 $Y=588180
X2547 913 1 914 3416 2 ND2P $T=1054620 598640 0 0 $X=1054620 $Y=598260
X2548 3404 1 3413 3418 2 ND2P $T=1055240 538160 1 0 $X=1055240 $Y=532740
X2549 3422 1 917 919 2 ND2P $T=1058340 518000 1 0 $X=1058340 $Y=512580
X2550 3419 1 3430 3394 2 ND2P $T=1058340 548240 1 0 $X=1058340 $Y=542820
X2551 3425 1 3426 918 2 ND2P $T=1063300 598640 0 180 $X=1059580 $Y=593220
X2552 3431 1 3433 3410 2 ND2P $T=1059580 598640 0 0 $X=1059580 $Y=598260
X2553 3387 1 3424 3450 2 ND2P $T=1062060 568400 1 0 $X=1062060 $Y=562980
X2554 921 1 924 3422 2 ND2P $T=1063300 518000 1 0 $X=1063300 $Y=512580
X2555 3442 1 3409 925 2 ND2P $T=1064540 528080 1 0 $X=1064540 $Y=522660
X2556 3407 1 3453 3439 2 ND2P $T=1065780 588560 0 0 $X=1065780 $Y=588180
X2557 3460 1 3469 924 2 ND2P $T=1070120 528080 1 0 $X=1070120 $Y=522660
X2558 3464 1 3468 3475 2 ND2P $T=1073840 538160 0 180 $X=1070120 $Y=532740
X2559 3441 1 3450 3466 2 ND2P $T=1070740 578480 1 0 $X=1070740 $Y=573060
X2560 3481 1 3476 3468 2 ND2P $T=1076940 548240 0 180 $X=1073220 $Y=542820
X2561 3475 1 3479 3459 2 ND2P $T=1073840 538160 1 0 $X=1073840 $Y=532740
X2562 648 2580 2571 2 1 2562 XNR3 $T=813440 558320 1 180 $X=802280 $Y=557940
X2563 2925 2919 2945 2 1 2969 XNR3 $T=898380 538160 1 0 $X=898380 $Y=532740
X2564 1108 1103 1091 1 2 1116 MAO222 $T=255440 548240 1 0 $X=255440 $Y=542820
X2565 1255 1206 1165 1 2 1219 MAO222 $T=301940 548240 1 0 $X=301940 $Y=542820
X2566 181 1686 1642 1 2 1695 MAO222 $T=415400 598640 1 0 $X=415400 $Y=593220
X2567 411 2105 414 1 2 2076 MAO222 $T=623100 518000 0 0 $X=623100 $Y=517620
X2568 2282 560 2285 1 2 2287 MAO222 $T=716720 578480 0 0 $X=716720 $Y=578100
X2569 2297 570 2287 1 2 2300 MAO222 $T=722300 588560 1 0 $X=722300 $Y=583140
X2570 732 2847 2840 1 2 2857 MAO222 $T=874820 578480 0 0 $X=874820 $Y=578100
X2571 2856 751 2858 1 2 2881 MAO222 $T=884740 598640 1 0 $X=884740 $Y=593220
X2572 2893 2876 2898 1 2 2917 MAO222 $T=888460 558320 0 0 $X=888460 $Y=557940
X2573 3011 3013 3015 1 2 3010 MAO222 $T=927520 528080 0 0 $X=927520 $Y=527700
X2574 3022 800 3031 1 2 2997 MAO222 $T=936820 558320 1 180 $X=931860 $Y=557940
X2575 3070 810 3061 1 2 3034 MAO222 $T=943640 568400 1 0 $X=943640 $Y=562980
X2576 3291 3317 879 1 2 3304 MAO222 $T=1029820 568400 1 180 $X=1024860 $Y=568020
X2577 3361 3373 903 1 2 3337 MAO222 $T=1042220 588560 1 0 $X=1042220 $Y=583140
X2578 2092 1 406 403 2 360 ND3HT $T=626200 518000 0 180 $X=618760 $Y=512580
X2579 2327 1 2334 2341 2 2309 ND3HT $T=737180 568400 1 0 $X=737180 $Y=562980
X2580 2363 1 592 593 2 2365 ND3HT $T=747100 518000 1 0 $X=747100 $Y=512580
X2581 1576 163 1 1551 2 OR2T $T=389980 598640 1 0 $X=389980 $Y=593220
X2582 1037 1041 1 1035 1053 2 OAI12H $T=233740 588560 0 0 $X=233740 $Y=588180
X2583 1040 1045 1 1052 1048 2 OAI12H $T=234980 588560 1 0 $X=234980 $Y=583140
X2584 2457 2463 1 2471 2435 2 OAI12H $T=771900 558320 0 0 $X=771900 $Y=557940
X2585 2794 711 1 2802 2785 2 OAI12H $T=859320 558320 0 0 $X=859320 $Y=557940
X2586 3390 3386 1 3329 3406 2 OAI12H $T=1049040 548240 0 0 $X=1049040 $Y=547860
X2587 3432 3461 1 929 3476 2 OAI12H $T=1069500 548240 0 0 $X=1069500 $Y=547860
X2588 292 290 1938 2 1936 288 1 AO22S $T=541260 578480 0 180 $X=536300 $Y=573060
X2589 324 290 318 2 1967 288 1 AO22S $T=567300 598640 0 180 $X=562340 $Y=593220
X2590 493 491 2192 2 2169 486 1 AO22S $T=676420 568400 1 180 $X=671460 $Y=568020
X2591 506 504 2214 2 2191 500 1 AO22S $T=685100 548240 1 180 $X=680140 $Y=547860
X2592 512 504 2218 2 2212 500 1 AO22S $T=687580 528080 1 180 $X=682620 $Y=527700
X2593 509 504 2203 2 2173 500 1 AO22S $T=687580 538160 0 180 $X=682620 $Y=532740
X2594 518 504 2225 2 2199 500 1 AO22S $T=692540 548240 0 180 $X=687580 $Y=542820
X2595 520 491 2221 2 2196 486 1 AO22S $T=694400 568400 0 180 $X=689440 $Y=562980
X2596 530 504 2238 2 2231 500 1 AO22S $T=698740 528080 0 180 $X=693780 $Y=522660
X2597 534 527 399 2 374 2252 1 AO22S $T=699360 588560 1 0 $X=699360 $Y=583140
X2598 549 533 399 2 374 2260 1 AO22S $T=711760 588560 0 180 $X=706800 $Y=583140
X2599 2311 578 2323 2 579 2332 1 AO22S $T=735320 598640 0 0 $X=735320 $Y=598260
X2600 2292 2323 581 2 583 2332 1 AO22S $T=737800 588560 0 0 $X=737800 $Y=588180
X2601 2297 2323 584 2 2343 2332 1 AO22S $T=740280 598640 0 0 $X=740280 $Y=598260
X2602 2351 2323 2359 2 2364 2332 1 AO22S $T=745240 588560 0 0 $X=745240 $Y=588180
X2603 2282 2323 591 2 2366 2332 1 AO22S $T=746480 598640 0 0 $X=746480 $Y=598260
X2604 606 603 2466 2 2469 608 1 AO22S $T=772520 518000 1 0 $X=772520 $Y=512580
X2605 2501 2323 2518 2 2491 2332 1 AO22S $T=786160 578480 1 0 $X=786160 $Y=573060
X2606 2840 2639 2815 2 2758 585 1 AO22S $T=874820 578480 1 180 $X=869860 $Y=578100
X2607 2849 2639 2841 2 2750 585 1 AO22S $T=877300 588560 0 180 $X=872340 $Y=583140
X2608 2961 2964 2966 2 2973 2976 1 AO22S $T=908300 578480 0 0 $X=908300 $Y=578100
X2609 2977 2974 2964 2 2981 2976 1 AO22S $T=914500 588560 0 0 $X=914500 $Y=588180
X2610 2987 2964 3006 2 3009 2976 1 AO22S $T=925040 578480 1 0 $X=925040 $Y=573060
X2611 3016 2964 3024 2 3021 2976 1 AO22S $T=932480 568400 0 0 $X=932480 $Y=568020
X2612 3022 2964 3044 2 3049 2976 1 AO22S $T=938680 568400 0 0 $X=938680 $Y=568020
X2613 3070 2964 3085 2 3086 2976 1 AO22S $T=949840 568400 0 0 $X=949840 $Y=568020
X2614 1358 94 2 1304 1 1248 MUX2S $T=327360 568400 1 180 $X=323020 $Y=568020
X2615 1295 1323 2 1368 1 1191 MUX2S $T=327980 578480 1 0 $X=327980 $Y=573060
X2616 1358 1323 2 1405 1 1300 MUX2S $T=337900 568400 0 0 $X=337900 $Y=568020
X2617 1248 1258 2 1449 1 1456 MUX2S $T=348440 568400 0 0 $X=348440 $Y=568020
X2618 1405 1263 2 1479 1 1449 MUX2S $T=355880 568400 0 0 $X=355880 $Y=568020
X2619 1447 1263 2 1486 1 1492 MUX2S $T=357740 578480 1 0 $X=357740 $Y=573060
X2620 1477 99 2 1488 1 1471 MUX2S $T=358360 588560 0 0 $X=358360 $Y=588180
X2621 1403 1263 2 1494 1 1436 MUX2S $T=358980 588560 1 0 $X=358980 $Y=583140
X2622 1471 1411 2 1497 1 1455 MUX2S $T=362080 578480 1 0 $X=362080 $Y=573060
X2623 1488 99 2 1498 1 1487 MUX2S $T=362700 588560 0 0 $X=362700 $Y=588180
X2624 1487 1411 2 1502 1 1494 MUX2S $T=363940 588560 1 0 $X=363940 $Y=583140
X2625 1497 1411 2 1504 1 1479 MUX2S $T=365180 578480 0 0 $X=365180 $Y=578100
X2626 1479 1263 2 1509 1 1513 MUX2S $T=366420 578480 1 0 $X=366420 $Y=573060
X2627 1300 1258 2 1513 1 1533 MUX2S $T=367040 568400 0 0 $X=367040 $Y=568020
X2628 1498 99 2 1503 1 1497 MUX2S $T=367040 588560 0 0 $X=367040 $Y=588180
X2629 1502 1411 2 1523 1 1486 MUX2S $T=368280 588560 1 0 $X=368280 $Y=583140
X2630 1504 1411 2 1509 1 1542 MUX2S $T=370760 578480 0 0 $X=370760 $Y=578100
X2631 1503 99 2 1518 1 1502 MUX2S $T=375720 588560 1 180 $X=371380 $Y=588180
X2632 1486 1263 2 1509 1 1546 MUX2S $T=372000 578480 1 0 $X=372000 $Y=573060
X2633 1518 99 2 1543 1 1504 MUX2S $T=372620 588560 1 0 $X=372620 $Y=583140
X2634 1357 1258 2 1546 1 1554 MUX2S $T=373240 568400 0 0 $X=373240 $Y=568020
X2635 1455 1263 2 1542 1 1565 MUX2S $T=376340 578480 0 0 $X=376340 $Y=578100
X2636 1523 1411 2 1509 1 1571 MUX2S $T=381300 588560 1 0 $X=381300 $Y=583140
X2637 1542 1263 2 1509 1 1578 MUX2S $T=381920 578480 1 0 $X=381920 $Y=573060
X2638 1376 1258 2 1578 1 1583 MUX2S $T=383160 568400 0 0 $X=383160 $Y=568020
X2639 1571 1263 2 1509 1 1606 MUX2S $T=383160 578480 0 0 $X=383160 $Y=578100
X2640 1494 1263 2 1571 1 1590 MUX2S $T=385640 588560 1 0 $X=385640 $Y=583140
X2641 1283 1258 2 1590 1 1574 MUX2S $T=388120 578480 1 0 $X=388120 $Y=573060
X2642 1436 1258 2 1606 1 1626 MUX2S $T=389980 588560 1 0 $X=389980 $Y=583140
X2643 1590 1258 2 1509 1 1624 MUX2S $T=393080 578480 0 0 $X=393080 $Y=578100
X2644 1492 1258 2 1509 1 1628 MUX2S $T=393700 568400 0 0 $X=393700 $Y=568020
X2645 1565 1258 2 1509 1 1629 MUX2S $T=393700 578480 1 0 $X=393700 $Y=573060
X2646 1499 60 2 1278 1 1734 MUX2S $T=427800 538160 0 0 $X=427800 $Y=537780
X2647 1470 60 2 1235 1 1735 MUX2S $T=430280 538160 1 0 $X=430280 $Y=532740
X2648 1580 60 2 1728 1 1744 MUX2S $T=436480 538160 1 0 $X=436480 $Y=532740
X2649 196 198 2 200 1 1748 MUX2S $T=442680 518000 0 0 $X=442680 $Y=517620
X2650 1653 60 2 1470 1 1760 MUX2S $T=443300 538160 1 0 $X=443300 $Y=532740
X2651 1506 60 2 1320 1 205 MUX2S $T=445160 538160 0 0 $X=445160 $Y=537780
X2652 1591 60 2 196 1 1769 MUX2S $T=447640 528080 0 0 $X=447640 $Y=527700
X2653 200 198 2 207 1 1740 MUX2S $T=448880 518000 1 0 $X=448880 $Y=512580
X2654 1766 60 2 1580 1 1777 MUX2S $T=450120 558320 1 0 $X=450120 $Y=552900
X2655 1661 60 2 206 1 1776 MUX2S $T=451980 528080 0 0 $X=451980 $Y=527700
X2656 1687 60 2 1499 1 1791 MUX2S $T=453220 538160 0 0 $X=453220 $Y=537780
X2657 1794 60 2 1755 1 1779 MUX2S $T=460660 568400 0 180 $X=456320 $Y=562980
X2658 224 60 2 1766 1 1773 MUX2S $T=468720 568400 0 180 $X=464380 $Y=562980
X2659 2271 446 2 559 1 2279 MUX2S $T=722300 528080 1 180 $X=717960 $Y=527700
X2660 2291 446 2 561 1 2281 MUX2S $T=722920 518000 1 180 $X=718580 $Y=517620
X2661 610 2446 2 595 1 2421 MUX2S $T=770040 598640 1 180 $X=765700 $Y=598260
X2662 2459 600 2 2441 1 2432 MUX2S $T=773140 588560 1 180 $X=768800 $Y=588180
X2663 614 2446 2 595 1 2441 MUX2S $T=773140 598640 0 180 $X=768800 $Y=593220
X2664 616 2446 2 610 1 2420 MUX2S $T=775620 598640 1 180 $X=771280 $Y=598260
X2665 2479 2446 2 595 1 2467 MUX2S $T=778720 598640 0 180 $X=774380 $Y=593220
X2666 2493 600 2 2475 1 2468 MUX2S $T=781820 588560 0 180 $X=777480 $Y=583140
X2667 2473 2489 2 2442 1 2498 MUX2S $T=778720 548240 1 0 $X=778720 $Y=542820
X2668 2442 2489 2 2433 1 2502 MUX2S $T=779340 538160 0 0 $X=779340 $Y=537780
X2669 2503 600 2 2420 1 2482 MUX2S $T=784300 588560 1 180 $X=779960 $Y=588180
X2670 625 2446 2 595 1 2475 MUX2S $T=784300 598640 1 180 $X=779960 $Y=598260
X2671 2500 2489 2 2473 1 2511 MUX2S $T=783060 548240 1 0 $X=783060 $Y=542820
X2672 2519 600 2 2398 1 2491 MUX2S $T=789260 588560 1 180 $X=784920 $Y=588180
X2673 629 2446 2 614 1 2406 MUX2S $T=789260 598640 0 180 $X=784920 $Y=593220
X2674 627 2446 2 2479 1 2398 MUX2S $T=789260 598640 1 180 $X=784920 $Y=598260
X2675 2514 2520 2 2454 1 2516 MUX2S $T=792360 518000 1 180 $X=788020 $Y=517620
X2676 2509 2489 2 2500 1 2535 MUX2S $T=788640 548240 0 0 $X=788640 $Y=547860
X2677 632 2446 2 625 1 2434 MUX2S $T=793600 598640 1 180 $X=789260 $Y=598260
X2678 2542 600 2 2406 1 2508 MUX2S $T=794840 588560 1 180 $X=790500 $Y=588180
X2679 2543 2520 2 2533 1 2526 MUX2S $T=796080 538160 0 180 $X=791740 $Y=532740
X2680 2551 2525 2 2526 1 630 MUX2S $T=796700 518000 1 180 $X=792360 $Y=517620
X2681 2555 2525 2 2516 1 2469 MUX2S $T=797320 518000 0 180 $X=792980 $Y=512580
X2682 2533 2520 2 2454 1 2549 MUX2S $T=792980 528080 0 0 $X=792980 $Y=527700
X2683 2535 2527 2 2498 1 2543 MUX2S $T=792980 548240 1 0 $X=792980 $Y=542820
X2684 637 2446 2 616 1 2440 MUX2S $T=798560 598640 1 180 $X=794220 $Y=598260
X2685 2540 2489 2 2509 1 2554 MUX2S $T=794840 548240 0 0 $X=794840 $Y=547860
X2686 2561 2520 2 2514 1 2547 MUX2S $T=801660 528080 0 180 $X=797320 $Y=522660
X2687 2511 2527 2 2502 1 2566 MUX2S $T=797320 538160 0 0 $X=797320 $Y=537780
X2688 2567 2525 2 2547 1 635 MUX2S $T=802280 518000 1 180 $X=797940 $Y=517620
X2689 2554 2527 2 2511 1 2563 MUX2S $T=797940 548240 1 0 $X=797940 $Y=542820
X2690 2583 600 2 2434 1 2553 MUX2S $T=803520 588560 1 180 $X=799180 $Y=588180
X2691 2575 2446 2 632 1 2493 MUX2S $T=803520 598640 1 180 $X=799180 $Y=598260
X2692 2556 2489 2 2540 1 2576 MUX2S $T=800420 548240 0 0 $X=800420 $Y=547860
X2693 645 2446 2 627 1 2478 MUX2S $T=805380 598640 0 180 $X=801040 $Y=593220
X2694 2563 2520 2 2574 1 2570 MUX2S $T=801660 538160 1 0 $X=801660 $Y=532740
X2695 2596 2525 2 2570 1 643 MUX2S $T=807240 518000 1 180 $X=802900 $Y=517620
X2696 2576 2527 2 2535 1 2561 MUX2S $T=807860 548240 0 180 $X=803520 $Y=542820
X2697 2573 2489 2 2556 1 2586 MUX2S $T=804140 558320 1 0 $X=804140 $Y=552900
X2698 2591 620 2 2573 1 2577 MUX2S $T=809720 548240 1 180 $X=805380 $Y=547860
X2699 2592 2446 2 629 1 2459 MUX2S $T=809720 598640 1 180 $X=805380 $Y=598260
X2700 2574 2520 2 2454 1 2582 MUX2S $T=811580 538160 0 180 $X=807240 $Y=532740
X2701 2566 2520 2 2454 1 2585 MUX2S $T=812200 528080 0 180 $X=807860 $Y=522660
X2702 2586 2527 2 2554 1 2600 MUX2S $T=807860 548240 1 0 $X=807860 $Y=542820
X2703 2601 2525 2 2585 1 647 MUX2S $T=812820 518000 0 180 $X=808480 $Y=512580
X2704 2577 2527 2 2576 1 2607 MUX2S $T=808480 538160 0 0 $X=808480 $Y=537780
X2705 2607 2520 2 2543 1 2559 MUX2S $T=816540 528080 1 180 $X=812200 $Y=527700
X2706 2602 2527 2 2586 1 2617 MUX2S $T=812200 548240 1 0 $X=812200 $Y=542820
X2707 2600 2520 2 2566 1 2578 MUX2S $T=817160 528080 0 180 $X=812820 $Y=522660
X2708 2622 2520 2 2561 1 2555 MUX2S $T=817780 518000 1 180 $X=813440 $Y=517620
X2709 2632 2520 2 2600 1 2601 MUX2S $T=821500 528080 0 180 $X=817160 $Y=522660
X2710 2617 2520 2 2563 1 2597 MUX2S $T=821500 528080 1 180 $X=817160 $Y=527700
X2711 2641 2525 2 2578 1 656 MUX2S $T=823360 518000 1 180 $X=819020 $Y=517620
X2712 2663 600 2 2459 1 2636 MUX2S $T=829560 578480 1 180 $X=825220 $Y=578100
X2713 2632 687 2 2686 1 2641 MUX2S $T=834520 538160 0 0 $X=834520 $Y=537780
X2714 791 702 2 798 1 802 MUX2S $T=931240 598640 0 0 $X=931240 $Y=598260
X2715 803 618 2 804 1 3057 MUX2S $T=937440 598640 0 0 $X=937440 $Y=598260
X2716 3046 620 2 3043 1 3069 MUX2S $T=940540 548240 0 0 $X=940540 $Y=547860
X2717 3043 620 2 3027 1 3077 MUX2S $T=942400 548240 1 0 $X=942400 $Y=542820
X2718 3072 600 2 3059 1 3049 MUX2S $T=946740 588560 0 180 $X=942400 $Y=583140
X2719 3050 3063 2 3004 1 3059 MUX2S $T=946740 588560 1 180 $X=942400 $Y=588180
X2720 3057 3063 2 3050 1 3018 MUX2S $T=946740 598640 0 180 $X=942400 $Y=593220
X2721 3027 620 2 3026 1 3084 MUX2S $T=947360 548240 0 0 $X=947360 $Y=547860
X2722 3080 3063 2 3004 1 3081 MUX2S $T=952320 598640 0 180 $X=947980 $Y=593220
X2723 3092 3063 2 3057 1 3072 MUX2S $T=952940 598640 1 180 $X=948600 $Y=598260
X2724 3088 600 2 3081 1 3079 MUX2S $T=953560 588560 1 180 $X=949220 $Y=588180
X2725 3083 620 2 3046 1 3093 MUX2S $T=950460 558320 1 0 $X=950460 $Y=552900
X2726 3101 3089 2 3038 1 3058 MUX2S $T=956040 538160 0 180 $X=951700 $Y=532740
X2727 3098 3089 2 3038 1 3078 MUX2S $T=956660 528080 1 180 $X=952320 $Y=527700
X2728 3115 3089 2 3038 1 3073 MUX2S $T=957900 528080 0 180 $X=953560 $Y=522660
X2729 3097 620 2 3083 1 3090 MUX2S $T=957900 548240 1 180 $X=953560 $Y=547860
X2730 3051 3063 2 3004 1 3105 MUX2S $T=953560 588560 0 0 $X=953560 $Y=588180
X2731 820 3063 2 3080 1 3019 MUX2S $T=958520 598640 0 180 $X=954180 $Y=593220
X2732 3119 3089 2 3107 1 815 MUX2S $T=962240 528080 1 180 $X=957900 $Y=527700
X2733 3108 3121 2 3038 1 3107 MUX2S $T=962240 538160 0 180 $X=957900 $Y=532740
X2734 3120 600 2 3105 1 3086 MUX2S $T=962240 588560 1 180 $X=957900 $Y=588180
X2735 3103 660 2 3093 1 3122 MUX2S $T=958520 548240 0 0 $X=958520 $Y=547860
X2736 3130 3121 2 3108 1 3101 MUX2S $T=963480 538160 1 180 $X=959140 $Y=537780
X2737 3093 660 2 3077 1 3130 MUX2S $T=959140 548240 1 0 $X=959140 $Y=542820
X2738 3131 3063 2 3051 1 3025 MUX2S $T=963480 598640 0 180 $X=959140 $Y=593220
X2739 814 824 2 803 1 3131 MUX2S $T=960380 598640 0 0 $X=960380 $Y=598260
X2740 3137 3089 2 3126 1 830 MUX2S $T=967200 518000 1 180 $X=962860 $Y=517620
X2741 829 3063 2 3004 1 3141 MUX2S $T=962860 588560 0 0 $X=962860 $Y=588180
X2742 3110 3121 2 3038 1 3126 MUX2S $T=967820 528080 0 180 $X=963480 $Y=522660
X2743 3122 3121 2 3110 1 3115 MUX2S $T=963480 528080 0 0 $X=963480 $Y=527700
X2744 3144 3121 2 3130 1 3119 MUX2S $T=969060 538160 1 180 $X=964720 $Y=537780
X2745 3090 660 2 3069 1 3146 MUX2S $T=964720 548240 1 0 $X=964720 $Y=542820
X2746 834 3063 2 829 1 3052 MUX2S $T=969680 598640 0 180 $X=965340 $Y=593220
X2747 3152 600 2 3141 1 3118 MUX2S $T=972780 588560 1 180 $X=968440 $Y=588180
X2748 3156 3089 2 3145 1 816 MUX2S $T=973400 518000 1 180 $X=969060 $Y=517620
X2749 3154 3121 2 3038 1 3145 MUX2S $T=973400 528080 0 180 $X=969060 $Y=522660
X2750 3146 3121 2 3154 1 3098 MUX2S $T=969060 528080 0 0 $X=969060 $Y=527700
X2751 3069 660 2 3084 1 3161 MUX2S $T=969680 538160 0 0 $X=969680 $Y=537780
X2752 3188 3089 2 3162 1 837 MUX2S $T=978980 518000 1 180 $X=974640 $Y=517620
X2753 3161 3121 2 3038 1 3162 MUX2S $T=978980 528080 0 180 $X=974640 $Y=522660
X2754 3179 3089 2 3101 1 840 MUX2S $T=979600 528080 1 180 $X=975260 $Y=527700
X2755 3176 3187 2 3018 1 3168 MUX2S $T=981460 598640 0 180 $X=977120 $Y=593220
X2756 3159 3121 2 3161 1 3113 MUX2S $T=984560 528080 0 180 $X=980220 $Y=522660
X2757 3189 3121 2 3159 1 3188 MUX2S $T=985800 528080 1 180 $X=981460 $Y=527700
X2758 854 634 2 843 1 3223 MUX2S $T=989520 598640 0 0 $X=989520 $Y=598260
X2759 3229 3219 2 3113 1 858 MUX2S $T=998820 518000 1 180 $X=994480 $Y=517620
X2760 3244 660 2 3222 1 3220 MUX2S $T=998820 548240 1 180 $X=994480 $Y=547860
X2761 1298 1 1302 1226 2 ND2T $T=313100 578480 1 0 $X=313100 $Y=573060
X2762 1802 223 219 2 1 1816 QDFFRBS $T=468100 598640 1 0 $X=468100 $Y=593220
X2763 1996 338 289 2 1 2018 QDFFRBS $T=576600 528080 0 0 $X=576600 $Y=527700
X2764 2296 338 523 2 1 2283 QDFFRBS $T=730980 558320 0 180 $X=719200 $Y=552900
X2765 2970 769 765 2 1 2943 QDFFRBS $T=914500 588560 1 180 $X=902720 $Y=588180
X2766 2990 770 776 2 1 3003 QDFFRBS $T=920700 548240 0 0 $X=920700 $Y=547860
X2767 1214 2 1 1226 1131 NR2F $T=287060 578480 0 0 $X=287060 $Y=578100
X2768 1073 1141 42 2 1148 1111 1 AO22P $T=266600 578480 0 0 $X=266600 $Y=578100
X2769 545 2273 1 2 INV12 $T=715480 598640 0 180 $X=708040 $Y=593220
X2770 574 568 1 2 INV12 $T=723540 598640 0 0 $X=723540 $Y=598260
X2771 2793 2785 719 2827 1 2 MXL2H $T=863040 548240 0 0 $X=863040 $Y=547860
X2772 278 279 119 295 1 2 MXL2HF $T=518320 588560 1 0 $X=518320 $Y=583140
X2773 529 538 541 563 1 2 MXL2HF $T=695020 598640 0 0 $X=695020 $Y=598260
X2774 2280 557 2 2273 1 ND2F $T=715480 598640 1 0 $X=715480 $Y=593220
X2775 1465 9 1097 1 2 1510 QDFFRBT $T=358980 528080 0 0 $X=358980 $Y=527700
X2776 2170 405 473 1 2 AN2P $T=664640 588560 1 0 $X=664640 $Y=583140
X2777 2148 2167 2181 1 2 2186 HA1 $T=663400 568400 0 0 $X=663400 $Y=568020
X2778 2183 2181 2195 1 2 2194 HA1 $T=668980 588560 0 0 $X=668980 $Y=588180
X2779 2184 495 2167 1 2 2200 HA1 $T=684480 568400 1 180 $X=676420 $Y=568020
X2780 2210 2195 2226 1 2 2217 HA1 $T=683240 588560 0 0 $X=683240 $Y=588180
X2781 3 12 18 1044 1 2 XOR3P $T=225060 598640 0 0 $X=225060 $Y=598260
X2782 2780 2729 2820 1 2 AN2B1T $T=862420 538160 0 0 $X=862420 $Y=537780
X2783 1039 1055 1050 1064 1 2 MAO222P $T=239320 558320 0 0 $X=239320 $Y=557940
X2784 1353 114 113 1296 1 2 MAO222P $T=325500 518000 1 0 $X=325500 $Y=512580
X2785 1619 168 1587 1625 1 2 MAO222P $T=393700 588560 0 0 $X=393700 $Y=588180
X2786 1630 169 1625 1642 1 2 MAO222P $T=396800 598640 1 0 $X=396800 $Y=593220
X2787 2268 2266 2269 2272 1 2 MAO222P $T=709280 578480 1 0 $X=709280 $Y=573060
X2788 709 2792 710 706 1 2 MAO222P $T=861800 518000 0 180 $X=856220 $Y=512580
X2789 2824 2821 725 2814 1 2 MAO222P $T=872960 568400 1 180 $X=867380 $Y=568020
X2790 3439 3443 923 3396 1 2 MAO222P $T=1065160 588560 0 180 $X=1059580 $Y=583140
X2791 3244 862 615 620 1 2 NR3HP $T=1001920 598640 0 180 $X=994480 $Y=593220
X2792 707 2796 2 2793 2773 1 AOI12H $T=863040 548240 1 180 $X=856840 $Y=547860
X2793 1758 1 2 1775 1520 1787 999 ICV_13 $T=449500 548240 1 0 $X=449500 $Y=542820
X2794 1797 1 2 1825 1744 1842 999 ICV_13 $T=486080 538160 1 0 $X=486080 $Y=532740
X2795 1853 1 2 1861 1866 1870 999 ICV_13 $T=498480 588560 1 0 $X=498480 $Y=583140
X2796 1835 1 2 1871 1875 1887 999 ICV_13 $T=504060 528080 0 0 $X=504060 $Y=527700
X2797 1865 1 2 1873 1876 1886 999 ICV_13 $T=504060 568400 0 0 $X=504060 $Y=568020
X2798 1889 1 2 1900 1902 1907 999 ICV_13 $T=515220 538160 0 0 $X=515220 $Y=537780
X2799 1809 1 2 1914 1862 1910 999 ICV_13 $T=522040 528080 0 0 $X=522040 $Y=527700
X2800 1879 1 2 1951 1878 1963 999 ICV_13 $T=542500 538160 1 0 $X=542500 $Y=532740
X2801 1912 1 2 1969 311 1944 999 ICV_13 $T=552420 538160 1 0 $X=552420 $Y=532740
X2802 2049 1 2 2047 2021 2048 999 ICV_13 $T=600780 548240 1 0 $X=600780 $Y=542820
X2803 1807 1 2 2097 1849 441 999 ICV_13 $T=631160 598640 0 0 $X=631160 $Y=598260
X2804 2159 1 2 2149 2168 2175 999 ICV_13 $T=659060 548240 1 0 $X=659060 $Y=542820
X2805 463 1 2 479 2155 2157 999 ICV_13 $T=659680 528080 1 0 $X=659680 $Y=522660
X2806 2166 1 2 2177 484 487 999 ICV_13 $T=664020 558320 1 0 $X=664020 $Y=552900
X2807 515 1 2 522 524 535 999 ICV_13 $T=690680 518000 0 0 $X=690680 $Y=517620
X2808 2232 1 2 2228 2247 2239 999 ICV_13 $T=695640 548240 0 0 $X=695640 $Y=547860
X2809 2256 1 2 2240 2255 2233 999 ICV_13 $T=704940 548240 1 0 $X=704940 $Y=542820
X2810 2281 1 2 2284 2264 2244 999 ICV_13 $T=721060 528080 1 0 $X=721060 $Y=522660
X2811 169 1630 1625 1 2 1673 XOR3T $T=402380 598640 1 0 $X=402380 $Y=593220
X2812 2266 2268 2269 1 2 2270 XOR3T $T=714860 578480 1 0 $X=714860 $Y=573060
X2813 531 346 3510 1 2 2259 DFFN $T=698120 578480 1 0 $X=698120 $Y=573060
X2814 1431 1394 1 2 1387 OR2B1 $T=346580 548240 1 180 $X=342860 $Y=547860
X2815 1627 1617 1 2 1620 OR2B1 $T=399280 548240 1 180 $X=395560 $Y=547860
X2816 1111 42 1131 1114 1 2 OA12P $T=263500 578480 1 0 $X=263500 $Y=573060
.ENDS
***************************************
.SUBCKT ICV_15 1 2 3 4 5 6 7 8 9
** N=9 EP=9 IP=12 FDC=0
X0 1 2 3 4 5 ND2 $T=0 0 1 180 $X=-1860 $Y=-380
X1 6 4 7 8 5 ND2P $T=0 0 0 0 $X=0 $Y=-380
.ENDS
***************************************
.SUBCKT ICV_16 1 2 3 4 5 6 7 8 9
** N=9 EP=9 IP=12 FDC=0
X0 1 2 3 4 5 ND2 $T=0 0 1 180 $X=-1860 $Y=-380
X1 6 7 8 4 5 ND2 $T=0 0 0 0 $X=0 $Y=-380
.ENDS
***************************************
.SUBCKT ICV_17 1 2 3 4 5 6 7 8 9
** N=9 EP=9 IP=12 FDC=0
X0 1 2 3 4 5 ND2 $T=-1860 0 0 0 $X=-1860 $Y=-380
X1 6 7 8 4 5 ND2 $T=0 0 0 0 $X=0 $Y=-380
.ENDS
***************************************
.SUBCKT XNR2H I2 O I1 GND VCC
** N=6 EP=5 IP=0 FDC=0
.ENDS
***************************************
.SUBCKT BUF3CK I GND VCC O
** N=5 EP=4 IP=0 FDC=0
.ENDS
***************************************
.SUBCKT OAI22H B2 B1 GND A2 O A1 VCC
** N=8 EP=7 IP=0 FDC=0
.ENDS
***************************************
.SUBCKT OR2B1P B1 I1 O GND VCC
** N=6 EP=5 IP=0 FDC=0
.ENDS
***************************************
.SUBCKT ICV_18 1 2 3 4 5 6 7 8 9 10 11
** N=11 EP=11 IP=14 FDC=0
X0 1 2 3 4 5 6 7 AO22 $T=10540 0 1 180 $X=5580 $Y=-380
X1 8 9 10 4 7 XOR2HS $T=0 0 0 0 $X=0 $Y=-380
.ENDS
***************************************
.SUBCKT ICV_19 1 2 3 4 5 6 7 8 9 10 11 12 13 14 15 16 17 18 19 20
+ 21 22 23 24 25 26 27 28 29 30 31 32 33 34 35 36 37 38 39 40
+ 41 42 43 44 45 46 47 48 49 50 51 52 53 54 55 56 57 58 59 60
+ 61 62 63 64 65 66 67 68 69 70 71 72 73 74 75 76 77 78 79 80
+ 81 82 83 84 85 86 87 88 89 90 91 92 93 94 95 96 97 98 99 100
+ 101 102 103 104 105 106 107 108 109 110 111 112 113 114 115 116 117 118 119 120
+ 121 122 123 124 125 126 127 128 129 130 131 132 133 134 135 136 137 138 139 140
+ 141 142 143 144 145 146 147 148 149 150 151 152 153 154 155 156 157 158 159 160
+ 161 162 163 164 165 166 167 168 169 170 171 172 173 174 175 176 177 178 179 180
+ 181 182 183 184 185 186 187 188 189 190 191 192 193 194 195 196 197 198 199 200
+ 201 202 203 204 205 206 207 208 209 210 211 212 213 214 215 216 217 218 219 220
+ 221 222 223 224 225 226 227 228 229 230 231 232 233 234 235 236 237 238 239 240
+ 241 242 243 244 245 246 247 248 249 250 251 252 253 254 255 256 257 258 259 260
+ 261 262 263 264 265 266 267 268 269 270 271 272 273 274 275 276 277 278 279 280
+ 281 282 283 284 285 286 287 288 289 290 291 292 293 294 295 296 297 298 299 300
+ 301 302 303 304 305 306 307 308 309 310 311 312 313 314 315 316 317 318 319 320
+ 321 322 323 324 325 326 327 328 329 330 331 332 333 334 335 336 337 338 339 340
+ 341 342 343 344 345 346 347 348 349 350 351 352 353 354 355 356 357 358 359 360
+ 361 362 363 364 365 366 367 368 369 370 371 372 373 374 375 376 377 378 379 380
+ 381 382 383 384 385 386 387 388 389 390 391 392 393 394 395 396 397 398 399 400
+ 401 402 403 404 405 406 407 408 409 410 411 412 413 414 415 416 417 418 419 420
+ 421 422 423 424 425 426 427 428 429 430 431 432 433 434 435 436 437 438 439 440
+ 441 442 443 444 445 446 447 448 449 450 451 452 453 454 455 456 457 458 459 460
+ 461 462 463 464 465 466 467 468 469 470 471 472 473 474 475 476 477 478 479 480
+ 481 482 483 484 485 486 487 488 489 490 491 492 493 494 495 496 497 498 499 500
+ 501 502 503 504 505 506 507 508 509 510 511 512 513 514 515 516 517 518 519 520
+ 521 522 523 524 525 526 527 528 529 530 531 532 533 534 535 536 537 538 539 540
+ 541 542 543 544 545 546 547 548 549 550 551 552 553 554 555 556 557 558 559 560
+ 561 562 563 564 565 566 567 568 569 570 571 572 573 574 575 576 577 578 579 580
+ 581 582 583 584 585 586 587 588 589 590 591 592 593 594 595 596 597 598 599 600
+ 601 602 603 604 605 606 607 608 609 610 611 612 613 614 615 616 617 618 619 620
+ 621 622 623 624 625 626 627 628 629 630 631 632 633 634 635 636 637 638 639 640
+ 641 642 643 644 645 646 647 648 649 650 651 652 653 654 655 656 657 658 659 660
+ 661 662 663 664 665 666 667 668 669 670 671 672 673 674 675 676 677 678 679 680
+ 681 682 683 684 685 686 687 688 689 690 691 692 693 694 695 696 697 698 699 700
+ 701 702 703 704 705 706 707 708 709 710 711 712 713 714 715 716 717 718 719 720
+ 721 722 723 724 725 726 727 728 729 730 731 732 733 734 735 736 737 738 739 740
+ 741 742 743 744 745 746 747 748 749 750 751 752 753 754 755 756 757 758 759 760
+ 761 762 763 764 765 766 767 768 769 770 771 772 773 774 775 776 777 778 779 780
+ 781 782 783 784 785 786 787 788 789 790 791 792 793 794 795 796 797 798 799 800
+ 801 802 803 804 805 806 807 808 809 810 811 812 813 814 815 816 817 818 819 820
+ 821 822 823 824 825 826 827 828 829 830 831 832 833 834 835 836 837 838 839 840
+ 841 842 843 844 845 846 847 848 849 850 851 852 853 854 855 856 857 858 859 860
+ 861 862 863 864 865 866 867 868 869 870 871 872 873 874 875 876 877 878 879 880
+ 881 882 883 884 885 886 887 888 889 890 891 892 893 894 895 896 897 898 899 900
+ 901 902 905 936
** N=4892 EP=904 IP=26561 FDC=0
X0 902 898 898 898 4358 898 905 YA2GSD $T=1309440 404530 0 90 $X=1169940 $Y=407380
X1 428 425 410 1 2 QDFFN $T=689440 507920 0 180 $X=678900 $Y=502500
X2 3454 426 3486 1 2 QDFFN $T=686960 467600 1 0 $X=686960 $Y=462180
X3 3494 447 3459 1 2 QDFFN $T=698120 376880 1 180 $X=687580 $Y=376500
X4 3494 448 3461 1 2 QDFFN $T=699360 366800 1 180 $X=688820 $Y=366420
X5 3440 426 3497 1 2 QDFFN $T=688820 467600 0 0 $X=688820 $Y=467220
X6 3463 425 3506 1 2 QDFFN $T=689440 507920 1 0 $X=689440 $Y=502500
X7 3465 425 3511 1 2 QDFFN $T=690060 487760 0 0 $X=690060 $Y=487380
X8 3467 426 3510 1 2 QDFFN $T=690680 477680 0 0 $X=690680 $Y=477300
X9 436 425 3523 1 2 QDFFN $T=691300 497840 1 0 $X=691300 $Y=492420
X10 443 448 3546 1 2 QDFFN $T=694400 366800 1 0 $X=694400 $Y=361380
X11 3494 458 3480 1 2 QDFFN $T=706180 386960 0 180 $X=695640 $Y=381540
X12 3492 426 3555 1 2 QDFFN $T=696880 457520 0 0 $X=696880 $Y=457140
X13 3493 447 3561 1 2 QDFFN $T=697500 376880 1 0 $X=697500 $Y=371460
X14 3493 458 3560 1 2 QDFFN $T=699360 376880 0 0 $X=699360 $Y=376500
X15 443 458 3565 1 2 QDFFN $T=699980 366800 0 0 $X=699980 $Y=366420
X16 3563 469 3516 1 2 QDFFN $T=710520 507920 0 180 $X=699980 $Y=502500
X17 3513 426 3568 1 2 QDFFN $T=700600 467600 1 0 $X=700600 $Y=462180
X18 3520 426 3579 1 2 QDFFN $T=701840 457520 1 0 $X=701840 $Y=452100
X19 3577 469 3531 1 2 QDFFN $T=713000 497840 1 180 $X=702460 $Y=497460
X20 3493 468 3584 1 2 QDFFN $T=706180 386960 1 0 $X=706180 $Y=381540
X21 3593 469 3529 1 2 QDFFN $T=716720 487760 1 180 $X=706180 $Y=487380
X22 3595 469 3548 1 2 QDFFN $T=717340 487760 0 180 $X=706800 $Y=482340
X23 3604 469 3551 1 2 QDFFN $T=719200 477680 0 180 $X=708660 $Y=472260
X24 3493 448 3599 1 2 QDFFN $T=711140 366800 0 0 $X=711140 $Y=366420
X25 3617 469 3575 1 2 QDFFN $T=722300 447440 0 180 $X=711760 $Y=442020
X26 3613 469 3571 1 2 QDFFN $T=722300 467600 0 180 $X=711760 $Y=462180
X27 3494 468 3609 1 2 QDFFN $T=713000 397040 1 0 $X=713000 $Y=391620
X28 3611 469 3585 1 2 QDFFN $T=724160 457520 0 180 $X=713620 $Y=452100
X29 3620 469 3559 1 2 QDFFN $T=724780 467600 1 180 $X=714240 $Y=467220
X30 3625 495 3591 1 2 QDFFN $T=726020 507920 0 180 $X=715480 $Y=502500
X31 3631 469 3602 1 2 QDFFN $T=729120 437360 0 180 $X=718580 $Y=431940
X32 3637 495 3614 1 2 QDFFN $T=731600 487760 0 180 $X=721060 $Y=482340
X33 3636 495 3603 1 2 QDFFN $T=731600 497840 0 180 $X=721060 $Y=492420
X34 3616 448 3645 1 2 QDFFN $T=722300 366800 0 0 $X=722300 $Y=366420
X35 3616 447 3643 1 2 QDFFN $T=722300 376880 0 0 $X=722300 $Y=376500
X36 491 448 509 1 2 QDFFN $T=722920 366800 1 0 $X=722920 $Y=361380
X37 3649 495 3610 1 2 QDFFN $T=734700 477680 1 180 $X=724160 $Y=477300
X38 3616 468 3638 1 2 QDFFN $T=724780 397040 1 0 $X=724780 $Y=391620
X39 3616 458 3653 1 2 QDFFN $T=726020 386960 0 0 $X=726020 $Y=386580
X40 3626 495 3640 1 2 QDFFN $T=726020 457520 1 0 $X=726020 $Y=452100
X41 3648 495 3628 1 2 QDFFN $T=737180 467600 1 180 $X=726640 $Y=467220
X42 3681 448 3647 1 2 QDFFN $T=744000 366800 1 180 $X=733460 $Y=366420
X43 3681 468 3644 1 2 QDFFN $T=744000 397040 1 180 $X=733460 $Y=396660
X44 491 468 508 1 2 QDFFN $T=745240 366800 0 180 $X=734700 $Y=361380
X45 3654 495 3676 1 2 QDFFN $T=735320 447440 1 0 $X=735320 $Y=442020
X46 3656 495 3659 1 2 QDFFN $T=747100 457520 1 180 $X=736560 $Y=457140
X47 3681 458 3661 1 2 QDFFN $T=747720 386960 1 180 $X=737180 $Y=386580
X48 3681 447 3668 1 2 QDFFN $T=750820 376880 1 180 $X=740280 $Y=376500
X49 3680 495 3696 1 2 QDFFN $T=744000 447440 0 0 $X=744000 $Y=447060
X50 3682 468 3705 1 2 QDFFN $T=745240 397040 0 0 $X=745240 $Y=396660
X51 3682 447 3704 1 2 QDFFN $T=745860 376880 1 0 $X=745860 $Y=371460
X52 3682 448 3693 1 2 QDFFN $T=746480 366800 1 0 $X=746480 $Y=361380
X53 3682 458 3745 1 2 QDFFN $T=752060 386960 0 0 $X=752060 $Y=386580
X54 3711 545 3750 1 2 QDFFN $T=752060 447440 1 0 $X=752060 $Y=442020
X55 3681 546 3746 1 2 QDFFN $T=752680 366800 0 0 $X=752680 $Y=366420
X56 3681 547 3742 1 2 QDFFN $T=752680 386960 1 0 $X=752680 $Y=381540
X57 3681 554 3760 1 2 QDFFN $T=756400 397040 0 0 $X=756400 $Y=396660
X58 491 547 555 1 2 QDFFN $T=768800 366800 0 180 $X=758260 $Y=361380
X59 3681 571 3744 1 2 QDFFN $T=771900 407120 0 180 $X=761360 $Y=401700
X60 564 545 3793 1 2 QDFFN $T=763220 437360 0 0 $X=763220 $Y=436980
X61 3757 545 3797 1 2 QDFFN $T=763220 447440 1 0 $X=763220 $Y=442020
X62 3493 546 3762 1 2 QDFFN $T=774380 366800 1 180 $X=763840 $Y=366420
X63 3493 547 3765 1 2 QDFFN $T=775000 386960 0 180 $X=764460 $Y=381540
X64 3767 545 3812 1 2 QDFFN $T=765080 457520 1 0 $X=765080 $Y=452100
X65 3493 571 3810 1 2 QDFFN $T=767560 397040 0 0 $X=767560 $Y=396660
X66 3752 545 3820 1 2 QDFFN $T=768800 447440 0 0 $X=768800 $Y=447060
X67 3493 554 3782 1 2 QDFFN $T=779960 397040 0 180 $X=769420 $Y=391620
X68 491 571 575 1 2 QDFFN $T=780580 366800 0 180 $X=770040 $Y=361380
X69 3682 546 3837 1 2 QDFFN $T=773760 376880 0 0 $X=773760 $Y=376500
X70 3682 547 3849 1 2 QDFFN $T=775000 376880 1 0 $X=775000 $Y=371460
X71 3805 545 3850 1 2 QDFFN $T=775000 447440 1 0 $X=775000 $Y=442020
X72 3796 545 3852 1 2 QDFFN $T=776240 467600 1 0 $X=776240 $Y=462180
X73 3682 571 3847 1 2 QDFFN $T=776860 386960 1 0 $X=776860 $Y=381540
X74 3804 545 3860 1 2 QDFFN $T=777480 457520 1 0 $X=777480 $Y=452100
X75 3682 554 3859 1 2 QDFFN $T=781820 397040 1 0 $X=781820 $Y=391620
X76 443 554 3875 1 2 QDFFN $T=782440 366800 0 0 $X=782440 $Y=366420
X77 3799 545 3892 1 2 QDFFN $T=783680 467600 0 0 $X=783680 $Y=467220
X78 585 545 3903 1 2 QDFFN $T=784300 447440 0 0 $X=784300 $Y=447060
X79 3786 545 3894 1 2 QDFFN $T=784920 437360 0 0 $X=784920 $Y=436980
X80 3494 546 3862 1 2 QDFFN $T=797320 376880 0 180 $X=786780 $Y=371460
X81 3863 545 3904 1 2 QDFFN $T=787400 457520 0 0 $X=787400 $Y=457140
X82 3687 545 3920 1 2 QDFFN $T=788020 467600 1 0 $X=788020 $Y=462180
X83 3616 571 3918 1 2 QDFFN $T=788640 397040 0 0 $X=788640 $Y=396660
X84 3494 571 3921 1 2 QDFFN $T=791120 407120 1 0 $X=791120 $Y=401700
X85 3616 546 3886 1 2 QDFFN $T=803520 366800 1 180 $X=792980 $Y=366420
X86 3890 545 3941 1 2 QDFFN $T=796080 467600 0 0 $X=796080 $Y=467220
X87 3758 545 3957 1 2 QDFFN $T=797940 447440 1 0 $X=797940 $Y=442020
X88 3730 545 3963 1 2 QDFFN $T=797940 447440 0 0 $X=797940 $Y=447060
X89 443 547 601 1 2 QDFFN $T=809100 366800 0 180 $X=798560 $Y=361380
X90 3923 545 3964 1 2 QDFFN $T=799800 467600 1 0 $X=799800 $Y=462180
X91 3616 547 3915 1 2 QDFFN $T=812200 376880 0 180 $X=801660 $Y=371460
X92 3494 554 3905 1 2 QDFFN $T=812200 386960 0 180 $X=801660 $Y=381540
X93 3494 547 3884 1 2 QDFFN $T=812820 376880 1 180 $X=802280 $Y=376500
X94 3616 554 3906 1 2 QDFFN $T=812820 397040 0 180 $X=802280 $Y=391620
X95 3494 608 3967 1 2 QDFFN $T=802280 407120 1 0 $X=802280 $Y=401700
X96 3616 608 3968 1 2 QDFFN $T=802280 417200 1 0 $X=802280 $Y=411780
X97 491 608 3965 1 2 QDFFN $T=803520 366800 0 0 $X=803520 $Y=366420
X98 3991 469 3877 1 2 QDFFN $T=820880 457520 0 180 $X=810340 $Y=452100
X99 4000 469 3944 1 2 QDFFN $T=822120 447440 0 180 $X=811580 $Y=442020
X100 443 608 3997 1 2 QDFFN $T=812820 376880 1 0 $X=812820 $Y=371460
X101 588 617 3998 1 2 QDFFN $T=813440 366800 1 0 $X=813440 $Y=361380
X102 3681 608 3993 1 2 QDFFN $T=813440 417200 1 0 $X=813440 $Y=411780
X103 588 619 4004 1 2 QDFFN $T=814060 366800 0 0 $X=814060 $Y=366420
X104 3682 608 3972 1 2 QDFFN $T=824600 386960 1 180 $X=814060 $Y=386580
X105 3493 608 3978 1 2 QDFFN $T=826460 397040 1 180 $X=815920 $Y=396660
X106 4015 629 3962 1 2 QDFFN $T=826460 457520 1 180 $X=815920 $Y=457140
X107 4008 629 3959 1 2 QDFFN $T=827080 467600 1 180 $X=816540 $Y=467220
X108 4024 469 3791 1 2 QDFFN $T=828320 437360 1 180 $X=817780 $Y=436980
X109 3616 619 4030 1 2 QDFFN $T=820260 407120 1 0 $X=820260 $Y=401700
X110 3616 625 4032 1 2 QDFFN $T=820880 427280 1 0 $X=820880 $Y=421860
X111 3616 617 4036 1 2 QDFFN $T=821500 397040 1 0 $X=821500 $Y=391620
X112 3616 627 4038 1 2 QDFFN $T=821500 417200 0 0 $X=821500 $Y=416820
X113 3616 633 4053 1 2 QDFFN $T=823980 376880 1 0 $X=823980 $Y=371460
X114 3616 636 4049 1 2 QDFFN $T=824600 366800 0 0 $X=824600 $Y=366420
X115 3616 637 4041 1 2 QDFFN $T=825840 386960 0 0 $X=825840 $Y=386580
X116 4043 469 3983 1 2 QDFFN $T=837000 437360 0 180 $X=826460 $Y=431940
X117 4031 629 3975 1 2 QDFFN $T=837000 467600 0 180 $X=826460 $Y=462180
X118 4042 629 3999 1 2 QDFFN $T=837620 457520 1 180 $X=827080 $Y=457140
X119 4069 469 3982 1 2 QDFFN $T=840100 437360 1 180 $X=829560 $Y=436980
X120 3681 619 4068 1 2 QDFFN $T=831420 407120 1 0 $X=831420 $Y=401700
X121 4072 469 3979 1 2 QDFFN $T=841960 427280 1 180 $X=831420 $Y=426900
X122 3681 625 4075 1 2 QDFFN $T=832660 427280 1 0 $X=832660 $Y=421860
X123 3681 633 4079 1 2 QDFFN $T=833280 366800 1 0 $X=833280 $Y=361380
X124 3681 617 4081 1 2 QDFFN $T=833280 397040 1 0 $X=833280 $Y=391620
X125 3681 627 4070 1 2 QDFFN $T=833900 417200 0 0 $X=833900 $Y=416820
X126 4051 629 4074 1 2 QDFFN $T=833900 457520 1 0 $X=833900 $Y=452100
X127 3681 636 4085 1 2 QDFFN $T=835140 376880 1 0 $X=835140 $Y=371460
X128 3681 637 4088 1 2 QDFFN $T=838240 386960 0 0 $X=838240 $Y=386580
X129 4089 469 3958 1 2 QDFFN $T=848780 437360 0 180 $X=838240 $Y=431940
X130 4076 629 4063 1 2 QDFFN $T=848780 467600 0 180 $X=838240 $Y=462180
X131 4107 469 3980 1 2 QDFFN $T=851880 437360 1 180 $X=841340 $Y=436980
X132 3682 619 4095 1 2 QDFFN $T=841960 407120 1 0 $X=841960 $Y=401700
X133 666 617 4106 1 2 QDFFN $T=843820 366800 1 0 $X=843820 $Y=361380
X134 3682 625 4104 1 2 QDFFN $T=844440 417200 0 0 $X=844440 $Y=416820
X135 4115 469 4014 1 2 QDFFN $T=854980 427280 1 180 $X=844440 $Y=426900
X136 3682 617 4102 1 2 QDFFN $T=845060 397040 1 0 $X=845060 $Y=391620
X137 4096 629 4087 1 2 QDFFN $T=855600 457520 0 180 $X=845060 $Y=452100
X138 3682 627 4113 1 2 QDFFN $T=846300 417200 1 0 $X=846300 $Y=411780
X139 4144 469 4002 1 2 QDFFN $T=859940 437360 0 180 $X=849400 $Y=431940
X140 3682 636 4108 1 2 QDFFN $T=850020 376880 1 0 $X=850020 $Y=371460
X141 3682 637 4114 1 2 QDFFN $T=850020 386960 0 0 $X=850020 $Y=386580
X142 3682 633 4099 1 2 QDFFN $T=850640 376880 0 0 $X=850640 $Y=376500
X143 4164 469 3783 1 2 QDFFN $T=862420 437360 1 180 $X=851880 $Y=436980
X144 491 625 4157 1 2 QDFFN $T=854360 366800 1 0 $X=854360 $Y=361380
X145 4150 629 4121 1 2 QDFFN $T=864900 447440 1 180 $X=854360 $Y=447060
X146 443 625 4165 1 2 QDFFN $T=855600 417200 0 0 $X=855600 $Y=416820
X147 4124 629 4112 1 2 QDFFN $T=866760 467600 0 180 $X=856220 $Y=462180
X148 443 617 4170 1 2 QDFFN $T=856840 397040 1 0 $X=856840 $Y=391620
X149 4175 629 4134 1 2 QDFFN $T=868000 457520 0 180 $X=857460 $Y=452100
X150 4176 629 4105 1 2 QDFFN $T=868000 467600 1 180 $X=857460 $Y=467220
X151 443 627 4162 1 2 QDFFN $T=858080 417200 1 0 $X=858080 $Y=411780
X152 443 619 4172 1 2 QDFFN $T=861180 407120 1 0 $X=861180 $Y=401700
X153 443 633 4181 1 2 QDFFN $T=861800 376880 1 0 $X=861800 $Y=371460
X154 443 637 4163 1 2 QDFFN $T=861800 386960 0 0 $X=861800 $Y=386580
X155 491 627 4198 1 2 QDFFN $T=864900 366800 1 0 $X=864900 $Y=361380
X156 443 636 4167 1 2 QDFFN $T=865520 366800 0 0 $X=865520 $Y=366420
X157 3494 625 4211 1 2 QDFFN $T=867380 417200 0 0 $X=867380 $Y=416820
X158 3494 617 4207 1 2 QDFFN $T=868620 397040 1 0 $X=868620 $Y=391620
X159 3494 627 4208 1 2 QDFFN $T=869860 417200 1 0 $X=869860 $Y=411780
X160 3494 633 4222 1 2 QDFFN $T=872960 376880 0 0 $X=872960 $Y=376500
X161 3494 637 4209 1 2 QDFFN $T=872960 386960 0 0 $X=872960 $Y=386580
X162 3494 619 4210 1 2 QDFFN $T=872960 407120 1 0 $X=872960 $Y=401700
X163 3494 636 4212 1 2 QDFFN $T=874820 376880 1 0 $X=874820 $Y=371460
X164 4250 629 4189 1 2 QDFFN $T=888460 467600 0 180 $X=877920 $Y=462180
X165 3493 625 4235 1 2 QDFFN $T=878540 427280 1 0 $X=878540 $Y=421860
X166 4241 629 4194 1 2 QDFFN $T=889080 457520 0 180 $X=878540 $Y=452100
X167 4247 629 4195 1 2 QDFFN $T=889700 457520 1 180 $X=879160 $Y=457140
X168 4254 629 4197 1 2 QDFFN $T=890320 467600 1 180 $X=879780 $Y=467220
X169 3493 617 4227 1 2 QDFFN $T=881020 397040 1 0 $X=881020 $Y=391620
X170 491 636 709 1 2 QDFFN $T=892180 366800 1 180 $X=881640 $Y=366420
X171 3493 627 4249 1 2 QDFFN $T=881640 417200 1 0 $X=881640 $Y=411780
X172 4260 629 4205 1 2 QDFFN $T=892800 487760 0 180 $X=882260 $Y=482340
X173 4238 629 4204 1 2 QDFFN $T=894040 477680 0 180 $X=883500 $Y=472260
X174 3493 619 4223 1 2 QDFFN $T=884120 407120 1 0 $X=884120 $Y=401700
X175 3493 633 4265 1 2 QDFFN $T=884740 376880 0 0 $X=884740 $Y=376500
X176 3493 637 4239 1 2 QDFFN $T=884740 386960 0 0 $X=884740 $Y=386580
X177 3493 636 4248 1 2 QDFFN $T=885360 376880 1 0 $X=885360 $Y=371460
X178 3781 730 4303 1 2 QDFFN $T=894660 407120 1 0 $X=894660 $Y=401700
X179 3594 730 4295 1 2 QDFFN $T=894660 417200 1 0 $X=894660 $Y=411780
X180 3598 730 4310 1 2 QDFFN $T=895280 407120 0 0 $X=895280 $Y=406740
X181 3623 730 4300 1 2 QDFFN $T=896520 386960 1 0 $X=896520 $Y=381540
X182 3598 753 4302 1 2 QDFFN $T=916980 407120 0 180 $X=906440 $Y=401700
X183 502 730 4348 1 2 QDFFN $T=907060 366800 0 0 $X=907060 $Y=366420
X184 3781 753 4306 1 2 QDFFN $T=917600 397040 0 180 $X=907060 $Y=391620
X185 3623 753 4331 1 2 QDFFN $T=907680 386960 0 0 $X=907680 $Y=386580
X186 502 753 4357 1 2 QDFFN $T=908920 376880 0 0 $X=908920 $Y=376500
X187 3594 768 4324 1 2 QDFFN $T=921940 417200 1 180 $X=911400 $Y=416820
X188 3594 753 4312 1 2 QDFFN $T=923180 407120 1 180 $X=912640 $Y=406740
X189 3594 760 4370 1 2 QDFFN $T=913260 417200 1 0 $X=913260 $Y=411780
X190 3594 764 4365 1 2 QDFFN $T=915740 437360 0 0 $X=915740 $Y=436980
X191 3598 760 4395 1 2 QDFFN $T=917600 407120 1 0 $X=917600 $Y=401700
X192 3781 760 4399 1 2 QDFFN $T=918220 397040 1 0 $X=918220 $Y=391620
X193 502 764 4404 1 2 QDFFN $T=919460 376880 1 0 $X=919460 $Y=371460
X194 3623 764 4405 1 2 QDFFN $T=919460 386960 0 0 $X=919460 $Y=386580
X195 3594 774 4416 1 2 QDFFN $T=919460 447440 1 0 $X=919460 $Y=442020
X196 3623 768 4412 1 2 QDFFN $T=920700 376880 0 0 $X=920700 $Y=376500
X197 502 768 4421 1 2 QDFFN $T=923800 366800 0 0 $X=923800 $Y=366420
X198 3598 768 4423 1 2 QDFFN $T=925040 417200 1 0 $X=925040 $Y=411780
X199 3781 768 4438 1 2 QDFFN $T=929380 407120 1 0 $X=929380 $Y=401700
X200 502 760 4433 1 2 QDFFN $T=930000 376880 1 0 $X=930000 $Y=371460
X201 3781 764 4427 1 2 QDFFN $T=930000 397040 1 0 $X=930000 $Y=391620
X202 3598 774 4410 1 2 QDFFN $T=940540 427280 1 180 $X=930000 $Y=426900
X203 3623 760 4437 1 2 QDFFN $T=931240 386960 0 0 $X=931240 $Y=386580
X204 3624 764 4455 1 2 QDFFN $T=931240 437360 1 0 $X=931240 $Y=431940
X205 3594 793 4407 1 2 QDFFN $T=942400 447440 0 180 $X=931860 $Y=442020
X206 3598 764 4397 1 2 QDFFN $T=944260 407120 1 180 $X=933720 $Y=406740
X207 3598 793 4413 1 2 QDFFN $T=946740 427280 0 180 $X=936200 $Y=421860
X208 3624 774 4470 1 2 QDFFN $T=936200 437360 0 0 $X=936200 $Y=436980
X209 3624 730 4484 1 2 QDFFN $T=936820 417200 0 0 $X=936820 $Y=416820
X210 3623 793 4475 1 2 QDFFN $T=940540 376880 1 0 $X=940540 $Y=371460
X211 3781 793 4467 1 2 QDFFN $T=941160 407120 1 0 $X=941160 $Y=401700
X212 3781 774 4476 1 2 QDFFN $T=941780 397040 1 0 $X=941780 $Y=391620
X213 3623 774 4480 1 2 QDFFN $T=943020 386960 0 0 $X=943020 $Y=386580
X214 3624 793 4485 1 2 QDFFN $T=943640 447440 1 0 $X=943640 $Y=442020
X215 502 793 4456 1 2 QDFFN $T=956040 366800 1 180 $X=945500 $Y=366420
X216 3624 753 4495 1 2 QDFFN $T=945500 407120 0 0 $X=945500 $Y=406740
X217 3624 760 4487 1 2 QDFFN $T=946740 427280 1 0 $X=946740 $Y=421860
X218 3624 768 4479 1 2 QDFFN $T=957900 427280 1 180 $X=947360 $Y=426900
X219 808 730 4516 1 2 QDFFN $T=951080 376880 1 0 $X=951080 $Y=371460
X220 3901 730 4491 1 2 QDFFN $T=963480 397040 1 180 $X=952940 $Y=396660
X221 4473 753 4492 1 2 QDFFN $T=963480 407120 0 180 $X=952940 $Y=401700
X222 808 753 4531 1 2 QDFFN $T=953560 366800 1 0 $X=953560 $Y=361380
X223 808 768 4529 1 2 QDFFN $T=953560 376880 0 0 $X=953560 $Y=376500
X224 3901 753 4496 1 2 QDFFN $T=965340 386960 1 180 $X=954800 $Y=386580
X225 4473 768 4548 1 2 QDFFN $T=956040 437360 0 0 $X=956040 $Y=436980
X226 4473 774 4545 1 2 QDFFN $T=956040 447440 1 0 $X=956040 $Y=442020
X227 4473 793 4547 1 2 QDFFN $T=957280 447440 0 0 $X=957280 $Y=447060
X228 4473 730 4509 1 2 QDFFN $T=968440 417200 0 180 $X=957900 $Y=411780
X229 4473 760 4538 1 2 QDFFN $T=959140 427280 0 0 $X=959140 $Y=426900
X230 572 768 823 1 2 QDFFN $T=961620 376880 1 0 $X=961620 $Y=371460
X231 3808 730 4563 1 2 QDFFN $T=963480 417200 0 0 $X=963480 $Y=416820
X232 3901 768 4569 1 2 QDFFN $T=964100 407120 1 0 $X=964100 $Y=401700
X233 3808 753 4565 1 2 QDFFN $T=964100 407120 0 0 $X=964100 $Y=406740
X234 4473 764 4543 1 2 QDFFN $T=978360 437360 1 180 $X=967820 $Y=436980
X235 3808 793 4582 1 2 QDFFN $T=969680 447440 0 0 $X=969680 $Y=447060
X236 3808 768 4600 1 2 QDFFN $T=970920 437360 1 0 $X=970920 $Y=431940
X237 572 793 824 1 2 QDFFN $T=982080 366800 0 180 $X=971540 $Y=361380
X238 808 764 4554 1 2 QDFFN $T=982700 376880 0 180 $X=972160 $Y=371460
X239 3901 760 4552 1 2 QDFFN $T=985800 407120 0 180 $X=975260 $Y=401700
X240 3901 793 4581 1 2 QDFFN $T=986420 386960 0 180 $X=975880 $Y=381540
X241 3808 764 4575 1 2 QDFFN $T=986420 407120 1 180 $X=975880 $Y=406740
X242 3901 764 4556 1 2 QDFFN $T=987040 397040 1 180 $X=976500 $Y=396660
X243 3808 760 4584 1 2 QDFFN $T=987660 417200 0 180 $X=977120 $Y=411780
X244 808 774 4583 1 2 QDFFN $T=988280 366800 1 180 $X=977740 $Y=366420
X245 808 760 4558 1 2 QDFFN $T=989520 376880 1 180 $X=978980 $Y=376500
X246 3594 833 4633 1 2 QDFFN $T=980220 437360 0 0 $X=980220 $Y=436980
X247 3808 774 4576 1 2 QDFFN $T=992000 447440 0 180 $X=981460 $Y=442020
X248 808 833 4627 1 2 QDFFN $T=982080 366800 1 0 $X=982080 $Y=361380
X249 808 793 4580 1 2 QDFFN $T=993240 376880 0 180 $X=982700 $Y=371460
X250 3808 833 4604 1 2 QDFFN $T=993860 417200 1 180 $X=983320 $Y=416820
X251 3901 774 4598 1 2 QDFFN $T=995100 397040 0 180 $X=984560 $Y=391620
X252 3624 833 4631 1 2 QDFFN $T=984560 437360 1 0 $X=984560 $Y=431940
X253 3781 833 4637 1 2 QDFFN $T=987040 407120 1 0 $X=987040 $Y=401700
X254 3623 833 4638 1 2 QDFFN $T=987660 386960 0 0 $X=987660 $Y=386580
X255 4473 833 4619 1 2 QDFFN $T=998200 407120 1 180 $X=987660 $Y=406740
X256 3901 833 4644 1 2 QDFFN $T=988900 397040 0 0 $X=988900 $Y=396660
X257 3808 842 4661 1 2 QDFFN $T=992000 447440 1 0 $X=992000 $Y=442020
X258 808 843 4659 1 2 QDFFN $T=992620 366800 1 0 $X=992620 $Y=361380
X259 502 833 4643 1 2 QDFFN $T=993240 376880 1 0 $X=993240 $Y=371460
X260 3624 842 4664 1 2 QDFFN $T=994480 447440 0 0 $X=994480 $Y=447060
X261 3598 833 4646 1 2 QDFFN $T=995100 417200 0 0 $X=995100 $Y=416820
X262 3624 843 4666 1 2 QDFFN $T=996340 457520 1 0 $X=996340 $Y=452100
X263 4473 843 4671 1 2 QDFFN $T=997580 417200 1 0 $X=997580 $Y=411780
X264 3623 843 4673 1 2 QDFFN $T=998200 376880 0 0 $X=998200 $Y=376500
X265 3781 843 4674 1 2 QDFFN $T=998200 407120 1 0 $X=998200 $Y=401700
X266 3901 843 4679 1 2 QDFFN $T=999440 386960 0 0 $X=999440 $Y=386580
X267 3598 842 4693 1 2 QDFFN $T=1000060 427280 1 0 $X=1000060 $Y=421860
X268 3594 843 4684 1 2 QDFFN $T=1001920 427280 0 0 $X=1001920 $Y=426900
X269 3623 842 4690 1 2 QDFFN $T=1003780 376880 1 0 $X=1003780 $Y=371460
X270 808 842 4694 1 2 QDFFN $T=1005020 366800 0 0 $X=1005020 $Y=366420
X271 3781 842 4685 1 2 QDFFN $T=1006260 397040 0 0 $X=1006260 $Y=396660
X272 3598 843 4702 1 2 QDFFN $T=1006260 417200 0 0 $X=1006260 $Y=416820
X273 3594 842 4699 1 2 QDFFN $T=1006260 437360 0 0 $X=1006260 $Y=436980
X274 3808 843 4708 1 2 QDFFN $T=1006880 447440 0 0 $X=1006880 $Y=447060
X275 502 843 4706 1 2 QDFFN $T=1008120 366800 1 0 $X=1008120 $Y=361380
X276 4473 842 4676 1 2 QDFFN $T=1018660 407120 1 180 $X=1008120 $Y=406740
X277 3901 842 4689 1 2 QDFFN $T=1022380 386960 0 180 $X=1011840 $Y=381540
X278 502 842 4698 1 2 QDFFN $T=1025480 376880 0 180 $X=1014940 $Y=371460
X279 3624 856 4727 1 2 QDFFN $T=1016800 457520 1 0 $X=1016800 $Y=452100
X280 3781 856 4711 1 2 QDFFN $T=1028580 397040 1 180 $X=1018040 $Y=396660
X281 3598 856 4753 1 2 QDFFN $T=1018040 417200 0 0 $X=1018040 $Y=416820
X282 3624 859 4720 1 2 QDFFN $T=1029200 447440 1 180 $X=1018660 $Y=447060
X283 4473 859 4752 1 2 QDFFN $T=1019900 417200 1 0 $X=1019900 $Y=411780
X284 3781 859 4722 1 2 QDFFN $T=1031060 407120 1 180 $X=1020520 $Y=406740
X285 3623 856 4739 1 2 QDFFN $T=1034780 376880 1 180 $X=1024240 $Y=376500
X286 502 856 4747 1 2 QDFFN $T=1037880 376880 0 180 $X=1027340 $Y=371460
X287 3901 856 4775 1 2 QDFFN $T=1027340 407120 1 0 $X=1027340 $Y=401700
X288 4777 856 4751 1 2 QDFFN $T=1039120 457520 0 180 $X=1028580 $Y=452100
X289 4473 856 4759 1 2 QDFFN $T=1040360 417200 1 180 $X=1029820 $Y=416820
X290 3808 859 4761 1 2 QDFFN $T=1041600 447440 1 180 $X=1031060 $Y=447060
X291 808 859 4756 1 2 QDFFN $T=1042220 366800 0 180 $X=1031680 $Y=361380
X292 502 859 4760 1 2 QDFFN $T=1043460 366800 1 180 $X=1032920 $Y=366420
X293 4473 869 4791 1 2 QDFFN $T=1032920 407120 0 0 $X=1032920 $Y=406740
X294 3594 856 4767 1 2 QDFFN $T=1043460 437360 1 180 $X=1032920 $Y=436980
X295 3901 859 4774 1 2 QDFFN $T=1044700 397040 0 180 $X=1034160 $Y=391620
X296 3623 859 4757 1 2 QDFFN $T=1045320 386960 0 180 $X=1034780 $Y=381540
X297 502 869 4794 1 2 QDFFN $T=1036640 376880 0 0 $X=1036640 $Y=376500
X298 3598 859 4770 1 2 QDFFN $T=1047800 427280 0 180 $X=1037260 $Y=421860
X299 3594 859 4771 1 2 QDFFN $T=1047800 437360 0 180 $X=1037260 $Y=431940
X300 4473 873 4801 1 2 QDFFN $T=1039120 447440 1 0 $X=1039120 $Y=442020
X301 3781 873 4807 1 2 QDFFN $T=1040360 407120 1 0 $X=1040360 $Y=401700
X302 3808 873 4804 1 2 QDFFN $T=1040980 457520 1 0 $X=1040980 $Y=452100
X303 4473 877 4803 1 2 QDFFN $T=1042220 417200 0 0 $X=1042220 $Y=416820
X304 502 877 4789 1 2 QDFFN $T=1053380 366800 0 180 $X=1042840 $Y=361380
X305 3808 869 4813 1 2 QDFFN $T=1044700 407120 0 0 $X=1044700 $Y=406740
X306 4473 882 4811 1 2 QDFFN $T=1045320 437360 0 0 $X=1045320 $Y=436980
X307 3781 869 4830 1 2 QDFFN $T=1047180 386960 1 0 $X=1047180 $Y=381540
X308 3781 877 4828 1 2 QDFFN $T=1048420 386960 0 0 $X=1048420 $Y=386580
X309 3808 877 4826 1 2 QDFFN $T=1049040 427280 1 0 $X=1049040 $Y=421860
X310 3781 882 4810 1 2 QDFFN $T=1052140 407120 1 0 $X=1052140 $Y=401700
X311 502 873 4834 1 2 QDFFN $T=1052760 376880 0 0 $X=1052760 $Y=376500
X312 502 882 4829 1 2 QDFFN $T=1053380 366800 1 0 $X=1053380 $Y=361380
X313 3598 877 4836 1 2 QDFFN $T=1054000 417200 0 0 $X=1054000 $Y=416820
X314 3808 882 4817 1 2 QDFFN $T=1054000 457520 1 0 $X=1054000 $Y=452100
X315 3598 869 4831 1 2 QDFFN $T=1056480 407120 0 0 $X=1056480 $Y=406740
X316 3901 882 4858 1 2 QDFFN $T=1057100 397040 0 0 $X=1057100 $Y=396660
X317 3598 873 4845 1 2 QDFFN $T=1057720 437360 0 0 $X=1057720 $Y=436980
X318 3623 882 4853 1 2 QDFFN $T=1060820 386960 1 0 $X=1060820 $Y=381540
X319 3598 882 4832 1 2 QDFFN $T=1062060 447440 1 0 $X=1062060 $Y=442020
X320 3623 873 4840 1 2 QDFFN $T=1074460 376880 0 180 $X=1063920 $Y=371460
X321 808 882 4856 1 2 QDFFN $T=1064540 366800 0 0 $X=1064540 $Y=366420
X322 3901 873 4869 1 2 QDFFN $T=1064540 407120 1 0 $X=1064540 $Y=401700
X323 3624 869 4886 1 2 QDFFN $T=1069500 417200 0 0 $X=1069500 $Y=416820
X324 3594 882 4860 1 2 QDFFN $T=1070120 437360 0 0 $X=1070120 $Y=436980
X325 3624 882 4874 1 2 QDFFN $T=1070120 457520 1 0 $X=1070120 $Y=452100
X326 3901 869 4885 1 2 QDFFN $T=1071980 397040 1 0 $X=1071980 $Y=391620
X327 3624 873 4882 1 2 QDFFN $T=1071980 457520 0 0 $X=1071980 $Y=457140
X328 3624 877 4889 1 2 QDFFN $T=1075700 427280 1 0 $X=1075700 $Y=421860
X329 808 873 4873 1 2 QDFFN $T=1076940 366800 0 0 $X=1076940 $Y=366420
X330 3623 877 4890 1 2 QDFFN $T=1076940 376880 1 0 $X=1076940 $Y=371460
X331 3901 877 4888 1 2 QDFFN $T=1076940 397040 0 0 $X=1076940 $Y=396660
X332 3594 869 4859 1 2 QDFFN $T=1076940 407120 1 0 $X=1076940 $Y=401700
X333 3594 873 4870 1 2 QDFFN $T=1076940 427280 0 0 $X=1076940 $Y=426900
X334 808 877 900 1 2 QDFFN $T=1077560 366800 1 0 $X=1077560 $Y=361380
X335 3623 869 4883 1 2 QDFFN $T=1077560 386960 1 0 $X=1077560 $Y=381540
X336 3594 877 4891 1 2 QDFFN $T=1077560 407120 0 0 $X=1077560 $Y=406740
X337 1203 1217 1231 1205 1 1199 2 AOI22S $T=289540 427280 1 180 $X=285820 $Y=426900
X338 1450 1429 1966 1962 1 1820 2 AOI22S $T=416020 386960 1 0 $X=416020 $Y=381540
X339 2427 2679 2671 2427 1 2700 2 AOI22S $T=548080 417200 0 0 $X=548080 $Y=416820
X340 3000 2990 2976 331 1 2859 2 AOI22S $T=605740 407120 0 180 $X=602020 $Y=401700
X341 3143 3157 3190 3102 1 3095 2 AOI22S $T=632400 487760 0 0 $X=632400 $Y=487380
X342 3248 3237 3215 3227 1 3227 2 AOI22S $T=641080 437360 0 180 $X=637360 $Y=431940
X343 466 3546 467 470 1 475 2 AOI22S $T=707420 366800 1 0 $X=707420 $Y=361380
X344 3459 3461 3569 470 1 475 2 AOI22S $T=711140 376880 1 0 $X=711140 $Y=371460
X345 3560 3584 3582 479 1 485 2 AOI22S $T=713000 376880 0 0 $X=713000 $Y=376500
X346 3565 481 480 479 1 485 2 AOI22S $T=714860 366800 1 0 $X=714860 $Y=361380
X347 3561 3599 3597 470 1 475 2 AOI22S $T=716720 376880 1 0 $X=716720 $Y=371460
X348 3480 3609 3607 479 1 485 2 AOI22S $T=719200 386960 0 0 $X=719200 $Y=386580
X349 3653 3638 3646 479 1 485 2 AOI22S $T=734080 386960 0 180 $X=730360 $Y=381540
X350 3643 3645 3650 470 1 475 2 AOI22S $T=734080 376880 1 0 $X=734080 $Y=371460
X351 3661 3644 3665 479 1 485 2 AOI22S $T=737800 397040 1 0 $X=737800 $Y=391620
X352 3668 3647 3671 470 1 475 2 AOI22S $T=740280 376880 1 0 $X=740280 $Y=371460
X353 3704 3693 3698 470 1 475 2 AOI22S $T=750200 366800 1 180 $X=746480 $Y=366420
X354 3745 3705 3694 479 1 485 2 AOI22S $T=753300 397040 0 180 $X=749580 $Y=391620
X355 3746 3742 3743 557 1 556 2 AOI22S $T=762600 376880 0 180 $X=758880 $Y=371460
X356 3744 3760 3731 565 1 566 2 AOI22S $T=762600 397040 1 0 $X=762600 $Y=391620
X357 3762 3765 3775 557 1 556 2 AOI22S $T=766320 376880 0 0 $X=766320 $Y=376500
X358 3810 3782 3773 565 1 566 2 AOI22S $T=775620 386960 1 180 $X=771900 $Y=386580
X359 3847 3859 3827 565 1 566 2 AOI22S $T=785540 386960 0 0 $X=785540 $Y=386580
X360 3837 3849 3838 557 1 556 2 AOI22S $T=786160 376880 0 0 $X=786160 $Y=376500
X361 594 3875 3897 565 1 566 2 AOI22S $T=792980 366800 0 180 $X=789260 $Y=361380
X362 3862 3884 3872 557 1 556 2 AOI22S $T=791740 376880 0 0 $X=791740 $Y=376500
X363 3921 3905 3879 565 1 566 2 AOI22S $T=799180 386960 1 180 $X=795460 $Y=386580
X364 3918 3906 3914 565 1 566 2 AOI22S $T=799180 397040 0 180 $X=795460 $Y=391620
X365 3886 3915 3913 557 1 556 2 AOI22S $T=797320 376880 1 0 $X=797320 $Y=371460
X366 3965 613 3961 612 1 611 2 AOI22S $T=813440 366800 0 180 $X=809720 $Y=361380
X367 3967 3891 3966 612 1 611 2 AOI22S $T=814060 397040 1 180 $X=810340 $Y=396660
X368 3968 612 3981 3917 1 611 2 AOI22S $T=814060 407120 1 180 $X=810340 $Y=406740
X369 3978 3785 3984 612 1 611 2 AOI22S $T=817780 407120 0 180 $X=814060 $Y=401700
X370 3972 3839 3976 612 1 611 2 AOI22S $T=815300 397040 1 0 $X=815300 $Y=391620
X371 3997 3898 4010 612 1 611 2 AOI22S $T=819640 376880 1 180 $X=815920 $Y=376500
X372 3993 3734 3992 612 1 611 2 AOI22S $T=821500 407120 1 180 $X=817780 $Y=406740
X373 4038 4032 4023 641 1 640 2 AOI22S $T=831420 417200 0 180 $X=827700 $Y=411780
X374 4070 4075 4054 641 1 640 2 AOI22S $T=840720 407120 0 0 $X=840720 $Y=406740
X375 4113 4104 4111 641 1 640 2 AOI22S $T=853120 407120 1 180 $X=849400 $Y=406740
X376 4162 4165 4142 641 1 640 2 AOI22S $T=864900 407120 0 0 $X=864900 $Y=406740
X377 687 690 4171 695 1 697 2 AOI22S $T=868620 507920 1 0 $X=868620 $Y=502500
X378 4198 4157 4203 641 1 640 2 AOI22S $T=875440 366800 1 0 $X=875440 $Y=361380
X379 4208 4211 4188 641 1 640 2 AOI22S $T=877300 407120 0 0 $X=877300 $Y=406740
X380 4249 4235 4258 641 1 640 2 AOI22S $T=888460 407120 1 180 $X=884740 $Y=406740
X381 4302 4310 4299 749 1 754 2 AOI22S $T=907060 407120 0 0 $X=907060 $Y=406740
X382 4312 4295 4307 749 1 754 2 AOI22S $T=907680 417200 0 0 $X=907680 $Y=416820
X383 4306 4303 4318 749 1 754 2 AOI22S $T=908300 397040 0 0 $X=908300 $Y=396660
X384 4331 4300 4328 749 1 754 2 AOI22S $T=914500 386960 0 180 $X=910780 $Y=381540
X385 4357 4348 4369 749 1 754 2 AOI22S $T=921320 366800 1 180 $X=917600 $Y=366420
X386 4425 4432 4368 4429 1 4436 2 AOI22S $T=936200 497840 0 0 $X=936200 $Y=497460
X387 4483 4448 4466 4481 1 4457 2 AOI22S $T=951700 497840 0 180 $X=947980 $Y=492420
X388 4495 4484 4461 749 1 754 2 AOI22S $T=954180 417200 0 180 $X=950460 $Y=411780
X389 4496 4491 4499 749 1 754 2 AOI22S $T=956040 397040 1 0 $X=956040 $Y=391620
X390 4492 4509 4508 749 1 754 2 AOI22S $T=957900 407120 0 0 $X=957900 $Y=406740
X391 4531 4516 4523 749 1 754 2 AOI22S $T=962860 366800 0 0 $X=962860 $Y=366420
X392 4565 4563 4564 749 1 754 2 AOI22S $T=974640 417200 0 180 $X=970920 $Y=411780
X393 4573 4596 4601 4579 1 4579 2 AOI22S $T=987040 467600 1 180 $X=983320 $Y=467220
X394 4604 4611 4606 729 1 836 2 AOI22S $T=983940 427280 0 0 $X=983940 $Y=426900
X395 4627 4624 4518 729 1 836 2 AOI22S $T=992620 366800 1 180 $X=988900 $Y=366420
X396 4619 4625 4524 729 1 836 2 AOI22S $T=990140 417200 1 0 $X=990140 $Y=411780
X397 4638 4630 4392 729 1 836 2 AOI22S $T=995100 376880 1 180 $X=991380 $Y=376500
X398 4646 4636 4305 729 1 836 2 AOI22S $T=997580 427280 0 180 $X=993860 $Y=421860
X399 4631 729 4453 4653 1 836 2 AOI22S $T=993860 427280 0 0 $X=993860 $Y=426900
X400 4643 4647 4384 729 1 836 2 AOI22S $T=998200 366800 0 0 $X=998200 $Y=366420
X401 4644 4651 4536 729 1 836 2 AOI22S $T=998820 397040 1 0 $X=998820 $Y=391620
X402 4633 4652 4323 729 1 836 2 AOI22S $T=998820 437360 1 0 $X=998820 $Y=431940
X403 4637 4660 4347 729 1 836 2 AOI22S $T=1005020 397040 1 180 $X=1001300 $Y=396660
X404 4666 4664 4668 853 1 850 2 AOI22S $T=1005020 447440 1 0 $X=1005020 $Y=442020
X405 4667 4639 4658 4670 1 4670 2 AOI22S $T=1008740 487760 0 180 $X=1005020 $Y=482340
X406 4671 4676 4680 853 1 850 2 AOI22S $T=1009980 417200 1 0 $X=1009980 $Y=411780
X407 4674 4685 4682 853 1 850 2 AOI22S $T=1010600 407120 1 0 $X=1010600 $Y=401700
X408 4673 4690 4686 853 1 850 2 AOI22S $T=1011840 376880 0 0 $X=1011840 $Y=376500
X409 4679 4689 4687 853 1 850 2 AOI22S $T=1011840 397040 1 0 $X=1011840 $Y=391620
X410 4702 4693 4717 853 1 850 2 AOI22S $T=1017420 427280 0 180 $X=1013700 $Y=421860
X411 4684 4699 4692 853 1 850 2 AOI22S $T=1014940 427280 0 0 $X=1014940 $Y=426900
X412 4706 4698 4715 853 1 850 2 AOI22S $T=1018040 366800 0 0 $X=1018040 $Y=366420
X413 4659 4694 4718 853 1 850 2 AOI22S $T=1018660 366800 1 0 $X=1018660 $Y=361380
X414 4708 4661 4738 853 1 850 2 AOI22S $T=1023620 437360 1 180 $X=1019900 $Y=436980
X415 4722 4711 4707 860 1 862 2 AOI22S $T=1021140 407120 1 0 $X=1021140 $Y=401700
X416 4720 4727 4695 860 1 862 2 AOI22S $T=1021140 447440 1 0 $X=1021140 $Y=442020
X417 4756 865 4733 860 1 862 2 AOI22S $T=1030440 366800 0 180 $X=1026720 $Y=361380
X418 4757 4739 4721 860 1 862 2 AOI22S $T=1030440 386960 0 180 $X=1026720 $Y=381540
X419 4760 4747 4736 860 1 862 2 AOI22S $T=1031060 366800 1 180 $X=1027340 $Y=366420
X420 4770 4753 4737 860 1 862 2 AOI22S $T=1034160 427280 0 180 $X=1030440 $Y=421860
X421 4771 4767 4741 860 1 862 2 AOI22S $T=1034160 437360 0 180 $X=1030440 $Y=431940
X422 4761 4751 4750 860 1 862 2 AOI22S $T=1031680 447440 1 0 $X=1031680 $Y=442020
X423 4752 4759 4704 860 1 862 2 AOI22S $T=1032300 417200 1 0 $X=1032300 $Y=411780
X424 4774 4775 4769 860 1 862 2 AOI22S $T=1037880 397040 1 180 $X=1034160 $Y=396660
X425 4803 4791 4779 878 1 876 2 AOI22S $T=1047180 417200 0 180 $X=1043460 $Y=411780
X426 4789 4794 4793 878 1 876 2 AOI22S $T=1044080 376880 1 0 $X=1044080 $Y=371460
X427 4807 4810 4798 884 1 885 2 AOI22S $T=1050900 397040 0 0 $X=1050900 $Y=396660
X428 4826 4813 4822 878 1 876 2 AOI22S $T=1054620 417200 0 180 $X=1050900 $Y=411780
X429 4801 4811 4786 884 1 885 2 AOI22S $T=1050900 427280 0 0 $X=1050900 $Y=426900
X430 4804 4817 4814 884 1 885 2 AOI22S $T=1052140 447440 0 0 $X=1052140 $Y=447060
X431 4834 4829 4800 884 1 885 2 AOI22S $T=1060200 376880 0 180 $X=1056480 $Y=371460
X432 4836 4831 4835 878 1 876 2 AOI22S $T=1062060 417200 0 180 $X=1058340 $Y=411780
X433 4845 4832 4833 884 1 885 2 AOI22S $T=1063300 427280 1 180 $X=1059580 $Y=426900
X434 4828 4830 4797 878 1 876 2 AOI22S $T=1062060 386960 0 0 $X=1062060 $Y=386580
X435 4840 4853 4847 884 1 885 2 AOI22S $T=1068260 376880 0 0 $X=1068260 $Y=376500
X436 4873 4856 891 884 1 885 2 AOI22S $T=1072600 366800 0 180 $X=1068880 $Y=361380
X437 4891 4859 4854 878 1 876 2 AOI22S $T=1072600 417200 0 180 $X=1068880 $Y=411780
X438 4870 4860 4862 884 1 885 2 AOI22S $T=1073220 427280 1 180 $X=1069500 $Y=426900
X439 4869 4858 4857 884 1 885 2 AOI22S $T=1073840 397040 1 180 $X=1070120 $Y=396660
X440 4882 4874 4879 884 1 885 2 AOI22S $T=1078180 447440 1 180 $X=1074460 $Y=447060
X441 4890 4883 4867 878 1 876 2 AOI22S $T=1083760 376880 1 180 $X=1080040 $Y=376500
X442 4888 4885 4852 878 1 876 2 AOI22S $T=1084380 397040 1 0 $X=1084380 $Y=391620
X443 4889 4886 4878 878 1 876 2 AOI22S $T=1084380 417200 0 0 $X=1084380 $Y=416820
X444 956 949 1 2 937 AN2 $T=224440 447440 1 180 $X=221960 $Y=447060
X445 957 937 1 2 938 AN2 $T=224440 457520 0 180 $X=221960 $Y=452100
X446 963 938 1 2 939 AN2 $T=224440 457520 1 180 $X=221960 $Y=457140
X447 964 939 1 2 940 AN2 $T=224440 467600 1 180 $X=221960 $Y=467220
X448 958 940 1 2 941 AN2 $T=224440 477680 0 180 $X=221960 $Y=472260
X449 959 941 1 2 942 AN2 $T=224440 477680 1 180 $X=221960 $Y=477300
X450 945 943 1 2 953 AN2 $T=222580 417200 1 0 $X=222580 $Y=411780
X451 973 952 1 2 943 AN2 $T=225680 407120 1 180 $X=223200 $Y=406740
X452 983 954 1 2 949 AN2 $T=225680 437360 1 180 $X=223200 $Y=436980
X453 944 942 1 2 955 AN2 $T=223200 497840 1 0 $X=223200 $Y=492420
X454 972 955 1 2 950 AN2 $T=225680 497840 1 180 $X=223200 $Y=497460
X455 971 953 1 2 948 AN2 $T=226300 427280 0 180 $X=223820 $Y=421860
X456 946 948 1 2 954 AN2 $T=223820 437360 1 0 $X=223820 $Y=431940
X457 967 968 1 2 961 AN2 $T=228160 386960 1 180 $X=225680 $Y=386580
X458 951 961 1 2 952 AN2 $T=225680 397040 0 0 $X=225680 $Y=396660
X459 966 3 1 2 1053 AN2 $T=227540 376880 1 0 $X=227540 $Y=371460
X460 1010 6 1 2 947 AN2 $T=238080 397040 1 180 $X=235600 $Y=396660
X461 1011 950 1 2 15 AN2 $T=238700 507920 1 0 $X=238700 $Y=502500
X462 1047 6 1 2 1008 AN2 $T=244900 397040 1 180 $X=242420 $Y=396660
X463 4 1063 1 2 1041 AN2 $T=249240 417200 1 180 $X=246760 $Y=416820
X464 1055 6 1 2 1054 AN2 $T=251720 397040 1 180 $X=249240 $Y=396660
X465 4 1073 1 2 1056 AN2 $T=251720 437360 0 180 $X=249240 $Y=431940
X466 1062 1053 1 2 1097 AN2 $T=252340 376880 1 0 $X=252340 $Y=371460
X467 1105 1087 1 2 1086 AN2 $T=257920 386960 1 180 $X=255440 $Y=386580
X468 1112 1098 1 2 1087 AN2 $T=257920 397040 1 180 $X=255440 $Y=396660
X469 1104 1097 1 2 1152 AN2 $T=264120 366800 0 0 $X=264120 $Y=366420
X470 1138 1144 1 2 1101 AN2 $T=266600 417200 0 0 $X=266600 $Y=416820
X471 1185 1178 1 2 1109 AN2 $T=275280 427280 0 180 $X=272800 $Y=421860
X472 1203 1205 1 2 1212 AN2 $T=283340 427280 0 0 $X=283340 $Y=426900
X473 1253 1254 1 2 1244 AN2 $T=297600 397040 0 0 $X=297600 $Y=396660
X474 1307 17 1 2 1283 AN2 $T=308140 397040 1 180 $X=305660 $Y=396660
X475 87 85 1 2 77 AN2 $T=308140 507920 1 180 $X=305660 $Y=507540
X476 1315 17 1 2 1214 AN2 $T=309380 397040 0 180 $X=306900 $Y=391620
X477 1313 17 1 2 1328 AN2 $T=310000 417200 1 0 $X=310000 $Y=411780
X478 1351 1344 1 2 85 AN2 $T=315580 507920 1 180 $X=313100 $Y=507540
X479 1342 17 1 2 1324 AN2 $T=316200 417200 0 180 $X=313720 $Y=411780
X480 1357 1365 1 2 1371 AN2 $T=318060 427280 1 0 $X=318060 $Y=421860
X481 1372 1371 1 2 1379 AN2 $T=319920 427280 0 0 $X=319920 $Y=426900
X482 1388 1381 1 2 1365 AN2 $T=323640 417200 1 180 $X=321160 $Y=416820
X483 1368 1341 1 2 1381 AN2 $T=322400 407120 0 0 $X=322400 $Y=406740
X484 1409 1396 1 2 1361 AN2 $T=326120 376880 1 180 $X=323640 $Y=376500
X485 1393 1404 1 2 1397 AN2 $T=327360 447440 0 180 $X=324880 $Y=442020
X486 1382 1379 1 2 1404 AN2 $T=325500 437360 0 0 $X=325500 $Y=436980
X487 1394 1405 1 2 1414 AN2 $T=325500 467600 1 0 $X=325500 $Y=462180
X488 1400 1406 1 2 1415 AN2 $T=325500 477680 1 0 $X=325500 $Y=472260
X489 1401 1414 1 2 1406 AN2 $T=326740 467600 0 0 $X=326740 $Y=467220
X490 1387 1397 1 2 1405 AN2 $T=327360 457520 0 0 $X=327360 $Y=457140
X491 1412 1422 1 2 1417 AN2 $T=329840 497840 1 180 $X=327360 $Y=497460
X492 1408 1417 1 2 1344 AN2 $T=327360 507920 0 0 $X=327360 $Y=507540
X493 1420 1415 1 2 1437 AN2 $T=329220 477680 0 0 $X=329220 $Y=477300
X494 1421 1447 1 2 1422 AN2 $T=332940 497840 0 180 $X=330460 $Y=492420
X495 99 1428 1 2 1396 AN2 $T=331080 366800 0 0 $X=331080 $Y=366420
X496 1407 1437 1 2 1447 AN2 $T=332940 487760 0 0 $X=332940 $Y=487380
X497 102 100 1 2 1428 AN2 $T=336040 366800 0 180 $X=333560 $Y=361380
X498 1567 1196 1 2 1546 AN2 $T=348440 417200 0 180 $X=345960 $Y=411780
X499 1557 107 1 2 1569 AN2 $T=348440 397040 1 0 $X=348440 $Y=391620
X500 1545 107 1 2 1583 AN2 $T=353400 407120 0 0 $X=353400 $Y=406740
X501 1588 107 1 2 1603 AN2 $T=355880 386960 0 0 $X=355880 $Y=386580
X502 1594 107 1 2 1591 AN2 $T=356500 427280 0 0 $X=356500 $Y=426900
X503 1637 1648 1 2 1687 AN2 $T=369520 417200 1 0 $X=369520 $Y=411780
X504 1684 107 1 2 1695 AN2 $T=375100 397040 1 0 $X=375100 $Y=391620
X505 1726 107 1 2 1752 AN2 $T=383160 397040 1 0 $X=383160 $Y=391620
X506 128 127 1 2 1729 AN2 $T=386260 366800 1 180 $X=383780 $Y=366420
X507 1728 1732 1 2 1742 AN2 $T=383780 407120 0 0 $X=383780 $Y=406740
X508 1741 1737 1 2 1716 AN2 $T=388120 507920 0 180 $X=385640 $Y=502500
X509 1765 1761 1 2 1748 AN2 $T=390600 497840 1 180 $X=388120 $Y=497460
X510 1750 1748 1 2 1737 AN2 $T=388120 507920 1 0 $X=388120 $Y=502500
X511 1776 11 1 2 1756 AN2 $T=394320 427280 0 180 $X=391840 $Y=421860
X512 1801 127 1 2 134 AN2 $T=397420 366800 0 180 $X=394940 $Y=361380
X513 1781 1742 1 2 1802 AN2 $T=394940 417200 1 0 $X=394940 $Y=411780
X514 1744 11 1 2 1815 AN2 $T=396180 427280 1 0 $X=396180 $Y=421860
X515 1749 11 1 2 1835 AN2 $T=398660 427280 0 0 $X=398660 $Y=426900
X516 1812 1817 1 2 1824 AN2 $T=398660 437360 0 0 $X=398660 $Y=436980
X517 1822 1824 1 2 1837 AN2 $T=399900 447440 1 0 $X=399900 $Y=442020
X518 1827 1844 1 2 1823 AN2 $T=402380 477680 0 0 $X=402380 $Y=477300
X519 1828 1819 1 2 1858 AN2 $T=402380 497840 0 0 $X=402380 $Y=497460
X520 1843 1849 1 2 1862 AN2 $T=403000 457520 0 0 $X=403000 $Y=457140
X521 1838 1837 1 2 1849 AN2 $T=403620 447440 0 0 $X=403620 $Y=447060
X522 1854 1848 1 2 1817 AN2 $T=404240 427280 0 0 $X=404240 $Y=426900
X523 1870 1862 1 2 1844 AN2 $T=407340 467600 0 180 $X=404860 $Y=462180
X524 1871 1858 1 2 1761 AN2 $T=407340 497840 1 180 $X=404860 $Y=497460
X525 1927 107 1 2 1783 AN2 $T=408580 397040 0 180 $X=406100 $Y=391620
X526 1852 1802 1 2 1890 AN2 $T=406100 407120 0 0 $X=406100 $Y=406740
X527 1865 1873 1 2 1848 AN2 $T=408580 427280 0 180 $X=406100 $Y=421860
X528 1883 1890 1 2 1910 AN2 $T=408580 417200 0 0 $X=408580 $Y=416820
X529 1906 1897 1 2 1873 AN2 $T=411060 427280 0 180 $X=408580 $Y=421860
X530 1872 127 1 2 1814 AN2 $T=412920 376880 1 180 $X=410440 $Y=376500
X531 1946 127 1 2 145 AN2 $T=415400 376880 1 180 $X=412920 $Y=376500
X532 1953 107 1 2 1885 AN2 $T=416020 397040 0 180 $X=413540 $Y=391620
X533 1978 1910 1 2 1897 AN2 $T=419740 417200 1 180 $X=417260 $Y=416820
X534 2013 127 1 2 156 AN2 $T=432140 376880 1 180 $X=429660 $Y=376500
X535 2091 107 1 2 2035 AN2 $T=435860 386960 1 180 $X=433380 $Y=386580
X536 2126 127 1 2 161 AN2 $T=442680 376880 1 180 $X=440200 $Y=376500
X537 166 107 1 2 1875 AN2 $T=445160 477680 0 180 $X=442680 $Y=472260
X538 169 107 1 2 2096 AN2 $T=446400 467600 0 180 $X=443920 $Y=462180
X539 2111 127 1 2 167 AN2 $T=448260 366800 1 180 $X=445780 $Y=366420
X540 172 107 1 2 2120 AN2 $T=450120 477680 1 180 $X=447640 $Y=477300
X541 173 107 1 2 1956 AN2 $T=450740 507920 0 180 $X=448260 $Y=502500
X542 2152 107 1 2 1947 AN2 $T=452600 427280 0 180 $X=450120 $Y=421860
X543 2158 107 1 2 2075 AN2 $T=455700 447440 1 180 $X=453220 $Y=447060
X544 181 107 1 2 2083 AN2 $T=455700 497840 0 180 $X=453220 $Y=492420
X545 2162 107 1 2 2022 AN2 $T=456940 467600 0 180 $X=454460 $Y=462180
X546 2147 107 1 2 2155 AN2 $T=458180 437360 0 180 $X=455700 $Y=431940
X547 2165 107 1 2 1974 AN2 $T=460660 437360 0 180 $X=458180 $Y=431940
X548 2217 2211 1 2 2205 AN2 $T=473680 376880 1 180 $X=471200 $Y=376500
X549 2233 2228 1 2 2212 AN2 $T=476160 397040 1 180 $X=473680 $Y=396660
X550 2303 2307 1 2 2262 AN2 $T=491040 386960 1 180 $X=488560 $Y=386580
X551 2313 2307 1 2 2273 AN2 $T=491660 376880 1 180 $X=489180 $Y=376500
X552 2292 2307 1 2 2320 AN2 $T=491040 386960 0 0 $X=491040 $Y=386580
X553 2293 2307 1 2 2350 AN2 $T=493520 386960 1 0 $X=493520 $Y=381540
X554 2324 2331 1 2 2344 AN2 $T=494760 407120 0 0 $X=494760 $Y=406740
X555 2354 2347 1 2 2341 AN2 $T=499100 376880 1 180 $X=496620 $Y=376500
X556 2348 2341 1 2 2331 AN2 $T=499720 397040 0 180 $X=497240 $Y=391620
X557 2352 2361 1 2 2372 AN2 $T=498480 457520 1 0 $X=498480 $Y=452100
X558 2362 2364 1 2 2382 AN2 $T=499100 477680 1 0 $X=499100 $Y=472260
X559 2355 2344 1 2 2377 AN2 $T=499720 417200 1 0 $X=499720 $Y=411780
X560 2366 2371 1 2 2378 AN2 $T=500340 437360 0 0 $X=500340 $Y=436980
X561 2359 2378 1 2 2361 AN2 $T=502820 447440 1 180 $X=500340 $Y=447060
X562 2386 2380 1 2 249 AN2 $T=502820 507920 1 180 $X=500340 $Y=507540
X563 2365 2369 1 2 2371 AN2 $T=500960 437360 1 0 $X=500960 $Y=431940
X564 2367 2377 1 2 2387 AN2 $T=501580 427280 1 0 $X=501580 $Y=421860
X565 2390 2387 1 2 2369 AN2 $T=504060 427280 1 180 $X=501580 $Y=426900
X566 2392 2388 1 2 2379 AN2 $T=504060 497840 0 180 $X=501580 $Y=492420
X567 2373 2382 1 2 2394 AN2 $T=502200 477680 0 0 $X=502200 $Y=477300
X568 2375 2372 1 2 2364 AN2 $T=502820 467600 1 0 $X=502820 $Y=462180
X569 2385 2379 1 2 2380 AN2 $T=505920 497840 1 180 $X=503440 $Y=497460
X570 2412 253 1 2 2338 AN2 $T=507780 366800 1 180 $X=505300 $Y=366420
X571 2397 2394 1 2 2388 AN2 $T=506540 487760 1 0 $X=506540 $Y=482340
X572 2528 2535 1 2 2534 AN2 $T=526380 397040 0 0 $X=526380 $Y=396660
X573 2577 284 1 2 2589 AN2 $T=534440 507920 0 0 $X=534440 $Y=507540
X574 2606 282 1 2 2579 AN2 $T=540640 417200 0 180 $X=538160 $Y=411780
X575 2585 2507 1 2 2611 AN2 $T=538780 427280 1 0 $X=538780 $Y=421860
X576 2623 2614 1 2 2605 AN2 $T=542500 397040 1 180 $X=540020 $Y=396660
X577 2603 282 1 2 2625 AN2 $T=540640 417200 1 0 $X=540640 $Y=411780
X578 2610 2613 1 2 2614 AN2 $T=543120 397040 1 0 $X=543120 $Y=391620
X579 2631 2636 1 2 2647 AN2 $T=543120 487760 1 0 $X=543120 $Y=482340
X580 2615 2605 1 2 2648 AN2 $T=543740 407120 1 0 $X=543740 $Y=401700
X581 2624 2648 1 2 2640 AN2 $T=546840 407120 1 180 $X=544360 $Y=406740
X582 2662 2607 1 2 2613 AN2 $T=547460 366800 1 180 $X=544980 $Y=366420
X583 2635 2640 1 2 2656 AN2 $T=545600 417200 0 0 $X=545600 $Y=416820
X584 2650 2656 1 2 2673 AN2 $T=546840 427280 0 0 $X=546840 $Y=426900
X585 2675 2670 1 2 2636 AN2 $T=549320 477680 0 180 $X=546840 $Y=472260
X586 2660 2669 1 2 2683 AN2 $T=547460 467600 1 0 $X=547460 $Y=462180
X587 2657 2673 1 2 2682 AN2 $T=548700 437360 0 0 $X=548700 $Y=436980
X588 2674 2682 1 2 2693 AN2 $T=548700 447440 0 0 $X=548700 $Y=447060
X589 2652 2647 1 2 2694 AN2 $T=548700 487760 0 0 $X=548700 $Y=487380
X590 2702 2683 1 2 2670 AN2 $T=551800 467600 1 180 $X=549320 $Y=467220
X591 2685 2697 1 2 292 AN2 $T=552420 507920 1 180 $X=549940 $Y=507540
X592 295 294 1 2 2676 AN2 $T=553040 366800 0 180 $X=550560 $Y=361380
X593 2699 2693 1 2 2669 AN2 $T=553040 457520 0 180 $X=550560 $Y=452100
X594 2684 2694 1 2 2697 AN2 $T=551180 497840 0 0 $X=551180 $Y=497460
X595 2777 2451 1 2 2760 AN2 $T=565440 417200 0 180 $X=562960 $Y=411780
X596 2832 2846 1 2 2843 AN2 $T=578460 386960 0 0 $X=578460 $Y=386580
X597 2827 2846 1 2 2858 AN2 $T=578460 407120 1 0 $X=578460 $Y=401700
X598 2852 2846 1 2 2844 AN2 $T=580320 417200 0 0 $X=580320 $Y=416820
X599 2842 2846 1 2 2874 AN2 $T=580940 386960 0 0 $X=580940 $Y=386580
X600 2865 2846 1 2 2882 AN2 $T=582180 417200 1 0 $X=582180 $Y=411780
X601 2999 2846 1 2 2930 AN2 $T=606360 376880 0 180 $X=603880 $Y=371460
X602 2987 2979 1 2 3013 AN2 $T=605740 417200 1 0 $X=605740 $Y=411780
X603 3011 3005 1 2 2992 AN2 $T=608220 497840 0 180 $X=605740 $Y=492420
X604 3025 3015 1 2 3005 AN2 $T=608840 497840 1 180 $X=606360 $Y=497460
X605 3007 3013 1 2 3012 AN2 $T=607600 407120 1 0 $X=607600 $Y=401700
X606 2965 337 1 2 3016 AN2 $T=608220 376880 1 0 $X=608220 $Y=371460
X607 346 337 1 2 342 AN2 $T=614420 366800 1 180 $X=611940 $Y=366420
X608 3050 3049 1 2 3045 AN2 $T=615040 477680 0 180 $X=612560 $Y=472260
X609 3018 334 1 2 3046 AN2 $T=616280 417200 1 180 $X=613800 $Y=416820
X610 3037 3045 1 2 3063 AN2 $T=614420 487760 1 0 $X=614420 $Y=482340
X611 3022 334 1 2 3053 AN2 $T=615040 417200 1 0 $X=615040 $Y=411780
X612 3074 3071 1 2 3049 AN2 $T=618760 467600 1 180 $X=616280 $Y=467220
X613 3093 337 1 2 352 AN2 $T=619380 366800 1 180 $X=616900 $Y=366420
X614 3058 334 1 2 3076 AN2 $T=617520 417200 0 0 $X=617520 $Y=416820
X615 3031 3063 1 2 3081 AN2 $T=618140 497840 0 0 $X=618140 $Y=497460
X616 3085 2846 1 2 3060 AN2 $T=621240 386960 0 180 $X=618760 $Y=381540
X617 3065 3042 1 2 3070 AN2 $T=618760 397040 0 0 $X=618760 $Y=396660
X618 3075 3086 1 2 3071 AN2 $T=621860 457520 1 180 $X=619380 $Y=457140
X619 3073 3070 1 2 3101 AN2 $T=620620 407120 0 0 $X=620620 $Y=406740
X620 3110 3081 1 2 3015 AN2 $T=623720 497840 1 180 $X=621240 $Y=497460
X621 3083 3108 1 2 3086 AN2 $T=624340 457520 0 180 $X=621860 $Y=452100
X622 3120 3119 1 2 3142 AN2 $T=624340 427280 1 0 $X=624340 $Y=421860
X623 3117 3127 1 2 3108 AN2 $T=624340 447440 0 0 $X=624340 $Y=447060
X624 3119 3135 1 2 3147 AN2 $T=625580 437360 0 0 $X=625580 $Y=436980
X625 3153 3148 1 2 3119 AN2 $T=629300 417200 1 180 $X=626820 $Y=416820
X626 3141 3145 1 2 3163 AN2 $T=628060 417200 1 0 $X=628060 $Y=411780
X627 3147 3120 1 2 3177 AN2 $T=628060 437360 0 0 $X=628060 $Y=436980
X628 3168 3164 1 2 3127 AN2 $T=631160 447440 1 180 $X=628680 $Y=447060
X629 3115 3073 1 2 3125 AN2 $T=629300 407120 1 0 $X=629300 $Y=401700
X630 3162 3163 1 2 3148 AN2 $T=631780 417200 1 180 $X=629300 $Y=416820
X631 3183 3177 1 2 3164 AN2 $T=632400 437360 0 0 $X=632400 $Y=436980
X632 374 337 1 2 3217 AN2 $T=640460 366800 1 180 $X=637980 $Y=366420
X633 3250 2846 1 2 3179 AN2 $T=641700 386960 0 180 $X=639220 $Y=381540
X634 385 383 1 2 3157 AN2 $T=650380 497840 1 180 $X=647900 $Y=497460
X635 3325 383 1 2 3192 AN2 $T=655340 497840 1 180 $X=652860 $Y=497460
X636 3306 370 1 2 3345 AN2 $T=657200 507920 0 180 $X=654720 $Y=502500
X637 3342 2846 1 2 3316 AN2 $T=657820 376880 0 180 $X=655340 $Y=371460
X638 3377 383 1 2 3087 AN2 $T=661540 497840 0 180 $X=659060 $Y=492420
X639 3393 337 1 2 3351 AN2 $T=665880 366800 1 180 $X=663400 $Y=366420
X640 3403 3394 1 2 3227 AN2 $T=667740 437360 1 180 $X=665260 $Y=436980
X641 3410 3394 1 2 3271 AN2 $T=669600 457520 1 180 $X=667120 $Y=457140
X642 3391 3394 1 2 3150 AN2 $T=671460 477680 1 180 $X=668980 $Y=477300
X643 399 401 1 2 3415 AN2 $T=668980 507920 0 0 $X=668980 $Y=507540
X644 3421 3394 1 2 3169 AN2 $T=673320 467600 0 180 $X=670840 $Y=462180
X645 3425 3394 1 2 3270 AN2 $T=673940 447440 0 180 $X=671460 $Y=442020
X646 399 401 1 2 406 AN2 $T=671460 507920 0 0 $X=671460 $Y=507540
X647 3431 3394 1 2 3300 AN2 $T=675180 417200 1 180 $X=672700 $Y=416820
X648 3447 3394 1 2 3356 AN2 $T=676420 417200 0 180 $X=673940 $Y=411780
X649 3426 3394 1 2 3149 AN2 $T=676420 477680 0 180 $X=673940 $Y=472260
X650 3438 3394 1 2 3210 AN2 $T=679520 407120 1 180 $X=677040 $Y=406740
X651 3446 370 1 2 3449 AN2 $T=682620 507920 0 0 $X=682620 $Y=507540
X652 399 401 1 2 3540 AN2 $T=703080 507920 0 0 $X=703080 $Y=507540
X653 3582 3597 1 2 3612 AN2 $T=719820 376880 0 0 $X=719820 $Y=376500
X654 3607 3569 1 2 3633 AN2 $T=725400 386960 1 0 $X=725400 $Y=381540
X655 3646 3650 1 2 3669 AN2 $T=735940 376880 0 0 $X=735940 $Y=376500
X656 3665 3671 1 2 3697 AN2 $T=744000 397040 1 0 $X=744000 $Y=391620
X657 3694 3698 1 2 3703 AN2 $T=748340 386960 0 0 $X=748340 $Y=386580
X658 3675 536 1 2 3708 AN2 $T=748340 487760 0 0 $X=748340 $Y=487380
X659 3655 536 1 2 3713 AN2 $T=750200 507920 1 0 $X=750200 $Y=502500
X660 3701 536 1 2 3787 AN2 $T=768800 487760 0 0 $X=768800 $Y=487380
X661 3689 536 1 2 3826 AN2 $T=773760 487760 1 0 $X=773760 $Y=482340
X662 3836 3833 1 2 587 AN2 $T=782440 507920 0 0 $X=782440 $Y=507540
X663 3864 3857 1 2 3833 AN2 $T=787400 507920 1 180 $X=784920 $Y=507540
X664 3706 536 1 2 3870 AN2 $T=788020 487760 1 0 $X=788020 $Y=482340
X665 3895 3896 1 2 3857 AN2 $T=796700 507920 0 180 $X=794220 $Y=502500
X666 607 605 1 2 3896 AN2 $T=803520 507920 1 180 $X=801040 $Y=507540
X667 610 609 1 2 605 AN2 $T=810340 507920 1 180 $X=807860 $Y=507540
X668 3707 536 1 2 3960 AN2 $T=809720 477680 0 0 $X=809720 $Y=477300
X669 3751 536 1 2 4045 AN2 $T=839480 477680 0 180 $X=837000 $Y=472260
X670 3777 536 1 2 4067 AN2 $T=844440 477680 0 180 $X=841960 $Y=472260
X671 4101 672 1 2 668 AN2 $T=850640 507920 1 180 $X=848160 $Y=507540
X672 3937 536 1 2 4103 AN2 $T=861180 477680 0 180 $X=858700 $Y=472260
X673 4147 683 1 2 681 AN2 $T=861800 507920 1 180 $X=859320 $Y=507540
X674 4251 722 1 2 4240 AN2 $T=891560 427280 0 180 $X=889080 $Y=421860
X675 4297 683 1 2 4190 AN2 $T=907680 497840 1 180 $X=905200 $Y=497460
X676 4293 785 1 2 778 AN2 $T=931860 507920 0 180 $X=929380 $Y=502500
X677 4406 785 1 2 4432 AN2 $T=934960 477680 0 0 $X=934960 $Y=477300
X678 4332 785 1 2 4441 AN2 $T=944880 477680 0 0 $X=944880 $Y=477300
X679 4414 785 1 2 4448 AN2 $T=952320 477680 0 0 $X=952320 $Y=477300
X680 812 809 1 2 806 AN2 $T=955420 507920 1 180 $X=952940 $Y=507540
X681 4325 785 1 2 4500 AN2 $T=954800 477680 0 0 $X=954800 $Y=477300
X682 4439 785 1 2 4587 AN2 $T=975260 467600 0 0 $X=975260 $Y=467220
X683 4434 785 1 2 4586 AN2 $T=980220 487760 1 0 $X=980220 $Y=482340
X684 4587 834 1 2 4610 AN2 $T=982700 487760 0 0 $X=982700 $Y=487380
X685 4486 785 1 2 4579 AN2 $T=983320 467600 1 0 $X=983320 $Y=462180
X686 4586 4591 1 2 4602 AN2 $T=986420 497840 1 180 $X=983940 $Y=497460
X687 835 4615 1 2 839 AN2 $T=987040 507920 0 0 $X=987040 $Y=507540
X688 4629 840 1 2 4615 AN2 $T=993240 507920 1 180 $X=990760 $Y=507540
X689 4449 785 1 2 4670 AN2 $T=1005020 477680 0 0 $X=1005020 $Y=477300
X690 4477 785 1 2 4663 AN2 $T=1009360 457520 1 180 $X=1006880 $Y=457140
X691 4746 785 1 2 4724 AN2 $T=1029820 477680 1 0 $X=1029820 $Y=472260
X692 4683 785 1 2 4749 AN2 $T=1034160 467600 0 180 $X=1031680 $Y=462180
X693 4786 4779 1 2 4712 AN2 $T=1040360 417200 0 180 $X=1037880 $Y=411780
X694 4546 785 1 2 4787 AN2 $T=1039740 477680 0 0 $X=1039740 $Y=477300
X695 881 880 1 2 872 AN2 $T=1047180 507920 1 180 $X=1044700 $Y=507540
X696 4798 4797 1 2 4710 AN2 $T=1048420 397040 0 180 $X=1045940 $Y=391620
X697 4800 4793 1 2 4740 AN2 $T=1049660 366800 1 180 $X=1047180 $Y=366420
X698 4814 4822 1 2 4762 AN2 $T=1054000 447440 1 0 $X=1054000 $Y=442020
X699 4833 4835 1 2 4754 AN2 $T=1062680 427280 1 0 $X=1062680 $Y=421860
X700 4857 4852 1 2 4765 AN2 $T=1070120 397040 0 180 $X=1067640 $Y=391620
X701 4862 4854 1 2 4744 AN2 $T=1071360 427280 0 180 $X=1068880 $Y=421860
X702 4865 785 1 2 4825 AN2 $T=1073840 497840 1 180 $X=1071360 $Y=497460
X703 4847 4867 1 2 4731 AN2 $T=1075700 386960 0 180 $X=1073220 $Y=381540
X704 4863 785 1 2 4876 AN2 $T=1077560 477680 1 0 $X=1077560 $Y=472260
X705 4879 4878 1 2 4696 AN2 $T=1080660 447440 0 180 $X=1078180 $Y=442020
X706 4700 877 1 2 INV6CK $T=1050900 366800 0 0 $X=1050900 $Y=366420
X707 648 645 1 2 INV4CK $T=832660 366800 0 180 $X=828940 $Y=361380
X708 660 661 1 2 INV4CK $T=840720 376880 0 0 $X=840720 $Y=376500
X709 284 290 1 2 2570 QDBHN $T=540640 507920 0 0 $X=540640 $Y=507540
X710 370 380 1 2 386 QDBHN $T=642940 507920 0 0 $X=642940 $Y=507540
X711 405 3415 1 2 3433 QDBHN $T=673320 397040 0 0 $X=673320 $Y=396660
X712 370 437 1 2 3504 QDBHN $T=688820 507920 0 0 $X=688820 $Y=507540
X713 549 531 1 2 612 QDBHN $T=812200 417200 0 0 $X=812200 $Y=416820
X714 642 649 1 2 4056 QDBHN $T=829560 376880 0 0 $X=829560 $Y=376500
X715 642 667 1 2 4093 QDBHN $T=841340 366800 0 0 $X=841340 $Y=366420
X716 642 686 1 2 4136 QDBHN $T=861180 376880 0 0 $X=861180 $Y=376500
X717 722 731 1 2 4215 QDBHN $T=900240 366800 1 180 $X=892800 $Y=366420
X718 722 3540 1 2 4233 QDBHN $T=902720 427280 0 180 $X=895280 $Y=421860
X719 722 762 1 2 757 QDBHN $T=919460 376880 0 180 $X=912020 $Y=371460
X720 722 771 1 2 4341 QDBHN $T=923180 366800 0 180 $X=915740 $Y=361380
X721 722 795 1 2 790 QDBHN $T=944880 366800 0 180 $X=937440 $Y=361380
X722 722 817 1 2 826 QDBHN $T=964100 376880 0 0 $X=964100 $Y=376500
X723 1543 1582 1 2 INV2CK $T=354640 487760 1 0 $X=354640 $Y=482340
X724 2122 1900 1 2 INV2CK $T=442060 447440 1 180 $X=439580 $Y=447060
X725 2589 2299 1 2 INV2CK $T=552420 507920 0 0 $X=552420 $Y=507540
X726 2909 2931 1 2 INV2CK $T=594580 417200 0 180 $X=592100 $Y=411780
X727 3208 375 1 2 INV2CK $T=639220 497840 0 0 $X=639220 $Y=497460
X728 3345 3360 1 2 INV2CK $T=659060 497840 0 180 $X=656580 $Y=492420
X729 3449 459 1 2 INV2CK $T=700600 507920 0 0 $X=700600 $Y=507540
X730 4240 4314 1 2 INV2CK $T=909540 427280 0 180 $X=907060 $Y=421860
X731 788 789 1 2 INV2CK $T=934340 507920 0 0 $X=934340 $Y=507540
X732 4665 4700 1 2 INV2CK $T=1015560 366800 0 0 $X=1015560 $Y=366420
X733 1026 1020 968 1 2 AN2T $T=242420 386960 1 180 $X=238080 $Y=386580
X734 1052 6 1095 1 2 AN2T $T=251100 397040 1 0 $X=251100 $Y=391620
X735 1108 1086 1020 1 2 AN2T $T=257920 376880 1 180 $X=253580 $Y=376500
X736 1219 1200 1245 1 2 AN2T $T=290780 366800 0 0 $X=290780 $Y=366420
X737 1278 1245 1318 1 2 AN2T $T=306900 376880 1 0 $X=306900 $Y=371460
X738 1323 1318 1310 1 2 AN2T $T=311240 376880 1 180 $X=306900 $Y=376500
X739 1316 1310 1341 1 2 AN2T $T=310620 407120 0 0 $X=310620 $Y=406740
X740 1736 11 1700 1 2 AN2T $T=389360 417200 1 180 $X=385020 $Y=416820
X741 1793 1794 1819 1 2 AN2T $T=396800 477680 0 0 $X=396800 $Y=477300
X742 1832 1823 1794 1 2 AN2T $T=401760 477680 0 180 $X=397420 $Y=472260
X743 2205 2237 2252 1 2 AN2T $T=476780 376880 1 0 $X=476780 $Y=371460
X744 2393 2252 2347 1 2 AN2T $T=505300 376880 0 180 $X=500960 $Y=371460
X745 2527 2534 2580 1 2 AN2T $T=530720 386960 0 0 $X=530720 $Y=386580
X746 2597 282 2545 1 2 AN2T $T=538160 407120 0 180 $X=533820 $Y=401700
X747 2572 2580 2584 1 2 AN2T $T=535060 386960 0 0 $X=535060 $Y=386580
X748 2591 282 2544 1 2 AN2T $T=540640 407120 1 180 $X=536300 $Y=406740
X749 2581 2584 2607 1 2 AN2T $T=537540 376880 1 0 $X=537540 $Y=371460
X750 2847 2844 2872 1 2 AN2T $T=582800 417200 0 0 $X=582800 $Y=416820
X751 2837 2873 2919 1 2 AN2T $T=586520 427280 0 0 $X=586520 $Y=426900
X752 2927 2879 2979 1 2 AN2T $T=597060 417200 0 0 $X=597060 $Y=416820
X753 3012 3019 3042 1 2 AN2T $T=609460 397040 0 0 $X=609460 $Y=396660
X754 3055 334 2995 1 2 AN2T $T=616280 407120 1 180 $X=611940 $Y=406740
X755 3125 3070 3145 1 2 AN2T $T=624960 407120 1 0 $X=624960 $Y=401700
X756 373 370 3208 1 2 AN2T $T=639220 507920 1 180 $X=634880 $Y=507540
X757 3439 405 409 1 2 AN2T $T=684480 397040 0 0 $X=684480 $Y=396660
X758 4138 642 685 1 2 AN2T $T=859320 366800 0 0 $X=859320 $Y=366420
X759 4291 722 4311 1 2 AN2T $T=903960 376880 1 0 $X=903960 $Y=371460
X760 746 722 755 1 2 AN2T $T=907680 366800 1 0 $X=907680 $Y=361380
X761 4478 722 805 1 2 AN2T $T=952940 366800 0 180 $X=948600 $Y=361380
X762 811 722 4513 1 2 AN2T $T=956040 366800 0 0 $X=956040 $Y=366420
X763 4560 722 827 1 2 AN2T $T=977740 366800 1 180 $X=973400 $Y=366420
X764 849 722 4665 1 2 AN2T $T=1008120 366800 0 180 $X=1003780 $Y=361380
X765 125 1 2 135 DELC $T=391840 386960 1 0 $X=391840 $Y=381540
X766 2013 1 2 2040 DELC $T=424700 376880 0 0 $X=424700 $Y=376500
X767 1946 1 2 2110 DELC $T=433380 376880 0 0 $X=433380 $Y=376500
X768 2124 1 2 2137 DELC $T=442680 397040 1 0 $X=442680 $Y=391620
X769 175 1 2 187 DELC $T=451980 507920 0 0 $X=451980 $Y=507540
X770 2161 1 2 202 DELC $T=457560 467600 1 0 $X=457560 $Y=462180
X771 2163 1 2 200 DELC $T=457560 497840 0 0 $X=457560 $Y=497460
X772 2167 1 2 2178 DELC $T=461280 376880 0 0 $X=461280 $Y=376500
X773 2199 1 2 228 DELC $T=474300 397040 1 0 $X=474300 $Y=391620
X774 2190 1 2 2173 DELC $T=483600 386960 1 0 $X=483600 $Y=381540
X775 2570 1 2 2577 DELC $T=533200 497840 1 0 $X=533200 $Y=492420
X776 366 1 2 371 DELC $T=631780 497840 0 0 $X=631780 $Y=497460
X777 378 1 2 3306 DELC $T=642940 497840 0 0 $X=642940 $Y=497460
X778 3355 1 2 3379 DELC $T=657200 467600 1 0 $X=657200 $Y=462180
X779 3367 1 2 3386 DELC $T=659060 457520 1 0 $X=659060 $Y=452100
X780 3384 1 2 3404 DELC $T=663400 386960 1 0 $X=663400 $Y=381540
X781 3399 1 2 3416 DELC $T=666500 366800 0 0 $X=666500 $Y=366420
X782 2965 1 2 3423 DELC $T=668980 386960 0 0 $X=668980 $Y=386580
X783 3377 1 2 3405 DELC $T=670840 507920 1 0 $X=670840 $Y=502500
X784 3436 1 2 3444 DELC $T=679520 366800 0 0 $X=679520 $Y=366420
X785 3448 1 2 3441 DELC $T=685100 417200 1 0 $X=685100 $Y=411780
X786 3437 1 2 3429 DELC $T=691920 477680 1 0 $X=691920 $Y=472260
X787 3476 1 2 3454 DELC $T=693780 417200 1 0 $X=693780 $Y=411780
X788 3495 1 2 3509 DELC $T=697500 437360 1 0 $X=697500 $Y=431940
X789 3442 1 2 3481 DELC $T=699360 397040 1 0 $X=699360 $Y=391620
X790 3498 1 2 3501 DELC $T=699980 447440 1 0 $X=699980 $Y=442020
X791 3504 1 2 3446 DELC $T=705560 507920 0 0 $X=705560 $Y=507540
X792 3502 1 2 3513 DELC $T=708040 437360 0 0 $X=708040 $Y=436980
X793 3630 1 2 3621 DELC $T=728500 457520 0 0 $X=728500 $Y=457140
X794 3632 1 2 3608 DELC $T=729120 507920 1 0 $X=729120 $Y=502500
X795 3642 1 2 3606 DELC $T=734700 477680 0 0 $X=734700 $Y=477300
X796 3667 1 2 3678 DELC $T=739040 447440 0 0 $X=739040 $Y=447060
X797 516 1 2 3687 DELC $T=740900 386960 1 0 $X=740900 $Y=381540
X798 3666 1 2 3627 DELC $T=740900 467600 1 0 $X=740900 $Y=462180
X799 3685 1 2 3618 DELC $T=747100 457520 0 0 $X=747100 $Y=457140
X800 3688 1 2 3677 DELC $T=758260 487760 1 0 $X=758260 $Y=482340
X801 3473 1 2 3799 DELC $T=763220 376880 1 0 $X=763220 $Y=371460
X802 3753 1 2 3757 DELC $T=763220 437360 1 0 $X=763220 $Y=431940
X803 3452 1 2 3786 DELC $T=766320 417200 1 0 $X=766320 $Y=411780
X804 3525 1 2 3796 DELC $T=768800 467600 1 0 $X=768800 $Y=462180
X805 3517 1 2 3804 DELC $T=770660 437360 1 0 $X=770660 $Y=431940
X806 3761 1 2 3756 DELC $T=770660 477680 0 0 $X=770660 $Y=477300
X807 3500 1 2 3767 DELC $T=779340 447440 0 0 $X=779340 $Y=447060
X808 598 1 2 3863 DELC $T=796080 376880 0 0 $X=796080 $Y=376500
X809 603 1 2 3923 DELC $T=800420 386960 0 0 $X=800420 $Y=386580
X810 634 1 2 3890 DELC $T=825840 427280 0 0 $X=825840 $Y=426900
X811 4233 1 2 4251 DELC $T=885980 417200 0 0 $X=885980 $Y=416820
X812 4264 1 2 4260 DELC $T=894040 477680 0 0 $X=894040 $Y=477300
X813 4274 1 2 4176 DELC $T=896520 467600 0 0 $X=896520 $Y=467220
X814 4278 1 2 4175 DELC $T=898380 457520 1 0 $X=898380 $Y=452100
X815 4280 1 2 4290 DELC $T=899000 487760 0 0 $X=899000 $Y=487380
X816 4286 1 2 4241 DELC $T=902720 477680 0 0 $X=902720 $Y=477300
X817 4289 1 2 4247 DELC $T=903340 437360 1 0 $X=903340 $Y=431940
X818 4319 1 2 4327 DELC $T=908920 437360 1 0 $X=908920 $Y=431940
X819 4321 1 2 4317 DELC $T=908920 477680 1 0 $X=908920 $Y=472260
X820 751 1 2 4333 DELC $T=909540 487760 0 0 $X=909540 $Y=487380
X821 4322 1 2 4250 DELC $T=910780 437360 0 0 $X=910780 $Y=436980
X822 4339 1 2 4124 DELC $T=915120 457520 0 0 $X=915120 $Y=457140
X823 4363 1 2 4389 DELC $T=920700 437360 1 0 $X=920700 $Y=431940
X824 4336 1 2 4150 DELC $T=920700 447440 0 0 $X=920700 $Y=447060
X825 4387 1 2 4349 DELC $T=925040 427280 0 0 $X=925040 $Y=426900
X826 4420 1 2 4076 DELC $T=933100 467600 0 0 $X=933100 $Y=467220
X827 4440 1 2 4388 DELC $T=938680 477680 0 0 $X=938680 $Y=477300
X828 4452 1 2 4042 DELC $T=942400 457520 1 0 $X=942400 $Y=452100
X829 4435 1 2 4408 DELC $T=959140 467600 1 0 $X=959140 $Y=462180
X830 4534 1 2 4488 DELC $T=963480 457520 0 0 $X=963480 $Y=457140
X831 4474 1 2 4446 DELC $T=967200 457520 1 0 $X=967200 $Y=452100
X832 4489 1 2 4464 DELC $T=974640 467600 1 0 $X=974640 $Y=462180
X833 4609 1 2 4486 DELC $T=985800 467600 1 0 $X=985800 $Y=462180
X834 4654 1 2 4544 DELC $T=1000680 437360 0 0 $X=1000680 $Y=436980
X835 4746 1 2 4585 DELC $T=1026720 467600 1 0 $X=1026720 $Y=462180
X836 947 2 967 1 INV1S $T=223200 386960 1 0 $X=223200 $Y=381540
X837 969 2 4 1 INV1S $T=226920 507920 1 0 $X=226920 $Y=502500
X838 984 2 944 1 INV1S $T=231260 487760 1 180 $X=230020 $Y=487380
X839 1000 2 983 1 INV1S $T=231880 437360 1 180 $X=230640 $Y=436980
X840 9 2 6 1 INV1S $T=231880 497840 1 180 $X=230640 $Y=497460
X841 944 2 965 1 INV1S $T=231260 487760 0 0 $X=231260 $Y=487380
X842 992 2 956 1 INV1S $T=233740 447440 1 180 $X=232500 $Y=447060
X843 998 2 957 1 INV1S $T=233740 457520 0 180 $X=232500 $Y=452100
X844 995 2 958 1 INV1S $T=233740 477680 0 180 $X=232500 $Y=472260
X845 1004 2 959 1 INV1S $T=233740 477680 1 180 $X=232500 $Y=477300
X846 1008 2 951 1 INV1S $T=234360 397040 0 180 $X=233120 $Y=391620
X847 1003 2 963 1 INV1S $T=234360 457520 1 180 $X=233120 $Y=457140
X848 1001 2 964 1 INV1S $T=234360 467600 1 180 $X=233120 $Y=467220
X849 1014 2 945 1 INV1S $T=234980 417200 0 180 $X=233740 $Y=411780
X850 973 2 991 1 INV1S $T=236220 407120 1 180 $X=234980 $Y=406740
X851 1012 2 973 1 INV1S $T=237460 407120 1 180 $X=236220 $Y=406740
X852 997 2 971 1 INV1S $T=238080 427280 0 180 $X=236840 $Y=421860
X853 1017 2 972 1 INV1S $T=238080 497840 0 180 $X=236840 $Y=492420
X854 14 2 966 1 INV1S $T=239940 366800 1 180 $X=238700 $Y=366420
X855 999 2 946 1 INV1S $T=240560 437360 0 180 $X=239320 $Y=431940
X856 1061 2 1011 1 INV1S $T=246760 497840 1 180 $X=245520 $Y=497460
X857 1054 2 1026 1 INV1S $T=247380 397040 0 180 $X=246140 $Y=391620
X858 4 2 1065 1 INV1S $T=246140 457520 1 0 $X=246140 $Y=452100
X859 20 2 994 1 INV1S $T=248000 417200 0 180 $X=246760 $Y=411780
X860 20 2 1005 1 INV1S $T=248620 407120 0 180 $X=247380 $Y=401700
X861 6 2 1050 1 INV1S $T=248620 447440 1 180 $X=247380 $Y=447060
X862 19 2 1062 1 INV1S $T=249240 376880 0 180 $X=248000 $Y=371460
X863 6 2 1042 1 INV1S $T=249240 467600 0 180 $X=248000 $Y=462180
X864 1070 2 16 1 INV1S $T=250480 507920 0 180 $X=249240 $Y=502500
X865 6 2 1057 1 INV1S $T=249860 487760 0 0 $X=249860 $Y=487380
X866 1109 2 1078 1 INV1S $T=255440 417200 1 180 $X=254200 $Y=416820
X867 1079 2 1096 1 INV1S $T=254200 437360 1 0 $X=254200 $Y=431940
X868 1018 2 1110 1 INV1S $T=256680 477680 1 0 $X=256680 $Y=472260
X869 1084 2 27 1 INV1S $T=259160 507920 1 0 $X=259160 $Y=502500
X870 29 2 1104 1 INV1S $T=261020 366800 1 180 $X=259780 $Y=366420
X871 1027 2 1118 1 INV1S $T=259780 437360 0 0 $X=259780 $Y=436980
X872 21 2 30 1 INV1S $T=261640 417200 1 180 $X=260400 $Y=416820
X873 1019 2 1123 1 INV1S $T=261020 447440 0 0 $X=261020 $Y=447060
X874 1051 2 1142 1 INV1S $T=261640 497840 1 0 $X=261640 $Y=492420
X875 1126 2 1127 1 INV1S $T=262260 507920 0 0 $X=262260 $Y=507540
X876 24 2 33 1 INV1S $T=264740 366800 1 0 $X=264740 $Y=361380
X877 1022 2 1140 1 INV1S $T=265360 457520 1 0 $X=265360 $Y=452100
X878 20 2 8 1 INV1S $T=269700 497840 0 0 $X=269700 $Y=497460
X879 1171 2 1143 1 INV1S $T=273420 407120 0 0 $X=273420 $Y=406740
X880 37 2 39 1 INV1S $T=273420 497840 1 0 $X=273420 $Y=492420
X881 1121 2 1175 1 INV1S $T=274040 366800 0 0 $X=274040 $Y=366420
X882 37 2 1178 1 INV1S $T=279620 427280 0 180 $X=278380 $Y=421860
X883 38 2 1204 1 INV1S $T=281480 407120 0 0 $X=281480 $Y=406740
X884 1214 2 1219 1 INV1S $T=287060 376880 1 0 $X=287060 $Y=371460
X885 1205 2 1199 1 INV1S $T=289540 427280 1 0 $X=289540 $Y=421860
X886 1223 2 1207 1 INV1S $T=291400 417200 0 180 $X=290160 $Y=411780
X887 1211 2 1205 1 INV1S $T=292020 427280 0 180 $X=290780 $Y=421860
X888 1231 2 1250 1 INV1S $T=293260 427280 0 0 $X=293260 $Y=426900
X889 1211 2 74 1 INV1S $T=295740 497840 1 0 $X=295740 $Y=492420
X890 71 2 1210 1 INV1S $T=297600 427280 0 180 $X=296360 $Y=421860
X891 1255 2 1281 1 INV1S $T=298840 427280 1 0 $X=298840 $Y=421860
X892 78 2 76 1 INV1S $T=301320 507920 1 180 $X=300080 $Y=507540
X893 1256 2 1282 1 INV1S $T=303180 397040 1 180 $X=301940 $Y=396660
X894 1283 2 1278 1 INV1S $T=302560 376880 1 0 $X=302560 $Y=371460
X895 1264 2 1294 1 INV1S $T=303180 437360 1 0 $X=303180 $Y=431940
X896 38 2 83 1 INV1S $T=307520 497840 1 180 $X=306280 $Y=497460
X897 86 2 88 1 INV1S $T=310620 366800 1 180 $X=309380 $Y=366420
X898 1324 2 1316 1 INV1S $T=310620 407120 1 180 $X=309380 $Y=406740
X899 1328 2 1323 1 INV1S $T=311240 386960 0 180 $X=310000 $Y=381540
X900 89 2 87 1 INV1S $T=311240 507920 1 180 $X=310000 $Y=507540
X901 1289 2 1320 1 INV1S $T=311860 447440 0 180 $X=310620 $Y=442020
X902 17 2 93 1 INV1S $T=311240 366800 1 0 $X=311240 $Y=361380
X903 1333 2 1327 1 INV1S $T=312480 427280 0 180 $X=311240 $Y=421860
X904 1208 2 1333 1 INV1S $T=312480 427280 1 0 $X=312480 $Y=421860
X905 17 2 1326 1 INV1S $T=313720 497840 0 0 $X=313720 $Y=497460
X906 1289 2 1350 1 INV1S $T=314340 447440 1 0 $X=314340 $Y=442020
X907 1322 2 1357 1 INV1S $T=314960 427280 1 0 $X=314960 $Y=421860
X908 17 2 1302 1 INV1S $T=316200 457520 0 0 $X=316200 $Y=457140
X909 1349 2 1368 1 INV1S $T=317440 417200 1 0 $X=317440 $Y=411780
X910 1359 2 1372 1 INV1S $T=318680 427280 0 0 $X=318680 $Y=426900
X911 95 2 1354 1 INV1S $T=321780 376880 0 180 $X=320540 $Y=371460
X912 1367 2 1382 1 INV1S $T=321160 437360 0 0 $X=321160 $Y=436980
X913 1348 2 1387 1 INV1S $T=321780 457520 1 0 $X=321780 $Y=452100
X914 92 2 1351 1 INV1S $T=323020 507920 0 180 $X=321780 $Y=502500
X915 1386 2 1394 1 INV1S $T=323020 467600 1 0 $X=323020 $Y=462180
X916 1383 2 1393 1 INV1S $T=323640 447440 1 0 $X=323640 $Y=442020
X917 1380 2 1401 1 INV1S $T=323640 467600 0 0 $X=323640 $Y=467220
X918 83 2 80 1 INV1S $T=324880 497840 1 180 $X=323640 $Y=497460
X919 1384 2 1408 1 INV1S $T=323640 507920 0 0 $X=323640 $Y=507540
X920 1394 2 1398 1 INV1S $T=324260 467600 1 0 $X=324260 $Y=462180
X921 1339 2 1400 1 INV1S $T=324260 477680 1 0 $X=324260 $Y=472260
X922 1330 2 1388 1 INV1S $T=326120 417200 1 180 $X=324880 $Y=416820
X923 1390 2 1407 1 INV1S $T=325500 487760 0 0 $X=325500 $Y=487380
X924 1399 2 1412 1 INV1S $T=326120 497840 0 0 $X=326120 $Y=497460
X925 1347 2 1420 1 INV1S $T=326740 477680 0 0 $X=326740 $Y=477300
X926 98 2 1409 1 INV1S $T=327360 376880 0 0 $X=327360 $Y=376500
X927 1413 2 1421 1 INV1S $T=327980 497840 1 0 $X=327980 $Y=492420
X928 1421 2 1430 1 INV1S $T=329220 497840 1 0 $X=329220 $Y=492420
X929 1429 2 1450 1 INV1S $T=331700 386960 1 0 $X=331700 $Y=381540
X930 38 2 1403 1 INV1S $T=331700 457520 0 0 $X=331700 $Y=457140
X931 1445 2 1455 1 INV1S $T=332320 437360 1 0 $X=332320 $Y=431940
X932 1457 2 1424 1 INV1S $T=333560 447440 1 180 $X=332320 $Y=447060
X933 1453 2 1467 1 INV1S $T=333560 407120 1 0 $X=333560 $Y=401700
X934 1446 2 1457 1 INV1S $T=336660 447440 1 180 $X=335420 $Y=447060
X935 1403 2 1432 1 INV1S $T=335420 457520 1 0 $X=335420 $Y=452100
X936 1455 2 1389 1 INV1S $T=336660 427280 0 0 $X=336660 $Y=426900
X937 1469 2 1489 1 INV1S $T=336660 457520 1 0 $X=336660 $Y=452100
X938 1498 2 1496 1 INV1S $T=338520 477680 1 0 $X=338520 $Y=472260
X939 1436 2 1513 1 INV1S $T=339760 447440 1 0 $X=339760 $Y=442020
X940 1460 2 1526 1 INV1S $T=342860 427280 1 0 $X=342860 $Y=421860
X941 1481 2 1528 1 INV1S $T=342860 447440 1 0 $X=342860 $Y=442020
X942 1496 2 1547 1 INV1S $T=345340 477680 1 0 $X=345340 $Y=472260
X943 1518 2 1535 1 INV1S $T=347200 487760 1 180 $X=345960 $Y=487380
X944 1493 2 1555 1 INV1S $T=347200 497840 1 0 $X=347200 $Y=492420
X945 1583 2 1570 1 INV1S $T=355880 407120 0 0 $X=355880 $Y=406740
X946 1551 2 1597 1 INV1S $T=357120 427280 0 180 $X=355880 $Y=421860
X947 1613 2 1610 1 INV1S $T=359600 437360 0 180 $X=358360 $Y=431940
X948 1624 2 1613 1 INV1S $T=360840 437360 0 180 $X=359600 $Y=431940
X949 108 2 112 1 INV1S $T=363940 497840 1 0 $X=363940 $Y=492420
X950 1649 2 1635 1 INV1S $T=365800 427280 1 180 $X=364560 $Y=426900
X951 108 2 1671 1 INV1S $T=368280 447440 1 0 $X=368280 $Y=442020
X952 119 2 69 1 INV1S $T=373240 366800 0 180 $X=372000 $Y=361380
X953 1666 2 1679 1 INV1S $T=372620 407120 0 0 $X=372620 $Y=406740
X954 1682 2 1688 1 INV1S $T=374480 437360 1 0 $X=374480 $Y=431940
X955 113 2 1675 1 INV1S $T=376340 427280 1 180 $X=375100 $Y=426900
X956 1676 2 1689 1 INV1S $T=375100 507920 1 0 $X=375100 $Y=502500
X957 11 2 1694 1 INV1S $T=377580 497840 1 0 $X=377580 $Y=492420
X958 1687 2 1717 1 INV1S $T=378200 417200 1 0 $X=378200 $Y=411780
X959 1711 2 1719 1 INV1S $T=381300 497840 0 0 $X=381300 $Y=497460
X960 123 2 1727 1 INV1S $T=387500 427280 1 180 $X=386260 $Y=426900
X961 1661 2 1755 1 INV1S $T=389360 427280 0 0 $X=389360 $Y=426900
X962 1764 2 1750 1 INV1S $T=390600 497840 0 180 $X=389360 $Y=492420
X963 1754 2 1741 1 INV1S $T=391840 507920 0 180 $X=390600 $Y=502500
X964 1731 2 1784 1 INV1S $T=391220 447440 1 0 $X=391220 $Y=442020
X965 11 2 1769 1 INV1S $T=393080 457520 0 0 $X=393080 $Y=457140
X966 1756 2 1781 1 INV1S $T=394940 417200 0 0 $X=394940 $Y=416820
X967 1778 2 1793 1 INV1S $T=395560 477680 0 0 $X=395560 $Y=477300
X968 1803 2 1812 1 INV1S $T=397420 437360 0 0 $X=397420 $Y=436980
X969 117 2 1660 1 INV1S $T=398040 417200 0 0 $X=398040 $Y=416820
X970 1805 2 1807 1 INV1S $T=399280 507920 1 180 $X=398040 $Y=507540
X971 1759 2 1822 1 INV1S $T=398660 447440 1 0 $X=398660 $Y=442020
X972 1780 2 1765 1 INV1S $T=399280 497840 1 0 $X=399280 $Y=492420
X973 117 2 1821 1 INV1S $T=399900 457520 0 0 $X=399900 $Y=457140
X974 1782 2 1827 1 INV1S $T=399900 467600 0 0 $X=399900 $Y=467220
X975 1811 2 1828 1 INV1S $T=399900 487760 1 0 $X=399900 $Y=482340
X976 1815 2 1852 1 INV1S $T=401140 417200 0 0 $X=401140 $Y=416820
X977 1787 2 1832 1 INV1S $T=401140 477680 0 0 $X=401140 $Y=477300
X978 1786 2 1843 1 INV1S $T=401760 457520 0 0 $X=401760 $Y=457140
X979 1810 2 1838 1 INV1S $T=402380 447440 0 0 $X=402380 $Y=447060
X980 1816 2 1854 1 INV1S $T=403000 427280 0 0 $X=403000 $Y=426900
X981 1790 2 1865 1 INV1S $T=404860 437360 1 0 $X=404860 $Y=431940
X982 1835 2 1883 1 INV1S $T=405480 417200 0 0 $X=405480 $Y=416820
X983 1813 2 1870 1 INV1S $T=406100 467600 0 0 $X=406100 $Y=467220
X984 1760 2 1871 1 INV1S $T=407340 497840 0 0 $X=407340 $Y=497460
X985 1839 2 1869 1 INV1S $T=408580 497840 0 0 $X=408580 $Y=497460
X986 1804 2 1906 1 INV1S $T=412300 427280 0 180 $X=411060 $Y=421860
X987 1855 2 1919 1 INV1S $T=411060 437360 1 0 $X=411060 $Y=431940
X988 1825 2 1978 1 INV1S $T=416020 417200 1 0 $X=416020 $Y=411780
X989 1820 2 1962 1 INV1S $T=419120 397040 1 180 $X=417880 $Y=396660
X990 1977 2 1980 1 INV1S $T=417880 437360 1 0 $X=417880 $Y=431940
X991 1866 2 1955 1 INV1S $T=419740 467600 0 0 $X=419740 $Y=467220
X992 1875 2 1952 1 INV1S $T=419740 477680 1 0 $X=419740 $Y=472260
X993 1945 2 2019 1 INV1S $T=425320 427280 1 0 $X=425320 $Y=421860
X994 1956 2 1863 1 INV1S $T=426560 507920 0 180 $X=425320 $Y=502500
X995 2007 2 1989 1 INV1S $T=425940 397040 0 0 $X=425940 $Y=396660
X996 1895 2 2032 1 INV1S $T=427180 487760 0 0 $X=427180 $Y=487380
X997 2054 2 2081 1 INV1S $T=434000 437360 0 0 $X=434000 $Y=436980
X998 1974 2 1939 1 INV1S $T=435860 437360 0 180 $X=434620 $Y=431940
X999 1922 2 2067 1 INV1S $T=435240 427280 1 0 $X=435240 $Y=421860
X1000 2100 2 2108 1 INV1S $T=437720 487760 0 0 $X=437720 $Y=487380
X1001 1904 2 2113 1 INV1S $T=438340 447440 0 0 $X=438340 $Y=447060
X1002 2047 2 2094 1 INV1S $T=440820 447440 0 180 $X=439580 $Y=442020
X1003 2094 2 2128 1 INV1S $T=442680 447440 1 0 $X=442680 $Y=442020
X1004 2096 2 2114 1 INV1S $T=442680 467600 1 0 $X=442680 $Y=462180
X1005 167 2 164 1 INV1S $T=445780 366800 1 180 $X=444540 $Y=366420
X1006 2120 2 2130 1 INV1S $T=447640 477680 1 180 $X=446400 $Y=477300
X1007 2083 2 2086 1 INV1S $T=453220 497840 0 180 $X=451980 $Y=492420
X1008 2155 2 2148 1 INV1S $T=453840 427280 1 180 $X=452600 $Y=426900
X1009 2029 2 2159 1 INV1S $T=456320 397040 1 0 $X=456320 $Y=391620
X1010 2110 2 2166 1 INV1S $T=460040 397040 1 0 $X=460040 $Y=391620
X1011 2040 2 2177 1 INV1S $T=464380 397040 1 0 $X=464380 $Y=391620
X1012 1864 2 2183 1 INV1S $T=468100 397040 1 0 $X=468100 $Y=391620
X1013 2212 2 2194 1 INV1S $T=472440 386960 1 180 $X=471200 $Y=386580
X1014 2206 2 2218 1 INV1S $T=473060 386960 0 0 $X=473060 $Y=386580
X1015 217 2 219 1 INV1S $T=473680 366800 0 0 $X=473680 $Y=366420
X1016 2191 2 2213 1 INV1S $T=473680 407120 1 0 $X=473680 $Y=401700
X1017 217 2 229 1 INV1S $T=477400 366800 0 0 $X=477400 $Y=366420
X1018 205 2 225 1 INV1S $T=478640 497840 1 180 $X=477400 $Y=497460
X1019 205 2 2232 1 INV1S $T=479880 497840 1 180 $X=478640 $Y=497460
X1020 205 2 2254 1 INV1S $T=481120 497840 1 180 $X=479880 $Y=497460
X1021 119 2 224 1 INV1S $T=481120 366800 0 0 $X=481120 $Y=366420
X1022 2273 2 2237 1 INV1S $T=482360 376880 0 180 $X=481120 $Y=371460
X1023 205 2 2195 1 INV1S $T=481120 497840 0 0 $X=481120 $Y=497460
X1024 2271 2 2239 1 INV1S $T=482360 386960 1 0 $X=482360 $Y=381540
X1025 2260 2 2266 1 INV1S $T=482980 427280 0 0 $X=482980 $Y=426900
X1026 2220 2 2285 1 INV1S $T=487320 427280 1 180 $X=486080 $Y=426900
X1027 233 2 2271 1 INV1S $T=488560 386960 1 180 $X=487320 $Y=386580
X1028 2208 2 2302 1 INV1S $T=487320 417200 1 0 $X=487320 $Y=411780
X1029 2321 2 2324 1 INV1S $T=492900 407120 1 0 $X=492900 $Y=401700
X1030 238 2 2307 1 INV1S $T=493520 376880 0 0 $X=493520 $Y=376500
X1031 2325 2 2355 1 INV1S $T=496000 417200 1 0 $X=496000 $Y=411780
X1032 2334 2 2352 1 INV1S $T=496620 457520 0 0 $X=496620 $Y=457140
X1033 2343 2 2365 1 INV1S $T=497240 437360 1 0 $X=497240 $Y=431940
X1034 2332 2 2359 1 INV1S $T=497240 447440 0 0 $X=497240 $Y=447060
X1035 2337 2 2335 1 INV1S $T=499100 366800 1 180 $X=497860 $Y=366420
X1036 2346 2 2366 1 INV1S $T=497860 447440 1 0 $X=497860 $Y=442020
X1037 2353 2 2373 1 INV1S $T=498480 477680 0 0 $X=498480 $Y=477300
X1038 2342 2 2348 1 INV1S $T=500340 397040 1 180 $X=499100 $Y=396660
X1039 2314 2 2367 1 INV1S $T=499720 427280 1 0 $X=499720 $Y=421860
X1040 2356 2 2375 1 INV1S $T=499720 457520 0 0 $X=499720 $Y=457140
X1041 2363 2 2362 1 INV1S $T=499720 467600 1 0 $X=499720 $Y=462180
X1042 2328 2 2386 1 INV1S $T=499720 507920 1 0 $X=499720 $Y=502500
X1043 2368 2 2385 1 INV1S $T=500340 497840 0 0 $X=500340 $Y=497460
X1044 2320 2 2354 1 INV1S $T=502820 386960 0 180 $X=501580 $Y=381540
X1045 2345 2 2397 1 INV1S $T=503440 487760 1 0 $X=503440 $Y=482340
X1046 2383 2 2392 1 INV1S $T=503440 487760 0 0 $X=503440 $Y=487380
X1047 2350 2 2393 1 INV1S $T=505300 376880 1 0 $X=505300 $Y=371460
X1048 2360 2 2390 1 INV1S $T=507780 427280 0 180 $X=506540 $Y=421860
X1049 254 2 2412 1 INV1S $T=509640 366800 0 0 $X=509640 $Y=366420
X1050 2277 2 2444 1 INV1S $T=513980 366800 0 0 $X=513980 $Y=366420
X1051 265 2 262 1 INV1S $T=518320 366800 1 180 $X=517080 $Y=366420
X1052 2410 2 2501 1 INV1S $T=520180 386960 1 0 $X=520180 $Y=381540
X1053 267 2 268 1 INV1S $T=525140 366800 1 180 $X=523900 $Y=366420
X1054 271 2 275 1 INV1S $T=528240 366800 0 0 $X=528240 $Y=366420
X1055 271 2 2511 1 INV1S $T=528860 407120 0 0 $X=528860 $Y=406740
X1056 2541 2 2564 1 INV1S $T=530100 427280 1 0 $X=530100 $Y=421860
X1057 282 2 2549 1 INV1S $T=534440 507920 1 180 $X=533200 $Y=507540
X1058 281 2 2585 1 INV1S $T=533820 427280 1 0 $X=533820 $Y=421860
X1059 2567 2 2573 1 INV1S $T=535060 437360 1 180 $X=533820 $Y=436980
X1060 282 2 286 1 INV1S $T=536920 366800 1 0 $X=536920 $Y=361380
X1061 282 2 2571 1 INV1S $T=538780 457520 1 0 $X=538780 $Y=452100
X1062 2601 2 2604 1 INV1S $T=539400 386960 1 0 $X=539400 $Y=381540
X1063 2579 2 2610 1 INV1S $T=539400 386960 0 0 $X=539400 $Y=386580
X1064 285 2 288 1 INV1S $T=539400 507920 0 0 $X=539400 $Y=507540
X1065 2583 2 2615 1 INV1S $T=540640 407120 0 0 $X=540640 $Y=406740
X1066 2618 2 2622 1 INV1S $T=541880 376880 1 0 $X=541880 $Y=371460
X1067 2629 2 2623 1 INV1S $T=543740 397040 1 180 $X=542500 $Y=396660
X1068 2630 2 2624 1 INV1S $T=543740 407120 1 180 $X=542500 $Y=406740
X1069 2632 2 2650 1 INV1S $T=543740 427280 0 0 $X=543740 $Y=426900
X1070 2646 2 2635 1 INV1S $T=545600 417200 1 180 $X=544360 $Y=416820
X1071 2651 2 2631 1 INV1S $T=546840 477680 1 180 $X=545600 $Y=477300
X1072 2628 2 2657 1 INV1S $T=546220 437360 0 0 $X=546220 $Y=436980
X1073 2654 2 2659 1 INV1S $T=546840 376880 1 0 $X=546840 $Y=371460
X1074 2653 2 2660 1 INV1S $T=547460 457520 1 0 $X=547460 $Y=452100
X1075 2638 2 293 1 INV1S $T=548080 497840 0 0 $X=548080 $Y=497460
X1076 2649 2 2674 1 INV1S $T=548700 447440 1 0 $X=548700 $Y=442020
X1077 2627 2 2684 1 INV1S $T=548700 497840 1 0 $X=548700 $Y=492420
X1078 2621 2 2685 1 INV1S $T=548700 507920 1 0 $X=548700 $Y=502500
X1079 2667 2 2675 1 INV1S $T=549320 477680 1 0 $X=549320 $Y=472260
X1080 2666 2 2699 1 INV1S $T=551180 447440 0 0 $X=551180 $Y=447060
X1081 2626 2 2652 1 INV1S $T=552420 487760 1 180 $X=551180 $Y=487380
X1082 2620 2 2702 1 INV1S $T=551800 467600 1 0 $X=551800 $Y=462180
X1083 2652 2 2687 1 INV1S $T=554280 487760 0 0 $X=554280 $Y=487380
X1084 2625 2 2662 1 INV1S $T=561100 366800 1 180 $X=559860 $Y=366420
X1085 2598 2 2768 1 INV1S $T=562960 366800 0 0 $X=562960 $Y=366420
X1086 2717 2 2766 1 INV1S $T=562960 477680 0 0 $X=562960 $Y=477300
X1087 2511 2 272 1 INV1S $T=564820 386960 0 180 $X=563580 $Y=381540
X1088 2760 2 2787 1 INV1S $T=565440 417200 1 0 $X=565440 $Y=411780
X1089 2786 2 2790 1 INV1S $T=566060 376880 1 0 $X=566060 $Y=371460
X1090 2703 2 2792 1 INV1S $T=567300 487760 1 0 $X=567300 $Y=482340
X1091 2724 2 2781 1 INV1S $T=569780 467600 0 0 $X=569780 $Y=467220
X1092 2789 2 2816 1 INV1S $T=572880 477680 1 0 $X=572880 $Y=472260
X1093 2825 2 2848 1 INV1S $T=579080 487760 0 0 $X=579080 $Y=487380
X1094 2825 2 2873 1 INV1S $T=579700 437360 1 0 $X=579700 $Y=431940
X1095 2835 2 2806 1 INV1S $T=582800 407120 1 180 $X=581560 $Y=406740
X1096 2857 2 2881 1 INV1S $T=583420 386960 0 0 $X=583420 $Y=386580
X1097 2825 2 313 1 INV1S $T=583420 487760 0 0 $X=583420 $Y=487380
X1098 2882 2 2887 1 INV1S $T=584660 417200 1 0 $X=584660 $Y=411780
X1099 2825 2 315 1 INV1S $T=585900 487760 1 180 $X=584660 $Y=487380
X1100 2875 2 2901 1 INV1S $T=587140 376880 1 0 $X=587140 $Y=371460
X1101 2872 2 2899 1 INV1S $T=587140 417200 0 0 $X=587140 $Y=416820
X1102 2859 2 2938 1 INV1S $T=592720 507920 0 0 $X=592720 $Y=507540
X1103 2797 2 2904 1 INV1S $T=593960 376880 0 0 $X=593960 $Y=376500
X1104 2967 2 2978 1 INV1S $T=600160 447440 1 0 $X=600160 $Y=442020
X1105 331 2 330 1 INV1S $T=603880 397040 1 180 $X=602640 $Y=396660
X1106 2940 2 2985 1 INV1S $T=603880 427280 0 180 $X=602640 $Y=421860
X1107 2956 2 2993 1 INV1S $T=603260 437360 1 0 $X=603260 $Y=431940
X1108 2950 2 2964 1 INV1S $T=603260 487760 0 0 $X=603260 $Y=487380
X1109 2993 2 2998 1 INV1S $T=604500 437360 1 0 $X=604500 $Y=431940
X1110 334 2 2974 1 INV1S $T=605740 487760 0 180 $X=604500 $Y=482340
X1111 2997 2 2958 1 INV1S $T=605120 386960 0 0 $X=605120 $Y=386580
X1112 3004 2 3008 1 INV1S $T=606360 427280 1 0 $X=606360 $Y=421860
X1113 325 2 3009 1 INV1S $T=606360 427280 0 0 $X=606360 $Y=426900
X1114 3024 2 3011 1 INV1S $T=609460 487760 1 180 $X=608220 $Y=487380
X1115 3010 2 3031 1 INV1S $T=609460 487760 0 0 $X=609460 $Y=487380
X1116 3027 2 3025 1 INV1S $T=611320 497840 1 180 $X=610080 $Y=497460
X1117 3020 2 3037 1 INV1S $T=610700 477680 0 0 $X=610700 $Y=477300
X1118 3046 2 3065 1 INV1S $T=615040 397040 1 0 $X=615040 $Y=391620
X1119 334 2 3052 1 INV1S $T=615040 447440 0 0 $X=615040 $Y=447060
X1120 3056 2 3050 1 INV1S $T=615040 477680 1 0 $X=615040 $Y=472260
X1121 3067 2 3083 1 INV1S $T=617520 457520 1 0 $X=617520 $Y=452100
X1122 3064 2 3075 1 INV1S $T=617520 457520 0 0 $X=617520 $Y=457140
X1123 3062 2 3074 1 INV1S $T=617520 467600 1 0 $X=617520 $Y=462180
X1124 3053 2 3073 1 INV1S $T=618760 407120 0 0 $X=618760 $Y=406740
X1125 331 2 3035 1 INV1S $T=620000 417200 0 180 $X=618760 $Y=411780
X1126 3094 2 3120 1 INV1S $T=621860 427280 0 0 $X=621860 $Y=426900
X1127 3088 2 3112 1 INV1S $T=621860 477680 1 0 $X=621860 $Y=472260
X1128 3095 2 3102 1 INV1S $T=621860 507920 1 0 $X=621860 $Y=502500
X1129 3076 2 3115 1 INV1S $T=623100 407120 0 0 $X=623100 $Y=406740
X1130 3121 2 3116 1 INV1S $T=624960 467600 1 180 $X=623720 $Y=467220
X1131 3080 2 3117 1 INV1S $T=625580 437360 1 180 $X=624340 $Y=436980
X1132 3126 2 3135 1 INV1S $T=624960 437360 1 0 $X=624960 $Y=431940
X1133 3030 2 3110 1 INV1S $T=624960 497840 0 0 $X=624960 $Y=497460
X1134 3077 2 3141 1 INV1S $T=626820 417200 1 0 $X=626820 $Y=411780
X1135 3040 2 3162 1 INV1S $T=630540 417200 1 0 $X=630540 $Y=411780
X1136 3104 2 3168 1 INV1S $T=631160 447440 0 0 $X=631160 $Y=447060
X1137 3092 2 3153 1 INV1S $T=631780 417200 0 0 $X=631780 $Y=416820
X1138 3103 2 3183 1 INV1S $T=633640 427280 1 180 $X=632400 $Y=426900
X1139 3152 2 3202 1 INV1S $T=634880 407120 0 0 $X=634880 $Y=406740
X1140 3154 2 3203 1 INV1S $T=634880 457520 1 0 $X=634880 $Y=452100
X1141 3139 2 3212 1 INV1S $T=637360 467600 1 180 $X=636120 $Y=467220
X1142 3220 2 3226 1 INV1S $T=637360 467600 0 0 $X=637360 $Y=467220
X1143 3150 2 3220 1 INV1S $T=637360 477680 1 0 $X=637360 $Y=472260
X1144 3109 2 3233 1 INV1S $T=638600 467600 0 0 $X=638600 $Y=467220
X1145 3138 2 3207 1 INV1S $T=640460 467600 0 180 $X=639220 $Y=462180
X1146 3219 2 3244 1 INV1S $T=639840 417200 0 0 $X=639840 $Y=416820
X1147 3230 2 3252 1 INV1S $T=640460 467600 1 0 $X=640460 $Y=462180
X1148 3239 2 3263 1 INV1S $T=641700 386960 1 0 $X=641700 $Y=381540
X1149 3263 2 3272 1 INV1S $T=642940 386960 1 0 $X=642940 $Y=381540
X1150 3265 2 3251 1 INV1S $T=644800 407120 1 180 $X=643560 $Y=406740
X1151 3294 2 3285 1 INV1S $T=646660 477680 0 180 $X=645420 $Y=472260
X1152 3157 2 3143 1 INV1S $T=646660 507920 1 0 $X=646660 $Y=502500
X1153 3297 2 3317 1 INV1S $T=648520 417200 1 0 $X=648520 $Y=411780
X1154 3231 2 3319 1 INV1S $T=652240 397040 1 180 $X=651000 $Y=396660
X1155 3314 2 3332 1 INV1S $T=655340 477680 0 180 $X=654100 $Y=472260
X1156 3087 2 3156 1 INV1S $T=656580 497840 0 180 $X=655340 $Y=492420
X1157 3300 2 3289 1 INV1S $T=657820 427280 1 180 $X=656580 $Y=426900
X1158 3284 2 3361 1 INV1S $T=657200 397040 0 0 $X=657200 $Y=396660
X1159 3149 2 3314 1 INV1S $T=659060 477680 0 180 $X=657820 $Y=472260
X1160 3356 2 3228 1 INV1S $T=659680 417200 0 180 $X=658440 $Y=411780
X1161 3254 2 3326 1 INV1S $T=661540 407120 1 180 $X=660300 $Y=406740
X1162 3210 2 3254 1 INV1S $T=665880 407120 1 180 $X=664640 $Y=406740
X1163 3211 2 3249 1 INV1S $T=666500 467600 0 180 $X=665260 $Y=462180
X1164 398 2 2846 1 INV1S $T=670840 397040 0 180 $X=669600 $Y=391620
X1165 3169 2 3211 1 INV1S $T=670840 467600 0 180 $X=669600 $Y=462180
X1166 408 2 3428 1 INV1S $T=675180 457520 1 0 $X=675180 $Y=452100
X1167 424 2 3462 1 INV1S $T=686960 427280 0 0 $X=686960 $Y=426900
X1168 429 2 3464 1 INV1S $T=689440 427280 1 0 $X=689440 $Y=421860
X1169 431 2 3469 1 INV1S $T=690060 417200 1 0 $X=690060 $Y=411780
X1170 432 2 3470 1 INV1S $T=690060 437360 1 0 $X=690060 $Y=431940
X1171 434 2 3474 1 INV1S $T=690680 427280 1 0 $X=690680 $Y=421860
X1172 435 2 3471 1 INV1S $T=690680 427280 0 0 $X=690680 $Y=426900
X1173 438 2 3477 1 INV1S $T=691920 417200 0 0 $X=691920 $Y=416820
X1174 439 2 3482 1 INV1S $T=693160 437360 1 0 $X=693160 $Y=431940
X1175 441 2 3485 1 INV1S $T=693780 427280 0 0 $X=693780 $Y=426900
X1176 444 2 3489 1 INV1S $T=694400 427280 1 0 $X=694400 $Y=421860
X1177 445 2 3483 1 INV1S $T=694400 457520 0 0 $X=694400 $Y=457140
X1178 446 2 3488 1 INV1S $T=695640 417200 0 0 $X=695640 $Y=416820
X1179 449 2 3491 1 INV1S $T=696260 437360 1 0 $X=696260 $Y=431940
X1180 451 2 3503 1 INV1S $T=697500 427280 0 0 $X=697500 $Y=426900
X1181 452 2 3515 1 INV1S $T=698120 427280 1 0 $X=698120 $Y=421860
X1182 453 2 3514 1 INV1S $T=698740 417200 0 0 $X=698740 $Y=416820
X1183 454 2 3505 1 INV1S $T=698740 447440 1 0 $X=698740 $Y=442020
X1184 455 2 3508 1 INV1S $T=699360 437360 0 0 $X=699360 $Y=436980
X1185 456 2 3522 1 INV1S $T=699980 427280 0 0 $X=699980 $Y=426900
X1186 457 2 3519 1 INV1S $T=700600 407120 1 0 $X=700600 $Y=401700
X1187 3499 2 3527 1 INV1S $T=701840 427280 1 0 $X=701840 $Y=421860
X1188 461 2 3542 1 INV1S $T=702460 417200 0 0 $X=702460 $Y=416820
X1189 3518 2 3537 1 INV1S $T=703080 427280 0 0 $X=703080 $Y=426900
X1190 462 2 3534 1 INV1S $T=703080 437360 1 0 $X=703080 $Y=431940
X1191 3550 2 3541 1 INV1S $T=706800 417200 0 0 $X=706800 $Y=416820
X1192 3545 2 3547 1 INV1S $T=706800 437360 1 0 $X=706800 $Y=431940
X1193 3536 2 3553 1 INV1S $T=706800 437360 0 0 $X=706800 $Y=436980
X1194 3557 2 3567 1 INV1S $T=709900 437360 1 0 $X=709900 $Y=431940
X1195 3530 2 3564 1 INV1S $T=709900 447440 1 0 $X=709900 $Y=442020
X1196 3570 2 3574 1 INV1S $T=711760 437360 1 0 $X=711760 $Y=431940
X1197 3588 2 3590 1 INV1S $T=715480 437360 1 0 $X=715480 $Y=431940
X1198 3589 2 3600 1 INV1S $T=717340 437360 1 0 $X=717340 $Y=431940
X1199 499 2 3572 1 INV1S $T=728500 457520 1 180 $X=727260 $Y=457140
X1200 507 2 3652 1 INV1S $T=732220 437360 1 0 $X=732220 $Y=431940
X1201 3635 2 3670 1 INV1S $T=739040 407120 0 0 $X=739040 $Y=406740
X1202 503 2 3672 1 INV1S $T=740280 437360 0 0 $X=740280 $Y=436980
X1203 504 2 3684 1 INV1S $T=744000 437360 0 0 $X=744000 $Y=436980
X1204 517 2 3683 1 INV1S $T=744620 417200 0 0 $X=744620 $Y=416820
X1205 518 2 3686 1 INV1S $T=745240 427280 1 0 $X=745240 $Y=421860
X1206 519 2 3691 1 INV1S $T=746480 427280 1 0 $X=746480 $Y=421860
X1207 3452 2 3695 1 INV1S $T=747100 427280 0 0 $X=747100 $Y=426900
X1208 3708 2 3719 1 INV1S $T=752060 497840 1 0 $X=752060 $Y=492420
X1209 3749 2 3735 1 INV1S $T=763220 417200 0 0 $X=763220 $Y=416820
X1210 3740 2 3755 1 INV1S $T=763840 427280 0 0 $X=763840 $Y=426900
X1211 3787 2 3790 1 INV1S $T=770660 497840 1 0 $X=770660 $Y=492420
X1212 3792 2 3738 1 INV1S $T=772520 417200 0 180 $X=771280 $Y=411780
X1213 3811 2 3816 1 INV1S $T=776240 427280 0 0 $X=776240 $Y=426900
X1214 583 2 3836 1 INV1S $T=780580 507920 0 0 $X=780580 $Y=507540
X1215 3832 2 3818 1 INV1S $T=782440 437360 0 180 $X=781200 $Y=431940
X1216 3826 2 3856 1 INV1S $T=785540 487760 0 0 $X=785540 $Y=487380
X1217 570 2 3864 1 INV1S $T=788640 507920 1 180 $X=787400 $Y=507540
X1218 3871 2 3853 1 INV1S $T=789260 427280 1 180 $X=788020 $Y=426900
X1219 3880 2 3876 1 INV1S $T=792360 427280 1 180 $X=791120 $Y=426900
X1220 3870 2 3887 1 INV1S $T=792980 497840 0 0 $X=792980 $Y=497460
X1221 593 2 3895 1 INV1S $T=794220 507920 0 0 $X=794220 $Y=507540
X1222 3932 2 3855 1 INV1S $T=801660 437360 0 180 $X=800420 $Y=431940
X1223 3928 2 3803 1 INV1S $T=802280 417200 1 180 $X=801040 $Y=416820
X1224 3936 2 3866 1 INV1S $T=805380 427280 0 180 $X=804140 $Y=421860
X1225 3943 2 3854 1 INV1S $T=806620 417200 1 180 $X=805380 $Y=416820
X1226 3952 2 3840 1 INV1S $T=810340 417200 1 180 $X=809100 $Y=416820
X1227 4045 2 4055 1 INV1S $T=837000 477680 0 180 $X=835760 $Y=472260
X1228 4013 2 4050 1 INV1S $T=841340 507920 0 180 $X=840100 $Y=502500
X1229 4067 2 4020 1 INV1S $T=841960 477680 0 180 $X=840720 $Y=472260
X1230 665 2 4101 1 INV1S $T=850640 507920 0 0 $X=850640 $Y=507540
X1231 4123 2 4120 1 INV1S $T=855600 507920 0 180 $X=854360 $Y=502500
X1232 4103 2 4086 1 INV1S $T=858700 477680 0 180 $X=857460 $Y=472260
X1233 4116 2 4131 1 INV1S $T=863040 487760 0 180 $X=861800 $Y=482340
X1234 4191 2 4206 1 INV1S $T=874200 487760 0 0 $X=874200 $Y=487380
X1235 4213 2 4178 1 INV1S $T=881640 447440 1 180 $X=880400 $Y=447060
X1236 4237 2 714 1 INV1S $T=885980 447440 1 180 $X=884740 $Y=447060
X1237 4225 2 4224 1 INV1S $T=886600 507920 1 0 $X=886600 $Y=502500
X1238 720 2 721 1 INV1S $T=887840 507920 1 0 $X=887840 $Y=502500
X1239 4176 2 4268 1 INV1S $T=889080 447440 0 0 $X=889080 $Y=447060
X1240 398 2 683 1 INV1S $T=892800 487760 0 0 $X=892800 $Y=487380
X1241 4316 2 747 1 INV1S $T=908920 497840 1 180 $X=907680 $Y=497460
X1242 4320 2 758 1 INV1S $T=910780 497840 1 0 $X=910780 $Y=492420
X1243 4326 2 759 1 INV1S $T=912640 497840 1 180 $X=911400 $Y=497460
X1244 778 2 4381 1 INV1S $T=927520 507920 0 180 $X=926280 $Y=502500
X1245 4418 2 4403 1 INV1S $T=932480 497840 1 180 $X=931240 $Y=497460
X1246 4432 2 4425 1 INV1S $T=937440 477680 0 0 $X=937440 $Y=477300
X1247 4436 2 4429 1 INV1S $T=943640 497840 1 180 $X=942400 $Y=497460
X1248 4441 2 4376 1 INV1S $T=944880 477680 1 180 $X=943640 $Y=477300
X1249 4457 2 4481 1 INV1S $T=950460 497840 0 0 $X=950460 $Y=497460
X1250 4448 2 4483 1 INV1S $T=952320 477680 1 180 $X=951080 $Y=477300
X1251 4500 2 4506 1 INV1S $T=957280 477680 1 0 $X=957280 $Y=472260
X1252 4506 2 4511 1 INV1S $T=959760 477680 0 180 $X=958520 $Y=472260
X1253 4512 2 4532 1 INV1S $T=966580 497840 1 180 $X=965340 $Y=497460
X1254 4589 2 4577 1 INV1S $T=980220 487760 0 180 $X=978980 $Y=482340
X1255 4597 2 4578 1 INV1S $T=980220 497840 0 180 $X=978980 $Y=492420
X1256 832 2 4608 1 INV1S $T=982080 507920 1 0 $X=982080 $Y=502500
X1257 4608 2 800 1 INV1S $T=991380 497840 0 0 $X=991380 $Y=497460
X1258 844 2 4629 1 INV1S $T=996340 507920 1 180 $X=995100 $Y=507540
X1259 868 2 871 1 INV1S $T=1034160 507920 0 0 $X=1034160 $Y=507540
X1260 4864 2 4872 1 INV1S $T=1075080 487760 1 0 $X=1075080 $Y=482340
X1261 1479 1 1433 1465 2 1439 ND3 $T=329840 386960 0 0 $X=329840 $Y=386580
X1262 1642 1 1620 1655 2 1652 ND3 $T=365800 376880 0 0 $X=365800 $Y=376500
X1263 1867 1 1884 1899 2 1806 ND3 $T=407960 386960 1 0 $X=407960 $Y=381540
X1264 2433 1 2419 2389 2 2414 ND3 $T=513980 407120 0 180 $X=511500 $Y=401700
X1265 3507 1 3479 3499 2 3487 ND3 $T=699980 497840 1 180 $X=697500 $Y=497460
X1266 3528 1 3479 3518 2 3512 ND3 $T=703080 487760 0 180 $X=700600 $Y=482340
X1267 3539 1 3479 3536 2 3490 ND3 $T=704940 477680 1 180 $X=702460 $Y=477300
X1268 3521 1 3479 3530 2 3524 ND3 $T=704940 487760 1 180 $X=702460 $Y=487380
X1269 3549 1 3479 3545 2 3532 ND3 $T=706800 467600 1 180 $X=704320 $Y=467220
X1270 3552 1 3479 3550 2 3535 ND3 $T=706800 477680 0 180 $X=704320 $Y=472260
X1271 3578 1 3479 3557 2 3538 ND3 $T=709280 447440 1 180 $X=706800 $Y=447060
X1272 3583 1 3479 3570 2 3496 ND3 $T=711760 457520 1 180 $X=709280 $Y=457140
X1273 3581 1 3479 3589 2 3558 ND3 $T=713000 447440 1 180 $X=710520 $Y=447060
X1274 3596 1 3479 3588 2 3543 ND3 $T=716100 437360 1 180 $X=713620 $Y=436980
X1275 3525 1 3544 3716 2 3475 ND3 $T=749580 417200 1 0 $X=749580 $Y=411780
X1276 3697 1 3731 3734 2 3743 ND3 $T=757020 397040 1 0 $X=757020 $Y=391620
X1277 3500 1 3452 3741 2 3517 ND3 $T=763840 417200 1 0 $X=763840 $Y=411780
X1278 3612 1 3773 3785 2 3775 ND3 $T=765700 386960 0 0 $X=765700 $Y=386580
X1279 3802 1 3736 3792 2 3784 ND3 $T=773140 427280 1 180 $X=770660 $Y=426900
X1280 3821 1 3736 3811 2 3807 ND3 $T=778100 437360 0 180 $X=775620 $Y=431940
X1281 3703 1 3827 3839 2 3838 ND3 $T=779340 386960 0 0 $X=779340 $Y=386580
X1282 3845 1 3736 3832 2 3835 ND3 $T=784920 437360 1 180 $X=782440 $Y=436980
X1283 3888 1 3736 3881 2 3865 ND3 $T=792360 437360 0 180 $X=789880 $Y=431940
X1284 3633 1 3879 3891 2 3872 ND3 $T=791120 386960 1 0 $X=791120 $Y=381540
X1285 597 1 3897 3898 2 600 ND3 $T=794840 366800 1 0 $X=794840 $Y=361380
X1286 3909 1 3736 3908 2 3829 ND3 $T=797940 437360 1 180 $X=795460 $Y=436980
X1287 3669 1 3914 3917 2 3913 ND3 $T=797320 386960 1 0 $X=797320 $Y=381540
X1288 3940 1 3736 3932 2 3925 ND3 $T=804140 437360 1 180 $X=801660 $Y=436980
X1289 3942 1 3736 3938 2 3907 ND3 $T=807240 427280 1 180 $X=804760 $Y=426900
X1290 3954 1 3736 3928 2 3919 ND3 $T=807240 437360 0 180 $X=804760 $Y=431940
X1291 3974 1 3736 3943 2 3931 ND3 $T=812200 427280 0 180 $X=809720 $Y=421860
X1292 3977 1 3736 3952 2 3934 ND3 $T=813440 427280 1 180 $X=810960 $Y=426900
X1293 4035 1 4023 3996 2 3981 ND3 $T=828940 407120 1 180 $X=826460 $Y=406740
X1294 4059 1 4054 4060 2 3992 ND3 $T=835760 407120 1 180 $X=833280 $Y=406740
X1295 4118 1 4111 4130 2 3976 ND3 $T=855600 407120 1 0 $X=855600 $Y=401700
X1296 4143 1 4142 4117 2 4010 ND3 $T=861180 407120 1 180 $X=858700 $Y=406740
X1297 4196 1 4188 4186 2 3966 ND3 $T=873580 407120 1 180 $X=871100 $Y=406740
X1298 707 1 4203 4221 2 3961 ND3 $T=879160 366800 1 0 $X=879160 $Y=361380
X1299 4256 1 4258 4267 2 3984 ND3 $T=891560 407120 0 0 $X=891560 $Y=406740
X1300 4254 1 4176 4261 2 4260 ND3 $T=895280 467600 1 180 $X=892800 $Y=467220
X1301 4250 1 4238 4269 2 4241 ND3 $T=897760 467600 1 0 $X=897760 $Y=462180
X1302 4296 1 4299 4259 2 4305 ND3 $T=904580 427280 1 0 $X=904580 $Y=421860
X1303 4308 1 4307 4200 2 4323 ND3 $T=907680 427280 0 0 $X=907680 $Y=426900
X1304 4343 1 4318 4346 2 4347 ND3 $T=916360 397040 0 0 $X=916360 $Y=396660
X1305 4364 1 4328 4294 2 4392 ND3 $T=920700 386960 1 0 $X=920700 $Y=381540
X1306 4377 1 4369 4378 2 4384 ND3 $T=923180 366800 1 0 $X=923180 $Y=361380
X1307 4451 1 4461 4444 2 4453 ND3 $T=944880 427280 1 180 $X=942400 $Y=426900
X1308 4502 1 4508 4287 2 4524 ND3 $T=959140 417200 0 0 $X=959140 $Y=416820
X1309 4528 1 4523 4520 2 4518 ND3 $T=962860 366800 1 180 $X=960380 $Y=366420
X1310 4561 1 4499 4275 2 4536 ND3 $T=967200 397040 0 180 $X=964720 $Y=391620
X1311 4570 1 4564 4276 2 4606 ND3 $T=974020 427280 0 180 $X=971540 $Y=421860
X1312 4696 1 4695 4653 2 4668 ND3 $T=1015560 447440 0 180 $X=1013080 $Y=442020
X1313 4712 1 4704 4625 2 4680 ND3 $T=1018040 417200 0 180 $X=1015560 $Y=411780
X1314 4710 1 4707 4660 2 4682 ND3 $T=1018660 407120 0 180 $X=1016180 $Y=401700
X1315 4731 1 4721 4630 2 4686 ND3 $T=1021140 376880 1 180 $X=1018660 $Y=376500
X1316 4703 1 4714 4713 2 4725 ND3 $T=1019280 487760 0 0 $X=1019280 $Y=487380
X1317 863 1 4733 4624 2 4718 ND3 $T=1024860 366800 0 180 $X=1022380 $Y=361380
X1318 4740 1 4736 4647 2 4715 ND3 $T=1025480 366800 1 180 $X=1023000 $Y=366420
X1319 4754 1 4737 4636 2 4717 ND3 $T=1025480 427280 0 180 $X=1023000 $Y=421860
X1320 4744 1 4741 4652 2 4692 ND3 $T=1026100 437360 0 180 $X=1023620 $Y=431940
X1321 4765 1 4769 4651 2 4687 ND3 $T=1028580 397040 0 180 $X=1026100 $Y=391620
X1322 4762 1 4750 4611 2 4738 ND3 $T=1029820 437360 1 180 $X=1027340 $Y=436980
X1323 1065 2 1064 1079 1 NR2 $T=249240 427280 0 0 $X=249240 $Y=426900
X1324 1078 2 1063 21 1 NR2 $T=252340 427280 0 180 $X=250480 $Y=421860
X1325 1101 2 1098 1080 1 NR2 $T=257920 407120 1 180 $X=256060 $Y=406740
X1326 1065 2 1069 1114 1 NR2 $T=257920 427280 1 0 $X=257920 $Y=421860
X1327 41 2 1184 46 1 NR2 $T=277760 497840 1 0 $X=277760 $Y=492420
X1328 70 2 1072 41 1 NR2 $T=281480 497840 1 180 $X=279620 $Y=497460
X1329 41 2 1160 45 1 NR2 $T=282100 447440 0 180 $X=280240 $Y=442020
X1330 41 2 1187 1241 1 NR2 $T=280240 457520 1 0 $X=280240 $Y=452100
X1331 41 2 1182 48 1 NR2 $T=280240 457520 0 0 $X=280240 $Y=457140
X1332 41 2 1183 54 1 NR2 $T=280860 467600 0 0 $X=280860 $Y=467220
X1333 41 2 1161 53 1 NR2 $T=281480 447440 0 0 $X=281480 $Y=447060
X1334 41 2 1191 55 1 NR2 $T=281480 477680 1 0 $X=281480 $Y=472260
X1335 41 2 1192 56 1 NR2 $T=281480 477680 0 0 $X=281480 $Y=477300
X1336 41 2 1180 50 1 NR2 $T=281480 487760 1 0 $X=281480 $Y=482340
X1337 41 2 1164 51 1 NR2 $T=281480 487760 0 0 $X=281480 $Y=487380
X1338 58 2 32 41 1 NR2 $T=285200 366800 0 180 $X=283340 $Y=361380
X1339 41 2 1179 62 1 NR2 $T=283960 457520 0 0 $X=283960 $Y=457140
X1340 52 2 1213 45 1 NR2 $T=286440 447440 0 180 $X=284580 $Y=442020
X1341 52 2 1235 48 1 NR2 $T=286440 467600 0 180 $X=284580 $Y=462180
X1342 41 2 1166 63 1 NR2 $T=284580 487760 1 0 $X=284580 $Y=482340
X1343 52 2 1218 43 1 NR2 $T=287060 447440 1 180 $X=285200 $Y=447060
X1344 52 2 1222 55 1 NR2 $T=285200 477680 1 0 $X=285200 $Y=472260
X1345 52 2 1216 56 1 NR2 $T=285200 477680 0 0 $X=285200 $Y=477300
X1346 52 2 60 64 1 NR2 $T=289540 366800 0 180 $X=287680 $Y=361380
X1347 59 2 1217 47 1 NR2 $T=290160 437360 0 180 $X=288300 $Y=431940
X1348 52 2 1228 62 1 NR2 $T=288300 457520 0 0 $X=288300 $Y=457140
X1349 52 2 1232 54 1 NR2 $T=288300 467600 0 0 $X=288300 $Y=467220
X1350 52 2 1233 50 1 NR2 $T=288300 487760 1 0 $X=288300 $Y=482340
X1351 52 2 1236 53 1 NR2 $T=290160 447440 0 0 $X=290160 $Y=447060
X1352 52 2 1247 1241 1 NR2 $T=291400 457520 0 0 $X=291400 $Y=457140
X1353 52 2 1248 63 1 NR2 $T=292020 487760 1 0 $X=292020 $Y=482340
X1354 1246 2 1254 1223 1 NR2 $T=294500 417200 0 180 $X=292640 $Y=411780
X1355 52 2 72 69 1 NR2 $T=293260 366800 1 0 $X=293260 $Y=361380
X1356 52 2 1265 46 1 NR2 $T=293260 487760 0 0 $X=293260 $Y=487380
X1357 52 2 1279 51 1 NR2 $T=300080 497840 0 0 $X=300080 $Y=497460
X1358 1289 2 1300 1280 1 NR2 $T=303800 427280 0 180 $X=301940 $Y=421860
X1359 1257 2 1256 1296 1 NR2 $T=303180 407120 1 0 $X=303180 $Y=401700
X1360 1289 2 1301 1255 1 NR2 $T=305040 417200 1 180 $X=303180 $Y=416820
X1361 70 2 1304 52 1 NR2 $T=305040 497840 1 180 $X=303180 $Y=497460
X1362 58 2 84 52 1 NR2 $T=308140 366800 0 180 $X=306280 $Y=361380
X1363 1289 2 1336 1296 1 NR2 $T=312480 437360 0 180 $X=310620 $Y=431940
X1364 1289 2 1345 1208 1 NR2 $T=314340 417200 1 180 $X=312480 $Y=416820
X1365 106 2 1553 1241 1 NR2 $T=345960 457520 0 180 $X=344100 $Y=452100
X1366 106 2 1595 55 1 NR2 $T=352160 477680 1 180 $X=350300 $Y=477300
X1367 106 2 1612 62 1 NR2 $T=352780 457520 0 180 $X=350920 $Y=452100
X1368 106 2 1599 44 1 NR2 $T=356500 437360 0 180 $X=354640 $Y=431940
X1369 106 2 1600 43 1 NR2 $T=356500 447440 0 180 $X=354640 $Y=442020
X1370 106 2 1625 45 1 NR2 $T=359600 437360 1 180 $X=357740 $Y=436980
X1371 106 2 1626 50 1 NR2 $T=359600 487760 1 180 $X=357740 $Y=487380
X1372 106 2 1633 48 1 NR2 $T=358360 467600 1 0 $X=358360 $Y=462180
X1373 106 2 1627 56 1 NR2 $T=358360 477680 0 0 $X=358360 $Y=477300
X1374 106 2 1616 54 1 NR2 $T=358980 477680 1 0 $X=358980 $Y=472260
X1375 106 2 1614 46 1 NR2 $T=359600 497840 1 0 $X=359600 $Y=492420
X1376 106 2 1622 53 1 NR2 $T=363320 447440 1 180 $X=361460 $Y=447060
X1377 106 2 1640 63 1 NR2 $T=363320 487760 0 0 $X=363320 $Y=487380
X1378 106 2 1646 49 1 NR2 $T=364560 447440 1 0 $X=364560 $Y=442020
X1379 1649 2 1648 1624 1 NR2 $T=367040 427280 0 0 $X=367040 $Y=426900
X1380 115 2 1657 51 1 NR2 $T=368900 497840 1 180 $X=367040 $Y=497460
X1381 106 2 1667 47 1 NR2 $T=370140 437360 1 180 $X=368280 $Y=436980
X1382 70 2 1678 115 1 NR2 $T=373240 497840 1 180 $X=371380 $Y=497460
X1383 1682 2 1731 113 1 NR2 $T=381920 447440 1 0 $X=381920 $Y=442020
X1384 123 2 1739 1721 1 NR2 $T=386260 437360 0 180 $X=384400 $Y=431940
X1385 123 2 1757 1724 1 NR2 $T=389360 437360 0 180 $X=387500 $Y=431940
X1386 123 2 1766 1661 1 NR2 $T=388120 427280 1 0 $X=388120 $Y=421860
X1387 123 2 1795 1784 1 NR2 $T=395560 447440 1 180 $X=393700 $Y=447060
X1388 1855 2 1979 1939 1 NR2 $T=417880 427280 1 0 $X=417880 $Y=421860
X1389 1453 2 2066 1989 1 NR2 $T=431520 397040 1 0 $X=431520 $Y=391620
X1390 1948 2 2132 2130 1 NR2 $T=443300 477680 0 0 $X=443300 $Y=477300
X1391 203 2 2172 48 1 NR2 $T=464380 467600 0 180 $X=462520 $Y=462180
X1392 203 2 2175 50 1 NR2 $T=465000 487760 0 180 $X=463140 $Y=482340
X1393 203 2 2197 192 1 NR2 $T=465620 457520 0 180 $X=463760 $Y=452100
X1394 203 2 209 208 1 NR2 $T=464380 366800 1 0 $X=464380 $Y=361380
X1395 203 2 2188 54 1 NR2 $T=466240 467600 1 180 $X=464380 $Y=467220
X1396 203 2 2196 62 1 NR2 $T=466860 457520 0 0 $X=466860 $Y=457140
X1397 203 2 2189 63 1 NR2 $T=468720 487760 0 180 $X=466860 $Y=482340
X1398 203 2 2202 53 1 NR2 $T=469340 447440 1 180 $X=467480 $Y=447060
X1399 203 2 216 64 1 NR2 $T=468100 366800 1 0 $X=468100 $Y=361380
X1400 203 2 2192 55 1 NR2 $T=468100 477680 1 0 $X=468100 $Y=472260
X1401 203 2 2210 56 1 NR2 $T=468100 477680 0 0 $X=468100 $Y=477300
X1402 203 2 2230 224 1 NR2 $T=474920 366800 0 0 $X=474920 $Y=366420
X1403 2207 2 2228 2214 1 NR2 $T=476780 407120 0 180 $X=474920 $Y=401700
X1404 203 2 2236 46 1 NR2 $T=477400 497840 1 0 $X=477400 $Y=492420
X1405 230 2 2276 2266 1 NR2 $T=483600 437360 0 180 $X=481740 $Y=431940
X1406 221 2 2267 51 1 NR2 $T=483600 497840 0 180 $X=481740 $Y=492420
X1407 70 2 2287 221 1 NR2 $T=485460 497840 1 180 $X=483600 $Y=497460
X1408 230 2 2310 2208 1 NR2 $T=490420 417200 1 180 $X=488560 $Y=416820
X1409 230 2 2305 2251 1 NR2 $T=491660 407120 1 180 $X=489800 $Y=406740
X1410 230 2 2323 2220 1 NR2 $T=492280 427280 1 180 $X=490420 $Y=426900
X1411 255 2 2439 54 1 NR2 $T=513980 467600 1 180 $X=512120 $Y=467220
X1412 2440 2 2448 55 1 NR2 $T=513980 477680 1 180 $X=512120 $Y=477300
X1413 255 2 2459 44 1 NR2 $T=515840 437360 1 180 $X=513980 $Y=436980
X1414 255 2 2447 48 1 NR2 $T=513980 467600 1 0 $X=513980 $Y=462180
X1415 255 2 2460 45 1 NR2 $T=517080 447440 0 180 $X=515220 $Y=442020
X1416 255 2 2461 192 1 NR2 $T=517080 457520 1 180 $X=515220 $Y=457140
X1417 255 2 2471 43 1 NR2 $T=515840 457520 1 0 $X=515840 $Y=452100
X1418 2440 2 2472 56 1 NR2 $T=517080 487760 1 0 $X=517080 $Y=482340
X1419 255 2 2485 62 1 NR2 $T=518320 467600 1 0 $X=518320 $Y=462180
X1420 255 2 2500 53 1 NR2 $T=518940 457520 0 0 $X=518940 $Y=457140
X1421 2440 2 2497 50 1 NR2 $T=518940 487760 0 0 $X=518940 $Y=487380
X1422 2440 2 2498 63 1 NR2 $T=518940 497840 1 0 $X=518940 $Y=492420
X1423 2440 2 2488 46 1 NR2 $T=519560 507920 1 0 $X=519560 $Y=502500
X1424 2440 2 2493 51 1 NR2 $T=519560 507920 0 0 $X=519560 $Y=507540
X1425 264 2 266 64 1 NR2 $T=520800 366800 1 0 $X=520800 $Y=361380
X1426 70 2 2516 2440 1 NR2 $T=525140 507920 1 180 $X=523280 $Y=507540
X1427 264 2 270 224 1 NR2 $T=524520 366800 1 0 $X=524520 $Y=361380
X1428 2509 2 2535 2470 1 NR2 $T=527620 407120 1 180 $X=525760 $Y=406740
X1429 278 2 277 264 1 NR2 $T=530720 366800 0 180 $X=528860 $Y=361380
X1430 281 2 2575 2541 1 NR2 $T=533200 417200 1 180 $X=531340 $Y=416820
X1431 281 2 2590 2576 1 NR2 $T=538160 417200 0 180 $X=536300 $Y=411780
X1432 281 2 2608 2567 1 NR2 $T=541880 447440 1 180 $X=540020 $Y=447060
X1433 2430 2 2774 2781 1 NR2 $T=564200 477680 0 0 $X=564200 $Y=477300
X1434 302 2 2831 54 1 NR2 $T=574740 467600 1 180 $X=572880 $Y=467220
X1435 302 2 2822 48 1 NR2 $T=575360 457520 1 180 $X=573500 $Y=457140
X1436 302 2 2828 55 1 NR2 $T=574740 477680 1 0 $X=574740 $Y=472260
X1437 302 2 2820 47 1 NR2 $T=575980 447440 1 0 $X=575980 $Y=442020
X1438 302 2 2841 44 1 NR2 $T=579700 437360 0 180 $X=577840 $Y=431940
X1439 302 2 2855 62 1 NR2 $T=580320 457520 0 180 $X=578460 $Y=452100
X1440 302 2 2868 56 1 NR2 $T=580940 477680 0 180 $X=579080 $Y=472260
X1441 302 2 2860 47 1 NR2 $T=582180 427280 1 180 $X=580320 $Y=426900
X1442 302 2 2861 50 1 NR2 $T=580320 477680 0 0 $X=580320 $Y=477300
X1443 302 2 2878 192 1 NR2 $T=581560 457520 0 0 $X=581560 $Y=457140
X1444 309 2 2880 46 1 NR2 $T=583420 497840 0 0 $X=583420 $Y=497460
X1445 302 2 2886 63 1 NR2 $T=584040 487760 1 0 $X=584040 $Y=482340
X1446 302 2 2897 43 1 NR2 $T=584660 447440 0 0 $X=584660 $Y=447060
X1447 309 2 2891 51 1 NR2 $T=585900 497840 0 0 $X=585900 $Y=497460
X1448 70 2 2911 309 1 NR2 $T=591480 497840 0 180 $X=589620 $Y=492420
X1449 325 2 2996 2956 1 NR2 $T=605120 427280 1 180 $X=603260 $Y=426900
X1450 2940 2 3000 3021 1 NR2 $T=605120 417200 0 0 $X=605120 $Y=416820
X1451 325 2 3033 2967 1 NR2 $T=610700 437360 1 180 $X=608840 $Y=436980
X1452 325 2 3051 3021 1 NR2 $T=613800 427280 1 180 $X=611940 $Y=426900
X1453 325 2 3066 2980 1 NR2 $T=613800 427280 1 0 $X=613800 $Y=421860
X1454 3154 2 3194 3211 1 NR2 $T=634260 457520 0 0 $X=634260 $Y=457140
X1455 3152 2 3247 3263 1 NR2 $T=640460 397040 1 0 $X=640460 $Y=391620
X1456 3525 2 3700 3475 1 NR2 $T=750200 427280 1 0 $X=750200 $Y=421860
X1457 3720 2 3725 411 1 NR2 $T=753920 427280 0 0 $X=753920 $Y=426900
X1458 3846 2 3883 3856 1 NR2 $T=791120 497840 1 0 $X=791120 $Y=492420
X1459 3902 2 3935 3887 1 NR2 $T=807860 507920 0 180 $X=806000 $Y=502500
X1460 4026 2 4035 4033 1 NR2 $T=828320 397040 0 0 $X=828320 $Y=396660
X1461 4029 2 4040 4020 1 NR2 $T=837000 497840 1 0 $X=837000 $Y=492420
X1462 4057 2 4059 4064 1 NR2 $T=837620 397040 0 0 $X=837620 $Y=396660
X1463 4084 2 4092 4086 1 NR2 $T=847540 497840 0 0 $X=847540 $Y=497460
X1464 4127 2 4118 4110 1 NR2 $T=856840 397040 1 180 $X=854980 $Y=396660
X1465 4141 2 4143 4148 1 NR2 $T=859940 397040 0 0 $X=859940 $Y=396660
X1466 4185 2 4196 4193 1 NR2 $T=871720 397040 0 0 $X=871720 $Y=396660
X1467 4005 2 4009 4213 1 NR2 $T=875440 447440 0 0 $X=875440 $Y=447060
X1468 712 2 4228 4224 1 NR2 $T=885360 497840 0 0 $X=885360 $Y=497460
X1469 4236 2 4256 4245 1 NR2 $T=890320 397040 0 0 $X=890320 $Y=396660
X1470 4250 2 4270 4241 1 NR2 $T=898380 457520 1 180 $X=896520 $Y=457140
X1471 4379 2 4343 4415 1 NR2 $T=924420 397040 0 0 $X=924420 $Y=396660
X1472 4380 2 4296 4391 1 NR2 $T=924420 427280 1 0 $X=924420 $Y=421860
X1473 776 2 4394 4381 1 NR2 $T=925040 507920 0 0 $X=925040 $Y=507540
X1474 4382 2 4308 4396 1 NR2 $T=925660 437360 1 0 $X=925660 $Y=431940
X1475 4400 2 4364 4422 1 NR2 $T=928760 386960 1 0 $X=928760 $Y=381540
X1476 4426 2 4377 4431 1 NR2 $T=935580 366800 1 0 $X=935580 $Y=361380
X1477 4463 2 4451 4468 1 NR2 $T=944260 437360 1 0 $X=944260 $Y=431940
X1478 4505 2 4502 4525 1 NR2 $T=957900 437360 1 0 $X=957900 $Y=431940
X1479 4512 2 4551 4506 1 NR2 $T=971540 497840 0 180 $X=969680 $Y=492420
X1480 4559 2 4528 4562 1 NR2 $T=970920 366800 0 0 $X=970920 $Y=366420
X1481 4550 2 4561 4567 1 NR2 $T=971540 386960 0 0 $X=971540 $Y=386580
X1482 4572 2 4570 4593 1 NR2 $T=977120 427280 0 0 $X=977120 $Y=426900
X1483 3517 2 3544 3500 3709 1 NR3 $T=752680 427280 1 0 $X=752680 $Y=421860
X1484 4260 2 4238 4254 4252 1 NR3 $T=894040 467600 0 180 $X=890940 $Y=462180
X1485 1223 1204 1 1207 1204 1193 2 MOAI1S $T=287060 417200 0 180 $X=283340 $Y=411780
X1486 2104 107 1 168 107 2069 2 MOAI1S $T=447640 397040 1 0 $X=447640 $Y=391620
X1487 3368 2846 1 389 2846 3239 2 MOAI1S $T=659060 386960 0 180 $X=655340 $Y=381540
X1488 4176 4009 1 4005 4178 4164 2 MOAI1S $T=871720 447440 1 180 $X=868000 $Y=447060
X1489 4230 683 1 379 683 4182 2 MOAI1S $T=885360 487760 1 180 $X=881640 $Y=487380
X1490 4815 785 1 4313 785 4809 2 MOAI1S $T=1058340 467600 1 0 $X=1058340 $Y=462180
X1491 976 1013 10 1 2 ND2 $T=240560 487760 0 180 $X=238700 $Y=482340
X1492 1015 1019 1002 1 2 ND2 $T=241180 447440 1 180 $X=239320 $Y=447060
X1493 987 1031 10 1 2 ND2 $T=241800 497840 0 180 $X=239940 $Y=492420
X1494 4 1088 6 1 2 ND2 $T=252960 407120 0 180 $X=251100 $Y=401700
X1495 1127 1137 34 1 2 ND2 $T=264740 507920 1 0 $X=264740 $Y=502500
X1496 1141 1138 1169 1 2 ND2 $T=267840 427280 1 0 $X=267840 $Y=421860
X1497 1167 1168 1156 1 2 ND2 $T=271560 397040 0 180 $X=269700 $Y=391620
X1498 1089 1171 1193 1 2 ND2 $T=271560 417200 1 0 $X=271560 $Y=411780
X1499 1185 1141 37 1 2 ND2 $T=273420 427280 0 0 $X=273420 $Y=426900
X1500 1189 1169 1178 1 2 ND2 $T=274040 437360 1 0 $X=274040 $Y=431940
X1501 1250 1255 1210 1 2 ND2 $T=293880 427280 0 180 $X=292020 $Y=421860
X1502 76 1266 77 1 2 ND2 $T=296980 507920 0 0 $X=296980 $Y=507540
X1503 1286 1299 1075 1 2 ND2 $T=303800 386960 1 180 $X=301940 $Y=386580
X1504 1358 1385 1046 1 2 ND2 $T=321780 397040 0 180 $X=319920 $Y=391620
X1505 1362 1377 1049 1 2 ND2 $T=322400 417200 0 180 $X=320540 $Y=411780
X1506 1464 1439 1237 1 2 ND2 $T=332940 397040 0 180 $X=331080 $Y=391620
X1507 1459 1449 1049 1 2 ND2 $T=332940 417200 1 180 $X=331080 $Y=416820
X1508 1452 1440 1436 1 2 ND2 $T=332940 437360 1 180 $X=331080 $Y=436980
X1509 1446 1456 1019 1 2 ND2 $T=333560 447440 0 0 $X=333560 $Y=447060
X1510 1470 1468 1009 1 2 ND2 $T=335420 487760 0 180 $X=333560 $Y=482340
X1511 1464 1433 1476 1 2 ND2 $T=334180 397040 1 0 $X=334180 $Y=391620
X1512 1461 1477 1436 1 2 ND2 $T=336660 437360 1 180 $X=334800 $Y=436980
X1513 1483 1482 1035 1 2 ND2 $T=337280 467600 1 180 $X=335420 $Y=467220
X1514 1493 1484 1051 1 2 ND2 $T=337280 497840 1 180 $X=335420 $Y=497460
X1515 1480 1488 1460 1 2 ND2 $T=336660 437360 1 0 $X=336660 $Y=431940
X1516 1237 1479 1476 1 2 ND2 $T=337280 386960 0 0 $X=337280 $Y=386580
X1517 1454 1487 981 1 2 ND2 $T=340380 427280 0 180 $X=338520 $Y=421860
X1518 1494 1501 1465 1 2 ND2 $T=339140 386960 1 0 $X=339140 $Y=381540
X1519 1514 1509 1506 1 2 ND2 $T=341620 447440 1 180 $X=339760 $Y=447060
X1520 1492 1472 988 1 2 ND2 $T=340380 437360 1 0 $X=340380 $Y=431940
X1521 1469 1515 1022 1 2 ND2 $T=341000 447440 1 0 $X=341000 $Y=442020
X1522 1495 1522 1481 1 2 ND2 $T=344100 457520 0 180 $X=342240 $Y=452100
X1523 1527 1538 1520 1 2 ND2 $T=344100 507920 0 180 $X=342240 $Y=502500
X1524 1536 1540 1490 1 2 ND2 $T=345340 487760 0 180 $X=343480 $Y=482340
X1525 1484 1527 1524 1 2 ND2 $T=343480 497840 0 0 $X=343480 $Y=497460
X1526 1537 1533 1528 1 2 ND2 $T=345960 447440 0 180 $X=344100 $Y=442020
X1527 1531 1544 1538 1 2 ND2 $T=347200 497840 1 180 $X=345340 $Y=497460
X1528 1560 1539 1574 1 2 ND2 $T=349680 407120 0 0 $X=349680 $Y=406740
X1529 1548 1565 1556 1 2 ND2 $T=352780 397040 1 180 $X=350920 $Y=396660
X1530 1511 1620 1220 1 2 ND2 $T=358360 376880 1 180 $X=356500 $Y=376500
X1531 1570 1615 1578 1 2 ND2 $T=358980 407120 1 180 $X=357120 $Y=406740
X1532 1593 1609 1591 1 2 ND2 $T=358980 417200 1 0 $X=358980 $Y=411780
X1533 1618 1634 1607 1 2 ND2 $T=359600 427280 1 0 $X=359600 $Y=421860
X1534 1630 1652 1511 1 2 ND2 $T=362700 376880 1 180 $X=360840 $Y=376500
X1535 1220 1642 1630 1 2 ND2 $T=364560 386960 0 180 $X=362700 $Y=381540
X1536 1646 1682 1671 1 2 ND2 $T=373860 447440 0 180 $X=372000 $Y=442020
X1537 1727 1663 11 1 2 ND2 $T=383780 427280 1 180 $X=381920 $Y=426900
X1538 1719 1677 1716 1 2 ND2 $T=383160 507920 1 0 $X=383160 $Y=502500
X1539 1738 1762 1752 1 2 ND2 $T=387500 397040 0 0 $X=387500 $Y=396660
X1540 1768 1773 1779 1 2 ND2 $T=390600 497840 1 0 $X=390600 $Y=492420
X1541 1720 1772 1775 1 2 ND2 $T=391220 397040 0 0 $X=391220 $Y=396660
X1542 1771 1806 1751 1 2 ND2 $T=398660 386960 0 180 $X=396800 $Y=381540
X1543 1760 1779 1689 1 2 ND2 $T=398660 507920 0 180 $X=396800 $Y=502500
X1544 1775 1799 1752 1 2 ND2 $T=398040 397040 0 0 $X=398040 $Y=396660
X1545 1800 1836 1808 1 2 ND2 $T=402380 407120 0 180 $X=400520 $Y=401700
X1546 1751 1867 1370 1 2 ND2 $T=404240 376880 1 180 $X=402380 $Y=376500
X1547 1771 1884 1370 1 2 ND2 $T=404240 386960 0 180 $X=402380 $Y=381540
X1548 139 1818 1839 1 2 ND2 $T=404240 507920 1 0 $X=404240 $Y=502500
X1549 1853 1856 1676 1 2 ND2 $T=406720 487760 0 180 $X=404860 $Y=482340
X1550 1654 1833 141 1 2 ND2 $T=406100 366800 0 0 $X=406100 $Y=366420
X1551 140 1829 1869 1 2 ND2 $T=407960 507920 0 180 $X=406100 $Y=502500
X1552 1915 1901 1898 1 2 ND2 $T=411680 497840 1 180 $X=409820 $Y=497460
X1553 1831 1928 1902 1 2 ND2 $T=412920 397040 1 180 $X=411060 $Y=396660
X1554 1945 1940 1929 1 2 ND2 $T=414160 427280 1 180 $X=412300 $Y=426900
X1555 146 1916 144 1 2 ND2 $T=414780 376880 0 180 $X=412920 $Y=371460
X1556 1933 1917 1899 1 2 ND2 $T=412920 386960 0 0 $X=412920 $Y=386580
X1557 1932 1941 1893 1 2 ND2 $T=415400 467600 1 180 $X=413540 $Y=467220
X1558 1952 1874 1955 1 2 ND2 $T=417260 477680 1 180 $X=415400 $Y=477300
X1559 1974 1958 1855 1 2 ND2 $T=417880 427280 0 180 $X=416020 $Y=421860
X1560 1874 1973 1914 1 2 ND2 $T=416640 467600 0 0 $X=416640 $Y=467220
X1561 1952 1964 1866 1 2 ND2 $T=417880 477680 1 0 $X=417880 $Y=472260
X1562 1924 1983 1957 1 2 ND2 $T=420360 457520 1 180 $X=418500 $Y=457140
X1563 1969 1988 1899 1 2 ND2 $T=422220 376880 1 180 $X=420360 $Y=376500
X1564 1558 1991 1985 1 2 ND2 $T=422220 477680 0 0 $X=422220 $Y=477300
X1565 1972 2010 1980 1 2 ND2 $T=424700 437360 1 180 $X=422840 $Y=436980
X1566 1903 2014 1947 1 2 ND2 $T=425320 427280 0 180 $X=423460 $Y=421860
X1567 2001 2027 1992 1 2 ND2 $T=425940 397040 1 0 $X=425940 $Y=391620
X1568 149 1994 152 1 2 ND2 $T=426560 366800 1 0 $X=426560 $Y=361380
X1569 2025 2021 2008 1 2 ND2 $T=426560 417200 1 0 $X=426560 $Y=411780
X1570 1568 2042 1987 1 2 ND2 $T=429040 427280 1 180 $X=427180 $Y=426900
X1571 2023 2044 1941 1 2 ND2 $T=429040 477680 0 180 $X=427180 $Y=472260
X1572 2037 2039 1895 1 2 ND2 $T=429040 497840 1 0 $X=429040 $Y=492420
X1573 2049 2053 2054 1 2 ND2 $T=429660 447440 0 0 $X=429660 $Y=447060
X1574 2046 2049 2062 1 2 ND2 $T=430280 437360 0 0 $X=430280 $Y=436980
X1575 153 2072 1773 1 2 ND2 $T=435240 497840 1 180 $X=433380 $Y=497460
X1576 2043 2078 2082 1 2 ND2 $T=434000 427280 0 0 $X=434000 $Y=426900
X1577 1961 2051 2065 1 2 ND2 $T=434000 507920 1 0 $X=434000 $Y=502500
X1578 2090 2070 2041 1 2 ND2 $T=437100 457520 0 180 $X=435240 $Y=452100
X1579 2100 2089 2024 1 2 ND2 $T=437720 487760 1 180 $X=435860 $Y=487380
X1580 2096 2061 1981 1 2 ND2 $T=437100 457520 0 0 $X=437100 $Y=457140
X1581 2084 2129 1562 1 2 ND2 $T=440200 417200 0 180 $X=438340 $Y=411780
X1582 2062 2119 2054 1 2 ND2 $T=442680 447440 0 180 $X=440820 $Y=442020
X1583 1998 2145 2117 1 2 ND2 $T=446400 407120 0 180 $X=444540 $Y=401700
X1584 1530 2141 2117 1 2 ND2 $T=446400 407120 1 180 $X=444540 $Y=406740
X1585 2084 2125 2143 1 2 ND2 $T=444540 417200 1 0 $X=444540 $Y=411780
X1586 1998 2154 1530 1 2 ND2 $T=451980 407120 0 180 $X=450120 $Y=401700
X1587 2143 2134 1562 1 2 ND2 $T=450120 417200 1 0 $X=450120 $Y=411780
X1588 2250 2245 2186 1 2 ND2 $T=478640 427280 0 180 $X=476780 $Y=421860
X1589 2238 2268 2239 1 2 ND2 $T=481120 376880 0 0 $X=481120 $Y=376500
X1590 2295 2303 2291 1 2 ND2 $T=487940 427280 0 180 $X=486080 $Y=421860
X1591 2264 2295 242 1 2 ND2 $T=491660 427280 1 0 $X=491660 $Y=421860
X1592 2312 2329 2239 1 2 ND2 $T=494760 397040 1 180 $X=492900 $Y=396660
X1593 2329 2349 2336 1 2 ND2 $T=497860 397040 1 180 $X=496000 $Y=396660
X1594 2342 2370 2271 1 2 ND2 $T=500960 386960 1 180 $X=499100 $Y=386580
X1595 2339 2336 2271 1 2 ND2 $T=500340 397040 0 0 $X=500340 $Y=396660
X1596 2350 2399 2271 1 2 ND2 $T=506540 376880 1 180 $X=504680 $Y=376500
X1597 2327 2381 241 1 2 ND2 $T=506540 386960 1 180 $X=504680 $Y=386580
X1598 2256 2414 2411 1 2 ND2 $T=506540 407120 1 0 $X=506540 $Y=401700
X1599 2256 2419 2426 1 2 ND2 $T=509020 407120 1 0 $X=509020 $Y=401700
X1600 2345 2418 251 1 2 ND2 $T=510880 487760 0 180 $X=509020 $Y=482340
X1601 2425 2413 241 1 2 ND2 $T=510260 376880 0 0 $X=510260 $Y=376500
X1602 2453 2442 2301 1 2 ND2 $T=513980 376880 1 180 $X=512120 $Y=376500
X1603 2284 2429 2435 1 2 ND2 $T=512120 417200 0 0 $X=512120 $Y=416820
X1604 2417 2423 233 1 2 ND2 $T=514600 487760 0 180 $X=512740 $Y=482340
X1605 2422 2449 2301 1 2 ND2 $T=515840 376880 0 180 $X=513980 $Y=371460
X1606 2411 2433 2426 1 2 ND2 $T=513980 407120 1 0 $X=513980 $Y=401700
X1607 2441 2455 259 1 2 ND2 $T=514600 427280 0 0 $X=514600 $Y=426900
X1608 2422 2468 2453 1 2 ND2 $T=518940 376880 1 180 $X=517080 $Y=376500
X1609 2455 2466 2473 1 2 ND2 $T=517700 427280 0 0 $X=517700 $Y=426900
X1610 2469 2435 2495 1 2 ND2 $T=518320 407120 0 0 $X=518320 $Y=406740
X1611 2476 2391 2494 1 2 ND2 $T=519560 397040 0 0 $X=519560 $Y=396660
X1612 2466 2502 265 1 2 ND2 $T=523280 427280 1 180 $X=521420 $Y=426900
X1613 2506 2476 2480 1 2 ND2 $T=524520 397040 1 180 $X=522660 $Y=396660
X1614 2505 2490 2511 1 2 ND2 $T=523900 397040 1 0 $X=523900 $Y=391620
X1615 2509 2450 2511 1 2 ND2 $T=524520 407120 1 0 $X=524520 $Y=401700
X1616 2520 2531 265 1 2 ND2 $T=527000 437360 0 0 $X=527000 $Y=436980
X1617 2585 2526 282 1 2 ND2 $T=536300 427280 1 0 $X=536300 $Y=421860
X1618 2609 2558 2618 1 2 ND2 $T=540640 386960 1 0 $X=540640 $Y=381540
X1619 2645 2644 2602 1 2 ND2 $T=545600 397040 1 180 $X=543740 $Y=396660
X1620 2601 2642 2410 1 2 ND2 $T=546220 386960 0 180 $X=544360 $Y=381540
X1621 2695 2692 2681 1 2 ND2 $T=551180 427280 1 180 $X=549320 $Y=426900
X1622 2698 2677 2690 1 2 ND2 $T=552420 386960 1 180 $X=550560 $Y=386580
X1623 2709 2703 2696 1 2 ND2 $T=553040 487760 0 180 $X=551180 $Y=482340
X1624 2672 2709 288 1 2 ND2 $T=556760 487760 0 180 $X=554900 $Y=482340
X1625 2717 2718 2436 1 2 ND2 $T=557380 487760 1 180 $X=555520 $Y=487380
X1626 2664 2678 2691 1 2 ND2 $T=558620 407120 0 180 $X=556760 $Y=401700
X1627 2724 2723 2430 1 2 ND2 $T=559240 477680 1 180 $X=557380 $Y=477300
X1628 2712 2738 2720 1 2 ND2 $T=560480 427280 1 180 $X=558620 $Y=426900
X1629 2735 2736 2722 1 2 ND2 $T=560480 457520 0 180 $X=558620 $Y=452100
X1630 2745 2739 2751 1 2 ND2 $T=561100 417200 1 0 $X=561100 $Y=411780
X1631 2721 2758 2752 1 2 ND2 $T=561100 447440 1 0 $X=561100 $Y=442020
X1632 2703 2761 2428 1 2 ND2 $T=562960 497840 1 0 $X=562960 $Y=492420
X1633 2443 2794 2752 1 2 ND2 $T=568540 447440 1 0 $X=568540 $Y=442020
X1634 2764 2813 2815 1 2 ND2 $T=570400 487760 0 0 $X=570400 $Y=487380
X1635 2787 2821 2835 1 2 ND2 $T=575980 407120 0 0 $X=575980 $Y=406740
X1636 2452 2805 2727 1 2 ND2 $T=577220 497840 0 0 $X=577220 $Y=497460
X1637 2851 2850 2843 1 2 ND2 $T=580320 397040 1 180 $X=578460 $Y=396660
X1638 2600 2854 2857 1 2 ND2 $T=579080 376880 1 0 $X=579080 $Y=371460
X1639 2921 2918 2930 1 2 ND2 $T=592100 386960 0 0 $X=592100 $Y=386580
X1640 2830 2945 323 1 2 ND2 $T=592720 437360 0 0 $X=592720 $Y=436980
X1641 2973 2967 326 1 2 ND2 $T=600780 437360 0 180 $X=598920 $Y=431940
X1642 2964 2948 2992 1 2 ND2 $T=599540 497840 1 0 $X=599540 $Y=492420
X1643 2966 2889 2975 1 2 ND2 $T=600160 397040 1 0 $X=600160 $Y=391620
X1644 2961 3017 335 1 2 ND2 $T=605740 437360 1 0 $X=605740 $Y=431940
X1645 2958 3006 2875 1 2 ND2 $T=608220 376880 0 180 $X=606360 $Y=371460
X1646 2997 3032 2756 1 2 ND2 $T=608840 386960 0 180 $X=606980 $Y=381540
X1647 3009 2940 334 1 2 ND2 $T=607600 427280 1 0 $X=607600 $Y=421860
X1648 341 343 344 1 2 ND2 $T=610700 507920 0 0 $X=610700 $Y=507540
X1649 347 3059 351 1 2 ND2 $T=614420 366800 0 0 $X=614420 $Y=366420
X1650 354 3038 351 1 2 ND2 $T=617520 366800 1 0 $X=617520 $Y=361380
X1651 3078 3089 3069 1 2 ND2 $T=621860 497840 0 180 $X=620000 $Y=492420
X1652 3128 3131 3138 1 2 ND2 $T=624960 467600 0 0 $X=624960 $Y=467220
X1653 3129 3133 3139 1 2 ND2 $T=624960 487760 0 0 $X=624960 $Y=487380
X1654 3149 3144 3121 1 2 ND2 $T=628680 467600 1 180 $X=626820 $Y=467220
X1655 3112 3129 3156 1 2 ND2 $T=627440 477680 0 0 $X=627440 $Y=477300
X1656 3157 3166 3095 1 2 ND2 $T=628680 487760 0 0 $X=628680 $Y=487380
X1657 3169 3159 3154 1 2 ND2 $T=631160 457520 1 180 $X=629300 $Y=457140
X1658 3114 3176 3139 1 2 ND2 $T=633640 487760 1 0 $X=633640 $Y=482340
X1659 3179 3197 3134 1 2 ND2 $T=636120 397040 0 180 $X=634260 $Y=391620
X1660 3100 3213 3134 1 2 ND2 $T=637980 386960 1 180 $X=636120 $Y=386580
X1661 3100 3221 3179 1 2 ND2 $T=637360 386960 1 0 $X=637360 $Y=381540
X1662 3211 3155 3203 1 2 ND2 $T=637360 467600 1 0 $X=637360 $Y=462180
X1663 3236 3235 3224 1 2 ND2 $T=639840 407120 1 180 $X=637980 $Y=406740
X1664 3239 3234 3152 1 2 ND2 $T=640460 397040 0 180 $X=638600 $Y=391620
X1665 3240 3241 3231 1 2 ND2 $T=640460 407120 0 180 $X=638600 $Y=401700
X1666 3228 3238 3137 1 2 ND2 $T=641080 417200 1 0 $X=641080 $Y=411780
X1667 3225 3283 3271 1 2 ND2 $T=641080 457520 1 0 $X=641080 $Y=452100
X1668 3257 3236 3265 1 2 ND2 $T=641700 407120 0 0 $X=641700 $Y=406740
X1669 3258 3261 3267 1 2 ND2 $T=641700 467600 1 0 $X=641700 $Y=462180
X1670 3263 3240 3202 1 2 ND2 $T=642320 397040 1 0 $X=642320 $Y=391620
X1671 3133 3243 3277 1 2 ND2 $T=642320 487760 0 0 $X=642320 $Y=487380
X1672 3255 3298 3191 1 2 ND2 $T=644800 427280 1 180 $X=642940 $Y=426900
X1673 3291 3281 3245 1 2 ND2 $T=644800 457520 1 180 $X=642940 $Y=457140
X1674 3284 3286 3214 1 2 ND2 $T=645420 407120 0 180 $X=643560 $Y=401700
X1675 3275 3260 3297 1 2 ND2 $T=643560 427280 1 0 $X=643560 $Y=421860
X1676 3299 3257 3280 1 2 ND2 $T=646660 407120 1 180 $X=644800 $Y=406740
X1677 3191 3288 3182 1 2 ND2 $T=644800 437360 1 0 $X=644800 $Y=431940
X1678 3253 3302 3230 1 2 ND2 $T=647280 467600 1 180 $X=645420 $Y=467220
X1679 3255 3324 3182 1 2 ND2 $T=647900 427280 0 0 $X=647900 $Y=426900
X1680 3293 3315 3297 1 2 ND2 $T=650380 417200 1 180 $X=648520 $Y=416820
X1681 3245 3301 3271 1 2 ND2 $T=648520 457520 0 0 $X=648520 $Y=457140
X1682 3314 3253 3116 1 2 ND2 $T=648520 467600 1 0 $X=648520 $Y=462180
X1683 3316 3335 3223 1 2 ND2 $T=651620 397040 0 180 $X=649760 $Y=391620
X1684 3315 3305 3327 1 2 ND2 $T=649760 417200 1 0 $X=649760 $Y=411780
X1685 3090 3331 3118 1 2 ND2 $T=652240 376880 1 180 $X=650380 $Y=376500
X1686 3303 3323 3278 1 2 ND2 $T=652240 477680 1 180 $X=650380 $Y=477300
X1687 3329 3304 3323 1 2 ND2 $T=652240 487760 0 180 $X=650380 $Y=482340
X1688 390 3318 388 1 2 ND2 $T=655340 366800 1 180 $X=653480 $Y=366420
X1689 3356 3299 3137 1 2 ND2 $T=655960 407120 1 180 $X=654100 $Y=406740
X1690 390 3330 3351 1 2 ND2 $T=657200 366800 0 0 $X=657200 $Y=366420
X1691 3334 3364 3336 1 2 ND2 $T=659060 447440 1 180 $X=657200 $Y=447060
X1692 2834 3354 3347 1 2 ND2 $T=657200 457520 1 0 $X=657200 $Y=452100
X1693 3369 3353 3357 1 2 ND2 $T=659680 407120 0 180 $X=657820 $Y=401700
X1694 3216 3369 3284 1 2 ND2 $T=659680 407120 1 180 $X=657820 $Y=406740
X1695 2839 3370 3261 1 2 ND2 $T=661540 477680 1 180 $X=659680 $Y=477300
X1696 3343 3374 3180 1 2 ND2 $T=663400 386960 0 180 $X=661540 $Y=381540
X1697 3363 3397 2744 1 2 ND2 $T=664020 397040 1 180 $X=662160 $Y=396660
X1698 2798 3389 3395 1 2 ND2 $T=665260 417200 0 0 $X=665260 $Y=416820
X1699 2744 3407 3353 1 2 ND2 $T=668980 407120 1 180 $X=667120 $Y=406740
X1700 3353 3417 3363 1 2 ND2 $T=667740 407120 1 0 $X=667740 $Y=401700
X1701 3343 3371 2734 1 2 ND2 $T=670220 386960 0 180 $X=668360 $Y=381540
X1702 428 3487 450 1 2 ND2 $T=695640 497840 0 0 $X=695640 $Y=497460
X1703 3454 3496 450 1 2 ND2 $T=697500 467600 1 0 $X=697500 $Y=462180
X1704 3440 3532 450 1 2 ND2 $T=702460 467600 1 180 $X=700600 $Y=467220
X1705 427 3524 450 1 2 ND2 $T=702460 487760 1 180 $X=700600 $Y=487380
X1706 3516 3507 460 1 2 ND2 $T=700600 497840 0 0 $X=700600 $Y=497460
X1707 3467 3535 450 1 2 ND2 $T=703080 477680 0 180 $X=701220 $Y=472260
X1708 3513 3538 450 1 2 ND2 $T=701840 447440 0 0 $X=701840 $Y=447060
X1709 3501 3543 450 1 2 ND2 $T=702460 437360 0 0 $X=702460 $Y=436980
X1710 3529 3528 460 1 2 ND2 $T=703080 487760 1 0 $X=703080 $Y=482340
X1711 3531 3521 460 1 2 ND2 $T=704940 497840 0 180 $X=703080 $Y=492420
X1712 3551 3552 460 1 2 ND2 $T=706800 477680 1 180 $X=704940 $Y=477300
X1713 3548 3539 460 1 2 ND2 $T=706800 487760 0 180 $X=704940 $Y=482340
X1714 3509 3558 450 1 2 ND2 $T=707420 447440 0 180 $X=705560 $Y=442020
X1715 3559 3549 460 1 2 ND2 $T=708660 467600 0 0 $X=708660 $Y=467220
X1716 3572 3583 3571 1 2 ND2 $T=716100 457520 1 180 $X=714240 $Y=457140
X1717 3585 3578 3572 1 2 ND2 $T=716100 447440 0 0 $X=716100 $Y=447060
X1718 3602 3596 3572 1 2 ND2 $T=719200 437360 0 0 $X=719200 $Y=436980
X1719 3575 3581 3572 1 2 ND2 $T=720440 447440 0 0 $X=720440 $Y=447060
X1720 3635 3662 513 1 2 ND2 $T=737180 407120 1 180 $X=735320 $Y=406740
X1721 3592 3658 513 1 2 ND2 $T=737180 417200 0 180 $X=735320 $Y=411780
X1722 513 3674 3670 1 2 ND2 $T=742140 407120 1 180 $X=740280 $Y=406740
X1723 3732 3723 3739 1 2 ND2 $T=757640 477680 0 0 $X=757640 $Y=477300
X1724 562 3729 3739 1 2 ND2 $T=761980 477680 0 0 $X=761980 $Y=477300
X1725 3708 3764 3722 1 2 ND2 $T=763220 497840 1 0 $X=763220 $Y=492420
X1726 564 3784 3755 1 2 ND2 $T=767560 427280 0 0 $X=767560 $Y=426900
X1727 3780 3769 3778 1 2 ND2 $T=768800 477680 0 0 $X=768800 $Y=477300
X1728 3737 3774 3779 1 2 ND2 $T=768800 497840 1 0 $X=768800 $Y=492420
X1729 3788 3800 3813 1 2 ND2 $T=774380 497840 1 0 $X=774380 $Y=492420
X1730 3801 3794 581 1 2 ND2 $T=774380 507920 1 0 $X=774380 $Y=502500
X1731 3805 3807 3755 1 2 ND2 $T=776860 437360 0 0 $X=776860 $Y=436980
X1732 3806 3802 3572 1 2 ND2 $T=779340 437360 1 0 $X=779340 $Y=431940
X1733 585 3829 3755 1 2 ND2 $T=782440 437360 1 180 $X=780580 $Y=436980
X1734 3826 3828 3846 1 2 ND2 $T=783680 487760 0 0 $X=783680 $Y=487380
X1735 3868 3831 3842 1 2 ND2 $T=785540 497840 0 180 $X=783680 $Y=492420
X1736 3799 3865 3755 1 2 ND2 $T=784920 437360 1 0 $X=784920 $Y=431940
X1737 3828 3869 3868 1 2 ND2 $T=786780 487760 0 0 $X=786780 $Y=487380
X1738 3687 3835 3755 1 2 ND2 $T=788020 447440 1 0 $X=788020 $Y=442020
X1739 3841 3822 3851 1 2 ND2 $T=788020 477680 0 0 $X=788020 $Y=477300
X1740 3877 3845 3572 1 2 ND2 $T=792360 447440 1 0 $X=792360 $Y=442020
X1741 3870 3893 3902 1 2 ND2 $T=794220 497840 1 0 $X=794220 $Y=492420
X1742 3863 3907 3755 1 2 ND2 $T=794840 427280 0 0 $X=794840 $Y=426900
X1743 3890 3919 3755 1 2 ND2 $T=797320 437360 0 180 $X=795460 $Y=431940
X1744 3899 3873 3916 1 2 ND2 $T=796080 487760 1 0 $X=796080 $Y=482340
X1745 3758 3925 3755 1 2 ND2 $T=799800 437360 1 180 $X=797940 $Y=436980
X1746 3730 3931 3755 1 2 ND2 $T=801040 427280 0 180 $X=799180 $Y=421860
X1747 3923 3934 3755 1 2 ND2 $T=801040 427280 1 180 $X=799180 $Y=426900
X1748 3944 3909 3572 1 2 ND2 $T=807860 437360 0 0 $X=807860 $Y=436980
X1749 3930 3949 3951 1 2 ND2 $T=807860 507920 1 0 $X=807860 $Y=502500
X1750 3958 3954 3572 1 2 ND2 $T=810960 437360 1 0 $X=810960 $Y=431940
X1751 3969 3950 3953 1 2 ND2 $T=814060 487760 0 180 $X=812200 $Y=482340
X1752 3982 3940 3572 1 2 ND2 $T=815300 437360 1 180 $X=813440 $Y=436980
X1753 3979 3974 3572 1 2 ND2 $T=816540 427280 1 0 $X=816540 $Y=421860
X1754 3980 3888 3572 1 2 ND2 $T=816540 437360 1 0 $X=816540 $Y=431940
X1755 3983 3977 3572 1 2 ND2 $T=817160 427280 0 0 $X=817160 $Y=426900
X1756 3985 3956 3960 1 2 ND2 $T=819020 497840 1 180 $X=817160 $Y=497460
X1757 4002 3834 3572 1 2 ND2 $T=823980 437360 0 180 $X=822120 $Y=431940
X1758 4014 3988 3572 1 2 ND2 $T=825840 427280 1 180 $X=823980 $Y=426900
X1759 4007 4012 4013 1 2 ND2 $T=823980 497840 0 0 $X=823980 $Y=497460
X1760 4019 4018 4011 1 2 ND2 $T=827080 487760 1 180 $X=825220 $Y=487380
X1761 4012 4011 4034 1 2 ND2 $T=828940 497840 1 0 $X=828940 $Y=492420
X1762 4103 4073 4084 1 2 ND2 $T=851260 497840 1 180 $X=849400 $Y=497460
X1763 4073 4109 4090 1 2 ND2 $T=853740 507920 0 180 $X=851880 $Y=502500
X1764 4131 4126 4120 1 2 ND2 $T=857460 497840 1 180 $X=855600 $Y=497460
X1765 680 4139 4128 1 2 ND2 $T=859320 487760 0 180 $X=857460 $Y=482340
X1766 690 4151 692 1 2 ND2 $T=865520 507920 0 0 $X=865520 $Y=507540
X1767 680 4168 4182 1 2 ND2 $T=869240 487760 1 0 $X=869240 $Y=482340
X1768 4225 4214 712 1 2 ND2 $T=884120 507920 0 0 $X=884120 $Y=507540
X1769 4253 4255 4243 1 2 ND2 $T=891560 507920 1 180 $X=889700 $Y=507540
X1770 752 4340 4315 1 2 ND2 $T=914500 497840 1 0 $X=914500 $Y=492420
X1771 4338 769 763 1 2 ND2 $T=915120 507920 0 0 $X=915120 $Y=507540
X1772 4338 766 772 1 2 ND2 $T=918840 507920 1 0 $X=918840 $Y=502500
X1773 4366 4361 4359 1 2 ND2 $T=921940 487760 1 180 $X=920080 $Y=487380
X1774 4360 4362 4329 1 2 ND2 $T=920080 497840 1 0 $X=920080 $Y=492420
X1775 4374 4372 4329 1 2 ND2 $T=923800 497840 0 180 $X=921940 $Y=492420
X1776 4398 4375 4354 1 2 ND2 $T=928760 487760 0 180 $X=926900 $Y=482340
X1777 4402 781 4367 1 2 ND2 $T=929380 507920 0 180 $X=927520 $Y=502500
X1778 4419 787 4402 1 2 ND2 $T=931860 507920 1 0 $X=931860 $Y=502500
X1779 4372 4418 4401 1 2 ND2 $T=932480 497840 0 0 $X=932480 $Y=497460
X1780 4459 4460 4445 1 2 ND2 $T=944260 497840 0 180 $X=942400 $Y=492420
X1781 802 4471 4465 1 2 ND2 $T=950460 487760 0 0 $X=950460 $Y=487380
X1782 4501 4497 4507 1 2 ND2 $T=956660 497840 0 0 $X=956660 $Y=497460
X1783 4503 4504 4515 1 2 ND2 $T=957280 477680 0 0 $X=957280 $Y=477300
X1784 4500 4514 4512 1 2 ND2 $T=960380 497840 1 180 $X=958520 $Y=497460
X1785 4517 4527 4535 1 2 ND2 $T=962240 507920 1 0 $X=962240 $Y=502500
X1786 4506 4501 4532 1 2 ND2 $T=963480 497840 0 0 $X=963480 $Y=497460
X1787 4590 4589 4588 1 2 ND2 $T=978980 487760 0 180 $X=977120 $Y=482340
X1788 4596 4594 4573 1 2 ND2 $T=979600 467600 1 180 $X=977740 $Y=467220
X1789 4616 4605 4621 1 2 ND2 $T=988280 487760 1 0 $X=988280 $Y=482340
X1790 4626 4617 4612 1 2 ND2 $T=992000 477680 0 180 $X=990140 $Y=472260
X1791 4655 4641 4663 1 2 ND2 $T=1001300 467600 1 0 $X=1001300 $Y=462180
X1792 4655 4632 4649 1 2 ND2 $T=1003780 477680 0 180 $X=1001920 $Y=472260
X1793 4639 4662 4667 1 2 ND2 $T=1006260 487760 0 0 $X=1006260 $Y=487380
X1794 854 4675 4677 1 2 ND2 $T=1012460 477680 0 0 $X=1012460 $Y=477300
X1795 848 4703 4669 1 2 ND2 $T=1014940 497840 0 180 $X=1013080 $Y=492420
X1796 4713 4688 4677 1 2 ND2 $T=1016180 477680 1 180 $X=1014320 $Y=477300
X1797 4705 4714 4669 1 2 ND2 $T=1019900 497840 0 180 $X=1018040 $Y=492420
X1798 4713 4678 854 1 2 ND2 $T=1020520 477680 1 180 $X=1018660 $Y=477300
X1799 4705 4725 848 1 2 ND2 $T=1020520 497840 1 0 $X=1020520 $Y=492420
X1800 4726 4719 4691 1 2 ND2 $T=1022380 497840 1 180 $X=1020520 $Y=497460
X1801 861 4763 4729 1 2 ND2 $T=1027960 507920 0 180 $X=1026100 $Y=502500
X1802 4766 4758 861 1 2 ND2 $T=1031680 497840 1 180 $X=1029820 $Y=497460
X1803 4766 4773 4729 1 2 ND2 $T=1035400 497840 1 180 $X=1033540 $Y=497460
X1804 4788 4784 4785 1 2 ND2 $T=1042840 497840 0 180 $X=1040980 $Y=492420
X1805 4796 4790 879 1 2 ND2 $T=1050280 487760 1 0 $X=1050280 $Y=482340
X1806 4824 4808 4809 1 2 ND2 $T=1054000 477680 0 180 $X=1052140 $Y=472260
X1807 4819 4820 4816 1 2 ND2 $T=1054620 497840 0 180 $X=1052760 $Y=492420
X1808 4824 4821 874 1 2 ND2 $T=1057720 477680 0 0 $X=1057720 $Y=477300
X1809 4825 4841 4823 1 2 ND2 $T=1062680 497840 1 180 $X=1060820 $Y=497460
X1810 887 4842 4823 1 2 ND2 $T=1063300 507920 0 180 $X=1061440 $Y=502500
X1811 4825 4849 887 1 2 ND2 $T=1071360 507920 0 180 $X=1069500 $Y=502500
X1812 4855 4861 4795 1 2 ND2 $T=1070740 487760 0 0 $X=1070740 $Y=487380
X1813 4864 4846 4866 1 2 ND2 $T=1071980 497840 1 0 $X=1071980 $Y=492420
X1814 4872 4871 893 1 2 ND2 $T=1075700 497840 0 180 $X=1073840 $Y=492420
X1815 4855 4848 4876 1 2 ND2 $T=1076320 487760 1 0 $X=1076320 $Y=482340
X1816 4876 4844 4795 1 2 ND2 $T=1083760 487760 1 0 $X=1083760 $Y=482340
X1817 478 473 472 1 2 3563 AO12 $T=714240 507920 0 180 $X=710520 $Y=502500
X1818 478 3587 472 1 2 3577 AO12 $T=716720 497840 1 180 $X=713000 $Y=497460
X1819 478 3606 472 1 2 3595 AO12 $T=721060 487760 0 180 $X=717340 $Y=482340
X1820 478 3605 472 1 2 3611 AO12 $T=717960 457520 0 0 $X=717960 $Y=457140
X1821 478 3608 472 1 2 3593 AO12 $T=721680 487760 1 180 $X=717960 $Y=487380
X1822 478 3618 472 1 2 3613 AO12 $T=725400 457520 1 180 $X=721680 $Y=457140
X1823 478 3621 472 1 2 3617 AO12 $T=726640 447440 1 180 $X=722920 $Y=447060
X1824 478 3601 472 1 2 3604 AO12 $T=726640 477680 0 180 $X=722920 $Y=472260
X1825 478 3622 472 1 2 3631 AO12 $T=724160 447440 1 0 $X=724160 $Y=442020
X1826 478 3627 472 1 2 3620 AO12 $T=728500 467600 0 180 $X=724780 $Y=462180
X1827 4009 4008 4005 1 2 3991 AO12 $T=826460 457520 0 180 $X=822740 $Y=452100
X1828 4009 4015 4005 1 2 4024 AO12 $T=824600 447440 1 0 $X=824600 $Y=442020
X1829 4009 4031 4005 1 2 4043 AO12 $T=828320 457520 1 0 $X=828320 $Y=452100
X1830 4009 4042 4005 1 2 4000 AO12 $T=834520 447440 0 180 $X=830800 $Y=442020
X1831 4009 4051 4005 1 2 4072 AO12 $T=836380 447440 1 0 $X=836380 $Y=442020
X1832 4009 4076 4005 1 2 4089 AO12 $T=841340 447440 0 0 $X=841340 $Y=447060
X1833 4009 4096 4005 1 2 4115 AO12 $T=848160 447440 0 0 $X=848160 $Y=447060
X1834 4009 4124 4005 1 2 4107 AO12 $T=857460 447440 0 180 $X=853740 $Y=442020
X1835 4009 4150 4005 1 2 4069 AO12 $T=863660 447440 0 180 $X=859940 $Y=442020
X1836 4009 4175 4005 1 2 4144 AO12 $T=869860 447440 0 180 $X=866140 $Y=442020
X1837 1017 1044 8 2 1 ND2S $T=245520 497840 1 0 $X=245520 $Y=492420
X1838 1138 1079 30 2 1 ND2S $T=264740 427280 0 180 $X=262880 $Y=421860
X1839 1175 1162 1152 2 1 ND2S $T=271560 366800 1 180 $X=269700 $Y=366420
X1840 65 61 40 2 1 ND2S $T=290160 507920 0 0 $X=290160 $Y=507540
X1841 1251 1268 1082 2 1 ND2S $T=300700 386960 1 0 $X=300700 $Y=381540
X1842 1354 1353 1361 2 1 ND2S $T=316820 376880 1 0 $X=316820 $Y=371460
X1843 1456 1452 1461 2 1 ND2S $T=332940 437360 0 0 $X=332940 $Y=436980
X1844 1504 1505 1480 2 1 ND2S $T=340380 437360 0 180 $X=338520 $Y=431940
X1845 1515 1514 1495 2 1 ND2S $T=340380 457520 1 0 $X=340380 $Y=452100
X1846 1554 1571 1513 2 1 ND2S $T=351540 437360 1 180 $X=349680 $Y=436980
X1847 1797 1777 1807 2 1 ND2S $T=396180 507920 0 0 $X=396180 $Y=507540
X1848 1818 1791 1829 2 1 ND2S $T=399280 507920 0 0 $X=399280 $Y=507540
X1849 1876 1888 1874 2 1 ND2S $T=409200 467600 1 180 $X=407340 $Y=467220
X1850 1956 1918 1857 2 1 ND2S $T=416020 487760 1 180 $X=414160 $Y=487380
X1851 1962 1933 1431 2 1 ND2S $T=416640 386960 1 180 $X=414780 $Y=386580
X1852 1958 1942 1929 2 1 ND2S $T=416020 427280 0 0 $X=416020 $Y=426900
X1853 2047 2046 1904 2 1 ND2S $T=430280 437360 1 180 $X=428420 $Y=436980
X1854 2008 2033 2069 2 1 ND2S $T=432760 417200 1 0 $X=432760 $Y=411780
X1855 2093 2059 2081 2 1 ND2S $T=434000 447440 1 0 $X=434000 $Y=442020
X1856 2083 2079 1850 2 1 ND2S $T=435860 487760 1 180 $X=434000 $Y=487380
X1857 2094 2099 1904 2 1 ND2S $T=438340 447440 1 180 $X=436480 $Y=447060
X1858 2086 2095 1850 2 1 ND2S $T=438340 497840 1 0 $X=438340 $Y=492420
X1859 2155 2102 1911 2 1 ND2S $T=455700 437360 0 180 $X=453840 $Y=431940
X1860 135 2164 168 2 1 ND2S $T=456940 397040 1 180 $X=455080 $Y=396660
X1861 2184 2186 205 2 1 ND2S $T=467480 427280 0 0 $X=467480 $Y=426900
X1862 2187 2185 2195 2 1 ND2S $T=468100 437360 1 0 $X=468100 $Y=431940
X1863 2201 2250 2254 2 1 ND2S $T=478640 427280 1 0 $X=478640 $Y=421860
X1864 2302 2291 230 2 1 ND2S $T=489800 427280 1 0 $X=489800 $Y=421860
X1865 2335 2304 2338 2 1 ND2S $T=492900 366800 0 0 $X=492900 $Y=366420
X1866 2471 2479 261 2 1 ND2S $T=519560 447440 1 180 $X=517700 $Y=447060
X1867 2431 2473 260 2 1 ND2S $T=519560 427280 0 0 $X=519560 $Y=426900
X1868 2441 2499 260 2 1 ND2S $T=521420 437360 0 0 $X=521420 $Y=436980
X1869 2482 2542 274 2 1 ND2S $T=530100 447440 0 180 $X=528240 $Y=442020
X1870 2550 2494 2511 2 1 ND2S $T=530720 397040 0 0 $X=530720 $Y=396660
X1871 2659 2563 2676 2 1 ND2S $T=547460 366800 1 0 $X=547460 $Y=361380
X1872 2626 2696 285 2 1 ND2S $T=554280 487760 1 180 $X=552420 $Y=487380
X1873 2820 2829 2825 2 1 ND2S $T=574120 437360 0 0 $X=574120 $Y=436980
X1874 2600 2895 2881 2 1 ND2S $T=586520 376880 0 0 $X=586520 $Y=376500
X1875 2894 2935 321 2 1 ND2S $T=595200 447440 0 180 $X=593340 $Y=442020
X1876 3008 2970 3035 2 1 ND2S $T=609460 407120 0 0 $X=609460 $Y=406740
X1877 3106 3114 3129 2 1 ND2S $T=623100 487760 0 0 $X=623100 $Y=487380
X1878 3143 3122 3102 2 1 ND2S $T=626820 487760 0 0 $X=626820 $Y=487380
X1879 3159 3128 3155 2 1 ND2S $T=627440 457520 0 0 $X=627440 $Y=457140
X1880 3160 3173 3136 2 1 ND2S $T=630540 487760 0 0 $X=630540 $Y=487380
X1881 3196 3198 3204 2 1 ND2S $T=634260 467600 0 0 $X=634260 $Y=467220
X1882 3210 3209 3219 2 1 ND2S $T=636120 407120 0 0 $X=636120 $Y=406740
X1883 3234 3218 3240 2 1 ND2S $T=639220 397040 0 0 $X=639220 $Y=396660
X1884 3242 3224 3251 2 1 ND2S $T=639840 407120 0 0 $X=639840 $Y=406740
X1885 3144 3256 3253 2 1 ND2S $T=639840 467600 0 0 $X=639840 $Y=467220
X1886 3289 3287 3174 2 1 ND2S $T=645420 427280 1 0 $X=645420 $Y=421860
X1887 3300 3269 3174 2 1 ND2S $T=646660 417200 1 0 $X=646660 $Y=411780
X1888 3296 3327 3317 2 1 ND2S $T=651620 417200 1 0 $X=651620 $Y=411780
X1889 3254 3339 3219 2 1 ND2S $T=654100 407120 0 180 $X=652240 $Y=401700
X1890 388 3307 3351 2 1 ND2S $T=655340 366800 0 0 $X=655340 $Y=366420
X1891 414 3479 442 2 1 ND2S $T=695640 497840 1 180 $X=693780 $Y=497460
X1892 3720 3736 442 2 1 ND2S $T=760740 437360 1 180 $X=758880 $Y=436980
X1893 570 3789 574 2 1 ND2S $T=768800 507920 1 0 $X=768800 $Y=502500
X1894 3800 3779 3795 2 1 ND2S $T=771280 487760 0 0 $X=771280 $Y=487380
X1895 3787 3795 3798 2 1 ND2S $T=772520 497840 1 0 $X=772520 $Y=492420
X1896 3951 3948 3960 2 1 ND2S $T=815300 497840 0 0 $X=815300 $Y=497460
X1897 4045 4016 4052 2 1 ND2S $T=832660 487760 0 0 $X=832660 $Y=487380
X1898 4067 4034 4029 2 1 ND2S $T=840720 497840 0 180 $X=838860 $Y=492420
X1899 4128 4160 4182 2 1 ND2S $T=865520 477680 1 0 $X=865520 $Y=472260
X1900 4450 4459 4442 2 1 ND2S $T=943640 497840 0 0 $X=943640 $Y=497460
X1901 4483 4442 4481 2 1 ND2S $T=951700 497840 1 0 $X=951700 $Y=492420
X1902 4514 4517 4501 2 1 ND2S $T=959760 497840 1 0 $X=959760 $Y=492420
X1903 4649 4628 4663 2 1 ND2S $T=1000680 457520 0 0 $X=1000680 $Y=457140
X1904 874 4802 4809 2 1 ND2S $T=1043460 477680 1 0 $X=1043460 $Y=472260
X1905 2904 2885 1 2895 2797 2 2881 2914 2896 OAI222S $T=593960 376880 1 180 $X=588380 $Y=376500
X1906 2875 2946 1 2971 2901 2 2790 2986 2991 OAI222S $T=598920 376880 0 0 $X=598920 $Y=376500
X1907 893 4887 1 4875 897 2 896 4880 4877 OAI222S $T=1085000 497840 0 180 $X=1079420 $Y=492420
X1908 3488 1 3533 3527 463 3554 2 OAI22S $T=702460 386960 0 0 $X=702460 $Y=386580
X1909 3477 1 3533 3541 464 3554 2 OAI22S $T=703700 397040 0 0 $X=703700 $Y=396660
X1910 3489 1 3533 3547 465 3554 2 OAI22S $T=704320 407120 1 0 $X=704320 $Y=401700
X1911 3464 1 3533 3574 483 3554 2 OAI22S $T=714240 397040 0 0 $X=714240 $Y=396660
X1912 3586 1 3464 3592 484 3574 2 OAI22S $T=714240 407120 1 0 $X=714240 $Y=401700
X1913 3586 1 3491 3592 3598 3553 2 OAI22S $T=714860 427280 1 0 $X=714860 $Y=421860
X1914 3586 1 3470 3592 3594 3564 2 OAI22S $T=714860 427280 0 0 $X=714860 $Y=426900
X1915 3586 1 3503 3592 486 3600 2 OAI22S $T=715480 407120 0 0 $X=715480 $Y=406740
X1916 3586 1 3489 3592 3623 3547 2 OAI22S $T=722920 407120 1 0 $X=722920 $Y=401700
X1917 3586 1 496 3592 3624 3522 2 OAI22S $T=722920 427280 0 0 $X=722920 $Y=426900
X1918 3586 1 3428 3592 498 3537 2 OAI22S $T=724780 407120 0 0 $X=724780 $Y=406740
X1919 3586 1 3508 3592 502 3567 2 OAI22S $T=726640 417200 1 0 $X=726640 $Y=411780
X1920 3586 1 3488 3592 512 3527 2 OAI22S $T=732220 407120 1 0 $X=732220 $Y=401700
X1921 3586 1 3483 3592 514 499 2 OAI22S $T=732840 417200 0 0 $X=732840 $Y=416820
X1922 3533 1 3483 3554 522 499 2 OAI22S $T=744620 417200 1 180 $X=740900 $Y=416820
X1923 3533 1 3672 3554 526 3683 2 OAI22S $T=742140 407120 0 0 $X=742140 $Y=406740
X1924 3586 1 3672 3592 529 3683 2 OAI22S $T=749580 407120 1 180 $X=745860 $Y=406740
X1925 3586 1 3686 3592 540 3652 2 OAI22S $T=748960 417200 0 0 $X=748960 $Y=416820
X1926 3533 1 3684 3554 544 3691 2 OAI22S $T=749580 407120 0 0 $X=749580 $Y=406740
X1927 3586 1 3684 3592 543 3691 2 OAI22S $T=750200 407120 1 0 $X=750200 $Y=401700
X1928 3533 1 3686 3554 548 3652 2 OAI22S $T=757640 417200 0 180 $X=753920 $Y=411780
X1929 3586 1 3474 3592 569 3735 2 OAI22S $T=765080 417200 0 0 $X=765080 $Y=416820
X1930 3469 1 3533 3803 579 3554 2 OAI22S $T=773140 407120 1 0 $X=773140 $Y=401700
X1931 3586 1 3471 3592 580 3818 2 OAI22S $T=773760 417200 1 0 $X=773760 $Y=411780
X1932 3586 1 3469 3592 596 3803 2 OAI22S $T=791120 407120 0 0 $X=791120 $Y=406740
X1933 3586 1 3542 3592 599 3855 2 OAI22S $T=793600 417200 1 0 $X=793600 $Y=411780
X1934 3586 1 3514 3592 604 3854 2 OAI22S $T=799800 407120 0 0 $X=799800 $Y=406740
X1935 3586 1 3519 3592 606 3840 2 OAI22S $T=800420 397040 0 0 $X=800420 $Y=396660
X1936 1036 1416 2 1535 1 1541 AOI12HS $T=341620 487760 0 0 $X=341620 $Y=487380
X1937 1453 1989 2 2066 1 2038 AOI12HS $T=433380 397040 1 0 $X=433380 $Y=391620
X1938 1948 2120 2 2108 1 2107 AOI12HS $T=443300 487760 1 180 $X=438960 $Y=487380
X1939 1948 2130 2 2132 1 2123 AOI12HS $T=443300 487760 1 0 $X=443300 $Y=482340
X1940 2430 2781 2 2774 1 2804 AOI12HS $T=570400 477680 0 180 $X=566060 $Y=472260
X1941 2430 2724 2 2816 1 2818 AOI12HS $T=569780 477680 0 0 $X=569780 $Y=477300
X1942 3674 3554 2 526 1 528 AOI12HS $T=742140 407120 1 0 $X=742140 $Y=401700
X1943 3662 3592 2 529 1 558 AOI12HS $T=755780 407120 1 0 $X=755780 $Y=401700
X1944 3846 3856 2 3883 1 3878 AOI12HS $T=789880 487760 0 0 $X=789880 $Y=487380
X1945 3902 3887 2 3935 1 3933 AOI12HS $T=801660 507920 1 0 $X=801660 $Y=502500
X1946 4029 4020 2 4040 1 4047 AOI12HS $T=828940 497840 0 0 $X=828940 $Y=497460
X1947 4084 4086 2 4092 1 4123 AOI12HS $T=851260 497840 0 0 $X=851260 $Y=497460
X1948 710 4224 2 4228 1 4234 AOI12HS $T=882260 507920 1 0 $X=882260 $Y=502500
X1949 4512 4506 2 4551 1 4533 AOI12HS $T=965340 497840 1 0 $X=965340 $Y=492420
X1950 1857 1863 1863 1857 2 1 1975 MAOI1 $T=418500 497840 1 0 $X=418500 $Y=492420
X1951 1981 2114 2114 1981 2 1 2063 MAOI1 $T=442060 457520 0 0 $X=442060 $Y=457140
X1952 1911 2148 2148 1911 2 1 2121 MAOI1 $T=453220 437360 1 180 $X=448260 $Y=436980
X1953 3722 3719 3719 3722 2 1 3718 MAOI1 $T=758260 487760 1 180 $X=753300 $Y=487380
X1954 3798 3790 3790 3798 2 1 3809 MAOI1 $T=783060 497840 1 180 $X=778100 $Y=497460
X1955 4052 4055 4055 4052 2 1 4025 MAOI1 $T=837620 487760 0 0 $X=837620 $Y=487380
X1956 1578 1570 1 1615 2 1592 OAI12HS $T=357120 407120 1 0 $X=357120 $Y=401700
X1957 1866 1952 1 1964 2 1926 OAI12HS $T=414160 477680 1 0 $X=414160 $Y=472260
X1958 1962 1450 1 1933 2 1969 OAI12HS $T=419120 376880 1 180 $X=415400 $Y=376500
X1959 1899 1966 1 1988 2 2000 OAI12HS $T=419740 386960 1 0 $X=419740 $Y=381540
X1960 1467 1989 1 1970 2 2001 OAI12HS $T=419740 397040 1 0 $X=419740 $Y=391620
X1961 1979 2002 1 2019 2 1986 OAI12HS $T=423460 427280 0 0 $X=423460 $Y=426900
X1962 1980 1972 1 2010 2 2030 OAI12HS $T=424700 437360 0 0 $X=424700 $Y=436980
X1963 1992 2038 1 2027 2 2052 OAI12HS $T=427800 397040 1 0 $X=427800 $Y=391620
X1964 1773 153 1 2072 2 2076 OAI12HS $T=430900 497840 1 0 $X=430900 $Y=492420
X1965 1850 2086 1 2095 2 2064 OAI12HS $T=434620 497840 1 0 $X=434620 $Y=492420
X1966 1904 2094 1 2099 2 2093 OAI12HS $T=435860 447440 1 0 $X=435860 $Y=442020
X1967 2121 2043 1 2112 2 1987 OAI12HS $T=442060 437360 1 180 $X=438340 $Y=436980
X1968 2159 168 1 2164 2 199 OAI12HS $T=456320 407120 1 0 $X=456320 $Y=401700
X1969 2166 168 1 2164 2 201 OAI12HS $T=461280 397040 0 0 $X=461280 $Y=396660
X1970 2177 168 1 2164 2 2174 OAI12HS $T=466240 407120 1 180 $X=462520 $Y=406740
X1971 2183 168 1 2164 2 207 OAI12HS $T=467480 407120 0 180 $X=463760 $Y=401700
X1972 2501 2604 1 2634 2 2609 OAI12HS $T=541260 376880 0 0 $X=541260 $Y=376500
X1973 2776 2787 1 2821 2 2808 OAI12HS $T=572260 407120 0 0 $X=572260 $Y=406740
X1974 2815 2800 1 2813 2 2826 OAI12HS $T=572260 487760 0 0 $X=572260 $Y=487380
X1975 2882 2872 1 2862 2 2871 OAI12HS $T=584660 407120 0 180 $X=580940 $Y=401700
X1976 324 2941 1 2945 2 2969 OAI12HS $T=596440 437360 0 0 $X=596440 $Y=436980
X1977 2875 2958 1 3006 2 2991 OAI12HS $T=604500 376880 0 0 $X=604500 $Y=376500
X1978 3102 3143 1 3122 2 3160 OAI12HS $T=626200 487760 1 0 $X=626200 $Y=482340
X1979 3194 3193 1 3207 2 3188 OAI12HS $T=633640 467600 1 0 $X=633640 $Y=462180
X1980 3137 3228 1 3238 2 3242 OAI12HS $T=637360 417200 1 0 $X=637360 $Y=411780
X1981 3174 3289 1 3287 2 3296 OAI12HS $T=648520 417200 1 180 $X=644800 $Y=416820
X1982 3247 3274 1 3319 2 3195 OAI12HS $T=647280 397040 0 0 $X=647280 $Y=396660
X1983 3219 3254 1 3339 2 3346 OAI12HS $T=654100 407120 1 0 $X=654100 $Y=401700
X1984 4137 4171 1 4169 2 4166 OAI12HS $T=864900 507920 1 0 $X=864900 $Y=502500
X1985 695 687 1 4173 2 4174 OAI12HS $T=871100 497840 1 180 $X=867380 $Y=497460
X1986 4156 4187 1 4180 2 4192 OAI12HS $T=869860 497840 1 0 $X=869860 $Y=492420
X1987 708 4206 1 4146 2 4183 OAI12HS $T=881640 487760 1 180 $X=877920 $Y=487380
X1988 718 4224 1 4246 2 4253 OAI12HS $T=887220 497840 0 0 $X=887220 $Y=497460
X1989 4243 4234 1 4255 2 4257 OAI12HS $T=889080 507920 1 0 $X=889080 $Y=502500
X1990 4334 4368 1 4362 2 4315 OAI12HS $T=923800 497840 1 180 $X=920080 $Y=497460
X1991 4385 4376 1 4371 2 4350 OAI12HS $T=925660 487760 1 180 $X=921940 $Y=487380
X1992 4394 779 1 4403 2 784 OAI12HS $T=926900 507920 0 0 $X=926900 $Y=507540
X1993 4445 4466 1 4460 2 4465 OAI12HS $T=947980 497840 0 180 $X=944260 $Y=492420
X1994 4541 4533 1 4527 2 4515 OAI12HS $T=965340 497840 0 180 $X=961620 $Y=492420
X1995 893 4872 1 4871 2 4875 OAI12HS $T=1075700 497840 1 0 $X=1075700 $Y=492420
X1996 3783 3572 3733 3725 3452 3755 1 2 3749 AO222 $T=768180 427280 0 180 $X=761980 $Y=421860
X1997 4053 652 650 4049 4041 647 1 2 4026 AO222 $T=837000 386960 0 180 $X=830800 $Y=381540
X1998 651 652 650 653 657 647 1 2 659 AO222 $T=835140 366800 0 0 $X=835140 $Y=366420
X1999 4079 652 650 4085 4088 647 1 2 4057 AO222 $T=850640 376880 1 180 $X=844440 $Y=376500
X2000 4099 652 650 4108 4114 647 1 2 4127 AO222 $T=850020 386960 1 0 $X=850020 $Y=381540
X2001 4181 652 650 4167 4163 647 1 2 4141 AO222 $T=869860 386960 0 180 $X=863660 $Y=381540
X2002 4222 652 650 4212 4209 647 1 2 4185 AO222 $T=882260 386960 0 180 $X=876060 $Y=381540
X2003 4265 652 650 4248 4239 647 1 2 4236 AO222 $T=893420 386960 0 180 $X=887220 $Y=381540
X2004 4324 770 773 4365 4370 775 1 2 4382 AO222 $T=918840 427280 0 0 $X=918840 $Y=426900
X2005 4423 770 773 4397 4395 775 1 2 4380 AO222 $T=931240 407120 1 180 $X=925040 $Y=406740
X2006 4438 770 773 4427 4399 775 1 2 4379 AO222 $T=939300 397040 1 180 $X=933100 $Y=396660
X2007 4421 770 773 4404 4433 775 1 2 4426 AO222 $T=934340 366800 0 0 $X=934340 $Y=366420
X2008 4412 770 773 4405 4437 775 1 2 4400 AO222 $T=934960 386960 1 0 $X=934960 $Y=381540
X2009 4479 770 773 4455 4487 775 1 2 4463 AO222 $T=949220 437360 1 0 $X=949220 $Y=431940
X2010 4548 770 773 4543 4538 775 1 2 4505 AO222 $T=969060 437360 0 180 $X=962860 $Y=431940
X2011 4529 770 773 4554 4558 775 1 2 4559 AO222 $T=967200 386960 1 0 $X=967200 $Y=381540
X2012 4569 770 773 4556 4552 775 1 2 4550 AO222 $T=973400 397040 1 180 $X=967200 $Y=396660
X2013 4600 770 773 4575 4584 775 1 2 4572 AO222 $T=981460 417200 1 180 $X=975260 $Y=416820
X2014 7 11 1 2 INV2 $T=232500 507920 1 0 $X=232500 $Y=502500
X2015 1095 1108 1 2 INV2 $T=258540 376880 0 0 $X=258540 $Y=376500
X2016 1111 1114 1 2 INV2 $T=260400 427280 1 180 $X=258540 $Y=426900
X2017 1117 1112 1 2 INV2 $T=261640 397040 1 180 $X=259780 $Y=396660
X2018 1080 1120 1 2 INV2 $T=259780 407120 0 0 $X=259780 $Y=406740
X2019 1134 1105 1 2 INV2 $T=264740 386960 0 0 $X=264740 $Y=386580
X2020 1234 1200 1 2 INV2 $T=291400 397040 1 180 $X=289540 $Y=396660
X2021 1246 1226 1 2 INV2 $T=293880 417200 1 180 $X=292020 $Y=416820
X2022 1221 1253 1 2 INV2 $T=293260 407120 1 0 $X=293260 $Y=401700
X2023 1284 1280 1 2 INV2 $T=301940 427280 1 180 $X=300080 $Y=426900
X2024 1272 1296 1 2 INV2 $T=306900 427280 0 0 $X=306900 $Y=426900
X2025 1429 1431 1 2 INV2 $T=329840 386960 1 0 $X=329840 $Y=381540
X2026 1518 1559 1 2 INV2 $T=347200 487760 0 0 $X=347200 $Y=487380
X2027 1609 1578 1 2 INV2 $T=358360 417200 0 180 $X=356500 $Y=411780
X2028 1706 1637 1 2 INV2 $T=376340 417200 1 180 $X=374480 $Y=416820
X2029 1632 1724 1 2 INV2 $T=381300 437360 1 0 $X=381300 $Y=431940
X2030 1718 1721 1 2 INV2 $T=381300 437360 0 0 $X=381300 $Y=436980
X2031 1700 1728 1 2 INV2 $T=381920 407120 0 0 $X=381920 $Y=406740
X2032 177 127 1 2 INV2 $T=455080 366800 0 180 $X=453220 $Y=361380
X2033 177 107 1 2 INV2 $T=456320 407120 0 0 $X=456320 $Y=406740
X2034 2207 2193 1 2 INV2 $T=471820 407120 0 180 $X=469960 $Y=401700
X2035 2214 2191 1 2 INV2 $T=473680 407120 0 180 $X=471820 $Y=401700
X2036 2223 2221 1 2 INV2 $T=474920 437360 0 0 $X=474920 $Y=436980
X2037 2241 2257 1 2 INV2 $T=477400 417200 1 0 $X=477400 $Y=411780
X2038 2262 2217 1 2 INV2 $T=481740 386960 0 180 $X=479880 $Y=381540
X2039 2257 2251 1 2 INV2 $T=482360 417200 0 180 $X=480500 $Y=411780
X2040 2222 2231 1 2 INV2 $T=480500 427280 1 0 $X=480500 $Y=421860
X2041 2283 2233 1 2 INV2 $T=487320 397040 1 180 $X=485460 $Y=396660
X2042 2289 2264 1 2 INV2 $T=490420 417200 0 0 $X=490420 $Y=416820
X2043 2429 2411 1 2 INV2 $T=512120 417200 0 180 $X=510260 $Y=411780
X2044 2470 2454 1 2 INV2 $T=518940 427280 0 180 $X=517080 $Y=421860
X2045 2454 2484 1 2 INV2 $T=518940 427280 1 0 $X=518940 $Y=421860
X2046 2509 2458 1 2 INV2 $T=524520 417200 1 180 $X=522660 $Y=416820
X2047 2505 2527 1 2 INV2 $T=528240 386960 0 0 $X=528240 $Y=386580
X2048 2520 2512 1 2 INV2 $T=528240 437360 1 0 $X=528240 $Y=431940
X2049 2550 2528 1 2 INV2 $T=531960 407120 1 0 $X=531960 $Y=401700
X2050 2511 2480 1 2 INV2 $T=532580 407120 0 0 $X=532580 $Y=406740
X2051 2545 2572 1 2 INV2 $T=533200 397040 0 0 $X=533200 $Y=396660
X2052 2521 2576 1 2 INV2 $T=533200 437360 1 0 $X=533200 $Y=431940
X2053 2544 2581 1 2 INV2 $T=535680 366800 0 0 $X=535680 $Y=366420
X2054 2771 2779 1 2 INV2 $T=564200 427280 0 0 $X=564200 $Y=426900
X2055 2919 2941 1 2 INV2 $T=592100 437360 1 0 $X=592100 $Y=431940
X2056 2893 2879 1 2 INV2 $T=593340 427280 0 0 $X=593340 $Y=426900
X2057 2944 2927 1 2 INV2 $T=595820 417200 1 180 $X=593960 $Y=416820
X2058 2955 2944 1 2 INV2 $T=597680 427280 0 180 $X=595820 $Y=421860
X2059 314 326 1 2 INV2 $T=598920 427280 0 0 $X=598920 $Y=426900
X2060 2976 2883 1 2 INV2 $T=602020 407120 0 180 $X=600160 $Y=401700
X2061 2969 2980 1 2 INV2 $T=601400 437360 1 0 $X=601400 $Y=431940
X2062 3029 2987 1 2 INV2 $T=610080 417200 0 180 $X=608220 $Y=411780
X2063 2912 3021 1 2 INV2 $T=608220 427280 0 0 $X=608220 $Y=426900
X2064 3000 3007 1 2 INV2 $T=611320 417200 1 0 $X=611320 $Y=411780
X2065 2995 3019 1 2 INV2 $T=613800 407120 0 180 $X=611940 $Y=401700
X2066 318 331 1 2 INV2 $T=620000 417200 1 0 $X=620000 $Y=411780
X2067 398 337 1 2 INV2 $T=677040 366800 1 0 $X=677040 $Y=361380
X2068 4149 550 1 2 INV2 $T=859940 427280 1 180 $X=858080 $Y=426900
X2069 4179 4158 1 2 INV2 $T=868620 487760 0 0 $X=868620 $Y=487380
X2070 4292 744 1 2 INV2 $T=903960 386960 0 0 $X=903960 $Y=386580
X2071 4309 756 1 2 INV2 $T=908300 376880 1 0 $X=908300 $Y=371460
X2072 398 785 1 2 INV2 $T=940540 477680 0 180 $X=938680 $Y=472260
X2073 1078 2 1085 1 1080 NR2P $T=254200 417200 0 180 $X=250480 $Y=411780
X2074 1088 2 1114 1 1117 NR2P $T=260400 407120 0 180 $X=256680 $Y=401700
X2075 41 2 44 1 1145 NR2P $T=280240 437360 1 180 $X=276520 $Y=436980
X2076 41 2 43 1 1165 NR2P $T=280240 447440 0 180 $X=276520 $Y=442020
X2077 42 2 49 1 1185 NR2P $T=281480 427280 1 180 $X=277760 $Y=426900
X2078 42 2 47 1 1189 NR2P $T=282100 437360 0 180 $X=278380 $Y=431940
X2079 59 2 49 1 1203 NR2P $T=283340 437360 1 0 $X=283340 $Y=431940
X2080 52 2 44 1 1238 NR2P $T=287060 437360 0 0 $X=287060 $Y=436980
X2081 1257 2 1208 1 1223 NR2P $T=295740 417200 1 0 $X=295740 $Y=411780
X2082 1257 2 1255 1 1246 NR2P $T=297600 417200 0 0 $X=297600 $Y=416820
X2083 1257 2 1280 1 1221 NR2P $T=300700 407120 0 0 $X=300700 $Y=406740
X2084 1663 2 1661 1 1649 NR2P $T=373240 427280 1 0 $X=373240 $Y=421860
X2085 1702 2 1682 1 1624 NR2P $T=380060 437360 0 180 $X=376340 $Y=431940
X2086 1663 2 1721 1 1706 NR2P $T=382540 427280 0 180 $X=378820 $Y=421860
X2087 1666 2 1717 1 1732 NR2P $T=385640 417200 0 180 $X=381920 $Y=411780
X2088 1663 2 1724 1 1666 NR2P $T=383160 427280 1 0 $X=383160 $Y=421860
X2089 203 2 44 1 2171 NR2P $T=464380 437360 0 180 $X=460660 $Y=431940
X2090 203 2 49 1 2184 NR2P $T=468100 427280 0 180 $X=464380 $Y=421860
X2091 203 2 45 1 2187 NR2P $T=468720 437360 1 180 $X=465000 $Y=436980
X2092 2206 2 2194 1 2211 NR2P $T=469340 386960 1 0 $X=469340 $Y=381540
X2093 2200 2 2220 1 2207 NR2P $T=473060 407120 1 180 $X=469340 $Y=406740
X2094 2200 2 2266 1 2206 NR2P $T=479260 407120 1 180 $X=475540 $Y=406740
X2095 255 2 49 1 2431 NR2P $T=513360 427280 1 180 $X=509640 $Y=426900
X2096 255 2 47 1 2441 NR2P $T=517700 437360 1 0 $X=517700 $Y=431940
X2097 302 2 49 1 2837 NR2P $T=576600 437360 0 180 $X=572880 $Y=431940
X2098 302 2 53 1 2863 NR2P $T=579700 447440 0 0 $X=579700 $Y=447060
X2099 2941 2 2932 1 2893 NR2P $T=595200 427280 0 0 $X=595200 $Y=426900
X2100 2940 2 2980 1 3029 NR2P $T=610080 417200 0 0 $X=610080 $Y=416820
X2101 1199 1203 2 1208 1210 1 OR3B2 $T=282100 427280 1 0 $X=282100 $Y=421860
X2102 165 151 1 2 INV12CK $T=444540 376880 0 0 $X=444540 $Y=376500
X2103 423 298 1 2 INV12CK $T=686340 457520 0 180 $X=676420 $Y=452100
X2104 818 696 1 2 INV12CK $T=966580 477680 0 0 $X=966580 $Y=477300
X2105 3622 3680 1 2 BUF2CK $T=742140 427280 1 0 $X=742140 $Y=421860
X2106 3606 3637 1 2 BUF2CK $T=744000 487760 1 0 $X=744000 $Y=482340
X2107 3938 3936 1 2 BUF2CK $T=805380 427280 1 0 $X=805380 $Y=421860
X2108 898 901 1 2 BUF2CK $T=1085000 437360 0 0 $X=1085000 $Y=436980
X2109 2299 1 2 185 INV3CK $T=487320 507920 0 0 $X=487320 $Y=507540
X2110 355 1 2 353 INV3CK $T=618140 507920 0 180 $X=615040 $Y=502500
X2111 362 1 2 363 INV3CK $T=628680 497840 0 0 $X=628680 $Y=497460
X2112 3360 1 2 393 INV3CK $T=665880 507920 0 0 $X=665880 $Y=507540
X2113 615 1 2 616 INV3CK $T=812820 376880 0 0 $X=812820 $Y=376500
X2114 4311 1 2 748 INV3CK $T=910160 386960 0 180 $X=907060 $Y=381540
X2115 4314 1 2 4288 INV3CK $T=910160 457520 0 0 $X=910160 $Y=457140
X2116 791 1 2 794 INV3CK $T=938680 376880 0 0 $X=938680 $Y=376500
X2117 4513 1 2 813 INV3CK $T=960380 386960 0 180 $X=957280 $Y=381540
X2118 1492 1 2 1587 BUF1CK $T=352160 437360 1 0 $X=352160 $Y=431940
X2119 2165 1 2 2168 BUF1CK $T=460040 417200 0 0 $X=460040 $Y=416820
X2120 2180 1 2 2153 BUF1CK $T=465620 477680 1 0 $X=465620 $Y=472260
X2121 2278 1 2 2294 BUF1CK $T=484220 507920 0 0 $X=484220 $Y=507540
X2122 2340 1 2 247 BUF1CK $T=497240 507920 1 0 $X=497240 $Y=502500
X2123 2835 1 2 2776 BUF1CK $T=577840 407120 0 0 $X=577840 $Y=406740
X2124 2972 1 2 2971 BUF1CK $T=611940 376880 0 0 $X=611940 $Y=376500
X2125 427 1 2 3463 BUF1CK $T=688200 477680 0 0 $X=688200 $Y=477300
X2126 3478 1 2 3465 BUF1CK $T=693160 487760 1 0 $X=693160 $Y=482340
X2127 3501 1 2 3492 BUF1CK $T=698120 447440 0 0 $X=698120 $Y=447060
X2128 3509 1 2 3520 BUF1CK $T=699360 457520 1 0 $X=699360 $Y=452100
X2129 473 1 2 474 BUF1CK $T=711140 507920 0 0 $X=711140 $Y=507540
X2130 3587 1 2 3625 BUF1CK $T=726020 507920 1 0 $X=726020 $Y=502500
X2131 3627 1 2 3648 BUF1CK $T=732220 477680 1 0 $X=732220 $Y=472260
X2132 3618 1 2 3656 BUF1CK $T=734080 457520 0 0 $X=734080 $Y=457140
X2133 3621 1 2 3654 BUF1CK $T=735320 437360 1 0 $X=735320 $Y=431940
X2134 3605 1 2 3626 BUF1CK $T=736560 457520 1 0 $X=736560 $Y=452100
X2135 3601 1 2 3649 BUF1CK $T=739660 477680 0 0 $X=739660 $Y=477300
X2136 3608 1 2 3636 BUF1CK $T=740900 487760 0 0 $X=740900 $Y=487380
X2137 3710 1 2 3752 BUF1CK $T=760120 437360 1 0 $X=760120 $Y=431940
X2138 3544 1 2 3715 BUF1CK $T=760740 427280 0 0 $X=760740 $Y=426900
X2139 3475 1 2 3753 BUF1CK $T=760740 437360 0 0 $X=760740 $Y=436980
X2140 3853 1 2 3848 BUF1CK $T=788640 417200 0 0 $X=788640 $Y=416820
X2141 3876 1 2 3843 BUF1CK $T=796700 427280 1 0 $X=796700 $Y=421860
X2142 4022 1 2 4028 BUF1CK $T=827080 376880 0 0 $X=827080 $Y=376500
X2143 4056 1 2 4022 BUF1CK $T=837000 376880 0 0 $X=837000 $Y=376500
X2144 4093 1 2 4094 BUF1CK $T=847540 376880 1 0 $X=847540 $Y=371460
X2145 4094 1 2 4097 BUF1CK $T=847540 386960 1 0 $X=847540 $Y=381540
X2146 4215 1 2 4219 BUF1CK $T=879160 366800 0 0 $X=879160 $Y=366420
X2147 4330 1 2 761 BUF1CK $T=913260 366800 1 0 $X=913260 $Y=361380
X2148 801 1 2 4478 BUF1CK $T=946120 366800 1 0 $X=946120 $Y=361380
X2149 819 1 2 4555 BUF1CK $T=968440 366800 0 0 $X=968440 $Y=366420
X2150 4555 1 2 4560 BUF1CK $T=969060 366800 1 0 $X=969060 $Y=361380
X2151 4796 1 2 4799 BUF1CK $T=1046560 477680 0 0 $X=1046560 $Y=477300
X2152 1177 1 2 1225 BUF1S $T=294500 376880 0 0 $X=294500 $Y=376500
X2153 1286 1 2 1329 BUF1S $T=309380 397040 1 0 $X=309380 $Y=391620
X2154 1800 1 2 1767 BUF1S $T=397420 417200 1 0 $X=397420 $Y=411780
X2155 1878 1 2 1896 BUF1S $T=407960 376880 0 0 $X=407960 $Y=376500
X2156 1976 1 2 1977 BUF1S $T=417880 427280 0 0 $X=417880 $Y=426900
X2157 1915 1 2 2015 BUF1S $T=417880 507920 1 0 $X=417880 $Y=502500
X2158 1907 1 2 1992 BUF1S $T=419120 386960 0 0 $X=419120 $Y=386580
X2159 1924 1 2 1996 BUF1S $T=420360 467600 1 0 $X=420360 $Y=462180
X2160 1886 1 2 2009 BUF1S $T=422220 447440 0 0 $X=422220 $Y=447060
X2161 1920 1 2 2018 BUF1S $T=423460 497840 1 0 $X=423460 $Y=492420
X2162 1965 1 2 2060 BUF1S $T=429040 477680 1 0 $X=429040 $Y=472260
X2163 2050 1 2 1967 BUF1S $T=432140 437360 1 0 $X=432140 $Y=431940
X2164 155 1 2 158 BUF1S $T=432140 507920 0 0 $X=432140 $Y=507540
X2165 1968 1 2 2097 BUF1S $T=434620 467600 0 0 $X=434620 $Y=467220
X2166 2023 1 2 2073 BUF1S $T=435240 477680 0 0 $X=435240 $Y=477300
X2167 1945 1 2 1954 BUF1S $T=436480 427280 1 0 $X=436480 $Y=421860
X2168 1604 1 2 2016 BUF1S $T=437100 467600 0 0 $X=437100 $Y=467220
X2169 1961 1 2 2135 BUF1S $T=440820 497840 0 0 $X=440820 $Y=497460
X2170 150 1 2 2098 BUF1S $T=442060 366800 0 0 $X=442060 $Y=366420
X2171 2092 1 2 2138 BUF1S $T=443920 417200 0 0 $X=443920 $Y=416820
X2172 2143 1 2 2157 BUF1S $T=451980 417200 1 0 $X=451980 $Y=411780
X2173 2229 1 2 2242 BUF1S $T=476160 427280 0 0 $X=476160 $Y=426900
X2174 2283 1 2 2339 BUF1S $T=493520 397040 1 0 $X=493520 $Y=391620
X2175 2504 1 2 2543 BUF1S $T=527620 386960 1 0 $X=527620 $Y=381540
X2176 2791 1 2 2810 BUF1S $T=569780 386960 1 0 $X=569780 $Y=381540
X2177 2756 1 2 2786 BUF1S $T=572260 386960 1 0 $X=572260 $Y=381540
X2178 2726 1 2 2815 BUF1S $T=575980 487760 0 0 $X=575980 $Y=487380
X2179 2780 1 2 2824 BUF1S $T=576600 477680 1 0 $X=576600 $Y=472260
X2180 2759 1 2 2823 BUF1S $T=576600 507920 1 0 $X=576600 $Y=502500
X2181 2884 1 2 2973 BUF1S $T=600780 427280 0 0 $X=600780 $Y=426900
X2182 3028 1 2 3205 BUF1S $T=624960 386960 1 0 $X=624960 $Y=381540
X2183 359 1 2 357 BUF1S $T=627440 507920 1 180 $X=624960 $Y=507540
X2184 3078 1 2 3146 BUF1S $T=625580 497840 1 0 $X=625580 $Y=492420
X2185 3048 1 2 360 BUF1S $T=626200 497840 0 0 $X=626200 $Y=497460
X2186 358 1 2 3171 BUF1S $T=628680 507920 1 0 $X=628680 $Y=502500
X2187 354 1 2 3151 BUF1S $T=630540 366800 1 0 $X=630540 $Y=361380
X2188 3170 1 2 3264 BUF1S $T=650380 477680 1 180 $X=647900 $Y=477300
X2189 3322 1 2 3341 BUF1S $T=652240 437360 0 0 $X=652240 $Y=436980
X2190 3090 1 2 3312 BUF1S $T=655960 376880 0 0 $X=655960 $Y=376500
X2191 3358 1 2 3352 BUF1S $T=657820 417200 0 0 $X=657820 $Y=416820
X2192 3338 1 2 3375 BUF1S $T=659060 467600 0 0 $X=659060 $Y=467220
X2193 2839 1 2 3387 BUF1S $T=662160 467600 1 0 $X=662160 $Y=462180
X2194 3329 1 2 3376 BUF1S $T=663400 487760 1 0 $X=663400 $Y=482340
X2195 2834 1 2 3392 BUF1S $T=664640 457520 0 0 $X=664640 $Y=457140
X2196 3395 1 2 3401 BUF1S $T=665880 417200 1 0 $X=665880 $Y=411780
X2197 3363 1 2 3400 BUF1S $T=667740 397040 0 0 $X=667740 $Y=396660
X2198 3385 1 2 3422 BUF1S $T=667740 437360 1 0 $X=667740 $Y=431940
X2199 3343 1 2 3409 BUF1S $T=670840 386960 1 0 $X=670840 $Y=381540
X2200 3526 1 2 3494 BUF1S $T=701840 407120 1 0 $X=701840 $Y=401700
X2201 3573 1 2 443 BUF1S $T=711760 397040 0 0 $X=711760 $Y=396660
X2202 3562 1 2 3493 BUF1S $T=711760 407120 1 0 $X=711760 $Y=401700
X2203 3619 1 2 3616 BUF1S $T=723540 386960 0 0 $X=723540 $Y=386580
X2204 3721 1 2 3690 BUF1S $T=754540 497840 1 180 $X=752060 $Y=497460
X2205 3732 1 2 3717 BUF1S $T=757640 477680 1 180 $X=755160 $Y=477300
X2206 3779 1 2 3747 BUF1S $T=767560 487760 1 180 $X=765080 $Y=487380
X2207 3629 1 2 3781 BUF1S $T=766320 397040 1 0 $X=766320 $Y=391620
X2208 3780 1 2 3817 BUF1S $T=775620 477680 0 0 $X=775620 $Y=477300
X2209 3841 1 2 3830 BUF1S $T=784300 477680 1 180 $X=781820 $Y=477300
X2210 3834 1 2 3821 BUF1S $T=782440 437360 1 0 $X=782440 $Y=431940
X2211 584 1 2 3867 BUF1S $T=785540 477680 0 0 $X=785540 $Y=477300
X2212 3881 1 2 3871 BUF1S $T=792360 427280 0 0 $X=792360 $Y=426900
X2213 3908 1 2 3880 BUF1S $T=796700 427280 0 0 $X=796700 $Y=426900
X2214 3899 1 2 3910 BUF1S $T=799800 477680 1 0 $X=799800 $Y=472260
X2215 3926 1 2 3939 BUF1S $T=805380 497840 0 0 $X=805380 $Y=497460
X2216 3927 1 2 3945 BUF1S $T=806000 487760 1 0 $X=806000 $Y=482340
X2217 3988 1 2 3942 BUF1S $T=819640 427280 0 0 $X=819640 $Y=426900
X2218 3969 1 2 3990 BUF1S $T=823980 477680 1 180 $X=821500 $Y=477300
X2219 3994 1 2 4006 BUF1S $T=831420 487760 0 180 $X=828940 $Y=482340
X2220 4066 1 2 4080 BUF1S $T=841340 487760 1 0 $X=841340 $Y=482340
X2221 4091 1 2 4100 BUF1S $T=854980 487760 1 0 $X=854980 $Y=482340
X2222 4132 1 2 4137 BUF1S $T=856840 507920 0 0 $X=856840 $Y=507540
X2223 4133 1 2 4146 BUF1S $T=859320 487760 1 0 $X=859320 $Y=482340
X2224 4129 1 2 4156 BUF1S $T=861180 497840 0 0 $X=861180 $Y=497460
X2225 4152 1 2 4173 BUF1S $T=865520 477680 0 0 $X=865520 $Y=477300
X2226 4145 1 2 4191 BUF1S $T=871100 487760 0 0 $X=871100 $Y=487380
X2227 712 1 2 710 BUF1S $T=889080 487760 0 0 $X=889080 $Y=487380
X2228 4232 1 2 4246 BUF1S $T=894040 487760 0 0 $X=894040 $Y=487380
X2229 4219 1 2 732 BUF1S $T=895900 376880 1 0 $X=895900 $Y=371460
X2230 4231 1 2 4243 BUF1S $T=897760 507920 0 0 $X=897760 $Y=507540
X2231 727 1 2 4282 BUF1S $T=902720 507920 0 0 $X=902720 $Y=507540
X2232 4329 1 2 4334 BUF1S $T=912640 497840 0 0 $X=912640 $Y=497460
X2233 4337 1 2 4344 BUF1S $T=914500 487760 0 0 $X=914500 $Y=487380
X2234 4338 1 2 4353 BUF1S $T=916360 507920 1 0 $X=916360 $Y=502500
X2235 4398 1 2 4424 BUF1S $T=939300 487760 1 180 $X=936820 $Y=487380
X2236 4418 1 2 792 BUF1S $T=936820 507920 0 0 $X=936820 $Y=507540
X2237 3844 1 2 4473 BUF1S $T=944880 427280 0 0 $X=944880 $Y=426900
X2238 3889 1 2 808 BUF1S $T=951080 376880 0 0 $X=951080 $Y=376500
X2239 4462 1 2 4519 BUF1S $T=957280 497840 1 0 $X=957280 $Y=492420
X2240 4503 1 2 4537 BUF1S $T=965960 487760 0 180 $X=963480 $Y=482340
X2241 4507 1 2 4541 BUF1S $T=964100 507920 1 0 $X=964100 $Y=502500
X2242 4507 1 2 4535 BUF1S $T=966580 507920 1 0 $X=966580 $Y=502500
X2243 4530 1 2 4574 BUF1S $T=982700 477680 1 180 $X=980220 $Y=477300
X2244 4616 1 2 4648 BUF1S $T=987040 467600 0 0 $X=987040 $Y=467220
X2245 4626 1 2 4656 BUF1S $T=999440 477680 1 0 $X=999440 $Y=472260
X2246 855 1 2 4716 BUF1S $T=1017420 507920 0 0 $X=1017420 $Y=507540
X2247 4713 1 2 4730 BUF1S $T=1020520 477680 0 0 $X=1020520 $Y=477300
X2248 4726 1 2 4723 BUF1S $T=1025480 507920 0 180 $X=1023000 $Y=502500
X2249 4766 1 2 4764 BUF1S $T=1037880 497840 1 180 $X=1035400 $Y=497460
X2250 4776 1 2 4780 BUF1S $T=1037260 507920 1 0 $X=1037260 $Y=502500
X2251 4788 1 2 4806 BUF1S $T=1052760 497840 0 180 $X=1050280 $Y=492420
X2252 4824 1 2 4843 BUF1S $T=1065780 487760 1 0 $X=1065780 $Y=482340
X2253 4819 1 2 4838 BUF1S $T=1068260 497840 0 180 $X=1065780 $Y=492420
X2254 4855 1 2 4868 BUF1S $T=1072600 487760 1 0 $X=1072600 $Y=482340
X2255 890 1 2 893 BUF1S $T=1072600 487760 0 0 $X=1072600 $Y=487380
X2256 4851 1 2 4877 BUF1S $T=1076320 497840 0 0 $X=1076320 $Y=497460
X2257 4864 1 2 4881 BUF1S $T=1080040 487760 1 0 $X=1080040 $Y=482340
X2258 1581 1 2 1532 DELB $T=355260 417200 0 0 $X=355260 $Y=416820
X2259 1801 1 2 1864 DELB $T=400520 397040 1 0 $X=400520 $Y=391620
X2260 1872 1 2 2029 DELB $T=423460 386960 1 0 $X=423460 $Y=381540
X2261 2111 1 2 2142 DELB $T=448260 366800 0 0 $X=448260 $Y=366420
X2262 2144 1 2 176 DELB $T=448880 457520 1 0 $X=448880 $Y=452100
X2263 2149 1 2 182 DELB $T=451360 397040 1 0 $X=451360 $Y=391620
X2264 2158 1 2 2160 DELB $T=453840 457520 1 0 $X=453840 $Y=452100
X2265 193 1 2 206 DELB $T=460040 507920 1 0 $X=460040 $Y=502500
X2266 2150 1 2 212 DELB $T=465000 507920 1 0 $X=465000 $Y=502500
X2267 2179 1 2 214 DELB $T=466240 376880 0 0 $X=466240 $Y=376500
X2268 2169 1 2 218 DELB $T=469340 397040 1 0 $X=469340 $Y=391620
X2269 2176 1 2 234 DELB $T=478640 507920 0 0 $X=478640 $Y=507540
X2270 2811 1 2 2803 DELB $T=587760 427280 1 0 $X=587760 $Y=421860
X2271 3861 1 2 595 DELB $T=789260 386960 0 0 $X=789260 $Y=386580
X2272 3946 1 2 620 DELB $T=812200 477680 0 0 $X=812200 $Y=477300
X2273 3970 1 2 622 DELB $T=814060 447440 0 0 $X=814060 $Y=447060
X2274 3996 1 2 4017 DELB $T=821500 407120 0 0 $X=821500 $Y=406740
X2275 4028 1 2 662 DELB $T=837000 386960 1 0 $X=837000 $Y=381540
X2276 4117 1 2 4159 DELB $T=853740 407120 0 0 $X=853740 $Y=406740
X2277 4097 1 2 679 DELB $T=854360 366800 0 0 $X=854360 $Y=366420
X2278 4154 1 2 4138 DELB $T=869860 386960 1 0 $X=869860 $Y=381540
X2279 4186 1 2 4199 DELB $T=871720 427280 1 0 $X=871720 $Y=421860
X2280 4218 1 2 4229 DELB $T=881020 417200 0 0 $X=881020 $Y=416820
X2281 713 1 2 4244 DELB $T=884740 366800 1 0 $X=884740 $Y=361380
X2282 4216 1 2 4202 DELB $T=895900 427280 0 0 $X=895900 $Y=426900
X2283 4273 1 2 4266 DELB $T=896520 397040 0 0 $X=896520 $Y=396660
X2284 4283 1 2 4281 DELB $T=900860 427280 0 0 $X=900860 $Y=426900
X2285 740 1 2 4291 DELB $T=902720 366800 1 0 $X=902720 $Y=361380
X2286 4298 1 2 4304 DELB $T=905200 417200 1 0 $X=905200 $Y=411780
X2287 4277 1 2 4272 DELB $T=914500 386960 1 0 $X=914500 $Y=381540
X2288 4346 1 2 4161 DELB $T=918840 397040 0 0 $X=918840 $Y=396660
X2289 4378 1 2 783 DELB $T=925660 366800 1 0 $X=925660 $Y=361380
X2290 4444 1 2 4220 DELB $T=940540 417200 1 0 $X=940540 $Y=411780
X2291 4520 1 2 4284 DELB $T=964100 366800 1 0 $X=964100 $Y=361380
X2292 21 2 1 24 BUF1 $T=254820 366800 1 0 $X=254820 $Y=361380
X2293 21 2 1 1131 BUF1 $T=262260 457520 0 0 $X=262260 $Y=457140
X2294 20 2 1 989 BUF1 $T=274040 376880 0 0 $X=274040 $Y=376500
X2295 20 2 1 10 BUF1 $T=279000 497840 1 180 $X=276520 $Y=497460
X2296 1211 2 1 1215 BUF1 $T=285200 467600 0 0 $X=285200 $Y=467220
X2297 1211 2 1 1227 BUF1 $T=292020 447440 0 0 $X=292020 $Y=447060
X2298 71 2 1 1275 BUF1 $T=297600 467600 0 0 $X=297600 $Y=467220
X2299 38 2 1 90 BUF1 $T=311860 376880 1 0 $X=311860 $Y=371460
X2300 81 2 1 1289 BUF1 $T=311860 447440 1 0 $X=311860 $Y=442020
X2301 1521 2 1 1519 BUF1 $T=340380 467600 1 0 $X=340380 $Y=462180
X2302 1481 2 1 1506 BUF1 $T=345960 447440 1 0 $X=345960 $Y=442020
X2303 5 2 1 1523 BUF1 $T=358360 497840 0 180 $X=355880 $Y=492420
X2304 1586 2 1 1520 BUF1 $T=361460 497840 1 0 $X=361460 $Y=492420
X2305 121 2 1 1714 BUF1 $T=380680 477680 1 0 $X=380680 $Y=472260
X2306 117 2 1 1607 BUF1 $T=389360 417200 0 0 $X=389360 $Y=416820
X2307 117 2 1 1676 BUF1 $T=396800 467600 1 0 $X=396800 $Y=462180
X2308 117 2 1 1826 BUF1 $T=398660 457520 1 0 $X=398660 $Y=452100
X2309 1523 2 1 163 BUF1 $T=453840 376880 1 0 $X=453840 $Y=371460
X2310 213 2 1 217 BUF1 $T=471820 366800 1 180 $X=469340 $Y=366420
X2311 213 2 1 2227 BUF1 $T=477400 477680 1 0 $X=477400 $Y=472260
X2312 230 2 1 2282 BUF1 $T=481740 457520 0 0 $X=481740 $Y=457140
X2313 235 2 1 2300 BUF1 $T=485460 497840 1 0 $X=485460 $Y=492420
X2314 235 2 1 238 BUF1 $T=491040 376880 1 0 $X=491040 $Y=371460
X2315 2271 2 1 251 BUF1 $T=504060 407120 0 0 $X=504060 $Y=406740
X2316 260 2 1 2462 BUF1 $T=515840 507920 1 0 $X=515840 $Y=502500
X2317 255 2 1 2440 BUF1 $T=515840 507920 0 0 $X=515840 $Y=507540
X2318 255 2 1 264 BUF1 $T=516460 366800 1 0 $X=516460 $Y=361380
X2319 265 2 1 267 BUF1 $T=518940 366800 0 0 $X=518940 $Y=366420
X2320 2410 2 1 2538 BUF1 $T=525140 386960 1 0 $X=525140 $Y=381540
X2321 265 2 1 2491 BUF1 $T=526380 507920 0 0 $X=526380 $Y=507540
X2322 279 2 1 2557 BUF1 $T=545600 467600 0 180 $X=543120 $Y=462180
X2323 2742 2 1 2755 BUF1 $T=560480 497840 1 0 $X=560480 $Y=492420
X2324 2762 2 1 2778 BUF1 $T=562960 467600 0 0 $X=562960 $Y=467220
X2325 306 2 1 307 BUF1 $T=579080 507920 1 0 $X=579080 $Y=502500
X2326 5 2 1 301 BUF1 $T=582180 487760 0 180 $X=579700 $Y=482340
X2327 2869 2 1 2875 BUF1 $T=581560 386960 1 0 $X=581560 $Y=381540
X2328 314 2 1 2905 BUF1 $T=586520 477680 0 0 $X=586520 $Y=477300
X2329 325 2 1 2959 BUF1 $T=597060 477680 1 0 $X=597060 $Y=472260
X2330 3214 2 1 3201 BUF1 $T=636120 397040 1 0 $X=636120 $Y=391620
X2331 379 2 1 389 BUF1 $T=657200 497840 0 0 $X=657200 $Y=497460
X2332 3394 2 1 383 BUF1 $T=665260 497840 0 180 $X=662780 $Y=492420
X2333 301 2 1 3424 BUF1 $T=670840 397040 0 0 $X=670840 $Y=396660
X2334 301 2 1 404 BUF1 $T=671460 366800 0 0 $X=671460 $Y=366420
X2335 2846 2 1 3394 BUF1 $T=674560 407120 0 0 $X=674560 $Y=406740
X2336 3572 2 1 460 BUF1 $T=713620 467600 1 180 $X=711140 $Y=467220
X2337 576 2 1 688 BUF1 $T=901480 467600 0 0 $X=901480 $Y=467220
X2338 379 2 1 4313 BUF1 $T=905820 487760 1 0 $X=905820 $Y=482340
X2339 576 2 1 743 BUF1 $T=912020 507920 1 180 $X=909540 $Y=507540
X2340 576 2 1 4352 BUF1 $T=918220 477680 0 0 $X=918220 $Y=477300
X2341 894 2 1 4866 BUF1 $T=1073840 497840 0 0 $X=1073840 $Y=497460
X2342 42 2 1 41 BUF3 $T=282720 497840 1 0 $X=282720 $Y=492420
X2343 59 2 1 52 BUF3 $T=288300 487760 1 180 $X=284580 $Y=487380
X2344 192 2 1 1241 BUF3 $T=458800 457520 1 0 $X=458800 $Y=452100
X2345 226 2 1 205 BUF3 $T=478640 507920 1 180 $X=474920 $Y=507540
X2346 2775 2 1 2807 BUF3 $T=564820 386960 1 0 $X=564820 $Y=381540
X2347 3808 2 1 4777 BUF3 $T=1036020 457520 0 0 $X=1036020 $Y=457140
X2348 981 989 990 2 997 994 1 AO22 $T=231260 417200 0 0 $X=231260 $Y=416820
X2349 988 989 962 2 999 994 1 AO22 $T=231880 427280 0 0 $X=231880 $Y=426900
X2350 1024 10 979 2 1003 994 1 AO22 $T=239940 467600 0 180 $X=234980 $Y=462180
X2351 1018 10 975 2 995 8 1 AO22 $T=239940 477680 0 180 $X=234980 $Y=472260
X2352 1022 10 974 2 998 994 1 AO22 $T=240560 457520 0 180 $X=235600 $Y=452100
X2353 1027 10 993 2 1000 994 1 AO22 $T=241180 437360 1 180 $X=236220 $Y=436980
X2354 1035 10 980 2 1001 8 1 AO22 $T=241180 467600 1 180 $X=236220 $Y=467220
X2355 1075 989 986 2 947 1005 1 AO22 $T=241800 386960 0 180 $X=236840 $Y=381540
X2356 1046 989 970 2 1008 1005 1 AO22 $T=243660 397040 0 180 $X=238700 $Y=391620
X2357 1049 989 982 2 1014 994 1 AO22 $T=244280 417200 0 180 $X=239320 $Y=411780
X2358 1068 989 985 2 1012 1005 1 AO22 $T=246140 407120 1 180 $X=241180 $Y=406740
X2359 22 989 977 2 14 1005 1 AO22 $T=246760 366800 0 180 $X=241800 $Y=361380
X2360 1081 989 1048 2 19 1005 1 AO22 $T=252340 366800 1 180 $X=247380 $Y=366420
X2361 1094 10 1028 2 1061 8 1 AO22 $T=254200 497840 1 180 $X=249240 $Y=497460
X2362 1103 10 1040 2 1070 8 1 AO22 $T=257300 507920 0 180 $X=252340 $Y=502500
X2363 28 10 25 2 1084 8 1 AO22 $T=260400 507920 1 180 $X=255440 $Y=507540
X2364 1153 20 1139 2 1101 1005 1 AO22 $T=268460 397040 1 180 $X=263500 $Y=396660
X2365 1170 989 1116 2 29 1005 1 AO22 $T=272180 376880 0 180 $X=267220 $Y=371460
X2366 1158 989 1135 2 1095 1005 1 AO22 $T=272180 386960 0 180 $X=267220 $Y=381540
X2367 1172 20 1124 2 1134 1005 1 AO22 $T=272800 386960 1 180 $X=267840 $Y=386580
X2368 1188 1147 10 2 1129 8 1 AO22 $T=275900 497840 1 180 $X=270940 $Y=497460
X2369 40 10 1150 2 1126 8 1 AO22 $T=275900 507920 1 180 $X=270940 $Y=507540
X2370 1198 1146 989 2 36 1005 1 AO22 $T=279000 366800 0 180 $X=274040 $Y=361380
X2371 1201 989 1195 2 1121 1005 1 AO22 $T=281480 376880 0 180 $X=276520 $Y=371460
X2372 1155 1206 38 2 1214 1204 1 AO22 $T=283960 376880 0 0 $X=283960 $Y=376500
X2373 1197 1204 1221 2 1224 38 1 AO22 $T=286440 407120 1 0 $X=286440 $Y=401700
X2374 1181 38 1252 2 1256 1204 1 AO22 $T=293260 397040 1 0 $X=293260 $Y=391620
X2375 1251 38 1260 2 1283 1204 1 AO22 $T=298220 376880 0 0 $X=298220 $Y=376500
X2376 1202 1277 80 2 1261 83 1 AO22 $T=301940 507920 1 0 $X=301940 $Y=502500
X2377 1287 38 1337 2 1328 1204 1 AO22 $T=311240 386960 1 0 $X=311240 $Y=381540
X2378 1358 38 1331 2 1324 1204 1 AO22 $T=316820 397040 0 180 $X=311860 $Y=391620
X2379 1376 38 1352 2 1349 1204 1 AO22 $T=319300 397040 1 180 $X=314340 $Y=396660
X2380 1375 1340 90 2 91 96 1 AO22 $T=320540 366800 0 0 $X=320540 $Y=366420
X2381 1416 83 1390 2 1392 80 1 AO22 $T=327980 497840 0 180 $X=323020 $Y=492420
X2382 1419 90 1373 2 95 96 1 AO22 $T=328600 376880 0 180 $X=323640 $Y=371460
X2383 1459 38 1410 2 1330 1403 1 AO22 $T=331080 417200 1 180 $X=326120 $Y=416820
X2384 1445 1432 1369 2 1367 1403 1 AO22 $T=332320 437360 0 180 $X=327360 $Y=431940
X2385 1446 1432 1426 2 1383 1403 1 AO22 $T=332320 447440 1 180 $X=327360 $Y=447060
X2386 1474 90 1438 2 98 96 1 AO22 $T=334180 376880 0 180 $X=329220 $Y=371460
X2387 1469 1432 1418 2 1348 1403 1 AO22 $T=335420 457520 0 180 $X=330460 $Y=452100
X2388 1470 1432 1443 2 1347 83 1 AO22 $T=337280 477680 1 180 $X=332320 $Y=477300
X2389 1503 80 1427 2 1384 83 1 AO22 $T=337900 507920 1 180 $X=332940 $Y=507540
X2390 1497 1432 1441 2 1386 1403 1 AO22 $T=339140 457520 1 180 $X=334180 $Y=457140
X2391 1483 1432 1462 2 1380 83 1 AO22 $T=339140 467600 0 180 $X=334180 $Y=462180
X2392 1590 1660 1666 2 1672 1607 1 AO22 $T=369520 407120 1 0 $X=369520 $Y=401700
X2393 118 1676 1662 2 1680 1689 1 AO22 $T=372000 507920 0 0 $X=372000 $Y=507540
X2394 1713 1607 1708 2 1700 1660 1 AO22 $T=381920 407120 0 180 $X=376960 $Y=401700
X2395 122 1676 1701 2 1711 1689 1 AO22 $T=376960 507920 0 0 $X=376960 $Y=507540
X2396 132 1676 1725 2 1754 1689 1 AO22 $T=392460 507920 1 180 $X=387500 $Y=507540
X2397 1775 1607 1763 2 1756 1660 1 AO22 $T=393080 407120 1 180 $X=388120 $Y=406740
X2398 1796 1676 1789 2 1780 1689 1 AO22 $T=396800 507920 0 180 $X=391840 $Y=502500
X2399 1850 1676 1809 2 1778 1689 1 AO22 $T=404240 487760 1 180 $X=399280 $Y=487380
X2400 1855 1826 1830 2 1816 1821 1 AO22 $T=404860 437360 0 180 $X=399900 $Y=431940
X2401 1808 1826 1834 2 1815 1660 1 AO22 $T=401140 417200 1 0 $X=401140 $Y=411780
X2402 1866 1676 1847 2 1782 1821 1 AO22 $T=406100 467600 1 180 $X=401140 $Y=467220
X2403 1902 1826 1879 2 1835 1660 1 AO22 $T=411060 407120 0 180 $X=406100 $Y=401700
X2404 1903 1826 1880 2 1790 1821 1 AO22 $T=411060 437360 0 180 $X=406100 $Y=431940
X2405 1904 1821 1759 2 1868 1826 1 AO22 $T=411060 447440 1 180 $X=406100 $Y=447060
X2406 1960 1826 1887 2 1786 1821 1 AO22 $T=416640 457520 0 180 $X=411680 $Y=452100
X2407 2006 1826 1990 2 1825 1660 1 AO22 $T=423460 407120 0 180 $X=418500 $Y=401700
X2408 2008 1826 1950 2 1804 1660 1 AO22 $T=424700 417200 1 180 $X=419740 $Y=416820
X2409 2047 107 2144 2 177 168 1 AO22 $T=450740 447440 1 0 $X=450740 $Y=442020
X2410 2396 233 2351 2 2321 2271 1 AO22 $T=505920 407120 0 180 $X=500960 $Y=401700
X2411 2420 233 2374 2 2325 251 1 AO22 $T=509020 417200 0 180 $X=504060 $Y=411780
X2412 2416 233 252 2 243 251 1 AO22 $T=509020 507920 1 180 $X=504060 $Y=507540
X2413 2427 233 2358 2 2314 251 1 AO22 $T=509640 417200 1 180 $X=504680 $Y=416820
X2414 2430 233 2401 2 2363 251 1 AO22 $T=512120 467600 0 180 $X=507160 $Y=462180
X2415 2438 233 2395 2 2334 251 1 AO22 $T=513360 457520 0 180 $X=508400 $Y=452100
X2416 2443 233 2406 2 2332 251 1 AO22 $T=514600 447440 1 180 $X=509640 $Y=447060
X2417 2436 233 2402 2 2353 251 1 AO22 $T=514600 477680 0 180 $X=509640 $Y=472260
X2418 2437 233 2407 2 2328 251 1 AO22 $T=514600 507920 0 180 $X=509640 $Y=502500
X2419 2445 233 2409 2 2360 251 1 AO22 $T=515220 427280 0 180 $X=510260 $Y=421860
X2420 2446 233 2415 2 2343 251 1 AO22 $T=516460 437360 0 180 $X=511500 $Y=431940
X2421 2452 233 2421 2 2383 251 1 AO22 $T=517080 487760 1 180 $X=512120 $Y=487380
X2422 2467 233 2424 2 2368 251 1 AO22 $T=517700 497840 1 180 $X=512740 $Y=497460
X2423 2602 2480 2596 2 2583 2511 1 AO22 $T=540020 397040 1 180 $X=535060 $Y=396660
X2424 2598 2578 272 2 280 291 1 AO22 $T=538160 366800 0 0 $X=538160 $Y=366420
X2425 2661 288 2639 2 2638 285 1 AO22 $T=548080 497840 1 180 $X=543120 $Y=497460
X2426 2681 2480 2680 2 2632 2511 1 AO22 $T=555520 437360 0 180 $X=550560 $Y=431940
X2427 2722 288 2701 2 2653 2511 1 AO22 $T=558620 457520 0 180 $X=553660 $Y=452100
X2428 2730 288 2708 2 2621 285 1 AO22 $T=559240 497840 1 180 $X=554280 $Y=497460
X2429 2720 2480 2713 2 2628 2511 1 AO22 $T=560480 437360 0 180 $X=555520 $Y=431940
X2430 2690 2480 2716 2 2629 2511 1 AO22 $T=558620 397040 1 0 $X=558620 $Y=391620
X2431 2668 272 2725 2 2625 2511 1 AO22 $T=561100 376880 1 0 $X=561100 $Y=371460
X2432 327 2938 2936 2 2942 2859 1 AO22 $T=598920 497840 1 180 $X=593960 $Y=497460
X2433 2937 2938 2943 2 2950 2859 1 AO22 $T=593960 507920 0 0 $X=593960 $Y=507540
X2434 348 2938 3001 2 3027 2859 1 AO22 $T=615040 507920 0 180 $X=610080 $Y=502500
X2435 3057 2938 3047 2 3010 2859 1 AO22 $T=615660 487760 1 180 $X=610700 $Y=487380
X2436 341 2938 3043 2 3024 2859 1 AO22 $T=617520 497840 1 180 $X=612560 $Y=497460
X2437 3068 331 3054 2 3053 330 1 AO22 $T=618760 397040 1 180 $X=613800 $Y=396660
X2438 3109 2938 3079 2 3056 2859 1 AO22 $T=623720 467600 1 180 $X=618760 $Y=467220
X2439 3095 2938 3099 2 3030 2859 1 AO22 $T=624960 507920 1 180 $X=620000 $Y=507540
X2440 3134 331 3082 2 3076 330 1 AO22 $T=626200 397040 1 180 $X=621240 $Y=396660
X2441 3137 331 3091 2 3094 2859 1 AO22 $T=626820 417200 0 180 $X=621860 $Y=411780
X2442 3152 331 3140 2 3040 330 1 AO22 $T=629300 407120 1 180 $X=624340 $Y=406740
X2443 3154 2938 3130 2 3064 2859 1 AO22 $T=629300 457520 0 180 $X=624340 $Y=452100
X2444 3174 331 3158 2 3126 2859 1 AO22 $T=631780 427280 0 180 $X=626820 $Y=421860
X2445 3187 331 3097 2 3080 2859 1 AO22 $T=633640 447440 0 180 $X=628680 $Y=442020
X2446 3223 331 3161 2 3077 330 1 AO22 $T=638600 407120 0 180 $X=633640 $Y=401700
X2447 3219 331 3199 2 3092 2859 1 AO22 $T=639840 417200 1 180 $X=634880 $Y=416820
X2448 3191 331 3200 2 3103 2859 1 AO22 $T=640460 427280 1 180 $X=635500 $Y=426900
X2449 3248 331 3206 2 3104 2859 1 AO22 $T=641080 447440 0 180 $X=636120 $Y=442020
X2450 3245 2938 3186 2 3067 2859 1 AO22 $T=641080 457520 0 180 $X=636120 $Y=452100
X2451 3182 3394 3412 2 398 389 1 AO22 $T=668980 427280 0 0 $X=668980 $Y=426900
X2452 487 482 3591 2 3506 477 1 AO22 $T=718580 507920 1 180 $X=713620 $Y=507540
X2453 489 482 3603 2 3523 477 1 AO22 $T=721060 497840 0 180 $X=716100 $Y=492420
X2454 494 482 3610 2 3510 477 1 AO22 $T=722920 477680 1 180 $X=717960 $Y=477300
X2455 497 482 3614 2 3511 477 1 AO22 $T=727260 487760 1 180 $X=722300 $Y=487380
X2456 3768 581 3819 2 583 574 1 AO22 $T=775620 507920 0 0 $X=775620 $Y=507540
X2457 3846 581 590 2 591 574 1 AO22 $T=788640 507920 0 0 $X=788640 $Y=507540
X2458 3798 581 3874 2 593 574 1 AO22 $T=789260 507920 1 0 $X=789260 $Y=502500
X2459 3946 482 3959 2 3920 477 1 AO22 $T=809100 467600 0 0 $X=809100 $Y=467220
X2460 3970 482 3962 2 3793 477 1 AO22 $T=814680 457520 1 180 $X=809720 $Y=457140
X2461 621 482 3975 2 3964 477 1 AO22 $T=817780 467600 0 180 $X=812820 $Y=462180
X2462 3902 581 3971 2 623 624 1 AO22 $T=816540 507920 0 0 $X=816540 $Y=507540
X2463 632 482 3999 2 3903 477 1 AO22 $T=825220 467600 0 180 $X=820260 $Y=462180
X2464 3951 581 626 2 630 624 1 AO22 $T=821500 507920 0 0 $X=821500 $Y=507540
X2465 628 631 3998 2 4004 639 1 AO22 $T=823980 366800 1 0 $X=823980 $Y=361380
X2466 3987 635 4021 2 638 624 1 AO22 $T=825220 507920 1 0 $X=825220 $Y=502500
X2467 4052 635 4044 2 644 624 1 AO22 $T=835140 507920 0 180 $X=830180 $Y=502500
X2468 4033 631 4036 2 4030 639 1 AO22 $T=831420 397040 0 0 $X=831420 $Y=396660
X2469 3989 536 3766 2 398 379 1 AO22 $T=832660 477680 0 0 $X=832660 $Y=477300
X2470 4029 635 4058 2 655 624 1 AO22 $T=835140 507920 1 0 $X=835140 $Y=502500
X2471 658 482 4074 2 3963 477 1 AO22 $T=838860 457520 0 0 $X=838860 $Y=457140
X2472 4064 631 4081 2 4068 639 1 AO22 $T=841340 397040 0 0 $X=841340 $Y=396660
X2473 4084 635 4082 2 665 624 1 AO22 $T=846300 507920 0 180 $X=841340 $Y=502500
X2474 670 482 4063 2 3941 477 1 AO22 $T=847540 467600 1 180 $X=842580 $Y=467220
X2475 673 482 4087 2 3904 477 1 AO22 $T=851260 457520 1 180 $X=846300 $Y=457140
X2476 4110 631 4102 2 4095 639 1 AO22 $T=853120 397040 1 180 $X=848160 $Y=396660
X2477 671 631 4106 2 674 639 1 AO22 $T=849400 366800 0 0 $X=849400 $Y=366420
X2478 677 482 4105 2 3894 477 1 AO22 $T=854360 467600 0 180 $X=849400 $Y=462180
X2479 678 482 4112 2 3892 477 1 AO22 $T=855600 467600 1 180 $X=850640 $Y=467220
X2480 4128 635 676 2 675 624 1 AO22 $T=856840 507920 1 180 $X=851880 $Y=507540
X2481 682 482 4121 2 3957 477 1 AO22 $T=858700 457520 1 180 $X=853740 $Y=457140
X2482 4155 549 4161 2 4159 694 1 AO22 $T=863040 427280 0 0 $X=863040 $Y=426900
X2483 4148 631 4170 2 4172 639 1 AO22 $T=864280 397040 0 0 $X=864280 $Y=396660
X2484 702 482 4189 2 3852 477 1 AO22 $T=875440 467600 0 180 $X=870480 $Y=462180
X2485 701 482 4194 2 3797 477 1 AO22 $T=876060 457520 0 180 $X=871100 $Y=452100
X2486 704 482 4195 2 3820 477 1 AO22 $T=876060 457520 1 180 $X=871100 $Y=457140
X2487 703 482 4197 2 3812 477 1 AO22 $T=876680 467600 1 180 $X=871720 $Y=467220
X2488 4216 549 4200 2 4199 694 1 AO22 $T=877920 427280 1 180 $X=872960 $Y=426900
X2489 705 482 4204 2 3750 477 1 AO22 $T=879160 477680 0 180 $X=874200 $Y=472260
X2490 706 482 4205 2 3860 477 1 AO22 $T=879160 487760 0 180 $X=874200 $Y=482340
X2491 4193 631 4207 2 4210 639 1 AO22 $T=875440 397040 0 0 $X=875440 $Y=396660
X2492 4201 549 4220 2 4017 694 1 AO22 $T=881020 427280 0 0 $X=881020 $Y=426900
X2493 4245 631 4227 2 4223 639 1 AO22 $T=887220 397040 1 180 $X=882260 $Y=396660
X2494 4218 549 4259 2 4267 694 1 AO22 $T=890940 417200 0 0 $X=890940 $Y=416820
X2495 4283 549 4276 2 4060 694 1 AO22 $T=900860 417200 1 180 $X=895900 $Y=416820
X2496 4273 549 4275 2 4221 694 1 AO22 $T=896520 386960 0 0 $X=896520 $Y=386580
X2497 4277 549 4284 2 737 694 1 AO22 $T=898380 376880 1 0 $X=898380 $Y=371460
X2498 4298 549 4287 2 4130 694 1 AO22 $T=905820 417200 1 180 $X=900860 $Y=416820
X2499 745 549 4294 2 741 694 1 AO22 $T=907060 366800 1 180 $X=902100 $Y=366420
X2500 4396 782 4407 2 4416 786 1 AO22 $T=928760 437360 0 0 $X=928760 $Y=436980
X2501 4391 782 4413 2 4410 786 1 AO22 $T=929380 427280 1 0 $X=929380 $Y=421860
X2502 4431 782 4456 2 798 786 1 AO22 $T=940540 366800 0 0 $X=940540 $Y=366420
X2503 776 796 797 2 799 800 1 AO22 $T=941160 507920 1 0 $X=941160 $Y=502500
X2504 4415 782 4467 2 4476 786 1 AO22 $T=944880 397040 0 0 $X=944880 $Y=396660
X2505 4436 796 4472 2 803 800 1 AO22 $T=945500 497840 0 0 $X=945500 $Y=497460
X2506 4422 782 4475 2 4480 786 1 AO22 $T=946120 386960 1 0 $X=946120 $Y=381540
X2507 4468 782 4485 2 4470 786 1 AO22 $T=948600 437360 0 0 $X=948600 $Y=436980
X2508 4385 796 4490 2 810 800 1 AO22 $T=951700 497840 0 0 $X=951700 $Y=497460
X2509 4457 796 4549 2 820 800 1 AO22 $T=966580 497840 0 0 $X=966580 $Y=497460
X2510 4525 782 4547 2 4545 786 1 AO22 $T=967820 447440 1 0 $X=967820 $Y=442020
X2511 4571 785 4553 2 398 4313 1 AO22 $T=975260 467600 1 180 $X=970300 $Y=467220
X2512 4512 796 4566 2 828 800 1 AO22 $T=971540 497840 0 0 $X=971540 $Y=497460
X2513 4562 782 4580 2 4583 786 1 AO22 $T=974020 376880 0 0 $X=974020 $Y=376500
X2514 4593 782 4582 2 4576 786 1 AO22 $T=979600 447440 0 180 $X=974640 $Y=442020
X2515 4591 796 4592 2 831 800 1 AO22 $T=981460 497840 1 180 $X=976500 $Y=497460
X2516 4567 782 4581 2 4598 786 1 AO22 $T=977120 397040 1 0 $X=977120 $Y=391620
X2517 4573 4608 4622 2 838 800 1 AO22 $T=986420 497840 0 0 $X=986420 $Y=497460
X2518 4649 4608 4635 2 844 800 1 AO22 $T=998820 497840 1 180 $X=993860 $Y=497460
X2519 4667 4608 847 2 846 800 1 AO22 $T=1005640 497840 1 180 $X=1000680 $Y=497460
X2520 4743 867 4732 2 866 832 1 AO22 $T=1032300 507920 1 180 $X=1027340 $Y=507540
X2521 4795 867 4783 2 868 832 1 AO22 $T=1044700 507920 0 180 $X=1039740 $Y=502500
X2522 4823 867 4812 2 883 832 1 AO22 $T=1055240 507920 0 180 $X=1050280 $Y=502500
X2523 944 942 960 965 2 1 MXL2HS $T=221960 487760 0 0 $X=221960 $Y=487380
X2524 973 952 985 991 2 1 MXL2HS $T=228160 407120 1 0 $X=228160 $Y=401700
X2525 1394 1405 1441 1398 2 1 MXL2HS $T=328600 467600 1 0 $X=328600 $Y=462180
X2526 1421 1447 1473 1430 2 1 MXL2HS $T=338520 497840 1 0 $X=338520 $Y=492420
X2527 1541 1543 1585 1576 2 1 MXL2HS $T=350300 497840 1 0 $X=350300 $Y=492420
X2528 1613 1635 1618 1610 2 1 MXL2HS $T=364560 427280 1 180 $X=358980 $Y=426900
X2529 1889 1921 1898 1975 2 1 MXL2HS $T=412920 497840 1 0 $X=412920 $Y=492420
X2530 2088 2041 2031 2063 2 1 MXL2HS $T=437100 457520 1 180 $X=431520 $Y=457140
X2531 1895 2076 2065 2032 2 1 MXL2HS $T=435240 497840 0 0 $X=435240 $Y=497460
X2532 2107 2024 1985 2123 2 1 MXL2HS $T=437720 487760 1 0 $X=437720 $Y=482340
X2533 2191 2193 2203 2213 2 1 MXL2HS $T=468100 397040 0 0 $X=468100 $Y=396660
X2534 2454 2458 2474 2484 2 1 MXL2HS $T=516460 417200 0 0 $X=516460 $Y=416820
X2535 2652 2647 2672 2687 2 1 MXL2HS $T=545600 487760 1 0 $X=545600 $Y=482340
X2536 2818 2824 2839 2804 2 1 MXL2HS $T=574120 477680 0 0 $X=574120 $Y=477300
X2537 2797 2600 2896 2904 2 1 MXL2HS $T=584040 386960 1 0 $X=584040 $Y=381540
X2538 3754 3747 3739 3718 2 1 MXL2HS $T=763840 487760 1 180 $X=758260 $Y=487380
X2539 3824 3813 3778 3809 2 1 MXL2HS $T=780580 487760 1 180 $X=775000 $Y=487380
X2540 4037 4011 3973 4025 2 1 MXL2HS $T=832660 487760 1 180 $X=827080 $Y=487380
X2541 4603 4589 4542 4618 2 1 MXL2HS $T=983320 497840 1 0 $X=983320 $Y=492420
X2542 4613 4599 4621 4623 2 1 MXL2HS $T=985180 487760 0 0 $X=985180 $Y=487380
X2543 4136 1 2 4154 DELA $T=858700 386960 1 0 $X=858700 $Y=381540
X2544 13 12 5 2 1 969 QDFFRBN $T=238700 507920 1 180 $X=226920 $Y=507540
X2545 1471 101 1523 2 1 1545 QDFFRBN $T=334800 407120 1 0 $X=334800 $Y=401700
X2546 1486 101 1523 2 1 1557 QDFFRBN $T=336660 397040 1 0 $X=336660 $Y=391620
X2547 1517 101 1523 2 1 1588 QDFFRBN $T=341620 376880 0 0 $X=341620 $Y=376500
X2548 1621 101 1523 2 1 1684 QDFFRBN $T=362080 386960 0 0 $X=362080 $Y=386580
X2549 1691 101 1523 2 1 1726 QDFFRBN $T=375720 386960 0 0 $X=375720 $Y=386580
X2550 1730 101 1523 2 1 1801 QDFFRBN $T=385640 376880 0 0 $X=385640 $Y=376500
X2551 1798 101 1523 2 1 1872 QDFFRBN $T=396180 376880 1 0 $X=396180 $Y=371460
X2552 1841 101 1523 2 1 1927 QDFFRBN $T=401140 386960 0 0 $X=401140 $Y=386580
X2553 1995 151 1523 2 1 1946 QDFFRBN $T=428420 376880 0 180 $X=416640 $Y=371460
X2554 2000 101 1523 2 1 1953 QDFFRBN $T=433380 386960 1 180 $X=421600 $Y=386580
X2555 2116 151 1523 2 1 2013 QDFFRBN $T=442060 366800 1 180 $X=430280 $Y=366420
X2556 2052 101 1523 2 1 2091 QDFFRBN $T=432140 386960 1 0 $X=432140 $Y=381540
X2557 2131 101 160 2 1 159 QDFFRBN $T=446400 507920 1 180 $X=434620 $Y=507540
X2558 2151 101 1523 2 1 2104 QDFFRBN $T=450120 386960 1 180 $X=438340 $Y=386580
X2559 171 151 163 2 1 2111 QDFFRBN $T=451360 366800 0 180 $X=439580 $Y=361380
X2560 2028 101 160 2 1 173 QDFFRBN $T=440200 497840 1 0 $X=440200 $Y=492420
X2561 2109 151 1523 2 1 2126 QDFFRBN $T=442060 376880 1 0 $X=442060 $Y=371460
X2562 2106 101 160 2 1 169 QDFFRBN $T=443300 467600 0 0 $X=443300 $Y=467220
X2563 2080 101 160 2 1 166 QDFFRBN $T=445160 477680 1 0 $X=445160 $Y=472260
X2564 2026 101 160 2 1 181 QDFFRBN $T=449500 487760 0 0 $X=449500 $Y=487380
X2565 2055 101 160 2 1 2162 QDFFRBN $T=450120 457520 0 0 $X=450120 $Y=457140
X2566 2074 101 160 2 1 172 QDFFRBN $T=450740 487760 1 0 $X=450740 $Y=482340
X2567 2170 101 1523 2 1 2152 QDFFRBN $T=464380 427280 0 180 $X=452600 $Y=421860
X2568 1937 101 1523 2 1 2147 QDFFRBN $T=453220 437360 0 0 $X=453220 $Y=436980
X2569 2146 101 1523 2 1 2165 QDFFRBN $T=453840 427280 0 0 $X=453840 $Y=426900
X2570 180 185 1523 2 1 2180 QDFFRBN $T=454460 477680 0 0 $X=454460 $Y=477300
X2571 2030 101 1523 2 1 2144 QDFFRBN $T=467480 447440 0 180 $X=455700 $Y=442020
X2572 2048 101 160 2 1 2158 QDFFRBN $T=455700 447440 0 0 $X=455700 $Y=447060
X2573 186 185 1523 2 1 2140 QDFFRBN $T=455700 497840 1 0 $X=455700 $Y=492420
X2574 2156 185 1523 2 1 2163 QDFFRBN $T=461280 487760 0 0 $X=461280 $Y=487380
X2575 2173 185 160 2 1 222 QDFFRBN $T=462520 497840 0 0 $X=462520 $Y=497460
X2576 2174 185 160 2 1 220 QDFFRBN $T=463140 507920 0 0 $X=463140 $Y=507540
X2577 2178 185 160 2 1 2278 QDFFRBN $T=473060 507920 1 0 $X=473060 $Y=502500
X2578 2137 185 160 2 1 2340 QDFFRBN $T=484840 507920 1 0 $X=484840 $Y=502500
X2579 2773 298 301 2 1 2827 QDFFRBN $T=564200 407120 1 0 $X=564200 $Y=401700
X2580 2783 298 301 2 1 2832 QDFFRBN $T=565440 386960 0 0 $X=565440 $Y=386580
X2581 2795 298 301 2 1 2842 QDFFRBN $T=567300 376880 1 0 $X=567300 $Y=371460
X2582 2796 298 301 2 1 2865 QDFFRBN $T=570400 417200 1 0 $X=570400 $Y=411780
X2583 2914 298 301 2 1 2999 QDFFRBN $T=593340 366800 0 0 $X=593340 $Y=366420
X2584 328 298 336 2 1 340 QDFFRBN $T=598920 507920 0 0 $X=598920 $Y=507540
X2585 2986 298 301 2 1 3085 QDFFRBN $T=610700 376880 1 0 $X=610700 $Y=371460
X2586 3172 298 301 2 1 3093 QDFFRBN $T=633640 366800 1 180 $X=621860 $Y=366420
X2587 3167 298 301 2 1 3250 QDFFRBN $T=629920 376880 1 0 $X=629920 $Y=371460
X2588 3262 298 301 2 1 3342 QDFFRBN $T=641700 376880 1 0 $X=641700 $Y=371460
X2589 3279 298 387 2 1 3325 QDFFRBN $T=643560 497840 1 0 $X=643560 $Y=492420
X2590 3276 298 387 2 1 3377 QDFFRBN $T=650380 487760 0 0 $X=650380 $Y=487380
X2591 3259 298 387 2 1 395 QDFFRBN $T=650380 507920 0 0 $X=650380 $Y=507540
X2592 392 393 387 2 1 402 QDFFRBN $T=659060 507920 1 0 $X=659060 $Y=502500
X2593 3411 298 301 2 1 3368 QDFFRBN $T=672080 376880 0 180 $X=660300 $Y=371460
X2594 3382 298 387 2 1 3391 QDFFRBN $T=662160 487760 0 0 $X=662160 $Y=487380
X2595 396 298 301 2 1 3393 QDFFRBN $T=664020 366800 1 0 $X=664020 $Y=361380
X2596 3398 298 387 2 1 3426 QDFFRBN $T=665880 487760 1 0 $X=665880 $Y=482340
X2597 3402 298 3424 2 1 3403 QDFFRBN $T=668980 437360 0 0 $X=668980 $Y=436980
X2598 3413 298 3424 2 1 3410 QDFFRBN $T=670220 447440 0 0 $X=670220 $Y=447060
X2599 403 393 387 2 1 418 QDFFRBN $T=670220 497840 0 0 $X=670220 $Y=497460
X2600 3419 298 387 2 1 3421 QDFFRBN $T=671460 477680 0 0 $X=671460 $Y=477300
X2601 3406 298 3424 2 1 3438 QDFFRBN $T=672700 407120 1 0 $X=672700 $Y=401700
X2602 3404 409 301 2 1 3452 QDFFRBN $T=673940 376880 0 0 $X=673940 $Y=376500
X2603 3416 409 301 2 1 3451 QDFFRBN $T=673940 386960 0 0 $X=673940 $Y=386580
X2604 3427 298 3424 2 1 3412 QDFFRBN $T=673940 427280 0 0 $X=673940 $Y=426900
X2605 3414 298 3424 2 1 3425 QDFFRBN $T=674560 447440 1 0 $X=674560 $Y=442020
X2606 3429 393 3424 2 1 3432 QDFFRBN $T=675800 467600 0 0 $X=675800 $Y=467220
X2607 3359 298 3424 2 1 3431 QDFFRBN $T=677660 427280 1 0 $X=677660 $Y=421860
X2608 3418 298 3424 2 1 3447 QDFFRBN $T=678280 417200 0 0 $X=678280 $Y=416820
X2609 3435 393 387 2 1 430 QDFFRBN $T=678280 487760 0 0 $X=678280 $Y=487380
X2610 416 409 404 2 1 3473 QDFFRBN $T=678900 366800 1 0 $X=678900 $Y=361380
X2611 417 393 387 2 1 433 QDFFRBN $T=678900 497840 1 0 $X=678900 $Y=492420
X2612 3379 393 387 2 1 3468 QDFFRBN $T=680140 477680 1 0 $X=680140 $Y=472260
X2613 3441 393 387 2 1 3472 QDFFRBN $T=681380 487760 1 0 $X=681380 $Y=482340
X2614 3444 409 404 2 1 3484 QDFFRBN $T=682000 376880 1 0 $X=682000 $Y=371460
X2615 420 409 3424 2 1 3475 QDFFRBN $T=682000 407120 0 0 $X=682000 $Y=406740
X2616 421 393 387 2 1 440 QDFFRBN $T=682000 497840 0 0 $X=682000 $Y=497460
X2617 3386 393 3424 2 1 3476 QDFFRBN $T=682620 457520 0 0 $X=682620 $Y=457140
X2618 3430 409 3424 2 1 3500 QDFFRBN $T=686340 407120 1 0 $X=686340 $Y=401700
X2619 3453 393 3424 2 1 3495 QDFFRBN $T=686340 447440 0 0 $X=686340 $Y=447060
X2620 3456 393 3424 2 1 3498 QDFFRBN $T=686960 447440 1 0 $X=686960 $Y=442020
X2621 3457 393 3424 2 1 3502 QDFFRBN $T=686960 457520 1 0 $X=686960 $Y=452100
X2622 3458 409 3424 2 1 3517 QDFFRBN $T=687580 386960 0 0 $X=687580 $Y=386580
X2623 3466 409 3424 2 1 3525 QDFFRBN $T=690060 397040 0 0 $X=690060 $Y=396660
X2624 3481 409 3424 2 1 3544 QDFFRBN $T=694400 407120 0 0 $X=694400 $Y=406740
X2625 3423 409 3424 2 1 3566 QDFFRBN $T=698740 417200 1 0 $X=698740 $Y=411780
X2626 3634 500 493 2 1 488 QDFFRBN $T=731600 507920 1 180 $X=719820 $Y=507540
X2627 3660 500 493 2 1 3615 QDFFRBN $T=738420 497840 1 180 $X=726640 $Y=497460
X2628 3663 500 3424 2 1 3630 QDFFRBN $T=739040 447440 1 180 $X=727260 $Y=447060
X2629 520 500 493 2 1 3632 QDFFRBN $T=740900 487760 1 180 $X=729120 $Y=487380
X2630 3641 298 493 2 1 3655 QDFFRBN $T=731600 497840 1 0 $X=731600 $Y=492420
X2631 3677 500 493 2 1 3642 QDFFRBN $T=744000 487760 0 180 $X=732220 $Y=482340
X2632 3576 500 493 2 1 3580 QDFFRBN $T=746480 477680 0 180 $X=734700 $Y=472260
X2633 3678 500 493 2 1 3666 QDFFRBN $T=750200 467600 1 180 $X=738420 $Y=467220
X2634 3712 298 493 2 1 3675 QDFFRBN $T=753920 477680 1 180 $X=742140 $Y=477300
X2635 3726 500 493 2 1 3685 QDFFRBN $T=757640 467600 0 180 $X=745860 $Y=462180
X2636 3756 500 493 2 1 3714 QDFFRBN $T=764460 457520 1 180 $X=752680 $Y=457140
X2637 3770 500 493 2 1 3724 QDFFRBN $T=767560 447440 1 180 $X=755780 $Y=447060
X2638 3771 298 493 2 1 3689 QDFFRBN $T=767560 477680 0 180 $X=755780 $Y=472260
X2639 3823 298 576 2 1 3701 QDFFRBN $T=780580 467600 1 180 $X=768800 $Y=467220
X2640 3858 298 576 2 1 3706 QDFFRBN $T=787400 457520 1 180 $X=775620 $Y=457140
X2641 3947 298 576 2 1 3707 QDFFRBN $T=809720 457520 1 180 $X=797940 $Y=457140
X2642 4003 298 576 2 1 3766 QDFFRBN $T=822740 477680 1 0 $X=822740 $Y=472260
X2643 4027 298 576 2 1 3751 QDFFRBN $T=828320 467600 0 0 $X=828320 $Y=467220
X2644 4119 298 576 2 1 3777 QDFFRBN $T=856220 477680 0 180 $X=844440 $Y=472260
X2645 4098 298 576 2 1 3937 QDFFRBN $T=849400 477680 0 0 $X=849400 $Y=477300
X2646 699 696 688 2 1 4149 QDFFRBN $T=873580 437360 0 180 $X=861800 $Y=431940
X2647 4166 696 576 2 1 4147 QDFFRBN $T=885360 497840 1 180 $X=873580 $Y=497460
X2648 4201 696 688 2 1 4237 QDFFRBN $T=875440 437360 1 0 $X=875440 $Y=431940
X2649 4202 696 688 2 1 717 QDFFRBN $T=875440 447440 1 0 $X=875440 $Y=442020
X2650 726 696 688 2 1 711 QDFFRBN $T=894660 437360 1 180 $X=882880 $Y=436980
X2651 4192 696 576 2 1 4230 QDFFRBN $T=899000 497840 0 180 $X=887220 $Y=492420
X2652 738 696 688 2 1 723 QDFFRBN $T=902720 447440 0 180 $X=890940 $Y=442020
X2653 4229 696 688 2 1 739 QDFFRBN $T=891560 437360 1 0 $X=891560 $Y=431940
X2654 4266 696 688 2 1 4292 QDFFRBN $T=893420 397040 1 0 $X=893420 $Y=391620
X2655 4257 696 576 2 1 4297 QDFFRBN $T=893420 497840 0 0 $X=893420 $Y=497460
X2656 4290 4288 576 2 1 4264 QDFFRBN $T=905820 487760 0 180 $X=894040 $Y=482340
X2657 742 696 688 2 1 728 QDFFRBN $T=906440 447440 1 180 $X=894660 $Y=447060
X2658 4301 4288 576 2 1 4226 QDFFRBN $T=907060 477680 0 180 $X=895280 $Y=472260
X2659 4272 696 688 2 1 4309 QDFFRBN $T=895900 376880 0 0 $X=895900 $Y=376500
X2660 4317 4288 688 2 1 4278 QDFFRBN $T=910160 457520 1 180 $X=898380 $Y=457140
X2661 4281 696 688 2 1 4316 QDFFRBN $T=899000 437360 0 0 $X=899000 $Y=436980
X2662 4285 696 576 2 1 4279 QDFFRBN $T=910780 497840 0 180 $X=899000 $Y=492420
X2663 4327 4288 688 2 1 4286 QDFFRBN $T=914500 467600 0 180 $X=902720 $Y=462180
X2664 750 4288 688 2 1 4289 QDFFRBN $T=915120 457520 0 180 $X=903340 $Y=452100
X2665 4335 696 743 2 1 4293 QDFFRBN $T=916360 507920 0 180 $X=904580 $Y=502500
X2666 4304 696 688 2 1 4326 QDFFRBN $T=905820 447440 1 0 $X=905820 $Y=442020
X2667 4349 4288 576 2 1 4242 QDFFRBN $T=919460 467600 1 180 $X=907680 $Y=467220
X2668 767 696 688 2 1 4320 QDFFRBN $T=920700 447440 1 180 $X=908920 $Y=447060
X2669 4388 4288 4352 2 1 4336 QDFFRBN $T=926900 457520 0 180 $X=915120 $Y=452100
X2670 4389 4288 4352 2 1 4322 QDFFRBN $T=928140 467600 0 180 $X=916360 $Y=462180
X2671 4409 4288 4352 2 1 4274 QDFFRBN $T=931240 467600 1 180 $X=919460 $Y=467220
X2672 4408 4288 4352 2 1 4339 QDFFRBN $T=931860 457520 1 180 $X=920080 $Y=457140
X2673 4355 696 4352 2 1 4406 QDFFRBN $T=920700 477680 0 0 $X=920700 $Y=477300
X2674 4430 4288 4352 2 1 4393 QDFFRBN $T=938060 447440 1 180 $X=926280 $Y=447060
X2675 4428 696 4352 2 1 4332 QDFFRBN $T=940540 487760 0 180 $X=928760 $Y=482340
X2676 4446 4288 4352 2 1 4411 QDFFRBN $T=942400 457520 0 180 $X=930620 $Y=452100
X2677 4464 4288 4352 2 1 4420 QDFFRBN $T=946120 467600 0 180 $X=934340 $Y=462180
X2678 4488 4288 4352 2 1 4452 QDFFRBN $T=954180 447440 1 180 $X=942400 $Y=447060
X2679 4498 696 804 2 1 4325 QDFFRBN $T=957280 477680 0 180 $X=945500 $Y=472260
X2680 4510 696 4352 2 1 4414 QDFFRBN $T=959760 487760 0 180 $X=947980 $Y=482340
X2681 4526 4288 804 2 1 4469 QDFFRBN $T=963480 457520 1 180 $X=951700 $Y=457140
X2682 4539 4288 804 2 1 4494 QDFFRBN $T=965960 467600 1 180 $X=954180 $Y=467220
X2683 4544 4288 804 2 1 4482 QDFFRBN $T=967200 457520 0 180 $X=955420 $Y=452100
X2684 4557 696 804 2 1 4434 QDFFRBN $T=971540 477680 0 180 $X=959760 $Y=472260
X2685 4614 696 804 2 1 4439 QDFFRBN $T=987660 457520 0 180 $X=975880 $Y=452100
X2686 4642 696 804 2 1 4609 QDFFRBN $T=996340 457520 1 180 $X=984560 $Y=457140
X2687 4701 696 804 2 1 4449 QDFFRBN $T=1020520 487760 0 180 $X=1008740 $Y=482340
X2688 4745 696 804 2 1 4477 QDFFRBN $T=1025480 457520 1 180 $X=1013700 $Y=457140
X2689 4681 696 804 2 1 4553 QDFFRBN $T=1026720 467600 0 180 $X=1014940 $Y=462180
X2690 4768 696 804 2 1 4746 QDFFRBN $T=1039120 467600 1 180 $X=1027340 $Y=467220
X2691 4818 696 804 2 1 4546 QDFFRBN $T=1050900 467600 0 180 $X=1039120 $Y=462180
X2692 4805 696 804 2 1 4683 QDFFRBN $T=1051520 457520 1 180 $X=1039740 $Y=457140
X2693 4837 696 804 2 1 4815 QDFFRBN $T=1064540 467600 1 180 $X=1052760 $Y=467220
X2694 4880 696 804 2 1 4863 QDFFRBN $T=1083760 467600 1 180 $X=1071980 $Y=467220
X2695 899 696 804 2 1 4865 QDFFRBN $T=1087480 507920 0 180 $X=1075700 $Y=502500
X2696 4155 696 688 560 1 2 QDFFRBP $T=878540 437360 1 180 $X=866140 $Y=436980
X2697 4244 696 688 735 1 2 QDFFRBP $T=889700 366800 1 0 $X=889700 $Y=361380
X2698 518 3639 3635 3483 2 1 490 XOR4 $T=740280 437360 1 180 $X=725400 $Y=436980
X2699 3652 3673 3651 499 2 1 510 XOR4 $T=746480 427280 1 180 $X=731600 $Y=426900
X2700 530 525 549 3699 2 1 553 XOR4 $T=745240 437360 1 0 $X=745240 $Y=431940
X2701 35 37 1 2 BUF2 $T=268460 497840 1 0 $X=268460 $Y=492420
X2702 57 38 1 2 BUF2 $T=280240 507920 1 180 $X=277140 $Y=507540
X2703 1211 67 1 2 BUF2 $T=289540 366800 1 0 $X=289540 $Y=361380
X2704 75 1211 1 2 BUF2 $T=296980 497840 1 0 $X=296980 $Y=492420
X2705 81 86 1 2 BUF2 $T=304420 366800 0 0 $X=304420 $Y=366420
X2706 1502 1579 1 2 BUF2 $T=350300 477680 1 0 $X=350300 $Y=472260
X2707 233 241 1 2 BUF2 $T=486700 397040 1 0 $X=486700 $Y=391620
X2708 311 2825 1 2 BUF2 $T=583420 487760 1 180 $X=580320 $Y=487380
X2709 318 2859 1 2 BUF2 $T=589000 507920 0 180 $X=585900 $Y=502500
X2710 177 398 1 2 BUF2 $T=667120 497840 1 0 $X=667120 $Y=492420
X2711 4341 4330 1 2 BUF2 $T=930620 366800 1 0 $X=930620 $Y=361380
X2712 111 108 1 2 BUF6 $T=365800 497840 1 180 $X=358360 $Y=497460
X2713 115 106 1 2 BUF6 $T=369520 507920 0 180 $X=362080 $Y=502500
X2714 114 113 1 2 BUF6 $T=373240 467600 1 180 $X=365800 $Y=467220
X2715 221 203 1 2 BUF6 $T=476160 497840 0 180 $X=468720 $Y=492420
X2716 18 17 1 2 INV3 $T=246760 507920 0 180 $X=244280 $Y=502500
X2717 121 123 1 2 BUF4 $T=375720 447440 0 0 $X=375720 $Y=447060
X2718 279 281 1 2 BUF4 $T=538780 457520 0 0 $X=538780 $Y=457140
X2719 309 302 1 2 BUF4 $T=581560 507920 1 0 $X=581560 $Y=502500
X2720 2825 316 1 2 BUF4 $T=584660 447440 1 0 $X=584660 $Y=442020
X2721 3388 2 2838 3336 3341 1 3414 FA1S $T=659680 447440 1 0 $X=659680 $Y=442020
X2722 3396 2 2814 3189 3375 1 3419 FA1S $T=661540 467600 0 0 $X=661540 $Y=467220
X2723 3664 2 537 3692 3690 1 3641 FA1S $T=750200 507920 0 180 $X=738420 $Y=502500
X2724 4697 2 4716 4691 4723 1 4681 FA1S $T=1023000 507920 0 180 $X=1011220 $Y=502500
X2725 1120 1101 1139 2 1 XNR2HS $T=262260 407120 0 0 $X=262260 $Y=406740
X2726 1036 1416 1576 2 1 XNR2HS $T=349060 487760 1 0 $X=349060 $Y=482340
X2727 1903 1947 1922 2 1 XNR2HS $T=416640 407120 1 180 $X=411060 $Y=406740
X2728 2428 2703 2800 2 1 XNR2HS $T=564820 487760 0 0 $X=564820 $Y=487380
X2729 531 532 3699 2 1 XNR2HS $T=745860 447440 1 0 $X=745860 $Y=442020
X2730 684 4191 4187 2 1 XNR2HS $T=879160 497840 0 180 $X=873580 $Y=492420
X2731 4591 4586 4618 2 1 XNR2HS $T=988900 497840 1 0 $X=988900 $Y=492420
X2732 834 4587 4623 2 1 XNR2HS $T=990760 487760 0 0 $X=990760 $Y=487380
X2733 946 948 962 2 1 XOR2HS $T=221960 427280 0 0 $X=221960 $Y=426900
X2734 951 961 970 2 1 XOR2HS $T=223820 397040 1 0 $X=223820 $Y=391620
X2735 957 937 974 2 1 XOR2HS $T=225680 457520 1 0 $X=225680 $Y=452100
X2736 958 940 975 2 1 XOR2HS $T=225680 477680 1 0 $X=225680 $Y=472260
X2737 959 941 976 2 1 XOR2HS $T=225680 477680 0 0 $X=225680 $Y=477300
X2738 966 3 977 2 1 XOR2HS $T=226300 366800 1 0 $X=226300 $Y=361380
X2739 956 949 978 2 1 XOR2HS $T=226300 447440 0 0 $X=226300 $Y=447060
X2740 963 938 979 2 1 XOR2HS $T=226300 457520 0 0 $X=226300 $Y=457140
X2741 964 939 980 2 1 XOR2HS $T=226300 467600 0 0 $X=226300 $Y=467220
X2742 945 943 982 2 1 XOR2HS $T=226920 417200 1 0 $X=226920 $Y=411780
X2743 967 968 986 2 1 XOR2HS $T=228160 386960 1 0 $X=228160 $Y=381540
X2744 972 955 987 2 1 XOR2HS $T=228160 497840 1 0 $X=228160 $Y=492420
X2745 971 953 990 2 1 XOR2HS $T=228780 427280 1 0 $X=228780 $Y=421860
X2746 983 954 993 2 1 XOR2HS $T=230020 437360 1 0 $X=230020 $Y=431940
X2747 1026 1020 1007 2 1 XOR2HS $T=241800 376880 1 180 $X=236220 $Y=376500
X2748 1011 950 1028 2 1 XOR2HS $T=237460 497840 0 0 $X=237460 $Y=497460
X2749 16 15 1040 2 1 XOR2HS $T=248000 507920 1 180 $X=242420 $Y=507540
X2750 1062 1053 1048 2 1 XOR2HS $T=249860 376880 1 180 $X=244280 $Y=376500
X2751 1104 1097 1116 2 1 XOR2HS $T=257300 376880 1 0 $X=257300 $Y=371460
X2752 1098 1112 1119 2 1 XOR2HS $T=257920 397040 1 0 $X=257920 $Y=391620
X2753 1105 1087 1124 2 1 XOR2HS $T=258540 386960 0 0 $X=258540 $Y=386580
X2754 1086 1108 1135 2 1 XOR2HS $T=261640 376880 0 0 $X=261640 $Y=376500
X2755 1129 1137 1147 2 1 XOR2HS $T=264120 497840 0 0 $X=264120 $Y=497460
X2756 1127 34 1150 2 1 XOR2HS $T=264740 507920 0 0 $X=264740 $Y=507540
X2757 36 1162 1146 2 1 XOR2HS $T=272180 366800 0 180 $X=266600 $Y=361380
X2758 1089 1193 1196 2 1 XOR2HS $T=275280 407120 0 0 $X=275280 $Y=406740
X2759 1175 1152 1195 2 1 XOR2HS $T=277140 366800 0 0 $X=277140 $Y=366420
X2760 1219 1200 1206 2 1 XOR2HS $T=288920 366800 1 180 $X=283340 $Y=366420
X2761 1207 1226 1174 2 1 XOR2HS $T=291400 417200 1 180 $X=285820 $Y=416820
X2762 1225 1230 1240 2 1 XOR2HS $T=288920 376880 0 0 $X=288920 $Y=376500
X2763 1251 1082 1230 2 1 XOR2HS $T=295740 376880 0 180 $X=290160 $Y=371460
X2764 1278 1245 1260 2 1 XOR2HS $T=300700 366800 1 180 $X=295120 $Y=366420
X2765 1253 1254 1224 2 1 XOR2HS $T=295740 407120 1 0 $X=295740 $Y=401700
X2766 1261 1266 1277 2 1 XOR2HS $T=295740 507920 1 0 $X=295740 $Y=502500
X2767 1282 1244 1252 2 1 XOR2HS $T=300080 397040 1 0 $X=300080 $Y=391620
X2768 1316 1310 1331 2 1 XOR2HS $T=308140 397040 0 0 $X=308140 $Y=396660
X2769 1323 1318 1337 2 1 XOR2HS $T=311240 376880 0 0 $X=311240 $Y=376500
X2770 91 1353 1340 2 1 XOR2HS $T=318680 366800 1 180 $X=313100 $Y=366420
X2771 1368 1341 1352 2 1 XOR2HS $T=321160 407120 1 180 $X=315580 $Y=406740
X2772 1354 1361 1373 2 1 XOR2HS $T=316820 376880 0 0 $X=316820 $Y=376500
X2773 1351 1344 94 2 1 XOR2HS $T=316820 507920 0 0 $X=316820 $Y=507540
X2774 1382 1379 1369 2 1 XOR2HS $T=323640 437360 0 180 $X=318060 $Y=431940
X2775 1388 1381 1410 2 1 XOR2HS $T=323020 417200 1 0 $X=323020 $Y=411780
X2776 1387 1397 1418 2 1 XOR2HS $T=324260 457520 1 0 $X=324260 $Y=452100
X2777 99 1428 97 2 1 XOR2HS $T=331700 366800 0 180 $X=326120 $Y=361380
X2778 1393 1404 1426 2 1 XOR2HS $T=327360 447440 1 0 $X=327360 $Y=442020
X2779 1407 1437 1392 2 1 XOR2HS $T=332940 487760 1 180 $X=327360 $Y=487380
X2780 1420 1415 1443 2 1 XOR2HS $T=327980 487760 1 0 $X=327980 $Y=482340
X2781 1401 1414 1462 2 1 XOR2HS $T=329840 467600 0 0 $X=329840 $Y=467220
X2782 1412 1422 1463 2 1 XOR2HS $T=329840 497840 0 0 $X=329840 $Y=497460
X2783 1409 1396 1438 2 1 XOR2HS $T=336660 376880 1 0 $X=336660 $Y=371460
X2784 1051 1493 1510 2 1 XOR2HS $T=336660 507920 1 0 $X=336660 $Y=502500
X2785 1009 1470 1516 2 1 XOR2HS $T=337900 487760 1 0 $X=337900 $Y=482340
X2786 1018 1498 1525 2 1 XOR2HS $T=339760 477680 1 0 $X=339760 $Y=472260
X2787 1035 1483 1534 2 1 XOR2HS $T=341000 467600 0 0 $X=341000 $Y=467220
X2788 1022 1469 1537 2 1 XOR2HS $T=341620 447440 0 0 $X=341620 $Y=447060
X2789 1027 1445 1542 2 1 XOR2HS $T=342240 437360 1 0 $X=342240 $Y=431940
X2790 1019 1446 1554 2 1 XOR2HS $T=344100 437360 0 0 $X=344100 $Y=436980
X2791 1536 1516 1558 2 1 XOR2HS $T=344720 477680 0 0 $X=344720 $Y=477300
X2792 1567 1196 1581 2 1 XOR2HS $T=349680 417200 0 0 $X=349680 $Y=416820
X2793 1593 1591 1567 2 1 XOR2HS $T=356500 417200 0 180 $X=350920 $Y=411780
X2794 1579 1525 1604 2 1 XOR2HS $T=353400 477680 1 0 $X=353400 $Y=472260
X2795 1511 1606 1621 2 1 XOR2HS $T=356500 386960 1 0 $X=356500 $Y=381540
X2796 1648 1637 1629 2 1 XOR2HS $T=368280 417200 0 180 $X=362700 $Y=411780
X2797 1220 1630 1606 2 1 XOR2HS $T=367040 386960 1 0 $X=367040 $Y=381540
X2798 1680 1677 1662 2 1 XOR2HS $T=375100 507920 0 180 $X=369520 $Y=502500
X2799 1658 1670 1681 2 1 XOR2HS $T=370760 366800 0 0 $X=370760 $Y=366420
X2800 1681 1692 1665 2 1 XOR2HS $T=378200 376880 0 180 $X=372620 $Y=371460
X2801 1679 1687 1672 2 1 XOR2HS $T=374480 407120 0 0 $X=374480 $Y=406740
X2802 1719 1716 1701 2 1 XOR2HS $T=382540 507920 0 180 $X=376960 $Y=502500
X2803 1741 1737 1725 2 1 XOR2HS $T=387500 507920 1 180 $X=381920 $Y=507540
X2804 1732 1728 1708 2 1 XOR2HS $T=383780 407120 1 0 $X=383780 $Y=401700
X2805 1750 1748 1734 2 1 XOR2HS $T=389360 497840 0 180 $X=383780 $Y=492420
X2806 1781 1742 1763 2 1 XOR2HS $T=394320 417200 0 180 $X=388740 $Y=411780
X2807 1793 1794 1809 2 1 XOR2HS $T=394320 487760 1 0 $X=394320 $Y=482340
X2808 1854 1848 1830 2 1 XOR2HS $T=405480 427280 0 180 $X=399900 $Y=421860
X2809 1852 1802 1834 2 1 XOR2HS $T=406100 407120 1 180 $X=400520 $Y=406740
X2810 1828 1819 1853 2 1 XOR2HS $T=400520 497840 1 0 $X=400520 $Y=492420
X2811 1839 139 1797 2 1 XOR2HS $T=406720 507920 1 180 $X=401140 $Y=507540
X2812 1827 1844 1847 2 1 XOR2HS $T=401760 477680 1 0 $X=401760 $Y=472260
X2813 1822 1824 1868 2 1 XOR2HS $T=402380 447440 1 0 $X=402380 $Y=442020
X2814 1843 1849 1887 2 1 XOR2HS $T=405480 457520 0 0 $X=405480 $Y=457140
X2815 1865 1873 1880 2 1 XOR2HS $T=406720 427280 0 0 $X=406720 $Y=426900
X2816 1871 1858 1840 2 1 XOR2HS $T=407960 507920 1 0 $X=407960 $Y=502500
X2817 1883 1890 1879 2 1 XOR2HS $T=408580 417200 1 0 $X=408580 $Y=411780
X2818 1906 1897 1950 2 1 XOR2HS $T=411680 417200 0 0 $X=411680 $Y=416820
X2819 1967 1959 1937 2 1 XOR2HS $T=417880 437360 0 180 $X=412300 $Y=431940
X2820 1934 1601 1972 2 1 XOR2HS $T=413540 447440 1 0 $X=413540 $Y=442020
X2821 1978 1910 1990 2 1 XOR2HS $T=419120 417200 1 0 $X=419120 $Y=411780
X2822 1568 1987 1959 2 1 XOR2HS $T=419120 437360 1 0 $X=419120 $Y=431940
X2823 2068 2064 1936 2 1 XOR2HS $T=434000 487760 1 180 $X=428420 $Y=487380
X2824 2067 2057 2084 2 1 XOR2HS $T=432140 417200 0 0 $X=432140 $Y=416820
X2825 2008 2069 2105 2 1 XOR2HS $T=436480 407120 0 0 $X=436480 $Y=406740
X2826 2077 2105 2117 2 1 XOR2HS $T=437100 407120 1 0 $X=437100 $Y=401700
X2827 1598 1999 2139 2 1 XOR2HS $T=444540 437360 1 0 $X=444540 $Y=431940
X2828 2139 2138 2146 2 1 XOR2HS $T=447020 427280 0 0 $X=447020 $Y=426900
X2829 2217 2211 2238 2 1 XOR2HS $T=473060 386960 1 0 $X=473060 $Y=381540
X2830 2212 2218 2244 2 1 XOR2HS $T=474300 386960 0 0 $X=474300 $Y=386580
X2831 2237 2205 2247 2 1 XOR2HS $T=475540 376880 0 0 $X=475540 $Y=376500
X2832 236 2304 2281 2 1 XOR2HS $T=490420 366800 0 180 $X=484840 $Y=361380
X2833 2228 2233 2312 2 1 XOR2HS $T=487320 397040 0 0 $X=487320 $Y=396660
X2834 2348 2341 2327 2 1 XOR2HS $T=499100 386960 1 180 $X=493520 $Y=386580
X2835 2324 2331 2351 2 1 XOR2HS $T=494760 407120 1 0 $X=494760 $Y=401700
X2836 2335 2338 2357 2 1 XOR2HS $T=495380 376880 1 0 $X=495380 $Y=371460
X2837 2355 2344 2374 2 1 XOR2HS $T=497860 407120 0 0 $X=497860 $Y=406740
X2838 2367 2377 2358 2 1 XOR2HS $T=503440 417200 1 180 $X=497860 $Y=416820
X2839 2354 2347 2384 2 1 XOR2HS $T=499100 376880 0 0 $X=499100 $Y=376500
X2840 2352 2361 2395 2 1 XOR2HS $T=501580 457520 1 0 $X=501580 $Y=452100
X2841 2375 2372 2398 2 1 XOR2HS $T=502200 457520 0 0 $X=502200 $Y=457140
X2842 2362 2364 2401 2 1 XOR2HS $T=502820 467600 0 0 $X=502820 $Y=467220
X2843 2373 2382 2402 2 1 XOR2HS $T=502820 477680 1 0 $X=502820 $Y=472260
X2844 2359 2378 2406 2 1 XOR2HS $T=503440 447440 0 0 $X=503440 $Y=447060
X2845 2386 2380 2407 2 1 XOR2HS $T=503440 507920 1 0 $X=503440 $Y=502500
X2846 2390 2387 2409 2 1 XOR2HS $T=504060 427280 0 0 $X=504060 $Y=426900
X2847 2365 2369 2415 2 1 XOR2HS $T=504680 437360 1 0 $X=504680 $Y=431940
X2848 2397 2394 2417 2 1 XOR2HS $T=505300 477680 0 0 $X=505300 $Y=477300
X2849 2392 2388 2421 2 1 XOR2HS $T=505920 497840 1 0 $X=505920 $Y=492420
X2850 2385 2379 2424 2 1 XOR2HS $T=506540 497840 0 0 $X=506540 $Y=497460
X2851 2393 2252 2425 2 1 XOR2HS $T=507160 376880 1 0 $X=507160 $Y=371460
X2852 246 256 257 2 1 XOR2HS $T=509640 507920 0 0 $X=509640 $Y=507540
X2853 2412 253 258 2 1 XOR2HS $T=510880 366800 1 0 $X=510880 $Y=361380
X2854 2284 2435 2451 2 1 XOR2HS $T=512740 417200 1 0 $X=512740 $Y=411780
X2855 2306 2487 2465 2 1 XOR2HS $T=522660 376880 0 180 $X=517080 $Y=371460
X2856 2534 2527 2496 2 1 XOR2HS $T=528240 386960 1 180 $X=522660 $Y=386580
X2857 2535 2528 2506 2 1 XOR2HS $T=526380 407120 1 0 $X=526380 $Y=401700
X2858 280 2563 2578 2 1 XOR2HS $T=531340 366800 1 0 $X=531340 $Y=361380
X2859 2584 2581 2540 2 1 XOR2HS $T=537540 376880 0 180 $X=531960 $Y=371460
X2860 2580 2572 2539 2 1 XOR2HS $T=537540 397040 0 180 $X=531960 $Y=391620
X2861 2610 2613 2582 2 1 XOR2HS $T=543120 397040 0 180 $X=537540 $Y=391620
X2862 2615 2605 2596 2 1 XOR2HS $T=543740 407120 0 180 $X=538160 $Y=401700
X2863 2601 2538 2643 2 1 XOR2HS $T=541260 386960 0 0 $X=541260 $Y=386580
X2864 293 292 2639 2 1 XOR2HS $T=548700 507920 0 180 $X=543120 $Y=502500
X2865 2650 2656 2680 2 1 XOR2HS $T=545600 427280 1 0 $X=545600 $Y=421860
X2866 2660 2669 2701 2 1 XOR2HS $T=548700 457520 0 0 $X=548700 $Y=457140
X2867 2657 2673 2713 2 1 XOR2HS $T=551800 437360 0 0 $X=551800 $Y=436980
X2868 2623 2614 2716 2 1 XOR2HS $T=553040 397040 1 0 $X=553040 $Y=391620
X2869 2702 2683 2715 2 1 XOR2HS $T=554280 467600 1 0 $X=554280 $Y=462180
X2870 295 294 297 2 1 XOR2HS $T=555520 366800 1 0 $X=555520 $Y=361380
X2871 2662 2607 2725 2 1 XOR2HS $T=555520 376880 1 0 $X=555520 $Y=371460
X2872 2434 2731 2763 2 1 XOR2HS $T=559860 457520 0 0 $X=559860 $Y=457140
X2873 2777 2451 2811 2 1 XOR2HS $T=568540 417200 0 0 $X=568540 $Y=416820
X2874 2436 2717 2812 2 1 XOR2HS $T=568540 487760 1 0 $X=568540 $Y=482340
X2875 2443 2752 2819 2 1 XOR2HS $T=570400 447440 1 0 $X=570400 $Y=442020
X2876 2809 2819 2838 2 1 XOR2HS $T=574120 447440 0 0 $X=574120 $Y=447060
X2877 2755 2812 2840 2 1 XOR2HS $T=574120 487760 1 0 $X=574120 $Y=482340
X2878 2847 2844 2777 2 1 XOR2HS $T=580320 417200 1 180 $X=574740 $Y=416820
X2879 2872 2882 2890 2 1 XOR2HS $T=582800 407120 0 0 $X=582800 $Y=406740
X2880 2927 2879 2909 2 1 XOR2HS $T=593960 417200 1 180 $X=588380 $Y=416820
X2881 2942 2948 2936 2 1 XOR2HS $T=598300 497840 0 180 $X=592720 $Y=492420
X2882 2862 2890 2835 2 1 XOR2HS $T=593960 407120 0 0 $X=593960 $Y=406740
X2883 2979 2987 2968 2 1 XOR2HS $T=605120 417200 0 180 $X=599540 $Y=411780
X2884 2964 2992 2943 2 1 XOR2HS $T=605740 497840 1 180 $X=600160 $Y=497460
X2885 3013 3007 2990 2 1 XOR2HS $T=608840 407120 1 180 $X=603260 $Y=406740
X2886 3019 3012 2982 2 1 XOR2HS $T=609460 397040 1 180 $X=603880 $Y=396660
X2887 3025 3015 3001 2 1 XOR2HS $T=610080 507920 0 180 $X=604500 $Y=502500
X2888 3011 3005 3043 2 1 XOR2HS $T=608840 497840 1 0 $X=608840 $Y=492420
X2889 3073 3070 3054 2 1 XOR2HS $T=619380 407120 0 180 $X=613800 $Y=401700
X2890 3031 3063 3047 2 1 XOR2HS $T=614420 497840 1 0 $X=614420 $Y=492420
X2891 3050 3049 3079 2 1 XOR2HS $T=616280 477680 1 0 $X=616280 $Y=472260
X2892 3065 3042 3039 2 1 XOR2HS $T=622480 397040 0 180 $X=616900 $Y=391620
X2893 3088 3087 3072 2 1 XOR2HS $T=622480 487760 0 180 $X=616900 $Y=482340
X2894 3115 3101 3082 2 1 XOR2HS $T=624960 407120 0 180 $X=619380 $Y=401700
X2895 3120 3119 3091 2 1 XOR2HS $T=626200 417200 1 180 $X=620620 $Y=416820
X2896 3117 3127 3097 2 1 XOR2HS $T=626820 447440 0 180 $X=621240 $Y=442020
X2897 3075 3086 3130 2 1 XOR2HS $T=621860 457520 0 0 $X=621860 $Y=457140
X2898 3110 3081 3099 2 1 XOR2HS $T=628680 507920 0 180 $X=623100 $Y=502500
X2899 3109 3150 3132 2 1 XOR2HS $T=629920 477680 0 180 $X=624340 $Y=472260
X2900 3141 3145 3161 2 1 XOR2HS $T=626200 397040 0 0 $X=626200 $Y=396660
X2901 3135 3142 3158 2 1 XOR2HS $T=626200 427280 0 0 $X=626200 $Y=426900
X2902 3121 3149 3181 2 1 XOR2HS $T=628680 467600 0 0 $X=628680 $Y=467220
X2903 3162 3163 3140 2 1 XOR2HS $T=629300 407120 0 0 $X=629300 $Y=406740
X2904 3083 3108 3186 2 1 XOR2HS $T=629300 457520 1 0 $X=629300 $Y=452100
X2905 3153 3148 3199 2 1 XOR2HS $T=631780 417200 1 0 $X=631780 $Y=411780
X2906 3183 3177 3200 2 1 XOR2HS $T=631780 437360 1 0 $X=631780 $Y=431940
X2907 3168 3164 3206 2 1 XOR2HS $T=632400 447440 0 0 $X=632400 $Y=447060
X2908 3313 3273 3118 2 1 XOR2HS $T=649760 386960 0 180 $X=644180 $Y=381540
X2909 3245 3271 3320 2 1 XOR2HS $T=646040 457520 1 0 $X=646040 $Y=452100
X2910 3316 3223 3313 2 1 XOR2HS $T=649760 386960 1 0 $X=649760 $Y=381540
X2911 3291 3320 3347 2 1 XOR2HS $T=651620 457520 1 0 $X=651620 $Y=452100
X2912 388 3351 391 2 1 XOR2HS $T=655340 366800 1 0 $X=655340 $Y=361380
X2913 2798 3235 3408 2 1 XOR2HS $T=667120 417200 0 0 $X=667120 $Y=416820
X2914 3408 3401 3418 2 1 XOR2HS $T=668360 417200 1 0 $X=668360 $Y=411780
X2915 503 504 3639 2 1 XOR2HS $T=728500 447440 1 0 $X=728500 $Y=442020
X2916 517 519 3673 2 1 XOR2HS $T=737800 437360 1 0 $X=737800 $Y=431940
X2917 3836 3833 3819 2 1 XOR2HS $T=783680 507920 0 180 $X=778100 $Y=502500
X2918 3864 3857 3801 2 1 XOR2HS $T=789260 507920 0 180 $X=783680 $Y=502500
X2919 3895 3896 3874 2 1 XOR2HS $T=795460 507920 0 0 $X=795460 $Y=507540
X2920 610 609 3971 2 1 XOR2HS $T=810340 507920 0 0 $X=810340 $Y=507540
X2921 646 643 4021 2 1 XOR2HS $T=832660 507920 1 180 $X=827080 $Y=507540
X2922 656 654 4044 2 1 XOR2HS $T=839480 507920 1 180 $X=833900 $Y=507540
X2923 669 668 4058 2 1 XOR2HS $T=846300 507920 1 180 $X=840720 $Y=507540
X2924 4101 672 4082 2 1 XOR2HS $T=851880 507920 0 180 $X=846300 $Y=502500
X2925 4158 680 4145 2 1 XOR2HS $T=863040 487760 0 0 $X=863040 $Y=487380
X2926 4282 733 4285 2 1 XOR2HS $T=899000 507920 1 0 $X=899000 $Y=502500
X2927 4386 4353 4335 2 1 XOR2HS $T=926280 507920 0 180 $X=920700 $Y=502500
X2928 772 763 4386 2 1 XOR2HS $T=935580 507920 1 0 $X=935580 $Y=502500
X2929 807 806 4472 2 1 XOR2HS $T=951700 507920 0 180 $X=946120 $Y=502500
X2930 812 809 4490 2 1 XOR2HS $T=957280 507920 0 0 $X=957280 $Y=507540
X2931 815 816 4549 2 1 XOR2HS $T=963480 507920 0 0 $X=963480 $Y=507540
X2932 821 822 4566 2 1 XOR2HS $T=969680 507920 0 0 $X=969680 $Y=507540
X2933 829 830 4592 2 1 XOR2HS $T=975880 507920 1 0 $X=975880 $Y=502500
X2934 835 4615 4622 2 1 XOR2HS $T=985180 507920 1 0 $X=985180 $Y=502500
X2935 4629 840 4635 2 1 XOR2HS $T=992000 507920 1 0 $X=992000 $Y=502500
X2936 852 851 4657 2 1 XOR2HS $T=1011220 507920 1 180 $X=1005640 $Y=507540
X2937 4649 4663 4672 2 1 XOR2HS $T=1006260 467600 1 0 $X=1006260 $Y=462180
X2938 4655 4672 4677 2 1 XOR2HS $T=1006260 477680 1 0 $X=1006260 $Y=472260
X2939 857 858 4732 2 1 XOR2HS $T=1019900 507920 0 0 $X=1019900 $Y=507540
X2940 871 872 4783 2 1 XOR2HS $T=1036640 507920 0 0 $X=1036640 $Y=507540
X2941 881 880 4812 2 1 XOR2HS $T=1049660 507920 0 0 $X=1049660 $Y=507540
X2942 874 4809 4839 2 1 XOR2HS $T=1060820 477680 1 0 $X=1060820 $Y=472260
X2943 4843 4839 4816 2 1 XOR2HS $T=1067020 487760 1 180 $X=1061440 $Y=487380
X2944 4884 4868 4864 2 1 XOR2HS $T=1083140 487760 1 180 $X=1077560 $Y=487380
X2945 4876 4795 4884 2 1 XOR2HS $T=1083140 487760 0 0 $X=1083140 $Y=487380
X2946 994 20 1080 1 2 1089 OA12 $T=250480 407120 0 0 $X=250480 $Y=406740
X2947 1660 117 1624 1 2 1593 OA12 $T=373240 417200 1 180 $X=369520 $Y=416820
X2948 2271 233 2214 1 2 2284 OA12 $T=482360 407120 0 0 $X=482360 $Y=406740
X2949 3716 3741 3566 1 2 3733 OA12 $T=759500 417200 1 0 $X=759500 $Y=411780
X2950 4269 4261 4247 1 2 4213 OA12 $T=895280 457520 1 180 $X=891560 $Y=457140
X2951 21 1088 2 1 1085 OR2 $T=257920 417200 0 180 $X=255440 $Y=411780
X2952 1302 1289 2 1 1257 OR2 $T=307520 417200 0 180 $X=305040 $Y=411780
X2953 1009 1470 2 1 1490 OR2 $T=335420 487760 1 0 $X=335420 $Y=482340
X2954 1140 1489 2 1 1507 OR2 $T=337900 457520 1 0 $X=337900 $Y=452100
X2955 1605 1607 2 1 1617 OR2 $T=357120 427280 1 0 $X=357120 $Y=421860
X2956 113 1663 2 1 1702 OR2 $T=380680 427280 1 180 $X=378200 $Y=426900
X2957 1869 140 2 1 1891 OR2 $T=412920 507920 1 180 $X=410440 $Y=507540
X2958 1955 1952 2 1 2003 OR2 $T=420980 477680 1 0 $X=420980 $Y=472260
X2959 1453 2007 2 1 1970 OR2 $T=425940 397040 0 180 $X=423460 $Y=391620
X2960 235 230 2 1 2200 OR2 $T=489800 407120 0 180 $X=487320 $Y=401700
X2961 265 2526 2 1 2517 OR2 $T=528860 427280 0 180 $X=526380 $Y=421860
X2962 265 2512 2 1 2567 OR2 $T=530100 437360 0 0 $X=530100 $Y=436980
X2963 2724 2430 2 1 2789 OR2 $T=570400 477680 1 0 $X=570400 $Y=472260
X2964 314 2940 2 1 2932 OR2 $T=595820 427280 0 180 $X=593340 $Y=421860
X2965 2958 2756 2 1 2946 OR2 $T=598920 376880 1 180 $X=596440 $Y=376500
X2966 3112 3156 2 1 3277 OR2 $T=644180 487760 0 0 $X=644180 $Y=487380
X2967 724 725 2 1 4263 OR2 $T=891560 507920 0 0 $X=891560 $Y=507540
X2968 734 736 2 1 4271 OR2 $T=900240 507920 0 0 $X=900240 $Y=507540
X2969 4586 4591 2 1 4597 OR2 $T=983940 497840 1 180 $X=981460 $Y=497460
X2970 4587 834 2 1 4595 OR2 $T=982700 487760 1 0 $X=982700 $Y=482340
X2971 4864 894 2 1 4851 OR2 $T=1075080 487760 0 0 $X=1075080 $Y=487380
X2972 411 413 414 2 1 419 OR3S $T=675800 507920 0 0 $X=675800 $Y=507540
X2973 411 3733 3720 2 1 3740 OR3S $T=757020 427280 0 0 $X=757020 $Y=426900
X2974 1255 1257 2 1 1190 OR2S $T=296980 417200 1 180 $X=294500 $Y=416820
X2975 1661 1663 2 1 1605 OR2S $T=372000 427280 0 180 $X=369520 $Y=421860
X2976 314 2941 2 1 2956 OR2S $T=595820 437360 1 0 $X=595820 $Y=431940
X2977 2980 2940 2 1 3004 OR2S $T=603880 427280 1 0 $X=603880 $Y=421860
X2978 3709 3720 3695 3700 2 3566 1 AOI13HS $T=752680 427280 1 180 $X=748960 $Y=426900
X2979 4252 4005 4268 4270 2 4247 1 AOI13HS $T=892800 457520 1 0 $X=892800 $Y=452100
X2980 1629 1607 1 1637 1636 1607 2 MOAI1 $T=361460 407120 0 0 $X=361460 $Y=406740
X2981 2944 2859 1 2931 2862 2859 2 MOAI1 $T=598920 417200 0 180 $X=594580 $Y=411780
X2982 560 552 1 552 551 550 2 MOAI1 $T=760740 427280 0 180 $X=756400 $Y=421860
X2983 3869 3842 1 3878 3851 3842 2 MOAI1 $T=794840 487760 0 180 $X=790500 $Y=482340
X2984 3911 3924 1 3933 3916 3924 2 MOAI1 $T=801040 497840 0 0 $X=801040 $Y=497460
X2985 739 552 1 552 4358 765 2 MOAI1 $T=913880 437360 1 0 $X=913880 $Y=431940
X2986 4591 4586 1 4577 4507 4578 2 MOAI1 $T=978980 487760 1 180 $X=974640 $Y=487380
X2987 4279 683 1 720 2 AN2S $T=899000 507920 0 180 $X=896520 $Y=502500
X2988 1041 1050 2 1 1012 1021 MUX2 $T=244280 417200 1 180 $X=239940 $Y=416820
X2989 1010 1050 2 1 998 1023 MUX2 $T=244900 457520 0 180 $X=240560 $Y=452100
X2990 1064 1050 2 1 1014 1029 MUX2 $T=245520 427280 1 180 $X=241180 $Y=426900
X2991 1052 1050 2 1 1000 1032 MUX2 $T=246140 437360 1 180 $X=241800 $Y=436980
X2992 1069 1050 2 1 997 1037 MUX2 $T=247380 427280 0 180 $X=243040 $Y=421860
X2993 1056 1050 2 1 999 1038 MUX2 $T=247380 437360 0 180 $X=243040 $Y=431940
X2994 1055 1050 2 1 992 1033 MUX2 $T=247380 447440 1 180 $X=243040 $Y=447060
X2995 1030 1057 2 1 1084 1072 MUX2 $T=247380 497840 1 0 $X=247380 $Y=492420
X2996 1073 1065 2 1 1047 1067 MUX2 $T=252960 437360 1 180 $X=248620 $Y=436980
X2997 1083 1065 2 1 1029 1071 MUX2 $T=253580 457520 0 180 $X=249240 $Y=452100
X2998 1091 1065 2 1 1037 1074 MUX2 $T=254820 447440 1 180 $X=250480 $Y=447060
X2999 1063 1065 2 1 1052 1102 MUX2 $T=252960 427280 0 0 $X=252960 $Y=426900
X3000 1096 1065 2 1 1055 1083 MUX2 $T=257300 447440 0 180 $X=252960 $Y=442020
X3001 1111 1065 2 1 1010 1091 MUX2 $T=259160 437360 1 180 $X=254820 $Y=436980
X3002 26 23 2 1 1121 32 MUX2 $T=257920 366800 1 0 $X=257920 $Y=361380
X3003 1102 1065 2 1 1021 1106 MUX2 $T=262260 447440 0 180 $X=257920 $Y=442020
X3004 1130 1131 2 1 1106 1113 MUX2 $T=264120 457520 0 180 $X=259780 $Y=452100
X3005 1133 1131 2 1 1090 1072 MUX2 $T=264120 487760 0 180 $X=259780 $Y=482340
X3006 1109 21 2 1 1111 1122 MUX2 $T=265980 427280 1 180 $X=261640 $Y=426900
X3007 1122 21 2 1 1102 1115 MUX2 $T=265980 437360 0 180 $X=261640 $Y=431940
X3008 1138 21 2 1 1073 1128 MUX2 $T=267840 437360 1 180 $X=263500 $Y=436980
X3009 1115 21 2 1 1091 1130 MUX2 $T=267840 447440 1 180 $X=263500 $Y=447060
X3010 1128 21 2 1 1083 1148 MUX2 $T=264120 447440 1 0 $X=264120 $Y=442020
X3011 1136 1131 2 1 1092 1072 MUX2 $T=269080 477680 0 180 $X=264740 $Y=472260
X3012 1117 1005 2 1 1156 1119 MUX2 $T=265360 397040 1 0 $X=265360 $Y=391620
X3013 1164 35 2 1 1133 1072 MUX2 $T=269700 487760 1 180 $X=265360 $Y=487380
X3014 1189 37 2 1 1122 1145 MUX2 $T=271560 437360 0 180 $X=267220 $Y=431940
X3015 1148 1131 2 1 1067 1176 MUX2 $T=267840 457520 1 0 $X=267840 $Y=452100
X3016 1145 37 2 1 1128 1160 MUX2 $T=274040 437360 1 180 $X=269700 $Y=436980
X3017 1165 37 2 1 1148 1161 MUX2 $T=274040 447440 1 180 $X=269700 $Y=447060
X3018 1160 37 2 1 1115 1165 MUX2 $T=274660 447440 0 180 $X=270320 $Y=442020
X3019 1187 37 2 1 1176 1179 MUX2 $T=278380 457520 0 180 $X=274040 $Y=452100
X3020 1161 37 2 1 1130 1187 MUX2 $T=279620 447440 1 180 $X=275280 $Y=447060
X3021 1216 1211 2 1 1239 1233 MUX2 $T=288300 477680 0 0 $X=288300 $Y=477300
X3022 1213 1227 2 1 1242 1218 MUX2 $T=288920 447440 1 0 $X=288920 $Y=442020
X3023 1238 1227 2 1 1259 1213 MUX2 $T=292020 437360 0 0 $X=292020 $Y=436980
X3024 1228 1211 2 1 1262 1235 MUX2 $T=292020 467600 1 0 $X=292020 $Y=462180
X3025 1217 1211 2 1 1264 1238 MUX2 $T=293260 437360 1 0 $X=293260 $Y=431940
X3026 1236 1211 2 1 1271 1247 MUX2 $T=293880 457520 1 0 $X=293880 $Y=452100
X3027 1250 71 2 1 1272 1259 MUX2 $T=295120 427280 0 0 $X=295120 $Y=426900
X3028 1247 1211 2 1 1274 1228 MUX2 $T=295120 457520 0 0 $X=295120 $Y=457140
X3029 1212 71 2 1 1284 1264 MUX2 $T=298840 437360 1 0 $X=298840 $Y=431940
X3030 1273 71 2 1 1290 1274 MUX2 $T=299460 457520 1 0 $X=299460 $Y=452100
X3031 1259 71 2 1 1297 1273 MUX2 $T=300080 437360 0 0 $X=300080 $Y=436980
X3032 1242 71 2 1 1298 1271 MUX2 $T=300080 447440 1 0 $X=300080 $Y=442020
X3033 1271 71 2 1 1295 1262 MUX2 $T=300080 457520 0 0 $X=300080 $Y=457140
X3034 1279 1211 2 1 1306 1304 MUX2 $T=301940 487760 0 0 $X=301940 $Y=487380
X3035 1281 1289 2 1 1307 1297 MUX2 $T=302560 427280 0 0 $X=302560 $Y=426900
X3036 1285 1275 2 1 1308 1304 MUX2 $T=304420 477680 0 0 $X=304420 $Y=477300
X3037 1298 1289 2 1 1321 1309 MUX2 $T=305040 457520 1 0 $X=305040 $Y=452100
X3038 1300 1302 2 1 1322 1321 MUX2 $T=305660 427280 1 0 $X=305660 $Y=421860
X3039 1297 1289 2 1 1319 1317 MUX2 $T=305660 447440 1 0 $X=305660 $Y=442020
X3040 1274 1275 2 1 1317 1263 MUX2 $T=305660 457520 0 0 $X=305660 $Y=457140
X3041 1306 1275 2 1 1334 1304 MUX2 $T=307520 487760 0 0 $X=307520 $Y=487380
X3042 1290 1289 2 1 1343 1288 MUX2 $T=310620 457520 1 0 $X=310620 $Y=452100
X3043 1313 1302 2 1 1348 1332 MUX2 $T=311240 457520 0 0 $X=311240 $Y=457140
X3044 1325 1289 2 1 1363 1295 MUX2 $T=313720 447440 0 0 $X=313720 $Y=447060
X3045 1345 1302 2 1 1349 1363 MUX2 $T=315580 417200 0 0 $X=315580 $Y=416820
X3046 1378 1326 2 1 92 1304 MUX2 $T=321780 497840 1 180 $X=317440 $Y=497460
X3047 1307 1302 2 1 1383 1346 MUX2 $T=318680 447440 0 0 $X=318680 $Y=447060
X3048 1342 1302 2 1 1386 1378 MUX2 $T=321160 457520 0 0 $X=321160 $Y=457140
X3049 1600 108 2 1 1619 1622 MUX2 $T=355880 447440 0 0 $X=355880 $Y=447060
X3050 1553 108 2 1 1623 1612 MUX2 $T=355880 457520 0 0 $X=355880 $Y=457140
X3051 1625 108 2 1 1611 1600 MUX2 $T=362700 447440 0 180 $X=358360 $Y=442020
X3052 1622 108 2 1 1638 1553 MUX2 $T=360220 457520 1 0 $X=360220 $Y=452100
X3053 1644 113 2 1 1632 1631 MUX2 $T=366420 437360 0 180 $X=362080 $Y=431940
X3054 1599 108 2 1 1631 1625 MUX2 $T=366420 437360 1 180 $X=362080 $Y=436980
X3055 1631 113 2 1 1653 1619 MUX2 $T=364560 447440 0 0 $X=364560 $Y=447060
X3056 1619 113 2 1 1664 1623 MUX2 $T=367040 457520 1 0 $X=367040 $Y=452100
X3057 1667 1671 2 1 1644 1646 MUX2 $T=372000 437360 0 180 $X=367660 $Y=431940
X3058 1611 113 2 1 1683 1638 MUX2 $T=370760 447440 0 0 $X=370760 $Y=447060
X3059 1667 108 2 1 1685 1599 MUX2 $T=371380 437360 0 0 $X=371380 $Y=436980
X3060 1656 114 2 1 1690 1678 MUX2 $T=372000 487760 1 0 $X=372000 $Y=482340
X3061 1657 108 2 1 1674 1678 MUX2 $T=372000 497840 1 0 $X=372000 $Y=492420
X3062 1638 113 2 1 1698 1647 MUX2 $T=372620 457520 1 0 $X=372620 $Y=452100
X3063 1674 114 2 1 1693 1678 MUX2 $T=372620 487760 0 0 $X=372620 $Y=487380
X3064 1685 113 2 1 1710 1611 MUX2 $T=375720 447440 1 0 $X=375720 $Y=442020
X3065 1688 113 2 1 1718 1685 MUX2 $T=376340 437360 0 0 $X=376340 $Y=436980
X3066 1683 121 2 1 1722 1707 MUX2 $T=378200 457520 1 0 $X=378200 $Y=452100
X3067 1653 121 2 1 1733 1673 MUX2 $T=380060 457520 0 0 $X=380060 $Y=457140
X3068 1632 121 2 1 1749 1664 MUX2 $T=383780 447440 0 0 $X=383780 $Y=447060
X3069 1710 121 2 1 1745 1698 MUX2 $T=383780 457520 1 0 $X=383780 $Y=452100
X3070 1731 123 2 1 1736 1710 MUX2 $T=389980 447440 0 180 $X=385640 $Y=442020
X3071 1755 123 2 1 1776 1653 MUX2 $T=388740 437360 0 0 $X=388740 $Y=436980
X3072 1776 1769 2 1 1759 1703 MUX2 $T=393700 447440 1 180 $X=389360 $Y=447060
X3073 1774 1694 2 1 1764 1678 MUX2 $T=394320 487760 1 180 $X=389980 $Y=487380
X3074 1739 1769 2 1 1790 1722 MUX2 $T=390600 437360 1 0 $X=390600 $Y=431940
X3075 1766 1769 2 1 1804 1733 MUX2 $T=392460 427280 0 0 $X=392460 $Y=426900
X3076 1736 1769 2 1 1803 1746 MUX2 $T=393080 437360 0 0 $X=393080 $Y=436980
X3077 1744 1769 2 1 1810 1723 MUX2 $T=394320 457520 1 0 $X=394320 $Y=452100
X3078 1757 1769 2 1 1816 1770 MUX2 $T=395560 437360 1 0 $X=395560 $Y=431940
X3079 1795 1769 2 1 1825 1745 MUX2 $T=396800 447440 0 0 $X=396800 $Y=447060
X3080 2142 168 2 1 2156 178 MUX2 $T=450120 386960 1 0 $X=450120 $Y=381540
X3081 2110 168 2 1 2149 190 MUX2 $T=453220 386960 0 0 $X=453220 $Y=386580
X3082 2040 168 2 1 2169 194 MUX2 $T=455080 386960 1 0 $X=455080 $Y=381540
X3083 2202 205 2 1 2224 2197 MUX2 $T=470580 447440 0 0 $X=470580 $Y=447060
X3084 2197 205 2 1 2225 2196 MUX2 $T=470580 457520 1 0 $X=470580 $Y=452100
X3085 2196 205 2 1 2226 2172 MUX2 $T=470580 457520 0 0 $X=470580 $Y=457140
X3086 2223 205 2 1 2209 2202 MUX2 $T=476160 447440 0 180 $X=471820 $Y=442020
X3087 2209 213 2 1 2248 2225 MUX2 $T=475540 447440 0 0 $X=475540 $Y=447060
X3088 2224 213 2 1 2255 2226 MUX2 $T=476160 457520 1 0 $X=476160 $Y=452100
X3089 2225 213 2 1 2261 2204 MUX2 $T=476160 457520 0 0 $X=476160 $Y=457140
X3090 2242 213 2 1 2265 2224 MUX2 $T=476780 447440 1 0 $X=476780 $Y=442020
X3091 2182 213 2 1 2263 2209 MUX2 $T=477400 437360 1 0 $X=477400 $Y=431940
X3092 2230 205 2 1 231 232 MUX2 $T=478640 366800 1 0 $X=478640 $Y=361380
X3093 2245 213 2 1 2260 2182 MUX2 $T=478640 427280 0 0 $X=478640 $Y=426900
X3094 2264 230 2 1 2319 2255 MUX2 $T=481120 447440 0 0 $X=481120 $Y=447060
X3095 2265 230 2 1 2290 2215 MUX2 $T=481120 457520 1 0 $X=481120 $Y=452100
X3096 2246 2227 2 1 2279 2287 MUX2 $T=481120 487760 1 0 $X=481120 $Y=482340
X3097 2260 230 2 1 2292 2248 MUX2 $T=481740 437360 0 0 $X=481740 $Y=436980
X3098 2269 2227 2 1 2286 2287 MUX2 $T=481740 477680 0 0 $X=481740 $Y=477300
X3099 2257 230 2 1 2293 2265 MUX2 $T=482980 417200 1 0 $X=482980 $Y=411780
X3100 2267 226 2 1 2246 2287 MUX2 $T=484220 487760 0 0 $X=484220 $Y=487380
X3101 2285 230 2 1 2313 2263 MUX2 $T=485460 437360 1 0 $X=485460 $Y=431940
X3102 2263 230 2 1 2311 2261 MUX2 $T=486700 447440 1 0 $X=486700 $Y=442020
X3103 2248 230 2 1 2315 2274 MUX2 $T=486700 457520 1 0 $X=486700 $Y=452100
X3104 2276 235 2 1 2314 2315 MUX2 $T=487320 437360 0 0 $X=487320 $Y=436980
X3105 2309 2300 2 1 2328 2287 MUX2 $T=489800 497840 1 0 $X=489800 $Y=492420
X3106 2305 235 2 1 2325 2290 MUX2 $T=490420 417200 1 0 $X=490420 $Y=411780
X3107 240 238 2 1 2337 232 MUX2 $T=491040 366800 1 0 $X=491040 $Y=361380
X3108 2313 235 2 1 2343 2326 MUX2 $T=491040 437360 1 0 $X=491040 $Y=431940
X3109 2292 235 2 1 2332 2309 MUX2 $T=491660 447440 1 0 $X=491660 $Y=442020
X3110 2310 235 2 1 2342 2319 MUX2 $T=492900 417200 0 0 $X=492900 $Y=416820
X3111 2293 235 2 1 2346 2296 MUX2 $T=492900 437360 0 0 $X=492900 $Y=436980
X3112 2323 235 2 1 2321 2311 MUX2 $T=494140 427280 0 0 $X=494140 $Y=426900
X3113 2303 235 2 1 2360 2308 MUX2 $T=495380 427280 1 0 $X=495380 $Y=421860
X3114 2459 260 2 1 2508 2460 MUX2 $T=518940 447440 1 0 $X=518940 $Y=442020
X3115 2493 2462 2 1 2524 2516 MUX2 $T=521420 507920 1 0 $X=521420 $Y=502500
X3116 2461 260 2 1 2522 2485 MUX2 $T=522040 467600 1 0 $X=522040 $Y=462180
X3117 2500 260 2 1 2529 2461 MUX2 $T=522660 457520 1 0 $X=522660 $Y=452100
X3118 2508 265 2 1 2537 2536 MUX2 $T=523900 447440 1 0 $X=523900 $Y=442020
X3119 2524 2491 2 1 2547 2516 MUX2 $T=525760 507920 1 0 $X=525760 $Y=502500
X3120 2536 265 2 1 2553 2522 MUX2 $T=527620 457520 1 0 $X=527620 $Y=452100
X3121 2529 265 2 1 2554 2518 MUX2 $T=527620 467600 1 0 $X=527620 $Y=462180
X3122 2530 2491 2 1 2556 2516 MUX2 $T=527620 487760 0 0 $X=527620 $Y=487380
X3123 2482 265 2 1 2569 2529 MUX2 $T=529480 447440 0 0 $X=529480 $Y=447060
X3124 2564 281 2 1 2591 2537 MUX2 $T=532580 427280 0 0 $X=532580 $Y=426900
X3125 2537 279 2 1 2592 2555 MUX2 $T=533200 457520 0 0 $X=533200 $Y=457140
X3126 2569 279 2 1 2593 2551 MUX2 $T=533200 467600 1 0 $X=533200 $Y=462180
X3127 2573 281 2 1 2597 2562 MUX2 $T=533820 447440 1 0 $X=533820 $Y=442020
X3128 2575 2571 2 1 2583 2592 MUX2 $T=534440 417200 0 0 $X=534440 $Y=416820
X3129 2562 281 2 1 2599 2554 MUX2 $T=534440 457520 1 0 $X=534440 $Y=452100
X3130 2521 281 2 1 2603 2569 MUX2 $T=535680 437360 1 0 $X=535680 $Y=431940
X3131 2591 2571 2 1 2628 2587 MUX2 $T=538160 447440 1 0 $X=538160 $Y=442020
X3132 2590 2571 2 1 2630 2593 MUX2 $T=540020 417200 0 0 $X=540020 $Y=416820
X3133 287 286 2 1 2654 277 MUX2 $T=540640 366800 1 0 $X=540640 $Y=361380
X3134 2597 2571 2 1 2632 2586 MUX2 $T=540640 437360 1 0 $X=540640 $Y=431940
X3135 2611 2571 2 1 2646 2619 MUX2 $T=541260 427280 1 0 $X=541260 $Y=421860
X3136 2603 2571 2 1 2649 2588 MUX2 $T=541880 437360 0 0 $X=541880 $Y=436980
X3137 2606 2571 2 1 2666 2616 MUX2 $T=543120 447440 0 0 $X=543120 $Y=447060
X3138 2608 2571 2 1 2629 2599 MUX2 $T=543740 447440 1 0 $X=543740 $Y=442020
X3139 2616 2549 2 1 2638 2516 MUX2 $T=543740 497840 1 0 $X=543740 $Y=492420
X3140 2841 2825 2 1 2876 2877 MUX2 $T=579700 437360 0 0 $X=579700 $Y=436980
X3141 2860 2873 2 1 2884 2837 MUX2 $T=582180 427280 0 0 $X=582180 $Y=426900
X3142 2863 2825 2 1 2892 2878 MUX2 $T=582800 457520 1 0 $X=582800 $Y=452100
X3143 2877 2825 2 1 2894 2897 MUX2 $T=584040 437360 0 0 $X=584040 $Y=436980
X3144 2878 2825 2 1 2929 2855 MUX2 $T=584660 457520 0 0 $X=584660 $Y=457140
X3145 2884 314 2 1 2912 2876 MUX2 $T=585900 437360 1 0 $X=585900 $Y=431940
X3146 2876 314 2 1 2922 2923 MUX2 $T=588380 437360 0 0 $X=588380 $Y=436980
X3147 2894 314 2 1 2924 2892 MUX2 $T=588380 447440 0 0 $X=588380 $Y=447060
X3148 2897 2825 2 1 2923 2863 MUX2 $T=589000 447440 1 0 $X=589000 $Y=442020
X3149 2892 314 2 1 2933 2900 MUX2 $T=589620 457520 1 0 $X=589620 $Y=452100
X3150 2923 314 2 1 2951 2929 MUX2 $T=593340 447440 0 0 $X=593340 $Y=447060
X3151 2913 2905 2 1 2952 2911 MUX2 $T=593340 467600 0 0 $X=593340 $Y=467220
X3152 2920 2905 2 1 2953 2911 MUX2 $T=593340 477680 0 0 $X=593340 $Y=477300
X3153 2891 2825 2 1 2920 2911 MUX2 $T=593340 487760 0 0 $X=593340 $Y=487380
X3154 2924 2959 2 1 2983 2963 MUX2 $T=598920 447440 0 0 $X=598920 $Y=447060
X3155 2978 325 2 1 3018 2922 MUX2 $T=602640 437360 0 0 $X=602640 $Y=436980
X3156 2922 325 2 1 3023 2960 MUX2 $T=603880 447440 0 0 $X=603880 $Y=447060
X3157 3003 2974 2 1 3027 2911 MUX2 $T=605740 487760 1 0 $X=605740 $Y=482340
X3158 2961 325 2 1 3041 2933 MUX2 $T=609460 447440 0 0 $X=609460 $Y=447060
X3159 3033 3052 2 1 3040 3023 MUX2 $T=616280 437360 1 180 $X=611940 $Y=436980
X3160 3051 3052 2 1 3094 3034 MUX2 $T=615660 427280 0 0 $X=615660 $Y=426900
X3161 2996 3052 2 1 3077 3041 MUX2 $T=615660 437360 1 0 $X=615660 $Y=431940
X3162 3066 3052 2 1 3092 2983 MUX2 $T=616900 427280 1 0 $X=616900 $Y=421860
X3163 3018 3052 2 1 3103 2988 MUX2 $T=618140 437360 0 0 $X=618140 $Y=436980
X3164 3022 3052 2 1 3104 2994 MUX2 $T=618140 447440 0 0 $X=618140 $Y=447060
X3165 3055 3052 2 1 3126 3026 MUX2 $T=620000 437360 1 0 $X=620000 $Y=431940
X3166 381 379 2 1 377 376 MUX2 $T=646660 507920 0 180 $X=642320 $Y=502500
X3167 394 389 2 1 397 3391 MUX2 $T=660920 497840 0 0 $X=660920 $Y=497460
X3168 374 389 2 1 3399 407 MUX2 $T=678280 376880 0 180 $X=673940 $Y=371460
X3169 385 389 2 1 415 3426 MUX2 $T=674560 497840 1 0 $X=674560 $Y=492420
X3170 3423 389 2 1 3420 3093 MUX2 $T=679520 386960 0 180 $X=675180 $Y=381540
X3171 3423 389 2 1 3442 346 MUX2 $T=686340 397040 0 180 $X=682000 $Y=391620
X3172 3423 389 2 1 3445 374 MUX2 $T=686960 386960 0 180 $X=682620 $Y=381540
X3173 3405 389 2 1 3448 3410 MUX2 $T=683240 477680 0 0 $X=683240 $Y=477300
X3174 3393 389 2 1 3436 422 MUX2 $T=688820 366800 1 180 $X=684480 $Y=366420
X3175 3423 389 2 1 3460 3393 MUX2 $T=693780 386960 0 180 $X=689440 $Y=381540
X3176 506 379 2 1 3657 3655 MUX2 $T=731600 507920 0 0 $X=731600 $Y=507540
X3177 523 379 2 1 3688 3689 MUX2 $T=743380 487760 0 0 $X=743380 $Y=487380
X3178 533 379 2 1 3679 3675 MUX2 $T=747720 497840 0 180 $X=743380 $Y=492420
X3179 750 4313 2 1 4280 4293 MUX2 $T=908300 487760 1 180 $X=903960 $Y=487380
X3180 4293 4313 2 1 4321 4325 MUX2 $T=908300 477680 0 0 $X=908300 $Y=477300
X3181 750 4313 2 1 4301 4333 MUX2 $T=913260 477680 0 0 $X=913260 $Y=477300
X3182 750 4313 2 1 4387 780 MUX2 $T=922560 477680 1 0 $X=922560 $Y=472260
X3183 750 4313 2 1 4363 4406 MUX2 $T=934340 467600 0 180 $X=930000 $Y=462180
X3184 4406 4313 2 1 4440 4434 MUX2 $T=933100 477680 1 0 $X=933100 $Y=472260
X3185 4414 4313 2 1 4489 4486 MUX2 $T=946740 467600 0 0 $X=946740 $Y=467220
X3186 30 2 1088 1144 1 AN2B1S $T=266600 417200 1 0 $X=266600 $Y=411780
X3187 1857 2 1863 1861 1 AN2B1S $T=407340 487760 1 180 $X=404240 $Y=487380
X3188 1877 2 1861 1889 1 AN2B1S $T=407340 487760 0 0 $X=407340 $Y=487380
X3189 1855 2 1974 2002 1 AN2B1S $T=420360 427280 0 0 $X=420360 $Y=426900
X3190 2090 2 2103 2088 1 AN2B1S $T=440200 457520 0 180 $X=437100 $Y=452100
X3191 1981 2 2114 2103 1 AN2B1S $T=442060 467600 0 180 $X=438960 $Y=462180
X3192 3154 2 3169 3193 1 AN2B1S $T=631160 457520 0 0 $X=631160 $Y=457140
X3193 3152 2 3239 3274 1 AN2B1S $T=641080 397040 0 0 $X=641080 $Y=396660
X3194 3722 2 3719 3728 1 AN2B1S $T=753920 497840 1 0 $X=753920 $Y=492420
X3195 3737 2 3728 3754 1 AN2B1S $T=760120 497840 1 0 $X=760120 $Y=492420
X3196 3798 2 3790 3814 1 AN2B1S $T=774380 497840 0 0 $X=774380 $Y=497460
X3197 3788 2 3814 3824 1 AN2B1S $T=776860 497840 1 0 $X=776860 $Y=492420
X3198 4007 2 4039 4046 1 AN2B1S $T=830800 497840 1 0 $X=830800 $Y=492420
X3199 4019 2 4048 4037 1 AN2B1S $T=834520 487760 0 180 $X=831420 $Y=482340
X3200 4029 2 4020 4039 1 AN2B1S $T=837000 497840 0 180 $X=833900 $Y=492420
X3201 4052 2 4055 4048 1 AN2B1S $T=837620 487760 0 180 $X=834520 $Y=482340
X3202 4597 2 4602 4603 1 AN2B1S $T=980220 497840 1 0 $X=980220 $Y=492420
X3203 4595 2 4610 4613 1 AN2B1S $T=985180 487760 1 0 $X=985180 $Y=482340
X3204 549 531 1 2 729 QDLHN $T=888460 427280 0 0 $X=888460 $Y=426900
X3205 1453 1068 2 1376 1425 1 1362 FA1 $T=333560 407120 0 180 $X=318060 $Y=401700
X3206 1471 1539 2 1546 1209 1 1464 FA1 $T=335420 397040 0 0 $X=335420 $Y=396660
X3207 109 1103 2 1503 1550 1 103 FA1 $T=356500 507920 1 180 $X=341000 $Y=507540
X3208 1608 1024 2 1497 1563 1 1521 FA1 $T=358360 467600 0 180 $X=342860 $Y=462180
X3209 1549 1201 2 1419 1500 1 1639 FA1 $T=346580 376880 1 0 $X=346580 $Y=371460
X3210 1628 1094 2 1478 1577 1 1550 FA1 $T=362080 507920 0 180 $X=346580 $Y=502500
X3211 1630 1713 2 1695 1589 1 1738 FA1 $T=370760 397040 0 0 $X=370760 $Y=396660
X3212 1691 1740 2 1240 1655 1 1771 FA1 $T=376340 386960 1 0 $X=376340 $Y=381540
X3213 154 1796 2 148 2017 1 1805 FA1 $T=428420 507920 1 180 $X=412920 $Y=507540
X3214 2007 2006 2 2035 1971 1 2025 FA1 $T=427180 397040 0 0 $X=427180 $Y=396660
X3215 2817 2740 2 2432 2770 1 2721 FA1 $T=574120 437360 1 180 $X=558620 $Y=436980
X3216 2833 2728 2 2404 299 1 2743 FA1 $T=576600 366800 0 180 $X=561100 $Y=361380
X3217 2757 2939 2 2858 2916 1 2851 FA1 $T=584660 407120 1 0 $X=584660 $Y=401700
X3218 333 2937 2 322 332 1 319 FA1 $T=604500 507920 0 180 $X=589000 $Y=502500
X3219 3069 3057 2 3192 3243 1 3136 FA1 $T=643560 497840 0 180 $X=628060 $Y=492420
X3220 382 372 2 3217 3290 1 369 FA1 $T=648520 366800 0 180 $X=633020 $Y=361380
X3221 3336 3187 2 3270 3232 1 3225 FA1 $T=653480 447440 1 180 $X=637980 $Y=447060
X3222 3402 3328 2 2817 3362 1 3334 FA1 $T=667740 437360 0 180 $X=652240 $Y=431940
X3223 3692 3768 2 3713 3759 1 573 FA1 $T=755160 497840 0 0 $X=755160 $Y=497460
X3224 3953 3987 2 3989 3995 1 3985 FA1 $T=809720 507920 1 0 $X=809720 $Y=502500
X3225 1476 1237 1464 2 1 1486 XOR3S $T=353400 386960 1 180 $X=342240 $Y=386580
X3226 338 3016 329 2 1 2907 XOR3S $T=610080 366800 0 180 $X=598920 $Y=361380
X3227 1168 1186 1194 1173 1 2 ND3P $T=276520 397040 0 180 $X=271560 $Y=391620
X3228 1249 1286 1258 1268 1 2 ND3P $T=294500 386960 0 0 $X=294500 $Y=386580
X3229 1377 1454 1444 1449 1 2 ND3P $T=328600 417200 1 0 $X=328600 $Y=411780
X3230 1485 1511 1458 1501 1 2 ND3P $T=335420 376880 0 0 $X=335420 $Y=376500
X3231 1762 1800 1772 1799 1 2 ND3P $T=393080 397040 0 0 $X=393080 $Y=396660
X3232 1846 130 1842 1833 1 2 ND3P $T=406100 366800 1 180 $X=401140 $Y=366420
X3233 1882 1915 1894 1905 1 2 ND3P $T=406720 487760 1 0 $X=406720 $Y=482340
X3234 1892 1878 1909 1916 1 2 ND3P $T=407960 376880 1 0 $X=407960 $Y=371460
X3235 1938 1961 1901 1949 1 2 ND3P $T=411680 497840 0 0 $X=411680 $Y=497460
X3236 1982 1920 1984 1991 1 2 ND3P $T=417260 477680 0 0 $X=417260 $Y=477300
X3237 2005 147 2012 1994 1 2 ND3P $T=426560 366800 0 180 $X=421600 $Y=361380
X3238 2021 2057 2020 2033 1 2 ND3P $T=424700 417200 0 0 $X=424700 $Y=416820
X3239 2034 1945 2045 2014 1 2 ND3P $T=426560 427280 1 0 $X=426560 $Y=421860
X3240 2118 2050 2101 2127 1 2 ND3P $T=439580 437360 1 0 $X=439580 $Y=431940
X3241 2129 2092 2125 2134 1 2 ND3P $T=442680 427280 1 0 $X=442680 $Y=421860
X3242 2145 2143 2154 2141 1 2 ND3P $T=453840 407120 1 180 $X=448880 $Y=406740
X3243 2468 2504 2442 2449 1 2 ND3P $T=518940 376880 0 0 $X=518940 $Y=376500
X3244 2533 2559 2510 2525 1 2 ND3P $T=527620 376880 0 0 $X=527620 $Y=376500
X3245 2753 2780 2772 2732 1 2 ND3P $T=561100 477680 1 0 $X=561100 $Y=472260
X3246 2758 2735 2788 2794 1 2 ND3P $T=563580 447440 1 0 $X=563580 $Y=442020
X3247 2805 2749 2802 2750 1 2 ND3P $T=567920 497840 1 0 $X=567920 $Y=492420
X3248 2884 2955 2985 326 1 2 ND3P $T=602640 427280 0 180 $X=597680 $Y=421860
X3249 3123 3078 3113 3105 1 2 ND3P $T=627440 477680 1 180 $X=622480 $Y=477300
X3250 3213 3273 3221 3197 1 2 ND3P $T=639220 386960 0 0 $X=639220 $Y=386580
X3251 3283 3138 3281 3301 1 2 ND3P $T=643560 467600 1 0 $X=643560 $Y=462180
X3252 3298 3237 3324 3288 1 2 ND3P $T=651620 437360 0 180 $X=646660 $Y=431940
X3253 3318 3290 3330 3307 1 2 ND3P $T=652240 366800 1 180 $X=647280 $Y=366420
X3254 3295 3231 3309 3335 1 2 ND3P $T=657200 397040 1 180 $X=652240 $Y=396660
X3255 3371 3363 3374 3366 1 2 ND3P $T=663400 386960 1 180 $X=658440 $Y=386580
X3256 3380 3358 3389 3372 1 2 ND3P $T=665260 417200 1 180 $X=660300 $Y=416820
X3257 3417 3395 3397 3407 1 2 ND3P $T=674560 407120 1 180 $X=669600 $Y=406740
X3258 3670 3533 3554 513 1 2 ND3P $T=747100 417200 0 180 $X=742140 $Y=411780
X3259 3723 3721 3727 3729 1 2 ND3P $T=753300 487760 1 0 $X=753300 $Y=482340
X3260 3956 3924 3949 3948 1 2 ND3P $T=812820 497840 1 180 $X=807860 $Y=497460
X3261 4168 4116 4139 4160 1 2 ND3P $T=869240 487760 0 180 $X=864280 $Y=482340
X3262 4345 4338 4342 4340 1 2 ND3P $T=920080 497840 1 180 $X=915120 $Y=497460
X3263 4632 4596 4641 4628 1 2 ND3P $T=996960 467600 0 180 $X=992000 $Y=462180
X3264 4678 4626 4688 4675 1 2 ND3P $T=1012460 477680 1 180 $X=1007500 $Y=477300
X3265 4773 4726 4758 4763 1 2 ND3P $T=1032300 507920 1 0 $X=1032300 $Y=502500
X3266 4808 4796 4821 4802 1 2 ND3P $T=1054000 477680 1 180 $X=1049040 $Y=477300
X3267 4848 4824 4861 4844 1 2 ND3P $T=1070740 477680 1 180 $X=1065780 $Y=477300
X3268 4849 4855 4842 4841 1 2 ND3P $T=1066400 497840 0 0 $X=1066400 $Y=497460
X3269 4225 712 4232 1 2 OR2P $T=883500 497840 1 0 $X=883500 $Y=492420
X3270 1256 1244 1 1234 2 OR2B1S $T=295740 397040 1 180 $X=292640 $Y=396660
X3271 1123 1424 1 1435 2 OR2B1S $T=327980 437360 0 0 $X=327980 $Y=436980
X3272 1019 1457 1 1461 2 OR2B1S $T=336040 447440 0 180 $X=332940 $Y=442020
X3273 1027 1455 1 1480 2 OR2B1S $T=333560 437360 1 0 $X=333560 $Y=431940
X3274 1022 1489 1 1495 2 OR2B1S $T=336660 447440 0 0 $X=336660 $Y=447060
X3275 1018 1496 1 1508 2 OR2B1S $T=337280 477680 0 0 $X=337280 $Y=477300
X3276 1520 1510 1 1531 2 OR2B1S $T=347200 497840 0 180 $X=344100 $Y=492420
X3277 1578 1570 1 1556 2 OR2B1S $T=353400 407120 0 180 $X=350300 $Y=401700
X3278 1857 1863 1 1877 2 OR2B1S $T=406100 497840 1 0 $X=406100 $Y=492420
X3279 1914 1926 1 1932 2 OR2B1S $T=411060 477680 1 0 $X=411060 $Y=472260
X3280 1773 153 1 2037 2 OR2B1S $T=425940 497840 1 0 $X=425940 $Y=492420
X3281 1981 2114 1 2090 2 OR2B1S $T=442060 457520 1 180 $X=438960 $Y=457140
X3282 2113 2128 1 2136 2 OR2B1S $T=443920 447440 1 0 $X=443920 $Y=442020
X3283 1948 2130 1 2100 2 OR2B1S $T=447640 487760 1 0 $X=447640 $Y=482340
X3284 2436 2766 1 2769 2 OR2B1S $T=567300 487760 0 180 $X=564200 $Y=482340
X3285 2428 2792 1 2754 2 OR2B1S $T=564820 497840 1 0 $X=564820 $Y=492420
X3286 2464 2808 1 2801 2 OR2B1S $T=569160 407120 0 0 $X=569160 $Y=406740
X3287 3233 3226 1 3246 2 OR2B1S $T=638600 477680 1 0 $X=638600 $Y=472260
X3288 3203 3249 1 3229 2 OR2B1S $T=639840 457520 0 0 $X=639840 $Y=457140
X3289 3219 3254 1 3214 2 OR2B1S $T=643560 407120 0 180 $X=640460 $Y=401700
X3290 3202 3272 1 3282 2 OR2B1S $T=644180 397040 0 0 $X=644180 $Y=396660
X3291 3244 3326 1 3308 2 OR2B1S $T=649140 407120 1 0 $X=649140 $Y=401700
X3292 3116 3332 1 3321 2 OR2B1S $T=654100 467600 1 180 $X=651000 $Y=467220
X3293 3722 3719 1 3737 2 OR2B1S $T=757020 497840 1 0 $X=757020 $Y=492420
X3294 3798 3790 1 3788 2 OR2B1S $T=773760 497840 1 180 $X=770660 $Y=497460
X3295 3846 3856 1 3868 2 OR2B1S $T=791740 497840 1 180 $X=788640 $Y=497460
X3296 3902 3887 1 3912 2 OR2B1S $T=800420 507920 0 180 $X=797320 $Y=502500
X3297 4029 4020 1 4007 2 OR2B1S $T=828940 497840 1 180 $X=825840 $Y=497460
X3298 4052 4055 1 4019 2 OR2B1S $T=837620 487760 1 180 $X=834520 $Y=487380
X3299 4084 4086 1 4090 2 OR2B1S $T=844440 497840 0 0 $X=844440 $Y=497460
X3300 4359 4350 1 4351 2 OR2B1S $T=920080 487760 1 180 $X=916980 $Y=487380
X3301 4532 4511 1 4493 2 OR2B1S $T=963480 497840 1 180 $X=960380 $Y=497460
X3302 894 4881 1 4887 2 OR2B1S $T=1078800 497840 0 0 $X=1078800 $Y=497460
X3303 1167 1194 1197 1 2 1156 1173 1197 936 ICV_9 $T=276520 397040 1 0 $X=276520 $Y=391620
X3304 1229 1458 1465 1 2 1229 1485 1494 936 ICV_9 $T=332940 386960 1 0 $X=332940 $Y=381540
X3305 1583 1548 1578 1 2 1592 1574 1597 936 ICV_9 $T=353400 407120 1 0 $X=353400 $Y=401700
X3306 1875 1876 1866 1 2 1888 1893 1914 936 ICV_9 $T=407340 477680 1 0 $X=407340 $Y=472260
X3307 1877 1908 1921 1 2 1920 1882 1585 936 ICV_9 $T=410440 487760 0 0 $X=410440 $Y=487380
X3308 1920 1894 1936 1 2 1585 1905 1936 936 ICV_9 $T=411680 487760 1 0 $X=411680 $Y=482340
X3309 1915 1938 1544 1 2 1544 1949 1898 936 ICV_9 $T=413540 507920 1 0 $X=413540 $Y=502500
X3310 2043 2112 2133 1 2 2082 2133 2102 936 ICV_9 $T=444540 437360 0 0 $X=444540 $Y=436980
X3311 2479 2482 2489 1 2 2460 2489 260 936 ICV_9 $T=519560 447440 0 0 $X=519560 $Y=447060
X3312 2483 2400 2490 1 2 2496 2483 2480 936 ICV_9 $T=520180 397040 1 0 $X=520180 $Y=391620
X3313 2470 2469 2480 1 2 2470 2495 2511 936 ICV_9 $T=520180 417200 1 0 $X=520180 $Y=411780
X3314 2481 2503 269 1 2 2503 2521 2531 936 ICV_9 $T=523280 437360 0 0 $X=523280 $Y=436980
X3315 2726 2729 2754 1 2 2761 2764 2754 936 ICV_9 $T=561100 487760 0 0 $X=561100 $Y=487380
X3316 2747 2745 2464 1 2 2760 2751 2776 936 ICV_9 $T=561720 407120 0 0 $X=561720 $Y=406740
X3317 2751 2785 2747 1 2 2793 2796 2801 936 ICV_9 $T=565440 407120 0 0 $X=565440 $Y=406740
X3318 2785 2793 2464 1 2 2787 2747 2806 936 ICV_9 $T=566680 417200 1 0 $X=566680 $Y=411780
X3319 2962 2939 2970 1 2 2968 2962 331 936 ICV_9 $T=599540 407120 0 0 $X=599540 $Y=406740
X3320 2982 2966 331 1 2 2995 2975 330 936 ICV_9 $T=602640 397040 1 0 $X=602640 $Y=391620
X3321 3165 3105 2826 1 2 3165 3123 3170 936 ICV_9 $T=629920 477680 1 0 $X=629920 $Y=472260
X3322 3233 3204 3220 1 2 3132 3278 3285 936 ICV_9 $T=641700 477680 1 0 $X=641700 $Y=472260
X3323 3198 3303 3294 1 2 3204 3292 3294 936 ICV_9 $T=646660 477680 1 0 $X=646660 $Y=472260
X3324 2798 3372 3235 1 2 3235 3380 3395 936 ICV_9 $T=662160 417200 1 0 $X=662160 $Y=411780
X3325 3478 3490 450 1 2 436 3512 450 936 ICV_9 $T=696260 487760 1 0 $X=696260 $Y=482340
X3326 3893 3911 3912 1 2 3912 3900 3924 936 ICV_9 $T=796080 497840 0 0 $X=796080 $Y=497460
X3327 4090 4077 4116 1 2 4109 4122 4116 936 ICV_9 $T=852500 497840 1 0 $X=852500 $Y=492420
X3328 4361 4329 4390 1 2 4390 4373 4366 936 ICV_9 $T=923800 497840 0 0 $X=923800 $Y=497460
X3329 778 4402 776 1 2 4367 4419 4418 936 ICV_9 $T=930620 507920 0 0 $X=930620 $Y=507540
X3330 4425 4374 4429 1 2 4432 4401 4436 936 ICV_9 $T=934960 497840 1 0 $X=934960 $Y=492420
X3331 4441 4390 4385 1 2 4443 4359 4450 936 ICV_9 $T=938680 497840 1 0 $X=938680 $Y=492420
X3332 4442 4443 4445 1 2 4448 4450 4457 936 ICV_9 $T=939300 487760 0 0 $X=939300 $Y=487380
X3333 4595 4590 4599 1 2 4587 4588 834 936 ICV_9 $T=978980 487760 0 0 $X=978980 $Y=487380
X3334 1159 1153 1143 2 1 1209 XOR3 $T=273420 407120 1 0 $X=273420 $Y=401700
X3335 1158 1155 1163 2 1 1220 XOR3 $T=277140 386960 1 0 $X=277140 $Y=381540
X3336 1172 1181 1186 2 1 1229 XOR3 $T=277760 386960 0 0 $X=277760 $Y=386580
X3337 1156 1197 1167 2 1 1237 XOR3 $T=280240 397040 1 0 $X=280240 $Y=391620
X3338 1188 1202 66 2 1 68 XOR3 $T=282100 507920 1 0 $X=282100 $Y=502500
X3339 1075 1287 1329 2 1 1370 XOR3 $T=309380 386960 0 0 $X=309380 $Y=386580
X3340 1046 1358 1303 2 1 1429 XOR3 $T=316200 386960 1 0 $X=316200 $Y=381540
X3341 1049 1459 1448 2 1 1530 XOR3 $T=333560 417200 1 0 $X=333560 $Y=411780
X3342 981 1434 1454 2 1 1562 XOR3 $T=338520 417200 0 0 $X=338520 $Y=416820
X3343 1170 1474 1491 2 1 1584 XOR3 $T=340380 366800 0 0 $X=340380 $Y=366420
X3344 1494 1229 1465 2 1 1517 XOR3 $T=354020 386960 0 180 $X=342860 $Y=381540
X3345 988 1451 1587 2 1 1598 XOR3 $T=345340 427280 0 0 $X=345340 $Y=426900
X3346 1081 104 105 2 1 1654 XOR3 $T=350300 366800 1 0 $X=350300 $Y=361380
X3347 1636 1569 1564 2 1 1476 XOR3 $T=363940 397040 1 180 $X=352780 $Y=396660
X3348 1198 1375 1639 2 1 1658 XOR3 $T=355260 366800 0 0 $X=355260 $Y=366420
X3349 1590 1603 1596 2 1 1494 XOR3 $T=375100 397040 0 180 $X=363940 $Y=391620
X3350 126 1729 120 2 1 1670 XOR3 $T=385640 366800 0 180 $X=374480 $Y=361380
X3351 124 1549 1712 2 1 1730 XOR3 $T=394940 376880 0 180 $X=383780 $Y=371460
X3352 1370 1751 1771 2 1 1841 XOR3 $T=387500 386960 0 0 $X=387500 $Y=386580
X3353 1752 1775 1720 2 1 1740 XOR3 $T=400520 397040 0 180 $X=389360 $Y=391620
X3354 1808 1783 1767 2 1 1751 XOR3 $T=400520 407120 0 180 $X=389360 $Y=401700
X3355 131 1584 130 2 1 1798 XOR3 $T=389980 366800 0 0 $X=389980 $Y=366420
X3356 1902 1885 1831 2 1 1820 XOR3 $T=411060 397040 1 180 $X=399900 $Y=396660
X3357 137 1814 143 2 1 131 XOR3 $T=402380 366800 1 0 $X=402380 $Y=361380
X3358 141 1654 1896 2 1 1995 XOR3 $T=411680 366800 0 0 $X=411680 $Y=366420
X3359 1936 1585 2018 2 1 2026 XOR3 $T=416020 487760 0 0 $X=416020 $Y=487380
X3360 1898 1544 2015 2 1 2028 XOR3 $T=416640 497840 0 0 $X=416640 $Y=497460
X3361 1900 1575 2009 2 1 2048 XOR3 $T=419120 447440 1 0 $X=419120 $Y=442020
X3362 1960 2022 1993 2 1 1957 XOR3 $T=431520 457520 0 180 $X=420360 $Y=452100
X3363 1957 1608 1996 2 1 2055 XOR3 $T=420360 457520 0 0 $X=420360 $Y=457140
X3364 1985 1558 2060 2 1 2074 XOR3 $T=422840 487760 1 0 $X=422840 $Y=482340
X3365 1941 2016 2073 2 1 2080 XOR3 $T=424080 477680 0 0 $X=424080 $Y=477300
X3366 2031 1602 2097 2 1 2106 XOR3 $T=427800 467600 1 0 $X=427800 $Y=462180
X3367 152 149 2098 2 1 2109 XOR3 $T=428420 366800 1 0 $X=428420 $Y=361380
X3368 144 146 162 2 1 2116 XOR3 $T=430900 376880 1 0 $X=430900 $Y=371460
X3369 2065 1628 2135 2 1 2131 XOR3 $T=437100 507920 1 0 $X=437100 $Y=502500
X3370 2117 1530 1998 2 1 2151 XOR3 $T=442680 397040 0 0 $X=442680 $Y=396660
X3371 2084 1562 2157 2 1 2170 XOR3 $T=455080 417200 1 0 $X=455080 $Y=411780
X3372 2400 2288 2403 2 1 2456 XOR3 $T=505920 397040 1 0 $X=505920 $Y=391620
X3373 2391 2349 2389 2 1 2463 XOR3 $T=507160 397040 0 0 $X=507160 $Y=396660
X3374 2256 2411 2426 2 1 2464 XOR3 $T=507160 407120 0 0 $X=507160 $Y=406740
X3375 2301 2422 2453 2 1 2475 XOR3 $T=509020 386960 1 0 $X=509020 $Y=381540
X3376 2602 2396 2645 2 1 2734 XOR3 $T=549320 397040 0 0 $X=549320 $Y=396660
X3377 2691 2420 2664 2 1 2744 XOR3 $T=550560 407120 0 0 $X=550560 $Y=406740
X3378 2668 2408 2559 2 1 2756 XOR3 $T=552420 376880 0 0 $X=552420 $Y=376500
X3379 2690 2376 2698 2 1 2775 XOR3 $T=554280 386960 0 0 $X=554280 $Y=386580
X3380 2700 2427 2679 2 1 2798 XOR3 $T=557380 417200 0 0 $X=557380 $Y=416820
X3381 2681 2445 2695 2 1 2799 XOR3 $T=557380 427280 1 0 $X=557380 $Y=421860
X3382 2722 2438 2735 2 1 2834 XOR3 $T=564200 457520 1 0 $X=564200 $Y=452100
X3383 2730 2467 2749 2 1 303 XOR3 $T=564820 497840 0 0 $X=564820 $Y=497460
X3384 2661 2437 2823 2 1 304 XOR3 $T=565440 507920 1 0 $X=565440 $Y=502500
X3385 2757 2463 2739 2 1 2773 XOR3 $T=566060 397040 0 0 $X=566060 $Y=396660
X3386 2768 2444 2743 2 1 2849 XOR3 $T=567920 366800 0 0 $X=567920 $Y=366420
X3387 2737 2416 2767 2 1 320 XOR3 $T=568540 507920 0 0 $X=568540 $Y=507540
X3388 2782 2475 2810 2 1 2795 XOR3 $T=569160 376880 0 0 $X=569160 $Y=376500
X3389 2784 2456 2765 2 1 2783 XOR3 $T=569160 397040 1 0 $X=569160 $Y=391620
X3390 2727 2452 2719 2 1 2903 XOR3 $T=575360 497840 1 0 $X=575360 $Y=492420
X3391 2849 2907 308 2 1 2856 XOR3 $T=591480 366800 1 180 $X=580320 $Y=366420
X3392 2889 2874 2870 2 1 2782 XOR3 $T=592720 397040 0 180 $X=581560 $Y=391620
X3393 310 2833 2853 2 1 317 XOR3 $T=598920 366800 0 180 $X=587760 $Y=361380
X3394 2843 2883 2851 2 1 2784 XOR3 $T=591480 397040 0 0 $X=591480 $Y=396660
X3395 2930 2934 2921 2 1 2857 XOR3 $T=605120 386960 1 180 $X=593960 $Y=386580
X3396 3068 3060 2910 2 1 2997 XOR3 $T=617520 386960 1 180 $X=606360 $Y=386580
X3397 351 347 3151 2 1 3172 XOR3 $T=619380 366800 1 0 $X=619380 $Y=361380
X3398 3134 3179 3100 2 1 3107 XOR3 $T=634260 397040 0 180 $X=623100 $Y=391620
X3399 3107 2568 3205 2 1 3167 XOR3 $T=626820 376880 0 0 $X=626820 $Y=376500
X3400 365 303 3171 2 1 3259 XOR3 $T=631160 507920 1 0 $X=631160 $Y=502500
X3401 3182 3191 3255 2 1 3266 XOR3 $T=632400 427280 1 0 $X=632400 $Y=421860
X3402 3165 2826 3264 2 1 3276 XOR3 $T=633020 477680 0 0 $X=633020 $Y=477300
X3403 3069 2903 3146 2 1 3279 XOR3 $T=635500 487760 1 0 $X=635500 $Y=482340
X3404 3118 2807 3312 2 1 3262 XOR3 $T=639220 376880 0 0 $X=639220 $Y=376500
X3405 3248 3227 3237 2 1 3328 XOR3 $T=641080 437360 0 0 $X=641080 $Y=436980
X3406 3305 2799 3352 2 1 3359 XOR3 $T=647280 427280 1 0 $X=647280 $Y=421860
X3407 3323 2840 3376 2 1 3382 XOR3 $T=652240 487760 1 0 $X=652240 $Y=482340
X3408 3353 2744 3400 2 1 3406 XOR3 $T=658440 397040 1 0 $X=658440 $Y=391620
X3409 3180 2734 3409 2 1 3411 XOR3 $T=660300 376880 0 0 $X=660300 $Y=376500
X3410 3261 3387 3396 2 1 3398 XOR3 $T=662780 477680 1 0 $X=662780 $Y=472260
X3411 3266 2779 3422 2 1 3427 XOR3 $T=664020 427280 1 0 $X=664020 $Y=421860
X3412 3347 3392 3388 2 1 3413 XOR3 $T=664020 457520 1 0 $X=664020 $Y=452100
X3413 534 527 3664 2 1 515 XOR3 $T=747720 507920 1 180 $X=736560 $Y=507540
X3414 3739 562 3717 2 1 3712 XOR3 $T=763220 467600 1 180 $X=752060 $Y=467220
X3415 578 577 567 2 1 534 XOR3 $T=775000 507920 1 180 $X=763840 $Y=507540
X3416 3778 568 3817 2 1 3823 XOR3 $T=767560 477680 1 0 $X=767560 $Y=472260
X3417 3851 3867 3830 2 1 3771 XOR3 $T=791120 477680 0 180 $X=779960 $Y=472260
X3418 3916 592 3910 2 1 3858 XOR3 $T=807240 477680 1 180 $X=796080 $Y=477300
X3419 3960 3951 3930 2 1 3926 XOR3 $T=812200 497840 0 180 $X=801040 $Y=492420
X3420 3939 602 3945 2 1 3947 XOR3 $T=805380 487760 0 0 $X=805380 $Y=487380
X3421 3953 614 3990 2 1 4003 XOR3 $T=810960 477680 1 0 $X=810960 $Y=472260
X3422 3973 618 4006 2 1 4027 XOR3 $T=814680 497840 1 0 $X=814680 $Y=492420
X3423 4071 664 4100 2 1 4098 XOR3 $T=840720 497840 1 0 $X=840720 $Y=492420
X3424 4061 663 4080 2 1 4119 XOR3 $T=843820 487760 1 0 $X=843820 $Y=482340
X3425 700 4190 698 2 1 4225 XOR3 $T=872960 507920 0 0 $X=872960 $Y=507540
X3426 4315 752 4344 2 1 4355 XOR3 $T=908300 487760 1 0 $X=908300 $Y=482340
X3427 4354 777 4424 2 1 4428 XOR3 $T=925660 487760 0 0 $X=925660 $Y=487380
X3428 4465 802 4519 2 1 4510 XOR3 $T=952320 487760 0 0 $X=952320 $Y=487380
X3429 4515 825 4537 2 1 4498 XOR3 $T=974640 487760 1 180 $X=963480 $Y=487380
X3430 4542 814 4574 2 1 4557 XOR3 $T=965960 487760 1 0 $X=965960 $Y=482340
X3431 4573 4579 4596 2 1 4612 XOR3 $T=975260 477680 1 0 $X=975260 $Y=472260
X3432 4621 837 4648 2 1 4614 XOR3 $T=990140 487760 1 0 $X=990140 $Y=482340
X3433 4612 841 4656 2 1 4642 XOR3 $T=993860 477680 0 0 $X=993860 $Y=477300
X3434 4650 4571 4645 2 1 4691 XOR3 $T=1000060 497840 1 0 $X=1000060 $Y=492420
X3435 4669 848 4697 2 1 4701 XOR3 $T=1005640 497840 0 0 $X=1005640 $Y=497460
X3436 4667 4670 4639 2 1 4669 XOR3 $T=1008120 487760 0 0 $X=1008120 $Y=487380
X3437 4677 854 4730 2 1 4745 XOR3 $T=1013700 477680 1 0 $X=1013700 $Y=472260
X3438 4729 861 4764 2 1 4768 XOR3 $T=1022380 497840 1 0 $X=1022380 $Y=492420
X3439 4743 4724 4734 2 1 4729 XOR3 $T=1038500 487760 1 180 $X=1027340 $Y=487380
X3440 864 4749 4742 2 1 4772 XOR3 $T=1031680 487760 1 0 $X=1031680 $Y=482340
X3441 4785 875 4806 2 1 4818 XOR3 $T=1042220 487760 0 0 $X=1042220 $Y=487380
X3442 4772 870 4780 2 1 4805 XOR3 $T=1043460 497840 0 0 $X=1043460 $Y=497460
X3443 879 4787 4799 2 1 4785 XOR3 $T=1052140 487760 1 0 $X=1052140 $Y=482340
X3444 4816 886 4838 2 1 4837 XOR3 $T=1054620 497840 1 0 $X=1054620 $Y=492420
X3445 4823 4825 887 2 1 888 XOR3 $T=1055240 507920 0 0 $X=1055240 $Y=507540
X3446 2431 2520 260 1 2 AN2B1 $T=522660 437360 1 0 $X=522660 $Y=431940
X3447 2201 47 1 203 2 NR2T $T=469340 427280 0 0 $X=469340 $Y=426900
X3448 2223 43 1 203 2 NR2T $T=474920 437360 1 180 $X=469960 $Y=436980
X3449 2214 2208 1 2200 2 NR2T $T=472440 417200 1 0 $X=472440 $Y=411780
X3450 2283 2251 1 2200 2 NR2T $T=486080 407120 0 180 $X=481120 $Y=401700
X3451 2470 2517 1 2512 2 NR2T $T=526380 427280 0 180 $X=521420 $Y=421860
X3452 2509 2541 1 2526 2 NR2T $T=530100 417200 1 180 $X=525140 $Y=416820
X3453 2550 2576 1 2526 2 NR2T $T=536300 417200 0 180 $X=531340 $Y=411780
X3454 2877 45 1 302 2 NR2T $T=577840 447440 1 0 $X=577840 $Y=442020
X3455 1174 38 1 1190 1159 38 2 MOAI1H $T=271560 417200 0 0 $X=271560 $Y=416820
X3456 1036 1416 1 1582 1586 1559 2 MOAI1H $T=349060 487760 0 0 $X=349060 $Y=487380
X3457 2187 205 1 2221 2229 205 2 MOAI1H $T=469960 437360 1 0 $X=469960 $Y=431940
X3458 2893 2859 1 2879 2847 2859 2 MOAI1H $T=587760 427280 0 180 $X=580320 $Y=421860
X3459 1287 1075 2 1286 1311 1287 1 AOI22H $T=302560 386960 1 0 $X=302560 $Y=381540
X3460 1434 981 2 1454 1475 1434 1 AOI22H $T=331080 427280 1 0 $X=331080 $Y=421860
X3461 1451 988 2 1492 1466 1451 1 AOI22H $T=345340 427280 1 180 $X=337900 $Y=426900
X3462 1603 1590 2 1596 1573 1603 1 AOI22H $T=356500 397040 1 0 $X=356500 $Y=391620
X3463 1549 124 2 1712 1699 1549 1 AOI22H $T=383780 366800 1 180 $X=376340 $Y=366420
X3464 1584 131 2 130 1743 1584 1 AOI22H $T=393080 366800 0 180 $X=385640 $Y=361380
X3465 1783 1808 2 1800 1792 1783 1 AOI22H $T=400520 407120 1 180 $X=393080 $Y=406740
X3466 1885 1902 2 1831 1943 1885 1 AOI22H $T=411060 407120 1 0 $X=411060 $Y=401700
X3467 1608 1957 2 1924 1935 1608 1 AOI22H $T=418500 457520 1 180 $X=411060 $Y=457140
X3468 1900 1575 2 1886 1931 1575 1 AOI22H $T=422220 447440 1 180 $X=414780 $Y=447060
X3469 2031 1602 2 1968 2011 1602 1 AOI22H $T=430280 467600 1 180 $X=422840 $Y=467220
X3470 2065 1628 2 1961 2036 1628 1 AOI22H $T=434000 507920 0 180 $X=426560 $Y=502500
X3471 1604 1941 2 2023 2071 1604 1 AOI22H $T=442680 477680 0 180 $X=435240 $Y=472260
X3472 205 2201 2 2171 2222 2232 1 AOI22H $T=469340 427280 1 0 $X=469340 $Y=421860
X3473 213 2198 2 2231 2241 227 1 AOI22H $T=471200 417200 0 0 $X=471200 $Y=416820
X3474 213 2231 2 2229 2289 237 1 AOI22H $T=481120 417200 0 0 $X=481120 $Y=416820
X3475 2602 2396 2 2645 2658 2396 1 AOI22H $T=545600 397040 1 0 $X=545600 $Y=391620
X3476 2408 2668 2 2559 2641 2408 1 AOI22H $T=555520 376880 0 180 $X=548080 $Y=371460
X3477 2681 2445 2 2695 2705 2445 1 AOI22H $T=558620 427280 1 180 $X=551180 $Y=426900
X3478 2691 2420 2 2664 2665 2420 1 AOI22H $T=553660 417200 1 0 $X=553660 $Y=411780
X3479 2376 2690 2 2698 2663 2376 1 AOI22H $T=563580 386960 0 180 $X=556140 $Y=381540
X3480 2720 2446 2 2712 2746 2446 1 AOI22H $T=567920 437360 0 180 $X=560480 $Y=431940
X3481 2722 2438 2 2735 2748 2438 1 AOI22H $T=562960 447440 0 0 $X=562960 $Y=447060
X3482 310 2833 2 2853 305 2833 1 AOI22H $T=584040 366800 0 180 $X=576600 $Y=361380
X3483 2843 2883 2 2851 2866 2883 1 AOI22H $T=591480 397040 1 180 $X=584040 $Y=396660
X3484 2874 2889 2 2870 2908 2889 1 AOI22H $T=584660 386960 0 0 $X=584660 $Y=386580
X3485 2930 2934 2 2921 2915 2934 1 AOI22H $T=600780 386960 0 180 $X=593340 $Y=381540
X3486 2903 3069 2 3078 3084 2903 1 AOI22H $T=615660 487760 0 0 $X=615660 $Y=487380
X3487 2568 3107 2 3028 3096 2568 1 AOI22H $T=629920 376880 0 180 $X=622480 $Y=371460
X3488 3336 2838 2 3322 3310 2838 1 AOI22H $T=654100 447440 0 180 $X=646660 $Y=442020
X3489 2840 3323 2 3329 3311 2840 1 AOI22H $T=652240 477680 0 0 $X=652240 $Y=477300
X3490 3336 2838 2 3334 3390 2838 1 AOI22H $T=659060 447440 0 0 $X=659060 $Y=447060
X3491 3778 568 2 3780 3772 568 1 AOI22H $T=773760 487760 0 180 $X=766320 $Y=482340
X3492 584 3851 2 3841 3825 584 1 AOI22H $T=788020 487760 0 180 $X=780580 $Y=482340
X3493 3916 592 2 3899 3882 592 1 AOI22H $T=799800 477680 0 180 $X=792360 $Y=472260
X3494 3926 602 2 3927 3922 602 1 AOI22H $T=805380 487760 1 180 $X=797940 $Y=487380
X3495 614 3953 2 3969 3955 614 1 AOI22H $T=814060 487760 1 0 $X=814060 $Y=482340
X3496 618 3973 2 3994 3986 618 1 AOI22H $T=825220 487760 1 180 $X=817780 $Y=487380
X3497 4050 4047 2 4046 4061 4013 1 AOI22H $T=833280 497840 0 0 $X=833280 $Y=497460
X3498 4061 663 2 4066 4065 663 1 AOI22H $T=848780 477680 1 180 $X=841340 $Y=477300
X3499 4125 664 2 4091 4083 664 1 AOI22H $T=857460 487760 1 180 $X=850020 $Y=487380
X3500 4190 700 2 698 4177 4190 1 AOI22H $T=872340 507920 1 0 $X=872340 $Y=502500
X3501 4354 777 2 4398 4383 777 1 AOI22H $T=927520 497840 1 0 $X=927520 $Y=492420
X3502 4542 814 2 4530 4521 814 1 AOI22H $T=966580 477680 1 180 $X=959140 $Y=477300
X3503 825 4515 2 4503 4522 825 1 AOI22H $T=978980 497840 0 180 $X=971540 $Y=492420
X3504 837 4621 2 4616 4607 837 1 AOI22H $T=993860 477680 1 180 $X=986420 $Y=477300
X3505 841 4612 2 4626 4620 841 1 AOI22H $T=992000 477680 1 0 $X=992000 $Y=472260
X3506 4571 4650 2 4645 4634 4571 1 AOI22H $T=1006260 487760 1 180 $X=998820 $Y=487380
X3507 4724 4743 2 4734 4728 4724 1 AOI22H $T=1027960 487760 0 180 $X=1020520 $Y=482340
X3508 855 4691 2 4726 4709 855 1 AOI22H $T=1022380 497840 0 0 $X=1022380 $Y=497460
X3509 4749 864 2 4742 4755 4749 1 AOI22H $T=1027960 477680 0 0 $X=1027960 $Y=477300
X3510 4772 870 2 4776 4778 870 1 AOI22H $T=1033540 497840 1 0 $X=1033540 $Y=492420
X3511 4787 879 2 4796 4792 4787 1 AOI22H $T=1042840 487760 1 0 $X=1042840 $Y=482340
X3512 875 4785 2 4788 4781 875 1 AOI22H $T=1050280 497840 0 180 $X=1042840 $Y=492420
X3513 4816 886 2 4819 4827 886 1 AOI22H $T=1054000 487760 0 0 $X=1054000 $Y=487380
X3514 996 1 1016 1036 2 ND2P $T=242420 487760 1 180 $X=238700 $Y=487380
X3515 1044 1 1031 1051 2 ND2P $T=245520 497840 0 180 $X=241800 $Y=492420
X3516 1059 1 1045 1082 2 ND2P $T=251720 386960 1 180 $X=248000 $Y=386580
X3517 1082 1 1177 1249 2 ND2P $T=290780 386960 0 0 $X=290780 $Y=386580
X3518 1251 1 1177 1258 2 ND2P $T=296360 386960 1 0 $X=296360 $Y=381540
X3519 73 1 1242 1270 2 ND2P $T=296360 437360 0 0 $X=296360 $Y=436980
X3520 1299 1 1311 1303 2 ND2P $T=305660 386960 0 0 $X=305660 $Y=386580
X3521 1350 1 1325 1338 2 ND2P $T=314960 427280 0 0 $X=314960 $Y=426900
X3522 1046 1 1303 1395 2 ND2P $T=324880 386960 1 180 $X=321160 $Y=386580
X3523 1358 1 1303 1423 2 ND2P $T=329220 386960 1 180 $X=325500 $Y=386580
X3524 1459 1 1448 1444 2 ND2P $T=332940 407120 0 0 $X=332940 $Y=406740
X3525 1472 1 1466 1460 2 ND2P $T=336660 427280 1 180 $X=332940 $Y=426900
X3526 1487 1 1475 1492 2 ND2P $T=338520 417200 1 180 $X=334800 $Y=416820
X3527 1435 1 1477 1481 2 ND2P $T=339760 447440 0 180 $X=336040 $Y=442020
X3528 1411 1 1488 1436 2 ND2P $T=336660 437360 0 0 $X=336660 $Y=436980
X3529 1482 1 1499 1502 2 ND2P $T=337280 467600 0 0 $X=337280 $Y=467220
X3530 1508 1 1502 1529 2 ND2P $T=341000 477680 0 0 $X=341000 $Y=477300
X3531 1468 1 1540 1543 2 ND2P $T=349060 487760 0 180 $X=345340 $Y=482340
X3532 1548 1 1552 1564 2 ND2P $T=345960 407120 0 0 $X=345960 $Y=406740
X3533 1561 1 1529 1536 2 ND2P $T=350300 467600 1 180 $X=346580 $Y=467220
X3534 1507 1 1522 1563 2 ND2P $T=350920 447440 1 180 $X=347200 $Y=447060
X3535 1571 1 1440 1601 2 ND2P $T=355260 437360 1 180 $X=351540 $Y=436980
X3536 1586 1 1524 1572 2 ND2P $T=353400 497840 0 0 $X=353400 $Y=497460
X3537 1617 1 1634 1551 2 ND2P $T=363320 427280 1 0 $X=363320 $Y=421860
X3538 1675 1 1644 1661 2 ND2P $T=373860 427280 1 180 $X=370140 $Y=426900
X3539 129 1 1743 1712 2 ND2P $T=386260 366800 0 0 $X=386260 $Y=366420
X3540 1836 1 1792 1831 2 ND2P $T=402380 407120 1 0 $X=402380 $Y=401700
X3541 1891 1 1851 142 2 ND2P $T=410440 507920 1 180 $X=406720 $Y=507540
X3542 1918 1 1908 1895 2 ND2P $T=412920 497840 0 180 $X=409200 $Y=492420
X3543 1912 1 1931 1924 2 ND2P $T=411060 447440 0 0 $X=411060 $Y=447060
X3544 1928 1 1943 1971 2 ND2P $T=412920 397040 0 0 $X=412920 $Y=396660
X3545 146 1 147 1909 2 ND2P $T=414160 366800 1 0 $X=414160 $Y=361380
X3546 1558 1 1965 1982 2 ND2P $T=419120 487760 0 180 $X=415400 $Y=482340
X3547 1907 1 1970 1963 2 ND2P $T=419740 397040 0 180 $X=416020 $Y=391620
X3548 1958 1 1940 2043 2 ND2P $T=416640 407120 0 0 $X=416640 $Y=406740
X3549 1983 1 1935 1968 2 ND2P $T=420360 457520 0 180 $X=416640 $Y=452100
X3550 144 1 147 1892 2 ND2P $T=417880 366800 1 0 $X=417880 $Y=361380
X3551 1985 1 1965 1984 2 ND2P $T=419120 487760 1 0 $X=419120 $Y=482340
X3552 1986 1 1944 1999 2 ND2P $T=419740 427280 1 0 $X=419740 $Y=421860
X3553 149 1 150 2012 2 ND2P $T=422840 366800 0 0 $X=422840 $Y=366420
X3554 2004 1 2011 2023 2 ND2P $T=422840 467600 1 0 $X=422840 $Y=462180
X3555 2003 1 1973 2024 2 ND2P $T=423460 477680 1 0 $X=423460 $Y=472260
X3556 152 1 150 2005 2 ND2P $T=426560 366800 0 0 $X=426560 $Y=366420
X3557 2051 1 2036 155 2 ND2P $T=432140 507920 1 180 $X=428420 $Y=507540
X3558 2042 1 2058 1976 2 ND2P $T=429660 427280 0 0 $X=429660 $Y=426900
X3559 2053 1 2059 1934 2 ND2P $T=434000 447440 0 180 $X=430280 $Y=442020
X3560 2031 1 1968 2004 2 ND2P $T=430280 467600 0 0 $X=430280 $Y=467220
X3561 2061 1 2070 1914 2 ND2P $T=431520 457520 1 0 $X=431520 $Y=452100
X3562 2044 1 2071 1965 2 ND2P $T=431520 477680 1 0 $X=431520 $Y=472260
X3563 2069 1 2077 2020 2 ND2P $T=432760 407120 0 0 $X=432760 $Y=406740
X3564 2079 1 2085 1921 2 ND2P $T=434000 487760 1 0 $X=434000 $Y=482340
X3565 1999 1 2092 2101 2 ND2P $T=439580 427280 1 180 $X=435860 $Y=426900
X3566 2102 1 2078 2054 2 ND2P $T=439580 437360 0 180 $X=435860 $Y=431940
X3567 1598 1 2092 2118 2 ND2P $T=442680 427280 0 180 $X=438960 $Y=421860
X3568 1999 1 1598 2127 2 ND2P $T=443300 427280 0 0 $X=443300 $Y=426900
X3569 2136 1 2119 2087 2 ND2P $T=447020 447440 1 0 $X=447020 $Y=442020
X3570 215 1 2198 2208 2 ND2P $T=472440 417200 0 180 $X=468720 $Y=411780
X3571 2239 1 2203 2253 2 ND2P $T=476160 397040 0 0 $X=476160 $Y=396660
X3572 215 1 2245 2220 2 ND2P $T=482360 427280 1 0 $X=482360 $Y=421860
X3573 2275 1 2258 2288 2 ND2P $T=487320 386960 1 180 $X=483600 $Y=386580
X3574 2370 1 2381 2376 2 ND2P $T=504680 386960 1 180 $X=500960 $Y=386580
X3575 2399 1 2413 2408 2 ND2P $T=506540 376880 0 0 $X=506540 $Y=376500
X3576 2418 1 2423 2428 2 ND2P $T=508400 487760 0 0 $X=508400 $Y=487380
X3577 2450 1 2457 2426 2 ND2P $T=515840 407120 1 0 $X=515840 $Y=401700
X3578 2480 1 2474 2457 2 ND2P $T=519560 407120 1 0 $X=519560 $Y=401700
X3579 2487 1 2306 2525 2 ND2P $T=526380 376880 0 180 $X=522660 $Y=371460
X3580 262 1 2466 2541 2 ND2P $T=532580 427280 1 180 $X=528860 $Y=426900
X3581 2548 1 2558 2568 2 ND2P $T=530100 386960 1 0 $X=530100 $Y=381540
X3582 2633 1 2641 2618 2 ND2P $T=543120 376880 1 0 $X=543120 $Y=371460
X3583 2644 1 2658 2664 2 ND2P $T=545600 397040 0 0 $X=545600 $Y=396660
X3584 2677 1 2663 2645 2 ND2P $T=550560 386960 1 180 $X=546840 $Y=386580
X3585 2678 1 2665 2679 2 ND2P $T=550560 407120 1 180 $X=546840 $Y=406740
X3586 2642 1 2688 2698 2 ND2P $T=548700 376880 0 0 $X=548700 $Y=376500
X3587 2692 1 2705 2712 2 ND2P $T=551180 427280 1 0 $X=551180 $Y=421860
X3588 2634 1 2618 2688 2 ND2P $T=552420 386960 1 0 $X=552420 $Y=381540
X3589 2761 1 2729 2719 2 ND2P $T=561100 487760 1 180 $X=557380 $Y=487380
X3590 2719 1 2727 2750 2 ND2P $T=557380 507920 0 0 $X=557380 $Y=507540
X3591 2723 1 2741 2742 2 ND2P $T=559240 477680 0 0 $X=559240 $Y=477300
X3592 2738 1 2746 2770 2 ND2P $T=564200 427280 1 180 $X=560480 $Y=426900
X3593 2736 1 2748 2762 2 ND2P $T=560480 457520 1 0 $X=560480 $Y=452100
X3594 2434 1 2762 2772 2 ND2P $T=569160 467600 1 180 $X=565440 $Y=467220
X3595 2789 1 2780 2741 2 ND2P $T=566060 477680 0 0 $X=566060 $Y=477300
X3596 2443 1 2809 2788 2 ND2P $T=574120 447440 1 180 $X=570400 $Y=447060
X3597 2854 1 2845 2869 2 ND2P $T=581560 386960 0 180 $X=577840 $Y=381540
X3598 2885 1 2797 2845 2 ND2P $T=584040 376880 1 180 $X=580320 $Y=376500
X3599 2850 1 2866 2870 2 ND2P $T=580320 397040 0 0 $X=580320 $Y=396660
X3600 310 1 2853 312 2 ND2P $T=584040 366800 1 0 $X=584040 $Y=361380
X3601 2719 1 2452 2802 2 ND2P $T=587760 497840 0 0 $X=587760 $Y=497460
X3602 2918 1 2915 2910 2 ND2P $T=593340 386960 0 180 $X=589620 $Y=381540
X3603 2874 1 2870 2949 2 ND2P $T=596440 397040 0 180 $X=592720 $Y=391620
X3604 2949 1 2908 2921 2 ND2P $T=596440 397040 1 0 $X=596440 $Y=391620
X3605 2869 1 2972 2981 2 ND2P $T=600160 376880 1 0 $X=600160 $Y=371460
X3606 3032 1 2981 3028 2 ND2P $T=611940 376880 1 180 $X=608220 $Y=376500
X3607 350 1 3048 345 2 ND2P $T=616280 507920 1 180 $X=612560 $Y=507540
X3608 304 1 3048 356 2 ND2P $T=620000 507920 1 180 $X=616280 $Y=507540
X3609 3089 1 3084 358 2 ND2P $T=621860 497840 1 0 $X=621860 $Y=492420
X3610 3166 1 3124 367 2 ND2P $T=629920 487760 1 0 $X=629920 $Y=482340
X3611 3195 1 3185 3180 2 ND2P $T=635500 397040 1 180 $X=631780 $Y=396660
X3612 3229 1 3175 3230 2 ND2P $T=639840 457520 1 180 $X=636120 $Y=457140
X3613 3269 1 3260 3255 2 ND2P $T=644800 417200 1 180 $X=641080 $Y=416820
X3614 3282 1 3241 3284 2 ND2P $T=644180 386960 0 0 $X=644180 $Y=386580
X3615 3246 1 3292 3139 2 ND2P $T=644180 477680 0 0 $X=644180 $Y=477300
X3616 3308 1 3286 3265 2 ND2P $T=649140 407120 0 180 $X=645420 $Y=401700
X3617 3299 1 3268 3297 2 ND2P $T=650380 407120 1 180 $X=646660 $Y=406740
X3618 3304 1 3311 3170 2 ND2P $T=646660 487760 1 0 $X=646660 $Y=482340
X3619 3321 1 3302 3294 2 ND2P $T=651000 467600 1 180 $X=647280 $Y=467220
X3620 3261 1 3333 3337 2 ND2P $T=650380 477680 1 0 $X=650380 $Y=472260
X3621 3331 1 3178 3343 2 ND2P $T=655960 376880 1 180 $X=652240 $Y=376500
X3622 3266 1 2779 3348 2 ND2P $T=652860 427280 0 0 $X=652860 $Y=426900
X3623 2834 1 3344 3340 2 ND2P $T=657200 447440 1 180 $X=653480 $Y=447060
X3624 2839 1 3350 3378 2 ND2P $T=659060 477680 1 0 $X=659060 $Y=472260
X3625 3347 1 3381 3365 2 ND2P $T=660920 457520 0 0 $X=660920 $Y=457140
X3626 2779 1 3385 3383 2 ND2P $T=665260 427280 0 0 $X=665260 $Y=426900
X3627 3364 1 3390 3381 2 ND2P $T=666500 447440 0 0 $X=666500 $Y=447060
X3628 3651 1 510 3554 2 ND2P $T=737180 427280 1 0 $X=737180 $Y=421860
X3629 527 1 3702 538 2 ND2P $T=748960 507920 0 0 $X=748960 $Y=507540
X3630 534 1 3748 563 2 ND2P $T=760120 507920 1 0 $X=760120 $Y=502500
X3631 562 1 3732 3727 2 ND2P $T=763220 467600 0 0 $X=763220 $Y=467220
X3632 3769 1 3772 3732 2 ND2P $T=764460 477680 0 0 $X=764460 $Y=477300
X3633 3764 1 3774 3759 2 ND2P $T=765080 497840 1 0 $X=765080 $Y=492420
X3634 3789 1 3794 3722 2 ND2P $T=770660 507920 1 0 $X=770660 $Y=502500
X3635 3822 1 3825 3780 2 ND2P $T=778100 477680 0 0 $X=778100 $Y=477300
X3636 3828 1 3831 3813 2 ND2P $T=779960 497840 1 0 $X=779960 $Y=492420
X3637 3873 1 3882 3841 2 ND2P $T=790500 477680 0 0 $X=790500 $Y=477300
X3638 3893 1 3900 3842 2 ND2P $T=794220 487760 0 0 $X=794220 $Y=487380
X3639 3929 1 3922 3899 2 ND2P $T=802280 487760 0 180 $X=798560 $Y=482340
X3640 3926 1 3927 3929 2 ND2P $T=802280 487760 1 0 $X=802280 $Y=482340
X3641 3950 1 3955 3927 2 ND2P $T=808480 487760 1 0 $X=808480 $Y=482340
X3642 3973 1 3994 4001 2 ND2P $T=825220 487760 0 180 $X=821500 $Y=482340
X3643 4001 1 3986 3969 2 ND2P $T=823980 477680 0 0 $X=823980 $Y=477300
X3644 4016 1 4018 3995 2 ND2P $T=825220 487760 1 0 $X=825220 $Y=482340
X3645 4062 1 4065 3994 2 ND2P $T=837620 477680 0 0 $X=837620 $Y=477300
X3646 4061 1 4066 4062 2 ND2P $T=837620 487760 1 0 $X=837620 $Y=482340
X3647 4073 1 4077 4013 2 ND2P $T=840720 497840 0 0 $X=840720 $Y=497460
X3648 4078 1 4083 4066 2 ND2P $T=842580 487760 0 0 $X=842580 $Y=487380
X3649 4071 1 4091 4078 2 ND2P $T=846300 487760 0 0 $X=846300 $Y=487380
X3650 4129 1 4133 4135 2 ND2P $T=856220 497840 1 0 $X=856220 $Y=492420
X3651 4122 1 4126 4125 2 ND2P $T=861180 497840 1 180 $X=857460 $Y=497460
X3652 4151 1 4153 4129 2 ND2P $T=861180 507920 1 0 $X=861180 $Y=502500
X3653 4152 1 4132 4153 2 ND2P $T=861800 507920 0 0 $X=861800 $Y=507540
X3654 687 1 689 4152 2 ND2P $T=863660 497840 0 0 $X=863660 $Y=497460
X3655 4214 1 4217 4132 2 ND2P $T=879160 497840 1 0 $X=879160 $Y=492420
X3656 4231 1 4232 4217 2 ND2P $T=885360 487760 0 0 $X=885360 $Y=487380
X3657 716 1 719 715 2 ND2P $T=885980 507920 0 0 $X=885980 $Y=507540
X3658 4271 1 727 4262 2 ND2P $T=896520 507920 0 180 $X=892800 $Y=502500
X3659 4263 1 4262 4231 2 ND2P $T=894040 507920 0 0 $X=894040 $Y=507540
X3660 4375 1 4383 4337 2 ND2P $T=923180 487760 1 0 $X=923180 $Y=482340
X3661 4465 1 4462 4458 2 ND2P $T=946740 487760 1 180 $X=943020 $Y=487380
X3662 802 1 4462 4454 2 ND2P $T=946740 487760 0 0 $X=946740 $Y=487380
X3663 4493 1 4497 4445 2 ND2P $T=953560 497840 1 0 $X=953560 $Y=492420
X3664 4504 1 4522 4462 2 ND2P $T=959760 487760 1 0 $X=959760 $Y=482340
X3665 4568 1 4521 4503 2 ND2P $T=975260 477680 0 180 $X=971540 $Y=472260
X3666 4542 1 4530 4568 2 ND2P $T=976500 477680 0 0 $X=976500 $Y=477300
X3667 4594 1 4601 4599 2 ND2P $T=979600 467600 0 0 $X=979600 $Y=467220
X3668 4605 1 4607 4530 2 ND2P $T=982700 477680 0 0 $X=982700 $Y=477300
X3669 4617 1 4620 4616 2 ND2P $T=986420 477680 1 0 $X=986420 $Y=472260
X3670 4662 1 4658 4655 2 ND2P $T=1005020 487760 0 180 $X=1001300 $Y=482340
X3671 4719 1 4709 4705 2 ND2P $T=1020520 497840 1 180 $X=1016800 $Y=497460
X3672 864 1 4742 4748 2 ND2P $T=1027960 477680 1 180 $X=1024240 $Y=477300
X3673 4748 1 4755 4734 2 ND2P $T=1027960 487760 1 0 $X=1027960 $Y=482340
X3674 4784 1 4781 4776 2 ND2P $T=1042220 487760 1 180 $X=1038500 $Y=487380
X3675 4790 1 4792 4742 2 ND2P $T=1042220 477680 0 0 $X=1042220 $Y=477300
X3676 4820 1 4827 4788 2 ND2P $T=1055860 497840 0 0 $X=1055860 $Y=497460
X3677 4846 1 4850 4819 2 ND2P $T=1067020 487760 0 0 $X=1067020 $Y=487380
X3678 4851 1 890 4850 2 ND2P $T=1068260 497840 1 0 $X=1068260 $Y=492420
X3679 1913 2075 2087 2 1 2122 XNR3 $T=453220 447440 1 180 $X=442060 $Y=447060
X3680 2446 2720 2712 2 1 2771 XNR3 $T=566680 427280 0 0 $X=566680 $Y=426900
X3681 1159 1153 1143 1 2 1167 MAO222 $T=267220 407120 1 0 $X=267220 $Y=401700
X3682 1172 1181 1186 1 2 1163 MAO222 $T=272800 386960 0 0 $X=272800 $Y=386580
X3683 1068 1376 1425 1 2 1448 MAO222 $T=326120 407120 0 0 $X=326120 $Y=406740
X3684 1170 1474 1491 1 2 1500 MAO222 $T=334800 366800 0 0 $X=334800 $Y=366420
X3685 1713 1695 1589 1 2 1720 MAO222 $T=377580 397040 1 0 $X=377580 $Y=391620
X3686 137 1814 136 1 2 138 MAO222 $T=397420 366800 1 0 $X=397420 $Y=361380
X3687 1960 2022 1993 1 2 2041 MAO222 $T=424700 447440 0 0 $X=424700 $Y=447060
X3688 2006 1971 2035 1 2 2077 MAO222 $T=425320 407120 1 0 $X=425320 $Y=401700
X3689 1913 2075 2087 1 2 1993 MAO222 $T=436480 447440 1 180 $X=431520 $Y=447060
X3690 2391 2349 2389 1 2 2403 MAO222 $T=502200 397040 0 0 $X=502200 $Y=396660
X3691 2757 2463 2739 1 2 2765 MAO222 $T=560480 397040 0 0 $X=560480 $Y=396660
X3692 2661 2437 2759 1 2 2767 MAO222 $T=560480 507920 1 0 $X=560480 $Y=502500
X3693 2782 2475 2791 1 2 2797 MAO222 $T=563580 376880 0 0 $X=563580 $Y=376500
X3694 2784 2456 2765 1 2 2791 MAO222 $T=563580 397040 1 0 $X=563580 $Y=391620
X3695 2737 2416 2767 1 2 300 MAO222 $T=563580 507920 0 0 $X=563580 $Y=507540
X3696 2740 2770 2432 1 2 2809 MAO222 $T=567920 437360 1 0 $X=567920 $Y=431940
X3697 3187 3270 3232 1 2 3291 MAO222 $T=641700 447440 1 0 $X=641700 $Y=442020
X3698 3189 2814 3338 1 2 3350 MAO222 $T=650380 467600 1 0 $X=650380 $Y=462180
X3699 3189 2814 3338 1 2 3333 MAO222 $T=654100 467600 0 0 $X=654100 $Y=467220
X3700 3328 2817 3362 1 2 3322 MAO222 $T=659680 437360 1 180 $X=654720 $Y=436980
X3701 3692 3721 537 1 2 3702 MAO222 $T=757640 507920 0 180 $X=752680 $Y=502500
X3702 3692 3721 537 1 2 3748 MAO222 $T=757020 507920 0 0 $X=757020 $Y=507540
X3703 3768 3713 3759 1 2 567 MAO222 $T=763840 507920 1 0 $X=763840 $Y=502500
X3704 3987 3995 3989 1 2 3930 MAO222 $T=823980 497840 1 180 $X=819020 $Y=497460
X3705 1385 1 1395 1423 2 1425 ND3HT $T=323640 397040 1 0 $X=323640 $Y=391620
X3706 3059 1 349 3038 2 2853 ND3HT $T=617520 366800 0 180 $X=610080 $Y=361380
X3707 361 1 364 368 2 3048 ND3HT $T=627440 507920 0 0 $X=627440 $Y=507540
X3708 3340 1 3354 3365 2 3338 ND3HT $T=653480 457520 0 0 $X=653480 $Y=457140
X3709 3348 1 3373 3383 2 3362 ND3HT $T=657820 427280 0 0 $X=657820 $Y=426900
X3710 3370 1 3337 3378 2 3329 ND3HT $T=668980 477680 1 180 $X=661540 $Y=477300
X3711 4471 1 4458 4454 2 4398 ND3HT $T=947980 487760 0 180 $X=940540 $Y=482340
X3712 1036 1416 1 1518 2 OR2T $T=335420 487760 0 0 $X=335420 $Y=487380
X3713 1493 1051 1 1524 2 OR2T $T=337280 497840 0 0 $X=337280 $Y=497460
X3714 2601 2410 1 2634 2 OR2T $T=546220 386960 1 0 $X=546220 $Y=381540
X3715 2600 2857 1 2885 2 OR2T $T=580940 376880 1 0 $X=580940 $Y=371460
X3716 2997 2756 1 2972 2 OR2T $T=606980 386960 0 180 $X=600780 $Y=381540
X3717 4145 684 1 4133 2 OR2T $T=859940 497840 1 0 $X=859940 $Y=492420
X3718 82 1294 1 1270 1325 2 OAI12H $T=304420 437360 0 0 $X=304420 $Y=436980
X3719 1320 1327 1 1338 1315 2 OAI12H $T=308760 427280 0 0 $X=308760 $Y=426900
X3720 1483 1035 1 1521 1499 2 OAI12H $T=339140 457520 0 0 $X=339140 $Y=457140
X3721 1555 1142 1 1572 1577 2 OAI12H $T=347200 497840 0 0 $X=347200 $Y=497460
X3722 1934 1601 1 1976 1951 2 OAI12H $T=422840 437360 1 180 $X=416640 $Y=436980
X3723 1568 1987 1 2050 2058 2 OAI12H $T=425940 437360 1 0 $X=425940 $Y=431940
X3724 2083 1850 1 2068 2085 2 OAI12H $T=449500 487760 1 180 $X=443300 $Y=487380
X3725 2887 2899 1 2871 2916 2 OAI12H $T=585900 417200 1 0 $X=585900 $Y=411780
X3726 339 2998 1 3017 3055 2 OAI12H $T=609460 437360 1 0 $X=609460 $Y=431940
X3727 3136 3190 1 3173 365 2 OAI12H $T=636120 487760 0 0 $X=636120 $Y=487380
X3728 2277 2281 2239 2 236 239 1 AO22S $T=484220 366800 0 0 $X=484220 $Y=366420
X3729 2404 241 2357 2 2337 239 1 AO22S $T=502820 366800 0 180 $X=497860 $Y=361380
X3730 2434 233 2398 2 2356 251 1 AO22S $T=513360 457520 1 180 $X=508400 $Y=457140
X3731 2731 288 2715 2 2620 285 1 AO22S $T=558620 467600 1 180 $X=553660 $Y=467220
X3732 505 482 3628 2 3497 477 1 AO22S $T=732220 477680 0 180 $X=727260 $Y=472260
X3733 511 482 3640 2 3568 477 1 AO22S $T=734700 467600 0 180 $X=729740 $Y=462180
X3734 521 482 3659 2 3486 477 1 AO22S $T=740900 467600 0 180 $X=735940 $Y=462180
X3735 524 482 3676 2 3579 477 1 AO22S $T=744620 457520 0 180 $X=739660 $Y=452100
X3736 541 482 3696 2 3555 477 1 AO22S $T=751440 457520 0 180 $X=746480 $Y=452100
X3737 691 482 4134 2 3850 477 1 AO22S $T=867380 457520 1 180 $X=862420 $Y=457140
X3738 4650 4608 4657 2 845 800 1 AO22S $T=1004400 507920 0 180 $X=999440 $Y=502500
X3739 1029 1042 2 1025 1 995 MUX2S $T=244280 477680 0 180 $X=239940 $Y=472260
X3740 1047 1050 2 1030 1 1003 MUX2S $T=245520 457520 1 180 $X=241180 $Y=457140
X3741 1021 1042 2 1034 1 1001 MUX2S $T=246140 467600 0 180 $X=241800 $Y=462180
X3742 1037 1042 2 1039 1 1004 MUX2S $T=247380 487760 0 180 $X=243040 $Y=482340
X3743 1038 1042 2 1043 1 984 MUX2S $T=248000 467600 1 180 $X=243660 $Y=467220
X3744 1023 1042 2 1058 1 1070 MUX2S $T=244280 487760 0 0 $X=244280 $Y=487380
X3745 1033 1042 2 1066 1 1061 MUX2S $T=245520 477680 1 0 $X=245520 $Y=472260
X3746 1067 1065 2 1060 1 1038 MUX2S $T=251720 457520 1 180 $X=247380 $Y=457140
X3747 1032 1042 2 1077 1 1017 MUX2S $T=248620 487760 1 0 $X=248620 $Y=482340
X3748 1076 1065 2 1072 1 1043 MUX2S $T=254200 467600 1 180 $X=249860 $Y=467220
X3749 1060 1065 2 1076 1 1030 MUX2S $T=255440 467600 0 180 $X=251100 $Y=462180
X3750 1092 1065 2 1072 1 1066 MUX2S $T=255440 477680 0 180 $X=251100 $Y=472260
X3751 1107 1065 2 1072 1 1077 MUX2S $T=257920 477680 1 180 $X=253580 $Y=477300
X3752 1090 1065 2 1072 1 1058 MUX2S $T=257920 487760 1 180 $X=253580 $Y=487380
X3753 1100 1065 2 1090 1 1039 MUX2S $T=258540 487760 0 180 $X=254200 $Y=482340
X3754 1106 1065 2 1093 1 1032 MUX2S $T=259160 457520 0 180 $X=254820 $Y=452100
X3755 1034 1057 2 1072 1 31 MUX2S $T=254820 497840 1 0 $X=254820 $Y=492420
X3756 1071 1065 2 1099 1 1033 MUX2S $T=260400 467600 0 180 $X=256060 $Y=462180
X3757 1074 1065 2 1100 1 1023 MUX2S $T=260400 467600 1 180 $X=256060 $Y=467220
X3758 1039 1057 2 1072 1 1129 MUX2S $T=256680 497840 0 0 $X=256680 $Y=497460
X3759 1099 1065 2 1092 1 1025 MUX2S $T=263500 477680 0 180 $X=259160 $Y=472260
X3760 1093 1065 2 1107 1 1034 MUX2S $T=263500 477680 1 180 $X=259160 $Y=477300
X3761 1025 1057 2 1072 1 1126 MUX2S $T=259780 487760 0 0 $X=259780 $Y=487380
X3762 1113 1131 2 1125 1 1074 MUX2S $T=265980 467600 0 180 $X=261640 $Y=462180
X3763 1125 1131 2 1132 1 1093 MUX2S $T=268460 467600 1 180 $X=264120 $Y=467220
X3764 1151 1131 2 1136 1 1076 MUX2S $T=269080 477680 1 180 $X=264740 $Y=477300
X3765 1157 1131 2 1133 1 1107 MUX2S $T=269700 487760 0 180 $X=265360 $Y=482340
X3766 1176 1131 2 1149 1 1071 MUX2S $T=272180 457520 1 180 $X=267840 $Y=457140
X3767 1149 1131 2 1154 1 1060 MUX2S $T=272800 467600 0 180 $X=268460 $Y=462180
X3768 1154 1131 2 1151 1 1099 MUX2S $T=274040 477680 0 180 $X=269700 $Y=472260
X3769 1132 1131 2 1157 1 1100 MUX2S $T=274040 477680 1 180 $X=269700 $Y=477300
X3770 1180 35 2 1166 1 1151 MUX2S $T=274660 487760 0 180 $X=270320 $Y=482340
X3771 1184 35 2 1164 1 1136 MUX2S $T=275280 487760 1 180 $X=270940 $Y=487380
X3772 1179 37 2 1182 1 1113 MUX2S $T=278380 457520 1 180 $X=274040 $Y=457140
X3773 1182 37 2 1183 1 1149 MUX2S $T=278380 467600 0 180 $X=274040 $Y=462180
X3774 1183 37 2 1191 1 1125 MUX2S $T=279620 467600 1 180 $X=275280 $Y=467220
X3775 1191 37 2 1192 1 1154 MUX2S $T=279620 477680 0 180 $X=275280 $Y=472260
X3776 1192 37 2 1180 1 1132 MUX2S $T=279620 477680 1 180 $X=275280 $Y=477300
X3777 1166 37 2 1184 1 1157 MUX2S $T=279620 487760 0 180 $X=275280 $Y=482340
X3778 1222 1215 2 1216 1 1243 MUX2S $T=288300 477680 1 0 $X=288300 $Y=472260
X3779 1235 1215 2 1232 1 1263 MUX2S $T=292020 467600 0 0 $X=292020 $Y=467220
X3780 1218 1211 2 1236 1 1273 MUX2S $T=294500 447440 1 0 $X=294500 $Y=442020
X3781 1265 75 2 1279 1 1285 MUX2S $T=296980 487760 0 0 $X=296980 $Y=487380
X3782 60 67 2 72 1 79 MUX2S $T=298220 366800 1 0 $X=298220 $Y=361380
X3783 1263 1275 2 1243 1 1288 MUX2S $T=298220 467600 1 0 $X=298220 $Y=462180
X3784 1293 81 2 1308 1 1312 MUX2S $T=303800 477680 1 0 $X=303800 $Y=472260
X3785 1284 1289 2 1298 1 1313 MUX2S $T=304420 437360 1 0 $X=304420 $Y=431940
X3786 1262 1275 2 1267 1 1309 MUX2S $T=304420 467600 1 0 $X=304420 $Y=462180
X3787 1301 1302 2 1319 1 1330 MUX2S $T=306280 417200 0 0 $X=306280 $Y=416820
X3788 1312 1326 2 1304 1 78 MUX2S $T=312480 507920 0 180 $X=308140 $Y=502500
X3789 1335 1326 2 1304 1 1261 MUX2S $T=313100 497840 1 180 $X=308760 $Y=497460
X3790 1317 81 2 1293 1 1346 MUX2S $T=310000 467600 1 0 $X=310000 $Y=462180
X3791 1321 1326 2 1335 1 1347 MUX2S $T=310000 477680 0 0 $X=310000 $Y=477300
X3792 1272 1289 2 1290 1 1342 MUX2S $T=310620 437360 0 0 $X=310620 $Y=436980
X3793 1305 81 2 1314 1 1355 MUX2S $T=312480 467600 0 0 $X=312480 $Y=467220
X3794 1336 1302 2 1343 1 1359 MUX2S $T=313720 437360 1 0 $X=313720 $Y=431940
X3795 1355 1326 2 1304 1 89 MUX2S $T=318680 507920 0 180 $X=314340 $Y=502500
X3796 1315 1302 2 1360 1 1367 MUX2S $T=314960 437360 0 0 $X=314960 $Y=436980
X3797 1308 81 2 1304 1 1374 MUX2S $T=315580 477680 0 0 $X=315580 $Y=477300
X3798 1295 1289 2 1305 1 1360 MUX2S $T=316200 457520 1 0 $X=316200 $Y=452100
X3799 1288 81 2 1291 1 1378 MUX2S $T=316200 467600 1 0 $X=316200 $Y=462180
X3800 1363 1326 2 1355 1 1380 MUX2S $T=318060 467600 0 0 $X=318060 $Y=467220
X3801 1343 1326 2 1364 1 1390 MUX2S $T=319920 477680 1 0 $X=319920 $Y=472260
X3802 1346 1326 2 1374 1 1399 MUX2S $T=321160 477680 0 0 $X=321160 $Y=477300
X3803 1616 108 2 1595 1 1641 MUX2S $T=360840 467600 0 0 $X=360840 $Y=467220
X3804 1595 108 2 1627 1 1651 MUX2S $T=361460 477680 1 0 $X=361460 $Y=472260
X3805 1627 108 2 1626 1 1643 MUX2S $T=361460 477680 0 0 $X=361460 $Y=477300
X3806 1612 108 2 1633 1 1647 MUX2S $T=362080 457520 0 0 $X=362080 $Y=457140
X3807 1614 111 2 1657 1 1656 MUX2S $T=366420 497840 1 0 $X=366420 $Y=492420
X3808 1640 108 2 1614 1 1669 MUX2S $T=367040 487760 0 0 $X=367040 $Y=487380
X3809 1651 114 2 1645 1 1686 MUX2S $T=367660 477680 0 0 $X=367660 $Y=477300
X3810 1623 113 2 1650 1 1673 MUX2S $T=368280 457520 0 0 $X=368280 $Y=457140
X3811 1641 113 2 1643 1 1696 MUX2S $T=372620 467600 1 0 $X=372620 $Y=462180
X3812 1669 114 2 1674 1 1709 MUX2S $T=373240 477680 1 0 $X=373240 $Y=472260
X3813 1647 113 2 1641 1 1707 MUX2S $T=373860 457520 0 0 $X=373860 $Y=457140
X3814 1705 1694 2 1678 1 1680 MUX2S $T=379440 497840 1 180 $X=375100 $Y=497460
X3815 1686 1714 2 1690 1 1697 MUX2S $T=381300 477680 1 180 $X=376960 $Y=477300
X3816 1673 1714 2 1686 1 1703 MUX2S $T=382540 467600 0 180 $X=378200 $Y=462180
X3817 1704 1714 2 1693 1 1705 MUX2S $T=382540 487760 1 180 $X=378200 $Y=487380
X3818 1697 1694 2 1678 1 1711 MUX2S $T=383780 497840 0 180 $X=379440 $Y=492420
X3819 1690 1714 2 1678 1 1735 MUX2S $T=381300 487760 1 0 $X=381300 $Y=482340
X3820 1698 1714 2 1696 1 1746 MUX2S $T=383160 467600 1 0 $X=383160 $Y=462180
X3821 1718 123 2 1683 1 1744 MUX2S $T=383780 437360 0 0 $X=383780 $Y=436980
X3822 1696 1714 2 1709 1 1753 MUX2S $T=383780 467600 0 0 $X=383780 $Y=467220
X3823 1709 1714 2 1678 1 1747 MUX2S $T=383780 477680 0 0 $X=383780 $Y=477300
X3824 1693 1714 2 1678 1 1758 MUX2S $T=384400 487760 0 0 $X=384400 $Y=487380
X3825 1703 1694 2 1735 1 1760 MUX2S $T=385640 487760 1 0 $X=385640 $Y=482340
X3826 1664 121 2 1668 1 1770 MUX2S $T=386260 457520 0 0 $X=386260 $Y=457140
X3827 1668 1714 2 1659 1 1774 MUX2S $T=388740 467600 1 0 $X=388740 $Y=462180
X3828 1749 1769 2 1774 1 1786 MUX2S $T=389360 457520 1 0 $X=389360 $Y=452100
X3829 1659 1714 2 1678 1 1785 MUX2S $T=389360 477680 0 0 $X=389360 $Y=477300
X3830 1722 1694 2 1705 1 1787 MUX2S $T=389980 487760 1 0 $X=389980 $Y=482340
X3831 1770 1694 2 1785 1 1778 MUX2S $T=397420 477680 0 180 $X=393080 $Y=472260
X3832 1753 1694 2 1678 1 1754 MUX2S $T=398660 497840 0 180 $X=394320 $Y=492420
X3833 1745 1769 2 1753 1 1813 MUX2S $T=394940 457520 0 0 $X=394940 $Y=457140
X3834 1723 1694 2 1758 1 1780 MUX2S $T=399280 487760 1 180 $X=394940 $Y=487380
X3835 2029 168 2 2142 1 170 MUX2S $T=445780 386960 1 0 $X=445780 $Y=381540
X3836 169 168 2 2147 1 2150 MUX2S $T=447640 507920 0 0 $X=447640 $Y=507540
X3837 172 168 2 2160 1 191 MUX2S $T=454460 507920 1 0 $X=454460 $Y=502500
X3838 179 168 2 195 1 197 MUX2S $T=456940 366800 0 0 $X=456940 $Y=366420
X3839 194 168 2 189 1 184 MUX2S $T=461280 376880 0 180 $X=456940 $Y=371460
X3840 190 168 2 179 1 183 MUX2S $T=461280 376880 1 180 $X=456940 $Y=376500
X3841 181 168 2 2162 1 198 MUX2S $T=456940 507920 0 0 $X=456940 $Y=507540
X3842 189 168 2 196 1 2124 MUX2S $T=457560 366800 1 0 $X=457560 $Y=361380
X3843 2160 168 2 2152 1 2161 MUX2S $T=457560 467600 0 0 $X=457560 $Y=467220
X3844 2162 168 2 2168 1 2176 MUX2S $T=459420 477680 1 0 $X=459420 $Y=472260
X3845 1864 168 2 2126 1 2199 MUX2S $T=462520 386960 0 0 $X=462520 $Y=386580
X3846 2126 168 2 204 1 2179 MUX2S $T=463760 386960 1 0 $X=463760 $Y=381540
X3847 178 168 2 210 1 2190 MUX2S $T=464380 366800 0 0 $X=464380 $Y=366420
X3848 204 168 2 211 1 2167 MUX2S $T=464380 376880 1 0 $X=464380 $Y=371460
X3849 2172 205 2 2188 1 2204 MUX2S $T=466240 467600 1 0 $X=466240 $Y=462180
X3850 2175 205 2 2189 1 2219 MUX2S $T=469960 487760 1 0 $X=469960 $Y=482340
X3851 2192 205 2 2210 1 2240 MUX2S $T=471820 477680 1 0 $X=471820 $Y=472260
X3852 216 205 2 2230 1 223 MUX2S $T=472440 366800 1 0 $X=472440 $Y=361380
X3853 2226 2227 2 2216 1 2215 MUX2S $T=476780 467600 0 180 $X=472440 $Y=462180
X3854 2189 205 2 2236 1 2234 MUX2S $T=473060 487760 0 0 $X=473060 $Y=487380
X3855 2234 2227 2 2246 1 2249 MUX2S $T=475540 487760 1 0 $X=475540 $Y=482340
X3856 2204 2227 2 2240 1 2274 MUX2S $T=478020 467600 1 0 $X=478020 $Y=462180
X3857 2236 226 2 2267 1 2269 MUX2S $T=478640 487760 0 0 $X=478640 $Y=487380
X3858 2219 2227 2 2269 1 2298 MUX2S $T=481120 477680 1 0 $X=481120 $Y=472260
X3859 2298 2282 2 2287 1 2316 MUX2S $T=487320 477680 1 0 $X=487320 $Y=472260
X3860 2249 2282 2 2287 1 2318 MUX2S $T=487320 477680 0 0 $X=487320 $Y=477300
X3861 2297 2300 2 2287 1 243 MUX2S $T=487940 497840 0 0 $X=487940 $Y=497460
X3862 2272 2282 2 2286 1 2322 MUX2S $T=489180 467600 0 0 $X=489180 $Y=467220
X3863 2279 2282 2 2287 1 2330 MUX2S $T=489800 487760 0 0 $X=489800 $Y=487380
X3864 2319 235 2 2297 1 2334 MUX2S $T=492280 457520 1 0 $X=492280 $Y=452100
X3865 2315 2300 2 2316 1 2353 MUX2S $T=492900 477680 1 0 $X=492900 $Y=472260
X3866 2308 2300 2 2318 1 2345 MUX2S $T=492900 477680 0 0 $X=492900 $Y=477300
X3867 2311 2300 2 2322 1 2356 MUX2S $T=494760 467600 1 0 $X=494760 $Y=462180
X3868 2290 2300 2 2317 1 2363 MUX2S $T=494760 467600 0 0 $X=494760 $Y=467220
X3869 2317 2300 2 2287 1 246 MUX2S $T=494760 497840 0 0 $X=494760 $Y=497460
X3870 2322 2300 2 2287 1 250 MUX2S $T=495380 497840 1 0 $X=495380 $Y=492420
X3871 2296 2300 2 2330 1 2368 MUX2S $T=496620 487760 0 0 $X=496620 $Y=487380
X3872 2326 2300 2 2333 1 2383 MUX2S $T=497240 487760 1 0 $X=497240 $Y=482340
X3873 2447 2462 2 2439 1 2477 MUX2S $T=515840 467600 0 0 $X=515840 $Y=467220
X3874 2439 2462 2 2448 1 2486 MUX2S $T=515840 477680 1 0 $X=515840 $Y=472260
X3875 2448 2462 2 2472 1 2492 MUX2S $T=515840 477680 0 0 $X=515840 $Y=477300
X3876 2472 2462 2 2497 1 2515 MUX2S $T=520800 487760 1 0 $X=520800 $Y=482340
X3877 2485 2462 2 2447 1 2518 MUX2S $T=521420 467600 0 0 $X=521420 $Y=467220
X3878 2477 2491 2 2492 1 2523 MUX2S $T=521420 477680 1 0 $X=521420 $Y=472260
X3879 2492 2491 2 2514 1 2519 MUX2S $T=521420 477680 0 0 $X=521420 $Y=477300
X3880 2497 2462 2 2498 1 2514 MUX2S $T=522040 487760 0 0 $X=522040 $Y=487380
X3881 2498 2462 2 2488 1 2532 MUX2S $T=522040 497840 1 0 $X=522040 $Y=492420
X3882 2488 2462 2 2493 1 2530 MUX2S $T=522660 497840 0 0 $X=522660 $Y=497460
X3883 2471 260 2 2500 1 2536 MUX2S $T=523900 447440 0 0 $X=523900 $Y=447060
X3884 2514 2491 2 2530 1 2546 MUX2S $T=526380 487760 1 0 $X=526380 $Y=482340
X3885 2522 265 2 2477 1 2555 MUX2S $T=527000 467600 0 0 $X=527000 $Y=467220
X3886 2518 2491 2 2486 1 2551 MUX2S $T=527000 477680 1 0 $X=527000 $Y=472260
X3887 2515 2491 2 2532 1 2560 MUX2S $T=527620 497840 1 0 $X=527620 $Y=492420
X3888 2566 2549 2 2516 1 276 MUX2S $T=533200 507920 1 180 $X=528860 $Y=507540
X3889 2547 279 2 2516 1 2574 MUX2S $T=530100 507920 1 0 $X=530100 $Y=502500
X3890 2519 2557 2 2556 1 2566 MUX2S $T=531960 487760 1 0 $X=531960 $Y=482340
X3891 2554 2557 2 2552 1 2586 MUX2S $T=532580 467600 0 0 $X=532580 $Y=467220
X3892 2595 2549 2 2516 1 283 MUX2S $T=538780 507920 0 180 $X=534440 $Y=502500
X3893 2546 2557 2 2516 1 2637 MUX2S $T=537540 477680 0 0 $X=537540 $Y=477300
X3894 2553 2585 2 2507 1 2606 MUX2S $T=538160 427280 0 0 $X=538160 $Y=426900
X3895 2553 279 2 2523 1 2619 MUX2S $T=538160 467600 1 0 $X=538160 $Y=462180
X3896 2587 2549 2 2612 1 2627 MUX2S $T=538160 497840 1 0 $X=538160 $Y=492420
X3897 2588 2549 2 2574 1 2621 MUX2S $T=538160 497840 0 0 $X=538160 $Y=497460
X3898 2586 2549 2 2617 1 2626 MUX2S $T=538780 487760 1 0 $X=538780 $Y=482340
X3899 2594 2549 2 2516 1 289 MUX2S $T=538780 507920 1 0 $X=538780 $Y=502500
X3900 2599 2571 2 2594 1 2653 MUX2S $T=541260 457520 1 0 $X=541260 $Y=452100
X3901 2619 2549 2 2637 1 2651 MUX2S $T=542500 477680 1 0 $X=542500 $Y=472260
X3902 2565 2557 2 2516 1 2617 MUX2S $T=543120 487760 0 0 $X=543120 $Y=487380
X3903 2822 2825 2 2831 1 2867 MUX2S $T=576600 467600 1 0 $X=576600 $Y=462180
X3904 2831 2825 2 2828 1 2864 MUX2S $T=576600 467600 0 0 $X=576600 $Y=467220
X3905 2828 2825 2 2868 1 2902 MUX2S $T=582180 467600 0 0 $X=582180 $Y=467220
X3906 2868 2825 2 2861 1 2898 MUX2S $T=582180 477680 1 0 $X=582180 $Y=472260
X3907 2861 2825 2 2886 1 2888 MUX2S $T=582180 477680 0 0 $X=582180 $Y=477300
X3908 2855 2825 2 2822 1 2900 MUX2S $T=582800 467600 1 0 $X=582800 $Y=462180
X3909 2886 2825 2 2880 1 2906 MUX2S $T=587140 487760 1 0 $X=587140 $Y=482340
X3910 2902 2905 2 2888 1 2926 MUX2S $T=587760 467600 0 0 $X=587760 $Y=467220
X3911 2880 311 2 2891 1 2913 MUX2S $T=587760 487760 0 0 $X=587760 $Y=487380
X3912 2906 2905 2 2920 1 2928 MUX2S $T=589000 477680 0 0 $X=589000 $Y=477300
X3913 2900 2905 2 2864 1 2963 MUX2S $T=593960 457520 0 0 $X=593960 $Y=457140
X3914 2977 2974 2 2911 1 2950 MUX2S $T=602020 477680 1 180 $X=597680 $Y=477300
X3915 2952 2959 2 2911 1 2984 MUX2S $T=598920 467600 0 0 $X=598920 $Y=467220
X3916 2963 2959 2 2947 1 2994 MUX2S $T=599540 457520 0 0 $X=599540 $Y=457140
X3917 2947 2959 2 2953 1 2989 MUX2S $T=599540 477680 1 0 $X=599540 $Y=472260
X3918 2989 2974 2 2911 1 2942 MUX2S $T=603880 487760 0 180 $X=599540 $Y=482340
X3919 2953 2959 2 2911 1 3002 MUX2S $T=602020 477680 0 0 $X=602020 $Y=477300
X3920 2969 325 2 2924 1 3022 MUX2S $T=603260 447440 1 0 $X=603260 $Y=442020
X3921 2988 2974 2 2984 1 3010 MUX2S $T=603260 467600 0 0 $X=603260 $Y=467220
X3922 2928 2959 2 2911 1 3014 MUX2S $T=603880 477680 1 0 $X=603880 $Y=472260
X3923 2933 2959 2 2957 1 3026 MUX2S $T=605120 457520 0 0 $X=605120 $Y=457140
X3924 2951 2959 2 2925 1 3034 MUX2S $T=605740 457520 1 0 $X=605740 $Y=452100
X3925 2994 2974 2 3002 1 3030 MUX2S $T=606360 477680 0 0 $X=606360 $Y=477300
X3926 2917 2959 2 2911 1 3036 MUX2S $T=607600 467600 0 0 $X=607600 $Y=467220
X3927 3026 2974 2 3014 1 3020 MUX2S $T=612560 477680 0 180 $X=608220 $Y=472260
X3928 2957 2959 2 2928 1 3044 MUX2S $T=608840 467600 1 0 $X=608840 $Y=462180
X3929 2912 325 2 2951 1 3058 MUX2S $T=610080 447440 1 0 $X=610080 $Y=442020
X3930 3044 2974 2 2911 1 3024 MUX2S $T=614420 487760 0 180 $X=610080 $Y=482340
X3931 3023 2974 2 2977 1 3064 MUX2S $T=610700 457520 0 0 $X=610700 $Y=457140
X3932 3041 2974 2 3044 1 3067 MUX2S $T=611940 457520 1 0 $X=611940 $Y=452100
X3933 2983 2974 2 2989 1 3062 MUX2S $T=611940 467600 0 0 $X=611940 $Y=467220
X3934 3034 2974 2 3036 1 3056 MUX2S $T=613180 467600 1 0 $X=613180 $Y=462180
X3935 3058 3052 2 3003 1 3080 MUX2S $T=616280 447440 1 0 $X=616280 $Y=442020
X3936 376 389 2 3325 1 384 MUX2S $T=654720 507920 0 180 $X=650380 $Y=502500
X3937 340 389 2 3405 1 400 MUX2S $T=665880 497840 0 0 $X=665880 $Y=497460
X3938 3426 389 2 3403 1 3437 MUX2S $T=673320 467600 1 0 $X=673320 $Y=462180
X3939 3093 389 2 412 1 3384 MUX2S $T=673940 366800 0 0 $X=673940 $Y=366420
X3940 3421 389 2 3412 1 3367 MUX2S $T=673940 457520 0 0 $X=673940 $Y=457140
X3941 3325 389 2 3421 1 3434 MUX2S $T=673940 487760 0 0 $X=673940 $Y=487380
X3942 3410 389 2 3431 1 3443 MUX2S $T=678280 457520 0 0 $X=678280 $Y=457140
X3943 3391 389 2 3425 1 3355 MUX2S $T=681380 467600 1 0 $X=681380 $Y=462180
X3944 3425 389 2 3447 1 3450 MUX2S $T=682000 447440 0 0 $X=682000 $Y=447060
X3945 3403 389 2 3438 1 3455 MUX2S $T=683240 437360 0 0 $X=683240 $Y=436980
X3946 535 379 2 3701 1 542 MUX2S $T=747720 497840 1 0 $X=747720 $Y=492420
X3947 3655 379 2 3706 1 3556 MUX2S $T=748340 487760 1 0 $X=748340 $Y=482340
X3948 3675 379 2 3707 1 3667 MUX2S $T=748960 477680 1 0 $X=748960 $Y=472260
X3949 3689 379 2 3751 1 3761 MUX2S $T=759500 467600 1 0 $X=759500 $Y=462180
X3950 3701 379 2 3766 1 3763 MUX2S $T=768800 467600 0 180 $X=764460 $Y=462180
X3951 3706 379 2 3777 1 3776 MUX2S $T=771280 457520 1 180 $X=766940 $Y=457140
X3952 3707 379 2 3937 1 3885 MUX2S $T=809100 477680 0 180 $X=804760 $Y=472260
X3953 4333 4313 2 4332 1 4319 MUX2S $T=918220 477680 0 180 $X=913880 $Y=472260
X3954 780 4313 2 4414 1 4417 MUX2S $T=928140 477680 1 0 $X=928140 $Y=472260
X3955 4332 4313 2 4439 1 4435 MUX2S $T=942400 467600 1 180 $X=938060 $Y=467220
X3956 4434 4313 2 4449 1 4447 MUX2S $T=945500 477680 0 180 $X=941160 $Y=472260
X3957 4325 4313 2 4477 1 4474 MUX2S $T=951700 457520 0 180 $X=947360 $Y=452100
X3958 4449 4313 2 4546 1 4540 MUX2S $T=970300 467600 1 180 $X=965960 $Y=467220
X3959 4439 4313 2 4553 1 4534 MUX2S $T=972780 457520 1 180 $X=968440 $Y=457140
X3960 4486 4313 2 4585 1 4526 MUX2S $T=980840 457520 1 180 $X=976500 $Y=457140
X3961 4477 4313 2 4683 1 4654 MUX2S $T=1014940 457520 0 180 $X=1010600 $Y=452100
X3962 1533 1 1509 1575 2 ND2T $T=354640 447440 0 180 $X=349680 $Y=442020
X3963 1923 1 1951 1886 2 ND2T $T=411680 437360 0 0 $X=411680 $Y=436980
X3964 3266 1 3385 3373 2 ND2T $T=660300 437360 0 0 $X=660300 $Y=436980
X3965 1532 101 1523 2 1 1594 QDFFRBS $T=344100 427280 1 0 $X=344100 $Y=421860
X3966 1665 101 1523 2 1 125 QDFFRBS $T=370760 376880 0 0 $X=370760 $Y=376500
X3967 2803 298 301 2 1 2852 QDFFRBS $T=568540 427280 1 0 $X=568540 $Y=421860
X3968 2856 298 301 2 1 2965 QDFFRBS $T=588380 376880 1 0 $X=588380 $Y=371460
X3969 1534 1519 1602 1 2 XOR2H $T=350300 467600 0 0 $X=350300 $Y=467220
X3970 2543 2465 2600 1 2 XOR2H $T=532580 376880 0 0 $X=532580 $Y=376500
X3971 2778 2763 2814 1 2 XOR2H $T=566060 467600 1 0 $X=566060 $Y=462180
X3972 1493 80 1473 2 1413 83 1 AO22P $T=338520 497840 0 180 $X=332940 $Y=492420
X3973 2306 2271 2273 2 2247 2239 1 AO22P $T=489800 376880 0 180 $X=484220 $Y=371460
X3974 2410 241 2384 2 2320 2271 1 AO22P $T=509020 386960 0 180 $X=503440 $Y=381540
X3975 2487 272 2540 2 2544 2511 1 AO22P $T=526380 376880 1 0 $X=526380 $Y=371460
X3976 2422 2539 2480 2 2545 2511 1 AO22P $T=526380 397040 1 0 $X=526380 $Y=391620
X3977 2601 272 2582 2 2579 2511 1 AO22P $T=539400 386960 0 180 $X=533820 $Y=381540
X3978 116 110 1 2 INV12 $T=364560 507920 0 0 $X=364560 $Y=507540
X3979 2934 331 3039 2 3046 330 1 AO22T $T=608840 397040 1 0 $X=608840 $Y=391620
X3980 213 215 1 2 INV6 $T=475540 376880 0 180 $X=470580 $Y=371460
X3981 1232 1211 2 1222 1 1267 1243 1275 1276 1293 936 ICV_11 $T=293880 477680 1 0 $X=293880 $Y=472260
X3982 1233 1211 2 1248 1 1276 1276 1275 1285 1291 936 ICV_11 $T=293880 477680 0 0 $X=293880 $Y=477300
X3983 1248 1211 2 1265 1 1269 1239 1275 1269 1292 936 ICV_11 $T=294500 487760 1 0 $X=294500 $Y=482340
X3984 1267 1275 2 1239 1 1305 1309 81 1292 1332 936 ICV_11 $T=301940 467600 0 0 $X=301940 $Y=467220
X3985 1269 1275 2 1306 1 1314 1292 81 1334 1335 936 ICV_11 $T=304420 487760 1 0 $X=304420 $Y=482340
X3986 1319 1326 2 1312 1 1339 1291 81 1304 1364 936 ICV_11 $T=309380 477680 1 0 $X=309380 $Y=472260
X3987 1334 81 2 1304 1 1356 1332 1326 1356 1384 936 ICV_11 $T=313100 487760 0 0 $X=313100 $Y=487380
X3988 1314 81 2 1304 1 1366 1360 1326 1366 1413 936 ICV_11 $T=314960 487760 1 0 $X=314960 $Y=482340
X3989 1626 108 2 1640 1 1645 1645 114 1656 1659 936 ICV_11 $T=361460 487760 1 0 $X=361460 $Y=482340
X3990 1633 108 2 1616 1 1650 1650 113 1651 1668 936 ICV_11 $T=362080 467600 1 0 $X=362080 $Y=462180
X3991 1643 113 2 1669 1 1704 1707 1714 1704 1723 936 ICV_11 $T=373860 467600 0 0 $X=373860 $Y=467220
X3992 1733 1694 2 1697 1 1782 1746 1694 1747 1811 936 ICV_11 $T=389360 467600 0 0 $X=389360 $Y=467220
X3993 2188 205 2 2192 1 2216 2216 2227 2235 2243 936 ICV_11 $T=468100 467600 0 0 $X=468100 $Y=467220
X3994 2210 205 2 2175 1 2235 2235 2227 2234 2259 936 ICV_11 $T=471820 477680 0 0 $X=471820 $Y=477300
X3995 2240 2227 2 2219 1 2272 2243 2282 2249 2297 936 ICV_11 $T=478640 467600 0 0 $X=478640 $Y=467220
X3996 2215 2282 2 2259 1 2296 2274 2282 2298 2309 936 ICV_11 $T=483600 467600 1 0 $X=483600 $Y=462180
X3997 2255 2282 2 2243 1 2308 2261 2282 2272 2326 936 ICV_11 $T=485460 457520 0 0 $X=485460 $Y=457140
X3998 2259 2282 2 2279 1 2317 2286 2282 2287 2333 936 ICV_11 $T=486700 487760 1 0 $X=486700 $Y=482340
X3999 2486 2491 2 2515 1 2552 2551 2557 2560 2588 936 ICV_11 $T=527000 477680 0 0 $X=527000 $Y=477300
X4000 2532 2491 2 2524 1 2565 2560 279 2547 2595 936 ICV_11 $T=528240 497840 0 0 $X=528240 $Y=497460
X4001 2555 2557 2 2519 1 2587 2523 2557 2546 2616 936 ICV_11 $T=532580 477680 1 0 $X=532580 $Y=472260
X4002 2552 2557 2 2565 1 2594 2556 2557 2516 2612 936 ICV_11 $T=532580 487760 0 0 $X=532580 $Y=487380
X4003 2592 2549 2 2566 1 2620 2593 2549 2595 2667 936 ICV_11 $T=538160 467600 0 0 $X=538160 $Y=467220
X4004 2888 2905 2 2913 1 2917 2898 2905 2906 2947 936 ICV_11 $T=587760 477680 1 0 $X=587760 $Y=472260
X4005 2867 2905 2 2902 1 2925 2864 2905 2898 2957 936 ICV_11 $T=588380 467600 1 0 $X=588380 $Y=462180
X4006 2929 2905 2 2867 1 2960 2960 2959 2926 2988 936 ICV_11 $T=595200 457520 1 0 $X=595200 $Y=452100
X4007 2926 2959 2 2952 1 2977 2925 2959 2917 3003 936 ICV_11 $T=599540 467600 1 0 $X=599540 $Y=462180
X4008 3118 2807 2 3090 3178 2807 1 AOI22HP $T=623100 386960 0 0 $X=623100 $Y=386580
X4009 888 889 2 892 895 889 1 AOI22HP $T=1066400 507920 0 0 $X=1066400 $Y=507540
X4010 1088 1073 1134 1 2 AN2B1T $T=261020 417200 1 0 $X=261020 $Y=411780
X4011 205 2184 2198 1 2 AN2B1T $T=465620 417200 0 0 $X=465620 $Y=416820
X4012 2526 2507 2505 1 2 AN2B1T $T=525760 417200 1 0 $X=525760 $Y=411780
X4013 1163 1158 1155 1177 1 2 MAO222P $T=268460 376880 0 0 $X=268460 $Y=376500
X4014 104 1081 105 1491 1 2 MAO222P $T=344720 366800 1 0 $X=344720 $Y=361380
X4015 1569 1636 1564 1596 1 2 MAO222P $T=369520 397040 1 180 $X=363940 $Y=396660
X4016 2403 2400 2288 2453 1 2 MAO222P $T=508400 386960 0 0 $X=508400 $Y=386580
X4017 2467 2730 2749 2759 1 2 MAO222P $T=559240 497840 0 0 $X=559240 $Y=497460
X4018 2910 3068 3060 3100 1 2 MAO222P $T=617520 386960 0 0 $X=617520 $Y=386580
X4019 3358 3305 2799 3385 1 2 MAO222P $T=658440 427280 1 0 $X=658440 $Y=421860
X4020 2140 1 2 174 2153 188 936 ICV_13 $T=447640 497840 0 0 $X=447640 $Y=497460
X4021 2294 1 2 244 245 248 936 ICV_13 $T=490420 507920 0 0 $X=490420 $Y=507540
X4022 3420 1 2 3430 3433 3439 936 ICV_13 $T=672080 397040 1 0 $X=672080 $Y=391620
X4023 3432 1 2 3440 3443 3457 936 ICV_13 $T=677040 437360 1 0 $X=677040 $Y=431940
X4024 3455 1 2 3456 3450 3453 936 ICV_13 $T=687580 437360 0 0 $X=687580 $Y=436980
X4025 3460 1 2 3466 3445 3458 936 ICV_13 $T=689440 397040 1 0 $X=689440 $Y=391620
X4026 3434 1 2 3435 3472 3478 936 ICV_13 $T=704940 497840 1 0 $X=704940 $Y=492420
X4027 3556 1 2 3576 3580 3601 936 ICV_13 $T=708040 477680 0 0 $X=708040 $Y=477300
X4028 3468 1 2 3467 3615 3587 936 ICV_13 $T=716720 497840 0 0 $X=716720 $Y=497460
X4029 3657 1 2 3634 3679 3660 936 ICV_13 $T=738420 497840 0 0 $X=738420 $Y=497460
X4030 3566 1 2 3710 3715 3711 936 ICV_13 $T=747720 437360 0 0 $X=747720 $Y=436980
X4031 3714 1 2 3605 3724 3622 936 ICV_13 $T=752680 457520 1 0 $X=752680 $Y=452100
X4032 539 1 2 3730 3484 3758 936 ICV_13 $T=753300 376880 0 0 $X=753300 $Y=376500
X4033 3763 1 2 3726 3885 3770 936 ICV_13 $T=788020 457520 1 0 $X=788020 $Y=452100
X4034 3776 1 2 3663 3451 3805 936 ICV_13 $T=797940 457520 1 0 $X=797940 $Y=452100
X4035 4226 1 2 4238 4242 4254 936 ICV_13 $T=884120 477680 0 0 $X=884120 $Y=477300
X4036 4411 1 2 4096 4393 4051 936 ICV_13 $T=931860 457520 0 0 $X=931860 $Y=457140
X4037 4417 1 2 4409 4469 4031 936 ICV_13 $T=941780 457520 0 0 $X=941780 $Y=457140
X4038 4482 1 2 4015 4494 4008 936 ICV_13 $T=949220 467600 1 0 $X=949220 $Y=462180
X4039 4540 1 2 4539 4447 4430 936 ICV_13 $T=964720 467600 1 0 $X=964720 $Y=462180
X4040 1389 1118 1 2 1411 OR2B1 $T=323640 437360 1 0 $X=323640 $Y=431940
X4041 1547 1110 1 2 1561 OR2B1 $T=346580 477680 1 0 $X=346580 $Y=472260
X4042 2094 1904 1 2 2062 OR2B1 $T=439580 427280 0 0 $X=439580 $Y=426900
X4043 2148 1911 1 2 2082 OR2B1 $T=453840 437360 0 180 $X=450120 $Y=431940
X4044 3228 3137 1 2 3280 OR2B1 $T=654100 407120 1 180 $X=650380 $Y=406740
X4045 3289 3174 1 2 3275 OR2B1 $T=654100 417200 1 180 $X=650380 $Y=416820
X4046 4381 776 1 2 4367 OR2B1 $T=925040 507920 1 180 $X=921320 $Y=507540
X4047 4376 4385 1 2 4366 OR2B1 $T=927520 497840 0 180 $X=923800 $Y=492420
X4048 1590 1580 1596 1 2 1580 1573 1589 936 ICV_15 $T=354640 397040 0 180 $X=350920 $Y=391620
X4049 1712 1715 124 1 2 1715 1699 1692 936 ICV_15 $T=381920 376880 0 180 $X=378200 $Y=371460
X4050 1601 1923 1934 1 2 1900 1886 1912 936 ICV_15 $T=411680 447440 0 180 $X=407960 $Y=442020
X4051 1429 1930 1820 1 2 1930 1917 1907 936 ICV_15 $T=414160 386960 0 180 $X=410440 $Y=381540
X4052 2007 1997 1453 1 2 1997 1963 1998 936 ICV_15 $T=424080 397040 1 180 $X=420360 $Y=396660
X4053 1773 2056 157 1 2 2056 2039 2017 936 ICV_15 $T=431520 497840 1 180 $X=427800 $Y=497460
X4054 2120 2115 1948 1 2 2115 2089 2068 936 ICV_15 $T=441440 477680 1 180 $X=437720 $Y=477300
X4055 2207 2270 2271 1 2 2270 2253 2256 936 ICV_15 $T=483600 397040 1 180 $X=479880 $Y=396660
X4056 2508 2513 273 1 2 2502 2513 2507 936 ICV_15 $T=527000 427280 1 180 $X=523280 $Y=426900
X4057 2679 2710 2700 1 2 2710 2671 2695 936 ICV_15 $T=555520 417200 1 180 $X=551800 $Y=416820
X4058 2742 2733 2769 1 2 2718 2733 2726 936 ICV_15 $T=562340 487760 0 180 $X=558620 $Y=482340
X4059 3028 3111 3107 1 2 3111 3096 3090 936 ICV_15 $T=624960 376880 1 180 $X=621240 $Y=376500
X4060 3237 3222 3248 1 2 3222 3215 3232 936 ICV_15 $T=639220 437360 1 180 $X=635500 $Y=436980
X4061 3322 3349 3336 1 2 3349 3310 3344 936 ICV_15 $T=657820 447440 0 180 $X=654100 $Y=442020
X4062 4145 4140 684 1 2 4140 4135 4091 936 ICV_15 $T=861180 487760 1 180 $X=857460 $Y=487380
X4063 698 4184 700 1 2 4184 4177 693 936 ICV_15 $T=871100 507920 1 180 $X=867380 $Y=507540
X4064 4645 4640 4650 1 2 4640 4634 4639 936 ICV_15 $T=998200 497840 0 180 $X=994480 $Y=492420
X4065 4734 4735 4743 1 2 4735 4728 4645 936 ICV_15 $T=1025480 487760 1 180 $X=1021760 $Y=487380
X4066 4776 4782 4772 1 2 4782 4778 4766 936 ICV_15 $T=1041600 497840 1 180 $X=1037880 $Y=497460
X4067 1445 1504 1027 1 2 1505 1512 1460 936 ICV_16 $T=342240 437360 1 180 $X=340380 $Y=436980
X4068 1791 1788 1805 1 2 1788 133 1777 936 ICV_16 $T=394320 507920 1 180 $X=392460 $Y=507540
X4069 1878 1842 1654 1 2 1878 1846 141 936 ICV_16 $T=409820 366800 1 180 $X=407960 $Y=366420
X4070 1942 1944 1954 1 2 1939 1929 1919 936 ICV_16 $T=414160 427280 0 180 $X=412300 $Y=421860
X4071 2057 2045 1947 1 2 2057 2034 1903 936 ICV_16 $T=433380 427280 0 180 $X=431520 $Y=421860
X4072 2206 2275 2271 1 2 2244 2258 2239 936 ICV_16 $T=481740 386960 1 180 $X=479880 $Y=386580
X4073 2559 2633 2668 1 2 2643 2548 2622 936 ICV_16 $T=546840 376880 1 180 $X=544980 $Y=376500
X4074 2841 2836 2848 1 2 2836 2830 2829 936 ICV_16 $T=577840 437360 1 180 $X=575980 $Y=436980
X4075 3122 3124 3136 1 2 3087 3106 3088 936 ICV_16 $T=624340 487760 0 180 $X=622480 $Y=482340
X4076 3176 3165 3184 1 2 3170 3113 2826 936 ICV_16 $T=631160 477680 1 180 $X=629300 $Y=477300
X4077 3131 3189 3188 1 2 3155 3175 3138 936 ICV_16 $T=631780 467600 0 180 $X=629920 $Y=462180
X4078 3072 3184 3212 1 2 3150 3196 3109 936 ICV_16 $T=635500 477680 0 180 $X=633640 $Y=472260
X4079 3218 3185 3231 1 2 3209 3216 3201 936 ICV_16 $T=637360 397040 1 180 $X=635500 $Y=396660
X4080 3273 3309 3316 1 2 3273 3295 3223 936 ICV_16 $T=647900 397040 0 180 $X=646040 $Y=391620
X4081 2734 3366 3180 1 2 3346 3357 3361 936 ICV_16 $T=660300 397040 1 180 $X=658440 $Y=396660
X4082 4376 4371 4385 1 2 4401 4360 4374 936 ICV_16 $T=929380 497840 1 180 $X=927520 $Y=497460
X4083 960 1016 10 1 2 984 996 8 936 ICV_17 $T=234980 487760 1 180 $X=233120 $Y=487380
X4084 978 1015 10 1 2 992 1002 994 936 ICV_17 $T=235600 447440 1 180 $X=233740 $Y=447060
X4085 1013 1009 1006 1 2 1004 1006 8 936 ICV_17 $T=236840 487760 0 180 $X=234980 $Y=482340
X4086 1054 1059 1005 1 2 1007 1045 989 936 ICV_17 $T=246140 386960 1 180 $X=244280 $Y=386580
X4087 1565 1560 1551 1 2 1556 1552 1551 936 ICV_17 $T=348440 407120 0 180 $X=346580 $Y=401700
X4088 1512 1568 1566 1 2 1542 1566 1526 936 ICV_17 $T=349680 437360 0 180 $X=347820 $Y=431940
X4089 1829 1851 1805 1 2 1840 1768 1676 936 ICV_17 $T=402380 507920 0 180 $X=400520 $Y=502500
X4090 1856 1857 1845 1 2 1811 1845 1689 936 ICV_17 $T=403000 487760 0 180 $X=401140 $Y=482340
X4091 2185 2182 2181 1 2 2171 2181 205 936 ICV_17 $T=466240 437360 0 180 $X=464380 $Y=431940
X4092 2268 2301 2280 1 2 2262 2280 2271 936 ICV_17 $T=484840 376880 1 180 $X=482980 $Y=376500
X4093 2499 2481 2478 1 2 2459 2478 263 936 ICV_17 $T=519560 437360 1 180 $X=517700 $Y=436980
X4094 2504 2533 2487 1 2 2504 2510 2306 936 ICV_17 $T=525760 376880 1 180 $X=523900 $Y=376500
X4095 2542 2562 2561 1 2 2481 2561 265 936 ICV_17 $T=531960 447440 0 180 $X=530100 $Y=442020
X4096 2762 2753 2731 1 2 2434 2732 2731 936 ICV_17 $T=561100 467600 1 180 $X=559240 $Y=467220
X4097 2935 2961 2954 1 2 2830 2954 314 936 ICV_17 $T=597060 447440 0 180 $X=595200 $Y=442020
X4098 3181 3267 3252 1 2 3256 3258 3230 936 ICV_17 $T=643560 467600 1 180 $X=641700 $Y=467220
X4099 3269 3293 3275 1 2 3280 3268 3265 936 ICV_17 $T=644800 417200 0 180 $X=642940 $Y=411780
X4100 4183 4180 4156 1 2 4174 4169 4137 936 ICV_17 $T=868000 497840 0 180 $X=866140 $Y=492420
X4101 4356 4354 4351 1 2 4337 4342 752 936 ICV_17 $T=918220 497840 0 180 $X=916360 $Y=492420
X4102 4373 4356 4359 1 2 4337 4345 4315 936 ICV_17 $T=921320 487760 0 180 $X=919460 $Y=482340
X4103 4182 4179 4128 1 2 XNR2H $T=868000 477680 0 0 $X=868000 $Y=477300
X4104 3791 1 2 3806 BUF3CK $T=771280 457520 0 0 $X=771280 $Y=457140
X4105 3816 1 2 3815 BUF3CK $T=777480 417200 1 0 $X=777480 $Y=411780
X4106 4125 1 2 4071 BUF3CK $T=861180 477680 0 0 $X=861180 $Y=477300
X4107 3491 3533 1 3553 3562 3554 2 OAI22H $T=704940 427280 1 0 $X=704940 $Y=421860
X4108 3470 3533 1 3564 3526 3554 2 OAI22H $T=706180 427280 0 0 $X=706180 $Y=426900
X4109 3428 3533 1 3537 471 3554 2 OAI22H $T=706800 407120 0 0 $X=706800 $Y=406740
X4110 3508 3533 1 3567 476 3554 2 OAI22H $T=710520 417200 1 0 $X=710520 $Y=411780
X4111 3505 3533 1 3590 3573 3554 2 OAI22H $T=712380 417200 0 0 $X=712380 $Y=416820
X4112 3503 3533 1 3600 492 3554 2 OAI22H $T=717960 417200 1 0 $X=717960 $Y=411780
X4113 3586 3505 1 3592 3629 3590 2 OAI22H $T=722300 417200 0 0 $X=722300 $Y=416820
X4114 496 3533 1 3522 3619 3554 2 OAI22H $T=722920 427280 1 0 $X=722920 $Y=421860
X4115 3586 3477 1 3592 501 3541 2 OAI22H $T=724160 397040 0 0 $X=724160 $Y=396660
X4116 3474 3533 1 3735 559 3554 2 OAI22H $T=755160 417200 0 0 $X=755160 $Y=416820
X4117 3462 3533 1 3738 561 3554 2 OAI22H $T=755780 407120 0 0 $X=755780 $Y=406740
X4118 3586 3462 1 3592 572 3738 2 OAI22H $T=764460 407120 0 0 $X=764460 $Y=406740
X4119 3586 3485 1 3592 3808 3816 2 OAI22H $T=770660 427280 1 0 $X=770660 $Y=421860
X4120 3485 3533 1 3815 3681 3554 2 OAI22H $T=772520 417200 0 0 $X=772520 $Y=416820
X4121 3471 3533 1 3818 582 3554 2 OAI22H $T=773140 407120 0 0 $X=773140 $Y=406740
X4122 3519 3533 1 3840 586 3554 2 OAI22H $T=779340 397040 0 0 $X=779340 $Y=396660
X4123 3586 3534 1 3592 3844 3853 2 OAI22H $T=779340 427280 0 0 $X=779340 $Y=426900
X4124 3482 3533 1 3843 588 3554 2 OAI22H $T=779960 427280 1 0 $X=779960 $Y=421860
X4125 3534 3533 1 3848 3682 3554 2 OAI22H $T=781200 417200 0 0 $X=781200 $Y=416820
X4126 3542 3533 1 3855 3861 3554 2 OAI22H $T=781820 407120 0 0 $X=781820 $Y=406740
X4127 3514 3533 1 3854 589 3554 2 OAI22H $T=782440 407120 1 0 $X=782440 $Y=401700
X4128 3515 3533 1 3866 491 3554 2 OAI22H $T=783680 417200 1 0 $X=783680 $Y=411780
X4129 3586 3482 1 3592 3889 3876 2 OAI22H $T=789260 427280 1 0 $X=789260 $Y=421860
X4130 3586 3515 1 3592 3901 3866 2 OAI22H $T=791120 417200 0 0 $X=791120 $Y=416820
X4131 510 3651 3592 1 2 OR2B1P $T=737180 427280 0 180 $X=732840 $Y=421860
X4132 3635 3658 3586 1 2 OR2B1P $T=741520 417200 0 180 $X=737180 $Y=411780
X4133 1434 38 1391 2 1322 1403 1 1357 1365 1391 936 ICV_18 $T=320540 427280 1 0 $X=320540 $Y=421860
X4134 1451 1432 1402 2 1359 1403 1 1372 1371 1402 936 ICV_18 $T=322400 427280 0 0 $X=322400 $Y=426900
X4135 1478 80 1463 2 1399 83 1 1408 1417 1427 936 ICV_18 $T=326120 507920 1 0 $X=326120 $Y=502500
X4136 1498 1432 1442 2 1339 83 1 1400 1406 1442 936 ICV_18 $T=327980 477680 1 0 $X=327980 $Y=472260
X4137 1839 1676 1734 2 1764 1689 1 1765 1761 1789 936 ICV_18 $T=390600 497840 0 0 $X=390600 $Y=497460
X4138 1911 1826 1859 2 1803 1821 1 1812 1817 1859 936 ICV_18 $T=401140 437360 0 0 $X=401140 $Y=436980
X4139 1913 1826 1860 2 1810 1821 1 1838 1837 1860 936 ICV_18 $T=401140 457520 1 0 $X=401140 $Y=452100
X4140 1948 1821 1787 2 1881 1676 1 1832 1823 1881 936 ICV_18 $T=404860 477680 0 0 $X=404860 $Y=477300
X4141 1981 1821 1813 2 1925 1676 1 1870 1862 1925 936 ICV_18 $T=408580 467600 1 0 $X=408580 $Y=462180
X4142 2432 233 2405 2 2346 251 1 2366 2371 2405 936 ICV_18 $T=503440 437360 0 0 $X=503440 $Y=436980
X4143 2700 2480 2655 2 2646 2511 1 2635 2640 2655 936 ICV_18 $T=543120 417200 1 0 $X=543120 $Y=411780
X4144 2691 2480 2686 2 2630 2511 1 2624 2648 2686 936 ICV_18 $T=546220 407120 1 0 $X=546220 $Y=401700
X4145 2717 288 2689 2 2651 285 1 2631 2636 2689 936 ICV_18 $T=546840 477680 0 0 $X=546840 $Y=477300
X4146 2728 272 2704 2 2654 291 1 2659 2676 2704 936 ICV_18 $T=549320 366800 0 0 $X=549320 $Y=366420
X4147 2740 2480 2706 2 2649 2511 1 2674 2682 2706 936 ICV_18 $T=549940 447440 1 0 $X=549940 $Y=442020
X4148 2727 288 2707 2 2627 285 1 2684 2694 2707 936 ICV_18 $T=549940 497840 1 0 $X=549940 $Y=492420
X4149 2737 288 296 2 289 285 1 2685 2697 2708 936 ICV_18 $T=549940 507920 1 0 $X=549940 $Y=502500
X4150 2724 288 2711 2 2667 285 1 2675 2670 2711 936 ICV_18 $T=550560 477680 1 0 $X=550560 $Y=472260
X4151 2752 2480 2714 2 2666 2511 1 2699 2693 2714 936 ICV_18 $T=552420 447440 0 0 $X=552420 $Y=447060
X4152 3088 2938 3061 2 3020 2859 1 3037 3045 3061 936 ICV_18 $T=611940 477680 0 0 $X=611940 $Y=477300
X4153 3121 2938 3098 2 3062 2859 1 3074 3071 3098 936 ICV_18 $T=618760 467600 1 0 $X=618760 $Y=462180
.ENDS
***************************************
.SUBCKT ICV_20 1 2 3 4 5 6 7 8 9 10 11
** N=11 EP=11 IP=14 FDC=0
X0 1 2 3 4 5 6 MUX2 $T=0 0 0 0 $X=0 $Y=-380
X1 7 8 3 4 9 10 MUX2 $T=0 10080 1 0 $X=0 $Y=4660
.ENDS
***************************************
.SUBCKT ICV_21 1 2 3 4 5 6 7 8 9 10 11 12 13 14 15 16 17 18 19 20
+ 21 22 23 24 25 26 27 28 29 30 31 32 33 34 35 36 37 38 39 40
+ 41 42 43 44 45 46 47 48 49 50 51 52 53 54 55 56 57 58 59 60
+ 61 62 63 64 65 66 67 68 69 70 71 72 73 74 75 76 77 78 79 80
+ 81 82 83 84 85 86 87 88 89 90 91 92 93 94 95 96 97 98 99 100
+ 101 102 103 104 105 106 107 108 109 110 111 112 113 114 115 116 117 118 119 120
+ 121 122 123 124 125 126 127 128 129 130 131 132 133 134 135 136 137 138 139 140
+ 141 142 143 144 145 146 147 148 149 150 151 152 153 154 155 156 157 158 159 160
+ 161 162 163 164 165 166 167 168 169 170 171 172 173 174 175 176 177 178 179 180
+ 181 182 183 184 185 186 187 188 189 190 191 192 193 194 195 196 197 198 199 200
+ 201 202 203 204 205 206 207 208 209 210 211 212 213 214 215 216 217 218 219 220
+ 221 222 223 224 225 226 227 228 229 230 231 232 233 234 235 236 237 238 239 240
+ 241 242 243 244 245 246 247 248 249 250 251 252 253 254 255 256 257 258 259 260
+ 261 262 263 264 265 266 267 268 269 270 271 272 273 274 275 276 277 278 279 280
+ 281 282 283 284 285 286 287 288 289 290 291 292 293 294 295 296 297 298 299 300
+ 301 302 303 304 305 306 307 308 309 310 311 312 313 314 315 316 317 318 319 320
+ 321 322 323 324 325 326 327 328 329 330 331 332 333 334 335 336 337 338 339 340
+ 341 342 343 344 345 346 347 348 349 350 351 352 353 354 355 356 357 358 359 360
+ 361 362 363 364 365 366 367 368 369 370 371 372 373 374 375 376 377 378 379 380
+ 381 382 383 384 385 386 387 388 389 390 391 392 393 394 395 396 397 398 399 400
+ 401 402 403 404 405 406 407 408 409 410 411 412 413 414 415 416 417 418 419 420
+ 421 422 423 424 425 426 427 428 429 430 431 432 433 434 435 436 437 438 439 440
+ 441 442 443 444 445 446 447 448 449 450 451 452 453 454 455 456 457 458 459 460
+ 461 462 463 464 465 466 467 468 469 470 471 472 473 474 475 476 477 478 479 480
+ 481 482 483 484 485 486 487 488 489 490 491 492 493 494 495 496 497 498 499 500
+ 501 502 503 504 505 506 507 508 509 510 511 512 513 514 515 516 517 518 519 520
+ 521 522 523 524 525 526 527 528 529 530 531 532 533 534 535 536 537 538 539 540
+ 541 542 543 544 545 546 547 548 549 550 551 552 553 554 555 556 557 558 559 560
+ 561 562 563 564 565 566 567 568 569 570 571 572 573 574 575 576 577 578 579 580
+ 581 582 583 584 585 586 587 588 589 590 591 592 593 594 595 596 597 598 599 600
+ 601 602 603 604 605 606 607 608 609 610 611 612 613 614 615 616 617 618 619 620
+ 621 622 623 624 625 626 627 628 629 630 632 639
** N=2953 EP=632 IP=16567 FDC=0
X0 629 630 630 630 2671 630 632 YA2GSD $T=1309440 295520 0 90 $X=1169940 $Y=298370
X1 366 370 383 1 2 QDFFN $T=696880 356720 0 0 $X=696880 $Y=356340
X2 384 370 2208 1 2 QDFFN $T=708660 266000 0 180 $X=698120 $Y=260580
X3 368 371 2218 1 2 QDFFN $T=698120 326480 1 0 $X=698120 $Y=321060
X4 2233 370 2211 1 2 QDFFN $T=710520 286160 0 180 $X=699980 $Y=280740
X5 2222 370 2213 1 2 QDFFN $T=711140 306320 1 180 $X=700600 $Y=305940
X6 384 371 2214 1 2 QDFFN $T=711760 276080 0 180 $X=701220 $Y=270660
X7 368 379 2229 1 2 QDFFN $T=701840 336560 1 0 $X=701840 $Y=331140
X8 377 371 2226 1 2 QDFFN $T=702460 336560 0 0 $X=702460 $Y=336180
X9 377 381 2228 1 2 QDFFN $T=703700 346640 1 0 $X=703700 $Y=341220
X10 377 370 2230 1 2 QDFFN $T=704940 346640 0 0 $X=704940 $Y=346260
X11 2233 371 2215 1 2 QDFFN $T=716100 296240 0 180 $X=705560 $Y=290820
X12 2222 371 2216 1 2 QDFFN $T=716100 316400 0 180 $X=705560 $Y=310980
X13 368 381 2234 1 2 QDFFN $T=706800 326480 0 0 $X=706800 $Y=326100
X14 384 381 2243 1 2 QDFFN $T=709900 266000 1 0 $X=709900 $Y=260580
X15 366 379 390 1 2 QDFFN $T=709900 356720 0 0 $X=709900 $Y=356340
X16 368 370 2223 1 2 QDFFN $T=721060 316400 1 180 $X=710520 $Y=316020
X17 2222 381 2242 1 2 QDFFN $T=711140 306320 1 0 $X=711140 $Y=300900
X18 2233 381 2224 1 2 QDFFN $T=722300 276080 1 180 $X=711760 $Y=275700
X19 2222 379 2247 1 2 QDFFN $T=711760 306320 0 0 $X=711760 $Y=305940
X20 384 379 2240 1 2 QDFFN $T=712380 276080 1 0 $X=712380 $Y=270660
X21 377 379 2241 1 2 QDFFN $T=713620 336560 0 0 $X=713620 $Y=336180
X22 389 379 2258 1 2 QDFFN $T=717960 326480 0 0 $X=717960 $Y=326100
X23 391 370 2254 1 2 QDFFN $T=719820 286160 1 0 $X=719820 $Y=280740
X24 2233 379 2237 1 2 QDFFN $T=731600 296240 0 180 $X=721060 $Y=290820
X25 389 370 2255 1 2 QDFFN $T=721060 316400 0 0 $X=721060 $Y=316020
X26 2248 370 2256 1 2 QDFFN $T=721680 266000 1 0 $X=721680 $Y=260580
X27 389 381 2265 1 2 QDFFN $T=722300 336560 1 0 $X=722300 $Y=331140
X28 395 379 2259 1 2 QDFFN $T=722300 346640 0 0 $X=722300 $Y=346260
X29 396 370 2267 1 2 QDFFN $T=722300 356720 1 0 $X=722300 $Y=351300
X30 2248 381 2249 1 2 QDFFN $T=733460 276080 1 180 $X=722920 $Y=275700
X31 391 381 2262 1 2 QDFFN $T=722920 306320 1 0 $X=722920 $Y=300900
X32 2248 379 2251 1 2 QDFFN $T=734700 266000 1 180 $X=724160 $Y=265620
X33 395 381 2271 1 2 QDFFN $T=724780 336560 0 0 $X=724780 $Y=336180
X34 389 371 2263 1 2 QDFFN $T=742140 306320 1 180 $X=731600 $Y=305940
X35 391 379 2252 1 2 QDFFN $T=742760 286160 1 180 $X=732220 $Y=285780
X36 2279 370 2273 1 2 QDFFN $T=744000 296240 0 180 $X=733460 $Y=290820
X37 395 371 2281 1 2 QDFFN $T=733460 336560 1 0 $X=733460 $Y=331140
X38 396 381 2272 1 2 QDFFN $T=744000 356720 0 180 $X=733460 $Y=351300
X39 404 371 400 1 2 QDFFN $T=744620 266000 0 180 $X=734080 $Y=260580
X40 391 371 2270 1 2 QDFFN $T=745240 276080 1 180 $X=734700 $Y=275700
X41 395 370 2293 1 2 QDFFN $T=735940 346640 0 0 $X=735940 $Y=346260
X42 2248 371 2266 1 2 QDFFN $T=748960 276080 0 180 $X=738420 $Y=270660
X43 2279 381 2298 1 2 QDFFN $T=739040 286160 1 0 $X=739040 $Y=280740
X44 2279 371 2275 1 2 QDFFN $T=749580 306320 0 180 $X=739040 $Y=300900
X45 384 402 2306 1 2 QDFFN $T=741520 266000 0 0 $X=741520 $Y=265620
X46 395 402 2329 1 2 QDFFN $T=744620 336560 1 0 $X=744620 $Y=331140
X47 377 402 2313 1 2 QDFFN $T=744620 356720 1 0 $X=744620 $Y=351300
X48 396 402 2318 1 2 QDFFN $T=745860 356720 0 0 $X=745860 $Y=356340
X49 406 370 411 1 2 QDFFN $T=746480 266000 1 0 $X=746480 $Y=260580
X50 2279 379 2300 1 2 QDFFN $T=746480 276080 0 0 $X=746480 $Y=275700
X51 377 409 2322 1 2 QDFFN $T=747100 346640 0 0 $X=747100 $Y=346260
X52 2233 402 2330 1 2 QDFFN $T=750200 296240 0 0 $X=750200 $Y=295860
X53 384 409 2305 1 2 QDFFN $T=761360 276080 0 180 $X=750820 $Y=270660
X54 2233 409 2332 1 2 QDFFN $T=750820 286160 1 0 $X=750820 $Y=280740
X55 389 402 2345 1 2 QDFFN $T=752060 326480 0 0 $X=752060 $Y=326100
X56 368 409 2341 1 2 QDFFN $T=752060 346640 1 0 $X=752060 $Y=341220
X57 389 409 2340 1 2 QDFFN $T=754540 326480 1 0 $X=754540 $Y=321060
X58 395 409 2350 1 2 QDFFN $T=756400 336560 0 0 $X=756400 $Y=336180
X59 415 417 423 1 2 QDFFN $T=758260 266000 1 0 $X=758260 $Y=260580
X60 2233 419 2327 1 2 QDFFN $T=769420 276080 1 180 $X=758880 $Y=275700
X61 368 402 2348 1 2 QDFFN $T=758880 346640 0 0 $X=758880 $Y=346260
X62 391 419 2357 1 2 QDFFN $T=761980 296240 1 0 $X=761980 $Y=290820
X63 2279 417 2363 1 2 QDFFN $T=762600 306320 0 0 $X=762600 $Y=305940
X64 2279 419 2361 1 2 QDFFN $T=762600 316400 0 0 $X=762600 $Y=316020
X65 384 419 2360 1 2 QDFFN $T=763220 276080 1 0 $X=763220 $Y=270660
X66 2233 417 2336 1 2 QDFFN $T=776860 286160 0 180 $X=766320 $Y=280740
X67 2222 417 2370 1 2 QDFFN $T=766320 286160 0 0 $X=766320 $Y=285780
X68 391 417 2368 1 2 QDFFN $T=766940 296240 0 0 $X=766940 $Y=295860
X69 377 417 2371 1 2 QDFFN $T=768180 356720 1 0 $X=768180 $Y=351300
X70 395 417 2366 1 2 QDFFN $T=770040 346640 1 0 $X=770040 $Y=341220
X71 415 419 425 1 2 QDFFN $T=781200 266000 0 180 $X=770660 $Y=260580
X72 389 417 2355 1 2 QDFFN $T=770660 326480 1 0 $X=770660 $Y=321060
X73 377 419 2375 1 2 QDFFN $T=770660 346640 0 0 $X=770660 $Y=346260
X74 2248 402 2382 1 2 QDFFN $T=771280 276080 0 0 $X=771280 $Y=275700
X75 389 419 2352 1 2 QDFFN $T=781820 316400 0 180 $X=771280 $Y=310980
X76 395 419 2359 1 2 QDFFN $T=781820 336560 0 180 $X=771280 $Y=331140
X77 384 417 2349 1 2 QDFFN $T=783680 266000 1 180 $X=773140 $Y=265620
X78 2222 419 2369 1 2 QDFFN $T=787400 286160 0 180 $X=776860 $Y=280740
X79 396 417 2358 1 2 QDFFN $T=788020 356720 1 180 $X=777480 $Y=356340
X80 391 402 2385 1 2 QDFFN $T=792360 306320 0 180 $X=781820 $Y=300900
X81 368 419 2381 1 2 QDFFN $T=792980 346640 1 180 $X=782440 $Y=346260
X82 2248 419 2390 1 2 QDFFN $T=793600 266000 0 180 $X=783060 $Y=260580
X83 2279 402 2416 1 2 QDFFN $T=783060 316400 0 0 $X=783060 $Y=316020
X84 2279 409 2415 1 2 QDFFN $T=783680 316400 1 0 $X=783680 $Y=310980
X85 366 419 432 1 2 QDFFN $T=783680 356720 1 0 $X=783680 $Y=351300
X86 2222 402 2406 1 2 QDFFN $T=787400 286160 1 0 $X=787400 $Y=280740
X87 368 417 2384 1 2 QDFFN $T=799800 346640 0 180 $X=789260 $Y=341220
X88 2222 409 2403 1 2 QDFFN $T=800420 296240 0 180 $X=789880 $Y=290820
X89 2248 417 2388 1 2 QDFFN $T=801040 266000 1 180 $X=790500 $Y=265620
X90 2248 409 2399 1 2 QDFFN $T=801040 276080 0 180 $X=790500 $Y=270660
X91 366 402 2412 1 2 QDFFN $T=804760 356720 0 180 $X=794220 $Y=351300
X92 431 417 433 1 2 QDFFN $T=805380 266000 0 180 $X=794840 $Y=260580
X93 391 409 2409 1 2 QDFFN $T=805380 306320 0 180 $X=794840 $Y=300900
X94 2222 441 2423 1 2 QDFFN $T=808480 286160 0 180 $X=797940 $Y=280740
X95 368 441 2426 1 2 QDFFN $T=809100 336560 1 180 $X=798560 $Y=336180
X96 391 441 2430 1 2 QDFFN $T=810960 296240 0 180 $X=800420 $Y=290820
X97 2248 441 2433 1 2 QDFFN $T=813440 276080 1 180 $X=802900 $Y=275700
X98 377 441 2436 1 2 QDFFN $T=815300 356720 0 180 $X=804760 $Y=351300
X99 2279 441 2458 1 2 QDFFN $T=806000 316400 1 0 $X=806000 $Y=310980
X100 389 441 2457 1 2 QDFFN $T=806620 326480 1 0 $X=806620 $Y=321060
X101 395 441 2448 1 2 QDFFN $T=819020 346640 0 180 $X=808480 $Y=341220
X102 395 449 2450 1 2 QDFFN $T=820260 356720 1 180 $X=809720 $Y=356340
X103 415 446 2469 1 2 QDFFN $T=812820 276080 1 0 $X=812820 $Y=270660
X104 2248 446 2473 1 2 QDFFN $T=813440 286160 0 0 $X=813440 $Y=285780
X105 395 447 2472 1 2 QDFFN $T=813440 336560 1 0 $X=813440 $Y=331140
X106 415 447 2470 1 2 QDFFN $T=814680 266000 1 0 $X=814680 $Y=260580
X107 2248 447 2478 1 2 QDFFN $T=814680 276080 0 0 $X=814680 $Y=275700
X108 377 456 454 1 2 QDFFN $T=829560 346640 0 180 $X=819020 $Y=341220
X109 395 456 2490 1 2 QDFFN $T=820260 346640 0 0 $X=820260 $Y=346260
X110 395 457 2489 1 2 QDFFN $T=820260 356720 0 0 $X=820260 $Y=356340
X111 395 446 2492 1 2 QDFFN $T=821500 336560 0 0 $X=821500 $Y=336180
X112 2233 464 2471 1 2 QDFFN $T=833280 306320 0 180 $X=822740 $Y=300900
X113 2248 464 2500 1 2 QDFFN $T=826460 266000 1 0 $X=826460 $Y=260580
X114 2248 457 2505 1 2 QDFFN $T=828320 266000 0 0 $X=828320 $Y=265620
X115 2222 447 2508 1 2 QDFFN $T=829560 306320 0 0 $X=829560 $Y=305940
X116 389 457 2506 1 2 QDFFN $T=830180 326480 0 0 $X=830180 $Y=326100
X117 377 457 467 1 2 QDFFN $T=841340 346640 1 180 $X=830800 $Y=346260
X118 377 449 465 1 2 QDFFN $T=841340 356720 1 180 $X=830800 $Y=356340
X119 2233 449 2510 1 2 QDFFN $T=831420 296240 0 0 $X=831420 $Y=295860
X120 2233 457 2517 1 2 QDFFN $T=834520 286160 0 0 $X=834520 $Y=285780
X121 2233 456 2522 1 2 QDFFN $T=835140 286160 1 0 $X=835140 $Y=280740
X122 2222 446 2512 1 2 QDFFN $T=852500 306320 0 180 $X=841960 $Y=300900
X123 389 449 2511 1 2 QDFFN $T=852500 326480 0 180 $X=841960 $Y=321060
X124 389 456 2503 1 2 QDFFN $T=853740 336560 0 180 $X=843200 $Y=331140
X125 2222 449 2549 1 2 QDFFN $T=847540 296240 1 0 $X=847540 $Y=290820
X126 2222 456 2557 1 2 QDFFN $T=848160 276080 0 0 $X=848160 $Y=275700
X127 2222 464 2556 1 2 QDFFN $T=852500 306320 1 0 $X=852500 $Y=300900
X128 389 443 2552 1 2 QDFFN $T=854980 346640 1 0 $X=854980 $Y=341220
X129 396 464 2582 1 2 QDFFN $T=859320 356720 1 0 $X=859320 $Y=351300
X130 368 464 2570 1 2 QDFFN $T=861180 336560 1 0 $X=861180 $Y=331140
X131 384 446 2573 1 2 QDFFN $T=864280 276080 0 0 $X=864280 $Y=275700
X132 2279 443 2574 1 2 QDFFN $T=865520 296240 1 0 $X=865520 $Y=290820
X133 384 464 489 1 2 QDFFN $T=868000 266000 1 0 $X=868000 $Y=260580
X134 396 443 2572 1 2 QDFFN $T=880400 346640 0 180 $X=869860 $Y=341220
X135 2279 456 2575 1 2 QDFFN $T=881020 286160 0 180 $X=870480 $Y=280740
X136 404 446 2592 1 2 QDFFN $T=871720 276080 1 0 $X=871720 $Y=270660
X137 368 443 2577 1 2 QDFFN $T=882260 336560 0 180 $X=871720 $Y=331140
X138 2279 449 2566 1 2 QDFFN $T=883500 286160 1 180 $X=872960 $Y=285780
X139 2279 447 2590 1 2 QDFFN $T=872960 306320 1 0 $X=872960 $Y=300900
X140 2279 446 2580 1 2 QDFFN $T=883500 316400 0 180 $X=872960 $Y=310980
X141 2279 464 2569 1 2 QDFFN $T=885980 296240 1 180 $X=875440 $Y=295860
X142 396 456 2583 1 2 QDFFN $T=885980 356720 0 180 $X=875440 $Y=351300
X143 391 464 2603 1 2 QDFFN $T=876680 296240 1 0 $X=876680 $Y=290820
X144 391 456 2596 1 2 QDFFN $T=877300 276080 0 0 $X=877300 $Y=275700
X145 396 449 2611 1 2 QDFFN $T=879160 356720 0 0 $X=879160 $Y=356340
X146 431 446 2620 1 2 QDFFN $T=879780 266000 1 0 $X=879780 $Y=260580
X147 368 456 2618 1 2 QDFFN $T=880400 346640 1 0 $X=880400 $Y=341220
X148 391 447 2636 1 2 QDFFN $T=883500 316400 1 0 $X=883500 $Y=310980
X149 404 447 2594 1 2 QDFFN $T=894660 276080 0 180 $X=884120 $Y=270660
X150 391 443 2613 1 2 QDFFN $T=884120 286160 0 0 $X=884120 $Y=285780
X151 368 449 2625 1 2 QDFFN $T=885980 306320 0 0 $X=885980 $Y=305940
X152 391 457 2600 1 2 QDFFN $T=889700 276080 0 0 $X=889700 $Y=275700
X153 431 447 2616 1 2 QDFFN $T=892800 266000 1 0 $X=892800 $Y=260580
X154 391 449 2604 1 2 QDFFN $T=894660 286160 1 0 $X=894660 $Y=280740
X155 391 446 2645 1 2 QDFFN $T=895280 316400 0 0 $X=895280 $Y=316020
X156 507 511 2679 1 2 QDFFN $T=902100 276080 1 0 $X=902100 $Y=270660
X157 515 511 2680 1 2 QDFFN $T=906440 286160 0 0 $X=906440 $Y=285780
X158 515 534 2666 1 2 QDFFN $T=919460 266000 1 180 $X=908920 $Y=265620
X159 521 511 2691 1 2 QDFFN $T=909540 296240 1 0 $X=909540 $Y=290820
X160 522 511 2690 1 2 QDFFN $T=910780 326480 0 0 $X=910780 $Y=326100
X161 507 534 2681 1 2 QDFFN $T=925040 266000 0 180 $X=914500 $Y=260580
X162 521 534 2702 1 2 QDFFN $T=917600 296240 0 0 $X=917600 $Y=295860
X163 527 534 2703 1 2 QDFFN $T=917600 316400 0 0 $X=917600 $Y=316020
X164 550 534 2684 1 2 QDFFN $T=928760 286160 1 180 $X=918220 $Y=285780
X165 550 511 2689 1 2 QDFFN $T=931860 276080 0 180 $X=921320 $Y=270660
X166 507 544 2708 1 2 QDFFN $T=921940 266000 0 0 $X=921940 $Y=265620
X167 527 542 2715 1 2 QDFFN $T=923800 316400 1 0 $X=923800 $Y=310980
X168 522 534 2686 1 2 QDFFN $T=924420 336560 1 0 $X=924420 $Y=331140
X169 521 542 2712 1 2 QDFFN $T=941160 286160 0 180 $X=930620 $Y=280740
X170 550 544 2728 1 2 QDFFN $T=931240 276080 0 0 $X=931240 $Y=275700
X171 527 553 2725 1 2 QDFFN $T=931240 306320 0 0 $X=931240 $Y=305940
X172 507 563 2707 1 2 QDFFN $T=944260 266000 0 180 $X=933720 $Y=260580
X173 555 534 2733 1 2 QDFFN $T=933720 266000 0 0 $X=933720 $Y=265620
X174 521 553 2718 1 2 QDFFN $T=944880 306320 0 180 $X=934340 $Y=300900
X175 522 553 2732 1 2 QDFFN $T=934340 326480 0 0 $X=934340 $Y=326100
X176 527 546 2724 1 2 QDFFN $T=948600 316400 1 180 $X=938060 $Y=316020
X177 522 544 2743 1 2 QDFFN $T=941160 336560 0 0 $X=941160 $Y=336180
X178 550 563 2727 1 2 QDFFN $T=952940 286160 0 180 $X=942400 $Y=280740
X179 562 544 568 1 2 QDFFN $T=942400 356720 0 0 $X=942400 $Y=356340
X180 521 563 2739 1 2 QDFFN $T=943020 296240 1 0 $X=943020 $Y=290820
X181 527 544 2745 1 2 QDFFN $T=943020 306320 0 0 $X=943020 $Y=305940
X182 555 511 2734 1 2 QDFFN $T=954800 276080 1 180 $X=944260 $Y=275700
X183 555 563 570 1 2 QDFFN $T=945500 266000 1 0 $X=945500 $Y=260580
X184 522 563 2741 1 2 QDFFN $T=947980 326480 1 0 $X=947980 $Y=321060
X185 527 563 2740 1 2 QDFFN $T=959140 316400 1 180 $X=948600 $Y=316020
X186 574 534 2747 1 2 QDFFN $T=965340 266000 1 180 $X=954800 $Y=265620
X187 573 542 2748 1 2 QDFFN $T=965340 286160 0 180 $X=954800 $Y=280740
X188 571 534 2762 1 2 QDFFN $T=954800 306320 0 0 $X=954800 $Y=305940
X189 574 511 2749 1 2 QDFFN $T=966580 276080 1 180 $X=956040 $Y=275700
X190 573 546 2750 1 2 QDFFN $T=966580 296240 0 180 $X=956040 $Y=290820
X191 571 542 2751 1 2 QDFFN $T=967200 316400 0 180 $X=956660 $Y=310980
X192 574 563 579 1 2 QDFFN $T=958520 266000 1 0 $X=958520 $Y=260580
X193 571 546 2754 1 2 QDFFN $T=969060 326480 0 180 $X=958520 $Y=321060
X194 567 553 2759 1 2 QDFFN $T=974020 346640 0 180 $X=963480 $Y=341220
X195 571 511 2772 1 2 QDFFN $T=965960 306320 0 0 $X=965960 $Y=305940
X196 573 511 2779 1 2 QDFFN $T=966580 286160 1 0 $X=966580 $Y=280740
X197 578 534 2788 1 2 QDFFN $T=967200 266000 0 0 $X=967200 $Y=265620
X198 573 534 2789 1 2 QDFFN $T=967200 286160 0 0 $X=967200 $Y=285780
X199 578 511 2781 1 2 QDFFN $T=967820 276080 0 0 $X=967820 $Y=275700
X200 578 563 588 1 2 QDFFN $T=970920 266000 1 0 $X=970920 $Y=260580
X201 571 544 2797 1 2 QDFFN $T=974640 316400 1 0 $X=974640 $Y=310980
X202 571 563 2793 1 2 QDFFN $T=987660 326480 0 180 $X=977120 $Y=321060
X203 567 544 2783 1 2 QDFFN $T=987660 356720 0 180 $X=977120 $Y=351300
X204 573 544 2799 1 2 QDFFN $T=977740 296240 1 0 $X=977740 $Y=290820
X205 573 563 2794 1 2 QDFFN $T=988280 306320 1 180 $X=977740 $Y=305940
X206 550 587 2804 1 2 QDFFN $T=978360 286160 1 0 $X=978360 $Y=280740
X207 521 587 2805 1 2 QDFFN $T=978980 286160 0 0 $X=978980 $Y=285780
X208 507 587 591 1 2 QDFFN $T=979600 266000 0 0 $X=979600 $Y=265620
X209 555 587 2809 1 2 QDFFN $T=980220 276080 0 0 $X=980220 $Y=275700
X210 567 587 2811 1 2 QDFFN $T=980220 346640 1 0 $X=980220 $Y=341220
X211 522 587 2806 1 2 QDFFN $T=998820 336560 0 180 $X=988280 $Y=331140
X212 527 587 2807 1 2 QDFFN $T=999440 306320 1 180 $X=988900 $Y=305940
X213 571 587 2808 1 2 QDFFN $T=1000060 326480 0 180 $X=989520 $Y=321060
X214 573 587 2812 1 2 QDFFN $T=1000680 296240 0 180 $X=990140 $Y=290820
X215 578 587 596 1 2 QDFFN $T=991380 266000 1 0 $X=991380 $Y=260580
X216 550 593 2829 1 2 QDFFN $T=992620 276080 0 0 $X=992620 $Y=275700
X217 555 593 2830 1 2 QDFFN $T=993240 266000 0 0 $X=993240 $Y=265620
X218 567 593 2854 1 2 QDFFN $T=993240 346640 1 0 $X=993240 $Y=341220
X219 571 593 2836 1 2 QDFFN $T=995720 316400 1 0 $X=995720 $Y=310980
X220 571 595 2841 1 2 QDFFN $T=998200 316400 0 0 $X=998200 $Y=316020
X221 573 593 2846 1 2 QDFFN $T=998820 296240 0 0 $X=998820 $Y=295860
X222 550 595 2840 1 2 QDFFN $T=1001300 286160 1 0 $X=1001300 $Y=280740
X223 573 595 2851 1 2 QDFFN $T=1001920 296240 1 0 $X=1001920 $Y=290820
X224 521 595 2866 1 2 QDFFN $T=1002540 286160 0 0 $X=1002540 $Y=285780
X225 567 595 2859 1 2 QDFFN $T=1002540 336560 0 0 $X=1002540 $Y=336180
X226 555 595 2844 1 2 QDFFN $T=1003160 266000 1 0 $X=1003160 $Y=260580
X227 571 603 2855 1 2 QDFFN $T=1023000 316400 1 180 $X=1012460 $Y=316020
X228 550 603 2857 1 2 QDFFN $T=1024240 286160 0 180 $X=1013700 $Y=280740
X229 550 602 2878 1 2 QDFFN $T=1014320 276080 1 0 $X=1014320 $Y=270660
X230 521 593 2884 1 2 QDFFN $T=1014320 296240 1 0 $X=1014320 $Y=290820
X231 507 595 601 1 2 QDFFN $T=1026100 266000 0 180 $X=1015560 $Y=260580
X232 605 602 610 1 2 QDFFN $T=1020520 356720 0 0 $X=1020520 $Y=356340
X233 567 602 2880 1 2 QDFFN $T=1032300 356720 0 180 $X=1021760 $Y=351300
X234 555 603 2890 1 2 QDFFN $T=1037260 276080 0 180 $X=1026720 $Y=270660
X235 521 602 2891 1 2 QDFFN $T=1037260 286160 0 180 $X=1026720 $Y=280740
X236 573 602 2888 1 2 QDFFN $T=1037260 296240 0 180 $X=1026720 $Y=290820
X237 527 602 2894 1 2 QDFFN $T=1026720 316400 0 0 $X=1026720 $Y=316020
X238 527 603 2898 1 2 QDFFN $T=1027340 306320 0 0 $X=1027340 $Y=305940
X239 571 602 2887 1 2 QDFFN $T=1037880 326480 0 180 $X=1027340 $Y=321060
X240 507 602 609 1 2 QDFFN $T=1038500 266000 0 180 $X=1027960 $Y=260580
X241 555 602 2883 1 2 QDFFN $T=1039120 266000 1 180 $X=1028580 $Y=265620
X242 573 603 2892 1 2 QDFFN $T=1042220 296240 1 180 $X=1031680 $Y=295860
X243 521 603 2893 1 2 QDFFN $T=1042840 286160 1 180 $X=1032300 $Y=285780
X244 567 603 2895 1 2 QDFFN $T=1044700 336560 1 180 $X=1034160 $Y=336180
X245 522 603 2897 1 2 QDFFN $T=1047180 326480 1 180 $X=1036640 $Y=326100
X246 515 615 2907 1 2 QDFFN $T=1040360 266000 0 0 $X=1040360 $Y=265620
X247 555 615 2909 1 2 QDFFN $T=1040360 276080 1 0 $X=1040360 $Y=270660
X248 555 616 2913 1 2 QDFFN $T=1040980 286160 1 0 $X=1040980 $Y=280740
X249 573 616 2911 1 2 QDFFN $T=1040980 296240 1 0 $X=1040980 $Y=290820
X250 571 614 2899 1 2 QDFFN $T=1051520 316400 1 180 $X=1040980 $Y=316020
X251 522 602 2896 1 2 QDFFN $T=1042220 336560 1 0 $X=1042220 $Y=331140
X252 555 619 2912 1 2 QDFFN $T=1045320 286160 0 0 $X=1045320 $Y=285780
X253 571 615 2902 1 2 QDFFN $T=1049660 316400 1 0 $X=1049660 $Y=310980
X254 573 619 2920 1 2 QDFFN $T=1050900 296240 0 0 $X=1050900 $Y=295860
X255 578 615 2916 1 2 QDFFN $T=1052140 266000 0 0 $X=1052140 $Y=265620
X256 555 614 2906 1 2 QDFFN $T=1052140 276080 1 0 $X=1052140 $Y=270660
X257 571 616 2914 1 2 QDFFN $T=1052140 326480 1 0 $X=1052140 $Y=321060
X258 567 615 2938 1 2 QDFFN $T=1054000 356720 0 0 $X=1054000 $Y=356340
X259 567 614 2932 1 2 QDFFN $T=1055240 356720 1 0 $X=1055240 $Y=351300
X260 567 616 2937 1 2 QDFFN $T=1058340 346640 0 0 $X=1058340 $Y=346260
X261 521 619 2930 1 2 QDFFN $T=1058960 286160 0 0 $X=1058960 $Y=285780
X262 527 616 2931 1 2 QDFFN $T=1062060 306320 0 0 $X=1062060 $Y=305940
X263 527 619 2936 1 2 QDFFN $T=1063300 316400 0 0 $X=1063300 $Y=316020
X264 550 616 2934 1 2 QDFFN $T=1063920 276080 1 0 $X=1063920 $Y=270660
X265 521 616 2922 1 2 QDFFN $T=1074460 296240 1 180 $X=1063920 $Y=295860
X266 574 615 2924 1 2 QDFFN $T=1075080 266000 1 180 $X=1064540 $Y=265620
X267 522 619 2925 1 2 QDFFN $T=1075080 326480 0 180 $X=1064540 $Y=321060
X268 567 619 2941 1 2 QDFFN $T=1065160 336560 0 0 $X=1065160 $Y=336180
X269 550 619 2940 1 2 QDFFN $T=1066400 286160 1 0 $X=1066400 $Y=280740
X270 527 615 2944 1 2 QDFFN $T=1072600 316400 1 0 $X=1072600 $Y=310980
X271 507 615 2948 1 2 QDFFN $T=1076320 266000 0 0 $X=1076320 $Y=265620
X272 550 615 2949 1 2 QDFFN $T=1076940 276080 1 0 $X=1076940 $Y=270660
X273 521 614 2946 1 2 QDFFN $T=1076940 296240 0 0 $X=1076940 $Y=295860
X274 521 615 2952 1 2 QDFFN $T=1076940 306320 0 0 $X=1076940 $Y=305940
X275 527 614 2950 1 2 QDFFN $T=1076940 316400 0 0 $X=1076940 $Y=316020
X276 522 615 2951 1 2 QDFFN $T=1076940 326480 1 0 $X=1076940 $Y=321060
X277 550 614 2945 1 2 QDFFN $T=1077560 286160 0 0 $X=1077560 $Y=285780
X278 522 614 2947 1 2 QDFFN $T=1077560 336560 0 0 $X=1077560 $Y=336180
X279 605 614 2943 1 2 QDFFN $T=1077560 346640 0 0 $X=1077560 $Y=346260
X280 778 763 766 25 1 21 2 AOI22S $T=273420 296240 1 180 $X=269700 $Y=295860
X281 866 878 872 67 1 66 2 AOI22S $T=307520 296240 0 0 $X=307520 $Y=295860
X282 1269 1275 1302 1279 1 1266 2 AOI22S $T=425940 326480 0 180 $X=422220 $Y=321060
X283 1567 1735 1730 1567 1 1754 2 AOI22S $T=562960 286160 1 0 $X=562960 $Y=280740
X284 2208 2214 2212 376 1 378 2 AOI22S $T=700600 266000 0 0 $X=700600 $Y=265620
X285 2213 2216 2217 376 1 378 2 AOI22S $T=706800 296240 0 0 $X=706800 $Y=295860
X286 2211 2215 2220 376 1 378 2 AOI22S $T=708660 286160 0 0 $X=708660 $Y=285780
X287 2223 2218 2225 376 1 378 2 AOI22S $T=711760 326480 1 0 $X=711760 $Y=321060
X288 2234 2229 2238 388 1 387 2 AOI22S $T=717340 336560 0 180 $X=713620 $Y=331140
X289 2224 2237 2227 388 1 387 2 AOI22S $T=716100 286160 0 0 $X=716100 $Y=285780
X290 2243 2240 2219 388 1 387 2 AOI22S $T=720440 266000 1 180 $X=716720 $Y=265620
X291 2228 2241 2236 388 1 387 2 AOI22S $T=717340 346640 1 0 $X=717340 $Y=341220
X292 2242 2247 2235 388 1 387 2 AOI22S $T=719820 296240 0 0 $X=719820 $Y=295860
X293 2230 2226 2239 376 1 378 2 AOI22S $T=722920 346640 1 0 $X=722920 $Y=341220
X294 2249 2251 2250 388 1 387 2 AOI22S $T=723540 276080 1 0 $X=723540 $Y=270660
X295 2262 2252 2257 388 1 387 2 AOI22S $T=729740 296240 1 180 $X=726020 $Y=295860
X296 2272 399 2260 388 1 387 2 AOI22S $T=732220 356720 1 180 $X=728500 $Y=356340
X297 2265 2258 2269 388 1 387 2 AOI22S $T=733460 326480 1 180 $X=729740 $Y=326100
X298 2271 2259 2277 388 1 387 2 AOI22S $T=733460 346640 0 180 $X=729740 $Y=341220
X299 2256 2266 2261 376 1 378 2 AOI22S $T=731600 276080 1 0 $X=731600 $Y=270660
X300 2255 2263 2264 376 1 378 2 AOI22S $T=731600 316400 0 0 $X=731600 $Y=316020
X301 2254 2270 2268 376 1 378 2 AOI22S $T=732840 286160 1 0 $X=732840 $Y=280740
X302 2273 2275 2278 376 1 378 2 AOI22S $T=737180 296240 1 180 $X=733460 $Y=295860
X303 2267 401 2276 376 1 378 2 AOI22S $T=735320 356720 0 0 $X=735320 $Y=356340
X304 2293 2281 2292 376 1 378 2 AOI22S $T=742140 336560 1 180 $X=738420 $Y=336180
X305 2298 2300 2295 388 1 387 2 AOI22S $T=746480 296240 1 0 $X=746480 $Y=290820
X306 2306 2305 2314 412 1 413 2 AOI22S $T=753920 266000 0 0 $X=753920 $Y=265620
X307 2313 2322 2320 412 1 413 2 AOI22S $T=756400 356720 1 0 $X=756400 $Y=351300
X308 2318 416 2325 412 1 413 2 AOI22S $T=758260 356720 0 0 $X=758260 $Y=356340
X309 2330 2332 2326 412 1 413 2 AOI22S $T=760120 286160 0 0 $X=760120 $Y=285780
X310 2327 2336 2316 420 1 421 2 AOI22S $T=762600 286160 1 0 $X=762600 $Y=280740
X311 2348 2341 2351 412 1 413 2 AOI22S $T=766940 346640 0 180 $X=763220 $Y=341220
X312 2345 2340 2343 412 1 413 2 AOI22S $T=765700 326480 0 0 $X=765700 $Y=326100
X313 2360 2349 2333 420 1 421 2 AOI22S $T=770660 266000 1 180 $X=766940 $Y=265620
X314 2329 2350 2347 412 1 413 2 AOI22S $T=767560 336560 1 0 $X=767560 $Y=331140
X315 2352 2355 2337 420 1 421 2 AOI22S $T=769420 326480 0 0 $X=769420 $Y=326100
X316 426 2358 2344 420 1 421 2 AOI22S $T=770660 356720 0 0 $X=770660 $Y=356340
X317 2361 2363 2365 420 1 421 2 AOI22S $T=777480 306320 1 180 $X=773760 $Y=305940
X318 2359 2366 2353 420 1 421 2 AOI22S $T=775000 336560 0 0 $X=775000 $Y=336180
X319 2357 2368 2364 420 1 421 2 AOI22S $T=775620 296240 1 0 $X=775620 $Y=290820
X320 2369 2370 2372 420 1 421 2 AOI22S $T=780580 286160 1 180 $X=776860 $Y=285780
X321 2375 2371 2335 420 1 421 2 AOI22S $T=779960 356720 1 0 $X=779960 $Y=351300
X322 2381 2384 2377 420 1 421 2 AOI22S $T=780580 346640 1 0 $X=780580 $Y=341220
X323 2390 2388 2401 420 1 421 2 AOI22S $T=784920 276080 0 180 $X=781200 $Y=270660
X324 2382 2399 2398 412 1 413 2 AOI22S $T=785540 276080 0 0 $X=785540 $Y=275700
X325 2406 2403 2397 412 1 413 2 AOI22S $T=789880 296240 0 180 $X=786160 $Y=290820
X326 2385 2409 2376 412 1 413 2 AOI22S $T=790500 296240 0 0 $X=790500 $Y=295860
X327 2412 435 434 412 1 413 2 AOI22S $T=794220 356720 0 0 $X=794220 $Y=356340
X328 2416 2415 2414 412 1 413 2 AOI22S $T=796080 316400 1 0 $X=796080 $Y=310980
X329 2423 2400 2429 439 1 438 2 AOI22S $T=799800 286160 0 0 $X=799800 $Y=285780
X330 2444 2324 2439 439 1 438 2 AOI22S $T=807860 286160 1 180 $X=804140 $Y=285780
X331 2426 2389 2437 439 1 438 2 AOI22S $T=805380 336560 1 0 $X=805380 $Y=331140
X332 2436 2346 2446 439 1 438 2 AOI22S $T=809100 356720 1 180 $X=805380 $Y=356340
X333 2430 2373 2442 439 1 438 2 AOI22S $T=806620 306320 1 0 $X=806620 $Y=300900
X334 2433 2402 2447 439 1 438 2 AOI22S $T=808480 276080 1 0 $X=808480 $Y=270660
X335 2448 2356 2449 439 1 438 2 AOI22S $T=809100 336560 0 0 $X=809100 $Y=336180
X336 2457 2334 2453 439 1 438 2 AOI22S $T=813440 336560 0 180 $X=809720 $Y=331140
X337 445 2339 2454 439 1 438 2 AOI22S $T=814060 266000 1 180 $X=810340 $Y=265620
X338 2458 2411 2455 439 1 438 2 AOI22S $T=814060 306320 0 180 $X=810340 $Y=300900
X339 2469 2470 452 458 1 459 2 AOI22S $T=821500 266000 0 0 $X=821500 $Y=265620
X340 2480 2484 2477 458 1 459 2 AOI22S $T=826460 286160 0 0 $X=826460 $Y=285780
X341 2473 2478 2482 458 1 459 2 AOI22S $T=830800 286160 1 0 $X=830800 $Y=280740
X342 2492 2472 2461 458 1 459 2 AOI22S $T=832040 336560 0 0 $X=832040 $Y=336180
X343 2512 2508 2518 458 1 459 2 AOI22S $T=845060 316400 1 0 $X=845060 $Y=310980
X344 2535 2534 476 458 1 459 2 AOI22S $T=853120 266000 1 180 $X=849400 $Y=265620
X345 2515 2525 2528 458 1 459 2 AOI22S $T=851260 336560 0 0 $X=851260 $Y=336180
X346 2555 2553 2559 458 1 459 2 AOI22S $T=862420 266000 0 180 $X=858700 $Y=260580
X347 2564 2558 2542 458 1 459 2 AOI22S $T=868000 326480 1 180 $X=864280 $Y=326100
X348 2573 2565 2567 458 1 459 2 AOI22S $T=870480 276080 0 180 $X=866760 $Y=270660
X349 2579 2588 2586 458 1 459 2 AOI22S $T=877920 326480 0 0 $X=877920 $Y=326100
X350 2580 2590 2571 458 1 459 2 AOI22S $T=879160 316400 0 0 $X=879160 $Y=316020
X351 2592 2594 490 458 1 459 2 AOI22S $T=881640 266000 0 0 $X=881640 $Y=265620
X352 2620 2616 495 458 1 459 2 AOI22S $T=892180 266000 1 180 $X=888460 $Y=265620
X353 2645 2636 2606 458 1 459 2 AOI22S $T=900240 306320 0 180 $X=896520 $Y=300900
X354 2666 2680 526 528 1 535 2 AOI22S $T=912640 286160 1 0 $X=912640 $Y=280740
X355 2681 2679 532 528 1 535 2 AOI22S $T=915120 276080 1 0 $X=915120 $Y=270660
X356 2684 2689 2687 528 1 535 2 AOI22S $T=919460 286160 1 0 $X=919460 $Y=280740
X357 2702 2691 2713 528 1 535 2 AOI22S $T=923800 296240 0 180 $X=920080 $Y=290820
X358 2703 2694 2704 528 1 535 2 AOI22S $T=924420 306320 1 180 $X=920700 $Y=305940
X359 2686 2690 2667 528 1 535 2 AOI22S $T=920700 336560 1 0 $X=920700 $Y=331140
X360 2733 2734 2738 528 1 535 2 AOI22S $T=947360 276080 1 0 $X=947360 $Y=270660
X361 2747 2749 575 528 1 535 2 AOI22S $T=959140 276080 1 0 $X=959140 $Y=270660
X362 2752 2755 2756 528 1 535 2 AOI22S $T=959760 346640 1 0 $X=959760 $Y=341220
X363 2762 2772 2769 528 1 535 2 AOI22S $T=969680 316400 1 0 $X=969680 $Y=310980
X364 2789 2779 2770 528 1 535 2 AOI22S $T=974020 296240 1 180 $X=970300 $Y=295860
X365 2788 2781 584 528 1 535 2 AOI22S $T=975880 276080 0 180 $X=972160 $Y=270660
X366 2809 2801 2744 580 1 590 2 AOI22S $T=988280 276080 0 180 $X=984560 $Y=270660
X367 2808 2803 2785 580 1 590 2 AOI22S $T=989520 316400 1 180 $X=985800 $Y=316020
X368 2807 2813 2710 580 1 590 2 AOI22S $T=988900 316400 1 0 $X=988900 $Y=310980
X369 2812 2815 2766 580 1 590 2 AOI22S $T=990760 296240 0 0 $X=990760 $Y=295860
X370 2806 2816 2662 580 1 590 2 AOI22S $T=991380 326480 0 0 $X=991380 $Y=326100
X371 2804 2819 2699 580 1 590 2 AOI22S $T=993240 286160 1 0 $X=993240 $Y=280740
X372 2805 2821 2717 580 1 590 2 AOI22S $T=993860 286160 0 0 $X=993860 $Y=285780
X373 2811 2825 2787 580 1 590 2 AOI22S $T=997580 346640 0 0 $X=997580 $Y=346260
X374 2829 2840 2835 599 1 600 2 AOI22S $T=1006260 276080 0 0 $X=1006260 $Y=275700
X375 2830 2844 2839 599 1 600 2 AOI22S $T=1006880 266000 0 0 $X=1006880 $Y=265620
X376 2842 2848 2843 599 1 600 2 AOI22S $T=1007500 326480 1 0 $X=1007500 $Y=321060
X377 2836 2841 2820 599 1 600 2 AOI22S $T=1008740 316400 0 0 $X=1008740 $Y=316020
X378 2846 2851 2853 599 1 600 2 AOI22S $T=1011840 296240 0 0 $X=1011840 $Y=295860
X379 2854 2859 2856 599 1 600 2 AOI22S $T=1013080 336560 1 0 $X=1013080 $Y=331140
X380 2884 2866 2876 599 1 600 2 AOI22S $T=1018660 286160 1 180 $X=1014940 $Y=285780
X381 2857 2878 2862 604 1 606 2 AOI22S $T=1020520 276080 0 0 $X=1020520 $Y=275700
X382 2847 2874 2867 599 1 600 2 AOI22S $T=1020520 306320 0 0 $X=1020520 $Y=305940
X383 2890 2883 2865 604 1 606 2 AOI22S $T=1025480 266000 1 180 $X=1021760 $Y=265620
X384 2855 2887 2823 604 1 606 2 AOI22S $T=1023000 316400 0 0 $X=1023000 $Y=316020
X385 2895 2880 2869 604 1 606 2 AOI22S $T=1027340 346640 0 180 $X=1023620 $Y=341220
X386 2892 2888 2872 604 1 606 2 AOI22S $T=1027960 296240 1 180 $X=1024240 $Y=295860
X387 2893 2891 2879 604 1 606 2 AOI22S $T=1029200 286160 1 180 $X=1025480 $Y=285780
X388 2898 2894 2870 604 1 606 2 AOI22S $T=1034160 316400 0 180 $X=1030440 $Y=310980
X389 2897 2896 2882 604 1 606 2 AOI22S $T=1036020 326480 1 180 $X=1032300 $Y=326100
X390 2902 2899 2900 608 1 613 2 AOI22S $T=1040980 316400 1 180 $X=1037260 $Y=316020
X391 2919 2903 2905 608 1 613 2 AOI22S $T=1045940 306320 0 180 $X=1042220 $Y=300900
X392 2907 617 618 608 1 613 2 AOI22S $T=1046560 266000 0 180 $X=1042840 $Y=260580
X393 2909 2906 2901 608 1 613 2 AOI22S $T=1049660 276080 1 180 $X=1045940 $Y=275700
X394 2916 620 621 608 1 613 2 AOI22S $T=1054620 266000 0 180 $X=1050900 $Y=260580
X395 2920 2911 2908 612 1 611 2 AOI22S $T=1058340 296240 0 180 $X=1054620 $Y=290820
X396 2915 2914 2910 612 1 611 2 AOI22S $T=1058960 316400 1 180 $X=1055240 $Y=316020
X397 2912 2913 2904 612 1 611 2 AOI22S $T=1056480 286160 1 0 $X=1056480 $Y=280740
X398 2924 622 623 608 1 613 2 AOI22S $T=1062680 266000 0 180 $X=1058960 $Y=260580
X399 2930 2922 2933 612 1 611 2 AOI22S $T=1066400 296240 0 180 $X=1062680 $Y=290820
X400 2925 2928 2927 612 1 611 2 AOI22S $T=1065780 336560 1 0 $X=1065780 $Y=331140
X401 2936 2931 2926 612 1 611 2 AOI22S $T=1070120 316400 0 180 $X=1066400 $Y=310980
X402 2940 2934 2929 612 1 611 2 AOI22S $T=1072600 276080 1 180 $X=1068880 $Y=275700
X403 2941 2937 2918 612 1 611 2 AOI22S $T=1074460 346640 0 180 $X=1070740 $Y=341220
X404 2938 2932 2917 608 1 613 2 AOI22S $T=1072600 346640 0 0 $X=1072600 $Y=346260
X405 2948 626 627 608 1 613 2 AOI22S $T=1083760 266000 0 180 $X=1080040 $Y=260580
X406 628 2943 2935 608 1 613 2 AOI22S $T=1083760 356720 0 180 $X=1080040 $Y=351300
X407 2949 2945 2923 608 1 613 2 AOI22S $T=1084380 286160 0 180 $X=1080660 $Y=280740
X408 2952 2946 2939 608 1 613 2 AOI22S $T=1084380 296240 0 180 $X=1080660 $Y=290820
X409 2951 2947 2942 608 1 613 2 AOI22S $T=1085000 336560 0 180 $X=1081280 $Y=331140
X410 2944 2950 2921 608 1 613 2 AOI22S $T=1084380 316400 1 0 $X=1084380 $Y=310980
X411 660 647 1 2 640 AN2 $T=225680 326480 1 180 $X=223200 $Y=326100
X412 663 640 1 2 641 AN2 $T=225680 336560 0 180 $X=223200 $Y=331140
X413 667 648 1 2 644 AN2 $T=226920 276080 1 180 $X=224440 $Y=275700
X414 668 649 1 2 645 AN2 $T=226920 296240 0 180 $X=224440 $Y=290820
X415 646 645 1 2 653 AN2 $T=224440 306320 0 0 $X=224440 $Y=305940
X416 643 641 1 2 658 AN2 $T=224440 346640 0 0 $X=224440 $Y=346260
X417 664 655 1 2 648 AN2 $T=228780 266000 0 180 $X=226300 $Y=260580
X418 650 644 1 2 649 AN2 $T=226920 286160 0 0 $X=226920 $Y=285780
X419 652 653 1 2 659 AN2 $T=227540 316400 0 0 $X=227540 $Y=316020
X420 665 659 1 2 647 AN2 $T=230020 326480 0 180 $X=227540 $Y=321060
X421 657 658 1 2 3 AN2 $T=230020 356720 1 180 $X=227540 $Y=356340
X422 713 5 1 2 655 AN2 $T=241800 266000 1 180 $X=239320 $Y=265620
X423 707 8 1 2 6 AN2 $T=244900 286160 1 180 $X=242420 $Y=285780
X424 718 8 1 2 13 AN2 $T=253580 276080 0 180 $X=251100 $Y=270660
X425 726 8 1 2 17 AN2 $T=257300 276080 1 0 $X=257300 $Y=270660
X426 804 800 1 2 778 AN2 $T=279620 296240 1 180 $X=277140 $Y=295860
X427 786 812 1 2 47 AN2 $T=285820 266000 1 0 $X=285820 $Y=260580
X428 855 819 1 2 851 AN2 $T=301940 276080 0 0 $X=301940 $Y=275700
X429 882 65 1 2 61 AN2 $T=308760 266000 1 180 $X=306280 $Y=265620
X430 875 65 1 2 63 AN2 $T=308760 276080 1 180 $X=306280 $Y=275700
X431 892 65 1 2 68 AN2 $T=312480 276080 1 180 $X=310000 $Y=275700
X432 71 70 1 2 894 AN2 $T=316820 266000 1 180 $X=314340 $Y=265620
X433 907 65 1 2 72 AN2 $T=319920 286160 0 180 $X=317440 $Y=280740
X434 898 894 1 2 913 AN2 $T=318680 266000 0 0 $X=318680 $Y=265620
X435 929 930 1 2 924 AN2 $T=327980 286160 1 180 $X=325500 $Y=285780
X436 925 924 1 2 945 AN2 $T=327360 296240 0 0 $X=327360 $Y=295860
X437 926 913 1 2 944 AN2 $T=327980 266000 0 0 $X=327980 $Y=265620
X438 936 938 1 2 948 AN2 $T=327980 346640 1 0 $X=327980 $Y=341220
X439 953 947 1 2 938 AN2 $T=331080 336560 1 180 $X=328600 $Y=336180
X440 935 944 1 2 930 AN2 $T=331700 276080 1 180 $X=329220 $Y=275700
X441 941 951 1 2 940 AN2 $T=330460 316400 1 0 $X=330460 $Y=310980
X442 950 945 1 2 957 AN2 $T=331080 306320 1 0 $X=331080 $Y=300900
X443 943 957 1 2 951 AN2 $T=333560 306320 1 180 $X=331080 $Y=305940
X444 946 940 1 2 958 AN2 $T=331700 326480 1 0 $X=331700 $Y=321060
X445 961 958 1 2 947 AN2 $T=334180 326480 1 180 $X=331700 $Y=326100
X446 954 948 1 2 88 AN2 $T=333560 356720 1 0 $X=333560 $Y=351300
X447 1004 825 1 2 94 AN2 $T=344100 266000 0 180 $X=341620 $Y=260580
X448 1057 102 1 2 1045 AN2 $T=358360 266000 1 180 $X=355880 $Y=265620
X449 1128 1059 1 2 1143 AN2 $T=381300 296240 1 0 $X=381300 $Y=290820
X450 1163 120 1 2 127 AN2 $T=391220 276080 0 180 $X=388740 $Y=270660
X451 132 134 1 2 1158 AN2 $T=391840 266000 1 0 $X=391840 $Y=260580
X452 1170 120 1 2 133 AN2 $T=394940 276080 0 180 $X=392460 $Y=270660
X453 1174 1173 1 2 1130 AN2 $T=397420 346640 1 180 $X=394940 $Y=346260
X454 1160 1158 1 2 138 AN2 $T=395560 266000 1 0 $X=395560 $Y=260580
X455 1154 120 1 2 1185 AN2 $T=396800 276080 1 0 $X=396800 $Y=270660
X456 1171 120 1 2 142 AN2 $T=400520 276080 1 0 $X=400520 $Y=270660
X457 1191 1189 1 2 1173 AN2 $T=403000 346640 0 180 $X=400520 $Y=341220
X458 1205 1199 1 2 1189 AN2 $T=405480 346640 0 180 $X=403000 $Y=341220
X459 1192 1202 1 2 1227 AN2 $T=404860 306320 1 0 $X=404860 $Y=300900
X460 1197 1212 1 2 1217 AN2 $T=405480 326480 1 0 $X=405480 $Y=321060
X461 1220 1216 1 2 1212 AN2 $T=408580 316400 0 180 $X=406100 $Y=310980
X462 1221 1227 1 2 1216 AN2 $T=409200 306320 0 0 $X=409200 $Y=305940
X463 1224 1217 1 2 1232 AN2 $T=409820 326480 0 0 $X=409820 $Y=326100
X464 1223 1232 1 2 1242 AN2 $T=412300 326480 0 0 $X=412300 $Y=326100
X465 1235 1245 1 2 1226 AN2 $T=416020 266000 1 180 $X=413540 $Y=265620
X466 1243 1242 1 2 1252 AN2 $T=414160 336560 1 0 $X=414160 $Y=331140
X467 1249 1252 1 2 1199 AN2 $T=418500 346640 1 180 $X=416020 $Y=346260
X468 150 151 1 2 1245 AN2 $T=416640 266000 1 0 $X=416640 $Y=260580
X469 1396 102 1 2 1301 AN2 $T=450120 296240 1 180 $X=447640 $Y=295860
X470 1401 102 1 2 1307 AN2 $T=451360 306320 1 180 $X=448880 $Y=305940
X471 1405 102 1 2 1275 AN2 $T=453840 316400 1 180 $X=451360 $Y=316020
X472 182 102 1 2 1320 AN2 $T=456320 276080 0 180 $X=453840 $Y=270660
X473 183 102 1 2 1262 AN2 $T=459420 336560 1 180 $X=456940 $Y=336180
X474 175 102 1 2 1336 AN2 $T=460040 346640 0 180 $X=457560 $Y=341220
X475 186 102 1 2 1326 AN2 $T=462520 326480 1 180 $X=460040 $Y=326100
X476 191 102 1 2 1392 AN2 $T=463140 276080 0 180 $X=460660 $Y=270660
X477 190 102 1 2 166 AN2 $T=465620 266000 0 180 $X=463140 $Y=260580
X478 1431 1428 1 2 1443 AN2 $T=469960 286160 1 0 $X=469960 $Y=280740
X479 1484 194 1 2 219 AN2 $T=494760 266000 1 0 $X=494760 $Y=260580
X480 1508 220 1 2 1523 AN2 $T=497240 266000 0 0 $X=497240 $Y=265620
X481 1502 1507 1 2 1513 AN2 $T=497240 306320 1 0 $X=497240 $Y=300900
X482 1506 1512 1 2 1526 AN2 $T=497860 286160 1 0 $X=497860 $Y=280740
X483 1505 1513 1 2 1520 AN2 $T=497860 316400 1 0 $X=497860 $Y=310980
X484 1510 1515 1 2 1521 AN2 $T=497860 336560 0 0 $X=497860 $Y=336180
X485 1525 1523 1 2 1512 AN2 $T=500960 276080 1 180 $X=498480 $Y=275700
X486 1514 1520 1 2 1528 AN2 $T=498480 316400 0 0 $X=498480 $Y=316020
X487 1516 1521 1 2 1531 AN2 $T=498480 346640 0 0 $X=498480 $Y=346260
X488 1530 1527 1 2 1507 AN2 $T=501580 296240 0 180 $X=499100 $Y=290820
X489 1509 1529 1 2 1515 AN2 $T=501580 326480 1 180 $X=499100 $Y=326100
X490 1517 1526 1 2 1527 AN2 $T=499720 286160 0 0 $X=499720 $Y=285780
X491 1518 1528 1 2 1529 AN2 $T=499720 326480 1 0 $X=499720 $Y=321060
X492 1522 1531 1 2 1533 AN2 $T=500340 356720 1 0 $X=500340 $Y=351300
X493 1535 1533 1 2 229 AN2 $T=505300 356720 0 0 $X=505300 $Y=356340
X494 1578 1573 1 2 1556 AN2 $T=517080 276080 0 180 $X=514600 $Y=270660
X495 1617 252 1 2 250 AN2 $T=536300 276080 0 180 $X=533820 $Y=270660
X496 1653 252 1 2 1658 AN2 $T=542500 276080 1 180 $X=540020 $Y=275700
X497 258 259 1 2 1667 AN2 $T=541260 266000 0 0 $X=541260 $Y=265620
X498 1639 252 1 2 262 AN2 $T=543120 276080 1 0 $X=543120 $Y=270660
X499 1677 1679 1 2 272 AN2 $T=546220 356720 0 0 $X=546220 $Y=356340
X500 1669 1667 1 2 1687 AN2 $T=546840 266000 0 0 $X=546840 $Y=265620
X501 1681 1682 1 2 1691 AN2 $T=547460 306320 1 0 $X=547460 $Y=300900
X502 1689 1693 1 2 1696 AN2 $T=548700 346640 0 0 $X=548700 $Y=346260
X503 1692 1691 1 2 1698 AN2 $T=549320 316400 1 0 $X=549320 $Y=310980
X504 1701 1714 1 2 1682 AN2 $T=554900 296240 1 180 $X=552420 $Y=295860
X505 1707 1715 1 2 1693 AN2 $T=554900 336560 1 180 $X=552420 $Y=336180
X506 1711 1698 1 2 1716 AN2 $T=553040 316400 0 0 $X=553040 $Y=316020
X507 1722 1720 1 2 1704 AN2 $T=556140 286160 0 180 $X=553660 $Y=280740
X508 1708 1716 1 2 1723 AN2 $T=553660 326480 1 0 $X=553660 $Y=321060
X509 1703 1687 1 2 1720 AN2 $T=554280 276080 1 0 $X=554280 $Y=270660
X510 1684 1696 1 2 1679 AN2 $T=556760 356720 0 180 $X=554280 $Y=351300
X511 1705 1704 1 2 1714 AN2 $T=555520 286160 0 0 $X=555520 $Y=285780
X512 1719 1723 1 2 1715 AN2 $T=558620 326480 1 180 $X=556140 $Y=326100
X513 1797 281 1 2 284 AN2 $T=575980 266000 0 180 $X=573500 $Y=260580
X514 1810 1809 1 2 293 AN2 $T=580940 266000 0 0 $X=580940 $Y=265620
X515 1819 292 1 2 1809 AN2 $T=583420 276080 0 180 $X=580940 $Y=270660
X516 1697 1827 1 2 1842 AN2 $T=584660 286160 1 0 $X=584660 $Y=280740
X517 1892 316 1 2 314 AN2 $T=603260 276080 1 180 $X=600780 $Y=275700
X518 1891 316 1 2 324 AN2 $T=609460 286160 1 0 $X=609460 $Y=280740
X519 1929 1923 1 2 1903 AN2 $T=611940 346640 0 180 $X=609460 $Y=341220
X520 1890 321 1 2 1930 AN2 $T=610080 266000 1 0 $X=610080 $Y=260580
X521 1904 316 1 2 330 AN2 $T=612560 286160 1 0 $X=612560 $Y=280740
X522 1877 316 1 2 1958 AN2 $T=616280 286160 1 0 $X=616280 $Y=280740
X523 1934 1936 1 2 1939 AN2 $T=616280 296240 0 0 $X=616280 $Y=295860
X524 1949 1930 1 2 1961 AN2 $T=617520 266000 0 0 $X=617520 $Y=265620
X525 1931 1939 1 2 1962 AN2 $T=618760 296240 0 0 $X=618760 $Y=295860
X526 1955 1952 1 2 1976 AN2 $T=619380 276080 0 0 $X=619380 $Y=275700
X527 1966 1961 1 2 334 AN2 $T=623100 266000 0 180 $X=620620 $Y=260580
X528 1960 1957 1 2 1923 AN2 $T=623100 336560 0 180 $X=620620 $Y=331140
X529 1974 1968 1 2 1936 AN2 $T=623720 296240 1 180 $X=621240 $Y=295860
X530 1972 1978 1 2 1984 AN2 $T=623720 326480 0 0 $X=623720 $Y=326100
X531 1971 1962 1 2 1956 AN2 $T=626820 306320 1 180 $X=624340 $Y=305940
X532 1950 1956 1 2 1982 AN2 $T=624340 316400 1 0 $X=624340 $Y=310980
X533 1951 1981 1 2 1968 AN2 $T=627440 286160 1 180 $X=624960 $Y=285780
X534 1979 1982 1 2 1978 AN2 $T=627440 326480 0 180 $X=624960 $Y=321060
X535 1943 1976 1 2 1981 AN2 $T=626200 286160 1 0 $X=626200 $Y=280740
X536 1989 1984 1 2 1957 AN2 $T=628680 336560 0 180 $X=626200 $Y=331140
X537 1991 1990 1 2 1952 AN2 $T=630540 276080 0 180 $X=628060 $Y=270660
X538 1997 341 1 2 1990 AN2 $T=633640 266000 1 180 $X=631160 $Y=265620
X539 358 292 1 2 2071 AN2 $T=671460 346640 0 180 $X=668980 $Y=341220
X540 2163 292 1 2 2073 AN2 $T=675800 346640 0 180 $X=673320 $Y=341220
X541 361 292 1 2 2092 AN2 $T=678280 356720 0 180 $X=675800 $Y=351300
X542 2187 292 1 2 2036 AN2 $T=684480 306320 0 180 $X=682000 $Y=300900
X543 2183 292 1 2 2111 AN2 $T=684480 306320 1 180 $X=682000 $Y=305940
X544 2190 292 1 2 2167 AN2 $T=688200 316400 0 180 $X=685720 $Y=310980
X545 363 292 1 2 2094 AN2 $T=688200 336560 0 180 $X=685720 $Y=331140
X546 2198 292 1 2 2068 AN2 $T=690680 266000 1 180 $X=688200 $Y=265620
X547 2202 292 1 2 2076 AN2 $T=691300 296240 0 180 $X=688820 $Y=290820
X548 2206 292 1 2 2035 AN2 $T=693160 266000 1 180 $X=690680 $Y=265620
X549 2219 2212 1 2 2231 AN2 $T=709900 266000 0 0 $X=709900 $Y=265620
X550 2227 2220 1 2 2232 AN2 $T=713000 286160 0 0 $X=713000 $Y=285780
X551 2235 2217 1 2 2244 AN2 $T=716100 296240 1 0 $X=716100 $Y=290820
X552 2236 2239 1 2 2245 AN2 $T=717340 346640 0 0 $X=717340 $Y=346260
X553 2238 2225 1 2 2246 AN2 $T=718580 336560 1 0 $X=718580 $Y=331140
X554 393 397 1 2 398 AN2 $T=722300 356720 0 0 $X=722300 $Y=356340
X555 2269 2264 1 2 2283 AN2 $T=734700 326480 0 0 $X=734700 $Y=326100
X556 2250 2261 1 2 2280 AN2 $T=737180 266000 0 0 $X=737180 $Y=265620
X557 2257 2268 1 2 2289 AN2 $T=740280 296240 0 0 $X=740280 $Y=295860
X558 2260 2276 1 2 2288 AN2 $T=741520 356720 0 0 $X=741520 $Y=356340
X559 2295 2278 1 2 2302 AN2 $T=745860 296240 0 0 $X=745860 $Y=295860
X560 2277 2292 1 2 2315 AN2 $T=746480 336560 0 0 $X=746480 $Y=336180
X561 2387 2386 1 2 378 AN2 $T=783680 326480 1 180 $X=781200 $Y=326100
X562 2391 2386 1 2 376 AN2 $T=784300 326480 0 180 $X=781820 $Y=321060
X563 2392 2386 1 2 387 AN2 $T=784300 336560 0 180 $X=781820 $Y=331140
X564 2405 2386 1 2 388 AN2 $T=788640 326480 1 180 $X=786160 $Y=326100
X565 2391 2408 1 2 420 AN2 $T=792980 326480 1 180 $X=790500 $Y=326100
X566 2392 2408 1 2 413 AN2 $T=791740 336560 0 0 $X=791740 $Y=336180
X567 2408 2405 1 2 412 AN2 $T=792980 326480 0 0 $X=792980 $Y=326100
X568 2387 2408 1 2 421 AN2 $T=796700 336560 1 180 $X=794220 $Y=336180
X569 2435 2405 1 2 438 AN2 $T=806620 326480 0 0 $X=806620 $Y=326100
X570 2438 2405 1 2 455 AN2 $T=819020 326480 0 0 $X=819020 $Y=326100
X571 2435 2392 1 2 458 AN2 $T=820260 326480 1 0 $X=820260 $Y=321060
X572 2435 2387 1 2 461 AN2 $T=823360 326480 0 0 $X=823360 $Y=326100
X573 2438 2387 1 2 462 AN2 $T=823980 336560 1 0 $X=823980 $Y=331140
X574 2435 2391 1 2 459 AN2 $T=826460 316400 0 0 $X=826460 $Y=316020
X575 2438 2391 1 2 463 AN2 $T=827700 326480 0 0 $X=827700 $Y=326100
X576 2438 2392 1 2 466 AN2 $T=835760 336560 0 0 $X=835760 $Y=336180
X577 2773 2771 1 2 556 AN2 $T=971540 326480 1 180 $X=969060 $Y=326100
X578 2773 2777 1 2 554 AN2 $T=972780 336560 0 180 $X=970300 $Y=331140
X579 2786 2777 1 2 528 AN2 $T=975260 336560 0 180 $X=972780 $Y=331140
X580 2773 2782 1 2 559 AN2 $T=975260 336560 1 180 $X=972780 $Y=336180
X581 2786 2782 1 2 535 AN2 $T=976500 326480 1 180 $X=974020 $Y=326100
X582 2773 2792 1 2 552 AN2 $T=976500 346640 1 0 $X=976500 $Y=341220
X583 2786 2771 1 2 549 AN2 $T=980220 326480 1 180 $X=977740 $Y=326100
X584 2786 2792 1 2 590 AN2 $T=990760 346640 1 0 $X=990760 $Y=341220
X585 2675 2792 1 2 599 AN2 $T=1019280 336560 0 180 $X=1016800 $Y=331140
X586 2782 2675 1 2 604 AN2 $T=1018660 346640 1 0 $X=1018660 $Y=341220
X587 2777 2675 1 2 600 AN2 $T=1021760 336560 0 180 $X=1019280 $Y=331140
X588 2782 2826 1 2 608 AN2 $T=1024860 326480 1 0 $X=1024860 $Y=321060
X589 2771 2675 1 2 606 AN2 $T=1027340 336560 0 0 $X=1027340 $Y=336180
X590 2777 2826 1 2 611 AN2 $T=1029200 336560 1 0 $X=1029200 $Y=331140
X591 2792 2826 1 2 612 AN2 $T=1029820 336560 0 0 $X=1029820 $Y=336180
X592 2771 2826 1 2 613 AN2 $T=1032300 336560 1 0 $X=1032300 $Y=331140
X593 2904 2901 1 2 2877 AN2 $T=1041600 276080 1 180 $X=1039120 $Y=275700
X594 2908 2905 1 2 2881 AN2 $T=1047800 296240 1 180 $X=1045320 $Y=295860
X595 2910 2900 1 2 2824 AN2 $T=1054000 316400 1 180 $X=1051520 $Y=316020
X596 2918 2917 1 2 2871 AN2 $T=1059580 346640 0 180 $X=1057100 $Y=341220
X597 2926 2921 1 2 2873 AN2 $T=1063920 316400 0 180 $X=1061440 $Y=310980
X598 2929 2923 1 2 2863 AN2 $T=1064540 276080 1 180 $X=1062060 $Y=275700
X599 625 2935 1 2 624 AN2 $T=1071980 356720 0 180 $X=1069500 $Y=351300
X600 2933 2939 1 2 2889 AN2 $T=1074460 296240 0 180 $X=1071980 $Y=290820
X601 2927 2942 1 2 2886 AN2 $T=1076940 336560 0 180 $X=1074460 $Y=331140
X602 2253 370 1 2 INV6CK $T=729120 326480 0 180 $X=723540 $Y=321060
X603 2274 379 1 2 INV6CK $T=735320 316400 0 180 $X=729740 $Y=310980
X604 2299 381 1 2 INV6CK $T=747720 346640 0 180 $X=742140 $Y=341220
X605 2296 371 1 2 INV6CK $T=745860 306320 0 0 $X=745860 $Y=305940
X606 2407 402 1 2 INV6CK $T=791120 306320 0 0 $X=791120 $Y=305940
X607 437 419 1 2 INV6CK $T=801040 336560 0 180 $X=795460 $Y=331140
X608 2422 417 1 2 INV6CK $T=797940 356720 0 0 $X=797940 $Y=356340
X609 2445 409 1 2 INV6CK $T=808480 276080 0 180 $X=802900 $Y=270660
X610 2456 441 1 2 INV6CK $T=812820 306320 0 0 $X=812820 $Y=305940
X611 444 449 1 2 INV6CK $T=812820 336560 0 0 $X=812820 $Y=336180
X612 470 457 1 2 INV6CK $T=840720 326480 0 0 $X=840720 $Y=326100
X613 2523 447 1 2 INV6CK $T=845680 336560 0 0 $X=845680 $Y=336180
X614 2538 464 1 2 INV6CK $T=859320 336560 0 0 $X=859320 $Y=336180
X615 2547 446 1 2 INV6CK $T=864900 306320 0 0 $X=864900 $Y=305940
X616 2563 456 1 2 INV6CK $T=882880 316400 0 0 $X=882880 $Y=316020
X617 2638 511 1 2 INV6CK $T=916360 326480 0 180 $X=910780 $Y=321060
X618 2672 534 1 2 INV6CK $T=924420 326480 0 0 $X=924420 $Y=326100
X619 2676 546 1 2 INV6CK $T=933720 316400 1 180 $X=928140 $Y=316020
X620 2641 542 1 2 INV6CK $T=943640 336560 0 180 $X=938060 $Y=331140
X621 2642 553 1 2 INV6CK $T=938060 346640 1 0 $X=938060 $Y=341220
X622 2673 563 1 2 INV6CK $T=951700 326480 0 0 $X=951700 $Y=326100
X623 569 544 1 2 INV6CK $T=952320 346640 0 0 $X=952320 $Y=346260
X624 2753 593 1 2 INV6CK $T=990140 356720 0 0 $X=990140 $Y=356340
X625 607 595 1 2 INV6CK $T=1024860 346640 0 0 $X=1024860 $Y=346260
X626 2784 602 1 2 INV6CK $T=1032920 356720 0 0 $X=1032920 $Y=356340
X627 2834 614 1 2 INV6CK $T=1046560 326480 0 180 $X=1040980 $Y=321060
X628 2798 603 1 2 INV6CK $T=1045940 346640 0 0 $X=1045940 $Y=346260
X629 2814 619 1 2 INV6CK $T=1059580 336560 0 180 $X=1054000 $Y=331140
X630 2858 616 1 2 INV6CK $T=1059580 346640 1 0 $X=1059580 $Y=341220
X631 2394 2299 1 2 INV4CK $T=784300 326480 1 0 $X=784300 $Y=321060
X632 2441 2407 1 2 INV4CK $T=807860 316400 0 0 $X=807860 $Y=316020
X633 2502 2526 1 2 INV4CK $T=846300 296240 0 0 $X=846300 $Y=295860
X634 2536 2523 1 2 INV4CK $T=851260 306320 0 0 $X=851260 $Y=305940
X635 592 587 1 2 INV4CK $T=990760 336560 1 180 $X=987040 $Y=336180
X636 422 2290 1 2 2321 QDBHN $T=765700 306320 0 180 $X=758260 $Y=300900
X637 422 2297 1 2 2317 QDBHN $T=771280 316400 0 180 $X=763840 $Y=310980
X638 422 2291 1 2 2395 QDBHN $T=791740 336560 0 180 $X=784300 $Y=331140
X639 427 429 1 2 2408 QDBHN $T=784300 336560 0 0 $X=784300 $Y=336180
X640 422 2285 1 2 2393 QDBHN $T=788640 286160 0 0 $X=788640 $Y=285780
X641 422 2328 1 2 2424 QDBHN $T=791740 276080 0 0 $X=791740 $Y=275700
X642 422 2331 1 2 2431 QDBHN $T=794220 346640 0 0 $X=794220 $Y=346260
X643 427 436 1 2 2421 QDBHN $T=795460 326480 0 0 $X=795460 $Y=326100
X644 427 440 1 2 2410 QDBHN $T=808480 346640 0 180 $X=801040 $Y=341220
X645 422 2309 1 2 2452 QDBHN $T=801660 306320 0 0 $X=801660 $Y=305940
X646 422 2307 1 2 2481 QDBHN $T=819640 356720 1 0 $X=819640 $Y=351300
X647 422 2475 1 2 2474 QDBHN $T=837000 336560 0 180 $X=829560 $Y=331140
X648 422 2465 1 2 2495 QDBHN $T=839480 316400 0 180 $X=832040 $Y=310980
X649 422 2466 1 2 2499 QDBHN $T=841340 296240 0 180 $X=833900 $Y=290820
X650 422 2434 1 2 2539 QDBHN $T=843200 316400 0 0 $X=843200 $Y=316020
X651 422 2440 1 2 2546 QDBHN $T=859320 286160 0 0 $X=859320 $Y=285780
X652 486 2581 1 2 2587 QDBHN $T=871720 336560 0 0 $X=871720 $Y=336180
X653 486 2591 1 2 2597 QDBHN $T=877920 346640 0 0 $X=877920 $Y=346260
X654 486 2637 1 2 2617 QDBHN $T=899620 296240 0 180 $X=892180 $Y=290820
X655 486 2657 1 2 2649 QDBHN $T=909540 296240 0 180 $X=902100 $Y=290820
X656 486 2714 1 2 2706 QDBHN $T=934960 356720 0 180 $X=927520 $Y=351300
X657 486 2760 1 2 2765 QDBHN $T=961620 346640 0 0 $X=961620 $Y=346260
X658 486 2802 1 2 2780 QDBHN $T=983940 326480 0 0 $X=983940 $Y=326100
X659 486 2832 1 2 2845 QDBHN $T=1001300 346640 0 0 $X=1001300 $Y=346260
X660 486 2864 1 2 2852 QDBHN $T=1018660 326480 0 180 $X=1011220 $Y=321060
X661 486 2860 1 2 2875 QDBHN $T=1011840 356720 0 0 $X=1011840 $Y=356340
X662 486 2885 1 2 2837 QDBHN $T=1026720 316400 0 180 $X=1019280 $Y=310980
X663 2627 2638 1 2 INV2CK $T=899000 316400 0 180 $X=896520 $Y=310980
X664 2677 2672 1 2 INV2CK $T=912640 316400 0 180 $X=910160 $Y=310980
X665 576 2753 1 2 INV2CK $T=959140 356720 1 180 $X=956660 $Y=356340
X666 585 2784 1 2 INV2CK $T=975880 356720 1 180 $X=973400 $Y=356340
X667 738 8 20 1 2 AN2T $T=260400 266000 0 0 $X=260400 $Y=265620
X668 1065 1064 1055 1 2 AN2T $T=362700 286160 1 180 $X=358360 $Y=285780
X669 1048 1045 111 1 2 AN2T $T=360840 266000 1 0 $X=360840 $Y=260580
X670 1075 1080 1112 1 2 AN2T $T=370760 266000 0 0 $X=370760 $Y=265620
X671 1218 1214 1206 1 2 AN2T $T=408580 276080 1 180 $X=404240 $Y=275700
X672 1219 1206 1202 1 2 AN2T $T=408580 286160 0 180 $X=404240 $Y=280740
X673 1229 1226 1214 1 2 AN2T $T=411060 276080 0 180 $X=406720 $Y=270660
X674 1476 194 217 1 2 AN2T $T=492900 266000 0 0 $X=492900 $Y=265620
X675 1554 1556 1571 1 2 AN2T $T=512740 266000 0 0 $X=512740 $Y=265620
X676 1592 1601 1605 1 2 AN2T $T=521420 286160 0 0 $X=521420 $Y=285780
X677 1606 1571 245 1 2 AN2T $T=524520 266000 1 0 $X=524520 $Y=260580
X678 1649 252 1651 1 2 AN2T $T=541260 266000 1 180 $X=536920 $Y=265620
X679 2342 422 2338 1 2 AN2T $T=765080 326480 1 0 $X=765080 $Y=321060
X680 2323 422 2354 1 2 AN2T $T=773760 306320 0 180 $X=769420 $Y=300900
X681 2378 422 2379 1 2 AN2T $T=780580 286160 0 0 $X=780580 $Y=285780
X682 2380 422 2394 1 2 AN2T $T=784300 346640 1 0 $X=784300 $Y=341220
X683 2418 422 2428 1 2 AN2T $T=796080 296240 0 0 $X=796080 $Y=295860
X684 2413 422 442 1 2 AN2T $T=809720 346640 1 180 $X=805380 $Y=346260
X685 2443 422 2441 1 2 AN2T $T=807860 286160 0 0 $X=807860 $Y=285780
X686 2459 422 2451 1 2 AN2T $T=815920 346640 1 180 $X=811580 $Y=346260
X687 2488 422 468 1 2 AN2T $T=829560 346640 1 0 $X=829560 $Y=341220
X688 2493 422 2502 1 2 AN2T $T=833280 306320 1 0 $X=833280 $Y=300900
X689 469 422 2504 1 2 AN2T $T=833280 356720 1 0 $X=833280 $Y=351300
X690 2529 422 2520 1 2 AN2T $T=847540 306320 1 180 $X=843200 $Y=305940
X691 474 422 475 1 2 AN2T $T=843200 356720 0 0 $X=843200 $Y=356340
X692 2476 422 2530 1 2 AN2T $T=845060 286160 0 0 $X=845060 $Y=285780
X693 2544 422 2536 1 2 AN2T $T=855600 286160 1 180 $X=851260 $Y=285780
X694 2602 486 2595 1 2 AN2T $T=887220 336560 1 180 $X=882880 $Y=336180
X695 2626 486 2615 1 2 AN2T $T=893420 346640 1 180 $X=889080 $Y=346260
X696 2632 486 2623 1 2 AN2T $T=895280 356720 1 180 $X=890940 $Y=356340
X697 2635 486 2627 1 2 AN2T $T=896520 306320 0 180 $X=892180 $Y=300900
X698 2665 486 2677 1 2 AN2T $T=908920 306320 1 0 $X=908920 $Y=300900
X699 2731 486 560 1 2 AN2T $T=943020 356720 0 180 $X=938680 $Y=351300
X700 2817 486 2796 1 2 AN2T $T=993240 346640 0 0 $X=993240 $Y=346260
X701 2822 486 2810 1 2 AN2T $T=999440 326480 1 180 $X=995100 $Y=326100
X702 2838 486 2833 1 2 AN2T $T=1007500 326480 0 180 $X=1003160 $Y=321060
X703 2850 486 2861 1 2 AN2T $T=1011220 316400 1 0 $X=1011220 $Y=310980
X704 168 1 2 173 DELC $T=447020 356720 1 0 $X=447020 $Y=351300
X705 174 1 2 178 DELC $T=451980 356720 1 0 $X=451980 $Y=351300
X706 179 1 2 185 DELC $T=456940 356720 1 0 $X=456940 $Y=351300
X707 2154 1 2 2162 DELC $T=670840 326480 1 0 $X=670840 $Y=321060
X708 2168 1 2 2179 DELC $T=677040 346640 1 0 $X=677040 $Y=341220
X709 2176 1 2 2189 DELC $T=680760 336560 1 0 $X=680760 $Y=331140
X710 2178 1 2 2192 DELC $T=681380 316400 0 0 $X=681380 $Y=316020
X711 2195 1 2 369 DELC $T=693780 346640 0 0 $X=693780 $Y=346260
X712 2207 1 2 2204 DELC $T=695020 316400 1 0 $X=695020 $Y=310980
X713 2193 1 2 2197 DELC $T=698120 296240 0 0 $X=698120 $Y=295860
X714 2199 1 2 2201 DELC $T=699980 316400 1 0 $X=699980 $Y=310980
X715 2210 1 2 380 DELC $T=699980 346640 0 0 $X=699980 $Y=346260
X716 2177 1 2 382 DELC $T=702460 356720 1 0 $X=702460 $Y=351300
X717 2221 1 2 392 DELC $T=715480 326480 1 0 $X=715480 $Y=321060
X718 2765 1 2 582 DELC $T=969060 346640 0 0 $X=969060 $Y=346260
X719 2837 1 2 2850 DELC $T=1006260 316400 1 0 $X=1006260 $Y=310980
X720 642 2 664 1 INV1S $T=224440 276080 1 0 $X=224440 $Y=270660
X721 643 2 656 1 INV1S $T=233740 346640 0 180 $X=232500 $Y=341220
X722 681 2 646 1 INV1S $T=234360 306320 1 180 $X=233120 $Y=305940
X723 682 2 643 1 INV1S $T=234980 346640 0 180 $X=233740 $Y=341220
X724 677 2 650 1 INV1S $T=237460 286160 1 180 $X=236220 $Y=285780
X725 690 2 652 1 INV1S $T=237460 316400 0 180 $X=236220 $Y=310980
X726 680 2 665 1 INV1S $T=238080 316400 1 180 $X=236840 $Y=316020
X727 683 2 663 1 INV1S $T=238700 336560 1 180 $X=237460 $Y=336180
X728 685 2 660 1 INV1S $T=239320 336560 0 180 $X=238080 $Y=331140
X729 679 2 657 1 INV1S $T=239320 356720 0 180 $X=238080 $Y=351300
X730 663 2 671 1 INV1S $T=238700 336560 0 0 $X=238700 $Y=336180
X731 4 2 672 1 INV1S $T=240560 316400 1 180 $X=239320 $Y=316020
X732 692 2 667 1 INV1S $T=241800 276080 1 180 $X=240560 $Y=275700
X733 678 2 668 1 INV1S $T=243660 296240 0 180 $X=242420 $Y=290820
X734 8 2 10 1 INV1S $T=243660 356720 0 0 $X=243660 $Y=356340
X735 672 2 684 1 INV1S $T=244280 326480 1 0 $X=244280 $Y=321060
X736 4 2 9 1 INV1S $T=244900 276080 0 0 $X=244900 $Y=275700
X737 733 2 730 1 INV1S $T=256680 296240 0 180 $X=255440 $Y=290820
X738 15 2 720 1 INV1S $T=256060 316400 1 0 $X=256060 $Y=310980
X739 742 2 713 1 INV1S $T=259160 266000 1 180 $X=257920 $Y=265620
X740 699 2 770 1 INV1S $T=269080 336560 0 0 $X=269080 $Y=336180
X741 750 2 760 1 INV1S $T=272800 286160 1 180 $X=271560 $Y=285780
X742 719 2 779 1 INV1S $T=272800 276080 0 0 $X=272800 $Y=275700
X743 777 2 783 1 INV1S $T=274040 266000 0 0 $X=274040 $Y=265620
X744 791 2 765 1 INV1S $T=280860 286160 0 180 $X=279620 $Y=280740
X745 27 2 800 1 INV1S $T=282100 296240 1 180 $X=280860 $Y=295860
X746 814 2 836 1 INV1S $T=290160 296240 1 0 $X=290160 $Y=290820
X747 35 2 48 1 INV1S $T=291400 276080 1 0 $X=291400 $Y=270660
X748 49 2 828 1 INV1S $T=296360 306320 0 180 $X=295120 $Y=300900
X749 55 2 848 1 INV1S $T=296980 296240 1 0 $X=296980 $Y=290820
X750 829 2 855 1 INV1S $T=298840 276080 1 0 $X=298840 $Y=270660
X751 854 2 856 1 INV1S $T=303180 266000 0 0 $X=303180 $Y=265620
X752 863 2 866 1 INV1S $T=304420 296240 1 0 $X=304420 $Y=290820
X753 872 2 875 1 INV1S $T=306280 296240 0 0 $X=306280 $Y=295860
X754 859 2 870 1 INV1S $T=308140 286160 1 180 $X=306900 $Y=285780
X755 851 2 877 1 INV1S $T=311240 266000 1 0 $X=311240 $Y=260580
X756 891 2 884 1 INV1S $T=313100 306320 0 180 $X=311860 $Y=300900
X757 895 2 898 1 INV1S $T=314960 276080 0 0 $X=314960 $Y=275700
X758 871 2 899 1 INV1S $T=316200 306320 1 0 $X=316200 $Y=300900
X759 73 2 71 1 INV1S $T=318680 266000 0 180 $X=317440 $Y=260580
X760 65 2 890 1 INV1S $T=318060 316400 1 0 $X=318060 $Y=310980
X761 910 2 925 1 INV1S $T=324880 296240 1 0 $X=324880 $Y=290820
X762 908 2 936 1 INV1S $T=325500 346640 1 0 $X=325500 $Y=341220
X763 922 2 929 1 INV1S $T=326120 286160 1 0 $X=326120 $Y=280740
X764 921 2 926 1 INV1S $T=326740 276080 1 0 $X=326740 $Y=270660
X765 933 2 935 1 INV1S $T=327360 286160 1 0 $X=327360 $Y=280740
X766 934 2 941 1 INV1S $T=327360 316400 1 0 $X=327360 $Y=310980
X767 931 2 943 1 INV1S $T=327980 306320 0 0 $X=327980 $Y=305940
X768 937 2 946 1 INV1S $T=328600 326480 1 0 $X=328600 $Y=321060
X769 939 2 84 1 INV1S $T=329220 356720 1 0 $X=329220 $Y=351300
X770 918 2 954 1 INV1S $T=329840 346640 0 0 $X=329840 $Y=346260
X771 952 2 953 1 INV1S $T=332940 336560 1 180 $X=331700 $Y=336180
X772 953 2 968 1 INV1S $T=332940 336560 0 0 $X=332940 $Y=336180
X773 970 2 973 1 INV1S $T=335420 266000 1 0 $X=335420 $Y=260580
X774 969 2 975 1 INV1S $T=335420 286160 1 0 $X=335420 $Y=280740
X775 919 2 950 1 INV1S $T=336660 306320 0 180 $X=335420 $Y=300900
X776 927 2 961 1 INV1S $T=337280 326480 0 180 $X=336040 $Y=321060
X777 916 2 93 1 INV1S $T=337900 356720 0 0 $X=337900 $Y=356340
X778 94 2 92 1 INV1S $T=339760 266000 0 180 $X=338520 $Y=260580
X779 76 2 82 1 INV1S $T=345340 276080 0 180 $X=344100 $Y=270660
X780 1008 2 1013 1 INV1S $T=344720 326480 1 0 $X=344720 $Y=321060
X781 991 2 1018 1 INV1S $T=347820 336560 0 180 $X=346580 $Y=331140
X782 1012 2 1023 1 INV1S $T=346580 346640 0 0 $X=346580 $Y=346260
X783 1034 2 1022 1 INV1S $T=350300 336560 0 180 $X=349060 $Y=331140
X784 994 2 1036 1 INV1S $T=349060 356720 1 0 $X=349060 $Y=351300
X785 991 2 1035 1 INV1S $T=350300 336560 1 0 $X=350300 $Y=331140
X786 87 2 104 1 INV1S $T=357740 266000 1 0 $X=357740 $Y=260580
X787 105 2 1064 1 INV1S $T=362700 286160 1 0 $X=362700 $Y=280740
X788 1005 2 1085 1 INV1S $T=365800 286160 1 0 $X=365800 $Y=280740
X789 115 2 112 1 INV1S $T=368280 356720 1 180 $X=367040 $Y=356340
X790 119 2 1133 1 INV1S $T=386260 276080 1 180 $X=385020 $Y=275700
X791 1155 2 1132 1 INV1S $T=389360 346640 0 180 $X=388120 $Y=341220
X792 1094 2 1161 1 INV1S $T=391840 286160 0 180 $X=390600 $Y=280740
X793 133 2 1160 1 INV1S $T=392460 266000 0 0 $X=392460 $Y=265620
X794 1127 2 1153 1 INV1S $T=394320 286160 1 0 $X=394320 $Y=280740
X795 106 2 1169 1 INV1S $T=395560 336560 1 180 $X=394320 $Y=336180
X796 1178 2 1174 1 INV1S $T=399280 346640 0 180 $X=398040 $Y=341220
X797 1185 2 140 1 INV1S $T=399900 266000 0 0 $X=399900 $Y=265620
X798 120 2 1139 1 INV1S $T=399900 336560 0 0 $X=399900 $Y=336180
X799 1188 2 1192 1 INV1S $T=401760 296240 0 0 $X=401760 $Y=295860
X800 1152 2 1197 1 INV1S $T=403620 316400 0 0 $X=403620 $Y=316020
X801 1195 2 1191 1 INV1S $T=406100 336560 0 180 $X=404860 $Y=331140
X802 1196 2 1221 1 INV1S $T=405480 306320 0 0 $X=405480 $Y=305940
X803 1198 2 1205 1 INV1S $T=407340 346640 1 180 $X=406100 $Y=346260
X804 1194 2 146 1 INV1S $T=407340 266000 1 0 $X=407340 $Y=260580
X805 1207 2 1223 1 INV1S $T=407960 326480 1 0 $X=407960 $Y=321060
X806 1183 2 1224 1 INV1S $T=407960 336560 1 0 $X=407960 $Y=331140
X807 1211 2 1218 1 INV1S $T=408580 276080 0 0 $X=408580 $Y=275700
X808 1187 2 1219 1 INV1S $T=408580 286160 0 0 $X=408580 $Y=285780
X809 1203 2 1220 1 INV1S $T=408580 316400 1 0 $X=408580 $Y=310980
X810 1169 2 1159 1 INV1S $T=409820 346640 1 180 $X=408580 $Y=346260
X811 1172 2 1235 1 INV1S $T=410440 266000 0 0 $X=410440 $Y=265620
X812 1193 2 1229 1 INV1S $T=411060 276080 1 0 $X=411060 $Y=270660
X813 1204 2 1243 1 INV1S $T=412920 336560 1 0 $X=412920 $Y=331140
X814 1184 2 1249 1 INV1S $T=414780 346640 0 0 $X=414780 $Y=346260
X815 1231 2 1257 1 INV1S $T=416640 336560 1 0 $X=416640 $Y=331140
X816 1266 2 1279 1 INV1S $T=422220 316400 1 0 $X=422220 $Y=310980
X817 1275 2 1269 1 INV1S $T=425320 316400 1 180 $X=424080 $Y=316020
X818 1274 2 1310 1 INV1S $T=427180 326480 0 0 $X=427180 $Y=326100
X819 1311 2 1325 1 INV1S $T=429040 346640 1 0 $X=429040 $Y=341220
X820 1318 2 1339 1 INV1S $T=434620 276080 1 180 $X=433380 $Y=275700
X821 1327 2 1352 1 INV1S $T=434000 336560 0 0 $X=434000 $Y=336180
X822 1326 2 1261 1 INV1S $T=435860 326480 1 180 $X=434620 $Y=326100
X823 1262 2 1282 1 INV1S $T=435240 336560 0 0 $X=435240 $Y=336180
X824 1255 2 1367 1 INV1S $T=441440 346640 0 180 $X=440200 $Y=341220
X825 167 2 169 1 INV1S $T=447020 266000 1 0 $X=447020 $Y=260580
X826 1336 2 1306 1 INV1S $T=457560 346640 0 180 $X=456320 $Y=341220
X827 1414 2 1428 1 INV1S $T=467480 286160 1 0 $X=467480 $Y=280740
X828 196 2 1430 1 INV1S $T=470580 266000 1 180 $X=469340 $Y=265620
X829 203 2 194 1 INV1S $T=475540 266000 1 180 $X=474300 $Y=265620
X830 1416 2 1450 1 INV1S $T=476780 286160 0 0 $X=476780 $Y=285780
X831 206 2 1460 1 INV1S $T=479880 276080 0 0 $X=479880 $Y=275700
X832 1436 2 1469 1 INV1S $T=481120 286160 1 0 $X=481120 $Y=280740
X833 209 2 1482 1 INV1S $T=487940 266000 1 0 $X=487940 $Y=260580
X834 1497 2 1502 1 INV1S $T=494760 306320 1 0 $X=494760 $Y=300900
X835 1492 2 1505 1 INV1S $T=494760 306320 0 0 $X=494760 $Y=305940
X836 1498 2 1509 1 INV1S $T=494760 326480 0 0 $X=494760 $Y=326100
X837 1491 2 1506 1 INV1S $T=495380 276080 0 0 $X=495380 $Y=275700
X838 1496 2 1514 1 INV1S $T=495380 316400 0 0 $X=495380 $Y=316020
X839 1494 2 1517 1 INV1S $T=496000 286160 0 0 $X=496000 $Y=285780
X840 1475 2 1508 1 INV1S $T=496620 276080 1 0 $X=496620 $Y=270660
X841 1495 2 1518 1 INV1S $T=496620 326480 1 0 $X=496620 $Y=321060
X842 1501 2 1516 1 INV1S $T=496620 346640 0 0 $X=496620 $Y=346260
X843 1499 2 1522 1 INV1S $T=496620 356720 1 0 $X=496620 $Y=351300
X844 1504 2 1510 1 INV1S $T=497860 336560 1 0 $X=497860 $Y=331140
X845 1500 2 222 1 INV1S $T=499100 266000 1 0 $X=499100 $Y=260580
X846 1503 2 1525 1 INV1S $T=499720 276080 1 0 $X=499720 $Y=270660
X847 222 2 224 1 INV1S $T=500340 266000 1 0 $X=500340 $Y=260580
X848 115 2 221 1 INV1S $T=500960 356720 0 0 $X=500960 $Y=356340
X849 1493 2 1530 1 INV1S $T=502200 296240 1 0 $X=502200 $Y=290820
X850 1524 2 1535 1 INV1S $T=509640 346640 1 180 $X=508400 $Y=346260
X851 1588 2 1586 1 INV1S $T=518940 276080 0 180 $X=517700 $Y=270660
X852 234 2 1601 1 INV1S $T=523900 286160 0 180 $X=522660 $Y=280740
X853 1607 2 1635 1 INV1S $T=530100 276080 0 0 $X=530100 $Y=275700
X854 1625 2 1632 1 INV1S $T=530100 286160 0 0 $X=530100 $Y=285780
X855 1633 2 1636 1 INV1S $T=531960 296240 1 0 $X=531960 $Y=290820
X856 246 2 1654 1 INV1S $T=537540 276080 0 0 $X=537540 $Y=275700
X857 237 2 254 1 INV1S $T=539400 266000 0 180 $X=538160 $Y=260580
X858 1658 2 255 1 INV1S $T=540020 276080 1 180 $X=538780 $Y=275700
X859 261 2 258 1 INV1S $T=544980 266000 1 180 $X=543740 $Y=265620
X860 252 2 1655 1 INV1S $T=543740 326480 1 0 $X=543740 $Y=321060
X861 1670 2 1681 1 INV1S $T=544980 306320 1 0 $X=544980 $Y=300900
X862 263 2 1669 1 INV1S $T=546840 266000 1 180 $X=545600 $Y=265620
X863 238 2 264 1 INV1S $T=545600 276080 0 0 $X=545600 $Y=275700
X864 1657 2 1684 1 INV1S $T=545600 346640 0 0 $X=545600 $Y=346260
X865 1673 2 1677 1 INV1S $T=545600 356720 1 0 $X=545600 $Y=351300
X866 1674 2 1692 1 INV1S $T=546840 316400 1 0 $X=546840 $Y=310980
X867 1683 2 1689 1 INV1S $T=548080 346640 1 0 $X=548080 $Y=341220
X868 1664 2 1701 1 INV1S $T=549940 296240 0 0 $X=549940 $Y=295860
X869 1695 2 1711 1 INV1S $T=550560 316400 0 0 $X=550560 $Y=316020
X870 1694 2 1708 1 INV1S $T=550560 326480 1 0 $X=550560 $Y=321060
X871 1699 2 1707 1 INV1S $T=551800 336560 1 0 $X=551800 $Y=331140
X872 1706 2 1719 1 INV1S $T=552420 326480 0 0 $X=552420 $Y=326100
X873 1688 2 1703 1 INV1S $T=553040 276080 1 0 $X=553040 $Y=270660
X874 1686 2 1705 1 INV1S $T=554280 286160 0 0 $X=554280 $Y=285780
X875 1680 2 1722 1 INV1S $T=556140 286160 1 0 $X=556140 $Y=280740
X876 1734 2 1738 1 INV1S $T=558620 336560 1 0 $X=558620 $Y=331140
X877 1739 2 1746 1 INV1S $T=559860 346640 1 0 $X=559860 $Y=341220
X878 1672 2 277 1 INV1S $T=564200 356720 0 0 $X=564200 $Y=356340
X879 1772 2 1767 1 INV1S $T=567920 356720 0 180 $X=566680 $Y=351300
X880 1765 2 1787 1 INV1S $T=570400 326480 0 0 $X=570400 $Y=326100
X881 284 2 282 1 INV1S $T=573500 266000 0 180 $X=572260 $Y=260580
X882 280 2 301 1 INV1S $T=583420 266000 0 0 $X=583420 $Y=265620
X883 286 2 1827 1 INV1S $T=583420 286160 1 0 $X=583420 $Y=280740
X884 1834 2 1861 1 INV1S $T=592100 276080 0 0 $X=592100 $Y=275700
X885 1821 2 1862 1 INV1S $T=592100 286160 0 0 $X=592100 $Y=285780
X886 1857 2 1867 1 INV1S $T=593960 276080 0 0 $X=593960 $Y=275700
X887 1828 2 1860 1 INV1S $T=595200 356720 0 180 $X=593960 $Y=351300
X888 1828 2 1878 1 INV1S $T=598920 356720 0 180 $X=597680 $Y=351300
X889 1855 2 1880 1 INV1S $T=600160 276080 1 180 $X=598920 $Y=275700
X890 314 2 1890 1 INV1S $T=601400 266000 0 0 $X=601400 $Y=265620
X891 1883 2 1897 1 INV1S $T=602640 286160 0 0 $X=602640 $Y=285780
X892 316 2 1901 1 INV1S $T=606980 296240 1 0 $X=606980 $Y=290820
X893 1916 2 1908 1 INV1S $T=609460 346640 0 180 $X=608220 $Y=341220
X894 316 2 1909 1 INV1S $T=610080 326480 1 0 $X=610080 $Y=321060
X895 1921 2 1931 1 INV1S $T=612560 306320 0 0 $X=612560 $Y=305940
X896 1937 2 1929 1 INV1S $T=613800 346640 0 180 $X=612560 $Y=341220
X897 1926 2 1934 1 INV1S $T=613180 296240 0 0 $X=613180 $Y=295860
X898 324 2 1949 1 INV1S $T=613800 266000 0 0 $X=613800 $Y=265620
X899 1931 2 1928 1 INV1S $T=615040 306320 1 180 $X=613800 $Y=305940
X900 1917 2 1943 1 INV1S $T=615660 286160 0 0 $X=615660 $Y=285780
X901 1933 2 1951 1 INV1S $T=616900 286160 0 0 $X=616900 $Y=285780
X902 1940 2 1950 1 INV1S $T=616900 316400 1 0 $X=616900 $Y=310980
X903 1948 2 1955 1 INV1S $T=618140 276080 0 0 $X=618140 $Y=275700
X904 1958 2 1966 1 INV1S $T=621240 266000 0 0 $X=621240 $Y=265620
X905 335 2 303 1 INV1S $T=621860 326480 1 0 $X=621860 $Y=321060
X906 1959 2 1972 1 INV1S $T=621860 326480 0 0 $X=621860 $Y=326100
X907 1966 2 1970 1 INV1S $T=622480 266000 0 0 $X=622480 $Y=265620
X908 303 2 1946 1 INV1S $T=623100 316400 0 0 $X=623100 $Y=316020
X909 1963 2 1960 1 INV1S $T=624340 336560 1 0 $X=624340 $Y=331140
X910 1924 2 1974 1 INV1S $T=624960 296240 0 0 $X=624960 $Y=295860
X911 1967 2 1979 1 INV1S $T=624960 316400 0 0 $X=624960 $Y=316020
X912 1922 2 1971 1 INV1S $T=629300 306320 1 180 $X=628060 $Y=305940
X913 1920 2 1991 1 INV1S $T=628680 276080 0 0 $X=628680 $Y=275700
X914 1988 2 1989 1 INV1S $T=628680 336560 0 0 $X=628680 $Y=336180
X915 323 2 1997 1 INV1S $T=629920 266000 0 0 $X=629920 $Y=265620
X916 1999 2 2007 1 INV1S $T=631780 316400 1 0 $X=631780 $Y=310980
X917 2054 2 2039 1 INV1S $T=643560 286160 1 180 $X=642320 $Y=285780
X918 2073 2 2014 1 INV1S $T=644180 346640 0 180 $X=642940 $Y=341220
X919 2018 2 2069 1 INV1S $T=644800 296240 0 0 $X=644800 $Y=295860
X920 2036 2 2028 1 INV1S $T=646660 306320 1 0 $X=646660 $Y=300900
X921 2028 2 2081 1 INV1S $T=648520 296240 0 0 $X=648520 $Y=295860
X922 2013 2 2050 1 INV1S $T=652240 326480 1 0 $X=652240 $Y=321060
X923 1780 2 2106 1 INV1S $T=654720 276080 1 0 $X=654720 $Y=270660
X924 2077 2 2136 1 INV1S $T=664640 276080 1 0 $X=664640 $Y=270660
X925 2071 2 2046 1 INV1S $T=666500 346640 1 0 $X=666500 $Y=341220
X926 2111 2 2126 1 INV1S $T=668980 296240 0 180 $X=667740 $Y=290820
X927 2035 2 346 1 INV1S $T=670220 266000 1 180 $X=668980 $Y=265620
X928 2120 2 2153 1 INV1S $T=670220 306320 1 0 $X=670220 $Y=300900
X929 2092 2 2019 1 INV1S $T=675800 356720 0 180 $X=674560 $Y=351300
X930 2167 2 2165 1 INV1S $T=677040 306320 1 180 $X=675800 $Y=305940
X931 2148 2 2182 1 INV1S $T=681380 266000 0 0 $X=681380 $Y=265620
X932 403 2 2286 1 INV1S $T=743380 326480 0 0 $X=743380 $Y=326100
X933 410 2 2301 1 INV1S $T=752060 326480 0 180 $X=750820 $Y=321060
X934 408 2 2310 1 INV1S $T=753920 316400 0 0 $X=753920 $Y=316020
X935 2408 2 2386 1 INV1S $T=796700 326480 1 0 $X=796700 $Y=321060
X936 2410 2 2425 1 INV1S $T=797940 326480 1 0 $X=797940 $Y=321060
X937 2421 2 2417 1 INV1S $T=801040 326480 1 0 $X=801040 $Y=321060
X938 2622 2 2629 1 INV1S $T=893420 346640 0 0 $X=893420 $Y=346260
X939 427 2 494 1 INV1S $T=897140 326480 0 180 $X=895900 $Y=321060
X940 525 2 2678 1 INV1S $T=912640 356720 1 0 $X=912640 $Y=351300
X941 543 2 2698 1 INV1S $T=924420 356720 0 0 $X=924420 $Y=356340
X942 545 2 2697 1 INV1S $T=925660 356720 0 0 $X=925660 $Y=356340
X943 2705 2 2795 1 INV1S $T=978980 346640 1 0 $X=978980 $Y=341220
X944 2685 2 2800 1 INV1S $T=981460 336560 1 0 $X=981460 $Y=331140
X945 2675 2 2826 1 INV1S $T=1024240 336560 1 0 $X=1024240 $Y=331140
X946 31 1 800 750 2 804 ND3 $T=280860 286160 1 180 $X=278380 $Y=285780
X947 302 1 1827 1834 2 1697 ND3 $T=586520 276080 1 180 $X=584040 $Y=275700
X948 2232 1 2316 2324 2 2326 ND3 $T=754540 286160 0 0 $X=754540 $Y=285780
X949 2231 1 2333 2339 2 2314 ND3 $T=761360 266000 0 0 $X=761360 $Y=265620
X950 2245 1 2335 2346 2 2320 ND3 $T=762600 356720 1 0 $X=762600 $Y=351300
X951 2283 1 2337 2334 2 2343 ND3 $T=763220 326480 0 0 $X=763220 $Y=326100
X952 2288 1 2344 424 2 2325 ND3 $T=764460 356720 0 0 $X=764460 $Y=356340
X953 2315 1 2353 2356 2 2347 ND3 $T=769420 336560 0 0 $X=769420 $Y=336180
X954 2289 1 2364 2373 2 2376 ND3 $T=778100 296240 0 0 $X=778100 $Y=295860
X955 2246 1 2377 2389 2 2351 ND3 $T=781820 336560 0 0 $X=781820 $Y=336180
X956 2244 1 2372 2400 2 2397 ND3 $T=783680 296240 1 0 $X=783680 $Y=290820
X957 2280 1 2401 2402 2 2398 ND3 $T=786780 276080 1 0 $X=786780 $Y=270660
X958 2302 1 2365 2411 2 2414 ND3 $T=792360 306320 1 0 $X=792360 $Y=300900
X959 2462 1 2461 450 2 2449 ND3 $T=817780 356720 0 180 $X=815300 $Y=351300
X960 2485 1 2482 2479 2 2447 ND3 $T=828320 276080 0 180 $X=825840 $Y=270660
X961 2494 1 2477 2497 2 2439 ND3 $T=832040 286160 0 0 $X=832040 $Y=285780
X962 2521 1 2518 2516 2 2429 ND3 $T=845060 316400 0 180 $X=842580 $Y=310980
X963 2513 1 2528 2531 2 2446 ND3 $T=847540 356720 0 0 $X=847540 $Y=356340
X964 2541 1 2542 2543 2 2453 ND3 $T=853740 336560 1 0 $X=853740 $Y=331140
X965 479 1 2559 2560 2 480 ND3 $T=863040 266000 1 0 $X=863040 $Y=260580
X966 2562 1 2571 2578 2 2455 ND3 $T=869860 316400 1 0 $X=869860 $Y=310980
X967 487 1 2567 2585 2 2454 ND3 $T=876680 266000 0 0 $X=876680 $Y=265620
X968 2589 1 2586 491 2 2437 ND3 $T=879160 336560 0 0 $X=879160 $Y=336180
X969 2609 1 2606 2610 2 2442 ND3 $T=889700 306320 0 180 $X=887220 $Y=300900
X970 2668 1 2667 2655 2 2662 ND3 $T=910780 326480 1 180 $X=908300 $Y=326100
X971 2709 1 2687 2663 2 2699 ND3 $T=928140 286160 0 180 $X=925660 $Y=280740
X972 2701 1 2704 2652 2 2710 ND3 $T=926900 306320 0 0 $X=926900 $Y=305940
X973 2722 1 2713 2650 2 2717 ND3 $T=930000 296240 1 0 $X=930000 $Y=290820
X974 566 1 2738 2651 2 2744 ND3 $T=947980 266000 0 0 $X=947980 $Y=265620
X975 2775 1 2770 2639 2 2766 ND3 $T=971540 306320 0 180 $X=969060 $Y=300900
X976 2768 1 2769 2624 2 2785 ND3 $T=971540 316400 0 0 $X=971540 $Y=316020
X977 2778 1 2756 2614 2 2787 ND3 $T=974020 346640 1 0 $X=974020 $Y=341220
X978 2824 1 2823 2803 2 2820 ND3 $T=998200 316400 1 180 $X=995720 $Y=316020
X979 2863 1 2862 2819 2 2835 ND3 $T=1016180 276080 1 180 $X=1013700 $Y=275700
X980 2877 1 2865 2801 2 2839 ND3 $T=1017420 266000 1 180 $X=1014940 $Y=265620
X981 2871 1 2869 2825 2 2856 ND3 $T=1018660 346640 0 180 $X=1016180 $Y=341220
X982 2873 1 2870 2813 2 2867 ND3 $T=1019280 316400 0 180 $X=1016800 $Y=310980
X983 2881 1 2872 2815 2 2853 ND3 $T=1019900 296240 1 180 $X=1017420 $Y=295860
X984 2889 1 2879 2821 2 2876 ND3 $T=1023000 286160 1 180 $X=1020520 $Y=285780
X985 2886 1 2882 2816 2 2843 ND3 $T=1024240 336560 0 180 $X=1021760 $Y=331140
X986 720 2 722 730 1 NR2 $T=252960 296240 0 0 $X=252960 $Y=295860
X987 720 2 743 750 1 NR2 $T=261020 286160 0 0 $X=261020 $Y=285780
X988 720 2 734 759 1 NR2 $T=265360 276080 0 0 $X=265360 $Y=275700
X989 731 2 26 730 1 NR2 $T=268460 276080 1 0 $X=268460 $Y=270660
X990 720 2 782 791 1 NR2 $T=275280 286160 0 0 $X=275280 $Y=285780
X991 30 2 781 33 1 NR2 $T=279620 326480 1 0 $X=279620 $Y=321060
X992 30 2 767 38 1 NR2 $T=282100 306320 1 0 $X=282100 $Y=300900
X993 30 2 801 36 1 NR2 $T=282100 316400 1 0 $X=282100 $Y=310980
X994 30 2 769 37 1 NR2 $T=282100 326480 0 0 $X=282100 $Y=326100
X995 30 2 802 41 1 NR2 $T=282100 346640 0 0 $X=282100 $Y=346260
X996 30 2 788 43 1 NR2 $T=283340 316400 0 0 $X=283340 $Y=316020
X997 30 2 807 54 1 NR2 $T=283340 336560 1 0 $X=283340 $Y=331140
X998 30 2 795 44 1 NR2 $T=283340 356720 1 0 $X=283340 $Y=351300
X999 30 2 797 39 1 NR2 $T=283960 326480 1 0 $X=283960 $Y=321060
X1000 30 2 789 40 1 NR2 $T=285200 306320 0 0 $X=285200 $Y=305940
X1001 30 2 798 46 1 NR2 $T=285200 346640 1 0 $X=285200 $Y=341220
X1002 30 2 796 42 1 NR2 $T=285200 356720 0 0 $X=285200 $Y=356340
X1003 45 2 816 40 1 NR2 $T=288300 316400 0 180 $X=286440 $Y=310980
X1004 45 2 815 33 1 NR2 $T=288300 326480 1 180 $X=286440 $Y=326100
X1005 45 2 809 41 1 NR2 $T=288300 346640 1 180 $X=286440 $Y=346260
X1006 30 2 780 50 1 NR2 $T=287060 306320 1 0 $X=287060 $Y=300900
X1007 810 2 819 813 1 NR2 $T=289540 286160 0 180 $X=287680 $Y=280740
X1008 30 2 772 52 1 NR2 $T=287680 316400 0 0 $X=287680 $Y=316020
X1009 45 2 821 39 1 NR2 $T=287680 326480 1 0 $X=287680 $Y=321060
X1010 45 2 820 37 1 NR2 $T=289540 336560 1 180 $X=287680 $Y=336180
X1011 814 2 813 817 1 NR2 $T=288300 286160 0 0 $X=288300 $Y=285780
X1012 30 2 790 53 1 NR2 $T=288300 356720 1 0 $X=288300 $Y=351300
X1013 45 2 826 50 1 NR2 $T=291400 306320 1 180 $X=289540 $Y=305940
X1014 45 2 818 46 1 NR2 $T=289540 346640 1 0 $X=289540 $Y=341220
X1015 45 2 832 53 1 NR2 $T=290160 356720 0 0 $X=290160 $Y=356340
X1016 45 2 823 38 1 NR2 $T=292640 306320 0 180 $X=290780 $Y=300900
X1017 45 2 824 54 1 NR2 $T=291400 336560 0 0 $X=291400 $Y=336180
X1018 45 2 833 43 1 NR2 $T=292020 316400 0 0 $X=292020 $Y=316020
X1019 45 2 834 52 1 NR2 $T=292020 326480 1 0 $X=292020 $Y=321060
X1020 66 2 888 859 1 NR2 $T=310620 286160 0 180 $X=308760 $Y=280740
X1021 66 2 893 863 1 NR2 $T=315580 296240 0 180 $X=313720 $Y=290820
X1022 66 2 911 891 1 NR2 $T=316200 296240 1 180 $X=314340 $Y=295860
X1023 66 2 896 899 1 NR2 $T=314340 306320 1 0 $X=314340 $Y=300900
X1024 699 2 1009 1035 1 NR2 $T=348440 346640 1 0 $X=348440 $Y=341220
X1025 103 2 1061 36 1 NR2 $T=359600 306320 1 180 $X=357740 $Y=305940
X1026 103 2 1062 33 1 NR2 $T=359600 326480 0 180 $X=357740 $Y=321060
X1027 103 2 1071 52 1 NR2 $T=360840 316400 0 180 $X=358980 $Y=310980
X1028 103 2 1070 50 1 NR2 $T=359600 296240 1 0 $X=359600 $Y=290820
X1029 103 2 1069 40 1 NR2 $T=359600 306320 1 0 $X=359600 $Y=300900
X1030 103 2 1066 37 1 NR2 $T=362700 326480 1 180 $X=360840 $Y=326100
X1031 103 2 1074 43 1 NR2 $T=362700 316400 1 0 $X=362700 $Y=310980
X1032 103 2 1081 39 1 NR2 $T=362700 316400 0 0 $X=362700 $Y=316020
X1033 103 2 1087 54 1 NR2 $T=364560 326480 1 180 $X=362700 $Y=326100
X1034 103 2 1084 38 1 NR2 $T=365800 296240 1 180 $X=363940 $Y=295860
X1035 103 2 1082 46 1 NR2 $T=366420 336560 0 180 $X=364560 $Y=331140
X1036 103 2 1098 53 1 NR2 $T=367660 346640 1 180 $X=365800 $Y=346260
X1037 112 2 1093 103 1 NR2 $T=366420 356720 1 0 $X=366420 $Y=351300
X1038 103 2 1091 41 1 NR2 $T=368280 346640 1 0 $X=368280 $Y=341220
X1039 103 2 1116 42 1 NR2 $T=373240 356720 0 180 $X=371380 $Y=351300
X1040 103 2 1107 44 1 NR2 $T=372620 356720 0 0 $X=372620 $Y=356340
X1041 1101 2 117 1120 1 NR2 $T=374480 276080 1 0 $X=374480 $Y=270660
X1042 119 2 1147 1097 1 NR2 $T=381920 286160 0 180 $X=380060 $Y=280740
X1043 119 2 1162 1120 1 NR2 $T=390600 276080 1 180 $X=388740 $Y=275700
X1044 119 2 1180 1153 1 NR2 $T=398660 276080 1 180 $X=396800 $Y=275700
X1045 119 2 1176 1094 1 NR2 $T=398040 286160 1 0 $X=398040 $Y=280740
X1046 1290 2 1283 1085 1 NR2 $T=424700 276080 0 180 $X=422840 $Y=270660
X1047 1246 2 1328 1261 1 NR2 $T=429660 326480 1 0 $X=429660 $Y=321060
X1048 1231 2 1351 1282 1 NR2 $T=433380 336560 1 0 $X=433380 $Y=331140
X1049 1255 2 1387 157 1 NR2 $T=443300 356720 1 0 $X=443300 $Y=351300
X1050 184 2 1413 38 1 NR2 $T=461280 296240 0 0 $X=461280 $Y=295860
X1051 184 2 1412 40 1 NR2 $T=461280 306320 1 0 $X=461280 $Y=300900
X1052 184 2 1415 54 1 NR2 $T=465000 336560 1 180 $X=463140 $Y=336180
X1053 184 2 1418 33 1 NR2 $T=466240 326480 1 180 $X=464380 $Y=326100
X1054 184 2 1421 46 1 NR2 $T=464380 346640 1 0 $X=464380 $Y=341220
X1055 184 2 1424 41 1 NR2 $T=464380 356720 1 0 $X=464380 $Y=351300
X1056 184 2 1417 50 1 NR2 $T=465000 296240 1 0 $X=465000 $Y=290820
X1057 184 2 1423 36 1 NR2 $T=465000 306320 1 0 $X=465000 $Y=300900
X1058 184 2 1419 43 1 NR2 $T=465000 316400 1 0 $X=465000 $Y=310980
X1059 184 2 1422 52 1 NR2 $T=465000 316400 0 0 $X=465000 $Y=316020
X1060 184 2 1427 37 1 NR2 $T=466240 336560 1 0 $X=466240 $Y=331140
X1061 196 2 1449 201 1 NR2 $T=473060 276080 1 0 $X=473060 $Y=270660
X1062 184 2 1434 39 1 NR2 $T=474920 316400 0 0 $X=474920 $Y=316020
X1063 196 2 1461 206 1 NR2 $T=478640 266000 0 0 $X=478640 $Y=265620
X1064 196 2 1481 1436 1 NR2 $T=485460 286160 0 180 $X=483600 $Y=280740
X1065 196 2 1483 1482 1 NR2 $T=491040 266000 1 180 $X=489180 $Y=265620
X1066 221 2 208 184 1 NR2 $T=499100 356720 1 180 $X=497240 $Y=356340
X1067 230 2 1552 50 1 NR2 $T=510260 296240 1 180 $X=508400 $Y=295860
X1068 230 2 1560 38 1 NR2 $T=512120 306320 0 180 $X=510260 $Y=300900
X1069 230 2 1558 39 1 NR2 $T=512120 326480 1 180 $X=510260 $Y=326100
X1070 233 2 1570 37 1 NR2 $T=513980 336560 0 180 $X=512120 $Y=331140
X1071 233 2 1568 54 1 NR2 $T=513980 336560 1 180 $X=512120 $Y=336180
X1072 230 2 1569 50 1 NR2 $T=514600 296240 1 180 $X=512740 $Y=295860
X1073 230 2 1582 40 1 NR2 $T=515220 306320 1 0 $X=515220 $Y=300900
X1074 230 2 1583 36 1 NR2 $T=515220 306320 0 0 $X=515220 $Y=305940
X1075 230 2 1589 43 1 NR2 $T=515840 316400 1 0 $X=515840 $Y=310980
X1076 230 2 1587 52 1 NR2 $T=515840 326480 1 0 $X=515840 $Y=321060
X1077 233 2 1590 33 1 NR2 $T=515840 336560 0 0 $X=515840 $Y=336180
X1078 233 2 1593 46 1 NR2 $T=515840 346640 1 0 $X=515840 $Y=341220
X1079 233 2 1599 41 1 NR2 $T=518940 346640 0 0 $X=518940 $Y=346260
X1080 233 2 1602 53 1 NR2 $T=518940 356720 1 0 $X=518940 $Y=351300
X1081 1632 2 1634 1588 1 NR2 $T=530720 276080 0 180 $X=528860 $Y=270660
X1082 246 2 1647 1607 1 NR2 $T=535060 276080 1 180 $X=533200 $Y=275700
X1083 246 2 1644 1632 1 NR2 $T=535060 286160 1 180 $X=533200 $Y=285780
X1084 246 2 1659 1633 1 NR2 $T=538780 286160 1 180 $X=536920 $Y=285780
X1085 246 2 1661 1621 1 NR2 $T=539400 296240 0 180 $X=537540 $Y=290820
X1086 251 2 1808 40 1 NR2 $T=573500 306320 0 180 $X=571640 $Y=300900
X1087 251 2 1817 33 1 NR2 $T=580320 326480 0 180 $X=578460 $Y=321060
X1088 251 2 1818 37 1 NR2 $T=580320 326480 1 180 $X=578460 $Y=326100
X1089 251 2 1815 36 1 NR2 $T=582800 306320 1 180 $X=580940 $Y=305940
X1090 251 2 1825 39 1 NR2 $T=582800 316400 1 180 $X=580940 $Y=316020
X1091 251 2 1820 43 1 NR2 $T=582800 306320 0 0 $X=582800 $Y=305940
X1092 251 2 1846 52 1 NR2 $T=582800 316400 1 0 $X=582800 $Y=310980
X1093 251 2 1832 41 1 NR2 $T=584660 336560 1 180 $X=582800 $Y=336180
X1094 251 2 1845 54 1 NR2 $T=585900 326480 1 180 $X=584040 $Y=326100
X1095 251 2 1843 297 1 NR2 $T=587140 346640 1 180 $X=585280 $Y=346260
X1096 251 2 1850 53 1 NR2 $T=587140 346640 1 0 $X=587140 $Y=341220
X1097 221 2 1844 251 1 NR2 $T=587140 356720 1 0 $X=587140 $Y=351300
X1098 251 2 1849 46 1 NR2 $T=588380 336560 1 0 $X=588380 $Y=331140
X1099 251 2 1852 44 1 NR2 $T=590860 356720 1 0 $X=590860 $Y=351300
X1100 1858 2 1879 1867 1 NR2 $T=598300 276080 0 180 $X=596440 $Y=270660
X1101 1858 2 1873 1834 1 NR2 $T=598300 276080 1 180 $X=596440 $Y=275700
X1102 1858 2 1888 1855 1 NR2 $T=601400 276080 0 180 $X=599540 $Y=270660
X1103 1837 2 317 1897 1 NR2 $T=602640 266000 0 0 $X=602640 $Y=265620
X1104 1858 2 1905 1897 1 NR2 $T=605120 276080 1 180 $X=603260 $Y=275700
X1105 2018 2 2020 2028 1 NR2 $T=637980 296240 0 0 $X=637980 $Y=295860
X1106 1969 2 2156 2165 1 NR2 $T=673940 306320 0 0 $X=673940 $Y=305940
X1107 2284 2 2285 2287 1 NR2 $T=742140 306320 0 0 $X=742140 $Y=305940
X1108 2294 2 2290 2287 1 NR2 $T=745860 306320 1 180 $X=744000 $Y=305940
X1109 2284 2 2297 2282 1 NR2 $T=744000 316400 1 0 $X=744000 $Y=310980
X1110 2294 2 2291 2282 1 NR2 $T=745860 316400 1 180 $X=744000 $Y=316020
X1111 2312 2 2307 2287 1 NR2 $T=749580 316400 0 180 $X=747720 $Y=310980
X1112 2308 2 2309 2287 1 NR2 $T=753300 306320 0 180 $X=751440 $Y=300900
X1113 2308 2 2328 2282 1 NR2 $T=761360 316400 0 180 $X=759500 $Y=310980
X1114 2312 2 2331 2282 1 NR2 $T=761980 316400 1 180 $X=760120 $Y=316020
X1115 2417 2 2392 2410 1 NR2 $T=795460 336560 0 180 $X=793600 $Y=331140
X1116 2303 2 2440 2308 1 NR2 $T=796080 316400 0 0 $X=796080 $Y=316020
X1117 2410 2 2387 2421 1 NR2 $T=796700 336560 0 0 $X=796700 $Y=336180
X1118 2425 2 2391 2421 1 NR2 $T=799180 326480 1 0 $X=799180 $Y=321060
X1119 2304 2 2434 2308 1 NR2 $T=804140 316400 0 180 $X=802280 $Y=310980
X1120 2417 2 2405 2425 1 NR2 $T=804760 326480 1 180 $X=802900 $Y=326100
X1121 2386 2 2435 439 1 NR2 $T=804140 326480 1 0 $X=804140 $Y=321060
X1122 2408 2 2438 439 1 NR2 $T=804760 326480 0 0 $X=804760 $Y=326100
X1123 2304 2 2465 2294 1 NR2 $T=819020 316400 0 180 $X=817160 $Y=310980
X1124 2303 2 448 2312 1 NR2 $T=819640 316400 1 180 $X=817780 $Y=316020
X1125 2303 2 453 2294 1 NR2 $T=819640 326480 0 180 $X=817780 $Y=321060
X1126 2464 2 2462 451 1 NR2 $T=819640 356720 0 180 $X=817780 $Y=351300
X1127 2304 2 2466 2312 1 NR2 $T=821500 316400 1 180 $X=819640 $Y=316020
X1128 2304 2 460 2284 1 NR2 $T=820880 316400 1 0 $X=820880 $Y=310980
X1129 2284 2 2475 2303 1 NR2 $T=823360 316400 1 180 $X=821500 $Y=316020
X1130 2491 2 2485 2496 1 NR2 $T=830800 276080 1 0 $X=830800 $Y=270660
X1131 2498 2 2494 2487 1 NR2 $T=833900 296240 0 180 $X=832040 $Y=290820
X1132 471 2 2513 473 1 NR2 $T=841340 356720 0 0 $X=841340 $Y=356340
X1133 2532 2 2521 2533 1 NR2 $T=849400 306320 0 0 $X=849400 $Y=305940
X1134 2514 2 2541 2545 1 NR2 $T=852500 326480 0 0 $X=852500 $Y=326100
X1135 2554 2 2562 2561 1 NR2 $T=863040 306320 0 0 $X=863040 $Y=305940
X1136 2576 2 488 2584 1 NR2 $T=872340 356720 0 0 $X=872340 $Y=356340
X1137 2608 2 2589 2598 1 NR2 $T=889080 336560 0 180 $X=887220 $Y=331140
X1138 2599 2 2609 2601 1 NR2 $T=888460 296240 0 0 $X=888460 $Y=295860
X1139 2692 2 2637 2695 1 NR2 $T=921320 336560 0 0 $X=921320 $Y=336180
X1140 2692 2 2591 2700 1 NR2 $T=924420 346640 0 0 $X=924420 $Y=346260
X1141 2692 2 2581 2696 1 NR2 $T=928140 346640 1 0 $X=928140 $Y=341220
X1142 2692 2 557 2719 1 NR2 $T=933720 346640 0 0 $X=933720 $Y=346260
X1143 558 2 2709 2721 1 NR2 $T=934340 276080 1 0 $X=934340 $Y=270660
X1144 2700 2 561 2683 1 NR2 $T=937440 346640 0 0 $X=937440 $Y=346260
X1145 2723 2 2722 2726 1 NR2 $T=938060 296240 1 0 $X=938060 $Y=290820
X1146 2683 2 565 2696 1 NR2 $T=942400 346640 0 0 $X=942400 $Y=346260
X1147 2730 2 2701 2736 1 NR2 $T=944880 316400 1 0 $X=944880 $Y=310980
X1148 2735 2 2668 2737 1 NR2 $T=944880 326480 0 0 $X=944880 $Y=326100
X1149 2683 2 2657 2719 1 NR2 $T=949840 346640 1 0 $X=949840 $Y=341220
X1150 2683 2 2714 2695 1 NR2 $T=957900 346640 1 0 $X=957900 $Y=341220
X1151 2761 2 2768 2764 1 NR2 $T=967200 316400 0 0 $X=967200 $Y=316020
X1152 2763 2 2778 2774 1 NR2 $T=969680 356720 1 0 $X=969680 $Y=351300
X1153 2675 2 2773 580 1 NR2 $T=970300 336560 0 0 $X=970300 $Y=336180
X1154 2776 2 2775 2791 1 NR2 $T=975260 306320 1 0 $X=975260 $Y=300900
X1155 2705 2 2771 2685 1 NR2 $T=977740 336560 1 0 $X=977740 $Y=331140
X1156 2795 2 2782 2685 1 NR2 $T=985180 336560 1 180 $X=983320 $Y=336180
X1157 2800 2 2777 2705 1 NR2 $T=987040 336560 0 180 $X=985180 $Y=331140
X1158 2800 2 2792 2795 1 NR2 $T=985180 336560 0 0 $X=985180 $Y=336180
X1159 2695 2 2760 2693 1 NR2 $T=989520 346640 0 0 $X=989520 $Y=346260
X1160 2695 2 594 541 1 NR2 $T=995720 356720 0 0 $X=995720 $Y=356340
X1161 2826 2 2786 580 1 NR2 $T=998820 336560 1 180 $X=996960 $Y=336180
X1162 2719 2 598 2693 1 NR2 $T=1006880 356720 0 0 $X=1006880 $Y=356340
X1163 2719 2 2832 541 1 NR2 $T=1011220 356720 1 0 $X=1011220 $Y=351300
X1164 2700 2 2864 2693 1 NR2 $T=1030440 346640 0 0 $X=1030440 $Y=346260
X1165 2700 2 2860 541 1 NR2 $T=1031060 356720 0 0 $X=1031060 $Y=356340
X1166 2696 2 2885 2693 1 NR2 $T=1036640 346640 1 180 $X=1034780 $Y=346260
X1167 2696 2 2802 541 1 NR2 $T=1042220 356720 1 0 $X=1042220 $Y=351300
X1168 669 700 684 1 2 ND2 $T=239320 336560 1 0 $X=239320 $Y=331140
X1169 683 695 672 1 2 ND2 $T=243040 336560 1 180 $X=241180 $Y=336180
X1170 674 697 4 1 2 ND2 $T=243040 276080 0 0 $X=243040 $Y=275700
X1171 692 710 9 1 2 ND2 $T=248000 276080 1 180 $X=246140 $Y=275700
X1172 15 731 8 1 2 ND2 $T=254820 276080 1 180 $X=252960 $Y=275700
X1173 784 785 799 1 2 ND2 $T=275900 286160 1 0 $X=275900 $Y=280740
X1174 792 32 805 1 2 ND2 $T=282100 266000 0 180 $X=280240 $Y=260580
X1175 836 863 848 1 2 ND2 $T=302560 296240 0 180 $X=300700 $Y=290820
X1176 75 909 23 1 2 ND2 $T=320540 266000 0 180 $X=318680 $Y=260580
X1177 920 955 696 1 2 ND2 $T=332320 266000 1 180 $X=330460 $Y=265620
X1178 969 963 794 1 2 ND2 $T=335420 286160 0 180 $X=333560 $Y=280740
X1179 965 964 956 1 2 ND2 $T=335420 286160 1 180 $X=333560 $Y=285780
X1180 979 978 698 1 2 ND2 $T=337900 296240 1 180 $X=336040 $Y=295860
X1181 91 90 89 1 2 ND2 $T=338520 266000 0 180 $X=336660 $Y=260580
X1182 987 977 970 1 2 ND2 $T=338520 276080 1 180 $X=336660 $Y=275700
X1183 97 96 95 1 2 ND2 $T=341620 266000 0 180 $X=339760 $Y=260580
X1184 983 1000 973 1 2 ND2 $T=342240 276080 1 180 $X=340380 $Y=275700
X1185 990 1001 1006 1 2 ND2 $T=342240 336560 0 0 $X=342240 $Y=336180
X1186 1015 1010 688 1 2 ND2 $T=346580 286160 1 180 $X=344720 $Y=285780
X1187 989 1017 970 1 2 ND2 $T=347200 276080 1 180 $X=345340 $Y=275700
X1188 995 1011 691 1 2 ND2 $T=346580 296240 1 0 $X=346580 $Y=290820
X1189 985 1031 712 1 2 ND2 $T=349060 326480 0 180 $X=347200 $Y=321060
X1190 1016 1026 1029 1 2 ND2 $T=347200 336560 0 0 $X=347200 $Y=336180
X1191 994 1028 98 1 2 ND2 $T=349060 356720 0 180 $X=347200 $Y=351300
X1192 997 1024 708 1 2 ND2 $T=349060 316400 1 0 $X=349060 $Y=310980
X1193 1021 1038 708 1 2 ND2 $T=351540 306320 1 180 $X=349680 $Y=305940
X1194 1039 1043 712 1 2 ND2 $T=351540 326480 0 180 $X=349680 $Y=321060
X1195 1052 1060 1023 1 2 ND2 $T=351540 356720 1 180 $X=349680 $Y=356340
X1196 1036 1041 98 1 2 ND2 $T=352160 356720 0 180 $X=350300 $Y=351300
X1197 1008 1037 702 1 2 ND2 $T=351540 326480 0 0 $X=351540 $Y=326100
X1198 997 1030 1021 1 2 ND2 $T=355880 306320 1 180 $X=354020 $Y=305940
X1199 1039 1051 985 1 2 ND2 $T=355880 326480 0 180 $X=354020 $Y=321060
X1200 1112 1111 1122 1 2 ND2 $T=376340 266000 1 0 $X=376340 $Y=260580
X1201 1201 1210 145 1 2 ND2 $T=406100 266000 0 0 $X=406100 $Y=265620
X1202 1208 1213 1159 1 2 ND2 $T=406100 336560 1 0 $X=406100 $Y=331140
X1203 1207 1228 1169 1 2 ND2 $T=411060 326480 0 180 $X=409200 $Y=321060
X1204 1301 1295 1254 1 2 ND2 $T=418500 296240 1 180 $X=416640 $Y=295860
X1205 1244 1259 1159 1 2 ND2 $T=418500 326480 0 180 $X=416640 $Y=321060
X1206 1262 1260 1231 1 2 ND2 $T=418500 336560 0 0 $X=418500 $Y=336180
X1207 1275 1258 1266 1 2 ND2 $T=422220 316400 0 180 $X=420360 $Y=310980
X1208 1271 1267 1277 1 2 ND2 $T=420360 336560 0 0 $X=420360 $Y=336180
X1209 1304 1292 1254 1 2 ND2 $T=423460 296240 0 180 $X=421600 $Y=290820
X1210 1282 1277 1257 1 2 ND2 $T=423460 336560 0 180 $X=421600 $Y=331140
X1211 1194 1294 113 1 2 ND2 $T=422220 266000 1 0 $X=422220 $Y=260580
X1212 1005 1289 1290 1 2 ND2 $T=422220 276080 0 0 $X=422220 $Y=275700
X1213 1269 1281 1279 1 2 ND2 $T=424080 316400 1 180 $X=422220 $Y=316020
X1214 1297 155 1294 1 2 ND2 $T=425940 266000 0 180 $X=424080 $Y=260580
X1215 1264 1284 1241 1 2 ND2 $T=425320 286160 1 0 $X=425320 $Y=280740
X1216 1299 1253 1281 1 2 ND2 $T=425320 316400 0 0 $X=425320 $Y=316020
X1217 1234 1297 145 1 2 ND2 $T=425940 266000 1 0 $X=425940 $Y=260580
X1218 1305 1321 1307 1 2 ND2 $T=428420 306320 0 180 $X=426560 $Y=300900
X1219 1304 1280 1301 1 2 ND2 $T=427180 296240 0 0 $X=427180 $Y=295860
X1220 1311 1319 1273 1 2 ND2 $T=429040 346640 0 180 $X=427180 $Y=341220
X1221 1326 1317 1246 1 2 ND2 $T=430280 326480 1 180 $X=428420 $Y=326100
X1222 1313 1322 1327 1 2 ND2 $T=428420 356720 1 0 $X=428420 $Y=351300
X1223 1305 1316 1268 1 2 ND2 $T=429040 306320 0 0 $X=429040 $Y=305940
X1224 1308 1349 1327 1 2 ND2 $T=432140 346640 0 180 $X=430280 $Y=341220
X1225 1322 1341 1337 1 2 ND2 $T=430280 356720 1 0 $X=430280 $Y=351300
X1226 1331 1315 1334 1 2 ND2 $T=431520 276080 0 0 $X=431520 $Y=275700
X1227 1336 1333 1287 1 2 ND2 $T=432140 336560 0 0 $X=432140 $Y=336180
X1228 1346 1355 1341 1 2 ND2 $T=434000 356720 0 180 $X=432140 $Y=351300
X1229 160 1343 1278 1 2 ND2 $T=437720 266000 1 180 $X=435860 $Y=265620
X1230 1058 1358 1356 1 2 ND2 $T=437720 296240 0 180 $X=435860 $Y=290820
X1231 164 1312 1255 1 2 ND2 $T=438340 346640 1 180 $X=436480 $Y=346260
X1232 1285 1371 1356 1 2 ND2 $T=439580 296240 1 180 $X=437720 $Y=295860
X1233 1374 1359 1270 1 2 ND2 $T=438960 286160 1 0 $X=438960 $Y=280740
X1234 158 165 166 1 2 ND2 $T=441440 266000 1 0 $X=441440 $Y=260580
X1235 1338 1384 1240 1 2 ND2 $T=443920 276080 1 180 $X=442060 $Y=275700
X1236 1285 1369 1058 1 2 ND2 $T=442680 296240 0 0 $X=442680 $Y=295860
X1237 163 1378 1377 1 2 ND2 $T=443300 266000 1 0 $X=443300 $Y=260580
X1238 1063 1394 1382 1 2 ND2 $T=447020 336560 0 180 $X=445160 $Y=331140
X1239 1398 1397 1063 1 2 ND2 $T=450120 336560 1 180 $X=448260 $Y=336180
X1240 999 1383 1376 1 2 ND2 $T=448260 346640 1 0 $X=448260 $Y=341220
X1241 1399 1388 1376 1 2 ND2 $T=450120 346640 1 180 $X=448260 $Y=346260
X1242 1398 1404 1382 1 2 ND2 $T=450740 336560 0 180 $X=448880 $Y=331140
X1243 1417 1426 1414 1 2 ND2 $T=466860 296240 1 0 $X=466860 $Y=290820
X1244 1432 1429 1426 1 2 ND2 $T=470580 296240 0 180 $X=468720 $Y=290820
X1245 1413 1432 195 1 2 ND2 $T=470580 296240 1 0 $X=470580 $Y=290820
X1246 1469 1473 196 1 2 ND2 $T=484220 286160 0 0 $X=484220 $Y=285780
X1247 1478 214 1473 1 2 ND2 $T=487940 286160 1 180 $X=486080 $Y=285780
X1248 1463 1478 215 1 2 ND2 $T=487940 286160 0 0 $X=487940 $Y=285780
X1249 1552 1562 232 1 2 ND2 $T=512120 286160 0 0 $X=512120 $Y=285780
X1250 1577 235 1585 1 2 ND2 $T=516460 266000 1 0 $X=516460 $Y=260580
X1251 1575 1579 237 1 2 ND2 $T=517080 266000 0 0 $X=517080 $Y=265620
X1252 1549 1577 238 1 2 ND2 $T=518320 266000 1 0 $X=518320 $Y=260580
X1253 1591 243 1579 1 2 ND2 $T=518940 266000 0 0 $X=518940 $Y=265620
X1254 1596 1585 237 1 2 ND2 $T=522040 266000 0 180 $X=520180 $Y=260580
X1255 1597 1591 238 1 2 ND2 $T=522660 266000 0 0 $X=522660 $Y=265620
X1256 267 271 266 1 2 ND2 $T=550560 266000 0 180 $X=548700 $Y=260580
X1257 269 268 225 1 2 ND2 $T=551180 266000 1 180 $X=549320 $Y=265620
X1258 270 1700 273 1 2 ND2 $T=551180 266000 0 0 $X=551180 $Y=265620
X1259 268 274 267 1 2 ND2 $T=552420 266000 1 0 $X=552420 $Y=260580
X1260 1732 1733 1727 1 2 ND2 $T=559240 296240 0 180 $X=557380 $Y=290820
X1261 1729 1737 1713 1 2 ND2 $T=559860 286160 1 180 $X=558000 $Y=285780
X1262 1734 1756 1551 1 2 ND2 $T=559860 336560 0 0 $X=559860 $Y=336180
X1263 1721 1742 1710 1 2 ND2 $T=560480 276080 1 0 $X=560480 $Y=270660
X1264 1750 1753 1743 1 2 ND2 $T=562340 296240 1 180 $X=560480 $Y=295860
X1265 1735 1740 1754 1 2 ND2 $T=561100 286160 1 0 $X=561100 $Y=280740
X1266 1770 1764 1763 1 2 ND2 $T=566060 346640 1 180 $X=564200 $Y=346260
X1267 1739 1786 1555 1 2 ND2 $T=569160 346640 0 180 $X=567300 $Y=341220
X1268 1757 1781 1745 1 2 ND2 $T=567920 306320 0 0 $X=567920 $Y=305940
X1269 1766 1782 1751 1 2 ND2 $T=568540 316400 1 0 $X=568540 $Y=310980
X1270 1747 1798 1574 1 2 ND2 $T=574120 346640 1 180 $X=572260 $Y=346260
X1271 1811 1821 1822 1 2 ND2 $T=582180 286160 0 0 $X=582180 $Y=285780
X1272 289 298 287 1 2 ND2 $T=585900 266000 0 180 $X=584040 $Y=260580
X1273 312 1876 1848 1 2 ND2 $T=597680 266000 1 0 $X=597680 $Y=260580
X1274 328 327 288 1 2 ND2 $T=613800 356720 1 180 $X=611940 $Y=356340
X1275 1839 1983 337 1 2 ND2 $T=628060 356720 1 0 $X=628060 $Y=351300
X1276 1812 2003 2023 1 2 ND2 $T=635500 306320 1 0 $X=635500 $Y=300900
X1277 2002 2016 1977 1 2 ND2 $T=638600 286160 0 180 $X=636740 $Y=280740
X1278 1816 2033 1995 1 2 ND2 $T=639840 316400 1 180 $X=637980 $Y=316020
X1279 1805 2027 2041 1 2 ND2 $T=638600 356720 1 0 $X=638600 $Y=351300
X1280 2038 2056 2042 1 2 ND2 $T=641080 326480 1 0 $X=641080 $Y=321060
X1281 2036 2057 2018 1 2 ND2 $T=644800 296240 1 180 $X=642940 $Y=295860
X1282 2060 348 347 1 2 ND2 $T=646040 266000 0 180 $X=644180 $Y=260580
X1283 2061 2051 1986 1 2 ND2 $T=646040 276080 0 180 $X=644180 $Y=270660
X1284 2072 2055 2054 1 2 ND2 $T=646040 286160 1 180 $X=644180 $Y=285780
X1285 2047 2062 2066 1 2 ND2 $T=644800 326480 1 0 $X=644800 $Y=321060
X1286 2075 2045 2038 1 2 ND2 $T=647280 336560 0 180 $X=645420 $Y=331140
X1287 2065 2079 2066 1 2 ND2 $T=646040 316400 1 0 $X=646040 $Y=310980
X1288 2028 2074 2069 1 2 ND2 $T=648520 296240 0 180 $X=646660 $Y=290820
X1289 2071 2059 1999 1 2 ND2 $T=646660 326480 1 0 $X=646660 $Y=321060
X1290 2085 2075 2042 1 2 ND2 $T=649760 336560 0 180 $X=647900 $Y=331140
X1291 2054 2090 2074 1 2 ND2 $T=648520 296240 1 0 $X=648520 $Y=290820
X1292 2080 2087 2063 1 2 ND2 $T=651000 346640 0 180 $X=649140 $Y=341220
X1293 2025 2100 2076 1 2 ND2 $T=659060 286160 1 0 $X=659060 $Y=280740
X1294 2105 2101 2097 1 2 ND2 $T=659060 296240 0 0 $X=659060 $Y=295860
X1295 1841 2107 2091 1 2 ND2 $T=659060 326480 0 0 $X=659060 $Y=326100
X1296 2111 2117 2012 1 2 ND2 $T=662780 296240 1 180 $X=660920 $Y=295860
X1297 2116 2125 2024 1 2 ND2 $T=664020 286160 0 180 $X=662160 $Y=280740
X1298 2118 2119 2091 1 2 ND2 $T=662160 326480 1 0 $X=662160 $Y=321060
X1299 2118 2121 1841 1 2 ND2 $T=662160 326480 0 0 $X=662160 $Y=326100
X1300 2108 2122 1802 1 2 ND2 $T=664020 336560 1 180 $X=662160 $Y=336180
X1301 2117 2105 2132 1 2 ND2 $T=663400 296240 0 0 $X=663400 $Y=295860
X1302 2109 2123 2077 1 2 ND2 $T=664020 266000 0 0 $X=664020 $Y=265620
X1303 2133 2129 2120 1 2 ND2 $T=665880 306320 1 180 $X=664020 $Y=305940
X1304 354 2127 355 1 2 ND2 $T=664640 266000 1 0 $X=664640 $Y=260580
X1305 2132 2110 2097 1 2 ND2 $T=665260 296240 0 0 $X=665260 $Y=295860
X1306 2129 1995 2134 1 2 ND2 $T=667120 316400 0 180 $X=665260 $Y=310980
X1307 2128 2133 2143 1 2 ND2 $T=665880 306320 0 0 $X=665880 $Y=305940
X1308 356 2141 355 1 2 ND2 $T=668360 266000 0 180 $X=666500 $Y=260580
X1309 2143 2135 2120 1 2 ND2 $T=668360 306320 1 0 $X=668360 $Y=300900
X1310 1813 2144 2130 1 2 ND2 $T=668360 316400 1 0 $X=668360 $Y=310980
X1311 2142 2157 2148 1 2 ND2 $T=671460 276080 0 180 $X=669600 $Y=270660
X1312 2037 2146 2130 1 2 ND2 $T=670220 316400 1 0 $X=670220 $Y=310980
X1313 2077 2160 1780 1 2 ND2 $T=673320 276080 1 180 $X=671460 $Y=275700
X1314 1813 2149 2037 1 2 ND2 $T=673320 316400 0 0 $X=673320 $Y=316020
X1315 2137 2171 2148 1 2 ND2 $T=676420 266000 0 0 $X=676420 $Y=265620
X1316 2161 2082 2052 1 2 ND2 $T=677040 306320 1 0 $X=677040 $Y=300900
X1317 2167 2128 1969 1 2 ND2 $T=677040 306320 0 0 $X=677040 $Y=305940
X1318 2172 2173 2024 1 2 ND2 $T=680760 286160 0 180 $X=678900 $Y=280740
X1319 1830 2169 2115 1 2 ND2 $T=678900 286160 0 0 $X=678900 $Y=285780
X1320 2171 2186 2188 1 2 ND2 $T=682000 276080 1 0 $X=682000 $Y=270660
X1321 2191 2188 2182 1 2 ND2 $T=685720 276080 1 0 $X=685720 $Y=270660
X1322 2286 2282 405 1 2 ND2 $T=744000 326480 1 0 $X=744000 $Y=321060
X1323 405 2287 403 1 2 ND2 $T=746480 326480 0 0 $X=746480 $Y=326100
X1324 2301 2294 408 1 2 ND2 $T=747720 316400 0 0 $X=747720 $Y=316020
X1325 2286 2303 407 1 2 ND2 $T=749580 326480 0 180 $X=747720 $Y=321060
X1326 407 2304 403 1 2 ND2 $T=751440 326480 1 180 $X=749580 $Y=326100
X1327 2301 2284 2310 1 2 ND2 $T=750820 316400 0 0 $X=750820 $Y=316020
X1328 408 2308 410 1 2 ND2 $T=752680 326480 1 0 $X=752680 $Y=321060
X1329 2310 2312 410 1 2 ND2 $T=758880 316400 1 180 $X=757020 $Y=316020
X1330 536 2683 525 1 2 ND2 $T=917600 346640 1 180 $X=915740 $Y=346260
X1331 536 2692 2678 1 2 ND2 $T=921940 346640 1 180 $X=920080 $Y=346260
X1332 540 2693 525 1 2 ND2 $T=922560 356720 1 180 $X=920700 $Y=356340
X1333 543 2695 545 1 2 ND2 $T=922560 356720 0 0 $X=922560 $Y=356340
X1334 2697 2696 543 1 2 ND2 $T=925660 356720 0 180 $X=923800 $Y=351300
X1335 2697 2700 2698 1 2 ND2 $T=925660 356720 1 0 $X=925660 $Y=351300
X1336 2698 2719 545 1 2 ND2 $T=935580 356720 1 180 $X=933720 $Y=356340
X1337 780 784 28 2 1 ND2S $T=277760 296240 0 180 $X=275900 $Y=290820
X1338 975 976 794 2 1 ND2S $T=337280 286160 1 180 $X=335420 $Y=285780
X1339 963 987 989 2 1 ND2S $T=338520 276080 0 0 $X=338520 $Y=275700
X1340 1070 1073 108 2 1 ND2S $T=362700 286160 0 0 $X=362700 $Y=285780
X1341 1090 1078 113 2 1 ND2S $T=367040 266000 0 0 $X=367040 $Y=265620
X1342 1065 1079 105 2 1 ND2S $T=368280 286160 0 0 $X=368280 $Y=285780
X1343 1108 116 1111 2 1 ND2S $T=373860 266000 0 180 $X=372000 $Y=260580
X1344 1132 1146 1130 2 1 ND2S $T=383780 346640 1 0 $X=383780 $Y=341220
X1345 1312 1313 1308 2 1 ND2S $T=428420 356720 0 180 $X=426560 $Y=351300
X1346 1445 1447 199 2 1 ND2S $T=476780 286160 1 180 $X=474920 $Y=285780
X1347 1563 1633 236 2 1 ND2S $T=531960 286160 0 180 $X=530100 $Y=280740
X1348 1756 1759 1752 2 1 ND2S $T=563580 336560 1 180 $X=561720 $Y=336180
X1349 1650 1829 296 2 1 ND2S $T=584040 296240 0 0 $X=584040 $Y=295860
X1350 1800 1822 300 2 1 ND2S $T=585280 296240 1 0 $X=585280 $Y=290820
X1351 1876 1853 1868 2 1 ND2S $T=593340 266000 1 0 $X=593340 $Y=260580
X1352 304 1868 310 2 1 ND2S $T=595200 266000 1 0 $X=595200 $Y=260580
X1353 1823 1866 1878 2 1 ND2S $T=596440 296240 0 0 $X=596440 $Y=295860
X1354 1908 1907 1903 2 1 ND2S $T=606360 346640 0 180 $X=604500 $Y=341220
X1355 2035 2060 345 2 1 ND2S $T=644180 266000 1 180 $X=642320 $Y=265620
X1356 2046 2047 2007 2 1 ND2S $T=642320 316400 0 0 $X=642320 $Y=316020
X1357 2073 2080 2008 2 1 ND2S $T=647280 346640 0 180 $X=645420 $Y=341220
X1358 2057 2072 2074 2 1 ND2S $T=646040 286160 0 0 $X=646040 $Y=285780
X1359 2092 2085 2013 2 1 ND2S $T=651620 336560 0 180 $X=649760 $Y=331140
X1360 2678 541 540 2 1 ND2S $T=923800 356720 0 180 $X=921940 $Y=351300
X1361 1318 1085 2 1283 1 1314 AOI12HS $T=429040 276080 0 180 $X=424700 $Y=270660
X1362 1287 1336 2 1325 1 1329 AOI12HS $T=433380 336560 0 180 $X=429040 $Y=331140
X1363 1246 1326 2 1310 1 1347 AOI12HS $T=430280 326480 0 0 $X=430280 $Y=326100
X1364 1246 1261 2 1328 1 1357 AOI12HS $T=431520 326480 1 0 $X=431520 $Y=321060
X1365 1231 1282 2 1351 1 1375 AOI12HS $T=435240 336560 1 0 $X=435240 $Y=331140
X1366 1574 1747 2 1767 1 1771 AOI12HS $T=562340 356720 1 0 $X=562340 $Y=351300
X1367 2008 2014 2014 2008 2 1 2005 MAOI1 $T=639220 346640 0 180 $X=634260 $Y=341220
X1368 2013 2019 2019 2013 2 1 2010 MAOI1 $T=641080 336560 0 180 $X=636120 $Y=331140
X1369 794 975 1 976 2 983 OAI12HS $T=340380 286160 0 180 $X=336660 $Y=280740
X1370 1009 1019 1 1022 2 1003 OAI12HS $T=344720 346640 1 0 $X=344720 $Y=341220
X1371 98 1036 1 1041 2 1052 OAI12HS $T=352160 356720 1 0 $X=352160 $Y=351300
X1372 1334 1314 1 1315 2 1323 OAI12HS $T=431520 276080 1 180 $X=427800 $Y=275700
X1373 1339 1085 1 1324 2 1331 OAI12HS $T=432760 286160 0 180 $X=429040 $Y=280740
X1374 1367 157 1 1349 2 1340 OAI12HS $T=437720 346640 0 180 $X=434000 $Y=341220
X1375 1387 1386 1 1352 2 1337 OAI12HS $T=444540 346640 1 0 $X=444540 $Y=341220
X1376 1551 1738 1 1785 2 1792 OAI12HS $T=569780 336560 0 0 $X=569780 $Y=336180
X1377 1860 1862 1 1866 2 1883 OAI12HS $T=592100 296240 1 0 $X=592100 $Y=290820
X1378 2020 2032 1 2039 2 2049 OAI12HS $T=639220 296240 1 0 $X=639220 $Y=290820
X1379 2038 2010 1 2045 2 2043 OAI12HS $T=645420 336560 0 180 $X=641700 $Y=331140
X1380 2007 2046 1 2047 2 2065 OAI12HS $T=648520 326480 1 0 $X=648520 $Y=321060
X1381 2097 2099 1 2101 2 2023 OAI12HS $T=655340 296240 0 0 $X=655340 $Y=295860
X1382 2106 2136 1 2142 2 2137 OAI12HS $T=665880 276080 1 0 $X=665880 $Y=270660
X1383 2156 2155 1 2153 2 2134 OAI12HS $T=673940 306320 1 180 $X=670220 $Y=305940
X1384 2490 466 462 2489 2450 463 1 2 2464 AO222 $T=833280 356720 0 180 $X=827080 $Y=351300
X1385 2509 466 462 2505 2501 463 1 2 2491 AO222 $T=840720 276080 0 180 $X=834520 $Y=270660
X1386 2503 466 462 2506 2511 463 1 2 2514 AO222 $T=837000 336560 1 0 $X=837000 $Y=331140
X1387 2522 466 462 2517 2510 463 1 2 2498 AO222 $T=847540 296240 0 180 $X=841340 $Y=290820
X1388 2557 466 462 2551 2549 463 1 2 2532 AO222 $T=864900 296240 0 180 $X=858700 $Y=290820
X1389 2575 466 462 2568 2566 463 1 2 2554 AO222 $T=872960 286160 1 180 $X=866760 $Y=285780
X1390 2596 466 462 2600 2604 463 1 2 2599 AO222 $T=884740 286160 1 0 $X=884740 $Y=280740
X1391 2583 466 462 493 2611 463 1 2 2576 AO222 $T=885980 356720 1 0 $X=885980 $Y=351300
X1392 2618 466 462 2628 2625 463 1 2 2608 AO222 $T=897140 346640 0 180 $X=890940 $Y=341220
X1393 2712 554 556 2716 2718 559 1 2 2723 AO222 $T=932480 296240 0 0 $X=932480 $Y=295860
X1394 2715 554 556 2724 2725 559 1 2 2730 AO222 $T=935580 316400 1 0 $X=935580 $Y=310980
X1395 2711 554 556 2729 2732 559 1 2 2735 AO222 $T=941780 326480 1 0 $X=941780 $Y=321060
X1396 2748 554 556 2750 2757 559 1 2 2776 AO222 $T=957900 296240 0 0 $X=957900 $Y=295860
X1397 2751 554 556 2754 2758 559 1 2 2761 AO222 $T=959140 316400 0 0 $X=959140 $Y=316020
X1398 581 554 556 2767 2759 559 1 2 2763 AO222 $T=972780 356720 1 180 $X=966580 $Y=356340
X1399 766 748 1 2 INV2 $T=269080 296240 1 180 $X=267220 $Y=295860
X1400 748 759 1 2 INV2 $T=268460 296240 1 0 $X=268460 $Y=290820
X1401 774 777 1 2 INV2 $T=274040 266000 1 180 $X=272180 $Y=265620
X1402 806 787 1 2 INV2 $T=281480 276080 0 180 $X=279620 $Y=270660
X1403 1090 1075 1 2 INV2 $T=367040 276080 1 180 $X=365180 $Y=275700
X1404 1088 1080 1 2 INV2 $T=369520 276080 1 0 $X=369520 $Y=270660
X1405 1105 1120 1 2 INV2 $T=376960 276080 0 0 $X=376960 $Y=275700
X1406 114 1059 1 2 INV2 $T=379440 296240 0 0 $X=379440 $Y=295860
X1407 1134 123 1 2 INV2 $T=384400 266000 1 0 $X=384400 $Y=260580
X1408 1255 1288 1 2 INV2 $T=421600 346640 1 0 $X=421600 $Y=341220
X1409 1433 201 1 2 INV2 $T=477400 276080 1 0 $X=477400 $Y=270660
X1410 1572 1554 1 2 INV2 $T=516460 266000 0 180 $X=514600 $Y=260580
X1411 1575 1573 1 2 INV2 $T=517700 276080 1 180 $X=515840 $Y=275700
X1412 1581 1575 1 2 INV2 $T=517700 286160 0 180 $X=515840 $Y=280740
X1413 240 1578 1 2 INV2 $T=519560 276080 1 180 $X=517700 $Y=275700
X1414 1598 1627 1 2 INV2 $T=528240 296240 1 0 $X=528240 $Y=290820
X1415 1627 1621 1 2 INV2 $T=530100 296240 1 0 $X=530100 $Y=290820
X1416 1634 1606 1 2 INV2 $T=531960 276080 1 0 $X=531960 $Y=270660
X1417 237 238 1 2 INV2 $T=535060 266000 1 180 $X=533200 $Y=265620
X1418 1651 253 1 2 INV2 $T=536920 266000 1 180 $X=535060 $Y=265620
X1419 1769 1778 1 2 INV2 $T=566060 296240 0 0 $X=566060 $Y=295860
X1420 1773 1780 1 2 INV2 $T=566680 286160 1 0 $X=566680 $Y=280740
X1421 1848 310 1 2 INV2 $T=599540 266000 1 0 $X=599540 $Y=260580
X1422 2022 2024 1 2 INV2 $T=638600 286160 1 0 $X=638600 $Y=280740
X1423 2064 2077 1 2 INV2 $T=646040 266000 1 0 $X=646040 $Y=260580
X1424 2622 496 1 2 INV2 $T=891560 336560 1 0 $X=891560 $Y=331140
X1425 2658 482 1 2 INV2 $T=908300 346640 1 180 $X=906440 $Y=346260
X1426 2669 520 1 2 INV2 $T=910780 336560 0 180 $X=908920 $Y=331140
X1427 2688 539 1 2 INV2 $T=923180 326480 1 180 $X=921320 $Y=326100
X1428 731 2 759 1 22 NR2P $T=267220 266000 0 0 $X=267220 $Y=265620
X1429 731 2 750 1 774 NR2P $T=272180 276080 1 180 $X=268460 $Y=275700
X1430 830 2 846 1 829 NR2P $T=300080 286160 1 180 $X=296360 $Y=285780
X1431 45 2 811 1 835 NR2P $T=296980 296240 0 0 $X=296980 $Y=295860
X1432 854 2 877 1 64 NR2P $T=306280 266000 1 0 $X=306280 $Y=260580
X1433 1101 2 1097 1 1090 NR2P $T=370760 286160 1 0 $X=370760 $Y=280740
X1434 1101 2 1120 1 1122 NR2P $T=378200 276080 1 0 $X=378200 $Y=270660
X1435 1101 2 1153 1 124 NR2P $T=388740 276080 0 180 $X=385020 $Y=270660
X1436 184 2 1511 1 1431 NR2P $T=497860 296240 0 180 $X=494140 $Y=290820
X1437 1588 2 1621 1 1572 NR2P $T=525140 276080 1 0 $X=525140 $Y=270660
X1438 251 2 38 1 1650 NR2P $T=532580 296240 0 0 $X=532580 $Y=295860
X1439 251 2 50 1 1800 NR2P $T=574120 296240 0 180 $X=570400 $Y=290820
X1440 1837 2 1834 1 1848 NR2P $T=589000 276080 0 180 $X=585280 $Y=270660
X1441 1837 2 1855 1 304 NR2P $T=593340 276080 0 180 $X=589620 $Y=270660
X1442 1837 2 1867 1 307 NR2P $T=595200 266000 0 0 $X=595200 $Y=265620
X1443 478 2537 1 2 INV12CK $T=861800 346640 0 0 $X=861800 $Y=346260
X1444 2537 486 1 2 INV12CK $T=868000 326480 0 0 $X=868000 $Y=326100
X1445 2374 2367 1 2 BUF2CK $T=778720 336560 0 0 $X=778720 $Y=336180
X1446 2587 2605 1 2 BUF2CK $T=885980 346640 0 0 $X=885980 $Y=346260
X1447 2233 441 2444 1 2 2233 446 2480 639 ICV_4 $T=808480 286160 1 0 $X=808480 $Y=280740
X1448 2233 443 2468 1 2 2233 447 2484 639 ICV_4 $T=810960 296240 1 0 $X=810960 $Y=290820
X1449 2248 449 2501 1 2 2248 456 2509 639 ICV_4 $T=827080 276080 0 0 $X=827080 $Y=275700
X1450 377 446 2515 1 2 389 464 2540 639 ICV_4 $T=833900 346640 1 0 $X=833900 $Y=341220
X1451 2248 443 2519 1 2 472 447 2534 639 ICV_4 $T=837620 266000 1 0 $X=837620 $Y=260580
X1452 377 447 2525 1 2 377 443 477 639 ICV_4 $T=838240 356720 1 0 $X=838240 $Y=351300
X1453 472 446 2535 1 2 406 447 2553 639 ICV_4 $T=841960 276080 1 0 $X=841960 $Y=270660
X1454 2222 457 2551 1 2 2279 457 2568 639 ICV_4 $T=848780 286160 1 0 $X=848780 $Y=280740
X1455 2222 443 2550 1 2 389 446 2564 639 ICV_4 $T=848780 316400 1 0 $X=848780 $Y=310980
X1456 389 447 2558 1 2 368 446 2579 639 ICV_4 $T=852500 326480 1 0 $X=852500 $Y=321060
X1457 406 446 2555 1 2 384 447 2565 639 ICV_4 $T=853120 266000 0 0 $X=853120 $Y=265620
X1458 368 447 2588 1 2 368 457 2628 639 ICV_4 $T=873580 326480 1 0 $X=873580 $Y=321060
X1459 527 511 2694 1 2 521 546 2716 639 ICV_4 $T=913260 306320 1 0 $X=913260 $Y=300900
X1460 522 542 2711 1 2 522 546 2729 639 ICV_4 $T=920700 326480 1 0 $X=920700 $Y=321060
X1461 521 544 2742 1 2 573 553 2757 639 ICV_4 $T=944880 306320 1 0 $X=944880 $Y=300900
X1462 567 534 2752 1 2 567 546 2767 639 ICV_4 $T=948600 356720 1 0 $X=948600 $Y=351300
X1463 567 511 2755 1 2 571 553 2758 639 ICV_4 $T=949220 336560 1 0 $X=949220 $Y=331140
X1464 527 593 2847 1 2 527 595 2874 639 ICV_4 $T=999440 306320 0 0 $X=999440 $Y=305940
X1465 522 593 2842 1 2 522 595 2848 639 ICV_4 $T=999440 326480 0 0 $X=999440 $Y=326100
X1466 573 614 2903 1 2 573 615 2919 639 ICV_4 $T=1038500 306320 0 0 $X=1038500 $Y=305940
X1467 571 619 2915 1 2 522 616 2928 639 ICV_4 $T=1047180 326480 0 0 $X=1047180 $Y=326100
X1468 2338 1 2 2253 INV3CK $T=764460 336560 0 180 $X=761360 $Y=331140
X1469 2354 1 2 2274 INV3CK $T=780580 306320 1 180 $X=777480 $Y=305940
X1470 2379 1 2 2296 INV3CK $T=780580 296240 0 0 $X=780580 $Y=295860
X1471 2451 1 2 2422 INV3CK $T=811580 326480 0 0 $X=811580 $Y=326100
X1472 2428 1 2 2445 INV3CK $T=814060 296240 0 0 $X=814060 $Y=295860
X1473 2504 1 2 2538 INV3CK $T=851260 346640 0 0 $X=851260 $Y=346260
X1474 2520 1 2 2456 INV3CK $T=854360 316400 0 0 $X=854360 $Y=316020
X1475 2530 1 2 2547 INV3CK $T=856840 296240 0 0 $X=856840 $Y=295860
X1476 481 1 2 2563 INV3CK $T=864900 356720 0 0 $X=864900 $Y=356340
X1477 2595 1 2 2641 INV3CK $T=900240 346640 0 180 $X=897140 $Y=341220
X1478 505 1 2 2642 INV3CK $T=899000 356720 1 0 $X=899000 $Y=351300
X1479 2623 1 2 2673 INV3CK $T=912640 356720 0 180 $X=909540 $Y=351300
X1480 2615 1 2 2676 INV3CK $T=913880 336560 0 180 $X=910780 $Y=331140
X1481 2796 1 2 2798 INV3CK $T=979600 346640 0 0 $X=979600 $Y=346260
X1482 2810 1 2 2814 INV3CK $T=989520 316400 0 0 $X=989520 $Y=316020
X1483 2833 1 2 2834 INV3CK $T=1006260 336560 0 180 $X=1003160 $Y=331140
X1484 2861 1 2 2858 INV3CK $T=1015560 306320 0 180 $X=1012460 $Y=300900
X1485 1318 1 2 1290 BUF1CK $T=427800 266000 1 0 $X=427800 $Y=260580
X1486 1770 1 2 1788 BUF1CK $T=567300 336560 0 0 $X=567300 $Y=336180
X1487 2317 1 2 2319 BUF1CK $T=754540 316400 1 0 $X=754540 $Y=310980
X1488 2319 1 2 2362 BUF1CK $T=778100 316400 0 0 $X=778100 $Y=316020
X1489 2383 1 2 2378 BUF1CK $T=780580 296240 1 0 $X=780580 $Y=290820
X1490 2395 1 2 2374 BUF1CK $T=783680 326480 0 0 $X=783680 $Y=326100
X1491 2396 1 2 2383 BUF1CK $T=784920 286160 0 0 $X=784920 $Y=285780
X1492 2420 1 2 2427 BUF1CK $T=797320 286160 0 0 $X=797320 $Y=285780
X1493 2424 1 2 2420 BUF1CK $T=799180 276080 0 0 $X=799180 $Y=275700
X1494 2431 1 2 2432 BUF1CK $T=801040 336560 1 0 $X=801040 $Y=331140
X1495 2432 1 2 2404 BUF1CK $T=801660 346640 0 0 $X=801660 $Y=346260
X1496 2460 1 2 2463 BUF1CK $T=815920 346640 0 0 $X=815920 $Y=346260
X1497 2463 1 2 2459 BUF1CK $T=818400 336560 0 0 $X=818400 $Y=336180
X1498 2499 1 2 2507 BUF1CK $T=837620 306320 1 0 $X=837620 $Y=300900
X1499 2507 1 2 2467 BUF1CK $T=841960 296240 0 0 $X=841960 $Y=295860
X1500 2524 1 2 2527 BUF1CK $T=846300 286160 1 0 $X=846300 $Y=280740
X1501 2546 1 2 2524 BUF1CK $T=856840 286160 0 0 $X=856840 $Y=285780
X1502 2617 1 2 2621 BUF1CK $T=889700 306320 1 0 $X=889700 $Y=300900
X1503 2597 1 2 2630 BUF1CK $T=892180 356720 1 0 $X=892180 $Y=351300
X1504 2621 1 2 2634 BUF1CK $T=900860 296240 0 0 $X=900860 $Y=295860
X1505 2660 1 2 2661 BUF1CK $T=906440 306320 1 0 $X=906440 $Y=300900
X1506 2746 1 2 572 BUF1CK $T=952940 356720 0 0 $X=952940 $Y=356340
X1507 2827 1 2 2831 BUF1CK $T=1000680 326480 1 0 $X=1000680 $Y=321060
X1508 2845 1 2 2849 BUF1CK $T=1008740 346640 0 0 $X=1008740 $Y=346260
X1509 2849 1 2 2818 BUF1CK $T=1011220 346640 0 0 $X=1011220 $Y=346260
X1510 2868 1 2 2828 BUF1CK $T=1016180 356720 1 0 $X=1016180 $Y=351300
X1511 2852 1 2 2827 BUF1CK $T=1018660 326480 1 0 $X=1018660 $Y=321060
X1512 2875 1 2 2868 BUF1CK $T=1018660 356720 1 0 $X=1018660 $Y=351300
X1513 806 1 2 803 BUF1S $T=280860 266000 0 0 $X=280860 $Y=265620
X1514 846 1 2 891 BUF1S $T=311240 296240 0 0 $X=311240 $Y=295860
X1515 920 1 2 1027 BUF1S $T=345960 276080 1 0 $X=345960 $Y=270660
X1516 995 1 2 1049 BUF1S $T=353400 296240 0 0 $X=353400 $Y=295860
X1517 1034 1 2 992 BUF1S $T=353400 336560 0 0 $X=353400 $Y=336180
X1518 1068 1 2 1094 BUF1S $T=368280 286160 1 0 $X=368280 $Y=280740
X1519 1092 1 2 1128 BUF1S $T=375100 286160 0 0 $X=375100 $Y=285780
X1520 141 1 2 148 BUF1S $T=407960 356720 1 0 $X=407960 $Y=351300
X1521 153 1 2 156 BUF1S $T=421600 356720 1 0 $X=421600 $Y=351300
X1522 1264 1 2 1291 BUF1S $T=432760 286160 1 0 $X=432760 $Y=280740
X1523 1285 1 2 1350 BUF1S $T=432760 296240 1 0 $X=432760 $Y=290820
X1524 1346 1 2 1363 BUF1S $T=434000 356720 0 0 $X=434000 $Y=356340
X1525 1353 1 2 1334 BUF1S $T=438340 276080 0 0 $X=438340 $Y=275700
X1526 1058 1 2 1372 BUF1S $T=439580 296240 0 0 $X=439580 $Y=295860
X1527 1366 1 2 1381 BUF1S $T=440200 306320 0 0 $X=440200 $Y=305940
X1528 1379 1 2 1390 BUF1S $T=444540 306320 1 0 $X=444540 $Y=300900
X1529 1399 1 2 1403 BUF1S $T=450120 346640 0 0 $X=450120 $Y=346260
X1530 1398 1 2 1406 BUF1S $T=451360 326480 1 0 $X=451360 $Y=321060
X1531 1572 1 2 1596 BUF1S $T=522040 266000 1 0 $X=522040 $Y=260580
X1532 1600 1 2 1607 BUF1S $T=522660 276080 0 0 $X=522660 $Y=275700
X1533 1790 1 2 1796 BUF1S $T=569780 346640 0 0 $X=569780 $Y=346260
X1534 1987 1 2 2021 BUF1S $T=634880 356720 1 0 $X=634880 $Y=351300
X1535 2011 1 2 2029 BUF1S $T=639840 316400 0 0 $X=639840 $Y=316020
X1536 2048 1 2 2089 BUF1S $T=648520 356720 1 0 $X=648520 $Y=351300
X1537 2026 1 2 2098 BUF1S $T=653480 306320 1 0 $X=653480 $Y=300900
X1538 2114 1 2 2145 BUF1S $T=663400 346640 0 0 $X=663400 $Y=346260
X1539 2108 1 2 2150 BUF1S $T=664640 336560 1 0 $X=664640 $Y=331140
X1540 2118 1 2 2139 BUF1S $T=665260 316400 0 0 $X=665260 $Y=316020
X1541 2037 1 2 2174 BUF1S $T=677040 316400 0 0 $X=677040 $Y=316020
X1542 354 1 2 2170 BUF1S $T=678280 266000 0 0 $X=678280 $Y=265620
X1543 2161 1 2 2175 BUF1S $T=678900 306320 1 0 $X=678900 $Y=300900
X1544 385 1 2 2222 BUF1S $T=709280 326480 1 0 $X=709280 $Y=321060
X1545 386 1 2 377 BUF1S $T=713000 356720 1 0 $X=713000 $Y=351300
X1546 394 1 2 2233 BUF1S $T=721060 326480 1 0 $X=721060 $Y=321060
X1547 414 1 2 2279 BUF1S $T=757020 316400 1 0 $X=757020 $Y=310980
X1548 418 1 2 2248 BUF1S $T=761360 316400 1 0 $X=761360 $Y=310980
X1549 430 1 2 431 BUF1S $T=789260 276080 0 0 $X=789260 $Y=275700
X1550 564 1 2 555 BUF1S $T=941780 276080 0 0 $X=941780 $Y=275700
X1551 1025 1 2 1033 DELB $T=350920 276080 0 0 $X=350920 $Y=275700
X1552 1401 1 2 181 DELB $T=453840 316400 0 0 $X=453840 $Y=316020
X1553 1396 1 2 187 DELB $T=458800 316400 0 0 $X=458800 $Y=316020
X1554 1405 1 2 200 DELB $T=471820 326480 1 0 $X=471820 $Y=321060
X1555 1777 1 2 1793 DELB $T=567300 266000 1 0 $X=567300 $Y=260580
X1556 2202 1 2 2196 DELB $T=693160 296240 0 0 $X=693160 $Y=295860
X1557 2311 1 2 2323 DELB $T=753300 306320 1 0 $X=753300 $Y=300900
X1558 2362 1 2 2342 DELB $T=773140 316400 0 0 $X=773140 $Y=316020
X1559 2367 1 2 2380 DELB $T=776240 326480 0 0 $X=776240 $Y=326100
X1560 2393 1 2 2396 DELB $T=783680 296240 0 0 $X=783680 $Y=295860
X1561 428 1 2 404 DELB $T=785540 266000 0 0 $X=785540 $Y=265620
X1562 2404 1 2 2413 DELB $T=789260 356720 0 0 $X=789260 $Y=356340
X1563 2419 1 2 2418 DELB $T=796700 306320 0 0 $X=796700 $Y=305940
X1564 2427 1 2 2443 DELB $T=802280 266000 0 0 $X=802280 $Y=265620
X1565 2467 1 2 2476 DELB $T=820260 296240 0 0 $X=820260 $Y=295860
X1566 2483 1 2 2493 DELB $T=827080 316400 1 0 $X=827080 $Y=310980
X1567 2486 1 2 2488 DELB $T=829560 326480 1 0 $X=829560 $Y=321060
X1568 2481 1 2 2460 DELB $T=841340 346640 0 0 $X=841340 $Y=346260
X1569 2527 1 2 2544 DELB $T=851880 296240 0 0 $X=851880 $Y=295860
X1570 2548 1 2 2529 DELB $T=857460 316400 0 0 $X=857460 $Y=316020
X1571 2593 1 2 492 DELB $T=881020 306320 0 0 $X=881020 $Y=305940
X1572 2619 1 2 498 DELB $T=890940 296240 0 0 $X=890940 $Y=295860
X1573 2585 1 2 2640 DELB $T=892180 266000 0 0 $X=892180 $Y=265620
X1574 2605 1 2 2612 DELB $T=893420 336560 1 0 $X=893420 $Y=331140
X1575 2634 1 2 2635 DELB $T=895900 296240 0 0 $X=895900 $Y=295860
X1576 2610 1 2 2647 DELB $T=897140 326480 1 0 $X=897140 $Y=321060
X1577 2643 1 2 2648 DELB $T=900240 316400 1 0 $X=900240 $Y=310980
X1578 2644 1 2 2626 DELB $T=900240 346640 1 0 $X=900240 $Y=341220
X1579 2646 1 2 513 DELB $T=901480 276080 0 0 $X=901480 $Y=275700
X1580 2631 1 2 516 DELB $T=902100 326480 1 0 $X=902100 $Y=321060
X1581 508 1 2 2632 DELB $T=902100 356720 1 0 $X=902100 $Y=351300
X1582 2653 1 2 519 DELB $T=903960 336560 1 0 $X=903960 $Y=331140
X1583 2649 1 2 2660 DELB $T=905200 316400 1 0 $X=905200 $Y=310980
X1584 2607 1 2 2633 DELB $T=905200 346640 1 0 $X=905200 $Y=341220
X1585 2654 1 2 2664 DELB $T=906440 276080 0 0 $X=906440 $Y=275700
X1586 523 1 2 2670 DELB $T=910780 346640 1 0 $X=910780 $Y=341220
X1587 2656 1 2 2659 DELB $T=911400 276080 0 0 $X=911400 $Y=275700
X1588 529 1 2 537 DELB $T=914500 356720 1 0 $X=914500 $Y=351300
X1589 2674 1 2 2682 DELB $T=916360 316400 1 0 $X=916360 $Y=310980
X1590 2706 1 2 2720 DELB $T=943020 356720 1 0 $X=943020 $Y=351300
X1591 577 1 2 2746 DELB $T=959140 356720 0 0 $X=959140 $Y=356340
X1592 586 1 2 589 DELB $T=977120 356720 0 0 $X=977120 $Y=356340
X1593 2790 1 2 2822 DELB $T=990760 336560 0 0 $X=990760 $Y=336180
X1594 2818 1 2 2817 DELB $T=993860 356720 1 0 $X=993860 $Y=351300
X1595 2828 1 2 597 DELB $T=1001920 356720 0 0 $X=1001920 $Y=356340
X1596 2831 1 2 2838 DELB $T=1006880 336560 1 0 $X=1006880 $Y=331140
X1597 720 2 1 723 BUF1 $T=249860 316400 0 0 $X=249860 $Y=316020
X1598 719 2 1 794 BUF1 $T=274040 276080 0 0 $X=274040 $Y=275700
X1599 55 2 1 858 BUF1 $T=298220 356720 1 0 $X=298220 $Y=351300
X1600 105 2 1 1115 BUF1 $T=377580 336560 0 0 $X=377580 $Y=336180
X1601 106 2 1 145 BUF1 $T=404240 276080 1 0 $X=404240 $Y=270660
X1602 188 2 1 1414 BUF1 $T=464380 346640 0 0 $X=464380 $Y=346260
X1603 196 2 1 1459 BUF1 $T=489800 346640 1 180 $X=487320 $Y=346260
X1604 234 2 1 1580 BUF1 $T=516460 356720 0 0 $X=516460 $Y=356340
X1605 309 2 1 1828 BUF1 $T=597680 356720 0 180 $X=595200 $Y=351300
X1606 2612 2 1 2602 BUF1 $T=889080 336560 1 0 $X=889080 $Y=331140
X1607 2661 2 1 2665 BUF1 $T=915120 296240 0 0 $X=915120 $Y=295860
X1608 118 2 1 121 BUF3 $T=378200 356720 0 0 $X=378200 $Y=356340
X1609 1803 2 1 1806 BUF3 $T=574120 276080 1 0 $X=574120 $Y=270660
X1610 2537 422 1 2 INV8CK $T=851260 356720 0 0 $X=851260 $Y=356340
X1611 2526 443 1 2 INV8CK $T=881640 326480 0 0 $X=881640 $Y=326100
X1612 691 684 676 2 678 672 1 AO22 $T=240560 296240 1 180 $X=235600 $Y=295860
X1613 693 684 666 2 679 672 1 AO22 $T=241180 346640 1 180 $X=236220 $Y=346260
X1614 698 684 654 2 681 672 1 AO22 $T=244280 306320 1 180 $X=239320 $Y=305940
X1615 703 684 651 2 682 672 1 AO22 $T=244280 346640 0 180 $X=239320 $Y=341220
X1616 708 684 662 2 690 672 1 AO22 $T=246760 316400 0 180 $X=241800 $Y=310980
X1617 696 4 673 2 642 9 1 AO22 $T=243040 276080 1 0 $X=243040 $Y=270660
X1618 712 684 687 2 680 672 1 AO22 $T=248620 316400 1 180 $X=243660 $Y=316020
X1619 23 4 721 2 742 9 1 AO22 $T=265980 266000 0 180 $X=261020 $Y=260580
X1620 34 35 808 2 810 48 1 AO22 $T=283340 276080 0 0 $X=283340 $Y=275700
X1621 51 35 822 2 829 48 1 AO22 $T=290780 276080 0 0 $X=290780 $Y=275700
X1622 56 35 842 2 854 48 1 AO22 $T=297600 266000 1 0 $X=297600 $Y=260580
X1623 78 76 889 2 895 48 1 AO22 $T=323020 276080 0 180 $X=318060 $Y=270660
X1624 80 76 917 2 921 48 1 AO22 $T=327980 276080 1 180 $X=323020 $Y=275700
X1625 969 76 949 2 922 82 1 AO22 $T=333560 286160 0 180 $X=328600 $Y=280740
X1626 86 76 85 2 939 82 1 AO22 $T=333560 356720 1 180 $X=328600 $Y=356340
X1627 974 76 959 2 933 82 1 AO22 $T=336660 276080 1 180 $X=331700 $Y=275700
X1628 985 76 928 2 937 82 1 AO22 $T=337280 316400 1 180 $X=332320 $Y=316020
X1629 993 76 967 2 908 82 1 AO22 $T=341000 346640 0 180 $X=336040 $Y=341220
X1630 994 76 986 2 916 82 1 AO22 $T=341000 356720 0 180 $X=336040 $Y=351300
X1631 980 76 966 2 919 82 1 AO22 $T=342860 306320 0 180 $X=337900 $Y=300900
X1632 1007 76 972 2 918 82 1 AO22 $T=344100 346640 1 180 $X=339140 $Y=346260
X1633 1008 76 982 2 927 82 1 AO22 $T=344720 326480 1 180 $X=339760 $Y=326100
X1634 1021 76 981 2 934 82 1 AO22 $T=346580 316400 0 180 $X=341620 $Y=310980
X1635 129 1159 1148 2 1142 1169 1 AO22 $T=388740 346640 0 0 $X=388740 $Y=346260
X1636 1151 1159 1123 2 1155 1169 1 AO22 $T=390600 346640 1 0 $X=390600 $Y=341220
X1637 143 1159 1186 2 1178 1169 1 AO22 $T=404240 346640 1 180 $X=399280 $Y=346260
X1638 1179 1159 1209 2 1195 1169 1 AO22 $T=407960 336560 0 0 $X=407960 $Y=336180
X1639 1240 145 1233 2 1211 1169 1 AO22 $T=414780 276080 1 180 $X=409820 $Y=275700
X1640 1246 1169 1152 2 1222 1159 1 AO22 $T=415400 316400 1 180 $X=410440 $Y=316020
X1641 1248 1159 1238 2 1184 1169 1 AO22 $T=416020 346640 0 180 $X=411060 $Y=341220
X1642 1254 145 1215 2 1188 1169 1 AO22 $T=417880 296240 0 180 $X=412920 $Y=290820
X1643 1256 1159 1225 2 1198 1169 1 AO22 $T=418500 356720 0 180 $X=413540 $Y=351300
X1644 1268 145 1236 2 1196 1169 1 AO22 $T=419740 306320 0 180 $X=414780 $Y=300900
X1645 1266 1159 1237 2 1203 1169 1 AO22 $T=420360 316400 0 180 $X=415400 $Y=310980
X1646 1270 145 1239 2 1187 1169 1 AO22 $T=420980 286160 1 180 $X=416020 $Y=285780
X1647 1278 145 1250 2 1193 1169 1 AO22 $T=422840 276080 0 180 $X=417880 $Y=270660
X1648 158 145 1272 2 1172 113 1 AO22 $T=428420 266000 1 180 $X=423460 $Y=265620
X1649 1368 102 176 2 177 180 1 AO22 $T=453220 296240 0 0 $X=453220 $Y=295860
X1650 1545 227 1519 2 1497 223 1 AO22 $T=507160 296240 1 180 $X=502200 $Y=295860
X1651 1550 227 1544 2 1498 226 1 AO22 $T=509640 336560 0 180 $X=504680 $Y=331140
X1652 1548 227 1546 2 1493 223 1 AO22 $T=510260 286160 1 180 $X=505300 $Y=285780
X1653 1551 227 1532 2 1504 226 1 AO22 $T=510260 336560 1 180 $X=505300 $Y=336180
X1654 1561 227 1534 2 1492 226 1 AO22 $T=512120 306320 1 180 $X=507160 $Y=305940
X1655 1553 227 1536 2 1475 223 1 AO22 $T=512740 266000 1 180 $X=507780 $Y=265620
X1656 1559 227 1539 2 1494 223 1 AO22 $T=513360 286160 0 180 $X=508400 $Y=280740
X1657 1564 227 1537 2 1496 226 1 AO22 $T=513360 316400 0 180 $X=508400 $Y=310980
X1658 1611 227 1542 2 1495 226 1 AO22 $T=513360 316400 1 180 $X=508400 $Y=316020
X1659 1555 227 1540 2 1501 226 1 AO22 $T=513360 346640 0 180 $X=508400 $Y=341220
X1660 1557 227 1541 2 1503 223 1 AO22 $T=513980 276080 0 180 $X=509020 $Y=270660
X1661 1567 227 1538 2 1491 223 1 AO22 $T=513980 276080 1 180 $X=509020 $Y=275700
X1662 1574 226 1499 2 1543 227 1 AO22 $T=516460 346640 1 180 $X=511500 $Y=346260
X1663 1710 238 1685 2 1688 264 1 AO22 $T=553040 276080 1 180 $X=548080 $Y=275700
X1664 1713 238 1690 2 1686 264 1 AO22 $T=554280 286160 1 180 $X=549320 $Y=285780
X1665 1724 275 1702 2 1673 264 1 AO22 $T=556140 346640 1 180 $X=551180 $Y=346260
X1666 1727 238 1717 2 1664 264 1 AO22 $T=557380 296240 0 180 $X=552420 $Y=290820
X1667 1734 275 1726 2 1699 264 1 AO22 $T=559860 336560 1 180 $X=554900 $Y=336180
X1668 1739 275 1709 2 1683 264 1 AO22 $T=559860 346640 0 180 $X=554900 $Y=341220
X1669 1744 275 276 2 1672 264 1 AO22 $T=559860 356720 1 180 $X=554900 $Y=356340
X1670 1743 238 1712 2 1670 264 1 AO22 $T=560480 306320 0 180 $X=555520 $Y=300900
X1671 1745 238 1725 2 1674 264 1 AO22 $T=560480 306320 1 180 $X=555520 $Y=305940
X1672 1747 275 1731 2 1657 264 1 AO22 $T=561100 346640 1 180 $X=556140 $Y=346260
X1673 1754 238 1755 2 1680 264 1 AO22 $T=565440 276080 1 180 $X=560480 $Y=275700
X1674 1751 238 1736 2 1695 264 1 AO22 $T=566060 316400 1 180 $X=561100 $Y=316020
X1675 1779 238 1741 2 1694 264 1 AO22 $T=567300 326480 0 180 $X=562340 $Y=321060
X1676 1791 238 1758 2 1706 264 1 AO22 $T=570400 326480 1 180 $X=565440 $Y=326100
X1677 289 303 1853 2 304 305 1 AO22 $T=587140 266000 1 0 $X=587140 $Y=260580
X1678 320 318 1896 2 1893 315 1 AO22 $T=606360 356720 0 180 $X=601400 $Y=351300
X1679 1942 318 1954 2 1937 315 1 AO22 $T=621860 356720 0 180 $X=616900 $Y=351300
X1680 2012 303 1944 2 1926 1946 1 AO22 $T=624340 296240 0 180 $X=619380 $Y=290820
X1681 1977 303 1964 2 1917 1946 1 AO22 $T=624960 286160 1 180 $X=620000 $Y=285780
X1682 336 318 1945 2 1963 315 1 AO22 $T=626200 346640 0 180 $X=621240 $Y=341220
X1683 1986 303 1941 2 1948 1946 1 AO22 $T=627440 276080 0 180 $X=622480 $Y=270660
X1684 1999 303 1965 2 1940 1946 1 AO22 $T=631780 316400 0 180 $X=626820 $Y=310980
X1685 342 318 1998 2 1988 315 1 AO22 $T=633640 346640 0 180 $X=628680 $Y=341220
X1686 2006 303 1980 2 1922 1946 1 AO22 $T=634260 306320 0 180 $X=629300 $Y=300900
X1687 345 303 2001 2 1920 1946 1 AO22 $T=635500 276080 1 180 $X=630540 $Y=275700
X1688 2018 303 1993 2 1924 1946 1 AO22 $T=637360 296240 1 180 $X=632400 $Y=295860
X1689 2013 318 1994 2 1967 1946 1 AO22 $T=637360 316400 1 180 $X=632400 $Y=316020
X1690 2008 315 1959 2 1996 318 1 AO22 $T=637980 326480 1 180 $X=633020 $Y=326100
X1691 2017 303 2000 2 1933 1946 1 AO22 $T=638600 286160 1 180 $X=633640 $Y=285780
X1692 1992 292 2194 2 365 359 1 AO22 $T=686340 316400 0 0 $X=686340 $Y=316020
X1693 2487 461 2471 2 2468 455 1 AO22 $T=830180 296240 1 180 $X=825220 $Y=295860
X1694 2496 461 2500 2 2519 455 1 AO22 $T=841340 266000 0 0 $X=841340 $Y=265620
X1695 2545 461 2540 2 2552 455 1 AO22 $T=856220 336560 1 0 $X=856220 $Y=331140
X1696 2533 461 2556 2 2550 455 1 AO22 $T=863040 306320 1 0 $X=863040 $Y=300900
X1697 2561 461 2569 2 2574 455 1 AO22 $T=868000 306320 1 0 $X=868000 $Y=300900
X1698 2584 461 2582 2 2572 455 1 AO22 $T=877920 346640 1 180 $X=872960 $Y=346260
X1699 2598 461 2570 2 2577 455 1 AO22 $T=887220 336560 0 180 $X=882260 $Y=331140
X1700 2601 461 2603 2 2613 455 1 AO22 $T=887220 296240 1 0 $X=887220 $Y=290820
X1701 2607 427 2614 2 2543 494 1 AO22 $T=888460 336560 0 0 $X=888460 $Y=336180
X1702 2631 427 2624 2 2578 494 1 AO22 $T=895280 316400 1 180 $X=890320 $Y=316020
X1703 506 427 502 2 2531 494 1 AO22 $T=900240 356720 1 180 $X=895280 $Y=356340
X1704 2643 427 2639 2 2497 494 1 AO22 $T=900860 286160 1 180 $X=895900 $Y=285780
X1705 2593 427 504 2 2479 494 1 AO22 $T=896520 276080 1 0 $X=896520 $Y=270660
X1706 2646 427 2650 2 2640 494 1 AO22 $T=905820 286160 1 180 $X=900860 $Y=285780
X1707 2656 427 2651 2 509 494 1 AO22 $T=906440 266000 1 180 $X=901480 $Y=265620
X1708 2619 427 2652 2 2516 494 1 AO22 $T=906440 306320 0 180 $X=901480 $Y=300900
X1709 2653 427 2655 2 2647 494 1 AO22 $T=908300 326480 1 180 $X=903340 $Y=326100
X1710 2654 427 518 2 2560 494 1 AO22 $T=906440 266000 1 0 $X=906440 $Y=260580
X1711 2674 427 2663 2 517 494 1 AO22 $T=911400 286160 0 180 $X=906440 $Y=280740
X1712 547 549 2707 2 2708 552 1 AO22 $T=926900 266000 1 0 $X=926900 $Y=260580
X1713 2721 549 2727 2 2728 552 1 AO22 $T=938060 276080 1 0 $X=938060 $Y=270660
X1714 2726 549 2739 2 2742 552 1 AO22 $T=946740 286160 0 0 $X=946740 $Y=285780
X1715 2737 549 2741 2 2743 552 1 AO22 $T=946740 326480 0 0 $X=946740 $Y=326100
X1716 2736 549 2740 2 2745 552 1 AO22 $T=947980 316400 1 0 $X=947980 $Y=310980
X1717 2774 549 583 2 2783 552 1 AO22 $T=971540 356720 1 0 $X=971540 $Y=351300
X1718 2764 549 2793 2 2797 552 1 AO22 $T=977120 316400 0 0 $X=977120 $Y=316020
X1719 2791 549 2794 2 2799 552 1 AO22 $T=980220 306320 1 0 $X=980220 $Y=300900
X1720 643 641 651 656 2 1 MXL2HS $T=223200 346640 1 0 $X=223200 $Y=341220
X1721 663 640 669 671 2 1 MXL2HS $T=229400 336560 0 0 $X=229400 $Y=336180
X1722 777 787 793 783 2 1 MXL2HS $T=280860 266000 1 180 $X=275280 $Y=265620
X1723 836 55 846 841 2 1 MXL2HS $T=300700 296240 0 0 $X=300700 $Y=295860
X1724 953 947 960 968 2 1 MXL2HS $T=330460 336560 1 0 $X=330460 $Y=331140
X1725 1298 1299 1332 1302 2 1 MXL2HS $T=434620 316400 1 180 $X=429040 $Y=316020
X1726 1347 1251 1362 1357 2 1 MXL2HS $T=435860 326480 0 0 $X=435860 $Y=326100
X1727 1329 1273 1376 1380 2 1 MXL2HS $T=436480 336560 0 0 $X=436480 $Y=336180
X1728 1309 1271 1382 1375 2 1 MXL2HS $T=439580 336560 1 0 $X=439580 $Y=331140
X1729 1771 1796 1805 1807 2 1 MXL2HS $T=572880 346640 1 0 $X=572880 $Y=341220
X1730 1931 1939 1932 1928 2 1 MXL2HS $T=617520 306320 0 180 $X=611940 $Y=300900
X1731 1966 1961 1985 1970 2 1 MXL2HS $T=623720 266000 0 0 $X=623720 $Y=265620
X1732 2321 1 2 2311 DELA $T=757640 306320 0 0 $X=757640 $Y=305940
X1733 2452 1 2 2419 DELA $T=814060 306320 1 0 $X=814060 $Y=300900
X1734 2474 1 2 2486 DELA $T=824600 326480 1 0 $X=824600 $Y=321060
X1735 2495 1 2 2483 DELA $T=832040 316400 0 0 $X=832040 $Y=316020
X1736 2539 1 2 2548 DELA $T=854980 306320 0 0 $X=854980 $Y=305940
X1737 548 1 2 551 DELA $T=926900 356720 0 0 $X=926900 $Y=356340
X1738 2720 1 2 2731 DELA $T=935580 356720 0 0 $X=935580 $Y=356340
X1739 2780 1 2 2790 DELA $T=972160 326480 1 0 $X=972160 $Y=321060
X1740 1033 100 101 2 1 1057 QDFFRBN $T=348440 276080 1 0 $X=348440 $Y=270660
X1741 1400 100 101 2 1 1396 QDFFRBN $T=450740 296240 1 0 $X=450740 $Y=290820
X1742 1410 100 101 2 1 1401 QDFFRBN $T=463760 306320 1 180 $X=451980 $Y=305940
X1743 1402 100 101 2 1 1405 QDFFRBN $T=452600 316400 1 0 $X=452600 $Y=310980
X1744 1407 100 101 2 1 183 QDFFRBN $T=453220 336560 1 0 $X=453220 $Y=331140
X1745 1391 100 101 2 1 186 QDFFRBN $T=453840 326480 1 0 $X=453840 $Y=321060
X1746 1411 100 101 2 1 175 QDFFRBN $T=465620 356720 1 180 $X=453840 $Y=356340
X1747 1296 100 101 2 1 176 QDFFRBN $T=454460 286160 1 0 $X=454460 $Y=280740
X1748 1408 100 101 2 1 182 QDFFRBN $T=455080 266000 0 0 $X=455080 $Y=265620
X1749 1323 100 101 2 1 191 QDFFRBN $T=460660 276080 0 0 $X=460660 $Y=275700
X1750 295 299 306 2 1 308 QDFFRBN $T=584660 356720 0 0 $X=584660 $Y=356340
X1751 2031 100 306 2 1 340 QDFFRBN $T=642320 356720 1 180 $X=630540 $Y=356340
X1752 2147 100 360 2 1 2163 QDFFRBN $T=668980 346640 0 0 $X=668980 $Y=346260
X1753 2151 100 360 2 1 358 QDFFRBN $T=669600 336560 0 0 $X=669600 $Y=336180
X1754 2164 100 360 2 1 363 QDFFRBN $T=675180 326480 0 0 $X=675180 $Y=326100
X1755 2034 100 360 2 1 2190 QDFFRBN $T=675800 326480 1 0 $X=675800 $Y=321060
X1756 2159 100 360 2 1 361 QDFFRBN $T=682000 346640 0 0 $X=682000 $Y=346260
X1757 2179 362 360 2 1 367 QDFFRBN $T=682000 356720 0 0 $X=682000 $Y=356340
X1758 2185 100 360 2 1 2206 QDFFRBN $T=683860 266000 1 0 $X=683860 $Y=260580
X1759 2103 100 360 2 1 2183 QDFFRBN $T=684480 306320 0 0 $X=684480 $Y=305940
X1760 2186 100 360 2 1 2198 QDFFRBN $T=688820 276080 1 0 $X=688820 $Y=270660
X1761 2197 362 360 2 1 372 QDFFRBN $T=689440 336560 1 0 $X=689440 $Y=331140
X1762 2201 362 360 2 1 373 QDFFRBN $T=690060 336560 0 0 $X=690060 $Y=336180
X1763 2189 362 360 2 1 374 QDFFRBN $T=690060 346640 1 0 $X=690060 $Y=341220
X1764 2162 362 360 2 1 375 QDFFRBN $T=690680 356720 1 0 $X=690680 $Y=351300
X1765 2205 100 360 2 1 2202 QDFFRBN $T=704320 296240 0 180 $X=692540 $Y=290820
X1766 2203 100 360 2 1 2187 QDFFRBN $T=693780 306320 1 0 $X=693780 $Y=300900
X1767 2204 362 360 2 1 2210 QDFFRBN $T=693780 326480 0 0 $X=693780 $Y=326100
X1768 2192 362 360 2 1 2221 QDFFRBN $T=695640 316400 0 0 $X=695640 $Y=316020
X1769 2209 100 360 2 1 2194 QDFFRBN $T=708040 286160 1 180 $X=696260 $Y=285780
X1770 2648 500 497 2 1 485 QDFFRBN $T=903340 326480 1 180 $X=891560 $Y=326100
X1771 512 500 497 2 1 2622 QDFFRBN $T=905200 336560 1 180 $X=893420 $Y=336180
X1772 2633 500 497 2 1 2658 QDFFRBN $T=894660 346640 0 0 $X=894660 $Y=346260
X1773 2659 500 497 2 1 501 QDFFRBN $T=908300 306320 1 180 $X=896520 $Y=305940
X1774 2670 500 497 2 1 503 QDFFRBN $T=912020 356720 1 180 $X=900240 $Y=356340
X1775 510 500 497 2 1 2669 QDFFRBN $T=903340 296240 0 0 $X=903340 $Y=295860
X1776 2682 500 497 2 1 514 QDFFRBN $T=917600 316400 1 180 $X=905820 $Y=316020
X1777 2664 500 497 2 1 2688 QDFFRBN $T=908300 306320 0 0 $X=908300 $Y=305940
X1778 313 1858 1 2 BUF2 $T=598300 346640 1 0 $X=598300 $Y=341220
X1779 2630 2644 1 2 BUF2 $T=912640 346640 0 0 $X=912640 $Y=346260
X1780 79 811 1 2 INV3 $T=323640 296240 0 0 $X=323640 $Y=295860
X1781 106 113 1 2 INV3 $T=383780 266000 1 180 $X=381300 $Y=265620
X1782 2166 2 283 355 2170 1 2185 FA1S $T=672080 266000 1 0 $X=672080 $Y=260580
X1783 2200 2 1806 2024 2180 1 2209 FA1S $T=686340 286160 1 0 $X=686340 $Y=280740
X1784 829 819 822 2 1 XNR2HS $T=296980 286160 0 180 $X=291400 $Y=280740
X1785 1287 1336 1380 2 1 XNR2HS $T=442060 336560 0 0 $X=442060 $Y=336180
X1786 225 269 278 2 1 XNR2HS $T=561720 266000 1 0 $X=561720 $Y=260580
X1787 1574 1747 1807 2 1 XNR2HS $T=574120 346640 0 0 $X=574120 $Y=346260
X1788 1555 1739 1814 2 1 XNR2HS $T=577220 336560 0 0 $X=577220 $Y=336180
X1789 2071 1999 2083 2 1 XNR2HS $T=654100 316400 0 0 $X=654100 $Y=316020
X1790 2012 2111 2099 2 1 XNR2HS $T=662160 296240 0 180 $X=656580 $Y=290820
X1791 646 645 654 2 1 XOR2HS $T=223820 296240 0 0 $X=223820 $Y=295860
X1792 650 644 661 2 1 XOR2HS $T=225680 286160 1 0 $X=225680 $Y=280740
X1793 652 653 662 2 1 XOR2HS $T=225680 316400 1 0 $X=225680 $Y=310980
X1794 657 658 666 2 1 XOR2HS $T=226920 356720 1 0 $X=226920 $Y=351300
X1795 660 647 670 2 1 XOR2HS $T=229400 326480 0 0 $X=229400 $Y=326100
X1796 664 655 673 2 1 XOR2HS $T=231880 276080 1 0 $X=231880 $Y=270660
X1797 667 648 674 2 1 XOR2HS $T=231880 276080 0 0 $X=231880 $Y=275700
X1798 668 649 676 2 1 XOR2HS $T=232500 296240 1 0 $X=232500 $Y=290820
X1799 665 659 687 2 1 XOR2HS $T=235600 326480 1 0 $X=235600 $Y=321060
X1800 713 5 721 2 1 XOR2HS $T=248620 266000 0 0 $X=248620 $Y=265620
X1801 813 810 808 2 1 XOR2HS $T=287680 286160 0 180 $X=282100 $Y=280740
X1802 786 812 825 2 1 XOR2HS $T=289540 266000 1 0 $X=289540 $Y=260580
X1803 856 851 842 2 1 XOR2HS $T=301940 266000 1 180 $X=296360 $Y=265620
X1804 898 894 889 2 1 XOR2HS $T=316820 276080 0 180 $X=311240 $Y=270660
X1805 926 913 917 2 1 XOR2HS $T=327360 266000 1 180 $X=321780 $Y=265620
X1806 946 940 928 2 1 XOR2HS $T=331080 316400 1 180 $X=325500 $Y=316020
X1807 925 924 942 2 1 XOR2HS $T=326120 296240 1 0 $X=326120 $Y=290820
X1808 929 930 949 2 1 XOR2HS $T=327980 286160 0 0 $X=327980 $Y=285780
X1809 935 944 959 2 1 XOR2HS $T=329840 276080 1 0 $X=329840 $Y=270660
X1810 950 945 966 2 1 XOR2HS $T=330460 296240 0 0 $X=330460 $Y=295860
X1811 936 938 967 2 1 XOR2HS $T=330460 346640 1 0 $X=330460 $Y=341220
X1812 954 948 972 2 1 XOR2HS $T=332320 346640 0 0 $X=332320 $Y=346260
X1813 941 951 981 2 1 XOR2HS $T=334180 316400 1 0 $X=334180 $Y=310980
X1814 961 958 982 2 1 XOR2HS $T=334180 326480 0 0 $X=334180 $Y=326100
X1815 943 957 984 2 1 XOR2HS $T=334800 306320 0 0 $X=334800 $Y=305940
X1816 985 712 998 2 1 XOR2HS $T=337900 326480 1 0 $X=337900 $Y=321060
X1817 93 88 986 2 1 XOR2HS $T=340380 356720 0 0 $X=340380 $Y=356340
X1818 1004 825 1025 2 1 XOR2HS $T=344100 266000 1 0 $X=344100 $Y=260580
X1819 1048 1045 1004 2 1 XOR2HS $T=356500 266000 0 180 $X=350920 $Y=260580
X1820 702 1008 1047 2 1 XOR2HS $T=351540 336560 1 0 $X=351540 $Y=331140
X1821 1039 998 1050 2 1 XOR2HS $T=352160 316400 0 0 $X=352160 $Y=316020
X1822 1029 1047 1063 2 1 XOR2HS $T=357120 336560 1 0 $X=357120 $Y=331140
X1823 1080 1075 1067 2 1 XOR2HS $T=367040 276080 0 180 $X=361460 $Y=270660
X1824 1132 1130 1123 2 1 XOR2HS $T=382540 346640 1 180 $X=376960 $Y=346260
X1825 1142 1146 1148 2 1 XOR2HS $T=382540 356720 1 0 $X=382540 $Y=351300
X1826 1160 1158 126 2 1 XOR2HS $T=391220 266000 1 180 $X=385640 $Y=265620
X1827 1174 1173 1186 2 1 XOR2HS $T=396180 356720 1 0 $X=396180 $Y=351300
X1828 140 138 1201 2 1 XOR2HS $T=401140 266000 1 0 $X=401140 $Y=260580
X1829 1191 1189 1209 2 1 XOR2HS $T=401760 336560 0 0 $X=401760 $Y=336180
X1830 1192 1202 1215 2 1 XOR2HS $T=403620 296240 0 0 $X=403620 $Y=295860
X1831 1224 1217 1208 2 1 XOR2HS $T=409820 326480 1 180 $X=404240 $Y=326100
X1832 1197 1212 1222 2 1 XOR2HS $T=404860 316400 0 0 $X=404860 $Y=316020
X1833 1205 1199 1225 2 1 XOR2HS $T=405480 346640 1 0 $X=405480 $Y=341220
X1834 1218 1214 1233 2 1 XOR2HS $T=408580 286160 1 0 $X=408580 $Y=280740
X1835 146 147 1234 2 1 XOR2HS $T=409200 266000 1 0 $X=409200 $Y=260580
X1836 1221 1227 1236 2 1 XOR2HS $T=409200 296240 0 0 $X=409200 $Y=295860
X1837 1220 1216 1237 2 1 XOR2HS $T=409820 316400 1 0 $X=409820 $Y=310980
X1838 1219 1206 1239 2 1 XOR2HS $T=410440 286160 0 0 $X=410440 $Y=285780
X1839 1223 1232 1244 2 1 XOR2HS $T=411060 326480 1 0 $X=411060 $Y=321060
X1840 1229 1226 1250 2 1 XOR2HS $T=412300 276080 1 0 $X=412300 $Y=270660
X1841 1243 1242 1247 2 1 XOR2HS $T=414780 326480 0 0 $X=414780 $Y=326100
X1842 1249 1252 1238 2 1 XOR2HS $T=416020 346640 1 0 $X=416020 $Y=341220
X1843 1235 1245 1272 2 1 XOR2HS $T=417880 266000 0 0 $X=417880 $Y=265620
X1844 1307 1268 1286 2 1 XOR2HS $T=427800 306320 1 180 $X=422220 $Y=305940
X1845 1286 1305 1345 2 1 XOR2HS $T=430280 306320 1 0 $X=430280 $Y=300900
X1846 999 1376 1409 2 1 XOR2HS $T=452600 346640 0 0 $X=452600 $Y=346260
X1847 1409 1403 1411 2 1 XOR2HS $T=458180 346640 0 0 $X=458180 $Y=346260
X1848 1502 1507 1519 2 1 XOR2HS $T=495380 296240 0 0 $X=495380 $Y=295860
X1849 1510 1515 1532 2 1 XOR2HS $T=499100 336560 1 0 $X=499100 $Y=331140
X1850 1505 1513 1534 2 1 XOR2HS $T=500340 306320 0 0 $X=500340 $Y=305940
X1851 1508 220 1536 2 1 XOR2HS $T=500960 266000 0 0 $X=500960 $Y=265620
X1852 1514 1520 1537 2 1 XOR2HS $T=500960 316400 1 0 $X=500960 $Y=310980
X1853 1506 1512 1538 2 1 XOR2HS $T=501580 276080 0 0 $X=501580 $Y=275700
X1854 1517 1526 1539 2 1 XOR2HS $T=501580 286160 1 0 $X=501580 $Y=280740
X1855 1516 1521 1540 2 1 XOR2HS $T=501580 346640 1 0 $X=501580 $Y=341220
X1856 1525 1523 1541 2 1 XOR2HS $T=502200 276080 1 0 $X=502200 $Y=270660
X1857 1518 1528 1542 2 1 XOR2HS $T=502200 316400 0 0 $X=502200 $Y=316020
X1858 1522 1531 1543 2 1 XOR2HS $T=502200 346640 0 0 $X=502200 $Y=346260
X1859 1509 1529 1544 2 1 XOR2HS $T=503440 326480 1 0 $X=503440 $Y=321060
X1860 1530 1527 1546 2 1 XOR2HS $T=504060 296240 1 0 $X=504060 $Y=290820
X1861 1535 1533 1547 2 1 XOR2HS $T=504060 356720 1 0 $X=504060 $Y=351300
X1862 1556 1554 1549 2 1 XOR2HS $T=514600 266000 0 180 $X=509020 $Y=260580
X1863 1578 1573 1597 2 1 XOR2HS $T=518940 276080 1 0 $X=518940 $Y=270660
X1864 1606 1571 1623 2 1 XOR2HS $T=525140 266000 0 0 $X=525140 $Y=265620
X1865 1669 1667 265 2 1 XOR2HS $T=543120 266000 1 0 $X=543120 $Y=260580
X1866 1703 1687 1685 2 1 XOR2HS $T=553040 276080 0 180 $X=547460 $Y=270660
X1867 1705 1704 1690 2 1 XOR2HS $T=553660 286160 0 180 $X=548080 $Y=280740
X1868 1677 1679 1702 2 1 XOR2HS $T=548080 356720 1 0 $X=548080 $Y=351300
X1869 1689 1693 1709 2 1 XOR2HS $T=549320 346640 1 0 $X=549320 $Y=341220
X1870 1681 1682 1712 2 1 XOR2HS $T=549940 306320 1 0 $X=549940 $Y=300900
X1871 1692 1691 1725 2 1 XOR2HS $T=552420 316400 1 0 $X=552420 $Y=310980
X1872 1707 1715 1726 2 1 XOR2HS $T=553040 336560 1 0 $X=553040 $Y=331140
X1873 1701 1714 1717 2 1 XOR2HS $T=554900 296240 0 0 $X=554900 $Y=295860
X1874 1711 1698 1736 2 1 XOR2HS $T=555520 316400 0 0 $X=555520 $Y=316020
X1875 1708 1716 1741 2 1 XOR2HS $T=556140 326480 1 0 $X=556140 $Y=321060
X1876 1684 1696 1731 2 1 XOR2HS $T=556760 356720 1 0 $X=556760 $Y=351300
X1877 1719 1723 1758 2 1 XOR2HS $T=559860 326480 0 0 $X=559860 $Y=326100
X1878 1722 1720 1755 2 1 XOR2HS $T=565440 276080 0 0 $X=565440 $Y=275700
X1879 1797 281 1777 2 1 XOR2HS $T=573500 266000 1 180 $X=567920 $Y=265620
X1880 1810 1809 1797 2 1 XOR2HS $T=580940 266000 1 180 $X=575360 $Y=265620
X1881 289 287 285 2 1 XOR2HS $T=582180 266000 0 180 $X=576600 $Y=260580
X1882 1893 1907 1896 2 1 XOR2HS $T=607600 346640 1 180 $X=602020 $Y=346260
X1883 1890 321 319 2 1 XOR2HS $T=609460 266000 0 180 $X=603880 $Y=260580
X1884 1908 1903 1927 2 1 XOR2HS $T=610080 346640 0 0 $X=610080 $Y=346260
X1885 1934 1936 1944 2 1 XOR2HS $T=613180 296240 1 0 $X=613180 $Y=290820
X1886 1949 1930 331 2 1 XOR2HS $T=619380 266000 0 180 $X=613800 $Y=260580
X1887 1955 1952 1941 2 1 XOR2HS $T=620620 276080 0 180 $X=615040 $Y=270660
X1888 1960 1957 1945 2 1 XOR2HS $T=621240 346640 0 180 $X=615660 $Y=341220
X1889 1929 1923 1954 2 1 XOR2HS $T=616280 346640 0 0 $X=616280 $Y=346260
X1890 1950 1956 1965 2 1 XOR2HS $T=618140 316400 1 0 $X=618140 $Y=310980
X1891 1943 1976 1964 2 1 XOR2HS $T=626200 286160 0 180 $X=620620 $Y=280740
X1892 1971 1962 1980 2 1 XOR2HS $T=622480 306320 1 0 $X=622480 $Y=300900
X1893 1974 1968 1993 2 1 XOR2HS $T=626200 296240 0 0 $X=626200 $Y=295860
X1894 1979 1982 1994 2 1 XOR2HS $T=626200 316400 0 0 $X=626200 $Y=316020
X1895 1972 1978 1996 2 1 XOR2HS $T=626820 326480 0 0 $X=626820 $Y=326100
X1896 1951 1981 2000 2 1 XOR2HS $T=628060 286160 0 0 $X=628060 $Y=285780
X1897 1989 1984 1998 2 1 XOR2HS $T=629920 336560 1 0 $X=629920 $Y=331140
X1898 1997 341 343 2 1 XOR2HS $T=633640 266000 0 0 $X=633640 $Y=265620
X1899 1991 1990 2001 2 1 XOR2HS $T=635500 276080 1 0 $X=635500 $Y=270660
X1900 351 352 2041 2 1 XOR2HS $T=660300 356720 1 180 $X=654720 $Y=356340
X1901 1802 2043 2140 2 1 XOR2HS $T=664020 336560 0 0 $X=664020 $Y=336180
X1902 2140 2150 2159 2 1 XOR2HS $T=670840 336560 1 0 $X=670840 $Y=331140
X1903 1780 2077 2191 2 1 XOR2HS $T=682620 266000 0 0 $X=682620 $Y=265620
X1904 9 4 774 1 2 786 OA12 $T=271560 266000 1 0 $X=271560 $Y=260580
X1905 48 35 813 1 2 812 OA12 $T=290160 276080 0 180 $X=286440 $Y=270660
X1906 113 106 1088 1 2 1048 OA12 $T=370140 266000 0 180 $X=366420 $Y=260580
X1907 305 303 1848 1 2 1810 OA12 $T=592100 266000 1 180 $X=588380 $Y=265620
X1908 55 830 2 1 817 OR2 $T=295120 286160 1 180 $X=292640 $Y=285780
X1909 890 66 2 1 830 OR2 $T=313100 286160 1 180 $X=310620 $Y=285780
X1910 779 975 2 1 1014 OR2 $T=344100 286160 1 0 $X=344100 $Y=280740
X1911 1318 1005 2 1 1324 OR2 $T=429040 276080 1 0 $X=429040 $Y=270660
X1912 1901 1858 2 1 1837 OR2 $T=603880 276080 0 180 $X=601400 $Y=270660
X1913 2050 2019 2 1 2067 OR2 $T=644180 326480 0 0 $X=644180 $Y=326100
X1914 1122 1112 2 1 1108 OR2S $T=378820 266000 1 180 $X=376340 $Y=265620
X1915 2087 2070 1 2005 2102 2070 2 MOAI1 $T=651000 336560 0 0 $X=651000 $Y=336180
X1916 485 484 1 484 483 482 2 MOAI1 $T=869860 346640 0 180 $X=865520 $Y=341220
X1917 503 484 1 484 499 2629 2 MOAI1 $T=899000 356720 0 180 $X=894660 $Y=351300
X1918 501 484 1 484 2671 524 2 MOAI1 $T=908300 346640 0 0 $X=908300 $Y=346260
X1919 514 484 1 484 531 533 2 MOAI1 $T=912020 356720 0 0 $X=912020 $Y=356340
X1920 530 484 1 484 538 520 2 MOAI1 $T=916360 356720 0 0 $X=916360 $Y=356340
X1921 705 10 2 1 7 701 MUX2 $T=250480 356720 0 180 $X=246140 $Y=351300
X1922 722 10 2 1 642 704 MUX2 $T=251100 296240 0 180 $X=246760 $Y=290820
X1923 718 10 2 1 678 705 MUX2 $T=251100 306320 0 180 $X=246760 $Y=300900
X1924 738 10 2 1 692 711 MUX2 $T=252340 286160 0 180 $X=248000 $Y=280740
X1925 707 10 2 1 681 706 MUX2 $T=252340 306320 1 180 $X=248000 $Y=305940
X1926 726 10 2 1 677 716 MUX2 $T=252960 286160 1 180 $X=248620 $Y=285780
X1927 706 10 2 1 11 12 MUX2 $T=252960 356720 1 180 $X=248620 $Y=356340
X1928 724 723 2 1 704 717 MUX2 $T=254200 316400 0 180 $X=249860 $Y=310980
X1929 733 720 2 1 707 724 MUX2 $T=257300 306320 0 180 $X=252960 $Y=300900
X1930 729 10 2 1 690 727 MUX2 $T=258540 306320 1 180 $X=254200 $Y=305940
X1931 737 723 2 1 711 728 MUX2 $T=258540 326480 0 180 $X=254200 $Y=321060
X1932 743 10 2 1 14 729 MUX2 $T=259780 286160 1 180 $X=255440 $Y=285780
X1933 734 10 2 1 742 746 MUX2 $T=257300 276080 0 0 $X=257300 $Y=275700
X1934 727 10 2 1 19 12 MUX2 $T=257300 356720 0 0 $X=257300 $Y=356340
X1935 751 720 2 1 729 737 MUX2 $T=262880 306320 0 180 $X=258540 $Y=300900
X1936 747 10 2 1 680 18 MUX2 $T=263500 316400 1 180 $X=259160 $Y=316020
X1937 736 720 2 1 746 744 MUX2 $T=259780 306320 0 0 $X=259780 $Y=305940
X1938 745 723 2 1 716 741 MUX2 $T=264120 326480 0 180 $X=259780 $Y=321060
X1939 782 10 2 1 16 747 MUX2 $T=265980 286160 0 180 $X=261640 $Y=280740
X1940 757 723 2 1 747 745 MUX2 $T=265980 316400 0 180 $X=261640 $Y=310980
X1941 760 720 2 1 738 751 MUX2 $T=267840 296240 0 180 $X=263500 $Y=290820
X1942 763 21 2 1 751 753 MUX2 $T=268460 306320 0 180 $X=264120 $Y=300900
X1943 758 21 2 1 737 755 MUX2 $T=269080 316400 1 180 $X=264740 $Y=316020
X1944 761 21 2 1 717 756 MUX2 $T=269080 326480 1 180 $X=264740 $Y=326100
X1945 765 720 2 1 726 757 MUX2 $T=269700 286160 1 180 $X=265360 $Y=285780
X1946 755 21 2 1 744 754 MUX2 $T=269700 336560 0 180 $X=265360 $Y=331140
X1947 740 10 2 1 24 12 MUX2 $T=265360 356720 0 0 $X=265360 $Y=356340
X1948 753 21 2 1 736 758 MUX2 $T=270320 306320 1 180 $X=265980 $Y=305940
X1949 764 21 2 1 745 761 MUX2 $T=271560 326480 0 180 $X=267220 $Y=321060
X1950 776 21 2 1 724 764 MUX2 $T=272800 316400 0 180 $X=268460 $Y=310980
X1951 780 27 2 1 763 767 MUX2 $T=274040 306320 0 180 $X=269700 $Y=300900
X1952 781 27 2 1 761 769 MUX2 $T=274660 326480 1 180 $X=270320 $Y=326100
X1953 788 27 2 1 758 772 MUX2 $T=275280 316400 1 180 $X=270940 $Y=316020
X1954 771 21 2 1 732 768 MUX2 $T=275280 356720 0 180 $X=270940 $Y=351300
X1955 785 21 2 1 733 775 MUX2 $T=275900 296240 0 180 $X=271560 $Y=290820
X1956 796 27 2 1 768 12 MUX2 $T=275900 356720 1 180 $X=271560 $Y=356340
X1957 775 21 2 1 757 776 MUX2 $T=276520 306320 1 180 $X=272180 $Y=305940
X1958 797 27 2 1 755 781 MUX2 $T=277760 326480 0 180 $X=273420 $Y=321060
X1959 769 27 2 1 754 807 MUX2 $T=275900 326480 0 0 $X=275900 $Y=326100
X1960 772 27 2 1 764 797 MUX2 $T=281480 316400 1 180 $X=277140 $Y=316020
X1961 789 27 2 1 753 801 MUX2 $T=282720 306320 1 180 $X=278380 $Y=305940
X1962 815 49 2 1 827 820 MUX2 $T=289540 326480 0 0 $X=289540 $Y=326100
X1963 826 49 2 1 841 823 MUX2 $T=293260 306320 0 0 $X=293260 $Y=305940
X1964 816 49 2 1 850 831 MUX2 $T=294500 316400 1 0 $X=294500 $Y=310980
X1965 823 49 2 1 862 816 MUX2 $T=298840 306320 0 0 $X=298840 $Y=305940
X1966 59 49 2 1 868 62 MUX2 $T=300080 356720 0 0 $X=300080 $Y=356340
X1967 831 49 2 1 864 833 MUX2 $T=300700 316400 1 0 $X=300700 $Y=310980
X1968 845 858 2 1 857 852 MUX2 $T=305040 326480 1 180 $X=300700 $Y=326100
X1969 850 55 2 1 860 853 MUX2 $T=305660 316400 1 180 $X=301320 $Y=316020
X1970 853 858 2 1 867 845 MUX2 $T=301320 326480 1 0 $X=301320 $Y=321060
X1971 840 858 2 1 869 868 MUX2 $T=301320 356720 1 0 $X=301320 $Y=351300
X1972 60 858 2 1 873 62 MUX2 $T=302560 346640 0 0 $X=302560 $Y=346260
X1973 861 55 2 1 871 862 MUX2 $T=304420 306320 1 0 $X=304420 $Y=300900
X1974 841 55 2 1 878 850 MUX2 $T=305040 306320 0 0 $X=305040 $Y=305940
X1975 827 858 2 1 881 843 MUX2 $T=305660 336560 1 0 $X=305660 $Y=331140
X1976 862 55 2 1 879 864 MUX2 $T=306280 316400 1 0 $X=306280 $Y=310980
X1977 847 858 2 1 880 827 MUX2 $T=306280 326480 0 0 $X=306280 $Y=326100
X1978 868 858 2 1 883 62 MUX2 $T=306280 356720 1 0 $X=306280 $Y=351300
X1979 870 66 2 1 882 879 MUX2 $T=306900 296240 1 0 $X=306900 $Y=290820
X1980 864 55 2 1 900 847 MUX2 $T=307520 326480 1 0 $X=307520 $Y=321060
X1981 884 66 2 1 892 860 MUX2 $T=310620 306320 0 0 $X=310620 $Y=305940
X1982 880 66 2 1 885 876 MUX2 $T=315580 336560 0 180 $X=311240 $Y=331140
X1983 879 66 2 1 902 880 MUX2 $T=311860 326480 0 0 $X=311860 $Y=326100
X1984 878 66 2 1 903 867 MUX2 $T=312480 316400 1 0 $X=312480 $Y=310980
X1985 888 890 2 1 895 902 MUX2 $T=313100 286160 1 0 $X=313100 $Y=280740
X1986 860 66 2 1 904 857 MUX2 $T=313100 316400 0 0 $X=313100 $Y=316020
X1987 886 69 2 1 74 62 MUX2 $T=314960 356720 0 0 $X=314960 $Y=356340
X1988 893 890 2 1 73 903 MUX2 $T=315580 286160 0 0 $X=315580 $Y=285780
X1989 882 890 2 1 910 885 MUX2 $T=316200 296240 1 0 $X=316200 $Y=290820
X1990 871 66 2 1 907 900 MUX2 $T=316200 306320 0 0 $X=316200 $Y=305940
X1991 867 66 2 1 914 865 MUX2 $T=317440 326480 1 0 $X=317440 $Y=321060
X1992 892 890 2 1 919 897 MUX2 $T=319300 306320 1 0 $X=319300 $Y=300900
X1993 900 66 2 1 923 881 MUX2 $T=319920 316400 0 0 $X=319920 $Y=316020
X1994 911 890 2 1 921 904 MUX2 $T=320540 296240 1 0 $X=320540 $Y=290820
X1995 887 69 2 1 81 62 MUX2 $T=320540 356720 0 0 $X=320540 $Y=356340
X1996 875 890 2 1 922 914 MUX2 $T=321160 286160 1 0 $X=321160 $Y=280740
X1997 903 890 2 1 934 912 MUX2 $T=321160 316400 1 0 $X=321160 $Y=310980
X1998 907 890 2 1 931 915 MUX2 $T=321780 306320 0 0 $X=321780 $Y=305940
X1999 902 69 2 1 937 887 MUX2 $T=323020 326480 1 0 $X=323020 $Y=321060
X2000 912 69 2 1 83 62 MUX2 $T=323020 356720 1 0 $X=323020 $Y=351300
X2001 915 69 2 1 939 62 MUX2 $T=324260 346640 0 0 $X=324260 $Y=346260
X2002 896 890 2 1 933 923 MUX2 $T=324880 306320 1 0 $X=324880 $Y=300900
X2003 1062 105 2 1 1077 1066 MUX2 $T=361460 326480 1 0 $X=361460 $Y=321060
X2004 1070 105 2 1 1089 1084 MUX2 $T=363320 296240 1 0 $X=363320 $Y=290820
X2005 1069 105 2 1 1103 1061 MUX2 $T=367660 306320 1 0 $X=367660 $Y=300900
X2006 1055 114 2 1 1105 1089 MUX2 $T=369520 296240 1 0 $X=369520 $Y=290820
X2007 1099 114 2 1 1124 1102 MUX2 $T=372620 316400 0 0 $X=372620 $Y=316020
X2008 1092 114 2 1 1127 1104 MUX2 $T=375100 296240 1 0 $X=375100 $Y=290820
X2009 1116 1115 2 1 1129 1093 MUX2 $T=376960 346640 1 0 $X=376960 $Y=341220
X2010 1104 114 2 1 1140 1076 MUX2 $T=379440 306320 1 0 $X=379440 $Y=300900
X2011 1144 1139 2 1 1152 1145 MUX2 $T=383780 316400 0 0 $X=383780 $Y=316020
X2012 1145 1139 2 1 1155 1093 MUX2 $T=383780 326480 0 0 $X=383780 $Y=326100
X2013 1147 1139 2 1 128 1144 MUX2 $T=385020 286160 1 0 $X=385020 $Y=280740
X2014 1143 119 2 1 1170 1140 MUX2 $T=385020 296240 1 0 $X=385020 $Y=290820
X2015 1140 119 2 1 1144 1141 MUX2 $T=389980 306320 0 180 $X=385640 $Y=300900
X2016 1157 1139 2 1 1142 1093 MUX2 $T=392460 336560 1 180 $X=388120 $Y=336180
X2017 1127 119 2 1 1171 1131 MUX2 $T=389360 296240 0 0 $X=389360 $Y=295860
X2018 1161 119 2 1 1163 1121 MUX2 $T=390600 286160 0 0 $X=390600 $Y=285780
X2019 1162 1139 2 1 1172 1150 MUX2 $T=391840 276080 0 0 $X=391840 $Y=275700
X2020 1121 119 2 1 1175 1113 MUX2 $T=391840 306320 1 0 $X=391840 $Y=300900
X2021 1113 119 2 1 1181 1117 MUX2 $T=394320 306320 0 0 $X=394320 $Y=305940
X2022 1165 1139 2 1 1178 1093 MUX2 $T=394940 326480 0 0 $X=394940 $Y=326100
X2023 1154 1139 2 1 1188 1135 MUX2 $T=395560 296240 0 0 $X=395560 $Y=295860
X2024 1170 1139 2 1 1187 1156 MUX2 $T=396800 286160 0 0 $X=396800 $Y=285780
X2025 1175 1139 2 1 1203 1165 MUX2 $T=399900 306320 0 0 $X=399900 $Y=305940
X2026 1164 1139 2 1 1195 1093 MUX2 $T=399900 326480 0 0 $X=399900 $Y=326100
X2027 1135 1139 2 1 1198 1167 MUX2 $T=400520 336560 1 0 $X=400520 $Y=331140
X2028 1163 1139 2 1 1211 1181 MUX2 $T=402380 286160 0 0 $X=402380 $Y=285780
X2029 1412 1414 2 1 1425 1423 MUX2 $T=465000 296240 0 0 $X=465000 $Y=295860
X2030 1431 1414 2 1 1416 1417 MUX2 $T=470580 286160 1 180 $X=466240 $Y=285780
X2031 1434 1414 2 1 1420 1418 MUX2 $T=471820 326480 0 180 $X=467480 $Y=321060
X2032 1418 1414 2 1 1438 1427 MUX2 $T=468100 326480 0 0 $X=468100 $Y=326100
X2033 1422 1414 2 1 1439 1434 MUX2 $T=468720 316400 0 0 $X=468720 $Y=316020
X2034 1427 1414 2 1 1446 1415 MUX2 $T=469960 336560 1 0 $X=469960 $Y=331140
X2035 1443 197 2 1 1433 1429 MUX2 $T=474920 286160 1 180 $X=470580 $Y=285780
X2036 1438 197 2 1 1448 1441 MUX2 $T=473060 326480 0 0 $X=473060 $Y=326100
X2037 1429 197 2 1 1455 1425 MUX2 $T=473680 296240 1 0 $X=473680 $Y=290820
X2038 1442 197 2 1 1453 205 MUX2 $T=473680 356720 0 0 $X=473680 $Y=356340
X2039 1445 197 2 1 1463 1435 MUX2 $T=476780 296240 0 0 $X=476780 $Y=295860
X2040 1420 197 2 1 1458 1446 MUX2 $T=477400 326480 1 0 $X=477400 $Y=321060
X2041 1435 197 2 1 1470 1439 MUX2 $T=478640 306320 0 0 $X=478640 $Y=305940
X2042 1439 197 2 1 1464 1438 MUX2 $T=478640 316400 0 0 $X=478640 $Y=316020
X2043 1451 1459 2 1 1468 1458 MUX2 $T=479260 316400 1 0 $X=479260 $Y=310980
X2044 202 197 2 1 1466 208 MUX2 $T=479260 346640 1 0 $X=479260 $Y=341220
X2045 205 197 2 1 1467 208 MUX2 $T=479260 356720 0 0 $X=479260 $Y=356340
X2046 1461 203 2 1 213 1471 MUX2 $T=481740 266000 0 0 $X=481740 $Y=265620
X2047 1449 203 2 1 1475 1468 MUX2 $T=482980 276080 1 0 $X=482980 $Y=270660
X2048 1460 196 2 1 1476 1455 MUX2 $T=482980 276080 0 0 $X=482980 $Y=275700
X2049 1456 1459 2 1 1480 1462 MUX2 $T=484220 316400 0 0 $X=484220 $Y=316020
X2050 209 196 2 1 1484 1470 MUX2 $T=484840 296240 1 0 $X=484840 $Y=290820
X2051 1464 1459 2 1 1486 1452 MUX2 $T=484840 326480 1 0 $X=484840 $Y=321060
X2052 1474 216 2 1 212 208 MUX2 $T=489180 356720 1 180 $X=484840 $Y=356340
X2053 1484 203 2 1 1497 1477 MUX2 $T=489180 306320 1 0 $X=489180 $Y=300900
X2054 1471 203 2 1 1492 1472 MUX2 $T=489180 306320 0 0 $X=489180 $Y=305940
X2055 1483 203 2 1 1503 1479 MUX2 $T=489800 276080 1 0 $X=489800 $Y=270660
X2056 214 203 2 1 1494 1486 MUX2 $T=489800 286160 0 0 $X=489800 $Y=285780
X2057 210 203 2 1 1493 1465 MUX2 $T=489800 296240 0 0 $X=489800 $Y=295860
X2058 1485 203 2 1 1496 211 MUX2 $T=489800 316400 1 0 $X=489800 $Y=310980
X2059 1477 216 2 1 1524 208 MUX2 $T=490420 346640 1 0 $X=490420 $Y=341220
X2060 1472 216 2 1 218 208 MUX2 $T=491040 356720 1 0 $X=491040 $Y=351300
X2061 1587 1580 2 1 1565 1558 MUX2 $T=518940 326480 1 180 $X=514600 $Y=326100
X2062 1569 234 2 1 1595 1560 MUX2 $T=516460 296240 0 0 $X=516460 $Y=295860
X2063 1570 1580 2 1 1594 1568 MUX2 $T=516460 336560 1 0 $X=516460 $Y=331140
X2064 1560 234 2 1 1604 1582 MUX2 $T=518940 306320 1 0 $X=518940 $Y=300900
X2065 1582 234 2 1 1614 1583 MUX2 $T=518940 306320 0 0 $X=518940 $Y=305940
X2066 1583 234 2 1 1603 1589 MUX2 $T=520180 316400 1 0 $X=520180 $Y=310980
X2067 1589 234 2 1 1612 1587 MUX2 $T=520180 326480 1 0 $X=520180 $Y=321060
X2068 1558 1580 2 1 1613 1590 MUX2 $T=520180 326480 0 0 $X=520180 $Y=326100
X2069 1595 242 2 1 1616 1614 MUX2 $T=522040 296240 0 0 $X=522040 $Y=295860
X2070 1590 1580 2 1 1615 1570 MUX2 $T=522040 336560 1 0 $X=522040 $Y=331140
X2071 1604 242 2 1 1622 1603 MUX2 $T=524520 306320 1 0 $X=524520 $Y=300900
X2072 1614 242 2 1 1618 1612 MUX2 $T=525140 316400 1 0 $X=525140 $Y=310980
X2073 1563 242 2 1 1625 1604 MUX2 $T=525760 286160 0 0 $X=525760 $Y=285780
X2074 1627 246 2 1 1617 1618 MUX2 $T=530720 296240 1 180 $X=526380 $Y=295860
X2075 1615 242 2 1 1630 1609 MUX2 $T=526380 326480 0 0 $X=526380 $Y=326100
X2076 244 1580 2 1 1624 248 MUX2 $T=526380 356720 0 0 $X=526380 $Y=356340
X2077 1620 242 2 1 1637 1624 MUX2 $T=528240 346640 0 0 $X=528240 $Y=346260
X2078 1624 242 2 1 1640 248 MUX2 $T=528860 356720 1 0 $X=528860 $Y=351300
X2079 1625 246 2 1 1639 1628 MUX2 $T=530100 306320 1 0 $X=530100 $Y=300900
X2080 1613 242 2 1 1642 1594 MUX2 $T=531340 326480 0 0 $X=531340 $Y=326100
X2081 1608 242 2 1 1643 248 MUX2 $T=531340 336560 0 0 $X=531340 $Y=336180
X2082 1612 242 2 1 1652 1613 MUX2 $T=531960 326480 1 0 $X=531960 $Y=321060
X2083 1638 256 2 1 247 248 MUX2 $T=536300 356720 1 180 $X=531960 $Y=356340
X2084 1635 246 2 1 1649 1616 MUX2 $T=532580 286160 1 0 $X=532580 $Y=280740
X2085 1636 246 2 1 1653 1622 MUX2 $T=533200 296240 1 0 $X=533200 $Y=290820
X2086 1617 1655 2 1 1664 1665 MUX2 $T=537540 296240 0 0 $X=537540 $Y=295860
X2087 1647 1655 2 1 260 1663 MUX2 $T=538160 286160 1 0 $X=538160 $Y=280740
X2088 1639 1655 2 1 1670 1662 MUX2 $T=539400 306320 1 0 $X=539400 $Y=300900
X2089 1665 256 2 1 1657 1656 MUX2 $T=543740 356720 0 180 $X=539400 $Y=351300
X2090 1659 1655 2 1 261 1641 MUX2 $T=540020 286160 0 0 $X=540020 $Y=285780
X2091 1660 256 2 1 1672 248 MUX2 $T=540020 356720 0 0 $X=540020 $Y=356340
X2092 1661 1655 2 1 263 1645 MUX2 $T=541260 296240 1 0 $X=541260 $Y=290820
X2093 1663 1655 2 1 1674 1660 MUX2 $T=541260 306320 0 0 $X=541260 $Y=305940
X2094 1649 1655 2 1 1680 1666 MUX2 $T=543740 286160 1 0 $X=543740 $Y=280740
X2095 1653 1655 2 1 1686 1668 MUX2 $T=543740 296240 0 0 $X=543740 $Y=295860
X2096 1641 1655 2 1 1695 257 MUX2 $T=543740 316400 0 0 $X=543740 $Y=316020
X2097 1662 256 2 1 1673 248 MUX2 $T=543740 346640 1 0 $X=543740 $Y=341220
X2098 1644 1655 2 1 1688 1671 MUX2 $T=544980 286160 0 0 $X=544980 $Y=285780
X2099 1808 286 2 1 1824 1815 MUX2 $T=579080 306320 1 0 $X=579080 $Y=300900
X2100 1650 286 2 1 1823 1808 MUX2 $T=579700 296240 0 0 $X=579700 $Y=295860
X2101 1817 286 2 1 1838 1818 MUX2 $T=582180 326480 1 0 $X=582180 $Y=321060
X2102 1820 286 2 1 1851 1846 MUX2 $T=584660 306320 0 0 $X=584660 $Y=305940
X2103 1825 286 2 1 1833 1817 MUX2 $T=589620 316400 1 180 $X=585280 $Y=316020
X2104 1824 1828 2 1 1854 1851 MUX2 $T=585900 296240 0 0 $X=585900 $Y=295860
X2105 1836 1828 2 1 1840 1824 MUX2 $T=591480 296240 0 180 $X=587140 $Y=290820
X2106 1818 286 2 1 1859 1845 MUX2 $T=587140 326480 1 0 $X=587140 $Y=321060
X2107 1842 1828 2 1 1857 1836 MUX2 $T=587760 286160 0 0 $X=587760 $Y=285780
X2108 1851 1828 2 1 1863 1833 MUX2 $T=589000 306320 0 0 $X=589000 $Y=305940
X2109 1846 286 2 1 1869 1825 MUX2 $T=589620 316400 1 0 $X=589620 $Y=310980
X2110 1823 1828 2 1 1884 1847 MUX2 $T=590860 296240 0 0 $X=590860 $Y=295860
X2111 1847 1828 2 1 1889 1869 MUX2 $T=592720 306320 1 0 $X=592720 $Y=300900
X2112 1833 1828 2 1 1872 1859 MUX2 $T=592720 326480 1 0 $X=592720 $Y=321060
X2113 1861 1858 2 1 1892 1840 MUX2 $T=593960 286160 1 0 $X=593960 $Y=280740
X2114 1838 1828 2 1 1885 1864 MUX2 $T=593960 316400 0 0 $X=593960 $Y=316020
X2115 1869 1828 2 1 1886 1838 MUX2 $T=595200 316400 1 0 $X=595200 $Y=310980
X2116 1854 1858 2 1 1887 1872 MUX2 $T=595820 306320 0 0 $X=595820 $Y=305940
X2117 1843 286 2 1 1882 1844 MUX2 $T=597060 346640 0 0 $X=597060 $Y=346260
X2118 1880 1858 2 1 1891 1884 MUX2 $T=598300 286160 0 0 $X=598300 $Y=285780
X2119 1840 1858 2 1 1906 1863 MUX2 $T=599540 296240 1 0 $X=599540 $Y=290820
X2120 1886 1858 2 1 1900 1875 MUX2 $T=600160 316400 0 0 $X=600160 $Y=316020
X2121 1863 1858 2 1 1902 1871 MUX2 $T=600780 316400 1 0 $X=600780 $Y=310980
X2122 1912 1909 2 1 1893 1844 MUX2 $T=608220 336560 1 180 $X=603880 $Y=336180
X2123 1891 1901 2 1 1917 1900 MUX2 $T=604500 286160 0 0 $X=604500 $Y=285780
X2124 1879 1901 2 1 323 1887 MUX2 $T=605120 266000 0 0 $X=605120 $Y=265620
X2125 1905 1901 2 1 1920 1913 MUX2 $T=605740 276080 0 0 $X=605740 $Y=275700
X2126 1911 1909 2 1 1921 1915 MUX2 $T=606980 306320 1 0 $X=606980 $Y=300900
X2127 1906 1901 2 1 1926 1925 MUX2 $T=608220 296240 1 0 $X=608220 $Y=290820
X2128 1915 1909 2 1 1916 1844 MUX2 $T=608840 336560 0 0 $X=608840 $Y=336180
X2129 1877 1901 2 1 1933 1914 MUX2 $T=610080 286160 0 0 $X=610080 $Y=285780
X2130 1892 1901 2 1 1948 1902 MUX2 $T=611940 276080 0 0 $X=611940 $Y=275700
X2131 1925 1909 2 1 1937 1844 MUX2 $T=616280 336560 0 0 $X=616280 $Y=336180
X2132 1919 1909 2 1 1963 1844 MUX2 $T=617520 326480 1 0 $X=617520 $Y=321060
X2133 1914 1909 2 1 1988 1938 MUX2 $T=621860 336560 0 0 $X=621860 $Y=336180
X2134 361 359 2 1 2168 2183 MUX2 $T=686340 346640 0 180 $X=682000 $Y=341220
X2135 699 2 991 1019 1 AN2B1S $T=344100 336560 0 0 $X=344100 $Y=336180
X2136 1266 2 1269 1276 1 AN2B1S $T=419120 316400 0 0 $X=419120 $Y=316020
X2137 1231 2 1282 1293 1 AN2B1S $T=422220 336560 0 0 $X=422220 $Y=336180
X2138 1281 2 1276 1298 1 AN2B1S $T=423460 316400 1 0 $X=423460 $Y=310980
X2139 1277 2 1293 1309 1 AN2B1S $T=423460 336560 1 0 $X=423460 $Y=331140
X2140 1255 2 164 1386 1 AN2B1S $T=441440 346640 1 0 $X=441440 $Y=341220
X2141 1555 2 1746 1760 1 AN2B1S $T=561100 346640 1 0 $X=561100 $Y=341220
X2142 1763 2 1760 1776 1 AN2B1S $T=564200 346640 1 0 $X=564200 $Y=341220
X2143 2035 2 345 344 1 AN2B1S $T=642320 266000 1 180 $X=639220 $Y=265620
X2144 2018 2 2036 2032 1 AN2B1S $T=642940 296240 1 180 $X=639840 $Y=295860
X2145 1969 2 2167 2155 1 AN2B1S $T=678900 306320 0 0 $X=678900 $Y=305940
X2146 427 429 1 2 2675 QDLHN $T=905200 336560 0 0 $X=905200 $Y=336180
X2147 427 436 1 2 2685 QDLHN $T=912640 336560 0 0 $X=912640 $Y=336180
X2148 427 440 1 2 2705 QDLHN $T=920700 346640 1 0 $X=920700 $Y=341220
X2149 137 1151 2 125 136 1 122 FA1 $T=397420 356720 1 180 $X=381920 $Y=356340
X2150 161 1248 2 154 1340 1 1263 FA1 $T=434000 346640 1 180 $X=418500 $Y=346260
X2151 288 1744 2 1566 1795 1 279 FA1 $T=580940 356720 1 180 $X=565440 $Y=356340
X2152 1839 1724 2 1584 1826 1 1795 FA1 $T=587140 356720 0 180 $X=571640 $Y=351300
X2153 311 1910 2 322 1918 1 325 FA1 $T=596440 356720 0 0 $X=596440 $Y=356340
X2154 2130 2006 2 2094 2124 1 2066 FA1 $T=665260 316400 0 180 $X=649760 $Y=310980
X2155 1030 1039 1024 1038 1 2 ND3P $T=347200 316400 0 0 $X=347200 $Y=316020
X2156 1051 1029 1043 1031 1 2 ND3P $T=358360 326480 1 180 $X=353400 $Y=326100
X2157 1280 1305 1292 1295 1 2 ND3P $T=420980 306320 1 0 $X=420980 $Y=300900
X2158 1316 1299 1321 1330 1 2 ND3P $T=426560 316400 1 0 $X=426560 $Y=310980
X2159 1369 1379 1371 1358 1 2 ND3P $T=435860 306320 1 0 $X=435860 $Y=300900
X2160 1388 1346 1393 1383 1 2 ND3P $T=447640 346640 1 180 $X=442680 $Y=346260
X2161 1404 1399 1397 1394 1 2 ND3P $T=456940 336560 1 180 $X=451980 $Y=336180
X2162 1563 1581 1586 236 1 2 ND3P $T=522660 286160 0 180 $X=517700 $Y=280740
X2163 1804 1801 1794 1799 1 2 ND3P $T=572880 326480 0 0 $X=572880 $Y=326100
X2164 1975 328 1973 1983 1 2 ND3P $T=622480 356720 1 0 $X=622480 $Y=351300
X2165 2030 2037 2058 2033 1 2 ND3P $T=646040 316400 0 180 $X=641080 $Y=310980
X2166 2078 2054 2100 2088 1 2 ND3P $T=657200 286160 1 180 $X=652240 $Y=285780
X2167 2119 2108 2121 2107 1 2 ND3P $T=664640 336560 0 180 $X=659680 $Y=331140
X2168 2149 2118 2146 2144 1 2 ND3P $T=672700 316400 1 180 $X=667740 $Y=316020
X2169 1747 1574 1772 1 2 OR2P $T=569780 346640 1 180 $X=566060 $Y=346260
X2170 2077 1780 2142 1 2 OR2P $T=673940 266000 1 180 $X=670220 $Y=265620
X2171 719 975 1 989 2 OR2B1S $T=342240 276080 0 0 $X=342240 $Y=275700
X2172 702 1013 1 1016 2 OR2B1S $T=344720 326480 0 0 $X=344720 $Y=326100
X2173 1122 1112 1 1134 2 OR2B1S $T=379440 266000 1 0 $X=379440 $Y=260580
X2174 1287 1306 1 1311 2 OR2B1S $T=425320 336560 0 0 $X=425320 $Y=336180
X2175 1551 1738 1 1752 2 OR2B1S $T=559860 336560 1 0 $X=559860 $Y=331140
X2176 1555 1746 1 1763 2 OR2B1S $T=561100 346640 0 0 $X=561100 $Y=346260
X2177 345 346 1 347 2 OR2B1S $T=641080 266000 1 0 $X=641080 $Y=260580
X2178 2069 2081 1 2093 2 OR2B1S $T=650380 296240 0 0 $X=650380 $Y=295860
X2179 2012 2126 1 2132 2 OR2B1S $T=662780 296240 1 0 $X=662780 $Y=290820
X2180 23 80 75 2 1 87 XOR3 $T=324260 266000 1 0 $X=324260 $Y=260580
X2181 698 971 979 2 1 1042 XOR3 $T=341620 296240 0 0 $X=341620 $Y=295860
X2182 696 974 1027 2 1 1046 XOR3 $T=343480 266000 0 0 $X=343480 $Y=265620
X2183 708 1021 997 2 1 1054 XOR3 $T=345960 306320 1 0 $X=345960 $Y=300900
X2184 688 964 1015 2 1 1053 XOR3 $T=346580 286160 0 0 $X=346580 $Y=285780
X2185 691 980 1049 2 1 1058 XOR3 $T=348440 296240 1 0 $X=348440 $Y=290820
X2186 693 1007 1032 2 1 109 XOR3 $T=354640 346640 0 0 $X=354640 $Y=346260
X2187 703 993 1044 2 1 1083 XOR3 $T=355880 346640 1 0 $X=355880 $Y=341220
X2188 1179 139 1177 2 1 149 XOR3 $T=402380 356720 0 0 $X=402380 $Y=356340
X2189 1241 1053 1291 2 1 1296 XOR3 $T=414160 286160 1 0 $X=414160 $Y=280740
X2190 1254 1301 1304 2 1 1356 XOR3 $T=424700 286160 0 0 $X=424700 $Y=285780
X2191 1278 1320 160 2 1 1377 XOR3 $T=435240 276080 1 0 $X=435240 $Y=270660
X2192 1362 1050 1373 2 1 1391 XOR3 $T=435860 326480 1 0 $X=435860 $Y=321060
X2193 1356 1372 1350 2 1 1400 XOR3 $T=437720 296240 1 0 $X=437720 $Y=290820
X2194 1341 1083 1363 2 1 172 XOR3 $T=440200 356720 0 0 $X=440200 $Y=356340
X2195 1270 1368 1374 2 1 1241 XOR3 $T=451980 286160 0 180 $X=440820 $Y=280740
X2196 1377 1046 171 2 1 1408 XOR3 $T=441440 266000 0 0 $X=441440 $Y=265620
X2197 1332 1086 1381 2 1 1402 XOR3 $T=441440 316400 1 0 $X=441440 $Y=310980
X2198 1042 1345 1390 2 1 1410 XOR3 $T=447020 306320 1 0 $X=447020 $Y=300900
X2199 1240 1392 1338 2 1 1318 XOR3 $T=458800 276080 1 180 $X=447640 $Y=275700
X2200 166 158 170 2 1 167 XOR3 $T=459420 266000 0 180 $X=448260 $Y=260580
X2201 1382 1063 1406 2 1 1407 XOR3 $T=448880 326480 0 0 $X=448880 $Y=326100
X2202 1553 273 270 2 1 280 XOR3 $T=556760 266000 0 0 $X=556760 $Y=265620
X2203 1710 1557 1721 2 1 283 XOR3 $T=562340 276080 1 0 $X=562340 $Y=270660
X2204 1745 1561 1757 2 1 1812 XOR3 $T=569780 306320 0 0 $X=569780 $Y=305940
X2205 1779 1611 1783 2 1 1813 XOR3 $T=569780 316400 0 0 $X=569780 $Y=316020
X2206 1751 1564 1766 2 1 1816 XOR3 $T=570400 316400 1 0 $X=570400 $Y=310980
X2207 1713 1559 1729 2 1 1803 XOR3 $T=571020 286160 0 0 $X=571020 $Y=285780
X2208 1727 1548 1732 2 1 1830 XOR3 $T=574120 296240 1 0 $X=574120 $Y=290820
X2209 1791 1550 1801 2 1 1841 XOR3 $T=576600 336560 1 0 $X=576600 $Y=331140
X2210 1942 332 333 2 1 338 XOR3 $T=618760 356720 0 0 $X=618760 $Y=356340
X2211 337 1839 2021 2 1 2031 XOR3 $T=629300 346640 0 0 $X=629300 $Y=346260
X2212 1995 1816 2029 2 1 2034 XOR3 $T=629920 326480 1 0 $X=629920 $Y=321060
X2213 2041 1805 2089 2 1 350 XOR3 $T=642940 356720 0 0 $X=642940 $Y=356340
X2214 2023 1812 2098 2 1 2103 XOR3 $T=646660 306320 0 0 $X=646660 $Y=305940
X2215 2076 2017 2025 2 1 2115 XOR3 $T=650380 276080 0 0 $X=650380 $Y=275700
X2216 2102 1831 2145 2 1 2147 XOR3 $T=661540 356720 0 0 $X=661540 $Y=356340
X2217 2091 1841 2139 2 1 2151 XOR3 $T=664020 326480 0 0 $X=664020 $Y=326100
X2218 2130 1813 2174 2 1 2164 XOR3 $T=674560 316400 1 0 $X=674560 $Y=310980
X2219 2052 1778 2175 2 1 2203 XOR3 $T=682000 296240 0 0 $X=682000 $Y=295860
X2220 2115 1830 2200 2 1 2205 XOR3 $T=683860 286160 0 0 $X=683860 $Y=285780
X2221 806 791 1 731 2 NR2T $T=282100 276080 1 180 $X=277140 $Y=275700
X2222 804 811 1 30 2 NR2T $T=283340 296240 0 0 $X=283340 $Y=295860
X2223 831 36 1 45 2 NR2T $T=294500 316400 0 180 $X=289540 $Y=310980
X2224 810 859 1 830 2 NR2T $T=297600 286160 1 0 $X=297600 $Y=280740
X2225 1065 811 1 103 2 NR2T $T=360840 296240 1 180 $X=355880 $Y=295860
X2226 1088 1068 1 1101 2 NR2T $T=370140 276080 0 0 $X=370140 $Y=275700
X2227 207 1436 1 198 2 NR2T $T=474920 266000 1 0 $X=474920 $Y=260580
X2228 1592 1511 1 230 2 NR2T $T=520800 296240 0 180 $X=515840 $Y=290820
X2229 240 1600 1 1588 2 NR2T $T=525140 276080 0 0 $X=525140 $Y=275700
X2230 1697 1511 1 251 2 NR2T $T=551800 296240 0 180 $X=546840 $Y=290820
X2231 1623 238 1 1606 249 254 2 MOAI1H $T=528860 266000 1 0 $X=528860 $Y=260580
X2232 971 698 2 979 988 971 1 AOI22H $T=335420 296240 1 0 $X=335420 $Y=290820
X2233 974 696 2 920 962 974 1 AOI22H $T=336040 266000 0 0 $X=336040 $Y=265620
X2234 980 691 2 995 1002 980 1 AOI22H $T=337280 286160 0 0 $X=337280 $Y=285780
X2235 964 688 2 1015 1040 964 1 AOI22H $T=346580 286160 1 0 $X=346580 $Y=280740
X2236 1241 1053 2 1264 1265 1053 1 AOI22H $T=414780 276080 0 0 $X=414780 $Y=275700
X2237 1320 1278 2 160 1342 1320 1 AOI22H $T=428420 266000 0 0 $X=428420 $Y=265620
X2238 1377 1046 2 163 1361 1046 1 AOI22H $T=441440 266000 0 180 $X=434000 $Y=260580
X2239 1341 1083 2 1346 1370 1083 1 AOI22H $T=443300 356720 0 180 $X=435860 $Y=351300
X2240 1368 1270 2 1374 1364 1368 1 AOI22H $T=444540 286160 1 180 $X=437100 $Y=285780
X2241 1362 1050 2 1348 1385 1050 1 AOI22H $T=448880 326480 1 180 $X=441440 $Y=326100
X2242 1392 1240 2 1338 1389 1392 1 AOI22H $T=453840 276080 0 180 $X=446400 $Y=270660
X2243 242 1605 2 1595 1598 241 1 AOI22H $T=528240 296240 0 180 $X=520800 $Y=290820
X2244 1710 1557 2 1721 1728 1557 1 AOI22H $T=553040 276080 0 0 $X=553040 $Y=275700
X2245 273 1553 2 270 1718 1553 1 AOI22H $T=561720 266000 0 180 $X=554280 $Y=260580
X2246 1743 1545 2 1750 1761 1545 1 AOI22H $T=560480 306320 1 0 $X=560480 $Y=300900
X2247 1745 1561 2 1757 1768 1561 1 AOI22H $T=560480 306320 0 0 $X=560480 $Y=305940
X2248 1751 1564 2 1766 1774 1564 1 AOI22H $T=561100 316400 1 0 $X=561100 $Y=310980
X2249 1727 1548 2 1732 1748 1548 1 AOI22H $T=562960 296240 1 0 $X=562960 $Y=290820
X2250 1713 1559 2 1729 1749 1559 1 AOI22H $T=571020 286160 1 180 $X=563580 $Y=285780
X2251 1992 1977 2 2002 2004 1992 1 AOI22H $T=629300 286160 1 0 $X=629300 $Y=280740
X2252 2068 1986 2 2061 2044 2068 1 AOI22H $T=646040 276080 1 0 $X=646040 $Y=270660
X2253 2077 1780 2 2109 2112 1780 1 AOI22H $T=655960 266000 0 0 $X=655960 $Y=265620
X2254 2024 1806 2 2116 2131 1806 1 AOI22H $T=670840 276080 1 180 $X=663400 $Y=275700
X2255 2024 1806 2 2172 2181 1806 1 AOI22H $T=677040 276080 0 0 $X=677040 $Y=275700
X2256 675 1 686 688 2 ND2P $T=244280 286160 0 180 $X=240560 $Y=280740
X2257 694 1 689 702 2 ND2P $T=246760 326480 1 180 $X=243040 $Y=326100
X2258 695 1 700 699 2 ND2P $T=246760 336560 1 180 $X=243040 $Y=336180
X2259 710 1 697 719 2 ND2P $T=251720 276080 1 180 $X=248000 $Y=275700
X2260 27 1 804 799 2 ND2P $T=279620 296240 1 0 $X=279620 $Y=290820
X2261 31 1 785 791 2 ND2P $T=282720 286160 0 0 $X=282720 $Y=285780
X2262 828 1 835 814 2 ND2P $T=293260 296240 0 0 $X=293260 $Y=295860
X2263 839 1 849 861 2 ND2P $T=303800 306320 0 180 $X=300080 $Y=300900
X2264 848 1 861 859 2 ND2P $T=300700 286160 0 0 $X=300700 $Y=285780
X2265 909 1 77 920 2 ND2P $T=320540 266000 1 0 $X=320540 $Y=260580
X2266 955 1 962 970 2 ND2P $T=332320 266000 0 0 $X=332320 $Y=265620
X2267 978 1 988 997 2 ND2P $T=337900 296240 0 0 $X=337900 $Y=295860
X2268 1000 1 977 1005 2 ND2P $T=344100 286160 0 180 $X=340380 $Y=280740
X2269 1003 1 996 999 2 ND2P $T=344720 346640 0 180 $X=341000 $Y=341220
X2270 1011 1 1002 979 2 ND2P $T=346580 296240 0 180 $X=342860 $Y=290820
X2271 1028 1 1020 99 2 ND2P $T=349680 356720 1 180 $X=345960 $Y=356340
X2272 1014 1 1017 1015 2 ND2P $T=347200 276080 0 0 $X=347200 $Y=275700
X2273 1037 1 1026 1034 2 ND2P $T=351540 326480 1 180 $X=347820 $Y=326100
X2274 1010 1 1040 995 2 ND2P $T=354020 286160 1 0 $X=354020 $Y=280740
X2275 1034 1 1006 1056 2 ND2P $T=359600 336560 1 180 $X=355880 $Y=336180
X2276 106 1 1067 1072 2 ND2P $T=363320 266000 1 180 $X=359600 $Y=265620
X2277 1078 1 1072 107 2 ND2P $T=367040 266000 1 180 $X=363320 $Y=265620
X2278 1073 1 1079 1092 2 ND2P $T=368280 286160 1 180 $X=364560 $Y=285780
X2279 1059 1 1092 1097 2 ND2P $T=373860 286160 1 180 $X=370140 $Y=285780
X2280 120 1 1133 1101 2 ND2P $T=380060 276080 0 0 $X=380060 $Y=275700
X2281 131 1 135 130 2 ND2P $T=392460 356720 1 0 $X=392460 $Y=351300
X2282 1258 1 1253 1251 2 ND2P $T=419120 316400 1 180 $X=415400 $Y=316020
X2283 1260 1 1267 1273 2 ND2P $T=417880 336560 1 0 $X=417880 $Y=331140
X2284 1228 1 1259 1287 2 ND2P $T=422220 326480 0 180 $X=418500 $Y=321060
X2285 1274 1 1251 1303 2 ND2P $T=424080 326480 1 180 $X=420360 $Y=326100
X2286 1284 1 1265 1285 2 ND2P $T=424700 286160 1 180 $X=420980 $Y=285780
X2287 157 1 1288 1308 2 ND2P $T=427180 346640 0 180 $X=423460 $Y=341220
X2288 1289 1 1300 1264 2 ND2P $T=424080 276080 0 0 $X=424080 $Y=275700
X2289 1317 1 1303 1271 2 ND2P $T=429660 326480 0 180 $X=425940 $Y=321060
X2290 1333 1 1319 1327 2 ND2P $T=432140 336560 1 180 $X=428420 $Y=336180
X2291 1343 1 1342 1338 2 ND2P $T=435240 276080 0 180 $X=431520 $Y=270660
X2292 1365 1 1354 1348 2 ND2P $T=437720 316400 0 180 $X=434000 $Y=310980
X2293 1353 1 1324 1300 2 ND2P $T=434620 276080 0 0 $X=434620 $Y=275700
X2294 1365 1 1354 1373 2 ND2P $T=438340 306320 1 180 $X=434620 $Y=305940
X2295 1359 1 1364 1304 2 ND2P $T=435240 286160 1 0 $X=435240 $Y=280740
X2296 1355 1 1370 162 2 ND2P $T=436480 356720 0 0 $X=436480 $Y=356340
X2297 1378 1 1361 1353 2 ND2P $T=441440 266000 1 180 $X=437720 $Y=265620
X2298 1332 1 1366 1365 2 ND2P $T=437720 316400 1 0 $X=437720 $Y=310980
X2299 1345 1 1379 1344 2 ND2P $T=440820 306320 1 0 $X=440820 $Y=300900
X2300 1042 1 1379 1360 2 ND2P $T=442680 306320 0 0 $X=442680 $Y=305940
X2301 1384 1 1389 1374 2 ND2P $T=443920 276080 0 0 $X=443920 $Y=275700
X2302 1395 1 1385 1398 2 ND2P $T=450740 326480 0 180 $X=447020 $Y=321060
X2303 1362 1 1373 1395 2 ND2P $T=447640 316400 0 0 $X=447640 $Y=316020
X2304 999 1 1399 1393 2 ND2P $T=451360 346640 1 0 $X=451360 $Y=341220
X2305 194 1 1430 198 2 ND2P $T=472440 266000 0 180 $X=468720 $Y=260580
X2306 192 1 1416 1436 2 ND2P $T=468720 276080 1 0 $X=468720 $Y=270660
X2307 192 1 1443 206 2 ND2P $T=478020 276080 1 180 $X=474300 $Y=275700
X2308 1576 1 1562 1563 2 ND2P $T=517700 286160 1 180 $X=513980 $Y=285780
X2309 234 1 1592 1576 2 ND2P $T=517700 286160 0 0 $X=517700 $Y=285780
X2310 236 1 1605 1600 2 ND2P $T=528240 286160 0 180 $X=524520 $Y=280740
X2311 252 1 1654 1588 2 ND2P $T=536300 276080 1 0 $X=536300 $Y=270660
X2312 1700 1 1718 1721 2 ND2P $T=553040 266000 0 0 $X=553040 $Y=265620
X2313 1742 1 1728 1735 2 ND2P $T=560480 276080 0 180 $X=556760 $Y=270660
X2314 1740 1 1730 1729 2 ND2P $T=561100 286160 0 180 $X=557380 $Y=280740
X2315 1733 1 1748 1750 2 ND2P $T=559240 296240 1 0 $X=559240 $Y=290820
X2316 1737 1 1749 1732 2 ND2P $T=559860 286160 0 0 $X=559860 $Y=285780
X2317 1753 1 1761 1757 2 ND2P $T=562340 296240 0 0 $X=562340 $Y=295860
X2318 1756 1 1762 1770 2 ND2P $T=567300 336560 1 180 $X=563580 $Y=336180
X2319 1782 1 1774 1783 2 ND2P $T=569780 316400 1 180 $X=566060 $Y=316020
X2320 1781 1 1768 1766 2 ND2P $T=567920 306320 1 0 $X=567920 $Y=300900
X2321 1779 1 1783 1794 2 ND2P $T=571640 326480 0 180 $X=567920 $Y=321060
X2322 1772 1 1790 1784 2 ND2P $T=567920 356720 1 0 $X=567920 $Y=351300
X2323 1786 1 1764 1790 2 ND2P $T=569160 346640 1 0 $X=569160 $Y=341220
X2324 1789 1 1775 1802 2 ND2P $T=577220 336560 1 180 $X=573500 $Y=336180
X2325 286 1 1697 1811 2 ND2P $T=583420 286160 0 180 $X=579700 $Y=280740
X2326 1798 1 1784 1826 2 ND2P $T=583420 346640 1 180 $X=579700 $Y=346260
X2327 294 1 291 290 2 ND2P $T=584660 356720 1 180 $X=580940 $Y=356340
X2328 302 1 1821 1855 2 ND2P $T=591480 276080 1 180 $X=587760 $Y=275700
X2329 1839 1 1987 1973 2 ND2P $T=625580 346640 0 0 $X=625580 $Y=346260
X2330 337 1 1987 1975 2 ND2P $T=630540 356720 1 0 $X=630540 $Y=351300
X2331 1816 1 2011 2030 2 ND2P $T=639220 316400 0 180 $X=635500 $Y=310980
X2332 2016 1 2004 2025 2 ND2P $T=642320 286160 1 180 $X=638600 $Y=285780
X2333 2026 1 1812 2015 2 ND2P $T=638600 306320 1 0 $X=638600 $Y=300900
X2334 1995 1 2011 2058 2 ND2P $T=644180 306320 1 180 $X=640460 $Y=305940
X2335 2051 1 2044 2002 2 ND2P $T=644800 276080 1 180 $X=641080 $Y=275700
X2336 2041 1 2048 2040 2 ND2P $T=645420 356720 0 180 $X=641700 $Y=351300
X2337 2049 1 2055 2052 2 ND2P $T=646660 296240 0 180 $X=642940 $Y=290820
X2338 2023 1 2026 2009 2 ND2P $T=642940 306320 1 0 $X=642940 $Y=300900
X2339 2059 1 2062 2038 2 ND2P $T=644180 316400 0 0 $X=644180 $Y=316020
X2340 2060 1 349 2061 2 ND2P $T=644800 266000 0 0 $X=644800 $Y=265620
X2341 2063 1 2070 2084 2 ND2P $T=649140 336560 1 180 $X=645420 $Y=336180
X2342 2067 1 2056 2070 2 ND2P $T=646660 326480 0 0 $X=646660 $Y=326100
X2343 2082 1 2086 2026 2 ND2P $T=649760 306320 1 0 $X=649760 $Y=300900
X2344 2093 1 2090 2097 2 ND2P $T=656580 296240 0 180 $X=652860 $Y=290820
X2345 2080 1 2084 351 2 ND2P $T=654100 346640 1 0 $X=654100 $Y=341220
X2346 2117 1 2110 2120 2 ND2P $T=662780 306320 0 180 $X=659060 $Y=300900
X2347 2102 1 2114 2096 2 ND2P $T=659060 346640 0 0 $X=659060 $Y=346260
X2348 2127 1 353 2109 2 ND2P $T=664020 266000 0 180 $X=660300 $Y=260580
X2349 2123 1 2112 2116 2 ND2P $T=664640 276080 0 180 $X=660920 $Y=270660
X2350 2125 1 2131 2138 2 ND2P $T=663400 286160 0 0 $X=663400 $Y=285780
X2351 2128 1 2135 2124 2 ND2P $T=664020 306320 1 0 $X=664020 $Y=300900
X2352 1830 1 2138 2152 2 ND2P $T=670840 286160 1 180 $X=667120 $Y=285780
X2353 2141 1 357 2148 2 ND2P $T=672080 266000 0 180 $X=668360 $Y=260580
X2354 2160 1 2157 2172 2 ND2P $T=676420 286160 0 180 $X=672700 $Y=280740
X2355 2173 1 2181 2184 2 ND2P $T=684480 286160 0 180 $X=680760 $Y=280740
X2356 2115 1 2184 2158 2 ND2P $T=681380 296240 1 0 $X=681380 $Y=290820
X2357 1567 1754 1735 2 1 1773 XNR3 $T=568540 286160 1 0 $X=568540 $Y=280740
X2358 1545 1743 1750 2 1 1769 XNR3 $T=568540 296240 0 0 $X=568540 $Y=295860
X2359 1977 1992 2002 2 1 2022 XNR3 $T=641700 286160 1 0 $X=641700 $Y=280740
X2360 1986 2068 2061 2 1 2064 XNR3 $T=649140 266000 1 0 $X=649140 $Y=260580
X2361 693 1007 1032 1 2 1012 MAO222 $T=349060 346640 0 0 $X=349060 $Y=346260
X2362 1179 139 1177 1 2 141 MAO222 $T=397420 356720 0 0 $X=397420 $Y=356340
X2363 1942 332 333 1 2 1918 MAO222 $T=613800 356720 0 0 $X=613800 $Y=356340
X2364 1335 1 1344 1360 2 1366 ND3HT $T=430280 296240 0 0 $X=430280 $Y=295860
X2365 2003 1 2009 2015 2 2011 ND3HT $T=632400 306320 0 0 $X=632400 $Y=305940
X2366 2027 1 2053 2040 2 1987 ND3HT $T=647900 346640 1 180 $X=640460 $Y=346260
X2367 2104 1 2122 2113 2 2114 ND3HT $T=657820 346640 1 0 $X=657820 $Y=341220
X2368 2169 1 2158 2152 2 2161 ND3HT $T=678280 286160 1 180 $X=670840 $Y=285780
X2369 98 994 1 1012 1020 2 OAI12H $T=341000 356720 1 0 $X=341000 $Y=351300
X2370 1023 1052 1 1060 110 2 OAI12H $T=355880 356720 1 0 $X=355880 $Y=351300
X2371 1035 770 1 1056 1044 2 OAI12H $T=359600 336560 0 0 $X=359600 $Y=336180
X2372 204 1450 1 1447 209 2 OAI12H $T=478020 286160 0 0 $X=478020 $Y=285780
X2373 2066 2083 1 2079 2091 2 OAI12H $T=647900 316400 0 0 $X=647900 $Y=316020
X2374 971 76 984 2 931 82 1 AO22S $T=346580 306320 1 180 $X=341620 $Y=305940
X2375 1566 227 231 2 218 226 1 AO22S $T=515220 356720 1 180 $X=510260 $Y=356340
X2376 1584 227 1547 2 1524 226 1 AO22S $T=516460 356720 0 180 $X=511500 $Y=351300
X2377 1910 318 1927 2 1916 315 1 AO22S $T=609460 356720 1 0 $X=609460 $Y=351300
X2378 711 10 2 709 1 682 MUX2S $T=251100 336560 1 180 $X=246760 $Y=336180
X2379 704 10 2 714 1 683 MUX2S $T=252340 326480 1 180 $X=248000 $Y=326100
X2380 716 10 2 715 1 679 MUX2S $T=252340 346640 0 180 $X=248000 $Y=341220
X2381 725 723 2 12 1 714 MUX2S $T=252960 336560 0 180 $X=248620 $Y=331140
X2382 732 723 2 12 1 709 MUX2S $T=256060 336560 1 180 $X=251720 $Y=336180
X2383 749 720 2 12 1 701 MUX2S $T=257300 356720 0 180 $X=252960 $Y=351300
X2384 717 723 2 725 1 706 MUX2S $T=257920 326480 1 180 $X=253580 $Y=326100
X2385 728 723 2 732 1 727 MUX2S $T=254200 336560 1 0 $X=254200 $Y=331140
X2386 739 723 2 12 1 715 MUX2S $T=258540 346640 0 180 $X=254200 $Y=341220
X2387 744 723 2 735 1 705 MUX2S $T=261640 336560 1 180 $X=257300 $Y=336180
X2388 748 720 2 736 1 718 MUX2S $T=262260 296240 0 180 $X=257920 $Y=290820
X2389 746 10 2 740 1 685 MUX2S $T=263500 326480 1 180 $X=259160 $Y=326100
X2390 735 723 2 749 1 740 MUX2S $T=259160 346640 0 0 $X=259160 $Y=346260
X2391 741 723 2 739 1 18 MUX2S $T=264120 346640 0 180 $X=259780 $Y=341220
X2392 762 21 2 752 1 725 MUX2S $T=267220 336560 1 180 $X=262880 $Y=336180
X2393 773 21 2 771 1 735 MUX2S $T=274660 346640 1 180 $X=270320 $Y=346260
X2394 754 21 2 773 1 728 MUX2S $T=275280 336560 0 180 $X=270940 $Y=331140
X2395 756 21 2 762 1 741 MUX2S $T=276520 336560 1 180 $X=272180 $Y=336180
X2396 801 27 2 788 1 776 MUX2S $T=279620 316400 0 180 $X=275280 $Y=310980
X2397 767 27 2 789 1 775 MUX2S $T=280240 306320 0 180 $X=275900 $Y=300900
X2398 802 27 2 790 1 762 MUX2S $T=280240 346640 1 180 $X=275900 $Y=346260
X2399 790 27 2 795 1 771 MUX2S $T=280860 356720 0 180 $X=276520 $Y=351300
X2400 807 27 2 798 1 756 MUX2S $T=281480 336560 0 180 $X=277140 $Y=331140
X2401 795 27 2 796 1 752 MUX2S $T=282100 356720 1 180 $X=277760 $Y=356340
X2402 798 27 2 802 1 773 MUX2S $T=282720 346640 0 180 $X=278380 $Y=341220
X2403 818 49 2 809 1 837 MUX2S $T=290780 346640 0 0 $X=290780 $Y=346260
X2404 809 49 2 832 1 844 MUX2S $T=292640 356720 1 0 $X=292640 $Y=351300
X2405 824 49 2 818 1 843 MUX2S $T=293880 346640 1 0 $X=293880 $Y=341220
X2406 832 49 2 58 1 840 MUX2S $T=293880 356720 0 0 $X=293880 $Y=356340
X2407 837 858 2 840 1 838 MUX2S $T=300700 346640 1 180 $X=296360 $Y=346260
X2408 844 858 2 60 1 874 MUX2S $T=299460 346640 1 0 $X=299460 $Y=341220
X2409 852 858 2 837 1 865 MUX2S $T=300080 336560 1 0 $X=300080 $Y=331140
X2410 843 858 2 844 1 876 MUX2S $T=305040 336560 0 0 $X=305040 $Y=336180
X2411 838 66 2 883 1 886 MUX2S $T=307520 346640 0 0 $X=307520 $Y=346260
X2412 876 66 2 873 1 887 MUX2S $T=308140 346640 1 0 $X=308140 $Y=341220
X2413 857 66 2 838 1 897 MUX2S $T=310620 336560 0 0 $X=310620 $Y=336180
X2414 883 66 2 62 1 901 MUX2S $T=311860 356720 1 0 $X=311860 $Y=351300
X2415 873 66 2 62 1 905 MUX2S $T=313100 346640 0 0 $X=313100 $Y=346260
X2416 869 66 2 62 1 906 MUX2S $T=313720 346640 1 0 $X=313720 $Y=341220
X2417 881 66 2 874 1 915 MUX2S $T=316820 336560 1 0 $X=316820 $Y=331140
X2418 865 66 2 869 1 912 MUX2S $T=316820 336560 0 0 $X=316820 $Y=336180
X2419 897 69 2 901 1 916 MUX2S $T=317440 356720 1 0 $X=317440 $Y=351300
X2420 885 69 2 905 1 918 MUX2S $T=318060 346640 0 0 $X=318060 $Y=346260
X2421 914 69 2 906 1 908 MUX2S $T=323640 346640 0 180 $X=319300 $Y=341220
X2422 904 69 2 886 1 927 MUX2S $T=322400 336560 1 0 $X=322400 $Y=331140
X2423 874 66 2 62 1 932 MUX2S $T=322400 336560 0 0 $X=322400 $Y=336180
X2424 923 69 2 932 1 952 MUX2S $T=327360 326480 0 0 $X=327360 $Y=326100
X2425 1061 105 2 1074 1 1076 MUX2S $T=361460 306320 0 0 $X=361460 $Y=305940
X2426 1087 105 2 1082 1 1100 MUX2S $T=367040 336560 1 0 $X=367040 $Y=331140
X2427 1084 105 2 1069 1 1104 MUX2S $T=368280 296240 0 0 $X=368280 $Y=295860
X2428 1082 105 2 1091 1 1106 MUX2S $T=368280 336560 0 0 $X=368280 $Y=336180
X2429 1091 105 2 1098 1 1110 MUX2S $T=370140 346640 1 0 $X=370140 $Y=341220
X2430 1098 105 2 1107 1 1109 MUX2S $T=370760 346640 0 0 $X=370760 $Y=346260
X2431 1102 114 2 1106 1 1117 MUX2S $T=372620 326480 1 0 $X=372620 $Y=321060
X2432 1100 114 2 1110 1 1118 MUX2S $T=372620 326480 0 0 $X=372620 $Y=326100
X2433 1106 114 2 1109 1 1119 MUX2S $T=373240 336560 0 0 $X=373240 $Y=336180
X2434 1107 1115 2 1116 1 1125 MUX2S $T=376960 356720 1 0 $X=376960 $Y=351300
X2435 1124 119 2 1119 1 1135 MUX2S $T=378200 316400 0 0 $X=378200 $Y=316020
X2436 1125 114 2 1093 1 1136 MUX2S $T=378200 326480 1 0 $X=378200 $Y=321060
X2437 1110 114 2 1125 1 1137 MUX2S $T=378200 326480 0 0 $X=378200 $Y=326100
X2438 1109 114 2 1129 1 1138 MUX2S $T=378820 336560 1 0 $X=378820 $Y=331140
X2439 1129 114 2 1093 1 1149 MUX2S $T=383160 336560 0 0 $X=383160 $Y=336180
X2440 1105 119 2 1126 1 1154 MUX2S $T=383780 296240 0 0 $X=383780 $Y=295860
X2441 1118 119 2 1136 1 1145 MUX2S $T=383780 326480 1 0 $X=383780 $Y=321060
X2442 1119 119 2 1149 1 1157 MUX2S $T=383780 336560 1 0 $X=383780 $Y=331140
X2443 1131 119 2 1114 1 1168 MUX2S $T=388740 306320 0 0 $X=388740 $Y=305940
X2444 1114 119 2 1137 1 1164 MUX2S $T=389360 316400 1 0 $X=389360 $Y=310980
X2445 1117 119 2 1138 1 1165 MUX2S $T=389360 316400 0 0 $X=389360 $Y=316020
X2446 1136 119 2 1093 1 1166 MUX2S $T=389360 326480 0 0 $X=389360 $Y=326100
X2447 1149 119 2 1093 1 1167 MUX2S $T=389360 336560 1 0 $X=389360 $Y=331140
X2448 1137 119 2 1093 1 1182 MUX2S $T=394320 316400 1 0 $X=394320 $Y=310980
X2449 1150 1139 2 1157 1 1183 MUX2S $T=394320 336560 1 0 $X=394320 $Y=331140
X2450 1138 119 2 1093 1 1190 MUX2S $T=394940 316400 0 0 $X=394940 $Y=316020
X2451 1156 1139 2 1166 1 1184 MUX2S $T=394940 326480 1 0 $X=394940 $Y=321060
X2452 1171 1139 2 1164 1 1196 MUX2S $T=398040 306320 1 0 $X=398040 $Y=300900
X2453 1168 1139 2 1182 1 1207 MUX2S $T=399900 316400 1 0 $X=399900 $Y=310980
X2454 1181 1139 2 1190 1 1204 MUX2S $T=400520 326480 1 0 $X=400520 $Y=321060
X2455 189 188 2 193 1 1442 MUX2S $T=467480 356720 0 0 $X=467480 $Y=356340
X2456 1415 1414 2 1421 1 1441 MUX2S $T=468100 336560 0 0 $X=468100 $Y=336180
X2457 1421 1414 2 1424 1 1444 MUX2S $T=468100 346640 0 0 $X=468100 $Y=346260
X2458 1424 188 2 189 1 1437 MUX2S $T=468100 356720 1 0 $X=468100 $Y=351300
X2459 1413 1414 2 1412 1 1445 MUX2S $T=470580 296240 0 0 $X=470580 $Y=295860
X2460 1441 197 2 1437 1 1452 MUX2S $T=473680 336560 0 0 $X=473680 $Y=336180
X2461 1437 197 2 202 1 1457 MUX2S $T=473680 346640 1 0 $X=473680 $Y=341220
X2462 1444 197 2 1442 1 1454 MUX2S $T=474300 356720 1 0 $X=474300 $Y=351300
X2463 1446 197 2 1444 1 1462 MUX2S $T=475540 336560 1 0 $X=475540 $Y=331140
X2464 1458 1459 2 1454 1 1465 MUX2S $T=478640 326480 0 0 $X=478640 $Y=326100
X2465 1433 196 2 1451 1 210 MUX2S $T=479260 296240 1 0 $X=479260 $Y=290820
X2466 1452 1459 2 1466 1 211 MUX2S $T=479880 336560 0 0 $X=479880 $Y=336180
X2467 1454 1459 2 1467 1 1474 MUX2S $T=479880 346640 0 0 $X=479880 $Y=346260
X2468 1462 1459 2 1453 1 1472 MUX2S $T=481120 336560 1 0 $X=481120 $Y=331140
X2469 1455 196 2 1456 1 1471 MUX2S $T=482980 296240 0 0 $X=482980 $Y=295860
X2470 1448 1459 2 1457 1 1477 MUX2S $T=483600 326480 0 0 $X=483600 $Y=326100
X2471 1466 1459 2 208 1 1487 MUX2S $T=484840 346640 1 0 $X=484840 $Y=341220
X2472 1453 1459 2 208 1 1489 MUX2S $T=485460 336560 0 0 $X=485460 $Y=336180
X2473 1467 196 2 208 1 1488 MUX2S $T=485460 356720 1 0 $X=485460 $Y=351300
X2474 1457 1459 2 208 1 1490 MUX2S $T=486700 336560 1 0 $X=486700 $Y=331140
X2475 1479 216 2 1490 1 1498 MUX2S $T=489180 326480 0 0 $X=489180 $Y=326100
X2476 1468 203 2 1474 1 1495 MUX2S $T=490420 316400 0 0 $X=490420 $Y=316020
X2477 1465 216 2 1488 1 1499 MUX2S $T=491040 346640 0 0 $X=491040 $Y=346260
X2478 1486 216 2 1487 1 1501 MUX2S $T=491660 336560 0 0 $X=491660 $Y=336180
X2479 1480 216 2 1489 1 1504 MUX2S $T=492280 336560 1 0 $X=492280 $Y=331140
X2480 1568 1580 2 1593 1 1609 MUX2S $T=519560 336560 0 0 $X=519560 $Y=336180
X2481 1593 1580 2 1599 1 1610 MUX2S $T=519560 346640 1 0 $X=519560 $Y=341220
X2482 239 1580 2 244 1 1608 MUX2S $T=520800 356720 0 0 $X=520800 $Y=356340
X2483 1599 1580 2 1602 1 1619 MUX2S $T=522660 346640 0 0 $X=522660 $Y=346260
X2484 1602 1580 2 239 1 1620 MUX2S $T=522660 356720 1 0 $X=522660 $Y=351300
X2485 1609 242 2 1619 1 1631 MUX2S $T=525760 336560 0 0 $X=525760 $Y=336180
X2486 1610 242 2 1620 1 1626 MUX2S $T=525760 346640 1 0 $X=525760 $Y=341220
X2487 1622 246 2 1629 1 1641 MUX2S $T=530100 306320 0 0 $X=530100 $Y=305940
X2488 1594 242 2 1610 1 1648 MUX2S $T=530100 336560 1 0 $X=530100 $Y=331140
X2489 1618 246 2 1642 1 1645 MUX2S $T=531960 316400 0 0 $X=531960 $Y=316020
X2490 1619 242 2 1608 1 1646 MUX2S $T=531960 346640 1 0 $X=531960 $Y=341220
X2491 1626 246 2 1640 1 1638 MUX2S $T=538160 346640 1 180 $X=533820 $Y=346260
X2492 1640 246 2 248 1 1656 MUX2S $T=534440 356720 1 0 $X=534440 $Y=351300
X2493 1616 246 2 1652 1 1663 MUX2S $T=535680 306320 0 0 $X=535680 $Y=305940
X2494 1630 246 2 1646 1 1662 MUX2S $T=535680 326480 0 0 $X=535680 $Y=326100
X2495 1648 246 2 1637 1 1660 MUX2S $T=536300 336560 0 0 $X=536300 $Y=336180
X2496 1631 246 2 1643 1 257 MUX2S $T=536920 346640 1 0 $X=536920 $Y=341220
X2497 1628 246 2 1630 1 1671 MUX2S $T=537540 316400 1 0 $X=537540 $Y=310980
X2498 1629 246 2 1631 1 1668 MUX2S $T=537540 326480 1 0 $X=537540 $Y=321060
X2499 1652 246 2 1648 1 1666 MUX2S $T=538160 316400 0 0 $X=538160 $Y=316020
X2500 1642 246 2 1626 1 1665 MUX2S $T=538160 346640 0 0 $X=538160 $Y=346260
X2501 1646 246 2 248 1 1675 MUX2S $T=541260 326480 0 0 $X=541260 $Y=326100
X2502 1637 246 2 248 1 1676 MUX2S $T=541880 336560 1 0 $X=541880 $Y=331140
X2503 1643 246 2 248 1 1678 MUX2S $T=542500 336560 0 0 $X=542500 $Y=336180
X2504 1645 1655 2 1638 1 1694 MUX2S $T=545600 326480 1 0 $X=545600 $Y=321060
X2505 1671 256 2 1675 1 1706 MUX2S $T=546840 326480 0 0 $X=546840 $Y=326100
X2506 1666 256 2 1676 1 1699 MUX2S $T=547460 336560 1 0 $X=547460 $Y=331140
X2507 1668 256 2 1678 1 1683 MUX2S $T=548080 336560 0 0 $X=548080 $Y=336180
X2508 1815 286 2 1820 1 1847 MUX2S $T=584660 306320 1 0 $X=584660 $Y=300900
X2509 1832 286 2 1850 1 1856 MUX2S $T=585900 336560 0 0 $X=585900 $Y=336180
X2510 1845 286 2 1849 1 1864 MUX2S $T=587760 326480 0 0 $X=587760 $Y=326100
X2511 1849 286 2 1832 1 1865 MUX2S $T=590240 336560 1 0 $X=590240 $Y=331140
X2512 1852 286 2 1843 1 1870 MUX2S $T=590240 346640 0 0 $X=590240 $Y=346260
X2513 1850 286 2 1852 1 1874 MUX2S $T=590860 346640 1 0 $X=590860 $Y=341220
X2514 1859 1828 2 1865 1 1871 MUX2S $T=592100 336560 0 0 $X=592100 $Y=336180
X2515 1864 1828 2 1856 1 1875 MUX2S $T=593340 326480 0 0 $X=593340 $Y=326100
X2516 1857 1858 2 1854 1 1877 MUX2S $T=593960 286160 0 0 $X=593960 $Y=285780
X2517 1865 1828 2 1874 1 1881 MUX2S $T=594580 336560 1 0 $X=594580 $Y=331140
X2518 1882 1828 2 1844 1 1895 MUX2S $T=598300 336560 0 0 $X=598300 $Y=336180
X2519 1856 1828 2 1870 1 1894 MUX2S $T=598920 326480 1 0 $X=598920 $Y=321060
X2520 1870 1828 2 1844 1 1898 MUX2S $T=598920 326480 0 0 $X=598920 $Y=326100
X2521 1874 1828 2 1882 1 1899 MUX2S $T=598920 336560 1 0 $X=598920 $Y=331140
X2522 1889 1858 2 1885 1 1913 MUX2S $T=601400 306320 0 0 $X=601400 $Y=305940
X2523 1872 1858 2 1881 1 1914 MUX2S $T=604500 326480 1 0 $X=604500 $Y=321060
X2524 1875 1858 2 1898 1 1915 MUX2S $T=604500 326480 0 0 $X=604500 $Y=326100
X2525 1881 1858 2 1895 1 1912 MUX2S $T=604500 336560 1 0 $X=604500 $Y=331140
X2526 1885 1858 2 1894 1 1919 MUX2S $T=605740 316400 0 0 $X=605740 $Y=316020
X2527 1887 1909 2 1912 1 1922 MUX2S $T=606360 316400 1 0 $X=606360 $Y=310980
X2528 1904 1901 2 1919 1 1924 MUX2S $T=606980 296240 0 0 $X=606980 $Y=295860
X2529 1871 1858 2 1899 1 1925 MUX2S $T=610080 326480 0 0 $X=610080 $Y=326100
X2530 1894 1858 2 1844 1 1935 MUX2S $T=610700 316400 0 0 $X=610700 $Y=316020
X2531 1895 1858 2 1844 1 1938 MUX2S $T=610700 336560 1 0 $X=610700 $Y=331140
X2532 1913 1909 2 1935 1 1940 MUX2S $T=611320 316400 1 0 $X=611320 $Y=310980
X2533 1899 1858 2 1844 1 1947 MUX2S $T=612560 326480 1 0 $X=612560 $Y=321060
X2534 1898 1858 2 1844 1 1953 MUX2S $T=615660 326480 0 0 $X=615660 $Y=326100
X2535 1902 1909 2 1947 1 1967 MUX2S $T=616280 316400 0 0 $X=616280 $Y=316020
X2536 1900 1909 2 1953 1 1959 MUX2S $T=616280 336560 1 0 $X=616280 $Y=331140
X2537 308 359 2 2163 1 2177 MUX2S $T=673940 356720 0 0 $X=673940 $Y=356340
X2538 358 359 2 2187 1 2176 MUX2S $T=681380 336560 0 0 $X=681380 $Y=336180
X2539 2163 359 2 2190 1 2195 MUX2S $T=682620 356720 1 0 $X=682620 $Y=351300
X2540 363 359 2 2196 1 2154 MUX2S $T=686960 326480 0 0 $X=686960 $Y=326100
X2541 2196 359 2 364 1 2193 MUX2S $T=692540 306320 0 180 $X=688200 $Y=300900
X2542 2183 359 2 2198 1 2199 MUX2S $T=695020 316400 0 180 $X=690680 $Y=310980
X2543 2190 359 2 2194 1 2207 MUX2S $T=690680 326480 1 0 $X=690680 $Y=321060
X2544 2187 359 2 2206 1 2178 MUX2S $T=696260 306320 0 0 $X=696260 $Y=305940
X2545 1059 1 1055 1068 2 ND2T $T=362700 286160 0 180 $X=357740 $Y=280740
X2546 1805 1 2048 2053 2 ND2T $T=647900 346640 0 0 $X=647900 $Y=346260
X2547 1793 100 101 2 1 1819 QDFFRBS $T=571020 276080 0 0 $X=571020 $Y=275700
X2548 991 76 960 2 952 82 1 AO22P $T=341620 336560 0 180 $X=336040 $Y=331140
X2549 1255 1159 1247 2 1204 1169 1 AO22P $T=418500 336560 1 180 $X=412920 $Y=336180
X2550 225 227 228 2 1500 226 1 AO22P $T=503440 266000 1 0 $X=503440 $Y=260580
X2551 1969 303 1932 2 1921 1946 1 AO22P $T=622480 306320 1 180 $X=616900 $Y=305940
X2552 339 303 1985 2 1958 305 1 AO22P $T=631160 266000 0 180 $X=625580 $Y=260580
X2553 1776 1788 1831 1814 1 2 MXL2H $T=578460 346640 1 0 $X=578460 $Y=341220
X2554 2077 1780 2166 1 2 2180 MAO222S $T=677040 276080 1 0 $X=677040 $Y=270660
X2555 79 1511 1 2 INV6 $T=509640 296240 1 0 $X=509640 $Y=290820
X2556 2096 2095 2 2048 1 ND2F $T=652860 346640 0 0 $X=652860 $Y=346260
X2557 1054 1 1086 2 BUF4CK $T=361460 306320 1 0 $X=361460 $Y=300900
X2558 1332 1086 2 1366 1354 1086 1 AOI22HP $T=447640 316400 1 180 $X=434620 $Y=316020
X2559 1831 2102 2 2114 2095 1831 1 AOI22HP $T=670220 356720 0 180 $X=657200 $Y=351300
X2560 2052 1778 2 2161 2086 1778 1 AOI22HP $T=681380 296240 1 180 $X=668360 $Y=295860
X2561 1256 152 1263 159 1 2 XOR3P $T=421600 356720 0 0 $X=421600 $Y=356340
X2562 774 787 29 1 2 AN2B1T $T=274040 276080 1 0 $X=274040 $Y=270660
X2563 830 871 854 1 2 AN2B1T $T=308760 286160 0 180 $X=303180 $Y=280740
X2564 993 703 1044 1032 1 2 MAO222P $T=350300 346640 1 0 $X=350300 $Y=341220
X2565 152 1256 1263 1177 1 2 MAO222P $T=416020 356720 0 0 $X=416020 $Y=356340
X2566 1550 1791 1801 1765 1 2 MAO222P $T=571020 336560 1 0 $X=571020 $Y=331140
X2567 1261 1246 1 2 1274 OR2B1 $T=418500 306320 0 0 $X=418500 $Y=305940
X2568 2019 2013 1 2 2042 OR2B1 $T=638600 326480 0 0 $X=638600 $Y=326100
X2569 2014 2008 1 2 2063 OR2B1 $T=639840 336560 0 0 $X=639840 $Y=336180
X2570 2165 1969 1 2 2143 OR2B1 $T=677040 306320 0 180 $X=673320 $Y=300900
X2571 661 686 4 1 2 677 675 672 639 ICV_17 $T=236840 286160 0 180 $X=234980 $Y=280740
X2572 685 694 672 1 2 670 689 684 639 ICV_17 $T=241180 326480 1 180 $X=239320 $Y=326100
X2573 803 805 9 1 2 793 792 4 639 ICV_17 $T=278380 266000 0 180 $X=276520 $Y=260580
X2574 835 849 49 1 2 826 839 57 639 ICV_17 $T=298220 306320 0 180 $X=296360 $Y=300900
X2575 942 965 76 1 2 910 956 82 639 ICV_17 $T=333560 296240 0 180 $X=331700 $Y=290820
X2576 1001 996 992 1 2 991 990 699 639 ICV_17 $T=340380 336560 1 180 $X=338520 $Y=336180
X2577 1210 144 1200 1 2 1185 1200 113 639 ICV_17 $T=404240 266000 1 180 $X=402380 $Y=265620
X2578 1213 1231 1230 1 2 1183 1230 1169 639 ICV_17 $T=411060 336560 0 180 $X=409200 $Y=331140
X2579 1345 1335 1042 1 2 1307 1330 1268 639 ICV_17 $T=432760 306320 1 180 $X=430900 $Y=305940
X2580 1759 1775 1765 1 2 1765 1762 1752 639 ICV_17 $T=564820 336560 0 180 $X=562960 $Y=331140
X2581 1792 1789 1787 1 2 1738 1785 1551 639 ICV_17 $T=569160 336560 0 180 $X=567300 $Y=331140
X2582 1783 1804 1611 1 2 1611 1799 1779 639 ICV_17 $T=574740 326480 0 180 $X=572880 $Y=321060
X2583 1829 1836 1835 1 2 1800 1835 286 639 ICV_17 $T=585900 286160 1 180 $X=584040 $Y=285780
X2584 2017 2088 2076 1 2 2025 2078 2017 639 ICV_17 $T=649760 286160 1 180 $X=647900 $Y=285780
X2585 2108 2113 2043 1 2 1802 2104 2043 639 ICV_17 $T=660300 336560 1 180 $X=658440 $Y=336180
X2586 1018 699 1006 1 2 OR2B1P $T=349060 336560 0 0 $X=349060 $Y=336180
X2587 752 21 2 1 739 12 768 21 749 12 639 ICV_20 $T=269080 346640 1 180 $X=264740 $Y=346260
X2588 821 49 2 1 845 815 820 49 852 824 639 ICV_20 $T=295120 326480 0 0 $X=295120 $Y=326100
X2589 833 49 2 1 853 834 834 49 847 821 639 ICV_20 $T=295740 316400 0 0 $X=295740 $Y=316020
X2590 1074 105 2 1 1095 1071 1071 105 1096 1081 639 ICV_20 $T=366420 306320 0 0 $X=366420 $Y=305940
X2591 1081 105 2 1 1099 1062 1066 105 1102 1087 639 ICV_20 $T=367040 316400 0 0 $X=367040 $Y=316020
X2592 1095 114 2 1 1113 1099 1077 114 1114 1100 639 ICV_20 $T=372000 306320 0 0 $X=372000 $Y=305940
X2593 1103 1059 2 1 1121 1089 1103 114 1126 1095 639 ICV_20 $T=373860 296240 0 0 $X=373860 $Y=295860
X2594 1076 114 2 1 1131 1096 1096 114 1141 1077 639 ICV_20 $T=377580 306320 0 0 $X=377580 $Y=305940
X2595 1126 119 2 1 1150 1124 1141 119 1156 1118 639 ICV_20 $T=383160 306320 0 0 $X=383160 $Y=305940
X2596 1180 1139 2 1 1193 1168 1176 1139 1194 1175 639 ICV_20 $T=399900 276080 0 0 $X=399900 $Y=275700
X2597 1423 1414 2 1 1435 1419 1419 1414 1440 1422 639 ICV_20 $T=468100 306320 0 0 $X=468100 $Y=305940
X2598 1425 197 2 1 1451 1440 1440 197 1456 1420 639 ICV_20 $T=473680 306320 0 0 $X=473680 $Y=305940
X2599 1463 196 2 1 1485 1464 1470 1459 1479 1448 639 ICV_20 $T=484220 306320 0 0 $X=484220 $Y=305940
X2600 1476 203 2 1 1491 1480 1481 203 1500 1485 639 ICV_20 $T=489180 276080 0 0 $X=489180 $Y=275700
X2601 1603 242 2 1 1628 1565 1565 242 1629 1615 639 ICV_20 $T=526380 316400 0 0 $X=526380 $Y=316020
X2602 1883 1858 2 1 1904 1889 1884 1858 1911 1886 639 ICV_20 $T=601400 296240 0 0 $X=601400 $Y=295860
X2603 1888 1901 2 1 326 1911 1873 1901 329 1906 639 ICV_20 $T=609460 266000 0 0 $X=609460 $Y=265620
.ENDS
***************************************
.SUBCKT TIE1 O VCC GND
** N=4 EP=3 IP=0 FDC=0
.ENDS
***************************************
.SUBCKT TIE0 O VCC GND
** N=4 EP=3 IP=0 FDC=0
.ENDS
***************************************
.SUBCKT NR3H O I3 I2 I1 VCC GND
** N=7 EP=6 IP=0 FDC=0
.ENDS
***************************************
.SUBCKT INV1 O I VCC GND
** N=5 EP=4 IP=0 FDC=0
.ENDS
***************************************
.SUBCKT ICV_22 1 2 3 4 5 6 7 8 9 10 11 12 13 14 15 16 17 18 19 20
+ 21 22 23 24 25 26 27 28 29 30 31 32 33 34 35 36 37 38 39 40
+ 41 42 43 44 45 46 47 48 49 50 51 52 53 54 55 56 57 58 59 60
+ 61 62 63 64 65 66 67 68 69 70 71 72 73 74 75 76 77 78 79 80
+ 81 82 83 84 85 86 87 88 89 90 91 92 93 94 95 96 97 98 99 100
+ 101 102 103 104 105 106 108 109 110 111 112 113 114 115 117 118 119 120 121 122
+ 123 124 125 126 127 128 129 131 132 133 134 135 136 137 138 139 140 141 142 143
+ 144 145 146 147 148 149 150 151 152 153 154 155 156 157 158 159 161 162 163 164
+ 165 166 167 168 170 171 172 173 174 175 177 178 179 180 181 182 183 184 185 186
+ 187 188 189 190 191 192 193 194 195 196 197 198 199 200 201 202 203 204 205 206
+ 207 208 209 210 211 212 213 214 215 216 217 218 219 220 221 222 223 224 225 226
+ 227 228 229 230 231 232 233 234 235 236 237 238 239 240 241 242 243 244 245 246
+ 247 248 249 250 251 252 253 254 255 256 257 258 259 260 261 262 263 264 265 266
+ 267 268 269 270 271 272 273 274 275 276 277 278 279 280 281 282 283 284 285 286
+ 287 288 289 290 291 292 293 294 295 296 297 324
** N=1136 EP=292 IP=5482 FDC=0
X0 296 247 247 247 297 247 295 YA2GSD $T=1309440 186510 0 90 $X=1169940 $Y=189360
X1 191 183 925 1 2 QDFFN $T=699360 235760 0 180 $X=688820 $Y=230340
X2 191 188 928 1 2 QDFFN $T=704940 225680 0 180 $X=694400 $Y=220260
X3 191 189 929 1 2 QDFFN $T=705560 245840 0 180 $X=695020 $Y=240420
X4 191 190 930 1 2 QDFFN $T=706180 255920 1 180 $X=695640 $Y=255540
X5 192 190 937 1 2 QDFFN $T=708040 255920 0 0 $X=708040 $Y=255540
X6 192 189 934 1 2 QDFFN $T=708660 245840 1 0 $X=708660 $Y=240420
X7 192 183 938 1 2 QDFFN $T=713000 235760 0 0 $X=713000 $Y=235380
X8 192 188 935 1 2 QDFFN $T=726020 225680 0 180 $X=715480 $Y=220260
X9 193 190 941 1 2 QDFFN $T=720440 255920 0 0 $X=720440 $Y=255540
X10 193 188 946 1 2 QDFFN $T=724780 255920 1 0 $X=724780 $Y=250500
X11 195 183 940 1 2 QDFFN $T=737180 225680 1 180 $X=726640 $Y=225300
X12 193 183 943 1 2 QDFFN $T=727880 235760 0 0 $X=727880 $Y=235380
X13 195 188 944 1 2 QDFFN $T=742760 225680 0 180 $X=732220 $Y=220260
X14 195 189 952 1 2 QDFFN $T=737180 245840 1 0 $X=737180 $Y=240420
X15 195 190 953 1 2 QDFFN $T=739040 255920 0 0 $X=739040 $Y=255540
X16 196 183 949 1 2 QDFFN $T=750820 225680 1 180 $X=740280 $Y=225300
X17 196 188 959 1 2 QDFFN $T=745860 225680 1 0 $X=745860 $Y=220260
X18 196 189 957 1 2 QDFFN $T=748960 245840 1 0 $X=748960 $Y=240420
X19 191 199 955 1 2 QDFFN $T=761360 255920 1 180 $X=750820 $Y=255540
X20 192 197 965 1 2 QDFFN $T=752680 225680 0 0 $X=752680 $Y=225300
X21 192 204 961 1 2 QDFFN $T=767560 235760 1 180 $X=757020 $Y=235380
X22 191 197 969 1 2 QDFFN $T=760120 225680 1 0 $X=760120 $Y=220260
X23 191 207 964 1 2 QDFFN $T=771900 245840 0 180 $X=761360 $Y=240420
X24 191 204 967 1 2 QDFFN $T=775620 225680 1 180 $X=765080 $Y=225300
X25 196 199 973 1 2 QDFFN $T=770040 255920 0 0 $X=770040 $Y=255540
X26 196 197 976 1 2 QDFFN $T=772520 225680 1 0 $X=772520 $Y=220260
X27 196 207 970 1 2 QDFFN $T=783680 245840 1 180 $X=773140 $Y=245460
X28 196 204 974 1 2 QDFFN $T=787400 225680 1 180 $X=776860 $Y=225300
X29 195 207 982 1 2 QDFFN $T=781200 255920 0 0 $X=781200 $Y=255540
X30 195 197 978 1 2 QDFFN $T=794840 225680 0 180 $X=784300 $Y=220260
X31 193 207 984 1 2 QDFFN $T=784920 245840 0 0 $X=784920 $Y=245460
X32 195 204 980 1 2 QDFFN $T=799800 225680 1 180 $X=789260 $Y=225300
X33 193 199 983 1 2 QDFFN $T=802900 255920 1 180 $X=792360 $Y=255540
X34 193 197 991 1 2 QDFFN $T=796080 225680 1 0 $X=796080 $Y=220260
X35 193 210 993 1 2 QDFFN $T=799180 255920 1 0 $X=799180 $Y=250500
X36 193 204 987 1 2 QDFFN $T=812820 225680 1 180 $X=802280 $Y=225300
X37 213 210 214 1 2 QDFFN $T=803520 255920 0 0 $X=803520 $Y=255540
X38 196 210 990 1 2 QDFFN $T=816540 235760 0 180 $X=806000 $Y=230340
X39 195 210 995 1 2 QDFFN $T=820260 225680 0 180 $X=809720 $Y=220260
X40 192 210 996 1 2 QDFFN $T=820880 255920 0 180 $X=810340 $Y=250500
X41 191 210 999 1 2 QDFFN $T=827700 225680 1 180 $X=817160 $Y=225300
X42 192 217 1005 1 2 QDFFN $T=817780 235760 0 0 $X=817780 $Y=235380
X43 192 218 1006 1 2 QDFFN $T=820880 245840 1 0 $X=820880 $Y=240420
X44 192 219 1004 1 2 QDFFN $T=821500 255920 0 0 $X=821500 $Y=255540
X45 192 221 1009 1 2 QDFFN $T=825220 225680 1 0 $X=825220 $Y=220260
X46 191 217 1013 1 2 QDFFN $T=830800 235760 0 0 $X=830800 $Y=235380
X47 191 219 1010 1 2 QDFFN $T=831420 245840 0 0 $X=831420 $Y=245460
X48 192 226 1007 1 2 QDFFN $T=832660 225680 0 0 $X=832660 $Y=225300
X49 191 218 1008 1 2 QDFFN $T=843820 245840 0 180 $X=833280 $Y=240420
X50 191 226 1012 1 2 QDFFN $T=850020 225680 0 180 $X=839480 $Y=220260
X51 196 217 1017 1 2 QDFFN $T=843200 235760 0 0 $X=843200 $Y=235380
X52 196 218 1018 1 2 QDFFN $T=843820 255920 1 0 $X=843820 $Y=250500
X53 191 221 1016 1 2 QDFFN $T=845680 225680 0 0 $X=845680 $Y=225300
X54 213 221 1020 1 2 QDFFN $T=845680 245840 1 0 $X=845680 $Y=240420
X55 196 226 1022 1 2 QDFFN $T=852500 225680 1 0 $X=852500 $Y=220260
X56 213 217 1024 1 2 QDFFN $T=855600 235760 0 0 $X=855600 $Y=235380
X57 196 219 1021 1 2 QDFFN $T=855600 255920 0 0 $X=855600 $Y=255540
X58 196 221 1027 1 2 QDFFN $T=858700 225680 0 0 $X=858700 $Y=225300
X59 195 226 1030 1 2 QDFFN $T=865520 225680 1 0 $X=865520 $Y=220260
X60 195 217 1031 1 2 QDFFN $T=867380 235760 0 0 $X=867380 $Y=235380
X61 213 226 1023 1 2 QDFFN $T=867380 245840 1 0 $X=867380 $Y=240420
X62 213 218 1032 1 2 QDFFN $T=867380 245840 0 0 $X=867380 $Y=245460
X63 195 221 1029 1 2 QDFFN $T=885360 225680 1 180 $X=874820 $Y=225300
X64 193 219 1036 1 2 QDFFN $T=878540 255920 1 0 $X=878540 $Y=250500
X65 193 218 1034 1 2 QDFFN $T=889700 235760 1 180 $X=879160 $Y=235380
X66 193 226 1047 1 2 QDFFN $T=886600 225680 1 0 $X=886600 $Y=220260
X67 193 221 1048 1 2 QDFFN $T=887220 225680 0 0 $X=887220 $Y=225300
X68 193 217 1045 1 2 QDFFN $T=892800 245840 1 0 $X=892800 $Y=240420
X69 195 219 1044 1 2 QDFFN $T=898380 245840 0 0 $X=898380 $Y=245460
X70 195 218 1046 1 2 QDFFN $T=899620 255920 1 0 $X=899620 $Y=250500
X71 244 239 1051 1 2 QDFFN $T=912640 225680 1 180 $X=902100 $Y=225300
X72 238 239 1058 1 2 QDFFN $T=907060 245840 1 0 $X=907060 $Y=240420
X73 238 243 1063 1 2 QDFFN $T=913260 245840 0 0 $X=913260 $Y=245460
X74 244 243 1054 1 2 QDFFN $T=928760 225680 1 180 $X=918220 $Y=225300
X75 244 253 1061 1 2 QDFFN $T=931860 225680 0 180 $X=921320 $Y=220260
X76 244 250 1066 1 2 QDFFN $T=923180 255920 1 0 $X=923180 $Y=250500
X77 238 253 1064 1 2 QDFFN $T=941160 245840 0 180 $X=930620 $Y=240420
X78 255 239 1067 1 2 QDFFN $T=943640 225680 1 180 $X=933100 $Y=225300
X79 244 257 1065 1 2 QDFFN $T=944880 255920 1 180 $X=934340 $Y=255540
X80 255 253 1069 1 2 QDFFN $T=934960 255920 1 0 $X=934960 $Y=250500
X81 255 243 1068 1 2 QDFFN $T=947980 225680 0 180 $X=937440 $Y=220260
X82 258 239 1071 1 2 QDFFN $T=954800 245840 0 180 $X=944260 $Y=240420
X83 258 250 1075 1 2 QDFFN $T=945500 245840 0 0 $X=945500 $Y=245460
X84 258 253 1073 1 2 QDFFN $T=957900 225680 1 180 $X=947360 $Y=225300
X85 258 243 1074 1 2 QDFFN $T=964100 225680 0 180 $X=953560 $Y=220260
X86 263 239 1078 1 2 QDFFN $T=967820 245840 0 180 $X=957280 $Y=240420
X87 263 243 1081 1 2 QDFFN $T=970920 235760 0 180 $X=960380 $Y=230340
X88 263 253 1082 1 2 QDFFN $T=973400 225680 1 180 $X=962860 $Y=225300
X89 263 250 1083 1 2 QDFFN $T=973400 245840 1 180 $X=962860 $Y=245460
X90 264 239 1088 1 2 QDFFN $T=971540 245840 1 0 $X=971540 $Y=240420
X91 264 253 1091 1 2 QDFFN $T=974020 225680 1 0 $X=974020 $Y=220260
X92 264 250 1090 1 2 QDFFN $T=974020 245840 0 0 $X=974020 $Y=245460
X93 264 243 1087 1 2 QDFFN $T=985800 235760 0 180 $X=975260 $Y=230340
X94 244 270 1093 1 2 QDFFN $T=996340 245840 0 180 $X=985800 $Y=240420
X95 263 270 1096 1 2 QDFFN $T=987040 245840 0 0 $X=987040 $Y=245460
X96 244 271 1099 1 2 QDFFN $T=989520 225680 1 0 $X=989520 $Y=220260
X97 244 272 1100 1 2 QDFFN $T=989520 235760 1 0 $X=989520 $Y=230340
X98 263 272 1108 1 2 QDFFN $T=1000060 245840 1 0 $X=1000060 $Y=240420
X99 238 271 1102 1 2 QDFFN $T=1000680 255920 0 0 $X=1000680 $Y=255540
X100 264 272 1101 1 2 QDFFN $T=1001920 235760 0 0 $X=1001920 $Y=235380
X101 263 271 1103 1 2 QDFFN $T=1003780 255920 1 0 $X=1003780 $Y=250500
X102 264 271 1105 1 2 QDFFN $T=1004400 225680 1 0 $X=1004400 $Y=220260
X103 244 279 1109 1 2 QDFFN $T=1024860 225680 1 180 $X=1014320 $Y=225300
X104 244 277 1111 1 2 QDFFN $T=1014320 235760 1 0 $X=1014320 $Y=230340
X105 264 279 1118 1 2 QDFFN $T=1037260 235760 0 180 $X=1026720 $Y=230340
X106 264 277 1117 1 2 QDFFN $T=1037880 225680 0 180 $X=1027340 $Y=220260
X107 263 277 1120 1 2 QDFFN $T=1040980 245840 0 180 $X=1030440 $Y=240420
X108 238 279 1119 1 2 QDFFN $T=1041600 255920 1 180 $X=1031060 $Y=255540
X109 263 279 1122 1 2 QDFFN $T=1044700 245840 1 180 $X=1034160 $Y=245460
X110 244 282 1126 1 2 QDFFN $T=1040360 235760 1 0 $X=1040360 $Y=230340
X111 244 285 1124 1 2 QDFFN $T=1042840 225680 0 0 $X=1042840 $Y=225300
X112 244 287 289 1 2 QDFFN $T=1043460 255920 1 0 $X=1043460 $Y=250500
X113 264 287 290 1 2 QDFFN $T=1047180 245840 0 0 $X=1047180 $Y=245460
X114 264 285 1128 1 2 QDFFN $T=1052760 235760 0 0 $X=1052760 $Y=235380
X115 263 287 292 1 2 QDFFN $T=1054620 255920 0 0 $X=1054620 $Y=255540
X116 264 282 1130 1 2 QDFFN $T=1056480 235760 1 0 $X=1056480 $Y=230340
X117 238 285 1131 1 2 QDFFN $T=1065160 245840 0 0 $X=1065160 $Y=245460
X118 263 285 1133 1 2 QDFFN $T=1068880 225680 0 0 $X=1068880 $Y=225300
X119 263 282 1134 1 2 QDFFN $T=1071980 235760 1 0 $X=1071980 $Y=230340
X120 238 287 294 1 2 QDFFN $T=1076940 255920 0 0 $X=1076940 $Y=255540
X121 238 282 1135 1 2 QDFFN $T=1077560 245840 0 0 $X=1077560 $Y=245460
X122 464 462 468 393 1 393 2 AOI22S $T=367660 225680 1 0 $X=367660 $Y=220260
X123 560 577 582 584 1 585 2 AOI22S $T=446400 235760 0 0 $X=446400 $Y=235380
X124 597 604 610 91 1 90 2 AOI22S $T=486080 245840 1 0 $X=486080 $Y=240420
X125 771 770 763 729 1 659 2 AOI22S $T=575360 245840 0 180 $X=571640 $Y=240420
X126 851 860 859 858 1 858 2 AOI22S $T=635500 245840 1 0 $X=635500 $Y=240420
X127 866 880 881 877 1 877 2 AOI22S $T=651000 245840 1 0 $X=651000 $Y=240420
X128 930 929 931 184 1 185 2 AOI22S $T=697500 255920 1 0 $X=697500 $Y=250500
X129 928 925 932 186 1 187 2 AOI22S $T=699360 225680 0 0 $X=699360 $Y=225300
X130 937 934 939 184 1 185 2 AOI22S $T=716720 245840 1 180 $X=713000 $Y=245460
X131 935 938 936 186 1 187 2 AOI22S $T=717960 235760 1 0 $X=717960 $Y=230340
X132 946 943 947 186 1 187 2 AOI22S $T=734700 245840 1 180 $X=730980 $Y=245460
X133 941 194 945 184 1 185 2 AOI22S $T=732840 255920 0 0 $X=732840 $Y=255540
X134 944 940 948 186 1 187 2 AOI22S $T=735940 235760 1 0 $X=735940 $Y=230340
X135 953 952 951 184 1 185 2 AOI22S $T=746480 255920 0 180 $X=742760 $Y=250500
X136 959 949 956 186 1 187 2 AOI22S $T=753300 235760 0 180 $X=749580 $Y=230340
X137 198 957 958 184 1 185 2 AOI22S $T=754540 255920 0 180 $X=750820 $Y=250500
X138 965 961 966 201 1 200 2 AOI22S $T=762600 235760 0 180 $X=758880 $Y=230340
X139 206 205 962 203 1 202 2 AOI22S $T=767560 255920 1 180 $X=763840 $Y=255540
X140 964 955 968 203 1 202 2 AOI22S $T=765700 255920 1 0 $X=765700 $Y=250500
X141 969 967 971 201 1 200 2 AOI22S $T=771900 235760 0 180 $X=768180 $Y=230340
X142 970 973 972 203 1 202 2 AOI22S $T=774380 255920 1 0 $X=774380 $Y=250500
X143 976 974 977 201 1 200 2 AOI22S $T=781200 235760 0 180 $X=777480 $Y=230340
X144 982 208 981 203 1 202 2 AOI22S $T=787400 255920 0 180 $X=783680 $Y=250500
X145 978 980 979 201 1 200 2 AOI22S $T=787400 235760 1 0 $X=787400 $Y=230340
X146 984 983 986 203 1 202 2 AOI22S $T=796080 255920 0 180 $X=792360 $Y=250500
X147 991 987 988 201 1 200 2 AOI22S $T=801040 235760 0 180 $X=797320 $Y=230340
X148 990 989 212 211 1 209 2 AOI22S $T=804140 245840 0 180 $X=800420 $Y=240420
X149 993 992 994 211 1 209 2 AOI22S $T=807860 245840 1 180 $X=804140 $Y=245460
X150 995 985 998 211 1 209 2 AOI22S $T=811580 245840 0 180 $X=807860 $Y=240420
X151 996 963 997 211 1 209 2 AOI22S $T=810340 245840 0 0 $X=810340 $Y=245460
X152 999 975 1001 211 1 209 2 AOI22S $T=817160 245840 0 180 $X=813440 $Y=240420
X153 269 1092 1057 268 1 267 2 AOI22S $T=988280 255920 1 180 $X=984560 $Y=255540
X154 1093 1094 1053 268 1 267 2 AOI22S $T=988280 255920 1 0 $X=988280 $Y=250500
X155 273 1095 1084 268 1 267 2 AOI22S $T=996960 255920 1 180 $X=993240 $Y=255540
X156 1096 1098 1076 268 1 267 2 AOI22S $T=995720 255920 1 0 $X=995720 $Y=250500
X157 1099 1100 1097 275 1 274 2 AOI22S $T=997580 225680 0 0 $X=997580 $Y=225300
X158 1105 1101 1106 275 1 274 2 AOI22S $T=1011840 235760 0 180 $X=1008120 $Y=230340
X159 1103 1108 1104 275 1 274 2 AOI22S $T=1012460 245840 0 0 $X=1012460 $Y=245460
X160 1102 276 1107 275 1 274 2 AOI22S $T=1013080 255920 0 0 $X=1013080 $Y=255540
X161 1109 1111 1110 280 1 278 2 AOI22S $T=1018660 235760 0 0 $X=1018660 $Y=235380
X162 1119 281 1112 280 1 278 2 AOI22S $T=1028580 255920 1 180 $X=1024860 $Y=255540
X163 1122 1120 1114 280 1 278 2 AOI22S $T=1030440 245840 1 180 $X=1026720 $Y=245460
X164 1118 1117 1121 280 1 278 2 AOI22S $T=1030440 235760 0 0 $X=1030440 $Y=235380
X165 1126 1124 1125 284 1 283 2 AOI22S $T=1046560 235760 1 180 $X=1042840 $Y=235380
X166 1130 1128 1127 284 1 283 2 AOI22S $T=1060820 245840 0 180 $X=1057100 $Y=240420
X167 1135 1131 1132 284 1 283 2 AOI22S $T=1072600 255920 0 180 $X=1068880 $Y=250500
X168 1134 1133 1129 284 1 283 2 AOI22S $T=1078800 235760 1 180 $X=1075080 $Y=235380
X169 325 326 1 2 331 AN2 $T=235600 245840 0 0 $X=235600 $Y=245460
X170 329 327 1 2 326 AN2 $T=238700 235760 0 180 $X=236220 $Y=230340
X171 339 331 1 2 334 AN2 $T=246140 245840 1 180 $X=243660 $Y=245460
X172 336 334 1 2 9 AN2 $T=245520 255920 0 0 $X=245520 $Y=255540
X173 346 345 1 2 327 AN2 $T=258540 225680 0 180 $X=256060 $Y=220260
X174 355 15 1 2 361 AN2 $T=274040 245840 0 0 $X=274040 $Y=245460
X175 377 378 1 2 380 AN2 $T=295740 245840 0 0 $X=295740 $Y=245460
X176 387 380 1 2 400 AN2 $T=310620 255920 1 0 $X=310620 $Y=250500
X177 402 400 1 2 31 AN2 $T=313100 255920 1 0 $X=313100 $Y=250500
X178 455 47 1 2 451 AN2 $T=351540 235760 0 180 $X=349060 $Y=230340
X179 452 47 1 2 456 AN2 $T=353400 245840 1 0 $X=353400 $Y=240420
X180 454 47 1 2 459 AN2 $T=356500 245840 0 0 $X=356500 $Y=245460
X181 487 55 1 2 56 AN2 $T=381300 255920 0 0 $X=381300 $Y=255540
X182 492 47 1 2 481 AN2 $T=385020 245840 0 180 $X=382540 $Y=240420
X183 504 47 1 2 493 AN2 $T=395560 245840 0 180 $X=393080 $Y=240420
X184 62 63 1 2 514 AN2 $T=398040 255920 0 0 $X=398040 $Y=255540
X185 517 514 1 2 66 AN2 $T=408580 255920 0 0 $X=408580 $Y=255540
X186 67 66 1 2 69 AN2 $T=413540 255920 0 0 $X=413540 $Y=255540
X187 538 47 1 2 533 AN2 $T=419120 235760 0 180 $X=416640 $Y=230340
X188 574 47 1 2 546 AN2 $T=442680 235760 1 180 $X=440200 $Y=235380
X189 600 601 1 2 608 AN2 $T=482360 225680 0 0 $X=482360 $Y=225300
X190 94 95 1 2 620 AN2 $T=490420 255920 1 0 $X=490420 $Y=250500
X191 92 95 1 2 621 AN2 $T=491040 255920 0 0 $X=491040 $Y=255540
X192 623 602 1 2 626 AN2 $T=494760 225680 1 0 $X=494760 $Y=220260
X193 624 626 1 2 631 AN2 $T=496620 235760 1 0 $X=496620 $Y=230340
X194 99 632 1 2 98 AN2 $T=501580 245840 1 180 $X=499100 $Y=245460
X195 634 631 1 2 632 AN2 $T=503440 245840 0 180 $X=500960 $Y=240420
X196 111 668 1 2 663 AN2 $T=528860 235760 1 180 $X=526380 $Y=235380
X197 674 617 1 2 671 AN2 $T=531340 235760 0 180 $X=528860 $Y=230340
X198 672 663 1 2 675 AN2 $T=528860 235760 0 0 $X=528860 $Y=235380
X199 690 675 1 2 695 AN2 $T=538780 245840 1 0 $X=538780 $Y=240420
X200 698 695 1 2 118 AN2 $T=542500 245840 1 180 $X=540020 $Y=245460
X201 776 137 1 2 140 AN2 $T=579700 255920 1 0 $X=579700 $Y=250500
X202 756 137 1 2 782 AN2 $T=581560 235760 1 0 $X=581560 $Y=230340
X203 778 137 1 2 775 AN2 $T=584660 235760 0 0 $X=584660 $Y=235380
X204 146 147 1 2 804 AN2 $T=596440 255920 0 0 $X=596440 $Y=255540
X205 810 137 1 2 803 AN2 $T=604500 235760 1 180 $X=602020 $Y=235380
X206 815 812 1 2 153 AN2 $T=606980 255920 0 0 $X=606980 $Y=255540
X207 822 137 1 2 818 AN2 $T=615040 235760 0 180 $X=612560 $Y=230340
X208 158 834 1 2 820 AN2 $T=623100 255920 0 180 $X=620620 $Y=250500
X209 862 137 1 2 858 AN2 $T=646040 235760 1 180 $X=643560 $Y=235380
X210 181 137 1 2 887 AN2 $T=683860 255920 1 180 $X=681380 $Y=255540
X211 927 137 1 2 891 AN2 $T=695640 235760 1 180 $X=693160 $Y=235380
X212 932 931 1 2 933 AN2 $T=701220 235760 0 0 $X=701220 $Y=235380
X213 936 939 1 2 942 AN2 $T=723540 245840 1 0 $X=723540 $Y=240420
X214 947 945 1 2 950 AN2 $T=737180 255920 1 0 $X=737180 $Y=250500
X215 948 951 1 2 954 AN2 $T=744000 235760 0 0 $X=744000 $Y=235380
X216 956 958 1 2 960 AN2 $T=752060 235760 0 0 $X=752060 $Y=235380
X217 1125 286 1 2 1115 AN2 $T=1046560 245840 0 180 $X=1044080 $Y=240420
X218 1127 288 1 2 1123 AN2 $T=1051520 245840 0 180 $X=1049040 $Y=240420
X219 1129 291 1 2 1116 AN2 $T=1062680 245840 1 180 $X=1060200 $Y=245460
X220 1132 293 1 2 1113 AN2 $T=1071980 255920 1 180 $X=1069500 $Y=255540
X221 350 358 345 1 2 AN2T $T=274040 225680 1 0 $X=274040 $Y=220260
X222 361 357 358 1 2 AN2T $T=278380 245840 0 180 $X=274040 $Y=240420
X223 590 592 602 1 2 AN2T $T=469960 225680 1 0 $X=469960 $Y=220260
X224 611 608 592 1 2 AN2T $T=486080 225680 0 180 $X=481740 $Y=220260
X225 643 630 649 1 2 AN2T $T=513360 255920 0 0 $X=513360 $Y=255540
X226 114 112 668 1 2 AN2T $T=533200 255920 0 180 $X=528860 $Y=250500
X227 821 820 830 1 2 AN2T $T=615040 245840 0 0 $X=615040 $Y=245460
X228 856 830 164 1 2 AN2T $T=631780 255920 1 0 $X=631780 $Y=250500
X229 5 2 325 1 INV1S $T=239940 255920 1 180 $X=238700 $Y=255540
X230 6 2 329 1 INV1S $T=241180 235760 1 180 $X=239940 $Y=235380
X231 337 2 341 1 INV1S $T=251720 235760 0 0 $X=251720 $Y=235380
X232 11 2 339 1 INV1S $T=254200 255920 0 180 $X=252960 $Y=250500
X233 12 2 336 1 INV1S $T=257920 255920 1 180 $X=256680 $Y=255540
X234 10 2 346 1 INV1S $T=259780 235760 1 180 $X=258540 $Y=235380
X235 335 2 352 1 INV1S $T=261020 245840 1 0 $X=261020 $Y=240420
X236 14 2 355 1 INV1S $T=270320 245840 0 0 $X=270320 $Y=245460
X237 23 2 374 1 INV1S $T=293880 255920 1 180 $X=292640 $Y=255540
X238 27 2 377 1 INV1S $T=302560 245840 1 180 $X=301320 $Y=245460
X239 24 2 385 1 INV1S $T=303180 255920 0 0 $X=303180 $Y=255540
X240 28 2 387 1 INV1S $T=305040 245840 0 0 $X=305040 $Y=245460
X241 386 2 394 1 INV1S $T=311240 235760 1 180 $X=310000 $Y=235380
X242 392 2 399 1 INV1S $T=312480 235760 1 180 $X=311240 $Y=235380
X243 399 2 401 1 INV1S $T=311240 245840 1 0 $X=311240 $Y=240420
X244 29 2 402 1 INV1S $T=316820 255920 0 180 $X=315580 $Y=250500
X245 22 2 32 1 INV1S $T=315580 255920 0 0 $X=315580 $Y=255540
X246 395 2 409 1 INV1S $T=317440 245840 0 180 $X=316200 $Y=240420
X247 429 2 440 1 INV1S $T=333560 235760 1 0 $X=333560 $Y=230340
X248 404 2 443 1 INV1S $T=337280 235760 0 0 $X=337280 $Y=235380
X249 431 2 449 1 INV1S $T=337280 245840 0 0 $X=337280 $Y=245460
X250 437 2 444 1 INV1S $T=337280 255920 1 0 $X=337280 $Y=250500
X251 442 2 446 1 INV1S $T=352780 255920 1 180 $X=351540 $Y=255540
X252 52 2 487 1 INV1S $T=379440 255920 0 0 $X=379440 $Y=255540
X253 58 2 59 1 INV1S $T=389980 255920 0 0 $X=389980 $Y=255540
X254 513 2 511 1 INV1S $T=403620 225680 0 180 $X=402380 $Y=220260
X255 523 2 505 1 INV1S $T=404240 245840 0 180 $X=403000 $Y=240420
X256 64 2 517 1 INV1S $T=404240 255920 1 0 $X=404240 $Y=250500
X257 526 2 530 1 INV1S $T=416640 245840 0 180 $X=415400 $Y=240420
X258 71 2 68 1 INV1S $T=419740 255920 1 180 $X=418500 $Y=255540
X259 563 2 561 1 INV1S $T=437100 235760 0 180 $X=435860 $Y=230340
X260 572 2 575 1 INV1S $T=442060 245840 1 0 $X=442060 $Y=240420
X261 560 2 577 1 INV1S $T=443300 255920 1 0 $X=443300 $Y=250500
X262 585 2 584 1 INV1S $T=451980 235760 1 0 $X=451980 $Y=230340
X263 596 2 594 1 INV1S $T=473680 235760 1 180 $X=472440 $Y=235380
X264 590 2 595 1 INV1S $T=480500 235760 0 180 $X=479260 $Y=230340
X265 91 2 93 1 INV1S $T=489800 245840 1 0 $X=489800 $Y=240420
X266 93 2 619 1 INV1S $T=492900 245840 0 180 $X=491660 $Y=240420
X267 96 2 624 1 INV1S $T=492280 235760 1 0 $X=492280 $Y=230340
X268 620 2 590 1 INV1S $T=494140 255920 0 180 $X=492900 $Y=250500
X269 91 2 90 1 INV1S $T=497240 245840 1 180 $X=496000 $Y=245460
X270 621 2 623 1 INV1S $T=505920 225680 0 0 $X=505920 $Y=225300
X271 102 2 634 1 INV1S $T=507160 255920 0 180 $X=505920 $Y=250500
X272 617 2 639 1 INV1S $T=509640 235760 1 0 $X=509640 $Y=230340
X273 618 2 641 1 INV1S $T=510260 235760 0 0 $X=510260 $Y=235380
X274 638 2 676 1 INV1S $T=529480 245840 0 0 $X=529480 $Y=245460
X275 671 2 670 1 INV1S $T=531340 235760 1 0 $X=531340 $Y=230340
X276 113 2 672 1 INV1S $T=532580 245840 0 180 $X=531340 $Y=240420
X277 674 2 661 1 INV1S $T=534440 255920 0 180 $X=533200 $Y=250500
X278 685 2 688 1 INV1S $T=535680 225680 1 0 $X=535680 $Y=220260
X279 119 2 690 1 INV1S $T=542500 245840 0 180 $X=541260 $Y=240420
X280 120 2 698 1 INV1S $T=541880 255920 1 0 $X=541880 $Y=250500
X281 645 2 706 1 INV1S $T=545600 235760 1 0 $X=545600 $Y=230340
X282 712 2 716 1 INV1S $T=551800 235760 1 0 $X=551800 $Y=230340
X283 715 2 719 1 INV1S $T=554280 235760 0 180 $X=553040 $Y=230340
X284 664 2 725 1 INV1S $T=553040 245840 0 0 $X=553040 $Y=245460
X285 659 2 729 1 INV1S $T=554900 245840 1 0 $X=554900 $Y=240420
X286 700 2 718 1 INV1S $T=559240 255920 1 0 $X=559240 $Y=250500
X287 758 2 771 1 INV1S $T=574740 245840 1 180 $X=573500 $Y=245460
X288 734 2 760 1 INV1S $T=579700 235760 1 0 $X=579700 $Y=230340
X289 744 2 781 1 INV1S $T=582180 225680 1 0 $X=582180 $Y=220260
X290 792 2 790 1 INV1S $T=589000 245840 0 180 $X=587760 $Y=240420
X291 804 2 808 1 INV1S $T=599540 255920 1 0 $X=599540 $Y=250500
X292 151 2 815 1 INV1S $T=606360 255920 1 0 $X=606360 $Y=250500
X293 813 2 825 1 INV1S $T=616280 225680 0 0 $X=616280 $Y=225300
X294 157 2 821 1 INV1S $T=617520 255920 0 180 $X=616280 $Y=250500
X295 156 2 834 1 INV1S $T=618140 255920 0 0 $X=618140 $Y=255540
X296 829 2 845 1 INV1S $T=624340 245840 1 0 $X=624340 $Y=240420
X297 835 2 846 1 INV1S $T=624960 235760 0 0 $X=624960 $Y=235380
X298 159 2 853 1 INV1S $T=628060 255920 1 0 $X=628060 $Y=250500
X299 846 2 855 1 INV1S $T=628680 245840 1 0 $X=628680 $Y=240420
X300 161 2 856 1 INV1S $T=629920 255920 1 0 $X=629920 $Y=250500
X301 861 2 868 1 INV1S $T=643560 255920 1 180 $X=642320 $Y=255540
X302 872 2 892 1 INV1S $T=655960 245840 0 0 $X=655960 $Y=245460
X303 888 2 870 1 INV1S $T=659060 255920 1 180 $X=657820 $Y=255540
X304 895 2 894 1 INV1S $T=659680 245840 0 180 $X=658440 $Y=240420
X305 887 2 888 1 INV1S $T=660920 255920 1 180 $X=659680 $Y=255540
X306 907 2 898 1 INV1S $T=665260 235760 1 180 $X=664020 $Y=235380
X307 912 2 911 1 INV1S $T=672080 235760 1 180 $X=670840 $Y=235380
X308 372 1 384 382 2 363 ND3 $T=303180 225680 0 0 $X=303180 $Y=225300
X309 697 1 692 707 2 701 ND3 $T=543740 225680 0 0 $X=543740 $Y=225300
X310 783 1 141 777 2 793 ND3 $T=585900 255920 1 0 $X=585900 $Y=250500
X311 789 1 794 795 2 797 ND3 $T=589620 235760 0 0 $X=589620 $Y=235380
X312 942 1 962 963 2 966 ND3 $T=758260 255920 1 0 $X=758260 $Y=250500
X313 933 1 968 975 2 971 ND3 $T=771900 235760 0 0 $X=771900 $Y=235380
X314 960 1 972 989 2 977 ND3 $T=779960 235760 0 0 $X=779960 $Y=235380
X315 954 1 981 985 2 979 ND3 $T=788020 245840 1 0 $X=788020 $Y=240420
X316 950 1 986 992 2 988 ND3 $T=797940 245840 0 0 $X=797940 $Y=245460
X317 1000 1 216 215 2 997 ND3 $T=819020 245840 1 180 $X=816540 $Y=245460
X318 1015 1 227 228 2 1001 ND3 $T=850020 255920 0 0 $X=850020 $Y=255540
X319 1039 1 232 1038 2 994 ND3 $T=884120 255920 1 180 $X=881640 $Y=255540
X320 1042 1 233 1040 2 998 ND3 $T=892180 255920 1 180 $X=889700 $Y=255540
X321 1055 1 241 240 2 1053 ND3 $T=912640 255920 1 0 $X=912640 $Y=250500
X322 1059 1 245 242 2 1057 ND3 $T=916360 255920 0 0 $X=916360 $Y=255540
X323 1079 1 261 1049 2 1076 ND3 $T=959140 255920 1 180 $X=956660 $Y=255540
X324 1085 1 265 1052 2 1084 ND3 $T=972780 255920 1 180 $X=970300 $Y=255540
X325 1113 1 1112 1092 2 1107 ND3 $T=1021140 255920 1 180 $X=1018660 $Y=255540
X326 1115 1 1110 1094 2 1097 ND3 $T=1021760 245840 0 180 $X=1019280 $Y=240420
X327 1116 1 1114 1098 2 1104 ND3 $T=1021760 245840 1 180 $X=1019280 $Y=245460
X328 1123 1 1121 1095 2 1106 ND3 $T=1027960 245840 0 180 $X=1025480 $Y=240420
X329 24 2 378 374 1 NR2 $T=296360 255920 0 180 $X=294500 $Y=250500
X330 563 2 566 441 1 NR2 $T=438340 235760 0 0 $X=438340 $Y=235380
X331 597 2 601 594 1 NR2 $T=478020 235760 1 180 $X=476160 $Y=235380
X332 768 2 772 760 1 NR2 $T=576600 225680 1 0 $X=576600 $Y=220260
X333 148 2 812 808 1 NR2 $T=602640 255920 1 0 $X=602640 $Y=250500
X334 173 2 893 894 1 NR2 $T=656580 245840 1 0 $X=656580 $Y=240420
X335 1002 2 1000 1003 1 NR2 $T=822120 245840 0 0 $X=822120 $Y=245460
X336 1011 2 1015 1014 1 NR2 $T=843820 255920 0 0 $X=843820 $Y=255540
X337 1019 2 229 1025 1 NR2 $T=863040 255920 1 0 $X=863040 $Y=250500
X338 1026 2 230 1028 1 NR2 $T=867380 255920 0 0 $X=867380 $Y=255540
X339 1037 2 1039 1035 1 NR2 $T=884740 235760 0 180 $X=882880 $Y=230340
X340 1033 2 1042 1041 1 NR2 $T=891560 245840 0 0 $X=891560 $Y=245460
X341 1056 2 1055 1060 1 NR2 $T=919460 255920 1 0 $X=919460 $Y=250500
X342 1062 2 1059 251 1 NR2 $T=922560 255920 0 0 $X=922560 $Y=255540
X343 1070 2 259 1072 1 NR2 $T=946120 255920 1 0 $X=946120 $Y=250500
X344 1077 2 1079 1080 1 NR2 $T=957900 255920 1 0 $X=957900 $Y=250500
X345 1086 2 1085 1089 1 NR2 $T=975260 255920 1 0 $X=975260 $Y=250500
X346 591 47 1 83 47 551 2 MOAI1S $T=468720 245840 1 180 $X=465000 $Y=245460
X347 926 137 1 182 137 877 2 MOAI1S $T=690060 255920 1 0 $X=690060 $Y=250500
X348 5 330 7 1 2 ND2 $T=244280 245840 1 0 $X=244280 $Y=240420
X349 328 333 8 1 2 ND2 $T=248000 245840 1 0 $X=248000 $Y=240420
X350 12 344 7 1 2 ND2 $T=258540 255920 0 180 $X=256680 $Y=250500
X351 338 348 8 1 2 ND2 $T=260400 255920 0 180 $X=258540 $Y=250500
X352 11 347 7 1 2 ND2 $T=261020 245840 1 180 $X=259160 $Y=245460
X353 342 349 8 1 2 ND2 $T=262880 245840 1 180 $X=261020 $Y=245460
X354 362 364 360 1 2 ND2 $T=280860 245840 1 180 $X=279000 $Y=245460
X355 365 363 359 1 2 ND2 $T=283340 235760 0 180 $X=281480 $Y=230340
X356 362 369 17 1 2 ND2 $T=286440 245840 1 180 $X=284580 $Y=245460
X357 371 372 359 1 2 ND2 $T=291400 225680 0 180 $X=289540 $Y=220260
X358 360 368 17 1 2 ND2 $T=290160 245840 0 0 $X=290160 $Y=245460
X359 376 384 371 1 2 ND2 $T=308140 225680 0 0 $X=308140 $Y=225300
X360 407 403 386 1 2 ND2 $T=315580 235760 0 0 $X=315580 $Y=235380
X361 395 411 337 1 2 ND2 $T=317440 235760 0 0 $X=317440 $Y=235380
X362 392 412 335 1 2 ND2 $T=319300 245840 0 180 $X=317440 $Y=240420
X363 411 407 416 1 2 ND2 $T=318060 235760 1 0 $X=318060 $Y=230340
X364 386 417 416 1 2 ND2 $T=319920 235760 1 0 $X=319920 $Y=230340
X365 373 425 439 1 2 ND2 $T=325500 225680 0 0 $X=325500 $Y=225300
X366 412 428 408 1 2 ND2 $T=328600 235760 0 0 $X=328600 $Y=235380
X367 428 430 429 1 2 ND2 $T=329840 245840 0 0 $X=329840 $Y=245460
X368 429 426 408 1 2 ND2 $T=330460 235760 0 0 $X=330460 $Y=235380
X369 421 434 440 1 2 ND2 $T=334180 235760 0 0 $X=334180 $Y=235380
X370 438 433 22 1 2 ND2 $T=334800 255920 0 0 $X=334800 $Y=255540
X371 39 435 442 1 2 ND2 $T=335420 255920 1 0 $X=335420 $Y=250500
X372 432 424 439 1 2 ND2 $T=336660 225680 0 0 $X=336660 $Y=225300
X373 432 423 373 1 2 ND2 $T=337280 235760 1 0 $X=337280 $Y=230340
X374 43 447 44 1 2 ND2 $T=340380 255920 0 0 $X=340380 $Y=255540
X375 462 466 464 1 2 ND2 $T=363940 225680 1 0 $X=363940 $Y=220260
X376 465 472 451 1 2 ND2 $T=370760 235760 1 180 $X=368900 $Y=235380
X377 50 477 51 1 2 ND2 $T=373240 255920 0 0 $X=373240 $Y=255540
X378 52 474 54 1 2 ND2 $T=375100 255920 1 0 $X=375100 $Y=250500
X379 53 475 54 1 2 ND2 $T=376960 255920 0 0 $X=376960 $Y=255540
X380 484 496 391 1 2 ND2 $T=382540 225680 1 0 $X=382540 $Y=220260
X381 57 498 51 1 2 ND2 $T=387500 255920 1 180 $X=385640 $Y=255540
X382 495 490 51 1 2 ND2 $T=388120 255920 0 180 $X=386260 $Y=250500
X383 58 488 54 1 2 ND2 $T=388120 255920 1 0 $X=388120 $Y=250500
X384 498 494 502 1 2 ND2 $T=391840 255920 0 0 $X=391840 $Y=255540
X385 60 502 54 1 2 ND2 $T=393700 255920 0 0 $X=393700 $Y=255540
X386 500 507 61 1 2 ND2 $T=397420 245840 0 180 $X=395560 $Y=240420
X387 467 508 503 1 2 ND2 $T=400520 225680 1 0 $X=400520 $Y=220260
X388 513 521 510 1 2 ND2 $T=403000 235760 0 180 $X=401140 $Y=230340
X389 431 531 526 1 2 ND2 $T=416640 225680 0 180 $X=414780 $Y=220260
X390 519 537 528 1 2 ND2 $T=418500 245840 0 180 $X=416640 $Y=240420
X391 529 540 525 1 2 ND2 $T=418500 225680 0 0 $X=418500 $Y=225300
X392 539 544 543 1 2 ND2 $T=418500 255920 1 0 $X=418500 $Y=250500
X393 536 548 525 1 2 ND2 $T=420360 225680 0 0 $X=420360 $Y=225300
X394 547 541 70 1 2 ND2 $T=420360 235760 0 0 $X=420360 $Y=235380
X395 555 556 553 1 2 ND2 $T=432140 235760 0 180 $X=430280 $Y=230340
X396 436 559 563 1 2 ND2 $T=434620 235760 0 0 $X=434620 $Y=235380
X397 437 564 558 1 2 ND2 $T=438340 245840 0 180 $X=436480 $Y=240420
X398 567 568 570 1 2 ND2 $T=439580 225680 0 0 $X=439580 $Y=225300
X399 75 573 77 1 2 ND2 $T=443300 255920 0 180 $X=441440 $Y=250500
X400 597 599 596 1 2 ND2 $T=474920 245840 0 180 $X=473060 $Y=240420
X401 87 605 603 1 2 ND2 $T=482360 245840 1 180 $X=480500 $Y=245460
X402 87 609 90 1 2 ND2 $T=483600 255920 1 0 $X=483600 $Y=250500
X403 612 613 609 1 2 ND2 $T=487320 255920 0 180 $X=485460 $Y=250500
X404 593 615 91 1 2 ND2 $T=486700 235760 1 0 $X=486700 $Y=230340
X405 614 612 91 1 2 ND2 $T=487320 255920 1 0 $X=487320 $Y=250500
X406 616 627 91 1 2 ND2 $T=498480 225680 1 180 $X=496620 $Y=225300
X407 97 633 93 1 2 ND2 $T=500340 225680 1 180 $X=498480 $Y=225300
X408 627 635 633 1 2 ND2 $T=502200 225680 1 180 $X=500340 $Y=225300
X409 102 636 93 1 2 ND2 $T=504680 245840 1 180 $X=502820 $Y=245460
X410 629 654 640 1 2 ND2 $T=518940 235760 1 180 $X=517080 $Y=235380
X411 629 657 104 1 2 ND2 $T=520800 235760 1 180 $X=518940 $Y=235380
X412 658 660 656 1 2 ND2 $T=527000 225680 1 180 $X=525140 $Y=225300
X413 661 662 639 1 2 ND2 $T=527000 235760 0 180 $X=525140 $Y=230340
X414 665 667 109 1 2 ND2 $T=528860 245840 1 180 $X=527000 $Y=245460
X415 658 669 635 1 2 ND2 $T=529480 225680 1 180 $X=527620 $Y=225300
X416 656 677 635 1 2 ND2 $T=531960 225680 0 180 $X=530100 $Y=220260
X417 686 684 670 1 2 ND2 $T=536300 225680 1 180 $X=534440 $Y=225300
X418 681 656 687 1 2 ND2 $T=534440 255920 1 0 $X=534440 $Y=250500
X419 680 686 678 1 2 ND2 $T=536300 225680 0 0 $X=536300 $Y=225300
X420 667 674 679 1 2 ND2 $T=538160 245840 1 180 $X=536300 $Y=245460
X421 678 692 617 1 2 ND2 $T=540020 225680 1 180 $X=538160 $Y=225300
X422 674 697 617 1 2 ND2 $T=541880 225680 1 180 $X=540020 $Y=225300
X423 678 701 674 1 2 ND2 $T=543740 225680 1 180 $X=541880 $Y=225300
X424 684 702 648 1 2 ND2 $T=543740 235760 1 0 $X=543740 $Y=230340
X425 691 713 648 1 2 ND2 $T=549320 225680 1 180 $X=547460 $Y=225300
X426 704 709 712 1 2 ND2 $T=547460 235760 0 0 $X=547460 $Y=235380
X427 707 710 691 1 2 ND2 $T=554900 225680 1 180 $X=553040 $Y=225300
X428 712 726 703 1 2 ND2 $T=554900 245840 0 180 $X=553040 $Y=240420
X429 732 727 721 1 2 ND2 $T=556140 235760 0 180 $X=554280 $Y=230340
X430 730 732 720 1 2 ND2 $T=556140 235760 1 0 $X=556140 $Y=230340
X431 726 132 723 1 2 ND2 $T=556140 245840 0 0 $X=556140 $Y=245460
X432 734 735 645 1 2 ND2 $T=559240 225680 0 180 $X=557380 $Y=220260
X433 733 730 737 1 2 ND2 $T=558000 235760 1 0 $X=558000 $Y=230340
X434 741 739 738 1 2 ND2 $T=561100 245840 1 180 $X=559240 $Y=245460
X435 708 733 625 1 2 ND2 $T=561720 235760 0 180 $X=559860 $Y=230340
X436 742 741 664 1 2 ND2 $T=560480 255920 1 0 $X=560480 $Y=250500
X437 738 746 742 1 2 ND2 $T=562960 245840 1 180 $X=561100 $Y=245460
X438 746 748 664 1 2 ND2 $T=564200 255920 0 180 $X=562340 $Y=250500
X439 748 753 752 1 2 ND2 $T=564200 255920 1 0 $X=564200 $Y=250500
X440 758 757 659 1 2 ND2 $T=567920 245840 0 180 $X=566060 $Y=240420
X441 761 754 739 1 2 ND2 $T=568540 235760 0 0 $X=568540 $Y=235380
X442 135 738 759 1 2 ND2 $T=568540 245840 0 0 $X=568540 $Y=245460
X443 764 769 750 1 2 ND2 $T=572260 225680 0 180 $X=570400 $Y=220260
X444 767 765 739 1 2 ND2 $T=572260 235760 1 180 $X=570400 $Y=235380
X445 779 780 744 1 2 ND2 $T=580320 225680 0 180 $X=578460 $Y=220260
X446 786 784 744 1 2 ND2 $T=585280 225680 0 180 $X=583420 $Y=220260
X447 139 783 140 1 2 ND2 $T=585900 255920 1 180 $X=584040 $Y=255540
X448 784 787 788 1 2 ND2 $T=585280 225680 0 0 $X=585280 $Y=225300
X449 791 788 781 1 2 ND2 $T=589000 225680 1 180 $X=587140 $Y=225300
X450 139 793 142 1 2 ND2 $T=588380 255920 0 0 $X=588380 $Y=255540
X451 773 797 782 1 2 ND2 $T=592720 235760 0 180 $X=590860 $Y=230340
X452 798 774 801 1 2 ND2 $T=591480 255920 1 0 $X=591480 $Y=250500
X453 685 796 792 1 2 ND2 $T=592720 225680 1 0 $X=592720 $Y=220260
X454 800 798 143 1 2 ND2 $T=594580 245840 1 180 $X=592720 $Y=245460
X455 773 794 785 1 2 ND2 $T=594580 235760 0 0 $X=594580 $Y=235380
X456 149 807 144 1 2 ND2 $T=600780 255920 1 180 $X=598920 $Y=255540
X457 809 805 807 1 2 ND2 $T=602640 255920 1 180 $X=600780 $Y=255540
X458 148 802 804 1 2 ND2 $T=602020 245840 0 0 $X=602020 $Y=245460
X459 152 809 143 1 2 ND2 $T=604500 255920 1 180 $X=602640 $Y=255540
X460 814 824 819 1 2 ND2 $T=618140 235760 1 180 $X=616280 $Y=235380
X461 827 828 825 1 2 ND2 $T=618760 225680 0 180 $X=616900 $Y=220260
X462 832 831 829 1 2 ND2 $T=620000 235760 1 180 $X=618140 $Y=235380
X463 833 832 837 1 2 ND2 $T=619380 245840 0 0 $X=619380 $Y=245460
X464 838 826 828 1 2 ND2 $T=621860 235760 0 180 $X=620000 $Y=230340
X465 835 833 159 1 2 ND2 $T=620000 235760 0 0 $X=620000 $Y=235380
X466 839 838 813 1 2 ND2 $T=621860 235760 1 0 $X=621860 $Y=230340
X467 837 841 829 1 2 ND2 $T=622480 245840 1 0 $X=622480 $Y=240420
X468 842 839 844 1 2 ND2 $T=623720 235760 1 0 $X=623720 $Y=230340
X469 831 850 848 1 2 ND2 $T=628060 245840 1 180 $X=626200 $Y=245460
X470 846 852 159 1 2 ND2 $T=628060 245840 0 0 $X=628060 $Y=245460
X471 850 842 731 1 2 ND2 $T=628680 225680 1 0 $X=628680 $Y=220260
X472 860 864 851 1 2 ND2 $T=636740 235760 1 180 $X=634880 $Y=235380
X473 872 876 869 1 2 ND2 $T=644800 245840 1 180 $X=642940 $Y=245460
X474 168 171 874 1 2 ND2 $T=644800 255920 0 0 $X=644800 $Y=255540
X475 867 879 847 1 2 ND2 $T=649140 235760 0 180 $X=647280 $Y=230340
X476 880 878 866 1 2 ND2 $T=649140 245840 0 180 $X=647280 $Y=240420
X477 887 886 861 1 2 ND2 $T=654720 255920 1 180 $X=652860 $Y=255540
X478 727 885 840 1 2 ND2 $T=655340 225680 1 180 $X=653480 $Y=225300
X479 867 882 891 1 2 ND2 $T=653480 235760 1 0 $X=653480 $Y=230340
X480 884 889 872 1 2 ND2 $T=654100 245840 0 0 $X=654100 $Y=245460
X481 888 869 868 1 2 ND2 $T=654720 255920 0 0 $X=654720 $Y=255540
X482 727 890 871 1 2 ND2 $T=657200 225680 1 180 $X=655340 $Y=225300
X483 847 883 891 1 2 ND2 $T=655960 235760 1 0 $X=655960 $Y=230340
X484 893 901 898 1 2 ND2 $T=660300 245840 1 0 $X=660300 $Y=240420
X485 902 903 895 1 2 ND2 $T=663400 255920 0 180 $X=661540 $Y=250500
X486 714 914 910 1 2 ND2 $T=670840 225680 1 180 $X=668980 $Y=225300
X487 895 916 173 1 2 ND2 $T=673320 245840 1 180 $X=671460 $Y=245460
X488 908 917 714 1 2 ND2 $T=675180 225680 0 180 $X=673320 $Y=220260
X489 910 918 908 1 2 ND2 $T=675180 225680 1 0 $X=675180 $Y=220260
X490 912 919 907 1 2 ND2 $T=676420 245840 1 0 $X=676420 $Y=240420
X491 397 398 394 2 1 ND2S $T=311860 235760 0 180 $X=310000 $Y=230340
X492 405 415 353 2 1 ND2S $T=319300 245840 1 0 $X=319300 $Y=240420
X493 41 438 446 2 1 ND2S $T=338520 255920 1 0 $X=338520 $Y=250500
X494 468 467 466 2 1 ND2S $T=367660 225680 0 180 $X=365800 $Y=220260
X495 478 476 51 2 1 ND2S $T=373240 255920 1 0 $X=373240 $Y=250500
X496 391 501 503 2 1 ND2S $T=393700 225680 1 0 $X=393700 $Y=220260
X497 443 510 505 2 1 ND2S $T=399280 235760 1 0 $X=399280 $Y=230340
X498 404 522 505 2 1 ND2S $T=405480 225680 0 180 $X=403620 $Y=220260
X499 441 555 561 2 1 ND2S $T=438960 235760 0 180 $X=437100 $Y=230340
X500 628 637 91 2 1 ND2S $T=506540 245840 1 180 $X=504680 $Y=245460
X501 662 666 670 2 1 ND2S $T=527000 235760 1 0 $X=527000 $Y=230340
X502 683 681 109 2 1 ND2S $T=540020 255920 1 0 $X=540020 $Y=250500
X503 717 711 716 2 1 ND2S $T=549320 235760 0 0 $X=549320 $Y=235380
X504 722 721 719 2 1 ND2S $T=553040 235760 1 180 $X=551180 $Y=235380
X505 751 752 725 2 1 ND2S $T=566060 245840 0 180 $X=564200 $Y=240420
X506 785 789 782 2 1 ND2S $T=589000 235760 0 180 $X=587140 $Y=230340
X507 148 801 144 2 1 ND2S $T=595200 255920 1 0 $X=595200 $Y=250500
X508 849 848 845 2 1 ND2S $T=627440 245840 0 180 $X=625580 $Y=240420
X509 886 884 869 2 1 ND2S $T=654100 255920 0 180 $X=652240 $Y=250500
X510 897 896 892 2 1 ND2S $T=660920 255920 0 180 $X=659060 $Y=250500
X511 911 906 907 2 1 ND2S $T=667120 235760 0 0 $X=667120 $Y=235380
X512 513 522 1 518 505 2 511 520 510 OAI222S $T=404860 225680 1 180 $X=399280 $Y=225300
X513 575 579 1 571 583 2 79 586 587 OAI222S $T=444540 255920 1 0 $X=444540 $Y=250500
X514 444 582 1 580 584 2 577 588 578 OAI222S $T=445780 245840 1 0 $X=445780 $Y=240420
X515 174 904 1 906 909 901 2 OAI112HS $T=662780 245840 1 0 $X=662780 $Y=240420
X516 563 441 2 566 1 576 AOI12HS $T=438960 235760 1 0 $X=438960 $Y=230340
X517 768 760 2 772 1 766 AOI12HS $T=572260 225680 1 0 $X=572260 $Y=220260
X518 167 166 2 165 1 863 AOI12HS $T=641700 255920 1 180 $X=637360 $Y=255540
X519 446 41 1 438 2 40 OAI12HS $T=340380 255920 1 180 $X=336660 $Y=255540
X520 530 449 1 529 2 536 OAI12HS $T=414780 225680 0 0 $X=414780 $Y=225300
X521 525 545 1 548 2 552 OAI12HS $T=422220 225680 1 0 $X=422220 $Y=220260
X522 561 441 1 555 2 567 OAI12HS $T=435860 225680 0 0 $X=435860 $Y=225300
X523 570 576 1 568 2 589 OAI12HS $T=443300 235760 1 0 $X=443300 $Y=230340
X524 596 597 1 599 2 604 OAI12HS $T=478020 245840 1 0 $X=478020 $Y=240420
X525 603 87 1 605 2 614 OAI12HS $T=482360 245840 0 0 $X=482360 $Y=245460
X526 619 590 1 615 2 617 OAI12HS $T=492280 235760 0 180 $X=488560 $Y=230340
X527 676 700 1 703 2 704 OAI12HS $T=542500 245840 1 0 $X=542500 $Y=240420
X528 706 760 1 755 2 764 OAI12HS $T=566680 225680 0 0 $X=566680 $Y=225300
X529 739 763 1 765 2 762 OAI12HS $T=567920 245840 1 0 $X=567920 $Y=240420
X530 750 766 1 769 2 728 OAI12HS $T=570400 225680 0 0 $X=570400 $Y=225300
X531 729 771 1 761 2 767 OAI12HS $T=575360 245840 1 0 $X=575360 $Y=240420
X532 790 688 1 779 2 786 OAI12HS $T=589000 225680 0 180 $X=585280 $Y=220260
X533 804 148 1 802 2 800 OAI12HS $T=599540 245840 1 180 $X=595820 $Y=245460
X534 159 846 1 852 2 849 OAI12HS $T=626200 235760 0 0 $X=626200 $Y=235380
X535 1009 225 224 1007 1005 222 1 2 1002 AO222 $T=832660 235760 0 180 $X=826460 $Y=230340
X536 1016 225 224 1012 1013 222 1 2 1011 AO222 $T=847540 235760 0 180 $X=841340 $Y=230340
X537 1027 225 224 1022 1017 222 1 2 1019 AO222 $T=862420 235760 0 180 $X=856220 $Y=230340
X538 1020 225 224 1023 1024 222 1 2 1026 AO222 $T=858700 245840 0 0 $X=858700 $Y=245460
X539 1029 225 224 1030 1031 222 1 2 1033 AO222 $T=870480 235760 1 0 $X=870480 $Y=230340
X540 1048 225 224 1047 1045 222 1 2 1037 AO222 $T=898380 235760 0 180 $X=892180 $Y=230340
X541 1061 249 248 1054 1051 246 1 2 1056 AO222 $T=925040 235760 0 180 $X=918840 $Y=230340
X542 1064 249 248 1063 1058 246 1 2 1062 AO222 $T=928760 245840 0 180 $X=922560 $Y=240420
X543 1069 249 248 1068 1067 246 1 2 256 AO222 $T=941780 235760 1 180 $X=935580 $Y=235380
X544 1073 249 248 1074 1071 246 1 2 1070 AO222 $T=952320 235760 1 180 $X=946120 $Y=235380
X545 1082 249 248 1081 1078 246 1 2 1077 AO222 $T=965960 235760 1 180 $X=959760 $Y=235380
X546 1091 249 248 1087 1088 246 1 2 1086 AO222 $T=980840 235760 1 180 $X=974640 $Y=235380
X547 13 350 1 2 INV2 $T=262880 235760 0 0 $X=262880 $Y=235380
X548 436 441 1 2 INV2 $T=334180 245840 1 0 $X=334180 $Y=240420
X549 554 563 1 2 INV2 $T=436480 235760 0 0 $X=436480 $Y=235380
X550 598 603 1 2 INV2 $T=478640 245840 0 0 $X=478640 $Y=245460
X551 607 600 1 2 INV2 $T=483600 245840 1 0 $X=483600 $Y=240420
X552 610 629 1 2 INV2 $T=492900 245840 1 0 $X=492900 $Y=240420
X553 97 611 1 2 INV2 $T=495380 225680 1 180 $X=493520 $Y=225300
X554 724 700 1 2 INV2 $T=556140 245840 1 180 $X=554280 $Y=245460
X555 143 144 1 2 INV2 $T=592100 255920 0 0 $X=592100 $Y=255540
X556 145 146 1 2 INV2 $T=595820 255920 1 180 $X=593960 $Y=255540
X557 598 2 87 1 596 NR2P $T=478640 245840 1 180 $X=474920 $Y=245460
X558 652 105 2 644 641 1 OR3B2 $T=517080 235760 1 180 $X=513360 $Y=235380
X559 105 641 2 650 653 1 OR3B2 $T=513980 225680 0 0 $X=513980 $Y=225300
X560 3 4 1 2 BUF2CK $T=226300 225680 1 0 $X=226300 $Y=220260
X561 3 247 1 2 BUF2CK $T=912020 225680 1 0 $X=912020 $Y=220260
X562 500 1 2 527 BUF1CK $T=409820 235760 0 0 $X=409820 $Y=235380
X563 519 1 2 534 BUF1CK $T=414780 245840 0 0 $X=414780 $Y=245460
X564 651 1 2 652 BUF1CK $T=517700 225680 0 0 $X=517700 $Y=225300
X565 673 1 2 685 BUF1CK $T=536920 225680 1 0 $X=536920 $Y=220260
X566 749 1 2 751 BUF1CK $T=564200 255920 0 0 $X=564200 $Y=255540
X567 758 1 2 770 BUF1CK $T=579080 245840 1 0 $X=579080 $Y=240420
X568 923 1 2 924 BUF1CK $T=680140 225680 0 0 $X=680140 $Y=225300
X569 382 1 2 389 BUF1S $T=310000 225680 0 0 $X=310000 $Y=225300
X570 470 1 2 469 BUF1S $T=367040 255920 1 0 $X=367040 $Y=250500
X571 489 1 2 516 BUF1S $T=403000 245840 0 0 $X=403000 $Y=245460
X572 539 1 2 557 BUF1S $T=432140 245840 0 0 $X=432140 $Y=245460
X573 553 1 2 570 BUF1S $T=435860 225680 1 0 $X=435860 $Y=220260
X574 572 1 2 583 BUF1S $T=447640 255920 0 0 $X=447640 $Y=255540
X575 80 1 2 81 BUF1S $T=450120 255920 0 0 $X=450120 $Y=255540
X576 558 1 2 585 BUF1S $T=451360 245840 0 0 $X=451360 $Y=245460
X577 550 1 2 82 BUF1S $T=452600 255920 0 0 $X=452600 $Y=255540
X578 651 1 2 653 BUF1S $T=516460 225680 1 0 $X=516460 $Y=220260
X579 678 1 2 693 BUF1S $T=543120 225680 1 0 $X=543120 $Y=220260
X580 715 1 2 720 BUF1S $T=550560 225680 0 0 $X=550560 $Y=225300
X581 724 1 2 740 BUF1S $T=565440 235760 1 0 $X=565440 $Y=230340
X582 645 1 2 768 BUF1S $T=574740 235760 0 0 $X=574740 $Y=235380
X583 908 1 2 920 BUF1S $T=672080 235760 1 0 $X=672080 $Y=230340
X584 915 1 2 922 BUF1S $T=677660 235760 0 0 $X=677660 $Y=235380
X585 1043 1 2 234 DELB $T=892180 255920 0 0 $X=892180 $Y=255540
X586 1050 1 2 237 DELB $T=902100 255920 0 0 $X=902100 $Y=255540
X587 132 2 1 736 BUF1 $T=556140 255920 0 0 $X=556140 $Y=255540
X588 343 8 340 2 10 7 1 AO22 $T=254820 245840 0 180 $X=249860 $Y=240420
X589 362 8 354 2 14 7 1 AO22 $T=274040 255920 0 180 $X=269080 $Y=250500
X590 359 8 356 2 13 7 1 AO22 $T=274660 235760 1 180 $X=269700 $Y=235380
X591 367 8 366 2 16 7 1 AO22 $T=285820 235760 1 180 $X=280860 $Y=235380
X592 381 26 375 2 27 25 1 AO22 $T=300080 245840 1 0 $X=300080 $Y=240420
X593 371 26 383 2 24 25 1 AO22 $T=305040 255920 0 180 $X=300080 $Y=250500
X594 392 26 388 2 29 25 1 AO22 $T=310000 235760 1 180 $X=305040 $Y=235380
X595 395 26 390 2 28 25 1 AO22 $T=311240 245840 0 180 $X=306280 $Y=240420
X596 405 25 30 2 396 26 1 AO22 $T=314960 255920 1 180 $X=310000 $Y=255540
X597 528 65 506 2 64 54 1 AO22 $T=412300 245840 1 180 $X=407340 $Y=245460
X598 543 65 532 2 71 54 1 AO22 $T=427800 255920 1 180 $X=422840 $Y=255540
X599 625 91 622 2 96 93 1 AO22 $T=496620 235760 1 180 $X=491660 $Y=235380
X600 648 91 642 2 621 93 1 AO22 $T=513980 225680 1 180 $X=509020 $Y=225300
X601 691 109 682 2 113 110 1 AO22 $T=538160 245840 0 180 $X=533200 $Y=240420
X602 708 109 694 2 119 110 1 AO22 $T=547460 235760 1 180 $X=542500 $Y=235380
X603 724 109 705 2 120 110 1 AO22 $T=553040 245840 1 180 $X=548080 $Y=245460
X604 133 109 129 2 127 110 1 AO22 $T=558000 255920 0 180 $X=553040 $Y=250500
X605 819 143 155 2 154 144 1 AO22 $T=616280 255920 1 180 $X=611320 $Y=255540
X606 847 143 817 2 157 144 1 AO22 $T=626200 245840 1 180 $X=621240 $Y=245460
X607 851 143 843 2 156 144 1 AO22 $T=628060 255920 0 180 $X=623100 $Y=250500
X608 861 143 163 2 162 144 1 AO22 $T=636120 255920 1 180 $X=631160 $Y=255540
X609 866 143 865 2 161 144 1 AO22 $T=641080 255920 0 180 $X=636120 $Y=250500
X610 1003 220 1004 2 1006 223 1 AO22 $T=825220 245840 0 0 $X=825220 $Y=245460
X611 1014 220 1010 2 1008 223 1 AO22 $T=839480 255920 1 180 $X=834520 $Y=255540
X612 1025 220 1021 2 1018 223 1 AO22 $T=860560 255920 0 180 $X=855600 $Y=250500
X613 1028 220 231 2 1032 223 1 AO22 $T=872340 255920 0 0 $X=872340 $Y=255540
X614 1035 220 1036 2 1034 223 1 AO22 $T=886600 245840 1 180 $X=881640 $Y=245460
X615 1041 220 1044 2 1046 223 1 AO22 $T=891560 255920 1 0 $X=891560 $Y=250500
X616 1050 236 1049 2 1040 235 1 AO22 $T=902100 255920 1 180 $X=897140 $Y=255540
X617 1043 236 1052 2 1038 235 1 AO22 $T=907060 255920 0 0 $X=907060 $Y=255540
X618 1060 252 1065 2 1066 254 1 AO22 $T=926900 255920 0 0 $X=926900 $Y=255540
X619 1072 252 260 2 1075 254 1 AO22 $T=949840 255920 1 0 $X=949840 $Y=250500
X620 1080 252 262 2 1083 254 1 AO22 $T=962240 255920 0 0 $X=962240 $Y=255540
X621 1089 252 266 2 1090 254 1 AO22 $T=979600 255920 1 0 $X=979600 $Y=250500
X622 446 41 45 442 2 1 MXL2HS $T=342240 255920 0 0 $X=342240 $Y=255540
X623 575 76 587 583 2 1 MXL2HS $T=450120 255920 1 0 $X=450120 $Y=250500
X624 590 592 593 595 2 1 MXL2HS $T=468720 225680 0 0 $X=468720 $Y=225300
X625 99 632 100 101 2 1 MXL2HS $T=500340 255920 0 0 $X=500340 $Y=255540
X626 689 693 696 666 2 1 MXL2HS $T=538160 235760 1 0 $X=538160 $Y=230340
X627 907 895 904 898 2 1 MXL2HS $T=669600 235760 0 180 $X=664020 $Y=230340
X628 445 42 46 2 1 452 QDFFRBN $T=338520 245840 1 0 $X=338520 $Y=240420
X629 447 42 46 2 1 454 QDFFRBN $T=340380 255920 1 0 $X=340380 $Y=250500
X630 450 42 46 2 1 455 QDFFRBN $T=344100 225680 0 0 $X=344100 $Y=225300
X631 482 42 46 2 1 492 QDFFRBN $T=375100 235760 1 0 $X=375100 $Y=230340
X632 491 42 46 2 1 504 QDFFRBN $T=388120 235760 0 0 $X=388120 $Y=235380
X633 520 42 46 2 1 524 QDFFRBN $T=403000 235760 1 0 $X=403000 $Y=230340
X634 552 42 46 2 1 538 QDFFRBN $T=434000 225680 1 180 $X=422220 $Y=225300
X635 589 42 46 2 1 574 QDFFRBN $T=455080 225680 1 180 $X=443300 $Y=225300
X636 588 42 46 2 1 591 QDFFRBN $T=453840 235760 0 0 $X=453840 $Y=235380
X637 586 42 46 2 1 84 QDFFRBN $T=455700 255920 0 0 $X=455700 $Y=255540
X638 728 42 46 2 1 756 QDFFRBN $T=554900 225680 0 0 $X=554900 $Y=225300
X639 753 42 46 2 1 776 QDFFRBN $T=566060 255920 1 0 $X=566060 $Y=250500
X640 762 42 46 2 1 778 QDFFRBN $T=567920 235760 1 0 $X=567920 $Y=230340
X641 787 42 150 2 1 810 QDFFRBN $T=592720 225680 0 0 $X=592720 $Y=225300
X642 811 42 150 2 1 822 QDFFRBN $T=604500 225680 0 0 $X=604500 $Y=225300
X643 826 42 150 2 1 854 QDFFRBN $T=617520 225680 0 0 $X=617520 $Y=225300
X644 875 42 150 2 1 862 QDFFRBN $T=647900 225680 0 180 $X=636120 $Y=220260
X645 909 42 150 2 1 181 QDFFRBN $T=675800 255920 1 0 $X=675800 $Y=250500
X646 921 42 150 2 1 926 QDFFRBN $T=677040 245840 0 0 $X=677040 $Y=245460
X647 924 42 150 2 1 927 QDFFRBN $T=682620 225680 0 0 $X=682620 $Y=225300
X648 480 2 393 464 473 1 482 FA1S $T=370140 225680 0 0 $X=370140 $Y=225300
X649 14 15 354 2 1 XNR2HS $T=266600 255920 0 0 $X=266600 $Y=255540
X650 526 431 545 2 1 XNR2HS $T=416640 225680 1 0 $X=416640 $Y=220260
X651 325 326 328 2 1 XOR2HS $T=234360 245840 1 0 $X=234360 $Y=240420
X652 329 327 332 2 1 XOR2HS $T=238700 225680 0 0 $X=238700 $Y=225300
X653 336 334 338 2 1 XOR2HS $T=243660 255920 1 0 $X=243660 $Y=250500
X654 339 331 342 2 1 XOR2HS $T=251100 245840 0 0 $X=251100 $Y=245460
X655 346 345 340 2 1 XOR2HS $T=259160 225680 1 180 $X=253580 $Y=225300
X656 350 358 356 2 1 XOR2HS $T=275900 225680 1 180 $X=270320 $Y=225300
X657 357 361 366 2 1 XOR2HS $T=279620 245840 1 0 $X=279620 $Y=240420
X658 377 378 375 2 1 XOR2HS $T=298220 245840 0 180 $X=292640 $Y=240420
X659 23 385 383 2 1 XOR2HS $T=304420 255920 0 0 $X=304420 $Y=255540
X660 387 380 390 2 1 XOR2HS $T=305040 255920 1 0 $X=305040 $Y=250500
X661 402 400 388 2 1 XOR2HS $T=316200 245840 1 180 $X=310620 $Y=245460
X662 33 31 396 2 1 XOR2HS $T=318060 255920 0 0 $X=318060 $Y=255540
X663 335 392 421 2 1 XOR2HS $T=319300 235760 0 0 $X=319300 $Y=235380
X664 337 395 397 2 1 XOR2HS $T=324260 235760 1 0 $X=324260 $Y=230340
X665 353 405 427 2 1 XOR2HS $T=324880 245840 1 0 $X=324880 $Y=240420
X666 422 427 436 2 1 XOR2HS $T=331700 245840 0 0 $X=331700 $Y=245460
X667 487 55 478 2 1 XOR2HS $T=382540 255920 0 180 $X=376960 $Y=250500
X668 59 56 495 2 1 XOR2HS $T=390600 255920 1 0 $X=390600 $Y=250500
X669 517 514 506 2 1 XOR2HS $T=402380 255920 0 180 $X=396800 $Y=250500
X670 513 404 518 2 1 XOR2HS $T=404860 225680 0 0 $X=404860 $Y=225300
X671 68 69 532 2 1 XOR2HS $T=412920 255920 1 0 $X=412920 $Y=250500
X672 600 601 606 2 1 XOR2HS $T=479880 235760 0 0 $X=479880 $Y=235380
X673 611 608 616 2 1 XOR2HS $T=486080 225680 0 0 $X=486080 $Y=225300
X674 634 631 628 2 1 XOR2HS $T=502200 235760 1 180 $X=496620 $Y=235380
X675 624 626 622 2 1 XOR2HS $T=500960 235760 1 0 $X=500960 $Y=230340
X676 643 630 103 2 1 XOR2HS $T=512740 255920 0 180 $X=507160 $Y=250500
X677 623 602 642 2 1 XOR2HS $T=507780 225680 1 0 $X=507780 $Y=220260
X678 111 668 665 2 1 XOR2HS $T=531340 245840 0 180 $X=525760 $Y=240420
X679 672 663 682 2 1 XOR2HS $T=531340 235760 0 0 $X=531340 $Y=235380
X680 114 112 683 2 1 XOR2HS $T=531340 255920 0 0 $X=531340 $Y=255540
X681 690 675 694 2 1 XOR2HS $T=536920 235760 0 0 $X=536920 $Y=235380
X682 117 118 699 2 1 XOR2HS $T=538780 255920 0 0 $X=538780 $Y=255540
X683 698 695 705 2 1 XOR2HS $T=542500 245840 0 0 $X=542500 $Y=245460
X684 625 708 722 2 1 XOR2HS $T=558620 235760 1 180 $X=553040 $Y=235380
X685 638 740 717 2 1 XOR2HS $T=558620 245840 1 0 $X=558620 $Y=240420
X686 759 135 749 2 1 XOR2HS $T=568540 245840 1 180 $X=562960 $Y=245460
X687 139 138 759 2 1 XOR2HS $T=583420 255920 1 180 $X=577840 $Y=255540
X688 792 685 791 2 1 XOR2HS $T=594580 225680 1 0 $X=594580 $Y=220260
X689 815 812 816 2 1 XOR2HS $T=608840 255920 1 0 $X=608840 $Y=250500
X690 821 820 817 2 1 XOR2HS $T=615040 245840 1 180 $X=609460 $Y=245460
X691 834 158 843 2 1 XOR2HS $T=620620 255920 0 0 $X=620620 $Y=255540
X692 731 850 827 2 1 XOR2HS $T=630540 225680 1 0 $X=630540 $Y=220260
X693 856 830 865 2 1 XOR2HS $T=635500 245840 0 0 $X=635500 $Y=245460
X694 861 887 897 2 1 XOR2HS $T=660920 255920 0 0 $X=660920 $Y=255540
X695 714 910 913 2 1 XOR2HS $T=667740 225680 1 0 $X=667740 $Y=220260
X696 913 920 923 2 1 XOR2HS $T=677660 225680 1 0 $X=677660 $Y=220260
X697 110 109 108 1 2 643 OA12 $T=521420 255920 1 180 $X=517700 $Y=255540
X698 392 335 2 1 408 OR2 $T=313720 245840 1 0 $X=313720 $Y=240420
X699 341 409 2 1 410 OR2 $T=315580 235760 1 0 $X=315580 $Y=230340
X700 353 405 2 1 414 OR2 $T=316200 245840 0 0 $X=316200 $Y=245460
X701 395 337 2 1 416 OR2 $T=324260 235760 0 180 $X=321780 $Y=230340
X702 431 526 2 1 529 OR2 $T=412300 225680 1 0 $X=412300 $Y=220260
X703 76 77 2 1 571 OR2 $T=438960 255920 1 0 $X=438960 $Y=250500
X704 437 560 2 1 580 OR2 $T=443300 245840 1 0 $X=443300 $Y=240420
X705 674 617 2 1 680 OR2 $T=532580 235760 1 0 $X=532580 $Y=230340
X706 111 115 2 1 679 OR2 $T=536300 245840 1 180 $X=533820 $Y=245460
X707 114 115 2 1 687 OR2 $T=536300 255920 1 0 $X=536300 $Y=250500
X708 122 128 2 1 126 OR2 $T=556140 255920 1 180 $X=553660 $Y=255540
X709 724 638 2 1 703 OR2 $T=558620 245840 0 180 $X=556140 $Y=240420
X710 625 708 2 1 737 OR2 $T=558620 235760 0 0 $X=558620 $Y=235380
X711 758 659 2 1 761 OR2 $T=574740 235760 1 180 $X=572260 $Y=235380
X712 673 792 2 1 779 OR2 $T=591480 225680 0 180 $X=589000 $Y=220260
X713 895 173 2 1 912 OR2 $T=668980 245840 1 0 $X=668980 $Y=240420
X714 443 505 2 1 509 OR2S $T=396800 225680 0 0 $X=396800 $Y=225300
X715 105 646 618 652 2 655 1 AOI13HS $T=515840 235760 1 0 $X=515840 $Y=230340
X716 131 736 1 134 747 736 2 MOAI1 $T=558620 255920 0 0 $X=558620 $Y=255540
X717 170 874 1 863 172 874 2 MOAI1 $T=647900 255920 0 0 $X=647900 $Y=255540
X718 524 47 1 512 2 AN2S $T=409820 235760 1 180 $X=407340 $Y=235380
X719 854 137 1 835 2 AN2S $T=630540 235760 0 0 $X=630540 $Y=235380
X720 151 144 2 1 785 816 MUX2 $T=605120 245840 0 0 $X=605120 $Y=245460
X721 680 2 671 689 1 AN2B1S $T=535060 235760 1 0 $X=535060 $Y=230340
X722 22 19 2 18 21 1 360 FA1 $T=292640 255920 1 180 $X=277140 $Y=255540
X723 379 367 2 20 370 1 365 FA1 $T=298840 235760 0 180 $X=283340 $Y=230340
X724 450 453 2 379 448 1 462 FA1 $T=343480 225680 1 0 $X=343480 $Y=220260
X725 439 458 2 456 460 1 463 FA1 $T=349680 235760 0 0 $X=349680 $Y=235380
X726 442 48 2 459 49 1 461 FA1 $T=354020 255920 0 0 $X=354020 $Y=255540
X727 364 370 368 369 1 2 ND3P $T=287060 245840 1 0 $X=287060 $Y=240420
X728 423 448 424 425 1 2 ND3P $T=323020 225680 1 0 $X=323020 $Y=220260
X729 496 513 508 501 1 2 ND3P $T=395560 225680 1 0 $X=395560 $Y=220260
X730 646 645 644 650 1 2 ND3P $T=510880 235760 1 0 $X=510880 $Y=230340
X731 654 651 647 657 1 2 ND3P $T=525760 235760 1 180 $X=520800 $Y=235380
X732 660 678 669 677 1 2 ND3P $T=529480 225680 0 0 $X=529480 $Y=225300
X733 710 715 702 713 1 2 ND3P $T=546840 235760 1 0 $X=546840 $Y=230340
X734 879 880 882 883 1 2 ND3P $T=648520 225680 0 0 $X=648520 $Y=225300
X735 885 908 890 900 1 2 ND3P $T=662780 225680 1 0 $X=662780 $Y=220260
X736 918 915 917 914 1 2 ND3P $T=677660 225680 1 180 $X=672700 $Y=225300
X737 734 645 755 1 2 OR2P $T=562960 225680 1 0 $X=562960 $Y=220260
X738 850 731 844 1 2 OR2P $T=633020 225680 1 180 $X=629300 $Y=225300
X739 352 401 1 406 2 OR2B1S $T=312480 235760 0 0 $X=312480 $Y=235380
X740 676 718 1 723 2 OR2B1S $T=549940 245840 1 0 $X=549940 $Y=240420
X741 759 136 1 742 2 OR2B1S $T=573500 245840 1 180 $X=570400 $Y=245460
X742 868 870 1 873 2 OR2B1S $T=642320 255920 1 0 $X=642320 $Y=250500
X743 17 360 362 2 1 373 XOR3 $T=279620 255920 1 0 $X=279620 $Y=250500
X744 343 381 389 2 1 391 XOR3 $T=298840 235760 1 0 $X=298840 $Y=230340
X745 359 371 376 2 1 393 XOR3 $T=299460 225680 1 0 $X=299460 $Y=220260
X746 351 35 413 2 1 437 XOR3 $T=324260 255920 1 0 $X=324260 $Y=250500
X747 439 373 432 2 1 445 XOR3 $T=349680 235760 1 180 $X=338520 $Y=235380
X748 451 465 457 2 1 453 XOR3 $T=367660 235760 0 180 $X=356500 $Y=230340
X749 483 481 469 2 1 464 XOR3 $T=376960 245840 1 180 $X=365800 $Y=245460
X750 503 391 480 2 1 491 XOR3 $T=396800 225680 1 180 $X=385640 $Y=225300
X751 494 493 516 2 1 503 XOR3 $T=391840 245840 0 0 $X=391840 $Y=245460
X752 61 512 527 2 1 523 XOR3 $T=404240 245840 1 0 $X=404240 $Y=240420
X753 528 533 534 2 1 526 XOR3 $T=433380 245840 0 180 $X=422220 $Y=240420
X754 543 551 557 2 1 560 XOR3 $T=424080 255920 1 0 $X=424080 $Y=250500
X755 104 640 629 2 1 659 XOR3 $T=514600 245840 1 0 $X=514600 $Y=240420
X756 106 613 649 2 1 664 XOR3 $T=515840 245840 0 0 $X=515840 $Y=245460
X757 635 656 658 2 1 673 XOR3 $T=518940 225680 1 0 $X=518940 $Y=220260
X758 648 691 707 2 1 731 XOR3 $T=546220 225680 1 0 $X=546220 $Y=220260
X759 785 782 773 2 1 734 XOR3 $T=585280 225680 1 180 $X=574120 $Y=225300
X760 774 775 777 2 1 758 XOR3 $T=580320 245840 0 0 $X=580320 $Y=245460
X761 805 803 795 2 1 792 XOR3 $T=600160 245840 0 180 $X=589000 $Y=240420
X762 806 696 799 2 1 811 XOR3 $T=600160 235760 1 0 $X=600160 $Y=230340
X763 819 818 814 2 1 806 XOR3 $T=616900 225680 0 180 $X=605740 $Y=220260
X764 851 858 860 2 1 871 XOR3 $T=633020 235760 1 0 $X=633020 $Y=230340
X765 871 727 840 2 1 875 XOR3 $T=659060 225680 0 180 $X=647900 $Y=220260
X766 866 877 880 2 1 899 XOR3 $T=647900 235760 0 0 $X=647900 $Y=235380
X767 891 847 867 2 1 910 XOR3 $T=657200 225680 0 0 $X=657200 $Y=225300
X768 899 747 922 2 1 921 XOR3 $T=680140 235760 0 0 $X=680140 $Y=235380
X769 597 85 1 86 2 NR2T $T=478020 255920 0 180 $X=473060 $Y=250500
X770 598 88 1 85 2 NR2T $T=478020 255920 1 0 $X=478020 $Y=250500
X771 35 351 2 413 420 35 1 AOI22H $T=322400 245840 0 0 $X=322400 $Y=245460
X772 36 37 2 34 38 36 1 AOI22H $T=323640 255920 0 0 $X=323640 $Y=255540
X773 481 483 2 470 485 481 1 AOI22H $T=374480 245840 1 0 $X=374480 $Y=240420
X774 493 494 2 489 499 493 1 AOI22H $T=385640 245840 1 0 $X=385640 $Y=240420
X775 512 61 2 500 515 512 1 AOI22H $T=407340 235760 1 180 $X=399900 $Y=235380
X776 533 528 2 519 542 533 1 AOI22H $T=424700 245840 1 180 $X=417260 $Y=245460
X777 546 70 2 547 535 546 1 AOI22H $T=429660 235760 1 180 $X=422220 $Y=235380
X778 551 543 2 539 549 551 1 AOI22H $T=432140 245840 1 180 $X=424700 $Y=245460
X779 818 819 2 814 823 818 1 AOI22H $T=611320 245840 1 0 $X=611320 $Y=240420
X780 895 173 2 902 905 173 1 AOI22H $T=670220 245840 1 180 $X=662780 $Y=245460
X781 172 177 2 175 178 177 1 AOI22H $T=666500 255920 0 0 $X=666500 $Y=255540
X782 177 172 2 180 179 177 1 AOI22H $T=681380 255920 1 180 $X=673940 $Y=255540
X783 330 1 333 335 2 ND2P $T=240560 245840 1 0 $X=240560 $Y=240420
X784 344 1 348 351 2 ND2P $T=265980 255920 0 180 $X=262260 $Y=250500
X785 347 1 349 353 2 ND2P $T=266600 245840 1 180 $X=262880 $Y=245460
X786 398 1 403 404 2 ND2P $T=311860 235760 1 0 $X=311860 $Y=230340
X787 351 1 413 419 2 ND2P $T=320540 255920 0 180 $X=316820 $Y=250500
X788 415 1 418 413 2 ND2P $T=318680 245840 0 0 $X=318680 $Y=245460
X789 419 1 420 34 2 ND2P $T=320540 255920 1 0 $X=320540 $Y=250500
X790 414 1 422 418 2 ND2P $T=321160 245840 1 0 $X=321160 $Y=240420
X791 406 1 426 422 2 ND2P $T=324880 235760 0 0 $X=324880 $Y=235380
X792 410 1 417 429 2 ND2P $T=329840 235760 1 0 $X=329840 $Y=230340
X793 434 1 430 431 2 ND2P $T=334180 245840 0 180 $X=330460 $Y=240420
X794 435 1 433 432 2 ND2P $T=334800 255920 1 180 $X=331080 $Y=255540
X795 451 1 463 471 2 ND2P $T=365180 235760 0 0 $X=365180 $Y=235380
X796 465 1 457 479 2 ND2P $T=371380 245840 0 180 $X=367660 $Y=240420
X797 474 1 476 465 2 ND2P $T=369520 255920 1 0 $X=369520 $Y=250500
X798 475 1 477 460 2 ND2P $T=369520 255920 0 0 $X=369520 $Y=255540
X799 483 1 470 486 2 ND2P $T=380680 245840 1 180 $X=376960 $Y=245460
X800 486 1 485 489 2 ND2P $T=384400 245840 1 180 $X=380680 $Y=245460
X801 488 1 490 483 2 ND2P $T=382540 255920 1 0 $X=382540 $Y=250500
X802 494 1 489 497 2 ND2P $T=388120 245840 1 180 $X=384400 $Y=245460
X803 497 1 499 500 2 ND2P $T=388120 245840 0 0 $X=388120 $Y=245460
X804 507 1 515 519 2 ND2P $T=399280 245840 1 0 $X=399280 $Y=240420
X805 521 1 509 525 2 ND2P $T=409200 225680 0 180 $X=405480 $Y=220260
X806 541 1 535 539 2 ND2P $T=420360 235760 1 180 $X=416640 $Y=235380
X807 537 1 542 547 2 ND2P $T=422220 245840 0 180 $X=418500 $Y=240420
X808 544 1 549 550 2 ND2P $T=420360 255920 1 0 $X=420360 $Y=250500
X809 531 1 540 553 2 ND2P $T=429660 225680 0 180 $X=425940 $Y=220260
X810 72 1 550 562 2 ND2P $T=427800 255920 0 0 $X=427800 $Y=255540
X811 559 1 556 558 2 ND2P $T=435860 235760 0 180 $X=432140 $Y=230340
X812 73 1 550 565 2 ND2P $T=435240 255920 1 0 $X=435240 $Y=250500
X813 564 1 569 572 2 ND2P $T=438340 245840 1 0 $X=438340 $Y=240420
X814 560 1 578 569 2 ND2P $T=442680 235760 0 0 $X=442680 $Y=235380
X815 572 1 579 581 2 ND2P $T=447640 255920 1 180 $X=443920 $Y=255540
X816 573 1 581 80 2 ND2P $T=445160 245840 0 0 $X=445160 $Y=245460
X817 636 1 637 638 2 ND2P $T=510260 245840 1 180 $X=506540 $Y=245460
X818 104 1 640 647 2 ND2P $T=510880 245840 1 0 $X=510880 $Y=240420
X819 711 1 709 714 2 ND2P $T=549940 245840 0 180 $X=546220 $Y=240420
X820 123 1 125 124 2 ND2P $T=549940 255920 0 0 $X=549940 $Y=255540
X821 735 1 743 744 2 ND2P $T=559240 225680 1 0 $X=559240 $Y=220260
X822 733 1 745 712 2 ND2P $T=561100 235760 0 0 $X=561100 $Y=235380
X823 715 1 737 745 2 ND2P $T=565440 235760 0 180 $X=561720 $Y=230340
X824 757 1 754 750 2 ND2P $T=568540 235760 1 180 $X=564820 $Y=235380
X825 750 1 755 743 2 ND2P $T=566680 225680 1 0 $X=566680 $Y=220260
X826 796 1 780 799 2 ND2P $T=592720 225680 1 180 $X=589000 $Y=225300
X827 824 1 823 829 2 ND2P $T=618760 245840 1 0 $X=618760 $Y=240420
X828 857 1 841 860 2 ND2P $T=634260 245840 1 180 $X=630540 $Y=245460
X829 864 1 859 867 2 ND2P $T=637980 235760 0 0 $X=637980 $Y=235380
X830 873 1 876 874 2 ND2P $T=645420 255920 1 0 $X=645420 $Y=250500
X831 878 1 881 872 2 ND2P $T=649140 245840 0 0 $X=649140 $Y=245460
X832 896 1 889 895 2 ND2P $T=661540 245840 1 180 $X=657820 $Y=245460
X833 840 1 871 900 2 ND2P $T=662780 225680 0 180 $X=659060 $Y=220260
X834 903 1 905 175 2 ND2P $T=664020 255920 1 0 $X=664020 $Y=250500
X835 916 1 919 180 2 ND2P $T=673320 245840 0 0 $X=673320 $Y=245460
X836 70 546 547 2 1 554 XNR3 $T=419120 235760 1 0 $X=419120 $Y=230340
X837 367 370 20 1 2 376 MAO222 $T=288300 235760 0 0 $X=288300 $Y=235380
X838 343 382 381 1 2 386 MAO222 $T=300080 235760 0 0 $X=300080 $Y=235380
X839 453 379 448 1 2 473 MAO222 $T=359600 225680 0 0 $X=359600 $Y=225300
X840 460 461 456 1 2 457 MAO222 $T=360220 245840 1 0 $X=360220 $Y=240420
X841 49 48 459 1 2 458 MAO222 $T=365800 245840 1 180 $X=360840 $Y=245460
X842 464 393 473 1 2 484 MAO222 $T=373860 225680 1 0 $X=373860 $Y=220260
X843 105 618 651 1 2 658 MAO222 $T=520180 225680 0 0 $X=520180 $Y=225300
X844 774 775 777 1 2 773 MAO222 $T=574740 245840 0 0 $X=574740 $Y=245460
X845 899 747 915 1 2 907 MAO222 $T=683240 235760 0 180 $X=678280 $Y=230340
X846 472 1 479 471 2 470 ND3HT $T=378200 235760 1 180 $X=370760 $Y=235380
X847 74 1 562 565 2 78 ND3HT $T=436480 255920 0 0 $X=436480 $Y=255540
X848 75 77 1 579 2 OR2T $T=438960 245840 0 0 $X=438960 $Y=245460
X849 558 437 1 578 2 OR2T $T=451360 245840 1 0 $X=451360 $Y=240420
X850 842 1 836 840 2 ND2T $T=623720 225680 0 180 $X=618760 $Y=220260
X851 813 1 844 836 2 ND2T $T=623720 225680 1 0 $X=623720 $Y=220260
X852 337 8 332 2 6 7 1 AO22P $T=246140 235760 0 0 $X=246140 $Y=235380
X853 618 91 606 2 607 90 1 AO22P $T=491660 235760 1 180 $X=486080 $Y=235380
X854 122 109 699 2 121 110 1 AO22P $T=549940 255920 1 180 $X=544360 $Y=255540
X855 85 89 607 1 2 AN2B1T $T=481740 255920 0 0 $X=481740 $Y=255540
X856 613 649 106 640 1 2 MAO222P $T=515840 245840 1 180 $X=510260 $Y=245460
X857 799 806 696 813 1 2 MAO222P $T=600160 225680 1 0 $X=600160 $Y=220260
X858 795 805 803 814 1 2 MAO222P $T=600160 245840 1 0 $X=600160 $Y=240420
X859 915 899 747 902 1 2 MAO222P $T=677660 235760 1 180 $X=672080 $Y=235380
X860 846 159 1 2 837 OR2B1 $T=625580 235760 1 0 $X=625580 $Y=230340
X861 855 853 1 2 857 OR2B1 $T=629920 245840 1 0 $X=629920 $Y=240420
X862 90 91 598 630 1 2 OA12P $T=494760 255920 0 0 $X=494760 $Y=255540
X863 295 2 1 TIE1 $T=1086860 225680 0 180 $X=1085000 $Y=220260
X864 3 2 1 TIE0 $T=902720 225680 1 0 $X=902720 $Y=220260
X865 655 641 105 651 2 1 NR3H $T=519560 235760 1 0 $X=519560 $Y=230340
X866 357 16 2 1 INV1 $T=270320 245840 0 180 $X=268460 $Y=240420
.ENDS
***************************************
.SUBCKT ICV_23 1 8 9 10 11 12 13 14 15 16 17 18 19 20 21 22 23 44
** N=63 EP=18 IP=54 FDC=0
X0 9 1 1 1 10 1 23 YA2GSD $T=295870 0 0 0 $X=298720 $Y=0
X1 11 1 1 1 12 1 23 YA2GSD $T=405050 0 0 0 $X=407900 $Y=0
X2 13 1 1 1 14 1 23 YA2GSD $T=732590 0 0 0 $X=735440 $Y=0
X3 15 1 1 1 16 1 23 YA2GSD $T=841770 0 0 0 $X=844620 $Y=0
X4 17 8 8 8 18 8 23 YA2GSD $T=950950 0 0 0 $X=953800 $Y=0
X5 19 8 8 8 20 8 23 YA2GSD $T=1060130 0 0 0 $X=1062980 $Y=0
X6 21 1 1 1 22 XMD $T=186690 0 0 0 $X=189540 $Y=0
.ENDS
***************************************
.SUBCKT ICV_24
** N=1 EP=0 IP=0 FDC=0
.ENDS
***************************************
.SUBCKT ICV_25 1 2 3 4
** N=5 EP=4 IP=6 FDC=0
X0 2 1 1 1 3 XMD $T=0 1121210 0 270 $X=0 $Y=1061440
.ENDS
***************************************
.SUBCKT ICV_26 2 3 5 10
** N=11 EP=4 IP=6 FDC=0
X0 2 3 3 3 5 XMD $T=0 1012200 0 270 $X=0 $Y=952430
.ENDS
***************************************
.SUBCKT ICV_27
** N=13 EP=0 IP=0 FDC=0
.ENDS
***************************************
.SUBCKT ICV_28 1 2 3 4
** N=5 EP=4 IP=6 FDC=0
X0 1 2 2 2 3 XMD $T=0 685170 0 270 $X=0 $Y=625400
.ENDS
***************************************
.SUBCKT ICV_29 1 2 3 4
** N=5 EP=4 IP=6 FDC=0
X0 1 2 2 2 3 XMD $T=0 576160 0 270 $X=0 $Y=516390
.ENDS
***************************************
.SUBCKT ICV_30 1 2 3 4
** N=5 EP=4 IP=6 FDC=0
X0 1 2 2 2 3 XMD $T=0 467150 0 270 $X=0 $Y=407380
.ENDS
***************************************
.SUBCKT ICV_31 1 2 3 4
** N=5 EP=4 IP=6 FDC=0
X0 1 2 2 2 3 XMD $T=0 358140 0 270 $X=0 $Y=298370
.ENDS
***************************************
.SUBCKT ICV_32 1 2 3 4 5
** N=6 EP=5 IP=6 FDC=0
X0 2 3 3 1 4 XMD $T=0 249130 0 270 $X=0 $Y=189360
.ENDS
***************************************
.SUBCKT ICV_33
** N=1 EP=0 IP=0 FDC=0
.ENDS
***************************************
.SUBCKT CHIP o_data[8] clk rst_n i_valid o_ready i_data[0] i_data[1] i_data[2] VCC o_data[10] GND o_data[9] o_data[7] o_data[6] o_data[5] o_data[4] i_data[10] i_ready o_valid o_data[0]
+ o_data[1] o_data[2] o_data[3] i_data[9] i_data[8] i_data[7] i_data[6] i_data[5] i_data[4] i_data[3]
** N=3099 EP=30 IP=6657 FDC=0
X0 o_data[8] 1 2 1920 3099 ICV_1 $T=1309440 840570 0 90 $X=1169940 $Y=843420
X1 7 clk rst_n i_valid o_ready i_data[0] 1 i_data[1] i_data[2] 49 50 51 58 59 1214 1931 3099 ICV_2 $T=0 0 0 0 $X=139500 $Y=1168200
X2 GND VCC 49 60 61 63 1982 64 2100 1978 66 65 62 67 1988 68 102 98 69 1970
+ 1969 79 94 70 101 1985 71 72 1975 76 73 1971 1977 77 74 1972 75 93 1974 1979
+ 96 3056 78 1976 110 132 80 81 2012 82 83 84 1980 1993 85 1981 86 2015 1989 137
+ 87 1984 2003 3054 3091 1983 88 89 97 92 3060 91 90 1991 136 1990 1992 3055 95 1997
+ 2007 1995 1994 2002 1996 100 112 126 99 104 103 120 1999 2000 1998 1987 105 106 107 2001
+ 2010 108 2005 109 1986 2004 111 2018 114 2008 113 115 116 2006 133 127 2009 2011 117 3058
+ 118 125 121 119 3057 1973 3059 128 122 2017 123 2013 2021 124 2016 2014 129 130 2020 134
+ 131 2019 135 138 2024 2022 139 140 141 142 163 143 144 2030 145 2031 2086 147 158 148
+ 2026 149 3061 150 2060 2023 151 2029 152 2038 2028 153 154 2027 155 156 146 171 157 2032
+ 175 159 2033 2045 2034 2076 2036 2039 2042 161 2037 2057 162 2047 2035 205 165 166 2040 2043
+ 167 3062 2044 160 3063 188 172 184 2041 169 170 2059 173 2050 174 2046 176 177 2049 2048
+ 178 179 2051 223 1939 181 220 180 2053 182 2055 183 2054 187 185 186 2062 191 189 2061
+ 193 194 2069 2063 195 190 197 2056 196 2058 198 192 2064 199 200 201 2071 2091 2084 2070
+ 211 202 2068 204 2065 203 215 2066 2067 2080 218 206 2073 243 207 2083 217 164 209 2052
+ 3064 227 208 210 2078 212 240 2072 2079 219 2088 214 2074 2077 216 2092 2081 2089 230 3065
+ 2085 232 2082 2025 2090 222 213 225 224 246 221 2087 226 228 241 229 236 2075 2095 231
+ 233 235 2093 234 238 2094 237 51 239 2096 1083 242 2097 245 2098 247 244 248 249 250
+ 251 252 2099 253 254 255 256 257 258 2101 262 259 260 261 269 263 264 265 266 2102
+ 267 268 270 271 278 272 273 274 2103 275 277 276 2104 279 280 2106 281 282 2105 283
+ 2107 2108 284 2112 2110 2109 2113 292 286 285 290 287 288 2111 289 295 2114 291 293 294
+ 296 299 297 298 301 300 306 302 307 303 304 305 310 308 309 311 312 2115 313 314
+ 2116 315 339 316 318 317 319 2117 2118 321 322 320 323 324 325 326 327 328 2119 329
+ 330 331 333 332 334 338 335 336 337 o_data[10] 1 2120 1920 3099
+ ICV_3 $T=0 0 0 0 $X=139500 $Y=1056900
X3 GND VCC 340 60 1987 61 342 3059 1941 3056 343 62 341 344 80 2122 63 2003 64 1214
+ 345 1969 1977 346 681 68 347 71 355 348 66 349 102 1970 67 98 65 69 94 2121
+ 1985 351 96 101 350 2123 75 84 70 72 3066 352 3054 1971 2131 73 93 353 1993 354
+ 2124 74 1972 1973 364 76 356 358 1974 1988 78 2125 3055 79 2354 2128 3058 1976 1990 1975
+ 359 385 360 2126 1979 81 2012 100 361 357 1980 363 77 367 365 382 366 82 1981 86
+ 87 1982 85 1978 1984 2362 123 2007 95 375 368 369 1983 370 376 392 362 88 91 90
+ 2127 371 92 89 1986 390 108 372 373 2144 374 2129 1989 1991 1992 1997 664 2148 136 377
+ 378 2145 105 379 2000 2132 1995 2130 380 97 383 99 120 381 2001 1942 1994 2133 2134 2006
+ 1996 126 103 109 104 386 1998 1999 387 2140 107 384 720 388 2005 83 389 110 117 2002
+ 135 2009 2004 3067 111 2008 112 391 114 116 671 118 3057 2143 2138 2015 2142 2018 106 121
+ 113 122 2010 124 119 2135 130 2137 2013 2019 2139 2141 133 393 2136 2017 394 115 125 127
+ 3060 2014 395 396 128 129 2021 2016 402 398 1943 2156 131 132 399 717 2146 2150 400 134
+ 2011 2147 401 2237 2020 403 2149 404 2152 2153 137 405 138 2151 406 2154 407 139 424 140
+ 2076 2157 2155 408 430 205 409 2033 2038 2022 410 494 141 2026 411 2159 142 147 413 412
+ 144 149 2158 2030 2031 161 2024 146 145 2214 143 414 157 417 2162 163 148 2161 416 418
+ 419 2160 2216 173 2023 421 420 166 151 2025 422 423 2168 2164 2027 152 3072 2182 150 425
+ 2163 2028 3080 2035 158 153 2180 3071 2029 154 459 426 427 2173 155 2165 490 2166 428 156
+ 415 2185 2169 445 460 3063 465 477 175 2057 429 2032 1939 159 2209 468 2034 165 431 3073
+ 2042 2192 2167 433 432 160 2047 162 2191 220 2036 2037 2170 434 3070 497 448 2044 441 435
+ 464 439 2039 436 437 2040 2048 3069 438 3061 164 2171 2175 2043 197 444 476 167 442 168
+ 170 169 440 3062 3068 184 481 2219 443 2052 2177 2174 2208 2172 496 2178 2041 171 452 454
+ 2045 2046 446 2224 486 185 447 172 484 500 2193 2049 2050 2179 174 176 449 453 177 2060
+ 2176 2183 2196 2181 2184 450 2190 466 2186 2058 2051 2056 3076 178 451 2187 180 2189 179 2071
+ 188 187 232 2053 181 2188 2202 455 223 2093 182 456 2054 2055 457 458 463 2061 2195 3074
+ 2197 461 2062 189 186 194 462 191 190 2198 210 192 2059 499 2194 193 2210 2074 196 2199
+ 2201 195 467 2063 493 489 469 2073 2200 470 2205 471 472 198 2211 2204 473 479 2203 2206
+ 2227 199 474 475 206 2084 2065 480 215 2067 200 2207 203 201 478 230 2066 3075 204 229
+ 2070 3079 207 218 2072 2068 482 202 2079 208 483 224 183 212 209 2213 3077 221 2215 1944
+ 211 228 2064 488 487 3078 485 3064 2075 213 2218 2092 2088 2226 2217 216 214 2077 491 492
+ 2221 2081 2220 2225 217 2089 2080 2228 2222 2094 2078 495 225 2212 3065 2085 2223 2082 2083 219
+ 1945 235 222 2090 498 226 2086 2229 501 2087 519 227 502 503 518 517 504 231 2091 505
+ 506 233 507 509 2096 510 508 234 511 2095 236 513 514 237 238 239 240 2234 512 515
+ 516 241 243 244 2097 2262 2263 2235 1178 245 247 2231 2249 246 2230 2098 2248 1121 1139 2259
+ 252 242 248 2240 1187 520 1465 249 2239 2243 521 250 2247 2523 2232 2236 522 2233 1136 251
+ 2252 2246 2238 2496 2099 253 258 523 267 269 2100 262 1148 257 256 255 2244 2241 254 2242
+ 264 525 524 2101 260 259 526 527 560 528 261 529 530 531 2250 263 532 1946 541 533
+ 580 534 2251 539 537 2253 266 2254 2102 265 535 2255 536 538 268 270 274 548 542 543
+ 540 271 2256 545 2257 2261 278 2260 550 544 546 553 2258 549 273 272 551 552 2270 554
+ 558 275 2264 276 555 2103 277 556 557 559 2245 2267 2265 562 2269 2268 2104 282 279 563
+ 2271 564 561 280 568 281 2274 2105 338 567 566 2275 569 2272 2277 2276 570 625 615 2286
+ 571 2281 573 2278 334 572 575 629 2279 2106 283 2266 578 2282 2116 596 2280 576 288 574
+ 2283 2108 577 284 2284 2305 590 2112 2291 2290 2109 2273 292 2285 2107 595 579 285 286 2296
+ 287 588 581 609 2288 2113 2111 307 582 2303 2292 289 2287 2110 290 2289 2299 584 585 2294
+ 2293 586 2295 295 583 2301 594 2297 2298 587 2300 291 2302 294 2114 589 296 293 591 592
+ 2304 1947 593 2306 299 297 2307 298 600 2310 300 2308 598 597 301 599 602 302 2311 601
+ 309 303 603 2309 604 313 304 306 305 605 607 606 308 2314 2313 310 2312 2315 608 311
+ 610 2115 323 312 611 2316 2317 612 613 614 2319 2318 2320 339 2322 2323 314 2321 315 2325
+ 622 617 616 635 638 2324 316 317 318 2326 325 620 319 621 2333 618 619 2328 2329 2327
+ 2117 322 2118 320 321 2335 2330 2119 2331 623 627 324 2332 624 326 2336 626 327 328 329
+ 330 628 331 2337 2338 630 631 632 332 633 2334 636 333 634 335 336 2340 337 2341 637
+ o_data[9] 1 2339 1920 3099
+ ICV_7 $T=0 0 0 0 $X=139500 $Y=880500
X4 GND VCC 340 2345 2342 1942 639 2343 341 2349 2122 2344 640 353 342 642 344 641 343 2121
+ 346 1941 2346 2347 2368 643 345 644 2348 348 347 648 645 349 360 646 647 665 649 350
+ 357 2350 355 2123 2351 351 651 2352 361 352 652 2357 2127 354 2353 364 656 356 650 359
+ 358 2355 2128 2124 654 385 653 655 2125 2356 382 2359 2361 2358 2126 661 362 363 658 657
+ 365 659 2360 367 1948 366 369 370 380 2363 368 660 371 372 662 374 2364 373 375 376
+ 2130 390 377 379 378 663 666 2365 392 381 2131 2132 2367 383 671 667 384 386 1949 668
+ 673 2370 669 2369 670 387 2371 388 2373 672 3067 389 2137 2372 2375 393 2397 716 674 3066
+ 2133 391 681 675 676 2379 2139 2376 677 2413 690 2377 678 679 2135 689 2378 680 2136 692
+ 683 2435 684 2381 685 2380 395 394 686 396 687 400 682 397 688 2382 1943 2354 398 2383
+ 2141 713 703 399 691 2366 710 697 1078 694 664 2145 700 2156 2420 402 2150 1079 1019 2374
+ 2146 2147 401 403 2157 2148 406 2384 693 2144 404 407 2388 695 2385 2152 696 2151 494 418
+ 2154 2155 2153 410 2149 698 746 409 744 1950 699 411 702 2387 2159 408 701 2389 2386 2158
+ 417 2393 1951 705 2172 2390 413 422 412 2175 2162 414 2391 704 415 416 2392 707 2161 419
+ 423 420 706 2394 2163 424 2160 708 709 425 2395 426 421 430 1024 711 2134 2164 427 2166
+ 2203 712 2165 714 2396 2169 2167 2140 429 2138 720 717 434 715 431 723 464 468 433 2362
+ 459 441 2170 435 439 2143 436 2171 432 438 437 719 718 2142 2399 721 490 2398 453 2176
+ 486 2177 726 440 2404 2400 3068 3069 442 2174 724 2401 443 2402 725 2186 722 2173 1952 730
+ 2408 444 728 2405 2194 2406 446 445 2403 447 3071 2168 2178 2407 2179 2181 500 2182 477 2180
+ 448 727 729 449 2409 3072 731 2410 489 3076 428 2196 2184 734 2183 2197 450 733 451 2185
+ 732 738 2411 452 735 454 737 2412 2187 455 2220 2189 2192 2190 456 1029 493 2193 2212 3070
+ 2195 458 2188 2415 2414 496 739 460 465 740 461 741 2208 463 462 2200 742 457 2199 2198
+ 466 467 3073 2418 2201 2416 2428 470 2417 743 2202 2429 2426 2423 745 1036 2433 2419 1035 469
+ 471 3074 484 2191 2205 2442 2206 2204 473 472 2421 2229 474 476 2207 748 518 749 2224 747
+ 757 478 479 2425 2424 2209 2231 2422 480 1028 3075 750 481 482 751 483 2210 2427 3077 475
+ 1944 2228 485 753 2216 752 2213 2432 2215 2430 755 1041 754 487 1047 2431 763 3078 488 760
+ 1945 756 3079 2218 772 2217 774 2211 761 1050 2223 491 2214 492 759 2434 2436 758 3080 767
+ 2225 2221 764 2219 2222 497 2227 495 2437 762 2226 765 498 766 517 499 1214 768 769 501
+ 503 770 771 2438 502 773 523 775 777 504 776 505 2440 782 506 2439 507 778 519 781
+ 779 509 780 511 508 510 783 784 785 2441 520 786 788 512 513 790 514 787 803 2452
+ 789 515 516 796 2445 791 2446 792 795 801 2447 2444 793 2232 794 2450 2448 798 2443 2449
+ 799 2230 797 800 2451 802 2236 808 2237 522 804 805 528 521 820 806 807 2455 3082 2240
+ 2242 2244 1957 811 1931 524 58 809 810 1959 2456 2245 527 525 526 818 59 2250 1082 530
+ 813 812 532 2453 814 2459 581 2457 817 815 816 2464 556 819 533 2460 2461 822 2251 821
+ 2463 2458 823 2454 2465 2466 535 832 2468 830 2472 2467 534 825 2462 828 2255 551 2477 2469
+ 829 827 2253 2470 824 536 2471 537 538 831 539 2475 2476 2474 834 833 826 2254 540 2256
+ 2258 542 835 544 543 2257 545 836 546 547 548 837 839 552 550 549 840 841 553 569
+ 852 2260 842 2480 554 843 555 853 557 2261 2280 2484 2482 844 2478 2264 2479 845 864 558
+ 2266 873 2486 872 2481 2270 846 847 848 541 2269 2485 2488 560 849 851 2267 563 2265 2483
+ 561 850 2272 2268 562 2271 2273 854 565 2275 855 856 857 2509 566 2495 2274 2487 567 861
+ 568 858 2492 570 2276 2489 2490 866 2278 868 859 860 571 2283 2281 572 862 863 2282 573
+ 838 2279 574 575 564 631 576 2497 580 2493 577 2491 2494 578 865 636 2287 2241 582 2285
+ 579 588 869 2499 870 2288 2277 867 609 2291 2284 2498 2289 586 583 874 585 295 584 871
+ 897 2302 2473 2502 2297 2303 2296 2305 2299 2290 2500 2298 2294 875 876 2301 2508 2511 2504 587
+ 2293 877 589 2501 2505 2503 595 596 2506 2507 2295 878 1947 2292 879 882 590 591 2510 2300
+ 881 2304 2286 284 880 2512 883 592 2306 594 896 593 2513 884 597 885 929 887 2307 2514
+ 886 296 2515 888 599 889 598 2309 891 890 600 893 2308 306 624 301 601 894 2520 2516
+ 895 2310 603 892 899 602 2311 2331 2517 915 903 605 900 898 604 905 908 309 917 2313
+ 606 2314 2312 2334 2521 2518 607 914 913 2332 2519 608 2315 907 2522 901 909 902 904 627
+ 559 610 611 2338 612 2316 613 911 912 614 910 2320 615 2322 2318 2340 2319 2321 635 916
+ 617 2326 906 922 2325 616 620 2324 618 318 619 918 919 920 2330 638 2328 921 933 2327
+ 621 927 923 322 316 939 925 2329 926 930 928 2317 622 320 623 2524 2333 2337 2323 2526
+ 2525 625 935 931 626 932 633 2335 2336 934 628 629 936 632 630 937 2529 2527 942 634
+ 938 2528 940 2341 941 637 944 943 1 o_data[7] 945 1920 3099
+ ICV_10 $T=0 0 0 0 $X=139500 $Y=699060
X5 GND VCC 949 947 948 946 639 2530 2531 1943 951 950 640 2532 641 644 2345 1948 642 643
+ 952 2533 953 2135 645 954 2534 955 646 956 957 647 2365 648 649 959 961 650 651 958
+ 2349 2351 962 2353 960 2536 964 652 653 963 965 2535 654 2357 655 2537 2382 2358 2355 656
+ 2356 2538 3066 2539 2354 2141 967 2348 966 971 657 658 663 665 2361 969 2352 968 2363 972
+ 660 659 2366 2540 970 2541 2368 2542 2543 661 681 973 671 974 976 2129 975 662 673 977
+ 2364 978 2371 2544 393 664 979 2555 692 2545 2546 666 2561 1096 668 672 980 2593 695 981
+ 982 717 670 2549 983 2579 2547 2591 2548 2594 2373 667 2369 2580 984 2551 2578 985 2583 669
+ 2384 2554 2569 987 986 2552 2573 2374 2377 2550 2556 2553 680 988 675 676 989 2557 674 990
+ 2567 684 2559 991 993 679 992 2558 2581 677 2601 2560 2575 2566 683 994 2571 678 995 682
+ 996 1563 2380 1004 2379 997 1509 689 999 998 687 2568 686 2562 1006 688 2565 2563 2577 1009
+ 691 1001 690 2564 1000 685 697 2383 706 1002 1003 693 694 2570 696 1005 698 1007 699 2386
+ 2387 700 701 2392 2393 2391 1950 2389 2390 1008 702 703 1010 2572 1951 705 1011 2394 704 707
+ 708 1012 2395 709 712 711 1013 710 713 715 1014 1015 1017 1018 1016 714 2397 2398 718 2400
+ 721 719 720 1020 723 722 2399 2403 2405 1037 1021 2401 726 2402 1952 724 725 730 1022 2407
+ 2404 2406 1023 727 729 744 728 1025 731 1026 2576 2409 1214 732 733 2414 734 735 736 739
+ 1019 738 737 2415 740 741 742 2412 1031 743 1032 2582 1030 1038 746 1033 2574 1034 2420 747
+ 745 2419 2424 2418 2417 2421 2423 2229 2585 2604 1027 1043 1039 749 2586 1332 750 405 2425 753
+ 2427 2590 2614 752 748 2588 1042 751 1040 2589 1044 1045 755 2422 756 2613 1048 754 763 757
+ 518 1049 772 2430 758 1046 1051 761 2434 2603 2600 1053 1052 2436 760 2599 2597 759 2602 764
+ 762 2437 765 2595 1054 766 776 767 1055 2605 2607 2584 768 769 2606 2598 1058 1056 1060 770
+ 1059 771 2438 1057 773 774 2587 778 2611 2612 2610 1062 1063 775 1064 2439 2596 2609 1065 777
+ 1067 1066 2454 779 1068 803 1086 780 1061 781 783 3082 1069 2608 1071 784 1070 782 785 2441
+ 2443 1072 1074 786 1075 788 2447 790 2450 1073 789 2592 2444 2442 1076 2449 2445 787 792 2429
+ 791 2615 2426 796 2616 793 794 2446 795 2448 1098 1077 2451 1079 797 2416 1089 800 2627 2232
+ 799 801 2456 2428 814 798 1081 1082 2452 802 1083 2617 1084 2433 1085 806 1078 804 2623 1087
+ 2618 2621 2619 1088 2453 807 2620 1953 818 2455 808 1954 1092 1090 811 1091 2625 2622 1093 1960
+ 809 810 50 1919 2624 812 813 1094 1095 819 835 2460 815 2459 1097 2626 817 823 2461 833
+ 2475 820 2629 2462 1099 2464 531 821 805 822 2630 1946 1101 2628 1100 1102 2467 2468 1368 2473
+ 824 2466 2633 825 2469 826 827 716 829 2465 1104 2413 2634 1679 2470 2472 2474 2640 1106 839
+ 2471 1103 828 2631 2458 831 1105 529 830 832 1107 2636 1108 2632 2637 834 2635 1109 837 1110
+ 2638 838 2639 1111 2234 1114 1113 836 1112 859 2259 1115 2252 1116 1136 2246 1121 840 2641 842
+ 841 1117 843 1118 2247 1120 2490 2477 1140 2263 864 2478 1119 2642 845 2482 2479 2643 2486 2484
+ 844 2488 2480 846 853 847 1122 848 1123 2644 2485 851 850 1124 852 849 883 2645 2483 854
+ 2646 855 2509 2647 856 1125 2648 857 860 2492 1127 868 1126 858 2650 861 1128 2649 2489 1129
+ 2651 862 1131 863 2652 1130 1133 1132 2653 872 873 1134 2654 1135 2691 2491 2655 2501 2505 2493
+ 865 2494 2689 869 866 2435 2658 2656 2657 2659 2481 1137 2497 867 2496 1138 870 2239 2487 2495
+ 2662 2499 2661 1139 2683 2663 2666 2664 1141 2690 1142 2498 2660 871 1143 2667 2671 2504 1144 2672
+ 2500 1145 1146 2682 874 2670 2665 1147 875 2503 2668 2502 2675 2685 2510 2673 878 2669 2680 2506
+ 2676 879 2507 2508 2678 2679 876 880 2677 2511 1148 881 2681 2684 2513 1150 2687 877 1152 1149
+ 2251 2512 1151 882 2688 1153 2686 2514 1154 885 1155 884 2515 887 888 1156 1434 891 890 1157
+ 892 889 2339 893 894 2516 1678 1158 945 886 896 1159 1163 2694 1160 899 2693 1162 2 2692
+ 2674 1161 900 898 2518 2519 1164 901 897 1165 2517 2695 1167 1166 902 904 905 906 1168 909
+ 2696 2521 907 908 2522 2520 2698 2697 1169 1174 912 911 913 910 1170 914 916 903 915 2699
+ 1171 2700 1172 2701 1173 918 917 919 1175 1177 1180 1176 920 2702 921 895 922 1179 923 924
+ 925 1181 2523 926 927 1182 2703 2704 2705 928 1183 929 930 2524 2235 1184 2525 2526 1196 2709
+ 2707 2708 2706 1185 931 932 1187 1189 933 1188 1178 934 1195 1186 1190 1191 935 1192 1193 2710
+ 1194 1197 1200 1198 1199 2711 936 2120 937 2713 2528 2527 2712 939 942 938 2714 1201 2715 1203
+ 1208 1202 1204 940 2716 2717 2718 1206 2719 1205 941 1207 943 2721 2722 2720 1210 1211 2529 1209
+ 1212 944 1213 3099
+ ICV_12 $T=0 0 0 0 $X=139500 $Y=603300
X6 GND VCC 946 2343 947 2342 2530 1217 2737 948 2533 950 2531 949 1214 2532 1215 951 1216 2346
+ 2344 952 1218 954 1219 1220 955 1221 956 957 958 1222 959 2350 953 1223 2534 960 1227 961
+ 962 2134 1226 2723 2535 1225 1228 2536 2359 2538 964 2537 966 967 965 963 1229 2539 1230 2574
+ 2540 1232 1233 2362 2360 1234 968 969 2543 1235 2541 1236 970 2542 2725 2724 1237 971 1238 2727
+ 972 2726 973 1239 974 977 1240 978 975 976 1241 1243 1242 2138 2370 2544 1244 720 714 979
+ 980 2548 717 2545 2396 984 983 1246 1245 982 981 2728 1248 1224 2546 1247 985 2547 1251 988
+ 1231 2381 2372 2549 987 2551 2552 2550 986 989 2556 2376 2367 2375 2553 2731 990 994 2554 2557
+ 992 996 2378 2730 1250 2559 2729 995 2558 2560 1563 1252 1509 1253 997 2762 998 999 1254 2562
+ 405 1270 2564 2565 1000 2568 1001 1002 2570 2566 1003 1255 1004 1005 1258 1259 1256 1257 1006 1007
+ 1008 1249 1009 1262 1260 1010 1013 1261 1263 2572 1030 2732 1265 1011 1264 1266 1012 1269 1267 2734
+ 2739 1268 1014 2736 2740 1271 1272 2738 2746 1015 1016 1017 1018 2735 1275 2743 2385 1276 1023 2741
+ 1020 1273 1019 1022 1037 1065 1274 1278 1051 1277 1021 1280 2745 2607 2408 2388 1281 2597 2733 1024
+ 1282 3083 2612 2742 2749 2767 2750 1283 2747 2754 2748 1284 2410 1286 1054 2744 2411 1279 1287 2763
+ 1027 1288 1290 1028 1289 2761 1029 2756 2755 2757 1292 2759 1955 2758 1293 2760 1291 2674 1097 2788
+ 2833 1297 1294 1035 1036 1296 1295 2588 1038 2589 1298 2592 2584 1299 1680 2853 2585 1068 1300 2586
+ 1301 2608 2768 2610 1039 1040 1041 1302 2765 2432 2753 1042 2606 2752 2751 2766 2595 1043 2764 2590
+ 1047 2769 2431 1044 1303 1046 1045 2598 2775 2587 1048 1304 2770 1049 1050 2773 2771 1306 2777 2772
+ 2596 2776 1305 2780 2600 2615 2602 2599 1052 2603 1053 2774 2794 1308 1285 1334 1309 2604 1331 1312
+ 1056 2609 1060 1057 2778 2605 1307 1310 1059 1055 2779 2611 1953 1351 1918 2785 1330 1058 2781 1960
+ 1061 1063 1313 1062 1344 1093 1314 1319 1938 1940 1311 2789 2782 2793 1316 2784 1957 1317 2820 1066
+ 1954 1324 1318 1067 2613 1315 1064 2786 2808 1959 1320 1337 2440 2791 1321 2812 2802 1070 1322 2787
+ 1071 2816 1323 2790 2799 1327 2804 1069 1325 2810 1326 2792 2818 2798 2801 2805 1073 2814 1072 2806
+ 1074 2783 2614 1075 1931 1332 2795 1076 2796 1329 1333 59 2797 1340 2817 1336 1339 1077 2829 2800
+ 2616 1328 1335 58 1078 1079 2803 1080 2857 2617 1338 1084 1087 1081 2825 814 1341 1082 1342 1091
+ 1083 2622 2807 2811 1085 3082 2809 1347 2815 1355 2454 2813 2618 1086 2620 1345 1346 1352 2241 1360
+ 1350 1348 1357 1362 1090 2621 1349 1088 819 2463 1089 2624 1353 2824 2819 2822 1092 2457 2823 816
+ 2827 2821 1370 1356 2845 2841 2465 2840 1094 2626 2458 2623 2462 2836 1358 2830 2835 1095 1354 1359
+ 1096 2625 1361 1365 2435 2826 2619 2828 2838 1100 2832 1098 1343 2837 1363 2627 1099 2628 1374 2631
+ 1373 2834 2843 2831 1364 2842 1369 1102 1375 2632 1103 1366 1367 2579 1104 2855 1105 1106 1107 2839
+ 1108 1371 1109 1111 1148 2635 1372 1110 1384 1112 1115 1376 1379 1113 1116 1377 1378 1114 2641 1178
+ 2642 2846 1385 2844 1380 1383 2571 1381 2575 1117 2601 1382 2643 1118 1139 1119 1120 1121 2581 2262
+ 2567 1387 2847 2644 1122 2573 1123 2848 1124 1956 2569 2645 2646 1187 1388 2647 1125 2580 2849 1391
+ 2850 2594 1389 1390 1126 1392 1386 2649 2851 2593 1127 2652 1393 1129 1394 1395 2852 1128 2248 2249
+ 2591 1396 1130 1131 1132 2578 2654 1397 1465 1398 1133 2243 2583 1399 1135 2655 1400 2397 1136 1401
+ 1405 716 1134 2238 2656 1137 2233 2658 1404 1142 1403 1402 1410 2854 1406 1407 1138 1408 2664 2666
+ 1409 1140 1141 2856 1411 1413 2670 1143 1419 1414 1144 1412 1416 1418 2672 1415 1145 2858 2860 1417
+ 1147 2859 1146 1420 2673 2675 2685 2861 1421 1422 1423 2681 2677 2866 1427 1431 2867 2682 2864 1424
+ 2868 1425 1151 1149 1426 2680 2870 1150 2865 2862 1153 2678 2686 1152 1428 1430 2688 2869 1429 1154
+ 1155 2863 2679 1432 883 1156 1433 1157 2251 2871 1443 2881 2873 1159 1160 1496 1161 1436 1437 1438
+ 1163 1435 2875 1439 1442 2694 1440 2874 2876 2695 1164 1441 2877 2872 1444 2880 2879 1166 1446 2696
+ 1167 1169 1168 1165 2878 1445 1448 1447 2698 2699 2697 1450 1451 1170 1449 1452 2700 1453 2702 1171
+ 1454 2882 1173 1172 1455 2701 2883 1456 1174 1457 2884 1459 1458 1175 1176 1177 1460 1179 1463 1462
+ 2705 1461 1180 2885 1464 1181 1467 2703 1468 1466 2561 2704 1182 1183 2886 2555 1471 1470 2706 1472
+ 2708 1184 2709 2707 1473 1469 1474 1186 1476 1185 1475 2887 2888 1188 1190 1189 1479 1477 2710 1191
+ 1485 1478 1192 1193 1194 1195 1210 2889 1196 1480 2890 2891 2711 1199 1197 2714 1481 1482 2712 1200
+ 2893 2892 2713 1483 2894 1484 2715 1198 1201 2895 1202 2718 1203 1204 2716 2896 1486 1490 1487 2719
+ 1488 1205 2717 1493 1489 1491 1206 1492 1207 2721 2897 1208 2720 1494 1209 1495 2722 1211 1212 1213
+ 3099
+ ICV_14 $T=0 0 0 0 $X=139500 $Y=512580
X7 GND VCC 1497 2899 1214 2898 1215 1229 1216 1230 2913 1217 2347 1498 1221 1219 2905 1218 1499 1228
+ 1220 1500 1501 1505 1222 1502 1223 1224 1503 2901 1225 1504 2900 1226 1227 1506 1507 1736 2902 1232
+ 1508 1231 2583 716 2397 2575 2435 2594 2413 2567 2571 1510 2578 2580 2569 2573 1233 1528 2728 1512
+ 1234 2593 2581 1509 1235 1236 1511 2729 1529 2601 2725 1513 2724 2903 2726 1238 1237 1240 1514 1239
+ 2723 2727 1241 1515 1242 1516 1243 2904 1244 2907 1518 1246 1517 1245 1520 1519 1521 2906 1522 1524
+ 2737 1525 1248 1523 1526 2909 1270 2910 1249 1251 1250 2908 2911 2730 1252 2561 1247 1253 2563 1531
+ 2731 1254 2912 1539 1530 1532 1556 1533 1535 1536 1537 1255 1256 1534 2738 1540 1541 1538 1257 1258
+ 1543 1259 1542 1549 2914 1544 1545 1261 1527 1550 2918 1547 2732 1260 1262 1548 1265 1263 1266 1264
+ 1546 2915 1557 1551 2736 2734 1552 1269 1268 2733 1554 1275 1271 2766 1273 1272 1030 2924 2916 2920
+ 1276 2741 1558 1555 2746 2917 1274 2765 2919 2922 1267 2591 2740 1559 2921 1560 1553 2739 2743 2764
+ 1280 2742 1562 1561 1565 2744 1278 1563 1564 2926 2925 1277 1025 3083 2929 1566 1567 2750 2923 1279
+ 2745 2751 2927 1593 2928 1283 1026 1281 2930 2754 1568 1569 1293 1282 2749 1570 2576 1571 1572 2931
+ 1573 2748 1284 2752 1288 1955 2753 1285 1286 2755 1292 1287 1574 2932 1290 1289 1291 1575 2759 2757
+ 2758 2933 2760 1576 2582 1577 2935 2934 1032 1578 2761 1586 1033 1034 1802 1294 1580 1579 1031 1581
+ 2936 1295 1296 2762 1297 1582 2937 1298 1299 2763 1584 1300 1301 1583 1585 1302 1587 1306 1588 1303
+ 1597 1589 1327 1317 1590 1304 1305 1591 2767 1596 2769 1592 2938 2773 2939 2941 1594 2772 1308 1307
+ 2774 1309 2776 2780 2770 2940 1310 1311 1600 2944 2942 1313 2775 2768 2771 1038 1613 1598 2777 1325
+ 2782 1599 1314 1324 1315 1595 2943 1320 1602 1316 1604 1603 2783 1601 2784 1318 1319 2787 1312 1329
+ 1326 1321 2797 2792 1322 2789 2791 2790 1605 1331 1323 1606 1328 1607 2800 2794 2795 1338 1332 1330
+ 1333 1609 1334 1335 1340 1336 1337 1608 1614 1610 1611 1342 2806 1339 2807 1612 1349 2949 405 2811
+ 1027 2813 2809 1617 2613 1341 2945 2805 2948 1343 1344 1615 1345 1350 2815 1616 1346 1347 1348 2946
+ 1353 2947 2604 2801 2606 2614 2821 1352 2793 1356 2781 2816 2819 2786 2798 1358 1354 2812 2799 1355
+ 2785 2820 1618 2808 2822 2818 2950 2958 2817 1357 2803 2802 2804 2814 2796 2824 2810 2953 2831 1351
+ 2779 2778 1620 1875 1622 1621 1623 2956 2829 1861 1624 1359 1367 1363 1634 2955 1360 1361 1626 1628
+ 1625 1362 1871 1893 1627 3011 2629 1364 2630 2830 1630 1629 1370 2633 2833 2825 1368 2957 2826 2835
+ 2994 3015 2832 2834 2634 1369 2836 1632 1633 1365 2637 3000 1366 3006 1371 2952 2828 2837 2838 1372
+ 2636 2960 1373 2638 2823 1635 1378 2961 2965 2840 2827 2841 2842 1377 1374 1375 2844 1376 2954 3013
+ 2639 2839 2963 1636 2788 2962 2978 2964 1670 2843 1927 2620 2845 2971 1638 1639 1637 2972 2967 2640
+ 2966 2846 1379 2959 1642 1643 1380 2847 2969 1956 2970 1700 1382 1381 1641 2616 1383 1384 1864 1895
+ 1385 2968 1386 2848 2951 2975 1387 1650 2974 1392 1388 2850 1389 1644 2973 1890 1631 1619 3010 1645
+ 1646 2849 2977 1903 1390 1902 1391 2980 1394 1393 1648 1649 1640 2852 1647 2979 2996 2851 1874 2648
+ 2651 2650 1395 1396 2995 1397 2998 1651 2853 1398 1653 2653 2989 2976 1412 2984 2988 1399 1654 1665
+ 2999 2991 1405 1401 2992 1400 2987 2986 2982 1667 1652 2990 1657 1402 1404 1403 1655 2657 1659 2993
+ 2981 1656 2854 2856 1408 1658 2985 1407 1406 2660 1660 1409 2663 1662 1410 1411 2669 2665 1661 1413
+ 1414 2671 1415 2860 2997 1663 2859 1674 1416 1417 2668 1418 1419 1672 1421 2871 2858 1422 3001 1420
+ 2864 2863 2676 2866 2862 2861 1664 2868 1668 2870 2684 2867 1671 2683 1423 1424 2691 2865 1426 1425
+ 1427 3002 2690 2869 1428 3003 1429 2689 1704 3007 1684 1673 1432 1430 1679 1431 2983 3004 2661 1683
+ 1666 3005 1433 1678 1675 1676 1434 3019 1694 2872 2874 2875 1691 1695 3008 1680 1677 2692 1158 3014
+ 1681 1682 1435 3012 2693 1436 3009 3018 1437 1685 1687 1438 1900 3016 1892 1439 2878 1442 1440 2876
+ 2877 1688 1669 1441 2879 1698 2880 2881 1443 1693 1686 1444 3017 3023 1702 1448 1445 1690 1446 1447
+ 1689 2882 1449 1496 3020 1450 1451 1713 1454 1452 1692 1453 3025 2883 1456 1455 1703 2873 1699 1457
+ 1458 1459 3021 1696 2884 1697 3022 1460 1461 1463 1462 1465 3024 1464 1466 1701 2885 1468 1467 1469
+ 2886 3026 1958 1470 1472 1471 1473 2888 1705 1707 1475 1476 1708 2887 2889 3027 1477 1479 3028 1710
+ 2890 1709 1716 2891 1711 1478 1480 1474 3029 2894 1481 1482 3032 2893 2895 1712 3030 1714 2892 1484
+ 1483 3031 1485 1715 1717 2896 1489 1488 1490 1487 1718 1493 1491 2897 1486 1492 1495 32 1494 1719
+ 1 o_data[6] 1920 3099
+ ICV_19 $T=0 0 0 0 $X=139500 $Y=361380
X8 GND VCC 1497 1228 1723 1720 1498 2898 1722 1501 1499 1504 1721 1724 2899 1725 1726 1502 1503 3033
+ 1505 1727 1745 1506 2900 1728 1507 2902 3034 1508 2901 1729 2553 1730 1736 2547 2557 2555 2556 2561
+ 2560 1529 2551 1509 1510 2558 1731 1734 1511 2579 1732 2552 1563 2559 2725 1733 2903 1512 1513 1514
+ 3035 1515 1735 1737 2905 1516 2904 1738 1517 1740 1742 1741 1739 1518 1743 2907 1747 1744 1096 1746
+ 1520 1519 2906 1522 1521 1523 3037 1524 1748 1752 1749 1750 1525 3036 1751 1753 1754 1500 1526 2918
+ 1557 1556 2909 1755 2910 1247 1756 2908 1527 1544 1757 1528 1775 2911 2577 1758 1759 1530 2912 2913
+ 1533 1531 1761 1760 1534 1763 1764 3038 1532 1535 1537 1765 1766 1762 1536 1538 1539 1768 2914 1767
+ 1540 1769 1541 1770 1777 1772 1771 1542 1543 1773 1774 1548 1545 1546 1776 2915 1551 1778 1549 1782
+ 1547 1550 1781 1552 1780 1779 1783 1553 1784 1786 1785 1554 2735 1555 2922 2925 1030 2920 1558 1269
+ 2916 2921 1559 1562 2917 1561 2919 1565 1564 1560 2926 2929 1566 1794 2928 2754 1567 1787 2923 2924
+ 1788 2927 2749 2930 1568 1789 1790 1569 1791 3039 2931 1570 1792 1793 2747 1571 3040 2932 1795 1796
+ 1579 1797 1800 1798 1817 1572 1573 1799 1574 1290 1575 2756 1576 2757 3041 2933 1802 1801 1577 3042
+ 2934 2935 1803 1578 1804 2936 1581 1580 3043 3044 1589 1295 1805 1806 3045 1582 2937 1807 1808 3047
+ 1809 3046 3048 1584 1810 1811 1816 1813 1812 1814 1815 1583 1819 1818 1586 1587 1585 1820 1588 3049
+ 1821 1822 1857 1823 1824 2941 1826 2943 1828 1591 1590 1613 1825 1592 1594 2938 1593 1827 1306 2939
+ 3050 2940 1829 1832 1830 1597 1831 1595 2773 1834 1596 1833 2770 1835 2944 2768 1836 2942 1837 1598
+ 1838 1599 1845 1839 1600 1844 1602 1601 1841 3051 1840 1603 1605 1842 2772 1606 1609 1604 1843 1607
+ 1847 1608 1846 1848 1850 1849 1851 1852 1853 1612 1610 1611 1856 1854 1855 1859 1858 2945 1614 1617
+ 1615 2948 2947 1860 2949 1618 2976 1622 1616 2950 2958 2952 2977 1619 2954 1861 1658 1634 2956 2951
+ 2953 2946 1621 1620 1624 2955 1627 1626 2966 1625 2973 2959 1628 1629 1650 1630 1623 1631 1632 1863
+ 1633 2962 2960 1862 1635 1864 2961 2964 2978 1636 1865 1637 1639 2967 1871 1638 2971 2968 2970 1642
+ 1643 2991 1866 1640 1867 1641 1670 2974 2841 2975 1868 1644 1869 1645 1646 2845 2979 1648 1649 2840
+ 2980 1647 1874 2981 1870 2998 2995 2982 2988 2983 1651 1873 1663 1652 1654 2989 2984 2999 1665 2985
+ 1653 1667 2987 2996 1655 2990 1657 2986 1656 2992 1659 1875 1660 1661 2993 1876 1662 2857 1877 1878
+ 2997 1101 1967 2620 2855 3002 1879 1664 1880 1881 1666 3001 1668 1672 1882 2687 1674 3004 3052 2871
+ 2667 1669 2662 1884 3008 1671 1895 1673 1886 1885 3007 1883 3005 2659 1890 3003 1872 1887 3009 1162
+ 3000 3010 1675 1678 3006 1888 2957 1694 1681 1679 1929 1889 1680 1691 1695 2972 1676 1928 2693 2965
+ 1706 3018 3013 3016 2963 3012 1891 1677 1688 1893 1683 1698 3014 1685 1896 1900 1684 1894 1892 1686
+ 1687 3015 3017 2994 1682 1897 1700 1690 3019 1898 2969 1689 3011 1902 1899 3020 1693 1903 1901 1704
+ 3021 1692 1696 1904 3022 1697 3024 1905 1699 1701 1906 3023 1958 1702 3026 1907 1705 1703 1708 1707
+ 1908 3027 3028 1710 1713 1709 3025 1714 1909 1711 1717 1715 1712 3029 3030 3031 1910 1911 3032 1913
+ 1912 1915 1914 1716 1718 1917 1916 1719 o_data[5] 32 1920 3099
+ ICV_21 $T=0 0 0 0 $X=139500 $Y=260580
X9 GND VCC 25 7 1720 1721 1722 1228 1723 1726 1724 1725 3033 1727 3034 1728 1732 1729 1730 1733
+ 1731 1748 1737 1735 1734 1736 3035 1738 1741 1739 1740 1751 1742 1743 1744 1746 1745 1747 3036 1749
+ 1750 2918 1752 1753 1754 1557 1556 1756 1757 1758 1247 1760 1759 1775 1761 1762 1763 1764 1765 1766
+ 1770 1767 1768 1769 1777 1771 1772 1773 1774 1776 3038 1778 1779 1780 1783 1784 3037 1782 1755 1781
+ 1785 1786 1269 1560 1787 1788 1790 1789 1791 1800 1573 3039 1572 1793 1794 1795 3040 1796 1797 1799
+ 1798 1792 1821 3041 3043 1803 3042 1801 1802 3045 1804 3044 1805 1806 1807 1808 3046 3047 1809 1812
+ 1813 1814 1815 1816 3048 1817 1810 1818 1811 1819 1820 1823 1822 1613 1824 1825 1826 1827 1828 1829
+ 1830 1832 1833 1834 1831 1835 1617 1836 1837 1838 1839 1840 3051 1841 1842 1843 1844 1845 1846 1847
+ 1848 1849 1850 1851 1852 1853 1855 3049 3050 1854 1857 1856 1858 1859 1860 1614 2956 1861 1634 1626
+ 1627 2953 2958 2950 1875 1871 1862 1863 1868 1864 2962 1865 2971 1639 1637 1643 1642 2978 1866 1867
+ 2970 1869 1648 2980 1649 1878 1620 1870 1872 1873 2988 1874 2996 1653 2989 2987 1654 1667 2990 2984
+ 1876 1886 1877 1879 1880 1881 1882 1883 1672 1670 1885 1895 3014 1887 1888 1884 3012 1890 1889 1892
+ 32 1900 1685 3016 1891 1688 3018 1698 1893 1894 3017 1896 1897 1898 1899 1901 1902 1903 1904 1905
+ 1701 1704 1906 3024 1958 3026 1907 1707 1708 1908 3027 1709 3028 1710 1909 3032 1717 1715 3031 1911
+ 3029 1912 1910 1913 1914 1915 1916 1917 1920 o_data[4] 3052 3099
+ ICV_22 $T=0 0 0 0 $X=139500 $Y=139500
X10 25 32 i_ready 1919 o_valid 1084 o_data[0] 1927 o_data[1] 1967 o_data[2] 1928 o_data[3] 1929 i_data[10] 1918 1920 3099 ICV_23 $T=0 0 0 0 $X=139500 $Y=-56920
X12 7 i_data[9] 1938 3099 ICV_25 $T=0 0 0 0 $X=-56920 $Y=1057700
X13 i_data[8] 7 1940 3099 ICV_26 $T=0 0 0 0 $X=-56920 $Y=880500
X15 i_data[7] 7 1953 3099 ICV_28 $T=0 0 0 0 $X=-56920 $Y=604100
X16 i_data[6] 7 1954 3099 ICV_29 $T=0 0 0 0 $X=-56920 $Y=512600
X17 i_data[5] 7 1957 3099 ICV_30 $T=0 0 0 0 $X=-56920 $Y=361400
X18 i_data[4] 7 1959 3099 ICV_31 $T=0 0 0 0 $X=-56920 $Y=260600
X19 25 i_data[3] 7 1960 3099 ICV_32 $T=0 0 0 0 $X=-56920 $Y=139500
.ENDS
***************************************

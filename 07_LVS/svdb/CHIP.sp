* SPICE NETLIST
***************************************

.SUBCKT L POS NEG SUB
.ENDS
***************************************
.SUBCKT XMD I SMT PU PD O
** N=6 EP=5 IP=0 FDC=0
.ENDS
***************************************
.SUBCKT ICV_1 1 2 3 4
** N=4 EP=4 IP=6 FDC=0
X0 1 2 2 2 3 XMD $T=0 0 0 0 $X=2850 $Y=0
.ENDS
***************************************
.SUBCKT ICV_2 1 2 3 4
** N=4 EP=4 IP=6 FDC=0
X0 1 2 2 2 3 XMD $T=0 0 0 0 $X=2850 $Y=0
.ENDS
***************************************
.SUBCKT ICV_3
** N=1 EP=0 IP=0 FDC=0
.ENDS
***************************************
.SUBCKT YA2GSD O E2 E8 E4 I SR E
** N=8 EP=7 IP=0 FDC=0
.ENDS
***************************************
.SUBCKT ICV_4 1 2 3 4 5
** N=6 EP=5 IP=8 FDC=0
X0 3 1 1 1 2 1 4 YA2GSD $T=1313160 1072130 0 90 $X=1173660 $Y=1074980
.ENDS
***************************************
.SUBCKT ICV_5 1 2 3 4 5 6 7 8
** N=10 EP=8 IP=16 FDC=0
X0 2 3 3 3 1 3 4 YA2GSD $T=1313160 891290 0 90 $X=1173660 $Y=894140
X1 5 6 6 6 7 6 4 YA2GSD $T=1313160 981710 0 90 $X=1173660 $Y=984560
.ENDS
***************************************
.SUBCKT ICV_6 1 2 3 4 5
** N=12 EP=5 IP=8 FDC=0
X0 4 1 1 1 2 1 3 YA2GSD $T=1313160 800870 0 90 $X=1173660 $Y=803720
.ENDS
***************************************
.SUBCKT ICV_7 1 2 3 4 5
** N=12 EP=5 IP=8 FDC=0
X0 1 2 2 2 3 2 4 YA2GSD $T=1313160 529610 0 90 $X=1173660 $Y=532460
.ENDS
***************************************
.SUBCKT ICV_8 1 2 3 4 5 6 7
** N=9 EP=7 IP=16 FDC=0
X0 3 1 1 1 2 1 4 YA2GSD $T=1313160 348770 0 90 $X=1173660 $Y=351620
X1 5 1 1 1 6 1 4 YA2GSD $T=1313160 439190 0 90 $X=1173660 $Y=442040
.ENDS
***************************************
.SUBCKT ICV_9 1 2 3 4 5 6 7
** N=9 EP=7 IP=16 FDC=0
X0 2 3 3 3 4 3 1 YA2GSD $T=1313160 167930 0 90 $X=1173660 $Y=170780
X1 5 3 3 3 6 3 1 YA2GSD $T=1313160 258350 0 90 $X=1173660 $Y=261200
.ENDS
***************************************
.SUBCKT ICV_10
** N=1 EP=0 IP=0 FDC=0
.ENDS
***************************************
.SUBCKT ICV_11 1 8 9 10 11 12 13 14 15 16 17 18 19 20 21 22 29 30 31 32
+ 33 48
** N=70 EP=22 IP=60 FDC=0
X0 8 1 1 1 18 XMD $T=224400 1302680 0 180 $X=164630 $Y=1163180
X1 9 1 1 1 19 XMD $T=308680 1302680 0 180 $X=248910 $Y=1163180
X2 10 1 1 1 20 XMD $T=392950 1302680 0 180 $X=333180 $Y=1163180
X3 11 1 1 1 21 XMD $T=477220 1302680 0 180 $X=417450 $Y=1163180
X4 12 1 1 1 22 XMD $T=561490 1302680 0 180 $X=501720 $Y=1163180
X5 13 1 1 1 29 XMD $T=814300 1302680 0 180 $X=754530 $Y=1163180
X6 14 1 1 1 30 XMD $T=898570 1302680 0 180 $X=838800 $Y=1163180
X7 15 1 1 1 31 XMD $T=982840 1302680 0 180 $X=923070 $Y=1163180
X8 16 1 1 1 32 XMD $T=1067110 1302680 0 180 $X=1007340 $Y=1163180
X9 17 1 1 1 33 XMD $T=1151380 1302680 0 180 $X=1091610 $Y=1163180
.ENDS
***************************************
.SUBCKT QDFFN D CK Q GND VCC
** N=6 EP=5 IP=0 FDC=0
.ENDS
***************************************
.SUBCKT AOI22S A1 B1 O B2 GND A2 VCC
** N=8 EP=7 IP=0 FDC=0
.ENDS
***************************************
.SUBCKT AN2 I1 I2 GND VCC O
** N=6 EP=5 IP=0 FDC=0
.ENDS
***************************************
.SUBCKT DELA I GND VCC O
** N=5 EP=4 IP=0 FDC=0
.ENDS
***************************************
.SUBCKT QDFFRBN D CK RB VCC GND Q
** N=7 EP=6 IP=0 FDC=0
.ENDS
***************************************
.SUBCKT AO22 O A2 A1 VCC B1 B2 GND
** N=8 EP=7 IP=0 FDC=0
.ENDS
***************************************
.SUBCKT FA1S CO VCC A B CI GND S
** N=8 EP=7 IP=0 FDC=0
.ENDS
***************************************
.SUBCKT INV1S I VCC O GND
** N=5 EP=4 IP=0 FDC=0
.ENDS
***************************************
.SUBCKT BUF1S I GND VCC O
** N=5 EP=4 IP=0 FDC=0
.ENDS
***************************************
.SUBCKT ND2P I2 GND I1 O VCC
** N=6 EP=5 IP=0 FDC=0
.ENDS
***************************************
.SUBCKT XOR3 I2 I1 I3 VCC GND O
** N=7 EP=6 IP=0 FDC=0
.ENDS
***************************************
.SUBCKT ND3HT I3 GND I2 I1 VCC O
** N=7 EP=6 IP=0 FDC=0
.ENDS
***************************************
.SUBCKT XOR2HS I1 I2 O VCC GND
** N=6 EP=5 IP=0 FDC=0
.ENDS
***************************************
.SUBCKT MAO222P A1 B1 C1 O GND VCC
** N=7 EP=6 IP=0 FDC=0
.ENDS
***************************************
.SUBCKT ND3P I1 O I2 I3 GND VCC
** N=7 EP=6 IP=0 FDC=0
.ENDS
***************************************
.SUBCKT ND2 I1 O I2 GND VCC
** N=6 EP=5 IP=0 FDC=0
.ENDS
***************************************
.SUBCKT INV12CK I O GND VCC
** N=5 EP=4 IP=0 FDC=0
.ENDS
***************************************
.SUBCKT ND2T I2 GND I1 O VCC
** N=6 EP=5 IP=0 FDC=0
.ENDS
***************************************
.SUBCKT FA1 S B VCC A CI GND CO
** N=8 EP=7 IP=0 FDC=0
.ENDS
***************************************
.SUBCKT XOR3S I2 I1 I3 VCC GND O
** N=7 EP=6 IP=0 FDC=0
.ENDS
***************************************
.SUBCKT INV3 I O GND VCC
** N=5 EP=4 IP=0 FDC=0
.ENDS
***************************************
.SUBCKT INV2 I O GND VCC
** N=5 EP=4 IP=0 FDC=0
.ENDS
***************************************
.SUBCKT AN4B1S I3 I2 I1 VCC B1 GND O
** N=8 EP=7 IP=0 FDC=0
.ENDS
***************************************
.SUBCKT OA22 A1 A2 B1 B2 VCC GND O
** N=8 EP=7 IP=0 FDC=0
.ENDS
***************************************
.SUBCKT NR2 I1 VCC O I2 GND
** N=6 EP=5 IP=0 FDC=0
.ENDS
***************************************
.SUBCKT AOI12HS B2 B1 VCC A1 GND O
** N=7 EP=6 IP=0 FDC=0
.ENDS
***************************************
.SUBCKT OA112 A1 B1 C1 C2 VCC GND O
** N=8 EP=7 IP=0 FDC=0
.ENDS
***************************************
.SUBCKT MAOI1 B1 B2 A1 A2 VCC GND O
** N=8 EP=7 IP=0 FDC=0
.ENDS
***************************************
.SUBCKT ND3 I3 GND I2 O VCC I1
** N=7 EP=6 IP=0 FDC=0
.ENDS
***************************************
.SUBCKT ICV_12 1 2 3 4 5 6 7 8 9 10 11 12 13 14 15 16 17 18 19 20
+ 21 22 23 24 25 26 27 28 29 30 31 32 33 34 35 36 37 38 39 40
+ 41 42 43 44 45 46 47 48 49 50 51 52 53 54 55 56 57 58 59 60
+ 61 62 63 64 65 66 67 68 69 70 71 72 73 74 75 76 77 78 79 80
+ 81 82 83 84 85 86 87 88 89 90 91 92 93 94 95 97 98 99 100 101
+ 102 104 105 106 107 108 110 111 112 113 114 115 116 117 119 120 121 122 123 125
+ 126 127 128 129 130 131 133 134 135 136 137 138 139 140 141 142 143 144 145 146
+ 147 148 149 150 151 152 153 154 155 156 157 158 159 160 161 162 163 164 165 166
+ 167 168 169 171 172 173 174 175 176 177 178 179 180 181 219
** N=333 EP=175 IP=1133 FDC=0
X0 125 121 119 1 2 QDFFN $T=684480 1062320 1 180 $X=673940 $Y=1061940
X1 120 121 286 1 2 QDFFN $T=677660 1082480 1 0 $X=677660 $Y=1077060
X2 125 123 122 1 2 QDFFN $T=691300 1072400 0 180 $X=680760 $Y=1066980
X3 120 123 287 1 2 QDFFN $T=703080 1082480 0 180 $X=692540 $Y=1077060
X4 125 129 289 1 2 QDFFN $T=699980 1062320 0 0 $X=699980 $Y=1061940
X5 125 130 288 1 2 QDFFN $T=701220 1072400 0 0 $X=701220 $Y=1072020
X6 131 123 290 1 2 QDFFN $T=709900 1082480 1 0 $X=709900 $Y=1077060
X7 131 130 292 1 2 QDFFN $T=718580 1062320 0 0 $X=718580 $Y=1061940
X8 131 121 291 1 2 QDFFN $T=732220 1072400 1 180 $X=721680 $Y=1072020
X9 137 121 293 1 2 QDFFN $T=724780 1082480 1 0 $X=724780 $Y=1077060
X10 137 123 294 1 2 QDFFN $T=748960 1082480 0 180 $X=738420 $Y=1077060
X11 137 130 142 1 2 QDFFN $T=739040 1062320 0 0 $X=739040 $Y=1061940
X12 141 121 295 1 2 QDFFN $T=741520 1072400 0 0 $X=741520 $Y=1072020
X13 141 123 296 1 2 QDFFN $T=763220 1082480 0 180 $X=752680 $Y=1077060
X14 141 129 145 1 2 QDFFN $T=753300 1062320 0 0 $X=753300 $Y=1061940
X15 144 123 297 1 2 QDFFN $T=760120 1072400 0 0 $X=760120 $Y=1072020
X16 144 130 147 1 2 QDFFN $T=766320 1062320 0 0 $X=766320 $Y=1061940
X17 144 121 298 1 2 QDFFN $T=766320 1082480 1 0 $X=766320 $Y=1077060
X18 148 130 149 1 2 QDFFN $T=778100 1062320 0 0 $X=778100 $Y=1061940
X19 148 123 300 1 2 QDFFN $T=778100 1072400 1 0 $X=778100 $Y=1066980
X20 148 121 299 1 2 QDFFN $T=779340 1082480 1 0 $X=779340 $Y=1077060
X21 148 129 150 1 2 QDFFN $T=799180 1062320 1 180 $X=788640 $Y=1061940
X22 152 121 304 1 2 QDFFN $T=794840 1082480 1 0 $X=794840 $Y=1077060
X23 152 123 301 1 2 QDFFN $T=804760 1072400 0 0 $X=804760 $Y=1072020
X24 159 156 305 1 2 QDFFN $T=819640 1082480 0 180 $X=809100 $Y=1077060
X25 159 160 155 1 2 QDFFN $T=826460 1072400 0 180 $X=815920 $Y=1066980
X26 159 162 306 1 2 QDFFN $T=834520 1082480 0 180 $X=823980 $Y=1077060
X27 161 162 307 1 2 QDFFN $T=827700 1072400 0 0 $X=827700 $Y=1072020
X28 159 164 163 1 2 QDFFN $T=841340 1062320 1 180 $X=830800 $Y=1061940
X29 161 156 310 1 2 QDFFN $T=837620 1082480 1 0 $X=837620 $Y=1077060
X30 161 166 311 1 2 QDFFN $T=847540 1072400 1 0 $X=847540 $Y=1066980
X31 161 160 312 1 2 QDFFN $T=847540 1072400 0 0 $X=847540 $Y=1072020
X32 167 160 315 1 2 QDFFN $T=860560 1072400 0 0 $X=860560 $Y=1072020
X33 167 156 317 1 2 QDFFN $T=872340 1082480 1 0 $X=872340 $Y=1077060
X34 167 162 316 1 2 QDFFN $T=874200 1072400 0 0 $X=874200 $Y=1072020
X35 171 166 319 1 2 QDFFN $T=882260 1062320 0 0 $X=882260 $Y=1061940
X36 171 160 318 1 2 QDFFN $T=896520 1082480 0 180 $X=885980 $Y=1077060
X37 171 156 322 1 2 QDFFN $T=907680 1062320 1 180 $X=897140 $Y=1061940
X38 171 162 323 1 2 QDFFN $T=910160 1082480 0 180 $X=899620 $Y=1077060
X39 173 162 324 1 2 QDFFN $T=905820 1072400 0 0 $X=905820 $Y=1072020
X40 174 164 175 1 2 QDFFN $T=911400 1062320 0 0 $X=911400 $Y=1061940
X41 173 156 325 1 2 QDFFN $T=916980 1082480 1 0 $X=916980 $Y=1077060
X42 173 160 327 1 2 QDFFN $T=938680 1072400 1 180 $X=928140 $Y=1072020
X43 173 166 329 1 2 QDFFN $T=936200 1062320 0 0 $X=936200 $Y=1061940
X44 177 156 330 1 2 QDFFN $T=939920 1082480 1 0 $X=939920 $Y=1077060
X45 177 160 331 1 2 QDFFN $T=941780 1072400 0 0 $X=941780 $Y=1072020
X46 177 162 333 1 2 QDFFN $T=954180 1082480 1 0 $X=954180 $Y=1077060
X47 177 166 332 1 2 QDFFN $T=957900 1062320 0 0 $X=957900 $Y=1061940
X48 174 156 180 1 2 QDFFN $T=964100 1072400 0 0 $X=964100 $Y=1072020
X49 174 166 181 1 2 QDFFN $T=988280 1072400 0 180 $X=977740 $Y=1066980
X50 13 17 223 16 1 15 2 AOI22S $T=262880 1062320 1 180 $X=259160 $Y=1061940
X51 20 19 224 18 1 15 2 AOI22S $T=267840 1062320 1 180 $X=264120 $Y=1061940
X52 19 35 36 18 1 30 2 AOI22S $T=295120 1062320 1 180 $X=291400 $Y=1061940
X53 286 287 126 127 1 128 2 AOI22S $T=695020 1072400 1 0 $X=695020 $Y=1066980
X54 288 289 133 134 1 135 2 AOI22S $T=712380 1062320 0 0 $X=712380 $Y=1061940
X55 291 290 136 127 1 128 2 AOI22S $T=718580 1072400 1 180 $X=714860 $Y=1072020
X56 292 139 138 134 1 135 2 AOI22S $T=732220 1062320 0 0 $X=732220 $Y=1061940
X57 293 294 140 127 1 128 2 AOI22S $T=735320 1072400 0 0 $X=735320 $Y=1072020
X58 295 296 143 127 1 128 2 AOI22S $T=754540 1072400 1 0 $X=754540 $Y=1066980
X59 298 297 146 127 1 128 2 AOI22S $T=776860 1072400 1 180 $X=773140 $Y=1072020
X60 299 300 151 127 1 128 2 AOI22S $T=790500 1072400 0 0 $X=790500 $Y=1072020
X61 304 301 302 127 1 128 2 AOI22S $T=802280 1072400 1 180 $X=798560 $Y=1072020
X62 157 154 303 134 1 135 2 AOI22S $T=809100 1062320 1 180 $X=805380 $Y=1061940
X63 305 306 158 127 1 128 2 AOI22S $T=820880 1072400 0 0 $X=820880 $Y=1072020
X64 310 307 308 127 1 128 2 AOI22S $T=845060 1072400 0 180 $X=841340 $Y=1066980
X65 311 312 309 134 1 135 2 AOI22S $T=859320 1072400 1 0 $X=859320 $Y=1066980
X66 169 315 313 134 1 135 2 AOI22S $T=866760 1072400 1 0 $X=866760 $Y=1066980
X67 317 316 314 127 1 128 2 AOI22S $T=875440 1062320 1 180 $X=871720 $Y=1061940
X68 319 318 320 134 1 135 2 AOI22S $T=890940 1072400 1 180 $X=887220 $Y=1072020
X69 322 323 321 127 1 128 2 AOI22S $T=897140 1072400 0 0 $X=897140 $Y=1072020
X70 325 324 328 127 1 128 2 AOI22S $T=923180 1072400 0 180 $X=919460 $Y=1066980
X71 329 327 326 134 1 135 2 AOI22S $T=933100 1072400 0 180 $X=929380 $Y=1066980
X72 332 331 178 134 1 135 2 AOI22S $T=954180 1062320 1 180 $X=950460 $Y=1061940
X73 330 333 179 127 1 128 2 AOI22S $T=955420 1072400 1 0 $X=955420 $Y=1066980
X74 229 54 1 2 231 AN2 $T=370760 1072400 1 0 $X=370760 $Y=1066980
X75 245 54 1 2 239 AN2 $T=414780 1072400 1 180 $X=412300 $Y=1072020
X76 256 54 1 2 253 AN2 $T=454460 1072400 0 0 $X=454460 $Y=1072020
X77 262 54 1 2 263 AN2 $T=469960 1082480 1 0 $X=469960 $Y=1077060
X78 270 54 1 2 76 AN2 $T=514600 1072400 1 180 $X=512120 $Y=1072020
X79 302 303 1 2 153 AN2 $T=801660 1062320 0 0 $X=801660 $Y=1061940
X80 308 309 1 2 165 AN2 $T=844440 1062320 0 0 $X=844440 $Y=1061940
X81 314 313 1 2 168 AN2 $T=866140 1072400 0 180 $X=863660 $Y=1066980
X82 321 320 1 2 172 AN2 $T=894660 1072400 0 180 $X=892180 $Y=1066980
X83 328 326 1 2 176 AN2 $T=928760 1062320 1 180 $X=926280 $Y=1061940
X84 279 1 2 280 DELA $T=613800 1072400 1 0 $X=613800 $Y=1066980
X85 108 1 2 281 DELA $T=619380 1062320 0 0 $X=619380 $Y=1061940
X86 282 1 2 283 DELA $T=641080 1072400 1 0 $X=641080 $Y=1066980
X87 285 1 2 284 DELA $T=664640 1072400 1 0 $X=664640 $Y=1066980
X88 49 50 52 2 1 53 QDFFRBN $T=347820 1062320 0 0 $X=347820 $Y=1061940
X89 230 50 52 2 1 229 QDFFRBN $T=376340 1072400 1 180 $X=364560 $Y=1072020
X90 247 50 52 2 1 245 QDFFRBN $T=429040 1072400 0 180 $X=417260 $Y=1066980
X91 246 50 52 2 1 256 QDFFRBN $T=435240 1082480 1 0 $X=435240 $Y=1077060
X92 257 50 52 2 1 262 QDFFRBN $T=451360 1082480 1 0 $X=451360 $Y=1077060
X93 268 50 52 2 1 270 QDFFRBN $T=493520 1072400 0 0 $X=493520 $Y=1072020
X94 273 50 52 2 1 79 QDFFRBN $T=516460 1062320 0 0 $X=516460 $Y=1061940
X95 278 50 52 2 1 90 QDFFRBN $T=554900 1062320 0 0 $X=554900 $Y=1061940
X96 94 93 52 2 1 92 QDFFRBN $T=584660 1062320 1 180 $X=572880 $Y=1061940
X97 98 93 52 2 1 101 QDFFRBN $T=591480 1072400 0 0 $X=591480 $Y=1072020
X98 280 93 52 2 1 104 QDFFRBN $T=621240 1072400 1 180 $X=609460 $Y=1072020
X99 281 93 52 2 1 111 QDFFRBN $T=618760 1072400 1 0 $X=618760 $Y=1066980
X100 283 93 52 2 1 110 QDFFRBN $T=643560 1072400 1 180 $X=631780 $Y=1072020
X101 284 117 52 2 1 116 QDFFRBN $T=664640 1072400 0 180 $X=652860 $Y=1066980
X102 279 107 106 2 105 100 1 AO22 $T=613800 1072400 0 180 $X=608840 $Y=1066980
X103 282 107 113 2 112 100 1 AO22 $T=641080 1072400 0 180 $X=636120 $Y=1066980
X104 285 107 115 2 114 100 1 AO22 $T=648520 1062320 1 180 $X=643560 $Y=1061940
X105 99 2 101 102 95 1 97 FA1S $T=601400 1062320 1 180 $X=589620 $Y=1061940
X106 5 2 220 1 INV1S $T=241800 1062320 0 0 $X=241800 $Y=1061940
X107 34 2 30 1 INV1S $T=287680 1062320 1 180 $X=286440 $Y=1061940
X108 87 2 88 1 INV1S $T=560480 1082480 1 0 $X=560480 $Y=1077060
X109 89 2 91 1 INV1S $T=564200 1082480 1 0 $X=564200 $Y=1077060
X110 255 1 2 259 BUF1S $T=458800 1072400 1 0 $X=458800 $Y=1066980
X111 78 1 2 277 BUF1S $T=552420 1062320 0 0 $X=552420 $Y=1061940
X112 56 1 57 58 2 ND2P $T=381300 1062320 0 0 $X=381300 $Y=1061940
X113 60 1 55 232 2 ND2P $T=386260 1072400 1 180 $X=382540 $Y=1072020
X114 233 1 55 236 2 ND2P $T=393700 1072400 1 180 $X=389980 $Y=1072020
X115 64 1 234 241 2 ND2P $T=403620 1072400 1 0 $X=403620 $Y=1066980
X116 239 1 234 243 2 ND2P $T=408580 1072400 1 0 $X=408580 $Y=1066980
X117 248 1 244 250 2 ND2P $T=432140 1062320 1 180 $X=428420 $Y=1061940
X118 249 1 244 251 2 ND2P $T=432140 1062320 0 0 $X=432140 $Y=1061940
X119 263 1 254 267 2 ND2P $T=482360 1072400 0 0 $X=482360 $Y=1072020
X120 75 1 264 269 2 ND2P $T=499720 1062320 0 0 $X=499720 $Y=1061940
X121 73 1 264 271 2 ND2P $T=509640 1072400 0 180 $X=505920 $Y=1066980
X122 84 1 78 276 2 ND2P $T=551180 1062320 1 180 $X=547460 $Y=1061940
X123 59 231 61 2 1 233 XOR3 $T=388120 1072400 1 0 $X=388120 $Y=1066980
X124 234 239 64 2 1 237 XOR3 $T=407340 1062320 1 180 $X=396180 $Y=1061940
X125 237 65 238 2 1 247 XOR3 $T=414160 1062320 0 0 $X=414160 $Y=1061940
X126 249 248 244 2 1 246 XOR3 $T=430900 1082480 0 180 $X=419740 $Y=1077060
X127 66 253 240 2 1 249 XOR3 $T=441440 1072400 1 0 $X=441440 $Y=1066980
X128 263 71 254 2 1 261 XOR3 $T=463760 1072400 0 0 $X=463760 $Y=1072020
X129 261 260 259 2 1 257 XOR3 $T=466860 1072400 1 0 $X=466860 $Y=1066980
X130 73 75 264 2 1 268 XOR3 $T=486700 1072400 1 0 $X=486700 $Y=1066980
X131 275 77 274 2 1 273 XOR3 $T=523280 1072400 1 0 $X=523280 $Y=1066980
X132 82 84 277 2 1 278 XOR3 $T=541880 1072400 1 0 $X=541880 $Y=1066980
X133 265 1 266 267 2 74 ND3HT $T=480500 1062320 0 0 $X=480500 $Y=1061940
X134 83 1 276 85 2 86 ND3HT $T=540020 1062320 0 0 $X=540020 $Y=1061940
X135 258 70 260 2 1 XOR2HS $T=458180 1062320 0 0 $X=458180 $Y=1061940
X136 80 81 275 2 1 XOR2HS $T=531960 1062320 0 0 $X=531960 $Y=1061940
X137 61 59 231 234 1 2 MAO222P $T=382540 1072400 1 0 $X=382540 $Y=1066980
X138 238 237 65 244 1 2 MAO222P $T=408580 1062320 0 0 $X=408580 $Y=1061940
X139 240 66 253 254 1 2 MAO222P $T=435860 1072400 1 0 $X=435860 $Y=1066980
X140 255 261 260 264 1 2 MAO222P $T=461280 1072400 1 0 $X=461280 $Y=1066980
X141 274 275 77 78 1 2 MAO222P $T=517700 1072400 1 0 $X=517700 $Y=1066980
X142 232 238 236 235 1 2 ND3P $T=394940 1072400 0 0 $X=394940 $Y=1072020
X143 241 240 243 242 1 2 ND3P $T=412300 1072400 1 180 $X=407340 $Y=1072020
X144 250 255 251 252 1 2 ND3P $T=437100 1062320 0 0 $X=437100 $Y=1061940
X145 271 274 269 272 1 2 ND3P $T=512120 1072400 1 0 $X=512120 $Y=1066980
X146 13 12 14 1 2 ND2 $T=255440 1062320 0 0 $X=255440 $Y=1061940
X147 25 225 24 1 2 ND2 $T=276520 1062320 1 180 $X=274660 $Y=1061940
X148 60 235 233 1 2 ND2 $T=388120 1072400 1 180 $X=386260 $Y=1072020
X149 63 62 56 1 2 ND2 $T=390600 1062320 1 180 $X=388740 $Y=1061940
X150 64 242 239 1 2 ND2 $T=414160 1072400 0 180 $X=412300 $Y=1066980
X151 248 252 249 1 2 ND2 $T=434000 1072400 0 180 $X=432140 $Y=1066980
X152 71 265 263 1 2 ND2 $T=489180 1082480 0 180 $X=487320 $Y=1077060
X153 75 272 73 1 2 ND2 $T=504680 1062320 0 0 $X=504680 $Y=1061940
X154 4 3 1 2 INV12CK $T=230640 1082480 0 180 $X=220720 $Y=1077060
X155 3 6 1 2 INV12CK $T=244280 1082480 0 180 $X=234360 $Y=1077060
X156 3 72 1 2 INV12CK $T=487320 1082480 0 180 $X=477400 $Y=1077060
X157 71 1 254 266 2 ND2T $T=482360 1072400 1 180 $X=477400 $Y=1072020
X158 248 69 2 68 67 1 258 FA1 $T=442060 1062320 0 0 $X=442060 $Y=1061940
X159 233 60 55 2 1 230 XOR3S $T=385640 1082480 0 180 $X=374480 $Y=1077060
X160 51 52 1 2 INV3 $T=358980 1072400 1 0 $X=358980 $Y=1066980
X161 48 51 1 2 INV2 $T=345340 1082480 1 0 $X=345340 $Y=1077060
X162 10 9 220 2 8 1 7 AN4B1S $T=248620 1062320 1 180 $X=244280 $Y=1061940
X163 228 223 41 2 42 1 43 AN4B1S $T=318060 1062320 0 0 $X=318060 $Y=1061940
X164 44 45 46 2 8 1 47 AN4B1S $T=324880 1062320 0 0 $X=324880 $Y=1061940
X165 227 32 40 226 2 1 228 OA22 $T=310000 1062320 0 0 $X=310000 $Y=1061940
X166 28 2 226 14 1 NR2 $T=279620 1072400 0 180 $X=277760 $Y=1066980
X167 35 2 227 39 1 NR2 $T=306280 1062320 0 0 $X=306280 $Y=1061940
X168 28 35 2 37 1 38 AOI12HS $T=299460 1072400 1 0 $X=299460 $Y=1066980
X169 29 224 27 26 2 1 222 OA112 $T=284580 1062320 1 180 $X=279620 $Y=1061940
X170 9 31 24 32 2 1 33 OA112 $T=285200 1072400 1 0 $X=285200 $Y=1066980
X171 23 22 21 225 2 1 221 MAOI1 $T=273420 1062320 1 180 $X=268460 $Y=1061940
X172 222 1 11 5 2 221 ND3 $T=252340 1062320 1 180 $X=249860 $Y=1061940
.ENDS
***************************************
.SUBCKT BUF2 I O GND VCC
** N=5 EP=4 IP=0 FDC=0
.ENDS
***************************************
.SUBCKT ICV_13 1 2 3 4 5 6 7 8 9
** N=9 EP=9 IP=12 FDC=0
X0 1 2 3 4 5 QDFFN $T=0 0 0 0 $X=0 $Y=-380
X1 6 7 8 4 5 QDFFN $T=10540 0 0 0 $X=10540 $Y=-380
.ENDS
***************************************
.SUBCKT INV4CK I O GND VCC
** N=5 EP=4 IP=0 FDC=0
.ENDS
***************************************
.SUBCKT ICV_14 1 2 3 4 5 6 7 8 9 10 11
** N=11 EP=11 IP=14 FDC=0
X0 1 2 3 4 5 QDFFN $T=0 0 0 0 $X=0 $Y=-380
X1 6 7 8 9 4 10 5 AOI22S $T=10540 0 0 0 $X=10540 $Y=-380
.ENDS
***************************************
.SUBCKT INV6CK I O GND VCC
** N=5 EP=4 IP=0 FDC=0
.ENDS
***************************************
.SUBCKT BUF1 I VCC GND O
** N=5 EP=4 IP=0 FDC=0
.ENDS
***************************************
.SUBCKT INV2CK I O GND VCC
** N=5 EP=4 IP=0 FDC=0
.ENDS
***************************************
.SUBCKT QDBHN CKB D GND VCC Q
** N=6 EP=5 IP=0 FDC=0
.ENDS
***************************************
.SUBCKT DELC I GND VCC O
** N=5 EP=4 IP=0 FDC=0
.ENDS
***************************************
.SUBCKT INV3CK I GND VCC O
** N=5 EP=4 IP=0 FDC=0
.ENDS
***************************************
.SUBCKT AN2T I1 I2 O GND VCC
** N=6 EP=5 IP=0 FDC=0
.ENDS
***************************************
.SUBCKT INV8CK I O GND VCC
** N=5 EP=4 IP=0 FDC=0
.ENDS
***************************************
.SUBCKT AO222 C1 C2 B2 B1 A1 A2 GND VCC O
** N=10 EP=9 IP=0 FDC=0
.ENDS
***************************************
.SUBCKT AN2P I1 I2 O GND VCC
** N=6 EP=5 IP=0 FDC=0
.ENDS
***************************************
.SUBCKT ND2S I1 O I2 VCC GND
** N=6 EP=5 IP=0 FDC=0
.ENDS
***************************************
.SUBCKT BUF3 I VCC GND O
** N=5 EP=4 IP=0 FDC=0
.ENDS
***************************************
.SUBCKT OAI22S B2 GND B1 A2 O A1 VCC
** N=8 EP=7 IP=0 FDC=0
.ENDS
***************************************
.SUBCKT DELB I GND VCC O
** N=5 EP=4 IP=0 FDC=0
.ENDS
***************************************
.SUBCKT BUF2CK I O GND VCC
** N=5 EP=4 IP=0 FDC=0
.ENDS
***************************************
.SUBCKT BUF1CK I GND VCC O
** N=5 EP=4 IP=0 FDC=0
.ENDS
***************************************
.SUBCKT OR3B2 I1 B1 VCC O B2 GND
** N=7 EP=6 IP=0 FDC=0
.ENDS
***************************************
.SUBCKT AOI12H B2 B1 VCC O A1 GND
** N=7 EP=6 IP=0 FDC=0
.ENDS
***************************************
.SUBCKT OAI112HS C2 C1 GND B1 O A1 VCC
** N=8 EP=7 IP=0 FDC=0
.ENDS
***************************************
.SUBCKT OA222S A2 A1 B2 B1 C2 C1 VCC GND O
** N=10 EP=9 IP=0 FDC=0
.ENDS
***************************************
.SUBCKT MOAI1S B1 B2 GND A1 A2 O VCC
** N=8 EP=7 IP=0 FDC=0
.ENDS
***************************************
.SUBCKT OAI222S C1 C2 GND B1 B2 VCC A1 O A2
** N=10 EP=9 IP=0 FDC=0
.ENDS
***************************************
.SUBCKT XNR2HS I1 I2 O VCC GND
** N=6 EP=5 IP=0 FDC=0
.ENDS
***************************************
.SUBCKT OA222 A2 A1 B2 B1 C2 C1 GND VCC O
** N=10 EP=9 IP=0 FDC=0
.ENDS
***************************************
.SUBCKT AO222S C1 C2 B2 B1 A1 A2 GND VCC O
** N=10 EP=9 IP=0 FDC=0
.ENDS
***************************************
.SUBCKT OR2S I2 I1 VCC GND O
** N=6 EP=5 IP=0 FDC=0
.ENDS
***************************************
.SUBCKT OR2 I2 I1 VCC GND O
** N=6 EP=5 IP=0 FDC=0
.ENDS
***************************************
.SUBCKT ND3S I3 GND I2 O I1 VCC
** N=7 EP=6 IP=0 FDC=0
.ENDS
***************************************
.SUBCKT AN3 I1 I2 I3 VCC GND O
** N=7 EP=6 IP=0 FDC=0
.ENDS
***************************************
.SUBCKT NR3 I1 VCC I2 I3 O GND
** N=7 EP=6 IP=0 FDC=0
.ENDS
***************************************
.SUBCKT AOI13HS B3 O B2 B1 VCC A1 GND
** N=8 EP=7 IP=0 FDC=0
.ENDS
***************************************
.SUBCKT OR2P I2 I1 O GND VCC
** N=6 EP=5 IP=0 FDC=0
.ENDS
***************************************
.SUBCKT NR2P I1 VCC I2 GND O
** N=6 EP=5 IP=0 FDC=0
.ENDS
***************************************
.SUBCKT OA13S B3 B2 B1 A1 GND VCC O
** N=8 EP=7 IP=0 FDC=0
.ENDS
***************************************
.SUBCKT MOAI1 B1 B2 GND A1 O A2 VCC
** N=8 EP=7 IP=0 FDC=0
.ENDS
***************************************
.SUBCKT AN2B1 I1 O B1 GND VCC
** N=6 EP=5 IP=0 FDC=0
.ENDS
***************************************
.SUBCKT OA12S B2 B1 A1 VCC GND O
** N=7 EP=6 IP=0 FDC=0
.ENDS
***************************************
.SUBCKT OAI12HS B2 B1 GND A1 VCC O
** N=7 EP=6 IP=0 FDC=0
.ENDS
***************************************
.SUBCKT INV1CK O I GND VCC
** N=5 EP=4 IP=0 FDC=0
.ENDS
***************************************
.SUBCKT QDFFRBP D CK RB Q GND VCC
** N=7 EP=6 IP=0 FDC=0
.ENDS
***************************************
.SUBCKT DFFRBN D CK RB Q GND VCC QB
** N=8 EP=7 IP=0 FDC=0
.ENDS
***************************************
.SUBCKT MAO222 B1 A1 C1 GND VCC O
** N=7 EP=6 IP=0 FDC=0
.ENDS
***************************************
.SUBCKT MUX2S B S VCC A GND O
** N=7 EP=6 IP=0 FDC=0
.ENDS
***************************************
.SUBCKT MUX2 B S VCC GND O A
** N=7 EP=6 IP=0 FDC=0
.ENDS
***************************************
.SUBCKT ICV_15 1 2 3 4 5 6 7 8 9 10 11
** N=11 EP=11 IP=14 FDC=0
X0 1 2 3 4 5 6 XOR3 $T=5580 0 0 0 $X=5580 $Y=-380
X1 7 8 9 10 5 4 MAO222P $T=0 0 0 0 $X=0 $Y=-380
.ENDS
***************************************
.SUBCKT XOR2H I1 I2 O GND VCC
** N=6 EP=5 IP=0 FDC=0
.ENDS
***************************************
.SUBCKT XNR3 I2 I1 I3 VCC GND O
** N=7 EP=6 IP=0 FDC=0
.ENDS
***************************************
.SUBCKT AO22S O A2 A1 VCC B1 B2 GND
** N=8 EP=7 IP=0 FDC=0
.ENDS
***************************************
.SUBCKT AO22P O A2 A1 VCC B1 B2 GND
** N=8 EP=7 IP=0 FDC=0
.ENDS
***************************************
.SUBCKT MXL2H B S OB A GND VCC
** N=7 EP=6 IP=0 FDC=0
.ENDS
***************************************
.SUBCKT ICV_16 1 2 3 4 5 6 7 8 9
** N=9 EP=9 IP=12 FDC=0
X0 1 2 3 4 5 ND2 $T=0 0 0 0 $X=0 $Y=-380
X1 6 7 8 4 5 ND2 $T=1860 0 0 0 $X=1860 $Y=-380
.ENDS
***************************************
.SUBCKT MXL2HS B S OB A VCC GND
** N=7 EP=6 IP=0 FDC=0
.ENDS
***************************************
.SUBCKT NR2T O I2 GND I1 VCC
** N=6 EP=5 IP=0 FDC=0
.ENDS
***************************************
.SUBCKT OR3B1 B1 I1 I2 GND VCC O
** N=7 EP=6 IP=0 FDC=0
.ENDS
***************************************
.SUBCKT AN2B1S I1 VCC B1 O GND
** N=6 EP=5 IP=0 FDC=0
.ENDS
***************************************
.SUBCKT AOI22H A2 A1 VCC B1 O B2 GND
** N=8 EP=7 IP=0 FDC=0
.ENDS
***************************************
.SUBCKT OA12 B2 B1 A1 GND VCC O
** N=7 EP=6 IP=0 FDC=0
.ENDS
***************************************
.SUBCKT AN2S I1 I2 GND O VCC
** N=6 EP=5 IP=0 FDC=0
.ENDS
***************************************
.SUBCKT OAI12H B2 B1 GND A1 O VCC
** N=7 EP=6 IP=0 FDC=0
.ENDS
***************************************
.SUBCKT MOAI1H B1 B2 GND A1 O A2 VCC
** N=8 EP=7 IP=0 FDC=0
.ENDS
***************************************
.SUBCKT OR2B1S I1 B1 GND O VCC
** N=6 EP=5 IP=0 FDC=0
.ENDS
***************************************
.SUBCKT DFFSBN D CK SB Q GND VCC QB
** N=8 EP=7 IP=0 FDC=0
.ENDS
***************************************
.SUBCKT AO13S B3 B2 B1 A1 GND VCC O
** N=8 EP=7 IP=0 FDC=0
.ENDS
***************************************
.SUBCKT INV4 I O GND VCC
** N=5 EP=4 IP=0 FDC=0
.ENDS
***************************************
.SUBCKT AO12 B2 B1 A1 GND VCC O
** N=7 EP=6 IP=0 FDC=0
.ENDS
***************************************
.SUBCKT AN3S I1 I2 I3 GND VCC O
** N=7 EP=6 IP=0 FDC=0
.ENDS
***************************************
.SUBCKT OA22S A1 A2 B1 B2 VCC GND O
** N=8 EP=7 IP=0 FDC=0
.ENDS
***************************************
.SUBCKT AO112 O C2 C1 VCC B1 GND A1
** N=8 EP=7 IP=0 FDC=0
.ENDS
***************************************
.SUBCKT OR3 I3 I2 I1 VCC GND O
** N=7 EP=6 IP=0 FDC=0
.ENDS
***************************************
.SUBCKT AN3B2S I1 B2 VCC B1 GND O
** N=7 EP=6 IP=0 FDC=0
.ENDS
***************************************
.SUBCKT AN2B1T B1 I1 O GND VCC
** N=6 EP=5 IP=0 FDC=0
.ENDS
***************************************
.SUBCKT OA112S A1 B1 C1 C2 VCC GND O
** N=8 EP=7 IP=0 FDC=0
.ENDS
***************************************
.SUBCKT OR3S I3 I2 I1 VCC GND O
** N=7 EP=6 IP=0 FDC=0
.ENDS
***************************************
.SUBCKT MAOI1S B1 B2 A1 A2 VCC GND O
** N=8 EP=7 IP=0 FDC=0
.ENDS
***************************************
.SUBCKT ICV_17 1 2 3 4 5 6 7 8 9 10 11 12 13 14 15 16 17 18 19 20
+ 21 22 23 24 25 26 27 28 29 30 31 32 33 34 35 36 37 38 39 40
+ 41 42 43 44 45 46 47 48 49 50 51 52 53 54 55 56 57 58 59 60
+ 61 62 63 64 65 66 67 68 69 70 71 72 73 74 75 76 77 78 79 80
+ 81 82 83 84 85 86 87 88 89 90 91 92 93 94 95 96 97 98 99 100
+ 101 102 103 104 105 106 107 108 109 110 111 112 113 114 115 116 117 118 119 120
+ 121 122 123 124 125 126 127 128 129 130 131 132 133 134 135 136 137 138 139 140
+ 141 142 143 144 145 146 147 148 149 150 151 152 153 154 155 156 157 158 159 160
+ 161 162 163 164 165 166 167 168 169 170 171 172 173 174 175 176 177 178 179 180
+ 181 182 183 184 185 186 187 188 189 190 191 192 193 194 195 196 197 198 199 200
+ 201 202 203 204 205 206 207 208 209 210 211 212 213 214 215 216 217 218 219 220
+ 221 222 223 224 225 226 227 228 229 230 231 232 233 234 235 236 237 238 239 240
+ 241 242 243 244 245 246 247 248 249 250 251 252 253 254 255 256 257 258 259 260
+ 261 262 263 264 265 266 267 268 269 270 271 272 273 274 275 276 277 278 279 280
+ 281 282 283 284 285 286 287 288 289 290 291 292 293 294 295 296 297 298 299 300
+ 301 302 303 304 305 306 307 308 309 310 311 312 313 314 315 316 317 318 319 320
+ 321 322 323 324 325 326 327 328 329 330 331 332 333 334 335 336 337 338 339 340
+ 341 342 343 344 345 346 347 348 349 350 351 352 353 354 355 356 357 358 359 360
+ 361 362 363 364 365 366 367 368 369 370 371 372 373 374 375 376 377 378 379 380
+ 381 382 383 384 385 386 387 388 389 390 391 392 393 394 395 396 397 398 399 400
+ 401 402 403 404 405 406 407 408 409 410 411 412 413 414 415 416 417 418 419 420
+ 421 422 423 424 425 426 427 428 429 430 431 432 433 434 435 436 437 438 439 440
+ 441 442 443 444 445 446 447 448 449 450 451 452 453 454 455 456 457 458 459 460
+ 461 462 463 464 465 466 467 468 469 470 471 472 473 474 475 476 477 478 479 480
+ 481 482 483 484 485 486 487 488 489 490 491 492 493 494 495 496 497 498 499 500
+ 501 502 503 504 505 506 507 508 509 510 511 512 513 514 515 516 517 518 519 520
+ 521 522 523 524 525 526 527 528 529 530 531 532 533 534 535 536 537 538 539 540
+ 541 542 543 544 545 546 547 548 549 550 551 552 553 554 555 556 557 558 559 560
+ 561 562 563 564 565 566 567 568 569 570 571 572 573 574 575 576 577 578 579 580
+ 581 582 583 584 585 586 587 588 589 590 591 592 593 594 595 596 597 598 599 600
+ 601 602 603 604 605 606 607 608 609 610 611 612 613 614 615 616 617 618 619 620
+ 621 622 623 624 625 626 627 628 629 630 631 632 633 634 635 636 637 638 639 640
+ 641 642 643 644 645 646 647 648 649 650 651 652 653 654 655 656 657 658 659 660
+ 661 662 663 664 665 666 667 668 669 670 671 672 673 674 675 676 697
** N=4863 EP=677 IP=28841 FDC=0
X0 352 3461 3511 1 2 QDFFN $T=675800 1052240 1 0 $X=675800 $Y=1046820
X1 352 3466 3500 1 2 QDFFN $T=676420 1062320 1 0 $X=676420 $Y=1056900
X2 354 3461 3510 1 2 QDFFN $T=678280 1032080 1 0 $X=678280 $Y=1026660
X3 354 3466 3513 1 2 QDFFN $T=679520 1042160 0 0 $X=679520 $Y=1041780
X4 3512 368 3577 1 2 QDFFN $T=689440 1022000 0 0 $X=689440 $Y=1021620
X5 3512 3531 3587 1 2 QDFFN $T=690680 971600 0 0 $X=690680 $Y=971220
X6 354 3531 3560 1 2 QDFFN $T=690680 1032080 1 0 $X=690680 $Y=1026660
X7 3512 3461 3569 1 2 QDFFN $T=691300 981680 0 0 $X=691300 $Y=981300
X8 3512 370 3563 1 2 QDFFN $T=691300 1011920 0 0 $X=691300 $Y=1011540
X9 3512 384 3529 1 2 QDFFN $T=703080 1011920 0 180 $X=692540 $Y=1006500
X10 352 3531 3550 1 2 QDFFN $T=706800 1052240 0 180 $X=696260 $Y=1046820
X11 3512 382 3543 1 2 QDFFN $T=707420 1001840 1 180 $X=696880 $Y=1001460
X12 354 382 3585 1 2 QDFFN $T=698120 1062320 1 0 $X=698120 $Y=1056900
X13 354 384 3598 1 2 QDFFN $T=699360 1052240 0 0 $X=699360 $Y=1051860
X14 3512 3466 3567 1 2 QDFFN $T=711760 991760 0 180 $X=701220 $Y=986340
X15 3570 382 3609 1 2 QDFFN $T=702460 1001840 1 0 $X=702460 $Y=996420
X16 3570 368 3614 1 2 QDFFN $T=702460 1022000 1 0 $X=702460 $Y=1016580
X17 354 3600 3556 1 2 QDFFN $T=713620 1032080 1 180 $X=703080 $Y=1031700
X18 352 3600 3553 1 2 QDFFN $T=713620 1042160 0 180 $X=703080 $Y=1036740
X19 3570 3461 3608 1 2 QDFFN $T=703700 981680 0 0 $X=703700 $Y=981300
X20 389 3600 3576 1 2 QDFFN $T=714240 1032080 0 180 $X=703700 $Y=1026660
X21 3570 3531 3622 1 2 QDFFN $T=707420 981680 1 0 $X=707420 $Y=976260
X22 3570 384 3632 1 2 QDFFN $T=709280 1001840 0 0 $X=709280 $Y=1001460
X23 389 3466 3637 1 2 QDFFN $T=709280 1052240 1 0 $X=709280 $Y=1046820
X24 3512 3600 3591 1 2 QDFFN $T=720440 961520 1 180 $X=709900 $Y=961140
X25 3570 370 3633 1 2 QDFFN $T=711140 1011920 0 0 $X=711140 $Y=1011540
X26 389 3461 3606 1 2 QDFFN $T=723540 1052240 1 180 $X=713000 $Y=1051860
X27 3570 3466 3607 1 2 QDFFN $T=724780 991760 1 180 $X=714240 $Y=991380
X28 394 368 3654 1 2 QDFFN $T=715480 1022000 0 0 $X=715480 $Y=1021620
X29 394 370 3649 1 2 QDFFN $T=717340 1032080 1 0 $X=717340 $Y=1026660
X30 394 3461 3653 1 2 QDFFN $T=719200 981680 0 0 $X=719200 $Y=981300
X31 394 384 3638 1 2 QDFFN $T=730980 1011920 0 180 $X=720440 $Y=1006500
X32 394 3531 3669 1 2 QDFFN $T=721060 971600 1 0 $X=721060 $Y=966180
X33 394 3466 3640 1 2 QDFFN $T=731600 971600 1 180 $X=721060 $Y=971220
X34 389 384 402 1 2 QDFFN $T=721060 1062320 1 0 $X=721060 $Y=1056900
X35 3570 3600 3630 1 2 QDFFN $T=732220 961520 1 180 $X=721680 $Y=961140
X36 399 3600 3662 1 2 QDFFN $T=721680 1042160 1 0 $X=721680 $Y=1036740
X37 399 3461 3676 1 2 QDFFN $T=721680 1052240 1 0 $X=721680 $Y=1046820
X38 394 382 3648 1 2 QDFFN $T=735320 1001840 0 180 $X=724780 $Y=996420
X39 3512 3656 3684 1 2 QDFFN $T=725400 941360 0 0 $X=725400 $Y=940980
X40 389 3531 3634 1 2 QDFFN $T=735940 1032080 1 180 $X=725400 $Y=1031700
X41 3570 3656 3690 1 2 QDFFN $T=726020 951440 1 0 $X=726020 $Y=946020
X42 394 3656 3691 1 2 QDFFN $T=726020 951440 0 0 $X=726020 $Y=951060
X43 399 3466 3701 1 2 QDFFN $T=726640 1052240 0 0 $X=726640 $Y=1051860
X44 401 3461 3712 1 2 QDFFN $T=729740 991760 1 0 $X=729740 $Y=986340
X45 401 368 3705 1 2 QDFFN $T=730360 1032080 1 0 $X=730360 $Y=1026660
X46 401 3466 3715 1 2 QDFFN $T=731600 981680 0 0 $X=731600 $Y=981300
X47 394 3600 3668 1 2 QDFFN $T=744000 961520 1 180 $X=733460 $Y=961140
X48 3512 408 3726 1 2 QDFFN $T=735940 901040 1 0 $X=735940 $Y=895620
X49 401 384 3664 1 2 QDFFN $T=746480 1011920 0 180 $X=735940 $Y=1006500
X50 3512 410 3727 1 2 QDFFN $T=737180 890960 0 0 $X=737180 $Y=890580
X51 407 3466 3756 1 2 QDFFN $T=737180 1052240 1 0 $X=737180 $Y=1046820
X52 3512 412 3730 1 2 QDFFN $T=737800 911120 0 0 $X=737800 $Y=910740
X53 3512 413 3734 1 2 QDFFN $T=737800 921200 0 0 $X=737800 $Y=920820
X54 401 382 3671 1 2 QDFFN $T=748340 991760 1 180 $X=737800 $Y=991380
X55 409 382 3758 1 2 QDFFN $T=737800 1001840 0 0 $X=737800 $Y=1001460
X56 407 382 3760 1 2 QDFFN $T=737800 1052240 0 0 $X=737800 $Y=1051860
X57 399 3531 3685 1 2 QDFFN $T=748960 1032080 1 180 $X=738420 $Y=1031700
X58 407 3531 3750 1 2 QDFFN $T=738420 1042160 1 0 $X=738420 $Y=1036740
X59 399 384 3741 1 2 QDFFN $T=738420 1062320 1 0 $X=738420 $Y=1056900
X60 3512 416 3744 1 2 QDFFN $T=739040 921200 1 0 $X=739040 $Y=915780
X61 401 3656 3733 1 2 QDFFN $T=739040 961520 1 0 $X=739040 $Y=956100
X62 401 3531 3745 1 2 QDFFN $T=739040 981680 1 0 $X=739040 $Y=976260
X63 3512 419 3777 1 2 QDFFN $T=740280 931280 0 0 $X=740280 $Y=930900
X64 401 3600 3751 1 2 QDFFN $T=740280 971600 1 0 $X=740280 $Y=966180
X65 3512 420 3755 1 2 QDFFN $T=741520 941360 1 0 $X=741520 $Y=935940
X66 407 3461 3759 1 2 QDFFN $T=741520 1042160 0 0 $X=741520 $Y=1041780
X67 399 3656 3768 1 2 QDFFN $T=743380 941360 0 0 $X=743380 $Y=940980
X68 409 3656 3761 1 2 QDFFN $T=744000 951440 1 0 $X=744000 $Y=946020
X69 409 368 3747 1 2 QDFFN $T=744000 1022000 0 0 $X=744000 $Y=1021620
X70 352 3656 3775 1 2 QDFFN $T=746480 961520 0 0 $X=746480 $Y=961140
X71 3570 408 3780 1 2 QDFFN $T=748340 901040 1 0 $X=748340 $Y=895620
X72 443 370 3737 1 2 QDFFN $T=758880 1022000 0 180 $X=748340 $Y=1016580
X73 3570 410 3789 1 2 QDFFN $T=750200 890960 0 0 $X=750200 $Y=890580
X74 3570 412 3778 1 2 QDFFN $T=750820 911120 1 0 $X=750820 $Y=905700
X75 409 3466 3746 1 2 QDFFN $T=761360 991760 1 180 $X=750820 $Y=991380
X76 3570 416 3773 1 2 QDFFN $T=751440 921200 1 0 $X=751440 $Y=915780
X77 407 3600 3757 1 2 QDFFN $T=761980 1032080 1 180 $X=751440 $Y=1031700
X78 409 3531 3763 1 2 QDFFN $T=763220 981680 1 180 $X=752680 $Y=981300
X79 3570 419 3798 1 2 QDFFN $T=753300 941360 1 0 $X=753300 $Y=935940
X80 409 3600 3765 1 2 QDFFN $T=763840 971600 0 180 $X=753300 $Y=966180
X81 409 3461 3731 1 2 QDFFN $T=765080 991760 0 180 $X=754540 $Y=986340
X82 443 384 3762 1 2 QDFFN $T=765080 1011920 1 180 $X=754540 $Y=1011540
X83 3570 420 3793 1 2 QDFFN $T=755780 941360 0 0 $X=755780 $Y=940980
X84 3570 413 3791 1 2 QDFFN $T=756400 921200 0 0 $X=756400 $Y=920820
X85 443 382 3776 1 2 QDFFN $T=766940 1001840 1 180 $X=756400 $Y=1001460
X86 443 368 3782 1 2 QDFFN $T=768180 1022000 1 180 $X=757640 $Y=1021620
X87 407 3656 3799 1 2 QDFFN $T=758880 961520 0 0 $X=758880 $Y=961140
X88 439 3461 3815 1 2 QDFFN $T=759500 1042160 0 0 $X=759500 $Y=1041780
X89 439 3466 3813 1 2 QDFFN $T=760740 1052240 1 0 $X=760740 $Y=1046820
X90 443 3531 3820 1 2 QDFFN $T=761360 981680 1 0 $X=761360 $Y=976260
X91 439 384 3828 1 2 QDFFN $T=761980 1062320 1 0 $X=761980 $Y=1056900
X92 399 408 3826 1 2 QDFFN $T=762600 890960 0 0 $X=762600 $Y=890580
X93 399 412 3796 1 2 QDFFN $T=773760 911120 0 180 $X=763220 $Y=905700
X94 389 3656 3823 1 2 QDFFN $T=763220 951440 0 0 $X=763220 $Y=951060
X95 460 370 3797 1 2 QDFFN $T=773760 1022000 0 180 $X=763220 $Y=1016580
X96 443 3466 3819 1 2 QDFFN $T=763840 991760 0 0 $X=763840 $Y=991380
X97 399 416 3800 1 2 QDFFN $T=775000 921200 0 180 $X=764460 $Y=915780
X98 439 3531 3801 1 2 QDFFN $T=775000 1032080 1 180 $X=764460 $Y=1031700
X99 354 408 3830 1 2 QDFFN $T=765080 901040 1 0 $X=765080 $Y=895620
X100 439 3656 3829 1 2 QDFFN $T=765080 961520 1 0 $X=765080 $Y=956100
X101 443 3461 3814 1 2 QDFFN $T=765080 981680 0 0 $X=765080 $Y=981300
X102 399 419 3834 1 2 QDFFN $T=765700 941360 1 0 $X=765700 $Y=935940
X103 443 3656 3845 1 2 QDFFN $T=766320 951440 1 0 $X=766320 $Y=946020
X104 443 3600 3824 1 2 QDFFN $T=766320 971600 1 0 $X=766320 $Y=966180
X105 460 382 3807 1 2 QDFFN $T=777480 1001840 1 180 $X=766940 $Y=1001460
X106 460 384 3806 1 2 QDFFN $T=778100 1011920 1 180 $X=767560 $Y=1011540
X107 399 413 3810 1 2 QDFFN $T=779340 921200 1 180 $X=768800 $Y=920820
X108 439 410 3852 1 2 QDFFN $T=769420 880880 1 0 $X=769420 $Y=875460
X109 399 420 3816 1 2 QDFFN $T=779960 941360 1 180 $X=769420 $Y=940980
X110 456 3600 3848 1 2 QDFFN $T=770040 1042160 1 0 $X=770040 $Y=1036740
X111 354 3656 3854 1 2 QDFFN $T=771280 961520 0 0 $X=771280 $Y=961140
X112 460 368 3822 1 2 QDFFN $T=781820 1022000 1 180 $X=771280 $Y=1021620
X113 354 410 3861 1 2 QDFFN $T=775000 890960 0 0 $X=775000 $Y=890580
X114 354 412 3837 1 2 QDFFN $T=786160 911120 0 180 $X=775620 $Y=905700
X115 354 416 3839 1 2 QDFFN $T=787400 921200 0 180 $X=776860 $Y=915780
X116 352 419 3871 1 2 QDFFN $T=776860 931280 1 0 $X=776860 $Y=925860
X117 460 3461 3842 1 2 QDFFN $T=787400 991760 1 180 $X=776860 $Y=991380
X118 354 419 3872 1 2 QDFFN $T=778100 941360 1 0 $X=778100 $Y=935940
X119 460 3466 3844 1 2 QDFFN $T=788640 981680 1 180 $X=778100 $Y=981300
X120 456 3531 3865 1 2 QDFFN $T=778100 1032080 0 0 $X=778100 $Y=1031700
X121 456 3461 3873 1 2 QDFFN $T=778100 1042160 0 0 $X=778100 $Y=1041780
X122 460 3600 3855 1 2 QDFFN $T=790500 971600 0 180 $X=779960 $Y=966180
X123 464 384 3867 1 2 QDFFN $T=779960 1011920 0 0 $X=779960 $Y=1011540
X124 456 3466 3878 1 2 QDFFN $T=781200 1052240 0 0 $X=781200 $Y=1051860
X125 439 408 3879 1 2 QDFFN $T=781820 880880 1 0 $X=781820 $Y=875460
X126 439 419 3880 1 2 QDFFN $T=781820 880880 0 0 $X=781820 $Y=880500
X127 354 413 3876 1 2 QDFFN $T=781820 921200 0 0 $X=781820 $Y=920820
X128 354 420 3883 1 2 QDFFN $T=781820 941360 0 0 $X=781820 $Y=940980
X129 464 382 3864 1 2 QDFFN $T=794220 1001840 0 180 $X=783680 $Y=996420
X130 460 3656 3884 1 2 QDFFN $T=784300 961520 0 0 $X=784300 $Y=961140
X131 464 3466 3892 1 2 QDFFN $T=784300 991760 1 0 $X=784300 $Y=986340
X132 352 412 3890 1 2 QDFFN $T=784920 911120 0 0 $X=784920 $Y=910740
X133 464 370 3891 1 2 QDFFN $T=784920 1022000 0 0 $X=784920 $Y=1021620
X134 352 410 3868 1 2 QDFFN $T=796700 901040 0 180 $X=786160 $Y=895620
X135 456 3656 3903 1 2 QDFFN $T=786780 951440 1 0 $X=786780 $Y=946020
X136 460 3531 3862 1 2 QDFFN $T=797940 981680 0 180 $X=787400 $Y=976260
X137 439 420 3898 1 2 QDFFN $T=788020 890960 0 0 $X=788020 $Y=890580
X138 464 3531 3926 1 2 QDFFN $T=790500 981680 0 0 $X=790500 $Y=981300
X139 352 420 3899 1 2 QDFFN $T=791120 941360 1 0 $X=791120 $Y=935940
X140 461 3600 3917 1 2 QDFFN $T=792360 1032080 1 0 $X=792360 $Y=1026660
X141 461 3531 3918 1 2 QDFFN $T=792360 1042160 0 0 $X=792360 $Y=1041780
X142 464 3600 3922 1 2 QDFFN $T=792980 971600 1 0 $X=792980 $Y=966180
X143 352 408 3881 1 2 QDFFN $T=793600 911120 1 0 $X=793600 $Y=905700
X144 352 416 3924 1 2 QDFFN $T=793600 921200 1 0 $X=793600 $Y=915780
X145 464 368 3875 1 2 QDFFN $T=804140 1022000 0 180 $X=793600 $Y=1016580
X146 461 3461 3906 1 2 QDFFN $T=794220 1052240 0 0 $X=794220 $Y=1051860
X147 461 3656 3931 1 2 QDFFN $T=794840 941360 0 0 $X=794840 $Y=940980
X148 464 3656 3904 1 2 QDFFN $T=807240 961520 1 180 $X=796700 $Y=961140
X149 467 3461 3937 1 2 QDFFN $T=796700 1001840 0 0 $X=796700 $Y=1001460
X150 352 413 3905 1 2 QDFFN $T=797320 931280 1 0 $X=797320 $Y=925860
X151 467 3531 3934 1 2 QDFFN $T=797320 971600 0 0 $X=797320 $Y=971220
X152 461 384 486 1 2 QDFFN $T=797940 1062320 1 0 $X=797940 $Y=1056900
X153 461 408 476 1 2 QDFFN $T=809100 880880 0 180 $X=798560 $Y=875460
X154 461 410 478 1 2 QDFFN $T=810340 880880 1 180 $X=799800 $Y=880500
X155 467 3656 3952 1 2 QDFFN $T=801040 951440 0 0 $X=801040 $Y=951060
X156 483 488 3925 1 2 QDFFN $T=814060 941360 0 180 $X=803520 $Y=935940
X157 467 368 3938 1 2 QDFFN $T=806000 1022000 1 0 $X=806000 $Y=1016580
X158 461 3466 3914 1 2 QDFFN $T=806000 1042160 0 0 $X=806000 $Y=1041780
X159 461 420 479 1 2 QDFFN $T=817780 870800 1 180 $X=807240 $Y=870420
X160 467 3600 3963 1 2 QDFFN $T=807240 971600 1 0 $X=807240 $Y=966180
X161 483 492 3941 1 2 QDFFN $T=818400 941360 1 180 $X=807860 $Y=940980
X162 483 3966 3940 1 2 QDFFN $T=818400 971600 1 180 $X=807860 $Y=971220
X163 467 382 3971 1 2 QDFFN $T=809100 1001840 1 0 $X=809100 $Y=996420
X164 483 497 3950 1 2 QDFFN $T=820880 921200 1 180 $X=810340 $Y=920820
X165 461 382 500 1 2 QDFFN $T=810960 1062320 1 0 $X=810960 $Y=1056900
X166 3981 504 3961 1 2 QDFFN $T=823980 951440 0 180 $X=813440 $Y=946020
X167 483 494 3993 1 2 QDFFN $T=815300 951440 0 0 $X=815300 $Y=951060
X168 483 499 3957 1 2 QDFFN $T=826460 941360 0 180 $X=815920 $Y=935940
X169 487 499 3998 1 2 QDFFN $T=818400 931280 1 0 $X=818400 $Y=925860
X170 487 512 3975 1 2 QDFFN $T=830180 1052240 1 180 $X=819640 $Y=1051860
X171 3990 516 3977 1 2 QDFFN $T=832040 1011920 1 180 $X=821500 $Y=1011540
X172 506 516 3980 1 2 QDFFN $T=832660 1001840 1 180 $X=822120 $Y=1001460
X173 506 497 4016 1 2 QDFFN $T=822740 870800 0 0 $X=822740 $Y=870420
X174 483 518 3985 1 2 QDFFN $T=833900 961520 1 180 $X=823360 $Y=961140
X175 506 488 4026 1 2 QDFFN $T=823980 890960 1 0 $X=823980 $Y=885540
X176 487 497 4019 1 2 QDFFN $T=823980 921200 0 0 $X=823980 $Y=920820
X177 487 504 4030 1 2 QDFFN $T=825840 951440 1 0 $X=825840 $Y=946020
X178 3990 4022 3995 1 2 QDFFN $T=837000 1022000 0 180 $X=826460 $Y=1016580
X179 506 513 4032 1 2 QDFFN $T=826460 1032080 1 0 $X=826460 $Y=1026660
X180 487 4024 4000 1 2 QDFFN $T=837620 1042160 0 180 $X=827080 $Y=1036740
X181 487 488 4007 1 2 QDFFN $T=839480 941360 0 180 $X=828940 $Y=935940
X182 487 492 4041 1 2 QDFFN $T=830800 941360 0 0 $X=830800 $Y=940980
X183 3990 499 4050 1 2 QDFFN $T=832040 911120 0 0 $X=832040 $Y=910740
X184 487 494 4046 1 2 QDFFN $T=832660 951440 0 0 $X=832660 $Y=951060
X185 506 504 520 1 2 QDFFN $T=843820 870800 1 180 $X=833280 $Y=870420
X186 506 3966 4052 1 2 QDFFN $T=833280 981680 0 0 $X=833280 $Y=981300
X187 506 4022 4017 1 2 QDFFN $T=843820 1011920 0 180 $X=833280 $Y=1006500
X188 487 4022 4014 1 2 QDFFN $T=843820 1062320 0 180 $X=833280 $Y=1056900
X189 487 4053 4018 1 2 QDFFN $T=845060 1052240 0 180 $X=834520 $Y=1046820
X190 3990 488 4057 1 2 QDFFN $T=835760 911120 1 0 $X=835760 $Y=905700
X191 511 488 4066 1 2 QDFFN $T=836380 890960 1 0 $X=836380 $Y=885540
X192 506 4053 4049 1 2 QDFFN $T=851260 1001840 0 180 $X=840720 $Y=996420
X193 3990 4024 4079 1 2 QDFFN $T=840720 1032080 1 0 $X=840720 $Y=1026660
X194 472 488 4080 1 2 QDFFN $T=841960 921200 0 0 $X=841960 $Y=920820
X195 3990 4053 4082 1 2 QDFFN $T=841960 1022000 1 0 $X=841960 $Y=1016580
X196 483 4024 4108 1 2 QDFFN $T=846300 1052240 1 0 $X=846300 $Y=1046820
X197 483 516 4109 1 2 QDFFN $T=846300 1062320 1 0 $X=846300 $Y=1056900
X198 506 499 4056 1 2 QDFFN $T=857460 890960 0 180 $X=846920 $Y=885540
X199 472 492 4070 1 2 QDFFN $T=857460 951440 1 180 $X=846920 $Y=951060
X200 506 4024 4072 1 2 QDFFN $T=857460 1011920 1 180 $X=846920 $Y=1011540
X201 506 518 4099 1 2 QDFFN $T=847540 880880 1 0 $X=847540 $Y=875460
X202 3990 504 4096 1 2 QDFFN $T=847540 911120 1 0 $X=847540 $Y=905700
X203 483 4022 4100 1 2 QDFFN $T=847540 1052240 0 0 $X=847540 $Y=1051860
X204 472 494 4110 1 2 QDFFN $T=848160 961520 0 0 $X=848160 $Y=961140
X205 472 504 4074 1 2 QDFFN $T=859320 941360 1 180 $X=848780 $Y=940980
X206 511 3966 4112 1 2 QDFFN $T=848780 981680 1 0 $X=848780 $Y=976260
X207 483 4053 4104 1 2 QDFFN $T=848780 1042160 0 0 $X=848780 $Y=1041780
X208 472 499 4085 1 2 QDFFN $T=862420 941360 0 180 $X=851880 $Y=935940
X209 511 535 4091 1 2 QDFFN $T=863040 1022000 0 180 $X=852500 $Y=1016580
X210 472 497 4092 1 2 QDFFN $T=863660 921200 0 180 $X=853120 $Y=915780
X211 511 523 4131 1 2 QDFFN $T=853740 1001840 0 0 $X=853740 $Y=1001460
X212 511 516 4138 1 2 QDFFN $T=854980 991760 1 0 $X=854980 $Y=986340
X213 4111 499 4141 1 2 QDFFN $T=858700 911120 0 0 $X=858700 $Y=910740
X214 506 535 4095 1 2 QDFFN $T=858700 1032080 1 0 $X=858700 $Y=1026660
X215 3990 523 4144 1 2 QDFFN $T=858700 1032080 0 0 $X=858700 $Y=1031700
X216 534 497 4155 1 2 QDFFN $T=859320 931280 1 0 $X=859320 $Y=925860
X217 534 494 4129 1 2 QDFFN $T=859320 961520 0 0 $X=859320 $Y=961140
X218 472 3966 4116 1 2 QDFFN $T=869860 981680 0 180 $X=859320 $Y=976260
X219 472 512 545 1 2 QDFFN $T=859320 1062320 1 0 $X=859320 $Y=1056900
X220 534 504 4157 1 2 QDFFN $T=861180 951440 0 0 $X=861180 $Y=951060
X221 4111 494 4160 1 2 QDFFN $T=861800 880880 0 0 $X=861800 $Y=880500
X222 4111 504 4167 1 2 QDFFN $T=863040 901040 1 0 $X=863040 $Y=895620
X223 4111 492 4172 1 2 QDFFN $T=863660 911120 1 0 $X=863660 $Y=905700
X224 534 499 4173 1 2 QDFFN $T=864280 941360 1 0 $X=864280 $Y=935940
X225 511 512 4119 1 2 QDFFN $T=874820 1001840 1 180 $X=864280 $Y=1001460
X226 472 4022 4169 1 2 QDFFN $T=864900 1052240 0 0 $X=864900 $Y=1051860
X227 4124 494 4170 1 2 QDFFN $T=865520 961520 1 0 $X=865520 $Y=956100
X228 542 494 4187 1 2 QDFFN $T=866140 880880 1 0 $X=866140 $Y=875460
X229 534 3966 4183 1 2 QDFFN $T=868000 981680 0 0 $X=868000 $Y=981300
X230 534 488 4188 1 2 QDFFN $T=868620 921200 0 0 $X=868620 $Y=920820
X231 511 4024 4181 1 2 QDFFN $T=868620 991760 0 0 $X=868620 $Y=991380
X232 3990 535 4209 1 2 QDFFN $T=871720 1042160 1 0 $X=871720 $Y=1036740
X233 472 516 4192 1 2 QDFFN $T=871720 1062320 1 0 $X=871720 $Y=1056900
X234 472 4024 4224 1 2 QDFFN $T=873580 1042160 0 0 $X=873580 $Y=1041780
X235 4118 494 4213 1 2 QDFFN $T=874200 880880 0 0 $X=874200 $Y=880500
X236 4124 504 4175 1 2 QDFFN $T=874200 941360 0 0 $X=874200 $Y=940980
X237 472 4053 4207 1 2 QDFFN $T=874200 1052240 1 0 $X=874200 $Y=1046820
X238 4124 4022 4210 1 2 QDFFN $T=875440 991760 1 0 $X=875440 $Y=986340
X239 4124 523 4178 1 2 QDFFN $T=885980 1011920 0 180 $X=875440 $Y=1006500
X240 4176 518 4220 1 2 QDFFN $T=876060 890960 0 0 $X=876060 $Y=890580
X241 4111 497 4162 1 2 QDFFN $T=886600 911120 0 180 $X=876060 $Y=905700
X242 4124 492 4185 1 2 QDFFN $T=877300 951440 0 0 $X=877300 $Y=951060
X243 4118 518 4217 1 2 QDFFN $T=878540 890960 1 0 $X=878540 $Y=885540
X244 3990 513 4179 1 2 QDFFN $T=889080 1032080 0 180 $X=878540 $Y=1026660
X245 548 494 551 1 2 QDFFN $T=879160 880880 1 0 $X=879160 $Y=875460
X246 4124 497 4199 1 2 QDFFN $T=890940 911120 1 180 $X=880400 $Y=910740
X247 4191 488 4226 1 2 QDFFN $T=881640 921200 0 0 $X=881640 $Y=920820
X248 4124 3966 4186 1 2 QDFFN $T=892800 981680 1 180 $X=882260 $Y=981300
X249 4111 513 4234 1 2 QDFFN $T=882260 1022000 1 0 $X=882260 $Y=1016580
X250 4124 499 4205 1 2 QDFFN $T=882880 941360 1 0 $X=882880 $Y=935940
X251 4191 504 4206 1 2 QDFFN $T=895280 941360 1 180 $X=884740 $Y=940980
X252 4124 535 4244 1 2 QDFFN $T=884740 1032080 0 0 $X=884740 $Y=1031700
X253 534 4022 4242 1 2 QDFFN $T=884740 1062320 1 0 $X=884740 $Y=1056900
X254 4191 497 4238 1 2 QDFFN $T=885980 921200 1 0 $X=885980 $Y=915780
X255 4124 516 4215 1 2 QDFFN $T=896520 991760 0 180 $X=885980 $Y=986340
X256 4124 4053 4227 1 2 QDFFN $T=885980 1011920 1 0 $X=885980 $Y=1006500
X257 534 4053 4212 1 2 QDFFN $T=896520 1042160 0 180 $X=885980 $Y=1036740
X258 4191 492 4203 1 2 QDFFN $T=898380 951440 1 180 $X=887840 $Y=951060
X259 4176 504 4260 1 2 QDFFN $T=889080 890960 0 0 $X=889080 $Y=890580
X260 4111 4022 4276 1 2 QDFFN $T=889700 1001840 1 0 $X=889700 $Y=996420
X261 4124 4024 4229 1 2 QDFFN $T=900240 1011920 1 180 $X=889700 $Y=1011540
X262 4124 513 4184 1 2 QDFFN $T=900240 1022000 1 180 $X=889700 $Y=1021620
X263 3990 512 4222 1 2 QDFFN $T=889700 1042160 0 0 $X=889700 $Y=1041780
X264 4118 492 4270 1 2 QDFFN $T=890940 890960 1 0 $X=890940 $Y=885540
X265 4191 518 4247 1 2 QDFFN $T=891560 961520 0 0 $X=891560 $Y=961140
X266 4118 504 4259 1 2 QDFFN $T=892180 870800 0 0 $X=892180 $Y=870420
X267 4176 492 4275 1 2 QDFFN $T=892180 901040 0 0 $X=892180 $Y=900660
X268 4232 497 4264 1 2 QDFFN $T=893420 911120 0 0 $X=893420 $Y=910740
X269 4191 499 4233 1 2 QDFFN $T=903960 941360 0 180 $X=893420 $Y=935940
X270 4216 497 4266 1 2 QDFFN $T=894660 921200 0 0 $X=894660 $Y=920820
X271 534 4024 4219 1 2 QDFFN $T=905200 1052240 0 180 $X=894660 $Y=1046820
X272 4216 492 4287 1 2 QDFFN $T=895900 941360 0 0 $X=895900 $Y=940980
X273 4216 518 4303 1 2 QDFFN $T=896520 971600 1 0 $X=896520 $Y=966180
X274 4176 3966 4289 1 2 QDFFN $T=896520 991760 1 0 $X=896520 $Y=986340
X275 4176 4024 4283 1 2 QDFFN $T=896520 1042160 1 0 $X=896520 $Y=1036740
X276 4111 512 4300 1 2 QDFFN $T=897760 1032080 0 0 $X=897760 $Y=1031700
X277 534 516 4245 1 2 QDFFN $T=908300 1062320 0 180 $X=897760 $Y=1056900
X278 4232 492 4304 1 2 QDFFN $T=900240 951440 1 0 $X=900240 $Y=946020
X279 4176 516 4312 1 2 QDFFN $T=900240 1052240 0 0 $X=900240 $Y=1051860
X280 4118 497 4263 1 2 QDFFN $T=912020 890960 1 180 $X=901480 $Y=890580
X281 4232 518 4282 1 2 QDFFN $T=901480 971600 0 0 $X=901480 $Y=971220
X282 4111 535 4281 1 2 QDFFN $T=913880 1022000 1 180 $X=903340 $Y=1021620
X283 542 499 4279 1 2 QDFFN $T=914500 880880 1 180 $X=903960 $Y=880500
X284 4111 4053 4316 1 2 QDFFN $T=903960 1011920 0 0 $X=903960 $Y=1011540
X285 4176 497 4286 1 2 QDFFN $T=915120 901040 0 180 $X=904580 $Y=895620
X286 4111 523 4278 1 2 QDFFN $T=915740 1022000 0 180 $X=905200 $Y=1016580
X287 4176 488 4296 1 2 QDFFN $T=916980 911120 1 180 $X=906440 $Y=910740
X288 4216 488 4256 1 2 QDFFN $T=916980 931280 0 180 $X=906440 $Y=925860
X289 4232 494 4268 1 2 QDFFN $T=916980 951440 1 180 $X=906440 $Y=951060
X290 4176 4053 4291 1 2 QDFFN $T=917600 1042160 0 180 $X=907060 $Y=1036740
X291 4232 488 4284 1 2 QDFFN $T=918220 921200 0 180 $X=907680 $Y=915780
X292 4232 499 4271 1 2 QDFFN $T=918220 921200 1 180 $X=907680 $Y=920820
X293 4111 516 4280 1 2 QDFFN $T=918840 981680 1 180 $X=908300 $Y=981300
X294 4216 499 4261 1 2 QDFFN $T=919460 941360 0 180 $X=908920 $Y=935940
X295 4216 494 4290 1 2 QDFFN $T=920080 961520 1 180 $X=909540 $Y=961140
X296 542 3966 4305 1 2 QDFFN $T=920080 971600 0 180 $X=909540 $Y=966180
X297 4191 535 4337 1 2 QDFFN $T=909540 1032080 1 0 $X=909540 $Y=1026660
X298 4191 4022 4332 1 2 QDFFN $T=910160 991760 0 0 $X=910160 $Y=991380
X299 548 4053 4329 1 2 QDFFN $T=910780 1032080 0 0 $X=910780 $Y=1031700
X300 4176 4022 4307 1 2 QDFFN $T=921320 1062320 0 180 $X=910780 $Y=1056900
X301 4118 499 4292 1 2 QDFFN $T=921940 890960 0 180 $X=911400 $Y=885540
X302 4176 499 4298 1 2 QDFFN $T=923180 911120 0 180 $X=912640 $Y=905700
X303 542 488 4306 1 2 QDFFN $T=923800 870800 1 180 $X=913260 $Y=870420
X304 4118 488 4309 1 2 QDFFN $T=924420 890960 1 180 $X=913880 $Y=890580
X305 4216 504 4302 1 2 QDFFN $T=924420 941360 1 180 $X=913880 $Y=940980
X306 548 4022 4338 1 2 QDFFN $T=913880 1052240 0 0 $X=913880 $Y=1051860
X307 4232 504 4313 1 2 QDFFN $T=926900 951440 0 180 $X=916360 $Y=946020
X308 4191 513 4336 1 2 QDFFN $T=916360 1022000 0 0 $X=916360 $Y=1021620
X309 562 565 4358 1 2 QDFFN $T=916980 880880 0 0 $X=916980 $Y=880500
X310 4191 4053 4346 1 2 QDFFN $T=916980 1001840 0 0 $X=916980 $Y=1001460
X311 563 565 4363 1 2 QDFFN $T=918220 901040 1 0 $X=918220 $Y=895620
X312 567 565 4359 1 2 QDFFN $T=919460 911120 0 0 $X=919460 $Y=910740
X313 561 571 4355 1 2 QDFFN $T=919460 961520 1 0 $X=919460 $Y=956100
X314 567 571 4357 1 2 QDFFN $T=920080 921200 1 0 $X=920080 $Y=915780
X315 568 571 4364 1 2 QDFFN $T=920700 921200 0 0 $X=920700 $Y=920820
X316 4232 3966 4339 1 2 QDFFN $T=931860 961520 1 180 $X=921320 $Y=961140
X317 580 3966 4325 1 2 QDFFN $T=933100 991760 0 180 $X=922560 $Y=986340
X318 4191 523 4340 1 2 QDFFN $T=933720 1011920 0 180 $X=923180 $Y=1006500
X319 562 571 4367 1 2 QDFFN $T=923800 890960 1 0 $X=923800 $Y=885540
X320 4216 3966 4334 1 2 QDFFN $T=934340 971600 1 180 $X=923800 $Y=971220
X321 4191 512 4341 1 2 QDFFN $T=934340 1032080 1 180 $X=923800 $Y=1031700
X322 542 516 4345 1 2 QDFFN $T=934340 1062320 0 180 $X=923800 $Y=1056900
X323 563 571 4371 1 2 QDFFN $T=925040 911120 1 0 $X=925040 $Y=905700
X324 570 571 4383 1 2 QDFFN $T=925040 941360 0 0 $X=925040 $Y=940980
X325 4191 4024 4333 1 2 QDFFN $T=935580 1001840 0 180 $X=925040 $Y=996420
X326 4118 3966 4343 1 2 QDFFN $T=936200 981680 1 180 $X=925660 $Y=981300
X327 548 4024 4331 1 2 QDFFN $T=936200 1042160 0 180 $X=925660 $Y=1036740
X328 562 575 4389 1 2 QDFFN $T=926900 890960 0 0 $X=926900 $Y=890580
X329 561 575 4390 1 2 QDFFN $T=926900 971600 1 0 $X=926900 $Y=966180
X330 542 4022 4347 1 2 QDFFN $T=937440 1052240 1 180 $X=926900 $Y=1051860
X331 4118 4022 4384 1 2 QDFFN $T=927520 1022000 1 0 $X=927520 $Y=1016580
X332 561 565 4356 1 2 QDFFN $T=939920 951440 0 180 $X=929380 $Y=946020
X333 4191 516 4344 1 2 QDFFN $T=939920 991760 1 180 $X=929380 $Y=991380
X334 4232 516 4418 1 2 QDFFN $T=930000 1022000 0 0 $X=930000 $Y=1021620
X335 4216 4022 4410 1 2 QDFFN $T=931240 1001840 0 0 $X=931240 $Y=1001460
X336 542 4053 4406 1 2 QDFFN $T=931240 1052240 1 0 $X=931240 $Y=1046820
X337 567 575 4408 1 2 QDFFN $T=932480 921200 1 0 $X=932480 $Y=915780
X338 591 575 4370 1 2 QDFFN $T=944260 880880 0 180 $X=933720 $Y=875460
X339 4216 516 4397 1 2 QDFFN $T=935580 991760 1 0 $X=935580 $Y=986340
X340 582 578 4427 1 2 QDFFN $T=936200 971600 0 0 $X=936200 $Y=971220
X341 4118 516 4407 1 2 QDFFN $T=936200 1011920 0 0 $X=936200 $Y=1011540
X342 4232 4022 4428 1 2 QDFFN $T=936200 1032080 0 0 $X=936200 $Y=1031700
X343 580 516 4412 1 2 QDFFN $T=936820 1062320 1 0 $X=936820 $Y=1056900
X344 563 578 4422 1 2 QDFFN $T=937440 911120 1 0 $X=937440 $Y=905700
X345 562 578 4375 1 2 QDFFN $T=948600 880880 1 180 $X=938060 $Y=880500
X346 561 578 4393 1 2 QDFFN $T=948600 961520 1 180 $X=938060 $Y=961140
X347 542 4024 4424 1 2 QDFFN $T=939300 1042160 1 0 $X=939300 $Y=1036740
X348 563 575 4403 1 2 QDFFN $T=950460 890960 1 180 $X=939920 $Y=890580
X349 582 565 4369 1 2 QDFFN $T=950460 951440 1 180 $X=939920 $Y=951060
X350 568 592 4439 1 2 QDFFN $T=940540 931280 0 0 $X=940540 $Y=930900
X351 591 592 4447 1 2 QDFFN $T=941780 870800 0 0 $X=941780 $Y=870420
X352 570 592 4451 1 2 QDFFN $T=942400 941360 1 0 $X=942400 $Y=935940
X353 4216 4024 4434 1 2 QDFFN $T=942400 991760 0 0 $X=942400 $Y=991380
X354 562 593 4464 1 2 QDFFN $T=943020 890960 1 0 $X=943020 $Y=885540
X355 563 593 4455 1 2 QDFFN $T=943640 901040 0 0 $X=943640 $Y=900660
X356 568 575 4411 1 2 QDFFN $T=954800 931280 0 180 $X=944260 $Y=925860
X357 4232 4024 4443 1 2 QDFFN $T=944260 1022000 0 0 $X=944260 $Y=1021620
X358 567 578 4417 1 2 QDFFN $T=955420 911120 1 180 $X=944880 $Y=910740
X359 567 593 4472 1 2 QDFFN $T=945500 921200 1 0 $X=945500 $Y=915780
X360 591 594 4468 1 2 QDFFN $T=946740 880880 1 0 $X=946740 $Y=875460
X361 580 4022 4425 1 2 QDFFN $T=946740 1052240 0 0 $X=946740 $Y=1051860
X362 582 571 4377 1 2 QDFFN $T=959140 961520 1 180 $X=948600 $Y=961140
X363 582 593 4481 1 2 QDFFN $T=949220 991760 1 0 $X=949220 $Y=986340
X364 591 596 4475 1 2 QDFFN $T=950460 880880 0 0 $X=950460 $Y=880500
X365 563 592 4470 1 2 QDFFN $T=950460 911120 1 0 $X=950460 $Y=905700
X366 568 593 4449 1 2 QDFFN $T=961620 931280 1 180 $X=951080 $Y=930900
X367 4216 4053 4438 1 2 QDFFN $T=962240 1001840 0 180 $X=951700 $Y=996420
X368 570 593 4452 1 2 QDFFN $T=962860 951440 1 180 $X=952320 $Y=951060
X369 562 592 4476 1 2 QDFFN $T=952940 890960 0 0 $X=952940 $Y=890580
X370 580 4024 4454 1 2 QDFFN $T=953560 1042160 1 0 $X=953560 $Y=1036740
X371 548 513 4502 1 2 QDFFN $T=954180 1062320 1 0 $X=954180 $Y=1056900
X372 567 592 4482 1 2 QDFFN $T=954800 931280 1 0 $X=954800 $Y=925860
X373 4118 4053 4463 1 2 QDFFN $T=965960 1011920 1 180 $X=955420 $Y=1011540
X374 4232 523 4499 1 2 QDFFN $T=955420 1032080 0 0 $X=955420 $Y=1031700
X375 601 571 4496 1 2 QDFFN $T=956040 901040 1 0 $X=956040 $Y=895620
X376 4118 513 4507 1 2 QDFFN $T=956660 1022000 1 0 $X=956660 $Y=1016580
X377 4232 4053 4459 1 2 QDFFN $T=967200 1022000 1 180 $X=956660 $Y=1021620
X378 580 4053 4501 1 2 QDFFN $T=957280 1052240 1 0 $X=957280 $Y=1046820
X379 604 594 4503 1 2 QDFFN $T=960380 880880 1 0 $X=960380 $Y=875460
X380 4176 513 4517 1 2 QDFFN $T=961000 1052240 0 0 $X=961000 $Y=1051860
X381 604 596 4505 1 2 QDFFN $T=962240 880880 0 0 $X=962240 $Y=880500
X382 567 594 4515 1 2 QDFFN $T=962240 921200 1 0 $X=962240 $Y=915780
X383 563 594 4523 1 2 QDFFN $T=962860 911120 1 0 $X=962860 $Y=905700
X384 562 596 4528 1 2 QDFFN $T=963480 890960 1 0 $X=963480 $Y=885540
X385 561 596 4536 1 2 QDFFN $T=964720 951440 0 0 $X=964720 $Y=951060
X386 582 596 4537 1 2 QDFFN $T=965340 981680 0 0 $X=965340 $Y=981300
X387 562 594 4534 1 2 QDFFN $T=965960 890960 0 0 $X=965960 $Y=890580
X388 4232 513 4511 1 2 QDFFN $T=967200 1042160 1 0 $X=967200 $Y=1036740
X389 607 571 4544 1 2 QDFFN $T=967820 921200 0 0 $X=967820 $Y=920820
X390 605 596 4513 1 2 QDFFN $T=979600 971600 1 180 $X=969060 $Y=971220
X391 4216 523 4512 1 2 QDFFN $T=980220 1011920 0 180 $X=969680 $Y=1006500
X392 4118 523 4520 1 2 QDFFN $T=980840 1022000 1 180 $X=970300 $Y=1021620
X393 601 565 4555 1 2 QDFFN $T=974020 911120 1 0 $X=974020 $Y=905700
X394 610 596 4567 1 2 QDFFN $T=974640 870800 0 0 $X=974640 $Y=870420
X395 4176 523 4563 1 2 QDFFN $T=975260 1052240 0 0 $X=975260 $Y=1051860
X396 4118 535 4568 1 2 QDFFN $T=975880 1022000 1 0 $X=975880 $Y=1016580
X397 605 565 4570 1 2 QDFFN $T=976500 951440 0 0 $X=976500 $Y=951060
X398 607 596 4600 1 2 QDFFN $T=978980 921200 0 0 $X=978980 $Y=920820
X399 610 594 4580 1 2 QDFFN $T=979600 880880 1 0 $X=979600 $Y=875460
X400 605 593 4577 1 2 QDFFN $T=979600 971600 0 0 $X=979600 $Y=971220
X401 4216 535 4578 1 2 QDFFN $T=979600 1011920 0 0 $X=979600 $Y=1011540
X402 605 578 4583 1 2 QDFFN $T=980220 981680 0 0 $X=980220 $Y=981300
X403 4232 512 4540 1 2 QDFFN $T=991380 1042160 0 180 $X=980840 $Y=1036740
X404 605 592 4584 1 2 QDFFN $T=981460 991760 0 0 $X=981460 $Y=991380
X405 548 535 4542 1 2 QDFFN $T=983940 1062320 1 0 $X=983940 $Y=1056900
X406 4118 512 4594 1 2 QDFFN $T=985800 1022000 0 0 $X=985800 $Y=1021620
X407 4232 535 4533 1 2 QDFFN $T=986420 1032080 0 0 $X=986420 $Y=1031700
X408 4176 535 4557 1 2 QDFFN $T=987040 1042160 0 0 $X=987040 $Y=1041780
X409 607 575 4603 1 2 QDFFN $T=988280 931280 0 0 $X=988280 $Y=930900
X410 619 571 4640 1 2 QDFFN $T=988280 951440 0 0 $X=988280 $Y=951060
X411 4176 512 4617 1 2 QDFFN $T=989520 1052240 0 0 $X=989520 $Y=1051860
X412 624 575 630 1 2 QDFFN $T=990760 870800 0 0 $X=990760 $Y=870420
X413 601 578 4628 1 2 QDFFN $T=990760 901040 0 0 $X=990760 $Y=900660
X414 619 593 4626 1 2 QDFFN $T=991380 981680 1 0 $X=991380 $Y=976260
X415 626 4614 4590 1 2 QDFFN $T=1001920 1001840 0 180 $X=991380 $Y=996420
X416 613 578 4631 1 2 QDFFN $T=994480 880880 0 0 $X=994480 $Y=880500
X417 619 565 4597 1 2 QDFFN $T=1005020 941360 1 180 $X=994480 $Y=940980
X418 627 4632 4601 1 2 QDFFN $T=1005640 1022000 0 180 $X=995100 $Y=1016580
X419 613 575 4623 1 2 QDFFN $T=997580 880880 1 0 $X=997580 $Y=875460
X420 626 4639 4606 1 2 QDFFN $T=1008120 1001840 1 180 $X=997580 $Y=1001460
X421 627 4634 4609 1 2 QDFFN $T=1008120 1011920 0 180 $X=997580 $Y=1006500
X422 626 4634 4607 1 2 QDFFN $T=1008120 1042160 0 180 $X=997580 $Y=1036740
X423 619 578 4619 1 2 QDFFN $T=1000060 971600 0 0 $X=1000060 $Y=971220
X424 627 4639 4621 1 2 QDFFN $T=1010600 981680 1 180 $X=1000060 $Y=981300
X425 626 4632 4615 1 2 QDFFN $T=1010600 1042160 1 180 $X=1000060 $Y=1041780
X426 607 594 4608 1 2 QDFFN $T=1011840 911120 1 180 $X=1001300 $Y=910740
X427 607 578 4613 1 2 QDFFN $T=1001300 921200 0 0 $X=1001300 $Y=920820
X428 632 594 4663 1 2 QDFFN $T=1003160 870800 0 0 $X=1003160 $Y=870420
X429 634 4634 4670 1 2 QDFFN $T=1003160 1022000 0 0 $X=1003160 $Y=1021620
X430 601 594 4664 1 2 QDFFN $T=1004400 901040 1 0 $X=1004400 $Y=895620
X431 613 594 4635 1 2 QDFFN $T=1015560 880880 1 180 $X=1005020 $Y=880500
X432 613 596 4646 1 2 QDFFN $T=1005640 890960 0 0 $X=1005640 $Y=890580
X433 627 4668 4649 1 2 QDFFN $T=1018660 1022000 0 180 $X=1008120 $Y=1016580
X434 634 4614 4676 1 2 QDFFN $T=1009360 1001840 1 0 $X=1009360 $Y=996420
X435 634 4632 4675 1 2 QDFFN $T=1011220 1032080 1 0 $X=1011220 $Y=1026660
X436 611 4614 4678 1 2 QDFFN $T=1013700 951440 0 0 $X=1013700 $Y=951060
X437 611 4634 4648 1 2 QDFFN $T=1024240 961520 0 180 $X=1013700 $Y=956100
X438 619 594 4683 1 2 QDFFN $T=1013700 971600 1 0 $X=1013700 $Y=966180
X439 626 638 4684 1 2 QDFFN $T=1013700 1001840 0 0 $X=1013700 $Y=1001460
X440 626 4668 4665 1 2 QDFFN $T=1024860 1042160 1 180 $X=1014320 $Y=1041780
X441 634 638 4692 1 2 QDFFN $T=1014940 1011920 0 0 $X=1014940 $Y=1011540
X442 613 593 4696 1 2 QDFFN $T=1015560 880880 0 0 $X=1015560 $Y=880500
X443 607 593 4673 1 2 QDFFN $T=1016800 931280 0 0 $X=1016800 $Y=930900
X444 634 4639 4671 1 2 QDFFN $T=1027340 991760 0 180 $X=1016800 $Y=986340
X445 613 592 4702 1 2 QDFFN $T=1018660 880880 1 0 $X=1018660 $Y=875460
X446 626 4707 4672 1 2 QDFFN $T=1032920 1042160 0 180 $X=1022380 $Y=1036740
X447 611 4632 4687 1 2 QDFFN $T=1034780 971600 0 180 $X=1024240 $Y=966180
X448 641 4614 4708 1 2 QDFFN $T=1024240 991760 0 0 $X=1024240 $Y=991380
X449 634 4668 4693 1 2 QDFFN $T=1035400 1032080 0 180 $X=1024860 $Y=1026660
X450 611 638 4705 1 2 QDFFN $T=1025480 951440 1 0 $X=1025480 $Y=946020
X451 644 4639 4714 1 2 QDFFN $T=1026100 931280 1 0 $X=1026100 $Y=925860
X452 650 4632 4704 1 2 QDFFN $T=1037880 901040 1 180 $X=1027340 $Y=900660
X453 626 647 4699 1 2 QDFFN $T=1037880 1011920 1 180 $X=1027340 $Y=1011540
X454 627 4707 4690 1 2 QDFFN $T=1038500 1022000 0 180 $X=1027960 $Y=1016580
X455 641 4707 4716 1 2 QDFFN $T=1027960 1042160 0 0 $X=1027960 $Y=1041780
X456 644 647 4732 1 2 QDFFN $T=1030440 911120 1 0 $X=1030440 $Y=905700
X457 646 4614 4722 1 2 QDFFN $T=1031060 890960 0 0 $X=1031060 $Y=890580
X458 634 647 4703 1 2 QDFFN $T=1041600 1001840 1 180 $X=1031060 $Y=1001460
X459 611 4639 4681 1 2 QDFFN $T=1042220 941360 0 180 $X=1031680 $Y=935940
X460 634 4707 4706 1 2 QDFFN $T=1042220 1022000 1 180 $X=1031680 $Y=1021620
X461 646 4639 4727 1 2 QDFFN $T=1033540 880880 1 0 $X=1033540 $Y=875460
X462 646 4632 4744 1 2 QDFFN $T=1034780 911120 0 0 $X=1034780 $Y=910740
X463 644 4614 4710 1 2 QDFFN $T=1045320 931280 1 180 $X=1034780 $Y=930900
X464 627 638 4712 1 2 QDFFN $T=1045940 991760 0 180 $X=1035400 $Y=986340
X465 611 647 4697 1 2 QDFFN $T=1046560 951440 0 180 $X=1036020 $Y=946020
X466 641 647 4749 1 2 QDFFN $T=1037260 1001840 1 0 $X=1037260 $Y=996420
X467 641 4639 4717 1 2 QDFFN $T=1049040 991760 1 180 $X=1038500 $Y=991380
X468 650 4634 4728 1 2 QDFFN $T=1050280 901040 1 180 $X=1039740 $Y=900660
X469 612 4634 4763 1 2 QDFFN $T=1040360 1011920 0 0 $X=1040360 $Y=1011540
X470 641 4634 4730 1 2 QDFFN $T=1051520 1022000 0 180 $X=1040980 $Y=1016580
X471 627 647 4715 1 2 QDFFN $T=1052140 981680 0 180 $X=1041600 $Y=976260
X472 641 4668 4723 1 2 QDFFN $T=1052760 1042160 1 180 $X=1042220 $Y=1041780
X473 650 4668 4758 1 2 QDFFN $T=1043460 911120 1 0 $X=1043460 $Y=905700
X474 641 638 4751 1 2 QDFFN $T=1043460 1001840 0 0 $X=1043460 $Y=1001460
X475 650 4639 4738 1 2 QDFFN $T=1055860 880880 0 180 $X=1045320 $Y=875460
X476 641 4632 4740 1 2 QDFFN $T=1055860 1032080 1 180 $X=1045320 $Y=1031700
X477 612 638 4767 1 2 QDFFN $T=1045940 981680 0 0 $X=1045940 $Y=981300
X478 653 4634 4779 1 2 QDFFN $T=1045940 1022000 0 0 $X=1045940 $Y=1021620
X479 646 4668 4778 1 2 QDFFN $T=1048420 911120 0 0 $X=1048420 $Y=910740
X480 646 4707 4771 1 2 QDFFN $T=1048420 921200 0 0 $X=1048420 $Y=920820
X481 612 647 4764 1 2 QDFFN $T=1049040 991760 1 0 $X=1049040 $Y=986340
X482 646 4634 4736 1 2 QDFFN $T=1062060 931280 0 180 $X=1051520 $Y=925860
X483 657 4639 4781 1 2 QDFFN $T=1052140 870800 0 0 $X=1052140 $Y=870420
X484 650 4707 4757 1 2 QDFFN $T=1062680 901040 1 180 $X=1052140 $Y=900660
X485 657 4634 4782 1 2 QDFFN $T=1054000 890960 0 0 $X=1054000 $Y=890580
X486 612 4632 4765 1 2 QDFFN $T=1064540 1022000 0 180 $X=1054000 $Y=1016580
X487 657 4632 4789 1 2 QDFFN $T=1055860 911120 1 0 $X=1055860 $Y=905700
X488 649 4614 4780 1 2 QDFFN $T=1055860 961520 0 0 $X=1055860 $Y=961140
X489 606 4614 4769 1 2 QDFFN $T=1067020 941360 1 180 $X=1056480 $Y=940980
X490 649 4639 4792 1 2 QDFFN $T=1056480 971600 0 0 $X=1056480 $Y=971220
X491 615 4639 4799 1 2 QDFFN $T=1056480 1001840 1 0 $X=1056480 $Y=996420
X492 615 638 4800 1 2 QDFFN $T=1056480 1001840 0 0 $X=1056480 $Y=1001460
X493 653 4632 4787 1 2 QDFFN $T=1056480 1042160 0 0 $X=1056480 $Y=1041780
X494 612 4639 4770 1 2 QDFFN $T=1067640 981680 1 180 $X=1057100 $Y=981300
X495 615 4632 4794 1 2 QDFFN $T=1058960 1032080 0 0 $X=1058960 $Y=1031700
X496 612 4707 4804 1 2 QDFFN $T=1060820 1011920 0 0 $X=1060820 $Y=1011540
X497 661 4614 4808 1 2 QDFFN $T=1061440 890960 1 0 $X=1061440 $Y=885540
X498 612 4614 4772 1 2 QDFFN $T=1072600 991760 0 180 $X=1062060 $Y=986340
X499 663 4632 4811 1 2 QDFFN $T=1062680 911120 0 0 $X=1062680 $Y=910740
X500 661 4639 4821 1 2 QDFFN $T=1064540 870800 0 0 $X=1064540 $Y=870420
X501 661 4632 4814 1 2 QDFFN $T=1064540 901040 0 0 $X=1064540 $Y=900660
X502 663 4634 4802 1 2 QDFFN $T=1064540 931280 1 0 $X=1064540 $Y=925860
X503 665 4634 4809 1 2 QDFFN $T=1065780 951440 1 0 $X=1065780 $Y=946020
X504 665 4632 4824 1 2 QDFFN $T=1067020 931280 0 0 $X=1067020 $Y=930900
X505 649 4632 4832 1 2 QDFFN $T=1067020 971600 1 0 $X=1067020 $Y=966180
X506 661 4634 4798 1 2 QDFFN $T=1078180 890960 1 180 $X=1067640 $Y=890580
X507 615 4634 4791 1 2 QDFFN $T=1078180 1022000 0 180 $X=1067640 $Y=1016580
X508 657 4668 4833 1 2 QDFFN $T=1068880 911120 1 0 $X=1068880 $Y=905700
X509 649 4634 4822 1 2 QDFFN $T=1068880 981680 1 0 $X=1068880 $Y=976260
X510 615 647 4803 1 2 QDFFN $T=1079420 1011920 0 180 $X=1068880 $Y=1006500
X511 606 4634 4834 1 2 QDFFN $T=1070120 951440 0 0 $X=1070120 $Y=951060
X512 653 4668 4810 1 2 QDFFN $T=1081280 1042160 1 180 $X=1070740 $Y=1041780
X513 663 4614 4848 1 2 QDFFN $T=1074460 890960 1 0 $X=1074460 $Y=885540
X514 615 4614 4806 1 2 QDFFN $T=1075080 991760 1 0 $X=1075080 $Y=986340
X515 612 4668 4820 1 2 QDFFN $T=1080040 1022000 1 0 $X=1080040 $Y=1016580
X516 653 4707 4858 1 2 QDFFN $T=1080040 1042160 1 0 $X=1080040 $Y=1036740
X517 665 4614 4854 1 2 QDFFN $T=1080660 890960 0 0 $X=1080660 $Y=890580
X518 657 4707 4846 1 2 QDFFN $T=1080660 911120 0 0 $X=1080660 $Y=910740
X519 665 4707 4841 1 2 QDFFN $T=1080660 941360 1 0 $X=1080660 $Y=935940
X520 665 4668 4827 1 2 QDFFN $T=1080660 941360 0 0 $X=1080660 $Y=940980
X521 606 4707 4859 1 2 QDFFN $T=1080660 961520 0 0 $X=1080660 $Y=961140
X522 649 4668 4845 1 2 QDFFN $T=1080660 971600 1 0 $X=1080660 $Y=966180
X523 653 4639 4842 1 2 QDFFN $T=1080660 981680 0 0 $X=1080660 $Y=981300
X524 653 4614 4826 1 2 QDFFN $T=1080660 991760 0 0 $X=1080660 $Y=991380
X525 653 638 4853 1 2 QDFFN $T=1080660 1011920 1 0 $X=1080660 $Y=1006500
X526 615 4707 4840 1 2 QDFFN $T=1080660 1022000 0 0 $X=1080660 $Y=1021620
X527 615 4668 4835 1 2 QDFFN $T=1080660 1032080 1 0 $X=1080660 $Y=1026660
X528 663 4639 4855 1 2 QDFFN $T=1081280 870800 0 0 $X=1081280 $Y=870420
X529 665 4639 4856 1 2 QDFFN $T=1081280 880880 0 0 $X=1081280 $Y=880500
X530 661 4668 4844 1 2 QDFFN $T=1081280 901040 1 0 $X=1081280 $Y=895620
X531 661 4707 4857 1 2 QDFFN $T=1081280 911120 1 0 $X=1081280 $Y=905700
X532 663 4707 4860 1 2 QDFFN $T=1081280 921200 1 0 $X=1081280 $Y=915780
X533 663 4668 4849 1 2 QDFFN $T=1081280 931280 1 0 $X=1081280 $Y=925860
X534 606 4668 4852 1 2 QDFFN $T=1081280 951440 1 0 $X=1081280 $Y=946020
X535 649 4707 4851 1 2 QDFFN $T=1081280 971600 0 0 $X=1081280 $Y=971220
X536 653 647 4843 1 2 QDFFN $T=1081280 1001840 0 0 $X=1081280 $Y=1001460
X537 947 920 915 869 1 898 2 AOI22S $T=241800 1052240 0 180 $X=238080 $Y=1046820
X538 942 920 813 985 1 954 2 AOI22S $T=244900 971600 0 0 $X=244900 $Y=971220
X539 1046 1021 993 894 1 858 2 AOI22S $T=252960 971600 1 180 $X=249240 $Y=971220
X540 1032 1011 24 1024 1 1013 2 AOI22S $T=253580 981680 0 180 $X=249860 $Y=976260
X541 920 23 853 1025 1 1006 2 AOI22S $T=249860 1042160 0 0 $X=249860 $Y=1041780
X542 1055 1021 1051 1042 1 829 2 AOI22S $T=256680 961520 1 180 $X=252960 $Y=961140
X543 716 952 1047 1046 1 1032 2 AOI22S $T=256680 971600 1 180 $X=252960 $Y=971220
X544 8 943 1061 23 1 1040 2 AOI22S $T=257920 1042160 1 180 $X=254200 $Y=1041780
X545 1040 8 1012 1017 1 1066 2 AOI22S $T=254820 1022000 0 0 $X=254820 $Y=1021620
X546 1087 30 1093 984 1 1067 2 AOI22S $T=260400 1032080 0 180 $X=256680 $Y=1026660
X547 865 803 1122 1072 1 984 2 AOI22S $T=261020 1062320 0 180 $X=257300 $Y=1056900
X548 920 1089 814 1094 1 1102 2 AOI22S $T=259160 1032080 0 0 $X=259160 $Y=1031700
X549 34 25 1053 26 1 1092 2 AOI22S $T=263500 1052240 0 180 $X=259780 $Y=1046820
X550 955 941 1107 1011 1 1055 2 AOI22S $T=264120 971600 0 180 $X=260400 $Y=966180
X551 1039 865 1118 1030 1 1072 2 AOI22S $T=265360 1022000 0 180 $X=261640 $Y=1016580
X552 942 855 1117 1090 1 927 2 AOI22S $T=264120 991760 0 0 $X=264120 $Y=991380
X553 1080 703 1125 33 1 1139 2 AOI22S $T=264120 1001840 1 0 $X=264120 $Y=996420
X554 1121 1067 1150 927 1 1046 2 AOI22S $T=269700 991760 0 180 $X=265980 $Y=986340
X555 894 1056 1158 826 1 1143 2 AOI22S $T=270940 951440 1 180 $X=267220 $Y=951060
X556 5 14 1162 865 1 1030 2 AOI22S $T=272180 1011920 1 180 $X=268460 $Y=1011540
X557 1149 1143 1175 1161 1 1153 2 AOI22S $T=272800 941360 1 180 $X=269080 $Y=940980
X558 1067 3 1204 10 1 919 2 AOI22S $T=274660 1022000 1 180 $X=270940 $Y=1021620
X559 803 25 1174 1210 1 14 2 AOI22S $T=270940 1042160 1 0 $X=270940 $Y=1036740
X560 1032 1055 1198 1132 1 1182 2 AOI22S $T=275280 971600 1 180 $X=271560 $Y=971220
X561 1011 855 1199 826 1 1178 2 AOI22S $T=275280 981680 0 180 $X=271560 $Y=976260
X562 8 1210 1157 1072 1 1239 2 AOI22S $T=274660 1042160 0 0 $X=274660 $Y=1041780
X563 1032 819 1233 1067 1 916 2 AOI22S $T=280860 981680 1 180 $X=277140 $Y=981300
X564 1046 1225 1248 1139 1 1076 2 AOI22S $T=280860 991760 1 180 $X=277140 $Y=991380
X565 1087 1040 1236 26 1 1067 2 AOI22S $T=281480 1032080 0 180 $X=277760 $Y=1026660
X566 5 947 1218 14 1 1239 2 AOI22S $T=277760 1052240 0 0 $X=277760 $Y=1051860
X567 1090 1056 1206 1246 1 1205 2 AOI22S $T=279000 941360 1 0 $X=279000 $Y=935940
X568 1265 1205 1187 916 1 959 2 AOI22S $T=283960 931280 1 180 $X=280240 $Y=930900
X569 34 3 52 1072 1 8 2 AOI22S $T=284580 1062320 0 180 $X=280860 $Y=1056900
X570 752 1221 1238 1269 1 920 2 AOI22S $T=282100 1032080 1 0 $X=282100 $Y=1026660
X571 1232 1027 1279 920 1 884 2 AOI22S $T=287060 991760 0 180 $X=283340 $Y=986340
X572 716 1291 1285 1293 1 1316 2 AOI22S $T=286440 951440 1 0 $X=286440 $Y=946020
X573 1239 1090 1318 920 1 1286 2 AOI22S $T=290780 1042160 1 180 $X=287060 $Y=1041780
X574 1090 934 1254 1362 1 1205 2 AOI22S $T=287680 911120 1 0 $X=287680 $Y=905700
X575 943 1030 1313 8 1 1089 2 AOI22S $T=291400 1022000 0 180 $X=287680 $Y=1016580
X576 752 1055 1304 1090 1 1322 2 AOI22S $T=288920 981680 1 0 $X=288920 $Y=976260
X577 1291 17 57 1021 1 1330 2 AOI22S $T=289540 971600 0 0 $X=289540 $Y=971220
X578 947 1210 1260 1340 1 1329 2 AOI22S $T=289540 1042160 1 0 $X=289540 $Y=1036740
X579 1021 855 61 1339 1 1319 2 AOI22S $T=295740 961520 1 180 $X=292020 $Y=961140
X580 926 934 1302 1362 1 1265 2 AOI22S $T=294500 911120 0 0 $X=294500 $Y=910740
X581 1381 798 1369 1359 1 1050 2 AOI22S $T=298220 951440 1 180 $X=294500 $Y=951060
X582 1027 942 1373 819 1 1011 2 AOI22S $T=298840 981680 1 180 $X=295120 $Y=981300
X583 1342 1265 1363 1386 1 1378 2 AOI22S $T=295740 941360 1 0 $X=295740 $Y=935940
X584 714 703 1380 1046 1 1032 2 AOI22S $T=299460 971600 1 180 $X=295740 $Y=971220
X585 925 1079 1370 1330 1 1072 2 AOI22S $T=299460 1001840 1 180 $X=295740 $Y=1001460
X586 23 1056 1357 1330 1 5 2 AOI22S $T=295740 1011920 0 0 $X=295740 $Y=1011540
X587 1368 1089 1379 1092 1 1064 2 AOI22S $T=299460 1022000 0 180 $X=295740 $Y=1016580
X588 1027 1246 849 1303 1 1381 2 AOI22S $T=296360 921200 0 0 $X=296360 $Y=920820
X589 1143 1303 1377 1284 1 1390 2 AOI22S $T=297600 931280 1 0 $X=297600 $Y=925860
X590 1030 47 1345 1389 1 1092 2 AOI22S $T=298220 1032080 1 0 $X=298220 $Y=1026660
X591 1381 1149 1372 1409 1 1338 2 AOI22S $T=298840 951440 0 0 $X=298840 $Y=951060
X592 1412 1232 1350 714 1 1143 2 AOI22S $T=303180 971600 1 180 $X=299460 $Y=971220
X593 1046 1090 1401 1032 1 1027 2 AOI22S $T=303180 981680 1 180 $X=299460 $Y=981300
X594 1029 1210 1393 1402 1 1403 2 AOI22S $T=300080 1022000 1 0 $X=300080 $Y=1016580
X595 1149 703 1425 1381 1 1090 2 AOI22S $T=304420 921200 1 180 $X=300700 $Y=920820
X596 1322 942 1443 798 1 934 2 AOI22S $T=306900 971600 1 180 $X=303180 $Y=971220
X597 47 1221 1419 1438 1 10 2 AOI22S $T=305040 1062320 1 0 $X=305040 $Y=1056900
X598 1342 894 1451 1232 1 1330 2 AOI22S $T=310000 981680 1 0 $X=310000 $Y=976260
X599 1412 14 1474 1029 1 1079 2 AOI22S $T=313720 1001840 1 180 $X=310000 $Y=1001460
X600 925 1225 63 1438 1 23 2 AOI22S $T=310000 1062320 1 0 $X=310000 $Y=1056900
X601 23 26 1462 1089 1 1221 2 AOI22S $T=315580 1052240 1 180 $X=311860 $Y=1051860
X602 925 865 76 14 1 1040 2 AOI22S $T=320540 1062320 1 0 $X=320540 $Y=1056900
X603 14 1040 1533 865 1 925 2 AOI22S $T=321160 1042160 0 0 $X=321160 $Y=1041780
X604 26 1330 900 1362 1 34 2 AOI22S $T=323640 1022000 1 0 $X=323640 $Y=1016580
X605 1080 3 81 1040 1 23 2 AOI22S $T=330460 1052240 0 0 $X=330460 $Y=1051860
X606 34 1040 1530 803 1 1221 2 AOI22S $T=335420 1032080 1 180 $X=331700 $Y=1031700
X607 1225 1040 1603 925 1 23 2 AOI22S $T=336040 1052240 0 180 $X=332320 $Y=1046820
X608 3 1080 70 25 1 34 2 AOI22S $T=335420 1052240 0 0 $X=335420 $Y=1051860
X609 1080 3 1514 14 1 1239 2 AOI22S $T=337280 1052240 1 0 $X=337280 $Y=1046820
X610 1342 3 1631 1641 1 1049 2 AOI22S $T=341000 971600 0 0 $X=341000 $Y=971220
X611 1687 729 1675 1541 1 1624 2 AOI22S $T=350920 971600 0 180 $X=347200 $Y=966180
X612 91 1535 1673 97 1 1695 2 AOI22S $T=349060 931280 0 0 $X=349060 $Y=930900
X613 1663 1701 1697 1064 1 1622 2 AOI22S $T=350920 951440 1 0 $X=350920 $Y=946020
X614 1705 1648 1707 1622 1 1713 2 AOI22S $T=352780 941360 1 0 $X=352780 $Y=935940
X615 1535 1210 1712 1654 1 1557 2 AOI22S $T=354020 961520 0 0 $X=354020 $Y=961140
X616 2055 2061 1857 1815 1 138 2 AOI22S $T=418500 941360 0 0 $X=418500 $Y=940980
X617 2948 2956 2953 293 1 282 2 AOI22S $T=589000 921200 0 0 $X=589000 $Y=920820
X618 2964 2979 2978 279 1 282 2 AOI22S $T=593340 901040 0 0 $X=593340 $Y=900660
X619 2969 2991 2988 293 1 291 2 AOI22S $T=595820 951440 0 0 $X=595820 $Y=951060
X620 2989 2997 2967 293 1 291 2 AOI22S $T=596440 961520 0 0 $X=596440 $Y=961140
X621 2984 3009 292 293 1 282 2 AOI22S $T=598920 901040 0 0 $X=598920 $Y=900660
X622 3005 3020 2973 293 1 291 2 AOI22S $T=600160 911120 0 0 $X=600160 $Y=910740
X623 2983 3018 294 279 1 282 2 AOI22S $T=601400 880880 1 0 $X=601400 $Y=875460
X624 3014 2986 296 298 1 282 2 AOI22S $T=601400 890960 1 0 $X=601400 $Y=885540
X625 2990 3049 3044 293 1 291 2 AOI22S $T=605120 941360 0 0 $X=605120 $Y=940980
X626 2955 3092 3075 293 1 291 2 AOI22S $T=611320 971600 0 0 $X=611320 $Y=971220
X627 3086 3114 3021 293 1 291 2 AOI22S $T=615040 981680 0 0 $X=615040 $Y=981300
X628 314 311 3101 3124 1 3137 2 AOI22S $T=623100 890960 0 180 $X=619380 $Y=885540
X629 311 314 3172 3193 1 3180 2 AOI22S $T=627440 880880 1 0 $X=627440 $Y=875460
X630 322 3199 3166 3137 1 3190 2 AOI22S $T=631160 890960 0 0 $X=631160 $Y=890580
X631 322 3179 3207 3137 1 3221 2 AOI22S $T=632400 901040 0 0 $X=632400 $Y=900660
X632 322 311 3212 3193 1 3180 2 AOI22S $T=633020 880880 0 0 $X=633020 $Y=880500
X633 3170 3199 3204 3124 1 3137 2 AOI22S $T=633640 901040 1 0 $X=633640 $Y=895620
X634 323 311 3158 3234 1 3240 2 AOI22S $T=635500 890960 0 0 $X=635500 $Y=890580
X635 323 314 3224 3131 1 3244 2 AOI22S $T=636120 870800 0 0 $X=636120 $Y=870420
X636 3180 3193 3239 326 1 327 2 AOI22S $T=637360 880880 0 0 $X=637360 $Y=880500
X637 323 322 3122 3234 1 3258 2 AOI22S $T=639840 890960 0 0 $X=639840 $Y=890580
X638 334 326 3282 3234 1 3240 2 AOI22S $T=644800 901040 0 180 $X=641080 $Y=895620
X639 334 3131 3268 330 1 3244 2 AOI22S $T=645420 880880 1 180 $X=641700 $Y=880500
X640 3221 331 3263 3137 1 327 2 AOI22S $T=642320 911120 1 0 $X=642320 $Y=905700
X641 327 335 3295 3137 1 3190 2 AOI22S $T=646660 901040 1 180 $X=642940 $Y=900660
X642 3180 3193 3320 330 1 326 2 AOI22S $T=649760 880880 1 180 $X=646040 $Y=880500
X643 334 327 3327 3234 1 3258 2 AOI22S $T=650380 901040 0 180 $X=646660 $Y=895620
X644 3272 3230 3296 279 1 291 2 AOI22S $T=646660 991760 1 0 $X=646660 $Y=986340
X645 3323 3269 3313 279 1 291 2 AOI22S $T=651000 1011920 1 180 $X=647280 $Y=1011540
X646 3270 3275 3285 293 1 291 2 AOI22S $T=647280 1022000 0 0 $X=647280 $Y=1021620
X647 3336 3322 3255 298 1 291 2 AOI22S $T=652240 981680 1 180 $X=648520 $Y=981300
X648 3297 3252 3324 293 1 291 2 AOI22S $T=650380 991760 0 0 $X=650380 $Y=991380
X649 3330 3281 3337 279 1 291 2 AOI22S $T=651620 1022000 0 0 $X=651620 $Y=1021620
X650 3319 3171 3344 293 1 291 2 AOI22S $T=654100 1001840 1 0 $X=654100 $Y=996420
X651 3372 3360 3370 293 1 291 2 AOI22S $T=659680 1022000 1 180 $X=655960 $Y=1021620
X652 315 335 3371 3124 1 3137 2 AOI22S $T=661540 901040 0 180 $X=657820 $Y=895620
X653 3137 3124 3369 326 1 330 2 AOI22S $T=658440 890960 0 0 $X=658440 $Y=890580
X654 3375 3381 3377 293 1 291 2 AOI22S $T=660300 1022000 0 0 $X=660300 $Y=1021620
X655 3399 3394 3402 298 1 282 2 AOI22S $T=666500 870800 1 180 $X=662780 $Y=870420
X656 3388 3407 3397 293 1 291 2 AOI22S $T=665880 971600 0 0 $X=665880 $Y=971220
X657 3433 3433 3408 3442 1 3448 2 AOI22S $T=670840 981680 0 0 $X=670840 $Y=981300
X658 3434 3434 3410 3442 1 3448 2 AOI22S $T=670840 1001840 1 0 $X=670840 $Y=996420
X659 3435 3435 3420 3442 1 3448 2 AOI22S $T=670840 1001840 0 0 $X=670840 $Y=1001460
X660 3436 3436 3411 3442 1 3448 2 AOI22S $T=670840 1022000 1 0 $X=670840 $Y=1016580
X661 3446 3446 3423 3442 1 3448 2 AOI22S $T=672700 991760 1 0 $X=672700 $Y=986340
X662 353 353 3447 3442 1 3448 2 AOI22S $T=678900 1022000 0 180 $X=675180 $Y=1016580
X663 3467 3467 3403 3442 1 3448 2 AOI22S $T=680760 1011920 1 180 $X=677040 $Y=1011540
X664 3481 3481 3474 3442 1 3448 2 AOI22S $T=683240 1022000 0 180 $X=679520 $Y=1016580
X665 3457 3464 3492 298 1 291 2 AOI22S $T=684480 901040 1 0 $X=684480 $Y=895620
X666 3438 3494 3491 279 1 291 2 AOI22S $T=684480 961520 0 0 $X=684480 $Y=961140
X667 3425 3508 3504 298 1 291 2 AOI22S $T=688200 911120 0 0 $X=688200 $Y=910740
X668 3487 3518 3514 298 1 291 2 AOI22S $T=689440 901040 1 0 $X=689440 $Y=895620
X669 3513 3510 3517 3522 1 3527 2 AOI22S $T=689440 1032080 0 0 $X=689440 $Y=1031700
X670 362 366 3516 367 1 371 2 AOI22S $T=689440 1062320 1 0 $X=689440 $Y=1056900
X671 3503 3525 3507 298 1 291 2 AOI22S $T=690060 961520 1 0 $X=690060 $Y=956100
X672 3462 3530 3526 298 1 291 2 AOI22S $T=691300 880880 0 0 $X=691300 $Y=880500
X673 3500 3511 3521 3522 1 3527 2 AOI22S $T=691300 1052240 1 0 $X=691300 $Y=1046820
X674 3543 3529 3549 385 1 381 2 AOI22S $T=696260 1001840 1 0 $X=696260 $Y=996420
X675 3472 3555 3546 298 1 291 2 AOI22S $T=696880 921200 1 0 $X=696880 $Y=915780
X676 3553 3550 3544 3558 1 3562 2 AOI22S $T=697500 1042160 1 0 $X=697500 $Y=1036740
X677 3528 3559 3557 298 1 291 2 AOI22S $T=698120 951440 1 0 $X=698120 $Y=946020
X678 3556 3560 3538 3558 1 3562 2 AOI22S $T=698120 1032080 0 0 $X=698120 $Y=1031700
X679 3489 3566 3568 298 1 291 2 AOI22S $T=701220 941360 0 0 $X=701220 $Y=940980
X680 3567 3569 3564 3522 1 3527 2 AOI22S $T=701220 981680 1 0 $X=701220 $Y=976260
X681 3563 3577 3574 367 1 371 2 AOI22S $T=703700 1011920 0 0 $X=703700 $Y=1011540
X682 3509 3575 3572 298 1 291 2 AOI22S $T=704940 931280 0 0 $X=704940 $Y=930900
X683 3591 3587 3589 3558 1 3562 2 AOI22S $T=710520 971600 0 180 $X=706800 $Y=966180
X684 3585 3598 3536 385 1 381 2 AOI22S $T=709900 1062320 1 0 $X=709900 $Y=1056900
X685 3444 3579 3593 298 1 291 2 AOI22S $T=711760 931280 0 0 $X=711760 $Y=930900
X686 3633 3614 3616 367 1 371 2 AOI22S $T=717340 1011920 0 180 $X=713620 $Y=1006500
X687 3630 3622 3631 3558 1 3562 2 AOI22S $T=718580 971600 0 180 $X=714860 $Y=966180
X688 3607 3608 3618 3522 1 3527 2 AOI22S $T=715480 981680 0 0 $X=715480 $Y=981300
X689 3637 3606 3626 3522 1 3527 2 AOI22S $T=719200 1042160 0 180 $X=715480 $Y=1036740
X690 3609 3632 3619 385 1 381 2 AOI22S $T=718580 1001840 1 0 $X=718580 $Y=996420
X691 3576 3634 3617 3558 1 3562 2 AOI22S $T=718580 1032080 0 0 $X=718580 $Y=1031700
X692 3648 3638 3650 385 1 381 2 AOI22S $T=726020 1001840 1 180 $X=722300 $Y=1001460
X693 3640 3653 3652 3522 1 3527 2 AOI22S $T=725400 981680 1 0 $X=725400 $Y=976260
X694 3649 3654 3651 367 1 371 2 AOI22S $T=725400 1011920 0 0 $X=725400 $Y=1011540
X695 3671 3664 3667 385 1 381 2 AOI22S $T=733460 1001840 1 180 $X=729740 $Y=1001460
X696 3701 3676 3696 3522 1 3527 2 AOI22S $T=737180 1052240 0 180 $X=733460 $Y=1046820
X697 3668 3669 3681 3558 1 3562 2 AOI22S $T=734080 971600 1 0 $X=734080 $Y=966180
X698 3662 3685 3680 3558 1 3562 2 AOI22S $T=734080 1042160 1 0 $X=734080 $Y=1036740
X699 3684 3573 3704 411 1 3716 2 AOI22S $T=737180 941360 0 0 $X=737180 $Y=940980
X700 3699 3705 3674 367 1 371 2 AOI22S $T=737180 1011920 0 0 $X=737180 $Y=1011540
X701 3690 3647 3710 411 1 3716 2 AOI22S $T=739040 951440 1 0 $X=739040 $Y=946020
X702 3691 3698 414 411 1 3716 2 AOI22S $T=739040 951440 0 0 $X=739040 $Y=951060
X703 3715 3712 3724 3522 1 3527 2 AOI22S $T=744620 981680 0 0 $X=744620 $Y=981300
X704 3726 3727 3728 427 1 428 2 AOI22S $T=745860 911120 1 0 $X=745860 $Y=905700
X705 3746 3731 3718 3522 1 3527 2 AOI22S $T=749580 991760 0 180 $X=745860 $Y=986340
X706 3733 3738 429 411 1 3716 2 AOI22S $T=748960 951440 0 0 $X=748960 $Y=951060
X707 3729 3747 3739 367 1 371 2 AOI22S $T=748960 1011920 0 0 $X=748960 $Y=1011540
X708 3757 3750 3767 3558 1 3562 2 AOI22S $T=752680 1042160 0 180 $X=748960 $Y=1036740
X709 3730 3744 3736 432 1 437 2 AOI22S $T=749580 911120 0 0 $X=749580 $Y=910740
X710 430 3741 3697 385 1 381 2 AOI22S $T=750820 1062320 1 0 $X=750820 $Y=1056900
X711 3751 3745 3743 3558 1 3562 2 AOI22S $T=751440 981680 1 0 $X=751440 $Y=976260
X712 3761 3719 433 411 1 3716 2 AOI22S $T=752680 961520 1 0 $X=752680 $Y=956100
X713 3758 3766 3749 385 1 381 2 AOI22S $T=752680 1001840 1 0 $X=752680 $Y=996420
X714 3778 3773 3783 432 1 437 2 AOI22S $T=757640 911120 1 180 $X=753920 $Y=910740
X715 3756 3759 3770 3522 1 3527 2 AOI22S $T=753920 1042160 0 0 $X=753920 $Y=1041780
X716 3765 3763 3721 3558 1 3562 2 AOI22S $T=755780 981680 1 0 $X=755780 $Y=976260
X717 3775 3535 3779 411 1 3716 2 AOI22S $T=757020 961520 1 0 $X=757020 $Y=956100
X718 3760 444 3772 385 1 381 2 AOI22S $T=757640 1062320 1 0 $X=757640 $Y=1056900
X719 3737 3782 3785 367 1 371 2 AOI22S $T=758880 1022000 1 0 $X=758880 $Y=1016580
X720 3768 3711 3788 411 1 3716 2 AOI22S $T=759500 951440 1 0 $X=759500 $Y=946020
X721 3780 3789 3786 427 1 428 2 AOI22S $T=760740 901040 1 0 $X=760740 $Y=895620
X722 3799 3769 450 411 1 3716 2 AOI22S $T=765080 961520 0 180 $X=761360 $Y=956100
X723 3796 3800 3802 432 1 437 2 AOI22S $T=764460 911120 0 0 $X=764460 $Y=910740
X724 3819 3814 3832 3522 1 3527 2 AOI22S $T=771900 991760 0 180 $X=768180 $Y=986340
X725 3807 3806 3812 385 1 381 2 AOI22S $T=769420 1011920 1 0 $X=769420 $Y=1006500
X726 3813 3815 3821 3522 1 3527 2 AOI22S $T=771280 1042160 0 0 $X=771280 $Y=1041780
X727 3824 3820 3825 3558 1 3562 2 AOI22S $T=773140 981680 1 0 $X=773140 $Y=976260
X728 462 3828 3836 385 1 381 2 AOI22S $T=776860 1062320 0 180 $X=773140 $Y=1056900
X729 3837 3839 3847 432 1 437 2 AOI22S $T=778720 911120 1 180 $X=775000 $Y=910740
X730 3829 411 3835 3838 1 3716 2 AOI22S $T=775000 951440 0 0 $X=775000 $Y=951060
X731 3797 3822 3833 367 1 371 2 AOI22S $T=775620 1022000 1 0 $X=775620 $Y=1016580
X732 3826 3841 3817 427 1 428 2 AOI22S $T=776240 901040 1 0 $X=776240 $Y=895620
X733 3854 3542 3856 411 1 3716 2 AOI22S $T=779960 961520 0 180 $X=776240 $Y=956100
X734 3844 3842 3840 3522 1 3527 2 AOI22S $T=778100 991760 1 0 $X=778100 $Y=986340
X735 3823 3620 463 411 1 3716 2 AOI22S $T=779340 951440 1 0 $X=779340 $Y=946020
X736 3830 3861 3853 427 1 428 2 AOI22S $T=781200 901040 1 0 $X=781200 $Y=895620
X737 3855 3862 3849 3558 1 3562 2 AOI22S $T=781200 981680 1 0 $X=781200 $Y=976260
X738 3848 3865 3863 3558 1 3562 2 AOI22S $T=782440 1042160 1 0 $X=782440 $Y=1036740
X739 3845 3827 465 411 1 3716 2 AOI22S $T=783060 951440 0 0 $X=783060 $Y=951060
X740 3864 3867 3860 385 1 381 2 AOI22S $T=783060 1011920 1 0 $X=783060 $Y=1006500
X741 3884 3850 469 411 1 3716 2 AOI22S $T=790500 961520 0 180 $X=786780 $Y=956100
X742 3881 3868 3882 427 1 428 2 AOI22S $T=791740 911120 0 180 $X=788020 $Y=905700
X743 3891 3875 3874 367 1 371 2 AOI22S $T=792360 1022000 0 180 $X=788640 $Y=1016580
X744 3878 3873 3877 3522 1 3527 2 AOI22S $T=792360 1042160 1 180 $X=788640 $Y=1041780
X745 468 473 3886 385 1 381 2 AOI22S $T=791740 1062320 1 0 $X=791740 $Y=1056900
X746 3879 3852 3889 427 1 428 2 AOI22S $T=793600 880880 1 0 $X=793600 $Y=875460
X747 3903 3885 475 411 1 3716 2 AOI22S $T=797320 951440 1 180 $X=793600 $Y=951060
X748 3914 3906 3908 3522 1 3527 2 AOI22S $T=799800 1042160 0 180 $X=796080 $Y=1036740
X749 3904 3910 480 411 1 3716 2 AOI22S $T=801040 961520 0 180 $X=797320 $Y=956100
X750 3931 3919 482 411 1 3716 2 AOI22S $T=804140 951440 0 180 $X=800420 $Y=946020
X751 3892 3909 3915 3522 1 3527 2 AOI22S $T=801040 991760 1 0 $X=801040 $Y=986340
X752 3890 3924 3916 432 1 437 2 AOI22S $T=802280 911120 0 0 $X=802280 $Y=910740
X753 3922 3926 3911 3558 1 3562 2 AOI22S $T=802900 981680 1 0 $X=802900 $Y=976260
X754 3943 3937 3948 3522 1 3527 2 AOI22S $T=809100 991760 0 180 $X=805380 $Y=986340
X755 3917 3918 3928 3558 1 3562 2 AOI22S $T=805380 1032080 0 0 $X=805380 $Y=1031700
X756 3901 3938 3936 367 1 371 2 AOI22S $T=806000 1011920 0 0 $X=806000 $Y=1011540
X757 3952 3949 502 411 1 3716 2 AOI22S $T=812200 961520 1 180 $X=808480 $Y=961140
X758 3971 3935 3945 385 1 381 2 AOI22S $T=814060 1011920 0 180 $X=810340 $Y=1006500
X759 3963 3934 3955 3558 1 3562 2 AOI22S $T=817160 981680 0 0 $X=817160 $Y=981300
X760 3941 3961 3983 432 1 437 2 AOI22S $T=822740 941360 0 0 $X=822740 $Y=940980
X761 3985 3993 3997 427 1 428 2 AOI22S $T=827700 951440 0 0 $X=827700 $Y=951060
X762 3975 514 3988 385 1 381 2 AOI22S $T=827700 1062320 1 0 $X=827700 $Y=1056900
X763 3940 4010 4002 411 1 3716 2 AOI22S $T=828940 971600 1 0 $X=828940 $Y=966180
X764 4018 4000 4012 3522 1 3527 2 AOI22S $T=833900 1042160 1 180 $X=830180 $Y=1041780
X765 4004 4009 4023 411 1 3716 2 AOI22S $T=836380 971600 0 180 $X=832660 $Y=966180
X766 4014 519 4008 3558 1 3562 2 AOI22S $T=832660 1052240 0 0 $X=832660 $Y=1051860
X767 4017 3980 4020 3558 1 3562 2 AOI22S $T=833280 1001840 0 0 $X=833280 $Y=1001460
X768 3995 3977 4021 3558 1 3562 2 AOI22S $T=833280 1011920 0 0 $X=833280 $Y=1011540
X769 4040 4032 4038 367 1 371 2 AOI22S $T=840720 1032080 0 180 $X=837000 $Y=1026660
X770 4036 4046 4042 427 1 428 2 AOI22S $T=840100 961520 0 0 $X=840100 $Y=961140
X771 4041 4030 4051 432 1 437 2 AOI22S $T=841960 941360 0 0 $X=841960 $Y=940980
X772 4052 4061 4059 411 1 3716 2 AOI22S $T=843820 981680 1 0 $X=843820 $Y=976260
X773 4049 4072 4078 3522 1 3527 2 AOI22S $T=850020 1001840 0 0 $X=850020 $Y=1001460
X774 4077 4094 4084 411 1 3716 2 AOI22S $T=853740 971600 1 0 $X=853740 $Y=966180
X775 4102 4095 4088 385 1 381 2 AOI22S $T=857460 1032080 0 180 $X=853740 $Y=1026660
X776 4090 4096 4093 432 1 437 2 AOI22S $T=854980 911120 0 0 $X=854980 $Y=910740
X777 4070 4074 4101 432 1 437 2 AOI22S $T=856840 951440 1 0 $X=856840 $Y=946020
X778 4103 4110 4107 427 1 428 2 AOI22S $T=857460 951440 0 0 $X=857460 $Y=951060
X779 4119 4091 4117 385 1 381 2 AOI22S $T=861180 1011920 1 180 $X=857460 $Y=1011540
X780 4104 4108 4060 3522 1 3527 2 AOI22S $T=859320 1052240 1 0 $X=859320 $Y=1046820
X781 4099 536 4062 427 1 428 2 AOI22S $T=859940 880880 1 0 $X=859940 $Y=875460
X782 4112 4122 538 411 1 3716 2 AOI22S $T=863660 971600 0 180 $X=859940 $Y=966180
X783 4100 4109 4064 3558 1 3562 2 AOI22S $T=859940 1052240 0 0 $X=859940 $Y=1051860
X784 4137 4129 4133 427 1 428 2 AOI22S $T=865520 961520 0 180 $X=861800 $Y=956100
X785 4116 4135 4123 411 1 3716 2 AOI22S $T=863660 981680 0 0 $X=863660 $Y=981300
X786 4082 4079 4127 3522 1 3527 2 AOI22S $T=863660 1011920 0 0 $X=863660 $Y=1011540
X787 4153 4160 4149 427 1 428 2 AOI22S $T=870480 890960 1 0 $X=870480 $Y=885540
X788 4131 4163 4159 367 1 371 2 AOI22S $T=871720 1011920 0 0 $X=871720 $Y=1011540
X789 4172 4167 4161 432 1 437 2 AOI22S $T=877300 901040 0 180 $X=873580 $Y=895620
X790 4185 4175 4180 432 1 437 2 AOI22S $T=877920 951440 0 180 $X=874200 $Y=946020
X791 4097 4138 4130 3558 1 3562 2 AOI22S $T=874820 1001840 1 0 $X=874820 $Y=996420
X792 4144 4179 4168 367 1 371 2 AOI22S $T=874820 1032080 1 0 $X=874820 $Y=1026660
X793 4140 4181 4126 3522 1 3527 2 AOI22S $T=875440 1001840 0 0 $X=875440 $Y=1001460
X794 547 4187 549 427 1 428 2 AOI22S $T=877300 870800 0 0 $X=877300 $Y=870420
X795 4186 4195 4189 411 1 3716 2 AOI22S $T=878540 981680 1 0 $X=878540 $Y=976260
X796 4202 4198 4150 411 1 3716 2 AOI22S $T=882260 981680 1 180 $X=878540 $Y=981300
X797 4169 4192 4147 3558 1 3562 2 AOI22S $T=878540 1052240 0 0 $X=878540 $Y=1051860
X798 4193 4170 4190 427 1 428 2 AOI22S $T=884120 961520 0 180 $X=880400 $Y=956100
X799 4203 4206 4204 432 1 437 2 AOI22S $T=882260 951440 1 0 $X=882260 $Y=946020
X800 4183 4214 4165 411 1 3716 2 AOI22S $T=888460 971600 1 180 $X=884740 $Y=971220
X801 4222 4209 4166 385 1 381 2 AOI22S $T=888460 1022000 1 180 $X=884740 $Y=1021620
X802 4212 4219 4228 3522 1 3527 2 AOI22S $T=889080 1052240 1 180 $X=885360 $Y=1051860
X803 4210 4215 4208 3558 1 3562 2 AOI22S $T=885980 1001840 1 0 $X=885980 $Y=996420
X804 4217 4213 4221 427 1 428 2 AOI22S $T=887220 880880 0 0 $X=887220 $Y=880500
X805 4207 4224 4164 3522 1 3527 2 AOI22S $T=887840 1052240 1 0 $X=887840 $Y=1046820
X806 4227 4229 4211 3522 1 3527 2 AOI22S $T=889080 1001840 0 0 $X=889080 $Y=1001460
X807 4242 4245 4235 3558 1 3562 2 AOI22S $T=894040 1052240 0 0 $X=894040 $Y=1051860
X808 4247 4231 4253 427 1 428 2 AOI22S $T=895900 961520 1 0 $X=895900 $Y=956100
X809 4248 4255 4251 411 1 3716 2 AOI22S $T=895900 981680 0 0 $X=895900 $Y=981300
X810 4270 4259 4254 432 1 437 2 AOI22S $T=901480 880880 1 180 $X=897760 $Y=880500
X811 4275 4260 4252 432 1 437 2 AOI22S $T=901480 901040 0 180 $X=897760 $Y=895620
X812 4282 4268 4272 427 1 428 2 AOI22S $T=903340 961520 0 180 $X=899620 $Y=956100
X813 4278 4234 4274 367 1 371 2 AOI22S $T=903960 1011920 1 180 $X=900240 $Y=1011540
X814 4276 4280 4265 3558 1 3562 2 AOI22S $T=902720 1001840 1 0 $X=902720 $Y=996420
X815 4291 4283 4295 3522 1 3527 2 AOI22S $T=906440 1042160 1 180 $X=902720 $Y=1041780
X816 4300 4281 4269 385 1 381 2 AOI22S $T=907060 1032080 0 180 $X=903340 $Y=1026660
X817 4303 4290 4293 427 1 428 2 AOI22S $T=907680 961520 0 180 $X=903960 $Y=956100
X818 4289 4294 4243 411 1 3716 2 AOI22S $T=908300 981680 1 180 $X=904580 $Y=981300
X819 4287 4302 4299 432 1 437 2 AOI22S $T=907680 941360 0 0 $X=907680 $Y=940980
X820 4304 4313 4277 432 1 437 2 AOI22S $T=914500 951440 0 180 $X=910780 $Y=946020
X821 4307 4312 4301 3558 1 3562 2 AOI22S $T=910780 1052240 1 0 $X=910780 $Y=1046820
X822 4305 4318 560 411 1 3716 2 AOI22S $T=912640 971600 0 0 $X=912640 $Y=971220
X823 4325 4322 564 411 1 3716 2 AOI22S $T=918220 981680 0 180 $X=914500 $Y=976260
X824 4334 4330 4288 411 1 3716 2 AOI22S $T=921320 971600 1 180 $X=917600 $Y=971220
X825 4329 4331 4324 3522 1 3527 2 AOI22S $T=918220 1042160 1 0 $X=918220 $Y=1036740
X826 4338 569 4319 3558 1 3562 2 AOI22S $T=921940 1042160 1 180 $X=918220 $Y=1041780
X827 4315 4321 566 411 1 3716 2 AOI22S $T=918840 981680 0 0 $X=918840 $Y=981300
X828 4346 4333 4323 3522 1 3527 2 AOI22S $T=922560 1001840 0 180 $X=918840 $Y=996420
X829 4343 4335 4237 411 1 3716 2 AOI22S $T=923180 981680 0 180 $X=919460 $Y=976260
X830 4340 4336 4328 367 1 371 2 AOI22S $T=923180 1011920 1 180 $X=919460 $Y=1011540
X831 4339 4342 4267 411 1 3716 2 AOI22S $T=925040 971600 0 180 $X=921320 $Y=966180
X832 4332 4344 4326 3558 1 3562 2 AOI22S $T=922560 991760 0 0 $X=922560 $Y=991380
X833 4341 4337 4327 385 1 381 2 AOI22S $T=924420 1032080 1 0 $X=924420 $Y=1026660
X834 4347 4345 4351 3558 1 3562 2 AOI22S $T=926280 1052240 1 0 $X=926280 $Y=1046820
X835 4367 4358 4378 577 1 576 2 AOI22S $T=933720 880880 1 180 $X=930000 $Y=880500
X836 4371 4363 4376 577 1 576 2 AOI22S $T=934960 901040 0 180 $X=931240 $Y=895620
X837 4357 4359 4366 577 1 576 2 AOI22S $T=931860 911120 0 0 $X=931860 $Y=910740
X838 4355 4356 4365 577 1 576 2 AOI22S $T=931860 961520 1 0 $X=931860 $Y=956100
X839 4377 4369 4372 577 1 576 2 AOI22S $T=935580 961520 1 180 $X=931860 $Y=961140
X840 4364 4354 4368 577 1 576 2 AOI22S $T=933100 931280 1 0 $X=933100 $Y=925860
X841 4383 4362 4401 577 1 576 2 AOI22S $T=939300 941360 1 180 $X=935580 $Y=940980
X842 579 4370 4349 587 1 588 2 AOI22S $T=936200 870800 0 0 $X=936200 $Y=870420
X843 4375 4389 4386 587 1 588 2 AOI22S $T=936820 890960 1 0 $X=936820 $Y=885540
X844 4393 4390 4392 587 1 588 2 AOI22S $T=941160 971600 0 180 $X=937440 $Y=966180
X845 4410 4397 4414 3558 1 3562 2 AOI22S $T=941780 1001840 0 180 $X=938060 $Y=996420
X846 4422 4403 4391 587 1 588 2 AOI22S $T=943020 901040 1 180 $X=939300 $Y=900660
X847 4417 4408 4404 587 1 588 2 AOI22S $T=943020 911120 1 180 $X=939300 $Y=910740
X848 4384 4407 4402 3558 1 3562 2 AOI22S $T=939920 1022000 1 0 $X=939920 $Y=1016580
X849 4425 4412 4415 3558 1 3562 2 AOI22S $T=943640 1052240 1 180 $X=939920 $Y=1051860
X850 4395 4411 4399 587 1 588 2 AOI22S $T=940540 931280 1 0 $X=940540 $Y=925860
X851 4428 4418 4435 3558 1 3562 2 AOI22S $T=945500 1032080 0 180 $X=941780 $Y=1026660
X852 4406 4424 4423 3522 1 3527 2 AOI22S $T=943640 1052240 1 0 $X=943640 $Y=1046820
X853 4438 4434 4421 3522 1 3527 2 AOI22S $T=949840 1001840 0 180 $X=946120 $Y=996420
X854 4459 4443 4442 3522 1 3527 2 AOI22S $T=952320 1032080 1 180 $X=948600 $Y=1031700
X855 4427 4432 4379 587 1 588 2 AOI22S $T=949220 971600 0 0 $X=949220 $Y=971220
X856 4463 4453 4445 3522 1 3527 2 AOI22S $T=955420 1011920 1 180 $X=951700 $Y=1011540
X857 4501 4454 4446 3522 1 3527 2 AOI22S $T=955420 1042160 1 180 $X=951700 $Y=1041780
X858 4447 598 4360 599 1 600 2 AOI22S $T=952940 870800 0 0 $X=952940 $Y=870420
X859 4476 4464 4479 599 1 600 2 AOI22S $T=959140 890960 0 180 $X=955420 $Y=885540
X860 4439 4449 4466 599 1 600 2 AOI22S $T=955420 941360 1 0 $X=955420 $Y=935940
X861 4468 4475 4361 602 1 603 2 AOI22S $T=957280 870800 0 0 $X=957280 $Y=870420
X862 4470 4455 4465 599 1 600 2 AOI22S $T=957280 901040 0 0 $X=957280 $Y=900660
X863 4451 4452 4471 599 1 600 2 AOI22S $T=957280 951440 1 0 $X=957280 $Y=946020
X864 4482 4472 4473 599 1 600 2 AOI22S $T=962240 921200 0 180 $X=958520 $Y=915780
X865 4487 4481 4486 599 1 600 2 AOI22S $T=965340 991760 1 0 $X=965340 $Y=986340
X866 4512 4491 4506 367 1 371 2 AOI22S $T=969680 1011920 0 180 $X=965960 $Y=1006500
X867 4498 4504 4474 602 1 603 2 AOI22S $T=967200 941360 1 0 $X=967200 $Y=935940
X868 4520 4507 4529 367 1 371 2 AOI22S $T=970920 1011920 1 180 $X=967200 $Y=1011540
X869 4499 4511 4514 367 1 371 2 AOI22S $T=970920 1032080 0 180 $X=967200 $Y=1026660
X870 609 4502 4518 367 1 371 2 AOI22S $T=970920 1062320 0 180 $X=967200 $Y=1056900
X871 4503 4505 608 602 1 603 2 AOI22S $T=967820 870800 0 0 $X=967820 $Y=870420
X872 4563 4517 4550 367 1 371 2 AOI22S $T=972780 1042160 1 180 $X=969060 $Y=1041780
X873 4531 4513 4530 602 1 603 2 AOI22S $T=975260 991760 0 180 $X=971540 $Y=986340
X874 4540 4533 4525 385 1 381 2 AOI22S $T=977120 1032080 0 180 $X=973400 $Y=1026660
X875 4535 4537 4488 602 1 603 2 AOI22S $T=978360 991760 1 180 $X=974640 $Y=991380
X876 4534 4528 4483 602 1 603 2 AOI22S $T=975880 890960 1 0 $X=975880 $Y=885540
X877 614 4542 4527 385 1 381 2 AOI22S $T=979600 1062320 0 180 $X=975880 $Y=1056900
X878 4509 4536 4492 602 1 603 2 AOI22S $T=977120 961520 1 0 $X=977120 $Y=956100
X879 4617 4557 4548 385 1 381 2 AOI22S $T=985800 1052240 0 180 $X=982080 $Y=1046820
X880 4552 4516 4522 602 1 603 2 AOI22S $T=982700 931280 0 0 $X=982700 $Y=930900
X881 4496 4555 4559 577 1 576 2 AOI22S $T=984560 901040 0 0 $X=984560 $Y=900660
X882 4580 4567 621 602 1 603 2 AOI22S $T=989520 870800 1 180 $X=985800 $Y=870420
X883 4584 4577 4547 599 1 600 2 AOI22S $T=990760 991760 0 180 $X=987040 $Y=986340
X884 4562 4578 4554 385 1 381 2 AOI22S $T=987660 1001840 0 0 $X=987660 $Y=1001460
X885 4594 4568 4526 385 1 381 2 AOI22S $T=993860 1011920 1 180 $X=990140 $Y=1011540
X886 4583 4585 4576 587 1 588 2 AOI22S $T=998200 961520 1 180 $X=994480 $Y=961140
X887 4608 4600 4605 602 1 603 2 AOI22S $T=998820 921200 1 180 $X=995100 $Y=920820
X888 4613 4603 4592 587 1 588 2 AOI22S $T=999440 911120 1 180 $X=995720 $Y=910740
X889 4640 4597 4629 577 1 576 2 AOI22S $T=1001920 961520 1 180 $X=998200 $Y=961140
X890 4631 4623 4602 587 1 588 2 AOI22S $T=1003780 890960 0 180 $X=1000060 $Y=885540
X891 4628 4630 4582 587 1 588 2 AOI22S $T=1005020 901040 1 180 $X=1001300 $Y=900660
X892 4615 4607 4625 599 1 600 2 AOI22S $T=1001300 1032080 1 0 $X=1001300 $Y=1026660
X893 4606 4590 4627 587 1 588 2 AOI22S $T=1001920 1001840 1 0 $X=1001920 $Y=996420
X894 4621 4644 4641 587 1 588 2 AOI22S $T=1005640 1001840 1 0 $X=1005640 $Y=996420
X895 4635 4646 4642 602 1 603 2 AOI22S $T=1006880 890960 1 0 $X=1006880 $Y=885540
X896 4687 4648 4698 599 1 600 2 AOI22S $T=1010600 961520 1 180 $X=1006880 $Y=961140
X897 4601 4609 4650 599 1 600 2 AOI22S $T=1008120 1011920 0 0 $X=1008120 $Y=1011540
X898 4616 4626 4654 599 1 600 2 AOI22S $T=1010600 981680 0 0 $X=1010600 $Y=981300
X899 4672 4665 4643 602 1 603 2 AOI22S $T=1018660 1042160 0 180 $X=1014940 $Y=1036740
X900 4663 639 637 602 1 603 2 AOI22S $T=1015560 870800 0 0 $X=1015560 $Y=870420
X901 4664 4667 4666 602 1 603 2 AOI22S $T=1015560 901040 1 0 $X=1015560 $Y=895620
X902 4675 4670 4674 599 1 600 2 AOI22S $T=1020520 1022000 1 180 $X=1016800 $Y=1021620
X903 4701 4673 4618 599 1 600 2 AOI22S $T=1021760 921200 1 180 $X=1018040 $Y=920820
X904 4681 4678 4682 587 1 588 2 AOI22S $T=1023620 941360 1 180 $X=1019900 $Y=940980
X905 4671 4676 4680 587 1 588 2 AOI22S $T=1023620 1001840 0 180 $X=1019900 $Y=996420
X906 4690 4649 4657 602 1 603 2 AOI22S $T=1025480 1022000 0 180 $X=1021760 $Y=1016580
X907 4695 4694 4679 599 1 600 2 AOI22S $T=1027340 901040 0 180 $X=1023620 $Y=895620
X908 4705 4697 4686 577 1 576 2 AOI22S $T=1028580 941360 1 180 $X=1024860 $Y=940980
X909 4706 4693 4677 602 1 603 2 AOI22S $T=1028580 1022000 1 180 $X=1024860 $Y=1021620
X910 4684 4699 4662 577 1 576 2 AOI22S $T=1025480 1001840 0 0 $X=1025480 $Y=1001460
X911 4692 4703 4691 577 1 576 2 AOI22S $T=1026100 1001840 1 0 $X=1026100 $Y=996420
X912 4717 4708 4709 587 1 588 2 AOI22S $T=1033540 1001840 0 180 $X=1029820 $Y=996420
X913 4712 4715 4653 577 1 576 2 AOI22S $T=1038500 991760 1 180 $X=1034780 $Y=991380
X914 4727 4722 4724 587 1 588 2 AOI22S $T=1040360 880880 1 180 $X=1036640 $Y=880500
X915 4714 4710 4718 587 1 588 2 AOI22S $T=1036640 921200 0 0 $X=1036640 $Y=920820
X916 4716 4723 4721 602 1 603 2 AOI22S $T=1037260 1042160 1 0 $X=1037260 $Y=1036740
X917 4738 4731 4746 587 1 588 2 AOI22S $T=1044080 880880 1 180 $X=1040360 $Y=880500
X918 4719 4732 4729 577 1 576 2 AOI22S $T=1040980 921200 1 0 $X=1040980 $Y=915780
X919 4704 4728 4733 599 1 600 2 AOI22S $T=1042220 890960 0 0 $X=1042220 $Y=890580
X920 4740 4730 4726 599 1 600 2 AOI22S $T=1045940 1032080 0 180 $X=1042220 $Y=1026660
X921 4744 4736 4739 599 1 600 2 AOI22S $T=1047180 921200 1 180 $X=1043460 $Y=920820
X922 4747 4743 4745 599 1 600 2 AOI22S $T=1049040 931280 0 180 $X=1045320 $Y=925860
X923 4734 4748 4761 577 1 576 2 AOI22S $T=1050280 951440 0 180 $X=1046560 $Y=946020
X924 4757 4758 4741 602 1 603 2 AOI22S $T=1054000 901040 0 180 $X=1050280 $Y=895620
X925 4751 4749 4711 577 1 576 2 AOI22S $T=1050280 1001840 1 0 $X=1050280 $Y=996420
X926 4767 4764 4752 577 1 576 2 AOI22S $T=1056480 991760 1 180 $X=1052760 $Y=991380
X927 4765 4763 4768 599 1 600 2 AOI22S $T=1056480 1011920 1 180 $X=1052760 $Y=1011540
X928 4786 4769 4766 587 1 588 2 AOI22S $T=1059580 951440 0 180 $X=1055860 $Y=946020
X929 4770 4772 4750 587 1 588 2 AOI22S $T=1057100 991760 0 0 $X=1057100 $Y=991380
X930 4781 4774 4777 587 1 588 2 AOI22S $T=1061440 880880 1 180 $X=1057720 $Y=880500
X931 4787 4779 4783 599 1 600 2 AOI22S $T=1062680 1032080 0 180 $X=1058960 $Y=1026660
X932 4792 4780 4773 587 1 588 2 AOI22S $T=1063300 971600 0 180 $X=1059580 $Y=966180
X933 4789 4782 4788 599 1 600 2 AOI22S $T=1064540 901040 0 180 $X=1060820 $Y=895620
X934 4771 4778 4737 602 1 603 2 AOI22S $T=1061440 921200 0 0 $X=1061440 $Y=920820
X935 4785 4784 4754 602 1 603 2 AOI22S $T=1063300 941360 1 0 $X=1063300 $Y=935940
X936 4794 4791 4795 599 1 600 2 AOI22S $T=1067640 1032080 0 180 $X=1063920 $Y=1026660
X937 4811 4802 4819 599 1 600 2 AOI22S $T=1071360 921200 1 180 $X=1067640 $Y=920820
X938 4821 4808 4812 587 1 588 2 AOI22S $T=1073220 880880 1 180 $X=1069500 $Y=880500
X939 4814 4798 4818 599 1 600 2 AOI22S $T=1073220 901040 0 180 $X=1069500 $Y=895620
X940 4824 4809 4817 599 1 600 2 AOI22S $T=1073220 941360 0 180 $X=1069500 $Y=935940
X941 4799 4806 4801 587 1 588 2 AOI22S $T=1069500 991760 0 0 $X=1069500 $Y=991380
X942 4800 4803 4793 577 1 576 2 AOI22S $T=1069500 1001840 1 0 $X=1069500 $Y=996420
X943 4858 4810 4815 602 1 603 2 AOI22S $T=1076320 1032080 1 180 $X=1072600 $Y=1031700
X944 4832 4822 4805 599 1 600 2 AOI22S $T=1076940 971600 1 180 $X=1073220 $Y=971220
X945 4804 4820 4776 602 1 603 2 AOI22S $T=1073220 1011920 0 0 $X=1073220 $Y=1011540
X946 4841 4827 4837 602 1 603 2 AOI22S $T=1078180 941360 0 180 $X=1074460 $Y=935940
X947 4842 4826 4829 587 1 588 2 AOI22S $T=1078180 991760 1 180 $X=1074460 $Y=991380
X948 4846 4833 4796 602 1 603 2 AOI22S $T=1079420 921200 0 180 $X=1075700 $Y=915780
X949 4831 4834 4839 599 1 600 2 AOI22S $T=1079420 961520 0 180 $X=1075700 $Y=956100
X950 4840 4835 4807 602 1 603 2 AOI22S $T=1079420 1032080 0 180 $X=1075700 $Y=1026660
X951 671 670 4830 577 1 576 2 AOI22S $T=1080040 870800 1 180 $X=1076320 $Y=870420
X952 4857 4844 4825 602 1 603 2 AOI22S $T=1081280 901040 1 180 $X=1077560 $Y=900660
X953 4851 4845 4813 602 1 603 2 AOI22S $T=1081280 971600 1 180 $X=1077560 $Y=971220
X954 4853 4843 4823 577 1 576 2 AOI22S $T=1081280 1001840 0 180 $X=1077560 $Y=996420
X955 4855 4848 674 587 1 588 2 AOI22S $T=1081900 880880 0 180 $X=1078180 $Y=875460
X956 4860 4849 4838 602 1 603 2 AOI22S $T=1082520 921200 1 180 $X=1078800 $Y=920820
X957 4859 4852 4847 602 1 603 2 AOI22S $T=1086860 951440 1 180 $X=1083140 $Y=951060
X958 4856 4854 4850 587 1 588 2 AOI22S $T=1091820 890960 0 180 $X=1088100 $Y=885540
X959 825 816 1 2 771 AN2 $T=230640 911120 0 180 $X=228160 $Y=905700
X960 915 900 1 2 891 AN2 $T=238700 1052240 1 180 $X=236220 $Y=1051860
X961 1058 1044 1 2 1073 AN2 $T=256680 931280 1 0 $X=256680 $Y=925860
X962 1109 1016 1 2 1078 AN2 $T=262880 921200 1 180 $X=260400 $Y=920820
X963 1224 1191 1 2 1270 AN2 $T=286440 941360 1 180 $X=283960 $Y=940980
X964 878 1181 1 2 1308 AN2 $T=287680 961520 0 0 $X=287680 $Y=961140
X965 1275 1347 1 2 1348 AN2 $T=296360 890960 0 0 $X=296360 $Y=890580
X966 1353 1348 1 2 1420 AN2 $T=297600 901040 0 0 $X=297600 $Y=900660
X967 1028 875 1 2 1433 AN2 $T=304420 931280 0 0 $X=304420 $Y=930900
X968 932 38 1 2 1431 AN2 $T=304420 1022000 0 0 $X=304420 $Y=1021620
X969 1432 69 1 2 1478 AN2 $T=308140 870800 0 0 $X=308140 $Y=870420
X970 1439 1466 1 2 1473 AN2 $T=311240 911120 1 0 $X=311240 $Y=905700
X971 1534 77 1 2 1488 AN2 $T=322400 921200 0 180 $X=319920 $Y=915780
X972 1546 1538 1 2 1297 AN2 $T=323640 901040 1 180 $X=321160 $Y=900660
X973 1547 77 1 2 1512 AN2 $T=323640 931280 1 180 $X=321160 $Y=930900
X974 1547 1552 1 2 1491 AN2 $T=325500 921200 1 180 $X=323020 $Y=920820
X975 74 1478 1 2 90 AN2 $T=324880 870800 0 0 $X=324880 $Y=870420
X976 1585 1538 1 2 1422 AN2 $T=327360 890960 1 180 $X=324880 $Y=890580
X977 1534 1552 1 2 1558 AN2 $T=329220 921200 1 180 $X=326740 $Y=920820
X978 1570 1531 1 2 1605 AN2 $T=328600 921200 1 0 $X=328600 $Y=915780
X979 1608 1538 1 2 1517 AN2 $T=333560 901040 1 180 $X=331080 $Y=900660
X980 1621 1538 1 2 1415 AN2 $T=336040 901040 1 180 $X=333560 $Y=900660
X981 1623 908 1 2 1583 AN2 $T=336040 961520 1 180 $X=333560 $Y=961140
X982 1606 1541 1 2 1611 AN2 $T=336040 981680 0 180 $X=333560 $Y=976260
X983 89 90 1 2 93 AN2 $T=335420 870800 0 0 $X=335420 $Y=870420
X984 1635 93 1 2 1642 AN2 $T=338520 870800 0 0 $X=338520 $Y=870420
X985 1644 1570 1 2 1655 AN2 $T=340380 921200 0 0 $X=340380 $Y=920820
X986 1531 1634 1 2 1644 AN2 $T=344720 921200 0 0 $X=344720 $Y=920820
X987 105 1635 1 2 1677 AN2 $T=346580 870800 0 0 $X=346580 $Y=870420
X988 1679 1655 1 2 1700 AN2 $T=350300 921200 0 0 $X=350300 $Y=920820
X989 112 111 1 2 1445 AN2 $T=354640 870800 1 180 $X=352160 $Y=870420
X990 1720 1741 1 2 1734 AN2 $T=360840 880880 1 180 $X=358360 $Y=880500
X991 1727 1700 1 2 1749 AN2 $T=360840 931280 1 0 $X=360840 $Y=925860
X992 119 121 1 2 1753 AN2 $T=360840 1052240 0 0 $X=360840 $Y=1051860
X993 1745 1749 1 2 1771 AN2 $T=365800 921200 0 0 $X=365800 $Y=920820
X994 1776 121 1 2 1808 AN2 $T=370760 1042160 0 0 $X=370760 $Y=1041780
X995 1802 1801 1 2 1781 AN2 $T=375100 1022000 0 180 $X=372620 $Y=1016580
X996 1795 1677 1 2 1818 AN2 $T=376340 921200 0 0 $X=376340 $Y=920820
X997 1786 1806 1 2 1800 AN2 $T=378820 1022000 1 0 $X=378820 $Y=1016580
X998 1825 1818 1 2 1867 AN2 $T=383160 931280 0 0 $X=383160 $Y=930900
X999 1851 1771 1 2 1874 AN2 $T=388740 921200 0 0 $X=388740 $Y=920820
X1000 1863 1865 1 2 1869 AN2 $T=389980 1001840 1 0 $X=389980 $Y=996420
X1001 1868 1869 1 2 1898 AN2 $T=391220 1001840 0 0 $X=391220 $Y=1001460
X1002 1886 1890 1 2 1873 AN2 $T=391220 1022000 0 0 $X=391220 $Y=1021620
X1003 1875 1867 1 2 1935 AN2 $T=393080 931280 0 0 $X=393080 $Y=930900
X1004 1901 1874 1 2 1922 AN2 $T=394940 921200 0 0 $X=394940 $Y=920820
X1005 1906 1766 1 2 1923 AN2 $T=394940 991760 1 0 $X=394940 $Y=986340
X1006 1931 1935 1 2 1948 AN2 $T=399900 921200 0 0 $X=399900 $Y=920820
X1007 1969 1922 1 2 1980 AN2 $T=404860 921200 0 0 $X=404860 $Y=920820
X1008 2031 1948 1 2 2063 AN2 $T=417260 921200 1 0 $X=417260 $Y=915780
X1009 2015 2038 1 2 2055 AN2 $T=417260 941360 1 0 $X=417260 $Y=935940
X1010 2008 2001 1 2 2053 AN2 $T=417260 1042160 1 0 $X=417260 $Y=1036740
X1011 2062 111 1 2 2023 AN2 $T=420980 1022000 0 180 $X=418500 $Y=1016580
X1012 2070 1980 1 2 2084 AN2 $T=421600 921200 1 0 $X=421600 $Y=915780
X1013 1898 2051 1 2 2089 AN2 $T=422220 1001840 0 0 $X=422220 $Y=1001460
X1014 2005 111 1 2 2107 AN2 $T=424080 1011920 0 0 $X=424080 $Y=1011540
X1015 2087 2063 1 2 2129 AN2 $T=427180 890960 0 0 $X=427180 $Y=890580
X1016 2119 2109 1 2 1984 AN2 $T=429660 1022000 0 180 $X=427180 $Y=1016580
X1017 2078 2081 1 2 2116 AN2 $T=427180 1032080 1 0 $X=427180 $Y=1026660
X1018 2115 2121 1 2 194 AN2 $T=430280 870800 0 0 $X=430280 $Y=870420
X1019 2125 2129 1 2 2152 AN2 $T=432140 880880 0 0 $X=432140 $Y=880500
X1020 2041 111 1 2 2158 AN2 $T=433380 1022000 0 0 $X=433380 $Y=1021620
X1021 2026 111 1 2 2154 AN2 $T=434000 1011920 1 0 $X=434000 $Y=1006500
X1022 2147 2141 1 2 2169 AN2 $T=434000 1042160 0 0 $X=434000 $Y=1041780
X1023 2176 2167 1 2 2121 AN2 $T=438340 880880 0 180 $X=435860 $Y=875460
X1024 2156 2152 1 2 2167 AN2 $T=435860 890960 1 0 $X=435860 $Y=885540
X1025 2172 1939 1 2 2039 AN2 $T=438340 941360 1 180 $X=435860 $Y=940980
X1026 2182 2169 1 2 2205 AN2 $T=440820 1042160 0 0 $X=440820 $Y=1041780
X1027 2184 2084 1 2 2208 AN2 $T=442680 921200 0 0 $X=442680 $Y=920820
X1028 2210 1939 1 2 2183 AN2 $T=445160 941360 1 180 $X=442680 $Y=940980
X1029 2180 2089 1 2 2232 AN2 $T=445160 1001840 0 0 $X=445160 $Y=1001460
X1030 2187 2211 1 2 2243 AN2 $T=445780 1011920 1 0 $X=445780 $Y=1006500
X1031 2221 2202 1 2 2135 AN2 $T=449500 1022000 1 180 $X=447020 $Y=1021620
X1032 2200 2208 1 2 2253 AN2 $T=449500 911120 1 0 $X=449500 $Y=905700
X1033 2260 2257 1 2 2305 AN2 $T=454460 1032080 1 0 $X=454460 $Y=1026660
X1034 2284 2202 1 2 2204 AN2 $T=458180 1022000 1 180 $X=455700 $Y=1021620
X1035 2263 2253 1 2 2323 AN2 $T=457560 911120 1 0 $X=457560 $Y=905700
X1036 2251 2205 1 2 2301 AN2 $T=457560 1042160 0 0 $X=457560 $Y=1041780
X1037 2314 2202 1 2 2239 AN2 $T=461900 1022000 1 180 $X=459420 $Y=1021620
X1038 2295 2202 1 2 2320 AN2 $T=465620 1032080 0 180 $X=463140 $Y=1026660
X1039 2309 2330 1 2 2343 AN2 $T=464380 901040 1 0 $X=464380 $Y=895620
X1040 2294 2323 1 2 2330 AN2 $T=464380 911120 1 0 $X=464380 $Y=905700
X1041 2311 2305 1 2 2351 AN2 $T=466240 1032080 0 0 $X=466240 $Y=1031700
X1042 2337 1939 1 2 2357 AN2 $T=466860 951440 1 0 $X=466860 $Y=946020
X1043 2336 2301 1 2 2359 AN2 $T=468100 1042160 1 0 $X=468100 $Y=1036740
X1044 2370 2232 1 2 2392 AN2 $T=473060 1001840 0 0 $X=473060 $Y=1001460
X1045 2365 2359 1 2 2399 AN2 $T=473680 1052240 1 0 $X=473680 $Y=1046820
X1046 2376 2343 1 2 2401 AN2 $T=474920 901040 1 0 $X=474920 $Y=895620
X1047 2394 2351 1 2 2415 AN2 $T=476780 1032080 0 0 $X=476780 $Y=1031700
X1048 2407 2401 1 2 2451 AN2 $T=479880 901040 1 0 $X=479880 $Y=895620
X1049 2425 2415 1 2 2440 AN2 $T=481740 1032080 1 0 $X=481740 $Y=1026660
X1050 2406 2436 1 2 2468 AN2 $T=484840 961520 1 0 $X=484840 $Y=956100
X1051 2458 2453 1 2 2436 AN2 $T=487320 961520 1 180 $X=484840 $Y=961140
X1052 2424 2392 1 2 2459 AN2 $T=484840 1001840 0 0 $X=484840 $Y=1001460
X1053 2441 2399 1 2 2461 AN2 $T=484840 1042160 0 0 $X=484840 $Y=1041780
X1054 2466 2461 1 2 2450 AN2 $T=487940 1042160 0 180 $X=485460 $Y=1036740
X1055 2460 2450 1 2 2488 AN2 $T=486700 1022000 1 0 $X=486700 $Y=1016580
X1056 2478 2488 1 2 2500 AN2 $T=491040 1022000 0 0 $X=491040 $Y=1021620
X1057 2469 2451 1 2 2494 AN2 $T=491660 890960 0 0 $X=491660 $Y=890580
X1058 2525 2520 1 2 2453 AN2 $T=499720 961520 1 180 $X=497240 $Y=961140
X1059 2476 2459 1 2 2529 AN2 $T=497240 1001840 0 0 $X=497240 $Y=1001460
X1060 2522 2535 1 2 2521 AN2 $T=500960 981680 1 180 $X=498480 $Y=981300
X1061 2510 2513 1 2 2535 AN2 $T=498480 991760 1 0 $X=498480 $Y=986340
X1062 2523 2530 1 2 2551 AN2 $T=498480 1011920 1 0 $X=498480 $Y=1006500
X1063 2509 2521 1 2 2561 AN2 $T=500340 971600 0 0 $X=500340 $Y=971220
X1064 232 121 1 2 2543 AN2 $T=504680 870800 1 180 $X=502200 $Y=870420
X1065 2545 2551 1 2 2513 AN2 $T=504680 991760 1 180 $X=502200 $Y=991380
X1066 2557 2500 1 2 2530 AN2 $T=504680 1011920 1 180 $X=502200 $Y=1011540
X1067 2550 2561 1 2 2520 AN2 $T=504060 971600 0 0 $X=504060 $Y=971220
X1068 2536 2580 1 2 2586 AN2 $T=506540 1032080 0 0 $X=506540 $Y=1031700
X1069 2552 2440 1 2 2580 AN2 $T=507160 1022000 0 0 $X=507160 $Y=1021620
X1070 2583 2591 1 2 2613 AN2 $T=509020 971600 0 0 $X=509020 $Y=971220
X1071 2567 2529 1 2 2606 AN2 $T=509020 1001840 0 0 $X=509020 $Y=1001460
X1072 2589 2586 1 2 2604 AN2 $T=509020 1032080 0 0 $X=509020 $Y=1031700
X1073 2594 2604 1 2 2628 AN2 $T=510880 1022000 0 0 $X=510880 $Y=1021620
X1074 2610 2623 1 2 2472 AN2 $T=515220 991760 1 180 $X=512740 $Y=991380
X1075 2625 2619 1 2 2563 AN2 $T=515840 890960 1 180 $X=513360 $Y=890580
X1076 2636 2629 1 2 2619 AN2 $T=516460 901040 0 180 $X=513980 $Y=895620
X1077 2620 2621 1 2 2629 AN2 $T=513980 911120 1 0 $X=513980 $Y=905700
X1078 2637 2630 1 2 2621 AN2 $T=516460 911120 1 180 $X=513980 $Y=910740
X1079 2622 2613 1 2 2623 AN2 $T=513980 981680 0 0 $X=513980 $Y=981300
X1080 2617 2631 1 2 2651 AN2 $T=515840 931280 0 0 $X=515840 $Y=930900
X1081 2656 2651 1 2 2630 AN2 $T=520180 921200 1 180 $X=517700 $Y=920820
X1082 2667 2652 1 2 2631 AN2 $T=520180 941360 0 180 $X=517700 $Y=935940
X1083 2645 2648 1 2 2654 AN2 $T=517700 951440 1 0 $X=517700 $Y=946020
X1084 2639 2649 1 2 2648 AN2 $T=517700 961520 0 0 $X=517700 $Y=961140
X1085 2635 2606 1 2 2649 AN2 $T=517700 991760 0 0 $X=517700 $Y=991380
X1086 2664 2670 1 2 2681 AN2 $T=520800 1011920 1 0 $X=520800 $Y=1006500
X1087 2675 2680 1 2 2697 AN2 $T=522660 981680 1 0 $X=522660 $Y=976260
X1088 2663 2676 1 2 2680 AN2 $T=522660 991760 1 0 $X=522660 $Y=986340
X1089 2692 2683 1 2 2676 AN2 $T=525140 991760 1 180 $X=522660 $Y=991380
X1090 2672 2681 1 2 2683 AN2 $T=522660 1001840 0 0 $X=522660 $Y=1001460
X1091 2638 2628 1 2 2698 AN2 $T=523900 1022000 0 0 $X=523900 $Y=1021620
X1092 240 121 1 2 2553 AN2 $T=527000 880880 0 180 $X=524520 $Y=875460
X1093 2703 2697 1 2 2591 AN2 $T=527000 971600 1 180 $X=524520 $Y=971220
X1094 2687 2698 1 2 2670 AN2 $T=528240 1011920 1 180 $X=525760 $Y=1011540
X1095 2689 2654 1 2 2719 AN2 $T=527000 951440 1 0 $X=527000 $Y=946020
X1096 2721 2725 1 2 2652 AN2 $T=530720 931280 0 0 $X=530720 $Y=930900
X1097 2722 2727 1 2 2725 AN2 $T=533820 941360 0 180 $X=531340 $Y=935940
X1098 2739 2719 1 2 2727 AN2 $T=533820 941360 1 180 $X=531340 $Y=940980
X1099 251 121 1 2 2754 AN2 $T=554280 901040 0 180 $X=551800 $Y=895620
X1100 2837 121 1 2 2700 AN2 $T=555520 911120 0 180 $X=553040 $Y=905700
X1101 2855 121 1 2 2705 AN2 $T=559240 911120 0 180 $X=556760 $Y=905700
X1102 2867 121 1 2 2673 AN2 $T=559240 921200 0 180 $X=556760 $Y=915780
X1103 2858 121 1 2 2761 AN2 $T=559240 931280 1 180 $X=556760 $Y=930900
X1104 252 121 1 2 2758 AN2 $T=560480 1042160 1 180 $X=558000 $Y=1041780
X1105 2863 121 1 2 2794 AN2 $T=564200 941360 0 180 $X=561720 $Y=935940
X1106 2880 121 1 2 2801 AN2 $T=566680 951440 1 180 $X=564200 $Y=951060
X1107 2870 121 1 2 2817 AN2 $T=571020 1032080 0 180 $X=568540 $Y=1026660
X1108 2897 121 1 2 2735 AN2 $T=571020 1032080 1 180 $X=568540 $Y=1031700
X1109 2893 121 1 2 2821 AN2 $T=572880 971600 0 180 $X=570400 $Y=966180
X1110 2910 121 1 2 2844 AN2 $T=574740 981680 1 180 $X=572260 $Y=981300
X1111 2852 121 1 2 2878 AN2 $T=573500 1001840 0 0 $X=573500 $Y=1001460
X1112 2928 2912 1 2 2999 AN2 $T=590860 1032080 1 0 $X=590860 $Y=1026660
X1113 3052 3038 1 2 3040 AN2 $T=606980 971600 1 180 $X=604500 $Y=971220
X1114 3096 3004 1 2 282 AN2 $T=613180 991760 1 180 $X=610700 $Y=991380
X1115 3096 3004 1 2 291 AN2 $T=613180 991760 0 0 $X=613180 $Y=991380
X1116 3053 3126 1 2 3072 AN2 $T=618760 1032080 0 180 $X=616280 $Y=1026660
X1117 3169 3178 1 2 3144 AN2 $T=628060 890960 0 0 $X=628060 $Y=890580
X1118 3134 3141 1 2 3173 AN2 $T=639840 921200 1 0 $X=639840 $Y=915780
X1119 3173 3083 1 2 3174 AN2 $T=642940 911120 0 0 $X=642940 $Y=910740
X1120 3250 333 1 2 339 AN2 $T=643560 870800 0 0 $X=643560 $Y=870420
X1121 3292 3219 1 2 3349 AN2 $T=655960 981680 0 180 $X=653480 $Y=976260
X1122 355 3446 1 2 3448 AN2 $T=680140 991760 0 180 $X=677660 $Y=986340
X1123 355 3465 1 2 3442 AN2 $T=683240 981680 1 180 $X=680760 $Y=981300
X1124 3471 356 1 2 3502 AN2 $T=685720 1001840 0 0 $X=685720 $Y=1001460
X1125 3502 364 1 2 3520 AN2 $T=687580 1001840 1 0 $X=687580 $Y=996420
X1126 3501 363 1 2 3552 AN2 $T=689440 991760 1 0 $X=689440 $Y=986340
X1127 3520 369 1 2 3501 AN2 $T=693780 1001840 0 180 $X=691300 $Y=996420
X1128 375 3536 1 2 3532 AN2 $T=695020 1052240 1 180 $X=692540 $Y=1051860
X1129 3516 373 1 2 3539 AN2 $T=694400 1062320 1 0 $X=694400 $Y=1056900
X1130 3552 379 1 2 3534 AN2 $T=698740 981680 0 180 $X=696260 $Y=976260
X1131 3574 3549 1 2 3583 AN2 $T=704940 1011920 1 0 $X=704940 $Y=1006500
X1132 3597 3213 1 2 3581 AN2 $T=708660 901040 0 180 $X=706180 $Y=895620
X1133 3590 3170 1 2 3602 AN2 $T=709900 890960 1 0 $X=709900 $Y=885540
X1134 3602 3199 1 2 392 AN2 $T=711760 880880 0 0 $X=711760 $Y=880500
X1135 3581 3179 1 2 3590 AN2 $T=711760 901040 1 0 $X=711760 $Y=895620
X1136 3610 3241 1 2 3597 AN2 $T=715480 911120 0 180 $X=713000 $Y=905700
X1137 3623 3245 1 2 3610 AN2 $T=717340 911120 1 180 $X=714860 $Y=910740
X1138 3612 3264 1 2 3623 AN2 $T=714860 931280 1 0 $X=714860 $Y=925860
X1139 396 395 1 2 3613 AN2 $T=717340 1062320 0 180 $X=714860 $Y=1056900
X1140 3616 3619 1 2 3625 AN2 $T=715480 1001840 1 0 $X=715480 $Y=996420
X1141 3628 3247 1 2 3612 AN2 $T=719200 931280 1 180 $X=716720 $Y=930900
X1142 3635 3237 1 2 3628 AN2 $T=721680 941360 1 0 $X=721680 $Y=935940
X1143 3651 3650 1 2 3660 AN2 $T=726640 1001840 0 0 $X=726640 $Y=1001460
X1144 3674 3667 1 2 3689 AN2 $T=733460 1001840 0 0 $X=733460 $Y=1001460
X1145 405 3697 1 2 3665 AN2 $T=735320 1062320 1 0 $X=735320 $Y=1056900
X1146 3739 3749 1 2 3722 AN2 $T=751440 1001840 0 180 $X=748960 $Y=996420
X1147 441 3772 1 2 3752 AN2 $T=756400 1052240 1 180 $X=753920 $Y=1051860
X1148 3785 3784 1 2 3811 AN2 $T=765700 1011920 1 0 $X=765700 $Y=1006500
X1149 458 3836 1 2 3843 AN2 $T=776240 1052240 0 0 $X=776240 $Y=1051860
X1150 3833 3812 1 2 3851 AN2 $T=777480 1011920 1 0 $X=777480 $Y=1006500
X1151 3874 3860 1 2 3894 AN2 $T=789880 1001840 0 0 $X=789880 $Y=1001460
X1152 470 3886 1 2 3870 AN2 $T=791740 1052240 1 0 $X=791740 $Y=1046820
X1153 3897 3893 1 2 3888 AN2 $T=796080 1042160 0 180 $X=793600 $Y=1036740
X1154 3942 3893 1 2 3923 AN2 $T=805380 1032080 0 180 $X=802900 $Y=1026660
X1155 3936 3945 1 2 3951 AN2 $T=807860 1011920 1 0 $X=807860 $Y=1006500
X1156 3932 3893 1 2 3970 AN2 $T=820260 961520 0 180 $X=817780 $Y=956100
X1157 3954 3893 1 2 3987 AN2 $T=822740 981680 1 0 $X=822740 $Y=976260
X1158 505 3988 1 2 3994 AN2 $T=823980 1062320 1 0 $X=823980 $Y=1056900
X1159 3992 3893 1 2 4005 AN2 $T=826460 991760 0 0 $X=826460 $Y=991380
X1160 4001 3893 1 2 3996 AN2 $T=827700 1042160 0 0 $X=827700 $Y=1041780
X1161 4039 4035 1 2 438 AN2 $T=840100 931280 0 180 $X=837620 $Y=925860
X1162 4027 4028 1 2 385 AN2 $T=840720 1001840 0 180 $X=838240 $Y=996420
X1163 4031 3893 1 2 4048 AN2 $T=839480 971600 1 0 $X=839480 $Y=966180
X1164 4055 4028 1 2 367 AN2 $T=843820 991760 1 180 $X=841340 $Y=991380
X1165 4039 4027 1 2 434 AN2 $T=844440 931280 0 0 $X=844440 $Y=930900
X1166 4034 4055 1 2 3716 AN2 $T=844440 961520 0 0 $X=844440 $Y=961140
X1167 4027 522 1 2 3558 AN2 $T=844440 981680 0 0 $X=844440 $Y=981300
X1168 4039 4054 1 2 440 AN2 $T=846300 931280 1 0 $X=846300 $Y=925860
X1169 522 4055 1 2 3522 AN2 $T=848160 991760 1 0 $X=848160 $Y=986340
X1170 4038 4088 1 2 4067 AN2 $T=853740 1032080 0 180 $X=851260 $Y=1026660
X1171 4114 3893 1 2 4083 AN2 $T=859320 961520 1 0 $X=859320 $Y=956100
X1172 4159 4117 1 2 4134 AN2 $T=870480 1011920 1 180 $X=868000 $Y=1011540
X1173 4146 3893 1 2 4152 AN2 $T=872340 951440 0 180 $X=869860 $Y=946020
X1174 4142 3893 1 2 4132 AN2 $T=869860 1032080 0 0 $X=869860 $Y=1031700
X1175 4168 4166 1 2 4120 AN2 $T=874820 1022000 1 180 $X=872340 $Y=1021620
X1176 4177 3893 1 2 4174 AN2 $T=876060 961520 1 0 $X=876060 $Y=956100
X1177 4182 4201 1 2 4196 AN2 $T=882260 1022000 0 180 $X=879780 $Y=1016580
X1178 4246 3893 1 2 4240 AN2 $T=899620 971600 1 180 $X=897140 $Y=971220
X1179 4274 4269 1 2 4262 AN2 $T=902720 1022000 1 180 $X=900240 $Y=1021620
X1180 4314 3893 1 2 4297 AN2 $T=909540 991760 0 180 $X=907060 $Y=986340
X1181 4328 4327 1 2 4320 AN2 $T=918840 1011920 1 180 $X=916360 $Y=1011540
X1182 4361 4360 1 2 4353 AN2 $T=931860 870800 1 180 $X=929380 $Y=870420
X1183 4437 4388 1 2 4350 AN2 $T=946120 951440 0 180 $X=943640 $Y=946020
X1184 597 595 1 2 4430 AN2 $T=952320 1062320 0 180 $X=949840 $Y=1056900
X1185 4461 4388 1 2 4398 AN2 $T=955420 941360 0 180 $X=952940 $Y=935940
X1186 4467 4465 1 2 4380 AN2 $T=957280 901040 1 180 $X=954800 $Y=900660
X1187 4457 4388 1 2 4462 AN2 $T=957280 971600 0 180 $X=954800 $Y=966180
X1188 4474 4471 1 2 4396 AN2 $T=958520 941360 1 180 $X=956040 $Y=940980
X1189 4477 4473 1 2 4381 AN2 $T=959140 911120 1 180 $X=956660 $Y=910740
X1190 4483 4479 1 2 4374 AN2 $T=962860 890960 0 180 $X=960380 $Y=885540
X1191 4488 4486 1 2 4387 AN2 $T=964720 991760 0 180 $X=962240 $Y=986340
X1192 4492 4490 1 2 4382 AN2 $T=965960 961520 0 180 $X=963480 $Y=956100
X1193 4522 4466 1 2 4385 AN2 $T=967820 931280 0 180 $X=965340 $Y=925860
X1194 4519 4388 1 2 4510 AN2 $T=971540 991760 0 180 $X=969060 $Y=986340
X1195 4514 4525 1 2 4497 AN2 $T=973400 1032080 0 180 $X=970920 $Y=1026660
X1196 4529 4526 1 2 4429 AN2 $T=974640 1022000 0 180 $X=972160 $Y=1016580
X1197 4518 4527 1 2 4317 AN2 $T=974640 1062320 0 180 $X=972160 $Y=1056900
X1198 4551 4388 1 2 4538 AN2 $T=978980 921200 0 180 $X=976500 $Y=915780
X1199 4541 4388 1 2 4546 AN2 $T=977120 1001840 1 0 $X=977120 $Y=996420
X1200 4530 4547 1 2 4549 AN2 $T=978980 991760 0 0 $X=978980 $Y=991380
X1201 4550 4548 1 2 4311 AN2 $T=981460 1052240 0 180 $X=978980 $Y=1046820
X1202 4506 4554 1 2 4426 AN2 $T=983940 1001840 0 180 $X=981460 $Y=996420
X1203 4612 4388 1 2 4595 AN2 $T=996340 991760 1 180 $X=993860 $Y=991380
X1204 4605 4618 1 2 4586 AN2 $T=1001300 921200 1 180 $X=998820 $Y=920820
X1205 4610 4388 1 2 4633 AN2 $T=1002540 911120 1 0 $X=1002540 $Y=905700
X1206 4642 4636 1 2 4598 AN2 $T=1006880 890960 0 180 $X=1004400 $Y=885540
X1207 4643 4625 1 2 4651 AN2 $T=1006260 1032080 1 0 $X=1006260 $Y=1026660
X1208 4661 4388 1 2 4652 AN2 $T=1013080 890960 0 180 $X=1010600 $Y=885540
X1209 4669 4654 1 2 4624 AN2 $T=1013080 971600 1 180 $X=1010600 $Y=971220
X1210 4657 4650 1 2 4655 AN2 $T=1011840 1011920 0 0 $X=1011840 $Y=1011540
X1211 4637 4388 1 2 4647 AN2 $T=1015560 921200 0 180 $X=1013080 $Y=915780
X1212 4666 4679 1 2 4574 AN2 $T=1023000 901040 0 180 $X=1020520 $Y=895620
X1213 4677 4674 1 2 4685 AN2 $T=1021140 1022000 0 0 $X=1021140 $Y=1021620
X1214 4700 4698 1 2 4688 AN2 $T=1027340 961520 0 0 $X=1027340 $Y=961140
X1215 4721 4726 1 2 4713 AN2 $T=1040980 1032080 0 180 $X=1038500 $Y=1026660
X1216 4737 4739 1 2 4742 AN2 $T=1045320 921200 1 0 $X=1045320 $Y=915780
X1217 4741 4733 1 2 4753 AN2 $T=1047180 890960 0 0 $X=1047180 $Y=890580
X1218 4754 4745 1 2 4735 AN2 $T=1051520 931280 0 180 $X=1049040 $Y=925860
X1219 4776 4768 1 2 4759 AN2 $T=1059580 1011920 1 180 $X=1057100 $Y=1011540
X1220 4796 4788 1 2 4790 AN2 $T=1068260 901040 0 180 $X=1065780 $Y=895620
X1221 4807 4795 1 2 4797 AN2 $T=1071360 1032080 0 180 $X=1068880 $Y=1026660
X1222 4813 4805 1 2 4775 AN2 $T=1071980 971600 1 180 $X=1069500 $Y=971220
X1223 4815 4783 1 2 4816 AN2 $T=1072600 1032080 1 0 $X=1072600 $Y=1026660
X1224 4825 4818 1 2 4836 AN2 $T=1075700 901040 1 0 $X=1075700 $Y=895620
X1225 4838 4819 1 2 667 AN2 $T=1078180 921200 1 180 $X=1075700 $Y=920820
X1226 4847 4839 1 2 4755 AN2 $T=1079420 951440 0 180 $X=1076940 $Y=946020
X1227 4837 4817 1 2 4828 AN2 $T=1079420 931280 0 0 $X=1079420 $Y=930900
X1228 1854 1 2 1816 DELA $T=386260 1022000 0 0 $X=386260 $Y=1021620
X1229 2924 1 2 274 DELA $T=583420 1062320 1 0 $X=583420 $Y=1056900
X1230 2940 1 2 2938 DELA $T=585900 1042160 1 0 $X=585900 $Y=1036740
X1231 2952 1 2 284 DELA $T=589000 1052240 0 0 $X=589000 $Y=1051860
X1232 2988 1 2 2995 DELA $T=596440 961520 1 0 $X=596440 $Y=956100
X1233 3254 1 2 3249 DELA $T=639840 1001840 0 0 $X=639840 $Y=1001460
X1234 3248 1 2 337 DELA $T=640460 1062320 1 0 $X=640460 $Y=1056900
X1235 3285 1 2 3317 DELA $T=645420 1022000 1 0 $X=645420 $Y=1016580
X1236 3308 1 2 3256 DELA $T=649140 1032080 1 0 $X=649140 $Y=1026660
X1237 3406 1 2 3367 DELA $T=667120 1032080 0 0 $X=667120 $Y=1031700
X1238 3456 1 2 3473 DELA $T=675800 971600 1 0 $X=675800 $Y=966180
X1239 3479 1 2 3477 DELA $T=680760 941360 0 0 $X=680760 $Y=940980
X1240 3397 1 2 3483 DELA $T=680760 971600 1 0 $X=680760 $Y=966180
X1241 3498 1 2 3494 DELA $T=686960 971600 1 0 $X=686960 $Y=966180
X1242 1633 1666 110 2 1 1717 QDFFRBN $T=344100 1042160 1 0 $X=344100 $Y=1036740
X1243 1341 1666 110 2 1 1643 QDFFRBN $T=352160 1001840 1 0 $X=352160 $Y=996420
X1244 1669 1666 110 2 1 126 QDFFRBN $T=353400 1001840 0 0 $X=353400 $Y=1001460
X1245 968 1666 110 2 1 1768 QDFFRBN $T=354020 1011920 1 0 $X=354020 $Y=1006500
X1246 1688 1666 110 2 1 129 QDFFRBN $T=354640 991760 1 0 $X=354640 $Y=986340
X1247 1685 1666 110 2 1 1505 QDFFRBN $T=355260 1042160 0 0 $X=355260 $Y=1041780
X1248 1684 1666 110 2 1 1770 QDFFRBN $T=355880 1032080 0 0 $X=355880 $Y=1031700
X1249 1722 115 125 2 1 1776 QDFFRBN $T=355880 1052240 1 0 $X=355880 $Y=1046820
X1250 1444 1666 110 2 1 1702 QDFFRBN $T=357120 1011920 0 0 $X=357120 $Y=1011540
X1251 1487 1666 110 2 1 137 QDFFRBN $T=358980 971600 0 0 $X=358980 $Y=971220
X1252 1740 115 110 2 1 1780 QDFFRBN $T=358980 1032080 1 0 $X=358980 $Y=1026660
X1253 1395 1666 110 2 1 138 QDFFRBN $T=361460 971600 1 0 $X=361460 $Y=966180
X1254 1575 1666 110 2 1 144 QDFFRBN $T=362080 981680 0 0 $X=362080 $Y=981300
X1255 1816 115 110 2 1 1765 QDFFRBN $T=378820 1011920 0 180 $X=367040 $Y=1006500
X1256 1295 1666 110 2 1 1774 QDFFRBN $T=367660 991760 0 0 $X=367660 $Y=991380
X1257 1428 1666 110 2 1 150 QDFFRBN $T=370140 951440 1 0 $X=370140 $Y=946020
X1258 1508 1666 110 2 1 1826 QDFFRBN $T=370760 991760 1 0 $X=370760 $Y=986340
X1259 2809 115 249 2 1 246 QDFFRBN $T=551800 870800 1 180 $X=540020 $Y=870420
X1260 2827 115 253 2 1 251 QDFFRBN $T=564820 890960 0 180 $X=553040 $Y=885540
X1261 2830 115 253 2 1 2837 QDFFRBN $T=554900 901040 0 0 $X=554900 $Y=900660
X1262 2810 115 253 2 1 2855 QDFFRBN $T=555520 911120 0 0 $X=555520 $Y=910740
X1263 2843 115 2874 2 1 2858 QDFFRBN $T=556140 931280 1 0 $X=556140 $Y=925860
X1264 2861 115 125 2 1 2863 QDFFRBN $T=559860 941360 0 0 $X=559860 $Y=940980
X1265 2864 255 253 2 1 258 QDFFRBN $T=560480 880880 0 0 $X=560480 $Y=880500
X1266 2853 115 125 2 1 2908 QDFFRBN $T=562340 1062320 1 0 $X=562340 $Y=1056900
X1267 2871 115 2874 2 1 2867 QDFFRBN $T=562960 921200 1 0 $X=562960 $Y=915780
X1268 2872 255 253 2 1 264 QDFFRBN $T=563580 911120 1 0 $X=563580 $Y=905700
X1269 2877 255 2874 2 1 265 QDFFRBN $T=564820 931280 0 0 $X=564820 $Y=930900
X1270 2905 115 125 2 1 2870 QDFFRBN $T=577220 1042160 0 180 $X=565440 $Y=1036740
X1271 2882 115 125 2 1 2880 QDFFRBN $T=566680 951440 0 0 $X=566680 $Y=951060
X1272 2883 255 253 2 1 261 QDFFRBN $T=567300 880880 1 0 $X=567300 $Y=875460
X1273 2879 255 125 2 1 266 QDFFRBN $T=567300 941360 1 0 $X=567300 $Y=935940
X1274 2886 255 253 2 1 2915 QDFFRBN $T=567920 931280 1 0 $X=567920 $Y=925860
X1275 2889 255 253 2 1 267 QDFFRBN $T=569780 911120 0 0 $X=569780 $Y=910740
X1276 2895 255 253 2 1 268 QDFFRBN $T=572260 870800 0 0 $X=572260 $Y=870420
X1277 2900 255 253 2 1 275 QDFFRBN $T=573500 890960 1 0 $X=573500 $Y=885540
X1278 2903 115 125 2 1 2931 QDFFRBN $T=574120 981680 1 0 $X=574120 $Y=976260
X1279 2904 115 125 2 1 2910 QDFFRBN $T=574740 991760 1 0 $X=574740 $Y=986340
X1280 2935 270 125 2 1 2902 QDFFRBN $T=586520 1022000 1 180 $X=574740 $Y=1021620
X1281 2896 255 253 2 1 272 QDFFRBN $T=575360 901040 0 0 $X=575360 $Y=900660
X1282 2938 270 125 2 1 2894 QDFFRBN $T=587140 1032080 1 180 $X=575360 $Y=1031700
X1283 2901 115 125 2 1 2852 QDFFRBN $T=587760 1001840 1 180 $X=575980 $Y=1001460
X1284 2890 115 125 2 1 2891 QDFFRBN $T=576600 1011920 1 0 $X=576600 $Y=1006500
X1285 2962 273 125 2 1 2909 QDFFRBN $T=589620 951440 0 180 $X=577840 $Y=946020
X1286 2971 273 2874 2 1 262 QDFFRBN $T=590240 921200 0 180 $X=578460 $Y=915780
X1287 2974 273 125 2 1 2917 QDFFRBN $T=591480 931280 0 180 $X=579700 $Y=925860
X1288 2959 273 125 2 1 2913 QDFFRBN $T=591480 961520 1 180 $X=579700 $Y=961140
X1289 2941 273 253 2 1 2992 QDFFRBN $T=585900 880880 1 0 $X=585900 $Y=875460
X1290 2949 270 125 2 1 3004 QDFFRBN $T=587760 1001840 0 0 $X=587760 $Y=1001460
X1291 2954 273 125 2 1 3012 QDFFRBN $T=589000 981680 1 0 $X=589000 $Y=976260
X1292 2975 273 125 2 1 3038 QDFFRBN $T=593340 991760 0 0 $X=593340 $Y=991380
X1293 3010 2977 125 2 1 3078 QDFFRBN $T=599540 1001840 0 0 $X=599540 $Y=1001460
X1294 3019 2977 125 2 1 3103 QDFFRBN $T=603260 1022000 1 0 $X=603260 $Y=1016580
X1295 3301 270 125 2 1 3219 QDFFRBN $T=646040 981680 1 180 $X=634260 $Y=981300
X1296 3379 273 125 2 1 3260 QDFFRBN $T=662160 1022000 0 180 $X=650380 $Y=1016580
X1297 3389 273 125 2 1 3293 QDFFRBN $T=665260 991760 0 180 $X=653480 $Y=986340
X1298 3393 273 125 2 1 3284 QDFFRBN $T=665260 1011920 1 180 $X=653480 $Y=1011540
X1299 3409 273 125 2 1 3096 QDFFRBN $T=668360 991760 1 180 $X=656580 $Y=991380
X1300 3405 273 125 2 1 3254 QDFFRBN $T=668360 1001840 1 180 $X=656580 $Y=1001460
X1301 3404 273 125 2 1 3308 QDFFRBN $T=675800 1032080 0 180 $X=664020 $Y=1026660
X1302 3443 273 125 2 1 3378 QDFFRBN $T=676420 1042160 1 180 $X=664640 $Y=1041780
X1303 3473 270 253 2 1 3225 QDFFRBN $T=680140 961520 1 180 $X=668360 $Y=961140
X1304 3477 270 253 2 1 3430 QDFFRBN $T=682000 951440 1 180 $X=670220 $Y=951060
X1305 3470 273 125 2 1 3406 QDFFRBN $T=685720 1042160 0 180 $X=673940 $Y=1036740
X1306 3547 270 253 2 1 3213 QDFFRBN $T=696260 901040 0 0 $X=696260 $Y=900660
X1307 3540 270 253 2 1 3179 QDFFRBN $T=696880 890960 0 0 $X=696880 $Y=890580
X1308 3561 270 253 2 1 3594 QDFFRBN $T=698740 880880 0 0 $X=698740 $Y=880500
X1309 3554 270 253 2 1 3592 QDFFRBN $T=698740 911120 1 0 $X=698740 $Y=905700
X1310 3582 270 253 2 1 3238 QDFFRBN $T=710520 961520 0 180 $X=698740 $Y=956100
X1311 383 270 253 2 1 314 QDFFRBN $T=699360 870800 0 0 $X=699360 $Y=870420
X1312 3428 270 253 2 1 3599 QDFFRBN $T=699980 880880 1 0 $X=699980 $Y=875460
X1313 3571 270 253 2 1 3604 QDFFRBN $T=701840 911120 0 0 $X=701840 $Y=910740
X1314 3584 270 253 2 1 3615 QDFFRBN $T=706800 921200 1 0 $X=706800 $Y=915780
X1315 3586 270 253 2 1 3247 QDFFRBN $T=707420 941360 1 0 $X=707420 $Y=935940
X1316 3596 270 253 2 1 3605 QDFFRBN $T=709900 941360 0 0 $X=709900 $Y=940980
X1317 3601 270 253 2 1 3257 QDFFRBN $T=711140 961520 1 0 $X=711140 $Y=956100
X1318 3624 397 253 2 1 3659 QDFFRBN $T=717340 901040 0 0 $X=717340 $Y=900660
X1319 3629 397 253 2 1 3663 QDFFRBN $T=719200 890960 1 0 $X=719200 $Y=885540
X1320 3580 397 253 2 1 3658 QDFFRBN $T=719200 890960 0 0 $X=719200 $Y=890580
X1321 3639 397 253 2 1 3670 QDFFRBN $T=721060 921200 0 0 $X=721060 $Y=920820
X1322 3644 397 253 2 1 3677 QDFFRBN $T=722920 880880 0 0 $X=722920 $Y=880500
X1323 3636 397 253 2 1 3687 QDFFRBN $T=723540 911120 1 0 $X=723540 $Y=905700
X1324 3646 397 253 2 1 3708 QDFFRBN $T=724160 870800 0 0 $X=724160 $Y=870420
X1325 3611 397 253 2 1 3702 QDFFRBN $T=725400 921200 1 0 $X=725400 $Y=915780
X1326 3643 397 253 2 1 3703 QDFFRBN $T=726020 931280 1 0 $X=726020 $Y=925860
X1327 3657 397 253 2 1 3707 QDFFRBN $T=727260 941360 1 0 $X=727260 $Y=935940
X1328 1075 1167 1171 2 1184 1147 1 AO22 $T=269700 901040 1 0 $X=269700 $Y=895620
X1329 1077 1167 1262 2 1272 1147 1 AO22 $T=281480 890960 1 0 $X=281480 $Y=885540
X1330 1510 71 79 2 1489 66 1 AO22 $T=327980 880880 0 180 $X=323020 $Y=875460
X1331 1483 1505 1556 2 1572 1147 1 AO22 $T=324880 911120 1 0 $X=324880 $Y=905700
X1332 1545 66 84 2 1580 71 1 AO22 $T=332940 880880 0 180 $X=327980 $Y=875460
X1333 1560 1505 1613 2 1629 1147 1 AO22 $T=333560 911120 0 0 $X=333560 $Y=910740
X1334 1602 95 1619 2 92 71 1 AO22 $T=341000 880880 1 180 $X=336040 $Y=880500
X1335 1596 1665 1662 2 1674 1147 1 AO22 $T=344720 911120 0 0 $X=344720 $Y=910740
X1336 1522 95 1651 2 108 71 1 AO22 $T=345960 880880 1 0 $X=345960 $Y=875460
X1337 1516 1665 1709 2 1718 1147 1 AO22 $T=352780 911120 0 0 $X=352780 $Y=910740
X1338 1703 1665 1757 2 1735 1147 1 AO22 $T=366420 911120 1 180 $X=361460 $Y=910740
X1339 1708 95 1777 2 1783 71 1 AO22 $T=367040 921200 1 0 $X=367040 $Y=915780
X1340 1792 95 1814 2 146 71 1 AO22 $T=380060 921200 0 180 $X=375100 $Y=915780
X1341 1789 1665 1832 2 1844 1147 1 AO22 $T=381300 921200 1 0 $X=381300 $Y=915780
X1342 1864 95 1862 2 162 71 1 AO22 $T=388120 921200 1 0 $X=388120 $Y=915780
X1343 1872 1665 1914 2 1897 1147 1 AO22 $T=399280 911120 1 180 $X=394320 $Y=910740
X1344 1985 95 1952 2 176 71 1 AO22 $T=407960 921200 0 180 $X=403000 $Y=915780
X1345 2006 1665 2002 2 1937 1147 1 AO22 $T=413540 921200 0 180 $X=408580 $Y=915780
X1346 2111 95 2047 2 2020 71 1 AO22 $T=420360 911120 1 180 $X=415400 $Y=910740
X1347 1882 1505 2064 2 2090 1936 1 AO22 $T=422220 1042160 1 0 $X=422220 $Y=1036740
X1348 2117 1665 2094 2 2048 1147 1 AO22 $T=429660 921200 0 180 $X=424700 $Y=915780
X1349 2088 1899 2120 2 2107 1959 1 AO22 $T=432760 1052240 0 180 $X=427800 $Y=1046820
X1350 2177 95 2105 2 2099 71 1 AO22 $T=435860 901040 0 180 $X=430900 $Y=895620
X1351 2171 95 2138 2 193 71 1 AO22 $T=438340 870800 1 180 $X=433380 $Y=870420
X1352 2207 95 2146 2 192 71 1 AO22 $T=441440 890960 1 180 $X=436480 $Y=890580
X1353 2196 1665 2166 2 2073 1147 1 AO22 $T=442680 911120 0 180 $X=437720 $Y=905700
X1354 203 128 2162 2 2183 1820 1 AO22 $T=443920 1011920 0 180 $X=438960 $Y=1006500
X1355 2082 1505 2195 2 2204 1936 1 AO22 $T=440820 1032080 0 0 $X=440820 $Y=1031700
X1356 207 1899 2170 2 2154 1959 1 AO22 $T=445780 1052240 0 180 $X=440820 $Y=1046820
X1357 2240 95 2197 2 2065 71 1 AO22 $T=450120 880880 0 180 $X=445160 $Y=875460
X1358 2241 95 2198 2 196 71 1 AO22 $T=450120 890960 0 180 $X=445160 $Y=885540
X1359 2193 1665 2223 2 2075 1147 1 AO22 $T=450120 901040 1 180 $X=445160 $Y=900660
X1360 205 1505 2233 2 2239 1936 1 AO22 $T=446400 1042160 1 0 $X=446400 $Y=1036740
X1361 2254 1899 2234 2 2158 1959 1 AO22 $T=451980 1052240 0 180 $X=447020 $Y=1046820
X1362 2265 1665 2246 2 1972 1147 1 AO22 $T=456940 901040 1 180 $X=451980 $Y=900660
X1363 2287 1899 2270 2 2102 1959 1 AO22 $T=458800 1052240 0 180 $X=453840 $Y=1046820
X1364 2269 1665 2303 2 2007 1147 1 AO22 $T=458800 901040 1 0 $X=458800 $Y=895620
X1365 2261 2306 2290 2 2320 1936 1 AO22 $T=460040 1042160 1 0 $X=460040 $Y=1036740
X1366 2285 1665 2331 2 2024 1147 1 AO22 $T=468100 890960 1 180 $X=463140 $Y=890580
X1367 2360 1899 2315 2 2131 1959 1 AO22 $T=470580 1052240 0 180 $X=465620 $Y=1046820
X1368 2384 1665 2352 2 2095 1147 1 AO22 $T=474300 890960 0 180 $X=469340 $Y=885540
X1369 2355 2306 2375 2 2358 1936 1 AO22 $T=471200 1042160 1 0 $X=471200 $Y=1036740
X1370 2429 2306 2416 2 2382 1936 1 AO22 $T=482360 1042160 0 180 $X=477400 $Y=1036740
X1371 2496 1899 2379 2 2145 1959 1 AO22 $T=484220 1052240 0 180 $X=479260 $Y=1046820
X1372 2318 2431 2432 2 2201 1959 1 AO22 $T=484840 951440 1 180 $X=479880 $Y=951060
X1373 2477 128 2404 2 2421 1820 1 AO22 $T=489180 1011920 0 180 $X=484220 $Y=1006500
X1374 226 2467 1665 2 2104 1147 1 AO22 $T=489800 880880 1 180 $X=484840 $Y=880500
X1375 2321 2482 2306 2 2473 1936 1 AO22 $T=492900 971600 0 180 $X=487940 $Y=966180
X1376 2508 128 2486 2 2457 1820 1 AO22 $T=495380 1011920 0 180 $X=490420 $Y=1006500
X1377 2507 2306 2501 2 2475 1936 1 AO22 $T=496000 981680 1 180 $X=491040 $Y=981300
X1378 2516 1899 2479 2 2098 1959 1 AO22 $T=497860 1032080 1 180 $X=492900 $Y=1031700
X1379 2537 1899 2490 2 2143 1959 1 AO22 $T=500340 1042160 0 180 $X=495380 $Y=1036740
X1380 2541 2432 2515 2 2178 1959 1 AO22 $T=500960 1022000 1 180 $X=496000 $Y=1021620
X1381 2542 1899 2491 2 2103 1959 1 AO22 $T=500960 1052240 0 180 $X=496000 $Y=1046820
X1382 2533 2559 2511 2 2534 1820 1 AO22 $T=505300 890960 1 180 $X=500340 $Y=890580
X1383 2547 2306 2558 2 2447 1936 1 AO22 $T=505920 1032080 1 180 $X=500960 $Y=1031700
X1384 2578 2432 2527 2 2186 1959 1 AO22 $T=506540 991760 0 180 $X=501580 $Y=986340
X1385 2556 2306 2566 2 2393 1936 1 AO22 $T=506540 1042160 0 180 $X=501580 $Y=1036740
X1386 2602 2432 2565 2 2150 1959 1 AO22 $T=510880 1001840 0 180 $X=505920 $Y=996420
X1387 2644 2432 2512 2 2161 1959 1 AO22 $T=510880 1011920 0 180 $X=505920 $Y=1006500
X1388 2548 2559 2590 2 2577 1820 1 AO22 $T=512120 890960 1 180 $X=507160 $Y=890580
X1389 2502 2306 2593 2 2464 1936 1 AO22 $T=507780 991760 1 0 $X=507780 $Y=986340
X1390 2614 2432 2571 2 2108 1959 1 AO22 $T=513360 981680 1 180 $X=508400 $Y=981300
X1391 2618 2432 2575 2 2179 1959 1 AO22 $T=513980 1022000 0 180 $X=509020 $Y=1016580
X1392 2627 2559 2605 2 2569 1820 1 AO22 $T=514600 931280 0 180 $X=509640 $Y=925860
X1393 2642 2559 2626 2 2611 1820 1 AO22 $T=517700 921200 1 180 $X=512740 $Y=920820
X1394 2650 2559 2615 2 2518 1820 1 AO22 $T=518320 1001840 1 180 $X=513360 $Y=1001460
X1395 2668 2559 2603 2 2492 1820 1 AO22 $T=519560 1011920 1 180 $X=514600 $Y=1011540
X1396 2633 2306 2641 2 2383 1936 1 AO22 $T=519560 1032080 1 180 $X=514600 $Y=1031700
X1397 2662 2306 2596 2 2470 1936 1 AO22 $T=521420 981680 0 180 $X=516460 $Y=976260
X1398 2679 2306 2624 2 2438 1936 1 AO22 $T=522660 1032080 0 180 $X=517700 $Y=1026660
X1399 2674 2306 2632 2 2463 1936 1 AO22 $T=523280 971600 1 180 $X=518320 $Y=971220
X1400 2684 2559 2643 2 2609 1820 1 AO22 $T=524520 890960 1 180 $X=519560 $Y=890580
X1401 2695 2559 2671 2 2526 1820 1 AO22 $T=525760 951440 0 180 $X=520800 $Y=946020
X1402 2741 2306 2653 2 2449 1936 1 AO22 $T=525760 1022000 0 180 $X=520800 $Y=1016580
X1403 2706 2559 2691 2 2554 1820 1 AO22 $T=527620 941360 0 180 $X=522660 $Y=935940
X1404 2661 2559 2640 2 2601 1820 1 AO22 $T=523280 921200 0 0 $X=523280 $Y=920820
X1405 2736 2559 2665 2 2612 1820 1 AO22 $T=529480 901040 0 180 $X=524520 $Y=895620
X1406 2733 2559 2685 2 2570 1820 1 AO22 $T=533200 971600 0 180 $X=528240 $Y=966180
X1407 2740 2306 2715 2 2445 1936 1 AO22 $T=533820 971600 1 180 $X=528860 $Y=971220
X1408 2770 2306 2731 2 2418 1936 1 AO22 $T=534440 1011920 1 180 $X=529480 $Y=1011540
X1409 2747 2559 2707 2 2497 1820 1 AO22 $T=535680 951440 0 180 $X=530720 $Y=946020
X1410 2738 2306 2712 2 2433 1936 1 AO22 $T=535680 981680 1 180 $X=530720 $Y=981300
X1411 2748 2306 2713 2 2411 1936 1 AO22 $T=535680 1001840 1 180 $X=530720 $Y=1001460
X1412 2757 2306 2717 2 2483 1936 1 AO22 $T=536300 991760 1 180 $X=531340 $Y=991380
X1413 2752 2306 2708 2 2413 1936 1 AO22 $T=536300 1011920 0 180 $X=531340 $Y=1006500
X1414 2759 2306 2716 2 2446 1936 1 AO22 $T=536920 991760 0 180 $X=531960 $Y=986340
X1415 2774 2559 2734 2 2587 1820 1 AO22 $T=539400 931280 1 180 $X=534440 $Y=930900
X1416 2787 2559 2767 2 2599 1820 1 AO22 $T=542500 951440 0 180 $X=537540 $Y=946020
X1417 2788 2559 2779 2 2595 1820 1 AO22 $T=542500 961520 0 180 $X=537540 $Y=956100
X1418 2851 121 2891 2 259 242 1 AO22 $T=569160 951440 1 0 $X=569160 $Y=946020
X1419 2924 279 281 2 2961 282 1 AO22 $T=588380 1062320 1 0 $X=588380 $Y=1056900
X1420 2935 279 2982 2 2946 282 1 AO22 $T=592720 1022000 1 0 $X=592720 $Y=1016580
X1421 2952 279 2907 2 2996 282 1 AO22 $T=594580 1062320 1 0 $X=594580 $Y=1056900
X1422 2940 279 2985 2 3000 282 1 AO22 $T=595200 1032080 0 0 $X=595200 $Y=1031700
X1423 313 279 3145 2 3110 282 1 AO22 $T=619380 1062320 1 0 $X=619380 $Y=1056900
X1424 2804 2 2730 2782 2785 1 2827 FA1S $T=543120 880880 0 0 $X=543120 $Y=880500
X1425 269 2 263 2942 2933 1 2907 FA1S $T=588380 1052240 1 180 $X=576600 $Y=1051860
X1426 2929 2 276 2950 2921 1 2964 FA1S $T=579080 911120 1 0 $X=579080 $Y=905700
X1427 2932 2 2909 2920 2937 1 2969 FA1S $T=580940 951440 0 0 $X=580940 $Y=951060
X1428 2933 2 2894 2957 2923 1 2985 FA1S $T=580940 1042160 0 0 $X=580940 $Y=1041780
X1429 2939 2 277 2945 2929 1 2984 FA1S $T=581560 890960 0 0 $X=581560 $Y=890580
X1430 2966 2 290 3001 2939 1 3014 FA1S $T=589000 890960 1 0 $X=589000 $Y=885540
X1431 2927 2 3012 2998 3003 1 2955 FA1S $T=601400 981680 1 180 $X=589620 $Y=981300
X1432 3002 2 295 3035 3017 1 2961 FA1S $T=603260 1052240 0 180 $X=591480 $Y=1046820
X1433 3008 2 2894 2972 2999 1 3000 FA1S $T=595820 1042160 1 0 $X=595820 $Y=1036740
X1434 3017 2 263 2960 3008 1 2996 FA1S $T=596440 1042160 0 0 $X=596440 $Y=1041780
X1435 3037 2 2909 3023 3050 1 2991 FA1S $T=610080 951440 0 180 $X=598300 $Y=946020
X1436 3031 2 3012 3015 3040 1 3092 FA1S $T=598920 971600 1 0 $X=598920 $Y=966180
X1437 3054 2 271 3006 3063 1 3018 FA1S $T=612560 880880 1 180 $X=600780 $Y=880500
X1438 3067 2 299 3033 301 1 310 FA1S $T=604500 1062320 1 0 $X=604500 $Y=1056900
X1439 3085 2 299 3029 3002 1 312 FA1S $T=606980 1052240 0 0 $X=606980 $Y=1051860
X1440 3113 2 302 3062 3054 1 316 FA1S $T=611940 880880 1 0 $X=611940 $Y=875460
X1441 3148 2 317 3163 3085 1 3110 FA1S $T=626820 1042160 1 180 $X=615040 $Y=1041780
X1442 3189 2 317 3203 3067 1 3145 FA1S $T=634880 1052240 1 180 $X=623100 $Y=1051860
X1443 3217 2 3249 3127 3228 1 3171 FA1S $T=638600 1001840 1 180 $X=626820 $Y=1001460
X1444 3210 2 324 3176 3189 1 328 FA1S $T=628680 1062320 1 0 $X=628680 $Y=1056900
X1445 3228 2 3259 3132 3242 1 3269 FA1S $T=632400 1011920 0 0 $X=632400 $Y=1011540
X1446 3233 2 3260 3180 3274 1 3270 FA1S $T=632400 1022000 0 0 $X=632400 $Y=1021620
X1447 3242 2 3260 3197 3232 1 3275 FA1S $T=633640 1022000 1 0 $X=633640 $Y=1016580
X1448 3232 2 3256 3053 3267 1 3281 FA1S $T=633640 1032080 1 0 $X=633640 $Y=1026660
X1449 3253 2 324 3183 3148 1 341 FA1S $T=635500 1052240 1 0 $X=635500 $Y=1046820
X1450 3261 2 3249 3131 3280 1 3319 FA1S $T=638600 1001840 1 0 $X=638600 $Y=996420
X1451 3286 2 342 3246 3253 1 3248 FA1S $T=650380 1052240 1 180 $X=638600 $Y=1051860
X1452 3274 2 3256 3194 3338 1 3330 FA1S $T=639840 1042160 1 0 $X=639840 $Y=1036740
X1453 3280 2 3259 3193 3233 1 3323 FA1S $T=641700 1011920 1 0 $X=641700 $Y=1006500
X1454 3342 2 3361 3251 3286 1 3372 FA1S $T=648520 1042160 0 0 $X=648520 $Y=1041780
X1455 344 2 314 3262 3325 1 346 FA1S $T=649140 870800 0 0 $X=649140 $Y=870420
X1456 3338 2 3367 3236 3342 1 3375 FA1S $T=649140 1032080 0 0 $X=649140 $Y=1031700
X1457 3356 2 3225 3316 3349 1 3388 FA1S $T=652240 971600 0 0 $X=652240 $Y=971220
X1458 3357 2 342 3347 3210 1 347 FA1S $T=652240 1062320 1 0 $X=652240 $Y=1056900
X1459 3267 2 3367 3350 3392 1 3381 FA1S $T=657820 1042160 1 0 $X=657820 $Y=1036740
X1460 3387 2 3225 3334 3380 1 3407 FA1S $T=659060 981680 1 0 $X=659060 $Y=976260
X1461 3392 2 3361 3368 3357 1 3360 FA1S $T=659680 1052240 0 0 $X=659680 $Y=1051860
X1462 3422 2 3179 3384 3414 1 3457 FA1S $T=664640 890960 0 0 $X=664640 $Y=890580
X1463 3383 2 3170 3398 3422 1 3462 FA1S $T=665260 890960 1 0 $X=665260 $Y=885540
X1464 3439 2 3245 3310 3441 1 3472 FA1S $T=667740 921200 1 0 $X=667740 $Y=915780
X1465 3454 2 3237 3431 3452 1 3489 FA1S $T=673320 941360 1 0 $X=673320 $Y=935940
X1466 3476 2 3430 3450 3387 1 3498 FA1S $T=675800 981680 1 0 $X=675800 $Y=976260
X1467 3486 2 3199 3459 3478 1 3394 FA1S $T=688200 880880 1 180 $X=676420 $Y=880500
X1468 3480 2 3241 3485 3505 1 3508 FA1S $T=683240 921200 1 0 $X=683240 $Y=915780
X1469 3519 2 3237 3499 3524 1 3566 FA1S $T=688200 941360 0 0 $X=688200 $Y=940980
X1470 3541 2 3264 3497 3506 1 3575 FA1S $T=691300 931280 1 0 $X=691300 $Y=925860
X1471 703 2 699 1 INV1S $T=220720 981680 0 0 $X=220720 $Y=981300
X1472 708 2 705 1 INV1S $T=222580 931280 0 180 $X=221340 $Y=925860
X1473 727 2 740 1 INV1S $T=222580 961520 0 0 $X=222580 $Y=961140
X1474 728 2 766 1 INV1S $T=223820 971600 1 0 $X=223820 $Y=966180
X1475 758 2 827 1 INV1S $T=230020 991760 1 0 $X=230020 $Y=986340
X1476 868 2 736 1 INV1S $T=233740 951440 0 180 $X=232500 $Y=946020
X1477 855 2 834 1 INV1S $T=233740 991760 0 180 $X=232500 $Y=986340
X1478 852 2 901 1 INV1S $T=233740 981680 1 0 $X=233740 $Y=976260
X1479 881 2 839 1 INV1S $T=236840 961520 1 0 $X=236840 $Y=956100
X1480 904 2 858 1 INV1S $T=238700 931280 1 180 $X=237460 $Y=930900
X1481 793 2 869 1 INV1S $T=237460 961520 0 0 $X=237460 $Y=961140
X1482 780 2 896 1 INV1S $T=240560 981680 0 180 $X=239320 $Y=976260
X1483 926 2 778 1 INV1S $T=241180 901040 1 180 $X=239940 $Y=900660
X1484 859 2 927 1 INV1S $T=239940 951440 0 0 $X=239940 $Y=951060
X1485 892 2 774 1 INV1S $T=240560 951440 1 0 $X=240560 $Y=946020
X1486 737 2 916 1 INV1S $T=241180 991760 1 0 $X=241180 $Y=986340
X1487 979 2 5 1 INV1S $T=245520 1052240 1 180 $X=244280 $Y=1051860
X1488 799 2 984 1 INV1S $T=245520 1042160 1 0 $X=245520 $Y=1036740
X1489 923 2 980 1 INV1S $T=246140 931280 1 0 $X=246140 $Y=925860
X1490 921 2 918 1 INV1S $T=247380 961520 0 180 $X=246140 $Y=956100
X1491 987 2 10 1 INV1S $T=248000 1022000 1 180 $X=246760 $Y=1021620
X1492 989 2 776 1 INV1S $T=248000 941360 0 0 $X=248000 $Y=940980
X1493 998 2 920 1 INV1S $T=249240 1042160 1 180 $X=248000 $Y=1041780
X1494 4 2 934 1 INV1S $T=248620 951440 1 0 $X=248620 $Y=946020
X1495 999 2 884 1 INV1S $T=250480 931280 1 180 $X=249240 $Y=930900
X1496 1011 2 789 1 INV1S $T=250480 981680 1 180 $X=249240 $Y=981300
X1497 870 2 943 1 INV1S $T=249240 1042160 1 0 $X=249240 $Y=1036740
X1498 1055 2 743 1 INV1S $T=252340 981680 1 180 $X=251100 $Y=981300
X1499 973 2 1031 1 INV1S $T=251720 911120 0 0 $X=251720 $Y=910740
X1500 831 2 812 1 INV1S $T=251720 941360 1 0 $X=251720 $Y=935940
X1501 988 2 947 1 INV1S $T=253580 1062320 0 180 $X=252340 $Y=1056900
X1502 1040 2 730 1 INV1S $T=254820 1032080 0 0 $X=254820 $Y=1031700
X1503 1043 2 1059 1 INV1S $T=255440 880880 0 0 $X=255440 $Y=880500
X1504 1021 2 841 1 INV1S $T=255440 981680 1 0 $X=255440 $Y=976260
X1505 824 2 27 1 INV1S $T=255440 1062320 1 0 $X=255440 $Y=1056900
X1506 878 2 716 1 INV1S $T=259160 961520 0 0 $X=259160 $Y=961140
X1507 33 2 749 1 INV1S $T=260400 1001840 0 180 $X=259160 $Y=996420
X1508 1030 2 797 1 INV1S $T=259160 1022000 1 0 $X=259160 $Y=1016580
X1509 751 2 30 1 INV1S $T=260400 1022000 1 180 $X=259160 $Y=1021620
X1510 1016 2 826 1 INV1S $T=259780 961520 1 0 $X=259780 $Y=956100
X1511 888 2 752 1 INV1S $T=259780 971600 0 0 $X=259780 $Y=971220
X1512 863 2 1027 1 INV1S $T=263500 941360 1 180 $X=262260 $Y=940980
X1513 942 2 706 1 INV1S $T=262260 1001840 1 0 $X=262260 $Y=996420
X1514 787 2 959 1 INV1S $T=262880 931280 0 0 $X=262880 $Y=930900
X1515 817 2 955 1 INV1S $T=264120 961520 1 180 $X=262880 $Y=961140
X1516 1014 2 17 1 INV1S $T=265360 991760 0 180 $X=264120 $Y=986340
X1517 1114 2 1094 1 INV1S $T=266600 1032080 1 180 $X=265360 $Y=1031700
X1518 1136 2 1039 1 INV1S $T=267840 1042160 0 180 $X=266600 $Y=1036740
X1519 961 2 919 1 INV1S $T=268460 931280 0 180 $X=267220 $Y=925860
X1520 783 2 1141 1 INV1S $T=269080 901040 1 180 $X=267840 $Y=900660
X1521 779 2 798 1 INV1S $T=273420 951440 1 180 $X=272180 $Y=951060
X1522 1180 2 767 1 INV1S $T=274040 941360 0 180 $X=272800 $Y=935940
X1523 1032 2 981 1 INV1S $T=274040 981680 1 180 $X=272800 $Y=981300
X1524 1165 2 1092 1 INV1S $T=273420 1032080 1 0 $X=273420 $Y=1026660
X1525 1164 2 1010 1 INV1S $T=275280 931280 0 180 $X=274040 $Y=925860
X1526 1046 2 1168 1 INV1S $T=277140 981680 0 180 $X=275900 $Y=976260
X1527 902 2 1205 1 INV1S $T=277140 911120 1 0 $X=277140 $Y=905700
X1528 748 2 1244 1 INV1S $T=277760 951440 0 0 $X=277760 $Y=951060
X1529 894 2 851 1 INV1S $T=279000 951440 1 0 $X=279000 $Y=946020
X1530 1226 2 1202 1 INV1S $T=282720 890960 1 180 $X=281480 $Y=890580
X1531 733 2 1056 1 INV1S $T=282720 941360 1 180 $X=281480 $Y=940980
X1532 1067 2 720 1 INV1S $T=281480 1001840 1 0 $X=281480 $Y=996420
X1533 1144 2 1277 1 INV1S $T=283340 961520 0 0 $X=283340 $Y=961140
X1534 1252 2 1037 1 INV1S $T=283340 1001840 0 0 $X=283340 $Y=1001460
X1535 1211 2 1296 1 INV1S $T=286440 1062320 1 0 $X=286440 $Y=1056900
X1536 819 2 1004 1 INV1S $T=288300 951440 0 0 $X=288300 $Y=951060
X1537 1232 2 718 1 INV1S $T=288300 971600 1 0 $X=288300 $Y=966180
X1538 1087 2 1224 1 INV1S $T=293260 941360 0 0 $X=293260 $Y=940980
X1539 1121 2 971 1 INV1S $T=294500 981680 1 180 $X=293260 $Y=981300
X1540 739 2 1143 1 INV1S $T=294500 921200 0 0 $X=294500 $Y=920820
X1541 951 2 714 1 INV1S $T=296980 961520 1 0 $X=296980 $Y=956100
X1542 1298 2 1269 1 INV1S $T=296980 1032080 0 0 $X=296980 $Y=1031700
X1543 1297 2 1353 1 INV1S $T=297600 911120 1 0 $X=297600 $Y=905700
X1544 1138 2 1303 1 INV1S $T=300080 911120 1 180 $X=298840 $Y=910740
X1545 732 2 1362 1 INV1S $T=300080 911120 0 0 $X=300080 $Y=910740
X1546 759 2 1383 1 INV1S $T=300080 961520 0 0 $X=300080 $Y=961140
X1547 825 2 1090 1 INV1S $T=303180 911120 1 180 $X=301940 $Y=910740
X1548 1414 2 1389 1 INV1S $T=303180 1032080 1 180 $X=301940 $Y=1031700
X1549 932 2 1089 1 INV1S $T=301940 1042160 1 0 $X=301940 $Y=1036740
X1550 1028 2 941 1 INV1S $T=302560 931280 0 0 $X=302560 $Y=930900
X1551 1412 2 1413 1 INV1S $T=305040 1001840 1 180 $X=303800 $Y=1001460
X1552 1072 2 872 1 INV1S $T=303800 1042160 0 0 $X=303800 $Y=1041780
X1553 1049 2 838 1 INV1S $T=304420 961520 1 0 $X=304420 $Y=956100
X1554 861 2 1079 1 INV1S $T=305040 911120 0 0 $X=305040 $Y=910740
X1555 1301 2 925 1 INV1S $T=305040 1042160 1 0 $X=305040 $Y=1036740
X1556 1415 2 1439 1 INV1S $T=305660 901040 0 0 $X=305660 $Y=900660
X1557 1439 2 1456 1 INV1S $T=306900 901040 0 0 $X=306900 $Y=900660
X1558 1243 2 1381 1 INV1S $T=309380 921200 0 180 $X=308140 $Y=915780
X1559 1321 2 1265 1 INV1S $T=308140 931280 1 0 $X=308140 $Y=925860
X1560 1322 2 724 1 INV1S $T=309380 981680 0 180 $X=308140 $Y=976260
X1561 763 2 1438 1 INV1S $T=308760 1042160 1 0 $X=308760 $Y=1036740
X1562 1423 2 894 1 INV1S $T=310000 971600 0 0 $X=310000 $Y=971220
X1563 715 2 1149 1 INV1S $T=313720 921200 1 180 $X=312480 $Y=920820
X1564 1490 2 1291 1 INV1S $T=314340 961520 0 180 $X=313100 $Y=956100
X1565 804 2 1342 1 INV1S $T=314960 931280 1 180 $X=313720 $Y=930900
X1566 14 2 39 1 INV1S $T=317440 1052240 1 180 $X=316200 $Y=1051860
X1567 1445 2 1432 1 INV1S $T=316820 880880 1 0 $X=316820 $Y=875460
X1568 21 2 803 1 INV1S $T=318060 1052240 1 0 $X=318060 $Y=1046820
X1569 1448 2 1029 1 INV1S $T=320540 1011920 0 0 $X=320540 $Y=1011540
X1570 1517 2 1475 1 INV1S $T=321780 911120 1 0 $X=321780 $Y=905700
X1571 977 2 26 1 INV1S $T=321780 1011920 1 0 $X=321780 $Y=1006500
X1572 77 2 1552 1 INV1S $T=323640 921200 1 0 $X=323640 $Y=915780
X1573 781 2 1225 1 INV1S $T=323640 991760 1 0 $X=323640 $Y=986340
X1574 889 2 47 1 INV1S $T=325500 1032080 0 180 $X=324260 $Y=1026660
X1575 1283 2 1221 1 INV1S $T=326120 1042160 0 0 $X=326120 $Y=1041780
X1576 1007 2 23 1 INV1S $T=327360 1032080 0 0 $X=327360 $Y=1031700
X1577 1572 2 1570 1 INV1S $T=330460 911120 0 0 $X=330460 $Y=910740
X1578 25 2 864 1 INV1S $T=333560 1062320 0 180 $X=332320 $Y=1056900
X1579 1580 2 89 1 INV1S $T=332940 880880 1 0 $X=332940 $Y=875460
X1580 91 2 1591 1 INV1S $T=334800 931280 1 180 $X=333560 $Y=930900
X1581 1643 2 1571 1 INV1S $T=337280 901040 1 180 $X=336040 $Y=900660
X1582 1022 2 952 1 INV1S $T=337280 961520 0 180 $X=336040 $Y=956100
X1583 1506 2 1630 1 INV1S $T=336660 941360 1 0 $X=336660 $Y=935940
X1584 1578 2 1264 1 INV1S $T=336660 991760 1 0 $X=336660 $Y=986340
X1585 1565 2 1617 1 INV1S $T=337900 1011920 0 180 $X=336660 $Y=1006500
X1586 1126 2 865 1 INV1S $T=337280 1022000 1 0 $X=337280 $Y=1016580
X1587 1641 2 1523 1 INV1S $T=339760 971600 1 180 $X=338520 $Y=971220
X1588 1649 2 1271 1 INV1S $T=340380 1011920 1 180 $X=339140 $Y=1011540
X1589 34 2 860 1 INV1S $T=339760 1052240 0 0 $X=339760 $Y=1051860
X1590 1629 2 1634 1 INV1S $T=340380 921200 1 0 $X=340380 $Y=915780
X1591 1525 2 1623 1 INV1S $T=341000 951440 1 0 $X=341000 $Y=946020
X1592 92 2 1635 1 INV1S $T=342860 880880 1 180 $X=341620 $Y=880500
X1593 1330 2 55 1 INV1S $T=341620 1001840 0 0 $X=341620 $Y=1001460
X1594 877 2 1080 1 INV1S $T=342860 1032080 0 180 $X=341620 $Y=1026660
X1595 1435 2 3 1 INV1S $T=342860 1052240 0 180 $X=341620 $Y=1046820
X1596 15 2 1210 1 INV1S $T=342240 1022000 0 0 $X=342240 $Y=1021620
X1597 97 2 1636 1 INV1S $T=344100 941360 0 180 $X=342860 $Y=935940
X1598 101 2 1637 1 INV1S $T=344100 951440 0 180 $X=342860 $Y=946020
X1599 71 2 95 1 INV1S $T=344100 880880 0 0 $X=344100 $Y=880500
X1600 100 2 1645 1 INV1S $T=344100 931280 1 0 $X=344100 $Y=925860
X1601 7 2 1239 1 INV1S $T=345340 1052240 0 180 $X=344100 $Y=1046820
X1602 1590 2 1524 1 INV1S $T=347820 981680 1 180 $X=346580 $Y=981300
X1603 1521 2 1681 1 INV1S $T=347820 890960 0 0 $X=347820 $Y=890580
X1604 94 2 1624 1 INV1S $T=349060 951440 0 180 $X=347820 $Y=946020
X1605 1601 2 1690 1 INV1S $T=347820 981680 0 0 $X=347820 $Y=981300
X1606 78 2 1513 1 INV1S $T=350920 951440 0 180 $X=349680 $Y=946020
X1607 1532 2 1652 1 INV1S $T=349680 961520 1 0 $X=349680 $Y=956100
X1608 108 2 102 1 INV1S $T=352160 870800 1 180 $X=350920 $Y=870420
X1609 1538 2 1682 1 INV1S $T=350920 901040 0 0 $X=350920 $Y=900660
X1610 1147 2 1665 1 INV1S $T=350920 911120 0 0 $X=350920 $Y=910740
X1611 1674 2 1679 1 INV1S $T=350920 921200 1 0 $X=350920 $Y=915780
X1612 1582 2 1541 1 INV1S $T=352160 951440 1 180 $X=350920 $Y=951060
X1613 1714 2 1374 1 INV1S $T=355260 981680 0 180 $X=354020 $Y=976260
X1614 107 2 1654 1 INV1S $T=355260 981680 1 0 $X=355260 $Y=976260
X1615 1622 2 1713 1 INV1S $T=355880 941360 0 0 $X=355880 $Y=940980
X1616 1717 2 111 1 INV1S $T=355880 1011920 0 0 $X=355880 $Y=1011540
X1617 1482 2 1733 1 INV1S $T=357120 901040 1 0 $X=357120 $Y=895620
X1618 1598 2 1658 1 INV1S $T=357740 981680 1 0 $X=357740 $Y=976260
X1619 1718 2 1727 1 INV1S $T=358360 921200 1 0 $X=358360 $Y=915780
X1620 1735 2 1745 1 INV1S $T=358980 911120 0 0 $X=358980 $Y=910740
X1621 1737 2 1736 1 INV1S $T=362700 951440 1 180 $X=361460 $Y=951060
X1622 729 2 1064 1 INV1S $T=361460 961520 1 0 $X=361460 $Y=956100
X1623 1643 2 1756 1 INV1S $T=363940 1001840 1 0 $X=363940 $Y=996420
X1624 1702 2 1741 1 INV1S $T=365800 880880 1 180 $X=364560 $Y=880500
X1625 126 2 1766 1 INV1S $T=365800 1001840 0 0 $X=365800 $Y=1001460
X1626 1774 2 1538 1 INV1S $T=367660 951440 1 180 $X=366420 $Y=951060
X1627 1643 2 1769 1 INV1S $T=366420 1001840 1 0 $X=366420 $Y=996420
X1628 1768 2 134 1 INV1S $T=368280 1001840 0 0 $X=368280 $Y=1001460
X1629 1702 2 1779 1 INV1S $T=370140 1011920 1 180 $X=368900 $Y=1011540
X1630 1699 2 1693 1 INV1S $T=371380 890960 0 180 $X=370140 $Y=885540
X1631 1702 2 1764 1 INV1S $T=371380 1011920 0 0 $X=371380 $Y=1011540
X1632 1786 2 1790 1 INV1S $T=371380 1022000 1 0 $X=371380 $Y=1016580
X1633 1702 2 1719 1 INV1S $T=372620 1011920 0 0 $X=372620 $Y=1011540
X1634 1783 2 1795 1 INV1S $T=373240 921200 1 0 $X=373240 $Y=915780
X1635 138 2 141 1 INV1S $T=373240 971600 1 0 $X=373240 $Y=966180
X1636 1702 2 1689 1 INV1S $T=375100 1011920 1 180 $X=373860 $Y=1011540
X1637 138 2 1815 1 INV1S $T=375720 971600 1 0 $X=375720 $Y=966180
X1638 1503 2 1812 1 INV1S $T=376340 901040 0 0 $X=376340 $Y=900660
X1639 1826 2 1699 1 INV1S $T=379440 961520 1 180 $X=378200 $Y=961140
X1640 146 2 1825 1 INV1S $T=378820 921200 0 0 $X=378820 $Y=920820
X1641 150 2 151 1 INV1S $T=380060 941360 0 0 $X=380060 $Y=940980
X1642 150 2 1840 1 INV1S $T=381920 941360 0 0 $X=381920 $Y=940980
X1643 150 2 1833 1 INV1S $T=381920 951440 1 0 $X=381920 $Y=946020
X1644 129 2 1905 1 INV1S $T=383780 991760 0 0 $X=383780 $Y=991380
X1645 1702 2 1723 1 INV1S $T=383780 1011920 0 0 $X=383780 $Y=1011540
X1646 1853 2 1852 1 INV1S $T=386880 971600 0 180 $X=385640 $Y=966180
X1647 1844 2 1851 1 INV1S $T=386880 921200 0 0 $X=386880 $Y=920820
X1648 162 2 1875 1 INV1S $T=391220 921200 0 0 $X=391220 $Y=920820
X1649 1897 2 1901 1 INV1S $T=393080 921200 0 0 $X=393080 $Y=920820
X1650 1893 2 1915 1 INV1S $T=393700 1011920 1 0 $X=393700 $Y=1006500
X1651 1899 2 1904 1 INV1S $T=393700 1042160 1 0 $X=393700 $Y=1036740
X1652 134 2 1955 1 INV1S $T=395560 1001840 0 0 $X=395560 $Y=1001460
X1653 144 2 1939 1 INV1S $T=399900 941360 0 0 $X=399900 $Y=940980
X1654 176 2 1931 1 INV1S $T=401760 921200 0 180 $X=400520 $Y=915780
X1655 1937 2 1969 1 INV1S $T=403620 921200 0 0 $X=403620 $Y=920820
X1656 1933 2 1979 1 INV1S $T=403620 1011920 1 0 $X=403620 $Y=1006500
X1657 1956 2 1965 1 INV1S $T=404240 1022000 1 0 $X=404240 $Y=1016580
X1658 1905 2 1917 1 INV1S $T=405480 991760 1 0 $X=405480 $Y=986340
X1659 1917 2 1998 1 INV1S $T=407960 991760 1 0 $X=407960 $Y=986340
X1660 1960 2 1991 1 INV1S $T=407960 991760 0 0 $X=407960 $Y=991380
X1661 1940 2 2013 1 INV1S $T=409200 1032080 0 0 $X=409200 $Y=1031700
X1662 1925 2 1987 1 INV1S $T=414160 1011920 1 180 $X=412920 $Y=1011540
X1663 2020 2 2031 1 INV1S $T=413540 921200 0 0 $X=413540 $Y=920820
X1664 2019 2 2008 1 INV1S $T=414160 1042160 1 0 $X=414160 $Y=1036740
X1665 1987 2 2004 1 INV1S $T=416640 1011920 1 180 $X=415400 $Y=1011540
X1666 150 2 2038 1 INV1S $T=416020 941360 1 0 $X=416020 $Y=935940
X1667 1964 2 2040 1 INV1S $T=418500 991760 1 180 $X=417260 $Y=991380
X1668 2039 2 2051 1 INV1S $T=419740 1001840 0 0 $X=419740 $Y=1001460
X1669 2023 2 2086 1 INV1S $T=419740 1032080 0 0 $X=419740 $Y=1031700
X1670 2048 2 2070 1 INV1S $T=420980 921200 0 0 $X=420980 $Y=920820
X1671 138 2 2032 1 INV1S $T=422220 931280 0 0 $X=422220 $Y=930900
X1672 2090 2 2081 1 INV1S $T=425940 1032080 0 0 $X=425940 $Y=1031700
X1673 2099 2 2087 1 INV1S $T=429040 901040 0 180 $X=427800 $Y=895620
X1674 193 2 2115 1 INV1S $T=429040 870800 0 0 $X=429040 $Y=870420
X1675 192 2 2125 1 INV1S $T=429040 880880 0 0 $X=429040 $Y=880500
X1676 111 2 2077 1 INV1S $T=432760 1001840 0 0 $X=432760 $Y=1001460
X1677 2154 2 2147 1 INV1S $T=435860 1032080 1 180 $X=434620 $Y=1031700
X1678 196 2 2156 1 INV1S $T=436480 880880 0 0 $X=436480 $Y=880500
X1679 2135 2 2181 1 INV1S $T=438960 1032080 1 0 $X=438960 $Y=1026660
X1680 2158 2 2182 1 INV1S $T=438960 1042160 0 0 $X=438960 $Y=1041780
X1681 2065 2 2176 1 INV1S $T=440820 870800 1 180 $X=439580 $Y=870420
X1682 204 2 200 1 INV1S $T=442680 870800 1 180 $X=441440 $Y=870420
X1683 2073 2 2184 1 INV1S $T=441440 921200 1 0 $X=441440 $Y=915780
X1684 2183 2 2180 1 INV1S $T=442680 1001840 1 180 $X=441440 $Y=1001460
X1685 2075 2 2200 1 INV1S $T=442680 901040 0 0 $X=442680 $Y=900660
X1686 1774 2 2202 1 INV1S $T=442680 1022000 1 0 $X=442680 $Y=1016580
X1687 1702 2 2211 1 INV1S $T=443920 1001840 0 0 $X=443920 $Y=1001460
X1688 2212 2 2206 1 INV1S $T=444540 1011920 0 0 $X=444540 $Y=1011540
X1689 2102 2 2251 1 INV1S $T=451980 1042160 1 0 $X=451980 $Y=1036740
X1690 2239 2 2260 1 INV1S $T=452600 1022000 0 0 $X=452600 $Y=1021620
X1691 1972 2 2263 1 INV1S $T=453840 911120 1 0 $X=453840 $Y=905700
X1692 1796 2 2267 1 INV1S $T=453840 1001840 0 0 $X=453840 $Y=1001460
X1693 2262 2 2277 1 INV1S $T=455080 1022000 1 0 $X=455080 $Y=1016580
X1694 2007 2 2294 1 INV1S $T=458180 901040 0 0 $X=458180 $Y=900660
X1695 2024 2 2309 1 INV1S $T=460040 890960 0 0 $X=460040 $Y=890580
X1696 2132 2 2302 1 INV1S $T=460660 1011920 0 0 $X=460660 $Y=1011540
X1697 2202 2 2328 1 INV1S $T=463760 1022000 1 0 $X=463760 $Y=1016580
X1698 2320 2 2311 1 INV1S $T=463760 1032080 0 0 $X=463760 $Y=1031700
X1699 2101 2 2339 1 INV1S $T=465620 941360 1 0 $X=465620 $Y=935940
X1700 2131 2 2336 1 INV1S $T=465620 1042160 1 0 $X=465620 $Y=1036740
X1701 1936 2 2306 1 INV1S $T=469960 1032080 0 0 $X=469960 $Y=1031700
X1702 2357 2 2370 1 INV1S $T=471820 1011920 0 0 $X=471820 $Y=1011540
X1703 2145 2 2365 1 INV1S $T=471820 1052240 0 0 $X=471820 $Y=1051860
X1704 2095 2 2376 1 INV1S $T=474300 890960 0 0 $X=474300 $Y=890580
X1705 2358 2 2394 1 INV1S $T=475540 1032080 1 0 $X=475540 $Y=1026660
X1706 2059 2 2407 1 INV1S $T=476780 890960 0 0 $X=476780 $Y=890580
X1707 1939 2 2400 1 INV1S $T=476780 951440 1 0 $X=476780 $Y=946020
X1708 2190 2 2406 1 INV1S $T=477400 961520 1 0 $X=477400 $Y=956100
X1709 2382 2 2425 1 INV1S $T=479260 1032080 1 0 $X=479260 $Y=1026660
X1710 2114 2 2435 1 INV1S $T=481740 890960 1 0 $X=481740 $Y=885540
X1711 2421 2 2424 1 INV1S $T=482360 1001840 0 0 $X=482360 $Y=1001460
X1712 2103 2 2441 1 INV1S $T=483600 1042160 1 0 $X=483600 $Y=1036740
X1713 2227 2 2448 1 INV1S $T=486080 951440 0 0 $X=486080 $Y=951060
X1714 2178 2 2478 1 INV1S $T=486700 1011920 0 0 $X=486700 $Y=1011540
X1715 2100 2 2469 1 INV1S $T=487320 901040 1 0 $X=487320 $Y=895620
X1716 2098 2 2460 1 INV1S $T=488560 1022000 1 180 $X=487320 $Y=1021620
X1717 2194 2 2458 1 INV1S $T=487940 961520 0 0 $X=487940 $Y=961140
X1718 2457 2 2476 1 INV1S $T=488560 1001840 0 0 $X=488560 $Y=1001460
X1719 2475 2 2480 1 INV1S $T=489180 991760 1 0 $X=489180 $Y=986340
X1720 2143 2 2466 1 INV1S $T=492280 1032080 1 180 $X=491040 $Y=1031700
X1721 2334 2 2546 1 INV1S $T=495380 951440 1 0 $X=495380 $Y=946020
X1722 2160 2 2509 1 INV1S $T=495380 981680 1 0 $X=495380 $Y=976260
X1723 2186 2 2510 1 INV1S $T=496620 991760 1 0 $X=496620 $Y=986340
X1724 2108 2 2522 1 INV1S $T=497240 981680 0 0 $X=497240 $Y=981300
X1725 2161 2 2523 1 INV1S $T=497240 1011920 1 0 $X=497240 $Y=1006500
X1726 2238 2 2525 1 INV1S $T=497860 961520 1 0 $X=497860 $Y=956100
X1727 2393 2 2536 1 INV1S $T=499100 1032080 0 0 $X=499100 $Y=1031700
X1728 2124 2 2550 1 INV1S $T=500340 961520 0 0 $X=500340 $Y=961140
X1729 2447 2 2552 1 INV1S $T=500960 1032080 1 0 $X=500960 $Y=1026660
X1730 2492 2 2567 1 INV1S $T=502820 1011920 1 0 $X=502820 $Y=1006500
X1731 2577 2 2568 1 INV1S $T=505920 901040 0 180 $X=504680 $Y=895620
X1732 2150 2 2545 1 INV1S $T=505920 991760 1 180 $X=504680 $Y=991380
X1733 2179 2 2557 1 INV1S $T=507160 1011920 1 180 $X=505920 $Y=1011540
X1734 2463 2 2583 1 INV1S $T=507160 971600 1 0 $X=507160 $Y=966180
X1735 2464 2 2610 1 INV1S $T=510880 991760 0 0 $X=510880 $Y=991380
X1736 2600 2 2620 1 INV1S $T=511500 911120 1 0 $X=511500 $Y=905700
X1737 2569 2 2617 1 INV1S $T=511500 941360 1 0 $X=511500 $Y=935940
X1738 2383 2 2589 1 INV1S $T=512740 1032080 0 0 $X=512740 $Y=1031700
X1739 2470 2 2622 1 INV1S $T=513360 991760 1 0 $X=513360 $Y=986340
X1740 2612 2 2636 1 INV1S $T=514600 901040 0 0 $X=514600 $Y=900660
X1741 2611 2 2637 1 INV1S $T=514600 921200 1 0 $X=514600 $Y=915780
X1742 2526 2 2645 1 INV1S $T=514600 951440 1 0 $X=514600 $Y=946020
X1743 2570 2 2639 1 INV1S $T=514600 961520 0 0 $X=514600 $Y=961140
X1744 2518 2 2635 1 INV1S $T=515220 991760 0 0 $X=515220 $Y=991380
X1745 2438 2 2594 1 INV1S $T=516460 1022000 0 180 $X=515220 $Y=1016580
X1746 2609 2 2625 1 INV1S $T=518320 890960 1 180 $X=517080 $Y=890580
X1747 2449 2 2638 1 INV1S $T=517700 1022000 1 0 $X=517700 $Y=1016580
X1748 1820 2 2559 1 INV1S $T=518320 1001840 1 0 $X=518320 $Y=996420
X1749 2601 2 2656 1 INV1S $T=521420 921200 1 180 $X=520180 $Y=920820
X1750 2446 2 2663 1 INV1S $T=520180 981680 0 0 $X=520180 $Y=981300
X1751 2413 2 2664 1 INV1S $T=520180 1001840 0 0 $X=520180 $Y=1001460
X1752 2411 2 2672 1 INV1S $T=520800 1001840 1 0 $X=520800 $Y=996420
X1753 2554 2 2667 1 INV1S $T=521420 931280 0 0 $X=521420 $Y=930900
X1754 2433 2 2675 1 INV1S $T=522660 981680 0 0 $X=522660 $Y=981300
X1755 2483 2 2692 1 INV1S $T=523280 1001840 1 0 $X=523280 $Y=996420
X1756 2418 2 2687 1 INV1S $T=523280 1011920 0 0 $X=523280 $Y=1011540
X1757 2445 2 2703 1 INV1S $T=528240 971600 1 180 $X=527000 $Y=971220
X1758 2497 2 2689 1 INV1S $T=529480 931280 1 180 $X=528240 $Y=930900
X1759 2587 2 2721 1 INV1S $T=528860 931280 1 0 $X=528860 $Y=925860
X1760 2599 2 2722 1 INV1S $T=529480 941360 1 0 $X=529480 $Y=935940
X1761 2595 2 2739 1 INV1S $T=535680 951440 1 0 $X=535680 $Y=946020
X1762 2902 2 2899 1 INV1S $T=574740 1022000 1 180 $X=573500 $Y=1021620
X1763 2928 2 2944 1 INV1S $T=586520 1022000 0 0 $X=586520 $Y=1021620
X1764 2958 2 2945 1 INV1S $T=590860 901040 1 180 $X=589620 $Y=900660
X1765 2960 2 2942 1 INV1S $T=590860 1052240 0 180 $X=589620 $Y=1046820
X1766 2963 2 2950 1 INV1S $T=592720 901040 1 180 $X=591480 $Y=900660
X1767 2972 2 2957 1 INV1S $T=592720 1042160 0 180 $X=591480 $Y=1036740
X1768 2981 2 2926 1 INV1S $T=595820 951440 1 180 $X=594580 $Y=951060
X1769 3006 2 2930 1 INV1S $T=597680 880880 1 180 $X=596440 $Y=880500
X1770 3023 2 2920 1 INV1S $T=601400 951440 1 180 $X=600160 $Y=951060
X1771 3015 2 2998 1 INV1S $T=601400 971600 1 180 $X=600160 $Y=971220
X1772 3022 2 3019 1 INV1S $T=602020 1022000 1 180 $X=600780 $Y=1021620
X1773 3038 2 3027 1 INV1S $T=603880 971600 1 180 $X=602640 $Y=971220
X1774 3029 2 3033 1 INV1S $T=602640 1062320 1 0 $X=602640 $Y=1056900
X1775 3035 2 297 1 INV1S $T=604500 1052240 1 180 $X=603260 $Y=1051860
X1776 3036 2 2951 1 INV1S $T=606980 911120 1 180 $X=605740 $Y=910740
X1777 3043 2 3011 1 INV1S $T=606980 931280 1 180 $X=605740 $Y=930900
X1778 3052 2 3057 1 INV1S $T=606360 981680 1 0 $X=606360 $Y=976260
X1779 3055 2 3001 1 INV1S $T=608220 890960 0 180 $X=606980 $Y=885540
X1780 3062 2 3042 1 INV1S $T=608840 880880 0 180 $X=607600 $Y=875460
X1781 3026 2 2943 1 INV1S $T=610080 941360 1 180 $X=608840 $Y=940980
X1782 3004 2 3047 1 INV1S $T=610080 1001840 0 180 $X=608840 $Y=996420
X1783 3081 2 304 1 INV1S $T=611320 880880 0 180 $X=610080 $Y=875460
X1784 2913 2 3100 1 INV1S $T=613180 971600 1 0 $X=613180 $Y=966180
X1785 3074 2 3088 1 INV1S $T=615660 1022000 0 0 $X=615660 $Y=1021620
X1786 3120 2 3108 1 INV1S $T=617520 1001840 0 180 $X=616280 $Y=996420
X1787 311 2 3117 1 INV1S $T=618140 880880 1 180 $X=616900 $Y=880500
X1788 314 2 3123 1 INV1S $T=623100 911120 1 0 $X=623100 $Y=905700
X1789 3170 2 3091 1 INV1S $T=627440 890960 1 180 $X=626200 $Y=890580
X1790 3179 2 3082 1 INV1S $T=629920 890960 0 180 $X=628680 $Y=885540
X1791 3151 2 3194 1 INV1S $T=628680 1011920 0 0 $X=628680 $Y=1011540
X1792 3183 2 3176 1 INV1S $T=629920 1052240 0 180 $X=628680 $Y=1046820
X1793 3180 2 3197 1 INV1S $T=630540 1032080 1 0 $X=630540 $Y=1026660
X1794 3199 2 3095 1 INV1S $T=632400 880880 1 180 $X=631160 $Y=880500
X1795 323 2 3140 1 INV1S $T=633020 870800 1 180 $X=631780 $Y=870420
X1796 3213 2 3098 1 INV1S $T=633020 911120 1 180 $X=631780 $Y=910740
X1797 3163 2 3203 1 INV1S $T=631780 1052240 1 0 $X=631780 $Y=1046820
X1798 2909 2 3208 1 INV1S $T=632400 971600 1 0 $X=632400 $Y=966180
X1799 3194 2 3053 1 INV1S $T=632400 1032080 0 0 $X=632400 $Y=1031700
X1800 322 2 3138 1 INV1S $T=636740 890960 1 0 $X=636740 $Y=885540
X1801 3152 2 3137 1 INV1S $T=637980 901040 1 180 $X=636740 $Y=900660
X1802 3241 2 3102 1 INV1S $T=639220 921200 0 180 $X=637980 $Y=915780
X1803 3247 2 3118 1 INV1S $T=639220 931280 1 180 $X=637980 $Y=930900
X1804 3237 2 3164 1 INV1S $T=639220 941360 1 180 $X=637980 $Y=940980
X1805 325 2 329 1 INV1S $T=639840 870800 0 0 $X=639840 $Y=870420
X1806 3083 2 3221 1 INV1S $T=641700 911120 0 180 $X=640460 $Y=905700
X1807 3245 2 3069 1 INV1S $T=641700 921200 1 180 $X=640460 $Y=920820
X1808 3257 2 3167 1 INV1S $T=641700 951440 1 180 $X=640460 $Y=951060
X1809 3238 2 3192 1 INV1S $T=642320 961520 1 180 $X=641080 $Y=961140
X1810 3264 2 3077 1 INV1S $T=644180 931280 0 180 $X=642940 $Y=925860
X1811 2917 2 3273 1 INV1S $T=643560 951440 1 0 $X=643560 $Y=946020
X1812 3073 2 3234 1 INV1S $T=645420 921200 0 180 $X=644180 $Y=915780
X1813 336 2 3276 1 INV1S $T=644800 941360 1 0 $X=644800 $Y=935940
X1814 338 2 3271 1 INV1S $T=646660 931280 0 180 $X=645420 $Y=925860
X1815 277 2 3291 1 INV1S $T=645420 931280 0 0 $X=645420 $Y=930900
X1816 3292 2 3283 1 INV1S $T=646660 981680 0 180 $X=645420 $Y=976260
X1817 262 2 3287 1 INV1S $T=649140 941360 0 0 $X=649140 $Y=940980
X1818 327 2 3303 1 INV1S $T=649760 890960 0 0 $X=649760 $Y=890580
X1819 3316 2 3334 1 INV1S $T=649760 971600 0 0 $X=649760 $Y=971220
X1820 276 2 3307 1 INV1S $T=651000 941360 0 0 $X=651000 $Y=940980
X1821 3236 2 3350 1 INV1S $T=652860 1042160 1 0 $X=652860 $Y=1036740
X1822 3251 2 3368 1 INV1S $T=652860 1052240 1 0 $X=652860 $Y=1046820
X1823 3246 2 3347 1 INV1S $T=652860 1052240 0 0 $X=652860 $Y=1051860
X1824 334 2 3341 1 INV1S $T=655340 901040 1 180 $X=654100 $Y=900660
X1825 326 2 3329 1 INV1S $T=660300 890960 0 180 $X=659060 $Y=885540
X1826 335 2 3343 1 INV1S $T=662780 901040 1 180 $X=661540 $Y=900660
X1827 315 2 3345 1 INV1S $T=662780 901040 0 0 $X=662780 $Y=900660
X1828 3219 2 3382 1 INV1S $T=663400 981680 0 0 $X=663400 $Y=981300
X1829 271 2 3314 1 INV1S $T=664640 921200 1 0 $X=664640 $Y=915780
X1830 3384 2 3412 1 INV1S $T=666500 901040 1 0 $X=666500 $Y=895620
X1831 3262 2 3421 1 INV1S $T=667740 870800 0 0 $X=667740 $Y=870420
X1832 3430 2 3223 1 INV1S $T=670840 961520 0 180 $X=669600 $Y=956100
X1833 3310 2 3432 1 INV1S $T=670220 921200 0 0 $X=670220 $Y=920820
X1834 331 2 3333 1 INV1S $T=672700 901040 1 180 $X=671460 $Y=900660
X1835 330 2 3351 1 INV1S $T=672700 911120 0 180 $X=671460 $Y=905700
X1836 3326 2 3459 1 INV1S $T=672700 880880 1 0 $X=672700 $Y=875460
X1837 3418 2 3450 1 INV1S $T=672700 981680 1 0 $X=672700 $Y=976260
X1838 3435 2 3449 1 INV1S $T=672700 1011920 1 0 $X=672700 $Y=1006500
X1839 3433 2 3419 1 INV1S $T=675180 981680 0 0 $X=675180 $Y=981300
X1840 3434 2 3426 1 INV1S $T=675800 991760 0 0 $X=675800 $Y=991380
X1841 3300 2 3463 1 INV1S $T=676420 911120 1 0 $X=676420 $Y=905700
X1842 3436 2 3427 1 INV1S $T=677660 1011920 0 180 $X=676420 $Y=1006500
X1843 3467 2 3424 1 INV1S $T=679520 1011920 0 180 $X=678280 $Y=1006500
X1844 3465 2 3446 1 INV1S $T=680140 981680 1 180 $X=678900 $Y=981300
X1845 3398 2 3475 1 INV1S $T=679520 890960 1 0 $X=679520 $Y=885540
X1846 3365 2 3485 1 INV1S $T=681380 921200 1 0 $X=681380 $Y=915780
X1847 3481 2 3484 1 INV1S $T=681380 1011920 0 0 $X=681380 $Y=1011540
X1848 353 2 3455 1 INV1S $T=683240 1011920 0 0 $X=683240 $Y=1011540
X1849 359 2 3490 1 INV1S $T=683860 1011920 1 0 $X=683860 $Y=1006500
X1850 3458 2 3497 1 INV1S $T=685100 931280 1 0 $X=685100 $Y=925860
X1851 3385 2 3496 1 INV1S $T=685100 941360 1 0 $X=685100 $Y=935940
X1852 3451 2 3515 1 INV1S $T=685720 951440 0 0 $X=685720 $Y=951060
X1853 3431 2 3499 1 INV1S $T=686340 941360 1 0 $X=686340 $Y=935940
X1854 3417 2 3548 1 INV1S $T=695020 961520 1 0 $X=695020 $Y=956100
X1855 380 2 3537 1 INV1S $T=698740 981680 1 0 $X=698740 $Y=976260
X1856 3673 2 3679 1 INV1S $T=733460 921200 0 0 $X=733460 $Y=920820
X1857 3675 2 3692 1 INV1S $T=734080 901040 1 0 $X=734080 $Y=895620
X1858 3678 2 3693 1 INV1S $T=734080 901040 0 0 $X=734080 $Y=900660
X1859 3683 2 3688 1 INV1S $T=734700 921200 0 0 $X=734700 $Y=920820
X1860 3686 2 3695 1 INV1S $T=735320 890960 1 0 $X=735320 $Y=885540
X1861 3694 2 3700 1 INV1S $T=735940 880880 0 0 $X=735940 $Y=880500
X1862 3706 2 3709 1 INV1S $T=738420 880880 0 0 $X=738420 $Y=880500
X1863 3661 2 3713 1 INV1S $T=740280 870800 0 0 $X=740280 $Y=870420
X1864 3666 2 3714 1 INV1S $T=740280 890960 1 0 $X=740280 $Y=885540
X1865 3708 2 3723 1 INV1S $T=744000 880880 1 0 $X=744000 $Y=875460
X1866 431 2 3740 1 INV1S $T=751440 880880 0 180 $X=750200 $Y=875460
X1867 493 2 3969 1 INV1S $T=817780 890960 1 180 $X=816540 $Y=890580
X1868 508 2 3982 1 INV1S $T=822740 890960 0 0 $X=822740 $Y=890580
X1869 509 2 3984 1 INV1S $T=826460 901040 1 0 $X=826460 $Y=895620
X1870 524 2 4047 1 INV1S $T=841340 931280 0 0 $X=841340 $Y=930900
X1871 522 2 4028 1 INV1S $T=847540 981680 1 0 $X=847540 $Y=976260
X1872 525 2 4058 1 INV1S $T=850020 941360 1 0 $X=850020 $Y=935940
X1873 1241 1 2 1184 BUF1S $T=280240 901040 1 0 $X=280240 $Y=895620
X1874 2050 1 2 2079 BUF1S $T=424700 1062320 1 0 $X=424700 $Y=1056900
X1875 2173 1 2 2212 BUF1S $T=451360 1011920 0 0 $X=451360 $Y=1011540
X1876 2702 1 2 2718 BUF1S $T=530720 961520 0 0 $X=530720 $Y=961140
X1877 250 1 2 2842 BUF1S $T=558000 1052240 0 0 $X=558000 $Y=1051860
X1878 2849 1 2 2898 BUF1S $T=563580 1042160 0 0 $X=563580 $Y=1041780
X1879 2833 1 2 2884 BUF1S $T=569780 1022000 0 0 $X=569780 $Y=1021620
X1880 2967 1 2 2980 BUF1S $T=592100 961520 0 0 $X=592100 $Y=961140
X1881 2992 1 2 278 BUF1S $T=597680 880880 1 0 $X=597680 $Y=875460
X1882 3066 1 2 3074 BUF1S $T=608220 1032080 1 0 $X=608220 $Y=1026660
X1883 3061 1 2 2954 BUF1S $T=615040 971600 0 0 $X=615040 $Y=971220
X1884 3294 1 2 3259 BUF1S $T=651000 1011920 0 0 $X=651000 $Y=1011540
X1885 3378 1 2 3361 BUF1S $T=660300 1042160 0 0 $X=660300 $Y=1041780
X1886 3732 1 2 399 BUF1S $T=747100 890960 1 0 $X=747100 $Y=885540
X1887 3682 1 2 3570 BUF1S $T=747720 890960 0 0 $X=747720 $Y=890580
X1888 3939 1 2 487 BUF1S $T=807860 921200 0 0 $X=807860 $Y=920820
X1889 4125 1 2 534 BUF1S $T=861800 921200 0 0 $X=861800 $Y=920820
X1890 4128 1 2 4111 BUF1S $T=863660 880880 1 0 $X=863660 $Y=875460
X1891 1196 1 45 1222 2 ND2P $T=274660 880880 1 0 $X=274660 $Y=875460
X1892 1186 1 45 1228 2 ND2P $T=277140 870800 0 0 $X=277140 $Y=870420
X1893 1290 1 1336 59 2 ND2P $T=296980 901040 0 180 $X=293260 $Y=895620
X1894 1344 1 1240 1376 2 ND2P $T=294500 880880 0 0 $X=294500 $Y=880500
X1895 1375 1 1240 1387 2 ND2P $T=301940 890960 1 0 $X=301940 $Y=885540
X1896 1454 1 1465 1344 2 ND2P $T=309380 880880 1 0 $X=309380 $Y=875460
X1897 1510 1 1398 1527 2 ND2P $T=317440 880880 0 0 $X=317440 $Y=880500
X1898 1483 1 1398 1520 2 ND2P $T=319300 890960 1 0 $X=319300 $Y=885540
X1899 1538 1 1571 1468 2 ND2P $T=326120 901040 0 0 $X=326120 $Y=900660
X1900 1699 1 1672 1521 2 ND2P $T=349680 880880 1 180 $X=345960 $Y=880500
X1901 1744 1 1747 1546 2 ND2P $T=360220 901040 1 0 $X=360220 $Y=895620
X1902 1756 1 1762 1747 2 ND2P $T=363940 901040 1 0 $X=363940 $Y=895620
X1903 1753 1 1755 1784 2 ND2P $T=367040 1052240 0 0 $X=367040 $Y=1051860
X1904 1822 1 1827 1755 2 ND2P $T=378820 1011920 1 0 $X=378820 $Y=1006500
X1905 140 1 127 1847 2 ND2P $T=386260 1062320 1 0 $X=386260 $Y=1056900
X1906 1905 1 1924 1933 2 ND2P $T=402380 1001840 0 180 $X=398660 $Y=996420
X1907 1887 1 1908 1974 2 ND2P $T=401760 1052240 0 0 $X=401760 $Y=1051860
X1908 1872 1 1838 1982 2 ND2P $T=406100 911120 1 180 $X=402380 $Y=910740
X1909 1961 1 1950 1835 2 ND2P $T=404240 1032080 0 0 $X=404240 $Y=1031700
X1910 1871 1 1908 1996 2 ND2P $T=410440 1052240 1 180 $X=406720 $Y=1051860
X1911 1994 1 1989 1942 2 ND2P $T=408580 941360 1 0 $X=408580 $Y=935940
X1912 2030 1 2014 1887 2 ND2P $T=415400 1052240 1 0 $X=415400 $Y=1046820
X1913 2046 1 2035 188 2 ND2P $T=417880 1011920 1 0 $X=417880 $Y=1006500
X1914 2477 1 224 2585 2 ND2P $T=503440 1062320 1 0 $X=503440 $Y=1056900
X1915 229 1 224 2607 2 ND2P $T=512120 1062320 0 180 $X=508400 $Y=1056900
X1916 2677 1 236 2709 2 ND2P $T=528240 1062320 1 0 $X=528240 $Y=1056900
X1917 2679 1 2655 2729 2 ND2P $T=531340 1032080 0 0 $X=531340 $Y=1031700
X1918 2532 1 2746 2724 2 ND2P $T=533200 961520 0 0 $X=533200 $Y=961140
X1919 2752 1 2763 2775 2 ND2P $T=535680 1001840 0 0 $X=535680 $Y=1001460
X1920 2644 1 2763 2776 2 ND2P $T=536920 1011920 1 0 $X=536920 $Y=1006500
X1921 235 1 245 244 2 ND2P $T=540640 1062320 0 180 $X=536920 $Y=1056900
X1922 2541 1 2714 2773 2 ND2P $T=541880 1011920 1 180 $X=538160 $Y=1011540
X1923 2741 1 2714 2777 2 ND2P $T=546220 1022000 0 180 $X=542500 $Y=1016580
X1924 2650 1 2771 2807 2 ND2P $T=547460 1022000 0 0 $X=547460 $Y=1021620
X1925 2657 1 250 2818 2 ND2P $T=551800 1042160 1 180 $X=548080 $Y=1041780
X1926 2756 1 2796 2806 2 ND2P $T=553660 901040 1 180 $X=549940 $Y=900660
X1927 2805 1 250 2826 2 ND2P $T=549940 1052240 1 0 $X=549940 $Y=1046820
X1928 2787 1 2854 2823 2 ND2P $T=556760 971600 1 0 $X=556760 $Y=966180
X1929 2793 1 2796 2850 2 ND2P $T=559240 911120 1 0 $X=559240 $Y=905700
X1930 1077 28 1008 2 1 18 XOR3 $T=259780 870800 1 180 $X=248620 $Y=870420
X1931 32 29 1075 2 1 42 XOR3 $T=261640 880880 1 0 $X=261640 $Y=875460
X1932 1082 31 1059 2 1 44 XOR3 $T=262880 880880 0 0 $X=262880 $Y=880500
X1933 1186 1196 45 2 1 60 XOR3 $T=283340 880880 1 0 $X=283340 $Y=875460
X1934 1375 1344 1240 2 1 73 XOR3 $T=301940 880880 0 0 $X=301940 $Y=880500
X1935 1516 1522 1573 2 1 83 XOR3 $T=318680 901040 1 0 $X=318680 $Y=895620
X1936 1483 1510 1398 2 1 88 XOR3 $T=322400 880880 0 0 $X=322400 $Y=880500
X1937 1560 1545 1544 2 1 96 XOR3 $T=328600 890960 1 0 $X=328600 $Y=885540
X1938 1596 1602 1568 2 1 99 XOR3 $T=331080 901040 1 0 $X=331080 $Y=895620
X1939 1703 1708 1670 2 1 124 XOR3 $T=352780 890960 1 0 $X=352780 $Y=885540
X1940 1773 1786 1806 2 1 1772 XOR3 $T=370140 1022000 0 0 $X=370140 $Y=1021620
X1941 1789 1792 1767 2 1 153 XOR3 $T=371380 911120 1 0 $X=371380 $Y=905700
X1942 1809 1808 1805 2 1 1785 XOR3 $T=375720 1042160 1 0 $X=375720 $Y=1036740
X1943 1760 1753 1755 2 1 143 XOR3 $T=375720 1052240 0 0 $X=375720 $Y=1051860
X1944 1772 1782 1781 2 1 1740 XOR3 $T=378200 1032080 0 0 $X=378200 $Y=1031700
X1945 1864 1872 1838 2 1 173 XOR3 $T=389360 911120 1 0 $X=389360 $Y=905700
X1946 1843 1849 1835 2 1 1793 XOR3 $T=394940 1042160 0 0 $X=394940 $Y=1041780
X1947 2006 1985 1999 2 1 189 XOR3 $T=411680 890960 1 0 $X=411680 $Y=885540
X1948 2111 2117 2113 2 1 199 XOR3 $T=429040 911120 0 0 $X=429040 $Y=910740
X1949 2193 2207 2258 2 1 212 XOR3 $T=443920 880880 0 0 $X=443920 $Y=880500
X1950 2269 2240 2274 2 1 216 XOR3 $T=456320 880880 0 0 $X=456320 $Y=880500
X1951 2285 2171 2288 2 1 219 XOR3 $T=463140 870800 0 0 $X=463140 $Y=870420
X1952 220 221 227 2 1 228 XOR3 $T=482980 870800 0 0 $X=482980 $Y=870420
X1953 2477 229 224 2 1 222 XOR3 $T=497860 1062320 0 180 $X=486700 $Y=1056900
X1954 2429 2360 2426 2 1 230 XOR3 $T=487320 1052240 0 0 $X=487320 $Y=1051860
X1955 2502 2439 2549 2 1 2573 XOR3 $T=494760 971600 1 0 $X=494760 $Y=966180
X1956 2548 2553 2598 2 1 2608 XOR3 $T=501580 890960 1 0 $X=501580 $Y=885540
X1957 2547 2496 2454 2 1 235 XOR3 $T=504680 1052240 0 0 $X=504680 $Y=1051860
X1958 2507 2564 2555 2 1 2634 XOR3 $T=507160 951440 0 0 $X=507160 $Y=951060
X1959 2694 2700 2726 2 1 2756 XOR3 $T=525140 911120 1 0 $X=525140 $Y=905700
X1960 2608 2634 2669 2 1 243 XOR3 $T=525760 870800 0 0 $X=525760 $Y=870420
X1961 2661 2673 2666 2 1 2766 XOR3 $T=525760 921200 1 0 $X=525760 $Y=915780
X1962 2684 239 2690 2 1 2751 XOR3 $T=529480 890960 1 0 $X=529480 $Y=885540
X1963 2650 2735 2771 2 1 2805 XOR3 $T=531960 1042160 1 0 $X=531960 $Y=1036740
X1964 2758 2668 2743 2 1 247 XOR3 $T=536300 1052240 1 0 $X=536300 $Y=1046820
X1965 2764 2772 2781 2 1 2810 XOR3 $T=537540 911120 1 0 $X=537540 $Y=905700
X1966 2674 2532 2746 2 1 2793 XOR3 $T=538160 961520 0 0 $X=538160 $Y=961140
X1967 2736 2754 2745 2 1 2782 XOR3 $T=539400 901040 1 0 $X=539400 $Y=895620
X1968 2756 2793 2796 2 1 2830 XOR3 $T=542500 911120 0 0 $X=542500 $Y=910740
X1969 2706 2794 2797 2 1 2795 XOR3 $T=542500 931280 0 0 $X=542500 $Y=930900
X1970 2770 2618 2789 2 1 2828 XOR3 $T=543120 1011920 0 0 $X=543120 $Y=1011540
X1971 2766 2783 2778 2 1 2871 XOR3 $T=544360 921200 0 0 $X=544360 $Y=920820
X1972 2752 2644 2763 2 1 2812 XOR3 $T=546220 1001840 0 0 $X=546220 $Y=1001460
X1973 2805 2657 2842 2 1 2853 XOR3 $T=546840 1052240 0 0 $X=546840 $Y=1051860
X1974 2829 2699 2884 2 1 2890 XOR3 $T=558620 1022000 0 0 $X=558620 $Y=1021620
X1975 2821 2787 2854 2 1 2820 XOR3 $T=572260 971600 1 180 $X=561100 $Y=971220
X1976 2926 2913 2927 2 1 2989 XOR3 $T=585900 971600 0 0 $X=585900 $Y=971220
X1977 1358 1 1376 1387 2 1398 ND3HT $T=294500 880880 1 0 $X=294500 $Y=875460
X1978 149 1 155 1847 2 152 ND3HT $T=378820 1062320 1 0 $X=378820 $Y=1056900
X1979 231 1 2585 2607 2 236 ND3HT $T=512120 1062320 1 0 $X=512120 $Y=1056900
X1980 2704 1 2720 2729 2 2714 ND3HT $T=526380 1032080 1 0 $X=526380 $Y=1026660
X1981 1023 22 20 2 1 XOR2HS $T=252340 880880 0 180 $X=246760 $Y=875460
X1982 1130 1123 1104 2 1 XOR2HS $T=266600 890960 1 180 $X=261020 $Y=890580
X1983 1347 1275 1262 2 1 XOR2HS $T=295740 890960 0 180 $X=290160 $Y=885540
X1984 1353 1348 1326 2 1 XOR2HS $T=296360 901040 1 180 $X=290780 $Y=900660
X1985 1429 1420 1406 2 1 XOR2HS $T=306900 901040 0 180 $X=301320 $Y=895620
X1986 1432 69 1410 2 1 XOR2HS $T=307520 880880 0 180 $X=301940 $Y=875460
X1987 1475 1473 1457 2 1 XOR2HS $T=313720 911120 1 180 $X=308140 $Y=910740
X1988 74 1478 1489 2 1 XOR2HS $T=319300 870800 1 180 $X=313720 $Y=870420
X1989 1570 1531 1556 2 1 XOR2HS $T=329220 911120 1 180 $X=323640 $Y=910740
X1990 1634 1605 1613 2 1 XOR2HS $T=339140 921200 0 180 $X=333560 $Y=915780
X1991 1635 93 1619 2 1 XOR2HS $T=339760 880880 0 180 $X=334180 $Y=875460
X1992 102 1642 1651 2 1 XOR2HS $T=345960 880880 0 180 $X=340380 $Y=875460
X1993 1679 1655 1662 2 1 XOR2HS $T=349680 921200 0 180 $X=344100 $Y=915780
X1994 1727 1700 1709 2 1 XOR2HS $T=358360 921200 1 180 $X=352780 $Y=920820
X1995 1745 1749 1757 2 1 XOR2HS $T=360840 921200 1 0 $X=360840 $Y=915780
X1996 1795 1677 1777 2 1 XOR2HS $T=374480 921200 1 180 $X=368900 $Y=920820
X1997 1825 1818 1814 2 1 XOR2HS $T=381920 931280 0 180 $X=376340 $Y=925860
X1998 1811 1799 1802 2 1 XOR2HS $T=376340 1001840 1 0 $X=376340 $Y=996420
X1999 1811 1836 1829 2 1 XOR2HS $T=386260 951440 1 180 $X=380680 $Y=951060
X2000 1851 1771 1832 2 1 XOR2HS $T=386880 921200 1 180 $X=381300 $Y=920820
X2001 1861 1852 1841 2 1 XOR2HS $T=388120 971600 1 180 $X=382540 $Y=971220
X2002 1802 1801 1854 2 1 XOR2HS $T=383160 1022000 1 0 $X=383160 $Y=1016580
X2003 1869 1868 1859 2 1 XOR2HS $T=391220 1001840 1 180 $X=385640 $Y=1001460
X2004 1875 1867 1862 2 1 XOR2HS $T=391840 931280 0 180 $X=386260 $Y=925860
X2005 1865 1863 1831 2 1 XOR2HS $T=388120 991760 1 0 $X=388120 $Y=986340
X2006 1890 1886 1801 2 1 XOR2HS $T=394320 1022000 0 180 $X=388740 $Y=1016580
X2007 1901 1874 1914 2 1 XOR2HS $T=393080 931280 1 0 $X=393080 $Y=925860
X2008 1931 1935 1952 2 1 XOR2HS $T=398660 931280 1 0 $X=398660 $Y=925860
X2009 1915 1928 1956 2 1 XOR2HS $T=398660 1022000 1 0 $X=398660 $Y=1016580
X2010 1969 1922 2002 2 1 XOR2HS $T=407340 921200 0 0 $X=407340 $Y=920820
X2011 2008 2001 1993 2 1 XOR2HS $T=412920 1042160 0 180 $X=407340 $Y=1036740
X2012 2051 1898 2027 2 1 XOR2HS $T=419120 1001840 1 180 $X=413540 $Y=1001460
X2013 2031 1948 2047 2 1 XOR2HS $T=415400 931280 1 0 $X=415400 $Y=925860
X2014 2079 2069 186 2 1 XOR2HS $T=424700 1062320 0 180 $X=419120 $Y=1056900
X2015 2081 2078 2064 2 1 XOR2HS $T=425320 1032080 0 180 $X=419740 $Y=1026660
X2016 2088 2082 2069 2 1 XOR2HS $T=425940 1052240 0 180 $X=420360 $Y=1046820
X2017 2070 1980 2094 2 1 XOR2HS $T=422220 921200 0 0 $X=422220 $Y=920820
X2018 2087 2063 2105 2 1 XOR2HS $T=424080 901040 0 0 $X=424080 $Y=900660
X2019 2107 2091 2120 2 1 XOR2HS $T=428420 1042160 1 0 $X=428420 $Y=1036740
X2020 2115 2121 2138 2 1 XOR2HS $T=429040 880880 1 0 $X=429040 $Y=875460
X2021 2125 2129 2146 2 1 XOR2HS $T=430280 890960 1 0 $X=430280 $Y=885540
X2022 2147 2141 2170 2 1 XOR2HS $T=434000 1052240 1 0 $X=434000 $Y=1046820
X2023 2180 2089 2162 2 1 XOR2HS $T=440820 1001840 1 180 $X=435240 $Y=1001460
X2024 2184 2084 2166 2 1 XOR2HS $T=441440 921200 1 180 $X=435860 $Y=920820
X2025 2176 2167 2197 2 1 XOR2HS $T=438960 880880 1 0 $X=438960 $Y=875460
X2026 2156 2152 2198 2 1 XOR2HS $T=438960 890960 1 0 $X=438960 $Y=885540
X2027 2204 2175 2195 2 1 XOR2HS $T=446400 1032080 0 180 $X=440820 $Y=1026660
X2028 2200 2208 2223 2 1 XOR2HS $T=443300 911120 0 0 $X=443300 $Y=910740
X2029 2182 2169 2234 2 1 XOR2HS $T=444540 1042160 0 0 $X=444540 $Y=1041780
X2030 2261 2254 209 2 1 XOR2HS $T=454460 1062320 0 180 $X=448880 $Y=1056900
X2031 2263 2253 2246 2 1 XOR2HS $T=455080 911120 1 180 $X=449500 $Y=910740
X2032 2251 2205 2270 2 1 XOR2HS $T=451360 1042160 0 0 $X=451360 $Y=1041780
X2033 2260 2257 2233 2 1 XOR2HS $T=453840 1042160 1 0 $X=453840 $Y=1036740
X2034 2311 2305 2290 2 1 XOR2HS $T=463140 1032080 1 180 $X=457560 $Y=1031700
X2035 2294 2323 2303 2 1 XOR2HS $T=465620 901040 1 180 $X=460040 $Y=900660
X2036 2336 2301 2315 2 1 XOR2HS $T=466860 1042160 1 180 $X=461280 $Y=1041780
X2037 2318 2321 2334 2 1 XOR2HS $T=461900 1011920 1 0 $X=461900 $Y=1006500
X2038 2309 2330 2331 2 1 XOR2HS $T=466860 901040 0 0 $X=466860 $Y=900660
X2039 2370 2232 2349 2 1 XOR2HS $T=472440 1001840 1 180 $X=466860 $Y=1001460
X2040 2376 2343 2352 2 1 XOR2HS $T=473680 901040 0 180 $X=468100 $Y=895620
X2041 2365 2359 2379 2 1 XOR2HS $T=469960 1042160 0 0 $X=469960 $Y=1041780
X2042 2235 2384 218 2 1 XOR2HS $T=476780 880880 1 180 $X=471200 $Y=880500
X2043 2394 2351 2375 2 1 XOR2HS $T=476780 1032080 1 180 $X=471200 $Y=1031700
X2044 2424 2392 2404 2 1 XOR2HS $T=482360 1001840 1 180 $X=476780 $Y=1001460
X2045 2273 2412 2428 2 1 XOR2HS $T=478020 880880 0 0 $X=478020 $Y=880500
X2046 2201 2417 2431 2 1 XOR2HS $T=478640 951440 1 0 $X=478640 $Y=946020
X2047 2406 2436 2414 2 1 XOR2HS $T=484220 961520 1 180 $X=478640 $Y=961140
X2048 2407 2401 2403 2 1 XOR2HS $T=479260 890960 0 0 $X=479260 $Y=890580
X2049 2425 2415 2416 2 1 XOR2HS $T=480500 1032080 0 0 $X=480500 $Y=1031700
X2050 2434 2428 223 2 1 XOR2HS $T=483600 880880 1 0 $X=483600 $Y=875460
X2051 2460 2450 2479 2 1 XOR2HS $T=486700 1032080 1 0 $X=486700 $Y=1026660
X2052 2448 2468 2485 2 1 XOR2HS $T=487940 951440 0 0 $X=487940 $Y=951060
X2053 2469 2451 2471 2 1 XOR2HS $T=494140 901040 0 180 $X=488560 $Y=895620
X2054 2473 2474 2482 2 1 XOR2HS $T=488560 981680 1 0 $X=488560 $Y=976260
X2055 2466 2461 2490 2 1 XOR2HS $T=488560 1042160 1 0 $X=488560 $Y=1036740
X2056 2441 2399 2491 2 1 XOR2HS $T=488560 1042160 0 0 $X=488560 $Y=1041780
X2057 2104 2481 2467 2 1 XOR2HS $T=490420 880880 0 0 $X=490420 $Y=880500
X2058 2458 2453 2487 2 1 XOR2HS $T=490420 961520 0 0 $X=490420 $Y=961140
X2059 2476 2459 2486 2 1 XOR2HS $T=496000 1001840 1 180 $X=490420 $Y=1001460
X2060 2480 2472 2501 2 1 XOR2HS $T=491040 991760 1 0 $X=491040 $Y=986340
X2061 2435 2494 2455 2 1 XOR2HS $T=493520 890960 1 0 $X=493520 $Y=885540
X2062 2478 2488 2515 2 1 XOR2HS $T=493520 1032080 1 0 $X=493520 $Y=1026660
X2063 2525 2520 2506 2 1 XOR2HS $T=499720 971600 1 180 $X=494140 $Y=971220
X2064 2534 2528 2511 2 1 XOR2HS $T=500960 901040 0 180 $X=495380 $Y=895620
X2065 2510 2513 2527 2 1 XOR2HS $T=495380 1001840 1 0 $X=495380 $Y=996420
X2066 2523 2530 2512 2 1 XOR2HS $T=500960 1011920 1 180 $X=495380 $Y=1011540
X2067 2509 2521 2539 2 1 XOR2HS $T=496620 981680 1 0 $X=496620 $Y=976260
X2068 2545 2551 2565 2 1 XOR2HS $T=500340 1001840 0 0 $X=500340 $Y=1001460
X2069 2522 2535 2571 2 1 XOR2HS $T=501580 981680 0 0 $X=501580 $Y=981300
X2070 2550 2561 2574 2 1 XOR2HS $T=502200 961520 0 0 $X=502200 $Y=961140
X2071 2557 2500 2575 2 1 XOR2HS $T=502200 1022000 1 0 $X=502200 $Y=1016580
X2072 2552 2440 2558 2 1 XOR2HS $T=507780 1032080 0 180 $X=502200 $Y=1026660
X2073 2582 2503 2592 2 1 XOR2HS $T=507160 880880 1 0 $X=507160 $Y=875460
X2074 2568 2563 2590 2 1 XOR2HS $T=507160 901040 1 0 $X=507160 $Y=895620
X2075 2567 2529 2603 2 1 XOR2HS $T=507780 1011920 0 0 $X=507780 $Y=1011540
X2076 2536 2580 2566 2 1 XOR2HS $T=507780 1042160 1 0 $X=507780 $Y=1036740
X2077 2592 2597 233 2 1 XOR2HS $T=509640 870800 0 0 $X=509640 $Y=870420
X2078 2622 2613 2596 2 1 XOR2HS $T=515220 981680 0 180 $X=509640 $Y=976260
X2079 2594 2604 2624 2 1 XOR2HS $T=510880 1032080 1 0 $X=510880 $Y=1026660
X2080 2617 2631 2605 2 1 XOR2HS $T=517080 941360 1 180 $X=511500 $Y=940980
X2081 2583 2591 2632 2 1 XOR2HS $T=512120 971600 1 0 $X=512120 $Y=966180
X2082 2635 2606 2615 2 1 XOR2HS $T=517700 1001840 0 180 $X=512120 $Y=996420
X2083 2625 2619 2643 2 1 XOR2HS $T=513980 890960 1 0 $X=513980 $Y=885540
X2084 2656 2651 2640 2 1 XOR2HS $T=521420 931280 0 180 $X=515840 $Y=925860
X2085 2610 2623 2593 2 1 XOR2HS $T=515840 991760 1 0 $X=515840 $Y=986340
X2086 2638 2628 2653 2 1 XOR2HS $T=515840 1022000 0 0 $X=515840 $Y=1021620
X2087 2620 2621 2660 2 1 XOR2HS $T=517080 911120 1 0 $X=517080 $Y=905700
X2088 2637 2630 2626 2 1 XOR2HS $T=517080 911120 0 0 $X=517080 $Y=910740
X2089 2636 2629 2665 2 1 XOR2HS $T=517700 901040 1 0 $X=517700 $Y=895620
X2090 2645 2648 2671 2 1 XOR2HS $T=518320 941360 0 0 $X=518320 $Y=940980
X2091 2499 2662 2678 2 1 XOR2HS $T=519560 951440 0 0 $X=519560 $Y=951060
X2092 2639 2649 2685 2 1 XOR2HS $T=520800 961520 0 0 $X=520800 $Y=961140
X2093 2589 2586 2641 2 1 XOR2HS $T=520800 1032080 0 0 $X=520800 $Y=1031700
X2094 2677 2508 238 2 1 XOR2HS $T=522040 1052240 0 0 $X=522040 $Y=1051860
X2095 2667 2652 2691 2 1 XOR2HS $T=522660 931280 1 0 $X=522660 $Y=925860
X2096 2689 2654 2707 2 1 XOR2HS $T=524520 941360 0 0 $X=524520 $Y=940980
X2097 2664 2670 2708 2 1 XOR2HS $T=524520 1011920 1 0 $X=524520 $Y=1006500
X2098 2675 2680 2712 2 1 XOR2HS $T=525140 981680 0 0 $X=525140 $Y=981300
X2099 2672 2681 2713 2 1 XOR2HS $T=525140 1001840 0 0 $X=525140 $Y=1001460
X2100 2703 2697 2715 2 1 XOR2HS $T=525760 981680 1 0 $X=525760 $Y=976260
X2101 2663 2676 2716 2 1 XOR2HS $T=525760 991760 1 0 $X=525760 $Y=986340
X2102 2692 2683 2717 2 1 XOR2HS $T=525760 1001840 1 0 $X=525760 $Y=996420
X2103 2678 2718 2730 2 1 XOR2HS $T=528240 951440 0 0 $X=528240 $Y=951060
X2104 2687 2698 2731 2 1 XOR2HS $T=528240 1022000 0 0 $X=528240 $Y=1021620
X2105 2721 2725 2734 2 1 XOR2HS $T=529480 921200 0 0 $X=529480 $Y=920820
X2106 2722 2727 2767 2 1 XOR2HS $T=534440 941360 0 0 $X=534440 $Y=940980
X2107 2739 2719 2779 2 1 XOR2HS $T=536920 951440 0 0 $X=536920 $Y=951060
X2108 2573 2751 2791 2 1 XOR2HS $T=539400 880880 1 0 $X=539400 $Y=875460
X2109 2804 2791 2809 2 1 XOR2HS $T=546220 880880 1 0 $X=546220 $Y=875460
X2110 2841 2819 2857 2 1 XOR2HS $T=555520 1032080 0 0 $X=555520 $Y=1031700
X2111 2817 2733 2841 2 1 XOR2HS $T=556760 1032080 1 0 $X=556760 $Y=1026660
X2112 2732 2857 2887 2 1 XOR2HS $T=564820 1052240 1 0 $X=564820 $Y=1046820
X2113 2887 2898 2905 2 1 XOR2HS $T=572260 1052240 1 0 $X=572260 $Y=1046820
X2114 2928 2912 2946 2 1 XOR2HS $T=584040 1032080 1 0 $X=584040 $Y=1026660
X2115 3052 3038 3114 2 1 XOR2HS $T=620620 981680 0 180 $X=615040 $Y=976260
X2116 3209 3261 3272 2 1 XOR2HS $T=640460 991760 1 0 $X=640460 $Y=986340
X2117 333 3250 340 2 1 XOR2HS $T=644180 880880 1 0 $X=644180 $Y=875460
X2118 3292 3219 3336 2 1 XOR2HS $T=660920 981680 1 180 $X=655340 $Y=981300
X2119 356 3471 3436 2 1 XOR2HS $T=681380 1001840 1 180 $X=675800 $Y=1001460
X2120 363 3501 3434 2 1 XOR2HS $T=689440 981680 1 180 $X=683860 $Y=981300
X2121 3490 3455 3481 2 1 XOR2HS $T=683860 1022000 1 0 $X=683860 $Y=1016580
X2122 364 3502 3467 2 1 XOR2HS $T=691300 1011920 0 180 $X=685720 $Y=1006500
X2123 369 3520 3435 2 1 XOR2HS $T=695020 1001840 1 180 $X=689440 $Y=1001460
X2124 3537 3534 3465 2 1 XOR2HS $T=695640 981680 0 180 $X=690060 $Y=976260
X2125 379 3552 3433 2 1 XOR2HS $T=698740 991760 1 180 $X=693160 $Y=991380
X2126 3213 3597 3603 2 1 XOR2HS $T=709900 901040 0 0 $X=709900 $Y=900660
X2127 3199 3602 393 2 1 XOR2HS $T=711760 870800 0 0 $X=711760 $Y=870420
X2128 3170 3590 3621 2 1 XOR2HS $T=713000 890960 1 0 $X=713000 $Y=885540
X2129 314 392 3627 2 1 XOR2HS $T=714860 880880 0 0 $X=714860 $Y=880500
X2130 3179 3581 3565 2 1 XOR2HS $T=714860 901040 1 0 $X=714860 $Y=895620
X2131 3241 3610 3636 2 1 XOR2HS $T=716720 911120 1 0 $X=716720 $Y=905700
X2132 311 398 3641 2 1 XOR2HS $T=718580 870800 0 0 $X=718580 $Y=870420
X2133 3245 3623 3595 2 1 XOR2HS $T=718580 911120 0 0 $X=718580 $Y=910740
X2134 3264 3612 3642 2 1 XOR2HS $T=718580 931280 1 0 $X=718580 $Y=925860
X2135 3237 3635 3643 2 1 XOR2HS $T=718580 951440 1 0 $X=718580 $Y=946020
X2136 3247 3628 3645 2 1 XOR2HS $T=719820 931280 0 0 $X=719820 $Y=930900
X2137 1573 1516 1522 1670 1 2 MAO222P $T=336040 911120 1 0 $X=336040 $Y=905700
X2138 1670 1703 1708 1767 1 2 MAO222P $T=354020 911120 1 0 $X=354020 $Y=905700
X2139 1767 1789 1792 1838 1 2 MAO222P $T=371380 911120 0 0 $X=371380 $Y=910740
X2140 2216 2193 2207 2245 1 2 MAO222P $T=443920 890960 0 0 $X=443920 $Y=890580
X2141 2245 2265 2241 2274 1 2 MAO222P $T=453220 890960 1 0 $X=453220 $Y=885540
X2142 2288 2285 2171 213 1 2 MAO222P $T=456940 870800 0 0 $X=456940 $Y=870420
X2143 2555 2507 2564 2576 1 2 MAO222P $T=500960 951440 0 0 $X=500960 $Y=951060
X2144 2666 2661 2673 2686 1 2 MAO222P $T=519560 921200 1 0 $X=519560 $Y=915780
X2145 2690 2684 239 2598 1 2 MAO222P $T=523280 890960 1 0 $X=523280 $Y=885540
X2146 2726 2694 2700 2745 1 2 MAO222P $T=529480 901040 0 0 $X=529480 $Y=900660
X2147 2745 2736 2754 2690 1 2 MAO222P $T=533200 901040 1 0 $X=533200 $Y=895620
X2148 2778 2766 2783 2781 1 2 MAO222P $T=538160 921200 0 0 $X=538160 $Y=920820
X2149 2789 2770 2618 2763 1 2 MAO222P $T=540640 1011920 1 0 $X=540640 $Y=1006500
X2150 2797 2706 2794 2755 1 2 MAO222P $T=542500 941360 1 0 $X=542500 $Y=935940
X2151 2824 2820 2812 2816 1 2 MAO222P $T=551800 981680 1 0 $X=551800 $Y=976260
X2152 1103 35 1133 37 1 2 ND3P $T=272180 870800 1 180 $X=267220 $Y=870420
X2153 1228 1217 1222 1189 1 2 ND3P $T=278380 880880 1 0 $X=278380 $Y=875460
X2154 1520 1544 1527 1502 1 2 ND3P $T=318060 880880 1 0 $X=318060 $Y=875460
X2155 1758 145 1763 1784 1 2 ND3P $T=370760 1052240 0 0 $X=370760 $Y=1051860
X2156 1963 1999 1982 1941 1 2 ND3P $T=404860 911120 1 0 $X=404860 $Y=905700
X2157 1974 2050 1996 2033 1 2 ND3P $T=412300 1062320 1 0 $X=412300 $Y=1056900
X2158 2015 1883 2038 2032 1 2 ND3P $T=419740 931280 1 180 $X=414780 $Y=930900
X2159 2142 195 2122 2151 1 2 ND3P $T=430900 1062320 1 0 $X=430900 $Y=1056900
X2160 2123 2189 2155 2165 1 2 ND3P $T=435860 901040 0 0 $X=435860 $Y=900660
X2161 2316 2363 2291 2307 1 2 ND3P $T=460660 1052240 0 0 $X=460660 $Y=1051860
X2162 2405 2426 2390 2387 1 2 ND3P $T=476780 1052240 0 0 $X=476780 $Y=1051860
X2163 2380 2434 2388 2427 1 2 ND3P $T=478020 870800 0 0 $X=478020 $Y=870420
X2164 2682 2549 2696 2658 1 2 ND3P $T=526380 961520 0 180 $X=521420 $Y=956100
X2165 2693 2743 2709 2701 1 2 ND3P $T=527000 1052240 1 0 $X=527000 $Y=1046820
X2166 2723 2669 2737 2710 1 2 ND3P $T=533200 880880 0 180 $X=528240 $Y=875460
X2167 2724 2702 2728 2711 1 2 ND3P $T=533200 961520 0 180 $X=528240 $Y=956100
X2168 2777 2789 2773 2760 1 2 ND3P $T=537540 1022000 1 0 $X=537540 $Y=1016580
X2169 2750 2771 2792 2765 1 2 ND3P $T=543120 1042160 1 180 $X=538160 $Y=1041780
X2170 2775 2769 2776 2780 1 2 ND3P $T=541260 1001840 0 0 $X=541260 $Y=1001460
X2171 2806 2785 2850 2800 1 2 ND3P $T=550560 890960 1 180 $X=545600 $Y=890580
X2172 2808 2819 2807 2811 1 2 ND3P $T=547460 1032080 1 0 $X=547460 $Y=1026660
X2173 2823 2798 2831 2834 1 2 ND3P $T=551800 971600 1 0 $X=551800 $Y=966180
X2174 2826 2849 2818 2825 1 2 ND3P $T=552420 1042160 0 0 $X=552420 $Y=1041780
X2175 2832 2839 2822 2815 1 2 ND3P $T=553040 1022000 1 0 $X=553040 $Y=1016580
X2176 2866 2833 2873 2868 1 2 ND3P $T=561720 1032080 0 0 $X=561720 $Y=1031700
X2177 3104 3126 3088 3030 1 2 ND3P $T=618760 1022000 0 0 $X=618760 $Y=1021620
X2178 699 847 878 1 2 ND2 $T=233740 991760 1 0 $X=233740 $Y=986340
X2179 809 788 863 1 2 ND2 $T=234980 941360 0 0 $X=234980 $Y=940980
X2180 793 844 878 1 2 ND2 $T=235600 961520 0 0 $X=235600 $Y=961140
X2181 748 886 699 1 2 ND2 $T=237460 971600 1 180 $X=235600 $Y=971220
X2182 878 893 817 1 2 ND2 $T=238080 1011920 0 180 $X=236220 $Y=1006500
X2183 872 898 730 1 2 ND2 $T=238700 1042160 1 180 $X=236840 $Y=1041780
X2184 904 975 786 1 2 ND2 $T=245520 931280 1 180 $X=243660 $Y=930900
X2185 931 1024 851 1 2 ND2 $T=245520 981680 0 180 $X=243660 $Y=976260
X2186 872 1017 1007 1 2 ND2 $T=248620 1022000 0 0 $X=248620 $Y=1021620
X2187 1004 1050 1028 1 2 ND2 $T=251100 961520 1 0 $X=251100 $Y=956100
X2188 793 1036 852 1 2 ND2 $T=251720 951440 1 0 $X=251720 $Y=946020
X2189 1023 1043 22 1 2 ND2 $T=255440 880880 0 180 $X=253580 $Y=875460
X2190 1004 1013 863 1 2 ND2 $T=253580 981680 1 0 $X=253580 $Y=976260
X2191 1030 769 26 1 2 ND2 $T=257920 1032080 1 180 $X=256060 $Y=1031700
X2192 1028 1076 778 1 2 ND2 $T=260400 981680 0 180 $X=258540 $Y=976260
X2193 1075 1103 29 1 2 ND2 $T=261640 870800 1 180 $X=259780 $Y=870420
X2194 1075 1133 32 1 2 ND2 $T=265360 870800 1 180 $X=263500 $Y=870420
X2195 995 1066 1126 1 2 ND2 $T=263500 1022000 0 0 $X=263500 $Y=1021620
X2196 706 1099 785 1 2 ND2 $T=265360 981680 1 0 $X=265360 $Y=976260
X2197 1048 1153 1022 1 2 ND2 $T=269080 941360 1 180 $X=267220 $Y=940980
X2198 1143 785 1064 1 2 ND2 $T=269080 981680 0 180 $X=267220 $Y=976260
X2199 834 1183 1074 1 2 ND2 $T=272800 991760 0 180 $X=270940 $Y=986340
X2200 1104 1152 1167 1 2 ND2 $T=272180 890960 0 0 $X=272180 $Y=890580
X2201 35 43 1077 1 2 ND2 $T=272800 870800 0 0 $X=272800 $Y=870420
X2202 1186 1189 1196 1 2 ND2 $T=272800 880880 1 0 $X=272800 $Y=875460
X2203 1149 1074 1064 1 2 ND2 $T=274660 961520 1 0 $X=274660 $Y=956100
X2204 1221 1110 1030 1 2 ND2 $T=277760 1022000 0 180 $X=275900 $Y=1016580
X2205 860 1139 797 1 2 ND2 $T=277760 1001840 1 0 $X=277760 $Y=996420
X2206 1077 50 28 1 2 ND2 $T=280860 870800 0 0 $X=280860 $Y=870420
X2207 1273 1211 1177 1 2 ND2 $T=283340 1052240 0 180 $X=281480 $Y=1046820
X2208 53 51 54 1 2 ND2 $T=283960 870800 0 0 $X=283960 $Y=870420
X2209 1165 1025 1283 1 2 ND2 $T=284580 1042160 0 0 $X=284580 $Y=1041780
X2210 892 1293 1022 1 2 ND2 $T=287060 951440 1 180 $X=285200 $Y=951060
X2211 1164 1284 892 1 2 ND2 $T=288300 931280 1 180 $X=286440 $Y=930900
X2212 870 1286 15 1 2 ND2 $T=288300 1052240 0 180 $X=286440 $Y=1046820
X2213 1297 1290 1147 1 2 ND2 $T=288920 901040 0 180 $X=287060 $Y=895620
X2214 1300 1299 1266 1 2 ND2 $T=289540 1011920 1 180 $X=287680 $Y=1011540
X2215 1326 1336 1167 1 2 ND2 $T=290780 901040 0 180 $X=288920 $Y=895620
X2216 932 1329 1007 1 2 ND2 $T=293260 1032080 0 0 $X=293260 $Y=1031700
X2217 62 1352 61 1 2 ND2 $T=296360 1062320 0 180 $X=294500 $Y=1056900
X2218 1375 1358 1344 1 2 ND2 $T=298220 890960 1 0 $X=298220 $Y=885540
X2219 764 1339 878 1 2 ND2 $T=298220 961520 1 0 $X=298220 $Y=956100
X2220 764 1274 817 1 2 ND2 $T=298220 961520 0 0 $X=298220 $Y=961140
X2221 63 1346 1318 1 2 ND2 $T=300080 1052240 1 180 $X=298220 $Y=1051860
X2222 1405 1386 1224 1 2 ND2 $T=301940 941360 0 180 $X=300080 $Y=935940
X2223 1414 1403 1007 1 2 ND2 $T=303180 1022000 1 180 $X=301320 $Y=1021620
X2224 1445 1454 71 1 2 ND2 $T=307520 880880 1 0 $X=307520 $Y=875460
X2225 715 1359 1243 1 2 ND2 $T=311860 941360 1 0 $X=311860 $Y=935940
X2226 1483 1502 1510 1 2 ND2 $T=313720 880880 0 0 $X=313720 $Y=880500
X2227 1491 783 1506 1 2 ND2 $T=314960 921200 0 0 $X=314960 $Y=920820
X2228 1492 715 1500 1 2 ND2 $T=314960 941360 1 0 $X=314960 $Y=935940
X2229 1488 861 1500 1 2 ND2 $T=316820 921200 1 0 $X=316820 $Y=915780
X2230 1491 902 1500 1 2 ND2 $T=318680 921200 0 0 $X=318680 $Y=920820
X2231 1500 739 1512 1 2 ND2 $T=318680 931280 1 0 $X=318680 $Y=925860
X2232 1492 1437 1506 1 2 ND2 $T=318680 941360 0 0 $X=318680 $Y=940980
X2233 1138 1509 804 1 2 ND2 $T=320540 961520 1 180 $X=318680 $Y=961140
X2234 1512 21 1532 1 2 ND2 $T=318680 971600 0 0 $X=318680 $Y=971220
X2235 1507 1448 1532 1 2 ND2 $T=320540 981680 1 0 $X=320540 $Y=976260
X2236 1488 48 1526 1 2 ND2 $T=320540 991760 1 0 $X=320540 $Y=986340
X2237 1535 787 1536 1 2 ND2 $T=321780 941360 0 0 $X=321780 $Y=940980
X2238 1528 825 1536 1 2 ND2 $T=321780 961520 0 0 $X=321780 $Y=961140
X2239 1500 732 1557 1 2 ND2 $T=323640 931280 1 0 $X=323640 $Y=925860
X2240 1506 1138 1558 1 2 ND2 $T=323640 931280 0 0 $X=323640 $Y=930900
X2241 1491 877 1532 1 2 ND2 $T=325500 981680 0 180 $X=323640 $Y=976260
X2242 1491 1136 1526 1 2 ND2 $T=325500 981680 1 180 $X=323640 $Y=981300
X2243 1492 979 1526 1 2 ND2 $T=324880 991760 1 0 $X=324880 $Y=986340
X2244 1500 1321 1558 1 2 ND2 $T=328600 931280 0 180 $X=326740 $Y=925860
X2245 1582 1423 1528 1 2 ND2 $T=328600 961520 1 180 $X=326740 $Y=961140
X2246 1557 889 1526 1 2 ND2 $T=328600 981680 0 180 $X=326740 $Y=976260
X2247 1414 1539 864 1 2 ND2 $T=326740 1042160 1 0 $X=326740 $Y=1036740
X2248 1532 977 1589 1 2 ND2 $T=327360 981680 0 0 $X=327360 $Y=981300
X2249 1507 870 1526 1 2 ND2 $T=327360 991760 1 0 $X=327360 $Y=986340
X2250 1578 922 1554 1 2 ND2 $T=329220 991760 1 180 $X=327360 $Y=991380
X2251 1506 1333 1589 1 2 ND2 $T=328600 931280 0 0 $X=328600 $Y=930900
X2252 1535 1028 1592 1 2 ND2 $T=328600 941360 1 0 $X=328600 $Y=935940
X2253 1578 1007 1598 1 2 ND2 $T=330460 981680 0 0 $X=330460 $Y=981300
X2254 1526 1126 1589 1 2 ND2 $T=330460 991760 1 0 $X=330460 $Y=986340
X2255 87 1600 1552 1 2 ND2 $T=334800 921200 1 180 $X=332940 $Y=920820
X2256 1492 751 1532 1 2 ND2 $T=333560 991760 1 0 $X=333560 $Y=986340
X2257 1500 1490 1589 1 2 ND2 $T=336040 941360 1 180 $X=334180 $Y=940980
X2258 803 1595 1239 1 2 ND2 $T=334180 1042160 0 0 $X=334180 $Y=1041780
X2259 87 1622 77 1 2 ND2 $T=337280 931280 1 0 $X=337280 $Y=925860
X2260 1542 1022 1592 1 2 ND2 $T=337280 961520 0 0 $X=337280 $Y=961140
X2261 1578 1632 1562 1 2 ND2 $T=337280 1001840 1 0 $X=337280 $Y=996420
X2262 1620 1646 1597 1 2 ND2 $T=341000 951440 1 180 $X=339140 $Y=951060
X2263 1298 1647 799 1 2 ND2 $T=341000 1032080 0 0 $X=341000 $Y=1031700
X2264 1630 1656 1591 1 2 ND2 $T=344100 931280 1 180 $X=342240 $Y=930900
X2265 1557 1435 1532 1 2 ND2 $T=342860 981680 0 0 $X=342860 $Y=981300
X2266 109 1694 1689 1 2 ND2 $T=352780 880880 0 180 $X=350920 $Y=875460
X2267 1704 1696 1690 1 2 ND2 $T=352780 981680 1 180 $X=350920 $Y=981300
X2268 1720 1710 1702 1 2 ND2 $T=354640 880880 0 180 $X=352780 $Y=875460
X2269 1463 1340 1696 1 2 ND2 $T=352780 1011920 0 0 $X=352780 $Y=1011540
X2270 1710 1672 1694 1 2 ND2 $T=358360 880880 0 180 $X=356500 $Y=875460
X2271 1704 1680 1714 1 2 ND2 $T=357740 981680 0 0 $X=357740 $Y=981300
X2272 1737 1498 729 1 2 ND2 $T=363320 961520 1 180 $X=361460 $Y=961140
X2273 1751 1726 1748 1 2 ND2 $T=362700 870800 0 0 $X=362700 $Y=870420
X2274 1782 1798 1781 1 2 ND2 $T=370760 1032080 1 0 $X=370760 $Y=1026660
X2275 1835 1848 1843 1 2 ND2 $T=382540 1042160 0 0 $X=382540 $Y=1041780
X2276 1839 1760 1846 1 2 ND2 $T=385640 1001840 1 0 $X=385640 $Y=996420
X2277 134 1903 111 1 2 ND2 $T=395560 1001840 1 180 $X=393700 $Y=1001460
X2278 1916 1920 1505 1 2 ND2 $T=396800 1032080 0 0 $X=396800 $Y=1031700
X2279 1872 1941 1864 1 2 ND2 $T=402380 911120 1 180 $X=400520 $Y=910740
X2280 1838 1963 1864 1 2 ND2 $T=403620 911120 0 180 $X=401760 $Y=905700
X2281 1923 1964 1905 1 2 ND2 $T=403620 991760 1 0 $X=403620 $Y=986340
X2282 1911 1957 1998 1 2 ND2 $T=404240 981680 0 0 $X=404240 $Y=981300
X2283 1887 2033 1871 1 2 ND2 $T=412300 1052240 1 180 $X=410440 $Y=1051860
X2284 2015 1994 150 1 2 ND2 $T=412300 941360 1 0 $X=412300 $Y=935940
X2285 2022 1843 1920 1 2 ND2 $T=413540 1032080 0 0 $X=413540 $Y=1031700
X2286 2071 2061 2067 1 2 ND2 $T=421600 941360 1 0 $X=421600 $Y=935940
X2287 2086 2091 2053 1 2 ND2 $T=424080 1042160 1 180 $X=422220 $Y=1041780
X2288 1942 2101 2032 1 2 ND2 $T=428420 941360 0 180 $X=426560 $Y=935940
X2289 2050 2142 2088 1 2 ND2 $T=427180 1052240 0 0 $X=427180 $Y=1051860
X2290 2050 2122 2082 1 2 ND2 $T=427180 1062320 1 0 $X=427180 $Y=1056900
X2291 2113 2123 2117 1 2 ND2 $T=430280 911120 1 0 $X=430280 $Y=905700
X2292 2113 2155 2111 1 2 ND2 $T=432760 901040 0 0 $X=432760 $Y=900660
X2293 2181 2175 2116 1 2 ND2 $T=439580 1032080 1 180 $X=437720 $Y=1031700
X2294 2088 2151 2082 1 2 ND2 $T=437720 1062320 1 0 $X=437720 $Y=1056900
X2295 2187 2192 1702 1 2 ND2 $T=441440 1001840 0 180 $X=439580 $Y=996420
X2296 2199 2119 2192 1 2 ND2 $T=443300 1001840 0 180 $X=441440 $Y=996420
X2297 2188 2173 2187 1 2 ND2 $T=443300 1011920 1 180 $X=441440 $Y=1011540
X2298 2191 2199 1779 1 2 ND2 $T=445160 1001840 0 180 $X=443300 $Y=996420
X2299 2272 2291 2254 1 2 ND2 $T=456320 1052240 0 0 $X=456320 $Y=1051860
X2300 2272 2316 2261 1 2 ND2 $T=456320 1062320 1 0 $X=456320 $Y=1056900
X2301 2261 2307 2254 1 2 ND2 $T=461900 1052240 0 180 $X=460040 $Y=1046820
X2302 213 2380 2235 1 2 ND2 $T=473680 880880 0 180 $X=471820 $Y=875460
X2303 2355 2387 2287 1 2 ND2 $T=474920 1052240 1 180 $X=473060 $Y=1051860
X2304 213 2388 2384 1 2 ND2 $T=474920 880880 1 0 $X=474920 $Y=875460
X2305 2363 2390 2287 1 2 ND2 $T=476780 1052240 1 180 $X=474920 $Y=1051860
X2306 2363 2405 2355 1 2 ND2 $T=479260 1052240 0 180 $X=477400 $Y=1046820
X2307 2480 2474 2472 1 2 ND2 $T=490420 991760 1 180 $X=488560 $Y=991380
X2308 2434 2493 2273 1 2 ND2 $T=492280 880880 0 180 $X=490420 $Y=875460
X2309 2435 2481 2494 1 2 ND2 $T=490420 890960 1 0 $X=490420 $Y=885540
X2310 2434 2517 2412 1 2 ND2 $T=499100 880880 1 180 $X=497240 $Y=880500
X2311 229 231 2477 1 2 ND2 $T=501580 1062320 0 180 $X=499720 $Y=1056900
X2312 2634 2646 2608 1 2 ND2 $T=515840 880880 1 0 $X=515840 $Y=875460
X2313 2499 2658 2662 1 2 ND2 $T=519560 961520 1 0 $X=519560 $Y=956100
X2314 2669 2659 2608 1 2 ND2 $T=521420 870800 0 0 $X=521420 $Y=870420
X2315 2669 2647 2634 1 2 ND2 $T=521420 880880 1 0 $X=521420 $Y=875460
X2316 2677 2701 2508 1 2 ND2 $T=524520 1052240 0 180 $X=522660 $Y=1046820
X2317 236 2693 2508 1 2 ND2 $T=524520 1062320 0 180 $X=522660 $Y=1056900
X2318 2702 2682 2499 1 2 ND2 $T=526380 951440 0 0 $X=526380 $Y=951060
X2319 2702 2696 2662 1 2 ND2 $T=526380 961520 1 0 $X=526380 $Y=956100
X2320 2516 2704 2679 1 2 ND2 $T=526380 1022000 0 0 $X=526380 $Y=1021620
X2321 2573 2710 2751 1 2 ND2 $T=531340 880880 0 0 $X=531340 $Y=880500
X2322 2744 2723 2573 1 2 ND2 $T=533200 890960 1 180 $X=531340 $Y=890580
X2323 2743 2750 2668 1 2 ND2 $T=535060 1042160 1 180 $X=533200 $Y=1041780
X2324 2744 2737 2751 1 2 ND2 $T=534440 880880 1 0 $X=534440 $Y=875460
X2325 2541 2760 2741 1 2 ND2 $T=536920 1022000 0 180 $X=535060 $Y=1016580
X2326 2532 2711 2674 1 2 ND2 $T=535680 961520 1 0 $X=535680 $Y=956100
X2327 2668 2765 2758 1 2 ND2 $T=538160 1042160 1 180 $X=536300 $Y=1041780
X2328 2644 2780 2752 1 2 ND2 $T=539400 1001840 0 0 $X=539400 $Y=1001460
X2329 235 248 247 1 2 ND2 $T=542500 1062320 0 180 $X=540640 $Y=1056900
X2330 2793 2800 2756 1 2 ND2 $T=546840 901040 1 180 $X=544980 $Y=900660
X2331 2743 2792 2758 1 2 ND2 $T=544980 1042160 0 0 $X=544980 $Y=1041780
X2332 2735 2811 2650 1 2 ND2 $T=550560 1022000 0 180 $X=548700 $Y=1016580
X2333 2771 2808 2735 1 2 ND2 $T=548700 1032080 0 0 $X=548700 $Y=1031700
X2334 2657 2825 2805 1 2 ND2 $T=550560 1042160 0 180 $X=548700 $Y=1036740
X2335 2817 2815 2733 1 2 ND2 $T=553040 1022000 1 180 $X=551180 $Y=1021620
X2336 2787 2834 2821 1 2 ND2 $T=551800 971600 0 0 $X=551800 $Y=971220
X2337 2819 2832 2733 1 2 ND2 $T=553660 1032080 1 0 $X=553660 $Y=1026660
X2338 2819 2822 2817 1 2 ND2 $T=553660 1032080 0 0 $X=553660 $Y=1031700
X2339 2732 2868 2857 1 2 ND2 $T=562340 1042160 0 180 $X=560480 $Y=1036740
X2340 2849 2873 2857 1 2 ND2 $T=561720 1042160 0 0 $X=561720 $Y=1041780
X2341 2849 2866 2732 1 2 ND2 $T=561720 1052240 1 0 $X=561720 $Y=1046820
X2342 2928 2923 2899 1 2 ND2 $T=580940 1032080 0 180 $X=579080 $Y=1026660
X2343 280 2941 2973 1 2 ND2 $T=590860 870800 0 0 $X=590860 $Y=870420
X2344 283 2962 2995 1 2 ND2 $T=592720 951440 1 0 $X=592720 $Y=946020
X2345 285 2959 2980 1 2 ND2 $T=594580 961520 0 0 $X=594580 $Y=961140
X2346 289 2971 2953 1 2 ND2 $T=597680 921200 0 180 $X=595820 $Y=915780
X2347 3052 3003 3027 1 2 ND2 $T=604500 981680 0 180 $X=602640 $Y=976260
X2348 300 3058 3047 1 2 ND2 $T=608220 981680 1 180 $X=606360 $Y=981300
X2349 3047 2936 3058 1 2 ND2 $T=606360 991760 1 0 $X=606360 $Y=986340
X2350 303 3061 3075 1 2 ND2 $T=608220 971600 0 0 $X=608220 $Y=971220
X2351 3058 3039 3071 1 2 ND2 $T=608220 991760 0 0 $X=608220 $Y=991380
X2352 307 2974 3044 1 2 ND2 $T=611940 941360 1 180 $X=610080 $Y=940980
X2353 306 3087 3045 1 2 ND2 $T=611320 981680 0 0 $X=611320 $Y=981300
X2354 3106 3081 3115 1 2 ND2 $T=615040 880880 0 0 $X=615040 $Y=880500
X2355 3104 3109 3004 1 2 ND2 $T=616900 1022000 0 180 $X=615040 $Y=1016580
X2356 3030 3125 3099 1 2 ND2 $T=618760 1022000 0 180 $X=616900 $Y=1016580
X2357 3172 318 3157 1 2 ND2 $T=626820 880880 0 180 $X=624960 $Y=875460
X2358 3194 3147 3094 1 2 ND2 $T=630540 1022000 0 180 $X=628680 $Y=1016580
X2359 3212 325 3224 1 2 ND2 $T=633640 870800 0 0 $X=633640 $Y=870420
X2360 3174 3240 3177 1 2 ND2 $T=639840 911120 0 0 $X=639840 $Y=910740
X2361 3144 3244 3152 1 2 ND2 $T=642320 890960 0 180 $X=640460 $Y=885540
X2362 3239 3262 3268 1 2 ND2 $T=641700 880880 1 0 $X=641700 $Y=875460
X2363 3209 3266 3261 1 2 ND2 $T=643560 991760 1 180 $X=641700 $Y=991380
X2364 3205 3289 3133 1 2 ND2 $T=647280 890960 1 0 $X=647280 $Y=885540
X2365 3320 3326 3335 1 2 ND2 $T=650380 890960 1 0 $X=650380 $Y=885540
X2366 345 3278 3279 1 2 ND2 $T=654720 981680 1 180 $X=652860 $Y=981300
X2367 3292 3380 3382 1 2 ND2 $T=660920 981680 0 0 $X=660920 $Y=981300
X2368 3400 3398 3359 1 2 ND2 $T=666500 901040 0 180 $X=664640 $Y=895620
X2369 350 3428 3402 1 2 ND2 $T=669600 880880 0 180 $X=667740 $Y=875460
X2370 3465 3460 3419 1 2 ND2 $T=678900 981680 1 180 $X=677040 $Y=981300
X2371 357 3456 3483 1 2 ND2 $T=683240 961520 1 180 $X=681380 $Y=961140
X2372 358 3479 3491 1 2 ND2 $T=683860 951440 0 0 $X=683860 $Y=951060
X2373 374 3523 3492 1 2 ND2 $T=696260 901040 0 180 $X=694400 $Y=895620
X2374 377 3561 3526 1 2 ND2 $T=698120 880880 1 180 $X=696260 $Y=880500
X2375 378 3554 3504 1 2 ND2 $T=698120 911120 1 180 $X=696260 $Y=910740
X2376 3551 3547 3514 1 2 ND2 $T=696880 901040 1 0 $X=696880 $Y=895620
X2377 3545 3571 3546 1 2 ND2 $T=699980 911120 1 180 $X=698120 $Y=910740
X2378 386 3584 3572 1 2 ND2 $T=701840 921200 1 0 $X=701840 $Y=915780
X2379 387 3596 3568 1 2 ND2 $T=706800 941360 1 180 $X=704940 $Y=940980
X2380 388 3582 3507 1 2 ND2 $T=706800 951440 0 180 $X=704940 $Y=946020
X2381 390 3601 3557 1 2 ND2 $T=708660 951440 0 180 $X=706800 $Y=946020
X2382 3588 3586 3593 1 2 ND2 $T=708660 931280 1 0 $X=708660 $Y=925860
X2383 491 3956 3969 1 2 ND2 $T=815300 890960 1 0 $X=815300 $Y=885540
X2384 491 3958 493 1 2 ND2 $T=817780 890960 1 0 $X=817780 $Y=885540
X2385 3969 3968 496 1 2 ND2 $T=819640 901040 0 180 $X=817780 $Y=895620
X2386 496 3965 493 1 2 ND2 $T=819020 890960 0 0 $X=819020 $Y=890580
X2387 3984 3973 3982 1 2 ND2 $T=823980 911120 1 0 $X=823980 $Y=905700
X2388 260 115 1 2 INV12CK $T=575360 1011920 0 0 $X=575360 $Y=1011540
X2389 544 499 1 2 INV12CK $T=868620 890960 0 180 $X=858700 $Y=885540
X2390 4013 518 1 2 INV12CK $T=876060 870800 1 180 $X=866140 $Y=870420
X2391 286 4230 1 2 INV12CK $T=895900 951440 0 180 $X=885980 $Y=946020
X2392 2516 1 2655 2720 2 ND2T $T=526380 1032080 0 0 $X=526380 $Y=1031700
X2393 2674 1 2746 2728 2 ND2T $T=534440 971600 1 0 $X=534440 $Y=966180
X2394 2821 1 2854 2831 2 ND2T $T=556140 971600 0 0 $X=556140 $Y=971220
X2395 198 2196 2 2177 2189 1 2258 FA1 $T=440200 901040 1 0 $X=440200 $Y=895620
X2396 2983 2930 2 271 2966 1 2914 FA1 $T=594580 880880 1 180 $X=579080 $Y=880500
X2397 2990 2943 2 2917 2932 1 2922 FA1 $T=597680 941360 0 180 $X=582180 $Y=935940
X2398 3005 2951 2 278 2987 1 2921 FA1 $T=599540 911120 1 180 $X=584040 $Y=910740
X2399 2948 3011 2 262 2922 1 2987 FA1 $T=590240 931280 0 0 $X=590240 $Y=930900
X2400 2979 2963 2 276 2993 1 3048 FA1 $T=595200 911120 1 0 $X=595200 $Y=905700
X2401 287 3042 2 302 2914 1 305 FA1 $T=595820 870800 0 0 $X=595820 $Y=870420
X2402 2956 3043 2 262 2994 1 3089 FA1 $T=595820 931280 1 0 $X=595820 $Y=925860
X2403 2986 3055 2 290 3111 1 3063 FA1 $T=597680 890960 0 0 $X=597680 $Y=890580
X2404 3049 3026 2 2917 3037 1 2994 FA1 $T=613180 941360 0 180 $X=597680 $Y=935940
X2405 3020 3036 2 278 3089 1 2993 FA1 $T=614420 921200 0 180 $X=598920 $Y=915780
X2406 2997 2981 2 2913 3031 1 3050 FA1 $T=602640 961520 1 0 $X=602640 $Y=956100
X2407 3009 2958 2 277 3048 1 3111 FA1 $T=603260 901040 0 0 $X=603260 $Y=900660
X2408 308 3081 2 315 3113 1 319 FA1 $T=613800 870800 0 0 $X=613800 $Y=870420
X2409 3399 3326 2 3199 3383 1 3325 FA1 $T=666500 880880 0 180 $X=651000 $Y=875460
X2410 3487 3300 2 3213 3482 1 3414 FA1 $T=683240 901040 0 180 $X=667740 $Y=895620
X2411 360 3421 2 314 3486 1 351 FA1 $T=685100 870800 1 180 $X=669600 $Y=870420
X2412 3425 3365 2 3241 3439 1 3482 FA1 $T=669600 911120 0 0 $X=669600 $Y=910740
X2413 3509 3458 2 3264 3495 1 3441 FA1 $T=687580 921200 1 180 $X=672080 $Y=920820
X2414 3444 3385 2 3247 3454 1 3495 FA1 $T=672700 931280 0 0 $X=672700 $Y=930900
X2415 3503 3417 2 3238 3488 1 3445 FA1 $T=688200 961520 0 180 $X=672700 $Y=956100
X2416 3438 3418 2 3430 3356 1 3488 FA1 $T=672700 971600 0 0 $X=672700 $Y=971220
X2417 3528 3451 2 3257 3445 1 3452 FA1 $T=692540 951440 0 180 $X=677040 $Y=946020
X2418 3464 3412 2 3179 3468 1 3533 FA1 $T=678280 890960 0 0 $X=678280 $Y=890580
X2419 3518 3463 2 3213 3480 1 3468 FA1 $T=694400 911120 0 180 $X=678900 $Y=905700
X2420 3530 3475 2 3170 3533 1 3478 FA1 $T=696260 890960 0 180 $X=680760 $Y=885540
X2421 3579 3496 2 3247 3519 1 3506 FA1 $T=704320 941360 0 180 $X=688820 $Y=935940
X2422 3555 3432 2 3245 3541 1 3505 FA1 $T=706180 921200 1 180 $X=690680 $Y=920820
X2423 3559 3515 2 3257 3578 1 3524 FA1 $T=706800 951440 1 180 $X=691300 $Y=951060
X2424 3525 3548 2 3238 3476 1 3578 FA1 $T=691300 961520 0 0 $X=691300 $Y=961140
X2425 143 140 127 2 1 122 XOR3S $T=375100 1062320 0 180 $X=363940 $Y=1056900
X2426 2533 2543 2588 2 1 2582 XOR3S $T=499720 880880 0 0 $X=499720 $Y=880500
X2427 2820 2812 2824 2 1 2903 XOR3S $T=557380 981680 1 0 $X=557380 $Y=976260
X2428 348 323 365 2 1 361 XOR3S $T=698740 880880 0 180 $X=687580 $Y=875460
X2429 1770 71 1 2 INV3 $T=377580 951440 0 0 $X=377580 $Y=951060
X2430 2498 2503 1 2 INV3 $T=492900 951440 1 0 $X=492900 $Y=946020
X2431 1241 1223 1 2 INV2 $T=284580 901040 0 0 $X=284580 $Y=900660
X2432 1272 1347 1 2 INV2 $T=296360 890960 1 0 $X=296360 $Y=885540
X2433 1422 1429 1 2 INV2 $T=312480 901040 1 0 $X=312480 $Y=895620
X2434 1505 1147 1 2 INV2 $T=341000 911120 0 0 $X=341000 $Y=910740
X2435 1732 1461 1 2 INV2 $T=357740 890960 1 180 $X=355880 $Y=890580
X2436 129 132 1 2 INV2 $T=366420 991760 1 0 $X=366420 $Y=986340
X2437 1829 1834 1 2 INV2 $T=385020 961520 0 0 $X=385020 $Y=961140
X2438 1842 1863 1 2 INV2 $T=386880 991760 0 180 $X=385020 $Y=986340
X2439 1866 160 1 2 INV2 $T=388740 1052240 0 0 $X=388740 $Y=1051860
X2440 1858 1868 1 2 INV2 $T=391220 1011920 1 0 $X=391220 $Y=1006500
X2441 1912 1924 1 2 INV2 $T=396180 991760 0 0 $X=396180 $Y=991380
X2442 1946 1928 1 2 INV2 $T=404240 1011920 1 180 $X=402380 $Y=1011540
X2443 1988 1870 1 2 INV2 $T=407340 1032080 1 0 $X=407340 $Y=1026660
X2444 1986 2018 1 2 INV2 $T=412300 1001840 1 0 $X=412300 $Y=996420
X2445 1899 1959 1 2 INV2 $T=436480 1042160 1 0 $X=436480 $Y=1036740
X2446 2164 1895 1 2 INV2 $T=437720 941360 1 0 $X=437720 $Y=935940
X2447 2137 2164 1 2 INV2 $T=445160 941360 0 0 $X=445160 $Y=940980
X2448 2185 2230 1 2 INV2 $T=447640 941360 1 0 $X=447640 $Y=935940
X2449 1505 1936 1 2 INV2 $T=447640 1032080 0 0 $X=447640 $Y=1031700
X2450 2252 2163 1 2 INV2 $T=453220 1022000 1 0 $X=453220 $Y=1016580
X2451 2338 215 1 2 INV2 $T=466240 1062320 1 0 $X=466240 $Y=1056900
X2452 128 1820 1 2 INV2 $T=493520 1001840 0 180 $X=491660 $Y=996420
X2453 2688 2699 1 2 INV2 $T=524520 1032080 1 0 $X=524520 $Y=1026660
X2454 2753 2803 1 2 INV2 $T=535680 1022000 0 0 $X=535680 $Y=1021620
X2455 3103 3104 1 2 INV2 $T=616900 1022000 0 0 $X=616900 $Y=1021620
X2456 3078 3094 1 2 INV2 $T=618760 1001840 0 0 $X=618760 $Y=1001460
X2457 3108 3177 1 2 INV2 $T=629920 971600 1 0 $X=629920 $Y=966180
X2458 3132 3193 1 2 INV2 $T=629920 991760 0 0 $X=629920 $Y=991380
X2459 3182 3073 1 2 INV2 $T=631160 981680 1 0 $X=631160 $Y=976260
X2460 3131 3127 1 2 INV2 $T=631780 1001840 1 0 $X=631780 $Y=996420
X2461 3124 3178 1 2 INV2 $T=635500 941360 0 0 $X=635500 $Y=940980
X2462 4 742 735 2 716 1 734 AN4B1S $T=225680 941360 1 180 $X=221340 $Y=940980
X2463 712 725 702 2 731 1 762 AN4B1S $T=221340 1022000 1 0 $X=221340 $Y=1016580
X2464 791 772 764 2 759 1 747 AN4B1S $T=228160 931280 0 180 $X=223820 $Y=925860
X2465 748 779 764 2 767 1 754 AN4B1S $T=228780 971600 1 180 $X=224440 $Y=971220
X2466 809 710 778 2 774 1 753 AN4B1S $T=229400 951440 1 180 $X=225060 $Y=951060
X2467 748 787 780 2 776 1 719 AN4B1S $T=229400 981680 0 180 $X=225060 $Y=976260
X2468 793 791 786 2 714 1 768 AN4B1S $T=230020 921200 0 180 $X=225680 $Y=915780
X2469 817 742 784 2 714 1 761 AN4B1S $T=230020 941360 0 180 $X=225680 $Y=935940
X2470 787 758 794 2 776 1 760 AN4B1S $T=230640 991760 1 180 $X=226300 $Y=991380
X2471 828 805 795 2 711 1 777 AN4B1S $T=230640 1001840 0 180 $X=226300 $Y=996420
X2472 770 757 796 2 806 1 820 AN4B1S $T=226300 1011920 1 0 $X=226300 $Y=1006500
X2473 779 793 742 2 812 1 792 AN4B1S $T=226920 961520 1 0 $X=226920 $Y=956100
X2474 721 713 814 2 802 1 815 AN4B1S $T=227540 1042160 1 0 $X=227540 $Y=1036740
X2475 723 699 831 2 826 1 846 AN4B1S $T=229400 981680 1 0 $X=229400 $Y=976260
X2476 811 837 849 2 746 1 843 AN4B1S $T=231260 911120 0 0 $X=231260 $Y=910740
X2477 772 825 787 2 858 1 845 AN4B1S $T=231260 921200 0 0 $X=231260 $Y=920820
X2478 708 859 851 2 844 1 775 AN4B1S $T=235600 961520 1 180 $X=231260 $Y=961140
X2479 859 699 852 2 767 1 833 AN4B1S $T=235600 971600 1 180 $X=231260 $Y=971220
X2480 801 848 853 2 836 1 856 AN4B1S $T=231260 1052240 1 0 $X=231260 $Y=1046820
X2481 851 881 875 2 705 1 722 AN4B1S $T=237460 931280 1 180 $X=233120 $Y=930900
X2482 809 825 892 2 896 1 857 AN4B1S $T=234980 951440 0 0 $X=234980 $Y=951060
X2483 13 12 891 2 11 1 880 AN4B1S $T=239320 1062320 0 180 $X=234980 $Y=1056900
X2484 748 908 904 2 896 1 830 AN4B1S $T=240560 951440 0 180 $X=236220 $Y=946020
X2485 786 881 831 2 919 1 854 AN4B1S $T=237460 921200 1 0 $X=237460 $Y=915780
X2486 935 924 835 2 909 1 906 AN4B1S $T=242420 1001840 1 180 $X=238080 $Y=1001460
X2487 921 863 852 2 847 1 967 AN4B1S $T=239940 971600 0 0 $X=239940 $Y=971220
X2488 913 929 938 2 945 1 933 AN4B1S $T=239940 1042160 1 0 $X=239940 $Y=1036740
X2489 923 973 786 2 703 1 950 AN4B1S $T=247380 921200 0 180 $X=243040 $Y=915780
X2490 999 989 735 2 980 1 964 AN4B1S $T=249240 911120 0 180 $X=244900 $Y=905700
X2491 1012 997 993 2 991 1 994 AN4B1S $T=250480 1022000 0 180 $X=246140 $Y=1016580
X2492 976 1022 1014 2 1006 1 755 AN4B1S $T=252960 991760 0 180 $X=248620 $Y=986340
X2493 999 881 1009 2 1027 1 1018 AN4B1S $T=251100 921200 1 0 $X=251100 $Y=915780
X2494 1048 1044 1028 2 703 1 726 AN4B1S $T=256060 931280 1 180 $X=251720 $Y=930900
X2495 1038 1003 1051 2 1057 1 1070 AN4B1S $T=253580 991760 0 0 $X=253580 $Y=991380
X2496 1016 838 852 2 17 1 1135 AN4B1S $T=261020 961520 1 0 $X=261020 $Y=956100
X2497 787 1009 1054 2 1087 1 1134 AN4B1S $T=262260 931280 1 0 $X=262260 $Y=925860
X2498 1160 1118 1145 2 1142 1 978 AN4B1S $T=270320 1022000 0 180 $X=265980 $Y=1016580
X2499 1107 1162 1125 2 1173 1 1200 AN4B1S $T=269080 991760 0 0 $X=269080 $Y=991380
X2500 1118 1179 1174 2 1176 1 1065 AN4B1S $T=270940 1022000 1 0 $X=270940 $Y=1016580
X2501 1175 1158 1206 2 1100 1 1207 AN4B1S $T=274040 951440 1 0 $X=274040 $Y=946020
X2502 875 1180 1159 2 752 1 1212 AN4B1S $T=275280 931280 0 0 $X=275280 $Y=930900
X2503 961 831 1213 2 926 1 1163 AN4B1S $T=276520 931280 1 0 $X=276520 $Y=925860
X2504 971 863 1224 2 975 1 1216 AN4B1S $T=280860 941360 1 180 $X=276520 $Y=940980
X2505 838 1235 1096 2 959 1 1230 AN4B1S $T=282100 961520 0 180 $X=277760 $Y=956100
X2506 1198 1231 1199 2 1247 1 1258 AN4B1S $T=278380 981680 1 0 $X=278380 $Y=976260
X2507 1234 1249 1227 2 1045 1 1266 AN4B1S $T=279620 1022000 1 0 $X=279620 $Y=1016580
X2508 1242 1128 1254 2 1195 1 1257 AN4B1S $T=280240 911120 1 0 $X=280240 $Y=905700
X2509 1204 1256 1260 2 1237 1 1305 AN4B1S $T=280860 1032080 0 0 $X=280860 $Y=1031700
X2510 1192 1108 1302 2 1311 1 1310 AN4B1S $T=287680 911120 0 0 $X=287680 $Y=910740
X2511 1324 56 1296 2 1281 1 1306 AN4B1S $T=292020 1052240 1 180 $X=287680 $Y=1051860
X2512 1343 1155 1081 2 1281 1 1314 AN4B1S $T=294500 1052240 0 180 $X=290160 $Y=1046820
X2513 1325 1292 1345 2 1320 1 1367 AN4B1S $T=292640 1032080 1 0 $X=292640 $Y=1026660
X2514 1285 1363 1369 2 1095 1 1388 AN4B1S $T=295120 951440 1 0 $X=295120 $Y=946020
X2515 1383 1374 699 2 1365 1 1219 AN4B1S $T=300080 971600 0 180 $X=295740 $Y=966180
X2516 1384 1145 1370 2 1355 1 1360 AN4B1S $T=300080 1001840 0 180 $X=295740 $Y=996420
X2517 1393 1287 1379 2 1328 1 1366 AN4B1S $T=300700 1022000 1 180 $X=296360 $Y=1021620
X2518 1401 1371 1361 2 1106 1 1385 AN4B1S $T=302560 1042160 1 180 $X=298220 $Y=1041780
X2519 1419 57 65 2 1355 1 1309 AN4B1S $T=303180 1062320 0 180 $X=298840 $Y=1056900
X2520 1388 887 1351 2 1408 1 1416 AN4B1S $T=300080 941360 0 0 $X=300080 $Y=940980
X2521 70 65 1155 2 1346 1 1399 AN4B1S $T=305660 1052240 1 180 $X=301320 $Y=1051860
X2522 878 838 825 2 1418 1 1430 AN4B1S $T=308760 951440 1 180 $X=304420 $Y=951060
X2523 1425 1187 1441 2 1426 1 1459 AN4B1S $T=305660 921200 0 0 $X=305660 $Y=920820
X2524 72 1462 1179 2 1467 1 1343 AN4B1S $T=308760 1052240 1 0 $X=308760 $Y=1046820
X2525 1459 1460 1377 2 1442 1 1476 AN4B1S $T=309380 931280 1 0 $X=309380 $Y=925860
X2526 1437 733 1427 2 1291 1 1480 AN4B1S $T=310000 951440 1 0 $X=310000 $Y=946020
X2527 1384 1451 1434 2 1052 1 1494 AN4B1S $T=311860 1001840 1 0 $X=311860 $Y=996420
X2528 1480 1486 914 2 1359 1 1511 AN4B1S $T=313100 941360 0 0 $X=313100 $Y=940980
X2529 708 1064 1541 2 941 1 1540 AN4B1S $T=321160 951440 0 0 $X=321160 $Y=951060
X2530 1555 979 1543 2 1098 1 1268 AN4B1S $T=325500 1001840 1 180 $X=321160 $Y=1001460
X2531 1565 979 877 2 26 1 876 AN4B1S $T=327360 1011920 0 180 $X=323020 $Y=1006500
X2532 1593 1136 876 2 1098 1 1577 AN4B1S $T=331080 1001840 1 180 $X=326740 $Y=1001460
X2533 1569 1576 1581 2 1586 1 1597 AN4B1S $T=327360 951440 0 0 $X=327360 $Y=951060
X2534 1603 1595 900 2 64 1 1499 AN4B1S $T=332940 1042160 1 180 $X=328600 $Y=1041780
X2535 1628 1434 1603 2 1299 1 1599 AN4B1S $T=336660 1001840 1 180 $X=332320 $Y=1001460
X2536 1631 1625 1548 2 1614 1 1620 AN4B1S $T=337900 971600 1 180 $X=333560 $Y=971220
X2537 1194 1530 1628 2 1467 1 1638 AN4B1S $T=336660 1042160 1 0 $X=336660 $Y=1036740
X2538 1675 55 860 2 1641 1 1653 AN4B1S $T=347820 981680 1 0 $X=347820 $Y=976260
X2539 1905 1766 1906 2 1903 1 1893 AN4B1S $T=397420 1001840 0 180 $X=393080 $Y=996420
X2540 3736 3728 3704 2 3754 1 435 AN4B1S $T=749580 921200 0 0 $X=749580 $Y=920820
X2541 3783 3786 3710 2 3790 1 447 AN4B1S $T=758880 911120 0 0 $X=758880 $Y=910740
X2542 3802 3817 3788 2 3808 1 459 AN4B1S $T=769420 911120 0 0 $X=769420 $Y=910740
X2543 3847 3853 3856 2 3858 1 466 AN4B1S $T=779340 911120 0 0 $X=779340 $Y=910740
X2544 471 3889 3835 2 3896 1 474 AN4B1S $T=793600 880880 0 0 $X=793600 $Y=880500
X2545 3916 3882 3779 2 3902 1 477 AN4B1S $T=800420 911120 1 180 $X=796080 $Y=910740
X2546 3983 3997 4002 2 3976 1 517 AN4B1S $T=826460 941360 0 0 $X=826460 $Y=940980
X2547 4051 4042 4023 2 4025 1 521 AN4B1S $T=843820 951440 0 180 $X=839480 $Y=946020
X2548 526 4062 4059 2 4065 1 528 AN4B1S $T=843820 870800 0 0 $X=843820 $Y=870420
X2549 4093 4089 4084 2 4075 1 532 AN4B1S $T=854980 911120 1 180 $X=850640 $Y=910740
X2550 4101 4107 4123 2 4106 1 540 AN4B1S $T=860560 951440 1 0 $X=860560 $Y=946020
X2551 4161 4149 4150 2 4143 1 543 AN4B1S $T=872340 901040 1 180 $X=868000 $Y=900660
X2552 4156 4133 4165 2 4154 1 546 AN4B1S $T=876060 951440 1 180 $X=871720 $Y=951060
X2553 4180 4190 4189 2 4197 1 550 AN4B1S $T=877920 951440 1 0 $X=877920 $Y=946020
X2554 4254 4221 4237 2 4236 1 552 AN4B1S $T=895280 880880 1 180 $X=890940 $Y=880500
X2555 4252 4223 4243 2 4241 1 553 AN4B1S $T=897140 901040 0 180 $X=892800 $Y=895620
X2556 4204 4253 4251 2 4250 1 556 AN4B1S $T=895900 951440 1 0 $X=895900 $Y=946020
X2557 4277 4272 4267 2 4258 1 555 AN4B1S $T=903960 951440 1 180 $X=899620 $Y=951060
X2558 4299 4293 4288 2 4285 1 557 AN4B1S $T=908300 941360 0 180 $X=903960 $Y=935940
X2559 860 782 7 824 2 1 801 OA22 $T=233120 1062320 0 180 $X=228780 $Y=1056900
X2560 863 890 797 782 2 1 911 OA22 $T=234980 1022000 0 0 $X=234980 $Y=1021620
X2561 864 822 724 778 2 1 1113 OA22 $T=258540 1001840 0 0 $X=258540 $Y=1001460
X2562 979 1127 1004 981 2 1 1105 OA22 $T=266600 1042160 0 180 $X=262260 $Y=1036740
X2563 729 1207 38 977 2 1 1234 OA22 $T=275280 1011920 0 0 $X=275280 $Y=1011540
X2564 39 1215 797 1193 2 1 1227 OA22 $T=275280 1022000 0 0 $X=275280 $Y=1021620
X2565 1138 791 902 710 2 1 1351 OA22 $T=288920 941360 1 0 $X=288920 $Y=935940
X2566 1640 1136 1126 1632 2 1 1628 OA22 $T=340380 1022000 1 180 $X=336040 $Y=1021620
X2567 714 2 707 703 1 NR2 $T=222580 961520 1 180 $X=220720 $Y=961140
X2568 752 2 758 714 1 NR2 $T=225060 911120 0 180 $X=223200 $Y=905700
X2569 803 2 782 5 1 NR2 $T=228160 1052240 0 180 $X=226300 $Y=1046820
X2570 752 2 741 798 1 NR2 $T=226920 971600 1 0 $X=226920 $Y=966180
X2571 819 2 764 714 1 NR2 $T=230020 931280 1 180 $X=228160 $Y=930900
X2572 826 2 816 752 1 NR2 $T=231260 961520 1 180 $X=229400 $Y=961140
X2573 803 2 745 8 1 NR2 $T=229400 1032080 0 0 $X=229400 $Y=1031700
X2574 839 2 723 819 1 NR2 $T=231880 971600 0 180 $X=230020 $Y=966180
X2575 821 2 823 842 1 NR2 $T=230020 1011920 0 0 $X=230020 $Y=1011540
X2576 705 2 809 819 1 NR2 $T=234360 941360 0 180 $X=232500 $Y=935940
X2577 884 2 786 759 1 NR2 $T=236220 941360 0 180 $X=234360 $Y=935940
X2578 879 2 866 897 1 NR2 $T=234980 1032080 0 0 $X=234980 $Y=1031700
X2579 894 2 882 885 1 NR2 $T=237460 991760 0 180 $X=235600 $Y=986340
X2580 884 2 742 705 1 NR2 $T=238080 941360 0 180 $X=236220 $Y=935940
X2581 752 2 790 919 1 NR2 $T=236840 911120 0 0 $X=236840 $Y=910740
X2582 884 2 905 827 1 NR2 $T=239320 991760 0 180 $X=237460 $Y=986340
X2583 884 2 852 798 1 NR2 $T=238700 961520 1 0 $X=238700 $Y=956100
X2584 927 2 794 916 1 NR2 $T=241180 991760 0 180 $X=239320 $Y=986340
X2585 925 2 807 8 1 NR2 $T=241800 1022000 1 180 $X=239940 $Y=1021620
X2586 941 2 859 952 1 NR2 $T=241800 951440 0 0 $X=241800 $Y=951060
X2587 952 2 928 776 1 NR2 $T=243660 961520 1 180 $X=241800 $Y=961140
X2588 819 2 910 955 1 NR2 $T=241800 971600 1 0 $X=241800 $Y=966180
X2589 934 2 737 955 1 NR2 $T=241800 981680 1 0 $X=241800 $Y=976260
X2590 869 2 944 827 1 NR2 $T=243660 1001840 0 180 $X=241800 $Y=996420
X2591 941 2 960 752 1 NR2 $T=245520 921200 1 180 $X=243660 $Y=920820
X2592 839 2 772 17 1 NR2 $T=243660 961520 1 0 $X=243660 $Y=956100
X2593 812 2 931 955 1 NR2 $T=243660 961520 0 0 $X=243660 $Y=961140
X2594 869 2 966 952 1 NR2 $T=243660 971600 1 0 $X=243660 $Y=966180
X2595 975 2 972 980 1 NR2 $T=245520 901040 0 0 $X=245520 $Y=900660
X2596 952 2 784 926 1 NR2 $T=245520 941360 1 0 $X=245520 $Y=935940
X2597 17 2 923 955 1 NR2 $T=245520 951440 1 0 $X=245520 $Y=946020
X2598 759 2 989 926 1 NR2 $T=246760 921200 0 0 $X=246760 $Y=920820
X2599 703 2 904 926 1 NR2 $T=246760 931280 0 0 $X=246760 $Y=930900
X2600 759 2 1034 714 1 NR2 $T=248620 921200 0 0 $X=248620 $Y=920820
X2601 858 2 1009 927 1 NR2 $T=248620 931280 1 0 $X=248620 $Y=925860
X2602 776 2 1001 1050 1 NR2 $T=248620 961520 1 0 $X=248620 $Y=956100
X2603 1026 2 996 1005 1 NR2 $T=251100 1062320 0 180 $X=249240 $Y=1056900
X2604 934 2 793 1027 1 NR2 $T=250480 931280 1 0 $X=250480 $Y=925860
X2605 774 2 1019 884 1 NR2 $T=250480 951440 0 0 $X=250480 $Y=951060
X2606 1029 2 912 1039 1 NR2 $T=252340 1032080 0 0 $X=252340 $Y=1031700
X2607 1029 2 824 943 1 NR2 $T=252340 1042160 1 0 $X=252340 $Y=1036740
X2608 1031 2 748 752 1 NR2 $T=255440 921200 1 180 $X=253580 $Y=920820
X2609 812 2 1044 916 1 NR2 $T=253580 941360 1 0 $X=253580 $Y=935940
X2610 1029 2 995 26 1 NR2 $T=253580 1032080 1 0 $X=253580 $Y=1026660
X2611 25 2 974 1040 1 NR2 $T=255440 1052240 0 180 $X=253580 $Y=1046820
X2612 934 2 1068 714 1 NR2 $T=255440 911120 1 0 $X=255440 $Y=905700
X2613 920 2 890 1067 1 NR2 $T=255440 1022000 1 0 $X=255440 $Y=1016580
X2614 812 2 875 959 1 NR2 $T=256680 931280 0 0 $X=256680 $Y=930900
X2615 934 2 1084 1000 1 NR2 $T=258540 951440 1 180 $X=256680 $Y=951060
X2616 1049 2 780 894 1 NR2 $T=258540 981680 0 180 $X=256680 $Y=976260
X2617 812 2 1083 1010 1 NR2 $T=257300 941360 1 0 $X=257300 $Y=935940
X2618 812 2 921 1049 1 NR2 $T=257300 961520 0 0 $X=257300 $Y=961140
X2619 916 2 881 1049 1 NR2 $T=258540 931280 0 0 $X=258540 $Y=930900
X2620 927 2 973 1090 1 NR2 $T=259160 931280 1 0 $X=259160 $Y=925860
X2621 959 2 1091 752 1 NR2 $T=259160 981680 0 0 $X=259160 $Y=981300
X2622 1080 2 873 1098 1 NR2 $T=259160 1042160 1 0 $X=259160 $Y=1036740
X2623 798 2 1048 1027 1 NR2 $T=260400 931280 0 0 $X=260400 $Y=930900
X2624 952 2 1016 716 1 NR2 $T=262260 941360 0 180 $X=260400 $Y=935940
X2625 774 2 1096 716 1 NR2 $T=262880 961520 1 180 $X=261020 $Y=961140
X2626 865 2 1101 1094 1 NR2 $T=261020 1032080 1 0 $X=261020 $Y=1026660
X2627 955 2 1088 1076 1 NR2 $T=263500 981680 1 180 $X=261640 $Y=981300
X2628 819 2 999 959 1 NR2 $T=262260 941360 1 0 $X=262260 $Y=935940
X2629 1027 2 892 955 1 NR2 $T=262260 951440 1 0 $X=262260 $Y=946020
X2630 1080 2 1114 1039 1 NR2 $T=264740 1032080 1 180 $X=262880 $Y=1031700
X2631 952 2 710 1090 1 NR2 $T=264120 941360 0 0 $X=264120 $Y=940980
X2632 798 2 1112 894 1 NR2 $T=264120 971600 1 0 $X=264120 $Y=966180
X2633 894 2 1014 1027 1 NR2 $T=264120 981680 0 0 $X=264120 $Y=981300
X2634 34 2 1127 23 1 NR2 $T=264120 1052240 1 0 $X=264120 $Y=1046820
X2635 804 2 33 729 1 NR2 $T=265980 971600 1 0 $X=265980 $Y=966180
X2636 1090 2 1151 1102 1 NR2 $T=267840 1011920 0 180 $X=265980 $Y=1006500
X2637 1131 2 1172 1124 1 NR2 $T=269080 911120 0 0 $X=269080 $Y=910740
X2638 919 2 1159 798 1 NR2 $T=269080 931280 0 0 $X=269080 $Y=930900
X2639 916 2 1166 826 1 NR2 $T=269080 981680 1 0 $X=269080 $Y=976260
X2640 925 2 1165 803 1 NR2 $T=269080 1042160 1 0 $X=269080 $Y=1036740
X2641 947 2 40 30 1 NR2 $T=270320 1052240 0 0 $X=270320 $Y=1051860
X2642 826 2 953 884 1 NR2 $T=271560 961520 1 0 $X=271560 $Y=956100
X2643 1169 2 1185 1154 1 NR2 $T=272180 971600 1 0 $X=272180 $Y=966180
X2644 17 2 1197 1010 1 NR2 $T=272800 921200 1 0 $X=272800 $Y=915780
X2645 759 2 908 819 1 NR2 $T=272800 941360 0 0 $X=272800 $Y=940980
X2646 1029 2 1193 3 1 NR2 $T=274660 1011920 1 180 $X=272800 $Y=1011540
X2647 819 2 1190 1090 1 NR2 $T=276520 981680 1 180 $X=274660 $Y=981300
X2648 916 2 1180 716 1 NR2 $T=277760 941360 0 180 $X=275900 $Y=935940
X2649 5 2 1215 47 1 NR2 $T=275900 1032080 1 0 $X=275900 $Y=1026660
X2650 884 2 1213 752 1 NR2 $T=276520 961520 0 0 $X=276520 $Y=961140
X2651 25 2 46 14 1 NR2 $T=277760 1062320 1 0 $X=277760 $Y=1056900
X2652 1123 2 1226 1130 1 NR2 $T=279620 890960 0 0 $X=279620 $Y=890580
X2653 1138 2 1067 729 1 NR2 $T=281480 1022000 1 180 $X=279620 $Y=1021620
X2654 1244 2 1235 714 1 NR2 $T=280240 951440 1 0 $X=280240 $Y=946020
X2655 1245 2 1250 1255 1 NR2 $T=280860 971600 1 0 $X=280860 $Y=966180
X2656 959 2 1259 1027 1 NR2 $T=280860 981680 0 0 $X=280860 $Y=981300
X2657 941 2 735 714 1 NR2 $T=283340 921200 1 180 $X=281480 $Y=920820
X2658 1271 2 1253 1025 1 NR2 $T=284580 1022000 1 180 $X=282720 $Y=1021620
X2659 1246 2 1191 959 1 NR2 $T=285200 941360 0 180 $X=283340 $Y=935940
X2660 1265 2 914 1205 1 NR2 $T=286440 911120 0 180 $X=284580 $Y=905700
X2661 703 2 1229 819 1 NR2 $T=284580 921200 1 0 $X=284580 $Y=915780
X2662 17 2 1054 1121 1 NR2 $T=284580 921200 0 0 $X=284580 $Y=920820
X2663 819 2 1276 767 1 NR2 $T=286440 931280 1 180 $X=284580 $Y=930900
X2664 1271 2 1203 947 1 NR2 $T=284580 1022000 1 0 $X=284580 $Y=1016580
X2665 8 2 1282 1221 1 NR2 $T=285200 1022000 0 0 $X=285200 $Y=1021620
X2666 703 2 1164 959 1 NR2 $T=287680 941360 0 180 $X=285820 $Y=935940
X2667 783 2 1055 729 1 NR2 $T=287680 961520 1 180 $X=285820 $Y=961140
X2668 934 2 976 959 1 NR2 $T=288300 961520 0 180 $X=286440 $Y=956100
X2669 703 2 791 952 1 NR2 $T=288300 931280 0 0 $X=288300 $Y=930900
X2670 1144 2 1317 934 1 NR2 $T=290160 961520 0 0 $X=290160 $Y=961140
X2671 1143 2 1337 1342 1 NR2 $T=292640 931280 0 0 $X=292640 $Y=930900
X2672 732 2 1032 729 1 NR2 $T=293260 971600 1 0 $X=293260 $Y=966180
X2673 1243 2 1011 729 1 NR2 $T=293260 971600 0 0 $X=293260 $Y=971220
X2674 902 2 1021 729 1 NR2 $T=293260 981680 1 0 $X=293260 $Y=976260
X2675 1264 2 1072 1374 1 NR2 $T=296360 991760 0 0 $X=296360 $Y=991380
X2676 1321 2 1046 729 1 NR2 $T=300080 971600 1 0 $X=300080 $Y=966180
X2677 1269 2 1394 1389 1 NR2 $T=300080 1032080 0 0 $X=300080 $Y=1031700
X2678 34 2 932 1072 1 NR2 $T=301320 1052240 1 0 $X=301320 $Y=1046820
X2679 941 2 961 1246 1 NR2 $T=301940 931280 1 0 $X=301940 $Y=925860
X2680 1086 2 1424 1404 1 NR2 $T=301940 991760 1 0 $X=301940 $Y=986340
X2681 952 2 1405 1121 1 NR2 $T=305040 941360 0 180 $X=303180 $Y=935940
X2682 798 2 1411 941 1 NR2 $T=303180 951440 1 0 $X=303180 $Y=946020
X2683 1383 2 1412 729 1 NR2 $T=303180 971600 1 0 $X=303180 $Y=966180
X2684 840 2 1391 1417 1 NR2 $T=303180 981680 0 0 $X=303180 $Y=981300
X2685 1239 2 987 1072 1 NR2 $T=305040 1032080 0 180 $X=303180 $Y=1026660
X2686 861 2 1322 729 1 NR2 $T=306900 961520 1 180 $X=305040 $Y=961140
X2687 1029 2 822 47 1 NR2 $T=306900 1032080 1 180 $X=305040 $Y=1031700
X2688 10 2 1414 1040 1 NR2 $T=306280 1042160 0 0 $X=306280 $Y=1041780
X2689 14 2 763 1030 1 NR2 $T=307520 1032080 0 0 $X=307520 $Y=1031700
X2690 1079 2 1449 1359 1 NR2 $T=310000 941360 1 0 $X=310000 $Y=935940
X2691 1469 2 1460 1452 1 NR2 $T=311860 941360 1 180 $X=310000 $Y=940980
X2692 1437 2 1232 729 1 NR2 $T=310000 961520 1 0 $X=310000 $Y=956100
X2693 1470 2 1471 1455 1 NR2 $T=311860 1032080 0 180 $X=310000 $Y=1026660
X2694 1438 2 1298 23 1 NR2 $T=310000 1042160 1 0 $X=310000 $Y=1036740
X2695 1495 2 1361 1485 1 NR2 $T=315580 1042160 0 180 $X=313720 $Y=1036740
X2696 1427 2 942 729 1 NR2 $T=314960 981680 1 0 $X=314960 $Y=976260
X2697 14 2 38 1040 1 NR2 $T=314960 1062320 1 0 $X=314960 $Y=1056900
X2698 1490 2 855 729 1 NR2 $T=315580 971600 0 0 $X=315580 $Y=971220
X2699 1509 2 1486 1501 1 NR2 $T=318680 961520 1 180 $X=316820 $Y=961140
X2700 1239 2 41 23 1 NR2 $T=320540 1052240 1 180 $X=318680 $Y=1051860
X2701 47 2 1551 1092 1 NR2 $T=322400 1052240 0 180 $X=320540 $Y=1046820
X2702 1523 2 926 78 1 NR2 $T=323640 941360 1 0 $X=323640 $Y=935940
X2703 1549 2 759 78 1 NR2 $T=323640 961520 1 0 $X=323640 $Y=956100
X2704 1513 2 819 1549 1 NR2 $T=325500 961520 1 180 $X=323640 $Y=961140
X2705 1590 2 1574 1274 1 NR2 $T=330460 971600 0 180 $X=328600 $Y=966180
X2706 1579 2 1584 1563 1 NR2 $T=328600 1032080 0 0 $X=328600 $Y=1031700
X2707 803 2 1561 1080 1 NR2 $T=328600 1052240 1 0 $X=328600 $Y=1046820
X2708 1493 2 1607 1566 1 NR2 $T=329220 1032080 1 0 $X=329220 $Y=1026660
X2709 1591 2 1547 87 1 NR2 $T=330460 931280 1 0 $X=330460 $Y=925860
X2710 1600 2 1507 1591 1 NR2 $T=332320 931280 1 180 $X=330460 $Y=930900
X2711 1513 2 1578 729 1 NR2 $T=330460 961520 0 0 $X=330460 $Y=961140
X2712 1513 2 1087 1601 1 NR2 $T=330460 971600 0 0 $X=330460 $Y=971220
X2713 1606 2 1121 1513 1 NR2 $T=332320 981680 0 180 $X=330460 $Y=976260
X2714 1264 2 1030 1523 1 NR2 $T=331080 991760 0 0 $X=331080 $Y=991380
X2715 1600 2 1492 91 1 NR2 $T=331700 941360 1 0 $X=331700 $Y=935940
X2716 1610 2 1564 1598 1 NR2 $T=334180 971600 0 180 $X=332320 $Y=966180
X2717 1617 2 1356 1092 1 NR2 $T=334180 1011920 1 180 $X=332320 $Y=1011540
X2718 1264 2 1040 1524 1 NR2 $T=333560 991760 0 0 $X=333560 $Y=991380
X2719 1622 2 1589 91 1 NR2 $T=336040 941360 0 180 $X=334180 $Y=935940
X2720 803 2 1618 1617 1 NR2 $T=334180 1022000 1 0 $X=334180 $Y=1016580
X2721 14 2 1594 1239 1 NR2 $T=334180 1032080 1 0 $X=334180 $Y=1026660
X2722 25 2 1567 1239 1 NR2 $T=334180 1062320 1 0 $X=334180 $Y=1056900
X2723 87 2 1534 91 1 NR2 $T=336040 921200 0 0 $X=336040 $Y=920820
X2724 1591 2 1557 1622 1 NR2 $T=336040 931280 0 0 $X=336040 $Y=930900
X2725 1225 2 1565 1221 1 NR2 $T=336040 1011920 0 0 $X=336040 $Y=1011540
X2726 1637 2 1525 1624 1 NR2 $T=339140 941360 1 180 $X=337280 $Y=940980
X2727 34 2 1639 1539 1 NR2 $T=339140 1042160 1 180 $X=337280 $Y=1041780
X2728 1637 2 1592 94 1 NR2 $T=339760 951440 0 180 $X=337900 $Y=946020
X2729 1645 2 1506 1636 1 NR2 $T=341000 941360 1 180 $X=339140 $Y=940980
X2730 1654 2 1542 78 1 NR2 $T=341000 961520 0 180 $X=339140 $Y=956100
X2731 865 2 1615 1221 1 NR2 $T=341000 1011920 0 180 $X=339140 $Y=1006500
X2732 1239 2 1640 1647 1 NR2 $T=339760 1032080 1 0 $X=339760 $Y=1026660
X2733 1643 2 1678 1482 1 NR2 $T=340380 901040 0 0 $X=340380 $Y=900660
X2734 1645 2 1500 97 1 NR2 $T=342240 931280 0 180 $X=340380 $Y=925860
X2735 865 2 1649 3 1 NR2 $T=341000 1011920 1 0 $X=341000 $Y=1006500
X2736 1654 2 1610 1624 1 NR2 $T=341620 961520 1 0 $X=341620 $Y=956100
X2737 1636 2 1526 100 1 NR2 $T=342240 941360 0 0 $X=342240 $Y=940980
X2738 1264 2 34 1559 1 NR2 $T=342860 991760 0 0 $X=342860 $Y=991380
X2739 1264 2 25 1601 1 NR2 $T=343480 1001840 1 0 $X=343480 $Y=996420
X2740 1643 2 1683 1521 1 NR2 $T=344100 890960 1 0 $X=344100 $Y=885540
X2741 34 2 799 25 1 NR2 $T=344100 1032080 0 0 $X=344100 $Y=1031700
X2742 97 2 1532 100 1 NR2 $T=345960 941360 0 0 $X=345960 $Y=940980
X2743 1624 2 1536 101 1 NR2 $T=345960 951440 1 0 $X=345960 $Y=946020
X2744 94 2 1582 101 1 NR2 $T=349060 951440 1 180 $X=347200 $Y=951060
X2745 1680 2 1252 15 1 NR2 $T=349060 1001840 1 180 $X=347200 $Y=1001460
X2746 1504 2 1659 1660 1 NR2 $T=347200 1022000 0 0 $X=347200 $Y=1021620
X2747 1513 2 1528 107 1 NR2 $T=350920 961520 1 180 $X=349060 $Y=961140
X2748 1541 2 1641 1654 1 NR2 $T=349060 971600 0 0 $X=349060 $Y=971220
X2749 729 2 1705 1686 1 NR2 $T=352780 941360 0 180 $X=350920 $Y=935940
X2750 1590 2 1691 1690 1 NR2 $T=353400 991760 0 180 $X=351540 $Y=986340
X2751 107 2 1535 78 1 NR2 $T=354020 961520 1 180 $X=352160 $Y=961140
X2752 1541 2 1598 107 1 NR2 $T=352780 971600 0 0 $X=352780 $Y=971220
X2753 1623 2 1590 1654 1 NR2 $T=354640 971600 1 0 $X=354640 $Y=966180
X2754 1643 2 1724 1461 1 NR2 $T=357120 901040 0 180 $X=355260 $Y=895620
X2755 1623 2 1714 107 1 NR2 $T=357740 981680 1 180 $X=355880 $Y=981300
X2756 729 2 1609 1737 1 NR2 $T=357120 951440 1 0 $X=357120 $Y=946020
X2757 729 2 1704 78 1 NR2 $T=357120 971600 0 0 $X=357120 $Y=971220
X2758 1658 2 1737 78 1 NR2 $T=358980 961520 0 0 $X=358980 $Y=961140
X2759 120 2 1720 118 1 NR2 $T=362080 880880 0 180 $X=360220 $Y=875460
X2760 1750 2 1721 1746 1 NR2 $T=364560 941360 0 0 $X=364560 $Y=940980
X2761 1813 2 1824 1812 1 NR2 $T=380060 901040 1 180 $X=378200 $Y=900660
X2762 1836 2 1861 1811 1 NR2 $T=388120 981680 1 0 $X=388120 $Y=976260
X2763 166 2 1885 163 1 NR2 $T=393700 961520 0 180 $X=391840 $Y=956100
X2764 166 2 1884 164 1 NR2 $T=394940 951440 1 180 $X=393080 $Y=951060
X2765 166 2 1930 169 1 NR2 $T=394320 951440 1 0 $X=394320 $Y=946020
X2766 166 2 1919 168 1 NR2 $T=394940 951440 0 0 $X=394940 $Y=951060
X2767 166 2 1909 167 1 NR2 $T=394940 961520 1 0 $X=394940 $Y=956100
X2768 1845 2 1926 138 1 NR2 $T=398040 941360 1 180 $X=396180 $Y=940980
X2769 166 2 1891 1927 1 NR2 $T=396800 981680 1 0 $X=396800 $Y=976260
X2770 166 2 1892 171 1 NR2 $T=396800 981680 0 0 $X=396800 $Y=981300
X2771 166 2 1947 175 1 NR2 $T=403620 941360 1 180 $X=401760 $Y=940980
X2772 1955 2 1973 1933 1 NR2 $T=405480 1001840 1 180 $X=403620 $Y=1001460
X2773 166 2 1966 177 1 NR2 $T=405480 951440 1 0 $X=405480 $Y=946020
X2774 166 2 1983 179 1 NR2 $T=408580 951440 1 0 $X=408580 $Y=946020
X2775 1955 2 2003 1991 1 NR2 $T=410440 1001840 0 180 $X=408580 $Y=996420
X2776 166 2 2016 180 1 NR2 $T=410440 941360 0 0 $X=410440 $Y=940980
X2777 136 2 1981 171 1 NR2 $T=414780 931280 1 180 $X=412920 $Y=930900
X2778 120 2 1970 182 1 NR2 $T=416020 870800 1 180 $X=414160 $Y=870420
X2779 1955 2 2028 2018 1 NR2 $T=416020 1001840 0 180 $X=414160 $Y=996420
X2780 2034 2 2056 183 1 NR2 $T=415400 951440 1 0 $X=415400 $Y=946020
X2781 187 2 1945 120 1 NR2 $T=420980 880880 0 180 $X=419120 $Y=875460
X2782 1955 2 2076 1964 1 NR2 $T=422220 991760 1 180 $X=420360 $Y=991380
X2783 190 2 2060 170 1 NR2 $T=423460 931280 0 0 $X=423460 $Y=930900
X2784 2110 2 2052 2132 1 NR2 $T=428420 1022000 0 0 $X=428420 $Y=1021620
X2785 2110 2 2109 1796 1 NR2 $T=432140 1022000 1 0 $X=432140 $Y=1016580
X2786 136 2 2136 163 1 NR2 $T=432760 921200 0 0 $X=432760 $Y=920820
X2787 2034 2 2068 197 1 NR2 $T=435860 951440 1 0 $X=435860 $Y=946020
X2788 136 2 2168 164 1 NR2 $T=437720 931280 1 0 $X=437720 $Y=925860
X2789 2034 2 2130 201 1 NR2 $T=439580 941360 0 0 $X=439580 $Y=940980
X2790 1702 2 2188 1796 1 NR2 $T=439580 1011920 0 0 $X=439580 $Y=1011540
X2791 2034 2 2106 202 1 NR2 $T=440820 951440 1 0 $X=440820 $Y=946020
X2792 206 2 2066 2034 1 NR2 $T=444540 951440 0 180 $X=442680 $Y=946020
X2793 120 2 2191 171 1 NR2 $T=444540 981680 0 180 $X=442680 $Y=976260
X2794 136 2 2203 167 1 NR2 $T=444540 921200 1 0 $X=444540 $Y=915780
X2795 2224 2 2218 163 1 NR2 $T=446400 961520 0 180 $X=444540 $Y=956100
X2796 120 2 2215 170 1 NR2 $T=446400 981680 0 180 $X=444540 $Y=976260
X2797 2224 2 2231 164 1 NR2 $T=449500 961520 0 180 $X=447640 $Y=956100
X2798 136 2 2237 168 1 NR2 $T=449500 921200 0 0 $X=449500 $Y=920820
X2799 137 2 2249 1857 1 NR2 $T=451360 941360 1 180 $X=449500 $Y=940980
X2800 2224 2 2242 168 1 NR2 $T=449500 951440 1 0 $X=449500 $Y=946020
X2801 2224 2 2222 167 1 NR2 $T=451360 961520 1 180 $X=449500 $Y=961140
X2802 2204 2 2257 2175 1 NR2 $T=452600 1032080 0 180 $X=450740 $Y=1026660
X2803 2224 2 2236 169 1 NR2 $T=451360 951440 1 0 $X=451360 $Y=946020
X2804 2224 2 2250 175 1 NR2 $T=455080 941360 1 180 $X=453220 $Y=940980
X2805 2224 2 2264 177 1 NR2 $T=454460 951440 1 0 $X=454460 $Y=946020
X2806 1643 2 2268 2212 1 NR2 $T=456320 1011920 1 180 $X=454460 $Y=1011540
X2807 136 2 2275 169 1 NR2 $T=455080 921200 0 0 $X=455080 $Y=920820
X2808 2271 2 2332 179 1 NR2 $T=458180 911120 1 180 $X=456320 $Y=910740
X2809 137 2 2289 1895 1 NR2 $T=458180 941360 1 180 $X=456320 $Y=940980
X2810 2224 2 2297 179 1 NR2 $T=458180 951440 0 180 $X=456320 $Y=946020
X2811 137 2 2293 1883 1 NR2 $T=460660 931280 1 180 $X=458800 $Y=930900
X2812 2271 2 2317 177 1 NR2 $T=460040 921200 1 0 $X=460040 $Y=915780
X2813 2271 2 2304 175 1 NR2 $T=460040 921200 0 0 $X=460040 $Y=920820
X2814 1643 2 2300 2163 1 NR2 $T=461900 1022000 0 180 $X=460040 $Y=1016580
X2815 2224 2 2298 183 1 NR2 $T=461280 951440 1 0 $X=461280 $Y=946020
X2816 1643 2 2313 2132 1 NR2 $T=463760 1022000 0 180 $X=461900 $Y=1016580
X2817 2224 2 2324 180 1 NR2 $T=463140 951440 1 0 $X=463140 $Y=946020
X2818 1643 2 2335 2262 1 NR2 $T=463140 1011920 0 0 $X=463140 $Y=1011540
X2819 2224 2 2345 197 1 NR2 $T=466860 941360 0 0 $X=466860 $Y=940980
X2820 2271 2 2356 202 1 NR2 $T=469960 911120 0 180 $X=468100 $Y=905700
X2821 2271 2 2367 197 1 NR2 $T=469960 911120 1 180 $X=468100 $Y=910740
X2822 2224 2 2368 202 1 NR2 $T=473680 951440 0 180 $X=471820 $Y=946020
X2823 2271 2 2366 180 1 NR2 $T=472440 921200 0 0 $X=472440 $Y=920820
X2824 137 2 2389 2101 1 NR2 $T=475540 941360 0 180 $X=473680 $Y=935940
X2825 2224 2 2396 201 1 NR2 $T=473680 941360 0 0 $X=473680 $Y=940980
X2826 206 2 2372 2224 1 NR2 $T=475540 951440 0 180 $X=473680 $Y=946020
X2827 2271 2 2385 183 1 NR2 $T=476160 921200 0 0 $X=476160 $Y=920820
X2828 206 2 2408 2271 1 NR2 $T=479880 901040 0 180 $X=478020 $Y=895620
X2829 2271 2 2419 201 1 NR2 $T=478640 901040 0 0 $X=478640 $Y=900660
X2830 3078 2 3097 3088 1 NR2 $T=610700 1011920 1 0 $X=610700 $Y=1006500
X2831 3143 2 3149 3154 1 NR2 $T=621860 971600 1 0 $X=621860 $Y=966180
X2832 3146 2 3155 3160 1 NR2 $T=623100 901040 1 0 $X=623100 $Y=895620
X2833 3159 2 3161 3150 1 NR2 $T=624340 981680 0 0 $X=624340 $Y=981300
X2834 3030 2 3136 3103 1 NR2 $T=624960 1011920 1 0 $X=624960 $Y=1006500
X2835 3195 2 3187 3168 1 NR2 $T=631780 901040 1 180 $X=629920 $Y=900660
X2836 3162 2 3190 3078 1 NR2 $T=629920 981680 0 0 $X=629920 $Y=981300
X2837 3125 2 3182 3078 1 NR2 $T=629920 991760 1 0 $X=629920 $Y=986340
X2838 3191 2 3198 3215 1 NR2 $T=631780 951440 1 0 $X=631780 $Y=946020
X2839 3201 2 3153 3216 1 NR2 $T=631780 961520 0 0 $X=631780 $Y=961140
X2840 3202 2 3181 3211 1 NR2 $T=631780 971600 0 0 $X=631780 $Y=971220
X2841 3184 2 3196 3214 1 NR2 $T=633020 921200 0 0 $X=633020 $Y=920820
X2842 3206 2 3090 3218 1 NR2 $T=633020 931280 0 0 $X=633020 $Y=930900
X2843 3186 2 3139 3222 1 NR2 $T=633640 941360 0 0 $X=633640 $Y=940980
X2844 3220 2 3076 3227 1 NR2 $T=634880 931280 1 0 $X=634880 $Y=925860
X2845 3185 2 3128 3231 1 NR2 $T=635500 931280 0 0 $X=635500 $Y=930900
X2846 3229 2 3051 3243 1 NR2 $T=636740 961520 1 0 $X=636740 $Y=956100
X2847 3244 2 3205 3180 1 NR2 $T=640460 890960 0 180 $X=638600 $Y=885540
X2848 3258 2 3169 3234 1 NR2 $T=643560 890960 0 0 $X=643560 $Y=890580
X2849 3288 2 3328 3277 1 NR2 $T=647280 961520 1 180 $X=645420 $Y=961140
X2850 3302 2 3304 3290 1 NR2 $T=648520 921200 0 180 $X=646660 $Y=915780
X2851 3309 2 3353 3321 1 NR2 $T=650380 911120 0 0 $X=650380 $Y=910740
X2852 3339 2 3332 3315 1 NR2 $T=652860 931280 0 180 $X=651000 $Y=925860
X2853 3340 2 3331 3318 1 NR2 $T=652860 931280 1 180 $X=651000 $Y=930900
X2854 3358 2 3305 3348 1 NR2 $T=657200 901040 1 180 $X=655340 $Y=900660
X2855 3312 2 3364 3311 1 NR2 $T=655960 961520 1 0 $X=655960 $Y=956100
X2856 3346 2 3363 3366 1 NR2 $T=657200 951440 1 0 $X=657200 $Y=946020
X2857 3355 2 3440 3298 1 NR2 $T=671460 941360 0 0 $X=671460 $Y=940980
X2858 353 2 3471 359 1 NR2 $T=682620 1001840 0 0 $X=682620 $Y=1001460
X2859 3958 2 3953 3959 1 NR2 $T=812200 951440 0 0 $X=812200 $Y=951060
X2860 3958 2 490 3964 1 NR2 $T=814060 890960 0 0 $X=814060 $Y=890580
X2861 3959 2 3962 3965 1 NR2 $T=814060 991760 0 0 $X=814060 $Y=991380
X2862 3956 2 495 3964 1 NR2 $T=815920 911120 1 0 $X=815920 $Y=905700
X2863 3973 2 498 3958 1 NR2 $T=819020 911120 0 0 $X=819020 $Y=910740
X2864 3964 2 3927 3965 1 NR2 $T=819020 1022000 0 0 $X=819020 $Y=1021620
X2865 3973 2 3972 3965 1 NR2 $T=819640 1011920 0 0 $X=819640 $Y=1011540
X2866 3973 2 3913 3968 1 NR2 $T=819640 1022000 1 0 $X=819640 $Y=1016580
X2867 3958 2 503 3979 1 NR2 $T=820880 890960 1 0 $X=820880 $Y=885540
X2868 3956 2 501 3979 1 NR2 $T=820880 890960 0 0 $X=820880 $Y=890580
X2869 3956 2 489 3959 1 NR2 $T=820880 901040 0 0 $X=820880 $Y=900660
X2870 3956 2 481 3973 1 NR2 $T=820880 911120 1 0 $X=820880 $Y=905700
X2871 3979 2 4003 3965 1 NR2 $T=823980 981680 1 180 $X=822120 $Y=981300
X2872 3964 2 3960 3968 1 NR2 $T=822120 1022000 1 0 $X=822120 $Y=1016580
X2873 3979 2 3991 3968 1 NR2 $T=825220 981680 1 0 $X=825220 $Y=976260
X2874 3959 2 3967 3968 1 NR2 $T=830180 991760 0 180 $X=828320 $Y=986340
X2875 4028 2 4034 411 1 NR2 $T=839480 981680 0 180 $X=837620 $Y=976260
X2876 524 2 4035 525 1 NR2 $T=841340 931280 1 0 $X=841340 $Y=925860
X2877 4047 2 4027 525 1 NR2 $T=841340 941360 1 0 $X=841340 $Y=935940
X2878 4058 2 4054 524 1 NR2 $T=844440 931280 1 180 $X=842580 $Y=930900
X2879 4058 2 4055 4047 1 NR2 $T=848160 941360 0 180 $X=846300 $Y=935940
X2880 522 2 4039 411 1 NR2 $T=846300 941360 0 0 $X=846300 $Y=940980
X2881 616 2 4460 617 1 NR2 $T=982700 931280 1 0 $X=982700 $Y=925860
X2882 616 2 4493 618 1 NR2 $T=986420 931280 0 0 $X=986420 $Y=930900
X2883 629 2 4400 618 1 NR2 $T=988280 941360 0 180 $X=986420 $Y=935940
X2884 622 2 4419 618 1 NR2 $T=989520 911120 1 180 $X=987660 $Y=910740
X2885 622 2 4579 617 1 NR2 $T=988900 911120 1 0 $X=988900 $Y=905700
X2886 631 2 4485 617 1 NR2 $T=1000680 931280 1 180 $X=998820 $Y=930900
X2887 629 2 4571 617 1 NR2 $T=1000060 941360 1 0 $X=1000060 $Y=935940
X2888 631 2 4456 618 1 NR2 $T=1002540 931280 0 0 $X=1002540 $Y=930900
X2889 1190 904 2 724 1 1220 AOI12HS $T=273420 1001840 1 0 $X=273420 $Y=996420
X2890 1610 1532 2 1590 1 1667 AOI12HS $T=344720 961520 1 0 $X=344720 $Y=956100
X2891 769 756 745 730 2 1 713 OA112 $T=226300 1042160 0 180 $X=221340 $Y=1036740
X2892 891 16 781 860 2 1 982 OA112 $T=240560 1062320 1 0 $X=240560 $Y=1056900
X2893 1037 1047 890 787 2 1 1063 OA112 $T=253580 1011920 1 0 $X=253580 $Y=1006500
X2894 917 1085 1091 749 2 1 1111 OA112 $T=258540 991760 1 0 $X=258540 $Y=986340
X2895 1110 1117 922 1126 2 1 36 OA112 $T=262880 1011920 0 0 $X=262880 $Y=1011540
X2896 1119 1122 1136 860 2 1 1155 OA112 $T=264120 1052240 0 0 $X=264120 $Y=1051860
X2897 1157 1150 1136 864 2 1 1120 OA112 $T=270320 1042160 1 180 $X=265360 $Y=1041780
X2898 1218 1238 15 864 2 1 1251 OA112 $T=279000 1042160 1 0 $X=279000 $Y=1036740
X2899 1324 1361 1136 797 2 1 1382 OA112 $T=294500 1042160 1 0 $X=294500 $Y=1036740
X2900 1401 1443 1136 1007 2 1 1464 OA112 $T=315580 991760 1 0 $X=315580 $Y=986340
X2901 81 1477 55 1243 2 1 1550 OA112 $T=328600 1022000 1 180 $X=323640 $Y=1021620
X2902 81 1530 889 864 2 1 1587 OA112 $T=334800 1022000 1 180 $X=329840 $Y=1021620
X2903 988 974 920 893 2 1 948 MAOI1 $T=247380 1042160 1 180 $X=242420 $Y=1041780
X2904 741 1 723 728 2 710 ND3 $T=223820 971600 1 180 $X=221340 $Y=971220
X2905 813 1 750 731 2 701 ND3 $T=225060 1001840 1 180 $X=222580 $Y=1001460
X2906 799 1 797 738 2 7 ND3 $T=228160 1032080 1 0 $X=228160 $Y=1026660
X2907 815 1 823 6 2 9 ND3 $T=229400 1042160 0 0 $X=229400 $Y=1041780
X2908 856 1 866 874 2 880 ND3 $T=233120 1042160 0 0 $X=233120 $Y=1041780
X2909 929 1 917 909 2 907 ND3 $T=240560 1011920 0 180 $X=238080 $Y=1006500
X2910 928 1 921 727 2 910 ND3 $T=241180 961520 1 180 $X=238700 $Y=961140
X2911 972 1 825 958 2 960 ND3 $T=242420 901040 0 0 $X=242420 $Y=900660
X2912 762 1 962 968 2 978 ND3 $T=243040 1022000 1 0 $X=243040 $Y=1016580
X2913 986 1 1037 991 2 907 ND3 $T=249240 1011920 1 180 $X=246760 $Y=1011540
X2914 994 1 996 19 2 982 ND3 $T=249240 1052240 1 180 $X=246760 $Y=1051860
X2915 1015 1 1004 1002 2 989 ND3 $T=251100 911120 1 180 $X=248620 $Y=910740
X2916 1019 1 710 937 2 989 ND3 $T=251720 941360 1 180 $X=249240 $Y=940980
X2917 1048 1 735 1035 2 949 ND3 $T=254200 941360 1 180 $X=251720 $Y=940980
X2918 1034 1 1009 1042 2 1054 ND3 $T=253580 931280 1 0 $X=253580 $Y=925860
X2919 1065 1 1033 1052 2 1041 ND3 $T=257300 1001840 1 180 $X=254820 $Y=1001460
X2920 1068 1 778 1115 2 950 ND3 $T=258540 911120 1 0 $X=258540 $Y=905700
X2921 1120 1 948 1106 2 1105 ND3 $T=264740 1042160 1 180 $X=262260 $Y=1041780
X2922 1111 1 1113 1116 2 1093 ND3 $T=262880 1011920 1 0 $X=262880 $Y=1006500
X2923 1062 1 951 1132 2 976 ND3 $T=266600 961520 1 0 $X=266600 $Y=956100
X2924 1166 1 1164 1178 2 1112 ND3 $T=271560 971600 1 180 $X=269080 $Y=971220
X2925 966 1 831 1182 2 1213 ND3 $T=274040 971600 1 0 $X=274040 $Y=966180
X2926 40 1 48 1098 2 870 ND3 $T=277760 1052240 1 0 $X=277760 $Y=1046820
X2927 1280 1 911 1281 2 1236 ND3 $T=285200 1052240 1 180 $X=282720 $Y=1051860
X2928 1163 1 892 1294 2 791 ND3 $T=283960 931280 1 0 $X=283960 $Y=925860
X2929 1331 1 1004 1338 2 892 ND3 $T=293260 951440 1 180 $X=290780 $Y=951060
X2930 1357 1 1334 1323 2 1350 ND3 $T=292640 1022000 1 0 $X=292640 $Y=1016580
X2931 1172 1 1364 1368 2 1372 ND3 $T=295740 931280 0 0 $X=295740 $Y=930900
X2932 1382 1 1304 1392 2 1373 ND3 $T=298840 991760 0 0 $X=298840 $Y=991380
X2933 1070 1 1391 1395 2 1360 ND3 $T=299460 991760 1 0 $X=299460 $Y=986340
X2934 1385 1 1261 1396 2 1400 ND3 $T=299460 1011920 0 0 $X=299460 $Y=1011540
X2935 976 1 708 1418 2 1411 ND3 $T=301320 961520 1 0 $X=301320 $Y=956100
X2936 1308 1 951 1421 2 787 ND3 $T=301940 961520 0 0 $X=301940 $Y=961140
X2937 906 1 1424 1428 2 1436 ND3 $T=304420 991760 1 0 $X=304420 $Y=986340
X2938 820 1 1306 1444 2 1440 ND3 $T=304420 1052240 1 0 $X=304420 $Y=1046820
X2939 1022 1 888 1472 2 1317 ND3 $T=315580 971600 1 180 $X=313100 $Y=971220
X2940 1200 1 1484 1487 2 1494 ND3 $T=313100 991760 0 0 $X=313100 $Y=991380
X2941 739 1 783 1501 2 861 ND3 $T=314960 961520 1 0 $X=314960 $Y=956100
X2942 777 1 1496 1508 2 1518 ND3 $T=316200 991760 0 0 $X=316200 $Y=991380
X2943 1533 1 1514 1450 2 1474 ND3 $T=319920 1042160 1 180 $X=317440 $Y=1041780
X2944 1533 1 1530 1397 2 1464 ND3 $T=322400 1022000 1 180 $X=319920 $Y=1021620
X2945 943 1 1562 750 2 1578 ND3 $T=326740 1001840 1 0 $X=326740 $Y=996420
X2946 1367 1 1550 1575 2 1399 ND3 $T=326740 1032080 1 0 $X=326740 $Y=1026660
X2947 82 1 1584 1588 2 85 ND3 $T=328600 1062320 1 0 $X=328600 $Y=1056900
X2948 888 1 1064 1612 2 1541 ND3 $T=336040 961520 0 180 $X=333560 $Y=956100
X2949 1606 1 1523 1554 2 1601 ND3 $T=339140 991760 1 180 $X=336660 $Y=991380
X2950 1366 1 1607 1633 2 1638 ND3 $T=336660 1032080 1 0 $X=336660 $Y=1026660
X2951 1258 1 1659 1669 2 1599 ND3 $T=343480 1011920 1 0 $X=343480 $Y=1006500
X2952 1676 1 1549 1562 2 1691 ND3 $T=349060 991760 1 0 $X=349060 $Y=986340
X2953 1699 1 1741 1482 2 1720 ND3 $T=363320 880880 1 180 $X=360840 $Y=880500
X2954 1775 1 1798 1787 2 1807 ND3 $T=373240 1032080 0 0 $X=373240 $Y=1031700
X2955 1848 1 1877 1881 2 1860 ND3 $T=389980 1042160 0 0 $X=389980 $Y=1041780
X2956 2538 1 2517 227 2 2493 ND3 $T=499720 870800 1 180 $X=497240 $Y=870420
X2957 2646 1 2647 2597 2 2659 ND3 $T=517700 880880 1 0 $X=517700 $Y=875460
X2958 3051 1 3046 2981 2 3034 ND3 $T=606980 951440 1 180 $X=604500 $Y=951060
X2959 3072 1 3060 2928 2 3080 ND3 $T=609460 1032080 1 180 $X=606980 $Y=1031700
X2960 3076 1 3068 2963 2 3056 ND3 $T=610080 911120 1 180 $X=607600 $Y=910740
X2961 3090 1 3079 3043 2 3070 ND3 $T=611940 931280 1 180 $X=609460 $Y=930900
X2962 3116 1 3122 3062 2 3101 ND3 $T=616900 890960 0 180 $X=614420 $Y=885540
X2963 3128 1 3107 3036 2 3112 ND3 $T=618760 921200 0 180 $X=616280 $Y=915780
X2964 3139 1 3130 3026 2 3129 ND3 $T=620620 941360 0 180 $X=618140 $Y=935940
X2965 3198 1 3119 3023 2 3121 ND3 $T=620620 951440 0 180 $X=618140 $Y=946020
X2966 3099 1 3094 3132 2 3041 ND3 $T=620000 1011920 1 0 $X=620000 $Y=1006500
X2967 3153 1 3135 3015 2 3142 ND3 $T=623720 961520 0 180 $X=621240 $Y=956100
X2968 3078 1 3088 3083 2 3136 ND3 $T=623720 991760 0 180 $X=621240 $Y=986340
X2969 3099 1 3041 3134 2 3078 ND3 $T=622480 1011920 1 0 $X=622480 $Y=1006500
X2970 3074 1 3136 3141 2 3078 ND3 $T=623100 1001840 1 0 $X=623100 $Y=996420
X2971 3074 1 3094 3105 2 3136 ND3 $T=625580 1001840 1 180 $X=623100 $Y=1001460
X2972 3155 1 3158 3006 2 3166 ND3 $T=623720 890960 1 0 $X=623720 $Y=885540
X2973 3181 1 3175 3052 2 3165 ND3 $T=628680 971600 1 180 $X=626200 $Y=971220
X2974 3187 1 3188 3055 2 3204 ND3 $T=629920 901040 1 0 $X=629920 $Y=895620
X2975 3196 1 3200 2958 2 3207 ND3 $T=631160 911120 1 0 $X=631160 $Y=905700
X2976 3125 1 3053 3251 2 3105 ND3 $T=634260 1042160 1 0 $X=634260 $Y=1036740
X2977 3161 1 3265 3292 2 3299 ND3 $T=645420 971600 1 0 $X=645420 $Y=966180
X2978 3305 1 3282 3300 2 3295 ND3 $T=649760 901040 1 180 $X=647280 $Y=900660
X2979 3304 1 3306 3310 2 3263 ND3 $T=648520 921200 1 0 $X=648520 $Y=915780
X2980 3149 1 3354 3316 2 3352 ND3 $T=657820 961520 1 180 $X=655340 $Y=961140
X2981 3353 1 3362 3365 2 3371 ND3 $T=657200 911120 0 0 $X=657200 $Y=910740
X2982 3331 1 3373 3385 2 3376 ND3 $T=659060 931280 0 0 $X=659060 $Y=930900
X2983 3390 1 3327 3384 2 3369 ND3 $T=664640 901040 0 180 $X=662160 $Y=895620
X2984 3328 1 3395 3418 2 3374 ND3 $T=664020 961520 0 0 $X=664020 $Y=961140
X2985 3364 1 3401 3417 2 3391 ND3 $T=665260 961520 1 0 $X=665260 $Y=956100
X2986 3332 1 3415 3458 2 3386 ND3 $T=667120 931280 1 0 $X=667120 $Y=925860
X2987 3440 1 3429 3431 2 3413 ND3 $T=672700 931280 1 180 $X=670220 $Y=930900
X2988 3363 1 3437 3451 2 3396 ND3 $T=670840 951440 1 0 $X=670840 $Y=946020
X2989 3427 1 3449 3453 2 3424 ND3 $T=673940 1011920 0 0 $X=673940 $Y=1011540
X2990 3426 1 3484 3469 2 3455 ND3 $T=680760 1011920 1 0 $X=680760 $Y=1006500
X2991 3539 1 3544 3535 2 3521 ND3 $T=695640 1042160 1 180 $X=693160 $Y=1041780
X2992 3532 1 3538 3542 2 3517 ND3 $T=694400 1032080 0 0 $X=694400 $Y=1031700
X2993 3583 1 3589 3573 2 3564 ND3 $T=705560 971600 1 180 $X=703080 $Y=971220
X2994 3613 1 3617 3620 2 3626 ND3 $T=714860 1032080 0 0 $X=714860 $Y=1031700
X2995 3625 1 3631 3647 2 3618 ND3 $T=719820 981680 1 0 $X=719820 $Y=976260
X2996 3660 1 3681 3698 2 3652 ND3 $T=735320 981680 1 0 $X=735320 $Y=976260
X2997 3665 1 3680 3711 2 3696 ND3 $T=738420 1042160 0 0 $X=738420 $Y=1041780
X2998 3722 1 3721 3719 2 3718 ND3 $T=745240 991760 0 180 $X=742760 $Y=986340
X2999 3689 1 3743 3738 2 3724 ND3 $T=748960 981680 0 0 $X=748960 $Y=981300
X3000 3752 1 3767 3769 2 3770 ND3 $T=753300 1042160 1 0 $X=753300 $Y=1036740
X3001 3811 1 3825 3827 2 3832 ND3 $T=772520 991760 1 0 $X=772520 $Y=986340
X3002 3843 1 3804 3838 2 3821 ND3 $T=778100 1042160 1 180 $X=775620 $Y=1041780
X3003 3851 1 3849 3850 2 3840 ND3 $T=780580 981680 0 180 $X=778100 $Y=976260
X3004 3870 1 3863 3885 2 3877 ND3 $T=791120 1042160 1 0 $X=791120 $Y=1036740
X3005 3894 1 3911 3910 2 3915 ND3 $T=798560 991760 1 0 $X=798560 $Y=986340
X3006 484 1 3928 3919 2 3908 ND3 $T=805380 1042160 1 180 $X=802900 $Y=1041780
X3007 3951 1 3955 3949 2 3948 ND3 $T=812820 991760 0 180 $X=810340 $Y=986340
X3008 3994 1 4008 4009 2 4012 ND3 $T=828940 1052240 1 0 $X=828940 $Y=1046820
X3009 529 1 4064 4010 2 4060 ND3 $T=846920 1052240 1 180 $X=844440 $Y=1051860
X3010 4067 1 4020 4061 2 4078 ND3 $T=847540 1001840 0 0 $X=847540 $Y=1001460
X3011 4120 1 4021 4094 2 4127 ND3 $T=861180 1011920 0 0 $X=861180 $Y=1011540
X3012 4134 1 4130 4122 2 4126 ND3 $T=864900 1001840 0 180 $X=862420 $Y=996420
X3013 539 1 4147 4135 2 4164 ND3 $T=868620 1052240 1 0 $X=868620 $Y=1046820
X3014 4196 1 4208 4195 2 4211 ND3 $T=883500 1001840 1 0 $X=883500 $Y=996420
X3015 554 1 4235 4214 2 4228 ND3 $T=892800 1052240 1 180 $X=890320 $Y=1051860
X3016 4262 1 4265 4198 2 4273 ND3 $T=900240 1001840 1 0 $X=900240 $Y=996420
X3017 4311 1 4301 4294 2 4295 ND3 $T=909540 1042160 1 180 $X=907060 $Y=1041780
X3018 4317 1 4319 4321 2 4324 ND3 $T=914500 1042160 0 0 $X=914500 $Y=1041780
X3019 4320 1 4326 4255 2 4323 ND3 $T=918840 1001840 0 180 $X=916360 $Y=996420
X3020 572 1 4351 4318 2 4423 ND3 $T=925040 1042160 1 180 $X=922560 $Y=1041780
X3021 4353 1 574 573 2 4349 ND3 $T=928760 870800 1 180 $X=926280 $Y=870420
X3022 4374 1 4378 581 2 4386 ND3 $T=934340 880880 0 0 $X=934340 $Y=880500
X3023 4387 1 4372 585 2 4379 ND3 $T=938060 961520 1 180 $X=935580 $Y=961140
X3024 4380 1 4376 583 2 4391 ND3 $T=936200 901040 0 0 $X=936200 $Y=900660
X3025 4381 1 4366 586 2 4404 ND3 $T=936200 911120 0 0 $X=936200 $Y=910740
X3026 4382 1 4365 584 2 4392 ND3 $T=936200 961520 1 0 $X=936200 $Y=956100
X3027 4385 1 4368 589 2 4399 ND3 $T=938060 931280 1 0 $X=938060 $Y=925860
X3028 4396 1 4401 590 2 4409 ND3 $T=939300 941360 0 0 $X=939300 $Y=940980
X3029 4426 1 4414 4330 2 4421 ND3 $T=945500 1001840 0 180 $X=943020 $Y=996420
X3030 4429 1 4402 4335 2 4445 ND3 $T=947980 1011920 0 0 $X=947980 $Y=1011540
X3031 4430 1 4415 4322 2 4446 ND3 $T=947980 1042160 0 0 $X=947980 $Y=1041780
X3032 4497 1 4435 4342 2 4442 ND3 $T=952320 1032080 0 180 $X=949840 $Y=1026660
X3033 4549 1 4572 620 2 4576 ND3 $T=986420 971600 1 0 $X=986420 $Y=966180
X3034 4574 1 4559 623 2 4582 ND3 $T=988280 901040 0 0 $X=988280 $Y=900660
X3035 4586 1 4560 625 2 4592 ND3 $T=990760 921200 1 0 $X=990760 $Y=915780
X3036 4598 1 4588 628 2 4602 ND3 $T=995100 880880 1 0 $X=995100 $Y=875460
X3037 4624 1 4629 633 2 4620 ND3 $T=1001920 961520 0 0 $X=1001920 $Y=961140
X3038 4655 1 4653 635 2 4641 ND3 $T=1011840 991760 1 180 $X=1009360 $Y=991380
X3039 4651 1 4662 636 2 4627 ND3 $T=1013700 1001840 1 180 $X=1011220 $Y=1001460
X3040 4688 1 4686 642 2 4682 ND3 $T=1025480 951440 0 180 $X=1023000 $Y=946020
X3041 4685 1 4691 643 2 4680 ND3 $T=1026100 1001840 0 180 $X=1023620 $Y=996420
X3042 4713 1 4711 648 2 4709 ND3 $T=1036640 1001840 0 180 $X=1034160 $Y=996420
X3043 4735 1 4729 651 2 4718 ND3 $T=1042840 931280 0 180 $X=1040360 $Y=925860
X3044 4742 1 654 652 2 4724 ND3 $T=1047800 870800 1 180 $X=1045320 $Y=870420
X3045 4753 1 658 655 2 4746 ND3 $T=1050900 870800 1 180 $X=1048420 $Y=870420
X3046 4759 1 4752 656 2 4750 ND3 $T=1051520 991760 1 180 $X=1049040 $Y=991380
X3047 4755 1 4761 659 2 4766 ND3 $T=1052140 951440 1 0 $X=1052140 $Y=946020
X3048 4775 1 4762 660 2 4773 ND3 $T=1055860 971600 1 0 $X=1055860 $Y=966180
X3049 4790 1 664 662 2 4777 ND3 $T=1064540 880880 0 180 $X=1062060 $Y=875460
X3050 4797 1 4793 666 2 4801 ND3 $T=1068260 991760 1 180 $X=1065780 $Y=991380
X3051 4816 1 4823 668 2 4829 ND3 $T=1074460 1001840 1 0 $X=1074460 $Y=996420
X3052 4836 1 4830 669 2 4812 ND3 $T=1078180 880880 0 180 $X=1075700 $Y=875460
X3053 4828 1 672 673 2 4850 ND3 $T=1078800 880880 0 0 $X=1078800 $Y=880500
X3054 1217 1307 1 2 BUF2 $T=287060 890960 1 0 $X=287060 $Y=885540
X3055 1810 120 1 2 BUF2 $T=372000 951440 1 180 $X=368900 $Y=951060
X3056 1819 166 1 2 BUF2 $T=385640 941360 1 0 $X=385640 $Y=935940
X3057 676 675 1 2 BUF2 $T=1091200 991760 0 180 $X=1088100 $Y=986340
X3058 401 370 3699 1 2 409 370 3729 697 ICV_13 $T=727260 1022000 1 0 $X=727260 $Y=1016580
X3059 399 410 3841 1 2 439 413 3887 697 ICV_13 $T=771900 890960 1 0 $X=771900 $Y=885540
X3060 467 370 3901 1 2 467 384 3935 697 ICV_13 $T=786780 1011920 1 0 $X=786780 $Y=1006500
X3061 464 3461 3909 1 2 467 3466 3943 697 ICV_13 $T=788640 991760 0 0 $X=788640 $Y=991380
X3062 487 3966 4004 1 2 487 518 4036 697 ICV_13 $T=818400 971600 0 0 $X=818400 $Y=971220
X3063 511 499 4029 1 2 511 497 4069 697 ICV_13 $T=827700 901040 1 0 $X=827700 $Y=895620
X3064 3990 497 4045 1 2 3990 492 4090 697 ICV_13 $T=832040 921200 1 0 $X=832040 $Y=915780
X3065 506 523 4040 1 2 506 512 4102 697 ICV_13 $T=837620 1042160 1 0 $X=837620 $Y=1036740
X3066 3990 3966 4077 1 2 472 518 4103 697 ICV_13 $T=839480 971600 0 0 $X=839480 $Y=971220
X3067 511 4022 4097 1 2 511 4053 4140 697 ICV_13 $T=847540 991760 0 0 $X=847540 $Y=991380
X3068 3990 518 4113 1 2 4111 518 4153 697 ICV_13 $T=853740 890960 0 0 $X=853740 $Y=890580
X3069 4111 488 4145 1 2 4124 488 4200 697 ICV_13 $T=863660 921200 1 0 $X=863660 $Y=915780
X3070 534 518 4137 1 2 4111 3966 4202 697 ICV_13 $T=863660 971600 0 0 $X=863660 $Y=971220
X3071 4124 518 4193 1 2 4191 494 4231 697 ICV_13 $T=870480 961520 0 0 $X=870480 $Y=961140
X3072 4191 3966 4248 1 2 548 3966 4315 697 ICV_13 $T=893420 981680 1 0 $X=893420 $Y=976260
X3073 568 565 4354 1 2 568 578 4395 697 ICV_13 $T=919460 931280 0 0 $X=919460 $Y=930900
X3074 570 565 4362 1 2 570 575 4413 697 ICV_13 $T=921320 941360 1 0 $X=921320 $Y=935940
X3075 582 575 4432 1 2 561 593 4469 697 ICV_13 $T=937440 981680 1 0 $X=937440 $Y=976260
X3076 4118 4024 4453 1 2 4216 513 4491 697 ICV_13 $T=944260 1001840 0 0 $X=944260 $Y=1001460
X3077 582 592 4487 1 2 605 594 4531 697 ICV_13 $T=953560 991760 0 0 $X=953560 $Y=991380
X3078 570 594 4498 1 2 570 596 4504 697 ICV_13 $T=958520 941360 0 0 $X=958520 $Y=940980
X3079 561 594 4509 1 2 605 571 4545 697 ICV_13 $T=959140 961520 0 0 $X=959140 $Y=961140
X3080 568 596 4516 1 2 568 594 4552 697 ICV_13 $T=961620 931280 0 0 $X=961620 $Y=930900
X3081 582 594 4535 1 2 4216 512 4562 697 ICV_13 $T=965340 1001840 0 0 $X=965340 $Y=1001460
X3082 613 565 4575 1 2 601 575 4630 697 ICV_13 $T=978980 890960 0 0 $X=978980 $Y=890580
X3083 619 592 4616 1 2 627 4614 4644 697 ICV_13 $T=990760 991760 1 0 $X=990760 $Y=986340
X3084 601 596 4667 1 2 601 593 4694 697 ICV_13 $T=1006880 911120 1 0 $X=1006880 $Y=905700
X3085 607 592 4701 1 2 644 638 4719 697 ICV_13 $T=1017420 921200 1 0 $X=1017420 $Y=915780
X3086 606 638 4734 1 2 606 647 4748 697 ICV_13 $T=1033540 961520 1 0 $X=1033540 $Y=956100
X3087 611 4668 4725 1 2 649 638 4760 697 ICV_13 $T=1034780 971600 1 0 $X=1034780 $Y=966180
X3088 650 4614 4731 1 2 657 4614 4774 697 ICV_13 $T=1039740 890960 1 0 $X=1039740 $Y=885540
X3089 644 4632 4747 1 2 644 4668 4784 697 ICV_13 $T=1042220 941360 1 0 $X=1042220 $Y=935940
X3090 644 4634 4743 1 2 644 4707 4785 697 ICV_13 $T=1045320 931280 0 0 $X=1045320 $Y=930900
X3091 606 4639 4786 1 2 606 4632 4831 697 ICV_13 $T=1054620 961520 1 0 $X=1054620 $Y=956100
X3092 1739 1666 1 2 INV4CK $T=378200 941360 0 180 $X=374480 $Y=935940
X3093 2918 2970 1 2 INV4CK $T=592720 941360 0 0 $X=592720 $Y=940980
X3094 3866 368 1 2 INV4CK $T=784300 1052240 0 180 $X=780580 $Y=1046820
X3095 3907 3600 1 2 INV4CK $T=798560 991760 0 180 $X=794840 $Y=986340
X3096 3912 384 1 2 INV4CK $T=799800 1011920 1 180 $X=796080 $Y=1011540
X3097 3921 3531 1 2 INV4CK $T=802900 981680 0 180 $X=799180 $Y=976260
X3098 3944 3461 1 2 INV4CK $T=808480 1001840 0 0 $X=808480 $Y=1001460
X3099 3947 3466 1 2 INV4CK $T=809720 1011920 0 0 $X=809720 $Y=1011540
X3100 3859 382 1 2 INV4CK $T=827080 1011920 0 180 $X=823360 $Y=1006500
X3101 3978 488 1 2 INV4CK $T=826460 890960 0 0 $X=826460 $Y=890580
X3102 527 497 1 2 INV4CK $T=845060 880880 0 0 $X=845060 $Y=880500
X3103 4121 535 1 2 INV4CK $T=861180 1022000 0 0 $X=861180 $Y=1021620
X3104 4086 516 1 2 INV4CK $T=864900 1001840 1 0 $X=864900 $Y=996420
X3105 4139 3966 1 2 INV4CK $T=869240 991760 0 180 $X=865520 $Y=986340
X3106 4158 4053 1 2 INV4CK $T=879160 1001840 0 0 $X=879160 $Y=1001460
X3107 4239 4024 1 2 INV4CK $T=892800 1001840 0 0 $X=892800 $Y=1001460
X3108 4249 513 1 2 INV4CK $T=896520 1022000 0 180 $X=892800 $Y=1016580
X3109 4532 596 1 2 INV4CK $T=975260 931280 0 180 $X=971540 $Y=925860
X3110 4566 578 1 2 INV4CK $T=990140 971600 0 0 $X=990140 $Y=971220
X3111 4543 4614 1 2 INV4CK $T=1021760 971600 1 180 $X=1018040 $Y=971220
X3112 4561 638 1 2 INV4CK $T=1028580 941360 0 0 $X=1028580 $Y=940980
X3113 4659 4634 1 2 INV4CK $T=1031060 961520 0 0 $X=1031060 $Y=961140
X3114 4589 4707 1 2 INV4CK $T=1035400 981680 0 180 $X=1031680 $Y=976260
X3115 4645 647 1 2 INV4CK $T=1045940 941360 1 180 $X=1042220 $Y=940980
X3116 4638 4668 1 2 INV4CK $T=1044700 961520 0 0 $X=1044700 $Y=961140
X3117 409 384 3766 1 2 3776 3762 3784 385 381 697 ICV_14 $T=747720 1011920 1 0 $X=747720 $Y=1006500
X3118 439 3600 3803 1 2 3803 3801 3804 3558 3562 697 ICV_14 $T=755780 1042160 1 0 $X=755780 $Y=1036740
X3119 3990 494 4105 1 2 4113 4105 4089 427 428 697 ICV_14 $T=848780 901040 1 0 $X=848780 $Y=895620
X3120 534 492 4148 1 2 4148 4157 4156 432 437 697 ICV_14 $T=859940 941360 0 0 $X=859940 $Y=940980
X3121 511 513 4163 1 2 4178 4184 4182 367 371 697 ICV_14 $T=865520 1022000 1 0 $X=865520 $Y=1016580
X3122 4176 494 4218 1 2 4220 4218 4223 427 428 697 ICV_14 $T=877300 901040 1 0 $X=877300 $Y=895620
X3123 4124 512 4257 1 2 4257 4244 4201 385 381 697 ICV_14 $T=889080 1032080 1 0 $X=889080 $Y=1026660
X3124 4111 4024 4310 1 2 4316 4310 4273 3522 3527 697 ICV_14 $T=902720 1001840 0 0 $X=902720 $Y=1001460
X3125 570 578 4448 1 2 4448 4413 4409 587 588 697 ICV_14 $T=941780 941360 0 0 $X=941780 $Y=940980
X3126 561 592 4489 1 2 4489 4469 4490 599 600 697 ICV_14 $T=954800 971600 0 0 $X=954800 $Y=971220
X3127 567 596 4508 1 2 4515 4508 4477 602 603 697 ICV_14 $T=959140 911120 0 0 $X=959140 $Y=910740
X3128 563 596 4521 1 2 4523 4521 4467 602 603 697 ICV_14 $T=961000 901040 0 0 $X=961000 $Y=900660
X3129 607 565 4556 1 2 4544 4556 4560 577 576 697 ICV_14 $T=973400 911120 0 0 $X=973400 $Y=910740
X3130 613 571 4581 1 2 4581 4575 4588 577 576 697 ICV_14 $T=980220 880880 0 0 $X=980220 $Y=880500
X3131 605 575 4585 1 2 4545 4570 4572 577 576 697 ICV_14 $T=980220 961520 0 0 $X=980220 $Y=961140
X3132 619 575 4611 1 2 4619 4611 4620 587 588 697 ICV_14 $T=989520 971600 1 0 $X=989520 $Y=966180
X3133 619 596 4689 1 2 4683 4689 4669 602 603 697 ICV_14 $T=1014320 981680 1 0 $X=1014320 $Y=976260
X3134 601 592 4695 1 2 4702 4696 4636 599 600 697 ICV_14 $T=1016800 890960 0 0 $X=1016800 $Y=890580
X3135 611 4707 4720 1 2 4720 4725 4700 602 603 697 ICV_14 $T=1027960 971600 0 0 $X=1027960 $Y=971220
X3136 649 647 4756 1 2 4760 4756 4762 577 576 697 ICV_14 $T=1042220 971600 0 0 $X=1042220 $Y=971220
X3137 2916 273 1 2 INV6CK $T=596440 961520 0 180 $X=590860 $Y=956100
X3138 2970 270 1 2 INV6CK $T=604500 961520 0 0 $X=604500 $Y=961140
X3139 3869 370 1 2 INV6CK $T=788020 1032080 0 180 $X=782440 $Y=1026660
X3140 4098 4022 1 2 INV6CK $T=857460 1011920 0 180 $X=851880 $Y=1006500
X3141 4087 523 1 2 INV6CK $T=871100 1011920 0 180 $X=865520 $Y=1006500
X3142 4171 512 1 2 INV6CK $T=874820 1022000 0 0 $X=874820 $Y=1021620
X3143 4352 592 1 2 INV6CK $T=963480 961520 0 180 $X=957900 $Y=956100
X3144 4478 575 1 2 INV6CK $T=958520 1011920 1 0 $X=958520 $Y=1006500
X3145 4405 593 1 2 INV6CK $T=967200 951440 0 180 $X=961620 $Y=946020
X3146 4539 571 1 2 INV6CK $T=977120 961520 0 180 $X=971540 $Y=956100
X3147 4416 594 1 2 INV6CK $T=977120 1032080 1 0 $X=977120 $Y=1026660
X3148 4656 4639 1 2 INV6CK $T=1011840 991760 0 0 $X=1011840 $Y=991380
X3149 4658 565 1 2 INV6CK $T=1026100 951440 0 0 $X=1026100 $Y=951060
X3150 4348 4632 1 2 INV6CK $T=1039740 951440 0 0 $X=1039740 $Y=951060
X3151 894 2 1 1246 BUF1 $T=283340 951440 1 0 $X=283340 $Y=946020
X3152 1505 2 1 1167 BUF1 $T=319300 901040 1 180 $X=316820 $Y=900660
X3153 86 2 1 729 BUF1 $T=330460 921200 0 0 $X=330460 $Y=920820
X3154 1826 2 1 1796 BUF1 $T=375720 971600 1 180 $X=373240 $Y=971220
X3155 1702 2 1 142 BUF1 $T=375100 880880 1 0 $X=375100 $Y=875460
X3156 1643 2 1 1813 BUF1 $T=386260 901040 0 0 $X=386260 $Y=900660
X3157 126 2 1 1910 BUF1 $T=389980 971600 0 180 $X=387500 $Y=966180
X3158 1770 2 1 1899 BUF1 $T=391220 1042160 1 0 $X=391220 $Y=1036740
X3159 166 2 1 2034 BUF1 $T=413540 941360 0 0 $X=413540 $Y=940980
X3160 150 2 1 2126 BUF1 $T=429040 921200 0 0 $X=429040 $Y=920820
X3161 138 2 1 2153 BUF1 $T=433380 931280 0 0 $X=433380 $Y=930900
X3162 1702 2 1 2214 BUF1 $T=442680 971600 0 0 $X=442680 $Y=971220
X3163 120 2 1 2224 BUF1 $T=445780 951440 1 0 $X=445780 $Y=946020
X3164 136 2 1 2271 BUF1 $T=452600 921200 0 0 $X=452600 $Y=920820
X3165 1643 2 1 2296 BUF1 $T=457560 991760 0 0 $X=457560 $Y=991380
X3166 137 2 1 2409 BUF1 $T=476780 931280 0 0 $X=476780 $Y=930900
X3167 1899 2 1 2432 BUF1 $T=491040 1011920 0 0 $X=491040 $Y=1011540
X3168 253 2 1 2874 BUF1 $T=587760 921200 1 180 $X=585280 $Y=920820
X3169 3147 2 1 3152 BUF1 $T=633640 941360 1 0 $X=633640 $Y=935940
X3170 3132 2 1 3235 BUF1 $T=639840 951440 1 0 $X=639840 $Y=946020
X3171 3235 2 1 3133 BUF1 $T=641700 931280 0 0 $X=641700 $Y=930900
X3172 3655 2 1 352 BUF1 $T=730360 901040 1 0 $X=730360 $Y=895620
X3173 403 2 1 3682 BUF1 $T=732220 890960 1 0 $X=732220 $Y=885540
X3174 3672 2 1 354 BUF1 $T=732220 890960 0 0 $X=732220 $Y=890580
X3175 445 2 1 3732 BUF1 $T=759500 890960 1 0 $X=759500 $Y=885540
X3176 3781 2 1 472 BUF1 $T=789880 921200 1 0 $X=789880 $Y=915780
X3177 3735 2 1 483 BUF1 $T=801660 921200 0 0 $X=801660 $Y=920820
X3178 485 2 1 3939 BUF1 $T=805380 921200 0 0 $X=805380 $Y=920820
X3179 3809 2 1 3990 BUF1 $T=823980 890960 0 0 $X=823980 $Y=890580
X3180 3774 2 1 4118 BUF1 $T=858080 880880 0 0 $X=858080 $Y=880500
X3181 3720 2 1 4124 BUF1 $T=859940 911120 1 0 $X=859940 $Y=905700
X3182 537 2 1 4128 BUF1 $T=861180 870800 0 0 $X=861180 $Y=870420
X3183 541 2 1 4125 BUF1 $T=864280 921200 0 0 $X=864280 $Y=920820
X3184 3748 2 1 4216 BUF1 $T=873580 901040 0 0 $X=873580 $Y=900660
X3185 3818 2 1 4176 BUF1 $T=874820 890960 1 0 $X=874820 $Y=885540
X3186 3771 2 1 4191 BUF1 $T=877300 911120 0 0 $X=877300 $Y=910740
X3187 3795 2 1 4232 BUF1 $T=888460 901040 0 0 $X=888460 $Y=900660
X3188 3764 2 1 606 BUF1 $T=962240 870800 0 0 $X=962240 $Y=870420
X3189 3792 2 1 612 BUF1 $T=974020 880880 1 0 $X=974020 $Y=875460
X3190 3717 2 1 611 BUF1 $T=974020 880880 0 0 $X=974020 $Y=880500
X3191 3831 2 1 615 BUF1 $T=977740 880880 0 0 $X=977740 $Y=880500
X3192 3794 2 1 626 BUF1 $T=990140 880880 1 0 $X=990140 $Y=875460
X3193 3787 2 1 627 BUF1 $T=992620 880880 1 0 $X=992620 $Y=875460
X3194 3805 2 1 649 BUF1 $T=1029820 870800 0 0 $X=1029820 $Y=870420
X3195 3753 2 1 644 BUF1 $T=1029820 880880 0 0 $X=1029820 $Y=880500
X3196 3846 2 1 646 BUF1 $T=1031060 890960 1 0 $X=1031060 $Y=885540
X3197 3725 2 1 650 BUF1 $T=1033540 880880 0 0 $X=1033540 $Y=880500
X3198 1731 1739 1 2 INV2CK $T=360840 931280 0 180 $X=358360 $Y=925860
X3199 3007 2976 1 2 INV2CK $T=601400 1011920 0 180 $X=598920 $Y=1006500
X3200 3857 3859 1 2 INV2CK $T=781200 1001840 0 0 $X=781200 $Y=1001460
X3201 3888 3866 1 2 INV2CK $T=796700 1052240 0 180 $X=794220 $Y=1046820
X3202 3923 3869 1 2 INV2CK $T=814060 1042160 0 180 $X=811580 $Y=1036740
X3203 3970 3900 1 2 INV2CK $T=820260 941360 0 0 $X=820260 $Y=940980
X3204 507 3978 1 2 INV2CK $T=823360 880880 0 180 $X=820880 $Y=875460
X3205 3989 3921 1 2 INV2CK $T=825220 931280 0 0 $X=825220 $Y=930900
X3206 3996 3912 1 2 INV2CK $T=827080 1032080 0 0 $X=827080 $Y=1031700
X3207 4037 3907 1 2 INV2CK $T=839480 951440 0 180 $X=837000 $Y=946020
X3208 3987 3947 1 2 INV2CK $T=837000 1001840 0 0 $X=837000 $Y=1001460
X3209 4005 3944 1 2 INV2CK $T=837000 1011920 0 0 $X=837000 $Y=1011540
X3210 4043 4087 1 2 INV2CK $T=853740 1001840 0 180 $X=851260 $Y=996420
X3211 4083 4086 1 2 INV2CK $T=851880 981680 0 0 $X=851880 $Y=981300
X3212 4048 4098 1 2 INV2CK $T=859940 971600 0 180 $X=857460 $Y=966180
X3213 4132 4121 1 2 INV2CK $T=863660 1042160 0 0 $X=863660 $Y=1041780
X3214 4152 4158 1 2 INV2CK $T=872340 981680 0 180 $X=869860 $Y=976260
X3215 4174 4171 1 2 INV2CK $T=876060 971600 0 180 $X=873580 $Y=966180
X3216 4240 4239 1 2 INV2CK $T=893420 981680 0 0 $X=893420 $Y=981300
X3217 4297 4249 1 2 INV2CK $T=909540 1001840 0 180 $X=907060 $Y=996420
X3218 4420 4416 1 2 INV2CK $T=943640 971600 0 180 $X=941160 $Y=966180
X3219 4500 4478 1 2 INV2CK $T=969060 901040 0 180 $X=966580 $Y=895620
X3220 4444 4539 1 2 INV2CK $T=977740 951440 0 180 $X=975260 $Y=946020
X3221 4510 4543 1 2 INV2CK $T=978980 981680 0 180 $X=976500 $Y=976260
X3222 4564 4561 1 2 INV2CK $T=986420 890960 0 180 $X=983940 $Y=885540
X3223 4538 4532 1 2 INV2CK $T=987660 931280 0 180 $X=985180 $Y=925860
X3224 4462 4566 1 2 INV2CK $T=987660 961520 0 180 $X=985180 $Y=956100
X3225 4546 4589 1 2 INV2CK $T=990760 981680 0 0 $X=990760 $Y=981300
X3226 4604 4638 1 2 INV2CK $T=1006260 981680 0 180 $X=1003780 $Y=976260
X3227 4647 4645 1 2 INV2CK $T=1008740 931280 0 180 $X=1006260 $Y=925860
X3228 4587 4659 1 2 INV2CK $T=1013700 1011920 0 180 $X=1011220 $Y=1006500
X3229 4595 4656 1 2 INV2CK $T=1014320 981680 0 0 $X=1014320 $Y=981300
X3230 4652 645 1 2 INV2CK $T=1031060 890960 0 180 $X=1028580 $Y=885540
X3231 117 130 1 2 1752 QDBHN $T=370140 951440 0 180 $X=362700 $Y=946020
X3232 117 2936 1 2 2919 QDBHN $T=582800 931280 0 0 $X=582800 $Y=930900
X3233 117 2936 1 2 2934 QDBHN $T=592720 971600 0 180 $X=585280 $Y=966180
X3234 286 2949 1 2 2947 QDBHN $T=595200 1022000 1 180 $X=587760 $Y=1021620
X3235 3893 3913 1 2 3930 QDBHN $T=797320 1001840 1 0 $X=797320 $Y=996420
X3236 3893 3927 1 2 3895 QDBHN $T=807240 1042160 0 180 $X=799800 $Y=1036740
X3237 3893 3953 1 2 3920 QDBHN $T=814060 961520 0 180 $X=806620 $Y=956100
X3238 3893 3960 1 2 3929 QDBHN $T=816540 1032080 0 180 $X=809100 $Y=1026660
X3239 3893 3967 1 2 3933 QDBHN $T=819020 981680 0 180 $X=811580 $Y=976260
X3240 3893 4003 1 2 3974 QDBHN $T=832040 961520 0 180 $X=824600 $Y=956100
X3241 3893 3962 1 2 4006 QDBHN $T=826460 1022000 0 0 $X=826460 $Y=1021620
X3242 3893 3972 1 2 4044 QDBHN $T=833900 1042160 0 0 $X=833900 $Y=1041780
X3243 3893 3960 1 2 3999 QDBHN $T=841960 961520 0 180 $X=834520 $Y=956100
X3244 3893 3991 1 2 4015 QDBHN $T=851880 961520 0 180 $X=844440 $Y=956100
X3245 3893 3991 1 2 4063 QDBHN $T=853120 971600 0 180 $X=845680 $Y=966180
X3246 3893 4003 1 2 4076 QDBHN $T=856840 951440 0 180 $X=849400 $Y=946020
X3247 531 3953 1 2 4115 QDBHN $T=853740 921200 0 0 $X=853740 $Y=920820
X3248 3893 3967 1 2 4136 QDBHN $T=882880 941360 0 180 $X=875440 $Y=935940
X3249 3893 3972 1 2 4151 QDBHN $T=876060 1032080 0 0 $X=876060 $Y=1031700
X3250 3893 3913 1 2 4194 QDBHN $T=887220 971600 0 180 $X=879780 $Y=966180
X3251 3893 3962 1 2 4225 QDBHN $T=882260 981680 1 0 $X=882260 $Y=976260
X3252 3893 3927 1 2 4308 QDBHN $T=920700 991760 0 180 $X=913260 $Y=986340
X3253 4388 4400 1 2 4433 QDBHN $T=937440 981680 0 0 $X=937440 $Y=981300
X3254 4388 4419 1 2 4394 QDBHN $T=946120 961520 0 180 $X=938680 $Y=956100
X3255 4388 4456 1 2 4440 QDBHN $T=957280 951440 0 180 $X=949840 $Y=946020
X3256 4388 4460 1 2 4431 QDBHN $T=952320 921200 0 0 $X=952320 $Y=920820
X3257 4388 4485 1 2 4480 QDBHN $T=966580 941360 0 180 $X=959140 $Y=935940
X3258 4388 4493 1 2 4441 QDBHN $T=968440 971600 0 180 $X=961000 $Y=966180
X3259 4388 4400 1 2 4494 QDBHN $T=973400 1001840 0 180 $X=965960 $Y=996420
X3260 4388 4456 1 2 4495 QDBHN $T=978360 971600 0 180 $X=970920 $Y=966180
X3261 4388 4460 1 2 4524 QDBHN $T=982700 991760 0 180 $X=975260 $Y=986340
X3262 4388 4571 1 2 4553 QDBHN $T=990140 921200 0 180 $X=982700 $Y=915780
X3263 4388 4485 1 2 4573 QDBHN $T=994480 1022000 0 180 $X=987040 $Y=1016580
X3264 4388 4419 1 2 4565 QDBHN $T=998820 901040 0 180 $X=991380 $Y=895620
X3265 4388 4579 1 2 4591 QDBHN $T=1000060 890960 0 180 $X=992620 $Y=885540
X3266 4388 4493 1 2 4599 QDBHN $T=1000060 991760 0 0 $X=1000060 $Y=991380
X3267 4388 4571 1 2 4596 QDBHN $T=1000060 1011920 0 0 $X=1000060 $Y=1011540
X3268 4388 4579 1 2 4622 QDBHN $T=1009360 921200 0 180 $X=1001920 $Y=915780
X3269 4388 640 1 2 4660 QDBHN $T=1024240 890960 0 180 $X=1016800 $Y=885540
X3270 1752 1 2 1743 DELC $T=364560 941360 1 0 $X=364560 $Y=935940
X3271 234 1 2 232 DELC $T=516460 870800 0 0 $X=516460 $Y=870420
X3272 2865 1 2 2879 DELC $T=561100 1001840 0 0 $X=561100 $Y=1001460
X3273 2919 1 2 2906 DELC $T=580320 941360 0 0 $X=580320 $Y=940980
X3274 2934 1 2 2925 DELC $T=592720 971600 1 0 $X=592720 $Y=966180
X3275 2968 1 2 3028 DELC $T=602020 1011920 1 0 $X=602020 $Y=1006500
X3276 2915 1 2 309 DELC $T=610700 911120 1 0 $X=610700 $Y=905700
X3277 3059 1 2 2965 DELC $T=618760 1022000 1 0 $X=618760 $Y=1016580
X3278 3257 1 2 3635 DELC $T=719820 951440 0 0 $X=719820 $Y=951060
X3279 406 1 2 3512 DELC $T=736560 901040 0 0 $X=736560 $Y=900660
X3280 3895 1 2 3897 DELC $T=795460 1032080 0 0 $X=795460 $Y=1031700
X3281 3920 1 2 3932 DELC $T=801660 961520 1 0 $X=801660 $Y=956100
X3282 3929 1 2 3942 DELC $T=804760 1022000 0 0 $X=804760 $Y=1021620
X3283 3933 1 2 3954 DELC $T=806620 981680 1 0 $X=806620 $Y=976260
X3284 3930 1 2 3946 DELC $T=815920 991760 0 0 $X=815920 $Y=991380
X3285 3974 1 2 3986 DELC $T=819640 971600 1 0 $X=819640 $Y=966180
X3286 510 1 2 515 DELC $T=824600 880880 1 0 $X=824600 $Y=875460
X3287 3999 1 2 4011 DELC $T=827700 981680 1 0 $X=827700 $Y=976260
X3288 4006 1 2 3992 DELC $T=828940 991760 0 0 $X=828940 $Y=991380
X3289 4015 1 2 4031 DELC $T=832660 981680 1 0 $X=832660 $Y=976260
X3290 4044 1 2 4001 DELC $T=841340 1042160 0 0 $X=841340 $Y=1041780
X3291 4063 1 2 4071 DELC $T=846920 981680 0 0 $X=846920 $Y=981300
X3292 533 1 2 4073 DELC $T=852500 870800 0 0 $X=852500 $Y=870420
X3293 4115 1 2 4068 DELC $T=859940 931280 0 0 $X=859940 $Y=930900
X3294 4076 1 2 4114 DELC $T=863660 971600 1 0 $X=863660 $Y=966180
X3295 4136 1 2 4146 DELC $T=864900 951440 1 0 $X=864900 $Y=946020
X3296 4151 1 2 4142 DELC $T=869860 1032080 1 0 $X=869860 $Y=1026660
X3297 4194 1 2 4177 DELC $T=887220 971600 1 0 $X=887220 $Y=966180
X3298 4225 1 2 4246 DELC $T=889080 971600 0 0 $X=889080 $Y=971220
X3299 4308 1 2 4314 DELC $T=911400 1001840 1 0 $X=911400 $Y=996420
X3300 4431 1 2 4450 DELC $T=947360 921200 0 0 $X=947360 $Y=920820
X3301 4441 1 2 4457 DELC $T=949840 971600 1 0 $X=949840 $Y=966180
X3302 4433 1 2 4436 DELC $T=952940 981680 0 0 $X=952940 $Y=981300
X3303 4394 1 2 4458 DELC $T=965960 961520 1 0 $X=965960 $Y=956100
X3304 4495 1 2 4484 DELC $T=966580 981680 1 0 $X=966580 $Y=976260
X3305 4440 1 2 4437 DELC $T=967200 951440 1 0 $X=967200 $Y=946020
X3306 4524 1 2 4519 DELC $T=971540 981680 1 0 $X=971540 $Y=976260
X3307 4480 1 2 4461 DELC $T=977740 941360 1 0 $X=977740 $Y=935940
X3308 4494 1 2 4541 DELC $T=983940 1001840 1 0 $X=983940 $Y=996420
X3309 4565 1 2 4558 DELC $T=986420 901040 1 0 $X=986420 $Y=895620
X3310 4573 1 2 4569 DELC $T=991380 1011920 1 0 $X=991380 $Y=1006500
X3311 4553 1 2 4551 DELC $T=993240 921200 1 0 $X=993240 $Y=915780
X3312 4591 1 2 4610 DELC $T=993860 911120 1 0 $X=993860 $Y=905700
X3313 4596 1 2 4593 DELC $T=993860 1011920 0 0 $X=993860 $Y=1011540
X3314 4599 1 2 4612 DELC $T=995100 981680 0 0 $X=995100 $Y=981300
X3315 4622 1 2 4637 DELC $T=1001300 931280 1 0 $X=1001300 $Y=925860
X3316 4660 1 2 4661 DELC $T=1012460 880880 1 0 $X=1012460 $Y=875460
X3317 2911 1 2 2916 INV3CK $T=580320 961520 0 180 $X=577220 $Y=956100
X3318 3025 1 2 3016 INV3CK $T=602020 1032080 0 180 $X=598920 $Y=1026660
X3319 3900 1 2 3656 INV3CK $T=797320 961520 0 180 $X=794220 $Y=956100
X3320 4373 1 2 4348 INV3CK $T=928140 981680 0 180 $X=925040 $Y=976260
X3321 4350 1 2 4352 INV3CK $T=926280 951440 0 0 $X=926280 $Y=951060
X3322 4398 1 2 4405 INV3CK $T=939920 921200 0 0 $X=939920 $Y=920820
X3323 4633 1 2 4658 INV3CK $T=1010600 901040 0 0 $X=1010600 $Y=900660
X3324 1223 1226 1275 1 2 AN2T $T=282720 901040 1 0 $X=282720 $Y=895620
X3325 1429 1420 1466 1 2 AN2T $T=308140 901040 1 0 $X=308140 $Y=895620
X3326 1475 1473 1531 1 2 AN2T $T=314960 911120 0 0 $X=314960 $Y=910740
X3327 1743 117 1731 1 2 AN2T $T=360840 941360 0 180 $X=356500 $Y=935940
X3328 1817 1773 1797 1 2 AN2T $T=379440 991760 0 0 $X=379440 $Y=991380
X3329 1942 1926 1836 1 2 AN2T $T=399900 941360 0 180 $X=395560 $Y=935940
X3330 1928 1915 1940 1 2 AN2T $T=398040 1011920 0 0 $X=398040 $Y=1011540
X3331 1976 1939 1858 1 2 AN2T $T=406720 941360 0 180 $X=402380 $Y=935940
X3332 2906 117 2918 1 2 AN2T $T=575980 941360 0 0 $X=575980 $Y=940980
X3333 2925 117 2911 1 2 AN2T $T=581560 971600 0 180 $X=577220 $Y=966180
X3334 3946 3893 3857 1 2 AN2T $T=809720 991760 0 0 $X=809720 $Y=991380
X3335 3986 3893 3989 1 2 AN2T $T=824600 971600 1 0 $X=824600 $Y=966180
X3336 4011 3893 4043 1 2 AN2T $T=843820 981680 0 180 $X=839480 $Y=976260
X3337 4071 3893 4037 1 2 AN2T $T=847540 991760 0 180 $X=843200 $Y=986340
X3338 4068 531 4081 1 2 AN2T $T=846920 931280 0 0 $X=846920 $Y=930900
X3339 4073 531 4033 1 2 AN2T $T=848160 870800 0 0 $X=848160 $Y=870420
X3340 4436 4388 4420 1 2 AN2T $T=948600 981680 0 0 $X=948600 $Y=981300
X3341 4458 4388 4444 1 2 AN2T $T=954180 961520 0 180 $X=949840 $Y=956100
X3342 4484 4388 4373 1 2 AN2T $T=962860 981680 0 180 $X=958520 $Y=976260
X3343 4450 4388 4500 1 2 AN2T $T=963480 921200 0 0 $X=963480 $Y=920820
X3344 4558 4388 4564 1 2 AN2T $T=984560 911120 1 0 $X=984560 $Y=905700
X3345 4569 4388 4587 1 2 AN2T $T=987040 1011920 1 0 $X=987040 $Y=1006500
X3346 4593 4388 4604 1 2 AN2T $T=993240 1001840 0 0 $X=993240 $Y=1001460
X3347 4033 4013 1 2 INV8CK $T=838240 880880 0 180 $X=831420 $Y=875460
X3348 4081 4139 1 2 INV8CK $T=864900 931280 0 0 $X=864900 $Y=930900
X3349 4230 3893 1 2 INV8CK $T=892800 961520 0 180 $X=885980 $Y=956100
X3350 4230 4388 1 2 INV8CK $T=977740 941360 0 180 $X=970920 $Y=935940
X3351 1035 1011 1055 1060 937 1021 1 2 1086 AO222 $T=254200 971600 1 0 $X=254200 $Y=966180
X3352 33 1069 1064 1071 1039 1017 1 2 806 AO222 $T=261640 1011920 1 180 $X=255440 $Y=1011540
X3353 1205 1002 1115 1079 1141 958 1 2 1131 AO222 $T=271560 911120 0 180 $X=265360 $Y=905700
X3354 1143 1129 1156 1149 1056 940 1 2 1071 AO222 $T=271560 941360 0 180 $X=265360 $Y=935940
X3355 1143 1294 17 1303 1149 1315 1 2 1311 AO222 $T=287060 921200 0 0 $X=287060 $Y=920820
X3356 1421 942 855 1472 1409 1232 1 2 1493 AO222 $T=309380 961520 0 0 $X=309380 $Y=961140
X3357 3777 440 438 3755 3734 434 1 2 3754 AO222 $T=758260 931280 0 180 $X=752060 $Y=925860
X3358 3798 440 438 3793 3791 434 1 2 3790 AO222 $T=766320 931280 0 180 $X=760120 $Y=925860
X3359 3834 440 438 3816 3810 434 1 2 3808 AO222 $T=774380 931280 0 180 $X=768180 $Y=925860
X3360 3872 440 438 3883 3876 434 1 2 3858 AO222 $T=795460 931280 0 180 $X=789260 $Y=925860
X3361 3880 440 438 3898 3887 434 1 2 3896 AO222 $T=794220 890960 1 0 $X=794220 $Y=885540
X3362 3871 440 438 3899 3905 434 1 2 3902 AO222 $T=794220 921200 0 0 $X=794220 $Y=920820
X3363 3925 440 438 3957 3950 434 1 2 3976 AO222 $T=809720 931280 0 0 $X=809720 $Y=930900
X3364 4007 440 438 3998 4019 434 1 2 4025 AO222 $T=830180 931280 1 0 $X=830180 $Y=925860
X3365 4026 440 438 4056 4016 434 1 2 4065 AO222 $T=841340 880880 1 0 $X=841340 $Y=875460
X3366 4057 440 438 4050 4045 434 1 2 4075 AO222 $T=843820 911120 0 0 $X=843820 $Y=910740
X3367 4066 440 438 4029 4069 434 1 2 530 AO222 $T=853740 890960 1 180 $X=847540 $Y=890580
X3368 4080 440 438 4085 4092 434 1 2 4106 AO222 $T=850640 931280 1 0 $X=850640 $Y=925860
X3369 4145 440 438 4141 4162 434 1 2 4143 AO222 $T=869240 911120 0 0 $X=869240 $Y=910740
X3370 4188 440 438 4173 4155 434 1 2 4154 AO222 $T=878540 931280 0 180 $X=872340 $Y=925860
X3371 4200 440 438 4205 4199 434 1 2 4197 AO222 $T=881020 931280 1 0 $X=881020 $Y=925860
X3372 4226 440 438 4233 4238 434 1 2 4250 AO222 $T=889080 931280 1 0 $X=889080 $Y=925860
X3373 4256 440 438 4261 4266 434 1 2 4285 AO222 $T=897760 931280 1 0 $X=897760 $Y=925860
X3374 4284 440 438 4271 4264 434 1 2 4258 AO222 $T=905200 921200 0 180 $X=899000 $Y=915780
X3375 4309 440 438 4292 4263 434 1 2 4236 AO222 $T=909540 890960 0 180 $X=903340 $Y=885540
X3376 4306 440 438 4279 559 434 1 2 558 AO222 $T=910780 870800 1 180 $X=904580 $Y=870420
X3377 4296 440 438 4298 4286 434 1 2 4241 AO222 $T=910780 911120 0 180 $X=904580 $Y=905700
X3378 3028 3016 3007 1 2 AN2P $T=602640 1022000 0 180 $X=598920 $Y=1016580
X3379 4034 4027 428 1 2 AN2P $T=838240 961520 1 180 $X=834520 $Y=961140
X3380 4035 4028 381 1 2 AN2P $T=838240 1001840 0 180 $X=834520 $Y=996420
X3381 4035 522 3562 1 2 AN2P $T=841340 991760 1 180 $X=837620 $Y=991380
X3382 4034 4035 432 1 2 AN2P $T=843200 951440 0 0 $X=843200 $Y=951060
X3383 4054 4028 371 1 2 AN2P $T=843820 991760 0 0 $X=843820 $Y=991380
X3384 4039 4055 437 1 2 AN2P $T=845680 951440 1 0 $X=845680 $Y=946020
X3385 4054 522 3527 1 2 AN2P $T=851260 991760 1 0 $X=851260 $Y=986340
X3386 4034 4054 427 1 2 AN2P $T=851880 961520 1 0 $X=851880 $Y=956100
X3387 742 885 892 2 1 ND2S $T=236840 941360 0 0 $X=236840 $Y=940980
X3388 953 954 772 2 1 ND2S $T=243660 961520 0 180 $X=241800 $Y=956100
X3389 1016 985 4 2 1 ND2S $T=251100 971600 0 180 $X=249240 $Y=966180
X3390 831 1006 708 2 1 ND2S $T=252340 991760 1 180 $X=250480 $Y=991380
X3391 787 1102 817 2 1 ND2S $T=264120 1001840 0 0 $X=264120 $Y=1001460
X3392 4 1161 825 2 1 ND2S $T=274040 951440 0 0 $X=274040 $Y=951060
X3393 1410 1465 66 2 1 ND2S $T=313100 880880 1 0 $X=313100 $Y=875460
X3394 1528 951 1525 2 1 ND2S $T=318680 951440 0 0 $X=318680 $Y=951060
X3395 1542 4 1525 2 1 ND2S $T=318680 961520 1 0 $X=318680 $Y=956100
X3396 1542 878 1536 2 1 ND2S $T=320540 961520 1 0 $X=320540 $Y=956100
X3397 1535 817 1525 2 1 ND2S $T=321780 941360 1 0 $X=321780 $Y=935940
X3398 1542 779 1582 2 1 ND2S $T=331080 961520 1 0 $X=331080 $Y=956100
X3399 107 1549 1536 2 1 ND2S $T=345960 961520 1 180 $X=344100 $Y=961140
X3400 1536 1601 1654 2 1 ND2S $T=344100 971600 1 0 $X=344100 $Y=966180
X3401 1592 1606 1654 2 1 ND2S $T=344100 981680 1 0 $X=344100 $Y=976260
X3402 1592 1559 107 2 1 ND2S $T=345960 971600 0 0 $X=345960 $Y=971220
X3403 1704 946 1590 2 1 ND2S $T=352780 981680 0 0 $X=352780 $Y=981300
X3404 113 1725 1719 2 1 ND2S $T=354640 870800 0 0 $X=354640 $Y=870420
X3405 1733 1744 1643 2 1 ND2S $T=358360 901040 1 0 $X=358360 $Y=895620
X3406 113 1748 1702 2 1 ND2S $T=360840 870800 0 0 $X=360840 $Y=870420
X3407 123 1751 1764 2 1 ND2S $T=364560 870800 0 0 $X=364560 $Y=870420
X3408 1885 1889 1766 2 1 ND2S $T=394320 981680 1 0 $X=394320 $Y=976260
X3409 1981 1989 1840 2 1 ND2S $T=406720 941360 1 0 $X=406720 $Y=935940
X3410 2060 2067 1833 2 1 ND2S $T=419740 941360 1 0 $X=419740 $Y=935940
X3411 1981 2071 150 2 1 ND2S $T=423460 941360 1 0 $X=423460 $Y=935940
X3412 2117 2165 2111 2 1 ND2S $T=436480 911120 0 180 $X=434620 $Y=905700
X3413 2206 2213 1643 2 1 ND2S $T=443920 1022000 1 0 $X=443920 $Y=1016580
X3414 2119 2262 2267 2 1 ND2S $T=453220 1011920 1 0 $X=453220 $Y=1006500
X3415 2235 2427 2384 2 1 ND2S $T=478640 880880 0 180 $X=476780 $Y=875460
X3416 2448 2417 2468 2 1 ND2S $T=485460 951440 1 0 $X=485460 $Y=946020
X3417 2273 2538 2412 2 1 ND2S $T=494140 880880 1 0 $X=494140 $Y=875460
X3418 2568 2528 2563 2 1 ND2S $T=502200 901040 1 0 $X=502200 $Y=895620
X3419 3126 3236 3132 2 1 ND2S $T=631780 1042160 1 0 $X=631780 $Y=1036740
X3420 508 3959 509 2 1 ND2S $T=822740 901040 1 0 $X=822740 $Y=895620
X3421 3984 3964 508 2 1 ND2S $T=823980 901040 0 0 $X=823980 $Y=900660
X3422 3982 3979 509 2 1 ND2S $T=824600 901040 1 0 $X=824600 $Y=895620
X3423 483 2 1 3981 BUF3 $T=820880 961520 1 0 $X=820880 $Y=956100
X3424 715 1 722 739 746 747 2 OAI22S $T=221340 921200 1 0 $X=221340 $Y=915780
X3425 841 1 990 789 969 967 2 OAI22S $T=249240 981680 1 180 $X=245520 $Y=981300
X3426 706 1 944 860 1097 1101 2 OAI22S $T=258540 1011920 1 0 $X=258540 $Y=1006500
X3427 1138 1 1134 733 1124 1078 2 OAI22S $T=267840 911120 1 180 $X=264120 $Y=910740
X3428 706 1 1096 1158 1169 729 2 OAI22S $T=268460 971600 1 0 $X=268460 $Y=966180
X3429 1109 1 733 715 1195 1212 2 OAI22S $T=272180 911120 0 0 $X=272180 $Y=910740
X3430 783 1 735 1427 1426 961 2 OAI22S $T=308140 931280 0 180 $X=304420 $Y=925860
X3431 1427 1 1135 1437 1408 1430 2 OAI22S $T=305040 951440 1 0 $X=305040 $Y=946020
X3432 817 1 1449 1333 1442 1433 2 OAI22S $T=310000 941360 0 180 $X=306280 $Y=935940
X3433 732 1 953 1490 1469 1411 2 OAI22S $T=318060 951440 1 180 $X=314340 $Y=951060
X3434 1416 1 729 1498 1579 15 2 OAI22S $T=326740 971600 0 0 $X=326740 $Y=971220
X3435 1713 1 1609 78 1750 100 2 OAI22S $T=359600 941360 0 0 $X=359600 $Y=940980
X3436 3047 1 3053 3041 3059 3065 2 OAI22S $T=605740 1011920 0 0 $X=605740 $Y=1011540
X3437 415 1 418 3692 3717 421 2 OAI22S $T=740280 880880 0 0 $X=740280 $Y=880500
X3438 423 1 415 422 3720 3692 2 OAI22S $T=746480 890960 0 180 $X=742760 $Y=885540
X3439 426 1 418 3679 3725 421 2 OAI22S $T=748960 880880 1 180 $X=745240 $Y=880500
X3440 423 1 425 422 3735 3742 2 OAI22S $T=745860 880880 1 0 $X=745860 $Y=875460
X3441 3740 1 418 3688 3753 421 2 OAI22S $T=748960 880880 0 0 $X=748960 $Y=880500
X3442 423 1 426 422 3748 3679 2 OAI22S $T=753300 890960 0 180 $X=749580 $Y=885540
X3443 425 1 418 3723 3764 421 2 OAI22S $T=751440 870800 0 0 $X=751440 $Y=870420
X3444 423 1 436 422 3774 3714 2 OAI22S $T=753300 880880 0 0 $X=753300 $Y=880500
X3445 423 1 3740 422 3771 3688 2 OAI22S $T=758260 890960 0 180 $X=754540 $Y=885540
X3446 423 1 442 422 3781 3709 2 OAI22S $T=755780 880880 1 0 $X=755780 $Y=875460
X3447 436 1 418 3714 3787 421 2 OAI22S $T=757640 880880 0 0 $X=757640 $Y=880500
X3448 442 1 418 3709 3792 421 2 OAI22S $T=760120 880880 1 0 $X=760120 $Y=875460
X3449 446 1 418 448 449 421 2 OAI22S $T=761360 870800 0 0 $X=761360 $Y=870420
X3450 452 1 418 3693 3794 421 2 OAI22S $T=766320 880880 1 180 $X=762600 $Y=880500
X3451 423 1 452 422 3795 3693 2 OAI22S $T=766940 890960 0 180 $X=763220 $Y=885540
X3452 451 1 418 3713 3805 421 2 OAI22S $T=764460 880880 1 0 $X=764460 $Y=875460
X3453 423 1 451 422 453 3713 2 OAI22S $T=770040 870800 1 180 $X=766320 $Y=870420
X3454 423 1 454 422 3809 3700 2 OAI22S $T=767560 880880 0 0 $X=767560 $Y=880500
X3455 423 1 455 422 3818 3695 2 OAI22S $T=768180 890960 1 0 $X=768180 $Y=885540
X3456 454 1 418 3700 3831 421 2 OAI22S $T=771900 880880 0 0 $X=771900 $Y=880500
X3457 455 1 418 3695 3846 421 2 OAI22S $T=776240 880880 0 0 $X=776240 $Y=880500
X3458 237 1 2 240 DELB $T=523900 880880 0 0 $X=523900 $Y=880500
X3459 2836 1 2 254 DELB $T=555520 880880 0 0 $X=555520 $Y=880500
X3460 252 1 2 2862 DELB $T=555520 1042160 1 0 $X=555520 $Y=1036740
X3461 2848 1 2 2864 DELB $T=556760 901040 1 0 $X=556760 $Y=895620
X3462 2860 1 2 256 DELB $T=559240 890960 0 0 $X=559240 $Y=890580
X3463 2870 1 2 2885 DELB $T=563580 1032080 1 0 $X=563580 $Y=1026660
X3464 2876 1 2 2872 DELB $T=564820 921200 0 0 $X=564820 $Y=920820
X3465 2869 1 2 257 DELB $T=567300 870800 0 0 $X=567300 $Y=870420
X3466 2858 1 2 2847 DELB $T=567920 901040 0 0 $X=567920 $Y=900660
X3467 2888 1 2 2883 DELB $T=568540 890960 1 0 $X=568540 $Y=885540
X3468 2867 1 2 2856 DELB $T=569780 921200 0 0 $X=569780 $Y=920820
X3469 2881 1 2 2895 DELB $T=572260 880880 0 0 $X=572260 $Y=880500
X3470 2902 1 2 2912 DELB $T=574120 1032080 1 0 $X=574120 $Y=1026660
X3471 2875 1 2 2889 DELB $T=574740 921200 0 0 $X=574740 $Y=920820
X3472 2908 1 2 2897 DELB $T=577220 1042160 1 0 $X=577220 $Y=1036740
X3473 2910 1 2 2892 DELB $T=577840 981680 0 0 $X=577840 $Y=981300
X3474 2931 1 2 2893 DELB $T=584660 981680 0 0 $X=584660 $Y=981300
X3475 3021 1 2 3045 DELB $T=601400 981680 0 0 $X=601400 $Y=981300
X3476 3032 1 2 3024 DELB $T=603260 1032080 1 0 $X=603260 $Y=1026660
X3477 3039 1 2 2949 DELB $T=603880 1001840 1 0 $X=603880 $Y=996420
X3478 3084 1 2 3010 DELB $T=611320 1001840 1 0 $X=611320 $Y=996420
X3479 3109 1 2 3022 DELB $T=614420 1011920 1 0 $X=614420 $Y=1006500
X3480 3087 1 2 2975 DELB $T=615660 991760 0 0 $X=615660 $Y=991380
X3481 2917 1 2 3250 DELB $T=634880 951440 1 0 $X=634880 $Y=946020
X3482 3255 1 2 3279 DELB $T=640460 981680 1 0 $X=640460 $Y=976260
X3483 3278 1 2 3301 DELB $T=644800 971600 0 0 $X=644800 $Y=971220
X3484 3293 1 2 3209 DELB $T=646660 1001840 0 0 $X=646660 $Y=1001460
X3485 3324 1 2 3416 DELB $T=668360 991760 0 0 $X=668360 $Y=991380
X3486 3523 1 2 3540 DELB $T=691300 901040 0 0 $X=691300 $Y=900660
X3487 376 1 2 3551 DELB $T=696880 890960 1 0 $X=696880 $Y=885540
X3488 3565 1 2 3580 DELB $T=701220 901040 1 0 $X=701220 $Y=895620
X3489 3592 1 2 3241 DELB $T=709900 890960 0 0 $X=709900 $Y=890580
X3490 3595 1 2 3611 DELB $T=710520 921200 0 0 $X=710520 $Y=920820
X3491 3594 1 2 3170 DELB $T=711760 880880 1 0 $X=711760 $Y=875460
X3492 3605 1 2 3237 DELB $T=713620 951440 1 0 $X=713620 $Y=946020
X3493 3615 1 2 3264 DELB $T=715480 921200 0 0 $X=715480 $Y=920820
X3494 3599 1 2 3199 DELB $T=716720 880880 1 0 $X=716720 $Y=875460
X3495 3604 1 2 3245 DELB $T=718580 921200 1 0 $X=718580 $Y=915780
X3496 3603 1 2 3624 DELB $T=720440 901040 1 0 $X=720440 $Y=895620
X3497 3621 1 2 3629 DELB $T=721680 880880 1 0 $X=721680 $Y=875460
X3498 3627 1 2 3644 DELB $T=726640 880880 1 0 $X=726640 $Y=875460
X3499 3645 1 2 3657 DELB $T=727880 931280 0 0 $X=727880 $Y=930900
X3500 3641 1 2 3646 DELB $T=731600 880880 1 0 $X=731600 $Y=875460
X3501 3642 1 2 3639 DELB $T=732840 931280 0 0 $X=732840 $Y=930900
X3502 417 1 2 424 DELB $T=741520 870800 0 0 $X=741520 $Y=870420
X3503 457 1 2 461 DELB $T=770660 870800 0 0 $X=770660 $Y=870420
X3504 3723 3742 1 2 BUF2CK $T=751440 880880 1 0 $X=751440 $Y=875460
X3505 170 1 2 1927 BUF1CK $T=398660 981680 1 0 $X=398660 $Y=976260
X3506 2947 1 2 2968 BUF1CK $T=590240 1022000 1 0 $X=590240 $Y=1016580
X3507 2978 1 2 288 BUF1CK $T=593960 901040 1 0 $X=593960 $Y=895620
X3508 3284 1 2 3294 BUF1CK $T=644800 1011920 0 0 $X=644800 $Y=1011540
X3509 372 1 2 3545 BUF1CK $T=693780 911120 0 0 $X=693780 $Y=910740
X3510 391 1 2 3588 BUF1CK $T=710520 931280 1 0 $X=710520 $Y=925860
X3511 400 1 2 3655 BUF1CK $T=725400 901040 1 0 $X=725400 $Y=895620
X3512 3658 1 2 3661 BUF1CK $T=727880 901040 1 0 $X=727880 $Y=895620
X3513 3659 1 2 3666 BUF1CK $T=729120 901040 0 0 $X=729120 $Y=900660
X3514 3670 1 2 3673 BUF1CK $T=733460 911120 0 0 $X=733460 $Y=910740
X3515 404 1 2 3672 BUF1CK $T=734700 890960 0 0 $X=734700 $Y=890580
X3516 3663 1 2 3694 BUF1CK $T=736560 890960 1 0 $X=736560 $Y=885540
X3517 3702 1 2 3678 BUF1CK $T=736560 911120 1 0 $X=736560 $Y=905700
X3518 3703 1 2 3675 BUF1CK $T=737800 931280 1 0 $X=737800 $Y=925860
X3519 3677 1 2 3706 BUF1CK $T=738420 880880 1 0 $X=738420 $Y=875460
X3520 3687 1 2 3686 BUF1CK $T=739040 911120 1 0 $X=739040 $Y=905700
X3521 3707 1 2 3683 BUF1CK $T=739040 941360 1 0 $X=739040 $Y=935940
X3522 1396 1451 2 1446 1160 1 OR3B2 $T=310620 1001840 0 180 $X=306900 $Y=996420
X3523 1176 1464 2 1519 1458 1 OR3B2 $T=308760 991760 0 0 $X=308760 $Y=991380
X3524 1340 799 2 1671 1698 1 OR3B2 $T=348440 1011920 0 0 $X=348440 $Y=1011540
X3525 3236 3105 2 3246 3162 1 OR3B2 $T=640460 1042160 1 180 $X=636740 $Y=1041780
X3526 3058 3493 2 349 3460 1 OR3B2 $T=683240 1001840 1 0 $X=683240 $Y=996420
X3527 3493 3460 2 355 3058 1 AOI12H $T=688200 991760 0 180 $X=682000 $Y=986340
X3528 703 894 1 1056 938 1064 2 OAI112HS $T=253580 991760 1 0 $X=253580 $Y=986340
X3529 749 1088 1 769 1057 1110 2 OAI112HS $T=259160 991760 0 0 $X=259160 $Y=991380
X3530 7 889 1 1146 1142 1157 2 OAI112HS $T=265360 1022000 0 0 $X=265360 $Y=1021620
X3531 1022 998 1 818 1176 1146 2 OAI112HS $T=268460 1011920 1 0 $X=268460 $Y=1006500
X3532 787 732 1 1170 832 1187 2 OAI112HS $T=269080 931280 1 0 $X=269080 $Y=925860
X3533 4 998 1 1194 1201 1218 2 OAI112HS $T=272180 1052240 1 0 $X=272180 $Y=1046820
X3534 872 1215 1 1110 1247 1263 2 OAI112HS $T=277140 991760 1 0 $X=277140 $Y=986340
X3535 1356 1298 1 1037 1328 769 2 OAI112HS $T=295740 1022000 1 180 $X=291400 $Y=1021620
X3536 739 55 1 1279 1354 1081 2 OAI112HS $T=298840 991760 0 180 $X=294500 $Y=986340
X3537 864 48 1 1380 64 1332 2 OAI112HS $T=295740 1052240 1 0 $X=295740 $Y=1046820
X3538 751 1594 1 1587 1529 1515 2 OAI112HS $T=332940 1022000 0 180 $X=328600 $Y=1016580
X3539 1712 94 1 1736 1701 1728 2 OAI112HS $T=356500 951440 0 0 $X=356500 $Y=951060
X3540 3104 3094 1 3080 3029 3053 2 OAI112HS $T=615040 1042160 0 180 $X=610700 $Y=1036740
X3541 3094 3099 1 3105 3035 3126 2 OAI112HS $T=612560 1032080 0 0 $X=612560 $Y=1031700
X3542 3104 3094 1 3132 2960 3125 2 OAI112HS $T=622480 1042160 0 180 $X=618140 $Y=1036740
X3543 3094 3088 1 3156 2972 3125 2 OAI112HS $T=621240 1032080 0 0 $X=621240 $Y=1031700
X3544 3424 349 1 3403 3379 3317 2 OAI112HS $T=669600 1022000 0 180 $X=665260 $Y=1016580
X3545 349 3419 1 3408 3389 3296 2 OAI112HS $T=670220 981680 1 180 $X=665880 $Y=981300
X3546 3426 349 1 3410 3405 3344 2 OAI112HS $T=670220 1001840 0 180 $X=665880 $Y=996420
X3547 3427 349 1 3411 3404 3337 2 OAI112HS $T=670220 1022000 1 180 $X=665880 $Y=1021620
X3548 3449 349 1 3420 3393 3313 2 OAI112HS $T=671460 1011920 1 180 $X=667120 $Y=1011540
X3549 349 3446 1 3423 3409 3416 2 OAI112HS $T=672080 991760 0 180 $X=667740 $Y=986340
X3550 3455 349 1 3447 3443 3370 2 OAI112HS $T=676420 1022000 1 180 $X=672080 $Y=1021620
X3551 3453 3469 1 3433 3493 3446 2 OAI112HS $T=678280 991760 0 0 $X=678280 $Y=991380
X3552 3484 349 1 3474 3470 3377 2 OAI112HS $T=683240 1022000 1 180 $X=678900 $Y=1021620
X3553 699 720 724 737 743 704 2 1 770 OA222S $T=220720 1011920 1 0 $X=220720 $Y=1006500
X3554 888 724 872 800 718 742 2 1 835 OA222S $T=236840 1001840 1 180 $X=231260 $Y=1001460
X3555 15 987 720 778 789 708 2 1 939 OA222S $T=248620 1001840 1 180 $X=243040 $Y=1001460
X3556 733 1078 861 950 902 1015 2 1 1108 OA222S $T=257920 911120 0 0 $X=257920 $Y=910740
X3557 7 988 718 863 715 55 2 1 1334 OA222S $T=287680 981680 0 0 $X=287680 $Y=981300
X3558 888 834 1004 841 7 977 2 1 1324 OA222S $T=287680 991760 1 0 $X=287680 $Y=986340
X3559 7 1435 724 1014 1427 55 2 1 1458 OA222S $T=306280 981680 0 0 $X=306280 $Y=981300
X3560 1437 1423 1524 1114 902 881 2 1 1548 OA222S $T=318060 971600 1 0 $X=318060 $Y=966180
X3561 1658 1649 1623 1565 1559 822 2 1 1625 OA222S $T=343480 991760 0 180 $X=337900 $Y=986340
X3562 3098 3083 3077 3073 3069 3064 2 1 3046 OA222S $T=613180 951440 1 180 $X=607600 $Y=951060
X3563 3117 3083 3091 3073 3095 3064 2 1 3068 OA222S $T=616900 911120 1 180 $X=611320 $Y=910740
X3564 3082 3083 3069 3073 3102 3064 2 1 3119 OA222S $T=611320 951440 1 0 $X=611320 $Y=946020
X3565 3091 3083 3102 3073 3098 3064 2 1 3130 OA222S $T=612560 941360 0 0 $X=612560 $Y=940980
X3566 3095 3083 3098 3073 3082 3064 2 1 3079 OA222S $T=618760 931280 1 180 $X=613180 $Y=930900
X3567 3102 3083 3118 3073 3077 3064 2 1 3135 OA222S $T=614420 951440 0 0 $X=614420 $Y=951060
X3568 3123 3083 3082 3073 3091 3064 2 1 3107 OA222S $T=620620 921200 1 180 $X=615040 $Y=920820
X3569 3095 3133 3091 3127 3123 3105 2 1 3106 OA222S $T=621240 911120 0 180 $X=615660 $Y=905700
X3570 3091 3133 3082 3127 3095 3105 2 1 3116 OA222S $T=621860 901040 0 180 $X=616280 $Y=895620
X3571 3098 3147 3140 3141 3138 3134 2 1 3056 OA222S $T=623720 911120 1 180 $X=618140 $Y=910740
X3572 3095 3127 3140 3144 3138 3152 2 1 3157 OA222S $T=618760 880880 0 0 $X=618760 $Y=880500
X3573 3102 3147 3138 3141 3117 3134 2 1 3112 OA222S $T=624960 921200 0 180 $X=619380 $Y=915780
X3574 3077 3147 3123 3141 3095 3134 2 1 3129 OA222S $T=625580 931280 1 180 $X=620000 $Y=930900
X3575 3164 3147 3091 3141 3082 3134 2 1 3034 OA222S $T=625580 941360 1 180 $X=620000 $Y=940980
X3576 3167 3147 3082 3141 3098 3134 2 1 3142 OA222S $T=626200 951440 1 180 $X=620620 $Y=951060
X3577 3069 3147 3117 3141 3123 3134 2 1 3070 OA222S $T=626820 931280 0 180 $X=621240 $Y=925860
X3578 3118 3147 3095 3141 3091 3134 2 1 3121 OA222S $T=626820 941360 0 180 $X=621240 $Y=935940
X3579 3138 3178 3140 3169 3117 3152 2 1 3115 OA222S $T=629920 880880 1 180 $X=624340 $Y=880500
X3580 3117 3064 3140 3174 3123 3073 2 1 3188 OA222S $T=624960 911120 1 0 $X=624960 $Y=905700
X3581 3123 3064 3140 3173 3095 3073 2 1 3200 OA222S $T=624960 921200 1 0 $X=624960 $Y=915780
X3582 3208 3147 3141 3314 3134 3271 2 1 3299 OA222S $T=648520 971600 1 0 $X=648520 $Y=966180
X3583 3273 3147 3141 3333 3134 3314 2 1 3352 OA222S $T=649140 951440 0 0 $X=649140 $Y=951060
X3584 3329 3064 3341 3174 3351 3073 2 1 3362 OA222S $T=651000 911120 1 0 $X=651000 $Y=905700
X3585 3127 3343 3341 3144 3303 3152 2 1 3335 OA222S $T=657200 890960 1 180 $X=651620 $Y=890580
X3586 3303 3178 3341 3169 3152 3329 2 1 3359 OA222S $T=651620 901040 1 0 $X=651620 $Y=895620
X3587 3064 3351 3341 3173 3343 3073 2 1 3306 OA222S $T=657820 921200 0 180 $X=652240 $Y=915780
X3588 3287 3152 3141 3345 3134 3333 2 1 3374 OA222S $T=655340 951440 0 0 $X=655340 $Y=951060
X3589 3271 3152 3141 3303 3134 3329 2 1 3376 OA222S $T=657200 921200 0 0 $X=657200 $Y=920820
X3590 3083 3271 3276 3073 3307 3064 2 1 3354 OA222S $T=663400 971600 0 180 $X=657820 $Y=966180
X3591 3314 3152 3141 3341 3134 3303 2 1 3386 OA222S $T=658440 921200 1 0 $X=658440 $Y=915780
X3592 3083 3314 3307 3073 3291 3064 2 1 3395 OA222S $T=658440 961520 1 0 $X=658440 $Y=956100
X3593 3307 3152 3141 3351 3134 3343 2 1 3396 OA222S $T=659060 941360 0 0 $X=659060 $Y=940980
X3594 3276 3152 3141 3343 3134 3345 2 1 3391 OA222S $T=659060 951440 1 0 $X=659060 $Y=946020
X3595 3133 3343 3127 3345 3105 3351 2 1 3400 OA222S $T=660300 911120 0 0 $X=660300 $Y=910740
X3596 3291 3152 3141 3329 3134 3351 2 1 3413 OA222S $T=660300 931280 1 0 $X=660300 $Y=925860
X3597 3083 3333 3291 3073 3271 3064 2 1 3401 OA222S $T=662160 951440 0 0 $X=662160 $Y=951060
X3598 3083 3329 3345 3073 3343 3064 2 1 3415 OA222S $T=663400 921200 0 0 $X=663400 $Y=920820
X3599 3083 3351 3333 3073 3345 3064 2 1 3373 OA222S $T=668980 931280 1 180 $X=663400 $Y=930900
X3600 3133 3345 3333 3127 3105 3343 2 1 3390 OA222S $T=664020 911120 1 0 $X=664020 $Y=905700
X3601 3083 3345 3271 3073 3314 3064 2 1 3437 OA222S $T=664640 951440 1 0 $X=664640 $Y=946020
X3602 3083 3343 3314 3073 3333 3064 2 1 3429 OA222S $T=665260 941360 0 0 $X=665260 $Y=940980
X3603 855 847 1 7 807 802 2 MOAI1S $T=233740 1022000 1 180 $X=230020 $Y=1021620
X3604 10 865 1 729 843 836 2 MOAI1S $T=234980 1032080 1 180 $X=231260 $Y=1031700
X3605 947 14 1 737 706 842 2 MOAI1S $T=242420 1011920 1 180 $X=238700 $Y=1011540
X3606 942 895 1 730 870 897 2 MOAI1S $T=242420 1022000 0 180 $X=238700 $Y=1016580
X3607 984 5 1 970 834 963 2 MOAI1S $T=247380 1032080 0 180 $X=243660 $Y=1026660
X3608 942 1000 1 864 995 1045 2 MOAI1S $T=251100 1022000 1 0 $X=251100 $Y=1016580
X3609 1072 5 1 988 864 1005 2 MOAI1S $T=255440 1052240 1 180 $X=251720 $Y=1051860
X3610 1056 1036 1 1084 715 1095 2 MOAI1S $T=257920 951440 1 0 $X=257920 $Y=946020
X3611 788 1079 1 1083 804 1100 2 MOAI1S $T=258540 941360 0 0 $X=258540 $Y=940980
X3612 1090 33 1 973 724 1154 2 MOAI1S $T=265360 971600 0 0 $X=265360 $Y=971220
X3613 1089 30 1 41 1136 1026 2 MOAI1S $T=274040 1062320 0 180 $X=270320 $Y=1056900
X3614 952 1183 1 872 1203 1173 2 MOAI1S $T=272800 991760 1 0 $X=272800 $Y=986340
X3615 774 1055 1 966 834 1245 2 MOAI1S $T=277140 971600 1 0 $X=277140 $Y=966180
X3616 1232 1208 1 729 1257 1255 2 MOAI1S $T=279620 961520 0 0 $X=279620 $Y=961140
X3617 947 1040 1 834 863 1288 2 MOAI1S $T=283960 1011920 0 0 $X=283960 $Y=1011540
X3618 1089 943 1 729 1310 1320 2 MOAI1S $T=287060 1022000 0 0 $X=287060 $Y=1021620
X3619 947 1072 1 48 39 1335 2 MOAI1S $T=289540 1062320 1 0 $X=289540 $Y=1056900
X3620 1342 1412 1 21 763 1417 2 MOAI1S $T=307520 981680 0 180 $X=303800 $Y=976260
X3621 1330 1381 1 1431 1126 1447 2 MOAI1S $T=304420 1022000 1 0 $X=304420 $Y=1016580
X3622 1359 1246 1 1405 1321 1452 2 MOAI1S $T=305040 941360 0 0 $X=305040 $Y=940980
X3623 34 925 1 877 763 1453 2 MOAI1S $T=305660 1001840 0 0 $X=305660 $Y=1001460
X3624 14 1029 1 877 763 1455 2 MOAI1S $T=305660 1032080 1 0 $X=305660 $Y=1026660
X3625 1265 1412 1 729 1476 1481 2 MOAI1S $T=310000 951440 0 0 $X=310000 $Y=951060
X3626 1412 1509 1 48 46 75 2 MOAI1S $T=316820 1001840 0 0 $X=316820 $Y=1001460
X3627 47 1539 1 872 870 1563 2 MOAI1S $T=321780 1042160 1 0 $X=321780 $Y=1036740
X3628 47 1539 1 1317 998 1566 2 MOAI1S $T=322400 1032080 0 0 $X=322400 $Y=1031700
X3629 1362 1553 1 1540 1333 1586 2 MOAI1S $T=323640 951440 1 0 $X=323640 $Y=946020
X3630 1225 34 1 1435 864 1479 2 MOAI1S $T=327360 991760 1 180 $X=323640 $Y=991380
X3631 1225 14 1 751 799 1616 2 MOAI1S $T=332320 1011920 1 0 $X=332320 $Y=1006500
X3632 1636 1049 1 91 1650 1648 2 MOAI1S $T=338520 931280 0 0 $X=338520 $Y=930900
X3633 1330 1501 1 1649 860 1657 2 MOAI1S $T=339140 1001840 1 0 $X=339140 $Y=996420
X3634 1647 1080 1 1639 1435 1467 2 MOAI1S $T=340380 1042160 0 0 $X=340380 $Y=1041780
X3635 1210 1671 1 1435 7 1660 2 MOAI1S $T=347820 1011920 1 180 $X=344100 $Y=1011540
X3636 1513 97 1 107 1645 1695 2 MOAI1S $T=345960 931280 1 0 $X=345960 $Y=925860
X3637 1513 1582 1 1645 1658 1716 2 MOAI1S $T=349060 941360 0 0 $X=349060 $Y=940980
X3638 241 121 1 242 121 2677 2 MOAI1S $T=531340 1052240 0 0 $X=531340 $Y=1051860
X3639 3099 3004 1 3088 3022 3032 2 MOAI1S $T=616280 1032080 0 180 $X=612560 $Y=1026660
X3640 3004 3108 1 3093 3094 3084 2 MOAI1S $T=618760 1001840 1 180 $X=615040 $Y=1001460
X3641 3124 314 1 3127 3098 3146 2 MOAI1S $T=625580 901040 1 180 $X=621860 $Y=900660
X3642 3180 2909 1 3132 3100 3154 2 MOAI1S $T=628680 971600 0 180 $X=624960 $Y=966180
X3643 3180 3170 1 3133 3082 3160 2 MOAI1S $T=629300 901040 0 180 $X=625580 $Y=895620
X3644 3180 3179 1 3133 3098 3168 2 MOAI1S $T=629300 901040 1 180 $X=625580 $Y=900660
X3645 3180 3213 1 3133 3102 3214 2 MOAI1S $T=637360 921200 0 180 $X=633640 $Y=915780
X3646 3193 3225 1 3105 3223 3211 2 MOAI1S $T=637980 971600 1 180 $X=634260 $Y=971220
X3647 3180 3237 1 3132 3167 3215 2 MOAI1S $T=638600 951440 1 180 $X=634880 $Y=951060
X3648 3180 3238 1 3132 3223 3216 2 MOAI1S $T=638600 971600 0 180 $X=634880 $Y=966180
X3649 3131 3241 1 3177 3138 3195 2 MOAI1S $T=639220 911120 0 180 $X=635500 $Y=905700
X3650 3180 3241 1 3133 3069 3227 2 MOAI1S $T=639220 921200 1 180 $X=635500 $Y=920820
X3651 3180 3247 1 3235 3164 3222 2 MOAI1S $T=639840 941360 0 180 $X=636120 $Y=935940
X3652 3180 3245 1 3235 3077 3231 2 MOAI1S $T=641080 931280 0 180 $X=637360 $Y=925860
X3653 3180 3257 1 3132 3192 3243 2 MOAI1S $T=642320 961520 0 180 $X=638600 $Y=956100
X3654 3180 3264 1 3235 3118 3218 2 MOAI1S $T=644180 941360 0 180 $X=640460 $Y=935940
X3655 3180 3250 1 3132 3208 3277 2 MOAI1S $T=640460 971600 1 0 $X=640460 $Y=966180
X3656 3180 271 1 3271 3133 3290 2 MOAI1S $T=642320 921200 0 0 $X=642320 $Y=920820
X3657 323 3289 1 3127 3138 332 2 MOAI1S $T=647280 890960 0 180 $X=643560 $Y=885540
X3658 3180 276 1 3235 3276 3298 2 MOAI1S $T=644180 941360 0 0 $X=644180 $Y=940980
X3659 3180 262 1 3235 3273 3311 2 MOAI1S $T=645420 951440 1 0 $X=645420 $Y=946020
X3660 3131 338 1 3177 3303 3309 2 MOAI1S $T=646040 911120 0 0 $X=646040 $Y=910740
X3661 338 3180 1 3133 3291 3315 2 MOAI1S $T=646660 921200 0 0 $X=646660 $Y=920820
X3662 3180 277 1 3133 3307 3318 2 MOAI1S $T=646660 931280 0 0 $X=646660 $Y=930900
X3663 3180 336 1 3133 3287 3366 2 MOAI1S $T=646660 941360 1 0 $X=646660 $Y=935940
X3664 3180 331 1 3133 3314 3321 2 MOAI1S $T=647280 911120 1 0 $X=647280 $Y=905700
X3665 315 3180 1 3333 3133 3348 2 MOAI1S $T=650380 901040 0 0 $X=650380 $Y=900660
X3666 330 3124 1 3127 3314 3358 2 MOAI1S $T=661540 901040 1 180 $X=657820 $Y=900660
X3667 334 3289 1 3127 3303 348 2 MOAI1S $T=660300 890960 1 0 $X=660300 $Y=885540
X3668 760 749 1 729 700 2 710 711 706 OAI222S $T=226300 1001840 0 180 $X=220720 $Y=996420
X3669 830 804 1 709 715 2 773 765 733 OAI222S $T=230640 951440 0 180 $X=225060 $Y=946020
X3670 851 706 1 871 789 2 846 840 834 OAI222S $T=236840 981680 1 180 $X=231260 $Y=981300
X3671 899 718 1 876 864 2 729 821 808 OAI222S $T=238080 1011920 1 180 $X=232500 $Y=1011540
X3672 735 902 1 914 863 2 923 903 739 OAI222S $T=236840 921200 0 0 $X=236840 $Y=920820
X3673 857 834 1 799 15 2 932 879 889 OAI222S $T=237460 1032080 1 0 $X=237460 $Y=1026660
X3674 946 15 1 743 960 2 789 956 910 OAI222S $T=248000 991760 0 180 $X=242420 $Y=986340
X3675 981 825 1 995 872 2 824 945 1007 OAI222S $T=245520 1032080 0 0 $X=245520 $Y=1031700
X3676 977 872 1 1007 21 2 988 983 864 OAI222S $T=247380 1032080 1 0 $X=247380 $Y=1026660
X3677 961 1168 1 981 817 2 904 1148 720 OAI222S $T=272800 981680 1 180 $X=267220 $Y=981300
X3678 1114 860 1 1127 48 2 822 1237 932 OAI222S $T=274660 1032080 0 0 $X=274660 $Y=1031700
X3679 799 781 1 1164 718 2 41 1312 1301 OAI222S $T=285820 1011920 1 0 $X=285820 $Y=1006500
X3680 1414 889 1 38 21 2 1267 1404 834 OAI222S $T=306900 991760 1 180 $X=301320 $Y=991380
X3681 730 1448 1 988 797 2 1007 1485 21 OAI222S $T=312480 1032080 1 0 $X=312480 $Y=1026660
X3682 877 39 1 988 797 2 977 1504 1007 OAI222S $T=319300 1022000 1 180 $X=313720 $Y=1021620
X3683 872 979 1 15 1413 2 1136 1495 7 OAI222S $T=316200 1042160 1 0 $X=316200 $Y=1036740
X3684 730 979 1 41 977 2 998 1470 817 OAI222S $T=318680 1032080 1 0 $X=318680 $Y=1026660
X3685 1606 1136 1 1374 877 2 1653 1614 15 OAI222S $T=337900 981680 1 0 $X=337900 $Y=976260
X3686 1652 1524 1 1623 1656 2 91 1663 1667 OAI222S $T=341000 951440 0 0 $X=341000 $Y=951060
X3687 3177 3098 1 3178 3077 2 3127 3191 3192 OAI222S $T=626200 951440 0 0 $X=626200 $Y=951060
X3688 3177 3117 1 3178 3091 2 3127 3184 3069 OAI222S $T=632400 921200 1 180 $X=626820 $Y=920820
X3689 3177 3095 1 3178 3098 2 3127 3185 3118 OAI222S $T=632400 931280 1 180 $X=626820 $Y=930900
X3690 3177 3082 1 3178 3069 2 3127 3186 3167 OAI222S $T=632400 941360 1 180 $X=626820 $Y=940980
X3691 3177 3091 1 3178 3102 2 3127 3206 3164 OAI222S $T=627440 941360 1 0 $X=627440 $Y=935940
X3692 3177 3123 1 3178 3082 2 3127 3220 3077 OAI222S $T=628060 931280 1 0 $X=628060 $Y=925860
X3693 3133 3138 1 3205 3140 2 3127 321 3117 OAI222S $T=636120 890960 0 180 $X=630540 $Y=885540
X3694 3177 3102 1 3178 3118 2 3127 3229 3223 OAI222S $T=630540 961520 1 0 $X=630540 $Y=956100
X3695 3271 3177 1 3178 3276 2 3127 3288 3100 OAI222S $T=648520 961520 0 180 $X=642940 $Y=956100
X3696 3177 3314 1 3178 3307 2 3127 3312 3208 OAI222S $T=654720 961520 0 180 $X=649140 $Y=956100
X3697 3177 3333 1 3178 3291 2 3127 3346 3273 OAI222S $T=655960 951440 0 180 $X=650380 $Y=946020
X3698 3329 3177 1 3345 3178 2 3127 3302 3291 OAI222S $T=651000 921200 0 0 $X=651000 $Y=920820
X3699 3303 3133 1 3205 3341 2 3329 343 3127 OAI222S $T=658440 890960 0 180 $X=652860 $Y=885540
X3700 3345 3177 1 3178 3271 2 3127 3355 3287 OAI222S $T=658440 941360 1 180 $X=652860 $Y=940980
X3701 3351 3177 1 3178 3333 2 3127 3339 3307 OAI222S $T=653480 931280 1 0 $X=653480 $Y=925860
X3702 3343 3177 1 3178 3314 2 3127 3340 3276 OAI222S $T=653480 931280 0 0 $X=653480 $Y=930900
X3703 874 106 1684 2 1 XNR2HS $T=345340 1042160 0 0 $X=345340 $Y=1041780
X3704 1588 106 1685 2 1 XNR2HS $T=346580 1052240 1 0 $X=346580 $Y=1046820
X3705 6 106 1692 2 1 XNR2HS $T=347820 1032080 1 0 $X=347820 $Y=1026660
X3706 1940 1938 1921 2 1 XNR2HS $T=401760 1042160 0 180 $X=396180 $Y=1036740
X3707 2052 2042 1916 2 1 XNR2HS $T=419120 1022000 1 180 $X=413540 $Y=1021620
X3708 2023 2053 2009 2 1 XNR2HS $T=416640 1042160 0 0 $X=416640 $Y=1041780
X3709 2116 2135 2133 2 1 XNR2HS $T=430280 1032080 1 0 $X=430280 $Y=1026660
X3710 2944 2912 2982 2 1 XNR2HS $T=595200 1022000 0 0 $X=595200 $Y=1021620
X3711 3057 3038 3086 2 1 XNR2HS $T=608220 981680 1 0 $X=608220 $Y=976260
X3712 3209 3217 3230 2 1 XNR2HS $T=633020 991760 1 0 $X=633020 $Y=986340
X3713 3096 3226 3252 2 1 XNR2HS $T=636120 991760 0 0 $X=636120 $Y=991380
X3714 3096 3266 3297 2 1 XNR2HS $T=643560 991760 0 0 $X=643560 $Y=991380
X3715 3283 3219 3322 2 1 XNR2HS $T=647280 981680 1 0 $X=647280 $Y=976260
X3716 739 753 733 707 715 717 1 2 700 OA222 $T=226300 961520 0 180 $X=220720 $Y=956100
X3717 743 755 749 736 724 719 1 2 702 OA222 $T=226300 991760 1 180 $X=220720 $Y=991380
X3718 739 761 715 734 733 726 1 2 698 OA222 $T=226920 931280 1 180 $X=221340 $Y=930900
X3719 807 763 751 744 698 729 1 2 712 OA222 $T=226920 1022000 1 180 $X=221340 $Y=1021620
X3720 732 758 733 771 783 790 1 2 811 OA222 $T=223820 911120 0 0 $X=223820 $Y=910740
X3721 739 740 715 775 733 792 1 2 810 OA222 $T=223820 961520 0 0 $X=223820 $Y=961140
X3722 706 779 789 754 718 766 1 2 757 OA222 $T=231260 981680 1 180 $X=225680 $Y=981300
X3723 730 822 720 784 797 782 1 2 725 OA222 $T=231880 1022000 0 180 $X=226300 $Y=1016580
X3724 878 789 743 851 825 841 1 2 828 OA222 $T=236220 991760 1 180 $X=230640 $Y=991380
X3725 797 781 863 834 718 833 1 2 805 OA222 $T=236220 1011920 0 180 $X=230640 $Y=1006500
X3726 783 845 739 862 861 768 1 2 887 OA222 $T=231260 921200 1 0 $X=231260 $Y=915780
X3727 902 883 804 867 861 854 1 2 837 OA222 $T=237460 911120 0 180 $X=231880 $Y=905700
X3728 872 889 797 877 870 864 1 2 796 OA222 $T=238080 1022000 0 180 $X=232500 $Y=1016580
X3729 912 763 718 882 797 873 1 2 848 OA222 $T=238700 1042160 0 180 $X=233120 $Y=1036740
X3730 810 729 749 905 870 922 1 2 935 OA222 $T=236220 1001840 1 0 $X=236220 $Y=996420
X3731 870 974 922 979 718 794 1 2 1003 OA222 $T=244280 991760 0 0 $X=244280 $Y=991380
X3732 988 860 1004 998 7 979 1 2 957 OA222 $T=251720 1052240 0 180 $X=246140 $Y=1046820
X3733 743 1004 789 816 1022 749 1 2 1033 OA222 $T=248000 1001840 1 0 $X=248000 $Y=996420
X3734 861 972 739 1018 804 964 1 2 1128 OA222 $T=248620 901040 0 0 $X=248620 $Y=900660
X3735 718 878 778 841 834 4 1 2 1041 OA222 $T=248620 1001840 0 0 $X=248620 $Y=1001460
X3736 1138 1137 861 965 783 1163 1 2 1170 OA222 $T=266600 921200 0 0 $X=266600 $Y=920820
X3737 870 38 979 974 988 1127 1 2 1177 OA222 $T=266600 1052240 1 0 $X=266600 $Y=1046820
X3738 763 1165 730 889 39 877 1 2 795 OA222 $T=272800 1032080 1 180 $X=267220 $Y=1031700
X3739 951 785 834 1151 1074 699 1 2 1209 OA222 $T=267840 1001840 0 0 $X=267840 $Y=1001460
X3740 1126 46 797 1193 706 1190 1 2 924 OA222 $T=279000 1011920 0 180 $X=273420 $Y=1006500
X3741 1243 875 804 1073 783 1197 1 2 1192 OA222 $T=281480 921200 0 180 $X=275900 $Y=915780
X3742 720 1219 1168 1216 1022 841 1 2 1231 OA222 $T=275900 971600 0 0 $X=275900 $Y=971220
X3743 778 914 783 1229 1243 1235 1 2 1242 OA222 $T=277140 911120 0 0 $X=277140 $Y=910740
X3744 981 831 1264 1268 1168 1009 1 2 1287 OA222 $T=281480 991760 0 0 $X=281480 $Y=991380
X3745 706 1230 834 1277 718 1181 1 2 1292 OA222 $T=282720 971600 1 0 $X=282720 $Y=966180
X3746 720 851 787 1278 1028 841 1 2 1289 OA222 $T=282720 981680 1 0 $X=282720 $Y=976260
X3747 864 1253 981 1259 1168 1270 1 2 1256 OA222 $T=288300 1001840 0 180 $X=282720 $Y=996420
X3748 1301 864 7 1165 55 732 1 2 1194 OA222 $T=289540 1042160 0 180 $X=283960 $Y=1036740
X3749 39 1114 1282 1298 7 1203 1 2 1325 OA222 $T=286440 1032080 1 0 $X=286440 $Y=1026660
X3750 1004 998 971 720 55 1333 1 2 1332 OA222 $T=289540 1011920 0 0 $X=289540 $Y=1011540
X3751 751 1264 706 1331 797 1301 1 2 1349 OA222 $T=290160 991760 0 0 $X=290160 $Y=991380
X3752 1321 1054 1337 1327 732 1276 1 2 1364 OA222 $T=291400 931280 1 0 $X=291400 $Y=925860
X3753 699 706 951 724 1413 902 1 2 1434 OA222 $T=300700 1001840 1 0 $X=300700 $Y=996420
X3754 864 1435 720 1423 751 1394 1 2 1400 OA222 $T=308140 1011920 1 180 $X=302560 $Y=1011540
X3755 1448 763 751 1394 977 1431 1 2 1477 OA222 $T=307520 1022000 0 0 $X=307520 $Y=1021620
X3756 730 889 1448 922 1413 902 1 2 72 OA222 $T=313720 1011920 1 180 $X=308140 $Y=1011540
X3757 783 1413 797 870 872 48 1 2 1179 OA222 $T=316820 1022000 0 180 $X=311240 $Y=1016580
X3758 1448 872 951 998 1498 15 1 2 1273 OA222 $T=319920 1011920 1 180 $X=314340 $Y=1011540
X3759 1126 41 864 1114 1136 38 1 2 1537 OA222 $T=316820 1001840 1 0 $X=316820 $Y=996420
X3760 1283 1567 872 1561 860 1551 1 2 1249 OA222 $T=328600 1052240 1 180 $X=323020 $Y=1051860
X3761 781 1564 1138 1574 1321 1583 1 2 1581 OA222 $T=325500 961520 1 0 $X=325500 $Y=956100
X3762 1609 1511 1577 1578 1490 1159 1 2 1569 OA222 $T=333560 941360 1 180 $X=327980 $Y=940980
X3763 889 1611 1549 1615 1601 1618 1 2 1576 OA222 $T=332320 981680 0 0 $X=332320 $Y=981300
X3764 1658 1645 1673 94 1541 1630 1 2 1686 OA222 $T=345340 941360 1 0 $X=345340 $Y=935940
X3765 3069 3083 3164 3073 3118 3064 1 2 3175 OA222 $T=624340 961520 1 0 $X=624340 $Y=956100
X3766 3192 3147 3098 3141 3102 3134 1 2 3165 OA222 $T=630540 961520 1 180 $X=624960 $Y=961140
X3767 3291 3083 3287 3073 3276 3064 1 2 3265 OA222 $T=648520 951440 1 180 $X=642940 $Y=951060
X3768 3108 277 262 3124 3131 3012 1 2 3143 AO222S $T=615040 971600 1 0 $X=615040 $Y=966180
X3769 276 3108 3124 2917 3038 3131 1 2 3159 AO222S $T=617520 971600 0 0 $X=617520 $Y=971220
X3770 3108 3245 3237 3124 3131 3225 1 2 3201 AO222S $T=640460 961520 1 180 $X=634260 $Y=961140
X3771 3264 3108 3124 3257 3219 3131 1 2 3202 AO222S $T=644800 971600 1 180 $X=638600 $Y=971220
X3772 1333 55 2 1 80 OR2S $T=327980 1062320 0 180 $X=325500 $Y=1056900
X3773 3190 3240 2 1 3258 OR2S $T=637980 901040 1 0 $X=637980 $Y=895620
X3774 15 946 2 1 907 OR2 $T=243660 1011920 0 180 $X=241180 $Y=1006500
X3775 977 922 2 1 929 OR2 $T=246140 1011920 1 180 $X=243660 $Y=1011540
X3776 41 1448 2 1 917 OR2 $T=313720 1001840 0 0 $X=313720 $Y=1001460
X3777 729 1333 2 1 998 OR2 $T=323640 1022000 0 180 $X=321160 $Y=1016580
X3778 1513 1559 2 1 863 OR2 $T=326120 971600 1 180 $X=323640 $Y=971220
X3779 1549 1264 2 1 7 OR2 $T=347820 991760 0 180 $X=345340 $Y=986340
X3780 1704 1528 2 1 1687 OR2 $T=354640 971600 0 180 $X=352160 $Y=966180
X3781 1797 1800 2 1 1805 OR2 $T=373240 1001840 0 0 $X=373240 $Y=1001460
X3782 1800 1808 2 1 1828 OR2 $T=375100 1032080 1 0 $X=375100 $Y=1026660
X3783 144 137 2 1 1845 OR2 $T=387500 941360 1 180 $X=385020 $Y=940980
X3784 1774 1643 2 1 2110 OR2 $T=424080 1022000 0 0 $X=424080 $Y=1021620
X3785 3209 3217 2 1 3226 OR2 $T=633020 991760 0 0 $X=633020 $Y=991380
X3786 758 1 786 829 772 2 ND3S $T=230020 941360 1 0 $X=230020 $Y=935940
X3787 708 1 838 850 779 2 ND3S $T=233120 951440 1 180 $X=230640 $Y=951060
X3788 931 1 852 895 859 2 ND3S $T=240560 971600 0 180 $X=238080 $Y=966180
X3789 961 1 838 936 863 2 ND3S $T=244280 991760 1 180 $X=241800 $Y=991380
X3790 971 1 4 930 951 2 ND3S $T=245520 951440 0 180 $X=243040 $Y=946020
X3791 859 1 951 992 971 2 ND3S $T=244900 941360 0 0 $X=244900 $Y=940980
X3792 1001 1 888 868 923 2 ND3S $T=247380 951440 1 180 $X=244900 $Y=951060
X3793 999 1 817 1020 1028 2 ND3S $T=249860 961520 0 0 $X=249860 $Y=961140
X3794 831 1 888 1000 1004 2 ND3S $T=251720 971600 1 0 $X=251720 $Y=966180
X3795 999 1 1044 1060 1009 2 ND3S $T=255440 941360 0 0 $X=255440 $Y=940980
X3796 1058 1 4 1069 888 2 ND3S $T=256680 971600 0 0 $X=256680 $Y=971220
X3797 1062 1 892 1129 999 2 ND3S $T=264120 951440 1 0 $X=264120 $Y=946020
X3798 1096 1 999 1144 921 2 ND3S $T=267840 961520 1 180 $X=265360 $Y=961140
X3799 1191 1 748 1156 1180 2 ND3S $T=274660 931280 1 180 $X=272180 $Y=930900
X3800 1164 1 881 1208 748 2 ND3S $T=272800 961520 0 0 $X=272800 $Y=961140
X3801 1309 1 1209 1295 1289 2 ND3S $T=290160 991760 1 180 $X=287680 $Y=991380
X3802 1317 1 1028 1315 708 2 ND3S $T=292640 931280 1 180 $X=290160 $Y=930900
X3803 1314 1 1250 1341 1349 2 ND3S $T=292640 1001840 1 0 $X=292640 $Y=996420
X3804 1185 1 1334 1355 1313 2 ND3S $T=292640 1001840 0 0 $X=292640 $Y=1001460
X3805 1463 1 1413 1402 987 2 ND3S $T=310620 1022000 0 180 $X=308140 $Y=1016580
X3806 1474 1 1119 1497 1462 2 ND3S $T=317440 1052240 0 180 $X=314960 $Y=1046820
X3807 1627 1 1668 1688 1537 2 ND3S $T=345340 1001840 1 0 $X=345340 $Y=996420
X3808 1713 1 1716 1728 97 2 ND3S $T=354640 951440 1 0 $X=354640 $Y=946020
X3809 3097 1 3103 3120 3030 2 ND3S $T=616900 1011920 0 0 $X=616900 $Y=1011540
X3810 3103 1 3041 3151 3074 2 ND3S $T=621240 1011920 0 0 $X=621240 $Y=1011540
X3811 3030 1 3104 3162 3074 2 ND3S $T=623720 1022000 0 0 $X=623720 $Y=1021620
X3812 3060 1 3132 3163 3105 2 ND3S $T=624960 1042160 1 0 $X=624960 $Y=1036740
X3813 3080 1 3132 3183 3125 2 ND3S $T=628060 1042160 1 0 $X=628060 $Y=1036740
X3814 957 939 933 2 1 13 AN3 $T=243660 1052240 1 180 $X=239940 $Y=1051860
X3815 1053 1061 1063 2 1 1081 AN3 $T=255440 1052240 1 0 $X=255440 $Y=1046820
X3816 1233 1248 1251 2 1 1160 AN3 $T=279620 1001840 0 0 $X=279620 $Y=1001460
X3817 1499 1471 1305 2 1 1145 AN3 $T=313720 1032080 1 180 $X=310000 $Y=1031700
X3818 1374 1606 1559 2 1 1676 AN3 $T=351540 991760 1 180 $X=347820 $Y=991380
X3819 3088 3094 3136 2 1 3131 AN3 $T=618140 1001840 1 0 $X=618140 $Y=996420
X3820 3136 3074 3094 2 1 3180 AN3 $T=624960 1011920 0 0 $X=624960 $Y=1011540
X3821 3126 3105 3162 2 1 3156 AN3 $T=631780 1032080 1 180 $X=628060 $Y=1031700
X3822 728 2 714 716 709 1 NR3 $T=224440 951440 0 180 $X=221340 $Y=946020
X3823 832 2 903 765 808 1 NR3 $T=231880 931280 0 180 $X=228780 $Y=925860
X3824 850 2 869 826 773 1 NR3 $T=233120 961520 1 0 $X=233120 $Y=956100
X3825 886 2 901 896 871 1 NR3 $T=236220 981680 1 0 $X=236220 $Y=976260
X3826 936 2 901 827 899 1 NR3 $T=240560 981680 1 180 $X=237460 $Y=981300
X3827 927 2 759 885 862 1 NR3 $T=241800 931280 0 180 $X=238700 $Y=925860
X3828 727 2 934 752 867 1 NR3 $T=239940 911120 0 0 $X=239940 $Y=910740
X3829 930 2 896 937 883 1 NR3 $T=239940 941360 0 0 $X=239940 $Y=940980
X3830 868 2 703 918 965 1 NR3 $T=245520 931280 0 180 $X=242420 $Y=925860
X3831 705 2 959 767 949 1 NR3 $T=242420 941360 1 0 $X=242420 $Y=935940
X3832 983 2 969 963 962 1 NR3 $T=246760 1022000 1 180 $X=243660 $Y=1021620
X3833 1020 2 918 847 970 1 NR3 $T=249240 971600 0 180 $X=246140 $Y=966180
X3834 844 2 941 1000 717 1 NR3 $T=246760 961520 0 0 $X=246760 $Y=961140
X3835 992 2 980 1010 990 1 NR3 $T=248000 941360 1 0 $X=248000 $Y=935940
X3836 1017 2 1040 1030 744 1 NR3 $T=251100 1022000 0 0 $X=251100 $Y=1021620
X3837 776 2 17 1050 1058 1 NR3 $T=253580 951440 0 0 $X=253580 $Y=951060
X3838 927 2 1049 776 1062 1 NR3 $T=257300 951440 0 180 $X=254200 $Y=946020
X3839 8 2 1080 1092 800 1 NR3 $T=258540 1042160 0 0 $X=258540 $Y=1041780
X3840 975 2 1121 919 1137 1 NR3 $T=266600 921200 0 180 $X=263500 $Y=915780
X3841 798 2 934 940 1109 1 NR3 $T=264740 931280 0 0 $X=264740 $Y=930900
X3842 1148 2 956 1188 1119 1 NR3 $T=270940 1042160 0 0 $X=270940 $Y=1041780
X3843 844 2 959 1244 1267 1 NR3 $T=279620 951440 0 0 $X=279620 $Y=951060
X3844 1097 2 1252 1220 1261 1 NR3 $T=280240 1011920 1 0 $X=280240 $Y=1006500
X3845 1055 2 1011 1021 1278 1 NR3 $T=285820 971600 0 0 $X=285820 $Y=971220
X3846 1115 2 1049 752 1327 1 NR3 $T=287680 931280 1 0 $X=287680 $Y=925860
X3847 1323 2 1312 1288 1300 1 NR3 $T=292020 1001840 0 180 $X=288920 $Y=996420
X3848 1335 2 1346 1352 1280 1 NR3 $T=293260 1052240 0 0 $X=293260 $Y=1051860
X3849 1354 2 1397 1116 1384 1 NR3 $T=300080 1001840 0 0 $X=300080 $Y=1001460
X3850 1497 2 1352 1447 1496 1 NR3 $T=316820 1042160 1 180 $X=313720 $Y=1041780
X3851 1519 2 1529 1392 1518 1 NR3 $T=319300 991760 0 0 $X=319300 $Y=991380
X3852 1604 2 1616 1481 1627 1 NR3 $T=333560 1001840 1 0 $X=333560 $Y=996420
X3853 1657 2 1252 1664 1668 1 NR3 $T=343480 1001840 0 0 $X=343480 $Y=1001460
X3854 1811 2 1836 1853 1865 1 NR3 $T=388120 981680 0 0 $X=388120 $Y=981300
X3855 1984 2 1925 2052 2078 1 NR3 $T=425940 1022000 0 180 $X=422840 $Y=1016580
X3856 3047 2 3094 3053 320 1 NR3 $T=626820 1001840 1 0 $X=626820 $Y=996420
X3857 1610 1650 1636 78 2 1525 1 AOI13HS $T=342240 941360 0 180 $X=338520 $Y=935940
X3858 1737 1738 97 91 2 1064 1 AOI13HS $T=358980 951440 1 0 $X=358980 $Y=946020
X3859 3030 3080 3074 3103 2 3180 1 AOI13HS $T=626200 1022000 0 0 $X=626200 $Y=1021620
X3860 3078 3162 3064 1 2 OR2P $T=626200 981680 0 0 $X=626200 $Y=981300
X3861 703 2 752 1 708 NR2P $T=225060 941360 0 180 $X=221340 $Y=935940
X3862 714 2 1090 1 831 NR2P $T=259780 921200 0 180 $X=256060 $Y=915780
X3863 838 2 729 1 1330 NR2P $T=306900 971600 1 0 $X=306900 $Y=966180
X3864 1468 2 1482 1 1130 NR2P $T=312480 890960 0 0 $X=312480 $Y=890580
X3865 1468 2 1521 1 1123 NR2P $T=317440 890960 0 0 $X=317440 $Y=890580
X3866 1523 2 1513 1 703 NR2P $T=318060 941360 1 0 $X=318060 $Y=935940
X3867 1264 2 1606 1 14 NR2P $T=339140 991760 0 0 $X=339140 $Y=991380
X3868 1524 2 1513 1 1049 NR2P $T=339760 971600 1 0 $X=339760 $Y=966180
X3869 1845 2 1857 1 1853 NR2P $T=386880 951440 0 180 $X=383160 $Y=946020
X3870 1845 2 1883 1 1811 NR2P $T=391840 951440 0 180 $X=388120 $Y=946020
X3871 166 2 174 1 1906 NR2P $T=398660 991760 1 0 $X=398660 $Y=986340
X3872 1903 2 2018 1 2019 NR2P $T=413540 1011920 0 180 $X=409820 $Y=1006500
X3873 2013 2 1938 1 2001 NR2P $T=410440 1032080 1 0 $X=410440 $Y=1026660
X3874 2107 2 2091 1 2141 NR2P $T=429660 1042160 1 180 $X=425940 $Y=1041780
X3875 2110 2 2173 1 1925 NR2P $T=438340 1011920 1 180 $X=434620 $Y=1011540
X3876 2110 2 2163 1 2090 NR2P $T=436480 1022000 0 0 $X=436480 $Y=1021620
X3877 3047 2 3096 1 279 NR2P $T=615040 991760 0 180 $X=611320 $Y=986340
X3878 3047 2 3096 1 293 NR2P $T=620000 991760 0 180 $X=616280 $Y=986340
X3879 3047 2 3096 1 298 NR2P $T=623720 981680 1 180 $X=620000 $Y=981300
X3880 3126 2 3078 1 3124 NR2P $T=624960 991760 0 0 $X=624960 $Y=991380
X3881 733 729 1213 917 1 2 1515 OA13S $T=313100 981680 0 0 $X=313100 $Y=981300
X3882 3094 3074 3103 3162 1 2 3060 OA13S $T=628680 1032080 0 180 $X=624340 $Y=1026660
X3883 1893 1899 1 1915 1886 1899 2 MOAI1 $T=394320 1022000 1 0 $X=394320 $Y=1016580
X3884 1946 1959 1 1965 1880 1904 2 MOAI1 $T=401760 1022000 0 0 $X=401760 $Y=1021620
X3885 3193 3012 1 3105 3150 3100 2 MOAI1 $T=626200 981680 0 180 $X=621860 $Y=976260
X3886 3103 3099 3074 1 2 AN2B1 $T=624340 1032080 0 180 $X=620000 $Y=1026660
X3887 3047 3030 3065 2 1 3093 OA12S $T=609460 1011920 0 0 $X=609460 $Y=1011540
X3888 3047 3074 3022 2 1 3065 OA12S $T=616900 1011920 1 180 $X=613180 $Y=1011540
X3889 943 925 1 14 2 913 OAI12HS $T=242420 1042160 1 180 $X=238700 $Y=1041780
X3890 1274 886 1 920 2 1263 OAI12HS $T=285200 971600 1 180 $X=281480 $Y=971220
X3891 1552 87 1 1600 2 1626 OAI12HS $T=332320 931280 1 0 $X=332320 $Y=925860
X3892 1626 1707 1 1721 2 1730 OAI12HS $T=354020 931280 0 0 $X=354020 $Y=930900
X3893 1723 114 1 1725 2 1742 OAI12HS $T=356500 870800 0 0 $X=356500 $Y=870420
X3894 1626 1697 1 1721 2 1759 OAI12HS $T=360840 941360 1 0 $X=360840 $Y=935940
X3895 3053 3094 1 3004 2 3071 OAI12HS $T=615040 1001840 1 180 $X=611320 $Y=1001460
X3896 2977 2976 1 2 INV1CK $T=595200 1011920 0 180 $X=593340 $Y=1006500
X3897 3013 2976 1 2 INV1CK $T=600780 1001840 0 180 $X=598920 $Y=996420
X3898 3025 286 1 2 INV1CK $T=612560 1032080 0 180 $X=610700 $Y=1026660
X3899 1692 1666 110 128 1 2 QDFFRBP $T=350920 1022000 0 0 $X=350920 $Y=1021620
X3900 3024 3013 125 3066 1 2 QDFFRBP $T=602020 1022000 0 0 $X=602020 $Y=1021620
X3901 2965 2977 125 3030 1 2 3041 DFFRBN $T=592100 1011920 0 0 $X=592100 $Y=1011540
X3902 1075 29 32 1 2 1008 MAO222 $T=256680 880880 1 0 $X=256680 $Y=875460
X3903 1082 31 1059 1 2 32 MAO222 $T=257300 880880 0 0 $X=257300 $Y=880500
X3904 1560 1544 1545 1 2 1568 MAO222 $T=323020 890960 1 0 $X=323020 $Y=885540
X3905 1596 1568 1602 1 2 1573 MAO222 $T=331080 890960 0 0 $X=331080 $Y=890580
X3906 2006 1999 1985 1 2 2113 MAO222 $T=411060 911120 1 0 $X=411060 $Y=905700
X3907 205 195 207 1 2 2272 MAO222 $T=442060 1052240 0 0 $X=442060 $Y=1051860
X3908 2196 2177 2189 1 2 2216 MAO222 $T=442680 911120 1 0 $X=442680 $Y=905700
X3909 2429 2426 2360 1 2 2454 MAO222 $T=481740 1052240 0 0 $X=481740 $Y=1051860
X3910 2547 2454 2496 1 2 2562 MAO222 $T=499100 1052240 0 0 $X=499100 $Y=1051860
X3911 2502 2439 2549 1 2 2555 MAO222 $T=501580 961520 1 0 $X=501580 $Y=956100
X3912 2548 2598 2553 1 2 2588 MAO222 $T=513980 880880 0 0 $X=513980 $Y=880500
X3913 2642 2686 2705 1 2 2726 MAO222 $T=524520 911120 0 0 $X=524520 $Y=910740
X3914 2782 2785 2730 1 2 2744 MAO222 $T=544360 890960 1 180 $X=539400 $Y=890580
X3915 2829 2833 2699 1 2 2846 MAO222 $T=553040 1022000 0 0 $X=553040 $Y=1021620
X3916 2926 2913 2927 1 2 2937 MAO222 $T=580940 971600 0 0 $X=580940 $Y=971220
X3917 1788 1813 2 1791 1 1706 MUX2S $T=376340 901040 0 180 $X=372000 $Y=895620
X3918 148 142 2 154 1 1821 MUX2S $T=379440 880880 1 0 $X=379440 $Y=875460
X3919 1823 1693 2 1837 1 1830 MUX2S $T=380060 890960 1 0 $X=380060 $Y=885540
X3920 1804 1813 2 1855 1 1850 MUX2S $T=383160 901040 1 0 $X=383160 $Y=895620
X3921 154 142 2 156 1 1837 MUX2S $T=389360 870800 1 180 $X=385020 $Y=870420
X3922 1821 1693 2 157 1 1791 MUX2S $T=385020 880880 1 0 $X=385020 $Y=875460
X3923 1837 1693 2 158 1 1855 MUX2S $T=385640 890960 1 0 $X=385640 $Y=885540
X3924 1830 1813 2 1878 1 1856 MUX2S $T=388120 890960 0 0 $X=388120 $Y=890580
X3925 1778 1813 2 1888 1 1754 MUX2S $T=388740 901040 1 0 $X=388740 $Y=895620
X3926 1621 1682 2 1894 1 1897 MUX2S $T=389980 901040 0 0 $X=389980 $Y=900660
X3927 161 142 2 165 1 1900 MUX2S $T=390600 870800 0 0 $X=390600 $Y=870420
X3928 157 1693 2 1900 1 1888 MUX2S $T=390600 880880 1 0 $X=390600 $Y=875460
X3929 158 1693 2 1902 1 1878 MUX2S $T=391220 890960 1 0 $X=391220 $Y=885540
X3930 1791 1813 2 1913 1 1894 MUX2S $T=393700 890960 0 0 $X=393700 $Y=890580
X3931 1855 1813 2 1918 1 1929 MUX2S $T=394320 901040 1 0 $X=394320 $Y=895620
X3932 1608 1682 2 1929 1 1937 MUX2S $T=395560 901040 0 0 $X=395560 $Y=900660
X3933 1900 1693 2 1932 1 1913 MUX2S $T=396180 880880 1 0 $X=396180 $Y=875460
X3934 165 142 2 172 1 1902 MUX2S $T=396800 870800 0 0 $X=396800 $Y=870420
X3935 1902 1693 2 1934 1 1918 MUX2S $T=396800 890960 1 0 $X=396800 $Y=885540
X3936 1930 1910 2 1947 1 1958 MUX2S $T=398660 951440 0 0 $X=398660 $Y=951060
X3937 1878 1813 2 1951 1 1962 MUX2S $T=399280 890960 0 0 $X=399280 $Y=890580
X3938 1918 1813 2 1945 1 1968 MUX2S $T=399900 901040 1 0 $X=399900 $Y=895620
X3939 1850 1682 2 1968 1 1972 MUX2S $T=401760 901040 0 0 $X=401760 $Y=900660
X3940 172 142 2 1970 1 1932 MUX2S $T=402380 870800 0 0 $X=402380 $Y=870420
X3941 1932 1693 2 1971 1 1975 MUX2S $T=402380 880880 1 0 $X=402380 $Y=875460
X3942 1958 1917 2 1977 1 1990 MUX2S $T=403620 961520 0 0 $X=403620 $Y=961140
X3943 1949 1917 2 1978 1 1995 MUX2S $T=403620 971600 1 0 $X=403620 $Y=966180
X3944 1947 1910 2 1966 1 1978 MUX2S $T=404240 951440 0 0 $X=404240 $Y=951060
X3945 1966 1910 2 1983 1 1977 MUX2S $T=404240 961520 1 0 $X=404240 $Y=956100
X3946 1951 1813 2 1945 1 1997 MUX2S $T=404860 890960 0 0 $X=404860 $Y=890580
X3947 1975 1813 2 1945 1 2000 MUX2S $T=406100 901040 1 0 $X=406100 $Y=895620
X3948 1754 1682 2 2000 1 2007 MUX2S $T=407340 901040 0 0 $X=407340 $Y=900660
X3949 1970 142 2 178 1 1934 MUX2S $T=412920 870800 1 180 $X=408580 $Y=870420
X3950 1978 1917 2 2012 1 2021 MUX2S $T=409200 961520 0 0 $X=409200 $Y=961140
X3951 1977 1917 2 2017 1 2025 MUX2S $T=409820 961520 1 0 $X=409820 $Y=956100
X3952 1856 1682 2 1997 1 2024 MUX2S $T=410440 890960 0 0 $X=410440 $Y=890580
X3953 1983 1910 2 2016 1 2012 MUX2S $T=410440 951440 1 0 $X=410440 $Y=946020
X3954 1960 1955 2 2010 1 2026 MUX2S $T=410440 991760 1 0 $X=410440 $Y=986340
X3955 1888 1813 2 1975 1 2037 MUX2S $T=411680 901040 1 0 $X=411680 $Y=895620
X3956 1913 1813 2 2011 1 2043 MUX2S $T=412920 880880 0 0 $X=412920 $Y=880500
X3957 1661 1682 2 2037 1 2048 MUX2S $T=412920 901040 0 0 $X=412920 $Y=900660
X3958 181 104 2 184 1 2020 MUX2S $T=413540 880880 1 0 $X=413540 $Y=875460
X3959 2029 1955 2 2049 1 2057 MUX2S $T=414780 961520 0 0 $X=414780 $Y=961140
X3960 2012 1917 2 2054 1 2029 MUX2S $T=415400 961520 1 0 $X=415400 $Y=956100
X3961 2016 1910 2 2056 1 2017 MUX2S $T=416020 951440 0 0 $X=416020 $Y=951060
X3962 135 104 2 185 1 2065 MUX2S $T=417260 870800 0 0 $X=417260 $Y=870420
X3963 1715 1682 2 1962 1 2073 MUX2S $T=417260 901040 1 0 $X=417260 $Y=895620
X3964 1995 1955 2 2029 1 2080 MUX2S $T=417880 971600 0 0 $X=417880 $Y=971220
X3965 1954 1955 2 2021 1 2072 MUX2S $T=417880 981680 1 0 $X=417880 $Y=976260
X3966 2011 1813 2 1945 1 2083 MUX2S $T=418500 880880 0 0 $X=418500 $Y=880500
X3967 1706 1682 2 2043 1 2075 MUX2S $T=418500 901040 0 0 $X=418500 $Y=900660
X3968 2056 1910 2 2068 1 2054 MUX2S $T=418500 951440 1 0 $X=418500 $Y=946020
X3969 2058 1955 2 2025 1 2085 MUX2S $T=419740 981680 0 0 $X=419740 $Y=981300
X3970 2049 1955 2 2066 1 2096 MUX2S $T=420980 961520 0 0 $X=420980 $Y=961140
X3971 1894 1682 2 2083 1 2095 MUX2S $T=421600 890960 0 0 $X=421600 $Y=890580
X3972 98 104 2 191 1 2099 MUX2S $T=422840 870800 0 0 $X=422840 $Y=870420
X3973 2054 1917 2 2092 1 2097 MUX2S $T=422840 951440 0 0 $X=422840 $Y=951060
X3974 2072 2077 2 2093 1 2108 MUX2S $T=423460 991760 1 0 $X=423460 $Y=986340
X3975 2080 2077 2 2096 1 2124 MUX2S $T=424080 971600 0 0 $X=424080 $Y=971220
X3976 2068 1910 2 2106 1 2112 MUX2S $T=424700 951440 1 0 $X=424700 $Y=946020
X3977 2097 1955 2 2066 1 2093 MUX2S $T=429660 981680 1 180 $X=425320 $Y=981300
X3978 2017 1917 2 2112 1 2118 MUX2S $T=427180 961520 1 0 $X=427180 $Y=956100
X3979 1990 1955 2 2118 1 2127 MUX2S $T=427180 961520 0 0 $X=427180 $Y=961140
X3980 2021 1955 2 2097 1 2128 MUX2S $T=427180 981680 1 0 $X=427180 $Y=976260
X3981 2055 138 2 2061 1 2148 MUX2S $T=429040 941360 0 0 $X=429040 $Y=940980
X3982 2045 2077 2 2057 1 2150 MUX2S $T=429660 991760 1 0 $X=429660 $Y=986340
X3983 2074 2077 2 2140 1 2161 MUX2S $T=429660 991760 0 0 $X=429660 $Y=991380
X3984 2025 1955 2 2134 1 2140 MUX2S $T=430280 971600 1 0 $X=430280 $Y=966180
X3985 2106 1910 2 2130 1 2092 MUX2S $T=435240 951440 0 180 $X=430900 $Y=946020
X3986 2134 1955 2 2066 1 2149 MUX2S $T=431520 981680 1 0 $X=431520 $Y=976260
X3987 2085 2077 2 2149 1 2160 MUX2S $T=431520 981680 0 0 $X=431520 $Y=981300
X3988 2118 1955 2 2159 1 2174 MUX2S $T=433380 961520 0 0 $X=433380 $Y=961140
X3989 2041 2077 2 2128 1 2179 MUX2S $T=435240 1001840 1 0 $X=435240 $Y=996420
X3990 2140 2077 2 2066 1 2190 MUX2S $T=436480 971600 0 0 $X=436480 $Y=971220
X3991 2044 2077 2 2174 1 2186 MUX2S $T=437100 981680 0 0 $X=437100 $Y=981300
X3992 2174 2077 2 2066 1 2201 MUX2S $T=438960 961520 1 0 $X=438960 $Y=956100
X3993 2159 1955 2 2066 1 2228 MUX2S $T=438960 961520 0 0 $X=438960 $Y=961140
X3994 2168 2126 2 2203 1 2209 MUX2S $T=440820 931280 1 0 $X=440820 $Y=925860
X3995 2148 137 2 2217 1 2210 MUX2S $T=442680 941360 1 0 $X=442680 $Y=935940
X3996 2057 2077 2 2066 1 2227 MUX2S $T=442680 951440 0 0 $X=442680 $Y=951060
X3997 2127 2077 2 2228 1 2238 MUX2S $T=444540 971600 1 0 $X=444540 $Y=966180
X3998 2203 2126 2 2237 1 2226 MUX2S $T=446400 931280 1 0 $X=446400 $Y=925860
X3999 2236 2214 2 2250 1 2255 MUX2S $T=448880 951440 0 0 $X=448880 $Y=951060
X4000 2242 2214 2 2236 1 2266 MUX2S $T=450740 971600 1 0 $X=450740 $Y=966180
X4001 2247 1796 2 2255 1 2278 MUX2S $T=451360 981680 0 0 $X=451360 $Y=981300
X4002 2237 2126 2 2275 1 2280 MUX2S $T=452600 931280 1 0 $X=452600 $Y=925860
X4003 2255 1796 2 2276 1 2282 MUX2S $T=452600 971600 0 0 $X=452600 $Y=971220
X4004 2250 2214 2 2264 1 2283 MUX2S $T=453220 961520 1 0 $X=453220 $Y=956100
X4005 2266 1796 2 2283 1 2308 MUX2S $T=456940 981680 0 0 $X=456940 $Y=981300
X4006 2275 2126 2 2304 1 2322 MUX2S $T=458180 931280 1 0 $X=458180 $Y=925860
X4007 2276 1796 2 2292 1 2310 MUX2S $T=458800 971600 0 0 $X=458800 $Y=971220
X4008 2278 2296 2 2310 1 2325 MUX2S $T=458800 991760 1 0 $X=458800 $Y=986340
X4009 2324 2214 2 2298 1 2292 MUX2S $T=463760 961520 0 180 $X=459420 $Y=956100
X4010 2283 1796 2 2312 1 2326 MUX2S $T=459420 981680 1 0 $X=459420 $Y=976260
X4011 2292 1796 2 2319 1 2329 MUX2S $T=460040 961520 0 0 $X=460040 $Y=961140
X4012 2226 2153 2 2322 1 2327 MUX2S $T=460660 931280 0 0 $X=460660 $Y=930900
X4013 2297 2214 2 2324 1 2312 MUX2S $T=461280 951440 0 0 $X=461280 $Y=951060
X4014 2248 2296 2 2282 1 2348 MUX2S $T=461280 991760 0 0 $X=461280 $Y=991380
X4015 2317 2126 2 2332 1 2344 MUX2S $T=462520 921200 1 0 $X=462520 $Y=915780
X4016 2304 2126 2 2317 1 2341 MUX2S $T=462520 921200 0 0 $X=462520 $Y=920820
X4017 2308 2296 2 2333 1 2342 MUX2S $T=462520 981680 0 0 $X=462520 $Y=981300
X4018 2322 2153 2 2344 1 2353 MUX2S $T=464380 931280 1 0 $X=464380 $Y=925860
X4019 2282 2296 2 2329 1 2350 MUX2S $T=464380 971600 1 0 $X=464380 $Y=966180
X4020 2298 2214 2 2345 1 2346 MUX2S $T=465000 961520 1 0 $X=465000 $Y=956100
X4021 2312 1796 2 2346 1 2333 MUX2S $T=465000 981680 1 0 $X=465000 $Y=976260
X4022 2310 2296 2 2347 1 2362 MUX2S $T=465000 991760 1 0 $X=465000 $Y=986340
X4023 2319 1796 2 2354 1 2347 MUX2S $T=466240 961520 0 0 $X=466240 $Y=961140
X4024 2332 2126 2 2366 1 2373 MUX2S $T=468100 921200 0 0 $X=468100 $Y=920820
X4025 2345 2214 2 2368 1 2319 MUX2S $T=468100 951440 0 0 $X=468100 $Y=951060
X4026 2333 2296 2 2369 1 2378 MUX2S $T=468100 981680 0 0 $X=468100 $Y=981300
X4027 2281 2296 2 2326 1 2377 MUX2S $T=468100 1001840 1 0 $X=468100 $Y=996420
X4028 2326 2296 2 2374 1 2381 MUX2S $T=469340 991760 0 0 $X=469340 $Y=991380
X4029 2280 2153 2 2341 1 2386 MUX2S $T=469960 931280 1 0 $X=469960 $Y=925860
X4030 2364 1796 2 2372 1 2369 MUX2S $T=470580 971600 1 0 $X=470580 $Y=966180
X4031 2217 137 2 2353 1 2395 MUX2S $T=471200 931280 0 0 $X=471200 $Y=930900
X4032 2396 2214 2 2372 1 2354 MUX2S $T=475540 961520 0 180 $X=471200 $Y=956100
X4033 2346 1796 2 2364 1 2374 MUX2S $T=471200 981680 1 0 $X=471200 $Y=976260
X4034 2347 2296 2 2372 1 2397 MUX2S $T=471200 991760 1 0 $X=471200 $Y=986340
X4035 2385 2126 2 2367 1 2371 MUX2S $T=476160 911120 0 180 $X=471820 $Y=905700
X4036 2366 2126 2 2385 1 2391 MUX2S $T=471820 921200 1 0 $X=471820 $Y=915780
X4037 2354 1796 2 2372 1 2398 MUX2S $T=472440 961520 0 0 $X=472440 $Y=961140
X4038 2367 2126 2 2356 1 2402 MUX2S $T=473060 901040 0 0 $X=473060 $Y=900660
X4039 2340 2328 2 2378 1 2411 MUX2S $T=473680 1001840 1 0 $X=473680 $Y=996420
X4040 2368 2214 2 2396 1 2364 MUX2S $T=474300 951440 0 0 $X=474300 $Y=951060
X4041 2369 2296 2 2372 1 2410 MUX2S $T=474300 981680 0 0 $X=474300 $Y=981300
X4042 2299 2328 2 2362 1 2413 MUX2S $T=474920 1011920 0 0 $X=474920 $Y=1011540
X4043 2374 2296 2 2372 1 2423 MUX2S $T=475540 991760 0 0 $X=475540 $Y=991380
X4044 2295 2328 2 2381 1 2418 MUX2S $T=475540 1022000 1 0 $X=475540 $Y=1016580
X4045 2341 2153 2 2373 1 2420 MUX2S $T=476160 931280 1 0 $X=476160 $Y=925860
X4046 2398 2296 2 2372 1 2422 MUX2S $T=476160 971600 1 0 $X=476160 $Y=966180
X4047 2329 2296 2 2398 1 2430 MUX2S $T=476780 981680 1 0 $X=476780 $Y=976260
X4048 2356 2126 2 2419 1 2452 MUX2S $T=477400 911120 0 0 $X=477400 $Y=910740
X4049 2325 2328 2 2397 1 2433 MUX2S $T=477400 991760 1 0 $X=477400 $Y=986340
X4050 2344 2153 2 2391 1 2437 MUX2S $T=478020 921200 1 0 $X=478020 $Y=915780
X4051 2373 2153 2 2371 1 2442 MUX2S $T=479260 921200 0 0 $X=479260 $Y=920820
X4052 2342 2328 2 2410 1 2445 MUX2S $T=479880 981680 0 0 $X=479880 $Y=981300
X4053 2377 2328 2 2423 1 2446 MUX2S $T=479880 1001840 1 0 $X=479880 $Y=996420
X4054 2314 2328 2 2350 1 2449 MUX2S $T=480500 1011920 0 0 $X=480500 $Y=1011540
X4055 2353 2409 2 2444 1 2462 MUX2S $T=481740 931280 1 0 $X=481740 $Y=925860
X4056 2362 2328 2 2372 1 2464 MUX2S $T=481740 991760 0 0 $X=481740 $Y=991380
X4057 2350 2328 2 2422 1 2463 MUX2S $T=482360 971600 1 0 $X=482360 $Y=966180
X4058 2419 2126 2 2408 1 2456 MUX2S $T=482980 901040 0 0 $X=482980 $Y=900660
X4059 2430 2328 2 2372 1 2473 MUX2S $T=482980 971600 0 0 $X=482980 $Y=971220
X4060 2391 2153 2 2402 1 2444 MUX2S $T=484220 921200 1 0 $X=484220 $Y=915780
X4061 2371 2153 2 2452 1 2489 MUX2S $T=485460 921200 0 0 $X=485460 $Y=920820
X4062 2378 2328 2 2372 1 2475 MUX2S $T=485460 981680 0 0 $X=485460 $Y=981300
X4063 2348 2328 2 2430 1 2483 MUX2S $T=486080 1001840 1 0 $X=486080 $Y=996420
X4064 2327 2409 2 2437 1 2484 MUX2S $T=486700 931280 0 0 $X=486700 $Y=930900
X4065 2386 2409 2 2442 1 2514 MUX2S $T=487940 931280 1 0 $X=487940 $Y=925860
X4066 2210 2400 2 2462 1 2497 MUX2S $T=488560 941360 1 0 $X=488560 $Y=935940
X4067 2444 2409 2 2495 1 2504 MUX2S $T=489800 911120 0 0 $X=489800 $Y=910740
X4068 2437 2409 2 2465 1 2505 MUX2S $T=490420 921200 1 0 $X=490420 $Y=915780
X4069 2286 2409 2 2420 1 2519 MUX2S $T=492280 931280 0 0 $X=492280 $Y=930900
X4070 2420 2409 2 2489 1 2524 MUX2S $T=493520 921200 0 0 $X=493520 $Y=920820
X4071 2504 2400 2 2408 1 2534 MUX2S $T=495380 901040 0 0 $X=495380 $Y=900660
X4072 2495 2409 2 2408 1 2544 MUX2S $T=495380 911120 1 0 $X=495380 $Y=905700
X4073 2442 2409 2 2531 1 2540 MUX2S $T=496620 921200 1 0 $X=496620 $Y=915780
X4074 2395 2400 2 2504 1 2554 MUX2S $T=497860 931280 1 0 $X=497860 $Y=925860
X4075 2489 2409 2 2408 1 2560 MUX2S $T=500340 921200 0 0 $X=500340 $Y=920820
X4076 2519 2400 2 2560 1 2569 MUX2S $T=500340 941360 1 0 $X=500340 $Y=935940
X4077 2540 2400 2 2408 1 2577 MUX2S $T=501580 901040 0 0 $X=501580 $Y=900660
X4078 2531 2409 2 2408 1 2572 MUX2S $T=501580 911120 0 0 $X=501580 $Y=910740
X4079 2462 2400 2 2544 1 2600 MUX2S $T=502200 911120 1 0 $X=502200 $Y=905700
X4080 2465 2409 2 2408 1 2581 MUX2S $T=502820 921200 1 0 $X=502820 $Y=915780
X4081 2443 2400 2 2540 1 2587 MUX2S $T=504060 931280 1 0 $X=504060 $Y=925860
X4082 2337 2400 2 2524 1 2595 MUX2S $T=505920 941360 0 0 $X=505920 $Y=940980
X4083 2484 2400 2 2581 1 2601 MUX2S $T=506540 921200 0 0 $X=506540 $Y=920820
X4084 2361 2400 2 2505 1 2599 MUX2S $T=506540 941360 1 0 $X=506540 $Y=935940
X4085 2505 2400 2 2408 1 2609 MUX2S $T=507780 901040 0 0 $X=507780 $Y=900660
X4086 2514 2400 2 2572 1 2611 MUX2S $T=508400 921200 1 0 $X=508400 $Y=915780
X4087 246 242 2 2856 1 2860 MUX2S $T=556140 870800 0 0 $X=556140 $Y=870420
X4088 2852 242 2 2862 1 2865 MUX2S $T=557380 1001840 1 0 $X=557380 $Y=996420
X4089 240 242 2 2855 1 2881 MUX2S $T=559240 880880 1 0 $X=559240 $Y=875460
X4090 2863 242 2 2852 1 2875 MUX2S $T=560480 931280 0 0 $X=560480 $Y=930900
X4091 2855 242 2 2880 1 2888 MUX2S $T=566060 890960 0 0 $X=566060 $Y=890580
X4092 2847 242 2 2892 1 2896 MUX2S $T=568540 901040 1 0 $X=568540 $Y=895620
X4093 2880 242 2 2891 1 2876 MUX2S $T=575980 941360 1 180 $X=571640 $Y=940980
X4094 2892 242 2 2897 1 2877 MUX2S $T=577220 961520 1 180 $X=572880 $Y=961140
X4095 2893 242 2 2885 1 2886 MUX2S $T=577220 971600 0 180 $X=572880 $Y=966180
X4096 103 104 2 1 1580 98 MUX2 $T=346580 870800 1 180 $X=342240 $Y=870420
X4097 1678 1682 2 1 1572 1661 MUX2 $T=349060 901040 0 180 $X=344720 $Y=895620
X4098 1681 1643 2 1 1585 1711 MUX2 $T=350300 890960 0 0 $X=350300 $Y=890580
X4099 1683 1682 2 1 1629 1715 MUX2 $T=350300 901040 1 0 $X=350300 $Y=895620
X4100 1672 1693 2 1 1503 1726 MUX2 $T=353400 880880 0 0 $X=353400 $Y=880500
X4101 1724 1682 2 1 1674 1706 MUX2 $T=357740 901040 1 180 $X=353400 $Y=900660
X4102 1734 1693 2 1 1732 1742 MUX2 $T=358980 890960 0 0 $X=358980 $Y=890580
X4103 1546 1682 2 1 1735 1754 MUX2 $T=359600 901040 0 0 $X=359600 $Y=900660
X4104 123 1702 2 1 1761 133 MUX2 $T=363940 880880 1 0 $X=363940 $Y=875460
X4105 1742 1693 2 1 1762 1761 MUX2 $T=369520 890960 0 180 $X=365180 $Y=885540
X4106 1762 1643 2 1 1661 1778 MUX2 $T=365180 901040 0 0 $X=365180 $Y=900660
X4107 131 104 2 1 1783 135 MUX2 $T=367660 870800 0 0 $X=367660 $Y=870420
X4108 1732 1643 2 1 1621 1788 MUX2 $T=367660 901040 1 0 $X=367660 $Y=895620
X4109 133 1702 2 1 1794 139 MUX2 $T=369520 880880 1 0 $X=369520 $Y=875460
X4110 1761 1693 2 1 1788 1803 MUX2 $T=370140 880880 0 0 $X=370140 $Y=880500
X4111 1726 1693 2 1 1711 1794 MUX2 $T=370760 890960 0 0 $X=370760 $Y=890580
X4112 1503 1643 2 1 1608 1804 MUX2 $T=370760 901040 0 0 $X=370760 $Y=900660
X4113 139 142 2 1 1803 147 MUX2 $T=373860 870800 0 0 $X=373860 $Y=870420
X4114 1803 1693 2 1 1778 1821 MUX2 $T=375100 890960 1 0 $X=375100 $Y=885540
X4115 1794 1693 2 1 1804 1823 MUX2 $T=376960 890960 0 0 $X=376960 $Y=890580
X4116 1711 1813 2 1 1715 1830 MUX2 $T=377580 901040 1 0 $X=377580 $Y=895620
X4117 147 142 2 1 1823 148 MUX2 $T=383780 870800 1 180 $X=379440 $Y=870420
X4118 1824 1682 2 1 1718 1850 MUX2 $T=380680 901040 0 0 $X=380680 $Y=900660
X4119 1585 1682 2 1 1844 1856 MUX2 $T=382540 890960 0 0 $X=382540 $Y=890580
X4120 1884 126 2 1 1907 1909 MUX2 $T=391220 961520 0 0 $X=391220 $Y=961140
X4121 1885 126 2 1 1967 1884 MUX2 $T=391220 971600 0 0 $X=391220 $Y=971220
X4122 1892 126 2 1 1911 1891 MUX2 $T=392460 981680 0 0 $X=392460 $Y=981300
X4123 1909 1910 2 1 1953 1919 MUX2 $T=397420 961520 0 0 $X=397420 $Y=961140
X4124 1907 1917 2 1 1954 1949 MUX2 $T=397420 971600 1 0 $X=397420 $Y=966180
X4125 1919 1910 2 1 1949 1930 MUX2 $T=398040 961520 1 0 $X=398040 $Y=956100
X4126 1879 1917 2 1 1944 1907 MUX2 $T=405480 981680 0 180 $X=401140 $Y=976260
X4127 1934 1693 2 1 1951 1945 MUX2 $T=406720 880880 1 180 $X=402380 $Y=880500
X4128 1924 1917 2 1 1986 1879 MUX2 $T=403620 991760 0 0 $X=403620 $Y=991380
X4129 1967 1917 2 1 2010 1953 MUX2 $T=406720 971600 0 0 $X=406720 $Y=971220
X4130 1979 1955 2 1 2005 1944 MUX2 $T=406720 1001840 0 0 $X=406720 $Y=1001460
X4131 1971 1693 2 1 2011 1945 MUX2 $T=407340 880880 0 0 $X=407340 $Y=880500
X4132 1911 1917 2 1 2036 1967 MUX2 $T=407340 981680 1 0 $X=407340 $Y=976260
X4133 178 142 2 1 1971 1945 MUX2 $T=412300 880880 0 180 $X=407960 $Y=875460
X4134 1953 1917 2 1 2058 1958 MUX2 $T=409820 971600 1 0 $X=409820 $Y=966180
X4135 1986 1955 2 1 2041 1954 MUX2 $T=411060 991760 0 0 $X=411060 $Y=991380
X4136 2010 1955 2 1 2044 1990 MUX2 $T=412920 971600 0 0 $X=412920 $Y=971220
X4137 1944 1955 2 1 2045 1995 MUX2 $T=413540 981680 0 0 $X=413540 $Y=981300
X4138 1929 1682 2 1 2059 1945 MUX2 $T=416020 890960 0 0 $X=416020 $Y=890580
X4139 2036 1955 2 1 2074 2058 MUX2 $T=416640 991760 1 0 $X=416640 $Y=986340
X4140 2040 1955 2 1 2062 2036 MUX2 $T=417260 1001840 1 0 $X=417260 $Y=996420
X4141 2092 1917 2 1 2049 2066 MUX2 $T=425320 961520 0 180 $X=420980 $Y=956100
X4142 2043 1682 2 1 2104 1945 MUX2 $T=422840 880880 1 0 $X=422840 $Y=875460
X4143 2037 1682 2 1 2100 1945 MUX2 $T=422840 901040 1 0 $X=422840 $Y=895620
X4144 2005 2077 2 1 2098 2080 MUX2 $T=422840 1011920 1 0 $X=422840 $Y=1006500
X4145 2076 2077 2 1 2102 2074 MUX2 $T=423460 991760 0 0 $X=423460 $Y=991380
X4146 2028 2077 2 1 2103 2072 MUX2 $T=423460 1001840 1 0 $X=423460 $Y=996420
X4147 1962 1682 2 1 2114 1945 MUX2 $T=424080 890960 1 0 $X=424080 $Y=885540
X4148 1973 2077 2 1 2131 2045 MUX2 $T=426560 1001840 0 0 $X=426560 $Y=1001460
X4149 2060 150 2 1 2139 2136 MUX2 $T=427180 931280 0 0 $X=427180 $Y=930900
X4150 2112 1917 2 1 2134 2144 MUX2 $T=429040 951440 0 0 $X=429040 $Y=951060
X4151 2062 2077 2 1 2143 2085 MUX2 $T=429040 1011920 1 0 $X=429040 $Y=1006500
X4152 2003 2077 2 1 2145 2044 MUX2 $T=429660 1001840 1 0 $X=429660 $Y=996420
X4153 2136 150 2 1 2157 2168 MUX2 $T=432140 931280 1 0 $X=432140 $Y=925860
X4154 2144 1917 2 1 2159 2066 MUX2 $T=433380 961520 1 0 $X=433380 $Y=956100
X4155 2026 2077 2 1 2178 2127 MUX2 $T=435240 991760 1 0 $X=435240 $Y=986340
X4156 2130 1910 2 1 2144 2066 MUX2 $T=435860 951440 0 0 $X=435860 $Y=951060
X4157 2061 138 2 1 2185 2157 MUX2 $T=437100 931280 0 0 $X=437100 $Y=930900
X4158 2128 2077 2 1 2194 2066 MUX2 $T=437100 981680 1 0 $X=437100 $Y=976260
X4159 2191 1702 2 1 2220 2215 MUX2 $T=441440 991760 0 0 $X=441440 $Y=991380
X4160 2157 2153 2 1 2217 2226 MUX2 $T=442680 931280 0 0 $X=442680 $Y=930900
X4161 2215 1702 2 1 2244 2218 MUX2 $T=445780 981680 0 0 $X=445780 $Y=981300
X4162 2222 2214 2 1 2247 2242 MUX2 $T=446400 971600 0 0 $X=446400 $Y=971220
X4163 2220 1796 2 1 2229 2225 MUX2 $T=446400 1001840 1 0 $X=446400 $Y=996420
X4164 2225 1796 2 1 2248 2247 MUX2 $T=447020 991760 1 0 $X=447020 $Y=986340
X4165 2218 2214 2 1 2225 2231 MUX2 $T=447640 981680 1 0 $X=447640 $Y=976260
X4166 2139 2153 2 1 2256 2209 MUX2 $T=448260 931280 0 0 $X=448260 $Y=930900
X4167 2119 1796 2 1 2252 2244 MUX2 $T=449500 1001840 0 0 $X=449500 $Y=1001460
X4168 2244 1796 2 1 2279 2259 MUX2 $T=451980 991760 0 0 $X=451980 $Y=991380
X4169 2231 2214 2 1 2259 2222 MUX2 $T=457560 981680 0 180 $X=453220 $Y=976260
X4170 2259 1796 2 1 2281 2266 MUX2 $T=453220 991760 1 0 $X=453220 $Y=986340
X4171 2209 2153 2 1 2286 2280 MUX2 $T=454460 931280 0 0 $X=454460 $Y=930900
X4172 2264 2214 2 1 2276 2297 MUX2 $T=455080 951440 0 0 $X=455080 $Y=951060
X4173 2252 1643 2 1 2295 2281 MUX2 $T=455700 1011920 1 0 $X=455700 $Y=1006500
X4174 2229 1643 2 1 2299 2278 MUX2 $T=456320 1001840 0 0 $X=456320 $Y=1001460
X4175 2277 1643 2 1 2284 2279 MUX2 $T=456320 1011920 0 0 $X=456320 $Y=1011540
X4176 2164 137 2 1 2337 2286 MUX2 $T=460040 941360 0 0 $X=460040 $Y=940980
X4177 2302 1643 2 1 2314 2248 MUX2 $T=461280 1001840 0 0 $X=461280 $Y=1001460
X4178 2279 1643 2 1 2340 2308 MUX2 $T=461900 1001840 1 0 $X=461900 $Y=996420
X4179 2185 137 2 1 2361 2327 MUX2 $T=465000 931280 0 0 $X=465000 $Y=930900
X4180 2268 2328 2 1 2358 2299 MUX2 $T=465000 1022000 0 0 $X=465000 $Y=1021620
X4181 2221 2328 2 1 2383 2325 MUX2 $T=466860 1032080 1 0 $X=466860 $Y=1026660
X4182 2339 137 2 1 2172 2256 MUX2 $T=468100 941360 1 0 $X=468100 $Y=935940
X4183 2335 2328 2 1 2382 2340 MUX2 $T=469340 1022000 1 0 $X=469340 $Y=1016580
X4184 2300 2328 2 1 2393 2377 MUX2 $T=471200 1022000 0 0 $X=471200 $Y=1021620
X4185 2293 2400 2 1 2421 2361 MUX2 $T=476780 941360 1 0 $X=476780 $Y=935940
X4186 2284 2328 2 1 2438 2342 MUX2 $T=476780 1022000 0 0 $X=476780 $Y=1021620
X4187 2256 2409 2 1 2443 2386 MUX2 $T=480500 931280 0 0 $X=480500 $Y=930900
X4188 2313 2328 2 1 2447 2348 MUX2 $T=481120 1022000 1 0 $X=481120 $Y=1016580
X4189 2389 2400 2 1 2457 2443 MUX2 $T=482980 941360 1 0 $X=482980 $Y=935940
X4190 2402 2153 2 1 2465 2456 MUX2 $T=483600 911120 1 0 $X=483600 $Y=905700
X4191 2381 2328 2 1 2470 2372 MUX2 $T=483600 991760 1 0 $X=483600 $Y=986340
X4192 2249 2400 2 1 2492 2395 MUX2 $T=488560 941360 0 0 $X=488560 $Y=940980
X4193 2456 2153 2 1 2495 2408 MUX2 $T=489180 911120 1 0 $X=489180 $Y=905700
X4194 2172 2400 2 1 2526 2514 MUX2 $T=494140 941360 1 0 $X=494140 $Y=935940
X4195 2289 2400 2 1 2518 2519 MUX2 $T=494140 941360 0 0 $X=494140 $Y=940980
X4196 2452 2153 2 1 2531 2408 MUX2 $T=496000 911120 0 0 $X=496000 $Y=910740
X4197 1976 2400 2 1 2570 2484 MUX2 $T=499720 941360 0 0 $X=499720 $Y=940980
X4198 2524 2400 2 1 2612 2408 MUX2 $T=507780 911120 0 0 $X=507780 $Y=910740
X4199 251 242 2 1 2836 2847 MUX2 $T=553040 880880 1 0 $X=553040 $Y=875460
X4200 2837 242 2 1 2848 2863 MUX2 $T=566060 901040 0 180 $X=561720 $Y=895620
X4201 232 242 2 1 2869 2837 MUX2 $T=567300 870800 1 180 $X=562960 $Y=870420
X4202 2856 242 2 1 2900 2893 MUX2 $T=570400 890960 0 0 $X=570400 $Y=890580
X4203 1214 49 1307 2 1 58 1217 1214 49 1240 697 ICV_15 $T=275280 880880 0 0 $X=275280 $Y=880500
X4204 1785 1793 1787 2 1 1722 1787 1785 1793 127 697 ICV_15 $T=369520 1052240 1 0 $X=369520 $Y=1046820
X4205 1873 1880 1870 2 1 1782 1880 1873 1870 1849 697 ICV_15 $T=389360 1032080 1 0 $X=389360 $Y=1026660
X4206 1882 1896 1881 2 1 140 1881 1882 1896 1908 697 ICV_15 $T=389980 1052240 1 0 $X=389980 $Y=1046820
X4207 2265 2241 2245 2 1 217 2274 2269 2240 2288 697 ICV_15 $T=453840 880880 1 0 $X=453840 $Y=875460
X4208 2556 2542 2562 2 1 2657 2562 2556 2542 2579 697 ICV_15 $T=501580 1052240 1 0 $X=501580 $Y=1046820
X4209 2633 2537 2579 2 1 2732 2579 2633 2537 2655 697 ICV_15 $T=514600 1042160 0 0 $X=514600 $Y=1041780
X4210 2738 2584 2742 2 1 2783 2742 2738 2584 2749 697 ICV_15 $T=532580 981680 1 0 $X=532580 $Y=976260
X4211 2740 2616 2749 2 1 2772 2749 2740 2616 2746 697 ICV_15 $T=533820 971600 0 0 $X=533820 $Y=971220
X4212 2627 2761 2755 2 1 2784 2755 2627 2761 2666 697 ICV_15 $T=534440 931280 1 0 $X=534440 $Y=925860
X4213 2759 2614 2762 2 1 2786 2762 2759 2614 2742 697 ICV_15 $T=535680 981680 0 0 $X=535680 $Y=981300
X4214 2757 2578 2768 2 1 2802 2768 2757 2578 2762 697 ICV_15 $T=536300 991760 0 0 $X=536300 $Y=991380
X4215 2748 2602 2769 2 1 2814 2769 2748 2602 2768 697 ICV_15 $T=536300 1001840 1 0 $X=536300 $Y=996420
X4216 2642 2705 2686 2 1 2764 2781 2764 2772 2796 697 ICV_15 $T=538780 921200 1 0 $X=538780 $Y=915780
X4217 2784 2786 2790 2 1 2843 2790 2786 2784 2778 697 ICV_15 $T=540640 941360 0 0 $X=540640 $Y=940980
X4218 2774 2801 2798 2 1 2813 2798 2774 2801 2797 697 ICV_15 $T=542500 951440 1 0 $X=542500 $Y=946020
X4219 2795 2802 2799 2 1 2861 2799 2795 2802 2790 697 ICV_15 $T=542500 961520 1 0 $X=542500 $Y=956100
X4220 2813 2814 2816 2 1 2882 2816 2813 2814 2799 697 ICV_15 $T=550560 961520 0 0 $X=550560 $Y=961140
X4221 2788 2844 2835 2 1 2838 2835 2788 2844 2854 697 ICV_15 $T=553660 991760 1 0 $X=553660 $Y=986340
X4222 2695 2851 2839 2 1 2829 2839 2695 2851 2859 697 ICV_15 $T=554280 1011920 1 0 $X=554280 $Y=1006500
X4223 2838 2828 2845 2 1 2904 2845 2838 2828 2824 697 ICV_15 $T=554900 991760 0 0 $X=554900 $Y=991380
X4224 2840 2803 2846 2 1 2901 2846 2840 2803 2845 697 ICV_15 $T=554900 1011920 0 0 $X=554900 $Y=1011540
X4225 2747 2878 2859 2 1 2840 2859 2747 2878 2835 697 ICV_15 $T=562340 1001840 1 0 $X=562340 $Y=996420
X4226 2546 2576 2498 1 2 XOR2H $T=542500 951440 0 0 $X=542500 $Y=951060
X4227 1871 1887 1908 2 1 1866 XNR3 $T=389980 1062320 1 0 $X=389980 $Y=1056900
X4228 2287 2355 2363 2 1 2338 XNR3 $T=468100 1062320 1 0 $X=468100 $Y=1056900
X4229 2679 2516 2655 2 1 2688 XNR3 $T=533820 1032080 1 0 $X=533820 $Y=1026660
X4230 2741 2541 2714 2 1 2753 XNR3 $T=535680 1032080 0 0 $X=535680 $Y=1031700
X4231 2235 95 208 2 204 71 1 AO22S $T=448880 870800 1 180 $X=443920 $Y=870420
X4232 2273 95 211 2 210 71 1 AO22S $T=455080 870800 1 180 $X=450120 $Y=870420
X4233 2412 1665 2403 2 2059 1147 1 AO22S $T=480500 890960 0 180 $X=475540 $Y=885540
X4234 2439 2432 2414 2 2190 1959 1 AO22S $T=484220 961520 0 180 $X=479260 $Y=956100
X4235 225 1665 2455 2 2114 1147 1 AO22S $T=489180 890960 0 180 $X=484220 $Y=885540
X4236 220 1665 2471 2 2100 1147 1 AO22S $T=491040 890960 1 180 $X=486080 $Y=890580
X4237 2499 2432 2487 2 2194 1959 1 AO22S $T=493520 961520 0 180 $X=488560 $Y=956100
X4238 2532 2432 2506 2 2238 1959 1 AO22S $T=499100 951440 1 180 $X=494140 $Y=951060
X4239 2584 2432 2539 2 2160 1959 1 AO22S $T=508400 981680 0 180 $X=503440 $Y=976260
X4240 2564 2432 2485 2 2227 1959 1 AO22S $T=513360 951440 0 180 $X=508400 $Y=946020
X4241 2616 2432 2574 2 2124 1959 1 AO22S $T=513980 961520 1 180 $X=509020 $Y=961140
X4242 2694 2559 2660 2 2600 1820 1 AO22S $T=528240 901040 1 180 $X=523280 $Y=900660
X4243 1214 1167 1407 2 1415 1147 1 AO22P $T=300080 911120 1 0 $X=300080 $Y=905700
X4244 1186 1167 1406 2 1422 1147 1 AO22P $T=300700 890960 0 0 $X=300700 $Y=890580
X4245 1196 66 67 2 68 71 1 AO22P $T=301940 870800 0 0 $X=301940 $Y=870420
X4246 1375 1505 1457 2 1517 1147 1 AO22P $T=314960 911120 1 0 $X=314960 $Y=905700
X4247 1809 128 1841 2 1853 1820 1 AO22P $T=381920 981680 0 0 $X=381920 $Y=981300
X4248 159 128 1859 2 1858 1820 1 AO22P $T=390600 1011920 1 180 $X=385020 $Y=1011540
X4249 1896 1899 1993 2 2019 1959 1 AO22P $T=409820 1042160 0 0 $X=409820 $Y=1041780
X4250 1871 1505 2133 2 2135 1936 1 AO22P $T=429040 1032080 0 0 $X=429040 $Y=1031700
X4251 214 128 2349 2 2357 1820 1 AO22P $T=466240 1011920 0 0 $X=466240 $Y=1011540
X4252 1883 137 1976 2230 1 2 MXL2H $T=450120 941360 1 0 $X=450120 $Y=935940
X4253 1123 1140 1147 1 2 1152 1082 1140 697 ICV_16 $T=266600 890960 0 0 $X=266600 $Y=890580
X4254 791 1319 971 1 2 1333 1316 732 697 ICV_16 $T=290780 951440 1 0 $X=290780 $Y=946020
X4255 764 1378 1028 1 2 1028 1390 863 697 ICV_16 $T=298220 931280 0 0 $X=298220 $Y=930900
X4256 1488 804 1506 1 2 1506 733 1512 697 ICV_16 $T=314960 931280 1 0 $X=314960 $Y=925860
X4257 1507 1427 1500 1 2 1507 1243 1506 697 ICV_16 $T=316820 931280 0 0 $X=316820 $Y=930900
X4258 1512 988 1526 1 2 1488 1301 1532 697 ICV_16 $T=318680 981680 0 0 $X=318680 $Y=981300
X4259 1029 1555 1554 1 2 26 1543 1562 697 ICV_16 $T=323020 1001840 1 0 $X=323020 $Y=996420
X4260 1532 781 1558 1 2 1558 1283 1526 697 ICV_16 $T=323640 971600 1 0 $X=323640 $Y=966180
X4261 1506 15 1557 1 2 1528 888 1592 697 ICV_16 $T=335420 971600 1 0 $X=335420 $Y=966180
X4262 1755 1758 1760 1 2 1760 1763 1753 697 ICV_16 $T=363320 1052240 0 0 $X=363320 $Y=1051860
X4263 1772 1775 1781 1 2 1782 1807 1772 697 ICV_16 $T=367660 1032080 0 0 $X=367660 $Y=1031700
X4264 1831 1839 128 1 2 1842 1846 1820 697 ICV_16 $T=381920 1001840 1 0 $X=381920 $Y=996420
X4265 1849 1860 1835 1 2 1849 1877 1843 697 ICV_16 $T=386260 1042160 0 0 $X=386260 $Y=1041780
X4266 1876 1879 1889 1 2 1891 1876 126 697 ICV_16 $T=390600 981680 1 0 $X=390600 $Y=976260
X4267 1923 1943 1917 1 2 1957 1960 1943 697 ICV_16 $T=400520 981680 0 0 $X=400520 $Y=981300
X4268 1921 1950 1899 1 2 1938 1961 1959 697 ICV_16 $T=400520 1032080 0 0 $X=400520 $Y=1031700
X4269 2009 2014 1899 1 2 2023 2030 1959 697 ICV_16 $T=411680 1052240 1 0 $X=411680 $Y=1046820
X4270 2027 2035 128 1 2 2039 2046 1820 697 ICV_16 $T=414160 1011920 1 0 $X=414160 $Y=1006500
X4271 2219 2221 2213 1 2 2229 2219 1769 697 ICV_16 $T=445780 1022000 1 0 $X=445780 $Y=1016580
X4272 1226 1223 1171 1202 2 1 MXL2HS $T=280240 901040 0 180 $X=274660 $Y=895620
X4273 1439 1466 1407 1456 2 1 MXL2HS $T=310000 901040 0 0 $X=310000 $Y=900660
X4274 1906 126 1912 1892 2 1 MXL2HS $T=398040 991760 0 0 $X=398040 $Y=991380
X4275 2004 1984 1992 1987 2 1 MXL2HS $T=412300 1022000 0 180 $X=406720 $Y=1016580
X4276 1942 138 2137 2139 2 1 MXL2HS $T=429040 941360 1 0 $X=429040 $Y=935940
X4277 2243 1796 2132 2220 2 1 MXL2HS $T=451360 1011920 1 180 $X=445780 $Y=1011540
X4278 1241 1461 1 1468 2 NR2T $T=306900 890960 0 0 $X=306900 $Y=890580
X4279 1842 1895 1 1845 2 NR2T $T=394320 941360 1 180 $X=389360 $Y=940980
X4280 1946 1933 1 1903 2 NR2T $T=403620 1011920 0 180 $X=398660 $Y=1006500
X4281 1938 1991 1 1903 2 NR2T $T=409820 1011920 0 180 $X=404860 $Y=1006500
X4282 2015 174 1 136 2 NR2T $T=406100 931280 0 0 $X=406100 $Y=930900
X4283 2187 174 1 120 2 NR2T $T=447020 991760 0 180 $X=442060 $Y=986340
X4284 1936 2110 2132 1 2 2022 OR3B1 $T=434000 1022000 1 0 $X=434000 $Y=1016580
X4285 1987 2 1984 2042 1 AN2B1S $T=412920 1022000 1 0 $X=412920 $Y=1016580
X4286 1936 1984 2 1992 1988 1505 1 AOI22H $T=405480 1011920 0 0 $X=405480 $Y=1011540
X4287 1147 1167 1130 1 2 1023 OA12 $T=279620 890960 1 180 $X=275900 $Y=890580
X4288 1138 1413 1514 1 2 1146 OA12 $T=320540 1022000 0 180 $X=316820 $Y=1016580
X4289 34 1239 1210 1 2 1664 OA12 $T=343480 1022000 0 0 $X=343480 $Y=1021620
X4290 1022 729 1680 1 2 1698 OA12 $T=349060 1001840 0 0 $X=349060 $Y=1001460
X4291 1936 1505 1925 1 2 1890 OA12 $T=399900 1022000 1 180 $X=396180 $Y=1021620
X4292 1780 121 1 1786 2 AN2S $T=368900 1022000 1 0 $X=368900 $Y=1016580
X4293 1765 121 1 1799 2 AN2S $T=370760 1001840 0 0 $X=370760 $Y=1001460
X4294 1811 1799 1 1806 2 AN2S $T=381300 1011920 0 0 $X=381300 $Y=1011540
X4295 1797 1800 1 1808 1827 2 OAI12H $T=375100 1011920 0 0 $X=375100 $Y=1011540
X4296 1797 1828 1 1809 1822 2 OAI12H $T=379440 1001840 0 0 $X=379440 $Y=1001460
X4297 1836 1820 1 1834 1773 1820 2 MOAI1H $T=385640 971600 0 180 $X=378200 $Y=966180
X4298 1806 1790 1 1817 2 OR2B1S $T=375100 1022000 1 0 $X=375100 $Y=1016580
X4299 1730 1666 110 136 1 2 4861 DFFSBN $T=360220 931280 0 0 $X=360220 $Y=930900
X4300 1759 1666 110 1819 1 2 4862 DFFSBN $T=367040 941360 0 0 $X=367040 $Y=940980
X4301 1646 1666 110 1810 1 2 4863 DFFSBN $T=367040 961520 1 0 $X=367040 $Y=956100
X4302 1557 1064 1729 1738 1 2 1746 AO13S $T=356500 961520 1 0 $X=356500 $Y=956100
X4303 116 110 1 2 INV4 $T=357740 1032080 0 180 $X=354640 $Y=1026660
X4304 748 723 718 1 2 701 AO12 $T=224440 981680 0 180 $X=220720 $Y=976260
X4305 800 781 763 1 2 756 AO12 $T=228780 1042160 1 180 $X=225060 $Y=1041780
X4306 834 789 976 1 2 986 AO12 $T=243660 1001840 1 0 $X=243660 $Y=996420
X4307 1582 1652 1598 1 2 1729 AO12 $T=352160 951440 0 0 $X=352160 $Y=951060
X4308 976 838 1235 1 2 1331 AN3S $T=289540 961520 1 0 $X=289540 $Y=956100
X4309 1498 55 946 1 2 1463 AN3S $T=347200 1011920 1 0 $X=347200 $Y=1006500
X4310 743 784 789 4 2 1 818 OA22S $T=225680 1011920 0 0 $X=225680 $Y=1011540
X4311 998 710 981 4 2 1 997 OA22S $T=253580 1011920 0 180 $X=249240 $Y=1006500
X4312 1074 1004 888 785 2 1 1038 OA22S $T=258540 1001840 0 180 $X=254200 $Y=996420
X4313 779 1437 4 804 2 1 1441 OA22S $T=320540 951440 0 180 $X=316200 $Y=946020
X4314 1696 15 55 1490 2 1 16 OA22S $T=343480 1022000 0 180 $X=339140 $Y=1016580
X4315 1553 1624 1535 2 1612 1 952 AO112 $T=337900 951440 0 180 $X=332940 $Y=946020
X4316 918 919 885 2 1 940 OR3 $T=238700 941360 1 0 $X=238700 $Y=935940
X4317 1121 774 1050 2 1 1365 OR3 $T=293260 961520 1 0 $X=293260 $Y=956100
X4318 894 819 1421 2 1 1409 OR3 $T=306280 961520 1 0 $X=306280 $Y=956100
X4319 1299 1529 1052 2 1 1604 OR3 $T=329220 1001840 1 0 $X=329220 $Y=996420
X4320 794 776 2 788 1 704 AN3B2S $T=230020 991760 0 180 $X=226300 $Y=986340
X4321 1054 1031 2 1010 1 1015 AN3B2S $T=257300 911120 1 180 $X=253580 $Y=910740
X4322 1048 839 2 886 1 1181 AN3B2S $T=269080 961520 0 0 $X=269080 $Y=961140
X4323 1458 1453 2 1446 1 1436 AN3B2S $T=310620 991760 0 180 $X=306900 $Y=986340
X4324 70 1396 2 1450 1 1440 AN3B2S $T=310620 1052240 1 180 $X=306900 $Y=1051860
X4325 1350 1392 2 1479 1 1484 AN3B2S $T=311240 991760 1 0 $X=311240 $Y=986340
X4326 822 1271 2 1092 1 1593 AN3B2S $T=327980 1011920 0 0 $X=327980 $Y=1011540
X4327 1468 1503 1272 1 2 AN2B1T $T=319300 890960 0 180 $X=313720 $Y=885540
X4328 52 1332 7 1301 2 1 1371 OA112S $T=291400 1042160 0 0 $X=291400 $Y=1041780
X4329 1106 1211 1201 2 1 1188 OR3S $T=277760 1052240 1 180 $X=274040 $Y=1051860
X4330 785 742 3 738 2 1 721 MAOI1S $T=226920 1032080 0 180 $X=221960 $Y=1026660
X4331 1074 1112 934 1099 2 1 1085 MAOI1S $T=265360 981680 0 180 $X=260400 $Y=976260
.ENDS
***************************************
.SUBCKT QDLHN CK D GND VCC Q
** N=6 EP=5 IP=0 FDC=0
.ENDS
***************************************
.SUBCKT XOR4 I1 I2 O I3 VCC GND I4
** N=8 EP=7 IP=0 FDC=0
.ENDS
***************************************
.SUBCKT AO12S B2 B1 A1 GND VCC O
** N=7 EP=6 IP=0 FDC=0
.ENDS
***************************************
.SUBCKT MXL2HP B S OB A GND VCC
** N=7 EP=6 IP=0 FDC=0
.ENDS
***************************************
.SUBCKT INV8 O I GND VCC
** N=5 EP=4 IP=0 FDC=0
.ENDS
***************************************
.SUBCKT OR2B1 B1 I1 GND VCC O
** N=6 EP=5 IP=0 FDC=0
.ENDS
***************************************
.SUBCKT BUF4 I O GND VCC
** N=5 EP=4 IP=0 FDC=0
.ENDS
***************************************
.SUBCKT ICV_18 1 2 3 4 5 6 7
** N=7 EP=7 IP=10 FDC=0
X0 1 2 3 4 DELB $T=0 0 0 0 $X=0 $Y=-380
X1 5 2 3 6 DELB $T=4960 0 0 0 $X=4960 $Y=-380
.ENDS
***************************************
.SUBCKT XOR3T I2 I1 I3 GND VCC O
** N=7 EP=6 IP=0 FDC=0
.ENDS
***************************************
.SUBCKT XNR2H I2 O I1 GND VCC
** N=6 EP=5 IP=0 FDC=0
.ENDS
***************************************
.SUBCKT XOR3P I2 I1 I3 O GND VCC
** N=7 EP=6 IP=0 FDC=0
.ENDS
***************************************
.SUBCKT AO13 B3 B2 B1 A1 GND VCC O
** N=8 EP=7 IP=0 FDC=0
.ENDS
***************************************
.SUBCKT OA13 B3 B2 B1 A1 VCC GND O
** N=8 EP=7 IP=0 FDC=0
.ENDS
***************************************
.SUBCKT MUXB2 S A B VCC EB O GND
** N=8 EP=7 IP=0 FDC=0
.ENDS
***************************************
.SUBCKT QDFFRBS D CK RB VCC GND Q
** N=7 EP=6 IP=0 FDC=0
.ENDS
***************************************
.SUBCKT AO12P B2 B1 A1 O GND VCC
** N=7 EP=6 IP=0 FDC=0
.ENDS
***************************************
.SUBCKT ICV_19 1 2 3 4 5 6 7 8 9 10 11 12 13 14 15 16 17 18 19 20
+ 21 22 23 24 25 26 27 28 29 30 31 32 33 34 35 36 37 38 39 40
+ 41 42 43 44 45 46 47 48 49 50 51 52 53 54 55 56 57 58 59 60
+ 61 62 63 64 65 66 67 68 69 70 71 72 73 74 75 76 77 78 79 80
+ 81 82 83 84 85 86 87 88 89 90 91 92 93 94 95 96 97 98 99 100
+ 101 102 103 104 105 106 107 108 109 110 111 112 113 114 115 116 117 118 119 120
+ 121 122 123 124 125 126 127 128 129 130 131 132 133 134 135 136 137 138 139 140
+ 141 142 143 144 145 146 147 148 149 150 151 152 153 154 155 156 157 158 159 160
+ 161 162 163 164 165 166 167 168 169 170 171 172 173 174 175 176 177 178 179 180
+ 181 182 183 184 185 186 187 188 189 190 191 192 193 194 195 196 197 198 199 200
+ 201 202 203 204 205 206 207 208 209 210 211 212 213 214 215 216 217 218 219 220
+ 221 222 223 224 225 226 227 228 229 230 231 232 233 234 235 236 237 238 239 240
+ 241 242 243 244 245 246 247 248 249 250 251 252 253 254 255 256 257 258 259 260
+ 261 262 263 264 265 266 267 268 269 270 271 272 273 274 275 276 277 278 279 280
+ 281 282 283 284 285 286 287 288 289 290 291 292 293 294 295 296 297 298 299 300
+ 301 302 303 304 305 306 307 308 309 310 311 312 313 314 315 316 317 318 319 320
+ 321 322 323 324 325 326 327 328 329 330 331 332 333 334 335 336 337 338 339 340
+ 341 342 343 344 345 346 347 348 349 350 351 352 353 354 355 356 357 358 359 360
+ 361 362 363 364 365 366 367 368 369 370 371 372 373 374 375 376 377 378 379 380
+ 381 382 383 384 385 386 387 388 389 390 391 392 393 394 395 396 397 398 399 400
+ 401 402 403 404 405 406 407 408 409 410 411 412 413 414 415 416 417 418 419 420
+ 421 422 423 424 425 426 427 428 429 430 431 432 433 434 435 436 437 438 439 440
+ 441 442 443 444 445 446 447 448 449 450 451 452 453 454 455 456 457 458 459 460
+ 461 462 463 464 465 466 467 468 469 470 471 472 473 474 475 476 477 478 479 480
+ 481 482 483 484 485 486 487 488 489 490 491 492 493 494 495 496 497 498 499 500
+ 501 502 503 504 505 506 507 508 509 510 511 512 513 514 515 516 517 518 519 520
+ 521 522 523 524 525 526 527 528 529 530 531 532 533 534 535 536 537 538 539 540
+ 541 542 543 544 545 546 547 548 549 550 551 552 553 554 555 556 557 558 559 560
+ 561 562 563 564 565 566 567 568 569 570 571 572 573 574 575 576 577 578 579 580
+ 581 582 583 584 585 586 587 588 589 590 591 592 593 594 595 596 597 598 599 600
+ 601 602 603 604 605 606 607 608 609 610 611 612 613 614 615 616 617 618 619 620
+ 621 622 623 624 625 626 627 628 629 630 631 632 633 634 635 636 637 638 639 640
+ 641 642 643 644 645 646 647 648 649 650 651 652 653 654 655 656 657 658 659 660
+ 661 662 663 664 665 666 667 668 669 670 671 672 673 674 675 676 677 678 679 680
+ 681 682 683 684 685 686 687 688 689 690 691 692 693 694 695 696 697 698 699 700
+ 701 702 703 704 705 706 707 708 709 710 711 712 713 714 715 716 717 718 719 720
+ 721 722 723 724 725 726 727 728 729 730 731 732 733 734 735 736 737 738 739 740
+ 741 742 743 744 745 746 747 748 749 750 751 752 753 754 755 756 757 758 759 760
+ 761 762 763 764 765 766 767 768 769 770 771 772 773 774 775 776 777 778 779 780
+ 781 782 783 784 785 786 787 788 789 790 791 792 793 794 795 796 797 798 799 800
+ 801 802 803 804 805 806 807 808 809 810 811 812 813 814 815 816 817 818 819 820
+ 821 822 823 824 825 826 827 828 829 830 831 832 833 834 835 836 837 838 839 840
+ 841 842 843 844 845 846 847 848 849 850 851 852 853 854 855 856 857 858 859 860
+ 861 862 863 864 865 866 867 868 869 870 871 872 873 874 875 876 877 878 879 880
+ 881 882 883 884 885 886 887 888 889 890 891 892 893 894 895 896 897 898 899 900
+ 901 902 903 904 905 906 907 908 909 910 911 912 913 914 915 916 917 918 919 920
+ 921 922 942
** N=4542 EP=923 IP=25170 FDC=0
X0 2754 443 2883 1 2 QDFFN $T=618760 780080 0 0 $X=618760 $Y=779700
X1 399 443 2897 1 2 QDFFN $T=623100 709520 1 0 $X=623100 $Y=704100
X2 2838 450 2908 1 2 QDFFN $T=624340 800240 0 0 $X=624340 $Y=799860
X3 2780 443 2934 1 2 QDFFN $T=629920 719600 1 0 $X=629920 $Y=714180
X4 2664 443 2913 1 2 QDFFN $T=629920 729680 1 0 $X=629920 $Y=724260
X5 2867 443 2901 1 2 QDFFN $T=629920 749840 0 0 $X=629920 $Y=749460
X6 2808 443 2902 1 2 QDFFN $T=631160 780080 0 0 $X=631160 $Y=779700
X7 417 443 2881 1 2 QDFFN $T=643560 709520 1 180 $X=633020 $Y=709140
X8 2889 450 2957 1 2 QDFFN $T=634880 790160 1 0 $X=634880 $Y=784740
X9 2862 450 2953 1 2 QDFFN $T=641080 800240 0 0 $X=641080 $Y=799860
X10 2657 443 2939 1 2 QDFFN $T=641700 729680 1 0 $X=641700 $Y=724260
X11 403 443 2931 1 2 QDFFN $T=642320 699440 0 0 $X=642320 $Y=699060
X12 2829 450 3001 1 2 QDFFN $T=644180 780080 0 0 $X=644180 $Y=779700
X13 466 443 2988 1 2 QDFFN $T=646040 709520 0 0 $X=646040 $Y=709140
X14 2982 487 3051 1 2 QDFFN $T=651000 800240 1 0 $X=651000 $Y=794820
X15 2986 487 3072 1 2 QDFFN $T=655960 790160 1 0 $X=655960 $Y=784740
X16 3019 487 3085 1 2 QDFFN $T=659680 800240 0 0 $X=659680 $Y=799860
X17 3005 487 3084 1 2 QDFFN $T=660300 780080 0 0 $X=660300 $Y=779700
X18 3013 487 3129 1 2 QDFFN $T=672080 800240 0 0 $X=672080 $Y=799860
X19 536 533 3134 1 2 QDFFN $T=688200 699440 0 180 $X=677660 $Y=694020
X20 3081 487 3195 1 2 QDFFN $T=684480 780080 0 0 $X=684480 $Y=779700
X21 2955 487 3178 1 2 QDFFN $T=684480 800240 0 0 $X=684480 $Y=799860
X22 556 487 3290 1 2 QDFFN $T=699360 719600 1 0 $X=699360 $Y=714180
X23 503 487 3313 1 2 QDFFN $T=704320 709520 1 0 $X=704320 $Y=704100
X24 3291 487 3327 1 2 QDFFN $T=708660 729680 1 0 $X=708660 $Y=724260
X25 585 487 3372 1 2 QDFFN $T=718580 699440 1 0 $X=718580 $Y=694020
X26 589 487 3374 1 2 QDFFN $T=722920 739760 1 0 $X=722920 $Y=734340
X27 574 487 3335 1 2 QDFFN $T=724160 719600 0 0 $X=724160 $Y=719220
X28 3353 487 3341 1 2 QDFFN $T=725400 709520 0 0 $X=725400 $Y=709140
X29 608 614 3382 1 2 QDFFN $T=742760 800240 0 180 $X=732220 $Y=794820
X30 608 613 3430 1 2 QDFFN $T=737800 790160 0 0 $X=737800 $Y=789780
X31 623 533 3342 1 2 QDFFN $T=748960 699440 0 180 $X=738420 $Y=694020
X32 608 617 3449 1 2 QDFFN $T=740900 780080 0 0 $X=740900 $Y=779700
X33 608 619 3450 1 2 QDFFN $T=744000 800240 1 0 $X=744000 $Y=794820
X34 579 614 3498 1 2 QDFFN $T=753920 810320 0 0 $X=753920 $Y=809940
X35 579 619 3506 1 2 QDFFN $T=754540 810320 1 0 $X=754540 $Y=804900
X36 608 636 3517 1 2 QDFFN $T=755780 770000 1 0 $X=755780 $Y=764580
X37 625 613 3472 1 2 QDFFN $T=767560 780080 1 180 $X=757020 $Y=779700
X38 579 613 3528 1 2 QDFFN $T=760120 820400 1 0 $X=760120 $Y=814980
X39 641 613 3540 1 2 QDFFN $T=760740 840560 1 0 $X=760740 $Y=835140
X40 625 619 3470 1 2 QDFFN $T=775620 790160 1 180 $X=765080 $Y=789780
X41 625 616 3521 1 2 QDFFN $T=778100 780080 1 180 $X=767560 $Y=779700
X42 649 616 3571 1 2 QDFFN $T=768800 790160 1 0 $X=768800 $Y=784740
X43 641 636 3582 1 2 QDFFN $T=770660 850640 1 0 $X=770660 $Y=845220
X44 641 614 3542 1 2 QDFFN $T=781820 840560 0 180 $X=771280 $Y=835140
X45 658 617 3601 1 2 QDFFN $T=772520 860720 0 0 $X=772520 $Y=860340
X46 649 618 3590 1 2 QDFFN $T=773140 770000 0 0 $X=773140 $Y=769620
X47 579 616 3584 1 2 QDFFN $T=773140 800240 0 0 $X=773140 $Y=799860
X48 579 617 3587 1 2 QDFFN $T=773140 820400 1 0 $X=773140 $Y=814980
X49 579 618 3575 1 2 QDFFN $T=775620 790160 0 0 $X=775620 $Y=789780
X50 641 618 3589 1 2 QDFFN $T=775620 850640 0 0 $X=775620 $Y=850260
X51 649 636 3600 1 2 QDFFN $T=776860 770000 1 0 $X=776860 $Y=764580
X52 641 617 3615 1 2 QDFFN $T=777480 830480 1 0 $X=777480 $Y=825060
X53 649 617 3583 1 2 QDFFN $T=778100 780080 0 0 $X=778100 $Y=779700
X54 625 636 3551 1 2 QDFFN $T=778720 759920 1 0 $X=778720 $Y=754500
X55 658 616 3611 1 2 QDFFN $T=779340 860720 1 0 $X=779340 $Y=855300
X56 641 619 3562 1 2 QDFFN $T=781820 840560 1 0 $X=781820 $Y=835140
X57 641 616 3625 1 2 QDFFN $T=784920 820400 1 0 $X=784920 $Y=814980
X58 672 617 3641 1 2 QDFFN $T=786160 850640 0 0 $X=786160 $Y=850260
X59 681 617 3646 1 2 QDFFN $T=788640 770000 0 0 $X=788640 $Y=769620
X60 658 619 3642 1 2 QDFFN $T=789260 860720 0 0 $X=789260 $Y=860340
X61 672 619 3628 1 2 QDFFN $T=802900 840560 0 180 $X=792360 $Y=835140
X62 609 617 3656 1 2 QDFFN $T=792980 830480 1 0 $X=792980 $Y=825060
X63 609 616 3683 1 2 QDFFN $T=796700 820400 1 0 $X=796700 $Y=814980
X64 672 636 3687 1 2 QDFFN $T=799180 860720 1 0 $X=799180 $Y=855300
X65 672 618 3694 1 2 QDFFN $T=800420 850640 0 0 $X=800420 $Y=850260
X66 609 618 3700 1 2 QDFFN $T=802900 840560 1 0 $X=802900 $Y=835140
X67 659 618 3709 1 2 QDFFN $T=805380 810320 0 0 $X=805380 $Y=809940
X68 658 614 3650 1 2 QDFFN $T=805380 860720 0 0 $X=805380 $Y=860340
X69 609 636 3718 1 2 QDFFN $T=809100 830480 1 0 $X=809100 $Y=825060
X70 677 618 3725 1 2 QDFFN $T=810960 780080 0 0 $X=810960 $Y=779700
X71 659 636 3728 1 2 QDFFN $T=815300 820400 1 0 $X=815300 $Y=814980
X72 681 636 3739 1 2 QDFFN $T=815920 770000 1 0 $X=815920 $Y=764580
X73 677 636 3735 1 2 QDFFN $T=817160 780080 1 0 $X=817160 $Y=774660
X74 681 619 3691 1 2 QDFFN $T=818400 790160 0 0 $X=818400 $Y=789780
X75 609 614 3729 1 2 QDFFN $T=831420 830480 1 180 $X=820880 $Y=830100
X76 659 613 3746 1 2 QDFFN $T=825840 830480 1 0 $X=825840 $Y=825060
X77 677 614 3779 1 2 QDFFN $T=827080 800240 1 0 $X=827080 $Y=794820
X78 677 613 3783 1 2 QDFFN $T=828940 780080 0 0 $X=828940 $Y=779700
X79 716 726 3776 1 2 QDFFN $T=830180 850640 0 0 $X=830180 $Y=850260
X80 609 619 3740 1 2 QDFFN $T=830800 840560 0 0 $X=830800 $Y=840180
X81 659 619 3800 1 2 QDFFN $T=832660 820400 1 0 $X=832660 $Y=814980
X82 677 619 3791 1 2 QDFFN $T=839480 790160 0 0 $X=839480 $Y=789780
X83 716 738 3820 1 2 QDFFN $T=840720 860720 0 0 $X=840720 $Y=860340
X84 716 753 3850 1 2 QDFFN $T=848160 860720 1 0 $X=848160 $Y=855300
X85 760 3841 3884 1 2 QDFFN $T=854360 719600 0 0 $X=854360 $Y=719220
X86 773 3841 3837 1 2 QDFFN $T=864900 729680 1 180 $X=854360 $Y=729300
X87 754 3841 3882 1 2 QDFFN $T=854360 770000 0 0 $X=854360 $Y=769620
X88 758 3862 3885 1 2 QDFFN $T=857460 759920 0 0 $X=857460 $Y=759540
X89 775 3841 3861 1 2 QDFFN $T=869240 739760 1 180 $X=858700 $Y=739380
X90 770 3841 3896 1 2 QDFFN $T=860560 749840 0 0 $X=860560 $Y=749460
X91 754 3862 3903 1 2 QDFFN $T=861180 780080 1 0 $X=861180 $Y=774660
X92 773 3862 3914 1 2 QDFFN $T=861800 729680 1 0 $X=861800 $Y=724260
X93 763 3841 3900 1 2 QDFFN $T=861800 790160 0 0 $X=861800 $Y=789780
X94 785 3841 3880 1 2 QDFFN $T=874200 800240 0 180 $X=863660 $Y=794820
X95 775 3862 3905 1 2 QDFFN $T=864280 739760 1 0 $X=864280 $Y=734340
X96 774 3841 3908 1 2 QDFFN $T=864280 759920 1 0 $X=864280 $Y=754500
X97 776 3862 3926 1 2 QDFFN $T=866140 719600 1 0 $X=866140 $Y=714180
X98 779 3841 3966 1 2 QDFFN $T=866760 800240 0 0 $X=866760 $Y=799860
X99 759 3841 3923 1 2 QDFFN $T=866760 810320 0 0 $X=866760 $Y=809940
X100 776 3841 3920 1 2 QDFFN $T=867380 719600 0 0 $X=867380 $Y=719220
X101 750 3841 3925 1 2 QDFFN $T=867380 790160 1 0 $X=867380 $Y=784740
X102 780 738 790 1 2 QDFFN $T=870480 870800 1 0 $X=870480 $Y=865380
X103 763 3862 3955 1 2 QDFFN $T=873580 790160 0 0 $X=873580 $Y=789780
X104 780 726 3949 1 2 QDFFN $T=873580 850640 1 0 $X=873580 $Y=845220
X105 778 738 3952 1 2 QDFFN $T=874200 860720 0 0 $X=874200 $Y=860340
X106 750 3862 3959 1 2 QDFFN $T=874820 780080 1 0 $X=874820 $Y=774660
X107 780 710 3944 1 2 QDFFN $T=874820 830480 0 0 $X=874820 $Y=830100
X108 778 710 3943 1 2 QDFFN $T=874820 840560 1 0 $X=874820 $Y=835140
X109 785 3862 3972 1 2 QDFFN $T=876680 800240 1 0 $X=876680 $Y=794820
X110 760 3862 3961 1 2 QDFFN $T=877920 709520 0 0 $X=877920 $Y=709140
X111 758 3915 3928 1 2 QDFFN $T=889080 759920 0 180 $X=878540 $Y=754500
X112 779 3862 3979 1 2 QDFFN $T=878540 810320 1 0 $X=878540 $Y=804900
X113 759 3862 3980 1 2 QDFFN $T=879160 810320 0 0 $X=879160 $Y=809940
X114 775 3915 3982 1 2 QDFFN $T=879780 739760 1 0 $X=879780 $Y=734340
X115 773 3915 3998 1 2 QDFFN $T=880400 719600 0 0 $X=880400 $Y=719220
X116 779 3915 4013 1 2 QDFFN $T=883500 830480 1 0 $X=883500 $Y=825060
X117 754 3996 3960 1 2 QDFFN $T=896520 770000 0 180 $X=885980 $Y=764580
X118 778 795 4014 1 2 QDFFN $T=885980 860720 0 0 $X=885980 $Y=860340
X119 769 710 3970 1 2 QDFFN $T=897760 840560 0 180 $X=887220 $Y=835140
X120 754 3915 4017 1 2 QDFFN $T=887840 780080 1 0 $X=887840 $Y=774660
X121 763 3996 3975 1 2 QDFFN $T=899000 790160 0 180 $X=888460 $Y=784740
X122 758 3996 3983 1 2 QDFFN $T=899620 759920 0 180 $X=889080 $Y=754500
X123 769 726 3973 1 2 QDFFN $T=900240 840560 1 180 $X=889700 $Y=840180
X124 776 3996 4035 1 2 QDFFN $T=890320 709520 1 0 $X=890320 $Y=704100
X125 776 3915 4027 1 2 QDFFN $T=891560 709520 0 0 $X=891560 $Y=709140
X126 785 3915 4039 1 2 QDFFN $T=891560 800240 1 0 $X=891560 $Y=794820
X127 779 3996 3995 1 2 QDFFN $T=902100 820400 0 180 $X=891560 $Y=814980
X128 769 805 4032 1 2 QDFFN $T=891560 860720 1 0 $X=891560 $Y=855300
X129 778 805 4037 1 2 QDFFN $T=892800 870800 1 0 $X=892800 $Y=865380
X130 763 4038 4007 1 2 QDFFN $T=905200 830480 1 180 $X=894660 $Y=830100
X131 785 3996 4056 1 2 QDFFN $T=897140 800240 0 0 $X=897140 $Y=799860
X132 759 3915 4040 1 2 QDFFN $T=897140 830480 1 0 $X=897140 $Y=825060
X133 789 3996 4057 1 2 QDFFN $T=897760 749840 1 0 $X=897760 $Y=744420
X134 789 3915 4060 1 2 QDFFN $T=899620 759920 1 0 $X=899620 $Y=754500
X135 785 4038 4061 1 2 QDFFN $T=899620 840560 1 0 $X=899620 $Y=835140
X136 775 3996 4021 1 2 QDFFN $T=910780 739760 0 180 $X=900240 $Y=734340
X137 773 3996 4020 1 2 QDFFN $T=911400 719600 1 180 $X=900860 $Y=719220
X138 784 3915 4074 1 2 QDFFN $T=901480 729680 0 0 $X=901480 $Y=729300
X139 769 795 4029 1 2 QDFFN $T=912640 860720 0 180 $X=902100 $Y=855300
X140 774 3915 4070 1 2 QDFFN $T=902720 770000 1 0 $X=902720 $Y=764580
X141 750 3996 4073 1 2 QDFFN $T=902720 770000 0 0 $X=902720 $Y=769620
X142 760 3915 4088 1 2 QDFFN $T=903960 709520 1 0 $X=903960 $Y=704100
X143 759 3996 4048 1 2 QDFFN $T=915120 820400 0 180 $X=904580 $Y=814980
X144 759 4038 4083 1 2 QDFFN $T=904580 850640 1 0 $X=904580 $Y=845220
X145 780 795 806 1 2 QDFFN $T=915740 870800 0 180 $X=905200 $Y=865380
X146 802 3996 4086 1 2 QDFFN $T=905820 810320 0 0 $X=905820 $Y=809940
X147 769 812 4051 1 2 QDFFN $T=916360 860720 1 180 $X=905820 $Y=860340
X148 763 3915 4031 1 2 QDFFN $T=917600 790160 0 180 $X=907060 $Y=784740
X149 802 3841 4089 1 2 QDFFN $T=907680 810320 1 0 $X=907680 $Y=804900
X150 770 3996 4001 1 2 QDFFN $T=918840 749840 0 180 $X=908300 $Y=744420
X151 750 4038 4067 1 2 QDFFN $T=920080 830480 0 180 $X=909540 $Y=825060
X152 774 3996 4066 1 2 QDFFN $T=910160 759920 1 0 $X=910160 $Y=754500
X153 800 3915 4072 1 2 QDFFN $T=921320 739760 0 180 $X=910780 $Y=734340
X154 802 3862 4099 1 2 QDFFN $T=910780 800240 0 0 $X=910780 $Y=799860
X155 800 3996 4075 1 2 QDFFN $T=922560 729680 1 180 $X=912020 $Y=729300
X156 760 3996 4077 1 2 QDFFN $T=923180 699440 1 180 $X=912640 $Y=699060
X157 779 813 4141 1 2 QDFFN $T=913260 860720 1 0 $X=913260 $Y=855300
X158 774 4104 4081 1 2 QDFFN $T=924420 770000 0 180 $X=913880 $Y=764580
X159 784 3996 4080 1 2 QDFFN $T=925040 719600 1 180 $X=914500 $Y=719220
X160 770 4038 4113 1 2 QDFFN $T=914500 840560 0 0 $X=914500 $Y=840180
X161 802 3915 4091 1 2 QDFFN $T=927520 820400 0 180 $X=916980 $Y=814980
X162 754 4038 4106 1 2 QDFFN $T=916980 840560 1 0 $X=916980 $Y=835140
X163 774 4038 4114 1 2 QDFFN $T=916980 850640 1 0 $X=916980 $Y=845220
X164 776 4087 4130 1 2 QDFFN $T=917600 709520 1 0 $X=917600 $Y=704100
X165 750 3915 4076 1 2 QDFFN $T=928140 790160 0 180 $X=917600 $Y=784740
X166 785 4087 4117 1 2 QDFFN $T=917600 790160 0 0 $X=917600 $Y=789780
X167 778 812 4049 1 2 QDFFN $T=928140 870800 0 180 $X=917600 $Y=865380
X168 784 3862 4119 1 2 QDFFN $T=918220 729680 1 0 $X=918220 $Y=724260
X169 779 815 4122 1 2 QDFFN $T=918220 860720 0 0 $X=918220 $Y=860340
X170 784 3841 4136 1 2 QDFFN $T=918840 719600 1 0 $X=918840 $Y=714180
X171 789 3841 4108 1 2 QDFFN $T=918840 749840 1 0 $X=918840 $Y=744420
X172 800 3862 4148 1 2 QDFFN $T=921320 739760 1 0 $X=921320 $Y=734340
X173 759 4087 4143 1 2 QDFFN $T=921320 810320 0 0 $X=921320 $Y=809940
X174 800 3841 4145 1 2 QDFFN $T=922560 729680 0 0 $X=922560 $Y=729300
X175 779 4038 4096 1 2 QDFFN $T=933100 820400 1 180 $X=922560 $Y=820020
X176 802 4038 4149 1 2 QDFFN $T=923800 830480 0 0 $X=923800 $Y=830100
X177 770 817 4157 1 2 QDFFN $T=925040 850640 0 0 $X=925040 $Y=850260
X178 785 4104 4160 1 2 QDFFN $T=928140 790160 1 0 $X=928140 $Y=784740
X179 789 3862 4111 1 2 QDFFN $T=939920 749840 0 180 $X=929380 $Y=744420
X180 770 815 4164 1 2 QDFFN $T=929380 850640 1 0 $X=929380 $Y=845220
X181 779 823 820 1 2 QDFFN $T=940540 870800 0 180 $X=930000 $Y=865380
X182 776 4104 4142 1 2 QDFFN $T=941160 709520 0 180 $X=930620 $Y=704100
X183 774 4162 4135 1 2 QDFFN $T=941160 770000 0 180 $X=930620 $Y=764580
X184 779 4087 4140 1 2 QDFFN $T=941160 800240 1 180 $X=930620 $Y=799860
X185 776 4162 4144 1 2 QDFFN $T=941780 709520 1 180 $X=931240 $Y=709140
X186 779 4104 4146 1 2 QDFFN $T=942400 810320 1 180 $X=931860 $Y=809940
X187 759 4104 4150 1 2 QDFFN $T=944260 820400 1 180 $X=933720 $Y=820020
X188 770 813 4177 1 2 QDFFN $T=933720 840560 0 0 $X=933720 $Y=840180
X189 750 4104 4159 1 2 QDFFN $T=945500 780080 0 180 $X=934960 $Y=774660
X190 770 823 4152 1 2 QDFFN $T=945500 860720 0 180 $X=934960 $Y=855300
X191 775 4038 4171 1 2 QDFFN $T=935580 840560 1 0 $X=935580 $Y=835140
X192 773 4087 4168 1 2 QDFFN $T=950460 719600 0 180 $X=939920 $Y=714180
X193 763 4087 4202 1 2 QDFFN $T=941780 780080 0 0 $X=941780 $Y=779700
X194 779 4162 4155 1 2 QDFFN $T=952320 810320 0 180 $X=941780 $Y=804900
X195 759 4162 4170 1 2 QDFFN $T=952940 810320 1 180 $X=942400 $Y=809940
X196 754 4104 4205 1 2 QDFFN $T=943020 770000 0 0 $X=943020 $Y=769620
X197 802 4162 4209 1 2 QDFFN $T=943020 800240 0 0 $X=943020 $Y=799860
X198 779 831 837 1 2 QDFFN $T=943020 870800 1 0 $X=943020 $Y=865380
X199 785 4162 4163 1 2 QDFFN $T=954180 790160 1 180 $X=943640 $Y=789780
X200 773 4104 4175 1 2 QDFFN $T=954800 709520 1 180 $X=944260 $Y=709140
X201 770 4104 4208 1 2 QDFFN $T=944260 749840 1 0 $X=944260 $Y=744420
X202 754 4162 4206 1 2 QDFFN $T=945500 759920 0 0 $X=945500 $Y=759540
X203 758 4087 4176 1 2 QDFFN $T=956660 759920 0 180 $X=946120 $Y=754500
X204 800 4038 4214 1 2 QDFFN $T=946740 840560 0 0 $X=946740 $Y=840180
X205 758 4038 4220 1 2 QDFFN $T=947980 830480 0 0 $X=947980 $Y=830100
X206 773 4162 4190 1 2 QDFFN $T=959760 719600 1 180 $X=949220 $Y=719220
X207 750 4162 4191 1 2 QDFFN $T=962860 780080 1 180 $X=952320 $Y=779700
X208 789 4162 4224 1 2 QDFFN $T=952940 749840 0 0 $X=952940 $Y=749460
X209 763 4162 4226 1 2 QDFFN $T=952940 800240 1 0 $X=952940 $Y=794820
X210 784 4087 4230 1 2 QDFFN $T=953560 719600 1 0 $X=953560 $Y=714180
X211 770 842 4210 1 2 QDFFN $T=965340 860720 0 180 $X=954800 $Y=855300
X212 758 4162 4215 1 2 QDFFN $T=966580 759920 1 180 $X=956040 $Y=759540
X213 802 4087 4217 1 2 QDFFN $T=966580 800240 1 180 $X=956040 $Y=799860
X214 773 815 4237 1 2 QDFFN $T=956660 850640 1 0 $X=956660 $Y=845220
X215 773 4038 4240 1 2 QDFFN $T=957280 820400 0 0 $X=957280 $Y=820020
X216 760 4162 4254 1 2 QDFFN $T=958520 709520 0 0 $X=958520 $Y=709140
X217 800 4162 4251 1 2 QDFFN $T=959140 739760 1 0 $X=959140 $Y=734340
X218 776 4038 4242 1 2 QDFFN $T=959140 830480 0 0 $X=959140 $Y=830100
X219 784 4162 4246 1 2 QDFFN $T=959760 729680 0 0 $X=959760 $Y=729300
X220 754 4087 4218 1 2 QDFFN $T=959760 770000 0 0 $X=959760 $Y=769620
X221 773 817 4258 1 2 QDFFN $T=962240 850640 0 0 $X=962240 $Y=850260
X222 763 4104 4219 1 2 QDFFN $T=973400 780080 1 180 $X=962860 $Y=779700
X223 802 4104 4221 1 2 QDFFN $T=962860 810320 1 0 $X=962860 $Y=804900
X224 770 831 4223 1 2 QDFFN $T=964100 870800 1 0 $X=964100 $Y=865380
X225 773 813 4252 1 2 QDFFN $T=964720 840560 0 0 $X=964720 $Y=840180
X226 784 4038 4236 1 2 QDFFN $T=975880 810320 1 180 $X=965340 $Y=809940
X227 789 4104 4239 1 2 QDFFN $T=977120 759920 1 180 $X=966580 $Y=759540
X228 773 823 4264 1 2 QDFFN $T=967820 860720 1 0 $X=967820 $Y=855300
X229 789 4087 4234 1 2 QDFFN $T=980840 749840 1 180 $X=970300 $Y=749460
X230 760 4087 4244 1 2 QDFFN $T=981460 709520 1 180 $X=970920 $Y=709140
X231 760 4104 4249 1 2 QDFFN $T=981460 719600 1 180 $X=970920 $Y=719220
X232 784 4104 4232 1 2 QDFFN $T=982700 729680 1 180 $X=972160 $Y=729300
X233 800 4104 4238 1 2 QDFFN $T=982700 739760 0 180 $X=972160 $Y=734340
X234 800 4087 4233 1 2 QDFFN $T=983320 739760 1 180 $X=972780 $Y=739380
X235 760 4038 4286 1 2 QDFFN $T=975260 820400 1 0 $X=975260 $Y=814980
X236 789 4038 4288 1 2 QDFFN $T=975880 840560 1 0 $X=975880 $Y=835140
X237 773 831 4269 1 2 QDFFN $T=976500 870800 1 0 $X=976500 $Y=865380
X238 775 815 4290 1 2 QDFFN $T=977120 840560 0 0 $X=977120 $Y=840180
X239 773 842 4276 1 2 QDFFN $T=977740 850640 1 0 $X=977740 $Y=845220
X240 858 4291 4270 1 2 QDFFN $T=991380 719600 0 180 $X=980840 $Y=714180
X241 868 4280 4272 1 2 QDFFN $T=992000 759920 0 180 $X=981460 $Y=754500
X242 853 4280 4310 1 2 QDFFN $T=982700 810320 1 0 $X=982700 $Y=804900
X243 855 4280 4295 1 2 QDFFN $T=983320 800240 1 0 $X=983320 $Y=794820
X244 775 817 4298 1 2 QDFFN $T=983940 850640 0 0 $X=983940 $Y=850260
X245 857 861 869 1 2 QDFFN $T=984560 699440 1 0 $X=984560 $Y=694020
X246 775 823 4299 1 2 QDFFN $T=985180 860720 1 0 $X=985180 $Y=855300
X247 858 4280 4302 1 2 QDFFN $T=985800 709520 1 0 $X=985800 $Y=704100
X248 859 4280 4306 1 2 QDFFN $T=985800 739760 1 0 $X=985800 $Y=734340
X249 863 4280 4308 1 2 QDFFN $T=987040 719600 0 0 $X=987040 $Y=719220
X250 863 4291 4304 1 2 QDFFN $T=987040 729680 0 0 $X=987040 $Y=729300
X251 853 4291 4313 1 2 QDFFN $T=987660 820400 1 0 $X=987660 $Y=814980
X252 775 813 4292 1 2 QDFFN $T=999440 840560 1 180 $X=988900 $Y=840180
X253 855 4291 4318 1 2 QDFFN $T=989520 800240 0 0 $X=989520 $Y=799860
X254 859 4291 4323 1 2 QDFFN $T=991380 739760 0 0 $X=991380 $Y=739380
X255 867 4291 4324 1 2 QDFFN $T=992000 790160 0 0 $X=992000 $Y=789780
X256 776 813 4327 1 2 QDFFN $T=994480 830480 0 0 $X=994480 $Y=830100
X257 776 823 4336 1 2 QDFFN $T=994480 860720 0 0 $X=994480 $Y=860340
X258 870 4291 4340 1 2 QDFFN $T=995100 820400 0 0 $X=995100 $Y=820020
X259 871 873 874 1 2 QDFFN $T=997580 699440 1 0 $X=997580 $Y=694020
X260 867 4280 4332 1 2 QDFFN $T=997580 780080 1 0 $X=997580 $Y=774660
X261 859 4319 4352 1 2 QDFFN $T=998200 739760 1 0 $X=998200 $Y=734340
X262 868 4319 4353 1 2 QDFFN $T=998200 749840 0 0 $X=998200 $Y=749460
X263 858 4319 4357 1 2 QDFFN $T=999440 709520 1 0 $X=999440 $Y=704100
X264 858 4330 4345 1 2 QDFFN $T=1000060 719600 0 0 $X=1000060 $Y=719220
X265 870 4319 4367 1 2 QDFFN $T=1000680 820400 1 0 $X=1000680 $Y=814980
X266 855 4330 4350 1 2 QDFFN $T=1001300 800240 0 0 $X=1001300 $Y=799860
X267 853 4319 4362 1 2 QDFFN $T=1001300 810320 1 0 $X=1001300 $Y=804900
X268 870 4280 4349 1 2 QDFFN $T=1001300 830480 1 0 $X=1001300 $Y=825060
X269 776 815 4339 1 2 QDFFN $T=1001300 840560 1 0 $X=1001300 $Y=835140
X270 775 842 4361 1 2 QDFFN $T=1001300 850640 0 0 $X=1001300 $Y=850260
X271 855 4319 4341 1 2 QDFFN $T=1014940 790160 1 180 $X=1004400 $Y=789780
X272 863 4330 4384 1 2 QDFFN $T=1005640 729680 1 0 $X=1005640 $Y=724260
X273 775 831 4358 1 2 QDFFN $T=1006260 860720 0 0 $X=1006260 $Y=860340
X274 857 873 881 1 2 QDFFN $T=1008120 699440 0 0 $X=1008120 $Y=699060
X275 775 878 883 1 2 QDFFN $T=1008120 870800 1 0 $X=1008120 $Y=865380
X276 867 4319 4359 1 2 QDFFN $T=1019900 780080 0 180 $X=1009360 $Y=774660
X277 859 4381 4354 1 2 QDFFN $T=1019900 850640 0 180 $X=1009360 $Y=845220
X278 857 882 879 1 2 QDFFN $T=1021140 699440 0 180 $X=1010600 $Y=694020
X279 859 4369 4389 1 2 QDFFN $T=1010600 749840 1 0 $X=1010600 $Y=744420
X280 863 4369 4392 1 2 QDFFN $T=1011840 729680 0 0 $X=1011840 $Y=729300
X281 863 4319 4387 1 2 QDFFN $T=1012460 719600 0 0 $X=1012460 $Y=719220
X282 858 4369 4396 1 2 QDFFN $T=1013080 709520 1 0 $X=1013080 $Y=704100
X283 858 4381 4368 1 2 QDFFN $T=1023620 840560 0 180 $X=1013080 $Y=835140
X284 853 4330 4376 1 2 QDFFN $T=1024240 800240 1 180 $X=1013700 $Y=799860
X285 859 4330 4363 1 2 QDFFN $T=1024860 739760 1 180 $X=1014320 $Y=739380
X286 870 4330 4377 1 2 QDFFN $T=1024860 830480 0 180 $X=1014320 $Y=825060
X287 855 4369 4399 1 2 QDFFN $T=1014940 790160 0 0 $X=1014940 $Y=789780
X288 868 4330 4373 1 2 QDFFN $T=1026720 749840 1 180 $X=1016180 $Y=749460
X289 867 4369 4398 1 2 QDFFN $T=1016180 780080 0 0 $X=1016180 $Y=779700
X290 867 4330 4351 1 2 QDFFN $T=1026720 790160 0 180 $X=1016180 $Y=784740
X291 860 4330 4364 1 2 QDFFN $T=1027960 770000 0 180 $X=1017420 $Y=764580
X292 870 4369 4404 1 2 QDFFN $T=1017420 820400 1 0 $X=1017420 $Y=814980
X293 868 4369 4406 1 2 QDFFN $T=1018040 759920 1 0 $X=1018040 $Y=754500
X294 776 831 4411 1 2 QDFFN $T=1018040 860720 1 0 $X=1018040 $Y=855300
X295 776 878 4405 1 2 QDFFN $T=1018660 860720 0 0 $X=1018660 $Y=860340
X296 868 4381 4382 1 2 QDFFN $T=1030440 830480 1 180 $X=1019900 $Y=830100
X297 776 842 4408 1 2 QDFFN $T=1019900 850640 1 0 $X=1019900 $Y=845220
X298 776 885 4410 1 2 QDFFN $T=1020520 870800 1 0 $X=1020520 $Y=865380
X299 853 4369 4418 1 2 QDFFN $T=1021760 810320 1 0 $X=1021760 $Y=804900
X300 871 889 886 1 2 QDFFN $T=1034160 699440 1 180 $X=1023620 $Y=699060
X301 870 4417 4391 1 2 QDFFN $T=1034160 810320 1 180 $X=1023620 $Y=809940
X302 860 4381 4420 1 2 QDFFN $T=1024860 840560 1 0 $X=1024860 $Y=835140
X303 858 4417 4401 1 2 QDFFN $T=1037260 709520 0 180 $X=1026720 $Y=704100
X304 858 4423 4393 1 2 QDFFN $T=1037260 719600 1 180 $X=1026720 $Y=719220
X305 857 889 887 1 2 QDFFN $T=1037880 699440 0 180 $X=1027340 $Y=694020
X306 859 4423 4395 1 2 QDFFN $T=1037880 739760 0 180 $X=1027340 $Y=734340
X307 855 4417 4403 1 2 QDFFN $T=1037880 790160 1 180 $X=1027340 $Y=789780
X308 870 4423 4402 1 2 QDFFN $T=1037880 830480 0 180 $X=1027340 $Y=825060
X309 867 4423 4407 1 2 QDFFN $T=1039120 780080 1 180 $X=1028580 $Y=779700
X310 860 4369 4425 1 2 QDFFN $T=1029820 770000 0 0 $X=1029820 $Y=769620
X311 863 4417 4414 1 2 QDFFN $T=1040980 729680 0 180 $X=1030440 $Y=724260
X312 868 4423 4412 1 2 QDFFN $T=1041600 759920 1 180 $X=1031060 $Y=759540
X313 863 4381 4413 1 2 QDFFN $T=1041600 850640 1 180 $X=1031060 $Y=850260
X314 859 4417 4409 1 2 QDFFN $T=1042220 749840 0 180 $X=1031680 $Y=744420
X315 860 4423 4419 1 2 QDFFN $T=1042840 780080 0 180 $X=1032300 $Y=774660
X316 853 4381 4426 1 2 QDFFN $T=1032300 830480 0 0 $X=1032300 $Y=830100
X317 890 894 4433 1 2 QDFFN $T=1032920 870800 1 0 $X=1032920 $Y=865380
X318 892 4291 4429 1 2 QDFFN $T=1033540 709520 0 0 $X=1033540 $Y=709140
X319 863 4423 4397 1 2 QDFFN $T=1044080 729680 1 180 $X=1033540 $Y=729300
X320 855 4423 4400 1 2 QDFFN $T=1044080 800240 1 180 $X=1033540 $Y=799860
X321 868 4417 4421 1 2 QDFFN $T=1045320 759920 0 180 $X=1034780 $Y=754500
X322 893 4381 4435 1 2 QDFFN $T=1034780 840560 0 0 $X=1034780 $Y=840180
X323 853 4417 4427 1 2 QDFFN $T=1035400 810320 1 0 $X=1035400 $Y=804900
X324 867 4417 4422 1 2 QDFFN $T=1047180 790160 0 180 $X=1036640 $Y=784740
X325 853 4423 4424 1 2 QDFFN $T=1047800 820400 0 180 $X=1037260 $Y=814980
X326 895 897 4439 1 2 QDFFN $T=1037260 860720 0 0 $X=1037260 $Y=860340
X327 895 4291 4456 1 2 QDFFN $T=1039740 749840 0 0 $X=1039740 $Y=749460
X328 898 4291 4447 1 2 QDFFN $T=1039740 790160 0 0 $X=1039740 $Y=789780
X329 893 4291 4448 1 2 QDFFN $T=1040360 719600 0 0 $X=1040360 $Y=719220
X330 890 4291 4452 1 2 QDFFN $T=1040360 739760 1 0 $X=1040360 $Y=734340
X331 892 4280 4444 1 2 QDFFN $T=1040980 709520 1 0 $X=1040980 $Y=704100
X332 890 897 4455 1 2 QDFFN $T=1040980 860720 1 0 $X=1040980 $Y=855300
X333 898 4280 4453 1 2 QDFFN $T=1041600 780080 0 0 $X=1041600 $Y=779700
X334 860 4417 4432 1 2 QDFFN $T=1054620 770000 0 180 $X=1044080 $Y=764580
X335 901 4291 4460 1 2 QDFFN $T=1044080 810320 0 0 $X=1044080 $Y=809940
X336 855 4381 4430 1 2 QDFFN $T=1055240 830480 1 180 $X=1044700 $Y=830100
X337 901 4280 4454 1 2 QDFFN $T=1045320 800240 0 0 $X=1045320 $Y=799860
X338 895 894 4470 1 2 QDFFN $T=1045320 870800 1 0 $X=1045320 $Y=865380
X339 902 4291 4477 1 2 QDFFN $T=1046560 780080 1 0 $X=1046560 $Y=774660
X340 867 4381 4476 1 2 QDFFN $T=1047180 850640 1 0 $X=1047180 $Y=845220
X341 893 4280 4445 1 2 QDFFN $T=1058340 729680 1 180 $X=1047800 $Y=729300
X342 871 906 910 1 2 QDFFN $T=1048420 699440 1 0 $X=1048420 $Y=694020
X343 904 4280 4496 1 2 QDFFN $T=1049040 820400 0 0 $X=1049040 $Y=820020
X344 890 4381 4446 1 2 QDFFN $T=1059580 840560 0 180 $X=1049040 $Y=835140
X345 904 4291 4495 1 2 QDFFN $T=1050280 820400 1 0 $X=1050280 $Y=814980
X346 895 4280 4449 1 2 QDFFN $T=1062060 759920 1 180 $X=1051520 $Y=759540
X347 892 4319 4471 1 2 QDFFN $T=1064540 709520 0 180 $X=1054000 $Y=704100
X348 893 4319 4468 1 2 QDFFN $T=1064540 719600 1 180 $X=1054000 $Y=719220
X349 890 4319 4503 1 2 QDFFN $T=1054000 749840 1 0 $X=1054000 $Y=744420
X350 901 897 4499 1 2 QDFFN $T=1054000 860720 1 0 $X=1054000 $Y=855300
X351 902 4280 4472 1 2 QDFFN $T=1065160 770000 0 180 $X=1054620 $Y=764580
X352 898 4319 4480 1 2 QDFFN $T=1065780 790160 0 180 $X=1055240 $Y=784740
X353 904 4319 4508 1 2 QDFFN $T=1056480 810320 0 0 $X=1056480 $Y=809940
X354 890 4280 4459 1 2 QDFFN $T=1057720 739760 0 0 $X=1057720 $Y=739380
X355 901 4319 4490 1 2 QDFFN $T=1068260 800240 0 180 $X=1057720 $Y=794820
X356 901 4381 4488 1 2 QDFFN $T=1068260 830480 1 180 $X=1057720 $Y=830100
X357 901 894 4505 1 2 QDFFN $T=1057720 870800 1 0 $X=1057720 $Y=865380
X358 902 4369 4525 1 2 QDFFN $T=1060200 780080 0 0 $X=1060200 $Y=779700
X359 893 4330 4482 1 2 QDFFN $T=1071360 729680 1 180 $X=1060820 $Y=729300
X360 895 4381 4473 1 2 QDFFN $T=1071980 850640 0 180 $X=1061440 $Y=845220
X361 857 906 914 1 2 QDFFN $T=1062060 699440 1 0 $X=1062060 $Y=694020
X362 895 4319 4485 1 2 QDFFN $T=1072600 759920 1 180 $X=1062060 $Y=759540
X363 898 4369 4511 1 2 QDFFN $T=1062060 790160 0 0 $X=1062060 $Y=789780
X364 902 4330 4493 1 2 QDFFN $T=1074460 770000 1 180 $X=1063920 $Y=769620
X365 901 4423 4513 1 2 QDFFN $T=1063920 810320 1 0 $X=1063920 $Y=804900
X366 892 4381 4497 1 2 QDFFN $T=1074460 840560 1 180 $X=1063920 $Y=840180
X367 892 4330 4491 1 2 QDFFN $T=1075700 719600 0 180 $X=1065160 $Y=714180
X368 895 4330 4492 1 2 QDFFN $T=1075700 759920 0 180 $X=1065160 $Y=754500
X369 902 4319 4501 1 2 QDFFN $T=1065160 770000 1 0 $X=1065160 $Y=764580
X370 898 894 4523 1 2 QDFFN $T=1066400 860720 0 0 $X=1066400 $Y=860340
X371 890 4330 4498 1 2 QDFFN $T=1077560 739760 0 180 $X=1067020 $Y=734340
X372 890 4369 4514 1 2 QDFFN $T=1067020 749840 1 0 $X=1067020 $Y=744420
X373 892 4417 4527 1 2 QDFFN $T=1067640 709520 1 0 $X=1067640 $Y=704100
X374 893 4369 4524 1 2 QDFFN $T=1067640 719600 0 0 $X=1067640 $Y=719220
X375 904 4369 4526 1 2 QDFFN $T=1067640 820400 0 0 $X=1067640 $Y=820020
X376 898 4381 4522 1 2 QDFFN $T=1067640 840560 1 0 $X=1067640 $Y=835140
X377 898 897 4507 1 2 QDFFN $T=1078180 860720 0 180 $X=1067640 $Y=855300
X378 898 4330 4489 1 2 QDFFN $T=1078800 790160 0 180 $X=1068260 $Y=784740
X379 904 4330 4509 1 2 QDFFN $T=1079420 810320 1 180 $X=1068880 $Y=809940
X380 901 4330 4494 1 2 QDFFN $T=1080040 800240 0 180 $X=1069500 $Y=794820
X381 895 4369 4520 1 2 QDFFN $T=1079420 770000 1 0 $X=1079420 $Y=764580
X382 895 4423 4515 1 2 QDFFN $T=1080040 759920 1 0 $X=1080040 $Y=754500
X383 892 4369 4537 1 2 QDFFN $T=1080660 709520 1 0 $X=1080660 $Y=704100
X384 892 4423 4538 1 2 QDFFN $T=1080660 719600 0 0 $X=1080660 $Y=719220
X385 893 4417 4540 1 2 QDFFN $T=1080660 729680 1 0 $X=1080660 $Y=724260
X386 893 4423 4517 1 2 QDFFN $T=1080660 739760 1 0 $X=1080660 $Y=734340
X387 890 4423 4512 1 2 QDFFN $T=1080660 739760 0 0 $X=1080660 $Y=739380
X388 890 4417 4531 1 2 QDFFN $T=1080660 749840 1 0 $X=1080660 $Y=744420
X389 895 4417 4532 1 2 QDFFN $T=1080660 759920 0 0 $X=1080660 $Y=759540
X390 902 4423 4518 1 2 QDFFN $T=1080660 770000 0 0 $X=1080660 $Y=769620
X391 902 4417 4541 1 2 QDFFN $T=1080660 780080 0 0 $X=1080660 $Y=779700
X392 898 4423 4521 1 2 QDFFN $T=1080660 790160 1 0 $X=1080660 $Y=784740
X393 904 4417 4529 1 2 QDFFN $T=1080660 820400 1 0 $X=1080660 $Y=814980
X394 904 4423 4519 1 2 QDFFN $T=1080660 820400 0 0 $X=1080660 $Y=820020
X395 870 4381 4542 1 2 QDFFN $T=1080660 830480 1 0 $X=1080660 $Y=825060
X396 904 4381 4534 1 2 QDFFN $T=1080660 840560 1 0 $X=1080660 $Y=835140
X397 902 4381 4533 1 2 QDFFN $T=1080660 840560 0 0 $X=1080660 $Y=840180
X398 902 897 4530 1 2 QDFFN $T=1080660 850640 1 0 $X=1080660 $Y=845220
X399 904 897 922 1 2 QDFFN $T=1080660 850640 0 0 $X=1080660 $Y=850260
X400 902 894 4535 1 2 QDFFN $T=1080660 860720 0 0 $X=1080660 $Y=860340
X401 898 4417 4539 1 2 QDFFN $T=1081280 800240 1 0 $X=1081280 $Y=794820
X402 901 4417 4536 1 2 QDFFN $T=1081280 800240 0 0 $X=1081280 $Y=799860
X403 901 4369 4528 1 2 QDFFN $T=1081280 810320 1 0 $X=1081280 $Y=804900
X404 904 894 921 1 2 QDFFN $T=1081280 870800 1 0 $X=1081280 $Y=865380
X405 1006 1009 1013 10 1 7 2 AOI22S $T=234360 800240 0 0 $X=234360 $Y=799860
X406 987 1018 1196 7 1 10 2 AOI22S $T=271560 770000 1 0 $X=271560 $Y=764580
X407 1978 1936 1962 261 1 259 2 AOI22S $T=437720 719600 1 0 $X=437720 $Y=714180
X408 249 1987 1970 261 1 259 2 AOI22S $T=437720 729680 1 0 $X=437720 $Y=724260
X409 1971 1954 1986 254 1 263 2 AOI22S $T=437720 759920 1 0 $X=437720 $Y=754500
X410 1985 1999 2015 261 1 259 2 AOI22S $T=443300 709520 1 180 $X=439580 $Y=709140
X411 1958 1990 1993 254 1 263 2 AOI22S $T=439580 759920 0 0 $X=439580 $Y=759540
X412 1995 262 1996 261 1 259 2 AOI22S $T=440200 699440 0 0 $X=440200 $Y=699060
X413 249 2016 1979 261 1 259 2 AOI22S $T=442680 729680 1 0 $X=442680 $Y=724260
X414 2026 1963 1997 254 1 263 2 AOI22S $T=446400 749840 1 180 $X=442680 $Y=749460
X415 2032 2043 2036 254 1 263 2 AOI22S $T=454460 749840 0 0 $X=454460 $Y=749460
X416 2045 2118 2109 254 1 263 2 AOI22S $T=463140 719600 1 0 $X=463140 $Y=714180
X417 2117 2122 2071 254 1 263 2 AOI22S $T=468100 729680 0 180 $X=464380 $Y=724260
X418 2131 2123 2054 254 1 263 2 AOI22S $T=468100 739760 1 180 $X=464380 $Y=739380
X419 2139 2126 2088 254 1 263 2 AOI22S $T=468720 709520 0 180 $X=465000 $Y=704100
X420 2100 2121 2106 254 1 263 2 AOI22S $T=466860 759920 0 0 $X=466860 $Y=759540
X421 2146 2149 2093 254 1 263 2 AOI22S $T=474300 759920 1 180 $X=470580 $Y=759540
X422 2164 2155 2114 254 1 263 2 AOI22S $T=477400 749840 1 180 $X=473680 $Y=749460
X423 2277 2271 2276 2284 1 2293 2 AOI22S $T=504060 759920 0 0 $X=504060 $Y=759540
X424 2305 2297 2286 2284 1 2293 2 AOI22S $T=509020 739760 1 180 $X=505300 $Y=739380
X425 2287 2306 2268 2319 1 2324 2 AOI22S $T=506540 749840 0 0 $X=506540 $Y=749460
X426 2271 2277 2259 330 1 331 2 AOI22S $T=507780 759920 0 0 $X=507780 $Y=759540
X427 2287 2271 2317 2319 1 2328 2 AOI22S $T=509020 739760 0 0 $X=509020 $Y=739380
X428 1926 1929 2334 2319 1 2328 2 AOI22S $T=515220 749840 1 180 $X=511500 $Y=749460
X429 1926 1905 2345 2319 1 2324 2 AOI22S $T=516460 759920 0 180 $X=512740 $Y=754500
X430 2306 2297 2327 2293 1 2357 2 AOI22S $T=513360 739760 0 0 $X=513360 $Y=739380
X431 2306 2271 2348 330 1 331 2 AOI22S $T=517080 759920 1 180 $X=513360 $Y=759540
X432 1905 2128 2347 2293 1 2357 2 AOI22S $T=515220 749840 0 0 $X=515220 $Y=749460
X433 2306 2339 2274 2293 1 2361 2 AOI22S $T=516460 739760 1 0 $X=516460 $Y=734340
X434 2287 2277 2355 2360 1 2362 2 AOI22S $T=516460 759920 1 0 $X=516460 $Y=754500
X435 2361 2145 2374 2293 1 1905 2 AOI22S $T=522040 739760 1 0 $X=522040 $Y=734340
X436 2141 2128 2389 2284 1 2293 2 AOI22S $T=525760 749840 0 180 $X=522040 $Y=744420
X437 2293 2284 2380 1929 1 2064 2 AOI22S $T=523280 759920 1 0 $X=523280 $Y=754500
X438 1926 2360 2449 2064 1 2362 2 AOI22S $T=536920 759920 0 180 $X=533200 $Y=754500
X439 331 330 2472 1929 1 1905 2 AOI22S $T=543120 759920 1 180 $X=539400 $Y=759540
X440 331 330 2471 2064 1 1929 2 AOI22S $T=545600 759920 0 180 $X=541880 $Y=754500
X441 2478 2506 2501 327 1 263 2 AOI22S $T=549940 790160 1 0 $X=549940 $Y=784740
X442 2505 2519 2522 327 1 263 2 AOI22S $T=553660 770000 0 0 $X=553660 $Y=769620
X443 2498 2499 2524 327 1 263 2 AOI22S $T=555520 739760 0 0 $X=555520 $Y=739380
X444 2562 2551 2564 254 1 263 2 AOI22S $T=563580 759920 1 180 $X=559860 $Y=759540
X445 2538 2565 2555 254 1 263 2 AOI22S $T=562960 790160 1 0 $X=562960 $Y=784740
X446 2575 2553 2580 254 1 263 2 AOI22S $T=567300 770000 1 180 $X=563580 $Y=769620
X447 2494 2566 2542 327 1 263 2 AOI22S $T=564200 790160 0 0 $X=564200 $Y=789780
X448 2509 2558 2571 327 1 263 2 AOI22S $T=564820 800240 0 0 $X=564820 $Y=799860
X449 2600 2594 2604 327 1 263 2 AOI22S $T=570400 709520 1 0 $X=570400 $Y=704100
X450 2581 2601 2598 254 1 263 2 AOI22S $T=570400 719600 0 0 $X=570400 $Y=719220
X451 2613 2569 2608 327 1 263 2 AOI22S $T=574120 749840 0 180 $X=570400 $Y=744420
X452 2587 2610 2606 327 1 263 2 AOI22S $T=572260 739760 1 0 $X=572260 $Y=734340
X453 2652 2652 2627 2661 1 2666 2 AOI22S $T=582800 790160 1 0 $X=582800 $Y=784740
X454 2648 2648 2630 2661 1 2666 2 AOI22S $T=583420 759920 0 0 $X=583420 $Y=759540
X455 2673 2653 2685 254 1 263 2 AOI22S $T=590860 739760 1 180 $X=587140 $Y=739380
X456 2667 2667 2649 2661 1 2666 2 AOI22S $T=587140 770000 1 0 $X=587140 $Y=764580
X457 2659 2672 2669 254 1 263 2 AOI22S $T=587760 709520 0 0 $X=587760 $Y=709140
X458 2675 2675 2654 2661 1 2666 2 AOI22S $T=591480 770000 1 180 $X=587760 $Y=769620
X459 2676 2676 2655 2661 1 2666 2 AOI22S $T=591480 780080 0 180 $X=587760 $Y=774660
X460 2677 2677 2670 2661 1 2666 2 AOI22S $T=591480 790160 0 180 $X=587760 $Y=784740
X461 2662 2688 2679 254 1 263 2 AOI22S $T=590860 699440 0 0 $X=590860 $Y=699060
X462 2690 2696 2692 254 1 263 2 AOI22S $T=592100 739760 0 0 $X=592100 $Y=739380
X463 2699 2699 2700 2661 1 2666 2 AOI22S $T=595820 790160 0 180 $X=592100 $Y=784740
X464 2723 2713 2722 254 1 263 2 AOI22S $T=600160 739760 1 180 $X=596440 $Y=739380
X465 2729 2727 2698 423 1 2751 2 AOI22S $T=602640 840560 0 0 $X=602640 $Y=840180
X466 2765 2757 2761 423 1 2751 2 AOI22S $T=610080 810320 1 180 $X=606360 $Y=809940
X467 2693 2736 424 423 1 2751 2 AOI22S $T=606360 830480 1 0 $X=606360 $Y=825060
X468 2766 2758 2730 423 1 2751 2 AOI22S $T=610080 840560 1 180 $X=606360 $Y=840180
X469 2775 2764 436 423 1 2751 2 AOI22S $T=611940 850640 1 180 $X=608220 $Y=850260
X470 2748 430 2755 433 1 434 2 AOI22S $T=608220 860720 0 0 $X=608220 $Y=860340
X471 418 437 2769 438 1 434 2 AOI22S $T=611940 860720 0 0 $X=611940 $Y=860340
X472 2789 2789 440 423 1 2751 2 AOI22S $T=616900 860720 0 180 $X=613180 $Y=855300
X473 2809 2798 2718 423 1 2751 2 AOI22S $T=618760 840560 0 180 $X=615040 $Y=835140
X474 2716 2805 2695 423 1 2751 2 AOI22S $T=616900 830480 1 0 $X=616900 $Y=825060
X475 2825 2830 442 423 1 2751 2 AOI22S $T=621240 820400 0 0 $X=621240 $Y=820020
X476 2857 2803 2831 438 1 434 2 AOI22S $T=624960 850640 1 180 $X=621240 $Y=850260
X477 2839 2854 447 423 1 2751 2 AOI22S $T=626820 810320 1 180 $X=623100 $Y=809940
X478 2876 2856 2770 423 1 2751 2 AOI22S $T=628680 820400 1 180 $X=624960 $Y=820020
X479 2807 2864 2779 423 1 2751 2 AOI22S $T=628680 830480 1 180 $X=624960 $Y=830100
X480 2890 2884 457 423 1 2751 2 AOI22S $T=631780 810320 1 180 $X=628060 $Y=809940
X481 2871 2868 2879 438 1 434 2 AOI22S $T=628680 850640 1 0 $X=628680 $Y=845220
X482 2896 2903 2878 423 1 2751 2 AOI22S $T=633640 830480 1 0 $X=633640 $Y=825060
X483 2886 2922 2920 438 1 434 2 AOI22S $T=638600 860720 1 0 $X=638600 $Y=855300
X484 2937 2943 2933 423 1 2751 2 AOI22S $T=643560 820400 0 0 $X=643560 $Y=820020
X485 2960 2925 2927 423 1 2751 2 AOI22S $T=647280 810320 1 0 $X=647280 $Y=804900
X486 3018 2984 2990 423 1 2751 2 AOI22S $T=657820 820400 1 180 $X=654100 $Y=820020
X487 3026 3025 3031 497 1 434 2 AOI22S $T=659060 850640 0 0 $X=659060 $Y=850260
X488 3018 3017 3039 423 1 2751 2 AOI22S $T=660300 820400 1 0 $X=660300 $Y=814980
X489 3021 3014 2998 438 1 434 2 AOI22S $T=661540 850640 1 0 $X=661540 $Y=845220
X490 3011 3053 3049 438 1 502 2 AOI22S $T=662780 860720 1 0 $X=662780 $Y=855300
X491 3076 3048 3091 423 1 2751 2 AOI22S $T=671460 830480 0 180 $X=667740 $Y=825060
X492 3086 3083 509 423 1 2751 2 AOI22S $T=669600 810320 0 0 $X=669600 $Y=809940
X493 3110 3117 517 423 1 2751 2 AOI22S $T=677660 810320 1 180 $X=673940 $Y=809940
X494 3095 3118 3115 423 1 2751 2 AOI22S $T=674560 830480 1 0 $X=674560 $Y=825060
X495 524 526 3132 438 1 502 2 AOI22S $T=678900 870800 1 0 $X=678900 $Y=865380
X496 532 3159 3164 438 1 502 2 AOI22S $T=684480 860720 0 180 $X=680760 $Y=855300
X497 3153 3157 3154 423 1 2751 2 AOI22S $T=682620 830480 0 0 $X=682620 $Y=830100
X498 3158 3140 534 423 1 2751 2 AOI22S $T=685720 820400 1 0 $X=685720 $Y=814980
X499 3197 3193 3202 438 1 502 2 AOI22S $T=690060 850640 1 180 $X=686340 $Y=850260
X500 3153 3194 3184 423 1 2751 2 AOI22S $T=687580 830480 0 0 $X=687580 $Y=830100
X501 3238 3218 554 423 1 2751 2 AOI22S $T=695020 790160 1 180 $X=691300 $Y=789780
X502 3182 3210 544 423 1 2751 2 AOI22S $T=691300 820400 1 0 $X=691300 $Y=814980
X503 3222 3222 550 423 1 2751 2 AOI22S $T=696260 820400 1 180 $X=692540 $Y=820020
X504 3235 3234 553 423 1 2751 2 AOI22S $T=698120 810320 1 180 $X=694400 $Y=809940
X505 3248 3246 555 423 1 2751 2 AOI22S $T=699980 820400 1 180 $X=696260 $Y=820020
X506 3260 3254 560 423 1 2751 2 AOI22S $T=703080 800240 1 180 $X=699360 $Y=799860
X507 3264 3257 561 423 1 2751 2 AOI22S $T=703700 820400 1 180 $X=699980 $Y=820020
X508 3276 3272 564 423 1 2751 2 AOI22S $T=706800 800240 1 180 $X=703080 $Y=799860
X509 3287 3275 563 423 1 2751 2 AOI22S $T=708040 810320 0 180 $X=704320 $Y=804900
X510 3302 3283 567 423 1 2751 2 AOI22S $T=709900 820400 0 180 $X=706180 $Y=814980
X511 3297 3293 569 423 1 2751 2 AOI22S $T=710520 810320 1 180 $X=706800 $Y=809940
X512 3432 3449 3459 628 1 627 2 AOI22S $T=755160 780080 0 180 $X=751440 $Y=774660
X513 3457 3517 3480 651 1 654 2 AOI22S $T=766320 770000 1 0 $X=766320 $Y=764580
X514 3521 3484 3518 628 1 627 2 AOI22S $T=766940 780080 1 0 $X=766940 $Y=774660
X515 3516 3551 3509 651 1 654 2 AOI22S $T=773140 770000 1 0 $X=773140 $Y=764580
X516 3575 3545 3565 651 1 654 2 AOI22S $T=779340 800240 0 180 $X=775620 $Y=794820
X517 3571 3583 3568 628 1 627 2 AOI22S $T=778720 780080 1 0 $X=778720 $Y=774660
X518 3584 3587 3572 628 1 627 2 AOI22S $T=779960 810320 0 0 $X=779960 $Y=809940
X519 3589 3582 3576 651 1 654 2 AOI22S $T=781820 840560 0 0 $X=781820 $Y=840180
X520 3611 3601 3606 628 1 627 2 AOI22S $T=788640 860720 1 180 $X=784920 $Y=860340
X521 3590 3600 3564 651 1 654 2 AOI22S $T=787400 770000 1 0 $X=787400 $Y=764580
X522 3625 3615 3585 628 1 627 2 AOI22S $T=792360 830480 0 180 $X=788640 $Y=825060
X523 3612 3567 683 628 1 627 2 AOI22S $T=789260 870800 1 0 $X=789260 $Y=865380
X524 689 687 3638 651 1 654 2 AOI22S $T=796700 870800 0 180 $X=792980 $Y=865380
X525 3640 3641 3643 628 1 627 2 AOI22S $T=796700 850640 0 0 $X=796700 $Y=850260
X526 3683 3656 3681 628 1 627 2 AOI22S $T=807860 830480 0 180 $X=804140 $Y=825060
X527 3670 3630 3693 628 1 627 2 AOI22S $T=809100 820400 1 0 $X=809100 $Y=814980
X528 3694 3687 3677 651 1 654 2 AOI22S $T=810960 850640 0 0 $X=810960 $Y=850260
X529 3692 3678 3699 628 1 627 2 AOI22S $T=811580 790160 1 0 $X=811580 $Y=784740
X530 3703 3646 3704 628 1 627 2 AOI22S $T=812200 770000 1 0 $X=812200 $Y=764580
X531 3700 3718 3710 651 1 654 2 AOI22S $T=816540 830480 0 0 $X=816540 $Y=830100
X532 3709 3728 3715 651 1 654 2 AOI22S $T=820260 810320 0 0 $X=820260 $Y=809940
X533 3725 3735 3733 651 1 654 2 AOI22S $T=822740 780080 0 0 $X=822740 $Y=779700
X534 3737 3739 3741 651 1 654 2 AOI22S $T=825220 770000 0 0 $X=825220 $Y=769620
X535 3751 724 722 628 1 627 2 AOI22S $T=830800 870800 1 0 $X=830800 $Y=865380
X536 3769 3776 3770 628 1 627 2 AOI22S $T=832660 860720 1 0 $X=832660 $Y=855300
X537 3820 3850 3813 651 1 654 2 AOI22S $T=866140 860720 0 0 $X=866140 $Y=860340
X538 3876 3885 3889 3892 1 3895 2 AOI22S $T=867380 770000 0 0 $X=867380 $Y=769620
X539 3882 3903 3910 3892 1 3895 2 AOI22S $T=874200 770000 1 0 $X=874200 $Y=764580
X540 3896 3906 3913 3892 1 3895 2 AOI22S $T=874820 759920 1 0 $X=874820 $Y=754500
X541 3837 3914 3909 3892 1 3895 2 AOI22S $T=875440 729680 1 0 $X=875440 $Y=724260
X542 3861 3905 3922 3892 1 3895 2 AOI22S $T=877300 739760 0 0 $X=877300 $Y=739380
X543 3908 3902 3929 3892 1 3895 2 AOI22S $T=881640 770000 0 180 $X=877920 $Y=764580
X544 3920 3926 3933 3892 1 3895 2 AOI22S $T=880400 719600 1 0 $X=880400 $Y=714180
X545 3943 3940 3948 628 1 627 2 AOI22S $T=882880 840560 0 0 $X=882880 $Y=840180
X546 3944 3949 3935 628 1 627 2 AOI22S $T=882880 850640 0 0 $X=882880 $Y=850260
X547 3893 3899 3951 651 1 654 2 AOI22S $T=883500 860720 1 0 $X=883500 $Y=855300
X548 3925 3959 3954 3892 1 3895 2 AOI22S $T=884740 790160 1 0 $X=884740 $Y=784740
X549 3884 3961 3956 3892 1 3895 2 AOI22S $T=885360 719600 1 0 $X=885360 $Y=714180
X550 3900 3955 3964 3892 1 3895 2 AOI22S $T=886600 790160 0 0 $X=886600 $Y=789780
X551 3970 3973 3993 628 1 627 2 AOI22S $T=890320 850640 1 180 $X=886600 $Y=850260
X552 3952 796 3971 651 1 654 2 AOI22S $T=887220 870800 1 0 $X=887220 $Y=865380
X553 3880 3972 3978 3892 1 3895 2 AOI22S $T=889080 800240 0 0 $X=889080 $Y=799860
X554 4001 3946 3999 3987 1 3986 2 AOI22S $T=893420 749840 0 180 $X=889700 $Y=744420
X555 3966 3979 3988 3892 1 3895 2 AOI22S $T=890320 810320 1 0 $X=890320 $Y=804900
X556 3923 3980 3990 3892 1 3895 2 AOI22S $T=890940 810320 0 0 $X=890940 $Y=809940
X557 4020 4009 4015 3987 1 3986 2 AOI22S $T=897760 719600 1 180 $X=894040 $Y=719220
X558 4021 4010 4011 3987 1 3986 2 AOI22S $T=897760 729680 1 180 $X=894040 $Y=729300
X559 3995 4019 4012 3987 1 3986 2 AOI22S $T=895900 810320 0 0 $X=895900 $Y=809940
X560 3983 3928 3941 3987 1 3986 2 AOI22S $T=896520 770000 1 0 $X=896520 $Y=764580
X561 4035 4027 4036 3987 1 3986 2 AOI22S $T=900860 719600 0 180 $X=897140 $Y=714180
X562 3960 4017 4026 3987 1 3986 2 AOI22S $T=899000 770000 0 0 $X=899000 $Y=769620
X563 3975 4031 3992 3987 1 3986 2 AOI22S $T=899000 790160 1 0 $X=899000 $Y=784740
X564 4048 4040 4041 3987 1 3986 2 AOI22S $T=903960 810320 1 180 $X=900240 $Y=809940
X565 4056 4039 4058 3987 1 3986 2 AOI22S $T=908920 800240 0 180 $X=905200 $Y=794820
X566 4007 807 3994 3924 1 4063 2 AOI22S $T=907060 830480 0 0 $X=907060 $Y=830100
X567 4083 809 4043 3924 1 4063 2 AOI22S $T=913260 840560 1 180 $X=909540 $Y=840180
X568 4066 4070 4069 3987 1 3986 2 AOI22S $T=910160 780080 1 0 $X=910160 $Y=774660
X569 4073 4076 4050 3987 1 3986 2 AOI22S $T=911400 780080 0 0 $X=911400 $Y=779700
X570 4067 810 4053 3924 1 4063 2 AOI22S $T=911400 830480 0 0 $X=911400 $Y=830100
X571 4061 811 4068 3924 1 4063 2 AOI22S $T=911400 840560 1 0 $X=911400 $Y=835140
X572 4077 4082 4059 3987 1 3986 2 AOI22S $T=912640 719600 1 0 $X=912640 $Y=714180
X573 4057 4060 4079 3987 1 3986 2 AOI22S $T=912640 749840 0 0 $X=912640 $Y=749460
X574 4080 4074 4084 3987 1 3986 2 AOI22S $T=914500 729680 1 0 $X=914500 $Y=724260
X575 4096 3924 4018 814 1 4063 2 AOI22S $T=919460 830480 1 180 $X=915740 $Y=830100
X576 4075 4072 4093 3987 1 3986 2 AOI22S $T=917600 739760 0 0 $X=917600 $Y=739380
X577 4086 4091 4092 3987 1 3986 2 AOI22S $T=917600 810320 0 0 $X=917600 $Y=809940
X578 4106 816 4030 3924 1 4063 2 AOI22S $T=923180 830480 1 180 $X=919460 $Y=830100
X579 4089 4099 4098 3892 1 3895 2 AOI22S $T=920080 810320 1 0 $X=920080 $Y=804900
X580 4108 4111 4109 3892 1 3895 2 AOI22S $T=924420 749840 0 0 $X=924420 $Y=749460
X581 4114 819 4095 3924 1 4063 2 AOI22S $T=927520 840560 0 0 $X=927520 $Y=840180
X582 4113 4138 4005 3924 1 4063 2 AOI22S $T=929380 840560 1 0 $X=929380 $Y=835140
X583 4122 4141 818 821 1 830 2 AOI22S $T=930000 860720 0 0 $X=930000 $Y=860340
X584 4145 4148 4156 3892 1 3895 2 AOI22S $T=935580 739760 0 180 $X=931860 $Y=734340
X585 4136 4119 4147 3892 1 3895 2 AOI22S $T=933720 719600 0 0 $X=933720 $Y=719220
X586 4149 822 4118 3924 1 4063 2 AOI22S $T=934340 830480 0 0 $X=934340 $Y=830100
X587 4152 4157 4161 825 1 828 2 AOI22S $T=936820 850640 0 0 $X=936820 $Y=850260
X588 4171 4166 4016 3924 1 4063 2 AOI22S $T=941780 830480 1 180 $X=938060 $Y=830100
X589 4164 4177 4174 821 1 830 2 AOI22S $T=941780 850640 1 0 $X=941780 $Y=845220
X590 4220 839 3947 3924 1 4063 2 AOI22S $T=957280 830480 0 180 $X=953560 $Y=825060
X591 4214 840 4172 3924 1 4063 2 AOI22S $T=958520 840560 0 0 $X=958520 $Y=840180
X592 4210 4223 4212 835 1 838 2 AOI22S $T=958520 870800 1 0 $X=958520 $Y=865380
X593 4240 4231 4025 3924 1 4063 2 AOI22S $T=965960 830480 0 180 $X=962240 $Y=825060
X594 4236 844 4137 3924 1 4063 2 AOI22S $T=967200 820400 1 0 $X=967200 $Y=814980
X595 4242 4245 4044 3924 1 4063 2 AOI22S $T=967200 830480 1 0 $X=967200 $Y=825060
X596 4237 4252 4250 821 1 830 2 AOI22S $T=969060 850640 1 0 $X=969060 $Y=845220
X597 4264 4258 4262 825 1 828 2 AOI22S $T=977740 850640 1 180 $X=974020 $Y=850260
X598 4276 4269 4271 835 1 838 2 AOI22S $T=982700 850640 1 180 $X=978980 $Y=850260
X599 4286 856 4062 3924 1 4063 2 AOI22S $T=985800 820400 1 180 $X=982080 $Y=820020
X600 4288 865 4105 3924 1 4063 2 AOI22S $T=988900 830480 0 0 $X=988900 $Y=830100
X601 4290 4292 4293 821 1 830 2 AOI22S $T=989520 850640 1 0 $X=989520 $Y=845220
X602 4270 4302 4300 3987 1 3986 2 AOI22S $T=994480 719600 1 0 $X=994480 $Y=714180
X603 4313 4310 4360 3987 1 3986 2 AOI22S $T=999440 810320 1 180 $X=995720 $Y=809940
X604 4299 4298 4297 825 1 828 2 AOI22S $T=995720 850640 0 0 $X=995720 $Y=850260
X605 4318 4295 4322 3987 1 3986 2 AOI22S $T=1000060 800240 0 180 $X=996340 $Y=794820
X606 4336 872 4320 825 1 828 2 AOI22S $T=1000060 860720 0 180 $X=996340 $Y=855300
X607 4304 4308 4317 3987 1 3986 2 AOI22S $T=999440 729680 0 0 $X=999440 $Y=729300
X608 4339 4327 4329 821 1 830 2 AOI22S $T=1003160 850640 0 180 $X=999440 $Y=845220
X609 4324 4332 4312 3987 1 3986 2 AOI22S $T=1001300 790160 1 0 $X=1001300 $Y=784740
X610 4323 4306 4334 3987 1 3986 2 AOI22S $T=1001920 739760 0 0 $X=1001920 $Y=739380
X611 4325 4303 4331 3987 1 3986 2 AOI22S $T=1001920 770000 0 0 $X=1001920 $Y=769620
X612 4357 4345 4338 3892 1 3895 2 AOI22S $T=1008740 719600 0 180 $X=1005020 $Y=714180
X613 4354 875 4348 3924 1 4063 2 AOI22S $T=1009360 850640 0 180 $X=1005640 $Y=845220
X614 4359 4351 4316 3892 1 3895 2 AOI22S $T=1009980 780080 1 180 $X=1006260 $Y=779700
X615 4341 4350 4344 3892 1 3895 2 AOI22S $T=1006260 800240 1 0 $X=1006260 $Y=794820
X616 4340 4349 4347 3987 1 3986 2 AOI22S $T=1006260 820400 0 0 $X=1006260 $Y=820020
X617 4368 877 4326 3924 1 4063 2 AOI22S $T=1010600 830480 1 180 $X=1006880 $Y=830100
X618 4361 4358 4343 835 1 838 2 AOI22S $T=1011840 860720 0 180 $X=1008120 $Y=855300
X619 4328 4272 4355 3987 1 3986 2 AOI22S $T=1008740 749840 0 0 $X=1008740 $Y=749460
X620 4370 4364 4366 3892 1 3895 2 AOI22S $T=1013080 770000 0 180 $X=1009360 $Y=764580
X621 4352 4363 4356 3892 1 3895 2 AOI22S $T=1009980 739760 0 0 $X=1009980 $Y=739380
X622 4353 4373 4372 3892 1 3895 2 AOI22S $T=1012460 749840 0 0 $X=1012460 $Y=749460
X623 4367 4377 4365 3892 1 3895 2 AOI22S $T=1013080 810320 0 0 $X=1013080 $Y=809940
X624 4362 4376 4375 3892 1 3895 2 AOI22S $T=1013700 810320 1 0 $X=1013700 $Y=804900
X625 4382 880 4378 3924 1 4063 2 AOI22S $T=1018040 830480 1 180 $X=1014320 $Y=830100
X626 4387 4384 4388 3892 1 3895 2 AOI22S $T=1021140 729680 0 180 $X=1017420 $Y=724260
X627 4413 888 4394 3924 1 4063 2 AOI22S $T=1029820 840560 1 180 $X=1026100 $Y=840180
X628 4408 4411 4415 835 1 838 2 AOI22S $T=1029820 860720 1 0 $X=1029820 $Y=855300
X629 4420 891 4380 3924 1 4063 2 AOI22S $T=1034780 840560 1 180 $X=1031060 $Y=840180
X630 4410 4405 4416 833 1 841 2 AOI22S $T=1031060 860720 0 0 $X=1031060 $Y=860340
X631 4426 896 4385 3924 1 4063 2 AOI22S $T=1040980 840560 0 180 $X=1037260 $Y=835140
X632 4430 899 4335 3924 1 4063 2 AOI22S $T=1044080 830480 0 180 $X=1040360 $Y=825060
X633 4435 900 4431 3924 1 4063 2 AOI22S $T=1044700 840560 0 180 $X=1040980 $Y=835140
X634 4446 903 4440 3924 1 4063 2 AOI22S $T=1049040 840560 1 180 $X=1045320 $Y=840180
X635 4429 4444 4443 3987 1 3986 2 AOI22S $T=1047180 709520 0 0 $X=1047180 $Y=709140
X636 4456 4449 4450 3987 1 3986 2 AOI22S $T=1050900 759920 0 180 $X=1047180 $Y=754500
X637 4460 4454 4457 3987 1 3986 2 AOI22S $T=1052140 810320 0 180 $X=1048420 $Y=804900
X638 4448 4445 4436 3987 1 3986 2 AOI22S $T=1049040 729680 1 0 $X=1049040 $Y=724260
X639 4447 4453 4451 3987 1 3986 2 AOI22S $T=1049040 790160 1 0 $X=1049040 $Y=784740
X640 4433 4455 905 821 1 830 2 AOI22S $T=1049040 860720 0 0 $X=1049040 $Y=860340
X641 4452 4459 4442 3987 1 3986 2 AOI22S $T=1050900 739760 0 0 $X=1050900 $Y=739380
X642 4473 908 4467 3924 1 4063 2 AOI22S $T=1055240 840560 1 180 $X=1051520 $Y=840180
X643 4477 4472 4483 3987 1 3986 2 AOI22S $T=1056480 770000 1 180 $X=1052760 $Y=769620
X644 4468 4482 4441 3892 1 3895 2 AOI22S $T=1055240 729680 1 0 $X=1055240 $Y=724260
X645 4476 909 4309 3924 1 4063 2 AOI22S $T=1055240 840560 0 0 $X=1055240 $Y=840180
X646 4470 4439 907 821 1 830 2 AOI22S $T=1055240 860720 0 0 $X=1055240 $Y=860340
X647 4501 4493 4486 3892 1 3895 2 AOI22S $T=1060820 770000 1 180 $X=1057100 $Y=769620
X648 4480 4489 4481 3892 1 3895 2 AOI22S $T=1057100 790160 0 0 $X=1057100 $Y=789780
X649 4471 4491 4479 3892 1 3895 2 AOI22S $T=1057720 709520 0 0 $X=1057720 $Y=709140
X650 4485 4492 4484 3892 1 3895 2 AOI22S $T=1057720 759920 1 0 $X=1057720 $Y=754500
X651 4490 4494 4487 3892 1 3895 2 AOI22S $T=1058960 810320 1 0 $X=1058960 $Y=804900
X652 4497 911 4466 3924 1 4063 2 AOI22S $T=1062680 840560 1 180 $X=1058960 $Y=840180
X653 4503 4498 4461 3892 1 3895 2 AOI22S $T=1064540 739760 0 180 $X=1060820 $Y=734340
X654 4488 912 4475 3924 1 4063 2 AOI22S $T=1060820 840560 1 0 $X=1060820 $Y=835140
X655 4505 4499 913 821 1 830 2 AOI22S $T=1064540 860720 1 180 $X=1060820 $Y=860340
X656 4495 4496 4504 3987 1 3986 2 AOI22S $T=1065160 820400 1 180 $X=1061440 $Y=820020
X657 4508 4509 4506 3892 1 3895 2 AOI22S $T=1071360 820400 0 180 $X=1067640 $Y=814980
X658 4522 4510 4465 3924 1 4063 2 AOI22S $T=1073220 830480 1 180 $X=1069500 $Y=830100
X659 4523 4507 4516 821 1 830 2 AOI22S $T=1073220 870800 0 180 $X=1069500 $Y=865380
X660 4542 916 4371 3924 1 4063 2 AOI22S $T=1078180 830480 1 180 $X=1074460 $Y=830100
X661 4533 917 4478 3924 1 4063 2 AOI22S $T=1078180 850640 0 180 $X=1074460 $Y=845220
X662 4534 918 4502 3924 1 4063 2 AOI22S $T=1080040 840560 1 180 $X=1076320 $Y=840180
X663 4535 4530 919 821 1 830 2 AOI22S $T=1080660 860720 1 180 $X=1076940 $Y=860340
X664 952 955 1 2 4 AN2 $T=223820 699440 0 180 $X=221340 $Y=694020
X665 946 947 1 2 956 AN2 $T=221340 729680 1 0 $X=221340 $Y=724260
X666 953 957 1 2 947 AN2 $T=223820 739760 1 180 $X=221340 $Y=739380
X667 948 958 1 2 944 AN2 $T=223820 759920 0 180 $X=221340 $Y=754500
X668 962 959 1 2 948 AN2 $T=223820 770000 0 180 $X=221340 $Y=764580
X669 943 954 1 2 962 AN2 $T=221340 770000 0 0 $X=221340 $Y=769620
X670 967 964 1 2 955 AN2 $T=225060 709520 1 180 $X=222580 $Y=709140
X671 949 956 1 2 964 AN2 $T=222580 719600 1 0 $X=222580 $Y=714180
X672 944 965 1 2 957 AN2 $T=223200 739760 1 0 $X=223200 $Y=734340
X673 992 984 1 2 980 AN2 $T=228780 739760 1 180 $X=226300 $Y=739380
X674 998 996 1 2 943 AN2 $T=231880 780080 1 180 $X=229400 $Y=779700
X675 1019 12 1 2 991 AN2 $T=233740 830480 1 180 $X=231260 $Y=830100
X676 17 984 1 2 1000 AN2 $T=235600 739760 1 180 $X=233120 $Y=739380
X677 1015 1010 1 2 998 AN2 $T=235600 780080 0 180 $X=233120 $Y=774660
X678 21 984 1 2 1018 AN2 $T=238700 739760 0 180 $X=236220 $Y=734340
X679 1022 984 1 2 1006 AN2 $T=236840 739760 0 0 $X=236840 $Y=739380
X680 1047 12 1 2 960 AN2 $T=241180 850640 0 180 $X=238700 $Y=845220
X681 1023 12 1 2 1058 AN2 $T=243040 850640 1 0 $X=243040 $Y=845220
X682 1005 1100 1 2 1092 AN2 $T=252340 719600 0 180 $X=249860 $Y=714180
X683 1093 31 1 2 966 AN2 $T=249860 870800 1 0 $X=249860 $Y=865380
X684 1098 1101 1 2 1126 AN2 $T=253580 739760 1 0 $X=253580 $Y=734340
X685 1110 12 1 2 1090 AN2 $T=253580 830480 0 0 $X=253580 $Y=830100
X686 1163 12 1 2 1070 AN2 $T=259160 830480 0 180 $X=256680 $Y=825060
X687 1161 1142 1 2 1088 AN2 $T=263500 759920 1 180 $X=261020 $Y=759540
X688 1169 1126 1 2 1177 AN2 $T=265360 739760 0 0 $X=265360 $Y=739380
X689 1171 1168 1 2 1144 AN2 $T=265980 719600 1 0 $X=265980 $Y=714180
X690 1170 1180 1 2 1195 AN2 $T=267220 800240 0 0 $X=267220 $Y=799860
X691 1182 12 1 2 1165 AN2 $T=270320 830480 1 0 $X=270320 $Y=825060
X692 1251 1253 1 2 1228 AN2 $T=283340 739760 0 180 $X=280860 $Y=734340
X693 1233 1184 1 2 1260 AN2 $T=280860 770000 1 0 $X=280860 $Y=764580
X694 72 1253 1 2 1250 AN2 $T=286440 739760 0 180 $X=283960 $Y=734340
X695 1264 1246 1 2 1277 AN2 $T=283960 749840 1 0 $X=283960 $Y=744420
X696 1285 1253 1 2 1208 AN2 $T=287680 729680 0 180 $X=285200 $Y=724260
X697 1281 1277 1 2 1289 AN2 $T=287060 749840 1 0 $X=287060 $Y=744420
X698 75 1253 1 2 1286 AN2 $T=290780 739760 0 180 $X=288300 $Y=734340
X699 1288 1284 1 2 1297 AN2 $T=288300 860720 1 0 $X=288300 $Y=855300
X700 1282 1257 1 2 1300 AN2 $T=289540 800240 1 0 $X=289540 $Y=794820
X701 1269 1289 1 2 1313 AN2 $T=292640 739760 0 0 $X=292640 $Y=739380
X702 1302 1300 1 2 1348 AN2 $T=292640 800240 0 0 $X=292640 $Y=799860
X703 1312 1313 1 2 1318 AN2 $T=294500 729680 0 0 $X=294500 $Y=729300
X704 1321 12 1 2 1304 AN2 $T=296980 830480 0 180 $X=294500 $Y=825060
X705 1314 1317 1 2 1330 AN2 $T=296360 719600 1 0 $X=296360 $Y=714180
X706 1303 12 1 2 1327 AN2 $T=296360 780080 0 0 $X=296360 $Y=779700
X707 1326 1318 1 2 1317 AN2 $T=300080 729680 1 180 $X=297600 $Y=729300
X708 1360 1353 1 2 1372 AN2 $T=305040 860720 0 0 $X=305040 $Y=860340
X709 1344 1330 1 2 1393 AN2 $T=309380 709520 0 0 $X=309380 $Y=709140
X710 1334 12 1 2 1388 AN2 $T=309380 770000 1 0 $X=309380 $Y=764580
X711 1374 1348 1 2 1382 AN2 $T=309380 800240 0 0 $X=309380 $Y=799860
X712 1400 1372 1 2 90 AN2 $T=312480 870800 0 180 $X=310000 $Y=865380
X713 1377 1393 1 2 89 AN2 $T=313720 699440 0 180 $X=311240 $Y=694020
X714 1390 1388 1 2 1403 AN2 $T=311240 749840 0 0 $X=311240 $Y=749460
X715 1373 12 1 2 1421 AN2 $T=311240 790160 0 0 $X=311240 $Y=789780
X716 1396 12 1 2 1394 AN2 $T=318060 790160 1 0 $X=318060 $Y=784740
X717 1389 1382 1 2 1437 AN2 $T=318060 810320 1 0 $X=318060 $Y=804900
X718 1447 12 1 2 1359 AN2 $T=323640 830480 0 180 $X=321160 $Y=825060
X719 111 98 1 2 1309 AN2 $T=324260 860720 0 180 $X=321780 $Y=855300
X720 1431 12 1 2 1455 AN2 $T=323020 780080 0 0 $X=323020 $Y=779700
X721 1470 1451 1 2 1335 AN2 $T=325500 800240 0 180 $X=323020 $Y=794820
X722 1457 1458 1 2 1474 AN2 $T=325500 790160 1 0 $X=325500 $Y=784740
X723 1481 1451 1 2 1224 AN2 $T=327980 800240 1 180 $X=325500 $Y=799860
X724 1519 1451 1 2 1265 AN2 $T=334180 800240 1 180 $X=331700 $Y=799860
X725 1510 1451 1 2 1296 AN2 $T=336040 790160 1 180 $X=333560 $Y=789780
X726 1505 98 1 2 1375 AN2 $T=336040 860720 0 180 $X=333560 $Y=855300
X727 1515 1507 1 2 1457 AN2 $T=337280 790160 0 180 $X=334800 $Y=784740
X728 1516 98 1 2 87 AN2 $T=337900 860720 1 180 $X=335420 $Y=860340
X729 1503 1437 1 2 1526 AN2 $T=337280 810320 1 0 $X=337280 $Y=804900
X730 116 122 1 2 124 AN2 $T=337900 870800 1 0 $X=337900 $Y=865380
X731 1522 1490 1 2 1537 AN2 $T=338520 709520 1 0 $X=338520 $Y=704100
X732 120 123 1 2 1531 AN2 $T=338520 840560 0 0 $X=338520 $Y=840180
X733 1536 12 1 2 1528 AN2 $T=342860 820400 1 180 $X=340380 $Y=820020
X734 1544 1361 1 2 1572 AN2 $T=343480 729680 0 0 $X=343480 $Y=729300
X735 1572 1578 1 2 1607 AN2 $T=350300 729680 0 0 $X=350300 $Y=729300
X736 1577 12 1 2 1601 AN2 $T=352160 770000 1 0 $X=352160 $Y=764580
X737 1603 1526 1 2 1634 AN2 $T=355880 810320 0 0 $X=355880 $Y=809940
X738 1631 12 1 2 1643 AN2 $T=359600 759920 1 0 $X=359600 $Y=754500
X739 1653 12 1 2 1620 AN2 $T=364560 830480 0 180 $X=362080 $Y=825060
X740 1557 132 1 2 1625 AN2 $T=362700 719600 0 0 $X=362700 $Y=719220
X741 1649 1652 1 2 1671 AN2 $T=363940 739760 1 0 $X=363940 $Y=734340
X742 156 132 1 2 1662 AN2 $T=364560 709520 1 0 $X=364560 $Y=704100
X743 1592 132 1 2 1664 AN2 $T=365800 719600 0 0 $X=365800 $Y=719220
X744 1678 1687 1 2 176 AN2 $T=369520 699440 1 0 $X=369520 $Y=694020
X745 1674 1688 1 2 1687 AN2 $T=369520 699440 0 0 $X=369520 $Y=699060
X746 1679 1689 1 2 1688 AN2 $T=369520 709520 1 0 $X=369520 $Y=704100
X747 1705 1693 1 2 1680 AN2 $T=372000 719600 1 180 $X=369520 $Y=719220
X748 1646 1671 1 2 1709 AN2 $T=369520 739760 1 0 $X=369520 $Y=734340
X749 1692 1680 1 2 1689 AN2 $T=370760 719600 1 0 $X=370760 $Y=714180
X750 1691 1634 1 2 1722 AN2 $T=374480 810320 1 0 $X=374480 $Y=804900
X751 1724 12 1 2 1712 AN2 $T=376340 820400 0 0 $X=376340 $Y=820020
X752 1709 1720 1 2 1737 AN2 $T=377580 729680 1 0 $X=377580 $Y=724260
X753 1754 1737 1 2 1693 AN2 $T=383780 719600 1 180 $X=381300 $Y=719220
X754 1753 1722 1 2 1770 AN2 $T=384400 800240 0 0 $X=384400 $Y=799860
X755 1766 12 1 2 1768 AN2 $T=386260 759920 1 0 $X=386260 $Y=754500
X756 1816 1770 1 2 1831 AN2 $T=398040 810320 1 0 $X=398040 $Y=804900
X757 1853 12 1 2 1803 AN2 $T=404240 749840 1 180 $X=401760 $Y=749460
X758 1856 1831 1 2 1878 AN2 $T=410440 810320 1 0 $X=410440 $Y=804900
X759 1881 1878 1 2 1871 AN2 $T=413540 810320 1 180 $X=411060 $Y=809940
X760 229 12 1 2 194 AN2 $T=420980 699440 0 180 $X=418500 $Y=694020
X761 224 12 1 2 197 AN2 $T=420980 709520 1 180 $X=418500 $Y=709140
X762 233 12 1 2 1777 AN2 $T=420980 719600 0 180 $X=418500 $Y=714180
X763 225 12 1 2 1763 AN2 $T=420980 729680 0 180 $X=418500 $Y=724260
X764 1892 223 1 2 1841 AN2 $T=420980 830480 0 180 $X=418500 $Y=825060
X765 1906 1871 1 2 1915 AN2 $T=421600 810320 1 0 $X=421600 $Y=804900
X766 1944 1915 1 2 1964 AN2 $T=432140 810320 0 0 $X=432140 $Y=809940
X767 1961 1957 1 2 1942 AN2 $T=436480 709520 1 180 $X=434000 $Y=709140
X768 1942 1945 1 2 1973 AN2 $T=434000 719600 0 0 $X=434000 $Y=719220
X769 244 246 1 2 1961 AN2 $T=435860 699440 0 0 $X=435860 $Y=699060
X770 1967 223 1 2 1921 AN2 $T=438340 830480 1 180 $X=435860 $Y=830100
X771 1969 1964 1 2 2005 AN2 $T=438960 800240 0 0 $X=438960 $Y=799860
X772 253 251 1 2 2018 AN2 $T=440820 870800 1 0 $X=440820 $Y=865380
X773 2014 2005 1 2 2022 AN2 $T=445160 800240 1 0 $X=445160 $Y=794820
X774 2007 2029 1 2 2035 AN2 $T=447020 860720 1 0 $X=447020 $Y=855300
X775 2010 2022 1 2 2046 AN2 $T=447640 800240 1 0 $X=447640 $Y=794820
X776 2049 2018 1 2 2029 AN2 $T=451980 870800 0 180 $X=449500 $Y=865380
X777 2038 223 1 2 1976 AN2 $T=453220 830480 0 180 $X=450740 $Y=825060
X778 2039 2046 1 2 2065 AN2 $T=452600 800240 1 0 $X=452600 $Y=794820
X779 2078 2058 1 2 2051 AN2 $T=455700 790160 0 180 $X=453220 $Y=784740
X780 2075 2065 1 2 2058 AN2 $T=458800 790160 1 180 $X=456320 $Y=789780
X781 2097 2051 1 2 2034 AN2 $T=460040 780080 1 180 $X=457560 $Y=779700
X782 2158 223 1 2 2112 AN2 $T=473680 830480 1 180 $X=471200 $Y=830100
X783 2157 223 1 2 2060 AN2 $T=475540 820400 0 180 $X=473060 $Y=814980
X784 2161 223 1 2 2085 AN2 $T=476780 830480 0 180 $X=474300 $Y=825060
X785 2172 223 1 2 2116 AN2 $T=479260 820400 0 180 $X=476780 $Y=814980
X786 2178 223 1 2 2062 AN2 $T=479260 830480 1 180 $X=476780 $Y=830100
X787 2188 223 1 2 1989 AN2 $T=482360 810320 1 180 $X=479880 $Y=809940
X788 2196 223 1 2 2134 AN2 $T=486080 800240 1 180 $X=483600 $Y=799860
X789 2191 223 1 2 2203 AN2 $T=489180 790160 1 180 $X=486700 $Y=789780
X790 2213 223 1 2 2152 AN2 $T=489180 800240 0 180 $X=486700 $Y=794820
X791 2221 223 1 2 2132 AN2 $T=491040 800240 1 180 $X=488560 $Y=799860
X792 2261 324 1 2 2235 AN2 $T=503440 749840 1 0 $X=503440 $Y=744420
X793 312 315 1 2 2244 AN2 $T=518940 729680 1 0 $X=518940 $Y=724260
X794 2244 306 1 2 2269 AN2 $T=521420 729680 1 180 $X=518940 $Y=729300
X795 2351 2364 1 2 2342 AN2 $T=521420 810320 1 180 $X=518940 $Y=809940
X796 2335 2358 1 2 2379 AN2 $T=523900 770000 1 0 $X=523900 $Y=764580
X797 2379 2307 1 2 331 AN2 $T=526380 770000 1 0 $X=526380 $Y=764580
X798 2300 2279 1 2 2405 AN2 $T=533200 800240 0 180 $X=530720 $Y=794820
X799 367 223 1 2 364 AN2 $T=538780 870800 0 180 $X=536300 $Y=865380
X800 396 397 1 2 2611 AN2 $T=582180 820400 0 0 $X=582180 $Y=820020
X801 396 397 1 2 2656 AN2 $T=586520 820400 0 180 $X=584040 $Y=814980
X802 261 2652 1 2 2666 AN2 $T=589620 759920 1 180 $X=587140 $Y=759540
X803 261 2691 1 2 2661 AN2 $T=593340 759920 1 180 $X=590860 $Y=759540
X804 2738 1905 1 2 2715 AN2 $T=603260 770000 1 180 $X=600780 $Y=769620
X805 2746 1929 1 2 2738 AN2 $T=606980 770000 0 180 $X=604500 $Y=764580
X806 2740 2064 1 2 2746 AN2 $T=604500 780080 0 0 $X=604500 $Y=779700
X807 2763 2306 1 2 2728 AN2 $T=610080 759920 1 180 $X=607600 $Y=759540
X808 332 336 1 2 2791 AN2 $T=609460 699440 1 0 $X=609460 $Y=694020
X809 347 276 1 2 2773 AN2 $T=609460 719600 1 0 $X=609460 $Y=714180
X810 2774 2128 1 2 2740 AN2 $T=611940 780080 1 180 $X=609460 $Y=779700
X811 2742 2743 1 2 2772 AN2 $T=609460 830480 0 0 $X=609460 $Y=830100
X812 2773 2535 1 2 2745 AN2 $T=613800 719600 1 180 $X=611320 $Y=719220
X813 2745 2084 1 2 2776 AN2 $T=611320 729680 1 0 $X=611320 $Y=724260
X814 2747 2752 1 2 2781 AN2 $T=611320 820400 1 0 $X=611320 $Y=814980
X815 2781 2777 1 2 2742 AN2 $T=613800 830480 0 180 $X=611320 $Y=825060
X816 2776 2513 1 2 2795 AN2 $T=612560 739760 1 0 $X=612560 $Y=734340
X817 2786 2141 1 2 2774 AN2 $T=615040 770000 1 180 $X=612560 $Y=769620
X818 2792 2145 1 2 2786 AN2 $T=616900 770000 0 180 $X=614420 $Y=764580
X819 2772 2778 1 2 2801 AN2 $T=614420 830480 0 0 $X=614420 $Y=830100
X820 2793 338 1 2 2810 AN2 $T=615660 709520 0 0 $X=615660 $Y=709140
X821 2791 337 1 2 2793 AN2 $T=616280 699440 1 0 $X=616280 $Y=694020
X822 2794 2311 1 2 2818 AN2 $T=616280 719600 0 0 $X=616280 $Y=719220
X823 2795 2061 1 2 2806 AN2 $T=616280 739760 1 0 $X=616280 $Y=734340
X824 2806 2067 1 2 2792 AN2 $T=618760 759920 0 180 $X=616280 $Y=754500
X825 2814 2271 1 2 2763 AN2 $T=618760 759920 1 180 $X=616280 $Y=759540
X826 2787 2790 1 2 2747 AN2 $T=618760 810320 1 180 $X=616280 $Y=809940
X827 2822 2815 1 2 2787 AN2 $T=621240 810320 0 180 $X=618760 $Y=804900
X828 2810 2341 1 2 2794 AN2 $T=619380 719600 1 0 $X=619380 $Y=714180
X829 2828 2277 1 2 2814 AN2 $T=621860 759920 1 180 $X=619380 $Y=759540
X830 2818 2326 1 2 2844 AN2 $T=621240 729680 1 0 $X=621240 $Y=724260
X831 2860 2835 1 2 2822 AN2 $T=623720 810320 0 180 $X=621240 $Y=804900
X832 2801 2816 1 2 2841 AN2 $T=621240 830480 1 0 $X=621240 $Y=825060
X833 2853 2508 1 2 2828 AN2 $T=625580 749840 1 180 $X=623100 $Y=749460
X834 2865 2305 1 2 2853 AN2 $T=627440 729680 0 180 $X=624960 $Y=724260
X835 2844 2339 1 2 2865 AN2 $T=624960 729680 0 0 $X=624960 $Y=729300
X836 2845 2848 1 2 2858 AN2 $T=626200 780080 1 0 $X=626200 $Y=774660
X837 2858 2861 1 2 2870 AN2 $T=628060 770000 0 0 $X=628060 $Y=769620
X838 2870 2866 1 2 2894 AN2 $T=629920 759920 0 0 $X=629920 $Y=759540
X839 2841 2885 1 2 2872 AN2 $T=629920 820400 0 0 $X=629920 $Y=820020
X840 2872 2875 1 2 2899 AN2 $T=631780 820400 1 0 $X=631780 $Y=814980
X841 2894 2898 1 2 2893 AN2 $T=635500 759920 1 180 $X=633020 $Y=759540
X842 2919 2911 1 2 2860 AN2 $T=639220 810320 0 180 $X=636740 $Y=804900
X843 2899 2905 1 2 2932 AN2 $T=641700 820400 1 0 $X=641700 $Y=814980
X844 2932 2942 1 2 2950 AN2 $T=643560 810320 0 0 $X=643560 $Y=809940
X845 2944 2946 1 2 2975 AN2 $T=646660 780080 1 0 $X=646660 $Y=774660
X846 478 432 1 2 2992 AN2 $T=648520 860720 0 0 $X=648520 $Y=860340
X847 2950 2966 1 2 2993 AN2 $T=649760 810320 0 0 $X=649760 $Y=809940
X848 2992 2785 1 2 3000 AN2 $T=652240 860720 0 0 $X=652240 $Y=860340
X849 3015 3024 1 2 3008 AN2 $T=658440 770000 1 0 $X=658440 $Y=764580
X850 3000 401 1 2 3041 AN2 $T=659060 860720 1 0 $X=659060 $Y=855300
X851 3041 427 1 2 3058 AN2 $T=663400 850640 0 0 $X=663400 $Y=850260
X852 3063 3061 1 2 3056 AN2 $T=667120 810320 1 180 $X=664640 $Y=809940
X853 3058 406 1 2 3067 AN2 $T=665260 840560 1 0 $X=665260 $Y=835140
X854 3077 3065 1 2 3037 AN2 $T=668360 830480 1 180 $X=665880 $Y=830100
X855 3066 3071 1 2 3074 AN2 $T=667120 759920 1 0 $X=667120 $Y=754500
X856 3067 452 1 2 3092 AN2 $T=667120 840560 0 0 $X=667120 $Y=840180
X857 3056 3064 1 2 3098 AN2 $T=670840 820400 0 0 $X=670840 $Y=820020
X858 3111 3105 1 2 3063 AN2 $T=675180 810320 0 180 $X=672700 $Y=804900
X859 3127 469 1 2 3143 AN2 $T=677660 840560 1 0 $X=677660 $Y=835140
X860 3139 3142 1 2 3150 AN2 $T=678900 739760 0 0 $X=678900 $Y=739380
X861 3122 3126 1 2 3156 AN2 $T=678900 759920 0 0 $X=678900 $Y=759540
X862 3147 3144 1 2 3137 AN2 $T=681380 780080 1 180 $X=678900 $Y=779700
X863 3098 3112 1 2 3148 AN2 $T=678900 830480 1 0 $X=678900 $Y=825060
X864 3152 2991 1 2 3127 AN2 $T=681380 840560 1 180 $X=678900 $Y=840180
X865 3092 414 1 2 3152 AN2 $T=678900 850640 0 0 $X=678900 $Y=850260
X866 3143 2961 1 2 3077 AN2 $T=683240 840560 0 180 $X=680760 $Y=835140
X867 3161 3165 1 2 3175 AN2 $T=682620 739760 1 0 $X=682620 $Y=734340
X868 3155 3163 1 2 3111 AN2 $T=686960 810320 0 180 $X=684480 $Y=804900
X869 3186 3183 1 2 3155 AN2 $T=687580 810320 1 180 $X=685100 $Y=809940
X870 3170 3207 1 2 3217 AN2 $T=691300 719600 1 0 $X=691300 $Y=714180
X871 3189 3168 1 2 3232 AN2 $T=694400 729680 1 0 $X=694400 $Y=724260
X872 3244 3241 1 2 3233 AN2 $T=698740 800240 0 180 $X=696260 $Y=794820
X873 3233 3242 1 2 3186 AN2 $T=698740 810320 0 180 $X=696260 $Y=804900
X874 3263 3258 1 2 3244 AN2 $T=703700 790160 0 180 $X=701220 $Y=784740
X875 3300 3280 1 2 3263 AN2 $T=708660 800240 0 180 $X=706180 $Y=794820
X876 3298 542 1 2 3289 AN2 $T=710520 870800 0 180 $X=708040 $Y=865380
X877 572 504 1 2 3298 AN2 $T=712380 860720 1 180 $X=709900 $Y=860340
X878 576 575 1 2 572 AN2 $T=714240 870800 0 180 $X=711760 $Y=865380
X879 3292 3269 1 2 3308 AN2 $T=715480 780080 1 180 $X=713000 $Y=779700
X880 3305 3309 1 2 3300 AN2 $T=717340 800240 0 180 $X=714860 $Y=794820
X881 3310 3311 1 2 3305 AN2 $T=715480 810320 0 0 $X=715480 $Y=809940
X882 3281 3288 1 2 3319 AN2 $T=716720 830480 1 0 $X=716720 $Y=825060
X883 3319 3323 1 2 3310 AN2 $T=717960 810320 1 0 $X=717960 $Y=804900
X884 3336 490 1 2 3321 AN2 $T=722920 749840 0 0 $X=722920 $Y=749460
X885 3337 490 1 2 3350 AN2 $T=722920 800240 0 0 $X=722920 $Y=799860
X886 3345 490 1 2 3354 AN2 $T=723540 840560 0 0 $X=723540 $Y=840180
X887 4134 3894 1 2 4125 AN2 $T=930620 820400 0 180 $X=928140 $Y=814980
X888 4185 4179 1 2 4063 AN2 $T=944260 830480 1 180 $X=941780 $Y=830100
X889 4200 4188 1 2 835 AN2 $T=949840 860720 1 0 $X=949840 $Y=855300
X890 4200 3927 1 2 821 AN2 $T=951700 850640 0 0 $X=951700 $Y=850260
X891 4185 4198 1 2 3892 AN2 $T=953560 810320 0 0 $X=953560 $Y=809940
X892 845 4212 1 2 4182 AN2 $T=957280 860720 1 180 $X=954800 $Y=860340
X893 4211 4198 1 2 4123 AN2 $T=956660 810320 0 0 $X=956660 $Y=809940
X894 4185 4194 1 2 3987 AN2 $T=957280 820400 1 0 $X=957280 $Y=814980
X895 4211 4200 1 2 4110 AN2 $T=959760 820400 1 0 $X=959760 $Y=814980
X896 4211 4194 1 2 4126 AN2 $T=962240 820400 1 0 $X=962240 $Y=814980
X897 862 4271 1 2 4263 AN2 $T=984560 860720 1 180 $X=982080 $Y=860340
X898 876 4343 1 2 4314 AN2 $T=1006880 860720 0 180 $X=1004400 $Y=855300
X899 4416 4415 1 2 4337 AN2 $T=1035400 860720 1 0 $X=1035400 $Y=855300
X900 1237 1 2 1268 DELA $T=279000 780080 1 0 $X=279000 $Y=774660
X901 278 1 2 284 DELA $T=461900 699440 0 0 $X=461900 $Y=699060
X902 2094 1 2 2024 DELA $T=471820 719600 0 0 $X=471820 $Y=719220
X903 2263 1 2 2289 DELA $T=500960 790160 0 0 $X=500960 $Y=789780
X904 2299 1 2 2295 DELA $T=506540 820400 1 0 $X=506540 $Y=814980
X905 2391 1 2 2415 DELA $T=530100 860720 0 0 $X=530100 $Y=860340
X906 2439 1 2 2459 DELA $T=537540 830480 0 0 $X=537540 $Y=830100
X907 2440 1 2 2394 DELA $T=537540 860720 0 0 $X=537540 $Y=860340
X908 2473 1 2 2502 DELA $T=546220 810320 1 0 $X=546220 $Y=804900
X909 2496 1 2 2534 DELA $T=550560 850640 1 0 $X=550560 $Y=845220
X910 2542 1 2 2561 DELA $T=558620 780080 1 0 $X=558620 $Y=774660
X911 2564 1 2 2628 DELA $T=582180 759920 1 0 $X=582180 $Y=754500
X912 2522 1 2 2644 DELA $T=587140 759920 1 0 $X=587140 $Y=754500
X913 400 1 2 2693 DELA $T=587760 830480 1 0 $X=587760 $Y=825060
X914 2756 1 2 2847 DELA $T=620000 749840 1 0 $X=620000 $Y=744420
X915 2811 1 2 3040 DELA $T=656580 749840 0 0 $X=656580 $Y=749460
X916 3294 1 2 3260 DELA $T=709280 709520 0 0 $X=709280 $Y=709140
X917 3301 1 2 579 DELA $T=710520 810320 0 0 $X=710520 $Y=809940
X918 3381 1 2 609 DELA $T=734080 820400 0 0 $X=734080 $Y=820020
X919 3453 1 2 3473 DELA $T=753300 860720 1 0 $X=753300 $Y=855300
X920 3483 1 2 3500 DELA $T=759500 860720 0 0 $X=759500 $Y=860340
X921 3496 1 2 3499 DELA $T=771900 840560 0 0 $X=771900 $Y=840180
X922 3462 1 2 677 DELA $T=779340 820400 0 0 $X=779340 $Y=820020
X923 3408 1 2 681 DELA $T=811580 820400 0 0 $X=811580 $Y=820020
X924 3860 1 2 870 DELA $T=987660 830480 1 0 $X=987660 $Y=825060
X925 993 11 20 2 1 1047 QDFFRBN $T=229400 860720 0 0 $X=229400 $Y=860340
X926 1085 11 20 2 1 1023 QDFFRBN $T=248620 850640 1 180 $X=236840 $Y=850260
X927 1044 11 20 2 1 1019 QDFFRBN $T=249240 830480 0 180 $X=237460 $Y=825060
X928 1055 11 20 2 1 1110 QDFFRBN $T=241800 840560 1 0 $X=241800 $Y=835140
X929 1115 11 20 2 1 1163 QDFFRBN $T=253580 840560 1 0 $X=253580 $Y=835140
X930 1239 11 20 2 1 1182 QDFFRBN $T=282720 840560 0 180 $X=270940 $Y=835140
X931 1235 11 20 2 1 1292 QDFFRBN $T=278380 830480 1 0 $X=278380 $Y=825060
X932 1255 11 20 2 1 1303 QDFFRBN $T=281480 780080 0 0 $X=281480 $Y=779700
X933 1287 11 20 2 1 1321 QDFFRBN $T=287680 840560 1 0 $X=287680 $Y=835140
X934 1316 11 20 2 1 1373 QDFFRBN $T=295740 790160 0 0 $X=295740 $Y=789780
X935 1338 11 20 2 1 1396 QDFFRBN $T=300700 790160 1 0 $X=300700 $Y=784740
X936 1369 11 20 2 1 1433 QDFFRBN $T=306280 830480 1 0 $X=306280 $Y=825060
X937 1378 11 20 2 1 1431 QDFFRBN $T=307520 780080 0 0 $X=307520 $Y=779700
X938 1381 11 20 2 1 1447 QDFFRBN $T=308140 840560 1 0 $X=308140 $Y=835140
X939 1430 11 20 2 1 1536 QDFFRBN $T=326120 830480 1 0 $X=326120 $Y=825060
X940 1535 11 20 2 1 1577 QDFFRBN $T=349060 780080 1 0 $X=349060 $Y=774660
X941 1584 11 20 2 1 1631 QDFFRBN $T=349680 749840 0 0 $X=349680 $Y=749460
X942 1611 11 20 2 1 1653 QDFFRBN $T=353400 830480 0 0 $X=353400 $Y=830100
X943 1710 181 20 2 1 1724 QDFFRBN $T=374480 830480 1 0 $X=374480 $Y=825060
X944 1704 11 20 2 1 1766 QDFFRBN $T=375100 759920 0 0 $X=375100 $Y=759540
X945 1785 181 20 2 1 1827 QDFFRBN $T=389360 830480 1 0 $X=389360 $Y=825060
X946 1824 11 20 2 1 1853 QDFFRBN $T=399900 759920 0 0 $X=399900 $Y=759540
X947 1821 181 20 2 1 1892 QDFFRBN $T=404240 830480 1 0 $X=404240 $Y=825060
X948 1865 11 20 2 1 1899 QDFFRBN $T=408580 749840 0 0 $X=408580 $Y=749460
X949 1888 11 20 2 1 224 QDFFRBN $T=420980 709520 0 0 $X=420980 $Y=709140
X950 1904 11 20 2 1 233 QDFFRBN $T=420980 729680 1 0 $X=420980 $Y=724260
X951 1965 236 20 2 1 1905 QDFFRBN $T=433380 739760 0 180 $X=421600 $Y=734340
X952 1917 11 20 2 1 1898 QDFFRBN $T=422840 709520 1 0 $X=422840 $Y=704100
X953 1913 181 20 2 1 1967 QDFFRBN $T=422840 830480 1 0 $X=422840 $Y=825060
X954 1966 236 20 2 1 1914 QDFFRBN $T=435240 749840 0 180 $X=423460 $Y=744420
X955 1887 11 237 2 1 229 QDFFRBN $T=424080 699440 0 0 $X=424080 $Y=699060
X956 1889 11 20 2 1 225 QDFFRBN $T=436480 729680 1 180 $X=424700 $Y=729300
X957 1947 236 20 2 1 1929 QDFFRBN $T=432140 739760 0 0 $X=432140 $Y=739380
X958 1983 181 20 2 1 2038 QDFFRBN $T=437720 830480 1 0 $X=437720 $Y=825060
X959 2003 236 237 2 1 2052 QDFFRBN $T=441440 699440 1 0 $X=441440 $Y=694020
X960 2009 236 20 2 1 2067 QDFFRBN $T=442680 729680 0 0 $X=442680 $Y=729300
X961 2021 236 20 2 1 2074 QDFFRBN $T=444540 749840 1 0 $X=444540 $Y=744420
X962 2024 236 237 2 1 2077 QDFFRBN $T=445160 719600 1 0 $X=445160 $Y=714180
X963 2033 236 20 2 1 2083 QDFFRBN $T=447020 739760 0 0 $X=447020 $Y=739380
X964 2040 236 237 2 1 2084 QDFFRBN $T=450120 699440 0 0 $X=450120 $Y=699060
X965 2089 236 20 2 1 2141 QDFFRBN $T=459420 780080 1 0 $X=459420 $Y=774660
X966 2095 236 20 2 1 2145 QDFFRBN $T=460040 749840 1 0 $X=460040 $Y=744420
X967 2096 236 20 2 1 2148 QDFFRBN $T=460660 749840 0 0 $X=460660 $Y=749460
X968 2091 181 20 2 1 2157 QDFFRBN $T=465000 840560 0 0 $X=465000 $Y=840180
X969 2099 181 296 2 1 2188 QDFFRBN $T=475540 850640 1 0 $X=475540 $Y=845220
X970 2159 181 296 2 1 2204 QDFFRBN $T=475540 860720 1 0 $X=475540 $Y=855300
X971 2154 181 296 2 1 2178 QDFFRBN $T=479880 840560 1 0 $X=479880 $Y=835140
X972 2199 2210 20 2 1 2254 QDFFRBN $T=487940 770000 1 0 $X=487940 $Y=764580
X973 2223 181 20 2 1 2172 QDFFRBN $T=490420 850640 1 0 $X=490420 $Y=845220
X974 2228 2210 20 2 1 2262 QDFFRBN $T=491040 790160 1 0 $X=491040 $Y=784740
X975 2229 2210 20 2 1 2275 QDFFRBN $T=491040 800240 1 0 $X=491040 $Y=794820
X976 2289 323 296 2 1 2233 QDFFRBN $T=504060 800240 1 180 $X=492280 $Y=799860
X977 2239 181 20 2 1 2196 QDFFRBN $T=494760 840560 1 0 $X=494760 $Y=835140
X978 2295 323 296 2 1 2237 QDFFRBN $T=507780 820400 1 180 $X=496000 $Y=820020
X979 2241 181 296 2 1 2213 QDFFRBN $T=496620 810320 0 0 $X=496620 $Y=809940
X980 2222 181 20 2 1 2221 QDFFRBN $T=496620 830480 1 0 $X=496620 $Y=825060
X981 2168 181 296 2 1 2161 QDFFRBN $T=498480 850640 0 0 $X=498480 $Y=850260
X982 2356 323 296 2 1 2292 QDFFRBN $T=517700 860720 0 180 $X=505920 $Y=855300
X983 2415 323 296 2 1 2363 QDFFRBN $T=533200 860720 0 180 $X=521420 $Y=855300
X984 363 181 296 2 1 345 QDFFRBN $T=533200 870800 0 180 $X=521420 $Y=865380
X985 2384 323 296 2 1 2310 QDFFRBN $T=523280 780080 0 0 $X=523280 $Y=779700
X986 2432 323 296 2 1 2364 QDFFRBN $T=537540 830480 0 180 $X=525760 $Y=825060
X987 2453 323 296 2 1 2440 QDFFRBN $T=549320 860720 0 180 $X=537540 $Y=855300
X988 2459 236 296 2 1 2437 QDFFRBN $T=553040 830480 0 180 $X=541260 $Y=825060
X989 2515 323 296 2 1 2297 QDFFRBN $T=553660 739760 1 180 $X=541880 $Y=739380
X990 2502 236 296 2 1 2426 QDFFRBN $T=560480 820400 0 180 $X=548700 $Y=814980
X991 2547 236 296 2 1 2470 QDFFRBN $T=561720 790160 1 180 $X=549940 $Y=789780
X992 2554 236 296 2 1 2489 QDFFRBN $T=562960 800240 1 180 $X=551180 $Y=799860
X993 2534 323 296 2 1 2491 QDFFRBN $T=564200 840560 1 180 $X=552420 $Y=840180
X994 381 383 296 2 1 2590 QDFFRBN $T=557380 850640 0 0 $X=557380 $Y=850260
X995 382 383 377 2 1 2591 QDFFRBN $T=558000 860720 1 0 $X=558000 $Y=855300
X996 384 383 377 2 1 389 QDFFRBN $T=560480 870800 1 0 $X=560480 $Y=865380
X997 2568 383 377 2 1 2612 QDFFRBN $T=563580 860720 0 0 $X=563580 $Y=860340
X998 2615 236 296 2 1 2526 QDFFRBN $T=576600 759920 1 180 $X=564820 $Y=759540
X999 2523 383 296 2 1 2621 QDFFRBN $T=565440 840560 0 0 $X=565440 $Y=840180
X1000 2625 236 296 2 1 2481 QDFFRBN $T=578460 770000 0 180 $X=566680 $Y=764580
X1001 2557 2599 296 2 1 2646 QDFFRBN $T=568540 820400 0 0 $X=568540 $Y=820020
X1002 2525 2599 296 2 1 2635 QDFFRBN $T=568540 830480 1 0 $X=568540 $Y=825060
X1003 2490 2599 296 2 1 2634 QDFFRBN $T=568540 830480 0 0 $X=568540 $Y=830100
X1004 2632 236 296 2 1 2541 QDFFRBN $T=580940 770000 1 180 $X=569160 $Y=769620
X1005 2596 2599 296 2 1 2645 QDFFRBN $T=569160 820400 1 0 $X=569160 $Y=814980
X1006 2638 236 296 2 1 2463 QDFFRBN $T=581560 780080 0 180 $X=569780 $Y=774660
X1007 2624 236 296 2 1 2430 QDFFRBN $T=582800 790160 1 180 $X=571020 $Y=789780
X1008 2528 2599 296 2 1 2658 QDFFRBN $T=573500 810320 1 0 $X=573500 $Y=804900
X1009 2622 323 296 2 1 2305 QDFFRBN $T=575980 729680 0 0 $X=575980 $Y=729300
X1010 2684 398 377 2 1 391 QDFFRBN $T=587760 870800 0 180 $X=575980 $Y=865380
X1011 2629 323 296 2 1 2277 QDFFRBN $T=577220 729680 1 0 $X=577220 $Y=724260
X1012 2537 383 296 2 1 2671 QDFFRBN $T=577220 840560 0 0 $X=577220 $Y=840180
X1013 2570 2599 296 2 1 2681 QDFFRBN $T=577840 800240 1 0 $X=577840 $Y=794820
X1014 2701 398 377 2 1 2626 QDFFRBN $T=589620 860720 0 180 $X=577840 $Y=855300
X1015 368 383 377 2 1 2678 QDFFRBN $T=578460 850640 0 0 $X=578460 $Y=850260
X1016 2607 2599 296 2 1 2704 QDFFRBN $T=584040 830480 0 0 $X=584040 $Y=830100
X1017 2549 2599 296 2 1 2710 QDFFRBN $T=585280 810320 1 0 $X=585280 $Y=804900
X1018 2717 398 377 2 1 2674 QDFFRBN $T=600780 840560 1 180 $X=589000 $Y=840180
X1019 2589 2599 296 2 1 2720 QDFFRBN $T=589620 820400 0 0 $X=589620 $Y=820020
X1020 2680 323 296 2 1 2271 QDFFRBN $T=590240 729680 0 0 $X=590240 $Y=729300
X1021 2616 2599 296 2 1 2707 QDFFRBN $T=590240 820400 1 0 $X=590240 $Y=814980
X1022 2586 323 296 2 1 2732 QDFFRBN $T=591480 719600 0 0 $X=591480 $Y=719220
X1023 2623 2599 296 2 1 2739 QDFFRBN $T=592100 800240 1 0 $X=592100 $Y=794820
X1024 2631 2599 296 2 1 2731 QDFFRBN $T=592720 830480 1 0 $X=592720 $Y=825060
X1025 2737 398 377 2 1 2697 QDFFRBN $T=605120 850640 0 180 $X=593340 $Y=845220
X1026 2726 398 377 2 1 2687 QDFFRBN $T=605120 850640 1 180 $X=593340 $Y=850260
X1027 2703 323 296 2 1 2306 QDFFRBN $T=594580 739760 1 0 $X=594580 $Y=734340
X1028 2708 323 296 2 1 2311 QDFFRBN $T=595200 719600 1 0 $X=595200 $Y=714180
X1029 412 323 296 2 1 2749 QDFFRBN $T=595820 699440 1 0 $X=595820 $Y=694020
X1030 2572 2599 296 2 1 2750 QDFFRBN $T=595820 800240 0 0 $X=595820 $Y=799860
X1031 2588 2599 296 2 1 2735 QDFFRBN $T=597060 810320 1 0 $X=597060 $Y=804900
X1032 2619 323 296 2 1 2326 QDFFRBN $T=598300 709520 0 0 $X=598300 $Y=709140
X1033 2721 323 296 2 1 2341 QDFFRBN $T=600160 699440 0 0 $X=600160 $Y=699060
X1034 2350 2599 296 2 1 2800 QDFFRBN $T=603260 790160 0 0 $X=603260 $Y=789780
X1035 2618 2599 296 2 1 2823 QDFFRBN $T=606360 800240 1 0 $X=606360 $Y=794820
X1036 2650 2599 296 2 1 2820 QDFFRBN $T=607600 800240 0 0 $X=607600 $Y=799860
X1037 2733 323 296 2 1 2846 QDFFRBN $T=608840 729680 0 0 $X=608840 $Y=729300
X1038 2783 398 377 2 1 2850 QDFFRBN $T=613180 850640 1 0 $X=613180 $Y=845220
X1039 2788 398 377 2 1 446 QDFFRBN $T=614420 840560 0 0 $X=614420 $Y=840180
X1040 2930 398 377 2 1 456 QDFFRBN $T=641700 840560 0 180 $X=629920 $Y=835140
X1041 2914 398 377 2 1 2972 QDFFRBN $T=637360 830480 0 0 $X=637360 $Y=830100
X1042 2980 398 377 2 1 472 QDFFRBN $T=650380 830480 0 0 $X=650380 $Y=830100
X1043 3057 398 377 2 1 477 QDFFRBN $T=666500 830480 0 180 $X=654720 $Y=825060
X1044 3068 495 296 2 1 2963 QDFFRBN $T=668980 699440 1 180 $X=657200 $Y=699060
X1045 2994 495 296 2 1 2997 QDFFRBN $T=657820 709520 1 0 $X=657820 $Y=704100
X1046 3032 495 296 2 1 3079 QDFFRBN $T=658440 729680 1 0 $X=658440 $Y=724260
X1047 2923 495 296 2 1 2996 QDFFRBN $T=660300 709520 0 0 $X=660300 $Y=709140
X1048 3113 495 296 2 1 3054 QDFFRBN $T=676420 699440 0 180 $X=664640 $Y=694020
X1049 3133 495 296 2 1 3069 QDFFRBN $T=679520 719600 1 180 $X=667740 $Y=719220
X1050 510 495 296 2 1 3097 QDFFRBN $T=669600 709520 1 0 $X=669600 $Y=704100
X1051 3179 3200 377 2 1 3249 QDFFRBN $T=688200 840560 0 0 $X=688200 $Y=840180
X1052 3188 3200 377 2 1 3253 QDFFRBN $T=689440 840560 1 0 $X=689440 $Y=835140
X1053 3141 3200 377 2 1 3270 QDFFRBN $T=693160 830480 1 0 $X=693160 $Y=825060
X1054 3225 551 377 2 1 542 QDFFRBN $T=694400 850640 0 0 $X=694400 $Y=850260
X1055 521 551 377 2 1 504 QDFFRBN $T=695640 870800 1 0 $X=695640 $Y=865380
X1056 552 3200 377 2 1 3312 QDFFRBN $T=696260 860720 1 0 $X=696260 $Y=855300
X1057 3173 551 377 2 1 548 QDFFRBN $T=698740 850640 1 0 $X=698740 $Y=845220
X1058 3130 3200 377 2 1 3303 QDFFRBN $T=699980 840560 0 0 $X=699980 $Y=840180
X1059 3100 3200 377 2 1 3317 QDFFRBN $T=704940 830480 1 0 $X=704940 $Y=825060
X1060 3120 3200 583 2 1 3330 QDFFRBN $T=709280 820400 0 0 $X=709280 $Y=820020
X1061 3101 3200 377 2 1 3339 QDFFRBN $T=711760 840560 0 0 $X=711760 $Y=840180
X1062 3094 3200 377 2 1 3340 QDFFRBN $T=711760 850640 1 0 $X=711760 $Y=845220
X1063 2847 3314 583 2 1 3343 QDFFRBN $T=712380 780080 1 0 $X=712380 $Y=774660
X1064 2759 3314 583 2 1 3333 QDFFRBN $T=713620 759920 1 0 $X=713620 $Y=754500
X1065 3216 3314 583 2 1 3362 QDFFRBN $T=714240 790160 1 0 $X=714240 $Y=784740
X1066 3087 3200 377 2 1 3355 QDFFRBN $T=714240 860720 1 0 $X=714240 $Y=855300
X1067 2976 3200 377 2 1 3366 QDFFRBN $T=715480 860720 0 0 $X=715480 $Y=860340
X1068 3040 3314 583 2 1 3369 QDFFRBN $T=717340 739760 0 0 $X=717340 $Y=739380
X1069 2771 3314 583 2 1 3370 QDFFRBN $T=717960 790160 0 0 $X=717960 $Y=789780
X1070 2936 3314 583 2 1 3371 QDFFRBN $T=717960 800240 1 0 $X=717960 $Y=794820
X1071 3349 593 377 2 1 3389 QDFFRBN $T=723540 870800 1 0 $X=723540 $Y=865380
X1072 2724 3314 583 2 1 3390 QDFFRBN $T=724160 810320 0 0 $X=724160 $Y=809940
X1073 2796 3314 583 2 1 3387 QDFFRBN $T=724780 749840 1 0 $X=724780 $Y=744420
X1074 2964 3314 583 2 1 3394 QDFFRBN $T=725400 759920 1 0 $X=725400 $Y=754500
X1075 2724 3314 583 2 1 3396 QDFFRBN $T=725400 810320 1 0 $X=725400 $Y=804900
X1076 3007 3364 583 2 1 3401 QDFFRBN $T=726020 780080 1 0 $X=726020 $Y=774660
X1077 3230 3314 583 2 1 3357 QDFFRBN $T=738420 770000 0 180 $X=726640 $Y=764580
X1078 3363 3364 583 2 1 3404 QDFFRBN $T=727260 719600 1 0 $X=727260 $Y=714180
X1079 3171 3314 583 2 1 3391 QDFFRBN $T=727260 790160 1 0 $X=727260 $Y=784740
X1080 3378 3200 377 2 1 3399 QDFFRBN $T=730360 860720 0 0 $X=730360 $Y=860340
X1081 604 3314 583 2 1 3414 QDFFRBN $T=731600 739760 0 0 $X=731600 $Y=739380
X1082 3416 610 583 2 1 372 QDFFRBN $T=745860 709520 0 180 $X=734080 $Y=704100
X1083 3020 3364 583 2 1 3420 QDFFRBN $T=734700 729680 1 0 $X=734700 $Y=724260
X1084 2940 3364 583 2 1 3471 QDFFRBN $T=735940 739760 1 0 $X=735940 $Y=734340
X1085 3073 3364 583 2 1 3431 QDFFRBN $T=737180 719600 0 0 $X=737180 $Y=719220
X1086 2462 610 583 2 1 3424 QDFFRBN $T=737180 759920 1 0 $X=737180 $Y=754500
X1087 2724 3314 583 2 1 3425 QDFFRBN $T=737180 820400 1 0 $X=737180 $Y=814980
X1088 3124 3200 377 2 1 3427 QDFFRBN $T=737180 840560 1 0 $X=737180 $Y=835140
X1089 3124 3200 377 2 1 3429 QDFFRBN $T=737180 850640 1 0 $X=737180 $Y=845220
X1090 603 610 377 2 1 3428 QDFFRBN $T=737180 860720 1 0 $X=737180 $Y=855300
X1091 2724 3314 583 2 1 3433 QDFFRBN $T=738420 810320 1 0 $X=738420 $Y=804900
X1092 2724 3314 583 2 1 3434 QDFFRBN $T=738420 810320 0 0 $X=738420 $Y=809940
X1093 611 593 377 2 1 3436 QDFFRBN $T=739040 870800 1 0 $X=739040 $Y=865380
X1094 3180 3314 583 2 1 3448 QDFFRBN $T=740280 749840 1 0 $X=740280 $Y=744420
X1095 2910 3364 583 2 1 3412 QDFFRBN $T=741520 770000 1 0 $X=741520 $Y=764580
X1096 3415 3364 583 2 1 631 QDFFRBN $T=743380 719600 1 0 $X=743380 $Y=714180
X1097 2969 3364 583 2 1 3489 QDFFRBN $T=745860 739760 0 0 $X=745860 $Y=739380
X1098 3124 3200 377 2 1 3453 QDFFRBN $T=746480 860720 0 0 $X=746480 $Y=860340
X1099 2813 3364 583 2 1 3485 QDFFRBN $T=748960 759920 1 0 $X=748960 $Y=754500
X1100 3124 3200 377 2 1 3496 QDFFRBN $T=751440 850640 1 0 $X=751440 $Y=845220
X1101 3124 3200 377 2 1 3483 QDFFRBN $T=751440 850640 0 0 $X=751440 $Y=850260
X1102 2926 3364 583 2 1 3508 QDFFRBN $T=752060 719600 0 0 $X=752060 $Y=719220
X1103 3447 3364 583 2 1 3503 QDFFRBN $T=752680 729680 0 0 $X=752680 $Y=729300
X1104 3469 610 646 2 1 3461 QDFFRBN $T=756400 699440 1 0 $X=756400 $Y=694020
X1105 3060 3364 583 2 1 3536 QDFFRBN $T=757020 749840 0 0 $X=757020 $Y=749460
X1106 3549 610 583 2 1 3331 QDFFRBN $T=771280 729680 0 180 $X=759500 $Y=724260
X1107 3546 610 583 2 1 3494 QDFFRBN $T=774380 719600 0 180 $X=762600 $Y=714180
X1108 3515 610 646 2 1 668 QDFFRBN $T=765700 699440 0 0 $X=765700 $Y=699060
X1109 3558 610 660 2 1 3527 QDFFRBN $T=781820 719600 1 180 $X=770040 $Y=719220
X1110 3591 610 660 2 1 3482 QDFFRBN $T=784920 729680 1 180 $X=773140 $Y=729300
X1111 3602 610 646 2 1 662 QDFFRBN $T=788020 709520 0 180 $X=776240 $Y=704100
X1112 3619 610 675 2 1 671 QDFFRBN $T=792360 709520 1 180 $X=780580 $Y=709140
X1113 694 691 675 2 1 680 QDFFRBN $T=800420 699440 1 180 $X=788640 $Y=699060
X1114 3626 610 583 2 1 3593 QDFFRBN $T=801660 749840 0 180 $X=789880 $Y=744420
X1115 3594 610 583 2 1 3586 QDFFRBN $T=802280 729680 1 180 $X=790500 $Y=729300
X1116 3653 691 675 2 1 3622 QDFFRBN $T=802900 709520 0 180 $X=791120 $Y=704100
X1117 3675 610 583 2 1 3620 QDFFRBN $T=804760 749840 1 180 $X=792980 $Y=749460
X1118 3660 610 583 2 1 3563 QDFFRBN $T=806000 759920 1 180 $X=794220 $Y=759540
X1119 3695 691 675 2 1 3639 QDFFRBN $T=807860 709520 1 180 $X=796080 $Y=709140
X1120 699 691 675 2 1 688 QDFFRBN $T=809100 699440 0 180 $X=797320 $Y=694020
X1121 3652 610 660 2 1 3605 QDFFRBN $T=810340 739760 0 180 $X=798560 $Y=734340
X1122 3689 610 660 2 1 3580 QDFFRBN $T=810340 739760 1 180 $X=798560 $Y=739380
X1123 3712 691 675 2 1 3666 QDFFRBN $T=816540 699440 1 180 $X=804760 $Y=699060
X1124 3708 610 660 2 1 3621 QDFFRBN $T=816540 759920 0 180 $X=804760 $Y=754500
X1125 3723 610 660 2 1 3680 QDFFRBN $T=820880 749840 1 180 $X=809100 $Y=749460
X1126 3727 691 660 2 1 3673 QDFFRBN $T=822740 709520 1 180 $X=810960 $Y=709140
X1127 3730 610 660 2 1 3553 QDFFRBN $T=823360 749840 0 180 $X=811580 $Y=744420
X1128 712 691 660 2 1 3701 QDFFRBN $T=823980 699440 0 180 $X=812200 $Y=694020
X1129 3734 610 660 2 1 3690 QDFFRBN $T=825220 729680 0 180 $X=813440 $Y=724260
X1130 3738 610 660 2 1 3682 QDFFRBN $T=825840 729680 1 180 $X=814060 $Y=729300
X1131 702 691 660 2 1 3744 QDFFRBN $T=814680 709520 1 0 $X=814680 $Y=704100
X1132 3720 610 660 2 1 3671 QDFFRBN $T=817780 739760 0 0 $X=817780 $Y=739380
X1133 3326 593 583 2 1 3756 QDFFRBN $T=818400 850640 0 0 $X=818400 $Y=850260
X1134 3758 610 660 2 1 3554 QDFFRBN $T=831420 759920 0 180 $X=819640 $Y=754500
X1135 3760 610 660 2 1 709 QDFFRBN $T=832040 719600 1 180 $X=820260 $Y=719220
X1136 3777 610 660 2 1 3707 QDFFRBN $T=835760 749840 1 180 $X=823980 $Y=749460
X1137 3757 610 660 2 1 3771 QDFFRBN $T=829560 729680 0 0 $X=829560 $Y=729300
X1138 3759 610 660 2 1 3798 QDFFRBN $T=830800 729680 1 0 $X=830800 $Y=724260
X1139 3805 610 660 2 1 723 QDFFRBN $T=844440 709520 0 180 $X=832660 $Y=704100
X1140 3775 610 660 2 1 3807 QDFFRBN $T=833280 749840 1 0 $X=833280 $Y=744420
X1141 3819 610 660 2 1 3747 QDFFRBN $T=850640 739760 1 180 $X=838860 $Y=739380
X1142 3326 593 583 2 1 3823 QDFFRBN $T=839480 850640 1 0 $X=839480 $Y=845220
X1143 2954 3364 583 2 1 3840 QDFFRBN $T=840720 780080 1 0 $X=840720 $Y=774660
X1144 3326 593 583 2 1 3826 QDFFRBN $T=840720 850640 0 0 $X=840720 $Y=850260
X1145 2954 3364 583 2 1 3829 QDFFRBN $T=841340 800240 0 0 $X=841340 $Y=799860
X1146 2954 3364 583 2 1 3809 QDFFRBN $T=841960 780080 0 0 $X=841960 $Y=779700
X1147 3326 593 583 2 1 3832 QDFFRBN $T=841960 830480 0 0 $X=841960 $Y=830100
X1148 3827 610 660 2 1 732 QDFFRBN $T=854360 699440 1 180 $X=842580 $Y=699060
X1149 2954 3364 583 2 1 3830 QDFFRBN $T=842580 800240 1 0 $X=842580 $Y=794820
X1150 3843 610 660 2 1 3778 QDFFRBN $T=856840 709520 0 180 $X=845060 $Y=704100
X1151 743 746 660 2 1 766 QDFFRBN $T=845680 699440 1 0 $X=845680 $Y=694020
X1152 3326 593 583 2 1 3836 QDFFRBN $T=845680 840560 1 0 $X=845680 $Y=835140
X1153 3846 610 660 2 1 740 QDFFRBN $T=858080 729680 0 180 $X=846300 $Y=724260
X1154 3849 610 660 2 1 3581 QDFFRBN $T=858700 749840 0 180 $X=846920 $Y=744420
X1155 3864 610 660 2 1 3596 QDFFRBN $T=859320 749840 1 180 $X=847540 $Y=749460
X1156 2954 3364 583 2 1 3851 QDFFRBN $T=850020 790160 0 0 $X=850020 $Y=789780
X1157 3888 610 660 2 1 762 QDFFRBN $T=868620 709520 0 180 $X=856840 $Y=704100
X1158 772 746 660 2 1 781 QDFFRBN $T=861180 699440 1 0 $X=861180 $Y=694020
X1159 3911 610 660 2 1 3804 QDFFRBN $T=880400 709520 0 180 $X=868620 $Y=704100
X1160 3985 610 660 2 1 786 QDFFRBN $T=887840 699440 0 180 $X=876060 $Y=694020
X1161 3974 610 660 2 1 788 QDFFRBN $T=890320 699440 1 180 $X=878540 $Y=699060
X1162 4022 610 660 2 1 808 QDFFRBN $T=897140 699440 0 0 $X=897140 $Y=699060
X1163 824 610 660 2 1 4124 QDFFRBN $T=939920 699440 0 180 $X=928140 $Y=694020
X1164 843 610 660 2 1 4204 QDFFRBN $T=964720 699440 1 180 $X=952940 $Y=699060
X1165 847 610 660 2 1 4201 QDFFRBN $T=978360 699440 1 180 $X=966580 $Y=699060
X1166 849 610 660 2 1 4213 QDFFRBN $T=978980 709520 0 180 $X=967200 $Y=704100
X1167 1011 10 970 2 979 983 1 AO22 $T=231260 729680 0 180 $X=226300 $Y=724260
X1168 997 10 968 2 982 983 1 AO22 $T=231880 699440 0 180 $X=226920 $Y=694020
X1169 1007 10 972 2 980 7 1 AO22 $T=231880 770000 1 180 $X=226920 $Y=769620
X1170 1002 10 969 2 985 983 1 AO22 $T=232500 719600 1 180 $X=227540 $Y=719220
X1171 1014 10 989 2 1001 983 1 AO22 $T=235600 709520 1 180 $X=230640 $Y=709140
X1172 1021 10 971 2 975 983 1 AO22 $T=235600 749840 0 180 $X=230640 $Y=744420
X1173 1026 10 986 2 1003 983 1 AO22 $T=238080 749840 1 180 $X=233120 $Y=749460
X1174 1028 10 990 2 1000 7 1 AO22 $T=238080 770000 0 180 $X=233120 $Y=764580
X1175 1073 10 1053 2 1042 983 1 AO22 $T=249860 759920 0 180 $X=244900 $Y=754500
X1176 1065 35 1112 2 1104 1152 1 AO22 $T=258540 749840 1 0 $X=258540 $Y=744420
X1177 1164 35 1203 2 1208 1152 1 AO22 $T=271560 759920 1 0 $X=271560 $Y=754500
X1178 1190 35 1242 2 1250 1152 1 AO22 $T=277760 749840 0 0 $X=277760 $Y=749460
X1179 1258 35 1249 2 1241 1152 1 AO22 $T=283340 739760 1 180 $X=278380 $Y=739380
X1180 1156 27 1263 2 1265 1097 1 AO22 $T=281480 810320 0 0 $X=281480 $Y=809940
X1181 60 52 1271 2 1275 49 1 AO22 $T=282720 860720 0 0 $X=282720 $Y=860340
X1182 1216 27 1295 2 1296 1097 1 AO22 $T=288300 810320 0 0 $X=288300 $Y=809940
X1183 1256 35 1301 2 1286 1152 1 AO22 $T=290160 749840 0 0 $X=290160 $Y=749460
X1184 86 35 1341 2 84 1152 1 AO22 $T=304420 699440 0 180 $X=299460 $Y=694020
X1185 1354 35 1345 2 1337 83 1 AO22 $T=305040 709520 0 180 $X=300080 $Y=704100
X1186 1356 35 1346 2 1320 1152 1 AO22 $T=305040 719600 0 180 $X=300080 $Y=714180
X1187 1357 35 1342 2 1311 1152 1 AO22 $T=306280 739760 0 180 $X=301320 $Y=734340
X1188 1370 35 1331 2 1310 1152 1 AO22 $T=307520 719600 1 180 $X=302560 $Y=719220
X1189 1387 35 1347 2 1278 1152 1 AO22 $T=312480 729680 1 180 $X=307520 $Y=729300
X1190 1355 27 1363 2 1410 1419 1 AO22 $T=311860 810320 1 0 $X=311860 $Y=804900
X1191 1399 27 1460 2 1471 1419 1 AO22 $T=324260 810320 0 0 $X=324260 $Y=809940
X1192 1454 1488 1379 2 1365 93 1 AO22 $T=343480 749840 1 0 $X=343480 $Y=744420
X1193 1511 27 1553 2 1558 1419 1 AO22 $T=343480 810320 0 0 $X=343480 $Y=809940
X1194 1593 1488 1629 2 1625 93 1 AO22 $T=362700 749840 0 180 $X=357740 $Y=744420
X1195 1623 27 1639 2 1645 1419 1 AO22 $T=359600 810320 1 0 $X=359600 $Y=804900
X1196 1669 1488 1637 2 1664 93 1 AO22 $T=370760 729680 1 180 $X=365800 $Y=729300
X1197 1730 1488 1706 2 1617 93 1 AO22 $T=376960 729680 1 180 $X=372000 $Y=729300
X1198 1732 1488 1697 2 1662 93 1 AO22 $T=378200 739760 1 180 $X=373240 $Y=739380
X1199 1746 1488 1736 2 1640 93 1 AO22 $T=382540 749840 0 180 $X=377580 $Y=744420
X1200 193 188 1714 2 1670 93 1 AO22 $T=383160 699440 0 180 $X=378200 $Y=694020
X1201 191 188 1716 2 1655 93 1 AO22 $T=383160 709520 1 180 $X=378200 $Y=709140
X1202 1707 27 1738 2 1734 1419 1 AO22 $T=383160 810320 0 180 $X=378200 $Y=804900
X1203 1759 1488 1743 2 1642 93 1 AO22 $T=384400 729680 1 180 $X=379440 $Y=729300
X1204 1765 188 1727 2 1666 93 1 AO22 $T=385640 719600 0 180 $X=380680 $Y=714180
X1205 1761 27 1800 2 1801 1419 1 AO22 $T=391840 810320 0 0 $X=391840 $Y=809940
X1206 1749 12 1827 2 210 96 1 AO22 $T=398040 810320 0 0 $X=398040 $Y=809940
X1207 1834 27 1840 2 1848 1419 1 AO22 $T=409820 810320 1 180 $X=404860 $Y=809940
X1208 1767 12 1898 2 210 96 1 AO22 $T=416640 699440 0 0 $X=416640 $Y=699060
X1209 258 250 1972 2 1931 52 1 AO22 $T=440200 860720 0 180 $X=435240 $Y=855300
X1210 2012 2004 2000 2 1974 1419 1 AO22 $T=443920 790160 0 180 $X=438960 $Y=784740
X1211 2028 2017 250 2 1998 52 1 AO22 $T=446400 860720 0 180 $X=441440 $Y=855300
X1212 2068 250 2048 2 1952 52 1 AO22 $T=455080 860720 1 180 $X=450120 $Y=860340
X1213 2263 327 2252 2 2315 263 1 AO22 $T=506540 800240 0 0 $X=506540 $Y=799860
X1214 2299 327 2331 2 2333 263 1 AO22 $T=510260 810320 0 0 $X=510260 $Y=809940
X1215 2354 254 2343 2 2338 263 1 AO22 $T=517700 850640 1 180 $X=512740 $Y=850260
X1216 2391 254 2371 2 2332 263 1 AO22 $T=523900 850640 1 180 $X=518940 $Y=850260
X1217 2400 254 2390 2 2387 263 1 AO22 $T=528240 820400 1 180 $X=523280 $Y=820020
X1218 2453 254 2444 2 2438 263 1 AO22 $T=541260 850640 0 180 $X=536300 $Y=845220
X1219 2439 254 2461 2 2464 263 1 AO22 $T=547460 830480 1 180 $X=542500 $Y=830100
X1220 2473 254 2483 2 2475 263 1 AO22 $T=550560 820400 1 180 $X=545600 $Y=820020
X1221 2496 254 2487 2 2476 263 1 AO22 $T=550560 850640 0 180 $X=545600 $Y=845220
X1222 2849 453 454 2 2881 458 1 AO22 $T=626820 709520 0 0 $X=626820 $Y=709140
X1223 2869 453 484 2 2988 458 1 AO22 $T=649140 719600 0 0 $X=649140 $Y=719220
X1224 3075 2877 505 2 3051 458 1 AO22 $T=668980 800240 0 180 $X=664020 $Y=794820
X1225 3052 2877 511 2 3072 458 1 AO22 $T=669600 790160 1 0 $X=669600 $Y=784740
X1226 3110 2877 512 2 3090 458 1 AO22 $T=675180 800240 0 180 $X=670220 $Y=794820
X1227 3095 2877 3114 2 3104 458 1 AO22 $T=673320 780080 0 0 $X=673320 $Y=779700
X1228 3158 2877 3134 2 3129 458 1 AO22 $T=681380 800240 0 180 $X=676420 $Y=794820
X1229 3162 2877 530 2 3178 458 1 AO22 $T=682620 800240 1 0 $X=682620 $Y=794820
X1230 3182 2877 537 2 3195 458 1 AO22 $T=686340 790160 0 0 $X=686340 $Y=789780
X1231 3196 453 543 2 3212 458 1 AO22 $T=689440 699440 0 0 $X=689440 $Y=699060
X1232 3294 453 571 2 3284 458 1 AO22 $T=709900 719600 1 0 $X=709900 $Y=714180
X1233 3282 453 580 2 3313 458 1 AO22 $T=714860 709520 1 0 $X=714860 $Y=704100
X1234 3315 453 581 2 3290 458 1 AO22 $T=714860 719600 1 0 $X=714860 $Y=714180
X1235 3329 453 587 2 3335 458 1 AO22 $T=719820 719600 1 0 $X=719820 $Y=714180
X1236 3248 453 588 2 3341 458 1 AO22 $T=720440 709520 1 0 $X=720440 $Y=704100
X1237 3222 453 3342 2 3327 458 1 AO22 $T=721060 729680 0 0 $X=721060 $Y=729300
X1238 3359 453 599 2 3373 458 1 AO22 $T=727260 699440 0 0 $X=727260 $Y=699060
X1239 3264 453 600 2 3374 458 1 AO22 $T=727260 729680 0 0 $X=727260 $Y=729300
X1240 3594 3597 3595 2 3603 3610 1 AO22 $T=783680 770000 0 0 $X=783680 $Y=769620
X1241 3515 3597 3543 2 3616 3610 1 AO22 $T=787400 719600 1 0 $X=787400 $Y=714180
X1242 679 3597 3608 2 3617 3610 1 AO22 $T=787400 719600 0 0 $X=787400 $Y=719220
X1243 3602 3597 3533 2 3629 3610 1 AO22 $T=790500 739760 1 0 $X=790500 $Y=734340
X1244 3619 3597 3627 2 3635 3610 1 AO22 $T=791120 739760 0 0 $X=791120 $Y=739380
X1245 3626 3597 3524 2 3637 3610 1 AO22 $T=792360 790160 0 0 $X=792360 $Y=789780
X1246 3652 3597 3647 2 3645 3610 1 AO22 $T=801660 790160 0 180 $X=796700 $Y=784740
X1247 3660 3597 3633 2 3651 3610 1 AO22 $T=804140 770000 1 180 $X=799180 $Y=769620
X1248 3689 3597 3636 2 3672 3610 1 AO22 $T=809720 800240 1 180 $X=804760 $Y=799860
X1249 3675 3597 3538 2 3696 3610 1 AO22 $T=807240 770000 1 0 $X=807240 $Y=764580
X1250 3708 3597 3686 2 3697 3610 1 AO22 $T=814680 800240 1 180 $X=809720 $Y=799860
X1251 713 665 3747 2 717 719 1 AO22 $T=825840 699440 1 0 $X=825840 $Y=694020
X1252 3736 3597 3748 2 3750 3610 1 AO22 $T=825840 749840 1 0 $X=825840 $Y=744420
X1253 3742 3597 3669 2 3762 3610 1 AO22 $T=828320 770000 1 0 $X=828320 $Y=764580
X1254 3757 3597 3764 2 3774 3610 1 AO22 $T=830800 739760 0 0 $X=830800 $Y=739380
X1255 725 666 3778 2 731 719 1 AO22 $T=832040 699440 1 0 $X=832040 $Y=694020
X1256 3738 3597 3787 2 3792 3610 1 AO22 $T=836380 770000 0 0 $X=836380 $Y=769620
X1257 3775 3597 3790 2 3793 3610 1 AO22 $T=837000 759920 1 0 $X=837000 $Y=754500
X1258 3752 3597 3780 2 3794 3610 1 AO22 $T=837000 770000 1 0 $X=837000 $Y=764580
X1259 3777 3597 3784 2 3795 3610 1 AO22 $T=837000 810320 1 0 $X=837000 $Y=804900
X1260 3766 3597 3782 2 3797 3610 1 AO22 $T=838240 749840 0 0 $X=838240 $Y=749460
X1261 3805 3597 3808 2 3811 3610 1 AO22 $T=843200 770000 0 0 $X=843200 $Y=769620
X1262 3819 3597 3806 2 3812 3610 1 AO22 $T=850020 759920 1 180 $X=845060 $Y=759540
X1263 3827 3597 3822 2 3818 3610 1 AO22 $T=853120 729680 1 180 $X=848160 $Y=729300
X1264 3843 3597 3853 2 3867 3610 1 AO22 $T=858080 800240 1 0 $X=858080 $Y=794820
X1265 3730 3597 3869 2 3874 3610 1 AO22 $T=859940 800240 0 0 $X=859940 $Y=799860
X1266 3758 3597 3866 2 3881 3610 1 AO22 $T=861800 790160 1 0 $X=861800 $Y=784740
X1267 3911 3597 3916 2 3921 3610 1 AO22 $T=874820 739760 1 0 $X=874820 $Y=734340
X1268 3864 3597 3930 2 3936 3610 1 AO22 $T=878540 820400 1 0 $X=878540 $Y=814980
X1269 3849 3597 3938 2 3942 3610 1 AO22 $T=879780 790160 1 0 $X=879780 $Y=784740
X1270 3846 3597 3919 2 3945 3610 1 AO22 $T=880400 729680 0 0 $X=880400 $Y=729300
X1271 3974 3597 3962 2 3957 3610 1 AO22 $T=889700 749840 0 180 $X=884740 $Y=744420
X1272 3723 3597 3965 2 3967 3610 1 AO22 $T=884740 820400 1 0 $X=884740 $Y=814980
X1273 3888 3597 3969 2 3977 3610 1 AO22 $T=886600 729680 0 0 $X=886600 $Y=729300
X1274 4022 3597 3997 2 3991 3610 1 AO22 $T=895280 719600 0 180 $X=890320 $Y=714180
X1275 3985 3597 3968 2 4002 3610 1 AO22 $T=890320 739760 1 0 $X=890320 $Y=734340
X1276 1434 2 1219 1402 1380 1 1378 FA1S $T=314960 780080 1 0 $X=314960 $Y=774660
X1277 1934 2 1905 1918 1948 1 1954 FA1S $T=423460 749840 0 0 $X=423460 $Y=749460
X1278 1953 2 1905 1922 1981 1 1971 FA1S $T=432140 770000 0 0 $X=432140 $Y=769620
X1279 2047 2 2064 2072 2069 1 2032 FA1S $T=459420 770000 1 180 $X=447640 $Y=769620
X1280 1955 2 2064 2080 2090 1 2043 FA1S $T=463140 759920 1 180 $X=451360 $Y=759540
X1281 2069 2 2128 2150 2135 1 2100 FA1S $T=472440 770000 0 180 $X=460660 $Y=764580
X1282 2090 2 2128 2173 2120 1 2121 FA1S $T=477400 759920 0 180 $X=465620 $Y=754500
X1283 2291 2 2233 2322 2281 1 2252 FA1S $T=510260 810320 0 180 $X=498480 $Y=804900
X1284 2314 2 2292 2301 2346 1 2343 FA1S $T=504680 840560 0 0 $X=504680 $Y=840180
X1285 2330 2 2292 2308 2340 1 2338 FA1S $T=507780 830480 0 0 $X=507780 $Y=830100
X1286 2340 2 2237 2296 2349 1 2333 FA1S $T=510260 820400 0 0 $X=510260 $Y=820020
X1287 2349 2 2233 2337 2342 1 2315 FA1S $T=511500 800240 0 0 $X=511500 $Y=799860
X1288 2346 2 2237 2265 2291 1 2331 FA1S $T=511500 830480 1 0 $X=511500 $Y=825060
X1289 2367 2 2363 2376 2330 1 2332 FA1S $T=524520 840560 0 180 $X=512740 $Y=835140
X1290 2383 2 2363 2365 2314 1 2371 FA1S $T=518940 850640 1 0 $X=518940 $Y=845220
X1291 2407 2 2394 2396 2367 1 2438 FA1S $T=525140 840560 0 0 $X=525140 $Y=840180
X1292 2409 2 2394 2427 2383 1 2444 FA1S $T=526380 850640 0 0 $X=526380 $Y=850260
X1293 2416 2 2437 2399 2455 1 2464 FA1S $T=527620 840560 1 0 $X=527620 $Y=835140
X1294 2433 2 2437 2410 2454 1 2461 FA1S $T=531960 820400 0 0 $X=531960 $Y=820020
X1295 2443 2 2426 2414 2416 1 2475 FA1S $T=533820 820400 1 0 $X=533820 $Y=814980
X1296 2446 2 2463 331 2451 1 2478 FA1S $T=535060 790160 1 0 $X=535060 $Y=784740
X1297 2447 2 2426 2423 2433 1 2483 FA1S $T=535060 810320 0 0 $X=535060 $Y=809940
X1298 2451 2 2470 2435 2458 1 2494 FA1S $T=536300 800240 1 0 $X=536300 $Y=794820
X1299 2457 2 2481 330 2446 1 2505 FA1S $T=538160 770000 1 0 $X=538160 $Y=764580
X1300 2458 2 2489 2417 2443 1 2509 FA1S $T=539400 800240 0 0 $X=539400 $Y=799860
X1301 2455 2 2491 2406 2407 1 2476 FA1S $T=539400 840560 0 0 $X=539400 $Y=840180
X1302 2467 2 2481 2336 2511 1 2519 FA1S $T=540020 770000 0 0 $X=540020 $Y=769620
X1303 2454 2 2491 2465 2409 1 2487 FA1S $T=541260 850640 0 0 $X=541260 $Y=850260
X1304 2500 2 2526 305 2467 1 2551 FA1S $T=546220 759920 0 0 $X=546220 $Y=759540
X1305 2511 2 2463 2486 2520 1 2506 FA1S $T=547460 780080 0 0 $X=547460 $Y=779700
X1306 2521 2 2489 2445 2447 1 2558 FA1S $T=549940 810320 0 0 $X=549940 $Y=809940
X1307 2536 2 2508 2550 2544 1 2499 FA1S $T=562340 759920 0 180 $X=550560 $Y=754500
X1308 2520 2 2470 2300 2521 1 2566 FA1S $T=550560 800240 1 0 $X=550560 $Y=794820
X1309 2532 2 2526 2360 2457 1 2562 FA1S $T=552420 770000 1 0 $X=552420 $Y=764580
X1310 2559 2 2339 2543 2518 1 2601 FA1S $T=558620 729680 0 0 $X=558620 $Y=729300
X1311 2597 2 337 2573 388 1 392 FA1S $T=565440 699440 1 0 $X=565440 $Y=694020
X1312 2585 2 2311 2412 2593 1 2659 FA1S $T=573500 709520 0 0 $X=573500 $Y=709140
X1313 2639 2 2277 2493 2595 1 2613 FA1S $T=576600 749840 1 0 $X=576600 $Y=744420
X1314 2647 2 2271 2452 2639 1 2673 FA1S $T=577220 739760 1 0 $X=577220 $Y=734340
X1315 2660 2 338 394 2597 1 409 FA1S $T=580940 699440 1 0 $X=580940 $Y=694020
X1316 2719 2 2306 2485 2647 1 2690 FA1S $T=605120 749840 0 180 $X=593340 $Y=744420
X1317 2851 2 446 445 451 1 2803 FA1S $T=629300 860720 1 180 $X=617520 $Y=860340
X1318 2880 2 446 2852 2686 1 2857 FA1S $T=624960 860720 1 0 $X=624960 $Y=855300
X1319 2904 2 469 461 2851 1 2922 FA1S $T=631160 870800 1 0 $X=631160 $Y=865380
X1320 2941 2 2970 2949 2952 1 2874 FA1S $T=649140 759920 0 180 $X=637360 $Y=754500
X1321 2945 2 2979 2941 2962 1 2917 FA1S $T=650380 749840 0 180 $X=638600 $Y=744420
X1322 2949 2 2977 2959 2965 1 2915 FA1S $T=651000 770000 0 180 $X=639220 $Y=764580
X1323 2959 2 2989 2975 2971 1 2916 FA1S $T=652240 770000 1 180 $X=640460 $Y=769620
X1324 2973 2 472 2958 2929 1 3021 FA1S $T=645420 840560 1 0 $X=645420 $Y=835140
X1325 2978 2 2947 475 2928 1 3014 FA1S $T=646040 850640 0 0 $X=646040 $Y=850260
X1326 3023 2 3045 3038 3035 1 2952 FA1S $T=663400 759920 0 180 $X=651620 $Y=754500
X1327 3034 2 3050 3023 3022 1 2962 FA1S $T=664640 749840 0 180 $X=652860 $Y=744420
X1328 3038 2 3016 3008 3047 1 2965 FA1S $T=665880 759920 1 180 $X=654100 $Y=759540
X1329 3088 2 3070 3096 3099 1 3022 FA1S $T=675800 739760 0 180 $X=664020 $Y=734340
X1330 3096 2 3119 3074 3109 1 3035 FA1S $T=678280 749840 1 180 $X=666500 $Y=749460
X1331 3102 2 3128 3137 3103 1 3062 FA1S $T=678280 780080 0 180 $X=666500 $Y=774660
X1332 3187 2 542 3211 3160 1 3193 FA1S $T=682620 860720 0 0 $X=682620 $Y=860340
X1333 535 2 542 529 3093 1 3197 FA1S $T=682620 870800 1 0 $X=682620 $Y=865380
X1334 3190 2 3185 3156 3123 1 3221 FA1S $T=683240 759920 0 0 $X=683240 $Y=759540
X1335 3191 2 3205 3102 3221 1 3208 FA1S $T=683240 780080 1 0 $X=683240 $Y=774660
X1336 3213 2 3236 3190 3224 1 3176 FA1S $T=697500 749840 1 180 $X=685720 $Y=749460
X1337 3206 2 3177 3150 3192 1 3224 FA1S $T=686340 749840 1 0 $X=686340 $Y=744420
X1338 3227 2 3209 3191 3176 1 3228 FA1S $T=691300 770000 0 0 $X=691300 $Y=769620
X1339 3240 2 3220 3175 3199 1 3277 FA1S $T=693160 729680 0 0 $X=693160 $Y=729300
X1340 3255 2 3215 3232 3239 1 3285 FA1S $T=696880 729680 1 0 $X=696880 $Y=724260
X1341 3269 2 3243 3227 3279 1 3223 FA1S $T=709280 780080 0 180 $X=697500 $Y=774660
X1342 3259 2 3251 3213 3306 1 3279 FA1S $T=698120 770000 1 0 $X=698120 $Y=764580
X1343 3286 2 3267 3278 3299 1 3316 FA1S $T=704320 759920 0 0 $X=704320 $Y=759540
X1344 3262 2 3271 3240 3285 1 3299 FA1S $T=704940 739760 1 0 $X=704940 $Y=734340
X1345 3278 2 3273 3206 3277 1 3306 FA1S $T=704940 749840 1 0 $X=704940 $Y=744420
X1346 3318 2 3296 3259 3316 1 3292 FA1S $T=712380 770000 1 0 $X=712380 $Y=764580
X1347 975 2 953 1 INV1S $T=225680 739760 1 180 $X=224440 $Y=739380
X1348 982 2 952 1 INV1S $T=226300 699440 0 180 $X=225060 $Y=694020
X1349 979 2 946 1 INV1S $T=226300 729680 0 180 $X=225060 $Y=724260
X1350 980 2 954 1 INV1S $T=226300 770000 1 180 $X=225060 $Y=769620
X1351 985 2 949 1 INV1S $T=228160 719600 0 180 $X=226920 $Y=714180
X1352 9 2 984 1 INV1S $T=229400 739760 0 180 $X=228160 $Y=734340
X1353 10 2 983 1 INV1S $T=230020 699440 0 0 $X=230020 $Y=699060
X1354 1003 2 965 1 INV1S $T=231880 749840 1 180 $X=230640 $Y=749460
X1355 1018 2 958 1 INV1S $T=231880 759920 0 180 $X=230640 $Y=754500
X1356 1000 2 959 1 INV1S $T=231880 759920 1 180 $X=230640 $Y=759540
X1357 1004 2 1017 1 INV1S $T=234980 719600 1 0 $X=234980 $Y=714180
X1358 1001 2 967 1 INV1S $T=238080 709520 1 180 $X=236840 $Y=709140
X1359 1031 2 1010 1 INV1S $T=238080 780080 0 180 $X=236840 $Y=774660
X1360 1029 2 950 1 INV1S $T=238080 840560 1 180 $X=236840 $Y=840180
X1361 24 2 1061 1 INV1S $T=241180 719600 0 0 $X=241180 $Y=719220
X1362 1104 2 1098 1 INV1S $T=252340 739760 0 180 $X=251100 $Y=734340
X1363 13 2 1100 1 INV1S $T=255440 729680 0 180 $X=254200 $Y=724260
X1364 43 2 1171 1 INV1S $T=267220 699440 1 180 $X=265980 $Y=699060
X1365 1164 2 1179 1 INV1S $T=266600 780080 1 0 $X=266600 $Y=774660
X1366 1179 2 1130 1 INV1S $T=267840 780080 1 0 $X=267840 $Y=774660
X1367 1128 2 1169 1 INV1S $T=269700 739760 1 180 $X=268460 $Y=739380
X1368 27 2 1097 1 INV1S $T=272180 810320 1 180 $X=270940 $Y=809940
X1369 1160 2 1222 1 INV1S $T=274660 719600 0 0 $X=274660 $Y=719220
X1370 1224 2 1202 1 INV1S $T=277140 810320 0 180 $X=275900 $Y=804900
X1371 1196 2 1229 1 INV1S $T=276520 759920 0 0 $X=276520 $Y=759540
X1372 59 2 1221 1 INV1S $T=276520 870800 1 0 $X=276520 $Y=865380
X1373 1228 2 1204 1 INV1S $T=277140 729680 1 0 $X=277140 $Y=724260
X1374 1252 2 1231 1 INV1S $T=279000 719600 1 180 $X=277760 $Y=719220
X1375 1250 2 1264 1 INV1S $T=281480 749840 1 0 $X=281480 $Y=744420
X1376 54 2 1253 1 INV1S $T=282720 729680 1 0 $X=282720 $Y=724260
X1377 1241 2 1269 1 INV1S $T=283340 739760 0 0 $X=283340 $Y=739380
X1378 1208 2 1198 1 INV1S $T=285200 729680 0 180 $X=283960 $Y=724260
X1379 1243 2 1191 1 INV1S $T=286440 719600 1 0 $X=286440 $Y=714180
X1380 1172 2 1291 1 INV1S $T=288300 719600 1 0 $X=288300 $Y=714180
X1381 1265 2 1282 1 INV1S $T=290780 810320 0 180 $X=289540 $Y=804900
X1382 1296 2 1302 1 INV1S $T=294500 800240 0 180 $X=293260 $Y=794820
X1383 1311 2 1312 1 INV1S $T=295740 739760 0 0 $X=295740 $Y=739380
X1384 1286 2 1281 1 INV1S $T=295740 749840 1 0 $X=295740 $Y=744420
X1385 1310 2 1314 1 INV1S $T=297600 729680 0 180 $X=296360 $Y=724260
X1386 1278 2 1326 1 INV1S $T=297600 729680 1 0 $X=297600 $Y=724260
X1387 35 2 1152 1 INV1S $T=299460 709520 1 180 $X=298220 $Y=709140
X1388 1320 2 1344 1 INV1S $T=301320 709520 0 0 $X=301320 $Y=709140
X1389 87 2 1360 1 INV1S $T=305040 870800 1 0 $X=305040 $Y=865380
X1390 1337 2 1377 1 INV1S $T=305660 709520 1 0 $X=305660 $Y=704100
X1391 1335 2 1374 1 INV1S $T=313720 800240 1 180 $X=312480 $Y=799860
X1392 1410 2 1389 1 INV1S $T=315580 800240 0 0 $X=315580 $Y=799860
X1393 1375 2 1400 1 INV1S $T=316820 860720 0 0 $X=316820 $Y=860340
X1394 52 2 49 1 INV1S $T=318680 870800 1 0 $X=318680 $Y=865380
X1395 49 2 1333 1 INV1S $T=319920 870800 1 0 $X=319920 $Y=865380
X1396 27 2 1419 1 INV1S $T=321780 810320 1 0 $X=321780 $Y=804900
X1397 100 2 1450 1 INV1S $T=324880 830480 1 180 $X=323640 $Y=830100
X1398 97 2 101 1 INV1S $T=323640 870800 1 0 $X=323640 $Y=865380
X1399 102 2 1469 1 INV1S $T=325500 719600 0 0 $X=325500 $Y=719220
X1400 1461 2 1446 1 INV1S $T=327360 729680 0 180 $X=326120 $Y=724260
X1401 113 2 1485 1 INV1S $T=334800 790160 0 180 $X=333560 $Y=784740
X1402 99 2 1490 1 INV1S $T=335420 709520 0 0 $X=335420 $Y=709140
X1403 1471 2 1503 1 INV1S $T=335420 810320 1 0 $X=335420 $Y=804900
X1404 118 2 1467 1 INV1S $T=337280 820400 0 180 $X=336040 $Y=814980
X1405 1552 2 1491 1 INV1S $T=338520 739760 1 180 $X=337280 $Y=739380
X1406 1441 2 1534 1 INV1S $T=339760 729680 0 0 $X=339760 $Y=729300
X1407 98 2 117 1 INV1S $T=343480 870800 0 180 $X=342240 $Y=865380
X1408 135 2 1507 1 INV1S $T=344100 780080 0 180 $X=342860 $Y=774660
X1409 1547 2 1548 1 INV1S $T=345340 860720 0 180 $X=344100 $Y=855300
X1410 138 2 1451 1 INV1S $T=346580 800240 1 180 $X=345340 $Y=799860
X1411 1555 2 1561 1 INV1S $T=345960 719600 0 0 $X=345960 $Y=719220
X1412 1365 2 1544 1 INV1S $T=347200 729680 0 180 $X=345960 $Y=724260
X1413 1583 2 1524 1 INV1S $T=347200 790160 1 180 $X=345960 $Y=789780
X1414 103 2 1521 1 INV1S $T=345960 860720 0 0 $X=345960 $Y=860340
X1415 1532 2 1564 1 INV1S $T=347200 800240 1 0 $X=347200 $Y=794820
X1416 1494 2 1570 1 INV1S $T=347820 719600 1 0 $X=347820 $Y=714180
X1417 143 2 1458 1 INV1S $T=350300 780080 1 180 $X=349060 $Y=779700
X1418 1598 2 1578 1 INV1S $T=352160 729680 0 180 $X=350920 $Y=724260
X1419 1560 2 1595 1 INV1S $T=350920 800240 1 0 $X=350920 $Y=794820
X1420 147 2 1532 1 INV1S $T=352160 830480 0 180 $X=350920 $Y=825060
X1421 1589 2 1412 1 INV1S $T=352160 860720 1 180 $X=350920 $Y=860340
X1422 1559 2 1606 1 INV1S $T=352780 719600 1 0 $X=352780 $Y=714180
X1423 132 2 1613 1 INV1S $T=352780 729680 1 0 $X=352780 $Y=724260
X1424 1558 2 1603 1 INV1S $T=352780 810320 1 0 $X=352780 $Y=804900
X1425 159 2 1556 1 INV1S $T=358980 850640 0 180 $X=357740 $Y=845220
X1426 127 2 1628 1 INV1S $T=358360 790160 0 0 $X=358360 $Y=789780
X1427 1627 2 1579 1 INV1S $T=358980 860720 1 0 $X=358980 $Y=855300
X1428 155 2 163 1 INV1S $T=358980 870800 1 0 $X=358980 $Y=865380
X1429 1625 2 1619 1 INV1S $T=362700 739760 0 180 $X=361460 $Y=734340
X1430 1662 2 1646 1 INV1S $T=363940 739760 1 180 $X=362700 $Y=739380
X1431 1636 2 1650 1 INV1S $T=362700 800240 1 0 $X=362700 $Y=794820
X1432 1664 2 1652 1 INV1S $T=367660 729680 0 180 $X=366420 $Y=724260
X1433 1655 2 1679 1 INV1S $T=367040 709520 0 0 $X=367040 $Y=709140
X1434 1668 2 1674 1 INV1S $T=367660 709520 1 0 $X=367660 $Y=704100
X1435 1670 2 1678 1 INV1S $T=368280 699440 1 0 $X=368280 $Y=694020
X1436 1666 2 1692 1 INV1S $T=368900 719600 1 0 $X=368900 $Y=714180
X1437 1694 2 1442 1 INV1S $T=371380 800240 1 0 $X=371380 $Y=794820
X1438 1645 2 1691 1 INV1S $T=372000 810320 1 0 $X=372000 $Y=804900
X1439 1617 2 1705 1 INV1S $T=375100 729680 1 0 $X=375100 $Y=724260
X1440 1640 2 1720 1 INV1S $T=377580 739760 0 180 $X=376340 $Y=734340
X1441 1642 2 1754 1 INV1S $T=381920 729680 1 0 $X=381920 $Y=724260
X1442 1734 2 1753 1 INV1S $T=381920 800240 0 0 $X=381920 $Y=799860
X1443 1780 2 1787 1 INV1S $T=389360 709520 0 0 $X=389360 $Y=709140
X1444 1801 2 1816 1 INV1S $T=395560 810320 1 0 $X=395560 $Y=804900
X1445 1848 2 1856 1 INV1S $T=407960 810320 1 0 $X=407960 $Y=804900
X1446 1868 2 1881 1 INV1S $T=414160 810320 1 0 $X=414160 $Y=804900
X1447 1901 2 1906 1 INV1S $T=420360 810320 1 0 $X=420360 $Y=804900
X1448 227 2 220 1 INV1S $T=420980 739760 0 0 $X=420980 $Y=739380
X1449 232 2 1874 1 INV1S $T=422220 749840 0 180 $X=420980 $Y=744420
X1450 228 2 226 1 INV1S $T=420980 759920 1 0 $X=420980 $Y=754500
X1451 231 2 1916 1 INV1S $T=422840 870800 1 0 $X=422840 $Y=865380
X1452 1918 2 1922 1 INV1S $T=424080 759920 0 0 $X=424080 $Y=759540
X1453 1927 2 1944 1 INV1S $T=430280 810320 1 0 $X=430280 $Y=804900
X1454 247 2 1945 1 INV1S $T=435860 719600 0 180 $X=434620 $Y=714180
X1455 1941 2 1969 1 INV1S $T=436480 800240 1 0 $X=436480 $Y=794820
X1456 1985 2 1957 1 INV1S $T=438960 709520 1 180 $X=437720 $Y=709140
X1457 256 2 246 1 INV1S $T=440200 699440 1 180 $X=438960 $Y=699060
X1458 249 2 2001 1 INV1S $T=440200 719600 0 0 $X=440200 $Y=719220
X1459 1931 2 2007 1 INV1S $T=440200 860720 0 0 $X=440200 $Y=860340
X1460 1930 2 2010 1 INV1S $T=441440 790160 0 0 $X=441440 $Y=789780
X1461 1900 2 2014 1 INV1S $T=442680 800240 0 0 $X=442680 $Y=799860
X1462 1994 2 2020 1 INV1S $T=444540 790160 1 0 $X=444540 $Y=784740
X1463 1924 2 2011 1 INV1S $T=449500 759920 1 180 $X=448260 $Y=759540
X1464 1923 2 2039 1 INV1S $T=449500 800240 0 0 $X=449500 $Y=799860
X1465 1952 2 2031 1 INV1S $T=451980 860720 0 180 $X=450740 $Y=855300
X1466 1943 2 2075 1 INV1S $T=456320 800240 1 0 $X=456320 $Y=794820
X1467 2080 2 2072 1 INV1S $T=458180 770000 0 180 $X=456940 $Y=764580
X1468 248 2 2049 1 INV1S $T=456940 860720 0 0 $X=456940 $Y=860340
X1469 2115 2 2055 1 INV1S $T=460660 729680 0 180 $X=459420 $Y=724260
X1470 273 2 275 1 INV1S $T=459420 749840 0 0 $X=459420 $Y=749460
X1471 1975 2 2097 1 INV1S $T=461280 780080 0 0 $X=461280 $Y=779700
X1472 1959 2 2078 1 INV1S $T=463140 790160 1 180 $X=461900 $Y=789780
X1473 280 2 282 1 INV1S $T=463140 759920 1 0 $X=463140 $Y=754500
X1474 2144 2 2081 1 INV1S $T=471820 719600 1 180 $X=470580 $Y=719220
X1475 291 2 292 1 INV1S $T=478020 749840 0 0 $X=478020 $Y=749460
X1476 2183 2 2142 1 INV1S $T=480500 699440 1 180 $X=479260 $Y=699060
X1477 2173 2 2150 1 INV1S $T=480500 759920 1 180 $X=479260 $Y=759540
X1478 2179 2 2110 1 INV1S $T=481120 719600 1 180 $X=479880 $Y=719220
X1479 295 2 294 1 INV1S $T=482360 749840 1 180 $X=481120 $Y=749460
X1480 2052 2 302 1 INV1S $T=484220 699440 0 0 $X=484220 $Y=699060
X1481 2174 2 2147 1 INV1S $T=486080 739760 1 180 $X=484840 $Y=739380
X1482 2195 2 2180 1 INV1S $T=486080 749840 1 180 $X=484840 $Y=749460
X1483 2167 2 2182 1 INV1S $T=490420 770000 1 180 $X=489180 $Y=769620
X1484 2296 2 2265 1 INV1S $T=502200 830480 1 180 $X=500960 $Y=830100
X1485 2271 2 2230 1 INV1S $T=503440 739760 1 180 $X=502200 $Y=739380
X1486 2266 2 2272 1 INV1S $T=502200 770000 1 0 $X=502200 $Y=764580
X1487 2277 2 2227 1 INV1S $T=504680 739760 1 180 $X=503440 $Y=739380
X1488 2285 2 2228 1 INV1S $T=504680 790160 0 180 $X=503440 $Y=784740
X1489 2287 2 2216 1 INV1S $T=505920 749840 1 180 $X=504680 $Y=749460
X1490 2297 2 2215 1 INV1S $T=507160 749840 0 180 $X=505920 $Y=744420
X1491 2305 2 2211 1 INV1S $T=507780 739760 0 180 $X=506540 $Y=734340
X1492 2306 2 2205 1 INV1S $T=509020 749840 0 180 $X=507780 $Y=744420
X1493 2308 2 2301 1 INV1S $T=509020 840560 0 180 $X=507780 $Y=835140
X1494 332 2 329 1 INV1S $T=510880 699440 0 180 $X=509640 $Y=694020
X1495 2326 2 310 1 INV1S $T=511500 709520 1 180 $X=510260 $Y=709140
X1496 2311 2 308 1 INV1S $T=512120 719600 0 180 $X=510880 $Y=714180
X1497 336 2 325 1 INV1S $T=513980 699440 1 180 $X=512740 $Y=699060
X1498 2339 2 307 1 INV1S $T=514600 719600 1 180 $X=513360 $Y=719220
X1499 338 2 311 1 INV1S $T=516460 699440 1 180 $X=515220 $Y=699060
X1500 2284 2 324 1 INV1S $T=517700 719600 0 180 $X=516460 $Y=714180
X1501 2298 2 2358 1 INV1S $T=516460 780080 1 0 $X=516460 $Y=774660
X1502 2337 2 2322 1 INV1S $T=516460 810320 1 0 $X=516460 $Y=804900
X1503 2364 2 2353 1 INV1S $T=517700 820400 0 180 $X=516460 $Y=814980
X1504 2310 2 2280 1 INV1S $T=517700 770000 0 0 $X=517700 $Y=769620
X1505 2341 2 313 1 INV1S $T=519560 709520 0 180 $X=518320 $Y=704100
X1506 2077 2 342 1 INV1S $T=518320 719600 1 0 $X=518320 $Y=714180
X1507 316 2 2293 1 INV1S $T=518940 749840 0 0 $X=518940 $Y=749460
X1508 2272 2 322 1 INV1S $T=519560 719600 0 0 $X=519560 $Y=719220
X1509 2376 2 2365 1 INV1S $T=520800 840560 1 180 $X=519560 $Y=840180
X1510 306 2 2361 1 INV1S $T=520800 739760 1 0 $X=520800 $Y=734340
X1511 2336 2 330 1 INV1S $T=521420 759920 0 0 $X=521420 $Y=759540
X1512 2351 2 2373 1 INV1S $T=521420 810320 1 0 $X=521420 $Y=804900
X1513 2284 2 357 1 INV1S $T=526380 719600 1 0 $X=526380 $Y=714180
X1514 2064 2 2381 1 INV1S $T=528240 739760 0 0 $X=528240 $Y=739380
X1515 2399 2 2410 1 INV1S $T=530100 820400 0 0 $X=530100 $Y=820020
X1516 2396 2 2427 1 INV1S $T=531960 850640 1 0 $X=531960 $Y=845220
X1517 2414 2 2423 1 INV1S $T=533200 810320 0 0 $X=533200 $Y=809940
X1518 2128 2 2392 1 INV1S $T=534440 749840 0 0 $X=534440 $Y=749460
X1519 2141 2 2404 1 INV1S $T=537540 749840 0 180 $X=536300 $Y=744420
X1520 2417 2 2445 1 INV1S $T=538160 800240 0 0 $X=538160 $Y=799860
X1521 1929 2 2403 1 INV1S $T=540020 739760 1 180 $X=538780 $Y=739380
X1522 2406 2 2465 1 INV1S $T=543120 850640 1 0 $X=543120 $Y=845220
X1523 1926 2 2385 1 INV1S $T=543740 749840 1 0 $X=543740 $Y=744420
X1524 2067 2 356 1 INV1S $T=546840 729680 1 180 $X=545600 $Y=729300
X1525 1905 2 2441 1 INV1S $T=546840 749840 0 180 $X=545600 $Y=744420
X1526 331 2 2486 1 INV1S $T=547460 790160 1 0 $X=547460 $Y=784740
X1527 2061 2 360 1 INV1S $T=549940 719600 1 180 $X=548700 $Y=719220
X1528 2145 2 359 1 INV1S $T=549940 749840 0 180 $X=548700 $Y=744420
X1529 2084 2 365 1 INV1S $T=551180 709520 1 180 $X=549940 $Y=709140
X1530 347 2 375 1 INV1S $T=553660 699440 0 180 $X=552420 $Y=694020
X1531 342 2 2513 1 INV1S $T=553660 719600 1 0 $X=553660 $Y=714180
X1532 276 2 2401 1 INV1S $T=554280 699440 1 0 $X=554280 $Y=694020
X1533 302 2 2535 1 INV1S $T=556760 699440 0 0 $X=556760 $Y=699060
X1534 2411 2 2543 1 INV1S $T=557380 729680 1 0 $X=557380 $Y=724260
X1535 2366 2 2540 1 INV1S $T=562340 709520 0 0 $X=562340 $Y=709140
X1536 2434 2 2560 1 INV1S $T=562340 739760 0 0 $X=562340 $Y=739380
X1537 2546 2 2550 1 INV1S $T=562340 759920 1 0 $X=562340 $Y=754500
X1538 373 2 2573 1 INV1S $T=565440 699440 0 0 $X=565440 $Y=699060
X1539 2493 2 2614 1 INV1S $T=566060 749840 0 0 $X=566060 $Y=749460
X1540 2412 2 2620 1 INV1S $T=575980 719600 0 0 $X=575980 $Y=719220
X1541 2413 2 2641 1 INV1S $T=579080 709520 1 0 $X=579080 $Y=704100
X1542 2648 2 2643 1 INV1S $T=582180 759920 0 180 $X=580940 $Y=754500
X1543 2667 2 2663 1 INV1S $T=587140 770000 1 180 $X=585900 $Y=769620
X1544 2452 2 2689 1 INV1S $T=589620 749840 1 0 $X=589620 $Y=744420
X1545 2675 2 2668 1 INV1S $T=592100 770000 0 180 $X=590860 $Y=764580
X1546 2691 2 2652 1 INV1S $T=592100 770000 1 0 $X=592100 $Y=764580
X1547 2676 2 2694 1 INV1S $T=592100 780080 1 0 $X=592100 $Y=774660
X1548 2699 2 2709 1 INV1S $T=596440 780080 0 0 $X=596440 $Y=779700
X1549 2677 2 2683 1 INV1S $T=599540 790160 1 180 $X=598300 $Y=789780
X1550 2485 2 2762 1 INV1S $T=606360 749840 0 0 $X=606360 $Y=749460
X1551 2744 2 2743 1 INV1S $T=607600 830480 0 0 $X=607600 $Y=830100
X1552 2693 2 2752 1 INV1S $T=608840 820400 0 0 $X=608840 $Y=820020
X1553 2766 2 2778 1 INV1S $T=612560 830480 0 0 $X=612560 $Y=830100
X1554 2716 2 2777 1 INV1S $T=615660 830480 0 180 $X=614420 $Y=825060
X1555 431 2 2790 1 INV1S $T=615040 820400 1 0 $X=615040 $Y=814980
X1556 2812 2 2734 1 INV1S $T=619380 790160 0 180 $X=618140 $Y=784740
X1557 2809 2 2816 1 INV1S $T=618140 830480 0 0 $X=618140 $Y=830100
X1558 2789 2 2799 1 INV1S $T=620000 860720 0 180 $X=618760 $Y=855300
X1559 2775 2 2802 1 INV1S $T=620620 850640 1 180 $X=619380 $Y=850260
X1560 2826 2 2815 1 INV1S $T=621240 800240 1 180 $X=620000 $Y=799860
X1561 445 2 2852 1 INV1S $T=623720 860720 1 0 $X=623720 $Y=855300
X1562 2867 2 2834 1 INV1S $T=626820 790160 1 180 $X=625580 $Y=789780
X1563 2874 2 2866 1 INV1S $T=628060 749840 1 180 $X=626820 $Y=749460
X1564 2821 2 2835 1 INV1S $T=627440 810320 1 0 $X=627440 $Y=804900
X1565 2807 2 2885 1 INV1S $T=630540 830480 1 0 $X=630540 $Y=825060
X1566 2876 2 2875 1 INV1S $T=632400 810320 0 0 $X=632400 $Y=809940
X1567 2896 2 2905 1 INV1S $T=634880 810320 0 0 $X=634880 $Y=809940
X1568 2909 2 2895 1 INV1S $T=636740 759920 0 180 $X=635500 $Y=754500
X1569 2917 2 2898 1 INV1S $T=637360 759920 1 180 $X=636120 $Y=759540
X1570 2890 2 2911 1 INV1S $T=636120 810320 0 0 $X=636120 $Y=809940
X1571 2915 2 2861 1 INV1S $T=638600 770000 0 180 $X=637360 $Y=764580
X1572 2916 2 2848 1 INV1S $T=638600 770000 1 180 $X=637360 $Y=769620
X1573 2907 2 2948 1 INV1S $T=644180 709520 0 0 $X=644180 $Y=709140
X1574 463 2 2912 1 INV1S $T=644800 850640 1 0 $X=644800 $Y=845220
X1575 2937 2 2966 1 INV1S $T=646040 820400 1 0 $X=646040 $Y=814980
X1576 2960 2 2942 1 INV1S $T=647900 810320 1 180 $X=646660 $Y=809940
X1577 475 2 2958 1 INV1S $T=646660 850640 1 0 $X=646660 $Y=845220
X1578 2963 2 2956 1 INV1S $T=648520 719600 1 180 $X=647280 $Y=719220
X1579 2996 2 2974 1 INV1S $T=652240 729680 1 180 $X=651000 $Y=729300
X1580 2997 2 2985 1 INV1S $T=655960 719600 0 0 $X=655960 $Y=719220
X1581 2963 2 3036 1 INV1S $T=659680 719600 1 0 $X=659680 $Y=714180
X1582 3018 2 3004 1 INV1S $T=660920 810320 1 180 $X=659680 $Y=809940
X1583 2590 2 3043 1 INV1S $T=660920 810320 1 0 $X=660920 $Y=804900
X1584 2997 2 3059 1 INV1S $T=665260 719600 0 0 $X=665260 $Y=719220
X1585 3029 2 2921 1 INV1S $T=665260 770000 0 0 $X=665260 $Y=769620
X1586 3086 2 3061 1 INV1S $T=670220 820400 0 180 $X=668980 $Y=814980
X1587 3029 2 3089 1 INV1S $T=669600 770000 0 0 $X=669600 $Y=769620
X1588 3076 2 3064 1 INV1S $T=671460 820400 1 0 $X=671460 $Y=814980
X1589 3069 2 3044 1 INV1S $T=673940 759920 1 180 $X=672700 $Y=759540
X1590 3095 2 3112 1 INV1S $T=672700 830480 1 0 $X=672700 $Y=825060
X1591 506 2 3106 1 INV1S $T=673320 870800 1 0 $X=673320 $Y=865380
X1592 3069 2 3116 1 INV1S $T=674560 770000 1 0 $X=674560 $Y=764580
X1593 3097 2 3006 1 INV1S $T=676420 749840 0 180 $X=675180 $Y=744420
X1594 3054 2 2983 1 INV1S $T=677040 729680 1 180 $X=675800 $Y=729300
X1595 3110 2 3105 1 INV1S $T=675800 810320 1 0 $X=675800 $Y=804900
X1596 519 2 3125 1 INV1S $T=676420 699440 1 0 $X=676420 $Y=694020
X1597 3062 2 523 1 INV1S $T=676420 790160 1 0 $X=676420 $Y=784740
X1598 3097 2 3121 1 INV1S $T=677040 749840 1 0 $X=677040 $Y=744420
X1599 3131 2 3135 1 INV1S $T=677660 729680 0 0 $X=677660 $Y=729300
X1600 2996 2 3151 1 INV1S $T=680760 719600 0 0 $X=680760 $Y=719220
X1601 3149 2 3146 1 INV1S $T=681380 729680 1 0 $X=681380 $Y=724260
X1602 3054 2 3145 1 INV1S $T=682000 739760 0 0 $X=682000 $Y=739380
X1603 3153 2 3167 1 INV1S $T=682620 820400 1 0 $X=682620 $Y=814980
X1604 3158 2 3163 1 INV1S $T=683240 800240 0 0 $X=683240 $Y=799860
X1605 3208 2 540 1 INV1S $T=690060 800240 0 180 $X=688820 $Y=794820
X1606 3012 2 3201 1 INV1S $T=692540 709520 1 180 $X=691300 $Y=709140
X1607 3182 2 3183 1 INV1S $T=691920 810320 1 0 $X=691920 $Y=804900
X1608 3223 2 545 1 INV1S $T=695020 810320 0 180 $X=693780 $Y=804900
X1609 529 2 3211 1 INV1S $T=694400 870800 1 0 $X=694400 $Y=865380
X1610 3226 2 3204 1 INV1S $T=696260 739760 1 180 $X=695020 $Y=739380
X1611 3228 2 546 1 INV1S $T=696260 800240 0 180 $X=695020 $Y=794820
X1612 3238 2 3241 1 INV1S $T=696880 780080 0 0 $X=696880 $Y=779700
X1613 3237 2 3136 1 INV1S $T=698740 739760 1 180 $X=697500 $Y=739380
X1614 3235 2 3242 1 INV1S $T=697500 800240 0 0 $X=697500 $Y=799860
X1615 3222 2 3245 1 INV1S $T=697500 820400 1 0 $X=697500 $Y=814980
X1616 3250 2 3214 1 INV1S $T=699980 739760 0 0 $X=699980 $Y=739380
X1617 3249 2 3261 1 INV1S $T=701220 840560 1 0 $X=701220 $Y=835140
X1618 3260 2 3258 1 INV1S $T=703080 780080 1 180 $X=701840 $Y=779700
X1619 3248 2 3266 1 INV1S $T=704940 810320 1 180 $X=703700 $Y=809940
X1620 3253 2 3346 1 INV1S $T=703700 840560 1 0 $X=703700 $Y=835140
X1621 3274 2 565 1 INV1S $T=706800 790160 0 0 $X=706800 $Y=789780
X1622 3276 2 3280 1 INV1S $T=709900 790160 0 180 $X=708660 $Y=784740
X1623 3264 2 3288 1 INV1S $T=713620 820400 0 180 $X=712380 $Y=814980
X1624 3297 2 3311 1 INV1S $T=716100 810320 0 180 $X=714860 $Y=804900
X1625 3287 2 3309 1 INV1S $T=715480 800240 0 0 $X=715480 $Y=799860
X1626 3312 2 3332 1 INV1S $T=719200 850640 0 0 $X=719200 $Y=850260
X1627 3302 2 3323 1 INV1S $T=721060 810320 1 180 $X=719820 $Y=809940
X1628 3270 2 3334 1 INV1S $T=721680 830480 1 0 $X=721680 $Y=825060
X1629 3333 2 3338 1 INV1S $T=722300 810320 1 0 $X=722300 $Y=804900
X1630 3325 2 3348 1 INV1S $T=722300 830480 0 0 $X=722300 $Y=830100
X1631 3330 2 3344 1 INV1S $T=722920 820400 0 0 $X=722920 $Y=820020
X1632 3343 2 3352 1 INV1S $T=723540 820400 1 0 $X=723540 $Y=814980
X1633 3360 2 3358 1 INV1S $T=726640 820400 1 0 $X=726640 $Y=814980
X1634 3362 2 3367 1 INV1S $T=727880 820400 0 0 $X=727880 $Y=820020
X1635 3366 2 3380 1 INV1S $T=729740 850640 0 0 $X=729740 $Y=850260
X1636 3370 2 3347 1 INV1S $T=730980 790160 0 0 $X=730980 $Y=789780
X1637 3371 2 3375 1 INV1S $T=730980 800240 1 0 $X=730980 $Y=794820
X1638 3387 2 3383 1 INV1S $T=734080 790160 1 180 $X=732840 $Y=789780
X1639 3355 2 3392 1 INV1S $T=735320 850640 0 0 $X=735320 $Y=850260
X1640 3391 2 3395 1 INV1S $T=735940 790160 0 0 $X=735940 $Y=789780
X1641 3339 2 3402 1 INV1S $T=736560 830480 1 0 $X=736560 $Y=825060
X1642 3399 2 3405 1 INV1S $T=737800 850640 0 0 $X=737800 $Y=850260
X1643 3401 2 612 1 INV1S $T=739040 790160 1 0 $X=739040 $Y=784740
X1644 3404 2 615 1 INV1S $T=739660 719600 1 0 $X=739660 $Y=714180
X1645 3394 2 3411 1 INV1S $T=739660 780080 1 0 $X=739660 $Y=774660
X1646 3351 2 3377 1 INV1S $T=740280 840560 0 0 $X=740280 $Y=840180
X1647 3369 2 3409 1 INV1S $T=740900 770000 0 0 $X=740900 $Y=769620
X1648 3414 2 3407 1 INV1S $T=743380 770000 1 180 $X=742140 $Y=769620
X1649 3412 2 621 1 INV1S $T=742760 780080 1 0 $X=742760 $Y=774660
X1650 3400 2 3418 1 INV1S $T=744620 860720 0 0 $X=744620 $Y=860340
X1651 3431 2 622 1 INV1S $T=748960 729680 0 180 $X=747720 $Y=724260
X1652 3331 2 3080 1 INV1S $T=750200 729680 0 0 $X=750200 $Y=729300
X1653 3434 2 3438 1 INV1S $T=750200 810320 0 0 $X=750200 $Y=809940
X1654 3340 2 3445 1 INV1S $T=751440 840560 1 0 $X=751440 $Y=835140
X1655 3443 2 3451 1 INV1S $T=752060 699440 0 0 $X=752060 $Y=699060
X1656 3440 2 3452 1 INV1S $T=752680 840560 0 0 $X=752680 $Y=840180
X1657 3448 2 3455 1 INV1S $T=753300 749840 0 0 $X=753300 $Y=749460
X1658 3396 2 3456 1 INV1S $T=753300 810320 1 0 $X=753300 $Y=804900
X1659 3390 2 3458 1 INV1S $T=753300 820400 1 0 $X=753300 $Y=814980
X1660 3442 2 3460 1 INV1S $T=753920 840560 0 0 $X=753920 $Y=840180
X1661 3436 2 632 1 INV1S $T=753920 870800 1 0 $X=753920 $Y=865380
X1662 3420 2 635 1 INV1S $T=755780 749840 0 0 $X=755780 $Y=749460
X1663 624 2 3488 1 INV1S $T=758260 719600 1 0 $X=758260 $Y=714180
X1664 3425 2 3476 1 INV1S $T=758260 820400 1 0 $X=758260 $Y=814980
X1665 3473 2 3479 1 INV1S $T=758260 860720 1 0 $X=758260 $Y=855300
X1666 3471 2 640 1 INV1S $T=759500 749840 1 0 $X=759500 $Y=744420
X1667 3494 2 3441 1 INV1S $T=761360 709520 1 180 $X=760120 $Y=709140
X1668 3485 2 642 1 INV1S $T=760740 759920 1 0 $X=760740 $Y=754500
X1669 3499 2 3507 1 INV1S $T=763220 850640 1 0 $X=763220 $Y=845220
X1670 3500 2 3504 1 INV1S $T=763220 850640 0 0 $X=763220 $Y=850260
X1671 3508 2 647 1 INV1S $T=766320 739760 0 180 $X=765080 $Y=734340
X1672 3433 2 3522 1 INV1S $T=765700 810320 1 0 $X=765700 $Y=804900
X1673 3527 2 2987 1 INV1S $T=767560 719600 1 180 $X=766320 $Y=719220
X1674 3482 2 3055 1 INV1S $T=766320 729680 0 0 $X=766320 $Y=729300
X1675 3502 2 3465 1 INV1S $T=766940 820400 0 0 $X=766940 $Y=820020
X1676 650 2 3524 1 INV1S $T=766940 870800 1 0 $X=766940 $Y=865380
X1677 3489 2 656 1 INV1S $T=768800 749840 1 0 $X=768800 $Y=744420
X1678 3495 2 3533 1 INV1S $T=769420 729680 0 0 $X=769420 $Y=729300
X1679 655 2 3538 1 INV1S $T=770040 860720 0 0 $X=770040 $Y=860340
X1680 3503 2 657 1 INV1S $T=770660 840560 0 0 $X=770660 $Y=840180
X1681 3490 2 3543 1 INV1S $T=771280 749840 1 0 $X=771280 $Y=744420
X1682 3536 2 3548 1 INV1S $T=773760 759920 1 0 $X=773760 $Y=754500
X1683 3569 2 3595 1 INV1S $T=783060 790160 1 0 $X=783060 $Y=784740
X1684 3550 2 3608 1 INV1S $T=785540 719600 0 0 $X=785540 $Y=719220
X1685 3559 2 3627 1 INV1S $T=792980 759920 1 0 $X=792980 $Y=754500
X1686 684 2 3636 1 INV1S $T=792980 810320 1 0 $X=792980 $Y=804900
X1687 685 2 3633 1 INV1S $T=792980 860720 1 0 $X=792980 $Y=855300
X1688 686 2 3669 1 INV1S $T=794840 800240 1 0 $X=794840 $Y=794820
X1689 675 2 3648 1 INV1S $T=799180 719600 1 0 $X=799180 $Y=714180
X1690 3664 2 3617 1 INV1S $T=803520 719600 1 180 $X=802280 $Y=719220
X1691 3663 2 3647 1 INV1S $T=804140 810320 1 0 $X=804140 $Y=804900
X1692 3671 2 3634 1 INV1S $T=806000 719600 1 0 $X=806000 $Y=714180
X1693 3667 2 3686 1 INV1S $T=809100 830480 0 180 $X=807860 $Y=825060
X1694 3702 2 3629 1 INV1S $T=812200 729680 1 180 $X=810960 $Y=729300
X1695 3761 2 3616 1 INV1S $T=829560 719600 0 180 $X=828320 $Y=714180
X1696 3755 2 3672 1 INV1S $T=829560 810320 0 180 $X=828320 $Y=804900
X1697 3754 2 3748 1 INV1S $T=828940 770000 0 0 $X=828940 $Y=769620
X1698 3716 2 3764 1 INV1S $T=831420 759920 0 0 $X=831420 $Y=759540
X1699 665 2 3765 1 INV1S $T=832040 709520 0 0 $X=832040 $Y=709140
X1700 3771 2 3781 1 INV1S $T=833280 709520 0 0 $X=833280 $Y=709140
X1701 3597 2 3610 1 INV1S $T=835140 770000 1 180 $X=833900 $Y=769620
X1702 3767 2 3782 1 INV1S $T=834520 759920 1 0 $X=834520 $Y=754500
X1703 3717 2 3790 1 INV1S $T=834520 759920 0 0 $X=834520 $Y=759540
X1704 729 2 3780 1 INV1S $T=835140 780080 1 0 $X=835140 $Y=774660
X1705 730 2 3784 1 INV1S $T=835760 820400 0 0 $X=835760 $Y=820020
X1706 3756 2 3785 1 INV1S $T=835760 840560 1 0 $X=835760 $Y=835140
X1707 736 2 3787 1 INV1S $T=839480 780080 0 180 $X=838240 $Y=774660
X1708 3796 2 3697 1 INV1S $T=839480 800240 1 180 $X=838240 $Y=799860
X1709 3799 2 3645 1 INV1S $T=840720 800240 0 180 $X=839480 $Y=794820
X1710 3803 2 3637 1 INV1S $T=843200 810320 0 180 $X=841960 $Y=804900
X1711 3825 2 3793 1 INV1S $T=844440 759920 0 180 $X=843200 $Y=754500
X1712 3801 2 3806 1 INV1S $T=843200 759920 0 0 $X=843200 $Y=759540
X1713 3815 2 3774 1 INV1S $T=846300 729680 1 180 $X=845060 $Y=729300
X1714 3816 2 3797 1 INV1S $T=846300 749840 1 180 $X=845060 $Y=749460
X1715 3809 2 3817 1 INV1S $T=845060 810320 0 0 $X=845060 $Y=809940
X1716 3821 2 3794 1 INV1S $T=850640 770000 0 180 $X=849400 $Y=764580
X1717 756 2 3808 1 INV1S $T=851260 770000 1 180 $X=850020 $Y=769620
X1718 755 2 3822 1 INV1S $T=850640 759920 0 0 $X=850640 $Y=759540
X1719 3824 2 3792 1 INV1S $T=851880 770000 0 180 $X=850640 $Y=764580
X1720 3828 2 3810 1 INV1S $T=853120 770000 0 180 $X=851880 $Y=764580
X1721 3834 2 3762 1 INV1S $T=854360 759920 1 180 $X=853120 $Y=759540
X1722 3830 2 3835 1 INV1S $T=853120 810320 1 0 $X=853120 $Y=804900
X1723 3836 2 3838 1 INV1S $T=853740 830480 0 0 $X=853740 $Y=830100
X1724 3826 2 3839 1 INV1S $T=853740 850640 1 0 $X=853740 $Y=845220
X1725 3847 2 3635 1 INV1S $T=855600 739760 1 180 $X=854360 $Y=739380
X1726 3840 2 3845 1 INV1S $T=854980 780080 0 0 $X=854980 $Y=779700
X1727 761 2 3853 1 INV1S $T=854980 800240 1 0 $X=854980 $Y=794820
X1728 3829 2 3848 1 INV1S $T=856220 800240 0 0 $X=856220 $Y=799860
X1729 3859 2 3651 1 INV1S $T=858080 780080 0 180 $X=856840 $Y=774660
X1730 3851 2 3852 1 INV1S $T=857460 800240 0 0 $X=857460 $Y=799860
X1731 3832 2 3857 1 INV1S $T=858080 830480 1 0 $X=858080 $Y=825060
X1732 3823 2 3858 1 INV1S $T=858080 840560 0 0 $X=858080 $Y=840180
X1733 3865 2 3603 1 INV1S $T=859940 790160 0 180 $X=858700 $Y=784740
X1734 767 2 3866 1 INV1S $T=859940 820400 0 0 $X=859940 $Y=820020
X1735 3873 2 3750 1 INV1S $T=862420 749840 0 180 $X=861180 $Y=744420
X1736 782 2 3869 1 INV1S $T=866760 810320 0 180 $X=865520 $Y=804900
X1737 787 2 3919 1 INV1S $T=877920 759920 1 180 $X=876680 $Y=759540
X1738 3989 2 3930 1 INV1S $T=881640 820400 1 180 $X=880400 $Y=820020
X1739 3932 2 3938 1 INV1S $T=880400 830480 1 0 $X=880400 $Y=825060
X1740 794 2 3916 1 INV1S $T=887840 759920 1 180 $X=886600 $Y=759540
X1741 797 2 3968 1 INV1S $T=889080 749840 1 180 $X=887840 $Y=749460
X1742 798 2 3969 1 INV1S $T=889080 759920 1 180 $X=887840 $Y=759540
X1743 799 2 3962 1 INV1S $T=889080 780080 1 180 $X=887840 $Y=779700
X1744 4003 2 3965 1 INV1S $T=893420 830480 1 180 $X=892180 $Y=830100
X1745 804 2 3997 1 INV1S $T=894040 729680 0 180 $X=892800 $Y=724260
X1746 4085 2 3811 1 INV1S $T=915740 790160 1 180 $X=914500 $Y=789780
X1747 4124 2 3753 1 INV1S $T=930000 699440 0 0 $X=930000 $Y=699060
X1748 3879 2 4184 1 INV1S $T=944880 820400 1 0 $X=944880 $Y=814980
X1749 3890 2 4189 1 INV1S $T=948600 820400 1 0 $X=948600 $Y=814980
X1750 4201 2 3789 1 INV1S $T=950460 699440 1 180 $X=949220 $Y=699060
X1751 3927 2 4188 1 INV1S $T=949840 850640 1 0 $X=949840 $Y=845220
X1752 4204 2 737 1 INV1S $T=952940 699440 0 180 $X=951700 $Y=694020
X1753 4213 2 3679 1 INV1S $T=956660 709520 0 180 $X=955420 $Y=704100
X1754 4227 2 3921 1 INV1S $T=960380 739760 1 180 $X=959140 $Y=739380
X1755 4225 2 3942 1 INV1S $T=961000 790160 0 180 $X=959760 $Y=784740
X1756 4259 2 3867 1 INV1S $T=965960 790160 1 180 $X=964720 $Y=789780
X1757 4235 2 3967 1 INV1S $T=965960 820400 0 180 $X=964720 $Y=814980
X1758 4241 2 3936 1 INV1S $T=967200 820400 0 180 $X=965960 $Y=814980
X1759 4248 2 3881 1 INV1S $T=969680 790160 0 180 $X=968440 $Y=784740
X1760 3831 2 4256 1 INV1S $T=971540 830480 1 0 $X=971540 $Y=825060
X1761 4273 2 3812 1 INV1S $T=973400 770000 0 180 $X=972160 $Y=764580
X1762 4261 2 3874 1 INV1S $T=976500 800240 0 180 $X=975260 $Y=794820
X1763 4277 2 3957 1 INV1S $T=978360 759920 1 180 $X=977120 $Y=759540
X1764 4268 2 3795 1 INV1S $T=978980 810320 1 180 $X=977740 $Y=809940
X1765 3788 2 4279 1 INV1S $T=979600 830480 0 0 $X=979600 $Y=830100
X1766 4305 2 3991 1 INV1S $T=983940 709520 1 180 $X=982700 $Y=709140
X1767 4281 2 3818 1 INV1S $T=983940 719600 1 180 $X=982700 $Y=719220
X1768 4282 2 4002 1 INV1S $T=984560 739760 1 180 $X=983320 $Y=739380
X1769 4284 2 3977 1 INV1S $T=985800 729680 0 180 $X=984560 $Y=724260
X1770 4285 2 3945 1 INV1S $T=985800 729680 1 180 $X=984560 $Y=729300
X1771 3772 2 4278 1 INV1S $T=986420 830480 0 180 $X=985180 $Y=825060
X1772 2074 1 2 2064 BUF1S $T=456320 759920 1 0 $X=456320 $Y=754500
X1773 2083 1 2 2061 BUF1S $T=458800 739760 0 0 $X=458800 $Y=739380
X1774 2148 1 2 2128 BUF1S $T=471820 749840 1 0 $X=471820 $Y=744420
X1775 2359 1 2 2356 BUF1S $T=517700 860720 1 0 $X=517700 $Y=855300
X1776 2482 1 2 2495 BUF1S $T=547460 790160 0 0 $X=547460 $Y=789780
X1777 2584 1 2 2603 BUF1S $T=568540 800240 0 0 $X=568540 $Y=799860
X1778 2687 1 2 405 BUF1S $T=590860 850640 0 0 $X=590860 $Y=850260
X1779 420 1 2 432 BUF1S $T=601400 870800 1 0 $X=601400 $Y=865380
X1780 405 1 2 427 BUF1S $T=603260 860720 1 0 $X=603260 $Y=855300
X1781 431 1 2 2765 BUF1S $T=608840 820400 1 0 $X=608840 $Y=814980
X1782 391 1 2 2785 BUF1S $T=611320 870800 1 0 $X=611320 $Y=865380
X1783 2849 1 2 2744 BUF1S $T=623720 840560 1 0 $X=623720 $Y=835140
X1784 448 1 2 452 BUF1S $T=624960 850640 1 0 $X=624960 $Y=845220
X1785 2850 1 2 448 BUF1S $T=632400 850640 1 0 $X=632400 $Y=845220
X1786 2760 1 2 2936 BUF1S $T=641700 800240 1 0 $X=641700 $Y=794820
X1787 516 1 2 3114 BUF1S $T=674560 699440 0 0 $X=674560 $Y=699060
X1788 3196 1 2 3238 BUF1S $T=697500 699440 0 0 $X=697500 $Y=699060
X1789 3282 1 2 3276 BUF1S $T=707420 719600 0 0 $X=707420 $Y=719220
X1790 3317 1 2 3325 BUF1S $T=716100 830480 0 0 $X=716100 $Y=830100
X1791 3315 1 2 3287 BUF1S $T=719200 729680 1 0 $X=719200 $Y=724260
X1792 3329 1 2 3297 BUF1S $T=721060 719600 0 0 $X=721060 $Y=719220
X1793 3359 1 2 3302 BUF1S $T=726020 709520 1 0 $X=726020 $Y=704100
X1794 3389 1 2 3400 BUF1S $T=735320 870800 1 0 $X=735320 $Y=865380
X1795 3398 1 2 608 BUF1S $T=737180 840560 0 0 $X=737180 $Y=840180
X1796 3427 1 2 3440 BUF1S $T=748960 840560 0 0 $X=748960 $Y=840180
X1797 3429 1 2 3442 BUF1S $T=748960 850640 1 0 $X=748960 $Y=845220
X1798 3417 1 2 649 BUF1S $T=765080 830480 1 0 $X=765080 $Y=825060
X1799 3520 1 2 653 BUF1S $T=766940 860720 0 0 $X=766940 $Y=860340
X1800 4006 1 2 3825 BUF1S $T=895280 749840 0 0 $X=895280 $Y=749460
X1801 1066 1 1071 1083 2 ND2P $T=247380 790160 0 180 $X=243660 $Y=784740
X1802 1079 1 1062 1075 2 ND2P $T=250480 770000 1 0 $X=250480 $Y=764580
X1803 1040 1 1107 1127 2 ND2P $T=256060 790160 1 180 $X=252340 $Y=789780
X1804 1089 1 1071 1119 2 ND2P $T=256680 759920 0 0 $X=256680 $Y=759540
X1805 1147 1 1151 1078 2 ND2P $T=261020 749840 0 0 $X=261020 $Y=749460
X1806 35 1 1155 1151 2 ND2P $T=261640 759920 1 0 $X=261640 $Y=754500
X1807 1153 1 1137 1084 2 ND2P $T=263500 810320 0 0 $X=263500 $Y=809940
X1808 1174 1 1107 1146 2 ND2P $T=265980 790160 1 0 $X=265980 $Y=784740
X1809 1174 1 1040 1145 2 ND2P $T=269700 790160 1 180 $X=265980 $Y=789780
X1810 1175 1 1158 1089 2 ND2P $T=267220 749840 1 0 $X=267220 $Y=744420
X1811 1194 1 1197 1057 2 ND2P $T=270320 820400 1 0 $X=270320 $Y=814980
X1812 1176 1 1199 1172 2 ND2P $T=270940 729680 1 0 $X=270940 $Y=724260
X1813 59 1 1211 1220 2 ND2P $T=272800 870800 1 0 $X=272800 $Y=865380
X1814 1234 1 1220 65 2 ND2P $T=277760 870800 1 0 $X=277760 $Y=865380
X1815 1223 1 66 1116 2 ND2P $T=279000 860720 0 0 $X=279000 $Y=860340
X1816 1247 1 67 1262 2 ND2P $T=279620 840560 0 0 $X=279620 $Y=840180
X1817 1307 1 1274 1322 2 ND2P $T=293260 850640 1 0 $X=293260 $Y=845220
X1818 1026 1 1267 1324 2 ND2P $T=294500 759920 1 0 $X=294500 $Y=754500
X1819 74 1 1274 1325 2 ND2P $T=295120 850640 0 0 $X=295120 $Y=850260
X1820 1258 1 1267 1328 2 ND2P $T=305660 749840 1 180 $X=301940 $Y=749460
X1821 1355 1 1351 1367 2 ND2P $T=310000 820400 0 180 $X=306280 $Y=814980
X1822 1359 1 1351 1392 2 ND2P $T=311240 820400 1 180 $X=307520 $Y=820020
X1823 1391 1 1395 1406 2 ND2P $T=310000 820400 1 0 $X=310000 $Y=814980
X1824 1354 1 1415 1411 2 ND2P $T=314340 709520 1 0 $X=314340 $Y=704100
X1825 1219 1 1380 1439 2 ND2P $T=317440 770000 0 0 $X=317440 $Y=769620
X1826 1469 1 1477 1441 2 ND2P $T=330460 729680 1 0 $X=330460 $Y=724260
X1827 132 1 121 1436 2 ND2P $T=341000 719600 1 180 $X=337280 $Y=719220
X1828 1451 1 1532 1429 2 ND2P $T=339140 800240 0 0 $X=339140 $Y=799860
X1829 1549 1 1502 1539 2 ND2P $T=344720 770000 0 180 $X=341000 $Y=764580
X1830 1455 1 1502 1586 2 ND2P $T=349680 759920 1 180 $X=345960 $Y=759540
X1831 1628 1 1644 1636 2 ND2P $T=360840 790160 0 0 $X=360840 $Y=789780
X1832 1440 1 1847 1813 2 ND2P $T=402380 729680 1 0 $X=402380 $Y=724260
X1833 1802 1 1847 1820 2 ND2P $T=403000 719600 0 0 $X=403000 $Y=719220
X1834 1863 1 1814 1877 2 ND2P $T=415400 830480 1 180 $X=411680 $Y=830100
X1835 217 1 1814 1897 2 ND2P $T=418500 840560 1 0 $X=418500 $Y=835140
X1836 2307 1 2435 316 2 ND2P $T=539400 780080 0 180 $X=535680 $Y=774660
X1837 3423 1 3428 598 2 ND2P $T=758260 820400 0 180 $X=754540 $Y=814980
X1838 950 960 973 2 1 5 XOR3 $T=222580 850640 0 0 $X=222580 $Y=850260
X1839 951 963 6 2 1 1044 XOR3 $T=226300 840560 1 0 $X=226300 $Y=835140
X1840 5 3 966 2 1 993 XOR3 $T=231260 870800 1 0 $X=231260 $Y=865380
X1841 1073 1078 1088 2 1 1122 XOR3 $T=244900 759920 0 0 $X=244900 $Y=759540
X1842 1039 25 981 2 1 1055 XOR3 $T=248620 840560 0 0 $X=248620 $Y=840180
X1843 1084 1090 1046 2 1 1039 XOR3 $T=251100 820400 0 0 $X=251100 $Y=820020
X1844 1057 1070 1048 2 1 1108 XOR3 $T=251720 820400 1 0 $X=251720 $Y=814980
X1845 1108 1116 1091 2 1 1115 XOR3 $T=261640 850640 1 0 $X=261640 $Y=845220
X1846 1156 1165 1102 2 1 1154 XOR3 $T=267840 820400 0 0 $X=267840 $Y=820020
X1847 1154 38 1134 2 1 1239 XOR3 $T=268460 840560 0 0 $X=268460 $Y=840180
X1848 1244 1095 1290 2 1 1316 XOR3 $T=279620 790160 0 0 $X=279620 $Y=789780
X1849 1216 1227 1178 2 1 1217 XOR3 $T=279620 820400 1 0 $X=279620 $Y=814980
X1850 1217 61 1181 2 1 1235 XOR3 $T=279620 850640 1 0 $X=279620 $Y=845220
X1851 1276 1054 1259 2 1 1338 XOR3 $T=293260 770000 0 0 $X=293260 $Y=769620
X1852 1247 67 1240 2 1 1287 XOR3 $T=295740 840560 0 0 $X=295740 $Y=840180
X1853 1305 1122 1260 2 1 1255 XOR3 $T=296980 770000 1 0 $X=296980 $Y=764580
X1854 1315 1304 1238 2 1 1247 XOR3 $T=308760 810320 1 180 $X=297600 $Y=809940
X1855 1307 74 1274 2 1 1381 XOR3 $T=301940 850640 1 0 $X=301940 $Y=845220
X1856 1021 1357 1340 2 1 1424 XOR3 $T=307520 749840 1 0 $X=307520 $Y=744420
X1857 1376 91 1332 2 1 1369 XOR3 $T=308760 830480 0 0 $X=308760 $Y=830100
X1858 1002 1370 1362 2 1 1440 XOR3 $T=310000 729680 1 0 $X=310000 $Y=724260
X1859 1399 1418 1408 2 1 1376 XOR3 $T=317440 820400 1 0 $X=317440 $Y=814980
X1860 1475 104 1438 2 1 1430 XOR3 $T=329840 850640 0 180 $X=318680 $Y=845220
X1861 1403 1327 1427 2 1 1305 XOR3 $T=323020 749840 0 0 $X=323020 $Y=749460
X1862 1528 1511 1406 2 1 1475 XOR3 $T=338520 820400 1 180 $X=327360 $Y=820020
X1863 1504 1215 1514 2 1 1584 XOR3 $T=335420 749840 0 0 $X=335420 $Y=749460
X1864 1527 125 1533 2 1 1611 XOR3 $T=339140 830480 0 0 $X=339140 $Y=830100
X1865 1707 1712 1676 2 1 1685 XOR3 $T=378200 810320 0 0 $X=378200 $Y=809940
X1866 1014 1356 1386 2 1 1812 XOR3 $T=383780 709520 1 0 $X=383780 $Y=704100
X1867 1730 1763 1769 2 1 1849 XOR3 $T=385640 729680 0 0 $X=385640 $Y=729300
X1868 1761 1749 1723 2 1 1742 XOR3 $T=388740 820400 1 0 $X=388740 $Y=814980
X1869 1765 1777 1771 2 1 1802 XOR3 $T=389360 699440 0 0 $X=389360 $Y=699060
X1870 1750 1767 1764 2 1 1826 XOR3 $T=391220 729680 1 0 $X=391220 $Y=724260
X1871 1788 1759 1781 2 1 1836 XOR3 $T=393080 739760 1 0 $X=393080 $Y=734340
X1872 1803 1746 1823 2 1 1843 XOR3 $T=396800 749840 1 0 $X=396800 $Y=744420
X1873 217 1863 1814 2 1 1821 XOR3 $T=410440 830480 1 180 $X=399280 $Y=830100
X1874 211 213 1842 2 1 1887 XOR3 $T=401760 699440 0 0 $X=401760 $Y=699060
X1875 1834 1841 1772 2 1 1863 XOR3 $T=401760 820400 1 0 $X=401760 $Y=814980
X1876 1826 1445 1833 2 1 1917 XOR3 $T=405480 709520 1 0 $X=405480 $Y=704100
X1877 1849 1371 1855 2 1 1889 XOR3 $T=406100 729680 1 0 $X=406100 $Y=724260
X1878 1802 1440 1847 2 1 1904 XOR3 $T=406720 719600 0 0 $X=406720 $Y=719220
X1879 1836 1424 1838 2 1 1865 XOR3 $T=407340 739760 0 0 $X=407340 $Y=739380
X1880 1843 1384 1829 2 1 1824 XOR3 $T=408580 759920 1 0 $X=408580 $Y=754500
X1881 1922 1926 1953 2 1 1958 XOR3 $T=424700 770000 1 0 $X=424700 $Y=764580
X1882 1907 231 1910 2 1 1913 XOR3 $T=424700 840560 1 0 $X=424700 $Y=835140
X1883 1924 1929 1955 2 1 1963 XOR3 $T=425320 759920 1 0 $X=425320 $Y=754500
X1884 1908 1921 1902 2 1 1907 XOR3 $T=427180 820400 0 0 $X=427180 $Y=820020
X1885 265 1949 1946 2 1 1983 XOR3 $T=450740 840560 0 180 $X=439580 $Y=835140
X1886 1956 1976 1928 2 1 1949 XOR3 $T=440820 820400 1 0 $X=440820 $Y=814980
X1887 2006 1989 1992 2 1 2019 XOR3 $T=447020 820400 0 0 $X=447020 $Y=820020
X1888 2055 2061 2073 2 1 2117 XOR3 $T=453840 739760 1 0 $X=453840 $Y=734340
X1889 2013 2062 2023 2 1 2057 XOR3 $T=453840 840560 1 0 $X=453840 $Y=835140
X1890 2059 2060 2076 2 1 2143 XOR3 $T=460660 820400 1 0 $X=460660 $Y=814980
X1891 2143 285 2107 2 1 2091 XOR3 $T=471820 860720 0 180 $X=460660 $Y=855300
X1892 2025 2085 2079 2 1 2104 XOR3 $T=461900 830480 1 0 $X=461900 $Y=825060
X1893 270 2057 2027 2 1 2154 XOR3 $T=461900 850640 1 0 $X=461900 $Y=845220
X1894 2111 2116 2119 2 1 2162 XOR3 $T=463760 810320 0 0 $X=463760 $Y=809940
X1895 2070 2112 2087 2 1 2153 XOR3 $T=465620 820400 0 0 $X=465620 $Y=820020
X1896 2125 2134 2129 2 1 2187 XOR3 $T=469340 810320 1 0 $X=469340 $Y=804900
X1897 2147 2067 2102 2 1 2131 XOR3 $T=471820 739760 1 0 $X=471820 $Y=734340
X1898 2044 2152 2138 2 1 2176 XOR3 $T=471820 790160 1 0 $X=471820 $Y=784740
X1899 2133 2132 2136 2 1 2175 XOR3 $T=473680 800240 1 0 $X=473680 $Y=794820
X1900 2175 293 2177 2 1 2222 XOR3 $T=479260 820400 1 0 $X=479260 $Y=814980
X1901 2176 2169 2181 2 1 2241 XOR3 $T=484220 830480 1 0 $X=484220 $Y=825060
X1902 2162 2163 2170 2 1 2223 XOR3 $T=485460 850640 0 0 $X=485460 $Y=850260
X1903 2187 298 2192 2 1 2239 XOR3 $T=487940 830480 0 0 $X=487940 $Y=830100
X1904 314 2068 2208 2 1 2169 XOR3 $T=493520 860720 1 0 $X=493520 $Y=855300
X1905 2620 2311 2642 2 1 2672 XOR3 $T=577840 719600 1 0 $X=577840 $Y=714180
X1906 2762 2287 2767 2 1 2713 XOR3 $T=620620 749840 1 180 $X=609460 $Y=749460
X1907 2945 2951 2918 2 1 2909 XOR3 $T=648520 739760 1 180 $X=637360 $Y=739380
X1908 2958 477 2973 2 1 3026 XOR3 $T=648520 850640 1 0 $X=648520 $Y=845220
X1909 3034 3027 2981 2 1 2918 XOR3 $T=660920 739760 0 180 $X=649760 $Y=734340
X1910 3088 3082 3042 2 1 2981 XOR3 $T=671460 729680 1 180 $X=660300 $Y=729300
X1911 3217 3219 3181 2 1 3265 XOR3 $T=693160 709520 1 0 $X=693160 $Y=704100
X1912 3262 3268 3307 2 1 3320 XOR3 $T=703080 739760 0 0 $X=703080 $Y=739380
X1913 3286 3256 3320 2 1 3328 XOR3 $T=708040 749840 0 0 $X=708040 $Y=749460
X1914 3255 3203 3265 2 1 3307 XOR3 $T=709900 719600 0 0 $X=709900 $Y=719220
X1915 3328 3318 3308 2 1 570 XOR3 $T=722300 770000 1 180 $X=711140 $Y=769620
X1916 1099 1 1083 1119 2 1107 ND3HT $T=249860 780080 1 0 $X=249860 $Y=774660
X1917 1266 1 1280 1262 2 1274 ND3HT $T=283340 840560 0 0 $X=283340 $Y=840180
X1918 1329 1 1349 1306 2 1351 ND3HT $T=298840 830480 1 0 $X=298840 $Y=825060
X1919 952 955 968 2 1 XOR2HS $T=221340 699440 0 0 $X=221340 $Y=699060
X1920 949 956 969 2 1 XOR2HS $T=221340 719600 0 0 $X=221340 $Y=719220
X1921 946 947 970 2 1 XOR2HS $T=221340 729680 0 0 $X=221340 $Y=729300
X1922 953 957 971 2 1 XOR2HS $T=221340 749840 1 0 $X=221340 $Y=744420
X1923 954 943 972 2 1 XOR2HS $T=221340 780080 1 0 $X=221340 $Y=774660
X1924 965 944 986 2 1 XOR2HS $T=224440 749840 0 0 $X=224440 $Y=749460
X1925 958 948 987 2 1 XOR2HS $T=224440 759920 0 0 $X=224440 $Y=759540
X1926 991 988 977 2 1 XOR2HS $T=230020 820400 1 180 $X=224440 $Y=820020
X1927 976 977 951 2 1 XOR2HS $T=224440 830480 0 0 $X=224440 $Y=830100
X1928 967 964 989 2 1 XOR2HS $T=225060 709520 0 0 $X=225060 $Y=709140
X1929 959 962 990 2 1 XOR2HS $T=225060 770000 1 0 $X=225060 $Y=764580
X1930 996 998 1009 2 1 XOR2HS $T=230020 790160 1 0 $X=230020 $Y=784740
X1931 1010 1015 1024 2 1 XOR2HS $T=233740 770000 0 0 $X=233740 $Y=769620
X1932 1038 1042 1053 2 1 XOR2HS $T=238700 749840 0 0 $X=238700 $Y=749460
X1933 1034 1027 1033 2 1 XOR2HS $T=243040 749840 1 0 $X=243040 $Y=744420
X1934 1069 1074 1086 2 1 XOR2HS $T=243660 860720 0 0 $X=243660 $Y=860340
X1935 1094 1067 1080 2 1 XOR2HS $T=250480 800240 0 180 $X=244900 $Y=794820
X1936 1049 1058 1093 2 1 XOR2HS $T=245520 850640 1 0 $X=245520 $Y=845220
X1937 1093 31 1109 2 1 XOR2HS $T=248620 860720 1 0 $X=248620 $Y=855300
X1938 1098 1101 1112 2 1 XOR2HS $T=249860 749840 1 0 $X=249860 $Y=744420
X1939 1105 1103 1114 2 1 XOR2HS $T=253580 800240 0 0 $X=253580 $Y=799860
X1940 1150 1125 1167 2 1 XOR2HS $T=261640 860720 1 0 $X=261640 $Y=855300
X1941 1142 1161 1184 2 1 XOR2HS $T=265360 759920 0 0 $X=265360 $Y=759540
X1942 1007 1140 1185 2 1 XOR2HS $T=265360 780080 0 0 $X=265360 $Y=779700
X1943 1195 1202 1192 2 1 XOR2HS $T=274660 800240 0 180 $X=269080 $Y=794820
X1944 1190 1028 1201 2 1 XOR2HS $T=270940 759920 0 0 $X=270940 $Y=759540
X1945 1164 1185 1209 2 1 XOR2HS $T=270940 780080 1 0 $X=270940 $Y=774660
X1946 1133 1201 1215 2 1 XOR2HS $T=271560 770000 0 0 $X=271560 $Y=769620
X1947 1107 1205 1219 2 1 XOR2HS $T=272180 780080 0 0 $X=272180 $Y=779700
X1948 1177 1204 1207 2 1 XOR2HS $T=274040 739760 1 0 $X=274040 $Y=734340
X1949 1157 1162 1155 2 1 XOR2HS $T=277140 759920 1 0 $X=277140 $Y=754500
X1950 1233 1184 1237 2 1 XOR2HS $T=277140 770000 0 0 $X=277140 $Y=769620
X1951 1282 1257 1263 2 1 XOR2HS $T=288300 800240 1 180 $X=282720 $Y=799860
X1952 1264 1246 1242 2 1 XOR2HS $T=283960 749840 0 0 $X=283960 $Y=749460
X1953 1269 1289 1249 2 1 XOR2HS $T=291400 739760 1 180 $X=285820 $Y=739380
X1954 1284 1288 1275 2 1 XOR2HS $T=287680 860720 0 0 $X=287680 $Y=860340
X1955 1281 1277 1301 2 1 XOR2HS $T=289540 749840 1 0 $X=289540 $Y=744420
X1956 69 1254 1212 2 1 XOR2HS $T=290780 870800 1 0 $X=290780 $Y=865380
X1957 1302 1300 1295 2 1 XOR2HS $T=292640 810320 1 0 $X=292640 $Y=804900
X1958 1319 1297 1308 2 1 XOR2HS $T=298220 860720 0 180 $X=292640 $Y=855300
X1959 1314 1317 1331 2 1 XOR2HS $T=295740 719600 0 0 $X=295740 $Y=719220
X1960 1312 1313 1342 2 1 XOR2HS $T=298220 739760 0 0 $X=298220 $Y=739380
X1961 1326 1318 1347 2 1 XOR2HS $T=298840 729680 1 0 $X=298840 $Y=724260
X1962 1343 1351 1307 2 1 XOR2HS $T=304420 830480 1 180 $X=298840 $Y=830100
X1963 1258 1026 1352 2 1 XOR2HS $T=299460 759920 1 0 $X=299460 $Y=754500
X1964 1359 1355 1343 2 1 XOR2HS $T=306280 820400 0 180 $X=300700 $Y=814980
X1965 1360 1353 85 2 1 XOR2HS $T=306900 850640 1 180 $X=301320 $Y=850260
X1966 1344 1330 1346 2 1 XOR2HS $T=308760 709520 1 180 $X=303180 $Y=709140
X1967 1374 1348 1339 2 1 XOR2HS $T=308760 800240 1 180 $X=303180 $Y=799860
X1968 88 89 1341 2 1 XOR2HS $T=305040 699440 1 0 $X=305040 $Y=694020
X1969 1389 1382 1363 2 1 XOR2HS $T=310620 810320 0 180 $X=305040 $Y=804900
X1970 1390 1388 1233 2 1 XOR2HS $T=311240 749840 1 180 $X=305660 $Y=749460
X1971 1267 1352 1384 2 1 XOR2HS $T=305660 759920 1 0 $X=305660 $Y=754500
X1972 1400 1372 1385 2 1 XOR2HS $T=313720 850640 1 180 $X=308140 $Y=850260
X1973 1377 1393 1345 2 1 XOR2HS $T=314340 709520 0 180 $X=308760 $Y=704100
X1974 1354 997 1416 2 1 XOR2HS $T=312480 709520 0 0 $X=312480 $Y=709140
X1975 1415 1416 1445 2 1 XOR2HS $T=318680 709520 0 0 $X=318680 $Y=709140
X1976 1443 1446 1453 2 1 XOR2HS $T=321160 739760 1 0 $X=321160 $Y=734340
X1977 1458 1457 1480 2 1 XOR2HS $T=324880 790160 0 0 $X=324880 $Y=789780
X1978 1467 1450 1482 2 1 XOR2HS $T=326120 830480 0 0 $X=326120 $Y=830100
X1979 1485 1474 1476 2 1 XOR2HS $T=332320 780080 1 180 $X=326740 $Y=779700
X1980 112 110 107 2 1 XOR2HS $T=334180 870800 0 180 $X=328600 $Y=865380
X1981 1463 1491 1496 2 1 XOR2HS $T=330460 739760 0 0 $X=330460 $Y=739380
X1982 1503 1437 1460 2 1 XOR2HS $T=336040 810320 1 180 $X=330460 $Y=809940
X1983 1502 1525 1402 2 1 XOR2HS $T=341000 770000 1 180 $X=335420 $Y=769620
X1984 1507 1515 1530 2 1 XOR2HS $T=336040 780080 0 0 $X=336040 $Y=779700
X1985 1549 1455 1525 2 1 XOR2HS $T=347820 770000 1 180 $X=342240 $Y=769620
X1986 1569 1565 1527 2 1 XOR2HS $T=349680 820400 1 180 $X=344100 $Y=820020
X1987 1578 1572 1600 2 1 XOR2HS $T=349060 739760 1 0 $X=349060 $Y=734340
X1988 1603 1526 1553 2 1 XOR2HS $T=354640 810320 1 180 $X=349060 $Y=809940
X1989 1623 1620 1565 2 1 XOR2HS $T=358360 830480 0 180 $X=352780 $Y=825060
X1990 1619 1607 1629 2 1 XOR2HS $T=355880 739760 0 0 $X=355880 $Y=739380
X1991 1652 1649 1637 2 1 XOR2HS $T=365180 729680 0 180 $X=359600 $Y=724260
X1992 1643 1669 1656 2 1 XOR2HS $T=369520 749840 0 180 $X=363940 $Y=744420
X1993 1691 1634 1639 2 1 XOR2HS $T=371380 810320 0 180 $X=365800 $Y=804900
X1994 1656 1690 1504 2 1 XOR2HS $T=372000 749840 1 180 $X=366420 $Y=749460
X1995 171 1685 1702 2 1 XOR2HS $T=369520 820400 0 0 $X=369520 $Y=820020
X1996 1678 1687 1714 2 1 XOR2HS $T=372000 699440 1 0 $X=372000 $Y=694020
X1997 1674 1688 1715 2 1 XOR2HS $T=372000 709520 1 0 $X=372000 $Y=704100
X1998 1679 1689 1716 2 1 XOR2HS $T=372000 709520 0 0 $X=372000 $Y=709140
X1999 1612 1721 1704 2 1 XOR2HS $T=378200 759920 0 180 $X=372620 $Y=754500
X2000 1702 1608 1710 2 1 XOR2HS $T=373240 830480 0 0 $X=373240 $Y=830100
X2001 1692 1680 1727 2 1 XOR2HS $T=373860 719600 1 0 $X=373860 $Y=714180
X2002 1705 1693 1706 2 1 XOR2HS $T=374480 719600 0 0 $X=374480 $Y=719220
X2003 1720 1709 1736 2 1 XOR2HS $T=379440 739760 0 0 $X=379440 $Y=739380
X2004 1236 1751 1721 2 1 XOR2HS $T=385020 759920 0 180 $X=379440 $Y=754500
X2005 1753 1722 1738 2 1 XOR2HS $T=385020 810320 1 0 $X=385020 $Y=804900
X2006 1754 1737 1743 2 1 XOR2HS $T=386260 719600 0 0 $X=386260 $Y=719220
X2007 1816 1770 1800 2 1 XOR2HS $T=399280 800240 1 180 $X=393700 $Y=799860
X2008 1856 1831 1840 2 1 XOR2HS $T=407340 810320 0 180 $X=401760 $Y=804900
X2009 1812 1780 1864 2 1 XOR2HS $T=405480 719600 1 0 $X=405480 $Y=714180
X2010 1864 1828 1888 2 1 XOR2HS $T=412300 719600 1 0 $X=412300 $Y=714180
X2011 1881 1878 1891 2 1 XOR2HS $T=414160 810320 0 0 $X=414160 $Y=809940
X2012 1906 1871 1932 2 1 XOR2HS $T=424080 810320 1 0 $X=424080 $Y=804900
X2013 1945 1942 1936 2 1 XOR2HS $T=432760 719600 0 180 $X=427180 $Y=714180
X2014 1969 1964 1950 2 1 XOR2HS $T=438340 800240 1 180 $X=432760 $Y=799860
X2015 1944 1915 1982 2 1 XOR2HS $T=434620 810320 1 0 $X=434620 $Y=804900
X2016 253 251 243 2 1 XOR2HS $T=440200 870800 0 180 $X=434620 $Y=865380
X2017 1974 1991 2000 2 1 XOR2HS $T=438340 780080 0 0 $X=438340 $Y=779700
X2018 1998 2002 2017 2 1 XOR2HS $T=440200 850640 0 0 $X=440200 $Y=850260
X2019 1808 1762 1780 2 1 XOR2HS $T=441440 739760 1 0 $X=441440 $Y=734340
X2020 2001 1973 2016 2 1 XOR2HS $T=442060 719600 0 0 $X=442060 $Y=719220
X2021 2007 2029 1972 2 1 XOR2HS $T=448880 860720 1 180 $X=443300 $Y=860340
X2022 2010 2022 2030 2 1 XOR2HS $T=443920 790160 0 0 $X=443920 $Y=789780
X2023 2014 2005 2008 2 1 XOR2HS $T=443920 800240 0 0 $X=443920 $Y=799860
X2024 1957 1961 1999 2 1 XOR2HS $T=444540 709520 0 0 $X=444540 $Y=709140
X2025 2020 2034 2037 2 1 XOR2HS $T=447640 780080 0 0 $X=447640 $Y=779700
X2026 2031 2035 2048 2 1 XOR2HS $T=449500 850640 0 0 $X=449500 $Y=850260
X2027 2039 2046 2053 2 1 XOR2HS $T=450740 800240 0 0 $X=450740 $Y=799860
X2028 2049 2018 271 2 1 XOR2HS $T=453840 870800 1 0 $X=453840 $Y=865380
X2029 2078 2058 2103 2 1 XOR2HS $T=458180 790160 1 0 $X=458180 $Y=784740
X2030 2075 2065 2098 2 1 XOR2HS $T=458180 800240 1 0 $X=458180 $Y=794820
X2031 2097 2051 2124 2 1 XOR2HS $T=463140 780080 0 0 $X=463140 $Y=779700
X2032 288 289 2163 2 1 XOR2HS $T=473060 870800 1 0 $X=473060 $Y=865380
X2033 2028 344 2368 2 1 XOR2HS $T=519560 830480 0 0 $X=519560 $Y=830100
X2034 2203 2012 2165 2 1 XOR2HS $T=524520 860720 0 0 $X=524520 $Y=860340
X2035 2351 2364 2387 2 1 XOR2HS $T=525760 820400 1 0 $X=525760 $Y=814980
X2036 2541 2532 2575 2 1 XOR2HS $T=562960 780080 0 0 $X=562960 $Y=779700
X2037 2714 2715 2724 2 1 XOR2HS $T=597680 780080 1 0 $X=597680 $Y=774660
X2038 2734 2709 2677 2 1 XOR2HS $T=604500 790160 0 180 $X=598920 $Y=784740
X2039 2287 2728 2741 2 1 XOR2HS $T=601400 759920 0 0 $X=601400 $Y=759540
X2040 2743 2742 2727 2 1 XOR2HS $T=606980 830480 1 180 $X=601400 $Y=830100
X2041 2752 2747 2736 2 1 XOR2HS $T=608220 820400 0 180 $X=602640 $Y=814980
X2042 1905 2738 2756 2 1 XOR2HS $T=604500 780080 1 0 $X=604500 $Y=774660
X2043 276 347 2759 2 1 XOR2HS $T=605120 719600 0 0 $X=605120 $Y=719220
X2044 2084 2745 429 2 1 XOR2HS $T=605120 729680 1 0 $X=605120 $Y=724260
X2045 2064 2740 2760 2 1 XOR2HS $T=605120 790160 1 0 $X=605120 $Y=784740
X2046 1929 2746 2768 2 1 XOR2HS $T=607600 770000 1 0 $X=607600 $Y=764580
X2047 2778 2772 2758 2 1 XOR2HS $T=613800 840560 0 180 $X=608220 $Y=835140
X2048 2306 2763 2782 2 1 XOR2HS $T=610080 759920 0 0 $X=610080 $Y=759540
X2049 2790 2787 2757 2 1 XOR2HS $T=616280 810320 1 180 $X=610700 $Y=809940
X2050 2128 2774 2753 2 1 XOR2HS $T=611320 790160 1 0 $X=611320 $Y=784740
X2051 2535 2773 2796 2 1 XOR2HS $T=613180 719600 1 0 $X=613180 $Y=714180
X2052 2141 2786 2797 2 1 XOR2HS $T=613180 780080 1 0 $X=613180 $Y=774660
X2053 2802 2799 2764 2 1 XOR2HS $T=618760 850640 1 180 $X=613180 $Y=850260
X2054 336 332 2804 2 1 XOR2HS $T=614420 699440 0 0 $X=614420 $Y=699060
X2055 2777 2781 2805 2 1 XOR2HS $T=614420 820400 0 0 $X=614420 $Y=820020
X2056 2513 2776 2811 2 1 XOR2HS $T=615040 729680 1 0 $X=615040 $Y=724260
X2057 2145 2792 2819 2 1 XOR2HS $T=615660 770000 0 0 $X=615660 $Y=769620
X2058 2271 2814 2827 2 1 XOR2HS $T=617520 770000 1 0 $X=617520 $Y=764580
X2059 2815 2822 2830 2 1 XOR2HS $T=618140 820400 1 0 $X=618140 $Y=814980
X2060 2067 2806 2832 2 1 XOR2HS $T=618760 739760 0 0 $X=618760 $Y=739380
X2061 337 2791 2836 2 1 XOR2HS $T=619380 699440 1 0 $X=619380 $Y=694020
X2062 2061 2795 2837 2 1 XOR2HS $T=619380 739760 1 0 $X=619380 $Y=734340
X2063 2816 2801 2798 2 1 XOR2HS $T=619380 830480 0 0 $X=619380 $Y=830100
X2064 338 2793 2842 2 1 XOR2HS $T=620000 709520 0 0 $X=620000 $Y=709140
X2065 2311 2794 2843 2 1 XOR2HS $T=620000 719600 0 0 $X=620000 $Y=719220
X2066 2848 2845 2676 2 1 XOR2HS $T=625580 780080 0 180 $X=620000 $Y=774660
X2067 2277 2828 2855 2 1 XOR2HS $T=621860 759920 1 0 $X=621860 $Y=754500
X2068 2861 2858 2667 2 1 XOR2HS $T=627440 770000 1 180 $X=621860 $Y=769620
X2069 2341 2810 2859 2 1 XOR2HS $T=622480 719600 1 0 $X=622480 $Y=714180
X2070 2866 2870 2648 2 1 XOR2HS $T=629300 759920 1 180 $X=623720 $Y=759540
X2071 2875 2872 2856 2 1 XOR2HS $T=629920 820400 0 180 $X=624340 $Y=814980
X2072 2508 2853 2873 2 1 XOR2HS $T=624960 749840 1 0 $X=624960 $Y=744420
X2073 2305 2865 2882 2 1 XOR2HS $T=626200 739760 0 0 $X=626200 $Y=739380
X2074 2326 2818 2887 2 1 XOR2HS $T=626820 719600 0 0 $X=626820 $Y=719220
X2075 2339 2844 2891 2 1 XOR2HS $T=628060 729680 0 0 $X=628060 $Y=729300
X2076 2895 2893 2691 2 1 XOR2HS $T=634260 759920 0 180 $X=628680 $Y=754500
X2077 2885 2841 2864 2 1 XOR2HS $T=629300 830480 0 0 $X=629300 $Y=830100
X2078 2835 2860 2854 2 1 XOR2HS $T=629920 810320 1 0 $X=629920 $Y=804900
X2079 2898 2894 2675 2 1 XOR2HS $T=636740 770000 1 180 $X=631160 $Y=769620
X2080 2905 2899 2903 2 1 XOR2HS $T=640460 820400 0 180 $X=634880 $Y=814980
X2081 2911 2919 2884 2 1 XOR2HS $T=637360 810320 0 0 $X=637360 $Y=809940
X2082 2942 2932 2925 2 1 XOR2HS $T=646040 810320 0 180 $X=640460 $Y=804900
X2083 2946 2944 2812 2 1 XOR2HS $T=646660 780080 0 180 $X=641080 $Y=774660
X2084 432 478 2976 2 1 XOR2HS $T=646660 870800 1 0 $X=646660 $Y=865380
X2085 2966 2950 2943 2 1 XOR2HS $T=647900 820400 0 0 $X=647900 $Y=820020
X2086 3004 2993 2984 2 1 XOR2HS $T=655960 820400 0 180 $X=650380 $Y=814980
X2087 3024 3015 2971 2 1 XOR2HS $T=659680 770000 1 180 $X=654100 $Y=769620
X2088 2785 2992 3028 2 1 XOR2HS $T=655340 860720 0 0 $X=655340 $Y=860340
X2089 477 3037 3046 2 1 XOR2HS $T=659060 840560 1 0 $X=659060 $Y=835140
X2090 3064 3056 3048 2 1 XOR2HS $T=667740 820400 1 180 $X=662160 $Y=820020
X2091 3071 3066 3047 2 1 XOR2HS $T=671460 770000 0 180 $X=665880 $Y=764580
X2092 3061 3063 3083 2 1 XOR2HS $T=665880 810320 1 0 $X=665880 $Y=804900
X2093 401 3000 3087 2 1 XOR2HS $T=667120 860720 1 0 $X=667120 $Y=855300
X2094 427 3041 3094 2 1 XOR2HS $T=668360 850640 1 0 $X=668360 $Y=845220
X2095 3065 3077 3100 2 1 XOR2HS $T=669600 830480 0 0 $X=669600 $Y=830100
X2096 406 3058 3101 2 1 XOR2HS $T=669600 840560 1 0 $X=669600 $Y=835140
X2097 3126 3122 3103 2 1 XOR2HS $T=678280 770000 1 180 $X=672700 $Y=769620
X2098 452 3067 3120 2 1 XOR2HS $T=672700 840560 0 0 $X=672700 $Y=840180
X2099 414 3092 3130 2 1 XOR2HS $T=673940 860720 1 0 $X=673940 $Y=855300
X2100 3112 3098 3118 2 1 XOR2HS $T=680140 820400 0 180 $X=674560 $Y=814980
X2101 3142 3139 3123 2 1 XOR2HS $T=681380 759920 0 180 $X=675800 $Y=754500
X2102 469 3127 3141 2 1 XOR2HS $T=675800 830480 0 0 $X=675800 $Y=830100
X2103 3105 3111 3117 2 1 XOR2HS $T=677660 810320 1 0 $X=677660 $Y=804900
X2104 3163 3155 3140 2 1 XOR2HS $T=683860 810320 1 180 $X=678280 $Y=809940
X2105 3144 3147 528 2 1 XOR2HS $T=679520 790160 1 0 $X=679520 $Y=784740
X2106 2991 3152 3179 2 1 XOR2HS $T=682000 840560 0 0 $X=682000 $Y=840180
X2107 3166 3169 3181 2 1 XOR2HS $T=682620 709520 0 0 $X=682620 $Y=709140
X2108 2961 3143 3188 2 1 XOR2HS $T=683860 840560 1 0 $X=683860 $Y=835140
X2109 3165 3161 3192 2 1 XOR2HS $T=684480 739760 0 0 $X=684480 $Y=739380
X2110 3168 3189 3199 2 1 XOR2HS $T=686340 739760 1 0 $X=686340 $Y=734340
X2111 3167 3148 3194 2 1 XOR2HS $T=686340 820400 0 0 $X=686340 $Y=820020
X2112 3183 3186 3210 2 1 XOR2HS $T=688200 810320 0 0 $X=688200 $Y=809940
X2113 3207 3170 3239 2 1 XOR2HS $T=693780 719600 1 0 $X=693780 $Y=714180
X2114 3241 3244 3218 2 1 XOR2HS $T=699980 790160 0 180 $X=694400 $Y=784740
X2115 3242 3233 3234 2 1 XOR2HS $T=698120 810320 0 0 $X=698120 $Y=809940
X2116 3266 3245 3246 2 1 XOR2HS $T=704940 820400 0 180 $X=699360 $Y=814980
X2117 3258 3263 3254 2 1 XOR2HS $T=705560 790160 1 180 $X=699980 $Y=789780
X2118 3288 3281 3257 2 1 XOR2HS $T=709280 820400 1 180 $X=703700 $Y=820020
X2119 3269 3292 3274 2 1 XOR2HS $T=710520 780080 1 180 $X=704940 $Y=779700
X2120 3309 3305 3275 2 1 XOR2HS $T=713620 800240 1 180 $X=708040 $Y=799860
X2121 548 3289 3304 2 1 XOR2HS $T=708040 850640 0 0 $X=708040 $Y=850260
X2122 3311 3310 3293 2 1 XOR2HS $T=714240 810320 0 180 $X=708660 $Y=804900
X2123 3280 3300 3272 2 1 XOR2HS $T=709280 790160 0 0 $X=709280 $Y=789780
X2124 3323 3319 3283 2 1 XOR2HS $T=719200 820400 0 180 $X=713620 $Y=814980
X2125 542 3298 584 2 1 XOR2HS $T=714860 870800 1 0 $X=714860 $Y=865380
X2126 3331 3482 3492 2 1 XOR2HS $T=758260 739760 1 0 $X=758260 $Y=734340
X2127 3492 2987 3497 2 1 XOR2HS $T=767560 739760 1 180 $X=761980 $Y=739380
X2128 6 951 963 981 1 2 MAO222P $T=220720 840560 1 0 $X=220720 $Y=835140
X2129 1065 1063 1075 1071 1 2 MAO222P $T=242420 770000 0 0 $X=242420 $Y=769620
X2130 1073 1078 1088 1063 1 2 MAO222P $T=244900 770000 1 0 $X=244900 $Y=764580
X2131 1102 1156 1165 1178 1 2 MAO222P $T=262260 820400 0 0 $X=262260 $Y=820020
X2132 1178 1216 1227 1238 1 2 MAO222P $T=274040 820400 1 0 $X=274040 $Y=814980
X2133 1181 1217 61 1240 1 2 MAO222P $T=274040 850640 1 0 $X=274040 $Y=845220
X2134 1186 1229 1256 1267 1 2 MAO222P $T=279620 759920 0 0 $X=279620 $Y=759540
X2135 1340 1021 1357 1366 1 2 MAO222P $T=301940 749840 1 0 $X=301940 $Y=744420
X2136 1362 1002 1370 1386 1 2 MAO222P $T=304420 729680 1 0 $X=304420 $Y=724260
X2137 1404 1401 1394 1414 1 2 MAO222P $T=311860 759920 1 0 $X=311860 $Y=754500
X2138 1386 1014 1356 1415 1 2 MAO222P $T=315580 719600 1 0 $X=315580 $Y=714180
X2139 1332 1376 91 1438 1 2 MAO222P $T=326120 840560 1 0 $X=326120 $Y=835140
X2140 1695 1742 190 1814 1 2 MAO222P $T=381300 830480 0 0 $X=381300 $Y=830100
X2141 1769 1730 1763 1771 1 2 MAO222P $T=385640 729680 1 0 $X=385640 $Y=724260
X2142 1771 1765 1777 1762 1 2 MAO222P $T=386260 719600 1 0 $X=386260 $Y=714180
X2143 1838 1836 1424 1855 1 2 MAO222P $T=401140 739760 0 0 $X=401140 $Y=739380
X2144 1842 211 213 216 1 2 MAO222P $T=401760 699440 1 0 $X=401760 $Y=694020
X2145 1772 1834 1841 1902 1 2 MAO222P $T=401760 820400 0 0 $X=401760 $Y=820020
X2146 1829 1843 1384 1838 1 2 MAO222P $T=402380 759920 1 0 $X=402380 $Y=754500
X2147 1855 1849 1371 1847 1 2 MAO222P $T=404860 729680 0 0 $X=404860 $Y=729300
X2148 1902 1908 1921 1928 1 2 MAO222P $T=420980 820400 0 0 $X=420980 $Y=820020
X2149 1928 1956 1976 1992 1 2 MAO222P $T=434620 820400 1 0 $X=434620 $Y=814980
X2150 1992 2006 1989 2023 1 2 MAO222P $T=440820 820400 0 0 $X=440820 $Y=820020
X2151 1988 2019 264 2027 1 2 MAO222P $T=443300 850640 1 0 $X=443300 $Y=845220
X2152 2023 2013 2062 2079 1 2 MAO222P $T=453840 830480 0 0 $X=453840 $Y=830100
X2153 2079 2025 2085 2076 1 2 MAO222P $T=455700 830480 1 0 $X=455700 $Y=825060
X2154 2129 2125 2134 2136 1 2 MAO222P $T=465620 800240 0 0 $X=465620 $Y=799860
X2155 2136 2133 2132 2138 1 2 MAO222P $T=467480 800240 1 0 $X=467480 $Y=794820
X2156 2113 2153 290 2170 1 2 MAO222P $T=473060 860720 0 0 $X=473060 $Y=860340
X2157 2177 2175 293 2181 1 2 MAO222P $T=478640 830480 1 0 $X=478640 $Y=825060
X2158 2170 2162 2163 2192 1 2 MAO222P $T=479260 850640 0 0 $X=479260 $Y=850260
X2159 2192 2187 298 2177 1 2 MAO222P $T=481740 830480 0 0 $X=481740 $Y=830100
X2160 299 297 258 2208 1 2 MAO222P $T=482980 870800 1 0 $X=482980 $Y=865380
X2161 945 963 961 974 1 2 ND3P $T=226300 870800 1 0 $X=226300 $Y=865380
X2162 978 976 994 995 1 2 ND3P $T=226920 850640 1 0 $X=226920 $Y=845220
X2163 1030 1046 1016 1025 1 2 ND3P $T=236220 820400 1 0 $X=236220 $Y=814980
X2164 1036 1091 1045 1056 1 2 ND3P $T=243660 840560 0 0 $X=243660 $Y=840180
X2165 1051 1102 1064 1076 1 2 ND3P $T=246760 820400 1 0 $X=246760 $Y=814980
X2166 1106 1134 1113 1123 1 2 ND3P $T=256680 850640 1 0 $X=256680 $Y=845220
X2167 1127 1140 1146 1145 1 2 ND3P $T=257920 790160 0 0 $X=257920 $Y=789780
X2168 1132 1133 1143 1139 1 2 ND3P $T=264740 780080 0 180 $X=259780 $Y=774660
X2169 1166 1181 1138 1149 1 2 ND3P $T=263500 840560 0 0 $X=263500 $Y=840180
X2170 1173 1186 1159 1183 1 2 ND3P $T=264740 770000 1 0 $X=264740 $Y=764580
X2171 1189 59 55 56 1 2 ND3P $T=267840 870800 1 0 $X=267840 $Y=865380
X2172 1261 1290 1279 1270 1 2 ND3P $T=288300 770000 0 0 $X=288300 $Y=769620
X2173 1328 1340 1324 1336 1 2 ND3P $T=296980 749840 1 0 $X=296980 $Y=744420
X2174 1322 1332 1325 1299 1 2 ND3P $T=296980 850640 1 0 $X=296980 $Y=845220
X2175 1358 1380 1350 1368 1 2 ND3P $T=303180 780080 1 0 $X=303180 $Y=774660
X2176 1423 94 1411 1435 1 2 ND3P $T=316200 699440 1 0 $X=316200 $Y=694020
X2177 1432 1362 1428 1417 1 2 ND3P $T=317440 729680 0 0 $X=317440 $Y=729300
X2178 1420 1456 1439 1398 1 2 ND3P $T=321160 770000 0 0 $X=321160 $Y=769620
X2179 1465 1502 1479 1495 1 2 ND3P $T=329840 770000 0 0 $X=329840 $Y=769620
X2180 1500 1533 1506 1499 1 2 ND3P $T=334800 840560 1 0 $X=334800 $Y=835140
X2181 1493 1514 1492 1518 1 2 ND3P $T=342240 759920 0 180 $X=337280 $Y=754500
X2182 1554 1569 1538 1540 1 2 ND3P $T=344100 820400 1 0 $X=344100 $Y=814980
X2183 1541 1608 1567 1550 1 2 ND3P $T=348440 840560 1 0 $X=348440 $Y=835140
X2184 1585 1612 1580 1568 1 2 ND3P $T=349060 759920 1 0 $X=349060 $Y=754500
X2185 1539 1638 1586 1582 1 2 ND3P $T=355260 759920 0 0 $X=355260 $Y=759540
X2186 1661 1676 1647 1630 1 2 ND3P $T=364560 820400 0 0 $X=364560 $Y=820020
X2187 1672 1690 1660 1682 1 2 ND3P $T=366420 759920 0 0 $X=366420 $Y=759540
X2188 1673 1695 1677 1686 1 2 ND3P $T=366420 830480 0 0 $X=366420 $Y=830100
X2189 1728 1747 1713 1701 1 2 ND3P $T=375720 749840 0 0 $X=375720 $Y=749460
X2190 1813 1828 1820 1804 1 2 ND3P $T=396180 719600 0 0 $X=396180 $Y=719220
X2191 1877 1910 1897 1890 1 2 ND3P $T=417880 830480 0 0 $X=417880 $Y=830100
X2192 1933 1946 1925 1912 1 2 ND3P $T=425940 840560 0 0 $X=425940 $Y=840180
X2193 1951 1988 1977 1984 1 2 ND3P $T=434620 840560 0 0 $X=434620 $Y=840180
X2194 2092 2113 2101 2108 1 2 ND3P $T=458180 860720 0 0 $X=458180 $Y=860340
X2195 3465 591 598 3424 1 2 ND3P $T=758880 820400 1 180 $X=753920 $Y=820020
X2196 3424 597 594 3502 1 2 ND3P $T=760120 830480 1 0 $X=760120 $Y=825060
X2197 973 978 960 1 2 ND2 $T=224440 850640 0 180 $X=222580 $Y=845220
X2198 5 974 966 1 2 ND2 $T=224440 870800 1 0 $X=224440 $Y=865380
X2199 988 1016 976 1 2 ND2 $T=233740 820400 0 180 $X=231880 $Y=814980
X2200 991 1025 976 1 2 ND2 $T=234980 830480 0 180 $X=233120 $Y=825060
X2201 988 1030 991 1 2 ND2 $T=236840 820400 0 0 $X=236840 $Y=820020
X2202 1033 1062 10 1 2 ND2 $T=238700 770000 1 0 $X=238700 $Y=764580
X2203 1049 1029 1058 1 2 ND2 $T=241180 850640 1 0 $X=241180 $Y=845220
X2204 1052 1079 983 1 2 ND2 $T=241800 780080 0 0 $X=241800 $Y=779700
X2205 25 1056 1039 1 2 ND2 $T=241800 840560 0 0 $X=241800 $Y=840180
X2206 1057 1076 1070 1 2 ND2 $T=244900 820400 1 0 $X=244900 $Y=814980
X2207 1066 1099 1089 1 2 ND2 $T=248620 790160 1 0 $X=248620 $Y=784740
X2208 1116 1123 1108 1 2 ND2 $T=254820 850640 1 0 $X=254820 $Y=845220
X2209 1125 1069 1150 1 2 ND2 $T=256680 850640 0 0 $X=256680 $Y=850260
X2210 1130 1132 1141 1 2 ND2 $T=259160 790160 1 0 $X=259160 $Y=784740
X2211 1140 1143 1007 1 2 ND2 $T=260400 780080 0 0 $X=260400 $Y=779700
X2212 1133 1159 1028 1 2 ND2 $T=264120 770000 0 180 $X=262260 $Y=764580
X2213 1134 1166 1154 1 2 ND2 $T=265360 840560 1 0 $X=265360 $Y=835140
X2214 1007 1139 1164 1 2 ND2 $T=267840 770000 1 180 $X=265980 $Y=769620
X2215 36 45 40 1 2 ND2 $T=267840 870800 0 180 $X=265980 $Y=865380
X2216 1133 1173 1190 1 2 ND2 $T=269080 770000 0 0 $X=269080 $Y=769620
X2217 1028 1183 1190 1 2 ND2 $T=271560 770000 0 180 $X=269700 $Y=764580
X2218 1204 1200 1177 1 2 ND2 $T=274040 739760 0 180 $X=272180 $Y=734340
X2219 1192 1197 27 1 2 ND2 $T=272800 800240 0 0 $X=272800 $Y=799860
X2220 1067 1187 1094 1 2 ND2 $T=283340 810320 1 0 $X=283340 $Y=804900
X2221 1259 1279 1276 1 2 ND2 $T=286440 770000 0 0 $X=286440 $Y=769620
X2222 74 1299 1307 1 2 ND2 $T=291400 850640 1 0 $X=291400 $Y=845220
X2223 1238 1306 1304 1 2 ND2 $T=295120 820400 1 180 $X=293260 $Y=820020
X2224 1026 1336 1258 1 2 ND2 $T=298220 749840 1 180 $X=296360 $Y=749460
X2225 1238 1349 1315 1 2 ND2 $T=298220 820400 1 180 $X=296360 $Y=820020
X2226 1304 1329 1315 1 2 ND2 $T=300080 820400 0 180 $X=298220 $Y=814980
X2227 1290 1350 1095 1 2 ND2 $T=303180 780080 0 180 $X=301320 $Y=774660
X2228 1290 1358 1244 1 2 ND2 $T=303180 780080 0 0 $X=303180 $Y=779700
X2229 1244 1368 1095 1 2 ND2 $T=309380 780080 1 0 $X=309380 $Y=774660
X2230 1355 1426 1359 1 2 ND2 $T=313100 820400 1 180 $X=311240 $Y=820020
X2231 1397 92 1383 1 2 ND2 $T=313100 860720 0 0 $X=313100 $Y=860340
X2232 1011 1417 1387 1 2 ND2 $T=315580 729680 1 180 $X=313720 $Y=729300
X2233 1408 1391 1399 1 2 ND2 $T=313720 820400 1 0 $X=313720 $Y=814980
X2234 1415 1423 997 1 2 ND2 $T=318680 699440 1 180 $X=316820 $Y=699060
X2235 1354 1435 997 1 2 ND2 $T=321160 709520 0 180 $X=319300 $Y=704100
X2236 1366 1428 1011 1 2 ND2 $T=321160 729680 1 0 $X=321160 $Y=724260
X2237 1366 1432 1387 1 2 ND2 $T=322400 729680 0 0 $X=322400 $Y=729300
X2238 1449 1427 1464 1 2 ND2 $T=323640 749840 1 0 $X=323640 $Y=744420
X2239 1454 1465 1421 1 2 ND2 $T=327980 770000 1 180 $X=326120 $Y=769620
X2240 1453 1464 1488 1 2 ND2 $T=326740 739760 1 0 $X=326740 $Y=734340
X2241 1414 1495 1421 1 2 ND2 $T=329220 770000 0 180 $X=327360 $Y=764580
X2242 103 1413 98 1 2 ND2 $T=327360 860720 0 0 $X=327360 $Y=860340
X2243 1454 1479 1414 1 2 ND2 $T=329840 770000 1 180 $X=327980 $Y=769620
X2244 1456 1493 1483 1 2 ND2 $T=331700 759920 1 180 $X=329840 $Y=759540
X2245 1456 1492 1209 1 2 ND2 $T=332320 759920 0 180 $X=330460 $Y=754500
X2246 104 1499 1475 1 2 ND2 $T=334180 840560 0 180 $X=332320 $Y=835140
X2247 1438 1500 1475 1 2 ND2 $T=334180 840560 1 180 $X=332320 $Y=840180
X2248 1496 1508 1488 1 2 ND2 $T=335420 749840 0 180 $X=333560 $Y=744420
X2249 1209 1518 1483 1 2 ND2 $T=336040 759920 1 180 $X=334180 $Y=759540
X2250 1438 1506 104 1 2 ND2 $T=337280 840560 1 180 $X=335420 $Y=840180
X2251 1508 1401 1529 1 2 ND2 $T=338520 749840 1 0 $X=338520 $Y=744420
X2252 1406 1554 1511 1 2 ND2 $T=340380 810320 1 0 $X=340380 $Y=804900
X2253 1406 1538 1528 1 2 ND2 $T=342240 810320 1 180 $X=340380 $Y=809940
X2254 1511 1540 1528 1 2 ND2 $T=342860 820400 0 180 $X=341000 $Y=814980
X2255 1533 1541 1527 1 2 ND2 $T=342860 840560 0 180 $X=341000 $Y=835140
X2256 125 1550 1527 1 2 ND2 $T=345960 840560 0 180 $X=344100 $Y=835140
X2257 1215 1568 1504 1 2 ND2 $T=347820 759920 0 180 $X=345960 $Y=754500
X2258 1549 1582 1455 1 2 ND2 $T=347820 770000 0 180 $X=345960 $Y=764580
X2259 1533 1567 125 1 2 ND2 $T=345960 840560 1 0 $X=345960 $Y=835140
X2260 1573 1549 1596 1 2 ND2 $T=349060 749840 1 0 $X=349060 $Y=744420
X2261 1514 1580 1215 1 2 ND2 $T=350920 759920 0 0 $X=350920 $Y=759540
X2262 1598 1596 93 1 2 ND2 $T=354020 729680 0 0 $X=354020 $Y=729300
X2263 1600 1573 1488 1 2 ND2 $T=354020 749840 1 0 $X=354020 $Y=744420
X2264 1597 1513 1609 1 2 ND2 $T=355260 860720 1 0 $X=355260 $Y=855300
X2265 1514 1585 1504 1 2 ND2 $T=357740 759920 0 180 $X=355880 $Y=754500
X2266 1618 1644 1624 1 2 ND2 $T=358980 790160 1 0 $X=358980 $Y=784740
X2267 1569 1661 1620 1 2 ND2 $T=360840 820400 0 180 $X=358980 $Y=814980
X2268 1623 1630 1620 1 2 ND2 $T=360840 830480 0 180 $X=358980 $Y=825060
X2269 1569 1647 1623 1 2 ND2 $T=363320 820400 1 180 $X=361460 $Y=820020
X2270 1638 1660 1601 1 2 ND2 $T=364560 759920 1 180 $X=362700 $Y=759540
X2271 1638 1672 1593 1 2 ND2 $T=364560 770000 0 180 $X=362700 $Y=764580
X2272 1593 1682 1601 1 2 ND2 $T=365180 759920 0 180 $X=363320 $Y=754500
X2273 1608 1673 171 1 2 ND2 $T=366420 840560 0 180 $X=364560 $Y=835140
X2274 171 1686 1685 1 2 ND2 $T=367660 830480 1 0 $X=367660 $Y=825060
X2275 1658 1627 1667 1 2 ND2 $T=367660 850640 0 0 $X=367660 $Y=850260
X2276 1643 1701 1669 1 2 ND2 $T=373240 749840 0 180 $X=371380 $Y=744420
X2277 1608 1677 1685 1 2 ND2 $T=371380 830480 1 0 $X=371380 $Y=825060
X2278 1690 1728 1669 1 2 ND2 $T=373240 749840 1 0 $X=373240 $Y=744420
X2279 1690 1713 1643 1 2 ND2 $T=373240 749840 0 0 $X=373240 $Y=749460
X2280 1774 1782 1746 1 2 ND2 $T=389980 749840 1 0 $X=389980 $Y=744420
X2281 1236 1792 1751 1 2 ND2 $T=389980 759920 1 0 $X=389980 $Y=754500
X2282 1612 1796 1236 1 2 ND2 $T=389980 759920 0 0 $X=389980 $Y=759540
X2283 1774 1790 1803 1 2 ND2 $T=391840 739760 0 0 $X=391840 $Y=739380
X2284 1612 1806 1751 1 2 ND2 $T=393700 759920 0 180 $X=391840 $Y=754500
X2285 1440 1804 1802 1 2 ND2 $T=393700 719600 0 0 $X=393700 $Y=719220
X2286 1828 1835 1812 1 2 ND2 $T=401760 719600 1 0 $X=401760 $Y=714180
X2287 1812 1850 1780 1 2 ND2 $T=404240 709520 0 0 $X=404240 $Y=709140
X2288 1863 1890 217 1 2 ND2 $T=415400 830480 0 0 $X=415400 $Y=830100
X2289 231 1912 1907 1 2 ND2 $T=424080 840560 0 180 $X=422220 $Y=835140
X2290 1910 1925 1907 1 2 ND2 $T=424080 840560 1 180 $X=422220 $Y=840180
X2291 1946 1951 1949 1 2 ND2 $T=432140 840560 0 0 $X=432140 $Y=840180
X2292 1970 1966 1993 1 2 ND2 $T=437720 749840 1 0 $X=437720 $Y=744420
X2293 1946 1977 265 1 2 ND2 $T=440200 840560 0 0 $X=440200 $Y=840180
X2294 1949 1984 265 1 2 ND2 $T=442680 840560 0 0 $X=442680 $Y=840180
X2295 2020 1991 2034 1 2 ND2 $T=444540 780080 1 0 $X=444540 $Y=774660
X2296 2027 2041 270 1 2 ND2 $T=446400 840560 0 0 $X=446400 $Y=840180
X2297 2015 2021 2036 1 2 ND2 $T=447640 749840 0 0 $X=447640 $Y=749460
X2298 267 2009 2054 1 2 ND2 $T=452600 729680 1 0 $X=452600 $Y=724260
X2299 2063 2033 2071 1 2 ND2 $T=455080 729680 1 0 $X=455080 $Y=724260
X2300 268 2042 2088 1 2 ND2 $T=456320 699440 1 0 $X=456320 $Y=694020
X2301 1980 2089 2093 1 2 ND2 $T=458800 770000 1 0 $X=458800 $Y=764580
X2302 274 2094 2109 1 2 ND2 $T=460040 719600 1 0 $X=460040 $Y=714180
X2303 2056 2096 2106 1 2 ND2 $T=460040 759920 1 0 $X=460040 $Y=754500
X2304 2027 2082 2057 1 2 ND2 $T=460040 840560 0 0 $X=460040 $Y=840180
X2305 2105 2095 2114 1 2 ND2 $T=461900 739760 0 0 $X=461900 $Y=739380
X2306 2107 2101 2143 1 2 ND2 $T=463140 860720 0 0 $X=463140 $Y=860340
X2307 2107 2092 285 1 2 ND2 $T=463760 870800 1 0 $X=463760 $Y=865380
X2308 285 2108 2143 1 2 ND2 $T=468720 870800 1 0 $X=468720 $Y=865380
X2309 2212 2167 2218 1 2 ND2 $T=488560 739760 1 0 $X=488560 $Y=734340
X2310 2259 2173 2248 1 2 ND2 $T=499720 780080 1 0 $X=499720 $Y=774660
X2311 2249 2320 2313 1 2 ND2 $T=510880 780080 1 180 $X=509020 $Y=779700
X2312 2269 2328 322 1 2 ND2 $T=514600 729680 0 0 $X=514600 $Y=729300
X2313 2351 2281 2353 1 2 ND2 $T=515840 810320 0 0 $X=515840 $Y=809940
X2314 2348 2080 2355 1 2 ND2 $T=517080 759920 0 0 $X=517080 $Y=759540
X2315 2235 2362 316 1 2 ND2 $T=520180 759920 1 0 $X=520180 $Y=754500
X2316 2307 309 2379 1 2 ND2 $T=524520 759920 1 180 $X=522660 $Y=759540
X2317 2398 2397 2375 1 2 ND2 $T=528240 780080 0 180 $X=526380 $Y=774660
X2318 2280 2234 2398 1 2 ND2 $T=530100 780080 0 180 $X=528240 $Y=774660
X2319 2209 2278 358 1 2 ND2 $T=532580 749840 0 0 $X=532580 $Y=749460
X2320 2428 2434 2442 1 2 ND2 $T=536300 739760 0 0 $X=536300 $Y=739380
X2321 372 2398 2280 1 2 ND2 $T=546840 780080 1 180 $X=544980 $Y=779700
X2322 2472 2493 2449 1 2 ND2 $T=548700 759920 0 180 $X=546840 $Y=754500
X2323 2471 2546 2456 1 2 ND2 $T=549940 749840 1 180 $X=548080 $Y=749460
X2324 376 2515 2524 1 2 ND2 $T=553660 729680 0 0 $X=553660 $Y=729300
X2325 2541 2527 2532 1 2 ND2 $T=560480 790160 1 0 $X=560480 $Y=784740
X2326 386 2586 2598 1 2 ND2 $T=568540 719600 0 0 $X=568540 $Y=719220
X2327 387 2602 2606 1 2 ND2 $T=569160 739760 1 0 $X=569160 $Y=734340
X2328 390 2629 2608 1 2 ND2 $T=575980 729680 0 180 $X=574120 $Y=724260
X2329 393 2619 2604 1 2 ND2 $T=577220 709520 0 180 $X=575360 $Y=704100
X2330 402 2703 2692 1 2 ND2 $T=589000 739760 1 0 $X=589000 $Y=734340
X2331 404 2682 2685 1 2 ND2 $T=590860 719600 1 0 $X=590860 $Y=714180
X2332 410 2705 2669 1 2 ND2 $T=594580 709520 1 180 $X=592720 $Y=709140
X2333 2695 2684 408 1 2 ND2 $T=592720 870800 1 0 $X=592720 $Y=865380
X2334 2698 2701 411 1 2 ND2 $T=594580 860720 1 0 $X=594580 $Y=855300
X2335 415 2721 2679 1 2 ND2 $T=597680 699440 1 180 $X=595820 $Y=699060
X2336 2691 2712 2668 1 2 ND2 $T=599540 770000 1 0 $X=599540 $Y=764580
X2337 2718 2717 419 1 2 ND2 $T=599540 840560 1 0 $X=599540 $Y=835140
X2338 422 2733 2722 1 2 ND2 $T=603260 739760 1 180 $X=601400 $Y=739380
X2339 2730 2726 421 1 2 ND2 $T=603260 860720 0 180 $X=601400 $Y=855300
X2340 2770 2737 2755 1 2 ND2 $T=611320 850640 0 180 $X=609460 $Y=845220
X2341 2779 2783 2769 1 2 ND2 $T=613180 840560 1 180 $X=611320 $Y=840180
X2342 2878 2788 2840 1 2 ND2 $T=628680 840560 0 180 $X=626820 $Y=835140
X2343 2927 2914 2920 1 2 ND2 $T=642320 820400 1 180 $X=640460 $Y=820020
X2344 2933 2930 2879 1 2 ND2 $T=643560 840560 1 0 $X=643560 $Y=835140
X2345 2990 2980 2998 1 2 ND2 $T=652240 830480 1 0 $X=652240 $Y=825060
X2346 3039 3033 3031 1 2 ND2 $T=660920 820400 1 180 $X=659060 $Y=820020
X2347 3115 521 3049 1 2 ND2 $T=676420 850640 0 180 $X=674560 $Y=845220
X2348 3091 518 3132 1 2 ND2 $T=675800 870800 1 0 $X=675800 $Y=865380
X2349 3154 3173 3164 1 2 ND2 $T=684480 850640 0 180 $X=682620 $Y=845220
X2350 3184 3225 3202 1 2 ND2 $T=693160 860720 0 180 $X=691300 $Y=855300
X2351 624 3419 3443 1 2 ND2 $T=749580 699440 0 0 $X=749580 $Y=699060
X2352 3502 3531 3424 1 2 ND2 $T=769420 830480 0 180 $X=767560 $Y=825060
X2353 3424 3529 3465 1 2 ND2 $T=770040 820400 1 180 $X=768180 $Y=820020
X2354 3804 734 666 1 2 ND2 $T=841340 709520 1 180 $X=839480 $Y=709140
X2355 4256 4257 3802 1 2 ND2 $T=974020 820400 0 180 $X=972160 $Y=814980
X2356 3802 4260 3831 1 2 ND2 $T=974020 820400 1 180 $X=972160 $Y=820020
X2357 3786 850 3831 1 2 ND2 $T=975880 830480 0 180 $X=974020 $Y=825060
X2358 4256 846 3786 1 2 ND2 $T=975880 830480 1 180 $X=974020 $Y=830100
X2359 4278 851 3788 1 2 ND2 $T=980840 830480 0 180 $X=978980 $Y=825060
X2360 4279 854 4278 1 2 ND2 $T=985180 830480 0 180 $X=983320 $Y=825060
X2361 333 335 1 2 INV12CK $T=510880 780080 0 0 $X=510880 $Y=779700
X2362 343 300 1 2 INV12CK $T=520180 749840 0 0 $X=520180 $Y=749460
X2363 590 3379 1 2 INV12CK $T=724160 759920 0 0 $X=724160 $Y=759540
X2364 525 620 1 2 INV12CK $T=739660 759920 0 0 $X=739660 $Y=759540
X2365 3379 3574 1 2 INV12CK $T=768800 759920 0 0 $X=768800 $Y=759540
X2366 3577 638 1 2 INV12CK $T=779340 739760 0 0 $X=779340 $Y=739380
X2367 3574 3577 1 2 INV12CK $T=779340 749840 0 0 $X=779340 $Y=749460
X2368 3661 617 1 2 INV12CK $T=804140 810320 0 180 $X=794220 $Y=804900
X2369 620 610 1 2 INV12CK $T=807240 759920 0 0 $X=807240 $Y=759540
X2370 3773 710 1 2 INV12CK $T=844440 870800 0 180 $X=834520 $Y=865380
X2371 67 1 1240 1280 2 ND2T $T=282720 840560 1 0 $X=282720 $Y=835140
X2372 1247 1 1240 1266 2 ND2T $T=290780 840560 0 0 $X=290780 $Y=840180
X2373 1751 1732 2 1768 1747 1 1823 FA1 $T=383780 749840 0 0 $X=383780 $Y=749460
X2374 2026 2011 2 1929 2047 1 1981 FA1 $T=453840 770000 0 180 $X=438340 $Y=764580
X2375 2045 2110 2 2077 2050 1 2073 FA1 $T=452600 719600 0 0 $X=452600 $Y=719220
X2376 2139 2081 2 2084 2127 1 2050 FA1 $T=468720 709520 1 180 $X=453220 $Y=709140
X2377 277 2142 2 2052 281 1 2127 FA1 $T=461280 699440 1 0 $X=461280 $Y=694020
X2378 2122 2115 2 2061 2184 1 2130 FA1 $T=483600 729680 0 180 $X=468100 $Y=724260
X2379 2123 2174 2 2067 2130 1 2186 FA1 $T=469340 739760 0 0 $X=469340 $Y=739380
X2380 2118 2179 2 2077 2151 1 2184 FA1 $T=470580 719600 1 0 $X=470580 $Y=714180
X2381 2146 2182 2 2141 2156 1 2135 FA1 $T=471200 780080 1 0 $X=471200 $Y=774660
X2382 286 2183 2 2052 287 1 2197 FA1 $T=471820 709520 1 0 $X=471820 $Y=704100
X2383 2126 2144 2 2084 2197 1 2151 FA1 $T=487940 709520 1 180 $X=472440 $Y=709140
X2384 2149 2167 2 2141 2193 1 2120 FA1 $T=487940 770000 0 180 $X=472440 $Y=764580
X2385 2164 2180 2 2145 2166 1 2156 FA1 $T=491040 749840 0 180 $X=475540 $Y=744420
X2386 2155 2195 2 2145 2186 1 2193 FA1 $T=479880 759920 1 0 $X=479880 $Y=754500
X2387 2498 2546 2 2508 2514 1 2595 FA1 $T=550560 749840 1 0 $X=550560 $Y=744420
X2388 2581 2411 2 2339 2530 1 2507 FA1 $T=566680 719600 1 180 $X=551180 $Y=719220
X2389 2587 2434 2 2305 2507 1 2514 FA1 $T=567300 739760 0 180 $X=551800 $Y=734340
X2390 2594 2540 2 2326 2579 1 2518 FA1 $T=569160 709520 0 180 $X=553660 $Y=704100
X2391 2600 2366 2 2326 2585 1 2530 FA1 $T=571640 719600 0 180 $X=556140 $Y=714180
X2392 2610 2560 2 2305 2559 1 2544 FA1 $T=579080 739760 1 180 $X=563580 $Y=739380
X2393 2569 2614 2 2277 2536 1 2640 FA1 $T=565440 759920 1 0 $X=565440 $Y=754500
X2394 2662 2413 2 2341 395 1 2593 FA1 $T=585900 699440 1 180 $X=570400 $Y=699060
X2395 2653 2689 2 2271 2640 1 2725 FA1 $T=583420 749840 0 0 $X=583420 $Y=749460
X2396 2748 413 2 414 426 1 2686 FA1 $T=606980 860720 1 180 $X=591480 $Y=860340
X2397 2696 2762 2 2306 2725 1 2767 FA1 $T=599540 759920 1 0 $X=599540 $Y=754500
X2398 2868 463 2 456 2904 1 2928 FA1 $T=626820 850640 0 0 $X=626820 $Y=850260
X2399 2871 2912 2 456 2924 1 2929 FA1 $T=627440 840560 0 0 $X=627440 $Y=840180
X2400 2886 470 2 469 2880 1 2924 FA1 $T=631160 860720 0 0 $X=631160 $Y=860340
X2401 3011 506 2 504 493 1 3093 FA1 $T=656580 870800 1 0 $X=656580 $Y=865380
X2402 3053 3106 2 504 507 1 3160 FA1 $T=664020 860720 0 0 $X=664020 $Y=860340
X2403 1209 1483 1434 2 1 1535 XOR3S $T=329840 780080 1 0 $X=329840 $Y=774660
X2404 1918 1926 1934 2 1 1990 XOR3S $T=427800 759920 0 0 $X=427800 $Y=759540
X2405 2019 264 1988 2 1 2099 XOR3S $T=449500 850640 1 0 $X=449500 $Y=845220
X2406 2485 2287 2719 2 1 2723 XOR3S $T=615660 739760 1 180 $X=604500 $Y=739380
X2407 475 477 2978 2 1 3025 XOR3S $T=644800 860720 1 0 $X=644800 $Y=855300
X2408 3211 548 3187 2 1 3159 XOR3S $T=696880 850640 0 180 $X=685720 $Y=845220
X2409 1230 1125 1 2 INV3 $T=278380 850640 1 180 $X=275900 $Y=850260
X2410 334 296 1 2 INV3 $T=512120 860720 0 0 $X=512120 $Y=860340
X2411 634 47 1 2 INV3 $T=753300 699440 0 180 $X=750820 $Y=694020
X2412 3644 183 1 2 INV3 $T=796700 719600 0 180 $X=794220 $Y=714180
X2413 3648 660 1 2 INV3 $T=814060 719600 0 0 $X=814060 $Y=719220
X2414 1006 996 1 2 INV2 $T=238700 790160 0 180 $X=236840 $Y=784740
X2415 1013 1040 1 2 INV2 $T=238080 790160 0 0 $X=238080 $Y=789780
X2416 1050 1037 1 2 INV2 $T=240560 719600 0 180 $X=238700 $Y=714180
X2417 1043 1054 1 2 INV2 $T=240560 770000 0 0 $X=240560 $Y=769620
X2418 1052 1027 1 2 INV2 $T=243660 739760 1 180 $X=241800 $Y=739380
X2419 1077 1095 1 2 INV2 $T=246760 780080 1 0 $X=246760 $Y=774660
X2420 1117 973 1 2 INV2 $T=255440 810320 0 0 $X=255440 $Y=809940
X2421 34 1176 1 2 INV2 $T=269700 729680 0 180 $X=267840 $Y=724260
X2422 1148 1180 1 2 INV2 $T=269080 810320 1 0 $X=269080 $Y=804900
X2423 1167 1210 1 2 INV2 $T=272800 850640 0 0 $X=272800 $Y=850260
X2424 1225 1211 1 2 INV2 $T=276520 860720 0 0 $X=276520 $Y=860340
X2425 1232 1236 1 2 INV2 $T=277760 759920 0 0 $X=277760 $Y=759540
X2426 1248 1150 1 2 INV2 $T=281480 850640 1 180 $X=279620 $Y=850260
X2427 1273 1067 1 2 INV2 $T=285200 800240 0 180 $X=283340 $Y=794820
X2428 1271 1288 1 2 INV2 $T=291400 850640 0 0 $X=291400 $Y=850260
X2429 1308 1323 1 2 INV2 $T=298220 860720 1 0 $X=298220 $Y=855300
X2430 1309 1319 1 2 INV2 $T=301320 870800 1 0 $X=301320 $Y=865380
X2431 1364 1371 1 2 INV2 $T=306280 739760 1 0 $X=306280 $Y=734340
X2432 1407 1244 1 2 INV2 $T=313720 759920 0 0 $X=313720 $Y=759540
X2433 1425 1276 1 2 INV2 $T=318060 759920 1 0 $X=318060 $Y=754500
X2434 1473 1443 1 2 INV2 $T=327360 739760 0 0 $X=327360 $Y=739380
X2435 1513 1409 1 2 INV2 $T=337280 850640 1 180 $X=335420 $Y=850260
X2436 93 1488 1 2 INV2 $T=338520 729680 1 180 $X=336660 $Y=729300
X2437 1517 1483 1 2 INV2 $T=339140 759920 0 0 $X=339140 $Y=759540
X2438 1542 1489 1 2 INV2 $T=342860 860720 0 180 $X=341000 $Y=855300
X2439 1574 1422 1 2 INV2 $T=352780 790160 1 180 $X=350920 $Y=789780
X2440 202 1808 1 2 INV2 $T=390600 709520 0 0 $X=390600 $Y=709140
X2441 2225 2219 1 2 INV2 $T=491040 860720 1 0 $X=491040 $Y=855300
X2442 2275 2298 1 2 INV2 $T=509640 790160 0 0 $X=509640 $Y=789780
X2443 2254 2307 1 2 INV2 $T=511500 759920 0 0 $X=511500 $Y=759540
X2444 2319 304 1 2 INV2 $T=512740 729680 0 0 $X=512740 $Y=729300
X2445 2262 2290 1 2 INV2 $T=515840 790160 1 0 $X=515840 $Y=784740
X2446 2357 303 1 2 INV2 $T=517080 729680 0 0 $X=517080 $Y=729300
X2447 362 223 1 2 INV2 $T=529480 790160 1 0 $X=529480 $Y=784740
X2448 2360 305 1 2 INV2 $T=535680 749840 0 0 $X=535680 $Y=749460
X2449 2300 2435 1 2 INV2 $T=536300 790160 0 0 $X=536300 $Y=789780
X2450 2637 259 1 2 INV2 $T=602640 729680 1 0 $X=602640 $Y=724260
X2451 453 458 1 2 INV2 $T=656580 699440 1 0 $X=656580 $Y=694020
X2452 508 2751 1 2 INV2 $T=667740 850640 1 180 $X=665880 $Y=850260
X2453 3474 633 1 2 INV2 $T=757020 749840 0 180 $X=755160 $Y=744420
X2454 3566 206 1 2 INV2 $T=777480 749840 1 180 $X=775620 $Y=749460
X2455 3570 205 1 2 INV2 $T=779340 739760 1 180 $X=777480 $Y=739380
X2456 3555 209 1 2 INV2 $T=779340 749840 1 180 $X=777480 $Y=749460
X2457 3592 192 1 2 INV2 $T=781820 719600 0 180 $X=779960 $Y=714180
X2458 3613 215 1 2 INV2 $T=788640 749840 0 180 $X=786780 $Y=744420
X2459 3459 3480 639 2 3435 1 3490 AN4B1S $T=757640 780080 1 0 $X=757640 $Y=774660
X2460 3518 3509 645 2 3501 1 3495 AN4B1S $T=766940 780080 0 180 $X=762600 $Y=774660
X2461 3568 3564 663 2 3557 1 3550 AN4B1S $T=778720 780080 0 180 $X=774380 $Y=774660
X2462 3572 3565 664 2 3547 1 3559 AN4B1S $T=778720 810320 1 180 $X=774380 $Y=809940
X2463 3585 3576 670 2 3537 1 3569 AN4B1S $T=781200 830480 1 180 $X=776860 $Y=830100
X2464 3606 3638 696 2 3658 1 3667 AN4B1S $T=801040 860720 0 0 $X=801040 $Y=860340
X2465 3643 3677 698 2 3685 1 3663 AN4B1S $T=805380 840560 0 0 $X=805380 $Y=840180
X2466 3681 3710 703 2 3713 1 3717 AN4B1S $T=813440 840560 1 0 $X=813440 $Y=835140
X2467 3693 3715 705 2 3721 1 3716 AN4B1S $T=815920 810320 0 0 $X=815920 $Y=809940
X2468 3704 3741 720 2 3711 1 3767 AN4B1S $T=828940 780080 1 0 $X=828940 $Y=774660
X2469 3699 3733 721 2 3763 1 3754 AN4B1S $T=828940 790160 0 0 $X=828940 $Y=789780
X2470 3770 3813 745 2 747 1 3801 AN4B1S $T=845060 870800 1 0 $X=845060 $Y=865380
X2471 3889 3941 3947 2 3950 1 3821 AN4B1S $T=881640 770000 1 0 $X=881640 $Y=764580
X2472 3935 791 792 2 793 1 3932 AN4B1S $T=881640 870800 1 0 $X=881640 $Y=865380
X2473 3948 3971 801 2 3981 1 3989 AN4B1S $T=887220 860720 1 0 $X=887220 $Y=855300
X2474 3964 3992 3994 2 4000 1 3865 AN4B1S $T=890320 790160 0 0 $X=890320 $Y=789780
X2475 3993 3951 803 2 4004 1 4003 AN4B1S $T=891560 850640 1 0 $X=891560 $Y=845220
X2476 3913 3999 4005 2 4008 1 4006 AN4B1S $T=893420 749840 1 0 $X=893420 $Y=744420
X2477 3922 4011 4016 2 4023 1 3847 AN4B1S $T=895280 739760 1 0 $X=895280 $Y=734340
X2478 3988 4012 4018 2 4024 1 3755 AN4B1S $T=895280 810320 1 0 $X=895280 $Y=804900
X2479 3909 4015 4025 2 4028 1 3702 AN4B1S $T=896520 729680 1 0 $X=896520 $Y=724260
X2480 3910 4026 4030 2 4034 1 3834 AN4B1S $T=898380 780080 1 0 $X=898380 $Y=774660
X2481 3990 4041 4043 2 4045 1 3796 AN4B1S $T=901480 810320 1 0 $X=901480 $Y=804900
X2482 3933 4036 4044 2 4046 1 4052 AN4B1S $T=902100 719600 1 0 $X=902100 $Y=714180
X2483 3954 4050 4053 2 4055 1 4065 AN4B1S $T=905200 780080 0 0 $X=905200 $Y=779700
X2484 3956 4059 4062 2 4064 1 3761 AN4B1S $T=907680 719600 1 0 $X=907680 $Y=714180
X2485 3978 4058 4068 2 4071 1 3799 AN4B1S $T=908920 800240 1 0 $X=908920 $Y=794820
X2486 3929 4069 4095 2 4097 1 3828 AN4B1S $T=917600 770000 0 0 $X=917600 $Y=769620
X2487 4109 4079 4105 2 4102 1 3816 AN4B1S $T=925040 759920 0 180 $X=920700 $Y=754500
X2488 4098 4092 4118 2 4120 1 3803 AN4B1S $T=925040 810320 1 0 $X=925040 $Y=804900
X2489 4147 4084 4137 2 4131 1 4127 AN4B1S $T=933100 729680 0 180 $X=928760 $Y=724260
X2490 4156 4093 4172 2 4173 1 4169 AN4B1S $T=939920 749840 1 0 $X=939920 $Y=744420
X2491 4316 4312 4309 2 4307 1 4085 AN4B1S $T=1000060 790160 0 180 $X=995720 $Y=784740
X2492 4338 4300 4326 2 4321 1 4311 AN4B1S $T=1003780 719600 0 180 $X=999440 $Y=714180
X2493 4344 4322 4335 2 4333 1 4259 AN4B1S $T=1005640 800240 0 180 $X=1001300 $Y=794820
X2494 4356 4334 4348 2 4346 1 4342 AN4B1S $T=1009980 739760 1 180 $X=1005640 $Y=739380
X2495 4365 4347 4371 2 4374 1 4241 AN4B1S $T=1011220 820400 0 0 $X=1011220 $Y=820020
X2496 4372 4355 4378 2 4379 1 4273 AN4B1S $T=1013700 759920 1 0 $X=1013700 $Y=754500
X2497 4366 4331 4380 2 4383 1 3824 AN4B1S $T=1015560 770000 0 0 $X=1015560 $Y=769620
X2498 4375 4360 4385 2 4386 1 4268 AN4B1S $T=1017420 810320 0 0 $X=1017420 $Y=809940
X2499 4388 4317 4394 2 4390 1 4315 AN4B1S $T=1023620 729680 1 0 $X=1023620 $Y=724260
X2500 4441 4436 4431 2 4434 1 4284 AN4B1S $T=1047800 729680 0 180 $X=1043460 $Y=724260
X2501 4461 4442 4440 2 4438 1 4282 AN4B1S $T=1049660 749840 0 180 $X=1045320 $Y=744420
X2502 4481 4451 4465 2 4462 1 4248 AN4B1S $T=1055860 790160 1 180 $X=1051520 $Y=789780
X2503 4479 4443 4466 2 4463 1 4281 AN4B1S $T=1056480 719600 0 180 $X=1052140 $Y=714180
X2504 4484 4450 4467 2 4464 1 4277 AN4B1S $T=1056480 759920 0 180 $X=1052140 $Y=754500
X2505 4487 4457 4475 2 4469 1 4261 AN4B1S $T=1057720 810320 0 180 $X=1053380 $Y=804900
X2506 4486 4483 4478 2 4474 1 4225 AN4B1S $T=1058340 780080 1 180 $X=1054000 $Y=779700
X2507 4506 4504 4502 2 4500 1 4235 AN4B1S $T=1066400 820400 0 180 $X=1062060 $Y=814980
X2508 16 2 999 1004 1 NR2 $T=234360 739760 0 180 $X=232500 $Y=734340
X2509 16 2 1008 1037 1 NR2 $T=236840 719600 1 0 $X=236840 $Y=714180
X2510 16 2 1032 1041 1 NR2 $T=238700 719600 0 0 $X=238700 $Y=719220
X2511 1042 2 1034 1038 1 NR2 $T=239940 749840 1 0 $X=239940 $Y=744420
X2512 16 2 1060 1087 1 NR2 $T=243660 729680 1 0 $X=243660 $Y=724260
X2513 1103 2 1094 1105 1 NR2 $T=254200 800240 0 180 $X=252340 $Y=794820
X2514 37 2 1120 41 1 NR2 $T=261020 709520 1 0 $X=261020 $Y=704100
X2515 37 2 1118 42 1 NR2 $T=261020 709520 0 0 $X=261020 $Y=709140
X2516 37 2 1124 44 1 NR2 $T=262260 699440 0 0 $X=262260 $Y=699060
X2517 37 2 33 47 1 NR2 $T=264120 699440 1 0 $X=264120 $Y=694020
X2518 37 2 1121 48 1 NR2 $T=264120 709520 1 0 $X=264120 $Y=704100
X2519 46 2 1168 39 1 NR2 $T=265980 709520 1 180 $X=264120 $Y=709140
X2520 1157 2 1101 1162 1 NR2 $T=266600 739760 0 180 $X=264740 $Y=734340
X2521 46 2 53 44 1 NR2 $T=269080 699440 1 0 $X=269080 $Y=694020
X2522 46 2 1206 48 1 NR2 $T=269080 699440 0 0 $X=269080 $Y=699060
X2523 46 2 1188 50 1 NR2 $T=269080 709520 1 0 $X=269080 $Y=704100
X2524 46 2 1193 42 1 NR2 $T=270320 709520 0 0 $X=270320 $Y=709140
X2525 46 2 1213 41 1 NR2 $T=271560 699440 1 0 $X=271560 $Y=694020
X2526 51 2 1214 1160 1 NR2 $T=272800 729680 0 0 $X=272800 $Y=729300
X2527 1208 2 1246 1200 1 NR2 $T=279620 749840 0 180 $X=277760 $Y=744420
X2528 51 2 1245 1231 1 NR2 $T=281480 729680 0 180 $X=279620 $Y=724260
X2529 51 2 1293 1191 1 NR2 $T=289540 719600 1 180 $X=287680 $Y=719220
X2530 51 2 1294 1172 1 NR2 $T=289540 729680 1 180 $X=287680 $Y=729300
X2531 95 2 1444 41 1 NR2 $T=321780 699440 0 0 $X=321780 $Y=699060
X2532 95 2 1462 48 1 NR2 $T=323640 699440 0 0 $X=323640 $Y=699060
X2533 95 2 1452 42 1 NR2 $T=323640 719600 1 0 $X=323640 $Y=714180
X2534 95 2 1468 39 1 NR2 $T=326120 719600 1 0 $X=326120 $Y=714180
X2535 1461 2 1463 1473 1 NR2 $T=326120 729680 0 0 $X=326120 $Y=729300
X2536 95 2 1478 44 1 NR2 $T=328600 699440 1 0 $X=328600 $Y=694020
X2537 95 2 1487 50 1 NR2 $T=332320 719600 1 0 $X=332320 $Y=714180
X2538 1497 2 1461 1509 1 NR2 $T=334180 729680 1 0 $X=334180 $Y=724260
X2539 1498 2 1105 1524 1 NR2 $T=334180 800240 1 0 $X=334180 $Y=794820
X2540 1521 2 1520 1409 1 NR2 $T=336040 850640 0 180 $X=334180 $Y=845220
X2541 95 2 114 47 1 NR2 $T=335420 699440 1 0 $X=335420 $Y=694020
X2542 100 2 1515 118 1 NR2 $T=337280 790160 0 0 $X=337280 $Y=789780
X2543 95 2 1522 39 1 NR2 $T=339140 719600 1 0 $X=339140 $Y=714180
X2544 1489 2 1547 105 1 NR2 $T=339140 850640 0 0 $X=339140 $Y=850260
X2545 1521 2 1523 1448 1 NR2 $T=339140 860720 1 0 $X=339140 $Y=855300
X2546 1521 2 137 1548 1 NR2 $T=345960 870800 0 180 $X=344100 $Y=865380
X2547 1509 2 1559 102 1 NR2 $T=347820 709520 1 180 $X=345960 $Y=709140
X2548 1521 2 1571 1412 1 NR2 $T=345960 870800 1 0 $X=345960 $Y=865380
X2549 126 2 1566 1441 1 NR2 $T=349680 729680 0 180 $X=347820 $Y=724260
X2550 126 2 1590 1561 1 NR2 $T=350920 719600 1 180 $X=349060 $Y=719220
X2551 1564 2 1591 1560 1 NR2 $T=349060 800240 0 0 $X=349060 $Y=799860
X2552 144 2 1602 146 1 NR2 $T=350300 780080 0 0 $X=350300 $Y=779700
X2553 126 2 1581 1570 1 NR2 $T=352780 719600 0 180 $X=350920 $Y=714180
X2554 1564 2 1614 1422 1 NR2 $T=354640 800240 1 180 $X=352780 $Y=799860
X2555 157 2 1575 151 1 NR2 $T=355880 840560 0 180 $X=354020 $Y=835140
X2556 126 2 1621 1606 1 NR2 $T=356500 719600 0 180 $X=354640 $Y=714180
X2557 157 2 1604 154 1 NR2 $T=356500 840560 1 180 $X=354640 $Y=840180
X2558 157 2 1635 161 1 NR2 $T=360220 840560 0 180 $X=358360 $Y=835140
X2559 1564 2 1633 1636 1 NR2 $T=359600 800240 1 0 $X=359600 $Y=794820
X2560 146 2 1615 150 1 NR2 $T=362700 810320 1 180 $X=360840 $Y=809940
X2561 146 2 1641 151 1 NR2 $T=362700 780080 0 0 $X=362700 $Y=779700
X2562 158 2 169 161 1 NR2 $T=362700 840560 1 0 $X=362700 $Y=835140
X2563 158 2 170 151 1 NR2 $T=362700 840560 0 0 $X=362700 $Y=840180
X2564 157 2 1576 150 1 NR2 $T=362700 850640 1 0 $X=362700 $Y=845220
X2565 146 2 1622 154 1 NR2 $T=366420 790160 0 180 $X=364560 $Y=784740
X2566 1564 2 1681 1442 1 NR2 $T=367660 800240 0 0 $X=367660 $Y=799860
X2567 177 2 1648 151 1 NR2 $T=371380 770000 1 180 $X=369520 $Y=769620
X2568 177 2 1683 161 1 NR2 $T=371380 780080 1 180 $X=369520 $Y=779700
X2569 158 2 174 178 1 NR2 $T=369520 840560 1 0 $X=369520 $Y=835140
X2570 157 2 1696 178 1 NR2 $T=371380 830480 0 0 $X=371380 $Y=830100
X2571 177 2 1731 178 1 NR2 $T=375100 770000 0 180 $X=373240 $Y=764580
X2572 177 2 1718 179 1 NR2 $T=375100 770000 1 180 $X=373240 $Y=769620
X2573 158 2 180 179 1 NR2 $T=373240 840560 1 0 $X=373240 $Y=835140
X2574 157 2 1703 179 1 NR2 $T=378200 840560 0 180 $X=376340 $Y=835140
X2575 183 2 184 158 1 NR2 $T=378200 840560 1 0 $X=378200 $Y=835140
X2576 157 2 1726 186 1 NR2 $T=378200 840560 0 0 $X=378200 $Y=840180
X2577 158 2 185 186 1 NR2 $T=378200 870800 1 0 $X=378200 $Y=865380
X2578 158 2 189 192 1 NR2 $T=381300 840560 1 0 $X=381300 $Y=835140
X2579 177 2 1748 186 1 NR2 $T=383160 770000 0 0 $X=383160 $Y=769620
X2580 157 2 1752 183 1 NR2 $T=383160 840560 1 0 $X=383160 $Y=835140
X2581 177 2 1776 183 1 NR2 $T=388120 770000 0 180 $X=386260 $Y=764580
X2582 158 2 196 199 1 NR2 $T=386260 840560 1 0 $X=386260 $Y=835140
X2583 157 2 1778 199 1 NR2 $T=390600 840560 0 180 $X=388740 $Y=835140
X2584 158 2 1757 206 1 NR2 $T=391840 840560 1 0 $X=391840 $Y=835140
X2585 157 2 1798 192 1 NR2 $T=391840 840560 0 0 $X=391840 $Y=840180
X2586 158 2 201 205 1 NR2 $T=391840 860720 0 0 $X=391840 $Y=860340
X2587 177 2 1794 199 1 NR2 $T=396800 759920 1 180 $X=394940 $Y=759540
X2588 157 2 1805 206 1 NR2 $T=394940 840560 1 0 $X=394940 $Y=835140
X2589 158 2 207 209 1 NR2 $T=394940 870800 1 0 $X=394940 $Y=865380
X2590 177 2 1807 192 1 NR2 $T=402380 770000 0 180 $X=400520 $Y=764580
X2591 177 2 1817 206 1 NR2 $T=402380 780080 1 180 $X=400520 $Y=779700
X2592 177 2 1857 205 1 NR2 $T=401760 770000 0 0 $X=401760 $Y=769620
X2593 157 2 1822 205 1 NR2 $T=401760 840560 1 0 $X=401760 $Y=835140
X2594 158 2 214 215 1 NR2 $T=403620 870800 1 0 $X=403620 $Y=865380
X2595 177 2 1861 209 1 NR2 $T=404240 770000 1 0 $X=404240 $Y=764580
X2596 157 2 1844 209 1 NR2 $T=404240 840560 1 0 $X=404240 $Y=835140
X2597 157 2 1860 215 1 NR2 $T=408580 840560 1 0 $X=408580 $Y=835140
X2598 158 2 218 1874 1 NR2 $T=410440 840560 0 0 $X=410440 $Y=840180
X2599 157 2 1870 220 1 NR2 $T=412300 850640 1 0 $X=412300 $Y=845220
X2600 177 2 1872 215 1 NR2 $T=416020 759920 1 180 $X=414160 $Y=759540
X2601 157 2 1883 1874 1 NR2 $T=414160 840560 0 0 $X=414160 $Y=840180
X2602 226 2 1866 157 1 NR2 $T=420980 850640 0 180 $X=419120 $Y=845220
X2603 177 2 1894 220 1 NR2 $T=420360 759920 0 0 $X=420360 $Y=759540
X2604 177 2 1886 1874 1 NR2 $T=422220 770000 1 180 $X=420360 $Y=769620
X2605 226 2 1879 177 1 NR2 $T=424080 770000 0 180 $X=422220 $Y=764580
X2606 249 2 1987 1973 1 NR2 $T=437720 719600 0 0 $X=437720 $Y=719220
X2607 2242 2 2240 2246 1 NR2 $T=496000 699440 1 0 $X=496000 $Y=694020
X2608 2251 2 2200 2256 1 NR2 $T=498480 719600 1 0 $X=498480 $Y=714180
X2609 2254 2 2257 2298 1 NR2 $T=505300 770000 0 0 $X=505300 $Y=769620
X2610 2282 2 2283 2302 1 NR2 $T=505920 729680 1 0 $X=505920 $Y=724260
X2611 2264 2 2232 2318 1 NR2 $T=507780 709520 0 0 $X=507780 $Y=709140
X2612 2309 2 2312 2323 1 NR2 $T=509020 729680 0 0 $X=509020 $Y=729300
X2613 2316 2 2273 2325 1 NR2 $T=509640 699440 0 0 $X=509640 $Y=699060
X2614 2324 2 2261 2319 1 NR2 $T=512120 749840 0 180 $X=510260 $Y=744420
X2615 2321 2 2303 2329 1 NR2 $T=510880 719600 0 0 $X=510880 $Y=719220
X2616 2249 2 2335 2262 1 NR2 $T=513360 770000 0 0 $X=513360 $Y=769620
X2617 2320 2 2319 2254 1 NR2 $T=515220 770000 0 0 $X=515220 $Y=769620
X2618 2369 2 2357 2254 1 NR2 $T=520800 770000 1 180 $X=518940 $Y=769620
X2619 2378 2 2372 2386 1 NR2 $T=522660 739760 0 0 $X=522660 $Y=739380
X2620 2362 2 2209 331 1 NR2 $T=532580 759920 0 180 $X=530720 $Y=754500
X2621 2425 2 2419 2421 1 NR2 $T=535060 729680 1 180 $X=533200 $Y=729300
X2622 2424 2 2422 2431 1 NR2 $T=534440 729680 1 0 $X=534440 $Y=724260
X2623 2280 2 327 2430 1 NR2 $T=540020 790160 1 180 $X=538160 $Y=789780
X2624 2466 2 2479 2477 1 NR2 $T=545600 719600 0 0 $X=545600 $Y=719220
X2625 2474 2 2480 2492 1 NR2 $T=546840 709520 0 0 $X=546840 $Y=709140
X2626 2504 2 2516 2512 1 NR2 $T=551180 699440 0 0 $X=551180 $Y=699060
X2627 2497 2 2563 2548 1 NR2 $T=561720 699440 1 0 $X=561720 $Y=694020
X2628 2658 2 2824 2754 1 NR2 $T=618140 790160 0 0 $X=618140 $Y=789780
X2629 2699 2 2845 2812 1 NR2 $T=628680 780080 1 0 $X=628680 $Y=774660
X2630 2789 2 2919 2775 1 NR2 $T=636740 800240 0 0 $X=636740 $Y=799860
X2631 2877 2 2699 2921 1 NR2 $T=638600 780080 1 0 $X=638600 $Y=774660
X2632 444 2 459 2907 1 NR2 $T=642320 709520 1 0 $X=642320 $Y=704100
X2633 2877 2 2951 2956 1 NR2 $T=649140 729680 1 180 $X=647280 $Y=729300
X2634 2877 2 2970 2974 1 NR2 $T=648520 749840 0 0 $X=648520 $Y=749460
X2635 2877 2 2977 2983 1 NR2 $T=649140 759920 0 0 $X=649140 $Y=759540
X2636 2877 2 2979 2985 1 NR2 $T=650380 739760 0 0 $X=650380 $Y=739380
X2637 2987 2 2944 2921 1 NR2 $T=652240 780080 0 180 $X=650380 $Y=774660
X2638 2877 2 2989 3006 1 NR2 $T=653480 770000 1 0 $X=653480 $Y=764580
X2639 3018 2 3017 2993 1 NR2 $T=659060 810320 1 180 $X=657200 $Y=809940
X2640 2591 2 3030 494 1 NR2 $T=657200 820400 1 0 $X=657200 $Y=814980
X2641 2987 2 3027 2985 1 NR2 $T=660920 739760 1 180 $X=659060 $Y=739380
X2642 2987 2 3024 3044 1 NR2 $T=660920 770000 0 0 $X=660920 $Y=769620
X2643 2877 2 2946 3044 1 NR2 $T=660920 780080 1 0 $X=660920 $Y=774660
X2644 2987 2 3050 2974 1 NR2 $T=662160 739760 0 0 $X=662160 $Y=739380
X2645 2987 2 3016 3006 1 NR2 $T=662160 770000 1 0 $X=662160 $Y=764580
X2646 3055 2 3015 2921 1 NR2 $T=665260 770000 1 180 $X=663400 $Y=769620
X2647 2987 2 3045 2983 1 NR2 $T=664020 759920 1 0 $X=664020 $Y=754500
X2648 3080 2 3066 2921 1 NR2 $T=669600 770000 1 180 $X=667740 $Y=769620
X2649 3055 2 3070 2983 1 NR2 $T=670840 749840 0 180 $X=668980 $Y=744420
X2650 3055 2 3071 3044 1 NR2 $T=669600 759920 0 0 $X=669600 $Y=759540
X2651 3080 2 3109 3044 1 NR2 $T=670840 759920 1 0 $X=670840 $Y=754500
X2652 3080 2 3042 2983 1 NR2 $T=672700 729680 0 0 $X=672700 $Y=729300
X2653 3080 2 3099 3006 1 NR2 $T=672700 749840 1 0 $X=672700 $Y=744420
X2654 3055 2 3119 3006 1 NR2 $T=676420 759920 1 180 $X=674560 $Y=759540
X2655 3136 2 3122 3121 1 NR2 $T=678280 770000 0 180 $X=676420 $Y=764580
X2656 3055 2 3082 2974 1 NR2 $T=679520 739760 0 180 $X=677660 $Y=734340
X2657 3136 2 3149 453 1 NR2 $T=681380 719600 0 180 $X=679520 $Y=714180
X2658 3136 2 3131 2987 1 NR2 $T=679520 729680 0 0 $X=679520 $Y=729300
X2659 3136 2 3139 3145 1 NR2 $T=679520 739760 1 0 $X=679520 $Y=734340
X2660 3121 2 3142 3146 1 NR2 $T=679520 749840 1 0 $X=679520 $Y=744420
X2661 3116 2 3126 3146 1 NR2 $T=679520 770000 1 0 $X=679520 $Y=764580
X2662 3089 2 3144 3146 1 NR2 $T=679520 770000 0 0 $X=679520 $Y=769620
X2663 3089 2 3128 3135 1 NR2 $T=679520 780080 1 0 $X=679520 $Y=774660
X2664 3151 2 3168 3146 1 NR2 $T=681380 729680 0 0 $X=681380 $Y=729300
X2665 3121 2 3177 3135 1 NR2 $T=681380 749840 0 0 $X=681380 $Y=749460
X2666 3136 2 3170 3036 1 NR2 $T=684480 719600 0 180 $X=682620 $Y=714180
X2667 3145 2 3165 3146 1 NR2 $T=682620 749840 1 0 $X=682620 $Y=744420
X2668 3136 2 3147 3116 1 NR2 $T=682620 770000 1 0 $X=682620 $Y=764580
X2669 3153 2 3157 3148 1 NR2 $T=682620 830480 1 0 $X=682620 $Y=825060
X2670 3136 2 3189 3059 1 NR2 $T=684480 719600 0 0 $X=684480 $Y=719220
X2671 3136 2 3161 3151 1 NR2 $T=684480 729680 0 0 $X=684480 $Y=729300
X2672 3136 2 531 3089 1 NR2 $T=684480 770000 0 0 $X=684480 $Y=769620
X2673 3136 2 3169 3125 1 NR2 $T=687580 709520 0 180 $X=685720 $Y=704100
X2674 3036 2 3166 3146 1 NR2 $T=686340 719600 1 0 $X=686340 $Y=714180
X2675 3059 2 3207 3146 1 NR2 $T=690060 719600 1 180 $X=688200 $Y=719220
X2676 3116 2 3185 3135 1 NR2 $T=690060 770000 0 180 $X=688200 $Y=764580
X2677 3089 2 3205 3204 1 NR2 $T=688200 770000 0 0 $X=688200 $Y=769620
X2678 3151 2 3203 3204 1 NR2 $T=690060 729680 0 0 $X=690060 $Y=729300
X2679 501 2 539 3012 1 NR2 $T=693160 709520 0 180 $X=691300 $Y=704100
X2680 3059 2 3219 3135 1 NR2 $T=691300 719600 0 0 $X=691300 $Y=719220
X2681 3089 2 3209 3214 1 NR2 $T=691300 770000 1 0 $X=691300 $Y=764580
X2682 3151 2 3215 3135 1 NR2 $T=692540 729680 1 0 $X=692540 $Y=724260
X2683 3145 2 3220 3135 1 NR2 $T=695020 739760 1 180 $X=693160 $Y=739380
X2684 3237 2 3243 3089 1 NR2 $T=695020 770000 0 180 $X=693160 $Y=764580
X2685 3136 2 3226 3055 1 NR2 $T=695020 739760 1 0 $X=695020 $Y=734340
X2686 3116 2 3236 3204 1 NR2 $T=698120 759920 1 180 $X=696260 $Y=759540
X2687 3116 2 3251 3214 1 NR2 $T=698120 759920 1 0 $X=698120 $Y=754500
X2688 3136 2 3250 3080 1 NR2 $T=699360 739760 1 0 $X=699360 $Y=734340
X2689 3237 2 3256 3121 1 NR2 $T=699980 749840 0 0 $X=699980 $Y=749460
X2690 3145 2 3271 3204 1 NR2 $T=701840 739760 1 0 $X=701840 $Y=734340
X2691 3145 2 3268 3214 1 NR2 $T=701840 749840 1 0 $X=701840 $Y=744420
X2692 3121 2 3273 3204 1 NR2 $T=701840 749840 0 0 $X=701840 $Y=749460
X2693 3121 2 3267 3214 1 NR2 $T=701840 759920 0 0 $X=701840 $Y=759540
X2694 3237 2 3296 3116 1 NR2 $T=706800 770000 1 180 $X=704940 $Y=769620
X2695 3055 2 3324 2987 1 NR2 $T=718580 749840 1 0 $X=718580 $Y=744420
X2696 3222 2 3281 3248 1 NR2 $T=721060 820400 0 0 $X=721060 $Y=820020
X2697 666 2 3561 3753 1 NR2 $T=827700 709520 1 0 $X=827700 $Y=704100
X2698 4184 2 4179 4189 1 NR2 $T=944260 820400 0 0 $X=944260 $Y=820020
X2699 4188 2 4185 3924 1 NR2 $T=946740 830480 1 180 $X=944880 $Y=830100
X2700 4184 2 4194 3890 1 NR2 $T=946120 820400 0 0 $X=946120 $Y=820020
X2701 3890 2 4198 3879 1 NR2 $T=949220 820400 0 0 $X=949220 $Y=820020
X2702 4189 2 4200 3879 1 NR2 $T=951080 820400 0 0 $X=951080 $Y=820020
X2703 3927 2 4211 3924 1 NR2 $T=953560 820400 0 0 $X=953560 $Y=820020
X2704 4260 2 826 848 1 NR2 $T=975880 820400 0 0 $X=975880 $Y=820020
X2705 4260 2 3931 851 1 NR2 $T=976500 790160 0 0 $X=976500 $Y=789780
X2706 4257 2 4054 851 1 NR2 $T=976500 800240 1 0 $X=976500 $Y=794820
X2707 4257 2 3901 848 1 NR2 $T=978980 810320 0 180 $X=977120 $Y=804900
X2708 4257 2 4078 852 1 NR2 $T=979600 790160 1 0 $X=979600 $Y=784740
X2709 854 2 4158 4257 1 NR2 $T=983320 790160 0 180 $X=981460 $Y=784740
X2710 4260 2 3937 852 1 NR2 $T=982700 790160 0 0 $X=982700 $Y=789780
X2711 4260 2 4094 854 1 NR2 $T=984560 780080 1 0 $X=984560 $Y=774660
X2712 3424 3441 2 3419 1 3454 AOI12HS $T=753300 709520 1 180 $X=748960 $Y=709140
X2713 3531 594 2 690 1 693 AOI12HS $T=794840 860720 1 0 $X=794840 $Y=855300
X2714 3529 598 2 3786 1 3802 AOI12HS $T=840720 820400 0 0 $X=840720 $Y=820020
X2715 1145 1 1127 1141 2 1146 ND3 $T=261020 790160 1 0 $X=261020 $Y=784740
X2716 1176 1 1171 1160 2 1168 ND3 $T=267840 719600 1 180 $X=265360 $Y=719220
X2717 1426 1 1392 1408 2 1367 ND3 $T=317440 820400 1 180 $X=314960 $Y=820020
X2718 1426 1 1367 1405 2 1392 ND3 $T=318060 810320 0 0 $X=318060 $Y=809940
X2719 1531 1 129 1551 2 133 ND3 $T=342240 840560 0 0 $X=342240 $Y=840180
X2720 136 1 1556 1448 2 1576 ND3 $T=345340 850640 1 0 $X=345340 $Y=845220
X2721 1791 1 1790 1781 2 1782 ND3 $T=391840 739760 1 180 $X=389360 $Y=739380
X2722 1792 1 1806 1829 2 1796 ND3 $T=394940 759920 1 0 $X=394940 $Y=754500
X2723 1850 1 1835 1833 2 1846 ND3 $T=401760 709520 0 0 $X=401760 $Y=709140
X2724 2066 1 2082 2086 2 2041 ND3 $T=457560 840560 0 0 $X=457560 $Y=840180
X2725 2200 1 2198 2144 2 2194 ND3 $T=487320 719600 1 180 $X=484840 $Y=719220
X2726 2232 1 2207 2183 2 2217 ND3 $T=492900 709520 1 180 $X=490420 $Y=709140
X2727 2240 1 2238 317 2 2250 ND3 $T=495380 699440 0 0 $X=495380 $Y=699060
X2728 2273 1 2243 318 2 2247 ND3 $T=499720 709520 0 180 $X=497240 $Y=704100
X2729 2283 1 2255 2179 2 2274 ND3 $T=500340 729680 0 0 $X=500340 $Y=729300
X2730 2245 1 2268 2195 2 2276 ND3 $T=501580 759920 0 0 $X=501580 $Y=759540
X2731 2303 1 2294 2115 2 2286 ND3 $T=507780 729680 1 180 $X=505300 $Y=729300
X2732 2312 1 2317 2174 2 2327 ND3 $T=509020 739760 1 0 $X=509020 $Y=734340
X2733 2313 1 2258 312 2 2254 ND3 $T=510880 770000 0 0 $X=510880 $Y=769620
X2734 2313 1 2307 2336 2 2258 ND3 $T=512740 780080 1 0 $X=512740 $Y=774660
X2735 2372 1 2334 2366 2 2347 ND3 $T=521420 739760 1 180 $X=518940 $Y=739380
X2736 2405 1 2402 2351 2 2370 ND3 $T=530100 790160 1 180 $X=527620 $Y=789780
X2737 2320 1 2300 2414 2 309 ND3 $T=529480 810320 1 0 $X=529480 $Y=804900
X2738 2408 1 2345 2411 2 2380 ND3 $T=532580 749840 1 180 $X=530100 $Y=749460
X2739 2419 1 2388 2412 2 2389 ND3 $T=533200 729680 1 180 $X=530720 $Y=729300
X2740 2422 1 2395 2413 2 2374 ND3 $T=533820 729680 0 180 $X=531340 $Y=724260
X2741 371 1 2429 369 2 2460 ND3 $T=545600 699440 0 180 $X=543120 $Y=694020
X2742 2480 1 2418 373 2 2469 ND3 $T=548700 719600 0 180 $X=546220 $Y=714180
X2743 2479 1 2420 374 2 2484 ND3 $T=548080 729680 1 0 $X=548080 $Y=724260
X2744 2516 1 2517 378 2 2448 ND3 $T=553040 699440 0 0 $X=553040 $Y=699060
X2745 2563 1 2436 385 2 2450 ND3 $T=564200 699440 1 180 $X=561720 $Y=699060
X2746 2675 1 2652 2706 2 2702 ND3 $T=592100 770000 0 0 $X=592100 $Y=769620
X2747 2711 1 2694 2702 2 2683 ND3 $T=596440 780080 0 180 $X=593960 $Y=774660
X2748 2808 1 2862 2863 2 2754 ND3 $T=627440 800240 0 180 $X=624960 $Y=794820
X2749 2889 1 2867 2888 2 2838 ND3 $T=630540 800240 0 180 $X=628060 $Y=794820
X2750 2986 1 2590 3002 2 2982 ND3 $T=651620 810320 1 0 $X=651620 $Y=804900
X2751 2591 1 3005 2999 2 3013 ND3 $T=659680 810320 0 180 $X=657200 $Y=804900
X2752 3324 1 458 3237 2 3331 ND3 $T=718580 739760 1 0 $X=718580 $Y=734340
X2753 3424 1 624 3443 2 453 ND3 $T=758260 709520 1 180 $X=755780 $Y=709140
X2754 4182 1 4174 4138 2 4161 ND3 $T=943640 850640 1 180 $X=941160 $Y=850260
X2755 4263 1 4250 4231 2 4262 ND3 $T=975880 850640 0 180 $X=973400 $Y=845220
X2756 4314 1 4293 4166 2 4297 ND3 $T=996340 850640 0 180 $X=993860 $Y=845220
X2757 4337 1 4329 4245 2 4320 ND3 $T=1003160 860720 0 180 $X=1000680 $Y=855300
X2758 915 1 4516 4510 2 920 ND3 $T=1073840 870800 1 0 $X=1073840 $Y=865380
X2759 146 177 1 2 BUF2 $T=373240 790160 0 0 $X=373240 $Y=789780
X2760 538 487 3212 1 2 3247 487 3284 942 ICV_13 $T=688200 699440 1 0 $X=688200 $Y=694020
X2761 608 616 3432 1 2 625 617 3484 942 ICV_13 $T=740280 790160 1 0 $X=740280 $Y=784740
X2762 608 618 3457 1 2 625 618 3516 942 ICV_13 $T=744000 770000 0 0 $X=744000 $Y=769620
X2763 625 614 3493 1 2 579 636 3545 942 ICV_13 $T=752060 800240 0 0 $X=752060 $Y=799860
X2764 653 617 3567 1 2 653 616 3612 942 ICV_13 $T=768180 870800 1 0 $X=768180 $Y=865380
X2765 672 614 3618 1 2 672 616 3640 942 ICV_13 $T=781200 850640 1 0 $X=781200 $Y=845220
X2766 649 613 3614 1 2 649 614 3609 942 ICV_13 $T=783680 800240 0 0 $X=783680 $Y=799860
X2767 659 617 3630 1 2 659 616 3670 942 ICV_13 $T=784300 810320 0 0 $X=784300 $Y=809940
X2768 649 619 3624 1 2 677 616 3692 942 ICV_13 $T=788640 780080 0 0 $X=788640 $Y=779700
X2769 677 617 3678 1 2 681 613 3698 942 ICV_13 $T=797320 790160 0 0 $X=797320 $Y=789780
X2770 681 616 3703 1 2 681 618 3737 942 ICV_13 $T=804140 770000 0 0 $X=804140 $Y=769620
X2771 609 613 3724 1 2 672 613 3665 942 ICV_13 $T=809720 840560 0 0 $X=809720 $Y=840180
X2772 681 614 3705 1 2 659 614 3743 942 ICV_13 $T=814680 800240 0 0 $X=814680 $Y=799860
X2773 708 710 3751 1 2 716 710 3769 942 ICV_13 $T=819640 860720 0 0 $X=819640 $Y=860340
X2774 708 753 765 1 2 769 738 3893 942 ICV_13 $T=849400 870800 1 0 $X=849400 $Y=865380
X2775 758 3841 3876 1 2 774 3862 3902 942 ICV_13 $T=853120 770000 1 0 $X=853120 $Y=764580
X2776 769 753 3899 1 2 778 726 3940 942 ICV_13 $T=862420 860720 1 0 $X=862420 $Y=855300
X2777 770 3862 3906 1 2 770 3915 3946 942 ICV_13 $T=863660 749840 1 0 $X=863660 $Y=744420
X2778 750 4087 4107 1 2 774 4087 4112 942 ICV_13 $T=913880 780080 1 0 $X=913880 $Y=774660
X2779 758 4104 4153 1 2 770 4162 4186 942 ICV_13 $T=925040 759920 1 0 $X=925040 $Y=754500
X2780 775 4104 4178 1 2 775 4087 4203 942 ICV_13 $T=933100 729680 1 0 $X=933100 $Y=724260
X2781 775 4162 4187 1 2 770 4087 4216 942 ICV_13 $T=936200 739760 1 0 $X=936200 $Y=734340
X2782 860 4280 4303 1 2 860 4291 4325 942 ICV_13 $T=985800 770000 1 0 $X=985800 $Y=764580
X2783 868 4291 4328 1 2 860 4319 4370 942 ICV_13 $T=992620 759920 1 0 $X=992620 $Y=754500
X2784 300 328 1 2 INV4CK $T=509020 759920 0 180 $X=505300 $Y=754500
X2785 3295 3200 1 2 INV4CK $T=709280 830480 0 0 $X=709280 $Y=830100
X2786 3410 593 1 2 INV4CK $T=741520 850640 0 0 $X=741520 $Y=850260
X2787 3544 3364 1 2 INV4CK $T=771900 749840 0 0 $X=771900 $Y=749460
X2788 3532 616 1 2 INV4CK $T=788020 790160 0 180 $X=784300 $Y=784740
X2789 3604 3631 1 2 INV4CK $T=794840 770000 0 180 $X=791120 $Y=764580
X2790 3732 753 1 2 INV4CK $T=854980 860720 1 180 $X=851260 $Y=860340
X2791 3891 3862 1 2 INV4CK $T=868620 759920 0 0 $X=868620 $Y=759540
X2792 3875 726 1 2 INV4CK $T=872960 850640 0 0 $X=872960 $Y=850260
X2793 3976 3915 1 2 INV4CK $T=889080 759920 0 0 $X=889080 $Y=759540
X2794 3907 3841 1 2 INV4CK $T=902720 759920 0 0 $X=902720 $Y=759540
X2795 3984 3996 1 2 INV4CK $T=913880 770000 0 0 $X=913880 $Y=769620
X2796 4151 4038 1 2 INV4CK $T=934960 830480 0 180 $X=931240 $Y=825060
X2797 4133 4104 1 2 INV4CK $T=934960 759920 0 0 $X=934960 $Y=759540
X2798 4139 4087 1 2 INV4CK $T=956660 759920 1 0 $X=956660 $Y=754500
X2799 4195 4280 1 2 INV4CK $T=995720 770000 1 180 $X=992000 $Y=769620
X2800 4197 4319 1 2 INV4CK $T=1000680 759920 0 0 $X=1000680 $Y=759540
X2801 4228 4291 1 2 INV4CK $T=1005640 770000 0 0 $X=1005640 $Y=769620
X2802 4255 4369 1 2 INV4CK $T=1014320 759920 0 0 $X=1014320 $Y=759540
X2803 4207 4330 1 2 INV4CK $T=1031680 770000 0 180 $X=1027960 $Y=764580
X2804 4287 4417 1 2 INV4CK $T=1041600 759920 0 0 $X=1041600 $Y=759540
X2805 4301 4423 1 2 INV4CK $T=1041600 770000 0 0 $X=1041600 $Y=769620
X2806 2140 236 1 2 INV6CK $T=491660 780080 0 0 $X=491660 $Y=779700
X2807 522 487 1 2 INV6CK $T=677040 709520 0 0 $X=677040 $Y=709140
X2808 3466 618 1 2 INV6CK $T=772520 810320 0 180 $X=766940 $Y=804900
X2809 3599 614 1 2 INV6CK $T=786160 810320 0 180 $X=780580 $Y=804900
X2810 3379 3604 1 2 INV6CK $T=788020 780080 0 180 $X=782440 $Y=774660
X2811 3649 613 1 2 INV6CK $T=813440 810320 0 180 $X=807860 $Y=804900
X2812 3659 636 1 2 INV6CK $T=823360 790160 0 180 $X=817780 $Y=784740
X2813 3722 718 1 2 INV6CK $T=832660 860720 0 180 $X=827080 $Y=855300
X2814 3863 3875 1 2 INV6CK $T=859320 840560 0 0 $X=859320 $Y=840180
X2815 983 2 1 7 BUF1 $T=230020 749840 0 180 $X=227540 $Y=744420
X2816 159 2 1 1659 BUF1 $T=367040 850640 1 0 $X=367040 $Y=845220
X2817 105 2 1 1725 BUF1 $T=377580 860720 1 0 $X=377580 $Y=855300
X2818 127 2 1 1735 BUF1 $T=386260 790160 1 0 $X=386260 $Y=784740
X2819 138 2 1 1793 BUF1 $T=389980 800240 0 0 $X=389980 $Y=799860
X2820 144 2 1 1740 BUF1 $T=391840 780080 1 0 $X=391840 $Y=774660
X2821 27 2 1 2004 BUF1 $T=457560 810320 0 0 $X=457560 $Y=809940
X2822 2336 2 1 301 BUF1 $T=521420 759920 1 180 $X=518940 $Y=759540
X2823 2336 2 1 358 BUF1 $T=527620 759920 1 0 $X=527620 $Y=754500
X2824 453 2 1 2877 BUF1 $T=635500 739760 0 180 $X=633020 $Y=734340
X2825 3388 2 1 3398 BUF1 $T=734700 840560 1 0 $X=734700 $Y=835140
X2826 3413 2 1 3439 BUF1 $T=748960 840560 1 0 $X=748960 $Y=835140
X2827 3463 2 1 3468 BUF1 $T=755780 840560 0 0 $X=755780 $Y=840180
X2828 3510 2 1 3520 BUF1 $T=764460 860720 0 0 $X=764460 $Y=860340
X2829 3530 2 1 652 BUF1 $T=766320 860720 1 0 $X=766320 $Y=855300
X2830 3491 2 1 3535 BUF1 $T=767560 840560 0 0 $X=767560 $Y=840180
X2831 3422 2 1 659 BUF1 $T=770660 830480 1 0 $X=770660 $Y=825060
X2832 583 2 1 675 BUF1 $T=798560 719600 0 0 $X=798560 $Y=719220
X2833 706 2 1 708 BUF1 $T=818400 870800 1 0 $X=818400 $Y=865380
X2834 3560 2 1 716 BUF1 $T=825840 840560 1 0 $X=825840 $Y=835140
X2835 3386 2 1 754 BUF1 $T=841340 840560 0 0 $X=841340 $Y=840180
X2836 3505 2 1 750 BUF1 $T=845680 860720 1 0 $X=845680 $Y=855300
X2837 3552 2 1 759 BUF1 $T=851260 850640 1 0 $X=851260 $Y=845220
X2838 3376 2 1 760 BUF1 $T=854980 830480 1 0 $X=854980 $Y=825060
X2839 3478 2 1 763 BUF1 $T=854980 830480 0 0 $X=854980 $Y=830100
X2840 3356 2 1 758 BUF1 $T=854980 850640 1 0 $X=854980 $Y=845220
X2841 3384 2 1 770 BUF1 $T=863040 830480 1 0 $X=863040 $Y=825060
X2842 3361 2 1 775 BUF1 $T=866760 830480 1 0 $X=866760 $Y=825060
X2843 3446 2 1 776 BUF1 $T=868620 820400 0 0 $X=868620 $Y=820020
X2844 3871 2 1 3878 BUF1 $T=868620 850640 1 0 $X=868620 $Y=845220
X2845 3526 2 1 779 BUF1 $T=868620 850640 0 0 $X=868620 $Y=850260
X2846 3403 2 1 773 BUF1 $T=869860 830480 0 0 $X=869860 $Y=830100
X2847 3368 2 1 774 BUF1 $T=871100 850640 1 0 $X=871100 $Y=845220
X2848 3437 2 1 784 BUF1 $T=871720 830480 1 0 $X=871720 $Y=825060
X2849 3886 2 1 3872 BUF1 $T=871720 840560 1 0 $X=871720 $Y=835140
X2850 3854 2 1 3939 BUF1 $T=876060 840560 0 0 $X=876060 $Y=840180
X2851 3444 2 1 789 BUF1 $T=876680 830480 1 0 $X=876680 $Y=825060
X2852 3477 2 1 800 BUF1 $T=885980 830480 0 0 $X=885980 $Y=830100
X2853 3385 2 1 802 BUF1 $T=888460 830480 0 0 $X=888460 $Y=830100
X2854 3514 2 1 785 BUF1 $T=903340 840560 0 0 $X=903340 $Y=840180
X2855 4180 2 1 866 BUF1 $T=980840 699440 0 0 $X=980840 $Y=699060
X2856 864 2 1 860 BUF1 $T=988900 870800 1 0 $X=988900 $Y=865380
X2857 3541 2 1 868 BUF1 $T=1014320 850640 0 0 $X=1014320 $Y=850260
X2858 4296 2 1 901 BUF1 $T=1043460 850640 1 0 $X=1043460 $Y=845220
X2859 4437 2 1 902 BUF1 $T=1045320 820400 0 0 $X=1045320 $Y=820020
X2860 4428 2 1 904 BUF1 $T=1045320 840560 1 0 $X=1045320 $Y=835140
X2861 4458 2 1 898 BUF1 $T=1049040 840560 0 0 $X=1049040 $Y=840180
X2862 1068 1087 1 2 INV2CK $T=248620 729680 1 0 $X=248620 $Y=724260
X2863 2567 2574 1 2 INV2CK $T=567300 840560 0 180 $X=564820 $Y=835140
X2864 351 2617 1 2 INV2CK $T=574740 810320 0 0 $X=574740 $Y=809940
X2865 3252 578 1 2 INV2CK $T=714240 709520 0 0 $X=714240 $Y=709140
X2866 3321 3322 1 2 INV2CK $T=717340 759920 0 0 $X=717340 $Y=759540
X2867 3350 3295 1 2 INV2CK $T=740900 800240 0 0 $X=740900 $Y=799860
X2868 3354 3410 1 2 INV2CK $T=741520 840560 0 0 $X=741520 $Y=840180
X2869 3464 3466 1 2 INV2CK $T=757640 780080 0 180 $X=755160 $Y=774660
X2870 3511 3544 1 2 INV2CK $T=782440 759920 0 0 $X=782440 $Y=759540
X2871 3904 3907 1 2 INV2CK $T=873580 729680 0 0 $X=873580 $Y=729300
X2872 3953 3976 1 2 INV2CK $T=889080 739760 0 0 $X=889080 $Y=739380
X2873 3912 3984 1 2 INV2CK $T=889080 770000 0 0 $X=889080 $Y=769620
X2874 4047 3891 1 2 INV2CK $T=905200 800240 0 180 $X=902720 $Y=794820
X2875 4101 4103 1 2 INV2CK $T=921320 759920 0 0 $X=921320 $Y=759540
X2876 4129 4133 1 2 INV2CK $T=929380 749840 0 0 $X=929380 $Y=749460
X2877 4132 4139 1 2 INV2CK $T=930000 770000 0 0 $X=930000 $Y=769620
X2878 4167 4195 1 2 INV2CK $T=947980 780080 0 180 $X=945500 $Y=774660
X2879 4125 4151 1 2 INV2CK $T=948600 820400 0 180 $X=946120 $Y=814980
X2880 4192 4197 1 2 INV2CK $T=947360 739760 0 0 $X=947360 $Y=739380
X2881 4229 4228 1 2 INV2CK $T=964100 790160 0 180 $X=961620 $Y=784740
X2882 4283 4287 1 2 INV2CK $T=985800 759920 0 0 $X=985800 $Y=759540
X2883 4267 4301 1 2 INV2CK $T=996340 800240 0 180 $X=993860 $Y=794820
X2884 300 2234 1 2 2171 QDBHN $T=491660 770000 0 0 $X=491660 $Y=769620
X2885 300 2234 1 2 2224 QDBHN $T=493520 749840 0 0 $X=493520 $Y=749460
X2886 351 2384 1 2 2377 QDBHN $T=530720 800240 0 0 $X=530720 $Y=799860
X2887 300 2611 1 2 2592 QDBHN $T=577220 860720 0 180 $X=569780 $Y=855300
X2888 351 2656 1 2 2665 QDBHN $T=588380 800240 0 0 $X=588380 $Y=799860
X2889 490 488 1 2 481 QDBHN $T=656580 699440 0 180 $X=649140 $Y=694020
X2890 490 488 1 2 482 QDBHN $T=657820 709520 0 180 $X=650380 $Y=704100
X2891 490 488 1 2 3172 QDBHN $T=677040 699440 0 0 $X=677040 $Y=699060
X2892 525 541 1 2 3108 QDBHN $T=692540 729680 0 180 $X=685100 $Y=724260
X2893 490 562 1 2 3231 QDBHN $T=703080 699440 0 0 $X=703080 $Y=699060
X2894 490 2462 1 2 3393 QDBHN $T=729120 749840 0 0 $X=729120 $Y=749460
X2895 490 603 1 2 3406 QDBHN $T=729120 800240 0 0 $X=729120 $Y=799860
X2896 490 603 1 2 3397 QDBHN $T=729740 840560 0 0 $X=729740 $Y=840180
X2897 638 643 1 2 3519 QDBHN $T=758880 820400 0 0 $X=758880 $Y=820020
X2898 638 2462 1 2 3486 QDBHN $T=768180 749840 0 180 $X=760740 $Y=744420
X2899 638 648 1 2 3481 QDBHN $T=768800 790160 0 180 $X=761360 $Y=784740
X2900 638 676 1 2 3578 QDBHN $T=786780 800240 0 180 $X=779340 $Y=794820
X2901 638 682 1 2 3632 QDBHN $T=786780 840560 0 0 $X=786780 $Y=840180
X2902 638 692 1 2 3657 QDBHN $T=795460 820400 0 0 $X=795460 $Y=820020
X2903 525 396 1 2 3688 QDBHN $T=815920 719600 0 180 $X=808480 $Y=714180
X2904 638 701 1 2 3655 QDBHN $T=817160 780080 0 180 $X=809720 $Y=774660
X2905 638 701 1 2 3684 QDBHN $T=817160 860720 0 180 $X=809720 $Y=855300
X2906 638 692 1 2 3719 QDBHN $T=825220 840560 0 180 $X=817780 $Y=835140
X2907 638 728 1 2 3714 QDBHN $T=837000 810320 0 180 $X=829560 $Y=804900
X2908 638 643 1 2 733 QDBHN $T=843820 860720 0 180 $X=836380 $Y=855300
X2909 638 676 1 2 3745 QDBHN $T=844440 840560 0 180 $X=837000 $Y=835140
X2910 3597 749 1 2 3879 QDBHN $T=856220 810320 1 0 $X=856220 $Y=804900
X2911 638 648 1 2 777 QDBHN $T=858700 860720 0 0 $X=858700 $Y=860340
X2912 3597 748 1 2 3890 QDBHN $T=861180 820400 1 0 $X=861180 $Y=814980
X2913 638 728 1 2 3887 QDBHN $T=861180 820400 0 0 $X=861180 $Y=820020
X2914 638 682 1 2 3917 QDBHN $T=868620 840560 0 0 $X=868620 $Y=840180
X2915 3894 3901 1 2 3918 QDBHN $T=869860 739760 0 0 $X=869860 $Y=739380
X2916 3597 752 1 2 3924 QDBHN $T=869860 820400 1 0 $X=869860 $Y=814980
X2917 525 783 1 2 3856 QDBHN $T=871100 699440 0 0 $X=871100 $Y=699060
X2918 3597 751 1 2 3927 QDBHN $T=871100 820400 0 0 $X=871100 $Y=820020
X2919 3894 3931 1 2 3958 QDBHN $T=877920 759920 0 0 $X=877920 $Y=759540
X2920 3894 3937 1 2 3963 QDBHN $T=879160 749840 0 0 $X=879160 $Y=749460
X2921 3894 4054 1 2 4033 QDBHN $T=910160 780080 0 180 $X=902720 $Y=774660
X2922 3894 4078 1 2 4090 QDBHN $T=910160 739760 0 0 $X=910160 $Y=739380
X2923 3894 4094 1 2 4116 QDBHN $T=916360 780080 0 0 $X=916360 $Y=779700
X2924 3894 3901 1 2 4154 QDBHN $T=928140 790160 0 0 $X=928140 $Y=789780
X2925 3894 4158 1 2 4165 QDBHN $T=933100 729680 0 0 $X=933100 $Y=729300
X2926 3894 826 1 2 4115 QDBHN $T=941780 820400 0 180 $X=934340 $Y=814980
X2927 3894 4054 1 2 4196 QDBHN $T=954800 790160 0 180 $X=947360 $Y=784740
X2928 3894 3937 1 2 4222 QDBHN $T=952320 729680 0 0 $X=952320 $Y=729300
X2929 3894 4094 1 2 4243 QDBHN $T=974640 800240 0 180 $X=967200 $Y=794820
X2930 3894 3931 1 2 4265 QDBHN $T=984560 780080 0 180 $X=977120 $Y=774660
X2931 3894 4158 1 2 4275 QDBHN $T=990760 790160 0 180 $X=983320 $Y=784740
X2932 3894 4078 1 2 4294 QDBHN $T=987040 749840 0 0 $X=987040 $Y=749460
X2933 2171 1 2 2189 DELC $T=478640 770000 0 0 $X=478640 $Y=769620
X2934 2202 1 2 2206 DELC $T=486700 780080 0 0 $X=486700 $Y=779700
X2935 2224 1 2 2201 DELC $T=491040 759920 0 0 $X=491040 $Y=759540
X2936 2191 1 2 2350 DELC $T=511500 810320 1 0 $X=511500 $Y=804900
X2937 2377 1 2 2382 DELC $T=522660 790160 0 0 $X=522660 $Y=789780
X2938 2592 1 2 2577 DELC $T=569780 850640 0 0 $X=569780 $Y=850260
X2939 2634 1 2 2657 DELC $T=579700 840560 1 0 $X=579700 $Y=835140
X2940 2635 1 2 2664 DELC $T=580320 830480 1 0 $X=580320 $Y=825060
X2941 2645 1 2 399 DELC $T=581560 810320 0 0 $X=581560 $Y=809940
X2942 2646 1 2 403 DELC $T=584660 820400 0 0 $X=584660 $Y=820020
X2943 2665 1 2 2636 DELC $T=586520 810320 0 0 $X=586520 $Y=809940
X2944 2707 1 2 416 DELC $T=595820 810320 0 0 $X=595820 $Y=809940
X2945 2704 1 2 417 DELC $T=595820 830480 0 0 $X=595820 $Y=830100
X2946 2720 1 2 425 DELC $T=600780 810320 0 0 $X=600780 $Y=809940
X2947 2735 1 2 2754 DELC $T=603260 840560 1 0 $X=603260 $Y=835140
X2948 2731 1 2 428 DELC $T=603880 820400 0 0 $X=603880 $Y=820020
X2949 2710 1 2 2780 DELC $T=608840 810320 1 0 $X=608840 $Y=804900
X2950 2658 1 2 2808 DELC $T=613800 810320 1 0 $X=613800 $Y=804900
X2951 2800 1 2 2829 DELC $T=619380 790160 1 0 $X=619380 $Y=784740
X2952 2739 1 2 2867 DELC $T=623100 770000 1 0 $X=623100 $Y=764580
X2953 2823 1 2 2889 DELC $T=627440 790160 0 0 $X=627440 $Y=789780
X2954 2750 1 2 466 DELC $T=632400 739760 0 0 $X=632400 $Y=739380
X2955 2681 1 2 2862 DELC $T=632400 790160 0 0 $X=632400 $Y=789780
X2956 2820 1 2 2838 DELC $T=637360 830480 1 0 $X=637360 $Y=825060
X2957 2678 1 2 2955 DELC $T=642320 830480 1 0 $X=642320 $Y=825060
X2958 2612 1 2 2982 DELC $T=647280 830480 1 0 $X=647280 $Y=825060
X2959 2621 1 2 2986 DELC $T=652240 780080 1 0 $X=652240 $Y=774660
X2960 2591 1 2 3019 DELC $T=659680 790160 0 0 $X=659680 $Y=789780
X2961 498 1 2 503 DELC $T=660920 719600 1 0 $X=660920 $Y=714180
X2962 2590 1 2 3081 DELC $T=664640 790160 0 0 $X=664640 $Y=789780
X2963 3108 1 2 3138 DELC $T=674560 719600 1 0 $X=674560 $Y=714180
X2964 494 1 2 3013 DELC $T=678280 820400 0 0 $X=678280 $Y=820020
X2965 3172 1 2 3078 DELC $T=684480 699440 0 0 $X=684480 $Y=699060
X2966 2671 1 2 3005 DELC $T=686960 810320 1 0 $X=686960 $Y=804900
X2967 3231 1 2 3229 DELC $T=696260 719600 0 0 $X=696260 $Y=719220
X2968 557 1 2 556 DELC $T=700600 759920 1 0 $X=700600 $Y=754500
X2969 559 1 2 3247 DELC $T=701840 709520 0 0 $X=701840 $Y=709140
X2970 566 1 2 574 DELC $T=708660 759920 1 0 $X=708660 $Y=754500
X2971 568 1 2 3291 DELC $T=709280 729680 0 0 $X=709280 $Y=729300
X2972 577 1 2 585 DELC $T=714240 729680 0 0 $X=714240 $Y=729300
X2973 605 1 2 3353 DELC $T=734080 759920 0 0 $X=734080 $Y=759540
X2974 3393 1 2 3336 DELC $T=736560 749840 0 0 $X=736560 $Y=749460
X2975 3406 1 2 3337 DELC $T=743380 800240 0 0 $X=743380 $Y=799860
X2976 3397 1 2 3345 DELC $T=744000 840560 0 0 $X=744000 $Y=840180
X2977 3481 1 2 3475 DELC $T=758880 800240 1 0 $X=758880 $Y=794820
X2978 3513 1 2 3546 DELC $T=765700 709520 1 0 $X=765700 $Y=704100
X2979 3486 1 2 3487 DELC $T=766320 739760 1 0 $X=766320 $Y=734340
X2980 3519 1 2 3534 DELC $T=774380 820400 0 0 $X=774380 $Y=820020
X2981 3578 1 2 3556 DELC $T=786780 800240 1 0 $X=786780 $Y=794820
X2982 3622 1 2 669 DELC $T=792360 719600 0 0 $X=792360 $Y=719220
X2983 3632 1 2 3588 DELC $T=793600 830480 0 0 $X=793600 $Y=830100
X2984 3639 1 2 678 DELC $T=796080 729680 1 0 $X=796080 $Y=724260
X2985 3655 1 2 3676 DELC $T=802280 770000 1 0 $X=802280 $Y=764580
X2986 3657 1 2 3607 DELC $T=802900 820400 0 0 $X=802900 $Y=820020
X2987 3673 1 2 3695 DELC $T=806620 709520 1 0 $X=806620 $Y=704100
X2988 3684 1 2 3674 DELC $T=807240 870800 1 0 $X=807240 $Y=865380
X2989 3688 1 2 3668 DELC $T=815920 719600 1 0 $X=815920 $Y=714180
X2990 3666 1 2 3653 DELC $T=816540 699440 0 0 $X=816540 $Y=699060
X2991 3714 1 2 3726 DELC $T=816540 810320 1 0 $X=816540 $Y=804900
X2992 3719 1 2 3706 DELC $T=819020 850640 1 0 $X=819020 $Y=845220
X2993 3701 1 2 3712 DELC $T=821500 699440 0 0 $X=821500 $Y=699060
X2994 3744 1 2 3727 DELC $T=826460 709520 0 0 $X=826460 $Y=709140
X2995 3745 1 2 3749 DELC $T=828940 820400 0 0 $X=828940 $Y=820020
X2996 3856 1 2 3877 DELC $T=858700 699440 0 0 $X=858700 $Y=699060
X2997 3887 1 2 3868 DELC $T=866760 840560 1 0 $X=866760 $Y=835140
X2998 3917 1 2 3833 DELC $T=876680 850640 0 0 $X=876680 $Y=850260
X2999 3963 1 2 3897 DELC $T=889080 749840 0 0 $X=889080 $Y=749460
X3000 3918 1 2 3934 DELC $T=891560 739760 0 0 $X=891560 $Y=739380
X3001 3958 1 2 3898 DELC $T=892800 759920 0 0 $X=892800 $Y=759540
X3002 4033 1 2 4042 DELC $T=900240 780080 0 0 $X=900240 $Y=779700
X3003 4090 1 2 4100 DELC $T=919460 749840 0 0 $X=919460 $Y=749460
X3004 4115 1 2 4134 DELC $T=926280 830480 1 0 $X=926280 $Y=825060
X3005 4116 1 2 4121 DELC $T=931860 780080 0 0 $X=931860 $Y=779700
X3006 4165 1 2 4128 DELC $T=939920 739760 0 0 $X=939920 $Y=739380
X3007 4154 1 2 4181 DELC $T=940540 800240 1 0 $X=940540 $Y=794820
X3008 4196 1 2 4199 DELC $T=954800 790160 1 0 $X=954800 $Y=784740
X3009 4222 1 2 4183 DELC $T=960380 729680 1 0 $X=960380 $Y=724260
X3010 4265 1 2 4247 DELC $T=977120 770000 0 0 $X=977120 $Y=769620
X3011 4243 1 2 4274 DELC $T=982080 800240 0 0 $X=982080 $Y=799860
X3012 4275 1 2 4266 DELC $T=983320 780080 0 0 $X=983320 $Y=779700
X3013 4294 1 2 4289 DELC $T=993240 749840 1 0 $X=993240 $Y=744420
X3014 2137 1 2 2140 INV3CK $T=469960 770000 0 0 $X=469960 $Y=769620
X3015 2220 1 2 2288 INV3CK $T=506540 770000 0 180 $X=503440 $Y=764580
X3016 2574 1 2 383 INV3CK $T=584040 850640 0 180 $X=580940 $Y=845220
X3017 547 1 2 549 INV3CK $T=694400 699440 0 0 $X=694400 $Y=699060
X3018 3322 1 2 3314 INV3CK $T=734080 780080 1 180 $X=730980 $Y=779700
X3019 3523 1 2 3525 INV3CK $T=767560 830480 0 0 $X=767560 $Y=830100
X3020 3598 1 2 3649 INV3CK $T=799180 830480 0 0 $X=799180 $Y=830100
X3021 3623 1 2 3599 INV3CK $T=809720 830480 0 0 $X=809720 $Y=830100
X3022 4103 1 2 4162 INV3CK $T=943020 749840 0 0 $X=943020 $Y=749460
X3023 4193 1 2 4207 INV3CK $T=955420 810320 0 180 $X=952320 $Y=804900
X3024 4253 1 2 4255 INV3CK $T=970300 759920 1 0 $X=970300 $Y=754500
X3025 884 1 2 4381 INV3CK $T=1019900 850640 0 0 $X=1019900 $Y=850260
X3026 1027 1034 1015 1 2 AN2T $T=237460 759920 1 0 $X=237460 $Y=754500
X3027 1202 1195 1257 1 2 AN2T $T=277760 800240 1 0 $X=277760 $Y=794820
X3028 1319 1297 1353 1 2 AN2T $T=300700 860720 0 0 $X=300700 $Y=860340
X3029 1491 1463 1361 1 2 AN2T $T=332940 739760 1 0 $X=332940 $Y=734340
X3030 2189 300 2137 1 2 AN2T $T=487940 770000 1 180 $X=483600 $Y=769620
X3031 2201 300 2220 1 2 AN2T $T=486700 759920 0 0 $X=486700 $Y=759540
X3032 2577 300 2567 1 2 AN2T $T=567300 850640 0 180 $X=562960 $Y=845220
X3033 2636 2633 2599 1 2 AN2T $T=580320 800240 0 0 $X=580320 $Y=799860
X3034 496 490 499 1 2 AN2T $T=660300 699440 1 0 $X=660300 $Y=694020
X3035 3078 490 513 1 2 AN2T $T=668980 699440 0 0 $X=668980 $Y=699060
X3036 3229 490 3252 1 2 AN2T $T=696260 709520 0 0 $X=696260 $Y=709140
X3037 3475 490 3464 1 2 AN2T $T=758880 800240 0 180 $X=754540 $Y=794820
X3038 3487 638 3511 1 2 AN2T $T=760740 759920 0 0 $X=760740 $Y=759540
X3039 3534 638 3523 1 2 AN2T $T=770040 820400 0 0 $X=770040 $Y=820020
X3040 3556 638 3512 1 2 AN2T $T=775620 800240 0 180 $X=771280 $Y=794820
X3041 3588 638 3598 1 2 AN2T $T=781200 830480 0 0 $X=781200 $Y=830100
X3042 3607 638 3623 1 2 AN2T $T=787400 820400 0 0 $X=787400 $Y=820020
X3043 3676 638 3654 1 2 AN2T $T=806000 780080 0 180 $X=801660 $Y=774660
X3044 3674 638 3662 1 2 AN2T $T=807240 870800 0 180 $X=802900 $Y=865380
X3045 3706 638 3722 1 2 AN2T $T=814680 850640 1 0 $X=814680 $Y=845220
X3046 714 638 711 1 2 AN2T $T=825220 860720 0 180 $X=820880 $Y=855300
X3047 3726 638 3731 1 2 AN2T $T=825840 810320 0 180 $X=821500 $Y=804900
X3048 3749 638 3768 1 2 AN2T $T=828940 840560 1 0 $X=828940 $Y=835140
X3049 3833 638 3844 1 2 AN2T $T=853120 840560 0 0 $X=853120 $Y=840180
X3050 3868 638 3863 1 2 AN2T $T=861180 830480 0 0 $X=861180 $Y=830100
X3051 3897 3894 3904 1 2 AN2T $T=871100 749840 0 0 $X=871100 $Y=749460
X3052 3898 3894 3912 1 2 AN2T $T=871100 770000 0 0 $X=871100 $Y=769620
X3053 3934 3894 3953 1 2 AN2T $T=881020 739760 0 0 $X=881020 $Y=739380
X3054 4042 3894 4047 1 2 AN2T $T=902720 790160 1 0 $X=902720 $Y=784740
X3055 4100 3894 4101 1 2 AN2T $T=921320 739760 0 0 $X=921320 $Y=739380
X3056 4121 3894 4132 1 2 AN2T $T=927520 780080 0 0 $X=927520 $Y=779700
X3057 4128 3894 4129 1 2 AN2T $T=929380 739760 0 0 $X=929380 $Y=739380
X3058 4181 3894 4167 1 2 AN2T $T=943640 790160 1 180 $X=939300 $Y=789780
X3059 4183 3894 4192 1 2 AN2T $T=944260 729680 0 0 $X=944260 $Y=729300
X3060 4199 3894 4193 1 2 AN2T $T=949840 800240 0 180 $X=945500 $Y=794820
X3061 4247 3894 4229 1 2 AN2T $T=969060 780080 1 0 $X=969060 $Y=774660
X3062 4266 3894 4253 1 2 AN2T $T=979600 790160 0 180 $X=975260 $Y=784740
X3063 4274 3894 4267 1 2 AN2T $T=982700 800240 0 180 $X=978360 $Y=794820
X3064 4289 3894 4283 1 2 AN2T $T=987040 739760 0 0 $X=987040 $Y=739380
X3065 2288 323 1 2 INV8CK $T=524520 770000 0 0 $X=524520 $Y=769620
X3066 3379 490 1 2 INV8CK $T=730980 770000 0 0 $X=730980 $Y=769620
X3067 3512 3532 1 2 INV8CK $T=766320 770000 0 0 $X=766320 $Y=769620
X3068 3631 525 1 2 INV8CK $T=797320 780080 0 180 $X=790500 $Y=774660
X3069 3525 619 1 2 INV8CK $T=804760 840560 1 180 $X=797940 $Y=840180
X3070 3654 3659 1 2 INV8CK $T=808480 790160 0 180 $X=801660 $Y=784740
X3071 3731 3661 1 2 INV8CK $T=822120 800240 0 180 $X=815300 $Y=794820
X3072 3662 3732 1 2 INV8CK $T=827700 870800 0 180 $X=820880 $Y=865380
X3073 3768 3773 1 2 INV8CK $T=832660 850640 1 0 $X=832660 $Y=845220
X3074 3844 764 1 2 INV8CK $T=856220 850640 0 0 $X=856220 $Y=850260
X3075 3379 3894 1 2 INV8CK $T=874820 780080 0 0 $X=874820 $Y=779700
X3076 3450 630 629 3430 3382 626 1 2 3435 AO222 $T=756400 790160 1 180 $X=750200 $Y=789780
X3077 3470 630 629 3472 3493 626 1 2 3501 AO222 $T=758260 790160 0 0 $X=758260 $Y=789780
X3078 3506 630 629 3528 3498 626 1 2 3547 AO222 $T=766320 810320 0 0 $X=766320 $Y=809940
X3079 3562 630 629 3540 3542 626 1 2 3537 AO222 $T=776860 830480 1 180 $X=770660 $Y=830100
X3080 3624 630 629 3614 3609 626 1 2 3557 AO222 $T=792360 790160 1 180 $X=786160 $Y=789780
X3081 3642 630 629 695 3650 626 1 2 3658 AO222 $T=796700 870800 1 0 $X=796700 $Y=865380
X3082 3628 630 629 3665 3618 626 1 2 3685 AO222 $T=802280 850640 1 0 $X=802280 $Y=845220
X3083 3691 630 629 3698 3705 626 1 2 3711 AO222 $T=809100 800240 1 0 $X=809100 $Y=794820
X3084 3740 630 629 3724 3729 626 1 2 3713 AO222 $T=825840 830480 0 180 $X=819640 $Y=825060
X3085 3800 630 629 3746 3743 626 1 2 3721 AO222 $T=830800 810320 1 180 $X=824600 $Y=809940
X3086 3791 630 629 3783 3779 626 1 2 3763 AO222 $T=839480 790160 1 180 $X=833280 $Y=789780
X3087 4051 630 629 4032 4029 626 1 2 4004 AO222 $T=903340 850640 1 180 $X=897140 $Y=850260
X3088 4049 630 629 4037 4014 626 1 2 3981 AO222 $T=904580 860720 1 180 $X=898380 $Y=860340
X3089 4135 4126 4123 4081 4112 4110 1 2 4097 AO222 $T=930620 770000 0 180 $X=924420 $Y=764580
X3090 4155 4126 4123 4146 4140 4110 1 2 4024 AO222 $T=935580 810320 0 180 $X=929380 $Y=804900
X3091 4144 4126 4123 4142 4130 4110 1 2 4046 AO222 $T=937440 719600 0 180 $X=931240 $Y=714180
X3092 4163 4126 4123 4160 4117 4110 1 2 4071 AO222 $T=939300 800240 0 180 $X=933100 $Y=794820
X3093 4170 4126 4123 4150 4143 4110 1 2 4045 AO222 $T=941780 810320 0 180 $X=935580 $Y=804900
X3094 4191 4126 4123 4159 4107 4110 1 2 4055 AO222 $T=944880 790160 0 180 $X=938680 $Y=784740
X3095 4190 4126 4123 4175 4168 4110 1 2 4028 AO222 $T=946120 719600 1 180 $X=939920 $Y=719220
X3096 4215 4126 4123 4153 4176 4110 1 2 3950 AO222 $T=947360 770000 0 180 $X=941160 $Y=764580
X3097 4206 4126 4123 4205 4218 4110 1 2 4034 AO222 $T=953560 770000 0 0 $X=953560 $Y=769620
X3098 4187 4126 4123 4178 4203 4110 1 2 4023 AO222 $T=954180 729680 1 0 $X=954180 $Y=724260
X3099 4186 4126 4123 4208 4216 4110 1 2 4008 AO222 $T=961000 749840 0 180 $X=954800 $Y=744420
X3100 4226 4126 4123 4219 4202 4110 1 2 4000 AO222 $T=961000 790160 1 180 $X=954800 $Y=789780
X3101 4209 4126 4123 4221 4217 4110 1 2 4120 AO222 $T=961620 810320 0 180 $X=955420 $Y=804900
X3102 4246 4126 4123 4232 4230 4110 1 2 4131 AO222 $T=968440 719600 1 180 $X=962240 $Y=719220
X3103 4251 4126 4123 4238 4233 4110 1 2 4173 AO222 $T=969680 739760 1 180 $X=963480 $Y=739380
X3104 4224 4126 4123 4239 4234 4110 1 2 4102 AO222 $T=969680 749840 1 180 $X=963480 $Y=749460
X3105 4254 4126 4123 4249 4244 4110 1 2 4064 AO222 $T=972780 719600 0 180 $X=966580 $Y=714180
X3106 4401 4126 4123 4396 4393 4110 1 2 4321 AO222 $T=1029820 719600 0 180 $X=1023620 $Y=714180
X3107 4409 4126 4123 4389 4395 4110 1 2 4346 AO222 $T=1029820 749840 0 180 $X=1023620 $Y=744420
X3108 4414 4126 4123 4392 4397 4110 1 2 4390 AO222 $T=1031060 729680 1 180 $X=1024860 $Y=729300
X3109 4403 4126 4123 4399 4400 4110 1 2 4333 AO222 $T=1031680 800240 1 180 $X=1025480 $Y=799860
X3110 4421 4126 4123 4406 4412 4110 1 2 4379 AO222 $T=1034780 759920 0 180 $X=1028580 $Y=754500
X3111 4422 4126 4123 4398 4407 4110 1 2 4307 AO222 $T=1034780 790160 0 180 $X=1028580 $Y=784740
X3112 4391 4126 4123 4404 4402 4110 1 2 4374 AO222 $T=1035400 820400 0 180 $X=1029200 $Y=814980
X3113 4427 4126 4123 4418 4424 4110 1 2 4386 AO222 $T=1042220 810320 1 180 $X=1036020 $Y=809940
X3114 4432 4126 4123 4425 4419 4110 1 2 4383 AO222 $T=1044080 770000 0 180 $X=1037880 $Y=764580
X3115 4531 4126 4123 4514 4512 4110 1 2 4438 AO222 $T=1077560 739760 1 180 $X=1071360 $Y=739380
X3116 4532 4126 4123 4520 4515 4110 1 2 4464 AO222 $T=1078800 759920 1 180 $X=1072600 $Y=759540
X3117 4540 4126 4123 4524 4517 4110 1 2 4434 AO222 $T=1079420 729680 1 180 $X=1073220 $Y=729300
X3118 4541 4126 4123 4525 4518 4110 1 2 4474 AO222 $T=1079420 780080 0 180 $X=1073220 $Y=774660
X3119 4529 4126 4123 4526 4519 4110 1 2 4500 AO222 $T=1079420 820400 0 180 $X=1073220 $Y=814980
X3120 4539 4126 4123 4511 4521 4110 1 2 4462 AO222 $T=1080040 790160 1 180 $X=1073840 $Y=789780
X3121 4536 4126 4123 4528 4513 4110 1 2 4469 AO222 $T=1081280 810320 0 180 $X=1075080 $Y=804900
X3122 4527 4126 4123 4537 4538 4110 1 2 4463 AO222 $T=1079420 709520 0 0 $X=1079420 $Y=709140
X3123 2382 351 2210 1 2 AN2P $T=523280 800240 0 0 $X=523280 $Y=799860
X3124 2430 2310 263 1 2 AN2P $T=536300 790160 1 180 $X=532580 $Y=789780
X3125 3138 525 495 1 2 AN2P $T=681380 729680 0 180 $X=677660 $Y=724260
X3126 3668 525 691 1 2 AN2P $T=804760 719600 0 180 $X=801040 $Y=714180
X3127 3877 525 746 1 2 AN2P $T=863660 699440 0 0 $X=863660 $Y=699060
X3128 4179 4188 833 1 2 AN2P $T=944260 850640 0 0 $X=944260 $Y=850260
X3129 4198 3927 830 1 2 AN2P $T=949220 850640 0 180 $X=945500 $Y=845220
X3130 3927 4179 825 1 2 AN2P $T=946120 860720 1 0 $X=946120 $Y=855300
X3131 4194 3927 828 1 2 AN2P $T=947980 850640 0 0 $X=947980 $Y=850260
X3132 4185 4200 3986 1 2 AN2P $T=952320 830480 0 180 $X=948600 $Y=825060
X3133 4198 4188 838 1 2 AN2P $T=951700 850640 1 0 $X=951700 $Y=845220
X3134 4194 4188 841 1 2 AN2P $T=957280 850640 0 0 $X=957280 $Y=850260
X3135 4211 4179 3895 1 2 AN2P $T=959760 810320 0 0 $X=959760 $Y=809940
X3136 1224 1194 1097 2 1 ND2S $T=277760 810320 0 0 $X=277760 $Y=809940
X3137 1522 1509 1490 2 1 ND2S $T=339140 719600 0 180 $X=337280 $Y=714180
X3138 1552 1529 93 2 1 ND2S $T=339140 739760 0 0 $X=339140 $Y=739380
X3139 1654 1658 136 2 1 ND2S $T=363940 850640 0 0 $X=363940 $Y=850260
X3140 1594 1667 105 2 1 ND2S $T=365800 850640 0 0 $X=365800 $Y=850260
X3141 1746 1791 1803 2 1 ND2S $T=394940 739760 0 0 $X=394940 $Y=739380
X3142 2031 2002 2035 2 1 ND2S $T=446400 850640 0 0 $X=446400 $Y=850260
X3143 2057 2066 270 2 1 ND2S $T=454460 840560 1 180 $X=452600 $Y=840180
X3144 2310 2304 2290 2 1 ND2S $T=509640 790160 1 0 $X=509640 $Y=784740
X3145 2279 2417 2336 2 1 ND2S $T=531960 810320 1 0 $X=531960 $Y=804900
X3146 3772 848 3788 2 1 ND2S $T=978980 830480 1 180 $X=977120 $Y=830100
X3147 4279 852 3772 2 1 ND2S $T=984560 830480 0 0 $X=984560 $Y=830100
X3148 296 2 1 377 BUF3 $T=556760 860720 1 180 $X=553040 $Y=860340
X3149 2821 2 1 2839 BUF3 $T=619380 810320 0 0 $X=619380 $Y=809940
X3150 472 2 1 2947 BUF3 $T=642320 850640 0 0 $X=642320 $Y=850260
X3151 2280 1 2300 2258 2202 2270 2 OAI22S $T=509020 780080 1 180 $X=505300 $Y=779700
X3152 3347 1 591 3261 3356 598 2 OAI22S $T=723540 850640 1 0 $X=723540 $Y=845220
X3153 597 1 3338 594 3301 3332 2 OAI22S $T=727880 820400 1 180 $X=724160 $Y=820020
X3154 3338 1 591 3332 3361 598 2 OAI22S $T=724160 830480 1 0 $X=724160 $Y=825060
X3155 597 1 3352 594 592 3348 2 OAI22S $T=727880 830480 1 180 $X=724160 $Y=830100
X3156 597 1 3347 594 595 3261 2 OAI22S $T=729120 850640 1 180 $X=725400 $Y=850260
X3157 3358 1 591 3365 3368 598 2 OAI22S $T=726020 840560 0 0 $X=726020 $Y=840180
X3158 597 1 3367 594 601 3377 2 OAI22S $T=727260 840560 1 0 $X=727260 $Y=835140
X3159 597 1 3358 594 602 3365 2 OAI22S $T=727260 850640 1 0 $X=727260 $Y=845220
X3160 597 1 3375 594 3381 3334 2 OAI22S $T=729120 820400 1 0 $X=729120 $Y=814980
X3161 3383 1 591 3380 3376 598 2 OAI22S $T=733460 830480 0 180 $X=729740 $Y=825060
X3162 3375 1 591 3334 3384 598 2 OAI22S $T=730360 820400 0 0 $X=730360 $Y=820020
X3163 3352 1 591 3348 3385 598 2 OAI22S $T=730360 830480 0 0 $X=730360 $Y=830100
X3164 3367 1 591 3377 3386 598 2 OAI22S $T=730980 840560 1 0 $X=730980 $Y=835140
X3165 597 1 3383 594 3388 3380 2 OAI22S $T=737800 830480 1 180 $X=734080 $Y=830100
X3166 3407 1 591 3405 3403 598 2 OAI22S $T=741520 830480 1 180 $X=737800 $Y=830100
X3167 597 1 3395 594 3408 3344 2 OAI22S $T=738420 830480 1 0 $X=738420 $Y=825060
X3168 597 1 3407 594 3413 3405 2 OAI22S $T=745240 830480 1 180 $X=741520 $Y=830100
X3169 597 1 3409 594 3417 3392 2 OAI22S $T=742760 820400 0 0 $X=742760 $Y=820020
X3170 597 1 3411 594 3421 3426 2 OAI22S $T=745240 830480 0 0 $X=745240 $Y=830100
X3171 3411 1 591 3402 3437 598 2 OAI22S $T=748960 830480 0 0 $X=748960 $Y=830100
X3172 3395 1 591 3344 3444 598 2 OAI22S $T=749580 820400 1 0 $X=749580 $Y=814980
X3173 3409 1 591 3392 3446 598 2 OAI22S $T=750200 820400 0 0 $X=750200 $Y=820020
X3174 597 1 3455 594 3462 3445 2 OAI22S $T=752680 830480 0 0 $X=752680 $Y=830100
X3175 597 1 3456 594 3463 3452 2 OAI22S $T=752680 840560 1 0 $X=752680 $Y=835140
X3176 597 1 3458 594 637 3479 2 OAI22S $T=755780 870800 1 0 $X=755780 $Y=865380
X3177 3455 1 591 3445 3477 598 2 OAI22S $T=756400 830480 1 0 $X=756400 $Y=825060
X3178 3456 1 591 3452 3478 598 2 OAI22S $T=756400 840560 1 0 $X=756400 $Y=835140
X3179 597 1 3438 594 3491 3460 2 OAI22S $T=758880 840560 0 0 $X=758880 $Y=840180
X3180 597 1 642 594 644 632 2 OAI22S $T=759500 870800 1 0 $X=759500 $Y=865380
X3181 3458 1 591 3479 3505 598 2 OAI22S $T=761360 860720 1 0 $X=761360 $Y=855300
X3182 3438 1 591 3460 3514 598 2 OAI22S $T=763220 840560 0 0 $X=763220 $Y=840180
X3183 597 1 3476 594 3510 3507 2 OAI22S $T=768180 850640 1 180 $X=764460 $Y=850260
X3184 3476 1 591 3507 3526 598 2 OAI22S $T=765700 850640 1 0 $X=765700 $Y=845220
X3185 597 1 3522 594 3530 3504 2 OAI22S $T=771900 850640 1 180 $X=768180 $Y=850260
X3186 3548 1 591 3418 3541 598 2 OAI22S $T=773760 860720 0 180 $X=770040 $Y=855300
X3187 3522 1 591 3504 3552 598 2 OAI22S $T=771900 850640 0 0 $X=771900 $Y=850260
X3188 597 1 3548 594 3560 3418 2 OAI22S $T=778720 860720 0 180 $X=775000 $Y=855300
X3189 597 1 453 594 704 453 2 OAI22S $T=818400 850640 1 180 $X=814680 $Y=850260
X3190 597 1 3080 594 690 3080 2 OAI22S $T=819640 860720 1 180 $X=815920 $Y=860340
X3191 597 1 2987 594 707 2987 2 OAI22S $T=817160 860720 1 0 $X=817160 $Y=855300
X3192 597 1 3055 594 715 3055 2 OAI22S $T=825220 850640 1 0 $X=825220 $Y=845220
X3193 591 1 2987 598 3772 2987 2 OAI22S $T=836380 830480 1 180 $X=832660 $Y=830100
X3194 591 1 3080 598 3786 3080 2 OAI22S $T=840720 820400 1 180 $X=837000 $Y=820020
X3195 591 1 3055 598 3788 3055 2 OAI22S $T=841340 830480 1 180 $X=837620 $Y=830100
X3196 591 1 453 598 3831 453 2 OAI22S $T=856220 820400 1 180 $X=852500 $Y=820020
X3197 3817 1 591 3839 3842 598 2 OAI22S $T=852500 850640 0 0 $X=852500 $Y=850260
X3198 597 1 3845 594 3854 3857 2 OAI22S $T=856220 820400 0 0 $X=856220 $Y=820020
X3199 3852 1 591 3838 3860 598 2 OAI22S $T=857460 830480 0 0 $X=857460 $Y=830100
X3200 3848 1 591 3785 3855 598 2 OAI22S $T=861180 840560 0 180 $X=857460 $Y=835140
X3201 597 1 3835 594 768 3858 2 OAI22S $T=857460 850640 1 0 $X=857460 $Y=845220
X3202 597 1 3817 594 771 3839 2 OAI22S $T=858700 860720 1 0 $X=858700 $Y=855300
X3203 3845 1 591 3857 3870 598 2 OAI22S $T=859320 830480 1 0 $X=859320 $Y=825060
X3204 597 1 3848 594 3871 3785 2 OAI22S $T=864900 850640 0 180 $X=861180 $Y=845220
X3205 3835 1 591 3858 3883 598 2 OAI22S $T=868620 850640 0 180 $X=864900 $Y=845220
X3206 597 1 3852 594 3886 3838 2 OAI22S $T=869240 830480 1 180 $X=865520 $Y=830100
X3207 1109 1 2 1085 DELB $T=254200 860720 1 0 $X=254200 $Y=855300
X3208 242 1 2 255 DELB $T=435240 699440 1 0 $X=435240 $Y=694020
X3209 241 1 2 257 DELB $T=435240 709520 1 0 $X=435240 $Y=704100
X3210 256 1 2 1995 DELB $T=443920 699440 0 0 $X=443920 $Y=699060
X3211 2185 1 2 2199 DELB $T=481740 759920 0 0 $X=481740 $Y=759540
X3212 2204 1 2 2158 DELB $T=488560 870800 1 0 $X=488560 $Y=865380
X3213 2226 1 2 2229 DELB $T=491660 790160 0 0 $X=491660 $Y=789780
X3214 2260 1 2 2270 DELB $T=500340 780080 0 0 $X=500340 $Y=779700
X3215 2304 1 2 2285 DELB $T=507780 780080 1 0 $X=507780 $Y=774660
X3216 2221 1 2 2352 DELB $T=511500 820400 1 0 $X=511500 $Y=814980
X3217 2213 1 2 2393 DELB $T=520800 820400 1 0 $X=520800 $Y=814980
X3218 2400 1 2 2432 DELB $T=528860 830480 0 0 $X=528860 $Y=830100
X3219 2397 1 2 2384 DELB $T=535060 780080 0 0 $X=535060 $Y=779700
X3220 2468 1 2 2490 DELB $T=544360 840560 1 0 $X=544360 $Y=835140
X3221 2297 1 2 2508 DELB $T=546840 739760 1 0 $X=546840 $Y=734340
X3222 2488 1 2 2523 DELB $T=548080 860720 0 0 $X=548080 $Y=860340
X3223 2503 1 2 2525 DELB $T=550560 830480 0 0 $X=550560 $Y=830100
X3224 2533 1 2 2568 DELB $T=556760 860720 0 0 $X=556760 $Y=860340
X3225 2539 1 2 2557 DELB $T=558000 850640 1 0 $X=558000 $Y=845220
X3226 2531 1 2 2589 DELB $T=560480 830480 1 0 $X=560480 $Y=825060
X3227 2552 1 2 2572 DELB $T=561100 810320 1 0 $X=561100 $Y=804900
X3228 2555 1 2 2582 DELB $T=563580 780080 1 0 $X=563580 $Y=774660
X3229 2576 1 2 2616 DELB $T=567300 850640 1 0 $X=567300 $Y=845220
X3230 2583 1 2 2596 DELB $T=569780 810320 0 0 $X=569780 $Y=809940
X3231 2602 1 2 2622 DELB $T=571020 729680 0 0 $X=571020 $Y=729300
X3232 2626 1 2 401 DELB $T=579080 860720 0 0 $X=579080 $Y=860340
X3233 2580 1 2 2651 DELB $T=580940 770000 0 0 $X=580940 $Y=769620
X3234 2674 1 2 406 DELB $T=589000 840560 1 0 $X=589000 $Y=835140
X3235 407 1 2 2716 DELB $T=594580 840560 1 0 $X=594580 $Y=835140
X3236 2697 1 2 414 DELB $T=596440 860720 1 0 $X=596440 $Y=855300
X3237 1926 1 2 2714 DELB $T=598300 780080 0 0 $X=598300 $Y=779700
X3238 2732 1 2 2339 DELB $T=603880 729680 0 0 $X=603880 $Y=729300
X3239 2749 1 2 338 DELB $T=606980 709520 1 0 $X=606980 $Y=704100
X3240 2753 1 2 2771 DELB $T=607600 770000 0 0 $X=607600 $Y=769620
X3241 2782 1 2 2813 DELB $T=613800 749840 1 0 $X=613800 $Y=744420
X3242 2784 1 2 2807 DELB $T=613800 780080 0 0 $X=613800 $Y=779700
X3243 439 1 2 441 DELB $T=615040 870800 1 0 $X=615040 $Y=865380
X3244 2817 1 2 2809 DELB $T=618760 840560 1 0 $X=618760 $Y=835140
X3245 2846 1 2 2287 DELB $T=624960 739760 1 0 $X=624960 $Y=734340
X3246 2869 1 2 2766 DELB $T=628060 699440 0 0 $X=628060 $Y=699060
X3247 2855 1 2 2910 DELB $T=632400 770000 1 0 $X=632400 $Y=764580
X3248 2900 1 2 2896 DELB $T=634260 820400 0 0 $X=634260 $Y=820020
X3249 2906 1 2 2923 DELB $T=636120 719600 0 0 $X=636120 $Y=719220
X3250 2859 1 2 2926 DELB $T=637360 699440 0 0 $X=637360 $Y=699060
X3251 2892 1 2 2876 DELB $T=637360 790160 0 0 $X=637360 $Y=789780
X3252 2741 1 2 2954 DELB $T=641700 759920 0 0 $X=641700 $Y=759540
X3253 2832 1 2 2964 DELB $T=643560 749840 0 0 $X=643560 $Y=749460
X3254 2935 1 2 2937 DELB $T=644180 800240 1 0 $X=644180 $Y=794820
X3255 2967 1 2 2994 DELB $T=648520 719600 1 0 $X=648520 $Y=714180
X3256 2968 1 2 2960 DELB $T=648520 790160 0 0 $X=648520 $Y=789780
X3257 2827 1 2 3007 DELB $T=651620 749840 0 0 $X=651620 $Y=749460
X3258 2887 1 2 3020 DELB $T=652240 739760 0 0 $X=652240 $Y=739380
X3259 2972 1 2 469 DELB $T=652860 840560 0 0 $X=652860 $Y=840180
X3260 2995 1 2 3032 DELB $T=653480 729680 1 0 $X=653480 $Y=724260
X3261 3003 1 2 3018 DELB $T=654720 790160 0 0 $X=654720 $Y=789780
X3262 2873 1 2 3060 DELB $T=661540 749840 0 0 $X=661540 $Y=749460
X3263 472 1 2 3065 DELB $T=662160 840560 0 0 $X=662160 $Y=840180
X3264 3052 1 2 3076 DELB $T=664020 820400 1 0 $X=664020 $Y=814980
X3265 3009 1 2 3068 DELB $T=665880 719600 1 0 $X=665880 $Y=714180
X3266 3046 1 2 3124 DELB $T=667740 850640 0 0 $X=667740 $Y=850260
X3267 3075 1 2 3086 DELB $T=673320 820400 0 0 $X=673320 $Y=820020
X3268 3107 1 2 3133 DELB $T=673940 739760 0 0 $X=673940 $Y=739380
X3269 2819 1 2 3171 DELB $T=679520 790160 0 0 $X=679520 $Y=789780
X3270 3162 1 2 3153 DELB $T=684480 830480 1 0 $X=684480 $Y=825060
X3271 2797 1 2 3216 DELB $T=685100 790160 1 0 $X=685100 $Y=784740
X3272 3033 1 2 3057 DELB $T=691300 830480 0 0 $X=691300 $Y=830100
X3273 558 1 2 3235 DELB $T=701220 719600 0 0 $X=701220 $Y=719220
X3274 3304 1 2 3326 DELB $T=714240 850640 0 0 $X=714240 $Y=850260
X3275 596 1 2 3349 DELB $T=726020 860720 1 0 $X=726020 $Y=855300
X3276 2804 1 2 3363 DELB $T=727880 729680 1 0 $X=727880 $Y=724260
X3277 3346 1 2 3365 DELB $T=730980 850640 1 0 $X=730980 $Y=845220
X3278 2836 1 2 3415 DELB $T=744000 709520 0 0 $X=744000 $Y=709140
X3279 3419 1 2 3416 DELB $T=745860 709520 1 0 $X=745860 $Y=704100
X3280 3439 1 2 625 DELB $T=750820 830480 1 0 $X=750820 $Y=825060
X3281 2843 1 2 3447 DELB $T=752680 729680 1 0 $X=752680 $Y=724260
X3282 3467 1 2 3469 DELB $T=757020 709520 1 0 $X=757020 $Y=704100
X3283 3468 1 2 641 DELB $T=757640 830480 0 0 $X=757640 $Y=830100
X3284 3535 1 2 672 DELB $T=776860 840560 0 0 $X=776860 $Y=840180
X3285 3872 1 2 778 DELB $T=861800 840560 1 0 $X=861800 $Y=835140
X3286 3878 1 2 769 DELB $T=863660 850640 0 0 $X=863660 $Y=850260
X3287 3939 1 2 780 DELB $T=884120 850640 1 0 $X=884120 $Y=845220
X3288 247 1978 1 2 BUF2CK $T=441440 719600 1 0 $X=441440 $Y=714180
X3289 2354 2359 1 2 BUF2CK $T=515840 860720 0 0 $X=515840 $Y=860340
X3290 377 583 1 2 BUF2CK $T=719200 830480 0 0 $X=719200 $Y=830100
X3291 3357 3360 1 2 BUF2CK $T=726640 770000 0 0 $X=726640 $Y=769620
X3292 1962 1 2 1968 BUF1CK $T=435240 729680 1 0 $X=435240 $Y=724260
X3293 1914 1 2 1926 BUF1CK $T=435240 749840 0 0 $X=435240 $Y=749460
X3294 245 1 2 1980 BUF1CK $T=435860 770000 1 0 $X=435860 $Y=764580
X3295 1996 1 2 2056 BUF1CK $T=451980 749840 0 0 $X=451980 $Y=749460
X3296 272 1 2 2063 BUF1CK $T=456940 729680 1 0 $X=456940 $Y=724260
X3297 283 1 2 2105 BUF1CK $T=465000 739760 1 0 $X=465000 $Y=734340
X3298 327 1 2 254 BUF1CK $T=543740 790160 0 0 $X=543740 $Y=789780
X3299 2501 1 2 2482 BUF1CK $T=549940 780080 1 0 $X=549940 $Y=774660
X3300 2571 1 2 2584 BUF1CK $T=566680 810320 1 0 $X=566680 $Y=804900
X3301 2744 1 2 2729 BUF1CK $T=605120 850640 1 0 $X=605120 $Y=845220
X3302 2761 1 2 435 BUF1CK $T=608840 860720 1 0 $X=608840 $Y=855300
X3303 2831 1 2 2840 BUF1CK $T=621240 860720 1 0 $X=621240 $Y=855300
X3304 2826 1 2 2825 BUF1CK $T=623720 830480 1 0 $X=623720 $Y=825060
X3305 2934 1 2 2938 BUF1CK $T=644180 719600 1 0 $X=644180 $Y=714180
X3306 3303 1 2 3351 BUF1CK $T=722920 850640 0 0 $X=722920 $Y=850260
X3307 3372 1 2 3373 BUF1CK $T=734700 699440 1 0 $X=734700 $Y=694020
X3308 3421 1 2 3422 BUF1CK $T=745860 830480 1 0 $X=745860 $Y=825060
X3309 3402 1 2 3426 BUF1CK $T=748340 830480 1 0 $X=748340 $Y=825060
X3310 3736 1 2 3720 BUF1CK $T=823360 749840 1 0 $X=823360 $Y=744420
X3311 3742 1 2 3734 BUF1CK $T=825220 729680 1 0 $X=825220 $Y=724260
X3312 3752 1 2 3759 BUF1CK $T=828320 729680 1 0 $X=828320 $Y=724260
X3313 3766 1 2 3760 BUF1CK $T=832040 719600 0 0 $X=832040 $Y=719220
X3314 3810 1 2 3696 BUF1CK $T=845060 770000 1 0 $X=845060 $Y=764580
X3315 3998 1 2 4009 BUF1CK $T=897760 719600 0 0 $X=897760 $Y=719220
X3316 3982 1 2 4010 BUF1CK $T=897760 729680 0 0 $X=897760 $Y=729300
X3317 4013 1 2 4019 BUF1CK $T=902100 820400 1 0 $X=902100 $Y=814980
X3318 4052 1 2 3664 BUF1CK $T=905820 729680 1 0 $X=905820 $Y=724260
X3319 4065 1 2 3859 BUF1CK $T=909540 759920 0 0 $X=909540 $Y=759540
X3320 4088 1 2 4082 BUF1CK $T=916360 719600 1 0 $X=916360 $Y=714180
X3321 4127 1 2 3815 BUF1CK $T=930620 719600 0 0 $X=930620 $Y=719220
X3322 4169 1 2 3873 BUF1CK $T=940540 749840 0 0 $X=940540 $Y=749460
X3323 3842 1 2 4296 BUF1CK $T=990760 860720 0 0 $X=990760 $Y=860340
X3324 4311 1 2 4305 BUF1CK $T=997580 709520 0 0 $X=997580 $Y=709140
X3325 4315 1 2 4285 BUF1CK $T=998200 729680 1 0 $X=998200 $Y=724260
X3326 4342 1 2 4227 BUF1CK $T=1007500 749840 1 0 $X=1007500 $Y=744420
X3327 3855 1 2 4428 BUF1CK $T=1030440 850640 1 0 $X=1030440 $Y=845220
X3328 3870 1 2 4437 BUF1CK $T=1044080 830480 1 0 $X=1044080 $Y=825060
X3329 3883 1 2 4458 BUF1CK $T=1049660 850640 0 0 $X=1049660 $Y=850260
X3330 26 1005 2 1041 1100 1 OR3B2 $T=255440 729680 1 0 $X=255440 $Y=724260
X3331 2417 309 2 2399 2369 1 OR3B2 $T=531340 810320 1 180 $X=527620 $Y=809940
X3332 2398 2706 2 2637 2712 1 OR3B2 $T=594580 770000 1 0 $X=594580 $Y=764580
X3333 2706 2712 2 261 2398 1 AOI12H $T=600160 759920 1 180 $X=593960 $Y=759540
X3334 2307 2313 1 309 2308 2279 2 OAI112HS $T=514600 800240 0 180 $X=510260 $Y=794820
X3335 2307 2298 1 2344 2337 2320 2 OAI112HS $T=512740 790160 0 0 $X=512740 $Y=789780
X3336 2290 2307 1 2336 2296 2320 2 OAI112HS $T=520800 800240 0 180 $X=516460 $Y=794820
X3337 2290 2307 1 2370 2376 2300 2 OAI112HS $T=522040 800240 1 0 $X=522040 $Y=794820
X3338 2637 2652 1 2627 2624 2582 2 OAI112HS $T=580940 790160 0 180 $X=576600 $Y=784740
X3339 2643 2637 1 2630 2615 2628 2 OAI112HS $T=582180 759920 1 180 $X=577840 $Y=759540
X3340 2663 2637 1 2649 2625 2644 2 OAI112HS $T=585280 770000 0 180 $X=580940 $Y=764580
X3341 2637 2668 1 2654 2632 2651 2 OAI112HS $T=587140 780080 0 180 $X=582800 $Y=774660
X3342 2694 2637 1 2655 2638 2495 2 OAI112HS $T=587140 780080 1 180 $X=582800 $Y=779700
X3343 2683 2637 1 2670 2547 2561 2 OAI112HS $T=591480 790160 1 180 $X=587140 $Y=789780
X3344 2709 2637 1 2700 2554 2603 2 OAI112HS $T=597060 790160 1 180 $X=592720 $Y=789780
X3345 2227 306 307 304 2211 303 2 1 2207 OA222S $T=492900 719600 1 180 $X=487320 $Y=719220
X3346 2230 306 2211 304 2215 303 2 1 2198 OA222S $T=492900 729680 0 180 $X=487320 $Y=724260
X3347 2211 306 308 304 310 303 2 1 2238 OA222S $T=488560 699440 0 0 $X=488560 $Y=699060
X3348 2215 301 2211 305 2227 309 2 1 2212 OA222S $T=495380 739760 1 180 $X=489800 $Y=739380
X3349 2215 306 310 304 307 303 2 1 2243 OA222S $T=490420 709520 1 0 $X=490420 $Y=704100
X3350 308 316 2205 315 2230 312 2 1 2217 OA222S $T=497860 719600 0 180 $X=492280 $Y=714180
X3351 310 316 2216 315 2205 312 2 1 2194 OA222S $T=497860 739760 0 180 $X=492280 $Y=734340
X3352 2215 305 2216 2235 2205 316 2 1 2248 OA222S $T=492280 749840 1 0 $X=492280 $Y=744420
X3353 311 316 2227 315 2215 312 2 1 2250 OA222S $T=493520 709520 0 0 $X=493520 $Y=709140
X3354 313 316 2230 315 2227 312 2 1 2247 OA222S $T=493520 719600 0 0 $X=493520 $Y=719220
X3355 2227 303 2216 2244 2215 304 2 1 2255 OA222S $T=493520 729680 0 0 $X=493520 $Y=729300
X3356 2211 301 307 305 2215 309 2 1 2245 OA222S $T=501580 739760 1 180 $X=496000 $Y=739380
X3357 2205 324 2216 2261 2230 316 2 1 2218 OA222S $T=503440 749840 0 180 $X=497860 $Y=744420
X3358 325 316 2211 315 307 312 2 1 319 OA222S $T=504060 699440 0 180 $X=498480 $Y=694020
X3359 321 316 2215 315 2211 312 2 1 320 OA222S $T=504060 699440 1 180 $X=498480 $Y=699060
X3360 2230 303 2216 2269 2227 304 2 1 2294 OA222S $T=500340 739760 1 0 $X=500340 $Y=734340
X3361 303 2381 2385 2244 2392 304 2 1 2395 OA222S $T=522040 719600 0 0 $X=522040 $Y=719220
X3362 352 316 315 356 312 360 2 1 361 OA222S $T=524520 699440 1 0 $X=524520 $Y=694020
X3363 2403 303 2385 2269 2381 304 2 1 2388 OA222S $T=530100 729680 1 180 $X=524520 $Y=729300
X3364 342 306 2401 304 302 303 2 1 354 OA222S $T=531340 699440 1 180 $X=525760 $Y=699060
X3365 306 2381 359 304 2404 303 2 1 2418 OA222S $T=527620 719600 1 0 $X=527620 $Y=714180
X3366 306 2403 2404 304 2392 303 2 1 2420 OA222S $T=527620 719600 0 0 $X=527620 $Y=719220
X3367 306 2392 356 304 359 303 2 1 2517 OA222S $T=528240 709520 1 0 $X=528240 $Y=704100
X3368 358 2392 305 2404 309 2381 2 1 2428 OA222S $T=530100 739760 0 0 $X=530100 $Y=739380
X3369 358 2404 359 305 309 2392 2 1 2408 OA222S $T=535680 749840 0 180 $X=530100 $Y=744420
X3370 306 359 342 304 360 303 2 1 2429 OA222S $T=530720 699440 1 0 $X=530720 $Y=694020
X3371 306 2404 360 304 356 303 2 1 2436 OA222S $T=531960 699440 0 0 $X=531960 $Y=699060
X3372 342 316 315 2403 312 2381 2 1 2448 OA222S $T=533820 719600 1 0 $X=533820 $Y=714180
X3373 365 316 315 2381 312 2392 2 1 2450 OA222S $T=534440 709520 0 0 $X=534440 $Y=709140
X3374 2401 316 315 2404 312 359 2 1 366 OA222S $T=542500 699440 0 180 $X=536920 $Y=694020
X3375 305 2392 2385 2235 2441 316 2 1 2456 OA222S $T=537540 749840 0 0 $X=537540 $Y=749460
X3376 302 316 315 2392 312 2404 2 1 2460 OA222S $T=538160 699440 0 0 $X=538160 $Y=699060
X3377 360 316 315 2441 312 2403 2 1 2469 OA222S $T=540020 719600 0 0 $X=540020 $Y=719220
X3378 2441 357 2385 2261 316 2403 2 1 2442 OA222S $T=545600 739760 0 180 $X=540020 $Y=734340
X3379 356 316 315 2385 312 2441 2 1 2484 OA222S $T=541880 729680 1 0 $X=541880 $Y=724260
X3380 1433 12 1 96 12 1418 2 MOAI1S $T=320540 820400 0 0 $X=320540 $Y=820020
X3381 1476 1472 1 1485 1472 109 2 MOAI1S $T=328600 790160 1 0 $X=328600 $Y=784740
X3382 1530 1472 1 1507 1472 131 2 MOAI1S $T=340380 790160 0 0 $X=340380 $Y=789780
X3383 1899 12 1 96 12 1788 2 MOAI1S $T=419120 749840 0 180 $X=415400 $Y=744420
X3384 2287 2278 1 305 2205 1918 2 MOAI1S $T=505300 759920 0 180 $X=501580 $Y=754500
X3385 2313 2310 1 2298 2285 2226 2 MOAI1S $T=509640 790160 1 180 $X=505920 $Y=789780
X3386 331 2311 1 301 313 2256 2 MOAI1S $T=510260 719600 0 180 $X=506540 $Y=714180
X3387 2310 2272 1 2267 2307 2185 2 MOAI1S $T=510880 770000 1 180 $X=507160 $Y=769620
X3388 2284 2277 1 305 310 2309 2 MOAI1S $T=512120 729680 0 180 $X=508400 $Y=724260
X3389 331 337 1 301 325 2246 2 MOAI1S $T=515840 699440 0 180 $X=512120 $Y=694020
X3390 331 2341 1 301 311 2318 2 MOAI1S $T=515840 709520 1 180 $X=512120 $Y=709140
X3391 331 2326 1 301 308 2302 2 MOAI1S $T=515840 719600 0 180 $X=512120 $Y=714180
X3392 331 2305 1 301 307 2323 2 MOAI1S $T=515840 739760 0 180 $X=512120 $Y=734340
X3393 331 2339 1 301 310 2329 2 MOAI1S $T=516460 729680 0 180 $X=512740 $Y=724260
X3394 331 338 1 301 321 2325 2 MOAI1S $T=517080 709520 0 180 $X=513360 $Y=704100
X3395 2360 2311 1 322 2205 2321 2 MOAI1S $T=519560 719600 1 180 $X=515840 $Y=719220
X3396 2064 2284 1 305 356 2378 2 MOAI1S $T=524520 739760 0 0 $X=524520 $Y=739380
X3397 331 2145 1 358 356 2421 2 MOAI1S $T=526380 739760 1 0 $X=526380 $Y=734340
X3398 2141 331 1 359 358 2386 2 MOAI1S $T=526380 749840 1 0 $X=526380 $Y=744420
X3399 2360 2061 1 322 2441 2425 2 MOAI1S $T=535680 729680 0 0 $X=535680 $Y=729300
X3400 331 2067 1 360 358 2431 2 MOAI1S $T=541260 729680 0 180 $X=537540 $Y=724260
X3401 1926 2278 1 305 2441 2485 2 MOAI1S $T=543120 749840 0 0 $X=543120 $Y=749460
X3402 2061 331 1 358 342 2477 2 MOAI1S $T=551800 729680 1 180 $X=548080 $Y=729300
X3403 331 2513 1 358 365 2492 2 MOAI1S $T=553040 719600 0 180 $X=549320 $Y=714180
X3404 331 2084 1 358 302 2512 2 MOAI1S $T=555520 709520 1 180 $X=551800 $Y=709140
X3405 331 2535 1 358 2401 2548 2 MOAI1S $T=556760 699440 1 0 $X=556760 $Y=694020
X3406 2867 459 1 444 2948 479 2 MOAI1S $T=644800 709520 1 0 $X=644800 $Y=704100
X3407 3081 539 1 501 3201 3198 2 MOAI1S $T=687580 709520 1 0 $X=687580 $Y=704100
X3408 3488 667 1 3488 3080 3549 2 MOAI1S $T=778720 729680 0 180 $X=775000 $Y=724260
X3409 3488 669 1 3488 2987 3558 2 MOAI1S $T=779340 719600 0 180 $X=775620 $Y=714180
X3410 3488 678 1 3488 3055 3591 2 MOAI1S $T=786780 729680 0 180 $X=783060 $Y=724260
X3411 3690 666 1 3679 666 3644 2 MOAI1S $T=809720 719600 1 180 $X=806000 $Y=719220
X3412 3807 666 1 3789 666 3592 2 MOAI1S $T=841340 719600 1 180 $X=837620 $Y=719220
X3413 3798 666 1 737 666 735 2 MOAI1S $T=841960 699440 0 180 $X=838240 $Y=694020
X3414 827 829 1 3753 827 4180 2 MOAI1S $T=939300 699440 0 0 $X=939300 $Y=699060
X3415 301 2205 1 2209 2216 2 305 1924 2230 OAI222S $T=486080 749840 0 0 $X=486080 $Y=749460
X3416 322 2215 1 324 310 2 305 2264 321 OAI222S $T=505920 709520 1 180 $X=500340 $Y=709140
X3417 322 2227 1 324 307 2 305 2251 311 OAI222S $T=500340 719600 1 0 $X=500340 $Y=714180
X3418 322 2230 1 324 2211 2 305 2282 313 OAI222S $T=500340 719600 0 0 $X=500340 $Y=719220
X3419 322 307 1 324 313 2 305 2242 329 OAI222S $T=504060 699440 0 0 $X=504060 $Y=699060
X3420 322 2211 1 324 308 2 305 2316 325 OAI222S $T=504060 709520 1 0 $X=504060 $Y=704100
X3421 2403 322 1 2404 357 2 305 2424 342 OAI222S $T=533820 719600 0 0 $X=533820 $Y=719220
X3422 2441 358 1 2209 2385 2 2403 2452 305 OAI222S $T=543120 749840 0 180 $X=537540 $Y=744420
X3423 2381 322 1 357 359 2 305 2466 365 OAI222S $T=540020 719600 1 0 $X=540020 $Y=714180
X3424 2392 322 1 357 356 2 305 2474 302 OAI222S $T=540640 709520 0 0 $X=540640 $Y=709140
X3425 2404 322 1 357 360 2 305 2504 2401 OAI222S $T=544980 699440 0 0 $X=544980 $Y=699060
X3426 322 359 1 357 342 2 305 2497 375 OAI222S $T=546220 699440 1 0 $X=546220 $Y=694020
X3427 1126 1128 1136 2 1 XNR2HS $T=256680 739760 0 0 $X=256680 $Y=739380
X3428 1187 1180 1131 2 1 XNR2HS $T=268460 830480 0 0 $X=268460 $Y=830100
X3429 1361 1365 1379 2 1 XNR2HS $T=305040 739760 0 0 $X=305040 $Y=739380
X3430 1662 1671 1697 2 1 XNR2HS $T=367660 739760 0 0 $X=367660 $Y=739380
X3431 2231 2214 2236 2 1 XNR2HS $T=491660 820400 1 0 $X=491660 $Y=814980
X3432 2368 2253 2225 2 1 XNR2HS $T=518940 860720 0 0 $X=518940 $Y=860340
X3433 2373 2364 2390 2 1 XNR2HS $T=521420 810320 0 0 $X=521420 $Y=809940
X3434 2430 2527 2538 2 1 XNR2HS $T=554280 790160 1 0 $X=554280 $Y=784740
X3435 2541 2500 2553 2 1 XNR2HS $T=558000 770000 0 0 $X=558000 $Y=769620
X3436 2430 2556 2565 2 1 XNR2HS $T=567920 790160 1 0 $X=567920 $Y=784740
X3437 453 3497 3423 2 1 XNR2HS $T=767560 759920 0 180 $X=761980 $Y=754500
X3438 3492 3527 3539 2 1 XNR2HS $T=767560 739760 0 0 $X=767560 $Y=739380
X3439 453 3539 3502 2 1 XNR2HS $T=773140 759920 0 180 $X=767560 $Y=754500
X3440 752 751 3814 2 1 XNR2HS $T=851260 719600 1 180 $X=845680 $Y=719220
X3441 338 2272 2284 332 341 2360 1 2 339 AO222S $T=523280 699440 0 180 $X=517080 $Y=694020
X3442 2272 2341 336 2284 2360 346 1 2 349 AO222S $T=517700 699440 0 0 $X=517700 $Y=699060
X3443 2272 2077 276 2284 2360 348 1 2 353 AO222S $T=519560 719600 1 0 $X=519560 $Y=714180
X3444 2084 2272 2284 347 350 2360 1 2 355 AO222S $T=520800 709520 1 0 $X=520800 $Y=704100
X3445 2357 2328 2 1 2324 OR2S $T=518940 749840 0 180 $X=516460 $Y=744420
X3446 9 16 2 1 1035 OR2 $T=241180 729680 0 0 $X=241180 $Y=729300
X3447 26 1035 2 1 1081 OR2 $T=242420 739760 1 0 $X=242420 $Y=734340
X3448 1012 26 2 1 1004 OR2 $T=249860 739760 0 0 $X=249860 $Y=739380
X3449 105 1413 2 1 1459 OR2 $T=327980 850640 1 180 $X=325500 $Y=850260
X3450 102 1436 2 1 1497 OR2 $T=336660 719600 1 180 $X=334180 $Y=719220
X3451 127 1429 2 1 1498 OR2 $T=342860 800240 0 180 $X=340380 $Y=794820
X3452 127 1524 2 1 1560 OR2 $T=343480 800240 1 0 $X=343480 $Y=794820
X3453 135 143 2 1 1563 OR2 $T=351540 770000 1 180 $X=349060 $Y=769620
X3454 2541 2500 2 1 2556 OR2 $T=559860 780080 0 0 $X=559860 $Y=779700
X3455 140 1 1551 139 1472 2 ND3S $T=347820 840560 1 180 $X=345340 $Y=840180
X3456 2257 1 2262 2266 2249 2 ND3S $T=499720 770000 1 0 $X=499720 $Y=764580
X3457 2249 1 2298 2279 2290 2 ND3S $T=514600 790160 0 180 $X=512120 $Y=784740
X3458 2254 1 2298 306 2335 2 ND3S $T=515220 770000 1 0 $X=515220 $Y=764580
X3459 2249 1 2290 2369 2358 2 ND3S $T=518940 790160 1 0 $X=518940 $Y=784740
X3460 2262 1 2258 2300 2358 2 ND3S $T=520800 780080 0 0 $X=520800 $Y=779700
X3461 2358 1 2335 315 2254 2 ND3S $T=521420 770000 1 0 $X=521420 $Y=764580
X3462 2402 1 2336 2396 309 2 ND3S $T=528240 810320 0 180 $X=525760 $Y=804900
X3463 2370 1 2336 2406 2320 2 ND3S $T=527620 800240 0 0 $X=527620 $Y=799860
X3464 1251 1253 1152 2 1 1218 AN3 $T=280240 729680 0 0 $X=280240 $Y=729300
X3465 2298 2307 2335 2 1 2360 AN3 $T=517700 770000 1 0 $X=517700 $Y=764580
X3466 2279 309 2369 2 1 2344 AN3 $T=522660 790160 1 180 $X=518940 $Y=789780
X3467 1248 2 1230 1074 1284 1 NR3 $T=287060 860720 0 180 $X=283960 $Y=855300
X3468 2280 2 2307 2300 2462 1 NR3 $T=543120 780080 1 180 $X=540020 $Y=779700
X3469 2667 2 2699 2648 2711 1 NR3 $T=595820 770000 0 0 $X=595820 $Y=769620
X3470 2838 2 2681 2823 2833 1 NR3 $T=623720 800240 0 180 $X=620620 $Y=794820
X3471 2612 2 3005 2986 3010 1 NR3 $T=654100 810320 0 0 $X=654100 $Y=809940
X3472 2249 2370 2358 2262 2 331 1 AOI13HS $T=519560 780080 1 0 $X=519560 $Y=774660
X3473 2833 444 2834 2824 2 2829 1 AOI13HS $T=624340 790160 1 180 $X=620620 $Y=789780
X3474 3010 501 3043 3030 2 2955 1 AOI13HS $T=662160 810320 1 0 $X=662160 $Y=804900
X3475 54 51 1135 1 2 OR2P $T=271560 729680 1 180 $X=267840 $Y=729300
X3476 1035 2 1037 1 1031 NR2P $T=241180 729680 1 180 $X=237460 $Y=729300
X3477 1081 2 1012 1 1042 NR2P $T=244900 729680 0 0 $X=244900 $Y=729300
X3478 1035 2 1041 1 1038 NR2P $T=251720 729680 0 0 $X=251720 $Y=729300
X3479 37 2 39 1 1005 NR2P $T=259160 719600 1 0 $X=259160 $Y=714180
X3480 1135 2 1160 1 1157 NR2P $T=262880 739760 0 180 $X=259160 $Y=734340
X3481 37 2 50 1 1020 NR2P $T=269080 719600 1 0 $X=269080 $Y=714180
X3482 1135 2 1191 1 1128 NR2P $T=269700 739760 0 0 $X=269700 $Y=739380
X3483 69 2 1254 1 1225 NR2P $T=285820 870800 1 0 $X=285820 $Y=865380
X3484 1413 2 1409 1 1074 NR2P $T=313720 850640 0 0 $X=313720 $Y=850260
X3485 1413 2 1412 1 1271 NR2P $T=314960 860720 1 0 $X=314960 $Y=855300
X3486 1429 2 1422 1 1273 NR2P $T=316820 800240 1 0 $X=316820 $Y=794820
X3487 1413 2 1448 1 1248 NR2P $T=320540 850640 0 0 $X=320540 $Y=850260
X3488 1436 2 1441 1 1473 NR2P $T=327980 729680 0 0 $X=327980 $Y=729300
X3489 1459 2 1489 1 1230 NR2P $T=329220 850640 0 0 $X=329220 $Y=850260
X3490 158 2 154 1 155 NR2P $T=355260 870800 1 0 $X=355260 $Y=865380
X3491 2279 2 2254 1 2284 NR2P $T=505300 770000 1 180 $X=501580 $Y=769620
X3492 2290 2 2275 1 2313 NR2P $T=507780 800240 0 180 $X=504060 $Y=794820
X3493 2307 2358 2262 2369 1 2 2402 OA13S $T=523900 790160 1 0 $X=523900 $Y=784740
X3494 100 1472 1 1450 106 1472 2 MOAI1 $T=326120 840560 0 0 $X=326120 $Y=840180
X3495 1480 1472 1 1458 108 1472 2 MOAI1 $T=327980 800240 1 0 $X=327980 $Y=794820
X3496 1482 1472 1 1467 119 1472 2 MOAI1 $T=332320 830480 0 0 $X=332320 $Y=830100
X3497 827 832 1 3679 834 827 2 MOAI1 $T=944260 699440 0 0 $X=944260 $Y=699060
X3498 827 731 1 827 836 3789 2 MOAI1 $T=944260 709520 1 0 $X=944260 $Y=704100
X3499 1494 1365 1436 1 2 AN2B1 $T=340380 729680 1 0 $X=340380 $Y=724260
X3500 2280 2249 2270 2 1 2267 OA12S $T=505300 780080 0 180 $X=501580 $Y=774660
X3501 2280 2275 2285 2 1 2260 OA12S $T=509020 790160 0 180 $X=505300 $Y=784740
X3502 2300 2307 1 2310 2 2375 OAI12HS $T=524520 770000 1 180 $X=520800 $Y=769620
X3503 2633 2617 1 2 INV1CK $T=579700 810320 0 0 $X=579700 $Y=809940
X3504 2236 181 20 2191 1 2 QDFFRBP $T=495380 810320 0 180 $X=482980 $Y=804900
X3505 326 181 296 340 1 2 QDFFRBP $T=506540 870800 1 0 $X=506540 $Y=865380
X3506 2206 2210 20 2249 1 2 2258 DFFRBN $T=486700 780080 1 0 $X=486700 $Y=774660
X3507 1084 1046 1090 1 2 1048 MAO222 $T=244900 820400 0 0 $X=244900 $Y=820020
X3508 1305 1122 1260 1 2 1259 MAO222 $T=290780 770000 1 0 $X=290780 $Y=764580
X3509 1327 1427 1403 1 2 1404 MAO222 $T=316820 749840 0 0 $X=316820 $Y=749460
X3510 1707 1676 1712 1 2 1723 MAO222 $T=372000 810320 0 0 $X=372000 $Y=809940
X3511 1761 1723 1749 1 2 1772 MAO222 $T=382540 820400 1 0 $X=382540 $Y=814980
X3512 1750 1764 1767 1 2 198 MAO222 $T=383780 699440 0 0 $X=383780 $Y=699060
X3513 191 1762 197 1 2 1764 MAO222 $T=383780 709520 0 0 $X=383780 $Y=709140
X3514 1732 1747 1768 1 2 1774 MAO222 $T=383780 749840 1 0 $X=383780 $Y=744420
X3515 193 198 194 1 2 208 MAO222 $T=385640 699440 1 0 $X=385640 $Y=694020
X3516 1759 1781 1788 1 2 1769 MAO222 $T=386880 739760 1 0 $X=386880 $Y=734340
X3517 1826 1833 1445 1 2 1842 MAO222 $T=399280 709520 1 0 $X=399280 $Y=704100
X3518 1924 1929 1955 1 2 1948 MAO222 $T=444540 759920 1 0 $X=444540 $Y=754500
X3519 2059 2076 2060 1 2 2087 MAO222 $T=454460 820400 1 0 $X=454460 $Y=814980
X3520 2055 2061 2073 1 2 2102 MAO222 $T=456940 729680 0 0 $X=456940 $Y=729300
X3521 2070 2087 2112 1 2 2119 MAO222 $T=459420 820400 0 0 $X=459420 $Y=820020
X3522 2104 2086 279 1 2 2107 MAO222 $T=459420 850640 0 0 $X=459420 $Y=850260
X3523 2111 2119 2116 1 2 2129 MAO222 $T=463760 810320 1 0 $X=463760 $Y=804900
X3524 2147 2067 2102 1 2 2166 MAO222 $T=471820 729680 0 0 $X=471820 $Y=729300
X3525 2044 2152 2138 1 2 2160 MAO222 $T=471820 780080 0 0 $X=471820 $Y=779700
X3526 2176 2181 2169 1 2 2231 MAO222 $T=478020 820400 0 0 $X=478020 $Y=820020
X3527 314 2068 2208 1 2 2253 MAO222 $T=493520 860720 0 0 $X=493520 $Y=860340
X3528 2620 2311 2642 1 2 2579 MAO222 $T=577840 719600 0 0 $X=577840 $Y=719220
X3529 2641 2341 2660 1 2 2642 MAO222 $T=582180 709520 1 0 $X=582180 $Y=704100
X3530 1068 16 2 30 1 17 MUX2S $T=244280 709520 1 0 $X=244280 $Y=704100
X3531 1193 43 2 1206 1 1226 MUX2S $T=271560 709520 1 0 $X=271560 $Y=704100
X3532 1252 51 2 73 1 72 MUX2S $T=285820 709520 0 0 $X=285820 $Y=709140
X3533 1587 126 2 149 1 153 MUX2S $T=350920 699440 1 0 $X=350920 $Y=694020
X3534 1543 126 2 162 1 165 MUX2S $T=356500 699440 1 0 $X=356500 $Y=694020
X3535 1592 145 2 172 1 1670 MUX2S $T=362700 699440 1 0 $X=362700 $Y=694020
X3536 1574 1564 2 1744 1 1510 MUX2S $T=378820 790160 0 0 $X=378820 $Y=789780
X3537 1719 1725 2 1745 1 1708 MUX2S $T=378820 850640 1 0 $X=378820 $Y=845220
X3538 1718 1740 2 1748 1 1760 MUX2S $T=379440 780080 1 0 $X=379440 $Y=774660
X3539 1726 1659 2 1752 1 1739 MUX2S $T=380680 840560 0 0 $X=380680 $Y=840180
X3540 1739 1725 2 1755 1 1699 MUX2S $T=381300 860720 1 0 $X=381300 $Y=855300
X3541 1651 1521 2 1756 1 1610 MUX2S $T=381300 860720 0 0 $X=381300 $Y=860340
X3542 189 187 2 1757 1 195 MUX2S $T=381300 870800 1 0 $X=381300 $Y=865380
X3543 1665 1521 2 1773 1 1546 MUX2S $T=385020 850640 1 0 $X=385020 $Y=845220
X3544 1748 1740 2 1776 1 1783 MUX2S $T=385640 780080 1 0 $X=385640 $Y=774660
X3545 1752 1659 2 1778 1 1745 MUX2S $T=386260 840560 0 0 $X=386260 $Y=840180
X3546 1708 1521 2 1779 1 204 MUX2S $T=386260 860720 0 0 $X=386260 $Y=860340
X3547 1733 1564 2 1784 1 1711 MUX2S $T=386880 800240 1 0 $X=386880 $Y=794820
X3548 1505 117 2 1786 1 203 MUX2S $T=386880 860720 1 0 $X=386880 $Y=855300
X3549 1760 1735 2 1789 1 1775 MUX2S $T=387500 780080 0 0 $X=387500 $Y=779700
X3550 1776 1740 2 1794 1 1789 MUX2S $T=389360 770000 1 0 $X=389360 $Y=764580
X3551 1757 187 2 201 1 200 MUX2S $T=393700 870800 0 180 $X=389360 $Y=865380
X3552 1744 1564 2 1795 1 1632 MUX2S $T=389980 790160 0 0 $X=389980 $Y=789780
X3553 1783 1735 2 1797 1 1758 MUX2S $T=390600 790160 1 0 $X=390600 $Y=784740
X3554 1778 1659 2 1798 1 1755 MUX2S $T=390600 850640 1 0 $X=390600 $Y=845220
X3555 1745 1725 2 1799 1 1773 MUX2S $T=390600 850640 0 0 $X=390600 $Y=850260
X3556 1789 1735 2 1809 1 1795 MUX2S $T=394320 780080 0 0 $X=394320 $Y=779700
X3557 1755 1725 2 1811 1 1756 MUX2S $T=394320 860720 1 0 $X=394320 $Y=855300
X3558 1794 1740 2 1807 1 1797 MUX2S $T=394940 770000 1 0 $X=394940 $Y=764580
X3559 1798 1659 2 1805 1 1799 MUX2S $T=394940 840560 0 0 $X=394940 $Y=840180
X3560 1699 1521 2 1815 1 1729 MUX2S $T=394940 860720 0 0 $X=394940 $Y=860340
X3561 1807 1740 2 1817 1 1809 MUX2S $T=396180 770000 0 0 $X=396180 $Y=769620
X3562 1775 1564 2 1818 1 1741 MUX2S $T=396180 790160 0 0 $X=396180 $Y=789780
X3563 1799 1725 2 1819 1 1779 MUX2S $T=396180 850640 0 0 $X=396180 $Y=850260
X3564 1805 1659 2 1822 1 1811 MUX2S $T=396800 840560 1 0 $X=396800 $Y=835140
X3565 1797 1735 2 1825 1 1784 MUX2S $T=397420 790160 1 0 $X=397420 $Y=784740
X3566 1758 1564 2 1830 1 1810 MUX2S $T=398040 800240 1 0 $X=398040 $Y=794820
X3567 168 117 2 1832 1 212 MUX2S $T=398660 870800 1 0 $X=398660 $Y=865380
X3568 1811 1725 2 1837 1 1815 MUX2S $T=399280 860720 1 0 $X=399280 $Y=855300
X3569 1510 1793 2 1839 1 1848 MUX2S $T=399900 800240 0 0 $X=399900 $Y=799860
X3570 1822 1659 2 1844 1 1819 MUX2S $T=400520 840560 0 0 $X=400520 $Y=840180
X3571 1756 1521 2 1845 1 1832 MUX2S $T=400520 860720 0 0 $X=400520 $Y=860340
X3572 1795 1564 2 1851 1 1839 MUX2S $T=402380 790160 0 0 $X=402380 $Y=789780
X3573 1773 1521 2 1852 1 1786 MUX2S $T=402380 850640 1 0 $X=402380 $Y=845220
X3574 1817 1740 2 1857 1 1825 MUX2S $T=403620 780080 1 0 $X=403620 $Y=774660
X3575 1809 1735 2 1858 1 1818 MUX2S $T=403620 780080 0 0 $X=403620 $Y=779700
X3576 1784 1564 2 1859 1 1862 MUX2S $T=404240 800240 1 0 $X=404240 $Y=794820
X3577 1470 1793 2 1862 1 1868 MUX2S $T=405480 800240 0 0 $X=405480 $Y=799860
X3578 1837 1725 2 1854 1 1845 MUX2S $T=409820 860720 0 180 $X=405480 $Y=855300
X3579 1844 1659 2 1860 1 1837 MUX2S $T=406100 840560 0 0 $X=406100 $Y=840180
X3580 1845 1521 2 1866 1 1869 MUX2S $T=406100 860720 0 0 $X=406100 $Y=860340
X3581 1610 117 2 1869 1 219 MUX2S $T=407340 870800 1 0 $X=407340 $Y=865380
X3582 1860 1659 2 1870 1 1875 MUX2S $T=407960 850640 0 0 $X=407960 $Y=850260
X3583 1861 1740 2 1872 1 1873 MUX2S $T=408580 770000 0 0 $X=408580 $Y=769620
X3584 1825 1735 2 1873 1 1830 MUX2S $T=408580 790160 0 0 $X=408580 $Y=789780
X3585 1858 1735 2 1876 1 1851 MUX2S $T=409200 780080 1 0 $X=409200 $Y=774660
X3586 1873 1735 2 1867 1 1859 MUX2S $T=413540 790160 0 180 $X=409200 $Y=784740
X3587 1859 1564 2 1879 1 1882 MUX2S $T=409820 800240 1 0 $X=409820 $Y=794820
X3588 1857 1740 2 1861 1 1858 MUX2S $T=415400 770000 0 180 $X=411060 $Y=764580
X3589 1711 1793 2 1882 1 1900 MUX2S $T=411060 800240 0 0 $X=411060 $Y=799860
X3590 1875 1725 2 1884 1 1880 MUX2S $T=411680 860720 1 0 $X=411680 $Y=855300
X3591 1779 1521 2 1880 1 221 MUX2S $T=411680 860720 0 0 $X=411680 $Y=860340
X3592 1870 1659 2 1883 1 1854 MUX2S $T=412300 840560 1 0 $X=412300 $Y=835140
X3593 1880 1521 2 1866 1 222 MUX2S $T=412920 870800 1 0 $X=412920 $Y=865380
X3594 1819 1725 2 1875 1 1852 MUX2S $T=414160 850640 0 0 $X=414160 $Y=850260
X3595 1894 1740 2 1886 1 1867 MUX2S $T=419120 770000 1 180 $X=414780 $Y=769620
X3596 1885 1564 2 1879 1 1893 MUX2S $T=414780 790160 0 0 $X=414780 $Y=789780
X3597 1830 1564 2 1885 1 1903 MUX2S $T=415400 790160 1 0 $X=415400 $Y=784740
X3598 1810 1793 2 1893 1 1923 MUX2S $T=415400 800240 1 0 $X=415400 $Y=794820
X3599 1562 1793 2 1896 1 1901 MUX2S $T=416020 810320 1 0 $X=416020 $Y=804900
X3600 1872 1740 2 1894 1 1876 MUX2S $T=416640 770000 1 0 $X=416640 $Y=764580
X3601 1815 1521 2 1895 1 230 MUX2S $T=417260 860720 1 0 $X=417260 $Y=855300
X3602 1895 1521 2 1866 1 1911 MUX2S $T=418500 870800 1 0 $X=418500 $Y=865380
X3603 1876 1735 2 1919 1 1920 MUX2S $T=420980 780080 1 0 $X=420980 $Y=774660
X3604 1818 1564 2 1920 1 1896 MUX2S $T=420980 780080 0 0 $X=420980 $Y=779700
X3605 1741 1793 2 1909 1 1930 MUX2S $T=420980 790160 0 0 $X=420980 $Y=789780
X3606 1657 1793 2 1903 1 1927 MUX2S $T=420980 800240 0 0 $X=420980 $Y=799860
X3607 1920 1564 2 1879 1 1909 MUX2S $T=426560 790160 0 180 $X=422220 $Y=784740
X3608 1729 117 2 1911 1 239 MUX2S $T=424080 870800 1 0 $X=424080 $Y=865380
X3609 1852 1521 2 1935 1 1940 MUX2S $T=425320 850640 1 0 $X=425320 $Y=845220
X3610 1632 1793 2 1938 1 1941 MUX2S $T=426560 800240 1 0 $X=426560 $Y=794820
X3611 1851 1564 2 1937 1 1938 MUX2S $T=427180 780080 0 0 $X=427180 $Y=779700
X3612 1839 1793 2 1939 1 1943 MUX2S $T=427180 800240 0 0 $X=427180 $Y=799860
X3613 1937 1564 2 1879 1 1939 MUX2S $T=428420 790160 0 0 $X=428420 $Y=789780
X3614 1546 117 2 1940 1 238 MUX2S $T=428420 850640 0 0 $X=428420 $Y=850260
X3615 1935 1521 2 1866 1 1960 MUX2S $T=430900 850640 1 0 $X=430900 $Y=845220
X3616 1786 117 2 1960 1 252 MUX2S $T=434620 850640 0 0 $X=434620 $Y=850260
X3617 1967 370 2 1653 1 2468 MUX2S $T=549320 840560 1 0 $X=549320 $Y=835140
X3618 2038 370 2 1724 1 2529 MUX2S $T=551180 820400 0 0 $X=551180 $Y=820020
X3619 2178 370 2 1892 1 2539 MUX2S $T=554900 840560 1 0 $X=554900 $Y=835140
X3620 1892 370 2 1536 1 2503 MUX2S $T=555520 830480 0 0 $X=555520 $Y=830100
X3621 2161 370 2 1967 1 2578 MUX2S $T=561720 830480 0 0 $X=561720 $Y=830100
X3622 2158 370 2 2188 1 2576 MUX2S $T=562340 820400 0 0 $X=562340 $Y=820020
X3623 2188 370 2 1827 1 2583 MUX2S $T=562960 820400 1 0 $X=562960 $Y=814980
X3624 2393 370 2 2158 1 2588 MUX2S $T=563580 810320 0 0 $X=563580 $Y=809940
X3625 2352 370 2 2157 1 2609 MUX2S $T=575360 800240 0 0 $X=575360 $Y=799860
X3626 1008 9 2 1 985 8 MUX2 $T=233120 719600 0 180 $X=228780 $Y=714180
X3627 999 9 2 1 975 18 MUX2 $T=232500 729680 0 0 $X=232500 $Y=729300
X3628 992 9 2 1 982 19 MUX2 $T=233120 699440 1 0 $X=233120 $Y=694020
X3629 1017 16 2 1 992 14 MUX2 $T=237460 709520 0 180 $X=233120 $Y=704100
X3630 1032 9 2 1 1003 15 MUX2 $T=238080 719600 1 180 $X=233740 $Y=719220
X3631 1022 9 2 1 1001 28 MUX2 $T=238700 699440 0 0 $X=238700 $Y=699060
X3632 1060 9 2 1 979 23 MUX2 $T=243040 729680 0 180 $X=238700 $Y=724260
X3633 1050 16 2 1 21 22 MUX2 $T=243660 699440 0 180 $X=239320 $Y=694020
X3634 1082 26 2 1 1050 1059 MUX2 $T=247380 719600 0 180 $X=243040 $Y=714180
X3635 1072 26 2 1 22 29 MUX2 $T=249240 699440 0 180 $X=244900 $Y=694020
X3636 1059 26 2 1 14 1072 MUX2 $T=249240 699440 1 180 $X=244900 $Y=699060
X3637 1092 26 2 1 1068 1111 MUX2 $T=249240 709520 0 0 $X=249240 $Y=709140
X3638 1111 26 2 1 24 1096 MUX2 $T=254200 709520 0 180 $X=249860 $Y=704100
X3639 1096 26 2 1 30 32 MUX2 $T=254820 699440 1 180 $X=250480 $Y=699060
X3640 1124 13 2 1 32 33 MUX2 $T=255440 699440 0 180 $X=251100 $Y=694020
X3641 1020 13 2 1 1111 1118 MUX2 $T=259160 719600 0 180 $X=254820 $Y=714180
X3642 1121 13 2 1 1096 1120 MUX2 $T=259780 709520 0 180 $X=255440 $Y=704100
X3643 1118 13 2 1 1059 1121 MUX2 $T=259780 709520 1 180 $X=255440 $Y=709140
X3644 1120 13 2 1 1072 1124 MUX2 $T=261020 699440 1 180 $X=256680 $Y=699060
X3645 1005 13 2 1 1082 1020 MUX2 $T=261020 719600 1 180 $X=256680 $Y=719220
X3646 1168 43 2 1 1199 1188 MUX2 $T=267840 719600 0 0 $X=267840 $Y=719220
X3647 1188 43 2 1 1129 1193 MUX2 $T=274040 709520 0 0 $X=274040 $Y=709140
X3648 1199 34 2 1 1243 1226 MUX2 $T=275900 719600 1 0 $X=275900 $Y=714180
X3649 1214 54 2 1 1241 64 MUX2 $T=275900 729680 0 0 $X=275900 $Y=729300
X3650 1213 43 2 1 1283 53 MUX2 $T=276520 699440 1 0 $X=276520 $Y=694020
X3651 1206 43 2 1 68 1213 MUX2 $T=277760 709520 1 0 $X=277760 $Y=704100
X3652 1144 34 2 1 1252 1129 MUX2 $T=279620 709520 0 0 $X=279620 $Y=709140
X3653 1222 51 2 1 1251 1272 MUX2 $T=280240 719600 1 0 $X=280240 $Y=714180
X3654 1272 51 2 1 64 63 MUX2 $T=286440 699440 1 180 $X=282100 $Y=699060
X3655 1245 54 2 1 1278 71 MUX2 $T=282100 719600 0 0 $X=282100 $Y=719220
X3656 1129 34 2 1 1272 68 MUX2 $T=283340 709520 1 0 $X=283340 $Y=704100
X3657 1226 34 2 1 1298 1283 MUX2 $T=287680 699440 0 0 $X=287680 $Y=699060
X3658 1283 34 2 1 77 76 MUX2 $T=288920 699440 1 0 $X=288920 $Y=694020
X3659 1243 51 2 1 75 77 MUX2 $T=288920 709520 1 0 $X=288920 $Y=704100
X3660 1291 51 2 1 1285 1298 MUX2 $T=290780 719600 1 0 $X=290780 $Y=714180
X3661 1293 54 2 1 1310 80 MUX2 $T=290780 719600 0 0 $X=290780 $Y=719220
X3662 1294 54 2 1 1311 79 MUX2 $T=290780 729680 1 0 $X=290780 $Y=724260
X3663 1251 54 2 1 1320 81 MUX2 $T=292640 709520 0 0 $X=292640 $Y=709140
X3664 1298 51 2 1 79 78 MUX2 $T=298220 699440 0 180 $X=293880 $Y=694020
X3665 1285 54 2 1 1337 82 MUX2 $T=294500 699440 0 0 $X=294500 $Y=699060
X3666 1444 99 2 1 1466 1478 MUX2 $T=323020 699440 1 0 $X=323020 $Y=694020
X3667 1452 99 2 1 1484 1462 MUX2 $T=325500 709520 0 0 $X=325500 $Y=709140
X3668 1462 99 2 1 1486 1444 MUX2 $T=326740 699440 0 0 $X=326740 $Y=699060
X3669 1487 1490 2 1 1477 1468 MUX2 $T=332320 719600 0 180 $X=327980 $Y=714180
X3670 1477 102 2 1 1494 1484 MUX2 $T=328600 719600 0 0 $X=328600 $Y=719220
X3671 1478 99 2 1 115 114 MUX2 $T=331080 699440 1 0 $X=331080 $Y=694020
X3672 1487 99 2 1 1501 1452 MUX2 $T=331080 709520 0 0 $X=331080 $Y=709140
X3673 1484 102 2 1 1512 1466 MUX2 $T=332940 699440 0 0 $X=332940 $Y=699060
X3674 1523 117 2 1 97 134 MUX2 $T=338520 860720 0 0 $X=338520 $Y=860340
X3675 1466 102 2 1 1543 128 MUX2 $T=339140 699440 1 0 $X=339140 $Y=694020
X3676 1501 102 2 1 1545 1486 MUX2 $T=339140 699440 0 0 $X=339140 $Y=699060
X3677 1520 117 2 1 130 1546 MUX2 $T=339140 850640 1 0 $X=339140 $Y=845220
X3678 1534 126 2 1 1557 1512 MUX2 $T=341620 719600 1 0 $X=341620 $Y=714180
X3679 1537 102 2 1 1555 1501 MUX2 $T=342240 709520 1 0 $X=342240 $Y=704100
X3680 1486 102 2 1 1587 115 MUX2 $T=344720 699440 1 0 $X=344720 $Y=694020
X3681 1512 126 2 1 142 141 MUX2 $T=344720 699440 0 0 $X=344720 $Y=699060
X3682 1591 138 2 1 1410 1562 MUX2 $T=351540 810320 0 180 $X=347200 $Y=804900
X3683 1542 105 2 1 1589 1588 MUX2 $T=347200 860720 1 0 $X=347200 $Y=855300
X3684 1555 126 2 1 1592 1587 MUX2 $T=347820 709520 0 0 $X=347820 $Y=709140
X3685 1575 1556 2 1 1594 1604 MUX2 $T=349060 840560 0 0 $X=349060 $Y=840180
X3686 1604 1556 2 1 1542 1576 MUX2 $T=353400 850640 0 180 $X=349060 $Y=845220
X3687 1571 117 2 1 152 1610 MUX2 $T=350300 870800 1 0 $X=350300 $Y=865380
X3688 1494 126 2 1 156 1543 MUX2 $T=350920 699440 0 0 $X=350920 $Y=699060
X3689 1590 145 2 1 1617 153 MUX2 $T=351540 719600 0 0 $X=351540 $Y=719220
X3690 1559 126 2 1 1616 1545 MUX2 $T=353400 709520 0 0 $X=353400 $Y=709140
X3691 1595 1564 2 1 1481 1626 MUX2 $T=353400 800240 1 0 $X=353400 $Y=794820
X3692 1614 138 2 1 1558 1632 MUX2 $T=355260 800240 0 0 $X=355260 $Y=799860
X3693 1545 126 2 1 164 166 MUX2 $T=356500 699440 0 0 $X=356500 $Y=699060
X3694 1566 145 2 1 1642 142 MUX2 $T=357120 719600 0 0 $X=357120 $Y=719220
X3695 1622 144 2 1 1599 1641 MUX2 $T=357120 780080 0 0 $X=357120 $Y=779700
X3696 1621 145 2 1 1640 164 MUX2 $T=357740 719600 1 0 $X=357740 $Y=714180
X3697 1575 159 2 1 1588 1635 MUX2 $T=357740 840560 0 0 $X=357740 $Y=840180
X3698 1616 145 2 1 1655 167 MUX2 $T=358980 709520 0 0 $X=358980 $Y=709140
X3699 1589 1521 2 1 168 1651 MUX2 $T=358980 860720 0 0 $X=358980 $Y=860340
X3700 1513 1521 2 1 1505 1665 MUX2 $T=359600 850640 0 0 $X=359600 $Y=850260
X3701 1547 1521 2 1 1516 1663 MUX2 $T=360840 870800 1 0 $X=360840 $Y=865380
X3702 1633 138 2 1 1471 1657 MUX2 $T=361460 800240 0 0 $X=361460 $Y=799860
X3703 1557 145 2 1 1668 173 MUX2 $T=362080 699440 0 0 $X=362080 $Y=699060
X3704 1581 145 2 1 1666 165 MUX2 $T=363320 719600 1 0 $X=363320 $Y=714180
X3705 1648 144 2 1 1698 1683 MUX2 $T=363940 780080 1 0 $X=363940 $Y=774660
X3706 1588 105 2 1 1663 1675 MUX2 $T=364560 860720 0 0 $X=364560 $Y=860340
X3707 1650 1564 2 1 1519 1684 MUX2 $T=365180 800240 1 0 $X=365180 $Y=794820
X3708 1635 1659 2 1 1654 1696 MUX2 $T=366420 840560 0 0 $X=366420 $Y=840180
X3709 1663 1521 2 1 175 1699 MUX2 $T=366420 870800 1 0 $X=366420 $Y=865380
X3710 1644 127 2 1 1694 1698 MUX2 $T=367040 790160 0 0 $X=367040 $Y=789780
X3711 1599 127 2 1 1626 1700 MUX2 $T=367660 790160 1 0 $X=367660 $Y=784740
X3712 1627 1521 2 1 134 1708 MUX2 $T=370140 860720 0 0 $X=370140 $Y=860340
X3713 1681 138 2 1 1645 1711 MUX2 $T=370760 800240 0 0 $X=370760 $Y=799860
X3714 1696 1659 2 1 1675 1703 MUX2 $T=372000 840560 0 0 $X=372000 $Y=840180
X3715 1654 105 2 1 1665 1719 MUX2 $T=372000 860720 1 0 $X=372000 $Y=855300
X3716 1516 117 2 1 182 1729 MUX2 $T=372620 870800 1 0 $X=372620 $Y=865380
X3717 1703 1659 2 1 1719 1726 MUX2 $T=373240 850640 1 0 $X=373240 $Y=845220
X3718 1698 127 2 1 1684 1717 MUX2 $T=373860 790160 1 0 $X=373860 $Y=784740
X3719 1683 144 2 1 1700 1731 MUX2 $T=374480 780080 1 0 $X=374480 $Y=774660
X3720 1694 1564 2 1 1470 1733 MUX2 $T=374480 800240 1 0 $X=374480 $Y=794820
X3721 1731 1740 2 1 1717 1718 MUX2 $T=380060 770000 1 180 $X=375720 $Y=769620
X3722 1675 1725 2 1 1651 1739 MUX2 $T=375720 860720 0 0 $X=375720 $Y=860340
X3723 1481 138 2 1 1734 1741 MUX2 $T=376340 800240 0 0 $X=376340 $Y=799860
X3724 1717 1735 2 1 1733 1783 MUX2 $T=380060 790160 1 0 $X=380060 $Y=784740
X3725 1684 1564 2 1 1657 1758 MUX2 $T=380680 800240 1 0 $X=380680 $Y=794820
X3726 1700 1735 2 1 1744 1760 MUX2 $T=381300 780080 0 0 $X=381300 $Y=779700
X3727 1626 1564 2 1 1562 1775 MUX2 $T=384400 790160 0 0 $X=384400 $Y=789780
X3728 1519 1793 2 1 1801 1810 MUX2 $T=392460 800240 1 0 $X=392460 $Y=794820
X3729 1867 1735 2 1 1885 1879 MUX2 $T=415400 780080 0 0 $X=415400 $Y=779700
X3730 1883 1659 2 1 1884 1866 MUX2 $T=416640 840560 0 0 $X=416640 $Y=840180
X3731 1854 1725 2 1 1895 1866 MUX2 $T=417880 860720 0 0 $X=417880 $Y=860340
X3732 1884 1725 2 1 1935 1866 MUX2 $T=423460 860720 1 0 $X=423460 $Y=855300
X3733 221 117 2 1 1931 1866 MUX2 $T=423460 860720 0 0 $X=423460 $Y=860340
X3734 1886 1740 2 1 1919 1879 MUX2 $T=425320 770000 0 0 $X=425320 $Y=769620
X3735 1919 1735 2 1 1937 1879 MUX2 $T=426560 780080 1 0 $X=426560 $Y=774660
X3736 230 117 2 1 1952 1866 MUX2 $T=429040 860720 1 0 $X=429040 $Y=855300
X3737 1832 117 2 1 248 1866 MUX2 $T=429040 860720 0 0 $X=429040 $Y=860340
X3738 1862 1793 2 1 1959 1879 MUX2 $T=431520 800240 1 0 $X=431520 $Y=794820
X3739 1938 1793 2 1 1974 1879 MUX2 $T=432760 780080 0 0 $X=432760 $Y=779700
X3740 1896 1793 2 1 1975 1879 MUX2 $T=432760 790160 1 0 $X=432760 $Y=784740
X3741 1903 1793 2 1 1994 1879 MUX2 $T=435240 790160 0 0 $X=435240 $Y=789780
X3742 1940 117 2 1 1998 1866 MUX2 $T=436480 850640 1 0 $X=436480 $Y=845220
X3743 368 370 2 1 2488 367 MUX2 $T=545600 870800 1 0 $X=545600 $Y=865380
X3744 368 370 2 1 2533 379 MUX2 $T=552420 870800 1 0 $X=552420 $Y=865380
X3745 368 370 2 1 2537 380 MUX2 $T=553660 860720 1 0 $X=553660 $Y=855300
X3746 2157 370 2 1 2531 2038 MUX2 $T=560480 830480 0 180 $X=556140 $Y=825060
X3747 2196 370 2 1 2552 2161 MUX2 $T=557380 820400 0 0 $X=557380 $Y=820020
X3748 2172 370 2 1 2545 2178 MUX2 $T=564820 840560 0 180 $X=560480 $Y=835140
X3749 2350 370 2 1 2570 2393 MUX2 $T=569780 800240 0 180 $X=565440 $Y=794820
X3750 2350 370 2 1 2510 2172 MUX2 $T=573500 810320 0 180 $X=569160 $Y=804900
X3751 2350 370 2 1 2618 2352 MUX2 $T=571020 800240 1 0 $X=571020 $Y=794820
X3752 2350 370 2 1 2605 2196 MUX2 $T=575360 800240 1 180 $X=571020 $Y=799860
X3753 486 485 2 1 3009 2963 MUX2 $T=652860 699440 0 0 $X=652860 $Y=699060
X3754 492 485 2 1 2967 2997 MUX2 $T=657820 719600 0 180 $X=653480 $Y=714180
X3755 489 485 2 1 2995 3029 MUX2 $T=654720 729680 0 0 $X=654720 $Y=729300
X3756 500 485 2 1 2906 2996 MUX2 $T=663400 719600 1 180 $X=659060 $Y=719220
X3757 520 485 2 1 514 3097 MUX2 $T=677040 709520 1 180 $X=672700 $Y=709140
X3758 515 485 2 1 3107 3069 MUX2 $T=672700 729680 1 0 $X=672700 $Y=724260
X3759 527 485 2 1 3174 3054 MUX2 $T=681380 709520 1 0 $X=681380 $Y=704100
X3760 1174 1040 1205 1 2 XOR2H $T=269700 790160 1 0 $X=269700 $Y=784740
X3761 2165 2160 2190 1 2 XOR2H $T=476780 780080 0 0 $X=476780 $Y=779700
X3762 1066 1089 1071 2 1 1077 XNR3 $T=246760 780080 0 0 $X=246760 $Y=779700
X3763 1063 1075 1065 2 1 1043 XNR3 $T=248000 770000 0 0 $X=248000 $Y=769620
X3764 1229 1256 1186 2 1 1232 XNR3 $T=285200 759920 0 0 $X=285200 $Y=759540
X3765 1011 1387 1366 2 1 1364 XNR3 $T=308140 739760 1 0 $X=308140 $Y=734340
X3766 1401 1394 1404 2 1 1425 XNR3 $T=314960 770000 1 0 $X=314960 $Y=764580
X3767 1414 1421 1454 2 1 1407 XNR3 $T=315580 759920 0 0 $X=315580 $Y=759540
X3768 1593 1601 1638 2 1 1517 XNR3 $T=351540 770000 0 0 $X=351540 $Y=769620
X3769 1750 188 1715 2 1668 93 1 AO22S $T=383780 709520 0 180 $X=378820 $Y=704100
X3770 1908 27 1891 2 1868 1419 1 AO22S $T=424080 820400 0 180 $X=419120 $Y=814980
X3771 1956 27 1932 2 1901 1419 1 AO22S $T=430900 820400 0 180 $X=425940 $Y=814980
X3772 2013 2004 1950 2 1941 1419 1 AO22S $T=443920 800240 0 180 $X=438960 $Y=794820
X3773 2025 2004 2008 2 1900 1419 1 AO22S $T=445160 810320 0 180 $X=440200 $Y=804900
X3774 2006 27 1982 2 1927 1419 1 AO22S $T=450740 810320 1 180 $X=445780 $Y=809940
X3775 2044 2004 2037 2 1994 1419 1 AO22S $T=451980 790160 0 180 $X=447020 $Y=784740
X3776 2059 2004 2030 2 1930 1419 1 AO22S $T=455080 790160 1 180 $X=450120 $Y=789780
X3777 2070 2004 2053 2 1923 1419 1 AO22S $T=456320 810320 1 180 $X=451360 $Y=809940
X3778 2111 2004 2098 2 1943 1419 1 AO22S $T=463140 800240 1 180 $X=458180 $Y=799860
X3779 2125 2004 2103 2 1959 1419 1 AO22S $T=468100 790160 1 180 $X=463140 $Y=789780
X3780 2133 2004 2124 2 1975 1419 1 AO22S $T=469960 790160 0 180 $X=465000 $Y=784740
X3781 2784 2877 455 2 2883 458 1 AO22S $T=628060 790160 1 0 $X=628060 $Y=784740
X3782 2817 2877 460 2 2901 458 1 AO22S $T=631780 749840 1 0 $X=631780 $Y=744420
X3783 2892 2877 462 2 2902 458 1 AO22S $T=631780 780080 1 0 $X=631780 $Y=774660
X3784 2789 2877 464 2 2913 458 1 AO22S $T=634880 729680 0 0 $X=634880 $Y=729300
X3785 2821 453 467 2 2897 458 1 AO22S $T=635500 709520 1 0 $X=635500 $Y=704100
X3786 2900 2877 468 2 2908 458 1 AO22S $T=636740 800240 1 0 $X=636740 $Y=794820
X3787 2826 453 471 2 2931 458 1 AO22S $T=640460 699440 1 0 $X=640460 $Y=694020
X3788 2890 453 473 2 2938 458 1 AO22S $T=641080 719600 0 0 $X=641080 $Y=719220
X3789 2775 453 474 2 2939 458 1 AO22S $T=641080 729680 0 0 $X=641080 $Y=729300
X3790 2935 2877 476 2 2953 458 1 AO22S $T=643560 790160 0 0 $X=643560 $Y=789780
X3791 2968 2877 483 2 2957 458 1 AO22S $T=648520 790160 1 0 $X=648520 $Y=784740
X3792 3003 2877 491 2 3001 458 1 AO22S $T=659680 780080 1 180 $X=654720 $Y=779700
X3793 1066 10 1024 2 1031 7 1 AO22P $T=244280 780080 0 180 $X=238700 $Y=774660
X3794 36 1086 49 2 1074 52 1 AO22P $T=265360 860720 0 0 $X=265360 $Y=860340
X3795 1315 27 1339 2 1335 1097 1 AO22P $T=304420 810320 0 180 $X=298840 $Y=804900
X3796 1574 127 1583 2 1599 148 1 AO22P $T=348440 790160 1 0 $X=348440 $Y=784740
X3797 3 945 5 1 2 3 961 966 942 ICV_16 $T=220720 870800 1 0 $X=220720 $Y=865380
X3798 960 995 950 1 2 973 994 950 942 ICV_16 $T=233120 850640 1 0 $X=233120 $Y=845220
X3799 981 1036 1039 1 2 981 1045 25 942 ICV_16 $T=238080 840560 0 0 $X=238080 $Y=840180
X3800 1048 1051 1057 1 2 1048 1064 1070 942 ICV_16 $T=241180 820400 1 0 $X=241180 $Y=814980
X3801 1091 1106 1108 1 2 1091 1113 1116 942 ICV_16 $T=251100 850640 1 0 $X=251100 $Y=845220
X3802 1131 1137 27 1 2 1148 1153 1097 942 ICV_16 $T=259780 810320 0 0 $X=259780 $Y=809940
X3803 1134 1138 38 1 2 38 1149 1154 942 ICV_16 $T=259780 840560 0 0 $X=259780 $Y=840180
X3804 1136 1158 35 1 2 1128 1175 1152 942 ICV_16 $T=263500 749840 1 0 $X=263500 $Y=744420
X3805 58 1189 60 1 2 1212 1223 1221 942 ICV_16 $T=272800 860720 0 0 $X=272800 $Y=860340
X3806 1254 1234 69 1 2 1234 70 1211 942 ICV_16 $T=281480 870800 1 0 $X=281480 $Y=865380
X3807 1259 1261 1054 1 2 1054 1270 1276 942 ICV_16 $T=282720 770000 0 0 $X=282720 $Y=769620
X3808 1375 1383 52 1 2 1385 1397 49 942 ICV_16 $T=307520 860720 0 0 $X=307520 $Y=860340
X3809 1219 1398 1402 1 2 1380 1420 1402 942 ICV_16 $T=311860 770000 0 0 $X=311860 $Y=769620
X3810 1594 1597 136 1 2 1605 1609 105 942 ICV_16 $T=351540 860720 1 0 $X=351540 $Y=855300
X3811 1615 1618 144 1 2 1622 1624 160 942 ICV_16 $T=355260 790160 1 0 $X=355260 $Y=784740
X3812 1979 1965 1986 1 2 1968 1947 1997 942 ICV_16 $T=437720 739760 1 0 $X=437720 $Y=734340
X3813 1005 13 1012 1020 2 1 MXL2HS $T=231880 780080 0 0 $X=231880 $Y=779700
X3814 1041 16 1022 1061 2 1 MXL2HS $T=239320 709520 0 0 $X=239320 $Y=709140
X3815 1208 1200 1203 1198 2 1 MXL2HS $T=277140 749840 1 180 $X=271560 $Y=749460
X3816 1448 1521 111 1579 2 1 MXL2HS $T=345340 850640 0 0 $X=345340 $Y=850260
X3817 727 3765 3573 3781 2 1 MXL2HS $T=832040 719600 1 0 $X=832040 $Y=714180
X3818 1052 1087 1 1035 2 NR2T $T=244900 739760 0 0 $X=244900 $Y=739380
X3819 1162 1172 1 1135 2 NR2T $T=267840 729680 0 180 $X=262880 $Y=724260
X3820 1148 1442 1 1429 2 NR2T $T=318680 800240 0 0 $X=318680 $Y=799860
X3821 1103 1636 1 1429 2 NR2T $T=364560 780080 0 0 $X=364560 $Y=779700
X3822 453 3461 1 3441 2 NR2T $T=758880 699440 0 0 $X=758880 $Y=699060
X3823 1152 1135 1172 1 2 1147 OR3B1 $T=270940 749840 1 0 $X=270940 $Y=744420
X3824 93 1436 1441 1 2 1449 OR3B1 $T=318680 749840 1 0 $X=318680 $Y=744420
X3825 1602 2 150 1583 1 AN2B1S $T=352780 790160 0 0 $X=352780 $Y=789780
X3826 1097 1103 2 1114 1117 27 1 AOI22H $T=249860 810320 1 0 $X=249860 $Y=804900
X3827 983 10 1038 1 2 1142 OA12 $T=250480 759920 1 0 $X=250480 $Y=754500
X3828 1097 27 1105 1 2 1049 OA12 $T=254200 810320 1 180 $X=250480 $Y=809940
X3829 1152 35 1157 1 2 1161 OA12 $T=270940 749840 1 180 $X=267220 $Y=749460
X3830 52 49 1248 1 2 62 OA12 $T=282720 860720 0 180 $X=279000 $Y=855300
X3831 93 1488 1461 1 2 1390 OA12 $T=332940 749840 0 180 $X=329220 $Y=744420
X3832 2863 2888 2829 1 2 2907 OA12 $T=631780 800240 1 0 $X=631780 $Y=794820
X3833 2999 3002 2955 1 2 3012 OA12 $T=653480 800240 0 0 $X=653480 $Y=799860
X3834 1067 1094 1 1170 2 AN2S $T=258540 800240 1 0 $X=258540 $Y=794820
X3835 1292 12 1 1227 2 AN2S $T=289540 820400 0 0 $X=289540 $Y=820020
X3836 1576 1556 1 1605 2 AN2S $T=356500 850640 0 180 $X=354020 $Y=845220
X3837 1399 1405 1 1418 1395 2 OAI12H $T=311860 810320 0 0 $X=311860 $Y=809940
X3838 1080 27 1 1067 988 27 2 MOAI1H $T=249240 810320 0 180 $X=241800 $Y=804900
X3839 1230 52 1 1210 57 52 2 MOAI1H $T=278380 860720 0 180 $X=270940 $Y=855300
X3840 1309 52 1 1323 1254 1333 2 MOAI1H $T=293260 860720 0 0 $X=293260 $Y=860340
X3841 3573 179 1 2 INV4 $T=771280 709520 1 180 $X=768180 $Y=709140
X3842 459 2664 444 1 2 449 AO12 $T=629920 699440 0 180 $X=626200 $Y=694020
X3843 459 2657 444 1 2 465 AO12 $T=633020 699440 0 0 $X=633020 $Y=699060
X3844 459 2780 444 1 2 480 AO12 $T=645420 699440 1 0 $X=645420 $Y=694020
X3845 539 3247 501 1 2 573 AO12 $T=709280 699440 1 0 $X=709280 $Y=694020
X3846 539 3291 501 1 2 582 AO12 $T=713000 699440 1 0 $X=713000 $Y=694020
X3847 539 3353 501 1 2 606 AO12 $T=730980 699440 1 0 $X=730980 $Y=694020
X3848 539 589 501 1 2 607 AO12 $T=734080 699440 0 0 $X=734080 $Y=699060
X3849 3454 3461 3451 1 2 3467 AO12 $T=753920 699440 0 0 $X=753920 $Y=699060
X3850 665 3553 661 1 2 291 AO12 $T=776860 739760 1 180 $X=773140 $Y=739380
X3851 666 3554 661 1 2 295 AO12 $T=776860 749840 0 180 $X=773140 $Y=744420
X3852 666 3563 3561 1 2 3555 AO12 $T=778720 759920 0 180 $X=775000 $Y=754500
X3853 666 3580 3561 1 2 228 AO12 $T=781820 739760 0 180 $X=778100 $Y=734340
X3854 666 3581 661 1 2 280 AO12 $T=781820 749840 0 180 $X=778100 $Y=744420
X3855 666 3586 3561 1 2 232 AO12 $T=783060 729680 0 180 $X=779340 $Y=724260
X3856 665 3593 3561 1 2 3570 AO12 $T=785540 739760 0 180 $X=781820 $Y=734340
X3857 666 3596 661 1 2 273 AO12 $T=786780 749840 0 180 $X=783060 $Y=744420
X3858 666 3605 3561 1 2 227 AO12 $T=789260 739760 0 180 $X=785540 $Y=734340
X3859 666 3620 3561 1 2 3566 AO12 $T=792980 749840 1 180 $X=789260 $Y=749460
X3860 666 3621 3561 1 2 3613 AO12 $T=792980 759920 0 180 $X=789260 $Y=754500
X3861 666 3680 661 1 2 3474 AO12 $T=809100 749840 0 180 $X=805380 $Y=744420
X3862 666 3707 661 1 2 700 AO12 $T=815920 739760 1 180 $X=812200 $Y=739380
X3863 1572 1625 2 1598 1 1649 AN3B2S $T=357120 729680 0 0 $X=357120 $Y=729300
X3864 1613 1616 1598 1 2 AN2B1T $T=354020 729680 1 0 $X=354020 $Y=724260
X3865 3597 749 1 2 739 QDLHN $T=850640 810320 0 180 $X=843200 $Y=804900
X3866 3597 748 1 2 741 QDLHN $T=851880 820400 0 180 $X=844440 $Y=814980
X3867 3597 751 1 2 742 QDLHN $T=852500 820400 1 180 $X=845060 $Y=820020
X3868 3597 752 1 2 757 QDLHN $T=859940 820400 0 180 $X=852500 $Y=814980
X3869 748 744 3597 3814 2 1 749 XOR4 $T=846300 709520 0 0 $X=846300 $Y=709140
X3870 3454 3494 3488 1 2 3513 AO12S $T=762600 709520 0 0 $X=762600 $Y=709140
X3871 666 3682 661 1 2 697 AO12S $T=809100 729680 1 180 $X=805380 $Y=729300
X3872 673 674 3579 3634 1 2 MXL2HP $T=780580 699440 1 0 $X=780580 $Y=694020
X3873 178 3579 1 2 INV8 $T=778100 699440 0 0 $X=778100 $Y=699060
X3874 3428 3423 1 2 594 OR2B1 $T=750200 820400 1 180 $X=746480 $Y=820020
X3875 3028 3378 1 2 BUF4 $T=730980 860720 1 0 $X=730980 $Y=855300
X3876 234 1 2 235 1898 240 942 ICV_18 $T=425320 699440 1 0 $X=425320 $Y=694020
X3877 260 1 2 1985 266 2003 942 ICV_18 $T=440820 709520 1 0 $X=440820 $Y=704100
X3878 2042 1 2 2040 269 276 942 ICV_18 $T=451360 709520 1 0 $X=451360 $Y=704100
X3879 2510 1 2 2528 2529 2549 942 ICV_18 $T=551180 810320 1 0 $X=551180 $Y=804900
X3880 2545 1 2 2607 2578 2631 942 ICV_18 $T=567300 840560 1 0 $X=567300 $Y=835140
X3881 2609 1 2 2623 2605 2650 942 ICV_18 $T=572880 780080 0 0 $X=572880 $Y=779700
X3882 2682 1 2 2680 2705 2708 942 ICV_18 $T=590860 729680 1 0 $X=590860 $Y=724260
X3883 2891 1 2 2940 2882 2969 942 ICV_18 $T=639840 739760 1 0 $X=639840 $Y=734340
X3884 456 1 2 2961 446 2991 942 ICV_18 $T=642940 840560 0 0 $X=642940 $Y=840180
X3885 2842 1 2 3073 3079 3029 942 ICV_18 $T=664020 739760 0 0 $X=664020 $Y=739380
X3886 3084 1 2 3104 3085 3090 942 ICV_18 $T=669600 790160 0 0 $X=669600 $Y=789780
X3887 2837 1 2 3180 2768 3230 942 ICV_18 $T=681380 759920 1 0 $X=681380 $Y=754500
X3888 3174 1 2 3113 3198 586 942 ICV_18 $T=710520 699440 0 0 $X=710520 $Y=699060
X3889 1742 190 1695 1 2 1785 XOR3T $T=381300 820400 0 0 $X=381300 $Y=820020
X3890 2641 2341 2660 1 2 2688 XOR3T $T=588380 709520 1 0 $X=588380 $Y=704100
X3891 2190 2214 2219 1 2 XNR2H $T=482360 840560 0 0 $X=482360 $Y=840180
X3892 2104 279 2086 2168 1 2 XOR3P $T=465620 850640 0 0 $X=465620 $Y=850260
X3893 2153 290 2113 2159 1 2 XOR3P $T=479260 860720 0 0 $X=479260 $Y=860340
X3894 1804 1813 1820 1787 1 2 1846 AO13 $T=406100 709520 0 0 $X=406100 $Y=709140
X3895 1890 1877 1897 1916 1 2 1933 AO13 $T=425940 830480 0 0 $X=425940 $Y=830100
X3896 1563 100 118 113 2 1 1472 OA13 $T=348440 780080 1 180 $X=343480 $Y=779700
X3897 34 1129 1144 2 1135 1104 1 MUXB2 $T=257300 729680 0 0 $X=257300 $Y=729300
X3898 102 1501 1537 2 1436 1552 1 MUXB2 $T=339760 739760 1 0 $X=339760 $Y=734340
X3899 1268 11 20 2 1 1334 QDFFRBS $T=283960 780080 1 0 $X=283960 $Y=774660
X3900 35 1207 1218 1174 1 2 AO12P $T=273420 739760 0 0 $X=273420 $Y=739380
.ENDS
***************************************
.SUBCKT OAI22H B2 B1 GND A2 O A1 VCC
** N=8 EP=7 IP=0 FDC=0
.ENDS
***************************************
.SUBCKT HA1 A B C GND VCC S
** N=7 EP=6 IP=0 FDC=0
.ENDS
***************************************
.SUBCKT ICV_20 1 2 3 4 5 6 7
** N=7 EP=7 IP=10 FDC=0
X0 1 2 3 4 DELC $T=0 0 0 0 $X=0 $Y=-380
X1 5 2 3 6 DELC $T=4960 0 0 0 $X=4960 $Y=-380
.ENDS
***************************************
.SUBCKT ICV_21 1 2 3 4 5 6 7 8 9 10 11
** N=11 EP=11 IP=14 FDC=0
X0 1 2 3 4 5 6 XOR3 $T=6200 0 0 0 $X=6200 $Y=-380
X1 7 8 9 10 5 4 MAO222P $T=0 0 0 0 $X=0 $Y=-380
.ENDS
***************************************
.SUBCKT INV6 I O GND VCC
** N=5 EP=4 IP=0 FDC=0
.ENDS
***************************************
.SUBCKT OAI112H C2 C1 GND B1 O A1 VCC
** N=8 EP=7 IP=0 FDC=0
.ENDS
***************************************
.SUBCKT AO13P B3 B2 B1 A1 O GND VCC
** N=8 EP=7 IP=0 FDC=0
.ENDS
***************************************
.SUBCKT NR3HP O I3 I2 I1 GND VCC
** N=7 EP=6 IP=0 FDC=0
.ENDS
***************************************
.SUBCKT NR3H O I3 I2 I1 VCC GND
** N=7 EP=6 IP=0 FDC=0
.ENDS
***************************************
.SUBCKT DFFN D CK Q GND VCC QB
** N=7 EP=6 IP=0 FDC=0
.ENDS
***************************************
.SUBCKT DFFRBP D CK RB Q QB GND VCC
** N=8 EP=7 IP=0 FDC=0
.ENDS
***************************************
.SUBCKT INV12 O I GND VCC
** N=5 EP=4 IP=0 FDC=0
.ENDS
***************************************
.SUBCKT MOAI1HT B1 B2 GND A1 O A2 VCC
** N=8 EP=7 IP=0 FDC=0
.ENDS
***************************************
.SUBCKT BUF12CK I GND VCC O
** N=5 EP=4 IP=0 FDC=0
.ENDS
***************************************
.SUBCKT ICV_22 1 2 3 4 5 6 7 8 9 10 11
** N=11 EP=11 IP=14 FDC=0
X0 1 2 3 4 5 6 MUX2S $T=0 0 1 0 $X=0 $Y=-5420
X1 7 8 3 9 5 10 MUX2S $T=0 0 0 0 $X=0 $Y=-380
.ENDS
***************************************
.SUBCKT OR3B2S I1 B1 VCC O B2 GND
** N=7 EP=6 IP=0 FDC=0
.ENDS
***************************************
.SUBCKT XOR2HT I1 I2 O GND VCC
** N=6 EP=5 IP=0 FDC=0
.ENDS
***************************************
.SUBCKT ICV_23 1 2 3 4 5 6 7 8 9 10 11 12 13 14 15 16 17 18 19 20
+ 21 22 23 24 25 26 27 28 29 30 31 32 33 34 35 36 37 38 39 40
+ 41 42 43 44 45 46 47 48 49 50 51 52 53 54 55 56 57 58 59 60
+ 61 62 63 64 65 66 67 68 69 70 71 72 73 74 75 76 77 78 79 80
+ 81 82 83 84 85 86 87 88 89 90 91 92 93 94 95 96 97 98 99 100
+ 101 102 103 104 105 106 107 108 109 110 111 112 113 114 115 116 117 118 119 120
+ 121 122 123 124 125 126 127 128 129 130 131 132 133 134 135 136 137 138 139 140
+ 141 142 143 144 145 146 147 148 149 150 151 152 153 154 155 156 157 158 159 160
+ 161 162 163 164 165 166 167 168 169 170 171 172 173 174 175 176 177 178 179 180
+ 181 182 183 184 185 186 187 188 189 190 191 192 193 194 195 196 197 198 199 200
+ 201 202 203 204 205 206 207 208 209 210 211 212 213 214 215 216 217 218 219 220
+ 221 222 223 224 225 226 227 228 229 230 231 232 233 234 235 236 237 238 239 240
+ 241 242 243 244 245 246 247 248 249 250 251 252 253 254 255 256 257 258 259 260
+ 261 262 263 264 265 266 267 268 269 270 271 272 273 274 275 276 277 278 279 280
+ 281 282 283 284 285 286 287 288 289 290 291 292 293 294 295 296 297 298 299 300
+ 301 302 303 304 305 306 307 308 309 310 311 312 313 314 315 316 317 318 319 320
+ 321 322 323 324 325 326 327 328 329 330 331 332 333 334 335 336 337 338 339 340
+ 341 342 343 344 345 346 347 348 349 350 351 352 353 354 355 356 357 358 359 360
+ 361 362 363 364 365 366 367 368 369 370 371 372 373 374 375 376 377 378 379 380
+ 381 382 383 384 385 386 387 388 389 390 391 392 393 394 395 396 397 398 399 400
+ 401 402 403 404 405 406 407 408 409 410 411 412 413 414 415 416 417 418 419 420
+ 421 422 423 424 425 426 427 428 429 430 431 432 433 434 435 436 437 438 439 440
+ 441 442 443 444 445 446 447 448 449 450 451 452 453 454 455 456 457 458 459 460
+ 461 462 463 464 465 466 467 468 469 470 471 472 473 474 475 476 477 478 479 480
+ 481 482 483 484 485 486 487 488 489 490 491 492 493 494 495 496 497 498 499 500
+ 501 502 503 504 505 506 507 508 509 510 511 512 513 514 515 516 517 518 519 520
+ 521 522 523 524 525 526 527 528 529 530 531 532 533 534 535 536 537 538 539 540
+ 541 542 543 544 545 546 547 548 549 550 551 552 553 554 555 556 557 558 559 560
+ 561 562 563 564 565 566 567 568 569 570 571 572 573 574 575 576 577 578 579 580
+ 581 582 583 584 585 586 587 588 589 590 591 592 593 594 595 596 597 598 599 600
+ 601 602 603 604 605 606 607 608 609 610 611 612 613 614 615 616 617 618 619 620
+ 621 622 623 624 625 626 627 628 629 630 631 632 633 634 635 636 637 638 639 640
+ 641 642 643 644 645 646 647 648 649 650 651 652 653 654 655 656 657 658 659 660
+ 661 662 663 664 665 666 667 668 669 670 671 672 673 674 675 676 677 678 679 680
+ 681 682 683 684 685 686 687 688 689 690 691 692 693 694 695 696 697 698 699 700
+ 701 702 703 704 705 706 707 708 709 710 711 712 713 714 715 716 717 718 719 720
+ 721 722 723 724 725 726 727 728 729 730 731 732 733 734 735 736 737 738 739 740
+ 741 742 743 744 745 746 747 748 749 750 751 752 753 754 755 756 757 758 759 760
+ 761 762 763 764 765 766 767 768 769 770 771 772 773 774 775 776 777 778 779 780
+ 781 782 783 784 785 786 787 788 789 790 791 792 793 794 795 796 797 798 799 800
+ 801 802 803 804 805 806 807 808 809 810 811 812 813 814 815 816 817 818 819 820
+ 821 822 823 824 825 826 827 828 829 830 831 832 833 834 835 836 837 838 839 840
+ 841 842 843 844 845 846 847 848 849 859
** N=4373 EP=850 IP=24244 FDC=0
X0 1735 193 1817 1 2 QDFFN $T=420980 608720 1 0 $X=420980 $Y=603300
X1 1730 193 1807 1 2 QDFFN $T=421600 628880 1 0 $X=421600 $Y=623460
X2 1774 193 1820 1 2 QDFFN $T=422220 598640 0 0 $X=422220 $Y=598260
X3 1775 193 1844 1 2 QDFFN $T=422840 598640 1 0 $X=422840 $Y=593220
X4 1789 1795 1825 1 2 QDFFN $T=425940 568400 0 0 $X=425940 $Y=568020
X5 1856 1821 1798 1 2 QDFFN $T=439580 548240 1 180 $X=429040 $Y=547860
X6 1797 1795 1847 1 2 QDFFN $T=429040 568400 1 0 $X=429040 $Y=562980
X7 1845 1821 1800 1 2 QDFFN $T=440200 538160 1 180 $X=429660 $Y=537780
X8 1809 1795 1848 1 2 QDFFN $T=432140 578480 0 0 $X=432140 $Y=578100
X9 1811 1821 1862 1 2 QDFFN $T=432760 558320 1 0 $X=432760 $Y=552900
X10 1780 193 1857 1 2 QDFFN $T=432760 618800 0 0 $X=432760 $Y=618420
X11 1764 193 1878 1 2 QDFFN $T=434000 618800 1 0 $X=434000 $Y=613380
X12 1877 1821 1812 1 2 QDFFN $T=445160 528080 1 180 $X=434620 $Y=527700
X13 1781 193 1864 1 2 QDFFN $T=435240 608720 0 0 $X=435240 $Y=608340
X14 1910 1821 1836 1 2 QDFFN $T=449500 548240 0 180 $X=438960 $Y=542820
X15 1861 1821 1907 1 2 QDFFN $T=442680 548240 0 0 $X=442680 $Y=547860
X16 1918 1821 1866 1 2 QDFFN $T=453840 538160 0 180 $X=443300 $Y=532740
X17 1869 193 1916 1 2 QDFFN $T=444540 598640 0 0 $X=444540 $Y=598260
X18 1875 1795 1926 1 2 QDFFN $T=445160 578480 1 0 $X=445160 $Y=573060
X19 1885 1821 1919 1 2 QDFFN $T=447640 568400 1 0 $X=447640 $Y=562980
X20 1768 193 1900 1 2 QDFFN $T=448260 608720 1 0 $X=448260 $Y=603300
X21 1961 1821 1903 1 2 QDFFN $T=463140 548240 0 180 $X=452600 $Y=542820
X22 1752 193 1971 1 2 QDFFN $T=453840 608720 0 0 $X=453840 $Y=608340
X23 1923 1821 1970 1 2 QDFFN $T=455700 548240 0 0 $X=455700 $Y=547860
X24 1934 1821 1988 1 2 QDFFN $T=457560 558320 1 0 $X=457560 $Y=552900
X25 1850 193 1985 1 2 QDFFN $T=460040 588560 1 0 $X=460040 $Y=583140
X26 2002 1795 1954 1 2 QDFFN $T=471820 578480 0 180 $X=461280 $Y=573060
X27 1953 1821 1980 1 2 QDFFN $T=461280 608720 1 0 $X=461280 $Y=603300
X28 1967 1821 1895 1 2 QDFFN $T=463760 538160 0 0 $X=463760 $Y=537780
X29 1968 1795 2001 1 2 QDFFN $T=466860 568400 0 0 $X=466860 $Y=568020
X30 1987 1821 2033 1 2 QDFFN $T=468720 548240 0 0 $X=468720 $Y=547860
X31 2012 1795 2042 1 2 QDFFN $T=474300 578480 1 0 $X=474300 $Y=573060
X32 2007 193 2032 1 2 QDFFN $T=475540 608720 1 0 $X=475540 $Y=603300
X33 1794 193 2055 1 2 QDFFN $T=478020 588560 0 0 $X=478020 $Y=588180
X34 2030 1795 2046 1 2 QDFFN $T=481740 588560 1 0 $X=481740 $Y=583140
X35 2095 1821 2024 1 2 QDFFN $T=493520 618800 0 180 $X=482980 $Y=613380
X36 1981 193 2126 1 2 QDFFN $T=491040 608720 0 0 $X=491040 $Y=608340
X37 2014 1795 2144 1 2 QDFFN $T=494760 588560 1 0 $X=494760 $Y=583140
X38 2183 1795 2129 1 2 QDFFN $T=508400 608720 0 180 $X=497860 $Y=603300
X39 2134 1795 2220 1 2 QDFFN $T=502820 618800 0 0 $X=502820 $Y=618420
X40 1957 1795 2158 1 2 QDFFN $T=506540 598640 0 0 $X=506540 $Y=598260
X41 2179 1795 2237 1 2 QDFFN $T=508400 608720 1 0 $X=508400 $Y=603300
X42 2180 326 2177 1 2 QDFFN $T=511500 638960 1 0 $X=511500 $Y=633540
X43 2207 326 2270 1 2 QDFFN $T=515840 628880 0 0 $X=515840 $Y=628500
X44 2152 326 2255 1 2 QDFFN $T=516460 618800 0 0 $X=516460 $Y=618420
X45 2324 356 2249 1 2 QDFFN $T=536300 618800 0 180 $X=525760 $Y=613380
X46 2151 326 2335 1 2 QDFFN $T=526380 628880 1 0 $X=526380 $Y=623460
X47 2174 326 2342 1 2 QDFFN $T=529480 628880 0 0 $X=529480 $Y=628500
X48 2015 326 2347 1 2 QDFFN $T=531960 638960 1 0 $X=531960 $Y=633540
X49 2194 326 2354 1 2 QDFFN $T=533200 638960 0 0 $X=533200 $Y=638580
X50 2312 356 2332 1 2 QDFFN $T=534440 618800 0 0 $X=534440 $Y=618420
X51 2327 356 2396 1 2 QDFFN $T=543120 628880 0 0 $X=543120 $Y=628500
X52 2357 356 2359 1 2 QDFFN $T=558620 628880 0 180 $X=548080 $Y=623460
X53 2383 356 2425 1 2 QDFFN $T=551180 618800 0 0 $X=551180 $Y=618420
X54 2376 356 2426 1 2 QDFFN $T=556760 628880 0 0 $X=556760 $Y=628500
X55 2440 356 2485 1 2 QDFFN $T=564820 618800 1 0 $X=564820 $Y=613380
X56 2106 385 2504 1 2 QDFFN $T=566060 638960 1 0 $X=566060 $Y=633540
X57 2489 356 2520 1 2 QDFFN $T=575360 628880 1 0 $X=575360 $Y=623460
X58 2079 385 2552 1 2 QDFFN $T=583420 638960 0 0 $X=583420 $Y=638580
X59 2596 356 2512 1 2 QDFFN $T=597680 608720 1 180 $X=587140 $Y=608340
X60 2550 356 2570 1 2 QDFFN $T=587760 618800 0 0 $X=587760 $Y=618420
X61 2572 1795 2617 1 2 QDFFN $T=593340 628880 1 0 $X=593340 $Y=623460
X62 2616 385 2650 1 2 QDFFN $T=600780 628880 0 0 $X=600780 $Y=628500
X63 2619 356 2662 1 2 QDFFN $T=601400 608720 1 0 $X=601400 $Y=603300
X64 2036 385 2663 1 2 QDFFN $T=606980 659120 0 0 $X=606980 $Y=658740
X65 2639 1795 2666 1 2 QDFFN $T=607600 628880 1 0 $X=607600 $Y=623460
X66 2710 356 2657 1 2 QDFFN $T=623720 618800 0 180 $X=613180 $Y=613380
X67 427 356 2707 1 2 QDFFN $T=615660 689360 0 0 $X=615660 $Y=688980
X68 2714 326 2652 1 2 QDFFN $T=626820 628880 1 180 $X=616280 $Y=628500
X69 2723 356 2677 1 2 QDFFN $T=628680 618800 1 180 $X=618140 $Y=618420
X70 431 356 2711 1 2 QDFFN $T=618140 679280 0 0 $X=618140 $Y=678900
X71 2732 356 2688 1 2 QDFFN $T=629920 628880 0 180 $X=619380 $Y=623460
X72 2554 385 2724 1 2 QDFFN $T=619380 669200 1 0 $X=619380 $Y=663780
X73 2696 385 2706 1 2 QDFFN $T=621860 659120 1 0 $X=621860 $Y=653700
X74 2748 193 2702 1 2 QDFFN $T=635500 669200 1 180 $X=624960 $Y=668820
X75 2738 326 2713 1 2 QDFFN $T=636740 649040 0 180 $X=626200 $Y=643620
X76 2757 326 2546 1 2 QDFFN $T=637360 628880 1 180 $X=626820 $Y=628500
X77 2716 1795 2755 1 2 QDFFN $T=628060 649040 0 0 $X=628060 $Y=648660
X78 2758 1821 446 1 2 QDFFN $T=639840 578480 0 180 $X=629300 $Y=573060
X79 2765 1821 450 1 2 QDFFN $T=641080 568400 1 180 $X=630540 $Y=568020
X80 448 356 2741 1 2 QDFFN $T=630540 679280 0 0 $X=630540 $Y=678900
X81 2764 193 452 1 2 QDFFN $T=642940 618800 1 180 $X=632400 $Y=618420
X82 2771 193 451 1 2 QDFFN $T=642940 628880 0 180 $X=632400 $Y=623460
X83 2770 193 453 1 2 QDFFN $T=643560 608720 1 180 $X=633020 $Y=608340
X84 2742 2740 2813 1 2 QDFFN $T=633020 669200 1 0 $X=633020 $Y=663780
X85 2746 2740 2762 1 2 QDFFN $T=634260 659120 1 0 $X=634260 $Y=653700
X86 2788 1821 2745 1 2 QDFFN $T=647280 588560 0 180 $X=636740 $Y=583140
X87 2786 193 460 1 2 QDFFN $T=647900 598640 1 180 $X=637360 $Y=598260
X88 2756 1795 2800 1 2 QDFFN $T=638600 649040 1 0 $X=638600 $Y=643620
X89 2793 1821 464 1 2 QDFFN $T=650380 588560 1 180 $X=639840 $Y=588180
X90 2811 1821 469 1 2 QDFFN $T=652240 568400 0 180 $X=641700 $Y=562980
X91 2806 1821 2733 1 2 QDFFN $T=652240 578480 0 180 $X=641700 $Y=573060
X92 2808 1821 471 1 2 QDFFN $T=653480 568400 1 180 $X=642940 $Y=568020
X93 2809 193 473 1 2 QDFFN $T=653480 638960 0 180 $X=642940 $Y=633540
X94 468 2740 2805 1 2 QDFFN $T=643560 679280 0 0 $X=643560 $Y=678900
X95 2827 1821 2776 1 2 QDFFN $T=655960 608720 1 180 $X=645420 $Y=608340
X96 2787 1795 2844 1 2 QDFFN $T=648520 638960 0 0 $X=648520 $Y=638580
X97 2847 1821 480 1 2 QDFFN $T=660920 558320 1 180 $X=650380 $Y=557940
X98 487 2740 2867 1 2 QDFFN $T=654720 689360 0 0 $X=654720 $Y=688980
X99 2780 2740 2882 1 2 QDFFN $T=656580 669200 0 0 $X=656580 $Y=668820
X100 2817 2740 2874 1 2 QDFFN $T=656580 679280 0 0 $X=656580 $Y=678900
X101 2877 1821 492 1 2 QDFFN $T=668980 578480 0 180 $X=658440 $Y=573060
X102 2861 1821 2893 1 2 QDFFN $T=662160 608720 1 0 $X=662160 $Y=603300
X103 2931 326 509 1 2 QDFFN $T=677660 669200 1 180 $X=667120 $Y=668820
X104 2887 326 524 1 2 QDFFN $T=668360 679280 0 0 $X=668360 $Y=678900
X105 2952 326 516 1 2 QDFFN $T=683240 659120 1 180 $X=672700 $Y=658740
X106 2868 326 2920 1 2 QDFFN $T=688200 669200 1 180 $X=677660 $Y=668820
X107 2971 326 2934 1 2 QDFFN $T=691300 689360 0 180 $X=680760 $Y=683940
X108 533 2740 2996 1 2 QDFFN $T=683240 679280 1 0 $X=683240 $Y=673860
X109 2946 326 548 1 2 QDFFN $T=686340 679280 0 0 $X=686340 $Y=678900
X110 3033 326 3005 1 2 QDFFN $T=704940 679280 0 180 $X=694400 $Y=673860
X111 3014 2740 3035 1 2 QDFFN $T=696880 669200 0 0 $X=696880 $Y=668820
X112 3053 326 551 1 2 QDFFN $T=708660 689360 0 180 $X=698120 $Y=683940
X113 2994 2740 3055 1 2 QDFFN $T=699360 659120 0 0 $X=699360 $Y=658740
X114 557 2740 3066 1 2 QDFFN $T=706180 669200 1 0 $X=706180 $Y=663780
X115 3086 326 558 1 2 QDFFN $T=717960 679280 0 180 $X=707420 $Y=673860
X116 3059 326 567 1 2 QDFFN $T=709900 669200 0 0 $X=709900 $Y=668820
X117 2894 385 3000 1 2 QDFFN $T=709900 689360 0 0 $X=709900 $Y=688980
X118 3074 2740 3098 1 2 QDFFN $T=713000 659120 0 0 $X=713000 $Y=658740
X119 3126 326 564 1 2 QDFFN $T=724160 689360 0 180 $X=713620 $Y=683940
X120 3150 326 569 1 2 QDFFN $T=730980 679280 0 180 $X=720440 $Y=673860
X121 3117 2740 3151 1 2 QDFFN $T=721680 669200 1 0 $X=721680 $Y=663780
X122 3141 2740 3112 1 2 QDFFN $T=733460 669200 1 180 $X=722920 $Y=668820
X123 3111 326 587 1 2 QDFFN $T=726640 679280 0 0 $X=726640 $Y=678900
X124 3133 2740 3170 1 2 QDFFN $T=727260 659120 0 0 $X=727260 $Y=658740
X125 579 2740 3200 1 2 QDFFN $T=733460 679280 1 0 $X=733460 $Y=673860
X126 3190 326 582 1 2 QDFFN $T=744620 689360 1 180 $X=734080 $Y=688980
X127 584 2740 3209 1 2 QDFFN $T=735940 669200 1 0 $X=735940 $Y=663780
X128 583 2740 3201 1 2 QDFFN $T=735940 669200 0 0 $X=735940 $Y=668820
X129 3263 326 589 1 2 QDFFN $T=749580 679280 1 180 $X=739040 $Y=678900
X130 639 1795 3417 1 2 QDFFN $T=785540 638960 0 0 $X=785540 $Y=638580
X131 642 1795 3429 1 2 QDFFN $T=788640 638960 1 0 $X=788640 $Y=633540
X132 3729 750 3744 1 2 QDFFN $T=874820 649040 0 0 $X=874820 $Y=648660
X133 749 755 3732 1 2 QDFFN $T=885980 679280 0 180 $X=875440 $Y=673860
X134 3733 750 3747 1 2 QDFFN $T=876680 659120 1 0 $X=876680 $Y=653700
X135 3685 750 3748 1 2 QDFFN $T=877920 538160 1 0 $X=877920 $Y=532740
X136 3701 755 3752 1 2 QDFFN $T=879780 628880 1 0 $X=879780 $Y=623460
X137 3701 750 3755 1 2 QDFFN $T=881020 628880 0 0 $X=881020 $Y=628500
X138 747 756 765 1 2 QDFFN $T=881640 528080 1 0 $X=881640 $Y=522660
X139 749 756 3750 1 2 QDFFN $T=881640 679280 0 0 $X=881640 $Y=678900
X140 3733 756 3751 1 2 QDFFN $T=883500 659120 0 0 $X=883500 $Y=658740
X141 3685 756 3758 1 2 QDFFN $T=884740 528080 0 0 $X=884740 $Y=527700
X142 3678 756 3759 1 2 QDFFN $T=884740 598640 0 0 $X=884740 $Y=598260
X143 3737 755 3760 1 2 QDFFN $T=886600 558320 1 0 $X=886600 $Y=552900
X144 3677 750 3767 1 2 QDFFN $T=887840 548240 1 0 $X=887840 $Y=542820
X145 3665 750 3770 1 2 QDFFN $T=888460 608720 0 0 $X=888460 $Y=608340
X146 3718 750 3768 1 2 QDFFN $T=888460 638960 1 0 $X=888460 $Y=633540
X147 3729 755 3771 1 2 QDFFN $T=888460 649040 0 0 $X=888460 $Y=648660
X148 714 755 3769 1 2 QDFFN $T=889080 669200 0 0 $X=889080 $Y=668820
X149 3737 756 3765 1 2 QDFFN $T=889700 558320 0 0 $X=889700 $Y=557940
X150 3678 755 3779 1 2 QDFFN $T=889700 598640 1 0 $X=889700 $Y=593220
X151 3720 750 3772 1 2 QDFFN $T=889700 649040 1 0 $X=889700 $Y=643620
X152 3686 756 3776 1 2 QDFFN $T=890320 588560 1 0 $X=890320 $Y=583140
X153 3685 755 3774 1 2 QDFFN $T=890940 538160 1 0 $X=890940 $Y=532740
X154 749 750 3754 1 2 QDFFN $T=901480 689360 1 180 $X=890940 $Y=688980
X155 3714 750 3777 1 2 QDFFN $T=892180 628880 1 0 $X=892180 $Y=623460
X156 714 750 3773 1 2 QDFFN $T=892180 689360 1 0 $X=892180 $Y=683940
X157 3714 756 3784 1 2 QDFFN $T=894040 628880 0 0 $X=894040 $Y=628500
X158 747 750 768 1 2 QDFFN $T=894660 528080 1 0 $X=894660 $Y=522660
X159 3665 756 3778 1 2 QDFFN $T=894660 608720 1 0 $X=894660 $Y=603300
X160 3701 756 3781 1 2 QDFFN $T=894660 618800 0 0 $X=894660 $Y=618420
X161 714 756 3785 1 2 QDFFN $T=895280 679280 0 0 $X=895280 $Y=678900
X162 3700 756 3783 1 2 QDFFN $T=896520 548240 0 0 $X=896520 $Y=547860
X163 3733 755 3757 1 2 QDFFN $T=907680 659120 1 180 $X=897140 $Y=658740
X164 3737 750 3764 1 2 QDFFN $T=908300 568400 0 180 $X=897760 $Y=562980
X165 3678 750 3790 1 2 QDFFN $T=897760 598640 0 0 $X=897760 $Y=598260
X166 3738 750 3789 1 2 QDFFN $T=898380 578480 1 0 $X=898380 $Y=573060
X167 3729 756 3793 1 2 QDFFN $T=899000 659120 1 0 $X=899000 $Y=653700
X168 3677 756 3806 1 2 QDFFN $T=900240 548240 1 0 $X=900240 $Y=542820
X169 3718 756 3801 1 2 QDFFN $T=900860 638960 1 0 $X=900860 $Y=633540
X170 3665 755 3795 1 2 QDFFN $T=902100 608720 0 0 $X=902100 $Y=608340
X171 3720 756 3816 1 2 QDFFN $T=902100 649040 0 0 $X=902100 $Y=648660
X172 3720 755 3815 1 2 QDFFN $T=902720 649040 1 0 $X=902720 $Y=643620
X173 736 756 3809 1 2 QDFFN $T=903340 538160 1 0 $X=903340 $Y=532740
X174 3659 755 3803 1 2 QDFFN $T=903340 669200 0 0 $X=903340 $Y=668820
X175 3659 750 3797 1 2 QDFFN $T=903960 689360 0 0 $X=903960 $Y=688980
X176 3700 750 3794 1 2 QDFFN $T=904580 558320 0 0 $X=904580 $Y=557940
X177 3718 755 3831 1 2 QDFFN $T=907060 628880 0 0 $X=907060 $Y=628500
X178 736 750 3798 1 2 QDFFN $T=907680 528080 0 0 $X=907680 $Y=527700
X179 3714 755 3826 1 2 QDFFN $T=907680 618800 0 0 $X=907680 $Y=618420
X180 3659 756 3788 1 2 QDFFN $T=918220 689360 0 180 $X=907680 $Y=683940
X181 3738 755 3796 1 2 QDFFN $T=918840 568400 0 180 $X=908300 $Y=562980
X182 3677 755 3825 1 2 QDFFN $T=908920 548240 0 0 $X=908920 $Y=547860
X183 3733 770 3802 1 2 QDFFN $T=921320 659120 1 180 $X=910780 $Y=658740
X184 3700 755 3799 1 2 QDFFN $T=925040 558320 0 180 $X=914500 $Y=552900
X185 3738 756 3820 1 2 QDFFN $T=915120 578480 0 0 $X=915120 $Y=578100
X186 747 770 3864 1 2 QDFFN $T=915740 528080 1 0 $X=915740 $Y=522660
X187 3685 771 3866 1 2 QDFFN $T=916360 538160 1 0 $X=916360 $Y=532740
X188 3733 771 3867 1 2 QDFFN $T=916360 649040 0 0 $X=916360 $Y=648660
X189 3659 770 3837 1 2 QDFFN $T=928140 689360 1 180 $X=917600 $Y=688980
X190 3700 770 3869 1 2 QDFFN $T=918220 558320 0 0 $X=918220 $Y=557940
X191 3738 770 3871 1 2 QDFFN $T=918840 568400 1 0 $X=918840 $Y=562980
X192 749 771 3868 1 2 QDFFN $T=918840 669200 0 0 $X=918840 $Y=668820
X193 3714 771 3860 1 2 QDFFN $T=919460 628880 0 0 $X=919460 $Y=628500
X194 3714 770 3857 1 2 QDFFN $T=920080 618800 0 0 $X=920080 $Y=618420
X195 747 771 3878 1 2 QDFFN $T=920700 528080 0 0 $X=920700 $Y=527700
X196 3677 771 3876 1 2 QDFFN $T=921320 538160 0 0 $X=921320 $Y=537780
X197 3700 771 3865 1 2 QDFFN $T=921320 548240 0 0 $X=921320 $Y=547860
X198 3659 771 3852 1 2 QDFFN $T=931860 679280 1 180 $X=921320 $Y=678900
X199 3686 770 3918 1 2 QDFFN $T=921940 578480 1 0 $X=921940 $Y=573060
X200 3665 770 3895 1 2 QDFFN $T=921940 598640 0 0 $X=921940 $Y=598260
X201 3718 770 3897 1 2 QDFFN $T=922560 638960 1 0 $X=922560 $Y=633540
X202 3729 770 3898 1 2 QDFFN $T=924420 659120 0 0 $X=924420 $Y=658740
X203 3720 770 3922 1 2 QDFFN $T=925040 649040 1 0 $X=925040 $Y=643620
X204 3665 771 3914 1 2 QDFFN $T=926280 608720 0 0 $X=926280 $Y=608340
X205 3678 770 3884 1 2 QDFFN $T=926900 588560 0 0 $X=926900 $Y=588180
X206 3737 771 3874 1 2 QDFFN $T=939920 568400 0 180 $X=929380 $Y=562980
X207 749 770 3862 1 2 QDFFN $T=942400 669200 1 180 $X=931860 $Y=668820
X208 3737 770 3931 1 2 QDFFN $T=932480 558320 1 0 $X=932480 $Y=552900
X209 3701 771 3896 1 2 QDFFN $T=943640 618800 1 180 $X=933100 $Y=618420
X210 3720 771 3930 1 2 QDFFN $T=933720 649040 0 0 $X=933720 $Y=648660
X211 736 771 3935 1 2 QDFFN $T=934340 528080 0 0 $X=934340 $Y=527700
X212 714 771 3906 1 2 QDFFN $T=944880 679280 1 180 $X=934340 $Y=678900
X213 3718 771 3910 1 2 QDFFN $T=946120 638960 0 180 $X=935580 $Y=633540
X214 3677 770 3894 1 2 QDFFN $T=947360 548240 0 180 $X=936820 $Y=542820
X215 3685 770 3893 1 2 QDFFN $T=948600 538160 0 180 $X=938060 $Y=532740
X216 3678 771 3892 1 2 QDFFN $T=948600 588560 1 180 $X=938060 $Y=588180
X217 3729 771 3901 1 2 QDFFN $T=948600 659120 1 180 $X=938060 $Y=658740
X218 714 770 3911 1 2 QDFFN $T=950460 679280 0 180 $X=939920 $Y=673860
X219 3738 771 3925 1 2 QDFFN $T=951080 568400 1 180 $X=940540 $Y=568020
X220 3701 770 3921 1 2 QDFFN $T=951080 628880 0 180 $X=940540 $Y=623460
X221 3686 771 3913 1 2 QDFFN $T=952320 578480 1 180 $X=941780 $Y=578100
X222 3737 779 3967 1 2 QDFFN $T=942400 558320 0 0 $X=942400 $Y=557940
X223 3677 779 3947 1 2 QDFFN $T=944880 548240 0 0 $X=944880 $Y=547860
X224 3718 779 4003 1 2 QDFFN $T=946740 649040 0 0 $X=946740 $Y=648660
X225 747 779 3949 1 2 QDFFN $T=957900 528080 1 180 $X=947360 $Y=527700
X226 749 779 4016 1 2 QDFFN $T=947360 679280 0 0 $X=947360 $Y=678900
X227 3686 779 4026 1 2 QDFFN $T=950460 588560 0 0 $X=950460 $Y=588180
X228 3701 779 3971 1 2 QDFFN $T=962240 618800 1 180 $X=951700 $Y=618420
X229 3701 799 3981 1 2 QDFFN $T=962860 628880 1 180 $X=952320 $Y=628500
X230 3737 799 3984 1 2 QDFFN $T=963480 558320 1 180 $X=952940 $Y=557940
X231 747 799 3965 1 2 QDFFN $T=965340 528080 0 180 $X=954800 $Y=522660
X232 3677 799 3952 1 2 QDFFN $T=967200 538160 1 180 $X=956660 $Y=537780
X233 3678 779 4014 1 2 QDFFN $T=968440 578480 1 180 $X=957900 $Y=578100
X234 3686 799 4020 1 2 QDFFN $T=969060 568400 1 180 $X=958520 $Y=568020
X235 3718 799 4007 1 2 QDFFN $T=970300 638960 1 180 $X=959760 $Y=638580
X236 3729 779 4057 1 2 QDFFN $T=959760 649040 0 0 $X=959760 $Y=648660
X237 749 799 4027 1 2 QDFFN $T=970300 669200 0 180 $X=959760 $Y=663780
X238 714 779 4063 1 2 QDFFN $T=960380 679280 0 0 $X=960380 $Y=678900
X239 3665 779 4018 1 2 QDFFN $T=971540 598640 1 180 $X=961000 $Y=598260
X240 3665 799 4022 1 2 QDFFN $T=962240 618800 0 0 $X=962240 $Y=618420
X241 714 799 4059 1 2 QDFFN $T=962860 689360 1 0 $X=962860 $Y=683940
X242 3700 779 4042 1 2 QDFFN $T=974020 558320 1 180 $X=963480 $Y=557940
X243 736 779 807 1 2 QDFFN $T=977740 528080 1 180 $X=967200 $Y=527700
X244 3720 799 4067 1 2 QDFFN $T=967200 638960 1 0 $X=967200 $Y=633540
X245 3685 799 4055 1 2 QDFFN $T=978360 538160 0 180 $X=967820 $Y=532740
X246 3714 799 4078 1 2 QDFFN $T=967820 628880 0 0 $X=967820 $Y=628500
X247 3685 779 4058 1 2 QDFFN $T=978980 548240 1 180 $X=968440 $Y=547860
X248 3700 799 4033 1 2 QDFFN $T=982700 558320 0 180 $X=972160 $Y=552900
X249 3665 809 4091 1 2 QDFFN $T=972160 608720 0 0 $X=972160 $Y=608340
X250 749 809 4090 1 2 QDFFN $T=972160 689360 0 0 $X=972160 $Y=688980
X251 3738 779 4068 1 2 QDFFN $T=983320 568400 1 180 $X=972780 $Y=568020
X252 3729 799 4061 1 2 QDFFN $T=983320 649040 1 180 $X=972780 $Y=648660
X253 3733 799 4086 1 2 QDFFN $T=972780 669200 0 0 $X=972780 $Y=668820
X254 3677 809 4094 1 2 QDFFN $T=974020 538160 0 0 $X=974020 $Y=537780
X255 3738 799 4062 1 2 QDFFN $T=984560 558320 1 180 $X=974020 $Y=557940
X256 3659 799 4069 1 2 QDFFN $T=984560 679280 1 180 $X=974020 $Y=678900
X257 3678 799 4060 1 2 QDFFN $T=985180 578480 1 180 $X=974640 $Y=578100
X258 3733 779 4087 1 2 QDFFN $T=987660 659120 1 180 $X=977120 $Y=658740
X259 3720 779 4074 1 2 QDFFN $T=988280 649040 0 180 $X=977740 $Y=643620
X260 3714 779 4082 1 2 QDFFN $T=988900 618800 1 180 $X=978360 $Y=618420
X261 3718 809 4107 1 2 QDFFN $T=978360 638960 1 0 $X=978360 $Y=633540
X262 3659 779 4080 1 2 QDFFN $T=989520 679280 0 180 $X=978980 $Y=673860
X263 736 809 814 1 2 QDFFN $T=979600 528080 0 0 $X=979600 $Y=527700
X264 3701 809 4110 1 2 QDFFN $T=979600 628880 0 0 $X=979600 $Y=628500
X265 3685 809 4114 1 2 QDFFN $T=980220 538160 1 0 $X=980220 $Y=532740
X266 3729 809 4113 1 2 QDFFN $T=980220 659120 1 0 $X=980220 $Y=653700
X267 3700 809 4119 1 2 QDFFN $T=981460 548240 1 0 $X=981460 $Y=542820
X268 3678 809 4118 1 2 QDFFN $T=981460 588560 0 0 $X=981460 $Y=588180
X269 3738 809 4093 1 2 QDFFN $T=992620 568400 0 180 $X=982080 $Y=562980
X270 3737 809 4092 1 2 QDFFN $T=995100 558320 1 180 $X=984560 $Y=557940
X271 3686 809 4098 1 2 QDFFN $T=995100 578480 0 180 $X=984560 $Y=573060
X272 3720 809 4103 1 2 QDFFN $T=996340 649040 1 180 $X=985800 $Y=648660
X273 3733 809 4127 1 2 QDFFN $T=985800 669200 0 0 $X=985800 $Y=668820
X274 3659 809 4131 1 2 QDFFN $T=987040 679280 0 0 $X=987040 $Y=678900
X275 3665 815 4133 1 2 QDFFN $T=988900 608720 0 0 $X=988900 $Y=608340
X276 747 815 818 1 2 QDFFN $T=992000 528080 1 0 $X=992000 $Y=522660
X277 3685 815 4146 1 2 QDFFN $T=992000 528080 0 0 $X=992000 $Y=527700
X278 3678 817 4136 1 2 QDFFN $T=992000 588560 1 0 $X=992000 $Y=583140
X279 3685 817 4138 1 2 QDFFN $T=993240 538160 1 0 $X=993240 $Y=532740
X280 3737 815 4148 1 2 QDFFN $T=993240 558320 1 0 $X=993240 $Y=552900
X281 3737 817 4142 1 2 QDFFN $T=993240 568400 1 0 $X=993240 $Y=562980
X282 3700 817 4147 1 2 QDFFN $T=993860 548240 0 0 $X=993860 $Y=547860
X283 749 815 4164 1 2 QDFFN $T=993860 689360 1 0 $X=993860 $Y=683940
X284 3665 817 4145 1 2 QDFFN $T=994480 608720 1 0 $X=994480 $Y=603300
X285 3720 815 4160 1 2 QDFFN $T=994480 649040 1 0 $X=994480 $Y=643620
X286 3738 817 4170 1 2 QDFFN $T=995100 568400 0 0 $X=995100 $Y=568020
X287 3733 817 4161 1 2 QDFFN $T=996340 669200 1 0 $X=996340 $Y=663780
X288 3677 817 4157 1 2 QDFFN $T=996960 548240 1 0 $X=996960 $Y=542820
X289 3678 815 4144 1 2 QDFFN $T=996960 598640 1 0 $X=996960 $Y=593220
X290 3701 815 4156 1 2 QDFFN $T=996960 618800 1 0 $X=996960 $Y=613380
X291 3659 817 4163 1 2 QDFFN $T=998200 669200 0 0 $X=998200 $Y=668820
X292 3720 817 4177 1 2 QDFFN $T=999440 649040 0 0 $X=999440 $Y=648660
X293 3659 815 4180 1 2 QDFFN $T=1000680 679280 0 0 $X=1000680 $Y=678900
X294 3729 815 4193 1 2 QDFFN $T=1001300 659120 1 0 $X=1001300 $Y=653700
X295 3677 815 4179 1 2 QDFFN $T=1006260 538160 0 0 $X=1006260 $Y=537780
X296 3686 815 4159 1 2 QDFFN $T=1016800 588560 0 180 $X=1006260 $Y=583140
X297 3700 823 4165 1 2 QDFFN $T=1017420 548240 1 180 $X=1006880 $Y=547860
X298 3714 817 4169 1 2 QDFFN $T=1018040 618800 0 180 $X=1007500 $Y=613380
X299 736 815 4155 1 2 QDFFN $T=1019280 528080 1 180 $X=1008740 $Y=527700
X300 3733 823 4214 1 2 QDFFN $T=1010600 669200 0 0 $X=1010600 $Y=668820
X301 3718 817 4210 1 2 QDFFN $T=1012460 638960 0 0 $X=1012460 $Y=638580
X302 3729 817 4207 1 2 QDFFN $T=1012460 649040 0 0 $X=1012460 $Y=648660
X303 3700 815 4166 1 2 QDFFN $T=1023620 568400 0 180 $X=1013080 $Y=562980
X304 3678 823 4224 1 2 QDFFN $T=1014320 598640 1 0 $X=1014320 $Y=593220
X305 3733 815 4173 1 2 QDFFN $T=1025480 659120 1 180 $X=1014940 $Y=658740
X306 3686 823 4235 1 2 QDFFN $T=1016180 578480 1 0 $X=1016180 $Y=573060
X307 3665 823 4202 1 2 QDFFN $T=1027960 608720 0 180 $X=1017420 $Y=603300
X308 3685 823 4225 1 2 QDFFN $T=1018040 538160 1 0 $X=1018040 $Y=532740
X309 3677 823 4244 1 2 QDFFN $T=1018040 548240 1 0 $X=1018040 $Y=542820
X310 3738 823 4254 1 2 QDFFN $T=1018040 568400 0 0 $X=1018040 $Y=568020
X311 3701 823 4239 1 2 QDFFN $T=1018040 628880 0 0 $X=1018040 $Y=628500
X312 3714 823 4238 1 2 QDFFN $T=1019280 618800 0 0 $X=1019280 $Y=618420
X313 3700 830 4208 1 2 QDFFN $T=1030440 548240 1 180 $X=1019900 $Y=547860
X314 3718 823 4255 1 2 QDFFN $T=1019900 638960 1 0 $X=1019900 $Y=633540
X315 3729 823 4258 1 2 QDFFN $T=1019900 659120 1 0 $X=1019900 $Y=653700
X316 3659 823 4218 1 2 QDFFN $T=1031680 679280 1 180 $X=1021140 $Y=678900
X317 3737 823 4228 1 2 QDFFN $T=1037260 568400 0 180 $X=1026720 $Y=562980
X318 3720 823 4240 1 2 QDFFN $T=1037260 649040 1 180 $X=1026720 $Y=648660
X319 3659 830 4227 1 2 QDFFN $T=1038500 669200 1 180 $X=1027960 $Y=668820
X320 3677 830 4243 1 2 QDFFN $T=1039120 538160 1 180 $X=1028580 $Y=537780
X321 3737 830 4241 1 2 QDFFN $T=1039740 558320 0 180 $X=1029200 $Y=552900
X322 3678 830 4226 1 2 QDFFN $T=1039740 588560 0 180 $X=1029200 $Y=583140
X323 3665 830 4234 1 2 QDFFN $T=1040360 618800 0 180 $X=1029820 $Y=613380
X324 736 823 833 1 2 QDFFN $T=1040980 528080 0 180 $X=1030440 $Y=522660
X325 3686 830 4249 1 2 QDFFN $T=1040980 578480 1 180 $X=1030440 $Y=578100
X326 3685 830 4230 1 2 QDFFN $T=1041600 528080 1 180 $X=1031060 $Y=527700
X327 3714 830 4247 1 2 QDFFN $T=1042220 618800 1 180 $X=1031680 $Y=618420
X328 749 830 4251 1 2 QDFFN $T=1042220 689360 0 180 $X=1031680 $Y=683940
X329 3738 830 4253 1 2 QDFFN $T=1042840 578480 0 180 $X=1032300 $Y=573060
X330 3733 830 4250 1 2 QDFFN $T=1043460 669200 0 180 $X=1032920 $Y=663780
X331 3720 830 4257 1 2 QDFFN $T=1044080 638960 1 180 $X=1033540 $Y=638580
X332 714 830 4232 1 2 QDFFN $T=1044700 679280 0 180 $X=1034160 $Y=673860
X333 3701 830 4259 1 2 QDFFN $T=1045320 628880 0 180 $X=1034780 $Y=623460
X334 3718 830 4260 1 2 QDFFN $T=1045320 638960 0 180 $X=1034780 $Y=633540
X335 3677 834 4283 1 2 QDFFN $T=1037880 548240 0 0 $X=1037880 $Y=547860
X336 3729 830 4266 1 2 QDFFN $T=1049660 649040 1 180 $X=1039120 $Y=648660
X337 3678 4269 4291 1 2 QDFFN $T=1039740 588560 0 0 $X=1039740 $Y=588180
X338 3729 834 4296 1 2 QDFFN $T=1039740 659120 0 0 $X=1039740 $Y=658740
X339 3700 834 4289 1 2 QDFFN $T=1040360 568400 1 0 $X=1040360 $Y=562980
X340 3678 834 4292 1 2 QDFFN $T=1040980 578480 0 0 $X=1040980 $Y=578100
X341 3685 4269 4270 1 2 QDFFN $T=1052140 548240 0 180 $X=1041600 $Y=542820
X342 3677 4269 4287 1 2 QDFFN $T=1041600 558320 1 0 $X=1041600 $Y=552900
X343 749 834 4285 1 2 QDFFN $T=1041600 669200 0 0 $X=1041600 $Y=668820
X344 3720 834 4288 1 2 QDFFN $T=1042220 649040 1 0 $X=1042220 $Y=643620
X345 3685 834 4272 1 2 QDFFN $T=1054000 528080 1 180 $X=1043460 $Y=527700
X346 749 4269 4274 1 2 QDFFN $T=1055240 689360 0 180 $X=1044700 $Y=683940
X347 757 4269 840 1 2 QDFFN $T=1045940 528080 1 0 $X=1045940 $Y=522660
X348 3729 4269 4299 1 2 QDFFN $T=1046560 669200 1 0 $X=1046560 $Y=663780
X349 3714 838 4301 1 2 QDFFN $T=1047180 618800 1 0 $X=1047180 $Y=613380
X350 3720 4269 4280 1 2 QDFFN $T=1057720 628880 1 180 $X=1047180 $Y=628500
X351 3714 4269 4308 1 2 QDFFN $T=1050280 628880 1 0 $X=1050280 $Y=623460
X352 3700 4269 4286 1 2 QDFFN $T=1062060 578480 1 180 $X=1051520 $Y=578100
X353 3700 838 4307 1 2 QDFFN $T=1052140 568400 0 0 $X=1052140 $Y=568020
X354 749 838 4304 1 2 QDFFN $T=1052760 689360 0 0 $X=1052760 $Y=688980
X355 714 834 4318 1 2 QDFFN $T=1053380 679280 1 0 $X=1053380 $Y=673860
X356 3677 841 4298 1 2 QDFFN $T=1054000 558320 1 0 $X=1054000 $Y=552900
X357 3677 838 4312 1 2 QDFFN $T=1054000 558320 0 0 $X=1054000 $Y=557940
X358 3678 841 4314 1 2 QDFFN $T=1054000 598640 1 0 $X=1054000 $Y=593220
X359 3714 834 4315 1 2 QDFFN $T=1055240 608720 1 0 $X=1055240 $Y=603300
X360 3714 841 4305 1 2 QDFFN $T=1055240 608720 0 0 $X=1055240 $Y=608340
X361 3720 841 4295 1 2 QDFFN $T=1055240 649040 1 0 $X=1055240 $Y=643620
X362 740 4269 4309 1 2 QDFFN $T=1055860 528080 0 0 $X=1055860 $Y=527700
X363 3685 841 4294 1 2 QDFFN $T=1066400 548240 0 180 $X=1055860 $Y=542820
X364 3686 841 4317 1 2 QDFFN $T=1055860 588560 1 0 $X=1055860 $Y=583140
X365 714 4269 4311 1 2 QDFFN $T=1055860 669200 0 0 $X=1055860 $Y=668820
X366 3720 838 4300 1 2 QDFFN $T=1057720 638960 1 0 $X=1057720 $Y=633540
X367 3685 838 4302 1 2 QDFFN $T=1068880 538160 0 180 $X=1058340 $Y=532740
X368 3700 841 4313 1 2 QDFFN $T=1058340 578480 1 0 $X=1058340 $Y=573060
X369 3701 838 4324 1 2 QDFFN $T=1058960 628880 0 0 $X=1058960 $Y=628500
X370 3729 838 4316 1 2 QDFFN $T=1059580 659120 0 0 $X=1059580 $Y=658740
X371 3729 841 4303 1 2 QDFFN $T=1060200 659120 1 0 $X=1060200 $Y=653700
X372 754 4269 846 1 2 QDFFN $T=1063920 528080 1 0 $X=1063920 $Y=522660
X373 3701 841 4334 1 2 QDFFN $T=1063920 628880 1 0 $X=1063920 $Y=623460
X374 3665 841 4336 1 2 QDFFN $T=1066400 598640 0 0 $X=1066400 $Y=598260
X375 3686 838 4337 1 2 QDFFN $T=1067020 598640 1 0 $X=1067020 $Y=593220
X376 3733 834 4355 1 2 QDFFN $T=1067020 649040 0 0 $X=1067020 $Y=648660
X377 714 838 4343 1 2 QDFFN $T=1067020 689360 0 0 $X=1067020 $Y=688980
X378 3718 4269 4348 1 2 QDFFN $T=1068260 638960 0 0 $X=1068260 $Y=638580
X379 747 834 4322 1 2 QDFFN $T=1079420 528080 1 180 $X=1068880 $Y=527700
X380 747 4269 4349 1 2 QDFFN $T=1068880 548240 1 0 $X=1068880 $Y=542820
X381 3737 834 4321 1 2 QDFFN $T=1079420 558320 1 180 $X=1068880 $Y=557940
X382 3738 834 4323 1 2 QDFFN $T=1079420 568400 0 180 $X=1068880 $Y=562980
X383 3665 838 4344 1 2 QDFFN $T=1068880 608720 0 0 $X=1068880 $Y=608340
X384 3659 834 4346 1 2 QDFFN $T=1068880 669200 0 0 $X=1068880 $Y=668820
X385 3737 4269 4326 1 2 QDFFN $T=1085000 548240 1 180 $X=1074460 $Y=547860
X386 3738 841 4365 1 2 QDFFN $T=1076320 578480 1 0 $X=1076320 $Y=573060
X387 3659 841 4347 1 2 QDFFN $T=1080040 689360 1 0 $X=1080040 $Y=683940
X388 736 838 849 1 2 QDFFN $T=1080660 528080 0 0 $X=1080660 $Y=527700
X389 736 834 4351 1 2 QDFFN $T=1080660 538160 1 0 $X=1080660 $Y=532740
X390 736 4269 4362 1 2 QDFFN $T=1080660 538160 0 0 $X=1080660 $Y=537780
X391 3737 838 4368 1 2 QDFFN $T=1080660 558320 1 0 $X=1080660 $Y=552900
X392 3738 838 4366 1 2 QDFFN $T=1080660 568400 0 0 $X=1080660 $Y=568020
X393 3686 834 4363 1 2 QDFFN $T=1080660 588560 1 0 $X=1080660 $Y=583140
X394 3686 4269 4369 1 2 QDFFN $T=1080660 598640 1 0 $X=1080660 $Y=593220
X395 3665 4269 4370 1 2 QDFFN $T=1080660 598640 0 0 $X=1080660 $Y=598260
X396 3665 834 4352 1 2 QDFFN $T=1080660 608720 0 0 $X=1080660 $Y=608340
X397 3701 834 4353 1 2 QDFFN $T=1080660 618800 1 0 $X=1080660 $Y=613380
X398 3701 4269 4356 1 2 QDFFN $T=1080660 618800 0 0 $X=1080660 $Y=618420
X399 3718 838 4345 1 2 QDFFN $T=1080660 628880 0 0 $X=1080660 $Y=628500
X400 3718 841 4341 1 2 QDFFN $T=1080660 638960 0 0 $X=1080660 $Y=638580
X401 3718 834 4354 1 2 QDFFN $T=1080660 649040 1 0 $X=1080660 $Y=643620
X402 3733 841 4350 1 2 QDFFN $T=1080660 649040 0 0 $X=1080660 $Y=648660
X403 3733 838 4371 1 2 QDFFN $T=1080660 659120 0 0 $X=1080660 $Y=658740
X404 3733 4269 4364 1 2 QDFFN $T=1080660 669200 1 0 $X=1080660 $Y=663780
X405 3659 4269 4372 1 2 QDFFN $T=1080660 669200 0 0 $X=1080660 $Y=668820
X406 3659 838 4361 1 2 QDFFN $T=1080660 679280 0 0 $X=1080660 $Y=678900
X407 3737 841 4367 1 2 QDFFN $T=1081280 558320 0 0 $X=1081280 $Y=557940
X408 214 1825 1830 1843 1 1853 2 AOI22S $T=437720 568400 0 0 $X=437720 $Y=568020
X409 215 1848 1846 1843 1 1853 2 AOI22S $T=438960 578480 1 0 $X=438960 $Y=573060
X410 1842 1823 217 220 1 223 2 AOI22S $T=438960 689360 1 0 $X=438960 $Y=683940
X411 221 1847 1852 1843 1 1853 2 AOI22S $T=441440 558320 0 0 $X=441440 $Y=557940
X412 1867 1838 1855 220 1 223 2 AOI22S $T=444540 669200 0 0 $X=444540 $Y=668820
X413 1871 1824 228 220 1 223 2 AOI22S $T=444540 679280 1 0 $X=444540 $Y=673860
X414 1839 1901 239 220 1 223 2 AOI22S $T=453220 659120 1 0 $X=453220 $Y=653700
X415 1904 1888 237 220 1 223 2 AOI22S $T=453220 669200 0 0 $X=453220 $Y=668820
X416 1913 1874 238 220 1 223 2 AOI22S $T=453220 679280 0 0 $X=453220 $Y=678900
X417 242 1926 1932 1843 1 1853 2 AOI22S $T=456940 568400 0 0 $X=456940 $Y=568020
X418 244 1938 1924 1843 1 1853 2 AOI22S $T=457560 578480 1 0 $X=457560 $Y=573060
X419 1958 1949 251 220 1 223 2 AOI22S $T=461900 669200 1 180 $X=458180 $Y=668820
X420 1960 1948 252 220 1 223 2 AOI22S $T=461900 679280 1 180 $X=458180 $Y=678900
X421 253 255 1865 258 1 259 2 AOI22S $T=460660 689360 0 0 $X=460660 $Y=688980
X422 1940 1959 1955 220 1 223 2 AOI22S $T=461280 659120 1 0 $X=461280 $Y=653700
X423 260 1954 1965 1843 1 1853 2 AOI22S $T=463140 568400 0 0 $X=463140 $Y=568020
X424 1986 1979 1983 220 1 223 2 AOI22S $T=468720 659120 0 180 $X=465000 $Y=653700
X425 1973 1978 1946 258 1 259 2 AOI22S $T=465000 689360 0 0 $X=465000 $Y=688980
X426 2001 1853 1999 264 1 1843 2 AOI22S $T=471820 558320 1 180 $X=468100 $Y=557940
X427 2010 1995 2011 258 1 259 2 AOI22S $T=473680 679280 1 180 $X=469960 $Y=678900
X428 275 2042 2038 1843 1 1853 2 AOI22S $T=479260 568400 1 0 $X=479260 $Y=562980
X429 276 2046 2043 1843 1 1853 2 AOI22S $T=479880 578480 0 0 $X=479880 $Y=578100
X430 2054 2049 2003 258 1 259 2 AOI22S $T=483600 679280 0 180 $X=479880 $Y=673860
X431 2044 2062 2077 220 1 223 2 AOI22S $T=488560 649040 1 0 $X=488560 $Y=643620
X432 2110 2056 2101 258 1 259 2 AOI22S $T=496000 659120 1 180 $X=492280 $Y=658740
X433 311 2144 2125 1843 1 1853 2 AOI22S $T=502820 578480 0 180 $X=499100 $Y=573060
X434 2099 2141 2131 220 1 223 2 AOI22S $T=499100 649040 1 0 $X=499100 $Y=643620
X435 2132 2112 2117 258 1 259 2 AOI22S $T=500340 669200 1 0 $X=500340 $Y=663780
X436 314 2158 2145 1843 1 1853 2 AOI22S $T=505920 568400 1 180 $X=502200 $Y=568020
X437 2111 2111 2167 220 1 223 2 AOI22S $T=505920 649040 1 0 $X=505920 $Y=643620
X438 2199 2189 2193 258 1 259 2 AOI22S $T=510880 669200 0 180 $X=507160 $Y=663780
X439 331 2129 2236 1843 1 1853 2 AOI22S $T=517080 598640 0 0 $X=517080 $Y=598260
X440 333 2237 2244 1843 1 1853 2 AOI22S $T=518940 608720 1 0 $X=518940 $Y=603300
X441 2253 2248 2258 258 1 259 2 AOI22S $T=522660 669200 0 180 $X=518940 $Y=663780
X442 344 2220 2266 1843 1 1853 2 AOI22S $T=523900 608720 0 0 $X=523900 $Y=608340
X443 2262 2226 2285 258 1 259 2 AOI22S $T=527620 659120 0 0 $X=527620 $Y=658740
X444 2310 2318 2338 365 1 259 2 AOI22S $T=540020 669200 1 0 $X=540020 $Y=663780
X445 2288 2366 370 220 1 223 2 AOI22S $T=546840 649040 0 0 $X=546840 $Y=648660
X446 2336 2373 2381 365 1 259 2 AOI22S $T=550560 669200 0 0 $X=550560 $Y=668820
X447 2419 2419 2295 220 1 223 2 AOI22S $T=561100 649040 0 180 $X=557380 $Y=643620
X448 2372 2444 384 220 1 223 2 AOI22S $T=565440 649040 1 0 $X=565440 $Y=643620
X449 2451 2422 2457 220 1 223 2 AOI22S $T=567300 669200 1 0 $X=567300 $Y=663780
X450 2365 2471 386 220 1 223 2 AOI22S $T=571640 649040 0 0 $X=571640 $Y=648660
X451 2472 2478 389 220 1 223 2 AOI22S $T=571640 669200 1 0 $X=571640 $Y=663780
X452 2465 391 2470 365 1 259 2 AOI22S $T=572260 689360 0 0 $X=572260 $Y=688980
X453 2487 2496 2506 365 1 259 2 AOI22S $T=579080 679280 0 180 $X=575360 $Y=673860
X454 2488 2494 2308 220 1 223 2 AOI22S $T=575980 649040 1 0 $X=575980 $Y=643620
X455 2514 2505 2384 220 1 223 2 AOI22S $T=580940 659120 0 180 $X=577220 $Y=653700
X456 2523 2495 404 220 1 223 2 AOI22S $T=582800 669200 1 0 $X=582800 $Y=663780
X457 2547 2537 2412 220 1 223 2 AOI22S $T=587140 659120 1 180 $X=583420 $Y=658740
X458 2458 2538 2536 258 1 259 2 AOI22S $T=584040 679280 0 0 $X=584040 $Y=678900
X459 2402 2517 406 220 1 223 2 AOI22S $T=587760 669200 0 0 $X=587760 $Y=668820
X460 2484 2566 407 220 1 223 2 AOI22S $T=589000 689360 1 0 $X=589000 $Y=683940
X461 2548 2575 411 220 1 223 2 AOI22S $T=595820 669200 1 180 $X=592100 $Y=668820
X462 2573 413 2579 258 1 259 2 AOI22S $T=594580 689360 0 0 $X=594580 $Y=688980
X463 2605 2598 2604 220 1 223 2 AOI22S $T=599540 669200 1 180 $X=595820 $Y=668820
X464 417 2617 2633 1843 1 1853 2 AOI22S $T=603260 618800 1 180 $X=599540 $Y=618420
X465 2627 2620 2626 220 1 223 2 AOI22S $T=603880 669200 1 180 $X=600160 $Y=668820
X466 2622 2613 2606 220 1 223 2 AOI22S $T=604500 659120 1 180 $X=600780 $Y=658740
X467 2484 2618 416 220 1 223 2 AOI22S $T=601400 679280 0 0 $X=601400 $Y=678900
X468 2654 2641 2655 220 1 223 2 AOI22S $T=609460 679280 0 180 $X=605740 $Y=673860
X469 426 2666 2660 1843 1 1853 2 AOI22S $T=613180 618800 0 0 $X=613180 $Y=618420
X470 470 2762 2763 1843 1 1853 2 AOI22S $T=643560 649040 1 180 $X=639840 $Y=648660
X471 490 2812 2836 1843 1 1853 2 AOI22S $T=657820 659120 1 0 $X=657820 $Y=653700
X472 515 2844 2863 1843 1 1853 2 AOI22S $T=664640 638960 1 180 $X=660920 $Y=638580
X473 510 2869 2881 1843 1 1853 2 AOI22S $T=667740 649040 0 180 $X=664020 $Y=643620
X474 502 2800 2876 1843 1 1853 2 AOI22S $T=664640 649040 0 0 $X=664640 $Y=648660
X475 528 2755 2915 1843 1 1853 2 AOI22S $T=672700 649040 1 180 $X=668980 $Y=648660
X476 3947 3952 3950 786 1 788 2 AOI22S $T=947360 548240 1 0 $X=947360 $Y=542820
X477 3949 3965 789 786 1 788 2 AOI22S $T=949840 528080 1 0 $X=949840 $Y=522660
X478 3971 3981 3961 786 1 788 2 AOI22S $T=955420 628880 1 0 $X=955420 $Y=623460
X479 3967 3984 4013 786 1 788 2 AOI22S $T=956040 548240 0 0 $X=956040 $Y=547860
X480 4003 4007 3962 786 1 788 2 AOI22S $T=956040 638960 0 0 $X=956040 $Y=638580
X481 4018 4022 3992 786 1 788 2 AOI22S $T=958520 608720 0 0 $X=958520 $Y=608340
X482 4016 4027 3977 786 1 788 2 AOI22S $T=959140 679280 1 0 $X=959140 $Y=673860
X483 4042 4033 4039 786 1 788 2 AOI22S $T=964720 568400 0 180 $X=961000 $Y=562980
X484 4026 4020 4008 786 1 788 2 AOI22S $T=961000 588560 0 0 $X=961000 $Y=588180
X485 4058 4055 4066 786 1 788 2 AOI22S $T=970920 538160 1 180 $X=967200 $Y=537780
X486 4063 4059 4004 786 1 788 2 AOI22S $T=970920 679280 0 180 $X=967200 $Y=673860
X487 4014 4060 4056 786 1 788 2 AOI22S $T=968440 578480 0 0 $X=968440 $Y=578100
X488 4068 4062 4005 786 1 788 2 AOI22S $T=972780 568400 1 180 $X=969060 $Y=568020
X489 4057 4061 4021 786 1 788 2 AOI22S $T=969060 659120 1 0 $X=969060 $Y=653700
X490 4074 4067 3993 786 1 788 2 AOI22S $T=974020 638960 1 180 $X=970300 $Y=638580
X491 4080 4069 4043 786 1 788 2 AOI22S $T=975880 679280 0 180 $X=972160 $Y=673860
X492 4082 4078 4047 786 1 788 2 AOI22S $T=976500 618800 1 180 $X=972780 $Y=618420
X493 4087 4086 4070 786 1 788 2 AOI22S $T=979600 659120 0 180 $X=975880 $Y=653700
X494 4092 4096 4034 810 1 812 2 AOI22S $T=982700 558320 1 0 $X=982700 $Y=552900
X495 4090 4095 3987 810 1 812 2 AOI22S $T=982700 689360 1 0 $X=982700 $Y=683940
X496 4093 4100 4012 810 1 812 2 AOI22S $T=983940 568400 0 0 $X=983940 $Y=568020
X497 4098 4102 4017 810 1 812 2 AOI22S $T=984560 588560 1 0 $X=984560 $Y=583140
X498 4091 810 3999 4104 1 812 2 AOI22S $T=985180 608720 0 0 $X=985180 $Y=608340
X499 4094 4106 3966 810 1 812 2 AOI22S $T=986420 538160 0 0 $X=986420 $Y=537780
X500 4119 4111 4052 810 1 812 2 AOI22S $T=991380 558320 0 180 $X=987660 $Y=552900
X501 816 4112 4009 810 1 812 2 AOI22S $T=991380 689360 0 180 $X=987660 $Y=683940
X502 4118 4115 4075 810 1 812 2 AOI22S $T=992000 588560 0 180 $X=988280 $Y=583140
X503 4107 4116 3976 810 1 812 2 AOI22S $T=988900 638960 1 0 $X=988900 $Y=633540
X504 4103 4117 4000 810 1 812 2 AOI22S $T=989520 638960 0 0 $X=989520 $Y=638580
X505 4114 4121 4073 810 1 812 2 AOI22S $T=990760 538160 0 0 $X=990760 $Y=537780
X506 4132 4123 4051 810 1 812 2 AOI22S $T=994480 618800 1 180 $X=990760 $Y=618420
X507 4127 4122 4081 810 1 812 2 AOI22S $T=994480 659120 1 180 $X=990760 $Y=658740
X508 4110 4124 3975 810 1 812 2 AOI22S $T=992620 628880 0 0 $X=992620 $Y=628500
X509 4131 4125 4048 810 1 812 2 AOI22S $T=996340 679280 0 180 $X=992620 $Y=673860
X510 4113 4129 4030 810 1 812 2 AOI22S $T=994480 659120 1 0 $X=994480 $Y=653700
X511 4136 4144 4140 819 1 820 2 AOI22S $T=1002540 588560 1 0 $X=1002540 $Y=583140
X512 822 4155 4219 819 1 820 2 AOI22S $T=1008120 528080 0 180 $X=1004400 $Y=522660
X513 4138 4146 4150 819 1 820 2 AOI22S $T=1004400 528080 0 0 $X=1004400 $Y=527700
X514 4142 4148 4152 819 1 820 2 AOI22S $T=1005020 558320 0 0 $X=1005020 $Y=557940
X515 4145 4133 4153 819 1 820 2 AOI22S $T=1005020 608720 1 0 $X=1005020 $Y=603300
X516 4147 4166 4158 819 1 820 2 AOI22S $T=1006260 558320 1 0 $X=1006260 $Y=552900
X517 4177 4160 4229 819 1 820 2 AOI22S $T=1009980 649040 0 180 $X=1006260 $Y=643620
X518 821 4164 4162 819 1 820 2 AOI22S $T=1006260 689360 0 0 $X=1006260 $Y=688980
X519 4161 4173 4171 819 1 820 2 AOI22S $T=1008120 659120 0 0 $X=1008120 $Y=658740
X520 4151 4159 4172 819 1 820 2 AOI22S $T=1008740 578480 0 0 $X=1008740 $Y=578100
X521 4157 4179 4178 819 1 820 2 AOI22S $T=1009980 548240 1 0 $X=1009980 $Y=542820
X522 4163 4180 4176 819 1 820 2 AOI22S $T=1009980 679280 1 0 $X=1009980 $Y=673860
X523 4170 4185 4183 819 1 820 2 AOI22S $T=1012460 578480 0 0 $X=1012460 $Y=578100
X524 825 824 4205 819 1 820 2 AOI22S $T=1016800 689360 0 180 $X=1013080 $Y=683940
X525 4210 4188 4196 819 1 820 2 AOI22S $T=1017420 638960 0 180 $X=1013700 $Y=633540
X526 4137 4156 4189 819 1 820 2 AOI22S $T=1014320 628880 0 0 $X=1014320 $Y=628500
X527 4207 4193 4199 819 1 820 2 AOI22S $T=1018660 659120 0 180 $X=1014940 $Y=653700
X528 4169 4195 4192 819 1 820 2 AOI22S $T=1015560 618800 0 0 $X=1015560 $Y=618420
X529 4208 4165 4206 828 1 826 2 AOI22S $T=1019280 558320 1 0 $X=1019280 $Y=552900
X530 4230 4225 4213 828 1 826 2 AOI22S $T=1025480 538160 1 180 $X=1021760 $Y=537780
X531 4226 4224 4217 828 1 826 2 AOI22S $T=1025480 588560 0 180 $X=1021760 $Y=583140
X532 4227 4218 4231 828 1 826 2 AOI22S $T=1025480 669200 1 180 $X=1021760 $Y=668820
X533 4232 829 4215 828 1 826 2 AOI22S $T=1025480 689360 0 180 $X=1021760 $Y=683940
X534 4234 4202 4236 828 1 826 2 AOI22S $T=1026720 618800 0 180 $X=1023000 $Y=613380
X535 4241 4228 4201 828 1 826 2 AOI22S $T=1027340 558320 1 180 $X=1023620 $Y=557940
X536 4247 4238 4245 828 1 826 2 AOI22S $T=1029200 628880 0 180 $X=1025480 $Y=623460
X537 4249 4235 4204 828 1 826 2 AOI22S $T=1030440 578480 1 180 $X=1026720 $Y=578100
X538 4250 4214 4233 828 1 826 2 AOI22S $T=1030440 669200 0 180 $X=1026720 $Y=663780
X539 4251 832 4246 828 1 826 2 AOI22S $T=1030440 689360 0 180 $X=1026720 $Y=683940
X540 4257 4240 4237 828 1 826 2 AOI22S $T=1031680 649040 0 180 $X=1027960 $Y=643620
X541 4259 4239 4256 828 1 826 2 AOI22S $T=1032920 628880 0 180 $X=1029200 $Y=623460
X542 4243 4244 4190 828 1 826 2 AOI22S $T=1029820 548240 1 0 $X=1029820 $Y=542820
X543 4260 4255 4198 828 1 826 2 AOI22S $T=1034160 638960 0 180 $X=1030440 $Y=633540
X544 4266 4258 4263 828 1 826 2 AOI22S $T=1034780 659120 0 180 $X=1031060 $Y=653700
X545 4253 4254 4248 828 1 826 2 AOI22S $T=1031680 568400 0 0 $X=1031680 $Y=568020
X546 4270 4272 4267 836 1 835 2 AOI22S $T=1045320 538160 1 0 $X=1045320 $Y=532740
X547 4274 4285 4279 836 1 835 2 AOI22S $T=1047180 679280 1 0 $X=1047180 $Y=673860
X548 4286 4289 4281 836 1 835 2 AOI22S $T=1048420 568400 0 0 $X=1048420 $Y=568020
X549 4280 4288 4282 836 1 835 2 AOI22S $T=1048420 638960 0 0 $X=1048420 $Y=638580
X550 4287 4283 4265 836 1 835 2 AOI22S $T=1049040 548240 0 0 $X=1049040 $Y=547860
X551 4302 4294 4264 839 1 837 2 AOI22S $T=1055860 538160 1 180 $X=1052140 $Y=537780
X552 4291 4292 4271 836 1 835 2 AOI22S $T=1052140 588560 1 0 $X=1052140 $Y=583140
X553 4300 4295 4277 839 1 837 2 AOI22S $T=1055860 638960 1 180 $X=1052140 $Y=638580
X554 4299 4296 4297 836 1 835 2 AOI22S $T=1056480 659120 0 180 $X=1052760 $Y=653700
X555 4312 4298 4262 839 1 837 2 AOI22S $T=1057720 548240 1 180 $X=1054000 $Y=547860
X556 4304 842 4278 839 1 837 2 AOI22S $T=1058960 679280 1 180 $X=1055240 $Y=678900
X557 4316 4303 4293 839 1 837 2 AOI22S $T=1059580 649040 1 180 $X=1055860 $Y=648660
X558 4309 843 844 836 1 835 2 AOI22S $T=1062680 528080 0 180 $X=1058960 $Y=522660
X559 4301 4305 4276 839 1 837 2 AOI22S $T=1058960 618800 1 0 $X=1058960 $Y=613380
X560 4307 4313 4275 839 1 837 2 AOI22S $T=1063920 568400 0 0 $X=1063920 $Y=568020
X561 4343 845 4306 839 1 837 2 AOI22S $T=1067640 679280 1 180 $X=1063920 $Y=678900
X562 4326 4321 4327 836 1 835 2 AOI22S $T=1069500 548240 1 180 $X=1065780 $Y=547860
X563 4308 4315 4284 836 1 835 2 AOI22S $T=1065780 618800 1 0 $X=1065780 $Y=613380
X564 4311 4318 4310 836 1 835 2 AOI22S $T=1065780 679280 1 0 $X=1065780 $Y=673860
X565 4319 4314 4268 839 1 837 2 AOI22S $T=1066400 588560 1 0 $X=1066400 $Y=583140
X566 4337 4317 4338 839 1 837 2 AOI22S $T=1073840 588560 0 180 $X=1070120 $Y=583140
X567 4349 4322 847 836 1 835 2 AOI22S $T=1075080 538160 1 180 $X=1071360 $Y=537780
X568 4344 4336 4325 839 1 837 2 AOI22S $T=1075080 608720 0 180 $X=1071360 $Y=603300
X569 4324 4334 4332 839 1 837 2 AOI22S $T=1071360 628880 0 0 $X=1071360 $Y=628500
X570 4358 4323 4331 836 1 835 2 AOI22S $T=1075700 568400 1 180 $X=1071980 $Y=568020
X571 4345 4341 4330 839 1 837 2 AOI22S $T=1076320 638960 0 180 $X=1072600 $Y=633540
X572 4372 4346 4340 836 1 835 2 AOI22S $T=1078180 679280 0 180 $X=1074460 $Y=673860
X573 4361 4347 4335 839 1 837 2 AOI22S $T=1078180 679280 1 180 $X=1074460 $Y=678900
X574 4362 4351 4357 836 1 835 2 AOI22S $T=1079420 538160 1 180 $X=1075700 $Y=537780
X575 4370 4352 4328 836 1 835 2 AOI22S $T=1079420 608720 0 180 $X=1075700 $Y=603300
X576 4356 4353 4360 836 1 835 2 AOI22S $T=1079420 618800 1 180 $X=1075700 $Y=618420
X577 4371 4350 4339 839 1 837 2 AOI22S $T=1079420 659120 0 180 $X=1075700 $Y=653700
X578 4364 4355 4342 836 1 835 2 AOI22S $T=1079420 659120 1 180 $X=1075700 $Y=658740
X579 4348 4354 4333 836 1 835 2 AOI22S $T=1076320 638960 1 0 $X=1076320 $Y=633540
X580 4369 4363 4359 836 1 835 2 AOI22S $T=1081280 588560 1 180 $X=1077560 $Y=588180
X581 4368 4367 4320 839 1 837 2 AOI22S $T=1091200 548240 1 180 $X=1087480 $Y=547860
X582 4366 4365 4329 839 1 837 2 AOI22S $T=1087480 578480 1 0 $X=1087480 $Y=573060
X583 888 875 1 2 861 AN2 $T=223820 528080 1 180 $X=221340 $Y=527700
X584 889 876 1 2 860 AN2 $T=223820 548240 1 180 $X=221340 $Y=547860
X585 862 860 1 2 878 AN2 $T=221340 558320 1 0 $X=221340 $Y=552900
X586 890 878 1 2 863 AN2 $T=223820 578480 0 180 $X=221340 $Y=573060
X587 894 863 1 2 864 AN2 $T=223820 578480 1 180 $X=221340 $Y=578100
X588 891 879 1 2 865 AN2 $T=223820 628880 0 180 $X=221340 $Y=623460
X589 885 880 1 2 866 AN2 $T=223820 638960 0 180 $X=221340 $Y=633540
X590 887 882 1 2 867 AN2 $T=223820 669200 0 180 $X=221340 $Y=663780
X591 892 883 1 2 868 AN2 $T=223820 679280 1 180 $X=221340 $Y=678900
X592 869 3 1 2 883 AN2 $T=221340 689360 1 0 $X=221340 $Y=683940
X593 870 861 1 2 876 AN2 $T=222580 548240 1 0 $X=222580 $Y=542820
X594 902 866 1 2 879 AN2 $T=225060 628880 1 180 $X=222580 $Y=628500
X595 871 881 1 2 880 AN2 $T=222580 638960 0 0 $X=222580 $Y=638580
X596 886 867 1 2 881 AN2 $T=225060 659120 1 180 $X=222580 $Y=658740
X597 893 868 1 2 882 AN2 $T=225060 669200 1 180 $X=222580 $Y=668820
X598 4 6 1 2 875 AN2 $T=223200 528080 1 0 $X=223200 $Y=522660
X599 903 864 1 2 899 AN2 $T=228160 588560 0 0 $X=228160 $Y=588180
X600 904 899 1 2 923 AN2 $T=228160 598640 1 0 $X=228160 $Y=593220
X601 934 923 1 2 900 AN2 $T=230640 608720 0 180 $X=228160 $Y=603300
X602 905 900 1 2 930 AN2 $T=229400 608720 0 0 $X=229400 $Y=608340
X603 908 865 1 2 935 AN2 $T=230020 618800 1 0 $X=230020 $Y=613380
X604 988 935 1 2 991 AN2 $T=241800 618800 0 0 $X=241800 $Y=618420
X605 1018 930 1 2 992 AN2 $T=245520 608720 0 180 $X=243040 $Y=603300
X606 1060 1054 1 2 1047 AN2 $T=257920 588560 0 180 $X=255440 $Y=583140
X607 1100 1090 1 2 1054 AN2 $T=264740 588560 0 180 $X=262260 $Y=583140
X608 1113 1109 1 2 1094 AN2 $T=267840 548240 1 180 $X=265360 $Y=547860
X609 1132 1130 1 2 1090 AN2 $T=271560 598640 1 180 $X=269080 $Y=598260
X610 1121 1119 1 2 1109 AN2 $T=272180 548240 0 180 $X=269700 $Y=542820
X611 1097 1094 1 2 1134 AN2 $T=269700 568400 0 0 $X=269700 $Y=568020
X612 1169 1150 1 2 1130 AN2 $T=276520 588560 0 180 $X=274040 $Y=583140
X613 1162 1134 1 2 1149 AN2 $T=277760 568400 1 180 $X=275280 $Y=568020
X614 1168 1149 1 2 1154 AN2 $T=278380 578480 0 180 $X=275900 $Y=573060
X615 1167 1154 1 2 1150 AN2 $T=278380 578480 1 180 $X=275900 $Y=578100
X616 1175 71 1 2 1119 AN2 $T=280860 538160 0 180 $X=278380 $Y=532740
X617 1195 1193 1 2 1157 AN2 $T=285200 628880 1 180 $X=282720 $Y=628500
X618 1220 1215 1 2 1193 AN2 $T=290160 628880 1 180 $X=287680 $Y=628500
X619 1233 1240 1 2 1258 AN2 $T=296360 669200 1 0 $X=296360 $Y=663780
X620 1260 1248 1 2 1243 AN2 $T=300080 628880 1 180 $X=297600 $Y=628500
X621 1268 1257 1 2 1251 AN2 $T=301940 649040 1 180 $X=299460 $Y=648660
X622 1255 1259 1 2 1240 AN2 $T=301940 679280 0 180 $X=299460 $Y=673860
X623 1264 1251 1 2 1248 AN2 $T=302560 649040 0 180 $X=300080 $Y=643620
X624 1253 1258 1 2 1257 AN2 $T=300080 659120 1 0 $X=300080 $Y=653700
X625 1256 1270 1 2 1259 AN2 $T=303800 679280 1 180 $X=301320 $Y=678900
X626 98 100 1 2 1270 AN2 $T=301320 689360 0 0 $X=301320 $Y=688980
X627 1286 1243 1 2 1215 AN2 $T=306900 628880 1 180 $X=304420 $Y=628500
X628 1318 113 1 2 1319 AN2 $T=318060 598640 1 0 $X=318060 $Y=593220
X629 1360 1354 1 2 1321 AN2 $T=324260 568400 1 180 $X=321780 $Y=568020
X630 1357 113 1 2 1344 AN2 $T=324260 598640 0 180 $X=321780 $Y=593220
X631 1403 1399 1 2 1354 AN2 $T=334180 578480 0 180 $X=331700 $Y=573060
X632 1440 1439 1 2 1399 AN2 $T=342860 568400 1 180 $X=340380 $Y=568020
X633 1443 113 1 2 1435 AN2 $T=343480 598640 1 0 $X=343480 $Y=593220
X634 1455 137 1 2 1422 AN2 $T=347200 628880 1 180 $X=344720 $Y=628500
X635 1474 113 1 2 1415 AN2 $T=349680 598640 0 180 $X=347200 $Y=593220
X636 1481 1482 1 2 1439 AN2 $T=352780 568400 1 180 $X=350300 $Y=568020
X637 150 152 1 2 1512 AN2 $T=355880 538160 1 0 $X=355880 $Y=532740
X638 1499 1495 1 2 1493 AN2 $T=358360 588560 1 180 $X=355880 $Y=588180
X639 1465 137 1 2 1488 AN2 $T=358980 628880 0 180 $X=356500 $Y=623460
X640 1507 1512 1 2 1519 AN2 $T=357120 538160 0 0 $X=357120 $Y=537780
X641 1516 1517 1 2 1487 AN2 $T=359600 649040 1 180 $X=357120 $Y=648660
X642 1525 1519 1 2 1518 AN2 $T=361460 538160 0 180 $X=358980 $Y=532740
X643 1520 1518 1 2 1530 AN2 $T=358980 548240 1 0 $X=358980 $Y=542820
X644 1526 1530 1 2 1542 AN2 $T=360840 558320 1 0 $X=360840 $Y=552900
X645 1544 137 1 2 1534 AN2 $T=364560 628880 1 180 $X=362080 $Y=628500
X646 1527 1522 1 2 1482 AN2 $T=362700 578480 1 0 $X=362700 $Y=573060
X647 1521 1542 1 2 1556 AN2 $T=363320 558320 0 0 $X=363320 $Y=557940
X648 1562 1551 1 2 1517 AN2 $T=366420 638960 1 180 $X=363940 $Y=638580
X649 1537 1556 1 2 1522 AN2 $T=367660 568400 0 180 $X=365180 $Y=562980
X650 1549 1552 1 2 1551 AN2 $T=366420 649040 1 0 $X=366420 $Y=643620
X651 1590 1594 1 2 1552 AN2 $T=373240 649040 0 180 $X=370760 $Y=643620
X652 1580 1582 1 2 1600 AN2 $T=370760 659120 1 0 $X=370760 $Y=653700
X653 1584 163 1 2 1583 AN2 $T=370760 689360 1 0 $X=370760 $Y=683940
X654 1608 1600 1 2 1594 AN2 $T=376960 659120 0 180 $X=374480 $Y=653700
X655 1618 137 1 2 1564 AN2 $T=378820 628880 0 180 $X=376340 $Y=623460
X656 1610 1611 1 2 1621 AN2 $T=376340 679280 1 0 $X=376340 $Y=673860
X657 1575 1583 1 2 1611 AN2 $T=376340 689360 1 0 $X=376340 $Y=683940
X658 1622 1621 1 2 1582 AN2 $T=380060 659120 1 180 $X=377580 $Y=658740
X659 1659 113 1 2 1499 AN2 $T=391220 588560 0 180 $X=388740 $Y=583140
X660 1672 113 1 2 1588 AN2 $T=391840 578480 0 180 $X=389360 $Y=573060
X661 1683 113 1 2 1536 AN2 $T=394320 578480 0 180 $X=391840 $Y=573060
X662 1699 113 1 2 1607 AN2 $T=397420 578480 0 180 $X=394940 $Y=573060
X663 1710 113 1 2 1605 AN2 $T=404240 548240 0 180 $X=401760 $Y=542820
X664 1700 137 1 2 1639 AN2 $T=404240 638960 0 180 $X=401760 $Y=633540
X665 1732 137 1 2 1662 AN2 $T=404240 669200 0 180 $X=401760 $Y=663780
X666 1721 137 1 2 1656 AN2 $T=406100 659120 0 180 $X=403620 $Y=653700
X667 1718 137 1 2 1657 AN2 $T=406100 669200 1 180 $X=403620 $Y=668820
X668 1728 137 1 2 1677 AN2 $T=406100 679280 0 180 $X=403620 $Y=673860
X669 1698 113 1 2 1623 AN2 $T=407340 548240 0 180 $X=404860 $Y=542820
X670 1742 113 1 2 1546 AN2 $T=411060 528080 0 180 $X=408580 $Y=522660
X671 1726 113 1 2 170 AN2 $T=411060 538160 0 180 $X=408580 $Y=532740
X672 1739 137 1 2 1660 AN2 $T=411060 638960 1 180 $X=408580 $Y=638580
X673 1747 137 1 2 1654 AN2 $T=414160 638960 1 180 $X=411680 $Y=638580
X674 1760 137 1 2 1650 AN2 $T=416020 689360 0 180 $X=413540 $Y=683940
X675 1829 1826 1 2 202 AN2 $T=438340 689360 0 180 $X=435860 $Y=683940
X676 1835 1841 1 2 1829 AN2 $T=443300 679280 1 180 $X=440820 $Y=678900
X677 1890 1876 1 2 1854 AN2 $T=446400 659120 1 180 $X=443920 $Y=658740
X678 1854 1859 1 2 1902 AN2 $T=448880 669200 0 0 $X=448880 $Y=668820
X679 1887 1891 1 2 1835 AN2 $T=451980 679280 1 180 $X=449500 $Y=678900
X680 1902 1905 1 2 1942 AN2 $T=454460 659120 0 0 $X=454460 $Y=658740
X681 1943 1935 1 2 1887 AN2 $T=458800 679280 0 180 $X=456320 $Y=673860
X682 1945 1941 1 2 1890 AN2 $T=460040 659120 0 180 $X=457560 $Y=653700
X683 1942 1975 1 2 1943 AN2 $T=466860 669200 0 180 $X=464380 $Y=663780
X684 268 265 1 2 1984 AN2 $T=470580 548240 0 180 $X=468100 $Y=542820
X685 2000 1992 1 2 1945 AN2 $T=470580 649040 1 180 $X=468100 $Y=648660
X686 268 265 1 2 1962 AN2 $T=471200 608720 0 0 $X=471200 $Y=608340
X687 268 265 1 2 1908 AN2 $T=474300 578480 0 180 $X=471820 $Y=573060
X688 2019 2029 1 2 2017 AN2 $T=478020 548240 1 0 $X=478020 $Y=542820
X689 2050 2035 1 2 2000 AN2 $T=480500 649040 1 180 $X=478020 $Y=648660
X690 2020 2017 1 2 2052 AN2 $T=481740 538160 0 0 $X=481740 $Y=537780
X691 2051 2052 1 2 2069 AN2 $T=483600 558320 0 0 $X=483600 $Y=557940
X692 2096 2090 1 2 2029 AN2 $T=492900 548240 0 180 $X=490420 $Y=542820
X693 2066 2069 1 2 2092 AN2 $T=490420 558320 1 0 $X=490420 $Y=552900
X694 2138 307 1 2 2146 AN2 $T=500340 528080 1 0 $X=500340 $Y=522660
X695 2153 2146 1 2 2102 AN2 $T=502820 528080 1 180 $X=500340 $Y=527700
X696 2093 2102 1 2 2154 AN2 $T=500340 538160 1 0 $X=500340 $Y=532740
X697 2162 2154 1 2 2090 AN2 $T=504680 538160 1 180 $X=502200 $Y=537780
X698 2216 324 1 2 2171 AN2 $T=513360 669200 1 180 $X=510880 $Y=668820
X699 2252 2247 1 2 2235 AN2 $T=521420 548240 0 180 $X=518940 $Y=542820
X700 2221 2217 1 2 2254 AN2 $T=520800 538160 1 0 $X=520800 $Y=532740
X701 2259 2254 1 2 2247 AN2 $T=523280 538160 1 180 $X=520800 $Y=537780
X702 2271 2261 1 2 2217 AN2 $T=525140 528080 1 180 $X=522660 $Y=527700
X703 2246 327 1 2 2281 AN2 $T=527620 669200 0 0 $X=527620 $Y=668820
X704 2313 2305 1 2 2261 AN2 $T=533820 538160 0 180 $X=531340 $Y=532740
X705 2349 2351 1 2 2305 AN2 $T=545600 528080 1 180 $X=543120 $Y=527700
X706 371 372 1 2 2378 AN2 $T=548080 528080 1 0 $X=548080 $Y=522660
X707 2393 2378 1 2 2351 AN2 $T=552420 528080 1 180 $X=549940 $Y=527700
X708 2367 2398 1 2 2400 AN2 $T=552420 588560 0 0 $X=552420 $Y=588180
X709 2219 2398 1 2 2382 AN2 $T=555520 598640 0 180 $X=553040 $Y=593220
X710 2394 2363 1 2 2408 AN2 $T=554900 649040 1 0 $X=554900 $Y=643620
X711 2421 2407 1 2 2394 AN2 $T=559240 638960 1 180 $X=556760 $Y=638580
X712 2434 2433 1 2 2421 AN2 $T=564200 649040 0 180 $X=561720 $Y=643620
X713 2296 2398 1 2 2447 AN2 $T=563580 578480 1 0 $X=563580 $Y=573060
X714 2455 2453 1 2 2434 AN2 $T=567920 659120 1 180 $X=565440 $Y=658740
X715 2297 2398 1 2 2466 AN2 $T=566060 588560 0 0 $X=566060 $Y=588180
X716 2408 2460 1 2 2467 AN2 $T=568540 659120 1 0 $X=568540 $Y=653700
X717 2483 2398 1 2 2497 AN2 $T=578460 568400 0 0 $X=578460 $Y=568020
X718 2511 2510 1 2 2455 AN2 $T=580940 659120 1 180 $X=578460 $Y=658740
X719 2531 2530 1 2 2507 AN2 $T=584660 528080 1 180 $X=582180 $Y=527700
X720 2479 2475 1 2 2530 AN2 $T=582180 548240 1 0 $X=582180 $Y=542820
X721 2467 2534 1 2 2553 AN2 $T=585900 679280 1 0 $X=585900 $Y=673860
X722 2477 2398 1 2 2535 AN2 $T=589620 588560 0 180 $X=587140 $Y=583140
X723 2565 2556 1 2 2511 AN2 $T=589620 659120 1 180 $X=587140 $Y=658740
X724 2558 2559 1 2 2475 AN2 $T=591480 538160 1 180 $X=589000 $Y=537780
X725 2427 2398 1 2 2533 AN2 $T=589000 578480 1 0 $X=589000 $Y=573060
X726 268 265 1 2 2569 AN2 $T=589000 598640 1 0 $X=589000 $Y=593220
X727 2539 2543 1 2 2568 AN2 $T=589000 649040 0 0 $X=589000 $Y=648660
X728 2577 410 1 2 2562 AN2 $T=592100 638960 0 180 $X=589620 $Y=633540
X729 2583 2580 1 2 2559 AN2 $T=596440 528080 1 180 $X=593960 $Y=527700
X730 2568 2571 1 2 2586 AN2 $T=593960 659120 1 0 $X=593960 $Y=653700
X731 2600 2595 1 2 2565 AN2 $T=598300 659120 1 180 $X=595820 $Y=658740
X732 2519 2398 1 2 2608 AN2 $T=598920 578480 1 0 $X=598920 $Y=573060
X733 2593 2588 1 2 2580 AN2 $T=600160 528080 1 0 $X=600160 $Y=522660
X734 420 418 1 2 2588 AN2 $T=605120 528080 0 180 $X=602640 $Y=522660
X735 2561 2398 1 2 2612 AN2 $T=602640 578480 1 0 $X=602640 $Y=573060
X736 2640 2630 1 2 2625 AN2 $T=605120 669200 0 180 $X=602640 $Y=663780
X737 2625 2636 1 2 2600 AN2 $T=606980 669200 1 180 $X=604500 $Y=668820
X738 2589 2398 1 2 2648 AN2 $T=605740 568400 0 0 $X=605740 $Y=568020
X739 2586 2629 1 2 2640 AN2 $T=605740 659120 1 0 $X=605740 $Y=653700
X740 432 434 1 2 428 AN2 $T=621860 528080 0 180 $X=619380 $Y=522660
X741 2670 2398 1 2 2682 AN2 $T=621860 578480 1 180 $X=619380 $Y=578100
X742 2698 2398 1 2 2709 AN2 $T=626200 568400 1 0 $X=626200 $Y=562980
X743 2712 2398 1 2 445 AN2 $T=626820 558320 1 0 $X=626820 $Y=552900
X744 268 265 1 2 507 AN2 $T=664020 558320 1 0 $X=664020 $Y=552900
X745 2905 526 1 2 2942 AN2 $T=678900 528080 0 0 $X=678900 $Y=527700
X746 2902 2398 1 2 2954 AN2 $T=680760 548240 1 0 $X=680760 $Y=542820
X747 2932 2398 1 2 2956 AN2 $T=680760 558320 0 0 $X=680760 $Y=557940
X748 2923 2398 1 2 2983 AN2 $T=693780 588560 0 180 $X=691300 $Y=583140
X749 2949 2398 1 2 2985 AN2 $T=692540 568400 1 0 $X=692540 $Y=562980
X750 2988 555 1 2 3006 AN2 $T=699980 618800 0 0 $X=699980 $Y=618420
X751 2943 555 1 2 2999 AN2 $T=701220 608720 1 0 $X=701220 $Y=603300
X752 3028 268 1 2 3038 AN2 $T=704320 618800 1 0 $X=704320 $Y=613380
X753 3029 3027 1 2 3063 AN2 $T=708040 568400 1 0 $X=708040 $Y=562980
X754 3007 555 1 2 3018 AN2 $T=710520 618800 0 180 $X=708040 $Y=613380
X755 3062 3063 1 2 3071 AN2 $T=710520 558320 0 0 $X=710520 $Y=557940
X756 3078 3076 1 2 3027 AN2 $T=714240 568400 0 180 $X=711760 $Y=562980
X757 3075 3071 1 2 3061 AN2 $T=717340 548240 1 180 $X=714860 $Y=547860
X758 3096 3095 1 2 3076 AN2 $T=719200 568400 0 180 $X=716720 $Y=562980
X759 3129 3123 1 2 3095 AN2 $T=724160 568400 0 180 $X=721680 $Y=562980
X760 3025 555 1 2 3088 AN2 $T=724160 618800 0 180 $X=721680 $Y=613380
X761 3012 555 1 2 3099 AN2 $T=723540 608720 1 0 $X=723540 $Y=603300
X762 3152 410 1 2 3153 AN2 $T=732220 689360 0 180 $X=729740 $Y=683940
X763 3164 3160 1 2 3123 AN2 $T=732840 568400 1 180 $X=730360 $Y=568020
X764 3191 3185 1 2 3160 AN2 $T=739660 568400 1 180 $X=737180 $Y=568020
X765 3115 555 1 2 3214 AN2 $T=741520 618800 1 0 $X=741520 $Y=613380
X766 3220 3213 1 2 3185 AN2 $T=746480 568400 1 180 $X=744000 $Y=568020
X767 268 265 1 2 3195 AN2 $T=746480 628880 0 180 $X=744000 $Y=623460
X768 3103 555 1 2 3106 AN2 $T=748960 608720 1 0 $X=748960 $Y=603300
X769 3246 3240 1 2 3213 AN2 $T=753300 568400 1 180 $X=750820 $Y=568020
X770 3268 3265 1 2 3240 AN2 $T=758260 568400 1 180 $X=755780 $Y=568020
X771 3258 268 1 2 3267 AN2 $T=755780 638960 1 0 $X=755780 $Y=633540
X772 3312 3299 1 2 3265 AN2 $T=766940 568400 1 180 $X=764460 $Y=568020
X773 3296 555 1 2 3278 AN2 $T=764460 618800 0 0 $X=764460 $Y=618420
X774 3322 3325 1 2 3299 AN2 $T=775000 568400 0 180 $X=772520 $Y=562980
X775 3338 3337 1 2 3325 AN2 $T=779960 568400 1 180 $X=777480 $Y=568020
X776 3232 555 1 2 3248 AN2 $T=779340 608720 1 0 $X=779340 $Y=603300
X777 3366 636 1 2 3360 AN2 $T=785540 528080 0 180 $X=783060 $Y=522660
X778 3378 3369 1 2 3354 AN2 $T=786160 568400 1 180 $X=783680 $Y=568020
X779 3376 3354 1 2 3337 AN2 $T=787400 578480 0 180 $X=784920 $Y=573060
X780 3380 3346 1 2 3375 AN2 $T=788640 548240 0 180 $X=786160 $Y=542820
X781 3380 3352 1 2 3372 AN2 $T=789880 548240 1 180 $X=787400 $Y=547860
X782 3202 555 1 2 3397 AN2 $T=791740 608720 1 0 $X=791740 $Y=603300
X783 3331 647 1 2 3413 AN2 $T=792980 548240 0 0 $X=792980 $Y=547860
X784 3306 647 1 2 3416 AN2 $T=792980 558320 0 0 $X=792980 $Y=557940
X785 3285 647 1 2 3414 AN2 $T=792980 568400 1 0 $X=792980 $Y=562980
X786 3321 647 1 2 3415 AN2 $T=794220 558320 1 0 $X=794220 $Y=552900
X787 3424 3418 1 2 3411 AN2 $T=799180 568400 0 180 $X=796700 $Y=562980
X788 3418 3402 1 2 3419 AN2 $T=796700 568400 0 0 $X=796700 $Y=568020
X789 3419 3424 1 2 3369 AN2 $T=796700 578480 1 0 $X=796700 $Y=573060
X790 3450 3434 1 2 3423 AN2 $T=799800 548240 1 180 $X=797320 $Y=547860
X791 3447 3437 1 2 3418 AN2 $T=801040 558320 1 180 $X=798560 $Y=557940
X792 3423 3459 1 2 3447 AN2 $T=804140 558320 0 180 $X=801660 $Y=552900
X793 3469 3463 1 2 3450 AN2 $T=806620 548240 1 0 $X=806620 $Y=542820
X794 3302 555 1 2 3432 AN2 $T=809720 608720 0 180 $X=807240 $Y=603300
X795 3511 555 1 2 3531 AN2 $T=819020 548240 0 0 $X=819020 $Y=547860
X796 596 675 1 2 673 AN2 $T=826460 689360 1 180 $X=823980 $Y=688980
X797 3583 555 1 2 3501 AN2 $T=831420 568400 1 180 $X=828940 $Y=568020
X798 3629 555 1 2 3540 AN2 $T=840720 548240 1 180 $X=838240 $Y=547860
X799 3657 555 1 2 3588 AN2 $T=845060 548240 1 180 $X=842580 $Y=547860
X800 3647 555 1 2 693 AN2 $T=844440 528080 0 0 $X=844440 $Y=527700
X801 3662 555 1 2 3528 AN2 $T=850640 568400 1 180 $X=848160 $Y=568020
X802 3829 3824 1 2 763 AN2 $T=917600 618800 0 180 $X=915120 $Y=613380
X803 3829 3828 1 2 764 AN2 $T=918220 608720 1 180 $X=915740 $Y=608340
X804 3829 3835 1 2 766 AN2 $T=919460 598640 1 180 $X=916980 $Y=598260
X805 3829 3934 1 2 773 AN2 $T=942400 608720 1 180 $X=939920 $Y=608340
X806 4002 3835 1 2 788 AN2 $T=956040 608720 0 0 $X=956040 $Y=608340
X807 4002 3828 1 2 772 AN2 $T=964100 608720 0 180 $X=961620 $Y=603300
X808 4002 3824 1 2 786 AN2 $T=962240 608720 0 0 $X=962240 $Y=608340
X809 4002 3934 1 2 812 AN2 $T=982700 608720 0 0 $X=982700 $Y=608340
X810 3828 4065 1 2 820 AN2 $T=1008740 608720 1 0 $X=1008740 $Y=603300
X811 3824 4065 1 2 826 AN2 $T=1010600 608720 0 0 $X=1010600 $Y=608340
X812 3835 4065 1 2 819 AN2 $T=1013700 608720 0 180 $X=1011220 $Y=603300
X813 4065 3934 1 2 828 AN2 $T=1023000 608720 0 0 $X=1023000 $Y=608340
X814 4265 4262 1 2 4187 AN2 $T=1035400 548240 1 180 $X=1032920 $Y=547860
X815 3828 4097 1 2 837 AN2 $T=1033540 608720 1 0 $X=1033540 $Y=603300
X816 4267 4264 1 2 4200 AN2 $T=1037260 548240 0 180 $X=1034780 $Y=542820
X817 4271 4268 1 2 4222 AN2 $T=1042220 588560 0 180 $X=1039740 $Y=583140
X818 3824 4097 1 2 835 AN2 $T=1043460 608720 0 0 $X=1043460 $Y=608340
X819 3934 4097 1 2 836 AN2 $T=1043460 618800 1 0 $X=1043460 $Y=613380
X820 4281 4275 1 2 4181 AN2 $T=1047800 568400 1 180 $X=1045320 $Y=568020
X821 4284 4276 1 2 4273 AN2 $T=1047800 618800 1 180 $X=1045320 $Y=618420
X822 4282 4277 1 2 4223 AN2 $T=1047800 638960 1 180 $X=1045320 $Y=638580
X823 4279 4278 1 2 4252 AN2 $T=1047800 689360 1 180 $X=1045320 $Y=688980
X824 3835 4097 1 2 839 AN2 $T=1047180 608720 0 0 $X=1047180 $Y=608340
X825 4297 4293 1 2 4290 AN2 $T=1054620 649040 1 180 $X=1052140 $Y=648660
X826 4310 4306 1 2 4203 AN2 $T=1062680 679280 1 180 $X=1060200 $Y=678900
X827 4327 4320 1 2 4191 AN2 $T=1068260 558320 0 180 $X=1065780 $Y=552900
X828 4328 4325 1 2 4212 AN2 $T=1070120 608720 0 180 $X=1067640 $Y=603300
X829 4331 4329 1 2 4242 AN2 $T=1071360 568400 1 180 $X=1068880 $Y=568020
X830 4333 4330 1 2 4209 AN2 $T=1071360 638960 0 180 $X=1068880 $Y=633540
X831 4340 4335 1 2 4194 AN2 $T=1073840 679280 0 180 $X=1071360 $Y=673860
X832 4342 4339 1 2 4221 AN2 $T=1075080 659120 1 180 $X=1072600 $Y=658740
X833 4359 4338 1 2 4197 AN2 $T=1076940 588560 0 180 $X=1074460 $Y=583140
X834 4357 848 1 2 4216 AN2 $T=1078180 528080 0 180 $X=1075700 $Y=522660
X835 4360 4332 1 2 4261 AN2 $T=1078180 628880 0 180 $X=1075700 $Y=623460
X836 1832 1 2 1842 DELA $T=443300 679280 0 0 $X=443300 $Y=678900
X837 1849 1 2 1871 DELA $T=448260 679280 1 0 $X=448260 $Y=673860
X838 1964 1 2 1960 DELA $T=463140 679280 1 0 $X=463140 $Y=673860
X839 1988 1 2 1982 DELA $T=471820 558320 0 0 $X=471820 $Y=557940
X840 2249 1 2 2273 DELA $T=520800 618800 1 0 $X=520800 $Y=613380
X841 2332 1 2 2345 DELA $T=538780 608720 0 0 $X=538780 $Y=608340
X842 2425 1 2 2431 DELA $T=567300 618800 0 0 $X=567300 $Y=618420
X843 2445 1 2 2484 DELA $T=569160 649040 1 0 $X=569160 $Y=643620
X844 2713 1 2 2603 DELA $T=626820 638960 0 0 $X=626820 $Y=638580
X845 3502 1 2 3370 DELA $T=819020 628880 1 0 $X=819020 $Y=623460
X846 1272 101 107 2 1 1318 QDFFRBN $T=302560 608720 0 0 $X=302560 $Y=608340
X847 1333 101 107 2 1 1357 QDFFRBN $T=319300 618800 1 0 $X=319300 $Y=613380
X848 1390 101 107 2 1 1441 QDFFRBN $T=330460 628880 0 0 $X=330460 $Y=628500
X849 1394 101 107 2 1 1444 QDFFRBN $T=332320 608720 1 0 $X=332320 $Y=603300
X850 1538 101 107 2 1 1460 QDFFRBN $T=359600 608720 0 180 $X=347820 $Y=603300
X851 1539 101 107 2 1 1449 QDFFRBN $T=360840 618800 0 180 $X=349060 $Y=613380
X852 1550 101 107 2 1 1618 QDFFRBN $T=364560 618800 1 0 $X=364560 $Y=613380
X853 1614 171 107 2 1 1659 QDFFRBN $T=376960 608720 1 0 $X=376960 $Y=603300
X854 1627 1637 107 2 1 1688 QDFFRBN $T=380680 618800 1 0 $X=380680 $Y=613380
X855 1638 1637 107 2 1 1693 QDFFRBN $T=382540 608720 0 0 $X=382540 $Y=608340
X856 1653 101 107 2 1 1700 QDFFRBN $T=386260 618800 0 0 $X=386260 $Y=618420
X857 1658 171 107 2 1 1683 QDFFRBN $T=387500 588560 0 0 $X=387500 $Y=588180
X858 1681 1637 107 2 1 1714 QDFFRBN $T=393080 608720 1 0 $X=393080 $Y=603300
X859 1685 171 107 2 1 1672 QDFFRBN $T=394320 588560 1 0 $X=394320 $Y=583140
X860 1689 171 126 2 1 1722 QDFFRBN $T=395560 568400 0 0 $X=395560 $Y=568020
X861 1695 171 126 2 1 1698 QDFFRBN $T=397420 558320 0 0 $X=397420 $Y=557940
X862 1705 1637 107 2 1 1749 QDFFRBN $T=401140 618800 0 0 $X=401140 $Y=618420
X863 1701 101 107 2 1 1739 QDFFRBN $T=401760 628880 1 0 $X=401760 $Y=623460
X864 1746 171 126 2 1 1710 QDFFRBN $T=415400 558320 0 180 $X=403620 $Y=552900
X865 1691 1637 107 2 1 1751 QDFFRBN $T=405480 618800 1 0 $X=405480 $Y=613380
X866 1392 1637 107 2 1 1754 QDFFRBN $T=406100 608720 0 0 $X=406100 $Y=608340
X867 1723 171 126 2 1 1726 QDFFRBN $T=407960 538160 0 0 $X=407960 $Y=537780
X868 1673 1637 107 2 1 1738 QDFFRBN $T=407960 598640 0 0 $X=407960 $Y=598260
X869 1734 1637 107 2 1 1766 QDFFRBN $T=409200 588560 1 0 $X=409200 $Y=583140
X870 1736 1637 107 2 1 1770 QDFFRBN $T=409200 588560 0 0 $X=409200 $Y=588180
X871 1692 1637 107 2 1 1767 QDFFRBN $T=409200 598640 1 0 $X=409200 $Y=593220
X872 1743 1637 126 2 1 1777 QDFFRBN $T=412300 568400 0 0 $X=412300 $Y=568020
X873 1750 1637 126 2 1 1776 QDFFRBN $T=414160 548240 0 0 $X=414160 $Y=547860
X874 1706 171 126 2 1 1742 QDFFRBN $T=426560 528080 0 180 $X=414780 $Y=522660
X875 1729 1637 126 2 1 1796 QDFFRBN $T=415400 568400 1 0 $X=415400 $Y=562980
X876 1753 101 107 2 1 1747 QDFFRBN $T=415400 638960 0 0 $X=415400 $Y=638580
X877 1788 101 107 2 1 1728 QDFFRBN $T=427180 679280 0 180 $X=415400 $Y=673860
X878 1801 101 107 2 1 1718 QDFFRBN $T=429040 659120 1 180 $X=417260 $Y=658740
X879 1761 1637 126 2 1 1799 QDFFRBN $T=418500 558320 1 0 $X=418500 $Y=552900
X880 1765 1637 126 2 1 1822 QDFFRBN $T=419740 528080 0 0 $X=419740 $Y=527700
X881 1769 101 107 2 1 1760 QDFFRBN $T=419740 689360 1 0 $X=419740 $Y=683940
X882 1759 101 107 2 1 1721 QDFFRBN $T=420360 649040 0 0 $X=420360 $Y=648660
X883 1755 101 107 2 1 1732 QDFFRBN $T=420360 659120 1 0 $X=420360 $Y=653700
X884 1778 1637 126 2 1 1837 QDFFRBN $T=423460 548240 1 0 $X=423460 $Y=542820
X885 1762 1637 107 2 1 1831 QDFFRBN $T=423460 588560 1 0 $X=423460 $Y=583140
X886 199 200 126 2 1 1851 QDFFRBN $T=429660 528080 1 0 $X=429660 $Y=522660
X887 201 1814 107 2 1 1873 QDFFRBN $T=430900 649040 1 0 $X=430900 $Y=643620
X888 1806 1814 107 2 1 1858 QDFFRBN $T=430900 659120 0 0 $X=430900 $Y=658740
X889 1818 1814 107 2 1 1882 QDFFRBN $T=433380 638960 1 0 $X=433380 $Y=633540
X890 1805 1814 107 2 1 1879 QDFFRBN $T=433380 649040 0 0 $X=433380 $Y=648660
X891 229 200 126 2 1 1899 QDFFRBN $T=445160 528080 1 0 $X=445160 $Y=522660
X892 1880 231 107 2 1 243 QDFFRBN $T=445160 689360 0 0 $X=445160 $Y=688980
X893 230 1814 107 2 1 1936 QDFFRBN $T=445780 649040 1 0 $X=445780 $Y=643620
X894 1886 1814 107 2 1 1937 QDFFRBN $T=447020 649040 0 0 $X=447020 $Y=648660
X895 1786 1814 107 2 1 1969 QDFFRBN $T=450120 628880 0 0 $X=450120 $Y=628500
X896 1828 1814 107 2 1 1990 QDFFRBN $T=455080 628880 1 0 $X=455080 $Y=623460
X897 1813 1814 107 2 1 1994 QDFFRBN $T=455080 638960 0 0 $X=455080 $Y=638580
X898 248 1814 107 2 1 1996 QDFFRBN $T=458800 649040 1 0 $X=458800 $Y=643620
X899 1966 231 107 2 1 2013 QDFFRBN $T=463140 669200 0 0 $X=463140 $Y=668820
X900 1974 1814 107 2 1 2021 QDFFRBN $T=465000 628880 0 0 $X=465000 $Y=628500
X901 1991 231 107 2 1 2028 QDFFRBN $T=468720 659120 1 0 $X=468720 $Y=653700
X902 1921 1814 107 2 1 2047 QDFFRBN $T=469960 628880 1 0 $X=469960 $Y=623460
X903 1793 1814 107 2 1 1998 QDFFRBN $T=471820 638960 1 0 $X=471820 $Y=633540
X904 1927 1814 107 2 1 2068 QDFFRBN $T=476160 618800 0 0 $X=476160 $Y=618420
X905 2041 1814 107 2 1 2085 QDFFRBN $T=479880 628880 0 0 $X=479880 $Y=628500
X906 2121 231 107 2 1 2053 QDFFRBN $T=494760 649040 1 180 $X=482980 $Y=648660
X907 1963 1814 107 2 1 2149 QDFFRBN $T=486080 638960 1 0 $X=486080 $Y=633540
X908 1572 1814 107 2 1 2140 QDFFRBN $T=487940 618800 0 0 $X=487940 $Y=618420
X909 2127 231 107 2 1 317 QDFFRBN $T=497860 649040 0 0 $X=497860 $Y=648660
X910 2169 319 2211 2 1 2195 QDFFRBN $T=505300 588560 0 0 $X=505300 $Y=588180
X911 2208 231 2211 2 1 324 QDFFRBN $T=512120 649040 1 0 $X=512120 $Y=643620
X912 2265 342 2211 2 1 327 QDFFRBN $T=525760 638960 1 180 $X=513980 $Y=638580
X913 2250 319 2211 2 1 2299 QDFFRBN $T=520800 588560 0 0 $X=520800 $Y=588180
X914 2245 2257 2211 2 1 2306 QDFFRBN $T=521420 598640 0 0 $X=521420 $Y=598260
X915 2280 2257 2211 2 1 2289 QDFFRBN $T=526380 608720 1 0 $X=526380 $Y=603300
X916 2302 342 2211 2 1 339 QDFFRBN $T=530720 649040 1 0 $X=530720 $Y=643620
X917 2355 342 2211 2 1 2309 QDFFRBN $T=546840 659120 0 180 $X=535060 $Y=653700
X918 2331 319 2211 2 1 2272 QDFFRBN $T=547460 578480 1 180 $X=535680 $Y=578100
X919 2323 2257 2211 2 1 2328 QDFFRBN $T=536920 598640 0 0 $X=536920 $Y=598260
X920 2278 2257 2211 2 1 2374 QDFFRBN $T=539400 598640 1 0 $X=539400 $Y=593220
X921 2358 319 2211 2 1 2405 QDFFRBN $T=546220 568400 0 0 $X=546220 $Y=568020
X922 2436 342 2211 2 1 2206 QDFFRBN $T=564820 659120 0 180 $X=553040 $Y=653700
X923 2424 2257 2211 2 1 2399 QDFFRBN $T=567300 598640 1 180 $X=555520 $Y=598260
X924 2456 2257 2211 2 1 2386 QDFFRBN $T=569160 608720 0 180 $X=557380 $Y=603300
X925 2428 319 2211 2 1 2483 QDFFRBN $T=561720 568400 0 0 $X=561720 $Y=568020
X926 2521 2257 2211 2 1 2353 QDFFRBN $T=582800 598640 1 180 $X=571020 $Y=598260
X927 2481 319 2211 2 1 2477 QDFFRBN $T=572880 588560 0 0 $X=572880 $Y=588180
X928 2529 2257 2211 2 1 2480 QDFFRBN $T=584660 608720 0 180 $X=572880 $Y=603300
X929 2582 2257 2211 2 1 2527 QDFFRBN $T=599540 608720 0 180 $X=587760 $Y=603300
X930 2623 319 2211 2 1 2561 QDFFRBN $T=604500 578480 1 180 $X=592720 $Y=578100
X931 2501 319 2211 2 1 2519 QDFFRBN $T=592720 588560 1 0 $X=592720 $Y=583140
X932 2592 342 419 2 1 321 QDFFRBN $T=596440 689360 1 0 $X=596440 $Y=683940
X933 2609 2257 2211 2 1 2601 QDFFRBN $T=598920 598640 1 0 $X=598920 $Y=593220
X934 2673 2257 2211 2 1 2594 QDFFRBN $T=614420 598640 1 180 $X=602640 $Y=598260
X935 2634 342 419 2 1 332 QDFFRBN $T=603880 689360 0 0 $X=603880 $Y=688980
X936 2685 319 2211 2 1 2589 QDFFRBN $T=618140 578480 0 180 $X=606360 $Y=573060
X937 2645 2257 2211 2 1 2686 QDFFRBN $T=608220 588560 0 0 $X=608220 $Y=588180
X938 2651 342 419 2 1 2690 QDFFRBN $T=611940 689360 1 0 $X=611940 $Y=683940
X939 2672 319 2211 2 1 2670 QDFFRBN $T=615660 588560 1 0 $X=615660 $Y=583140
X940 2678 319 2211 2 1 2698 QDFFRBN $T=616900 568400 0 0 $X=616900 $Y=568020
X941 2665 2257 2211 2 1 2721 QDFFRBN $T=616900 598640 0 0 $X=616900 $Y=598260
X942 2687 2257 2211 2 1 2743 QDFFRBN $T=619380 598640 1 0 $X=619380 $Y=593220
X943 2751 2257 2211 2 1 2694 QDFFRBN $T=633640 608720 0 180 $X=621860 $Y=603300
X944 2679 2257 2211 2 1 2701 QDFFRBN $T=636740 588560 1 180 $X=624960 $Y=588180
X945 2747 2257 2211 2 1 2775 QDFFRBN $T=634260 598640 1 0 $X=634260 $Y=593220
X946 2789 319 433 2 1 2712 QDFFRBN $T=650380 558320 0 180 $X=638600 $Y=552900
X947 2819 484 433 2 1 2766 QDFFRBN $T=655960 538160 0 180 $X=644180 $Y=532740
X948 2779 319 433 2 1 2737 QDFFRBN $T=656580 548240 0 180 $X=644800 $Y=542820
X949 2823 484 433 2 1 2773 QDFFRBN $T=657200 548240 1 180 $X=645420 $Y=547860
X950 496 484 433 2 1 2785 QDFFRBN $T=661540 528080 1 180 $X=649760 $Y=527700
X951 500 484 433 2 1 2781 QDFFRBN $T=662160 528080 0 180 $X=650380 $Y=522660
X952 2846 319 433 2 1 2902 QDFFRBN $T=659680 538160 0 0 $X=659680 $Y=537780
X953 519 484 433 2 1 2794 QDFFRBN $T=675800 528080 1 180 $X=664020 $Y=527700
X954 2914 2908 2211 2 1 2839 QDFFRBN $T=675800 638960 0 180 $X=664020 $Y=633540
X955 520 484 433 2 1 2801 QDFFRBN $T=676420 528080 0 180 $X=664640 $Y=522660
X956 2880 508 419 2 1 518 QDFFRBN $T=665260 689360 0 0 $X=665260 $Y=688980
X957 2883 319 2211 2 1 2932 QDFFRBN $T=666500 558320 0 0 $X=666500 $Y=557940
X958 2885 2908 2211 2 1 2888 QDFFRBN $T=680140 628880 0 180 $X=668360 $Y=623460
X959 2933 2908 2211 2 1 2889 QDFFRBN $T=680140 649040 0 180 $X=668360 $Y=643620
X960 2896 319 2211 2 1 2943 QDFFRBN $T=669600 598640 0 0 $X=669600 $Y=598260
X961 2899 319 2211 2 1 2949 QDFFRBN $T=670220 568400 0 0 $X=670220 $Y=568020
X962 2900 319 2211 2 1 2923 QDFFRBN $T=670840 588560 1 0 $X=670840 $Y=583140
X963 2939 2908 2211 2 1 2919 QDFFRBN $T=679520 628880 0 0 $X=679520 $Y=628500
X964 2918 2908 2211 2 1 2989 QDFFRBN $T=679520 638960 0 0 $X=679520 $Y=638580
X965 2967 2908 2211 2 1 2929 QDFFRBN $T=692540 649040 0 180 $X=680760 $Y=643620
X966 3003 2908 2211 2 1 2928 QDFFRBN $T=696260 628880 0 180 $X=684480 $Y=623460
X967 2981 319 2211 2 1 2988 QDFFRBN $T=686960 608720 0 0 $X=686960 $Y=608340
X968 3004 2908 2211 2 1 3056 QDFFRBN $T=694400 638960 1 0 $X=694400 $Y=633540
X969 3022 2908 2211 2 1 3068 QDFFRBN $T=700600 628880 1 0 $X=700600 $Y=623460
X970 3023 2908 2211 2 1 3069 QDFFRBN $T=700600 638960 0 0 $X=700600 $Y=638580
X971 3038 319 2211 2 1 3013 QDFFRBN $T=704940 618800 0 0 $X=704940 $Y=618420
X972 3046 319 563 2 1 3007 QDFFRBN $T=706180 608720 0 0 $X=706180 $Y=608340
X973 3108 2908 2211 2 1 3051 QDFFRBN $T=721680 638960 0 180 $X=709900 $Y=633540
X974 3072 2908 2211 2 1 3087 QDFFRBN $T=712380 638960 0 0 $X=712380 $Y=638580
X975 3138 2908 2211 2 1 3085 QDFFRBN $T=727880 628880 0 180 $X=716100 $Y=623460
X976 3145 576 563 2 1 3012 QDFFRBN $T=732840 608720 1 180 $X=721060 $Y=608340
X977 3173 2908 2211 2 1 3130 QDFFRBN $T=736560 638960 0 180 $X=724780 $Y=633540
X978 3180 576 563 2 1 3025 QDFFRBN $T=739040 618800 1 180 $X=727260 $Y=618420
X979 3142 2908 2211 2 1 3179 QDFFRBN $T=727260 638960 0 0 $X=727260 $Y=638580
X980 3221 576 563 2 1 3103 QDFFRBN $T=748960 608720 1 180 $X=737180 $Y=608340
X981 3235 2908 2211 2 1 3196 QDFFRBN $T=752060 638960 0 180 $X=740280 $Y=633540
X982 3219 2908 594 2 1 3230 QDFFRBN $T=745860 649040 0 0 $X=745860 $Y=648660
X983 3272 576 563 2 1 3115 QDFFRBN $T=760740 628880 0 180 $X=748960 $Y=623460
X984 3267 576 2211 2 1 265 QDFFRBN $T=760740 638960 1 180 $X=748960 $Y=638580
X985 3239 576 563 2 1 3296 QDFFRBN $T=751440 618800 0 0 $X=751440 $Y=618420
X986 3287 576 594 2 1 3242 QDFFRBN $T=763840 649040 0 180 $X=752060 $Y=643620
X987 613 615 594 2 1 3335 QDFFRBN $T=767560 689360 0 0 $X=767560 $Y=688980
X988 3334 576 621 2 1 3125 QDFFRBN $T=781820 618800 0 180 $X=770040 $Y=613380
X989 3395 576 621 2 1 3351 QDFFRBN $T=794220 608720 1 180 $X=782440 $Y=608340
X990 3396 645 640 2 1 3358 QDFFRBN $T=794220 689360 1 180 $X=782440 $Y=688980
X991 2087 576 621 2 1 3422 QDFFRBN $T=783680 628880 1 0 $X=783680 $Y=623460
X992 3407 576 621 2 1 3202 QDFFRBN $T=796700 618800 0 180 $X=784920 $Y=613380
X993 3475 3454 640 2 1 3400 QDFFRBN $T=804760 689360 0 180 $X=792980 $Y=683940
X994 3489 3454 640 2 1 3410 QDFFRBN $T=807240 669200 1 180 $X=795460 $Y=668820
X995 3458 3454 621 2 1 3516 QDFFRBN $T=802280 638960 1 0 $X=802280 $Y=633540
X996 3484 3454 640 2 1 3536 QDFFRBN $T=808480 689360 1 0 $X=808480 $Y=683940
X997 3543 576 621 2 1 3302 QDFFRBN $T=822740 608720 1 180 $X=810960 $Y=608340
X998 672 576 433 2 1 3511 QDFFRBN $T=825220 548240 0 180 $X=813440 $Y=542820
X999 3522 3454 621 2 1 3582 QDFFRBN $T=816540 679280 0 0 $X=816540 $Y=678900
X1000 3575 576 433 2 1 3515 QDFFRBN $T=833900 598640 1 180 $X=822120 $Y=598260
X1001 3553 3454 621 2 1 3595 QDFFRBN $T=822120 638960 1 0 $X=822120 $Y=633540
X1002 3587 3454 621 2 1 3550 QDFFRBN $T=835140 669200 0 180 $X=823360 $Y=663780
X1003 3622 3454 621 2 1 3530 QDFFRBN $T=839480 628880 1 180 $X=827700 $Y=628500
X1004 686 576 433 2 1 3647 QDFFRBN $T=832660 528080 1 0 $X=832660 $Y=522660
X1005 3650 576 433 2 1 3583 QDFFRBN $T=844440 568400 1 180 $X=832660 $Y=568020
X1006 3631 3454 621 2 1 3521 QDFFRBN $T=840100 638960 1 0 $X=840100 $Y=633540
X1007 3635 694 621 2 1 3668 QDFFRBN $T=840100 669200 1 0 $X=840100 $Y=663780
X1008 3636 576 433 2 1 3662 QDFFRBN $T=841340 568400 1 0 $X=841340 $Y=562980
X1009 3646 576 621 2 1 692 QDFFRBN $T=843200 679280 0 0 $X=843200 $Y=678900
X1010 3692 576 433 2 1 3629 QDFFRBN $T=859320 548240 1 180 $X=847540 $Y=547860
X1011 3705 576 433 2 1 3657 QDFFRBN $T=861800 548240 0 180 $X=850020 $Y=542820
X1012 3727 576 433 2 1 3379 QDFFRBN $T=874820 538160 1 180 $X=863040 $Y=537780
X1013 3726 694 621 2 1 3698 QDFFRBN $T=868620 659120 0 0 $X=868620 $Y=658740
X1014 3735 576 433 2 1 3605 QDFFRBN $T=881020 528080 1 180 $X=869240 $Y=527700
X1015 3743 576 433 2 1 3703 QDFFRBN $T=885360 548240 0 180 $X=873580 $Y=542820
X1016 3717 694 621 2 1 3694 QDFFRBN $T=874200 669200 0 0 $X=874200 $Y=668820
X1017 3730 694 621 2 1 3746 QDFFRBN $T=874820 689360 0 0 $X=874820 $Y=688980
X1018 3742 576 433 2 1 3393 QDFFRBN $T=887220 588560 1 180 $X=875440 $Y=588180
X1019 3734 576 621 2 1 3749 QDFFRBN $T=876680 618800 0 0 $X=876680 $Y=618420
X1020 3753 576 433 2 1 3404 QDFFRBN $T=892800 608720 0 180 $X=881020 $Y=603300
X1021 3756 576 433 2 1 3736 QDFFRBN $T=894660 548240 1 180 $X=882880 $Y=547860
X1022 767 576 433 2 1 3745 QDFFRBN $T=898380 578480 0 180 $X=886600 $Y=573060
X1023 3763 576 433 2 1 3741 QDFFRBN $T=899000 568400 1 180 $X=887220 $Y=568020
X1024 3928 615 621 2 1 683 QDFFRBN $T=943640 689360 0 180 $X=931860 $Y=683940
X1025 3951 576 621 2 1 3601 QDFFRBN $T=950460 659120 0 180 $X=938680 $Y=653700
X1026 4001 576 621 2 1 780 QDFFRBN $T=957280 669200 0 180 $X=945500 $Y=663780
X1027 4011 576 621 2 1 675 QDFFRBN $T=959140 689360 0 180 $X=947360 $Y=683940
X1028 4045 615 621 2 1 784 QDFFRBN $T=966580 689360 1 180 $X=954800 $Y=688980
X1029 877 5 896 2 901 9 1 AO22 $T=222580 558320 0 0 $X=222580 $Y=557940
X1030 938 5 898 2 906 8 1 AO22 $T=232500 689360 1 180 $X=227540 $Y=688980
X1031 940 5 895 2 922 9 1 AO22 $T=233120 538160 1 180 $X=228160 $Y=537780
X1032 950 5 897 2 909 8 1 AO22 $T=233120 649040 1 180 $X=228160 $Y=648660
X1033 945 5 914 2 928 8 1 AO22 $T=234360 638960 1 180 $X=229400 $Y=638580
X1034 956 5 907 2 929 8 1 AO22 $T=234980 659120 0 180 $X=230020 $Y=653700
X1035 951 5 913 2 931 9 1 AO22 $T=235600 528080 1 180 $X=230640 $Y=527700
X1036 957 5 916 2 932 9 1 AO22 $T=235600 558320 0 180 $X=230640 $Y=552900
X1037 963 5 872 2 927 9 1 AO22 $T=235600 588560 0 180 $X=230640 $Y=583140
X1038 958 5 915 2 933 8 1 AO22 $T=235600 669200 0 180 $X=230640 $Y=663780
X1039 977 5 920 2 911 8 1 AO22 $T=236220 679280 0 180 $X=231260 $Y=673860
X1040 969 5 917 2 921 9 1 AO22 $T=236840 578480 0 180 $X=231880 $Y=573060
X1041 959 5 918 2 937 9 1 AO22 $T=236840 578480 1 180 $X=231880 $Y=578100
X1042 966 5 873 2 942 9 1 AO22 $T=237460 598640 0 180 $X=232500 $Y=593220
X1043 968 5 926 2 944 8 1 AO22 $T=237460 689360 0 180 $X=232500 $Y=683940
X1044 990 5 874 2 960 9 1 AO22 $T=240560 608720 0 180 $X=235600 $Y=603300
X1045 980 5 884 2 964 8 1 AO22 $T=240560 618800 0 180 $X=235600 $Y=613380
X1046 986 5 919 2 948 8 1 AO22 $T=240560 628880 0 180 $X=235600 $Y=623460
X1047 998 5 925 2 952 8 1 AO22 $T=240560 628880 1 180 $X=235600 $Y=628500
X1048 1004 5 949 2 979 9 1 AO22 $T=243660 598640 1 180 $X=238700 $Y=598260
X1049 1044 5 997 2 1011 8 1 AO22 $T=252340 618800 0 180 $X=247380 $Y=613380
X1050 1057 5 1021 2 1012 8 1 AO22 $T=257300 618800 1 180 $X=252340 $Y=618420
X1051 1064 1025 5 2 1014 8 1 AO22 $T=257920 628880 1 180 $X=252960 $Y=628500
X1052 1083 5 1027 2 1040 9 1 AO22 $T=258540 608720 0 180 $X=253580 $Y=603300
X1053 1095 5 1028 2 1038 9 1 AO22 $T=259160 608720 1 180 $X=254200 $Y=608340
X1054 1089 53 1077 2 1048 1098 1 AO22 $T=269700 588560 1 180 $X=264740 $Y=588180
X1055 1108 1076 1117 2 1092 63 1 AO22 $T=266600 628880 0 0 $X=266600 $Y=628500
X1056 1143 53 1082 2 1111 1098 1 AO22 $T=274040 578480 0 180 $X=269080 $Y=573060
X1057 1106 53 1084 2 1114 1098 1 AO22 $T=269700 578480 0 0 $X=269700 $Y=578100
X1058 1063 53 1102 2 1142 68 1 AO22 $T=271560 538160 0 0 $X=271560 $Y=537780
X1059 1155 53 1125 2 1135 1098 1 AO22 $T=276520 588560 1 180 $X=271560 $Y=588180
X1060 1164 53 1093 2 1133 68 1 AO22 $T=278380 548240 0 180 $X=273420 $Y=542820
X1061 1073 53 1151 2 1161 68 1 AO22 $T=274040 528080 1 0 $X=274040 $Y=522660
X1062 1069 53 1139 2 1158 63 1 AO22 $T=274660 618800 0 0 $X=274660 $Y=618420
X1063 1190 53 1152 2 1174 1098 1 AO22 $T=283340 598640 0 180 $X=278380 $Y=593220
X1064 1208 53 1180 2 1189 63 1 AO22 $T=286440 618800 1 180 $X=281480 $Y=618420
X1065 1213 53 1184 2 1170 1098 1 AO22 $T=289540 588560 1 180 $X=284580 $Y=588180
X1066 1223 53 1183 2 1194 1098 1 AO22 $T=291400 578480 0 180 $X=286440 $Y=573060
X1067 1226 53 1191 2 1201 1098 1 AO22 $T=291400 578480 1 180 $X=286440 $Y=578100
X1068 1225 53 1188 2 1205 1098 1 AO22 $T=292640 568400 1 180 $X=287680 $Y=568020
X1069 1217 53 1212 2 1219 63 1 AO22 $T=298220 628880 0 180 $X=293260 $Y=623460
X1070 1280 53 1261 2 1244 63 1 AO22 $T=304420 628880 0 180 $X=299460 $Y=623460
X1071 1294 1117 1284 2 1236 63 1 AO22 $T=309380 679280 1 180 $X=304420 $Y=678900
X1072 1314 1117 1274 2 1207 63 1 AO22 $T=311860 659120 0 180 $X=306900 $Y=653700
X1073 1309 1117 1273 2 1241 63 1 AO22 $T=311860 669200 0 180 $X=306900 $Y=663780
X1074 1302 1117 1279 2 1246 63 1 AO22 $T=312480 638960 0 180 $X=307520 $Y=633540
X1075 1315 1117 1287 2 1250 63 1 AO22 $T=314960 649040 1 180 $X=310000 $Y=648660
X1076 1325 1117 1292 2 1245 63 1 AO22 $T=316200 638960 1 180 $X=311240 $Y=638580
X1077 1275 1342 1328 2 1310 116 1 AO22 $T=319300 568400 1 0 $X=319300 $Y=562980
X1078 1313 1342 1339 2 1336 116 1 AO22 $T=323020 578480 1 0 $X=323020 $Y=573060
X1079 1337 1342 1379 2 1387 116 1 AO22 $T=328600 578480 0 0 $X=328600 $Y=578100
X1080 1409 1342 1453 2 1442 116 1 AO22 $T=344100 578480 1 0 $X=344100 $Y=573060
X1081 1495 1342 1492 2 1485 116 1 AO22 $T=355880 578480 0 180 $X=350920 $Y=573060
X1082 1416 1486 1490 2 1491 128 1 AO22 $T=350920 638960 0 0 $X=350920 $Y=638580
X1083 162 157 155 2 1503 116 1 AO22 $T=361460 528080 0 180 $X=356500 $Y=522660
X1084 1531 1342 1508 2 1509 116 1 AO22 $T=365800 578480 1 0 $X=365800 $Y=573060
X1085 168 1342 1553 2 1496 116 1 AO22 $T=373860 538160 0 180 $X=368900 $Y=532740
X1086 1601 1342 1558 2 1468 116 1 AO22 $T=373860 548240 0 180 $X=368900 $Y=542820
X1087 1540 1342 1545 2 1500 116 1 AO22 $T=374480 528080 1 180 $X=369520 $Y=527700
X1088 1604 166 1598 2 1557 128 1 AO22 $T=375720 679280 1 180 $X=370760 $Y=678900
X1089 1609 166 1597 2 1571 128 1 AO22 $T=376960 669200 1 180 $X=372000 $Y=668820
X1090 1620 1486 1565 2 1541 128 1 AO22 $T=377580 649040 1 180 $X=372620 $Y=648660
X1091 1555 1486 1587 2 1573 128 1 AO22 $T=373860 638960 0 0 $X=373860 $Y=638580
X1092 1649 1486 1630 2 1574 128 1 AO22 $T=383780 649040 1 180 $X=378820 $Y=648660
X1093 1640 166 1635 2 1484 128 1 AO22 $T=384400 669200 0 180 $X=379440 $Y=663780
X1094 1647 166 1636 2 1548 128 1 AO22 $T=384400 679280 0 180 $X=379440 $Y=673860
X1095 1652 166 1606 2 1577 128 1 AO22 $T=384400 689360 1 180 $X=379440 $Y=688980
X1096 1644 1486 1615 2 1581 128 1 AO22 $T=385020 649040 0 180 $X=380060 $Y=643620
X1097 1904 1827 1919 2 1916 1815 1 AO22 $T=451360 588560 0 0 $X=451360 $Y=588180
X1098 2074 287 2040 2 2016 284 1 AO22 $T=489800 538160 0 180 $X=484840 $Y=532740
X1099 2075 287 2006 2 2026 284 1 AO22 $T=489800 548240 0 180 $X=484840 $Y=542820
X1100 2097 287 2059 2 2064 284 1 AO22 $T=492900 548240 1 180 $X=487940 $Y=547860
X1101 2122 287 2083 2 2073 284 1 AO22 $T=498480 558320 0 180 $X=493520 $Y=552900
X1102 2142 287 2115 2 2086 284 1 AO22 $T=500960 538160 1 180 $X=496000 $Y=537780
X1103 2172 287 2119 2 300 284 1 AO22 $T=506540 548240 0 180 $X=501580 $Y=542820
X1104 2191 287 2176 2 310 284 1 AO22 $T=509020 538160 0 180 $X=504060 $Y=532740
X1105 2156 2168 287 2 2128 284 1 AO22 $T=511500 558320 0 180 $X=506540 $Y=552900
X1106 2170 2192 322 2 2201 2218 1 AO22 $T=508400 558320 0 0 $X=508400 $Y=557940
X1107 2210 287 2200 2 316 284 1 AO22 $T=513980 548240 0 180 $X=509020 $Y=542820
X1108 2214 287 2175 2 303 284 1 AO22 $T=514600 528080 0 180 $X=509640 $Y=522660
X1109 2241 322 2203 2 2223 2218 1 AO22 $T=519560 538160 1 180 $X=514600 $Y=537780
X1110 2178 322 2233 2 2212 2218 1 AO22 $T=519560 558320 1 180 $X=514600 $Y=557940
X1111 2288 1827 2273 2 2197 1815 1 AO22 $T=529480 638960 0 180 $X=524520 $Y=633540
X1112 2228 322 2276 2 2284 2218 1 AO22 $T=525760 558320 1 0 $X=525760 $Y=552900
X1113 2256 322 2283 2 2298 2218 1 AO22 $T=530100 548240 1 0 $X=530100 $Y=542820
X1114 2319 322 2292 2 357 2218 1 AO22 $T=540640 528080 1 180 $X=535680 $Y=527700
X1115 2316 322 2329 2 358 2218 1 AO22 $T=541260 548240 0 180 $X=536300 $Y=542820
X1116 2365 1827 2345 2 2279 1815 1 AO22 $T=544980 628880 0 180 $X=540020 $Y=623460
X1117 2361 322 2352 2 366 2218 1 AO22 $T=547460 548240 0 180 $X=542500 $Y=542820
X1118 2372 1827 2359 2 2354 1815 1 AO22 $T=549320 638960 0 180 $X=544360 $Y=633540
X1119 2401 322 2387 2 2346 2218 1 AO22 $T=554280 538160 1 180 $X=549320 $Y=537780
X1120 2402 1827 2396 2 2347 1815 1 AO22 $T=555520 638960 0 180 $X=550560 $Y=633540
X1121 2409 322 375 2 367 369 1 AO22 $T=556760 528080 0 180 $X=551800 $Y=522660
X1122 2449 1827 2426 2 2270 1815 1 AO22 $T=564200 638960 0 180 $X=559240 $Y=633540
X1123 2445 1827 2431 2 2335 1815 1 AO22 $T=565440 628880 0 180 $X=560480 $Y=623460
X1124 2473 1827 2464 2 2342 1815 1 AO22 $T=572260 628880 0 180 $X=567300 $Y=623460
X1125 2371 394 2491 2 398 401 1 AO22 $T=575980 538160 1 0 $X=575980 $Y=532740
X1126 2476 394 2462 2 393 401 1 AO22 $T=575980 548240 1 0 $X=575980 $Y=542820
X1127 2461 394 2500 2 399 401 1 AO22 $T=577220 538160 0 0 $X=577220 $Y=537780
X1128 2523 1827 2520 2 2504 1815 1 AO22 $T=584040 638960 0 180 $X=579080 $Y=633540
X1129 2488 1827 2546 2 2552 1815 1 AO22 $T=584660 638960 1 0 $X=584660 $Y=633540
X1130 2525 394 2557 2 408 401 1 AO22 $T=587140 528080 1 0 $X=587140 $Y=522660
X1131 2544 394 2549 2 409 401 1 AO22 $T=587140 528080 0 0 $X=587140 $Y=527700
X1132 2578 1827 2551 2 2567 1815 1 AO22 $T=595820 628880 1 180 $X=590860 $Y=628500
X1133 2492 394 2574 2 412 401 1 AO22 $T=592100 538160 0 0 $X=592100 $Y=537780
X1134 2555 1827 2590 2 2503 1815 1 AO22 $T=595820 628880 0 0 $X=595820 $Y=628500
X1135 2591 1827 2603 2 2610 1815 1 AO22 $T=596440 638960 0 0 $X=596440 $Y=638580
X1136 2615 394 2642 2 424 401 1 AO22 $T=606360 528080 1 0 $X=606360 $Y=522660
X1137 2514 1827 2652 2 2653 1815 1 AO22 $T=607600 649040 0 0 $X=607600 $Y=648660
X1138 2547 1827 2657 2 2663 1815 1 AO22 $T=609460 659120 1 0 $X=609460 $Y=653700
X1139 2627 1827 2662 2 2650 1815 1 AO22 $T=611320 628880 0 0 $X=611320 $Y=628500
X1140 2622 1827 2680 2 2684 1815 1 AO22 $T=615660 659120 1 0 $X=615660 $Y=653700
X1141 2667 1827 2688 2 2693 1815 1 AO22 $T=618760 669200 0 0 $X=618760 $Y=668820
X1142 2691 394 2697 2 435 401 1 AO22 $T=624960 538160 0 180 $X=620000 $Y=532740
X1143 437 438 2702 2 2711 443 1 AO22 $T=623720 689360 1 0 $X=623720 $Y=683940
X1144 447 438 2733 2 2741 443 1 AO22 $T=629920 689360 0 0 $X=629920 $Y=688980
X1145 456 438 2750 2 2707 443 1 AO22 $T=634880 689360 0 0 $X=634880 $Y=688980
X1146 459 2398 2737 2 463 403 1 AO22 $T=637360 548240 0 0 $X=637360 $Y=547860
X1147 2997 3031 3036 2 3044 3049 1 AO22 $T=703700 538160 1 0 $X=703700 $Y=532740
X1148 3091 3031 3162 2 3156 3049 1 AO22 $T=730360 578480 0 0 $X=730360 $Y=578100
X1149 3082 3031 3183 2 3193 3049 1 AO22 $T=736560 578480 0 0 $X=736560 $Y=578100
X1150 3100 3031 3210 2 3217 3049 1 AO22 $T=743380 578480 0 0 $X=743380 $Y=578100
X1151 3228 555 3125 2 463 2937 1 AO22 $T=750200 618800 1 180 $X=745240 $Y=618420
X1152 3218 3031 3250 2 3253 3049 1 AO22 $T=752680 578480 0 0 $X=752680 $Y=578100
X1153 3286 3031 3279 2 3275 3049 1 AO22 $T=763840 578480 1 180 $X=758880 $Y=578100
X1154 3244 3031 3330 2 3327 3049 1 AO22 $T=777480 578480 1 180 $X=772520 $Y=578100
X1155 3364 3031 3349 2 3342 3049 1 AO22 $T=783680 578480 1 180 $X=778720 $Y=578100
X1156 3389 3031 3384 2 3381 3049 1 AO22 $T=792360 568400 0 180 $X=787400 $Y=562980
X1157 3390 3031 3385 2 3350 3049 1 AO22 $T=792360 578480 1 180 $X=787400 $Y=578100
X1158 3457 2087 639 2 3417 1843 1 AO22 $T=802900 649040 0 180 $X=797940 $Y=643620
X1159 3466 642 2087 2 1843 3429 1 AO22 $T=805380 628880 1 180 $X=800420 $Y=628500
X1160 3492 656 3431 2 3357 3049 1 AO22 $T=809100 578480 0 180 $X=804140 $Y=573060
X1161 3490 656 3461 2 3414 3049 1 AO22 $T=810960 568400 1 180 $X=806000 $Y=568020
X1162 3512 656 3470 2 3416 3049 1 AO22 $T=812820 568400 0 180 $X=807860 $Y=562980
X1163 3514 656 3500 2 3413 3049 1 AO22 $T=814680 548240 1 180 $X=809720 $Y=547860
X1164 3523 656 3479 2 3415 3049 1 AO22 $T=815300 558320 0 180 $X=810340 $Y=552900
X1165 661 656 3485 2 3455 3049 1 AO22 $T=816540 538160 1 180 $X=811580 $Y=537780
X1166 3545 656 3517 2 3456 3049 1 AO22 $T=820880 528080 0 180 $X=815920 $Y=522660
X1167 3252 625 681 2 683 596 1 AO22 $T=828320 689360 1 0 $X=828320 $Y=683940
X1168 680 610 688 2 3601 596 1 AO22 $T=831420 679280 0 0 $X=831420 $Y=678900
X1169 3591 687 610 2 3605 596 1 AO22 $T=832040 669200 0 0 $X=832040 $Y=668820
X1170 3833 772 3837 2 3852 773 1 AO22 $T=918840 679280 1 0 $X=918840 $Y=673860
X1171 3847 772 3857 2 3860 773 1 AO22 $T=921320 628880 1 0 $X=921320 $Y=623460
X1172 3856 772 3802 2 3867 773 1 AO22 $T=925040 659120 1 0 $X=925040 $Y=653700
X1173 3830 772 3862 2 3868 773 1 AO22 $T=925040 679280 1 0 $X=925040 $Y=673860
X1174 3882 772 3869 2 3865 773 1 AO22 $T=931240 558320 0 180 $X=926280 $Y=552900
X1175 775 772 3864 2 3878 773 1 AO22 $T=933720 528080 0 180 $X=928760 $Y=522660
X1176 3872 772 3884 2 3892 773 1 AO22 $T=930000 578480 0 0 $X=930000 $Y=578100
X1177 3881 772 3898 2 3901 773 1 AO22 $T=931240 659120 1 0 $X=931240 $Y=653700
X1178 3875 772 3893 2 3866 773 1 AO22 $T=931860 538160 1 0 $X=931860 $Y=532740
X1179 3885 772 3894 2 3876 773 1 AO22 $T=931860 548240 1 0 $X=931860 $Y=542820
X1180 3888 772 3897 2 3910 773 1 AO22 $T=932480 628880 0 0 $X=932480 $Y=628500
X1181 3838 772 3895 2 3914 773 1 AO22 $T=933100 598640 0 0 $X=933100 $Y=598260
X1182 3891 772 3911 2 3906 773 1 AO22 $T=933720 679280 1 0 $X=933720 $Y=673860
X1183 3927 772 3918 2 3913 773 1 AO22 $T=939920 578480 1 180 $X=934960 $Y=578100
X1184 3908 772 3871 2 3925 773 1 AO22 $T=935580 568400 0 0 $X=935580 $Y=568020
X1185 3909 772 3921 2 3896 773 1 AO22 $T=935580 628880 1 0 $X=935580 $Y=623460
X1186 3879 772 3931 2 3874 773 1 AO22 $T=937440 558320 0 0 $X=937440 $Y=557940
X1187 3916 772 777 2 3935 773 1 AO22 $T=938680 528080 1 0 $X=938680 $Y=522660
X1188 3937 772 3922 2 3930 773 1 AO22 $T=943640 649040 0 180 $X=938680 $Y=643620
X1189 3907 753 778 2 3941 783 1 AO22 $T=942400 628880 0 0 $X=942400 $Y=628500
X1190 3850 753 785 2 3958 783 1 AO22 $T=946740 608720 0 0 $X=946740 $Y=608340
X1191 3969 753 787 2 3956 783 1 AO22 $T=952320 638960 0 180 $X=947360 $Y=633540
X1192 3955 753 790 2 3989 783 1 AO22 $T=951080 568400 0 0 $X=951080 $Y=568020
X1193 3929 753 791 2 3957 783 1 AO22 $T=951700 538160 0 0 $X=951700 $Y=537780
X1194 4006 753 794 2 3986 783 1 AO22 $T=956660 659120 1 180 $X=951700 $Y=658740
X1195 3973 753 792 2 3996 783 1 AO22 $T=952320 578480 0 0 $X=952320 $Y=578100
X1196 3940 753 793 2 3997 783 1 AO22 $T=952320 659120 1 0 $X=952320 $Y=653700
X1197 3991 753 795 2 3994 783 1 AO22 $T=954180 598640 0 0 $X=954180 $Y=598260
X1198 4036 753 798 2 4025 783 1 AO22 $T=962860 659120 1 180 $X=957900 $Y=658740
X1199 3943 753 800 2 4031 783 1 AO22 $T=959140 538160 1 0 $X=959140 $Y=532740
X1200 4024 753 801 2 4032 783 1 AO22 $T=959760 548240 0 0 $X=959760 $Y=547860
X1201 4028 753 803 2 4037 783 1 AO22 $T=960380 528080 0 0 $X=960380 $Y=527700
X1202 4050 753 804 2 4044 783 1 AO22 $T=967820 628880 1 180 $X=962860 $Y=628500
X1203 4054 753 805 2 4041 783 1 AO22 $T=967820 659120 0 180 $X=962860 $Y=653700
X1204 4079 753 806 2 4046 783 1 AO22 $T=969680 659120 1 180 $X=964720 $Y=658740
X1205 2081 2 2053 2089 2098 1 2056 FA1S $T=496000 679280 0 180 $X=484220 $Y=673860
X1206 2063 2 2053 2071 2109 1 2110 FA1S $T=485460 659120 1 0 $X=485460 $Y=653700
X1207 2098 2 317 2133 2171 1 2112 FA1S $T=508400 669200 1 180 $X=496620 $Y=668820
X1208 2109 2 317 2187 2182 1 2132 FA1S $T=510260 659120 1 180 $X=498480 $Y=658740
X1209 381 2 332 377 2392 1 2465 FA1S $T=558620 689360 0 0 $X=558620 $Y=688980
X1210 392 2 325 2415 2446 1 2538 FA1S $T=570400 689360 1 0 $X=570400 $Y=683940
X1211 2664 2 2459 2628 2631 1 2685 FA1S $T=609460 548240 1 0 $X=609460 $Y=542820
X1212 3010 2 2986 2976 2970 1 2981 FA1S $T=701220 598640 0 180 $X=689440 $Y=593220
X1213 3281 2 3247 3290 3274 1 3239 FA1S $T=766320 618800 0 180 $X=754540 $Y=613380
X1214 901 2 862 1 INV1S $T=226300 558320 0 180 $X=225060 $Y=552900
X1215 906 2 869 1 INV1S $T=226300 689360 0 180 $X=225060 $Y=683940
X1216 7 2 4 1 INV1S $T=227540 528080 0 180 $X=226300 $Y=522660
X1217 909 2 871 1 INV1S $T=228160 638960 1 180 $X=226920 $Y=638580
X1218 911 2 893 1 INV1S $T=228160 669200 1 180 $X=226920 $Y=668820
X1219 922 2 870 1 INV1S $T=229400 548240 0 180 $X=228160 $Y=542820
X1220 921 2 890 1 INV1S $T=229400 568400 0 180 $X=228160 $Y=562980
X1221 927 2 903 1 INV1S $T=230020 588560 0 180 $X=228780 $Y=583140
X1222 933 2 887 1 INV1S $T=231260 669200 1 180 $X=230020 $Y=668820
X1223 932 2 889 1 INV1S $T=231880 548240 1 180 $X=230640 $Y=547860
X1224 928 2 885 1 INV1S $T=231880 638960 0 180 $X=230640 $Y=633540
X1225 942 2 904 1 INV1S $T=233120 588560 1 180 $X=231880 $Y=588180
X1226 944 2 892 1 INV1S $T=233120 679280 1 180 $X=231880 $Y=678900
X1227 960 2 905 1 INV1S $T=234980 608720 1 180 $X=233740 $Y=608340
X1228 964 2 908 1 INV1S $T=234980 618800 1 180 $X=233740 $Y=618420
X1229 948 2 891 1 INV1S $T=234980 628880 0 180 $X=233740 $Y=623460
X1230 952 2 902 1 INV1S $T=234980 628880 1 180 $X=233740 $Y=628500
X1231 931 2 888 1 INV1S $T=238080 528080 1 180 $X=236840 $Y=527700
X1232 937 2 894 1 INV1S $T=238080 578480 1 180 $X=236840 $Y=578100
X1233 929 2 886 1 INV1S $T=238080 659120 0 180 $X=236840 $Y=653700
X1234 24 2 22 1 INV1S $T=239940 689360 0 180 $X=238700 $Y=683940
X1235 24 2 972 1 INV1S $T=239940 649040 1 0 $X=239940 $Y=643620
X1236 979 2 934 1 INV1S $T=241800 598640 0 180 $X=240560 $Y=593220
X1237 1011 2 988 1 INV1S $T=243660 618800 0 180 $X=242420 $Y=613380
X1238 1012 2 993 1 INV1S $T=243660 628880 0 180 $X=242420 $Y=623460
X1239 1038 2 1018 1 INV1S $T=253580 598640 0 180 $X=252340 $Y=593220
X1240 1040 2 995 1 INV1S $T=255440 598640 0 180 $X=254200 $Y=593220
X1241 1048 2 1060 1 INV1S $T=255440 598640 1 0 $X=255440 $Y=593220
X1242 1111 2 1097 1 INV1S $T=268460 568400 1 180 $X=267220 $Y=568020
X1243 1114 2 1059 1 INV1S $T=269080 578480 1 180 $X=267840 $Y=578100
X1244 1133 2 1113 1 INV1S $T=272180 548240 1 180 $X=270940 $Y=547860
X1245 1135 2 1100 1 INV1S $T=272800 588560 0 180 $X=271560 $Y=583140
X1246 53 2 1098 1 INV1S $T=274660 568400 1 180 $X=273420 $Y=568020
X1247 1142 2 1121 1 INV1S $T=277140 538160 0 180 $X=275900 $Y=532740
X1248 1161 2 1175 1 INV1S $T=279000 528080 0 0 $X=279000 $Y=527700
X1249 1170 2 1169 1 INV1S $T=280860 588560 0 180 $X=279620 $Y=583140
X1250 1174 2 1132 1 INV1S $T=279620 598640 0 0 $X=279620 $Y=598260
X1251 1158 2 1163 1 INV1S $T=280860 628880 1 180 $X=279620 $Y=628500
X1252 1194 2 1168 1 INV1S $T=284580 578480 0 180 $X=283340 $Y=573060
X1253 1201 2 1167 1 INV1S $T=284580 588560 0 180 $X=283340 $Y=583140
X1254 1205 2 1162 1 INV1S $T=286440 568400 1 180 $X=285200 $Y=568020
X1255 1189 2 1195 1 INV1S $T=287060 628880 1 180 $X=285820 $Y=628500
X1256 1219 2 1220 1 INV1S $T=292640 628880 1 180 $X=291400 $Y=628500
X1257 1241 2 1233 1 INV1S $T=296980 679280 1 0 $X=296980 $Y=673860
X1258 1246 2 1260 1 INV1S $T=298840 638960 0 0 $X=298840 $Y=638580
X1259 1222 2 1255 1 INV1S $T=298840 679280 0 0 $X=298840 $Y=678900
X1260 1236 2 1256 1 INV1S $T=298840 689360 1 0 $X=298840 $Y=683940
X1261 97 2 98 1 INV1S $T=298840 689360 0 0 $X=298840 $Y=688980
X1262 93 2 63 1 INV1S $T=301320 689360 1 0 $X=301320 $Y=683940
X1263 1245 2 1264 1 INV1S $T=302560 649040 1 0 $X=302560 $Y=643620
X1264 1250 2 1268 1 INV1S $T=303180 659120 1 0 $X=303180 $Y=653700
X1265 1207 2 1253 1 INV1S $T=305660 659120 0 180 $X=304420 $Y=653700
X1266 1244 2 1286 1 INV1S $T=305040 628880 1 0 $X=305040 $Y=623460
X1267 1336 2 1320 1 INV1S $T=319920 568400 1 180 $X=318680 $Y=568020
X1268 1387 2 1360 1 INV1S $T=330460 578480 0 180 $X=329220 $Y=573060
X1269 125 2 121 1 INV1S $T=332940 659120 0 180 $X=331700 $Y=653700
X1270 1411 2 1403 1 INV1S $T=335420 578480 0 180 $X=334180 $Y=573060
X1271 1442 2 1440 1 INV1S $T=344100 578480 0 180 $X=342860 $Y=573060
X1272 140 2 1378 1 INV1S $T=349680 538160 0 180 $X=348440 $Y=532740
X1273 140 2 1470 1 INV1S $T=350300 659120 0 180 $X=349060 $Y=653700
X1274 1485 2 1481 1 INV1S $T=352780 568400 0 180 $X=351540 $Y=562980
X1275 1493 2 1494 1 INV1S $T=353400 578480 0 0 $X=353400 $Y=578100
X1276 1491 2 1483 1 INV1S $T=354640 649040 1 180 $X=353400 $Y=648660
X1277 1500 2 1507 1 INV1S $T=355260 538160 0 0 $X=355260 $Y=537780
X1278 140 2 1506 1 INV1S $T=355880 649040 0 0 $X=355880 $Y=648660
X1279 1503 2 150 1 INV1S $T=357740 528080 1 180 $X=356500 $Y=527700
X1280 128 2 1486 1 INV1S $T=356500 638960 1 0 $X=356500 $Y=633540
X1281 1515 2 1521 1 INV1S $T=358360 558320 1 0 $X=358360 $Y=552900
X1282 1511 2 1526 1 INV1S $T=358980 548240 0 0 $X=358980 $Y=547860
X1283 1496 2 1525 1 INV1S $T=359600 528080 0 0 $X=359600 $Y=527700
X1284 1468 2 1520 1 INV1S $T=360220 538160 0 0 $X=360220 $Y=537780
X1285 1498 2 1537 1 INV1S $T=360840 558320 0 0 $X=360840 $Y=557940
X1286 1533 2 1516 1 INV1S $T=362700 649040 0 180 $X=361460 $Y=643620
X1287 1509 2 1527 1 INV1S $T=363940 568400 0 180 $X=362700 $Y=562980
X1288 140 2 156 1 INV1S $T=363320 689360 0 0 $X=363320 $Y=688980
X1289 1541 2 1549 1 INV1S $T=363940 649040 1 0 $X=363940 $Y=643620
X1290 1524 2 1569 1 INV1S $T=367040 598640 0 0 $X=367040 $Y=598260
X1291 1557 2 1575 1 INV1S $T=367040 679280 0 0 $X=367040 $Y=678900
X1292 1573 2 1562 1 INV1S $T=370140 649040 0 180 $X=368900 $Y=643620
X1293 128 2 1342 1 INV1S $T=369520 528080 1 0 $X=369520 $Y=522660
X1294 1571 2 1580 1 INV1S $T=369520 669200 0 0 $X=369520 $Y=668820
X1295 1577 2 1584 1 INV1S $T=369520 689360 1 0 $X=369520 $Y=683940
X1296 1581 2 1590 1 INV1S $T=370760 649040 0 0 $X=370760 $Y=648660
X1297 128 2 166 1 INV1S $T=375720 669200 1 0 $X=375720 $Y=663780
X1298 1574 2 1608 1 INV1S $T=376960 659120 1 0 $X=376960 $Y=653700
X1299 1548 2 1610 1 INV1S $T=376960 679280 0 0 $X=376960 $Y=678900
X1300 1484 2 1622 1 INV1S $T=378200 669200 0 0 $X=378200 $Y=668820
X1301 190 2 1086 1 INV1S $T=419120 558320 1 180 $X=417880 $Y=557940
X1302 192 2 1096 1 INV1S $T=420360 548240 0 180 $X=419120 $Y=542820
X1303 1752 2 1772 1 INV1S $T=420980 618800 1 0 $X=420980 $Y=613380
X1304 197 2 1081 1 INV1S $T=429040 558320 1 180 $X=427800 $Y=557940
X1305 1832 2 1826 1 INV1S $T=437720 679280 1 180 $X=436480 $Y=678900
X1306 1849 2 1841 1 INV1S $T=442680 679280 0 180 $X=441440 $Y=673860
X1307 1867 2 1859 1 INV1S $T=444540 679280 0 180 $X=443300 $Y=673860
X1308 1839 2 1876 1 INV1S $T=445160 659120 1 0 $X=445160 $Y=653700
X1309 1904 2 1905 1 INV1S $T=451980 659120 0 0 $X=451980 $Y=658740
X1310 1465 2 1920 1 INV1S $T=453220 618800 0 0 $X=453220 $Y=618420
X1311 1913 2 1891 1 INV1S $T=454460 679280 0 180 $X=453220 $Y=673860
X1312 1819 2 1930 1 INV1S $T=456320 598640 0 0 $X=456320 $Y=598260
X1313 240 2 1929 1 INV1S $T=458180 528080 1 180 $X=456940 $Y=527700
X1314 245 2 1112 1 INV1S $T=458800 669200 0 180 $X=457560 $Y=663780
X1315 1940 2 1941 1 INV1S $T=458800 649040 0 0 $X=458800 $Y=648660
X1316 254 2 1107 1 INV1S $T=461280 659120 1 180 $X=460040 $Y=658740
X1317 1964 2 1935 1 INV1S $T=463140 679280 0 180 $X=461900 $Y=673860
X1318 1958 2 1975 1 INV1S $T=468100 669200 1 0 $X=468100 $Y=663780
X1319 1986 2 1992 1 INV1S $T=468720 638960 1 0 $X=468720 $Y=633540
X1320 270 2 1931 1 INV1S $T=471820 689360 1 180 $X=470580 $Y=688980
X1321 2016 2 2019 1 INV1S $T=475540 538160 1 0 $X=475540 $Y=532740
X1322 274 2 1122 1 INV1S $T=477400 649040 0 180 $X=476160 $Y=643620
X1323 2034 2 2023 1 INV1S $T=478020 679280 0 180 $X=476780 $Y=673860
X1324 2026 2 2020 1 INV1S $T=480500 548240 0 0 $X=480500 $Y=547860
X1325 2044 2 2035 1 INV1S $T=481740 638960 1 180 $X=480500 $Y=638580
X1326 282 2 1110 1 INV1S $T=483600 659120 0 180 $X=482360 $Y=653700
X1327 2064 2 2051 1 INV1S $T=484840 548240 1 180 $X=483600 $Y=547860
X1328 2073 2 2066 1 INV1S $T=489180 558320 0 180 $X=487940 $Y=552900
X1329 2080 2 1868 1 INV1S $T=490420 568400 1 180 $X=489180 $Y=568020
X1330 2089 2 2071 1 INV1S $T=490420 659120 1 180 $X=489180 $Y=658740
X1331 2086 2 2093 1 INV1S $T=491040 538160 1 0 $X=491040 $Y=532740
X1332 277 2 2060 1 INV1S $T=492280 679280 1 180 $X=491040 $Y=678900
X1333 300 2 2096 1 INV1S $T=494140 548240 1 0 $X=494140 $Y=542820
X1334 303 2 2138 1 INV1S $T=497860 528080 1 0 $X=497860 $Y=522660
X1335 2099 2 2137 1 INV1S $T=497860 638960 0 0 $X=497860 $Y=638580
X1336 2130 2 2135 1 INV1S $T=498480 628880 0 0 $X=498480 $Y=628500
X1337 2053 2 2136 1 INV1S $T=498480 679280 1 0 $X=498480 $Y=673860
X1338 2107 2 2123 1 INV1S $T=499100 558320 0 0 $X=499100 $Y=557940
X1339 310 2 2153 1 INV1S $T=504060 528080 0 0 $X=504060 $Y=527700
X1340 2111 2 2159 1 INV1S $T=505300 649040 0 180 $X=504060 $Y=643620
X1341 2133 2 2187 1 INV1S $T=504680 669200 1 0 $X=504680 $Y=663780
X1342 316 2 2162 1 INV1S $T=505920 538160 0 0 $X=505920 $Y=537780
X1343 2190 2 2205 1 INV1S $T=509640 628880 1 0 $X=509640 $Y=623460
X1344 324 2 2198 1 INV1S $T=512120 649040 1 180 $X=510880 $Y=648660
X1345 2206 2 2184 1 INV1S $T=512740 679280 0 180 $X=511500 $Y=673860
X1346 2216 2 2230 1 INV1S $T=514600 669200 0 0 $X=514600 $Y=668820
X1347 332 2 306 1 INV1S $T=518320 689360 1 180 $X=517080 $Y=688980
X1348 2212 2 2239 1 INV1S $T=517700 548240 0 0 $X=517700 $Y=547860
X1349 327 2 2238 1 INV1S $T=517700 669200 0 0 $X=517700 $Y=668820
X1350 2223 2 2221 1 INV1S $T=518320 538160 1 0 $X=518320 $Y=532740
X1351 2246 2 2267 1 INV1S $T=526380 679280 0 180 $X=525140 $Y=673860
X1352 2028 2 348 1 INV1S $T=527000 689360 1 0 $X=527000 $Y=683940
X1353 2298 2 2259 1 INV1S $T=529480 538160 0 180 $X=528240 $Y=532740
X1354 2284 2 2252 1 INV1S $T=529480 548240 1 180 $X=528240 $Y=547860
X1355 2309 2 2227 1 INV1S $T=532580 669200 1 180 $X=531340 $Y=668820
X1356 2307 2 2274 1 INV1S $T=533200 659120 1 180 $X=531960 $Y=658740
X1357 357 2 2271 1 INV1S $T=534440 528080 1 180 $X=533200 $Y=527700
X1358 358 2 2313 1 INV1S $T=535680 538160 0 180 $X=534440 $Y=532740
X1359 366 2 2349 1 INV1S $T=544980 528080 0 180 $X=543740 $Y=522660
X1360 367 2 371 1 INV1S $T=545600 528080 1 0 $X=545600 $Y=522660
X1361 2321 2 2360 1 INV1S $T=545600 669200 1 0 $X=545600 $Y=663780
X1362 2288 2 2363 1 INV1S $T=546840 649040 1 0 $X=546840 $Y=643620
X1363 2346 2 2393 1 INV1S $T=550560 538160 1 0 $X=550560 $Y=532740
X1364 2353 2 2390 1 INV1S $T=553660 608720 1 180 $X=552420 $Y=608340
X1365 2372 2 2407 1 INV1S $T=556760 638960 1 0 $X=556760 $Y=633540
X1366 373 2 2413 1 INV1S $T=557380 669200 0 0 $X=557380 $Y=668820
X1367 376 2 2415 1 INV1S $T=557380 689360 0 0 $X=557380 $Y=688980
X1368 379 2 2439 1 INV1S $T=562340 669200 0 0 $X=562340 $Y=668820
X1369 2451 2 2433 1 INV1S $T=567300 659120 0 180 $X=566060 $Y=653700
X1370 2365 2 2460 1 INV1S $T=570400 649040 1 180 $X=569160 $Y=648660
X1371 2468 2 2453 1 INV1S $T=570400 659120 1 180 $X=569160 $Y=658740
X1372 282 2 388 1 INV1S $T=570400 528080 0 0 $X=570400 $Y=527700
X1373 274 2 390 1 INV1S $T=571640 528080 0 0 $X=571640 $Y=527700
X1374 2469 2 2452 1 INV1S $T=572260 608720 0 0 $X=572260 $Y=608340
X1375 2488 2 2486 1 INV1S $T=575360 638960 1 180 $X=574120 $Y=638580
X1376 393 2 2479 1 INV1S $T=575980 538160 1 180 $X=574740 $Y=537780
X1377 395 2 396 1 INV1S $T=577220 689360 0 0 $X=577220 $Y=688980
X1378 2419 2 2513 1 INV1S $T=582800 649040 0 180 $X=581560 $Y=643620
X1379 2523 2 2510 1 INV1S $T=582800 659120 1 180 $X=581560 $Y=658740
X1380 399 2 2531 1 INV1S $T=582800 538160 1 0 $X=582800 $Y=532740
X1381 398 2 2509 1 INV1S $T=585900 538160 0 180 $X=584660 $Y=532740
X1382 2402 2 2534 1 INV1S $T=585900 669200 0 0 $X=585900 $Y=668820
X1383 2548 2 2556 1 INV1S $T=587760 669200 1 0 $X=587760 $Y=663780
X1384 2484 2 2563 1 INV1S $T=589000 679280 1 0 $X=589000 $Y=673860
X1385 409 2 2558 1 INV1S $T=590860 538160 0 180 $X=589620 $Y=532740
X1386 2514 2 2543 1 INV1S $T=592720 649040 1 180 $X=591480 $Y=648660
X1387 2547 2 2571 1 INV1S $T=593960 659120 0 0 $X=593960 $Y=658740
X1388 412 2 2583 1 INV1S $T=596440 528080 0 0 $X=596440 $Y=527700
X1389 2605 2 2595 1 INV1S $T=598300 659120 0 180 $X=597060 $Y=653700
X1390 408 2 2593 1 INV1S $T=598920 528080 1 0 $X=598920 $Y=522660
X1391 2622 2 2629 1 INV1S $T=605120 649040 0 0 $X=605120 $Y=648660
X1392 2627 2 2636 1 INV1S $T=607600 669200 0 0 $X=607600 $Y=668820
X1393 2654 2 2630 1 INV1S $T=616900 669200 1 180 $X=615660 $Y=668820
X1394 438 2 1815 1 INV1S $T=624960 669200 1 180 $X=623720 $Y=668820
X1395 1951 2 2760 1 INV1S $T=638600 568400 1 0 $X=638600 $Y=562980
X1396 1893 2 2769 1 INV1S $T=643560 558320 0 0 $X=643560 $Y=557940
X1397 2061 2 2774 1 INV1S $T=644800 558320 0 0 $X=644800 $Y=557940
X1398 1881 2 2791 1 INV1S $T=647900 558320 0 0 $X=647900 $Y=557940
X1399 1956 2 2821 1 INV1S $T=654100 568400 0 0 $X=654100 $Y=568020
X1400 1909 2 2828 1 INV1S $T=655340 558320 1 0 $X=655340 $Y=552900
X1401 2045 2 2834 1 INV1S $T=657820 558320 1 0 $X=657820 $Y=552900
X1402 2801 2 2854 1 INV1S $T=666500 568400 0 180 $X=665260 $Y=562980
X1403 2878 2 2803 1 INV1S $T=665880 578480 0 0 $X=665880 $Y=578100
X1404 2027 2 2891 1 INV1S $T=667740 568400 1 0 $X=667740 $Y=562980
X1405 2139 2 2890 1 INV1S $T=667740 568400 0 0 $X=667740 $Y=568020
X1406 2065 2 2895 1 INV1S $T=667740 578480 0 0 $X=667740 $Y=578100
X1407 2108 2 2904 1 INV1S $T=670220 588560 0 0 $X=670220 $Y=588180
X1408 2649 2 2901 1 INV1S $T=670220 618800 0 0 $X=670220 $Y=618420
X1409 2656 2 2912 1 INV1S $T=672080 618800 0 0 $X=672080 $Y=618420
X1410 2430 2 2910 1 INV1S $T=672700 618800 1 0 $X=672700 $Y=613380
X1411 2094 2 2087 1 INV1S $T=672700 628880 0 0 $X=672700 $Y=628500
X1412 2542 2 2962 1 INV1S $T=684480 608720 0 0 $X=684480 $Y=608340
X1413 2211 2 2948 1 INV1S $T=686340 649040 1 180 $X=685100 $Y=648660
X1414 204 2 2398 1 INV1S $T=687580 578480 0 0 $X=687580 $Y=578100
X1415 2946 2 2963 1 INV1S $T=688820 659120 0 180 $X=687580 $Y=653700
X1416 3001 2 2837 1 INV1S $T=694400 538160 0 0 $X=694400 $Y=537780
X1417 3008 2 3021 1 INV1S $T=696880 659120 1 0 $X=696880 $Y=653700
X1418 2499 2 3034 1 INV1S $T=701840 608720 0 0 $X=701840 $Y=608340
X1419 3050 2 3029 1 INV1S $T=706800 568400 0 180 $X=705560 $Y=562980
X1420 3037 2 3065 1 INV1S $T=714860 548240 0 180 $X=713620 $Y=542820
X1421 3081 2 3078 1 INV1S $T=715480 568400 0 180 $X=714240 $Y=562980
X1422 3042 2 3075 1 INV1S $T=715480 558320 1 0 $X=715480 $Y=552900
X1423 3052 2 3062 1 INV1S $T=717340 558320 1 180 $X=716100 $Y=557940
X1424 274 2 565 1 INV1S $T=716720 538160 1 0 $X=716720 $Y=532740
X1425 282 2 570 1 INV1S $T=718580 528080 0 0 $X=718580 $Y=527700
X1426 3110 2 3096 1 INV1S $T=721060 568400 0 180 $X=719820 $Y=562980
X1427 3140 2 3129 1 INV1S $T=727260 568400 0 180 $X=726020 $Y=562980
X1428 3156 2 3164 1 INV1S $T=733460 568400 0 0 $X=733460 $Y=568020
X1429 3193 2 3191 1 INV1S $T=740900 568400 1 180 $X=739660 $Y=568020
X1430 3217 2 3220 1 INV1S $T=748960 568400 1 180 $X=747720 $Y=568020
X1431 3253 2 3246 1 INV1S $T=755160 568400 1 180 $X=753920 $Y=568020
X1432 3275 2 3268 1 INV1S $T=760740 568400 1 180 $X=759500 $Y=568020
X1433 604 2 3288 1 INV1S $T=763840 689360 0 180 $X=762600 $Y=683940
X1434 3309 2 3312 1 INV1S $T=768800 568400 1 0 $X=768800 $Y=562980
X1435 3327 2 3322 1 INV1S $T=775000 558320 1 180 $X=773760 $Y=557940
X1436 3342 2 3338 1 INV1S $T=781200 568400 1 180 $X=779960 $Y=568020
X1437 513 2 3353 1 INV1S $T=781200 669200 1 0 $X=781200 $Y=663780
X1438 3350 2 3376 1 INV1S $T=785540 578480 0 0 $X=785540 $Y=578100
X1439 3381 2 3378 1 INV1S $T=788640 568400 1 180 $X=787400 $Y=568020
X1440 606 2 3386 1 INV1S $T=788640 528080 1 0 $X=788640 $Y=522660
X1441 574 2 3380 1 INV1S $T=788640 548240 1 0 $X=788640 $Y=542820
X1442 3362 2 3388 1 INV1S $T=789880 659120 1 0 $X=789880 $Y=653700
X1443 3392 2 3344 1 INV1S $T=792360 659120 0 180 $X=791120 $Y=653700
X1444 3049 2 3031 1 INV1S $T=792980 548240 0 180 $X=791740 $Y=542820
X1445 647 2 3109 1 INV1S $T=792980 548240 1 180 $X=791740 $Y=547860
X1446 3405 2 3345 1 INV1S $T=794840 538160 0 180 $X=793600 $Y=532740
X1447 3357 2 3402 1 INV1S $T=793600 578480 0 0 $X=793600 $Y=578100
X1448 3414 2 3424 1 INV1S $T=796700 558320 0 0 $X=796700 $Y=557940
X1449 3422 2 3440 1 INV1S $T=797320 618800 0 0 $X=797320 $Y=618420
X1450 3425 2 3439 1 INV1S $T=797320 649040 0 0 $X=797320 $Y=648660
X1451 3352 2 3444 1 INV1S $T=798560 538160 0 0 $X=798560 $Y=537780
X1452 3229 2 3445 1 INV1S $T=798560 618800 1 0 $X=798560 $Y=613380
X1453 3416 2 3437 1 INV1S $T=799180 558320 1 0 $X=799180 $Y=552900
X1454 3455 2 3469 1 INV1S $T=802280 538160 0 0 $X=802280 $Y=537780
X1455 652 2 3460 1 INV1S $T=802280 679280 0 0 $X=802280 $Y=678900
X1456 3386 2 3462 1 INV1S $T=802900 538160 1 0 $X=802900 $Y=532740
X1457 3413 2 3434 1 INV1S $T=806000 548240 0 180 $X=804760 $Y=542820
X1458 2777 2 3494 1 INV1S $T=810340 618800 0 0 $X=810340 $Y=618420
X1459 3443 2 3510 1 INV1S $T=812820 528080 0 0 $X=812820 $Y=527700
X1460 183 2 3505 1 INV1S $T=812820 628880 1 0 $X=812820 $Y=623460
X1461 3410 2 3481 1 INV1S $T=812820 659120 1 0 $X=812820 $Y=653700
X1462 3464 2 3495 1 INV1S $T=814680 659120 0 0 $X=814680 $Y=658740
X1463 3415 2 3459 1 INV1S $T=816540 558320 1 0 $X=816540 $Y=552900
X1464 663 2 3508 1 INV1S $T=819020 679280 0 180 $X=817780 $Y=673860
X1465 668 2 3520 1 INV1S $T=820880 669200 1 180 $X=819640 $Y=668820
X1466 3516 2 655 1 INV1S $T=820260 638960 1 0 $X=820260 $Y=633540
X1467 2906 2 3557 1 INV1S $T=822120 608720 1 0 $X=822120 $Y=603300
X1468 3538 2 3559 1 INV1S $T=822740 598640 1 0 $X=822740 $Y=593220
X1469 3529 2 3563 1 INV1S $T=824600 608720 0 0 $X=824600 $Y=608340
X1470 3128 2 3561 1 INV1S $T=824600 618800 0 0 $X=824600 $Y=618420
X1471 2830 2 3572 1 INV1S $T=827080 578480 0 0 $X=827080 $Y=578100
X1472 2884 2 3569 1 INV1S $T=827080 618800 1 0 $X=827080 $Y=613380
X1473 679 2 3567 1 INV1S $T=828940 528080 0 180 $X=827700 $Y=522660
X1474 3205 2 3594 1 INV1S $T=827700 608720 0 0 $X=827700 $Y=608340
X1475 2875 2 3580 1 INV1S $T=827700 618800 0 0 $X=827700 $Y=618420
X1476 2859 2 3578 1 INV1S $T=828320 618800 1 0 $X=828320 $Y=613380
X1477 3448 2 3573 1 INV1S $T=828320 628880 1 0 $X=828320 $Y=623460
X1478 3566 2 3576 1 INV1S $T=828940 588560 0 0 $X=828940 $Y=588180
X1479 2843 2 3584 1 INV1S $T=830800 588560 1 0 $X=830800 $Y=583140
X1480 3599 2 3607 1 INV1S $T=834520 608720 0 0 $X=834520 $Y=608340
X1481 3457 2 3627 1 INV1S $T=835140 628880 1 0 $X=835140 $Y=623460
X1482 3609 2 3604 1 INV1S $T=836380 538160 1 0 $X=836380 $Y=532740
X1483 2797 2 3611 1 INV1S $T=836380 588560 0 0 $X=836380 $Y=588180
X1484 3530 2 3600 1 INV1S $T=837000 638960 0 0 $X=837000 $Y=638580
X1485 2814 2 3623 1 INV1S $T=838860 568400 1 0 $X=838860 $Y=562980
X1486 2826 2 3624 1 INV1S $T=838860 588560 0 0 $X=838860 $Y=588180
X1487 2872 2 3625 1 INV1S $T=838860 598640 0 0 $X=838860 $Y=598260
X1488 2835 2 3637 1 INV1S $T=839480 588560 1 0 $X=839480 $Y=583140
X1489 3466 2 3630 1 INV1S $T=839480 618800 0 0 $X=839480 $Y=618420
X1490 2892 2 3655 1 INV1S $T=840100 578480 1 0 $X=840100 $Y=573060
X1491 2851 2 3633 1 INV1S $T=840100 588560 0 0 $X=840100 $Y=588180
X1492 2860 2 3638 1 INV1S $T=840100 598640 1 0 $X=840100 $Y=593220
X1493 2858 2 3643 1 INV1S $T=840100 598640 0 0 $X=840100 $Y=598260
X1494 3612 2 3634 1 INV1S $T=840100 618800 1 0 $X=840100 $Y=613380
X1495 693 2 3596 1 INV1S $T=841340 538160 1 0 $X=841340 $Y=532740
X1496 3476 2 3640 1 INV1S $T=841340 618800 1 0 $X=841340 $Y=613380
X1497 3597 2 3656 1 INV1S $T=844440 598640 0 0 $X=844440 $Y=598260
X1498 692 2 3628 1 INV1S $T=845060 659120 0 0 $X=845060 $Y=658740
X1499 3518 2 3558 1 INV1S $T=845680 659120 1 0 $X=845680 $Y=653700
X1500 3166 2 3663 1 INV1S $T=848780 628880 0 0 $X=848780 $Y=628500
X1501 3521 2 3632 1 INV1S $T=848780 638960 0 0 $X=848780 $Y=638580
X1502 3073 2 3666 1 INV1S $T=851260 638960 0 0 $X=851260 $Y=638580
X1503 2864 2 3669 1 INV1S $T=851880 568400 0 0 $X=851880 $Y=568020
X1504 3080 2 3670 1 INV1S $T=851880 628880 0 0 $X=851880 $Y=628500
X1505 3102 2 3693 1 INV1S $T=851880 649040 1 0 $X=851880 $Y=643620
X1506 3215 2 3671 1 INV1S $T=852500 638960 0 0 $X=852500 $Y=638580
X1507 3586 2 3681 1 INV1S $T=853120 608720 1 0 $X=853120 $Y=603300
X1508 3047 2 3675 1 INV1S $T=853120 628880 0 0 $X=853120 $Y=628500
X1509 3048 2 3682 1 INV1S $T=854360 638960 0 0 $X=854360 $Y=638580
X1510 3668 2 3683 1 INV1S $T=856840 659120 0 0 $X=856840 $Y=658740
X1511 3674 2 3667 1 INV1S $T=858080 689360 0 180 $X=856840 $Y=683940
X1512 3703 2 3570 1 INV1S $T=859320 558320 0 180 $X=858080 $Y=552900
X1513 3698 2 3696 1 INV1S $T=859940 659120 0 180 $X=858700 $Y=653700
X1514 710 2 3699 1 INV1S $T=858700 689360 0 0 $X=858700 $Y=688980
X1515 3694 2 3725 1 INV1S $T=868000 679280 1 0 $X=868000 $Y=673860
X1516 3721 2 723 1 INV1S $T=870480 689360 1 0 $X=870480 $Y=683940
X1517 3708 2 3814 1 INV1S $T=909540 598640 0 0 $X=909540 $Y=598260
X1518 3731 2 3912 1 INV1S $T=938060 598640 0 0 $X=938060 $Y=598260
X1519 3939 2 3945 1 INV1S $T=946740 608720 1 180 $X=945500 $Y=608340
X1520 3728 2 3924 1 INV1S $T=947360 598640 1 0 $X=947360 $Y=593220
X1521 3944 2 3960 1 INV1S $T=949840 608720 1 0 $X=949840 $Y=603300
X1522 4065 2 4097 1 INV1S $T=988900 618800 1 0 $X=988900 $Y=613380
X1523 1903 1 2 1892 BUF1S $T=450740 558320 1 0 $X=450740 $Y=552900
X1524 2449 1 2 2451 BUF1S $T=567300 628880 0 0 $X=567300 $Y=628500
X1525 2473 1 2 2468 BUF1S $T=572260 628880 1 0 $X=572260 $Y=623460
X1526 2745 1 2 2750 BUF1S $T=634260 588560 1 0 $X=634260 $Y=583140
X1527 2776 1 2 477 BUF1S $T=645420 628880 1 0 $X=645420 $Y=623460
X1528 2893 1 2 512 BUF1S $T=668980 608720 0 0 $X=668980 $Y=608340
X1529 2920 1 2 522 BUF1S $T=674560 689360 1 0 $X=674560 $Y=683940
X1530 2934 1 2 529 BUF1S $T=678280 689360 1 0 $X=678280 $Y=683940
X1531 3430 1 2 3425 BUF1S $T=797320 638960 0 0 $X=797320 $Y=638580
X1532 3675 1 2 3691 BUF1S $T=855600 628880 1 0 $X=855600 $Y=623460
X1533 3682 1 2 3715 BUF1S $T=861800 638960 0 0 $X=861800 $Y=638580
X1534 3721 1 2 3688 BUF1S $T=868000 689360 1 0 $X=868000 $Y=683940
X1535 968 1 1299 1306 2 ND2P $T=313100 679280 1 180 $X=309380 $Y=678900
X1536 1294 1 1299 1316 2 ND2P $T=313720 679280 0 180 $X=310000 $Y=673860
X1537 1327 1 1348 1334 2 ND2P $T=324260 669200 1 180 $X=320540 $Y=668820
X1538 1436 1 1396 1395 2 ND2P $T=339760 598640 1 0 $X=339760 $Y=593220
X1539 1266 1 1554 1560 2 ND2P $T=363940 608720 1 0 $X=363940 $Y=603300
X1540 1592 1 1628 1632 2 ND2P $T=379440 548240 0 0 $X=379440 $Y=547860
X1541 1593 1 1633 1576 2 ND2P $T=384400 598640 1 180 $X=380680 $Y=598260
X1542 1298 1 1633 1579 2 ND2P $T=385020 588560 1 180 $X=381300 $Y=588180
X1543 1677 1 1675 1670 2 ND2P $T=391840 689360 1 0 $X=391840 $Y=683940
X1544 1604 1 1675 1663 2 ND2P $T=392460 679280 1 0 $X=392460 $Y=673860
X1545 176 1 1687 1696 2 ND2P $T=398040 548240 1 0 $X=398040 $Y=542820
X1546 1694 1 1716 1711 2 ND2P $T=403620 649040 1 0 $X=403620 $Y=643620
X1547 1368 1 1725 1731 2 ND2P $T=411060 679280 0 0 $X=411060 $Y=678900
X1548 2097 1 2269 2286 2 ND2P $T=530100 568400 1 0 $X=530100 $Y=562980
X1549 2316 1 2343 2340 2 ND2P $T=544980 548240 1 180 $X=541260 $Y=547860
X1550 2210 1 2397 2388 2 ND2P $T=554900 548240 1 180 $X=551180 $Y=547860
X1551 2361 1 2397 2379 2 ND2P $T=558000 548240 1 0 $X=558000 $Y=542820
X1552 2482 1 2607 2584 2 ND2P $T=597680 538160 1 0 $X=597680 $Y=532740
X1553 2648 1 2705 2749 2 ND2P $T=634260 558320 1 0 $X=634260 $Y=552900
X1554 521 1 2926 2961 2 ND2P $T=684480 578480 1 0 $X=684480 $Y=573060
X1555 2917 1 2926 2968 2 ND2P $T=686960 568400 1 0 $X=686960 $Y=562980
X1556 3079 1 3058 3054 2 ND2P $T=714860 598640 1 0 $X=714860 $Y=593220
X1557 187 1 610 268 2 ND2P $T=786780 638960 0 180 $X=783060 $Y=633540
X1558 647 1 3380 3409 2 ND2P $T=792980 548240 1 0 $X=792980 $Y=542820
X1559 650 1 3435 3420 2 ND2P $T=800420 608720 1 0 $X=800420 $Y=603300
X1560 655 1 2937 660 2 ND2P $T=809720 618800 1 0 $X=809720 $Y=613380
X1561 3598 1 3592 3590 2 ND2P $T=836380 558320 1 180 $X=832660 $Y=557940
X1562 3606 1 690 3613 2 ND2P $T=834520 689360 1 0 $X=834520 $Y=683940
X1563 682 1 3616 3555 2 ND2P $T=835760 588560 1 0 $X=835760 $Y=583140
X1564 3658 1 3483 3660 2 ND2P $T=850020 618800 1 0 $X=850020 $Y=613380
X1565 50 51 64 2 1 67 XOR3 $T=262260 528080 0 0 $X=262260 $Y=527700
X1566 1083 1106 1099 2 1 1186 XOR3 $T=269080 608720 1 0 $X=269080 $Y=603300
X1567 990 1155 1199 2 1 1230 XOR3 $T=282720 608720 0 0 $X=282720 $Y=608340
X1568 966 1213 1211 2 1 1266 XOR3 $T=289540 588560 0 0 $X=289540 $Y=588180
X1569 877 1143 1218 2 1 1281 XOR3 $T=293260 558320 0 0 $X=293260 $Y=557940
X1570 1275 1282 1307 2 1 1300 XOR3 $T=303800 588560 0 0 $X=303800 $Y=588180
X1571 969 1225 1235 2 1 1330 XOR3 $T=304420 568400 0 0 $X=304420 $Y=568020
X1572 1269 1186 1276 2 1 1272 XOR3 $T=307520 608720 1 0 $X=307520 $Y=603300
X1573 998 1302 1326 2 1 1372 XOR3 $T=314340 628880 0 0 $X=314340 $Y=628500
X1574 956 1314 1323 2 1 1366 XOR3 $T=315580 659120 1 0 $X=315580 $Y=653700
X1575 1313 1319 1308 2 1 1269 XOR3 $T=317440 588560 1 0 $X=317440 $Y=583140
X1576 1364 1187 1338 2 1 1333 XOR3 $T=329220 608720 1 180 $X=318060 $Y=608340
X1577 1337 1344 1347 2 1 1364 XOR3 $T=324260 588560 0 0 $X=324260 $Y=588180
X1578 1436 1230 1396 2 1 1394 XOR3 $T=342860 598640 1 180 $X=331700 $Y=598260
X1579 1409 1415 1420 2 1 1462 XOR3 $T=336040 578480 0 0 $X=336040 $Y=578100
X1580 1416 1422 1452 2 1 1389 XOR3 $T=337280 618800 0 0 $X=337280 $Y=618420
X1581 1531 1536 1559 2 1 1593 XOR3 $T=361460 588560 0 0 $X=361460 $Y=588180
X1582 1540 1546 164 2 1 1603 XOR3 $T=363320 538160 0 0 $X=363320 $Y=537780
X1583 1298 1593 1633 2 1 1658 XOR3 $T=374480 588560 1 0 $X=374480 $Y=583140
X1584 1601 1605 1612 2 1 1678 XOR3 $T=375720 538160 1 0 $X=375720 $Y=532740
X1585 1588 1595 1602 2 1 1616 XOR3 $T=388740 578480 0 180 $X=377580 $Y=573060
X1586 162 172 175 2 1 178 XOR3 $T=378200 528080 1 0 $X=378200 $Y=522660
X1587 1625 1330 1619 2 1 1689 XOR3 $T=383160 568400 0 0 $X=383160 $Y=568020
X1588 1649 1654 1664 2 1 1694 XOR3 $T=385640 649040 0 0 $X=385640 $Y=648660
X1589 173 174 180 2 1 181 XOR3 $T=385640 669200 0 0 $X=385640 $Y=668820
X1590 1652 1650 177 2 1 1712 XOR3 $T=386260 689360 0 0 $X=386260 $Y=688980
X1591 1668 1281 1684 2 1 1695 XOR3 $T=389360 558320 1 0 $X=389360 $Y=552900
X1592 1647 1657 1669 2 1 1703 XOR3 $T=389980 669200 1 0 $X=389980 $Y=663780
X1593 1603 45 179 2 1 1706 XOR3 $T=390600 528080 1 0 $X=390600 $Y=522660
X1594 1640 1662 1651 2 1 1708 XOR3 $T=391220 659120 1 0 $X=391220 $Y=653700
X1595 176 1145 1687 2 1 1723 XOR3 $T=394320 538160 1 0 $X=394320 $Y=532740
X1596 1463 1694 1716 2 1 1753 XOR3 $T=407340 638960 1 0 $X=407340 $Y=633540
X1597 1704 1368 1725 2 1 1788 XOR3 $T=416640 679280 0 0 $X=416640 $Y=678900
X1598 1703 1381 1737 2 1 1801 XOR3 $T=419120 669200 1 0 $X=419120 $Y=663780
X1599 2178 2163 2196 2 1 2209 XOR3 $T=508400 578480 1 0 $X=508400 $Y=573060
X1600 2202 2209 2204 2 1 2169 XOR3 $T=515220 588560 1 0 $X=515220 $Y=583140
X1601 2287 2290 2293 2 1 2331 XOR3 $T=528240 578480 1 0 $X=528240 $Y=573060
X1602 2241 2075 2264 2 1 2341 XOR3 $T=533820 568400 0 0 $X=533820 $Y=568020
X1603 2337 2341 2344 2 1 2358 XOR3 $T=540640 558320 0 0 $X=540640 $Y=557940
X1604 2228 2122 2224 2 1 2301 XOR3 $T=547460 578480 0 0 $X=547460 $Y=578100
X1605 2371 2382 2377 2 1 2202 XOR3 $T=554900 588560 0 0 $X=554900 $Y=588180
X1606 2432 2438 2443 2 1 2501 XOR3 $T=562960 548240 0 0 $X=562960 $Y=547860
X1607 2461 2466 2463 2 1 2291 XOR3 $T=569160 588560 1 0 $X=569160 $Y=583140
X1608 2476 2447 2474 2 1 2287 XOR3 $T=576600 578480 1 0 $X=576600 $Y=573060
X1609 2401 2142 2410 2 1 2532 XOR3 $T=580320 558320 1 0 $X=580320 $Y=552900
X1610 2492 2497 2490 2 1 2420 XOR3 $T=584040 568400 1 0 $X=584040 $Y=562980
X1611 2615 2612 2624 2 1 2540 XOR3 $T=600780 558320 1 0 $X=600780 $Y=552900
X1612 421 422 429 2 1 2683 XOR3 $T=606980 528080 0 0 $X=606980 $Y=527700
X1613 2614 2482 2664 2 1 2672 XOR3 $T=607600 548240 0 0 $X=607600 $Y=547860
X1614 439 2709 2717 2 1 2638 XOR3 $T=624960 538160 0 0 $X=624960 $Y=537780
X1615 457 2683 454 2 1 2789 XOR3 $T=635500 528080 0 0 $X=635500 $Y=527700
X1616 2925 517 2898 2 1 2883 XOR3 $T=680140 558320 0 180 $X=668980 $Y=552900
X1617 514 2903 2907 2 1 2900 XOR3 $T=671460 578480 1 0 $X=671460 $Y=573060
X1618 2917 521 2926 2 1 2899 XOR3 $T=674560 568400 1 0 $X=674560 $Y=562980
X1619 2980 2950 3010 2 1 2896 XOR3 $T=687580 608720 1 0 $X=687580 $Y=603300
X1620 2993 2999 3002 2 1 2980 XOR3 $T=693160 578480 1 0 $X=693160 $Y=573060
X1621 554 556 3026 2 1 3067 XOR3 $T=705560 528080 0 0 $X=705560 $Y=527700
X1622 3079 3067 3058 2 1 3046 XOR3 $T=719200 608720 0 180 $X=708040 $Y=603300
X1623 3100 3106 3146 2 1 3158 XOR3 $T=719200 588560 1 0 $X=719200 $Y=583140
X1624 3082 3088 3084 2 1 3149 XOR3 $T=721680 588560 0 0 $X=721680 $Y=588180
X1625 3091 3099 3094 2 1 3090 XOR3 $T=724160 598640 1 0 $X=724160 $Y=593220
X1626 3149 3155 3187 2 1 3180 XOR3 $T=729120 598640 0 0 $X=729120 $Y=598260
X1627 581 578 580 2 1 3155 XOR3 $T=736560 528080 1 0 $X=736560 $Y=522660
X1628 3158 588 3204 2 1 3221 XOR3 $T=737800 598640 1 0 $X=737800 $Y=593220
X1629 3214 3218 3249 2 1 3241 XOR3 $T=745240 588560 0 0 $X=745240 $Y=588180
X1630 3241 3245 3281 2 1 3272 XOR3 $T=752060 608720 0 0 $X=752060 $Y=608340
X1631 3244 3248 3283 2 1 3294 XOR3 $T=752680 598640 0 0 $X=752680 $Y=598260
X1632 608 607 3264 2 1 3247 XOR3 $T=766940 528080 1 180 $X=755780 $Y=527700
X1633 3303 611 3326 2 1 3334 XOR3 $T=766940 608720 0 0 $X=766940 $Y=608340
X1634 3294 623 3332 2 1 3395 XOR3 $T=791740 598640 1 0 $X=791740 $Y=593220
X1635 3397 3364 3391 2 1 3438 XOR3 $T=793600 588560 0 0 $X=793600 $Y=588180
X1636 3438 650 3435 2 1 3407 XOR3 $T=808480 608720 1 180 $X=797320 $Y=608340
X1637 3432 3390 3427 2 1 3471 XOR3 $T=806620 588560 0 0 $X=806620 $Y=588180
X1638 3492 3501 3504 2 1 3566 XOR3 $T=810960 568400 0 0 $X=810960 $Y=568020
X1639 3389 3491 3493 2 1 3538 XOR3 $T=814680 578480 0 0 $X=814680 $Y=578100
X1640 3512 3531 3525 2 1 665 XOR3 $T=816540 578480 1 0 $X=816540 $Y=573060
X1641 3523 3540 3548 2 1 3589 XOR3 $T=820260 558320 0 0 $X=820260 $Y=557940
X1642 3566 682 3616 2 1 3650 XOR3 $T=830180 578480 0 0 $X=830180 $Y=578100
X1643 3598 684 3592 2 1 3636 XOR3 $T=837000 558320 0 0 $X=837000 $Y=557940
X1644 3610 706 709 2 1 3705 XOR3 $T=849400 528080 0 0 $X=849400 $Y=527700
X1645 2260 1 2277 2286 2 2224 ND3HT $T=522660 568400 1 0 $X=522660 $Y=562980
X1646 2368 1 2379 2388 2 2343 ND3HT $T=547460 548240 1 0 $X=547460 $Y=542820
X1647 2958 1 2968 2961 2 2898 ND3HT $T=683240 548240 1 0 $X=683240 $Y=542820
X1648 3295 1 3284 3319 2 3315 ND3HT $T=777480 659120 0 180 $X=770040 $Y=653700
X1649 3295 1 3284 3319 2 3323 ND3HT $T=770660 659120 0 0 $X=770660 $Y=658740
X1650 870 861 895 2 1 XOR2HS $T=221340 538160 0 0 $X=221340 $Y=537780
X1651 862 860 896 2 1 XOR2HS $T=221340 568400 0 0 $X=221340 $Y=568020
X1652 903 864 872 2 1 XOR2HS $T=226920 588560 0 180 $X=221340 $Y=583140
X1653 904 899 873 2 1 XOR2HS $T=226920 598640 0 180 $X=221340 $Y=593220
X1654 905 900 874 2 1 XOR2HS $T=226920 608720 0 180 $X=221340 $Y=603300
X1655 871 881 897 2 1 XOR2HS $T=221340 649040 0 0 $X=221340 $Y=648660
X1656 869 3 898 2 1 XOR2HS $T=221340 689360 0 0 $X=221340 $Y=688980
X1657 908 865 884 2 1 XOR2HS $T=228160 618800 0 180 $X=222580 $Y=613380
X1658 886 867 907 2 1 XOR2HS $T=223200 659120 1 0 $X=223200 $Y=653700
X1659 888 875 913 2 1 XOR2HS $T=224440 538160 1 0 $X=224440 $Y=532740
X1660 885 880 914 2 1 XOR2HS $T=224440 638960 1 0 $X=224440 $Y=633540
X1661 887 882 915 2 1 XOR2HS $T=224440 669200 1 0 $X=224440 $Y=663780
X1662 889 876 916 2 1 XOR2HS $T=225060 548240 0 0 $X=225060 $Y=547860
X1663 890 878 917 2 1 XOR2HS $T=225060 578480 1 0 $X=225060 $Y=573060
X1664 894 863 918 2 1 XOR2HS $T=225060 578480 0 0 $X=225060 $Y=578100
X1665 891 879 919 2 1 XOR2HS $T=225060 628880 1 0 $X=225060 $Y=623460
X1666 893 868 920 2 1 XOR2HS $T=225060 679280 0 0 $X=225060 $Y=678900
X1667 902 866 925 2 1 XOR2HS $T=226300 628880 0 0 $X=226300 $Y=628500
X1668 892 883 926 2 1 XOR2HS $T=226300 689360 1 0 $X=226300 $Y=683940
X1669 934 923 949 2 1 XOR2HS $T=231260 598640 0 0 $X=231260 $Y=598260
X1670 988 935 997 2 1 XOR2HS $T=240560 608720 0 0 $X=240560 $Y=608340
X1671 1007 999 1020 2 1 XOR2HS $T=244900 598640 1 0 $X=244900 $Y=593220
X1672 993 991 1021 2 1 XOR2HS $T=244900 618800 0 0 $X=244900 $Y=618420
X1673 1014 1005 1025 2 1 XOR2HS $T=246140 628880 0 0 $X=246140 $Y=628500
X1674 995 992 1027 2 1 XOR2HS $T=246760 598640 0 0 $X=246760 $Y=598260
X1675 1018 930 1028 2 1 XOR2HS $T=246760 608720 0 0 $X=246760 $Y=608340
X1676 1051 1053 1067 2 1 XOR2HS $T=255440 578480 1 0 $X=255440 $Y=573060
X1677 1060 1054 1077 2 1 XOR2HS $T=257300 588560 0 0 $X=257300 $Y=588180
X1678 1059 1047 1084 2 1 XOR2HS $T=258540 578480 0 0 $X=258540 $Y=578100
X1679 1092 1088 1076 2 1 XOR2HS $T=264740 628880 1 180 $X=259160 $Y=628500
X1680 1097 1094 1082 2 1 XOR2HS $T=265980 568400 1 180 $X=260400 $Y=568020
X1681 1113 1109 1093 2 1 XOR2HS $T=268460 548240 0 180 $X=262880 $Y=542820
X1682 1121 1119 1102 2 1 XOR2HS $T=270320 538160 1 180 $X=264740 $Y=537780
X1683 1100 1090 1125 2 1 XOR2HS $T=265980 588560 1 0 $X=265980 $Y=583140
X1684 1132 1130 1152 2 1 XOR2HS $T=272180 598640 0 0 $X=272180 $Y=598260
X1685 1163 1157 1139 2 1 XOR2HS $T=278380 628880 0 180 $X=272800 $Y=623460
X1686 1168 1149 1183 2 1 XOR2HS $T=277760 568400 0 0 $X=277760 $Y=568020
X1687 1169 1150 1184 2 1 XOR2HS $T=277760 588560 0 0 $X=277760 $Y=588180
X1688 1162 1134 1188 2 1 XOR2HS $T=279000 568400 1 0 $X=279000 $Y=562980
X1689 1167 1154 1191 2 1 XOR2HS $T=279620 578480 0 0 $X=279620 $Y=578100
X1690 1195 1193 1180 2 1 XOR2HS $T=285200 628880 0 180 $X=279620 $Y=623460
X1691 1175 71 1151 2 1 XOR2HS $T=280240 528080 1 0 $X=280240 $Y=522660
X1692 1220 1215 1212 2 1 XOR2HS $T=292020 628880 0 180 $X=286440 $Y=623460
X1693 1233 1240 1273 2 1 XOR2HS $T=299460 669200 0 0 $X=299460 $Y=668820
X1694 1253 1258 1274 2 1 XOR2HS $T=300080 659120 0 0 $X=300080 $Y=658740
X1695 1260 1248 1279 2 1 XOR2HS $T=300700 638960 1 0 $X=300700 $Y=633540
X1696 1256 1270 1284 2 1 XOR2HS $T=302560 689360 1 0 $X=302560 $Y=683940
X1697 1268 1257 1287 2 1 XOR2HS $T=303180 649040 0 0 $X=303180 $Y=648660
X1698 1255 1259 1288 2 1 XOR2HS $T=303180 679280 1 0 $X=303180 $Y=673860
X1699 1264 1251 1292 2 1 XOR2HS $T=304420 638960 0 0 $X=304420 $Y=638580
X1700 1108 1064 1023 2 1 XOR2HS $T=305040 618800 0 0 $X=305040 $Y=618420
X1701 1286 1243 1261 2 1 XOR2HS $T=308140 628880 0 0 $X=308140 $Y=628500
X1702 1310 1312 1328 2 1 XOR2HS $T=313100 568400 1 0 $X=313100 $Y=562980
X1703 1320 1321 1339 2 1 XOR2HS $T=316200 578480 1 0 $X=316200 $Y=573060
X1704 1360 1354 1379 2 1 XOR2HS $T=324880 568400 0 0 $X=324880 $Y=568020
X1705 1403 1399 1419 2 1 XOR2HS $T=334180 568400 0 0 $X=334180 $Y=568020
X1706 1440 1439 1453 2 1 XOR2HS $T=344100 568400 0 0 $X=344100 $Y=568020
X1707 1433 1469 1450 2 1 XOR2HS $T=350920 649040 1 180 $X=345340 $Y=648660
X1708 1499 1495 1479 2 1 XOR2HS $T=355880 598640 0 180 $X=350300 $Y=593220
X1709 1483 1487 1490 2 1 XOR2HS $T=350920 649040 1 0 $X=350920 $Y=643620
X1710 1481 1482 1492 2 1 XOR2HS $T=354020 568400 1 0 $X=354020 $Y=562980
X1711 1527 1522 1508 2 1 XOR2HS $T=361460 568400 1 180 $X=355880 $Y=568020
X1712 1510 1479 1524 2 1 XOR2HS $T=356500 598640 1 0 $X=356500 $Y=593220
X1713 1516 1517 1528 2 1 XOR2HS $T=357740 638960 0 0 $X=357740 $Y=638580
X1714 1507 1512 1545 2 1 XOR2HS $T=360840 528080 0 0 $X=360840 $Y=527700
X1715 1526 1530 1547 2 1 XOR2HS $T=360840 548240 0 0 $X=360840 $Y=547860
X1716 1525 1519 1553 2 1 XOR2HS $T=362080 538160 1 0 $X=362080 $Y=532740
X1717 1520 1518 1558 2 1 XOR2HS $T=362700 548240 1 0 $X=362700 $Y=542820
X1718 1549 1552 1565 2 1 XOR2HS $T=363940 649040 0 0 $X=363940 $Y=648660
X1719 1521 1542 1566 2 1 XOR2HS $T=364560 558320 1 0 $X=364560 $Y=552900
X1720 1537 1556 1578 2 1 XOR2HS $T=366420 558320 0 0 $X=366420 $Y=557940
X1721 1266 1524 1586 2 1 XOR2HS $T=367660 608720 1 0 $X=367660 $Y=603300
X1722 1562 1551 1587 2 1 XOR2HS $T=367660 638960 0 0 $X=367660 $Y=638580
X1723 1580 1582 1597 2 1 XOR2HS $T=369520 659120 0 0 $X=369520 $Y=658740
X1724 1575 1583 1598 2 1 XOR2HS $T=369520 679280 1 0 $X=369520 $Y=673860
X1725 1592 1607 1599 2 1 XOR2HS $T=378200 558320 0 180 $X=372620 $Y=552900
X1726 1584 163 1606 2 1 XOR2HS $T=372620 689360 0 0 $X=372620 $Y=688980
X1727 1590 1594 1615 2 1 XOR2HS $T=373860 649040 1 0 $X=373860 $Y=643620
X1728 1554 1586 1614 2 1 XOR2HS $T=374480 598640 0 0 $X=374480 $Y=598260
X1729 1534 1445 1345 2 1 XOR2HS $T=375100 598640 1 0 $X=375100 $Y=593220
X1730 1608 1600 1630 2 1 XOR2HS $T=379440 659120 1 0 $X=379440 $Y=653700
X1731 1622 1621 1635 2 1 XOR2HS $T=379440 669200 0 0 $X=379440 $Y=668820
X1732 1610 1611 1636 2 1 XOR2HS $T=379440 679280 0 0 $X=379440 $Y=678900
X1733 1628 1599 1625 2 1 XOR2HS $T=383160 548240 0 0 $X=383160 $Y=547860
X1734 1366 1708 1744 2 1 XOR2HS $T=409200 659120 0 0 $X=409200 $Y=658740
X1735 1744 1727 1755 2 1 XOR2HS $T=412920 659120 1 0 $X=412920 $Y=653700
X1736 206 202 198 2 1 XOR2HS $T=433380 689360 1 180 $X=427800 $Y=688980
X1737 1826 1829 1823 2 1 XOR2HS $T=439580 689360 1 180 $X=434000 $Y=688980
X1738 1841 1835 1824 2 1 XOR2HS $T=440200 679280 0 180 $X=434620 $Y=673860
X1739 1859 1854 1838 2 1 XOR2HS $T=443300 669200 1 180 $X=437720 $Y=668820
X1740 1891 1887 1874 2 1 XOR2HS $T=449500 689360 0 180 $X=443920 $Y=683940
X1741 1876 1890 1901 2 1 XOR2HS $T=447020 659120 1 0 $X=447020 $Y=653700
X1742 1905 1902 1888 2 1 XOR2HS $T=452600 669200 0 180 $X=447020 $Y=663780
X1743 1941 1945 1959 2 1 XOR2HS $T=461280 649040 0 0 $X=461280 $Y=648660
X1744 1975 1942 1949 2 1 XOR2HS $T=468100 659120 1 180 $X=462520 $Y=658740
X1745 1935 1943 1948 2 1 XOR2HS $T=463140 679280 0 0 $X=463140 $Y=678900
X1746 2020 2017 2006 2 1 XOR2HS $T=477400 548240 0 180 $X=471820 $Y=542820
X1747 1992 2000 1979 2 1 XOR2HS $T=471820 649040 0 0 $X=471820 $Y=648660
X1748 2019 2029 2040 2 1 XOR2HS $T=476780 538160 1 0 $X=476780 $Y=532740
X1749 2051 2052 2059 2 1 XOR2HS $T=481740 558320 1 0 $X=481740 $Y=552900
X1750 2035 2050 2062 2 1 XOR2HS $T=482360 649040 1 0 $X=482360 $Y=643620
X1751 2066 2069 2083 2 1 XOR2HS $T=486700 568400 1 0 $X=486700 $Y=562980
X1752 2093 2102 2115 2 1 XOR2HS $T=493520 538160 1 0 $X=493520 $Y=532740
X1753 2123 2092 2100 2 1 XOR2HS $T=499100 558320 1 180 $X=493520 $Y=557940
X1754 2096 2090 2119 2 1 XOR2HS $T=494140 548240 0 0 $X=494140 $Y=547860
X1755 2137 2159 2141 2 1 XOR2HS $T=505920 638960 1 180 $X=500340 $Y=638580
X1756 2128 2155 2168 2 1 XOR2HS $T=502200 558320 0 0 $X=502200 $Y=557940
X1757 2138 307 2175 2 1 XOR2HS $T=502820 528080 1 0 $X=502820 $Y=522660
X1758 2164 2173 2185 2 1 XOR2HS $T=504680 578480 0 0 $X=504680 $Y=578100
X1759 2153 2146 2176 2 1 XOR2HS $T=505920 528080 0 0 $X=505920 $Y=527700
X1760 2162 2154 2200 2 1 XOR2HS $T=507780 538160 0 0 $X=507780 $Y=537780
X1761 2221 2217 2203 2 1 XOR2HS $T=516460 538160 0 180 $X=510880 $Y=532740
X1762 2201 2225 2192 2 1 XOR2HS $T=517700 558320 0 180 $X=512120 $Y=552900
X1763 2216 324 2189 2 1 XOR2HS $T=517700 659120 1 180 $X=512120 $Y=658740
X1764 2239 2235 2233 2 1 XOR2HS $T=519560 558320 1 0 $X=519560 $Y=552900
X1765 2246 327 2253 2 1 XOR2HS $T=526380 659120 1 180 $X=520800 $Y=658740
X1766 2252 2247 2276 2 1 XOR2HS $T=522660 548240 1 0 $X=522660 $Y=542820
X1767 2259 2254 2283 2 1 XOR2HS $T=523900 538160 0 0 $X=523900 $Y=537780
X1768 2271 2261 2292 2 1 XOR2HS $T=526380 528080 0 0 $X=526380 $Y=527700
X1769 2172 2316 2304 2 1 XOR2HS $T=536920 548240 1 180 $X=531340 $Y=547860
X1770 2313 2305 2329 2 1 XOR2HS $T=536300 538160 1 0 $X=536300 $Y=532740
X1771 2185 2243 2326 2 1 XOR2HS $T=540640 578480 1 0 $X=540640 $Y=573060
X1772 2349 2351 2352 2 1 XOR2HS $T=543120 538160 1 0 $X=543120 $Y=532740
X1773 2363 2394 2366 2 1 XOR2HS $T=554280 649040 0 180 $X=548700 $Y=643620
X1774 2393 2378 2387 2 1 XOR2HS $T=553660 528080 0 0 $X=553660 $Y=527700
X1775 2343 2304 2417 2 1 XOR2HS $T=554900 548240 0 0 $X=554900 $Y=547860
X1776 2433 2434 2422 2 1 XOR2HS $T=564820 659120 1 180 $X=559240 $Y=658740
X1777 2407 2421 2444 2 1 XOR2HS $T=561100 638960 0 0 $X=561100 $Y=638580
X1778 2400 380 2370 2 1 XOR2HS $T=561720 618800 0 0 $X=561720 $Y=618420
X1779 2460 2408 2471 2 1 XOR2HS $T=567920 638960 0 0 $X=567920 $Y=638580
X1780 2479 2475 2462 2 1 XOR2HS $T=574120 548240 0 180 $X=568540 $Y=542820
X1781 2453 2455 2478 2 1 XOR2HS $T=571640 659120 0 0 $X=571640 $Y=658740
X1782 2509 2507 2491 2 1 XOR2HS $T=580940 528080 1 180 $X=575360 $Y=527700
X1783 2510 2511 2495 2 1 XOR2HS $T=581560 669200 0 180 $X=575980 $Y=663780
X1784 2486 2513 2494 2 1 XOR2HS $T=582180 638960 1 180 $X=576600 $Y=638580
X1785 2534 2467 2517 2 1 XOR2HS $T=585280 679280 0 180 $X=579700 $Y=673860
X1786 2543 2539 2505 2 1 XOR2HS $T=587140 659120 0 180 $X=581560 $Y=653700
X1787 2531 2530 2500 2 1 XOR2HS $T=582800 538160 0 0 $X=582800 $Y=537780
X1788 2558 2559 2549 2 1 XOR2HS $T=591480 548240 0 180 $X=585900 $Y=542820
X1789 2571 2568 2537 2 1 XOR2HS $T=593340 659120 0 180 $X=587760 $Y=653700
X1790 2556 2565 2575 2 1 XOR2HS $T=590240 669200 1 0 $X=590240 $Y=663780
X1791 2563 2553 2566 2 1 XOR2HS $T=590860 679280 1 0 $X=590860 $Y=673860
X1792 2532 2540 2581 2 1 XOR2HS $T=592100 548240 0 0 $X=592100 $Y=547860
X1793 2593 2588 2557 2 1 XOR2HS $T=598300 528080 0 180 $X=592720 $Y=522660
X1794 2595 2600 2598 2 1 XOR2HS $T=596440 669200 1 0 $X=596440 $Y=663780
X1795 2583 2580 2574 2 1 XOR2HS $T=598920 528080 0 0 $X=598920 $Y=527700
X1796 2581 2541 2623 2 1 XOR2HS $T=598920 548240 0 0 $X=598920 $Y=547860
X1797 2629 2586 2613 2 1 XOR2HS $T=605120 659120 0 180 $X=599540 $Y=653700
X1798 2636 2625 2620 2 1 XOR2HS $T=609460 669200 0 0 $X=609460 $Y=668820
X1799 2630 2640 2641 2 1 XOR2HS $T=611320 679280 1 0 $X=611320 $Y=673860
X1800 430 428 2642 2 1 XOR2HS $T=618140 528080 0 180 $X=612560 $Y=522660
X1801 432 434 2697 2 1 XOR2HS $T=619380 528080 0 0 $X=619380 $Y=527700
X1802 2681 2699 2614 2 1 XOR2HS $T=625580 558320 0 180 $X=620000 $Y=552900
X1803 2682 2691 2699 2 1 XOR2HS $T=620620 558320 0 0 $X=620620 $Y=557940
X1804 2635 2526 2560 2 1 XOR2HS $T=628060 578480 0 0 $X=628060 $Y=578100
X1805 465 462 2753 2 1 XOR2HS $T=641700 528080 0 180 $X=636120 $Y=522660
X1806 472 2753 2779 2 1 XOR2HS $T=642940 528080 1 0 $X=642940 $Y=522660
X1807 2940 2935 2846 2 1 XOR2HS $T=681380 538160 1 180 $X=675800 $Y=537780
X1808 537 2957 2935 2 1 XOR2HS $T=684480 538160 0 0 $X=684480 $Y=537780
X1809 540 544 2950 2 1 XOR2HS $T=693780 528080 1 180 $X=688200 $Y=527700
X1810 3029 3027 3020 2 1 XOR2HS $T=704940 568400 0 180 $X=699360 $Y=562980
X1811 3065 3061 3030 2 1 XOR2HS $T=712380 538160 1 180 $X=706800 $Y=537780
X1812 3075 3071 3040 2 1 XOR2HS $T=714240 548240 1 180 $X=708660 $Y=547860
X1813 3062 3063 3045 2 1 XOR2HS $T=714860 558320 0 180 $X=709280 $Y=552900
X1814 3044 3077 3036 2 1 XOR2HS $T=715480 538160 0 180 $X=709900 $Y=532740
X1815 3078 3076 3070 2 1 XOR2HS $T=716720 568400 1 180 $X=711140 $Y=568020
X1816 3096 3095 3101 2 1 XOR2HS $T=717340 578480 1 0 $X=717340 $Y=573060
X1817 3129 3123 3134 2 1 XOR2HS $T=724160 568400 0 0 $X=724160 $Y=568020
X1818 3164 3160 3162 2 1 XOR2HS $T=732220 578480 1 0 $X=732220 $Y=573060
X1819 3191 3185 3183 2 1 XOR2HS $T=739040 578480 1 0 $X=739040 $Y=573060
X1820 3220 3213 3210 2 1 XOR2HS $T=745860 578480 1 0 $X=745860 $Y=573060
X1821 3246 3240 3250 2 1 XOR2HS $T=752680 578480 1 0 $X=752680 $Y=573060
X1822 600 601 3245 2 1 XOR2HS $T=757640 528080 1 0 $X=757640 $Y=522660
X1823 3268 3265 3279 2 1 XOR2HS $T=758880 578480 1 0 $X=758880 $Y=573060
X1824 3312 3299 3301 2 1 XOR2HS $T=771280 578480 0 180 $X=765700 $Y=573060
X1825 3322 3325 3330 2 1 XOR2HS $T=771900 578480 1 0 $X=771900 $Y=573060
X1826 3338 3337 3349 2 1 XOR2HS $T=778100 578480 1 0 $X=778100 $Y=573060
X1827 3376 3354 3385 2 1 XOR2HS $T=787400 578480 1 0 $X=787400 $Y=573060
X1828 3378 3369 3384 2 1 XOR2HS $T=790500 568400 0 0 $X=790500 $Y=568020
X1829 3402 3411 3431 2 1 XOR2HS $T=794840 578480 0 0 $X=794840 $Y=578100
X1830 3426 3433 3443 2 1 XOR2HS $T=797320 538160 1 0 $X=797320 $Y=532740
X1831 3424 3418 3461 2 1 XOR2HS $T=799800 568400 1 0 $X=799800 $Y=562980
X1832 3467 3410 3451 2 1 XOR2HS $T=806000 679280 0 180 $X=800420 $Y=673860
X1833 3437 3447 3470 2 1 XOR2HS $T=801660 558320 0 0 $X=801660 $Y=557940
X1834 3459 3423 3479 2 1 XOR2HS $T=804140 558320 1 0 $X=804140 $Y=552900
X1835 664 3538 3562 2 1 XOR2HS $T=823980 588560 1 0 $X=823980 $Y=583140
X1836 3562 3549 3575 2 1 XOR2HS $T=825840 598640 1 0 $X=825840 $Y=593220
X1837 3482 3413 3500 2 1 XOR2HS $T=833280 558320 1 0 $X=833280 $Y=552900
X1838 3599 3612 3621 2 1 XOR2HS $T=835760 608720 0 0 $X=835760 $Y=608340
X1839 3476 3466 3649 2 1 XOR2HS $T=840720 628880 0 0 $X=840720 $Y=628500
X1840 3690 3668 3672 2 1 XOR2HS $T=858080 659120 0 180 $X=852500 $Y=653700
X1841 47 951 1073 1066 1 2 MAO222P $T=256680 528080 0 0 $X=256680 $Y=527700
X1842 1211 966 1213 1198 1 2 MAO222P $T=285820 598640 1 0 $X=285820 $Y=593220
X1843 1221 980 1217 1204 1 2 MAO222P $T=289540 618800 0 0 $X=289540 $Y=618420
X1844 1218 877 1143 1235 1 2 MAO222P $T=293260 568400 1 0 $X=293260 $Y=562980
X1845 1326 998 1302 1301 1 2 MAO222P $T=314340 638960 1 0 $X=314340 $Y=633540
X1846 1323 956 1314 1343 1 2 MAO222P $T=315580 649040 0 0 $X=315580 $Y=648660
X1847 1420 1409 1415 1426 1 2 MAO222P $T=336040 588560 1 0 $X=336040 $Y=583140
X1848 1559 1536 1531 1510 1 2 MAO222P $T=364560 578480 0 0 $X=364560 $Y=578100
X1849 1561 1555 1564 1477 1 2 MAO222P $T=364560 628880 0 0 $X=364560 $Y=628500
X1850 1570 1567 1252 1475 1 2 MAO222P $T=367040 618800 0 0 $X=367040 $Y=618420
X1851 164 1540 1546 169 1 2 MAO222P $T=372620 528080 1 0 $X=372620 $Y=522660
X1852 169 168 170 1612 1 2 MAO222P $T=375100 528080 0 0 $X=375100 $Y=527700
X1853 1612 1601 1605 1617 1 2 MAO222P $T=375720 538160 0 0 $X=375720 $Y=537780
X1854 1642 1380 1646 1570 1 2 MAO222P $T=382540 628880 1 0 $X=382540 $Y=623460
X1855 177 1652 1650 1675 1 2 MAO222P $T=386260 689360 1 0 $X=386260 $Y=683940
X1856 179 1603 45 1687 1 2 MAO222P $T=390600 528080 0 0 $X=390600 $Y=527700
X1857 1713 1680 1472 1716 1 2 MAO222P $T=402380 649040 0 0 $X=402380 $Y=648660
X1858 1727 1708 1366 1713 1 2 MAO222P $T=406720 659120 1 0 $X=406720 $Y=653700
X1859 2204 2202 2209 2222 1 2 MAO222P $T=510260 578480 0 0 $X=510260 $Y=578100
X1860 2264 2241 2075 2269 1 2 MAO222P $T=522660 558320 0 0 $X=522660 $Y=557940
X1861 2293 2287 2290 2294 1 2 MAO222P $T=528240 568400 0 0 $X=528240 $Y=568020
X1862 2344 2337 2341 2293 1 2 MAO222P $T=540640 568400 1 0 $X=540640 $Y=562980
X1863 2410 2401 2142 2397 1 2 MAO222P $T=556140 538160 0 0 $X=556140 $Y=537780
X1864 2463 2461 2466 2377 1 2 MAO222P $T=567920 578480 0 0 $X=567920 $Y=578100
X1865 2528 2525 2535 2490 1 2 MAO222P $T=581560 558320 0 0 $X=581560 $Y=557940
X1866 2602 414 2608 2528 1 2 MAO222P $T=596440 568400 1 0 $X=596440 $Y=562980
X1867 2624 2615 2612 2602 1 2 MAO222P $T=600780 558320 0 0 $X=600780 $Y=557940
X1868 2717 439 2709 2705 1 2 MAO222P $T=631160 538160 0 180 $X=625580 $Y=532740
X1869 2907 514 2903 2926 1 2 MAO222P $T=671460 578480 0 0 $X=671460 $Y=578100
X1870 3002 2993 2999 2979 1 2 MAO222P $T=693160 578480 0 0 $X=693160 $Y=578100
X1871 3084 3082 3088 3094 1 2 MAO222P $T=713620 588560 1 0 $X=713620 $Y=583140
X1872 3094 3091 3099 3019 1 2 MAO222P $T=716100 588560 0 0 $X=716100 $Y=588180
X1873 3107 3090 566 3058 1 2 MAO222P $T=718580 598640 1 0 $X=718580 $Y=593220
X1874 3146 3100 3106 3084 1 2 MAO222P $T=731600 588560 1 0 $X=731600 $Y=583140
X1875 3332 3294 623 3326 1 2 MAO222P $T=775000 598640 0 0 $X=775000 $Y=598260
X1876 3283 3244 3248 3280 1 2 MAO222P $T=776240 598640 1 0 $X=776240 $Y=593220
X1877 3504 3492 3501 3493 1 2 MAO222P $T=810960 578480 1 0 $X=810960 $Y=573060
X1878 3525 3512 3531 3524 1 2 MAO222P $T=814680 558320 0 0 $X=814680 $Y=557940
X1879 667 665 671 3592 1 2 MAO222P $T=819640 538160 1 0 $X=819640 $Y=532740
X1880 3548 3523 3540 3525 1 2 MAO222P $T=820260 558320 1 0 $X=820260 $Y=552900
X1881 709 3610 706 3654 1 2 MAO222P $T=849400 538160 1 0 $X=849400 $Y=532740
X1882 1249 1238 1237 1242 1 2 ND3P $T=301940 578480 0 180 $X=296980 $Y=573060
X1883 1306 1348 1316 1304 1 2 ND3P $T=313100 679280 0 0 $X=313100 $Y=678900
X1884 1329 1303 1334 1331 1 2 ND3P $T=315580 669200 0 0 $X=315580 $Y=668820
X1885 1370 1338 1395 1362 1 2 ND3P $T=330460 598640 0 180 $X=325500 $Y=593220
X1886 1505 1420 1513 1494 1 2 ND3P $T=354640 578480 0 0 $X=354640 $Y=578100
X1887 1563 1464 1560 1543 1 2 ND3P $T=370140 598640 0 180 $X=365180 $Y=593220
X1888 1596 1559 1591 1585 1 2 ND3P $T=375720 578480 1 180 $X=370760 $Y=578100
X1889 1576 1554 1579 1568 1 2 ND3P $T=380680 588560 1 180 $X=375720 $Y=588180
X1890 1629 1602 1632 1624 1 2 ND3P $T=383780 558320 1 180 $X=378820 $Y=557940
X1891 1663 1669 1670 1671 1 2 ND3P $T=386260 679280 0 0 $X=386260 $Y=678900
X1892 1690 1686 1696 1682 1 2 ND3P $T=397420 538160 0 0 $X=397420 $Y=537780
X1893 1707 1667 1711 1697 1 2 ND3P $T=400520 638960 0 0 $X=400520 $Y=638580
X1894 1724 1737 1731 1717 1 2 ND3P $T=405480 679280 0 0 $X=405480 $Y=678900
X1895 1741 1727 1745 1740 1 2 ND3P $T=409820 669200 1 0 $X=409820 $Y=663780
X1896 2356 2320 2340 2330 1 2 ND3P $T=544360 538160 0 0 $X=544360 $Y=537780
X1897 382 2416 2437 2442 1 2 ND3P $T=562340 528080 1 0 $X=562340 $Y=522660
X1898 2516 2443 2522 2524 1 2 ND3P $T=579080 548240 0 0 $X=579080 $Y=547860
X1899 2576 2541 2584 2587 1 2 ND3P $T=592720 548240 1 0 $X=592720 $Y=542820
X1900 2647 2631 2661 2643 1 2 ND3P $T=612560 538160 1 180 $X=607600 $Y=537780
X1901 2676 2624 2671 2668 1 2 ND3P $T=619380 568400 0 180 $X=614420 $Y=562980
X1902 442 2717 2708 2719 1 2 ND3P $T=625580 528080 0 0 $X=625580 $Y=527700
X1903 2736 2681 2749 2720 1 2 ND3P $T=634880 558320 1 180 $X=629920 $Y=557940
X1904 2744 2674 2734 2735 1 2 ND3P $T=636740 538160 0 180 $X=631780 $Y=532740
X1905 2927 2907 2936 2922 1 2 ND3P $T=679520 588560 1 180 $X=674560 $Y=588180
X1906 2924 2940 2911 2938 1 2 ND3P $T=676420 548240 0 0 $X=676420 $Y=547860
X1907 532 538 2955 535 1 2 ND3P $T=680760 528080 1 0 $X=680760 $Y=522660
X1908 2953 2913 2972 2960 1 2 ND3P $T=693780 528080 0 0 $X=693780 $Y=527700
X1909 3043 2970 3054 3032 1 2 ND3P $T=708660 598640 0 180 $X=703700 $Y=593220
X1910 3304 3274 3318 3298 1 2 ND3P $T=770040 598640 1 180 $X=765080 $Y=598260
X1911 3361 3283 3368 3373 1 2 ND3P $T=781820 588560 0 0 $X=781820 $Y=588180
X1912 3406 3332 3420 3421 1 2 ND3P $T=793600 598640 0 0 $X=793600 $Y=598260
X1913 3590 3616 3585 3579 1 2 ND3P $T=832660 578480 1 0 $X=832660 $Y=573060
X1914 3556 3549 3555 3551 1 2 ND3P $T=838240 598640 0 180 $X=833280 $Y=593220
X1915 3651 3642 3653 3586 1 2 ND3P $T=846920 598640 0 0 $X=846920 $Y=598260
X1916 3681 3648 3660 3651 1 2 ND3P $T=856220 608720 1 0 $X=856220 $Y=603300
X1917 1235 1237 1225 1 2 ND2 $T=295120 578480 0 180 $X=293260 $Y=573060
X1918 1225 1242 969 1 2 ND2 $T=296360 568400 1 180 $X=294500 $Y=568020
X1919 1235 1249 969 1 2 ND2 $T=300080 568400 0 0 $X=300080 $Y=568020
X1920 1294 1304 968 1 2 ND2 $T=310000 689360 0 180 $X=308140 $Y=683940
X1921 1348 1329 977 1 2 ND2 $T=320540 669200 0 180 $X=318680 $Y=663780
X1922 1338 1361 1187 1 2 ND2 $T=323640 608720 0 180 $X=321780 $Y=603300
X1923 1338 1388 1364 1 2 ND2 $T=328600 598640 0 0 $X=328600 $Y=598260
X1924 1396 1370 1230 1 2 ND2 $T=332320 598640 1 0 $X=332320 $Y=593220
X1925 1230 1362 1436 1 2 ND2 $T=335420 598640 1 0 $X=335420 $Y=593220
X1926 1477 1458 1501 1 2 ND2 $T=350300 628880 0 0 $X=350300 $Y=628500
X1927 1477 1466 1488 1 2 ND2 $T=350920 628880 1 0 $X=350920 $Y=623460
X1928 1495 1505 1510 1 2 ND2 $T=358980 588560 1 0 $X=358980 $Y=583140
X1929 1510 1513 1499 1 2 ND2 $T=361460 588560 1 0 $X=361460 $Y=583140
X1930 1266 1543 1524 1 2 ND2 $T=364560 598640 0 180 $X=362700 $Y=593220
X1931 1602 1591 1588 1 2 ND2 $T=373240 568400 1 180 $X=371380 $Y=568020
X1932 1593 1568 1298 1 2 ND2 $T=375100 598640 0 180 $X=373240 $Y=593220
X1933 1602 1596 1595 1 2 ND2 $T=374480 568400 1 0 $X=374480 $Y=562980
X1934 1628 1629 1607 1 2 ND2 $T=381920 558320 0 180 $X=380060 $Y=552900
X1935 1145 1682 176 1 2 ND2 $T=393700 538160 1 180 $X=391840 $Y=537780
X1936 1684 1645 1668 1 2 ND2 $T=393700 558320 1 180 $X=391840 $Y=557940
X1937 1684 1665 1281 1 2 ND2 $T=393700 568400 0 180 $X=391840 $Y=562980
X1938 1677 1671 1604 1 2 ND2 $T=393700 679280 0 0 $X=393700 $Y=678900
X1939 1687 1690 1145 1 2 ND2 $T=396180 538160 1 180 $X=394320 $Y=537780
X1940 1694 1697 1463 1 2 ND2 $T=400520 638960 1 180 $X=398660 $Y=638580
X1941 167 182 183 1 2 ND2 $T=401760 578480 1 0 $X=401760 $Y=573060
X1942 1368 1717 1704 1 2 ND2 $T=403620 689360 0 180 $X=401760 $Y=683940
X1943 1716 1707 1463 1 2 ND2 $T=405480 638960 0 0 $X=405480 $Y=638580
X1944 1725 1724 1704 1 2 ND2 $T=407340 689360 1 0 $X=407340 $Y=683940
X1945 1381 1740 1703 1 2 ND2 $T=411060 679280 0 180 $X=409200 $Y=673860
X1946 1737 1741 1381 1 2 ND2 $T=412300 679280 1 0 $X=412300 $Y=673860
X1947 1737 1745 1703 1 2 ND2 $T=415400 669200 1 0 $X=415400 $Y=663780
X1948 1855 222 1865 1 2 ND2 $T=441440 689360 0 0 $X=441440 $Y=688980
X1949 1851 1863 1868 1 2 ND2 $T=442680 568400 0 0 $X=442680 $Y=568020
X1950 208 1872 1868 1 2 ND2 $T=444540 558320 1 0 $X=444540 $Y=552900
X1951 219 1898 1868 1 2 ND2 $T=447640 558320 1 0 $X=447640 $Y=552900
X1952 226 1915 1868 1 2 ND2 $T=453220 558320 1 0 $X=453220 $Y=552900
X1953 246 1880 1946 1 2 ND2 $T=458180 689360 0 0 $X=458180 $Y=688980
X1954 249 1950 1868 1 2 ND2 $T=460040 558320 0 0 $X=460040 $Y=557940
X1955 256 1997 1868 1 2 ND2 $T=469960 558320 1 0 $X=469960 $Y=552900
X1956 1983 1991 2003 1 2 ND2 $T=469960 659120 0 0 $X=469960 $Y=658740
X1957 1955 1966 2011 1 2 ND2 $T=469960 669200 1 0 $X=469960 $Y=663780
X1958 269 2031 1868 1 2 ND2 $T=476780 558320 1 0 $X=476780 $Y=552900
X1959 285 2058 1868 1 2 ND2 $T=485460 578480 1 180 $X=483600 $Y=578100
X1960 1953 2070 1868 1 2 ND2 $T=485460 568400 0 0 $X=485460 $Y=568020
X1961 288 2067 1868 1 2 ND2 $T=489180 578480 0 180 $X=487320 $Y=573060
X1962 291 2076 1868 1 2 ND2 $T=489800 578480 1 180 $X=487940 $Y=578100
X1963 2077 2091 2101 1 2 ND2 $T=492280 649040 1 0 $X=492280 $Y=643620
X1964 2131 2120 2117 1 2 ND2 $T=499100 649040 0 180 $X=497240 $Y=643620
X1965 2167 2181 2193 1 2 ND2 $T=507160 638960 0 0 $X=507160 $Y=638580
X1966 2216 2182 2198 1 2 ND2 $T=512740 659120 0 180 $X=510880 $Y=653700
X1967 2246 2240 2238 1 2 ND2 $T=520180 659120 1 180 $X=518320 $Y=658740
X1968 2097 2260 2256 1 2 ND2 $T=522040 568400 0 0 $X=522040 $Y=568020
X1969 2295 2265 2263 1 2 ND2 $T=526380 649040 0 180 $X=524520 $Y=643620
X1970 2308 2300 2285 1 2 ND2 $T=530720 638960 1 180 $X=528860 $Y=638580
X1971 2343 2356 2172 1 2 ND2 $T=548700 548240 1 180 $X=546840 $Y=547860
X1972 2384 2339 2338 1 2 ND2 $T=551800 659120 0 180 $X=549940 $Y=653700
X1973 2210 2368 2361 1 2 ND2 $T=554900 548240 1 0 $X=554900 $Y=542820
X1974 2412 2411 2381 1 2 ND2 $T=558620 659120 1 180 $X=556760 $Y=658740
X1975 2214 2442 378 1 2 ND2 $T=560480 528080 0 0 $X=560480 $Y=527700
X1976 383 2437 2214 1 2 ND2 $T=565440 528080 0 0 $X=565440 $Y=527700
X1977 2353 2441 2452 1 2 ND2 $T=565440 608720 0 0 $X=565440 $Y=608340
X1978 2489 2508 2452 1 2 ND2 $T=577220 618800 1 0 $X=577220 $Y=613380
X1979 2532 2524 2540 1 2 ND2 $T=584040 548240 0 0 $X=584040 $Y=547860
X1980 2541 2522 2540 1 2 ND2 $T=585900 548240 0 0 $X=585900 $Y=547860
X1981 2527 2545 2452 1 2 ND2 $T=587760 618800 0 180 $X=585900 $Y=613380
X1982 2541 2516 2532 1 2 ND2 $T=589000 548240 0 0 $X=589000 $Y=547860
X1983 2606 2592 2506 1 2 ND2 $T=599540 679280 1 180 $X=597680 $Y=678900
X1984 2604 415 2579 1 2 ND2 $T=598920 689360 0 0 $X=598920 $Y=688980
X1985 2611 2576 2614 1 2 ND2 $T=599540 538160 0 0 $X=599540 $Y=537780
X1986 2482 2587 2614 1 2 ND2 $T=599540 548240 1 0 $X=599540 $Y=542820
X1987 2626 2621 2470 1 2 ND2 $T=603260 689360 1 180 $X=601400 $Y=688980
X1988 2594 2637 2452 1 2 ND2 $T=602640 618800 1 0 $X=602640 $Y=613380
X1989 2601 2644 2452 1 2 ND2 $T=609460 618800 0 180 $X=607600 $Y=613380
X1990 2655 2651 2536 1 2 ND2 $T=611320 679280 1 180 $X=609460 $Y=678900
X1991 2638 2643 423 1 2 ND2 $T=612560 538160 0 0 $X=612560 $Y=537780
X1992 2674 2661 423 1 2 ND2 $T=617520 538160 1 180 $X=615660 $Y=537780
X1993 2674 2647 2638 1 2 ND2 $T=618140 538160 0 0 $X=618140 $Y=537780
X1994 2681 2671 2682 1 2 ND2 $T=618140 558320 0 0 $X=618140 $Y=557940
X1995 2682 2668 2691 1 2 ND2 $T=620000 568400 1 0 $X=620000 $Y=562980
X1996 2681 2676 2691 1 2 ND2 $T=621860 568400 1 0 $X=621860 $Y=562980
X1997 441 2708 445 1 2 ND2 $T=626820 528080 1 0 $X=626820 $Y=522660
X1998 2648 2720 436 1 2 ND2 $T=626820 558320 0 0 $X=626820 $Y=557940
X1999 2694 2718 2452 1 2 ND2 $T=626820 608720 0 0 $X=626820 $Y=608340
X2000 2721 2722 2452 1 2 ND2 $T=628680 618800 0 180 $X=626820 $Y=613380
X2001 2686 2727 2452 1 2 ND2 $T=629920 608720 0 0 $X=629920 $Y=608340
X2002 2701 2730 2452 1 2 ND2 $T=631780 618800 0 180 $X=629920 $Y=613380
X2003 2738 2728 2452 1 2 ND2 $T=631780 618800 1 180 $X=629920 $Y=618420
X2004 449 2719 445 1 2 ND2 $T=631780 528080 1 0 $X=631780 $Y=522660
X2005 454 2734 2683 1 2 ND2 $T=633640 528080 1 180 $X=631780 $Y=527700
X2006 2705 2736 436 1 2 ND2 $T=632400 558320 1 0 $X=632400 $Y=552900
X2007 2683 2735 457 1 2 ND2 $T=636740 538160 1 0 $X=636740 $Y=532740
X2008 2743 2754 2452 1 2 ND2 $T=638600 608720 0 180 $X=636740 $Y=603300
X2009 454 2744 457 1 2 ND2 $T=640460 538160 1 180 $X=638600 $Y=537780
X2010 2768 2772 1843 1 2 ND2 $T=645420 608720 1 0 $X=645420 $Y=603300
X2011 2759 2782 1843 1 2 ND2 $T=647280 618800 0 0 $X=647280 $Y=618420
X2012 2795 2792 1843 1 2 ND2 $T=651000 618800 0 180 $X=649140 $Y=613380
X2013 2764 2790 2803 1 2 ND2 $T=650380 588560 1 0 $X=650380 $Y=583140
X2014 2773 2798 2803 1 2 ND2 $T=650380 598640 0 0 $X=650380 $Y=598260
X2015 474 2815 2803 1 2 ND2 $T=650380 608720 1 0 $X=650380 $Y=603300
X2016 2805 2799 1843 1 2 ND2 $T=652240 618800 1 180 $X=650380 $Y=618420
X2017 2822 2810 1843 1 2 ND2 $T=655340 618800 1 180 $X=653480 $Y=618420
X2018 486 2820 2803 1 2 ND2 $T=654100 578480 1 0 $X=654100 $Y=573060
X2019 2813 2818 1843 1 2 ND2 $T=654100 618800 1 0 $X=654100 $Y=613380
X2020 2766 2824 2803 1 2 ND2 $T=655340 588560 0 0 $X=655340 $Y=588180
X2021 2781 2825 2803 1 2 ND2 $T=655960 578480 0 0 $X=655960 $Y=578100
X2022 2748 2842 2803 1 2 ND2 $T=659060 588560 0 180 $X=657200 $Y=583140
X2023 2832 2831 1843 1 2 ND2 $T=657200 608720 0 0 $X=657200 $Y=608340
X2024 485 2833 2803 1 2 ND2 $T=657820 588560 0 0 $X=657820 $Y=588180
X2025 493 2838 2803 1 2 ND2 $T=659680 598640 0 180 $X=657820 $Y=593220
X2026 498 2849 2803 1 2 ND2 $T=660300 598640 1 0 $X=660300 $Y=593220
X2027 2856 2850 1843 1 2 ND2 $T=662780 628880 0 180 $X=660920 $Y=623460
X2028 2874 2862 1843 1 2 ND2 $T=664020 628880 1 0 $X=664020 $Y=623460
X2029 2882 2873 1843 1 2 ND2 $T=667740 618800 0 0 $X=667740 $Y=618420
X2030 2898 2911 517 1 2 ND2 $T=675800 538160 1 180 $X=673940 $Y=537780
X2031 517 2924 2925 1 2 ND2 $T=674560 548240 0 0 $X=674560 $Y=547860
X2032 2944 2936 2950 1 2 ND2 $T=681380 588560 0 0 $X=681380 $Y=588180
X2033 2940 2972 537 1 2 ND2 $T=682620 528080 0 0 $X=682620 $Y=527700
X2034 2940 2953 2957 1 2 ND2 $T=682620 538160 1 0 $X=682620 $Y=532740
X2035 2898 2938 2925 1 2 ND2 $T=682620 548240 0 0 $X=682620 $Y=547860
X2036 537 2960 2957 1 2 ND2 $T=686340 538160 0 180 $X=684480 $Y=532740
X2037 2944 2927 2980 1 2 ND2 $T=685100 588560 1 0 $X=685100 $Y=583140
X2038 2950 2922 2980 1 2 ND2 $T=686340 598640 0 0 $X=686340 $Y=598260
X2039 540 2955 542 1 2 ND2 $T=689440 528080 1 0 $X=689440 $Y=522660
X2040 2917 2958 521 1 2 ND2 $T=690680 548240 1 0 $X=690680 $Y=542820
X2041 3013 2094 2937 1 2 ND2 $T=696880 618800 0 0 $X=696880 $Y=618420
X2042 3033 3041 3021 1 2 ND2 $T=706180 649040 0 180 $X=704320 $Y=643620
X2043 3035 3039 1843 1 2 ND2 $T=704940 659120 1 0 $X=704940 $Y=653700
X2044 3055 3057 1843 1 2 ND2 $T=708660 659120 0 180 $X=706800 $Y=653700
X2045 3053 3064 3021 1 2 ND2 $T=710520 649040 0 180 $X=708660 $Y=643620
X2046 3058 3043 3067 1 2 ND2 $T=709900 598640 1 0 $X=709900 $Y=593220
X2047 3066 3060 1843 1 2 ND2 $T=711760 659120 0 180 $X=709900 $Y=653700
X2048 3067 3032 3079 1 2 ND2 $T=711760 598640 1 0 $X=711760 $Y=593220
X2049 3086 3083 3021 1 2 ND2 $T=714860 649040 0 180 $X=713000 $Y=643620
X2050 3059 3092 3021 1 2 ND2 $T=716720 649040 0 0 $X=716720 $Y=648660
X2051 3098 3093 1843 1 2 ND2 $T=718580 659120 1 0 $X=718580 $Y=653700
X2052 3126 3121 3021 1 2 ND2 $T=722300 649040 1 180 $X=720440 $Y=648660
X2053 3111 3143 3021 1 2 ND2 $T=727260 649040 1 180 $X=725400 $Y=648660
X2054 3112 3161 1843 1 2 ND2 $T=727260 659120 0 180 $X=725400 $Y=653700
X2055 3150 3154 3021 1 2 ND2 $T=729120 649040 0 180 $X=727260 $Y=643620
X2056 3151 3139 1843 1 2 ND2 $T=729120 649040 0 0 $X=729120 $Y=648660
X2057 3155 3176 3149 1 2 ND2 $T=735940 588560 1 180 $X=734080 $Y=588180
X2058 3170 3172 1843 1 2 ND2 $T=734080 649040 0 0 $X=734080 $Y=648660
X2059 3190 3181 3021 1 2 ND2 $T=739040 649040 1 180 $X=737180 $Y=648660
X2060 3187 3178 3149 1 2 ND2 $T=740900 588560 1 180 $X=739040 $Y=588180
X2061 3200 3199 1843 1 2 ND2 $T=740900 659120 1 180 $X=739040 $Y=658740
X2062 3187 3186 3155 1 2 ND2 $T=740900 588560 0 0 $X=740900 $Y=588180
X2063 3201 3198 1843 1 2 ND2 $T=740900 649040 0 0 $X=740900 $Y=648660
X2064 591 3211 3021 1 2 ND2 $T=744620 649040 1 180 $X=742760 $Y=648660
X2065 3209 3206 1843 1 2 ND2 $T=744620 659120 1 0 $X=744620 $Y=653700
X2066 3230 3222 3021 1 2 ND2 $T=750200 659120 0 180 $X=748340 $Y=653700
X2067 3218 3223 3214 1 2 ND2 $T=749580 578480 0 0 $X=749580 $Y=578100
X2068 3249 3227 3214 1 2 ND2 $T=754540 588560 0 180 $X=752680 $Y=583140
X2069 3249 3238 3218 1 2 ND2 $T=757640 588560 0 180 $X=755780 $Y=583140
X2070 3273 3262 3241 1 2 ND2 $T=758260 608720 0 180 $X=756400 $Y=603300
X2071 3273 3271 3245 1 2 ND2 $T=759500 608720 1 0 $X=759500 $Y=603300
X2072 3264 605 607 1 2 ND2 $T=763840 528080 1 0 $X=763840 $Y=522660
X2073 3326 3304 611 1 2 ND2 $T=771280 608720 0 180 $X=769420 $Y=603300
X2074 611 3298 3303 1 2 ND2 $T=771280 598640 1 0 $X=771280 $Y=593220
X2075 3326 3318 3303 1 2 ND2 $T=773140 608720 1 0 $X=773140 $Y=603300
X2076 636 3377 3366 1 2 ND2 $T=786780 528080 1 0 $X=786780 $Y=522660
X2077 3391 3368 3364 1 2 ND2 $T=790500 588560 0 180 $X=788640 $Y=583140
X2078 3387 3405 3386 1 2 ND2 $T=793600 528080 1 180 $X=791740 $Y=527700
X2079 3391 3361 3397 1 2 ND2 $T=791740 588560 1 0 $X=791740 $Y=583140
X2080 650 3421 3438 1 2 ND2 $T=796700 608720 1 0 $X=796700 $Y=603300
X2081 3435 3406 3438 1 2 ND2 $T=798560 598640 0 0 $X=798560 $Y=598260
X2082 3452 3270 3449 1 2 ND2 $T=803520 659120 1 0 $X=803520 $Y=653700
X2083 2937 3465 3473 1 2 ND2 $T=807240 618800 1 180 $X=805380 $Y=618420
X2084 3464 3449 3383 1 2 ND2 $T=805380 659120 0 0 $X=805380 $Y=658740
X2085 664 3541 3538 1 2 ND2 $T=819020 588560 1 0 $X=819020 $Y=583140
X2086 3549 3546 664 1 2 ND2 $T=822120 588560 1 0 $X=822120 $Y=583140
X2087 3564 3571 3588 1 2 ND2 $T=827700 538160 0 0 $X=827700 $Y=537780
X2088 3564 3568 3514 1 2 ND2 $T=829560 548240 1 0 $X=829560 $Y=542820
X2089 3514 3577 3588 1 2 ND2 $T=830800 548240 0 0 $X=830800 $Y=547860
X2090 682 3551 3566 1 2 ND2 $T=833900 588560 0 180 $X=832040 $Y=583140
X2091 3598 3579 684 1 2 ND2 $T=836380 568400 0 180 $X=834520 $Y=562980
X2092 3609 3620 661 1 2 ND2 $T=837620 538160 1 0 $X=837620 $Y=532740
X2093 661 3615 693 1 2 ND2 $T=844440 538160 1 0 $X=844440 $Y=532740
X2094 3383 3673 3628 1 2 ND2 $T=851880 649040 1 180 $X=850020 $Y=648660
X2095 3586 3695 3651 1 2 ND2 $T=853120 598640 0 0 $X=853120 $Y=598260
X2096 3651 3712 3681 1 2 ND2 $T=864900 608720 0 180 $X=863040 $Y=603300
X2097 3739 3813 3708 1 2 ND2 $T=915120 598640 0 180 $X=913260 $Y=593220
X2098 3814 3822 3739 1 2 ND2 $T=915740 598640 1 180 $X=913880 $Y=598260
X2099 3723 3821 3708 1 2 ND2 $T=916360 588560 1 180 $X=914500 $Y=588180
X2100 3814 3845 3723 1 2 ND2 $T=920080 608720 0 180 $X=918220 $Y=603300
X2101 3912 3849 3924 1 2 ND2 $T=935580 598640 1 0 $X=935580 $Y=593220
X2102 3912 3855 3728 1 2 ND2 $T=939300 598640 0 0 $X=939300 $Y=598260
X2103 3924 3959 3731 1 2 ND2 $T=950460 598640 1 180 $X=948600 $Y=598260
X2104 3728 3974 3731 1 2 ND2 $T=952320 598640 1 180 $X=950460 $Y=598260
X2105 1719 171 1 2 INV12CK $T=406720 598640 0 180 $X=396800 $Y=593220
X2106 1719 101 1 2 INV12CK $T=417880 628880 0 0 $X=417880 $Y=628500
X2107 2072 1719 1 2 INV12CK $T=501580 598640 1 180 $X=491660 $Y=598260
X2108 1719 319 1 2 INV12CK $T=517700 598640 0 180 $X=507780 $Y=593220
X2109 585 576 1 2 INV12CK $T=740900 618800 0 180 $X=730980 $Y=613380
X2110 330 796 1 2 INV12CK $T=961000 598640 0 180 $X=951080 $Y=593220
X2111 2256 1 2269 2277 2 ND2T $T=522040 578480 1 0 $X=522040 $Y=573060
X2112 684 1 3592 3585 2 ND2T $T=833280 548240 0 0 $X=833280 $Y=547860
X2113 1973 1931 2 241 1972 1 235 FA1 $T=467480 689360 0 180 $X=451980 $Y=683940
X2114 1995 277 2 279 2008 1 2057 FA1 $T=469960 689360 1 0 $X=469960 $Y=683940
X2115 2054 2023 2 2028 2063 1 2005 FA1 $T=487940 659120 1 180 $X=472440 $Y=658740
X2116 1978 270 2 241 2057 1 271 FA1 $T=488560 689360 1 180 $X=473060 $Y=688980
X2117 2010 2060 2 279 2005 1 1972 FA1 $T=475540 679280 0 0 $X=475540 $Y=678900
X2118 2049 2034 2 2028 2081 1 2008 FA1 $T=491660 669200 0 180 $X=476160 $Y=663780
X2119 2226 2274 2 339 2240 1 2311 FA1 $T=515840 659120 1 0 $X=515840 $Y=653700
X2120 2262 2307 2 339 2281 1 2325 FA1 $T=523900 669200 1 0 $X=523900 $Y=663780
X2121 2310 2321 2 2309 2325 1 2369 FA1 $T=534440 669200 0 0 $X=534440 $Y=668820
X2122 2318 2360 2 2309 2311 1 2389 FA1 $T=536920 659120 0 0 $X=536920 $Y=658740
X2123 2336 373 2 2206 2369 1 2403 FA1 $T=540020 679280 1 0 $X=540020 $Y=673860
X2124 2373 2413 2 2206 2389 1 2450 FA1 $T=549320 669200 1 0 $X=549320 $Y=663780
X2125 2458 376 2 325 2414 1 2392 FA1 $T=567300 689360 0 180 $X=551800 $Y=683940
X2126 2487 379 2 321 2403 1 2414 FA1 $T=573500 679280 0 180 $X=558000 $Y=673860
X2127 2496 2439 2 321 2450 1 2446 FA1 $T=580940 669200 1 180 $X=565440 $Y=668820
X2128 2573 395 2 402 381 1 397 FA1 $T=593960 689360 1 180 $X=578460 $Y=688980
X2129 669 3537 2 685 3567 1 3618 FA1 $T=821500 528080 0 0 $X=821500 $Y=527700
X2130 697 3618 2 695 3545 1 720 FA1 $T=848780 528080 1 0 $X=848780 $Y=522660
X2131 2638 423 2674 2 1 2678 XOR3S $T=606980 538160 1 0 $X=606980 $Y=532740
X2132 1324 1368 1 2 INV3 $T=315580 679280 1 0 $X=315580 $Y=673860
X2133 187 403 1 2 INV3 $T=676420 608720 1 180 $X=673940 $Y=608340
X2134 3297 187 1 2 INV3 $T=766940 659120 0 0 $X=766940 $Y=658740
X2135 5 9 1 2 INV2 $T=226920 558320 1 0 $X=226920 $Y=552900
X2136 1050 45 1 2 INV2 $T=256060 528080 1 0 $X=256060 $Y=522660
X2137 1311 1317 1 2 INV2 $T=313720 689360 1 0 $X=313720 $Y=683940
X2138 1523 1471 1 2 INV2 $T=359600 628880 1 0 $X=359600 $Y=623460
X2139 1589 1567 1 2 INV2 $T=371380 628880 0 0 $X=371380 $Y=628500
X2140 1643 1648 1 2 INV2 $T=384400 638960 0 0 $X=384400 $Y=638580
X2141 1674 1646 1 2 INV2 $T=391220 628880 0 0 $X=391220 $Y=628500
X2142 1679 1680 1 2 INV2 $T=392460 659120 0 0 $X=392460 $Y=658740
X2143 1720 1704 1 2 INV2 $T=406100 669200 0 0 $X=406100 $Y=668820
X2144 204 137 1 2 INV2 $T=432140 628880 0 0 $X=432140 $Y=628500
X2145 2322 2290 1 2 INV2 $T=536920 568400 1 0 $X=536920 $Y=562980
X2146 2370 2229 1 2 INV2 $T=549320 578480 1 0 $X=549320 $Y=573060
X2147 2454 2459 1 2 INV2 $T=567300 528080 1 0 $X=567300 $Y=522660
X2148 2518 2429 1 2 INV2 $T=580940 568400 0 0 $X=580940 $Y=568020
X2149 2560 2337 1 2 INV2 $T=589620 568400 0 0 $X=589620 $Y=568020
X2150 2632 2438 1 2 INV2 $T=604500 578480 0 0 $X=604500 $Y=578100
X2151 2695 2628 1 2 INV2 $T=621860 548240 0 0 $X=621860 $Y=547860
X2152 204 526 1 2 INV2 $T=679520 528080 0 180 $X=677660 $Y=522660
X2153 204 555 1 2 INV2 $T=726020 618800 1 0 $X=726020 $Y=613380
X2154 590 58 1 2 INV2 $T=740900 618800 1 180 $X=739040 $Y=618420
X2155 3252 52 1 2 INV2 $T=752060 689360 0 180 $X=750200 $Y=683940
X2156 593 59 1 2 INV2 $T=750820 669200 1 0 $X=750820 $Y=663780
X2157 595 56 1 2 INV2 $T=753300 689360 0 0 $X=753300 $Y=688980
X2158 602 54 1 2 INV2 $T=759500 689360 0 0 $X=759500 $Y=688980
X2159 3329 3356 1 2 INV2 $T=781200 548240 1 0 $X=781200 $Y=542820
X2160 3348 3329 1 2 INV2 $T=781820 538160 0 0 $X=781820 $Y=537780
X2161 3382 1853 1 2 INV2 $T=802900 618800 0 180 $X=801040 $Y=613380
X2162 656 3049 1 2 INV2 $T=803520 578480 1 180 $X=801660 $Y=578100
X2163 3465 1843 1 2 INV2 $T=812200 618800 0 0 $X=812200 $Y=618420
X2164 3608 3610 1 2 INV2 $T=835760 548240 1 0 $X=835760 $Y=542820
X2165 3595 183 1 2 INV2 $T=835760 638960 1 0 $X=835760 $Y=633540
X2166 3736 752 1 2 INV2 $T=882260 548240 1 180 $X=880400 $Y=547860
X2167 3741 3320 1 2 INV2 $T=885980 558320 1 180 $X=884120 $Y=557940
X2168 3745 3355 1 2 INV2 $T=889080 578480 0 0 $X=889080 $Y=578100
X2169 3749 3310 1 2 INV2 $T=890320 618800 0 0 $X=890320 $Y=618420
X2170 268 183 655 2 3486 1 3502 AN4B1S $T=807240 628880 0 0 $X=807240 $Y=628500
X2171 3521 268 3518 2 3513 1 3506 AN4B1S $T=817160 638960 1 180 $X=812820 $Y=638580
X2172 3544 3516 3505 2 3526 1 3408 AN4B1S $T=821500 649040 1 180 $X=817160 $Y=648660
X2173 3481 3521 3530 2 3558 1 3544 AN4B1S $T=822120 649040 0 0 $X=822120 $Y=648660
X2174 48 2 1041 1081 1 NR2 $T=259160 558320 0 0 $X=259160 $Y=557940
X2175 1086 2 962 48 1 NR2 $T=261020 568400 0 180 $X=259160 $Y=562980
X2176 48 2 1032 49 1 NR2 $T=260400 548240 0 0 $X=260400 $Y=547860
X2177 48 2 1046 1096 1 NR2 $T=262260 548240 0 0 $X=262260 $Y=547860
X2178 1086 2 1087 55 1 NR2 $T=262260 568400 1 0 $X=262260 $Y=562980
X2179 48 2 1062 54 1 NR2 $T=262260 689360 1 0 $X=262260 $Y=683940
X2180 48 2 1080 52 1 NR2 $T=262260 689360 0 0 $X=262260 $Y=688980
X2181 48 2 1070 1112 1 NR2 $T=264120 649040 0 0 $X=264120 $Y=648660
X2182 48 2 1065 1107 1 NR2 $T=264120 659120 1 0 $X=264120 $Y=653700
X2183 48 2 1075 58 1 NR2 $T=264120 669200 1 0 $X=264120 $Y=663780
X2184 48 2 1071 59 1 NR2 $T=264120 679280 1 0 $X=264120 $Y=673860
X2185 48 2 1072 56 1 NR2 $T=264120 679280 0 0 $X=264120 $Y=678900
X2186 48 2 1078 1110 1 NR2 $T=265360 649040 1 0 $X=265360 $Y=643620
X2187 55 2 1101 56 1 NR2 $T=267220 689360 0 180 $X=265360 $Y=683940
X2188 1122 2 943 48 1 NR2 $T=267840 638960 1 180 $X=265980 $Y=638580
X2189 48 2 1079 60 1 NR2 $T=265980 659120 0 0 $X=265980 $Y=658740
X2190 55 2 1118 54 1 NR2 $T=267840 689360 1 180 $X=265980 $Y=688980
X2191 1122 2 1129 55 1 NR2 $T=269080 638960 0 180 $X=267220 $Y=633540
X2192 55 2 1120 1110 1 NR2 $T=267220 649040 1 0 $X=267220 $Y=643620
X2193 55 2 1123 1112 1 NR2 $T=267220 649040 0 0 $X=267220 $Y=648660
X2194 55 2 1126 1107 1 NR2 $T=267220 659120 1 0 $X=267220 $Y=653700
X2195 55 2 1127 60 1 NR2 $T=267220 669200 1 0 $X=267220 $Y=663780
X2196 55 2 1128 58 1 NR2 $T=267220 669200 0 0 $X=267220 $Y=668820
X2197 55 2 1124 59 1 NR2 $T=267220 679280 1 0 $X=267220 $Y=673860
X2198 55 2 1115 52 1 NR2 $T=267220 689360 1 0 $X=267220 $Y=683940
X2199 55 2 1131 62 1 NR2 $T=269080 689360 0 0 $X=269080 $Y=688980
X2200 55 2 1295 108 1 NR2 $T=313100 538160 1 0 $X=313100 $Y=532740
X2201 55 2 1291 1081 1 NR2 $T=313100 558320 1 0 $X=313100 $Y=552900
X2202 48 2 1039 108 1 NR2 $T=313720 548240 1 0 $X=313720 $Y=542820
X2203 55 2 1296 109 1 NR2 $T=314960 528080 1 0 $X=314960 $Y=522660
X2204 55 2 1290 110 1 NR2 $T=314960 528080 0 0 $X=314960 $Y=527700
X2205 48 2 1074 109 1 NR2 $T=314960 538160 0 0 $X=314960 $Y=537780
X2206 55 2 1293 49 1 NR2 $T=314960 548240 0 0 $X=314960 $Y=547860
X2207 55 2 1297 1096 1 NR2 $T=315580 558320 1 0 $X=315580 $Y=552900
X2208 55 2 106 112 1 NR2 $T=316820 528080 0 0 $X=316820 $Y=527700
X2209 48 2 1029 112 1 NR2 $T=316820 538160 1 0 $X=316820 $Y=532740
X2210 48 2 1031 114 1 NR2 $T=316820 538160 0 0 $X=316820 $Y=537780
X2211 48 2 1058 110 1 NR2 $T=316820 548240 1 0 $X=316820 $Y=542820
X2212 55 2 1305 114 1 NR2 $T=318680 528080 1 0 $X=318680 $Y=522660
X2213 111 2 1350 114 1 NR2 $T=321780 528080 1 180 $X=319920 $Y=527700
X2214 111 2 1341 109 1 NR2 $T=321780 538160 0 180 $X=319920 $Y=532740
X2215 111 2 1355 110 1 NR2 $T=321780 538160 1 180 $X=319920 $Y=537780
X2216 111 2 1346 1096 1 NR2 $T=319920 558320 1 0 $X=319920 $Y=552900
X2217 111 2 1351 1081 1 NR2 $T=319920 558320 0 0 $X=319920 $Y=557940
X2218 111 2 1332 49 1 NR2 $T=320540 548240 1 0 $X=320540 $Y=542820
X2219 111 2 117 112 1 NR2 $T=321780 528080 1 0 $X=321780 $Y=522660
X2220 111 2 1359 60 1 NR2 $T=323640 669200 1 0 $X=323640 $Y=663780
X2221 1086 2 1358 111 1 NR2 $T=325500 568400 1 0 $X=325500 $Y=562980
X2222 111 2 1383 52 1 NR2 $T=327360 689360 1 180 $X=325500 $Y=688980
X2223 111 2 1398 1112 1 NR2 $T=328600 669200 0 180 $X=326740 $Y=663780
X2224 111 2 1375 59 1 NR2 $T=328600 679280 1 180 $X=326740 $Y=678900
X2225 111 2 1367 1107 1 NR2 $T=328600 659120 1 0 $X=328600 $Y=653700
X2226 111 2 1385 58 1 NR2 $T=328600 679280 1 0 $X=328600 $Y=673860
X2227 111 2 1397 56 1 NR2 $T=328600 679280 0 0 $X=328600 $Y=678900
X2228 111 2 1391 54 1 NR2 $T=328600 689360 1 0 $X=328600 $Y=683940
X2229 111 2 1363 108 1 NR2 $T=329220 548240 1 0 $X=329220 $Y=542820
X2230 1122 2 1408 111 1 NR2 $T=334180 649040 0 0 $X=334180 $Y=648660
X2231 111 2 1417 1110 1 NR2 $T=337280 649040 0 0 $X=337280 $Y=648660
X2232 1735 2 1773 1763 1 NR2 $T=420980 608720 1 180 $X=419120 $Y=608340
X2233 1792 2 1808 1819 1 NR2 $T=441440 598640 0 0 $X=441440 $Y=598260
X2234 216 2 1884 227 1 NR2 $T=446400 528080 0 0 $X=446400 $Y=527700
X2235 2111 2 2050 2099 1 NR2 $T=497240 638960 1 180 $X=495380 $Y=638580
X2236 2149 2 2148 1969 1 NR2 $T=502200 638960 1 0 $X=502200 $Y=633540
X2237 2160 2 2118 2165 1 NR2 $T=504060 679280 1 0 $X=504060 $Y=673860
X2238 2161 2 2084 2166 1 NR2 $T=504060 679280 0 0 $X=504060 $Y=678900
X2239 2143 2 2157 2190 1 NR2 $T=507780 628880 1 0 $X=507780 $Y=623460
X2240 340 2 2150 2231 1 NR2 $T=519560 679280 1 180 $X=517700 $Y=678900
X2241 334 2 2232 2242 1 NR2 $T=519560 689360 0 0 $X=519560 $Y=688980
X2242 343 2 2275 2251 1 NR2 $T=523280 689360 1 180 $X=521420 $Y=688980
X2243 345 2 2282 2268 1 NR2 $T=526380 679280 0 0 $X=526380 $Y=678900
X2244 2334 2 2333 2348 1 NR2 $T=541880 689360 1 0 $X=541880 $Y=683940
X2245 2350 2 374 2385 1 NR2 $T=549940 689360 0 0 $X=549940 $Y=688980
X2246 2399 2 2380 2386 1 NR2 $T=556760 608720 1 180 $X=554900 $Y=608340
X2247 2419 2 2539 2488 1 NR2 $T=584040 649040 1 0 $X=584040 $Y=643620
X2248 2484 2 2618 2553 1 NR2 $T=601400 679280 1 180 $X=599540 $Y=678900
X2249 458 2 2841 466 1 NR2 $T=657200 568400 1 0 $X=657200 $Y=562980
X2250 2848 2 2879 2094 1 NR2 $T=667740 588560 1 0 $X=667740 $Y=583140
X2251 534 2 491 2948 1 NR2 $T=683860 649040 1 180 $X=682000 $Y=648660
X2252 2868 2 2951 527 1 NR2 $T=682000 659120 1 0 $X=682000 $Y=653700
X2253 2948 2 543 2094 1 NR2 $T=689440 649040 0 0 $X=689440 $Y=648660
X2254 2959 2 3016 2094 1 NR2 $T=696880 638960 1 180 $X=695020 $Y=638580
X2255 565 2 3089 568 1 NR2 $T=718580 538160 0 0 $X=718580 $Y=537780
X2256 568 2 3105 570 1 NR2 $T=724160 528080 1 180 $X=722300 $Y=527700
X2257 568 2 3132 573 1 NR2 $T=725400 528080 0 0 $X=725400 $Y=527700
X2258 568 2 3157 575 1 NR2 $T=732220 528080 1 180 $X=730360 $Y=527700
X2259 568 2 3177 60 1 NR2 $T=735940 528080 0 0 $X=735940 $Y=527700
X2260 568 2 3192 58 1 NR2 $T=739040 528080 0 0 $X=739040 $Y=527700
X2261 568 2 3207 59 1 NR2 $T=746480 528080 0 0 $X=746480 $Y=527700
X2262 568 2 3216 56 1 NR2 $T=750200 528080 0 0 $X=750200 $Y=527700
X2263 568 2 3236 52 1 NR2 $T=750820 528080 1 0 $X=750820 $Y=522660
X2264 568 2 3259 62 1 NR2 $T=757640 538160 1 0 $X=757640 $Y=532740
X2265 568 2 3266 603 1 NR2 $T=759500 538160 1 0 $X=759500 $Y=532740
X2266 568 2 3307 616 1 NR2 $T=768180 538160 1 0 $X=768180 $Y=532740
X2267 568 2 3313 617 1 NR2 $T=769420 528080 1 0 $X=769420 $Y=522660
X2268 3365 2 513 3292 1 NR2 $T=783680 659120 1 180 $X=781820 $Y=658740
X2269 574 2 3367 3356 1 NR2 $T=784300 548240 1 0 $X=784300 $Y=542820
X2270 3377 2 3346 606 1 NR2 $T=786780 538160 1 180 $X=784920 $Y=537780
X2271 574 2 3394 3405 1 NR2 $T=795460 538160 1 0 $X=795460 $Y=532740
X2272 513 2 3436 1853 1 NR2 $T=796700 679280 1 0 $X=796700 $Y=673860
X2273 3440 2 3473 3013 1 NR2 $T=800420 618800 0 0 $X=800420 $Y=618420
X2274 3440 2 3446 3428 1 NR2 $T=800420 628880 1 0 $X=800420 $Y=623460
X2275 3426 2 3497 3433 1 NR2 $T=802280 528080 0 0 $X=802280 $Y=527700
X2276 3487 2 3392 183 1 NR2 $T=806000 649040 0 180 $X=804140 $Y=643620
X2277 3382 2 3542 655 1 NR2 $T=805380 598640 0 0 $X=805380 $Y=598260
X2278 3487 2 3477 3505 1 NR2 $T=810340 649040 0 0 $X=810340 $Y=648660
X2279 3403 2 659 3365 1 NR2 $T=812200 669200 0 180 $X=810340 $Y=663780
X2280 3516 2 3519 3526 1 NR2 $T=814060 649040 0 0 $X=814060 $Y=648660
X2281 3617 2 3403 3628 1 NR2 $T=837620 669200 0 0 $X=837620 $Y=668820
X2282 691 2 3645 3628 1 NR2 $T=841340 669200 0 0 $X=841340 $Y=668820
X2283 187 2 699 655 1 NR2 $T=848160 638960 1 180 $X=846300 $Y=638580
X2284 187 2 705 183 1 NR2 $T=847540 659120 0 0 $X=847540 $Y=658740
X2285 187 2 704 3632 1 NR2 $T=848160 649040 1 0 $X=848160 $Y=643620
X2286 187 2 707 3600 1 NR2 $T=850020 659120 1 0 $X=850020 $Y=653700
X2287 187 2 708 3558 1 NR2 $T=850020 659120 0 0 $X=850020 $Y=658740
X2288 3683 2 3697 3696 1 NR2 $T=858080 659120 0 0 $X=858080 $Y=658740
X2289 3762 2 3823 3830 1 NR2 $T=915740 679280 1 0 $X=915740 $Y=673860
X2290 3818 2 3836 3833 1 NR2 $T=916360 669200 0 0 $X=916360 $Y=668820
X2291 3804 2 3834 3838 1 NR2 $T=917600 618800 1 0 $X=917600 $Y=613380
X2292 3839 2 3843 3847 1 NR2 $T=919460 628880 1 0 $X=919460 $Y=623460
X2293 3849 2 3844 3822 1 NR2 $T=921940 598640 1 180 $X=920080 $Y=598260
X2294 3822 2 3851 3855 1 NR2 $T=921320 598640 1 0 $X=921320 $Y=593220
X2295 3761 2 3859 3856 1 NR2 $T=921320 659120 1 0 $X=921320 $Y=653700
X2296 3813 2 3877 3849 1 NR2 $T=927520 598640 1 0 $X=927520 $Y=593220
X2297 3811 2 3870 3872 1 NR2 $T=928140 578480 0 0 $X=928140 $Y=578100
X2298 3782 2 3880 3875 1 NR2 $T=928760 538160 1 0 $X=928760 $Y=532740
X2299 3780 2 3873 3879 1 NR2 $T=929380 558320 0 0 $X=929380 $Y=557940
X2300 3832 2 3889 3881 1 NR2 $T=930000 649040 0 0 $X=930000 $Y=648660
X2301 3848 2 3887 3888 1 NR2 $T=930620 628880 0 0 $X=930620 $Y=628500
X2302 3808 2 3883 3882 1 NR2 $T=931240 558320 0 0 $X=931240 $Y=557940
X2303 3766 2 3890 3891 1 NR2 $T=931240 679280 1 0 $X=931240 $Y=673860
X2304 3842 2 3903 3885 1 NR2 $T=933100 538160 0 0 $X=933100 $Y=537780
X2305 3846 2 3904 3908 1 NR2 $T=933720 568400 0 0 $X=933720 $Y=568020
X2306 3813 2 3905 3855 1 NR2 $T=933720 598640 1 0 $X=933720 $Y=593220
X2307 3807 2 3900 3909 1 NR2 $T=933720 628880 1 0 $X=933720 $Y=623460
X2308 3787 2 776 3916 1 NR2 $T=934960 528080 1 0 $X=934960 $Y=522660
X2309 3819 2 3953 3927 1 NR2 $T=943640 578480 1 0 $X=943640 $Y=573060
X2310 3939 2 3828 3944 1 NR2 $T=943640 608720 0 0 $X=943640 $Y=608340
X2311 3858 2 3988 3937 1 NR2 $T=944880 638960 0 0 $X=944880 $Y=638580
X2312 3945 2 3835 3944 1 NR2 $T=947980 608720 1 0 $X=947980 $Y=603300
X2313 3822 2 3964 3959 1 NR2 $T=948600 598640 1 0 $X=948600 $Y=593220
X2314 3960 2 3934 3945 1 NR2 $T=951080 618800 0 180 $X=949220 $Y=613380
X2315 3960 2 3824 3939 1 NR2 $T=953560 608720 1 180 $X=951700 $Y=608340
X2316 3822 2 3978 3974 1 NR2 $T=952320 598640 0 0 $X=952320 $Y=598260
X2317 3813 2 3902 3974 1 NR2 $T=972160 608720 1 0 $X=972160 $Y=603300
X2318 3813 2 4038 3959 1 NR2 $T=973400 598640 1 0 $X=973400 $Y=593220
X2319 4065 2 3829 810 1 NR2 $T=975260 618800 1 0 $X=975260 $Y=613380
X2320 3959 2 3800 3845 1 NR2 $T=982700 608720 1 0 $X=982700 $Y=603300
X2321 4097 2 4002 810 1 NR2 $T=984560 618800 0 180 $X=982700 $Y=613380
X2322 3959 2 4088 3821 1 NR2 $T=993860 598640 0 0 $X=993860 $Y=598260
X2323 3974 2 4083 3821 1 NR2 $T=1008120 598640 0 0 $X=1008120 $Y=598260
X2324 3974 2 4109 3845 1 NR2 $T=1015560 588560 0 0 $X=1015560 $Y=588180
X2325 3855 2 4141 3821 1 NR2 $T=1025480 588560 1 0 $X=1025480 $Y=583140
X2326 3849 2 4220 3821 1 NR2 $T=1027340 598640 0 180 $X=1025480 $Y=593220
X2327 3849 2 4174 3845 1 NR2 $T=1027340 598640 1 0 $X=1027340 $Y=593220
X2328 3855 2 4182 3845 1 NR2 $T=1027960 608720 1 0 $X=1027960 $Y=603300
X2329 3695 3653 2 732 1 762 AOI12HS $T=868620 588560 1 0 $X=868620 $Y=583140
X2330 3712 3660 2 3723 1 3739 AOI12HS $T=878540 598640 0 0 $X=878540 $Y=598260
X2331 625 3449 3439 187 2 1 3401 OA112 $T=802900 659120 1 180 $X=797940 $Y=658740
X2332 1371 1 1361 1276 2 1388 ND3 $T=328600 608720 0 180 $X=326120 $Y=603300
X2333 1476 1 1466 1452 2 1458 ND3 $T=349680 628880 1 180 $X=347200 $Y=628500
X2334 1641 1 1645 1619 2 1665 ND3 $T=384400 558320 0 0 $X=384400 $Y=557940
X2335 1735 1 1730 1784 2 1781 ND3 $T=422220 608720 0 0 $X=422220 $Y=608340
X2336 1764 1 1752 1804 2 1780 ND3 $T=429040 618800 0 0 $X=429040 $Y=618420
X2337 1852 1 1889 1881 2 1872 ND3 $T=447640 558320 1 180 $X=445160 $Y=557940
X2338 1830 1 1889 1893 2 1898 ND3 $T=447640 558320 0 0 $X=447640 $Y=557940
X2339 216 1 234 1906 2 227 ND3 $T=448260 528080 0 0 $X=448260 $Y=527700
X2340 1846 1 1889 1909 2 1915 ND3 $T=452600 558320 0 0 $X=452600 $Y=557940
X2341 236 1 240 1925 2 1899 ND3 $T=456940 538160 0 180 $X=454460 $Y=532740
X2342 1924 1 1889 1951 2 1950 ND3 $T=459420 568400 1 0 $X=459420 $Y=562980
X2343 1932 1 1889 1956 2 1863 ND3 $T=460660 568400 0 0 $X=460660 $Y=568020
X2344 1965 1 1889 2045 2 2031 ND3 $T=476780 558320 0 0 $X=476780 $Y=557940
X2345 1999 1 1889 2027 2 1997 ND3 $T=476780 568400 1 0 $X=476780 $Y=562980
X2346 2038 1 1889 2061 2 2058 ND3 $T=483600 568400 1 0 $X=483600 $Y=562980
X2347 2043 1 1889 2065 2 2067 ND3 $T=485460 578480 0 0 $X=485460 $Y=578100
X2348 2084 1 2082 2034 2 289 ND3 $T=491040 689360 0 180 $X=488560 $Y=683940
X2349 2125 1 1889 2108 2 2076 ND3 $T=497860 578480 0 180 $X=495380 $Y=573060
X2350 2118 1 2113 2089 2 301 ND3 $T=497860 679280 1 180 $X=495380 $Y=678900
X2351 2145 1 2103 2139 2 2070 ND3 $T=500960 568400 1 180 $X=498480 $Y=568020
X2352 2150 1 2147 2133 2 2114 ND3 $T=502820 679280 0 180 $X=500340 $Y=673860
X2353 2152 1 2174 2186 2 2180 ND3 $T=505300 628880 0 0 $X=505300 $Y=628500
X2354 2194 1 2015 2213 2 2207 ND3 $T=510260 638960 0 0 $X=510260 $Y=638580
X2355 2232 1 2188 2216 2 2215 ND3 $T=517080 689360 1 180 $X=514600 $Y=688980
X2356 2275 1 347 2246 2 349 ND3 $T=525760 689360 0 0 $X=525760 $Y=688980
X2357 2282 1 2303 2307 2 2315 ND3 $T=531340 679280 1 0 $X=531340 $Y=673860
X2358 2333 1 2314 2321 2 359 ND3 $T=538780 679280 0 180 $X=536300 $Y=673860
X2359 2289 1 2353 2375 2 2328 ND3 $T=544360 618800 1 0 $X=544360 $Y=613380
X2360 2357 1 2327 2362 2 2376 ND3 $T=546220 618800 0 0 $X=546220 $Y=618420
X2361 2236 1 2418 2430 2 2441 ND3 $T=561720 608720 0 0 $X=561720 $Y=608340
X2362 2266 1 2498 2499 2 2508 ND3 $T=577220 608720 0 0 $X=577220 $Y=608340
X2363 2244 1 2498 2542 2 2545 ND3 $T=584660 608720 0 0 $X=584660 $Y=608340
X2364 2633 1 2498 2656 2 2637 ND3 $T=604500 618800 0 0 $X=604500 $Y=618420
X2365 2660 1 2498 2649 2 2644 ND3 $T=611940 618800 1 180 $X=609460 $Y=618420
X2366 2763 1 2498 2777 2 2728 ND3 $T=646040 618800 1 180 $X=643560 $Y=618420
X2367 2799 1 2804 2797 2 2790 ND3 $T=652860 598640 0 180 $X=650380 $Y=593220
X2368 2792 1 2804 2814 2 2820 ND3 $T=652240 578480 0 0 $X=652240 $Y=578100
X2369 2782 1 2804 2830 2 2825 ND3 $T=653480 588560 1 0 $X=653480 $Y=583140
X2370 458 1 488 2829 2 466 ND3 $T=654100 568400 1 0 $X=654100 $Y=562980
X2371 2810 1 2804 2826 2 2798 ND3 $T=654720 608720 1 0 $X=654720 $Y=603300
X2372 2818 1 2804 2843 2 2833 ND3 $T=655340 598640 0 0 $X=655340 $Y=598260
X2373 2831 1 2804 2835 2 2838 ND3 $T=657200 608720 1 0 $X=657200 $Y=603300
X2374 2836 1 2498 2872 2 2754 ND3 $T=660920 618800 0 180 $X=658440 $Y=613380
X2375 2772 1 2804 2864 2 2842 ND3 $T=659060 588560 1 0 $X=659060 $Y=583140
X2376 2850 1 2804 2851 2 2815 ND3 $T=661540 608720 1 180 $X=659060 $Y=608340
X2377 2862 1 2804 2858 2 2849 ND3 $T=662780 598640 1 180 $X=660300 $Y=598260
X2378 2863 1 2498 2859 2 2730 ND3 $T=662780 618800 1 180 $X=660300 $Y=618420
X2379 497 1 2801 2871 2 2794 ND3 $T=662160 558320 0 0 $X=662160 $Y=557940
X2380 2873 1 2804 2860 2 2824 ND3 $T=664640 598640 0 180 $X=662160 $Y=593220
X2381 2876 1 2498 2875 2 2722 ND3 $T=666500 618800 1 180 $X=664020 $Y=618420
X2382 2881 1 2498 2884 2 2727 ND3 $T=667740 618800 0 180 $X=665260 $Y=613380
X2383 2915 1 2498 2906 2 2718 ND3 $T=673940 608720 1 180 $X=671460 $Y=608340
X2384 2868 1 2887 2965 2 527 ND3 $T=683240 659120 0 0 $X=683240 $Y=658740
X2385 2889 1 2946 2975 2 2929 ND3 $T=684480 669200 1 0 $X=684480 $Y=663780
X2386 3039 1 2992 3047 2 3041 ND3 $T=708660 649040 0 180 $X=706180 $Y=643620
X2387 3057 1 2992 3073 2 3064 ND3 $T=710520 649040 1 0 $X=710520 $Y=643620
X2388 3060 1 2992 3080 2 3083 ND3 $T=713000 649040 0 0 $X=713000 $Y=648660
X2389 3093 1 2992 3102 2 3092 ND3 $T=718580 649040 1 0 $X=718580 $Y=643620
X2390 3139 1 2992 3128 2 3121 ND3 $T=726020 649040 0 180 $X=723540 $Y=643620
X2391 3161 1 2992 3166 2 3143 ND3 $T=731600 649040 0 0 $X=731600 $Y=648660
X2392 3172 1 2992 3175 2 3154 ND3 $T=734700 649040 0 180 $X=732220 $Y=643620
X2393 3176 1 3178 3107 2 3186 ND3 $T=736560 588560 0 0 $X=736560 $Y=588180
X2394 3198 1 2992 3205 2 3181 ND3 $T=741520 649040 0 180 $X=739040 $Y=643620
X2395 3199 1 2992 3215 2 3211 ND3 $T=742140 649040 1 0 $X=742140 $Y=643620
X2396 3206 1 2992 3260 2 3222 ND3 $T=742140 659120 0 0 $X=742140 $Y=658740
X2397 3223 1 3227 3146 2 3238 ND3 $T=748960 588560 1 0 $X=748960 $Y=583140
X2398 3251 1 3262 3204 2 3271 ND3 $T=755780 598640 1 0 $X=755780 $Y=593220
X2399 3446 1 3429 3441 2 3417 ND3 $T=802280 638960 1 180 $X=799800 $Y=638580
X2400 3499 1 3410 3487 2 3519 ND3 $T=812200 649040 1 0 $X=812200 $Y=643620
X2401 3520 1 3460 3526 2 3508 ND3 $T=816540 659120 0 0 $X=816540 $Y=658740
X2402 3516 1 3530 3513 2 3505 ND3 $T=819640 638960 0 180 $X=817160 $Y=633540
X2403 3541 1 3546 3474 2 3534 ND3 $T=821500 588560 1 180 $X=819020 $Y=588180
X2404 3577 1 3568 3548 2 3571 ND3 $T=827080 548240 0 0 $X=827080 $Y=547860
X2405 692 1 691 3644 2 3452 ND3 $T=840100 659120 1 180 $X=837620 $Y=658740
X2406 692 1 691 696 2 3614 ND3 $T=840100 679280 0 180 $X=837620 $Y=673860
X2407 3600 1 3558 3486 2 3632 ND3 $T=845680 638960 1 180 $X=843200 $Y=638580
X2408 3697 1 692 3689 2 3688 ND3 $T=858700 679280 0 180 $X=856220 $Y=673860
X2409 3674 1 3694 3664 2 710 ND3 $T=859940 679280 1 0 $X=859940 $Y=673860
X2410 3903 1 3950 3942 2 3966 ND3 $T=949220 538160 0 0 $X=949220 $Y=537780
X2411 3900 1 3961 3954 2 3975 ND3 $T=949840 628880 0 0 $X=949840 $Y=628500
X2412 3887 1 3962 3932 2 3976 ND3 $T=949840 638960 0 0 $X=949840 $Y=638580
X2413 3823 1 3977 3979 2 3987 ND3 $T=951700 679280 1 0 $X=951700 $Y=673860
X2414 3834 1 3992 3994 2 3999 ND3 $T=953560 608720 0 0 $X=953560 $Y=608340
X2415 3988 1 3993 3985 2 4000 ND3 $T=953560 638960 0 0 $X=953560 $Y=638580
X2416 3890 1 4004 4015 2 4009 ND3 $T=955420 679280 1 0 $X=955420 $Y=673860
X2417 3904 1 4005 3990 2 4012 ND3 $T=956040 568400 0 0 $X=956040 $Y=568020
X2418 3953 1 4008 4010 2 4017 ND3 $T=956660 588560 1 0 $X=956660 $Y=583140
X2419 3889 1 4021 4023 2 4030 ND3 $T=958520 659120 1 0 $X=958520 $Y=653700
X2420 3873 1 4013 802 2 4034 ND3 $T=961000 558320 1 0 $X=961000 $Y=552900
X2421 3836 1 4043 4041 2 4048 ND3 $T=963480 679280 1 0 $X=963480 $Y=673860
X2422 3883 1 4039 4049 2 4052 ND3 $T=964720 548240 0 0 $X=964720 $Y=547860
X2423 3843 1 4047 4029 2 4051 ND3 $T=965340 628880 1 0 $X=965340 $Y=623460
X2424 3880 1 4066 4064 2 4073 ND3 $T=970920 538160 0 0 $X=970920 $Y=537780
X2425 3870 1 4056 4071 2 4075 ND3 $T=972160 578480 0 0 $X=972160 $Y=578100
X2426 3859 1 4070 4046 2 4081 ND3 $T=972160 659120 0 0 $X=972160 $Y=658740
X2427 4181 1 4158 4111 2 4206 ND3 $T=1012460 558320 1 0 $X=1012460 $Y=552900
X2428 4187 1 4178 4106 2 4190 ND3 $T=1014320 548240 1 0 $X=1014320 $Y=542820
X2429 4191 1 4152 4096 2 4201 ND3 $T=1016180 558320 1 0 $X=1016180 $Y=552900
X2430 4194 1 4176 4125 2 4231 ND3 $T=1016180 679280 1 0 $X=1016180 $Y=673860
X2431 4197 1 4172 4102 2 4204 ND3 $T=1016800 588560 1 0 $X=1016800 $Y=583140
X2432 4209 1 4196 4116 2 4198 ND3 $T=1019900 638960 0 180 $X=1017420 $Y=633540
X2433 4200 1 4150 4121 2 4213 ND3 $T=1018040 538160 0 0 $X=1018040 $Y=537780
X2434 4203 1 4205 4112 2 4215 ND3 $T=1018040 689360 1 0 $X=1018040 $Y=683940
X2435 4222 1 4140 4115 2 4217 ND3 $T=1019280 588560 1 0 $X=1019280 $Y=583140
X2436 4252 1 4162 4095 2 4246 ND3 $T=1019900 689360 0 0 $X=1019900 $Y=688980
X2437 4216 1 4219 827 2 831 ND3 $T=1021140 528080 1 0 $X=1021140 $Y=522660
X2438 4212 1 4153 4104 2 4236 ND3 $T=1021760 598640 0 0 $X=1021760 $Y=598260
X2439 4221 1 4171 4122 2 4233 ND3 $T=1023620 669200 1 0 $X=1023620 $Y=663780
X2440 4223 1 4229 4117 2 4237 ND3 $T=1024860 649040 1 0 $X=1024860 $Y=643620
X2441 4242 1 4183 4100 2 4248 ND3 $T=1027960 578480 1 0 $X=1027960 $Y=573060
X2442 4273 1 4192 4123 2 4245 ND3 $T=1028580 628880 0 0 $X=1028580 $Y=628500
X2443 4261 1 4189 4124 2 4256 ND3 $T=1033540 628880 1 180 $X=1031060 $Y=628500
X2444 4290 1 4199 4129 2 4263 ND3 $T=1037880 659120 0 180 $X=1035400 $Y=653700
X2445 126 107 1 2 BUF2 $T=336660 608720 1 180 $X=333560 $Y=608340
X2446 403 167 1 2 BUF2 $T=585900 598640 0 180 $X=582800 $Y=593220
X2447 3547 676 1 2 BUF2 $T=822740 618800 1 0 $X=822740 $Y=613380
X2448 3552 677 1 2 BUF2 $T=823980 628880 1 0 $X=823980 $Y=623460
X2449 1816 193 1894 1 2 1896 1795 1938 859 ICV_13 $T=438960 588560 1 0 $X=438960 $Y=583140
X2450 1787 193 1977 1 2 2048 1821 2088 859 ICV_13 $T=470580 598640 0 0 $X=470580 $Y=598260
X2451 1944 193 2105 1 2 288 1821 2116 859 ICV_13 $T=486080 598640 1 0 $X=486080 $Y=593220
X2452 2078 385 2503 1 2 2039 385 2567 859 ICV_13 $T=569780 628880 0 0 $X=569780 $Y=628500
X2453 2018 385 2610 1 2 2104 385 2653 859 ICV_13 $T=593340 649040 1 0 $X=593340 $Y=643620
X2454 2725 2740 2759 1 2 2761 2740 2795 859 ICV_13 $T=630540 659120 0 0 $X=630540 $Y=658740
X2455 2731 2740 2768 1 2 476 2740 2822 859 ICV_13 $T=635500 669200 0 0 $X=635500 $Y=668820
X2456 2767 1795 2812 1 2 2816 1795 2869 859 ICV_13 $T=643560 649040 0 0 $X=643560 $Y=648660
X2457 481 2740 2856 1 2 2796 2740 2832 859 ICV_13 $T=651620 659120 0 0 $X=651620 $Y=658740
X2458 3686 755 3775 1 2 3686 750 3805 859 ICV_13 $T=892800 578480 0 0 $X=892800 $Y=578100
X2459 3701 817 4137 1 2 3718 815 4188 859 ICV_13 $T=992620 638960 1 0 $X=992620 $Y=633540
X2460 3686 817 4151 1 2 3738 815 4185 859 ICV_13 $T=995100 578480 1 0 $X=995100 $Y=573060
X2461 3714 809 4132 1 2 3714 815 4195 859 ICV_13 $T=995100 628880 1 0 $X=995100 $Y=623460
X2462 3678 838 4319 1 2 3738 4269 4358 859 ICV_13 $T=1062060 578480 0 0 $X=1062060 $Y=578100
X2463 1790 1637 1 2 INV4CK $T=425940 588560 0 0 $X=425940 $Y=588180
X2464 2025 2072 1 2 INV4CK $T=487320 608720 0 0 $X=487320 $Y=608340
X2465 2599 2257 1 2 INV4CK $T=597680 608720 0 0 $X=597680 $Y=608340
X2466 553 2740 1 2 INV4CK $T=699360 679280 0 0 $X=699360 $Y=678900
X2467 3224 2908 1 2 INV4CK $T=753920 659120 0 180 $X=750200 $Y=653700
X2468 3899 3917 1 2 INV4CK $T=934960 538160 0 0 $X=934960 $Y=537780
X2469 3970 3983 1 2 INV4CK $T=954800 538160 0 180 $X=951080 $Y=532740
X2470 4120 4130 1 2 INV4CK $T=995720 598640 0 0 $X=995720 $Y=598260
X2471 4134 4135 1 2 INV4CK $T=1000680 638960 0 0 $X=1000680 $Y=638580
X2472 257 250 1 2 INV6CK $T=461900 588560 0 0 $X=461900 $Y=588180
X2473 250 2025 1 2 INV6CK $T=479880 608720 0 0 $X=479880 $Y=608340
X2474 257 225 1 2 INV6CK $T=491660 578480 0 0 $X=491660 $Y=578100
X2475 2726 356 1 2 INV6CK $T=633640 679280 0 180 $X=628060 $Y=673860
X2476 2855 1821 1 2 INV6CK $T=661540 608720 0 0 $X=661540 $Y=608340
X2477 2852 326 1 2 INV6CK $T=675180 669200 1 0 $X=675180 $Y=663780
X2478 552 1795 1 2 INV6CK $T=699980 649040 0 180 $X=694400 $Y=643620
X2479 3792 750 1 2 INV6CK $T=908920 588560 0 180 $X=903340 $Y=583140
X2480 3791 756 1 2 INV6CK $T=908300 568400 0 0 $X=908300 $Y=568020
X2481 3812 755 1 2 INV6CK $T=921940 568400 0 0 $X=921940 $Y=568020
X2482 3915 770 1 2 INV6CK $T=936820 588560 0 180 $X=931240 $Y=583140
X2483 3968 771 1 2 INV6CK $T=952320 588560 0 180 $X=946740 $Y=583140
X2484 3983 779 1 2 INV6CK $T=970300 608720 0 180 $X=964720 $Y=603300
X2485 3980 799 1 2 INV6CK $T=979600 578480 0 180 $X=974020 $Y=573060
X2486 3917 809 1 2 INV6CK $T=993240 578480 1 180 $X=987660 $Y=578100
X2487 4035 815 1 2 INV6CK $T=1005020 608720 1 180 $X=999440 $Y=608340
X2488 3841 817 1 2 INV6CK $T=1005640 588560 0 0 $X=1005640 $Y=588180
X2489 4085 823 1 2 INV6CK $T=1016800 578480 0 0 $X=1016800 $Y=578100
X2490 4105 830 1 2 INV6CK $T=1045940 598640 0 180 $X=1040360 $Y=593220
X2491 4143 4269 1 2 INV6CK $T=1047800 588560 0 180 $X=1042220 $Y=583140
X2492 4130 834 1 2 INV6CK $T=1048420 578480 0 180 $X=1042840 $Y=573060
X2493 4135 838 1 2 INV6CK $T=1049660 618800 0 0 $X=1049660 $Y=618420
X2494 4211 841 1 2 INV6CK $T=1056480 598640 0 0 $X=1056480 $Y=598260
X2495 93 2 1 1117 BUF1 $T=295740 638960 1 0 $X=295740 $Y=633540
X2496 128 2 1 116 BUF1 $T=366420 528080 0 0 $X=366420 $Y=527700
X2497 369 2 1 2218 BUF1 $T=548700 528080 1 180 $X=546220 $Y=527700
X2498 403 2 1 400 BUF1 $T=584660 618800 0 180 $X=582180 $Y=613380
X2499 438 2 1 1827 BUF1 $T=628060 679280 0 180 $X=625580 $Y=673860
X2500 204 2 1 463 BUF1 $T=679520 618800 1 180 $X=677040 $Y=618420
X2501 403 2 1 2937 BUF1 $T=681380 618800 1 0 $X=681380 $Y=613380
X2502 2211 2 1 594 BUF1 $T=747100 649040 1 0 $X=747100 $Y=643620
X2503 598 2 1 3113 BUF1 $T=756400 528080 0 180 $X=753920 $Y=522660
X2504 606 2 1 3136 BUF1 $T=765700 538160 1 180 $X=763220 $Y=537780
X2505 2937 2 1 3488 BUF1 $T=806620 628880 1 0 $X=806620 $Y=623460
X2506 3533 2 1 662 BUF1 $T=820260 669200 0 180 $X=817780 $Y=663780
X2507 1947 1917 1 2 INV2CK $T=463140 538160 0 180 $X=460660 $Y=532740
X2508 2562 2599 1 2 INV2CK $T=610080 638960 0 180 $X=607600 $Y=633540
X2509 2729 2726 1 2 INV2CK $T=631160 689360 0 180 $X=628680 $Y=683940
X2510 499 2852 1 2 INV2CK $T=660300 689360 1 0 $X=660300 $Y=683940
X2511 2857 2995 1 2 INV2CK $T=691920 538160 0 0 $X=691920 $Y=537780
X2512 3153 3224 1 2 INV2CK $T=750200 689360 0 180 $X=747720 $Y=683940
X2513 597 3255 1 2 INV2CK $T=754540 669200 0 0 $X=754540 $Y=668820
X2514 225 1908 1 2 1922 QDBHN $T=449500 568400 0 0 $X=449500 $Y=568020
X2515 250 1962 1 2 1993 QDBHN $T=460660 618800 0 0 $X=460660 $Y=618420
X2516 250 1984 1 2 263 QDBHN $T=474300 528080 0 180 $X=466860 $Y=522660
X2517 410 2569 1 2 2585 QDBHN $T=603260 638960 0 180 $X=595820 $Y=633540
X2518 410 491 1 2 2807 QDBHN $T=660920 649040 0 180 $X=653480 $Y=643620
X2519 410 491 1 2 2886 QDBHN $T=678900 659120 0 180 $X=671460 $Y=653700
X2520 410 543 1 2 2964 QDBHN $T=702460 689360 0 0 $X=702460 $Y=688980
X2521 410 3195 1 2 3131 QDBHN $T=743380 689360 0 180 $X=735940 $Y=683940
X2522 586 3276 1 2 3539 QDBHN $T=813440 689360 0 0 $X=813440 $Y=688980
X2523 3810 3800 1 2 3786 QDBHN $T=913260 598640 0 180 $X=905820 $Y=593220
X2524 3810 3844 1 2 3853 QDBHN $T=929380 608720 0 180 $X=921940 $Y=603300
X2525 3810 3877 1 2 3861 QDBHN $T=933720 628880 0 180 $X=926280 $Y=623460
X2526 3810 3902 1 2 3926 QDBHN $T=931860 548240 0 0 $X=931860 $Y=547860
X2527 3810 3851 1 2 3886 QDBHN $T=939300 618800 0 180 $X=931860 $Y=613380
X2528 753 730 1 2 3944 QDBHN $T=941160 598640 0 0 $X=941160 $Y=598260
X2529 3810 3905 1 2 3936 QDBHN $T=950460 568400 0 180 $X=943020 $Y=562980
X2530 753 719 1 2 3939 QDBHN $T=944260 618800 0 0 $X=944260 $Y=618420
X2531 3810 3978 1 2 3982 QDBHN $T=965340 638960 0 180 $X=957900 $Y=633540
X2532 3810 4038 1 2 4019 QDBHN $T=966580 548240 0 180 $X=959140 $Y=542820
X2533 753 716 1 2 4065 QDBHN $T=964720 608720 0 0 $X=964720 $Y=608340
X2534 753 713 1 2 810 QDBHN $T=966580 588560 0 0 $X=966580 $Y=588180
X2535 3810 3964 1 2 4053 QDBHN $T=975260 618800 0 180 $X=967820 $Y=613380
X2536 3810 4088 1 2 4076 QDBHN $T=981460 608720 0 180 $X=974020 $Y=603300
X2537 3810 4083 1 2 4089 QDBHN $T=974020 638960 0 0 $X=974020 $Y=638580
X2538 3810 4109 1 2 4099 QDBHN $T=992000 608720 0 180 $X=984560 $Y=603300
X2539 3810 4141 1 2 4128 QDBHN $T=1006260 628880 1 180 $X=998820 $Y=628500
X2540 3810 4174 1 2 4154 QDBHN $T=1006880 618800 0 0 $X=1006880 $Y=618420
X2541 3810 4182 1 2 4168 QDBHN $T=1009980 558320 0 0 $X=1009980 $Y=557940
X2542 3810 4220 1 2 4167 QDBHN $T=1025480 628880 0 180 $X=1018040 $Y=623460
X2543 1322 1 2 1392 DELC $T=316820 618800 0 0 $X=316820 $Y=618420
X2544 1449 1 2 1465 DELC $T=344100 618800 1 0 $X=344100 $Y=613380
X2545 1544 1 2 1572 DELC $T=364560 638960 1 0 $X=364560 $Y=633540
X2546 1688 1 2 1730 DELC $T=404240 628880 0 0 $X=404240 $Y=628500
X2547 1714 1 2 1735 DELC $T=404860 608720 1 0 $X=404860 $Y=603300
X2548 1758 1 2 1786 DELC $T=419120 649040 1 0 $X=419120 $Y=643620
X2549 1766 1 2 1775 DELC $T=420360 578480 0 0 $X=420360 $Y=578100
X2550 1770 1 2 1787 DELC $T=420980 588560 0 0 $X=420980 $Y=588180
X2551 1693 1 2 1781 DELC $T=422220 618800 1 0 $X=422220 $Y=613380
X2552 1776 1 2 1794 DELC $T=422840 558320 0 0 $X=422840 $Y=557940
X2553 1777 1 2 1774 DELC $T=423460 578480 1 0 $X=423460 $Y=573060
X2554 1771 1 2 1828 DELC $T=432140 628880 1 0 $X=432140 $Y=623460
X2555 208 1 2 1811 DELC $T=432760 538160 1 0 $X=432760 $Y=532740
X2556 216 1 2 1845 DELC $T=438340 538160 1 0 $X=438340 $Y=532740
X2557 1831 1 2 1869 DELC $T=442060 588560 0 0 $X=442060 $Y=588180
X2558 1851 1 2 1885 DELC $T=442680 568400 1 0 $X=442680 $Y=562980
X2559 226 1 2 1861 DELC $T=444540 568400 0 0 $X=444540 $Y=568020
X2560 1822 1 2 1944 DELC $T=455080 558320 0 0 $X=455080 $Y=557940
X2561 1922 1 2 1860 DELC $T=455700 578480 0 0 $X=455700 $Y=578100
X2562 249 1 2 1934 DELC $T=461900 558320 0 0 $X=461900 $Y=557940
X2563 1837 1 2 1981 DELC $T=463140 548240 1 0 $X=463140 $Y=542820
X2564 1993 1 2 2004 DELC $T=470580 618800 1 0 $X=470580 $Y=613380
X2565 1996 1 2 2018 DELC $T=471200 649040 1 0 $X=471200 $Y=643620
X2566 269 1 2 1987 DELC $T=471820 558320 1 0 $X=471820 $Y=552900
X2567 1858 1 2 2036 DELC $T=474920 669200 0 0 $X=474920 $Y=668820
X2568 1767 1 2 2007 DELC $T=475540 598640 1 0 $X=475540 $Y=593220
X2569 2021 1 2 2078 DELC $T=481740 628880 1 0 $X=481740 $Y=623460
X2570 1936 1 2 2079 DELC $T=481740 638960 0 0 $X=481740 $Y=638580
X2571 285 1 2 2048 DELC $T=488560 588560 0 0 $X=488560 $Y=588180
X2572 1873 1 2 2104 DELC $T=490420 638960 0 0 $X=490420 $Y=638580
X2573 2085 1 2 2106 DELC $T=491040 628880 1 0 $X=491040 $Y=623460
X2574 291 1 2 2095 DELC $T=497240 578480 0 0 $X=497240 $Y=578100
X2575 2140 1 2 2151 DELC $T=500340 618800 1 0 $X=500340 $Y=613380
X2576 1969 1 2 2207 DELC $T=512120 649040 0 0 $X=512120 $Y=648660
X2577 1990 1 2 2174 DELC $T=515840 618800 1 0 $X=515840 $Y=613380
X2578 2047 1 2 2180 DELC $T=516460 628880 1 0 $X=516460 $Y=623460
X2579 2289 1 2 2312 DELC $T=529480 618800 0 0 $X=529480 $Y=618420
X2580 2306 1 2 2327 DELC $T=533820 608720 0 0 $X=533820 $Y=608340
X2581 2328 1 2 2324 DELC $T=538160 618800 1 0 $X=538160 $Y=613380
X2582 2367 1 2 2278 DELC $T=549320 598640 0 0 $X=549320 $Y=598260
X2583 2374 1 2 2383 DELC $T=550560 618800 1 0 $X=550560 $Y=613380
X2584 2386 1 2 2376 DELC $T=551800 638960 0 0 $X=551800 $Y=638580
X2585 2399 1 2 2357 DELC $T=556140 588560 1 0 $X=556140 $Y=583140
X2586 2353 1 2 2440 DELC $T=559860 618800 1 0 $X=559860 $Y=613380
X2587 1879 1 2 2554 DELC $T=580940 649040 0 0 $X=580940 $Y=648660
X2588 2527 1 2 2550 DELC $T=582800 618800 0 0 $X=582800 $Y=618420
X2589 2594 1 2 2596 DELC $T=597060 618800 1 0 $X=597060 $Y=613380
X2590 2601 1 2 2619 DELC $T=597680 598640 0 0 $X=597680 $Y=598260
X2591 1882 1 2 2616 DELC $T=601400 638960 0 0 $X=601400 $Y=638580
X2592 2585 1 2 2577 DELC $T=610080 638960 1 0 $X=610080 $Y=633540
X2593 1937 1 2 2696 DELC $T=619380 659120 0 0 $X=619380 $Y=658740
X2594 2694 1 2 2710 DELC $T=621860 608720 0 0 $X=621860 $Y=608340
X2595 2686 1 2 2714 DELC $T=626200 638960 1 0 $X=626200 $Y=633540
X2596 2743 1 2 2732 DELC $T=638600 608720 1 0 $X=638600 $Y=603300
X2597 474 1 2 2770 DELC $T=644180 618800 1 0 $X=644180 $Y=613380
X2598 2781 1 2 2788 DELC $T=647280 578480 0 0 $X=647280 $Y=578100
X2599 2785 1 2 2764 DELC $T=648520 538160 0 0 $X=648520 $Y=537780
X2600 2794 1 2 2808 DELC $T=650380 558320 1 0 $X=650380 $Y=552900
X2601 2801 1 2 2793 DELC $T=650380 588560 0 0 $X=650380 $Y=588180
X2602 2807 1 2 2802 DELC $T=652240 659120 1 0 $X=652240 $Y=653700
X2603 2773 1 2 2786 DELC $T=652860 598640 1 0 $X=652860 $Y=593220
X2604 485 1 2 2809 DELC $T=653480 638960 1 0 $X=653480 $Y=633540
X2605 486 1 2 2806 DELC $T=655340 568400 0 0 $X=655340 $Y=568020
X2606 2766 1 2 2827 DELC $T=655340 618800 0 0 $X=655340 $Y=618420
X2607 2839 1 2 2868 DELC $T=659060 638960 1 0 $X=659060 $Y=633540
X2608 497 1 2 2847 DELC $T=660300 548240 0 0 $X=660300 $Y=547860
X2609 494 1 2 503 DELC $T=660300 679280 1 0 $X=660300 $Y=673860
X2610 501 1 2 2877 DELC $T=660920 578480 0 0 $X=660920 $Y=578100
X2611 498 1 2 2861 DELC $T=662780 598640 0 0 $X=662780 $Y=598260
X2612 2775 1 2 2738 DELC $T=664640 598640 1 0 $X=664640 $Y=593220
X2613 506 1 2 2894 DELC $T=665260 689360 1 0 $X=665260 $Y=683940
X2614 2886 1 2 2897 DELC $T=667120 669200 1 0 $X=667120 $Y=663780
X2615 493 1 2 2771 DELC $T=667740 618800 1 0 $X=667740 $Y=613380
X2616 2888 1 2 2887 DELC $T=667740 628880 0 0 $X=667740 $Y=628500
X2617 488 1 2 2811 DELC $T=668980 568400 1 0 $X=668980 $Y=562980
X2618 2919 1 2 527 DELC $T=674560 628880 0 0 $X=674560 $Y=628500
X2619 2928 1 2 2946 DELC $T=677040 638960 1 0 $X=677040 $Y=633540
X2620 2929 1 2 2931 DELC $T=677040 679280 1 0 $X=677040 $Y=673860
X2621 2921 1 2 2880 DELC $T=678900 679280 0 0 $X=678900 $Y=678900
X2622 2964 1 2 2990 DELC $T=685100 689360 0 0 $X=685100 $Y=688980
X2623 2889 1 2 2952 DELC $T=689440 659120 0 0 $X=689440 $Y=658740
X2624 2989 1 2 2971 DELC $T=691300 649040 0 0 $X=691300 $Y=648660
X2625 3024 1 2 3022 DELC $T=701220 628880 0 0 $X=701220 $Y=628500
X2626 3051 1 2 3059 DELC $T=708040 649040 0 0 $X=708040 $Y=648660
X2627 3068 1 2 3086 DELC $T=711760 598640 0 0 $X=711760 $Y=598260
X2628 3069 1 2 3053 DELC $T=711760 659120 1 0 $X=711760 $Y=653700
X2629 3104 1 2 3108 DELC $T=721060 628880 0 0 $X=721060 $Y=628500
X2630 3131 1 2 3152 DELC $T=724780 689360 1 0 $X=724780 $Y=683940
X2631 3085 1 2 3126 DELC $T=726020 608720 1 0 $X=726020 $Y=603300
X2632 3124 1 2 3072 DELC $T=734700 628880 1 0 $X=734700 $Y=623460
X2633 3169 1 2 3173 DELC $T=737800 608720 1 0 $X=737800 $Y=603300
X2634 3179 1 2 3190 DELC $T=738420 659120 1 0 $X=738420 $Y=653700
X2635 3196 1 2 591 DELC $T=742140 638960 0 0 $X=742140 $Y=638580
X2636 3230 1 2 3263 DELC $T=757020 659120 0 0 $X=757020 $Y=658740
X2637 3242 1 2 3258 DELC $T=758260 638960 1 0 $X=758260 $Y=633540
X2638 3339 1 2 3347 DELC $T=779960 679280 1 0 $X=779960 $Y=673860
X2639 3358 1 2 641 DELC $T=788020 689360 1 0 $X=788020 $Y=683940
X2640 3400 1 2 652 DELC $T=795460 679280 0 0 $X=795460 $Y=678900
X2641 3480 1 2 3489 DELC $T=807860 659120 0 0 $X=807860 $Y=658740
X2642 3506 1 2 3287 DELC $T=819020 649040 1 0 $X=819020 $Y=643620
X2643 3539 1 2 654 DELC $T=820260 689360 1 0 $X=820260 $Y=683940
X2644 3536 1 2 663 DELC $T=826460 689360 0 0 $X=826460 $Y=688980
X2645 3582 1 2 668 DELC $T=836380 679280 0 0 $X=836380 $Y=678900
X2646 3687 1 2 3635 DELC $T=859940 659120 1 0 $X=859940 $Y=653700
X2647 3709 1 2 3717 DELC $T=863040 679280 1 0 $X=863040 $Y=673860
X2648 3706 1 2 3726 DELC $T=869240 669200 1 0 $X=869240 $Y=663780
X2649 3786 1 2 3827 DELC $T=916360 588560 0 0 $X=916360 $Y=588180
X2650 3861 1 2 3863 DELC $T=926280 618800 1 0 $X=926280 $Y=613380
X2651 3886 1 2 3920 DELC $T=937440 608720 1 0 $X=937440 $Y=603300
X2652 3926 1 2 3919 DELC $T=939300 548240 0 0 $X=939300 $Y=547860
X2653 3853 1 2 3946 DELC $T=943020 608720 1 0 $X=943020 $Y=603300
X2654 3936 1 2 3963 DELC $T=950460 568400 1 0 $X=950460 $Y=562980
X2655 3982 1 2 3995 DELC $T=952940 638960 1 0 $X=952940 $Y=633540
X2656 4019 1 2 3998 DELC $T=966580 548240 1 0 $X=966580 $Y=542820
X2657 4053 1 2 3948 DELC $T=977120 618800 1 0 $X=977120 $Y=613380
X2658 4076 1 2 4072 DELC $T=978360 628880 1 0 $X=978360 $Y=623460
X2659 4089 1 2 4077 DELC $T=988280 649040 1 0 $X=988280 $Y=643620
X2660 4099 1 2 4108 DELC $T=990140 618800 1 0 $X=990140 $Y=613380
X2661 4128 1 2 4126 DELC $T=995720 638960 0 0 $X=995720 $Y=638580
X2662 4154 1 2 4149 DELC $T=1005640 608720 0 0 $X=1005640 $Y=608340
X2663 4167 1 2 4175 DELC $T=1007500 638960 0 0 $X=1007500 $Y=638580
X2664 4168 1 2 4184 DELC $T=1008120 568400 1 0 $X=1008120 $Y=562980
X2665 1917 1 2 200 INV3CK $T=453840 528080 0 0 $X=453840 $Y=527700
X2666 1883 1 2 1790 INV3CK $T=460660 578480 0 0 $X=460660 $Y=578100
X2667 2783 1 2 2784 INV3CK $T=658440 679280 0 180 $X=655340 $Y=673860
X2668 2870 1 2 2855 INV3CK $T=664640 669200 0 180 $X=661540 $Y=663780
X2669 523 1 2 525 INV3CK $T=677040 689360 0 0 $X=677040 $Y=688980
X2670 3817 1 2 3812 INV3CK $T=914500 608720 0 180 $X=911400 $Y=603300
X2671 3840 1 2 3841 INV3CK $T=920700 588560 0 180 $X=917600 $Y=583140
X2672 3854 1 2 3791 INV3CK $T=922560 618800 0 180 $X=919460 $Y=613380
X2673 3923 1 2 3915 INV3CK $T=937440 628880 0 0 $X=937440 $Y=628500
X2674 3933 1 2 3792 INV3CK $T=943640 578480 0 180 $X=940540 $Y=573060
X2675 3972 1 2 3980 INV3CK $T=954180 608720 0 180 $X=951080 $Y=603300
X2676 4040 1 2 4035 INV3CK $T=964100 618800 0 180 $X=961000 $Y=613380
X2677 3938 1 2 3968 INV3CK $T=967820 568400 0 180 $X=964720 $Y=562980
X2678 4084 1 2 4085 INV3CK $T=978360 598640 0 180 $X=975260 $Y=593220
X2679 4101 1 2 4105 INV3CK $T=985180 638960 0 0 $X=985180 $Y=638580
X2680 4139 1 2 4143 INV3CK $T=1003160 578480 0 0 $X=1003160 $Y=578100
X2681 4186 1 2 4211 INV3CK $T=1021140 618800 0 180 $X=1018040 $Y=613380
X2682 1860 225 1883 1 2 AN2T $T=442680 578480 0 0 $X=442680 $Y=578100
X2683 261 250 1947 1 2 AN2T $T=463140 528080 0 180 $X=458800 $Y=522660
X2684 2004 2009 1814 1 2 AN2T $T=471820 618800 0 0 $X=471820 $Y=618420
X2685 2778 410 2729 1 2 AN2T $T=646660 689360 0 180 $X=642320 $Y=683940
X2686 2802 410 2783 1 2 AN2T $T=651000 659120 0 180 $X=646660 $Y=653700
X2687 2897 410 2870 1 2 AN2T $T=667740 659120 0 180 $X=663400 $Y=653700
X2688 2990 410 549 1 2 AN2T $T=694400 689360 0 0 $X=694400 $Y=688980
X2689 654 586 3454 1 2 AN2T $T=805380 689360 0 0 $X=805380 $Y=688980
X2690 3827 3810 3840 1 2 AN2T $T=916980 598640 1 0 $X=916980 $Y=593220
X2691 3863 3810 3817 1 2 AN2T $T=927520 598640 0 180 $X=923180 $Y=593220
X2692 3919 3810 3899 1 2 AN2T $T=937440 558320 1 180 $X=933100 $Y=557940
X2693 3920 3810 3854 1 2 AN2T $T=937440 608720 0 180 $X=933100 $Y=603300
X2694 3946 3810 3933 1 2 AN2T $T=944260 598640 0 180 $X=939920 $Y=593220
X2695 3963 3810 3938 1 2 AN2T $T=947360 558320 0 180 $X=943020 $Y=552900
X2696 3948 3810 3923 1 2 AN2T $T=947360 618800 0 180 $X=943020 $Y=613380
X2697 3998 3810 3970 1 2 AN2T $T=955420 548240 0 180 $X=951080 $Y=542820
X2698 3995 3810 3972 1 2 AN2T $T=955420 628880 0 180 $X=951080 $Y=623460
X2699 4072 3810 4040 1 2 AN2T $T=972160 628880 0 180 $X=967820 $Y=623460
X2700 4077 3810 4084 1 2 AN2T $T=974020 628880 1 0 $X=974020 $Y=623460
X2701 4108 3810 4101 1 2 AN2T $T=988900 618800 0 180 $X=984560 $Y=613380
X2702 4126 3810 4120 1 2 AN2T $T=995100 628880 0 180 $X=990760 $Y=623460
X2703 4149 3810 4134 1 2 AN2T $T=1003160 618800 1 180 $X=998820 $Y=618420
X2704 4184 3810 4139 1 2 AN2T $T=1014320 568400 1 180 $X=1009980 $Y=568020
X2705 4175 3810 4186 1 2 AN2T $T=1009980 628880 0 0 $X=1009980 $Y=628500
X2706 330 257 1 2 INV8CK $T=515840 618800 0 180 $X=509020 $Y=613380
X2707 2784 193 1 2 INV8CK $T=648520 679280 0 180 $X=641700 $Y=673860
X2708 586 585 1 2 INV8CK $T=737800 608720 0 180 $X=730980 $Y=603300
X2709 796 3810 1 2 INV8CK $T=957900 558320 0 180 $X=951080 $Y=552900
X2710 2867 1843 2866 2879 2801 2803 1 2 2892 AO222 $T=663400 588560 0 0 $X=663400 $Y=588180
X2711 2996 1843 2984 3016 2946 3021 1 2 3048 AO222 $T=696260 649040 0 0 $X=696260 $Y=648660
X2712 3750 763 764 3754 3732 766 1 2 3762 AO222 $T=889080 679280 1 0 $X=889080 $Y=673860
X2713 3751 763 764 3747 3757 766 1 2 3761 AO222 $T=890320 659120 1 0 $X=890320 $Y=653700
X2714 3758 763 764 3748 3774 766 1 2 3782 AO222 $T=898380 528080 0 0 $X=898380 $Y=527700
X2715 3765 763 764 3764 3760 766 1 2 3780 AO222 $T=898380 558320 1 0 $X=898380 $Y=552900
X2716 3785 763 764 3773 3769 766 1 2 3766 AO222 $T=904580 679280 0 180 $X=898380 $Y=673860
X2717 3778 763 764 3770 3795 766 1 2 3804 AO222 $T=905200 608720 1 0 $X=905200 $Y=603300
X2718 3781 763 764 3755 3752 766 1 2 3807 AO222 $T=905200 628880 1 0 $X=905200 $Y=623460
X2719 3783 763 764 3794 3799 766 1 2 3808 AO222 $T=906440 558320 1 0 $X=906440 $Y=552900
X2720 3809 763 764 3798 769 766 1 2 3787 AO222 $T=913260 528080 0 180 $X=907060 $Y=522660
X2721 3788 763 764 3797 3803 766 1 2 3818 AO222 $T=907060 679280 1 0 $X=907060 $Y=673860
X2722 3759 763 764 3790 3779 766 1 2 3811 AO222 $T=907680 588560 0 0 $X=907680 $Y=588180
X2723 3776 763 764 3805 3775 766 1 2 3819 AO222 $T=908920 578480 1 0 $X=908920 $Y=573060
X2724 3793 763 764 3744 3771 766 1 2 3832 AO222 $T=912020 659120 1 0 $X=912020 $Y=653700
X2725 3806 763 764 3767 3825 766 1 2 3842 AO222 $T=913260 538160 0 0 $X=913260 $Y=537780
X2726 3784 763 764 3777 3826 766 1 2 3839 AO222 $T=913260 628880 1 0 $X=913260 $Y=623460
X2727 3801 763 764 3768 3831 766 1 2 3848 AO222 $T=913880 638960 1 0 $X=913880 $Y=633540
X2728 3820 763 764 3789 3796 766 1 2 3846 AO222 $T=915120 578480 1 0 $X=915120 $Y=573060
X2729 3816 763 764 3772 3815 766 1 2 3858 AO222 $T=915740 649040 1 0 $X=915740 $Y=643620
X2730 1322 113 1282 1 2 AN2P $T=323640 598640 1 180 $X=319920 $Y=598260
X2731 993 1005 991 2 1 ND2S $T=243660 628880 1 180 $X=241800 $Y=628500
X2732 995 999 992 2 1 ND2S $T=244280 598640 0 180 $X=242420 $Y=593220
X2733 1059 1053 1047 2 1 ND2S $T=257300 578480 1 180 $X=255440 $Y=578100
X2734 1163 1088 1157 2 1 ND2S $T=275900 628880 0 0 $X=275900 $Y=628500
X2735 1320 1312 1321 2 1 ND2S $T=313720 578480 1 0 $X=313720 $Y=573060
X2736 1327 1331 977 2 1 ND2S $T=316820 669200 0 180 $X=314960 $Y=663780
X2737 1187 1371 1364 2 1 ND2S $T=325500 598640 0 0 $X=325500 $Y=598260
X2738 1483 1469 1487 2 1 ND2S $T=350920 649040 0 0 $X=350920 $Y=648660
X2739 1501 1476 1488 2 1 ND2S $T=355260 628880 0 0 $X=355260 $Y=628500
X2740 1595 1585 1588 2 1 ND2S $T=375100 568400 0 0 $X=375100 $Y=568020
X2741 1592 1624 1607 2 1 ND2S $T=378200 568400 0 180 $X=376340 $Y=562980
X2742 1281 1641 1668 2 1 ND2S $T=385020 558320 1 0 $X=385020 $Y=552900
X2743 187 185 183 2 1 ND2S $T=413540 628880 1 180 $X=411680 $Y=628500
X2744 1572 1933 167 2 1 ND2S $T=458800 618800 0 0 $X=458800 $Y=618420
X2745 2087 1889 1939 2 1 ND2S $T=491660 578480 1 180 $X=489800 $Y=578100
X2746 2123 2155 2092 2 1 ND2S $T=502820 568400 0 180 $X=500960 $Y=562980
X2747 2239 2225 2235 2 1 ND2S $T=515840 548240 1 0 $X=515840 $Y=542820
X2748 2172 2330 2316 2 1 ND2S $T=541260 548240 1 180 $X=539400 $Y=547860
X2749 2404 2498 2087 2 1 ND2S $T=575980 608720 1 180 $X=574120 $Y=608340
X2750 2509 405 2507 2 1 ND2S $T=584040 528080 1 0 $X=584040 $Y=522660
X2751 2087 2804 2848 2 1 ND2S $T=659060 578480 0 0 $X=659060 $Y=578100
X2752 2087 2992 2959 2 1 ND2S $T=694400 649040 0 180 $X=692540 $Y=643620
X2753 3065 3077 3061 2 1 ND2S $T=713620 538160 0 0 $X=713620 $Y=537780
X2754 596 534 3013 2 1 ND2S $T=750200 669200 1 180 $X=748340 $Y=668820
X2755 3245 3251 3241 2 1 ND2S $T=755780 608720 0 180 $X=753920 $Y=603300
X2756 3371 3365 3362 2 1 ND2S $T=788020 659120 1 0 $X=788020 $Y=653700
X2757 3364 3373 3397 2 1 ND2S $T=791740 598640 0 0 $X=791740 $Y=598260
X2758 3439 3452 3488 2 1 ND2S $T=807240 649040 1 0 $X=807240 $Y=643620
X2759 689 3606 596 2 1 ND2S $T=836380 679280 0 180 $X=834520 $Y=673860
X2760 3288 2 1 112 BUF3 $T=757640 669200 0 180 $X=753920 $Y=663780
X2761 3315 2 1 625 BUF3 $T=779960 649040 1 0 $X=779960 $Y=643620
X2762 3670 2 1 3716 BUF3 $T=864280 638960 0 0 $X=864280 $Y=638580
X2763 3671 2 1 3719 BUF3 $T=868000 638960 0 0 $X=868000 $Y=638580
X2764 3383 1 692 3664 3661 3689 2 OAI22S $T=850020 679280 1 0 $X=850020 $Y=673860
X2765 3648 1 3563 3660 3708 3465 2 OAI22S $T=859940 598640 0 0 $X=859940 $Y=598260
X2766 3642 1 3563 3653 726 3465 2 OAI22S $T=868000 598640 1 180 $X=864280 $Y=598260
X2767 3642 1 3607 3653 732 3640 2 OAI22S $T=866140 608720 1 0 $X=866140 $Y=603300
X2768 3648 1 3607 3660 3723 3640 2 OAI22S $T=866760 608720 0 0 $X=866760 $Y=608340
X2769 3642 1 3656 3653 737 3627 2 OAI22S $T=868620 598640 0 0 $X=868620 $Y=598260
X2770 3642 1 3634 3653 742 3630 2 OAI22S $T=870480 608720 1 0 $X=870480 $Y=603300
X2771 3648 1 3656 3660 3728 3627 2 OAI22S $T=877300 598640 1 180 $X=873580 $Y=598260
X2772 3648 1 3634 3660 3731 3630 2 OAI22S $T=878540 608720 0 180 $X=874820 $Y=603300
X2773 1318 1 2 1340 DELB $T=314960 598640 0 0 $X=314960 $Y=598260
X2774 1357 1 2 1412 DELB $T=332320 618800 0 0 $X=332320 $Y=618420
X2775 1444 1 2 1443 DELB $T=347820 608720 0 0 $X=347820 $Y=608340
X2776 1441 1 2 1455 DELB $T=347820 638960 1 0 $X=347820 $Y=633540
X2777 1460 1 2 1474 DELB $T=348440 588560 1 0 $X=348440 $Y=583140
X2778 1676 1 2 1692 DELB $T=391840 598640 1 0 $X=391840 $Y=593220
X2779 1709 1 2 1729 DELB $T=404240 568400 1 0 $X=404240 $Y=562980
X2780 1722 1 2 1699 DELB $T=407340 568400 0 0 $X=407340 $Y=568020
X2781 1733 1 2 1743 DELB $T=412920 578480 1 0 $X=412920 $Y=573060
X2782 1748 1 2 1750 DELB $T=414160 548240 1 0 $X=414160 $Y=542820
X2783 1756 1 2 1765 DELB $T=416640 538160 1 0 $X=416640 $Y=532740
X2784 1757 1 2 1761 DELB $T=418500 578480 1 0 $X=418500 $Y=573060
X2785 1728 1 2 1782 DELB $T=419740 669200 0 0 $X=419740 $Y=668820
X2786 1779 1 2 1778 DELB $T=424080 538160 1 0 $X=424080 $Y=532740
X2787 1783 1 2 1813 DELB $T=425320 638960 1 0 $X=425320 $Y=633540
X2788 1791 1 2 1805 DELB $T=425940 649040 1 0 $X=425940 $Y=643620
X2789 1760 1 2 1802 DELB $T=427180 669200 0 0 $X=427180 $Y=668820
X2790 1810 1 2 1806 DELB $T=432140 669200 1 0 $X=432140 $Y=663780
X2791 1803 1 2 1818 DELB $T=437100 638960 0 0 $X=437100 $Y=638580
X2792 1840 1 2 224 DELB $T=438960 669200 1 0 $X=438960 $Y=663780
X2793 1870 1 2 1886 DELB $T=447640 638960 0 0 $X=447640 $Y=638580
X2794 1833 1 2 1921 DELB $T=450120 628880 1 0 $X=450120 $Y=623460
X2795 1912 1 2 1913 DELB $T=452600 669200 1 0 $X=452600 $Y=663780
X2796 1928 1 2 1940 DELB $T=456940 588560 0 0 $X=456940 $Y=588180
X2797 1989 1 2 1986 DELB $T=469340 588560 0 0 $X=469340 $Y=588180
X2798 1834 1 2 2041 DELB $T=477400 649040 1 0 $X=477400 $Y=643620
X2799 2013 1 2 279 DELB $T=479880 669200 0 0 $X=479880 $Y=668820
X2800 2091 1 2 2121 DELB $T=492280 669200 1 0 $X=492280 $Y=663780
X2801 2177 1 2 2197 DELB $T=506540 638960 1 0 $X=506540 $Y=633540
X2802 2195 1 2 2219 DELB $T=510260 588560 1 0 $X=510260 $Y=583140
X2803 2255 1 2 2279 DELB $T=521420 628880 1 0 $X=521420 $Y=623460
X2804 2258 1 2 2263 DELB $T=526380 679280 1 0 $X=526380 $Y=673860
X2805 2300 1 2 2302 DELB $T=530720 649040 0 0 $X=530720 $Y=648660
X2806 2339 1 2 2355 DELB $T=541880 649040 0 0 $X=541880 $Y=648660
X2807 2405 1 2 2427 DELB $T=557380 578480 1 0 $X=557380 $Y=573060
X2808 2411 1 2 2436 DELB $T=558620 649040 0 0 $X=558620 $Y=648660
X2809 2483 1 2 2448 DELB $T=573500 568400 0 0 $X=573500 $Y=568020
X2810 2485 1 2 2464 DELB $T=574120 618800 0 0 $X=574120 $Y=618420
X2811 2512 1 2 2551 DELB $T=579700 608720 0 0 $X=579700 $Y=608340
X2812 2515 1 2 2529 DELB $T=580940 588560 1 0 $X=580940 $Y=583140
X2813 2555 1 2 2548 DELB $T=588380 649040 1 0 $X=588380 $Y=643620
X2814 2564 1 2 2582 DELB $T=590240 588560 0 0 $X=590240 $Y=588180
X2815 2570 1 2 2590 DELB $T=592100 618800 1 0 $X=592100 $Y=613380
X2816 2578 1 2 2605 DELB $T=595200 649040 0 0 $X=595200 $Y=648660
X2817 2597 1 2 2609 DELB $T=599540 588560 0 0 $X=599540 $Y=588180
X2818 2591 1 2 2419 DELB $T=606360 638960 0 0 $X=606360 $Y=638580
X2819 2646 1 2 2665 DELB $T=609460 568400 1 0 $X=609460 $Y=562980
X2820 2621 1 2 2634 DELB $T=611320 679280 0 0 $X=611320 $Y=678900
X2821 2658 1 2 2679 DELB $T=611940 568400 0 0 $X=611940 $Y=568020
X2822 2667 1 2 2654 DELB $T=614420 669200 1 0 $X=614420 $Y=663780
X2823 2669 1 2 2645 DELB $T=620000 588560 0 0 $X=620000 $Y=588180
X2824 2690 1 2 325 DELB $T=620620 679280 1 0 $X=620620 $Y=673860
X2825 2700 1 2 2687 DELB $T=624340 578480 1 0 $X=624340 $Y=573060
X2826 2706 1 2 2684 DELB $T=625580 659120 0 0 $X=625580 $Y=658740
X2827 2675 1 2 2716 DELB $T=631160 638960 1 0 $X=631160 $Y=633540
X2828 2692 1 2 2746 DELB $T=631780 638960 0 0 $X=631780 $Y=638580
X2829 2739 1 2 2751 DELB $T=632400 598640 0 0 $X=632400 $Y=598260
X2830 2724 1 2 2693 DELB $T=633640 679280 1 0 $X=633640 $Y=673860
X2831 2752 1 2 2747 DELB $T=637980 548240 1 0 $X=637980 $Y=542820
X2832 2703 1 2 2787 DELB $T=648520 628880 0 0 $X=648520 $Y=628500
X2833 2689 1 2 2816 DELB $T=654100 669200 1 0 $X=654100 $Y=663780
X2834 489 1 2 2819 DELB $T=655960 538160 1 0 $X=655960 $Y=532740
X2835 2865 1 2 2885 DELB $T=662780 628880 0 0 $X=662780 $Y=628500
X2836 504 1 2 2823 DELB $T=665260 548240 0 0 $X=665260 $Y=547860
X2837 505 1 2 511 DELB $T=665260 679280 1 0 $X=665260 $Y=673860
X2838 2916 1 2 2914 DELB $T=674560 638960 0 0 $X=674560 $Y=638580
X2839 2930 1 2 2933 DELB $T=678900 598640 1 0 $X=678900 $Y=593220
X2840 530 1 2 536 DELB $T=680140 689360 0 0 $X=680140 $Y=688980
X2841 2945 1 2 2967 DELB $T=681380 598640 0 0 $X=681380 $Y=598260
X2842 2947 1 2 2939 DELB $T=682000 638960 1 0 $X=682000 $Y=633540
X2843 2987 1 2 3003 DELB $T=689440 638960 1 0 $X=689440 $Y=633540
X2844 2991 1 2 3004 DELB $T=695020 628880 0 0 $X=695020 $Y=628500
X2845 265 1 2 3028 DELB $T=704320 598640 0 0 $X=704320 $Y=598260
X2846 3015 1 2 3023 DELB $T=706180 628880 0 0 $X=706180 $Y=628500
X2847 3188 1 2 3142 DELB $T=740900 628880 0 0 $X=740900 $Y=628500
X2848 3296 1 2 3167 DELB $T=768180 628880 1 0 $X=768180 $Y=623460
X2849 3371 1 2 3398 DELB $T=790500 659120 0 0 $X=790500 $Y=658740
X2850 3550 1 2 3518 DELB $T=822120 659120 0 0 $X=822120 $Y=658740
X2851 3581 1 2 3553 DELB $T=831420 638960 0 0 $X=831420 $Y=638580
X2852 3496 1 2 3475 DELB $T=831420 689360 0 0 $X=831420 $Y=688980
X2853 3619 1 2 3622 DELB $T=840720 618800 0 0 $X=840720 $Y=618420
X2854 3626 1 2 3631 DELB $T=840720 649040 1 0 $X=840720 $Y=643620
X2855 3503 1 2 3484 DELB $T=841340 689360 1 0 $X=841340 $Y=683940
X2856 3652 1 2 3646 DELB $T=845060 679280 1 0 $X=845060 $Y=673860
X2857 3850 1 2 3753 DELB $T=921320 608720 0 0 $X=921320 $Y=608340
X2858 774 1 2 3734 DELB $T=926900 548240 1 0 $X=926900 $Y=542820
X2859 3943 1 2 3735 DELB $T=944880 528080 1 0 $X=944880 $Y=522660
X2860 3969 1 2 4001 DELB $T=951700 618800 1 0 $X=951700 $Y=613380
X2861 3979 1 2 3986 DELB $T=952940 669200 0 0 $X=952940 $Y=668820
X2862 3985 1 2 3958 DELB $T=953560 649040 1 0 $X=953560 $Y=643620
X2863 3991 1 2 797 DELB $T=954800 608720 1 0 $X=954800 $Y=603300
X2864 3973 1 2 3742 DELB $T=959140 578480 1 0 $X=959140 $Y=573060
X2865 4010 1 2 3996 DELB $T=959140 588560 1 0 $X=959140 $Y=583140
X2866 4023 1 2 3997 DELB $T=959760 649040 1 0 $X=959760 $Y=643620
X2867 4029 1 2 4044 DELB $T=960380 628880 1 0 $X=960380 $Y=623460
X2868 4028 1 2 3727 DELB $T=965340 528080 1 0 $X=965340 $Y=522660
X2869 4049 1 2 4032 DELB $T=965960 558320 1 0 $X=965960 $Y=552900
X2870 4050 1 2 808 DELB $T=967200 649040 1 0 $X=967200 $Y=643620
X2871 4036 1 2 4045 DELB $T=970300 669200 1 0 $X=970300 $Y=663780
X2872 4064 1 2 4037 DELB $T=971540 528080 1 0 $X=971540 $Y=522660
X2873 4024 1 2 3756 DELB $T=971540 548240 1 0 $X=971540 $Y=542820
X2874 4071 1 2 4031 DELB $T=973400 588560 1 0 $X=973400 $Y=583140
X2875 563 2211 1 2 BUF2CK $T=714860 618800 0 180 $X=711760 $Y=613380
X2876 3507 658 1 2 BUF2CK $T=814060 669200 1 180 $X=810960 $Y=668820
X2877 3509 666 1 2 BUF2CK $T=819020 628880 0 0 $X=819020 $Y=628500
X2878 3532 670 1 2 BUF2CK $T=820260 618800 0 0 $X=820260 $Y=618420
X2879 1693 1 2 1763 BUF1CK $T=418500 618800 1 0 $X=418500 $Y=613380
X2880 1990 1 2 2130 BUF1CK $T=496620 628880 1 0 $X=496620 $Y=623460
X2881 2457 1 2 387 BUF1CK $T=567920 679280 0 0 $X=567920 $Y=678900
X2882 2468 1 2 2472 BUF1CK $T=571020 659120 1 0 $X=571020 $Y=653700
X2883 3175 1 2 3229 BUF1CK $T=747100 628880 0 0 $X=747100 $Y=628500
X2884 3351 1 2 3232 BUF1CK $T=779960 608720 0 0 $X=779960 $Y=608340
X2885 3260 1 2 3448 BUF1CK $T=799180 638960 1 0 $X=799180 $Y=633540
X2886 3441 1 2 3430 BUF1CK $T=802280 638960 0 0 $X=802280 $Y=638580
X2887 3666 1 2 3679 BUF1CK $T=852500 638960 1 0 $X=852500 $Y=633540
X2888 3693 1 2 3704 BUF1CK $T=858700 649040 1 0 $X=858700 $Y=643620
X2889 3746 1 2 3721 BUF1CK $T=885980 689360 1 0 $X=885980 $Y=683940
X2890 302 297 298 296 295 294 2 1 2082 OA222S $T=496000 689360 1 180 $X=490420 $Y=688980
X2891 293 297 299 296 298 294 2 1 2113 OA222S $T=491660 689360 1 0 $X=491660 $Y=683940
X2892 309 308 302 305 293 304 2 1 2114 OA222S $T=502820 689360 1 180 $X=497240 $Y=688980
X2893 297 350 351 296 353 294 2 1 2303 OA222S $T=528860 679280 0 0 $X=528860 $Y=678900
X2894 297 352 353 296 355 294 2 1 2314 OA222S $T=529480 689360 0 0 $X=529480 $Y=688980
X2895 364 308 305 361 304 352 2 1 2315 OA222S $T=541880 689360 1 180 $X=536300 $Y=688980
X2896 1752 1808 1 1792 1930 1957 2 MOAI1S $T=458180 598640 0 0 $X=458180 $Y=598260
X2897 323 321 1 320 2184 2165 2 MOAI1S $T=510880 679280 0 180 $X=507160 $Y=673860
X2898 323 325 1 320 309 2166 2 MOAI1S $T=512740 679280 1 180 $X=509020 $Y=678900
X2899 2174 2157 1 2143 2205 2183 2 MOAI1S $T=516460 628880 0 180 $X=512740 $Y=623460
X2900 323 2206 1 320 2227 2231 2 MOAI1S $T=513360 679280 1 0 $X=513360 $Y=673860
X2901 341 339 1 336 2227 2242 2 MOAI1S $T=522660 689360 0 180 $X=518940 $Y=683940
X2902 323 2028 1 320 2136 2268 2 MOAI1S $T=520800 679280 1 0 $X=520800 $Y=673860
X2903 341 317 1 336 2136 2251 2 MOAI1S $T=523280 689360 1 0 $X=523280 $Y=683940
X2904 323 279 1 368 348 2348 2 MOAI1S $T=548700 689360 0 180 $X=544980 $Y=683940
X2905 323 241 1 368 364 2385 2 MOAI1S $T=555520 689360 1 180 $X=551800 $Y=688980
X2906 1853 3408 1 3401 3398 3399 2 MOAI1S $T=796700 659120 0 180 $X=792980 $Y=653700
X2907 2087 641 1 3465 3428 3476 2 MOAI1S $T=802900 628880 1 0 $X=802900 $Y=623460
X2908 3451 3453 1 3478 3481 3480 2 MOAI1S $T=805380 669200 1 0 $X=805380 $Y=663780
X2909 3468 3453 1 3478 3460 3496 2 MOAI1S $T=807240 679280 1 0 $X=807240 $Y=673860
X2910 655 3453 1 655 3495 3458 2 MOAI1S $T=808480 638960 0 0 $X=808480 $Y=638580
X2911 3515 555 1 2937 555 3491 2 MOAI1S $T=814060 608720 0 180 $X=810340 $Y=603300
X2912 3527 3453 1 3478 3508 3503 2 MOAI1S $T=815920 679280 0 180 $X=812200 $Y=673860
X2913 3550 3488 1 3488 3460 3507 2 MOAI1S $T=817160 669200 0 180 $X=813440 $Y=663780
X2914 3530 3488 1 3488 3520 3509 2 MOAI1S $T=817780 628880 1 180 $X=814060 $Y=628500
X2915 3521 3488 1 3488 3508 3532 2 MOAI1S $T=815300 628880 1 0 $X=815300 $Y=623460
X2916 3535 3453 1 3478 3520 3522 2 MOAI1S $T=819020 669200 1 180 $X=815300 $Y=668820
X2917 187 3521 1 3508 187 3547 2 MOAI1S $T=818400 618800 1 0 $X=818400 $Y=613380
X2918 187 3518 1 187 3460 3533 2 MOAI1S $T=823980 659120 0 180 $X=820260 $Y=653700
X2919 187 3530 1 3520 187 3552 2 MOAI1S $T=826460 628880 1 180 $X=822740 $Y=628500
X2920 3565 3453 1 183 3495 3581 2 MOAI1S $T=828320 649040 1 0 $X=828320 $Y=643620
X2921 3603 3453 1 3558 3495 3587 2 MOAI1S $T=835140 659120 0 180 $X=831420 $Y=653700
X2922 3593 3453 1 3600 3495 3619 2 MOAI1S $T=832660 649040 1 0 $X=832660 $Y=643620
X2923 3641 3453 1 3632 3495 3626 2 MOAI1S $T=843200 638960 1 180 $X=839480 $Y=638580
X2924 3676 3645 1 3644 3667 698 2 MOAI1S $T=854980 689360 0 180 $X=851260 $Y=683940
X2925 3672 3645 1 3644 3683 3687 2 MOAI1S $T=853120 659120 0 0 $X=853120 $Y=658740
X2926 692 3676 1 655 3673 3702 2 MOAI1S $T=856220 638960 0 0 $X=856220 $Y=638580
X2927 3710 3645 1 3644 3696 3706 2 MOAI1S $T=864900 659120 1 180 $X=861180 $Y=658740
X2928 3713 3645 1 3644 3699 3707 2 MOAI1S $T=865520 689360 0 180 $X=861800 $Y=683940
X2929 3722 3645 1 3644 3725 3709 2 MOAI1S $T=869860 679280 1 0 $X=869860 $Y=673860
X2930 723 3645 1 723 3644 3730 2 MOAI1S $T=879160 679280 1 180 $X=875440 $Y=678900
X2931 723 3379 1 3320 723 758 2 MOAI1S $T=880400 558320 0 0 $X=880400 $Y=557940
X2932 312 293 1 313 299 2 318 2161 2184 OAI222S $T=502820 689360 1 0 $X=502820 $Y=683940
X2933 312 295 1 313 306 2 318 2160 2227 OAI222S $T=513360 689360 1 0 $X=513360 $Y=683940
X2934 350 312 1 363 351 2 318 2334 2136 OAI222S $T=541260 689360 0 180 $X=535680 $Y=683940
X2935 312 352 1 363 353 2 318 2350 348 OAI222S $T=548700 689360 1 180 $X=543120 $Y=688980
X2936 3374 3353 1 3315 3344 2 3340 3339 3319 OAI222S $T=783680 659120 0 180 $X=778100 $Y=653700
X2937 187 3472 1 3392 625 2 3408 3453 3382 OAI222S $T=807240 649040 1 180 $X=801660 $Y=648660
X2938 1049 1055 1068 2 1 XNR2HS $T=255440 598640 0 0 $X=255440 $Y=598260
X2939 1068 1091 1103 2 1 XNR2HS $T=262260 598640 0 0 $X=262260 $Y=598260
X2940 1289 1285 1277 2 1 XNR2HS $T=306900 598640 0 0 $X=306900 $Y=598260
X2941 1103 1300 1289 2 1 XNR2HS $T=309380 598640 1 0 $X=309380 $Y=593220
X2942 205 209 212 2 1 XNR2HS $T=431520 638960 0 0 $X=431520 $Y=638580
X2943 2230 324 2199 2 1 XNR2HS $T=517700 669200 0 180 $X=512120 $Y=663780
X2944 2229 2234 2243 2 1 XNR2HS $T=515840 578480 0 0 $X=515840 $Y=578100
X2945 2267 327 2248 2 1 XNR2HS $T=525760 669200 1 180 $X=520180 $Y=668820
X2946 2210 2361 2406 2 1 XNR2HS $T=553660 558320 1 0 $X=553660 $Y=552900
X2947 2397 2406 2432 2 1 XNR2HS $T=561720 548240 1 0 $X=561720 $Y=542820
X2948 2533 2544 2635 2 1 XNR2HS $T=601400 608720 0 0 $X=601400 $Y=608340
X2949 2837 2845 2857 2 1 XNR2HS $T=658440 548240 1 0 $X=658440 $Y=542820
X2950 2909 2913 2853 2 1 XNR2HS $T=672700 538160 1 0 $X=672700 $Y=532740
X2951 2942 2997 3001 2 1 XNR2HS $T=692540 598640 0 0 $X=692540 $Y=598260
X2952 3463 3455 3485 2 1 XNR2HS $T=806000 538160 0 0 $X=806000 $Y=537780
X2953 3497 3456 3517 2 1 XNR2HS $T=810960 538160 1 0 $X=810960 $Y=532740
X2954 3661 3628 3652 2 1 XNR2HS $T=850020 669200 1 180 $X=844440 $Y=668820
X2955 713 716 3740 2 1 XNR2HS $T=880400 638960 1 0 $X=880400 $Y=633540
X2956 295 297 306 296 299 294 1 2 2147 OA222 $T=497860 679280 0 0 $X=497860 $Y=678900
X2957 298 297 315 296 306 294 1 2 2188 OA222 $T=503440 689360 0 0 $X=503440 $Y=688980
X2958 2184 308 293 305 295 304 1 2 2215 OA222 $T=509020 689360 0 0 $X=509020 $Y=688980
X2959 3319 3365 2 1 3382 OR2S $T=784920 659120 0 0 $X=784920 $Y=658740
X2960 606 3409 2 1 3442 OR2 $T=794840 528080 1 0 $X=794840 $Y=522660
X2961 3439 3477 2 1 3472 OR2 $T=807860 638960 1 180 $X=805380 $Y=638580
X2962 1853 3483 2 1 3651 OR2 $T=842580 618800 1 0 $X=842580 $Y=613380
X2963 3398 1 3388 3383 3319 2 ND3S $T=792980 649040 1 180 $X=790500 $Y=648660
X2964 3436 1 3383 3614 625 2 ND3S $T=830800 679280 1 0 $X=830800 $Y=673860
X2965 3284 3292 3295 2 1 3297 AN3 $T=761980 659120 0 0 $X=761980 $Y=658740
X2966 3698 3694 3688 2 1 3680 AN3 $T=859940 669200 0 180 $X=856220 $Y=663780
X2967 1749 2 1730 1764 1785 1 NR3 $T=424700 618800 0 0 $X=424700 $Y=618420
X2968 1899 2 234 236 1914 1 NR3 $T=450740 528080 0 0 $X=450740 $Y=527700
X2969 2047 2 1998 2068 2124 1 NR3 $T=497240 628880 1 180 $X=494140 $Y=628500
X2970 2328 2 2306 2289 2364 1 NR3 $T=546840 608720 1 180 $X=543740 $Y=608340
X2971 2794 2 488 497 2840 1 NR3 $T=659680 558320 1 0 $X=659680 $Y=552900
X2972 2929 2 2887 2889 2941 1 NR3 $T=682000 659120 0 180 $X=678900 $Y=653700
X2973 513 2 268 1853 3464 1 NR3 $T=801660 669200 1 0 $X=801660 $Y=663780
X2974 3530 2 3518 3521 3499 1 NR3 $T=819020 649040 0 180 $X=815920 $Y=643620
X2975 1785 1792 1772 1773 2 1768 1 AOI13HS $T=425940 608720 0 0 $X=425940 $Y=608340
X2976 1914 1939 1929 1884 2 247 1 AOI13HS $T=458180 528080 0 0 $X=458180 $Y=527700
X2977 2124 2143 2135 2148 2 2151 1 AOI13HS $T=500340 628880 0 0 $X=500340 $Y=628500
X2978 2364 2404 2390 2380 2 2374 1 AOI13HS $T=553660 608720 0 180 $X=549940 $Y=603300
X2979 2840 2848 2854 2841 2 501 1 AOI13HS $T=660300 568400 1 0 $X=660300 $Y=562980
X2980 2941 2959 2963 2951 2 2971 1 AOI13HS $T=683860 659120 1 0 $X=683860 $Y=653700
X2981 3477 3478 3425 3488 2 3464 1 AOI13HS $T=808480 659120 1 0 $X=808480 $Y=653700
X2982 3442 2 3377 1 3426 NR2P $T=800420 528080 1 0 $X=800420 $Y=522660
X2983 3444 2 3409 1 3455 NR2P $T=804140 538160 1 0 $X=804140 $Y=532740
X2984 3433 3049 1 3510 3537 3049 2 MOAI1 $T=815300 528080 0 0 $X=815300 $Y=527700
X2985 674 625 1 625 3314 3570 2 MOAI1 $T=823980 659120 1 0 $X=823980 $Y=653700
X2986 3672 692 1 3558 713 3673 2 MOAI1 $T=854360 649040 0 0 $X=854360 $Y=648660
X2987 692 3710 1 3632 716 3673 2 MOAI1 $T=864900 649040 1 180 $X=860560 $Y=648660
X2988 692 3713 1 183 719 3673 2 MOAI1 $T=865520 649040 0 180 $X=861180 $Y=643620
X2989 723 635 1 619 734 723 2 MOAI1 $T=864280 528080 1 0 $X=864280 $Y=522660
X2990 692 3722 1 3600 730 3673 2 MOAI1 $T=871100 649040 1 180 $X=866760 $Y=648660
X2991 723 3605 1 738 745 723 2 MOAI1 $T=869860 528080 1 0 $X=869860 $Y=522660
X2992 723 689 1 752 751 723 2 MOAI1 $T=875440 528080 1 0 $X=875440 $Y=522660
X2993 723 3404 1 3310 760 723 2 MOAI1 $T=881020 608720 0 0 $X=881020 $Y=608340
X2994 723 3393 1 3355 759 723 2 MOAI1 $T=882880 578480 0 0 $X=882880 $Y=578100
X2995 723 3601 1 3570 761 723 2 MOAI1 $T=884120 598640 1 0 $X=884120 $Y=593220
X2996 723 784 1 781 782 723 2 MOAI1 $T=949840 689360 1 180 $X=945500 $Y=688980
X2997 3403 648 513 2 1 3374 OA12S $T=795460 679280 0 180 $X=791740 $Y=673860
X2998 3473 3013 2937 2 1 3483 OA12S $T=805380 618800 1 0 $X=805380 $Y=613380
X2999 1920 167 1 1933 2 1927 OAI12HS $T=455080 618800 0 0 $X=455080 $Y=618420
X3000 2009 2025 1 2 INV1CK $T=476780 628880 0 0 $X=476780 $Y=628500
X3001 1277 101 107 1322 1 2 QDFFRBP $T=303800 618800 1 0 $X=303800 $Y=613380
X3002 1451 101 107 1544 1 2 QDFFRBP $T=354640 608720 0 0 $X=354640 $Y=608340
X3003 2317 319 2211 2367 1 2 QDFFRBP $T=536920 588560 0 0 $X=536920 $Y=588180
X3004 3347 3255 594 3292 1 2 QDFFRBP $T=780580 669200 0 180 $X=768180 $Y=663780
X3005 3370 576 621 204 1 2 QDFFRBP $T=783060 628880 1 180 $X=770660 $Y=628500
X3006 1083 1099 1106 1 2 1091 MAO222 $T=262880 608720 1 0 $X=262880 $Y=603300
X3007 1269 1276 1186 1 2 1285 MAO222 $T=301320 608720 1 0 $X=301320 $Y=603300
X3008 1313 1308 1319 1 2 1307 MAO222 $T=311860 588560 1 0 $X=311860 $Y=583140
X3009 1337 1344 1347 1 2 1308 MAO222 $T=318060 588560 0 0 $X=318060 $Y=588180
X3010 1416 1452 1422 1 2 1349 MAO222 $T=342860 638960 1 0 $X=342860 $Y=633540
X3011 1625 1619 1330 1 2 1626 MAO222 $T=376960 568400 0 0 $X=376960 $Y=568020
X3012 1620 1634 1639 1 2 1561 MAO222 $T=380060 638960 1 0 $X=380060 $Y=633540
X3013 1640 1651 1662 1 2 1666 MAO222 $T=384400 669200 1 0 $X=384400 $Y=663780
X3014 1644 1661 1660 1 2 1634 MAO222 $T=385020 649040 1 0 $X=385020 $Y=643620
X3015 1649 1664 1654 1 2 1661 MAO222 $T=385640 659120 1 0 $X=385640 $Y=653700
X3016 1372 1667 1648 1 2 1642 MAO222 $T=386260 628880 0 0 $X=386260 $Y=628500
X3017 1609 1666 1656 1 2 1664 MAO222 $T=386880 659120 0 0 $X=386880 $Y=658740
X3018 1647 1669 1657 1 2 1651 MAO222 $T=386880 679280 1 0 $X=386880 $Y=673860
X3019 2178 2196 2163 1 2 2173 MAO222 $T=508400 568400 0 0 $X=508400 $Y=568020
X3020 2228 2224 2122 1 2 2196 MAO222 $T=513980 568400 0 0 $X=513980 $Y=568020
X3021 2371 2377 2382 1 2 2234 MAO222 $T=548080 588560 1 0 $X=548080 $Y=583140
X3022 2432 2443 2438 1 2 2435 MAO222 $T=562960 558320 1 0 $X=562960 $Y=552900
X3023 2476 2474 2447 1 2 2463 MAO222 $T=570400 578480 1 0 $X=570400 $Y=573060
X3024 2492 2490 2497 1 2 2502 MAO222 $T=574120 558320 1 0 $X=574120 $Y=552900
X3025 2492 2497 2490 1 2 2526 MAO222 $T=577840 568400 1 0 $X=577840 $Y=562980
X3026 2544 2502 2533 1 2 2474 MAO222 $T=584040 568400 0 0 $X=584040 $Y=568020
X3027 2628 2631 2459 1 2 2607 MAO222 $T=606980 538160 1 180 $X=602020 $Y=537780
X3028 2628 2631 2459 1 2 2611 MAO222 $T=607600 548240 0 180 $X=602640 $Y=542820
X3029 2976 2970 2986 1 2 2944 MAO222 $T=688820 588560 1 180 $X=683860 $Y=588180
X3030 554 3026 556 1 2 2998 MAO222 $T=699360 528080 0 0 $X=699360 $Y=527700
X3031 561 562 560 1 2 3026 MAO222 $T=711140 528080 1 0 $X=711140 $Y=522660
X3032 581 580 578 1 2 562 MAO222 $T=730360 528080 1 0 $X=730360 $Y=522660
X3033 3158 3204 588 1 2 3187 MAO222 $T=740280 598640 0 0 $X=740280 $Y=598260
X3034 3290 3274 3247 1 2 3273 MAO222 $T=764460 598640 0 180 $X=759500 $Y=593220
X3035 633 631 628 1 2 3264 MAO222 $T=781820 528080 0 180 $X=776860 $Y=522660
X3036 3432 3427 3390 1 2 3391 MAO222 $T=796080 588560 1 0 $X=796080 $Y=583140
X3037 3389 3493 3491 1 2 3427 MAO222 $T=808480 578480 0 0 $X=808480 $Y=578100
X3038 3618 3545 695 1 2 3609 MAO222 $T=843200 528080 1 180 $X=838240 $Y=527700
X3039 10 11 2 910 1 909 MUX2S $T=231260 659120 1 180 $X=226920 $Y=658740
X3040 13 11 2 924 1 901 MUX2S $T=233740 558320 1 180 $X=229400 $Y=557940
X3041 912 11 2 941 1 942 MUX2S $T=230640 568400 1 0 $X=230640 $Y=562980
X3042 15 11 2 936 1 922 MUX2S $T=236220 548240 0 180 $X=231880 $Y=542820
X3043 967 972 2 943 1 910 MUX2S $T=237460 659120 1 180 $X=233120 $Y=658740
X3044 16 17 2 947 1 14 MUX2S $T=238080 528080 0 180 $X=233740 $Y=522660
X3045 14 11 2 961 1 937 MUX2S $T=233740 548240 0 0 $X=233740 $Y=547860
X3046 29 11 2 939 1 944 MUX2S $T=238700 679280 1 180 $X=234360 $Y=678900
X3047 28 17 2 953 1 912 MUX2S $T=239320 538160 1 180 $X=234980 $Y=537780
X3048 23 11 2 954 1 927 MUX2S $T=239320 558320 1 180 $X=234980 $Y=557940
X3049 21 11 2 955 1 952 MUX2S $T=239320 649040 0 180 $X=234980 $Y=643620
X3050 983 17 2 962 1 941 MUX2S $T=240560 568400 0 180 $X=236220 $Y=562980
X3051 936 11 2 962 1 960 MUX2S $T=240560 588560 1 180 $X=236220 $Y=588180
X3052 946 11 2 965 1 948 MUX2S $T=240560 638960 1 180 $X=236220 $Y=638580
X3053 27 11 2 973 1 932 MUX2S $T=241800 558320 0 180 $X=237460 $Y=552900
X3054 947 17 2 975 1 936 MUX2S $T=242420 548240 0 180 $X=238080 $Y=542820
X3055 18 11 2 984 1 921 MUX2S $T=238080 578480 1 0 $X=238080 $Y=573060
X3056 974 11 2 985 1 979 MUX2S $T=238080 588560 1 0 $X=238080 $Y=583140
X3057 30 11 2 976 1 929 MUX2S $T=243040 659120 1 180 $X=238700 $Y=658740
X3058 971 11 2 943 1 1011 MUX2S $T=239320 638960 1 0 $X=239320 $Y=633540
X3059 975 17 2 962 1 961 MUX2S $T=244280 548240 1 180 $X=239940 $Y=547860
X3060 36 11 2 981 1 928 MUX2S $T=244280 659120 0 180 $X=239940 $Y=653700
X3061 32 17 2 982 1 974 MUX2S $T=244900 538160 0 180 $X=240560 $Y=532740
X3062 34 972 2 987 1 10 MUX2S $T=244900 679280 0 180 $X=240560 $Y=673860
X3063 1010 17 2 962 1 954 MUX2S $T=245520 558320 1 180 $X=241180 $Y=557940
X3064 953 17 2 983 1 924 MUX2S $T=242420 568400 1 0 $X=242420 $Y=562980
X3065 1016 972 2 943 1 965 MUX2S $T=246760 638960 1 180 $X=242420 $Y=638580
X3066 1006 972 2 943 1 955 MUX2S $T=246760 649040 0 180 $X=242420 $Y=643620
X3067 989 972 2 994 1 21 MUX2S $T=246760 669200 1 180 $X=242420 $Y=668820
X3068 978 17 2 1010 1 973 MUX2S $T=243040 558320 1 0 $X=243040 $Y=552900
X3069 987 972 2 967 1 939 MUX2S $T=247380 669200 0 180 $X=243040 $Y=663780
X3070 1001 17 2 962 1 985 MUX2S $T=248000 578480 1 180 $X=243660 $Y=578100
X3071 984 11 2 962 1 1007 MUX2S $T=243660 588560 0 0 $X=243660 $Y=588180
X3072 1003 37 2 1000 1 978 MUX2S $T=248620 548240 0 180 $X=244280 $Y=542820
X3073 982 17 2 1001 1 984 MUX2S $T=248620 578480 0 180 $X=244280 $Y=573060
X3074 994 972 2 1006 1 970 MUX2S $T=249240 659120 1 180 $X=244900 $Y=658740
X3075 1026 37 2 1009 1 975 MUX2S $T=249860 548240 1 180 $X=245520 $Y=547860
X3076 1034 972 2 943 1 981 MUX2S $T=250480 659120 0 180 $X=246140 $Y=653700
X3077 1008 972 2 1013 1 946 MUX2S $T=250480 679280 0 180 $X=246140 $Y=673860
X3078 1002 37 2 1015 1 947 MUX2S $T=251100 538160 1 180 $X=246760 $Y=537780
X3079 970 11 2 943 1 1012 MUX2S $T=246760 638960 1 0 $X=246760 $Y=633540
X3080 996 972 2 1017 1 36 MUX2S $T=251100 679280 1 180 $X=246760 $Y=678900
X3081 1024 37 2 1019 1 1010 MUX2S $T=251720 558320 1 180 $X=247380 $Y=557940
X3082 1009 37 2 962 1 983 MUX2S $T=252340 568400 0 180 $X=248000 $Y=562980
X3083 1037 37 2 1022 1 987 MUX2S $T=252340 669200 1 180 $X=248000 $Y=668820
X3084 1013 972 2 1016 1 976 MUX2S $T=248620 638960 0 0 $X=248620 $Y=638580
X3085 1017 972 2 1034 1 971 MUX2S $T=248620 669200 1 0 $X=248620 $Y=663780
X3086 1000 37 2 1024 1 982 MUX2S $T=253580 558320 0 180 $X=249240 $Y=552900
X3087 973 11 2 962 1 1038 MUX2S $T=249240 588560 1 0 $X=249240 $Y=583140
X3088 1019 37 2 962 1 1001 MUX2S $T=254200 578480 0 180 $X=249860 $Y=573060
X3089 924 11 2 962 1 1040 MUX2S $T=249860 578480 0 0 $X=249860 $Y=578100
X3090 44 43 2 1029 1 38 MUX2S $T=254820 528080 0 180 $X=250480 $Y=522660
X3091 1029 43 2 1031 1 1002 MUX2S $T=255440 528080 1 180 $X=251100 $Y=527700
X3092 1039 43 2 1032 1 1026 MUX2S $T=255440 548240 0 180 $X=251100 $Y=542820
X3093 1045 37 2 1033 1 967 MUX2S $T=255440 659120 1 180 $X=251100 $Y=658740
X3094 1015 37 2 1026 1 953 MUX2S $T=256060 548240 1 180 $X=251720 $Y=547860
X3095 1042 37 2 1036 1 1013 MUX2S $T=256680 649040 1 180 $X=252340 $Y=648660
X3096 46 37 2 1037 1 989 MUX2S $T=256680 679280 1 180 $X=252340 $Y=678900
X3097 1058 43 2 1039 1 1000 MUX2S $T=257300 538160 1 180 $X=252960 $Y=537780
X3098 1046 43 2 1041 1 1009 MUX2S $T=257920 558320 1 180 $X=253580 $Y=557940
X3099 976 11 2 943 1 1014 MUX2S $T=253580 638960 1 0 $X=253580 $Y=633540
X3100 1030 37 2 1042 1 1017 MUX2S $T=257920 669200 1 180 $X=253580 $Y=668820
X3101 1022 37 2 1045 1 994 MUX2S $T=258540 669200 0 180 $X=254200 $Y=663780
X3102 1032 43 2 1046 1 1024 MUX2S $T=259160 558320 0 180 $X=254820 $Y=552900
X3103 1074 43 2 1058 1 1015 MUX2S $T=261640 548240 0 180 $X=257300 $Y=542820
X3104 1080 43 2 1062 1 1052 MUX2S $T=261640 689360 0 180 $X=257300 $Y=683940
X3105 1079 43 2 1065 1 1045 MUX2S $T=262260 659120 0 180 $X=257920 $Y=653700
X3106 1065 43 2 1070 1 1036 MUX2S $T=262880 649040 1 180 $X=258540 $Y=648660
X3107 1031 43 2 1074 1 1003 MUX2S $T=263500 538160 1 180 $X=259160 $Y=537780
X3108 1071 43 2 1075 1 1022 MUX2S $T=263500 669200 1 180 $X=259160 $Y=668820
X3109 1070 43 2 1078 1 1033 MUX2S $T=264740 649040 0 180 $X=260400 $Y=643620
X3110 1075 43 2 1079 1 1042 MUX2S $T=264740 659120 1 180 $X=260400 $Y=658740
X3111 1105 57 2 1087 1 1048 MUX2S $T=266600 558320 1 180 $X=262260 $Y=557940
X3112 1137 57 2 1087 1 1051 MUX2S $T=272800 568400 0 180 $X=268460 $Y=562980
X3113 1153 57 2 1129 1 1092 MUX2S $T=275280 638960 0 180 $X=270940 $Y=633540
X3114 1127 61 2 1126 1 1160 MUX2S $T=270940 659120 1 0 $X=270940 $Y=653700
X3115 1115 61 2 1118 1 1141 MUX2S $T=270940 689360 1 0 $X=270940 $Y=683940
X3116 1138 70 2 1087 1 1173 MUX2S $T=273420 548240 0 0 $X=273420 $Y=547860
X3117 1165 70 2 1138 1 1116 MUX2S $T=278380 558320 0 180 $X=274040 $Y=552900
X3118 1166 57 2 1087 1 1135 MUX2S $T=278380 568400 0 180 $X=274040 $Y=562980
X3119 1141 69 2 1144 1 1176 MUX2S $T=275280 679280 0 0 $X=275280 $Y=678900
X3120 1144 69 2 1148 1 1200 MUX2S $T=275900 669200 1 0 $X=275900 $Y=663780
X3121 1140 69 2 1171 1 1179 MUX2S $T=275900 679280 1 0 $X=275900 $Y=673860
X3122 1185 57 2 1129 1 1158 MUX2S $T=280860 638960 0 180 $X=276520 $Y=633540
X3123 74 57 2 1105 1 1133 MUX2S $T=283340 538160 1 180 $X=279000 $Y=537780
X3124 76 57 2 1173 1 1170 MUX2S $T=283340 548240 0 180 $X=279000 $Y=542820
X3125 1197 70 2 1087 1 1172 MUX2S $T=283340 558320 0 180 $X=279000 $Y=552900
X3126 1210 57 2 1172 1 1174 MUX2S $T=283960 558320 1 180 $X=279620 $Y=557940
X3127 82 57 2 1166 1 1142 MUX2S $T=284580 528080 1 180 $X=280240 $Y=527700
X3128 1171 69 2 1160 1 1203 MUX2S $T=281480 669200 0 0 $X=281480 $Y=668820
X3129 1182 70 2 1181 1 1153 MUX2S $T=286440 649040 0 180 $X=282100 $Y=643620
X3130 1206 57 2 1129 1 1189 MUX2S $T=287060 638960 1 180 $X=282720 $Y=638580
X3131 75 57 2 1153 1 1207 MUX2S $T=282720 659120 1 0 $X=282720 $Y=653700
X3132 1203 70 2 1192 1 1185 MUX2S $T=287060 659120 1 180 $X=282720 $Y=658740
X3133 83 57 2 1196 1 1194 MUX2S $T=288300 538160 1 180 $X=283960 $Y=537780
X3134 84 57 2 1202 1 1201 MUX2S $T=288920 548240 0 180 $X=284580 $Y=542820
X3135 1214 69 2 1087 1 1138 MUX2S $T=289540 558320 0 180 $X=285200 $Y=552900
X3136 86 57 2 1137 1 1205 MUX2S $T=290160 568400 0 180 $X=285820 $Y=562980
X3137 1200 70 2 1177 1 1206 MUX2S $T=286440 669200 0 0 $X=286440 $Y=668820
X3138 87 57 2 1210 1 1161 MUX2S $T=291400 528080 0 180 $X=287060 $Y=522660
X3139 1181 70 2 1129 1 1224 MUX2S $T=287680 638960 0 0 $X=287680 $Y=638580
X3140 1177 70 2 1129 1 1239 MUX2S $T=287680 649040 1 0 $X=287680 $Y=643620
X3141 79 57 2 1206 1 1222 MUX2S $T=287680 679280 1 0 $X=287680 $Y=673860
X3142 90 70 2 1203 1 80 MUX2S $T=292020 679280 1 180 $X=287680 $Y=678900
X3143 73 69 2 1140 1 90 MUX2S $T=288300 689360 1 0 $X=288300 $Y=683940
X3144 91 70 2 1216 1 1166 MUX2S $T=293260 538160 0 180 $X=288920 $Y=532740
X3145 1179 70 2 1178 1 1231 MUX2S $T=289540 669200 1 0 $X=289540 $Y=663780
X3146 1216 70 2 1087 1 1196 MUX2S $T=294500 538160 1 180 $X=290160 $Y=537780
X3147 1234 70 2 1087 1 1202 MUX2S $T=295120 548240 0 180 $X=290780 $Y=542820
X3148 1232 70 2 1197 1 1137 MUX2S $T=295120 558320 0 180 $X=290780 $Y=552900
X3149 94 70 2 1165 1 76 MUX2S $T=296980 528080 0 180 $X=292640 $Y=522660
X3150 88 57 2 1185 1 1241 MUX2S $T=292640 669200 0 0 $X=292640 $Y=668820
X3151 89 57 2 1231 1 1236 MUX2S $T=292640 679280 1 0 $X=292640 $Y=673860
X3152 1209 57 2 1224 1 1244 MUX2S $T=293880 638960 0 0 $X=293880 $Y=638580
X3153 78 57 2 1239 1 1245 MUX2S $T=293880 649040 0 0 $X=293880 $Y=648660
X3154 95 70 2 1179 1 92 MUX2S $T=298220 689360 0 180 $X=293880 $Y=683940
X3155 96 70 2 1232 1 1210 MUX2S $T=299460 538160 0 180 $X=295120 $Y=532740
X3156 1263 69 2 1214 1 1216 MUX2S $T=300700 538160 1 180 $X=296360 $Y=537780
X3157 1247 70 2 1234 1 1105 MUX2S $T=300700 548240 0 180 $X=296360 $Y=542820
X3158 1254 69 2 1087 1 1197 MUX2S $T=300700 558320 0 180 $X=296360 $Y=552900
X3159 99 70 2 1247 1 84 MUX2S $T=302560 528080 0 180 $X=298220 $Y=522660
X3160 103 69 2 1262 1 1247 MUX2S $T=305660 538160 0 180 $X=301320 $Y=532740
X3161 1262 69 2 1265 1 1232 MUX2S $T=306280 548240 0 180 $X=301940 $Y=542820
X3162 1278 69 2 1263 1 1165 MUX2S $T=306900 538160 1 180 $X=302560 $Y=537780
X3163 104 69 2 1278 1 91 MUX2S $T=308140 528080 1 180 $X=303800 $Y=527700
X3164 1265 69 2 1254 1 1234 MUX2S $T=308140 548240 1 180 $X=303800 $Y=547860
X3165 1296 61 2 1290 1 1278 MUX2S $T=311860 538160 0 180 $X=307520 $Y=532740
X3166 1297 61 2 1291 1 1214 MUX2S $T=311860 558320 1 180 $X=307520 $Y=557940
X3167 1295 61 2 1293 1 1263 MUX2S $T=312480 548240 0 180 $X=308140 $Y=542820
X3168 1290 61 2 1295 1 1262 MUX2S $T=313100 538160 1 180 $X=308760 $Y=537780
X3169 1305 61 2 1296 1 103 MUX2S $T=313720 528080 1 180 $X=309380 $Y=527700
X3170 1293 61 2 1297 1 1265 MUX2S $T=313720 548240 1 180 $X=309380 $Y=547860
X3171 106 61 2 1305 1 104 MUX2S $T=310000 528080 1 0 $X=310000 $Y=522660
X3172 1332 115 2 1346 1 1352 MUX2S $T=318060 548240 0 0 $X=318060 $Y=547860
X3173 1350 115 2 1341 1 1369 MUX2S $T=323020 528080 0 0 $X=323020 $Y=527700
X3174 1341 115 2 1355 1 1384 MUX2S $T=323020 538160 1 0 $X=323020 $Y=532740
X3175 1355 115 2 1363 1 1373 MUX2S $T=323640 548240 1 0 $X=323640 $Y=542820
X3176 1363 115 2 1332 1 1356 MUX2S $T=327980 548240 1 180 $X=323640 $Y=547860
X3177 1346 115 2 1351 1 1376 MUX2S $T=323640 558320 1 0 $X=323640 $Y=552900
X3178 1377 1378 2 1358 1 1310 MUX2S $T=327980 558320 1 180 $X=323640 $Y=557940
X3179 117 115 2 1350 1 1382 MUX2S $T=324260 528080 1 0 $X=324260 $Y=522660
X3180 1359 115 2 1367 1 1374 MUX2S $T=324260 669200 0 0 $X=324260 $Y=668820
X3181 1400 1378 2 1358 1 1336 MUX2S $T=332940 568400 0 180 $X=328600 $Y=562980
X3182 1383 115 2 1391 1 1401 MUX2S $T=328600 689360 0 0 $X=328600 $Y=688980
X3183 1382 119 2 1384 1 1402 MUX2S $T=329220 528080 0 0 $X=329220 $Y=527700
X3184 1384 119 2 1356 1 1410 MUX2S $T=329220 538160 1 0 $X=329220 $Y=532740
X3185 1385 115 2 1359 1 1429 MUX2S $T=329220 669200 0 0 $X=329220 $Y=668820
X3186 120 119 2 1382 1 122 MUX2S $T=329840 528080 1 0 $X=329840 $Y=522660
X3187 1356 119 2 1376 1 1405 MUX2S $T=329840 548240 0 0 $X=329840 $Y=547860
X3188 1386 119 2 1358 1 1406 MUX2S $T=329840 558320 0 0 $X=329840 $Y=557940
X3189 1367 115 2 1398 1 1404 MUX2S $T=329840 659120 0 0 $X=329840 $Y=658740
X3190 1397 115 2 1375 1 1425 MUX2S $T=332320 679280 0 0 $X=332320 $Y=678900
X3191 1391 115 2 1397 1 1414 MUX2S $T=332320 689360 1 0 $X=332320 $Y=683940
X3192 1373 119 2 1352 1 1418 MUX2S $T=332940 538160 0 0 $X=332940 $Y=537780
X3193 1375 115 2 1385 1 1413 MUX2S $T=332940 679280 1 0 $X=332940 $Y=673860
X3194 123 115 2 1383 1 130 MUX2S $T=334180 689360 0 0 $X=334180 $Y=688980
X3195 1424 1378 2 1358 1 1387 MUX2S $T=339140 568400 0 180 $X=334800 $Y=562980
X3196 1376 119 2 1358 1 1432 MUX2S $T=335420 558320 1 0 $X=335420 $Y=552900
X3197 1398 115 2 1417 1 1434 MUX2S $T=335420 659120 0 0 $X=335420 $Y=658740
X3198 1352 119 2 1386 1 1437 MUX2S $T=336040 548240 0 0 $X=336040 $Y=547860
X3199 1418 127 2 1406 1 1377 MUX2S $T=340380 558320 1 180 $X=336040 $Y=557940
X3200 1402 127 2 1405 1 1438 MUX2S $T=337900 538160 1 0 $X=337900 $Y=532740
X3201 1401 119 2 1425 1 131 MUX2S $T=337900 689360 1 0 $X=337900 $Y=683940
X3202 1425 119 2 1429 1 1447 MUX2S $T=338520 679280 0 0 $X=338520 $Y=678900
X3203 1423 127 2 1437 1 1424 MUX2S $T=339140 538160 0 0 $X=339140 $Y=537780
X3204 1429 119 2 1404 1 1446 MUX2S $T=339140 669200 0 0 $X=339140 $Y=668820
X3205 1438 1378 2 1358 1 1411 MUX2S $T=344720 568400 0 180 $X=340380 $Y=562980
X3206 130 119 2 1414 1 132 MUX2S $T=340380 689360 0 0 $X=340380 $Y=688980
X3207 1410 127 2 1432 1 1400 MUX2S $T=341000 558320 1 0 $X=341000 $Y=552900
X3208 1405 127 2 1358 1 1456 MUX2S $T=341620 548240 0 0 $X=341620 $Y=547860
X3209 1430 127 2 1418 1 1461 MUX2S $T=342240 538160 1 0 $X=342240 $Y=532740
X3210 1406 127 2 1358 1 1457 MUX2S $T=342240 558320 0 0 $X=342240 $Y=557940
X3211 1467 1470 2 1408 1 1433 MUX2S $T=348440 659120 0 180 $X=344100 $Y=653700
X3212 1414 119 2 1413 1 139 MUX2S $T=344100 689360 1 0 $X=344100 $Y=683940
X3213 1413 119 2 1374 1 1473 MUX2S $T=344720 679280 0 0 $X=344720 $Y=678900
X3214 135 1378 2 1424 1 1468 MUX2S $T=345340 538160 0 0 $X=345340 $Y=537780
X3215 1374 119 2 1434 1 1480 MUX2S $T=345340 669200 0 0 $X=345340 $Y=668820
X3216 138 119 2 1401 1 145 MUX2S $T=345960 689360 0 0 $X=345960 $Y=688980
X3217 1461 1378 2 1457 1 1442 MUX2S $T=350920 568400 0 180 $X=346580 $Y=562980
X3218 1432 127 2 1358 1 1478 MUX2S $T=347200 558320 1 0 $X=347200 $Y=552900
X3219 1446 121 2 1454 1 1467 MUX2S $T=347200 659120 0 0 $X=347200 $Y=658740
X3220 1459 121 2 1408 1 1497 MUX2S $T=347200 669200 1 0 $X=347200 $Y=663780
X3221 1437 127 2 1358 1 1489 MUX2S $T=347820 548240 0 0 $X=347820 $Y=547860
X3222 1448 1378 2 1478 1 1485 MUX2S $T=348440 558320 0 0 $X=348440 $Y=557940
X3223 142 1378 2 1438 1 1496 MUX2S $T=349680 538160 1 0 $X=349680 $Y=532740
X3224 131 121 2 1446 1 149 MUX2S $T=349680 689360 1 0 $X=349680 $Y=683940
X3225 144 1378 2 1456 1 1498 MUX2S $T=350920 538160 0 0 $X=350920 $Y=537780
X3226 1447 121 2 1428 1 1504 MUX2S $T=350920 679280 0 0 $X=350920 $Y=678900
X3227 147 143 2 1461 1 1500 MUX2S $T=351540 528080 0 0 $X=351540 $Y=527700
X3228 1473 121 2 1459 1 1502 MUX2S $T=351540 679280 1 0 $X=351540 $Y=673860
X3229 132 121 2 1473 1 151 MUX2S $T=352160 689360 0 0 $X=352160 $Y=688980
X3230 148 1378 2 1400 1 1511 MUX2S $T=352780 558320 1 0 $X=352780 $Y=552900
X3231 1502 1506 2 1408 1 1491 MUX2S $T=357120 659120 0 180 $X=352780 $Y=653700
X3232 153 1506 2 1467 1 1484 MUX2S $T=357120 669200 1 180 $X=352780 $Y=668820
X3233 134 1378 2 1489 1 1509 MUX2S $T=353400 548240 0 0 $X=353400 $Y=547860
X3234 1454 121 2 1408 1 1514 MUX2S $T=353400 659120 0 0 $X=353400 $Y=658740
X3235 141 1378 2 1377 1 1515 MUX2S $T=354640 558320 0 0 $X=354640 $Y=557940
X3236 139 121 2 1480 1 1529 MUX2S $T=355880 689360 1 0 $X=355880 $Y=683940
X3237 154 156 2 1502 1 1548 MUX2S $T=357120 679280 0 0 $X=357120 $Y=678900
X3238 1480 121 2 1408 1 1532 MUX2S $T=357740 669200 0 0 $X=357740 $Y=668820
X3239 145 121 2 1447 1 158 MUX2S $T=357740 689360 0 0 $X=357740 $Y=688980
X3240 1504 1506 2 1408 1 1533 MUX2S $T=358360 659120 1 0 $X=358360 $Y=653700
X3241 1428 121 2 1408 1 1535 MUX2S $T=358360 669200 1 0 $X=358360 $Y=663780
X3242 149 1506 2 1514 1 1541 MUX2S $T=358980 659120 0 0 $X=358980 $Y=658740
X3243 159 156 2 1504 1 1557 MUX2S $T=362080 689360 1 0 $X=362080 $Y=683940
X3244 160 1506 2 1532 1 1571 MUX2S $T=363940 679280 1 0 $X=363940 $Y=673860
X3245 161 156 2 1529 1 1577 MUX2S $T=365180 689360 0 0 $X=365180 $Y=688980
X3246 1340 167 2 1659 1 1631 MUX2S $T=384400 598640 0 0 $X=384400 $Y=598260
X3247 1659 167 2 1698 1 1702 MUX2S $T=396800 578480 0 0 $X=396800 $Y=578100
X3248 1412 167 2 1683 1 1655 MUX2S $T=396800 598640 0 0 $X=396800 $Y=598260
X3249 1672 167 2 1726 1 1733 MUX2S $T=405480 578480 1 0 $X=405480 $Y=573060
X3250 1699 167 2 1742 1 1709 MUX2S $T=409200 568400 1 0 $X=409200 $Y=562980
X3251 1710 167 2 186 1 1748 MUX2S $T=409820 548240 1 0 $X=409820 $Y=542820
X3252 1698 167 2 188 1 1757 MUX2S $T=412300 558320 0 0 $X=412300 $Y=557940
X3253 1742 167 2 189 1 1756 MUX2S $T=412920 528080 0 0 $X=412920 $Y=527700
X3254 1455 167 2 1739 1 1758 MUX2S $T=413540 628880 0 0 $X=413540 $Y=628500
X3255 1465 167 2 1747 1 1771 MUX2S $T=415400 628880 1 0 $X=415400 $Y=623460
X3256 1739 167 2 1718 1 1783 MUX2S $T=420980 638960 1 0 $X=420980 $Y=633540
X3257 191 167 2 194 1 196 MUX2S $T=422220 689360 0 0 $X=422220 $Y=688980
X3258 1726 167 2 195 1 1779 MUX2S $T=422840 538160 0 0 $X=422840 $Y=537780
X3259 1782 167 2 203 1 210 MUX2S $T=429040 679280 1 0 $X=429040 $Y=673860
X3260 1802 167 2 211 1 213 MUX2S $T=431520 679280 0 0 $X=431520 $Y=678900
X3261 1718 167 2 207 1 1810 MUX2S $T=436480 669200 1 180 $X=432140 $Y=668820
X3262 1721 167 2 1802 1 1791 MUX2S $T=438340 659120 0 180 $X=434000 $Y=653700
X3263 1732 167 2 191 1 1870 MUX2S $T=440200 659120 1 0 $X=440200 $Y=653700
X3264 266 267 2 262 1 1976 MUX2S $T=470580 528080 1 180 $X=466240 $Y=527700
X3265 262 267 2 272 1 2022 MUX2S $T=471200 528080 0 0 $X=471200 $Y=527700
X3266 273 267 2 272 1 2037 MUX2S $T=474300 528080 1 0 $X=474300 $Y=522660
X3267 290 280 2 1976 1 2086 MUX2S $T=489180 528080 0 0 $X=489180 $Y=527700
X3268 362 335 2 346 1 2346 MUX2S $T=538780 528080 1 0 $X=538780 $Y=522660
X3269 2219 167 2 2448 1 2456 MUX2S $T=562960 598640 1 0 $X=562960 $Y=593220
X3270 2297 167 2 2477 1 2493 MUX2S $T=569780 598640 1 0 $X=569780 $Y=593220
X3271 2589 403 2 425 1 2669 MUX2S $T=606980 588560 1 0 $X=606980 $Y=583140
X3272 2448 403 2 2670 1 2659 MUX2S $T=611940 598640 1 0 $X=611940 $Y=593220
X3273 2519 403 2 2698 1 2700 MUX2S $T=620000 578480 1 0 $X=620000 $Y=573060
X3274 2561 403 2 2712 1 2646 MUX2S $T=623720 578480 0 0 $X=623720 $Y=578100
X3275 2670 403 2 2737 1 2739 MUX2S $T=629300 588560 1 0 $X=629300 $Y=583140
X3276 2698 403 2 455 1 2658 MUX2S $T=631160 568400 1 0 $X=631160 $Y=562980
X3277 2712 403 2 461 1 2752 MUX2S $T=636740 558320 0 0 $X=636740 $Y=557940
X3278 2902 403 2 2943 1 2947 MUX2S $T=680760 608720 1 0 $X=680760 $Y=603300
X3279 2932 2937 2 2988 1 2987 MUX2S $T=686960 618800 1 0 $X=686960 $Y=613380
X3280 2943 2937 2 3025 1 3024 MUX2S $T=698740 618800 1 0 $X=698740 $Y=613380
X3281 3007 2937 2 3115 1 3120 MUX2S $T=718580 618800 0 0 $X=718580 $Y=618420
X3282 3132 3113 2 3105 1 3097 MUX2S $T=724160 538160 0 180 $X=719820 $Y=532740
X3283 3025 2937 2 3125 1 3124 MUX2S $T=727260 618800 1 180 $X=722920 $Y=618420
X3284 3122 574 2 3089 1 3127 MUX2S $T=727880 558320 0 180 $X=723540 $Y=552900
X3285 3147 574 2 3122 1 3114 MUX2S $T=728500 548240 1 180 $X=724160 $Y=547860
X3286 3157 3113 2 3132 1 3135 MUX2S $T=730360 538160 0 180 $X=726020 $Y=532740
X3287 3168 3109 2 3114 1 3156 MUX2S $T=734700 548240 1 180 $X=730360 $Y=547860
X3288 3012 2937 2 3167 1 3169 MUX2S $T=730360 628880 1 0 $X=730360 $Y=623460
X3289 3177 3113 2 3157 1 3163 MUX2S $T=736560 538160 0 180 $X=732220 $Y=532740
X3290 3182 3136 2 3135 1 3147 MUX2S $T=738420 538160 1 180 $X=734080 $Y=537780
X3291 3163 3136 2 3097 1 3184 MUX2S $T=734700 548240 1 0 $X=734700 $Y=542820
X3292 3194 574 2 3165 1 3118 MUX2S $T=740280 548240 1 180 $X=735940 $Y=547860
X3293 3207 3113 2 3192 1 3189 MUX2S $T=743380 538160 0 180 $X=739040 $Y=532740
X3294 3192 3113 2 3177 1 3182 MUX2S $T=739660 538160 0 0 $X=739660 $Y=537780
X3295 3189 3136 2 3163 1 3194 MUX2S $T=745240 548240 0 180 $X=740900 $Y=542820
X3296 3184 574 2 3089 1 3197 MUX2S $T=745240 558320 0 180 $X=740900 $Y=552900
X3297 3208 3109 2 3118 1 3193 MUX2S $T=745240 568400 0 180 $X=740900 $Y=562980
X3298 3115 2937 2 3202 1 3188 MUX2S $T=745240 618800 1 180 $X=740900 $Y=618420
X3299 3212 574 2 3147 1 3144 MUX2S $T=745860 548240 1 180 $X=741520 $Y=547860
X3300 3216 3113 2 3207 1 3203 MUX2S $T=746480 528080 1 180 $X=742140 $Y=527700
X3301 592 3113 2 3216 1 3231 MUX2S $T=745240 538160 1 0 $X=745240 $Y=532740
X3302 3203 3136 2 3182 1 3226 MUX2S $T=745860 538160 0 0 $X=745860 $Y=537780
X3303 3233 3136 2 3203 1 3212 MUX2S $T=750820 548240 0 180 $X=746480 $Y=542820
X3304 3256 3109 2 3197 1 3140 MUX2S $T=750820 568400 0 180 $X=746480 $Y=562980
X3305 3243 574 2 3194 1 3171 MUX2S $T=751440 548240 1 180 $X=747100 $Y=547860
X3306 3226 574 2 3159 1 3116 MUX2S $T=751440 558320 0 180 $X=747100 $Y=552900
X3307 3103 2937 2 3232 1 3234 MUX2S $T=747100 618800 1 0 $X=747100 $Y=613380
X3308 3236 3113 2 592 1 3233 MUX2S $T=751440 538160 1 0 $X=751440 $Y=532740
X3309 3259 3113 2 3236 1 3237 MUX2S $T=755780 538160 1 180 $X=751440 $Y=537780
X3310 3231 3136 2 3189 1 3257 MUX2S $T=752060 548240 1 0 $X=752060 $Y=542820
X3311 3261 3109 2 3116 1 3217 MUX2S $T=756400 558320 1 180 $X=752060 $Y=557940
X3312 3257 574 2 3184 1 3119 MUX2S $T=757020 558320 0 180 $X=752680 $Y=552900
X3313 3237 3136 2 3231 1 3243 MUX2S $T=757640 548240 1 180 $X=753300 $Y=547860
X3314 3285 3109 2 3119 1 3253 MUX2S $T=761980 568400 0 180 $X=757640 $Y=562980
X3315 3282 3136 2 3233 1 3269 MUX2S $T=762600 548240 0 180 $X=758260 $Y=542820
X3316 3269 574 2 3226 1 3225 MUX2S $T=762600 558320 1 180 $X=758260 $Y=557940
X3317 3293 574 2 3212 1 3168 MUX2S $T=763220 548240 1 180 $X=758880 $Y=547860
X3318 3306 3109 2 3144 1 3275 MUX2S $T=767560 568400 0 180 $X=763220 $Y=562980
X3319 3167 2937 2 3302 1 3254 MUX2S $T=763840 628880 1 0 $X=763840 $Y=623460
X3320 3311 574 2 3257 1 3256 MUX2S $T=768800 558320 0 180 $X=764460 $Y=552900
X3321 12 11 2 1 7 912 MUX2 $T=232500 528080 0 180 $X=228160 $Y=522660
X3322 939 11 2 1 964 943 MUX2 $T=233120 638960 1 0 $X=233120 $Y=633540
X3323 20 11 2 1 906 946 MUX2 $T=238080 689360 1 180 $X=233740 $Y=688980
X3324 19 22 2 1 26 996 MUX2 $T=239940 689360 0 0 $X=239940 $Y=688980
X3325 35 972 2 1 25 989 MUX2 $T=245520 689360 0 180 $X=241180 $Y=683940
X3326 40 972 2 1 30 1008 MUX2 $T=249860 689360 1 180 $X=245520 $Y=688980
X3327 1033 37 2 1 1006 943 MUX2 $T=252960 649040 0 180 $X=248620 $Y=643620
X3328 42 37 2 1 996 1052 MUX2 $T=251720 689360 1 0 $X=251720 $Y=683940
X3329 1052 37 2 1 1008 1030 MUX2 $T=256680 679280 0 180 $X=252340 $Y=673860
X3330 1041 43 2 1 1019 962 MUX2 $T=258540 568400 1 180 $X=254200 $Y=568020
X3331 1036 37 2 1 1034 1043 MUX2 $T=258540 649040 0 180 $X=254200 $Y=643620
X3332 1043 37 2 1 1016 943 MUX2 $T=259160 638960 1 180 $X=254820 $Y=638580
X3333 41 43 2 1 46 1080 MUX2 $T=257300 689360 0 0 $X=257300 $Y=688980
X3334 1078 43 2 1 1043 943 MUX2 $T=264740 638960 0 180 $X=260400 $Y=633540
X3335 1120 61 2 1 1146 1129 MUX2 $T=270320 638960 0 0 $X=270320 $Y=638580
X3336 65 61 2 1 1156 1131 MUX2 $T=272180 689360 0 0 $X=272180 $Y=688980
X3337 1146 69 2 1 1181 1129 MUX2 $T=275900 649040 1 0 $X=275900 $Y=643620
X3338 1159 69 2 1 1177 1146 MUX2 $T=276520 649040 0 0 $X=276520 $Y=648660
X3339 1156 69 2 1 72 1141 MUX2 $T=276520 689360 1 0 $X=276520 $Y=683940
X3340 1131 61 2 1 73 1115 MUX2 $T=277760 689360 0 0 $X=277760 $Y=688980
X3341 1147 69 2 1 1192 1129 MUX2 $T=282100 649040 0 0 $X=282100 $Y=648660
X3342 77 70 2 1 75 1176 MUX2 $T=287060 689360 0 180 $X=282720 $Y=683940
X3343 81 69 2 1 77 1156 MUX2 $T=287680 689360 1 180 $X=283340 $Y=688980
X3344 1231 57 2 1 1219 1129 MUX2 $T=294500 638960 0 180 $X=290160 $Y=633540
X3345 85 57 2 1 97 1209 MUX2 $T=294500 689360 0 0 $X=294500 $Y=688980
X3346 1291 61 2 1 1254 1087 MUX2 $T=306280 558320 0 180 $X=301940 $Y=552900
X3347 1351 115 2 1 1386 1358 MUX2 $T=329220 558320 1 0 $X=329220 $Y=552900
X3348 1404 119 2 1 1428 1427 MUX2 $T=335420 669200 1 0 $X=335420 $Y=663780
X3349 1417 115 2 1 1427 1408 MUX2 $T=337280 659120 1 0 $X=337280 $Y=653700
X3350 1433 128 2 1 1445 1450 MUX2 $T=339760 649040 0 0 $X=339760 $Y=648660
X3351 1434 119 2 1 1459 1408 MUX2 $T=341000 669200 1 0 $X=341000 $Y=663780
X3352 1427 119 2 1 1454 1408 MUX2 $T=341620 659120 0 0 $X=341620 $Y=658740
X3353 146 143 2 1 1503 1448 MUX2 $T=350920 528080 1 0 $X=350920 $Y=522660
X3354 1529 1506 2 1 1573 1408 MUX2 $T=365180 659120 0 0 $X=365180 $Y=658740
X3355 1392 167 2 1 1627 1340 MUX2 $T=375100 608720 0 0 $X=375100 $Y=608340
X3356 1392 167 2 1 1681 1474 MUX2 $T=390600 598640 0 0 $X=390600 $Y=598260
X3357 1392 167 2 1 1691 1412 MUX2 $T=401140 618800 0 180 $X=396800 $Y=613380
X3358 1392 167 2 1 1705 1443 MUX2 $T=398660 608720 0 0 $X=398660 $Y=608340
X3359 1683 167 2 1 1715 1710 MUX2 $T=401140 578480 0 0 $X=401140 $Y=578100
X3360 1474 167 2 1 1736 1699 MUX2 $T=402380 588560 0 0 $X=402380 $Y=588180
X3361 1443 167 2 1 1676 1672 MUX2 $T=402380 598640 0 0 $X=402380 $Y=598260
X3362 1747 167 2 1 1803 1782 MUX2 $T=427180 638960 0 0 $X=427180 $Y=638580
X3363 1572 167 2 1 1793 1455 MUX2 $T=432140 628880 1 180 $X=427800 $Y=628500
X3364 1618 167 2 1 1834 1721 MUX2 $T=434000 628880 0 0 $X=434000 $Y=628500
X3365 1572 167 2 1 1833 1618 MUX2 $T=442680 628880 0 180 $X=438340 $Y=623460
X3366 1572 167 2 1 1897 1700 MUX2 $T=445160 628880 0 0 $X=445160 $Y=628500
X3367 1700 167 2 1 1911 1732 MUX2 $T=447640 638960 1 0 $X=447640 $Y=633540
X3368 278 280 2 1 2026 2022 MUX2 $T=481740 528080 1 180 $X=477400 $Y=527700
X3369 283 280 2 1 2016 2037 MUX2 $T=484220 528080 0 180 $X=479880 $Y=522660
X3370 281 280 2 1 2064 272 MUX2 $T=482980 528080 0 0 $X=482980 $Y=527700
X3371 286 280 2 1 2073 272 MUX2 $T=486080 528080 1 0 $X=486080 $Y=522660
X3372 292 280 2 1 2107 272 MUX2 $T=492280 528080 1 0 $X=492280 $Y=522660
X3373 1976 280 2 1 2128 272 MUX2 $T=494760 528080 0 0 $X=494760 $Y=527700
X3374 337 335 2 1 2223 328 MUX2 $T=520180 528080 0 180 $X=515840 $Y=522660
X3375 338 335 2 1 2212 329 MUX2 $T=520180 528080 1 180 $X=515840 $Y=527700
X3376 2278 167 2 1 2245 2219 MUX2 $T=523900 598640 0 180 $X=519560 $Y=593220
X3377 346 335 2 1 2201 329 MUX2 $T=526380 528080 0 180 $X=522040 $Y=522660
X3378 2278 167 2 1 2280 2297 MUX2 $T=526380 598640 1 0 $X=526380 $Y=593220
X3379 354 335 2 1 2284 329 MUX2 $T=531960 528080 0 180 $X=527620 $Y=522660
X3380 2278 167 2 1 2323 2296 MUX2 $T=532580 598640 1 0 $X=532580 $Y=593220
X3381 360 335 2 1 2298 329 MUX2 $T=537540 528080 0 180 $X=533200 $Y=522660
X3382 2278 167 2 1 2424 2427 MUX2 $T=557380 598640 1 0 $X=557380 $Y=593220
X3383 2296 167 2 1 2515 2519 MUX2 $T=577220 598640 1 0 $X=577220 $Y=593220
X3384 2427 403 2 1 2564 2561 MUX2 $T=585900 588560 0 0 $X=585900 $Y=588180
X3385 2477 403 2 1 2597 2589 MUX2 $T=592720 598640 1 0 $X=592720 $Y=593220
X3386 417 513 2 1 2921 518 MUX2 $T=670220 689360 1 0 $X=670220 $Y=683940
X3387 2918 403 2 1 2865 2902 MUX2 $T=674560 608720 1 0 $X=674560 $Y=603300
X3388 2918 2937 2 1 2916 2923 MUX2 $T=679520 618800 0 180 $X=675180 $Y=613380
X3389 2918 2937 2 1 2930 2932 MUX2 $T=682620 608720 1 180 $X=678280 $Y=608340
X3390 2918 2937 2 1 2945 2949 MUX2 $T=681380 618800 0 0 $X=681380 $Y=618420
X3391 2949 2937 2 1 2991 3007 MUX2 $T=688200 618800 0 0 $X=688200 $Y=618420
X3392 2923 2937 2 1 3015 3012 MUX2 $T=692540 618800 1 0 $X=692540 $Y=613380
X3393 2988 2937 2 1 3104 3103 MUX2 $T=716100 618800 1 0 $X=716100 $Y=613380
X3394 3114 3109 2 1 3044 3089 MUX2 $T=721060 548240 0 180 $X=716720 $Y=542820
X3395 3116 3109 2 1 3042 3089 MUX2 $T=722300 558320 0 180 $X=717960 $Y=552900
X3396 3118 3109 2 1 3037 3089 MUX2 $T=722920 548240 1 180 $X=718580 $Y=547860
X3397 3119 3109 2 1 3052 3089 MUX2 $T=722920 558320 1 180 $X=718580 $Y=557940
X3398 3105 3113 2 1 3137 3089 MUX2 $T=721680 538160 0 0 $X=721680 $Y=537780
X3399 3137 3136 2 1 3122 3089 MUX2 $T=727260 548240 0 180 $X=722920 $Y=542820
X3400 3144 3109 2 1 3050 3127 MUX2 $T=728500 558320 1 180 $X=724160 $Y=557940
X3401 3135 3136 2 1 3159 3137 MUX2 $T=727880 538160 0 0 $X=727880 $Y=537780
X3402 3097 3136 2 1 3165 3089 MUX2 $T=729120 548240 1 0 $X=729120 $Y=542820
X3403 3266 3113 2 1 3282 3259 MUX2 $T=757640 538160 0 0 $X=757640 $Y=537780
X3404 3307 598 2 1 3289 3266 MUX2 $T=766940 538160 0 180 $X=762600 $Y=532740
X3405 3308 3136 2 1 3293 3282 MUX2 $T=768800 548240 0 180 $X=764460 $Y=542820
X3406 3289 3136 2 1 3311 3237 MUX2 $T=764460 548240 0 0 $X=764460 $Y=547860
X3407 3317 606 2 1 3300 3289 MUX2 $T=771900 538160 1 180 $X=767560 $Y=537780
X3408 3321 3109 2 1 3309 3171 MUX2 $T=773140 558320 1 180 $X=768800 $Y=557940
X3409 3329 574 2 1 3306 3293 MUX2 $T=774380 548240 0 180 $X=770040 $Y=542820
X3410 3300 574 2 1 3208 3243 MUX2 $T=774380 548240 1 180 $X=770040 $Y=547860
X3411 3328 574 2 1 3261 3269 MUX2 $T=774380 558320 0 180 $X=770040 $Y=552900
X3412 620 598 2 1 3308 3307 MUX2 $T=775620 538160 0 180 $X=771280 $Y=532740
X3413 3313 598 2 1 3317 620 MUX2 $T=776860 528080 0 180 $X=772520 $Y=522660
X3414 3333 606 2 1 3328 3308 MUX2 $T=778100 538160 1 180 $X=773760 $Y=537780
X3415 3345 574 2 1 3321 3300 MUX2 $T=780580 548240 0 180 $X=776240 $Y=542820
X3416 3346 574 2 1 3331 3328 MUX2 $T=780580 548240 1 180 $X=776240 $Y=547860
X3417 3352 574 2 1 3285 3311 MUX2 $T=780580 558320 0 180 $X=776240 $Y=552900
X3418 3331 3109 2 1 3327 3225 MUX2 $T=780580 558320 1 180 $X=776240 $Y=557940
X3419 3341 598 2 1 3333 3313 MUX2 $T=782440 528080 1 180 $X=778100 $Y=527700
X3420 3367 3109 2 1 3350 3168 MUX2 $T=785540 548240 1 180 $X=781200 $Y=547860
X3421 3372 3109 2 1 3342 3256 MUX2 $T=786160 558320 1 180 $X=781820 $Y=557940
X3422 3375 3109 2 1 3357 3261 MUX2 $T=786780 558320 0 180 $X=782440 $Y=552900
X3423 3366 598 2 1 3387 3341 MUX2 $T=786780 538160 1 0 $X=786780 $Y=532740
X3424 3387 606 2 1 3352 3317 MUX2 $T=792360 538160 1 180 $X=788020 $Y=537780
X3425 3394 3109 2 1 3381 3208 MUX2 $T=792360 558320 0 180 $X=788020 $Y=552900
X3426 1023 1035 1056 1 2 XOR2H $T=250480 628880 1 0 $X=250480 $Y=623460
X3427 1345 1349 1365 1 2 XOR2H $T=320540 638960 1 0 $X=320540 $Y=633540
X3428 2326 2222 2317 1 2 XOR2H $T=538160 608720 1 0 $X=538160 $Y=603300
X3429 951 1073 47 2 1 1050 XNR3 $T=257920 528080 1 0 $X=257920 $Y=522660
X3430 968 1294 1299 2 1 1311 XNR3 $T=315580 689360 1 0 $X=315580 $Y=683940
X3431 977 1327 1348 2 1 1324 XNR3 $T=337280 679280 1 0 $X=337280 $Y=673860
X3432 1488 1501 1477 2 1 1523 XNR3 $T=361460 628880 1 0 $X=361460 $Y=623460
X3433 1555 1564 1561 2 1 1589 XNR3 $T=373240 628880 0 0 $X=373240 $Y=628500
X3434 1644 1660 1661 2 1 1643 XNR3 $T=386260 638960 0 0 $X=386260 $Y=638580
X3435 1620 1639 1634 2 1 1674 XNR3 $T=393080 628880 0 0 $X=393080 $Y=628500
X3436 1609 1656 1666 2 1 1679 XNR3 $T=394320 659120 0 0 $X=394320 $Y=658740
X3437 1604 1677 1675 2 1 1720 XNR3 $T=407960 669200 0 0 $X=407960 $Y=668820
X3438 2256 2097 2269 2 1 2322 XNR3 $T=529480 558320 0 0 $X=529480 $Y=557940
X3439 378 2214 383 2 1 2454 XNR3 $T=569160 528080 1 0 $X=569160 $Y=522660
X3440 2525 2535 2528 2 1 2518 XNR3 $T=587140 558320 0 0 $X=587140 $Y=557940
X3441 414 2608 2602 2 1 2632 XNR3 $T=606360 578480 0 0 $X=606360 $Y=578100
X3442 436 2648 2705 2 1 2695 XNR3 $T=623720 548240 0 0 $X=623720 $Y=547860
X3443 3514 3588 3564 2 1 3608 XNR3 $T=837620 548240 1 0 $X=837620 $Y=542820
X3444 1049 1020 5 2 1007 9 1 AO22S $T=254200 588560 1 180 $X=249240 $Y=588180
X3445 1055 1067 53 2 1051 1098 1 AO22S $T=262880 578480 1 0 $X=262880 $Y=573060
X3446 1327 1117 1288 2 1222 63 1 AO22S $T=314960 669200 1 180 $X=310000 $Y=668820
X3447 1421 1342 1419 2 1411 116 1 AO22S $T=341620 578480 0 180 $X=336660 $Y=573060
X3448 1501 1486 1528 2 1533 128 1 AO22S $T=358980 638960 1 0 $X=358980 $Y=633540
X3449 1592 1342 1566 2 1515 116 1 AO22S $T=372620 548240 1 180 $X=367660 $Y=547860
X3450 1595 1342 1578 2 1498 116 1 AO22S $T=373240 568400 0 180 $X=368280 $Y=562980
X3451 1613 1342 1547 2 1511 116 1 AO22S $T=378820 548240 1 180 $X=373860 $Y=547860
X3452 1832 1827 1800 2 1817 1815 1 AO22S $T=438960 608720 0 180 $X=434000 $Y=603300
X3453 1839 1827 1798 2 1820 1815 1 AO22S $T=439580 598640 1 180 $X=434620 $Y=598260
X3454 218 1827 1836 2 1857 1815 1 AO22S $T=438960 628880 0 0 $X=438960 $Y=628500
X3455 1849 1827 1812 2 1864 1815 1 AO22S $T=440200 608720 1 0 $X=440200 $Y=603300
X3456 1867 1827 1862 2 1844 1815 1 AO22S $T=445780 598640 0 180 $X=440820 $Y=593220
X3457 232 1827 1892 2 1878 1815 1 AO22S $T=447020 618800 1 0 $X=447020 $Y=613380
X3458 1840 1827 1895 2 1900 1815 1 AO22S $T=447640 608720 0 0 $X=447640 $Y=608340
X3459 233 1827 1866 2 1807 1815 1 AO22S $T=448260 618800 0 0 $X=448260 $Y=618420
X3460 1928 1827 1907 2 1894 1815 1 AO22S $T=459420 598640 0 180 $X=454460 $Y=593220
X3461 1958 1827 1970 2 1977 1815 1 AO22S $T=463140 598640 0 0 $X=463140 $Y=598260
X3462 1989 1827 1982 2 1985 1815 1 AO22S $T=470580 598640 0 180 $X=465620 $Y=593220
X3463 1912 1827 1980 2 1971 1815 1 AO22S $T=465620 608720 0 0 $X=465620 $Y=608340
X3464 1964 1827 2024 2 2032 1815 1 AO22S $T=475540 618800 1 0 $X=475540 $Y=613380
X3465 2044 1827 2033 2 2055 1815 1 AO22S $T=481120 598640 1 0 $X=481120 $Y=593220
X3466 2099 1827 2116 2 2126 1815 1 AO22S $T=495380 618800 1 0 $X=495380 $Y=613380
X3467 2163 287 2100 2 2107 284 1 AO22S $T=504680 558320 0 180 $X=499720 $Y=552900
X3468 2111 1827 2088 2 2105 1815 1 AO22S $T=506540 598640 1 180 $X=501580 $Y=598260
X3469 550 438 3005 2 3000 443 1 AO22S $T=698120 689360 0 180 $X=693160 $Y=683940
X3470 2973 3031 3030 2 3037 3049 1 AO22S $T=702460 548240 1 0 $X=702460 $Y=542820
X3471 2966 3031 3040 2 3042 3049 1 AO22S $T=703080 558320 1 0 $X=703080 $Y=552900
X3472 2978 3031 3045 2 3052 3049 1 AO22S $T=704940 558320 0 0 $X=704940 $Y=557940
X3473 2974 3031 3020 2 3050 3049 1 AO22S $T=704940 568400 0 0 $X=704940 $Y=568020
X3474 2993 3031 3070 2 3081 3049 1 AO22S $T=711760 578480 0 0 $X=711760 $Y=578100
X3475 3009 3031 3101 2 3110 3049 1 AO22S $T=717960 578480 0 0 $X=717960 $Y=578100
X3476 3017 3031 3134 2 3140 3049 1 AO22S $T=724160 578480 0 0 $X=724160 $Y=578100
X3477 3277 3031 3301 2 3309 3049 1 AO22S $T=765700 578480 0 0 $X=765700 $Y=578100
X3478 630 632 3323 2 596 635 1 AO22P $T=777480 669200 0 0 $X=777480 $Y=668820
X3479 3336 637 3323 2 596 3379 1 AO22P $T=782440 689360 1 0 $X=782440 $Y=683940
X3480 3363 644 3323 2 596 3393 1 AO22P $T=787400 669200 0 0 $X=787400 $Y=668820
X3481 3359 3323 646 2 596 3404 1 AO22P $T=789880 679280 0 0 $X=789880 $Y=678900
X3482 3360 606 3348 3333 2 1 MXL2HS $T=782440 528080 0 0 $X=782440 $Y=527700
X3483 3366 598 3412 3341 2 1 MXL2HS $T=792980 538160 0 0 $X=792980 $Y=537780
X3484 3341 626 1 568 2 NR2T $T=776860 538160 1 0 $X=776860 $Y=532740
X3485 3366 638 1 568 2 NR2T $T=781820 538160 1 0 $X=781820 $Y=532740
X3486 3456 3356 1 3409 2 NR2T $T=802900 548240 0 180 $X=797940 $Y=542820
X3487 3383 2 3374 3276 1 AN2B1S $T=790500 679280 0 180 $X=787400 $Y=673860
X3488 1784 1804 1768 1 2 1819 OA12 $T=430280 608720 0 0 $X=430280 $Y=608340
X3489 1906 1925 247 1 2 1952 OA12 $T=456940 538160 1 0 $X=456940 $Y=532740
X3490 2213 2186 2151 1 2 2190 OA12 $T=512740 628880 1 180 $X=509020 $Y=628500
X3491 2362 2375 2374 1 2 2391 OA12 $T=548700 608720 0 0 $X=548700 $Y=608340
X3492 2829 2871 501 1 2 2866 OA12 $T=662780 568400 0 0 $X=662780 $Y=568020
X3493 2965 2975 2971 1 2 2984 OA12 $T=685720 659120 0 0 $X=685720 $Y=658740
X3494 3382 3408 3401 1 2 3340 OA12 $T=797320 649040 1 180 $X=793600 $Y=648660
X3495 3049 656 3426 1 2 678 OA12 $T=822120 528080 1 0 $X=822120 $Y=522660
X3496 3323 627 1 3323 3324 3320 2 MOAI1H $T=779340 679280 1 180 $X=771900 $Y=678900
X3497 610 3335 1 610 622 619 2 MOAI1H $T=779960 618800 1 180 $X=772520 $Y=618420
X3498 3323 624 1 610 3316 3355 2 MOAI1H $T=773760 638960 1 0 $X=773760 $Y=633540
X3499 3455 3463 1 3482 2 OR2B1S $T=802900 548240 0 0 $X=802900 $Y=547860
X3500 3680 3674 710 3668 1 2 3617 AO13S $T=855600 669200 1 180 $X=851260 $Y=668820
X3501 165 126 1 2 INV4 $T=370760 608720 1 180 $X=367660 $Y=608340
X3502 165 433 1 2 INV4 $T=617520 608720 0 180 $X=614420 $Y=603300
X3503 3305 3284 1 2 INV4 $T=766320 669200 0 180 $X=763220 $Y=663780
X3504 3314 614 1 2 INV4 $T=771280 618800 1 180 $X=768180 $Y=618420
X3505 630 618 1 2 INV4 $T=774380 669200 0 0 $X=774380 $Y=668820
X3506 625 629 1 2 INV4 $T=775620 679280 1 0 $X=775620 $Y=673860
X3507 3292 3319 1 2 INV4 $T=778100 659120 0 0 $X=778100 $Y=658740
X3508 3613 603 1 2 INV4 $T=838240 689360 1 0 $X=838240 $Y=683940
X3509 1808 1774 1792 1 2 1789 AO12 $T=432760 578480 0 180 $X=429040 $Y=573060
X3510 1808 1775 1792 1 2 1797 AO12 $T=437720 578480 0 180 $X=434000 $Y=573060
X3511 1808 1816 1792 1 2 1809 AO12 $T=439580 588560 1 180 $X=435860 $Y=588180
X3512 1808 1869 1792 1 2 1875 AO12 $T=450740 578480 1 180 $X=447020 $Y=578100
X3513 1808 1850 1792 1 2 1896 AO12 $T=447640 588560 0 0 $X=447640 $Y=588180
X3514 1808 1787 1792 1 2 1968 AO12 $T=460660 598640 1 0 $X=460660 $Y=593220
X3515 1808 1794 1792 1 2 2002 AO12 $T=470580 588560 1 0 $X=470580 $Y=583140
X3516 1808 2007 1792 1 2 2014 AO12 $T=471820 598640 1 0 $X=471820 $Y=593220
X3517 1808 1981 1792 1 2 2030 AO12 $T=474920 588560 1 0 $X=474920 $Y=583140
X3518 1808 1944 1792 1 2 2012 AO12 $T=475540 578480 0 0 $X=475540 $Y=578100
X3519 2157 2106 2143 1 2 2134 AO12 $T=502820 628880 0 180 $X=499100 $Y=623460
X3520 2157 2078 2143 1 2 2179 AO12 $T=503440 628880 1 0 $X=503440 $Y=623460
X3521 2157 2039 2143 1 2 2572 AO12 $T=589000 628880 1 0 $X=589000 $Y=623460
X3522 2157 2616 2143 1 2 2639 AO12 $T=603880 628880 1 0 $X=603880 $Y=623460
X3523 2157 2036 2143 1 2 2675 AO12 $T=613180 649040 0 0 $X=613180 $Y=648660
X3524 2157 2104 2143 1 2 2689 AO12 $T=616900 649040 1 0 $X=616900 $Y=643620
X3525 2157 2018 2143 1 2 2692 AO12 $T=617520 649040 0 0 $X=617520 $Y=648660
X3526 2157 2079 2143 1 2 2703 AO12 $T=621240 638960 0 0 $X=621240 $Y=638580
X3527 2157 2696 2143 1 2 2704 AO12 $T=621240 649040 1 0 $X=621240 $Y=643620
X3528 2157 2554 2143 1 2 2715 AO12 $T=621860 649040 0 0 $X=621860 $Y=648660
X3529 440 427 444 1 2 2725 AO12 $T=626200 689360 0 0 $X=626200 $Y=688980
X3530 440 431 444 1 2 2731 AO12 $T=634880 689360 0 180 $X=631160 $Y=683940
X3531 440 448 444 1 2 2761 AO12 $T=638600 689360 1 0 $X=638600 $Y=683940
X3532 440 467 444 1 2 2742 AO12 $T=639840 689360 0 0 $X=639840 $Y=688980
X3533 440 475 444 1 2 2780 AO12 $T=643560 689360 0 0 $X=643560 $Y=688980
X3534 440 479 444 1 2 2796 AO12 $T=647280 689360 0 0 $X=647280 $Y=688980
X3535 440 482 444 1 2 2817 AO12 $T=651000 689360 0 0 $X=651000 $Y=688980
X3536 541 495 545 1 2 2994 AO12 $T=690060 689360 0 0 $X=690060 $Y=688980
X3537 541 2894 545 1 2 3014 AO12 $T=698740 689360 0 0 $X=698740 $Y=688980
X3538 541 559 545 1 2 3074 AO12 $T=708660 689360 1 0 $X=708660 $Y=683940
X3539 541 571 545 1 2 3117 AO12 $T=720440 689360 0 0 $X=720440 $Y=688980
X3540 541 572 545 1 2 3141 AO12 $T=724160 689360 0 0 $X=724160 $Y=688980
X3541 541 577 545 1 2 3133 AO12 $T=732220 689360 1 180 $X=728500 $Y=688980
X3542 3505 1853 1843 1 2 3529 AO12 $T=814060 618800 1 0 $X=814060 $Y=613380
X3543 1853 3521 3466 1 2 3612 AO12 $T=834520 618800 0 0 $X=834520 $Y=618420
X3544 3276 1853 2 268 1 599 AN3B2S $T=761360 679280 0 180 $X=757640 $Y=673860
X3545 2094 1952 1939 2 1 2080 OR3S $T=494140 578480 0 180 $X=490420 $Y=573060
X3546 2094 2391 2404 2 1 2469 OR3S $T=567920 608720 0 0 $X=567920 $Y=608340
X3547 2094 2866 2848 2 1 2878 OR3S $T=662160 588560 1 0 $X=662160 $Y=583140
X3548 2094 2984 2959 2 1 3008 OR3S $T=692540 659120 1 0 $X=692540 $Y=653700
X3549 3597 3621 3586 3563 2 1 3542 XOR4 $T=841340 608720 0 180 $X=826460 $Y=603300
X3550 3627 3649 3658 3465 2 1 3483 XOR4 $T=840720 628880 1 0 $X=840720 $Y=623460
X3551 719 3702 753 3740 2 1 730 XOR4 $T=870480 649040 1 0 $X=870480 $Y=643620
X3552 1853 3518 3476 1 2 3599 AO12S $T=830180 618800 1 0 $X=830180 $Y=613380
X3553 1853 3530 3457 1 2 3597 AO12S $T=830800 628880 1 0 $X=830800 $Y=623460
X3554 596 610 1 2 INV8 $T=770660 669200 1 180 $X=764460 $Y=668820
X3555 609 3324 1 2 INV8 $T=773140 689360 0 180 $X=766940 $Y=683940
X3556 612 3316 1 2 INV8 $T=773760 638960 0 180 $X=767560 $Y=633540
X3557 626 3336 1 2 INV8 $T=780580 689360 0 180 $X=774380 $Y=683940
X3558 643 3343 1 2 INV8 $T=784300 649040 1 0 $X=784300 $Y=643620
X3559 3483 3658 1 2 3653 OR2B1 $T=846300 618800 1 0 $X=846300 $Y=613380
X3560 1631 1 2 1638 1655 1673 859 ICV_18 $T=381920 598640 1 0 $X=381920 $Y=593220
X3561 1715 1 2 1734 1702 1762 859 ICV_18 $T=405480 578480 0 0 $X=405480 $Y=578100
X3562 1897 1 2 1963 1911 1974 859 ICV_18 $T=458800 638960 1 0 $X=458800 $Y=633540
X3563 2120 1 2 2127 2181 2208 859 ICV_18 $T=517080 649040 0 0 $X=517080 $Y=648660
X3564 2272 1 2 2296 2299 2297 859 ICV_18 $T=525760 578480 0 0 $X=525760 $Y=578100
X3565 2659 1 2 2673 2677 2680 859 ICV_18 $T=611940 608720 0 0 $X=611940 $Y=608340
X3566 2704 1 2 2756 2715 2767 859 ICV_18 $T=638600 638960 0 0 $X=638600 $Y=638580
X3567 3234 1 2 3219 3254 3235 859 ICV_18 $T=750200 628880 0 0 $X=750200 $Y=628500
X3568 3907 1 2 3928 3932 3941 859 ICV_18 $T=934960 638960 0 0 $X=934960 $Y=638580
X3569 3929 1 2 3743 3942 3957 859 ICV_18 $T=939300 538160 0 0 $X=939300 $Y=537780
X3570 3940 1 2 3951 3954 3956 859 ICV_18 $T=943640 649040 1 0 $X=943640 $Y=643620
X3571 3955 1 2 3763 3990 3989 859 ICV_18 $T=949220 578480 1 0 $X=949220 $Y=573060
X3572 4015 1 2 4025 4006 4011 859 ICV_18 $T=959140 669200 0 0 $X=959140 $Y=668820
X3573 4079 1 2 811 4054 813 859 ICV_18 $T=977120 669200 1 0 $X=977120 $Y=663780
X3574 1567 1252 1570 1 2 1550 XOR3T $T=373240 618800 0 0 $X=373240 $Y=618420
X3575 1365 1431 1056 1 2 XNR2H $T=333560 618800 1 0 $X=333560 $Y=613380
X3576 1407 1451 1431 1 2 XNR2H $T=339140 608720 0 0 $X=339140 $Y=608340
X3577 539 2909 2995 1 2 XNR2H $T=686340 538160 1 0 $X=686340 $Y=532740
X3578 1648 1372 1667 1701 1 2 XOR3P $T=386260 638960 1 0 $X=386260 $Y=633540
X3579 1646 1380 1642 1653 1 2 XOR3P $T=388740 628880 1 0 $X=388740 $Y=623460
X3580 1680 1472 1713 1759 1 2 XOR3P $T=407340 649040 1 0 $X=407340 $Y=643620
X3581 3090 566 3107 3145 1 2 XOR3P $T=716720 598640 0 0 $X=716720 $Y=598260
X3582 1568 1576 1579 1569 1 2 1563 AO13 $T=368280 598640 0 0 $X=368280 $Y=598260
X3583 3551 3555 3556 3559 1 2 3534 AO13 $T=822740 588560 0 0 $X=822740 $Y=588180
X3584 2853 319 433 2 1 2905 QDFFRBS $T=660920 538160 1 0 $X=660920 $Y=532740
X3585 3642 3578 1 3653 701 3594 2 OAI22H $T=842580 588560 1 0 $X=842580 $Y=583140
X3586 3642 2904 1 3653 702 3643 2 OAI22H $T=842580 588560 0 0 $X=842580 $Y=588180
X3587 2904 3648 1 3643 3659 3660 2 OAI22H $T=842580 598640 1 0 $X=842580 $Y=593220
X3588 3642 3580 1 3653 703 3445 2 OAI22H $T=842580 608720 0 0 $X=842580 $Y=608340
X3589 2890 3648 1 3655 3665 3660 2 OAI22H $T=846920 578480 1 0 $X=846920 $Y=573060
X3590 2791 3648 1 3623 3677 3660 2 OAI22H $T=850020 558320 0 0 $X=850020 $Y=557940
X3591 3580 3648 1 3445 3678 3660 2 OAI22H $T=850020 608720 0 0 $X=850020 $Y=608340
X3592 3578 3648 1 3594 3685 3660 2 OAI22H $T=851260 588560 1 0 $X=851260 $Y=583140
X3593 3569 3648 1 3573 3686 3660 2 OAI22H $T=851260 588560 0 0 $X=851260 $Y=588180
X3594 3642 3569 1 3653 711 3573 2 OAI22H $T=851260 598640 1 0 $X=851260 $Y=593220
X3595 3642 2890 1 3653 712 3655 2 OAI22H $T=853120 568400 0 0 $X=853120 $Y=568020
X3596 2769 3648 1 3669 3700 3660 2 OAI22H $T=854360 568400 1 0 $X=854360 $Y=562980
X3597 3034 3648 1 3691 3701 3660 2 OAI22H $T=854360 628880 0 0 $X=854360 $Y=628500
X3598 2962 3648 1 3679 714 3660 2 OAI22H $T=854980 638960 1 0 $X=854980 $Y=633540
X3599 3642 3625 1 3653 717 3561 2 OAI22H $T=856220 578480 0 0 $X=856220 $Y=578100
X3600 3642 3034 1 3653 718 3691 2 OAI22H $T=856220 618800 0 0 $X=856220 $Y=618420
X3601 2891 3648 1 3638 3714 3660 2 OAI22H $T=858700 598640 1 0 $X=858700 $Y=593220
X3602 3642 2962 1 3653 722 3666 2 OAI22H $T=858700 608720 0 0 $X=858700 $Y=608340
X3603 3642 2891 1 3653 725 3638 2 OAI22H $T=859940 588560 1 0 $X=859940 $Y=583140
X3604 3642 2769 1 3653 724 3669 2 OAI22H $T=861180 558320 1 0 $X=861180 $Y=552900
X3605 3642 2760 1 3653 728 3637 2 OAI22H $T=861180 568400 0 0 $X=861180 $Y=568020
X3606 3642 3494 1 3653 721 3671 2 OAI22H $T=861180 628880 1 0 $X=861180 $Y=623460
X3607 3642 2791 1 3653 727 3623 2 OAI22H $T=861800 548240 0 0 $X=861800 $Y=547860
X3608 3642 2774 1 3653 731 3611 2 OAI22H $T=863040 568400 1 0 $X=863040 $Y=562980
X3609 2912 3648 1 3716 3718 3660 2 OAI22H $T=863040 628880 0 0 $X=863040 $Y=628500
X3610 3642 2828 1 3653 733 3584 2 OAI22H $T=863660 548240 1 0 $X=863660 $Y=542820
X3611 3494 3648 1 3719 3720 3660 2 OAI22H $T=863660 638960 1 0 $X=863660 $Y=633540
X3612 3625 3648 1 3561 736 3660 2 OAI22H $T=864900 578480 0 0 $X=864900 $Y=578100
X3613 3642 2912 1 3653 729 3670 2 OAI22H $T=872340 618800 1 180 $X=864900 $Y=618420
X3614 3642 3557 1 3653 739 3663 2 OAI22H $T=867380 598640 1 0 $X=867380 $Y=593220
X3615 3642 2895 1 3653 743 3624 2 OAI22H $T=869240 568400 0 0 $X=869240 $Y=568020
X3616 3642 2821 1 3653 744 3572 2 OAI22H $T=869240 578480 1 0 $X=869240 $Y=573060
X3617 2834 3648 1 3633 740 3660 2 OAI22H $T=869860 558320 1 0 $X=869860 $Y=552900
X3618 3642 2901 1 3653 741 3704 2 OAI22H $T=869860 628880 1 0 $X=869860 $Y=623460
X3619 3642 2834 1 3653 746 3633 2 OAI22H $T=870480 548240 0 0 $X=870480 $Y=547860
X3620 2774 3648 1 3611 747 3660 2 OAI22H $T=871720 558320 0 0 $X=871720 $Y=557940
X3621 3642 2910 1 3653 748 3715 2 OAI22H $T=871720 608720 0 0 $X=871720 $Y=608340
X3622 2910 3648 1 3715 749 3660 2 OAI22H $T=871720 628880 0 0 $X=871720 $Y=628500
X3623 2901 3648 1 3704 3729 3660 2 OAI22H $T=872340 638960 1 0 $X=872340 $Y=633540
X3624 2821 3648 1 3572 3733 3660 2 OAI22H $T=873580 578480 0 0 $X=873580 $Y=578100
X3625 3557 3648 1 3663 754 3660 2 OAI22H $T=875440 598640 1 0 $X=875440 $Y=593220
X3626 2828 3648 1 3584 757 3660 2 OAI22H $T=877920 558320 1 0 $X=877920 $Y=552900
X3627 2760 3648 1 3637 3737 3660 2 OAI22H $T=877920 568400 0 0 $X=877920 $Y=568020
X3628 2895 3648 1 3624 3738 3660 2 OAI22H $T=877920 578480 1 0 $X=877920 $Y=573060
X3629 652 3498 3467 1 2 3468 HA1 $T=812820 679280 1 180 $X=804760 $Y=678900
X3630 3505 3516 3560 1 2 3565 HA1 $T=819020 638960 0 0 $X=819020 $Y=638580
X3631 663 3554 3498 1 2 3527 HA1 $T=828320 679280 0 180 $X=820260 $Y=673860
X3632 668 3574 3554 1 2 3535 HA1 $T=830180 669200 1 180 $X=822120 $Y=668820
X3633 3530 3560 3602 1 2 3593 HA1 $T=827700 649040 0 0 $X=827700 $Y=648660
X3634 3518 3639 3574 1 2 3603 HA1 $T=843200 659120 0 180 $X=835140 $Y=653700
X3635 3521 3602 3639 1 2 3641 HA1 $T=838240 649040 0 0 $X=838240 $Y=648660
X3636 3674 3688 3684 1 2 3676 HA1 $T=863040 679280 1 180 $X=854980 $Y=678900
X3637 3694 3711 3724 1 2 3722 HA1 $T=862420 669200 0 0 $X=862420 $Y=668820
X3638 710 3684 3711 1 2 3713 HA1 $T=872960 679280 1 180 $X=864900 $Y=678900
X3639 3698 3724 3690 1 2 3710 HA1 $T=873580 659120 0 180 $X=865520 $Y=653700
X3640 1738 1 2 1752 1754 1768 859 ICV_20 $T=411060 608720 1 0 $X=411060 $Y=603300
X3641 1751 1 2 1764 1749 1780 859 ICV_20 $T=414780 618800 0 0 $X=414780 $Y=618420
X3642 1796 1 2 1816 1799 1850 859 ICV_20 $T=429040 558320 0 0 $X=429040 $Y=557940
X3643 219 1 2 1856 227 1877 859 ICV_20 $T=440200 538160 0 0 $X=440200 $Y=537780
X3644 1899 1 2 1910 234 1918 859 ICV_20 $T=450120 538160 0 0 $X=450120 $Y=537780
X3645 256 1 2 1923 240 1953 859 ICV_20 $T=461900 568400 1 0 $X=461900 $Y=562980
X3646 247 1 2 1967 236 1961 859 ICV_20 $T=463760 538160 1 0 $X=463760 $Y=532740
X3647 1998 1 2 2015 1994 2039 859 ICV_20 $T=470580 638960 0 0 $X=470580 $Y=638580
X3648 2068 1 2 2152 2149 2194 859 ICV_20 $T=498480 659120 1 0 $X=498480 $Y=653700
X3649 2480 1 2 2489 2493 2521 859 ICV_20 $T=582800 598640 0 0 $X=582800 $Y=598260
X3650 2721 1 2 2723 2701 2757 859 ICV_20 $T=631780 618800 1 0 $X=631780 $Y=613380
X3651 458 1 2 2758 466 2765 859 ICV_20 $T=635500 578480 0 0 $X=635500 $Y=578100
X3652 478 1 2 2778 483 495 859 ICV_20 $T=647280 689360 1 0 $X=647280 $Y=683940
X3653 2905 1 2 2918 531 2748 859 ICV_20 $T=677040 578480 0 0 $X=677040 $Y=578100
X3654 3056 1 2 3033 3087 3111 859 ICV_20 $T=711140 628880 0 0 $X=711140 $Y=628500
X3655 3120 1 2 3138 3130 3150 859 ICV_20 $T=726640 628880 0 0 $X=726640 $Y=628500
X3656 649 1 2 3396 651 653 859 ICV_20 $T=794220 689360 0 0 $X=794220 $Y=688980
X3657 715 1 2 3674 3707 735 859 ICV_20 $T=859940 689360 0 0 $X=859940 $Y=688980
X3658 1057 1069 1061 2 1 1136 1061 1057 1069 1035 859 ICV_21 $T=256060 618800 1 0 $X=256060 $Y=613380
X3659 940 1063 1066 2 1 1145 1066 940 1063 1085 859 ICV_21 $T=257300 538160 1 0 $X=257300 $Y=532740
X3660 1095 1089 1104 2 1 1187 1104 1095 1089 1099 859 ICV_21 $T=264120 608720 0 0 $X=264120 $Y=608340
X3661 1004 1190 1198 2 1 1283 1198 1004 1190 1199 859 ICV_21 $T=282720 598640 0 0 $X=282720 $Y=598260
X3662 980 1217 1221 2 1 1252 1199 990 1155 1104 859 ICV_21 $T=282720 608720 1 0 $X=282720 $Y=603300
X3663 1044 1208 1204 2 1 1267 1204 1044 1208 1061 859 ICV_21 $T=283960 618800 1 0 $X=283960 $Y=613380
X3664 957 1164 1085 2 1 1271 1085 957 1164 1218 859 ICV_21 $T=285200 548240 0 0 $X=285200 $Y=547860
X3665 963 1226 1229 2 1 1298 1229 963 1226 1211 859 ICV_21 $T=292640 588560 1 0 $X=292640 $Y=583140
X3666 959 1223 1238 2 1 1353 1238 959 1223 1229 859 ICV_21 $T=294500 578480 0 0 $X=294500 $Y=578100
X3667 938 102 105 2 1 118 105 938 102 1299 859 ICV_21 $T=306900 689360 0 0 $X=306900 $Y=688980
X3668 986 1280 1301 2 1 1380 1301 986 1280 1221 859 ICV_21 $T=310000 628880 1 0 $X=310000 $Y=623460
X3669 958 1309 1303 2 1 1381 1303 958 1309 1323 859 ICV_21 $T=310620 659120 0 0 $X=310620 $Y=658740
X3670 945 1325 1335 2 1 1463 1335 945 1325 1326 859 ICV_21 $T=317440 638960 0 0 $X=317440 $Y=638580
X3671 950 1315 1343 2 1 1472 1343 950 1315 1335 859 ICV_21 $T=318680 649040 1 0 $X=318680 $Y=643620
X3672 1389 1136 1393 2 1 1390 1393 1389 1136 1407 859 ICV_21 $T=329840 628880 1 0 $X=329840 $Y=623460
X3673 1421 1435 1426 2 1 1436 1426 1421 1435 1347 859 ICV_21 $T=337280 588560 0 0 $X=337280 $Y=588180
X3674 1462 1283 1464 2 1 1538 1464 1462 1283 1396 859 ICV_21 $T=346580 598640 0 0 $X=346580 $Y=598260
X3675 1471 1267 1475 2 1 1539 1475 1471 1267 1393 859 ICV_21 $T=348440 618800 0 0 $X=348440 $Y=618420
X3676 1613 1623 1617 2 1 1668 1617 1613 1623 1628 859 ICV_21 $T=376340 548240 1 0 $X=376340 $Y=542820
X3677 1616 1353 1626 2 1 1685 1626 1616 1353 1633 859 ICV_21 $T=377580 578480 0 0 $X=377580 $Y=578100
X3678 1678 1271 1686 2 1 1746 1686 1678 1271 1684 859 ICV_21 $T=393080 548240 0 0 $X=393080 $Y=547860
X3679 1712 1317 184 2 1 1769 184 1712 1317 1725 859 ICV_21 $T=403620 689360 0 0 $X=403620 $Y=688980
X3680 2291 2301 2294 2 1 2250 2294 2291 2301 2204 859 ICV_21 $T=528240 588560 1 0 $X=528240 $Y=583140
X3681 2319 2074 2320 2 1 2395 2320 2319 2074 2264 859 ICV_21 $T=535060 558320 1 0 $X=535060 $Y=552900
X3682 2409 2191 2416 2 1 2482 2416 2409 2191 2410 859 ICV_21 $T=556760 538160 1 0 $X=556760 $Y=532740
X3683 2420 2395 2423 2 1 2428 2423 2420 2395 2344 859 ICV_21 $T=559240 568400 1 0 $X=559240 $Y=562980
X3684 2429 2417 2435 2 1 2481 2435 2429 2417 2423 859 ICV_21 $T=561720 558320 0 0 $X=561720 $Y=557940
X3685 2966 2956 2969 2 1 2925 2969 2966 2956 2977 859 ICV_21 $T=684480 558320 1 0 $X=684480 $Y=552900
X3686 2973 2954 2977 2 1 2957 2977 2973 2954 2845 859 ICV_21 $T=685720 548240 0 0 $X=685720 $Y=547860
X3687 2974 2983 2979 2 1 2903 2979 2974 2983 2982 859 ICV_21 $T=685720 568400 0 0 $X=685720 $Y=568020
X3688 2978 2985 2982 2 1 2917 2982 2978 2985 2969 859 ICV_21 $T=686340 558320 0 0 $X=686340 $Y=557940
X3689 546 547 2998 2 1 2986 2998 546 547 540 859 ICV_21 $T=692540 528080 1 0 $X=692540 $Y=522660
X3690 3009 3006 3011 2 1 2976 3011 3009 3006 3002 859 ICV_21 $T=695020 588560 1 0 $X=695020 $Y=583140
X3691 3017 3018 3019 2 1 3079 3019 3017 3018 3011 859 ICV_21 $T=697500 588560 0 0 $X=697500 $Y=588180
X3692 3277 3228 3280 2 1 3303 3280 3277 3228 3291 859 ICV_21 $T=759500 588560 0 0 $X=759500 $Y=588180
X3693 3286 3278 3291 2 1 3290 3291 3286 3278 3249 859 ICV_21 $T=761360 588560 1 0 $X=761360 $Y=583140
X3694 3471 657 3474 2 1 3543 3474 3471 657 3435 859 ICV_21 $T=804140 598640 1 0 $X=804140 $Y=593220
X3695 3490 3528 3524 2 1 3598 3524 3490 3528 3504 859 ICV_21 $T=814060 568400 1 0 $X=814060 $Y=562980
X3696 3589 700 3654 2 1 3692 3654 3589 700 667 859 ICV_21 $T=844440 538160 0 0 $X=844440 $Y=537780
X3697 3363 617 1 2 INV6 $T=784300 649040 0 0 $X=784300 $Y=648660
X3698 3591 616 1 2 INV6 $T=835140 669200 1 0 $X=835140 $Y=663780
X3699 3596 3604 1 3615 3564 3620 2 OAI112H $T=833280 538160 0 0 $X=833280 $Y=537780
X3700 3579 3585 3590 3576 3556 1 2 AO13P $T=830180 588560 0 0 $X=830180 $Y=588180
X3701 3433 3412 3409 3462 1 2 NR3HP $T=825840 558320 1 0 $X=825840 $Y=552900
X3702 3463 3456 3426 3433 2 1 NR3H $T=816540 538160 0 0 $X=816540 $Y=537780
X3703 641 1795 4373 1 2 3428 DFFN $T=786160 628880 0 0 $X=786160 $Y=628500
X3704 3270 3255 563 3305 3362 1 2 DFFRBP $T=757640 649040 0 0 $X=757640 $Y=648660
X3705 3399 3255 563 3295 3371 1 2 DFFRBP $T=799180 669200 0 180 $X=784920 $Y=663780
X3706 638 3359 1 2 INV12 $T=781200 679280 0 0 $X=781200 $Y=678900
X3707 610 634 1 3323 3343 3310 2 MOAI1HT $T=785540 638960 1 180 $X=766940 $Y=638580
X3708 3315 1 2 610 BUF12CK $T=778100 649040 0 180 $X=765700 $Y=643620
X3709 26 11 2 971 1 911 25 11 970 933 859 ICV_22 $T=241180 669200 0 180 $X=236840 $Y=663780
X3710 31 11 2 974 1 931 33 17 978 23 859 ICV_22 $T=243660 528080 0 180 $X=239320 $Y=522660
X3711 38 37 2 1003 1 32 39 37 1002 28 859 ICV_22 $T=249240 528080 0 180 $X=244900 $Y=522660
X3712 1062 43 2 1072 1 1037 1072 43 1071 1030 859 ICV_22 $T=262880 679280 0 180 $X=258540 $Y=673860
X3713 1116 57 2 1087 1 1114 66 57 1116 1111 859 ICV_22 $T=272180 558320 0 180 $X=267840 $Y=552900
X3714 1118 61 2 1101 1 1140 1101 61 1124 1144 859 ICV_22 $T=269700 679280 1 0 $X=269700 $Y=673860
X3715 1126 61 2 1123 1 1159 1123 61 1120 1147 859 ICV_22 $T=270320 649040 1 0 $X=270320 $Y=643620
X3716 1124 61 2 1128 1 1171 1128 61 1127 1148 859 ICV_22 $T=270320 669200 1 0 $X=270320 $Y=663780
X3717 1148 69 2 1159 1 1182 1160 69 1147 1178 859 ICV_22 $T=276520 659120 1 0 $X=276520 $Y=653700
X3718 72 70 2 1200 1 78 1176 70 1182 1209 859 ICV_22 $T=281480 679280 1 0 $X=281480 $Y=673860
X3719 1178 70 2 1129 1 1228 1192 70 1129 1227 859 ICV_22 $T=288300 659120 1 0 $X=288300 $Y=653700
X3720 92 57 2 1228 1 1250 80 57 1227 1246 859 ICV_22 $T=294500 659120 1 0 $X=294500 $Y=653700
X3721 1369 119 2 1373 1 1423 124 119 1369 1430 859 ICV_22 $T=334800 528080 1 0 $X=334800 $Y=522660
X3722 122 127 2 1410 1 1448 129 127 1423 134 859 ICV_22 $T=340380 528080 1 0 $X=340380 $Y=522660
X3723 136 127 2 1402 1 144 133 127 1430 141 859 ICV_22 $T=345960 528080 1 0 $X=345960 $Y=522660
X3724 158 1506 2 1535 1 1574 151 1506 1497 1581 859 ICV_22 $T=363940 669200 1 0 $X=363940 $Y=663780
X3725 3171 3109 2 3148 1 3081 3165 574 3089 3148 859 ICV_22 $T=733460 558320 0 180 $X=729120 $Y=552900
X3726 3225 3109 2 3174 1 3110 3159 574 3089 3174 859 ICV_22 $T=739660 558320 0 180 $X=735320 $Y=552900
X3727 1939 2087 2 2103 1952 1 OR3B2S $T=497860 568400 1 180 $X=494140 $Y=568020
X3728 2404 2087 2 2418 2391 1 OR3B2S $T=561100 608720 1 180 $X=557380 $Y=608340
X3729 2156 2170 2164 1 2 XOR2HT $T=501580 608720 0 0 $X=501580 $Y=608340
.ENDS
***************************************
.SUBCKT ICV_24 1 2 3 4 5 6 7 8 9
** N=9 EP=9 IP=12 FDC=0
X0 1 2 3 4 5 NR2 $T=0 0 0 0 $X=0 $Y=-380
X1 6 2 7 8 5 NR2 $T=1860 0 0 0 $X=1860 $Y=-380
.ENDS
***************************************
.SUBCKT ICV_25 1 2 3 4 5 6 7 8
** N=8 EP=8 IP=12 FDC=0
X0 2 3 4 1 INV2 $T=0 0 0 0 $X=0 $Y=-380
X1 5 6 7 1 4 2 XNR3 $T=1860 0 0 0 $X=1860 $Y=-380
.ENDS
***************************************
.SUBCKT AO12T B2 B1 A1 GND VCC O
** N=7 EP=6 IP=0 FDC=0
.ENDS
***************************************
.SUBCKT NR4 I3 I4 I2 I1 VCC GND O
** N=8 EP=7 IP=0 FDC=0
.ENDS
***************************************
.SUBCKT ICV_26 1 2 3 4 5 6 7 8 9
** N=9 EP=9 IP=12 FDC=0
X0 1 2 3 4 5 NR2 $T=0 0 1 0 $X=0 $Y=-5420
X1 6 2 7 8 5 NR2 $T=0 0 0 0 $X=0 $Y=-380
.ENDS
***************************************
.SUBCKT OR2T I2 I1 GND O VCC
** N=6 EP=5 IP=0 FDC=0
.ENDS
***************************************
.SUBCKT AN3B1 B1 I2 I1 GND VCC O
** N=7 EP=6 IP=0 FDC=0
.ENDS
***************************************
.SUBCKT MOAI1HP B2 B1 GND A1 O A2 VCC
** N=8 EP=7 IP=0 FDC=0
.ENDS
***************************************
.SUBCKT QDFFRBT D CK RB GND VCC Q
** N=7 EP=6 IP=0 FDC=0
.ENDS
***************************************
.SUBCKT NR2F I1 VCC GND I2 O
** N=6 EP=5 IP=0 FDC=0
.ENDS
***************************************
.SUBCKT XNR2HT I2 O I1 GND VCC
** N=6 EP=5 IP=0 FDC=0
.ENDS
***************************************
.SUBCKT AN4B1 I3 I2 I1 O B1 GND VCC
** N=8 EP=7 IP=0 FDC=0
.ENDS
***************************************
.SUBCKT BUF6 I O GND VCC
** N=5 EP=4 IP=0 FDC=0
.ENDS
***************************************
.SUBCKT ICV_27 1 2 3 4 5 6 7 8 9 10 11 12 13 14 15 16 17 18 19 20
+ 21 22 23 24 25 26 27 28 29 30 31 32 33 34 35 36 37 38 39 40
+ 41 42 43 44 45 46 47 48 49 50 51 52 53 54 55 56 57 58 59 60
+ 61 62 63 64 65 66 67 68 69 70 71 72 73 74 75 76 77 78 79 80
+ 81 82 83 84 85 86 87 88 89 90 91 92 93 94 95 96 97 98 99 100
+ 101 102 103 104 105 106 107 108 109 110 111 112 113 114 115 116 117 118 119 120
+ 121 122 123 124 125 126 127 128 129 130 131 132 133 134 135 136 137 138 139 140
+ 141 142 143 144 145 146 147 148 149 150 151 152 153 154 155 156 157 158 159 160
+ 161 162 163 164 165 166 167 168 169 170 171 172 173 174 175 176 177 178 179 180
+ 181 182 183 184 185 186 187 188 189 190 191 192 193 194 195 196 197 198 199 200
+ 201 202 203 204 205 206 207 208 209 210 211 212 213 214 215 216 217 218 219 220
+ 221 222 223 224 225 226 227 228 229 230 231 232 233 234 235 236 237 238 239 240
+ 241 242 243 244 245 246 247 248 249 250 251 252 253 254 255 256 257 258 259 260
+ 261 262 263 264 265 266 267 268 269 270 271 272 273 274 275 276 277 278 279 280
+ 281 282 283 284 285 286 287 288 289 290 291 292 293 294 295 296 297 298 299 300
+ 301 302 303 304 305 306 307 308 309 310 311 312 313 314 315 316 317 318 319 320
+ 321 322 323 324 325 326 327 328 329 330 331 332 333 334 335 336 337 338 339 340
+ 341 342 343 344 345 346 347 348 349 350 351 352 353 354 355 356 357 358 359 360
+ 361 362 363 364 365 366 367 368 369 370 371 372 373 374 375 376 377 378 379 380
+ 381 382 383 384 385 386 387 388 389 390 391 392 393 394 395 396 397 398 399 400
+ 401 402 403 404 405 406 407 408 409 410 411 412 413 414 415 416 417 418 419 420
+ 421 422 423 424 425 426 427 428 429 430 431 432 433 434 435 436 437 438 439 440
+ 441 442 443 444 445 446 447 448 449 450 451 452 453 454 455 456 457 458 459 460
+ 461 462 463 464 465 466 467 468 469 470 471 472 473 474 475 476 477 478 479 480
+ 481 482 483 484 485 486 487 488 489 490 491 492 493 494 495 496 497 498 499 500
+ 501 502 503 504 505 506 507 508 509 510 511 512 513 514 515 516 517 518 519 520
+ 521 522 523 524 525 526 527 528 529 530 531 532 533 534 535 536 537 538 539 540
+ 541 542 543 544 545 546 547 548 549 550 551 552 553 554 555 556 557 558 559 560
+ 561 562 563 564 565 566 567 568 569 570 571 572 573 574 575 576 577 578 579 580
+ 581 582 583 584 585 586 587 588 589 590 591 592 593 594 595 596 597 598 599 600
+ 601 602 603 604 605 606 607 608 609 610 611 612 613 614 615 616 617 618 619 620
+ 621 622 623 624 625 626 627 628 629 630 631 632 633 634 635 636 637 638 639 640
+ 641 642 643 644 645 646 647 648 649 650 651 652 653 654 655 656 657 658 659 660
+ 661 662 663 664 665 666 667 668 669 670 671 672 673 674 675 676 677 678 679 680
+ 681 682 683 684 685 686 687 688 689 690 691 692 693 694 695 696 697 698 699 700
+ 701 702 703 704 705 706 707 708 709 710 711 712 713 714 715 716 717 718 719 720
+ 721 722 723 724 725 726 727 728 729 730 731 732 733 734 735 736 737 738 739 740
+ 741 742 743 744 745 746 747 748 749 750 751 752 753 754 755 756 757 758 759 760
+ 761 762 763 764 765 766 767 768 769 770 771 772 773 774 775 776 777 778 779 780
+ 781 782 783 784 785 786 787 788 789 790 791 792 793 794 795 796 797 798 799 800
+ 801 802 803 804 805 806 807 808 809 810 811 812 813 814 815 816 817 818 819 820
+ 821 822 823 824 825 826 827 828 829 830 831 832 833 834 835 836 837 838 839 840
+ 841 842 843 844 845 846 847 848 849 850 851 852 853 854 855 856 857 858 859 860
+ 861 862 863 864 865 866 867 868 869 870 871 872 873 874 875 876 877 878 879 880
+ 881 882 883 884 885 886 887 888 889 890 891 892 893 894 895 896 897 898 899 900
+ 901 902 903 904 905 906 907 908 909 910 911 912 913 914 915 916 917 918 919 920
+ 921 922 923 924 925 926 927 928 929 930 931 932 933 934 935 936 937 938 939 940
+ 941 942 943 944 945 946 947 948 949 950 951 952 953 954 955 956 957 958 959 960
+ 961 962 963 964 965 966 967 968 969 970 971 972 973 974 975 976 977 978 979 980
+ 981 982 983 984 985 986 987 988 989 990 991 992 993 994 995 996 997 998 999 1000
+ 1001 1002 1003 1004 1005 1006 1007 1008 1009 1010 1011 1012 1013 1014 1015 1016 1017 1018 1019 1020
+ 1021 1022 1023 1024 1025 1026 1027 1028 1029 1030 1031 1032 1033 1034 1035 1036 1037 1038 1039 1040
+ 1041 1042 1043 1044 1045 1046 1047 1048 1049 1050 1051 1052 1053 1054 1055 1056 1057 1058 1059 1060
+ 1061 1062 1063 1064 1065 1066 1067 1068 1069 1070 1071 1072 1073 1074 1075 1076 1077 1078 1079 1080
+ 1081 1082 1083 1084 1085 1086 1087 1088 1089 1090 1091 1092 1093 1094 1095 1096 1097 1098 1099 1100
+ 1101 1102 1103 1104 1105 1106 1107 1108 1109 1110 1111 1112 1113 1114 1115 1116 1117 1118 1119 1120
+ 1121 1122 1123 1124 1125 1126 1127 1128 1129 1130 1131 1132 1133 1134 1135 1136 1137 1138 1139 1140
+ 1141 1142 1143 1144 1145 1146 1147 1148 1149 1150 1151 1152 1153 1154 1155 1156 1157 1158 1159 1160
+ 1161 1162 1163 1164 1165 1166 1167 1168 1169 1170 1171 1172 1173 1174 1175 1176 1177 1178 1179 1180
+ 1181 1182 1183 1184 1185 1186 1187 1188 1189 1190 1191 1192 1193 1194 1195 1196 1197 1198 1199 1200
+ 1201 1202 1203 1204 1205 1206 1207 1208 1209 1210 1211 1212 1213 1214 1215 1216 1217 1218 1219 1220
+ 1221 1222 1223 1224 1225 1226 1227 1228 1229 1230 1231 1232 1233 1234 1235 1236 1237 1238 1239 1240
+ 1241 1242 1243 1244 1245 1246 1247 1248 1249 1250 1251 1252 1253 1254 1255 1256 1257 1258 1259 1260
+ 1261 1262 1263 1264 1265 1266 1267 1268 1269 1270 1271 1272 1295
** N=5643 EP=1273 IP=32843 FDC=0
X0 994 1001 4829 1 2 QDFFN $T=858700 447440 0 0 $X=858700 $Y=447060
X1 995 1001 4835 1 2 QDFFN $T=858700 467600 1 0 $X=858700 $Y=462180
X2 994 1004 4853 1 2 QDFFN $T=859940 447440 1 0 $X=859940 $Y=442020
X3 995 1004 4842 1 2 QDFFN $T=859940 457520 1 0 $X=859940 $Y=452100
X4 1000 1001 4844 1 2 QDFFN $T=860560 407120 1 0 $X=860560 $Y=401700
X5 997 1001 4845 1 2 QDFFN $T=860560 427280 1 0 $X=860560 $Y=421860
X6 1000 1004 4852 1 2 QDFFN $T=861180 397040 1 0 $X=861180 $Y=391620
X7 997 1004 4848 1 2 QDFFN $T=861800 417200 0 0 $X=861800 $Y=416820
X8 1023 1004 4811 1 2 QDFFN $T=872340 427280 1 180 $X=861800 $Y=426900
X9 1011 1001 4850 1 2 QDFFN $T=864280 407120 0 0 $X=864280 $Y=406740
X10 995 4847 4820 1 2 QDFFN $T=875440 467600 1 180 $X=864900 $Y=467220
X11 1023 1001 4867 1 2 QDFFN $T=868620 437360 1 0 $X=868620 $Y=431940
X12 995 1044 4839 1 2 QDFFN $T=882260 457520 1 180 $X=871720 $Y=457140
X13 1033 4847 4890 1 2 QDFFN $T=872960 477680 0 0 $X=872960 $Y=477300
X14 1000 1044 4851 1 2 QDFFN $T=884740 397040 0 180 $X=874200 $Y=391620
X15 1011 1044 4856 1 2 QDFFN $T=885360 417200 0 180 $X=874820 $Y=411780
X16 997 1044 4860 1 2 QDFFN $T=885980 427280 1 180 $X=875440 $Y=426900
X17 1023 1044 4883 1 2 QDFFN $T=875440 447440 1 0 $X=875440 $Y=442020
X18 995 1050 4862 1 2 QDFFN $T=886600 477680 0 180 $X=876060 $Y=472260
X19 1043 1001 4889 1 2 QDFFN $T=877300 386960 1 0 $X=877300 $Y=381540
X20 1033 1050 4895 1 2 QDFFN $T=877920 487760 1 0 $X=877920 $Y=482340
X21 1051 1056 4897 1 2 QDFFN $T=879780 507920 0 0 $X=879780 $Y=507540
X22 994 1044 4857 1 2 QDFFN $T=890940 447440 1 180 $X=880400 $Y=447060
X23 1011 1004 4873 1 2 QDFFN $T=892800 407120 0 180 $X=882260 $Y=401700
X24 1051 1064 4907 1 2 QDFFN $T=882260 497840 0 0 $X=882260 $Y=497460
X25 997 4847 4915 1 2 QDFFN $T=882880 417200 0 0 $X=882880 $Y=416820
X26 1058 1064 4900 1 2 QDFFN $T=882880 507920 1 0 $X=882880 $Y=502500
X27 1060 1044 4932 1 2 QDFFN $T=883500 457520 1 0 $X=883500 $Y=452100
X28 1060 1001 4916 1 2 QDFFN $T=885360 467600 1 0 $X=885360 $Y=462180
X29 1068 1056 4925 1 2 QDFFN $T=885980 518000 0 0 $X=885980 $Y=517620
X30 1043 1044 4908 1 2 QDFFN $T=886600 386960 0 0 $X=886600 $Y=386580
X31 1000 1050 4930 1 2 QDFFN $T=886600 397040 1 0 $X=886600 $Y=391620
X32 1023 1050 4937 1 2 QDFFN $T=886600 467600 0 0 $X=886600 $Y=467220
X33 1043 1004 4905 1 2 QDFFN $T=887220 376880 0 0 $X=887220 $Y=376500
X34 1011 1050 4914 1 2 QDFFN $T=887220 417200 1 0 $X=887220 $Y=411780
X35 1051 1077 4917 1 2 QDFFN $T=888460 497840 1 0 $X=888460 $Y=492420
X36 1033 1044 4894 1 2 QDFFN $T=899620 447440 0 180 $X=889080 $Y=442020
X37 1033 1001 4892 1 2 QDFFN $T=900240 427280 1 180 $X=889700 $Y=426900
X38 1060 1050 4933 1 2 QDFFN $T=890940 487760 1 0 $X=890940 $Y=482340
X39 1058 1056 4958 1 2 QDFFN $T=893420 507920 0 0 $X=893420 $Y=507540
X40 1060 1004 4910 1 2 QDFFN $T=904580 447440 1 180 $X=894040 $Y=447060
X41 1058 1077 4955 1 2 QDFFN $T=895280 497840 0 0 $X=895280 $Y=497460
X42 1060 4847 4922 1 2 QDFFN $T=906440 477680 1 180 $X=895900 $Y=477300
X43 1089 1044 4966 1 2 QDFFN $T=897760 417200 1 0 $X=897760 $Y=411780
X44 997 1050 4931 1 2 QDFFN $T=908920 427280 0 180 $X=898380 $Y=421860
X45 1033 1004 4899 1 2 QDFFN $T=908920 437360 1 180 $X=898380 $Y=436980
X46 1043 4847 4965 1 2 QDFFN $T=899000 386960 0 0 $X=899000 $Y=386580
X47 1011 4847 4923 1 2 QDFFN $T=909540 407120 1 180 $X=899000 $Y=406740
X48 1000 4847 4936 1 2 QDFFN $T=910160 397040 1 180 $X=899620 $Y=396660
X49 1043 1050 4959 1 2 QDFFN $T=900240 376880 1 0 $X=900240 $Y=371460
X50 1098 1001 4944 1 2 QDFFN $T=912640 467600 0 180 $X=902100 $Y=462180
X51 1096 1077 4981 1 2 QDFFN $T=902100 497840 1 0 $X=902100 $Y=492420
X52 1098 1044 4951 1 2 QDFFN $T=913260 447440 0 180 $X=902720 $Y=442020
X53 1098 1050 4984 1 2 QDFFN $T=903960 487760 1 0 $X=903960 $Y=482340
X54 1100 1001 4993 1 2 QDFFN $T=904580 417200 0 0 $X=904580 $Y=416820
X55 1023 4847 4957 1 2 QDFFN $T=915120 477680 0 180 $X=904580 $Y=472260
X56 1096 1056 4992 1 2 QDFFN $T=906440 507920 0 0 $X=906440 $Y=507540
X57 1100 1044 5034 1 2 QDFFN $T=907680 427280 0 0 $X=907680 $Y=426900
X58 1098 1004 4964 1 2 QDFFN $T=918220 447440 1 180 $X=907680 $Y=447060
X59 1124 1056 1105 1 2 QDFFN $T=918220 518000 1 180 $X=907680 $Y=517620
X60 1096 1064 4989 1 2 QDFFN $T=908300 497840 0 0 $X=908300 $Y=497460
X61 1108 1050 5000 1 2 QDFFN $T=908920 366800 0 0 $X=908920 $Y=366420
X62 1116 1044 5013 1 2 QDFFN $T=911400 376880 0 0 $X=911400 $Y=376500
X63 1116 1001 5006 1 2 QDFFN $T=911400 386960 1 0 $X=911400 $Y=381540
X64 1100 1004 5011 1 2 QDFFN $T=911400 427280 1 0 $X=911400 $Y=421860
X65 1112 1044 5017 1 2 QDFFN $T=912020 437360 0 0 $X=912020 $Y=436980
X66 1119 1004 5020 1 2 QDFFN $T=912640 457520 1 0 $X=912640 $Y=452100
X67 1089 1004 4979 1 2 QDFFN $T=923800 397040 1 180 $X=913260 $Y=396660
X68 994 4847 5035 1 2 QDFFN $T=913880 467600 0 0 $X=913880 $Y=467220
X69 1089 1001 4975 1 2 QDFFN $T=926280 407120 1 180 $X=915740 $Y=406740
X70 1119 1001 5023 1 2 QDFFN $T=915740 467600 1 0 $X=915740 $Y=462180
X71 1058 1123 5025 1 2 QDFFN $T=915740 487760 0 0 $X=915740 $Y=487380
X72 1112 1004 5039 1 2 QDFFN $T=916360 447440 1 0 $X=916360 $Y=442020
X73 1089 1050 5037 1 2 QDFFN $T=917600 417200 0 0 $X=917600 $Y=416820
X74 1098 4847 4980 1 2 QDFFN $T=928760 487760 0 180 $X=918220 $Y=482340
X75 1058 1128 5031 1 2 QDFFN $T=919460 507920 0 0 $X=919460 $Y=507540
X76 1108 1004 5060 1 2 QDFFN $T=920700 366800 0 0 $X=920700 $Y=366420
X77 1096 1128 5067 1 2 QDFFN $T=920700 518000 1 0 $X=920700 $Y=512580
X78 1108 1001 5055 1 2 QDFFN $T=921320 366800 1 0 $X=921320 $Y=361380
X79 1112 1001 5008 1 2 QDFFN $T=931860 437360 0 180 $X=921320 $Y=431940
X80 1119 1044 5044 1 2 QDFFN $T=921320 447440 0 0 $X=921320 $Y=447060
X81 1096 1123 5073 1 2 QDFFN $T=921320 497840 1 0 $X=921320 $Y=492420
X82 994 1050 5048 1 2 QDFFN $T=921940 477680 1 0 $X=921940 $Y=472260
X83 1116 1004 5018 1 2 QDFFN $T=933720 376880 0 180 $X=923180 $Y=371460
X84 1100 1050 5066 1 2 QDFFN $T=928140 417200 0 0 $X=928140 $Y=416820
X85 1119 1050 5105 1 2 QDFFN $T=930000 487760 0 0 $X=930000 $Y=487380
X86 1116 1050 5065 1 2 QDFFN $T=941780 366800 1 180 $X=931240 $Y=366420
X87 1023 5076 5129 1 2 QDFFN $T=931240 467600 1 0 $X=931240 $Y=462180
X88 1119 4847 5108 1 2 QDFFN $T=931240 487760 1 0 $X=931240 $Y=482340
X89 994 5076 5118 1 2 QDFFN $T=931860 457520 0 0 $X=931860 $Y=457140
X90 1051 1128 5117 1 2 QDFFN $T=932480 518000 1 0 $X=932480 $Y=512580
X91 1116 4847 5091 1 2 QDFFN $T=944880 386960 1 180 $X=934340 $Y=386580
X92 1089 4847 5072 1 2 QDFFN $T=944880 407120 1 180 $X=934340 $Y=406740
X93 1100 4847 5056 1 2 QDFFN $T=944880 427280 1 180 $X=934340 $Y=426900
X94 1112 1050 5089 1 2 QDFFN $T=944880 437360 1 180 $X=934340 $Y=436980
X95 1051 1123 5113 1 2 QDFFN $T=934340 497840 1 0 $X=934340 $Y=492420
X96 1112 4847 5093 1 2 QDFFN $T=945500 457520 0 180 $X=934960 $Y=452100
X97 1108 1044 5082 1 2 QDFFN $T=947360 356720 1 180 $X=936820 $Y=356340
X98 1124 1123 1146 1 2 QDFFN $T=947980 518000 1 180 $X=937440 $Y=517620
X99 1147 1001 5151 1 2 QDFFN $T=938060 356720 1 0 $X=938060 $Y=351300
X100 1116 5076 5153 1 2 QDFFN $T=938680 376880 0 0 $X=938680 $Y=376500
X101 1089 5076 5154 1 2 QDFFN $T=938680 417200 0 0 $X=938680 $Y=416820
X102 1098 5076 5152 1 2 QDFFN $T=938680 467600 0 0 $X=938680 $Y=467220
X103 995 5076 5166 1 2 QDFFN $T=940540 447440 0 0 $X=940540 $Y=447060
X104 1108 4847 5123 1 2 QDFFN $T=952320 366800 1 180 $X=941780 $Y=366420
X105 994 5150 5124 1 2 QDFFN $T=952940 457520 1 180 $X=942400 $Y=457140
X106 1098 5150 5133 1 2 QDFFN $T=954180 487760 1 180 $X=943640 $Y=487380
X107 1023 5150 5137 1 2 QDFFN $T=955420 487760 0 180 $X=944880 $Y=482340
X108 995 5150 5177 1 2 QDFFN $T=945500 437360 0 0 $X=945500 $Y=436980
X109 1011 5076 5213 1 2 QDFFN $T=946740 407120 0 0 $X=946740 $Y=406740
X110 1147 1044 5188 1 2 QDFFN $T=947360 356720 0 0 $X=947360 $Y=356340
X111 1096 1172 5159 1 2 QDFFN $T=958520 497840 0 180 $X=947980 $Y=492420
X112 1116 5150 5204 1 2 QDFFN $T=949220 376880 0 0 $X=949220 $Y=376500
X113 1000 5150 5198 1 2 QDFFN $T=949220 386960 0 0 $X=949220 $Y=386580
X114 997 5076 5149 1 2 QDFFN $T=959760 417200 1 180 $X=949220 $Y=416820
X115 997 5150 5157 1 2 QDFFN $T=961620 427280 1 180 $X=951080 $Y=426900
X116 1147 1050 5238 1 2 QDFFN $T=951700 336560 0 0 $X=951700 $Y=336180
X117 1147 1004 5173 1 2 QDFFN $T=962240 346640 0 180 $X=951700 $Y=341220
X118 1112 5076 5220 1 2 QDFFN $T=951700 447440 0 0 $X=951700 $Y=447060
X119 1060 5150 5233 1 2 QDFFN $T=952940 457520 0 0 $X=952940 $Y=457140
X120 1033 5076 5227 1 2 QDFFN $T=952940 467600 0 0 $X=952940 $Y=467220
X121 1096 1180 5167 1 2 QDFFN $T=964100 497840 1 180 $X=953560 $Y=497460
X122 1100 5150 5246 1 2 QDFFN $T=956040 437360 0 0 $X=956040 $Y=436980
X123 1174 5150 5249 1 2 QDFFN $T=957280 346640 0 0 $X=957280 $Y=346260
X124 1108 5150 5207 1 2 QDFFN $T=968440 366800 0 180 $X=957900 $Y=361380
X125 1033 5150 5243 1 2 QDFFN $T=958520 487760 1 0 $X=958520 $Y=482340
X126 1174 5076 5264 1 2 QDFFN $T=959140 366800 0 0 $X=959140 $Y=366420
X127 1000 5076 5209 1 2 QDFFN $T=969680 397040 1 180 $X=959140 $Y=396660
X128 1051 1180 5272 1 2 QDFFN $T=959140 518000 1 0 $X=959140 $Y=512580
X129 1058 1172 5279 1 2 QDFFN $T=961000 497840 1 0 $X=961000 $Y=492420
X130 1100 5076 5253 1 2 QDFFN $T=961620 427280 0 0 $X=961620 $Y=426900
X131 1181 5150 5277 1 2 QDFFN $T=962240 356720 0 0 $X=962240 $Y=356340
X132 1043 5150 5232 1 2 QDFFN $T=972780 386960 1 180 $X=962240 $Y=386580
X133 1112 5150 5260 1 2 QDFFN $T=962240 447440 0 0 $X=962240 $Y=447060
X134 1174 4847 5284 1 2 QDFFN $T=963480 326480 0 0 $X=963480 $Y=326100
X135 1043 5076 5239 1 2 QDFFN $T=974020 376880 1 180 $X=963480 $Y=376500
X136 1011 5150 5219 1 2 QDFFN $T=974020 407120 1 180 $X=963480 $Y=406740
X137 1060 5076 5270 1 2 QDFFN $T=963480 457520 0 0 $X=963480 $Y=457140
X138 1089 5150 5236 1 2 QDFFN $T=976500 417200 1 180 $X=965960 $Y=416820
X139 1119 5076 5251 1 2 QDFFN $T=976500 467600 1 180 $X=965960 $Y=467220
X140 1147 4847 5248 1 2 QDFFN $T=977740 336560 0 180 $X=967200 $Y=331140
X141 1108 5076 5241 1 2 QDFFN $T=980220 366800 1 180 $X=969680 $Y=366420
X142 997 5290 5273 1 2 QDFFN $T=982700 427280 1 180 $X=972160 $Y=426900
X143 1119 5150 5271 1 2 QDFFN $T=982700 487760 0 180 $X=972160 $Y=482340
X144 1058 1180 5261 1 2 QDFFN $T=982700 507920 0 180 $X=972160 $Y=502500
X145 1068 1195 5307 1 2 QDFFN $T=972160 518000 1 0 $X=972160 $Y=512580
X146 1147 5150 5309 1 2 QDFFN $T=972780 356720 0 0 $X=972780 $Y=356340
X147 1011 5290 5300 1 2 QDFFN $T=972780 386960 0 0 $X=972780 $Y=386580
X148 1112 5290 5311 1 2 QDFFN $T=972780 447440 0 0 $X=972780 $Y=447060
X149 1194 5150 5313 1 2 QDFFN $T=974020 346640 0 0 $X=974020 $Y=346260
X150 1100 5290 5326 1 2 QDFFN $T=974020 437360 0 0 $X=974020 $Y=436980
X151 995 5290 5312 1 2 QDFFN $T=974020 457520 0 0 $X=974020 $Y=457140
X152 1051 1172 5280 1 2 QDFFN $T=984560 507920 1 180 $X=974020 $Y=507540
X153 1124 1180 5268 1 2 QDFFN $T=984560 518000 1 180 $X=974020 $Y=517620
X154 1023 5290 5335 1 2 QDFFN $T=974640 477680 1 0 $X=974640 $Y=472260
X155 1000 5290 5323 1 2 QDFFN $T=975880 376880 0 0 $X=975880 $Y=376500
X156 994 5290 5319 1 2 QDFFN $T=975880 467600 1 0 $X=975880 $Y=462180
X157 1194 1050 5334 1 2 QDFFN $T=976500 326480 0 0 $X=976500 $Y=326100
X158 1147 5076 5320 1 2 QDFFN $T=976500 346640 1 0 $X=976500 $Y=341220
X159 1181 4847 1197 1 2 QDFFN $T=987660 326480 0 180 $X=977120 $Y=321060
X160 1198 1050 5339 1 2 QDFFN $T=977740 336560 1 0 $X=977740 $Y=331140
X161 1060 5290 5337 1 2 QDFFN $T=978980 467600 0 0 $X=978980 $Y=467220
X162 1089 5290 5347 1 2 QDFFN $T=980840 417200 0 0 $X=980840 $Y=416820
X163 997 1201 5355 1 2 QDFFN $T=982700 427280 0 0 $X=982700 $Y=426900
X164 1181 5076 5338 1 2 QDFFN $T=983320 356720 0 0 $X=983320 $Y=356340
X165 995 1201 5375 1 2 QDFFN $T=983320 447440 0 0 $X=983320 $Y=447060
X166 1198 5150 5350 1 2 QDFFN $T=983940 366800 0 0 $X=983940 $Y=366420
X167 1058 1195 5318 1 2 QDFFN $T=994480 497840 1 180 $X=983940 $Y=497460
X168 1119 5290 5366 1 2 QDFFN $T=985180 487760 1 0 $X=985180 $Y=482340
X169 1096 1195 5367 1 2 QDFFN $T=985180 487760 0 0 $X=985180 $Y=487380
X170 1051 1195 5362 1 2 QDFFN $T=987040 507920 0 0 $X=987040 $Y=507540
X171 997 1212 5379 1 2 QDFFN $T=988900 437360 1 0 $X=988900 $Y=431940
X172 997 1213 5381 1 2 QDFFN $T=989520 427280 1 0 $X=989520 $Y=421860
X173 995 1221 5346 1 2 QDFFN $T=1000060 437360 1 180 $X=989520 $Y=436980
X174 1068 1214 5383 1 2 QDFFN $T=990140 518000 1 0 $X=990140 $Y=512580
X175 995 1212 5374 1 2 QDFFN $T=990760 457520 1 0 $X=990760 $Y=452100
X176 1217 4847 1215 1 2 QDFFN $T=1003780 326480 0 180 $X=993240 $Y=321060
X177 1098 5290 5388 1 2 QDFFN $T=993240 477680 0 0 $X=993240 $Y=477300
X178 1217 5150 5360 1 2 QDFFN $T=993860 356720 0 0 $X=993860 $Y=356340
X179 1198 5076 5356 1 2 QDFFN $T=1005020 366800 0 180 $X=994480 $Y=361380
X180 995 1213 5391 1 2 QDFFN $T=994480 467600 1 0 $X=994480 $Y=462180
X181 1011 1201 5406 1 2 QDFFN $T=995100 376880 0 0 $X=995100 $Y=376500
X182 1217 5076 5368 1 2 QDFFN $T=1006880 356720 0 180 $X=996340 $Y=351300
X183 1198 4847 5352 1 2 QDFFN $T=1008120 336560 1 180 $X=997580 $Y=336180
X184 1194 5076 5373 1 2 QDFFN $T=1008120 346640 0 180 $X=997580 $Y=341220
X185 1011 1212 5405 1 2 QDFFN $T=997580 366800 0 0 $X=997580 $Y=366420
X186 1096 1214 5404 1 2 QDFFN $T=997580 497840 0 0 $X=997580 $Y=497460
X187 1096 1222 5392 1 2 QDFFN $T=998200 497840 1 0 $X=998200 $Y=492420
X188 1033 5290 5403 1 2 QDFFN $T=998820 487760 1 0 $X=998820 $Y=482340
X189 1051 1214 5408 1 2 QDFFN $T=999440 507920 0 0 $X=999440 $Y=507540
X190 997 1165 5384 1 2 QDFFN $T=1010600 427280 0 180 $X=1000060 $Y=421860
X191 997 1232 5385 1 2 QDFFN $T=1010600 437360 1 180 $X=1000060 $Y=436980
X192 1194 4847 5349 1 2 QDFFN $T=1011220 326480 1 180 $X=1000680 $Y=326100
X193 995 1165 5399 1 2 QDFFN $T=1000680 467600 0 0 $X=1000680 $Y=467220
X194 995 1230 5428 1 2 QDFFN $T=1002540 447440 1 0 $X=1002540 $Y=442020
X195 995 1231 5421 1 2 QDFFN $T=1002540 447440 0 0 $X=1002540 $Y=447060
X196 1043 5290 5425 1 2 QDFFN $T=1004400 356720 0 0 $X=1004400 $Y=356340
X197 995 1232 5438 1 2 QDFFN $T=1004400 457520 0 0 $X=1004400 $Y=457140
X198 1198 1212 1238 1 2 QDFFN $T=1006260 326480 1 0 $X=1006260 $Y=321060
X199 1124 1214 1234 1 2 QDFFN $T=1016800 518000 1 180 $X=1006260 $Y=517620
X200 1011 1213 5398 1 2 QDFFN $T=1018040 366800 0 180 $X=1007500 $Y=361380
X201 994 1231 5427 1 2 QDFFN $T=1008120 397040 0 0 $X=1008120 $Y=396660
X202 994 1213 5451 1 2 QDFFN $T=1008120 477680 0 0 $X=1008120 $Y=477300
X203 1217 5290 5442 1 2 QDFFN $T=1009360 356720 1 0 $X=1009360 $Y=351300
X204 1174 5290 5439 1 2 QDFFN $T=1009980 346640 0 0 $X=1009980 $Y=346260
X205 994 1232 5436 1 2 QDFFN $T=1009980 417200 1 0 $X=1009980 $Y=411780
X206 1198 5290 5413 1 2 QDFFN $T=1021760 336560 0 180 $X=1011220 $Y=331140
X207 994 1201 5437 1 2 QDFFN $T=1011220 477680 1 0 $X=1011220 $Y=472260
X208 1058 1222 5415 1 2 QDFFN $T=1021760 487760 1 180 $X=1011220 $Y=487380
X209 1058 1214 5447 1 2 QDFFN $T=1011220 497840 0 0 $X=1011220 $Y=497460
X210 1051 1222 5416 1 2 QDFFN $T=1021760 518000 0 180 $X=1011220 $Y=512580
X211 1011 1232 5422 1 2 QDFFN $T=1023000 376880 1 180 $X=1012460 $Y=376500
X212 997 1221 5423 1 2 QDFFN $T=1023000 437360 0 180 $X=1012460 $Y=431940
X213 1060 1221 5448 1 2 QDFFN $T=1013080 437360 0 0 $X=1013080 $Y=436980
X214 994 1165 5459 1 2 QDFFN $T=1013080 487760 1 0 $X=1013080 $Y=482340
X215 1194 1212 1246 1 2 QDFFN $T=1014940 326480 0 0 $X=1014940 $Y=326100
X216 997 1231 5411 1 2 QDFFN $T=1025480 417200 1 180 $X=1014940 $Y=416820
X217 1011 1231 5433 1 2 QDFFN $T=1026100 386960 1 180 $X=1015560 $Y=386580
X218 994 1212 5457 1 2 QDFFN $T=1015560 467600 1 0 $X=1015560 $Y=462180
X219 1011 1165 5420 1 2 QDFFN $T=1026720 366800 1 180 $X=1016180 $Y=366420
X220 994 1221 5463 1 2 QDFFN $T=1016800 407120 0 0 $X=1016800 $Y=406740
X221 997 1230 5426 1 2 QDFFN $T=1028580 427280 1 180 $X=1018040 $Y=426900
X222 1060 1232 5466 1 2 QDFFN $T=1018040 457520 0 0 $X=1018040 $Y=457140
X223 1194 1201 1240 1 2 QDFFN $T=1030440 326480 0 180 $X=1019900 $Y=321060
X224 1108 5290 5467 1 2 QDFFN $T=1019900 366800 1 0 $X=1019900 $Y=361380
X225 1011 1230 5475 1 2 QDFFN $T=1019900 386960 1 0 $X=1019900 $Y=381540
X226 1051 1242 5479 1 2 QDFFN $T=1019900 507920 0 0 $X=1019900 $Y=507540
X227 994 1230 5469 1 2 QDFFN $T=1020520 397040 0 0 $X=1020520 $Y=396660
X228 1116 5290 5470 1 2 QDFFN $T=1021140 356720 0 0 $X=1021140 $Y=356340
X229 1181 5290 5472 1 2 QDFFN $T=1021760 356720 1 0 $X=1021760 $Y=351300
X230 1089 1213 5478 1 2 QDFFN $T=1022380 417200 1 0 $X=1022380 $Y=411780
X231 1060 1213 5477 1 2 QDFFN $T=1023620 477680 0 0 $X=1023620 $Y=477300
X232 1194 5290 5446 1 2 QDFFN $T=1034780 336560 0 180 $X=1024240 $Y=331140
X233 1096 1242 5458 1 2 QDFFN $T=1034780 497840 0 180 $X=1024240 $Y=492420
X234 1068 1242 5452 1 2 QDFFN $T=1034780 518000 0 180 $X=1024240 $Y=512580
X235 1060 1212 5483 1 2 QDFFN $T=1024860 467600 0 0 $X=1024860 $Y=467220
X236 1058 1242 5461 1 2 QDFFN $T=1035400 487760 1 180 $X=1024860 $Y=487380
X237 1011 1221 5480 1 2 QDFFN $T=1025480 376880 0 0 $X=1025480 $Y=376500
X238 1100 1213 5481 1 2 QDFFN $T=1025480 437360 1 0 $X=1025480 $Y=431940
X239 1060 1230 5453 1 2 QDFFN $T=1026720 437360 0 0 $X=1026720 $Y=436980
X240 1147 5290 5460 1 2 QDFFN $T=1038500 336560 1 180 $X=1027960 $Y=336180
X241 1100 1165 5486 1 2 QDFFN $T=1027960 417200 0 0 $X=1027960 $Y=416820
X242 1217 1212 1251 1 2 QDFFN $T=1028580 326480 0 0 $X=1028580 $Y=326100
X243 1000 1213 5492 1 2 QDFFN $T=1028580 366800 0 0 $X=1028580 $Y=366420
X244 1023 1231 5484 1 2 QDFFN $T=1028580 386960 0 0 $X=1028580 $Y=386580
X245 1060 1201 5494 1 2 QDFFN $T=1028580 467600 1 0 $X=1028580 $Y=462180
X246 1060 1231 5464 1 2 QDFFN $T=1029820 457520 1 0 $X=1029820 $Y=452100
X247 1060 1165 5495 1 2 QDFFN $T=1029820 487760 1 0 $X=1029820 $Y=482340
X248 1023 1212 5497 1 2 QDFFN $T=1030440 457520 0 0 $X=1030440 $Y=457140
X249 1112 1212 5496 1 2 QDFFN $T=1031060 447440 1 0 $X=1031060 $Y=442020
X250 1181 1212 1254 1 2 QDFFN $T=1032920 326480 1 0 $X=1032920 $Y=321060
X251 1043 1213 5504 1 2 QDFFN $T=1034160 356720 0 0 $X=1034160 $Y=356340
X252 1089 1165 5485 1 2 QDFFN $T=1045320 407120 0 180 $X=1034780 $Y=401700
X253 1124 1255 5474 1 2 QDFFN $T=1045940 518000 1 180 $X=1035400 $Y=517620
X254 1116 1165 5521 1 2 QDFFN $T=1036020 346640 0 0 $X=1036020 $Y=346260
X255 1096 1255 5462 1 2 QDFFN $T=1046560 497840 1 180 $X=1036020 $Y=497460
X256 1068 1255 5465 1 2 QDFFN $T=1047800 518000 0 180 $X=1037260 $Y=512580
X257 1181 1201 1252 1 2 QDFFN $T=1048420 336560 0 180 $X=1037880 $Y=331140
X258 1000 1165 5493 1 2 QDFFN $T=1048420 376880 1 180 $X=1037880 $Y=376500
X259 1023 1232 5489 1 2 QDFFN $T=1048420 397040 0 180 $X=1037880 $Y=391620
X260 1089 1212 5515 1 2 QDFFN $T=1038500 417200 1 0 $X=1038500 $Y=411780
X261 1100 1201 5518 1 2 QDFFN $T=1038500 427280 0 0 $X=1038500 $Y=426900
X262 1112 1165 5508 1 2 QDFFN $T=1038500 437360 1 0 $X=1038500 $Y=431940
X263 1058 1255 5488 1 2 QDFFN $T=1049040 497840 0 180 $X=1038500 $Y=492420
X264 1051 1255 5491 1 2 QDFFN $T=1049660 507920 0 180 $X=1039120 $Y=502500
X265 1023 1221 5517 1 2 QDFFN $T=1039740 386960 1 0 $X=1039740 $Y=381540
X266 1043 1165 5516 1 2 QDFFN $T=1040360 366800 1 0 $X=1040360 $Y=361380
X267 1089 1201 5522 1 2 QDFFN $T=1040360 407120 0 0 $X=1040360 $Y=406740
X268 1100 1212 5520 1 2 QDFFN $T=1040360 427280 1 0 $X=1040360 $Y=421860
X269 1116 1213 5524 1 2 QDFFN $T=1040980 336560 0 0 $X=1040980 $Y=336180
X270 1043 1201 5530 1 2 QDFFN $T=1041600 356720 1 0 $X=1041600 $Y=351300
X271 1174 1201 1253 1 2 QDFFN $T=1052760 326480 1 180 $X=1042220 $Y=326100
X272 1023 1230 5519 1 2 QDFFN $T=1042220 386960 0 0 $X=1042220 $Y=386580
X273 1112 1201 5502 1 2 QDFFN $T=1054000 457520 1 180 $X=1043460 $Y=457140
X274 1023 1165 5506 1 2 QDFFN $T=1054000 487760 0 180 $X=1043460 $Y=482340
X275 1023 1213 5503 1 2 QDFFN $T=1054620 477680 1 180 $X=1044080 $Y=477300
X276 1000 1212 5534 1 2 QDFFN $T=1045940 376880 1 0 $X=1045940 $Y=371460
X277 1119 1212 5540 1 2 QDFFN $T=1046560 447440 0 0 $X=1046560 $Y=447060
X278 1112 1213 5514 1 2 QDFFN $T=1058960 437360 1 180 $X=1048420 $Y=436980
X279 1098 1201 5555 1 2 QDFFN $T=1049040 477680 1 0 $X=1049040 $Y=472260
X280 1096 1256 5547 1 2 QDFFN $T=1049040 497840 0 0 $X=1049040 $Y=497460
X281 1023 1201 5501 1 2 QDFFN $T=1050280 467600 0 0 $X=1050280 $Y=467220
X282 1096 1259 5525 1 2 QDFFN $T=1050280 507920 0 0 $X=1050280 $Y=507540
X283 1147 1201 5554 1 2 QDFFN $T=1050900 336560 1 0 $X=1050900 $Y=331140
X284 1089 1221 5552 1 2 QDFFN $T=1051520 407120 1 0 $X=1051520 $Y=401700
X285 1119 1221 5551 1 2 QDFFN $T=1051520 437360 1 0 $X=1051520 $Y=431940
X286 1096 1261 5544 1 2 QDFFN $T=1052760 497840 1 0 $X=1052760 $Y=492420
X287 1000 1201 5531 1 2 QDFFN $T=1063920 386960 0 180 $X=1053380 $Y=381540
X288 1089 1232 5557 1 2 QDFFN $T=1053380 427280 1 0 $X=1053380 $Y=421860
X289 1116 1201 5536 1 2 QDFFN $T=1065160 356720 0 180 $X=1054620 $Y=351300
X290 1043 1212 5537 1 2 QDFFN $T=1065160 366800 0 180 $X=1054620 $Y=361380
X291 1089 1231 5549 1 2 QDFFN $T=1054620 407120 0 0 $X=1054620 $Y=406740
X292 1116 1212 5565 1 2 QDFFN $T=1055240 346640 0 0 $X=1055240 $Y=346260
X293 1100 1221 5569 1 2 QDFFN $T=1055240 386960 0 0 $X=1055240 $Y=386580
X294 1089 1230 5570 1 2 QDFFN $T=1055240 397040 0 0 $X=1055240 $Y=396660
X295 1119 1201 5535 1 2 QDFFN $T=1067020 457520 1 180 $X=1056480 $Y=457140
X296 1033 1212 5582 1 2 QDFFN $T=1057100 487760 1 0 $X=1057100 $Y=482340
X297 1000 1221 5574 1 2 QDFFN $T=1057720 376880 1 0 $X=1057720 $Y=371460
X298 1098 1212 5567 1 2 QDFFN $T=1057720 477680 0 0 $X=1057720 $Y=477300
X299 1058 1259 1265 1 2 QDFFN $T=1068260 518000 1 180 $X=1057720 $Y=517620
X300 1108 1212 1267 1 2 QDFFN $T=1058340 326480 1 0 $X=1058340 $Y=321060
X301 1098 1221 5588 1 2 QDFFN $T=1061440 447440 0 0 $X=1061440 $Y=447060
X302 1058 1256 5560 1 2 QDFFN $T=1073840 497840 1 180 $X=1063300 $Y=497460
X303 1051 1259 5595 1 2 QDFFN $T=1063300 507920 0 0 $X=1063300 $Y=507540
X304 1033 1201 5575 1 2 QDFFN $T=1063920 467600 0 0 $X=1063920 $Y=467220
X305 1116 1230 5598 1 2 QDFFN $T=1064540 336560 1 0 $X=1064540 $Y=331140
X306 1000 1230 5591 1 2 QDFFN $T=1064540 376880 0 0 $X=1064540 $Y=376500
X307 1119 1230 5558 1 2 QDFFN $T=1075080 437360 0 180 $X=1064540 $Y=431940
X308 1112 1230 5566 1 2 QDFFN $T=1076320 427280 0 180 $X=1065780 $Y=421860
X309 1058 1261 5564 1 2 QDFFN $T=1077560 497840 0 180 $X=1067020 $Y=492420
X310 1116 1221 5607 1 2 QDFFN $T=1067640 346640 0 0 $X=1067640 $Y=346260
X311 1043 1230 5601 1 2 QDFFN $T=1067640 356720 1 0 $X=1067640 $Y=351300
X312 1043 1221 5611 1 2 QDFFN $T=1067640 366800 0 0 $X=1067640 $Y=366420
X313 1100 1230 5578 1 2 QDFFN $T=1078180 386960 1 180 $X=1067640 $Y=386580
X314 1112 1221 5573 1 2 QDFFN $T=1078180 427280 1 180 $X=1067640 $Y=426900
X315 1033 1230 5581 1 2 QDFFN $T=1078800 397040 1 180 $X=1068260 $Y=396660
X316 1033 1221 5577 1 2 QDFFN $T=1078800 417200 0 180 $X=1068260 $Y=411780
X317 1098 1230 5571 1 2 QDFFN $T=1078800 437360 1 180 $X=1068260 $Y=436980
X318 1119 1165 5583 1 2 QDFFN $T=1078800 457520 0 180 $X=1068260 $Y=452100
X319 1147 1212 5563 1 2 QDFFN $T=1068880 326480 0 0 $X=1068880 $Y=326100
X320 1033 1165 5610 1 2 QDFFN $T=1070740 487760 1 0 $X=1070740 $Y=482340
X321 1147 1221 1270 1 2 QDFFN $T=1081900 326480 0 180 $X=1071360 $Y=321060
X322 1068 1261 5613 1 2 QDFFN $T=1072600 507920 1 0 $X=1072600 $Y=502500
X323 1124 1261 5624 1 2 QDFFN $T=1075700 518000 0 0 $X=1075700 $Y=517620
X324 1051 1256 5625 1 2 QDFFN $T=1078180 497840 0 0 $X=1078180 $Y=497460
X325 1098 1165 5609 1 2 QDFFN $T=1080040 467600 0 0 $X=1080040 $Y=467220
X326 1051 1261 5626 1 2 QDFFN $T=1080040 497840 1 0 $X=1080040 $Y=492420
X327 1147 1165 5572 1 2 QDFFN $T=1080660 336560 1 0 $X=1080660 $Y=331140
X328 1116 1231 5614 1 2 QDFFN $T=1080660 346640 0 0 $X=1080660 $Y=346260
X329 1043 1232 5629 1 2 QDFFN $T=1080660 356720 1 0 $X=1080660 $Y=351300
X330 1043 1231 5616 1 2 QDFFN $T=1080660 366800 1 0 $X=1080660 $Y=361380
X331 1000 1232 5630 1 2 QDFFN $T=1080660 376880 1 0 $X=1080660 $Y=371460
X332 1000 1231 5617 1 2 QDFFN $T=1080660 386960 1 0 $X=1080660 $Y=381540
X333 1100 1231 5608 1 2 QDFFN $T=1080660 386960 0 0 $X=1080660 $Y=386580
X334 1100 1232 5615 1 2 QDFFN $T=1080660 397040 1 0 $X=1080660 $Y=391620
X335 1033 1231 5612 1 2 QDFFN $T=1080660 407120 1 0 $X=1080660 $Y=401700
X336 1033 1232 5620 1 2 QDFFN $T=1080660 407120 0 0 $X=1080660 $Y=406740
X337 1112 1232 5631 1 2 QDFFN $T=1080660 427280 1 0 $X=1080660 $Y=421860
X338 1098 1231 5621 1 2 QDFFN $T=1080660 447440 1 0 $X=1080660 $Y=442020
X339 1098 1232 5632 1 2 QDFFN $T=1080660 457520 1 0 $X=1080660 $Y=452100
X340 1119 1213 5633 1 2 QDFFN $T=1080660 457520 0 0 $X=1080660 $Y=457140
X341 1098 1213 5622 1 2 QDFFN $T=1080660 477680 1 0 $X=1080660 $Y=472260
X342 1068 1256 5634 1 2 QDFFN $T=1080660 518000 1 0 $X=1080660 $Y=512580
X343 1147 1213 5576 1 2 QDFFN $T=1081280 326480 0 0 $X=1081280 $Y=326100
X344 1116 1232 5628 1 2 QDFFN $T=1081280 336560 0 0 $X=1081280 $Y=336180
X345 1112 1231 5618 1 2 QDFFN $T=1081280 417200 1 0 $X=1081280 $Y=411780
X346 1119 1231 5619 1 2 QDFFN $T=1081280 427280 0 0 $X=1081280 $Y=426900
X347 1119 1232 5627 1 2 QDFFN $T=1081280 437360 0 0 $X=1081280 $Y=436980
X348 1033 1213 5623 1 2 QDFFN $T=1081280 477680 0 0 $X=1081280 $Y=477300
X349 1310 1302 1340 1314 1 1296 2 AOI22S $T=226920 356720 0 180 $X=223200 $Y=351300
X350 26 1310 1352 1320 1 17 2 AOI22S $T=228160 326480 1 180 $X=224440 $Y=326100
X351 1390 55 1387 58 1 1325 2 AOI22S $T=233740 356720 1 0 $X=233740 $Y=351300
X352 1428 68 1431 1314 1 65 2 AOI22S $T=239940 336560 0 180 $X=236220 $Y=331140
X353 1426 1411 1399 79 1 1436 2 AOI22S $T=238700 386960 0 0 $X=238700 $Y=386580
X354 1460 70 1445 1310 1 1390 2 AOI22S $T=245520 346640 1 180 $X=241800 $Y=346260
X355 1428 58 1466 110 1 1503 2 AOI22S $T=248620 366800 1 0 $X=248620 $Y=361380
X356 58 1390 1502 1298 1 116 2 AOI22S $T=251100 346640 1 0 $X=251100 $Y=341220
X357 1524 1302 1506 1380 1 1298 2 AOI22S $T=254820 356720 0 180 $X=251100 $Y=351300
X358 1524 1521 1543 1325 1 1296 2 AOI22S $T=258540 356720 0 180 $X=254820 $Y=351300
X359 1563 1551 131 1320 1 1380 2 AOI22S $T=261640 326480 0 180 $X=257920 $Y=321060
X360 1521 58 1572 129 1 1525 2 AOI22S $T=261640 366800 0 180 $X=257920 $Y=361380
X361 1615 1428 1586 1561 1 1529 2 AOI22S $T=262880 376880 1 180 $X=259160 $Y=376500
X362 145 1361 1588 39 1 149 2 AOI22S $T=265360 326480 0 0 $X=265360 $Y=326100
X363 146 1594 1536 1570 1 148 2 AOI22S $T=265360 336560 0 0 $X=265360 $Y=336180
X364 1616 1428 1642 97 1 1615 2 AOI22S $T=272180 376880 1 180 $X=268460 $Y=376500
X365 1504 70 1635 1390 1 1503 2 AOI22S $T=273420 366800 0 180 $X=269700 $Y=361380
X366 1298 146 1640 157 1 1608 2 AOI22S $T=274660 326480 1 180 $X=270940 $Y=326100
X367 89 1302 1631 1460 1 164 2 AOI22S $T=272180 356720 1 0 $X=272180 $Y=351300
X368 1428 55 1663 145 1 1298 2 AOI22S $T=277760 336560 0 180 $X=274040 $Y=331140
X369 1639 1444 1643 1298 1 1657 2 AOI22S $T=274040 376880 1 0 $X=274040 $Y=371460
X370 1639 170 1682 110 1 1654 2 AOI22S $T=280240 356720 0 180 $X=276520 $Y=351300
X371 139 1615 1664 1671 1 173 2 AOI22S $T=277140 346640 0 0 $X=277140 $Y=346260
X372 1648 26 1707 89 1 1720 2 AOI22S $T=283960 356720 1 0 $X=283960 $Y=351300
X373 1537 1639 192 1714 1 1503 2 AOI22S $T=290160 366800 1 180 $X=286440 $Y=366420
X374 1721 1725 1678 1630 1 133 2 AOI22S $T=286440 427280 1 0 $X=286440 $Y=421860
X375 1639 194 1734 170 1 1648 2 AOI22S $T=291400 356720 0 180 $X=287680 $Y=351300
X376 1537 196 1742 137 1 1405 2 AOI22S $T=292020 326480 0 180 $X=288300 $Y=321060
X377 17 1298 207 1428 1 202 2 AOI22S $T=296360 326480 1 180 $X=292640 $Y=326100
X378 1485 1720 1602 1757 1 1767 2 AOI22S $T=292640 366800 1 0 $X=292640 $Y=361380
X379 1720 50 1778 1552 1 1786 2 AOI22S $T=296360 366800 1 0 $X=296360 $Y=361380
X380 89 150 1938 1730 1 1948 2 AOI22S $T=331700 336560 1 0 $X=331700 $Y=331140
X381 1991 303 1996 2004 1 1954 2 AOI22S $T=345340 346640 0 0 $X=345340 $Y=346260
X382 2898 2836 2978 2620 1 388 2 AOI22S $T=528240 437360 1 0 $X=528240 $Y=431940
X383 2996 3005 2980 551 1 3012 2 AOI22S $T=531960 356720 1 0 $X=531960 $Y=351300
X384 605 604 3102 603 1 541 2 AOI22S $T=553660 326480 0 180 $X=549940 $Y=321060
X385 614 611 3163 608 1 3151 2 AOI22S $T=558620 336560 0 180 $X=554900 $Y=331140
X386 3196 538 627 630 1 631 2 AOI22S $T=565440 326480 1 0 $X=565440 $Y=321060
X387 631 538 3216 3200 1 3197 2 AOI22S $T=569160 346640 0 180 $X=565440 $Y=341220
X388 538 611 3058 634 1 3221 2 AOI22S $T=568540 336560 1 0 $X=568540 $Y=331140
X389 3229 636 3202 634 1 3194 2 AOI22S $T=572260 336560 1 180 $X=568540 $Y=336180
X390 3229 644 3060 636 1 3165 2 AOI22S $T=572260 336560 0 0 $X=572260 $Y=336180
X391 3229 3237 3270 541 1 3234 2 AOI22S $T=580940 346640 1 180 $X=577220 $Y=346260
X392 3165 659 3213 633 1 3306 2 AOI22S $T=580940 346640 1 0 $X=580940 $Y=341220
X393 573 593 3285 553 1 3221 2 AOI22S $T=582180 326480 0 0 $X=582180 $Y=326100
X394 610 3229 662 3260 1 3221 2 AOI22S $T=583420 346640 0 0 $X=583420 $Y=346260
X395 633 604 3287 666 1 668 2 AOI22S $T=584040 326480 1 0 $X=584040 $Y=321060
X396 3306 645 667 3190 1 3320 2 AOI22S $T=585280 346640 1 0 $X=585280 $Y=341220
X397 3339 3306 3249 3130 1 3355 2 AOI22S $T=592100 336560 0 0 $X=592100 $Y=336180
X398 633 609 3492 3307 1 3508 2 AOI22S $T=616900 346640 1 0 $X=616900 $Y=341220
X399 3542 732 3569 3584 1 3557 2 AOI22S $T=631780 346640 0 0 $X=631780 $Y=346260
X400 4599 4473 4601 3879 1 832 2 AOI22S $T=822120 487760 0 0 $X=822120 $Y=487380
X401 4697 4524 4691 4514 1 875 2 AOI22S $T=840720 427280 1 0 $X=840720 $Y=421860
X402 4696 4706 4686 4664 1 4713 2 AOI22S $T=841340 376880 1 0 $X=841340 $Y=371460
X403 960 974 4700 975 1 978 2 AOI22S $T=849400 326480 0 0 $X=849400 $Y=326100
X404 4762 4749 4675 973 1 4664 2 AOI22S $T=853120 366800 0 180 $X=849400 $Y=361380
X405 966 976 986 974 1 978 2 AOI22S $T=853740 336560 1 0 $X=853740 $Y=331140
X406 991 917 4772 988 1 972 2 AOI22S $T=858080 336560 1 180 $X=854360 $Y=336180
X407 4790 970 4783 4778 1 4716 2 AOI22S $T=858080 356720 0 180 $X=854360 $Y=351300
X408 972 974 953 992 1 996 2 AOI22S $T=856840 326480 1 0 $X=856840 $Y=321060
X409 283 4790 4793 3519 1 4799 2 AOI22S $T=858080 386960 1 0 $X=858080 $Y=381540
X410 992 1040 1038 970 1 1029 2 AOI22S $T=874200 326480 1 0 $X=874200 $Y=321060
X411 1039 976 4854 4866 1 947 2 AOI22S $T=874820 336560 0 0 $X=874820 $Y=336180
X412 4865 938 4864 4802 1 4718 2 AOI22S $T=878540 376880 0 180 $X=874820 $Y=371460
X413 1080 1082 4911 1083 1 973 2 AOI22S $T=894040 326480 1 0 $X=894040 $Y=321060
X414 1026 970 4942 4952 1 4956 2 AOI22S $T=902100 336560 1 0 $X=902100 $Y=331140
X415 1081 970 4970 4920 1 4961 2 AOI22S $T=909540 346640 0 180 $X=905820 $Y=341220
X416 975 1055 1122 1029 1 974 2 AOI22S $T=916360 326480 0 0 $X=916360 $Y=326100
X417 972 976 1125 1073 1 1066 2 AOI22S $T=919460 326480 1 0 $X=919460 $Y=321060
X418 1066 1117 1135 978 1 974 2 AOI22S $T=926900 326480 1 180 $X=923180 $Y=326100
X419 972 1040 1134 991 1 1083 2 AOI22S $T=926900 336560 1 0 $X=926900 $Y=331140
X420 972 978 5007 991 1 1137 2 AOI22S $T=927520 346640 1 0 $X=927520 $Y=341220
X421 1145 978 5102 4985 1 1150 2 AOI22S $T=936820 336560 1 0 $X=936820 $Y=331140
X422 5129 5137 5119 5143 1 5164 2 AOI22S $T=944880 477680 0 0 $X=944880 $Y=477300
X423 5149 5157 5138 5143 1 5164 2 AOI22S $T=947360 427280 0 0 $X=947360 $Y=426900
X424 5152 5133 5161 5143 1 5164 2 AOI22S $T=948600 477680 1 0 $X=948600 $Y=472260
X425 5118 5124 5136 5143 1 5164 2 AOI22S $T=949220 467600 0 0 $X=949220 $Y=467220
X426 5159 5167 5162 1166 1 1167 2 AOI22S $T=949840 507920 1 0 $X=949840 $Y=502500
X427 5166 5177 5174 5143 1 5164 2 AOI22S $T=952320 457520 1 0 $X=952320 $Y=452100
X428 5209 5198 5201 5143 1 5164 2 AOI22S $T=959140 397040 1 180 $X=955420 $Y=396660
X429 5153 5204 5180 5143 1 5164 2 AOI22S $T=959760 376880 0 0 $X=959760 $Y=376500
X430 5213 5219 5186 5143 1 5164 2 AOI22S $T=959760 407120 0 0 $X=959760 $Y=406740
X431 5241 5207 5193 5143 1 5164 2 AOI22S $T=964720 376880 0 180 $X=961000 $Y=371460
X432 5154 5236 5217 5143 1 5164 2 AOI22S $T=962240 417200 0 0 $X=962240 $Y=416820
X433 1081 1145 5125 1185 1 5181 2 AOI22S $T=963480 336560 1 0 $X=963480 $Y=331140
X434 5227 5243 5242 5143 1 5164 2 AOI22S $T=964100 477680 0 0 $X=964100 $Y=477300
X435 5239 5232 5216 5143 1 5164 2 AOI22S $T=966580 386960 1 0 $X=966580 $Y=381540
X436 5253 5246 5212 5143 1 5164 2 AOI22S $T=966580 437360 0 0 $X=966580 $Y=436980
X437 5279 5261 5130 1166 1 1167 2 AOI22S $T=970920 497840 1 180 $X=967200 $Y=497460
X438 5220 5260 5197 5143 1 5164 2 AOI22S $T=967820 457520 1 0 $X=967820 $Y=452100
X439 5280 5272 5247 1166 1 1167 2 AOI22S $T=972160 507920 1 180 $X=968440 $Y=507540
X440 1189 5268 5254 1166 1 1167 2 AOI22S $T=968440 518000 0 0 $X=968440 $Y=517620
X441 5251 5271 5211 5143 1 5164 2 AOI22S $T=969060 477680 0 0 $X=969060 $Y=477300
X442 5270 5233 5182 5143 1 5164 2 AOI22S $T=969680 467600 1 0 $X=969680 $Y=462180
X443 5264 5249 5274 5143 1 5164 2 AOI22S $T=970300 346640 0 0 $X=970300 $Y=346260
X444 5273 5278 5145 5282 1 5285 2 AOI22S $T=970300 437360 0 0 $X=970300 $Y=436980
X445 5312 5301 5214 5282 1 5285 2 AOI22S $T=982700 457520 0 180 $X=978980 $Y=452100
X446 5300 5308 5240 5282 1 5285 2 AOI22S $T=980840 386960 1 0 $X=980840 $Y=381540
X447 5311 5322 5202 5282 1 5285 2 AOI22S $T=983940 447440 1 0 $X=983940 $Y=442020
X448 5326 5327 5222 5282 1 5285 2 AOI22S $T=988280 437360 1 180 $X=984560 $Y=436980
X449 5319 5324 5142 5282 1 5285 2 AOI22S $T=984560 457520 0 0 $X=984560 $Y=457140
X450 5318 5325 5163 1205 1 1203 2 AOI22S $T=984560 507920 1 0 $X=984560 $Y=502500
X451 5320 5309 5258 5143 1 5164 2 AOI22S $T=985180 346640 0 0 $X=985180 $Y=346260
X452 5307 5328 5175 1205 1 1203 2 AOI22S $T=985180 518000 1 0 $X=985180 $Y=512580
X453 1209 1207 5257 1205 1 1203 2 AOI22S $T=989520 518000 1 180 $X=985800 $Y=517620
X454 5323 5341 5210 5282 1 5285 2 AOI22S $T=987660 376880 0 0 $X=987660 $Y=376500
X455 5366 5342 5231 5282 1 5285 2 AOI22S $T=991380 477680 0 180 $X=987660 $Y=472260
X456 5338 5277 5329 5143 1 5164 2 AOI22S $T=988280 356720 1 0 $X=988280 $Y=351300
X457 5356 5350 5330 5143 1 5164 2 AOI22S $T=992620 366800 0 180 $X=988900 $Y=361380
X458 5337 5282 5195 5351 1 5285 2 AOI22S $T=988900 467600 1 0 $X=988900 $Y=462180
X459 5362 5353 5256 1205 1 1203 2 AOI22S $T=993240 507920 0 180 $X=989520 $Y=502500
X460 5347 5357 5223 5282 1 5285 2 AOI22S $T=991380 417200 0 0 $X=991380 $Y=416820
X461 5368 5360 5345 5143 1 5164 2 AOI22S $T=995720 356720 0 180 $X=992000 $Y=351300
X462 5373 5313 5363 5143 1 5164 2 AOI22S $T=996340 346640 1 180 $X=992620 $Y=346260
X463 5335 5361 5127 5282 1 5285 2 AOI22S $T=992620 467600 0 0 $X=992620 $Y=467220
X464 5367 5370 5160 1205 1 1203 2 AOI22S $T=994480 507920 1 0 $X=994480 $Y=502500
X465 5374 5375 5369 1219 1 1223 2 AOI22S $T=996340 447440 0 0 $X=996340 $Y=447060
X466 5388 5378 5190 5282 1 5285 2 AOI22S $T=1000060 477680 0 180 $X=996340 $Y=472260
X467 5379 5355 5382 1219 1 1223 2 AOI22S $T=999440 437360 1 0 $X=999440 $Y=431940
X468 5383 1224 5387 1225 1 1227 2 AOI22S $T=1001300 518000 0 0 $X=1001300 $Y=517620
X469 5381 5384 5390 1229 1 1228 2 AOI22S $T=1003160 427280 0 0 $X=1003160 $Y=426900
X470 5404 5392 5386 1225 1 1227 2 AOI22S $T=1006880 507920 0 180 $X=1003160 $Y=502500
X471 5403 5395 5267 5282 1 5285 2 AOI22S $T=1008120 477680 0 180 $X=1004400 $Y=472260
X472 5391 5399 5364 1229 1 1228 2 AOI22S $T=1006260 467600 1 0 $X=1006260 $Y=462180
X473 5405 5406 5397 1219 1 1223 2 AOI22S $T=1008120 376880 0 0 $X=1008120 $Y=376500
X474 5385 5411 5401 1226 1 1236 2 AOI22S $T=1008120 427280 0 0 $X=1008120 $Y=426900
X475 5413 1237 5321 5282 1 5285 2 AOI22S $T=1013080 336560 1 180 $X=1009360 $Y=336180
X476 5398 5420 5393 1229 1 1228 2 AOI22S $T=1011220 376880 1 0 $X=1011220 $Y=371460
X477 5447 5415 5430 1225 1 1227 2 AOI22S $T=1014940 507920 0 180 $X=1011220 $Y=502500
X478 5408 5416 5419 1225 1 1227 2 AOI22S $T=1011840 507920 0 0 $X=1011840 $Y=507540
X479 5436 5427 5412 1226 1 1236 2 AOI22S $T=1016180 407120 1 180 $X=1012460 $Y=406740
X480 5423 5426 5414 1233 1 1235 2 AOI22S $T=1013080 427280 0 0 $X=1013080 $Y=426900
X481 5446 1239 5358 5282 1 5285 2 AOI22S $T=1017420 346640 0 180 $X=1013700 $Y=341220
X482 5425 5431 5229 5282 1 5285 2 AOI22S $T=1014940 356720 0 0 $X=1014940 $Y=356340
X483 5457 5437 5418 1219 1 1223 2 AOI22S $T=1018660 467600 1 180 $X=1014940 $Y=467220
X484 5422 5433 5407 1226 1 1236 2 AOI22S $T=1015560 386960 1 0 $X=1015560 $Y=381540
X485 5346 5428 5432 1233 1 1235 2 AOI22S $T=1015560 447440 1 0 $X=1015560 $Y=442020
X486 5438 5421 5429 1226 1 1236 2 AOI22S $T=1017420 447440 0 0 $X=1017420 $Y=447060
X487 5439 1241 5283 5282 1 5285 2 AOI22S $T=1018040 336560 0 0 $X=1018040 $Y=336180
X488 5460 5456 5269 5282 1 5285 2 AOI22S $T=1025480 336560 1 180 $X=1021760 $Y=336180
X489 5448 5453 5450 1233 1 1235 2 AOI22S $T=1021760 447440 1 0 $X=1021760 $Y=442020
X490 5462 5458 5380 1244 1 1243 2 AOI22S $T=1025480 507920 0 180 $X=1021760 $Y=502500
X491 5465 5452 5444 1244 1 1243 2 AOI22S $T=1026100 518000 1 180 $X=1022380 $Y=517620
X492 5442 1245 5348 5282 1 5285 2 AOI22S $T=1023000 346640 0 0 $X=1023000 $Y=346260
X493 5466 5464 5454 1226 1 1236 2 AOI22S $T=1028580 447440 1 180 $X=1024860 $Y=447060
X494 5451 5459 5424 1229 1 1228 2 AOI22S $T=1024860 477680 1 0 $X=1024860 $Y=472260
X495 5488 5461 5434 1244 1 1243 2 AOI22S $T=1030440 507920 0 180 $X=1026720 $Y=502500
X496 5463 5469 5417 1233 1 1235 2 AOI22S $T=1028580 407120 0 0 $X=1028580 $Y=406740
X497 5474 1247 1248 1244 1 1243 2 AOI22S $T=1032300 518000 1 180 $X=1028580 $Y=517620
X498 5470 5471 5185 5282 1 5285 2 AOI22S $T=1029820 346640 0 0 $X=1029820 $Y=346260
X499 5489 5484 5510 1226 1 1236 2 AOI22S $T=1036640 397040 1 180 $X=1032920 $Y=396660
X500 5491 5479 5440 1244 1 1243 2 AOI22S $T=1036640 507920 1 180 $X=1032920 $Y=507540
X501 5467 1249 5199 5282 1 5285 2 AOI22S $T=1033540 366800 1 0 $X=1033540 $Y=361380
X502 5480 5475 5409 1233 1 1235 2 AOI22S $T=1033540 386960 1 0 $X=1033540 $Y=381540
X503 5478 5485 5482 1229 1 1228 2 AOI22S $T=1033540 407120 0 0 $X=1033540 $Y=406740
X504 5481 5486 5468 1229 1 1228 2 AOI22S $T=1033540 427280 0 0 $X=1033540 $Y=426900
X505 5472 1250 5331 5282 1 5285 2 AOI22S $T=1034780 356720 1 0 $X=1034780 $Y=351300
X506 5483 5494 5449 1219 1 1223 2 AOI22S $T=1037880 467600 0 0 $X=1037880 $Y=467220
X507 5477 5495 5455 1229 1 1228 2 AOI22S $T=1037880 477680 0 0 $X=1037880 $Y=477300
X508 5492 5493 5498 1229 1 1228 2 AOI22S $T=1040360 366800 0 0 $X=1040360 $Y=366420
X509 5497 5501 5499 1219 1 1223 2 AOI22S $T=1040360 467600 1 0 $X=1040360 $Y=462180
X510 5496 5502 5500 1219 1 1223 2 AOI22S $T=1042220 457520 1 0 $X=1042220 $Y=452100
X511 5514 5508 5511 1229 1 1228 2 AOI22S $T=1047180 447440 0 180 $X=1043460 $Y=442020
X512 5503 5506 5505 1229 1 1228 2 AOI22S $T=1043460 477680 1 0 $X=1043460 $Y=472260
X513 5504 5516 5513 1229 1 1228 2 AOI22S $T=1047180 356720 0 0 $X=1047180 $Y=356340
X514 5524 5521 5529 1229 1 1228 2 AOI22S $T=1052760 346640 0 180 $X=1049040 $Y=341220
X515 5517 5519 5509 1233 1 1235 2 AOI22S $T=1049040 397040 0 0 $X=1049040 $Y=396660
X516 5515 5522 5487 1219 1 1223 2 AOI22S $T=1050280 417200 1 0 $X=1050280 $Y=411780
X517 1260 5525 5532 1258 1 1257 2 AOI22S $T=1054000 518000 1 180 $X=1050280 $Y=517620
X518 5520 5518 5473 1219 1 1223 2 AOI22S $T=1050900 427280 0 0 $X=1050900 $Y=426900
X519 5540 5535 5541 1219 1 1223 2 AOI22S $T=1055860 457520 0 180 $X=1052140 $Y=452100
X520 5534 5531 5523 1219 1 1223 2 AOI22S $T=1054000 376880 0 0 $X=1054000 $Y=376500
X521 5547 5544 5527 1263 1 1262 2 AOI22S $T=1058960 507920 0 180 $X=1055240 $Y=502500
X522 5537 5530 5528 1219 1 1223 2 AOI22S $T=1055860 356720 0 0 $X=1055860 $Y=356340
X523 5565 5536 5539 1219 1 1223 2 AOI22S $T=1060820 336560 1 180 $X=1057100 $Y=336180
X524 5557 5549 5543 1226 1 1236 2 AOI22S $T=1062060 417200 1 180 $X=1058340 $Y=416820
X525 5563 5554 5553 1219 1 1223 2 AOI22S $T=1063300 326480 1 180 $X=1059580 $Y=326100
X526 5551 5558 5556 1233 1 1235 2 AOI22S $T=1060820 437360 0 0 $X=1060820 $Y=436980
X527 5567 5555 5562 1219 1 1223 2 AOI22S $T=1064540 477680 0 180 $X=1060820 $Y=472260
X528 5573 5566 5568 1233 1 1235 2 AOI22S $T=1066400 417200 1 180 $X=1062680 $Y=416820
X529 5560 5564 5550 1263 1 1262 2 AOI22S $T=1062680 507920 1 0 $X=1062680 $Y=502500
X530 5588 5571 5606 1233 1 1235 2 AOI22S $T=1067640 447440 0 180 $X=1063920 $Y=442020
X531 5576 5572 5538 1229 1 1228 2 AOI22S $T=1068260 326480 1 180 $X=1064540 $Y=326100
X532 5552 5570 5546 1233 1 1235 2 AOI22S $T=1064540 407120 1 0 $X=1064540 $Y=401700
X533 5582 5575 5587 1219 1 1223 2 AOI22S $T=1069500 477680 0 180 $X=1065780 $Y=472260
X534 5569 5578 5579 1233 1 1235 2 AOI22S $T=1067640 397040 1 0 $X=1067640 $Y=391620
X535 5577 5581 5585 1233 1 1235 2 AOI22S $T=1068880 407120 0 0 $X=1068880 $Y=406740
X536 5574 5591 5586 1233 1 1235 2 AOI22S $T=1069500 376880 1 0 $X=1069500 $Y=371460
X537 5633 5583 5545 1229 1 1228 2 AOI22S $T=1073220 467600 0 180 $X=1069500 $Y=462180
X538 1269 5595 5584 1258 1 1257 2 AOI22S $T=1071360 518000 0 0 $X=1071360 $Y=517620
X539 5607 5598 5593 1233 1 1235 2 AOI22S $T=1076320 346640 0 180 $X=1072600 $Y=341220
X540 5611 5601 5594 1233 1 1235 2 AOI22S $T=1076940 356720 1 180 $X=1073220 $Y=356340
X541 5615 5608 5597 1226 1 1236 2 AOI22S $T=1079420 397040 0 180 $X=1075700 $Y=391620
X542 5622 5609 5602 1229 1 1228 2 AOI22S $T=1079420 477680 0 180 $X=1075700 $Y=472260
X543 5623 5610 5603 1229 1 1228 2 AOI22S $T=1079420 477680 1 180 $X=1075700 $Y=477300
X544 5620 5612 5599 1226 1 1236 2 AOI22S $T=1080040 407120 1 180 $X=1076320 $Y=406740
X545 5634 5613 5592 1263 1 1262 2 AOI22S $T=1080040 507920 1 180 $X=1076320 $Y=507540
X546 5628 5614 5589 1226 1 1236 2 AOI22S $T=1080660 346640 0 180 $X=1076940 $Y=341220
X547 5629 5616 5590 1226 1 1236 2 AOI22S $T=1081280 356720 1 180 $X=1077560 $Y=356340
X548 5630 5617 5604 1226 1 1236 2 AOI22S $T=1081280 376880 1 180 $X=1077560 $Y=376500
X549 5631 5618 5561 1226 1 1236 2 AOI22S $T=1081280 417200 1 180 $X=1077560 $Y=416820
X550 5627 5619 5559 1226 1 1236 2 AOI22S $T=1081280 437360 0 180 $X=1077560 $Y=431940
X551 5632 5621 5605 1226 1 1236 2 AOI22S $T=1081280 447440 1 180 $X=1077560 $Y=447060
X552 5625 5626 5580 1263 1 1262 2 AOI22S $T=1087480 507920 1 0 $X=1087480 $Y=502500
X553 1272 5624 1271 1263 1 1262 2 AOI22S $T=1087480 518000 0 0 $X=1087480 $Y=517620
X554 1297 9 1 2 16 AN2 $T=221340 366800 1 0 $X=221340 $Y=361380
X555 1318 1311 1 2 1304 AN2 $T=223820 437360 0 180 $X=221340 $Y=431940
X556 1337 1304 1 2 1305 AN2 $T=223820 447440 0 180 $X=221340 $Y=442020
X557 1299 1305 1 2 1316 AN2 $T=221340 457520 1 0 $X=221340 $Y=452100
X558 1329 1312 1 2 1306 AN2 $T=223820 467600 1 180 $X=221340 $Y=467220
X559 1317 1308 1 2 1300 AN2 $T=223820 497840 1 180 $X=221340 $Y=497460
X560 1301 1306 1 2 1322 AN2 $T=222580 477680 0 0 $X=222580 $Y=477300
X561 1327 1322 1 2 1308 AN2 $T=225060 487760 1 180 $X=222580 $Y=487380
X562 1343 1300 1 2 1313 AN2 $T=225060 507920 1 180 $X=222580 $Y=507540
X563 1338 1313 1 2 15 AN2 $T=225060 518000 0 180 $X=222580 $Y=512580
X564 29 1344 1 2 1342 AN2 $T=229400 457520 0 180 $X=226920 $Y=452100
X565 1388 1299 1 2 1312 AN2 $T=234980 467600 1 0 $X=234980 $Y=462180
X566 66 1344 1 2 1392 AN2 $T=237460 477680 0 180 $X=234980 $Y=472260
X567 1431 1445 1 2 1319 AN2 $T=241800 336560 0 0 $X=241800 $Y=336180
X568 82 1344 1 2 1453 AN2 $T=241800 467600 1 0 $X=241800 $Y=462180
X569 1476 1471 1 2 1350 AN2 $T=247380 427280 1 180 $X=244900 $Y=426900
X570 1464 1477 1 2 1483 AN2 $T=246760 467600 1 0 $X=246760 $Y=462180
X571 1512 1507 1 2 1493 AN2 $T=254200 477680 1 180 $X=251720 $Y=477300
X572 1658 1651 1 2 1477 AN2 $T=276520 457520 0 180 $X=274040 $Y=452100
X573 1666 1546 1 2 1633 AN2 $T=278380 427280 0 180 $X=275900 $Y=421860
X574 1663 1670 1 2 166 AN2 $T=279620 326480 1 180 $X=277140 $Y=326100
X575 1626 1621 1 2 1667 AN2 $T=277140 487760 1 0 $X=277140 $Y=482340
X576 1707 1682 1 2 1686 AN2 $T=283340 356720 0 180 $X=280860 $Y=351300
X577 1704 1700 1 2 1621 AN2 $T=283340 477680 1 180 $X=280860 $Y=477300
X578 1673 1667 1 2 1701 AN2 $T=280860 487760 0 0 $X=280860 $Y=487380
X579 1683 1548 1 2 1700 AN2 $T=282720 457520 0 0 $X=282720 $Y=457140
X580 185 1708 1 2 1605 AN2 $T=285200 487760 0 180 $X=282720 $Y=482340
X581 182 1708 1 2 1636 AN2 $T=285200 497840 0 180 $X=282720 $Y=492420
X582 1695 1689 1 2 180 AN2 $T=285200 518000 1 180 $X=282720 $Y=517620
X583 1719 1708 1 2 1522 AN2 $T=286440 487760 1 180 $X=283960 $Y=487380
X584 1688 1701 1 2 1723 AN2 $T=283960 497840 0 0 $X=283960 $Y=497460
X585 1733 1724 1 2 1651 AN2 $T=288300 457520 1 180 $X=285820 $Y=457140
X586 1726 1723 1 2 1689 AN2 $T=288300 518000 0 180 $X=285820 $Y=512580
X587 1743 1708 1 2 1694 AN2 $T=290160 487760 0 180 $X=287680 $Y=482340
X588 1734 1738 1 2 199 AN2 $T=289540 346640 0 0 $X=289540 $Y=346260
X589 1470 90 1 2 188 AN2 $T=289540 376880 0 0 $X=289540 $Y=376500
X590 1759 1711 1 2 1724 AN2 $T=293260 447440 0 180 $X=290780 $Y=442020
X591 1788 1637 1 2 1718 AN2 $T=300080 386960 1 180 $X=297600 $Y=386580
X592 1637 1716 1 2 1623 AN2 $T=301940 386960 0 180 $X=299460 $Y=381540
X593 209 1467 1 2 9 AN2 $T=303800 336560 0 180 $X=301320 $Y=331140
X594 1860 1869 1 2 1877 AN2 $T=319920 447440 1 0 $X=319920 $Y=442020
X595 1887 1867 1 2 1909 AN2 $T=324880 366800 1 0 $X=324880 $Y=361380
X596 1840 1869 1 2 1878 AN2 $T=326120 447440 1 0 $X=326120 $Y=442020
X597 270 1911 1 2 1834 AN2 $T=329220 356720 0 180 $X=326740 $Y=351300
X598 1917 1709 1 2 1830 AN2 $T=329220 427280 1 180 $X=326740 $Y=426900
X599 1897 1869 1 2 1885 AN2 $T=327980 437360 1 0 $X=327980 $Y=431940
X600 1927 1923 1 2 1892 AN2 $T=331080 447440 0 180 $X=328600 $Y=442020
X601 1905 1926 1 2 1615 AN2 $T=331700 376880 1 180 $X=329220 $Y=376500
X602 1911 1931 1 2 1852 AN2 $T=332320 346640 1 180 $X=329840 $Y=346260
X603 1978 1960 1 2 1936 AN2 $T=339140 397040 1 180 $X=336660 $Y=396660
X604 1961 249 1 2 1928 AN2 $T=339760 376880 0 180 $X=337280 $Y=371460
X605 268 1868 1 2 1974 AN2 $T=338520 346640 0 0 $X=338520 $Y=346260
X606 2012 1869 1 2 1923 AN2 $T=344100 437360 0 180 $X=341620 $Y=431940
X607 1992 1988 1 2 1977 AN2 $T=344100 477680 0 180 $X=341620 $Y=472260
X608 1984 1869 1 2 1985 AN2 $T=344720 447440 1 180 $X=342240 $Y=447060
X609 1972 1934 1 2 1988 AN2 $T=344720 467600 0 0 $X=344720 $Y=467220
X610 1973 299 1 2 2008 AN2 $T=345340 487760 0 0 $X=345340 $Y=487380
X611 307 299 1 2 2020 AN2 $T=346580 487760 1 0 $X=346580 $Y=482340
X612 2026 1869 1 2 1982 AN2 $T=351540 447440 1 180 $X=349060 $Y=447060
X613 298 299 1 2 2039 AN2 $T=350300 487760 1 0 $X=350300 $Y=482340
X614 2044 1955 1 2 281 AN2 $T=353400 356720 0 180 $X=350920 $Y=351300
X615 2044 286 1 2 293 AN2 $T=355880 346640 0 180 $X=353400 $Y=341220
X616 283 286 1 2 2018 AN2 $T=358360 386960 0 180 $X=355880 $Y=381540
X617 314 299 1 2 2083 AN2 $T=355880 497840 1 0 $X=355880 $Y=492420
X618 2073 2071 1 2 320 AN2 $T=358360 518000 1 180 $X=355880 $Y=517620
X619 2075 2078 1 2 2071 AN2 $T=359600 507920 1 180 $X=357120 $Y=507540
X620 2058 1977 1 2 2089 AN2 $T=358980 477680 1 0 $X=358980 $Y=472260
X621 2092 2091 1 2 2084 AN2 $T=363320 497840 0 180 $X=360840 $Y=492420
X622 2085 2084 1 2 2078 AN2 $T=360840 507920 1 0 $X=360840 $Y=502500
X623 2100 2089 1 2 2088 AN2 $T=362700 477680 0 0 $X=362700 $Y=477300
X624 2013 2088 1 2 2113 AN2 $T=362700 487760 1 0 $X=362700 $Y=482340
X625 2053 1869 1 2 2067 AN2 $T=363940 417200 0 0 $X=363940 $Y=416820
X626 2124 2113 1 2 2091 AN2 $T=368280 487760 0 180 $X=365800 $Y=482340
X627 2122 327 1 2 328 AN2 $T=367660 326480 1 0 $X=367660 $Y=321060
X628 2123 1869 1 2 2087 AN2 $T=367660 447440 1 0 $X=367660 $Y=442020
X629 2136 1869 1 2 2142 AN2 $T=370760 397040 0 0 $X=370760 $Y=396660
X630 2170 327 1 2 2105 AN2 $T=378820 346640 0 180 $X=376340 $Y=341220
X631 2259 1869 1 2 2128 AN2 $T=381920 457520 1 180 $X=379440 $Y=457140
X632 2148 1869 1 2 2190 AN2 $T=383780 407120 1 180 $X=381300 $Y=406740
X633 2208 1869 1 2 2072 AN2 $T=385640 437360 1 180 $X=383160 $Y=436980
X634 2107 1869 1 2 2133 AN2 $T=386880 427280 0 180 $X=384400 $Y=421860
X635 2227 2231 1 2 2239 AN2 $T=388120 397040 0 0 $X=388120 $Y=396660
X636 2260 2255 1 2 2249 AN2 $T=393700 346640 1 180 $X=391220 $Y=346260
X637 2250 2249 1 2 2261 AN2 $T=391220 356720 0 0 $X=391220 $Y=356340
X638 2257 2256 1 2 2231 AN2 $T=393700 397040 1 180 $X=391220 $Y=396660
X639 2262 2261 1 2 2243 AN2 $T=395560 376880 0 180 $X=393080 $Y=371460
X640 2251 2243 1 2 2256 AN2 $T=393080 386960 0 0 $X=393080 $Y=386580
X641 2263 346 1 2 2270 AN2 $T=394940 336560 1 0 $X=394940 $Y=331140
X642 2276 1869 1 2 2229 AN2 $T=397420 457520 0 180 $X=394940 $Y=452100
X643 2277 1869 1 2 2209 AN2 $T=397420 467600 0 180 $X=394940 $Y=462180
X644 2274 2270 1 2 2255 AN2 $T=400520 336560 1 180 $X=398040 $Y=336180
X645 2275 1869 1 2 2137 AN2 $T=400520 477680 1 180 $X=398040 $Y=477300
X646 354 1869 1 2 2163 AN2 $T=404240 507920 1 180 $X=401760 $Y=507540
X647 2282 2239 1 2 2327 AN2 $T=403620 397040 0 0 $X=403620 $Y=396660
X648 363 1869 1 2 2166 AN2 $T=406100 507920 0 180 $X=403620 $Y=502500
X649 2300 2304 1 2 2324 AN2 $T=404860 407120 1 0 $X=404860 $Y=401700
X650 362 1869 1 2 2238 AN2 $T=407340 497840 1 180 $X=404860 $Y=497460
X651 2315 2324 1 2 2340 AN2 $T=406720 407120 0 0 $X=406720 $Y=406740
X652 2374 2371 1 2 2304 AN2 $T=416640 407120 0 180 $X=414160 $Y=401700
X653 2351 2327 1 2 2371 AN2 $T=415400 397040 0 0 $X=415400 $Y=396660
X654 2414 1869 1 2 2328 AN2 $T=424700 467600 0 180 $X=422220 $Y=462180
X655 2451 1869 1 2 2331 AN2 $T=429660 467600 0 180 $X=427180 $Y=462180
X656 2448 2442 1 2 2430 AN2 $T=431520 407120 0 180 $X=429040 $Y=401700
X657 2432 2430 1 2 2449 AN2 $T=429040 407120 0 0 $X=429040 $Y=406740
X658 2443 2449 1 2 2454 AN2 $T=432140 407120 0 0 $X=432140 $Y=406740
X659 2486 2464 1 2 2442 AN2 $T=436480 397040 0 180 $X=434000 $Y=391620
X660 391 390 1 2 2497 AN2 $T=437100 326480 1 0 $X=437100 $Y=321060
X661 2474 2463 1 2 2464 AN2 $T=440200 386960 1 180 $X=437720 $Y=386580
X662 2459 2454 1 2 2510 AN2 $T=437720 427280 1 0 $X=437720 $Y=421860
X663 2479 1869 1 2 2391 AN2 $T=440200 457520 1 180 $X=437720 $Y=457140
X664 2495 2497 1 2 2473 AN2 $T=438960 336560 1 0 $X=438960 $Y=331140
X665 2499 2500 1 2 2504 AN2 $T=438960 366800 1 0 $X=438960 $Y=361380
X666 2508 2504 1 2 2463 AN2 $T=441440 376880 1 180 $X=438960 $Y=376500
X667 2511 2506 1 2 2500 AN2 $T=442060 356720 0 180 $X=439580 $Y=351300
X668 2480 2473 1 2 2506 AN2 $T=440820 346640 1 0 $X=440820 $Y=341220
X669 2519 2510 1 2 2538 AN2 $T=443920 427280 1 0 $X=443920 $Y=421860
X670 2545 2538 1 2 2555 AN2 $T=449500 427280 1 0 $X=449500 $Y=421860
X671 2533 1869 1 2 2487 AN2 $T=451980 487760 0 180 $X=449500 $Y=482340
X672 2560 1869 1 2 2584 AN2 $T=452600 477680 0 0 $X=452600 $Y=477300
X673 2593 1869 1 2 2471 AN2 $T=458800 457520 1 180 $X=456320 $Y=457140
X674 2599 2606 1 2 2569 AN2 $T=463760 437360 0 180 $X=461280 $Y=431940
X675 2608 420 1 2 426 AN2 $T=463140 326480 1 0 $X=463140 $Y=321060
X676 2635 2630 1 2 2606 AN2 $T=467480 437360 1 180 $X=465000 $Y=436980
X677 2659 2654 1 2 2623 AN2 $T=471200 407120 0 180 $X=468720 $Y=401700
X678 2629 2623 1 2 2649 AN2 $T=468720 407120 0 0 $X=468720 $Y=406740
X679 2676 2671 1 2 2654 AN2 $T=475540 397040 1 180 $X=473060 $Y=396660
X680 2655 2649 1 2 2682 AN2 $T=473060 417200 1 0 $X=473060 $Y=411780
X681 2684 2672 1 2 2630 AN2 $T=475540 447440 0 180 $X=473060 $Y=442020
X682 438 440 1 2 2706 AN2 $T=474920 326480 1 0 $X=474920 $Y=321060
X683 2688 2685 1 2 2671 AN2 $T=477400 376880 1 180 $X=474920 $Y=376500
X684 2714 2713 1 2 2696 AN2 $T=482360 336560 1 180 $X=479880 $Y=336180
X685 2707 2710 1 2 2716 AN2 $T=479880 427280 1 0 $X=479880 $Y=421860
X686 2715 2716 1 2 2672 AN2 $T=482360 437360 0 180 $X=479880 $Y=431940
X687 2689 2682 1 2 2710 AN2 $T=481740 417200 0 0 $X=481740 $Y=416820
X688 2719 2706 1 2 2685 AN2 $T=484840 366800 0 0 $X=484840 $Y=366420
X689 2747 2735 1 2 2776 AN2 $T=489800 437360 1 0 $X=489800 $Y=431940
X690 2811 2817 1 2 2818 AN2 $T=498480 477680 0 0 $X=498480 $Y=477300
X691 2812 2818 1 2 2827 AN2 $T=498480 487760 1 0 $X=498480 $Y=482340
X692 2814 2819 1 2 483 AN2 $T=498480 518000 0 0 $X=498480 $Y=517620
X693 2783 2799 1 2 2829 AN2 $T=499720 447440 0 0 $X=499720 $Y=447060
X694 2746 2799 1 2 2836 AN2 $T=500340 447440 1 0 $X=500340 $Y=442020
X695 2833 2827 1 2 2822 AN2 $T=502820 487760 1 180 $X=500340 $Y=487380
X696 2810 2822 1 2 2830 AN2 $T=500340 507920 1 0 $X=500340 $Y=502500
X697 2837 2830 1 2 2819 AN2 $T=502820 507920 1 180 $X=500340 $Y=507540
X698 2848 2839 1 2 2817 AN2 $T=504680 477680 0 180 $X=502200 $Y=472260
X699 2789 2799 1 2 2857 AN2 $T=504060 447440 1 0 $X=504060 $Y=442020
X700 2788 2799 1 2 2858 AN2 $T=504060 447440 0 0 $X=504060 $Y=447060
X701 2866 2859 1 2 2846 AN2 $T=507780 457520 0 180 $X=505300 $Y=452100
X702 2871 2869 1 2 2852 AN2 $T=509640 417200 1 180 $X=507160 $Y=416820
X703 2845 2870 1 2 2859 AN2 $T=509640 447440 0 180 $X=507160 $Y=442020
X704 2868 2846 1 2 2839 AN2 $T=509640 467600 1 180 $X=507160 $Y=467220
X705 2876 2875 1 2 2870 AN2 $T=510260 447440 1 0 $X=510260 $Y=442020
X706 2961 2970 1 2 3001 AN2 $T=529480 437360 0 0 $X=529480 $Y=436980
X707 3060 3042 1 2 577 AN2 $T=543120 346640 0 180 $X=540640 $Y=341220
X708 3096 3083 1 2 3071 AN2 $T=546840 477680 0 180 $X=544360 $Y=472260
X709 3106 3071 1 2 3087 AN2 $T=548700 477680 1 180 $X=546220 $Y=477300
X710 3077 3087 1 2 3093 AN2 $T=546220 487760 0 0 $X=546220 $Y=487380
X711 3088 3093 1 2 3105 AN2 $T=546220 497840 1 0 $X=546220 $Y=492420
X712 3034 3023 1 2 3112 AN2 $T=548080 437360 0 0 $X=548080 $Y=436980
X713 3066 3023 1 2 3118 AN2 $T=548080 447440 1 0 $X=548080 $Y=442020
X714 3031 3023 1 2 3122 AN2 $T=548080 447440 0 0 $X=548080 $Y=447060
X715 3099 3113 1 2 3083 AN2 $T=551180 467600 0 180 $X=548700 $Y=462180
X716 3082 3092 1 2 3139 AN2 $T=549940 427280 0 0 $X=549940 $Y=426900
X717 3127 3119 1 2 3113 AN2 $T=552420 457520 1 180 $X=549940 $Y=457140
X718 3137 3120 1 2 3114 AN2 $T=552420 507920 1 180 $X=549940 $Y=507540
X719 3139 3138 1 2 3126 AN2 $T=554280 437360 0 180 $X=551800 $Y=431940
X720 3128 3126 1 2 3141 AN2 $T=553040 447440 1 0 $X=553040 $Y=442020
X721 3129 3141 1 2 3119 AN2 $T=553040 457520 0 0 $X=553040 $Y=457140
X722 3108 3105 1 2 3120 AN2 $T=553040 507920 1 0 $X=553040 $Y=502500
X723 3109 3114 1 2 594 AN2 $T=555520 518000 0 180 $X=553040 $Y=512580
X724 3054 3166 1 2 3157 AN2 $T=563580 407120 0 0 $X=563580 $Y=406740
X725 3213 3202 1 2 2918 AN2 $T=567920 336560 1 180 $X=565440 $Y=336180
X726 3169 3147 1 2 3159 AN2 $T=567920 366800 0 0 $X=567920 $Y=366420
X727 3228 641 1 2 3250 AN2 $T=571640 397040 1 0 $X=571640 $Y=391620
X728 638 558 1 2 612 AN2 $T=572260 356720 0 0 $X=572260 $Y=356340
X729 3212 641 1 2 3242 AN2 $T=573500 407120 1 0 $X=573500 $Y=401700
X730 3164 641 1 2 3265 AN2 $T=575360 386960 0 0 $X=575360 $Y=386580
X731 3289 3169 1 2 3268 AN2 $T=582800 366800 0 180 $X=580320 $Y=361380
X732 3344 641 1 2 3380 AN2 $T=595820 376880 0 0 $X=595820 $Y=376500
X733 3359 641 1 2 3392 AN2 $T=597680 417200 1 0 $X=597680 $Y=411780
X734 3375 3315 1 2 3403 AN2 $T=598920 437360 1 0 $X=598920 $Y=431940
X735 3401 3366 1 2 3419 AN2 $T=602020 356720 1 0 $X=602020 $Y=351300
X736 3403 3416 1 2 3426 AN2 $T=604500 427280 0 0 $X=604500 $Y=426900
X737 3476 3466 1 2 631 AN2 $T=615040 346640 1 180 $X=612560 $Y=346260
X738 3451 2968 1 2 3471 AN2 $T=612560 437360 0 0 $X=612560 $Y=436980
X739 700 701 1 2 688 AN2 $T=615040 518000 1 180 $X=612560 $Y=517620
X740 3474 2968 1 2 3467 AN2 $T=616900 437360 0 180 $X=614420 $Y=431940
X741 3472 3478 1 2 3494 AN2 $T=614420 467600 0 0 $X=614420 $Y=467220
X742 3507 641 1 2 3458 AN2 $T=618760 407120 1 180 $X=616280 $Y=406740
X743 3443 2968 1 2 3498 AN2 $T=616280 447440 1 0 $X=616280 $Y=442020
X744 3483 3491 1 2 3506 AN2 $T=616280 487760 0 0 $X=616280 $Y=487380
X745 3488 3494 1 2 3491 AN2 $T=616900 487760 1 0 $X=616900 $Y=482340
X746 3426 3461 1 2 3504 AN2 $T=617520 427280 0 0 $X=617520 $Y=426900
X747 3512 3510 1 2 3478 AN2 $T=620620 467600 1 180 $X=618140 $Y=467220
X748 3499 3506 1 2 3511 AN2 $T=618140 497840 1 0 $X=618140 $Y=492420
X749 3505 3504 1 2 3526 AN2 $T=618760 447440 1 0 $X=618760 $Y=442020
X750 3495 3511 1 2 3496 AN2 $T=618760 507920 0 0 $X=618760 $Y=507540
X751 3520 685 1 2 3447 AN2 $T=621860 366800 0 180 $X=619380 $Y=361380
X752 3521 3504 1 2 3509 AN2 $T=621860 437360 0 180 $X=619380 $Y=431940
X753 3500 3496 1 2 709 AN2 $T=621860 518000 0 180 $X=619380 $Y=512580
X754 283 3519 1 2 3501 AN2 $T=622480 376880 0 180 $X=620000 $Y=371460
X755 3535 708 1 2 3433 AN2 $T=623720 336560 1 180 $X=621240 $Y=336180
X756 270 3535 1 2 690 AN2 $T=625580 326480 1 180 $X=623100 $Y=326100
X757 3534 3526 1 2 3522 AN2 $T=625580 457520 0 180 $X=623100 $Y=452100
X758 3524 3522 1 2 3510 AN2 $T=625580 467600 0 180 $X=623100 $Y=462180
X759 3517 3521 1 2 3505 AN2 $T=625580 447440 1 0 $X=625580 $Y=442020
X760 692 696 1 2 3583 AN2 $T=626200 356720 0 0 $X=626200 $Y=356340
X761 3566 3558 1 2 3513 AN2 $T=630540 386960 1 180 $X=628060 $Y=386580
X762 734 641 1 2 3618 AN2 $T=634880 487760 0 0 $X=634880 $Y=487380
X763 739 641 1 2 3610 AN2 $T=636120 507920 1 0 $X=636120 $Y=502500
X764 3612 641 1 2 3531 AN2 $T=639220 437360 0 180 $X=636740 $Y=431940
X765 3630 641 1 2 3582 AN2 $T=641080 417200 0 180 $X=638600 $Y=411780
X766 3598 3519 1 2 718 AN2 $T=642940 346640 1 180 $X=640460 $Y=346260
X767 3598 3540 1 2 713 AN2 $T=646040 346640 0 180 $X=643560 $Y=341220
X768 752 641 1 2 3594 AN2 $T=651000 467600 0 0 $X=651000 $Y=467220
X769 3696 641 1 2 3545 AN2 $T=659060 447440 1 180 $X=656580 $Y=447060
X770 3649 641 1 2 3747 AN2 $T=657200 336560 0 0 $X=657200 $Y=336180
X771 3656 641 1 2 3707 AN2 $T=657200 356720 1 0 $X=657200 $Y=351300
X772 3679 641 1 2 3717 AN2 $T=658440 366800 1 0 $X=658440 $Y=361380
X773 3677 641 1 2 3715 AN2 $T=660300 346640 0 0 $X=660300 $Y=346260
X774 3680 641 1 2 3711 AN2 $T=660300 376880 0 0 $X=660300 $Y=376500
X775 3678 641 1 2 3716 AN2 $T=667120 386960 0 0 $X=667120 $Y=386580
X776 3706 641 1 2 3741 AN2 $T=667120 417200 0 0 $X=667120 $Y=416820
X777 3652 641 1 2 3758 AN2 $T=672080 397040 0 0 $X=672080 $Y=396660
X778 3722 641 1 2 3774 AN2 $T=672080 437360 0 0 $X=672080 $Y=436980
X779 3757 641 1 2 3765 AN2 $T=673940 447440 0 0 $X=673940 $Y=447060
X780 3801 3811 1 2 3804 AN2 $T=679520 457520 1 0 $X=679520 $Y=452100
X781 3808 3804 1 2 3850 AN2 $T=682620 457520 0 0 $X=682620 $Y=457140
X782 3855 3843 1 2 3833 AN2 $T=686960 386960 1 180 $X=684480 $Y=386580
X783 3846 3833 1 2 3792 AN2 $T=686960 397040 1 180 $X=684480 $Y=396660
X784 3840 3842 1 2 3843 AN2 $T=685100 386960 1 0 $X=685100 $Y=381540
X785 3784 3783 1 2 3842 AN2 $T=685720 366800 0 0 $X=685720 $Y=366420
X786 3854 3848 1 2 3811 AN2 $T=688200 447440 1 180 $X=685720 $Y=447060
X787 3793 3792 1 2 3859 AN2 $T=686340 407120 1 0 $X=686340 $Y=401700
X788 3813 3858 1 2 3860 AN2 $T=687580 346640 0 0 $X=687580 $Y=346260
X789 3872 3860 1 2 3853 AN2 $T=690060 356720 0 180 $X=687580 $Y=351300
X790 3865 3853 1 2 3783 AN2 $T=690060 366800 0 180 $X=687580 $Y=361380
X791 3775 641 1 2 3874 AN2 $T=687580 437360 0 0 $X=687580 $Y=436980
X792 3864 785 1 2 3881 AN2 $T=691300 326480 0 0 $X=691300 $Y=326100
X793 3889 3881 1 2 3858 AN2 $T=693780 346640 0 180 $X=691300 $Y=341220
X794 3866 3859 1 2 3886 AN2 $T=691300 407120 1 0 $X=691300 $Y=401700
X795 3776 641 1 2 3887 AN2 $T=691300 437360 1 0 $X=691300 $Y=431940
X796 3922 3915 1 2 3848 AN2 $T=698740 447440 1 180 $X=696260 $Y=447060
X797 3882 3886 1 2 3924 AN2 $T=696880 407120 1 0 $X=696880 $Y=401700
X798 3893 3888 1 2 3925 AN2 $T=698120 507920 1 0 $X=698120 $Y=502500
X799 3760 641 1 2 3745 AN2 $T=698740 407120 0 0 $X=698740 $Y=406740
X800 3930 3941 1 2 3908 AN2 $T=701220 487760 1 0 $X=701220 $Y=482340
X801 3945 3948 1 2 3915 AN2 $T=703080 457520 0 0 $X=703080 $Y=457140
X802 3929 3925 1 2 3941 AN2 $T=703080 497840 1 0 $X=703080 $Y=492420
X803 3963 3958 1 2 3888 AN2 $T=705560 497840 1 180 $X=703080 $Y=497460
X804 4003 3984 1 2 3948 AN2 $T=710520 457520 1 180 $X=708040 $Y=457140
X805 3973 3969 1 2 3958 AN2 $T=710520 518000 0 180 $X=708040 $Y=512580
X806 4012 3997 1 2 3969 AN2 $T=712380 507920 1 180 $X=709900 $Y=507540
X807 4038 4028 1 2 3984 AN2 $T=717340 467600 0 180 $X=714860 $Y=462180
X808 4064 4077 1 2 3997 AN2 $T=723540 507920 1 0 $X=723540 $Y=502500
X809 4112 4101 1 2 4077 AN2 $T=729120 507920 0 180 $X=726640 $Y=502500
X810 4127 4115 1 2 4028 AN2 $T=730980 467600 0 180 $X=728500 $Y=462180
X811 4150 4145 1 2 4101 AN2 $T=737800 507920 0 180 $X=735320 $Y=502500
X812 4176 4177 1 2 4115 AN2 $T=744620 467600 0 180 $X=742140 $Y=462180
X813 4187 4181 1 2 4161 AN2 $T=746480 336560 0 180 $X=744000 $Y=331140
X814 4155 4149 1 2 4193 AN2 $T=744000 386960 0 0 $X=744000 $Y=386580
X815 4167 4161 1 2 4168 AN2 $T=748340 336560 1 180 $X=745860 $Y=336180
X816 4163 4168 1 2 4189 AN2 $T=745860 346640 1 0 $X=745860 $Y=341220
X817 4190 4189 1 2 4203 AN2 $T=745860 366800 1 0 $X=745860 $Y=361380
X818 4207 4203 1 2 4186 AN2 $T=748340 366800 1 180 $X=745860 $Y=366420
X819 4191 4186 1 2 4182 AN2 $T=745860 376880 0 0 $X=745860 $Y=376500
X820 4192 4182 1 2 4149 AN2 $T=749580 386960 1 180 $X=747100 $Y=386580
X821 843 842 1 2 4181 AN2 $T=750820 326480 0 180 $X=748340 $Y=321060
X822 4204 4193 1 2 4226 AN2 $T=748960 397040 1 0 $X=748960 $Y=391620
X823 4209 4223 1 2 4145 AN2 $T=751440 507920 0 180 $X=748960 $Y=502500
X824 4227 4226 1 2 4242 AN2 $T=750820 407120 0 0 $X=750820 $Y=406740
X825 4263 4252 1 2 4177 AN2 $T=758260 467600 0 180 $X=755780 $Y=462180
X826 4269 4266 1 2 4223 AN2 $T=760120 507920 0 180 $X=757640 $Y=502500
X827 4256 4242 1 2 4284 AN2 $T=760740 417200 0 0 $X=760740 $Y=416820
X828 4310 4303 1 2 4252 AN2 $T=766940 457520 0 180 $X=764460 $Y=452100
X829 4326 4316 1 2 4266 AN2 $T=770040 507920 0 180 $X=767560 $Y=502500
X830 863 4333 1 2 4342 AN2 $T=772520 427280 0 0 $X=772520 $Y=426900
X831 4362 4367 1 2 4303 AN2 $T=781820 457520 0 180 $X=779340 $Y=452100
X832 4377 4369 1 2 4316 AN2 $T=781820 507920 0 180 $X=779340 $Y=502500
X833 4373 4376 1 2 879 AN2 $T=783060 326480 1 0 $X=783060 $Y=321060
X834 4417 4411 1 2 4367 AN2 $T=788640 457520 0 180 $X=786160 $Y=452100
X835 4426 4413 1 2 4369 AN2 $T=788640 507920 0 180 $X=786160 $Y=502500
X836 4452 4442 1 2 4387 AN2 $T=794220 417200 0 180 $X=791740 $Y=411780
X837 4355 4458 1 2 4473 AN2 $T=796700 487760 0 0 $X=796700 $Y=487380
X838 4488 4482 1 2 4413 AN2 $T=801040 507920 0 180 $X=798560 $Y=502500
X839 4486 4490 1 2 4411 AN2 $T=802280 457520 0 180 $X=799800 $Y=452100
X840 4304 4458 1 2 4494 AN2 $T=799800 487760 0 0 $X=799800 $Y=487380
X841 4235 4458 1 2 4499 AN2 $T=801660 497840 1 0 $X=801660 $Y=492420
X842 4509 4496 1 2 4482 AN2 $T=804140 497840 1 180 $X=801660 $Y=497460
X843 4521 4517 1 2 4490 AN2 $T=807860 457520 0 180 $X=805380 $Y=452100
X844 4414 4516 1 2 4524 AN2 $T=806000 427280 0 0 $X=806000 $Y=426900
X845 4479 4516 1 2 4545 AN2 $T=806620 437360 1 0 $X=806620 $Y=431940
X846 4536 4539 1 2 4442 AN2 $T=810960 417200 1 180 $X=808480 $Y=416820
X847 900 901 1 2 4541 AN2 $T=810340 326480 1 0 $X=810340 $Y=321060
X848 4548 4547 1 2 4496 AN2 $T=812820 487760 1 180 $X=810340 $Y=487380
X849 4361 4516 1 2 4585 AN2 $T=811580 427280 0 0 $X=811580 $Y=426900
X850 4565 4557 1 2 4517 AN2 $T=814680 447440 1 180 $X=812200 $Y=447060
X851 4572 4511 1 2 4530 AN2 $T=814680 477680 0 180 $X=812200 $Y=472260
X852 4512 4541 1 2 4546 AN2 $T=813440 336560 0 0 $X=813440 $Y=336180
X853 4515 4546 1 2 4580 AN2 $T=813440 356720 1 0 $X=813440 $Y=351300
X854 4567 4566 1 2 4547 AN2 $T=815920 487760 1 180 $X=813440 $Y=487380
X855 4579 4580 1 2 4560 AN2 $T=817780 366800 1 180 $X=815300 $Y=366420
X856 4568 4570 1 2 4586 AN2 $T=815300 397040 1 0 $X=815300 $Y=391620
X857 4534 4538 1 2 4588 AN2 $T=815300 477680 0 0 $X=815300 $Y=477300
X858 4559 4560 1 2 4589 AN2 $T=817160 376880 1 0 $X=817160 $Y=371460
X859 4576 4589 1 2 4570 AN2 $T=819640 376880 1 180 $X=817160 $Y=376500
X860 4562 4590 1 2 4539 AN2 $T=819640 417200 0 180 $X=817160 $Y=411780
X861 4595 4588 1 2 4584 AN2 $T=819640 487760 0 180 $X=817160 $Y=482340
X862 4587 4586 1 2 4590 AN2 $T=819020 397040 1 0 $X=819020 $Y=391620
X863 4617 4616 1 2 4607 AN2 $T=826460 427280 1 180 $X=823980 $Y=426900
X864 4611 4607 1 2 4557 AN2 $T=826460 457520 0 180 $X=823980 $Y=452100
X865 4610 270 1 2 908 AN2 $T=824600 346640 0 0 $X=824600 $Y=346260
X866 4642 270 1 2 911 AN2 $T=831420 336560 0 180 $X=828940 $Y=331140
X867 4632 4639 1 2 4616 AN2 $T=831420 427280 1 180 $X=828940 $Y=426900
X868 4642 4623 1 2 4654 AN2 $T=830800 336560 0 0 $X=830800 $Y=336180
X869 4610 4623 1 2 4662 AN2 $T=832660 356720 1 0 $X=832660 $Y=351300
X870 4669 927 1 2 4653 AN2 $T=835760 518000 0 180 $X=833280 $Y=512580
X871 4668 4620 1 2 4644 AN2 $T=836380 386960 1 180 $X=833900 $Y=386580
X872 283 3519 1 2 4673 AN2 $T=838240 397040 1 180 $X=835760 $Y=396660
X873 4698 4689 1 2 4730 AN2 $T=840720 497840 0 0 $X=840720 $Y=497460
X874 4719 927 1 2 921 AN2 $T=845060 518000 1 180 $X=842580 $Y=517620
X875 4744 927 1 2 951 AN2 $T=848780 518000 0 180 $X=846300 $Y=512580
X876 4649 4514 1 2 4785 AN2 $T=852500 447440 0 0 $X=852500 $Y=447060
X877 4808 1049 1 2 4837 AN2 $T=881020 356720 1 180 $X=878540 $Y=356340
X878 4879 4802 1 2 4901 AN2 $T=890320 366800 0 0 $X=890320 $Y=366420
X879 5125 4772 1 2 5068 AN2 $T=943640 346640 0 180 $X=941160 $Y=341220
X880 5293 5265 1 2 1032 AN2 $T=970300 407120 0 180 $X=967820 $Y=401700
X881 5293 5291 1 2 1034 AN2 $T=976500 407120 1 180 $X=974020 $Y=406740
X882 5293 5299 1 2 1065 AN2 $T=982700 407120 0 180 $X=980220 $Y=401700
X883 5293 5310 1 2 1042 AN2 $T=981460 407120 0 0 $X=981460 $Y=406740
X884 5344 5265 1 2 5143 AN2 $T=989520 407120 1 180 $X=987040 $Y=406740
X885 5344 5291 1 2 1048 AN2 $T=990760 417200 0 180 $X=988280 $Y=411780
X886 5344 5310 1 2 5164 AN2 $T=992620 407120 1 180 $X=990140 $Y=406740
X887 5344 5299 1 2 5285 AN2 $T=995100 407120 1 180 $X=992620 $Y=406740
X888 5310 5303 1 2 1219 AN2 $T=995100 407120 0 0 $X=995100 $Y=406740
X889 5291 5303 1 2 1223 AN2 $T=997580 417200 0 0 $X=997580 $Y=416820
X890 5299 5377 1 2 1233 AN2 $T=1001920 397040 0 0 $X=1001920 $Y=396660
X891 5310 5377 1 2 1226 AN2 $T=1001920 417200 1 0 $X=1001920 $Y=411780
X892 5265 5303 1 2 1228 AN2 $T=1002540 407120 0 0 $X=1002540 $Y=406740
X893 5303 5299 1 2 1229 AN2 $T=1002540 417200 0 0 $X=1002540 $Y=416820
X894 5265 5377 1 2 1235 AN2 $T=1006260 407120 0 0 $X=1006260 $Y=406740
X895 5409 5407 1 2 5400 AN2 $T=1009980 386960 0 180 $X=1007500 $Y=381540
X896 5291 5377 1 2 1236 AN2 $T=1007500 407120 1 0 $X=1007500 $Y=401700
X897 5414 5401 1 2 5394 AN2 $T=1009980 437360 0 180 $X=1007500 $Y=431940
X898 5417 5412 1 2 5410 AN2 $T=1011840 407120 1 180 $X=1009360 $Y=406740
X899 5432 5429 1 2 5371 AN2 $T=1016180 447440 1 180 $X=1013700 $Y=447060
X900 5450 5454 1 2 5445 AN2 $T=1024240 447440 1 180 $X=1021760 $Y=447060
X901 5509 5510 1 2 5512 AN2 $T=1045320 407120 1 0 $X=1045320 $Y=401700
X902 5532 5527 1 2 5389 AN2 $T=1054620 507920 0 180 $X=1052140 $Y=502500
X903 5546 5543 1 2 5490 AN2 $T=1057720 417200 1 180 $X=1055240 $Y=416820
X904 1266 5550 1 2 5443 AN2 $T=1061440 507920 0 180 $X=1058960 $Y=502500
X905 5556 5559 1 2 5548 AN2 $T=1063300 447440 0 180 $X=1060820 $Y=442020
X906 5568 5561 1 2 5507 AN2 $T=1064540 427280 1 180 $X=1062060 $Y=426900
X907 5584 5580 1 2 5435 AN2 $T=1069500 507920 0 180 $X=1067020 $Y=502500
X908 5593 5589 1 2 5542 AN2 $T=1071980 346640 0 180 $X=1069500 $Y=341220
X909 5594 5590 1 2 5533 AN2 $T=1071980 356720 1 180 $X=1069500 $Y=356340
X910 1268 5592 1 2 5441 AN2 $T=1071980 507920 0 180 $X=1069500 $Y=502500
X911 5579 5597 1 2 5476 AN2 $T=1075080 397040 0 180 $X=1072600 $Y=391620
X912 5585 5599 1 2 5596 AN2 $T=1075700 407120 1 180 $X=1073220 $Y=406740
X913 5586 5604 1 2 5526 AN2 $T=1076940 376880 0 180 $X=1074460 $Y=371460
X914 5606 5605 1 2 5600 AN2 $T=1076940 447440 1 180 $X=1074460 $Y=447060
X915 1309 1363 61 2 1 1451 QDFFRBN $T=228160 417200 0 0 $X=228160 $Y=416820
X916 38 1363 61 2 1 1438 QDFFRBN $T=230640 397040 0 0 $X=230640 $Y=396660
X917 87 1363 61 2 1 1321 QDFFRBN $T=244900 407120 1 180 $X=233120 $Y=406740
X918 54 1363 61 2 1 1417 QDFFRBN $T=233740 407120 1 0 $X=233740 $Y=401700
X919 1559 1363 61 2 1 1461 QDFFRBN $T=258540 397040 1 180 $X=246760 $Y=396660
X920 1573 1363 61 2 1 1490 QDFFRBN $T=263500 407120 0 180 $X=251720 $Y=401700
X921 1644 1363 61 2 1 1590 QDFFRBN $T=279000 407120 1 180 $X=267220 $Y=406740
X922 1609 1363 61 2 1 1736 QDFFRBN $T=268460 407120 1 0 $X=268460 $Y=401700
X923 1692 1363 61 2 1 1747 QDFFRBN $T=280860 407120 0 0 $X=280860 $Y=406740
X924 222 1363 61 2 1 1748 QDFFRBN $T=305040 407120 0 180 $X=293260 $Y=401700
X925 1805 1363 61 2 1 1761 QDFFRBN $T=306280 417200 0 180 $X=294500 $Y=411780
X926 1792 217 61 2 1 1840 QDFFRBN $T=298840 437360 1 0 $X=298840 $Y=431940
X927 1857 1363 61 2 1 1807 QDFFRBN $T=316200 407120 1 180 $X=304420 $Y=406740
X928 1817 217 61 2 1 1860 QDFFRBN $T=305660 447440 0 0 $X=305660 $Y=447060
X929 1849 217 61 2 1 1897 QDFFRBN $T=314340 437360 1 0 $X=314340 $Y=431940
X930 264 1363 61 2 1 1953 QDFFRBN $T=324880 407120 0 0 $X=324880 $Y=406740
X931 1932 217 61 2 1 1984 QDFFRBN $T=331080 447440 1 0 $X=331080 $Y=442020
X932 1995 217 315 2 1 2053 QDFFRBN $T=344100 417200 1 0 $X=344100 $Y=411780
X933 1998 217 61 2 1 2026 QDFFRBN $T=344720 437360 0 0 $X=344720 $Y=436980
X934 2034 217 61 2 1 2107 QDFFRBN $T=351540 427280 0 0 $X=351540 $Y=426900
X935 316 217 315 2 1 2122 QDFFRBN $T=353400 326480 1 0 $X=353400 $Y=321060
X936 2060 217 315 2 1 2136 QDFFRBN $T=355880 397040 0 0 $X=355880 $Y=396660
X937 2066 217 315 2 1 2131 QDFFRBN $T=356500 376880 1 0 $X=356500 $Y=371460
X938 2082 217 315 2 1 2148 QDFFRBN $T=360220 407120 0 0 $X=360220 $Y=406740
X939 2093 217 315 2 1 2170 QDFFRBN $T=362080 346640 1 0 $X=362080 $Y=341220
X940 2150 217 61 2 1 2123 QDFFRBN $T=380060 437360 1 180 $X=368280 $Y=436980
X941 2165 217 61 2 1 2208 QDFFRBN $T=373860 447440 0 0 $X=373860 $Y=447060
X942 2194 217 61 2 1 2259 QDFFRBN $T=380680 457520 1 0 $X=380680 $Y=452100
X943 2203 217 61 2 1 2275 QDFFRBN $T=383160 477680 0 0 $X=383160 $Y=477300
X944 2225 217 61 2 1 2277 QDFFRBN $T=387500 467600 0 0 $X=387500 $Y=467220
X945 2287 217 61 2 1 2276 QDFFRBN $T=403620 477680 1 0 $X=403620 $Y=472260
X946 2326 217 61 2 1 2332 QDFFRBN $T=406100 487760 1 0 $X=406100 $Y=482340
X947 2289 217 61 2 1 354 QDFFRBN $T=407340 507920 0 0 $X=407340 $Y=507540
X948 2343 217 61 2 1 2414 QDFFRBN $T=409200 457520 0 0 $X=409200 $Y=457140
X949 2205 217 61 2 1 363 QDFFRBN $T=409200 507920 1 0 $X=409200 $Y=502500
X950 2226 217 61 2 1 362 QDFFRBN $T=411060 497840 1 0 $X=411060 $Y=492420
X951 2365 217 61 2 1 364 QDFFRBN $T=413540 518000 0 0 $X=413540 $Y=517620
X952 2396 376 61 2 1 389 QDFFRBN $T=419740 518000 1 0 $X=419740 $Y=512580
X953 2400 376 61 2 1 392 QDFFRBN $T=422220 487760 0 0 $X=422220 $Y=487380
X954 2401 376 61 2 1 387 QDFFRBN $T=422220 507920 0 0 $X=422220 $Y=507540
X955 2389 217 61 2 1 2451 QDFFRBN $T=422840 467600 0 0 $X=422840 $Y=467220
X956 2413 217 61 2 1 2479 QDFFRBN $T=423460 457520 0 0 $X=423460 $Y=457140
X957 2348 376 61 2 1 393 QDFFRBN $T=424080 497840 0 0 $X=424080 $Y=497460
X958 2359 376 61 2 1 395 QDFFRBN $T=425940 497840 1 0 $X=425940 $Y=492420
X959 2306 376 61 2 1 397 QDFFRBN $T=427800 518000 0 0 $X=427800 $Y=517620
X960 2462 376 61 2 1 402 QDFFRBN $T=434620 518000 1 0 $X=434620 $Y=512580
X961 2489 376 61 2 1 409 QDFFRBN $T=436480 507920 1 0 $X=436480 $Y=502500
X962 2388 376 61 2 1 2549 QDFFRBN $T=438960 497840 0 0 $X=438960 $Y=497460
X963 2505 217 61 2 1 2533 QDFFRBN $T=440200 477680 0 0 $X=440200 $Y=477300
X964 2483 376 61 2 1 414 QDFFRBN $T=441440 497840 1 0 $X=441440 $Y=492420
X965 2440 376 61 2 1 413 QDFFRBN $T=442680 518000 0 0 $X=442680 $Y=517620
X966 2551 376 61 2 1 421 QDFFRBN $T=450120 518000 1 0 $X=450120 $Y=512580
X967 2557 376 61 2 1 424 QDFFRBN $T=451360 507920 1 0 $X=451360 $Y=502500
X968 2526 376 61 2 1 427 QDFFRBN $T=453220 497840 0 0 $X=453220 $Y=497460
X969 2580 376 61 2 1 431 QDFFRBN $T=456320 518000 0 0 $X=456320 $Y=517620
X970 2583 217 61 2 1 2593 QDFFRBN $T=472440 457520 0 180 $X=460660 $Y=452100
X971 492 490 315 2 1 476 QDFFRBN $T=510260 326480 1 180 $X=498480 $Y=326100
X972 2896 490 315 2 1 2841 QDFFRBN $T=515840 336560 1 180 $X=504060 $Y=336180
X973 2928 490 315 2 1 401 QDFFRBN $T=520180 356720 1 180 $X=508400 $Y=356340
X974 525 490 315 2 1 450 QDFFRBN $T=525760 346640 1 180 $X=513980 $Y=346260
X975 3080 490 315 2 1 2723 QDFFRBN $T=541260 356720 1 180 $X=529480 $Y=356340
X976 3007 490 315 2 1 3006 QDFFRBN $T=533820 386960 1 0 $X=533820 $Y=381540
X977 3148 490 315 2 1 2926 QDFFRBN $T=553660 376880 1 180 $X=541880 $Y=376500
X978 3084 591 315 2 1 3164 QDFFRBN $T=545600 386960 0 0 $X=545600 $Y=386580
X979 3144 490 315 2 1 3192 QDFFRBN $T=553660 386960 1 0 $X=553660 $Y=381540
X980 3179 591 315 2 1 3228 QDFFRBN $T=561100 386960 0 0 $X=561100 $Y=386580
X981 3282 591 315 2 1 3344 QDFFRBN $T=580940 376880 0 0 $X=580940 $Y=376500
X982 3288 591 315 2 1 3359 QDFFRBN $T=581560 407120 0 0 $X=581560 $Y=406740
X983 3464 702 315 2 1 3507 QDFFRBN $T=612560 397040 0 0 $X=612560 $Y=396660
X984 3577 591 315 2 1 3630 QDFFRBN $T=631780 407120 0 0 $X=631780 $Y=406740
X985 3607 702 315 2 1 3652 QDFFRBN $T=636120 397040 0 0 $X=636120 $Y=396660
X986 3655 591 743 2 1 3612 QDFFRBN $T=649140 427280 1 180 $X=637360 $Y=426900
X987 3640 702 315 2 1 3678 QDFFRBN $T=643560 386960 0 0 $X=643560 $Y=386580
X988 3642 702 315 2 1 3677 QDFFRBN $T=644800 336560 0 0 $X=644800 $Y=336180
X989 3643 702 315 2 1 3679 QDFFRBN $T=644800 366800 0 0 $X=644800 $Y=366420
X990 3644 702 315 2 1 3680 QDFFRBN $T=644800 376880 0 0 $X=644800 $Y=376500
X991 758 702 315 2 1 3647 QDFFRBN $T=657820 326480 0 180 $X=646040 $Y=321060
X992 3683 702 315 2 1 3649 QDFFRBN $T=658440 336560 0 180 $X=646660 $Y=331140
X993 3654 591 743 2 1 3696 QDFFRBN $T=646660 447440 1 0 $X=646660 $Y=442020
X994 3708 754 743 2 1 749 QDFFRBN $T=659060 477680 0 180 $X=647280 $Y=472260
X995 3690 702 315 2 1 3656 QDFFRBN $T=659680 346640 1 180 $X=647900 $Y=346260
X996 3698 591 743 2 1 739 QDFFRBN $T=660920 507920 0 180 $X=649140 $Y=502500
X997 3663 754 743 2 1 750 QDFFRBN $T=661540 518000 1 180 $X=649760 $Y=517620
X998 3661 591 743 2 1 3706 QDFFRBN $T=650380 417200 0 0 $X=650380 $Y=416820
X999 3658 591 743 2 1 752 QDFFRBN $T=662160 467600 0 180 $X=650380 $Y=462180
X1000 3703 754 743 2 1 751 QDFFRBN $T=662780 507920 1 180 $X=651000 $Y=507540
X1001 3670 754 743 2 1 769 QDFFRBN $T=653480 497840 1 0 $X=653480 $Y=492420
X1002 3691 591 743 2 1 734 QDFFRBN $T=667120 487760 0 180 $X=655340 $Y=482340
X1003 3685 591 743 2 1 3722 QDFFRBN $T=657200 437360 1 0 $X=657200 $Y=431940
X1004 3731 754 743 2 1 756 QDFFRBN $T=668980 467600 1 180 $X=657200 $Y=467220
X1005 3742 754 743 2 1 761 QDFFRBN $T=670220 518000 0 180 $X=658440 $Y=512580
X1006 3693 591 743 2 1 3681 QDFFRBN $T=671460 457520 1 180 $X=659680 $Y=457140
X1007 3756 754 743 2 1 762 QDFFRBN $T=671460 487760 1 180 $X=659680 $Y=487380
X1008 3653 754 743 2 1 766 QDFFRBN $T=674560 497840 1 180 $X=662780 $Y=497460
X1009 3650 754 743 2 1 767 QDFFRBN $T=675180 477680 0 180 $X=663400 $Y=472260
X1010 3781 754 743 2 1 768 QDFFRBN $T=675800 507920 1 180 $X=664020 $Y=507540
X1011 3739 754 743 2 1 771 QDFFRBN $T=680140 497840 0 180 $X=668360 $Y=492420
X1012 3837 591 743 2 1 3757 QDFFRBN $T=686340 437360 1 180 $X=674560 $Y=436980
X1013 3905 591 743 2 1 3775 QDFFRBN $T=701840 447440 0 180 $X=690060 $Y=442020
X1014 4092 591 743 2 1 3776 QDFFRBN $T=727880 437360 0 180 $X=716100 $Y=431940
X1015 4603 906 743 2 1 4555 QDFFRBN $T=824600 346640 1 180 $X=812820 $Y=346260
X1016 4627 906 743 2 1 4550 QDFFRBN $T=829560 326480 1 180 $X=817780 $Y=326100
X1017 4714 906 743 2 1 4619 QDFFRBN $T=845680 407120 1 180 $X=833900 $Y=406740
X1018 4726 955 743 2 1 4669 QDFFRBN $T=847540 507920 1 180 $X=835760 $Y=507540
X1019 4729 906 743 2 1 899 QDFFRBN $T=848160 417200 1 180 $X=836380 $Y=416820
X1020 4833 955 743 2 1 4719 QDFFRBN $T=859940 497840 1 180 $X=848160 $Y=497460
X1021 4748 906 743 2 1 4804 QDFFRBN $T=849400 417200 1 0 $X=849400 $Y=411780
X1022 4807 955 743 2 1 4744 QDFFRBN $T=862420 507920 1 180 $X=850640 $Y=507540
X1023 4859 955 743 2 1 1012 QDFFRBN $T=877300 507920 1 180 $X=865520 $Y=507540
X1024 4863 955 743 2 1 4825 QDFFRBN $T=878540 497840 0 180 $X=866760 $Y=492420
X1025 4869 955 743 2 1 1020 QDFFRBN $T=879780 507920 0 180 $X=868000 $Y=502500
X1026 1052 955 743 2 1 4830 QDFFRBN $T=882260 518000 1 180 $X=870480 $Y=517620
X1027 1378 32 1360 2 1354 20 1 AO22 $T=231880 507920 0 180 $X=226920 $Y=502500
X1028 45 32 1331 2 28 20 1 AO22 $T=232500 518000 1 180 $X=227540 $Y=517620
X1029 1383 32 1330 2 1307 20 1 AO22 $T=233120 477680 0 180 $X=228160 $Y=472260
X1030 1394 32 1351 2 1375 20 1 AO22 $T=234980 477680 1 180 $X=230020 $Y=477300
X1031 1397 32 1345 2 1376 20 1 AO22 $T=234980 497840 0 180 $X=230020 $Y=492420
X1032 1408 32 1396 2 1341 20 1 AO22 $T=237460 437360 0 180 $X=232500 $Y=431940
X1033 1409 32 1366 2 1389 20 1 AO22 $T=237460 518000 0 180 $X=232500 $Y=512580
X1034 1427 32 1328 2 1342 20 1 AO22 $T=238700 447440 1 180 $X=233740 $Y=447060
X1035 1430 32 1365 2 1392 20 1 AO22 $T=239940 467600 1 180 $X=234980 $Y=467220
X1036 1479 32 1424 2 1453 20 1 AO22 $T=247380 457520 0 180 $X=242420 $Y=452100
X1037 1515 133 1501 2 1605 1630 1 AO22 $T=267840 457520 1 0 $X=267840 $Y=452100
X1038 1487 133 1492 2 1522 1630 1 AO22 $T=269080 447440 0 0 $X=269080 $Y=447060
X1039 1463 133 1628 2 1636 1630 1 AO22 $T=270320 457520 0 0 $X=270320 $Y=457140
X1040 1581 161 1638 2 1650 162 1 AO22 $T=272180 507920 1 0 $X=272180 $Y=502500
X1041 1562 133 1610 2 1652 1630 1 AO22 $T=274040 477680 0 0 $X=274040 $Y=477300
X1042 1565 161 1649 2 1660 162 1 AO22 $T=274040 497840 1 0 $X=274040 $Y=492420
X1043 1550 133 1655 2 1665 1630 1 AO22 $T=274660 467600 0 0 $X=274660 $Y=467220
X1044 127 161 1669 2 1677 162 1 AO22 $T=275900 518000 0 0 $X=275900 $Y=517620
X1045 1569 161 1681 2 1685 162 1 AO22 $T=277760 507920 0 0 $X=277760 $Y=507540
X1046 1614 133 1680 2 1694 1630 1 AO22 $T=279000 447440 0 0 $X=279000 $Y=447060
X1047 1578 133 1737 2 1703 1630 1 AO22 $T=288300 437360 1 0 $X=288300 $Y=431940
X1048 1882 265 1898 2 1870 253 1 AO22 $T=328600 467600 1 180 $X=323640 $Y=467220
X1049 1872 265 1941 2 1947 253 1 AO22 $T=331080 467600 0 0 $X=331080 $Y=467220
X1050 1927 265 1884 2 1950 253 1 AO22 $T=332320 477680 1 0 $X=332320 $Y=472260
X1051 1993 265 2019 2 2008 253 1 AO22 $T=352780 467600 1 180 $X=347820 $Y=467220
X1052 1976 265 2038 2 2039 253 1 AO22 $T=354020 467600 0 0 $X=354020 $Y=467220
X1053 2077 265 2061 2 2020 253 1 AO22 $T=358980 477680 1 180 $X=354020 $Y=477300
X1054 2096 265 2097 2 2083 253 1 AO22 $T=365180 467600 1 180 $X=360220 $Y=467220
X1055 2130 265 2118 2 2054 253 1 AO22 $T=368900 497840 0 180 $X=363940 $Y=492420
X1056 2135 265 2068 2 2059 253 1 AO22 $T=369520 507920 0 180 $X=364560 $Y=502500
X1057 2153 265 2098 2 2042 325 1 AO22 $T=370140 518000 0 180 $X=365180 $Y=512580
X1058 2139 265 2108 2 2062 253 1 AO22 $T=371380 507920 1 180 $X=366420 $Y=507540
X1059 2147 265 2134 2 2047 253 1 AO22 $T=373240 477680 1 180 $X=368280 $Y=477300
X1060 2140 337 2200 2 2204 2211 1 AO22 $T=381300 386960 1 0 $X=381300 $Y=381540
X1061 332 337 2210 2 2212 339 1 AO22 $T=383160 326480 0 0 $X=383160 $Y=326100
X1062 2081 337 2214 2 2223 339 1 AO22 $T=385020 356720 0 0 $X=385020 $Y=356340
X1063 2184 337 2219 2 2228 339 1 AO22 $T=385640 346640 0 0 $X=385640 $Y=346260
X1064 2167 337 2222 2 2232 339 1 AO22 $T=386260 346640 1 0 $X=386260 $Y=341220
X1065 2191 337 2233 2 2224 2211 1 AO22 $T=391840 366800 1 180 $X=386880 $Y=366420
X1066 2185 337 2234 2 2241 2211 1 AO22 $T=387500 397040 1 0 $X=387500 $Y=391620
X1067 2173 337 2237 2 2247 339 1 AO22 $T=388120 326480 0 0 $X=388120 $Y=326100
X1068 2155 337 2213 2 2266 2211 1 AO22 $T=394320 417200 1 0 $X=394320 $Y=411780
X1069 2102 327 2131 2 347 350 1 AO22 $T=395560 356720 0 0 $X=395560 $Y=356340
X1070 2286 337 2269 2 2267 2211 1 AO22 $T=402380 407120 1 180 $X=397420 $Y=406740
X1071 331 355 364 2 347 350 1 AO22 $T=406100 518000 1 0 $X=406100 $Y=512580
X1072 2358 337 2342 2 2335 2211 1 AO22 $T=413540 407120 0 180 $X=408580 $Y=401700
X1073 2372 337 2293 2 2303 2211 1 AO22 $T=415400 407120 1 180 $X=410440 $Y=406740
X1074 2376 337 2336 2 2346 2211 1 AO22 $T=416640 427280 0 180 $X=411680 $Y=421860
X1075 2302 337 2386 2 2368 2211 1 AO22 $T=416640 407120 0 0 $X=416640 $Y=406740
X1076 2398 337 2357 2 2379 2211 1 AO22 $T=422840 427280 0 180 $X=417880 $Y=421860
X1077 2434 2428 337 2 2403 2211 1 AO22 $T=428420 427280 0 180 $X=423460 $Y=421860
X1078 2319 2423 2425 2 2431 2437 1 AO22 $T=424080 437360 0 0 $X=424080 $Y=436980
X1079 2156 388 2455 2 2465 2491 1 AO22 $T=432760 346640 0 0 $X=432760 $Y=346260
X1080 2399 2423 2460 2 2469 2437 1 AO22 $T=432760 427280 0 0 $X=432760 $Y=426900
X1081 2176 388 2472 2 2475 2491 1 AO22 $T=433380 336560 1 0 $X=433380 $Y=331140
X1082 2141 2423 2453 2 2477 2491 1 AO22 $T=433380 386960 1 0 $X=433380 $Y=381540
X1083 2162 2423 2435 2 2452 2437 1 AO22 $T=433380 397040 0 0 $X=433380 $Y=396660
X1084 2186 388 2467 2 2484 2491 1 AO22 $T=434000 356720 1 0 $X=434000 $Y=351300
X1085 2199 2423 2468 2 2485 2491 1 AO22 $T=434000 376880 1 0 $X=434000 $Y=371460
X1086 2086 388 2476 2 2481 2491 1 AO22 $T=434620 356720 0 0 $X=434620 $Y=356340
X1087 2192 2423 2478 2 2490 2437 1 AO22 $T=434620 407120 1 0 $X=434620 $Y=401700
X1088 2377 2423 2456 2 2496 2437 1 AO22 $T=435860 417200 0 0 $X=435860 $Y=416820
X1089 2280 2423 2412 2 2458 2437 1 AO22 $T=436480 417200 1 0 $X=436480 $Y=411780
X1090 2407 2423 2517 2 2529 2437 1 AO22 $T=441440 417200 0 0 $X=441440 $Y=416820
X1091 2530 2423 2541 2 2539 2437 1 AO22 $T=450120 427280 1 180 $X=445160 $Y=426900
X1092 2482 419 2561 2 2592 422 1 AO22 $T=457560 447440 0 0 $X=457560 $Y=447060
X1093 2566 2598 388 2 2588 2620 1 AO22 $T=460040 427280 1 0 $X=460040 $Y=421860
X1094 2127 419 2611 2 2631 422 1 AO22 $T=463760 417200 1 0 $X=463760 $Y=411780
X1095 2439 419 2617 2 2624 422 1 AO22 $T=463760 447440 0 0 $X=463760 $Y=447060
X1096 2064 419 2632 2 2648 422 1 AO22 $T=466240 427280 1 0 $X=466240 $Y=421860
X1097 2647 419 2657 2 2643 422 1 AO22 $T=468720 437360 0 0 $X=468720 $Y=436980
X1098 2179 419 2661 2 2669 422 1 AO22 $T=471200 386960 1 0 $X=471200 $Y=381540
X1099 2057 419 2677 2 2679 422 1 AO22 $T=472440 407120 0 0 $X=472440 $Y=406740
X1100 2206 419 2667 2 2680 422 1 AO22 $T=472440 427280 0 0 $X=472440 $Y=426900
X1101 2320 419 2687 2 2697 422 1 AO22 $T=474920 437360 0 0 $X=474920 $Y=436980
X1102 2090 419 2699 2 2701 422 1 AO22 $T=475540 356720 0 0 $X=475540 $Y=356340
X1103 2149 419 2666 2 2702 422 1 AO22 $T=475540 366800 0 0 $X=475540 $Y=366420
X1104 2311 419 2709 2 2720 422 1 AO22 $T=479260 447440 0 0 $X=479260 $Y=447060
X1105 2872 491 2832 2 2765 460 1 AO22 $T=509640 497840 1 180 $X=504680 $Y=497460
X1106 494 491 2867 2 2731 460 1 AO22 $T=510260 507920 0 180 $X=505300 $Y=502500
X1107 2883 491 2843 2 2813 460 1 AO22 $T=512120 518000 1 180 $X=507160 $Y=517620
X1108 2893 491 2854 2 2800 460 1 AO22 $T=514600 477680 1 180 $X=509640 $Y=477300
X1109 2894 491 2861 2 2816 460 1 AO22 $T=514600 487760 1 180 $X=509640 $Y=487380
X1110 2899 491 2860 2 2794 460 1 AO22 $T=515220 487760 0 180 $X=510260 $Y=482340
X1111 2905 491 2873 2 2826 2620 1 AO22 $T=515840 467600 1 180 $X=510880 $Y=467220
X1112 2920 491 2879 2 2853 2620 1 AO22 $T=518320 467600 0 180 $X=513360 $Y=462180
X1113 2916 491 2884 2 2858 2620 1 AO22 $T=518940 447440 1 180 $X=513980 $Y=447060
X1114 2937 388 2904 2 2820 2620 1 AO22 $T=523280 417200 0 180 $X=518320 $Y=411780
X1115 3152 607 3124 2 3076 602 1 AO22 $T=556140 477680 0 180 $X=551180 $Y=472260
X1116 3175 607 3133 2 3090 602 1 AO22 $T=559860 477680 1 180 $X=554900 $Y=477300
X1117 3180 607 3134 2 3072 602 1 AO22 $T=560480 487760 0 180 $X=555520 $Y=482340
X1118 3176 607 3135 2 3035 602 1 AO22 $T=560480 487760 1 180 $X=555520 $Y=487380
X1119 618 607 3136 2 3101 602 1 AO22 $T=560480 497840 1 180 $X=555520 $Y=497460
X1120 3177 3006 3158 2 3118 602 1 AO22 $T=561720 437360 0 180 $X=556760 $Y=431940
X1121 3146 3006 3149 2 3073 602 1 AO22 $T=562340 467600 0 180 $X=557380 $Y=462180
X1122 3185 3006 3150 2 3112 602 1 AO22 $T=562960 447440 0 180 $X=558000 $Y=442020
X1123 621 607 3167 2 3100 602 1 AO22 $T=562960 518000 1 180 $X=558000 $Y=517620
X1124 3199 3006 3154 2 3122 602 1 AO22 $T=564820 447440 1 180 $X=559860 $Y=447060
X1125 3211 607 3156 2 3125 602 1 AO22 $T=564820 507920 1 180 $X=559860 $Y=507540
X1126 3201 3006 3174 2 3123 602 1 AO22 $T=568540 457520 1 180 $X=563580 $Y=457140
X1127 648 652 3241 2 3252 650 1 AO22 $T=574120 518000 1 0 $X=574120 $Y=512580
X1128 680 652 3388 2 3370 650 1 AO22 $T=601400 518000 1 180 $X=596440 $Y=517620
X1129 3398 419 3390 2 3378 650 1 AO22 $T=602020 417200 1 180 $X=597060 $Y=416820
X1130 723 652 3477 2 3452 650 1 AO22 $T=627440 507920 1 180 $X=622480 $Y=507540
X1131 3547 419 3518 2 3471 650 1 AO22 $T=628060 417200 1 180 $X=623100 $Y=416820
X1132 3536 419 3493 2 3498 650 1 AO22 $T=628680 437360 0 180 $X=623720 $Y=431940
X1133 730 652 3529 2 3486 650 1 AO22 $T=630540 507920 0 180 $X=625580 $Y=502500
X1134 3546 419 3516 2 3523 650 1 AO22 $T=631160 447440 1 180 $X=626200 $Y=447060
X1135 3600 652 3527 2 3473 650 1 AO22 $T=631160 477680 1 180 $X=626200 $Y=477300
X1136 721 652 3537 2 3484 650 1 AO22 $T=631780 497840 0 180 $X=626820 $Y=492420
X1137 3573 652 3539 2 3445 650 1 AO22 $T=632400 467600 1 180 $X=627440 $Y=467220
X1138 3579 652 3533 2 3450 650 1 AO22 $T=632400 487760 1 180 $X=627440 $Y=487380
X1139 3571 652 3502 2 3497 650 1 AO22 $T=633020 457520 1 180 $X=628060 $Y=457140
X1140 3675 641 3647 2 347 737 1 AO22 $T=655960 356720 0 180 $X=651000 $Y=351300
X1141 3754 776 3796 2 3807 778 1 AO22 $T=676420 397040 0 0 $X=676420 $Y=396660
X1142 3748 776 3806 2 3814 778 1 AO22 $T=677660 386960 0 0 $X=677660 $Y=386580
X1143 3733 776 3815 2 3821 778 1 AO22 $T=679520 326480 0 0 $X=679520 $Y=326100
X1144 3737 776 3763 2 3798 778 1 AO22 $T=679520 376880 1 0 $X=679520 $Y=371460
X1145 3702 776 3818 2 3826 778 1 AO22 $T=680140 386960 1 0 $X=680140 $Y=381540
X1146 3779 776 3778 2 3827 778 1 AO22 $T=680140 407120 0 0 $X=680140 $Y=406740
X1147 3743 776 3824 2 3829 778 1 AO22 $T=681380 356720 1 0 $X=681380 $Y=351300
X1148 3718 776 3825 2 3830 778 1 AO22 $T=681380 366800 1 0 $X=681380 $Y=361380
X1149 3738 776 3832 2 3797 778 1 AO22 $T=682000 346640 0 0 $X=682000 $Y=346260
X1150 3819 3828 3822 2 3785 3862 1 AO22 $T=682620 457520 1 0 $X=682620 $Y=452100
X1151 3771 776 3836 2 3844 778 1 AO22 $T=683240 336560 1 0 $X=683240 $Y=331140
X1152 3761 3851 3857 2 3863 3879 1 AO22 $T=686340 487760 1 0 $X=686340 $Y=482340
X1153 3780 776 3847 2 3870 778 1 AO22 $T=687580 417200 1 0 $X=687580 $Y=411780
X1154 3816 3851 3869 2 3876 3879 1 AO22 $T=688200 497840 1 0 $X=688200 $Y=492420
X1155 3820 3828 3883 2 3867 3862 1 AO22 $T=690060 457520 0 0 $X=690060 $Y=457140
X1156 3817 3851 3875 2 3885 3879 1 AO22 $T=690060 507920 0 0 $X=690060 $Y=507540
X1157 3767 3828 3868 2 3891 3862 1 AO22 $T=690680 467600 0 0 $X=690680 $Y=467220
X1158 3791 3851 3902 2 3907 3879 1 AO22 $T=693160 487760 0 0 $X=693160 $Y=487380
X1159 3871 776 3900 2 3896 778 1 AO22 $T=698740 417200 1 180 $X=693780 $Y=416820
X1160 3894 3828 3906 2 3914 3862 1 AO22 $T=694400 457520 1 0 $X=694400 $Y=452100
X1161 3899 3911 3828 2 3918 3862 1 AO22 $T=695640 467600 0 0 $X=695640 $Y=467220
X1162 795 3851 3923 2 3931 3879 1 AO22 $T=697500 518000 1 0 $X=697500 $Y=512580
X1163 793 3851 3932 2 3936 3879 1 AO22 $T=698120 507920 0 0 $X=698120 $Y=507540
X1164 798 3828 3935 2 3940 3862 1 AO22 $T=699360 477680 1 0 $X=699360 $Y=472260
X1165 3939 776 3934 2 3959 778 1 AO22 $T=701840 407120 0 0 $X=701840 $Y=406740
X1166 804 3828 3975 2 3983 3862 1 AO22 $T=706180 477680 1 0 $X=706180 $Y=472260
X1167 3749 776 3999 2 3988 778 1 AO22 $T=714240 407120 1 180 $X=709280 $Y=406740
X1168 810 3851 4010 2 4015 3879 1 AO22 $T=711760 518000 1 0 $X=711760 $Y=512580
X1169 811 3828 4022 2 4008 3862 1 AO22 $T=717340 477680 0 180 $X=712380 $Y=472260
X1170 808 3851 4048 2 4036 3879 1 AO22 $T=717960 518000 1 0 $X=717960 $Y=512580
X1171 4090 832 4129 2 4131 837 1 AO22 $T=730360 336560 1 0 $X=730360 $Y=331140
X1172 4070 832 4132 2 4139 837 1 AO22 $T=731600 346640 1 0 $X=731600 $Y=341220
X1173 838 3828 4140 2 4130 3862 1 AO22 $T=737800 467600 1 180 $X=732840 $Y=467220
X1174 835 3851 4133 2 4128 3879 1 AO22 $T=733460 507920 0 0 $X=733460 $Y=507540
X1175 826 832 4148 2 4151 837 1 AO22 $T=736560 326480 0 0 $X=736560 $Y=326100
X1176 4084 832 4142 2 4153 837 1 AO22 $T=736560 386960 0 0 $X=736560 $Y=386580
X1177 4086 832 4152 2 4158 837 1 AO22 $T=737800 376880 0 0 $X=737800 $Y=376500
X1178 4062 832 4164 2 4170 837 1 AO22 $T=739660 366800 1 0 $X=739660 $Y=361380
X1179 3937 832 4165 2 4171 837 1 AO22 $T=739660 366800 0 0 $X=739660 $Y=366420
X1180 4107 3828 4166 2 4157 3862 1 AO22 $T=739660 467600 0 0 $X=739660 $Y=467220
X1181 4108 3851 4169 2 4156 3879 1 AO22 $T=739660 507920 0 0 $X=739660 $Y=507540
X1182 4071 832 4173 2 4175 837 1 AO22 $T=740280 356720 0 0 $X=740280 $Y=356340
X1183 4099 832 4180 2 4188 837 1 AO22 $T=742760 407120 0 0 $X=742760 $Y=406740
X1184 4098 832 4178 2 4199 837 1 AO22 $T=744000 407120 1 0 $X=744000 $Y=401700
X1185 4232 3851 4210 2 4202 3879 1 AO22 $T=750820 507920 1 180 $X=745860 $Y=507540
X1186 4100 832 4216 2 4225 837 1 AO22 $T=747720 417200 1 0 $X=747720 $Y=411780
X1187 4240 3828 4253 2 4249 3862 1 AO22 $T=754540 467600 0 0 $X=754540 $Y=467220
X1188 864 3851 4295 2 4277 3879 1 AO22 $T=766940 507920 1 180 $X=761980 $Y=507540
X1189 4211 4294 832 2 4307 837 1 AO22 $T=763220 427280 1 0 $X=763220 $Y=421860
X1190 4121 832 4309 2 4306 837 1 AO22 $T=763840 417200 0 0 $X=763840 $Y=416820
X1191 867 3828 4334 2 4339 3862 1 AO22 $T=770660 467600 1 0 $X=770660 $Y=462180
X1192 873 3851 4347 2 4331 3879 1 AO22 $T=779960 507920 1 180 $X=775000 $Y=507540
X1193 874 3828 4358 2 4346 3862 1 AO22 $T=781200 467600 0 180 $X=776240 $Y=462180
X1194 4208 4366 875 2 4379 876 1 AO22 $T=779340 417200 1 0 $X=779340 $Y=411780
X1195 4118 875 4375 2 4400 876 1 AO22 $T=783060 427280 1 0 $X=783060 $Y=421860
X1196 4437 3851 4389 2 4368 3879 1 AO22 $T=792980 507920 1 180 $X=788020 $Y=507540
X1197 4109 875 4436 2 4441 876 1 AO22 $T=789880 427280 1 0 $X=789880 $Y=421860
X1198 4450 3828 4438 2 4412 3862 1 AO22 $T=794840 467600 0 180 $X=789880 $Y=462180
X1199 4472 3851 4454 2 4435 3879 1 AO22 $T=799180 507920 1 180 $X=794220 $Y=507540
X1200 4105 875 4492 2 4500 876 1 AO22 $T=801040 417200 1 0 $X=801040 $Y=411780
X1201 4477 3828 4497 2 4501 4514 1 AO22 $T=801660 467600 0 0 $X=801660 $Y=467220
X1202 827 875 898 2 4507 876 1 AO22 $T=802280 326480 1 0 $X=802280 $Y=321060
X1203 4072 875 4518 2 4526 876 1 AO22 $T=805380 366800 0 0 $X=805380 $Y=366420
X1204 4102 875 4522 2 4506 876 1 AO22 $T=806000 346640 1 0 $X=806000 $Y=341220
X1205 4549 3851 4528 2 4448 3879 1 AO22 $T=811580 507920 0 180 $X=806620 $Y=502500
X1206 4104 875 4533 2 4523 876 1 AO22 $T=807240 407120 0 0 $X=807240 $Y=406740
X1207 4563 3851 4502 2 4471 3879 1 AO22 $T=812200 507920 1 180 $X=807240 $Y=507540
X1208 4066 875 4525 2 4513 876 1 AO22 $T=807860 356720 1 0 $X=807860 $Y=351300
X1209 4094 875 4535 2 4544 876 1 AO22 $T=807860 407120 1 0 $X=807860 $Y=401700
X1210 3951 875 4542 2 4531 876 1 AO22 $T=809100 376880 0 0 $X=809100 $Y=376500
X1211 4083 875 4553 2 4520 876 1 AO22 $T=809720 356720 0 0 $X=809720 $Y=356340
X1212 4558 3828 4551 2 4481 4514 1 AO22 $T=814680 457520 1 180 $X=809720 $Y=457140
X1213 4093 875 4554 2 4543 876 1 AO22 $T=810340 386960 0 0 $X=810340 $Y=386580
X1214 4571 832 4552 2 4527 3879 1 AO22 $T=815920 487760 0 180 $X=810960 $Y=482340
X1215 4596 3851 4569 2 4474 3879 1 AO22 $T=817780 507920 0 180 $X=812820 $Y=502500
X1216 4574 3828 4593 2 4503 4514 1 AO22 $T=822740 457520 1 180 $X=817780 $Y=457140
X1217 4602 3851 4594 2 4499 3879 1 AO22 $T=822740 497840 1 180 $X=817780 $Y=497460
X1218 4613 4614 4624 2 4504 4514 1 AO22 $T=826460 447440 0 0 $X=826460 $Y=447060
X1219 4678 832 4609 2 4484 3879 1 AO22 $T=831420 477680 0 180 $X=826460 $Y=472260
X1220 4608 4614 4633 2 4564 4514 1 AO22 $T=827080 437360 0 0 $X=827080 $Y=436980
X1221 4670 832 4615 2 4494 3879 1 AO22 $T=833280 487760 0 180 $X=828320 $Y=482340
X1222 4683 4614 4666 2 4585 4514 1 AO22 $T=838240 437360 0 180 $X=833280 $Y=431940
X1223 4782 875 4784 2 4545 4514 1 AO22 $T=858700 437360 1 180 $X=853740 $Y=436980
X1224 4870 1048 4862 2 4820 1065 1 AO22 $T=878540 467600 0 0 $X=878540 $Y=467220
X1225 4904 1048 4895 2 4890 1065 1 AO22 $T=892180 477680 1 180 $X=887220 $Y=477300
X1226 4893 1048 4914 2 4923 1065 1 AO22 $T=894040 407120 0 0 $X=894040 $Y=406740
X1227 4909 1048 4931 2 4915 1065 1 AO22 $T=897140 417200 0 0 $X=897140 $Y=416820
X1228 4929 1048 4933 2 4922 1065 1 AO22 $T=902100 477680 0 180 $X=897140 $Y=472260
X1229 4927 1048 4930 2 4936 1065 1 AO22 $T=899620 397040 1 0 $X=899620 $Y=391620
X1230 4943 1048 4959 2 4965 1065 1 AO22 $T=903960 376880 0 0 $X=903960 $Y=376500
X1231 4947 1048 4937 2 4957 1065 1 AO22 $T=904580 467600 0 0 $X=904580 $Y=467220
X1232 5002 1048 4984 2 4980 1065 1 AO22 $T=915740 477680 1 180 $X=910780 $Y=477300
X1233 5009 1129 5025 2 5031 1136 1 AO22 $T=923180 507920 1 0 $X=923180 $Y=502500
X1234 5058 1048 5048 2 5035 1065 1 AO22 $T=931860 467600 1 180 $X=926900 $Y=467220
X1235 5028 1048 5037 2 5072 1065 1 AO22 $T=929380 407120 0 0 $X=929380 $Y=406740
X1236 5085 1048 5066 2 5056 1065 1 AO22 $T=934340 427280 1 180 $X=929380 $Y=426900
X1237 5090 1129 5073 2 5067 1136 1 AO22 $T=935580 497840 1 180 $X=930620 $Y=497460
X1238 5061 1048 5089 2 5093 1065 1 AO22 $T=933100 447440 0 0 $X=933100 $Y=447060
X1239 5077 1048 5065 2 5091 1065 1 AO22 $T=933720 376880 0 0 $X=933720 $Y=376500
X1240 5086 1048 5105 2 5108 1065 1 AO22 $T=934960 477680 1 0 $X=934960 $Y=472260
X1241 5099 1149 5115 2 5116 1154 1 AO22 $T=938060 497840 0 0 $X=938060 $Y=497460
X1242 5106 1129 5113 2 5117 1136 1 AO22 $T=938060 507920 1 0 $X=938060 $Y=502500
X1243 5029 1149 5139 2 5147 1154 1 AO22 $T=944260 497840 0 0 $X=944260 $Y=497460
X1244 1156 1149 5148 2 5158 1154 1 AO22 $T=945500 518000 1 0 $X=945500 $Y=512580
X1245 5005 1149 5178 2 5183 1154 1 AO22 $T=951700 518000 1 0 $X=951700 $Y=512580
X1246 5196 1048 5000 2 5123 1065 1 AO22 $T=957280 366800 1 180 $X=952320 $Y=366420
X1247 5043 1149 5191 2 1173 1154 1 AO22 $T=954180 518000 0 0 $X=954180 $Y=517620
X1248 5050 1149 5218 2 5221 1154 1 AO22 $T=957900 507920 0 0 $X=957900 $Y=507540
X1249 5234 1048 5238 2 5248 1065 1 AO22 $T=963480 336560 0 0 $X=963480 $Y=336180
X1250 5259 1048 1192 2 5284 1065 1 AO22 $T=969680 326480 1 0 $X=969680 $Y=321060
X1251 5365 1048 5334 2 5349 1065 1 AO22 $T=994480 326480 1 180 $X=989520 $Y=326100
X1252 5354 1048 5339 2 5352 1065 1 AO22 $T=995100 336560 0 180 $X=990140 $Y=331140
X1253 3682 2 3699 3697 3687 1 3607 FA1S $T=661540 397040 1 180 $X=649760 $Y=396660
X1254 1307 2 1301 1 INV1S $T=221960 477680 1 180 $X=220720 $Y=477300
X1255 9 2 1296 1 INV1S $T=222580 346640 1 180 $X=221340 $Y=346260
X1256 19 2 1325 1 INV1S $T=226300 366800 0 180 $X=225060 $Y=361380
X1257 1341 2 1318 1 INV1S $T=226300 437360 0 180 $X=225060 $Y=431940
X1258 1342 2 1299 1 INV1S $T=226300 457520 0 180 $X=225060 $Y=452100
X1259 21 2 1310 1 INV1S $T=227540 346640 1 180 $X=226300 $Y=346260
X1260 1354 2 1343 1 INV1S $T=228160 507920 1 180 $X=226920 $Y=507540
X1261 1375 2 1327 1 INV1S $T=229400 487760 1 180 $X=228160 $Y=487380
X1262 1348 2 1337 1 INV1S $T=230640 447440 1 180 $X=229400 $Y=447060
X1263 1389 2 1338 1 INV1S $T=231260 507920 1 180 $X=230020 $Y=507540
X1264 50 2 30 1 INV1S $T=233740 356720 1 180 $X=232500 $Y=356340
X1265 1321 2 1344 1 INV1S $T=232500 457520 1 0 $X=232500 $Y=452100
X1266 1392 2 1329 1 INV1S $T=234360 467600 0 180 $X=233120 $Y=462180
X1267 23 2 1390 1 INV1S $T=236220 356720 1 180 $X=234980 $Y=356340
X1268 39 2 34 1 INV1S $T=236220 376880 0 180 $X=234980 $Y=371460
X1269 1344 2 1403 1 INV1S $T=234980 457520 1 0 $X=234980 $Y=452100
X1270 62 2 59 1 INV1S $T=236840 487760 0 180 $X=235600 $Y=482340
X1271 1376 2 1317 1 INV1S $T=237460 497840 0 180 $X=236220 $Y=492420
X1272 1418 2 1414 1 INV1S $T=238700 336560 1 180 $X=237460 $Y=336180
X1273 1420 2 1410 1 INV1S $T=238700 497840 1 180 $X=237460 $Y=497460
X1274 1459 2 1406 1 INV1S $T=239940 487760 0 180 $X=238700 $Y=482340
X1275 44 2 1444 1 INV1S $T=240560 386960 1 0 $X=240560 $Y=381540
X1276 1441 2 47 1 INV1S $T=241800 356720 1 0 $X=241800 $Y=351300
X1277 41 2 1298 1 INV1S $T=241800 376880 1 0 $X=241800 $Y=371460
X1278 1453 2 1370 1 INV1S $T=243040 457520 1 180 $X=241800 $Y=457140
X1279 1442 2 1416 1 INV1S $T=241800 467600 0 0 $X=241800 $Y=467220
X1280 1467 2 97 1 INV1S $T=246140 386960 1 0 $X=246140 $Y=381540
X1281 1493 2 1457 1 INV1S $T=248000 467600 1 180 $X=246760 $Y=467220
X1282 1478 2 1476 1 INV1S $T=249860 427280 1 180 $X=248620 $Y=426900
X1283 111 2 1380 1 INV1S $T=250480 326480 1 0 $X=250480 $Y=321060
X1284 12 2 112 1 INV1S $T=251100 326480 0 0 $X=251100 $Y=326100
X1285 1490 2 1507 1 INV1S $T=252340 477680 1 0 $X=252340 $Y=472260
X1286 1522 2 1464 1 INV1S $T=255440 447440 1 180 $X=254200 $Y=447060
X1287 42 2 1508 1 INV1S $T=255440 467600 1 180 $X=254200 $Y=467220
X1288 108 2 1537 1 INV1S $T=258540 376880 1 180 $X=257300 $Y=376500
X1289 1460 2 1482 1 INV1S $T=259160 356720 1 0 $X=259160 $Y=351300
X1290 104 2 1302 1 INV1S $T=261020 356720 1 0 $X=261020 $Y=351300
X1291 24 2 1524 1 INV1S $T=263500 386960 1 0 $X=263500 $Y=381540
X1292 80 2 1594 1 INV1S $T=265360 346640 0 0 $X=265360 $Y=346260
X1293 1604 2 1494 1 INV1S $T=267840 397040 0 180 $X=266600 $Y=391620
X1294 1605 2 1519 1 INV1S $T=267840 457520 1 180 $X=266600 $Y=457140
X1295 31 2 1361 1 INV1S $T=269700 336560 1 0 $X=269700 $Y=331140
X1296 154 2 1398 1 INV1S $T=270940 336560 1 180 $X=269700 $Y=336180
X1297 124 2 1504 1 INV1S $T=272180 346640 1 0 $X=272180 $Y=341220
X1298 161 2 162 1 INV1S $T=272800 497840 1 0 $X=272800 $Y=492420
X1299 1648 2 1496 1 INV1S $T=275280 386960 0 180 $X=274040 $Y=381540
X1300 1652 2 1626 1 INV1S $T=275900 487760 0 180 $X=274660 $Y=482340
X1301 133 2 1630 1 INV1S $T=277140 447440 0 180 $X=275900 $Y=442020
X1302 1607 2 1503 1 INV1S $T=277760 366800 0 0 $X=277760 $Y=366420
X1303 1694 2 1658 1 INV1S $T=279000 457520 0 180 $X=277760 $Y=452100
X1304 1616 2 1662 1 INV1S $T=279620 386960 0 180 $X=278380 $Y=381540
X1305 1660 2 1673 1 INV1S $T=279000 497840 1 0 $X=279000 $Y=492420
X1306 95 2 70 1 INV1S $T=279620 366800 1 0 $X=279620 $Y=361380
X1307 1650 2 1688 1 INV1S $T=280240 497840 1 0 $X=280240 $Y=492420
X1308 1636 2 1683 1 INV1S $T=280860 467600 0 0 $X=280860 $Y=467220
X1309 1698 2 1485 1 INV1S $T=282720 366800 1 0 $X=282720 $Y=361380
X1310 1665 2 1704 1 INV1S $T=284580 467600 1 180 $X=283340 $Y=467220
X1311 1677 2 1695 1 INV1S $T=284580 518000 0 180 $X=283340 $Y=512580
X1312 52 2 1521 1 INV1S $T=285820 346640 0 180 $X=284580 $Y=341220
X1313 1405 2 91 1 INV1S $T=287680 366800 0 180 $X=286440 $Y=361380
X1314 1639 2 60 1 INV1S $T=288920 376880 1 180 $X=287680 $Y=376500
X1315 132 2 1708 1 INV1S $T=288920 487760 1 180 $X=287680 $Y=487380
X1316 1685 2 1726 1 INV1S $T=289540 518000 0 180 $X=288300 $Y=512580
X1317 1745 2 1739 1 INV1S $T=291400 477680 1 180 $X=290160 $Y=477300
X1318 1753 2 1741 1 INV1S $T=292640 487760 0 180 $X=291400 $Y=482340
X1319 1735 2 200 1 INV1S $T=293260 397040 1 180 $X=292020 $Y=396660
X1320 1615 2 1491 1 INV1S $T=292640 376880 0 0 $X=292640 $Y=376500
X1321 1703 2 1759 1 INV1S $T=292640 447440 0 0 $X=292640 $Y=447060
X1322 1771 2 1755 1 INV1S $T=296360 467600 1 180 $X=295120 $Y=467220
X1323 184 2 1764 1 INV1S $T=295740 336560 0 0 $X=295740 $Y=336180
X1324 1761 2 1780 1 INV1S $T=295740 447440 0 0 $X=295740 $Y=447060
X1325 1782 2 1783 1 INV1S $T=299460 376880 0 180 $X=298220 $Y=371460
X1326 1720 2 93 1 INV1S $T=300080 356720 0 0 $X=300080 $Y=356340
X1327 1699 2 1779 1 INV1S $T=300080 427280 0 0 $X=300080 $Y=426900
X1328 1813 2 1797 1 INV1S $T=302560 467600 0 180 $X=301320 $Y=462180
X1329 1814 2 1577 1 INV1S $T=306280 386960 1 180 $X=305040 $Y=386580
X1330 1727 2 239 1 INV1S $T=306900 397040 0 0 $X=306900 $Y=396660
X1331 1832 2 1712 1 INV1S $T=310620 376880 1 180 $X=309380 $Y=376500
X1332 186 2 1428 1 INV1S $T=310000 336560 0 0 $X=310000 $Y=336180
X1333 14 2 150 1 INV1S $T=310000 346640 1 0 $X=310000 $Y=341220
X1334 1748 2 1833 1 INV1S $T=310620 457520 1 0 $X=310620 $Y=452100
X1335 1837 2 1835 1 INV1S $T=314960 366800 1 180 $X=313720 $Y=366420
X1336 1765 2 1691 1 INV1S $T=313720 397040 1 0 $X=313720 $Y=391620
X1337 249 2 1819 1 INV1S $T=316200 376880 1 180 $X=314960 $Y=376500
X1338 1843 2 1864 1 INV1S $T=314960 467600 1 0 $X=314960 $Y=462180
X1339 254 2 1811 1 INV1S $T=318060 376880 1 180 $X=316820 $Y=376500
X1340 1627 2 89 1 INV1S $T=318060 336560 0 0 $X=318060 $Y=336180
X1341 231 2 1861 1 INV1S $T=318680 376880 0 0 $X=318680 $Y=376500
X1342 1866 2 1856 1 INV1S $T=319920 477680 1 180 $X=318680 $Y=477300
X1343 1603 2 1744 1 INV1S $T=322400 376880 1 180 $X=321160 $Y=376500
X1344 1710 2 1730 1 INV1S $T=322400 366800 0 0 $X=322400 $Y=366420
X1345 1369 2 1880 1 INV1S $T=323020 336560 1 0 $X=323020 $Y=331140
X1346 263 2 1722 1 INV1S $T=324880 386960 1 180 $X=323640 $Y=386580
X1347 210 2 1894 1 INV1S $T=323640 487760 0 0 $X=323640 $Y=487380
X1348 1831 2 257 1 INV1S $T=325500 376880 0 0 $X=325500 $Y=376500
X1349 1879 2 1886 1 INV1S $T=327980 487760 1 180 $X=326740 $Y=487380
X1350 1858 2 1937 1 INV1S $T=331080 477680 0 0 $X=331080 $Y=477300
X1351 1953 2 275 1 INV1S $T=332940 417200 1 180 $X=331700 $Y=416820
X1352 290 2 1930 1 INV1S $T=336660 386960 1 180 $X=335420 $Y=386580
X1353 1903 2 1965 1 INV1S $T=337900 497840 1 0 $X=337900 $Y=492420
X1354 283 2 1963 1 INV1S $T=339140 366800 1 0 $X=339140 $Y=361380
X1355 270 2 1931 1 INV1S $T=339760 336560 1 0 $X=339760 $Y=331140
X1356 275 2 292 1 INV1S $T=339760 497840 0 0 $X=339760 $Y=497460
X1357 297 2 1956 1 INV1S $T=342240 386960 1 180 $X=341000 $Y=386580
X1358 279 2 296 1 INV1S $T=342860 326480 0 180 $X=341620 $Y=321060
X1359 271 2 1966 1 INV1S $T=341620 336560 1 0 $X=341620 $Y=331140
X1360 263 2 280 1 INV1S $T=342240 376880 0 0 $X=342240 $Y=376500
X1361 300 2 1960 1 INV1S $T=343480 397040 0 180 $X=342240 $Y=391620
X1362 301 2 1842 1 INV1S $T=343480 326480 1 0 $X=343480 $Y=321060
X1363 1987 2 1964 1 INV1S $T=343480 487760 1 0 $X=343480 $Y=482340
X1364 1975 2 2003 1 INV1S $T=344100 497840 1 0 $X=344100 $Y=492420
X1365 234 2 1926 1 INV1S $T=344720 376880 0 0 $X=344720 $Y=376500
X1366 2008 2 1992 1 INV1S $T=347200 477680 1 180 $X=345960 $Y=477300
X1367 1913 2 2000 1 INV1S $T=348440 497840 0 180 $X=347200 $Y=492420
X1368 1939 2 2009 1 INV1S $T=347200 497840 0 0 $X=347200 $Y=497460
X1369 310 2 311 1 INV1S $T=347820 326480 1 0 $X=347820 $Y=321060
X1370 2010 2 1994 1 INV1S $T=349680 397040 0 180 $X=348440 $Y=391620
X1371 272 2 1954 1 INV1S $T=349680 346640 1 0 $X=349680 $Y=341220
X1372 312 2 2024 1 INV1S $T=349680 397040 1 0 $X=349680 $Y=391620
X1373 299 2 313 1 INV1S $T=350300 507920 0 0 $X=350300 $Y=507540
X1374 306 2 287 1 INV1S $T=350920 326480 1 0 $X=350920 $Y=321060
X1375 2020 2 2013 1 INV1S $T=352160 477680 1 180 $X=350920 $Y=477300
X1376 2005 2 1904 1 INV1S $T=352780 346640 1 180 $X=351540 $Y=346260
X1377 286 2 1955 1 INV1S $T=355880 366800 0 0 $X=355880 $Y=366420
X1378 2042 2 2073 1 INV1S $T=355880 518000 1 0 $X=355880 $Y=512580
X1379 2039 2 2058 1 INV1S $T=357120 477680 1 0 $X=357120 $Y=472260
X1380 2062 2 2075 1 INV1S $T=357120 507920 1 0 $X=357120 $Y=502500
X1381 2059 2 2085 1 INV1S $T=358980 507920 1 0 $X=358980 $Y=502500
X1382 2083 2 2100 1 INV1S $T=360840 477680 0 0 $X=360840 $Y=477300
X1383 2054 2 2092 1 INV1S $T=361460 497840 0 0 $X=361460 $Y=497460
X1384 2047 2 2124 1 INV1S $T=368280 487760 1 0 $X=368280 $Y=482340
X1385 337 2 2211 1 INV1S $T=385020 366800 0 0 $X=385020 $Y=366420
X1386 2241 2 2257 1 INV1S $T=391840 407120 0 0 $X=391840 $Y=406740
X1387 2228 2 2260 1 INV1S $T=392460 336560 0 0 $X=392460 $Y=336180
X1388 2247 2 2263 1 INV1S $T=393700 326480 0 0 $X=393700 $Y=326100
X1389 2204 2 2251 1 INV1S $T=394940 386960 0 180 $X=393700 $Y=381540
X1390 2266 2 2227 1 INV1S $T=394940 407120 1 180 $X=393700 $Y=406740
X1391 2223 2 2250 1 INV1S $T=394320 356720 1 0 $X=394320 $Y=351300
X1392 2224 2 2262 1 INV1S $T=394320 356720 0 0 $X=394320 $Y=356340
X1393 2212 2 345 1 INV1S $T=398040 326480 0 180 $X=396800 $Y=321060
X1394 2232 2 2274 1 INV1S $T=399280 346640 1 0 $X=399280 $Y=341220
X1395 2267 2 2282 1 INV1S $T=401140 397040 0 0 $X=401140 $Y=396660
X1396 2303 2 2300 1 INV1S $T=404860 407120 0 180 $X=403620 $Y=401700
X1397 2346 2 2315 1 INV1S $T=408580 417200 0 180 $X=407340 $Y=411780
X1398 2335 2 2351 1 INV1S $T=411060 397040 1 0 $X=411060 $Y=391620
X1399 2353 2 357 1 INV1S $T=412300 326480 1 0 $X=412300 $Y=321060
X1400 2368 2 2374 1 INV1S $T=416640 407120 1 0 $X=416640 $Y=401700
X1401 2379 2 2375 1 INV1S $T=419120 417200 1 0 $X=419120 $Y=411780
X1402 378 2 2416 1 INV1S $T=427800 407120 0 180 $X=426560 $Y=401700
X1403 2452 2 2448 1 INV1S $T=432760 397040 0 180 $X=431520 $Y=391620
X1404 2458 2 2432 1 INV1S $T=433380 407120 0 180 $X=432140 $Y=401700
X1405 2431 2 2459 1 INV1S $T=434620 427280 1 0 $X=434620 $Y=421860
X1406 2481 2 2499 1 INV1S $T=436480 366800 1 0 $X=436480 $Y=361380
X1407 2465 2 2480 1 INV1S $T=438340 346640 1 0 $X=438340 $Y=341220
X1408 388 2 2491 1 INV1S $T=439580 386960 0 180 $X=438340 $Y=381540
X1409 2485 2 2508 1 INV1S $T=439580 376880 1 0 $X=439580 $Y=371460
X1410 2423 2 2437 1 INV1S $T=439580 407120 1 0 $X=439580 $Y=401700
X1411 2475 2 2495 1 INV1S $T=441440 326480 0 180 $X=440200 $Y=321060
X1412 2477 2 2474 1 INV1S $T=442680 386960 1 180 $X=441440 $Y=386580
X1413 2490 2 2486 1 INV1S $T=442680 407120 0 180 $X=441440 $Y=401700
X1414 2496 2 2443 1 INV1S $T=442680 407120 1 180 $X=441440 $Y=406740
X1415 2469 2 2519 1 INV1S $T=442680 427280 1 0 $X=442680 $Y=421860
X1416 2484 2 2511 1 INV1S $T=447640 346640 1 180 $X=446400 $Y=346260
X1417 2539 2 2545 1 INV1S $T=447020 427280 1 0 $X=447020 $Y=421860
X1418 2553 2 2544 1 INV1S $T=450740 326480 1 180 $X=449500 $Y=326100
X1419 412 2 2562 1 INV1S $T=453840 326480 0 180 $X=452600 $Y=321060
X1420 2529 2 2559 1 INV1S $T=453220 417200 0 0 $X=453220 $Y=416820
X1421 2585 2 415 1 INV1S $T=456320 326480 0 180 $X=455080 $Y=321060
X1422 2592 2 2574 1 INV1S $T=459420 447440 0 180 $X=458180 $Y=442020
X1423 416 2 2590 1 INV1S $T=461280 326480 1 180 $X=460040 $Y=326100
X1424 2624 2 2599 1 INV1S $T=466240 437360 0 180 $X=465000 $Y=431940
X1425 2631 2 2629 1 INV1S $T=468100 407120 0 180 $X=466860 $Y=401700
X1426 2648 2 2655 1 INV1S $T=470580 417200 1 0 $X=470580 $Y=411780
X1427 380 2 327 1 INV1S $T=472440 366800 0 0 $X=472440 $Y=366420
X1428 2665 2 2635 1 INV1S $T=476780 447440 1 180 $X=475540 $Y=447060
X1429 2679 2 2659 1 INV1S $T=477400 397040 1 180 $X=476160 $Y=396660
X1430 2693 2 2707 1 INV1S $T=478020 427280 1 0 $X=478020 $Y=421860
X1431 2702 2 2688 1 INV1S $T=479880 376880 1 180 $X=478640 $Y=376500
X1432 2669 2 2676 1 INV1S $T=479880 397040 0 180 $X=478640 $Y=391620
X1433 2633 2 2713 1 INV1S $T=480500 336560 1 0 $X=480500 $Y=331140
X1434 233 2 2714 1 INV1S $T=480500 346640 1 0 $X=480500 $Y=341220
X1435 2680 2 2689 1 INV1S $T=480500 417200 0 0 $X=480500 $Y=416820
X1436 2697 2 2715 1 INV1S $T=480500 427280 0 0 $X=480500 $Y=426900
X1437 2720 2 2684 1 INV1S $T=481740 437360 1 180 $X=480500 $Y=436980
X1438 2701 2 2719 1 INV1S $T=481120 356720 0 0 $X=481120 $Y=356340
X1439 388 2 460 1 INV1S $T=484220 447440 1 0 $X=484220 $Y=442020
X1440 425 2 2735 1 INV1S $T=487320 427280 0 0 $X=487320 $Y=426900
X1441 2663 2 2754 1 INV1S $T=487320 467600 1 0 $X=487320 $Y=462180
X1442 2775 2 2766 1 INV1S $T=492280 467600 1 180 $X=491040 $Y=467220
X1443 2780 2 2768 1 INV1S $T=494140 336560 1 0 $X=494140 $Y=331140
X1444 2799 2 456 1 INV1S $T=496620 457520 1 180 $X=495380 $Y=457140
X1445 2765 2 2810 1 INV1S $T=496000 497840 0 0 $X=496000 $Y=497460
X1446 2802 2 2808 1 INV1S $T=496620 437360 1 0 $X=496620 $Y=431940
X1447 2800 2 2811 1 INV1S $T=497240 477680 0 0 $X=497240 $Y=477300
X1448 2794 2 2812 1 INV1S $T=497240 487760 1 0 $X=497240 $Y=482340
X1449 2723 2 475 1 INV1S $T=499100 326480 1 0 $X=499100 $Y=321060
X1450 2801 2 2823 1 INV1S $T=499100 457520 1 0 $X=499100 $Y=452100
X1451 2813 2 2814 1 INV1S $T=499100 518000 1 0 $X=499100 $Y=512580
X1452 401 2 2799 1 INV1S $T=500340 417200 0 0 $X=500340 $Y=416820
X1453 484 2 2441 1 INV1S $T=502200 407120 0 180 $X=500960 $Y=401700
X1454 2802 2 2791 1 INV1S $T=502200 437360 1 180 $X=500960 $Y=436980
X1455 2816 2 2833 1 INV1S $T=501580 487760 1 0 $X=501580 $Y=482340
X1456 2836 2 2845 1 INV1S $T=504060 437360 0 0 $X=504060 $Y=436980
X1457 2731 2 2837 1 INV1S $T=504060 507920 1 0 $X=504060 $Y=502500
X1458 2844 2 2849 1 INV1S $T=504680 437360 1 0 $X=504680 $Y=431940
X1459 2826 2 2848 1 INV1S $T=504680 467600 0 0 $X=504680 $Y=467220
X1460 2858 2 2866 1 INV1S $T=506540 447440 0 0 $X=506540 $Y=447060
X1461 388 2 2620 1 INV1S $T=507160 407120 0 0 $X=507160 $Y=406740
X1462 373 2 2878 1 INV1S $T=509020 366800 1 0 $X=509020 $Y=361380
X1463 2820 2 2871 1 INV1S $T=509640 417200 0 0 $X=509640 $Y=416820
X1464 2863 2 2874 1 INV1S $T=509640 427280 1 0 $X=509640 $Y=421860
X1465 2853 2 2868 1 INV1S $T=510880 457520 1 180 $X=509640 $Y=457140
X1466 2840 2 2885 1 INV1S $T=510880 407120 0 0 $X=510880 $Y=406740
X1467 496 2 2447 1 INV1S $T=511500 386960 0 0 $X=511500 $Y=386580
X1468 2889 2 498 1 INV1S $T=513360 326480 1 180 $X=512120 $Y=326100
X1469 2792 2 2882 1 INV1S $T=515840 407120 0 0 $X=515840 $Y=406740
X1470 377 2 2970 1 INV1S $T=523900 437360 0 0 $X=523900 $Y=436980
X1471 517 2 530 1 INV1S $T=525140 336560 1 0 $X=525140 $Y=331140
X1472 554 2 538 1 INV1S $T=529480 346640 1 180 $X=528240 $Y=346260
X1473 450 2 2994 1 INV1S $T=528240 386960 1 0 $X=528240 $Y=381540
X1474 514 2 553 1 INV1S $T=533200 336560 1 0 $X=533200 $Y=331140
X1475 550 2 546 1 INV1S $T=535060 326480 0 0 $X=535060 $Y=326100
X1476 2919 2 3011 1 INV1S $T=535680 417200 1 0 $X=535680 $Y=411780
X1477 536 2 3023 1 INV1S $T=535680 427280 0 0 $X=535680 $Y=426900
X1478 3010 2 3041 1 INV1S $T=538160 437360 0 0 $X=538160 $Y=436980
X1479 2982 2 3032 1 INV1S $T=541260 457520 1 180 $X=540020 $Y=457140
X1480 3013 2 3049 1 INV1S $T=540020 467600 0 0 $X=540020 $Y=467220
X1481 3009 2 2997 1 INV1S $T=541880 447440 0 0 $X=541880 $Y=447060
X1482 513 2 541 1 INV1S $T=543740 346640 1 0 $X=543740 $Y=341220
X1483 3017 2 3052 1 INV1S $T=544360 447440 0 0 $X=544360 $Y=447060
X1484 3072 2 3077 1 INV1S $T=544360 487760 0 0 $X=544360 $Y=487380
X1485 3035 2 3088 1 INV1S $T=544360 497840 1 0 $X=544360 $Y=492420
X1486 3023 2 570 1 INV1S $T=546840 457520 1 180 $X=545600 $Y=457140
X1487 3073 2 3099 1 INV1S $T=546840 467600 1 0 $X=546840 $Y=462180
X1488 3076 2 3096 1 INV1S $T=546840 467600 0 0 $X=546840 $Y=467220
X1489 3090 2 3106 1 INV1S $T=546840 487760 1 0 $X=546840 $Y=482340
X1490 3101 2 3108 1 INV1S $T=548080 497840 0 0 $X=548080 $Y=497460
X1491 3100 2 3109 1 INV1S $T=548080 507920 0 0 $X=548080 $Y=507540
X1492 596 2 537 1 INV1S $T=551800 336560 0 180 $X=550560 $Y=331140
X1493 539 2 605 1 INV1S $T=551800 346640 1 0 $X=551800 $Y=341220
X1494 3122 2 3129 1 INV1S $T=551800 447440 0 0 $X=551800 $Y=447060
X1495 606 2 590 1 INV1S $T=553660 336560 0 180 $X=552420 $Y=331140
X1496 3065 2 3103 1 INV1S $T=553660 366800 0 180 $X=552420 $Y=361380
X1497 3118 2 3138 1 INV1S $T=556760 437360 0 180 $X=555520 $Y=431940
X1498 3112 2 3128 1 INV1S $T=557380 447440 0 180 $X=556140 $Y=442020
X1499 3123 2 3127 1 INV1S $T=556140 457520 0 0 $X=556140 $Y=457140
X1500 569 2 610 1 INV1S $T=557380 346640 0 0 $X=557380 $Y=346260
X1501 3125 2 3137 1 INV1S $T=558620 507920 0 180 $X=557380 $Y=502500
X1502 3006 2 2984 1 INV1S $T=561720 427280 1 0 $X=561720 $Y=421860
X1503 3165 2 3140 1 INV1S $T=563580 356720 1 180 $X=562340 $Y=356340
X1504 2978 2 3184 1 INV1S $T=562340 437360 1 0 $X=562340 $Y=431940
X1505 623 2 2804 1 INV1S $T=563580 518000 1 0 $X=563580 $Y=512580
X1506 3223 2 3074 1 INV1S $T=570400 356720 1 180 $X=569160 $Y=356340
X1507 3218 2 3221 1 INV1S $T=569780 346640 1 0 $X=569780 $Y=341220
X1508 631 2 568 1 INV1S $T=573500 346640 0 180 $X=572260 $Y=341220
X1509 642 2 2784 1 INV1S $T=572260 518000 1 0 $X=572260 $Y=512580
X1510 3195 2 654 1 INV1S $T=574120 376880 0 0 $X=574120 $Y=376500
X1511 3196 2 3203 1 INV1S $T=575360 356720 0 0 $X=575360 $Y=356340
X1512 548 2 3237 1 INV1S $T=575980 346640 1 0 $X=575980 $Y=341220
X1513 3242 2 3257 1 INV1S $T=577220 407120 1 0 $X=577220 $Y=401700
X1514 619 2 593 1 INV1S $T=578460 326480 1 0 $X=578460 $Y=321060
X1515 563 2 604 1 INV1S $T=578460 326480 0 0 $X=578460 $Y=326100
X1516 656 2 573 1 INV1S $T=579700 326480 0 0 $X=579700 $Y=326100
X1517 3206 2 3171 1 INV1S $T=582800 366800 1 0 $X=582800 $Y=361380
X1518 3247 2 3321 1 INV1S $T=587140 437360 1 0 $X=587140 $Y=431940
X1519 3229 2 545 1 INV1S $T=589620 336560 1 0 $X=589620 $Y=331140
X1520 669 2 543 1 INV1S $T=590860 356720 0 180 $X=589620 $Y=351300
X1521 3230 2 672 1 INV1S $T=590860 366800 0 0 $X=590860 $Y=366420
X1522 3306 2 520 1 INV1S $T=592720 346640 0 180 $X=591480 $Y=341220
X1523 3340 2 3308 1 INV1S $T=592100 427280 0 0 $X=592100 $Y=426900
X1524 651 2 3339 1 INV1S $T=593340 326480 0 0 $X=593340 $Y=326100
X1525 3231 2 3311 1 INV1S $T=593960 427280 0 0 $X=593960 $Y=426900
X1526 3326 2 3307 1 INV1S $T=594580 356720 0 0 $X=594580 $Y=356340
X1527 3348 2 3248 1 INV1S $T=594580 447440 1 0 $X=594580 $Y=442020
X1528 3360 2 3356 1 INV1S $T=596440 346640 0 180 $X=595200 $Y=341220
X1529 3236 2 3373 1 INV1S $T=597060 447440 1 0 $X=597060 $Y=442020
X1530 3379 2 3274 1 INV1S $T=598920 356720 1 180 $X=597680 $Y=356340
X1531 3311 2 3382 1 INV1S $T=597680 447440 0 0 $X=597680 $Y=447060
X1532 547 2 630 1 INV1S $T=598300 326480 0 0 $X=598300 $Y=326100
X1533 3300 2 3331 1 INV1S $T=599540 356720 1 0 $X=599540 $Y=351300
X1534 676 2 3297 1 INV1S $T=599540 376880 0 0 $X=599540 $Y=376500
X1535 3378 2 3375 1 INV1S $T=600780 437360 1 180 $X=599540 $Y=436980
X1536 518 2 609 1 INV1S $T=600160 336560 1 0 $X=600160 $Y=331140
X1537 3370 2 686 1 INV1S $T=601400 518000 0 0 $X=601400 $Y=517620
X1538 533 2 3116 1 INV1S $T=603880 336560 1 180 $X=602640 $Y=336180
X1539 3310 2 3323 1 INV1S $T=603880 356720 1 180 $X=602640 $Y=356340
X1540 683 2 3357 1 INV1S $T=603880 366800 1 180 $X=602640 $Y=366420
X1541 2994 2 3405 1 INV1S $T=602640 447440 1 0 $X=602640 $Y=442020
X1542 677 2 3295 1 INV1S $T=603260 326480 1 0 $X=603260 $Y=321060
X1543 685 2 3301 1 INV1S $T=604500 366800 0 180 $X=603260 $Y=361380
X1544 684 2 3402 1 INV1S $T=605740 366800 1 180 $X=604500 $Y=366420
X1545 3408 2 3420 1 INV1S $T=604500 447440 0 0 $X=604500 $Y=447060
X1546 2968 2 3327 1 INV1S $T=606360 437360 1 0 $X=606360 $Y=431940
X1547 3411 2 3430 1 INV1S $T=606980 457520 0 0 $X=606980 $Y=457140
X1548 645 2 516 1 INV1S $T=609460 336560 1 180 $X=608220 $Y=336180
X1549 297 2 3460 1 INV1S $T=610080 376880 0 0 $X=610080 $Y=376500
X1550 694 2 700 1 INV1S $T=612560 518000 1 0 $X=612560 $Y=512580
X1551 3395 2 3425 1 INV1S $T=613800 366800 0 0 $X=613800 $Y=366420
X1552 3450 2 3483 1 INV1S $T=614420 487760 1 0 $X=614420 $Y=482340
X1553 3467 2 3461 1 INV1S $T=615040 427280 1 0 $X=615040 $Y=421860
X1554 3473 2 3472 1 INV1S $T=615040 477680 1 0 $X=615040 $Y=472260
X1555 3465 2 3488 1 INV1S $T=615040 477680 0 0 $X=615040 $Y=477300
X1556 671 2 3466 1 INV1S $T=615660 366800 0 0 $X=615660 $Y=366420
X1557 3484 2 3499 1 INV1S $T=615660 497840 1 0 $X=615660 $Y=492420
X1558 3486 2 3495 1 INV1S $T=616900 507920 1 0 $X=616900 $Y=502500
X1559 3445 2 3512 1 INV1S $T=618140 477680 1 0 $X=618140 $Y=472260
X1560 290 2 3514 1 INV1S $T=620620 386960 0 0 $X=620620 $Y=386580
X1561 3452 2 3500 1 INV1S $T=622480 507920 1 180 $X=621240 $Y=507540
X1562 3471 2 3521 1 INV1S $T=624340 427280 1 180 $X=623100 $Y=426900
X1563 3498 2 3517 1 INV1S $T=623720 447440 1 0 $X=623720 $Y=442020
X1564 283 2 3528 1 INV1S $T=626200 356720 0 180 $X=624960 $Y=351300
X1565 698 2 720 1 INV1S $T=624960 518000 0 0 $X=624960 $Y=517620
X1566 3523 2 3534 1 INV1S $T=628060 457520 0 180 $X=626820 $Y=452100
X1567 3497 2 3524 1 INV1S $T=629920 467600 0 180 $X=628680 $Y=462180
X1568 731 2 3561 1 INV1S $T=631780 326480 0 180 $X=630540 $Y=321060
X1569 270 2 708 1 INV1S $T=632400 326480 0 0 $X=632400 $Y=326100
X1570 279 2 714 1 INV1S $T=634880 326480 0 180 $X=633640 $Y=321060
X1571 300 2 3558 1 INV1S $T=635500 386960 1 180 $X=634260 $Y=386580
X1572 2005 2 722 1 INV1S $T=636120 336560 0 180 $X=634880 $Y=331140
X1573 3608 2 3345 1 INV1S $T=636740 326480 1 180 $X=635500 $Y=326100
X1574 650 2 652 1 INV1S $T=635500 457520 0 0 $X=635500 $Y=457140
X1575 2010 2 3592 1 INV1S $T=636740 366800 0 0 $X=636740 $Y=366420
X1576 726 2 3557 1 INV1S $T=639840 346640 1 180 $X=638600 $Y=346260
X1577 742 2 740 1 INV1S $T=641080 326480 0 180 $X=639840 $Y=321060
X1578 741 2 727 1 INV1S $T=645420 326480 0 180 $X=644180 $Y=321060
X1579 3519 2 3540 1 INV1S $T=644180 356720 1 0 $X=644180 $Y=351300
X1580 3613 2 3611 1 INV1S $T=646660 386960 0 180 $X=645420 $Y=381540
X1581 3785 2 3801 1 INV1S $T=675800 457520 1 0 $X=675800 $Y=452100
X1582 3798 2 3784 1 INV1S $T=678900 376880 0 180 $X=677660 $Y=371460
X1583 3797 2 3813 1 INV1S $T=678280 346640 0 0 $X=678280 $Y=346260
X1584 3827 2 3793 1 INV1S $T=683240 397040 1 180 $X=682000 $Y=396660
X1585 3838 2 3808 1 INV1S $T=684480 467600 0 180 $X=683240 $Y=462180
X1586 3826 2 3840 1 INV1S $T=684480 376880 0 0 $X=684480 $Y=376500
X1587 3830 2 3865 1 INV1S $T=688200 356720 0 0 $X=688200 $Y=356340
X1588 3807 2 3846 1 INV1S $T=689440 397040 0 180 $X=688200 $Y=391620
X1589 3814 2 3855 1 INV1S $T=688820 386960 1 0 $X=688820 $Y=381540
X1590 3867 2 3854 1 INV1S $T=690060 447440 0 180 $X=688820 $Y=442020
X1591 3870 2 3866 1 INV1S $T=690680 407120 0 180 $X=689440 $Y=401700
X1592 3829 2 3872 1 INV1S $T=690680 346640 0 0 $X=690680 $Y=346260
X1593 3891 2 3849 1 INV1S $T=694400 467600 0 180 $X=693160 $Y=462180
X1594 3821 2 3864 1 INV1S $T=695020 326480 1 180 $X=693780 $Y=326100
X1595 3896 2 3882 1 INV1S $T=695640 407120 0 180 $X=694400 $Y=401700
X1596 3844 2 3889 1 INV1S $T=696260 346640 0 180 $X=695020 $Y=341220
X1597 3885 2 3893 1 INV1S $T=695640 497840 0 0 $X=695640 $Y=497460
X1598 3863 2 3913 1 INV1S $T=698740 487760 1 0 $X=698740 $Y=482340
X1599 3907 2 3930 1 INV1S $T=698740 487760 0 0 $X=698740 $Y=487380
X1600 3914 2 3922 1 INV1S $T=699980 447440 0 0 $X=699980 $Y=447060
X1601 3876 2 3929 1 INV1S $T=701220 497840 0 0 $X=701220 $Y=497460
X1602 3940 2 3945 1 INV1S $T=701840 457520 0 0 $X=701840 $Y=457140
X1603 3936 2 3963 1 INV1S $T=703700 507920 0 0 $X=703700 $Y=507540
X1604 806 2 3962 1 INV1S $T=708660 326480 0 180 $X=707420 $Y=321060
X1605 3959 2 3955 1 INV1S $T=707420 407120 0 0 $X=707420 $Y=406740
X1606 3931 2 3973 1 INV1S $T=710520 518000 1 180 $X=709280 $Y=517620
X1607 3983 2 4003 1 INV1S $T=713620 457520 1 180 $X=712380 $Y=457140
X1608 4015 2 4012 1 INV1S $T=714860 507920 1 180 $X=713620 $Y=507540
X1609 4008 2 4038 1 INV1S $T=715480 457520 0 0 $X=715480 $Y=457140
X1610 824 2 822 1 INV1S $T=722300 326480 0 180 $X=721060 $Y=321060
X1611 4036 2 4064 1 INV1S $T=721060 507920 0 0 $X=721060 $Y=507540
X1612 4059 2 4026 1 INV1S $T=724780 427280 1 0 $X=724780 $Y=421860
X1613 623 2 828 1 INV1S $T=725400 518000 0 0 $X=725400 $Y=517620
X1614 642 2 830 1 INV1S $T=731600 507920 1 180 $X=730360 $Y=507540
X1615 4128 2 4112 1 INV1S $T=732840 507920 1 180 $X=731600 $Y=507540
X1616 4130 2 4127 1 INV1S $T=733460 467600 0 180 $X=732220 $Y=462180
X1617 4156 2 4150 1 INV1S $T=740280 507920 0 180 $X=739040 $Y=502500
X1618 4139 2 4163 1 INV1S $T=739660 346640 0 0 $X=739660 $Y=346260
X1619 4153 2 4155 1 INV1S $T=741520 386960 0 0 $X=741520 $Y=386580
X1620 4157 2 4176 1 INV1S $T=742140 457520 0 0 $X=742140 $Y=457140
X1621 4171 2 4191 1 INV1S $T=743380 376880 0 0 $X=743380 $Y=376500
X1622 4151 2 4187 1 INV1S $T=744000 326480 0 0 $X=744000 $Y=326100
X1623 4175 2 4190 1 INV1S $T=747720 356720 0 180 $X=746480 $Y=351300
X1624 4202 2 4209 1 INV1S $T=747100 507920 1 0 $X=747100 $Y=502500
X1625 4131 2 4167 1 INV1S $T=748960 336560 0 180 $X=747720 $Y=331140
X1626 4170 2 4207 1 INV1S $T=748340 366800 0 0 $X=748340 $Y=366420
X1627 4188 2 4227 1 INV1S $T=748340 407120 0 0 $X=748340 $Y=406740
X1628 4158 2 4192 1 INV1S $T=750820 376880 1 180 $X=749580 $Y=376500
X1629 4199 2 4204 1 INV1S $T=750820 397040 1 180 $X=749580 $Y=396660
X1630 847 2 843 1 INV1S $T=753300 326480 0 180 $X=752060 $Y=321060
X1631 4249 2 4263 1 INV1S $T=756400 457520 0 0 $X=756400 $Y=457140
X1632 4225 2 4256 1 INV1S $T=758260 417200 0 0 $X=758260 $Y=416820
X1633 4277 2 4269 1 INV1S $T=761980 507920 0 180 $X=760740 $Y=502500
X1634 4339 2 4310 1 INV1S $T=769420 457520 1 180 $X=768180 $Y=457140
X1635 4306 2 4320 1 INV1S $T=768800 417200 0 0 $X=768800 $Y=416820
X1636 4055 2 4333 1 INV1S $T=770040 437360 1 0 $X=770040 $Y=431940
X1637 4331 2 4326 1 INV1S $T=772520 507920 0 180 $X=771280 $Y=502500
X1638 868 2 4332 1 INV1S $T=771280 507920 0 0 $X=771280 $Y=507540
X1639 484 2 4054 1 INV1S $T=775620 407120 0 0 $X=775620 $Y=406740
X1640 496 2 4141 1 INV1S $T=777480 397040 1 0 $X=777480 $Y=391620
X1641 378 2 4081 1 INV1S $T=778100 407120 0 0 $X=778100 $Y=406740
X1642 4346 2 4362 1 INV1S $T=778720 457520 0 0 $X=778720 $Y=457140
X1643 4273 2 4376 1 INV1S $T=780580 326480 1 0 $X=780580 $Y=321060
X1644 4368 2 4377 1 INV1S $T=784920 507920 0 180 $X=783680 $Y=502500
X1645 824 2 878 1 INV1S $T=783680 518000 0 0 $X=783680 $Y=517620
X1646 4344 2 4403 1 INV1S $T=784920 487760 1 0 $X=784920 $Y=482340
X1647 4397 2 4359 1 INV1S $T=785540 467600 1 0 $X=785540 $Y=462180
X1648 4405 2 4398 1 INV1S $T=786780 497840 1 180 $X=785540 $Y=497460
X1649 4412 2 4417 1 INV1S $T=787400 467600 1 0 $X=787400 $Y=462180
X1650 4200 2 882 1 INV1S $T=789260 336560 1 0 $X=789260 $Y=331140
X1651 4400 2 4392 1 INV1S $T=789260 417200 0 0 $X=789260 $Y=416820
X1652 4200 2 4444 1 INV1S $T=789260 427280 0 0 $X=789260 $Y=426900
X1653 4434 2 4388 1 INV1S $T=791740 487760 0 180 $X=790500 $Y=482340
X1654 4435 2 4426 1 INV1S $T=791740 507920 0 180 $X=790500 $Y=502500
X1655 4329 2 4446 1 INV1S $T=794840 427280 1 0 $X=794840 $Y=421860
X1656 809 2 4458 1 INV1S $T=794840 487760 0 0 $X=794840 $Y=487380
X1657 4441 2 4452 1 INV1S $T=796700 417200 0 180 $X=795460 $Y=411780
X1658 4380 2 4453 1 INV1S $T=795460 477680 0 0 $X=795460 $Y=477300
X1659 834 2 888 1 INV1S $T=797320 427280 1 0 $X=797320 $Y=421860
X1660 4471 2 4488 1 INV1S $T=799180 497840 1 0 $X=799180 $Y=492420
X1661 4501 2 4486 1 INV1S $T=802280 447440 1 180 $X=801040 $Y=447060
X1662 4493 2 4505 1 INV1S $T=804140 477680 1 0 $X=804140 $Y=472260
X1663 4506 2 4512 1 INV1S $T=805380 336560 0 0 $X=805380 $Y=336180
X1664 4448 2 4509 1 INV1S $T=806620 507920 0 180 $X=805380 $Y=502500
X1665 4513 2 4515 1 INV1S $T=806000 346640 0 0 $X=806000 $Y=346260
X1666 4500 2 4536 1 INV1S $T=806000 417200 1 0 $X=806000 $Y=411780
X1667 4507 2 900 1 INV1S $T=807860 326480 1 0 $X=807860 $Y=321060
X1668 4527 2 4534 1 INV1S $T=808480 487760 1 0 $X=808480 $Y=482340
X1669 841 2 4516 1 INV1S $T=809100 427280 0 0 $X=809100 $Y=426900
X1670 4481 2 4521 1 INV1S $T=809100 457520 1 0 $X=809100 $Y=452100
X1671 4526 2 4559 1 INV1S $T=810960 366800 0 0 $X=810960 $Y=366420
X1672 4474 2 4548 1 INV1S $T=810960 497840 1 0 $X=810960 $Y=492420
X1673 4544 2 4587 1 INV1S $T=812820 407120 1 0 $X=812820 $Y=401700
X1674 4523 2 4562 1 INV1S $T=812820 407120 0 0 $X=812820 $Y=406740
X1675 4499 2 4567 1 INV1S $T=814060 497840 1 0 $X=814060 $Y=492420
X1676 4531 2 4576 1 INV1S $T=814680 376880 0 0 $X=814680 $Y=376500
X1677 4484 2 4572 1 INV1S $T=815300 467600 0 0 $X=815300 $Y=467220
X1678 4520 2 4579 1 INV1S $T=815920 356720 0 0 $X=815920 $Y=356340
X1679 4503 2 4565 1 INV1S $T=815920 447440 0 0 $X=815920 $Y=447060
X1680 4573 2 4581 1 INV1S $T=815920 497840 1 0 $X=815920 $Y=492420
X1681 4543 2 4568 1 INV1S $T=816540 386960 0 0 $X=816540 $Y=386580
X1682 4582 2 4597 1 INV1S $T=819020 427280 0 0 $X=819020 $Y=426900
X1683 4473 2 4595 1 INV1S $T=820880 477680 0 0 $X=820880 $Y=477300
X1684 4604 2 4556 1 INV1S $T=822740 427280 1 180 $X=821500 $Y=426900
X1685 3879 2 3851 1 INV1S $T=823980 497840 0 180 $X=822740 $Y=492420
X1686 270 2 4623 1 INV1S $T=824600 366800 1 0 $X=824600 $Y=361380
X1687 290 2 4620 1 INV1S $T=824600 386960 0 0 $X=824600 $Y=386580
X1688 4564 2 4617 1 INV1S $T=824600 437360 0 0 $X=824600 $Y=436980
X1689 4504 2 4611 1 INV1S $T=825840 447440 1 180 $X=824600 $Y=447060
X1690 4494 2 4573 1 INV1S $T=826460 497840 0 180 $X=825220 $Y=492420
X1691 4585 2 4632 1 INV1S $T=827080 427280 0 0 $X=827080 $Y=426900
X1692 297 2 4631 1 INV1S $T=827700 386960 1 0 $X=827700 $Y=381540
X1693 917 2 913 1 INV1S $T=830800 326480 0 180 $X=829560 $Y=321060
X1694 832 2 4667 1 INV1S $T=832040 437360 0 0 $X=832040 $Y=436980
X1695 300 2 4659 1 INV1S $T=833280 397040 1 0 $X=833280 $Y=391620
X1696 283 2 4665 1 INV1S $T=836380 356720 0 180 $X=835140 $Y=351300
X1697 3519 2 4701 1 INV1S $T=839480 366800 1 0 $X=839480 $Y=361380
X1698 779 2 4724 1 INV1S $T=843200 386960 0 0 $X=843200 $Y=386580
X1699 4664 2 4713 1 INV1S $T=845060 376880 1 0 $X=845060 $Y=371460
X1700 940 2 4717 1 INV1S $T=845060 386960 1 0 $X=845060 $Y=381540
X1701 958 2 960 1 INV1S $T=845680 346640 0 0 $X=845680 $Y=346260
X1702 4545 2 4743 1 INV1S $T=847540 437360 1 0 $X=847540 $Y=431940
X1703 931 2 966 1 INV1S $T=848160 346640 1 0 $X=848160 $Y=341220
X1704 4649 2 4754 1 INV1S $T=850020 437360 0 0 $X=850020 $Y=436980
X1705 963 2 976 1 INV1S $T=850640 346640 0 0 $X=850640 $Y=346260
X1706 3613 2 4757 1 INV1S $T=850640 397040 1 0 $X=850640 $Y=391620
X1707 919 2 4765 1 INV1S $T=851880 356720 0 0 $X=851880 $Y=356340
X1708 923 2 4791 1 INV1S $T=856840 366800 0 0 $X=856840 $Y=366420
X1709 942 2 991 1 INV1S $T=857460 336560 1 0 $X=857460 $Y=331140
X1710 4795 2 4759 1 INV1S $T=858700 376880 1 180 $X=857460 $Y=376500
X1711 4822 2 4815 1 INV1S $T=868620 376880 0 180 $X=867380 $Y=371460
X1712 4819 2 4802 1 INV1S $T=869240 376880 0 0 $X=869240 $Y=376500
X1713 4766 2 4778 1 INV1S $T=871100 366800 0 180 $X=869860 $Y=361380
X1714 4746 2 4846 1 INV1S $T=871720 376880 0 0 $X=871720 $Y=376500
X1715 4787 2 4810 1 INV1S $T=873580 356720 1 180 $X=872340 $Y=356340
X1716 4718 2 4767 1 INV1S $T=873580 386960 0 180 $X=872340 $Y=381540
X1717 4738 2 4808 1 INV1S $T=873580 366800 0 0 $X=873580 $Y=366420
X1718 4694 2 996 1 INV1S $T=879160 336560 0 0 $X=879160 $Y=336180
X1719 4801 2 4884 1 INV1S $T=884120 346640 0 0 $X=884120 $Y=346260
X1720 4866 2 4885 1 INV1S $T=885360 346640 0 0 $X=885360 $Y=346260
X1721 938 2 973 1 INV1S $T=887840 376880 1 0 $X=887840 $Y=371460
X1722 929 2 1055 1 INV1S $T=889700 346640 1 180 $X=888460 $Y=346260
X1723 4882 2 1071 1 INV1S $T=894660 366800 1 180 $X=893420 $Y=366420
X1724 956 2 989 1 INV1S $T=896520 336560 1 180 $X=895280 $Y=336180
X1725 934 2 1026 1 INV1S $T=895900 326480 0 0 $X=895900 $Y=326100
X1726 916 2 992 1 INV1S $T=897760 326480 1 0 $X=897760 $Y=321060
X1727 4826 2 1030 1 INV1S $T=899000 346640 0 180 $X=897760 $Y=341220
X1728 4887 2 4940 1 INV1S $T=900860 356720 0 0 $X=900860 $Y=356340
X1729 4877 2 4946 1 INV1S $T=903340 356720 1 0 $X=903340 $Y=351300
X1730 982 2 970 1 INV1S $T=907060 356720 0 0 $X=907060 $Y=356340
X1731 925 2 1081 1 INV1S $T=909540 336560 0 180 $X=908300 $Y=331140
X1732 946 2 1099 1 INV1S $T=910160 336560 1 0 $X=910160 $Y=331140
X1733 961 2 978 1 INV1S $T=913260 336560 0 0 $X=913260 $Y=336180
X1734 1127 2 5016 1 INV1S $T=921940 407120 1 0 $X=921940 $Y=401700
X1735 1073 2 1046 1 INV1S $T=925040 336560 1 0 $X=925040 $Y=331140
X1736 928 2 1117 1 INV1S $T=925660 346640 1 0 $X=925660 $Y=341220
X1737 1132 2 5036 1 INV1S $T=926280 407120 0 0 $X=926280 $Y=406740
X1738 981 2 1109 1 INV1S $T=931240 326480 1 0 $X=931240 $Y=321060
X1739 1040 2 1025 1 INV1S $T=932480 336560 0 180 $X=931240 $Y=331140
X1740 1111 2 1082 1 INV1S $T=931860 326480 0 0 $X=931860 $Y=326100
X1741 972 2 999 1 INV1S $T=931860 346640 1 0 $X=931860 $Y=341220
X1742 1139 2 5081 1 INV1S $T=933100 407120 1 0 $X=933100 $Y=401700
X1743 964 2 954 1 INV1S $T=934340 346640 1 0 $X=934340 $Y=341220
X1744 5087 2 5059 1 INV1S $T=936200 356720 0 180 $X=934960 $Y=351300
X1745 1029 2 971 1 INV1S $T=942400 326480 0 0 $X=942400 $Y=326100
X1746 4840 2 1083 1 INV1S $T=946740 346640 0 180 $X=945500 $Y=341220
X1747 1035 2 1183 1 INV1S $T=960380 326480 1 0 $X=960380 $Y=321060
X1748 1149 2 1154 1 INV1S $T=963480 518000 0 0 $X=963480 $Y=517620
X1749 5287 2 5295 1 INV1S $T=976500 407120 0 0 $X=976500 $Y=406740
X1750 5244 2 5297 1 INV1S $T=977740 417200 0 0 $X=977740 $Y=416820
X1751 5303 2 5377 1 INV1S $T=997580 407120 0 0 $X=997580 $Y=406740
X1752 5019 1 2 1130 BUF1S $T=923180 497840 0 0 $X=923180 $Y=497460
X1753 5099 1 2 5019 BUF1S $T=935580 497840 0 0 $X=935580 $Y=497460
X1754 1404 1 1393 1452 2 ND2P $T=238700 427280 0 0 $X=238700 $Y=426900
X1755 2179 1 2168 2164 2 ND2P $T=377580 407120 0 180 $X=373860 $Y=401700
X1756 2190 1 2168 2172 2 ND2P $T=381920 397040 1 180 $X=378200 $Y=396660
X1757 1656 1 2175 2254 2 ND2P $T=389980 518000 1 0 $X=389980 $Y=512580
X1758 2323 1 2316 2309 2 ND2P $T=405480 467600 1 0 $X=405480 $Y=462180
X1759 2344 1 2316 2299 2 ND2P $T=409820 467600 0 0 $X=409820 $Y=467220
X1760 2407 1 2420 2436 2 ND2P $T=422840 447440 1 0 $X=422840 $Y=442020
X1761 2398 1 2420 2457 2 ND2P $T=426560 427280 0 0 $X=426560 $Y=426900
X1762 2439 1 2446 2461 2 ND2P $T=429040 447440 1 0 $X=429040 $Y=442020
X1763 2471 1 2446 2503 2 ND2P $T=435240 447440 1 0 $X=435240 $Y=442020
X1764 2883 1 3210 3193 2 ND2P $T=565440 507920 1 0 $X=565440 $Y=502500
X1765 3201 1 3224 3227 2 ND2P $T=574740 457520 1 180 $X=571020 $Y=457140
X1766 3263 1 3298 3254 2 ND2P $T=581560 427280 1 0 $X=581560 $Y=421860
X1767 419 1 3303 3298 2 ND2P $T=582800 437360 1 0 $X=582800 $Y=431940
X1768 3329 1 3271 3277 2 ND2P $T=590240 417200 1 0 $X=590240 $Y=411780
X1769 419 1 3338 3329 2 ND2P $T=590240 417200 0 0 $X=590240 $Y=416820
X1770 2968 1 2994 3240 2 ND2P $T=592720 437360 1 0 $X=592720 $Y=431940
X1771 3449 1 3399 3556 2 ND2P $T=623100 417200 1 0 $X=623100 $Y=411780
X1772 3587 1 3596 3588 2 ND2P $T=633020 467600 0 0 $X=633020 $Y=467220
X1773 3579 1 3606 3553 2 ND2P $T=637980 518000 1 0 $X=637980 $Y=512580
X1774 3243 1 3585 3633 2 ND2P $T=646660 437360 1 0 $X=646660 $Y=431940
X1775 3684 1 3659 3676 2 ND2P $T=657200 386960 0 0 $X=657200 $Y=386580
X1776 3705 1 3728 3714 2 ND2P $T=663400 397040 0 0 $X=663400 $Y=396660
X1777 3709 1 3753 3713 2 ND2P $T=668980 407120 0 0 $X=668980 $Y=406740
X1778 3964 1 3788 3989 2 ND2P $T=708040 427280 0 0 $X=708040 $Y=426900
X1779 4086 1 4124 4103 2 ND2P $T=730360 397040 0 0 $X=730360 $Y=396660
X1780 4093 1 4124 4117 2 ND2P $T=730980 386960 0 0 $X=730980 $Y=386580
X1781 4424 1 4407 4434 2 ND2P $T=790500 467600 0 0 $X=790500 $Y=467220
X1782 832 1 4466 4476 2 ND2P $T=795460 467600 0 0 $X=795460 $Y=467220
X1783 4498 1 4476 4519 2 ND2P $T=802900 477680 0 0 $X=802900 $Y=477300
X1784 4683 1 4690 4693 2 ND2P $T=837620 477680 0 0 $X=837620 $Y=477300
X1785 1430 1463 1511 2 1 1518 XOR3 $T=244280 457520 0 0 $X=244280 $Y=457140
X1786 1452 1578 1582 2 1 1646 XOR3 $T=261640 427280 1 0 $X=261640 $Y=421860
X1787 1378 1581 1568 2 1 1676 XOR3 $T=265980 497840 0 0 $X=265980 $Y=497460
X1788 1633 1645 1517 2 1 1752 XOR3 $T=273420 417200 1 0 $X=273420 $Y=411780
X1789 1815 1613 1823 2 1 1817 XOR3 $T=305660 447440 1 0 $X=305660 $Y=442020
X1790 1827 1646 1822 2 1 1792 XOR3 $T=311860 427280 0 0 $X=311860 $Y=426900
X1791 1825 1752 1830 2 1 1849 XOR3 $T=312480 427280 1 0 $X=312480 $Y=421860
X1792 1872 1877 1891 2 1 1815 XOR3 $T=321780 457520 1 0 $X=321780 $Y=452100
X1793 1888 1878 1855 2 1 1827 XOR3 $T=327980 457520 0 0 $X=327980 $Y=457140
X1794 1906 1672 1865 2 1 1932 XOR3 $T=333560 437360 0 0 $X=333560 $Y=436980
X1795 1976 1982 1986 2 1 2030 XOR3 $T=341000 467600 1 0 $X=341000 $Y=462180
X1796 2007 2014 2041 2 1 1995 XOR3 $T=347820 407120 0 0 $X=347820 $Y=406740
X1797 1993 1985 1933 2 1 1906 XOR3 $T=347820 457520 1 0 $X=347820 $Y=452100
X1798 2030 1534 1940 2 1 1998 XOR3 $T=355260 447440 1 0 $X=355260 $Y=442020
X1799 2057 2067 2112 2 1 2007 XOR3 $T=355880 417200 1 0 $X=355880 $Y=411780
X1800 2064 2072 2116 2 1 2117 XOR3 $T=356500 437360 0 0 $X=356500 $Y=436980
X1801 2069 2076 321 2 1 2093 XOR3 $T=357120 336560 0 0 $X=357120 $Y=336180
X1802 2103 2106 2080 2 1 2066 XOR3 $T=368900 366800 0 180 $X=357740 $Y=361380
X1803 2045 2063 2050 2 1 2060 XOR3 $T=357740 407120 1 0 $X=357740 $Y=401700
X1804 2081 2086 2125 2 1 2104 XOR3 $T=358980 376880 0 0 $X=358980 $Y=376500
X1805 2052 1596 2043 2 1 2150 XOR3 $T=358980 447440 0 0 $X=358980 $Y=447060
X1806 2126 2104 2074 2 1 2082 XOR3 $T=371380 386960 0 180 $X=360220 $Y=381540
X1807 2090 2102 2121 2 1 2106 XOR3 $T=362080 366800 0 0 $X=362080 $Y=366420
X1808 2167 2156 2110 2 1 2103 XOR3 $T=375100 346640 1 180 $X=363940 $Y=346260
X1809 2096 2087 2079 2 1 2052 XOR3 $T=366420 457520 0 0 $X=366420 $Y=457140
X1810 2077 2128 2114 2 1 2095 XOR3 $T=368900 467600 1 0 $X=368900 $Y=462180
X1811 2137 2147 2181 2 1 2202 XOR3 $T=370760 477680 1 0 $X=370760 $Y=472260
X1812 2138 1676 2152 2 1 2205 XOR3 $T=370760 487760 0 0 $X=370760 $Y=487380
X1813 2142 2149 2171 2 1 2045 XOR3 $T=371380 376880 1 0 $X=371380 $Y=371460
X1814 2127 2133 2129 2 1 2023 XOR3 $T=372000 427280 0 0 $X=372000 $Y=426900
X1815 2155 2162 2198 2 1 2201 XOR3 $T=372620 417200 0 0 $X=372620 $Y=416820
X1816 2153 2163 2159 2 1 2221 XOR3 $T=372620 518000 1 0 $X=372620 $Y=512580
X1817 2173 2176 335 2 1 2076 XOR3 $T=375720 336560 0 0 $X=375720 $Y=336180
X1818 2157 1545 2151 2 1 2226 XOR3 $T=376340 497840 0 0 $X=376340 $Y=497460
X1819 333 336 338 2 1 340 XOR3 $T=376960 507920 0 0 $X=376960 $Y=507540
X1820 2206 2209 2143 2 1 2216 XOR3 $T=384400 437360 1 0 $X=384400 $Y=431940
X1821 2218 1540 2236 2 1 2326 XOR3 $T=386880 487760 1 0 $X=386880 $Y=482340
X1822 2235 2240 2245 2 1 2287 XOR3 $T=389360 447440 0 0 $X=389360 $Y=447060
X1823 1656 2221 2175 2 1 2289 XOR3 $T=389360 507920 0 0 $X=389360 $Y=507540
X1824 2286 2280 2248 2 1 2240 XOR3 $T=401140 427280 0 180 $X=389980 $Y=421860
X1825 2135 2238 2242 2 1 2157 XOR3 $T=389980 507920 1 0 $X=389980 $Y=502500
X1826 2202 1580 2119 2 1 2203 XOR3 $T=391220 477680 1 0 $X=391220 $Y=472260
X1827 2130 2252 2193 2 1 2218 XOR3 $T=394320 497840 1 0 $X=394320 $Y=492420
X1828 341 342 2264 2 1 2365 XOR3 $T=399280 518000 0 0 $X=399280 $Y=517620
X1829 2305 2312 2322 2 1 2343 XOR3 $T=404240 457520 1 0 $X=404240 $Y=452100
X1830 2358 2377 2362 2 1 2344 XOR3 $T=415400 417200 0 0 $X=415400 $Y=416820
X1831 2387 2391 2341 2 1 2421 XOR3 $T=418500 447440 0 0 $X=418500 $Y=447060
X1832 2488 2493 2502 2 1 2505 XOR3 $T=437100 477680 1 0 $X=437100 $Y=472260
X1833 2439 2471 2446 2 1 2520 XOR3 $T=441440 447440 1 0 $X=441440 $Y=442020
X1834 2482 2487 2494 2 1 2488 XOR3 $T=441440 467600 1 0 $X=441440 $Y=462180
X1835 2398 2407 2420 2 1 2493 XOR3 $T=442060 467600 0 0 $X=442060 $Y=467220
X1836 2520 2531 2438 2 1 2583 XOR3 $T=443300 457520 1 0 $X=443300 $Y=452100
X1837 2434 2566 2492 2 1 2615 XOR3 $T=453220 427280 0 0 $X=453220 $Y=426900
X1838 3050 3059 3117 2 1 3084 XOR3 $T=541260 397040 1 0 $X=541260 $Y=391620
X1839 3110 3107 3160 2 1 3173 XOR3 $T=549320 427280 1 0 $X=549320 $Y=421860
X1840 2905 3146 3181 2 1 3187 XOR3 $T=553040 457520 1 0 $X=553040 $Y=452100
X1841 3157 2995 3168 2 1 3179 XOR3 $T=557380 397040 0 0 $X=557380 $Y=396660
X1842 3175 2899 3191 2 1 3256 XOR3 $T=562340 487760 1 0 $X=562340 $Y=482340
X1843 3180 2894 3186 2 1 3233 XOR3 $T=562340 497840 0 0 $X=562340 $Y=497460
X1844 3185 3184 3189 2 1 3235 XOR3 $T=564200 427280 0 0 $X=564200 $Y=426900
X1845 2916 3199 3208 2 1 3243 XOR3 $T=565440 457520 1 0 $X=565440 $Y=452100
X1846 3152 2893 3188 2 1 3266 XOR3 $T=567920 477680 1 0 $X=567920 $Y=472260
X1847 2856 3207 3155 2 1 3279 XOR3 $T=571020 417200 0 0 $X=571020 $Y=416820
X1848 3211 2883 3210 2 1 663 XOR3 $T=571020 507920 0 0 $X=571020 $Y=507540
X1849 3177 2888 3214 2 1 3290 XOR3 $T=571640 437360 1 0 $X=571640 $Y=431940
X1850 3284 3279 3198 2 1 3282 XOR3 $T=581560 386960 0 0 $X=581560 $Y=386580
X1851 3176 2872 3238 2 1 733 XOR3 $T=619380 497840 0 0 $X=619380 $Y=497460
X1852 3531 3536 3574 2 1 3601 XOR3 $T=623100 427280 1 0 $X=623100 $Y=421860
X1853 3591 3215 3599 2 1 3654 XOR3 $T=633640 447440 1 0 $X=633640 $Y=442020
X1854 3565 3235 3490 2 1 3577 XOR3 $T=634880 407120 1 0 $X=634880 $Y=401700
X1855 3587 3266 3596 2 1 3658 XOR3 $T=636740 467600 0 0 $X=636740 $Y=467220
X1856 735 3579 3606 2 1 747 XOR3 $T=636740 507920 0 0 $X=636740 $Y=507540
X1857 3648 3651 3674 2 1 3642 XOR3 $T=646040 346640 1 0 $X=646040 $Y=341220
X1858 3662 3684 3659 2 1 3640 XOR3 $T=659060 386960 0 180 $X=647900 $Y=381540
X1859 3621 3233 3616 2 1 3698 XOR3 $T=647900 497840 0 0 $X=647900 $Y=497460
X1860 3729 3734 3694 2 1 3685 XOR3 $T=668980 427280 1 180 $X=657820 $Y=426900
X1861 3692 3695 765 2 1 3683 XOR3 $T=658440 326480 0 0 $X=658440 $Y=326100
X1862 3771 3747 3704 2 1 3692 XOR3 $T=671460 336560 0 180 $X=660300 $Y=331140
X1863 3702 3716 3724 2 1 3662 XOR3 $T=662780 407120 1 0 $X=662780 $Y=401700
X1864 3718 3717 3727 2 1 3664 XOR3 $T=663400 366800 0 0 $X=663400 $Y=366420
X1865 3733 3675 773 2 1 774 XOR3 $T=665880 326480 1 0 $X=665880 $Y=321060
X1866 3743 3707 3762 2 1 3721 XOR3 $T=668980 366800 1 0 $X=668980 $Y=361380
X1867 3737 3711 3736 2 1 3666 XOR3 $T=671460 376880 0 0 $X=671460 $Y=376500
X1868 3761 3767 3810 2 1 782 XOR3 $T=671460 487760 1 0 $X=671460 $Y=482340
X1869 3766 3769 3725 2 1 3837 XOR3 $T=672080 427280 0 0 $X=672080 $Y=426900
X1870 3754 3741 3751 2 1 3705 XOR3 $T=674560 417200 1 0 $X=674560 $Y=411780
X1871 3780 3765 3773 2 1 3766 XOR3 $T=677660 437360 1 0 $X=677660 $Y=431940
X1872 3779 3774 3772 2 1 3729 XOR3 $T=678280 417200 0 0 $X=678280 $Y=416820
X1873 3791 3794 3787 2 1 787 XOR3 $T=680760 487760 0 0 $X=680760 $Y=487380
X1874 3871 3874 3856 2 1 3961 XOR3 $T=690060 427280 1 0 $X=690060 $Y=421860
X1875 3937 3951 4000 2 1 3684 XOR3 $T=702460 376880 0 0 $X=702460 $Y=376500
X1876 3939 3887 3954 2 1 4002 XOR3 $T=703700 417200 0 0 $X=703700 $Y=416820
X1877 808 811 820 2 1 823 XOR3 $T=711140 518000 0 0 $X=711140 $Y=517620
X1878 4002 4001 4009 2 1 4092 XOR3 $T=711760 427280 0 0 $X=711760 $Y=426900
X1879 3943 4026 4037 2 1 4085 XOR3 $T=714860 417200 0 0 $X=714860 $Y=416820
X1880 4062 4072 4080 2 1 3672 XOR3 $T=722920 366800 0 0 $X=722920 $Y=366420
X1881 4071 4083 4079 2 1 3671 XOR3 $T=724160 346640 0 0 $X=724160 $Y=346260
X1882 826 827 836 2 1 3695 XOR3 $T=724780 326480 1 0 $X=724780 $Y=321060
X1883 4100 4109 4114 2 1 3964 XOR3 $T=727880 417200 0 0 $X=727880 $Y=416820
X1884 4108 4107 4116 2 1 840 XOR3 $T=728500 518000 0 0 $X=728500 $Y=517620
X1885 4098 4104 4095 2 1 3734 XOR3 $T=731600 407120 1 0 $X=731600 $Y=401700
X1886 4099 4105 4096 2 1 3769 XOR3 $T=733460 417200 1 0 $X=733460 $Y=411780
X1887 4121 4118 4126 2 1 4001 XOR3 $T=735320 427280 1 0 $X=735320 $Y=421860
X1888 4437 4450 4429 2 1 897 XOR3 $T=792980 518000 0 0 $X=792980 $Y=517620
X1889 4472 4477 4468 2 1 902 XOR3 $T=802280 518000 1 0 $X=802280 $Y=512580
X1890 903 904 909 2 1 912 XOR3 $T=817160 518000 1 0 $X=817160 $Y=512580
X1891 4549 4574 4591 2 1 920 XOR3 $T=822120 507920 0 0 $X=822120 $Y=507540
X1892 4596 4613 4606 2 1 939 XOR3 $T=827700 507920 1 0 $X=827700 $Y=502500
X1893 4679 4702 4715 2 1 979 XOR3 $T=840720 487760 1 0 $X=840720 $Y=482340
X1894 1002 4751 4730 2 1 4833 XOR3 $T=860560 487760 1 0 $X=860560 $Y=482340
X1895 2144 1 2177 2183 2 2168 ND3HT $T=373240 386960 1 0 $X=373240 $Y=381540
X1896 2278 1 2288 2296 2 2316 ND3HT $T=397420 467600 1 0 $X=397420 $Y=462180
X1897 1299 1305 1328 2 1 XOR2HS $T=221340 447440 0 0 $X=221340 $Y=447060
X1898 1301 1306 1330 2 1 XOR2HS $T=221340 477680 1 0 $X=221340 $Y=472260
X1899 10 15 1331 2 1 XOR2HS $T=221340 518000 0 0 $X=221340 $Y=517620
X1900 1317 1308 1345 2 1 XOR2HS $T=222580 497840 1 0 $X=222580 $Y=492420
X1901 1327 1322 1351 2 1 XOR2HS $T=223820 487760 1 0 $X=223820 $Y=482340
X1902 1329 1312 1365 2 1 XOR2HS $T=226300 467600 0 0 $X=226300 $Y=467220
X1903 1343 1300 1360 2 1 XOR2HS $T=226300 497840 0 0 $X=226300 $Y=497460
X1904 1338 1313 1366 2 1 XOR2HS $T=226300 518000 1 0 $X=226300 $Y=512580
X1905 1370 1316 1424 2 1 XOR2HS $T=234980 457520 0 0 $X=234980 $Y=457140
X1906 1454 1353 1382 2 1 XOR2HS $T=243040 437360 1 0 $X=243040 $Y=431940
X1907 1487 1427 1474 2 1 XOR2HS $T=251100 447440 0 180 $X=245520 $Y=442020
X1908 1464 1477 1492 2 1 XOR2HS $T=246760 447440 0 0 $X=246760 $Y=447060
X1909 1515 1479 1498 2 1 XOR2HS $T=255440 457520 0 180 $X=249860 $Y=452100
X1910 1519 1483 1501 2 1 XOR2HS $T=256060 467600 0 180 $X=250480 $Y=462180
X1911 1514 1474 1534 2 1 XOR2HS $T=253580 437360 0 0 $X=253580 $Y=436980
X1912 1556 1498 1596 2 1 XOR2HS $T=262260 447440 0 0 $X=262260 $Y=447060
X1913 1626 1621 1610 2 1 XOR2HS $T=272800 477680 1 180 $X=267220 $Y=477300
X1914 1673 1667 1649 2 1 XOR2HS $T=279620 487760 1 180 $X=274040 $Y=487380
X1915 1658 1651 1680 2 1 XOR2HS $T=275900 457520 0 0 $X=275900 $Y=457140
X1916 1683 1548 1628 2 1 XOR2HS $T=281480 467600 0 180 $X=275900 $Y=462180
X1917 1695 1689 1669 2 1 XOR2HS $T=282720 518000 0 180 $X=277140 $Y=512580
X1918 1688 1701 1638 2 1 XOR2HS $T=283960 507920 0 180 $X=278380 $Y=502500
X1919 1546 1666 1709 2 1 XOR2HS $T=280860 427280 1 0 $X=280860 $Y=421860
X1920 1704 1700 1655 2 1 XOR2HS $T=282100 477680 1 0 $X=282100 $Y=472260
X1921 1706 1693 1675 2 1 XOR2HS $T=282720 417200 0 0 $X=282720 $Y=416820
X1922 1726 1723 1681 2 1 XOR2HS $T=288920 507920 1 180 $X=283340 $Y=507540
X1923 1858 1856 1843 2 1 XOR2HS $T=318680 477680 0 180 $X=313100 $Y=472260
X1924 1884 1870 1898 2 1 XOR2HS $T=323640 477680 1 0 $X=323640 $Y=472260
X1925 1930 1936 1916 2 1 XOR2HS $T=333560 397040 0 180 $X=327980 $Y=391620
X1926 1917 1709 1945 2 1 XOR2HS $T=329840 427280 0 0 $X=329840 $Y=426900
X1927 1927 1923 1917 2 1 XOR2HS $T=330460 437360 1 0 $X=330460 $Y=431940
X1928 1956 1951 1968 2 1 XOR2HS $T=336040 397040 1 0 $X=336040 $Y=391620
X1929 1934 1972 1941 2 1 XOR2HS $T=343480 467600 1 180 $X=337900 $Y=467220
X1930 1960 1978 2001 2 1 XOR2HS $T=342240 397040 0 0 $X=342240 $Y=396660
X1931 1988 1992 2019 2 1 XOR2HS $T=345960 477680 1 0 $X=345960 $Y=472260
X1932 2058 1977 2038 2 1 XOR2HS $T=357120 477680 0 180 $X=351540 $Y=472260
X1933 2024 1994 2051 2 1 XOR2HS $T=355880 386960 0 0 $X=355880 $Y=386580
X1934 2085 2084 2068 2 1 XOR2HS $T=361460 497840 1 180 $X=355880 $Y=497460
X1935 2013 2088 2061 2 1 XOR2HS $T=362080 487760 0 180 $X=356500 $Y=482340
X1936 2073 2071 2098 2 1 XOR2HS $T=358980 518000 1 0 $X=358980 $Y=512580
X1937 322 320 323 2 1 XOR2HS $T=359600 518000 0 0 $X=359600 $Y=517620
X1938 2075 2078 2108 2 1 XOR2HS $T=360840 507920 0 0 $X=360840 $Y=507540
X1939 2100 2089 2097 2 1 XOR2HS $T=362700 477680 1 0 $X=362700 $Y=472260
X1940 2092 2091 2118 2 1 XOR2HS $T=363940 487760 0 0 $X=363940 $Y=487380
X1941 2160 2154 2063 2 1 XOR2HS $T=374480 356720 0 180 $X=368900 $Y=351300
X1942 2124 2113 2134 2 1 XOR2HS $T=370760 487760 1 0 $X=370760 $Y=482340
X1943 2168 2174 2126 2 1 XOR2HS $T=377580 397040 0 180 $X=372000 $Y=391620
X1944 2186 2184 2160 2 1 XOR2HS $T=380680 356720 0 180 $X=375100 $Y=351300
X1945 2179 2190 2174 2 1 XOR2HS $T=381300 397040 1 0 $X=381300 $Y=391620
X1946 2227 2231 2213 2 1 XOR2HS $T=390600 417200 0 180 $X=385020 $Y=411780
X1947 2251 2243 2200 2 1 XOR2HS $T=392460 386960 0 180 $X=386880 $Y=381540
X1948 345 344 2210 2 1 XOR2HS $T=395560 326480 0 180 $X=389980 $Y=321060
X1949 2262 2261 2233 2 1 XOR2HS $T=395560 366800 0 180 $X=389980 $Y=361380
X1950 2274 2270 2222 2 1 XOR2HS $T=398040 346640 0 180 $X=392460 $Y=341220
X1951 2257 2256 2234 2 1 XOR2HS $T=393080 397040 1 0 $X=393080 $Y=391620
X1952 2260 2255 2219 2 1 XOR2HS $T=394940 346640 0 0 $X=394940 $Y=346260
X1953 2282 2239 2269 2 1 XOR2HS $T=400520 397040 1 180 $X=394940 $Y=396660
X1954 2263 346 2237 2 1 XOR2HS $T=396180 326480 0 0 $X=396180 $Y=326100
X1955 2250 2249 2214 2 1 XOR2HS $T=396180 356720 1 0 $X=396180 $Y=351300
X1956 2300 2304 2293 2 1 XOR2HS $T=406100 417200 0 180 $X=400520 $Y=411780
X1957 2315 2324 2336 2 1 XOR2HS $T=404860 417200 0 0 $X=404860 $Y=416820
X1958 2351 2327 2342 2 1 XOR2HS $T=414160 397040 1 180 $X=408580 $Y=396660
X1959 2375 2340 2357 2 1 XOR2HS $T=417260 417200 0 180 $X=411680 $Y=411780
X1960 2344 2323 2380 2 1 XOR2HS $T=414160 467600 1 0 $X=414160 $Y=462180
X1961 2316 2380 2389 2 1 XOR2HS $T=415400 467600 0 0 $X=415400 $Y=467220
X1962 2374 2371 2386 2 1 XOR2HS $T=419120 407120 1 0 $X=419120 $Y=401700
X1963 2432 2430 2412 2 1 XOR2HS $T=428420 407120 1 180 $X=422840 $Y=406740
X1964 2403 2404 2428 2 1 XOR2HS $T=423460 417200 1 0 $X=423460 $Y=411780
X1965 2448 2442 2435 2 1 XOR2HS $T=432760 397040 1 180 $X=427180 $Y=396660
X1966 2459 2454 2425 2 1 XOR2HS $T=434620 427280 0 180 $X=429040 $Y=421860
X1967 2443 2449 2456 2 1 XOR2HS $T=429660 417200 1 0 $X=429660 $Y=411780
X1968 391 390 381 2 1 XOR2HS $T=436480 326480 0 180 $X=430900 $Y=321060
X1969 2474 2463 2453 2 1 XOR2HS $T=437100 386960 1 180 $X=431520 $Y=386580
X1970 2480 2473 2455 2 1 XOR2HS $T=437720 346640 0 180 $X=432140 $Y=341220
X1971 2495 2497 2472 2 1 XOR2HS $T=440820 326480 1 180 $X=435240 $Y=326100
X1972 2508 2504 2468 2 1 XOR2HS $T=442680 366800 1 180 $X=437100 $Y=366420
X1973 2486 2464 2478 2 1 XOR2HS $T=437720 397040 1 0 $X=437720 $Y=391620
X1974 2519 2510 2460 2 1 XOR2HS $T=444540 427280 1 180 $X=438960 $Y=426900
X1975 2499 2500 2476 2 1 XOR2HS $T=440200 356720 0 0 $X=440200 $Y=356340
X1976 2511 2506 2467 2 1 XOR2HS $T=442680 356720 1 0 $X=442680 $Y=351300
X1977 2559 2555 2517 2 1 XOR2HS $T=453220 417200 1 180 $X=447640 $Y=416820
X1978 2574 2569 2561 2 1 XOR2HS $T=456940 437360 1 180 $X=451360 $Y=436980
X1979 2545 2538 2541 2 1 XOR2HS $T=453220 427280 1 0 $X=453220 $Y=421860
X1980 2575 2501 2587 2 1 XOR2HS $T=455080 467600 0 0 $X=455080 $Y=467220
X1981 2588 2582 2598 2 1 XOR2HS $T=458180 417200 0 0 $X=458180 $Y=416820
X1982 2599 2606 2617 2 1 XOR2HS $T=460660 447440 1 0 $X=460660 $Y=442020
X1983 2600 2509 2618 2 1 XOR2HS $T=460660 467600 0 0 $X=460660 $Y=467220
X1984 2629 2623 2611 2 1 XOR2HS $T=467480 407120 1 180 $X=461900 $Y=406740
X1985 2621 2615 2600 2 1 XOR2HS $T=464380 457520 0 0 $X=464380 $Y=457140
X1986 2655 2649 2632 2 1 XOR2HS $T=471200 417200 1 180 $X=465620 $Y=416820
X1987 2635 2630 2658 2 1 XOR2HS $T=466860 447440 1 0 $X=466860 $Y=442020
X1988 2643 2613 2657 2 1 XOR2HS $T=467480 437360 1 0 $X=467480 $Y=431940
X1989 2676 2671 2661 2 1 XOR2HS $T=476780 397040 0 180 $X=471200 $Y=391620
X1990 2659 2654 2677 2 1 XOR2HS $T=471820 407120 1 0 $X=471820 $Y=401700
X1991 2688 2685 2666 2 1 XOR2HS $T=478020 376880 0 180 $X=472440 $Y=371460
X1992 2689 2682 2667 2 1 XOR2HS $T=478020 417200 1 180 $X=472440 $Y=416820
X1993 2684 2672 2709 2 1 XOR2HS $T=476780 447440 1 0 $X=476780 $Y=442020
X1994 2719 2706 2699 2 1 XOR2HS $T=483600 366800 0 180 $X=478020 $Y=361380
X1995 2715 2716 2687 2 1 XOR2HS $T=481740 427280 0 0 $X=481740 $Y=426900
X1996 2707 2710 2683 2 1 XOR2HS $T=482980 427280 1 0 $X=482980 $Y=421860
X1997 2810 2822 2832 2 1 XOR2HS $T=498480 497840 0 0 $X=498480 $Y=497460
X1998 2814 2819 2843 2 1 XOR2HS $T=500960 518000 1 0 $X=500960 $Y=512580
X1999 2852 2849 2835 2 1 XOR2HS $T=507780 427280 0 180 $X=502200 $Y=421860
X2000 2811 2817 2854 2 1 XOR2HS $T=502200 477680 0 0 $X=502200 $Y=477300
X2001 2812 2818 2860 2 1 XOR2HS $T=503440 487760 1 0 $X=503440 $Y=482340
X2002 2833 2827 2861 2 1 XOR2HS $T=503440 497840 1 0 $X=503440 $Y=492420
X2003 2837 2830 2867 2 1 XOR2HS $T=504060 507920 0 0 $X=504060 $Y=507540
X2004 2848 2839 2873 2 1 XOR2HS $T=505920 477680 1 0 $X=505920 $Y=472260
X2005 2876 2875 2865 2 1 XOR2HS $T=512120 437360 0 180 $X=506540 $Y=431940
X2006 2868 2846 2879 2 1 XOR2HS $T=507160 467600 1 0 $X=507160 $Y=462180
X2007 2866 2859 2884 2 1 XOR2HS $T=508400 457520 1 0 $X=508400 $Y=452100
X2008 2882 2885 2897 2 1 XOR2HS $T=510880 407120 1 0 $X=510880 $Y=401700
X2009 2845 2870 2898 2 1 XOR2HS $T=510880 437360 0 0 $X=510880 $Y=436980
X2010 2967 2993 2979 2 1 XOR2HS $T=533200 417200 1 180 $X=527620 $Y=416820
X2011 2927 2919 3054 2 1 XOR2HS $T=538160 407120 0 0 $X=538160 $Y=406740
X2012 3092 3082 3068 2 1 XOR2HS $T=548700 427280 1 180 $X=543120 $Y=426900
X2013 3075 3081 3059 2 1 XOR2HS $T=544360 397040 0 0 $X=544360 $Y=396660
X2014 2937 3091 3081 2 1 XOR2HS $T=546840 407120 1 0 $X=546840 $Y=401700
X2015 592 594 601 2 1 XOR2HS $T=546840 518000 0 0 $X=546840 $Y=517620
X2016 3096 3083 3124 2 1 XOR2HS $T=548080 467600 0 0 $X=548080 $Y=467220
X2017 3047 3048 3132 2 1 XOR2HS $T=549320 417200 0 0 $X=549320 $Y=416820
X2018 3106 3071 3133 2 1 XOR2HS $T=549320 487760 1 0 $X=549320 $Y=482340
X2019 3077 3087 3134 2 1 XOR2HS $T=549320 487760 0 0 $X=549320 $Y=487380
X2020 3088 3093 3135 2 1 XOR2HS $T=549320 497840 1 0 $X=549320 $Y=492420
X2021 3108 3105 3136 2 1 XOR2HS $T=549320 497840 0 0 $X=549320 $Y=497460
X2022 3099 3113 3149 2 1 XOR2HS $T=551180 467600 1 0 $X=551180 $Y=462180
X2023 3128 3126 3150 2 1 XOR2HS $T=551800 437360 0 0 $X=551800 $Y=436980
X2024 3129 3141 3154 2 1 XOR2HS $T=553040 447440 0 0 $X=553040 $Y=447060
X2025 3137 3120 3156 2 1 XOR2HS $T=553660 507920 0 0 $X=553660 $Y=507540
X2026 3138 3139 3158 2 1 XOR2HS $T=554280 427280 0 0 $X=554280 $Y=426900
X2027 3166 3054 3153 2 1 XOR2HS $T=561100 407120 1 180 $X=555520 $Y=406740
X2028 3127 3119 3174 2 1 XOR2HS $T=557380 457520 0 0 $X=557380 $Y=457140
X2029 3109 3114 3167 2 1 XOR2HS $T=557380 518000 1 0 $X=557380 $Y=512580
X2030 3246 3242 3166 2 1 XOR2HS $T=577840 417200 0 180 $X=572260 $Y=411780
X2031 3252 661 3241 2 1 XOR2HS $T=585280 518000 1 180 $X=579700 $Y=517620
X2032 3416 3403 3410 2 1 XOR2HS $T=608220 427280 0 180 $X=602640 $Y=421860
X2033 686 688 3388 2 1 XOR2HS $T=605740 518000 0 0 $X=605740 $Y=517620
X2034 3461 3426 3441 2 1 XOR2HS $T=613800 427280 1 180 $X=608220 $Y=426900
X2035 3460 3469 3487 2 1 XOR2HS $T=613180 386960 1 0 $X=613180 $Y=381540
X2036 3500 3496 3477 2 1 XOR2HS $T=619380 518000 0 180 $X=613800 $Y=512580
X2037 3517 3509 3493 2 1 XOR2HS $T=621860 437360 1 180 $X=616280 $Y=436980
X2038 3524 3522 3502 2 1 XOR2HS $T=623100 457520 1 180 $X=617520 $Y=457140
X2039 3472 3478 3527 2 1 XOR2HS $T=618760 477680 0 0 $X=618760 $Y=477300
X2040 3534 3526 3516 2 1 XOR2HS $T=624960 447440 1 180 $X=619380 $Y=447060
X2041 3495 3511 3529 2 1 XOR2HS $T=619380 507920 1 0 $X=619380 $Y=502500
X2042 3488 3494 3532 2 1 XOR2HS $T=620000 487760 1 0 $X=620000 $Y=482340
X2043 3483 3491 3533 2 1 XOR2HS $T=620000 487760 0 0 $X=620000 $Y=487380
X2044 3499 3506 3537 2 1 XOR2HS $T=620620 497840 1 0 $X=620620 $Y=492420
X2045 3512 3510 3539 2 1 XOR2HS $T=621240 467600 0 0 $X=621240 $Y=467220
X2046 3514 3513 3541 2 1 XOR2HS $T=621860 386960 1 0 $X=621860 $Y=381540
X2047 721 719 3530 2 1 XOR2HS $T=627440 518000 0 180 $X=621860 $Y=512580
X2048 3558 3566 3581 2 1 XOR2HS $T=629920 386960 1 0 $X=629920 $Y=381540
X2049 724 3530 738 2 1 XOR2HS $T=632400 518000 1 0 $X=632400 $Y=512580
X2050 3611 3592 3622 2 1 XOR2HS $T=636740 376880 0 0 $X=636740 $Y=376500
X2051 3582 3547 3646 2 1 XOR2HS $T=642320 417200 1 0 $X=642320 $Y=411780
X2052 3646 3564 3565 2 1 XOR2HS $T=646040 407120 0 0 $X=646040 $Y=406740
X2053 3682 3688 3661 2 1 XOR2HS $T=659680 417200 0 180 $X=654100 $Y=411780
X2054 3709 3705 3688 2 1 XOR2HS $T=663400 407120 1 180 $X=657820 $Y=406740
X2055 3715 3738 3726 2 1 XOR2HS $T=669600 346640 1 180 $X=664020 $Y=346260
X2056 3784 3783 3763 2 1 XOR2HS $T=676420 376880 0 180 $X=670840 $Y=371460
X2057 3793 3792 3778 2 1 XOR2HS $T=678900 407120 1 180 $X=673320 $Y=406740
X2058 3808 3804 3786 2 1 XOR2HS $T=680760 457520 1 180 $X=675180 $Y=457140
X2059 3819 3816 3802 2 1 XOR2HS $T=683240 497840 1 180 $X=677660 $Y=497460
X2060 3800 3802 780 2 1 XOR2HS $T=677660 507920 1 0 $X=677660 $Y=502500
X2061 3820 3817 3803 2 1 XOR2HS $T=683240 518000 0 180 $X=677660 $Y=512580
X2062 777 3803 781 2 1 XOR2HS $T=677660 518000 0 0 $X=677660 $Y=517620
X2063 3726 3782 3648 2 1 XOR2HS $T=678280 346640 1 0 $X=678280 $Y=341220
X2064 3801 3811 3822 2 1 XOR2HS $T=678900 447440 0 0 $X=678900 $Y=447060
X2065 3834 3805 783 2 1 XOR2HS $T=683860 477680 1 0 $X=683860 $Y=472260
X2066 3813 3858 3832 2 1 XOR2HS $T=690060 346640 0 180 $X=684480 $Y=341220
X2067 3864 785 3815 2 1 XOR2HS $T=690680 326480 1 180 $X=685100 $Y=326100
X2068 3840 3842 3818 2 1 XOR2HS $T=685720 376880 0 0 $X=685720 $Y=376500
X2069 3866 3859 3847 2 1 XOR2HS $T=691300 407120 1 180 $X=685720 $Y=406740
X2070 3849 3850 3868 2 1 XOR2HS $T=686340 467600 1 0 $X=686340 $Y=462180
X2071 3846 3833 3796 2 1 XOR2HS $T=686960 397040 0 0 $X=686960 $Y=396660
X2072 3855 3843 3806 2 1 XOR2HS $T=688820 386960 0 0 $X=688820 $Y=386580
X2073 3889 3881 3836 2 1 XOR2HS $T=695020 336560 0 180 $X=689440 $Y=331140
X2074 3854 3848 3883 2 1 XOR2HS $T=689440 447440 0 0 $X=689440 $Y=447060
X2075 3893 3888 3875 2 1 XOR2HS $T=695020 497840 1 180 $X=689440 $Y=497460
X2076 3865 3853 3825 2 1 XOR2HS $T=690680 366800 1 0 $X=690680 $Y=361380
X2077 3899 3895 3834 2 1 XOR2HS $T=696260 477680 1 180 $X=690680 $Y=477300
X2078 3872 3860 3824 2 1 XOR2HS $T=691300 356720 1 0 $X=691300 $Y=351300
X2079 3882 3886 3900 2 1 XOR2HS $T=691920 407120 0 0 $X=691920 $Y=406740
X2080 3894 793 790 2 1 XOR2HS $T=697500 518000 0 180 $X=691920 $Y=512580
X2081 3764 3892 3904 2 1 XOR2HS $T=692540 376880 0 0 $X=692540 $Y=376500
X2082 3913 3908 3857 2 1 XOR2HS $T=698120 487760 0 180 $X=692540 $Y=482340
X2083 3788 3920 3905 2 1 XOR2HS $T=700600 437360 0 180 $X=695020 $Y=431940
X2084 3929 3925 3869 2 1 XOR2HS $T=701220 497840 0 180 $X=695640 $Y=492420
X2085 3918 3861 3911 2 1 XOR2HS $T=701840 457520 1 180 $X=696260 $Y=457140
X2086 3955 3924 3934 2 1 XOR2HS $T=705560 407120 0 180 $X=699980 $Y=401700
X2087 3922 3915 3906 2 1 XOR2HS $T=699980 457520 1 0 $X=699980 $Y=452100
X2088 3930 3941 3902 2 1 XOR2HS $T=701220 487760 0 0 $X=701220 $Y=487380
X2089 3964 3961 3920 2 1 XOR2HS $T=707420 437360 0 180 $X=701840 $Y=431940
X2090 3945 3948 3935 2 1 XOR2HS $T=701840 467600 1 0 $X=701840 $Y=462180
X2091 3927 3957 3917 2 1 XOR2HS $T=703080 477680 0 0 $X=703080 $Y=477300
X2092 3963 3958 3932 2 1 XOR2HS $T=708660 507920 0 180 $X=703080 $Y=502500
X2093 3973 3969 3923 2 1 XOR2HS $T=708660 518000 1 180 $X=703080 $Y=517620
X2094 4003 3984 3975 2 1 XOR2HS $T=714240 467600 0 180 $X=708660 $Y=462180
X2095 4012 3997 4010 2 1 XOR2HS $T=714860 507920 0 0 $X=714860 $Y=507540
X2096 3988 3998 3999 2 1 XOR2HS $T=715480 407120 1 0 $X=715480 $Y=401700
X2097 4038 4028 4022 2 1 XOR2HS $T=719820 467600 0 0 $X=719820 $Y=467220
X2098 4064 4077 4048 2 1 XOR2HS $T=722920 518000 1 0 $X=722920 $Y=512580
X2099 4112 4101 4133 2 1 XOR2HS $T=729740 507920 1 0 $X=729740 $Y=502500
X2100 4127 4115 4140 2 1 XOR2HS $T=734080 467600 1 0 $X=734080 $Y=462180
X2101 4155 4149 4142 2 1 XOR2HS $T=740900 386960 0 180 $X=735320 $Y=381540
X2102 4167 4161 4129 2 1 XOR2HS $T=742760 336560 0 180 $X=737180 $Y=331140
X2103 4163 4168 4132 2 1 XOR2HS $T=744000 346640 0 180 $X=738420 $Y=341220
X2104 4150 4145 4169 2 1 XOR2HS $T=740900 507920 1 0 $X=740900 $Y=502500
X2105 4192 4182 4152 2 1 XOR2HS $T=747100 386960 0 180 $X=741520 $Y=381540
X2106 4187 4181 4148 2 1 XOR2HS $T=747720 326480 0 180 $X=742140 $Y=321060
X2107 4190 4189 4173 2 1 XOR2HS $T=747720 346640 1 180 $X=742140 $Y=346260
X2108 4204 4193 4178 2 1 XOR2HS $T=748340 397040 1 180 $X=742760 $Y=396660
X2109 4191 4186 4165 2 1 XOR2HS $T=745240 376880 1 0 $X=745240 $Y=371460
X2110 4176 4177 4166 2 1 XOR2HS $T=745860 467600 1 0 $X=745860 $Y=462180
X2111 4208 4211 4049 2 1 XOR2HS $T=747100 487760 0 0 $X=747100 $Y=487380
X2112 4207 4203 4164 2 1 XOR2HS $T=748340 356720 0 0 $X=748340 $Y=356340
X2113 4227 4226 4180 2 1 XOR2HS $T=750200 407120 1 0 $X=750200 $Y=401700
X2114 4209 4223 4210 2 1 XOR2HS $T=751440 507920 1 0 $X=751440 $Y=502500
X2115 4256 4242 4216 2 1 XOR2HS $T=758880 417200 0 180 $X=753300 $Y=411780
X2116 4240 4232 857 2 1 XOR2HS $T=755160 507920 0 0 $X=755160 $Y=507540
X2117 4263 4252 4253 2 1 XOR2HS $T=761360 467600 1 0 $X=761360 $Y=462180
X2118 4269 4266 4295 2 1 XOR2HS $T=761980 507920 1 0 $X=761980 $Y=502500
X2119 4307 4324 4294 2 1 XOR2HS $T=769420 427280 1 0 $X=769420 $Y=421860
X2120 4310 4303 4334 2 1 XOR2HS $T=770660 457520 1 0 $X=770660 $Y=452100
X2121 4326 4316 4347 2 1 XOR2HS $T=772520 507920 1 0 $X=772520 $Y=502500
X2122 4320 4284 4309 2 1 XOR2HS $T=773760 417200 1 0 $X=773760 $Y=411780
X2123 4392 4387 4375 2 1 XOR2HS $T=786160 417200 1 180 $X=780580 $Y=416820
X2124 4362 4367 4358 2 1 XOR2HS $T=780580 457520 0 0 $X=780580 $Y=457140
X2125 4377 4369 4389 2 1 XOR2HS $T=781200 507920 0 0 $X=781200 $Y=507540
X2126 4379 4401 4366 2 1 XOR2HS $T=784920 417200 1 0 $X=784920 $Y=411780
X2127 4417 4411 4438 2 1 XOR2HS $T=790500 457520 0 0 $X=790500 $Y=457140
X2128 4426 4413 4454 2 1 XOR2HS $T=791740 507920 1 0 $X=791740 $Y=502500
X2129 4452 4442 4436 2 1 XOR2HS $T=794220 417200 0 0 $X=794220 $Y=416820
X2130 4486 4490 4497 2 1 XOR2HS $T=799800 457520 0 0 $X=799800 $Y=457140
X2131 4488 4482 4502 2 1 XOR2HS $T=800420 507920 0 0 $X=800420 $Y=507540
X2132 4509 4496 4528 2 1 XOR2HS $T=804760 497840 1 0 $X=804760 $Y=492420
X2133 4512 4541 4522 2 1 XOR2HS $T=812200 336560 1 180 $X=806620 $Y=336180
X2134 4515 4546 4525 2 1 XOR2HS $T=812820 346640 1 180 $X=807240 $Y=346260
X2135 4505 4530 4466 2 1 XOR2HS $T=807240 467600 0 0 $X=807240 $Y=467220
X2136 4534 4538 4552 2 1 XOR2HS $T=808480 477680 0 0 $X=808480 $Y=477300
X2137 4559 4560 4518 2 1 XOR2HS $T=815920 376880 0 180 $X=810340 $Y=371460
X2138 4536 4539 4492 2 1 XOR2HS $T=810960 417200 1 0 $X=810960 $Y=411780
X2139 4521 4517 4551 2 1 XOR2HS $T=810960 457520 1 0 $X=810960 $Y=452100
X2140 4568 4570 4554 2 1 XOR2HS $T=817160 386960 0 180 $X=811580 $Y=381540
X2141 4548 4547 4569 2 1 XOR2HS $T=811580 497840 0 0 $X=811580 $Y=497460
X2142 4562 4590 4533 2 1 XOR2HS $T=820880 407120 1 180 $X=815300 $Y=406740
X2143 4565 4557 4593 2 1 XOR2HS $T=817160 457520 1 0 $X=817160 $Y=452100
X2144 4567 4566 4594 2 1 XOR2HS $T=817160 497840 1 0 $X=817160 $Y=492420
X2145 4587 4586 4535 2 1 XOR2HS $T=817780 397040 0 0 $X=817780 $Y=396660
X2146 4579 4580 4553 2 1 XOR2HS $T=818400 366800 1 0 $X=818400 $Y=361380
X2147 4576 4589 4542 2 1 XOR2HS $T=819020 386960 1 0 $X=819020 $Y=381540
X2148 4573 4584 4615 2 1 XOR2HS $T=821500 487760 1 0 $X=821500 $Y=482340
X2149 4595 4588 4599 2 1 XOR2HS $T=822740 477680 0 0 $X=822740 $Y=477300
X2150 4611 4607 4624 2 1 XOR2HS $T=823980 447440 1 0 $X=823980 $Y=442020
X2151 4631 4644 4629 2 1 XOR2HS $T=832660 386960 1 180 $X=827080 $Y=386580
X2152 4617 4616 4633 2 1 XOR2HS $T=827080 417200 0 0 $X=827080 $Y=416820
X2153 4608 4602 4646 2 1 XOR2HS $T=827700 497840 1 0 $X=827700 $Y=492420
X2154 4632 4639 4666 2 1 XOR2HS $T=831420 427280 0 0 $X=831420 $Y=426900
X2155 4620 4668 4681 2 1 XOR2HS $T=833900 386960 1 0 $X=833900 $Y=381540
X2156 4618 4646 935 2 1 XOR2HS $T=834520 497840 0 0 $X=834520 $Y=497460
X2157 4677 4663 4689 2 1 XOR2HS $T=835760 467600 0 0 $X=835760 $Y=467220
X2158 915 4653 4698 2 1 XOR2HS $T=837620 518000 1 0 $X=837620 $Y=512580
X2159 4659 4688 4711 2 1 XOR2HS $T=840100 397040 1 0 $X=840100 $Y=391620
X2160 4524 4692 4697 2 1 XOR2HS $T=840720 427280 0 0 $X=840720 $Y=426900
X2161 4698 4689 4721 2 1 XOR2HS $T=841340 507920 1 0 $X=841340 $Y=502500
X2162 4754 4750 4773 2 1 XOR2HS $T=851260 447440 1 0 $X=851260 $Y=442020
X2163 4757 4724 4779 2 1 XOR2HS $T=852500 397040 1 0 $X=852500 $Y=391620
X2164 126 45 127 130 1 2 MAO222P $T=254820 518000 0 0 $X=254820 $Y=517620
X2165 1553 1394 1562 1585 1 2 MAO222P $T=257920 487760 1 0 $X=257920 $Y=482340
X2166 1582 1452 1578 1587 1 2 MAO222P $T=261640 427280 0 0 $X=261640 $Y=426900
X2167 1408 1587 1584 1595 1 2 MAO222P $T=262880 437360 1 0 $X=262880 $Y=431940
X2168 1645 1517 1633 1582 1 2 MAO222P $T=273420 417200 0 0 $X=273420 $Y=416820
X2169 326 324 2105 2121 1 2 MAO222P $T=365800 326480 0 0 $X=365800 $Y=326100
X2170 2121 2090 2102 2171 1 2 MAO222P $T=365800 356720 0 0 $X=365800 $Y=356340
X2171 2116 2064 2072 2143 1 2 MAO222P $T=366420 427280 0 0 $X=366420 $Y=426900
X2172 2112 2057 2067 2129 1 2 MAO222P $T=367660 417200 1 0 $X=367660 $Y=411780
X2173 2129 2127 2133 2116 1 2 MAO222P $T=367660 427280 1 0 $X=367660 $Y=421860
X2174 2152 2138 1676 2175 1 2 MAO222P $T=370760 497840 0 0 $X=370760 $Y=497460
X2175 2159 2153 2163 330 1 2 MAO222P $T=371380 507920 0 0 $X=371380 $Y=507540
X2176 2125 2081 2086 2197 1 2 MAO222P $T=372000 366800 1 0 $X=372000 $Y=361380
X2177 330 329 331 334 1 2 MAO222P $T=372000 518000 0 0 $X=372000 $Y=517620
X2178 335 2173 2176 2110 1 2 MAO222P $T=375720 336560 1 0 $X=375720 $Y=331140
X2179 2143 2206 2209 2220 1 2 MAO222P $T=384400 427280 0 0 $X=384400 $Y=426900
X2180 2198 2155 2162 2248 1 2 MAO222P $T=385020 417200 0 0 $X=385020 $Y=416820
X2181 2242 2135 2238 2158 1 2 MAO222P $T=388740 497840 0 0 $X=388740 $Y=497460
X2182 2322 2305 2312 2378 1 2 MAO222P $T=404240 447440 0 0 $X=404240 $Y=447060
X2183 2341 2387 2391 2446 1 2 MAO222P $T=430900 447440 0 0 $X=430900 $Y=447060
X2184 3117 3050 3059 3198 1 2 MAO222P $T=553660 397040 1 0 $X=553660 $Y=391620
X2185 3186 3180 2894 3238 1 2 MAO222P $T=562340 487760 0 0 $X=562340 $Y=487380
X2186 3208 3199 2916 3224 1 2 MAO222P $T=565440 447440 1 0 $X=565440 $Y=442020
X2187 637 618 494 3210 1 2 MAO222P $T=569160 507920 1 0 $X=569160 $Y=502500
X2188 3238 3176 2872 637 1 2 MAO222P $T=573500 497840 1 0 $X=573500 $Y=492420
X2189 3284 3198 3279 3346 1 2 MAO222P $T=581560 386960 1 0 $X=581560 $Y=381540
X2190 3386 3377 3392 3399 1 2 MAO222P $T=597060 407120 0 0 $X=597060 $Y=406740
X2191 3548 3546 3545 3567 1 2 MAO222P $T=626200 437360 0 0 $X=626200 $Y=436980
X2192 3490 3565 3235 3585 1 2 MAO222P $T=629300 407120 1 0 $X=629300 $Y=401700
X2193 3599 3591 3215 3628 1 2 MAO222P $T=633640 447440 0 0 $X=633640 $Y=447060
X2194 3616 3233 3621 745 1 2 MAO222P $T=636740 497840 0 0 $X=636740 $Y=497460
X2195 3674 3648 3651 3723 1 2 MAO222P $T=658440 346640 1 0 $X=658440 $Y=341220
X2196 765 3692 3695 3674 1 2 MAO222P $T=660300 326480 1 0 $X=660300 $Y=321060
X2197 3724 3702 3716 3750 1 2 MAO222P $T=662780 386960 1 0 $X=662780 $Y=381540
X2198 3725 3766 3769 3788 1 2 MAO222P $T=672080 437360 1 0 $X=672080 $Y=431940
X2199 4079 4071 4083 4080 1 2 MAO222P $T=722920 356720 0 0 $X=722920 $Y=356340
X2200 4080 4062 4072 4000 1 2 MAO222P $T=722920 366800 1 0 $X=722920 $Y=361380
X2201 4000 3937 3951 4124 1 2 MAO222P $T=722920 376880 1 0 $X=722920 $Y=371460
X2202 4088 4084 4094 4095 1 2 MAO222P $T=724160 397040 0 0 $X=724160 $Y=396660
X2203 4774 4571 4782 4715 1 2 MAO222P $T=853120 487760 1 0 $X=853120 $Y=482340
X2204 1538 1556 1547 1526 1 2 ND3P $T=256060 447440 0 0 $X=256060 $Y=447060
X2205 1601 1568 1598 1618 1 2 ND3P $T=266600 507920 1 0 $X=266600 $Y=502500
X2206 2101 2050 2094 2111 1 2 ND3P $T=361460 356720 1 0 $X=361460 $Y=351300
X2207 2172 2112 2164 2161 1 2 ND3P $T=378200 407120 1 180 $X=373240 $Y=406740
X2208 2178 2193 2188 2189 1 2 ND3P $T=376960 487760 1 0 $X=376960 $Y=482340
X2209 2195 2154 2182 2187 1 2 ND3P $T=384400 346640 1 180 $X=379440 $Y=346260
X2210 2207 2125 2196 2217 1 2 ND3P $T=383160 356720 1 0 $X=383160 $Y=351300
X2211 2265 2264 2254 2230 1 2 ND3P $T=401140 518000 0 180 $X=396180 $Y=512580
X2212 2299 2322 2309 2313 1 2 ND3P $T=401760 467600 0 0 $X=401760 $Y=467220
X2213 2457 2492 2436 2470 1 2 ND3P $T=432140 437360 0 0 $X=432140 $Y=436980
X2214 2461 2494 2503 2536 1 2 ND3P $T=441440 447440 0 0 $X=441440 $Y=447060
X2215 3033 3075 3040 3037 1 2 ND3P $T=540640 407120 1 0 $X=540640 $Y=401700
X2216 3095 3155 3094 3078 1 2 ND3P $T=550560 417200 1 0 $X=550560 $Y=411780
X2217 3205 628 3193 3217 1 2 ND3P $T=565440 518000 1 0 $X=565440 $Y=512580
X2218 3219 3181 3227 3209 1 2 ND3P $T=572880 467600 0 180 $X=567920 $Y=462180
X2219 3389 3406 3371 3363 1 2 ND3P $T=597680 397040 1 0 $X=597680 $Y=391620
X2220 3543 3564 3556 3525 1 2 ND3P $T=626200 407120 0 0 $X=626200 $Y=406740
X2221 3560 724 3553 3549 1 2 ND3P $T=632400 518000 0 180 $X=627440 $Y=512580
X2222 3559 3574 3554 3570 1 2 ND3P $T=628060 417200 0 0 $X=628060 $Y=416820
X2223 3578 3548 3593 3552 1 2 ND3P $T=631780 437360 1 0 $X=631780 $Y=431940
X2224 3595 3609 3588 3602 1 2 ND3P $T=632400 477680 1 0 $X=632400 $Y=472260
X2225 3627 3599 3633 3632 1 2 ND3P $T=639220 437360 0 0 $X=639220 $Y=436980
X2226 3638 748 3636 3645 1 2 ND3P $T=641700 518000 1 0 $X=641700 $Y=512580
X2227 3667 3687 3676 3686 1 2 ND3P $T=654100 397040 1 0 $X=654100 $Y=391620
X2228 3770 3782 3777 3795 1 2 ND3P $T=674560 336560 0 0 $X=674560 $Y=336180
X2229 3841 3800 3839 3852 1 2 ND3P $T=683860 507920 0 0 $X=683860 $Y=507540
X2230 3990 4009 3989 3970 1 2 ND3P $T=711140 437360 1 0 $X=711140 $Y=431940
X2231 4103 4088 4117 4091 1 2 ND3P $T=730980 386960 1 180 $X=726020 $Y=386580
X2232 4271 845 860 4279 1 2 ND3P $T=758260 518000 0 0 $X=758260 $Y=517620
X2233 4682 4618 4693 4674 1 2 ND3P $T=840100 497840 0 180 $X=835140 $Y=492420
X2234 1382 1404 32 1 2 ND2 $T=232500 427280 0 0 $X=232500 $Y=426900
X2235 75 1411 24 1 2 ND2 $T=238700 376880 1 180 $X=236840 $Y=376500
X2236 62 1374 1344 1 2 ND2 $T=241800 447440 0 0 $X=241800 $Y=447060
X2237 85 1326 89 1 2 ND2 $T=243040 346640 1 0 $X=243040 $Y=341220
X2238 60 1426 93 1 2 ND2 $T=243660 386960 1 0 $X=243660 $Y=381540
X2239 85 1446 17 1 2 ND2 $T=245520 336560 1 0 $X=245520 $Y=331140
X2240 100 1465 58 1 2 ND2 $T=248000 346640 1 180 $X=246140 $Y=346260
X2241 1467 1418 1482 1 2 ND2 $T=248000 336560 1 0 $X=248000 $Y=331140
X2242 1486 1420 1508 1 2 ND2 $T=251720 467600 0 0 $X=251720 $Y=467220
X2243 1487 1526 1427 1 2 ND2 $T=254200 447440 0 180 $X=252340 $Y=442020
X2244 1506 121 1516 1 2 ND2 $T=253580 356720 0 0 $X=253580 $Y=356340
X2245 1521 76 70 1 2 ND2 $T=256680 346640 0 180 $X=254820 $Y=341220
X2246 21 1551 124 1 2 ND2 $T=257300 326480 1 180 $X=255440 $Y=326100
X2247 1504 125 1380 1 2 ND2 $T=257300 336560 0 180 $X=255440 $Y=331140
X2248 122 1525 41 1 2 ND2 $T=257300 376880 0 180 $X=255440 $Y=371460
X2249 1496 1529 90 1 2 ND2 $T=257920 386960 0 180 $X=256060 $Y=381540
X2250 1514 1538 1487 1 2 ND2 $T=257300 447440 1 0 $X=257300 $Y=442020
X2251 1515 1539 1479 1 2 ND2 $T=259160 457520 0 180 $X=257300 $Y=452100
X2252 1448 1552 44 1 2 ND2 $T=259160 356720 0 0 $X=259160 $Y=356340
X2253 30 1561 1482 1 2 ND2 $T=261020 376880 0 180 $X=259160 $Y=371460
X2254 1514 1547 1427 1 2 ND2 $T=259160 447440 1 0 $X=259160 $Y=442020
X2255 1556 1564 1479 1 2 ND2 $T=259780 457520 1 0 $X=259780 $Y=452100
X2256 9 1570 1482 1 2 ND2 $T=262260 346640 0 180 $X=260400 $Y=341220
X2257 1566 1320 41 1 2 ND2 $T=262260 326480 0 0 $X=262260 $Y=326100
X2258 1585 1601 1397 1 2 ND2 $T=263500 497840 1 0 $X=263500 $Y=492420
X2259 104 1608 80 1 2 ND2 $T=265980 336560 0 180 $X=264120 $Y=331140
X2260 1556 1583 1515 1 2 ND2 $T=264120 457520 1 0 $X=264120 $Y=452100
X2261 1585 1598 1565 1 2 ND2 $T=265980 507920 0 180 $X=264120 $Y=502500
X2262 1595 1576 1413 1 2 ND2 $T=265360 447440 1 0 $X=265360 $Y=442020
X2263 1565 1618 1397 1 2 ND2 $T=269080 497840 0 180 $X=267220 $Y=492420
X2264 1595 1557 1614 1 2 ND2 $T=270940 447440 0 180 $X=269080 $Y=442020
X2265 1614 1624 1413 1 2 ND2 $T=270940 447440 1 0 $X=270940 $Y=442020
X2266 1637 1589 1470 1 2 ND2 $T=274040 386960 0 180 $X=272180 $Y=381540
X2267 1647 1563 24 1 2 ND2 $T=274660 326480 1 0 $X=274660 $Y=321060
X2268 1730 1470 1722 1 2 ND2 $T=289540 376880 0 180 $X=287680 $Y=371460
X2269 1555 1735 1494 1 2 ND2 $T=291400 397040 1 180 $X=289540 $Y=396660
X2270 1623 1757 1496 1 2 ND2 $T=295120 366800 1 180 $X=293260 $Y=366420
X2271 1783 1391 1722 1 2 ND2 $T=298220 376880 0 180 $X=296360 $Y=371460
X2272 1775 1745 1780 1 2 ND2 $T=296360 457520 0 0 $X=296360 $Y=457140
X2273 1637 1786 1687 1 2 ND2 $T=300700 376880 1 0 $X=300700 $Y=371460
X2274 1783 1555 1806 1 2 ND2 $T=303180 386960 1 0 $X=303180 $Y=381540
X2275 1811 90 1722 1 2 ND2 $T=305040 376880 0 0 $X=305040 $Y=376500
X2276 1811 1637 1806 1 2 ND2 $T=305040 386960 1 0 $X=305040 $Y=381540
X2277 1819 1687 1806 1 2 ND2 $T=306900 376880 0 0 $X=306900 $Y=376500
X2278 1819 1716 1722 1 2 ND2 $T=306900 386960 0 0 $X=306900 $Y=386580
X2279 1603 1467 1831 1 2 ND2 $T=308140 376880 1 0 $X=308140 $Y=371460
X2280 35 1767 124 1 2 ND2 $T=310000 346640 0 0 $X=310000 $Y=346260
X2281 1832 1505 1722 1 2 ND2 $T=310000 376880 1 0 $X=310000 $Y=371460
X2282 1833 1813 1808 1 2 ND2 $T=310000 457520 0 0 $X=310000 $Y=457140
X2283 188 1814 1691 1 2 ND2 $T=310620 397040 1 0 $X=310620 $Y=391620
X2284 1834 104 243 1 2 ND2 $T=311240 356720 1 0 $X=311240 $Y=351300
X2285 1834 124 1846 1 2 ND2 $T=313100 346640 1 0 $X=313100 $Y=341220
X2286 1852 108 243 1 2 ND2 $T=314960 356720 0 180 $X=313100 $Y=351300
X2287 1838 24 243 1 2 ND2 $T=313720 336560 1 0 $X=313720 $Y=331140
X2288 1838 23 1846 1 2 ND2 $T=313720 346640 0 0 $X=313720 $Y=346260
X2289 1838 186 1851 1 2 ND2 $T=314960 346640 1 0 $X=314960 $Y=341220
X2290 1851 31 1852 1 2 ND2 $T=315580 356720 1 0 $X=315580 $Y=351300
X2291 1854 14 1851 1 2 ND2 $T=316820 346640 0 0 $X=316820 $Y=346260
X2292 1599 1837 22 1 2 ND2 $T=316820 366800 1 0 $X=316820 $Y=361380
X2293 1846 1627 1854 1 2 ND2 $T=318060 346640 1 0 $X=318060 $Y=341220
X2294 1846 21 1852 1 2 ND2 $T=318060 356720 1 0 $X=318060 $Y=351300
X2295 1861 1679 1722 1 2 ND2 $T=318060 386960 1 0 $X=318060 $Y=381540
X2296 1868 22 1852 1 2 ND2 $T=321160 346640 1 180 $X=319300 $Y=346260
X2297 1861 1788 1806 1 2 ND2 $T=319920 386960 1 0 $X=319920 $Y=381540
X2298 234 1874 1691 1 2 ND2 $T=322400 356720 1 180 $X=320540 $Y=356340
X2299 1834 52 1868 1 2 ND2 $T=321780 346640 1 0 $X=321780 $Y=341220
X2300 1838 44 1868 1 2 ND2 $T=323640 336560 0 0 $X=323640 $Y=336180
X2301 1834 35 1851 1 2 ND2 $T=323640 346640 0 0 $X=323640 $Y=346260
X2302 260 1357 1905 1 2 ND2 $T=323640 356720 0 0 $X=323640 $Y=356340
X2303 1854 1369 243 1 2 ND2 $T=326740 346640 0 0 $X=326740 $Y=346260
X2304 1900 1903 1894 1 2 ND2 $T=328600 497840 1 180 $X=326740 $Y=497460
X2305 1868 80 1854 1 2 ND2 $T=332320 346640 0 0 $X=332320 $Y=346260
X2306 275 1871 299 1 2 ND2 $T=341620 487760 1 0 $X=341620 $Y=482340
X2307 311 1948 280 1 2 ND2 $T=345960 336560 0 180 $X=344100 $Y=331140
X2308 1969 1710 287 1 2 ND2 $T=344100 366800 0 0 $X=344100 $Y=366420
X2309 1969 1782 306 1 2 ND2 $T=344100 376880 1 0 $X=344100 $Y=371460
X2310 268 1961 304 1 2 ND2 $T=347200 376880 1 0 $X=347200 $Y=371460
X2311 1904 2004 2011 1 2 ND2 $T=347820 346640 1 0 $X=347820 $Y=341220
X2312 272 2011 283 1 2 ND2 $T=350920 346640 1 0 $X=350920 $Y=341220
X2313 2080 2101 2106 1 2 ND2 $T=360840 356720 0 0 $X=360840 $Y=356340
X2314 2080 2094 2103 1 2 ND2 $T=362080 346640 0 0 $X=362080 $Y=346260
X2315 2074 2099 2104 1 2 ND2 $T=362700 386960 0 0 $X=362700 $Y=386580
X2316 2074 2109 2126 1 2 ND2 $T=364560 386960 0 0 $X=364560 $Y=386580
X2317 2104 2120 2126 1 2 ND2 $T=367660 397040 1 0 $X=367660 $Y=391620
X2318 2149 2144 2142 1 2 ND2 $T=373240 376880 1 180 $X=371380 $Y=376500
X2319 2171 2183 2149 1 2 ND2 $T=376340 366800 1 180 $X=374480 $Y=366420
X2320 2171 2177 2142 1 2 ND2 $T=376340 376880 1 180 $X=374480 $Y=376500
X2321 2110 2182 2167 1 2 ND2 $T=378200 346640 1 180 $X=376340 $Y=346260
X2322 2181 2178 2137 1 2 ND2 $T=378200 477680 1 180 $X=376340 $Y=477300
X2323 2181 2188 2147 1 2 ND2 $T=378200 477680 0 0 $X=378200 $Y=477300
X2324 2179 2161 2190 1 2 ND2 $T=379440 407120 0 0 $X=379440 $Y=406740
X2325 2110 2195 2156 1 2 ND2 $T=381920 346640 0 180 $X=380060 $Y=341220
X2326 2154 2196 2184 1 2 ND2 $T=383160 356720 0 180 $X=381300 $Y=351300
X2327 2154 2207 2186 1 2 ND2 $T=383160 356720 1 180 $X=381300 $Y=356340
X2328 2156 2187 2167 1 2 ND2 $T=383160 346640 1 0 $X=383160 $Y=341220
X2329 2147 2189 2137 1 2 ND2 $T=383160 487760 1 0 $X=383160 $Y=482340
X2330 2186 2217 2184 1 2 ND2 $T=389980 356720 0 180 $X=388120 $Y=351300
X2331 2221 2230 1656 1 2 ND2 $T=389980 518000 0 180 $X=388120 $Y=512580
X2332 342 2246 341 1 2 ND2 $T=389980 518000 1 180 $X=388120 $Y=517620
X2333 2175 2265 2221 1 2 ND2 $T=395560 518000 0 180 $X=393700 $Y=512580
X2334 2264 2253 342 1 2 ND2 $T=395560 518000 1 180 $X=393700 $Y=517620
X2335 2264 2258 341 1 2 ND2 $T=395560 518000 0 0 $X=395560 $Y=517620
X2336 2240 2278 2235 1 2 ND2 $T=398660 457520 1 0 $X=398660 $Y=452100
X2337 2248 2318 2286 1 2 ND2 $T=403620 427280 1 180 $X=401760 $Y=426900
X2338 2245 2296 2240 1 2 ND2 $T=403620 457520 0 180 $X=401760 $Y=452100
X2339 2245 2288 2235 1 2 ND2 $T=403620 457520 0 0 $X=403620 $Y=457140
X2340 2248 2349 2280 1 2 ND2 $T=407340 427280 0 0 $X=407340 $Y=426900
X2341 2344 2313 2323 1 2 ND2 $T=410440 467600 1 0 $X=410440 $Y=462180
X2342 2407 2470 2398 1 2 ND2 $T=439580 437360 0 0 $X=439580 $Y=436980
X2343 2520 2516 2531 1 2 ND2 $T=444540 457520 0 0 $X=444540 $Y=457140
X2344 2438 2507 2531 1 2 ND2 $T=448260 457520 1 180 $X=446400 $Y=457140
X2345 2438 2512 2520 1 2 ND2 $T=450120 457520 1 180 $X=448260 $Y=457140
X2346 2471 2536 2439 1 2 ND2 $T=448880 447440 0 0 $X=448880 $Y=447060
X2347 2747 2745 2735 1 2 ND2 $T=488560 437360 1 180 $X=486700 $Y=436980
X2348 2960 2969 2946 1 2 ND2 $T=526380 427280 1 180 $X=524520 $Y=426900
X2349 2946 2934 2960 1 2 ND2 $T=524520 437360 1 0 $X=524520 $Y=431940
X2350 2934 2982 2878 1 2 ND2 $T=531960 447440 1 180 $X=530100 $Y=447060
X2351 555 3005 539 1 2 ND2 $T=534440 346640 0 0 $X=534440 $Y=346260
X2352 545 2996 520 1 2 ND2 $T=535060 366800 1 0 $X=535060 $Y=361380
X2353 2891 3033 2948 1 2 ND2 $T=536300 397040 0 0 $X=536300 $Y=396660
X2354 2948 3037 3018 1 2 ND2 $T=536300 407120 1 0 $X=536300 $Y=401700
X2355 2891 3040 3018 1 2 ND2 $T=541260 397040 1 180 $X=539400 $Y=396660
X2356 550 580 578 1 2 ND2 $T=543740 326480 1 180 $X=541880 $Y=326100
X2357 2937 3078 3091 1 2 ND2 $T=544980 407120 0 0 $X=544980 $Y=406740
X2358 3075 3094 3091 1 2 ND2 $T=548700 407120 1 180 $X=546840 $Y=406740
X2359 3075 3095 2937 1 2 ND2 $T=548700 417200 1 180 $X=546840 $Y=416820
X2360 3102 589 3115 1 2 ND2 $T=548080 326480 0 0 $X=548080 $Y=326100
X2361 613 3151 513 1 2 ND2 $T=558000 326480 1 180 $X=556140 $Y=326100
X2362 612 3065 3171 1 2 ND2 $T=556760 366800 0 0 $X=556760 $Y=366420
X2363 3159 3130 3140 1 2 ND2 $T=560480 356720 0 0 $X=560480 $Y=356340
X2364 3056 3195 3074 1 2 ND2 $T=564820 366800 1 180 $X=562960 $Y=366420
X2365 3000 3190 548 1 2 ND2 $T=565440 336560 1 180 $X=563580 $Y=336180
X2366 2920 3209 3201 1 2 ND2 $T=563580 467600 1 0 $X=563580 $Y=462180
X2367 3140 3197 558 1 2 ND2 $T=565440 346640 0 0 $X=565440 $Y=346260
X2368 628 626 621 1 2 ND2 $T=565440 518000 0 0 $X=565440 $Y=517620
X2369 516 3200 578 1 2 ND2 $T=566680 336560 1 0 $X=566680 $Y=331140
X2370 3210 3205 3211 1 2 ND2 $T=567300 507920 0 0 $X=567300 $Y=507540
X2371 3224 3219 2920 1 2 ND2 $T=571020 457520 1 180 $X=569160 $Y=457140
X2372 3169 3253 638 1 2 ND2 $T=579080 356720 1 0 $X=579080 $Y=351300
X2373 3274 2942 3297 1 2 ND2 $T=580940 376880 1 0 $X=580940 $Y=371460
X2374 3301 3147 3297 1 2 ND2 $T=584040 376880 1 0 $X=584040 $Y=371460
X2375 3307 638 3297 1 2 ND2 $T=585280 366800 1 0 $X=585280 $Y=361380
X2376 3310 3097 3297 1 2 ND2 $T=585900 356720 0 0 $X=585900 $Y=356340
X2377 3169 3320 3070 1 2 ND2 $T=587760 376880 1 0 $X=587760 $Y=371460
X2378 3301 3070 676 1 2 ND2 $T=590860 376880 1 0 $X=590860 $Y=371460
X2379 3357 558 3297 1 2 ND2 $T=594580 366800 1 0 $X=594580 $Y=361380
X2380 517 3355 656 1 2 ND2 $T=595820 336560 1 0 $X=595820 $Y=331140
X2381 3357 3169 676 1 2 ND2 $T=595820 366800 0 0 $X=595820 $Y=366420
X2382 3277 3363 3265 1 2 ND2 $T=595820 397040 1 0 $X=595820 $Y=391620
X2383 3272 3371 3277 1 2 ND2 $T=597680 397040 1 180 $X=595820 $Y=396660
X2384 3274 3056 676 1 2 ND2 $T=597680 376880 1 0 $X=597680 $Y=371460
X2385 3272 3389 3265 1 2 ND2 $T=599540 386960 1 180 $X=597680 $Y=386580
X2386 3275 3360 521 1 2 ND2 $T=599540 346640 1 0 $X=599540 $Y=341220
X2387 3300 547 3395 1 2 ND2 $T=599540 356720 0 0 $X=599540 $Y=356340
X2388 3402 3131 3297 1 2 ND2 $T=603260 376880 0 180 $X=601400 $Y=371460
X2389 3398 3409 3380 1 2 ND2 $T=602640 397040 1 0 $X=602640 $Y=391620
X2390 3402 3289 676 1 2 ND2 $T=604500 376880 1 0 $X=604500 $Y=371460
X2391 3427 554 3439 1 2 ND2 $T=607600 336560 1 0 $X=607600 $Y=331140
X2392 690 563 691 1 2 ND2 $T=608220 326480 1 0 $X=608220 $Y=321060
X2393 3427 539 691 1 2 ND2 $T=608220 326480 0 0 $X=608220 $Y=326100
X2394 696 521 3433 1 2 ND2 $T=610080 346640 0 180 $X=608220 $Y=341220
X2395 3406 3417 3380 1 2 ND2 $T=608220 397040 1 0 $X=608220 $Y=391620
X2396 3398 3423 3406 1 2 ND2 $T=608220 397040 0 0 $X=608220 $Y=396660
X2397 699 532 3433 1 2 ND2 $T=611940 336560 0 180 $X=610080 $Y=331140
X2398 3439 511 3433 1 2 ND2 $T=610080 336560 0 0 $X=610080 $Y=336180
X2399 3433 569 691 1 2 ND2 $T=610080 346640 0 0 $X=610080 $Y=346260
X2400 3427 514 699 1 2 ND2 $T=611320 326480 0 0 $X=611320 $Y=326100
X2401 699 622 3463 1 2 ND2 $T=612560 336560 1 0 $X=612560 $Y=331140
X2402 3427 548 696 1 2 ND2 $T=613180 326480 0 0 $X=613180 $Y=326100
X2403 3463 533 691 1 2 ND2 $T=613180 336560 0 0 $X=613180 $Y=336180
X2404 696 606 3463 1 2 ND2 $T=615040 326480 1 0 $X=615040 $Y=321060
X2405 703 2999 3476 1 2 ND2 $T=616900 346640 0 180 $X=615040 $Y=341220
X2406 3463 518 3439 1 2 ND2 $T=616280 326480 0 0 $X=616280 $Y=326100
X2407 671 3453 3171 1 2 ND2 $T=616280 366800 1 0 $X=616280 $Y=361380
X2408 690 517 3439 1 2 ND2 $T=620000 326480 0 0 $X=620000 $Y=326100
X2409 3449 3525 3458 1 2 ND2 $T=621860 407120 1 180 $X=620000 $Y=406740
X2410 3399 3543 3458 1 2 ND2 $T=623100 407120 0 0 $X=623100 $Y=406740
X2411 3536 3552 3531 1 2 ND2 $T=626820 427280 1 180 $X=624960 $Y=426900
X2412 718 571 726 1 2 ND2 $T=626820 336560 1 0 $X=626820 $Y=331140
X2413 724 725 721 1 2 ND2 $T=626820 518000 0 0 $X=626820 $Y=517620
X2414 3564 3554 3547 1 2 ND2 $T=629920 417200 1 0 $X=629920 $Y=411780
X2415 3574 3578 3536 1 2 ND2 $T=631780 427280 1 180 $X=629920 $Y=426900
X2416 722 3584 3597 1 2 ND2 $T=633020 336560 0 0 $X=633020 $Y=336180
X2417 3564 3559 3582 1 2 ND2 $T=634880 417200 1 180 $X=633020 $Y=416820
X2418 3574 3593 3531 1 2 ND2 $T=633640 427280 0 0 $X=633640 $Y=426900
X2419 3606 3560 735 1 2 ND2 $T=636740 507920 1 180 $X=634880 $Y=507540
X2420 3582 3570 3547 1 2 ND2 $T=635500 417200 1 0 $X=635500 $Y=411780
X2421 3596 3595 3266 1 2 ND2 $T=635500 477680 0 0 $X=635500 $Y=477300
X2422 3604 3326 727 1 2 ND2 $T=636120 336560 1 0 $X=636120 $Y=331140
X2423 3604 3379 741 1 2 ND2 $T=636740 336560 0 0 $X=636740 $Y=336180
X2424 740 3508 710 1 2 ND2 $T=636740 346640 0 0 $X=636740 $Y=346260
X2425 3579 3549 735 1 2 ND2 $T=636740 518000 0 0 $X=636740 $Y=517620
X2426 3587 3602 3266 1 2 ND2 $T=637360 477680 1 0 $X=637360 $Y=472260
X2427 692 3520 736 1 2 ND2 $T=638600 366800 0 0 $X=638600 $Y=366420
X2428 726 3597 283 1 2 ND2 $T=639220 336560 0 0 $X=639220 $Y=336180
X2429 3243 3632 3601 1 2 ND2 $T=641080 437360 0 180 $X=639220 $Y=431940
X2430 744 705 746 1 2 ND2 $T=641700 326480 1 0 $X=641700 $Y=321060
X2431 745 3636 747 1 2 ND2 $T=642320 518000 0 0 $X=642320 $Y=517620
X2432 3585 3627 3601 1 2 ND2 $T=644800 437360 0 180 $X=642940 $Y=431940
X2433 745 3638 733 1 2 ND2 $T=643560 507920 1 0 $X=643560 $Y=502500
X2434 747 3645 733 1 2 ND2 $T=648520 518000 1 0 $X=648520 $Y=512580
X2435 3659 3667 3662 1 2 ND2 $T=651000 397040 1 0 $X=651000 $Y=391620
X2436 3684 3686 3662 1 2 ND2 $T=660920 386960 0 0 $X=660920 $Y=386580
X2437 3719 3712 3729 1 2 ND2 $T=664020 417200 0 0 $X=664020 $Y=416820
X2438 3709 3710 3705 1 2 ND2 $T=665880 407120 0 0 $X=665880 $Y=406740
X2439 3747 3770 3704 1 2 ND2 $T=670840 326480 0 0 $X=670840 $Y=326100
X2440 3747 3777 3771 1 2 ND2 $T=670840 336560 0 0 $X=670840 $Y=336180
X2441 3715 3755 3738 1 2 ND2 $T=673320 346640 0 0 $X=673320 $Y=346260
X2442 3782 3768 3738 1 2 ND2 $T=674560 346640 1 0 $X=674560 $Y=341220
X2443 3782 3759 3715 1 2 ND2 $T=675180 346640 0 0 $X=675180 $Y=346260
X2444 717 3809 728 1 2 ND2 $T=678280 467600 0 180 $X=676420 $Y=462180
X2445 3767 3789 3761 1 2 ND2 $T=677660 467600 0 0 $X=677660 $Y=467220
X2446 3771 3795 3823 1 2 ND2 $T=681380 336560 1 0 $X=681380 $Y=331140
X2447 3810 3812 3767 1 2 ND2 $T=681380 467600 0 0 $X=681380 $Y=467220
X2448 3810 3799 3761 1 2 ND2 $T=681380 477680 1 0 $X=681380 $Y=472260
X2449 3800 3831 3819 1 2 ND2 $T=685720 507920 0 180 $X=683860 $Y=502500
X2450 777 3839 3817 1 2 ND2 $T=686340 518000 0 180 $X=684480 $Y=512580
X2451 777 3841 3820 1 2 ND2 $T=686340 518000 1 180 $X=684480 $Y=517620
X2452 3800 3845 3816 1 2 ND2 $T=687580 507920 0 180 $X=685720 $Y=502500
X2453 786 784 3894 1 2 ND2 $T=689440 518000 0 0 $X=689440 $Y=517620
X2454 3894 794 793 1 2 ND2 $T=695640 507920 0 0 $X=695640 $Y=507540
X2455 3788 3990 3961 1 2 ND2 $T=710520 437360 0 180 $X=708660 $Y=431940
X2456 845 4197 4232 1 2 ND2 $T=751440 518000 1 0 $X=751440 $Y=512580
X2457 4240 4222 4232 1 2 ND2 $T=753920 507920 1 180 $X=752060 $Y=507540
X2458 845 4185 4240 1 2 ND2 $T=755780 518000 1 0 $X=755780 $Y=512580
X2459 4297 4271 864 1 2 ND2 $T=764460 518000 1 0 $X=764460 $Y=512580
X2460 867 4279 864 1 2 ND2 $T=770040 507920 1 180 $X=768180 $Y=507540
X2461 4359 4405 4424 1 2 ND2 $T=790500 477680 1 0 $X=790500 $Y=472260
X2462 4608 4612 4602 1 2 ND2 $T=824600 497840 1 180 $X=822740 $Y=497460
X2463 4618 4625 4608 1 2 ND2 $T=825840 497840 0 0 $X=825840 $Y=497460
X2464 4618 4648 4602 1 2 ND2 $T=830180 497840 1 180 $X=828320 $Y=497460
X2465 915 914 4653 1 2 ND2 $T=829560 518000 1 0 $X=829560 $Y=512580
X2466 919 918 4643 1 2 ND2 $T=832660 356720 0 180 $X=830800 $Y=351300
X2467 279 4635 4623 1 2 ND2 $T=830800 366800 1 0 $X=830800 $Y=361380
X2468 911 916 923 1 2 ND2 $T=832660 326480 0 0 $X=832660 $Y=326100
X2469 924 922 919 1 2 ND2 $T=834520 336560 0 180 $X=832660 $Y=331140
X2470 279 4664 270 1 2 ND2 $T=834520 366800 0 180 $X=832660 $Y=361380
X2471 911 925 4672 1 2 ND2 $T=833900 336560 0 0 $X=833900 $Y=336180
X2472 932 928 4672 1 2 ND2 $T=837620 326480 1 180 $X=835760 $Y=326100
X2473 908 930 4672 1 2 ND2 $T=838240 336560 0 180 $X=836380 $Y=331140
X2474 4672 929 4643 1 2 ND2 $T=836380 336560 0 0 $X=836380 $Y=336180
X2475 4654 931 923 1 2 ND2 $T=836380 346640 1 0 $X=836380 $Y=341220
X2476 4683 4674 4670 1 2 ND2 $T=838240 487760 0 180 $X=836380 $Y=482340
X2477 908 933 923 1 2 ND2 $T=837620 326480 1 0 $X=837620 $Y=321060
X2478 932 934 923 1 2 ND2 $T=839480 326480 1 180 $X=837620 $Y=326100
X2479 943 936 4662 1 2 ND2 $T=840720 346640 1 180 $X=838860 $Y=346260
X2480 943 937 4643 1 2 ND2 $T=840720 356720 0 180 $X=838860 $Y=351300
X2481 4654 941 919 1 2 ND2 $T=841340 326480 0 180 $X=839480 $Y=321060
X2482 923 942 4643 1 2 ND2 $T=841340 336560 0 180 $X=839480 $Y=331140
X2483 4662 4694 4672 1 2 ND2 $T=841340 336560 1 180 $X=839480 $Y=336180
X2484 4654 952 4672 1 2 ND2 $T=843200 346640 0 180 $X=841340 $Y=341220
X2485 924 946 4672 1 2 ND2 $T=843200 346640 1 180 $X=841340 $Y=346260
X2486 4654 949 943 1 2 ND2 $T=844440 336560 0 180 $X=842580 $Y=331140
X2487 943 950 4716 1 2 ND2 $T=843200 346640 0 0 $X=843200 $Y=346260
X2488 4710 4682 4670 1 2 ND2 $T=843200 497840 1 0 $X=843200 $Y=492420
X2489 4716 963 923 1 2 ND2 $T=846300 346640 0 180 $X=844440 $Y=341220
X2490 4716 956 4672 1 2 ND2 $T=846920 356720 0 180 $X=845060 $Y=351300
X2491 968 4727 962 1 2 ND2 $T=850020 336560 1 180 $X=848160 $Y=336180
X2492 4739 4692 4743 1 2 ND2 $T=848160 427280 0 0 $X=848160 $Y=426900
X2493 4678 4777 4657 1 2 ND2 $T=850020 467600 1 180 $X=848160 $Y=467220
X2494 923 958 4662 1 2 ND2 $T=849400 356720 1 0 $X=849400 $Y=351300
X2495 919 969 4662 1 2 ND2 $T=849400 356720 0 0 $X=849400 $Y=356340
X2496 919 982 4716 1 2 ND2 $T=851260 356720 1 0 $X=851260 $Y=351300
X2497 4765 4789 4665 1 2 ND2 $T=854980 356720 1 180 $X=853120 $Y=356340
X2498 4678 4768 4684 1 2 ND2 $T=854980 467600 0 180 $X=853120 $Y=462180
X2499 992 4769 954 1 2 ND2 $T=858700 326480 0 0 $X=858700 $Y=326100
X2500 4790 1003 4738 1 2 ND2 $T=863040 346640 1 0 $X=863040 $Y=341220
X2501 4812 4637 4817 1 2 ND2 $T=863040 356720 1 0 $X=863040 $Y=351300
X2502 4826 4709 4834 1 2 ND2 $T=867380 336560 1 0 $X=867380 $Y=331140
X2503 4826 961 4822 1 2 ND2 $T=871100 336560 1 180 $X=869240 $Y=336180
X2504 4790 1028 4843 1 2 ND2 $T=870480 346640 1 0 $X=870480 $Y=341220
X2505 4841 1018 4843 1 2 ND2 $T=871100 346640 0 0 $X=871100 $Y=346260
X2506 4841 1027 4738 1 2 ND2 $T=871720 336560 1 0 $X=871720 $Y=331140
X2507 4849 1013 4843 1 2 ND2 $T=875440 356720 0 180 $X=873580 $Y=351300
X2508 4849 1045 4738 1 2 ND2 $T=878540 336560 0 180 $X=876680 $Y=331140
X2509 4790 1047 4838 1 2 ND2 $T=877920 326480 0 0 $X=877920 $Y=326100
X2510 4843 4874 4766 1 2 ND2 $T=880400 376880 0 180 $X=878540 $Y=371460
X2511 4849 1054 4838 1 2 ND2 $T=880400 326480 0 0 $X=880400 $Y=326100
X2512 4766 4878 4838 1 2 ND2 $T=884120 366800 0 180 $X=882260 $Y=361380
X2513 4795 4880 938 1 2 ND2 $T=887220 366800 0 0 $X=887220 $Y=366420
X2514 1087 4760 1025 1 2 ND2 $T=897140 326480 0 0 $X=897140 $Y=326100
X2515 4872 4928 4882 1 2 ND2 $T=899000 376880 0 180 $X=897140 $Y=371460
X2516 1087 4956 961 1 2 ND2 $T=900860 326480 1 180 $X=899000 $Y=326100
X2517 4826 1090 4902 1 2 ND2 $T=899000 346640 1 0 $X=899000 $Y=341220
X2518 991 4949 4834 1 2 ND2 $T=902720 346640 1 180 $X=900860 $Y=346260
X2519 1026 4948 4902 1 2 ND2 $T=904580 346640 0 180 $X=902720 $Y=341220
X2520 4872 4968 4940 1 2 ND2 $T=906440 366800 1 180 $X=904580 $Y=366420
X2521 4960 4920 4968 1 2 ND2 $T=907680 356720 1 0 $X=907680 $Y=351300
X2522 1111 4961 961 1 2 ND2 $T=910780 346640 1 0 $X=910780 $Y=341220
X2523 1133 5021 1132 1 2 ND2 $T=926280 397040 0 0 $X=926280 $Y=396660
X2524 1133 5047 5036 1 2 ND2 $T=929380 407120 1 180 $X=927520 $Y=406740
X2525 5016 5032 1139 1 2 ND2 $T=929380 397040 0 0 $X=929380 $Y=396660
X2526 1140 5064 964 1 2 ND2 $T=933720 336560 1 0 $X=933720 $Y=331140
X2527 5016 5083 5081 1 2 ND2 $T=935580 397040 1 180 $X=933720 $Y=396660
X2528 1139 5101 1127 1 2 ND2 $T=936820 397040 0 180 $X=934960 $Y=391620
X2529 4840 4985 4694 1 2 ND2 $T=938060 336560 0 0 $X=938060 $Y=336180
X2530 1040 5110 1102 1 2 ND2 $T=938680 346640 1 0 $X=938680 $Y=341220
X2531 1151 5141 1132 1 2 ND2 $T=946740 407120 1 180 $X=944880 $Y=406740
X2532 1046 5181 1014 1 2 ND2 $T=954180 336560 1 0 $X=954180 $Y=331140
X2533 755 702 1 2 INV12CK $T=655960 407120 0 180 $X=646040 $Y=401700
X2534 1200 4786 1 2 INV12CK $T=978980 447440 0 180 $X=969060 $Y=442020
X2535 881 873 2 874 877 1 4297 FA1 $T=786160 518000 0 180 $X=770660 $Y=512580
X2536 3243 3601 3585 2 1 3655 XOR3S $T=636740 427280 1 0 $X=636740 $Y=421860
X2537 2806 2801 1 2 INV3 $T=495380 427280 0 0 $X=495380 $Y=426900
X2538 4460 885 1 2 INV3 $T=796080 326480 1 180 $X=793600 $Y=326100
X2539 1450 1379 1 2 INV2 $T=243660 487760 1 180 $X=241800 $Y=487380
X2540 1438 62 1 2 INV2 $T=242420 427280 1 0 $X=242420 $Y=421860
X2541 1481 1471 1 2 INV2 $T=250480 427280 0 0 $X=250480 $Y=426900
X2542 1510 1517 1 2 INV2 $T=253580 427280 1 0 $X=253580 $Y=421860
X2543 1632 1584 1 2 INV2 $T=272800 427280 0 0 $X=272800 $Y=426900
X2544 1678 1645 1 2 INV2 $T=279000 417200 0 0 $X=279000 $Y=416820
X2545 1693 1733 1 2 INV2 $T=289540 447440 0 0 $X=289540 $Y=447060
X2546 1807 253 1 2 INV2 $T=313100 417200 1 180 $X=311240 $Y=416820
X2547 1939 1942 1 2 INV2 $T=332320 477680 0 0 $X=332320 $Y=477300
X2548 1947 1972 1 2 INV2 $T=339140 477680 1 0 $X=339140 $Y=472260
X2549 1451 299 1 2 INV2 $T=341620 427280 1 0 $X=341620 $Y=421860
X2550 1952 2006 1 2 INV2 $T=345340 518000 1 0 $X=345340 $Y=512580
X2551 253 265 1 2 INV2 $T=353400 487760 1 0 $X=353400 $Y=482340
X2552 337 339 1 2 INV2 $T=390600 356720 1 0 $X=390600 $Y=351300
X2553 380 1869 1 2 INV2 $T=430280 477680 1 180 $X=428420 $Y=477300
X2554 2717 448 1 2 INV2 $T=482360 326480 0 180 $X=480500 $Y=321060
X2555 2675 2783 1 2 INV2 $T=502820 457520 0 0 $X=502820 $Y=457140
X2556 2857 2876 1 2 INV2 $T=510880 427280 1 0 $X=510880 $Y=421860
X2557 446 2968 1 2 INV2 $T=520800 427280 1 0 $X=520800 $Y=421860
X2558 2954 2963 1 2 INV2 $T=524520 417200 1 0 $X=524520 $Y=411780
X2559 2965 2972 1 2 INV2 $T=526380 417200 1 0 $X=526380 $Y=411780
X2560 2878 2933 1 2 INV2 $T=528860 447440 1 180 $X=527000 $Y=447060
X2561 2992 2995 1 2 INV2 $T=531340 407120 0 0 $X=531340 $Y=406740
X2562 3008 2948 1 2 INV2 $T=536300 407120 0 0 $X=536300 $Y=406740
X2563 2979 3055 1 2 INV2 $T=536920 417200 1 0 $X=536920 $Y=411780
X2564 3030 2993 1 2 INV2 $T=540020 427280 0 180 $X=538160 $Y=421860
X2565 3085 3092 1 2 INV2 $T=546220 437360 0 0 $X=546220 $Y=436980
X2566 3045 3107 1 2 INV2 $T=547460 427280 1 0 $X=547460 $Y=421860
X2567 3220 3207 1 2 INV2 $T=569780 417200 1 0 $X=569780 $Y=411780
X2568 3280 3314 1 2 INV2 $T=587760 417200 0 0 $X=587760 $Y=416820
X2569 3251 3348 1 2 INV2 $T=591480 447440 1 0 $X=591480 $Y=442020
X2570 3372 3347 1 2 INV2 $T=597680 397040 0 0 $X=597680 $Y=396660
X2571 3397 3284 1 2 INV2 $T=601400 386960 1 0 $X=601400 $Y=381540
X2572 3414 3416 1 2 INV2 $T=604500 437360 1 0 $X=604500 $Y=431940
X2573 3361 3429 1 2 INV2 $T=606360 447440 1 0 $X=606360 $Y=442020
X2574 3434 3390 1 2 INV2 $T=608220 427280 1 0 $X=608220 $Y=421860
X2575 3470 3449 1 2 INV2 $T=614420 417200 0 0 $X=614420 $Y=416820
X2576 676 710 1 2 INV2 $T=625580 376880 0 180 $X=623720 $Y=371460
X2577 419 650 1 2 INV2 $T=629920 437360 1 0 $X=629920 $Y=431940
X2578 3904 3943 1 2 INV2 $T=700600 417200 0 0 $X=700600 $Y=416820
X2579 839 4424 1 2 INV2 $T=788640 467600 0 0 $X=788640 $Y=467220
X2580 4382 4459 1 2 INV2 $T=790500 437360 1 0 $X=790500 $Y=431940
X2581 4443 4495 1 2 INV2 $T=802280 437360 0 0 $X=802280 $Y=436980
X2582 832 3879 1 2 INV2 $T=805380 487760 1 0 $X=805380 $Y=482340
X2583 4421 4443 1 2 INV2 $T=806000 437360 0 0 $X=806000 $Y=436980
X2584 4451 4540 1 2 INV2 $T=808480 437360 0 0 $X=808480 $Y=436980
X2585 4463 4479 1 2 INV2 $T=810340 437360 0 0 $X=810340 $Y=436980
X2586 4561 4578 1 2 INV2 $T=815920 467600 1 0 $X=815920 $Y=462180
X2587 4605 4641 1 2 INV2 $T=828320 467600 0 0 $X=828320 $Y=467220
X2588 4640 4652 1 2 INV2 $T=830800 467600 1 0 $X=830800 $Y=462180
X2589 4601 4679 1 2 INV2 $T=830800 477680 0 0 $X=830800 $Y=477300
X2590 4651 4657 1 2 INV2 $T=832040 457520 1 0 $X=832040 $Y=452100
X2591 4600 4661 1 2 INV2 $T=832660 447440 1 0 $X=832660 $Y=442020
X2592 4691 4702 1 2 INV2 $T=840720 437360 0 0 $X=840720 $Y=436980
X2593 4707 4718 1 2 INV2 $T=843200 376880 0 0 $X=843200 $Y=376500
X2594 4598 4722 1 2 INV2 $T=844440 447440 1 0 $X=844440 $Y=442020
X2595 875 4514 1 2 INV2 $T=849400 447440 0 0 $X=849400 $Y=447060
X2596 4825 1008 1 2 INV2 $T=864900 507920 0 180 $X=863040 $Y=502500
X2597 4830 1016 1 2 INV2 $T=868620 518000 1 180 $X=866760 $Y=517620
X2598 4734 4821 1 2 INV2 $T=871720 386960 0 0 $X=871720 $Y=386580
X2599 1399 1326 1384 2 49 1 1377 AN4B1S $T=235600 386960 0 180 $X=231260 $Y=381540
X2600 1407 1402 1356 2 1368 1 46 AN4B1S $T=237460 336560 1 180 $X=233120 $Y=336180
X2601 88 1446 1395 2 1439 1 81 AN4B1S $T=244900 336560 0 180 $X=240560 $Y=331140
X2602 1456 1423 1357 2 96 1 1473 AN4B1S $T=244280 376880 1 0 $X=244280 $Y=371460
X2603 1611 1602 1572 2 1592 1 1591 AN4B1S $T=269080 366800 0 180 $X=264740 $Y=361380
X2604 1625 1617 1402 2 151 1 1606 AN4B1S $T=272180 346640 1 180 $X=267840 $Y=346260
X2605 165 1642 163 2 1385 1 1629 AN4B1S $T=276520 346640 1 180 $X=272180 $Y=346260
X2606 1643 1631 1635 2 168 1 1611 AN4B1S $T=274660 366800 1 0 $X=274660 $Y=361380
X2607 179 1686 1684 2 167 1 1362 AN4B1S $T=283340 356720 1 180 $X=279000 $Y=356340
X2608 90 1691 1687 2 1702 1 1697 AN4B1S $T=280240 386960 0 0 $X=280240 $Y=386580
X2609 1774 1764 1731 2 203 1 1749 AN4B1S $T=296980 346640 0 180 $X=292640 $Y=341220
X2610 90 1520 1716 2 1765 1 1758 AN4B1S $T=292640 386960 0 0 $X=292640 $Y=386580
X2611 1577 1505 1555 2 1757 1 1809 AN4B1S $T=303180 366800 0 0 $X=303180 $Y=366420
X2612 21 31 1845 2 138 1 1867 AN4B1S $T=314960 356720 0 0 $X=314960 $Y=356340
X2613 1895 1788 1679 2 1831 1 1876 AN4B1S $T=326120 386960 0 180 $X=321780 $Y=381540
X2614 1924 274 1938 2 276 1 1925 AN4B1S $T=330460 336560 0 0 $X=330460 $Y=336180
X2615 2855 2842 488 2 487 1 482 AN4B1S $T=506540 326480 0 180 $X=502200 $Y=321060
X2616 497 495 2842 2 493 1 489 AN4B1S $T=512740 326480 0 180 $X=508400 $Y=321060
X2617 512 2918 2912 2 506 1 2887 AN4B1S $T=520800 346640 0 180 $X=516460 $Y=341220
X2618 2980 534 2966 2 531 1 2943 AN4B1S $T=529480 356720 1 180 $X=525140 $Y=356340
X2619 3021 3062 2999 2 581 1 3061 AN4B1S $T=541880 336560 0 0 $X=541880 $Y=336180
X2620 3121 599 3104 2 595 1 3086 AN4B1S $T=551800 346640 1 180 $X=547460 $Y=346260
X2621 3103 3097 3056 2 3130 1 3026 AN4B1S $T=550560 356720 0 0 $X=550560 $Y=356340
X2622 558 3142 3147 2 3206 1 3178 AN4B1S $T=564820 366800 1 0 $X=564820 $Y=361380
X2623 558 3171 3070 2 3226 1 3225 AN4B1S $T=569160 366800 1 0 $X=569160 $Y=361380
X2624 3258 3249 3163 2 3239 1 647 AN4B1S $T=579080 336560 0 180 $X=574740 $Y=331140
X2625 3270 3287 3285 2 660 1 3258 AN4B1S $T=580940 336560 1 0 $X=580940 $Y=331140
X2626 532 511 3385 2 649 1 3366 AN4B1S $T=601400 336560 1 180 $X=597060 $Y=336180
X2627 3448 3289 3131 2 3395 1 3422 AN4B1S $T=611320 376880 0 180 $X=606980 $Y=371460
X2628 3482 704 3492 2 706 1 3489 AN4B1S $T=615660 336560 0 0 $X=615660 $Y=336180
X2629 4704 945 4700 2 944 1 4699 AN4B1S $T=843820 326480 1 180 $X=839480 $Y=326100
X2630 957 953 4704 2 948 1 4647 AN4B1S $T=846300 326480 0 180 $X=841960 $Y=321060
X2631 4700 4769 4772 2 987 1 4797 AN4B1S $T=853120 326480 0 0 $X=853120 $Y=326100
X2632 1006 973 4802 2 998 1 4803 AN4B1S $T=863040 346640 0 180 $X=858700 $Y=341220
X2633 4836 4831 4827 2 4814 1 4817 AN4B1S $T=870480 356720 0 180 $X=866140 $Y=351300
X2634 4854 4855 4858 2 4861 1 4812 AN4B1S $T=874200 346640 1 0 $X=874200 $Y=341220
X2635 4864 913 999 2 4866 1 4888 AN4B1S $T=882260 356720 0 0 $X=882260 $Y=356340
X2636 4942 1093 4911 2 4935 1 4656 AN4B1S $T=903340 326480 0 180 $X=899000 $Y=321060
X2637 4948 946 4949 2 4962 1 1106 AN4B1S $T=903960 346640 0 0 $X=903960 $Y=346260
X2638 1114 1110 4970 2 1107 1 4813 AN4B1S $T=912020 326480 0 180 $X=907680 $Y=321060
X2639 4877 946 931 2 991 1 1120 AN4B1S $T=910160 346640 0 0 $X=910160 $Y=346260
X2640 4988 952 1120 2 4962 1 4824 AN4B1S $T=915120 346640 0 0 $X=915120 $Y=346260
X2641 1126 4996 986 2 5010 1 4999 AN4B1S $T=920080 356720 1 0 $X=920080 $Y=351300
X2642 1095 1138 5059 2 5010 1 5074 AN4B1S $T=929380 346640 0 0 $X=929380 $Y=346260
X2643 1126 5110 5068 2 5087 1 5120 AN4B1S $T=938060 346640 0 0 $X=938060 $Y=346260
X2644 1152 1153 5102 2 5111 1 5132 AN4B1S $T=940540 326480 1 0 $X=940540 $Y=321060
X2645 31 1297 22 19 2 1 1323 OA22 $T=230020 376880 0 180 $X=225680 $Y=371460
X2646 91 1448 34 23 2 1 1429 OA22 $T=244900 366800 1 180 $X=240560 $Y=366420
X2647 1482 108 104 48 2 1 1456 OA22 $T=251100 366800 1 180 $X=246760 $Y=366420
X2648 60 1505 44 1467 2 1 1516 OA22 $T=251100 376880 0 0 $X=251100 $Y=376500
X2649 108 34 1619 93 2 1 1617 OA22 $T=269700 376880 1 0 $X=269700 $Y=371460
X2650 1391 93 30 23 2 1 1684 OA22 $T=292020 356720 1 180 $X=287680 $Y=356340
X2651 1787 1744 200 1491 2 1 1625 OA22 $T=298840 376880 1 180 $X=294500 $Y=376500
X2652 60 1716 80 1482 2 1 213 OA22 $T=302560 346640 1 180 $X=298220 $Y=346260
X2653 60 1687 93 1555 2 1 1690 OA22 $T=300080 366800 1 0 $X=300080 $Y=361380
X2654 1926 1846 1842 272 2 1 1997 OA22 $T=340380 336560 0 0 $X=340380 $Y=336180
X2655 2942 520 516 514 2 1 2912 OA22 $T=523900 336560 1 180 $X=519560 $Y=336180
X2656 511 519 521 522 2 1 2956 OA22 $T=520800 326480 1 0 $X=520800 $Y=321060
X2657 543 3000 537 514 2 1 556 OA22 $T=531340 336560 0 0 $X=531340 $Y=336180
X2658 578 569 563 567 2 1 3021 OA22 $T=540640 336560 1 180 $X=536300 $Y=336180
X2659 569 537 3036 520 2 1 495 OA22 $T=541880 346640 1 180 $X=537540 $Y=346260
X2660 545 3070 520 3056 2 1 508 OA22 $T=546220 366800 0 180 $X=541880 $Y=361380
X2661 545 3097 548 547 2 1 3115 OA22 $T=546840 336560 0 0 $X=546840 $Y=336180
X2662 545 3147 606 578 2 1 600 OA22 $T=556140 326480 1 180 $X=551800 $Y=326100
X2663 3335 3331 654 568 2 1 497 OA22 $T=592100 346640 1 180 $X=587760 $Y=346260
X2664 3466 699 3345 726 2 1 3555 OA22 $T=627440 336560 0 0 $X=627440 $Y=336180
X2665 4720 952 929 4709 2 1 4704 OA22 $T=846300 336560 1 180 $X=841960 $Y=336180
X2666 1296 2 1303 1298 1 NR2 $T=220720 356720 0 0 $X=220720 $Y=356340
X2667 12 2 1335 1298 1 NR2 $T=223200 376880 1 180 $X=221340 $Y=376500
X2668 1325 2 1297 1298 1 NR2 $T=223820 376880 0 180 $X=221960 $Y=371460
X2669 1302 2 1346 1310 1 NR2 $T=225060 326480 1 0 $X=225060 $Y=321060
X2670 1302 2 27 1361 1 NR2 $T=228160 326480 1 0 $X=228160 $Y=321060
X2671 39 2 36 1380 1 NR2 $T=231260 326480 1 0 $X=231260 $Y=321060
X2672 1298 2 48 50 1 NR2 $T=231880 366800 1 0 $X=231880 $Y=361380
X2673 50 2 56 1398 1 NR2 $T=233740 326480 1 0 $X=233740 $Y=321060
X2674 1405 2 19 12 1 NR2 $T=236840 366800 0 180 $X=234980 $Y=361380
X2675 59 2 1400 1420 1 NR2 $T=236840 487760 0 0 $X=236840 $Y=487380
X2676 59 2 1421 1406 1 NR2 $T=240560 507920 0 180 $X=238700 $Y=502500
X2677 1444 2 75 1428 1 NR2 $T=241800 376880 1 180 $X=239940 $Y=376500
X2678 1374 2 1440 42 1 NR2 $T=241800 437360 1 180 $X=239940 $Y=436980
X2679 59 2 1443 1379 1 NR2 $T=239940 487760 0 0 $X=239940 $Y=487380
X2680 59 2 1434 1442 1 NR2 $T=240560 477680 1 0 $X=240560 $Y=472260
X2681 1380 2 86 1320 1 NR2 $T=241800 326480 1 0 $X=241800 $Y=321060
X2682 1441 2 1455 1439 1 NR2 $T=241800 366800 1 0 $X=241800 $Y=361380
X2683 1485 2 106 97 1 NR2 $T=250480 356720 0 180 $X=248620 $Y=351300
X2684 1418 2 120 1298 1 NR2 $T=253580 326480 0 0 $X=253580 $Y=326100
X2685 1325 2 122 70 1 NR2 $T=255440 356720 0 0 $X=255440 $Y=356340
X2686 1537 2 1448 1521 1 NR2 $T=257300 366800 1 180 $X=255440 $Y=366420
X2687 1542 2 1433 1549 1 NR2 $T=257920 346640 0 0 $X=257920 $Y=346260
X2688 144 2 1512 136 1 NR2 $T=262880 477680 1 180 $X=261020 $Y=477300
X2689 1537 2 1567 1302 1 NR2 $T=262260 356720 1 0 $X=262260 $Y=351300
X2690 1521 2 1574 1524 1 NR2 $T=262260 366800 1 0 $X=262260 $Y=361380
X2691 1604 2 1558 1589 1 NR2 $T=265980 386960 1 180 $X=264120 $Y=386580
X2692 1405 2 107 39 1 NR2 $T=266600 326480 0 180 $X=264740 $Y=321060
X2693 97 2 1566 1405 1 NR2 $T=267220 326480 1 0 $X=267220 $Y=321060
X2694 1604 2 1619 1616 1 NR2 $T=267220 386960 0 0 $X=267220 $Y=386580
X2695 97 2 1607 39 1 NR2 $T=269700 376880 0 180 $X=267840 $Y=371460
X2696 1444 2 1599 1594 1 NR2 $T=269080 386960 1 0 $X=269080 $Y=381540
X2697 1622 2 1520 1648 1 NR2 $T=272800 386960 0 0 $X=272800 $Y=386580
X2698 1594 2 1659 1390 1 NR2 $T=274660 346640 1 0 $X=274660 $Y=341220
X2699 1390 2 1653 1302 1 NR2 $T=277760 356720 1 180 $X=275900 $Y=356340
X2700 26 2 155 100 1 NR2 $T=277760 326480 1 0 $X=277760 $Y=321060
X2701 1310 2 1715 1521 1 NR2 $T=282720 336560 0 0 $X=282720 $Y=336180
X2702 1361 2 1647 150 1 NR2 $T=283340 326480 0 0 $X=283340 $Y=326100
X2703 50 2 1698 1405 1 NR2 $T=286440 366800 0 180 $X=284580 $Y=361380
X2704 41 2 184 1647 1 NR2 $T=287680 326480 1 180 $X=285820 $Y=326100
X2705 1361 2 1729 1537 1 NR2 $T=289540 336560 1 0 $X=289540 $Y=331140
X2706 1744 2 1405 1712 1 NR2 $T=291400 376880 0 180 $X=289540 $Y=371460
X2707 1744 2 39 1710 1 NR2 $T=290780 366800 0 0 $X=290780 $Y=366420
X2708 1361 2 205 1310 1 NR2 $T=292640 326480 1 0 $X=292640 $Y=321060
X2709 1537 2 1756 1310 1 NR2 $T=292640 336560 1 0 $X=292640 $Y=331140
X2710 1736 2 1754 1755 1 NR2 $T=292640 467600 0 0 $X=292640 $Y=467220
X2711 1761 2 1789 1750 1 NR2 $T=294500 457520 1 0 $X=294500 $Y=452100
X2712 1736 2 1728 1745 1 NR2 $T=294500 477680 1 0 $X=294500 $Y=472260
X2713 50 2 209 70 1 NR2 $T=295120 336560 1 0 $X=295120 $Y=331140
X2714 1460 2 214 1298 1 NR2 $T=298220 326480 1 180 $X=296360 $Y=326100
X2715 1782 2 1460 1744 1 NR2 $T=298220 366800 1 180 $X=296360 $Y=366420
X2716 1736 2 1766 1781 1 NR2 $T=296360 467600 0 0 $X=296360 $Y=467220
X2717 1736 2 1773 1741 1 NR2 $T=298220 487760 1 180 $X=296360 $Y=487380
X2718 1725 2 1711 1699 1 NR2 $T=297600 447440 1 0 $X=297600 $Y=442020
X2719 1813 2 1771 1761 1 NR2 $T=303180 457520 0 180 $X=301320 $Y=452100
X2720 1744 2 50 231 1 NR2 $T=306280 366800 1 0 $X=306280 $Y=361380
X2721 144 2 1472 233 1 NR2 $T=310620 487760 0 180 $X=308760 $Y=482340
X2722 1831 2 1829 1819 1 NR2 $T=311860 386960 0 180 $X=310000 $Y=381540
X2723 1722 2 1648 1842 1 NR2 $T=311860 386960 1 0 $X=311860 $Y=381540
X2724 241 2 1828 246 1 NR2 $T=311860 467600 0 0 $X=311860 $Y=467220
X2725 241 2 1818 233 1 NR2 $T=313720 477680 1 180 $X=311860 $Y=477300
X2726 1839 2 1787 1847 1 NR2 $T=313100 376880 1 0 $X=313100 $Y=371460
X2727 144 2 1527 248 1 NR2 $T=313100 487760 0 0 $X=313100 $Y=487380
X2728 241 2 1821 245 1 NR2 $T=313100 507920 1 0 $X=313100 $Y=502500
X2729 1842 2 1765 1806 1 NR2 $T=313720 386960 0 0 $X=313720 $Y=386580
X2730 241 2 1816 248 1 NR2 $T=313720 487760 1 0 $X=313720 $Y=482340
X2731 144 2 1523 245 1 NR2 $T=313720 518000 1 0 $X=313720 $Y=512580
X2732 1861 2 1841 1811 1 NR2 $T=316820 386960 0 180 $X=314960 $Y=381540
X2733 241 2 1808 136 1 NR2 $T=314960 457520 0 0 $X=314960 $Y=457140
X2734 252 2 1844 245 1 NR2 $T=316820 507920 1 180 $X=314960 $Y=507540
X2735 1836 2 250 1850 1 NR2 $T=315580 336560 0 0 $X=315580 $Y=336180
X2736 252 2 1859 244 1 NR2 $T=317440 507920 0 180 $X=315580 $Y=502500
X2737 144 2 1509 251 1 NR2 $T=316820 518000 1 0 $X=316820 $Y=512580
X2738 241 2 1826 256 1 NR2 $T=318680 518000 0 0 $X=318680 $Y=517620
X2739 252 2 1883 251 1 NR2 $T=321780 518000 0 180 $X=319920 $Y=512580
X2740 1870 2 1858 1884 1 NR2 $T=320540 477680 1 0 $X=320540 $Y=472260
X2741 1880 2 261 1428 1 NR2 $T=323020 336560 0 180 $X=321160 $Y=331140
X2742 1691 2 260 234 1 NR2 $T=321160 346640 0 0 $X=321160 $Y=346260
X2743 252 2 1893 256 1 NR2 $T=321780 518000 0 0 $X=321780 $Y=517620
X2744 252 2 1890 248 1 NR2 $T=323640 497840 0 0 $X=323640 $Y=497460
X2745 150 2 1887 1880 1 NR2 $T=326120 336560 0 180 $X=324260 $Y=331140
X2746 263 2 1603 234 1 NR2 $T=325500 386960 0 0 $X=325500 $Y=386580
X2747 1804 2 1902 1912 1 NR2 $T=326740 376880 0 0 $X=326740 $Y=376500
X2748 1914 2 1908 1929 1 NR2 $T=328600 376880 1 0 $X=328600 $Y=371460
X2749 1889 2 1920 246 1 NR2 $T=331080 487760 1 180 $X=329220 $Y=487380
X2750 1866 2 1934 1937 1 NR2 $T=329840 477680 1 0 $X=329840 $Y=472260
X2751 1889 2 1900 136 1 NR2 $T=331700 497840 1 0 $X=331700 $Y=492420
X2752 1832 2 1944 1730 1 NR2 $T=336040 356720 1 180 $X=334180 $Y=356340
X2753 1954 2 1854 1904 1 NR2 $T=337280 346640 1 180 $X=335420 $Y=346260
X2754 1955 2 1851 283 1 NR2 $T=337280 356720 0 180 $X=335420 $Y=351300
X2755 252 2 1946 233 1 NR2 $T=335420 497840 0 0 $X=335420 $Y=497460
X2756 1903 2 1884 1962 1 NR2 $T=336040 487760 0 0 $X=336040 $Y=487380
X2757 1966 2 1838 1904 1 NR2 $T=339140 336560 1 180 $X=337280 $Y=336180
X2758 1955 2 1846 1963 1 NR2 $T=337280 356720 0 0 $X=337280 $Y=356340
X2759 287 2 1832 282 1 NR2 $T=339140 366800 0 180 $X=337280 $Y=361380
X2760 228 2 1950 1964 1 NR2 $T=337280 477680 1 0 $X=337280 $Y=472260
X2761 295 2 1969 268 1 NR2 $T=341620 356720 1 180 $X=339760 $Y=356340
X2762 296 2 272 1931 1 NR2 $T=342240 326480 1 180 $X=340380 $Y=326100
X2763 228 2 1975 1903 1 NR2 $T=342240 487760 1 180 $X=340380 $Y=487380
X2764 1903 2 1987 1871 1 NR2 $T=342240 487760 0 0 $X=342240 $Y=487380
X2765 1842 2 303 234 1 NR2 $T=344100 326480 0 0 $X=344100 $Y=326100
X2766 279 2 289 2005 1 NR2 $T=345960 326480 1 0 $X=345960 $Y=321060
X2767 287 2 1831 1961 1 NR2 $T=345960 366800 0 0 $X=345960 $Y=366420
X2768 292 2 2029 2006 1 NR2 $T=349060 518000 0 180 $X=347200 $Y=512580
X2769 234 2 310 268 1 NR2 $T=347820 326480 0 0 $X=347820 $Y=326100
X2770 282 2 2016 1954 1 NR2 $T=349060 346640 0 0 $X=349060 $Y=346260
X2771 2010 2 1978 312 1 NR2 $T=349060 397040 0 0 $X=349060 $Y=396660
X2772 292 2 2021 2003 1 NR2 $T=349060 487760 0 0 $X=349060 $Y=487380
X2773 1955 2 2048 1954 1 NR2 $T=354640 356720 1 0 $X=354640 $Y=351300
X2774 283 2 2044 2005 1 NR2 $T=359600 346640 0 0 $X=359600 $Y=346260
X2775 353 2 2307 357 1 NR2 $T=405480 326480 1 0 $X=405480 $Y=321060
X2776 2416 2 2292 2427 1 NR2 $T=424080 397040 0 0 $X=424080 $Y=396660
X2777 2418 2 2417 246 1 NR2 $T=429660 326480 1 180 $X=427800 $Y=326100
X2778 2418 2 2392 245 1 NR2 $T=429660 356720 0 180 $X=427800 $Y=351300
X2779 2418 2 2393 233 1 NR2 $T=429040 336560 1 0 $X=429040 $Y=331140
X2780 2418 2 2408 248 1 NR2 $T=430900 346640 0 180 $X=429040 $Y=341220
X2781 2427 2 2424 379 1 NR2 $T=430900 376880 0 180 $X=429040 $Y=371460
X2782 2427 2 2419 2447 1 NR2 $T=429040 386960 0 0 $X=429040 $Y=386580
X2783 2427 2 2406 2441 1 NR2 $T=429040 397040 1 0 $X=429040 $Y=391620
X2784 2418 2 2394 251 1 NR2 $T=430900 356720 1 0 $X=430900 $Y=351300
X2785 2427 2 2445 385 1 NR2 $T=430900 366800 0 0 $X=430900 $Y=366420
X2786 2427 2 2410 384 1 NR2 $T=430900 376880 1 0 $X=430900 $Y=371460
X2787 2427 2 2411 382 1 NR2 $T=430900 386960 1 0 $X=430900 $Y=381540
X2788 2427 2 2409 386 1 NR2 $T=432140 356720 0 0 $X=432140 $Y=356340
X2789 2418 2 2405 383 1 NR2 $T=434620 366800 0 180 $X=432760 $Y=361380
X2790 407 2 2542 2553 1 NR2 $T=449500 326480 1 0 $X=449500 $Y=321060
X2791 2633 2 2622 251 1 NR2 $T=467480 356720 0 180 $X=465620 $Y=351300
X2792 2636 2 2603 2441 1 NR2 $T=468100 386960 1 180 $X=466240 $Y=386580
X2793 2644 2 2625 430 1 NR2 $T=468720 477680 0 180 $X=466860 $Y=472260
X2794 2636 2 2602 384 1 NR2 $T=468100 386960 1 0 $X=468100 $Y=381540
X2795 2636 2 2610 382 1 NR2 $T=468720 386960 0 0 $X=468720 $Y=386580
X2796 2633 2 2634 246 1 NR2 $T=471820 326480 1 180 $X=469960 $Y=326100
X2797 2633 2 2652 383 1 NR2 $T=471820 376880 0 180 $X=469960 $Y=371460
X2798 2644 2 2645 434 1 NR2 $T=471820 487760 0 180 $X=469960 $Y=482340
X2799 2644 2 2670 436 1 NR2 $T=473680 467600 0 180 $X=471820 $Y=462180
X2800 2633 2 2608 136 1 NR2 $T=473060 326480 0 0 $X=473060 $Y=326100
X2801 2633 2 2668 248 1 NR2 $T=475540 346640 0 180 $X=473680 $Y=341220
X2802 2633 2 2641 244 1 NR2 $T=473680 346640 0 0 $X=473680 $Y=346260
X2803 2644 2 2651 441 1 NR2 $T=474300 487760 0 0 $X=474300 $Y=487380
X2804 2633 2 2638 386 1 NR2 $T=476780 366800 0 180 $X=474920 $Y=361380
X2805 2644 2 2673 444 1 NR2 $T=475540 467600 0 0 $X=475540 $Y=467220
X2806 2416 2 2692 2756 1 NR2 $T=486700 397040 1 0 $X=486700 $Y=391620
X2807 2745 2 2663 416 1 NR2 $T=488560 437360 0 180 $X=486700 $Y=431940
X2808 407 2 2760 2775 1 NR2 $T=490420 467600 1 0 $X=490420 $Y=462180
X2809 2644 2 2646 472 1 NR2 $T=490420 487760 0 0 $X=490420 $Y=487380
X2810 2756 2 2779 136 1 NR2 $T=492280 326480 0 0 $X=492280 $Y=326100
X2811 407 2 2777 2791 1 NR2 $T=492280 457520 0 0 $X=492280 $Y=457140
X2812 2644 2 2627 2784 1 NR2 $T=492280 507920 1 0 $X=492280 $Y=502500
X2813 407 2 2795 2754 1 NR2 $T=495380 467600 0 180 $X=493520 $Y=462180
X2814 2644 2 2662 2804 1 NR2 $T=495380 507920 1 0 $X=495380 $Y=502500
X2815 2756 2 2753 233 1 NR2 $T=496000 336560 0 0 $X=496000 $Y=336180
X2816 2644 2 2759 477 1 NR2 $T=496620 457520 1 0 $X=496620 $Y=452100
X2817 2644 2 2653 478 1 NR2 $T=496620 518000 1 0 $X=496620 $Y=512580
X2818 407 2 2803 2801 1 NR2 $T=497240 447440 0 0 $X=497240 $Y=447060
X2819 2644 2 2681 481 1 NR2 $T=497240 457520 0 0 $X=497240 $Y=457140
X2820 2644 2 2614 479 1 NR2 $T=497240 497840 1 0 $X=497240 $Y=492420
X2821 480 2 432 2644 1 NR2 $T=499100 507920 0 180 $X=497240 $Y=502500
X2822 2756 2 2749 246 1 NR2 $T=499100 336560 1 0 $X=499100 $Y=331140
X2823 2756 2 2807 245 1 NR2 $T=500960 356720 0 0 $X=500960 $Y=356340
X2824 2756 2 2805 383 1 NR2 $T=502820 366800 1 180 $X=500960 $Y=366420
X2825 2644 2 2771 485 1 NR2 $T=500960 457520 0 0 $X=500960 $Y=457140
X2826 2644 2 2650 486 1 NR2 $T=500960 467600 0 0 $X=500960 $Y=467220
X2827 2756 2 2757 248 1 NR2 $T=502200 346640 1 0 $X=502200 $Y=341220
X2828 2756 2 2797 244 1 NR2 $T=502820 346640 0 0 $X=502820 $Y=346260
X2829 2756 2 2831 386 1 NR2 $T=504060 356720 0 0 $X=504060 $Y=356340
X2830 2756 2 2847 379 1 NR2 $T=505300 376880 1 0 $X=505300 $Y=371460
X2831 2756 2 2864 382 1 NR2 $T=505300 386960 1 0 $X=505300 $Y=381540
X2832 2756 2 2815 251 1 NR2 $T=505920 356720 1 0 $X=505920 $Y=351300
X2833 2756 2 2851 2441 1 NR2 $T=507780 397040 1 180 $X=505920 $Y=396660
X2834 2756 2 2796 256 1 NR2 $T=506540 356720 0 0 $X=506540 $Y=356340
X2835 2792 2 2869 2840 1 NR2 $T=509020 417200 1 0 $X=509020 $Y=411780
X2836 2829 2 2875 2874 1 NR2 $T=509020 427280 0 0 $X=509020 $Y=426900
X2837 2756 2 2834 385 1 NR2 $T=510880 366800 0 0 $X=510880 $Y=366420
X2838 2756 2 2880 384 1 NR2 $T=510880 376880 0 0 $X=510880 $Y=376500
X2839 2756 2 2850 2447 1 NR2 $T=510880 397040 1 0 $X=510880 $Y=391620
X2840 2877 2 2881 2804 1 NR2 $T=510880 507920 1 0 $X=510880 $Y=502500
X2841 2877 2 2890 478 1 NR2 $T=510880 518000 1 0 $X=510880 $Y=512580
X2842 2877 2 2907 485 1 NR2 $T=514600 457520 1 180 $X=512740 $Y=457140
X2843 2877 2 2903 430 1 NR2 $T=514600 477680 0 180 $X=512740 $Y=472260
X2844 2756 2 2902 485 1 NR2 $T=516460 457520 0 180 $X=514600 $Y=452100
X2845 2877 2 2911 434 1 NR2 $T=515840 477680 0 0 $X=515840 $Y=477300
X2846 2877 2 2924 444 1 NR2 $T=517700 467600 0 0 $X=517700 $Y=467220
X2847 2877 2 2931 436 1 NR2 $T=519560 447440 0 0 $X=519560 $Y=447060
X2848 2877 2 2930 481 1 NR2 $T=519560 457520 0 0 $X=519560 $Y=457140
X2849 2877 2 2944 486 1 NR2 $T=519560 467600 1 0 $X=519560 $Y=462180
X2850 480 2 501 2877 1 NR2 $T=521420 507920 1 180 $X=519560 $Y=507540
X2851 2954 2 2967 2965 1 NR2 $T=524520 417200 0 0 $X=524520 $Y=416820
X2852 2889 2 2973 535 1 NR2 $T=526380 336560 1 0 $X=526380 $Y=331140
X2853 2877 2 2961 469 1 NR2 $T=527620 437360 0 0 $X=527620 $Y=436980
X2854 546 2 2941 541 1 NR2 $T=531340 326480 1 180 $X=529480 $Y=326100
X2855 2925 2 2965 3017 1 NR2 $T=530100 427280 1 0 $X=530100 $Y=421860
X2856 540 2 3053 3041 1 NR2 $T=541880 447440 0 180 $X=540020 $Y=442020
X2857 540 2 3044 3049 1 NR2 $T=540020 477680 1 0 $X=540020 $Y=472260
X2858 579 2 2983 541 1 NR2 $T=543740 356720 0 180 $X=541880 $Y=351300
X2859 590 2 3069 553 1 NR2 $T=546840 326480 1 180 $X=544980 $Y=326100
X2860 3116 2 597 538 1 NR2 $T=551180 346640 0 180 $X=549320 $Y=341220
X2861 568 2 581 3097 1 NR2 $T=553660 336560 1 180 $X=551800 $Y=336180
X2862 610 2 3000 614 1 NR2 $T=556140 336560 0 0 $X=556140 $Y=336180
X2863 614 2 3162 605 1 NR2 $T=558620 326480 0 0 $X=558620 $Y=326100
X2864 3143 2 3142 3165 1 NR2 $T=558620 356720 0 0 $X=558620 $Y=356340
X2865 3223 2 3036 3196 1 NR2 $T=570400 356720 0 180 $X=568540 $Y=351300
X2866 630 2 3218 596 1 NR2 $T=572260 326480 1 180 $X=570400 $Y=326100
X2867 541 2 567 645 1 NR2 $T=572260 336560 1 0 $X=572260 $Y=331140
X2868 3237 2 555 538 1 NR2 $T=574740 346640 1 180 $X=572880 $Y=346260
X2869 2756 2 3255 481 1 NR2 $T=575360 457520 0 0 $X=575360 $Y=457140
X2870 610 2 653 604 1 NR2 $T=575980 326480 1 0 $X=575980 $Y=321060
X2871 2756 2 3264 430 1 NR2 $T=577840 467600 1 180 $X=575980 $Y=467220
X2872 3223 2 3232 3253 1 NR2 $T=577220 356720 1 0 $X=577220 $Y=351300
X2873 2756 2 3244 2804 1 NR2 $T=579080 507920 0 180 $X=577220 $Y=502500
X2874 2756 2 3293 477 1 NR2 $T=580320 457520 0 180 $X=578460 $Y=452100
X2875 2756 2 3286 436 1 NR2 $T=579080 457520 0 0 $X=579080 $Y=457140
X2876 2756 2 3281 434 1 NR2 $T=579080 467600 1 0 $X=579080 $Y=462180
X2877 2756 2 3291 479 1 NR2 $T=579080 477680 0 0 $X=579080 $Y=477300
X2878 2756 2 3292 441 1 NR2 $T=579080 487760 1 0 $X=579080 $Y=482340
X2879 2756 2 3267 2784 1 NR2 $T=580940 487760 1 180 $X=579080 $Y=487380
X2880 2756 2 3276 478 1 NR2 $T=582180 507920 0 180 $X=580320 $Y=502500
X2881 3237 2 3275 590 1 NR2 $T=580940 346640 0 0 $X=580940 $Y=346260
X2882 2756 2 3283 469 1 NR2 $T=582800 437360 1 180 $X=580940 $Y=436980
X2883 2756 2 3304 466 1 NR2 $T=582180 447440 0 0 $X=582180 $Y=447060
X2884 480 2 3269 2756 1 NR2 $T=582800 507920 1 0 $X=582800 $Y=502500
X2885 553 2 3337 604 1 NR2 $T=585900 326480 0 0 $X=585900 $Y=326100
X2886 3323 2 3223 3297 1 NR2 $T=587760 356720 0 180 $X=585900 $Y=351300
X2887 2756 2 3305 472 1 NR2 $T=585900 467600 0 0 $X=585900 $Y=467220
X2888 3221 2 670 669 1 NR2 $T=586520 336560 1 0 $X=586520 $Y=331140
X2889 3326 2 3196 3297 1 NR2 $T=589620 366800 0 180 $X=587760 $Y=361380
X2890 3331 2 596 3326 1 NR2 $T=590860 336560 1 180 $X=589000 $Y=336180
X2891 572 2 3229 671 1 NR2 $T=589000 346640 1 0 $X=589000 $Y=341220
X2892 3240 2 3247 3145 1 NR2 $T=591480 437360 0 180 $X=589620 $Y=431940
X2893 645 2 651 669 1 NR2 $T=590860 336560 1 0 $X=590860 $Y=331140
X2894 3297 2 3165 3345 1 NR2 $T=590860 366800 1 0 $X=590860 $Y=361380
X2895 3331 2 669 3323 1 NR2 $T=592100 356720 1 0 $X=592100 $Y=351300
X2896 3353 2 674 3334 1 NR2 $T=594580 326480 0 180 $X=592720 $Y=321060
X2897 675 2 3306 671 1 NR2 $T=592720 346640 1 0 $X=592720 $Y=341220
X2898 3345 2 3206 676 1 NR2 $T=592720 366800 0 0 $X=592720 $Y=366420
X2899 3402 2 3369 3357 1 NR2 $T=601400 366800 1 180 $X=599540 $Y=366420
X2900 3339 2 681 630 1 NR2 $T=600780 326480 1 0 $X=600780 $Y=321060
X2901 3395 2 3393 3301 1 NR2 $T=601400 366800 1 0 $X=601400 $Y=361380
X2902 3379 2 666 3331 1 NR2 $T=602640 326480 0 0 $X=602640 $Y=326100
X2903 3331 2 645 684 1 NR2 $T=602640 346640 1 0 $X=602640 $Y=341220
X2904 645 2 687 3295 1 NR2 $T=606980 326480 1 180 $X=605120 $Y=326100
X2905 676 2 3300 671 1 NR2 $T=606360 356720 0 0 $X=606360 $Y=356340
X2906 3064 2 3437 3438 1 NR2 $T=606360 366800 1 0 $X=606360 $Y=361380
X2907 3405 2 3440 3411 1 NR2 $T=610700 457520 1 180 $X=608840 $Y=457140
X2908 3405 2 3446 3420 1 NR2 $T=611320 467600 0 180 $X=609460 $Y=462180
X2909 3405 2 3457 3248 1 NR2 $T=613180 447440 0 180 $X=611320 $Y=442020
X2910 3310 2 3459 3307 1 NR2 $T=611940 356720 0 0 $X=611940 $Y=356340
X2911 3462 2 3468 3475 1 NR2 $T=613180 356720 1 0 $X=613180 $Y=351300
X2912 3456 2 3480 3454 1 NR2 $T=613180 366800 1 0 $X=613180 $Y=361380
X2913 3405 2 3485 3396 1 NR2 $T=613800 447440 0 0 $X=613800 $Y=447060
X2914 3171 2 703 671 1 NR2 $T=618140 356720 0 0 $X=618140 $Y=356340
X2915 279 2 711 2005 1 NR2 $T=621240 326480 1 0 $X=621240 $Y=321060
X2916 3528 2 691 3519 1 NR2 $T=623100 346640 0 180 $X=621240 $Y=341220
X2917 3540 2 3439 283 1 NR2 $T=624960 336560 0 180 $X=623100 $Y=331140
X2918 3425 2 716 671 1 NR2 $T=623100 346640 1 0 $X=623100 $Y=341220
X2919 3540 2 699 3528 1 NR2 $T=626820 336560 1 180 $X=624960 $Y=336180
X2920 283 2 696 3519 1 NR2 $T=625580 346640 0 0 $X=625580 $Y=346260
X2921 722 2 3535 279 1 NR2 $T=626820 326480 0 0 $X=626820 $Y=326100
X2922 727 2 3310 705 1 NR2 $T=628680 356720 0 180 $X=626820 $Y=351300
X2923 3557 2 3463 722 1 NR2 $T=629920 346640 1 180 $X=628060 $Y=346260
X2924 3561 2 3427 722 1 NR2 $T=630540 326480 0 180 $X=628680 $Y=321060
X2925 705 2 3562 3557 1 NR2 $T=631780 356720 0 180 $X=629920 $Y=351300
X2926 714 2 726 708 1 NR2 $T=631780 326480 1 0 $X=631780 $Y=321060
X2927 727 2 3395 3520 1 NR2 $T=631780 366800 1 0 $X=631780 $Y=361380
X2928 3345 2 732 671 1 NR2 $T=632400 336560 1 0 $X=632400 $Y=331140
X2929 728 2 2010 737 1 NR2 $T=633640 397040 1 0 $X=633640 $Y=391620
X2930 2010 2 3566 3613 1 NR2 $T=636740 386960 1 0 $X=636740 $Y=381540
X2931 715 2 3613 737 1 NR2 $T=636740 397040 1 0 $X=636740 $Y=391620
X2932 3540 2 3617 3557 1 NR2 $T=640460 356720 0 180 $X=638600 $Y=351300
X2933 744 2 3604 692 1 NR2 $T=641700 326480 1 180 $X=639840 $Y=326100
X2934 283 2 3598 2005 1 NR2 $T=645420 346640 0 0 $X=645420 $Y=346260
X2935 792 2 3919 3962 1 NR2 $T=704320 326480 1 0 $X=704320 $Y=321060
X2936 4051 2 4016 256 1 NR2 $T=720440 356720 1 0 $X=720440 $Y=351300
X2937 4051 2 4019 385 1 NR2 $T=720440 376880 0 0 $X=720440 $Y=376500
X2938 819 2 4052 4054 1 NR2 $T=720440 397040 0 0 $X=720440 $Y=396660
X2939 817 2 3956 4055 1 NR2 $T=720440 457520 0 0 $X=720440 $Y=457140
X2940 4051 2 4046 248 1 NR2 $T=722300 336560 1 0 $X=722300 $Y=331140
X2941 4051 2 4032 244 1 NR2 $T=722300 346640 1 0 $X=722300 $Y=341220
X2942 4081 2 3878 819 1 NR2 $T=724160 407120 0 180 $X=722300 $Y=401700
X2943 4055 2 4047 821 1 NR2 $T=724160 457520 1 180 $X=722300 $Y=457140
X2944 819 2 4021 382 1 NR2 $T=724160 386960 0 0 $X=724160 $Y=386580
X2945 4051 2 4061 233 1 NR2 $T=725400 336560 1 0 $X=725400 $Y=331140
X2946 4043 2 4074 828 1 NR2 $T=728500 467600 1 180 $X=726640 $Y=467220
X2947 4055 2 4073 828 1 NR2 $T=729120 457520 1 180 $X=727260 $Y=457140
X2948 4051 2 831 246 1 NR2 $T=729120 326480 0 0 $X=729120 $Y=326100
X2949 4043 2 4106 830 1 NR2 $T=729120 467600 0 0 $X=729120 $Y=467220
X2950 4055 2 4120 830 1 NR2 $T=732220 457520 1 180 $X=730360 $Y=457140
X2951 4043 2 4097 441 1 NR2 $T=730360 477680 1 0 $X=730360 $Y=472260
X2952 819 2 4068 4141 1 NR2 $T=734700 386960 0 0 $X=734700 $Y=386580
X2953 4055 2 4143 441 1 NR2 $T=737800 457520 1 180 $X=735940 $Y=457140
X2954 4055 2 4162 479 1 NR2 $T=739040 457520 0 0 $X=739040 $Y=457140
X2955 4043 2 4147 479 1 NR2 $T=739040 477680 1 0 $X=739040 $Y=472260
X2956 4055 2 4206 472 1 NR2 $T=744000 457520 0 0 $X=744000 $Y=457140
X2957 4043 2 4194 472 1 NR2 $T=747720 467600 1 180 $X=745860 $Y=467220
X2958 4043 2 4221 434 1 NR2 $T=747720 477680 1 0 $X=747720 $Y=472260
X2959 819 2 852 430 1 NR2 $T=748960 518000 0 0 $X=748960 $Y=517620
X2960 4055 2 4219 434 1 NR2 $T=752680 457520 1 180 $X=750820 $Y=457140
X2961 4055 2 4205 430 1 NR2 $T=754540 467600 0 180 $X=752680 $Y=462180
X2962 4055 2 4261 444 1 NR2 $T=758260 457520 0 180 $X=756400 $Y=452100
X2963 4055 2 4274 486 1 NR2 $T=759500 467600 1 0 $X=759500 $Y=462180
X2964 4043 2 4267 486 1 NR2 $T=762600 467600 1 180 $X=760740 $Y=467220
X2965 4055 2 4291 481 1 NR2 $T=762600 457520 1 0 $X=762600 $Y=452100
X2966 4043 2 4301 481 1 NR2 $T=762600 467600 0 0 $X=762600 $Y=467220
X2967 4055 2 4314 436 1 NR2 $T=770040 457520 0 180 $X=768180 $Y=452100
X2968 4043 2 4315 436 1 NR2 $T=768180 467600 1 0 $X=768180 $Y=462180
X2969 4043 2 4317 383 1 NR2 $T=771280 376880 0 180 $X=769420 $Y=371460
X2970 4043 2 4321 4141 1 NR2 $T=771280 397040 1 180 $X=769420 $Y=396660
X2971 4043 2 4328 477 1 NR2 $T=769420 477680 1 0 $X=769420 $Y=472260
X2972 4305 2 4308 233 1 NR2 $T=770040 336560 1 0 $X=770040 $Y=331140
X2973 4055 2 4330 477 1 NR2 $T=771900 447440 1 180 $X=770040 $Y=447060
X2974 4305 2 869 136 1 NR2 $T=771280 326480 1 0 $X=771280 $Y=321060
X2975 819 2 870 4332 1 NR2 $T=771280 518000 0 0 $X=771280 $Y=517620
X2976 4081 2 4244 4043 1 NR2 $T=773140 407120 0 0 $X=773140 $Y=406740
X2977 4305 2 4323 251 1 NR2 $T=776240 356720 0 180 $X=774380 $Y=351300
X2978 4305 2 871 246 1 NR2 $T=775000 336560 1 0 $X=775000 $Y=331140
X2979 4305 2 4335 244 1 NR2 $T=775000 346640 1 0 $X=775000 $Y=341220
X2980 4043 2 4319 384 1 NR2 $T=775000 386960 1 0 $X=775000 $Y=381540
X2981 4043 2 4327 382 1 NR2 $T=775000 397040 1 0 $X=775000 $Y=391620
X2982 4043 2 4340 4054 1 NR2 $T=775000 407120 1 0 $X=775000 $Y=401700
X2983 4043 2 4343 4332 1 NR2 $T=775000 467600 0 0 $X=775000 $Y=467220
X2984 4305 2 4322 386 1 NR2 $T=777480 356720 1 180 $X=775620 $Y=356340
X2985 4305 2 4312 245 1 NR2 $T=776240 346640 0 0 $X=776240 $Y=346260
X2986 4353 2 4348 384 1 NR2 $T=778100 386960 1 180 $X=776240 $Y=386580
X2987 4354 2 4350 233 1 NR2 $T=778720 336560 0 180 $X=776860 $Y=331140
X2988 4305 2 4313 256 1 NR2 $T=776860 356720 1 0 $X=776860 $Y=351300
X2989 4353 2 4349 4054 1 NR2 $T=778720 407120 0 180 $X=776860 $Y=401700
X2990 4055 2 4351 4332 1 NR2 $T=778720 457520 0 180 $X=776860 $Y=452100
X2991 4354 2 4373 136 1 NR2 $T=778100 326480 0 0 $X=778100 $Y=326100
X2992 4354 2 4356 245 1 NR2 $T=779960 346640 1 180 $X=778100 $Y=346260
X2993 4354 2 4394 251 1 NR2 $T=779960 356720 1 180 $X=778100 $Y=356340
X2994 4354 2 4364 385 1 NR2 $T=781820 376880 1 180 $X=779960 $Y=376500
X2995 4353 2 4365 4141 1 NR2 $T=781820 397040 0 180 $X=779960 $Y=391620
X2996 4081 2 4378 4353 1 NR2 $T=779960 407120 0 0 $X=779960 $Y=406740
X2997 4354 2 4390 256 1 NR2 $T=783680 366800 0 180 $X=781820 $Y=361380
X2998 4043 2 4381 469 1 NR2 $T=781820 467600 1 0 $X=781820 $Y=462180
X2999 4353 2 4399 382 1 NR2 $T=783060 386960 0 0 $X=783060 $Y=386580
X3000 4055 2 4383 466 1 NR2 $T=784920 457520 0 180 $X=783060 $Y=452100
X3001 4354 2 4404 386 1 NR2 $T=783680 366800 0 0 $X=783680 $Y=366420
X3002 813 2 4419 4405 1 NR2 $T=786160 487760 0 0 $X=786160 $Y=487380
X3003 813 2 4418 4403 1 NR2 $T=788640 487760 1 0 $X=788640 $Y=482340
X3004 813 2 4440 4434 1 NR2 $T=790500 477680 0 0 $X=790500 $Y=477300
X3005 813 2 4447 4453 1 NR2 $T=793600 477680 0 0 $X=793600 $Y=477300
X3006 812 2 4475 4422 1 NR2 $T=798560 427280 1 180 $X=796700 $Y=426900
X3007 812 2 4478 4459 1 NR2 $T=796700 437360 1 0 $X=796700 $Y=431940
X3008 4464 2 4493 4403 1 NR2 $T=800420 477680 1 180 $X=798560 $Y=477300
X3009 812 2 4510 4495 1 NR2 $T=804140 437360 0 0 $X=804140 $Y=436980
X3010 812 2 4537 4540 1 NR2 $T=810340 447440 1 0 $X=810340 $Y=442020
X3011 4561 2 4511 4487 1 NR2 $T=814060 467600 1 0 $X=814060 $Y=462180
X3012 279 2 4610 283 1 NR2 $T=828940 356720 1 0 $X=828940 $Y=351300
X3013 4665 2 4642 279 1 NR2 $T=832660 346640 0 180 $X=830800 $Y=341220
X3014 4600 2 4645 4583 1 NR2 $T=830800 447440 1 0 $X=830800 $Y=442020
X3015 926 2 4655 4676 1 NR2 $T=834520 326480 1 0 $X=834520 $Y=321060
X3016 4635 2 924 283 1 NR2 $T=837000 346640 0 0 $X=837000 $Y=346260
X3017 4524 2 4639 4692 1 NR2 $T=837620 427280 0 0 $X=837620 $Y=426900
X3018 779 2 4688 3613 1 NR2 $T=839480 397040 0 0 $X=839480 $Y=396660
X3019 3519 2 923 940 1 NR2 $T=840720 356720 1 0 $X=840720 $Y=351300
X3020 938 2 4696 4705 1 NR2 $T=840720 376880 0 0 $X=840720 $Y=376500
X3021 4701 2 4672 940 1 NR2 $T=841340 356720 0 0 $X=841340 $Y=356340
X3022 4717 2 943 3519 1 NR2 $T=845060 356720 0 180 $X=843200 $Y=351300
X3023 954 2 4720 4727 1 NR2 $T=844440 336560 1 0 $X=844440 $Y=331140
X3024 4717 2 919 4701 1 NR2 $T=846300 356720 1 180 $X=844440 $Y=356340
X3025 4665 2 4716 4664 1 NR2 $T=846300 356720 0 0 $X=846300 $Y=356340
X3026 4735 2 4733 4731 1 NR2 $T=849400 326480 1 180 $X=847540 $Y=326100
X3027 4732 2 4680 4741 1 NR2 $T=847540 376880 1 0 $X=847540 $Y=371460
X3028 972 2 4736 4760 1 NR2 $T=851260 336560 1 0 $X=851260 $Y=331140
X3029 4778 2 4725 4718 1 NR2 $T=864900 366800 1 180 $X=863040 $Y=366420
X3030 4818 2 4809 4823 1 NR2 $T=864900 326480 0 0 $X=864900 $Y=326100
X3031 4725 2 4828 4822 1 NR2 $T=864900 366800 1 0 $X=864900 $Y=361380
X3032 1019 2 1017 4816 1 NR2 $T=868620 326480 0 180 $X=866760 $Y=321060
X3033 938 2 4737 4795 1 NR2 $T=866760 376880 0 0 $X=866760 $Y=376500
X3034 4767 2 4819 4746 1 NR2 $T=866760 386960 1 0 $X=866760 $Y=381540
X3035 4766 2 4790 4734 1 NR2 $T=869240 386960 1 0 $X=869240 $Y=381540
X3036 4802 2 4822 4766 1 NR2 $T=869860 376880 1 0 $X=869860 $Y=371460
X3037 1030 2 974 4810 1 NR2 $T=872960 336560 1 180 $X=871100 $Y=336180
X3038 4778 2 4841 4734 1 NR2 $T=871720 356720 1 0 $X=871720 $Y=351300
X3039 4810 2 947 4821 1 NR2 $T=871720 366800 1 0 $X=871720 $Y=361380
X3040 4718 2 4838 4746 1 NR2 $T=873580 366800 1 180 $X=871720 $Y=366420
X3041 4846 2 4843 4767 1 NR2 $T=873580 376880 0 180 $X=871720 $Y=371460
X3042 4846 2 4738 4718 1 NR2 $T=873580 376880 0 0 $X=873580 $Y=376500
X3043 4808 2 4787 4778 1 NR2 $T=875440 356720 0 0 $X=875440 $Y=356340
X3044 4821 2 4849 4766 1 NR2 $T=876060 366800 0 0 $X=876060 $Y=366420
X3045 972 2 962 1040 1 NR2 $T=878540 346640 1 0 $X=878540 $Y=341220
X3046 4802 2 4866 4778 1 NR2 $T=878540 366800 1 0 $X=878540 $Y=361380
X3047 1055 2 4801 976 1 NR2 $T=882260 346640 0 180 $X=880400 $Y=341220
X3048 4868 2 4875 4870 1 NR2 $T=880400 457520 1 0 $X=880400 $Y=452100
X3049 4815 2 4795 4734 1 NR2 $T=881020 376880 0 0 $X=881020 $Y=376500
X3050 1030 2 972 4874 1 NR2 $T=881640 336560 0 0 $X=881640 $Y=336180
X3051 4808 2 4882 4766 1 NR2 $T=882260 376880 1 0 $X=882260 $Y=371460
X3052 1066 2 4886 996 1 NR2 $T=885980 326480 0 180 $X=884120 $Y=321060
X3053 4885 2 1059 4734 1 NR2 $T=885980 346640 0 180 $X=884120 $Y=341220
X3054 938 2 4872 4734 1 NR2 $T=885360 376880 1 0 $X=885360 $Y=371460
X3055 4878 2 1069 4734 1 NR2 $T=888460 346640 0 180 $X=886600 $Y=341220
X3056 960 2 4877 996 1 NR2 $T=886600 346640 0 0 $X=886600 $Y=346260
X3057 4881 2 4891 4893 1 NR2 $T=887220 407120 0 0 $X=887220 $Y=406740
X3058 4821 2 1072 4878 1 NR2 $T=890320 336560 0 180 $X=888460 $Y=331140
X3059 1030 2 1073 1071 1 NR2 $T=889080 326480 0 0 $X=889080 $Y=326100
X3060 4879 2 1074 4821 1 NR2 $T=890940 336560 1 180 $X=889080 $Y=336180
X3061 4821 2 4826 938 1 NR2 $T=889080 356720 0 0 $X=889080 $Y=356340
X3062 4821 2 1075 4887 1 NR2 $T=889700 346640 0 0 $X=889700 $Y=346260
X3063 1030 2 1078 4885 1 NR2 $T=892180 336560 0 180 $X=890320 $Y=331140
X3064 4884 2 1076 1081 1 NR2 $T=892180 326480 0 0 $X=892180 $Y=326100
X3065 4876 2 4918 4909 1 NR2 $T=892180 427280 1 0 $X=892180 $Y=421860
X3066 4787 2 4832 1084 1 NR2 $T=894040 356720 0 0 $X=894040 $Y=356340
X3067 4912 2 4919 4904 1 NR2 $T=895900 477680 0 180 $X=894040 $Y=472260
X3068 1055 2 4913 996 1 NR2 $T=896520 346640 1 180 $X=894660 $Y=346260
X3069 1030 2 1040 4887 1 NR2 $T=895280 346640 1 0 $X=895280 $Y=341220
X3070 4906 2 4953 4927 1 NR2 $T=895900 407120 1 0 $X=895900 $Y=401700
X3071 4787 2 4924 4940 1 NR2 $T=897760 366800 1 0 $X=897760 $Y=361380
X3072 4928 2 981 982 1 NR2 $T=899000 356720 1 0 $X=899000 $Y=351300
X3073 4941 2 4934 4929 1 NR2 $T=900860 467600 0 180 $X=899000 $Y=462180
X3074 4926 2 4950 4943 1 NR2 $T=900860 376880 0 0 $X=900860 $Y=376500
X3075 992 2 4921 4946 1 NR2 $T=901480 356720 1 0 $X=901480 $Y=351300
X3076 4939 2 4954 4947 1 NR2 $T=901480 467600 0 0 $X=901480 $Y=467220
X3077 1099 2 1101 1102 1 NR2 $T=904580 326480 1 0 $X=904580 $Y=321060
X3078 4946 2 4963 1083 1 NR2 $T=905820 356720 1 0 $X=905820 $Y=351300
X3079 1029 2 1062 974 1 NR2 $T=912640 326480 1 0 $X=912640 $Y=321060
X3080 4976 2 4994 4986 1 NR2 $T=912640 356720 0 0 $X=912640 $Y=356340
X3081 4977 2 5004 5002 1 NR2 $T=917600 477680 1 0 $X=917600 $Y=472260
X3082 4990 2 4998 4997 1 NR2 $T=918840 346640 1 0 $X=918840 $Y=341220
X3083 954 2 1010 978 1 NR2 $T=921320 336560 1 180 $X=919460 $Y=336180
X3084 4978 2 5012 5009 1 NR2 $T=920700 507920 1 0 $X=920700 $Y=502500
X3085 954 2 1104 1073 1 NR2 $T=921320 326480 0 0 $X=921320 $Y=326100
X3086 972 2 1111 1073 1 NR2 $T=923180 336560 1 0 $X=923180 $Y=331140
X3087 5021 2 5024 5032 1 NR2 $T=924420 397040 1 0 $X=924420 $Y=391620
X3088 4991 2 5033 5028 1 NR2 $T=924420 417200 1 0 $X=924420 $Y=411780
X3089 1081 2 5027 1102 1 NR2 $T=926280 336560 0 0 $X=926280 $Y=336180
X3090 975 2 4840 992 1 NR2 $T=928140 326480 1 0 $X=928140 $Y=321060
X3091 4871 2 5049 5058 1 NR2 $T=928140 467600 1 0 $X=928140 $Y=462180
X3092 5052 2 5057 5061 1 NR2 $T=930000 447440 1 0 $X=930000 $Y=442020
X3093 5047 2 5054 5032 1 NR2 $T=933100 386960 1 180 $X=931240 $Y=386580
X3094 5003 2 5144 5090 1 NR2 $T=931240 507920 0 0 $X=931240 $Y=507540
X3095 5053 2 5075 5077 1 NR2 $T=931860 376880 0 0 $X=931860 $Y=376500
X3096 5047 2 5071 5063 1 NR2 $T=933720 397040 1 180 $X=931860 $Y=396660
X3097 1099 2 1141 989 1 NR2 $T=933100 326480 1 0 $X=933100 $Y=321060
X3098 5062 2 5094 5086 1 NR2 $T=933100 467600 0 0 $X=933100 $Y=467220
X3099 4967 2 5078 1142 1 NR2 $T=933100 518000 0 0 $X=933100 $Y=517620
X3100 1040 2 5092 954 1 NR2 $T=936820 336560 1 180 $X=934960 $Y=336180
X3101 1026 2 1063 989 1 NR2 $T=936200 346640 1 0 $X=936200 $Y=341220
X3102 4945 2 5100 5106 1 NR2 $T=936200 507920 1 0 $X=936200 $Y=502500
X3103 1040 2 1140 1029 1 NR2 $T=936820 326480 0 0 $X=936820 $Y=326100
X3104 5047 2 5098 5083 1 NR2 $T=936820 407120 1 0 $X=936820 $Y=401700
X3105 5045 2 5176 5085 1 NR2 $T=941160 437360 1 0 $X=941160 $Y=431940
X3106 989 2 5121 1083 1 NR2 $T=941780 336560 1 0 $X=941780 $Y=331140
X3107 992 2 5165 1066 1 NR2 $T=950460 326480 1 180 $X=948600 $Y=326100
X3108 992 2 5131 966 1 NR2 $T=948600 336560 0 0 $X=948600 $Y=336180
X3109 966 2 1159 4962 1 NR2 $T=950460 346640 0 180 $X=948600 $Y=341220
X3110 5021 2 4982 5063 1 NR2 $T=953560 397040 0 0 $X=953560 $Y=396660
X3111 5097 2 5189 5196 1 NR2 $T=957280 366800 0 0 $X=957280 $Y=366420
X3112 5203 2 5235 5234 1 NR2 $T=962860 346640 1 0 $X=962860 $Y=341220
X3113 1055 2 1187 1183 1 NR2 $T=964100 326480 1 0 $X=964100 $Y=321060
X3114 1188 2 5263 5259 1 NR2 $T=967200 326480 1 0 $X=967200 $Y=321060
X3115 5063 2 5275 5122 1 NR2 $T=972160 397040 0 0 $X=972160 $Y=396660
X3116 5021 2 5109 5101 1 NR2 $T=974640 397040 1 0 $X=974640 $Y=391620
X3117 5063 2 5230 5141 1 NR2 $T=975260 397040 0 0 $X=975260 $Y=396660
X3118 5295 2 5265 5244 1 NR2 $T=977740 407120 0 0 $X=977740 $Y=406740
X3119 5303 2 5293 5282 1 NR2 $T=981460 407120 1 180 $X=979600 $Y=406740
X3120 5297 2 5310 5287 1 NR2 $T=985800 407120 1 180 $X=983940 $Y=406740
X3121 5101 2 5294 5141 1 NR2 $T=987660 397040 0 0 $X=987660 $Y=396660
X3122 1208 2 5333 1216 1 NR2 $T=989520 326480 1 0 $X=989520 $Y=321060
X3123 1210 2 5336 5354 1 NR2 $T=989520 336560 0 0 $X=989520 $Y=336180
X3124 5032 2 5376 5141 1 NR2 $T=992620 397040 0 0 $X=992620 $Y=396660
X3125 5032 2 5314 5122 1 NR2 $T=994480 386960 0 0 $X=994480 $Y=386580
X3126 5377 2 5344 5282 1 NR2 $T=997580 407120 0 180 $X=995720 $Y=401700
X3127 1220 2 5372 5365 1 NR2 $T=998200 326480 1 180 $X=996340 $Y=326100
X3128 5083 2 5296 5122 1 NR2 $T=998200 386960 1 180 $X=996340 $Y=386580
X3129 1524 97 2 1339 1 117 AOI12HS $T=257920 346640 1 180 $X=253580 $Y=346260
X3130 4725 923 2 4787 1 4792 AOI12HS $T=853740 366800 1 0 $X=853740 $Y=361380
X3131 1326 1336 1335 24 2 1 1358 OA112 $T=224440 376880 0 0 $X=224440 $Y=376500
X3132 1357 1465 93 90 2 1 1447 OA112 $T=248000 356720 0 180 $X=243040 $Y=351300
X3133 1617 1641 43 160 2 1 1395 OA112 $T=276520 336560 1 180 $X=271560 $Y=336180
X3134 1686 1690 177 160 2 1 1407 OA112 $T=283340 336560 0 180 $X=278380 $Y=331140
X3135 259 1853 247 1627 2 1 242 OA112 $T=317440 326480 0 180 $X=312480 $Y=321060
X3136 2918 508 507 505 2 1 2855 OA112 $T=520800 326480 1 180 $X=515840 $Y=326100
X3137 534 2986 2983 539 2 1 2915 OA112 $T=531960 356720 0 180 $X=527000 $Y=351300
X3138 2999 565 520 558 2 1 544 OA112 $T=539400 336560 0 180 $X=534440 $Y=331140
X3139 1125 5007 982 913 2 1 5026 OA112 $T=920700 346640 1 0 $X=920700 $Y=341220
X3140 5068 5046 958 999 2 1 5040 OA112 $T=932480 356720 0 180 $X=927520 $Y=351300
X3141 1115 5179 5165 1014 2 1 1175 OA112 $T=953560 326480 0 0 $X=953560 $Y=326100
X3142 122 31 150 1570 2 1 1402 MAOI1 $T=271560 346640 0 180 $X=266600 $Y=341220
X3143 613 511 609 580 2 1 2842 MAOI1 $T=559240 326480 0 180 $X=554280 $Y=321060
X3144 1010 5027 989 5064 2 1 5079 MAOI1 $T=928760 336560 0 0 $X=928760 $Y=336180
X3145 3 1 11 1309 2 1334 ND3 $T=221340 326480 0 0 $X=221340 $Y=326100
X3146 1372 1 40 1349 2 1395 ND3 $T=230640 346640 1 0 $X=230640 $Y=341220
X3147 1373 1 1340 1385 2 1387 ND3 $T=231880 346640 0 0 $X=231880 $Y=346260
X3148 1415 1 1425 1368 2 1433 ND3 $T=238080 356720 1 0 $X=238080 $Y=351300
X3149 1435 1 1401 1332 2 1429 ND3 $T=241800 336560 1 180 $X=239320 $Y=336180
X3150 107 1 95 1314 2 48 ND3 $T=247380 326480 0 180 $X=244900 $Y=321060
X3151 1447 1 88 1469 2 1319 ND3 $T=244900 336560 0 0 $X=244900 $Y=336180
X3152 48 1 1467 65 2 112 ND3 $T=248620 326480 0 0 $X=248620 $Y=326100
X3153 1531 1 1536 1554 2 1543 ND3 $T=256680 346640 1 0 $X=256680 $Y=341220
X3154 1520 1 1555 1436 2 1577 ND3 $T=259160 386960 0 0 $X=259160 $Y=386580
X3155 1539 1 1564 1511 2 1583 ND3 $T=260400 457520 0 0 $X=260400 $Y=457140
X3156 1624 1 1576 1514 2 1557 ND3 $T=263500 437360 1 180 $X=261020 $Y=436980
X3157 143 1 141 1544 2 134 ND3 $T=264740 326480 0 180 $X=262260 $Y=321060
X3158 1574 1 23 138 2 1567 ND3 $T=262260 356720 0 0 $X=262260 $Y=356340
X3159 1586 1 135 1592 2 1600 ND3 $T=263500 376880 0 0 $X=263500 $Y=376500
X3160 1591 1 147 1609 2 1606 ND3 $T=265360 356720 0 0 $X=265360 $Y=356340
X3161 1524 1 1597 1600 2 1603 ND3 $T=265360 376880 1 0 $X=265360 $Y=371460
X3162 1603 1 1597 1384 2 1594 ND3 $T=267840 386960 0 180 $X=265360 $Y=381540
X3163 1629 1 153 1573 2 1620 ND3 $T=269080 356720 1 0 $X=269080 $Y=351300
X3164 1619 1 1505 1622 2 1391 ND3 $T=270320 386960 0 0 $X=270320 $Y=386580
X3165 1662 1 1496 1654 2 1505 ND3 $T=278380 386960 0 180 $X=275900 $Y=381540
X3166 169 1 1664 1668 2 171 ND3 $T=277140 346640 1 0 $X=277140 $Y=341220
X3167 1717 1 1691 1657 2 1687 ND3 $T=283340 386960 0 180 $X=280860 $Y=381540
X3168 1662 1 1679 1727 2 1391 ND3 $T=283960 397040 0 0 $X=283960 $Y=396660
X3169 1718 1 1717 1714 2 188 ND3 $T=285820 386960 0 0 $X=285820 $Y=386580
X3170 1494 1 1505 1751 2 1391 ND3 $T=289540 397040 1 0 $X=289540 $Y=391620
X3171 200 1 1391 1702 2 1623 ND3 $T=292640 386960 0 180 $X=290160 $Y=381540
X3172 1763 1 206 1692 2 1746 ND3 $T=295120 346640 1 180 $X=292640 $Y=346260
X3173 57 1 1625 1760 2 207 ND3 $T=300080 336560 0 180 $X=297600 $Y=331140
X3174 1778 1 125 1785 2 1764 ND3 $T=297600 346640 1 0 $X=297600 $Y=341220
X3175 1640 1 125 1799 2 1796 ND3 $T=299460 326480 0 0 $X=299460 $Y=326100
X3176 1716 1 1691 1791 2 1788 ND3 $T=301940 397040 0 180 $X=299460 $Y=391620
X3177 1623 1 1679 1804 2 1687 ND3 $T=301320 386960 0 0 $X=301320 $Y=386580
X3178 1824 1 1800 1805 2 226 ND3 $T=303180 346640 1 0 $X=303180 $Y=341220
X3179 238 1 1690 225 2 1742 ND3 $T=306900 326480 0 180 $X=304420 $Y=321060
X3180 1829 1 1782 1597 2 1841 ND3 $T=311240 376880 0 0 $X=311240 $Y=376500
X3181 1803 1 258 1863 2 255 ND3 $T=320540 326480 1 180 $X=318060 $Y=326100
X3182 1535 1 1749 1873 2 262 ND3 $T=319920 336560 0 0 $X=319920 $Y=336180
X3183 271 1 1904 177 2 1846 ND3 $T=329220 326480 1 180 $X=326740 $Y=326100
X3184 1846 1 1904 99 2 272 ND3 $T=326740 336560 0 0 $X=326740 $Y=336180
X3185 272 1 1904 43 2 243 ND3 $T=331080 336560 0 180 $X=328600 $Y=331140
X3186 1925 1 1922 1910 2 1908 ND3 $T=331080 366800 0 180 $X=328600 $Y=361380
X3187 271 1 1904 273 2 243 ND3 $T=329840 326480 1 0 $X=329840 $Y=321060
X3188 289 1 1931 118 2 1846 ND3 $T=336040 326480 1 180 $X=333560 $Y=326100
X3189 289 1 270 235 2 1846 ND3 $T=339140 326480 1 180 $X=336660 $Y=326100
X3190 289 1 1931 223 2 243 ND3 $T=339140 336560 0 180 $X=336660 $Y=331140
X3191 293 1 296 103 2 1931 ND3 $T=341000 326480 0 180 $X=338520 $Y=321060
X3192 1974 1 1954 1989 2 285 ND3 $T=342240 346640 0 0 $X=342240 $Y=346260
X3193 1996 1 1999 1990 2 1989 ND3 $T=346580 356720 0 180 $X=344100 $Y=351300
X3194 2018 1 270 2031 2 279 ND3 $T=349680 386960 0 180 $X=347200 $Y=381540
X3195 2016 1 1926 1999 2 2032 ND3 $T=349060 356720 0 0 $X=349060 $Y=356340
X3196 1831 1 1955 2037 2 1904 ND3 $T=350300 366800 1 0 $X=350300 $Y=361380
X3197 2005 1 2031 1579 2 1919 ND3 $T=352780 386960 0 180 $X=350300 $Y=381540
X3198 2005 1 295 2065 2 287 ND3 $T=358980 326480 1 180 $X=356500 $Y=326100
X3199 2120 1 2109 2041 2 2099 ND3 $T=366420 397040 0 180 $X=363940 $Y=391620
X3200 2246 1 2253 343 2 2258 ND3 $T=390600 518000 0 0 $X=390600 $Y=517620
X3201 2301 1 2349 2362 2 2318 ND3 $T=409820 427280 0 0 $X=409820 $Y=426900
X3202 2516 1 2512 2502 2 2507 ND3 $T=443300 457520 1 180 $X=440820 $Y=457140
X3203 2590 1 420 412 2 2608 ND3 $T=459420 326480 1 0 $X=459420 $Y=321060
X3204 475 1 2768 473 2 2779 ND3 $T=496000 326480 0 180 $X=493520 $Y=321060
X3205 2901 1 502 2896 2 499 ND3 $T=515840 326480 1 180 $X=513360 $Y=326100
X3206 588 1 3086 3080 2 584 ND3 $T=547460 356720 0 180 $X=544980 $Y=351300
X3207 3074 1 3097 3089 2 2942 ND3 $T=548700 366800 1 180 $X=546220 $Y=366420
X3208 3142 1 3056 3012 2 3103 ND3 $T=550560 356720 0 180 $X=548080 $Y=351300
X3209 3036 1 3097 3143 2 2942 ND3 $T=554900 356720 0 0 $X=554900 $Y=356340
X3210 3159 1 3131 3064 2 3070 ND3 $T=559240 366800 0 180 $X=556760 $Y=361380
X3211 3203 1 3140 3194 2 3097 ND3 $T=567300 356720 0 180 $X=564820 $Y=351300
X3212 3162 1 514 649 2 653 ND3 $T=573500 326480 1 0 $X=573500 $Y=321060
X3213 3111 1 3171 3234 2 3070 ND3 $T=573500 366800 0 0 $X=573500 $Y=366420
X3214 654 1 2942 3226 2 3159 ND3 $T=576600 366800 0 180 $X=574120 $Y=361380
X3215 3216 1 646 3239 2 3245 ND3 $T=574740 346640 0 0 $X=574740 $Y=346260
X3216 3268 1 3111 3260 2 612 ND3 $T=579700 366800 1 180 $X=577220 $Y=366420
X3217 3203 1 3131 3230 2 2942 ND3 $T=579700 376880 0 180 $X=577220 $Y=371460
X3218 3147 1 3171 3222 2 3289 ND3 $T=580320 366800 0 0 $X=580320 $Y=366420
X3219 605 1 3296 3245 2 3300 ND3 $T=582180 356720 1 0 $X=582180 $Y=351300
X3220 3300 1 3296 2966 2 590 ND3 $T=584660 356720 1 180 $X=582180 $Y=356340
X3221 3393 1 3379 3296 2 3369 ND3 $T=600160 366800 0 180 $X=597680 $Y=361380
X3222 3417 1 3409 3386 2 3423 ND3 $T=602640 397040 0 0 $X=602640 $Y=396660
X3223 2005 1 3421 3022 2 3428 ND3 $T=605740 376880 0 0 $X=605740 $Y=376500
X3224 3489 1 3480 2952 2 3468 ND3 $T=616900 356720 1 180 $X=614420 $Y=356340
X3225 711 1 708 572 2 691 ND3 $T=620620 326480 0 180 $X=618140 $Y=321060
X3226 3501 1 270 3421 2 279 ND3 $T=619380 376880 0 0 $X=619380 $Y=376500
X3227 718 1 714 675 2 708 ND3 $T=625580 326480 0 180 $X=623100 $Y=321060
X3228 699 1 722 616 2 726 ND3 $T=626200 326480 1 0 $X=626200 $Y=321060
X3229 3562 1 3466 3576 2 3572 ND3 $T=629920 356720 0 0 $X=629920 $Y=356340
X3230 3569 1 3576 3575 2 3590 ND3 $T=631780 356720 1 0 $X=631780 $Y=351300
X3231 3583 1 3557 3590 2 712 ND3 $T=633020 356720 0 0 $X=633020 $Y=356340
X3232 671 1 710 505 2 3608 ND3 $T=634880 326480 1 0 $X=634880 $Y=321060
X3233 3395 1 3540 3614 2 722 ND3 $T=634880 366800 1 0 $X=634880 $Y=361380
X3234 2005 1 744 3637 2 727 ND3 $T=645420 326480 1 180 $X=642940 $Y=326100
X3235 3710 1 3713 3719 2 3714 ND3 $T=662160 417200 1 0 $X=662160 $Y=411780
X3236 3710 1 3714 3694 2 3713 ND3 $T=663400 407120 0 0 $X=663400 $Y=406740
X3237 3720 1 3712 3725 2 3730 ND3 $T=663400 427280 1 0 $X=663400 $Y=421860
X3238 3755 1 3759 3762 2 3768 ND3 $T=670840 346640 0 0 $X=670840 $Y=346260
X3239 3789 1 3799 3805 2 3812 ND3 $T=677660 477680 1 0 $X=677660 $Y=472260
X3240 3835 1 3831 3787 2 3845 ND3 $T=684480 497840 1 0 $X=684480 $Y=492420
X3241 4222 1 4197 4116 2 4185 ND3 $T=747720 518000 0 180 $X=745240 $Y=512580
X3242 4612 1 4648 4606 2 4625 ND3 $T=830800 497840 0 0 $X=830800 $Y=497460
X3243 4673 1 270 4695 2 279 ND3 $T=835760 407120 1 0 $X=835760 $Y=401700
X3244 959 1 4733 4627 2 4699 ND3 $T=846920 326480 1 180 $X=844440 $Y=326100
X3245 4755 1 4768 4770 2 4777 ND3 $T=853120 467600 0 0 $X=853120 $Y=467220
X3246 4713 1 4780 4753 2 3519 ND3 $T=854980 376880 0 0 $X=854980 $Y=376500
X3247 1013 1 973 4806 2 4802 ND3 $T=866140 356720 1 180 $X=863660 $Y=356340
X3248 4896 1 4878 4834 2 4924 ND3 $T=895280 366800 1 0 $X=895280 $Y=361380
X3249 1117 1 4834 1103 2 4826 ND3 $T=904580 336560 1 180 $X=902100 $Y=336180
X3250 1121 1 4994 4742 2 4999 ND3 $T=915740 356720 0 0 $X=915740 $Y=356340
X3251 5027 1 930 4962 2 928 ND3 $T=925040 336560 1 180 $X=922560 $Y=336180
X3252 1131 1 4998 5010 2 5040 ND3 $T=925660 346640 0 0 $X=925660 $Y=346260
X3253 5026 1 1143 5087 2 5079 ND3 $T=936820 346640 1 180 $X=934340 $Y=346260
X3254 4954 1 5119 5115 2 5127 ND3 $T=941160 477680 0 0 $X=941160 $Y=477300
X3255 5132 1 1155 4788 2 5120 ND3 $T=944880 346640 1 180 $X=942400 $Y=346260
X3256 5012 1 5130 5116 2 5163 ND3 $T=943020 507920 0 0 $X=943020 $Y=507540
X3257 5049 1 5136 5139 2 5142 ND3 $T=944260 467600 1 0 $X=944260 $Y=462180
X3258 4918 1 5138 1157 2 5145 ND3 $T=944880 427280 0 0 $X=944880 $Y=426900
X3259 5144 1 5162 5147 2 5160 ND3 $T=946740 507920 1 0 $X=946740 $Y=502500
X3260 1168 1 1161 4781 2 5074 ND3 $T=950460 346640 1 180 $X=947980 $Y=346260
X3261 5078 1 1164 5158 2 5175 ND3 $T=949840 518000 0 0 $X=949840 $Y=517620
X3262 5075 1 5180 1169 2 5185 ND3 $T=952940 386960 1 0 $X=952940 $Y=381540
X3263 4934 1 5182 1170 2 5195 ND3 $T=953560 467600 1 0 $X=953560 $Y=462180
X3264 5004 1 5161 1171 2 5190 ND3 $T=953560 477680 1 0 $X=953560 $Y=472260
X3265 4891 1 5186 1162 2 5240 ND3 $T=954180 407120 1 0 $X=954180 $Y=401700
X3266 5189 1 5193 5191 2 5199 ND3 $T=955420 366800 1 0 $X=955420 $Y=361380
X3267 5057 1 5197 5178 2 5202 ND3 $T=956040 457520 1 0 $X=956040 $Y=452100
X3268 4953 1 5201 1176 2 5210 ND3 $T=957280 407120 0 0 $X=957280 $Y=406740
X3269 4875 1 5174 1177 2 5214 ND3 $T=958520 457520 1 0 $X=958520 $Y=452100
X3270 5094 1 5211 5148 2 5231 ND3 $T=958520 477680 0 0 $X=958520 $Y=477300
X3271 5176 1 5212 1179 2 5222 ND3 $T=959140 437360 1 0 $X=959140 $Y=431940
X3272 4950 1 5216 1182 2 5229 ND3 $T=959760 386960 0 0 $X=959760 $Y=386580
X3273 5033 1 5217 5218 2 5223 ND3 $T=959760 417200 0 0 $X=959760 $Y=416820
X3274 4919 1 5242 1184 2 5267 ND3 $T=963480 477680 1 0 $X=963480 $Y=472260
X3275 5100 1 5247 5221 2 5256 ND3 $T=965340 507920 0 0 $X=965340 $Y=507540
X3276 1186 1 5254 5183 2 5257 ND3 $T=965960 518000 0 0 $X=965960 $Y=517620
X3277 5235 1 5258 1190 2 5269 ND3 $T=967820 346640 0 0 $X=967820 $Y=346260
X3278 5263 1 5274 1193 2 5283 ND3 $T=970920 336560 0 0 $X=970920 $Y=336180
X3279 1202 1 5329 1206 2 5331 ND3 $T=985800 356720 1 0 $X=985800 $Y=351300
X3280 5336 1 5330 1204 2 5321 ND3 $T=988280 366800 0 180 $X=985800 $Y=361380
X3281 5333 1 5345 1211 2 5348 ND3 $T=988900 346640 1 0 $X=988900 $Y=341220
X3282 5372 1 5363 1218 2 5358 ND3 $T=995100 336560 1 180 $X=992620 $Y=336180
X3283 5371 1 5369 5301 2 5364 ND3 $T=996340 447440 1 180 $X=993860 $Y=447060
X3284 5389 1 5386 5370 2 5380 ND3 $T=1001920 507920 0 180 $X=999440 $Y=502500
X3285 5394 1 5382 5278 2 5390 ND3 $T=1003160 437360 1 0 $X=1003160 $Y=431940
X3286 5400 1 5397 5308 2 5393 ND3 $T=1008120 376880 1 180 $X=1005640 $Y=376500
X3287 5410 1 5418 5324 2 5424 ND3 $T=1011220 467600 1 0 $X=1011220 $Y=462180
X3288 5443 1 5430 5325 2 5434 ND3 $T=1018660 507920 0 180 $X=1016180 $Y=502500
X3289 5435 1 5419 5353 2 5440 ND3 $T=1016180 507920 0 0 $X=1016180 $Y=507540
X3290 5441 1 5387 5328 2 5444 ND3 $T=1017420 518000 0 0 $X=1017420 $Y=517620
X3291 5445 1 5449 5351 2 5455 ND3 $T=1021140 467600 0 0 $X=1021140 $Y=467220
X3292 5476 1 5473 5327 2 5468 ND3 $T=1032920 427280 1 180 $X=1030440 $Y=426900
X3293 5490 1 5487 5357 2 5482 ND3 $T=1037260 417200 0 180 $X=1034780 $Y=411780
X3294 5507 1 5500 5322 2 5511 ND3 $T=1042840 437360 1 180 $X=1040360 $Y=436980
X3295 5512 1 5499 5361 2 5505 ND3 $T=1047800 467600 0 180 $X=1045320 $Y=462180
X3296 5526 1 5523 5341 2 5498 ND3 $T=1052760 376880 1 180 $X=1050280 $Y=376500
X3297 5533 1 5528 5431 2 5513 ND3 $T=1054620 356720 1 180 $X=1052140 $Y=356340
X3298 5542 1 5539 5471 2 5529 ND3 $T=1056480 336560 1 180 $X=1054000 $Y=336180
X3299 1264 1 5553 5456 2 5538 ND3 $T=1057720 326480 1 180 $X=1055240 $Y=326100
X3300 5548 1 5541 5342 2 5545 ND3 $T=1059580 457520 0 180 $X=1057100 $Y=452100
X3301 5600 1 5562 5378 2 5602 ND3 $T=1072600 477680 1 0 $X=1072600 $Y=472260
X3302 5596 1 5587 5395 2 5603 ND3 $T=1072600 477680 0 0 $X=1072600 $Y=477300
X3303 1321 5 1 2 BUF2 $T=224440 457520 1 180 $X=221340 $Y=457140
X3304 1461 32 1 2 BUF2 $T=244900 417200 0 0 $X=244900 $Y=416820
X3305 1590 133 1 2 BUF2 $T=263500 417200 1 180 $X=260400 $Y=416820
X3306 1747 210 1 2 BUF2 $T=292640 407120 0 0 $X=292640 $Y=406740
X3307 1736 204 1 2 BUF2 $T=296360 507920 0 180 $X=293260 $Y=502500
X3308 1761 215 1 2 BUF2 $T=300080 487760 1 0 $X=300080 $Y=482340
X3309 1889 252 1 2 BUF2 $T=319920 497840 0 180 $X=316820 $Y=492420
X3310 1896 241 1 2 BUF2 $T=325500 427280 1 0 $X=325500 $Y=421860
X3311 2841 2780 1 2 BUF2 $T=506540 346640 0 0 $X=506540 $Y=346260
X3312 2633 2644 1 2 BUF2 $T=515220 386960 1 0 $X=515220 $Y=381540
X3313 2418 2877 1 2 BUF2 $T=515220 386960 0 0 $X=515220 $Y=386580
X3314 3809 779 1 2 BUF2 $T=679520 467600 1 0 $X=679520 $Y=462180
X3315 4353 4055 1 2 BUF2 $T=779340 427280 0 180 $X=776240 $Y=421860
X3316 899 776 1 2 BUF2 $T=802900 417200 1 180 $X=799800 $Y=416820
X3317 4550 4273 1 2 BUF2 $T=812200 326480 1 180 $X=809100 $Y=326100
X3318 4555 4200 1 2 BUF2 $T=820260 346640 1 0 $X=820260 $Y=341220
X3319 4619 832 1 2 BUF2 $T=826460 407120 1 180 $X=823360 $Y=406740
X3320 3538 3624 1 2 INV4CK $T=638600 518000 0 0 $X=638600 $Y=517620
X3321 1980 1363 1 2 INV6CK $T=341620 417200 0 0 $X=341620 $Y=416820
X3322 2988 490 1 2 INV6CK $T=530720 366800 0 180 $X=525140 $Y=361380
X3323 4983 1001 1 2 INV6CK $T=928760 407120 0 180 $X=923180 $Y=401700
X3324 4969 1044 1 2 INV6CK $T=948600 386960 0 180 $X=943020 $Y=381540
X3325 5155 4847 1 2 INV6CK $T=948600 407120 0 180 $X=943020 $Y=401700
X3326 5168 1165 1 2 INV6CK $T=952320 467600 0 180 $X=946740 $Y=462180
X3327 5194 1050 1 2 INV6CK $T=956660 376880 0 180 $X=951080 $Y=371460
X3328 5088 5150 1 2 INV6CK $T=956660 397040 0 180 $X=951080 $Y=391620
X3329 5038 1004 1 2 INV6CK $T=956660 386960 1 0 $X=956660 $Y=381540
X3330 4903 5076 1 2 INV6CK $T=970300 417200 0 180 $X=964720 $Y=411780
X3331 5250 1212 1 2 INV6CK $T=994480 447440 0 180 $X=988900 $Y=442020
X3332 5169 1201 1 2 INV6CK $T=997580 397040 0 180 $X=992000 $Y=391620
X3333 5305 1213 1 2 INV6CK $T=993240 427280 0 0 $X=993240 $Y=426900
X3334 5140 5290 1 2 INV6CK $T=1003160 407120 0 180 $X=997580 $Y=401700
X3335 5304 1232 1 2 INV6CK $T=1009980 386960 1 0 $X=1009980 $Y=381540
X3336 5276 1231 1 2 INV6CK $T=1016800 407120 0 180 $X=1011220 $Y=401700
X3337 5396 1230 1 2 INV6CK $T=1024860 407120 1 0 $X=1024860 $Y=401700
X3338 5343 1221 1 2 INV6CK $T=1031060 397040 0 180 $X=1025480 $Y=391620
X3339 133 2 1 161 BUF1 $T=272180 518000 0 0 $X=272180 $Y=517620
X3340 1748 2 1 236 BUF1 $T=306900 477680 0 180 $X=304420 $Y=472260
X3341 263 2 1 1806 BUF1 $T=326120 397040 0 180 $X=323640 $Y=391620
X3342 353 2 1 2297 BUF1 $T=401760 336560 1 0 $X=401760 $Y=331140
X3343 1869 2 1 355 BUF1 $T=401760 518000 1 0 $X=401760 $Y=512580
X3344 373 2 1 2360 BUF1 $T=422840 336560 1 180 $X=420360 $Y=336180
X3345 377 2 1 2402 BUF1 $T=431520 356720 1 180 $X=429040 $Y=356340
X3346 2418 2 1 2427 BUF1 $T=436480 366800 1 180 $X=434000 $Y=366420
X3347 388 2 1 2423 BUF1 $T=443300 386960 0 180 $X=440820 $Y=381540
X3348 407 2 1 2556 BUF1 $T=450740 346640 0 0 $X=450740 $Y=346260
X3349 2633 2 1 2636 BUF1 $T=472440 376880 1 180 $X=469960 $Y=376500
X3350 407 2 1 442 BUF1 $T=476780 477680 1 0 $X=476780 $Y=472260
X3351 450 2 1 2739 BUF1 $T=492900 386960 0 180 $X=490420 $Y=381540
X3352 377 2 1 2886 BUF1 $T=517080 457520 1 0 $X=517080 $Y=452100
X3353 388 2 1 491 BUF1 $T=520180 447440 0 180 $X=517700 $Y=442020
X3354 540 2 1 2910 BUF1 $T=531960 477680 0 0 $X=531960 $Y=477300
X3355 2723 2 1 3145 BUF1 $T=551800 407120 0 0 $X=551800 $Y=406740
X3356 3006 2 1 607 BUF1 $T=559240 477680 0 180 $X=556760 $Y=472260
X3357 2984 2 1 602 BUF1 $T=561720 427280 0 0 $X=561720 $Y=426900
X3358 3145 2 1 3322 BUF1 $T=598300 467600 0 180 $X=595820 $Y=462180
X3359 3405 2 1 3364 BUF1 $T=608220 467600 0 180 $X=605740 $Y=462180
X3360 807 2 1 3967 BUF1 $T=708660 336560 1 180 $X=706180 $Y=336180
X3361 824 2 1 4025 BUF1 $T=727880 346640 0 180 $X=725400 $Y=341220
X3362 834 2 1 789 BUF1 $T=734700 326480 1 180 $X=732220 $Y=326100
X3363 839 2 1 4060 BUF1 $T=741520 477680 1 180 $X=739040 $Y=477300
X3364 4200 2 1 4089 BUF1 $T=746480 437360 1 180 $X=744000 $Y=436980
X3365 841 2 1 3971 BUF1 $T=750200 427280 1 180 $X=747720 $Y=426900
X3366 4273 2 1 4063 BUF1 $T=761980 457520 0 180 $X=759500 $Y=452100
X3367 4353 2 1 4354 BUF1 $T=777480 376880 1 0 $X=777480 $Y=371460
X3368 4514 2 1 3862 BUF1 $T=809100 457520 1 180 $X=806620 $Y=457140
X3369 4614 2 1 3828 BUF1 $T=829560 457520 1 180 $X=827080 $Y=457140
X3370 4650 2 1 938 BUF1 $T=836380 376880 1 0 $X=836380 $Y=371460
X3371 875 2 1 4614 BUF1 $T=843200 447440 0 180 $X=840720 $Y=442020
X3372 4804 2 1 875 BUF1 $T=853740 417200 1 180 $X=851260 $Y=416820
X3373 1057 2 1 1061 BUF1 $T=881640 497840 1 0 $X=881640 $Y=492420
X3374 2587 2621 1 2 INV2CK $T=466240 467600 0 0 $X=466240 $Y=467220
X3375 2748 2725 1 2 INV2CK $T=492280 437360 1 0 $X=492280 $Y=431940
X3376 3051 3079 1 2 INV2CK $T=541260 417200 0 0 $X=541260 $Y=416820
X3377 3734 3740 1 2 INV2CK $T=665880 427280 1 0 $X=665880 $Y=421860
X3378 4075 3709 1 2 INV2CK $T=724160 397040 1 0 $X=724160 $Y=391620
X3379 4798 4622 1 2 INV2CK $T=872960 346640 0 0 $X=872960 $Y=346260
X3380 5030 5088 1 2 INV2CK $T=936200 376880 0 180 $X=933720 $Y=371460
X3381 5170 5168 1 2 INV2CK $T=952320 457520 0 180 $X=949840 $Y=452100
X3382 5306 5304 1 2 INV2CK $T=982080 427280 0 180 $X=979600 $Y=421860
X3383 5402 5396 1 2 INV2CK $T=1008120 397040 0 180 $X=1005640 $Y=391620
X3384 288 309 1 2 1958 QDBHN $T=350300 447440 0 180 $X=342860 $Y=442020
X3385 288 309 1 2 2929 QDBHN $T=528240 386960 0 180 $X=520800 $Y=381540
X3386 288 729 1 2 3481 QDBHN $T=627440 507920 0 0 $X=627440 $Y=507540
X3387 4786 309 1 2 4800 QDBHN $T=861800 336560 0 0 $X=861800 $Y=336180
X3388 4786 4982 1 2 4972 QDBHN $T=915740 417200 0 180 $X=908300 $Y=411780
X3389 4786 5069 1 2 5022 QDBHN $T=934960 397040 0 180 $X=927520 $Y=391620
X3390 4786 5054 1 2 5041 QDBHN $T=934960 417200 0 180 $X=927520 $Y=411780
X3391 4786 5098 1 2 5070 QDBHN $T=939300 447440 0 180 $X=931860 $Y=442020
X3392 4786 5109 1 2 5080 QDBHN $T=941160 366800 0 180 $X=933720 $Y=361380
X3393 4786 5096 1 2 5104 QDBHN $T=944880 397040 0 180 $X=937440 $Y=391620
X3394 4786 5024 1 2 5095 QDBHN $T=944880 427280 0 180 $X=937440 $Y=421860
X3395 4786 5215 1 2 5192 QDBHN $T=963480 336560 0 180 $X=956040 $Y=331140
X3396 4786 5230 1 2 5200 QDBHN $T=965340 467600 0 180 $X=957900 $Y=462180
X3397 4786 5071 1 2 5224 QDBHN $T=969060 437360 0 180 $X=961620 $Y=431940
X3398 4786 5275 1 2 5252 QDBHN $T=974020 356720 0 180 $X=966580 $Y=351300
X3399 4786 5294 1 2 5226 QDBHN $T=978980 457520 0 180 $X=971540 $Y=452100
X3400 4786 5296 1 2 5286 QDBHN $T=980840 437360 0 180 $X=973400 $Y=431940
X3401 4786 5302 1 2 5289 QDBHN $T=983940 356720 0 180 $X=976500 $Y=351300
X3402 4786 5314 1 2 5298 QDBHN $T=986420 336560 1 180 $X=978980 $Y=336180
X3403 4786 5376 1 2 5359 QDBHN $T=1001920 417200 0 180 $X=994480 $Y=411780
X3404 1958 1 2 1971 DELC $T=337280 447440 0 0 $X=337280 $Y=447060
X3405 2560 1 2 2526 DELC $T=451980 487760 1 0 $X=451980 $Y=482340
X3406 2549 1 2 418 DELC $T=453840 507920 0 0 $X=453840 $Y=507540
X3407 423 1 2 429 DELC $T=461900 518000 1 0 $X=461900 $Y=512580
X3408 2929 1 2 2957 DELC $T=520800 376880 0 0 $X=520800 $Y=376500
X3409 3481 1 2 3515 DELC $T=615660 518000 0 0 $X=615660 $Y=517620
X3410 3760 1 2 3739 DELC $T=671460 447440 1 0 $X=671460 $Y=442020
X3411 4800 1 2 4776 DELC $T=859320 346640 0 0 $X=859320 $Y=346260
X3412 1957 1 2 1980 INV3CK $T=357120 437360 0 180 $X=354020 $Y=431940
X3413 2900 1 2 2988 INV3CK $T=535060 376880 0 180 $X=531960 $Y=371460
X3414 3624 1 2 754 INV3CK $T=661540 518000 0 0 $X=661540 $Y=517620
X3415 4622 1 2 906 INV3CK $T=827080 346640 0 0 $X=827080 $Y=346260
X3416 4898 1 2 4903 INV3CK $T=890940 407120 0 0 $X=890940 $Y=406740
X3417 4971 1 2 4969 INV3CK $T=908920 397040 0 180 $X=905820 $Y=391620
X3418 4987 1 2 4983 INV3CK $T=914500 437360 0 180 $X=911400 $Y=431940
X3419 5042 1 2 5038 INV3CK $T=928140 457520 0 180 $X=925040 $Y=452100
X3420 5134 1 2 5140 INV3CK $T=944880 346640 0 0 $X=944880 $Y=346260
X3421 5172 1 2 5169 INV3CK $T=954180 427280 0 180 $X=951080 $Y=421860
X3422 5107 1 2 5194 INV3CK $T=957900 437360 0 180 $X=954800 $Y=431940
X3423 5171 1 2 5250 INV3CK $T=967820 376880 0 180 $X=964720 $Y=371460
X3424 5051 1 2 5155 INV3CK $T=967820 427280 0 180 $X=964720 $Y=421860
X3425 5245 1 2 5276 INV3CK $T=972160 366800 0 180 $X=969060 $Y=361380
X3426 5228 1 2 5305 INV3CK $T=982700 366800 0 180 $X=979600 $Y=361380
X3427 5281 1 2 5343 INV3CK $T=988900 346640 0 0 $X=988900 $Y=346260
X3428 1486 1440 1478 1 2 AN2T $T=249860 437360 1 0 $X=249860 $Y=431940
X3429 1478 20 1530 1 2 AN2T $T=255440 427280 1 0 $X=255440 $Y=421860
X3430 1483 1519 1548 1 2 AN2T $T=256060 457520 0 0 $X=256060 $Y=457140
X3431 1775 1789 1725 1 2 AN2T $T=298220 447440 0 0 $X=298220 $Y=447060
X3432 1971 288 1957 1 2 AN2T $T=340380 437360 0 180 $X=336040 $Y=431940
X3433 2957 288 2900 1 2 AN2T $T=518320 376880 0 180 $X=513980 $Y=371460
X3434 2969 2940 2954 1 2 AN2T $T=533200 417200 0 0 $X=533200 $Y=416820
X3435 3027 3023 3085 1 2 AN2T $T=543120 447440 1 0 $X=543120 $Y=442020
X3436 3311 3247 3280 1 2 AN2T $T=586520 427280 1 180 $X=582180 $Y=426900
X3437 3515 288 3538 1 2 AN2T $T=620620 518000 0 0 $X=620620 $Y=517620
X3438 4415 4556 4583 1 2 AN2T $T=812200 437360 0 0 $X=812200 $Y=436980
X3439 4677 4663 4658 1 2 AN2T $T=842580 467600 0 0 $X=842580 $Y=467220
X3440 4776 4786 4798 1 2 AN2T $T=854980 346640 0 0 $X=854980 $Y=346260
X3441 4973 4786 4898 1 2 AN2T $T=909540 407120 0 180 $X=905200 $Y=401700
X3442 5015 4786 4971 1 2 AN2T $T=923800 397040 0 180 $X=919460 $Y=391620
X3443 5001 4786 4987 1 2 AN2T $T=923800 417200 0 180 $X=919460 $Y=411780
X3444 5128 4786 5030 1 2 AN2T $T=929380 386960 0 180 $X=925040 $Y=381540
X3445 5084 4786 5051 1 2 AN2T $T=933720 427280 0 180 $X=929380 $Y=421860
X3446 5114 4786 5107 1 2 AN2T $T=941160 437360 0 180 $X=936820 $Y=431940
X3447 5146 4786 5042 1 2 AN2T $T=947360 447440 0 180 $X=943020 $Y=442020
X3448 5135 4786 5134 1 2 AN2T $T=949220 366800 0 180 $X=944880 $Y=361380
X3449 5184 4786 5171 1 2 AN2T $T=955420 366800 0 180 $X=951080 $Y=361380
X3450 5187 4786 5172 1 2 AN2T $T=955420 447440 0 180 $X=951080 $Y=442020
X3451 5205 4786 5228 1 2 AN2T $T=958520 356720 1 0 $X=958520 $Y=351300
X3452 5255 4786 5170 1 2 AN2T $T=967820 457520 0 180 $X=963480 $Y=452100
X3453 5266 4786 5245 1 2 AN2T $T=969060 346640 0 180 $X=964720 $Y=341220
X3454 5292 4786 5281 1 2 AN2T $T=975260 346640 0 180 $X=970920 $Y=341220
X3455 5317 4786 5306 1 2 AN2T $T=984560 437360 1 0 $X=984560 $Y=431940
X3456 5332 4786 5402 1 2 AN2T $T=1005640 417200 1 0 $X=1005640 $Y=411780
X3457 139 137 1537 1380 1320 1504 1 2 1495 AO222 $T=263500 336560 0 180 $X=257300 $Y=331140
X3458 310 2040 260 2048 2049 1954 1 2 2017 AO222 $T=353400 356720 0 0 $X=353400 $Y=356340
X3459 742 3626 703 3617 3615 3557 1 2 3563 AO222 $T=642940 356720 1 180 $X=636740 $Y=356340
X3460 4829 1032 1034 4853 4857 1042 1 2 4871 AO222 $T=871720 447440 0 0 $X=871720 $Y=447060
X3461 4835 1032 1034 4842 4839 1042 1 2 4868 AO222 $T=872340 457520 1 0 $X=872340 $Y=452100
X3462 4844 1032 1034 4852 4851 1042 1 2 4906 AO222 $T=873580 397040 0 0 $X=873580 $Y=396660
X3463 4845 1032 1034 4848 4860 1042 1 2 4876 AO222 $T=874200 417200 0 0 $X=874200 $Y=416820
X3464 4850 1032 1034 4873 4856 1042 1 2 4881 AO222 $T=877920 407120 0 0 $X=877920 $Y=406740
X3465 4867 1032 1034 4811 4883 1042 1 2 4939 AO222 $T=881020 437360 1 0 $X=881020 $Y=431940
X3466 4892 1032 1034 4899 4894 1042 1 2 4912 AO222 $T=889080 437360 0 0 $X=889080 $Y=436980
X3467 4889 1032 1034 4905 4908 1042 1 2 4926 AO222 $T=890940 386960 1 0 $X=890940 $Y=381540
X3468 4916 1032 1034 4910 4932 1042 1 2 4941 AO222 $T=895900 457520 0 0 $X=895900 $Y=457140
X3469 4917 1086 1088 4907 4897 1092 1 2 4945 AO222 $T=895900 507920 1 0 $X=895900 $Y=502500
X3470 1085 1086 1088 1094 4925 1092 1 2 4967 AO222 $T=899000 518000 0 0 $X=899000 $Y=517620
X3471 4944 1032 1034 4964 4951 1042 1 2 4977 AO222 $T=903960 457520 1 0 $X=903960 $Y=452100
X3472 4955 1086 1088 4900 4958 1092 1 2 4978 AO222 $T=903960 507920 1 0 $X=903960 $Y=502500
X3473 4975 1032 1034 4979 4966 1042 1 2 4991 AO222 $T=909540 407120 0 0 $X=909540 $Y=406740
X3474 4981 1086 1088 4989 4992 1092 1 2 5003 AO222 $T=912640 507920 1 0 $X=912640 $Y=502500
X3475 4993 1032 1034 5011 5034 1042 1 2 5045 AO222 $T=923180 427280 1 0 $X=923180 $Y=421860
X3476 5006 1032 1034 5018 5013 1042 1 2 5053 AO222 $T=924420 376880 0 0 $X=924420 $Y=376500
X3477 5008 1032 1034 5039 5017 1042 1 2 5052 AO222 $T=925040 437360 0 0 $X=925040 $Y=436980
X3478 5023 1032 1034 5020 5044 1042 1 2 5062 AO222 $T=925040 457520 0 0 $X=925040 $Y=457140
X3479 5055 1032 1034 5060 5082 1042 1 2 5097 AO222 $T=930620 356720 0 0 $X=930620 $Y=356340
X3480 5151 1032 1034 5173 5188 1042 1 2 5203 AO222 $T=951700 356720 1 0 $X=951700 $Y=351300
X3481 2106 2111 2103 2 1 ND2S $T=366420 356720 1 0 $X=366420 $Y=351300
X3482 2280 2301 2286 2 1 ND2S $T=403620 417200 1 180 $X=401760 $Y=416820
X3483 2375 2404 2340 2 1 ND2S $T=422840 417200 0 180 $X=420980 $Y=411780
X3484 2559 2582 2555 2 1 ND2S $T=456940 417200 1 180 $X=455080 $Y=416820
X3485 417 2553 2590 2 1 ND2S $T=458180 326480 0 0 $X=458180 $Y=326100
X3486 2574 2613 2569 2 1 ND2S $T=460040 437360 1 180 $X=458180 $Y=436980
X3487 2936 2946 2970 2 1 ND2S $T=524520 447440 1 0 $X=524520 $Y=442020
X3488 2961 2960 377 2 1 ND2S $T=525760 437360 0 0 $X=525760 $Y=436980
X3489 2883 3217 3211 2 1 ND2S $T=570400 518000 1 0 $X=570400 $Y=512580
X3490 3734 3720 3729 2 1 ND2S $T=668980 427280 1 0 $X=668980 $Y=421860
X3491 3819 3835 3816 2 1 ND2S $T=684480 497840 0 0 $X=684480 $Y=497460
X3492 3849 3861 3850 2 1 ND2S $T=689440 457520 1 180 $X=687580 $Y=457140
X3493 3820 3852 3817 2 1 ND2S $T=689440 507920 1 0 $X=689440 $Y=502500
X3494 3913 3957 3908 2 1 ND2S $T=703700 487760 1 0 $X=703700 $Y=482340
X3495 3955 3998 3924 2 1 ND2S $T=708660 407120 0 180 $X=706800 $Y=401700
X3496 3964 3970 3961 2 1 ND2S $T=710520 427280 0 180 $X=708660 $Y=421860
X3497 4093 4091 4086 2 1 ND2S $T=732220 386960 1 0 $X=732220 $Y=381540
X3498 4320 4324 4284 2 1 ND2S $T=771280 417200 1 0 $X=771280 $Y=411780
X3499 4392 4401 4387 2 1 ND2S $T=786780 417200 0 0 $X=786780 $Y=416820
X3500 4415 4422 4444 2 1 ND2S $T=795460 437360 0 180 $X=793600 $Y=431940
X3501 4657 4755 4684 2 1 ND2S $T=853120 467600 0 180 $X=851260 $Y=462180
X3502 4819 1031 4849 2 1 ND2S $T=872340 346640 1 0 $X=872340 $Y=341220
X3503 4841 1037 4819 2 1 ND2S $T=874820 336560 1 180 $X=872960 $Y=336180
X3504 4841 1036 4838 2 1 ND2S $T=873580 336560 1 0 $X=873580 $Y=331140
X3505 4843 4879 4778 2 1 ND2S $T=880400 366800 1 180 $X=878540 $Y=366420
X3506 4838 4887 4778 2 1 ND2S $T=885980 366800 1 180 $X=884120 $Y=366420
X3507 4872 1097 4787 2 1 ND2S $T=903960 366800 1 180 $X=902100 $Y=366420
X3508 5081 5063 1127 2 1 ND2S $T=934340 407120 1 0 $X=934340 $Y=401700
X3509 5036 5122 1151 2 1 ND2S $T=941780 407120 0 180 $X=939920 $Y=401700
X3510 61 2 1 315 BUF3 $T=359600 417200 0 0 $X=359600 $Y=416820
X3511 3006 2 1 337 BUF3 $T=533200 386960 0 0 $X=533200 $Y=386580
X3512 3063 2 1 2756 BUF3 $T=538780 376880 0 180 $X=535060 $Y=371460
X3513 1467 1 1369 91 1441 22 2 OAI22S $T=247380 376880 1 180 $X=243660 $Y=376500
X3514 24 1 112 1715 183 34 2 OAI22S $T=288300 326480 0 180 $X=284580 $Y=321060
X3515 80 1 1944 118 1935 284 2 OAI22S $T=332320 346640 1 0 $X=332320 $Y=341220
X3516 547 1 533 543 2889 521 2 OAI22S $T=532580 336560 0 180 $X=528860 $Y=331140
X3517 606 1 3459 697 3454 695 2 OAI22S $T=614420 326480 0 180 $X=610700 $Y=321060
X3518 4713 1 4737 4734 4732 940 2 OAI22S $T=850020 376880 1 180 $X=846300 $Y=376500
X3519 1113 1 938 4880 4976 982 2 OAI22S $T=912640 356720 1 180 $X=908920 $Y=356340
X3520 1945 1 2 1959 DELB $T=333560 427280 1 0 $X=333560 $Y=421860
X3521 2053 1 2 2146 DELB $T=366420 417200 0 0 $X=366420 $Y=416820
X3522 2136 1 2 2180 DELB $T=373240 397040 0 0 $X=373240 $Y=396660
X3523 2284 1 2 2306 DELB $T=399900 497840 0 0 $X=399900 $Y=497460
X3524 2317 1 2 2348 DELB $T=406100 497840 1 0 $X=406100 $Y=492420
X3525 2338 1 2 2359 DELB $T=409200 497840 0 0 $X=409200 $Y=497460
X3526 2366 1 2 2388 DELB $T=414160 497840 0 0 $X=414160 $Y=497460
X3527 2370 1 2 2396 DELB $T=414780 518000 1 0 $X=414780 $Y=512580
X3528 2390 1 2 2401 DELB $T=419120 497840 0 0 $X=419120 $Y=497460
X3529 2395 1 2 2400 DELB $T=420980 477680 1 0 $X=420980 $Y=472260
X3530 2422 1 2 2440 DELB $T=425320 507920 1 0 $X=425320 $Y=502500
X3531 2444 1 2 2489 DELB $T=430280 507920 1 0 $X=430280 $Y=502500
X3532 2450 1 2 2483 DELB $T=432140 477680 1 0 $X=432140 $Y=472260
X3533 2426 1 2 394 DELB $T=434000 507920 0 0 $X=434000 $Y=507540
X3534 2466 1 2 2462 DELB $T=438960 507920 0 0 $X=438960 $Y=507540
X3535 2533 1 2 2521 DELB $T=444540 487760 1 0 $X=444540 $Y=482340
X3536 2527 1 2 410 DELB $T=445780 507920 0 0 $X=445780 $Y=507540
X3537 2570 1 2 2557 DELB $T=455080 487760 0 0 $X=455080 $Y=487380
X3538 2593 1 2 2595 DELB $T=460040 467600 1 0 $X=460040 $Y=462180
X3539 3153 1 2 3161 DELB $T=558620 417200 0 0 $X=558620 $Y=416820
X3540 3634 1 2 3650 DELB $T=642320 477680 1 0 $X=642320 $Y=472260
X3541 3635 1 2 3653 DELB $T=642940 497840 0 0 $X=642940 $Y=497460
X3542 3657 1 2 3663 DELB $T=647900 477680 0 0 $X=647900 $Y=477300
X3543 3660 1 2 3670 DELB $T=652860 477680 0 0 $X=652860 $Y=477300
X3544 3668 1 2 760 DELB $T=653480 518000 1 0 $X=653480 $Y=512580
X3545 3673 1 2 3708 DELB $T=657820 477680 0 0 $X=657820 $Y=477300
X3546 3701 1 2 3731 DELB $T=660920 437360 0 0 $X=660920 $Y=436980
X3547 3689 1 2 770 DELB $T=660920 507920 1 0 $X=660920 $Y=502500
X3548 3700 1 2 3703 DELB $T=662780 477680 0 0 $X=662780 $Y=477300
X3549 3735 1 2 3742 DELB $T=668360 507920 1 0 $X=668360 $Y=502500
X3550 3752 1 2 772 DELB $T=670220 518000 1 0 $X=670220 $Y=512580
X3551 3746 1 2 775 DELB $T=672700 518000 0 0 $X=672700 $Y=517620
X3552 3776 1 2 3744 DELB $T=673940 477680 0 0 $X=673940 $Y=477300
X3553 3790 1 2 3781 DELB $T=678900 477680 0 0 $X=678900 $Y=477300
X3554 4721 1 2 4726 DELB $T=846920 507920 1 0 $X=846920 $Y=502500
X3555 4974 1 2 4973 DELB $T=909540 407120 1 0 $X=909540 $Y=401700
X3556 5005 1 2 4859 DELB $T=921320 518000 0 0 $X=921320 $Y=517620
X3557 5014 1 2 5015 DELB $T=923180 386960 0 0 $X=923180 $Y=386580
X3558 5029 1 2 4863 DELB $T=925660 497840 0 0 $X=925660 $Y=497460
X3559 5043 1 2 1052 DELB $T=928140 518000 0 0 $X=928140 $Y=517620
X3560 5050 1 2 4869 DELB $T=929380 507920 1 0 $X=929380 $Y=502500
X3561 5041 1 2 4995 DELB $T=934960 417200 1 0 $X=934960 $Y=411780
X3562 5112 1 2 5128 DELB $T=939300 397040 0 0 $X=939300 $Y=396660
X3563 5103 1 2 5084 DELB $T=944880 427280 1 0 $X=944880 $Y=421860
X3564 5080 1 2 5126 DELB $T=946120 376880 1 0 $X=946120 $Y=371460
X3565 5070 1 2 5156 DELB $T=955420 447440 1 0 $X=955420 $Y=442020
X3566 5208 1 2 5187 DELB $T=958520 477680 1 0 $X=958520 $Y=472260
X3567 5225 1 2 5114 DELB $T=961620 447440 1 0 $X=961620 $Y=442020
X3568 5252 1 2 5206 DELB $T=972160 366800 1 0 $X=972160 $Y=361380
X3569 5192 1 2 5262 DELB $T=973400 336560 0 0 $X=973400 $Y=336180
X3570 5288 1 2 5205 DELB $T=974640 376880 1 0 $X=974640 $Y=371460
X3571 5237 1 2 5255 DELB $T=982700 457520 1 0 $X=982700 $Y=452100
X3572 5315 1 2 5332 DELB $T=983320 417200 1 0 $X=983320 $Y=411780
X3573 5316 1 2 5317 DELB $T=984560 427280 1 0 $X=984560 $Y=421860
X3574 5340 1 2 5292 DELB $T=991380 346640 1 0 $X=991380 $Y=341220
X3575 4972 1 2 4974 BUF1CK $T=908920 427280 1 0 $X=908920 $Y=421860
X3576 4995 1 2 5001 BUF1CK $T=916980 417200 1 0 $X=916980 $Y=411780
X3577 5022 1 2 5014 BUF1CK $T=923800 397040 0 0 $X=923800 $Y=396660
X3578 5095 1 2 5103 BUF1CK $T=934960 427280 1 0 $X=934960 $Y=421860
X3579 5126 1 2 5135 BUF1CK $T=942400 366800 1 0 $X=942400 $Y=361380
X3580 5104 1 2 5112 BUF1CK $T=944880 397040 1 0 $X=944880 $Y=391620
X3581 5156 1 2 5146 BUF1CK $T=947360 447440 1 0 $X=947360 $Y=442020
X3582 5206 1 2 5184 BUF1CK $T=957900 356720 0 0 $X=957900 $Y=356340
X3583 5226 1 2 5237 BUF1CK $T=961000 457520 1 0 $X=961000 $Y=452100
X3584 5200 1 2 5208 BUF1CK $T=963480 467600 0 0 $X=963480 $Y=467220
X3585 5262 1 2 5266 BUF1CK $T=968440 336560 0 0 $X=968440 $Y=336180
X3586 5224 1 2 5225 BUF1CK $T=969060 437360 1 0 $X=969060 $Y=431940
X3587 5289 1 2 5288 BUF1CK $T=974020 356720 1 0 $X=974020 $Y=351300
X3588 5286 1 2 5316 BUF1CK $T=980840 437360 1 0 $X=980840 $Y=431940
X3589 5298 1 2 5340 BUF1CK $T=986420 336560 0 0 $X=986420 $Y=336180
X3590 5359 1 2 5315 BUF1CK $T=992000 417200 1 0 $X=992000 $Y=411780
X3591 1589 1662 2 1671 1555 1 OR3B2 $T=275900 386960 0 0 $X=275900 $Y=386580
X3592 3231 3247 2 3263 650 1 OR3B2 $T=574740 427280 1 0 $X=574740 $Y=421860
X3593 3253 3203 2 658 3056 1 OR3B2 $T=577220 356720 0 0 $X=577220 $Y=356340
X3594 4464 4344 2 4498 3879 1 OR3B2 $T=802280 467600 1 0 $X=802280 $Y=462180
X3595 4920 962 2 4745 4938 1 OR3B2 $T=896520 346640 0 0 $X=896520 $Y=346260
X3596 32 1497 2 1510 1530 1 AOI12H $T=252340 407120 0 0 $X=252340 $Y=406740
X3597 4614 4621 2 4640 4577 1 AOI12H $T=824600 467600 1 0 $X=824600 $Y=462180
X3598 8 13 1 1319 1315 1372 2 OAI112HS $T=221340 336560 0 0 $X=221340 $Y=336180
X3599 14 1303 1 1323 1324 1347 2 OAI112HS $T=222580 356720 0 0 $X=222580 $Y=356340
X3600 21 19 1 73 1432 1447 2 OAI112HS $T=236840 356720 0 0 $X=236840 $Y=356340
X3601 98 103 1 1484 1439 1502 2 OAI112HS $T=247380 336560 0 0 $X=247380 $Y=336180
X3602 1369 268 1 1874 1921 1899 2 OAI112HS $T=326740 356720 0 0 $X=326740 $Y=356340
X3603 280 1961 1 1926 1912 257 2 OAI112HS $T=340380 376880 1 180 $X=336040 $Y=376500
X3604 1961 283 1 2028 2049 2037 2 OAI112HS $T=349060 366800 0 0 $X=349060 $Y=366420
X3605 285 2011 1 2036 2040 2065 2 OAI112HS $T=350300 326480 0 0 $X=350300 $Y=326100
X3606 518 2941 1 2956 529 2975 2 OAI112HS $T=522660 326480 0 0 $X=522660 $Y=326100
X3607 532 522 1 542 2998 544 2 OAI112HS $T=526380 326480 1 0 $X=526380 $Y=321060
X3608 533 692 1 3453 3456 3455 2 OAI112HS $T=608840 366800 1 0 $X=608840 $Y=361380
X3609 710 3520 1 3466 3438 3425 2 OAI112HS $T=626820 366800 1 180 $X=622480 $Y=366420
X3610 3520 283 1 3620 3615 3614 2 OAI112HS $T=642940 366800 0 180 $X=638600 $Y=361380
X3611 712 3597 1 3629 3626 3637 2 OAI112HS $T=639220 336560 1 0 $X=639220 $Y=331140
X3612 4783 4767 1 4759 4749 4753 2 OAI112HS $T=855600 376880 0 180 $X=851260 $Y=371460
X3613 4963 968 1 1109 4935 1115 2 OAI112HS $T=907060 326480 0 0 $X=907060 $Y=326100
X3614 4815 4717 4793 4767 4802 4765 2 1 4705 OA222S $T=865520 376880 1 180 $X=859940 $Y=376500
X3615 922 1031 4810 1035 949 1041 2 1 4858 OA222S $T=871720 326480 0 0 $X=871720 $Y=326100
X3616 4815 4801 4808 4877 4874 1063 2 1 4855 OA222S $T=880400 356720 1 0 $X=880400 $Y=351300
X3617 1298 1310 1 14 30 1367 2 MOAI1S $T=226920 336560 1 0 $X=226920 $Y=331140
X3618 1296 1390 1 63 13 1419 2 MOAI1S $T=234980 346640 0 0 $X=234980 $Y=346260
X3619 89 116 1 1491 1470 1339 2 MOAI1S $T=252960 346640 1 180 $X=249240 $Y=346260
X3620 1298 1504 1 1491 1494 1422 2 MOAI1S $T=253580 376880 0 180 $X=249860 $Y=371460
X3621 1537 1525 1 1520 1491 1513 2 MOAI1S $T=257920 386960 1 180 $X=254200 $Y=386580
X3622 139 140 1 1567 1482 1542 2 MOAI1S $T=264120 346640 1 180 $X=260400 $Y=346260
X3623 1390 1570 1 120 35 1593 2 MOAI1S $T=262260 346640 1 0 $X=262260 $Y=341220
X3624 1398 1524 1 1599 95 1549 2 MOAI1S $T=264740 356720 1 0 $X=264740 $Y=351300
X3625 1594 70 1 1619 1491 167 2 MOAI1S $T=273420 366800 0 0 $X=273420 $Y=366420
X3626 146 175 1 111 104 1696 2 MOAI1S $T=279620 326480 0 0 $X=279620 $Y=326100
X3627 1298 1504 1 1467 108 1705 2 MOAI1S $T=280240 346640 1 0 $X=280240 $Y=341220
X3628 191 139 1 1698 52 1713 2 MOAI1S $T=288920 346640 1 180 $X=285200 $Y=346260
X3629 89 116 1 60 1788 1850 2 MOAI1S $T=311240 336560 0 0 $X=311240 $Y=336180
X3630 1905 1943 1 1887 282 1929 2 MOAI1S $T=332320 366800 1 0 $X=332320 $Y=361380
X3631 1963 1912 1 286 1895 1991 2 MOAI1S $T=340380 376880 1 0 $X=340380 $Y=371460
X3632 2056 287 1 304 2044 2035 2 MOAI1S $T=355880 346640 1 0 $X=355880 $Y=341220
X3633 2005 283 1 2044 1955 2032 2 MOAI1S $T=361460 356720 0 180 $X=357740 $Y=351300
X3634 2332 1869 1 350 1869 2252 2 MOAI1S $T=407340 487760 1 180 $X=403620 $Y=487380
X3635 541 573 1 547 569 562 2 MOAI1S $T=541260 326480 1 180 $X=537540 $Y=326100
X3636 541 573 1 568 3074 3004 2 MOAI1S $T=542500 346640 0 0 $X=542500 $Y=346260
X3637 590 593 1 3036 568 506 2 MOAI1S $T=549320 346640 0 180 $X=545600 $Y=341220
X3638 610 3151 1 3142 568 2947 2 MOAI1S $T=556760 346640 0 180 $X=553040 $Y=341220
X3639 633 635 1 568 638 639 2 MOAI1S $T=569160 326480 1 0 $X=569160 $Y=321060
X3640 3295 605 1 3275 619 657 2 MOAI1S $T=583420 326480 0 180 $X=579700 $Y=321060
X3641 633 635 1 545 3289 3334 2 MOAI1S $T=587760 326480 1 0 $X=587760 $Y=321060
X3642 3476 3503 1 3401 705 3475 2 MOAI1S $T=620000 356720 0 180 $X=616280 $Y=351300
X3643 3528 3438 1 3519 3448 3542 2 MOAI1S $T=622480 366800 1 0 $X=622480 $Y=361380
X3644 2005 283 1 3598 3540 3572 2 MOAI1S $T=637980 356720 0 180 $X=634260 $Y=351300
X3645 3639 727 1 736 3598 3625 2 MOAI1S $T=644180 356720 0 180 $X=640460 $Y=351300
X3646 3681 641 1 737 641 3586 2 MOAI1S $T=655960 457520 0 180 $X=652240 $Y=452100
X3647 4629 4636 1 4631 4636 4650 2 MOAI1S $T=828940 386960 1 0 $X=828940 $Y=381540
X3648 4681 4636 1 4620 4636 4707 2 MOAI1S $T=838860 386960 0 0 $X=838860 $Y=386580
X3649 4701 947 1 283 4712 4706 2 MOAI1S $T=841340 366800 1 0 $X=841340 $Y=361380
X3650 4711 4636 1 4659 4636 4746 2 MOAI1S $T=846300 397040 1 0 $X=846300 $Y=391620
X3651 4727 966 1 4736 963 948 2 MOAI1S $T=850640 336560 0 180 $X=846920 $Y=331140
X3652 970 4745 1 963 964 4731 2 MOAI1S $T=850640 346640 1 180 $X=846920 $Y=346260
X3653 989 4760 1 985 983 4676 2 MOAI1S $T=856840 326480 0 180 $X=853120 $Y=321060
X3654 917 993 1 4801 999 4771 2 MOAI1S $T=858080 336560 0 0 $X=858080 $Y=336180
X3655 988 4794 1 4803 918 4814 2 MOAI1S $T=858700 356720 1 0 $X=858700 $Y=351300
X3656 4821 3519 1 4766 4717 4799 2 MOAI1S $T=862420 386960 1 180 $X=858700 $Y=386580
X3657 4821 4819 1 4717 4815 4780 2 MOAI1S $T=866140 386960 0 180 $X=862420 $Y=381540
X3658 1029 1026 1 931 1021 4823 2 MOAI1S $T=871720 326480 1 180 $X=868000 $Y=326100
X3659 989 4760 1 1046 928 4986 2 MOAI1S $T=912020 336560 1 0 $X=912020 $Y=331140
X3660 1082 1102 1 1010 952 4990 2 MOAI1S $T=918840 346640 0 180 $X=915120 $Y=341220
X3661 1073 1099 1 925 1025 4997 2 MOAI1S $T=915740 336560 1 0 $X=915740 $Y=331140
X3662 1144 1055 1 938 1148 5111 2 MOAI1S $T=936200 326480 1 0 $X=936200 $Y=321060
X3663 1566 124 1 155 1627 2 159 1634 43 OAI222S $T=269080 326480 1 0 $X=269080 $Y=321060
X3664 152 99 1 1623 60 2 158 1480 1627 OAI222S $T=269080 356720 0 0 $X=269080 $Y=356340
X3665 1697 60 1 1607 24 2 93 1674 1494 OAI222S $T=283960 376880 0 180 $X=278380 $Y=371460
X3666 1491 1391 1 1758 93 2 1777 1770 60 OAI222S $T=293260 386960 1 0 $X=293260 $Y=381540
X3667 14 95 1 1482 44 2 158 1772 1627 OAI222S $T=303800 346640 0 0 $X=303800 $Y=346260
X3668 154 44 1 209 31 2 1369 1836 1482 OAI222S $T=307520 336560 1 0 $X=307520 $Y=331140
X3669 1841 108 1 1653 1712 2 1835 1839 1710 OAI222S $T=315580 366800 0 180 $X=310000 $Y=361380
X3670 1369 231 1 1599 249 2 257 1847 44 OAI222S $T=315580 376880 1 0 $X=315580 $Y=371460
X3671 1603 1909 1 1902 103 2 1928 1914 22 OAI222S $T=327360 366800 0 0 $X=327360 $Y=366420
X3672 615 616 1 3159 545 2 620 2959 622 OAI222S $T=558000 336560 0 0 $X=558000 $Y=336180
X3673 568 2942 1 3178 520 2 3183 3170 545 OAI222S $T=559240 366800 1 0 $X=559240 $Y=361380
X3674 518 619 1 578 548 2 620 3182 622 OAI222S $T=560480 336560 1 0 $X=560480 $Y=331140
X3675 3225 545 1 3218 539 2 520 632 3074 OAI222S $T=572880 346640 1 180 $X=567300 $Y=346260
X3676 3369 569 1 3337 3323 2 3356 3362 3326 OAI222S $T=598920 346640 1 180 $X=593340 $Y=346260
X3677 677 548 1 678 511 2 533 3353 578 OAI222S $T=594580 326480 1 0 $X=594580 $Y=321060
X3678 533 684 1 3275 685 2 3425 3394 548 OAI222S $T=603880 346640 0 0 $X=603880 $Y=346260
X3679 3300 3419 1 3437 675 2 3447 3462 521 OAI222S $T=606360 356720 1 0 $X=606360 $Y=351300
X3680 931 971 1 925 965 2 942 4735 961 OAI222S $T=852500 326480 0 180 $X=846920 $Y=321060
X3681 4791 4810 1 4808 4789 2 283 4762 4792 OAI222S $T=864280 366800 0 180 $X=858700 $Y=361380
X3682 1014 934 1 925 965 2 961 4816 916 OAI222S $T=866140 326480 0 180 $X=860560 $Y=321060
X3683 1014 946 1 1010 942 2 983 4818 1003 OAI222S $T=867380 336560 0 180 $X=861800 $Y=331140
X3684 1046 946 1 982 1053 2 952 1019 964 OAI222S $T=877920 326480 1 0 $X=877920 $Y=321060
X3685 4879 952 1 1071 931 2 4888 4861 982 OAI222S $T=892800 356720 0 180 $X=887220 $Y=351300
X3686 1348 1304 1364 2 1 XNR2HS $T=226300 447440 1 0 $X=226300 $Y=442020
X3687 1341 1311 1396 2 1 XNR2HS $T=237460 437360 1 0 $X=237460 $Y=431940
X3688 1478 1471 1497 2 1 XNR2HS $T=247380 427280 1 0 $X=247380 $Y=421860
X3689 142 1579 1559 2 1 XNR2HS $T=264740 397040 0 180 $X=259160 $Y=391620
X3690 156 1579 1644 2 1 XNR2HS $T=270940 397040 0 0 $X=270940 $Y=396660
X3691 1779 1725 1721 2 1 XNR2HS $T=298220 427280 1 180 $X=292640 $Y=426900
X3692 1863 1579 1857 2 1 XNR2HS $T=321780 397040 0 180 $X=316200 $Y=391620
X3693 2869 2820 2904 2 1 XNR2HS $T=512740 417200 1 0 $X=512740 $Y=411780
X3694 2863 2829 2906 2 1 XNR2HS $T=513980 427280 1 0 $X=513980 $Y=421860
X3695 564 3022 3007 2 1 XNR2HS $T=538160 376880 1 180 $X=532580 $Y=376500
X3696 617 3022 3148 2 1 XNR2HS $T=561100 376880 1 180 $X=555520 $Y=376500
X3697 629 3022 3144 2 1 XNR2HS $T=567920 376880 0 180 $X=562340 $Y=371460
X3698 3273 3314 3303 2 1 XNR2HS $T=589000 417200 0 180 $X=583420 $Y=411780
X3699 3309 3340 3338 2 1 XNR2HS $T=593340 427280 1 0 $X=593340 $Y=421860
X3700 3378 3381 3434 2 1 XNR2HS $T=605740 417200 0 0 $X=605740 $Y=416820
X3701 3471 3504 3518 2 1 XNR2HS $T=617520 417200 0 0 $X=617520 $Y=416820
X3702 3745 3749 3764 2 1 XNR2HS $T=668360 477680 0 0 $X=668360 $Y=477300
X3703 4049 4053 4059 2 1 XNR2HS $T=719200 427280 1 0 $X=719200 $Y=421860
X3704 4487 4578 4605 2 1 XNR2HS $T=819640 467600 0 0 $X=819640 $Y=467220
X3705 4511 4484 4609 2 1 XNR2HS $T=820880 477680 1 0 $X=820880 $Y=472260
X3706 4661 4583 4621 2 1 XNR2HS $T=833900 457520 1 0 $X=833900 $Y=452100
X3707 4645 4598 4703 2 1 XNR2HS $T=838240 447440 0 0 $X=838240 $Y=447060
X3708 4742 4708 4714 2 1 XNR2HS $T=850020 407120 0 180 $X=844440 $Y=401700
X3709 4781 4708 4729 2 1 XNR2HS $T=856840 407120 0 180 $X=851260 $Y=401700
X3710 4788 4708 4748 2 1 XNR2HS $T=858080 397040 1 180 $X=852500 $Y=396660
X3711 4739 4545 4784 2 1 XNR2HS $T=863660 437360 0 0 $X=863660 $Y=436980
X3712 23 1303 30 14 35 41 1 2 1381 OA222 $T=227540 356720 1 0 $X=227540 $Y=351300
X3713 52 48 43 37 34 21 1 2 1355 OA222 $T=234360 326480 1 180 $X=228780 $Y=326100
X3714 60 1391 34 22 30 1369 1 2 1356 OA222 $T=235600 366800 1 180 $X=230020 $Y=366420
X3715 80 1414 30 1346 13 64 1 2 1401 OA222 $T=241180 326480 1 180 $X=235600 $Y=326100
X3716 93 1470 80 48 99 105 1 2 1484 OA222 $T=244900 346640 1 0 $X=244900 $Y=341220
X3717 1494 60 1496 93 24 91 1 2 101 OA222 $T=253580 386960 0 180 $X=248000 $Y=381540
X3718 115 118 108 122 123 13 1 2 1531 OA222 $T=251720 326480 1 0 $X=251720 $Y=321060
X3719 1555 1491 1467 1659 172 176 1 2 1670 OA222 $T=276520 336560 0 0 $X=276520 $Y=336180
X3720 1716 60 104 1698 44 1607 1 2 174 OA222 $T=285200 366800 1 180 $X=279620 $Y=366420
X3721 1482 14 91 1715 95 1729 1 2 197 OA222 $T=285200 336560 0 0 $X=285200 $Y=336180
X3722 186 91 34 104 1391 93 1 2 1738 OA222 $T=286440 346640 1 0 $X=286440 $Y=341220
X3723 21 1467 1555 93 1496 1491 1 2 1774 OA222 $T=292020 356720 0 0 $X=292020 $Y=356340
X3724 208 13 1391 1491 52 1467 1 2 219 OA222 $T=295120 326480 1 0 $X=295120 $Y=321060
X3725 93 1505 99 158 1637 60 1 2 179 OA222 $T=302560 356720 1 0 $X=302560 $Y=351300
X3726 1467 223 93 1810 1491 1809 1 2 230 OA222 $T=302560 356720 0 0 $X=302560 $Y=356340
X3727 98 223 41 1756 24 209 1 2 1641 OA222 $T=309380 336560 1 180 $X=303800 $Y=336180
X3728 95 1369 1491 188 235 237 1 2 240 OA222 $T=306900 326480 0 0 $X=306900 $Y=326100
X3729 24 91 1482 22 30 21 1 2 259 OA222 $T=315580 336560 1 0 $X=315580 $Y=331140
X3730 208 13 44 91 123 99 1 2 1853 OA222 $T=326740 326480 1 180 $X=321160 $Y=326100
X3731 1842 1867 13 267 223 1876 1 2 1924 OA222 $T=325500 346640 1 0 $X=325500 $Y=341220
X3732 514 2941 516 518 517 513 1 2 510 OA222 $T=525140 336560 0 180 $X=519560 $Y=331140
X3733 545 2942 537 521 516 533 1 2 488 OA222 $T=530720 336560 1 180 $X=525140 $Y=336180
X3734 554 543 537 563 2942 520 1 2 3042 OA222 $T=534440 346640 1 0 $X=534440 $Y=341220
X3735 575 571 2942 568 566 547 1 2 557 OA222 $T=541260 326480 0 180 $X=535680 $Y=321060
X3736 547 572 520 3029 568 3026 1 2 559 OA222 $T=541260 356720 0 180 $X=535680 $Y=351300
X3737 3056 568 547 3069 583 586 1 2 598 OA222 $T=541880 326480 1 0 $X=541880 $Y=321060
X3738 532 547 3056 520 3140 568 1 2 3121 OA222 $T=557380 346640 1 180 $X=551800 $Y=346260
X3739 520 3097 616 620 3169 545 1 2 512 OA222 $T=564820 346640 0 180 $X=559240 $Y=341220
X3740 3074 545 3140 520 539 543 1 2 625 OA222 $T=559240 356720 1 0 $X=559240 $Y=351300
X3741 3147 545 563 651 548 3218 1 2 643 OA222 $T=578460 326480 1 180 $X=572880 $Y=326100
X3742 3345 3366 571 707 572 3422 1 2 3482 OA222 $T=621860 336560 0 180 $X=616280 $Y=331140
X3743 4737 1015 4824 4826 937 1022 1 2 4836 OA222 $T=864900 346640 1 0 $X=864900 $Y=341220
X3744 958 4828 969 4832 936 4837 1 2 4827 OA222 $T=866760 356720 0 0 $X=866760 $Y=356340
X3745 933 1025 964 4840 913 950 1 2 957 OA222 $T=868620 326480 1 0 $X=868620 $Y=321060
X3746 934 1046 1045 983 4880 982 1 2 1070 OA222 $T=880400 336560 1 0 $X=880400 $Y=331140
X3747 929 1010 1025 1035 952 1062 1 2 4634 OA222 $T=888460 326480 1 180 $X=882880 $Y=326100
X3748 971 1035 4886 968 964 1076 1 2 1079 OA222 $T=886600 326480 1 0 $X=886600 $Y=321060
X3749 956 4901 4878 4913 4887 4921 1 2 4831 OA222 $T=892800 356720 1 0 $X=892800 $Y=351300
X3750 1014 956 934 1090 1053 949 1 2 1095 OA222 $T=896520 336560 0 0 $X=896520 $Y=336180
X3751 4694 5092 1046 5131 999 5121 1 2 1158 OA222 $T=941780 336560 0 0 $X=941780 $Y=336180
X3752 1021 4840 1014 956 971 931 1 2 1160 OA222 $T=944260 336560 1 0 $X=944260 $Y=331140
X3753 1761 1750 2 1 1802 OR2S $T=301320 447440 1 0 $X=301320 $Y=442020
X3754 228 1886 2 1 1913 OR2S $T=323020 487760 1 0 $X=323020 $Y=482340
X3755 2801 2778 2 1 2862 OR2S $T=505300 417200 1 0 $X=505300 $Y=411780
X3756 3145 3373 2 1 3396 OR2S $T=598920 447440 1 0 $X=598920 $Y=442020
X3757 918 913 2 1 4996 OR2S $T=915740 356720 1 0 $X=915740 $Y=351300
X3758 1417 1374 2 1 1468 OR2 $T=242420 437360 0 0 $X=242420 $Y=436980
X3759 42 1457 2 1 1442 OR2 $T=245520 477680 0 180 $X=243040 $Y=472260
X3760 1481 1478 2 1 1454 OR2 $T=254200 437360 1 0 $X=254200 $Y=431940
X3761 132 1736 2 1 1750 OR2 $T=289540 467600 1 0 $X=289540 $Y=462180
X3762 249 1744 2 1 95 OR2 $T=319920 366800 1 0 $X=319920 $Y=361380
X3763 254 1744 2 1 41 OR2 $T=322400 366800 1 180 $X=319920 $Y=366420
X3764 228 1871 2 1 1875 OR2 $T=319920 487760 1 0 $X=319920 $Y=482340
X3765 228 1871 2 1 1962 OR2 $T=341000 487760 0 180 $X=338520 $Y=482340
X3766 300 290 2 1 2055 OR2 $T=361460 397040 0 180 $X=358980 $Y=391620
X3767 416 2778 2 1 2770 OR2 $T=491660 417200 0 0 $X=491660 $Y=416820
X3768 401 407 2 1 2778 OR2 $T=495380 417200 0 0 $X=495380 $Y=416820
X3769 536 540 2 1 2925 OR2 $T=527620 427280 0 0 $X=527620 $Y=426900
X3770 3145 3382 2 1 3411 OR2 $T=598920 457520 1 0 $X=598920 $Y=452100
X3771 685 3331 2 1 619 OR2 $T=605120 336560 0 180 $X=602640 $Y=331140
X3772 683 3331 2 1 513 OR2 $T=604500 336560 0 0 $X=604500 $Y=336180
X3773 300 290 2 1 3619 OR2 $T=642320 386960 1 180 $X=639840 $Y=386580
X3774 300 290 2 1 4630 OR2 $T=823980 397040 1 0 $X=823980 $Y=391620
X3775 938 918 2 1 983 OR2 $T=861800 336560 0 180 $X=859320 $Y=331140
X3776 4872 4849 2 1 4865 OR2 $T=879780 376880 1 180 $X=877300 $Y=376500
X3777 4878 1030 2 1 964 OR2 $T=888460 346640 1 0 $X=888460 $Y=341220
X3778 4821 4874 2 1 1091 OR2 $T=893420 336560 1 0 $X=893420 $Y=331140
X3779 4 1 1377 1371 1412 2 ND3S $T=231260 386960 0 0 $X=231260 $Y=386580
X3780 515 1 2943 2928 2951 2 ND3S $T=522660 356720 0 0 $X=522660 $Y=356340
X3781 907 1 4626 4603 4634 2 ND3S $T=827080 336560 0 0 $X=827080 $Y=336180
X3782 4656 1 4655 4628 4647 2 ND3S $T=833900 326480 0 180 $X=831420 $Y=321060
X3783 940 1 4695 4708 4636 2 ND3S $T=839480 407120 1 0 $X=839480 $Y=401700
X3784 4879 1 4885 4902 4887 2 ND3S $T=891560 346640 0 0 $X=891560 $Y=346260
X3785 4960 1 1053 4952 1104 2 ND3S $T=905820 336560 1 0 $X=905820 $Y=331140
X3786 1333 1344 20 2 1 1359 AN3 $T=225060 457520 0 0 $X=225060 $Y=457140
X3787 1355 1358 1362 2 1 1372 AN3 $T=228160 356720 0 0 $X=228160 $Y=356340
X3788 1352 47 1381 2 1 57 AN3 $T=231260 336560 1 0 $X=231260 $Y=331140
X3789 84 1326 76 2 1 1425 AN3 $T=242420 346640 0 180 $X=238700 $Y=341220
X3790 1455 1466 1473 2 1 40 AN3 $T=244900 366800 1 0 $X=244900 $Y=361380
X3791 1588 1575 1528 2 1 134 AN3 $T=264740 336560 1 180 $X=261020 $Y=336180
X3792 2015 280 1997 2 1 2002 AN3 $T=349680 336560 1 180 $X=345960 $Y=336180
X3793 509 2915 2887 2 1 504 AN3 $T=519560 336560 0 180 $X=515840 $Y=331140
X3794 2973 3058 3061 2 1 582 AN3 $T=541260 336560 1 0 $X=541260 $Y=331140
X3795 3027 3023 602 2 1 3098 AN3 $T=557380 437360 0 0 $X=557380 $Y=436980
X3796 3568 710 3555 2 1 3550 AN3 $T=631780 346640 0 180 $X=628060 $Y=341220
X3797 4415 4556 4514 2 1 4577 AN3 $T=812200 447440 1 0 $X=812200 $Y=442020
X3798 4797 4809 4813 2 1 1009 AN3 $T=861180 326480 0 0 $X=861180 $Y=326100
X3799 1071 4879 4874 2 1 4896 AN3 $T=887220 366800 1 0 $X=887220 $Y=361380
X3800 1315 2 1324 1332 18 1 NR3 $T=223200 336560 1 0 $X=223200 $Y=331140
X3801 25 2 1339 1368 1373 1 NR3 $T=228160 346640 0 0 $X=228160 $Y=346260
X3802 1432 2 1422 1419 1415 1 NR3 $T=240560 366800 0 180 $X=237460 $Y=361380
X3803 1480 2 109 1513 1412 1 NR3 $T=248620 386960 0 0 $X=248620 $Y=386580
X3804 1554 2 1544 1469 1535 1 NR3 $T=260400 336560 1 180 $X=257300 $Y=336180
X3805 1674 2 178 1713 1620 1 NR3 $T=281480 346640 0 0 $X=281480 $Y=346260
X3806 1760 2 1332 1696 1746 1 NR3 $T=295120 336560 1 180 $X=292020 $Y=336180
X3807 1791 2 1735 1727 1777 1 NR3 $T=297600 397040 0 180 $X=294500 $Y=391620
X3808 211 2 1772 1770 1763 1 NR3 $T=298220 346640 1 180 $X=295120 $Y=346260
X3809 220 2 1705 1593 1800 1 NR3 $T=303180 346640 0 180 $X=300080 $Y=341220
X3810 218 2 1799 1634 1803 1 NR3 $T=301320 326480 1 0 $X=301320 $Y=321060
X3811 1668 2 1785 229 1824 1 NR3 $T=305660 346640 1 0 $X=305660 $Y=341220
X3812 1751 2 1804 1814 1810 1 NR3 $T=306900 397040 1 0 $X=306900 $Y=391620
X3813 1767 2 1428 1837 1845 1 NR3 $T=310620 356720 0 0 $X=310620 $Y=356340
X3814 2959 2 524 2947 2951 1 NR3 $T=526380 346640 0 180 $X=523280 $Y=341220
X3815 2998 2 3004 552 549 1 NR3 $T=531960 326480 1 0 $X=531960 $Y=321060
X3816 3089 2 3064 3065 3029 1 NR3 $T=541880 366800 0 0 $X=541880 $Y=366420
X3817 624 2 3182 3170 2901 1 NR3 $T=564820 326480 1 180 $X=561720 $Y=326100
X3818 3222 2 3195 3230 3183 1 NR3 $T=570400 376880 1 0 $X=570400 $Y=371460
X3819 2780 2 2756 469 3236 1 NR3 $T=586520 437360 1 180 $X=583420 $Y=436980
X3820 3355 2 538 3360 3385 1 NR3 $T=596440 346640 1 0 $X=596440 $Y=341220
X3821 4771 2 981 4761 4626 1 NR3 $T=854980 346640 1 180 $X=851880 $Y=346260
X3822 1066 2 966 1083 1163 1 NR3 $T=947980 326480 0 180 $X=944880 $Y=321060
X3823 281 2028 268 306 2 234 1 AOI13HS $T=352780 376880 0 180 $X=349060 $Y=371460
X3824 272 2036 2035 286 2 89 1 AOI13HS $T=354020 336560 1 180 $X=350300 $Y=336180
X3825 726 3629 3625 3519 2 633 1 AOI13HS $T=641080 336560 0 0 $X=641080 $Y=336180
X3826 713 3620 692 741 2 671 1 AOI13HS $T=643560 356720 0 0 $X=643560 $Y=356340
X3827 4725 4712 4701 4734 2 4738 1 AOI13HS $T=845680 366800 1 0 $X=845680 $Y=361380
X3828 4795 4756 3519 283 2 973 1 AOI13HS $T=858080 366800 0 0 $X=858080 $Y=366420
X3829 841 812 4582 1 2 OR2P $T=809100 427280 1 0 $X=809100 $Y=421860
X3830 1374 2 1406 1 1341 NR2P $T=236220 437360 0 0 $X=236220 $Y=436980
X3831 1374 2 1379 1 1353 NR2P $T=238700 447440 1 0 $X=238700 $Y=442020
X3832 1468 2 1457 1 1481 NR2P $T=245520 437360 0 0 $X=245520 $Y=436980
X3833 1750 2 1741 1 1693 NR2P $T=290780 457520 1 0 $X=290780 $Y=452100
X3834 1750 2 1781 1 1703 NR2P $T=295120 467600 1 0 $X=295120 $Y=462180
X3835 1802 2 1813 1 1699 NR2P $T=305040 457520 1 0 $X=305040 $Y=452100
X3836 144 2 246 1 1499 NR2P $T=313720 477680 0 0 $X=313720 $Y=477300
X3837 1942 2 1871 1 1866 NR2P $T=334180 477680 0 0 $X=334180 $Y=477300
X3838 2006 2 1871 1 1947 NR2P $T=355260 487760 0 0 $X=355260 $Y=487380
X3839 2418 2 136 1 369 NR2P $T=430280 326480 0 0 $X=430280 $Y=326100
X3840 2778 2 2775 1 2820 NR2P $T=499720 427280 0 180 $X=496000 $Y=421860
X3841 2778 2 2801 1 2840 NR2P $T=500960 417200 0 180 $X=497240 $Y=411780
X3842 2808 2 2778 1 2844 NR2P $T=497860 437360 1 0 $X=497860 $Y=431940
X3843 3079 2 2925 1 3030 NR2P $T=554900 417200 0 0 $X=554900 $Y=416820
X3844 3273 2 3280 1 3309 NR2P $T=587760 427280 1 0 $X=587760 $Y=421860
X3845 715 2 717 1 3519 NR2P $T=623100 397040 1 0 $X=623100 $Y=391620
X3846 728 2 717 1 2005 NR2P $T=628060 397040 0 0 $X=628060 $Y=396660
X3847 4051 2 136 1 872 NR2P $T=775000 326480 1 0 $X=775000 $Y=321060
X3848 4055 2 469 1 4374 NR2P $T=783680 447440 0 0 $X=783680 $Y=447060
X3849 4464 2 4434 1 4487 NR2P $T=799180 467600 0 180 $X=795460 $Y=462180
X3850 4582 2 4459 1 4649 NR2P $T=819640 437360 0 180 $X=815920 $Y=431940
X3851 4582 2 4540 1 4600 NR2P $T=821500 447440 0 180 $X=817780 $Y=442020
X3852 4582 2 4495 1 4598 NR2P $T=822120 437360 1 180 $X=818400 $Y=436980
X3853 4885 2 4821 1 1067 NR2P $T=885360 336560 0 0 $X=885360 $Y=336180
X3854 1030 2 4879 1 1029 NR2P $T=891560 336560 0 0 $X=891560 $Y=336180
X3855 2055 2010 312 297 1 2 1919 OA13S $T=355880 397040 0 180 $X=351540 $Y=391620
X3856 3619 2010 3613 297 1 2 3428 OA13S $T=639220 386960 1 0 $X=639220 $Y=381540
X3857 1866 253 1 1864 1855 253 2 MOAI1 $T=321780 467600 1 180 $X=317440 $Y=467220
X3858 1916 1919 1 1930 268 1919 2 MOAI1 $T=328600 386960 1 0 $X=328600 $Y=381540
X3859 1968 1919 1 1956 234 1919 2 MOAI1 $T=340380 386960 0 180 $X=336040 $Y=381540
X3860 2010 1919 1 1994 263 1919 2 MOAI1 $T=347820 386960 1 180 $X=343480 $Y=386580
X3861 2001 1919 1 1960 304 1919 2 MOAI1 $T=347820 397040 0 180 $X=343480 $Y=391620
X3862 2051 1919 1 2024 306 1919 2 MOAI1 $T=354640 386960 1 180 $X=350300 $Y=386580
X3863 2792 2620 1 2882 2919 2620 2 MOAI1 $T=522660 407120 1 180 $X=518320 $Y=406740
X3864 3030 2984 1 3055 3091 2984 2 MOAI1 $T=541260 417200 1 0 $X=541260 $Y=411780
X3865 3487 3428 1 3460 671 3428 2 MOAI1 $T=615660 376880 0 180 $X=611320 $Y=371460
X3866 3541 3428 1 3514 692 3428 2 MOAI1 $T=624960 376880 0 0 $X=624960 $Y=376500
X3867 2010 3428 1 3592 676 3428 2 MOAI1 $T=631780 376880 1 0 $X=631780 $Y=371460
X3868 3581 3428 1 3558 736 3428 2 MOAI1 $T=631780 376880 0 0 $X=631780 $Y=376500
X3869 3622 3428 1 3611 741 3428 2 MOAI1 $T=646660 376880 0 180 $X=642320 $Y=371460
X3870 4600 4514 1 4661 4677 4514 2 MOAI1 $T=835140 447440 1 0 $X=835140 $Y=442020
X3871 779 4636 1 4724 4734 4636 2 MOAI1 $T=846300 386960 0 0 $X=846300 $Y=386580
X3872 4779 4636 1 4757 4766 4636 2 MOAI1 $T=856840 386960 1 180 $X=852500 $Y=386580
X3873 1320 12 1 1302 2 7 OAI12HS $T=224440 326480 0 180 $X=220720 $Y=321060
X3874 39 70 1 68 2 1423 OAI12HS $T=240560 366800 1 180 $X=236840 $Y=366420
X3875 2002 1904 1 1874 2 1979 OAI12HS $T=345960 356720 1 180 $X=342240 $Y=356340
X3876 596 593 1 530 2 3062 OAI12HS $T=549940 336560 0 180 $X=546220 $Y=331140
X3877 3550 722 1 3453 2 3544 OAI12HS $T=630540 366800 0 180 $X=626820 $Y=361380
X3878 4623 279 1 4635 2 4638 OAI12HS $T=827080 366800 1 0 $X=827080 $Y=361380
X3879 4638 4675 1 4680 2 4660 OAI12HS $T=835140 366800 1 0 $X=835140 $Y=361380
X3880 4638 4686 1 4680 2 4687 OAI12HS $T=837620 366800 0 0 $X=837620 $Y=366420
X3881 1371 1363 61 132 1 2 QDFFRBP $T=249860 417200 1 0 $X=249860 $Y=411780
X3882 1873 1363 61 228 1 2 QDFFRBP $T=321780 407120 0 180 $X=309380 $Y=401700
X3883 2618 217 61 2560 1 2 QDFFRBP $T=466860 477680 0 180 $X=454460 $Y=472260
X3884 4085 591 743 3760 1 2 QDFFRBP $T=724780 417200 0 180 $X=712380 $Y=411780
X3885 4628 906 743 841 1 2 QDFFRBP $T=825220 336560 0 180 $X=812820 $Y=331140
X3886 910 906 743 824 1 2 QDFFRBP $T=827700 326480 0 180 $X=815300 $Y=321060
X3887 1383 1541 1550 1 2 1553 MAO222 $T=256060 477680 1 0 $X=256060 $Y=472260
X3888 1430 1511 1463 1 2 1541 MAO222 $T=257920 467600 0 0 $X=257920 $Y=467220
X3889 1378 1568 1581 1 2 1560 MAO222 $T=259780 507920 0 0 $X=259780 $Y=507540
X3890 1822 1646 1827 1 2 1823 MAO222 $T=305660 427280 0 0 $X=305660 $Y=426900
X3891 1815 1823 1613 1 2 1865 MAO222 $T=305660 437360 0 0 $X=305660 $Y=436980
X3892 1825 1752 1830 1 2 1822 MAO222 $T=306280 427280 1 0 $X=306280 $Y=421860
X3893 1885 1882 1892 1 2 1888 MAO222 $T=321160 467600 1 0 $X=321160 $Y=462180
X3894 1872 1891 1877 1 2 1933 MAO222 $T=321780 447440 0 0 $X=321780 $Y=447060
X3895 1888 1855 1878 1 2 1891 MAO222 $T=321780 457520 0 0 $X=321780 $Y=457140
X3896 1672 1865 1906 1 2 1940 MAO222 $T=327360 437360 0 0 $X=327360 $Y=436980
X3897 1976 1986 1982 1 2 2079 MAO222 $T=341000 457520 0 0 $X=341000 $Y=457140
X3898 1993 1933 1985 1 2 1986 MAO222 $T=341620 457520 1 0 $X=341620 $Y=452100
X3899 2030 1940 1534 1 2 2043 MAO222 $T=350300 447440 1 0 $X=350300 $Y=442020
X3900 2007 2041 2014 1 2 2025 MAO222 $T=351540 417200 0 0 $X=351540 $Y=416820
X3901 2052 2043 1596 1 2 2070 MAO222 $T=352780 447440 0 0 $X=352780 $Y=447060
X3902 2045 2050 2063 1 2 2074 MAO222 $T=353400 376880 0 0 $X=353400 $Y=376500
X3903 2096 2079 2087 1 2 2114 MAO222 $T=360220 457520 0 0 $X=360220 $Y=457140
X3904 2077 2114 2128 1 2 2181 MAO222 $T=368900 467600 0 0 $X=368900 $Y=467220
X3905 2157 2151 1545 1 2 2152 MAO222 $T=370760 497840 1 0 $X=370760 $Y=492420
X3906 2202 2119 1580 1 2 2236 MAO222 $T=385020 477680 1 0 $X=385020 $Y=472260
X3907 2218 2236 1540 1 2 2151 MAO222 $T=386880 487760 0 0 $X=386880 $Y=487380
X3908 2130 2193 2252 1 2 2242 MAO222 $T=388120 497840 1 0 $X=388120 $Y=492420
X3909 2358 2362 2377 1 2 2308 MAO222 $T=415400 427280 0 0 $X=415400 $Y=426900
X3910 2482 2487 2494 1 2 2501 MAO222 $T=435240 467600 1 0 $X=435240 $Y=462180
X3911 2488 2502 2493 1 2 2509 MAO222 $T=437100 467600 0 0 $X=437100 $Y=467220
X3912 3157 2995 3168 1 2 3117 MAO222 $T=557380 407120 1 0 $X=557380 $Y=401700
X3913 3146 3181 2905 1 2 3188 MAO222 $T=559860 467600 0 0 $X=559860 $Y=467220
X3914 3152 3188 2893 1 2 3191 MAO222 $T=561720 477680 1 0 $X=561720 $Y=472260
X3915 3175 3191 2899 1 2 3186 MAO222 $T=562340 477680 0 0 $X=562340 $Y=477300
X3916 3185 3189 3184 1 2 3208 MAO222 $T=562960 437360 0 0 $X=562960 $Y=436980
X3917 3207 3155 2856 1 2 3160 MAO222 $T=564820 417200 0 0 $X=564820 $Y=416820
X3918 3110 3160 3107 1 2 3214 MAO222 $T=564820 427280 1 0 $X=564820 $Y=421860
X3919 3177 3214 2888 1 2 3189 MAO222 $T=565440 437360 1 0 $X=565440 $Y=431940
X3920 3250 3254 3262 1 2 3272 MAO222 $T=575980 397040 0 0 $X=575980 $Y=396660
X3921 3697 3687 3699 1 2 3728 MAO222 $T=660300 397040 1 0 $X=660300 $Y=391620
X3922 3718 3727 3717 1 2 3736 MAO222 $T=663400 366800 1 0 $X=663400 $Y=361380
X3923 3737 3736 3711 1 2 3724 MAO222 $T=665260 376880 0 0 $X=665260 $Y=376500
X3924 3697 3687 3699 1 2 3753 MAO222 $T=667120 397040 0 0 $X=667120 $Y=396660
X3925 3754 3751 3741 1 2 3772 MAO222 $T=668360 417200 1 0 $X=668360 $Y=411780
X3926 3743 3762 3707 1 2 3727 MAO222 $T=670840 356720 0 0 $X=670840 $Y=356340
X3927 3779 3772 3774 1 2 3773 MAO222 $T=672080 417200 0 0 $X=672080 $Y=416820
X3928 3780 3773 3765 1 2 3856 MAO222 $T=672080 427280 1 0 $X=672080 $Y=421860
X3929 3733 773 3675 1 2 3704 MAO222 $T=678900 326480 1 180 $X=673940 $Y=326100
X3930 3791 3787 3794 1 2 3810 MAO222 $T=674560 487760 0 0 $X=674560 $Y=487380
X3931 3733 773 3675 1 2 3823 MAO222 $T=678280 326480 1 0 $X=678280 $Y=321060
X3932 3871 3874 3856 1 2 3954 MAO222 $T=690060 427280 0 0 $X=690060 $Y=426900
X3933 4002 4009 4001 1 2 4037 MAO222 $T=711760 427280 1 0 $X=711760 $Y=421860
X3934 3939 3887 3954 1 2 3892 MAO222 $T=713620 397040 1 0 $X=713620 $Y=391620
X3935 4098 4095 4104 1 2 4096 MAO222 $T=725400 407120 1 0 $X=725400 $Y=401700
X3936 4099 4096 4105 1 2 4114 MAO222 $T=725400 407120 0 0 $X=725400 $Y=406740
X3937 4100 4114 4109 1 2 4126 MAO222 $T=727880 417200 1 0 $X=727880 $Y=411780
X3938 4108 4116 4107 1 2 833 MAO222 $T=728500 518000 1 0 $X=728500 $Y=512580
X3939 4121 4118 4126 1 2 4053 MAO222 $T=729120 427280 1 0 $X=729120 $Y=421860
X3940 4437 4429 4450 1 2 877 MAO222 $T=793600 518000 0 180 $X=788640 $Y=512580
X3941 4472 4468 4477 1 2 4429 MAO222 $T=796080 518000 1 0 $X=796080 $Y=512580
X3942 4563 4575 4558 1 2 4468 MAO222 $T=813440 518000 0 0 $X=813440 $Y=517620
X3943 4549 4591 4574 1 2 4575 MAO222 $T=815920 507920 0 0 $X=815920 $Y=507540
X3944 4596 4606 4613 1 2 4591 MAO222 $T=821500 507920 1 0 $X=821500 $Y=502500
X3945 4679 4702 4715 1 2 4710 MAO222 $T=841340 487760 0 0 $X=841340 $Y=487380
X3946 4679 4715 4702 1 2 4690 MAO222 $T=846920 477680 1 180 $X=841960 $Y=477300
X3947 4519 4770 4796 1 2 4774 MAO222 $T=854980 477680 1 0 $X=854980 $Y=472260
X3948 4751 1002 4730 1 2 4740 MAO222 $T=860560 487760 0 0 $X=860560 $Y=487380
X3949 1449 59 2 77 1 74 MUX2S $T=243660 518000 1 180 $X=239320 $Y=517620
X3950 1450 59 2 1449 1 82 MUX2S $T=247380 497840 1 180 $X=243040 $Y=497460
X3951 1462 42 2 94 1 92 MUX2S $T=249860 518000 1 180 $X=245520 $Y=517620
X3952 1509 128 2 113 1 102 MUX2S $T=254820 518000 0 180 $X=250480 $Y=512580
X3953 189 1708 2 1743 1 1685 MUX2S $T=287680 507920 1 0 $X=287680 $Y=502500
X3954 1740 204 2 201 1 190 MUX2S $T=296360 518000 1 180 $X=292020 $Y=517620
X3955 1794 204 2 212 1 195 MUX2S $T=301940 518000 1 180 $X=297600 $Y=517620
X3956 1798 215 2 1801 1 216 MUX2S $T=306900 507920 1 180 $X=302560 $Y=507540
X3957 1795 215 2 221 1 198 MUX2S $T=306900 518000 0 180 $X=302560 $Y=512580
X3958 1801 215 2 224 1 212 MUX2S $T=308140 518000 1 180 $X=303800 $Y=517620
X3959 1820 236 2 1826 1 1795 MUX2S $T=312480 507920 1 180 $X=308140 $Y=507540
X3960 1826 236 2 232 1 1801 MUX2S $T=312480 518000 0 180 $X=308140 $Y=512580
X3961 1859 210 2 1844 1 1881 MUX2S $T=318060 507920 0 0 $X=318060 $Y=507540
X3962 1883 210 2 1893 1 278 MUX2S $T=323020 518000 1 0 $X=323020 $Y=512580
X3963 1893 210 2 266 1 269 MUX2S $T=324260 518000 0 0 $X=324260 $Y=517620
X3964 1907 228 2 269 1 294 MUX2S $T=334800 518000 0 0 $X=334800 $Y=517620
X3965 349 348 2 2268 1 2204 MUX2S $T=399900 386960 0 180 $X=395560 $Y=381540
X3966 351 348 2 2271 1 2224 MUX2S $T=400520 366800 1 180 $X=396180 $Y=366420
X3967 2281 348 2 2272 1 2266 MUX2S $T=400520 376880 0 180 $X=396180 $Y=371460
X3968 2283 348 2 2273 1 2267 MUX2S $T=400520 386960 1 180 $X=396180 $Y=386580
X3969 352 348 2 2285 1 2241 MUX2S $T=404240 397040 0 180 $X=399900 $Y=391620
X3970 2279 348 2 2298 1 2335 MUX2S $T=400520 376880 0 0 $X=400520 $Y=376500
X3971 2294 2297 2 2291 1 2290 MUX2S $T=405480 366800 0 180 $X=401140 $Y=361380
X3972 2314 2297 2 2292 1 2273 MUX2S $T=405480 386960 0 180 $X=401140 $Y=381540
X3973 2337 2297 2 2294 1 2281 MUX2S $T=406100 346640 1 180 $X=401760 $Y=346260
X3974 2310 2297 2 2295 1 2279 MUX2S $T=406100 356720 1 180 $X=401760 $Y=356340
X3975 2291 2297 2 2292 1 2272 MUX2S $T=406100 366800 1 180 $X=401760 $Y=366420
X3976 2290 348 2 2292 1 2303 MUX2S $T=401760 386960 0 0 $X=401760 $Y=386580
X3977 359 348 2 2290 1 2223 MUX2S $T=407340 356720 0 180 $X=403000 $Y=351300
X3978 2180 350 2 356 1 2338 MUX2S $T=403620 477680 0 0 $X=403620 $Y=477300
X3979 2271 348 2 2292 1 2346 MUX2S $T=405480 397040 1 0 $X=405480 $Y=391620
X3980 2339 2297 2 2314 1 2271 MUX2S $T=411060 366800 0 180 $X=406720 $Y=361380
X3981 2347 2297 2 2292 1 2298 MUX2S $T=411060 376880 0 180 $X=406720 $Y=371460
X3982 2325 2297 2 2292 1 2345 MUX2S $T=406720 386960 1 0 $X=406720 $Y=381540
X3983 2334 2297 2 2330 1 2329 MUX2S $T=411680 356720 1 180 $X=407340 $Y=356340
X3984 2329 348 2 2345 1 2368 MUX2S $T=407340 386960 0 0 $X=407340 $Y=386580
X3985 2350 2297 2 2334 1 352 MUX2S $T=412300 336560 1 180 $X=407960 $Y=336180
X3986 366 348 2 2329 1 2228 MUX2S $T=412300 346640 0 180 $X=407960 $Y=341220
X3987 2295 2297 2 2347 1 2268 MUX2S $T=407960 366800 0 0 $X=407960 $Y=366420
X3988 2354 2297 2 2339 1 2283 MUX2S $T=412920 356720 0 180 $X=408580 $Y=351300
X3989 2146 350 2 2170 1 2284 MUX2S $T=408580 487760 0 0 $X=408580 $Y=487380
X3990 2148 350 2 2122 1 2366 MUX2S $T=409820 477680 0 0 $X=409820 $Y=477300
X3991 2355 2360 2 2352 1 2294 MUX2S $T=416020 366800 0 180 $X=411680 $Y=361380
X3992 2364 2360 2 2355 1 2310 MUX2S $T=416640 356720 1 180 $X=412300 $Y=356340
X3993 2330 2297 2 2325 1 2285 MUX2S $T=412300 386960 1 0 $X=412300 $Y=381540
X3994 2268 348 2 2292 1 2379 MUX2S $T=412920 397040 1 0 $X=412920 $Y=391620
X3995 2352 2360 2 2361 1 2295 MUX2S $T=417880 366800 1 180 $X=413540 $Y=366420
X3996 2363 2360 2 2367 1 2354 MUX2S $T=418500 356720 0 180 $X=414160 $Y=351300
X3997 2277 350 2 2148 1 2370 MUX2S $T=416020 477680 0 0 $X=416020 $Y=477300
X3998 2367 2360 2 2382 1 2334 MUX2S $T=421600 366800 0 180 $X=417260 $Y=361380
X3999 2394 377 2 2383 1 2364 MUX2S $T=422220 356720 1 180 $X=417880 $Y=356340
X4000 2385 2360 2 2292 1 2325 MUX2S $T=422220 386960 0 180 $X=417880 $Y=381540
X4001 2285 348 2 2292 1 2403 MUX2S $T=419120 397040 0 0 $X=419120 $Y=396660
X4002 2382 2360 2 2397 1 2339 MUX2S $T=419740 366800 0 0 $X=419740 $Y=366420
X4003 2208 350 2 2180 1 2395 MUX2S $T=424700 487760 0 180 $X=420360 $Y=482340
X4004 2107 350 2 2131 1 2390 MUX2S $T=426560 477680 1 180 $X=422220 $Y=477300
X4005 2409 2402 2 2405 1 2355 MUX2S $T=427180 366800 0 180 $X=422840 $Y=361380
X4006 2393 377 2 2408 1 2373 MUX2S $T=427800 336560 0 180 $X=423460 $Y=331140
X4007 2383 2402 2 2409 1 2367 MUX2S $T=427800 356720 1 180 $X=423460 $Y=356340
X4008 2411 2402 2 2419 1 2384 MUX2S $T=428420 386960 1 180 $X=424080 $Y=386580
X4009 2419 2402 2 2406 1 2356 MUX2S $T=428420 397040 0 180 $X=424080 $Y=391620
X4010 2445 2402 2 2424 1 2352 MUX2S $T=429660 366800 1 180 $X=425320 $Y=366420
X4011 2451 350 2 2107 1 2426 MUX2S $T=430900 487760 0 180 $X=426560 $Y=482340
X4012 2405 2402 2 2445 1 2382 MUX2S $T=427800 366800 1 0 $X=427800 $Y=361380
X4013 2521 350 2 2451 1 2422 MUX2S $T=443300 487760 0 180 $X=438960 $Y=482340
X4014 2534 401 2 2513 1 2431 MUX2S $T=446400 397040 1 180 $X=442060 $Y=396660
X4015 396 401 2 2537 1 2481 MUX2S $T=442680 366800 1 0 $X=442680 $Y=361380
X4016 2514 401 2 2523 1 2452 MUX2S $T=447640 376880 1 180 $X=443300 $Y=376500
X4017 2498 401 2 2524 1 2496 MUX2S $T=447640 386960 1 180 $X=443300 $Y=386580
X4018 2537 401 2 2525 1 2469 MUX2S $T=447640 407120 0 180 $X=443300 $Y=401700
X4019 404 401 2 2522 1 2485 MUX2S $T=448260 376880 0 180 $X=443920 $Y=371460
X4020 2518 401 2 2528 1 2458 MUX2S $T=448260 397040 0 180 $X=443920 $Y=391620
X4021 406 401 2 2534 1 2484 MUX2S $T=448880 346640 0 180 $X=444540 $Y=341220
X4022 2515 401 2 2535 1 2477 MUX2S $T=448880 386960 0 180 $X=444540 $Y=381540
X4023 2522 401 2 2525 1 2539 MUX2S $T=444540 417200 1 0 $X=444540 $Y=411780
X4024 2532 2556 2 2540 1 2514 MUX2S $T=450740 356720 1 180 $X=446400 $Y=356340
X4025 2540 2556 2 2543 1 2537 MUX2S $T=452600 366800 1 180 $X=448260 $Y=366420
X4026 2558 2556 2 2525 1 2513 MUX2S $T=452600 397040 1 180 $X=448260 $Y=396660
X4027 2543 2556 2 2525 1 2523 MUX2S $T=453220 376880 1 180 $X=448880 $Y=376500
X4028 2554 2556 2 2525 1 2524 MUX2S $T=453220 386960 1 180 $X=448880 $Y=386580
X4029 2550 2556 2 2546 1 2522 MUX2S $T=453840 376880 0 180 $X=449500 $Y=371460
X4030 411 401 2 2547 1 2490 MUX2S $T=453840 407120 0 180 $X=449500 $Y=401700
X4031 2552 2556 2 2550 1 2518 MUX2S $T=454460 356720 0 180 $X=450120 $Y=351300
X4032 2546 2556 2 2525 1 2528 MUX2S $T=454460 397040 0 180 $X=450120 $Y=391620
X4033 2563 2556 2 2554 1 2535 MUX2S $T=455080 386960 0 180 $X=450740 $Y=381540
X4034 2535 401 2 2525 1 2529 MUX2S $T=451360 417200 1 0 $X=451360 $Y=411780
X4035 2548 2556 2 2563 1 2498 MUX2S $T=456940 366800 0 180 $X=452600 $Y=361380
X4036 2565 407 2 2568 1 411 MUX2S $T=458800 346640 1 180 $X=454460 $Y=346260
X4037 2568 2556 2 2567 1 2534 MUX2S $T=458800 366800 1 180 $X=454460 $Y=366420
X4038 2567 2556 2 2558 1 2547 MUX2S $T=454460 397040 0 0 $X=454460 $Y=396660
X4039 2581 416 2 2525 1 2554 MUX2S $T=459420 386960 1 180 $X=455080 $Y=386580
X4040 2579 416 2 2576 1 2548 MUX2S $T=460040 356720 0 180 $X=455700 $Y=351300
X4041 2573 416 2 2577 1 2546 MUX2S $T=460040 397040 0 180 $X=455700 $Y=391620
X4042 2577 416 2 2525 1 2558 MUX2S $T=460040 407120 1 180 $X=455700 $Y=406740
X4043 2572 416 2 2581 1 2543 MUX2S $T=461280 386960 0 180 $X=456940 $Y=381540
X4044 2595 350 2 2276 1 2570 MUX2S $T=461280 487760 0 180 $X=456940 $Y=482340
X4045 2547 401 2 2525 1 2588 MUX2S $T=457560 417200 1 0 $X=457560 $Y=411780
X4046 2576 416 2 2586 1 2540 MUX2S $T=462520 366800 0 180 $X=458180 $Y=361380
X4047 2591 416 2 2609 1 2619 MUX2S $T=459420 477680 0 0 $X=459420 $Y=477300
X4048 2604 416 2 2594 1 2552 MUX2S $T=464380 346640 1 180 $X=460040 $Y=346260
X4049 2616 416 2 2589 1 2550 MUX2S $T=464380 366800 1 180 $X=460040 $Y=366420
X4050 2610 425 2 2597 1 2573 MUX2S $T=465000 386960 1 180 $X=460660 $Y=386580
X4051 2597 425 2 2603 1 2581 MUX2S $T=465620 397040 0 180 $X=461280 $Y=391620
X4052 2602 425 2 2610 1 2572 MUX2S $T=466860 386960 0 180 $X=462520 $Y=381540
X4053 2609 416 2 2612 1 2639 MUX2S $T=462520 497840 1 0 $X=462520 $Y=492420
X4054 2646 425 2 2614 1 2609 MUX2S $T=467480 487760 0 180 $X=463140 $Y=482340
X4055 2612 416 2 2628 1 2640 MUX2S $T=463140 507920 0 0 $X=463140 $Y=507540
X4056 2594 416 2 2616 1 2568 MUX2S $T=468100 366800 0 180 $X=463760 $Y=361380
X4057 2625 425 2 2645 1 2591 MUX2S $T=465620 477680 0 0 $X=465620 $Y=477300
X4058 2651 425 2 2627 1 2612 MUX2S $T=469960 507920 0 180 $X=465620 $Y=502500
X4059 2652 425 2 2626 1 2616 MUX2S $T=470580 366800 1 180 $X=466240 $Y=366420
X4060 2605 425 2 2638 1 2594 MUX2S $T=471820 356720 1 180 $X=467480 $Y=356340
X4061 2614 425 2 2651 1 2637 MUX2S $T=468100 487760 0 0 $X=468100 $Y=487380
X4062 2637 416 2 2660 1 437 MUX2S $T=468720 497840 1 0 $X=468720 $Y=492420
X4063 2662 425 2 2653 1 2628 MUX2S $T=473680 507920 1 180 $X=469340 $Y=507540
X4064 2638 425 2 2652 1 2576 MUX2S $T=474300 366800 0 180 $X=469960 $Y=361380
X4065 2673 425 2 2625 1 2656 MUX2S $T=474920 477680 0 180 $X=470580 $Y=472260
X4066 2627 425 2 2662 1 2660 MUX2S $T=476160 497840 1 180 $X=471820 $Y=497460
X4067 2664 416 2 2591 1 2694 MUX2S $T=472440 477680 0 0 $X=472440 $Y=477300
X4068 2645 425 2 2646 1 2704 MUX2S $T=473060 487760 1 0 $X=473060 $Y=482340
X4069 2705 442 2 437 1 439 MUX2S $T=479260 497840 0 180 $X=474920 $Y=492420
X4070 2703 446 2 2692 1 2624 MUX2S $T=481120 417200 0 180 $X=476780 $Y=411780
X4071 2639 442 2 435 1 449 MUX2S $T=476780 518000 0 0 $X=476780 $Y=517620
X4072 443 446 2 2708 1 2680 MUX2S $T=477400 386960 0 0 $X=477400 $Y=386580
X4073 451 446 2 2703 1 2679 MUX2S $T=482360 397040 1 180 $X=478020 $Y=396660
X4074 2704 416 2 2637 1 2691 MUX2S $T=482360 487760 1 180 $X=478020 $Y=487380
X4075 2619 442 2 2640 1 454 MUX2S $T=478020 497840 0 0 $X=478020 $Y=497460
X4076 447 446 2 2718 1 2669 MUX2S $T=478640 386960 1 0 $X=478640 $Y=381540
X4077 2724 446 2 2692 1 2592 MUX2S $T=482980 407120 0 180 $X=478640 $Y=401700
X4078 2718 446 2 2692 1 2665 MUX2S $T=483600 407120 1 180 $X=479260 $Y=406740
X4079 2656 416 2 2704 1 2705 MUX2S $T=483600 487760 0 180 $X=479260 $Y=482340
X4080 2691 442 2 2698 1 461 MUX2S $T=479260 518000 1 0 $X=479260 $Y=512580
X4081 457 450 2 2711 1 443 MUX2S $T=484840 356720 0 180 $X=480500 $Y=351300
X4082 458 446 2 2712 1 2693 MUX2S $T=484840 397040 0 180 $X=480500 $Y=391620
X4083 445 446 2 2728 1 2702 MUX2S $T=481120 376880 1 0 $X=481120 $Y=371460
X4084 2640 442 2 432 1 2738 MUX2S $T=481120 507920 0 0 $X=481120 $Y=507540
X4085 2694 442 2 2639 1 470 MUX2S $T=481740 497840 1 0 $X=481740 $Y=492420
X4086 2721 456 2 461 1 464 MUX2S $T=482360 518000 0 0 $X=482360 $Y=517620
X4087 2734 2739 2 2692 1 2708 MUX2S $T=487320 386960 1 180 $X=482980 $Y=386580
X4088 2741 446 2 2729 1 2697 MUX2S $T=487940 397040 1 180 $X=483600 $Y=396660
X4089 467 446 2 2724 1 2631 MUX2S $T=488560 407120 0 180 $X=484220 $Y=401700
X4090 2727 442 2 2691 1 2755 MUX2S $T=484220 487760 0 0 $X=484220 $Y=487380
X4091 2695 450 2 2742 1 468 MUX2S $T=484840 366800 1 0 $X=484840 $Y=361380
X4092 2711 2739 2 2734 1 2718 MUX2S $T=489180 386960 0 180 $X=484840 $Y=381540
X4093 468 446 2 2736 1 2648 MUX2S $T=489800 417200 0 180 $X=485460 $Y=411780
X4094 2678 442 2 2619 1 2764 MUX2S $T=485460 487760 1 0 $X=485460 $Y=482340
X4095 2736 446 2 2692 1 2643 MUX2S $T=490420 417200 1 180 $X=486080 $Y=416820
X4096 2698 442 2 432 1 2772 MUX2S $T=486080 518000 1 0 $X=486080 $Y=512580
X4097 2764 456 2 2738 1 462 MUX2S $T=491040 507920 1 180 $X=486700 $Y=507540
X4098 2742 450 2 2761 1 2728 MUX2S $T=487320 376880 1 0 $X=487320 $Y=371460
X4099 2751 450 2 2773 1 458 MUX2S $T=488560 366800 0 0 $X=488560 $Y=366420
X4100 2750 2739 2 2774 1 2741 MUX2S $T=488560 386960 0 0 $X=488560 $Y=386580
X4101 2732 456 2 449 1 474 MUX2S $T=488560 518000 0 0 $X=488560 $Y=517620
X4102 2769 2723 2 2758 1 2751 MUX2S $T=493520 356720 1 180 $X=489180 $Y=356340
X4103 2763 2739 2 2692 1 2729 MUX2S $T=493520 397040 1 180 $X=489180 $Y=396660
X4104 2773 2739 2 2762 1 2703 MUX2S $T=494140 397040 0 180 $X=489800 $Y=391620
X4105 2774 2739 2 2763 1 2724 MUX2S $T=494140 407120 0 180 $X=489800 $Y=401700
X4106 2781 2723 2 2767 1 2750 MUX2S $T=494760 366800 0 180 $X=490420 $Y=361380
X4107 2728 446 2 2787 1 2720 MUX2S $T=491040 417200 1 0 $X=491040 $Y=411780
X4108 2758 2723 2 2785 1 2742 MUX2S $T=497860 376880 1 180 $X=493520 $Y=376500
X4109 2785 2723 2 2786 1 2773 MUX2S $T=497860 386960 0 180 $X=493520 $Y=381540
X4110 2809 2723 2 2790 1 2774 MUX2S $T=498480 386960 1 180 $X=494140 $Y=386580
X4111 2767 2723 2 2809 1 2711 MUX2S $T=494760 366800 0 0 $X=494760 $Y=366420
X4112 2762 2739 2 2692 1 2712 MUX2S $T=499100 397040 0 180 $X=494760 $Y=391620
X4113 2761 2739 2 2793 1 2736 MUX2S $T=499100 407120 0 180 $X=494760 $Y=401700
X4114 2788 456 2 454 1 2813 MUX2S $T=494760 507920 0 0 $X=494760 $Y=507540
X4115 2815 2780 2 2796 1 2781 MUX2S $T=499720 356720 1 180 $X=495380 $Y=356340
X4116 2793 2739 2 2692 1 2787 MUX2S $T=500340 407120 1 180 $X=496000 $Y=406740
X4117 2831 2780 2 2805 1 2767 MUX2S $T=500960 366800 0 180 $X=496620 $Y=361380
X4118 2786 2723 2 2821 1 2761 MUX2S $T=503440 376880 1 180 $X=499100 $Y=376500
X4119 2805 2780 2 2834 1 2785 MUX2S $T=499720 376880 1 0 $X=499720 $Y=371460
X4120 2790 2723 2 2824 1 2734 MUX2S $T=504060 386960 0 180 $X=499720 $Y=381540
X4121 2821 2723 2 2825 1 2762 MUX2S $T=504060 397040 0 180 $X=499720 $Y=391620
X4122 2824 2723 2 2692 1 2763 MUX2S $T=504680 397040 1 180 $X=500340 $Y=396660
X4123 2825 2723 2 2692 1 2793 MUX2S $T=505920 407120 1 180 $X=501580 $Y=406740
X4124 2796 2780 2 2831 1 2758 MUX2S $T=507160 366800 0 180 $X=502820 $Y=361380
X4125 2834 2780 2 2847 1 2809 MUX2S $T=509020 366800 1 180 $X=504680 $Y=366420
X4126 2864 2780 2 2850 1 2821 MUX2S $T=509640 386960 1 180 $X=505300 $Y=386580
X4127 2850 2780 2 2851 1 2824 MUX2S $T=509640 397040 0 180 $X=505300 $Y=391620
X4128 2847 2780 2 2880 1 2786 MUX2S $T=508400 376880 1 0 $X=508400 $Y=371460
X4129 2880 2780 2 2864 1 2790 MUX2S $T=512740 386960 0 180 $X=508400 $Y=381540
X4130 2895 2886 2 2881 1 2921 MUX2S $T=513980 497840 0 0 $X=513980 $Y=497460
X4131 2881 2886 2 2890 1 2908 MUX2S $T=513980 507920 0 0 $X=513980 $Y=507540
X4132 2922 2910 2 501 1 500 MUX2S $T=518320 518000 1 180 $X=513980 $Y=517620
X4133 2892 2886 2 2895 1 2923 MUX2S $T=514600 497840 1 0 $X=514600 $Y=492420
X4134 2903 2886 2 2911 1 2932 MUX2S $T=515220 477680 1 0 $X=515220 $Y=472260
X4135 2924 2886 2 2903 1 2949 MUX2S $T=519560 477680 0 0 $X=519560 $Y=477300
X4136 2913 2886 2 2914 1 2950 MUX2S $T=519560 487760 0 0 $X=519560 $Y=487380
X4137 2945 2933 2 2921 1 2917 MUX2S $T=523900 497840 1 180 $X=519560 $Y=497460
X4138 2917 2910 2 2922 1 526 MUX2S $T=519560 518000 0 0 $X=519560 $Y=517620
X4139 2914 2886 2 2892 1 2945 MUX2S $T=520800 497840 1 0 $X=520800 $Y=492420
X4140 2944 2886 2 2924 1 2962 MUX2S $T=523280 477680 1 0 $X=523280 $Y=472260
X4141 2949 2933 2 2938 1 2977 MUX2S $T=524520 487760 1 0 $X=524520 $Y=482340
X4142 2977 2910 2 2917 1 528 MUX2S $T=529480 497840 1 180 $X=525140 $Y=497460
X4143 2981 2910 2 2958 1 527 MUX2S $T=529480 518000 1 180 $X=525140 $Y=517620
X4144 2962 2933 2 2932 1 2991 MUX2S $T=525760 477680 0 0 $X=525760 $Y=477300
X4145 2938 2933 2 2945 1 2985 MUX2S $T=525760 487760 0 0 $X=525760 $Y=487380
X4146 2985 2910 2 2964 1 523 MUX2S $T=530100 518000 0 180 $X=525760 $Y=512580
X4147 2950 2933 2 2923 1 2981 MUX2S $T=527000 497840 1 0 $X=527000 $Y=492420
X4148 2976 2933 2 2949 1 2990 MUX2S $T=528240 467600 0 0 $X=528240 $Y=467220
X4149 2932 2933 2 2950 1 3015 MUX2S $T=530100 487760 1 0 $X=530100 $Y=482340
X4150 2923 2933 2 2908 1 3016 MUX2S $T=530720 497840 0 0 $X=530720 $Y=497460
X4151 2958 2910 2 501 1 3019 MUX2S $T=530720 518000 0 0 $X=530720 $Y=517620
X4152 2964 2910 2 501 1 3024 MUX2S $T=531340 518000 1 0 $X=531340 $Y=512580
X4153 2990 2910 2 2985 1 3025 MUX2S $T=531960 487760 0 0 $X=531960 $Y=487380
X4154 2991 2910 2 2981 1 3028 MUX2S $T=533200 497840 1 0 $X=533200 $Y=492420
X4155 3010 540 2 2974 1 3034 MUX2S $T=533820 447440 1 0 $X=533820 $Y=442020
X4156 3016 2910 2 501 1 3039 MUX2S $T=534440 507920 0 0 $X=534440 $Y=507540
X4157 2974 540 2 2977 1 574 MUX2S $T=535680 477680 0 0 $X=535680 $Y=477300
X4158 3003 2910 2 3015 1 3046 MUX2S $T=535680 487760 1 0 $X=535680 $Y=482340
X4159 3015 2910 2 3016 1 576 MUX2S $T=536920 497840 0 0 $X=536920 $Y=497460
X4160 3046 570 2 3039 1 585 MUX2S $T=540640 507920 0 0 $X=540640 $Y=507540
X4161 3014 570 2 527 1 587 MUX2S $T=541880 518000 0 0 $X=541880 $Y=517620
X4162 3034 570 2 528 1 3101 MUX2S $T=542500 497840 0 0 $X=542500 $Y=497460
X4163 3043 570 2 523 1 3100 MUX2S $T=542500 518000 1 0 $X=542500 $Y=512580
X4164 3031 570 2 576 1 3125 MUX2S $T=546840 507920 1 0 $X=546840 $Y=502500
X4165 3244 2780 2 3276 1 3299 MUX2S $T=577840 497840 0 0 $X=577840 $Y=497460
X4166 3264 2780 2 3281 1 3302 MUX2S $T=580320 467600 0 0 $X=580320 $Y=467220
X4167 3292 2780 2 3267 1 3312 MUX2S $T=582180 487760 0 0 $X=582180 $Y=487380
X4168 3267 2780 2 3244 1 3325 MUX2S $T=582800 497840 1 0 $X=582800 $Y=492420
X4169 3305 2780 2 3291 1 3342 MUX2S $T=587760 477680 0 0 $X=587760 $Y=477300
X4170 3294 2780 2 3264 1 3349 MUX2S $T=588380 477680 1 0 $X=588380 $Y=472260
X4171 3325 3322 2 3332 1 3350 MUX2S $T=588380 497840 1 0 $X=588380 $Y=492420
X4172 3317 2780 2 3294 1 3352 MUX2S $T=589000 467600 1 0 $X=589000 $Y=462180
X4173 3332 3322 2 3269 1 3351 MUX2S $T=590240 497840 0 0 $X=590240 $Y=497460
X4174 3351 3364 2 3269 1 3333 MUX2S $T=595200 518000 0 180 $X=590860 $Y=512580
X4175 3342 3322 2 3312 1 3368 MUX2S $T=592720 487760 1 0 $X=592720 $Y=482340
X4176 3343 3364 2 3351 1 3328 MUX2S $T=597060 507920 1 180 $X=592720 $Y=507540
X4177 3352 3322 2 3302 1 3383 MUX2S $T=593340 467600 0 0 $X=593340 $Y=467220
X4178 3349 3322 2 3318 1 3374 MUX2S $T=593340 477680 0 0 $X=593340 $Y=477300
X4179 3312 3322 2 3299 1 3387 MUX2S $T=593340 487760 0 0 $X=593340 $Y=487380
X4180 3316 3145 2 3358 1 3376 MUX2S $T=593960 457520 1 0 $X=593960 $Y=452100
X4181 3374 3364 2 3343 1 3354 MUX2S $T=598300 497840 0 180 $X=593960 $Y=492420
X4182 3358 3145 2 3349 1 3391 MUX2S $T=594580 457520 0 0 $X=594580 $Y=457140
X4183 3299 3322 2 3269 1 3365 MUX2S $T=595820 497840 0 0 $X=595820 $Y=497460
X4184 3365 3364 2 3269 1 3400 MUX2S $T=596440 518000 1 0 $X=596440 $Y=512580
X4185 3383 3364 2 3368 1 3404 MUX2S $T=598300 487760 1 0 $X=598300 $Y=482340
X4186 3368 3364 2 3365 1 3330 MUX2S $T=603260 507920 1 180 $X=598920 $Y=507540
X4187 3407 3364 2 3387 1 3319 MUX2S $T=603880 487760 1 180 $X=599540 $Y=487380
X4188 3336 3364 2 3350 1 3384 MUX2S $T=603880 497840 0 180 $X=599540 $Y=492420
X4189 3324 3145 2 3352 1 3415 MUX2S $T=600160 467600 1 0 $X=600160 $Y=462180
X4190 3350 3364 2 3269 1 3424 MUX2S $T=602020 497840 0 0 $X=602020 $Y=497460
X4191 3391 3364 2 3336 1 3432 MUX2S $T=603880 487760 1 0 $X=603880 $Y=482340
X4192 3415 3364 2 3407 1 3435 MUX2S $T=604500 477680 0 0 $X=604500 $Y=477300
X4193 3435 3327 2 3418 1 3370 MUX2S $T=609460 487760 1 180 $X=605120 $Y=487380
X4194 3387 3364 2 3269 1 3418 MUX2S $T=605120 497840 1 0 $X=605120 $Y=492420
X4195 3412 3327 2 3328 1 694 MUX2S $T=605120 507920 0 0 $X=605120 $Y=507540
X4196 3348 3405 2 3376 1 3451 MUX2S $T=605740 437360 0 0 $X=605740 $Y=436980
X4197 3431 3327 2 3330 1 698 MUX2S $T=608220 518000 1 0 $X=608220 $Y=512580
X4198 3451 3327 2 3354 1 3484 MUX2S $T=610700 497840 1 0 $X=610700 $Y=492420
X4199 3479 3327 2 3384 1 3452 MUX2S $T=615660 507920 1 180 $X=611320 $Y=507540
X4200 3443 3327 2 3319 1 3486 MUX2S $T=613800 497840 0 0 $X=613800 $Y=497460
X4201 3680 737 2 3649 1 3660 MUX2S $T=654720 437360 0 180 $X=650380 $Y=431940
X4202 3656 737 2 753 1 3657 MUX2S $T=651000 427280 1 0 $X=651000 $Y=421860
X4203 3679 737 2 3647 1 3635 MUX2S $T=655340 427280 1 180 $X=651000 $Y=426900
X4204 3649 737 2 763 1 3668 MUX2S $T=655960 407120 1 0 $X=655960 $Y=401700
X4205 3677 737 2 759 1 757 MUX2S $T=661540 427280 0 180 $X=657200 $Y=421860
X4206 3706 737 2 3679 1 3689 MUX2S $T=662160 457520 0 180 $X=657820 $Y=452100
X4207 3678 737 2 3677 1 3700 MUX2S $T=665260 447440 0 180 $X=660920 $Y=442020
X4208 3744 737 2 3706 1 3634 MUX2S $T=668980 467600 0 180 $X=664640 $Y=462180
X4209 3775 737 2 3652 1 3746 MUX2S $T=674560 457520 0 180 $X=670220 $Y=452100
X4210 791 789 2 3873 1 3826 MUX2S $T=694400 366800 1 180 $X=690060 $Y=366420
X4211 3897 789 2 3877 1 3830 MUX2S $T=695640 356720 1 180 $X=691300 $Y=356340
X4212 3898 792 2 3878 1 3873 MUX2S $T=695640 376880 0 180 $X=691300 $Y=371460
X4213 3901 789 2 3880 1 3827 MUX2S $T=696260 397040 0 180 $X=691920 $Y=391620
X4214 3903 789 2 3884 1 3807 MUX2S $T=696880 386960 0 180 $X=692540 $Y=381540
X4215 796 789 2 3890 1 3797 MUX2S $T=697500 346640 1 180 $X=693160 $Y=346260
X4216 3890 789 2 3878 1 3870 MUX2S $T=698120 397040 1 180 $X=693780 $Y=396660
X4217 797 789 2 3901 1 3844 MUX2S $T=699980 336560 1 180 $X=695640 $Y=336180
X4218 802 789 2 3909 1 3798 MUX2S $T=700600 366800 1 180 $X=696260 $Y=366420
X4219 799 789 2 3910 1 3814 MUX2S $T=700600 386960 1 180 $X=696260 $Y=386580
X4220 3933 792 2 3912 1 3903 MUX2S $T=701220 356720 1 180 $X=696880 $Y=356340
X4221 3912 792 2 3926 1 3877 MUX2S $T=696880 376880 1 0 $X=696880 $Y=371460
X4222 801 789 2 3916 1 3829 MUX2S $T=701840 356720 0 180 $X=697500 $Y=351300
X4223 3921 792 2 3898 1 3890 MUX2S $T=701840 366800 0 180 $X=697500 $Y=361380
X4224 3947 792 2 3878 1 3880 MUX2S $T=701840 397040 0 180 $X=697500 $Y=391620
X4225 3926 792 2 3878 1 3884 MUX2S $T=702460 386960 0 180 $X=698120 $Y=381540
X4226 3928 792 2 3921 1 791 MUX2S $T=703080 346640 1 180 $X=698740 $Y=346260
X4227 3916 789 2 3878 1 3896 MUX2S $T=703700 397040 1 180 $X=699360 $Y=396660
X4228 3952 792 2 3946 1 3916 MUX2S $T=706800 366800 1 180 $X=702460 $Y=366420
X4229 3946 792 2 3878 1 3910 MUX2S $T=706800 386960 1 180 $X=702460 $Y=386580
X4230 3966 3967 2 3949 1 3933 MUX2S $T=707420 356720 1 180 $X=703080 $Y=356340
X4231 3974 3967 2 3950 1 3898 MUX2S $T=707420 376880 0 180 $X=703080 $Y=371460
X4232 3938 792 2 3952 1 799 MUX2S $T=708040 356720 0 180 $X=703700 $Y=351300
X4233 3960 792 2 3953 1 3901 MUX2S $T=708040 366800 0 180 $X=703700 $Y=361380
X4234 3950 3967 2 3878 1 3926 MUX2S $T=708040 386960 0 180 $X=703700 $Y=381540
X4235 3953 792 2 3947 1 3909 MUX2S $T=708040 397040 0 180 $X=703700 $Y=391620
X4236 3978 792 2 3960 1 802 MUX2S $T=709280 346640 0 180 $X=704940 $Y=341220
X4237 3877 789 2 3878 1 3959 MUX2S $T=704940 397040 0 0 $X=704940 $Y=396660
X4238 3980 3967 2 3977 1 3952 MUX2S $T=712380 366800 1 180 $X=708040 $Y=366420
X4239 3986 3967 2 3980 1 3960 MUX2S $T=713000 356720 1 180 $X=708660 $Y=356340
X4240 3949 3967 2 3981 1 3921 MUX2S $T=713000 366800 0 180 $X=708660 $Y=361380
X4241 3981 3967 2 3974 1 3912 MUX2S $T=713000 376880 0 180 $X=708660 $Y=371460
X4242 3987 3967 2 3982 1 3946 MUX2S $T=713000 386960 1 180 $X=708660 $Y=386580
X4243 4013 812 2 3956 1 3944 MUX2S $T=713000 447440 0 180 $X=708660 $Y=442020
X4244 3994 3967 2 3986 1 3938 MUX2S $T=713620 346640 1 180 $X=709280 $Y=346260
X4245 3977 3967 2 3987 1 3953 MUX2S $T=713620 386960 0 180 $X=709280 $Y=381540
X4246 3982 3967 2 3878 1 3947 MUX2S $T=713620 397040 0 180 $X=709280 $Y=391620
X4247 4014 3971 2 3993 1 3914 MUX2S $T=714860 437360 1 180 $X=710520 $Y=436980
X4248 3909 789 2 3878 1 3988 MUX2S $T=711140 397040 0 0 $X=711140 $Y=396660
X4249 4029 813 2 4007 1 4004 MUX2S $T=716720 487760 0 180 $X=712380 $Y=482340
X4250 4034 813 2 3968 1 4005 MUX2S $T=716720 497840 0 180 $X=712380 $Y=492420
X4251 4030 809 2 4005 1 3936 MUX2S $T=716720 507920 0 180 $X=712380 $Y=502500
X4252 4033 3971 2 4006 1 4008 MUX2S $T=717340 447440 1 180 $X=713000 $Y=447060
X4253 4007 813 2 3968 1 3972 MUX2S $T=717340 487760 1 180 $X=713000 $Y=487380
X4254 4017 4025 2 4018 1 3949 MUX2S $T=718580 366800 1 180 $X=714240 $Y=366420
X4255 4018 4025 2 4019 1 3980 MUX2S $T=718580 376880 0 180 $X=714240 $Y=371460
X4256 4019 4025 2 4024 1 3981 MUX2S $T=719200 376880 1 180 $X=714860 $Y=376500
X4257 4041 812 2 4013 1 4006 MUX2S $T=719200 447440 0 180 $X=714860 $Y=442020
X4258 4050 812 2 3956 1 3993 MUX2S $T=720440 437360 1 180 $X=716100 $Y=436980
X4259 4057 809 2 4040 1 3931 MUX2S $T=722300 507920 0 180 $X=717960 $Y=502500
X4260 4074 825 2 4045 1 4039 MUX2S $T=722920 477680 0 180 $X=718580 $Y=472260
X4261 4073 4063 2 4047 1 4044 MUX2S $T=723540 457520 0 180 $X=719200 $Y=452100
X4262 4068 4025 2 4052 1 3950 MUX2S $T=724160 397040 0 180 $X=719820 $Y=391620
X4263 4021 4025 2 4068 1 3987 MUX2S $T=727880 386960 0 180 $X=723540 $Y=381540
X4264 4106 825 2 4074 1 4069 MUX2S $T=729120 477680 0 180 $X=724780 $Y=472260
X4265 4120 4063 2 4073 1 4087 MUX2S $T=729740 457520 0 180 $X=725400 $Y=452100
X4266 4082 812 2 3956 1 4119 MUX2S $T=726640 447440 1 0 $X=726640 $Y=442020
X4267 4097 825 2 4106 1 4125 MUX2S $T=727260 477680 0 0 $X=727260 $Y=477300
X4268 4122 812 2 4050 1 4035 MUX2S $T=732220 437360 0 180 $X=727880 $Y=431940
X4269 4125 4060 2 4039 1 4111 MUX2S $T=733460 487760 0 180 $X=729120 $Y=482340
X4270 4134 812 2 3956 1 4113 MUX2S $T=734080 427280 1 180 $X=729740 $Y=426900
X4271 4136 3971 2 4119 1 3940 MUX2S $T=734700 447440 1 180 $X=730360 $Y=447060
X4272 4138 813 2 4034 1 3991 MUX2S $T=734700 487760 1 180 $X=730360 $Y=487380
X4273 4137 813 2 4111 1 4031 MUX2S $T=734700 497840 1 180 $X=730360 $Y=497460
X4274 4143 4063 2 4120 1 4123 MUX2S $T=735940 457520 0 180 $X=731600 $Y=452100
X4275 4144 3971 2 4035 1 4130 MUX2S $T=737180 437360 1 180 $X=732840 $Y=436980
X4276 4123 4089 2 4044 1 4134 MUX2S $T=737800 437360 0 180 $X=733460 $Y=431940
X4277 4154 839 2 4125 1 4138 MUX2S $T=739040 487760 1 180 $X=734700 $Y=487380
X4278 4159 3971 2 4113 1 3983 MUX2S $T=740280 427280 1 180 $X=735940 $Y=426900
X4279 4146 4089 2 4087 1 4041 MUX2S $T=740280 447440 1 180 $X=735940 $Y=447060
X4280 4160 809 2 3991 1 4128 MUX2S $T=740280 497840 1 180 $X=735940 $Y=497460
X4281 4172 813 2 4065 1 3992 MUX2S $T=740900 497840 0 180 $X=736560 $Y=492420
X4282 4162 4063 2 4143 1 4146 MUX2S $T=742140 457520 0 180 $X=737800 $Y=452100
X4283 4174 812 2 4082 1 3995 MUX2S $T=742760 437360 1 180 $X=738420 $Y=436980
X4284 4179 4089 2 4123 1 4122 MUX2S $T=743380 437360 0 180 $X=739040 $Y=431940
X4285 4195 839 2 4154 1 4137 MUX2S $T=744620 487760 1 180 $X=740280 $Y=487380
X4286 4183 812 2 4134 1 3979 MUX2S $T=745860 427280 1 180 $X=741520 $Y=426900
X4287 4184 3971 2 3995 1 4157 MUX2S $T=745860 447440 1 180 $X=741520 $Y=447060
X4288 4194 825 2 4147 1 4154 MUX2S $T=746480 477680 0 180 $X=742140 $Y=472260
X4289 4201 809 2 3992 1 4156 MUX2S $T=746480 497840 1 180 $X=742140 $Y=497460
X4290 4196 839 2 4135 1 4172 MUX2S $T=747100 477680 1 180 $X=742760 $Y=477300
X4291 4212 813 2 4138 1 4030 MUX2S $T=747720 497840 0 180 $X=743380 $Y=492420
X4292 4206 4063 2 4162 1 4179 MUX2S $T=748340 457520 0 180 $X=744000 $Y=452100
X4293 4220 4200 2 4179 1 4183 MUX2S $T=749580 437360 0 180 $X=745240 $Y=431940
X4294 4213 4200 2 4146 1 4174 MUX2S $T=750200 447440 0 180 $X=745860 $Y=442020
X4295 4228 813 2 4029 1 3996 MUX2S $T=750200 487760 0 180 $X=745860 $Y=482340
X4296 855 809 2 4198 1 4151 MUX2S $T=750820 326480 1 180 $X=746480 $Y=326100
X4297 4205 4063 2 4219 1 4220 MUX2S $T=747100 447440 0 0 $X=747100 $Y=447060
X4298 4235 809 2 4031 1 4202 MUX2S $T=752060 497840 1 180 $X=747720 $Y=497460
X4299 4221 825 2 4194 1 4196 MUX2S $T=752680 477680 1 180 $X=748340 $Y=477300
X4300 848 809 2 4214 1 4131 MUX2S $T=753300 336560 1 180 $X=748960 $Y=336180
X4301 849 809 2 4215 1 4175 MUX2S $T=753300 356720 0 180 $X=748960 $Y=351300
X4302 4239 812 2 4041 1 3965 MUX2S $T=753300 437360 1 180 $X=748960 $Y=436980
X4303 4218 813 2 4233 1 846 MUX2S $T=749580 346640 1 0 $X=749580 $Y=341220
X4304 4237 839 2 4195 1 4212 MUX2S $T=753920 497840 0 180 $X=749580 $Y=492420
X4305 853 809 2 4224 1 4153 MUX2S $T=754540 386960 0 180 $X=750200 $Y=381540
X4306 856 809 2 4229 1 4139 MUX2S $T=755160 346640 1 180 $X=750820 $Y=346260
X4307 4233 813 2 4230 1 4214 MUX2S $T=755160 366800 1 180 $X=750820 $Y=366420
X4308 4217 825 2 4221 1 4195 MUX2S $T=755160 477680 0 180 $X=750820 $Y=472260
X4309 854 809 2 4231 1 4158 MUX2S $T=755780 376880 1 180 $X=751440 $Y=376500
X4310 4248 839 2 4196 1 4228 MUX2S $T=755780 487760 0 180 $X=751440 $Y=482340
X4311 846 809 2 4241 1 4171 MUX2S $T=752060 376880 1 0 $X=752060 $Y=371460
X4312 4198 809 2 4234 1 4199 MUX2S $T=756400 397040 1 180 $X=752060 $Y=396660
X4313 4258 812 2 4122 1 4014 MUX2S $T=756400 427280 1 180 $X=752060 $Y=426900
X4314 4251 812 2 4183 1 4159 MUX2S $T=756400 437360 0 180 $X=752060 $Y=431940
X4315 4246 812 2 4174 1 4136 MUX2S $T=756400 447440 0 180 $X=752060 $Y=442020
X4316 4214 809 2 4244 1 4188 MUX2S $T=752680 386960 0 0 $X=752680 $Y=386580
X4317 4261 4063 2 4205 1 4236 MUX2S $T=757640 447440 1 180 $X=753300 $Y=447060
X4318 4257 813 2 4172 1 4057 MUX2S $T=758260 497840 1 180 $X=753920 $Y=497460
X4319 851 809 2 4250 1 4170 MUX2S $T=754540 356720 0 0 $X=754540 $Y=356340
X4320 4267 825 2 4238 1 4237 MUX2S $T=758880 477680 1 180 $X=754540 $Y=477300
X4321 4262 813 2 4243 1 853 MUX2S $T=759500 356720 0 180 $X=755160 $Y=351300
X4322 4236 4200 2 4213 1 4239 MUX2S $T=759500 437360 1 180 $X=755160 $Y=436980
X4323 858 813 2 4247 1 851 MUX2S $T=760120 346640 0 180 $X=755780 $Y=341220
X4324 4243 813 2 4264 1 4215 MUX2S $T=755780 386960 1 0 $X=755780 $Y=381540
X4325 4229 809 2 4244 1 4225 MUX2S $T=755780 407120 0 0 $X=755780 $Y=406740
X4326 4259 813 2 4255 1 4229 MUX2S $T=761360 366800 1 180 $X=757020 $Y=366420
X4327 4255 813 2 4244 1 4231 MUX2S $T=761360 376880 1 180 $X=757020 $Y=376500
X4328 4260 813 2 4244 1 4234 MUX2S $T=761360 397040 1 180 $X=757020 $Y=396660
X4329 4238 825 2 4217 1 4248 MUX2S $T=757020 477680 1 0 $X=757020 $Y=472260
X4330 4245 813 2 4259 1 854 MUX2S $T=761980 346640 1 180 $X=757640 $Y=346260
X4331 4230 813 2 4244 1 4241 MUX2S $T=761980 376880 0 180 $X=757640 $Y=371460
X4332 4270 813 2 4260 1 4250 MUX2S $T=761980 397040 0 180 $X=757640 $Y=391620
X4333 4283 841 2 3979 1 4249 MUX2S $T=761980 437360 0 180 $X=757640 $Y=431940
X4334 4280 813 2 4228 1 4058 MUX2S $T=761980 487760 0 180 $X=757640 $Y=482340
X4335 4264 813 2 4244 1 4224 MUX2S $T=762600 386960 1 180 $X=758260 $Y=386580
X4336 4265 4200 2 4220 1 4258 MUX2S $T=762600 427280 1 180 $X=758260 $Y=426900
X4337 4247 813 2 4270 1 4198 MUX2S $T=763840 356720 1 180 $X=759500 $Y=356340
X4338 4286 839 2 4248 1 4257 MUX2S $T=764460 477680 1 180 $X=760120 $Y=477300
X4339 4287 813 2 4137 1 4110 MUX2S $T=764460 497840 1 180 $X=760120 $Y=497460
X4340 4215 809 2 4244 1 4306 MUX2S $T=760740 407120 0 0 $X=760740 $Y=406740
X4341 4268 839 2 4278 1 4262 MUX2S $T=765700 356720 0 180 $X=761360 $Y=351300
X4342 4288 839 2 4282 1 4230 MUX2S $T=766320 386960 0 180 $X=761980 $Y=381540
X4343 4304 809 2 3996 1 4277 MUX2S $T=766320 497840 0 180 $X=761980 $Y=492420
X4344 4278 839 2 4285 1 4233 MUX2S $T=766940 366800 0 180 $X=762600 $Y=361380
X4345 4289 839 2 4244 1 4260 MUX2S $T=766940 407120 0 180 $X=762600 $Y=401700
X4346 4285 839 2 4288 1 4243 MUX2S $T=767560 376880 1 180 $X=763220 $Y=376500
X4347 4302 839 2 4293 1 4259 MUX2S $T=768180 376880 0 180 $X=763840 $Y=371460
X4348 4275 839 2 4299 1 4245 MUX2S $T=768800 346640 1 180 $X=764460 $Y=346260
X4349 4293 839 2 4300 1 4270 MUX2S $T=768800 386960 1 180 $X=764460 $Y=386580
X4350 4299 839 2 4302 1 4247 MUX2S $T=769420 356720 1 180 $X=765080 $Y=356340
X4351 4250 809 2 4244 1 4307 MUX2S $T=766940 407120 0 0 $X=766940 $Y=406740
X4352 4323 825 2 4313 1 4268 MUX2S $T=772520 356720 0 180 $X=768180 $Y=351300
X4353 4338 4200 2 4281 1 4311 MUX2S $T=772520 437360 1 180 $X=768180 $Y=436980
X4354 4322 825 2 4317 1 4278 MUX2S $T=773140 366800 0 180 $X=768800 $Y=361380
X4355 4341 825 2 4318 1 4285 MUX2S $T=773140 376880 1 180 $X=768800 $Y=376500
X4356 4318 825 2 4319 1 4293 MUX2S $T=773140 386960 0 180 $X=768800 $Y=381540
X4357 4327 825 2 4321 1 4300 MUX2S $T=773760 397040 0 180 $X=769420 $Y=391620
X4358 4313 825 2 4322 1 4299 MUX2S $T=774380 356720 1 180 $X=770040 $Y=356340
X4359 4319 825 2 4327 1 4288 MUX2S $T=775000 386960 1 180 $X=770660 $Y=386580
X4360 4317 825 2 4341 1 4302 MUX2S $T=772520 376880 1 0 $X=772520 $Y=371460
X4361 4321 825 2 4340 1 4282 MUX2S $T=772520 397040 0 0 $X=772520 $Y=396660
X4362 4380 813 2 4280 1 4304 MUX2S $T=783060 477680 1 180 $X=778720 $Y=477300
X4363 4330 4273 2 4351 1 4357 MUX2S $T=783680 447440 1 180 $X=779340 $Y=447060
X4364 4365 4273 2 4349 1 4406 MUX2S $T=782440 397040 1 0 $X=782440 $Y=391620
X4365 4348 4273 2 4399 1 4409 MUX2S $T=783060 386960 1 0 $X=783060 $Y=381540
X4366 4410 841 2 4378 1 4379 MUX2S $T=788020 407120 1 180 $X=783680 $Y=406740
X4367 4390 4273 2 4404 1 4432 MUX2S $T=784920 366800 1 0 $X=784920 $Y=361380
X4368 4394 4273 2 4390 1 4427 MUX2S $T=785540 356720 1 0 $X=785540 $Y=351300
X4369 4396 4200 2 4378 1 4425 MUX2S $T=785540 407120 1 0 $X=785540 $Y=401700
X4370 4399 4273 2 4365 1 4428 MUX2S $T=786160 386960 0 0 $X=786160 $Y=386580
X4371 4404 4273 2 4391 1 4445 MUX2S $T=786780 366800 0 0 $X=786780 $Y=366420
X4372 4428 4200 2 4396 1 4416 MUX2S $T=792360 397040 0 180 $X=788020 $Y=391620
X4373 4386 4273 2 4348 1 4439 MUX2S $T=788640 386960 1 0 $X=788640 $Y=381540
X4374 4449 841 2 4378 1 4400 MUX2S $T=793600 407120 1 180 $X=789260 $Y=406740
X4375 4427 4200 2 4445 1 4455 MUX2S $T=791120 356720 1 0 $X=791120 $Y=351300
X4376 4432 4200 2 4433 1 4467 MUX2S $T=791120 366800 1 0 $X=791120 $Y=361380
X4377 4457 812 2 4425 1 4410 MUX2S $T=795460 407120 0 180 $X=791120 $Y=401700
X4378 4439 4200 2 4428 1 4457 MUX2S $T=792360 386960 0 0 $X=792360 $Y=386580
X4379 4384 4200 2 4432 1 4465 MUX2S $T=792980 346640 0 0 $X=792980 $Y=346260
X4380 4445 4200 2 4423 1 4461 MUX2S $T=793600 366800 0 0 $X=793600 $Y=366420
X4381 4406 4200 2 4378 1 4470 MUX2S $T=793600 397040 1 0 $X=793600 $Y=391620
X4382 4409 4200 2 4406 1 4483 MUX2S $T=794840 386960 1 0 $X=794840 $Y=381540
X4383 4480 841 2 4378 1 4441 MUX2S $T=800420 407120 1 180 $X=796080 $Y=406740
X4384 4431 812 2 4461 1 891 MUX2S $T=796700 356720 1 0 $X=796700 $Y=351300
X4385 4425 812 2 4378 1 4485 MUX2S $T=796700 407120 1 0 $X=796700 $Y=401700
X4386 4465 812 2 4462 1 894 MUX2S $T=797320 356720 0 0 $X=797320 $Y=356340
X4387 4462 812 2 4416 1 4480 MUX2S $T=798560 386960 0 0 $X=798560 $Y=386580
X4388 4455 812 2 4456 1 896 MUX2S $T=799180 366800 0 0 $X=799180 $Y=366420
X4389 4456 812 2 4470 1 4449 MUX2S $T=799180 397040 1 0 $X=799180 $Y=391620
X4390 889 841 2 4489 1 4506 MUX2S $T=799800 336560 0 0 $X=799800 $Y=336180
X4391 4483 812 2 4378 1 4508 MUX2S $T=800420 386960 1 0 $X=800420 $Y=381540
X4392 893 841 2 4480 1 4513 MUX2S $T=801660 346640 0 0 $X=801660 $Y=346260
X4393 4489 841 2 4378 1 4500 MUX2S $T=801660 407120 0 0 $X=801660 $Y=406740
X4394 4469 812 2 4467 1 892 MUX2S $T=806620 356720 0 180 $X=802280 $Y=351300
X4395 4491 841 2 4485 1 4523 MUX2S $T=802280 407120 1 0 $X=802280 $Y=401700
X4396 891 841 2 4508 1 4531 MUX2S $T=802900 376880 0 0 $X=802900 $Y=376500
X4397 887 841 2 4449 1 4520 MUX2S $T=803520 356720 0 0 $X=803520 $Y=356340
X4398 895 841 2 4491 1 4507 MUX2S $T=804140 336560 1 0 $X=804140 $Y=331140
X4399 892 841 2 4410 1 4526 MUX2S $T=804140 376880 1 0 $X=804140 $Y=371460
X4400 4416 812 2 4378 1 4532 MUX2S $T=804760 386960 0 0 $X=804760 $Y=386580
X4401 4470 812 2 4378 1 4529 MUX2S $T=804760 397040 1 0 $X=804760 $Y=391620
X4402 894 841 2 4532 1 4543 MUX2S $T=806000 386960 1 0 $X=806000 $Y=381540
X4403 896 841 2 4529 1 4544 MUX2S $T=810340 397040 1 0 $X=810340 $Y=391620
X4404 1400 5 2 1 1375 33 MUX2 $T=235600 487760 0 180 $X=231260 $Y=482340
X4405 1410 59 2 1 29 1386 MUX2 $T=237460 497840 1 180 $X=233120 $Y=497460
X4406 1421 5 2 1 1354 51 MUX2 $T=237460 507920 0 180 $X=233120 $Y=502500
X4407 1386 59 2 1 33 53 MUX2 $T=238080 518000 1 180 $X=233740 $Y=517620
X4408 1416 59 2 1 1333 1437 MUX2 $T=237460 467600 1 0 $X=237460 $Y=462180
X4409 1434 5 2 1 1307 69 MUX2 $T=242420 477680 1 180 $X=238080 $Y=477300
X4410 1333 5 2 1 1389 71 MUX2 $T=243040 518000 0 180 $X=238700 $Y=512580
X4411 1443 5 2 1 1376 74 MUX2 $T=243660 497840 0 180 $X=239320 $Y=492420
X4412 1459 59 2 1 66 83 MUX2 $T=246760 507920 1 180 $X=242420 $Y=507540
X4413 1437 59 2 1 69 92 MUX2 $T=248620 518000 0 180 $X=244280 $Y=512580
X4414 1458 42 2 1 1437 1489 MUX2 $T=244900 497840 1 0 $X=244900 $Y=492420
X4415 1493 42 2 1 1450 1458 MUX2 $T=249860 487760 1 180 $X=245520 $Y=487380
X4416 1499 1490 2 1 1458 1472 MUX2 $T=250480 477680 1 180 $X=246140 $Y=477300
X4417 1486 42 2 1 1459 1475 MUX2 $T=251100 477680 0 180 $X=246760 $Y=472260
X4418 1488 42 2 1 83 102 MUX2 $T=252340 507920 1 180 $X=248000 $Y=507540
X4419 1489 42 2 1 1449 1462 MUX2 $T=252960 507920 0 180 $X=248620 $Y=502500
X4420 1475 42 2 1 1386 1488 MUX2 $T=254200 497840 1 180 $X=249860 $Y=497460
X4421 1472 1490 2 1 1475 1527 MUX2 $T=251100 487760 1 0 $X=251100 $Y=482340
X4422 1527 128 2 1 1489 1500 MUX2 $T=255440 497840 0 180 $X=251100 $Y=492420
X4423 1523 128 2 1 1462 1509 MUX2 $T=258540 507920 1 180 $X=254200 $Y=507540
X4424 1512 1490 2 1 1486 1499 MUX2 $T=259780 477680 1 180 $X=255440 $Y=477300
X4425 1500 128 2 1 1488 1523 MUX2 $T=259780 507920 0 180 $X=255440 $Y=502500
X4426 1728 132 2 1 1652 181 MUX2 $T=288920 477680 1 180 $X=284580 $Y=477300
X4427 1719 132 2 1 1677 187 MUX2 $T=290780 518000 1 180 $X=286440 $Y=517620
X4428 1754 132 2 1 1665 193 MUX2 $T=293260 477680 0 180 $X=288920 $Y=472260
X4429 1773 132 2 1 1650 190 MUX2 $T=293260 497840 0 180 $X=288920 $Y=492420
X4430 1766 132 2 1 1660 195 MUX2 $T=293880 487760 1 180 $X=289540 $Y=487380
X4431 1753 204 2 1 182 1740 MUX2 $T=294500 507920 1 180 $X=290160 $Y=507540
X4432 1769 204 2 1 181 198 MUX2 $T=295120 518000 0 180 $X=290780 $Y=512580
X4433 1739 1736 2 1 1719 1769 MUX2 $T=292020 477680 0 0 $X=292020 $Y=477300
X4434 1771 1736 2 1 1743 1762 MUX2 $T=298840 487760 0 180 $X=294500 $Y=482340
X4435 1784 215 2 1 1762 1768 MUX2 $T=299460 497840 1 180 $X=295120 $Y=497460
X4436 1776 204 2 1 185 1794 MUX2 $T=296360 507920 0 0 $X=296360 $Y=507540
X4437 1762 204 2 1 193 216 MUX2 $T=296360 518000 1 0 $X=296360 $Y=512580
X4438 1797 1761 2 1 1776 1784 MUX2 $T=302560 477680 0 180 $X=298220 $Y=472260
X4439 1775 1761 2 1 1753 1790 MUX2 $T=303800 477680 1 180 $X=299460 $Y=477300
X4440 1790 215 2 1 1769 1793 MUX2 $T=304420 497840 0 180 $X=300080 $Y=492420
X4441 1793 215 2 1 1740 1795 MUX2 $T=305040 507920 0 180 $X=300700 $Y=502500
X4442 1768 215 2 1 1794 1798 MUX2 $T=305660 497840 1 180 $X=301320 $Y=497460
X4443 1828 1833 2 1 1775 1808 MUX2 $T=308760 457520 1 180 $X=304420 $Y=457140
X4444 1818 236 2 1 1790 1816 MUX2 $T=310000 477680 1 180 $X=305660 $Y=477300
X4445 1828 1748 2 1 1784 1818 MUX2 $T=310620 467600 1 180 $X=306280 $Y=467220
X4446 1816 236 2 1 1768 1812 MUX2 $T=310620 497840 0 180 $X=306280 $Y=492420
X4447 1821 236 2 1 1798 1820 MUX2 $T=311240 507920 0 180 $X=306900 $Y=502500
X4448 1812 236 2 1 1793 1821 MUX2 $T=311860 497840 1 180 $X=307520 $Y=497460
X4449 1890 210 2 1 1862 1859 MUX2 $T=322400 507920 0 180 $X=318060 $Y=502500
X4450 1844 210 2 1 1907 1883 MUX2 $T=323640 507920 0 0 $X=323640 $Y=507540
X4451 1900 210 2 1 1879 1920 MUX2 $T=326120 497840 1 0 $X=326120 $Y=492420
X4452 1918 228 2 1 1915 1881 MUX2 $T=332940 507920 1 180 $X=328600 $Y=507540
X4453 1946 210 2 1 1918 1890 MUX2 $T=333560 507920 0 180 $X=329220 $Y=502500
X4454 1881 228 2 1 277 278 MUX2 $T=329220 518000 0 0 $X=329220 $Y=517620
X4455 1920 210 2 1 1949 1946 MUX2 $T=329840 497840 0 0 $X=329840 $Y=497460
X4456 1879 228 2 1 1952 1918 MUX2 $T=331700 487760 1 0 $X=331700 $Y=482340
X4457 1965 228 2 1 1939 1949 MUX2 $T=339140 507920 0 180 $X=334800 $Y=502500
X4458 1949 228 2 1 1967 1862 MUX2 $T=334800 507920 0 0 $X=334800 $Y=507540
X4459 1862 228 2 1 291 1907 MUX2 $T=334800 518000 1 0 $X=334800 $Y=512580
X4460 1975 292 2 1 1973 1967 MUX2 $T=344720 507920 0 180 $X=340380 $Y=502500
X4461 1915 292 2 1 308 302 MUX2 $T=340380 507920 0 0 $X=340380 $Y=507540
X4462 1967 292 2 1 305 294 MUX2 $T=340380 518000 1 0 $X=340380 $Y=512580
X4463 2000 292 2 1 298 1915 MUX2 $T=345960 497840 1 180 $X=341620 $Y=497460
X4464 1952 292 2 1 307 277 MUX2 $T=345340 518000 0 0 $X=345340 $Y=517620
X4465 1939 292 2 1 314 291 MUX2 $T=346580 507920 1 0 $X=346580 $Y=502500
X4466 1973 313 2 1 2042 317 MUX2 $T=350300 518000 0 0 $X=350300 $Y=517620
X4467 2021 313 2 1 2047 305 MUX2 $T=350920 487760 0 0 $X=350920 $Y=487380
X4468 2027 313 2 1 2054 308 MUX2 $T=350920 497840 0 0 $X=350920 $Y=497460
X4469 2022 313 2 1 2059 318 MUX2 $T=351540 507920 1 0 $X=351540 $Y=502500
X4470 2029 313 2 1 2062 319 MUX2 $T=351540 507920 0 0 $X=351540 $Y=507540
X4471 2307 348 2 1 2212 2281 MUX2 $T=403620 326480 0 180 $X=399280 $Y=321060
X4472 360 348 2 1 2232 2279 MUX2 $T=406100 346640 0 180 $X=401760 $Y=341220
X4473 358 348 2 1 2247 2283 MUX2 $T=407340 326480 1 180 $X=403000 $Y=326100
X4474 365 2297 2 1 349 2310 MUX2 $T=409200 336560 0 180 $X=404860 $Y=331140
X4475 361 353 2 1 366 2350 MUX2 $T=407340 326480 1 0 $X=407340 $Y=321060
X4476 2353 353 2 1 359 2337 MUX2 $T=412920 326480 1 180 $X=408580 $Y=326100
X4477 367 2297 2 1 351 2354 MUX2 $T=411060 336560 1 0 $X=411060 $Y=331140
X4478 2369 2360 2 1 2350 2363 MUX2 $T=418500 336560 1 180 $X=414160 $Y=336180
X4479 2381 2360 2 1 2337 2364 MUX2 $T=418500 346640 0 180 $X=414160 $Y=341220
X4480 371 373 2 1 367 2369 MUX2 $T=419120 326480 1 180 $X=414780 $Y=326100
X4481 2276 350 2 1 2317 2146 MUX2 $T=419120 487760 1 180 $X=414780 $Y=487380
X4482 375 373 2 1 2353 2373 MUX2 $T=420980 326480 0 180 $X=416640 $Y=321060
X4483 2373 373 2 1 365 2381 MUX2 $T=421600 336560 0 180 $X=417260 $Y=331140
X4484 2406 2402 2 1 2385 2292 MUX2 $T=422840 397040 0 180 $X=418500 $Y=391620
X4485 2415 377 2 1 2381 2392 MUX2 $T=424080 346640 0 180 $X=419740 $Y=341220
X4486 2392 377 2 1 2363 2394 MUX2 $T=424700 356720 0 180 $X=420360 $Y=351300
X4487 2417 377 2 1 371 2393 MUX2 $T=425320 326480 1 180 $X=420980 $Y=326100
X4488 2408 377 2 1 2369 2415 MUX2 $T=428420 336560 1 180 $X=424080 $Y=336180
X4489 369 377 2 1 375 2417 MUX2 $T=429660 326480 0 180 $X=425320 $Y=321060
X4490 2479 350 2 1 2444 2277 MUX2 $T=437100 477680 1 180 $X=432760 $Y=477300
X4491 2414 350 2 1 2450 2208 MUX2 $T=437100 487760 0 180 $X=432760 $Y=482340
X4492 2526 350 2 1 2466 2414 MUX2 $T=440820 487760 1 180 $X=436480 $Y=487380
X4493 400 401 2 1 2465 2498 MUX2 $T=443300 336560 1 180 $X=438960 $Y=336180
X4494 405 401 2 1 398 2514 MUX2 $T=447020 326480 0 180 $X=442680 $Y=321060
X4495 2542 401 2 1 399 2515 MUX2 $T=447020 326480 1 180 $X=442680 $Y=326100
X4496 403 401 2 1 2475 2518 MUX2 $T=447640 336560 0 180 $X=443300 $Y=331140
X4497 408 407 2 1 396 2532 MUX2 $T=448880 336560 1 180 $X=444540 $Y=336180
X4498 2526 350 2 1 2527 2479 MUX2 $T=448880 487760 1 180 $X=444540 $Y=487380
X4499 2544 407 2 1 400 2564 MUX2 $T=448880 336560 1 0 $X=448880 $Y=331140
X4500 2564 407 2 1 2515 2548 MUX2 $T=454460 346640 0 180 $X=450120 $Y=341220
X4501 2571 407 2 1 404 2552 MUX2 $T=455080 336560 1 180 $X=450740 $Y=336180
X4502 2526 350 2 1 2551 2521 MUX2 $T=455080 487760 1 180 $X=450740 $Y=487380
X4503 2562 407 2 1 403 2571 MUX2 $T=452600 326480 0 0 $X=452600 $Y=326100
X4504 2585 407 2 1 406 2565 MUX2 $T=459420 336560 0 180 $X=455080 $Y=331140
X4505 2596 416 2 1 2564 2578 MUX2 $T=460660 336560 1 180 $X=456320 $Y=336180
X4506 2578 416 2 1 2532 2579 MUX2 $T=460660 346640 0 180 $X=456320 $Y=341220
X4507 2526 350 2 1 2580 2595 MUX2 $T=456320 497840 1 0 $X=456320 $Y=492420
X4508 2603 425 2 1 2577 2525 MUX2 $T=465000 407120 0 180 $X=460660 $Y=401700
X4509 417 416 2 1 408 2596 MUX2 $T=465620 336560 0 180 $X=461280 $Y=331140
X4510 2607 416 2 1 2565 2604 MUX2 $T=466240 346640 0 180 $X=461900 $Y=341220
X4511 2622 425 2 1 2579 2605 MUX2 $T=466240 356720 1 180 $X=461900 $Y=356340
X4512 428 416 2 1 2571 2607 MUX2 $T=466860 336560 1 180 $X=462520 $Y=336180
X4513 426 416 2 1 2585 428 MUX2 $T=464380 326480 0 0 $X=464380 $Y=326100
X4514 2628 416 2 1 435 432 MUX2 $T=466860 518000 1 0 $X=466860 $Y=512580
X4515 2634 425 2 1 428 2696 MUX2 $T=467480 336560 1 0 $X=467480 $Y=331140
X4516 2642 425 2 1 2604 2622 MUX2 $T=471820 356720 0 180 $X=467480 $Y=351300
X4517 2608 425 2 1 417 2634 MUX2 $T=472440 326480 0 180 $X=468100 $Y=321060
X4518 2668 425 2 1 2607 2641 MUX2 $T=472440 336560 1 180 $X=468100 $Y=336180
X4519 2641 425 2 1 2578 2642 MUX2 $T=472440 346640 0 180 $X=468100 $Y=341220
X4520 2650 425 2 1 2664 2673 MUX2 $T=469340 467600 0 0 $X=469340 $Y=467220
X4521 2674 416 2 1 433 432 MUX2 $T=474920 518000 1 180 $X=470580 $Y=517620
X4522 2660 416 2 1 2698 2674 MUX2 $T=473060 518000 1 0 $X=473060 $Y=512580
X4523 2696 425 2 1 2596 2668 MUX2 $T=478020 336560 1 180 $X=473680 $Y=336180
X4524 2730 416 2 1 2678 2664 MUX2 $T=479260 457520 0 180 $X=474920 $Y=452100
X4525 2681 425 2 1 2700 2650 MUX2 $T=475540 467600 1 0 $X=475540 $Y=462180
X4526 2653 425 2 1 2674 432 MUX2 $T=479880 507920 1 180 $X=475540 $Y=507540
X4527 2717 450 2 1 445 2695 MUX2 $T=481740 326480 1 180 $X=477400 $Y=326100
X4528 2690 442 2 1 453 2705 MUX2 $T=478640 477680 0 0 $X=478640 $Y=477300
X4529 2737 416 2 1 2690 2700 MUX2 $T=483600 467600 1 180 $X=479260 $Y=467220
X4530 2700 416 2 1 2727 2656 MUX2 $T=479880 477680 1 0 $X=479880 $Y=472260
X4531 2670 425 2 1 2730 2681 MUX2 $T=480500 457520 0 0 $X=480500 $Y=457140
X4532 465 2723 2 1 452 2722 MUX2 $T=487320 326480 0 180 $X=482980 $Y=321060
X4533 2725 416 2 1 2686 2737 MUX2 $T=482980 467600 1 0 $X=482980 $Y=462180
X4534 2743 2723 2 1 2717 2726 MUX2 $T=487940 326480 1 180 $X=483600 $Y=326100
X4535 2726 2723 2 1 463 2740 MUX2 $T=483600 336560 1 0 $X=483600 $Y=331140
X4536 455 446 2 1 2701 2741 MUX2 $T=483600 356720 0 0 $X=483600 $Y=356340
X4537 2722 2723 2 1 459 2744 MUX2 $T=484220 346640 1 0 $X=484220 $Y=341220
X4538 2746 456 2 1 2731 439 MUX2 $T=488560 497840 1 180 $X=484220 $Y=497460
X4539 459 450 2 1 467 2750 MUX2 $T=484840 346640 0 0 $X=484840 $Y=346260
X4540 2752 442 2 1 2732 2694 MUX2 $T=489180 477680 1 180 $X=484840 $Y=477300
X4541 2686 407 2 1 2721 2727 MUX2 $T=489800 477680 0 180 $X=485460 $Y=472260
X4542 463 450 2 1 451 2751 MUX2 $T=486700 356720 1 0 $X=486700 $Y=351300
X4543 2771 425 2 1 2737 2670 MUX2 $T=491660 457520 1 180 $X=487320 $Y=457140
X4544 2779 2780 2 1 465 2749 MUX2 $T=492900 326480 0 180 $X=488560 $Y=321060
X4545 2749 2780 2 1 2726 2753 MUX2 $T=493520 336560 0 180 $X=489180 $Y=331140
X4546 2747 425 2 1 2782 2733 MUX2 $T=489180 437360 0 0 $X=489180 $Y=436980
X4547 2753 2780 2 1 2722 2757 MUX2 $T=494140 346640 0 180 $X=489800 $Y=341220
X4548 2789 456 2 1 2765 470 MUX2 $T=494760 497840 1 180 $X=490420 $Y=497460
X4549 2740 2723 2 1 2695 2769 MUX2 $T=495380 346640 1 180 $X=491040 $Y=346260
X4550 2759 425 2 1 2798 2771 MUX2 $T=491040 457520 1 0 $X=491040 $Y=452100
X4551 2760 456 2 1 2800 453 MUX2 $T=491040 477680 0 0 $X=491040 $Y=477300
X4552 2766 407 2 1 2746 2690 MUX2 $T=491660 477680 1 0 $X=491660 $Y=472260
X4553 2777 456 2 1 2794 2764 MUX2 $T=491660 487760 1 0 $X=491660 $Y=482340
X4554 2798 416 2 1 2752 2730 MUX2 $T=496620 447440 1 180 $X=492280 $Y=447060
X4555 2755 456 2 1 471 2772 MUX2 $T=496620 518000 0 180 $X=492280 $Y=512580
X4556 2744 2723 2 1 457 2781 MUX2 $T=497240 356720 0 180 $X=492900 $Y=351300
X4557 2783 456 2 1 2816 2755 MUX2 $T=493520 487760 0 0 $X=493520 $Y=487380
X4558 2802 407 2 1 2788 2678 MUX2 $T=498480 437360 1 180 $X=494140 $Y=436980
X4559 2782 416 2 1 2802 2798 MUX2 $T=495380 447440 1 0 $X=495380 $Y=442020
X4560 2757 2780 2 1 2740 2797 MUX2 $T=500340 346640 0 180 $X=496000 $Y=341220
X4561 2795 456 2 1 2853 2721 MUX2 $T=496000 467600 1 0 $X=496000 $Y=462180
X4562 2803 456 2 1 2826 2732 MUX2 $T=496620 467600 0 0 $X=496620 $Y=467220
X4563 2797 2780 2 1 2744 2807 MUX2 $T=501580 346640 1 180 $X=497240 $Y=346260
X4564 2807 2780 2 1 2769 2815 MUX2 $T=504060 356720 0 180 $X=499720 $Y=351300
X4565 2823 407 2 1 2789 2752 MUX2 $T=500340 457520 1 0 $X=500340 $Y=452100
X4566 2851 2780 2 1 2825 2692 MUX2 $T=507160 407120 0 180 $X=502820 $Y=401700
X4567 2890 2886 2 1 2909 501 MUX2 $T=513980 518000 1 0 $X=513980 $Y=512580
X4568 2911 2886 2 1 2938 2913 MUX2 $T=518940 487760 1 0 $X=518940 $Y=482340
X4569 2909 2933 2 1 2922 501 MUX2 $T=523900 518000 0 180 $X=519560 $Y=512580
X4570 2931 2886 2 1 2971 2930 MUX2 $T=522660 457520 0 0 $X=522660 $Y=457140
X4571 2930 2886 2 1 2976 2944 MUX2 $T=522660 467600 0 0 $X=522660 $Y=467220
X4572 2921 2933 2 1 2964 2909 MUX2 $T=522660 507920 0 0 $X=522660 $Y=507540
X4573 2955 377 2 1 2989 2907 MUX2 $T=525760 457520 1 0 $X=525760 $Y=452100
X4574 2936 377 2 1 3002 2955 MUX2 $T=528240 447440 1 0 $X=528240 $Y=442020
X4575 2997 2933 2 1 2974 2976 MUX2 $T=532580 457520 1 180 $X=528240 $Y=457140
X4576 2971 2933 2 1 3003 2962 MUX2 $T=528860 477680 1 0 $X=528860 $Y=472260
X4577 2908 2933 2 1 2958 501 MUX2 $T=533200 507920 1 180 $X=528860 $Y=507540
X4578 2934 2933 2 1 3013 2989 MUX2 $T=530720 457520 1 0 $X=530720 $Y=452100
X4579 3001 2933 2 1 3010 3002 MUX2 $T=532580 437360 0 0 $X=532580 $Y=436980
X4580 3002 2933 2 1 3020 2997 MUX2 $T=532580 447440 0 0 $X=532580 $Y=447060
X4581 2989 2933 2 1 3038 2971 MUX2 $T=533820 457520 0 0 $X=533820 $Y=457140
X4582 3013 540 2 1 3031 3003 MUX2 $T=534440 467600 0 0 $X=534440 $Y=467220
X4583 3038 540 2 1 3014 2991 MUX2 $T=538780 477680 0 180 $X=534440 $Y=472260
X4584 3020 540 2 1 3043 2990 MUX2 $T=536300 457520 1 0 $X=536300 $Y=452100
X4585 3028 570 2 1 561 3019 MUX2 $T=540640 518000 1 180 $X=536300 $Y=517620
X4586 3025 570 2 1 560 3024 MUX2 $T=541260 518000 0 180 $X=536920 $Y=512580
X4587 3052 540 2 1 3027 3020 MUX2 $T=541880 447440 1 180 $X=537540 $Y=447060
X4588 3027 570 2 1 3072 3025 MUX2 $T=538160 487760 0 0 $X=538160 $Y=487380
X4589 3001 2933 2 1 3051 3002 MUX2 $T=538780 427280 0 0 $X=538780 $Y=426900
X4590 3066 570 2 1 3035 3028 MUX2 $T=543120 497840 0 180 $X=538780 $Y=492420
X4591 3032 540 2 1 3066 3038 MUX2 $T=539400 467600 1 0 $X=539400 $Y=462180
X4592 3053 570 2 1 3076 574 MUX2 $T=541260 477680 0 0 $X=541260 $Y=477300
X4593 3057 570 2 1 3073 3014 MUX2 $T=541880 467600 0 0 $X=541880 $Y=467220
X4594 3044 570 2 1 3090 3046 MUX2 $T=541880 487760 1 0 $X=541880 $Y=482340
X4595 3067 570 2 1 3123 3043 MUX2 $T=544980 457520 1 0 $X=544980 $Y=452100
X4596 3319 3327 2 1 655 3269 MUX2 $T=584040 518000 0 180 $X=579700 $Y=512580
X4597 3286 2780 2 1 3324 3255 MUX2 $T=582800 457520 0 0 $X=582800 $Y=457140
X4598 2902 2780 2 1 3316 3286 MUX2 $T=583420 457520 1 0 $X=583420 $Y=452100
X4599 3276 2780 2 1 3332 3269 MUX2 $T=584040 497840 0 0 $X=584040 $Y=497460
X4600 3330 3327 2 1 664 3269 MUX2 $T=589620 507920 1 180 $X=585280 $Y=507540
X4601 3304 2780 2 1 3259 3293 MUX2 $T=585900 447440 0 0 $X=585900 $Y=447060
X4602 3328 3327 2 1 3252 3269 MUX2 $T=590240 518000 1 180 $X=585900 $Y=517620
X4603 3384 3327 2 1 665 3269 MUX2 $T=590860 507920 0 180 $X=586520 $Y=502500
X4604 3293 2780 2 1 3341 2902 MUX2 $T=588380 457520 1 0 $X=588380 $Y=452100
X4605 3255 2780 2 1 3358 3317 MUX2 $T=589000 457520 0 0 $X=589000 $Y=457140
X4606 3354 3327 2 1 673 3333 MUX2 $T=595820 518000 1 180 $X=591480 $Y=517620
X4607 3259 3145 2 1 3361 3316 MUX2 $T=592100 447440 0 0 $X=592100 $Y=447060
X4608 3311 3145 2 1 3408 3341 MUX2 $T=599540 447440 0 0 $X=599540 $Y=447060
X4609 3341 3145 2 1 3413 3324 MUX2 $T=600780 457520 0 0 $X=600780 $Y=457140
X4610 3404 3327 2 1 682 3400 MUX2 $T=606980 518000 0 180 $X=602640 $Y=512580
X4611 3413 3364 2 1 3431 3383 MUX2 $T=603880 467600 0 0 $X=603880 $Y=467220
X4612 3408 3405 2 1 3443 3415 MUX2 $T=604500 457520 1 0 $X=604500 $Y=452100
X4613 3432 3327 2 1 689 3424 MUX2 $T=611940 497840 1 180 $X=607600 $Y=497460
X4614 3457 3327 2 1 3445 3412 MUX2 $T=613800 467600 1 180 $X=609460 $Y=467220
X4615 3442 3327 2 1 3465 3432 MUX2 $T=609460 487760 1 0 $X=609460 $Y=482340
X4616 3446 3327 2 1 3473 3435 MUX2 $T=610080 477680 0 0 $X=610080 $Y=477300
X4617 3361 3405 2 1 3479 3391 MUX2 $T=610700 457520 1 0 $X=610700 $Y=452100
X4618 3474 3327 2 1 3450 3404 MUX2 $T=615040 487760 1 180 $X=610700 $Y=487380
X4619 3430 3405 2 1 3474 3413 MUX2 $T=611940 457520 0 0 $X=611940 $Y=457140
X4620 3440 3327 2 1 3497 3431 MUX2 $T=612560 467600 1 0 $X=612560 $Y=462180
X4621 3485 3327 2 1 3523 3479 MUX2 $T=616900 457520 1 0 $X=616900 $Y=452100
X4622 3652 737 2 1 3673 3656 MUX2 $T=650380 447440 0 0 $X=650380 $Y=447060
X4623 3722 737 2 1 764 3680 MUX2 $T=665260 447440 1 180 $X=660920 $Y=447060
X4624 3739 737 2 1 3701 3722 MUX2 $T=668360 457520 0 180 $X=664020 $Y=452100
X4625 3757 737 2 1 3735 3678 MUX2 $T=671460 447440 0 180 $X=667120 $Y=442020
X4626 3739 737 2 1 3752 3757 MUX2 $T=667740 447440 0 0 $X=667740 $Y=447060
X4627 3739 737 2 1 3756 3744 MUX2 $T=675180 467600 0 180 $X=670840 $Y=462180
X4628 3739 737 2 1 3790 3775 MUX2 $T=672080 467600 0 0 $X=672080 $Y=467220
X4629 3919 789 2 1 788 3897 MUX2 $T=699360 326480 0 180 $X=695020 $Y=321060
X4630 800 789 2 1 3821 3903 MUX2 $T=701220 326480 1 180 $X=696880 $Y=326100
X4631 803 792 2 1 796 3928 MUX2 $T=704320 326480 0 180 $X=699980 $Y=321060
X4632 3942 792 2 1 3897 3933 MUX2 $T=704940 336560 1 180 $X=700600 $Y=336180
X4633 805 792 2 1 801 3938 MUX2 $T=706180 336560 0 180 $X=701840 $Y=331140
X4634 3965 3971 2 1 3867 3944 MUX2 $T=706800 447440 0 180 $X=702460 $Y=442020
X4635 806 792 2 1 800 3942 MUX2 $T=707420 326480 1 180 $X=703080 $Y=326100
X4636 3979 3971 2 1 3785 3956 MUX2 $T=708660 437360 1 180 $X=704320 $Y=436980
X4637 3991 809 2 1 3863 3968 MUX2 $T=711140 487760 0 180 $X=706800 $Y=482340
X4638 3992 809 2 1 3907 3968 MUX2 $T=711140 497840 0 180 $X=706800 $Y=492420
X4639 4031 809 2 1 3876 3968 MUX2 $T=711140 497840 1 180 $X=706800 $Y=497460
X4640 3995 3971 2 1 3838 3956 MUX2 $T=711760 447440 1 180 $X=707420 $Y=447060
X4641 4006 3971 2 1 3918 3956 MUX2 $T=711760 457520 0 180 $X=707420 $Y=452100
X4642 3996 809 2 1 3885 3972 MUX2 $T=711760 487760 1 180 $X=707420 $Y=487380
X4643 3985 807 2 1 3942 3976 MUX2 $T=712380 336560 0 180 $X=708040 $Y=331140
X4644 815 792 2 1 797 3978 MUX2 $T=713000 326480 1 180 $X=708660 $Y=326100
X4645 814 807 2 1 803 3985 MUX2 $T=714860 326480 0 180 $X=710520 $Y=321060
X4646 3976 3967 2 1 3928 3966 MUX2 $T=714860 346640 0 180 $X=710520 $Y=341220
X4647 4004 809 2 1 3927 3968 MUX2 $T=714860 477680 1 180 $X=710520 $Y=477300
X4648 4011 3967 2 1 3978 3994 MUX2 $T=715480 336560 1 180 $X=711140 $Y=336180
X4649 816 807 2 1 805 4011 MUX2 $T=717960 336560 0 180 $X=713620 $Y=331140
X4650 4035 3971 2 1 3891 3956 MUX2 $T=717960 457520 0 180 $X=713620 $Y=452100
X4651 4027 4025 2 1 3994 4023 MUX2 $T=719200 346640 1 180 $X=714860 $Y=346260
X4652 818 807 2 1 815 816 MUX2 $T=719820 326480 0 180 $X=715480 $Y=321060
X4653 4052 4025 2 1 3982 3878 MUX2 $T=719820 397040 1 180 $X=715480 $Y=396660
X4654 4032 4025 2 1 3976 4027 MUX2 $T=720440 346640 0 180 $X=716100 $Y=341220
X4655 4046 4025 2 1 4011 4032 MUX2 $T=721060 336560 1 180 $X=716720 $Y=336180
X4656 4056 4060 2 1 4007 3968 MUX2 $T=722300 487760 0 180 $X=717960 $Y=482340
X4657 4047 4063 2 1 4042 3956 MUX2 $T=722920 447440 1 180 $X=718580 $Y=447060
X4658 4061 824 2 1 3985 4046 MUX2 $T=723540 326480 1 180 $X=719200 $Y=326100
X4659 4042 4089 2 1 4013 3956 MUX2 $T=724780 447440 0 180 $X=720440 $Y=442020
X4660 4044 4089 2 1 4050 3956 MUX2 $T=726020 437360 1 180 $X=721680 $Y=436980
X4661 4045 825 2 1 4056 3968 MUX2 $T=726020 477680 1 180 $X=721680 $Y=477300
X4662 831 824 2 1 816 4061 MUX2 $T=727880 326480 1 180 $X=723540 $Y=326100
X4663 4069 4060 2 1 4065 4056 MUX2 $T=727880 487760 0 180 $X=723540 $Y=482340
X4664 4039 4060 2 1 4034 3968 MUX2 $T=728500 487760 1 180 $X=724160 $Y=487380
X4665 4087 4089 2 1 4082 4042 MUX2 $T=729120 447440 1 180 $X=724780 $Y=447060
X4666 4219 4063 2 1 4213 4206 MUX2 $T=754540 457520 0 180 $X=750200 $Y=452100
X4667 844 813 2 1 856 4245 MUX2 $T=752060 336560 1 0 $X=752060 $Y=331140
X4668 850 813 2 1 849 4262 MUX2 $T=753920 336560 0 0 $X=753920 $Y=336180
X4669 859 813 2 1 848 4218 MUX2 $T=758880 326480 0 180 $X=754540 $Y=321060
X4670 4276 813 2 1 4160 4212 MUX2 $T=760120 497840 0 180 $X=755780 $Y=492420
X4671 861 839 2 1 850 4254 MUX2 $T=762600 336560 0 180 $X=758260 $Y=331140
X4672 4281 4200 2 1 4246 4236 MUX2 $T=762600 447440 0 180 $X=758260 $Y=442020
X4673 4274 4273 2 1 4265 4261 MUX2 $T=763220 447440 1 180 $X=758880 $Y=447060
X4674 4254 839 2 1 4218 4268 MUX2 $T=763840 336560 1 180 $X=759500 $Y=336180
X4675 4292 839 2 1 844 4272 MUX2 $T=764460 326480 1 180 $X=760120 $Y=326100
X4676 4311 812 2 1 4033 4239 MUX2 $T=765700 437360 1 180 $X=761360 $Y=436980
X4677 4272 839 2 1 858 4275 MUX2 $T=766320 346640 0 180 $X=761980 $Y=341220
X4678 4301 825 2 1 4286 4267 MUX2 $T=767560 477680 0 180 $X=763220 $Y=472260
X4679 4298 839 2 1 4287 4237 MUX2 $T=767560 487760 0 180 $X=763220 $Y=482340
X4680 4308 825 2 1 861 4290 MUX2 $T=768180 336560 0 180 $X=763840 $Y=331140
X4681 4296 4200 2 1 4251 4265 MUX2 $T=768180 437360 0 180 $X=763840 $Y=431940
X4682 4291 4273 2 1 4281 4274 MUX2 $T=768800 447440 0 180 $X=764460 $Y=442020
X4683 4314 4273 2 1 4296 4291 MUX2 $T=768800 447440 1 180 $X=764460 $Y=447060
X4684 4315 825 2 1 4298 4301 MUX2 $T=769420 467600 1 180 $X=765080 $Y=467220
X4685 866 865 2 1 862 4292 MUX2 $T=770040 326480 0 180 $X=765700 $Y=321060
X4686 871 825 2 1 4292 4308 MUX2 $T=770660 326480 1 180 $X=766320 $Y=326100
X4687 4329 812 2 1 4144 4258 MUX2 $T=770660 427280 1 180 $X=766320 $Y=426900
X4688 4325 839 2 1 4280 4286 MUX2 $T=770660 477680 1 180 $X=766320 $Y=477300
X4689 4336 813 2 1 4201 4257 MUX2 $T=772520 497840 0 180 $X=768180 $Y=492420
X4690 4290 825 2 1 4272 4335 MUX2 $T=768800 336560 0 0 $X=768800 $Y=336180
X4691 4335 825 2 1 4254 4312 MUX2 $T=773140 346640 0 180 $X=768800 $Y=341220
X4692 4340 825 2 1 4289 4244 MUX2 $T=773140 407120 0 180 $X=768800 $Y=401700
X4693 4337 839 2 1 4276 4298 MUX2 $T=773140 487760 0 180 $X=768800 $Y=482340
X4694 4312 825 2 1 4275 4323 MUX2 $T=775000 346640 1 180 $X=770660 $Y=346260
X4695 4345 812 2 1 4184 4246 MUX2 $T=775000 447440 0 180 $X=770660 $Y=442020
X4696 4343 825 2 1 4325 4315 MUX2 $T=775000 467600 1 180 $X=770660 $Y=467220
X4697 4328 825 2 1 4337 4343 MUX2 $T=772520 477680 1 0 $X=772520 $Y=472260
X4698 4352 839 2 1 4336 4325 MUX2 $T=776860 477680 1 180 $X=772520 $Y=477300
X4699 4351 4273 2 1 4338 4314 MUX2 $T=777480 447440 1 180 $X=773140 $Y=447060
X4700 4357 4200 2 1 4329 4296 MUX2 $T=778100 437360 0 180 $X=773760 $Y=431940
X4701 4344 813 2 1 4235 4287 MUX2 $T=778100 497840 0 180 $X=773760 $Y=492420
X4702 4361 841 2 1 4339 3965 MUX2 $T=778720 437360 1 180 $X=774380 $Y=436980
X4703 4359 839 2 1 4344 4337 MUX2 $T=778720 487760 1 180 $X=774380 $Y=487380
X4704 4355 809 2 1 4331 4030 MUX2 $T=778720 497840 1 180 $X=774380 $Y=497460
X4705 4414 841 2 1 4346 4014 MUX2 $T=781820 427280 1 180 $X=777480 $Y=426900
X4706 4372 4200 2 1 4345 4338 MUX2 $T=781820 447440 0 180 $X=777480 $Y=442020
X4707 4370 825 2 1 4352 4328 MUX2 $T=782440 477680 0 180 $X=778100 $Y=472260
X4708 4382 812 2 1 4283 4251 MUX2 $T=783680 437360 0 180 $X=779340 $Y=431940
X4709 4356 4273 2 1 4384 4394 MUX2 $T=779960 356720 1 0 $X=779960 $Y=351300
X4710 4349 4273 2 1 4396 4378 MUX2 $T=779960 397040 0 0 $X=779960 $Y=396660
X4711 4388 813 2 1 4363 4336 MUX2 $T=784300 487760 1 180 $X=779960 $Y=487380
X4712 4398 813 2 1 4355 4276 MUX2 $T=784300 497840 0 180 $X=779960 $Y=492420
X4713 4363 809 2 1 4368 4057 MUX2 $T=784920 497840 1 180 $X=780580 $Y=497460
X4714 4371 4273 2 1 4393 4356 MUX2 $T=781200 346640 0 0 $X=781200 $Y=346260
X4715 4350 4273 2 1 4402 4342 MUX2 $T=781820 336560 0 0 $X=781820 $Y=336180
X4716 4342 4273 2 1 4395 4371 MUX2 $T=781820 346640 1 0 $X=781820 $Y=341220
X4717 4374 4273 2 1 4415 4383 MUX2 $T=782440 437360 0 0 $X=782440 $Y=436980
X4718 4373 4273 2 1 880 4360 MUX2 $T=783060 326480 0 0 $X=783060 $Y=326100
X4719 4360 4273 2 1 4408 4350 MUX2 $T=783680 336560 1 0 $X=783680 $Y=331140
X4720 4407 839 2 1 4380 4352 MUX2 $T=788640 477680 1 180 $X=784300 $Y=477300
X4721 4415 4200 2 1 4382 4357 MUX2 $T=789260 437360 0 180 $X=784920 $Y=431940
X4722 4402 4200 2 1 4430 4393 MUX2 $T=787400 346640 1 0 $X=787400 $Y=341220
X4723 4393 4200 2 1 4431 4427 MUX2 $T=787400 346640 0 0 $X=787400 $Y=346260
X4724 880 4200 2 1 883 4402 MUX2 $T=788020 326480 1 0 $X=788020 $Y=321060
X4725 4408 4200 2 1 884 4395 MUX2 $T=788020 336560 0 0 $X=788020 $Y=336180
X4726 4383 4273 2 1 4372 4330 MUX2 $T=792360 447440 1 180 $X=788020 $Y=447060
X4727 4418 809 2 1 4435 4110 MUX2 $T=788020 497840 0 0 $X=788020 $Y=497460
X4728 4443 812 2 1 4361 4311 MUX2 $T=793600 437360 1 180 $X=789260 $Y=436980
X4729 4419 809 2 1 4448 4160 MUX2 $T=789260 487760 0 0 $X=789260 $Y=487380
X4730 879 4200 2 1 4460 4408 MUX2 $T=792980 336560 1 0 $X=792980 $Y=331140
X4731 4395 4200 2 1 4469 4384 MUX2 $T=793600 346640 1 0 $X=793600 $Y=341220
X4732 4447 809 2 1 4471 4058 MUX2 $T=793600 487760 1 0 $X=793600 $Y=482340
X4733 883 812 2 1 889 4431 MUX2 $T=794220 336560 0 0 $X=794220 $Y=336180
X4734 4440 809 2 1 4474 4201 MUX2 $T=794220 497840 1 0 $X=794220 $Y=492420
X4735 4479 841 2 1 4412 4136 MUX2 $T=799180 447440 1 180 $X=794840 $Y=447060
X4736 886 812 2 1 890 4430 MUX2 $T=796700 326480 0 0 $X=796700 $Y=326100
X4737 4430 812 2 1 887 4455 MUX2 $T=801660 346640 1 180 $X=797320 $Y=346260
X4738 4460 812 2 1 895 4469 MUX2 $T=798560 336560 1 0 $X=798560 $Y=331140
X4739 884 812 2 1 893 4465 MUX2 $T=799800 346640 1 0 $X=799800 $Y=341220
X4740 4475 841 2 1 4503 4144 MUX2 $T=799800 427280 0 0 $X=799800 $Y=426900
X4741 4510 841 2 1 4481 4033 MUX2 $T=804140 447440 0 180 $X=799800 $Y=442020
X4742 4478 841 2 1 4501 4159 MUX2 $T=800420 437360 1 0 $X=800420 $Y=431940
X4743 4537 841 2 1 4504 4184 MUX2 $T=809100 447440 1 180 $X=804760 $Y=447060
X4744 1732 1703 1737 1 2 XOR2H $T=288920 417200 0 0 $X=288920 $Y=416820
X4745 2972 2963 2953 1 2 XOR2H $T=531340 407120 1 180 $X=522660 $Y=406740
X4746 2948 2939 2891 2 1 2992 XNR3 $T=523900 407120 1 0 $X=523900 $Y=401700
X4747 3398 3380 3406 2 1 3397 XNR3 $T=601400 386960 0 0 $X=601400 $Y=386580
X4748 3377 3392 3386 2 1 3372 XNR3 $T=602640 407120 0 0 $X=602640 $Y=406740
X4749 4084 4094 4088 2 1 4075 XNR3 $T=726640 397040 1 0 $X=726640 $Y=391620
X4750 2387 419 2658 2 2665 422 1 AO22S $T=469960 447440 0 0 $X=469960 $Y=447060
X4751 2215 419 2683 2 2693 422 1 AO22S $T=474300 437360 1 0 $X=474300 $Y=431940
X4752 3589 652 3532 2 3465 650 1 AO22S $T=632400 487760 0 180 $X=627440 $Y=482340
X4753 3794 3828 3786 2 3838 3862 1 AO22S $T=684480 467600 0 0 $X=684480 $Y=467220
X4754 3895 3917 3851 2 3927 3879 1 AO22S $T=696880 477680 0 0 $X=696880 $Y=477300
X4755 2888 388 2865 2 2857 2620 1 AO22P $T=512120 427280 0 0 $X=512120 $Y=426900
X4756 3377 419 3410 2 3414 650 1 AO22P $T=601400 417200 1 0 $X=601400 $Y=411780
X4757 2747 425 2828 2733 1 2 MXL2H $T=512740 507920 1 0 $X=512740 $Y=502500
X4758 2953 337 3008 2954 1 2 MXL2H $T=527620 397040 0 0 $X=527620 $Y=396660
X4759 3396 3405 3442 3429 1 2 MXL2H $T=606360 477680 1 0 $X=606360 $Y=472260
X4760 4385 4200 4421 4372 1 2 MXL2H $T=783680 447440 1 0 $X=783680 $Y=442020
X4761 4420 825 4397 4370 1 2 MXL2H $T=819640 417200 1 0 $X=819640 $Y=411780
X4762 4578 4667 4671 4641 1 2 MXL2H $T=834520 457520 0 0 $X=834520 $Y=457140
X4763 1797 1761 1781 1784 2 1 MXL2HS $T=305040 467600 1 180 $X=299460 $Y=467220
X4764 2663 407 2675 2686 2 1 MXL2HS $T=471820 457520 0 0 $X=471820 $Y=457140
X4765 2733 425 2748 2759 2 1 MXL2HS $T=485460 457520 1 0 $X=485460 $Y=452100
X4766 2776 416 2775 2725 2 1 MXL2HS $T=495380 427280 1 180 $X=489800 $Y=426900
X4767 2907 2886 3009 2931 2 1 MXL2HS $T=530720 467600 1 0 $X=530720 $Y=462180
X4768 3236 3145 3251 3259 2 1 MXL2HS $T=574120 447440 1 0 $X=574120 $Y=442020
X4769 3283 2780 3231 3304 2 1 MXL2HS $T=585900 447440 1 0 $X=585900 $Y=442020
X4770 4422 812 4414 4446 2 1 MXL2HS $T=789260 397040 0 0 $X=789260 $Y=396660
X4771 4451 812 4463 4345 2 1 MXL2HS $T=793600 437360 0 0 $X=793600 $Y=436980
X4772 2747 469 1 2644 2 NR2T $T=487320 447440 1 0 $X=487320 $Y=442020
X4773 2806 2828 1 416 2 NR2T $T=497860 427280 0 0 $X=497860 $Y=426900
X4774 4290 248 1 4305 2 NR2T $T=768800 336560 1 180 $X=763840 $Y=336180
X4775 4371 244 1 4354 2 NR2T $T=781820 346640 0 180 $X=776860 $Y=341220
X4776 4370 466 1 4043 2 NR2T $T=778100 467600 0 0 $X=778100 $Y=467220
X4777 4360 246 1 4354 2 NR2T $T=783680 336560 0 180 $X=778720 $Y=331140
X4778 4420 469 1 4043 2 NR2T $T=782440 477680 1 0 $X=782440 $Y=472260
X4779 20 1374 1379 1 2 1393 OR3B1 $T=230020 437360 0 0 $X=230020 $Y=436980
X4780 650 3240 3248 1 2 3271 OR3B1 $T=574740 437360 0 0 $X=574740 $Y=436980
X4781 1350 2 1353 1311 1 AN2B1S $T=226920 437360 1 0 $X=226920 $Y=431940
X4782 2852 2 2844 2863 1 AN2B1S $T=505300 437360 0 0 $X=505300 $Y=436980
X4783 2878 2 2925 2940 1 AN2B1S $T=518940 417200 0 0 $X=518940 $Y=416820
X4784 2927 2 3011 3018 1 AN2B1S $T=533200 407120 0 0 $X=533200 $Y=406740
X4785 4374 2 4273 4385 1 AN2B1S $T=794220 457520 1 0 $X=794220 $Y=452100
X4786 4584 2 4581 4566 1 AN2B1S $T=816540 487760 0 0 $X=816540 $Y=487380
X4787 133 1675 2 1693 1632 1630 1 AOI22H $T=277140 447440 1 0 $X=277140 $Y=442020
X4788 388 2906 2 2829 3045 2620 1 AOI22H $T=535680 437360 1 0 $X=535680 $Y=431940
X4789 337 3132 2 3048 3220 2984 1 AOI22H $T=567920 407120 0 0 $X=567920 $Y=406740
X4790 419 3441 2 3467 3470 650 1 AOI22H $T=634880 417200 0 0 $X=634880 $Y=416820
X4791 875 4703 2 4598 4651 4514 1 AOI22H $T=840720 457520 1 0 $X=840720 $Y=452100
X4792 1369 9 1357 1 2 1347 OA12 $T=231260 366800 0 180 $X=227540 $Y=361380
X4793 20 32 1481 1 2 1546 OA12 $T=253580 427280 0 0 $X=253580 $Y=426900
X4794 93 1558 135 1 2 1575 OA12 $T=259160 386960 1 0 $X=259160 $Y=381540
X4795 1630 133 1699 1 2 1666 OA12 $T=284580 427280 1 180 $X=280860 $Y=426900
X4796 1730 1783 1603 1 2 12 OA12 $T=303800 376880 1 180 $X=300080 $Y=376500
X4797 280 257 1926 1 2 1895 OA12 $T=335420 376880 1 180 $X=331700 $Y=376500
X4798 1931 279 1966 1 2 1981 OA12 $T=342240 346640 1 0 $X=342240 $Y=341220
X4799 533 550 2999 1 2 2975 OA12 $T=535060 326480 1 180 $X=531340 $Y=326100
X4800 520 3232 646 1 2 640 OA12 $T=575980 356720 0 180 $X=572260 $Y=351300
X4801 650 419 3273 1 2 3246 OA12 $T=582800 417200 0 180 $X=579080 $Y=411780
X4802 3307 3274 3300 1 2 579 OA12 $T=592720 356720 1 180 $X=589000 $Y=356340
X4803 710 3425 3466 1 2 3448 OA12 $T=621240 366800 1 180 $X=617520 $Y=366420
X4804 708 279 3561 1 2 3551 OA12 $T=632400 336560 0 180 $X=628680 $Y=331140
X4805 3879 832 4487 1 2 4663 OA12 $T=831420 467600 0 0 $X=831420 $Y=467220
X4806 972 954 970 1 2 4761 OA12 $T=850640 336560 0 0 $X=850640 $Y=336180
X4807 1018 938 4928 1 2 4938 OA12 $T=896520 356720 0 0 $X=896520 $Y=356340
X4808 1370 1305 1 1388 2 AN2S $T=230020 457520 0 0 $X=230020 $Y=457140
X4809 1936 1930 1 1951 2 AN2S $T=333560 397040 0 0 $X=333560 $Y=396660
X4810 2779 2768 1 2743 2 AN2S $T=491660 326480 1 180 $X=489180 $Y=326100
X4811 2844 2620 1 2838 2 AN2S $T=511500 417200 0 0 $X=511500 $Y=416820
X4812 2927 2919 1 2939 2 AN2S $T=519560 407120 1 0 $X=519560 $Y=401700
X4813 3308 3309 1 3315 2 AN2S $T=585280 427280 1 0 $X=585280 $Y=421860
X4814 3513 3514 1 3469 2 AN2S $T=620620 386960 1 180 $X=618140 $Y=386580
X4815 4363 4458 1 4527 2 AN2S $T=803520 487760 0 0 $X=803520 $Y=487380
X4816 4283 4516 1 4564 2 AN2S $T=812200 437360 1 0 $X=812200 $Y=431940
X4817 4688 4659 1 4668 2 AN2S $T=838240 397040 0 180 $X=835760 $Y=391620
X4818 4722 4645 1 4750 2 AN2S $T=847540 447440 1 0 $X=847540 $Y=442020
X4819 2965 2984 1 2972 2927 2984 2 MOAI1H $T=528240 417200 1 0 $X=528240 $Y=411780
X4820 1703 1711 1 1706 2 OR2B1S $T=282720 457520 1 0 $X=282720 $Y=452100
X4821 2877 2878 1 2935 2 OR2B1S $T=517700 437360 1 0 $X=517700 $Y=431940
X4822 3030 2967 1 3047 2 OR2B1S $T=538160 417200 0 0 $X=538160 $Y=416820
X4823 3340 3309 1 3381 2 OR2B1S $T=595820 427280 0 0 $X=595820 $Y=426900
X4824 4200 4597 1 4604 2 OR2B1S $T=822740 427280 1 0 $X=822740 $Y=421860
X4825 1910 1363 61 1848 1 2 5635 DFFSBN $T=326740 397040 1 180 $X=313720 $Y=396660
X4826 1970 1363 61 1896 1 2 5636 DFFSBN $T=339140 407120 0 180 $X=326120 $Y=401700
X4827 1983 1363 61 1889 1 2 5637 DFFSBN $T=342860 417200 0 180 $X=329840 $Y=411780
X4828 2952 490 315 2418 1 2 5638 DFFSBN $T=525140 366800 0 180 $X=512120 $Y=361380
X4829 2987 490 315 2633 1 2 5639 DFFSBN $T=528860 366800 1 180 $X=515840 $Y=366420
X4830 3172 490 315 3063 1 2 5640 DFFSBN $T=556760 376880 0 180 $X=543740 $Y=371460
X4831 4637 906 743 4305 1 2 5641 DFFSBN $T=830800 356720 1 180 $X=817780 $Y=356340
X4832 4660 906 743 4353 1 2 5642 DFFSBN $T=833280 366800 1 180 $X=820260 $Y=366420
X4833 4687 906 743 4051 1 2 5643 DFFSBN $T=834520 376880 1 180 $X=821500 $Y=376500
X4834 4716 973 4758 4756 1 2 4741 AO13S $T=854980 366800 1 180 $X=850640 $Y=366420
X4835 1303 34 44 1 2 1336 AO12 $T=230020 376880 1 0 $X=230020 $Y=371460
X4836 1369 22 41 1 2 135 AO12 $T=261640 376880 1 0 $X=261640 $Y=371460
X4837 1577 1717 60 1 2 1731 AO12 $T=285820 386960 1 0 $X=285820 $Y=381540
X4838 90 1637 1491 1 2 1796 AO12 $T=298220 356720 1 0 $X=298220 $Y=351300
X4839 1756 80 111 1 2 227 AO12 $T=303180 326480 0 0 $X=303180 $Y=326100
X4840 231 257 1729 1 2 1899 AO12 $T=323020 356720 1 0 $X=323020 $Y=351300
X4841 1990 1981 1979 1 2 1970 AO12 $T=344100 366800 0 180 $X=340380 $Y=361380
X4842 2017 1981 1979 1 2 1983 AO12 $T=349680 366800 0 180 $X=345960 $Y=361380
X4843 283 280 2005 1 2 2056 AO12 $T=354020 346640 0 0 $X=354020 $Y=346260
X4844 2941 537 548 1 2 2986 AO12 $T=529480 346640 1 0 $X=529480 $Y=341220
X4845 3006 3068 3098 1 2 3110 AO12 $T=545600 437360 1 0 $X=545600 $Y=431940
X4846 3103 3111 545 1 2 3104 AO12 $T=551800 366800 0 180 $X=548080 $Y=361380
X4847 533 521 513 1 2 646 AO12 $T=580320 336560 1 180 $X=576600 $Y=336180
X4848 558 3169 568 1 2 679 AO12 $T=594580 356720 1 0 $X=594580 $Y=351300
X4849 684 3425 693 1 2 3455 AO12 $T=608220 356720 0 0 $X=608220 $Y=356340
X4850 3563 3551 3544 1 2 3172 AO12 $T=630540 376880 0 180 $X=626820 $Y=371460
X4851 3575 3551 3544 1 2 2987 AO12 $T=631780 366800 1 180 $X=628060 $Y=366420
X4852 283 710 2005 1 2 3639 AO12 $T=650380 356720 0 180 $X=646660 $Y=351300
X4853 4819 4791 4822 1 2 4758 AO12 $T=868620 366800 1 180 $X=864900 $Y=366420
X4854 1163 958 1021 1 2 5179 AO12 $T=950460 336560 1 0 $X=950460 $Y=331140
X4855 4880 913 1097 1 2 4960 AN3S $T=902720 356720 0 0 $X=902720 $Y=356340
X4856 4968 982 913 937 2 1 5046 OA22S $T=920700 356720 0 0 $X=920700 $Y=356340
X4857 6 1310 1314 2 1324 1 1339 AO112 $T=221340 346640 1 0 $X=221340 $Y=341220
X4858 1943 268 285 2 1757 1 234 AO112 $T=334180 366800 0 0 $X=334180 $Y=366420
X4859 3503 692 712 2 3130 1 671 AO112 $T=620620 356720 0 0 $X=620620 $Y=356340
X4860 4794 4718 4790 2 4806 1 1007 AO112 $T=858080 356720 0 0 $X=858080 $Y=356340
X4861 306 311 2011 2 1 2015 OR3 $T=346580 336560 1 0 $X=346580 $Y=331140
X4862 469 377 2935 2 1 3017 OR3 $T=530720 427280 0 0 $X=530720 $Y=426900
X4863 741 740 3597 2 1 3568 OR3 $T=639220 346640 0 180 $X=635500 $Y=341220
X4864 1356 25 2 1349 1 1334 AN3B2S $T=230020 346640 0 180 $X=226300 $Y=341220
X4865 117 114 2 1495 1 1435 AN3B2S $T=253580 336560 0 180 $X=249860 $Y=331140
X4866 1502 114 2 1367 1 1528 AN3B2S $T=252340 336560 0 0 $X=252340 $Y=336180
X4867 281 279 2 270 1 1905 AN3B2S $T=336040 376880 0 180 $X=332320 $Y=371460
X4868 713 279 2 270 1 3476 AN3B2S $T=624340 346640 1 180 $X=620620 $Y=346260
X4869 4511 4493 2 4484 1 4538 AN3B2S $T=805380 477680 1 0 $X=805380 $Y=472260
X4870 1063 4884 2 1083 1 4988 AN3B2S $T=910780 356720 1 0 $X=910780 $Y=351300
X4871 1403 1333 1348 1 2 AN2B1T $T=236220 457520 1 0 $X=236220 $Y=452100
X4872 1875 1879 1870 1 2 AN2B1T $T=320540 477680 0 0 $X=320540 $Y=477300
X4873 2925 3013 3048 1 2 AN2B1T $T=540640 437360 0 0 $X=540640 $Y=436980
X4874 3257 3246 3262 1 2 AN2B1T $T=578460 407120 1 0 $X=578460 $Y=401700
X4875 3321 3236 3273 1 2 AN2B1T $T=586520 427280 0 0 $X=586520 $Y=426900
X4876 3240 3348 3340 1 2 AN2B1T $T=591480 437360 0 0 $X=591480 $Y=436980
X4877 3327 3442 3414 1 2 AN2B1T $T=607600 437360 1 0 $X=607600 $Y=431940
X4878 825 4381 4407 1 2 AN2B1T $T=783060 467600 0 0 $X=783060 $Y=467220
X4879 1149 1178 1 2 5244 QDLHN $T=956660 487760 0 0 $X=956660 $Y=487380
X4880 1149 1191 1 2 5287 QDLHN $T=966580 487760 0 0 $X=966580 $Y=487380
X4881 1149 1196 1 2 5303 QDLHN $T=974020 497840 1 0 $X=974020 $Y=492420
X4882 1149 1199 1 2 5282 QDLHN $T=975260 487760 0 0 $X=975260 $Y=487380
X4883 1417 42 1 2 BUF4 $T=237460 427280 0 180 $X=233120 $Y=421860
X4884 1848 144 1 2 BUF4 $T=318680 417200 1 0 $X=318680 $Y=411780
X4885 2926 388 1 2 BUF4 $T=520800 376880 1 180 $X=516460 $Y=376500
X4886 3192 419 1 2 BUF4 $T=569160 386960 1 0 $X=569160 $Y=381540
X4887 4305 4043 1 2 BUF4 $T=774380 366800 0 0 $X=774380 $Y=366420
X4888 4051 819 1 2 BUF4 $T=778100 386960 0 0 $X=778100 $Y=386580
X4889 4630 779 3613 297 2 1 4636 OA13 $T=828320 397040 0 0 $X=828320 $Y=396660
X4890 3145 3341 3311 2 3240 3378 1 MUXB2 $T=631780 437360 0 0 $X=631780 $Y=436980
X4891 839 4352 4407 2 4464 4484 1 MUXB2 $T=792360 497840 0 0 $X=792360 $Y=497460
X4892 1959 217 61 2 1 2012 QDFFRBS $T=337280 427280 0 0 $X=337280 $Y=426900
X4893 3161 591 315 2 1 3212 QDFFRBS $T=558000 417200 1 0 $X=558000 $Y=411780
X4894 32 1364 1359 1413 1 2 AO12P $T=231880 447440 1 0 $X=231880 $Y=442020
X4895 1409 1569 1560 2 1 1656 1560 1409 1569 126 1295 ICV_21 $T=258540 518000 1 0 $X=258540 $Y=512580
X4896 2023 2033 2025 2 1 2034 2025 2023 2033 2046 1295 ICV_21 $T=349060 427280 1 0 $X=349060 $Y=421860
X4897 324 2105 326 2 1 2069 321 2069 2076 2080 1295 ICV_21 $T=357120 336560 1 0 $X=357120 $Y=331140
X4898 2095 1518 2070 2 1 2194 2070 2095 1518 2119 1295 ICV_21 $T=361460 457520 1 0 $X=361460 $Y=452100
X4899 2117 2115 2046 2 1 2165 2046 2117 2115 2132 1295 ICV_21 $T=365180 437360 1 0 $X=365180 $Y=431940
X4900 2140 2141 2145 2 1 2033 2145 2140 2141 2169 1295 ICV_21 $T=370140 386960 0 0 $X=370140 $Y=386580
X4901 2139 2166 2158 2 1 2138 2158 2139 2166 2159 1295 ICV_21 $T=371380 507920 1 0 $X=371380 $Y=502500
X4902 2185 2192 2169 2 1 2115 2169 2185 2192 2198 1295 ICV_21 $T=378200 407120 1 0 $X=378200 $Y=401700
X4903 2191 2199 2197 2 1 2014 2197 2191 2199 2145 1295 ICV_21 $T=380060 376880 0 0 $X=380060 $Y=376500
X4904 2215 2229 2220 2 1 2235 2220 2215 2229 2244 1295 ICV_21 $T=385640 437360 0 0 $X=385640 $Y=436980
X4905 2216 2201 2132 2 1 2225 2132 2216 2201 2245 1295 ICV_21 $T=385640 447440 1 0 $X=385640 $Y=442020
X4906 2302 2319 2308 2 1 2312 2308 2302 2319 2333 1295 ICV_21 $T=403000 437360 1 0 $X=403000 $Y=431940
X4907 2311 2328 2321 2 1 2305 2321 2311 2328 2341 1295 ICV_21 $T=404240 447440 1 0 $X=404240 $Y=442020
X4908 2320 2331 2244 2 1 2323 2244 2320 2331 2321 1295 ICV_21 $T=404860 437360 0 0 $X=404860 $Y=436980
X4909 2372 2399 2333 2 1 2429 2333 2372 2399 2433 1295 ICV_21 $T=422220 437360 1 0 $X=422220 $Y=431940
X4910 2421 2429 2378 2 1 2413 2378 2421 2429 2438 1295 ICV_21 $T=423460 457520 1 0 $X=423460 $Y=452100
X4911 2376 2530 2433 2 1 2531 2433 2376 2530 2420 1295 ICV_21 $T=441440 437360 1 0 $X=441440 $Y=431940
X4912 3347 3173 3346 2 1 3288 3346 3347 3173 3367 1295 ICV_21 $T=592100 407120 1 0 $X=592100 $Y=401700
X4913 3444 3290 3367 2 1 3464 3367 3444 3290 3490 1295 ICV_21 $T=611940 407120 1 0 $X=611940 $Y=401700
X4914 3571 3586 3567 2 1 3623 3567 3571 3586 3580 1295 ICV_21 $T=630540 457520 1 0 $X=630540 $Y=452100
X4915 3573 3594 3580 2 1 3587 3580 3573 3594 3605 1295 ICV_21 $T=631160 467600 1 0 $X=631160 $Y=462180
X4916 3589 3610 3603 2 1 3621 3603 3589 3610 3606 1295 ICV_21 $T=634260 497840 1 0 $X=634260 $Y=492420
X4917 3600 3618 3605 2 1 3631 3605 3600 3618 3603 1295 ICV_21 $T=636120 487760 1 0 $X=636120 $Y=482340
X4918 3623 3187 3628 2 1 3693 3628 3623 3187 3596 1295 ICV_21 $T=639220 457520 0 0 $X=639220 $Y=457140
X4919 3631 3256 3609 2 1 3691 3609 3631 3256 3616 1295 ICV_21 $T=640460 487760 0 0 $X=640460 $Y=487380
X4920 3664 3671 3665 2 1 3643 3665 3664 3671 3669 1295 ICV_21 $T=651620 356720 0 0 $X=651620 $Y=356340
X4921 3666 3672 3669 2 1 3644 3669 3666 3672 3659 1295 ICV_21 $T=652240 376880 1 0 $X=652240 $Y=371460
X4922 3721 3732 3723 2 1 3690 3723 3721 3732 3665 1295 ICV_21 $T=662780 356720 1 0 $X=662780 $Y=351300
X4923 3748 3758 3750 2 1 3697 3750 3748 3758 3751 1295 ICV_21 $T=668360 397040 1 0 $X=668360 $Y=391620
X4924 4070 4066 4078 2 1 3732 4078 4070 4066 4079 1295 ICV_21 $T=722920 356720 1 0 $X=722920 $Y=351300
X4925 4090 4102 829 2 1 3651 829 4090 4102 4078 1295 ICV_21 $T=725400 336560 0 0 $X=725400 $Y=336180
X4926 4671 4652 4658 2 1 4751 4652 4658 4671 4684 1295 ICV_21 $T=832660 467600 1 0 $X=832660 $Y=462180
X4927 967 4728 4740 2 1 4807 967 4740 4728 4764 1295 ICV_21 $T=847540 497840 1 0 $X=847540 $Y=492420
X4928 4752 4775 4764 2 1 1024 4764 4752 4775 990 1295 ICV_21 $T=851880 518000 1 0 $X=851880 $Y=512580
X4929 863 248 1 2 INV6 $T=766320 497840 0 0 $X=766320 $Y=497460
X4930 3710 3714 3713 3740 3730 1 2 AO13P $T=665880 437360 0 0 $X=665880 $Y=436980
X4931 4561 4397 839 4464 2 1 NR3H $T=817780 467600 1 0 $X=817780 $Y=462180
X4932 2356 2360 2 2292 1 2347 2361 2360 2356 2291 1295 ICV_22 $T=416640 376880 0 180 $X=412300 $Y=371460
X4933 2384 2360 2 2385 1 2314 2397 2360 2384 2330 1295 ICV_22 $T=422220 376880 0 180 $X=417880 $Y=371460
X4934 2410 2402 2 2411 1 2361 2424 2402 2410 2397 1295 ICV_22 $T=427800 376880 0 180 $X=423460 $Y=371460
X4935 2589 416 2 2573 1 2567 2586 416 2572 2563 1295 ICV_22 $T=459420 376880 0 180 $X=455080 $Y=371460
X4936 2601 425 2 2602 1 2589 2626 425 2601 2586 1295 ICV_22 $T=465620 376880 0 180 $X=461280 $Y=371460
X4937 3291 2780 2 3292 1 3313 3281 2780 3305 3318 1295 ICV_22 $T=582180 477680 1 0 $X=582180 $Y=472260
X4938 3313 3322 2 3325 1 3343 3318 3322 3313 3336 1295 ICV_22 $T=587760 487760 1 0 $X=587760 $Y=482340
X4939 3302 3322 2 3342 1 3407 3376 3364 3374 3412 1295 ICV_22 $T=598920 477680 1 0 $X=598920 $Y=472260
X4940 4016 4025 2 4017 1 3986 4023 4025 4016 3966 1295 ICV_22 $T=718580 356720 0 180 $X=714240 $Y=351300
X4941 4020 4025 2 4021 1 3974 4024 4025 4020 3977 1295 ICV_22 $T=718580 386960 0 180 $X=714240 $Y=381540
X4942 4065 813 2 3968 1 4040 4058 809 4004 4036 1295 ICV_22 $T=722920 497840 0 180 $X=718580 $Y=492420
X4943 4110 809 2 4076 1 4015 4111 813 3968 4076 1295 ICV_22 $T=728500 497840 0 180 $X=724160 $Y=492420
X4944 4135 4060 2 4069 1 4029 4147 825 4097 4135 1295 ICV_22 $T=737800 477680 0 180 $X=733460 $Y=472260
X4945 4282 839 2 4244 1 4264 4300 839 4289 4255 1295 ICV_22 $T=767560 397040 0 180 $X=763220 $Y=391620
X4946 4364 4273 2 4386 1 4423 4391 4273 4364 4433 1295 ICV_22 $T=784920 376880 1 0 $X=784920 $Y=371460
X4947 4423 4200 2 4409 1 4456 4433 4200 4439 4462 1295 ICV_22 $T=791120 376880 1 0 $X=791120 $Y=371460
X4948 4461 812 2 4483 1 4489 4467 812 4457 4491 1295 ICV_22 $T=797320 376880 1 0 $X=797320 $Y=371460
X4949 1314 2 67 1418 1 68 72 78 1295 ICV_24 $T=236840 326480 1 0 $X=236840 $Y=321060
X4950 1405 2 154 1460 1 70 111 1460 1295 ICV_24 $T=287680 326480 0 0 $X=287680 $Y=326100
X4951 241 2 1820 251 1 144 113 256 1295 ICV_24 $T=314960 518000 0 0 $X=314960 $Y=517620
X4952 1921 2 1922 1935 1 1904 1911 279 1295 ICV_24 $T=330460 356720 1 0 $X=330460 $Y=351300
X4953 283 2 1868 286 1 1963 243 286 1295 ICV_24 $T=337280 346640 1 0 $X=337280 $Y=341220
X4954 2416 2 2525 2636 1 2636 2597 2447 1295 ICV_24 $T=466860 397040 0 0 $X=466860 $Y=396660
X4955 2877 2 2936 466 1 2877 2955 477 1295 ICV_24 $T=522040 447440 0 0 $X=522040 $Y=447060
X4956 2756 2 3294 444 1 2756 3317 486 1295 ICV_24 $T=582180 467600 1 0 $X=582180 $Y=462180
X4957 3362 2 3335 3394 1 609 3401 3116 1295 ICV_24 $T=599540 346640 0 0 $X=599540 $Y=346260
X4958 817 2 3968 4043 1 4043 4045 821 1295 ICV_24 $T=716720 477680 0 0 $X=716720 $Y=477300
X4959 4051 2 4023 251 1 4051 4027 245 1295 ICV_24 $T=720440 346640 0 0 $X=720440 $Y=346260
X4960 4043 2 4217 430 1 4043 4238 444 1295 ICV_24 $T=748960 467600 0 0 $X=748960 $Y=467220
X4961 4043 2 4318 379 1 4043 4341 385 1295 ICV_24 $T=775000 376880 0 0 $X=775000 $Y=376500
X4962 4884 2 1118 4985 1 1029 1021 1078 1295 ICV_24 $T=912640 326480 0 0 $X=912640 $Y=326100
X4963 5047 2 5096 5101 1 5083 5069 5021 1295 ICV_24 $T=935580 397040 0 0 $X=935580 $Y=396660
X4964 5244 2 5291 5287 1 5295 5299 5297 1295 ICV_24 $T=974640 417200 1 0 $X=974640 $Y=411780
X4965 5101 2 5302 5122 1 5083 5215 5141 1295 ICV_24 $T=988280 397040 1 0 $X=988280 $Y=391620
X4966 2 1532 1540 1 1394 1562 1553 1295 ICV_25 $T=257300 467600 1 0 $X=257300 $Y=462180
X4967 2 1533 1545 1 1397 1565 1585 1295 ICV_25 $T=257920 487760 0 0 $X=257920 $Y=487380
X4968 2 1571 1580 1 1383 1550 1541 1295 ICV_25 $T=261640 477680 1 0 $X=261640 $Y=472260
X4969 2 1612 1613 1 1587 1584 1408 1295 ICV_25 $T=268460 437360 1 0 $X=268460 $Y=431940
X4970 2 1661 1672 1 1413 1614 1595 1295 ICV_25 $T=277140 437360 0 0 $X=277140 $Y=436980
X4971 2 1901 1825 1 1882 1885 1892 1295 ICV_25 $T=326740 467600 1 0 $X=326740 $Y=462180
X4972 2 3204 3215 1 2920 3201 3224 1295 ICV_25 $T=566680 447440 0 0 $X=566680 $Y=447060
X4973 2 3261 3050 1 3277 3265 3272 1295 ICV_25 $T=579080 397040 1 0 $X=579080 $Y=391620
X4974 2 3278 3168 1 3262 3250 3254 1295 ICV_25 $T=581560 397040 0 0 $X=581560 $Y=396660
X4975 2 3436 3444 1 3449 3458 3399 1295 ICV_25 $T=608840 417200 1 0 $X=608840 $Y=411780
X4976 2 3641 3591 1 3546 3545 3548 1295 ICV_25 $T=644180 437360 0 0 $X=644180 $Y=436980
X4977 2 4067 3699 1 4086 4093 4124 1295 ICV_25 $T=723540 376880 0 0 $X=723540 $Y=376500
X4978 2 4592 905 1 4563 4558 4575 1295 ICV_25 $T=819020 518000 0 0 $X=819020 $Y=517620
X4979 2 4685 904 1 4670 4683 4690 1295 ICV_25 $T=838240 477680 1 0 $X=838240 $Y=472260
X4980 2 4723 4728 1 4657 4684 4678 1295 ICV_25 $T=846300 457520 0 0 $X=846300 $Y=457140
X4981 2 4747 4752 1 980 984 1005 1295 ICV_25 $T=850640 518000 0 0 $X=850640 $Y=517620
X4982 2 4763 977 1 4571 4782 4774 1295 ICV_25 $T=852500 477680 0 0 $X=852500 $Y=477300
X4983 2 4805 4775 1 4519 4796 4770 1295 ICV_25 $T=860560 477680 1 0 $X=860560 $Y=472260
X4984 388 2835 2838 1 2 2856 AO12T $T=501580 417200 0 0 $X=501580 $Y=416820
X4985 875 4773 4785 1 2 4796 AO12T $T=858700 437360 0 0 $X=858700 $Y=436980
X4986 469 425 2644 2770 2 1 2792 NR4 $T=488560 427280 1 0 $X=488560 $Y=421860
X4987 2965 3048 2954 3030 2 1 3082 NR4 $T=540020 427280 1 0 $X=540020 $Y=421860
X4988 4200 4273 469 4055 2 1 4451 NR4 $T=792360 447440 1 0 $X=792360 $Y=442020
X4989 4583 4600 4649 4598 2 1 4739 NR4 $T=850020 437360 1 0 $X=850020 $Y=431940
X4990 1491 2 96 1505 1 1503 119 1405 1295 ICV_26 $T=252340 366800 1 0 $X=252340 $Y=361380
X4991 1712 2 1604 1722 1 1710 1616 1722 1295 ICV_26 $T=284580 376880 1 0 $X=284580 $Y=371460
X4992 223 2 1639 234 1 103 1720 234 1295 ICV_26 $T=308140 356720 1 0 $X=308140 $Y=351300
X4993 241 2 1812 244 1 144 1500 244 1295 ICV_26 $T=313100 497840 1 0 $X=313100 $Y=492420
X4994 292 2 2022 2009 1 292 2027 1913 1295 ICV_26 $T=349060 497840 1 0 $X=349060 $Y=492420
X4995 2418 2 2383 256 1 2418 2415 244 1295 ICV_26 $T=425940 346640 1 0 $X=425940 $Y=341220
X4996 2636 2 2601 379 1 2636 2626 385 1295 ICV_26 $T=468720 376880 0 180 $X=466860 $Y=371460
X4997 2633 2 2605 256 1 2633 2642 245 1295 ICV_26 $T=473680 356720 1 0 $X=473680 $Y=351300
X4998 2877 2 2895 2784 1 2877 2892 441 1295 ICV_26 $T=510880 497840 1 0 $X=510880 $Y=492420
X4999 2877 2 2914 479 1 2877 2913 472 1295 ICV_26 $T=515840 487760 1 0 $X=515840 $Y=482340
X5000 540 2 3057 2982 1 540 3067 3017 1295 ICV_26 $T=541880 457520 1 0 $X=541880 $Y=452100
X5001 671 2 742 692 1 705 3608 741 1295 ICV_26 $T=637980 326480 1 0 $X=637980 $Y=321060
X5002 4051 2 4018 383 1 4051 4017 386 1295 ICV_26 $T=720440 366800 1 0 $X=720440 $Y=361380
X5003 4051 2 4020 384 1 4051 4024 379 1295 ICV_26 $T=720440 386960 1 0 $X=720440 $Y=381540
X5004 4354 2 4386 379 1 4354 4391 383 1295 ICV_26 $T=781820 376880 1 0 $X=781820 $Y=371460
X5005 4664 2 4643 283 1 4635 932 4665 1295 ICV_26 $T=836380 356720 1 0 $X=836380 $Y=351300
X5006 1699 1725 1 1732 2 OR2T $T=293880 437360 0 0 $X=293880 $Y=436980
X5007 809 813 1 4464 2 OR2T $T=794840 477680 1 0 $X=794840 $Y=472260
X5008 1622 1555 1679 1 2 1717 AN3B1 $T=277760 397040 1 0 $X=277760 $Y=391620
X5009 3143 3056 3131 1 2 3111 AN3B1 $T=555520 366800 1 180 $X=550560 $Y=366420
X5010 388 2897 1 2862 2891 388 2 MOAI1HP $T=522040 397040 1 180 $X=509020 $Y=396660
X5011 503 490 315 1 2 377 QDFFRBT $T=515840 336560 0 180 $X=502200 $Y=331140
X5012 2644 2 1 466 2733 NR2F $T=485460 447440 0 0 $X=485460 $Y=447060
X5013 2647 2575 2584 1 2 XNR2HT $T=469960 507920 1 0 $X=469960 $Y=502500
X5014 368 369 370 372 374 1 2 AN4B1 $T=415400 346640 0 0 $X=415400 $Y=346260
X5015 1490 128 1 2 BUF6 $T=255440 497840 0 0 $X=255440 $Y=497460
.ENDS
***************************************
.SUBCKT TIE0 O VCC GND
** N=4 EP=3 IP=0 FDC=0
.ENDS
***************************************
.SUBCKT TIE1 O VCC GND
** N=4 EP=3 IP=0 FDC=0
.ENDS
***************************************
.SUBCKT AN3B2 B2 I1 B1 GND VCC O
** N=7 EP=6 IP=0 FDC=0
.ENDS
***************************************
.SUBCKT AN4S I1 I2 I4 I3 VCC GND O
** N=8 EP=7 IP=0 FDC=0
.ENDS
***************************************
.SUBCKT AOI22HP A2 A1 VCC B1 O B2 GND
** N=8 EP=7 IP=0 FDC=0
.ENDS
***************************************
.SUBCKT ICV_28 1 2 3 4 5 6 7 8 9 10 11 12 13 14 15 16 17 18 19 20
+ 21 22 23 24 25 26 27 28 29 30 31 32 33 34 35 36 37 38 39 40
+ 41 42 43 44 45 46 47 48 49 50 51 52 53 54 55 56 57 58 59 60
+ 61 62 63 64 65 66 67 68 69 70 71 72 73 74 75 76 77 78 79 80
+ 81 82 83 84 85 86 87 88 89 90 91 92 93 94 95 96 97 98 99 100
+ 101 102 103 104 105 106 107 108 109 110 111 112 113 114 115 116 117 118 119 120
+ 121 122 123 124 125 126 127 128 129 130 131 132 133 134 135 136 137 138 139 140
+ 141 142 143 144 145 146 147 148 149 150 151 152 153 154 155 156 157 158 159 160
+ 161 162 163 164 165 166 167 168 169 170 171 172 173 174 175 176 177 178 179 180
+ 181 182 183 184 185 186 187 188 189 190 191 192 193 194 195 196 197 198 199 200
+ 201 202 203 204 205 206 207 208 209 210 211 212 213 214 215 216 217 218 219 220
+ 221 222 223 224 225 226 227 228 229 230 231 232 233 234 235 236 237 238 239 240
+ 241 242 243 244 245 246 247 248 249 250 251 252 253 254 255 256 257 258 259 260
+ 261 262 263 264 265 266 267 268 269 270 271 272 273 274 275 276 277 278 279 280
+ 281 282 283 284 285 286 287 288 289 290 291 292 293 294 295 296 297 298 299 300
+ 301 302 303 304 305 306 307 308 309 310 311 312 313 314 315 316 317 318 319 320
+ 321 322 323 324 325 326 327 328 329 330 331 332 333 334 335 336 337 338 339 340
+ 341 342 343 344 345 346 347 348 349 350 351 352 353 354 355 356 357 358 359 360
+ 361 362 363 364 365 366 367 368 369 370 371 372 373 374 375 376 377 378 379 380
+ 381 382 383 384 385 386 387 388 389 390 391 392 393 394 395 396 397 398 399 400
+ 401 402 403 404 405 406 407 408 409 410 411 412 413 414 415 416 417 418 419 420
+ 421 422 423 424 425 426 427 428 429 430 431 432 433 434 435 436 437 438 439 440
+ 441 442 443 444 445 446 447 448 449 450 451 452 453 454 455 456 457 458 459 460
+ 461 462 463 464 465 466 467 468 469 470 471 472 473 474 475 476 477 478 479 480
+ 481 482 483 484 485 486 487 488 489 490 491 492 493 494 495 496 497 498 499 500
+ 501 502 503 504 505 506 507 508 510 511 512 513 514 516 517 518 519 520 521 522
+ 523 524 525 526 527 528 529 530 531 533 534 535 536 537 538 539 540 541 542 543
+ 544 545 546 547 548 549 550 552 553 554 555 556 557 558 559 560 561 562 563 564
+ 565 566 567 569 570 571 572 573 574 575 576 577 578 579 580 582 583 584 585 586
+ 587 588 589 590 591 592 593 594 595 596 597 598 599 600 601 602 603 604 605 606
+ 607 608 609 610 611 612 613 614 615 616 617 618 619 620 621 622 623 624 625 626
+ 627 628 629 630 631 632 633 634 635 636 637 638 639 640 641 642 643 644 645 646
+ 647 648 649 650 651 652 653 654 655 656 657 658 659 660 661 662 663 664 665 666
+ 667 668 669 670 671 672 673 674 675 676 677 678 679 680 681 682 683 684 685 686
+ 687 688 689 690 691 692 693 694 695 696 697 698 699 700 701 702 703 704 705 706
+ 707 708 709 710 711 712 713 714 715 716 717 718 719 720 721 722 723 724 725 726
+ 727 728 729 730 731 732 733 734 735 736 737 738 739 740 741 742 743 744 745 746
+ 747 748 749 750 751 752 753 754 755 756 757 758 759 760 761 762 763 764 765 766
+ 767 768 769 770 771 772 773 774 775 776 777 778 779 780 781 782 783 784 785 786
+ 787 788 789 790 791 792 793 794 795 796 797 798 799 800 801 802 803 804 805 806
+ 807 808 809 810 811 812 813 814 815 816 817 818 819 820 821 822 823 824 825 826
+ 827 828 829 830 831 832 833 867
** N=3410 EP=828 IP=19093 FDC=0
X0 779 781 775 1 2 QDFFN $T=977120 316400 0 180 $X=966580 $Y=310980
X1 774 777 3316 1 2 QDFFN $T=967200 286160 0 0 $X=967200 $Y=285780
X2 778 780 3317 1 2 QDFFN $T=972160 306320 1 0 $X=972160 $Y=300900
X3 774 781 3318 1 2 QDFFN $T=972780 306320 0 0 $X=972780 $Y=305940
X4 779 777 3320 1 2 QDFFN $T=974020 296240 1 0 $X=974020 $Y=290820
X5 779 782 3319 1 2 QDFFN $T=975260 276080 0 0 $X=975260 $Y=275700
X6 779 780 3323 1 2 QDFFN $T=975880 266000 0 0 $X=975880 $Y=265620
X7 774 782 3326 1 2 QDFFN $T=980220 276080 1 0 $X=980220 $Y=270660
X8 774 780 3327 1 2 QDFFN $T=984560 255920 0 0 $X=984560 $Y=255540
X9 778 782 3321 1 2 QDFFN $T=995720 296240 1 180 $X=985180 $Y=295860
X10 791 781 3328 1 2 QDFFN $T=985800 306320 0 0 $X=985800 $Y=305940
X11 778 777 3324 1 2 QDFFN $T=997580 296240 0 180 $X=987040 $Y=290820
X12 791 780 3332 1 2 QDFFN $T=988900 266000 0 0 $X=988900 $Y=265620
X13 794 782 3331 1 2 QDFFN $T=992620 306320 1 0 $X=992620 $Y=300900
X14 791 782 3329 1 2 QDFFN $T=993860 276080 0 0 $X=993860 $Y=275700
X15 778 798 3336 1 2 QDFFN $T=997580 316400 0 0 $X=997580 $Y=316020
X16 794 780 3334 1 2 QDFFN $T=998820 286160 0 0 $X=998820 $Y=285780
X17 794 799 3335 1 2 QDFFN $T=998820 306320 0 0 $X=998820 $Y=305940
X18 794 800 3338 1 2 QDFFN $T=1001920 266000 0 0 $X=1001920 $Y=265620
X19 794 801 3343 1 2 QDFFN $T=1003160 266000 1 0 $X=1003160 $Y=260580
X20 791 777 3330 1 2 QDFFN $T=1013700 286160 0 180 $X=1003160 $Y=280740
X21 778 799 3341 1 2 QDFFN $T=1004400 306320 1 0 $X=1004400 $Y=300900
X22 794 777 3333 1 2 QDFFN $T=1016800 296240 0 180 $X=1006260 $Y=290820
X23 794 802 3350 1 2 QDFFN $T=1006880 276080 0 0 $X=1006880 $Y=275700
X24 794 807 3351 1 2 QDFFN $T=1011220 286160 0 0 $X=1011220 $Y=285780
X25 778 801 3352 1 2 QDFFN $T=1018040 255920 1 0 $X=1018040 $Y=250500
X26 778 800 3355 1 2 QDFFN $T=1018040 266000 1 0 $X=1018040 $Y=260580
X27 794 814 3346 1 2 QDFFN $T=1028580 306320 1 180 $X=1018040 $Y=305940
X28 778 802 3356 1 2 QDFFN $T=1019900 276080 0 0 $X=1019900 $Y=275700
X29 778 814 3349 1 2 QDFFN $T=1019900 296240 1 0 $X=1019900 $Y=290820
X30 791 798 3361 1 2 QDFFN $T=1019900 316400 1 0 $X=1019900 $Y=310980
X31 778 807 3357 1 2 QDFFN $T=1024240 286160 0 0 $X=1024240 $Y=285780
X32 791 814 3366 1 2 QDFFN $T=1025480 306320 1 0 $X=1025480 $Y=300900
X33 791 800 3369 1 2 QDFFN $T=1027960 266000 0 0 $X=1027960 $Y=265620
X34 791 801 3378 1 2 QDFFN $T=1031680 266000 1 0 $X=1031680 $Y=260580
X35 791 799 3364 1 2 QDFFN $T=1043460 296240 0 180 $X=1032920 $Y=290820
X36 791 802 3365 1 2 QDFFN $T=1044080 276080 1 180 $X=1033540 $Y=275700
X37 791 807 3368 1 2 QDFFN $T=1047800 286160 1 180 $X=1037260 $Y=285780
X38 774 814 3374 1 2 QDFFN $T=1050280 306320 0 180 $X=1039740 $Y=300900
X39 779 801 3380 1 2 QDFFN $T=1052760 255920 1 180 $X=1042220 $Y=255540
X40 779 800 3381 1 2 QDFFN $T=1056480 266000 0 180 $X=1045940 $Y=260580
X41 779 802 3372 1 2 QDFFN $T=1056480 276080 1 180 $X=1045940 $Y=275700
X42 779 826 3384 1 2 QDFFN $T=1056480 316400 1 180 $X=1045940 $Y=316020
X43 779 799 3385 1 2 QDFFN $T=1047180 306320 0 0 $X=1047180 $Y=305940
X44 774 799 3382 1 2 QDFFN $T=1058960 296240 0 180 $X=1048420 $Y=290820
X45 779 807 3376 1 2 QDFFN $T=1060200 286160 1 180 $X=1049660 $Y=285780
X46 825 798 3390 1 2 QDFFN $T=1050280 316400 1 0 $X=1050280 $Y=310980
X47 779 814 3389 1 2 QDFFN $T=1052760 306320 1 0 $X=1052760 $Y=300900
X48 774 801 3387 1 2 QDFFN $T=1055860 255920 1 0 $X=1055860 $Y=250500
X49 774 802 3391 1 2 QDFFN $T=1055860 276080 1 0 $X=1055860 $Y=270660
X50 774 800 3392 1 2 QDFFN $T=1061440 266000 1 0 $X=1061440 $Y=260580
X51 774 807 3398 1 2 QDFFN $T=1061440 286160 0 0 $X=1061440 $Y=285780
X52 825 799 3394 1 2 QDFFN $T=1077560 296240 1 180 $X=1067020 $Y=295860
X53 825 800 3396 1 2 QDFFN $T=1078800 266000 1 180 $X=1068260 $Y=265620
X54 831 801 3397 1 2 QDFFN $T=1080040 306320 1 180 $X=1069500 $Y=305940
X55 825 801 3401 1 2 QDFFN $T=1081280 286160 0 180 $X=1070740 $Y=280740
X56 825 802 3408 1 2 QDFFN $T=1078180 276080 0 0 $X=1078180 $Y=275700
X57 825 814 3395 1 2 QDFFN $T=1080040 306320 1 0 $X=1080040 $Y=300900
X58 825 807 3409 1 2 QDFFN $T=1080660 296240 1 0 $X=1080660 $Y=290820
X59 831 807 3407 1 2 QDFFN $T=1080660 316400 1 0 $X=1080660 $Y=310980
X60 831 802 3406 1 2 QDFFN $T=1080660 316400 0 0 $X=1080660 $Y=316020
X61 26 19 870 921 1 915 2 AOI22S $T=226300 286160 0 0 $X=226300 $Y=285780
X62 61 56 894 959 1 966 2 AOI22S $T=240560 255920 1 180 $X=236840 $Y=255540
X63 60 26 1000 1012 1 1008 2 AOI22S $T=245520 306320 1 0 $X=245520 $Y=300900
X64 26 1082 1071 1079 1 932 2 AOI22S $T=265360 266000 0 180 $X=261640 $Y=260580
X65 26 96 1087 1074 1 1080 2 AOI22S $T=265980 306320 0 180 $X=262260 $Y=300900
X66 86 1097 1052 61 1 117 2 AOI22S $T=265980 316400 0 0 $X=265980 $Y=316020
X67 1115 1082 122 1110 1 1088 2 AOI22S $T=272800 276080 1 180 $X=269080 $Y=275700
X68 96 1120 1103 998 1 1125 2 AOI22S $T=272180 245840 0 0 $X=272180 $Y=245460
X69 1129 1126 1063 1112 1 1122 2 AOI22S $T=276520 266000 0 180 $X=272800 $Y=260580
X70 56 45 1118 128 1 938 2 AOI22S $T=277140 316400 1 180 $X=273420 $Y=316020
X71 61 1126 1050 1134 1 1136 2 AOI22S $T=275900 255920 0 0 $X=275900 $Y=255540
X72 61 52 1133 934 1 879 2 AOI22S $T=276520 296240 1 0 $X=276520 $Y=290820
X73 1126 1088 1078 1116 1 1150 2 AOI22S $T=277760 235760 0 0 $X=277760 $Y=235380
X74 1088 15 143 1160 1 1164 2 AOI22S $T=283960 276080 0 0 $X=283960 $Y=275700
X75 56 1120 1179 1175 1 1169 2 AOI22S $T=291400 266000 0 180 $X=287680 $Y=260580
X76 879 1146 1187 1088 1 147 2 AOI22S $T=292640 306320 1 0 $X=292640 $Y=300900
X77 1082 19 1195 1184 1 1154 2 AOI22S $T=296980 266000 1 180 $X=293260 $Y=265620
X78 1129 1120 1204 1211 1 1223 2 AOI22S $T=300700 266000 0 0 $X=300700 $Y=265620
X79 19 106 1216 15 1 1228 2 AOI22S $T=301940 286160 0 0 $X=301940 $Y=285780
X80 1082 19 1230 1024 1 1238 2 AOI22S $T=306900 266000 0 0 $X=306900 $Y=265620
X81 1126 1088 1257 1262 1 1269 2 AOI22S $T=315580 235760 0 0 $X=315580 $Y=235380
X82 15 1120 201 130 1 1309 2 AOI22S $T=335420 296240 1 0 $X=335420 $Y=290820
X83 1464 1466 1455 1418 1 232 2 AOI22S $T=393700 255920 1 0 $X=393700 $Y=250500
X84 1467 1451 1420 236 1 235 2 AOI22S $T=394940 255920 0 0 $X=394940 $Y=255540
X85 1776 1782 1783 1765 1 1794 2 AOI22S $T=507160 255920 0 0 $X=507160 $Y=255540
X86 1863 1825 1856 1780 1 1850 2 AOI22S $T=521420 235760 1 180 $X=517700 $Y=235380
X87 1829 339 1768 341 1 1862 2 AOI22S $T=517700 306320 1 0 $X=517700 $Y=300900
X88 341 352 1889 1840 1 1896 2 AOI22S $T=524520 306320 1 0 $X=524520 $Y=300900
X89 1868 1829 1852 1898 1 1909 2 AOI22S $T=525140 266000 0 0 $X=525140 $Y=265620
X90 1892 1819 1908 1825 1 362 2 AOI22S $T=528860 286160 1 0 $X=528860 $Y=280740
X91 1863 1825 1929 1922 1 1920 2 AOI22S $T=535060 235760 0 180 $X=531340 $Y=230340
X92 1941 1782 1956 1939 1 1959 2 AOI22S $T=543740 266000 0 180 $X=540020 $Y=260580
X93 1838 386 1986 1840 1 377 2 AOI22S $T=543740 316400 1 180 $X=540020 $Y=316020
X94 364 2002 1994 395 1 1888 2 AOI22S $T=546840 316400 1 0 $X=546840 $Y=310980
X95 390 1960 2003 2009 1 399 2 AOI22S $T=547460 296240 1 0 $X=547460 $Y=290820
X96 2009 395 1875 2008 1 1892 2 AOI22S $T=551800 276080 0 180 $X=548080 $Y=270660
X97 341 2002 2004 2009 1 339 2 AOI22S $T=548080 306320 0 0 $X=548080 $Y=305940
X98 405 402 2023 1888 1 377 2 AOI22S $T=553660 316400 1 180 $X=549940 $Y=316020
X99 1868 404 2024 361 1 2046 2 AOI22S $T=551800 306320 1 0 $X=551800 $Y=300900
X100 413 412 1897 1838 1 364 2 AOI22S $T=558000 306320 1 180 $X=554280 $Y=305940
X101 411 1941 1964 2045 1 409 2 AOI22S $T=555520 296240 0 0 $X=555520 $Y=295860
X102 2099 2092 1938 2087 1 1825 2 AOI22S $T=571020 266000 0 180 $X=567300 $Y=260580
X103 395 364 2081 339 1 427 2 AOI22S $T=567300 306320 0 0 $X=567300 $Y=305940
X104 2092 1829 2104 2089 1 2097 2 AOI22S $T=572880 255920 1 180 $X=569160 $Y=255540
X105 1825 353 2076 2106 1 1925 2 AOI22S $T=570400 245840 0 0 $X=570400 $Y=245460
X106 1941 435 2035 436 1 1869 2 AOI22S $T=572880 296240 1 0 $X=572880 $Y=290820
X107 1776 442 2133 439 1 2053 2 AOI22S $T=577840 316400 0 180 $X=574120 $Y=310980
X108 1829 427 1958 353 1 2139 2 AOI22S $T=577220 266000 1 0 $X=577220 $Y=260580
X109 446 1838 1821 2118 1 1829 2 AOI22S $T=582180 306320 1 180 $X=578460 $Y=305940
X110 2092 1829 2000 2149 1 2148 2 AOI22S $T=579700 255920 0 0 $X=579700 $Y=255540
X111 2009 2138 2123 408 1 2158 2 AOI22S $T=581560 306320 1 0 $X=581560 $Y=300900
X112 2160 1782 2137 2159 1 2147 2 AOI22S $T=587760 255920 0 180 $X=584040 $Y=250500
X113 352 1868 2112 2178 1 2174 2 AOI22S $T=585900 286160 1 0 $X=585900 $Y=280740
X114 2009 1941 2177 2176 1 2175 2 AOI22S $T=591480 245840 0 180 $X=587760 $Y=240420
X115 2009 1863 2181 2191 1 2197 2 AOI22S $T=590240 235760 0 0 $X=590240 $Y=235380
X116 1868 1776 2188 2190 1 2199 2 AOI22S $T=590860 286160 0 0 $X=590860 $Y=285780
X117 1868 2092 1867 2207 1 2210 2 AOI22S $T=593960 255920 1 0 $X=593960 $Y=250500
X118 2160 1863 2219 2226 1 2213 2 AOI22S $T=598920 266000 1 0 $X=598920 $Y=260580
X119 339 1868 2222 2229 1 2239 2 AOI22S $T=599540 306320 1 0 $X=599540 $Y=300900
X120 2225 2232 2237 2118 1 406 2 AOI22S $T=604500 306320 1 180 $X=600780 $Y=305940
X121 353 1782 472 2045 1 2283 2 AOI22S $T=617520 286160 0 0 $X=617520 $Y=285780
X122 2769 2759 2760 2755 1 2753 2 AOI22S $T=822740 245840 1 180 $X=819020 $Y=245460
X123 2775 2788 2772 2791 1 2769 2 AOI22S $T=824600 276080 1 0 $X=824600 $Y=270660
X124 600 2778 2796 2813 1 2816 2 AOI22S $T=826460 245840 0 0 $X=826460 $Y=245460
X125 600 2793 2764 2788 1 616 2 AOI22S $T=826460 276080 0 0 $X=826460 $Y=275700
X126 2820 2808 2779 618 1 2844 2 AOI22S $T=831420 266000 0 0 $X=831420 $Y=265620
X127 2820 2793 2847 2759 1 2821 2 AOI22S $T=836380 235760 1 180 $X=832660 $Y=235380
X128 2821 2834 2818 2822 1 2841 2 AOI22S $T=832660 255920 0 0 $X=832660 $Y=255540
X129 621 2797 2833 616 1 633 2 AOI22S $T=832660 306320 1 0 $X=832660 $Y=300900
X130 2855 2853 2860 635 1 2848 2 AOI22S $T=840100 235760 0 180 $X=836380 $Y=230340
X131 2819 2850 2785 2855 1 2845 2 AOI22S $T=836380 276080 1 0 $X=836380 $Y=270660
X132 2834 640 2871 2821 1 2855 2 AOI22S $T=841340 235760 1 180 $X=837620 $Y=235380
X133 2845 2808 2857 2865 1 2853 2 AOI22S $T=838240 266000 0 0 $X=838240 $Y=265620
X134 2821 2865 2867 2787 1 2878 2 AOI22S $T=839480 255920 1 0 $X=839480 $Y=250500
X135 2889 2852 2882 2876 1 2874 2 AOI22S $T=844440 255920 1 180 $X=840720 $Y=255540
X136 2788 2820 2859 648 1 2884 2 AOI22S $T=840720 276080 1 0 $X=840720 $Y=270660
X137 644 2855 2877 648 1 2890 2 AOI22S $T=841340 306320 1 0 $X=841340 $Y=300900
X138 2852 2908 2907 2922 1 616 2 AOI22S $T=848160 276080 1 0 $X=848160 $Y=270660
X139 671 2853 2916 635 1 2778 2 AOI22S $T=852500 235760 0 180 $X=848780 $Y=230340
X140 621 643 2898 2914 1 670 2 AOI22S $T=848780 316400 0 0 $X=848780 $Y=316020
X141 670 2924 2886 616 1 675 2 AOI22S $T=851260 286160 1 0 $X=851260 $Y=280740
X142 676 677 2920 678 1 625 2 AOI22S $T=854360 316400 1 0 $X=854360 $Y=310980
X143 641 680 2887 681 1 621 2 AOI22S $T=856840 306320 1 0 $X=856840 $Y=300900
X144 679 683 2926 2914 1 684 2 AOI22S $T=858080 316400 0 0 $X=858080 $Y=316020
X145 677 676 2953 641 1 644 2 AOI22S $T=858700 306320 0 0 $X=858700 $Y=305940
X146 2922 2814 2960 2981 1 2965 2 AOI22S $T=860560 266000 1 0 $X=860560 $Y=260580
X147 2791 640 2980 2976 1 2987 2 AOI22S $T=863660 266000 0 0 $X=863660 $Y=265620
X148 2976 2855 2870 2987 1 2820 2 AOI22S $T=866760 276080 1 0 $X=866760 $Y=270660
X149 2778 2848 2968 3000 1 2989 2 AOI22S $T=868000 235760 0 0 $X=868000 $Y=235380
X150 2855 2924 3003 2793 1 2848 2 AOI22S $T=871720 245840 0 180 $X=868000 $Y=240420
X151 2775 641 2955 699 1 2797 2 AOI22S $T=869860 296240 0 0 $X=869860 $Y=295860
X152 670 641 2970 700 1 702 2 AOI22S $T=869860 306320 0 0 $X=869860 $Y=305940
X153 670 700 2992 703 1 683 2 AOI22S $T=870480 316400 0 0 $X=870480 $Y=316020
X154 675 689 3018 641 1 644 2 AOI22S $T=877920 306320 1 180 $X=874200 $Y=305940
X155 710 680 2996 700 1 3037 2 AOI22S $T=878540 316400 1 0 $X=878540 $Y=310980
X156 702 711 3025 633 1 644 2 AOI22S $T=879780 316400 0 0 $X=879780 $Y=316020
X157 2976 643 3035 3047 1 3026 2 AOI22S $T=880400 296240 1 0 $X=880400 $Y=290820
X158 2987 618 3044 3037 1 3000 2 AOI22S $T=883500 276080 1 0 $X=883500 $Y=270660
X159 2834 2769 3046 3075 1 3061 2 AOI22S $T=884120 245840 0 0 $X=884120 $Y=245460
X160 2793 2924 3008 3056 1 2769 2 AOI22S $T=884120 255920 0 0 $X=884120 $Y=255540
X161 677 640 3055 3017 1 3047 2 AOI22S $T=887840 296240 0 180 $X=884120 $Y=290820
X162 2819 683 3029 3050 1 648 2 AOI22S $T=884120 306320 1 0 $X=884120 $Y=300900
X163 675 641 3058 681 1 717 2 AOI22S $T=887840 296240 0 0 $X=887840 $Y=295860
X164 719 717 2975 702 1 703 2 AOI22S $T=892180 306320 0 180 $X=888460 $Y=300900
X165 2844 2814 3082 3056 1 3080 2 AOI22S $T=894660 266000 0 180 $X=890940 $Y=260580
X166 717 679 3069 3067 1 722 2 AOI22S $T=890940 316400 0 0 $X=890940 $Y=316020
X167 653 3037 3081 3084 1 2976 2 AOI22S $T=892180 286160 0 0 $X=892180 $Y=285780
X168 3105 681 3012 717 1 633 2 AOI22S $T=895900 306320 0 180 $X=892180 $Y=300900
X169 710 724 3093 3101 1 3037 2 AOI22S $T=895280 306320 0 0 $X=895280 $Y=305940
X170 2987 2850 3097 3104 1 3106 2 AOI22S $T=896520 266000 1 0 $X=896520 $Y=260580
X171 681 726 3059 633 1 3101 2 AOI22S $T=897760 316400 1 0 $X=897760 $Y=310980
X172 2850 2922 3161 3160 1 3186 2 AOI22S $T=913880 255920 0 0 $X=913880 $Y=255540
X173 3149 666 3068 2844 1 2850 2 AOI22S $T=914500 276080 0 0 $X=914500 $Y=275700
X174 678 3017 3164 2908 1 743 2 AOI22S $T=915740 316400 1 0 $X=915740 $Y=310980
X175 3037 676 746 684 1 3027 2 AOI22S $T=920080 316400 1 0 $X=920080 $Y=310980
X176 2808 2814 3191 2855 1 3084 2 AOI22S $T=928140 286160 1 180 $X=924420 $Y=285780
X177 2976 2922 3207 2793 1 3185 2 AOI22S $T=929380 266000 1 180 $X=925660 $Y=265620
X178 680 702 3202 3192 1 3213 2 AOI22S $T=928140 306320 1 0 $X=928140 $Y=300900
X179 2889 656 3218 2976 1 2987 2 AOI22S $T=933720 266000 0 180 $X=930000 $Y=260580
X180 2987 2844 757 3232 1 3234 2 AOI22S $T=935580 276080 0 0 $X=935580 $Y=275700
X181 2808 648 3245 3238 1 3235 2 AOI22S $T=942400 276080 0 180 $X=938680 $Y=270660
X182 648 703 3282 771 1 3265 2 AOI22S $T=960380 316400 0 0 $X=960380 $Y=316020
X183 806 3336 3339 804 1 803 2 AOI22S $T=1013080 316400 1 180 $X=1009360 $Y=316020
X184 3335 3346 3345 809 1 811 2 AOI22S $T=1014320 316400 1 0 $X=1014320 $Y=310980
X185 3338 3343 3342 816 1 815 2 AOI22S $T=1014940 266000 0 0 $X=1014940 $Y=265620
X186 3341 3349 3348 809 1 811 2 AOI22S $T=1016800 306320 1 0 $X=1016800 $Y=300900
X187 817 810 3344 804 1 803 2 AOI22S $T=1020520 316400 1 180 $X=1016800 $Y=316020
X188 3351 3350 3347 812 1 813 2 AOI22S $T=1018660 286160 1 0 $X=1018660 $Y=280740
X189 3355 3352 3354 816 1 815 2 AOI22S $T=1025480 266000 1 180 $X=1021760 $Y=265620
X190 3357 3356 3353 812 1 813 2 AOI22S $T=1029820 286160 0 180 $X=1026100 $Y=280740
X191 819 3361 3359 804 1 803 2 AOI22S $T=1035400 316400 0 180 $X=1031680 $Y=310980
X192 3368 3365 3360 812 1 813 2 AOI22S $T=1037260 286160 0 180 $X=1033540 $Y=280740
X193 3364 3366 3363 809 1 811 2 AOI22S $T=1033540 306320 0 0 $X=1033540 $Y=305940
X194 823 821 3370 804 1 803 2 AOI22S $T=1039740 316400 0 180 $X=1036020 $Y=310980
X195 3376 3372 3373 812 1 813 2 AOI22S $T=1041600 286160 0 180 $X=1037880 $Y=280740
X196 3369 3378 3362 816 1 815 2 AOI22S $T=1040980 266000 0 0 $X=1040980 $Y=265620
X197 3382 3374 3367 809 1 811 2 AOI22S $T=1045940 306320 1 180 $X=1042220 $Y=305940
X198 3384 824 3377 804 1 803 2 AOI22S $T=1047180 316400 0 180 $X=1043460 $Y=310980
X199 3381 3380 3383 816 1 815 2 AOI22S $T=1045940 276080 1 0 $X=1045940 $Y=270660
X200 3392 3387 3388 816 1 815 2 AOI22S $T=1062680 266000 1 180 $X=1058960 $Y=265620
X201 3385 3389 3379 809 1 811 2 AOI22S $T=1060820 306320 0 0 $X=1060820 $Y=305940
X202 3398 3391 3386 812 1 813 2 AOI22S $T=1066400 286160 0 180 $X=1062680 $Y=280740
X203 827 3390 3393 804 1 803 2 AOI22S $T=1066400 316400 0 180 $X=1062680 $Y=310980
X204 3394 3395 3400 809 1 811 2 AOI22S $T=1069500 306320 0 180 $X=1065780 $Y=300900
X205 830 3397 3404 816 1 815 2 AOI22S $T=1072600 316400 1 180 $X=1068880 $Y=316020
X206 3396 3401 3399 816 1 815 2 AOI22S $T=1069500 276080 0 0 $X=1069500 $Y=275700
X207 3407 3406 3403 812 1 813 2 AOI22S $T=1079420 316400 0 180 $X=1075700 $Y=310980
X208 3409 3408 3405 812 1 813 2 AOI22S $T=1081280 286160 1 180 $X=1077560 $Y=285780
X209 17 34 1 2 923 AN2 $T=228160 276080 0 0 $X=228160 $Y=275700
X210 36 900 1 2 931 AN2 $T=230020 245840 0 0 $X=230020 $Y=245460
X211 68 939 1 2 978 AN2 $T=242420 235760 1 180 $X=239940 $Y=235380
X212 13 75 1 2 987 AN2 $T=247380 296240 0 180 $X=244900 $Y=290820
X213 933 1048 1 2 98 AN2 $T=256060 286160 1 0 $X=256060 $Y=280740
X214 986 1020 1 2 1149 AN2 $T=279000 286160 0 0 $X=279000 $Y=285780
X215 1119 1075 1 2 1043 AN2 $T=290780 245840 0 0 $X=290780 $Y=245460
X216 996 1205 1 2 1188 AN2 $T=300080 296240 0 180 $X=297600 $Y=290820
X217 1187 164 1 2 166 AN2 $T=300080 316400 0 0 $X=300080 $Y=316020
X218 1258 1151 1 2 1234 AN2 $T=317440 296240 1 180 $X=314960 $Y=295860
X219 1111 16 1 2 1253 AN2 $T=320540 276080 0 180 $X=318060 $Y=270660
X220 47 1167 1 2 1048 AN2 $T=320540 286160 0 180 $X=318060 $Y=280740
X221 1325 198 1 2 1322 AN2 $T=350300 286160 1 0 $X=350300 $Y=280740
X222 1368 228 1 2 1389 AN2 $T=367660 266000 1 0 $X=367660 $Y=260580
X223 229 228 1 2 1385 AN2 $T=369520 306320 0 0 $X=369520 $Y=305940
X224 1391 228 1 2 1369 AN2 $T=370140 235760 0 0 $X=370140 $Y=235380
X225 1388 228 1 2 1395 AN2 $T=371380 245840 1 0 $X=371380 $Y=240420
X226 1463 1465 1 2 237 AN2 $T=393080 316400 0 0 $X=393080 $Y=316020
X227 1472 1471 1 2 1465 AN2 $T=397420 306320 0 180 $X=394940 $Y=300900
X228 239 237 1 2 241 AN2 $T=396800 316400 0 0 $X=396800 $Y=316020
X229 1477 1475 1 2 1471 AN2 $T=400520 296240 0 180 $X=398040 $Y=290820
X230 244 1479 1 2 1476 AN2 $T=402380 306320 0 180 $X=399900 $Y=300900
X231 1483 1494 1 2 1445 AN2 $T=407340 286160 0 180 $X=404860 $Y=280740
X232 246 1479 1 2 1489 AN2 $T=408580 306320 0 180 $X=406100 $Y=300900
X233 1453 228 1 2 1444 AN2 $T=411060 225680 0 180 $X=408580 $Y=220260
X234 250 1479 1 2 1451 AN2 $T=411060 296240 1 180 $X=408580 $Y=295860
X235 248 1479 1 2 1513 AN2 $T=410440 306320 1 0 $X=410440 $Y=300900
X236 1519 1508 1 2 1494 AN2 $T=414160 286160 0 180 $X=411680 $Y=280740
X237 1511 1505 1 2 1518 AN2 $T=417880 266000 1 180 $X=415400 $Y=265620
X238 1547 228 1 2 1498 AN2 $T=420980 235760 1 180 $X=418500 $Y=235380
X239 1514 236 1 2 1533 AN2 $T=419120 276080 0 0 $X=419120 $Y=275700
X240 1522 1479 1 2 1510 AN2 $T=427180 306320 1 0 $X=427180 $Y=300900
X241 1557 1556 1 2 1568 AN2 $T=432140 306320 1 0 $X=432140 $Y=300900
X242 1516 1570 1 2 1556 AN2 $T=436480 296240 1 180 $X=434000 $Y=295860
X243 1573 1568 1 2 265 AN2 $T=437720 316400 1 180 $X=435240 $Y=316020
X244 1579 228 1 2 1548 AN2 $T=438340 235760 1 180 $X=435860 $Y=235380
X245 1562 1560 1 2 1570 AN2 $T=435860 296240 1 0 $X=435860 $Y=290820
X246 268 1576 1 2 1466 AN2 $T=441440 306320 0 180 $X=438960 $Y=300900
X247 269 1576 1 2 1553 AN2 $T=441440 316400 0 180 $X=438960 $Y=310980
X248 270 1576 1 2 1586 AN2 $T=442680 306320 1 0 $X=442680 $Y=300900
X249 1611 228 1 2 1590 AN2 $T=448260 225680 1 180 $X=445780 $Y=225300
X250 1587 1609 1 2 1591 AN2 $T=445780 255920 0 0 $X=445780 $Y=255540
X251 1601 1603 1 2 1604 AN2 $T=448260 286160 0 180 $X=445780 $Y=280740
X252 1618 1614 1 2 1599 AN2 $T=451980 296240 0 180 $X=449500 $Y=290820
X253 1634 281 1 2 1644 AN2 $T=460040 266000 1 0 $X=460040 $Y=260580
X254 1643 1641 1 2 1646 AN2 $T=464380 245840 0 0 $X=464380 $Y=245460
X255 1650 1646 1 2 1661 AN2 $T=466240 266000 0 0 $X=466240 $Y=265620
X256 1663 1661 1 2 1671 AN2 $T=469960 276080 1 0 $X=469960 $Y=270660
X257 1673 1671 1 2 1664 AN2 $T=472440 286160 1 180 $X=469960 $Y=285780
X258 1667 1664 1 2 1674 AN2 $T=469960 296240 1 0 $X=469960 $Y=290820
X259 1665 1662 1 2 289 AN2 $T=469960 306320 1 0 $X=469960 $Y=300900
X260 292 1682 1 2 1634 AN2 $T=476160 286160 1 180 $X=473680 $Y=285780
X261 1692 1684 1 2 1641 AN2 $T=477400 255920 0 180 $X=474920 $Y=250500
X262 1680 1682 1 2 1678 AN2 $T=474920 286160 1 0 $X=474920 $Y=280740
X263 1677 1674 1 2 1662 AN2 $T=474920 296240 0 0 $X=474920 $Y=295860
X264 1695 228 1 2 1676 AN2 $T=480500 225680 1 180 $X=478020 $Y=225300
X265 295 1682 1 2 1639 AN2 $T=480500 296240 0 180 $X=478020 $Y=290820
X266 302 1682 1 2 1638 AN2 $T=482360 286160 1 180 $X=479880 $Y=285780
X267 1703 1702 1 2 1687 AN2 $T=485460 266000 0 180 $X=482980 $Y=260580
X268 1710 228 1 2 1698 AN2 $T=489180 225680 0 180 $X=486700 $Y=220260
X269 1706 1630 1 2 1653 AN2 $T=489180 235760 0 180 $X=486700 $Y=230340
X270 338 337 1 2 1827 AN2 $T=517700 286160 0 180 $X=515220 $Y=280740
X271 333 1822 1 2 1816 AN2 $T=519560 235760 0 180 $X=517080 $Y=230340
X272 1889 1897 1 2 1870 AN2 $T=525760 306320 0 0 $X=525760 $Y=305940
X273 1908 359 1 2 360 AN2 $T=529480 306320 0 0 $X=529480 $Y=305940
X274 2004 393 1 2 1983 AN2 $T=548700 296240 1 180 $X=546220 $Y=295860
X275 1926 1932 1 2 401 AN2 $T=549940 255920 0 0 $X=549940 $Y=255540
X276 1893 2184 1 2 1932 AN2 $T=591480 266000 0 180 $X=589000 $Y=260580
X277 2047 2185 1 2 2196 AN2 $T=598300 276080 1 180 $X=595820 $Y=275700
X278 447 380 1 2 337 AN2 $T=597680 316400 0 0 $X=597680 $Y=316020
X279 1935 2231 1 2 2234 AN2 $T=601400 225680 1 0 $X=601400 $Y=220260
X280 1895 2228 1 2 2240 AN2 $T=608220 276080 1 180 $X=605740 $Y=275700
X281 1795 1911 1 2 2260 AN2 $T=608220 225680 1 0 $X=608220 $Y=220260
X282 1975 1793 1 2 2263 AN2 $T=611320 225680 0 0 $X=611320 $Y=225300
X283 2116 2267 1 2 2243 AN2 $T=615040 255920 1 180 $X=612560 $Y=255540
X284 469 2189 1 2 2284 AN2 $T=618140 296240 1 0 $X=618140 $Y=290820
X285 2325 481 1 2 2317 AN2 $T=645420 296240 1 180 $X=642940 $Y=295860
X286 2051 455 1 2 2316 AN2 $T=646660 266000 1 0 $X=646660 $Y=260580
X287 502 503 1 2 2359 AN2 $T=660300 316400 1 0 $X=660300 $Y=310980
X288 2366 503 1 2 2376 AN2 $T=664020 225680 0 0 $X=664020 $Y=225300
X289 2361 503 1 2 2375 AN2 $T=664020 235760 0 0 $X=664020 $Y=235380
X290 507 503 1 2 2374 AN2 $T=664020 306320 1 0 $X=664020 $Y=300900
X291 505 503 1 2 2377 AN2 $T=665260 286160 0 0 $X=665260 $Y=285780
X292 2412 503 1 2 2425 AN2 $T=684480 245840 1 0 $X=684480 $Y=240420
X293 2429 2423 1 2 2409 AN2 $T=688200 266000 1 180 $X=685720 $Y=265620
X294 2411 2409 1 2 2427 AN2 $T=685720 276080 0 0 $X=685720 $Y=275700
X295 2416 2419 1 2 2414 AN2 $T=686960 306320 1 0 $X=686960 $Y=300900
X296 2430 2427 1 2 2419 AN2 $T=690060 296240 0 180 $X=687580 $Y=290820
X297 2417 2414 1 2 2436 AN2 $T=688820 306320 0 0 $X=688820 $Y=305940
X298 2431 2433 1 2 2435 AN2 $T=690060 306320 1 0 $X=690060 $Y=300900
X299 2445 2436 1 2 516 AN2 $T=692540 316400 1 180 $X=690060 $Y=316020
X300 2443 2434 1 2 2423 AN2 $T=693780 266000 0 180 $X=691300 $Y=260580
X301 2444 2440 1 2 2434 AN2 $T=693780 276080 0 180 $X=691300 $Y=270660
X302 2432 2437 1 2 2444 AN2 $T=691300 276080 0 0 $X=691300 $Y=275700
X303 517 2433 1 2 2406 AN2 $T=694400 296240 0 180 $X=691920 $Y=290820
X304 523 2433 1 2 2447 AN2 $T=696880 296240 1 180 $X=694400 $Y=295860
X305 2467 2458 1 2 2450 AN2 $T=700600 296240 0 180 $X=698120 $Y=290820
X306 524 2433 1 2 2441 AN2 $T=700600 296240 1 180 $X=698120 $Y=295860
X307 2465 503 1 2 2455 AN2 $T=703700 235760 0 180 $X=701220 $Y=230340
X308 2510 503 1 2 2501 AN2 $T=717340 225680 1 180 $X=714860 $Y=225300
X309 2520 503 1 2 2477 AN2 $T=720440 245840 1 180 $X=717960 $Y=245460
X310 2515 503 1 2 2472 AN2 $T=721060 266000 0 180 $X=718580 $Y=260580
X311 2519 503 1 2 2484 AN2 $T=721060 276080 1 180 $X=718580 $Y=275700
X312 2512 503 1 2 2508 AN2 $T=718580 286160 0 0 $X=718580 $Y=285780
X313 2527 2541 1 2 2529 AN2 $T=735320 286160 1 0 $X=735320 $Y=280740
X314 2570 2566 1 2 2545 AN2 $T=746480 276080 1 180 $X=744000 $Y=275700
X315 2547 2545 1 2 2576 AN2 $T=747100 286160 0 0 $X=747100 $Y=285780
X316 2574 2576 1 2 2577 AN2 $T=748960 306320 0 0 $X=748960 $Y=305940
X317 553 2586 1 2 2582 AN2 $T=754540 286160 1 180 $X=752060 $Y=285780
X318 2581 2577 1 2 546 AN2 $T=755160 316400 0 180 $X=752680 $Y=310980
X319 2585 2587 1 2 2591 AN2 $T=753920 266000 0 0 $X=753920 $Y=265620
X320 2593 2591 1 2 2566 AN2 $T=756400 276080 1 180 $X=753920 $Y=275700
X321 554 2586 1 2 2584 AN2 $T=756400 286160 0 180 $X=753920 $Y=280740
X322 2592 2595 1 2 2587 AN2 $T=756400 255920 0 0 $X=756400 $Y=255540
X323 2590 2601 1 2 2592 AN2 $T=757640 255920 1 0 $X=757640 $Y=250500
X324 2594 2586 1 2 2599 AN2 $T=757640 286160 1 0 $X=757640 $Y=280740
X325 2600 2586 1 2 2630 AN2 $T=763220 286160 1 0 $X=763220 $Y=280740
X326 2623 2618 1 2 2595 AN2 $T=766940 255920 0 180 $X=764460 $Y=250500
X327 2624 2625 1 2 2631 AN2 $T=764460 276080 1 0 $X=764460 $Y=270660
X328 2631 2627 1 2 2618 AN2 $T=769420 255920 1 180 $X=766940 $Y=255540
X329 2639 566 1 2 565 AN2 $T=770660 316400 1 180 $X=768180 $Y=316020
X330 565 2636 1 2 2645 AN2 $T=769420 306320 1 0 $X=769420 $Y=300900
X331 2675 2680 1 2 2686 AN2 $T=786780 255920 1 0 $X=786780 $Y=250500
X332 2682 2677 1 2 2678 AN2 $T=787400 306320 0 0 $X=787400 $Y=305940
X333 2691 2688 1 2 2679 AN2 $T=791120 286160 0 180 $X=788640 $Y=280740
X334 2692 2693 1 2 2677 AN2 $T=792360 296240 1 180 $X=789880 $Y=295860
X335 2684 2681 1 2 2703 AN2 $T=791740 225680 0 0 $X=791740 $Y=225300
X336 2683 2678 1 2 580 AN2 $T=791740 316400 1 0 $X=791740 $Y=310980
X337 2718 2716 1 2 2693 AN2 $T=801040 286160 0 180 $X=798560 $Y=280740
X338 2710 2715 1 2 2716 AN2 $T=799800 266000 0 0 $X=799800 $Y=265620
X339 590 2688 1 2 2723 AN2 $T=803520 286160 1 0 $X=803520 $Y=280740
X340 591 2688 1 2 2725 AN2 $T=803520 286160 0 0 $X=803520 $Y=285780
X341 2729 2728 1 2 2715 AN2 $T=807860 266000 0 180 $X=805380 $Y=260580
X342 2731 2733 1 2 2728 AN2 $T=808480 255920 0 0 $X=808480 $Y=255540
X343 2734 2732 1 2 2733 AN2 $T=812820 245840 0 180 $X=810340 $Y=240420
X344 601 2739 1 2 2737 AN2 $T=817780 245840 1 180 $X=815300 $Y=245460
X345 2962 2986 1 2 2950 AN2 $T=867380 225680 1 180 $X=864900 $Y=225300
X346 694 2993 1 2 2985 AN2 $T=869240 255920 1 180 $X=866760 $Y=255540
X347 2836 3074 1 2 3133 AN2 $T=892180 245840 0 0 $X=892180 $Y=245460
X348 732 728 1 2 2828 AN2 $T=906440 316400 0 180 $X=903960 $Y=310980
X349 3171 3179 1 2 2945 AN2 $T=921940 245840 1 180 $X=919460 $Y=245460
X350 706 3246 1 2 3239 AN2 $T=949840 225680 1 180 $X=947360 $Y=225300
X351 3342 3347 1 2 3340 AN2 $T=1017420 286160 0 180 $X=1014940 $Y=280740
X352 3354 3353 1 2 3337 AN2 $T=1025480 286160 0 180 $X=1023000 $Y=280740
X353 3362 3360 1 2 3358 AN2 $T=1032920 286160 0 180 $X=1030440 $Y=280740
X354 3383 3373 1 2 3375 AN2 $T=1044080 286160 0 180 $X=1041600 $Y=280740
X355 3388 3386 1 2 3371 AN2 $T=1061440 286160 0 180 $X=1058960 $Y=280740
X356 3404 3403 1 2 829 AN2 $T=1075080 316400 0 180 $X=1072600 $Y=310980
X357 3399 3405 1 2 3402 AN2 $T=1076940 286160 1 180 $X=1074460 $Y=285780
X358 1338 221 1354 2 1 1388 QDFFRBN $T=351540 235760 0 0 $X=351540 $Y=235380
X359 1334 221 1354 2 1 1368 QDFFRBN $T=354020 266000 1 0 $X=354020 $Y=260580
X360 1342 221 1354 2 1 1367 QDFFRBN $T=354020 276080 0 0 $X=354020 $Y=275700
X361 1346 223 225 2 1 229 QDFFRBN $T=355880 306320 0 0 $X=355880 $Y=305940
X362 1350 221 1354 2 1 1391 QDFFRBN $T=358360 235760 1 0 $X=358360 $Y=230340
X363 1478 221 1354 2 1 1453 QDFFRBN $T=402380 225680 1 180 $X=390600 $Y=225300
X364 1515 221 225 2 1 1547 QDFFRBN $T=414160 225680 0 0 $X=414160 $Y=225300
X365 1561 221 225 2 1 1579 QDFFRBN $T=429660 225680 0 0 $X=429660 $Y=225300
X366 1637 221 225 2 1 1611 QDFFRBN $T=463760 225680 1 180 $X=451980 $Y=225300
X367 1675 221 225 2 1 1695 QDFFRBN $T=471820 225680 1 0 $X=471820 $Y=220260
X368 1729 312 225 2 1 306 QDFFRBN $T=500340 266000 1 180 $X=488560 $Y=265620
X369 1731 312 225 2 1 294 QDFFRBN $T=500960 276080 0 180 $X=489180 $Y=270660
X370 1741 312 225 2 1 298 QDFFRBN $T=503440 286160 0 180 $X=491660 $Y=280740
X371 1746 312 225 2 1 258 QDFFRBN $T=504060 306320 1 180 $X=492280 $Y=305940
X372 2330 221 225 2 1 2361 QDFFRBN $T=647900 225680 1 0 $X=647900 $Y=220260
X373 2331 221 225 2 1 502 QDFFRBN $T=647900 316400 0 0 $X=647900 $Y=316020
X374 2333 221 225 2 1 507 QDFFRBN $T=650380 296240 0 0 $X=650380 $Y=295860
X375 2336 221 225 2 1 505 QDFFRBN $T=651000 286160 0 0 $X=651000 $Y=285780
X376 2338 221 225 2 1 2366 QDFFRBN $T=652240 235760 1 0 $X=652240 $Y=230340
X377 2356 221 225 2 1 2340 QDFFRBN $T=664640 266000 1 180 $X=652860 $Y=265620
X378 2392 221 225 2 1 2412 QDFFRBN $T=673940 235760 1 0 $X=673940 $Y=230340
X379 2424 221 225 2 1 2465 QDFFRBN $T=687580 225680 1 0 $X=687580 $Y=220260
X380 2542 221 225 2 1 2515 QDFFRBN $T=735320 266000 0 180 $X=723540 $Y=260580
X381 2546 221 225 2 1 2519 QDFFRBN $T=736560 276080 0 180 $X=724780 $Y=270660
X382 2544 221 225 2 1 2510 QDFFRBN $T=738420 225680 0 180 $X=726640 $Y=220260
X383 2548 221 225 2 1 2520 QDFFRBN $T=740280 235760 1 180 $X=728500 $Y=235380
X384 2752 598 225 2 1 2612 QDFFRBN $T=818400 266000 1 180 $X=806620 $Y=265620
X385 2740 598 225 2 1 2726 QDFFRBN $T=818400 276080 1 180 $X=806620 $Y=275700
X386 2742 598 592 2 1 567 QDFFRBN $T=819020 296240 1 180 $X=807240 $Y=295860
X387 2746 598 225 2 1 2730 QDFFRBN $T=819640 276080 0 180 $X=807860 $Y=270660
X388 2768 598 592 2 1 597 QDFFRBN $T=823980 316400 1 180 $X=812200 $Y=316020
X389 1221 1290 96 2 52 1314 1 AO22 $T=336660 286160 1 0 $X=336660 $Y=280740
X390 1440 235 1452 2 1459 236 1 AO22 $T=388740 306320 1 0 $X=388740 $Y=300900
X391 1422 235 1473 2 1476 236 1 AO22 $T=398040 266000 0 0 $X=398040 $Y=265620
X392 1469 235 1491 2 1489 236 1 AO22 $T=403000 296240 1 0 $X=403000 $Y=290820
X393 1512 235 1525 2 1513 236 1 AO22 $T=418500 286160 0 0 $X=418500 $Y=285780
X394 1545 1509 235 2 1530 236 1 AO22 $T=425320 276080 0 180 $X=420360 $Y=270660
X395 1425 232 1549 2 1553 1418 1 AO22 $T=424700 286160 0 0 $X=424700 $Y=285780
X396 1412 232 1554 2 1558 1418 1 AO22 $T=425940 316400 1 0 $X=425940 $Y=310980
X397 1403 232 262 2 263 1418 1 AO22 $T=425940 316400 0 0 $X=425940 $Y=316020
X398 1427 232 1543 2 264 1418 1 AO22 $T=427180 296240 0 0 $X=427180 $Y=295860
X399 1470 232 1580 2 1586 1418 1 AO22 $T=437100 276080 0 0 $X=437100 $Y=275700
X400 1441 279 1632 2 1638 281 1 AO22 $T=457560 255920 1 0 $X=457560 $Y=250500
X401 1401 1633 279 2 1639 281 1 AO22 $T=457560 276080 1 0 $X=457560 $Y=270660
X402 1371 279 1648 2 1655 281 1 AO22 $T=462520 286160 0 0 $X=462520 $Y=285780
X403 1372 279 1654 2 1656 281 1 AO22 $T=462520 296240 0 0 $X=462520 $Y=295860
X404 286 279 1652 2 1658 281 1 AO22 $T=463140 316400 0 0 $X=463140 $Y=316020
X405 1397 279 1660 2 1666 281 1 AO22 $T=465000 276080 0 0 $X=465000 $Y=275700
X406 1383 279 1649 2 1668 281 1 AO22 $T=466240 316400 1 0 $X=466240 $Y=310980
X407 2026 1980 1776 2 395 2042 1 AO22 $T=552420 276080 1 0 $X=552420 $Y=270660
X408 2380 510 2390 2 2396 511 1 AO22 $T=672080 306320 0 0 $X=672080 $Y=305940
X409 2391 510 2401 2 513 2410 1 AO22 $T=678280 286160 1 0 $X=678280 $Y=280740
X410 2378 510 2403 2 2406 2410 1 AO22 $T=678900 255920 0 0 $X=678900 $Y=255540
X411 2388 510 2404 2 2407 2410 1 AO22 $T=678900 296240 1 0 $X=678900 $Y=290820
X412 2394 510 2400 2 2408 2410 1 AO22 $T=679520 266000 0 0 $X=679520 $Y=265620
X413 2355 510 2413 2 2418 511 1 AO22 $T=683240 316400 0 0 $X=683240 $Y=316020
X414 2422 510 2439 2 2441 2410 1 AO22 $T=690060 255920 1 0 $X=690060 $Y=250500
X415 2459 510 2451 2 2447 2410 1 AO22 $T=699360 266000 0 180 $X=694400 $Y=260580
X416 2466 510 2462 2 2435 2410 1 AO22 $T=701840 255920 1 0 $X=701840 $Y=250500
X417 2485 510 2493 2 2494 2410 1 AO22 $T=708040 286160 1 0 $X=708040 $Y=280740
X418 2468 510 2488 2 2474 2410 1 AO22 $T=708040 286160 0 0 $X=708040 $Y=285780
X419 2532 543 2543 2 2561 545 1 AO22 $T=740280 296240 1 0 $X=740280 $Y=290820
X420 2536 543 2557 2 544 545 1 AO22 $T=740900 316400 0 0 $X=740900 $Y=316020
X421 2528 543 2562 2 2563 545 1 AO22 $T=741520 306320 0 0 $X=741520 $Y=305940
X422 2530 543 2564 2 2569 545 1 AO22 $T=743380 306320 1 0 $X=743380 $Y=300900
X423 2555 543 2572 2 2573 2568 1 AO22 $T=745860 276080 1 0 $X=745860 $Y=270660
X424 2565 543 2580 2 2582 2568 1 AO22 $T=747720 266000 0 0 $X=747720 $Y=265620
X425 2611 543 2603 2 2599 2568 1 AO22 $T=761980 245840 0 180 $X=757020 $Y=240420
X426 2415 543 2605 2 2596 2568 1 AO22 $T=757640 266000 0 0 $X=757640 $Y=265620
X427 2619 543 2613 2 2608 2568 1 AO22 $T=764460 266000 0 180 $X=759500 $Y=260580
X428 2654 2633 543 2 2630 2568 1 AO22 $T=775000 245840 0 180 $X=770040 $Y=240420
X429 2653 543 2645 2 2649 545 1 AO22 $T=778100 286160 0 180 $X=773140 $Y=280740
X430 2650 543 2658 2 2638 545 1 AO22 $T=779960 286160 1 180 $X=775000 $Y=285780
X431 2540 572 2665 2 2666 573 1 AO22 $T=779340 316400 0 0 $X=779340 $Y=316020
X432 2526 572 2668 2 2670 573 1 AO22 $T=779960 306320 0 0 $X=779960 $Y=305940
X433 2534 572 2669 2 2672 573 1 AO22 $T=781200 296240 1 0 $X=781200 $Y=290820
X434 2657 572 2673 2 2679 573 1 AO22 $T=784300 235760 1 0 $X=784300 $Y=230340
X435 2640 572 2696 2 2687 573 1 AO22 $T=790500 255920 0 0 $X=790500 $Y=255540
X436 2549 2694 2697 2 2699 573 1 AO22 $T=790500 266000 1 0 $X=790500 $Y=260580
X437 2539 2694 2705 2 2708 573 1 AO22 $T=792980 276080 0 0 $X=792980 $Y=275700
X438 2626 572 2709 2 2712 573 1 AO22 $T=794840 235760 1 0 $X=794840 $Y=230340
X439 2421 2694 2720 2 2721 573 1 AO22 $T=799800 255920 1 0 $X=799800 $Y=250500
X440 2571 2694 2724 2 2725 573 1 AO22 $T=802900 245840 0 0 $X=802900 $Y=245460
X441 3322 788 3318 2 785 783 1 AO22 $T=984560 316400 0 180 $X=979600 $Y=310980
X442 796 788 3328 2 793 783 1 AO22 $T=995720 316400 1 180 $X=990760 $Y=316020
X443 17 2 871 1 INV1S $T=221960 255920 1 180 $X=220720 $Y=255540
X444 21 2 19 1 INV1S $T=225680 296240 0 180 $X=224440 $Y=290820
X445 892 2 900 1 INV1S $T=225680 245840 0 0 $X=225680 $Y=245460
X446 927 2 902 1 INV1S $T=231880 306320 0 180 $X=230640 $Y=300900
X447 933 2 901 1 INV1S $T=232500 255920 1 180 $X=231260 $Y=255540
X448 952 2 930 1 INV1S $T=236840 286160 0 180 $X=235600 $Y=280740
X449 53 2 913 1 INV1S $T=237460 316400 0 180 $X=236220 $Y=310980
X450 14 2 969 1 INV1S $T=240560 245840 1 180 $X=239320 $Y=245460
X451 18 2 60 1 INV1S $T=239320 306320 0 0 $X=239320 $Y=305940
X452 62 2 979 1 INV1S $T=241180 316400 1 180 $X=239940 $Y=316020
X453 944 2 974 1 INV1S $T=242420 245840 1 180 $X=241180 $Y=245460
X454 941 2 61 1 INV1S $T=241800 255920 0 0 $X=241800 $Y=255540
X455 986 2 924 1 INV1S $T=243660 225680 1 180 $X=242420 $Y=225300
X456 44 2 50 1 INV1S $T=245520 245840 1 180 $X=244280 $Y=245460
X457 42 2 934 1 INV1S $T=246140 276080 0 0 $X=246140 $Y=275700
X458 1017 2 946 1 INV1S $T=249860 235760 1 180 $X=248620 $Y=235380
X459 991 2 84 1 INV1S $T=248620 266000 1 0 $X=248620 $Y=260580
X460 945 2 1004 1 INV1S $T=249240 266000 0 0 $X=249240 $Y=265620
X461 41 2 1014 1 INV1S $T=251720 245840 1 180 $X=250480 $Y=245460
X462 929 2 87 1 INV1S $T=250480 286160 0 0 $X=250480 $Y=285780
X463 950 2 1030 1 INV1S $T=252340 245840 0 0 $X=252340 $Y=245460
X464 1061 2 994 1 INV1S $T=260400 255920 0 180 $X=259160 $Y=250500
X465 917 2 26 1 INV1S $T=259160 286160 1 0 $X=259160 $Y=280740
X466 1051 2 102 1 INV1S $T=260400 296240 1 0 $X=260400 $Y=290820
X467 896 2 1083 1 INV1S $T=262880 266000 0 0 $X=262880 $Y=265620
X468 938 2 1081 1 INV1S $T=266600 296240 0 180 $X=265360 $Y=290820
X469 943 2 1088 1 INV1S $T=265980 245840 0 0 $X=265980 $Y=245460
X470 1092 2 1096 1 INV1S $T=265980 255920 1 0 $X=265980 $Y=250500
X471 27 2 1082 1 INV1S $T=265980 266000 0 0 $X=265980 $Y=265620
X472 1056 2 1054 1 INV1S $T=269080 235760 1 0 $X=269080 $Y=230340
X473 24 2 96 1 INV1S $T=270320 286160 0 0 $X=270320 $Y=285780
X474 1102 2 878 1 INV1S $T=273420 286160 1 0 $X=273420 $Y=280740
X475 942 2 56 1 INV1S $T=275900 296240 1 180 $X=274660 $Y=295860
X476 1131 2 23 1 INV1S $T=277140 276080 1 180 $X=275900 $Y=275700
X477 1138 2 890 1 INV1S $T=282100 245840 1 180 $X=280860 $Y=245460
X478 1058 2 879 1 INV1S $T=283340 276080 1 180 $X=282100 $Y=275700
X479 113 2 25 1 INV1S $T=282720 286160 1 0 $X=282720 $Y=280740
X480 1161 2 1024 1 INV1S $T=285200 286160 0 180 $X=283960 $Y=280740
X481 1163 2 951 1 INV1S $T=285820 255920 1 0 $X=285820 $Y=250500
X482 1105 2 1015 1 INV1S $T=287680 276080 0 0 $X=287680 $Y=275700
X483 1177 2 77 1 INV1S $T=292640 286160 1 180 $X=291400 $Y=285780
X484 1183 2 1044 1 INV1S $T=294500 276080 1 180 $X=293260 $Y=275700
X485 981 2 1194 1 INV1S $T=297600 245840 0 180 $X=296360 $Y=240420
X486 142 2 158 1 INV1S $T=298840 266000 1 180 $X=297600 $Y=265620
X487 1090 2 1146 1 INV1S $T=298840 235760 1 0 $X=298840 $Y=230340
X488 11 2 1129 1 INV1S $T=301320 276080 0 180 $X=300080 $Y=270660
X489 996 2 1158 1 INV1S $T=303800 235760 0 0 $X=303800 $Y=235380
X490 914 2 1217 1 INV1S $T=305040 245840 0 180 $X=303800 $Y=240420
X491 918 2 1097 1 INV1S $T=303800 276080 0 0 $X=303800 $Y=275700
X492 1237 2 1168 1 INV1S $T=310000 235760 0 180 $X=308760 $Y=230340
X493 975 2 1120 1 INV1S $T=310000 276080 1 0 $X=310000 $Y=270660
X494 1218 2 1119 1 INV1S $T=313100 225680 1 180 $X=311860 $Y=225300
X495 909 2 1139 1 INV1S $T=312480 245840 1 0 $X=312480 $Y=240420
X496 1106 2 1100 1 INV1S $T=313720 276080 1 180 $X=312480 $Y=275700
X497 954 2 1238 1 INV1S $T=314340 286160 1 0 $X=314340 $Y=280740
X498 995 2 1261 1 INV1S $T=318680 255920 1 180 $X=317440 $Y=255540
X499 1271 2 106 1 INV1S $T=321160 296240 1 180 $X=319920 $Y=295860
X500 1273 2 94 1 INV1S $T=322400 296240 1 180 $X=321160 $Y=295860
X501 66 2 1126 1 INV1S $T=324880 245840 1 180 $X=323640 $Y=245460
X502 1279 2 1107 1 INV1S $T=325500 235760 0 180 $X=324260 $Y=230340
X503 1178 2 1104 1 INV1S $T=326120 235760 0 0 $X=326120 $Y=235380
X504 1189 2 1127 1 INV1S $T=327360 255920 1 180 $X=326120 $Y=255540
X505 57 2 15 1 INV1S $T=326740 296240 0 0 $X=326740 $Y=295860
X506 83 2 52 1 INV1S $T=332320 296240 0 0 $X=332320 $Y=295860
X507 16 2 1164 1 INV1S $T=336040 235760 1 180 $X=334800 $Y=235380
X508 30 2 81 1 INV1S $T=334800 286160 1 0 $X=334800 $Y=280740
X509 1258 2 926 1 INV1S $T=337280 276080 1 180 $X=336040 $Y=275700
X510 1264 2 1298 1 INV1S $T=339140 255920 1 180 $X=337900 $Y=255540
X511 956 2 130 1 INV1S $T=344720 255920 0 180 $X=343480 $Y=250500
X512 68 2 76 1 INV1S $T=344720 276080 1 180 $X=343480 $Y=275700
X513 1317 2 1319 1 INV1S $T=344100 276080 1 0 $X=344100 $Y=270660
X514 1333 2 1287 1 INV1S $T=350300 255920 1 180 $X=349060 $Y=255540
X515 218 2 1337 1 INV1S $T=350920 316400 1 0 $X=350920 $Y=310980
X516 216 2 217 1 INV1S $T=355260 306320 1 0 $X=355260 $Y=300900
X517 1329 2 1384 1 INV1S $T=367660 276080 1 0 $X=367660 $Y=270660
X518 1369 2 1363 1 INV1S $T=372620 235760 0 0 $X=372620 $Y=235380
X519 1349 2 1394 1 INV1S $T=386260 245840 0 0 $X=386260 $Y=245460
X520 1439 2 1463 1 INV1S $T=389980 316400 0 0 $X=389980 $Y=316020
X521 1459 2 1472 1 INV1S $T=397420 306320 1 0 $X=397420 $Y=300900
X522 1476 2 1474 1 INV1S $T=399900 286160 0 180 $X=398660 $Y=280740
X523 1433 2 1477 1 INV1S $T=400520 296240 0 0 $X=400520 $Y=295860
X524 1489 2 1483 1 INV1S $T=404860 296240 1 180 $X=403620 $Y=295860
X525 1485 2 1484 1 INV1S $T=405480 316400 0 180 $X=404240 $Y=310980
X526 1451 2 1488 1 INV1S $T=407340 286160 1 0 $X=407340 $Y=280740
X527 249 2 1486 1 INV1S $T=410440 316400 0 180 $X=409200 $Y=310980
X528 1513 2 1508 1 INV1S $T=411680 296240 0 180 $X=410440 $Y=290820
X529 1510 2 1517 1 INV1S $T=412300 306320 0 0 $X=412300 $Y=305940
X530 252 2 1520 1 INV1S $T=412920 316400 1 0 $X=412920 $Y=310980
X531 1522 2 243 1 INV1S $T=414780 306320 1 180 $X=413540 $Y=305940
X532 1479 2 242 1 INV1S $T=417260 306320 0 180 $X=416020 $Y=300900
X533 254 2 1529 1 INV1S $T=417260 306320 1 0 $X=417260 $Y=300900
X534 256 2 257 1 INV1S $T=419120 306320 1 0 $X=419120 $Y=300900
X535 258 2 253 1 INV1S $T=420360 306320 0 0 $X=420360 $Y=305940
X536 1553 2 1562 1 INV1S $T=430900 286160 0 0 $X=430900 $Y=285780
X537 1466 2 1565 1 INV1S $T=432760 276080 0 0 $X=432760 $Y=275700
X538 1567 2 1587 1 INV1S $T=434000 266000 1 0 $X=434000 $Y=260580
X539 264 2 1557 1 INV1S $T=434620 306320 1 0 $X=434620 $Y=300900
X540 263 2 267 1 INV1S $T=439580 316400 1 180 $X=438340 $Y=316020
X541 1558 2 1573 1 INV1S $T=441440 316400 1 180 $X=440200 $Y=316020
X542 1418 2 1592 1 INV1S $T=441440 306320 1 0 $X=441440 $Y=300900
X543 1589 2 1601 1 INV1S $T=443920 286160 1 0 $X=443920 $Y=280740
X544 1586 2 1606 1 INV1S $T=444540 276080 0 0 $X=444540 $Y=275700
X545 1585 2 1597 1 INV1S $T=447640 296240 0 0 $X=447640 $Y=295860
X546 274 2 1607 1 INV1S $T=448880 316400 0 180 $X=447640 $Y=310980
X547 1599 2 1575 1 INV1S $T=449500 296240 0 0 $X=449500 $Y=295860
X548 1627 2 1618 1 INV1S $T=455080 296240 0 0 $X=455080 $Y=295860
X549 278 2 1615 1 INV1S $T=457560 316400 0 0 $X=457560 $Y=316020
X550 1370 2 1528 1 INV1S $T=458800 255920 0 0 $X=458800 $Y=255540
X551 283 2 282 1 INV1S $T=462520 316400 1 180 $X=461280 $Y=316020
X552 1638 2 1643 1 INV1S $T=464380 255920 1 0 $X=464380 $Y=250500
X553 1634 2 1650 1 INV1S $T=466860 255920 0 0 $X=466860 $Y=255540
X554 1666 2 1673 1 INV1S $T=473680 296240 1 0 $X=473680 $Y=290820
X555 1656 2 1677 1 INV1S $T=473680 306320 1 0 $X=473680 $Y=300900
X556 1668 2 1665 1 INV1S $T=474920 306320 1 180 $X=473680 $Y=305940
X557 1658 2 290 1 INV1S $T=473680 316400 1 0 $X=473680 $Y=310980
X558 1639 2 1663 1 INV1S $T=475540 276080 1 0 $X=475540 $Y=270660
X559 1655 2 1667 1 INV1S $T=475540 296240 1 0 $X=475540 $Y=290820
X560 294 2 1479 1 INV1S $T=478020 306320 0 180 $X=476780 $Y=300900
X561 1696 2 1679 1 INV1S $T=479880 245840 0 180 $X=478640 $Y=240420
X562 298 2 1682 1 INV1S $T=482980 306320 1 180 $X=481740 $Y=305940
X563 1678 2 1692 1 INV1S $T=483600 245840 0 0 $X=483600 $Y=245460
X564 301 2 1704 1 INV1S $T=486700 296240 0 180 $X=485460 $Y=290820
X565 1707 2 1709 1 INV1S $T=489180 316400 1 180 $X=487940 $Y=316020
X566 1701 2 1702 1 INV1S $T=490420 266000 1 0 $X=490420 $Y=260580
X567 309 2 1712 1 INV1S $T=491660 306320 1 180 $X=490420 $Y=305940
X568 306 2 1522 1 INV1S $T=498480 306320 0 180 $X=497240 $Y=300900
X569 1763 2 1758 1 INV1S $T=509020 255920 0 180 $X=507780 $Y=250500
X570 313 2 1759 1 INV1S $T=509020 266000 0 180 $X=507780 $Y=260580
X571 1748 2 1782 1 INV1S $T=507780 266000 0 0 $X=507780 $Y=265620
X572 1719 2 1825 1 INV1S $T=514600 255920 0 0 $X=514600 $Y=255540
X573 334 2 1776 1 INV1S $T=516460 276080 0 180 $X=515220 $Y=270660
X574 1860 2 1844 1 INV1S $T=520800 266000 0 180 $X=519560 $Y=260580
X575 1861 2 1868 1 INV1S $T=520180 276080 1 0 $X=520180 $Y=270660
X576 333 2 1843 1 INV1S $T=520800 286160 0 0 $X=520800 $Y=285780
X577 1812 2 1879 1 INV1S $T=522660 255920 0 0 $X=522660 $Y=255540
X578 1874 2 1883 1 INV1S $T=523280 225680 1 0 $X=523280 $Y=220260
X579 1809 2 1829 1 INV1S $T=524520 255920 0 0 $X=524520 $Y=255540
X580 349 2 1888 1 INV1S $T=525760 316400 1 180 $X=524520 $Y=316020
X581 1896 2 1872 1 INV1S $T=527000 296240 1 180 $X=525760 $Y=295860
X582 345 2 1838 1 INV1S $T=527000 316400 0 180 $X=525760 $Y=310980
X583 1881 2 1805 1 INV1S $T=527000 245840 1 0 $X=527000 $Y=240420
X584 363 2 1919 1 INV1S $T=531960 296240 1 180 $X=530720 $Y=295860
X585 1802 2 1941 1 INV1S $T=534440 266000 0 0 $X=534440 $Y=265620
X586 1926 2 1917 1 INV1S $T=535060 255920 1 0 $X=535060 $Y=250500
X587 1714 2 1819 1 INV1S $T=535680 225680 0 0 $X=535680 $Y=225300
X588 1955 2 1962 1 INV1S $T=538780 255920 0 0 $X=538780 $Y=255540
X589 1876 2 1961 1 INV1S $T=539400 306320 0 0 $X=539400 $Y=305940
X590 1806 2 1974 1 INV1S $T=541260 235760 0 0 $X=541260 $Y=235380
X591 1984 2 1982 1 INV1S $T=544980 255920 0 0 $X=544980 $Y=255540
X592 1895 2 1991 1 INV1S $T=547460 225680 1 0 $X=547460 $Y=220260
X593 2018 2 400 1 INV1S $T=550560 266000 1 0 $X=550560 $Y=260580
X594 1880 2 2009 1 INV1S $T=551800 245840 1 0 $X=551800 $Y=240420
X595 368 2 402 1 INV1S $T=556140 316400 0 0 $X=556140 $Y=316020
X596 1911 2 1925 1 INV1S $T=556760 245840 1 0 $X=556760 $Y=240420
X597 2036 2 1993 1 INV1S $T=559860 266000 0 0 $X=559860 $Y=265620
X598 407 2 1965 1 INV1S $T=560480 306320 1 0 $X=560480 $Y=300900
X599 2060 2 1975 1 INV1S $T=565440 225680 1 0 $X=565440 $Y=220260
X600 1859 2 2068 1 INV1S $T=566680 245840 0 180 $X=565440 $Y=240420
X601 2062 2 1937 1 INV1S $T=571020 266000 1 0 $X=571020 $Y=260580
X602 2128 2 1739 1 INV1S $T=578460 235760 1 180 $X=577220 $Y=235380
X603 1869 2 2135 1 INV1S $T=577840 286160 0 0 $X=577840 $Y=285780
X604 1907 2 2025 1 INV1S $T=578460 235760 0 0 $X=578460 $Y=235380
X605 348 2 2092 1 INV1S $T=580940 245840 1 180 $X=579700 $Y=245460
X606 2038 2 2136 1 INV1S $T=582180 245840 1 0 $X=582180 $Y=240420
X607 2168 2 2149 1 INV1S $T=587760 276080 0 180 $X=586520 $Y=270660
X608 1789 2 2141 1 INV1S $T=587140 225680 0 0 $X=587140 $Y=225300
X609 2162 2 1770 1 INV1S $T=588380 235760 0 180 $X=587140 $Y=230340
X610 1933 2 2082 1 INV1S $T=589620 266000 0 0 $X=589620 $Y=265620
X611 2189 2 406 1 INV1S $T=592720 306320 1 0 $X=592720 $Y=300900
X612 1738 2 1863 1 INV1S $T=595820 225680 1 180 $X=594580 $Y=225300
X613 2203 2 452 1 INV1S $T=595820 316400 0 180 $X=594580 $Y=310980
X614 403 2 2138 1 INV1S $T=596440 316400 1 180 $X=595200 $Y=316020
X615 346 2 2160 1 INV1S $T=597680 255920 1 180 $X=596440 $Y=255540
X616 1905 2 1862 1 INV1S $T=598300 225680 1 0 $X=598300 $Y=220260
X617 2048 2 2148 1 INV1S $T=598920 255920 0 0 $X=598920 $Y=255540
X618 1830 2 1923 1 INV1S $T=602020 245840 1 0 $X=602020 $Y=240420
X619 413 2 383 1 INV1S $T=603260 316400 0 0 $X=603260 $Y=316020
X620 1813 2 1977 1 INV1S $T=605120 245840 0 0 $X=605120 $Y=245460
X621 1885 2 2235 1 INV1S $T=608220 235760 1 180 $X=606980 $Y=235380
X622 1927 2 1960 1 INV1S $T=606980 266000 1 0 $X=606980 $Y=260580
X623 467 2 362 1 INV1S $T=615660 316400 0 0 $X=615660 $Y=316020
X624 2192 2 2157 1 INV1S $T=621860 255920 0 180 $X=620620 $Y=250500
X625 1749 2 2045 1 INV1S $T=623100 235760 0 180 $X=621860 $Y=230340
X626 2289 2 1892 1 INV1S $T=623100 266000 0 180 $X=621860 $Y=260580
X627 419 2 395 1 INV1S $T=624340 316400 0 180 $X=623100 $Y=310980
X628 2116 2 2291 1 INV1S $T=623720 225680 0 0 $X=623720 $Y=225300
X629 2201 2 446 1 INV1S $T=626200 235760 0 180 $X=624960 $Y=230340
X630 471 2 1839 1 INV1S $T=624960 266000 1 0 $X=624960 $Y=260580
X631 2155 2 421 1 INV1S $T=626820 235760 1 180 $X=625580 $Y=235380
X632 1817 2 353 1 INV1S $T=628060 296240 0 180 $X=626820 $Y=290820
X633 1997 2 2146 1 INV1S $T=630540 235760 0 180 $X=629300 $Y=230340
X634 2266 2 1999 1 INV1S $T=631780 306320 0 180 $X=630540 $Y=300900
X635 1887 2 2124 1 INV1S $T=632400 235760 0 180 $X=631160 $Y=230340
X636 382 2 429 1 INV1S $T=631160 286160 0 0 $X=631160 $Y=285780
X637 2070 2 2002 1 INV1S $T=633020 266000 1 180 $X=631780 $Y=265620
X638 2315 2 2231 1 INV1S $T=633640 225680 1 180 $X=632400 $Y=225300
X639 2216 2 2008 1 INV1S $T=637360 266000 0 0 $X=637360 $Y=265620
X640 2115 2 2096 1 INV1S $T=640460 255920 0 180 $X=639220 $Y=250500
X641 2040 2 1924 1 INV1S $T=640460 235760 0 0 $X=640460 $Y=235380
X642 2047 2 2292 1 INV1S $T=645420 276080 0 180 $X=644180 $Y=270660
X643 500 2 498 1 INV1S $T=644180 316400 0 0 $X=644180 $Y=316020
X644 2322 2 2227 1 INV1S $T=645420 276080 1 0 $X=645420 $Y=270660
X645 2051 2 2327 1 INV1S $T=647280 255920 1 0 $X=647280 $Y=250500
X646 2334 2 427 1 INV1S $T=651000 276080 0 180 $X=649760 $Y=270660
X647 2212 2 1918 1 INV1S $T=651620 255920 1 0 $X=651620 $Y=250500
X648 2332 2 2069 1 INV1S $T=652240 235760 0 0 $X=652240 $Y=235380
X649 497 2 495 1 INV1S $T=654720 316400 1 0 $X=654720 $Y=310980
X650 2351 2 2357 1 INV1S $T=659680 245840 0 0 $X=659680 $Y=245460
X651 510 2 511 1 INV1S $T=679520 306320 1 180 $X=678280 $Y=305940
X652 2396 2 2417 1 INV1S $T=684480 306320 1 0 $X=684480 $Y=300900
X653 2407 2 2416 1 INV1S $T=685100 296240 1 0 $X=685100 $Y=290820
X654 2408 2 2411 1 INV1S $T=686340 276080 1 0 $X=686340 $Y=270660
X655 2406 2 2429 1 INV1S $T=688200 276080 1 0 $X=688200 $Y=270660
X656 513 2 2430 1 INV1S $T=690060 286160 0 0 $X=690060 $Y=285780
X657 2435 2 2437 1 INV1S $T=691300 286160 1 0 $X=691300 $Y=280740
X658 518 2 2433 1 INV1S $T=693780 306320 1 180 $X=692540 $Y=305940
X659 2418 2 2445 1 INV1S $T=695020 316400 1 180 $X=693780 $Y=316020
X660 2447 2 2440 1 INV1S $T=696260 276080 0 180 $X=695020 $Y=270660
X661 2441 2 2443 1 INV1S $T=701840 255920 0 0 $X=701840 $Y=255540
X662 2474 2 2467 1 INV1S $T=703080 296240 0 180 $X=701840 $Y=290820
X663 2452 2 2469 1 INV1S $T=704940 286160 1 0 $X=704940 $Y=280740
X664 529 2 2479 1 INV1S $T=705560 316400 0 0 $X=705560 $Y=316020
X665 521 2 2463 1 INV1S $T=707420 316400 0 180 $X=706180 $Y=310980
X666 533 2 2489 1 INV1S $T=709900 316400 0 180 $X=708660 $Y=310980
X667 2494 2 2504 1 INV1S $T=715480 286160 0 0 $X=715480 $Y=285780
X668 2508 2 2509 1 INV1S $T=716720 276080 0 0 $X=716720 $Y=275700
X669 2497 2 2507 1 INV1S $T=716720 296240 0 0 $X=716720 $Y=295860
X670 526 2 2518 1 INV1S $T=720440 306320 0 0 $X=720440 $Y=305940
X671 543 2 2568 1 INV1S $T=742140 276080 1 0 $X=742140 $Y=270660
X672 2561 2 2547 1 INV1S $T=745860 286160 0 0 $X=745860 $Y=285780
X673 2569 2 2574 1 INV1S $T=749580 306320 1 0 $X=749580 $Y=300900
X674 2573 2 2570 1 INV1S $T=751440 286160 0 180 $X=750200 $Y=280740
X675 2582 2 2585 1 INV1S $T=752680 276080 1 0 $X=752680 $Y=270660
X676 2584 2 2590 1 INV1S $T=754540 255920 0 0 $X=754540 $Y=255540
X677 2563 2 2581 1 INV1S $T=755160 316400 1 0 $X=755160 $Y=310980
X678 2596 2 2593 1 INV1S $T=757640 276080 0 180 $X=756400 $Y=270660
X679 560 2 2604 1 INV1S $T=759500 306320 1 0 $X=759500 $Y=300900
X680 2599 2 2601 1 INV1S $T=760740 255920 0 0 $X=760740 $Y=255540
X681 2612 2 2586 1 INV1S $T=761360 286160 1 0 $X=761360 $Y=280740
X682 2630 2 2623 1 INV1S $T=765700 245840 1 180 $X=764460 $Y=245460
X683 2628 2 2624 1 INV1S $T=765700 276080 1 180 $X=764460 $Y=275700
X684 2629 2 2609 1 INV1S $T=766320 306320 1 180 $X=765080 $Y=305940
X685 567 2 2635 1 INV1S $T=771900 306320 0 0 $X=771900 $Y=305940
X686 571 2 2639 1 INV1S $T=776240 316400 0 0 $X=776240 $Y=316020
X687 2670 2 2682 1 INV1S $T=786160 306320 0 0 $X=786160 $Y=305940
X688 2666 2 2683 1 INV1S $T=788640 316400 1 0 $X=788640 $Y=310980
X689 2679 2 2681 1 INV1S $T=790500 235760 1 0 $X=790500 $Y=230340
X690 2687 2 2675 1 INV1S $T=790500 255920 1 0 $X=790500 $Y=250500
X691 2672 2 2692 1 INV1S $T=791740 296240 0 180 $X=790500 $Y=290820
X692 2676 2 2702 1 INV1S $T=794220 316400 0 0 $X=794220 $Y=316020
X693 2699 2 2710 1 INV1S $T=796080 266000 1 0 $X=796080 $Y=260580
X694 577 2 2704 1 INV1S $T=797320 286160 1 180 $X=796080 $Y=285780
X695 2701 2 2690 1 INV1S $T=796700 235760 0 0 $X=796700 $Y=235380
X696 2674 2 583 1 INV1S $T=796700 316400 0 0 $X=796700 $Y=316020
X697 2688 2 2714 1 INV1S $T=797320 286160 1 0 $X=797320 $Y=280740
X698 2708 2 2718 1 INV1S $T=799180 276080 0 0 $X=799180 $Y=275700
X699 2712 2 2719 1 INV1S $T=801040 235760 1 0 $X=801040 $Y=230340
X700 2721 2 2729 1 INV1S $T=803520 255920 0 0 $X=803520 $Y=255540
X701 582 2 2688 1 INV1S $T=803520 296240 1 0 $X=803520 $Y=290820
X702 2725 2 2731 1 INV1S $T=805380 255920 1 0 $X=805380 $Y=250500
X703 2723 2 2734 1 INV1S $T=807860 245840 1 0 $X=807860 $Y=240420
X704 2744 2 600 1 INV1S $T=818400 245840 0 180 $X=817160 $Y=240420
X705 2774 2 2769 1 INV1S $T=823980 245840 0 180 $X=822740 $Y=240420
X706 602 2 2778 1 INV1S $T=825840 245840 1 0 $X=825840 $Y=240420
X707 2799 2 2821 1 INV1S $T=827700 235760 0 0 $X=827700 $Y=235380
X708 2827 2 2834 1 INV1S $T=833280 245840 0 0 $X=833280 $Y=245460
X709 2838 2 2797 1 INV1S $T=835760 225680 0 180 $X=834520 $Y=220260
X710 609 2 635 1 INV1S $T=836380 255920 1 0 $X=836380 $Y=250500
X711 630 2 2852 1 INV1S $T=837000 255920 0 0 $X=837000 $Y=255540
X712 636 2 621 1 INV1S $T=837620 296240 0 0 $X=837620 $Y=295860
X713 646 2 2862 1 INV1S $T=841340 235760 0 180 $X=840100 $Y=230340
X714 2845 2 2883 1 INV1S $T=842580 266000 0 0 $X=842580 $Y=265620
X715 654 2 2759 1 INV1S $T=846300 245840 0 180 $X=845060 $Y=240420
X716 2788 2 2903 1 INV1S $T=846920 276080 1 0 $X=846920 $Y=270660
X717 614 2 2914 1 INV1S $T=846920 316400 1 0 $X=846920 $Y=310980
X718 672 2 2848 1 INV1S $T=853120 225680 1 180 $X=851880 $Y=225300
X719 661 2 2819 1 INV1S $T=854980 266000 0 180 $X=853740 $Y=260580
X720 2835 2 2924 1 INV1S $T=854360 245840 0 0 $X=854360 $Y=245460
X721 601 2 666 1 INV1S $T=858700 266000 1 0 $X=858700 $Y=260580
X722 2922 2 2959 1 INV1S $T=859940 266000 0 0 $X=859940 $Y=265620
X723 619 2 2943 1 INV1S $T=863660 255920 1 180 $X=862420 $Y=255540
X724 2896 2 2978 1 INV1S $T=865520 245840 1 0 $X=865520 $Y=240420
X725 653 2 2979 1 INV1S $T=865520 245840 0 0 $X=865520 $Y=245460
X726 690 2 2791 1 INV1S $T=867380 255920 0 180 $X=866140 $Y=250500
X727 692 2 2853 1 INV1S $T=869240 255920 0 180 $X=868000 $Y=250500
X728 2808 2 2997 1 INV1S $T=869240 266000 0 0 $X=869240 $Y=265620
X729 694 2 2889 1 INV1S $T=871100 255920 1 0 $X=871100 $Y=250500
X730 701 2 2865 1 INV1S $T=872340 245840 1 0 $X=872340 $Y=240420
X731 688 2 2989 1 INV1S $T=873580 225680 0 0 $X=873580 $Y=225300
X732 3013 2 2994 1 INV1S $T=876680 225680 1 180 $X=875440 $Y=225300
X733 710 2 2836 1 INV1S $T=878540 245840 0 180 $X=877300 $Y=240420
X734 2814 2 2964 1 INV1S $T=877300 276080 1 0 $X=877300 $Y=270660
X735 2946 2 3023 1 INV1S $T=880400 255920 1 180 $X=879160 $Y=255540
X736 3007 2 2854 1 INV1S $T=879780 235760 1 0 $X=879780 $Y=230340
X737 2775 2 707 1 INV1S $T=881020 286160 1 0 $X=881020 $Y=280740
X738 3022 2 3036 1 INV1S $T=883500 255920 0 180 $X=882260 $Y=250500
X739 3037 2 2972 1 INV1S $T=884740 286160 0 180 $X=883500 $Y=280740
X740 674 2 3050 1 INV1S $T=884120 316400 0 0 $X=884120 $Y=316020
X741 3064 2 2948 1 INV1S $T=887220 296240 1 180 $X=885980 $Y=295860
X742 714 2 3041 1 INV1S $T=887840 276080 1 0 $X=887840 $Y=270660
X743 671 2 2880 1 INV1S $T=890940 235760 0 180 $X=889700 $Y=230340
X744 2893 2 3048 1 INV1S $T=889700 235760 0 0 $X=889700 $Y=235380
X745 717 2 663 1 INV1S $T=894040 316400 0 180 $X=892800 $Y=310980
X746 723 2 3067 1 INV1S $T=895900 316400 1 180 $X=894660 $Y=316020
X747 638 2 3105 1 INV1S $T=896520 296240 1 0 $X=896520 $Y=290820
X748 637 2 3101 1 INV1S $T=903340 316400 0 180 $X=902100 $Y=310980
X749 3070 2 3116 1 INV1S $T=907680 255920 0 180 $X=906440 $Y=250500
X750 3125 2 3076 1 INV1S $T=908920 225680 0 180 $X=907680 $Y=220260
X751 611 2 2820 1 INV1S $T=908920 235760 1 0 $X=908920 $Y=230340
X752 2976 2 3111 1 INV1S $T=908920 276080 0 0 $X=908920 $Y=275700
X753 3017 2 3126 1 INV1S $T=910780 276080 0 0 $X=910780 $Y=275700
X754 2983 2 3134 1 INV1S $T=917600 245840 0 180 $X=916360 $Y=240420
X755 3063 2 2884 1 INV1S $T=918220 245840 1 180 $X=916980 $Y=245460
X756 2850 2 3174 1 INV1S $T=917600 276080 1 0 $X=917600 $Y=270660
X757 693 2 648 1 INV1S $T=917600 306320 0 0 $X=917600 $Y=305940
X758 2892 2 2908 1 INV1S $T=920700 276080 1 180 $X=919460 $Y=275700
X759 748 2 684 1 INV1S $T=921940 316400 1 180 $X=920700 $Y=316020
X760 3152 2 3185 1 INV1S $T=925660 235760 1 180 $X=924420 $Y=235380
X761 3148 2 3084 1 INV1S $T=926280 245840 1 180 $X=925040 $Y=245460
X762 687 2 702 1 INV1S $T=925040 316400 1 0 $X=925040 $Y=310980
X763 640 2 3034 1 INV1S $T=928760 255920 0 0 $X=928760 $Y=255540
X764 2987 2 3142 1 INV1S $T=933100 276080 0 180 $X=931860 $Y=270660
X765 3205 2 743 1 INV1S $T=933100 306320 1 180 $X=931860 $Y=305940
X766 3227 2 3000 1 INV1S $T=934960 276080 0 180 $X=933720 $Y=270660
X767 680 2 756 1 INV1S $T=934340 316400 0 0 $X=934340 $Y=316020
X768 2844 2 3151 1 INV1S $T=936820 286160 1 0 $X=936820 $Y=280740
X769 2843 2 724 1 INV1S $T=938680 316400 1 0 $X=938680 $Y=310980
X770 2986 2 3056 1 INV1S $T=940540 255920 1 0 $X=940540 $Y=250500
X771 708 2 3200 1 INV1S $T=940540 255920 0 0 $X=940540 $Y=255540
X772 3040 2 3027 1 INV1S $T=948600 255920 0 180 $X=947360 $Y=250500
X773 608 2 3149 1 INV1S $T=947360 255920 0 0 $X=947360 $Y=255540
X774 706 2 2855 1 INV1S $T=952320 225680 0 0 $X=952320 $Y=225300
X775 618 2 2939 1 INV1S $T=956660 235760 0 180 $X=955420 $Y=230340
X776 3222 2 3289 1 INV1S $T=957900 255920 0 0 $X=957900 $Y=255540
X777 669 2 3224 1 INV1S $T=961620 245840 1 180 $X=960380 $Y=245460
X778 3215 2 758 1 INV1S $T=962240 266000 0 0 $X=962240 $Y=265620
X779 3112 2 3089 1 INV1S $T=962860 245840 0 0 $X=962860 $Y=245460
X780 685 2 2793 1 INV1S $T=965340 245840 1 0 $X=965340 $Y=240420
X781 3304 2 3308 1 INV1S $T=966580 266000 0 0 $X=966580 $Y=265620
X782 3307 2 3199 1 INV1S $T=967200 255920 1 0 $X=967200 $Y=250500
X783 3122 2 3312 1 INV1S $T=972780 276080 0 0 $X=972780 $Y=275700
X784 3107 2 3313 1 INV1S $T=974020 266000 1 0 $X=974020 $Y=260580
X785 3230 2 3306 1 INV1S $T=976500 266000 1 0 $X=976500 $Y=260580
X786 1349 1 1355 1357 2 ND2P $T=358980 245840 0 0 $X=358980 $Y=245460
X787 1378 1 1357 1379 2 ND2P $T=366420 245840 0 0 $X=366420 $Y=245460
X788 1377 1 1348 1398 2 ND2P $T=371380 276080 1 180 $X=367660 $Y=275700
X789 1401 1 1379 1404 2 ND2P $T=372620 266000 1 0 $X=372620 $Y=260580
X790 1395 1 1379 1415 2 ND2P $T=376340 266000 1 0 $X=376340 $Y=260580
X791 1387 1 1374 1348 2 ND2P $T=376340 276080 0 0 $X=376340 $Y=275700
X792 1427 1 1434 1437 2 ND2P $T=384400 296240 1 0 $X=384400 $Y=290820
X793 1440 1 1434 1430 2 ND2P $T=387500 296240 0 0 $X=387500 $Y=295860
X794 1422 1 1426 1457 2 ND2P $T=392460 266000 1 180 $X=388740 $Y=265620
X795 1560 1 1562 1550 2 ND2P $T=429040 296240 1 0 $X=429040 $Y=290820
X796 1559 1 1566 1571 2 ND2P $T=430280 266000 0 0 $X=430280 $Y=265620
X797 1669 1 1670 1584 2 ND2P $T=469340 266000 0 0 $X=469340 $Y=265620
X798 1686 1 1687 1689 2 ND2P $T=476780 266000 1 0 $X=476780 $Y=260580
X799 2384 1 2379 2362 2 ND2P $T=673320 245840 1 0 $X=673320 $Y=240420
X800 2398 1 2379 2364 2 ND2P $T=677040 245840 1 0 $X=677040 $Y=240420
X801 2461 1 2473 2483 2 ND2P $T=701840 276080 0 0 $X=701840 $Y=275700
X802 2478 1 510 2461 2 ND2P $T=705560 296240 0 0 $X=705560 $Y=295860
X803 2466 1 2495 2471 2 ND2P $T=709900 245840 1 0 $X=709900 $Y=240420
X804 2501 1 2495 2487 2 ND2P $T=714240 245840 0 0 $X=714240 $Y=245460
X805 2549 1 2550 2552 2 ND2P $T=738420 276080 1 0 $X=738420 $Y=270660
X806 575 1 574 2674 2 ND2P $T=789260 316400 1 180 $X=785540 $Y=316020
X807 575 1 578 2676 2 ND2P $T=789880 316400 0 0 $X=789880 $Y=316020
X808 2688 1 2704 2671 2 ND2P $T=793600 286160 1 0 $X=793600 $Y=280740
X809 1377 1364 1348 2 1 1342 XOR3 $T=367040 286160 0 180 $X=355880 $Y=280740
X810 1340 1343 1341 2 1 227 XOR3 $T=357120 316400 0 0 $X=357120 $Y=316020
X811 1351 1356 1353 2 1 1346 XOR3 $T=363320 296240 0 0 $X=363320 $Y=295860
X812 1372 1385 1376 2 1 1351 XOR3 $T=370760 306320 1 0 $X=370760 $Y=300900
X813 1395 1401 1379 2 1 1345 XOR3 $T=382540 255920 0 180 $X=371380 $Y=250500
X814 1383 226 1381 2 1 1340 XOR3 $T=371380 316400 1 0 $X=371380 $Y=310980
X815 1400 1421 1410 2 1 1350 XOR3 $T=385640 235760 0 180 $X=374480 $Y=230340
X816 233 1403 1399 2 1 1343 XOR3 $T=375720 316400 0 0 $X=375720 $Y=316020
X817 1406 1412 1408 2 1 1356 XOR3 $T=378820 306320 0 0 $X=378820 $Y=305940
X818 1424 1428 1431 2 1 1421 XOR3 $T=383780 255920 0 0 $X=383780 $Y=255540
X819 1446 1454 1458 2 1 1478 XOR3 $T=389980 235760 0 0 $X=389980 $Y=235380
X820 1441 1444 1450 2 1 1446 XOR3 $T=393700 245840 0 0 $X=393700 $Y=245460
X821 1493 1498 1499 2 1 1503 XOR3 $T=406720 255920 1 0 $X=406720 $Y=250500
X822 1537 1539 1546 2 1 1542 XOR3 $T=422220 255920 0 0 $X=422220 $Y=255540
X823 1540 1542 1555 2 1 1561 XOR3 $T=423460 235760 1 0 $X=423460 $Y=230340
X824 1544 1548 1551 2 1 1540 XOR3 $T=425320 245840 0 0 $X=425320 $Y=245460
X825 1591 1596 1571 2 1 1631 XOR3 $T=442060 266000 0 0 $X=442060 $Y=265620
X826 1602 1605 1600 2 1 1637 XOR3 $T=448880 235760 1 0 $X=448880 $Y=230340
X827 1647 1631 1653 2 1 1675 XOR3 $T=468100 235760 1 0 $X=468100 $Y=230340
X828 1679 1676 1659 2 1 1647 XOR3 $T=483600 245840 1 0 $X=483600 $Y=240420
X829 2337 2339 2343 2 1 2331 XOR3 $T=651620 306320 1 0 $X=651620 $Y=300900
X830 2353 2351 2341 2 1 2338 XOR3 $T=663400 245840 0 180 $X=652240 $Y=240420
X831 2355 2359 2382 2 1 2337 XOR3 $T=659680 306320 0 0 $X=659680 $Y=305940
X832 2344 2346 2345 2 1 2336 XOR3 $T=661540 286160 1 0 $X=661540 $Y=280740
X833 2347 2354 2348 2 1 2333 XOR3 $T=662780 296240 1 0 $X=662780 $Y=290820
X834 2380 2374 2385 2 1 2347 XOR3 $T=668360 306320 1 0 $X=668360 $Y=300900
X835 506 2371 2350 2 1 512 XOR3 $T=668980 316400 0 0 $X=668980 $Y=316020
X836 2363 2391 2387 2 1 2373 XOR3 $T=682000 266000 0 180 $X=670840 $Y=260580
X837 2378 2375 2381 2 1 2384 XOR3 $T=673320 245840 0 0 $X=673320 $Y=245460
X838 2388 2377 2386 2 1 2344 XOR3 $T=676420 286160 0 0 $X=676420 $Y=285780
X839 2399 2405 2402 2 1 2392 XOR3 $T=685100 225680 0 0 $X=685100 $Y=225300
X840 2468 2472 2475 2 1 2502 XOR3 $T=702460 266000 0 0 $X=702460 $Y=265620
X841 2477 2483 2481 2 1 2517 XOR3 $T=709280 255920 0 0 $X=709280 $Y=255540
X842 2491 2453 2492 2 1 2424 XOR3 $T=722300 225680 0 180 $X=711140 $Y=220260
X843 2513 2514 2516 2 1 2544 XOR3 $T=719200 225680 0 0 $X=719200 $Y=225300
X844 2502 2521 2522 2 1 2542 XOR3 $T=721680 255920 0 0 $X=721680 $Y=255540
X845 2490 2484 2485 2 1 2525 XOR3 $T=722920 276080 0 0 $X=722920 $Y=275700
X846 2517 2524 2531 2 1 2548 XOR3 $T=724160 245840 1 0 $X=724160 $Y=240420
X847 2530 2534 2537 2 1 2354 XOR3 $T=725400 306320 1 0 $X=725400 $Y=300900
X848 2525 2523 2529 2 1 2546 XOR3 $T=728500 266000 0 0 $X=728500 $Y=265620
X849 2532 2539 2535 2 1 2346 XOR3 $T=730980 286160 0 0 $X=730980 $Y=285780
X850 2528 2526 2533 2 1 2339 XOR3 $T=730980 296240 0 0 $X=730980 $Y=295860
X851 2536 2540 2538 2 1 2371 XOR3 $T=731600 316400 1 0 $X=731600 $Y=310980
X852 2555 2549 2550 2 1 2372 XOR3 $T=749580 266000 0 180 $X=738420 $Y=260580
X853 2641 2646 2650 2 1 2523 XOR3 $T=771280 266000 1 0 $X=771280 $Y=260580
X854 2640 2637 2647 2 1 2521 XOR3 $T=777480 255920 0 0 $X=777480 $Y=255540
X855 1347 1345 1352 2 1 XOR2HS $T=355880 255920 1 0 $X=355880 $Y=250500
X856 1329 1326 1335 2 1 XOR2HS $T=355880 276080 1 0 $X=355880 $Y=270660
X857 1352 1361 1338 2 1 XOR2HS $T=365800 245840 0 180 $X=360220 $Y=240420
X858 1425 1422 1417 2 1 XOR2HS $T=385020 266000 1 180 $X=379440 $Y=265620
X859 1426 1417 1347 2 1 XOR2HS $T=385640 266000 0 180 $X=380060 $Y=260580
X860 1434 1438 1377 2 1 XOR2HS $T=388740 286160 1 180 $X=383160 $Y=285780
X861 1427 1440 1438 2 1 XOR2HS $T=388120 296240 1 0 $X=388120 $Y=290820
X862 1448 1432 1326 2 1 XOR2HS $T=389360 276080 0 0 $X=389360 $Y=275700
X863 1463 1465 1435 2 1 XOR2HS $T=396180 316400 0 180 $X=390600 $Y=310980
X864 1472 1471 1452 2 1 XOR2HS $T=398660 296240 1 180 $X=393080 $Y=295860
X865 1477 1475 1449 2 1 XOR2HS $T=400520 286160 1 180 $X=394940 $Y=285780
X866 1429 1436 1448 2 1 XOR2HS $T=396800 276080 0 0 $X=396800 $Y=275700
X867 1474 1462 1473 2 1 XOR2HS $T=403000 276080 0 180 $X=397420 $Y=270660
X868 1469 1470 1481 2 1 XOR2HS $T=398040 266000 1 0 $X=398040 $Y=260580
X869 1468 1481 1454 2 1 XOR2HS $T=403620 255920 0 0 $X=403620 $Y=255540
X870 1488 1445 1467 2 1 XOR2HS $T=403620 276080 1 0 $X=403620 $Y=270660
X871 1483 1494 1491 2 1 XOR2HS $T=405480 286160 0 0 $X=405480 $Y=285780
X872 1511 1505 1509 2 1 XOR2HS $T=415400 276080 0 180 $X=409820 $Y=270660
X873 1523 1497 1515 2 1 XOR2HS $T=417260 235760 0 180 $X=411680 $Y=230340
X874 1500 1503 1523 2 1 XOR2HS $T=411680 245840 1 0 $X=411680 $Y=240420
X875 1512 1507 1524 2 1 XOR2HS $T=412920 266000 1 0 $X=412920 $Y=260580
X876 1508 1519 1525 2 1 XOR2HS $T=412920 296240 1 0 $X=412920 $Y=290820
X877 1506 1524 1500 2 1 XOR2HS $T=419120 255920 1 180 $X=413540 $Y=255540
X878 1557 1556 1543 2 1 XOR2HS $T=429660 306320 1 180 $X=424080 $Y=305940
X879 1565 1564 1464 2 1 XOR2HS $T=432760 276080 0 180 $X=427180 $Y=270660
X880 260 1535 1563 2 1 XOR2HS $T=432760 276080 1 0 $X=432760 $Y=270660
X881 1573 1568 1554 2 1 XOR2HS $T=438340 316400 0 180 $X=432760 $Y=310980
X882 1562 1560 1549 2 1 XOR2HS $T=434000 286160 0 0 $X=434000 $Y=285780
X883 1599 1597 1588 2 1 XOR2HS $T=445160 296240 0 180 $X=439580 $Y=290820
X884 1583 1598 1602 2 1 XOR2HS $T=442680 235760 0 0 $X=442680 $Y=235380
X885 1584 1590 1598 2 1 XOR2HS $T=449500 245840 1 180 $X=443920 $Y=245460
X886 1606 1604 1580 2 1 XOR2HS $T=446400 276080 0 0 $X=446400 $Y=275700
X887 1601 1603 1577 2 1 XOR2HS $T=448260 286160 0 0 $X=448260 $Y=285780
X888 1545 1608 1620 2 1 XOR2HS $T=449500 255920 1 0 $X=449500 $Y=250500
X889 1595 1620 1605 2 1 XOR2HS $T=450740 245840 0 0 $X=450740 $Y=245460
X890 1609 1587 1630 2 1 XOR2HS $T=452600 255920 0 0 $X=452600 $Y=255540
X891 1622 1626 1624 2 1 XOR2HS $T=455080 276080 0 0 $X=455080 $Y=275700
X892 1643 1641 1632 2 1 XOR2HS $T=462520 245840 1 180 $X=456940 $Y=245460
X893 1614 1618 1640 2 1 XOR2HS $T=457560 296240 1 0 $X=457560 $Y=290820
X894 1650 1646 1635 2 1 XOR2HS $T=465620 266000 1 180 $X=460040 $Y=265620
X895 1663 1661 1633 2 1 XOR2HS $T=468720 276080 0 180 $X=463140 $Y=270660
X896 1665 1662 1649 2 1 XOR2HS $T=468720 306320 0 180 $X=463140 $Y=300900
X897 1667 1664 1648 2 1 XOR2HS $T=469340 296240 0 180 $X=463760 $Y=290820
X898 1677 1674 1654 2 1 XOR2HS $T=473680 296240 1 180 $X=468100 $Y=295860
X899 290 289 1652 2 1 XOR2HS $T=474300 316400 1 180 $X=468720 $Y=316020
X900 1673 1671 1660 2 1 XOR2HS $T=471200 276080 0 0 $X=471200 $Y=275700
X901 1686 1687 1681 2 1 XOR2HS $T=479260 266000 1 180 $X=473680 $Y=265620
X902 1692 1684 1672 2 1 XOR2HS $T=481740 245840 1 180 $X=476160 $Y=245460
X903 1691 1698 1706 2 1 XOR2HS $T=481740 225680 0 0 $X=481740 $Y=225300
X904 1706 1630 1716 2 1 XOR2HS $T=490420 235760 1 0 $X=490420 $Y=230340
X905 2367 2365 2356 2 1 XOR2HS $T=664640 266000 0 180 $X=659060 $Y=260580
X906 2372 2373 2367 2 1 XOR2HS $T=671460 255920 1 180 $X=665880 $Y=255540
X907 2411 2409 2400 2 1 XOR2HS $T=684480 276080 1 180 $X=678900 $Y=275700
X908 2417 2414 2390 2 1 XOR2HS $T=686960 306320 1 180 $X=681380 $Y=305940
X909 2429 2423 2403 2 1 XOR2HS $T=690060 255920 1 180 $X=684480 $Y=255540
X910 2430 2427 2401 2 1 XOR2HS $T=690060 286160 0 180 $X=684480 $Y=280740
X911 2416 2419 2404 2 1 XOR2HS $T=685100 296240 0 0 $X=685100 $Y=295860
X912 2445 2436 2413 2 1 XOR2HS $T=694400 316400 0 180 $X=688820 $Y=310980
X913 2446 2442 2399 2 1 XOR2HS $T=695020 235760 1 180 $X=689440 $Y=235380
X914 2422 2425 2442 2 1 XOR2HS $T=690680 245840 1 0 $X=690680 $Y=240420
X915 2443 2434 2439 2 1 XOR2HS $T=696880 255920 1 180 $X=691300 $Y=255540
X916 2440 2444 2451 2 1 XOR2HS $T=696260 266000 0 0 $X=696260 $Y=265620
X917 2450 2469 2478 2 1 XOR2HS $T=701220 286160 0 0 $X=701220 $Y=285780
X918 2458 2467 2488 2 1 XOR2HS $T=704940 296240 1 0 $X=704940 $Y=290820
X919 2466 2501 2505 2 1 XOR2HS $T=712380 235760 0 0 $X=712380 $Y=235380
X920 2495 2505 2513 2 1 XOR2HS $T=718580 235760 0 0 $X=718580 $Y=235380
X921 2506 2508 2527 2 1 XOR2HS $T=721680 286160 1 0 $X=721680 $Y=280740
X922 2527 2541 2503 2 1 XOR2HS $T=734080 286160 0 180 $X=728500 $Y=280740
X923 2547 2545 2543 2 1 XOR2HS $T=739040 296240 0 180 $X=733460 $Y=290820
X924 2558 2554 2398 2 1 XOR2HS $T=744000 235760 0 180 $X=738420 $Y=230340
X925 2571 2565 2554 2 1 XOR2HS $T=750820 225680 1 180 $X=745240 $Y=225300
X926 2574 2576 2564 2 1 XOR2HS $T=751440 296240 1 180 $X=745860 $Y=295860
X927 2581 2577 2562 2 1 XOR2HS $T=751440 316400 0 180 $X=745860 $Y=310980
X928 547 546 2557 2 1 XOR2HS $T=752680 316400 1 180 $X=747100 $Y=316020
X929 2570 2566 2572 2 1 XOR2HS $T=753300 276080 1 180 $X=747720 $Y=275700
X930 2590 2589 2583 2 1 XOR2HS $T=756400 245840 1 180 $X=750820 $Y=245460
X931 2585 2587 2580 2 1 XOR2HS $T=752680 266000 1 0 $X=752680 $Y=260580
X932 2601 2595 2603 2 1 XOR2HS $T=763220 245840 1 180 $X=757640 $Y=245460
X933 2593 2591 2605 2 1 XOR2HS $T=757640 276080 0 0 $X=757640 $Y=275700
X934 2618 2623 2633 2 1 XOR2HS $T=763220 235760 0 0 $X=763220 $Y=235380
X935 2627 2631 2613 2 1 XOR2HS $T=765700 266000 1 0 $X=765700 $Y=260580
X936 2626 2611 2642 2 1 XOR2HS $T=768180 225680 0 0 $X=768180 $Y=225300
X937 2622 2642 2491 2 1 XOR2HS $T=774380 235760 0 180 $X=768800 $Y=230340
X938 2653 2659 2541 2 1 XOR2HS $T=778720 276080 1 180 $X=773140 $Y=275700
X939 2645 2638 2658 2 1 XOR2HS $T=773140 296240 1 0 $X=773140 $Y=290820
X940 2652 2664 2514 2 1 XOR2HS $T=781820 245840 0 180 $X=776240 $Y=240420
X941 2662 2667 2663 2 1 XOR2HS $T=784300 276080 0 180 $X=778720 $Y=270660
X942 2654 2657 2664 2 1 XOR2HS $T=783060 245840 1 0 $X=783060 $Y=240420
X943 2682 2677 2668 2 1 XOR2HS $T=788640 296240 1 180 $X=783060 $Y=295860
X944 2683 2678 2665 2 1 XOR2HS $T=788640 316400 0 180 $X=783060 $Y=310980
X945 2684 2681 2673 2 1 XOR2HS $T=789260 225680 1 180 $X=783680 $Y=225300
X946 2690 2686 2698 2 1 XOR2HS $T=789880 245840 1 0 $X=789880 $Y=240420
X947 2692 2693 2669 2 1 XOR2HS $T=789880 286160 0 0 $X=789880 $Y=285780
X948 2719 2703 2709 2 1 XOR2HS $T=802280 225680 1 180 $X=796700 $Y=225300
X949 2710 2715 2697 2 1 XOR2HS $T=798560 266000 1 0 $X=798560 $Y=260580
X950 2718 2716 2705 2 1 XOR2HS $T=800420 276080 1 0 $X=800420 $Y=270660
X951 596 580 593 2 1 XOR2HS $T=809100 316400 1 180 $X=803520 $Y=316020
X952 2731 2733 2724 2 1 XOR2HS $T=808480 245840 0 0 $X=808480 $Y=245460
X953 2729 2728 2720 2 1 XOR2HS $T=812200 255920 0 0 $X=812200 $Y=255540
X954 1341 1340 1343 222 1 2 MAO222P $T=351540 316400 0 0 $X=351540 $Y=316020
X955 1353 1351 1356 1341 1 2 MAO222P $T=357740 296240 0 0 $X=357740 $Y=295860
X956 1399 233 1403 234 1 2 MAO222P $T=370140 316400 0 0 $X=370140 $Y=316020
X957 1408 1406 1412 1399 1 2 MAO222P $T=373240 306320 0 0 $X=373240 $Y=305940
X958 1431 1424 1428 1426 1 2 MAO222P $T=383780 255920 1 0 $X=383780 $Y=250500
X959 1432 1429 1436 1434 1 2 MAO222P $T=383780 276080 0 0 $X=383780 $Y=275700
X960 1444 1441 1450 1349 1 2 MAO222P $T=387500 245840 0 0 $X=387500 $Y=245460
X961 1458 1446 1454 1410 1 2 MAO222P $T=389980 245840 1 0 $X=389980 $Y=240420
X962 1499 1493 1498 1450 1 2 MAO222P $T=406720 245840 0 0 $X=406720 $Y=245460
X963 1571 1591 1596 1595 1 2 MAO222P $T=441440 266000 1 0 $X=441440 $Y=260580
X964 2343 2337 2339 2350 1 2 MAO222P $T=654100 306320 0 0 $X=654100 $Y=305940
X965 2348 2347 2354 2343 1 2 MAO222P $T=656580 296240 1 0 $X=656580 $Y=290820
X966 2350 506 2371 508 1 2 MAO222P $T=662780 316400 0 0 $X=662780 $Y=316020
X967 2381 2378 2375 2383 1 2 MAO222P $T=667120 245840 0 0 $X=667120 $Y=245460
X968 2402 2399 2405 2379 1 2 MAO222P $T=678900 225680 0 0 $X=678900 $Y=225300
X969 2475 2468 2472 2481 1 2 MAO222P $T=702460 266000 1 0 $X=702460 $Y=260580
X970 2481 2477 2483 2495 1 2 MAO222P $T=703700 245840 0 0 $X=703700 $Y=245460
X971 2516 2513 2514 2492 1 2 MAO222P $T=719200 235760 1 0 $X=719200 $Y=230340
X972 2533 2528 2526 2538 1 2 MAO222P $T=724160 306320 0 0 $X=724160 $Y=305940
X973 2535 2532 2539 2537 1 2 MAO222P $T=724780 286160 0 0 $X=724780 $Y=285780
X974 541 539 540 542 1 2 MAO222P $T=724780 316400 0 0 $X=724780 $Y=316020
X975 2537 2530 2534 2533 1 2 MAO222P $T=725400 296240 0 0 $X=725400 $Y=295860
X976 2538 2536 2540 541 1 2 MAO222P $T=725400 316400 1 0 $X=725400 $Y=310980
X977 2448 2415 2421 2550 1 2 MAO222P $T=740900 266000 0 0 $X=740900 $Y=265620
X978 2643 2619 2648 2652 1 2 MAO222P $T=770040 245840 0 0 $X=770040 $Y=245460
X979 1373 1331 1366 1360 1 2 ND3P $T=366420 255920 0 0 $X=366420 $Y=255540
X980 1404 1393 1415 1396 1 2 ND3P $T=376340 266000 1 180 $X=371380 $Y=265620
X981 1402 1353 1398 1409 1 2 ND3P $T=371380 276080 0 0 $X=371380 $Y=275700
X982 1414 1361 1419 1411 1 2 ND3P $T=380680 245840 0 180 $X=375720 $Y=240420
X983 1430 1408 1437 1423 1 2 ND3P $T=387500 296240 1 180 $X=382540 $Y=295860
X984 1457 1432 1447 1442 1 2 ND3P $T=393700 276080 0 180 $X=388740 $Y=270660
X985 1461 1431 1460 1456 1 2 ND3P $T=395560 266000 0 180 $X=390600 $Y=260580
X986 1496 1468 1502 1490 1 2 ND3P $T=409200 266000 0 180 $X=404240 $Y=260580
X987 1536 1506 1541 1532 1 2 ND3P $T=424700 266000 0 180 $X=419740 $Y=260580
X988 1538 1497 1552 1534 1 2 ND3P $T=425940 245840 0 180 $X=420980 $Y=240420
X989 1582 1546 1593 1574 1 2 ND3P $T=442060 255920 1 180 $X=437100 $Y=255540
X990 1617 1583 1621 1623 1 2 ND3P $T=449500 245840 1 0 $X=449500 $Y=240420
X991 2352 2365 2349 2358 1 2 ND3P $T=657200 255920 0 0 $X=657200 $Y=255540
X992 2364 2341 2362 2360 1 2 ND3P $T=672700 235760 1 180 $X=667740 $Y=235380
X993 2395 2386 2393 2389 1 2 ND3P $T=673320 286160 1 0 $X=673320 $Y=280740
X994 2428 2381 2438 2420 1 2 ND3P $T=691300 245840 1 180 $X=686340 $Y=245460
X995 2480 2457 2487 2471 1 2 ND3P $T=708040 245840 0 180 $X=703080 $Y=240420
X996 2551 2535 2552 2556 1 2 ND3P $T=739040 286160 1 0 $X=739040 $Y=280740
X997 2560 2448 2567 2553 1 2 ND3P $T=745860 245840 1 180 $X=740900 $Y=245460
X998 2610 2588 2620 2606 1 2 ND3P $T=763840 235760 0 180 $X=758880 $Y=230340
X999 2660 2622 2661 2656 1 2 ND3P $T=780580 225680 1 180 $X=775620 $Y=225300
X1000 956 985 944 1 2 ND2 $T=243660 255920 0 180 $X=241800 $Y=250500
X1001 82 1008 78 1 2 ND2 $T=249240 316400 0 180 $X=247380 $Y=310980
X1002 37 85 92 1 2 ND2 $T=251720 316400 0 0 $X=251720 $Y=316020
X1003 1051 874 98 1 2 ND2 $T=257300 296240 1 0 $X=257300 $Y=290820
X1004 44 1080 42 1 2 ND2 $T=261020 306320 1 180 $X=259160 $Y=305940
X1005 1017 1068 956 1 2 ND2 $T=262880 235760 1 180 $X=261020 $Y=235380
X1006 1081 1074 996 1 2 ND2 $T=263500 296240 1 180 $X=261640 $Y=295860
X1007 1081 104 956 1 2 ND2 $T=264120 296240 0 180 $X=262260 $Y=290820
X1008 34 1003 1102 1 2 ND2 $T=267840 286160 0 0 $X=267840 $Y=285780
X1009 1106 938 1111 1 2 ND2 $T=269700 286160 1 0 $X=269700 $Y=280740
X1010 1109 1112 1119 1 2 ND2 $T=270940 225680 0 0 $X=270940 $Y=225300
X1011 1117 1110 113 1 2 ND2 $T=272800 255920 0 0 $X=272800 $Y=255540
X1012 1106 1115 1054 1 2 ND2 $T=272800 276080 0 0 $X=272800 $Y=275700
X1013 1102 1122 1131 1 2 ND2 $T=275900 276080 1 0 $X=275900 $Y=270660
X1014 133 134 68 1 2 ND2 $T=277140 316400 0 0 $X=277140 $Y=316020
X1015 1092 1136 1131 1 2 ND2 $T=277760 255920 1 0 $X=277760 $Y=250500
X1016 1131 135 42 1 2 ND2 $T=277760 306320 0 0 $X=277760 $Y=305940
X1017 1146 1145 96 1 2 ND2 $T=281480 306320 1 0 $X=281480 $Y=300900
X1018 1143 1154 986 1 2 ND2 $T=285200 276080 0 180 $X=283340 $Y=270660
X1019 1034 1178 1075 1 2 ND2 $T=293260 235760 1 180 $X=291400 $Y=235380
X1020 1189 906 1075 1 2 ND2 $T=294500 245840 0 0 $X=294500 $Y=245460
X1021 1189 1157 909 1 2 ND2 $T=297600 245840 0 0 $X=297600 $Y=245460
X1022 1209 165 944 1 2 ND2 $T=300080 266000 0 180 $X=298220 $Y=260580
X1023 1237 914 1111 1 2 ND2 $T=309380 245840 1 0 $X=309380 $Y=240420
X1024 1090 1156 1111 1 2 ND2 $T=310000 235760 0 0 $X=310000 $Y=235380
X1025 1243 1231 1049 1 2 ND2 $T=311860 316400 0 180 $X=310000 $Y=310980
X1026 1237 1218 1065 1 2 ND2 $T=313720 235760 1 0 $X=313720 $Y=230340
X1027 1248 957 68 1 2 ND2 $T=315580 235760 1 180 $X=313720 $Y=235380
X1028 1265 178 1254 1 2 ND2 $T=318680 306320 1 180 $X=316820 $Y=305940
X1029 14 1262 1237 1 2 ND2 $T=320540 235760 1 0 $X=320540 $Y=230340
X1030 1174 1269 1065 1 2 ND2 $T=321160 235760 0 0 $X=321160 $Y=235380
X1031 191 941 194 1 2 ND2 $T=329220 316400 0 0 $X=329220 $Y=316020
X1032 1102 1223 918 1 2 ND2 $T=329840 276080 1 0 $X=329840 $Y=270660
X1033 193 942 191 1 2 ND2 $T=330460 316400 1 0 $X=330460 $Y=310980
X1034 1196 911 1271 1 2 ND2 $T=331080 276080 0 0 $X=331080 $Y=275700
X1035 194 11 197 1 2 ND2 $T=331700 316400 0 0 $X=331700 $Y=316020
X1036 1301 1273 198 1 2 ND2 $T=333560 296240 0 0 $X=333560 $Y=295860
X1037 1302 1131 198 1 2 ND2 $T=333560 306320 0 0 $X=333560 $Y=305940
X1038 1301 42 199 1 2 ND2 $T=333560 316400 0 0 $X=333560 $Y=316020
X1039 1302 113 199 1 2 ND2 $T=335420 306320 0 0 $X=335420 $Y=305940
X1040 193 917 197 1 2 ND2 $T=335420 316400 1 0 $X=335420 $Y=310980
X1041 1312 1271 198 1 2 ND2 $T=339140 296240 1 0 $X=339140 $Y=290820
X1042 1312 1177 199 1 2 ND2 $T=340380 296240 0 0 $X=340380 $Y=295860
X1043 1102 1314 1258 1 2 ND2 $T=341000 276080 0 0 $X=341000 $Y=275700
X1044 1315 1258 199 1 2 ND2 $T=342860 286160 1 180 $X=341000 $Y=285780
X1045 206 981 198 1 2 ND2 $T=342240 296240 1 0 $X=342240 $Y=290820
X1046 1315 1058 198 1 2 ND2 $T=342860 286160 1 0 $X=342860 $Y=280740
X1047 1316 212 214 1 2 ND2 $T=343480 306320 0 0 $X=343480 $Y=305940
X1048 918 1290 981 1 2 ND2 $T=344100 266000 1 0 $X=344100 $Y=260580
X1049 1318 210 218 1 2 ND2 $T=344100 316400 1 0 $X=344100 $Y=310980
X1050 1321 1323 1324 1 2 ND2 $T=345340 276080 1 0 $X=345340 $Y=270660
X1051 1322 1237 1318 1 2 ND2 $T=345340 276080 0 0 $X=345340 $Y=275700
X1052 1320 956 1325 1 2 ND2 $T=345340 286160 1 0 $X=345340 $Y=280740
X1053 1326 1321 1329 1 2 ND2 $T=347200 276080 1 0 $X=347200 $Y=270660
X1054 68 980 944 1 2 ND2 $T=347820 255920 1 0 $X=347820 $Y=250500
X1055 1323 1332 1331 1 2 ND2 $T=349060 266000 0 0 $X=349060 $Y=265620
X1056 1316 209 219 1 2 ND2 $T=349060 306320 0 0 $X=349060 $Y=305940
X1057 1332 1334 1336 1 2 ND2 $T=349680 276080 0 0 $X=349680 $Y=275700
X1058 1330 14 198 1 2 ND2 $T=349680 316400 0 0 $X=349680 $Y=316020
X1059 1075 1333 996 1 2 ND2 $T=352780 255920 0 180 $X=350920 $Y=250500
X1060 944 1056 1111 1 2 ND2 $T=350920 255920 0 0 $X=350920 $Y=255540
X1061 68 1264 1111 1 2 ND2 $T=350920 266000 0 0 $X=350920 $Y=265620
X1062 217 208 1337 1 2 ND2 $T=350920 306320 1 0 $X=350920 $Y=300900
X1063 1345 1360 1347 1 2 ND2 $T=355880 255920 0 0 $X=355880 $Y=255540
X1064 1358 1359 1355 1 2 ND2 $T=362700 245840 0 0 $X=362700 $Y=245460
X1065 1361 1373 1345 1 2 ND2 $T=363940 255920 1 0 $X=363940 $Y=250500
X1066 1363 1365 1370 1 2 ND2 $T=364560 245840 0 0 $X=364560 $Y=245460
X1067 1361 1366 1347 1 2 ND2 $T=364560 255920 0 0 $X=364560 $Y=255540
X1068 1369 1358 1370 1 2 ND2 $T=365800 245840 1 0 $X=365800 $Y=240420
X1069 1359 1386 1349 1 2 ND2 $T=367660 255920 1 0 $X=367660 $Y=250500
X1070 1386 1400 1392 1 2 ND2 $T=370140 245840 0 0 $X=370140 $Y=245460
X1071 1401 1396 1395 1 2 ND2 $T=372620 266000 0 180 $X=370760 $Y=260580
X1072 1348 1402 1364 1 2 ND2 $T=376340 286160 1 0 $X=376340 $Y=280740
X1073 1364 1409 1377 1 2 ND2 $T=380060 286160 1 0 $X=380060 $Y=280740
X1074 1410 1414 1400 1 2 ND2 $T=383160 235760 0 0 $X=383160 $Y=235380
X1075 1421 1411 1400 1 2 ND2 $T=383160 245840 1 0 $X=383160 $Y=240420
X1076 1410 1419 1421 1 2 ND2 $T=385020 245840 1 0 $X=385020 $Y=240420
X1077 1425 1442 1422 1 2 ND2 $T=388120 266000 1 180 $X=386260 $Y=265620
X1078 1468 1460 1470 1 2 ND2 $T=394940 266000 0 0 $X=394940 $Y=265620
X1079 1469 1456 1470 1 2 ND2 $T=394940 276080 1 0 $X=394940 $Y=270660
X1080 1468 1461 1469 1 2 ND2 $T=395560 266000 1 0 $X=395560 $Y=260580
X1081 1497 1487 1500 1 2 ND2 $T=407340 225680 0 0 $X=407340 $Y=225300
X1082 1497 1492 1503 1 2 ND2 $T=407340 245840 1 0 $X=407340 $Y=240420
X1083 1500 1495 1503 1 2 ND2 $T=409200 235760 0 0 $X=409200 $Y=235380
X1084 1506 1496 1507 1 2 ND2 $T=410440 255920 0 0 $X=410440 $Y=255540
X1085 1506 1502 1512 1 2 ND2 $T=410440 266000 1 0 $X=410440 $Y=260580
X1086 1507 1490 1512 1 2 ND2 $T=410440 266000 0 0 $X=410440 $Y=265620
X1087 1514 1526 1518 1 2 ND2 $T=417260 276080 1 180 $X=415400 $Y=275700
X1088 1521 1527 1526 1 2 ND2 $T=415400 286160 1 0 $X=415400 $Y=280740
X1089 1531 1504 253 1 2 ND2 $T=417260 316400 0 180 $X=415400 $Y=310980
X1090 259 1485 253 1 2 ND2 $T=420360 316400 1 0 $X=420360 $Y=310980
X1091 1522 261 1479 1 2 ND2 $T=422220 296240 0 0 $X=422220 $Y=295860
X1092 1537 1541 1539 1 2 ND2 $T=424080 266000 0 0 $X=424080 $Y=265620
X1093 1546 1532 1537 1 2 ND2 $T=425940 266000 1 0 $X=425940 $Y=260580
X1094 1555 1538 1540 1 2 ND2 $T=427800 235760 0 0 $X=427800 $Y=235380
X1095 1542 1534 1540 1 2 ND2 $T=429660 245840 0 180 $X=427800 $Y=240420
X1096 1546 1536 1539 1 2 ND2 $T=427800 266000 1 0 $X=427800 $Y=260580
X1097 1555 1552 1542 1 2 ND2 $T=430900 245840 1 0 $X=430900 $Y=240420
X1098 1563 1566 235 1 2 ND2 $T=430900 255920 1 0 $X=430900 $Y=250500
X1099 1583 1569 1590 1 2 ND2 $T=439580 235760 0 0 $X=439580 $Y=235380
X1100 1583 1578 1584 1 2 ND2 $T=439580 245840 1 0 $X=439580 $Y=240420
X1101 1584 1572 1590 1 2 ND2 $T=439580 245840 0 0 $X=439580 $Y=245460
X1102 1595 1582 1608 1 2 ND2 $T=442680 255920 1 0 $X=442680 $Y=250500
X1103 1595 1593 1545 1 2 ND2 $T=442680 255920 0 0 $X=442680 $Y=255540
X1104 1607 1619 1576 1 2 ND2 $T=445780 306320 0 0 $X=445780 $Y=305940
X1105 1608 1574 1545 1 2 ND2 $T=446400 255920 1 0 $X=446400 $Y=250500
X1106 1616 1609 1625 1 2 ND2 $T=451360 276080 1 0 $X=451360 $Y=270660
X1107 1629 1608 1642 1 2 ND2 $T=455700 286160 0 0 $X=455700 $Y=285780
X1108 232 1629 1640 1 2 ND2 $T=455700 306320 0 0 $X=455700 $Y=305940
X1109 277 1613 1636 1 2 ND2 $T=456320 306320 1 0 $X=456320 $Y=300900
X1110 1659 1621 1679 1 2 ND2 $T=466240 245840 1 0 $X=466240 $Y=240420
X1111 1681 1670 279 1 2 ND2 $T=474920 276080 0 180 $X=473060 $Y=270660
X1112 1659 1617 1676 1 2 ND2 $T=473680 245840 1 0 $X=473680 $Y=240420
X1113 1691 1696 1698 1 2 ND2 $T=480500 235760 0 0 $X=480500 $Y=235380
X1114 1704 1694 1682 1 2 ND2 $T=484840 286160 0 0 $X=484840 $Y=285780
X1115 1703 1697 1701 1 2 ND2 $T=487320 266000 0 180 $X=485460 $Y=260580
X1116 1700 1699 1702 1 2 ND2 $T=485460 276080 1 0 $X=485460 $Y=270660
X1117 1708 1713 279 1 2 ND2 $T=489180 245840 1 180 $X=487320 $Y=245460
X1118 310 1707 308 1 2 ND2 $T=491660 316400 1 180 $X=489800 $Y=316020
X1119 1713 1659 1715 1 2 ND2 $T=491040 255920 1 0 $X=491040 $Y=250500
X1120 1726 1762 1749 1 2 ND2 $T=502200 266000 1 0 $X=502200 $Y=260580
X1121 1751 1757 1792 1 2 ND2 $T=504060 286160 0 0 $X=504060 $Y=285780
X1122 1819 1807 1776 1 2 ND2 $T=514600 286160 0 180 $X=512740 $Y=280740
X1123 333 1806 1795 1 2 ND2 $T=515840 245840 1 180 $X=513980 $Y=245460
X1124 1843 1837 1829 1 2 ND2 $T=517700 306320 0 180 $X=515840 $Y=300900
X1125 1847 1767 333 1 2 ND2 $T=518320 245840 0 180 $X=516460 $Y=240420
X1126 1885 1763 1795 1 2 ND2 $T=525140 225680 1 180 $X=523280 $Y=225300
X1127 1722 1881 1793 1 2 ND2 $T=524520 235760 0 0 $X=524520 $Y=235380
X1128 1793 1812 1895 1 2 ND2 $T=525140 255920 1 0 $X=525140 $Y=250500
X1129 1749 1866 1885 1 2 ND2 $T=526380 245840 0 0 $X=526380 $Y=245460
X1130 333 1774 1885 1 2 ND2 $T=528240 225680 1 0 $X=528240 $Y=220260
X1131 1887 1922 1830 1 2 ND2 $T=530720 225680 1 180 $X=528860 $Y=225300
X1132 1843 371 362 1 2 ND2 $T=532580 306320 1 0 $X=532580 $Y=300900
X1133 1936 1920 1747 1 2 ND2 $T=536300 235760 1 0 $X=536300 $Y=230340
X1134 380 1876 383 1 2 ND2 $T=538160 316400 1 0 $X=538160 $Y=310980
X1135 1927 1980 1859 1 2 ND2 $T=544980 276080 0 180 $X=543120 $Y=270660
X1136 368 1902 387 1 2 ND2 $T=543740 286160 0 0 $X=543740 $Y=285780
X1137 1999 396 395 1 2 ND2 $T=548080 316400 0 0 $X=548080 $Y=316020
X1138 2018 1890 401 1 2 ND2 $T=553040 266000 0 0 $X=553040 $Y=265620
X1139 402 1930 412 1 2 ND2 $T=554900 316400 1 0 $X=554900 $Y=310980
X1140 1997 2043 1813 1 2 ND2 $T=558620 255920 0 180 $X=556760 $Y=250500
X1141 2041 1784 2080 1 2 ND2 $T=556760 296240 1 0 $X=556760 $Y=290820
X1142 2031 2053 1885 1 2 ND2 $T=560480 235760 0 0 $X=560480 $Y=235380
X1143 2062 2042 2047 1 2 ND2 $T=562340 276080 0 180 $X=560480 $Y=270660
X1144 1830 2060 1747 1 2 ND2 $T=561720 225680 1 0 $X=561720 $Y=220260
X1145 1947 2087 382 1 2 ND2 $T=569160 245840 1 180 $X=567300 $Y=245460
X1146 2115 2099 1758 1 2 ND2 $T=574120 266000 0 180 $X=572260 $Y=260580
X1147 2061 2097 2116 1 2 ND2 $T=572880 255920 0 0 $X=572880 $Y=255540
X1148 2115 1869 1795 1 2 ND2 $T=575360 276080 0 180 $X=573500 $Y=270660
X1149 2135 2144 1749 1 2 ND2 $T=583420 296240 1 0 $X=583420 $Y=290820
X1150 433 2165 406 1 2 ND2 $T=584040 306320 0 0 $X=584040 $Y=305940
X1151 2062 2147 1927 1 2 ND2 $T=586520 266000 1 0 $X=586520 $Y=260580
X1152 2135 2190 1895 1 2 ND2 $T=587760 296240 1 0 $X=587760 $Y=290820
X1153 1714 2183 1795 1 2 ND2 $T=590860 225680 1 180 $X=589000 $Y=225300
X1154 453 2174 369 1 2 ND2 $T=589000 286160 0 0 $X=589000 $Y=285780
X1155 1789 2197 2201 1 2 ND2 $T=592720 235760 1 0 $X=592720 $Y=230340
X1156 1905 2199 2216 1 2 ND2 $T=594580 296240 0 0 $X=594580 $Y=295860
X1157 2062 2213 2201 1 2 ND2 $T=597680 266000 0 180 $X=595820 $Y=260580
X1158 2201 2158 2216 1 2 ND2 $T=597680 306320 1 0 $X=597680 $Y=300900
X1159 2211 2225 424 1 2 ND2 $T=599540 316400 1 0 $X=599540 $Y=310980
X1160 2233 2118 448 1 2 ND2 $T=603260 316400 1 0 $X=603260 $Y=310980
X1161 387 2239 394 1 2 ND2 $T=604500 306320 1 0 $X=604500 $Y=300900
X1162 2245 2226 1975 1 2 ND2 $T=605120 225680 1 0 $X=605120 $Y=220260
X1163 463 368 466 1 2 ND2 $T=610080 316400 0 0 $X=610080 $Y=316020
X1164 345 2232 336 1 2 ND2 $T=611320 306320 1 0 $X=611320 $Y=300900
X1165 463 336 468 1 2 ND2 $T=613180 316400 0 0 $X=613180 $Y=316020
X1166 2262 464 333 1 2 ND2 $T=617520 316400 1 0 $X=617520 $Y=310980
X1167 478 2201 481 1 2 ND2 $T=624960 306320 0 0 $X=624960 $Y=305940
X1168 478 382 482 1 2 ND2 $T=624960 316400 1 0 $X=624960 $Y=310980
X1169 479 1802 485 1 2 ND2 $T=628060 306320 1 0 $X=628060 $Y=300900
X1170 1997 2111 1793 1 2 ND2 $T=629920 225680 0 0 $X=629920 $Y=225300
X1171 487 1859 481 1 2 ND2 $T=633640 296240 0 180 $X=631780 $Y=290820
X1172 485 1880 483 1 2 ND2 $T=633640 316400 1 0 $X=633640 $Y=310980
X1173 2308 2266 481 1 2 ND2 $T=635500 306320 1 0 $X=635500 $Y=300900
X1174 479 1861 486 1 2 ND2 $T=635500 316400 0 0 $X=635500 $Y=316020
X1175 2308 2216 482 1 2 ND2 $T=636740 296240 0 0 $X=636740 $Y=295860
X1176 2312 490 491 1 2 ND2 $T=636740 316400 1 0 $X=636740 $Y=310980
X1177 2314 1887 481 1 2 ND2 $T=638600 306320 1 0 $X=638600 $Y=300900
X1178 2312 494 493 1 2 ND2 $T=638600 316400 1 0 $X=638600 $Y=310980
X1179 2317 1830 2319 1 2 ND2 $T=639840 286160 0 0 $X=639840 $Y=285780
X1180 482 2040 2314 1 2 ND2 $T=640460 306320 0 0 $X=640460 $Y=305940
X1181 455 2276 2062 1 2 ND2 $T=644180 276080 0 180 $X=642320 $Y=270660
X1182 2324 1749 2325 1 2 ND2 $T=643560 296240 1 0 $X=643560 $Y=290820
X1183 2319 499 500 1 2 ND2 $T=643560 306320 0 0 $X=643560 $Y=305940
X1184 2321 2047 482 1 2 ND2 $T=644800 276080 0 0 $X=644800 $Y=275700
X1185 2321 2289 481 1 2 ND2 $T=647900 276080 1 0 $X=647900 $Y=270660
X1186 1830 2332 1795 1 2 ND2 $T=650380 235760 1 180 $X=648520 $Y=235380
X1187 2329 2070 482 1 2 ND2 $T=650380 286160 0 180 $X=648520 $Y=280740
X1188 2250 2208 2334 1 2 ND2 $T=649760 255920 1 0 $X=649760 $Y=250500
X1189 2329 2334 481 1 2 ND2 $T=652240 276080 1 180 $X=650380 $Y=275700
X1190 2341 2349 2353 1 2 ND2 $T=660920 255920 0 180 $X=659060 $Y=250500
X1191 2351 2358 2353 1 2 ND2 $T=662780 255920 0 0 $X=662780 $Y=255540
X1192 2372 2370 2373 1 2 ND2 $T=665880 266000 1 0 $X=665880 $Y=260580
X1193 2365 2368 2372 1 2 ND2 $T=665880 266000 0 0 $X=665880 $Y=265620
X1194 2365 2369 2373 1 2 ND2 $T=667740 276080 1 180 $X=665880 $Y=275700
X1195 2384 2360 2398 1 2 ND2 $T=670840 225680 0 0 $X=670840 $Y=225300
X1196 2387 2395 2391 1 2 ND2 $T=674560 276080 1 0 $X=674560 $Y=270660
X1197 2387 2393 2363 1 2 ND2 $T=674560 276080 0 0 $X=674560 $Y=275700
X1198 2426 2428 2422 1 2 ND2 $T=688820 255920 0 180 $X=686960 $Y=250500
X1199 2422 2420 2425 1 2 ND2 $T=688200 245840 1 0 $X=688200 $Y=240420
X1200 2454 2438 2425 1 2 ND2 $T=695020 245840 1 180 $X=693160 $Y=245460
X1201 2453 2476 2491 1 2 ND2 $T=706800 225680 0 0 $X=706800 $Y=225300
X1202 2492 2482 2491 1 2 ND2 $T=711760 225680 1 180 $X=709900 $Y=225300
X1203 2453 2470 2492 1 2 ND2 $T=711760 235760 0 180 $X=709900 $Y=230340
X1204 2496 2493 2500 1 2 ND2 $T=711760 296240 1 0 $X=711760 $Y=290820
X1205 2466 2480 2501 1 2 ND2 $T=713620 245840 1 0 $X=713620 $Y=240420
X1206 2504 2496 2497 1 2 ND2 $T=715480 286160 0 180 $X=713620 $Y=280740
X1207 2494 2500 2507 1 2 ND2 $T=713620 296240 0 0 $X=713620 $Y=295860
X1208 2550 2551 2555 1 2 ND2 $T=739040 276080 0 0 $X=739040 $Y=275700
X1209 2559 2560 2565 1 2 ND2 $T=744000 245840 1 0 $X=744000 $Y=240420
X1210 2549 2556 2555 1 2 ND2 $T=744000 286160 1 0 $X=744000 $Y=280740
X1211 2558 2567 2571 1 2 ND2 $T=745860 245840 1 0 $X=745860 $Y=240420
X1212 2571 2553 2565 1 2 ND2 $T=747720 255920 1 0 $X=747720 $Y=250500
X1213 2602 2615 543 1 2 ND2 $T=758260 276080 1 0 $X=758260 $Y=270660
X1214 2626 2606 2611 1 2 ND2 $T=763220 225680 0 180 $X=761360 $Y=220260
X1215 2622 2610 2626 1 2 ND2 $T=764460 225680 0 0 $X=764460 $Y=225300
X1216 2622 2620 2611 1 2 ND2 $T=764460 235760 1 0 $X=764460 $Y=230340
X1217 2632 2629 2635 1 2 ND2 $T=767560 306320 0 0 $X=767560 $Y=305940
X1218 2615 2637 2644 1 2 ND2 $T=768800 276080 1 0 $X=768800 $Y=270660
X1219 2653 2651 2659 1 2 ND2 $T=775000 276080 1 0 $X=775000 $Y=270660
X1220 2657 2656 2654 1 2 ND2 $T=776240 235760 1 0 $X=776240 $Y=230340
X1221 2652 2661 2654 1 2 ND2 $T=779960 235760 0 180 $X=778100 $Y=230340
X1222 2652 2660 2657 1 2 ND2 $T=781820 235760 1 0 $X=781820 $Y=230340
X1223 2698 2713 2694 1 2 ND2 $T=794220 276080 1 0 $X=794220 $Y=270660
X1224 2707 2648 2713 1 2 ND2 $T=796700 245840 0 0 $X=796700 $Y=245460
X1225 606 2774 603 1 2 ND2 $T=822740 276080 1 180 $X=820880 $Y=275700
X1226 601 2753 611 1 2 ND2 $T=823980 245840 0 0 $X=823980 $Y=245460
X1227 2784 2813 2836 1 2 ND2 $T=829560 245840 1 0 $X=829560 $Y=240420
X1228 2827 2787 2799 1 2 ND2 $T=831420 255920 0 180 $X=829560 $Y=250500
X1229 2825 2816 601 1 2 ND2 $T=832660 245840 1 180 $X=830800 $Y=245460
X1230 626 2835 603 1 2 ND2 $T=832660 286160 0 180 $X=830800 $Y=280740
X1231 627 2830 606 1 2 ND2 $T=832660 296240 0 180 $X=830800 $Y=290820
X1232 624 2744 626 1 2 ND2 $T=831420 276080 0 0 $X=831420 $Y=275700
X1233 632 2827 606 1 2 ND2 $T=834520 296240 0 180 $X=832660 $Y=290820
X1234 627 2799 626 1 2 ND2 $T=832660 316400 0 0 $X=832660 $Y=316020
X1235 624 2838 606 1 2 ND2 $T=836380 286160 0 180 $X=834520 $Y=280740
X1236 632 2843 639 1 2 ND2 $T=835760 316400 0 0 $X=835760 $Y=316020
X1237 604 2874 609 1 2 ND2 $T=840100 255920 1 180 $X=838240 $Y=255540
X1238 2881 599 2900 1 2 ND2 $T=842580 306320 0 0 $X=842580 $Y=305940
X1239 2898 2888 2877 1 2 ND2 $T=845060 316400 0 180 $X=843200 $Y=310980
X1240 2896 2755 2893 1 2 ND2 $T=846300 245840 1 180 $X=844440 $Y=245460
X1241 2893 2876 655 1 2 ND2 $T=844440 255920 1 0 $X=844440 $Y=250500
X1242 664 2890 668 1 2 ND2 $T=848160 306320 1 0 $X=848160 $Y=300900
X1243 654 2910 2744 1 2 ND2 $T=851260 276080 0 0 $X=851260 $Y=275700
X1244 2939 2878 601 1 2 ND2 $T=856840 255920 1 180 $X=854980 $Y=255540
X1245 2970 2790 2960 1 2 ND2 $T=863040 306320 0 180 $X=861180 $Y=300900
X1246 2967 2965 2979 1 2 ND2 $T=861800 245840 0 0 $X=861800 $Y=245460
X1247 2825 2981 694 1 2 ND2 $T=864900 266000 1 0 $X=864900 $Y=260580
X1248 601 3026 2880 1 2 ND2 $T=880400 276080 1 180 $X=878540 $Y=275700
X1249 712 3047 663 1 2 ND2 $T=884740 296240 1 180 $X=882880 $Y=295860
X1250 2834 3062 713 1 2 ND2 $T=885980 266000 0 0 $X=885980 $Y=265620
X1251 2964 3078 3062 1 2 ND2 $T=890320 276080 0 0 $X=890320 $Y=275700
X1252 3085 3061 655 1 2 ND2 $T=894040 255920 1 180 $X=892180 $Y=255540
X1253 2769 3073 713 1 2 ND2 $T=892180 266000 0 0 $X=892180 $Y=265620
X1254 716 3064 3086 1 2 ND2 $T=892180 306320 0 0 $X=892180 $Y=305940
X1255 2997 3090 3073 1 2 ND2 $T=896520 266000 0 180 $X=894660 $Y=260580
X1256 694 3136 608 1 2 ND2 $T=907060 306320 1 180 $X=905200 $Y=305940
X1257 2825 742 608 1 2 ND2 $T=914500 276080 1 0 $X=914500 $Y=270660
X1258 683 3181 717 1 2 ND2 $T=918840 306320 1 0 $X=918840 $Y=300900
X1259 717 740 700 1 2 ND2 $T=918840 316400 0 0 $X=918840 $Y=316020
X1260 709 3192 634 1 2 ND2 $T=925660 306320 1 0 $X=925660 $Y=300900
X1261 3210 3213 628 1 2 ND2 $T=930000 306320 0 0 $X=930000 $Y=305940
X1262 3215 3211 3122 1 2 ND2 $T=933100 245840 0 0 $X=933100 $Y=245460
X1263 3034 3140 694 1 2 ND2 $T=946740 266000 0 0 $X=946740 $Y=265620
X1264 2939 3234 611 1 2 ND2 $T=946740 276080 1 0 $X=946740 $Y=270660
X1265 3215 3124 694 1 2 ND2 $T=950460 255920 0 180 $X=948600 $Y=250500
X1266 3264 3232 685 1 2 ND2 $T=948600 266000 1 0 $X=948600 $Y=260580
X1267 688 3265 608 1 2 ND2 $T=950460 296240 1 180 $X=948600 $Y=295860
X1268 3275 3071 611 1 2 ND2 $T=960380 245840 1 0 $X=960380 $Y=240420
X1269 3022 3197 3034 1 2 ND2 $T=971540 266000 1 0 $X=971540 $Y=260580
X1270 1425 1 1426 1447 2 ND2T $T=385640 266000 1 0 $X=385640 $Y=260580
X1271 2353 2394 2 2376 2383 1 3410 FA1 $T=667740 255920 1 0 $X=667740 $Y=250500
X1272 2453 2459 2 2455 2457 1 2446 FA1 $T=696880 235760 0 0 $X=696880 $Y=235380
X1273 2405 2575 2 2578 2588 1 2559 FA1 $T=760120 235760 1 180 $X=744620 $Y=235380
X1274 2398 2384 2379 2 1 2330 XOR3S $T=678280 225680 0 180 $X=667120 $Y=220260
X1275 1416 1436 1 2 INV3 $T=396180 286160 1 0 $X=396180 $Y=280740
X1276 572 573 1 2 INV3 $T=784300 266000 0 0 $X=784300 $Y=265620
X1277 1362 1364 1 2 INV2 $T=363940 296240 1 0 $X=363940 $Y=290820
X1278 1382 1387 1 2 INV2 $T=367040 286160 1 0 $X=367040 $Y=280740
X1279 1407 1329 1 2 INV2 $T=374480 276080 1 0 $X=374480 $Y=270660
X1280 1420 1424 1 2 INV2 $T=381920 255920 0 0 $X=381920 $Y=255540
X1281 1455 1428 1 2 INV2 $T=390600 255920 1 0 $X=390600 $Y=250500
X1282 1530 1511 1 2 INV2 $T=417880 276080 0 180 $X=416020 $Y=270660
X1283 232 1418 1 2 INV2 $T=432140 316400 0 0 $X=432140 $Y=316020
X1284 1413 1516 1 2 INV2 $T=437720 296240 0 0 $X=437720 $Y=295860
X1285 272 1576 1 2 INV2 $T=444540 316400 0 180 $X=442680 $Y=310980
X1286 1612 1596 1 2 INV2 $T=448880 286160 1 0 $X=448880 $Y=280740
X1287 1613 1626 1 2 INV2 $T=456940 296240 0 180 $X=455080 $Y=290820
X1288 279 281 1 2 INV2 $T=461280 316400 0 180 $X=459420 $Y=310980
X1289 1657 1544 1 2 INV2 $T=468100 255920 1 0 $X=468100 $Y=250500
X1290 1651 1683 1 2 INV2 $T=471820 266000 1 0 $X=471820 $Y=260580
X1291 293 1685 1 2 INV2 $T=476780 316400 1 180 $X=474920 $Y=316020
X1292 1693 1686 1 2 INV2 $T=480500 266000 0 0 $X=480500 $Y=265620
X1293 1700 1703 1 2 INV2 $T=485460 266000 0 0 $X=485460 $Y=265620
X1294 1726 1721 1 2 INV2 $T=499100 255920 0 180 $X=497240 $Y=250500
X1295 2397 2351 1 2 INV2 $T=677040 235760 0 0 $X=677040 $Y=235380
X1296 510 2410 1 2 INV2 $T=694400 286160 1 180 $X=692540 $Y=285780
X1297 534 2499 1 2 INV2 $T=715480 316400 1 180 $X=713620 $Y=316020
X1298 543 545 1 2 INV2 $T=746480 286160 1 0 $X=746480 $Y=280740
X1299 2579 2575 1 2 INV2 $T=750200 245840 1 0 $X=750200 $Y=240420
X1300 2608 2627 1 2 INV2 $T=763220 266000 0 0 $X=763220 $Y=265620
X1301 564 2617 1 2 INV2 $T=763840 306320 1 0 $X=763840 $Y=300900
X1302 563 2616 1 2 INV2 $T=765700 306320 1 0 $X=765700 $Y=300900
X1303 2651 2641 1 2 INV2 $T=775000 266000 0 0 $X=775000 $Y=265620
X1304 2655 2524 1 2 INV2 $T=775620 245840 0 0 $X=775620 $Y=245460
X1305 579 2695 1 2 INV2 $T=791740 306320 0 0 $X=791740 $Y=305940
X1306 2717 2578 1 2 INV2 $T=801660 235760 0 0 $X=801660 $Y=235380
X1307 655 656 1 2 INV2 $T=894040 255920 0 0 $X=894040 $Y=255540
X1308 891 880 872 2 876 1 4 AN4B1S $T=225060 266000 0 180 $X=220720 $Y=260580
X1309 945 17 881 2 879 1 869 AN4B1S $T=225680 266000 1 180 $X=221340 $Y=265620
X1310 904 898 894 2 875 1 888 AN4B1S $T=228160 296240 1 180 $X=223820 $Y=295860
X1311 47 14 42 2 930 1 877 AN4B1S $T=234980 286160 0 180 $X=230640 $Y=280740
X1312 47 929 950 2 946 1 903 AN4B1S $T=237460 276080 0 180 $X=233120 $Y=270660
X1313 17 954 936 2 946 1 940 AN4B1S $T=238080 286160 1 180 $X=233740 $Y=285780
X1314 945 976 952 2 951 1 972 AN4B1S $T=241800 286160 0 180 $X=237460 $Y=280740
X1315 16 44 996 2 998 1 955 AN4B1S $T=243660 245840 1 0 $X=243660 $Y=240420
X1316 929 34 976 2 994 1 989 AN4B1S $T=248000 276080 0 180 $X=243660 $Y=270660
X1317 936 918 17 2 1003 1 1013 AN4B1S $T=244900 286160 0 0 $X=244900 $Y=285780
X1318 997 1001 80 2 961 1 1057 AN4B1S $T=246760 306320 0 0 $X=246760 $Y=305940
X1319 90 1019 1016 2 999 1 971 AN4B1S $T=252340 296240 1 180 $X=248000 $Y=295860
X1320 945 1020 881 2 1015 1 922 AN4B1S $T=252960 276080 0 180 $X=248620 $Y=270660
X1321 36 929 1022 2 1024 1 1031 AN4B1S $T=249860 266000 1 0 $X=249860 $Y=260580
X1322 953 1000 1023 2 1025 1 89 AN4B1S $T=249860 306320 1 0 $X=249860 $Y=300900
X1323 1054 1034 1017 2 1030 1 1005 AN4B1S $T=257920 245840 0 180 $X=253580 $Y=240420
X1324 1075 956 1065 2 957 1 1033 AN4B1S $T=263500 235760 0 180 $X=259160 $Y=230340
X1325 1071 1078 1066 2 1084 1 111 AN4B1S $T=261640 255920 0 0 $X=261640 $Y=255540
X1326 113 954 1027 2 896 1 912 AN4B1S $T=267840 286160 1 180 $X=263500 $Y=285780
X1327 114 1094 1064 2 110 1 1086 AN4B1S $T=268460 316400 0 180 $X=264120 $Y=310980
X1328 1067 1091 1105 2 1100 1 1006 AN4B1S $T=267840 276080 1 0 $X=267840 $Y=270660
X1329 1152 1145 139 2 138 1 1144 AN4B1S $T=283340 316400 1 180 $X=279000 $Y=316020
X1330 142 1119 1104 2 1157 1 1141 AN4B1S $T=282100 245840 0 0 $X=282100 $Y=245460
X1331 17 1151 1027 2 969 1 1165 AN4B1S $T=282720 296240 1 0 $X=282720 $Y=290820
X1332 1144 144 1132 2 1162 1 149 AN4B1S $T=283340 316400 0 0 $X=283340 $Y=316020
X1333 152 1087 1172 2 148 1 1173 AN4B1S $T=290780 316400 0 180 $X=286440 $Y=310980
X1334 1153 945 1177 2 879 1 1072 AN4B1S $T=287680 296240 1 0 $X=287680 $Y=290820
X1335 1105 16 1183 2 1185 1 1089 AN4B1S $T=290160 286160 1 0 $X=290160 $Y=280740
X1336 16 1163 1043 2 974 1 1191 AN4B1S $T=291400 255920 1 0 $X=291400 $Y=250500
X1337 1198 1083 1105 2 1127 1 1210 AN4B1S $T=295740 276080 1 0 $X=295740 $Y=270660
X1338 1217 1138 1034 2 1157 1 1208 AN4B1S $T=303800 245840 1 180 $X=299460 $Y=245460
X1339 160 1216 1179 2 1220 1 1085 AN4B1S $T=300700 296240 1 0 $X=300700 $Y=290820
X1340 1111 142 1075 2 1097 1 1222 AN4B1S $T=302560 255920 1 0 $X=302560 $Y=250500
X1341 1091 1213 950 2 934 1 1219 AN4B1S $T=306900 276080 0 180 $X=302560 $Y=270660
X1342 1229 170 1226 2 168 1 167 AN4B1S $T=307520 316400 1 180 $X=303180 $Y=316020
X1343 1227 1201 1224 2 1190 1 1252 AN4B1S $T=305660 296240 1 0 $X=305660 $Y=290820
X1344 1186 1236 1119 2 50 1 1250 AN4B1S $T=308140 245840 0 0 $X=308140 $Y=245460
X1345 1242 1212 1249 2 1225 1 1254 AN4B1S $T=311860 306320 0 0 $X=311860 $Y=305940
X1346 1152 1247 174 2 1231 1 1255 AN4B1S $T=311860 316400 1 0 $X=311860 $Y=310980
X1347 1257 1241 1230 2 1099 1 1245 AN4B1S $T=316820 266000 0 180 $X=312480 $Y=260580
X1348 976 16 47 2 1238 1 1259 AN4B1S $T=319300 276080 1 180 $X=314960 $Y=275700
X1349 1214 944 1017 2 1223 1 1266 AN4B1S $T=321160 255920 1 0 $X=321160 $Y=250500
X1350 1017 1151 16 2 911 1 1277 AN4B1S $T=326740 266000 1 0 $X=326740 $Y=260580
X1351 1297 192 1292 2 1289 1 1265 AN4B1S $T=331700 306320 0 180 $X=327360 $Y=300900
X1352 1298 1017 1170 2 1290 1 1276 AN4B1S $T=332320 255920 1 180 $X=327980 $Y=255540
X1353 995 1214 1104 2 1296 1 1288 AN4B1S $T=328600 245840 1 0 $X=328600 $Y=240420
X1354 1273 81 1258 2 1299 1 1285 AN4B1S $T=330460 296240 1 0 $X=330460 $Y=290820
X1355 1236 1189 1298 2 1304 1 1270 AN4B1S $T=332320 255920 0 0 $X=332320 $Y=255540
X1356 1236 1065 996 2 980 1 1300 AN4B1S $T=334800 255920 1 0 $X=334800 $Y=250500
X1357 1214 14 1102 2 76 1 215 AN4B1S $T=341620 266000 0 0 $X=341620 $Y=265620
X1358 1248 956 1237 2 1264 1 1306 AN4B1S $T=343480 255920 0 0 $X=343480 $Y=255540
X1359 1686 1702 1703 2 1651 1 1684 AN4B1S $T=487320 255920 0 0 $X=487320 $Y=255540
X1360 1758 1722 1726 2 1739 1 1733 AN4B1S $T=504680 245840 1 180 $X=500340 $Y=245460
X1361 1766 1756 1753 2 1745 1 1742 AN4B1S $T=506540 276080 0 180 $X=502200 $Y=270660
X1362 1788 316 1764 2 1728 1 1751 AN4B1S $T=508400 286160 0 180 $X=504060 $Y=280740
X1363 1793 1749 1747 2 1767 1 1735 AN4B1S $T=509640 235760 1 180 $X=505300 $Y=235380
X1364 1796 1787 1768 2 1784 1 1777 AN4B1S $T=511500 296240 0 180 $X=507160 $Y=290820
X1365 1796 1807 328 2 329 1 1824 AN4B1S $T=510880 306320 1 0 $X=510880 $Y=300900
X1366 1847 1749 1830 2 1806 1 1831 AN4B1S $T=518320 255920 0 180 $X=513980 $Y=250500
X1367 1723 332 1833 2 1836 1 1832 AN4B1S $T=513980 296240 0 0 $X=513980 $Y=295860
X1368 1854 1837 1810 2 335 1 1814 AN4B1S $T=519560 306320 1 180 $X=515220 $Y=305940
X1369 1867 1856 1855 2 1851 1 1803 AN4B1S $T=522040 255920 1 180 $X=517700 $Y=255540
X1370 1911 1905 1895 2 1765 1 1808 AN4B1S $T=530720 235760 0 180 $X=526380 $Y=230340
X1371 1940 1747 1895 2 1774 1 1943 AN4B1S $T=540640 225680 0 180 $X=536300 $Y=220260
X1372 374 1958 1956 2 1901 1 1948 AN4B1S $T=541260 266000 1 180 $X=536920 $Y=265620
X1373 351 1963 1967 2 385 1 1968 AN4B1S $T=539400 296240 1 0 $X=539400 $Y=290820
X1374 1973 1940 1975 2 1862 1 1970 AN4B1S $T=545600 225680 1 180 $X=541260 $Y=225300
X1375 1974 1726 1878 2 1980 1 1998 AN4B1S $T=543120 235760 0 0 $X=543120 $Y=235380
X1376 1940 1997 1974 2 2005 1 2010 AN4B1S $T=546220 235760 1 0 $X=546220 $Y=230340
X1377 1929 1995 2000 2 2006 1 1799 AN4B1S $T=546220 245840 0 0 $X=546220 $Y=245460
X1378 1824 1996 2012 2 2020 1 2030 AN4B1S $T=548700 296240 0 0 $X=548700 $Y=295860
X1379 1907 2015 1805 2 2034 1 1976 AN4B1S $T=552420 235760 1 0 $X=552420 $Y=230340
X1380 2036 1975 1805 2 2043 1 2050 AN4B1S $T=554900 235760 0 0 $X=554900 $Y=235380
X1381 382 2048 2044 2 1955 1 1798 AN4B1S $T=559860 266000 1 180 $X=555520 $Y=265620
X1382 2069 2040 1722 2 2043 1 2057 AN4B1S $T=563580 245840 0 180 $X=559240 $Y=240420
X1383 2055 420 2076 2 1990 1 2085 AN4B1S $T=563580 286160 0 0 $X=563580 $Y=285780
X1384 2066 2038 2070 2 1892 1 2063 AN4B1S $T=569160 276080 0 180 $X=564820 $Y=270660
X1385 2105 2098 426 2 2084 1 2064 AN4B1S $T=572260 296240 0 180 $X=567920 $Y=290820
X1386 2119 2112 2078 2 2028 1 2093 AN4B1S $T=574740 286160 0 180 $X=570400 $Y=280740
X1387 443 2130 2132 2 2134 1 1778 AN4B1S $T=576600 276080 1 0 $X=576600 $Y=270660
X1388 1795 2036 1793 2 1960 1 2122 AN4B1S $T=577220 225680 0 0 $X=577220 $Y=225300
X1389 2015 1885 1726 2 2147 1 2091 AN4B1S $T=579700 235760 1 0 $X=579700 $Y=230340
X1390 1935 2155 2145 2 2149 1 1900 AN4B1S $T=585280 266000 0 180 $X=580940 $Y=260580
X1391 2180 2182 2177 2 2151 1 1732 AN4B1S $T=592100 245840 1 180 $X=587760 $Y=245460
X1392 2194 2188 2200 2 2203 1 2187 AN4B1S $T=592100 306320 0 0 $X=592100 $Y=305940
X1393 1726 2185 1911 2 2208 1 2075 AN4B1S $T=595200 235760 0 0 $X=595200 $Y=235380
X1394 2192 1911 1933 2 2214 1 1931 AN4B1S $T=595820 266000 0 0 $X=595820 $Y=265620
X1395 2206 2215 2220 2 2224 1 1792 AN4B1S $T=597680 286160 1 0 $X=597680 $Y=280740
X1396 2238 1911 1893 2 2148 1 2230 AN4B1S $T=604500 255920 1 180 $X=600160 $Y=255540
X1397 2221 2251 2255 2 2257 1 2252 AN4B1S $T=606980 276080 1 0 $X=606980 $Y=270660
X1398 1911 2212 2263 2 2235 1 2268 AN4B1S $T=609460 235760 1 0 $X=609460 $Y=230340
X1399 2015 1887 2062 2 1843 1 465 AN4B1S $T=609460 286160 1 0 $X=609460 $Y=280740
X1400 2038 2267 2198 2 2157 1 2285 AN4B1S $T=611940 245840 0 0 $X=611940 $Y=245460
X1401 2038 2051 2198 2 1892 1 2279 AN4B1S $T=614420 266000 1 0 $X=614420 $Y=260580
X1402 2264 2282 2128 2 2008 1 2017 AN4B1S $T=621860 245840 0 180 $X=617520 $Y=240420
X1403 1893 1887 2216 2 2227 1 2273 AN4B1S $T=620620 266000 0 0 $X=620620 $Y=265620
X1404 2051 2185 2044 2 2124 1 2294 AN4B1S $T=623100 286160 1 0 $X=623100 $Y=280740
X1405 2246 1962 2192 2 2146 1 2298 AN4B1S $T=624960 245840 0 0 $X=624960 $Y=245460
X1406 2266 1839 2047 2 2300 1 2297 AN4B1S $T=628680 286160 1 0 $X=628680 $Y=280740
X1407 2304 2264 2192 2 2096 1 2306 AN4B1S $T=631780 255920 1 0 $X=631780 $Y=250500
X1408 2155 455 2238 2 1770 1 2305 AN4B1S $T=636120 266000 0 180 $X=631780 $Y=260580
X1409 2051 2048 2126 2 1721 1 2307 AN4B1S $T=633020 266000 0 0 $X=633020 $Y=265620
X1410 1893 2155 2128 2 1721 1 2310 AN4B1S $T=633640 235760 0 0 $X=633640 $Y=235380
X1411 2126 1927 2051 2 2276 1 2195 AN4B1S $T=637360 276080 1 0 $X=637360 $Y=270660
X1412 2038 2238 2322 2 1918 1 2318 AN4B1S $T=641700 266000 1 0 $X=641700 $Y=260580
X1413 2770 2762 2760 2 2756 1 2749 AN4B1S $T=823360 255920 1 180 $X=819020 $Y=255540
X1414 2824 2764 607 2 2743 1 2745 AN4B1S $T=825220 286160 1 180 $X=820880 $Y=285780
X1415 2824 629 2833 2 2839 1 2823 AN4B1S $T=832660 286160 0 0 $X=832660 $Y=285780
X1416 2882 2796 2867 2 2872 1 2864 AN4B1S $T=843820 245840 0 180 $X=839480 $Y=240420
X1417 620 2835 2830 2 2852 1 2891 AN4B1S $T=839480 266000 1 0 $X=839480 $Y=260580
X1418 2891 2895 2885 2 2787 1 660 AN4B1S $T=844440 255920 0 0 $X=844440 $Y=255540
X1419 2920 2911 2909 2 2888 1 2807 AN4B1S $T=852500 306320 1 180 $X=848160 $Y=305940
X1420 2926 2907 2911 2 2839 1 2912 AN4B1S $T=853120 286160 1 180 $X=848780 $Y=285780
X1421 2957 2918 2916 2 2905 1 2917 AN4B1S $T=853740 235760 1 180 $X=849400 $Y=235380
X1422 2904 2931 2860 2 2938 1 2925 AN4B1S $T=853120 235760 1 0 $X=853120 $Y=230340
X1423 2947 2909 2868 2 2935 1 2927 AN4B1S $T=858080 306320 1 180 $X=853740 $Y=305940
X1424 2921 2932 2948 2 2935 1 2941 AN4B1S $T=856220 296240 1 0 $X=856220 $Y=290820
X1425 2871 2968 2971 2 2974 1 2770 AN4B1S $T=861180 245840 1 0 $X=861180 $Y=240420
X1426 2870 2984 667 2 2988 1 2973 AN4B1S $T=864280 296240 1 0 $X=864280 $Y=290820
X1427 696 2992 2990 2 691 1 2947 AN4B1S $T=869860 316400 1 180 $X=865520 $Y=316020
X1428 2943 2899 3006 2 2989 1 2999 AN4B1S $T=874200 255920 1 180 $X=869860 $Y=255540
X1429 3012 2990 698 2 2849 1 3002 AN4B1S $T=874200 296240 0 180 $X=869860 $Y=290820
X1430 2739 3007 704 2 2819 1 2995 AN4B1S $T=872340 235760 0 0 $X=872340 $Y=235380
X1431 694 2943 706 2 2958 1 3011 AN4B1S $T=877920 255920 0 180 $X=873580 $Y=250500
X1432 2780 3012 629 2 3021 1 3028 AN4B1S $T=875440 296240 1 0 $X=875440 $Y=290820
X1433 688 3030 2767 2 710 1 2951 AN4B1S $T=881640 225680 1 180 $X=877300 $Y=225300
X1434 3046 3008 3003 2 3032 1 3024 AN4B1S $T=882880 245840 1 180 $X=878540 $Y=245460
X1435 3068 3058 3055 2 3053 1 2761 AN4B1S $T=887840 286160 1 180 $X=883500 $Y=285780
X1436 720 3038 3069 2 3065 1 2786 AN4B1S $T=890320 316400 1 180 $X=885980 $Y=316020
X1437 3063 2983 3031 2 3076 1 3039 AN4B1S $T=888460 225680 1 0 $X=888460 $Y=220260
X1438 3063 708 3030 2 2820 1 3042 AN4B1S $T=888460 225680 0 0 $X=888460 $Y=225300
X1439 3041 718 3034 2 3079 1 3113 AN4B1S $T=889700 276080 1 0 $X=889700 $Y=270660
X1440 3097 3091 3082 2 3087 1 721 AN4B1S $T=897140 276080 1 180 $X=892800 $Y=275700
X1441 2979 611 2836 2 3100 1 3094 AN4B1S $T=900240 255920 0 180 $X=895900 $Y=250500
X1442 3040 3112 3096 2 671 1 2961 AN4B1S $T=902720 245840 0 180 $X=898380 $Y=240420
X1443 3125 3013 3117 2 640 1 2923 AN4B1S $T=904580 225680 0 180 $X=900240 $Y=220260
X1444 2986 2943 3122 2 2908 1 3015 AN4B1S $T=901480 255920 1 0 $X=901480 $Y=250500
X1445 3070 611 3122 2 3140 1 3158 AN4B1S $T=910160 266000 1 0 $X=910160 $Y=260580
X1446 2864 3154 3156 2 3014 1 737 AN4B1S $T=911400 245840 1 0 $X=911400 $Y=240420
X1447 3153 3162 3161 2 3167 1 2806 AN4B1S $T=913880 286160 1 0 $X=913880 $Y=280740
X1448 3139 3164 741 2 3166 1 744 AN4B1S $T=914500 316400 0 0 $X=914500 $Y=316020
X1449 3193 706 688 2 3185 1 3178 AN4B1S $T=925040 225680 0 180 $X=920700 $Y=220260
X1450 3085 3179 601 2 640 1 3195 AN4B1S $T=921320 255920 1 0 $X=921320 $Y=250500
X1451 3215 2967 3117 2 2791 1 3168 AN4B1S $T=926280 225680 1 180 $X=921940 $Y=225300
X1452 3209 3176 3188 2 3190 1 3180 AN4B1S $T=926900 296240 1 180 $X=922560 $Y=295860
X1453 3117 708 3112 2 3027 1 3214 AN4B1S $T=928140 235760 1 0 $X=928140 $Y=230340
X1454 2967 3193 2825 2 714 1 3219 AN4B1S $T=928140 235760 0 0 $X=928140 $Y=235380
X1455 3202 3208 3207 2 3212 1 753 AN4B1S $T=928140 286160 0 0 $X=928140 $Y=285780
X1456 3233 3229 2847 2 3226 1 754 AN4B1S $T=938680 225680 1 180 $X=934340 $Y=225300
X1457 685 708 2739 2 3224 1 3237 AN4B1S $T=942400 235760 1 180 $X=938060 $Y=235380
X1458 692 3241 3031 2 2889 1 3252 AN4B1S $T=939920 245840 0 0 $X=939920 $Y=245460
X1459 2963 655 2892 2 760 1 3253 AN4B1S $T=939920 286160 1 0 $X=939920 $Y=280740
X1460 3240 3243 3247 2 3250 1 3049 AN4B1S $T=940540 286160 0 0 $X=940540 $Y=285780
X1461 608 3241 3223 2 2791 1 3251 AN4B1S $T=947360 266000 0 180 $X=943020 $Y=260580
X1462 3268 3262 3259 2 3204 1 2944 AN4B1S $T=950460 286160 0 180 $X=946120 $Y=280740
X1463 3127 763 3260 2 3263 1 2900 AN4B1S $T=946120 306320 0 0 $X=946120 $Y=305940
X1464 3275 3159 2880 2 3048 1 3261 AN4B1S $T=952320 235760 1 180 $X=947980 $Y=235380
X1465 3275 706 2893 2 3199 1 3249 AN4B1S $T=952940 245840 1 0 $X=952940 $Y=240420
X1466 669 3148 685 2 3124 1 3273 AN4B1S $T=957280 245840 1 180 $X=952940 $Y=245460
X1467 3270 3034 3112 2 3056 1 3274 AN4B1S $T=953560 276080 1 0 $X=953560 $Y=270660
X1468 3283 3279 3277 2 3248 1 2831 AN4B1S $T=957900 296240 1 180 $X=953560 $Y=295860
X1469 3287 769 3282 2 3267 1 767 AN4B1S $T=959140 316400 1 180 $X=954800 $Y=316020
X1470 3272 3281 768 2 3284 1 2750 AN4B1S $T=955420 286160 1 0 $X=955420 $Y=280740
X1471 3148 3034 3122 2 2854 1 3278 AN4B1S $T=956040 266000 0 0 $X=956040 $Y=265620
X1472 701 3215 3241 2 3089 1 3294 AN4B1S $T=961000 255920 1 0 $X=961000 $Y=250500
X1473 3022 701 2825 2 2854 1 3296 AN4B1S $T=967820 276080 0 180 $X=963480 $Y=270660
X1474 3022 688 3307 2 3134 1 3314 AN4B1S $T=969680 255920 1 0 $X=969680 $Y=250500
X1475 3022 752 3152 2 3199 1 3315 AN4B1S $T=970300 245840 0 0 $X=970300 $Y=245460
X1476 688 3230 3170 2 3134 1 3297 AN4B1S $T=974020 255920 0 0 $X=974020 $Y=255540
X1477 20 883 27 936 2 1 953 OA22 $T=231880 306320 1 0 $X=231880 $Y=300900
X1478 1047 942 1031 941 2 1 1066 OA22 $T=256680 255920 0 0 $X=256680 $Y=255540
X1479 1072 21 100 91 2 1 1023 OA22 $T=262260 306320 0 180 $X=257920 $Y=300900
X1480 1053 16 58 82 2 1 112 OA22 $T=261640 316400 0 0 $X=261640 $Y=316020
X1481 41 1186 49 153 2 1 1200 OA22 $T=291400 316400 1 0 $X=291400 $Y=310980
X1482 57 909 1130 942 2 1 1152 OA22 $T=314340 296240 1 180 $X=310000 $Y=295860
X1483 1817 1813 1800 1802 2 1 1796 OA22 $T=514600 266000 1 180 $X=510260 $Y=265620
X1484 1913 1802 1900 1880 2 1 1855 OA22 $T=530720 255920 1 180 $X=526380 $Y=255540
X1485 313 1973 357 1981 2 1 2019 OA22 $T=543740 286160 1 0 $X=543740 $Y=280740
X1486 2063 1809 403 1965 2 1 2078 OA22 $T=561720 276080 0 0 $X=561720 $Y=275700
X1487 336 2129 348 2126 2 1 2119 OA22 $T=579700 286160 0 180 $X=575360 $Y=280740
X1488 2217 1911 394 453 2 1 2172 OA22 $T=599540 286160 1 180 $X=595200 $Y=285780
X1489 650 725 2883 2880 2 1 3098 OA22 $T=900860 286160 1 180 $X=896520 $Y=285780
X1490 605 3024 728 642 2 1 3127 OA22 $T=900240 306320 1 0 $X=900240 $Y=300900
X1491 3115 613 728 730 2 1 3139 OA22 $T=902100 316400 0 0 $X=902100 $Y=316020
X1492 734 3146 2939 3142 2 1 3137 OA22 $T=910780 296240 1 180 $X=906440 $Y=295860
X1493 654 2967 672 3159 2 1 3156 OA22 $T=911400 235760 0 0 $X=911400 $Y=235380
X1494 611 3189 663 3217 2 1 2991 OA22 $T=934340 316400 1 180 $X=930000 $Y=316020
X1495 712 3217 658 3205 2 1 759 OA22 $T=936820 316400 0 0 $X=936820 $Y=316020
X1496 686 751 663 3266 2 1 3260 OA22 $T=946740 316400 1 0 $X=946740 $Y=310980
X1497 874 2 886 878 1 NR2 $T=221340 296240 1 0 $X=221340 $Y=290820
X1498 887 2 12 873 1 NR2 $T=223200 296240 1 180 $X=221340 $Y=295860
X1499 879 2 34 23 1 NR2 $T=224440 286160 1 0 $X=224440 $Y=280740
X1500 896 2 897 901 1 NR2 $T=225680 266000 1 0 $X=225680 $Y=260580
X1501 30 2 889 25 1 NR2 $T=228160 255920 1 180 $X=226300 $Y=255540
X1502 890 2 910 906 1 NR2 $T=228160 245840 0 0 $X=228160 $Y=245460
X1503 890 2 925 871 1 NR2 $T=230020 255920 1 180 $X=228160 $Y=255540
X1504 890 2 36 23 1 NR2 $T=229400 255920 1 0 $X=229400 $Y=250500
X1505 951 2 919 915 1 NR2 $T=231880 296240 0 180 $X=230020 $Y=290820
X1506 890 2 916 921 1 NR2 $T=231880 296240 1 180 $X=230020 $Y=295860
X1507 926 2 929 25 1 NR2 $T=231260 276080 0 0 $X=231260 $Y=275700
X1508 926 2 936 934 1 NR2 $T=231260 286160 0 0 $X=231260 $Y=285780
X1509 45 2 883 39 1 NR2 $T=233120 316400 1 180 $X=231260 $Y=316020
X1510 50 2 949 930 1 NR2 $T=236220 266000 0 180 $X=234360 $Y=260580
X1511 926 2 952 890 1 NR2 $T=234360 276080 0 0 $X=234360 $Y=275700
X1512 957 2 958 901 1 NR2 $T=236840 255920 0 180 $X=234980 $Y=250500
X1513 934 2 51 890 1 NR2 $T=234980 296240 0 0 $X=234980 $Y=295860
X1514 946 2 960 890 1 NR2 $T=238080 296240 0 180 $X=236220 $Y=290820
X1515 962 2 963 968 1 NR2 $T=236840 306320 1 0 $X=236840 $Y=300900
X1516 1007 2 988 983 1 NR2 $T=243660 286160 0 180 $X=241800 $Y=280740
X1517 990 2 939 985 1 NR2 $T=244280 245840 1 180 $X=242420 $Y=245460
X1518 969 2 984 994 1 NR2 $T=244280 276080 0 0 $X=244280 $Y=275700
X1519 76 2 17 77 1 NR2 $T=246140 296240 0 0 $X=246140 $Y=295860
X1520 969 2 935 94 1 NR2 $T=247380 276080 0 0 $X=247380 $Y=275700
X1521 969 2 976 77 1 NR2 $T=247380 296240 1 0 $X=247380 $Y=290820
X1522 980 2 1011 990 1 NR2 $T=248620 235760 1 0 $X=248620 $Y=230340
X1523 23 2 1018 1004 1 NR2 $T=251720 286160 0 180 $X=249860 $Y=280740
X1524 1004 2 1028 1030 1 NR2 $T=252340 255920 1 0 $X=252340 $Y=250500
X1525 93 2 1035 86 1 NR2 $T=253580 316400 0 0 $X=253580 $Y=316020
X1526 1044 2 1022 76 1 NR2 $T=257300 266000 1 180 $X=255440 $Y=265620
X1527 87 2 933 879 1 NR2 $T=255440 276080 0 0 $X=255440 $Y=275700
X1528 969 2 1051 890 1 NR2 $T=257300 286160 0 0 $X=257300 $Y=285780
X1529 15 2 1053 52 1 NR2 $T=259160 296240 1 180 $X=257300 $Y=295860
X1530 1014 2 1077 96 1 NR2 $T=259160 245840 1 0 $X=259160 $Y=240420
X1531 890 2 1067 77 1 NR2 $T=259780 276080 1 0 $X=259780 $Y=270660
X1532 926 2 982 106 1 NR2 $T=261640 276080 1 0 $X=261640 $Y=270660
X1533 980 2 1093 1060 1 NR2 $T=267840 235760 0 180 $X=265980 $Y=230340
X1534 951 2 1101 1056 1 NR2 $T=265980 245840 1 0 $X=265980 $Y=240420
X1535 1096 2 1061 1100 1 NR2 $T=267840 255920 1 0 $X=267840 $Y=250500
X1536 878 2 1092 50 1 NR2 $T=270320 245840 0 0 $X=270320 $Y=245460
X1537 878 2 950 1100 1 NR2 $T=272800 266000 0 180 $X=270940 $Y=260580
X1538 930 2 118 76 1 NR2 $T=271560 286160 1 0 $X=271560 $Y=280740
X1539 1096 2 1117 969 1 NR2 $T=272180 255920 1 0 $X=272180 $Y=250500
X1540 96 2 1039 1120 1 NR2 $T=272800 276080 1 0 $X=272800 $Y=270660
X1541 1096 2 1073 1127 1 NR2 $T=274040 255920 1 0 $X=274040 $Y=250500
X1542 130 2 1109 1097 1 NR2 $T=275900 235760 1 0 $X=275900 $Y=230340
X1543 946 2 995 1127 1 NR2 $T=275900 255920 1 0 $X=275900 $Y=250500
X1544 1097 2 1020 77 1 NR2 $T=277760 286160 0 180 $X=275900 $Y=280740
X1545 1096 2 881 1139 1 NR2 $T=277760 266000 0 0 $X=277760 $Y=265620
X1546 934 2 1105 94 1 NR2 $T=277760 286160 1 0 $X=277760 $Y=280740
X1547 134 2 47 106 1 NR2 $T=279620 306320 0 0 $X=279620 $Y=305940
X1548 1015 2 1143 106 1 NR2 $T=280240 276080 0 0 $X=280240 $Y=275700
X1549 1097 2 954 879 1 NR2 $T=280240 286160 1 0 $X=280240 $Y=280740
X1550 878 2 986 1139 1 NR2 $T=280860 255920 1 0 $X=280860 $Y=250500
X1551 1146 2 140 878 1 NR2 $T=282720 296240 0 180 $X=280860 $Y=290820
X1552 1158 2 142 890 1 NR2 $T=284580 235760 1 180 $X=282720 $Y=235380
X1553 1044 2 1155 1156 1 NR2 $T=282720 245840 1 0 $X=282720 $Y=240420
X1554 878 2 1153 25 1 NR2 $T=282720 296240 0 0 $X=282720 $Y=295860
X1555 1044 2 1151 879 1 NR2 $T=283960 266000 0 0 $X=283960 $Y=265620
X1556 1139 2 1161 934 1 NR2 $T=285200 286160 0 0 $X=285200 $Y=285780
X1557 1168 2 1142 1178 1 NR2 $T=287680 245840 0 0 $X=287680 $Y=245460
X1558 77 2 1167 934 1 NR2 $T=289540 286160 0 180 $X=287680 $Y=280740
X1559 87 2 1091 30 1 NR2 $T=290780 266000 0 0 $X=290780 $Y=265620
X1560 130 2 1034 1194 1 NR2 $T=293260 225680 0 0 $X=293260 $Y=225300
X1561 1194 2 1180 906 1 NR2 $T=295120 245840 0 180 $X=293260 $Y=240420
X1562 926 2 1198 23 1 NR2 $T=295120 276080 0 180 $X=293260 $Y=270660
X1563 25 2 1196 934 1 NR2 $T=295120 286160 1 0 $X=295120 $Y=280740
X1564 157 2 1199 93 1 NR2 $T=297600 316400 1 180 $X=295740 $Y=316020
X1565 1139 2 1205 974 1 NR2 $T=298220 255920 0 180 $X=296360 $Y=250500
X1566 158 2 1207 1146 1 NR2 $T=298220 255920 0 0 $X=298220 $Y=255540
X1567 1218 2 1214 1146 1 NR2 $T=303180 235760 0 180 $X=301320 $Y=230340
X1568 1146 2 1170 1158 1 NR2 $T=301320 235760 0 0 $X=301320 $Y=235380
X1569 1139 2 1215 1168 1 NR2 $T=305040 245840 1 0 $X=305040 $Y=240420
X1570 1164 2 920 1097 1 NR2 $T=306900 266000 1 180 $X=305040 $Y=265620
X1571 30 2 945 106 1 NR2 $T=306900 286160 0 180 $X=305040 $Y=280740
X1572 1168 2 1130 1097 1 NR2 $T=306280 235760 0 0 $X=306280 $Y=235380
X1573 1127 2 1233 1156 1 NR2 $T=306280 255920 0 0 $X=306280 $Y=255540
X1574 1056 2 1186 1139 1 NR2 $T=307520 245840 1 0 $X=307520 $Y=240420
X1575 50 2 1183 1097 1 NR2 $T=309380 276080 1 180 $X=307520 $Y=275700
X1576 1100 2 1163 50 1 NR2 $T=310620 255920 1 180 $X=308760 $Y=255540
X1577 926 2 1240 1100 1 NR2 $T=310620 276080 0 0 $X=310620 $Y=275700
X1578 1082 2 1239 1120 1 NR2 $T=311860 286160 1 0 $X=311860 $Y=280740
X1579 930 2 1251 1261 1 NR2 $T=314960 266000 0 0 $X=314960 $Y=265620
X1580 106 2 1027 94 1 NR2 $T=314960 306320 1 0 $X=314960 $Y=300900
X1581 1100 2 1189 1097 1 NR2 $T=318680 235760 0 180 $X=316820 $Y=230340
X1582 1264 2 1174 1097 1 NR2 $T=318680 245840 1 180 $X=316820 $Y=245460
X1583 1261 2 1046 1264 1 NR2 $T=316820 266000 1 0 $X=316820 $Y=260580
X1584 94 2 1263 1139 1 NR2 $T=319300 296240 1 180 $X=317440 $Y=295860
X1585 1178 2 1236 1164 1 NR2 $T=322400 245840 1 180 $X=320540 $Y=245460
X1586 203 2 1302 205 1 NR2 $T=337280 306320 0 0 $X=337280 $Y=305940
X1587 1311 2 899 1305 1 NR2 $T=338520 276080 1 0 $X=338520 $Y=270660
X1588 209 2 1301 205 1 NR2 $T=341000 306320 0 0 $X=341000 $Y=305940
X1589 207 2 191 200 1 NR2 $T=341000 316400 0 0 $X=341000 $Y=316020
X1590 212 2 1315 205 1 NR2 $T=344100 306320 0 180 $X=342240 $Y=300900
X1591 210 2 1312 205 1 NR2 $T=342860 296240 0 0 $X=342860 $Y=295860
X1592 208 2 211 214 1 NR2 $T=349060 316400 1 180 $X=347200 $Y=316020
X1593 217 2 1318 214 1 NR2 $T=349680 276080 1 180 $X=347820 $Y=275700
X1594 216 2 1328 199 1 NR2 $T=347820 306320 1 0 $X=347820 $Y=300900
X1595 1337 2 1325 205 1 NR2 $T=352780 296240 1 180 $X=350920 $Y=295860
X1596 198 2 1344 219 1 NR2 $T=352780 306320 1 0 $X=352780 $Y=300900
X1597 1337 2 1316 216 1 NR2 $T=352780 306320 0 0 $X=352780 $Y=305940
X1598 1317 2 1382 1384 1 NR2 $T=365800 276080 0 0 $X=365800 $Y=275700
X1599 243 2 1482 1486 1 NR2 $T=401140 316400 0 0 $X=401140 $Y=316020
X1600 243 2 1480 1485 1 NR2 $T=401760 306320 0 0 $X=401760 $Y=305940
X1601 243 2 1501 1504 1 NR2 $T=410440 316400 1 0 $X=410440 $Y=310980
X1602 256 2 1531 1529 1 NR2 $T=422220 306320 1 0 $X=422220 $Y=300900
X1603 274 2 273 1615 1 NR2 $T=449500 316400 1 0 $X=449500 $Y=310980
X1604 274 2 1610 276 1 NR2 $T=451360 316400 1 0 $X=451360 $Y=310980
X1605 1622 2 1614 1626 1 NR2 $T=452600 296240 1 0 $X=452600 $Y=290820
X1606 274 2 1628 280 1 NR2 $T=454460 316400 1 0 $X=454460 $Y=310980
X1607 1619 2 1622 276 1 NR2 $T=457560 296240 0 0 $X=457560 $Y=295860
X1608 284 2 1636 1619 1 NR2 $T=463140 306320 0 180 $X=461280 $Y=300900
X1609 301 2 1688 297 1 NR2 $T=481740 306320 0 180 $X=479880 $Y=300900
X1610 1694 2 1693 297 1 NR2 $T=480500 276080 0 0 $X=480500 $Y=275700
X1611 301 2 1690 1685 1 NR2 $T=482360 316400 0 180 $X=480500 $Y=310980
X1612 301 2 1705 1707 1 NR2 $T=487320 306320 1 0 $X=487320 $Y=300900
X1613 1694 2 1701 309 1 NR2 $T=489800 286160 0 0 $X=489800 $Y=285780
X1614 301 2 1711 309 1 NR2 $T=490420 306320 1 0 $X=490420 $Y=300900
X1615 1724 2 1727 1734 1 NR2 $T=499100 255920 0 0 $X=499100 $Y=255540
X1616 1737 2 1754 1743 1 NR2 $T=500960 286160 0 0 $X=500960 $Y=285780
X1617 1774 2 1786 1750 1 NR2 $T=506540 225680 1 180 $X=504680 $Y=225300
X1618 1759 2 1771 1776 1 NR2 $T=505920 266000 1 0 $X=505920 $Y=260580
X1619 1772 2 1760 1781 1 NR2 $T=506540 276080 0 0 $X=506540 $Y=275700
X1620 1774 2 1835 1858 1 NR2 $T=513980 225680 0 0 $X=513980 $Y=225300
X1621 1858 2 1822 1866 1 NR2 $T=520180 225680 0 0 $X=520180 $Y=225300
X1622 1876 2 1873 339 1 NR2 $T=523280 306320 0 180 $X=521420 $Y=300900
X1623 1840 2 1884 1876 1 NR2 $T=524520 296240 1 180 $X=522660 $Y=295860
X1624 1888 2 338 339 1 NR2 $T=524520 316400 0 180 $X=522660 $Y=310980
X1625 352 2 1894 1902 1 NR2 $T=527000 286160 1 0 $X=527000 $Y=280740
X1626 1767 2 1953 1917 1 NR2 $T=529480 245840 0 0 $X=529480 $Y=245460
X1627 1918 2 1891 1909 1 NR2 $T=531340 266000 1 180 $X=529480 $Y=265620
X1628 1924 2 1910 1898 1 NR2 $T=531960 276080 0 180 $X=530100 $Y=270660
X1629 1923 2 1916 1881 1 NR2 $T=533200 235760 1 180 $X=531340 $Y=235380
X1630 1890 2 1899 1937 1 NR2 $T=534440 276080 1 0 $X=534440 $Y=270660
X1631 1881 2 1940 1925 1 NR2 $T=535680 245840 1 0 $X=535680 $Y=240420
X1632 1955 2 1949 1917 1 NR2 $T=538780 255920 1 180 $X=536920 $Y=255540
X1633 1806 2 1936 1960 1 NR2 $T=538780 235760 0 0 $X=538780 $Y=235380
X1634 1923 2 1800 1960 1 NR2 $T=538780 245840 1 0 $X=538780 $Y=240420
X1635 386 2 1969 1838 1 NR2 $T=542500 306320 1 180 $X=540640 $Y=305940
X1636 1763 2 1973 1977 1 NR2 $T=541880 245840 1 0 $X=541880 $Y=240420
X1637 1862 2 1933 1960 1 NR2 $T=541880 266000 0 0 $X=541880 $Y=265620
X1638 2008 2 1978 1924 1 NR2 $T=544980 276080 1 180 $X=543120 $Y=275700
X1639 1819 2 1878 1991 1 NR2 $T=544980 225680 1 0 $X=544980 $Y=220260
X1640 1993 2 1811 1819 1 NR2 $T=546840 266000 1 180 $X=544980 $Y=265620
X1641 1819 2 388 1937 1 NR2 $T=544980 276080 1 0 $X=544980 $Y=270660
X1642 1999 2 1945 1977 1 NR2 $T=548700 266000 1 180 $X=546840 $Y=265620
X1643 1918 2 2007 1763 1 NR2 $T=549320 255920 0 180 $X=547460 $Y=250500
X1644 2060 2 2015 1819 1 NR2 $T=551800 225680 0 180 $X=549940 $Y=220260
X1645 2025 2 2021 1806 1 NR2 $T=553040 245840 1 180 $X=551180 $Y=245460
X1646 408 2 1972 406 1 NR2 $T=555520 296240 1 180 $X=553660 $Y=295860
X1647 409 2 349 407 1 NR2 $T=555520 316400 1 180 $X=553660 $Y=316020
X1648 1838 2 2052 402 1 NR2 $T=558620 316400 0 180 $X=556760 $Y=310980
X1649 1888 2 415 412 1 NR2 $T=557380 316400 0 0 $X=557380 $Y=316020
X1650 1991 2 2036 1924 1 NR2 $T=558620 225680 0 0 $X=558620 $Y=225300
X1651 409 2 1981 408 1 NR2 $T=558620 306320 1 0 $X=558620 $Y=300900
X1652 2045 2 1722 2068 1 NR2 $T=561720 235760 1 0 $X=561720 $Y=230340
X1653 2068 2 2058 2111 1 NR2 $T=563580 225680 0 0 $X=563580 $Y=225300
X1654 421 2 1926 1892 1 NR2 $T=566680 266000 0 180 $X=564820 $Y=260580
X1655 1937 2 2066 429 1 NR2 $T=570400 276080 1 0 $X=570400 $Y=270660
X1656 2102 2 1818 2113 1 NR2 $T=571640 266000 0 0 $X=571640 $Y=265620
X1657 1924 2 2103 2111 1 NR2 $T=574120 225680 1 180 $X=572260 $Y=225300
X1658 1937 2 1789 1862 1 NR2 $T=572260 235760 1 0 $X=572260 $Y=230340
X1659 1937 2 1911 1924 1 NR2 $T=572260 235760 0 0 $X=572260 $Y=235380
X1660 1937 2 2116 1977 1 NR2 $T=574120 235760 0 0 $X=574120 $Y=235380
X1661 2124 2 2018 1924 1 NR2 $T=577220 266000 0 180 $X=575360 $Y=260580
X1662 406 2 2108 2118 1 NR2 $T=575360 296240 0 0 $X=575360 $Y=295860
X1663 2121 2 1928 444 1 NR2 $T=575980 316400 0 0 $X=575980 $Y=316020
X1664 1937 2 2128 2096 1 NR2 $T=577220 235760 1 0 $X=577220 $Y=230340
X1665 2136 2 2117 1739 1 NR2 $T=579080 245840 1 180 $X=577220 $Y=245460
X1666 435 2 2129 408 1 NR2 $T=577220 296240 1 0 $X=577220 $Y=290820
X1667 386 2 1966 2138 1 NR2 $T=577220 296240 0 0 $X=577220 $Y=295860
X1668 2138 2 2120 1838 1 NR2 $T=579080 306320 1 0 $X=579080 $Y=300900
X1669 412 2 2143 390 1 NR2 $T=581560 296240 1 180 $X=579700 $Y=295860
X1670 2141 2 1864 2146 1 NR2 $T=580320 245840 1 0 $X=580320 $Y=240420
X1671 2141 2 1947 2124 1 NR2 $T=582800 235760 1 180 $X=580940 $Y=235380
X1672 2082 2 2145 1843 1 NR2 $T=580940 276080 1 0 $X=580940 $Y=270660
X1673 446 2 2150 2136 1 NR2 $T=584040 245840 1 180 $X=582180 $Y=245460
X1674 1776 2 2152 1782 1 NR2 $T=582180 266000 0 0 $X=582180 $Y=265620
X1675 411 2 2153 1838 1 NR2 $T=584040 306320 1 180 $X=582180 $Y=305940
X1676 2138 2 449 411 1 NR2 $T=582180 316400 0 0 $X=582180 $Y=316020
X1677 1721 2 1907 2146 1 NR2 $T=584040 235760 0 0 $X=584040 $Y=235380
X1678 407 2 2169 412 1 NR2 $T=585900 306320 1 0 $X=585900 $Y=300900
X1679 2141 2 2162 2096 1 NR2 $T=587760 235760 0 0 $X=587760 $Y=235380
X1680 2157 2 2061 427 1 NR2 $T=587760 255920 0 0 $X=587760 $Y=255540
X1681 435 2 447 412 1 NR2 $T=587760 316400 0 0 $X=587760 $Y=316020
X1682 2082 2 2171 2183 1 NR2 $T=589000 225680 1 0 $X=589000 $Y=220260
X1683 2146 2 1979 2183 1 NR2 $T=589000 235760 1 0 $X=589000 $Y=230340
X1684 412 2 2189 413 1 NR2 $T=589000 306320 1 0 $X=589000 $Y=300900
X1685 2082 2 2185 1892 1 NR2 $T=590860 255920 0 0 $X=590860 $Y=255540
X1686 2092 2 2202 1782 1 NR2 $T=592720 266000 1 0 $X=592720 $Y=260580
X1687 1977 2 2168 2008 1 NR2 $T=594580 266000 1 180 $X=592720 $Y=265620
X1688 448 2 2203 2211 1 NR2 $T=595820 316400 1 0 $X=595820 $Y=310980
X1689 2141 2 2198 1977 1 NR2 $T=597060 245840 1 0 $X=597060 $Y=240420
X1690 2096 2 2212 1862 1 NR2 $T=597680 235760 1 0 $X=597680 $Y=230340
X1691 2138 2 2211 399 1 NR2 $T=597680 316400 1 0 $X=597680 $Y=310980
X1692 1924 2 1935 446 1 NR2 $T=599540 225680 0 0 $X=599540 $Y=225300
X1693 1862 2 2086 2227 1 NR2 $T=599540 235760 0 0 $X=599540 $Y=235380
X1694 390 2 2233 409 1 NR2 $T=602640 316400 1 180 $X=600780 $Y=316020
X1695 409 2 457 413 1 NR2 $T=601400 316400 1 0 $X=601400 $Y=310980
X1696 413 2 2244 339 1 NR2 $T=605120 296240 1 180 $X=603260 $Y=295860
X1697 1977 2 2228 2235 1 NR2 $T=604500 235760 1 0 $X=604500 $Y=230340
X1698 2124 2 1726 1977 1 NR2 $T=604500 235760 0 0 $X=604500 $Y=235380
X1699 1977 2 2242 1923 1 NR2 $T=606360 245840 0 180 $X=604500 $Y=240420
X1700 1960 2 2048 1892 1 NR2 $T=606980 266000 0 180 $X=605120 $Y=260580
X1701 2096 2 1997 1960 1 NR2 $T=606360 225680 0 0 $X=606360 $Y=225300
X1702 1925 2 2253 1960 1 NR2 $T=607600 245840 0 0 $X=607600 $Y=245460
X1703 2227 2 2261 2025 1 NR2 $T=610080 235760 1 180 $X=608220 $Y=235380
X1704 446 2 2262 1999 1 NR2 $T=608840 316400 1 0 $X=608840 $Y=310980
X1705 1960 2 2267 2002 1 NR2 $T=609460 255920 1 0 $X=609460 $Y=250500
X1706 2227 2 2265 1843 1 NR2 $T=613180 276080 0 180 $X=611320 $Y=270660
X1707 2002 2 2184 2008 1 NR2 $T=612560 266000 1 0 $X=612560 $Y=260580
X1708 2045 2 2245 1960 1 NR2 $T=616900 225680 0 180 $X=615040 $Y=220260
X1709 1843 2 2051 2002 1 NR2 $T=615040 286160 1 0 $X=615040 $Y=280740
X1710 464 2 1893 427 1 NR2 $T=618140 306320 0 0 $X=618140 $Y=305940
X1711 1892 2 455 446 1 NR2 $T=619380 266000 1 0 $X=619380 $Y=260580
X1712 353 2 2217 395 1 NR2 $T=621860 286160 0 0 $X=621860 $Y=285780
X1713 421 2 2264 471 1 NR2 $T=624340 235760 1 180 $X=622480 $Y=235380
X1714 2292 2 2270 2096 1 NR2 $T=623100 245840 1 0 $X=623100 $Y=240420
X1715 2292 2 2246 446 1 NR2 $T=623100 255920 1 0 $X=623100 $Y=250500
X1716 2124 2 2290 1770 1 NR2 $T=624960 266000 0 180 $X=623100 $Y=260580
X1717 2124 2 2167 1999 1 NR2 $T=626820 266000 0 0 $X=626820 $Y=265620
X1718 2124 2 2238 2002 1 NR2 $T=628060 266000 1 0 $X=628060 $Y=260580
X1719 2008 2 2192 1999 1 NR2 $T=628680 266000 0 0 $X=628680 $Y=265620
X1720 427 2 2044 1999 1 NR2 $T=628680 286160 0 0 $X=628680 $Y=285780
X1721 477 2 485 200 1 NR2 $T=631780 316400 0 0 $X=631780 $Y=316020
X1722 1721 2 2302 1924 1 NR2 $T=633020 286160 1 0 $X=633020 $Y=280740
X1723 1924 2 2304 2002 1 NR2 $T=638600 255920 0 180 $X=636740 $Y=250500
X1724 490 2 2308 488 1 NR2 $T=636740 306320 0 0 $X=636740 $Y=305940
X1725 2292 2 2126 2008 1 NR2 $T=642320 266000 1 180 $X=640460 $Y=265620
X1726 494 2 2321 488 1 NR2 $T=641700 316400 1 0 $X=641700 $Y=310980
X1727 498 2 2312 497 1 NR2 $T=643560 316400 1 180 $X=641700 $Y=316020
X1728 2292 2 2155 429 1 NR2 $T=643560 235760 0 0 $X=643560 $Y=235380
X1729 2292 2 2288 427 1 NR2 $T=643560 255920 0 0 $X=643560 $Y=255540
X1730 2292 2 2322 1924 1 NR2 $T=643560 266000 0 0 $X=643560 $Y=265620
X1731 495 2 2319 493 1 NR2 $T=646040 306320 0 180 $X=644180 $Y=300900
X1732 471 2 2323 429 1 NR2 $T=647280 245840 0 180 $X=645420 $Y=240420
X1733 429 2 2250 2008 1 NR2 $T=647280 255920 0 180 $X=645420 $Y=250500
X1734 1924 2 2218 2327 1 NR2 $T=645420 255920 0 0 $X=645420 $Y=255540
X1735 498 2 2325 488 1 NR2 $T=645420 316400 1 0 $X=645420 $Y=310980
X1736 481 2 2328 491 1 NR2 $T=649140 306320 1 180 $X=647280 $Y=305940
X1737 499 2 2329 488 1 NR2 $T=649140 316400 0 180 $X=647280 $Y=310980
X1738 471 2 2038 427 1 NR2 $T=651000 255920 1 180 $X=649140 $Y=255540
X1739 497 2 2320 482 1 NR2 $T=652240 306320 1 180 $X=650380 $Y=305940
X1740 525 2 2456 2464 1 NR2 $T=699980 306320 1 0 $X=699980 $Y=300900
X1741 525 2 2460 2463 1 NR2 $T=699980 306320 0 0 $X=699980 $Y=305940
X1742 525 2 2486 2489 1 NR2 $T=708660 306320 0 0 $X=708660 $Y=305940
X1743 2499 2 531 526 1 NR2 $T=711760 316400 1 180 $X=709900 $Y=316020
X1744 2497 2 2458 2494 1 NR2 $T=711760 296240 0 0 $X=711760 $Y=295860
X1745 558 2 2598 2604 1 NR2 $T=757640 306320 1 0 $X=757640 $Y=300900
X1746 558 2 2597 2616 1 NR2 $T=761980 306320 1 0 $X=761980 $Y=300900
X1747 558 2 2614 2607 1 NR2 $T=763220 286160 0 0 $X=763220 $Y=285780
X1748 558 2 2621 2629 1 NR2 $T=764460 296240 1 0 $X=764460 $Y=290820
X1749 567 2 2636 2634 1 NR2 $T=771280 296240 1 180 $X=769420 $Y=295860
X1750 2638 2 2625 2645 1 NR2 $T=770040 286160 1 0 $X=770040 $Y=280740
X1751 2634 2 2649 2607 1 NR2 $T=773140 286160 1 180 $X=771280 $Y=285780
X1752 2667 2 2680 2662 1 NR2 $T=784920 276080 1 0 $X=784920 $Y=270660
X1753 577 2 2689 2674 1 NR2 $T=791740 306320 1 180 $X=789880 $Y=305940
X1754 577 2 2700 2676 1 NR2 $T=794220 296240 0 180 $X=792360 $Y=290820
X1755 577 2 2706 576 1 NR2 $T=795460 306320 0 180 $X=793600 $Y=300900
X1756 2695 2 2701 2671 1 NR2 $T=794220 266000 0 0 $X=794220 $Y=265620
X1757 577 2 2711 2695 1 NR2 $T=794840 296240 1 0 $X=794840 $Y=290820
X1758 2736 2 2762 2741 1 NR2 $T=815920 255920 1 0 $X=815920 $Y=250500
X1759 2769 2 2758 600 1 NR2 $T=822120 245840 0 180 $X=820260 $Y=240420
X1760 2797 2 2771 2787 1 NR2 $T=827700 255920 1 180 $X=825840 $Y=255540
X1761 620 2 2788 605 1 NR2 $T=827700 266000 1 180 $X=825840 $Y=265620
X1762 2805 2 2809 2800 1 NR2 $T=829560 286160 0 180 $X=827700 $Y=280740
X1763 2830 2 2808 605 1 NR2 $T=830800 276080 0 180 $X=828940 $Y=270660
X1764 2829 2 2804 2837 1 NR2 $T=832660 235760 1 0 $X=832660 $Y=230340
X1765 2778 2 2885 2848 1 NR2 $T=834520 225680 0 0 $X=834520 $Y=225300
X1766 630 2 2814 605 1 NR2 $T=834520 276080 1 0 $X=834520 $Y=270660
X1767 618 2 2782 2854 1 NR2 $T=835760 245840 1 0 $X=835760 $Y=240420
X1768 2799 2 2844 605 1 NR2 $T=835760 266000 0 0 $X=835760 $Y=265620
X1769 2838 2 2845 605 1 NR2 $T=836380 266000 1 0 $X=836380 $Y=260580
X1770 641 2 2846 644 1 NR2 $T=839480 306320 0 0 $X=839480 $Y=305940
X1771 640 2 2894 618 1 NR2 $T=843200 235760 1 0 $X=843200 $Y=230340
X1772 646 2 2850 605 1 NR2 $T=844440 266000 0 0 $X=844440 $Y=265620
X1773 2793 2 2892 2820 1 NR2 $T=844440 276080 1 0 $X=844440 $Y=270660
X1774 2908 2 2767 653 1 NR2 $T=848160 235760 0 180 $X=846300 $Y=230340
X1775 656 2 2784 653 1 NR2 $T=848160 245840 1 180 $X=846300 $Y=245460
X1776 2853 2 2902 2791 1 NR2 $T=846920 225680 0 0 $X=846920 $Y=225300
X1777 2865 2 2840 666 1 NR2 $T=848160 255920 1 0 $X=848160 $Y=250500
X1778 2910 2 2895 657 1 NR2 $T=850020 276080 1 180 $X=848160 $Y=275700
X1779 2915 2 2930 2929 1 NR2 $T=851260 266000 0 0 $X=851260 $Y=265620
X1780 672 2 2922 605 1 NR2 $T=852500 276080 1 0 $X=852500 $Y=270660
X1781 2914 2 674 670 1 NR2 $T=853120 316400 0 0 $X=853120 $Y=316020
X1782 640 2 2967 656 1 NR2 $T=857460 245840 1 180 $X=855600 $Y=245460
X1783 2946 2 665 2853 1 NR2 $T=858080 266000 0 180 $X=856220 $Y=260580
X1784 2908 2 2952 2978 1 NR2 $T=861800 235760 0 0 $X=861800 $Y=235380
X1785 602 2 2976 605 1 NR2 $T=861800 266000 0 0 $X=861800 $Y=265620
X1786 640 2 2896 2989 1 NR2 $T=864280 235760 0 0 $X=864280 $Y=235380
X1787 609 2 2987 605 1 NR2 $T=867380 266000 0 0 $X=867380 $Y=265620
X1788 2853 2 2963 2989 1 NR2 $T=869240 255920 1 0 $X=869240 $Y=250500
X1789 3005 2 2937 3010 1 NR2 $T=870480 266000 0 0 $X=870480 $Y=265620
X1790 3000 2 3007 2889 1 NR2 $T=872340 235760 1 0 $X=872340 $Y=230340
X1791 3000 2 708 619 1 NR2 $T=875440 245840 1 0 $X=875440 $Y=240420
X1792 2744 2 3017 605 1 NR2 $T=875440 276080 0 0 $X=875440 $Y=275700
X1793 3027 2 704 2865 1 NR2 $T=879780 235760 0 180 $X=877920 $Y=230340
X1794 3036 2 2899 2791 1 NR2 $T=881020 255920 0 180 $X=879160 $Y=250500
X1795 3041 2 2775 605 1 NR2 $T=881640 276080 0 180 $X=879780 $Y=270660
X1796 654 2 3037 605 1 NR2 $T=881640 266000 0 0 $X=881640 $Y=265620
X1797 3048 2 3006 2889 1 NR2 $T=884120 255920 1 180 $X=882260 $Y=255540
X1798 3050 2 2866 3067 1 NR2 $T=883500 316400 1 0 $X=883500 $Y=310980
X1799 618 2 3063 2989 1 NR2 $T=884120 225680 0 0 $X=884120 $Y=225300
X1800 2865 2 3057 2793 1 NR2 $T=884120 266000 0 0 $X=884120 $Y=265620
X1801 3000 2 3072 3056 1 NR2 $T=889080 255920 0 0 $X=889080 $Y=255540
X1802 3084 2 3013 2855 1 NR2 $T=894040 235760 0 180 $X=892180 $Y=230340
X1803 3089 2 2739 2989 1 NR2 $T=894040 235760 1 180 $X=892180 $Y=235380
X1804 2793 2 3074 2989 1 NR2 $T=892180 245840 1 0 $X=892180 $Y=240420
X1805 3089 2 3060 2978 1 NR2 $T=897140 245840 0 180 $X=895280 $Y=240420
X1806 3100 2 3051 3076 1 NR2 $T=897760 225680 0 180 $X=895900 $Y=220260
X1807 684 2 723 680 1 NR2 $T=895900 316400 0 0 $X=895900 $Y=316020
X1808 3119 2 2826 3102 1 NR2 $T=899000 296240 1 180 $X=897140 $Y=295860
X1809 641 2 3115 684 1 NR2 $T=899000 316400 0 0 $X=899000 $Y=316020
X1810 2884 2 3096 2819 1 NR2 $T=902720 266000 1 0 $X=902720 $Y=260580
X1811 2989 2 3131 2819 1 NR2 $T=907680 266000 1 180 $X=905820 $Y=265620
X1812 666 2 3120 2819 1 NR2 $T=909540 255920 1 180 $X=907680 $Y=255540
X1813 2989 2 3143 2820 1 NR2 $T=907680 266000 0 0 $X=907680 $Y=265620
X1814 2908 2 3125 3149 1 NR2 $T=908920 255920 1 0 $X=908920 $Y=250500
X1815 3134 2 3155 2878 1 NR2 $T=912640 255920 0 180 $X=910780 $Y=250500
X1816 625 2 3146 670 1 NR2 $T=912640 316400 0 180 $X=910780 $Y=310980
X1817 3149 2 3157 3026 1 NR2 $T=914500 276080 1 180 $X=912640 $Y=275700
X1818 678 2 3144 680 1 NR2 $T=913260 316400 1 0 $X=913260 $Y=310980
X1819 714 2 3169 2791 1 NR2 $T=916360 235760 0 0 $X=916360 $Y=235380
X1820 2820 2 2893 3149 1 NR2 $T=918220 266000 0 180 $X=916360 $Y=260580
X1821 2865 2 3085 2820 1 NR2 $T=917600 255920 1 0 $X=917600 $Y=250500
X1822 714 2 2983 671 1 NR2 $T=919460 235760 0 0 $X=919460 $Y=235380
X1823 3048 2 3182 2884 1 NR2 $T=921320 245840 1 0 $X=921320 $Y=240420
X1824 3089 2 3179 3000 1 NR2 $T=922560 245840 0 0 $X=922560 $Y=245460
X1825 648 2 3189 3037 1 NR2 $T=924420 316400 1 180 $X=922560 $Y=316020
X1826 3185 2 3030 3084 1 NR2 $T=923180 235760 1 0 $X=923180 $Y=230340
X1827 3084 2 3170 3000 1 NR2 $T=925040 266000 1 180 $X=923180 $Y=265620
X1828 2884 2 3117 714 1 NR2 $T=926280 235760 0 0 $X=926280 $Y=235380
X1829 3200 2 3193 2908 1 NR2 $T=928140 255920 0 180 $X=926280 $Y=250500
X1830 699 2 3210 700 1 NR2 $T=928760 316400 0 180 $X=926900 $Y=310980
X1831 714 2 752 618 1 NR2 $T=929380 276080 1 0 $X=929380 $Y=270660
X1832 3089 2 3070 619 1 NR2 $T=930000 255920 0 0 $X=930000 $Y=255540
X1833 656 2 3220 3134 1 NR2 $T=933100 255920 1 0 $X=933100 $Y=250500
X1834 618 2 3194 3149 1 NR2 $T=933100 266000 0 0 $X=933100 $Y=265620
X1835 699 2 3205 719 1 NR2 $T=935580 306320 1 180 $X=933720 $Y=305940
X1836 2853 2 3215 2820 1 NR2 $T=936200 235760 1 180 $X=934340 $Y=235380
X1837 656 2 3223 671 1 NR2 $T=934960 266000 1 0 $X=934960 $Y=260580
X1838 2853 2 3216 3231 1 NR2 $T=935580 255920 1 0 $X=935580 $Y=250500
X1839 2853 2 3227 3149 1 NR2 $T=936200 276080 1 0 $X=936200 $Y=270660
X1840 621 2 3228 702 1 NR2 $T=936200 306320 0 0 $X=936200 $Y=305940
X1841 726 2 3217 675 1 NR2 $T=938060 316400 0 180 $X=936200 $Y=310980
X1842 640 2 3152 671 1 NR2 $T=938680 245840 0 180 $X=936820 $Y=240420
X1843 666 2 3148 656 1 NR2 $T=936820 245840 0 0 $X=936820 $Y=245460
X1844 758 2 3043 656 1 NR2 $T=938680 266000 0 180 $X=936820 $Y=260580
X1845 3056 2 2832 2884 1 NR2 $T=938060 255920 1 0 $X=938060 $Y=250500
X1846 656 2 2986 2889 1 NR2 $T=939920 245840 1 0 $X=939920 $Y=240420
X1847 666 2 3040 2793 1 NR2 $T=944880 245840 0 180 $X=943020 $Y=240420
X1848 677 2 731 3105 1 NR2 $T=943640 316400 0 0 $X=943640 $Y=316020
X1849 666 2 3031 2791 1 NR2 $T=944260 235760 0 0 $X=944260 $Y=235380
X1850 3242 2 762 3256 1 NR2 $T=944260 306320 0 0 $X=944260 $Y=305940
X1851 656 2 3159 2855 1 NR2 $T=945500 245840 0 0 $X=945500 $Y=245460
X1852 699 2 3257 3105 1 NR2 $T=947360 316400 1 180 $X=945500 $Y=316020
X1853 2819 2 3244 3027 1 NR2 $T=948600 225680 0 180 $X=946740 $Y=220260
X1854 2855 2 3066 3265 1 NR2 $T=948600 286160 0 0 $X=948600 $Y=285780
X1855 2793 2 3269 3129 1 NR2 $T=951080 245840 0 180 $X=949220 $Y=240420
X1856 3089 2 3264 3149 1 NR2 $T=951700 255920 1 180 $X=949840 $Y=255540
X1857 699 2 3266 676 1 NR2 $T=951700 316400 1 0 $X=951700 $Y=310980
X1858 3056 2 3246 2819 1 NR2 $T=953560 266000 0 0 $X=953560 $Y=265620
X1859 3224 2 3275 618 1 NR2 $T=955420 235760 0 0 $X=955420 $Y=235380
X1860 3200 2 3270 618 1 NR2 $T=955420 266000 1 0 $X=955420 $Y=260580
X1861 2884 2 3241 3224 1 NR2 $T=957280 245840 1 0 $X=957280 $Y=240420
X1862 2884 2 3122 2865 1 NR2 $T=957280 255920 1 0 $X=957280 $Y=250500
X1863 618 2 2825 2791 1 NR2 $T=958520 235760 0 0 $X=958520 $Y=235380
X1864 618 2 3280 2855 1 NR2 $T=959140 296240 0 0 $X=959140 $Y=295860
X1865 2791 2 3285 640 1 NR2 $T=962240 235760 0 180 $X=960380 $Y=230340
X1866 3295 2 770 3290 1 NR2 $T=964100 316400 0 180 $X=962240 $Y=310980
X1867 2819 2 3300 2865 1 NR2 $T=965340 266000 1 180 $X=963480 $Y=265620
X1868 2819 2 3230 2791 1 NR2 $T=964100 225680 0 0 $X=964100 $Y=225300
X1869 2791 2 3112 2855 1 NR2 $T=965960 235760 0 180 $X=964100 $Y=230340
X1870 2884 2 3288 3306 1 NR2 $T=964100 296240 1 0 $X=964100 $Y=290820
X1871 619 2 3307 2793 1 NR2 $T=965340 245840 0 0 $X=965340 $Y=245460
X1872 758 2 3299 3306 1 NR2 $T=970920 306320 0 180 $X=969060 $Y=300900
X1873 3325 2 786 3322 1 NR2 $T=989520 316400 1 180 $X=987660 $Y=316020
X1874 405 390 2 343 1 2072 AOI12HS $T=559860 316400 0 0 $X=559860 $Y=316020
X1875 675 641 2 673 1 2911 AOI12HS $T=855600 306320 0 180 $X=851260 $Y=300900
X1876 3280 3152 2 2883 1 3309 AOI12HS $T=967200 296240 0 0 $X=967200 $Y=295860
X1877 10 1052 71 100 2 1 1064 OA112 $T=256060 316400 0 0 $X=256060 $Y=316020
X1878 124 136 1138 942 2 1 1159 OA112 $T=277140 316400 1 0 $X=277140 $Y=310980
X1879 114 1133 975 1065 2 1 1226 OA112 $T=300700 316400 1 0 $X=300700 $Y=310980
X1880 186 1283 57 1102 2 1 1275 OA112 $T=324260 316400 0 0 $X=324260 $Y=316020
X1881 340 1841 1817 333 2 1 1810 OA112 $T=518940 316400 1 180 $X=513980 $Y=316020
X1882 351 1875 1748 1747 2 1 1833 OA112 $T=524520 296240 0 180 $X=519560 $Y=290820
X1883 1930 2003 366 403 2 1 1967 OA112 $T=556760 296240 0 180 $X=551800 $Y=290820
X1884 1983 2072 2040 1802 2 1 2109 OA112 $T=562340 306320 1 0 $X=562340 $Y=300900
X1885 2259 2278 1893 467 2 1 2073 OA112 $T=619380 296240 1 180 $X=614420 $Y=295860
X1886 2259 2296 1817 2062 2 1 2248 OA112 $T=625580 296240 0 0 $X=625580 $Y=295860
X1887 622 2812 615 2799 2 1 2795 OA112 $T=831420 316400 1 180 $X=826460 $Y=316020
X1888 2870 2857 638 634 2 1 2842 OA112 $T=840720 296240 0 180 $X=835760 $Y=290820
X1889 622 645 651 650 2 1 2851 OA112 $T=848160 316400 1 180 $X=843200 $Y=316020
X1890 2921 667 638 663 2 1 2789 OA112 $T=851880 296240 0 180 $X=846920 $Y=290820
X1891 682 2907 658 613 2 1 2932 OA112 $T=859320 286160 1 180 $X=854360 $Y=285780
X1892 3018 3029 668 650 2 1 3033 OA112 $T=877920 306320 1 0 $X=877920 $Y=300900
X1893 2998 3059 638 712 2 1 2909 OA112 $T=887840 306320 1 180 $X=882880 $Y=305940
X1894 3025 3081 638 650 2 1 3099 OA112 $T=892180 296240 0 0 $X=892180 $Y=295860
X1895 3095 3128 3131 3126 2 1 3110 OA112 $T=907680 276080 1 180 $X=902720 $Y=275700
X1896 3181 3191 738 628 2 1 682 OA112 $T=925660 306320 1 180 $X=920700 $Y=305940
X1897 755 3218 3189 688 2 1 3201 OA112 $T=934960 316400 0 180 $X=930000 $Y=310980
X1898 11 886 15 874 2 1 882 MAOI1 $T=226300 286160 1 180 $X=221340 $Y=285780
X1899 1613 1592 1624 232 2 1 1612 MAOI1 $T=450740 286160 1 0 $X=450740 $Y=280740
X1900 346 1899 353 1890 2 1 1848 MAOI1 $T=529480 276080 0 180 $X=524520 $Y=270660
X1901 662 3144 648 3136 2 1 3132 MAOI1 $T=910160 306320 0 180 $X=905200 $Y=300900
X1902 17 1 14 896 2 16 ND3 $T=222580 255920 0 0 $X=222580 $Y=255540
X1903 888 1 899 28 2 32 ND3 $T=225680 296240 1 0 $X=225680 $Y=290820
X1904 886 1 909 915 2 918 ND3 $T=227540 286160 1 0 $X=227540 $Y=280740
X1905 937 1 923 932 2 935 ND3 $T=231260 266000 1 0 $X=231260 $Y=260580
X1906 931 1 956 959 2 44 ND3 $T=235600 245840 0 0 $X=235600 $Y=245460
X1907 935 1 929 965 2 923 ND3 $T=236220 276080 0 0 $X=236220 $Y=275700
X1908 971 1 963 55 2 54 ND3 $T=239320 316400 1 180 $X=236840 $Y=316020
X1909 992 1 988 65 2 64 ND3 $T=244280 286160 1 180 $X=241800 $Y=285780
X1910 913 1 71 62 2 78 ND3 $T=244280 316400 1 0 $X=244280 $Y=310980
X1911 1050 1 88 1045 2 1042 ND3 $T=257920 266000 0 180 $X=255440 $Y=260580
X1912 1036 1 99 1059 2 1063 ND3 $T=258540 276080 0 0 $X=258540 $Y=275700
X1913 1091 1 42 1079 2 1083 ND3 $T=265980 276080 0 180 $X=263500 $Y=270660
X1914 1076 1 1085 109 2 1086 ND3 $T=263500 296240 0 0 $X=263500 $Y=295860
X1915 1109 1 1090 970 2 1065 ND3 $T=267840 225680 1 180 $X=265360 $Y=225300
X1916 1093 1 1092 1070 2 1104 ND3 $T=267220 235760 0 0 $X=267220 $Y=235380
X1917 1057 1 1108 108 2 1114 ND3 $T=269080 306320 0 0 $X=269080 $Y=305940
X1918 1107 1 1111 1055 2 1073 ND3 $T=272180 255920 0 180 $X=269700 $Y=250500
X1919 1130 1 1111 1029 2 1092 ND3 $T=272800 235760 1 180 $X=270320 $Y=235380
X1920 1105 1 918 1121 2 113 ND3 $T=272180 286160 0 0 $X=272180 $Y=285780
X1921 1133 1 1132 1124 2 84 ND3 $T=277760 306320 1 180 $X=275280 $Y=305940
X1922 113 1 81 1140 2 944 ND3 $T=277140 266000 1 0 $X=277140 $Y=260580
X1923 1143 1 34 137 2 881 ND3 $T=279620 276080 1 180 $X=277140 $Y=275700
X1924 17 1 1131 1147 2 1163 ND3 $T=280860 266000 1 0 $X=280860 $Y=260580
X1925 17 1 1138 1148 2 113 ND3 $T=280860 276080 1 0 $X=280860 $Y=270660
X1926 1161 1 47 1135 2 1151 ND3 $T=285200 286160 1 180 $X=282720 $Y=285780
X1927 1193 1 986 990 2 928 ND3 $T=288300 235760 0 180 $X=285820 $Y=230340
X1928 1083 1 1058 1160 2 1105 ND3 $T=288300 276080 0 180 $X=285820 $Y=270660
X1929 1166 1 1170 1150 2 1034 ND3 $T=287060 235760 0 0 $X=287060 $Y=235380
X1930 1170 1 1174 1175 2 1117 ND3 $T=290160 255920 0 180 $X=287680 $Y=250500
X1931 1173 1 1176 1162 2 1159 ND3 $T=290160 316400 1 180 $X=287680 $Y=316020
X1932 113 1 909 1185 2 1177 ND3 $T=295120 286160 1 180 $X=292640 $Y=285780
X1933 1197 1 1195 156 2 1204 ND3 $T=295740 266000 1 0 $X=295740 $Y=260580
X1934 1203 1 1107 1125 2 1207 ND3 $T=297600 235760 0 0 $X=297600 $Y=235380
X1935 1202 1 1200 161 2 162 ND3 $T=297600 316400 0 0 $X=297600 $Y=316020
X1936 1061 1 996 1211 2 1214 ND3 $T=299460 255920 1 0 $X=299460 $Y=250500
X1937 1171 1 88 1225 2 169 ND3 $T=303180 306320 1 0 $X=303180 $Y=300900
X1938 1232 1 945 1228 2 34 ND3 $T=308760 286160 1 180 $X=306280 $Y=285780
X1939 1236 1 944 927 2 1183 ND3 $T=310620 286160 0 180 $X=308140 $Y=280740
X1940 1046 1 1214 1244 2 142 ND3 $T=313720 255920 1 180 $X=311240 $Y=255540
X1941 1130 1 909 1256 2 1075 ND3 $T=313720 255920 1 0 $X=313720 $Y=250500
X1942 954 1 1258 1260 2 1048 ND3 $T=315580 286160 1 0 $X=315580 $Y=280740
X1943 1252 1 1275 184 2 1235 ND3 $T=323640 316400 0 180 $X=321160 $Y=310980
X1944 1073 1 68 1295 2 1237 ND3 $T=328600 235760 1 0 $X=328600 $Y=230340
X1945 976 1 1183 1299 2 34 ND3 $T=331080 286160 1 0 $X=331080 $Y=280740
X1946 204 1 202 975 2 200 ND3 $T=337900 316400 1 180 $X=335420 $Y=316020
X1947 1209 1 1189 1313 2 16 ND3 $T=339140 245840 0 180 $X=336660 $Y=240420
X1948 1209 1 1073 1281 2 1298 ND3 $T=339760 266000 1 180 $X=337280 $Y=265620
X1949 1058 1 81 1308 2 44 ND3 $T=337280 276080 0 0 $X=337280 $Y=275700
X1950 193 1 207 41 2 200 ND3 $T=341000 316400 1 180 $X=338520 $Y=316020
X1951 944 1 44 1296 2 1138 ND3 $T=342240 255920 0 180 $X=339760 $Y=250500
X1952 194 1 207 943 2 200 ND3 $T=342860 316400 0 180 $X=340380 $Y=310980
X1953 205 1 198 68 2 211 ND3 $T=345960 316400 1 180 $X=343480 $Y=316020
X1954 1322 1 216 1090 2 214 ND3 $T=347820 296240 0 180 $X=345340 $Y=290820
X1955 1325 1 1318 996 2 199 ND3 $T=347200 296240 0 0 $X=347200 $Y=295860
X1956 1073 1 981 1339 2 1065 ND3 $T=349060 245840 0 0 $X=349060 $Y=245460
X1957 1322 1 217 1075 2 219 ND3 $T=350920 296240 1 0 $X=350920 $Y=290820
X1958 1322 1 217 944 2 214 ND3 $T=354020 276080 1 180 $X=351540 $Y=275700
X1959 1344 1 217 1111 2 1325 ND3 $T=356500 286160 1 180 $X=354020 $Y=285780
X1960 1344 1 216 1065 2 1325 ND3 $T=356500 296240 1 180 $X=354020 $Y=295860
X1961 1495 1 1492 1458 2 1487 ND3 $T=406720 235760 1 180 $X=404240 $Y=235380
X1962 1572 1 1569 1551 2 1578 ND3 $T=436480 245840 0 180 $X=434000 $Y=240420
X1963 1732 1 1727 1729 2 1720 ND3 $T=499720 266000 0 180 $X=497240 $Y=260580
X1964 1730 1 314 1779 2 1768 ND3 $T=503440 306320 1 0 $X=503440 $Y=300900
X1965 1742 1 1760 1741 2 1761 ND3 $T=504060 276080 0 0 $X=504060 $Y=275700
X1966 1778 1 1754 1746 2 315 ND3 $T=507780 296240 1 180 $X=505300 $Y=295860
X1967 1786 1 1789 1797 2 1805 ND3 $T=508400 225680 0 0 $X=508400 $Y=225300
X1968 1800 1 1795 1718 2 1789 ND3 $T=511500 235760 0 180 $X=509020 $Y=230340
X1969 325 1 1803 324 2 321 ND3 $T=512120 316400 0 180 $X=509640 $Y=310980
X1970 1800 1 1813 1804 2 1793 ND3 $T=513980 255920 1 180 $X=511500 $Y=255540
X1971 331 1 320 1769 2 1810 ND3 $T=514600 316400 0 180 $X=512120 $Y=310980
X1972 1823 1 1818 1731 2 1814 ND3 $T=515220 276080 1 180 $X=512740 $Y=275700
X1973 1849 1 1820 1755 2 1832 ND3 $T=515220 296240 0 180 $X=512740 $Y=290820
X1974 1864 1 333 1865 2 1830 ND3 $T=521420 245840 0 180 $X=518940 $Y=240420
X1975 1864 1 1859 1801 2 1747 ND3 $T=521420 245840 1 180 $X=518940 $Y=245460
X1976 1882 1 1878 1850 2 1722 ND3 $T=524520 235760 1 180 $X=522040 $Y=235380
X1977 1886 1 1883 1794 2 1811 ND3 $T=525140 255920 0 180 $X=522660 $Y=250500
X1978 358 1 1854 1904 2 1870 ND3 $T=530100 316400 0 180 $X=527620 $Y=310980
X1979 1899 1 1813 1909 2 1927 ND3 $T=531340 266000 0 0 $X=531340 $Y=265620
X1980 365 1 1921 342 2 1928 ND3 $T=531340 316400 1 0 $X=531340 $Y=310980
X1981 1872 1 366 363 2 369 ND3 $T=531960 296240 0 0 $X=531960 $Y=295860
X1982 382 1 1839 1906 2 1885 ND3 $T=535060 245840 1 180 $X=532580 $Y=245460
X1983 1940 1 1885 1860 2 1933 ND3 $T=536920 266000 0 180 $X=534440 $Y=260580
X1984 1878 1 1936 1939 2 1947 ND3 $T=535060 235760 0 0 $X=535060 $Y=235380
X1985 1954 1 1952 1785 2 375 ND3 $T=538780 306320 1 180 $X=536300 $Y=305940
X1986 1951 1 381 1836 2 1964 ND3 $T=538780 296240 0 0 $X=538780 $Y=295860
X1987 376 1 380 1896 2 1965 ND3 $T=538780 306320 1 0 $X=538780 $Y=300900
X1988 1944 1 1948 384 2 1968 ND3 $T=539400 276080 1 0 $X=539400 $Y=270660
X1989 1981 1 369 1840 2 376 ND3 $T=543740 306320 0 180 $X=541260 $Y=300900
X1990 1982 1 1985 1989 2 1996 ND3 $T=544360 296240 1 0 $X=544360 $Y=290820
X1991 1877 1 1986 1990 2 1994 ND3 $T=544360 316400 0 0 $X=544360 $Y=316020
X1992 1875 1 2012 2013 2 1982 ND3 $T=550560 286160 0 180 $X=548080 $Y=280740
X1993 2031 1 1997 1846 2 1911 ND3 $T=554280 225680 1 180 $X=551800 $Y=225300
X1994 2032 1 2024 2016 2 2023 ND3 $T=554280 306320 1 180 $X=551800 $Y=305940
X1995 1883 1 1795 2014 2 1864 ND3 $T=555520 245840 1 180 $X=553040 $Y=245460
X1996 2021 1 2015 2037 2 2036 ND3 $T=553040 255920 1 0 $X=553040 $Y=250500
X1997 1885 1 1905 2034 2 2040 ND3 $T=554900 225680 0 0 $X=554900 $Y=225300
X1998 2048 1 2047 1971 2 1932 ND3 $T=558620 266000 0 180 $X=556140 $Y=260580
X1999 2051 1 1887 1955 2 1911 ND3 $T=559240 255920 1 180 $X=556760 $Y=255540
X2000 2031 1 1864 2056 2 1974 ND3 $T=560480 235760 0 180 $X=558000 $Y=230340
X2001 2064 1 2059 416 2 2039 ND3 $T=562340 296240 1 180 $X=559860 $Y=295860
X2002 2051 1 2040 2054 2 382 ND3 $T=566060 255920 1 180 $X=563580 $Y=255540
X2003 2090 1 2088 422 2 2030 ND3 $T=569160 296240 1 180 $X=566680 $Y=295860
X2004 2085 1 2093 425 2 2100 ND3 $T=568540 286160 0 0 $X=568540 $Y=285780
X2005 2101 1 2116 1858 2 2142 ND3 $T=573500 225680 1 0 $X=573500 $Y=220260
X2006 2127 1 2104 440 2 2137 ND3 $T=577220 255920 0 0 $X=577220 $Y=255540
X2007 2162 1 1895 2159 2 2015 ND3 $T=586520 225680 1 180 $X=584040 $Y=225300
X2008 2161 1 2133 2163 2 2172 ND3 $T=585280 286160 0 0 $X=585280 $Y=285780
X2009 450 1 2165 2166 2 452 ND3 $T=585900 306320 0 0 $X=585900 $Y=305940
X2010 2173 1 2019 2164 2 451 ND3 $T=589000 276080 1 180 $X=586520 $Y=275700
X2011 2168 1 1893 2179 2 2185 ND3 $T=588380 276080 1 0 $X=588380 $Y=270660
X2012 2187 1 2186 2020 2 2109 ND3 $T=591480 306320 1 180 $X=589000 $Y=305940
X2013 2061 1 455 2193 2 2198 ND3 $T=590860 255920 1 0 $X=590860 $Y=250500
X2014 2181 1 2165 1842 2 2204 ND3 $T=592720 245840 0 0 $X=592720 $Y=245460
X2015 2051 1 2201 1912 2 2212 ND3 $T=595820 245840 0 0 $X=595820 $Y=245460
X2016 2222 1 2165 2205 2 459 ND3 $T=600160 306320 1 180 $X=597680 $Y=305940
X2017 382 1 1813 2214 2 2070 ND3 $T=603260 276080 0 180 $X=600780 $Y=270660
X2018 2236 1 2165 2224 2 2223 ND3 $T=603260 296240 0 180 $X=600780 $Y=290820
X2019 2234 1 1749 2176 2 1905 ND3 $T=602640 225680 0 0 $X=602640 $Y=225300
X2020 2241 1 2237 1957 2 2219 ND3 $T=605120 266000 0 180 $X=602640 $Y=260580
X2021 2252 1 2248 461 2 1934 ND3 $T=608220 296240 1 180 $X=605740 $Y=295860
X2022 2264 1 2216 2207 2 1962 ND3 $T=611940 266000 0 180 $X=609460 $Y=260580
X2023 2245 1 1714 2287 2 1747 ND3 $T=618140 225680 1 0 $X=618140 $Y=220260
X2024 474 1 473 1748 2 200 ND3 $T=620620 316400 1 180 $X=618140 $Y=316020
X2025 474 1 200 1738 2 468 ND3 $T=621860 316400 0 180 $X=619380 $Y=310980
X2026 474 1 476 334 2 468 ND3 $T=623100 316400 1 180 $X=620620 $Y=316020
X2027 1962 1 2289 2106 2 2192 ND3 $T=623720 245840 1 180 $X=621240 $Y=245460
X2028 479 1 477 313 2 200 ND3 $T=625580 316400 1 180 $X=623100 $Y=316020
X2029 483 1 477 1719 2 200 ND3 $T=628060 316400 1 180 $X=625580 $Y=316020
X2030 485 1 484 1809 2 473 ND3 $T=629920 316400 0 180 $X=627440 $Y=310980
X2031 485 1 484 348 2 468 ND3 $T=630540 316400 1 180 $X=628060 $Y=316020
X2032 2289 1 1839 2299 2 1905 ND3 $T=629920 255920 0 0 $X=629920 $Y=255540
X2033 486 1 484 1817 2 473 ND3 $T=632400 316400 0 180 $X=629920 $Y=310980
X2034 2192 1 1927 2301 2 382 ND3 $T=633640 276080 0 180 $X=631160 $Y=270660
X2035 2238 1 1933 2300 2 455 ND3 $T=637360 286160 0 180 $X=634880 $Y=280740
X2036 2167 1 2155 2277 2 2316 ND3 $T=637980 266000 1 0 $X=637980 $Y=260580
X2037 2317 1 495 1885 2 493 ND3 $T=641080 286160 0 180 $X=638600 $Y=280740
X2038 2317 1 497 1714 2 493 ND3 $T=643560 296240 0 180 $X=641080 $Y=290820
X2039 2325 1 2319 1895 2 482 ND3 $T=644180 276080 1 180 $X=641700 $Y=275700
X2040 2328 1 495 1795 2 2325 ND3 $T=649140 276080 1 180 $X=646660 $Y=275700
X2041 2317 1 495 1793 2 491 ND3 $T=649140 296240 0 180 $X=646660 $Y=290820
X2042 2328 1 497 1747 2 2325 ND3 $T=649140 306320 0 180 $X=646660 $Y=300900
X2043 2335 1 2038 2139 2 455 ND3 $T=651000 266000 1 180 $X=648520 $Y=265620
X2044 2342 1 2316 2210 2 2167 ND3 $T=654720 266000 0 180 $X=652240 $Y=260580
X2045 2370 1 2369 2345 2 2368 ND3 $T=665880 276080 1 180 $X=663400 $Y=275700
X2046 2482 1 2476 2402 2 2470 ND3 $T=705560 225680 1 180 $X=703080 $Y=225300
X2047 2518 1 536 2464 2 535 ND3 $T=720440 316400 0 180 $X=717960 $Y=310980
X2048 2750 1 2748 2742 2 2738 ND3 $T=819640 296240 0 180 $X=817160 $Y=290820
X2049 2761 1 2765 2740 2 2745 ND3 $T=821500 286160 0 180 $X=819020 $Y=280740
X2050 2789 1 2785 2777 2 2779 ND3 $T=826460 276080 1 180 $X=823980 $Y=275700
X2051 2786 1 2795 2768 2 2807 ND3 $T=827080 316400 1 0 $X=827080 $Y=310980
X2052 2804 1 2803 612 2 2818 ND3 $T=828940 235760 1 0 $X=828940 $Y=230340
X2053 2806 1 2809 2815 2 2823 ND3 $T=828940 286160 0 0 $X=828940 $Y=285780
X2054 2831 1 2826 623 2 2798 ND3 $T=833280 296240 1 180 $X=830800 $Y=295860
X2055 2887 1 645 2863 2 2842 ND3 $T=842580 296240 1 180 $X=840100 $Y=295860
X2056 2886 1 2879 2873 2 2772 ND3 $T=843200 286160 0 180 $X=840720 $Y=280740
X2057 2774 1 646 657 2 2838 ND3 $T=844440 276080 0 0 $X=844440 $Y=275700
X2058 655 1 661 2817 2 665 ND3 $T=847540 266000 0 0 $X=847540 $Y=265620
X2059 2902 1 2880 2811 2 2923 ND3 $T=849400 225680 1 0 $X=849400 $Y=220260
X2060 2942 1 2939 2841 2 2893 ND3 $T=856840 255920 0 180 $X=854360 $Y=250500
X2061 2944 1 2941 2735 2 2934 ND3 $T=857460 296240 1 180 $X=854980 $Y=295860
X2062 2937 1 2879 2839 2 2975 ND3 $T=855600 286160 1 0 $X=855600 $Y=280740
X2063 2887 1 2953 2928 2 2955 ND3 $T=858080 296240 0 0 $X=858080 $Y=295860
X2064 2961 1 2893 2919 2 2967 ND3 $T=861180 245840 1 180 $X=858700 $Y=245460
X2065 2963 1 669 2958 2 2840 ND3 $T=861180 255920 1 180 $X=858700 $Y=255540
X2066 2973 1 2969 2754 2 2954 ND3 $T=863660 296240 0 180 $X=861180 $Y=290820
X2067 2940 1 2939 2875 2 2983 ND3 $T=863040 225680 1 0 $X=863040 $Y=220260
X2068 2985 1 690 2801 2 688 ND3 $T=866140 255920 0 180 $X=863660 $Y=250500
X2069 2982 1 2991 2935 2 2996 ND3 $T=866760 306320 0 0 $X=866760 $Y=305940
X2070 3002 1 3009 2743 2 3001 ND3 $T=874200 286160 0 180 $X=871720 $Y=280740
X2071 3049 1 3045 2746 2 3028 ND3 $T=884120 276080 1 180 $X=881640 $Y=275700
X2072 3072 1 2896 3080 2 3057 ND3 $T=888460 266000 0 0 $X=888460 $Y=265620
X2073 3051 1 706 2858 2 3120 ND3 $T=893420 225680 0 0 $X=893420 $Y=225300
X2074 3109 1 690 3104 2 2963 ND3 $T=899620 255920 1 180 $X=897140 $Y=255540
X2075 3110 1 3098 2869 2 3093 ND3 $T=899620 286160 0 180 $X=897140 $Y=280740
X2076 3099 1 3132 2988 2 3137 ND3 $T=904580 296240 1 0 $X=904580 $Y=290820
X2077 3169 1 3030 3160 2 2767 ND3 $T=916360 235760 0 180 $X=913880 $Y=230340
X2078 3182 1 3159 3173 2 2983 ND3 $T=921320 245840 0 180 $X=918840 $Y=240420
X2079 3085 1 3031 3183 2 3203 ND3 $T=926280 245840 0 0 $X=926280 $Y=245460
X2080 3225 1 755 3212 2 3221 ND3 $T=935580 286160 1 180 $X=933100 $Y=285780
X2081 3176 1 3095 3248 2 3221 ND3 $T=933100 306320 1 0 $X=933100 $Y=300900
X2082 637 1 663 3254 2 658 ND3 $T=941160 316400 1 0 $X=941160 $Y=310980
X2083 3245 1 761 3250 2 3258 ND3 $T=943020 266000 0 0 $X=943020 $Y=265620
X2084 3040 1 2943 3291 2 611 ND3 $T=959140 276080 1 0 $X=959140 $Y=270660
X2085 3300 1 3270 3304 2 3159 ND3 $T=970300 266000 0 180 $X=967820 $Y=260580
X2086 3337 1 3339 805 2 3348 ND3 $T=1011220 306320 0 0 $X=1011220 $Y=305940
X2087 3340 1 3344 808 2 3345 ND3 $T=1013700 316400 0 0 $X=1013700 $Y=316020
X2088 3358 1 3359 818 2 3363 ND3 $T=1030440 306320 0 0 $X=1030440 $Y=305940
X2089 3371 1 3370 820 2 3367 ND3 $T=1039120 306320 0 180 $X=1036640 $Y=300900
X2090 3375 1 3377 822 2 3379 ND3 $T=1040360 316400 1 0 $X=1040360 $Y=310980
X2091 3402 1 3393 828 2 3400 ND3 $T=1070120 316400 0 180 $X=1067640 $Y=310980
X2092 288 3 1 2 BUF2 $T=468100 225680 0 180 $X=465000 $Y=220260
X2093 311 274 1 2 BUF2 $T=495380 316400 0 0 $X=495380 $Y=316020
X2094 2612 556 1 2 BUF2 $T=773140 306320 1 0 $X=773140 $Y=300900
X2095 567 569 1 2 BUF2 $T=773140 316400 1 0 $X=773140 $Y=310980
X2096 2685 558 1 2 BUF2 $T=784300 286160 1 180 $X=781200 $Y=285780
X2097 225 2 1 1354 BUF1 $T=370140 266000 1 180 $X=367660 $Y=265620
X2098 572 2 1 2694 BUF1 $T=796700 255920 0 0 $X=796700 $Y=255540
X2099 1326 1317 1 2 INV2CK $T=381300 276080 0 0 $X=381300 $Y=275700
X2100 1564 1565 1560 1 2 AN2T $T=432140 286160 1 0 $X=432140 $Y=280740
X2101 2601 2595 2589 1 2 AN2T $T=762600 255920 0 0 $X=762600 $Y=255540
X2102 2632 2636 2638 1 2 AN2T $T=767560 296240 1 0 $X=767560 $Y=290820
X2103 2686 2690 2684 1 2 AN2T $T=796080 235760 1 180 $X=791740 $Y=235380
X2104 1776 2045 411 406 2118 433 1 2 2077 AO222 $T=578460 306320 0 180 $X=572260 $Y=300900
X2105 2801 2808 2814 2817 2822 2788 1 2 631 AO222 $T=828320 266000 1 0 $X=828320 $Y=260580
X2106 2848 2875 2811 2797 2862 2858 1 2 2829 AO222 $T=843820 225680 0 180 $X=837620 $Y=220260
X2107 2769 2919 2908 2759 2834 2906 1 2 2905 AO222 $T=853740 245840 0 180 $X=847540 $Y=240420
X2108 2769 3054 3052 2834 2924 3004 1 2 3077 AO222 $T=884120 245840 1 0 $X=884120 $Y=240420
X2109 3183 2844 2850 3177 3173 2922 1 2 3119 AO222 $T=921940 266000 1 180 $X=915740 $Y=265620
X2110 3017 3187 713 3077 3105 3192 1 2 3204 AO222 $T=921320 276080 0 0 $X=921320 $Y=275700
X2111 3323 790 789 3320 3319 787 1 2 784 AO222 $T=987660 286160 1 180 $X=981460 $Y=285780
X2112 3317 790 789 3324 3321 787 1 2 792 AO222 $T=983940 306320 1 0 $X=983940 $Y=300900
X2113 3327 790 789 3316 3326 787 1 2 3325 AO222 $T=993240 286160 0 180 $X=987040 $Y=280740
X2114 3332 790 789 3330 3329 787 1 2 795 AO222 $T=1001300 286160 0 180 $X=995100 $Y=280740
X2115 3334 790 789 3333 3331 787 1 2 797 AO222 $T=1004400 296240 1 180 $X=998200 $Y=295860
X2116 14 1279 1075 2 1 ND2S $T=325500 235760 1 180 $X=323640 $Y=235380
X2117 1320 1106 213 2 1 ND2S $T=344100 286160 0 0 $X=344100 $Y=285780
X2118 199 1138 1330 2 1 ND2S $T=345960 316400 1 0 $X=345960 $Y=310980
X2119 1390 1392 1394 2 1 ND2S $T=369520 255920 1 0 $X=369520 $Y=250500
X2120 1427 1423 1440 2 1 ND2S $T=386260 306320 1 0 $X=386260 $Y=300900
X2121 1622 1616 232 2 1 ND2S $T=453220 276080 0 0 $X=453220 $Y=275700
X2122 1622 1625 1418 2 1 ND2S $T=454460 276080 1 0 $X=454460 $Y=270660
X2123 1679 1623 1676 2 1 ND2S $T=471200 245840 1 0 $X=471200 $Y=240420
X2124 1693 1669 281 2 1 ND2S $T=480500 276080 1 0 $X=480500 $Y=270660
X2125 1699 1708 1697 2 1 ND2S $T=487320 255920 1 180 $X=485460 $Y=255540
X2126 1700 1715 281 2 1 ND2S $T=485460 276080 0 0 $X=485460 $Y=275700
X2127 1887 1874 1793 2 1 ND2S $T=525140 225680 0 0 $X=525140 $Y=225300
X2128 2324 2115 492 2 1 ND2S $T=640460 296240 0 180 $X=638600 $Y=290820
X2129 2391 2389 2363 2 1 ND2S $T=674560 276080 1 180 $X=672700 $Y=275700
X2130 565 2607 2635 2 1 ND2S $T=769420 306320 0 180 $X=767560 $Y=300900
X2131 692 3075 706 2 1 ND2S $T=889080 245840 0 0 $X=889080 $Y=245460
X2132 3152 3100 3117 2 1 ND2S $T=912640 235760 0 180 $X=910780 $Y=230340
X2133 2832 3235 3193 2 1 ND2S $T=938680 255920 1 180 $X=936820 $Y=255540
X2134 2986 3238 692 2 1 ND2S $T=939920 266000 1 0 $X=939920 $Y=260580
X2135 3241 3129 2893 2 1 ND2S $T=946740 245840 1 0 $X=946740 $Y=240420
X2136 3112 760 669 2 1 ND2S $T=951700 286160 1 0 $X=951700 $Y=280740
X2137 2730 2 1 577 BUF3 $T=807240 296240 1 0 $X=807240 $Y=290820
X2138 49 1 48 942 46 895 2 OAI22S $T=236840 316400 1 180 $X=233120 $Y=316020
X2139 57 1 940 941 977 972 2 OAI22S $T=238080 286160 0 0 $X=238080 $Y=285780
X2140 66 1 978 975 74 1011 2 OAI22S $T=243660 235760 1 0 $X=243660 $Y=230340
X2141 1039 1 981 917 1026 935 2 OAI22S $T=255440 266000 1 180 $X=251720 $Y=265620
X2142 21 1 1181 975 1190 1191 2 OAI22S $T=292020 266000 1 0 $X=292020 $Y=260580
X2143 57 1 1165 11 1282 1285 2 OAI22S $T=322400 296240 0 0 $X=322400 $Y=295860
X2144 27 1 1284 21 1280 1210 2 OAI22S $T=327360 276080 1 180 $X=323640 $Y=275700
X2145 943 1 1294 81 1220 190 2 OAI22S $T=331700 296240 1 180 $X=327980 $Y=295860
X2146 1738 1 1816 1748 330 1835 2 OAI22S $T=512120 235760 1 0 $X=512120 $Y=230340
X2147 1719 1 1871 1839 1901 356 2 OAI22S $T=525760 266000 1 0 $X=525760 $Y=260580
X2148 424 1 1965 2052 2033 373 2 OAI22S $T=568540 286160 0 180 $X=564820 $Y=280740
X2149 2152 1 1859 1861 1826 2167 2 OAI22S $T=584040 266000 0 0 $X=584040 $Y=265620
X2150 357 1 462 1802 1775 2254 2 OAI22S $T=605120 316400 1 0 $X=605120 $Y=310980
X2151 1809 1 2274 1748 2257 2268 2 OAI22S $T=618140 235760 1 180 $X=614420 $Y=235380
X2152 1817 1 2294 346 2258 2297 2 OAI22S $T=623720 286160 0 0 $X=623720 $Y=285780
X2153 348 1 2303 1809 1992 2298 2 OAI22S $T=633640 245840 1 180 $X=629920 $Y=245460
X2154 1817 1 2307 1880 2275 2318 2 OAI22S $T=633640 276080 0 0 $X=633640 $Y=275700
X2155 608 1 2771 604 2756 2737 2 OAI22S $T=824600 266000 0 180 $X=820880 $Y=260580
X2156 609 1 2832 630 2736 2840 2 OAI22S $T=832040 255920 1 0 $X=832040 $Y=250500
X2157 654 1 2951 2835 2837 2950 2 OAI22S $T=857460 235760 1 0 $X=857460 $Y=230340
X2158 2962 1 2835 2827 2938 2995 2 OAI22S $T=861180 235760 1 0 $X=861180 $Y=230340
X2159 2997 1 3006 3008 3005 605 2 OAI22S $T=875440 266000 0 180 $X=871720 $Y=260580
X2160 2830 1 3015 620 3014 3011 2 OAI22S $T=877300 245840 1 180 $X=873580 $Y=245460
X2161 646 1 3031 2830 2974 3040 2 OAI22S $T=878540 245840 1 0 $X=878540 $Y=240420
X2162 2959 1 3147 3151 3135 3158 2 OAI22S $T=909540 266000 0 0 $X=909540 $Y=265620
X2163 2827 1 3237 2774 3226 3219 2 OAI22S $T=943640 225680 1 180 $X=939920 $Y=225300
X2164 2997 1 3299 712 3301 773 2 OAI22S $T=963480 306320 0 0 $X=963480 $Y=305940
X2165 1716 1 2 1725 DELB $T=493520 235760 0 0 $X=493520 $Y=235380
X2166 2503 1 2 2511 DELB $T=713620 296240 1 0 $X=713620 $Y=290820
X2167 288 833 1 2 BUF2CK $T=1088720 286160 0 0 $X=1088720 $Y=285780
X2168 906 889 2 892 884 1 OR3B2 $T=226920 235760 1 180 $X=223200 $Y=235380
X2169 1003 929 2 1012 1027 1 OR3B2 $T=249240 296240 1 0 $X=249240 $Y=290820
X2170 957 1054 2 1116 1034 1 OR3B2 $T=274660 235760 0 180 $X=270940 $Y=230340
X2171 1140 1130 2 1169 1083 1 OR3B2 $T=283960 255920 0 0 $X=283960 $Y=255540
X2172 1162 160 2 1206 166 1 OR3B2 $T=296360 316400 1 0 $X=296360 $Y=310980
X2173 206 909 2 1309 1183 1 OR3B2 $T=339760 296240 1 180 $X=336040 $Y=295860
X2174 1767 1758 2 1780 1722 1 OR3B2 $T=509640 245840 1 180 $X=505920 $Y=245460
X2175 2020 374 2 1942 360 1 OR3B2 $T=538160 306320 0 180 $X=534440 $Y=300900
X2176 1906 1800 2 1959 1962 1 OR3B2 $T=536300 255920 1 0 $X=536300 $Y=250500
X2177 2276 2155 2 2178 2044 1 OR3B2 $T=618140 276080 0 0 $X=618140 $Y=275700
X2178 487 1813 2 2283 1933 1 OR3B2 $T=633640 296240 1 0 $X=633640 $Y=290820
X2179 2111 2323 2 2315 2326 1 OR3B2 $T=641700 225680 0 0 $X=641700 $Y=225300
X2180 2754 2764 2 2781 2780 1 OR3B2 $T=819640 296240 1 0 $X=819640 $Y=290820
X2181 2849 2842 2 2794 2810 1 OR3B2 $T=837620 296240 1 180 $X=833900 $Y=295860
X2182 20 883 1 10 875 5 2 OAI112HS $T=225060 316400 1 180 $X=220720 $Y=316020
X2183 21 912 1 1103 119 120 2 OAI112HS $T=266600 306320 1 0 $X=266600 $Y=300900
X2184 941 1028 1 115 1099 1095 2 OAI112HS $T=271560 255920 1 180 $X=267220 $Y=255540
X2185 941 945 1 1118 1113 1064 2 OAI112HS $T=275900 316400 0 180 $X=271560 $Y=310980
X2186 1090 943 1 1229 1289 188 2 OAI112HS $T=331700 306320 1 180 $X=327360 $Y=305940
X2187 208 205 1 920 1307 14 2 OAI112HS $T=341000 306320 0 180 $X=336660 $Y=300900
X2188 1714 1719 1 1723 1728 1730 2 OAI112HS $T=495380 286160 0 0 $X=495380 $Y=285780
X2189 1809 1798 1 1783 319 320 2 OAI112HS $T=512740 276080 1 180 $X=508400 $Y=275700
X2190 1887 346 1 1870 1773 331 2 OAI112HS $T=525140 306320 1 180 $X=520800 $Y=305940
X2191 1880 2038 1 2035 2027 1967 2 OAI112HS $T=558000 286160 0 180 $X=553660 $Y=280740
X2192 1839 398 1 2083 335 2081 2 OAI112HS $T=564820 316400 0 0 $X=564820 $Y=316020
X2193 1880 2117 1 438 2006 2131 2 OAI112HS $T=572880 245840 1 0 $X=572880 $Y=240420
X2194 336 2129 1 1930 2151 2154 2 OAI112HS $T=579080 296240 1 0 $X=579080 $Y=290820
X2195 489 488 1 2253 2293 1887 2 OAI112HS $T=635500 306320 1 180 $X=631160 $Y=305940
X2196 2843 2846 1 2851 2747 2861 2 OAI112HS $T=835140 306320 0 0 $X=835140 $Y=305940
X2197 2774 615 1 2859 2856 2868 2 OAI112HS $T=836380 286160 1 0 $X=836380 $Y=280740
X2198 650 687 1 2980 673 2977 2 OAI112HS $T=868000 306320 0 180 $X=863660 $Y=300900
X2199 692 693 1 705 3019 3018 2 OAI112HS $T=872340 306320 1 0 $X=872340 $Y=300900
X2200 655 693 1 3016 2849 3020 2 OAI112HS $T=872960 286160 0 0 $X=872960 $Y=285780
X2201 658 651 1 3020 3021 3025 2 OAI112HS $T=882880 296240 1 180 $X=878540 $Y=295860
X2202 688 609 1 3123 3150 2968 2 OAI112HS $T=914500 225680 0 180 $X=910160 $Y=220260
X2203 3126 3157 1 740 3167 3181 2 OAI112HS $T=913260 286160 0 0 $X=913260 $Y=285780
X2204 640 2793 1 2924 3188 713 2 OAI112HS $T=919460 276080 1 0 $X=919460 $Y=270660
X2205 709 751 1 3181 3087 3198 2 OAI112HS $T=930620 286160 0 180 $X=926280 $Y=280740
X2206 941 1017 105 146 27 1163 2 1 1227 OA222S $T=301320 296240 0 0 $X=301320 $Y=295860
X2207 1880 1726 378 454 348 2212 2 1 2221 OA222S $T=594580 276080 1 0 $X=594580 $Y=270660
X2208 658 649 2883 2892 2830 615 2 1 2810 OA222S $T=847540 286160 1 180 $X=841960 $Y=285780
X2209 658 662 2903 611 2827 615 2 1 2879 OA222S $T=850020 286160 0 180 $X=844440 $Y=280740
X2210 2835 2950 2838 2923 672 2940 2 1 2918 OA222S $T=860560 225680 0 180 $X=854980 $Y=220260
X2211 661 2964 2939 2959 658 642 2 1 2921 OA222S $T=864280 276080 1 180 $X=858700 $Y=275700
X2212 2939 693 2979 2972 615 604 2 1 2977 OA222S $T=870480 286160 0 180 $X=864900 $Y=280740
X2213 694 3151 3174 685 706 2959 2 1 3272 OA222S $T=945500 276080 0 0 $X=945500 $Y=275700
X2214 661 2883 709 766 2903 3241 2 1 3277 OA222S $T=949840 306320 1 0 $X=949840 $Y=300900
X2215 3034 2972 2883 3227 3174 3298 2 1 3268 OA222S $T=960380 286160 0 0 $X=960380 $Y=285780
X2216 15 879 1 9 8 873 2 MOAI1S $T=224440 306320 0 180 $X=220720 $Y=300900
X2217 52 965 1 58 59 973 2 MOAI1S $T=236840 296240 0 0 $X=236840 $Y=295860
X2218 52 926 1 41 944 983 2 MOAI1S $T=239940 276080 0 0 $X=239940 $Y=275700
X2219 998 1014 1 1005 943 876 2 MOAI1S $T=250480 245840 1 180 $X=246760 $Y=245460
X2220 86 85 1 81 79 1002 2 MOAI1S $T=251100 316400 1 180 $X=247380 $Y=316020
X2221 1044 96 1 37 91 1007 2 MOAI1S $T=256060 286160 1 180 $X=252340 $Y=285780
X2222 1014 1055 1 975 1046 1025 2 MOAI1S $T=259160 255920 0 180 $X=255440 $Y=250500
X2223 1014 1070 1 103 107 1084 2 MOAI1S $T=261020 255920 1 0 $X=261020 $Y=250500
X2224 1088 1068 1 1077 1075 1037 2 MOAI1S $T=265360 245840 1 180 $X=261640 $Y=245460
X2225 102 56 1 1101 66 127 2 MOAI1S $T=266600 296240 0 0 $X=266600 $Y=295860
X2226 1129 1135 1 1013 57 129 2 MOAI1S $T=279000 286160 1 180 $X=275280 $Y=285780
X2227 1024 1129 1 8 150 151 2 MOAI1S $T=287060 286160 0 0 $X=287060 $Y=285780
X2228 1126 1244 1 1246 21 1123 2 MOAI1S $T=311240 266000 0 0 $X=311240 $Y=265620
X2229 990 1088 1 1266 975 1267 2 MOAI1S $T=316820 255920 1 0 $X=316820 $Y=250500
X2230 1126 1281 1 1277 21 1272 2 MOAI1S $T=326120 266000 1 180 $X=322400 $Y=265620
X2231 15 1260 1 1017 941 1291 2 MOAI1S $T=326740 286160 1 0 $X=326740 $Y=280740
X2232 52 1307 1 1138 21 195 2 MOAI1S $T=336040 306320 0 180 $X=332320 $Y=300900
X2233 1367 228 1 231 228 1380 2 MOAI1S $T=369520 286160 1 0 $X=369520 $Y=280740
X2234 1765 1759 1 1733 1719 1745 2 MOAI1S $T=505920 255920 1 180 $X=502200 $Y=255540
X2235 1825 1762 1 1771 1793 1790 2 MOAI1S $T=512740 266000 0 180 $X=509020 $Y=260580
X2236 1759 1797 1 345 1873 1851 2 MOAI1S $T=521420 266000 1 0 $X=521420 $Y=260580
X2237 353 1892 1 337 347 1781 2 MOAI1S $T=527000 286160 0 180 $X=523280 $Y=280740
X2238 364 361 1 1873 354 1903 2 MOAI1S $T=531960 306320 0 180 $X=528240 $Y=300900
X2239 377 364 1 1911 346 370 2 MOAI1S $T=537540 316400 0 180 $X=533820 $Y=310980
X2240 353 1971 1 1726 1880 1988 2 MOAI1S $T=541260 245840 0 0 $X=541260 $Y=245460
X2241 390 1902 1 1839 398 2001 2 MOAI1S $T=546220 286160 0 0 $X=546220 $Y=285780
X2242 400 1941 1 2007 1738 397 2 MOAI1S $T=552420 266000 1 180 $X=548700 $Y=265620
X2243 1759 2014 1 1748 2021 2028 2 MOAI1S $T=549320 255920 1 0 $X=549320 $Y=250500
X2244 1863 2037 1 2029 1809 2022 2 MOAI1S $T=556140 255920 1 180 $X=552420 $Y=255540
X2245 339 1838 1 347 389 2067 2 MOAI1S $T=559240 306320 0 0 $X=559240 $Y=305940
X2246 1863 2056 1 2075 1809 2094 2 MOAI1S $T=563580 235760 0 0 $X=563580 $Y=235380
X2247 1858 1825 1 2091 1748 2095 2 MOAI1S $T=567300 235760 1 0 $X=567300 $Y=230340
X2248 2082 1776 1 368 1965 2102 2 MOAI1S $T=567300 266000 0 0 $X=567300 $Y=265620
X2249 1993 1776 1 441 368 2114 2 MOAI1S $T=574120 286160 0 0 $X=574120 $Y=285780
X2250 1776 2144 1 445 383 2121 2 MOAI1S $T=582180 316400 1 180 $X=578460 $Y=316020
X2251 2149 2160 1 347 447 2107 2 MOAI1S $T=586520 276080 0 180 $X=582800 $Y=270660
X2252 1868 2193 1 2189 387 1791 2 MOAI1S $T=593960 296240 1 180 $X=590240 $Y=295860
X2253 2160 2179 1 2195 1817 458 2 MOAI1S $T=590860 276080 1 0 $X=590860 $Y=270660
X2254 395 2277 1 394 448 2272 2 MOAI1S $T=618140 296240 0 180 $X=614420 $Y=290820
X2255 395 2293 1 2040 1809 475 2 MOAI1S $T=624960 306320 1 180 $X=621240 $Y=305940
X2256 395 2292 1 313 1885 2113 2 MOAI1S $T=626820 276080 1 180 $X=623100 $Y=275700
X2257 2340 503 1 504 503 2363 2 MOAI1S $T=659060 276080 0 0 $X=659060 $Y=275700
X2258 2778 2775 1 605 2749 2763 2 MOAI1S $T=824600 266000 1 180 $X=820880 $Y=265620
X2259 2787 2793 1 2784 602 2741 2 MOAI1S $T=827700 255920 0 180 $X=823980 $Y=250500
X2260 600 2775 1 613 614 2800 2 MOAI1S $T=825840 296240 1 0 $X=825840 $Y=290820
X2261 625 621 1 617 614 2802 2 MOAI1S $T=832040 306320 0 180 $X=828320 $Y=300900
X2262 616 2821 1 2828 628 2792 2 MOAI1S $T=830800 316400 1 0 $X=830800 $Y=310980
X2263 643 641 1 2843 637 2766 2 MOAI1S $T=840720 306320 0 180 $X=837000 $Y=300900
X2264 643 625 1 649 650 2776 2 MOAI1S $T=841960 296240 1 0 $X=841960 $Y=290820
X2265 2788 2913 1 605 2925 2929 2 MOAI1S $T=850020 255920 0 0 $X=850020 $Y=255540
X2266 689 680 1 2964 611 2901 2 MOAI1S $T=864280 296240 1 180 $X=860560 $Y=295860
X2267 689 633 1 687 686 2966 2 MOAI1S $T=865520 316400 1 180 $X=861800 $Y=316020
X2268 2855 3017 1 3013 2883 3010 2 MOAI1S $T=876680 276080 0 180 $X=872960 $Y=270660
X2269 3048 2850 1 3043 2964 2915 2 MOAI1S $T=885360 266000 0 180 $X=881640 $Y=260580
X2270 3071 2797 1 3060 2744 3032 2 MOAI1S $T=889080 235760 1 180 $X=885360 $Y=235380
X2271 656 3078 1 709 715 3053 2 MOAI1S $T=892180 286160 1 180 $X=888460 $Y=285780
X2272 703 719 1 605 2917 3065 2 MOAI1S $T=892180 316400 0 180 $X=888460 $Y=310980
X2273 3101 675 1 3121 2964 3141 2 MOAI1S $T=900860 286160 1 0 $X=900860 $Y=280740
X2274 2775 2910 1 687 739 3166 2 MOAI1S $T=912640 306320 0 0 $X=912640 $Y=305940
X2275 2924 3211 1 3216 2827 2872 2 MOAI1S $T=929380 245840 0 0 $X=929380 $Y=245460
X2276 2814 3140 1 658 3228 3267 2 MOAI1S $T=941780 296240 1 0 $X=941780 $Y=290820
X2277 2808 3255 1 756 664 3256 2 MOAI1S $T=944880 286160 0 0 $X=944880 $Y=285780
X2278 2808 3231 1 650 3210 3263 2 MOAI1S $T=944880 296240 0 0 $X=944880 $Y=295860
X2279 689 641 1 3227 2997 3290 2 MOAI1S $T=958520 306320 0 0 $X=958520 $Y=305940
X2280 913 31 1 905 24 2 22 893 20 OAI222S $T=230020 316400 0 180 $X=224440 $Y=310980
X2281 22 20 1 902 24 2 912 887 917 OAI222S $T=225060 306320 1 0 $X=225060 $Y=300900
X2282 916 941 1 43 40 2 919 38 27 OAI222S $T=235600 316400 0 180 $X=230020 $Y=310980
X2283 928 41 1 900 942 2 947 964 66 OAI222S $T=231260 235760 1 0 $X=231260 $Y=230340
X2284 910 975 1 958 27 2 949 961 941 OAI222S $T=241800 266000 0 180 $X=236220 $Y=260580
X2285 943 981 1 979 49 2 43 968 18 OAI222S $T=243040 316400 0 180 $X=237460 $Y=310980
X2286 1006 941 1 967 917 2 989 999 21 OAI222S $T=248000 266000 1 180 $X=242420 $Y=265620
X2287 1021 41 1 1033 66 2 1040 962 975 OAI222S $T=251720 235760 1 0 $X=251720 $Y=230340
X2288 105 101 1 1054 24 2 49 1062 78 OAI222S $T=262880 316400 0 180 $X=257300 $Y=310980
X2289 1038 27 1 107 37 2 1089 1069 917 OAI222S $T=261020 286160 1 0 $X=261020 $Y=280740
X2290 1253 942 1 1251 11 2 1240 176 21 OAI222S $T=316820 276080 0 180 $X=311240 $Y=270660
X2291 1017 942 1 58 180 2 59 1268 37 OAI222S $T=322400 306320 0 180 $X=316820 $Y=300900
X2292 941 1273 1 75 173 2 183 181 103 OAI222S $T=323640 316400 1 180 $X=318060 $Y=316020
X2293 1177 942 1 183 18 2 83 1274 113 OAI222S $T=319300 286160 0 0 $X=319300 $Y=285780
X2294 1300 41 1 1250 975 2 1288 1293 943 OAI222S $T=332320 255920 0 180 $X=326740 $Y=250500
X2295 24 944 1 1208 41 2 83 1305 113 OAI222S $T=336660 266000 1 180 $X=331080 $Y=265620
X2296 1327 943 1 1310 66 2 1303 1311 975 OAI222S $T=341000 245840 1 180 $X=335420 $Y=245460
X2297 1717 313 1 1735 1738 2 1740 1737 1748 OAI222S $T=498480 235760 0 0 $X=498480 $Y=235380
X2298 1736 1719 1 1744 1738 2 1752 1724 1748 OAI222S $T=500340 255920 1 0 $X=500340 $Y=250500
X2299 1827 336 1 1844 334 2 1798 1772 1861 OAI222S $T=515220 276080 0 0 $X=515220 $Y=275700
X2300 1872 344 1 1857 334 2 1827 1845 336 OAI222S $T=523280 286160 0 180 $X=517700 $Y=280740
X2301 1910 1880 1 1884 1894 2 1891 350 348 OAI222S $T=530100 276080 1 180 $X=524520 $Y=275700
X2302 1719 1859 1 1919 357 2 1884 1743 354 OAI222S $T=533200 296240 0 180 $X=527620 $Y=290820
X2303 1915 348 1 1873 368 2 1931 1946 1861 OAI222S $T=530720 276080 0 0 $X=530720 $Y=275700
X2304 378 379 1 1758 334 2 357 1950 369 OAI222S $T=536920 276080 0 0 $X=536920 $Y=275700
X2305 1943 313 1 1970 1748 2 1976 1987 1719 OAI222S $T=539400 235760 1 0 $X=539400 $Y=230340
X2306 334 1885 1 2057 313 2 419 1734 382 OAI222S $T=558620 245840 0 0 $X=558620 $Y=245460
X2307 2070 1802 1 415 354 2 419 2065 382 OAI222S $T=567300 266000 1 180 $X=561720 $Y=265620
X2308 2103 1748 1 1953 348 2 2086 2084 1880 OAI222S $T=572260 245840 0 180 $X=566680 $Y=240420
X2309 1726 1802 1 394 389 2 448 2249 368 OAI222S $T=610080 296240 0 180 $X=604500 $Y=290820
X2310 1880 2266 1 2189 460 2 415 1914 345 OAI222S $T=614420 296240 1 180 $X=608840 $Y=295860
X2311 2260 1802 1 2261 346 2 2270 2170 1809 OAI222S $T=610700 245840 1 0 $X=610700 $Y=240420
X2312 2233 336 1 2262 467 2 2265 2209 1817 OAI222S $T=610700 316400 1 0 $X=610700 $Y=310980
X2313 2142 313 1 2231 1802 2 2281 2271 1738 OAI222S $T=615040 235760 1 0 $X=615040 $Y=230340
X2314 2306 1880 1 2309 1861 2 2305 2134 1809 OAI222S $T=633020 255920 0 0 $X=633020 $Y=255540
X2315 637 652 1 2896 2903 2 659 2897 636 OAI222S $T=844440 296240 0 0 $X=844440 $Y=295860
X2316 642 709 1 634 613 2 662 3118 650 OAI222S $T=904580 296240 0 180 $X=899000 $Y=290820
X2317 723 651 1 728 613 2 3114 3102 2964 OAI222S $T=899000 306320 0 0 $X=899000 $Y=305940
X2318 3031 672 1 2885 611 2 3125 3145 2774 OAI222S $T=913260 225680 1 180 $X=907680 $Y=225300
X2319 731 712 1 3146 687 2 725 735 732 OAI222S $T=907680 316400 0 0 $X=907680 $Y=316020
X2320 3040 3111 1 3142 608 2 3152 3092 2972 OAI222S $T=908300 276080 1 0 $X=908300 $Y=270660
X2321 745 668 1 3174 3120 2 3151 3088 3194 OAI222S $T=919460 286160 1 0 $X=919460 $Y=280740
X2322 3142 706 1 3210 709 2 3205 3190 634 OAI222S $T=933100 296240 0 180 $X=927520 $Y=290820
X2323 3249 2964 1 637 668 2 732 3242 651 OAI222S $T=943640 306320 1 180 $X=938060 $Y=305940
X2324 685 2997 1 3276 3151 2 3274 2805 2964 OAI222S $T=957280 276080 1 180 $X=951700 $Y=275700
X2325 3297 3126 1 605 3286 2 3159 3284 2997 OAI222S $T=962860 276080 1 180 $X=957280 $Y=275700
X2326 3303 2903 1 772 650 2 605 3295 3293 OAI222S $T=967820 306320 0 180 $X=962240 $Y=300900
X2327 3315 2744 1 3302 2827 2 3311 3310 2835 OAI222S $T=975260 235760 1 180 $X=969680 $Y=235380
X2328 1689 1683 1645 2 1 XNR2HS $T=489180 225680 1 0 $X=489180 $Y=220260
X2329 2435 2432 2462 2 1 XNR2HS $T=697500 286160 1 0 $X=697500 $Y=280740
X2330 2625 2628 2602 2 1 XNR2HS $T=766320 266000 0 0 $X=766320 $Y=265620
X2331 2680 2687 2696 2 1 XNR2HS $T=792360 255920 1 0 $X=792360 $Y=250500
X2332 21 869 18 13 11 877 1 2 872 OA222 $T=226300 276080 0 180 $X=220720 $Y=270660
X2333 37 35 33 29 27 897 1 2 880 OA222 $T=230640 316400 1 180 $X=225060 $Y=316020
X2334 21 922 917 907 27 903 1 2 898 OA222 $T=231880 276080 0 180 $X=226300 $Y=270660
X2335 41 955 942 948 943 939 1 2 885 OA222 $T=238080 245840 0 180 $X=232500 $Y=240420
X2336 41 984 18 987 943 993 1 2 997 OA222 $T=240560 296240 0 0 $X=240560 $Y=295860
X2337 11 47 981 66 68 941 1 2 73 OA222 $T=240560 306320 0 0 $X=240560 $Y=305940
X2338 24 986 67 69 70 72 1 2 1001 OA222 $T=241180 316400 0 0 $X=241180 $Y=316020
X2339 943 1022 27 1018 92 1035 1 2 1049 OA222 $T=251720 316400 1 0 $X=251720 $Y=310980
X2340 1058 1053 941 982 41 1043 1 2 1036 OA222 $T=259780 276080 0 180 $X=254200 $Y=270660
X2341 121 125 1102 1039 66 1107 1 2 132 OA222 $T=270940 306320 1 0 $X=270940 $Y=300900
X2342 131 913 941 1137 66 1141 1 2 141 OA222 $T=276520 296240 0 0 $X=276520 $Y=295860
X2343 131 71 57 1167 105 146 1 2 904 OA222 $T=290160 296240 1 180 $X=284580 $Y=295860
X2344 31 153 24 1180 941 1153 1 2 1192 OA222 $T=290160 296240 0 0 $X=290160 $Y=295860
X2345 101 155 83 1105 131 154 1 2 1176 OA222 $T=295740 316400 1 180 $X=290160 $Y=316020
X2346 66 1188 11 1149 31 1199 1 2 1201 OA222 $T=292020 296240 1 0 $X=292020 $Y=290820
X2347 11 976 24 1205 83 1196 1 2 1016 OA222 $T=301320 286160 1 180 $X=295740 $Y=285780
X2348 941 976 121 159 66 1205 1 2 1212 OA222 $T=295740 296240 0 0 $X=295740 $Y=295860
X2349 27 1213 131 9 11 1128 1 2 1202 OA222 $T=302560 306320 0 180 $X=296980 $Y=300900
X2350 917 1198 18 163 24 1215 1 2 1224 OA222 $T=297600 286160 1 0 $X=297600 $Y=280740
X2351 91 159 943 1222 24 1217 1 2 1197 OA222 $T=306280 255920 1 180 $X=300700 $Y=255540
X2352 41 1138 57 1027 105 172 1 2 1243 OA222 $T=305660 306320 0 0 $X=305660 $Y=305940
X2353 91 8 41 1233 975 1207 1 2 1241 OA222 $T=306280 266000 1 0 $X=306280 $Y=260580
X2354 105 171 57 1234 44 1239 1 2 1242 OA222 $T=306280 306320 1 0 $X=306280 $Y=300900
X2355 78 173 31 154 41 1119 1 2 1249 OA222 $T=308140 316400 0 0 $X=308140 $Y=316020
X2356 975 1276 941 1219 66 1270 1 2 891 OA222 $T=324880 255920 1 180 $X=319300 $Y=255540
X2357 44 41 103 75 1065 943 1 2 1283 OA222 $T=319920 306320 0 0 $X=319920 $Y=305940
X2358 943 1287 78 187 27 1263 1 2 185 OA222 $T=329220 316400 0 180 $X=323640 $Y=310980
X2359 11 1278 917 1189 83 1259 1 2 1292 OA222 $T=324260 276080 1 0 $X=324260 $Y=270660
X2360 68 975 24 1306 81 21 1 2 1297 OA222 $T=337900 276080 0 180 $X=332320 $Y=270660
X2361 313 1808 1802 1815 1719 1822 1 2 1834 OA222 $T=510880 235760 0 0 $X=510880 $Y=235380
X2362 333 1748 334 1831 1839 1809 1 2 1788 OA222 $T=520800 266000 1 180 $X=515220 $Y=265620
X2363 346 1893 1859 1738 333 1880 1 2 1854 OA222 $T=527620 286160 1 180 $X=522040 $Y=285780
X2364 1719 1879 369 372 348 1945 1 2 1951 OA222 $T=532580 286160 1 0 $X=532580 $Y=280740
X2365 368 376 1817 1935 373 345 1 2 367 OA222 $T=538780 296240 0 180 $X=533200 $Y=290820
X2366 368 1972 1966 349 348 1949 1 2 1756 OA222 $T=543740 286160 0 180 $X=538160 $Y=280740
X2367 1965 347 313 1979 1748 1811 1 2 1995 OA222 $T=541260 255920 1 0 $X=541260 $Y=250500
X2368 394 1961 389 1969 346 1978 1 2 1952 OA222 $T=548080 306320 1 180 $X=542500 $Y=305940
X2369 1748 1998 1880 2017 1738 2010 1 2 1766 OA222 $T=553660 235760 1 180 $X=548080 $Y=235380
X2370 410 1872 1880 2049 1738 2050 1 2 2055 OA222 $T=555520 276080 0 0 $X=555520 $Y=275700
X2371 313 2040 1817 2044 378 414 1 2 2041 OA222 $T=562960 286160 1 180 $X=557380 $Y=285780
X2372 344 1981 334 2058 1880 2066 1 2 2071 OA222 $T=558620 286160 1 0 $X=558620 $Y=280740
X2373 369 417 418 414 1738 2036 1 2 2079 OA222 $T=559860 316400 1 0 $X=559860 $Y=310980
X2374 334 2116 431 2108 430 376 1 2 2098 OA222 $T=575360 296240 1 180 $X=569780 $Y=295860
X2375 437 434 394 376 419 2051 1 2 2083 OA222 $T=575360 316400 1 180 $X=569780 $Y=316020
X2376 1965 2120 1719 2122 334 2069 1 2 2127 OA222 $T=574120 255920 1 0 $X=574120 $Y=250500
X2377 1719 2145 348 2150 387 2143 1 2 2080 OA222 $T=585280 286160 1 180 $X=579700 $Y=285780
X2378 373 424 2062 2152 1738 1883 1 2 2161 OA222 $T=580320 276080 0 0 $X=580320 $Y=275700
X2379 1839 356 448 2153 424 447 1 2 1841 OA222 $T=588380 316400 0 180 $X=582800 $Y=310980
X2380 383 347 366 2052 369 449 1 2 2194 OA222 $T=589000 316400 1 0 $X=589000 $Y=310980
X2381 410 366 1817 2184 378 454 1 2 2180 OA222 $T=595200 276080 1 180 $X=589620 $Y=275700
X2382 379 437 419 2192 410 457 1 2 2186 OA222 $T=589620 316400 0 0 $X=589620 $Y=316020
X2383 378 456 1817 2196 1905 2202 1 2 2206 OA222 $T=590240 286160 1 0 $X=590240 $Y=280740
X2384 1880 2238 373 2120 1738 2228 1 2 2215 OA222 $T=605120 276080 1 180 $X=599540 $Y=275700
X2385 369 460 344 457 313 1975 1 2 2220 OA222 $T=606360 286160 1 180 $X=600780 $Y=285780
X2386 346 2247 1861 1997 419 2230 1 2 1764 OA222 $T=608220 255920 0 180 $X=602640 $Y=250500
X2387 1738 2240 346 2243 344 2169 1 2 2251 OA222 $T=602640 286160 1 0 $X=602640 $Y=280740
X2388 1861 2246 354 2244 334 2242 1 2 2255 OA222 $T=603880 266000 0 0 $X=603880 $Y=265620
X2389 424 366 383 460 389 345 1 2 2259 OA222 $T=604500 316400 0 0 $X=604500 $Y=316020
X2390 1905 334 431 415 2216 346 1 2 2032 OA222 $T=610700 306320 1 180 $X=605120 $Y=305940
X2391 346 2238 334 2228 419 2250 1 2 2132 OA222 $T=611940 255920 1 180 $X=606360 $Y=255540
X2392 382 346 410 366 2216 419 1 2 2278 OA222 $T=612560 306320 0 0 $X=612560 $Y=305940
X2393 1809 2279 354 469 346 2273 1 2 1753 OA222 $T=620000 266000 1 180 $X=614420 $Y=265620
X2394 348 2282 410 337 346 2280 1 2 2173 OA222 $T=622480 286160 0 180 $X=616900 $Y=280740
X2395 2289 2217 1880 2288 313 2263 1 2 2241 OA222 $T=625580 255920 1 180 $X=620000 $Y=255540
X2396 1905 313 345 2189 1747 1719 1 2 2296 OA222 $T=620000 296240 0 0 $X=620000 $Y=295860
X2397 313 2290 354 2284 1719 2295 1 2 2105 OA222 $T=621240 296240 1 0 $X=621240 $Y=290820
X2398 1809 2285 1861 2311 348 2310 1 2 2182 OA222 $T=639840 245840 0 180 $X=634260 $Y=240420
X2399 602 2767 2758 2773 609 2782 1 2 2803 OA222 $T=820880 235760 1 0 $X=820880 $Y=230340
X2400 647 614 2843 2866 642 2828 1 2 2812 OA222 $T=843200 316400 0 180 $X=837620 $Y=310980
X2401 2880 2885 646 2894 2799 2899 1 2 2904 OA222 $T=842580 235760 0 0 $X=842580 $Y=235380
X2402 2799 2739 2744 2945 646 2952 1 2 2957 OA222 $T=854980 245840 1 0 $X=854980 $Y=240420
X2403 650 649 2972 685 2843 2866 1 2 2954 OA222 $T=865520 286160 1 180 $X=859940 $Y=285780
X2404 2972 685 688 2956 601 2959 1 2 2949 OA222 $T=866140 276080 0 180 $X=860560 $Y=270660
X2405 2843 697 2997 2942 663 636 1 2 2933 OA222 $T=871720 286160 1 180 $X=866140 $Y=285780
X2406 2903 694 2880 2959 2964 692 1 2 3001 OA222 $T=875440 276080 1 180 $X=869860 $Y=275700
X2407 646 707 663 664 709 687 1 2 2990 OA222 $T=879780 316400 1 180 $X=874200 $Y=316020
X2408 3034 2997 690 2883 707 672 1 2 607 OA222 $T=880400 286160 0 180 $X=874820 $Y=280740
X2409 2997 2999 2964 3023 2903 2993 1 2 3038 OA222 $T=876060 266000 1 0 $X=876060 $Y=260580
X2410 2838 3051 2774 3042 2744 3039 1 2 2931 OA222 $T=885980 225680 0 180 $X=880400 $Y=220260
X2411 690 3073 2964 3066 3062 3034 1 2 2936 OA222 $T=890320 276080 1 180 $X=884740 $Y=275700
X2412 2972 3113 3111 3094 655 2959 1 2 3091 OA222 $T=902720 276080 1 180 $X=897140 $Y=275700
X2413 654 3103 2838 3108 646 2961 1 2 3123 OA222 $T=897760 235760 1 0 $X=897760 $Y=230340
X2414 3142 3112 697 729 3111 3030 1 2 727 OA222 $T=907060 286160 1 180 $X=901480 $Y=285780
X2415 650 736 3142 3143 3111 3133 1 2 733 OA222 $T=912640 296240 0 180 $X=907060 $Y=290820
X2416 664 728 734 3144 662 3146 1 2 3086 OA222 $T=912640 306320 1 180 $X=907060 $Y=305940
X2417 662 712 2939 693 658 734 1 2 3165 OA222 $T=910780 306320 1 0 $X=910780 $Y=300900
X2418 664 3144 738 734 2903 3170 1 2 3162 OA222 $T=912640 296240 1 0 $X=912640 $Y=290820
X2419 646 3178 2774 3172 2838 3168 1 2 3154 OA222 $T=920700 225680 1 180 $X=915120 $Y=225300
X2420 668 748 2972 2880 3151 669 1 2 3175 OA222 $T=923800 296240 0 180 $X=918220 $Y=290820
X2421 672 3196 2744 3206 2838 3214 1 2 3229 OA222 $T=926900 225680 1 0 $X=926900 $Y=220260
X2422 756 725 2972 3223 663 3217 1 2 3243 OA222 $T=935580 296240 1 0 $X=935580 $Y=290820
X2423 3228 614 2843 3184 3236 605 1 2 3240 OA222 $T=936200 296240 0 0 $X=936200 $Y=295860
X2424 609 3230 2835 3239 646 3244 1 2 3233 OA222 $T=938060 225680 1 0 $X=938060 $Y=220260
X2425 3174 2939 3151 3246 655 3126 1 2 3009 OA222 $T=945500 276080 1 180 $X=939920 $Y=275700
X2426 2774 3251 2827 3252 2835 3195 1 2 3236 OA222 $T=947360 255920 0 180 $X=941780 $Y=250500
X2427 709 651 663 617 664 650 1 2 3259 OA222 $T=943640 306320 1 0 $X=943640 $Y=300900
X2428 3257 614 2903 3269 663 765 1 2 764 OA222 $T=953560 316400 1 180 $X=947980 $Y=316020
X2429 663 652 611 2964 2903 3278 1 2 3281 OA222 $T=951700 296240 1 0 $X=951700 $Y=290820
X2430 628 739 663 3266 2997 3280 1 2 3279 OA222 $T=952320 306320 0 0 $X=952320 $Y=305940
X2431 2774 3261 2835 3285 2827 3271 1 2 3286 OA222 $T=955420 225680 0 0 $X=955420 $Y=225300
X2432 3292 605 3126 3288 664 738 1 2 3283 OA222 $T=962860 296240 0 180 $X=957280 $Y=290820
X2433 2774 3289 2827 3273 2835 3294 1 2 3292 OA222 $T=959760 255920 0 0 $X=959760 $Y=255540
X2434 2997 701 3151 3296 2903 3308 1 2 3262 OA222 $T=963480 286160 1 0 $X=963480 $Y=280740
X2435 3174 3253 3126 3313 2883 3314 1 2 3247 OA222 $T=969060 286160 1 0 $X=969060 $Y=280740
X2436 50 1156 2 1 1134 OR2 $T=285200 255920 0 180 $X=282720 $Y=250500
X2437 87 1157 2 1 1184 OR2 $T=289540 276080 0 0 $X=289540 $Y=275700
X2438 1075 942 2 1 1247 OR2 $T=311860 306320 1 0 $X=311860 $Y=300900
X2439 1344 216 2 1 224 OR2 $T=355880 316400 1 0 $X=355880 $Y=310980
X2440 1793 1802 2 1 1787 OR2 $T=512120 286160 0 180 $X=509640 $Y=280740
X2441 421 2043 2 1 2089 OR2 $T=566680 255920 1 0 $X=566680 $Y=250500
X2442 1862 2183 2 1 2191 OR2 $T=594580 225680 0 180 $X=592100 $Y=220260
X2443 2328 497 2 1 501 OR2 $T=651000 316400 1 0 $X=651000 $Y=310980
X2444 526 2449 2 1 2498 OR2 $T=714240 306320 0 180 $X=711760 $Y=300900
X2445 518 525 2 1 2449 OR2 $T=715480 306320 1 0 $X=715480 $Y=300900
X2446 2612 2685 2 1 2634 OR2 $T=789260 296240 0 180 $X=786780 $Y=290820
X2447 659 647 2 1 3095 OR2 $T=894040 316400 1 0 $X=894040 $Y=310980
X2448 642 738 2 1 3176 OR2 $T=916360 306320 1 0 $X=916360 $Y=300900
X2449 668 745 2 1 3221 OR2 $T=933100 296240 0 0 $X=933100 $Y=295860
X2450 885 1 882 868 870 2 ND3S $T=223820 286160 0 180 $X=221340 $Y=280740
X2451 944 1 44 908 14 2 ND3S $T=233740 255920 0 180 $X=231260 $Y=250500
X2452 1010 1 933 966 995 2 ND3S $T=247380 255920 0 180 $X=244900 $Y=250500
X2453 1038 1 1017 921 933 2 ND3S $T=254200 286160 0 180 $X=251720 $Y=280740
X2454 1017 1 1090 1060 1065 2 ND3S $T=265980 235760 1 180 $X=263500 $Y=235380
X2455 1098 1 1017 116 118 2 ND3S $T=267220 286160 1 0 $X=267220 $Y=280740
X2456 960 1 1106 123 113 2 ND3S $T=270320 296240 1 0 $X=270320 $Y=290820
X2457 1142 1 1054 998 995 2 ND3S $T=278380 245840 0 180 $X=275900 $Y=240420
X2458 1189 1 14 1182 1131 2 ND3S $T=295120 255920 1 180 $X=292640 $Y=255540
X2459 1214 1 44 1304 14 2 ND3S $T=342240 255920 1 180 $X=339760 $Y=255540
X2460 199 1 1318 1102 213 2 ND3S $T=347200 296240 1 180 $X=344720 $Y=295860
X2461 1328 1 214 44 213 2 ND3S $T=347820 306320 1 180 $X=345340 $Y=305940
X2462 213 1 198 918 1318 2 ND3S $T=349680 286160 0 180 $X=347200 $Y=280740
X2463 1344 1 217 909 213 2 ND3S $T=352780 286160 1 180 $X=350300 $Y=285780
X2464 1726 1 1714 1750 1747 2 ND3S $T=500340 235760 1 0 $X=500340 $Y=230340
X2465 1834 1 1848 1853 1852 2 ND3S $T=517080 276080 1 0 $X=517080 $Y=270660
X2466 1916 1 1758 1765 1907 2 ND3S $T=531340 245840 0 180 $X=528860 $Y=240420
X2467 1915 1 1726 1898 1926 2 ND3S $T=531340 266000 1 0 $X=531340 $Y=260580
X2468 2015 1 1905 2005 1887 2 ND3S $T=550560 225680 1 180 $X=548080 $Y=225300
X2469 2156 1 1926 2175 1907 2 ND3S $T=583420 245840 1 0 $X=583420 $Y=240420
X2470 2269 1 1726 2046 2265 2 ND3S $T=613800 286160 1 180 $X=611320 $Y=285780
X2471 1997 1 1887 2286 2201 2 ND3S $T=628680 235760 0 180 $X=626200 $Y=230340
X2472 2302 1 2115 2229 382 2 ND3S $T=630540 296240 0 180 $X=628060 $Y=290820
X2473 1885 1 1905 2313 1887 2 ND3S $T=633640 235760 1 0 $X=633640 $Y=230340
X2474 2320 1 493 1905 492 2 ND3S $T=642320 296240 1 180 $X=639840 $Y=295860
X2475 492 1 481 1927 2319 2 ND3S $T=644180 286160 0 180 $X=641700 $Y=280740
X2476 482 1 2319 2062 492 2 ND3S $T=644180 306320 0 180 $X=641700 $Y=300900
X2477 2328 1 495 1813 492 2 ND3S $T=647900 286160 1 180 $X=645420 $Y=285780
X2478 665 1 601 2906 669 2 ND3S $T=849400 245840 0 0 $X=849400 $Y=245460
X2479 2927 1 2930 2757 2933 2 ND3S $T=852500 296240 1 0 $X=852500 $Y=290820
X2480 2912 1 2936 2752 2949 2 ND3S $T=854360 276080 1 0 $X=854360 $Y=270660
X2481 2955 1 2998 2783 2992 2 ND3S $T=870480 306320 0 180 $X=868000 $Y=300900
X2482 2896 1 708 2913 3022 2 ND3S $T=876060 255920 0 0 $X=876060 $Y=255540
X2483 3074 1 3022 3052 3007 2 ND3S $T=884740 235760 0 180 $X=882260 $Y=230340
X2484 3006 1 3063 2946 3070 2 ND3S $T=885980 266000 1 0 $X=885980 $Y=260580
X2485 3109 1 2893 3054 3063 2 ND3S $T=899000 235760 1 180 $X=896520 $Y=235380
X2486 3043 1 3112 3106 3096 2 ND3S $T=902720 266000 0 180 $X=900240 $Y=260580
X2487 3063 1 608 3130 601 2 ND3S $T=907060 255920 1 180 $X=904580 $Y=255540
X2488 2979 1 692 3163 690 2 ND3S $T=907060 245840 0 0 $X=907060 $Y=245460
X2489 3148 1 690 3138 2979 2 ND3S $T=910160 245840 0 180 $X=907680 $Y=240420
X2490 3155 1 661 3107 3125 2 ND3S $T=913260 255920 1 180 $X=910780 $Y=255540
X2491 3063 1 3179 3177 3030 2 ND3S $T=918840 266000 1 0 $X=918840 $Y=260580
X2492 3171 1 692 3187 661 2 ND3S $T=921320 266000 1 0 $X=921320 $Y=260580
X2493 3230 1 3117 3186 3193 2 ND3S $T=931860 245840 0 180 $X=929380 $Y=240420
X2494 3220 1 3070 3222 3194 2 ND3S $T=933100 255920 0 0 $X=933100 $Y=255540
X2495 3264 1 3122 3255 3148 2 ND3S $T=951700 266000 1 0 $X=951700 $Y=260580
X2496 3112 1 661 3231 2939 2 ND3S $T=957280 255920 1 180 $X=954800 $Y=255540
X2497 669 1 2943 3305 701 2 ND3S $T=963480 266000 1 0 $X=963480 $Y=260580
X2498 982 920 923 2 1 967 AN3 $T=242420 266000 1 180 $X=238700 $Y=265620
X2499 1048 81 1073 2 1 1038 AN3 $T=264740 276080 1 180 $X=261020 $Y=275700
X2500 126 124 120 2 1 1094 AN3 $T=273420 316400 1 180 $X=269700 $Y=316020
X2501 1155 142 1107 2 1 928 AN3 $T=284580 235760 0 180 $X=280860 $Y=230340
X2502 1196 1163 1177 2 1 1232 AN3 $T=313100 286160 1 180 $X=309380 $Y=285780
X2503 175 1192 177 2 1 126 AN3 $T=313720 316400 0 0 $X=313720 $Y=316020
X2504 1255 179 1245 2 1 1229 AN3 $T=316820 316400 1 0 $X=316820 $Y=310980
X2505 47 1138 1151 2 1 1213 AN3 $T=319920 276080 0 0 $X=319920 $Y=275700
X2506 1091 920 1167 2 1 1278 AN3 $T=320540 276080 1 0 $X=320540 $Y=270660
X2507 266 1576 1418 2 1 1581 AN3 $T=437100 266000 0 0 $X=437100 $Y=265620
X2508 1777 323 1799 2 1 1723 AN3 $T=509020 296240 0 0 $X=509020 $Y=295860
X2509 1821 328 327 2 1 1730 AN3 $T=514600 306320 1 180 $X=510880 $Y=305940
X2510 1932 1839 1864 2 1 1915 AN3 $T=535060 255920 0 180 $X=531340 $Y=250500
X2511 1938 371 1930 2 1 1921 AN3 $T=536300 306320 1 180 $X=532580 $Y=305940
X2512 1985 1983 320 2 1 1963 AN3 $T=545600 296240 1 180 $X=541880 $Y=295860
X2513 2079 2071 2073 2 1 1985 AN3 $T=566680 296240 1 180 $X=562960 $Y=295860
X2514 2123 432 2110 2 1 1996 AN3 $T=574740 306320 1 180 $X=571020 $Y=305940
X2515 2171 2036 1883 2 1 2142 AN3 $T=585900 225680 0 180 $X=582180 $Y=220260
X2516 2264 2253 2184 2 1 2247 AN3 $T=619380 255920 1 180 $X=615660 $Y=255540
X2517 1893 2040 2185 2 1 2282 AN3 $T=631780 235760 1 180 $X=628060 $Y=235380
X2518 2288 2253 2316 2 1 2309 AN3 $T=642940 255920 1 180 $X=639220 $Y=255540
X2519 2250 2212 2070 2 1 2335 AN3 $T=654100 276080 0 0 $X=654100 $Y=275700
X2520 2963 2943 2899 2 1 2942 AN3 $T=860560 255920 0 180 $X=856840 $Y=250500
X2521 3044 3035 3033 2 1 2780 AN3 $T=882260 286160 1 180 $X=878540 $Y=285780
X2522 3165 3175 3180 2 1 747 AN3 $T=918220 296240 0 0 $X=918220 $Y=295860
X2523 750 749 3201 2 1 2868 AN3 $T=928760 316400 1 180 $X=925040 $Y=316020
X2524 868 2 893 7 6 1 NR3 $T=223820 316400 0 180 $X=220720 $Y=310980
X2525 908 2 23 892 895 1 NR3 $T=228780 255920 0 180 $X=225680 $Y=250500
X2526 914 2 871 924 884 1 NR3 $T=228780 235760 0 0 $X=228780 $Y=235380
X2527 927 2 938 946 905 1 NR3 $T=232500 296240 1 0 $X=232500 $Y=290820
X2528 930 2 30 951 937 1 NR3 $T=233740 255920 0 0 $X=233740 $Y=255540
X2529 959 2 969 974 948 1 NR3 $T=237460 255920 1 0 $X=237460 $Y=250500
X2530 964 2 973 977 63 1 NR3 $T=238080 296240 1 0 $X=238080 $Y=290820
X2531 970 2 924 980 947 1 NR3 $T=238700 235760 1 0 $X=238700 $Y=230340
X2532 1004 2 890 1015 1010 1 NR3 $T=248000 255920 1 0 $X=248000 $Y=250500
X2533 1045 2 1037 1026 992 1 NR3 $T=256680 255920 1 180 $X=253580 $Y=255540
X2534 1032 2 97 1041 1019 1 NR3 $T=253580 296240 0 0 $X=253580 $Y=295860
X2535 1060 2 1056 994 1040 1 NR3 $T=260400 235760 1 180 $X=257300 $Y=235380
X2536 1059 2 1062 1069 1076 1 NR3 $T=259780 286160 0 0 $X=259780 $Y=285780
X2537 1015 2 30 1100 1098 1 NR3 $T=265980 276080 0 0 $X=265980 $Y=275700
X2538 1124 2 110 1123 1114 1 NR3 $T=272180 306320 0 0 $X=272180 $Y=305940
X2539 1121 2 946 1003 1128 1 NR3 $T=275900 296240 0 180 $X=272800 $Y=290820
X2540 1147 2 1140 946 1047 1 NR3 $T=283340 255920 1 180 $X=280240 $Y=255540
X2541 145 2 1221 1113 1132 1 NR3 $T=285820 306320 1 180 $X=282720 $Y=305940
X2542 951 2 1168 1164 1166 1 NR3 $T=286440 245840 1 0 $X=286440 $Y=240420
X2543 1182 2 1015 87 1181 1 NR3 $T=292020 255920 1 180 $X=288920 $Y=255540
X2544 1044 2 1194 1168 1203 1 NR3 $T=294500 235760 0 0 $X=294500 $Y=235380
X2545 1218 2 1194 1100 1193 1 NR3 $T=299460 225680 1 180 $X=296360 $Y=225300
X2546 1158 2 130 1218 1209 1 NR3 $T=304420 235760 1 0 $X=304420 $Y=230340
X2547 1206 2 168 1231 1235 1 NR3 $T=306280 316400 1 0 $X=306280 $Y=310980
X2548 1100 2 1139 1164 1248 1 NR3 $T=316200 245840 1 180 $X=313100 $Y=245460
X2549 1274 2 1272 1267 182 1 NR3 $T=322400 266000 1 180 $X=319300 $Y=265620
X2550 1268 2 1286 1282 1108 1 NR3 $T=323020 306320 1 0 $X=323020 $Y=300900
X2551 1293 2 1291 1280 189 1 NR3 $T=331080 276080 1 180 $X=327980 $Y=275700
X2552 1308 2 926 1127 196 1 NR3 $T=336040 276080 1 180 $X=332940 $Y=275700
X2553 1313 2 1279 980 1310 1 NR3 $T=341000 245840 1 0 $X=341000 $Y=240420
X2554 214 2 216 198 1320 1 NR3 $T=346580 286160 0 0 $X=346580 $Y=285780
X2555 219 2 217 220 1330 1 NR3 $T=355260 316400 0 180 $X=352160 $Y=310980
X2556 1339 2 1056 1333 1327 1 NR3 $T=352780 245840 0 0 $X=352780 $Y=245460
X2557 1750 2 1763 1770 1740 1 NR3 $T=504680 235760 1 0 $X=504680 $Y=230340
X2558 1773 2 318 1785 1720 1 NR3 $T=506540 306320 0 0 $X=506540 $Y=305940
X2559 1779 2 1785 1791 322 1 NR3 $T=507160 306320 1 0 $X=507160 $Y=300900
X2560 1801 2 1763 1812 1736 1 NR3 $T=510880 245840 0 0 $X=510880 $Y=245460
X2561 1842 2 1790 1826 1823 1 NR3 $T=517700 266000 0 180 $X=514600 $Y=260580
X2562 1846 2 1874 1774 1744 1 NR3 $T=518320 225680 0 180 $X=515220 $Y=220260
X2563 1853 2 1845 1828 326 1 NR3 $T=519560 286160 1 180 $X=516460 $Y=285780
X2564 1775 2 343 342 1877 1 NR3 $T=522660 316400 1 180 $X=519560 $Y=316020
X2565 1860 2 1869 1721 1857 1 NR3 $T=520800 276080 0 0 $X=520800 $Y=275700
X2566 1912 2 1906 1721 1913 1 NR3 $T=530720 255920 0 180 $X=527620 $Y=250500
X2567 1914 2 355 1903 1820 1 NR3 $T=530720 296240 1 180 $X=527620 $Y=295860
X2568 1918 2 1923 1925 1882 1 NR3 $T=531340 245840 1 0 $X=531340 $Y=240420
X2569 1942 2 1836 1784 1934 1 NR3 $T=537540 296240 1 180 $X=534440 $Y=295860
X2570 1957 2 1950 1946 1944 1 NR3 $T=539400 276080 0 180 $X=536300 $Y=270660
X2571 1987 2 1988 1992 391 1 NR3 $T=544360 245840 1 0 $X=544360 $Y=240420
X2572 2016 2 1989 1904 392 1 NR3 $T=547460 306320 0 180 $X=544360 $Y=300900
X2573 2013 2 385 2022 2039 1 NR3 $T=549940 286160 0 0 $X=549940 $Y=285780
X2574 2033 2 2026 2027 2012 1 NR3 $T=554900 276080 1 180 $X=551800 $Y=275700
X2575 1991 2 2045 2060 2031 1 NR3 $T=557380 225680 1 0 $X=557380 $Y=220260
X2576 2082 2 2068 1923 1886 1 NR3 $T=567300 245840 1 180 $X=564200 $Y=245460
X2577 2060 2 2068 2096 2101 1 NR3 $T=567920 225680 1 0 $X=567920 $Y=220260
X2578 2065 2 2094 2095 2088 1 NR3 $T=567920 235760 0 0 $X=567920 $Y=235380
X2579 428 2 2107 2114 2100 1 NR3 $T=571020 286160 0 0 $X=571020 $Y=285780
X2580 2125 2 423 2140 2130 1 NR3 $T=577840 266000 0 0 $X=577840 $Y=265620
X2581 2136 2 1924 2157 2156 1 NR3 $T=584040 245840 0 0 $X=584040 $Y=245460
X2582 2163 2 2166 2170 1849 1 NR3 $T=585900 296240 0 0 $X=585900 $Y=295860
X2583 2164 2 2205 2209 2090 1 NR3 $T=593960 306320 1 0 $X=593960 $Y=300900
X2584 2096 2 1977 1925 1847 1 NR3 $T=602640 245840 1 180 $X=599540 $Y=245460
X2585 2176 2 2124 2235 1815 1 NR3 $T=600780 235760 1 0 $X=600780 $Y=230340
X2586 2249 2 2256 2258 2059 1 NR3 $T=607600 286160 0 0 $X=607600 $Y=285780
X2587 2271 2 2272 2275 470 1 NR3 $T=614420 286160 0 0 $X=614420 $Y=285780
X2588 2157 2 471 2096 2269 1 NR3 $T=616900 245840 0 0 $X=616900 $Y=245460
X2589 2286 2 2157 421 2274 1 NR3 $T=621860 235760 1 180 $X=618760 $Y=235380
X2590 2287 2 2291 1774 2281 1 NR3 $T=621860 225680 1 0 $X=621860 $Y=220260
X2591 2299 2 2292 2146 480 1 NR3 $T=629300 255920 1 180 $X=626200 $Y=255540
X2592 2301 2 1721 2276 2280 1 NR3 $T=630540 276080 1 180 $X=627440 $Y=275700
X2593 2313 2 446 2315 2254 1 NR3 $T=637980 235760 1 0 $X=637980 $Y=230340
X2594 491 2 495 496 2314 1 NR3 $T=637980 316400 0 0 $X=637980 $Y=316020
X2595 2332 2 2327 2291 2326 1 NR3 $T=649140 235760 0 180 $X=646040 $Y=230340
X2596 493 2 497 481 2324 1 NR3 $T=646040 296240 0 0 $X=646040 $Y=295860
X2597 2227 2 471 1918 2342 1 NR3 $T=652860 255920 0 0 $X=652860 $Y=255540
X2598 2751 2 2766 2763 610 1 NR3 $T=820880 306320 1 0 $X=820880 $Y=300900
X2599 2794 2 2747 2777 2738 1 NR3 $T=826460 296240 1 180 $X=823360 $Y=295860
X2600 2783 2 2790 2792 2748 1 NR3 $T=824600 306320 1 0 $X=824600 $Y=300900
X2601 2811 2 619 2819 2773 1 NR3 $T=829560 225680 0 0 $X=829560 $Y=225300
X2602 2856 2 2863 2869 2824 1 NR3 $T=838240 286160 0 0 $X=838240 $Y=285780
X2603 2873 2 2897 2901 2881 1 NR3 $T=845060 306320 1 0 $X=845060 $Y=300900
X2604 2850 2 2844 2922 2956 1 NR3 $T=860560 276080 0 180 $X=857460 $Y=270660
X2605 2966 2 2888 2790 2982 1 NR3 $T=866140 306320 1 180 $X=863040 $Y=305940
X2606 2865 2 2853 3004 2962 1 NR3 $T=868620 225680 0 0 $X=868620 $Y=225300
X2607 3092 2 3088 3083 2998 1 NR3 $T=895900 286160 0 180 $X=892800 $Y=280740
X2608 3100 2 653 3027 3103 1 NR3 $T=897760 235760 0 180 $X=894660 $Y=230340
X2609 3107 2 640 3116 3108 1 NR3 $T=899620 235760 0 0 $X=899620 $Y=235380
X2610 3124 2 2989 3036 3114 1 NR3 $T=903960 255920 1 180 $X=900860 $Y=255540
X2611 3138 2 3076 2978 3147 1 NR3 $T=906440 235760 1 180 $X=903340 $Y=235380
X2612 3084 2 619 3134 3109 1 NR3 $T=903960 245840 1 0 $X=903960 $Y=240420
X2613 3130 2 3116 3140 3121 1 NR3 $T=905200 266000 1 0 $X=905200 $Y=260580
X2614 3118 2 3135 3141 3045 1 NR3 $T=905200 286160 1 0 $X=905200 $Y=280740
X2615 3134 2 2908 2878 3171 1 NR3 $T=916980 255920 0 180 $X=913880 $Y=250500
X2616 3084 2 714 3129 3172 1 NR3 $T=918220 235760 1 0 $X=918220 $Y=230340
X2617 3192 2 680 717 3184 1 NR3 $T=924420 306320 0 180 $X=921320 $Y=300900
X2618 3163 2 3199 3173 3196 1 NR3 $T=925040 245840 1 0 $X=925040 $Y=240420
X2619 3224 2 2989 2854 3203 1 NR3 $T=935580 245840 0 180 $X=932480 $Y=240420
X2620 3222 2 2853 2819 3206 1 NR3 $T=933720 225680 1 0 $X=933720 $Y=220260
X2621 3124 2 666 3231 3271 1 NR3 $T=954180 255920 0 180 $X=951080 $Y=250500
X2622 3304 2 2791 2889 3302 1 NR3 $T=965340 235760 1 180 $X=962240 $Y=235380
X2623 3150 2 3145 3310 3293 1 NR3 $T=967200 235760 1 0 $X=967200 $Y=230340
X2624 3301 2 776 3309 2969 1 NR3 $T=967820 306320 0 0 $X=967820 $Y=305940
X2625 3305 2 758 3056 3311 1 NR3 $T=972160 276080 0 180 $X=969060 $Y=270660
X2626 3291 2 3312 3306 3303 1 NR3 $T=969060 276080 0 0 $X=969060 $Y=275700
X2627 3197 2 3312 3199 3276 1 NR3 $T=973400 276080 1 0 $X=973400 $Y=270660
X2628 1107 1032 1102 1054 2 942 1 AOI13HS $T=270320 296240 0 180 $X=266600 $Y=290820
X2629 1248 1286 1167 34 2 917 1 AOI13HS $T=325500 286160 0 0 $X=325500 $Y=285780
X2630 1883 2125 2062 1758 2 1802 1 AOI13HS $T=577840 266000 1 180 $X=574120 $Y=265620
X2631 1847 2256 2184 455 2 1861 1 AOI13HS $T=609460 266000 0 0 $X=609460 $Y=265620
X2632 1528 1363 1378 1 2 OR2P $T=417880 255920 1 0 $X=417880 $Y=250500
X2633 878 2 890 1 16 NR2P $T=225060 245840 1 180 $X=221340 $Y=245460
X2634 969 2 1139 1 1017 NR2P $T=277140 245840 0 0 $X=277140 $Y=245460
X2635 251 2 261 1 1514 NR2P $T=415400 296240 1 180 $X=411680 $Y=295860
X2636 260 2 1535 1 1505 NR2P $T=419120 266000 0 0 $X=419120 $Y=265620
X2637 261 2 1485 1 1535 NR2P $T=419120 296240 1 0 $X=419120 $Y=290820
X2638 1585 2 1575 1 1603 NR2P $T=438960 306320 0 0 $X=438960 $Y=305940
X2639 1619 2 1615 1 1585 NR2P $T=450120 306320 1 0 $X=450120 $Y=300900
X2640 1694 2 1685 1 1651 NR2P $T=479260 286160 1 0 $X=479260 $Y=280740
X2641 1694 2 1707 1 1700 NR2P $T=486080 286160 1 0 $X=486080 $Y=280740
X2642 2498 2 2499 1 2494 NR2P $T=711760 306320 0 0 $X=711760 $Y=305940
X2643 2449 2 2464 1 2497 NR2P $T=718580 296240 0 0 $X=718580 $Y=295860
X2644 2634 2 2604 1 2608 NR2P $T=765080 296240 0 0 $X=765080 $Y=295860
X2645 2634 2 2616 1 2628 NR2P $T=766320 286160 0 0 $X=766320 $Y=285780
X2646 2671 2 2674 1 2667 NR2P $T=786160 286160 0 180 $X=782440 $Y=280740
X2647 2671 2 2676 1 2662 NR2P $T=786780 276080 0 0 $X=786780 $Y=275700
X2648 2671 2 576 1 2687 NR2P $T=789880 266000 0 0 $X=789880 $Y=265620
X2649 640 2 2819 1 669 NR2P $T=850640 255920 1 0 $X=850640 $Y=250500
X2650 2943 2 605 1 616 NR2P $T=854980 266000 0 0 $X=854980 $Y=265620
X2651 2994 2 2819 1 3022 NR2P $T=879160 225680 0 180 $X=875440 $Y=220260
X2652 2835 605 3096 3095 1 2 2861 OA13S $T=899000 266000 1 180 $X=894660 $Y=265620
X2653 1003 969 15 2 1 1041 OA12S $T=252960 296240 1 0 $X=252960 $Y=290820
X2654 2276 2124 353 2 1 2140 OA12S $T=618140 276080 0 180 $X=614420 $Y=270660
X2655 83 925 1 88 2 1009 OAI12HS $T=249240 255920 0 0 $X=249240 $Y=255540
X2656 911 1096 1 26 2 1095 OAI12HS $T=265980 266000 1 0 $X=265980 $Y=260580
X2657 134 969 1 147 2 1171 OAI12HS $T=283960 306320 1 0 $X=283960 $Y=300900
X2658 1370 1363 1 1365 2 1390 OAI12HS $T=373860 245840 0 0 $X=373860 $Y=245460
X2659 236 235 1 260 2 1567 OAI12HS $T=434000 225680 1 0 $X=434000 $Y=220260
X2660 2118 407 1 386 2 2154 OAI12HS $T=582180 296240 0 0 $X=582180 $Y=295860
X2661 2208 2141 1 1868 2 2131 OAI12HS $T=596440 245840 0 180 $X=592720 $Y=240420
X2662 419 2218 1 2165 2 2011 OAI12HS $T=598300 255920 1 0 $X=598300 $Y=250500
X2663 464 2124 1 362 2 2236 OAI12HS $T=610700 296240 1 0 $X=610700 $Y=290820
X2664 742 3197 1 648 2 3198 OAI12HS $T=924420 276080 1 0 $X=924420 $Y=270660
X2665 719 621 1 641 2 3209 OAI12HS $T=926280 306320 0 0 $X=926280 $Y=305940
X2666 1757 312 225 283 1 2 QDFFRBP $T=502200 296240 0 180 $X=489800 $Y=290820
X2667 1755 312 225 284 1 2 QDFFRBP $T=503440 296240 1 180 $X=491040 $Y=295860
X2668 2735 598 592 571 1 2 QDFFRBP $T=812200 316400 0 180 $X=799800 $Y=310980
X2669 2815 598 592 526 1 2 QDFFRBP $T=826460 306320 1 180 $X=814060 $Y=305940
X2670 1371 1375 1380 1 2 1376 MAO222 $T=364560 286160 0 0 $X=364560 $Y=285780
X2671 1372 1376 1385 1 2 1381 MAO222 $T=364560 306320 1 0 $X=364560 $Y=300900
X2672 1383 1381 226 1 2 230 MAO222 $T=365180 316400 1 0 $X=365180 $Y=310980
X2673 1397 1393 1389 1 2 1375 MAO222 $T=368900 276080 1 0 $X=368900 $Y=270660
X2674 1544 1551 1548 1 2 1499 MAO222 $T=425320 255920 1 0 $X=425320 $Y=250500
X2675 1602 1600 1605 1 2 1555 MAO222 $T=442680 235760 1 0 $X=442680 $Y=230340
X2676 1647 1631 1653 1 2 1600 MAO222 $T=461900 235760 1 0 $X=461900 $Y=230340
X2677 2344 2345 2346 1 2 2348 MAO222 $T=655340 286160 1 0 $X=655340 $Y=280740
X2678 2380 2385 2374 1 2 2382 MAO222 $T=668360 296240 0 0 $X=668360 $Y=295860
X2679 2388 2386 2377 1 2 2385 MAO222 $T=670220 286160 0 0 $X=670220 $Y=285780
X2680 2394 2383 2376 1 2 2387 MAO222 $T=672700 255920 0 0 $X=672700 $Y=255540
X2681 2355 2382 2359 1 2 514 MAO222 $T=677040 316400 1 0 $X=677040 $Y=310980
X2682 2459 2457 2455 1 2 2426 MAO222 $T=701840 255920 0 180 $X=696880 $Y=250500
X2683 2459 2457 2455 1 2 2454 MAO222 $T=702460 245840 0 180 $X=697500 $Y=240420
X2684 2484 2485 2490 1 2 2475 MAO222 $T=706180 276080 1 0 $X=706180 $Y=270660
X2685 2522 2521 2502 1 2 2531 MAO222 $T=721680 255920 1 0 $X=721680 $Y=250500
X2686 2525 2523 2529 1 2 2522 MAO222 $T=722300 266000 0 0 $X=722300 $Y=265620
X2687 2517 2531 2524 1 2 2516 MAO222 $T=724160 245840 0 0 $X=724160 $Y=245460
X2688 2575 2588 2578 1 2 2558 MAO222 $T=757020 225680 1 180 $X=752060 $Y=225300
X2689 2640 2647 2637 1 2 2643 MAO222 $T=770040 255920 1 0 $X=770040 $Y=250500
X2690 2646 2650 2641 1 2 2647 MAO222 $T=771280 255920 0 0 $X=771280 $Y=255540
X2691 300 1682 2 1680 1 1658 MUX2S $T=480500 306320 1 180 $X=476160 $Y=305940
X2692 1480 242 2 1 1459 238 MUX2 $T=400520 306320 1 180 $X=396180 $Y=305940
X2693 1482 242 2 1 1439 240 MUX2 $T=402380 316400 0 180 $X=398040 $Y=310980
X2694 1484 243 2 1 246 247 MUX2 $T=404240 316400 0 0 $X=404240 $Y=316020
X2695 1501 242 2 1 1433 245 MUX2 $T=409200 306320 1 180 $X=404860 $Y=305940
X2696 1531 258 2 1 249 255 MUX2 $T=422220 316400 1 180 $X=417880 $Y=316020
X2697 1610 272 2 1 1413 271 MUX2 $T=447640 316400 1 180 $X=443300 $Y=316020
X2698 1628 272 2 1 1558 275 MUX2 $T=453840 316400 1 180 $X=449500 $Y=316020
X2699 1690 298 2 1 1668 291 MUX2 $T=479260 316400 0 180 $X=474920 $Y=310980
X2700 293 301 2 1 295 296 MUX2 $T=482360 316400 1 180 $X=478020 $Y=316020
X2701 1705 298 2 1 1655 299 MUX2 $T=485460 296240 0 180 $X=481120 $Y=290820
X2702 1688 298 2 1 1656 307 MUX2 $T=482360 296240 0 0 $X=482360 $Y=295860
X2703 1709 301 2 1 302 303 MUX2 $T=487320 316400 1 180 $X=482980 $Y=316020
X2704 1712 301 2 1 1680 304 MUX2 $T=487940 316400 0 180 $X=483600 $Y=310980
X2705 1711 298 2 1 1666 305 MUX2 $T=489180 306320 1 180 $X=484840 $Y=305940
X2706 2456 518 2 1 2408 519 MUX2 $T=699360 306320 1 180 $X=695020 $Y=305940
X2707 2460 518 2 1 2396 520 MUX2 $T=699360 316400 0 180 $X=695020 $Y=310980
X2708 2431 518 2 1 2418 522 MUX2 $T=700600 316400 1 180 $X=696260 $Y=316020
X2709 2486 518 2 1 2407 527 MUX2 $T=707420 306320 1 180 $X=703080 $Y=305940
X2710 535 538 2 1 534 537 MUX2 $T=724780 316400 1 180 $X=720440 $Y=316020
X2711 2598 556 2 1 2569 548 MUX2 $T=756400 306320 0 180 $X=752060 $Y=300900
X2712 2600 556 2 1 2563 550 MUX2 $T=757020 306320 1 180 $X=752680 $Y=305940
X2713 2597 556 2 1 2561 549 MUX2 $T=757640 296240 0 180 $X=753300 $Y=290820
X2714 2594 556 2 1 544 552 MUX2 $T=758260 316400 1 180 $X=753920 $Y=316020
X2715 2614 2612 2 1 2596 557 MUX2 $T=761360 286160 1 180 $X=757020 $Y=285780
X2716 2609 558 2 1 2594 555 MUX2 $T=761360 316400 0 180 $X=757020 $Y=310980
X2717 2621 2612 2 1 2573 559 MUX2 $T=763220 296240 0 180 $X=758880 $Y=290820
X2718 563 558 2 1 554 561 MUX2 $T=763840 316400 1 180 $X=759500 $Y=316020
X2719 2632 567 2 1 560 562 MUX2 $T=766940 316400 0 180 $X=762600 $Y=310980
X2720 570 2639 2 1 2632 566 MUX2 $T=775620 316400 1 180 $X=771280 $Y=316020
X2721 2689 582 2 1 2699 585 MUX2 $T=794840 306320 0 0 $X=794840 $Y=305940
X2722 2702 577 2 1 2691 586 MUX2 $T=794840 316400 1 0 $X=794840 $Y=310980
X2723 2706 582 2 1 2708 588 MUX2 $T=796080 306320 1 0 $X=796080 $Y=300900
X2724 2711 582 2 1 2672 589 MUX2 $T=797940 296240 1 0 $X=797940 $Y=290820
X2725 587 582 2 1 2666 584 MUX2 $T=802280 316400 1 180 $X=797940 $Y=316020
X2726 2700 582 2 1 2721 594 MUX2 $T=801040 296240 0 0 $X=801040 $Y=295860
X2727 2691 582 2 1 2670 595 MUX2 $T=801040 306320 0 0 $X=801040 $Y=305940
X2728 2723 2727 2722 1 2 XOR2H $T=805380 235760 0 0 $X=805380 $Y=235380
X2729 1371 1380 1375 2 1 1362 XNR3 $T=365800 296240 1 0 $X=365800 $Y=290820
X2730 1397 1389 1393 2 1 1407 XNR3 $T=376340 276080 1 0 $X=376340 $Y=270660
X2731 2415 2421 2448 2 1 2397 XNR3 $T=685720 235760 1 0 $X=685720 $Y=230340
X2732 2619 2648 2643 2 1 2655 XNR3 $T=777480 245840 0 0 $X=777480 $Y=245460
X2733 1406 235 1435 2 1439 236 1 AO22S $T=384400 316400 1 0 $X=384400 $Y=310980
X2734 1493 279 1672 2 1678 281 1 AO22P $T=469340 245840 0 0 $X=469340 $Y=245460
X2735 2646 572 2663 2 2667 573 1 AO22P $T=782440 266000 1 0 $X=782440 $Y=260580
X2736 1504 243 248 1520 2 1 MXL2HS $T=409200 316400 0 0 $X=409200 $Y=316020
X2737 2464 525 2431 2479 2 1 MXL2HS $T=700600 316400 1 0 $X=700600 $Y=310980
X2738 2607 558 2600 2617 2 1 MXL2HS $T=758880 306320 0 0 $X=758880 $Y=305940
X2739 236 261 1485 1 2 1559 OR3B1 $T=424080 286160 1 0 $X=424080 $Y=280740
X2740 1418 1619 280 1 2 1642 OR3B1 $T=458180 286160 1 0 $X=458180 $Y=280740
X2741 2410 2449 2463 1 2 2473 OR3B1 $T=699980 276080 1 0 $X=699980 $Y=270660
X2742 2568 2634 2616 1 2 2644 OR3B1 $T=766320 276080 0 0 $X=766320 $Y=275700
X2743 573 2695 2671 1 2 2707 OR3B1 $T=796700 245840 1 0 $X=796700 $Y=240420
X2744 2684 2679 2712 1 2 2727 OR3B1 $T=810340 235760 1 0 $X=810340 $Y=230340
X2745 1445 2 1451 1462 1 AN2B1S $T=389360 286160 0 0 $X=389360 $Y=285780
X2746 1518 2 1514 1519 1 AN2B1S $T=412920 286160 0 0 $X=412920 $Y=285780
X2747 2450 2 2452 2432 1 AN2B1S $T=695640 286160 0 0 $X=695640 $Y=285780
X2748 2506 2 2509 2490 1 AN2B1S $T=716100 286160 1 0 $X=716100 $Y=280740
X2749 279 1645 2 1651 1657 281 1 AOI22H $T=461280 235760 0 0 $X=461280 $Y=235380
X2750 2583 543 2 2584 2579 2568 1 AOI22H $T=768800 235760 0 0 $X=768800 $Y=235380
X2751 572 2722 2 2723 2717 573 1 AOI22H $T=802280 225680 0 0 $X=802280 $Y=225300
X2752 281 279 1701 1 2 1691 OA12 $T=482360 255920 1 0 $X=482360 $Y=250500
X2753 2410 510 2497 1 2 2506 OA12 $T=711760 276080 0 0 $X=711760 $Y=275700
X2754 573 572 2662 1 2 2659 OA12 $T=781820 286160 0 180 $X=778100 $Y=280740
X2755 654 707 2953 1 2 3020 OA12 $T=874200 296240 0 0 $X=874200 $Y=295860
X2756 981 960 1 993 2 AN2S $T=241800 296240 1 0 $X=241800 $Y=290820
X2757 1433 236 1 1443 2 AN2S $T=385640 286160 1 0 $X=385640 $Y=280740
X2758 1585 1418 1 1594 2 AN2S $T=439580 276080 1 0 $X=439580 $Y=270660
X2759 266 1576 1 1589 2 AN2S $T=443920 296240 1 180 $X=441440 $Y=295860
X2760 1859 2302 1 2295 2 AN2S $T=633020 296240 1 180 $X=630540 $Y=295860
X2761 535 536 1 530 2 AN2S $T=719200 316400 1 180 $X=716720 $Y=316020
X2762 1329 1319 1 1331 1374 2 OAI12H $T=352780 266000 0 0 $X=352780 $Y=265620
X2763 1331 1335 1 1336 2 OR2B1S $T=349060 276080 1 0 $X=349060 $Y=270660
X2764 96 890 97 1 2 95 AO12 $T=257920 306320 0 180 $X=254200 $Y=300900
X2765 1067 1058 27 1 2 1042 AO12 $T=261640 266000 0 180 $X=257920 $Y=260580
X2766 976 42 57 1 2 1172 AO12 $T=292020 306320 0 180 $X=288300 $Y=300900
X2767 1449 235 1443 1 2 1429 AO12 $T=389980 286160 1 0 $X=389980 $Y=280740
X2768 1505 1511 1514 1 2 1521 AO12 $T=410440 276080 0 0 $X=410440 $Y=275700
X2769 232 1577 1581 1 2 1507 AO12 $T=437100 286160 1 0 $X=437100 $Y=280740
X2770 232 1588 1594 1 2 1539 AO12 $T=441440 286160 0 0 $X=441440 $Y=285780
X2771 1776 1924 423 1 2 2074 AO12 $T=570400 276080 1 180 $X=566680 $Y=275700
X2772 2153 394 2189 1 2 2223 AO12 $T=596440 296240 1 0 $X=596440 $Y=290820
X2773 2304 2289 348 1 2 2204 AO12 $T=630540 255920 0 180 $X=626820 $Y=250500
X2774 2238 2216 1817 1 2 2200 AO12 $T=636740 296240 1 180 $X=633020 $Y=295860
X2775 2964 3151 2963 1 2 3225 AO12 $T=939920 286160 1 180 $X=936200 $Y=285780
X2776 3022 3270 2903 1 2 3258 AO12 $T=952940 276080 0 180 $X=949220 $Y=270660
X2777 701 620 692 2744 2 1 2971 OA22S $T=872340 245840 1 180 $X=868000 $Y=245460
X2778 3062 2939 661 3073 2 1 3153 OA22S $T=908300 286160 1 0 $X=908300 $Y=280740
X2779 693 3159 3142 692 2 1 3208 OA22S $T=929380 276080 0 0 $X=929380 $Y=275700
X2780 3174 3223 3151 692 2 1 3016 OA22S $T=936200 286160 0 180 $X=931860 $Y=280740
X2781 991 56 985 2 1002 1 1009 AO112 $T=243660 255920 0 0 $X=243660 $Y=255540
X2782 1828 1838 1840 2 318 1 343 AO112 $T=515220 316400 1 0 $X=515220 $Y=310980
X2783 1984 1941 1866 2 2001 1 2011 AO112 $T=544980 266000 1 0 $X=544980 $Y=260580
X2784 599 2747 2743 2 1 2751 OR3 $T=815920 306320 1 0 $X=815920 $Y=300900
X2785 2793 618 2801 2 1 2822 OR3 $T=828320 255920 0 0 $X=828320 $Y=255540
X2786 653 3048 2878 2 1 3079 OR3 $T=887840 255920 1 0 $X=887840 $Y=250500
X2787 3116 3027 3129 2 1 3004 OR3 $T=907680 235760 0 180 $X=903960 $Y=230340
X2788 920 871 2 911 1 907 AN3B2S $T=231260 266000 0 180 $X=227540 $Y=260580
X2789 1034 946 2 1029 1 1021 AN3B2S $T=255440 235760 1 180 $X=251720 $Y=235380
X2790 1143 1157 2 1148 1 1137 AN3B2S $T=290160 266000 1 180 $X=286440 $Y=265620
X2791 1170 1178 2 1295 1 1294 AN3B2S $T=328600 235760 0 0 $X=328600 $Y=235380
X2792 1207 1264 2 1256 1 1303 AN3B2S $T=330460 245840 0 0 $X=330460 $Y=245460
X2793 1722 1721 2 1718 1 1717 AN3B2S $T=499100 245840 1 180 $X=495380 $Y=245460
X2794 317 1775 2 1769 1 1761 AN3B2S $T=509020 316400 0 180 $X=505300 $Y=310980
X2795 1811 1806 2 1804 1 1752 AN3B2S $T=513980 255920 0 180 $X=510260 $Y=250500
X2796 1878 1881 2 1865 1 1871 AN3B2S $T=525760 245840 0 180 $X=522040 $Y=240420
X2797 2061 2043 2 2054 1 2049 AN3B2S $T=562960 255920 1 180 $X=559240 $Y=255540
X2798 2072 2074 2 2077 1 1954 AN3B2S $T=563580 306320 0 0 $X=563580 $Y=305940
X2799 2081 2074 2 2067 1 2110 AN3B2S $T=566060 316400 1 0 $X=566060 $Y=310980
X2800 2253 2327 2 2208 1 2311 AN3B2S $T=647280 245840 0 0 $X=647280 $Y=245460
X2801 2772 2777 2 2776 1 2765 AN3B2S $T=826460 286160 0 180 $X=822740 $Y=280740
X2802 2810 2802 2 2781 1 2798 AN3B2S $T=830800 296240 1 180 $X=827080 $Y=295860
X2803 2920 2754 2 2928 1 2934 AN3B2S $T=851260 296240 0 0 $X=851260 $Y=295860
X2804 2767 2994 2 2978 1 2940 AN3B2S $T=870480 225680 0 180 $X=866760 $Y=220260
X2805 3085 3200 2 3197 1 2993 AN3B2S $T=928140 266000 0 180 $X=924420 $Y=260580
X2806 3170 3134 2 3071 1 3298 AN3B2S $T=970920 255920 1 180 $X=967200 $Y=255540
X2807 1586 1604 1564 1 2 AN2B1T $T=443920 276080 1 0 $X=443920 $Y=270660
X2808 2449 521 2452 1 2 AN2B1T $T=694400 306320 1 0 $X=694400 $Y=300900
X2809 2714 587 2712 1 2 AN2B1T $T=797940 286160 0 0 $X=797940 $Y=285780
X2810 695 2977 658 636 2 1 2984 OA112S $T=869860 296240 1 180 $X=864900 $Y=295860
X2811 2988 3064 3019 2 1 3083 OR3S $T=888460 296240 1 0 $X=888460 $Y=290820
X2812 3062 3057 2853 3090 2 1 3128 MAOI1S $T=900240 266000 0 0 $X=900240 $Y=265620
X2813 3073 3241 676 3254 2 1 3287 MAOI1S $T=955420 316400 1 0 $X=955420 $Y=310980
X2814 1317 1329 1 2 1324 OR2B1 $T=352160 276080 1 0 $X=352160 $Y=270660
X2815 1363 1370 1 2 1355 OR2B1 $T=367660 245840 1 0 $X=367660 $Y=240420
X2816 1516 1405 1550 1 2 XNR2H $T=411680 225680 1 0 $X=411680 $Y=220260
X2817 2360 2362 2364 2357 1 2 2352 AO13 $T=660920 245840 0 0 $X=660920 $Y=245460
X2818 258 255 1531 2 1517 1530 1 MUXB2 $T=429660 306320 0 0 $X=429660 $Y=305940
X2819 284 285 287 2 1619 1627 1 MUXB2 $T=461900 306320 0 0 $X=461900 $Y=305940
X2820 526 528 530 2 2449 2474 1 MUXB2 $T=702460 306320 1 0 $X=702460 $Y=300900
X2821 1725 221 225 2 1 1710 QDFFRBS $T=502820 225680 1 180 $X=491040 $Y=225300
X2822 2511 221 225 2 1 2512 QDFFRBS $T=730360 296240 0 180 $X=718580 $Y=290820
X2823 2757 598 225 2 1 2685 QDFFRBS $T=817780 286160 1 180 $X=806000 $Y=285780
X2824 235 1527 1533 1 2 1537 AO12T $T=419120 286160 1 0 $X=419120 $Y=280740
X2825 1635 279 1644 1 2 1370 AO12T $T=460040 255920 0 0 $X=460040 $Y=255540
X2826 1451 1445 1474 1 2 1475 AN3B1 $T=402380 276080 0 0 $X=402380 $Y=275700
X2827 2726 525 1 2 BUF6 $T=807240 306320 1 0 $X=807240 $Y=300900
X2828 288 2 1 TIE0 $T=1089960 225680 1 0 $X=1089960 $Y=220260
X2829 832 2 1 TIE1 $T=1088100 225680 0 180 $X=1086240 $Y=220260
X2830 2712 2684 2679 1 2 2732 AN3B2 $T=803520 235760 1 0 $X=803520 $Y=230340
X2831 1177 1258 1027 1248 2 1 1246 AN4S $T=318680 286160 1 180 $X=313720 $Y=285780
X2832 1196 1106 976 1213 2 1 1284 AN4S $T=321780 286160 1 0 $X=321780 $Y=280740
X2833 2070 2047 2044 1847 2 1 2029 AN4S $T=564200 266000 0 180 $X=559240 $Y=260580
X2834 2250 2115 2238 2282 2 1 2303 AN4S $T=646040 245840 1 180 $X=641080 $Y=245460
X2835 232 1405 2 1413 1416 1418 1 AOI22HP $T=370140 286160 0 0 $X=370140 $Y=285780
.ENDS
***************************************
.SUBCKT ICV_29 1 2 9 10 11 12 13 14 15 16 17 18 19 20 21 22 23 24 25 26
+ 27 28 29 50
** N=72 EP=24 IP=68 FDC=0
X0 9 1 1 1 24 XMD $T=161780 0 0 0 $X=164630 $Y=0
X1 10 1 1 1 25 XMD $T=246060 0 0 0 $X=248910 $Y=0
X2 11 1 1 1 26 XMD $T=330330 0 0 0 $X=333180 $Y=0
X3 12 1 1 1 27 XMD $T=414600 0 0 0 $X=417450 $Y=0
X4 13 2 2 2 28 XMD $T=498870 0 0 0 $X=501720 $Y=0
X5 14 2 2 2 29 XMD $T=583140 0 0 0 $X=585990 $Y=0
X6 15 2 2 2 16 2 17 YA2GSD $T=835950 0 0 0 $X=838800 $Y=0
X7 18 2 2 2 19 2 17 YA2GSD $T=920220 0 0 0 $X=923070 $Y=0
X8 20 2 2 2 21 2 17 YA2GSD $T=1004490 0 0 0 $X=1007340 $Y=0
X9 22 2 2 2 23 2 17 YA2GSD $T=1088760 0 0 0 $X=1091610 $Y=0
.ENDS
***************************************
.SUBCKT ICV_30
** N=1 EP=0 IP=0 FDC=0
.ENDS
***************************************
.SUBCKT ICV_31 1 2 3 4
** N=5 EP=4 IP=6 FDC=0
X0 1 2 2 2 3 XMD $T=0 1141710 0 270 $X=0 $Y=1081940
.ENDS
***************************************
.SUBCKT ICV_32 1 2 3 4 5 8
** N=10 EP=6 IP=12 FDC=0
X0 1 2 2 2 4 XMD $T=0 974770 0 270 $X=0 $Y=915000
X1 3 2 2 2 5 XMD $T=0 1058240 0 270 $X=0 $Y=998470
.ENDS
***************************************
.SUBCKT ICV_33 2 3 5 13
** N=14 EP=4 IP=6 FDC=0
X0 2 3 3 3 5 XMD $T=0 807840 0 270 $X=0 $Y=748070
.ENDS
***************************************
.SUBCKT ICV_34
** N=16 EP=0 IP=0 FDC=0
.ENDS
***************************************
.SUBCKT ICV_35 1 2 3 4 5 9
** N=11 EP=6 IP=12 FDC=0
X0 1 2 2 2 4 XMD $T=0 390530 0 270 $X=0 $Y=330760
X1 3 2 2 2 5 XMD $T=0 474000 0 270 $X=0 $Y=414230
.ENDS
***************************************
.SUBCKT ICV_36 1 2 3 4 5 6
** N=8 EP=6 IP=12 FDC=0
X0 2 1 1 1 4 XMD $T=0 223590 0 270 $X=0 $Y=163820
X1 3 1 1 1 5 XMD $T=0 307060 0 270 $X=0 $Y=247290
.ENDS
***************************************
.SUBCKT ICV_37
** N=1 EP=0 IP=0 FDC=0
.ENDS
***************************************
.SUBCKT CHIP i_data[12] i_data[10] o_data[10] o_data[8] o_data[9] o_data[7] o_data[6] o_data[4] o_data[5] o_data[2] o_data[3] clk rst_n i_valid o_ready i_data[0] i_data[1] i_data[2] i_data[3] i_data[4]
+ i_data[5] GND VCC i_data[16] i_data[17] i_data[18] i_data[19] i_data[20] i_data[21] i_ready o_valid o_data[0] o_data[1] i_data[15] i_data[13] i_data[14] i_data[11] i_data[8] i_data[9] i_data[6]
+ i_data[7]
** N=2421 EP=41 IP=5076 FDC=0
X0 i_data[12] 37 1388 2421 ICV_1 $T=0 891300 0 270 $X=0 $Y=831530
X1 i_data[10] 37 1389 2421 ICV_2 $T=0 557460 0 270 $X=0 $Y=497690
X3 3 4 o_data[10] 11 2421 ICV_4 $T=0 0 0 0 $X=1173660 $Y=1062700
X4 6 o_data[8] 9 11 o_data[9] 3 488 2421 ICV_5 $T=0 0 0 0 $X=1173660 $Y=871200
X5 9 10 11 o_data[7] 2421 ICV_6 $T=0 0 0 0 $X=1173660 $Y=694800
X6 o_data[6] 9 1390 11 2421 ICV_7 $T=0 0 0 0 $X=1173660 $Y=522700
X7 9 14 o_data[4] 11 o_data[5] 936 2421 ICV_8 $T=0 0 0 0 $X=1173660 $Y=321800
X8 11 o_data[2] 38 1391 o_data[3] 933 2421 ICV_9 $T=0 0 0 0 $X=1173660 $Y=139500
X10 3 clk rst_n i_valid o_ready i_data[0] i_data[1] i_data[2] i_data[3] i_data[4] i_data[5] 64 65 66 67 68 75 76 77 78
+ 79 2421
+ ICV_11 $T=0 0 0 0 $X=139500 $Y=1163180
X11 GND VCC 1438 64 82 1427 1399 85 1428 1433 1426 86 87 95 88 1429 89 90 91 92
+ 110 93 94 1432 97 1400 1431 96 100 99 107 114 101 102 98 105 108 109 111 113
+ 115 1434 116 83 117 118 119 65 122 1435 120 123 121 146 126 124 127 128 129 131
+ 125 130 132 134 133 135 136 139 137 138 1436 1437 140 141 142 144 145 151 147 148
+ 149 152 153 154 150 155 67 156 66 157 158 159 1439 160 161 163 162 169 165 166
+ 167 168 171 170 164 172 173 174 178 175 176 177 179 1440 180 181 1445 182 1444 183
+ 187 184 185 1441 1442 188 186 189 190 191 192 193 194 195 1443 196 197 198 199 200
+ 201 202 203 204 205 206 207 208 209 1450 210 211 212 1449 214 1446 213 1447 215 1448
+ 218 216 217 219 220 224 221 222 223 225 226 227 228 229 2421
+ ICV_12 $T=0 0 0 0 $X=139500 $Y=1061940
X12 GND VCC 80 1430 96 81 1432 99 1399 111 82 86 83 98 1431 84 1429 1451 85 233
+ 114 1452 91 1426 87 90 88 234 235 95 1453 236 89 92 240 1428 237 113 103 93
+ 94 232 239 231 241 97 110 102 1456 238 242 100 243 244 1400 101 107 246 247 1454
+ 104 105 106 108 109 245 248 249 250 112 253 1433 1455 252 1434 115 1054 1459 251 117
+ 118 116 1466 254 119 1460 1463 1457 255 256 1462 258 257 1465 294 1458 1464 271 1461 1469
+ 1467 259 260 262 261 1471 1468 263 265 1481 1470 264 1473 267 1435 120 1516 1475 121 266
+ 146 122 268 1480 123 1477 127 1488 1484 1518 269 1479 270 1472 280 1485 1476 1483 272 132
+ 1478 275 124 1490 125 273 274 1486 130 1489 1474 126 1487 278 128 276 277 1491 129 131
+ 279 1493 1500 1503 281 1492 524 504 1504 1497 1496 282 1495 1494 1508 283 1507 284 1506 1511
+ 1482 286 1510 287 288 133 1498 134 289 1499 290 292 291 293 136 285 1509 1502 1501 295
+ 1512 1505 135 296 137 1513 139 297 138 298 299 300 301 1436 142 303 302 304 305 306
+ 307 140 308 141 311 1514 309 310 144 145 143 314 312 313 152 149 315 148 317 1515
+ 147 320 316 150 151 318 154 153 319 155 321 157 327 323 1519 322 324 325 1517 1573
+ 326 341 159 1567 1534 1522 1535 328 161 1439 1521 1532 1440 162 1533 1526 329 335 164 330
+ 163 165 1524 160 1525 1427 332 331 1529 1523 362 334 1531 336 166 337 167 356 168 1520
+ 169 343 339 333 338 1528 1530 340 1527 170 372 171 172 370 344 345 174 346 347 1547
+ 1536 366 1555 173 348 1537 1538 175 349 1541 358 350 342 1543 1539 1540 176 1542 351 352
+ 178 179 354 353 1546 355 177 363 1544 1545 357 183 1550 181 1549 1552 1551 1560 1553 361
+ 364 180 1557 1554 365 182 184 1444 1556 1445 185 1561 186 1558 187 367 1548 368 1559 1563
+ 190 1442 359 1441 189 369 1562 1564 188 1566 1565 371 375 1570 193 191 1568 373 192 1571
+ 1574 194 1569 374 195 376 1443 1598 1581 1590 1626 1595 1596 1594 1576 1587 378 1583 1599 1604
+ 380 382 381 377 1572 1578 393 389 1579 196 379 423 1577 398 1580 1582 411 429 198 396
+ 197 1575 1585 199 383 384 1586 386 456 1591 387 1584 403 1593 1588 202 388 200 1600 1597
+ 206 201 1606 1589 1592 1602 1605 203 1607 205 391 218 204 1601 400 395 392 394 397 1603
+ 390 399 214 207 385 208 212 1645 402 1614 401 1621 1608 1625 1613 1609 1618 1610 1637 210
+ 405 1612 418 1620 211 404 1611 406 407 412 413 1448 1446 209 408 1447 1617 1624 213 410
+ 1616 1622 1450 414 1619 409 1615 415 215 416 1628 1627 417 219 1449 420 419 1623 216 1630
+ 421 224 1403 1629 217 1631 422 221 424 1632 426 1634 1633 220 1638 1635 1636 427 428 425
+ 1639 434 1641 1640 1644 1642 433 431 222 1643 1646 223 435 436 1647 481 439 1652 438 225
+ 440 1651 432 1649 1648 1650 441 442 437 430 443 1655 1654 1674 226 1670 227 446 447 448
+ 1653 444 449 450 1660 451 1658 452 228 453 1671 454 1661 229 1682 1663 1666 1659 1662 1656
+ 455 1665 445 458 1657 1669 465 457 1664 459 1668 460 1667 1677 1672 461 462 1676 464 463
+ 1675 1673 466 467 1678 468 1679 469 477 470 1681 472 1687 473 471 1680 474 475 1683 1684
+ 479 1685 480 478 487 476 482 1686 483 484 489 486 1688 485 3 9 2421
+ ICV_17 $T=0 0 0 0 $X=139500 $Y=870420
X13 GND VCC 231 490 230 232 1689 1690 492 491 1725 549 501 1696 1691 495 1692 1693 1695 1481
+ 494 496 1694 493 1451 497 1488 1697 502 498 233 500 499 509 1705 235 503 1454 1494 236
+ 1503 1497 506 524 237 766 504 1500 245 1496 515 253 505 758 239 238 1453 240 244 234
+ 246 1452 507 1698 241 242 1455 510 247 243 508 512 1699 1457 1702 511 514 513 1701 1703
+ 1704 1700 1706 516 248 518 249 517 519 250 1458 1456 542 520 523 551 251 1470 521 1711
+ 252 526 1472 1461 1484 1459 254 1465 1460 256 269 255 1829 525 528 257 262 1710 1468 1462
+ 1709 259 1464 261 1466 530 1483 527 1054 258 1467 537 1463 1482 1831 1479 260 1490 1471 1469
+ 529 1713 1712 1489 536 1485 1476 1478 531 1475 1817 263 532 1716 265 538 1492 266 1477 1474
+ 1717 534 267 535 1715 533 1714 264 268 1473 1480 539 540 270 271 541 1499 1813 1812 272
+ 1435 273 1707 1486 274 1718 275 543 276 1487 1722 1708 544 545 277 278 1723 1720 1721 1491
+ 279 1719 1493 280 1824 1727 281 546 1733 1517 547 283 522 282 1820 548 1495 284 285 286
+ 287 288 146 559 553 1498 1739 1724 550 290 289 1726 561 552 556 1735 554 292 291 562
+ 563 560 297 557 1728 558 1734 298 1729 294 293 296 295 575 564 1731 1732 307 566 1730
+ 567 555 577 1502 1501 565 568 570 571 300 299 569 1736 1738 1505 611 573 1737 302 844
+ 576 1509 1740 572 303 574 578 301 304 305 1741 1513 310 1512 580 319 306 308 309 1516
+ 1749 1758 583 1742 608 591 587 1743 1755 582 1745 585 1746 311 586 588 584 579 1744 581
+ 590 606 1761 1747 592 312 620 1816 589 1751 612 630 1438 120 1748 631 593 624 594 313
+ 595 604 1750 1514 315 596 610 1752 1754 1753 1757 598 1756 599 597 600 607 614 605 601
+ 602 1764 316 317 603 1759 318 314 1760 320 609 1520 615 1765 1763 1762 327 613 321 1515
+ 322 324 1519 323 616 618 1766 619 1777 1767 1526 621 1768 622 623 1518 1769 1440 1788 635
+ 329 625 642 1770 1523 1521 638 331 627 1771 334 628 333 344 626 1774 644 332 336 335
+ 337 629 1549 330 1772 338 1542 1773 1798 340 1775 1540 164 165 1529 339 345 1531 341 1528
+ 342 1530 1778 633 346 1539 1524 343 632 1783 347 358 636 634 1779 1537 1525 641 637 1786
+ 348 1782 1536 1780 640 1789 639 1785 1541 349 643 1538 1784 1781 350 1787 1543 351 648 1790
+ 645 646 1791 1799 647 1417 1776 652 68 1792 1793 79 353 328 651 650 356 1533 1794 78
+ 664 362 660 372 1797 354 357 1544 1545 657 1795 1800 1801 655 75 653 1548 359 654 76
+ 360 1802 1552 355 1814 361 77 1553 363 1803 1550 364 1804 1558 365 658 1805 649 663 1554
+ 679 366 659 367 1557 1556 1807 1555 1806 1546 1439 352 368 1561 1551 1809 1532 1808 326 369
+ 1560 661 1562 1565 1559 1535 1564 1522 1566 1563 662 373 665 670 370 371 1567 1810 1570 667
+ 1811 666 681 378 668 656 669 671 1527 1437 1583 1569 1568 382 374 375 381 380 674 675
+ 1571 376 1547 1796 1534 672 673 1574 188 1818 377 1572 1604 1596 1576 1595 1587 1598 1599 1573
+ 1575 1578 676 677 1581 398 411 423 429 396 379 386 1510 1830 1582 1590 383 1628 1579 387
+ 1443 384 1613 385 1577 684 1584 418 1585 1586 393 388 198 389 1580 1593 1588 206 1589 697
+ 701 1819 1592 1594 682 705 1821 685 1825 1591 1822 202 687 688 689 1614 1597 1823 683 691
+ 1605 390 391 1601 1600 392 394 692 395 1609 1826 1610 401 693 397 399 1815 400 695 696
+ 402 1828 1606 1608 1603 403 406 404 698 1621 1611 699 700 408 407 413 702 1615 703 1612
+ 1607 409 704 410 678 1620 1833 405 1602 1617 1837 706 412 707 680 1616 721 1624 1619 690
+ 414 1622 709 708 1623 1832 416 710 1834 1651 1835 711 1625 1641 415 1627 1626 1653 1643 1661
+ 1630 712 1639 1629 420 713 1403 419 225 450 421 714 453 431 460 458 417 221 443 224
+ 715 1631 716 1658 433 1836 1632 1827 1662 422 424 425 427 1634 1618 426 1633 1635 1636 1660
+ 1642 434 1640 1638 1637 428 1649 686 430 1648 1650 1645 1644 435 1646 432 1647 436 437 438
+ 439 440 1652 717 441 463 718 442 719 481 1654 720 444 10 447 488 446 448 445 1656
+ 449 1655 1838 1657 452 1659 723 1663 724 1666 1665 1664 451 1668 454 457 722 1669 465 1675
+ 1839 455 1671 456 1667 4 1682 1677 725 1687 726 459 1840 727 1672 462 461 1670 728 466
+ 729 1841 464 1678 1674 731 730 1673 1842 468 469 477 467 1676 470 1683 1679 480 1680 1681
+ 474 487 472 479 473 1843 475 471 476 732 1684 1685 478 733 482 1686 1688 483 486 485
+ 489 484 2421
+ ICV_19 $T=0 0 0 0 $X=139500 $Y=694020
X14 GND VCC 490 734 491 735 736 1689 737 1690 492 1845 1844 738 1847 740 741 1848 493 1692
+ 1695 495 1846 1849 1693 1691 1851 739 494 1694 1850 742 743 496 1696 1697 497 744 745 498
+ 499 500 501 746 747 502 748 503 1820 749 750 1504 753 1508 766 1507 758 1511 1506 1510
+ 506 504 1706 751 505 1852 752 754 509 515 755 507 511 1854 508 756 1699 1704 1698 1700
+ 510 757 759 761 512 1855 1853 1701 1702 513 760 1703 1705 1856 514 1857 516 517 762 519
+ 1725 518 763 765 520 764 554 1733 1727 1824 523 1721 793 1708 521 781 767 522 526 768
+ 530 772 525 769 1709 797 771 542 770 527 531 529 773 778 1859 774 549 528 534 537
+ 1862 1858 775 777 533 1860 776 1861 539 779 540 1863 532 1713 780 536 783 1714 535 1715
+ 538 782 541 785 120 543 551 784 789 787 1864 786 544 545 790 788 546 791 792 1720
+ 547 1464 1895 548 1710 794 1911 796 795 1724 550 1739 1783 553 1865 552 1726 555 798 799
+ 564 557 559 1764 1723 558 562 800 1722 560 561 1719 563 1372 1398 804 1728 1731 801 567
+ 1373 565 566 1729 1867 1866 805 1740 803 1732 1735 1730 1734 806 576 810 570 568 1737 1871
+ 611 1374 571 1402 1736 572 808 556 1870 1757 1738 569 573 844 574 1872 1750 575 577 1401
+ 809 812 807 1375 1769 1873 814 1518 802 579 578 811 813 1741 1404 1388 584 1874 610 816
+ 815 580 818 823 1875 817 824 1868 581 1876 1869 819 582 583 1743 1742 591 1746 1745 1878
+ 1744 587 821 585 586 590 822 588 589 820 1376 606 1747 1377 592 1877 1752 608 1907 1749
+ 630 839 612 1753 631 1804 595 825 826 1748 1389 593 1405 594 833 1755 1879 827 596 1754
+ 1751 1761 597 1406 1756 828 599 598 602 601 1758 600 603 829 604 1778 831 830 1759 832
+ 605 1880 607 1763 620 834 835 614 840 1762 836 837 1760 609 838 613 615 841 616 1882
+ 617 842 843 1766 1776 1767 618 1883 1768 1881 621 619 1884 845 1765 622 623 1886 846 320
+ 849 624 1899 1771 847 1770 625 1888 848 1792 626 1889 627 1890 628 629 1418 850 319 851
+ 1891 1892 1887 852 1897 1417 1774 853 1885 854 1773 857 866 855 856 1893 1775 636 1894 637
+ 858 859 641 633 861 1782 635 1772 860 1779 639 1780 1784 1901 1896 638 862 1905 1898 1781
+ 1900 863 1517 1786 864 867 642 632 1787 68 1785 865 643 1903 644 640 634 645 1788 1791
+ 1790 1789 325 1908 1910 1904 648 869 868 79 652 1793 1909 646 649 870 873 871 1794 872
+ 875 78 650 1906 1798 1777 874 651 1797 76 1796 1799 647 1912 75 1795 1913 654 876 877
+ 1914 1800 1801 653 1802 878 658 77 1803 655 1902 880 656 677 1916 657 879 881 1915 882
+ 663 883 661 884 664 885 1917 1805 1807 1808 659 1806 1810 886 922 887 665 662 660 889
+ 888 891 681 1811 890 892 667 898 669 1919 1809 668 893 1208 894 1942 670 1920 666 895
+ 896 671 672 673 1921 1814 674 897 675 1815 676 899 696 684 678 703 1816 906 679 900
+ 901 700 524 680 902 912 904 903 1716 682 911 1817 683 1718 1818 1503 1497 1500 932 905
+ 697 1922 913 1819 705 1496 685 907 688 1923 910 686 908 1822 931 909 712 1494 1825 689
+ 1821 1823 1475 1827 1826 690 1924 158 691 1925 692 695 693 694 1918 1928 1927 1463 1384 1469
+ 926 1829 1828 1930 914 1462 1929 699 915 1054 1926 916 701 698 719 1712 1831 917 918 1830
+ 704 1932 720 1931 919 920 1836 706 935 707 156 1385 927 1832 921 716 923 709 708 924
+ 1934 1333 1933 1835 710 925 1834 711 928 715 1935 940 965 722 713 1972 1936 1940 1956 929
+ 1937 1345 718 1370 1939 1938 930 1359 1944 1959 951 1946 1941 933 714 949 1943 687 1945 941
+ 1335 1948 1947 1342 14 934 937 1346 726 1952 936 1833 961 981 1949 1951 939 938 1391 1386
+ 1390 1950 944 945 942 947 943 946 948 1953 1954 1955 956 950 953 954 955 1957 1963 1837
+ 721 6 963 702 1958 1969 1966 962 957 1962 958 1960 1971 1973 1961 1965 717 1975 1968 1967
+ 1970 959 960 1964 1974 1977 964 1838 1839 966 724 1976 723 968 1841 725 1840 969 970 971
+ 727 972 1842 728 729 1978 967 973 730 1979 975 731 974 1980 977 976 986 1981 985 978
+ 1843 732 979 980 733 983 982 984 987 2421
+ ICV_23 $T=0 0 0 0 $X=139500 $Y=522660
X15 GND VCC 989 1987 492 992 990 2347 1983 734 991 1033 1032 1986 735 988 1991 1988 993 737
+ 2073 2070 1038 2031 998 1984 994 736 1845 2072 1017 491 1844 1028 2351 995 1982 1989 996 1993
+ 2063 497 1023 2064 749 1002 2004 1009 1995 997 738 999 739 1001 2029 1000 2081 1997 741 2059
+ 797 1849 2352 1999 2000 1847 1003 2001 1851 1016 1846 1004 2045 1848 2353 1996 742 1005 1006 1018
+ 2002 1850 740 1990 2005 1008 1985 1010 2358 2060 2043 743 1031 744 1011 2014 2006 1013 1407 1026
+ 1992 745 1012 2018 2007 1998 2023 1007 2354 2359 2008 2010 746 2013 2015 2066 2017 1015 2012 2021
+ 2024 2074 1051 1994 2016 751 750 501 2346 748 2019 758 1705 2026 2357 1475 2084 2033 2025 2020
+ 1021 2350 2022 503 2027 2009 2345 2028 2032 1020 2356 2348 1014 1030 1024 2355 2030 2099 1022 1025
+ 753 754 2034 2037 2040 2035 1027 2349 2036 2360 1019 2039 2362 2011 2042 2041 1046 2050 2061 755
+ 1852 757 1029 2044 1853 2049 756 2065 761 759 2047 2058 1854 2361 1855 2046 2048 1856 2051 2367
+ 760 2052 2038 515 2056 2003 2068 2054 2053 521 2363 1857 2057 2055 509 762 1864 1034 1035 1043
+ 765 2071 2080 763 1037 1036 2062 526 2100 2077 2365 764 1817 1057 2067 506 2097 1044 2364 1039
+ 766 1040 1053 1813 1812 1716 2069 1717 2098 1041 1718 523 542 2366 1042 1707 2085 2075 1045 2087
+ 2079 2078 2086 2076 783 767 2082 2092 769 1054 1047 1050 1048 2095 1709 2083 774 768 1463 2089
+ 2090 2091 1462 2096 1063 1464 1061 1867 1052 1712 773 771 1049 770 2093 1055 1829 1860 537 1831
+ 1056 772 2088 2094 1859 1058 1858 1861 1518 1059 1060 1710 775 776 1064 1065 778 1862 777 1863
+ 1062 779 780 1098 781 1067 1408 1066 782 790 786 1069 784 785 1068 787 2102 789 1070 788
+ 752 791 792 1071 1072 1073 1517 2105 2103 551 2107 2104 1074 794 793 2101 2110 1077 2106 2108
+ 1075 795 1865 796 1076 2109 1078 2111 1079 2112 1080 2114 1082 2113 1081 799 1083 1724 1824 1764
+ 1084 1820 1708 1733 1727 1721 1870 1085 801 1086 1087 1866 800 798 1875 1088 802 2116 2115 2117
+ 1090 804 2118 1089 1091 2119 2120 2121 1869 803 1092 1093 805 1872 1094 1097 1095 1868 2126 1096
+ 806 2123 807 1871 1100 1099 808 2122 809 1508 810 811 812 1507 813 1503 1873 1101 1874 2124
+ 1510 814 1102 1504 2125 2131 2127 1104 819 1105 1108 1106 1876 815 2130 816 1103 2128 1107 823
+ 817 1877 1109 821 1111 1496 2129 2134 1494 818 1878 1506 1112 820 1110 1113 1497 1883 1511 1881
+ 524 1114 822 1726 1500 504 1115 1117 1118 2137 824 1120 2140 1892 1121 1739 1116 1123 1119 825
+ 826 2382 2136 2145 1124 2143 1125 2162 2146 2147 1171 2139 2205 2379 2141 2182 1131 2151 1127 2197
+ 2204 1128 829 2133 2381 828 827 1879 1129 2152 2371 1130 2174 2153 1158 2132 2157 2149 1174 2138
+ 1132 1133 2378 1134 2144 1137 1139 1168 1135 1172 2148 1136 2158 2156 2181 2161 1138 2160 2135 830
+ 831 2150 2202 2373 1146 1140 2165 1155 2206 833 1141 2193 2188 1880 1143 832 2163 1142 2190 2166
+ 2370 2164 1409 2368 834 1144 835 2168 2167 2171 1907 836 1154 837 2169 2173 2154 1147 2377 2159
+ 838 840 1148 1149 1150 1151 839 2372 2170 1163 1145 2178 1153 1152 2172 2177 2176 1891 2175 2383
+ 841 1180 1736 2369 2179 842 1157 843 2180 1156 1159 2184 2155 1410 1160 2380 1885 1161 1126 2183
+ 878 844 2185 2374 1167 2375 1122 1882 1162 849 2186 845 1164 2198 1884 2189 1165 2187 2376 2191
+ 847 2194 1887 1886 846 1173 2192 1166 2196 2200 2214 2199 848 2142 2203 2219 1169 1170 2201 1890
+ 2208 1889 2212 2220 1189 851 1175 850 1888 1176 1181 2221 2195 852 1411 1178 1177 856 1179 854
+ 853 2223 2384 2207 2217 2209 2210 1183 855 2216 1182 1195 2215 1184 1895 2211 1911 1185 861 857
+ 860 1186 1893 858 859 1188 1194 1918 874 1894 1187 2213 863 1896 1898 2222 1899 862 1897 1190
+ 2218 1191 866 1192 865 1193 864 1901 1904 1903 1902 1900 1197 1908 1921 1905 1906 1196 2224 870
+ 871 869 2225 868 1198 1909 867 873 1910 872 875 876 1200 1199 877 1201 881 1202 1711 1914
+ 1912 879 1915 880 1203 882 1913 2226 1206 884 2227 1208 883 1916 885 1205 2229 1917 1204 1207
+ 2228 2230 2231 887 1209 1210 912 888 1228 886 889 1246 1233 1212 1211 2232 890 1213 898 891
+ 1919 1214 892 906 1239 1215 1216 893 1220 894 1217 1221 895 1218 896 1219 2233 1920 2241 897
+ 1250 1222 1223 2240 901 2234 1224 1225 2237 2239 2236 899 1226 2235 1227 2238 900 1229 1230 902
+ 1231 1232 1922 903 1235 1234 904 1923 1236 905 1238 1237 908 907 1251 1240 910 909 1241 1242
+ 911 1243 2242 1245 1244 1247 2243 1924 1248 1249 2245 2246 2247 2249 2248 2244 913 1252 1928 1253
+ 1254 1925 914 1926 1927 2260 1257 2261 1929 1258 1256 916 1259 918 917 1260 1261 2256 1267 1930
+ 919 2388 1266 1262 2275 1255 922 1264 1263 1288 1276 2265 2255 1265 1931 2257 2266 2300 1932 1469
+ 1268 1412 2263 1269 2259 2303 2279 1270 2391 2258 921 2272 1271 2277 1942 1272 1273 2271 2386 2273
+ 2267 2269 2264 2285 2276 1320 923 1278 2394 1290 1275 1281 2297 1282 1274 1310 925 1277 924 926
+ 1331 1413 2397 927 1279 2270 2274 2251 1280 928 1286 1296 2254 1941 1940 1283 1944 2392 1318 1935
+ 2321 915 2252 2326 929 2393 2401 687 2268 2395 1937 935 2390 2319 2387 932 1284 2396 1285 931
+ 1323 2385 934 920 2280 2312 1287 2253 1297 2288 2278 2328 1939 2331 1302 2399 2398 2281 2262 2282
+ 2389 2332 1933 2334 2284 1289 2313 1338 2309 2330 981 952 2283 2400 2296 1949 938 941 2402 940
+ 1371 1299 2304 1952 1334 1292 2287 937 2286 2289 2292 2293 1291 2290 2291 1414 1951 2295 1293 2250
+ 2294 1327 1294 2404 942 944 1295 945 1945 2306 2299 947 1298 946 2298 939 2308 930 1317 1934
+ 1300 1301 2322 1311 948 2302 1303 1359 1316 2301 1315 1936 2403 1304 1308 1947 1312 1305 951 2305
+ 1307 1306 1953 949 1415 2307 1948 1954 1955 943 2310 1938 1950 1314 1313 956 2314 2311 1943 1325
+ 2315 953 2317 1309 2318 955 1370 2316 961 2320 1946 1319 1321 963 2323 950 1957 2324 1322 2325
+ 2327 1958 1416 957 2337 1969 962 1324 1962 1961 958 1963 959 1335 1326 1960 1966 1956 960 1968
+ 1333 1967 1328 1964 2329 954 1329 1330 964 1970 1959 1332 1971 1342 1839 1972 1336 1346 965 1965
+ 2335 1337 1976 1973 966 1974 967 2333 968 1339 1975 2338 2336 1840 1340 1341 1345 1977 1362 1343
+ 2341 1841 1361 969 970 1369 971 2339 1344 2340 2343 2342 1367 972 1365 1368 1347 1348 1349 1350
+ 1356 1842 1978 973 1352 1351 974 975 1364 1353 1354 1355 1358 1357 1979 1981 977 976 1980 978
+ 1843 986 985 1360 979 980 1363 982 983 1366 984 987 2421
+ ICV_27 $T=0 0 0 0 $X=139500 $Y=321060
X16 GND VCC 37 989 990 1987 992 1986 1983 1996 1032 991 1998 2347 2360 2352 2007 2351 1991 1994
+ 1048 988 1984 1015 2361 2009 1046 1989 993 2087 1038 1988 994 2099 995 1982 999 1995 996 1004
+ 2039 1051 1003 2015 997 998 2069 1000 2049 2052 1999 1997 2000 1002 1001 2046 1023 1018 2063 2001
+ 2027 1006 2003 2002 1985 2067 1007 1025 1008 2353 2043 1009 1010 2354 2008 2005 2029 1011 1012 1992
+ 1013 2012 1407 2022 1005 2006 2359 2016 1014 2011 2010 2018 1016 1026 2013 2025 2014 2348 2019 1017
+ 2060 2346 2073 2020 2059 2066 2021 2355 2350 2024 2345 1019 2054 2051 2357 2028 1020 1022 2356 1993
+ 1028 1990 2030 2035 2031 1021 2038 2033 2349 2084 2064 2036 1024 2037 2032 2017 2042 1027 2004 2041
+ 2040 2097 2034 2026 1029 2367 2358 2044 1042 2053 2050 2048 2023 1030 1031 2363 1033 2047 2056 2057
+ 1034 2058 2055 1035 2362 2045 1036 1037 2062 2061 2364 2065 2070 2068 1039 2100 1040 2071 1041 2072
+ 1043 2075 2074 2076 1044 1045 2079 2081 2078 2080 1047 2077 2090 1049 2083 2082 1050 2089 2086 1054
+ 2095 1053 2085 1052 1057 2088 1055 2091 2366 2365 1056 2098 1059 1058 2096 2094 2093 2092 1061 1060
+ 2223 1062 1864 1063 1064 1066 1065 1408 2101 1067 551 1085 1069 1068 2102 1070 1071 2103 1072 2104
+ 1073 2105 1074 2106 2107 2108 1076 1077 1075 2109 2110 1078 2111 1079 1080 1083 2112 1082 1081 2114
+ 2113 1084 2116 2115 1086 2118 1087 2119 1088 2117 1089 1090 1091 2120 1092 1093 1095 2121 2126 1094
+ 2123 1096 1100 1097 2122 1098 1099 38 2124 1101 1102 2125 1106 2132 2127 1103 1104 2131 2129 2128
+ 1105 2130 1107 1109 1108 2138 2134 1110 1112 1111 1113 2137 1409 1116 1114 2135 1117 1129 2140 2164
+ 1118 1119 2142 1120 1122 2141 2147 1123 2143 2133 2145 2139 1124 1177 1158 2189 1172 1127 1132 1121
+ 2149 1115 1126 2379 1130 1141 2151 1125 1128 2371 2163 2152 2380 1131 2150 2193 2156 1134 1138 1133
+ 2166 2155 2148 2158 1135 2378 2146 1140 2175 1136 2153 2154 2157 2159 2161 2165 1137 2144 2160 1139
+ 2162 1143 1142 2373 2167 1149 2202 1144 2182 1156 2368 2168 1147 1151 1145 1146 2169 2203 2170 2372
+ 2172 1152 1171 2171 1150 1148 2190 2173 2196 1168 1163 1154 1173 2178 1153 2176 2174 1155 2177 1157
+ 1410 2180 2370 1174 2136 2179 1160 2184 2374 2181 2206 2183 2188 1161 1167 1162 2197 2375 2187 2369
+ 2186 1159 2185 1165 1164 2376 1170 2205 2195 2192 2194 2377 2200 2198 2383 2199 1169 2191 2201 2204
+ 2381 1175 1176 1166 1411 1178 1180 1179 2208 2382 2384 2207 1181 1182 2209 1183 1184 2211 2215 2210
+ 2216 2219 1185 1186 1187 1188 2213 2214 2217 2212 1194 1191 2218 1189 1192 1190 2222 1193 2220 2221
+ 1195 1197 878 1899 2225 1199 2224 1198 1201 1202 1196 2226 1200 1203 1205 1206 2228 2227 2231 1204
+ 1207 2229 1208 912 2230 2232 1209 1213 1210 1211 1212 1237 1214 1217 906 1215 1216 1219 1220 1221
+ 1224 2233 1222 1223 2234 2236 2235 1226 1225 1227 2239 1228 2238 1233 2237 1230 1229 1231 1232 2240
+ 1234 1236 1235 2241 1238 1239 1251 1240 1242 1243 1244 1246 1241 2242 1254 1250 1247 2244 2243 1245
+ 1249 2246 2245 2248 1248 866 1252 2247 2249 1253 1218 2260 1269 2262 2253 2257 1256 2256 2300 2263
+ 2259 2252 2258 1257 2299 2250 1260 1323 1259 1261 1276 2293 2279 2388 1274 2270 1258 2261 1281 1267
+ 2265 1263 2268 2266 1255 1262 1291 2267 2251 2255 2269 2272 1266 2287 1297 1412 2273 2277 1271 1268
+ 1265 2318 2264 2280 1272 2271 2290 2394 2396 2401 2254 2285 2395 2387 2390 2275 2276 1264 1279 2392
+ 1284 1413 2393 1277 2402 2391 2274 1278 1317 1310 1320 2282 1280 1282 2296 2311 1283 1309 2278 1275
+ 1288 2313 2294 2284 1270 1287 2397 2399 1415 2298 2288 2281 2312 1286 2398 1292 1327 2385 1273 2400
+ 2283 2389 1289 2291 1290 1318 2297 2286 1414 2289 2295 2292 1312 1293 2386 1294 1295 1301 2304 1296
+ 1298 1299 2302 1300 1302 1315 2301 2303 1303 1305 2403 2306 1325 1308 1306 2404 2314 1307 2308 1304
+ 2307 1311 1313 1314 2315 2309 2310 2316 1316 2319 2317 2329 1319 2320 2322 2323 2324 1321 1322 1416
+ 1324 2325 1326 2327 1328 2305 1329 1333 1332 1331 2326 1346 1335 2321 2330 2334 1334 1330 1336 1337
+ 2332 1338 2331 2328 1345 1339 1340 1342 2333 1341 1343 2335 2336 2341 2340 2343 1361 1362 1347 1348
+ 2342 1349 1344 1350 2339 1369 1368 2337 1365 1367 1351 1352 1354 1353 1355 1356 1357 1358 1359 2338
+ 1363 1364 1360 1366 1370 11 9 2421
+ ICV_28 $T=0 0 0 0 $X=139500 $Y=139500
X17 37 38 i_data[16] i_data[17] i_data[18] i_data[19] i_data[20] i_data[21] i_ready 1384 11 o_valid 1385 o_data[0] 1386 o_data[1] 1371 1372 1373 1374
+ 1375 1376 1377 2421
+ ICV_29 $T=0 0 0 0 $X=139500 $Y=-56920
X19 i_data[15] 37 1398 2421 ICV_31 $T=0 0 0 0 $X=-56920 $Y=1062700
X20 i_data[13] 37 i_data[14] 1401 1402 2421 ICV_32 $T=0 0 0 0 $X=-56920 $Y=871200
X21 i_data[11] 37 1404 2421 ICV_33 $T=0 0 0 0 $X=-56920 $Y=694800
X23 i_data[8] 37 i_data[9] 1405 1406 2421 ICV_35 $T=0 0 0 0 $X=-56920 $Y=321800
X24 37 i_data[6] i_data[7] 1417 1418 2421 ICV_36 $T=0 0 0 0 $X=-56920 $Y=139500
.ENDS
***************************************

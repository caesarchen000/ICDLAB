* SPICE NETLIST
***************************************

.SUBCKT L POS NEG SUB
.ENDS
***************************************
.SUBCKT YA2GSD O E2 E8 E4 I SR E
** N=8 EP=7 IP=0 FDC=0
.ENDS
***************************************
.SUBCKT ICV_1 1 2 3 4 5
** N=5 EP=5 IP=8 FDC=0
X0 1 2 2 2 3 2 4 YA2GSD $T=0 0 0 0 $X=2850 $Y=0
.ENDS
***************************************
.SUBCKT ICV_2 1 2 3 4 5
** N=5 EP=5 IP=8 FDC=0
X0 1 2 2 2 3 2 4 YA2GSD $T=0 0 0 0 $X=2850 $Y=0
.ENDS
***************************************
.SUBCKT XMD I SMT PU PD O
** N=6 EP=5 IP=0 FDC=0
.ENDS
***************************************
.SUBCKT ICV_3 1 2 3 4
** N=4 EP=4 IP=6 FDC=0
X0 1 2 2 2 3 XMD $T=0 0 0 0 $X=2850 $Y=0
.ENDS
***************************************
.SUBCKT ICV_4 1 8 9 10 11 12 13 14 15 16 17 18 19 20 21 28 29 30 31 32
+ 33 48
** N=70 EP=22 IP=60 FDC=0
X0 8 1 1 1 33 XMD $T=224590 1312760 0 180 $X=164820 $Y=1173260
X1 9 1 1 1 18 XMD $T=309060 1312760 0 180 $X=249290 $Y=1173260
X2 10 1 1 1 19 XMD $T=393520 1312760 0 180 $X=333750 $Y=1173260
X3 11 1 1 1 20 XMD $T=477980 1312760 0 180 $X=418210 $Y=1173260
X4 12 1 1 1 21 XMD $T=562440 1312760 0 180 $X=502670 $Y=1173260
X5 13 1 1 1 28 XMD $T=815820 1312760 0 180 $X=756050 $Y=1173260
X6 14 1 1 1 29 XMD $T=900280 1312760 0 180 $X=840510 $Y=1173260
X7 15 1 1 1 30 XMD $T=984740 1312760 0 180 $X=924970 $Y=1173260
X8 16 1 1 1 31 XMD $T=1069200 1312760 0 180 $X=1009430 $Y=1173260
X9 17 1 1 1 32 XMD $T=1153670 1312760 0 180 $X=1093900 $Y=1173260
.ENDS
***************************************
.SUBCKT QDFFN D CK Q GND VCC
** N=6 EP=5 IP=0 FDC=0
.ENDS
***************************************
.SUBCKT AOI22S A1 B1 O B2 GND A2 VCC
** N=8 EP=7 IP=0 FDC=0
.ENDS
***************************************
.SUBCKT AN2 I1 I2 GND VCC O
** N=6 EP=5 IP=0 FDC=0
.ENDS
***************************************
.SUBCKT INV4CK I O GND VCC
** N=5 EP=4 IP=0 FDC=0
.ENDS
***************************************
.SUBCKT INV2CK I O GND VCC
** N=5 EP=4 IP=0 FDC=0
.ENDS
***************************************
.SUBCKT DELC I GND VCC O
** N=5 EP=4 IP=0 FDC=0
.ENDS
***************************************
.SUBCKT QDBHN CKB D GND VCC Q
** N=6 EP=5 IP=0 FDC=0
.ENDS
***************************************
.SUBCKT AN2T I1 I2 O GND VCC
** N=6 EP=5 IP=0 FDC=0
.ENDS
***************************************
.SUBCKT DELA I GND VCC O
** N=5 EP=4 IP=0 FDC=0
.ENDS
***************************************
.SUBCKT AO22 O A2 A1 VCC B1 B2 GND
** N=8 EP=7 IP=0 FDC=0
.ENDS
***************************************
.SUBCKT FA1S CO VCC A B CI GND S
** N=8 EP=7 IP=0 FDC=0
.ENDS
***************************************
.SUBCKT QDFFRBN D CK RB VCC GND Q
** N=7 EP=6 IP=0 FDC=0
.ENDS
***************************************
.SUBCKT INV1S I VCC O GND
** N=5 EP=4 IP=0 FDC=0
.ENDS
***************************************
.SUBCKT XOR3 I2 I1 I3 VCC GND O
** N=7 EP=6 IP=0 FDC=0
.ENDS
***************************************
.SUBCKT MAO222 B1 A1 C1 GND VCC O
** N=7 EP=6 IP=0 FDC=0
.ENDS
***************************************
.SUBCKT XOR2HS I1 I2 O VCC GND
** N=6 EP=5 IP=0 FDC=0
.ENDS
***************************************
.SUBCKT ND2S I1 O I2 VCC GND
** N=6 EP=5 IP=0 FDC=0
.ENDS
***************************************
.SUBCKT ND2 I1 O I2 GND VCC
** N=6 EP=5 IP=0 FDC=0
.ENDS
***************************************
.SUBCKT ND3P I1 O I2 I3 GND VCC
** N=7 EP=6 IP=0 FDC=0
.ENDS
***************************************
.SUBCKT MAO222P A1 B1 C1 O GND VCC
** N=7 EP=6 IP=0 FDC=0
.ENDS
***************************************
.SUBCKT ND2P I2 GND I1 O VCC
** N=6 EP=5 IP=0 FDC=0
.ENDS
***************************************
.SUBCKT ND2T I2 GND I1 O VCC
** N=6 EP=5 IP=0 FDC=0
.ENDS
***************************************
.SUBCKT XNR3 I2 I1 I3 VCC GND O
** N=7 EP=6 IP=0 FDC=0
.ENDS
***************************************
.SUBCKT INV2 I O GND VCC
** N=5 EP=4 IP=0 FDC=0
.ENDS
***************************************
.SUBCKT MXL2H B S OB A GND VCC
** N=7 EP=6 IP=0 FDC=0
.ENDS
***************************************
.SUBCKT AN2B1S I1 VCC B1 O GND
** N=6 EP=5 IP=0 FDC=0
.ENDS
***************************************
.SUBCKT AN2S I1 I2 GND O VCC
** N=6 EP=5 IP=0 FDC=0
.ENDS
***************************************
.SUBCKT INV8CK I O GND VCC
** N=5 EP=4 IP=0 FDC=0
.ENDS
***************************************
.SUBCKT BUF2CK I O GND VCC
** N=5 EP=4 IP=0 FDC=0
.ENDS
***************************************
.SUBCKT INV12CK I O GND VCC
** N=5 EP=4 IP=0 FDC=0
.ENDS
***************************************
.SUBCKT ICV_5 1 2 3 4 5 6 7 8 9 10 11 12 13 14 15 16 17 18 19 20
+ 21 22 23 24 25 26 27 28 29 30 31 32 33 34 35 36 37 38 39 40
+ 41 42 43 44 45 46 47 48 49 50 51 52 53 54 55 56 57 58 59 60
+ 61 62 63 64 65 66 67 68 69 70 71 72 73 74 75 76 77 78 79 80
+ 81 82 83 84 85 86 87 88 89 90 91 92 93 94 95 96 97 98 99 100
+ 101 102 103 104 105 106 108 109 110 111 113 114 115 116 118 119 120 121 122 123
+ 124 125 126 127 129 130 131 132 133 134 135 137 138 139 140 142 143 144 145 146
+ 147 148 149 150 151 152 153 154 155 156 157 158 159 160 161 162 163 164 165 166
+ 167 168 169 170 171 172 173 174 175 176 177 178 179 180 181 182 183 184 185 186
+ 187 188 189 190 191 192 193 194 195 196 197 198 199 200 201 202 203 204 205 206
+ 207 208 209 210 211 212 213 214 215 216 217 218 219 220 221 222 223 252
** N=457 EP=218 IP=1804 FDC=0
X0 144 145 148 1 2 QDFFN $T=723540 1072400 0 0 $X=723540 $Y=1072020
X1 146 147 379 1 2 QDFFN $T=726640 1082480 1 0 $X=726640 $Y=1077060
X2 146 145 380 1 2 QDFFN $T=726640 1092560 1 0 $X=726640 $Y=1087140
X3 144 149 383 1 2 QDFFN $T=737180 1072400 1 0 $X=737180 $Y=1066980
X4 146 149 384 1 2 QDFFN $T=741520 1082480 0 0 $X=741520 $Y=1082100
X5 144 156 385 1 2 QDFFN $T=765700 1072400 0 180 $X=755160 $Y=1066980
X6 146 156 386 1 2 QDFFN $T=766320 1082480 1 180 $X=755780 $Y=1082100
X7 159 149 387 1 2 QDFFN $T=769420 1082480 0 180 $X=758880 $Y=1077060
X8 162 149 158 1 2 QDFFN $T=776240 1072400 0 180 $X=765700 $Y=1066980
X9 159 156 391 1 2 QDFFN $T=769420 1082480 0 0 $X=769420 $Y=1082100
X10 159 147 393 1 2 QDFFN $T=786780 1072400 0 180 $X=776240 $Y=1066980
X11 167 149 165 1 2 QDFFN $T=793600 1082480 0 180 $X=783060 $Y=1077060
X12 159 145 395 1 2 QDFFN $T=795460 1092560 0 180 $X=784920 $Y=1087140
X13 166 156 168 1 2 QDFFN $T=786780 1072400 1 0 $X=786780 $Y=1066980
X14 169 147 397 1 2 QDFFN $T=797320 1072400 1 0 $X=797320 $Y=1066980
X15 169 145 399 1 2 QDFFN $T=801040 1082480 0 0 $X=801040 $Y=1082100
X16 170 149 171 1 2 QDFFN $T=803520 1072400 0 0 $X=803520 $Y=1072020
X17 169 156 401 1 2 QDFFN $T=822120 1082480 1 180 $X=811580 $Y=1082100
X18 169 149 403 1 2 QDFFN $T=830800 1072400 1 180 $X=820260 $Y=1072020
X19 175 147 405 1 2 QDFFN $T=823980 1082480 0 0 $X=823980 $Y=1082100
X20 175 145 407 1 2 QDFFN $T=848160 1092560 0 180 $X=837620 $Y=1087140
X21 180 145 408 1 2 QDFFN $T=840100 1082480 1 0 $X=840100 $Y=1077060
X22 180 156 182 1 2 QDFFN $T=840720 1072400 0 0 $X=840720 $Y=1072020
X23 180 147 409 1 2 QDFFN $T=862420 1092560 0 180 $X=851880 $Y=1087140
X24 183 156 412 1 2 QDFFN $T=857460 1072400 0 0 $X=857460 $Y=1072020
X25 183 145 410 1 2 QDFFN $T=859320 1082480 1 0 $X=859320 $Y=1077060
X26 183 147 413 1 2 QDFFN $T=867380 1092560 1 0 $X=867380 $Y=1087140
X27 183 149 414 1 2 QDFFN $T=886600 1082480 0 180 $X=876060 $Y=1077060
X28 185 156 187 1 2 QDFFN $T=879160 1072400 0 0 $X=879160 $Y=1072020
X29 186 149 418 1 2 QDFFN $T=882260 1092560 1 0 $X=882260 $Y=1087140
X30 188 149 190 1 2 QDFFN $T=889700 1072400 1 0 $X=889700 $Y=1066980
X31 186 156 416 1 2 QDFFN $T=902100 1072400 1 180 $X=891560 $Y=1072020
X32 186 147 421 1 2 QDFFN $T=895900 1092560 1 0 $X=895900 $Y=1087140
X33 186 145 420 1 2 QDFFN $T=903960 1082480 0 0 $X=903960 $Y=1082100
X34 192 191 422 1 2 QDFFN $T=927520 1082480 0 180 $X=916980 $Y=1077060
X35 192 195 423 1 2 QDFFN $T=936820 1082480 1 180 $X=926280 $Y=1082100
X36 193 191 196 1 2 QDFFN $T=928140 1072400 1 0 $X=928140 $Y=1066980
X37 192 198 426 1 2 QDFFN $T=950460 1082480 0 180 $X=939920 $Y=1077060
X38 192 197 427 1 2 QDFFN $T=939920 1082480 0 0 $X=939920 $Y=1082100
X39 193 197 199 1 2 QDFFN $T=941780 1072400 1 0 $X=941780 $Y=1066980
X40 200 195 428 1 2 QDFFN $T=952940 1072400 1 0 $X=952940 $Y=1066980
X41 200 191 429 1 2 QDFFN $T=953560 1082480 0 0 $X=953560 $Y=1082100
X42 200 197 433 1 2 QDFFN $T=965960 1082480 1 0 $X=965960 $Y=1077060
X43 200 198 432 1 2 QDFFN $T=977740 1092560 0 180 $X=967200 $Y=1087140
X44 207 197 205 1 2 QDFFN $T=985180 1072400 1 180 $X=974640 $Y=1072020
X45 206 198 434 1 2 QDFFN $T=980220 1082480 1 0 $X=980220 $Y=1077060
X46 206 197 435 1 2 QDFFN $T=981460 1092560 1 0 $X=981460 $Y=1087140
X47 206 195 437 1 2 QDFFN $T=1004400 1082480 1 180 $X=993860 $Y=1082100
X48 207 191 438 1 2 QDFFN $T=1005640 1072400 0 180 $X=995100 $Y=1066980
X49 211 198 442 1 2 QDFFN $T=1005020 1082480 1 0 $X=1005020 $Y=1077060
X50 206 191 440 1 2 QDFFN $T=1016180 1072400 0 180 $X=1005640 $Y=1066980
X51 211 197 441 1 2 QDFFN $T=1008120 1082480 0 0 $X=1008120 $Y=1082100
X52 213 198 445 1 2 QDFFN $T=1019280 1082480 1 0 $X=1019280 $Y=1077060
X53 214 197 215 1 2 QDFFN $T=1021760 1072400 1 0 $X=1021760 $Y=1066980
X54 213 197 444 1 2 QDFFN $T=1022380 1082480 0 0 $X=1022380 $Y=1082100
X55 214 191 217 1 2 QDFFN $T=1035400 1072400 1 0 $X=1035400 $Y=1066980
X56 213 191 448 1 2 QDFFN $T=1036020 1082480 0 0 $X=1036020 $Y=1082100
X57 213 195 447 1 2 QDFFN $T=1056480 1072400 1 180 $X=1045940 $Y=1072020
X58 218 197 449 1 2 QDFFN $T=1048420 1072400 1 0 $X=1048420 $Y=1066980
X59 219 197 452 1 2 QDFFN $T=1049660 1082480 0 0 $X=1049660 $Y=1082100
X60 218 198 451 1 2 QDFFN $T=1072600 1072400 0 180 $X=1062060 $Y=1066980
X61 219 198 453 1 2 QDFFN $T=1074460 1082480 1 180 $X=1063920 $Y=1082100
X62 219 195 456 1 2 QDFFN $T=1078180 1082480 0 0 $X=1078180 $Y=1082100
X63 218 195 223 1 2 QDFFN $T=1083140 1072400 1 0 $X=1083140 $Y=1066980
X64 219 191 457 1 2 QDFFN $T=1083140 1082480 1 0 $X=1083140 $Y=1077060
X65 379 380 381 150 1 151 2 AOI22S $T=740280 1082480 1 0 $X=740280 $Y=1077060
X66 383 385 152 154 1 155 2 AOI22S $T=750820 1072400 0 0 $X=750820 $Y=1072020
X67 384 386 382 154 1 155 2 AOI22S $T=750820 1082480 1 0 $X=750820 $Y=1077060
X68 387 391 390 154 1 155 2 AOI22S $T=773140 1082480 1 0 $X=773140 $Y=1077060
X69 393 395 394 150 1 151 2 AOI22S $T=781200 1092560 1 0 $X=781200 $Y=1087140
X70 397 399 398 150 1 151 2 AOI22S $T=804140 1082480 1 0 $X=804140 $Y=1077060
X71 403 401 402 154 1 155 2 AOI22S $T=820260 1072400 1 180 $X=816540 $Y=1072020
X72 177 178 404 154 1 155 2 AOI22S $T=830800 1072400 0 0 $X=830800 $Y=1072020
X73 405 407 406 150 1 151 2 AOI22S $T=834520 1082480 1 0 $X=834520 $Y=1077060
X74 409 408 181 150 1 151 2 AOI22S $T=853120 1082480 1 0 $X=853120 $Y=1077060
X75 413 410 411 150 1 151 2 AOI22S $T=874200 1082480 0 180 $X=870480 $Y=1077060
X76 414 412 415 154 1 155 2 AOI22S $T=877300 1072400 1 180 $X=873580 $Y=1072020
X77 418 416 417 154 1 155 2 AOI22S $T=892800 1082480 0 180 $X=889080 $Y=1077060
X78 421 420 419 150 1 151 2 AOI22S $T=901480 1082480 0 180 $X=897760 $Y=1077060
X79 422 423 424 150 1 151 2 AOI22S $T=930000 1082480 1 0 $X=930000 $Y=1077060
X80 427 426 425 154 1 155 2 AOI22S $T=952320 1082480 1 0 $X=952320 $Y=1077060
X81 429 428 430 150 1 151 2 AOI22S $T=962860 1082480 0 180 $X=959140 $Y=1077060
X82 433 432 431 154 1 155 2 AOI22S $T=977120 1072400 0 180 $X=973400 $Y=1066980
X83 435 434 436 154 1 155 2 AOI22S $T=993240 1072400 1 180 $X=989520 $Y=1072020
X84 438 208 209 150 1 151 2 AOI22S $T=995100 1072400 0 180 $X=991380 $Y=1066980
X85 440 437 439 150 1 151 2 AOI22S $T=998200 1072400 1 180 $X=994480 $Y=1072020
X86 441 442 212 154 1 155 2 AOI22S $T=1016180 1072400 1 0 $X=1016180 $Y=1066980
X87 444 445 443 154 1 155 2 AOI22S $T=1032300 1072400 0 0 $X=1032300 $Y=1072020
X88 448 447 446 150 1 151 2 AOI22S $T=1044700 1082480 0 180 $X=1040980 $Y=1077060
X89 449 451 450 154 1 155 2 AOI22S $T=1058340 1072400 0 0 $X=1058340 $Y=1072020
X90 452 453 454 154 1 155 2 AOI22S $T=1067020 1072400 1 180 $X=1063300 $Y=1072020
X91 457 456 455 150 1 151 2 AOI22S $T=1081900 1072400 1 180 $X=1078180 $Y=1072020
X92 265 19 1 2 20 AN2 $T=296360 1072400 0 0 $X=296360 $Y=1072020
X93 269 19 1 2 25 AN2 $T=311860 1072400 0 0 $X=311860 $Y=1072020
X94 275 39 1 2 285 AN2 $T=373240 1082480 0 0 $X=373240 $Y=1082100
X95 299 39 1 2 300 AN2 $T=400520 1072400 0 0 $X=400520 $Y=1072020
X96 64 39 1 2 315 AN2 $T=442060 1072400 0 180 $X=439580 $Y=1066980
X97 74 39 1 2 322 AN2 $T=481740 1072400 0 180 $X=479260 $Y=1066980
X98 77 39 1 2 331 AN2 $T=493520 1072400 0 180 $X=491040 $Y=1066980
X99 346 345 1 2 86 AN2 $T=529480 1092560 0 180 $X=527000 $Y=1087140
X100 352 351 1 2 350 AN2 $T=538160 1082480 0 180 $X=535680 $Y=1077060
X101 93 94 1 2 351 AN2 $T=536920 1072400 1 0 $X=536920 $Y=1066980
X102 353 350 1 2 345 AN2 $T=541260 1082480 1 180 $X=538780 $Y=1082100
X103 102 39 1 2 359 AN2 $T=563580 1072400 0 180 $X=561100 $Y=1066980
X104 106 39 1 2 364 AN2 $T=587140 1082480 0 180 $X=584660 $Y=1077060
X105 109 39 1 2 366 AN2 $T=588380 1072400 1 0 $X=588380 $Y=1066980
X106 382 381 1 2 153 AN2 $T=745240 1082480 1 0 $X=745240 $Y=1077060
X107 390 394 1 2 163 AN2 $T=777480 1082480 1 0 $X=777480 $Y=1077060
X108 402 398 1 2 174 AN2 $T=814060 1072400 0 0 $X=814060 $Y=1072020
X109 404 406 1 2 179 AN2 $T=837000 1072400 0 0 $X=837000 $Y=1072020
X110 415 411 1 2 184 AN2 $T=872340 1072400 0 180 $X=869860 $Y=1066980
X111 417 419 1 2 189 AN2 $T=894040 1082480 0 0 $X=894040 $Y=1082100
X112 425 424 1 2 194 AN2 $T=937440 1082480 0 180 $X=934960 $Y=1077060
X113 431 430 1 2 204 AN2 $T=965340 1072400 0 0 $X=965340 $Y=1072020
X114 436 439 1 2 210 AN2 $T=999440 1072400 0 0 $X=999440 $Y=1072020
X115 443 446 1 2 216 AN2 $T=1037260 1082480 1 0 $X=1037260 $Y=1077060
X116 450 222 1 2 220 AN2 $T=1077560 1072400 0 180 $X=1075080 $Y=1066980
X117 454 455 1 2 221 AN2 $T=1077560 1072400 1 180 $X=1075080 $Y=1072020
X118 388 156 1 2 INV4CK $T=761980 1072400 1 180 $X=758260 $Y=1072020
X119 400 149 1 2 INV4CK $T=807860 1082480 1 0 $X=807860 $Y=1077060
X120 203 197 1 2 INV4CK $T=963480 1072400 1 0 $X=963480 $Y=1066980
X121 392 388 1 2 INV2CK $T=779960 1082480 0 0 $X=779960 $Y=1082100
X122 172 400 1 2 INV2CK $T=814680 1072400 0 180 $X=812200 $Y=1066980
X123 202 201 1 2 INV2CK $T=958520 1082480 0 180 $X=956040 $Y=1077060
X124 157 1 2 160 DELC $T=764460 1072400 0 0 $X=764460 $Y=1072020
X125 396 1 2 389 DELC $T=787400 1072400 0 0 $X=787400 $Y=1072020
X126 173 1 2 176 DELC $T=819640 1072400 1 0 $X=819640 $Y=1066980
X127 161 164 1 2 396 QDBHN $T=779960 1072400 0 0 $X=779960 $Y=1072020
X128 389 161 392 1 2 AN2T $T=771900 1072400 0 0 $X=771900 $Y=1072020
X129 367 1 2 368 DELA $T=648520 1072400 1 0 $X=648520 $Y=1066980
X130 369 1 2 370 DELA $T=655960 1082480 0 0 $X=655960 $Y=1082100
X131 371 1 2 372 DELA $T=666500 1072400 1 0 $X=666500 $Y=1066980
X132 377 1 2 376 DELA $T=722300 1072400 1 0 $X=722300 $Y=1066980
X133 286 45 296 2 46 47 1 AO22 $T=393080 1072400 1 0 $X=393080 $Y=1066980
X134 335 39 78 2 44 80 1 AO22 $T=494760 1072400 1 0 $X=494760 $Y=1066980
X135 348 92 347 2 88 90 1 AO22 $T=535060 1082480 0 180 $X=530100 $Y=1077060
X136 349 92 344 2 91 90 1 AO22 $T=535680 1072400 0 180 $X=530720 $Y=1066980
X137 99 92 354 2 98 90 1 AO22 $T=548700 1072400 0 180 $X=543740 $Y=1066980
X138 356 92 355 2 97 90 1 AO22 $T=551800 1082480 0 180 $X=546840 $Y=1077060
X139 367 124 123 2 122 121 1 AO22 $T=648520 1072400 0 180 $X=643560 $Y=1066980
X140 369 124 125 2 126 121 1 AO22 $T=659680 1072400 0 0 $X=659680 $Y=1072020
X141 371 124 129 2 130 121 1 AO22 $T=671460 1072400 1 0 $X=671460 $Y=1066980
X142 137 124 375 2 138 121 1 AO22 $T=697500 1072400 1 0 $X=697500 $Y=1066980
X143 377 124 378 2 143 121 1 AO22 $T=717340 1072400 1 0 $X=717340 $Y=1066980
X144 373 2 133 134 135 1 375 FA1S $T=686340 1072400 0 0 $X=686340 $Y=1072020
X145 140 2 139 374 373 1 378 FA1S $T=704940 1072400 0 0 $X=704940 $Y=1072020
X146 258 17 18 2 1 265 QDFFRBN $T=283340 1072400 1 0 $X=283340 $Y=1066980
X147 264 17 18 2 1 269 QDFFRBN $T=306280 1082480 0 0 $X=306280 $Y=1082100
X148 270 17 18 2 1 271 QDFFRBN $T=323640 1082480 1 0 $X=323640 $Y=1077060
X149 272 17 32 2 1 275 QDFFRBN $T=336040 1082480 0 0 $X=336040 $Y=1082100
X150 277 17 32 2 1 279 QDFFRBN $T=358360 1082480 1 0 $X=358360 $Y=1077060
X151 289 17 32 2 1 299 QDFFRBN $T=391840 1082480 1 0 $X=391840 $Y=1077060
X152 307 17 32 2 1 56 QDFFRBN $T=415400 1082480 1 0 $X=415400 $Y=1077060
X153 312 17 32 2 1 64 QDFFRBN $T=432760 1082480 0 0 $X=432760 $Y=1082100
X154 330 17 32 2 1 74 QDFFRBN $T=472440 1092560 1 0 $X=472440 $Y=1087140
X155 336 17 32 2 1 77 QDFFRBN $T=482980 1082480 0 0 $X=482980 $Y=1082100
X156 342 83 32 2 1 87 QDFFRBN $T=514600 1082480 1 0 $X=514600 $Y=1077060
X157 343 83 32 2 1 78 QDFFRBN $T=515220 1082480 0 0 $X=515220 $Y=1082100
X158 104 83 32 2 1 102 QDFFRBN $T=578460 1072400 0 180 $X=566680 $Y=1066980
X159 111 83 18 2 1 109 QDFFRBN $T=607600 1072400 0 180 $X=595820 $Y=1066980
X160 116 115 114 2 1 113 QDFFRBN $T=623100 1072400 1 180 $X=611320 $Y=1072020
X161 118 115 114 2 1 119 QDFFRBN $T=627440 1072400 1 0 $X=627440 $Y=1066980
X162 368 115 114 2 1 120 QDFFRBN $T=651620 1082480 0 180 $X=639840 $Y=1077060
X163 370 115 114 2 1 127 QDFFRBN $T=655340 1082480 1 0 $X=655340 $Y=1077060
X164 372 115 114 2 1 132 QDFFRBN $T=670220 1072400 0 0 $X=670220 $Y=1072020
X165 376 142 114 2 1 139 QDFFRBN $T=714860 1072400 0 180 $X=703080 $Y=1066980
X166 40 2 41 1 INV1S $T=378820 1092560 1 0 $X=378820 $Y=1087140
X167 306 2 295 1 INV1S $T=412300 1092560 0 180 $X=411060 $Y=1087140
X168 88 2 346 1 INV1S $T=527620 1082480 1 0 $X=527620 $Y=1077060
X169 95 2 96 1 INV1S $T=537540 1092560 1 0 $X=537540 $Y=1087140
X170 98 2 352 1 INV1S $T=541880 1072400 1 180 $X=540640 $Y=1072020
X171 97 2 353 1 INV1S $T=542500 1082480 0 0 $X=542500 $Y=1082100
X172 131 2 374 1 INV1S $T=678280 1072400 1 0 $X=678280 $Y=1066980
X173 10 11 12 2 1 256 XOR3 $T=249860 1072400 0 0 $X=249860 $Y=1072020
X174 22 253 263 2 1 264 XOR3 $T=299460 1082480 1 180 $X=288300 $Y=1082100
X175 24 20 21 2 1 255 XOR3 $T=310000 1072400 0 180 $X=298840 $Y=1066980
X176 28 27 23 2 1 270 XOR3 $T=330460 1072400 1 180 $X=319300 $Y=1072020
X177 30 31 33 2 1 34 XOR3 $T=337900 1072400 1 0 $X=337900 $Y=1066980
X178 273 274 35 2 1 277 XOR3 $T=350300 1072400 0 0 $X=350300 $Y=1072020
X179 278 36 276 2 1 272 XOR3 $T=363320 1082480 1 180 $X=352160 $Y=1082100
X180 286 284 37 2 1 273 XOR3 $T=376960 1072400 0 180 $X=365800 $Y=1066980
X181 295 294 283 2 1 289 XOR3 $T=393080 1092560 0 180 $X=381920 $Y=1087140
X182 59 58 52 2 1 308 XOR3 $T=430900 1072400 0 180 $X=419740 $Y=1066980
X183 62 315 63 2 1 317 XOR3 $T=437720 1072400 0 0 $X=437720 $Y=1072020
X184 317 65 316 2 1 312 XOR3 $T=452600 1092560 0 180 $X=441440 $Y=1087140
X185 67 320 321 2 1 330 XOR3 $T=456940 1092560 1 0 $X=456940 $Y=1087140
X186 73 331 328 2 1 327 XOR3 $T=476160 1082480 0 180 $X=465000 $Y=1077060
X187 327 69 325 2 1 336 XOR3 $T=469340 1082480 0 0 $X=469340 $Y=1082100
X188 340 81 341 2 1 342 XOR3 $T=500340 1072400 0 0 $X=500340 $Y=1072020
X189 79 334 329 2 1 343 XOR3 $T=500960 1082480 0 0 $X=500960 $Y=1082100
X190 85 84 76 2 1 340 XOR3 $T=520800 1072400 0 180 $X=509640 $Y=1066980
X191 356 359 358 2 1 103 XOR3 $T=560480 1082480 1 0 $X=560480 $Y=1077060
X192 349 366 363 2 1 110 XOR3 $T=589620 1082480 1 0 $X=589620 $Y=1077060
X193 62 63 315 1 2 326 MAO222 $T=443920 1072400 1 0 $X=443920 $Y=1066980
X194 66 326 322 1 2 328 MAO222 $T=465620 1072400 1 0 $X=465620 $Y=1066980
X195 73 328 331 1 2 332 MAO222 $T=472440 1072400 1 0 $X=472440 $Y=1066980
X196 99 101 100 1 2 358 MAO222 $T=552420 1072400 0 0 $X=552420 $Y=1072020
X197 349 363 366 1 2 108 MAO222 $T=582180 1072400 0 0 $X=582180 $Y=1072020
X198 5 6 253 2 1 XOR2HS $T=236220 1072400 1 0 $X=236220 $Y=1066980
X199 256 255 254 2 1 XOR2HS $T=267840 1072400 0 180 $X=262260 $Y=1066980
X200 254 257 258 2 1 XOR2HS $T=269080 1072400 1 0 $X=269080 $Y=1066980
X201 288 287 278 2 1 XOR2HS $T=382540 1082480 1 180 $X=376960 $Y=1082100
X202 285 43 287 2 1 XOR2HS $T=388740 1082480 1 180 $X=383160 $Y=1082100
X203 49 48 296 2 1 XOR2HS $T=404240 1072400 0 180 $X=398660 $Y=1066980
X204 309 302 307 2 1 XOR2HS $T=421600 1092560 0 180 $X=416020 $Y=1087140
X205 55 308 309 2 1 XOR2HS $T=428420 1082480 1 180 $X=422840 $Y=1082100
X206 89 86 344 2 1 XOR2HS $T=529480 1072400 0 180 $X=523900 $Y=1066980
X207 346 345 347 2 1 XOR2HS $T=530720 1082480 0 0 $X=530720 $Y=1082100
X208 352 351 354 2 1 XOR2HS $T=539400 1082480 1 0 $X=539400 $Y=1077060
X209 353 350 355 2 1 XOR2HS $T=544980 1082480 0 0 $X=544980 $Y=1082100
X210 348 364 365 2 1 XOR2HS $T=574740 1082480 0 0 $X=574740 $Y=1082100
X211 357 365 105 2 1 XOR2HS $T=576600 1082480 1 0 $X=576600 $Y=1077060
X212 348 362 364 2 1 ND2S $T=571640 1082480 0 0 $X=571640 $Y=1082100
X213 10 7 11 1 2 ND2 $T=248620 1072400 1 0 $X=248620 $Y=1066980
X214 256 259 257 1 2 ND2 $T=272800 1072400 0 0 $X=272800 $Y=1072020
X215 256 260 255 1 2 ND2 $T=272800 1082480 1 0 $X=272800 $Y=1077060
X216 16 262 14 1 2 ND2 $T=279620 1072400 0 180 $X=277760 $Y=1066980
X217 257 261 255 1 2 ND2 $T=282720 1082480 1 0 $X=282720 $Y=1077060
X218 263 266 253 1 2 ND2 $T=300080 1082480 1 0 $X=300080 $Y=1077060
X219 263 267 22 1 2 ND2 $T=300080 1092560 1 0 $X=300080 $Y=1087140
X220 22 268 253 1 2 ND2 $T=309380 1072400 1 180 $X=307520 $Y=1072020
X221 278 282 36 1 2 ND2 $T=375100 1092560 1 0 $X=375100 $Y=1087140
X222 288 290 285 1 2 ND2 $T=383780 1072400 1 180 $X=381920 $Y=1072020
X223 288 293 43 1 2 ND2 $T=386880 1072400 1 0 $X=386880 $Y=1066980
X224 285 292 43 1 2 ND2 $T=394320 1072400 0 0 $X=394320 $Y=1072020
X225 283 297 294 1 2 ND2 $T=397420 1092560 0 180 $X=395560 $Y=1087140
X226 283 298 295 1 2 ND2 $T=397420 1092560 1 0 $X=397420 $Y=1087140
X227 291 303 300 1 2 ND2 $T=406100 1072400 1 180 $X=404240 $Y=1072020
X228 295 301 294 1 2 ND2 $T=409200 1092560 0 180 $X=407340 $Y=1087140
X229 51 304 300 1 2 ND2 $T=411060 1072400 0 180 $X=409200 $Y=1066980
X230 291 305 51 1 2 ND2 $T=411060 1072400 1 180 $X=409200 $Y=1072020
X231 302 310 308 1 2 ND2 $T=430900 1082480 1 180 $X=429040 $Y=1082100
X232 308 314 55 1 2 ND2 $T=431520 1082480 0 180 $X=429660 $Y=1077060
X233 302 311 55 1 2 ND2 $T=431520 1092560 0 180 $X=429660 $Y=1087140
X234 52 313 58 1 2 ND2 $T=433380 1072400 1 180 $X=431520 $Y=1072020
X235 67 324 320 1 2 ND2 $T=460040 1082480 1 0 $X=460040 $Y=1077060
X236 79 339 334 1 2 ND2 $T=498480 1082480 0 180 $X=496620 $Y=1077060
X237 357 360 348 1 2 ND2 $T=558000 1092560 0 180 $X=556140 $Y=1087140
X238 357 361 364 1 2 ND2 $T=569780 1092560 1 0 $X=569780 $Y=1087140
X239 15 257 13 262 1 2 ND3P $T=275900 1072400 0 0 $X=275900 $Y=1072020
X240 259 263 261 260 1 2 ND3P $T=275900 1082480 1 0 $X=275900 $Y=1077060
X241 267 23 266 268 1 2 ND3P $T=300080 1072400 0 0 $X=300080 $Y=1072020
X242 281 283 280 282 1 2 ND3P $T=369520 1092560 1 0 $X=369520 $Y=1087140
X243 293 291 290 292 1 2 ND3P $T=390600 1072400 1 180 $X=385640 $Y=1072020
X244 297 302 298 301 1 2 ND3P $T=400520 1092560 1 0 $X=400520 $Y=1087140
X245 303 52 305 304 1 2 ND3P $T=412300 1072400 1 0 $X=412300 $Y=1066980
X246 311 316 310 314 1 2 ND3P $T=433380 1092560 1 0 $X=433380 $Y=1087140
X247 60 63 313 61 1 2 ND3P $T=434000 1072400 1 0 $X=434000 $Y=1066980
X248 323 325 319 324 1 2 ND3P $T=453840 1082480 1 0 $X=453840 $Y=1077060
X249 338 341 337 339 1 2 ND3P $T=494760 1092560 1 0 $X=494760 $Y=1087140
X250 361 363 360 362 1 2 ND3P $T=562960 1082480 0 0 $X=562960 $Y=1082100
X251 35 274 273 276 1 2 MAO222P $T=349060 1082480 1 0 $X=349060 $Y=1077060
X252 37 286 284 288 1 2 MAO222P $T=376340 1072400 0 0 $X=376340 $Y=1072020
X253 316 317 65 321 1 2 MAO222P $T=446400 1082480 1 0 $X=446400 $Y=1077060
X254 325 327 69 329 1 2 MAO222P $T=461280 1082480 0 0 $X=461280 $Y=1082100
X255 332 75 335 76 1 2 MAO222P $T=483600 1072400 1 0 $X=483600 $Y=1066980
X256 341 340 81 82 1 2 MAO222P $T=500960 1072400 1 0 $X=500960 $Y=1066980
X257 358 356 359 357 1 2 MAO222P $T=558000 1082480 0 180 $X=552420 $Y=1077060
X258 278 1 276 280 2 ND2P $T=369520 1092560 0 180 $X=365800 $Y=1087140
X259 36 1 276 281 2 ND2P $T=368280 1082480 0 0 $X=368280 $Y=1082100
X260 320 1 321 319 2 ND2P $T=455080 1082480 1 180 $X=451360 $Y=1082100
X261 67 1 321 323 2 ND2P $T=455080 1082480 0 0 $X=455080 $Y=1082100
X262 79 1 329 338 2 ND2P $T=504060 1092560 1 0 $X=504060 $Y=1087140
X263 334 1 329 337 2 ND2T $T=488560 1092560 1 0 $X=488560 $Y=1087140
X264 51 300 291 2 1 306 XNR3 $T=407340 1082480 0 0 $X=407340 $Y=1082100
X265 66 322 326 2 1 318 XNR3 $T=452600 1072400 0 0 $X=452600 $Y=1072020
X266 75 335 332 2 1 333 XNR3 $T=482360 1082480 1 0 $X=482360 $Y=1077060
X267 42 274 1 2 INV2 $T=385640 1072400 0 180 $X=383780 $Y=1066980
X268 44 39 1 2 INV2 $T=389980 1072400 1 0 $X=389980 $Y=1066980
X269 50 294 1 2 INV2 $T=407960 1072400 0 180 $X=406100 $Y=1066980
X270 318 320 1 2 INV2 $T=450740 1072400 0 0 $X=450740 $Y=1072020
X271 333 334 1 2 INV2 $T=480500 1082480 1 0 $X=480500 $Y=1077060
X272 68 70 71 72 1 2 MXL2H $T=463760 1072400 0 0 $X=463760 $Y=1072020
X273 53 2 54 57 1 AN2B1S $T=422840 1072400 0 0 $X=422840 $Y=1072020
X274 271 19 1 29 2 AN2S $T=335420 1072400 0 0 $X=335420 $Y=1072020
X275 279 39 1 284 2 AN2S $T=376960 1082480 1 0 $X=376960 $Y=1077060
X276 8 38 1 2 INV8CK $T=376960 1082480 0 180 $X=370140 $Y=1077060
X277 4 3 1 2 BUF2CK $T=221340 1082480 0 0 $X=221340 $Y=1082100
X278 18 32 1 2 BUF2CK $T=341000 1072400 0 0 $X=341000 $Y=1072020
X279 9 8 1 2 INV12CK $T=246140 1092560 0 180 $X=236220 $Y=1087140
X280 8 26 1 2 INV12CK $T=329220 1092560 0 180 $X=319300 $Y=1087140
.ENDS
***************************************
.SUBCKT AO222 C1 C2 B2 B1 A1 A2 GND VCC O
** N=10 EP=9 IP=0 FDC=0
.ENDS
***************************************
.SUBCKT ND3 I3 GND I2 O VCC I1
** N=7 EP=6 IP=0 FDC=0
.ENDS
***************************************
.SUBCKT AN4B1S I3 I2 I1 VCC B1 GND O
** N=8 EP=7 IP=0 FDC=0
.ENDS
***************************************
.SUBCKT BUF1CK I GND VCC O
** N=5 EP=4 IP=0 FDC=0
.ENDS
***************************************
.SUBCKT OA22 A1 A2 B1 B2 VCC GND O
** N=8 EP=7 IP=0 FDC=0
.ENDS
***************************************
.SUBCKT ICV_6 1 2 3 4 5 6 7 8 9
** N=9 EP=9 IP=12 FDC=0
X0 1 2 3 4 5 QDFFN $T=0 0 0 0 $X=0 $Y=-380
X1 6 7 8 4 5 QDFFN $T=10540 0 0 0 $X=10540 $Y=-380
.ENDS
***************************************
.SUBCKT INV3CK I GND VCC O
** N=5 EP=4 IP=0 FDC=0
.ENDS
***************************************
.SUBCKT INV6CK I O GND VCC
** N=5 EP=4 IP=0 FDC=0
.ENDS
***************************************
.SUBCKT OAI22S B2 GND B1 A2 O A1 VCC
** N=8 EP=7 IP=0 FDC=0
.ENDS
***************************************
.SUBCKT NR2 I1 VCC O I2 GND
** N=6 EP=5 IP=0 FDC=0
.ENDS
***************************************
.SUBCKT AOI12HS B2 B1 VCC A1 GND O
** N=7 EP=6 IP=0 FDC=0
.ENDS
***************************************
.SUBCKT DELB I GND VCC O
** N=5 EP=4 IP=0 FDC=0
.ENDS
***************************************
.SUBCKT AN2P I1 I2 O GND VCC
** N=6 EP=5 IP=0 FDC=0
.ENDS
***************************************
.SUBCKT BUF1 I VCC GND O
** N=5 EP=4 IP=0 FDC=0
.ENDS
***************************************
.SUBCKT BUF1S I GND VCC O
** N=5 EP=4 IP=0 FDC=0
.ENDS
***************************************
.SUBCKT BUF3 I VCC GND O
** N=5 EP=4 IP=0 FDC=0
.ENDS
***************************************
.SUBCKT OR3B2 I1 B1 VCC O B2 GND
** N=7 EP=6 IP=0 FDC=0
.ENDS
***************************************
.SUBCKT NR3 I1 VCC I2 I3 O GND
** N=7 EP=6 IP=0 FDC=0
.ENDS
***************************************
.SUBCKT OAI112HS C2 C1 GND B1 O A1 VCC
** N=8 EP=7 IP=0 FDC=0
.ENDS
***************************************
.SUBCKT XOR3S I2 I1 I3 VCC GND O
** N=7 EP=6 IP=0 FDC=0
.ENDS
***************************************
.SUBCKT FA1 S B VCC A CI GND CO
** N=8 EP=7 IP=0 FDC=0
.ENDS
***************************************
.SUBCKT XNR2HS I1 I2 O VCC GND
** N=6 EP=5 IP=0 FDC=0
.ENDS
***************************************
.SUBCKT OR2 I2 I1 VCC GND O
** N=6 EP=5 IP=0 FDC=0
.ENDS
***************************************
.SUBCKT MOAI1S B1 B2 GND A1 A2 O VCC
** N=8 EP=7 IP=0 FDC=0
.ENDS
***************************************
.SUBCKT OAI222S C1 C2 GND B1 B2 VCC A1 O A2
** N=10 EP=9 IP=0 FDC=0
.ENDS
***************************************
.SUBCKT NR2P I1 VCC I2 GND O
** N=6 EP=5 IP=0 FDC=0
.ENDS
***************************************
.SUBCKT BUF2 I O GND VCC
** N=5 EP=4 IP=0 FDC=0
.ENDS
***************************************
.SUBCKT OA222S A2 A1 B2 B1 C2 C1 VCC GND O
** N=10 EP=9 IP=0 FDC=0
.ENDS
***************************************
.SUBCKT OAI12HS B2 B1 GND A1 VCC O
** N=7 EP=6 IP=0 FDC=0
.ENDS
***************************************
.SUBCKT AOI13HS B3 O B2 B1 VCC A1 GND
** N=8 EP=7 IP=0 FDC=0
.ENDS
***************************************
.SUBCKT ND3S I3 GND I2 O I1 VCC
** N=7 EP=6 IP=0 FDC=0
.ENDS
***************************************
.SUBCKT OA222 A2 A1 B2 B1 C2 C1 GND VCC O
** N=10 EP=9 IP=0 FDC=0
.ENDS
***************************************
.SUBCKT OA12S B2 B1 A1 VCC GND O
** N=7 EP=6 IP=0 FDC=0
.ENDS
***************************************
.SUBCKT AN3 I1 I2 I3 VCC GND O
** N=7 EP=6 IP=0 FDC=0
.ENDS
***************************************
.SUBCKT OA13S B3 B2 B1 A1 GND VCC O
** N=8 EP=7 IP=0 FDC=0
.ENDS
***************************************
.SUBCKT AO222S C1 C2 B2 B1 A1 A2 GND VCC O
** N=10 EP=9 IP=0 FDC=0
.ENDS
***************************************
.SUBCKT MUX2 B S VCC GND O A
** N=7 EP=6 IP=0 FDC=0
.ENDS
***************************************
.SUBCKT XNR2H I2 O I1 GND VCC
** N=6 EP=5 IP=0 FDC=0
.ENDS
***************************************
.SUBCKT QDFFRBS D CK RB VCC GND Q
** N=7 EP=6 IP=0 FDC=0
.ENDS
***************************************
.SUBCKT BUF8CK I GND VCC O
** N=5 EP=4 IP=0 FDC=0
.ENDS
***************************************
.SUBCKT AO22S O A2 A1 VCC B1 B2 GND
** N=8 EP=7 IP=0 FDC=0
.ENDS
***************************************
.SUBCKT MUX2S B S VCC A GND O
** N=7 EP=6 IP=0 FDC=0
.ENDS
***************************************
.SUBCKT XOR2H I1 I2 O GND VCC
** N=6 EP=5 IP=0 FDC=0
.ENDS
***************************************
.SUBCKT ND3HT I3 GND I2 I1 VCC O
** N=7 EP=6 IP=0 FDC=0
.ENDS
***************************************
.SUBCKT AOI13H B3 B2 B1 VCC O GND A1
** N=8 EP=7 IP=0 FDC=0
.ENDS
***************************************
.SUBCKT MXL2HS B S OB A VCC GND
** N=7 EP=6 IP=0 FDC=0
.ENDS
***************************************
.SUBCKT AN2B1T B1 I1 O GND VCC
** N=6 EP=5 IP=0 FDC=0
.ENDS
***************************************
.SUBCKT AN4B1 I3 I2 I1 O B1 GND VCC
** N=8 EP=7 IP=0 FDC=0
.ENDS
***************************************
.SUBCKT OA12 B2 B1 A1 GND VCC O
** N=7 EP=6 IP=0 FDC=0
.ENDS
***************************************
.SUBCKT AO22P O A2 A1 VCC B1 B2 GND
** N=8 EP=7 IP=0 FDC=0
.ENDS
***************************************
.SUBCKT MOAI1 B1 B2 GND A1 O A2 VCC
** N=8 EP=7 IP=0 FDC=0
.ENDS
***************************************
.SUBCKT OR2B1S I1 B1 GND O VCC
** N=6 EP=5 IP=0 FDC=0
.ENDS
***************************************
.SUBCKT AOI22H A2 A1 VCC B1 O B2 GND
** N=8 EP=7 IP=0 FDC=0
.ENDS
***************************************
.SUBCKT NR3H O I3 I2 I1 VCC GND
** N=7 EP=6 IP=0 FDC=0
.ENDS
***************************************
.SUBCKT MOAI1H B1 B2 GND A1 O A2 VCC
** N=8 EP=7 IP=0 FDC=0
.ENDS
***************************************
.SUBCKT NR2T O I2 GND I1 VCC
** N=6 EP=5 IP=0 FDC=0
.ENDS
***************************************
.SUBCKT OR2B1P B1 I1 O GND VCC
** N=6 EP=5 IP=0 FDC=0
.ENDS
***************************************
.SUBCKT ICV_7 1 2 3 4 5 6 7 8 9 10 11 12 13 14 15 16 17 18 19 20
+ 21 22 23 24 25 26 27 28 29 30 31 32 33 34 35 36 37 38 39 40
+ 41 42 43 44 45 46 47 48 49 50 51 52 53 54 55 56 57 58 59 60
+ 61 62 63 64 65 66 67 68 69 70 71 72 73 74 75 76 77 78 79 80
+ 81 82 83 84 85 86 87 88 89 90 91 92 93 94 95 96 97 98 99 100
+ 101 102 103 104 105 106 107 108 109 110 111 112 113 114 115 116 117 118 119 120
+ 121 122 123 124 125 126 127 128 129 130 131 132 133 134 135 136 137 138 139 140
+ 141 142 143 144 145 146 147 148 149 150 151 152 153 154 155 156 157 158 159 160
+ 161 162 163 164 165 166 167 168 169 170 171 172 173 174 175 176 177 178 179 180
+ 181 182 183 184 185 186 187 188 189 190 191 192 193 194 195 196 197 198 199 200
+ 201 202 203 204 205 206 207 208 209 210 211 212 213 214 215 216 217 218 219 220
+ 221 222 223 224 225 226 227 228 229 230 231 232 233 234 235 236 237 238 239 240
+ 241 242 243 244 245 246 247 248 249 250 251 252 253 254 255 256 257 258 259 260
+ 261 262 263 264 265 266 267 268 269 270 271 272 273 274 275 276 277 278 279 280
+ 281 282 283 284 285 286 287 288 289 290 291 292 293 294 295 296 297 298 299 300
+ 301 302 303 304 305 306 307 308 309 310 311 312 313 314 315 316 317 318 319 320
+ 321 322 323 324 325 326 327 328 329 330 331 332 333 334 335 336 337 338 339 340
+ 341 342 343 344 345 346 347 348 349 350 351 352 353 354 355 356 357 358 359 360
+ 361 362 363 364 365 366 367 368 369 370 371 372 373 374 375 376 377 378 379 380
+ 381 382 383 384 385 386 387 388 389 390 391 392 393 394 395 396 397 398 399 400
+ 401 402 403 404 405 406 407 408 409 410 411 412 413 414 415 416 417 418 419 420
+ 421 422 423 424 425 426 427 428 429 430 431 432 433 434 435 436 437 438 439 440
+ 441 442 443 444 445 446 447 448 449 450 451 452 453 454 455 456 457 458 459 460
+ 461 462 463 464 465 466 467 468 469 470 471 472 473 474 475 476 477 478 479 480
+ 481 482 483 484 485 486 487 488 489 490 491 492 493 494 495 496 497 498 499 500
+ 501 502 503 504 505 506 507 508 509 510 511 512 513 514 515 516 517 518 519 520
+ 521 522 523 524 525 526 527 528 529 530 531 532 533 534 535 536 537 538 539 540
+ 541 542 543 544 545 546 547 548 549 550 551 552 553 554 555 556 557 558 559 560
+ 561 562 563 564 565 566 567 568 569 570 571 589
** N=4500 EP=572 IP=26533 FDC=0
X0 2203 210 2258 1 2 QDFFN $T=513980 901040 1 0 $X=513980 $Y=895620
X1 2198 210 2267 1 2 QDFFN $T=517080 890960 1 0 $X=517080 $Y=885540
X2 224 220 2225 1 2 QDFFN $T=528860 901040 1 180 $X=518320 $Y=900660
X3 223 220 2237 1 2 QDFFN $T=531960 890960 1 180 $X=521420 $Y=890580
X4 2274 232 2204 1 2 QDFFN $T=535060 931280 1 180 $X=524520 $Y=930900
X5 2238 210 2290 1 2 QDFFN $T=526380 911120 1 0 $X=526380 $Y=905700
X6 2293 232 2213 1 2 QDFFN $T=536920 931280 0 180 $X=526380 $Y=925860
X7 2261 210 2297 1 2 QDFFN $T=527000 921200 1 0 $X=527000 $Y=915780
X8 2291 232 2245 1 2 QDFFN $T=538160 921200 1 180 $X=527620 $Y=920820
X9 2274 220 2322 1 2 QDFFN $T=530720 941360 0 0 $X=530720 $Y=940980
X10 2306 232 2284 1 2 QDFFN $T=543740 901040 0 180 $X=533200 $Y=895620
X11 2291 220 2315 1 2 QDFFN $T=536920 931280 0 0 $X=536920 $Y=930900
X12 2293 220 2341 1 2 QDFFN $T=537540 951440 1 0 $X=537540 $Y=946020
X13 2303 210 2346 1 2 QDFFN $T=539400 911120 1 0 $X=539400 $Y=905700
X14 2305 210 2342 1 2 QDFFN $T=540020 921200 0 0 $X=540020 $Y=920820
X15 2306 220 2359 1 2 QDFFN $T=540020 961520 1 0 $X=540020 $Y=956100
X16 2349 232 2296 1 2 QDFFN $T=551180 890960 0 180 $X=540640 $Y=885540
X17 2287 210 2323 1 2 QDFFN $T=543120 880880 0 0 $X=543120 $Y=880500
X18 2326 210 2367 1 2 QDFFN $T=544980 911120 0 0 $X=544980 $Y=910740
X19 2371 220 2327 1 2 QDFFN $T=555520 961520 1 180 $X=544980 $Y=961140
X20 2349 220 2331 1 2 QDFFN $T=556760 901040 0 180 $X=546220 $Y=895620
X21 2371 232 2285 1 2 QDFFN $T=556760 931280 0 180 $X=546220 $Y=925860
X22 2384 220 2339 1 2 QDFFN $T=559240 941360 0 180 $X=548700 $Y=935940
X23 2395 232 2309 1 2 QDFFN $T=560480 931280 1 180 $X=549940 $Y=930900
X24 2351 210 2389 1 2 QDFFN $T=550560 901040 0 0 $X=550560 $Y=900660
X25 2358 210 2406 1 2 QDFFN $T=552420 911120 1 0 $X=552420 $Y=905700
X26 2329 210 2407 1 2 QDFFN $T=553040 890960 1 0 $X=553040 $Y=885540
X27 2384 232 2314 1 2 QDFFN $T=563580 921200 1 180 $X=553040 $Y=920820
X28 2395 220 2373 1 2 QDFFN $T=566060 971600 1 180 $X=555520 $Y=971220
X29 2350 210 2411 1 2 QDFFN $T=556140 880880 0 0 $X=556140 $Y=880500
X30 2378 210 2423 1 2 QDFFN $T=557380 911120 0 0 $X=557380 $Y=910740
X31 2385 210 2438 1 2 QDFFN $T=558620 901040 1 0 $X=558620 $Y=895620
X32 245 220 2427 1 2 QDFFN $T=558620 991760 1 0 $X=558620 $Y=986340
X33 2404 210 2455 1 2 QDFFN $T=562960 901040 0 0 $X=562960 $Y=900660
X34 2410 210 2461 1 2 QDFFN $T=565440 890960 1 0 $X=565440 $Y=885540
X35 2442 220 2479 1 2 QDFFN $T=570400 1011920 1 0 $X=570400 $Y=1006500
X36 2578 220 2492 1 2 QDFFN $T=590860 1001840 1 180 $X=580320 $Y=1001460
X37 2597 220 2524 1 2 QDFFN $T=595200 1011920 1 180 $X=584660 $Y=1011540
X38 2618 220 2559 1 2 QDFFN $T=603260 1001840 0 180 $X=592720 $Y=996420
X39 2622 220 2569 1 2 QDFFN $T=604500 1001840 1 180 $X=593960 $Y=1001460
X40 2602 220 2615 1 2 QDFFN $T=598920 1011920 0 0 $X=598920 $Y=1011540
X41 3239 343 3296 1 2 QDFFN $T=723540 1052240 0 0 $X=723540 $Y=1051860
X42 3239 346 3293 1 2 QDFFN $T=724780 1062320 1 0 $X=724780 $Y=1056900
X43 342 346 3285 1 2 QDFFN $T=724780 1062320 0 0 $X=724780 $Y=1061940
X44 3239 3278 3318 1 2 QDFFN $T=730360 1032080 0 0 $X=730360 $Y=1031700
X45 3239 3282 3356 1 2 QDFFN $T=730980 1032080 1 0 $X=730980 $Y=1026660
X46 342 3291 3331 1 2 QDFFN $T=732840 1011920 0 0 $X=732840 $Y=1011540
X47 350 3291 3325 1 2 QDFFN $T=732840 1022000 1 0 $X=732840 $Y=1016580
X48 342 3278 3335 1 2 QDFFN $T=732840 1042160 1 0 $X=732840 $Y=1036740
X49 342 3282 3345 1 2 QDFFN $T=733460 1042160 0 0 $X=733460 $Y=1041780
X50 3239 3291 3348 1 2 QDFFN $T=737800 1001840 0 0 $X=737800 $Y=1001460
X51 3239 355 3370 1 2 QDFFN $T=739660 1062320 1 0 $X=739660 $Y=1056900
X52 342 3362 3336 1 2 QDFFN $T=753920 971600 0 180 $X=743380 $Y=966180
X53 3239 3347 3377 1 2 QDFFN $T=743380 991760 0 0 $X=743380 $Y=991380
X54 3239 3376 3346 1 2 QDFFN $T=755160 981680 0 180 $X=744620 $Y=976260
X55 350 3347 3385 1 2 QDFFN $T=745240 991760 1 0 $X=745240 $Y=986340
X56 342 3347 3394 1 2 QDFFN $T=745240 1001840 1 0 $X=745240 $Y=996420
X57 350 3362 3391 1 2 QDFFN $T=746480 951440 0 0 $X=746480 $Y=951060
X58 350 3282 3373 1 2 QDFFN $T=747100 1052240 1 0 $X=747100 $Y=1046820
X59 3239 365 3359 1 2 QDFFN $T=757640 1062320 1 180 $X=747100 $Y=1061940
X60 342 3395 3344 1 2 QDFFN $T=760120 1011920 1 180 $X=749580 $Y=1011540
X61 350 3278 3368 1 2 QDFFN $T=760120 1042160 0 180 $X=749580 $Y=1036740
X62 3239 3362 3403 1 2 QDFFN $T=750200 961520 1 0 $X=750200 $Y=956100
X63 3239 3395 3353 1 2 QDFFN $T=760740 1001840 1 180 $X=750200 $Y=1001460
X64 360 3376 3405 1 2 QDFFN $T=750820 931280 1 0 $X=750820 $Y=925860
X65 362 3376 3410 1 2 QDFFN $T=752060 951440 1 0 $X=752060 $Y=946020
X66 360 3278 3408 1 2 QDFFN $T=752680 1032080 1 0 $X=752680 $Y=1026660
X67 360 3383 3418 1 2 QDFFN $T=753300 941360 1 0 $X=753300 $Y=935940
X68 362 3383 3409 1 2 QDFFN $T=753300 941360 0 0 $X=753300 $Y=940980
X69 342 3376 3415 1 2 QDFFN $T=753300 971600 0 0 $X=753300 $Y=971220
X70 350 3395 3369 1 2 QDFFN $T=764460 1022000 0 180 $X=753920 $Y=1016580
X71 360 3362 3427 1 2 QDFFN $T=754540 921200 0 0 $X=754540 $Y=920820
X72 342 3390 3420 1 2 QDFFN $T=754540 971600 1 0 $X=754540 $Y=966180
X73 360 346 3424 1 2 QDFFN $T=755780 1052240 0 0 $X=755780 $Y=1051860
X74 342 3383 3435 1 2 QDFFN $T=757020 981680 0 0 $X=757020 $Y=981300
X75 360 3282 3436 1 2 QDFFN $T=757020 1032080 0 0 $X=757020 $Y=1031700
X76 3239 3383 3451 1 2 QDFFN $T=757640 991760 1 0 $X=757640 $Y=986340
X77 360 3347 3447 1 2 QDFFN $T=758880 1001840 1 0 $X=758880 $Y=996420
X78 360 3390 3438 1 2 QDFFN $T=759500 921200 1 0 $X=759500 $Y=915780
X79 360 3395 3445 1 2 QDFFN $T=760740 1011920 0 0 $X=760740 $Y=1011540
X80 350 3390 3412 1 2 QDFFN $T=773140 951440 0 180 $X=762600 $Y=946020
X81 360 3291 3463 1 2 QDFFN $T=762600 1011920 1 0 $X=762600 $Y=1006500
X82 378 3383 3477 1 2 QDFFN $T=765700 931280 0 0 $X=765700 $Y=930900
X83 378 3278 3482 1 2 QDFFN $T=766940 1042160 1 0 $X=766940 $Y=1036740
X84 362 3362 3484 1 2 QDFFN $T=767560 941360 0 0 $X=767560 $Y=940980
X85 360 343 3414 1 2 QDFFN $T=778720 1052240 0 180 $X=768180 $Y=1046820
X86 350 3383 3490 1 2 QDFFN $T=769420 981680 0 0 $X=769420 $Y=981300
X87 378 3291 3499 1 2 QDFFN $T=770040 1022000 1 0 $X=770040 $Y=1016580
X88 350 3376 3498 1 2 QDFFN $T=770660 991760 1 0 $X=770660 $Y=986340
X89 378 3282 3464 1 2 QDFFN $T=781820 1032080 1 180 $X=771280 $Y=1031700
X90 378 3347 3500 1 2 QDFFN $T=771900 1001840 0 0 $X=771900 $Y=1001460
X91 362 3390 3473 1 2 QDFFN $T=783680 951440 0 180 $X=773140 $Y=946020
X92 378 3395 3502 1 2 QDFFN $T=773140 1011920 0 0 $X=773140 $Y=1011540
X93 3239 3390 3469 1 2 QDFFN $T=784920 961520 0 180 $X=774380 $Y=956100
X94 362 346 3480 1 2 QDFFN $T=785540 1042160 1 180 $X=775000 $Y=1041780
X95 362 365 3514 1 2 QDFFN $T=775000 1062320 1 0 $X=775000 $Y=1056900
X96 378 3390 3481 1 2 QDFFN $T=786780 911120 1 180 $X=776240 $Y=910740
X97 378 3376 3483 1 2 QDFFN $T=788640 931280 0 180 $X=778100 $Y=925860
X98 360 3478 3525 1 2 QDFFN $T=778100 941360 1 0 $X=778100 $Y=935940
X99 362 3282 3516 1 2 QDFFN $T=779960 1042160 1 0 $X=779960 $Y=1036740
X100 378 3506 3532 1 2 QDFFN $T=780580 921200 0 0 $X=780580 $Y=920820
X101 362 3278 3524 1 2 QDFFN $T=781200 1032080 1 0 $X=781200 $Y=1026660
X102 3239 3506 3538 1 2 QDFFN $T=781820 981680 1 0 $X=781820 $Y=976260
X103 350 3506 3548 1 2 QDFFN $T=782440 991760 1 0 $X=782440 $Y=986340
X104 360 3506 3539 1 2 QDFFN $T=783060 941360 0 0 $X=783060 $Y=940980
X105 362 3291 3535 1 2 QDFFN $T=783060 1001840 0 0 $X=783060 $Y=1001460
X106 362 3395 3529 1 2 QDFFN $T=784300 1011920 0 0 $X=784300 $Y=1011540
X107 350 3523 3552 1 2 QDFFN $T=786780 961520 1 0 $X=786780 $Y=956100
X108 400 3282 3549 1 2 QDFFN $T=786780 1032080 0 0 $X=786780 $Y=1031700
X109 362 3523 3551 1 2 QDFFN $T=788020 951440 1 0 $X=788020 $Y=946020
X110 400 343 3571 1 2 QDFFN $T=789260 1052240 1 0 $X=789260 $Y=1046820
X111 400 346 3560 1 2 QDFFN $T=789260 1062320 1 0 $X=789260 $Y=1056900
X112 360 3523 3544 1 2 QDFFN $T=790500 931280 1 0 $X=790500 $Y=925860
X113 362 3347 3512 1 2 QDFFN $T=802280 1001840 0 180 $X=791740 $Y=996420
X114 378 3523 3547 1 2 QDFFN $T=792360 911120 0 0 $X=792360 $Y=910740
X115 400 3278 3565 1 2 QDFFN $T=792980 1042160 0 0 $X=792980 $Y=1041780
X116 362 3478 3597 1 2 QDFFN $T=794220 951440 0 0 $X=794220 $Y=951060
X117 342 3506 3580 1 2 QDFFN $T=794840 981680 1 0 $X=794840 $Y=976260
X118 342 3523 3576 1 2 QDFFN $T=794840 981680 0 0 $X=794840 $Y=981300
X119 400 3395 3563 1 2 QDFFN $T=795460 1022000 1 0 $X=795460 $Y=1016580
X120 362 3506 3575 1 2 QDFFN $T=796080 941360 0 0 $X=796080 $Y=940980
X121 400 3291 3557 1 2 QDFFN $T=808480 1001840 1 180 $X=797940 $Y=1001460
X122 400 3506 3579 1 2 QDFFN $T=799180 941360 1 0 $X=799180 $Y=935940
X123 400 3478 3567 1 2 QDFFN $T=799800 921200 0 0 $X=799800 $Y=920820
X124 342 3478 3598 1 2 QDFFN $T=800420 971600 1 0 $X=800420 $Y=966180
X125 400 355 3578 1 2 QDFFN $T=800420 1062320 0 0 $X=800420 $Y=1061940
X126 410 343 3577 1 2 QDFFN $T=813440 1052240 0 180 $X=802900 $Y=1046820
X127 408 3395 3627 1 2 QDFFN $T=803520 1011920 0 0 $X=803520 $Y=1011540
X128 400 3390 3600 1 2 QDFFN $T=819020 911120 0 180 $X=808480 $Y=905700
X129 400 3523 3590 1 2 QDFFN $T=820880 921200 1 180 $X=810340 $Y=920820
X130 3610 3478 3637 1 2 QDFFN $T=810340 961520 1 0 $X=810340 $Y=956100
X131 410 346 3608 1 2 QDFFN $T=821500 1062320 1 180 $X=810960 $Y=1061940
X132 410 3395 3647 1 2 QDFFN $T=811580 1001840 0 0 $X=811580 $Y=1001460
X133 400 3383 3614 1 2 QDFFN $T=822740 951440 0 180 $X=812200 $Y=946020
X134 3610 3390 3651 1 2 QDFFN $T=812200 951440 0 0 $X=812200 $Y=951060
X135 3610 3506 3648 1 2 QDFFN $T=812200 971600 0 0 $X=812200 $Y=971220
X136 408 3291 3619 1 2 QDFFN $T=822740 1011920 0 180 $X=812200 $Y=1006500
X137 3610 3376 3666 1 2 QDFFN $T=812820 981680 0 0 $X=812820 $Y=981300
X138 408 3523 3664 1 2 QDFFN $T=814060 921200 1 0 $X=814060 $Y=915780
X139 3610 3523 3659 1 2 QDFFN $T=814060 981680 1 0 $X=814060 $Y=976260
X140 410 3278 3628 1 2 QDFFN $T=826460 1032080 0 180 $X=815920 $Y=1026660
X141 3610 346 3689 1 2 QDFFN $T=815920 1052240 1 0 $X=815920 $Y=1046820
X142 3610 365 3693 1 2 QDFFN $T=816540 1052240 0 0 $X=816540 $Y=1051860
X143 410 3347 3692 1 2 QDFFN $T=817160 991760 0 0 $X=817160 $Y=991380
X144 410 3282 3640 1 2 QDFFN $T=830180 1042160 0 180 $X=819640 $Y=1036740
X145 410 3291 3641 1 2 QDFFN $T=830800 1011920 1 180 $X=820260 $Y=1011540
X146 410 3390 3656 1 2 QDFFN $T=831420 911120 0 180 $X=820880 $Y=905700
X147 433 355 431 1 2 QDFFN $T=832040 1062320 1 180 $X=821500 $Y=1061940
X148 442 3390 3663 1 2 QDFFN $T=832660 941360 0 180 $X=822120 $Y=935940
X149 433 3362 3718 1 2 QDFFN $T=823980 951440 0 0 $X=823980 $Y=951060
X150 3610 3362 3658 1 2 QDFFN $T=835140 961520 0 180 $X=824600 $Y=956100
X151 433 3523 3710 1 2 QDFFN $T=824600 971600 0 0 $X=824600 $Y=971220
X152 3610 3291 3675 1 2 QDFFN $T=835140 1011920 0 180 $X=824600 $Y=1006500
X153 410 365 3654 1 2 QDFFN $T=835760 1062320 0 180 $X=825220 $Y=1056900
X154 3610 3383 3676 1 2 QDFFN $T=836380 981680 1 180 $X=825840 $Y=981300
X155 433 3376 3723 1 2 QDFFN $T=828320 981680 1 0 $X=828320 $Y=976260
X156 408 3362 3691 1 2 QDFFN $T=839480 921200 0 180 $X=828940 $Y=915780
X157 3610 3395 3682 1 2 QDFFN $T=840100 1022000 1 180 $X=829560 $Y=1021620
X158 433 3390 3725 1 2 QDFFN $T=831420 941360 0 0 $X=831420 $Y=940980
X159 408 3390 3737 1 2 QDFFN $T=833280 911120 1 0 $X=833280 $Y=905700
X160 408 3506 3698 1 2 QDFFN $T=845680 931280 0 180 $X=835140 $Y=925860
X161 3610 355 3702 1 2 QDFFN $T=845680 1052240 1 180 $X=835140 $Y=1051860
X162 433 365 443 1 2 QDFFN $T=845680 1062320 1 180 $X=835140 $Y=1061940
X163 433 3347 3721 1 2 QDFFN $T=846300 991760 1 180 $X=835760 $Y=991380
X164 433 3282 3744 1 2 QDFFN $T=835760 1032080 1 0 $X=835760 $Y=1026660
X165 433 3291 3720 1 2 QDFFN $T=846920 1001840 1 180 $X=836380 $Y=1001460
X166 433 3383 3749 1 2 QDFFN $T=837620 981680 0 0 $X=837620 $Y=981300
X167 433 3395 3724 1 2 QDFFN $T=848160 1011920 0 180 $X=837620 $Y=1006500
X168 433 3506 3722 1 2 QDFFN $T=849400 981680 0 180 $X=838860 $Y=976260
X169 3610 343 3706 1 2 QDFFN $T=849400 1052240 0 180 $X=838860 $Y=1046820
X170 446 3506 3732 1 2 QDFFN $T=850020 921200 0 180 $X=839480 $Y=915780
X171 442 3347 3752 1 2 QDFFN $T=839480 1001840 1 0 $X=839480 $Y=996420
X172 433 3478 3730 1 2 QDFFN $T=840100 961520 0 0 $X=840100 $Y=961140
X173 3734 3395 3784 1 2 QDFFN $T=840720 1022000 1 0 $X=840720 $Y=1016580
X174 410 3523 3761 1 2 QDFFN $T=841960 911120 0 0 $X=841960 $Y=910740
X175 442 3362 3729 1 2 QDFFN $T=852500 941360 1 180 $X=841960 $Y=940980
X176 442 3478 3762 1 2 QDFFN $T=841960 951440 0 0 $X=841960 $Y=951060
X177 442 3395 3755 1 2 QDFFN $T=842580 1022000 0 0 $X=842580 $Y=1021620
X178 442 355 3764 1 2 QDFFN $T=843200 1062320 1 0 $X=843200 $Y=1056900
X179 408 3383 3733 1 2 QDFFN $T=856220 931280 0 180 $X=845680 $Y=925860
X180 442 3376 3780 1 2 QDFFN $T=848160 991760 1 0 $X=848160 $Y=986340
X181 3734 343 3801 1 2 QDFFN $T=848160 1052240 0 0 $X=848160 $Y=1051860
X182 442 3291 3754 1 2 QDFFN $T=860560 1011920 0 180 $X=850020 $Y=1006500
X183 442 3523 3756 1 2 QDFFN $T=861180 971600 1 180 $X=850640 $Y=971220
X184 442 3383 3757 1 2 QDFFN $T=861180 981680 1 180 $X=850640 $Y=981300
X185 442 3278 3759 1 2 QDFFN $T=862420 1052240 0 180 $X=851880 $Y=1046820
X186 446 3478 3769 1 2 QDFFN $T=863040 911120 1 180 $X=852500 $Y=910740
X187 3734 3506 3766 1 2 QDFFN $T=863040 941360 1 180 $X=852500 $Y=940980
X188 442 3506 3767 1 2 QDFFN $T=863040 951440 1 180 $X=852500 $Y=951060
X189 3734 3291 3802 1 2 QDFFN $T=853740 1011920 0 0 $X=853740 $Y=1011540
X190 3734 3347 3818 1 2 QDFFN $T=854360 1001840 1 0 $X=854360 $Y=996420
X191 3734 3390 3798 1 2 QDFFN $T=855600 941360 1 0 $X=855600 $Y=935940
X192 3734 3282 3808 1 2 QDFFN $T=856220 1032080 1 0 $X=856220 $Y=1026660
X193 3734 365 3783 1 2 QDFFN $T=868620 1062320 1 180 $X=858080 $Y=1061940
X194 3734 3523 3790 1 2 QDFFN $T=870480 971600 0 180 $X=859940 $Y=966180
X195 3734 3478 3776 1 2 QDFFN $T=873580 961520 0 180 $X=863040 $Y=956100
X196 3734 3278 3803 1 2 QDFFN $T=873580 1042160 0 180 $X=863040 $Y=1036740
X197 446 3291 3831 1 2 QDFFN $T=863660 1011920 1 0 $X=863660 $Y=1006500
X198 3734 3383 3800 1 2 QDFFN $T=875440 981680 0 180 $X=864900 $Y=976260
X199 446 3282 3838 1 2 QDFFN $T=865520 1052240 1 0 $X=865520 $Y=1046820
X200 3734 355 3788 1 2 QDFFN $T=876060 1062320 0 180 $X=865520 $Y=1056900
X201 446 3376 3817 1 2 QDFFN $T=876680 941360 0 180 $X=866140 $Y=935940
X202 453 3506 3828 1 2 QDFFN $T=866140 951440 1 0 $X=866140 $Y=946020
X203 446 3278 3849 1 2 QDFFN $T=867380 1032080 0 0 $X=867380 $Y=1031700
X204 3734 346 3815 1 2 QDFFN $T=878540 1052240 1 180 $X=868000 $Y=1051860
X205 446 3390 3843 1 2 QDFFN $T=871100 921200 1 0 $X=871100 $Y=915780
X206 453 355 3858 1 2 QDFFN $T=871720 1062320 0 0 $X=871720 $Y=1061940
X207 453 3383 3883 1 2 QDFFN $T=872960 971600 0 0 $X=872960 $Y=971220
X208 446 3395 3826 1 2 QDFFN $T=883500 1022000 0 180 $X=872960 $Y=1016580
X209 453 3523 3833 1 2 QDFFN $T=884120 961520 1 180 $X=873580 $Y=961140
X210 453 3347 3864 1 2 QDFFN $T=873580 1001840 0 0 $X=873580 $Y=1001460
X211 453 3395 3881 1 2 QDFFN $T=875440 1011920 0 0 $X=875440 $Y=1011540
X212 453 3282 3859 1 2 QDFFN $T=876060 1042160 1 0 $X=876060 $Y=1036740
X213 453 3376 3876 1 2 QDFFN $T=876680 981680 0 0 $X=876680 $Y=981300
X214 453 3291 3877 1 2 QDFFN $T=876680 1011920 1 0 $X=876680 $Y=1006500
X215 453 3362 3887 1 2 QDFFN $T=877300 941360 0 0 $X=877300 $Y=940980
X216 453 3478 3823 1 2 QDFFN $T=887840 951440 1 180 $X=877300 $Y=951060
X217 453 343 3875 1 2 QDFFN $T=877920 1062320 1 0 $X=877920 $Y=1056900
X218 453 346 3885 1 2 QDFFN $T=878540 1042160 0 0 $X=878540 $Y=1041780
X219 459 3376 3891 1 2 QDFFN $T=879780 931280 0 0 $X=879780 $Y=930900
X220 453 3278 3853 1 2 QDFFN $T=890320 1032080 0 180 $X=879780 $Y=1026660
X221 446 3362 3835 1 2 QDFFN $T=891560 921200 1 180 $X=881020 $Y=920820
X222 462 3376 3908 1 2 QDFFN $T=881640 991760 1 0 $X=881640 $Y=986340
X223 459 3362 3879 1 2 QDFFN $T=896520 911120 1 180 $X=885980 $Y=910740
X224 462 3523 3919 1 2 QDFFN $T=886600 971600 1 0 $X=886600 $Y=966180
X225 462 3282 3912 1 2 QDFFN $T=886600 1032080 0 0 $X=886600 $Y=1031700
X226 462 3395 3884 1 2 QDFFN $T=897760 1001840 1 180 $X=887220 $Y=1001460
X227 459 3390 3918 1 2 QDFFN $T=887840 931280 1 0 $X=887840 $Y=925860
X228 462 3291 3915 1 2 QDFFN $T=888460 1011920 0 0 $X=888460 $Y=1011540
X229 462 3278 3921 1 2 QDFFN $T=889080 1042160 1 0 $X=889080 $Y=1036740
X230 462 343 3917 1 2 QDFFN $T=889700 1052240 0 0 $X=889700 $Y=1051860
X231 462 3478 3930 1 2 QDFFN $T=890940 961520 1 0 $X=890940 $Y=956100
X232 462 3383 3901 1 2 QDFFN $T=904580 981680 0 180 $X=894040 $Y=976260
X233 459 3347 3936 1 2 QDFFN $T=894660 991760 0 0 $X=894660 $Y=991380
X234 462 3347 3906 1 2 QDFFN $T=894660 1001840 1 0 $X=894660 $Y=996420
X235 459 3395 3932 1 2 QDFFN $T=896520 1011920 1 0 $X=896520 $Y=1006500
X236 459 3478 3957 1 2 QDFFN $T=897140 921200 0 0 $X=897140 $Y=920820
X237 459 3523 3940 1 2 QDFFN $T=897760 911120 0 0 $X=897760 $Y=910740
X238 462 365 3911 1 2 QDFFN $T=897760 1062320 1 0 $X=897760 $Y=1056900
X239 462 3362 3910 1 2 QDFFN $T=898380 951440 1 0 $X=898380 $Y=946020
X240 462 346 3945 1 2 QDFFN $T=899000 1042160 0 0 $X=899000 $Y=1041780
X241 459 3282 3926 1 2 QDFFN $T=900240 1032080 0 0 $X=900240 $Y=1031700
X242 459 3278 3947 1 2 QDFFN $T=900860 1022000 0 0 $X=900860 $Y=1021620
X243 459 3383 3924 1 2 QDFFN $T=901480 931280 0 0 $X=901480 $Y=930900
X244 462 3506 3927 1 2 QDFFN $T=903340 971600 1 0 $X=903340 $Y=966180
X245 459 3506 3962 1 2 QDFFN $T=906440 931280 1 0 $X=906440 $Y=925860
X246 459 3291 3938 1 2 QDFFN $T=907680 1011920 0 0 $X=907680 $Y=1011540
X247 486 4000 3970 1 2 QDFFN $T=928140 971600 0 180 $X=917600 $Y=966180
X248 477 487 480 1 2 QDFFN $T=928760 880880 1 180 $X=918220 $Y=880500
X249 3981 4006 3980 1 2 QDFFN $T=929380 921200 1 180 $X=918840 $Y=920820
X250 3981 484 4016 1 2 QDFFN $T=919460 1042160 0 0 $X=919460 $Y=1041780
X251 486 4010 3989 1 2 QDFFN $T=930620 1011920 0 180 $X=920080 $Y=1006500
X252 486 3956 3982 1 2 QDFFN $T=930620 1011920 1 180 $X=920080 $Y=1011540
X253 486 3975 3987 1 2 QDFFN $T=930620 1032080 1 180 $X=920080 $Y=1031700
X254 493 492 3992 1 2 QDFFN $T=932480 1062320 1 180 $X=921940 $Y=1061940
X255 486 4019 3993 1 2 QDFFN $T=933100 981680 1 180 $X=922560 $Y=981300
X256 493 4006 3996 1 2 QDFFN $T=934340 961520 0 180 $X=923800 $Y=956100
X257 493 4000 3998 1 2 QDFFN $T=934960 931280 1 180 $X=924420 $Y=930900
X258 3981 3975 4041 1 2 QDFFN $T=924420 1032080 1 0 $X=924420 $Y=1026660
X259 486 4037 4009 1 2 QDFFN $T=938060 1042160 0 180 $X=927520 $Y=1036740
X260 3981 492 4024 1 2 QDFFN $T=927520 1062320 1 0 $X=927520 $Y=1056900
X261 3981 4000 4011 1 2 QDFFN $T=938680 911120 1 180 $X=928140 $Y=910740
X262 486 4043 4007 1 2 QDFFN $T=938680 981680 0 180 $X=928140 $Y=976260
X263 3981 4051 4015 1 2 QDFFN $T=939920 901040 1 180 $X=929380 $Y=900660
X264 493 4043 4014 1 2 QDFFN $T=939920 941360 1 180 $X=929380 $Y=940980
X265 493 4010 4063 1 2 QDFFN $T=930620 1001840 1 0 $X=930620 $Y=996420
X266 493 3956 4023 1 2 QDFFN $T=941160 1011920 0 180 $X=930620 $Y=1006500
X267 486 4073 4031 1 2 QDFFN $T=943640 981680 1 180 $X=933100 $Y=981300
X268 493 4019 4097 1 2 QDFFN $T=933100 991760 0 0 $X=933100 $Y=991380
X269 486 4006 4059 1 2 QDFFN $T=934340 961520 0 0 $X=934340 $Y=961140
X270 3981 4043 4029 1 2 QDFFN $T=946120 921200 1 180 $X=935580 $Y=920820
X271 493 3975 4101 1 2 QDFFN $T=937440 1032080 1 0 $X=937440 $Y=1026660
X272 486 4051 4032 1 2 QDFFN $T=949220 951440 1 180 $X=938680 $Y=951060
X273 493 4037 4105 1 2 QDFFN $T=939920 1042160 1 0 $X=939920 $Y=1036740
X274 3981 506 4070 1 2 QDFFN $T=950460 1052240 0 180 $X=939920 $Y=1046820
X275 4075 4010 4108 1 2 QDFFN $T=941160 1011920 0 0 $X=941160 $Y=1011540
X276 3981 3956 4120 1 2 QDFFN $T=942400 1001840 0 0 $X=942400 $Y=1001460
X277 4075 492 4036 1 2 QDFFN $T=952940 1062320 0 180 $X=942400 $Y=1056900
X278 3981 4010 4115 1 2 QDFFN $T=943640 1001840 1 0 $X=943640 $Y=996420
X279 493 4051 4085 1 2 QDFFN $T=954800 941360 1 180 $X=944260 $Y=940980
X280 493 4073 4095 1 2 QDFFN $T=955420 961520 1 180 $X=944880 $Y=961140
X281 3981 507 4092 1 2 QDFFN $T=955420 1062320 1 180 $X=944880 $Y=1061940
X282 4075 4103 4130 1 2 QDFFN $T=946120 911120 1 0 $X=946120 $Y=905700
X283 4075 4006 4124 1 2 QDFFN $T=946120 921200 0 0 $X=946120 $Y=920820
X284 493 4107 4119 1 2 QDFFN $T=947980 981680 0 0 $X=947980 $Y=981300
X285 3981 4019 4102 1 2 QDFFN $T=958520 991760 0 180 $X=947980 $Y=986340
X286 3981 4037 4098 1 2 QDFFN $T=958520 1022000 0 180 $X=947980 $Y=1016580
X287 486 4107 4082 1 2 QDFFN $T=959140 981680 0 180 $X=948600 $Y=976260
X288 3981 4103 4100 1 2 QDFFN $T=959760 921200 0 180 $X=949220 $Y=915780
X289 4075 484 4049 1 2 QDFFN $T=961000 1052240 0 180 $X=950460 $Y=1046820
X290 493 4103 4091 1 2 QDFFN $T=962860 951440 1 180 $X=952320 $Y=951060
X291 493 506 4087 1 2 QDFFN $T=963480 1062320 0 180 $X=952940 $Y=1056900
X292 4075 4043 4140 1 2 QDFFN $T=954180 931280 1 0 $X=954180 $Y=925860
X293 4075 4037 4123 1 2 QDFFN $T=954800 1032080 1 0 $X=954800 $Y=1026660
X294 486 4103 4035 1 2 QDFFN $T=955420 961520 0 0 $X=955420 $Y=961140
X295 509 3956 4147 1 2 QDFFN $T=955420 1011920 1 0 $X=955420 $Y=1006500
X296 509 4043 4153 1 2 QDFFN $T=956040 971600 0 0 $X=956040 $Y=971220
X297 4075 4073 4139 1 2 QDFFN $T=956660 941360 0 0 $X=956660 $Y=940980
X298 509 4010 4152 1 2 QDFFN $T=956660 1001840 1 0 $X=956660 $Y=996420
X299 4075 4051 4128 1 2 QDFFN $T=967820 901040 1 180 $X=957280 $Y=900660
X300 509 4073 4168 1 2 QDFFN $T=959140 981680 1 0 $X=959140 $Y=976260
X301 4075 4000 4136 1 2 QDFFN $T=971540 921200 0 180 $X=961000 $Y=915780
X302 509 4006 4169 1 2 QDFFN $T=961000 971600 1 0 $X=961000 $Y=966180
X303 4075 506 4160 1 2 QDFFN $T=961000 1052240 1 0 $X=961000 $Y=1046820
X304 4075 4019 4137 1 2 QDFFN $T=972780 991760 0 180 $X=962240 $Y=986340
X305 4075 507 4156 1 2 QDFFN $T=963480 1052240 0 0 $X=963480 $Y=1051860
X306 514 506 4178 1 2 QDFFN $T=963480 1062320 0 0 $X=963480 $Y=1061940
X307 509 4103 4175 1 2 QDFFN $T=964100 951440 0 0 $X=964100 $Y=951060
X308 509 3975 4145 1 2 QDFFN $T=974640 1022000 0 180 $X=964100 $Y=1016580
X309 509 4037 4148 1 2 QDFFN $T=975880 1032080 0 180 $X=965340 $Y=1026660
X310 4127 4103 4188 1 2 QDFFN $T=965960 911120 1 0 $X=965960 $Y=905700
X311 4127 4006 4154 1 2 QDFFN $T=977120 931280 1 180 $X=966580 $Y=930900
X312 509 4019 4161 1 2 QDFFN $T=979600 1001840 0 180 $X=969060 $Y=996420
X313 509 4000 4192 1 2 QDFFN $T=969680 961520 1 0 $X=969680 $Y=956100
X314 4127 506 4193 1 2 QDFFN $T=971540 1042160 0 0 $X=971540 $Y=1041780
X315 4127 3956 4184 1 2 QDFFN $T=972780 1001840 0 0 $X=972780 $Y=1001460
X316 4127 4000 4166 1 2 QDFFN $T=984560 921200 0 180 $X=974020 $Y=915780
X317 4127 4051 4202 1 2 QDFFN $T=974640 901040 0 0 $X=974640 $Y=900660
X318 4127 4107 4217 1 2 QDFFN $T=974640 941360 1 0 $X=974640 $Y=935940
X319 509 4107 4177 1 2 QDFFN $T=985180 981680 1 180 $X=974640 $Y=981300
X320 514 4043 4203 1 2 QDFFN $T=975260 971600 0 0 $X=975260 $Y=971220
X321 4127 4019 4211 1 2 QDFFN $T=975260 991760 1 0 $X=975260 $Y=986340
X322 514 4037 4209 1 2 QDFFN $T=975880 1022000 0 0 $X=975880 $Y=1021620
X323 4127 4010 4180 1 2 QDFFN $T=976500 1011920 0 0 $X=976500 $Y=1011540
X324 4075 4107 4144 1 2 QDFFN $T=987660 931280 1 180 $X=977120 $Y=930900
X325 514 4006 4195 1 2 QDFFN $T=992000 961520 0 180 $X=981460 $Y=956100
X326 4127 492 4187 1 2 QDFFN $T=992000 1062320 0 180 $X=981460 $Y=1056900
X327 4127 4037 4190 1 2 QDFFN $T=992620 1042160 0 180 $X=982080 $Y=1036740
X328 4127 4043 4174 1 2 QDFFN $T=993860 931280 0 180 $X=983320 $Y=925860
X329 4075 3956 4142 1 2 QDFFN $T=983320 1011920 1 0 $X=983320 $Y=1006500
X330 514 4019 4227 1 2 QDFFN $T=983940 1001840 1 0 $X=983940 $Y=996420
X331 509 4051 4208 1 2 QDFFN $T=984560 951440 1 0 $X=984560 $Y=946020
X332 4206 4010 4232 1 2 QDFFN $T=984560 1022000 1 0 $X=984560 $Y=1016580
X333 514 492 533 1 2 QDFFN $T=984560 1062320 0 0 $X=984560 $Y=1061940
X334 4206 4006 4238 1 2 QDFFN $T=985180 921200 0 0 $X=985180 $Y=920820
X335 514 3956 4230 1 2 QDFFN $T=985180 1001840 0 0 $X=985180 $Y=1001460
X336 4127 484 4198 1 2 QDFFN $T=995720 1052240 0 180 $X=985180 $Y=1046820
X337 514 4051 4234 1 2 QDFFN $T=985800 951440 0 0 $X=985800 $Y=951060
X338 4206 4000 4235 1 2 QDFFN $T=987040 921200 1 0 $X=987040 $Y=915780
X339 514 4073 4218 1 2 QDFFN $T=997580 981680 0 180 $X=987040 $Y=976260
X340 514 4107 4215 1 2 QDFFN $T=997580 981680 1 180 $X=987040 $Y=981300
X341 522 535 528 1 2 QDFFN $T=998200 880880 1 180 $X=987660 $Y=880500
X342 4206 4051 4239 1 2 QDFFN $T=988280 911120 1 0 $X=988280 $Y=905700
X343 4127 4073 4221 1 2 QDFFN $T=998820 941360 1 180 $X=988280 $Y=940980
X344 514 4000 4219 1 2 QDFFN $T=1001300 971600 0 180 $X=990760 $Y=966180
X345 4206 4073 4243 1 2 QDFFN $T=991380 931280 0 0 $X=991380 $Y=930900
X346 514 3975 4223 1 2 QDFFN $T=1001920 1032080 0 180 $X=991380 $Y=1026660
X347 4206 3975 4253 1 2 QDFFN $T=992620 1042160 1 0 $X=992620 $Y=1036740
X348 534 3975 4255 1 2 QDFFN $T=993860 1022000 0 0 $X=993860 $Y=1021620
X349 4206 484 4256 1 2 QDFFN $T=993860 1052240 0 0 $X=993860 $Y=1051860
X350 4127 507 4207 1 2 QDFFN $T=994480 1062320 1 0 $X=994480 $Y=1056900
X351 4206 4043 4248 1 2 QDFFN $T=995720 931280 1 0 $X=995720 $Y=925860
X352 514 4103 4236 1 2 QDFFN $T=1006880 951440 0 180 $X=996340 $Y=946020
X353 534 4019 4264 1 2 QDFFN $T=996340 991760 0 0 $X=996340 $Y=991380
X354 534 3956 4272 1 2 QDFFN $T=996340 1001840 1 0 $X=996340 $Y=996420
X355 514 4010 4237 1 2 QDFFN $T=1006880 1011920 0 180 $X=996340 $Y=1006500
X356 534 4010 4274 1 2 QDFFN $T=996960 1001840 0 0 $X=996960 $Y=1001460
X357 534 4043 4266 1 2 QDFFN $T=997580 971600 0 0 $X=997580 $Y=971220
X358 4206 3956 4240 1 2 QDFFN $T=1008740 1011920 1 180 $X=998200 $Y=1011540
X359 534 4051 4271 1 2 QDFFN $T=998820 951440 0 0 $X=998820 $Y=951060
X360 4206 492 4268 1 2 QDFFN $T=998820 1062320 0 0 $X=998820 $Y=1061940
X361 4206 4103 4242 1 2 QDFFN $T=1010600 921200 0 180 $X=1000060 $Y=915780
X362 534 4000 4244 1 2 QDFFN $T=1010600 961520 0 180 $X=1000060 $Y=956100
X363 4206 4019 4245 1 2 QDFFN $T=1010600 981680 0 180 $X=1000060 $Y=976260
X364 4206 4037 4261 1 2 QDFFN $T=1014940 1042160 0 180 $X=1004400 $Y=1036740
X365 534 4107 4284 1 2 QDFFN $T=1005640 991760 1 0 $X=1005640 $Y=986340
X366 537 4103 4293 1 2 QDFFN $T=1006880 911120 1 0 $X=1006880 $Y=905700
X367 537 4073 4294 1 2 QDFFN $T=1006880 931280 0 0 $X=1006880 $Y=930900
X368 534 4103 4279 1 2 QDFFN $T=1006880 951440 1 0 $X=1006880 $Y=946020
X369 4206 506 4259 1 2 QDFFN $T=1017420 1042160 1 180 $X=1006880 $Y=1041780
X370 537 4043 4300 1 2 QDFFN $T=1008120 931280 1 0 $X=1008120 $Y=925860
X371 534 4037 4270 1 2 QDFFN $T=1019280 1032080 0 180 $X=1008740 $Y=1026660
X372 537 4010 4304 1 2 QDFFN $T=1009360 1001840 1 0 $X=1009360 $Y=996420
X373 537 3956 4296 1 2 QDFFN $T=1009360 1001840 0 0 $X=1009360 $Y=1001460
X374 534 4006 4265 1 2 QDFFN $T=1021760 961520 1 180 $X=1011220 $Y=961140
X375 537 4037 4299 1 2 QDFFN $T=1011840 1022000 0 0 $X=1011840 $Y=1021620
X376 537 4006 4325 1 2 QDFFN $T=1012460 921200 0 0 $X=1012460 $Y=920820
X377 537 484 4280 1 2 QDFFN $T=1023000 1062320 1 180 $X=1012460 $Y=1061940
X378 537 4000 4313 1 2 QDFFN $T=1013080 921200 1 0 $X=1013080 $Y=915780
X379 534 4073 4282 1 2 QDFFN $T=1024240 981680 0 180 $X=1013700 $Y=976260
X380 537 4019 4314 1 2 QDFFN $T=1015560 991760 0 0 $X=1015560 $Y=991380
X381 537 3975 4315 1 2 QDFFN $T=1016800 1042160 1 0 $X=1016800 $Y=1036740
X382 4292 506 4320 1 2 QDFFN $T=1017420 1042160 0 0 $X=1017420 $Y=1041780
X383 4292 4051 4323 1 2 QDFFN $T=1018040 951440 0 0 $X=1018040 $Y=951060
X384 4292 4043 4328 1 2 QDFFN $T=1018040 971600 0 0 $X=1018040 $Y=971220
X385 4292 4000 4317 1 2 QDFFN $T=1018660 971600 1 0 $X=1018660 $Y=966180
X386 4292 507 4327 1 2 QDFFN $T=1018660 1052240 0 0 $X=1018660 $Y=1051860
X387 542 4073 4356 1 2 QDFFN $T=1019280 951440 1 0 $X=1019280 $Y=946020
X388 537 4051 4312 1 2 QDFFN $T=1020520 901040 0 0 $X=1020520 $Y=900660
X389 542 4037 4347 1 2 QDFFN $T=1020520 1032080 0 0 $X=1020520 $Y=1031700
X390 4292 4010 4308 1 2 QDFFN $T=1032300 1001840 0 180 $X=1021760 $Y=996420
X391 4292 3956 4309 1 2 QDFFN $T=1032300 1011920 0 180 $X=1021760 $Y=1006500
X392 542 506 4343 1 2 QDFFN $T=1021760 1062320 1 0 $X=1021760 $Y=1056900
X393 542 4107 4335 1 2 QDFFN $T=1022380 941360 1 0 $X=1022380 $Y=935940
X394 4292 3975 4346 1 2 QDFFN $T=1024240 1022000 0 0 $X=1024240 $Y=1021620
X395 542 4043 4355 1 2 QDFFN $T=1024860 931280 0 0 $X=1024860 $Y=930900
X396 4292 4019 4318 1 2 QDFFN $T=1035400 991760 0 180 $X=1024860 $Y=986340
X397 542 4103 4358 1 2 QDFFN $T=1025480 911120 1 0 $X=1025480 $Y=905700
X398 542 4000 4344 1 2 QDFFN $T=1026720 911120 0 0 $X=1026720 $Y=910740
X399 542 4006 4349 1 2 QDFFN $T=1026720 931280 1 0 $X=1026720 $Y=925860
X400 4292 4107 4353 1 2 QDFFN $T=1026720 981680 1 0 $X=1026720 $Y=976260
X401 4292 4103 4331 1 2 QDFFN $T=1039740 951440 1 180 $X=1029200 $Y=951060
X402 542 3956 4359 1 2 QDFFN $T=1029200 1022000 1 0 $X=1029200 $Y=1016580
X403 542 3975 4350 1 2 QDFFN $T=1031060 1042160 1 0 $X=1031060 $Y=1036740
X404 4292 492 4361 1 2 QDFFN $T=1031680 1052240 1 0 $X=1031680 $Y=1046820
X405 531 4107 4388 1 2 QDFFN $T=1034160 941360 0 0 $X=1034160 $Y=940980
X406 542 4019 4375 1 2 QDFFN $T=1034160 1001840 1 0 $X=1034160 $Y=996420
X407 542 4010 4348 1 2 QDFFN $T=1034160 1001840 0 0 $X=1034160 $Y=1001460
X408 542 4051 4374 1 2 QDFFN $T=1034780 901040 0 0 $X=1034780 $Y=900660
X409 542 492 4377 1 2 QDFFN $T=1034780 1052240 0 0 $X=1034780 $Y=1051860
X410 4292 4006 4324 1 2 QDFFN $T=1046560 961520 1 180 $X=1036020 $Y=961140
X411 4292 4073 4338 1 2 QDFFN $T=1046560 971600 1 180 $X=1036020 $Y=971220
X412 4362 4073 4398 1 2 QDFFN $T=1037880 971600 1 0 $X=1037880 $Y=966180
X413 531 4019 4389 1 2 QDFFN $T=1037880 981680 0 0 $X=1037880 $Y=981300
X414 531 4043 4383 1 2 QDFFN $T=1038500 931280 0 0 $X=1038500 $Y=930900
X415 4362 4103 4401 1 2 QDFFN $T=1039120 961520 1 0 $X=1039120 $Y=956100
X416 531 3956 4394 1 2 QDFFN $T=1039120 1011920 1 0 $X=1039120 $Y=1006500
X417 531 4000 4371 1 2 QDFFN $T=1050900 911120 1 180 $X=1040360 $Y=910740
X418 531 4037 4405 1 2 QDFFN $T=1040980 1032080 1 0 $X=1040980 $Y=1026660
X419 4292 484 4370 1 2 QDFFN $T=1052760 1042160 1 180 $X=1042220 $Y=1041780
X420 531 4103 4413 1 2 QDFFN $T=1042840 911120 1 0 $X=1042840 $Y=905700
X421 531 3975 4404 1 2 QDFFN $T=1042840 1022000 0 0 $X=1042840 $Y=1021620
X422 4292 4037 4360 1 2 QDFFN $T=1054620 1032080 1 180 $X=1044080 $Y=1031700
X423 4362 507 4408 1 2 QDFFN $T=1044700 1052240 1 0 $X=1044700 $Y=1046820
X424 531 4010 4406 1 2 QDFFN $T=1045940 1001840 1 0 $X=1045940 $Y=996420
X425 4362 3956 4410 1 2 QDFFN $T=1045940 1011920 0 0 $X=1045940 $Y=1011540
X426 553 535 558 1 2 QDFFN $T=1046560 890960 1 0 $X=1046560 $Y=885540
X427 555 4107 4416 1 2 QDFFN $T=1047800 941360 0 0 $X=1047800 $Y=940980
X428 4362 4051 4393 1 2 QDFFN $T=1058340 951440 0 180 $X=1047800 $Y=946020
X429 4362 4107 4391 1 2 QDFFN $T=1058340 981680 0 180 $X=1047800 $Y=976260
X430 4392 507 4419 1 2 QDFFN $T=1048420 1052240 0 0 $X=1048420 $Y=1051860
X431 531 4051 4422 1 2 QDFFN $T=1049660 901040 0 0 $X=1049660 $Y=900660
X432 531 4006 4378 1 2 QDFFN $T=1060200 921200 1 180 $X=1049660 $Y=920820
X433 4362 4019 4423 1 2 QDFFN $T=1049660 991760 0 0 $X=1049660 $Y=991380
X434 531 4073 4379 1 2 QDFFN $T=1060820 941360 0 180 $X=1050280 $Y=935940
X435 4392 4107 4439 1 2 QDFFN $T=1051520 931280 1 0 $X=1051520 $Y=925860
X436 554 4107 4428 1 2 QDFFN $T=1051520 991760 1 0 $X=1051520 $Y=986340
X437 4392 506 4436 1 2 QDFFN $T=1052760 1062320 0 0 $X=1052760 $Y=1061940
X438 4392 4051 4445 1 2 QDFFN $T=1054000 911120 0 0 $X=1054000 $Y=910740
X439 554 4103 4407 1 2 QDFFN $T=1066400 961520 1 180 $X=1055860 $Y=961140
X440 4362 3975 4412 1 2 QDFFN $T=1066400 1022000 1 180 $X=1055860 $Y=1021620
X441 4362 506 4435 1 2 QDFFN $T=1055860 1042160 0 0 $X=1055860 $Y=1041780
X442 4362 4037 4418 1 2 QDFFN $T=1067640 1032080 1 180 $X=1057100 $Y=1031700
X443 4362 4010 4420 1 2 QDFFN $T=1068260 1001840 1 180 $X=1057720 $Y=1001460
X444 554 4010 4457 1 2 QDFFN $T=1057720 1011920 1 0 $X=1057720 $Y=1006500
X445 554 4051 4411 1 2 QDFFN $T=1069500 951440 1 180 $X=1058960 $Y=951060
X446 554 4073 4414 1 2 QDFFN $T=1071360 981680 0 180 $X=1060820 $Y=976260
X447 560 535 562 1 2 QDFFN $T=1062060 890960 1 0 $X=1062060 $Y=885540
X448 555 4073 4430 1 2 QDFFN $T=1073220 951440 0 180 $X=1062680 $Y=946020
X449 4392 4073 4443 1 2 QDFFN $T=1073840 931280 1 180 $X=1063300 $Y=930900
X450 4362 4043 4444 1 2 QDFFN $T=1074460 971600 1 180 $X=1063920 $Y=971220
X451 555 4051 4450 1 2 QDFFN $T=1064540 901040 0 0 $X=1064540 $Y=900660
X452 555 4010 4479 1 2 QDFFN $T=1065160 1011920 0 0 $X=1065160 $Y=1011540
X453 560 561 566 1 2 QDFFN $T=1066400 880880 0 0 $X=1066400 $Y=880500
X454 4362 492 4482 1 2 QDFFN $T=1066400 1052240 1 0 $X=1066400 $Y=1046820
X455 4392 492 4470 1 2 QDFFN $T=1066400 1062320 0 0 $X=1066400 $Y=1061940
X456 4392 4103 4442 1 2 QDFFN $T=1078180 921200 0 180 $X=1067640 $Y=915780
X457 555 4103 4438 1 2 QDFFN $T=1079420 911120 0 180 $X=1068880 $Y=905700
X458 4362 4000 4455 1 2 QDFFN $T=1080040 961520 0 180 $X=1069500 $Y=956100
X459 4392 4010 4466 1 2 QDFFN $T=1069500 1001840 1 0 $X=1069500 $Y=996420
X460 4362 484 4489 1 2 QDFFN $T=1069500 1042160 0 0 $X=1069500 $Y=1041780
X461 4392 3975 4463 1 2 QDFFN $T=1080660 1032080 1 180 $X=1070120 $Y=1031700
X462 4392 4043 4465 1 2 QDFFN $T=1081900 931280 0 180 $X=1071360 $Y=925860
X463 4362 4006 4452 1 2 QDFFN $T=1083760 951440 1 180 $X=1073220 $Y=951060
X464 4392 4019 4449 1 2 QDFFN $T=1084380 981680 0 180 $X=1073840 $Y=976260
X465 565 535 570 1 2 QDFFN $T=1076320 890960 1 0 $X=1076320 $Y=885540
X466 554 3956 4490 1 2 QDFFN $T=1077560 1001840 0 0 $X=1077560 $Y=1001460
X467 555 4043 4471 1 2 QDFFN $T=1078180 951440 1 0 $X=1078180 $Y=946020
X468 554 4043 4472 1 2 QDFFN $T=1079420 971600 0 0 $X=1079420 $Y=971220
X469 555 4019 4491 1 2 QDFFN $T=1080660 991760 0 0 $X=1080660 $Y=991380
X470 4392 4000 4484 1 2 QDFFN $T=1081900 921200 1 0 $X=1081900 $Y=915780
X471 565 561 571 1 2 QDFFN $T=1082520 880880 0 0 $X=1082520 $Y=880500
X472 554 4019 4483 1 2 QDFFN $T=1082520 981680 0 0 $X=1082520 $Y=981300
X473 4392 4006 4476 1 2 QDFFN $T=1083140 921200 0 0 $X=1083140 $Y=920820
X474 555 4000 4492 1 2 QDFFN $T=1083140 931280 0 0 $X=1083140 $Y=930900
X475 555 4006 4477 1 2 QDFFN $T=1083140 941360 1 0 $X=1083140 $Y=935940
X476 554 4006 4478 1 2 QDFFN $T=1083140 961520 1 0 $X=1083140 $Y=956100
X477 554 4000 4485 1 2 QDFFN $T=1083140 971600 1 0 $X=1083140 $Y=966180
X478 4392 3956 4473 1 2 QDFFN $T=1083140 1001840 1 0 $X=1083140 $Y=996420
X479 555 3956 4488 1 2 QDFFN $T=1083140 1011920 0 0 $X=1083140 $Y=1011540
X480 555 3975 4486 1 2 QDFFN $T=1083140 1022000 1 0 $X=1083140 $Y=1016580
X481 554 3975 4493 1 2 QDFFN $T=1083140 1022000 0 0 $X=1083140 $Y=1021620
X482 554 4037 4481 1 2 QDFFN $T=1083140 1032080 0 0 $X=1083140 $Y=1031700
X483 555 4037 4480 1 2 QDFFN $T=1083140 1042160 1 0 $X=1083140 $Y=1036740
X484 4392 4037 4462 1 2 QDFFN $T=1083140 1042160 0 0 $X=1083140 $Y=1041780
X485 4392 484 4487 1 2 QDFFN $T=1083140 1052240 0 0 $X=1083140 $Y=1051860
X486 554 484 4494 1 2 QDFFN $T=1083140 1062320 1 0 $X=1083140 $Y=1056900
X487 2377 2400 2412 248 1 249 2 AOI22S $T=564820 951440 0 0 $X=564820 $Y=951060
X488 2324 2413 2420 248 1 249 2 AOI22S $T=566060 941360 1 0 $X=566060 $Y=935940
X489 2276 2435 2432 248 1 249 2 AOI22S $T=567920 931280 1 0 $X=567920 $Y=925860
X490 2335 2414 2433 248 1 249 2 AOI22S $T=567920 951440 1 0 $X=567920 $Y=946020
X491 2386 2415 2441 248 1 249 2 AOI22S $T=569780 951440 0 0 $X=569780 $Y=951060
X492 2434 2434 2446 248 1 249 2 AOI22S $T=571020 911120 0 0 $X=571020 $Y=910740
X493 2416 2409 2464 248 1 249 2 AOI22S $T=572880 971600 0 0 $X=572880 $Y=971220
X494 2364 2447 2467 248 1 249 2 AOI22S $T=573500 971600 1 0 $X=573500 $Y=966180
X495 2354 2439 2472 248 1 249 2 AOI22S $T=574740 911120 1 0 $X=574740 $Y=905700
X496 2354 2462 2474 248 1 249 2 AOI22S $T=574740 911120 0 0 $X=574740 $Y=910740
X497 250 2487 2480 248 1 249 2 AOI22S $T=576600 901040 0 0 $X=576600 $Y=900660
X498 2460 2444 2491 248 1 249 2 AOI22S $T=580320 991760 0 180 $X=576600 $Y=986340
X499 2387 2458 2485 248 1 249 2 AOI22S $T=577840 991760 0 0 $X=577840 $Y=991380
X500 2374 2486 2489 248 1 249 2 AOI22S $T=578460 890960 1 0 $X=578460 $Y=885540
X501 2512 2501 2513 248 1 249 2 AOI22S $T=582180 971600 0 180 $X=578460 $Y=966180
X502 258 259 2502 248 1 249 2 AOI22S $T=580320 880880 0 0 $X=580320 $Y=880500
X503 2500 2507 2496 260 1 261 2 AOI22S $T=580320 951440 0 0 $X=580320 $Y=951060
X504 2497 2517 2505 262 1 261 2 AOI22S $T=581560 901040 0 0 $X=581560 $Y=900660
X505 263 263 2493 248 1 249 2 AOI22S $T=583420 890960 1 0 $X=583420 $Y=885540
X506 265 266 2538 248 1 249 2 AOI22S $T=585280 880880 0 0 $X=585280 $Y=880500
X507 2552 2543 2534 260 1 261 2 AOI22S $T=589000 941360 0 180 $X=585280 $Y=935940
X508 2494 2537 2532 248 1 249 2 AOI22S $T=585900 991760 1 0 $X=585900 $Y=986340
X509 2568 2558 2551 260 1 261 2 AOI22S $T=592100 901040 1 180 $X=588380 $Y=900660
X510 2471 2549 2548 248 1 249 2 AOI22S $T=588380 991760 0 0 $X=588380 $Y=991380
X511 2570 2562 2481 262 1 261 2 AOI22S $T=592720 921200 1 180 $X=589000 $Y=920820
X512 2577 2575 2584 248 1 249 2 AOI22S $T=595200 991760 1 0 $X=595200 $Y=986340
X513 2610 2581 2591 260 1 261 2 AOI22S $T=600780 890960 0 180 $X=597060 $Y=885540
X514 2590 2603 2459 260 1 261 2 AOI22S $T=598300 941360 0 0 $X=598300 $Y=940980
X515 2587 2604 2504 262 1 261 2 AOI22S $T=598920 971600 1 0 $X=598920 $Y=966180
X516 2609 2612 2470 262 1 261 2 AOI22S $T=601400 951440 1 0 $X=601400 $Y=946020
X517 2634 2641 2639 248 1 249 2 AOI22S $T=605120 991760 1 0 $X=605120 $Y=986340
X518 2664 2652 2670 248 1 249 2 AOI22S $T=611320 981680 1 0 $X=611320 $Y=976260
X519 2698 2690 2626 260 1 261 2 AOI22S $T=617520 991760 0 180 $X=613800 $Y=986340
X520 2682 2688 2666 260 1 261 2 AOI22S $T=613800 991760 0 0 $X=613800 $Y=991380
X521 2681 2673 2718 248 1 249 2 AOI22S $T=620620 981680 1 180 $X=616900 $Y=981300
X522 2692 2725 2714 262 1 261 2 AOI22S $T=622480 971600 1 180 $X=618760 $Y=971220
X523 2681 2732 2729 248 1 249 2 AOI22S $T=620620 981680 0 0 $X=620620 $Y=981300
X524 2742 2772 2770 262 1 261 2 AOI22S $T=627440 1011920 0 0 $X=627440 $Y=1011540
X525 2862 2879 2858 260 1 261 2 AOI22S $T=649140 981680 0 0 $X=649140 $Y=981300
X526 2852 2894 2809 260 1 261 2 AOI22S $T=652240 1001840 1 0 $X=652240 $Y=996420
X527 2965 2934 2946 260 1 261 2 AOI22S $T=665880 991760 0 180 $X=662160 $Y=986340
X528 2917 2976 2966 2656 1 2984 2 AOI22S $T=666500 921200 0 0 $X=666500 $Y=920820
X529 2970 2929 2897 2984 1 2988 2 AOI22S $T=667120 931280 1 0 $X=667120 $Y=925860
X530 2959 2980 2967 2656 1 2984 2 AOI22S $T=667120 941360 0 0 $X=667120 $Y=940980
X531 2985 2979 2861 260 1 261 2 AOI22S $T=668980 971600 0 0 $X=668980 $Y=971220
X532 3005 311 2877 2984 1 2970 2 AOI22S $T=674560 931280 1 180 $X=670840 $Y=930900
X533 2977 2996 2997 2656 1 2984 2 AOI22S $T=674560 951440 1 180 $X=670840 $Y=951060
X534 2964 2999 2955 262 1 290 2 AOI22S $T=672080 890960 1 0 $X=672080 $Y=885540
X535 2996 2977 3009 2614 1 2711 2 AOI22S $T=676420 941360 1 180 $X=672700 $Y=940980
X536 2988 2976 3029 2984 1 2941 2 AOI22S $T=681380 931280 0 180 $X=677660 $Y=925860
X537 3005 2980 3022 2984 1 2941 2 AOI22S $T=682000 941360 0 180 $X=678280 $Y=935940
X538 3056 2988 3044 3048 1 3034 2 AOI22S $T=685100 931280 1 180 $X=681380 $Y=930900
X539 3057 3005 2992 3058 1 3034 2 AOI22S $T=686960 941360 1 180 $X=683240 $Y=940980
X540 2984 2656 3055 3068 1 2994 2 AOI22S $T=684480 921200 1 0 $X=684480 $Y=915780
X541 3057 2996 3011 3048 1 2928 2 AOI22S $T=684480 941360 1 0 $X=684480 $Y=935940
X542 3056 3068 3021 3048 1 2928 2 AOI22S $T=689440 931280 1 180 $X=685720 $Y=930900
X543 3084 3076 3063 260 1 261 2 AOI22S $T=691300 981680 0 180 $X=687580 $Y=976260
X544 3005 2996 3082 2614 1 2914 2 AOI22S $T=693160 941360 1 180 $X=689440 $Y=940980
X545 2914 2614 3090 3068 1 2988 2 AOI22S $T=692540 931280 0 0 $X=692540 $Y=930900
X546 3057 2977 3091 3100 1 3053 2 AOI22S $T=692540 951440 1 0 $X=692540 $Y=946020
X547 2914 2614 3085 2994 1 3068 2 AOI22S $T=693160 921200 0 0 $X=693160 $Y=920820
X548 3096 3099 2983 262 1 290 2 AOI22S $T=694400 901040 1 0 $X=694400 $Y=895620
X549 3135 3112 3026 262 1 290 2 AOI22S $T=699360 911120 1 180 $X=695640 $Y=910740
X550 3123 3116 3032 262 1 290 2 AOI22S $T=699980 890960 0 180 $X=696260 $Y=885540
X551 3136 3117 3121 260 1 261 2 AOI22S $T=699980 971600 1 180 $X=696260 $Y=971220
X552 3056 3100 3114 2994 1 3053 2 AOI22S $T=697500 951440 0 0 $X=697500 $Y=951060
X553 3128 3109 3167 262 1 290 2 AOI22S $T=701220 1022000 1 180 $X=697500 $Y=1021620
X554 3122 3101 3115 262 1 290 2 AOI22S $T=701840 1011920 1 180 $X=698120 $Y=1011540
X555 3127 3137 3134 262 1 290 2 AOI22S $T=701220 1032080 0 0 $X=701220 $Y=1031700
X556 3126 3067 3138 262 1 290 2 AOI22S $T=701840 1011920 1 0 $X=701840 $Y=1006500
X557 3145 3142 3065 262 1 290 2 AOI22S $T=706180 921200 1 180 $X=702460 $Y=920820
X558 3095 3097 3140 262 1 290 2 AOI22S $T=703080 1001840 1 0 $X=703080 $Y=996420
X559 3160 3148 3163 260 1 261 2 AOI22S $T=708040 971600 1 180 $X=704320 $Y=971220
X560 3147 3146 3151 260 1 261 2 AOI22S $T=708660 971600 0 180 $X=704940 $Y=966180
X561 3173 3159 3124 262 1 290 2 AOI22S $T=709900 941360 0 180 $X=706180 $Y=935940
X562 3152 3161 3179 262 1 290 2 AOI22S $T=711760 991760 0 0 $X=711760 $Y=991380
X563 3190 3190 3164 3196 1 3220 2 AOI22S $T=714860 1001840 1 0 $X=714860 $Y=996420
X564 3191 3191 3172 3196 1 3220 2 AOI22S $T=714860 1032080 1 0 $X=714860 $Y=1026660
X565 3197 3204 3199 262 1 290 2 AOI22S $T=716720 1042160 1 0 $X=716720 $Y=1036740
X566 3224 3224 3210 3196 1 3220 2 AOI22S $T=723540 1001840 0 180 $X=719820 $Y=996420
X567 3225 3225 3221 3196 1 3220 2 AOI22S $T=723540 1032080 0 180 $X=719820 $Y=1026660
X568 3223 3223 3194 3196 1 3220 2 AOI22S $T=724160 1022000 1 180 $X=720440 $Y=1021620
X569 3236 3236 3180 3196 1 3220 2 AOI22S $T=725400 1011920 0 180 $X=721680 $Y=1006500
X570 3211 3211 3203 3196 1 3220 2 AOI22S $T=725400 1011920 1 180 $X=721680 $Y=1011540
X571 3293 3296 3304 353 1 354 2 AOI22S $T=737180 1052240 0 0 $X=737180 $Y=1051860
X572 3285 352 3305 353 1 354 2 AOI22S $T=737180 1062320 0 0 $X=737180 $Y=1061940
X573 3331 3344 3337 3350 1 3358 2 AOI22S $T=744000 1022000 1 0 $X=744000 $Y=1016580
X574 3335 3345 3342 3351 1 3354 2 AOI22S $T=744000 1032080 0 0 $X=744000 $Y=1031700
X575 3348 3353 3323 3350 1 3358 2 AOI22S $T=745240 1011920 1 0 $X=745240 $Y=1006500
X576 3318 3356 3355 3351 1 3354 2 AOI22S $T=747100 1032080 1 0 $X=747100 $Y=1026660
X577 3325 3369 3363 3350 1 3358 2 AOI22S $T=748960 1022000 1 0 $X=748960 $Y=1016580
X578 3370 3359 3324 361 1 363 2 AOI22S $T=750200 1052240 0 0 $X=750200 $Y=1051860
X579 3368 3373 3372 3351 1 3354 2 AOI22S $T=750820 1032080 0 0 $X=750820 $Y=1031700
X580 3377 3382 3387 367 1 3399 2 AOI22S $T=755780 991760 0 0 $X=755780 $Y=991380
X581 3394 3341 3406 367 1 3399 2 AOI22S $T=760740 991760 0 0 $X=760740 $Y=991380
X582 3424 3414 3422 353 1 354 2 AOI22S $T=765080 1042160 1 180 $X=761360 $Y=1041780
X583 3405 3418 3411 3421 1 3429 2 AOI22S $T=762600 931280 1 0 $X=762600 $Y=925860
X584 3410 3409 3423 3421 1 3429 2 AOI22S $T=763840 941360 0 0 $X=763840 $Y=940980
X585 3415 3435 3431 3421 1 3429 2 AOI22S $T=764460 981680 1 0 $X=764460 $Y=976260
X586 3408 3436 3426 3351 1 3354 2 AOI22S $T=764460 1032080 1 0 $X=764460 $Y=1026660
X587 3412 3391 3433 3439 1 3443 2 AOI22S $T=765080 961520 1 0 $X=765080 $Y=956100
X588 3420 3336 3434 3439 1 3443 2 AOI22S $T=765080 971600 1 0 $X=765080 $Y=966180
X589 382 3416 3442 361 1 363 2 AOI22S $T=768800 1062320 1 180 $X=765080 $Y=1061940
X590 3438 3427 3425 3439 1 3443 2 AOI22S $T=766320 921200 0 0 $X=766320 $Y=920820
X591 3385 3413 3440 367 1 3399 2 AOI22S $T=766320 991760 0 0 $X=766320 $Y=991380
X592 3463 3445 3448 3350 1 3358 2 AOI22S $T=770040 1022000 1 180 $X=766320 $Y=1021620
X593 3469 3403 3474 3439 1 3443 2 AOI22S $T=773140 961520 0 180 $X=769420 $Y=956100
X594 3346 3451 3449 3421 1 3429 2 AOI22S $T=769420 981680 1 0 $X=769420 $Y=976260
X595 3447 3459 3450 367 1 3399 2 AOI22S $T=771280 1001840 1 0 $X=771280 $Y=996420
X596 3483 3477 3470 3421 1 3429 2 AOI22S $T=776860 931280 0 180 $X=773140 $Y=925860
X597 3482 3464 3487 3351 1 3354 2 AOI22S $T=776860 1022000 1 180 $X=773140 $Y=1021620
X598 3481 3489 3479 3439 1 3443 2 AOI22S $T=776240 921200 0 0 $X=776240 $Y=920820
X599 3498 3490 3456 3421 1 3429 2 AOI22S $T=779960 981680 0 180 $X=776240 $Y=976260
X600 3500 3491 3466 367 1 3399 2 AOI22S $T=779960 1001840 0 180 $X=776240 $Y=996420
X601 3473 3484 3493 3439 1 3443 2 AOI22S $T=778100 941360 0 0 $X=778100 $Y=940980
X602 3480 3475 3495 353 1 354 2 AOI22S $T=778720 1052240 0 0 $X=778720 $Y=1051860
X603 3512 3504 3510 367 1 3399 2 AOI22S $T=784300 991760 1 180 $X=780580 $Y=991380
X604 3499 3502 3494 3350 1 3358 2 AOI22S $T=780580 1022000 0 0 $X=780580 $Y=1021620
X605 3524 3516 3509 3351 1 3354 2 AOI22S $T=786780 1032080 1 180 $X=783060 $Y=1031700
X606 398 3514 3513 361 1 363 2 AOI22S $T=785540 1062320 1 0 $X=785540 $Y=1056900
X607 3535 3529 3515 3350 1 3358 2 AOI22S $T=791740 1022000 1 180 $X=788020 $Y=1021620
X608 3582 3556 3570 367 1 3399 2 AOI22S $T=802280 991760 0 180 $X=798560 $Y=986340
X609 3557 3563 3558 3350 1 3358 2 AOI22S $T=798560 1011920 0 0 $X=798560 $Y=1011540
X610 3578 409 3581 361 1 363 2 AOI22S $T=803520 1062320 0 180 $X=799800 $Y=1056900
X611 3565 3549 3561 3351 1 3354 2 AOI22S $T=800420 1032080 1 0 $X=800420 $Y=1026660
X612 3560 3571 3588 353 1 354 2 AOI22S $T=806000 1052240 0 0 $X=806000 $Y=1051860
X613 3600 3569 3594 3439 1 3443 2 AOI22S $T=808480 911120 0 0 $X=808480 $Y=910740
X614 3608 3577 3609 353 1 354 2 AOI22S $T=809720 1052240 0 0 $X=809720 $Y=1051860
X615 3620 3599 3607 3351 1 3354 2 AOI22S $T=814060 1032080 0 180 $X=810340 $Y=1026660
X616 3632 3613 3639 367 1 3399 2 AOI22S $T=815300 991760 0 180 $X=811580 $Y=986340
X617 3634 3614 3584 3421 1 3429 2 AOI22S $T=817780 931280 1 180 $X=814060 $Y=930900
X618 3619 3627 3612 3350 1 3358 2 AOI22S $T=815300 1022000 1 0 $X=815300 $Y=1016580
X619 3628 3640 3635 3351 1 3354 2 AOI22S $T=817780 1032080 0 0 $X=817780 $Y=1031700
X620 3641 3647 3643 3350 1 3358 2 AOI22S $T=819020 1022000 1 0 $X=819020 $Y=1016580
X621 430 3654 3621 361 1 363 2 AOI22S $T=820260 1062320 1 0 $X=820260 $Y=1056900
X622 3651 3658 3653 3439 1 3443 2 AOI22S $T=820880 961520 1 0 $X=820880 $Y=956100
X623 3661 3665 3657 3421 1 3429 2 AOI22S $T=822120 931280 0 0 $X=822120 $Y=930900
X624 3666 3676 3672 3421 1 3429 2 AOI22S $T=824600 981680 1 0 $X=824600 $Y=976260
X625 3656 3616 3670 3439 1 3443 2 AOI22S $T=825220 921200 0 0 $X=825220 $Y=920820
X626 3675 3682 3678 3350 1 3358 2 AOI22S $T=825220 1022000 1 0 $X=825220 $Y=1016580
X627 3687 3696 3688 367 1 3399 2 AOI22S $T=829560 991760 0 0 $X=829560 $Y=991380
X628 3692 3662 3680 367 1 3399 2 AOI22S $T=829560 1001840 1 0 $X=829560 $Y=996420
X629 3702 3693 3700 361 1 363 2 AOI22S $T=833280 1052240 1 180 $X=829560 $Y=1051860
X630 3713 3705 3697 3351 1 3354 2 AOI22S $T=835140 1032080 0 180 $X=831420 $Y=1026660
X631 3689 3706 3695 353 1 354 2 AOI22S $T=832660 1052240 1 0 $X=832660 $Y=1046820
X632 3721 3716 3701 367 1 3399 2 AOI22S $T=837620 1001840 0 180 $X=833900 $Y=996420
X633 3725 3718 3709 3439 1 3443 2 AOI22S $T=838240 951440 1 180 $X=834520 $Y=951060
X634 3720 3724 3728 3350 1 3358 2 AOI22S $T=839480 1022000 0 180 $X=835760 $Y=1016580
X635 3663 3729 3726 3439 1 3443 2 AOI22S $T=838240 951440 0 0 $X=838240 $Y=951060
X636 3737 3691 3690 3439 1 3443 2 AOI22S $T=842580 921200 1 180 $X=838860 $Y=920820
X637 3735 3733 3685 3421 1 3429 2 AOI22S $T=842580 931280 1 180 $X=838860 $Y=930900
X638 3723 3749 3704 3421 1 3429 2 AOI22S $T=846920 971600 0 0 $X=846920 $Y=971220
X639 3748 3744 3736 3351 1 3354 2 AOI22S $T=848160 1032080 1 0 $X=848160 $Y=1026660
X640 3754 3755 3763 3350 1 3358 2 AOI22S $T=853120 1011920 1 180 $X=849400 $Y=1011540
X641 3752 3765 3739 367 1 3399 2 AOI22S $T=851260 991760 0 0 $X=851260 $Y=991380
X642 3759 3768 3760 3351 1 3354 2 AOI22S $T=851880 1032080 0 0 $X=851880 $Y=1031700
X643 3764 449 3758 361 1 363 2 AOI22S $T=851880 1062320 0 0 $X=851880 $Y=1061940
X644 3780 3757 3738 3421 1 3429 2 AOI22S $T=858700 981680 0 180 $X=854980 $Y=976260
X645 3788 3783 3791 361 1 363 2 AOI22S $T=860560 1062320 0 180 $X=856840 $Y=1056900
X646 3810 3800 3796 3421 1 3429 2 AOI22S $T=864900 981680 0 180 $X=861180 $Y=976260
X647 3803 3808 3812 3351 1 3354 2 AOI22S $T=865520 1032080 1 180 $X=861800 $Y=1031700
X648 3815 3801 3797 353 1 354 2 AOI22S $T=865520 1052240 1 180 $X=861800 $Y=1051860
X649 3798 3771 3799 3439 1 3443 2 AOI22S $T=862420 951440 1 0 $X=862420 $Y=946020
X650 3818 3811 3789 367 1 3399 2 AOI22S $T=866760 991760 1 180 $X=863040 $Y=991380
X651 3802 3784 3816 3350 1 3358 2 AOI22S $T=865520 1011920 0 0 $X=865520 $Y=1011540
X652 3831 3826 3824 3350 1 3358 2 AOI22S $T=873580 1011920 1 180 $X=869860 $Y=1011540
X653 3843 3835 3837 3439 1 3443 2 AOI22S $T=876680 921200 1 180 $X=872960 $Y=920820
X654 3845 367 3841 3834 1 3399 2 AOI22S $T=876680 981680 1 180 $X=872960 $Y=981300
X655 3817 3836 3832 3421 1 3429 2 AOI22S $T=873580 931280 0 0 $X=873580 $Y=930900
X656 3849 3838 3829 3351 1 3354 2 AOI22S $T=877300 1032080 0 180 $X=873580 $Y=1026660
X657 3853 3859 3857 3351 1 3354 2 AOI22S $T=880400 1032080 0 0 $X=880400 $Y=1031700
X658 3864 3866 3868 367 1 3399 2 AOI22S $T=883500 1001840 1 0 $X=883500 $Y=996420
X659 3885 3875 3860 353 1 354 2 AOI22S $T=887840 1052240 1 180 $X=884120 $Y=1051860
X660 3858 464 3865 361 1 363 2 AOI22S $T=884120 1062320 0 0 $X=884120 $Y=1061940
X661 3918 3879 3895 3439 1 3443 2 AOI22S $T=889700 921200 0 180 $X=885980 $Y=915780
X662 3877 3881 3872 3350 1 3358 2 AOI22S $T=885980 1022000 1 0 $X=885980 $Y=1016580
X663 3876 3883 3880 3421 1 3429 2 AOI22S $T=886600 981680 1 0 $X=886600 $Y=976260
X664 3896 3887 3897 3439 1 3443 2 AOI22S $T=890940 951440 0 180 $X=887220 $Y=946020
X665 3906 3889 3886 367 1 3399 2 AOI22S $T=891560 1001840 0 180 $X=887840 $Y=996420
X666 3908 3901 3888 3421 1 3429 2 AOI22S $T=894040 981680 0 180 $X=890320 $Y=976260
X667 3915 3884 3894 3350 1 3358 2 AOI22S $T=894040 1011920 0 180 $X=890320 $Y=1006500
X668 3920 3910 3892 3439 1 3443 2 AOI22S $T=895900 951440 0 180 $X=892180 $Y=946020
X669 470 3911 3907 361 1 363 2 AOI22S $T=895900 1062320 0 180 $X=892180 $Y=1056900
X670 3921 3912 3914 3351 1 3354 2 AOI22S $T=896520 1032080 0 180 $X=892800 $Y=1026660
X671 3945 3917 3899 353 1 354 2 AOI22S $T=897760 1052240 0 180 $X=894040 $Y=1046820
X672 3891 3924 3904 3421 1 3429 2 AOI22S $T=897760 931280 0 0 $X=897760 $Y=930900
X673 3936 3925 3905 367 1 3399 2 AOI22S $T=901480 981680 1 180 $X=897760 $Y=981300
X674 3947 3926 3931 3351 1 3354 2 AOI22S $T=901480 1032080 0 180 $X=897760 $Y=1026660
X675 3938 3932 3922 3350 1 3358 2 AOI22S $T=904580 1011920 1 180 $X=900860 $Y=1011540
X676 3982 3989 4002 3350 1 3358 2 AOI22S $T=925660 1022000 1 0 $X=925660 $Y=1016580
X677 4016 4024 4018 353 1 354 2 AOI22S $T=930000 1052240 1 0 $X=930000 $Y=1046820
X678 3993 4026 4020 367 1 3399 2 AOI22S $T=930620 991760 1 0 $X=930620 $Y=986340
X679 4049 4036 4045 353 1 354 2 AOI22S $T=937440 1052240 0 180 $X=933720 $Y=1046820
X680 4032 4035 4034 3439 1 3443 2 AOI22S $T=934340 961520 1 0 $X=934340 $Y=956100
X681 498 3992 4050 353 1 354 2 AOI22S $T=938680 1062320 1 180 $X=934960 $Y=1061940
X682 4082 4031 4078 3421 1 3429 2 AOI22S $T=943020 971600 1 180 $X=939300 $Y=971220
X683 3987 4009 4027 3351 1 3354 2 AOI22S $T=940540 1032080 0 0 $X=940540 $Y=1031700
X684 504 4087 4071 361 1 363 2 AOI22S $T=944880 1062320 1 180 $X=941160 $Y=1061940
X685 4092 4070 4052 361 1 363 2 AOI22S $T=945500 1052240 1 180 $X=941780 $Y=1051860
X686 4085 4091 4088 3439 1 3443 2 AOI22S $T=943640 951440 1 0 $X=943640 $Y=946020
X687 4097 4057 4077 367 1 3399 2 AOI22S $T=947360 981680 1 180 $X=943640 $Y=981300
X688 4102 4086 4055 367 1 3399 2 AOI22S $T=947980 991760 0 180 $X=944260 $Y=986340
X689 4023 4063 4056 3350 1 3358 2 AOI22S $T=944260 1022000 1 0 $X=944260 $Y=1016580
X690 4041 4098 4089 3351 1 3354 2 AOI22S $T=944260 1022000 0 0 $X=944260 $Y=1021620
X691 4015 4100 4069 3439 1 3443 2 AOI22S $T=945500 921200 1 0 $X=945500 $Y=915780
X692 4101 4105 4064 3351 1 3354 2 AOI22S $T=949220 1032080 1 0 $X=949220 $Y=1026660
X693 4119 4095 4080 3421 1 3429 2 AOI22S $T=954180 971600 1 180 $X=950460 $Y=971220
X694 4120 4115 4083 3350 1 3358 2 AOI22S $T=955420 1011920 1 180 $X=951700 $Y=1011540
X695 4117 4123 4116 3351 1 3354 2 AOI22S $T=954180 1022000 0 0 $X=954180 $Y=1021620
X696 4142 4108 4113 3350 1 3358 2 AOI22S $T=959140 1011920 1 180 $X=955420 $Y=1011540
X697 4137 4114 4132 367 1 3399 2 AOI22S $T=962240 991760 0 180 $X=958520 $Y=986340
X698 4128 4130 4133 3439 1 3443 2 AOI22S $T=959140 911120 1 0 $X=959140 $Y=905700
X699 4135 4104 4058 3421 1 3429 2 AOI22S $T=961000 931280 0 0 $X=961000 $Y=930900
X700 4144 4139 4134 3421 1 3429 2 AOI22S $T=964720 941360 0 180 $X=961000 $Y=935940
X701 4147 4152 4146 3350 1 3358 2 AOI22S $T=967200 1001840 0 0 $X=967200 $Y=1001460
X702 4156 4160 4109 361 1 363 2 AOI22S $T=967820 1042160 0 0 $X=967820 $Y=1041780
X703 4161 4164 4157 367 1 3399 2 AOI22S $T=969060 991760 0 0 $X=969060 $Y=991380
X704 4177 4168 4165 3421 1 3429 2 AOI22S $T=974640 981680 0 180 $X=970920 $Y=976260
X705 4145 4148 4163 3351 1 3354 2 AOI22S $T=972160 1022000 0 0 $X=972160 $Y=1021620
X706 4184 4180 4183 3350 1 3358 2 AOI22S $T=978980 1022000 0 180 $X=975260 $Y=1016580
X707 521 4178 4181 361 1 363 2 AOI22S $T=976500 1062320 0 0 $X=976500 $Y=1061940
X708 4179 4190 4189 3351 1 3354 2 AOI22S $T=978360 1032080 0 0 $X=978360 $Y=1031700
X709 4202 4188 4200 3439 1 3443 2 AOI22S $T=983320 911120 0 180 $X=979600 $Y=905700
X710 4207 4193 4194 361 1 363 2 AOI22S $T=985180 1052240 0 180 $X=981460 $Y=1046820
X711 4208 4175 4170 3439 1 3443 2 AOI22S $T=985800 951440 1 180 $X=982080 $Y=951060
X712 4198 4187 4196 353 1 354 2 AOI22S $T=982080 1042160 0 0 $X=982080 $Y=1041780
X713 4223 4209 4224 3351 1 3354 2 AOI22S $T=990140 1022000 1 180 $X=986420 $Y=1021620
X714 4211 4216 4197 367 1 3399 2 AOI22S $T=987040 991760 0 0 $X=987040 $Y=991380
X715 4217 4221 4199 3421 1 3429 2 AOI22S $T=987660 931280 0 0 $X=987660 $Y=930900
X716 4215 4218 4222 3421 1 3429 2 AOI22S $T=988280 971600 0 0 $X=988280 $Y=971220
X717 4227 4226 4228 367 1 3399 2 AOI22S $T=992620 991760 0 0 $X=992620 $Y=991380
X718 4234 4236 4233 3439 1 3443 2 AOI22S $T=996340 961520 1 0 $X=996340 $Y=956100
X719 4230 4237 4225 3350 1 3358 2 AOI22S $T=996340 1022000 1 0 $X=996340 $Y=1016580
X720 4239 4242 4241 3439 1 3443 2 AOI22S $T=1000060 911120 1 0 $X=1000060 $Y=905700
X721 4245 4249 4252 367 1 3399 2 AOI22S $T=1003780 981680 1 180 $X=1000060 $Y=981300
X722 4262 4243 4263 3421 1 3429 2 AOI22S $T=1005640 931280 1 180 $X=1001920 $Y=930900
X723 4240 4232 4250 3350 1 3358 2 AOI22S $T=1001920 1022000 1 0 $X=1001920 $Y=1016580
X724 4254 4259 4246 361 1 363 2 AOI22S $T=1003160 1042160 0 0 $X=1003160 $Y=1041780
X725 4253 4261 4258 3351 1 3354 2 AOI22S $T=1004400 1032080 1 0 $X=1004400 $Y=1026660
X726 4256 4268 4231 353 1 354 2 AOI22S $T=1006260 1052240 0 0 $X=1006260 $Y=1051860
X727 4255 4270 4267 3351 1 3354 2 AOI22S $T=1006880 1022000 0 0 $X=1006880 $Y=1021620
X728 4264 4269 4273 367 1 3399 2 AOI22S $T=1008740 991760 0 0 $X=1008740 $Y=991380
X729 4272 4274 4276 3350 1 3358 2 AOI22S $T=1010600 1011920 0 0 $X=1010600 $Y=1011540
X730 4271 4279 4277 3439 1 3443 2 AOI22S $T=1011840 951440 0 0 $X=1011840 $Y=951060
X731 4284 4282 4278 3421 1 3429 2 AOI22S $T=1015560 971600 1 180 $X=1011840 $Y=971220
X732 4280 4283 4285 353 1 354 2 AOI22S $T=1015560 1062320 0 180 $X=1011840 $Y=1056900
X733 4315 4299 4297 3351 1 3354 2 AOI22S $T=1020520 1022000 0 180 $X=1016800 $Y=1016580
X734 4312 4293 4303 3439 1 3443 2 AOI22S $T=1022380 911120 0 180 $X=1018660 $Y=905700
X735 4298 4294 4301 3421 1 3429 2 AOI22S $T=1018660 931280 0 0 $X=1018660 $Y=930900
X736 4314 4288 4307 367 1 3399 2 AOI22S $T=1022380 991760 0 180 $X=1018660 $Y=986340
X737 4296 4304 4290 3350 1 3358 2 AOI22S $T=1019280 1011920 0 0 $X=1019280 $Y=1011540
X738 4309 4308 4311 3350 1 3358 2 AOI22S $T=1023620 1011920 0 0 $X=1023620 $Y=1011540
X739 4327 4320 4329 361 1 363 2 AOI22S $T=1027960 1042160 0 0 $X=1027960 $Y=1041780
X740 4318 4330 4332 367 1 3399 2 AOI22S $T=1029200 991760 0 0 $X=1029200 $Y=991380
X741 4323 4331 4333 3439 1 3443 2 AOI22S $T=1029820 961520 1 0 $X=1029820 $Y=956100
X742 4353 4338 4337 3421 1 3429 2 AOI22S $T=1034160 971600 1 180 $X=1030440 $Y=971220
X743 4350 4347 4369 3351 1 3354 2 AOI22S $T=1036020 1032080 0 180 $X=1032300 $Y=1026660
X744 546 4343 4339 361 1 363 2 AOI22S $T=1032300 1062320 0 0 $X=1032300 $Y=1061940
X745 4359 4348 4354 3350 1 3358 2 AOI22S $T=1036640 1011920 0 180 $X=1032920 $Y=1006500
X746 4335 4356 4351 3421 1 3429 2 AOI22S $T=1036020 941360 1 0 $X=1036020 $Y=935940
X747 4375 4363 4364 367 1 3399 2 AOI22S $T=1039740 991760 0 180 $X=1036020 $Y=986340
X748 4370 4361 4345 353 1 354 2 AOI22S $T=1039740 1042160 1 180 $X=1036020 $Y=1041780
X749 4346 4360 4326 3351 1 3354 2 AOI22S $T=1036640 1022000 0 0 $X=1036640 $Y=1021620
X750 4374 4358 4368 3439 1 3443 2 AOI22S $T=1042220 911120 0 180 $X=1038500 $Y=905700
X751 552 4377 4365 353 1 354 2 AOI22S $T=1044700 1062320 1 180 $X=1040980 $Y=1061940
X752 4388 4379 4390 3421 1 3429 2 AOI22S $T=1046560 941360 0 180 $X=1042840 $Y=935940
X753 4389 4380 4384 367 1 3399 2 AOI22S $T=1046560 991760 1 180 $X=1042840 $Y=991380
X754 4391 4398 4395 3421 1 3429 2 AOI22S $T=1048420 971600 0 0 $X=1048420 $Y=971220
X755 4393 4401 4403 3439 1 3443 2 AOI22S $T=1051520 961520 1 0 $X=1051520 $Y=956100
X756 4394 4406 4376 3350 1 3358 2 AOI22S $T=1052140 1011920 1 0 $X=1052140 $Y=1006500
X757 4411 4407 4417 3439 1 3443 2 AOI22S $T=1056480 971600 0 180 $X=1052760 $Y=966180
X758 4404 4405 4402 3351 1 3354 2 AOI22S $T=1054000 1032080 1 0 $X=1054000 $Y=1026660
X759 4428 4414 4424 3421 1 3429 2 AOI22S $T=1058340 971600 1 180 $X=1054620 $Y=971220
X760 4422 4413 4396 3439 1 3443 2 AOI22S $T=1059580 911120 0 180 $X=1055860 $Y=905700
X761 4412 4418 4429 3351 1 3354 2 AOI22S $T=1060200 1032080 1 0 $X=1060200 $Y=1026660
X762 4410 4420 4421 3350 1 3358 2 AOI22S $T=1060820 1011920 0 0 $X=1060820 $Y=1011540
X763 4450 4438 4440 3439 1 3443 2 AOI22S $T=1065160 911120 0 180 $X=1061440 $Y=905700
X764 4416 4434 4432 3421 1 3429 2 AOI22S $T=1061440 941360 0 0 $X=1061440 $Y=940980
X765 4408 4435 4431 361 1 363 2 AOI22S $T=1061440 1052240 1 0 $X=1061440 $Y=1046820
X766 4419 4436 4433 361 1 363 2 AOI22S $T=1061440 1052240 0 0 $X=1061440 $Y=1051860
X767 4445 4442 4447 3439 1 3443 2 AOI22S $T=1065780 921200 1 180 $X=1062060 $Y=920820
X768 4423 4441 4400 367 1 3399 2 AOI22S $T=1062680 991760 0 0 $X=1062680 $Y=991380
X769 4439 4443 4451 3421 1 3429 2 AOI22S $T=1068260 931280 0 180 $X=1064540 $Y=925860
X770 4449 4446 4448 367 1 3399 2 AOI22S $T=1068260 991760 0 180 $X=1064540 $Y=986340
X771 4491 4460 4453 367 1 3399 2 AOI22S $T=1071980 991760 0 180 $X=1068260 $Y=986340
X772 4463 4462 4464 3351 1 3354 2 AOI22S $T=1071980 1032080 0 180 $X=1068260 $Y=1026660
X773 4473 4466 4459 3350 1 3358 2 AOI22S $T=1073840 1001840 1 180 $X=1070120 $Y=1001460
X774 4490 4457 4467 3350 1 3358 2 AOI22S $T=1073840 1011920 0 180 $X=1070120 $Y=1006500
X775 4483 4469 4426 367 1 3399 2 AOI22S $T=1075700 981680 1 180 $X=1071980 $Y=981300
X776 4487 4470 4454 353 1 354 2 AOI22S $T=1075700 1052240 1 180 $X=1071980 $Y=1051860
X777 4486 4480 4468 3351 1 3354 2 AOI22S $T=1080660 1022000 1 180 $X=1076940 $Y=1021620
X778 4493 4481 4475 3351 1 3354 2 AOI22S $T=1080660 1032080 0 180 $X=1076940 $Y=1026660
X779 4488 4479 4474 3350 1 3358 2 AOI22S $T=1081900 1011920 1 180 $X=1078180 $Y=1011540
X780 4494 568 569 353 1 354 2 AOI22S $T=1081900 1062320 1 180 $X=1078180 $Y=1061940
X781 4489 4482 4425 353 1 354 2 AOI22S $T=1082520 1052240 0 180 $X=1078800 $Y=1046820
X782 600 590 1 2 3 AN2 $T=223820 890960 1 180 $X=221340 $Y=890580
X783 601 609 1 2 590 AN2 $T=223820 901040 1 180 $X=221340 $Y=900660
X784 593 594 1 2 609 AN2 $T=221340 921200 1 0 $X=221340 $Y=915780
X785 602 595 1 2 594 AN2 $T=223820 931280 1 180 $X=221340 $Y=930900
X786 603 596 1 2 595 AN2 $T=223820 941360 1 180 $X=221340 $Y=940980
X787 604 597 1 2 596 AN2 $T=223820 961520 0 180 $X=221340 $Y=956100
X788 610 605 1 2 597 AN2 $T=223820 971600 1 180 $X=221340 $Y=971220
X789 591 606 1 2 610 AN2 $T=221340 981680 0 0 $X=221340 $Y=981300
X790 611 607 1 2 591 AN2 $T=223820 1001840 0 180 $X=221340 $Y=996420
X791 628 599 1 2 598 AN2 $T=223820 1022000 1 180 $X=221340 $Y=1021620
X792 614 612 1 2 599 AN2 $T=223820 1032080 0 180 $X=221340 $Y=1026660
X793 592 608 1 2 614 AN2 $T=221340 1032080 0 0 $X=221340 $Y=1031700
X794 618 615 1 2 592 AN2 $T=225060 1052240 0 180 $X=222580 $Y=1046820
X795 674 643 1 2 611 AN2 $T=228780 1011920 0 180 $X=226300 $Y=1006500
X796 636 598 1 2 658 AN2 $T=228160 1011920 0 0 $X=228160 $Y=1011540
X797 665 9 1 2 648 AN2 $T=232500 991760 0 180 $X=230020 $Y=986340
X798 701 684 1 2 615 AN2 $T=233740 1052240 0 180 $X=231260 $Y=1046820
X799 707 9 1 2 654 AN2 $T=236840 991760 1 180 $X=234360 $Y=991380
X800 709 9 1 2 689 AN2 $T=237460 1001840 0 180 $X=234980 $Y=996420
X801 658 721 1 2 674 AN2 $T=239320 1011920 1 180 $X=236840 $Y=1011540
X802 708 715 1 2 722 AN2 $T=236840 1032080 0 0 $X=236840 $Y=1031700
X803 738 722 1 2 701 AN2 $T=239320 1042160 1 180 $X=236840 $Y=1041780
X804 788 770 1 2 759 AN2 $T=249860 971600 0 180 $X=247380 $Y=966180
X805 789 795 1 2 801 AN2 $T=249240 991760 0 0 $X=249240 $Y=991380
X806 806 765 1 2 775 AN2 $T=251720 1022000 0 0 $X=251720 $Y=1021620
X807 858 44 1 2 824 AN2 $T=262880 991760 0 180 $X=260400 $Y=986340
X808 831 801 1 2 855 AN2 $T=260400 1001840 1 0 $X=260400 $Y=996420
X809 845 855 1 2 836 AN2 $T=262880 1011920 1 180 $X=260400 $Y=1011540
X810 882 44 1 2 790 AN2 $T=266600 991760 0 180 $X=264120 $Y=986340
X811 839 836 1 2 883 AN2 $T=264120 1011920 0 0 $X=264120 $Y=1011540
X812 867 879 1 2 892 AN2 $T=265980 971600 1 0 $X=265980 $Y=966180
X813 899 894 1 2 921 AN2 $T=270940 1001840 1 0 $X=270940 $Y=996420
X814 926 44 1 2 914 AN2 $T=274040 991760 1 0 $X=274040 $Y=986340
X815 931 929 1 2 899 AN2 $T=276520 1001840 0 180 $X=274040 $Y=996420
X816 883 928 1 2 931 AN2 $T=274040 1011920 0 0 $X=274040 $Y=1011540
X817 951 44 1 2 905 AN2 $T=279620 991760 0 180 $X=277140 $Y=986340
X818 921 942 1 2 955 AN2 $T=277760 1001840 1 0 $X=277760 $Y=996420
X819 955 964 1 2 986 AN2 $T=280860 1001840 0 0 $X=280860 $Y=1001460
X820 986 989 1 2 994 AN2 $T=285820 991760 0 0 $X=285820 $Y=991380
X821 1006 1003 1 2 71 AN2 $T=290160 880880 1 180 $X=287680 $Y=880500
X822 994 960 1 2 1009 AN2 $T=287680 991760 1 0 $X=287680 $Y=986340
X823 1014 1007 1 2 999 AN2 $T=290780 921200 0 180 $X=288300 $Y=915780
X824 1009 1011 1 2 1036 AN2 $T=289540 981680 0 0 $X=289540 $Y=981300
X825 1026 841 1 2 970 AN2 $T=292020 1022000 1 180 $X=289540 $Y=1021620
X826 1045 1044 1 2 1003 AN2 $T=296980 901040 0 180 $X=294500 $Y=895620
X827 1018 999 1 2 1044 AN2 $T=294500 911120 1 0 $X=294500 $Y=905700
X828 1016 75 1 2 1056 AN2 $T=294500 1042160 1 0 $X=294500 $Y=1036740
X829 996 75 1 2 1057 AN2 $T=294500 1052240 1 0 $X=294500 $Y=1046820
X830 1032 1046 1 2 1007 AN2 $T=296360 951440 0 0 $X=296360 $Y=951060
X831 1031 75 1 2 1029 AN2 $T=296360 1062320 0 0 $X=296360 $Y=1061940
X832 1040 1036 1 2 1046 AN2 $T=298220 971600 0 0 $X=298220 $Y=971220
X833 1072 75 1 2 1079 AN2 $T=301320 1022000 0 0 $X=301320 $Y=1021620
X834 1109 1079 1 2 1082 AN2 $T=307520 1022000 1 180 $X=305040 $Y=1021620
X835 1113 1125 1 2 1142 AN2 $T=311860 1032080 0 0 $X=311860 $Y=1031700
X836 1131 1121 1 2 1151 AN2 $T=313100 981680 0 0 $X=313100 $Y=981300
X837 91 75 1 2 1178 AN2 $T=324260 890960 0 180 $X=321780 $Y=885540
X838 1174 1168 1 2 1203 AN2 $T=321780 1042160 0 0 $X=321780 $Y=1041780
X839 1225 1213 1 2 1202 AN2 $T=326120 1032080 1 180 $X=323640 $Y=1031700
X840 1242 1203 1 2 1213 AN2 $T=329220 1052240 0 180 $X=326740 $Y=1046820
X841 96 75 1 2 94 AN2 $T=329840 880880 1 180 $X=327360 $Y=880500
X842 1238 1233 1 2 1228 AN2 $T=329840 890960 1 180 $X=327360 $Y=890580
X843 1247 1224 1 2 1208 AN2 $T=331080 1001840 1 180 $X=328600 $Y=1001460
X844 1236 1202 1 2 1230 AN2 $T=328600 1022000 0 0 $X=328600 $Y=1021620
X845 1255 1243 1 2 1233 AN2 $T=331700 901040 0 180 $X=329220 $Y=895620
X846 1257 1224 1 2 1232 AN2 $T=332940 1011920 0 180 $X=330460 $Y=1006500
X847 1231 1230 1 2 1261 AN2 $T=330460 1022000 1 0 $X=330460 $Y=1016580
X848 1271 1224 1 2 1239 AN2 $T=334800 1001840 1 180 $X=332320 $Y=1001460
X849 1297 1290 1 2 1243 AN2 $T=339760 890960 1 180 $X=337280 $Y=890580
X850 1283 1261 1 2 1305 AN2 $T=337280 1001840 0 0 $X=337280 $Y=1001460
X851 102 75 1 2 101 AN2 $T=341620 880880 1 180 $X=339140 $Y=880500
X852 1306 1312 1 2 1328 AN2 $T=344100 971600 0 0 $X=344100 $Y=971220
X853 1340 1305 1 2 1312 AN2 $T=347820 991760 0 180 $X=345340 $Y=986340
X854 1326 1333 1 2 1343 AN2 $T=345960 931280 1 0 $X=345960 $Y=925860
X855 1316 1315 1 2 1333 AN2 $T=345960 941360 0 0 $X=345960 $Y=940980
X856 1327 1328 1 2 1349 AN2 $T=345960 961520 0 0 $X=345960 $Y=961140
X857 1323 1337 1 2 1290 AN2 $T=347820 890960 0 0 $X=347820 $Y=890580
X858 1353 1347 1 2 1337 AN2 $T=350300 901040 0 180 $X=347820 $Y=895620
X859 1341 1339 1 2 1331 AN2 $T=347820 911120 0 0 $X=347820 $Y=910740
X860 1355 1349 1 2 1315 AN2 $T=350300 951440 0 180 $X=347820 $Y=946020
X861 1338 1331 1 2 1347 AN2 $T=349060 911120 1 0 $X=349060 $Y=905700
X862 1320 1343 1 2 1339 AN2 $T=351540 931280 0 180 $X=349060 $Y=925860
X863 1360 75 1 2 1276 AN2 $T=351540 1052240 1 180 $X=349060 $Y=1051860
X864 1376 75 1 2 1286 AN2 $T=357120 1032080 1 180 $X=354640 $Y=1031700
X865 1417 75 1 2 1364 AN2 $T=363940 951440 0 180 $X=361460 $Y=946020
X866 1419 75 1 2 1383 AN2 $T=367040 941360 0 180 $X=364560 $Y=935940
X867 1427 75 1 2 1352 AN2 $T=368900 1001840 1 180 $X=366420 $Y=1001460
X868 1444 75 1 2 1336 AN2 $T=372000 1001840 1 180 $X=369520 $Y=1001460
X869 1411 116 1 2 1455 AN2 $T=371380 1062320 0 0 $X=371380 $Y=1061940
X870 1478 75 1 2 1370 AN2 $T=375720 991760 0 180 $X=373240 $Y=986340
X871 1459 75 1 2 1395 AN2 $T=376340 901040 1 180 $X=373860 $Y=900660
X872 1500 75 1 2 1378 AN2 $T=378820 931280 1 180 $X=376340 $Y=930900
X873 1457 116 1 2 1463 AN2 $T=376340 1042160 0 0 $X=376340 $Y=1041780
X874 121 75 1 2 120 AN2 $T=380060 880880 1 180 $X=377580 $Y=880500
X875 123 75 1 2 115 AN2 $T=382540 880880 1 180 $X=380060 $Y=880500
X876 1498 116 1 2 1477 AN2 $T=384400 1032080 1 180 $X=381920 $Y=1031700
X877 1493 75 1 2 1409 AN2 $T=386260 921200 0 180 $X=383780 $Y=915780
X878 127 75 1 2 1386 AN2 $T=387500 890960 1 180 $X=385020 $Y=890580
X879 1516 75 1 2 1403 AN2 $T=391220 911120 0 180 $X=388740 $Y=905700
X880 1541 1557 1 2 1569 AN2 $T=395560 991760 1 0 $X=395560 $Y=986340
X881 1567 1566 1 2 1532 AN2 $T=398660 1062320 1 180 $X=396180 $Y=1061940
X882 1540 1548 1 2 1566 AN2 $T=397420 1052240 1 0 $X=397420 $Y=1046820
X883 1563 1572 1 2 1557 AN2 $T=400520 971600 1 180 $X=398040 $Y=971220
X884 1569 1573 1 2 1586 AN2 $T=398660 981680 0 0 $X=398660 $Y=981300
X885 1532 1574 1 2 133 AN2 $T=398660 1062320 0 0 $X=398660 $Y=1061940
X886 1539 1571 1 2 1577 AN2 $T=402380 921200 0 0 $X=402380 $Y=920820
X887 1584 1569 1 2 1601 AN2 $T=402380 981680 0 0 $X=402380 $Y=981300
X888 1600 1597 1 2 1570 AN2 $T=406100 971600 0 180 $X=403620 $Y=966180
X889 136 133 1 2 1603 AN2 $T=403620 1062320 0 0 $X=403620 $Y=1061940
X890 1601 1573 1 2 1624 AN2 $T=405480 991760 1 0 $X=405480 $Y=986340
X891 1612 1614 1 2 1626 AN2 $T=407340 941360 1 0 $X=407340 $Y=935940
X892 1626 1631 1 2 1644 AN2 $T=410440 941360 1 0 $X=410440 $Y=935940
X893 1656 1641 1 2 1587 AN2 $T=412920 961520 0 180 $X=410440 $Y=956100
X894 1649 1642 1 2 1561 AN2 $T=412920 1022000 0 180 $X=410440 $Y=1016580
X895 1628 116 1 2 1667 AN2 $T=410440 1032080 0 0 $X=410440 $Y=1031700
X896 1646 1603 1 2 144 AN2 $T=412300 1062320 0 0 $X=412300 $Y=1061940
X897 1678 143 1 2 1632 AN2 $T=418500 981680 0 180 $X=416020 $Y=976260
X898 1687 143 1 2 1657 AN2 $T=419740 981680 1 180 $X=417260 $Y=981300
X899 1675 1661 1 2 1691 AN2 $T=417880 961520 1 0 $X=417880 $Y=956100
X900 1676 1624 1 2 1699 AN2 $T=419120 991760 1 0 $X=419120 $Y=986340
X901 1715 1663 1 2 1634 AN2 $T=421600 1052240 0 180 $X=419120 $Y=1046820
X902 1694 1663 1 2 134 AN2 $T=421600 1062320 0 180 $X=419120 $Y=1056900
X903 1644 1689 1 2 1703 AN2 $T=419740 941360 1 0 $X=419740 $Y=935940
X904 1718 148 1 2 1640 AN2 $T=425320 931280 1 180 $X=422840 $Y=930900
X905 1708 1702 1 2 1714 AN2 $T=422840 1022000 1 0 $X=422840 $Y=1016580
X906 1725 148 1 2 1560 AN2 $T=426560 921200 1 180 $X=424080 $Y=920820
X907 1704 1699 1 2 1728 AN2 $T=424080 1001840 1 0 $X=424080 $Y=996420
X908 1710 1723 1 2 1726 AN2 $T=425940 901040 1 0 $X=425940 $Y=895620
X909 1746 148 1 2 1582 AN2 $T=428420 921200 0 180 $X=425940 $Y=915780
X910 1706 1703 1 2 1737 AN2 $T=425940 931280 0 0 $X=425940 $Y=930900
X911 1751 165 1 2 1766 AN2 $T=431520 1062320 1 0 $X=431520 $Y=1056900
X912 1757 1728 1 2 1784 AN2 $T=432760 991760 0 0 $X=432760 $Y=991380
X913 1737 1764 1 2 1795 AN2 $T=434620 931280 0 0 $X=434620 $Y=930900
X914 1801 1784 1 2 1818 AN2 $T=439580 991760 0 0 $X=439580 $Y=991380
X915 1810 1795 1 2 1835 AN2 $T=443300 931280 1 0 $X=443300 $Y=925860
X916 1840 1835 1 2 1882 AN2 $T=446400 931280 1 0 $X=446400 $Y=925860
X917 1842 1818 1 2 1860 AN2 $T=446400 991760 0 0 $X=446400 $Y=991380
X918 1831 1766 1 2 1877 AN2 $T=450120 1052240 0 0 $X=450120 $Y=1051860
X919 1879 1877 1 2 1864 AN2 $T=452600 1062320 0 180 $X=450120 $Y=1056900
X920 1872 1860 1 2 1890 AN2 $T=451980 981680 0 0 $X=451980 $Y=981300
X921 1880 1882 1 2 1918 AN2 $T=453220 931280 1 0 $X=453220 $Y=925860
X922 1618 1897 1 2 1907 AN2 $T=455080 1042160 1 0 $X=455080 $Y=1036740
X923 1915 1918 1 2 1933 AN2 $T=460040 931280 1 0 $X=460040 $Y=925860
X924 1873 1879 1 2 1958 AN2 $T=465000 1062320 0 0 $X=465000 $Y=1061940
X925 1929 1890 1 2 1971 AN2 $T=465620 991760 1 0 $X=465620 $Y=986340
X926 1958 1877 1 2 1988 AN2 $T=467480 1062320 0 0 $X=467480 $Y=1061940
X927 1981 1933 1 2 2021 AN2 $T=473680 931280 0 0 $X=473680 $Y=930900
X928 1993 1971 1 2 2013 AN2 $T=474920 991760 1 0 $X=474920 $Y=986340
X929 2008 2013 1 2 2033 AN2 $T=477400 991760 1 0 $X=477400 $Y=986340
X930 2014 1988 1 2 2037 AN2 $T=479260 1062320 0 0 $X=479260 $Y=1061940
X931 2019 2021 1 2 2050 AN2 $T=480500 941360 0 0 $X=480500 $Y=940980
X932 2066 2073 1 2 2140 AN2 $T=487320 941360 1 0 $X=487320 $Y=935940
X933 2069 2050 1 2 2073 AN2 $T=487320 941360 0 0 $X=487320 $Y=940980
X934 2068 2033 1 2 2096 AN2 $T=491040 991760 1 0 $X=491040 $Y=986340
X935 2081 2037 1 2 2100 AN2 $T=491040 1062320 0 0 $X=491040 $Y=1061940
X936 2113 2119 1 2 2130 AN2 $T=496000 981680 1 0 $X=496000 $Y=976260
X937 2088 2100 1 2 2168 AN2 $T=496000 1062320 1 0 $X=496000 $Y=1056900
X938 2112 2130 1 2 2141 AN2 $T=498480 971600 1 0 $X=498480 $Y=966180
X939 2111 2140 1 2 2167 AN2 $T=500960 941360 1 0 $X=500960 $Y=935940
X940 2185 116 1 2 2147 AN2 $T=505300 1042160 1 180 $X=502820 $Y=1041780
X941 2169 2166 1 2 2134 AN2 $T=507160 921200 0 180 $X=504680 $Y=915780
X942 2178 2175 1 2 2119 AN2 $T=509020 981680 1 180 $X=506540 $Y=981300
X943 2131 2096 1 2 2172 AN2 $T=506540 991760 1 0 $X=506540 $Y=986340
X944 2162 2167 1 2 2170 AN2 $T=507780 941360 1 0 $X=507780 $Y=935940
X945 2148 2170 1 2 2191 AN2 $T=509640 941360 0 0 $X=509640 $Y=940980
X946 2181 2141 1 2 2192 AN2 $T=509640 961520 0 0 $X=509640 $Y=961140
X947 2160 2172 1 2 2175 AN2 $T=509640 991760 1 0 $X=509640 $Y=986340
X948 2205 2207 1 2 2164 AN2 $T=515840 951440 1 180 $X=513360 $Y=951060
X949 214 116 1 2 209 AN2 $T=517080 1062320 1 180 $X=514600 $Y=1061940
X950 2223 2216 1 2 2166 AN2 $T=517700 921200 0 180 $X=515220 $Y=915780
X951 2209 2224 1 2 2216 AN2 $T=518940 921200 1 180 $X=516460 $Y=920820
X952 2226 116 1 2 2195 AN2 $T=518940 1032080 0 180 $X=516460 $Y=1026660
X953 2217 2168 1 2 2228 AN2 $T=516460 1052240 0 0 $X=516460 $Y=1051860
X954 2235 2191 1 2 2224 AN2 $T=520800 931280 1 180 $X=518320 $Y=930900
X955 2242 2192 1 2 2207 AN2 $T=522660 961520 0 180 $X=520180 $Y=956100
X956 2254 116 1 2 2243 AN2 $T=525760 1032080 0 180 $X=523280 $Y=1026660
X957 2233 2228 1 2 2271 AN2 $T=528240 1052240 0 0 $X=528240 $Y=1051860
X958 2298 116 1 2 2273 AN2 $T=539400 1032080 1 180 $X=536920 $Y=1031700
X959 2268 2271 1 2 2313 AN2 $T=536920 1052240 1 0 $X=536920 $Y=1046820
X960 2307 2313 1 2 2334 AN2 $T=542500 1062320 1 0 $X=542500 $Y=1056900
X961 2304 116 1 2 2319 AN2 $T=548080 1032080 0 180 $X=545600 $Y=1026660
X962 2337 2334 1 2 236 AN2 $T=549940 1062320 0 180 $X=547460 $Y=1056900
X963 2345 116 1 2 2355 AN2 $T=550560 1032080 1 0 $X=550560 $Y=1026660
X964 2388 2379 1 2 2375 AN2 $T=558620 951440 0 180 $X=556140 $Y=946020
X965 2397 2393 1 2 2388 AN2 $T=561720 951440 0 180 $X=559240 $Y=946020
X966 2392 116 1 2 242 AN2 $T=561720 1062320 0 180 $X=559240 $Y=1056900
X967 2394 2403 1 2 2397 AN2 $T=563580 941360 0 180 $X=561100 $Y=935940
X968 2382 116 1 2 2376 AN2 $T=563580 1032080 1 180 $X=561100 $Y=1031700
X969 2375 2398 1 2 2422 AN2 $T=564200 961520 0 0 $X=564200 $Y=961140
X970 2422 2426 1 2 2425 AN2 $T=567920 971600 0 0 $X=567920 $Y=971220
X971 2425 2430 1 2 2451 AN2 $T=569780 981680 1 0 $X=569780 $Y=976260
X972 253 2445 1 2 2452 AN2 $T=574120 880880 1 180 $X=571640 $Y=880500
X973 2452 2450 1 2 2429 AN2 $T=572260 901040 1 0 $X=572260 $Y=895620
X974 2451 2465 1 2 2476 AN2 $T=572880 991760 0 0 $X=572880 $Y=991380
X975 2476 2478 1 2 2495 AN2 $T=577840 1001840 1 0 $X=577840 $Y=996420
X976 2495 2515 1 2 2523 AN2 $T=581560 1001840 1 0 $X=581560 $Y=996420
X977 2533 116 1 2 2484 AN2 $T=584040 1042160 1 180 $X=581560 $Y=1041780
X978 2523 2514 1 2 2521 AN2 $T=587760 981680 0 0 $X=587760 $Y=981300
X979 2521 2527 1 2 2564 AN2 $T=588380 981680 1 0 $X=588380 $Y=976260
X980 2564 2560 1 2 2583 AN2 $T=593340 991760 0 0 $X=593340 $Y=991380
X981 2586 2556 1 2 2565 AN2 $T=596440 921200 1 180 $X=593960 $Y=920820
X982 2583 2589 1 2 2595 AN2 $T=595820 991760 0 0 $X=595820 $Y=991380
X983 2520 2518 1 2 2593 AN2 $T=600160 911120 1 180 $X=597680 $Y=910740
X984 2659 282 1 2 2674 AN2 $T=610700 1052240 1 0 $X=610700 $Y=1046820
X985 2595 2642 1 2 2671 AN2 $T=611320 991760 0 0 $X=611320 $Y=991380
X986 285 287 1 2 307 AN2 $T=649760 880880 0 0 $X=649760 $Y=880500
X987 2907 2740 1 2 2921 AN2 $T=658440 941360 0 0 $X=658440 $Y=940980
X988 2962 277 1 2 2945 AN2 $T=664640 1011920 0 0 $X=664640 $Y=1011540
X989 2922 2848 1 2 2942 AN2 $T=669600 1052240 0 180 $X=667120 $Y=1046820
X990 3003 2712 1 2 3016 AN2 $T=677660 951440 1 0 $X=677660 $Y=946020
X991 3031 2892 1 2 261 AN2 $T=679520 1011920 0 0 $X=679520 $Y=1011540
X992 307 296 1 2 3125 AN2 $T=697500 880880 0 0 $X=697500 $Y=880500
X993 3125 286 1 2 333 AN2 $T=701220 880880 0 0 $X=701220 $Y=880500
X994 333 288 1 2 3205 AN2 $T=709900 880880 0 0 $X=709900 $Y=880500
X995 3187 3005 1 2 3158 AN2 $T=713000 901040 1 180 $X=710520 $Y=900660
X996 2508 2580 1 2 3188 AN2 $T=712380 921200 0 0 $X=712380 $Y=920820
X997 3200 2996 1 2 3187 AN2 $T=717340 901040 0 180 $X=714860 $Y=895620
X998 3188 2768 1 2 3201 AN2 $T=714860 921200 0 0 $X=714860 $Y=920820
X999 2901 3211 1 2 3220 AN2 $T=718580 1011920 1 0 $X=718580 $Y=1006500
X1000 3201 2665 1 2 3226 AN2 $T=719820 911120 0 0 $X=719820 $Y=910740
X1001 3209 3213 1 2 3231 AN2 $T=719820 951440 0 0 $X=719820 $Y=951060
X1002 3232 3222 1 2 3216 AN2 $T=722300 961520 1 180 $X=719820 $Y=961140
X1003 3237 2977 1 2 3200 AN2 $T=724160 901040 1 180 $X=721680 $Y=900660
X1004 3205 301 1 2 3244 AN2 $T=722920 880880 0 0 $X=722920 $Y=880500
X1005 3235 3234 1 2 3245 AN2 $T=722920 941360 1 0 $X=722920 $Y=935940
X1006 3244 304 1 2 3254 AN2 $T=724780 901040 1 0 $X=724780 $Y=895620
X1007 3226 2678 1 2 3255 AN2 $T=724780 911120 0 0 $X=724780 $Y=910740
X1008 3241 3248 1 2 3263 AN2 $T=726640 991760 1 0 $X=726640 $Y=986340
X1009 2901 3264 1 2 3196 AN2 $T=730980 1001840 0 180 $X=728500 $Y=996420
X1010 3254 311 1 2 3271 AN2 $T=729120 901040 1 0 $X=729120 $Y=895620
X1011 3255 2752 1 2 3280 AN2 $T=729740 921200 1 0 $X=729740 $Y=915780
X1012 3263 3267 1 2 3273 AN2 $T=729740 991760 1 0 $X=729740 $Y=986340
X1013 3287 2980 1 2 3237 AN2 $T=734080 901040 1 180 $X=731600 $Y=900660
X1014 3273 3277 1 2 3289 AN2 $T=731600 991760 0 0 $X=731600 $Y=991380
X1015 3280 2886 1 2 3297 AN2 $T=733460 911120 1 0 $X=733460 $Y=905700
X1016 3269 3250 1 2 3294 AN2 $T=733460 921200 0 0 $X=733460 $Y=920820
X1017 3283 3286 1 2 351 AN2 $T=737800 880880 1 180 $X=735320 $Y=880500
X1018 3271 3061 1 2 3287 AN2 $T=737800 901040 0 180 $X=735320 $Y=895620
X1019 3261 3272 1 2 3317 AN2 $T=737180 981680 1 0 $X=737180 $Y=976260
X1020 3297 2929 1 2 3320 AN2 $T=740280 921200 0 0 $X=740280 $Y=920820
X1021 3298 3321 1 2 3365 AN2 $T=740280 961520 0 0 $X=740280 $Y=961140
X1022 3317 3322 1 2 3340 AN2 $T=740280 981680 1 0 $X=740280 $Y=976260
X1023 3324 3304 1 2 3329 AN2 $T=742140 1052240 0 0 $X=742140 $Y=1051860
X1024 356 3305 1 2 3327 AN2 $T=744620 1062320 1 180 $X=742140 $Y=1061940
X1025 3320 2917 1 2 3332 AN2 $T=743380 921200 0 0 $X=743380 $Y=920820
X1026 3333 2988 1 2 3352 AN2 $T=743380 941360 0 0 $X=743380 $Y=940980
X1027 3332 2976 1 2 3366 AN2 $T=745240 911120 0 0 $X=745240 $Y=910740
X1028 3366 2994 1 2 3379 AN2 $T=750200 911120 0 0 $X=750200 $Y=910740
X1029 3379 3068 1 2 3333 AN2 $T=752680 921200 1 180 $X=750200 $Y=920820
X1030 3442 3422 1 2 3454 AN2 $T=767560 1042160 0 0 $X=767560 $Y=1041780
X1031 3513 3495 1 2 3517 AN2 $T=784920 1052240 1 0 $X=784920 $Y=1046820
X1032 3550 3543 1 2 353 AN2 $T=796080 1032080 0 180 $X=793600 $Y=1026660
X1033 3550 406 1 2 3350 AN2 $T=797940 1011920 1 180 $X=795460 $Y=1011540
X1034 3559 3550 1 2 3546 AN2 $T=801040 961520 0 180 $X=798560 $Y=956100
X1035 3573 3543 1 2 361 AN2 $T=802900 1022000 1 180 $X=800420 $Y=1021620
X1036 3587 406 1 2 3354 AN2 $T=805380 1022000 1 180 $X=802900 $Y=1021620
X1037 3587 3543 1 2 363 AN2 $T=805380 1032080 1 180 $X=802900 $Y=1031700
X1038 3581 3588 1 2 3554 AN2 $T=806000 1052240 1 180 $X=803520 $Y=1051860
X1039 3559 3596 1 2 3537 AN2 $T=806620 981680 1 0 $X=806620 $Y=976260
X1040 3596 406 1 2 3358 AN2 $T=806620 1011920 1 0 $X=806620 $Y=1006500
X1041 3593 3573 1 2 3399 AN2 $T=807240 991760 0 0 $X=807240 $Y=991380
X1042 3559 3587 1 2 3534 AN2 $T=807860 971600 0 0 $X=807860 $Y=971220
X1043 406 3573 1 2 3351 AN2 $T=807860 1032080 1 0 $X=807860 $Y=1026660
X1044 3593 3587 1 2 3421 AN2 $T=810340 981680 1 0 $X=810340 $Y=976260
X1045 3621 3609 1 2 3624 AN2 $T=813440 1052240 0 0 $X=813440 $Y=1051860
X1046 3700 3695 1 2 3683 AN2 $T=831420 1052240 0 180 $X=828940 $Y=1046820
X1047 3758 447 1 2 3751 AN2 $T=850640 1062320 1 180 $X=848160 $Y=1061940
X1048 3791 3797 1 2 3813 AN2 $T=861180 1062320 1 0 $X=861180 $Y=1056900
X1049 3865 3860 1 2 3854 AN2 $T=882880 1052240 1 180 $X=880400 $Y=1051860
X1050 3907 3899 1 2 3890 AN2 $T=892800 1052240 0 180 $X=890320 $Y=1046820
X1051 4052 4018 1 2 4066 AN2 $T=937440 1052240 1 0 $X=937440 $Y=1046820
X1052 4071 4050 1 2 4053 AN2 $T=941160 1062320 1 180 $X=938680 $Y=1061940
X1053 4109 4045 1 2 4112 AN2 $T=951080 1042160 0 0 $X=951080 $Y=1041780
X1054 4194 4196 1 2 4214 AN2 $T=980840 1052240 0 0 $X=980840 $Y=1051860
X1055 4181 526 1 2 4205 AN2 $T=980840 1062320 0 0 $X=980840 $Y=1061940
X1056 4246 4231 1 2 4229 AN2 $T=995720 1042160 1 180 $X=993240 $Y=1041780
X1057 541 4285 1 2 4287 AN2 $T=1016800 1062320 1 0 $X=1016800 $Y=1056900
X1058 4329 4345 1 2 4319 AN2 $T=1034780 1042160 1 180 $X=1032300 $Y=1041780
X1059 4339 4365 1 2 4357 AN2 $T=1039740 1062320 1 180 $X=1037260 $Y=1061940
X1060 4431 4425 1 2 4415 AN2 $T=1060820 1052240 0 180 $X=1058340 $Y=1046820
X1061 4433 4454 1 2 4461 AN2 $T=1068260 1052240 0 0 $X=1068260 $Y=1051860
X1062 2825 2828 1 2 INV4CK $T=639220 981680 0 0 $X=639220 $Y=981300
X1063 3519 3291 1 2 INV4CK $T=785540 1022000 1 0 $X=785540 $Y=1016580
X1064 3586 3591 1 2 INV4CK $T=804760 961520 0 0 $X=804760 $Y=961140
X1065 3626 3282 1 2 INV4CK $T=819020 1042160 0 0 $X=819020 $Y=1041780
X1066 3694 441 1 2 INV4CK $T=830180 880880 0 0 $X=830180 $Y=880500
X1067 3681 405 1 2 INV4CK $T=831420 890960 0 0 $X=831420 $Y=890580
X1068 3583 3278 1 2 INV4CK $T=836380 1042160 1 180 $X=832660 $Y=1041780
X1069 3806 3395 1 2 INV4CK $T=866760 1022000 0 180 $X=863040 $Y=1016580
X1070 3750 3523 1 2 INV4CK $T=876680 981680 1 0 $X=876680 $Y=976260
X1071 3903 3711 1 2 INV4CK $T=893420 911120 0 180 $X=889700 $Y=905700
X1072 3960 3956 1 2 INV4CK $T=913880 1022000 0 180 $X=910160 $Y=1016580
X1073 3952 3975 1 2 INV4CK $T=920080 1042160 0 180 $X=916360 $Y=1036740
X1074 3999 4005 1 2 INV4CK $T=928140 901040 0 180 $X=924420 $Y=895620
X1075 3985 4010 1 2 INV4CK $T=945500 991760 0 0 $X=945500 $Y=991380
X1076 4005 4000 1 2 INV4CK $T=951080 951440 0 180 $X=947360 $Y=946020
X1077 3997 4051 1 2 INV4CK $T=956040 961520 0 180 $X=952320 $Y=956100
X1078 508 492 1 2 INV4CK $T=953560 1042160 0 0 $X=953560 $Y=1041780
X1079 4062 4019 1 2 INV4CK $T=959140 991760 0 0 $X=959140 $Y=991380
X1080 3937 4107 1 2 INV4CK $T=968440 941360 0 180 $X=964720 $Y=935940
X1081 4121 506 1 2 INV4CK $T=975260 1052240 0 180 $X=971540 $Y=1046820
X1082 4171 4037 1 2 INV4CK $T=990140 1032080 0 0 $X=990140 $Y=1031700
X1083 959 843 1 2 INV2CK $T=280860 971600 0 0 $X=280860 $Y=971220
X1084 2107 2103 1 2 INV2CK $T=495380 1022000 0 180 $X=492900 $Y=1016580
X1085 2535 2540 1 2 INV2CK $T=585280 971600 0 0 $X=585280 $Y=971220
X1086 3398 3389 1 2 INV2CK $T=758880 981680 0 180 $X=756400 $Y=976260
X1087 3432 3437 1 2 INV2CK $T=765080 1042160 0 0 $X=765080 $Y=1041780
X1088 3501 3401 1 2 INV2CK $T=781820 961520 0 0 $X=781820 $Y=961140
X1089 3468 3486 1 2 INV2CK $T=790500 1062320 0 0 $X=790500 $Y=1061940
X1090 3492 3519 1 2 INV2CK $T=797940 1011920 0 180 $X=795460 $Y=1006500
X1091 3566 3583 1 2 INV2CK $T=803520 1042160 0 0 $X=803520 $Y=1041780
X1092 3603 3626 1 2 INV2CK $T=815300 1032080 0 0 $X=815300 $Y=1031700
X1093 3727 3731 1 2 INV2CK $T=840720 991760 0 180 $X=838240 $Y=986340
X1094 3679 3694 1 2 INV2CK $T=840100 901040 0 0 $X=840100 $Y=900660
X1095 3782 3806 1 2 INV2CK $T=863040 961520 0 0 $X=863040 $Y=961140
X1096 3809 3819 1 2 INV2CK $T=867380 901040 0 0 $X=867380 $Y=900660
X1097 473 472 1 2 INV2CK $T=899000 880880 1 180 $X=896520 $Y=880500
X1098 3863 3903 1 2 INV2CK $T=902100 921200 0 180 $X=899620 $Y=915780
X1099 3935 3937 1 2 INV2CK $T=903960 951440 0 0 $X=903960 $Y=951060
X1100 3953 3952 1 2 INV2CK $T=912640 1032080 0 180 $X=910160 $Y=1026660
X1101 3939 3985 1 2 INV2CK $T=919460 1001840 0 0 $X=919460 $Y=1001460
X1102 4028 494 1 2 INV2CK $T=932480 1062320 0 0 $X=932480 $Y=1061940
X1103 4008 4062 1 2 INV2CK $T=941160 981680 0 180 $X=938680 $Y=976260
X1104 4065 4084 1 2 INV2CK $T=941780 1022000 0 0 $X=941780 $Y=1021620
X1105 4079 4081 1 2 INV2CK $T=949220 911120 0 0 $X=949220 $Y=910740
X1106 4106 4121 1 2 INV2CK $T=954180 1032080 0 0 $X=954180 $Y=1031700
X1107 4047 3960 1 2 INV2CK $T=959140 1001840 0 0 $X=959140 $Y=1001460
X1108 4176 4171 1 2 INV2CK $T=973400 1011920 0 180 $X=970920 $Y=1006500
X1109 1611 1 2 1828 DELC $T=440200 901040 0 0 $X=440200 $Y=900660
X1110 201 1 2 2198 DELC $T=509020 880880 0 0 $X=509020 $Y=880500
X1111 197 1 2 2203 DELC $T=513980 880880 0 0 $X=513980 $Y=880500
X1112 1677 1 2 2238 DELC $T=517700 911120 0 0 $X=517700 $Y=910740
X1113 2241 1 2 223 DELC $T=522660 911120 0 0 $X=522660 $Y=910740
X1114 2265 1 2 224 DELC $T=527620 911120 0 0 $X=527620 $Y=910740
X1115 231 1 2 2287 DELC $T=530720 880880 0 0 $X=530720 $Y=880500
X1116 1592 1 2 2261 DELC $T=532580 911120 0 0 $X=532580 $Y=910740
X1117 1650 1 2 2303 DELC $T=536300 890960 0 0 $X=536300 $Y=890580
X1118 2295 1 2 2293 DELC $T=538160 991760 0 0 $X=538160 $Y=991380
X1119 2188 1 2 2305 DELC $T=540020 921200 1 0 $X=540020 $Y=915780
X1120 239 1 2 2329 DELC $T=541260 890960 0 0 $X=541260 $Y=890580
X1121 2311 1 2 2306 DELC $T=541880 971600 1 0 $X=541880 $Y=966180
X1122 2320 1 2 2274 DELC $T=543120 991760 0 0 $X=543120 $Y=991380
X1123 2318 1 2 2291 DELC $T=543120 1011920 0 0 $X=543120 $Y=1011540
X1124 1761 1 2 2326 DELC $T=544980 921200 1 0 $X=544980 $Y=915780
X1125 2202 1 2 2350 DELC $T=546220 890960 0 0 $X=546220 $Y=890580
X1126 2338 1 2 2349 DELC $T=548080 941360 0 0 $X=548080 $Y=940980
X1127 2062 1 2 2351 DELC $T=551180 890960 0 0 $X=551180 $Y=890580
X1128 1665 1 2 2358 DELC $T=552420 921200 1 0 $X=552420 $Y=915780
X1129 2362 1 2 2384 DELC $T=554280 991760 0 0 $X=554280 $Y=991380
X1130 2179 1 2 2378 DELC $T=557380 921200 1 0 $X=557380 $Y=915780
X1131 2151 1 2 2385 DELC $T=558000 890960 0 0 $X=558000 $Y=890580
X1132 2380 1 2 245 DELC $T=559240 991760 0 0 $X=559240 $Y=991380
X1133 2234 1 2 2404 DELC $T=562960 890960 0 0 $X=562960 $Y=890580
X1134 2383 1 2 2371 DELC $T=562960 1011920 1 0 $X=562960 $Y=1006500
X1135 2144 1 2 2410 DELC $T=567920 890960 0 0 $X=567920 $Y=890580
X1136 2443 1 2 2442 DELC $T=570400 1022000 1 0 $X=570400 $Y=1016580
X1137 2453 1 2 2395 DELC $T=572260 1001840 0 0 $X=572260 $Y=1001460
X1138 2533 1 2 2529 DELC $T=586520 1042160 1 0 $X=586520 $Y=1036740
X1139 2561 1 2 2578 DELC $T=590240 1011920 1 0 $X=590240 $Y=1006500
X1140 270 1 2 2544 DELC $T=591480 1052240 1 0 $X=591480 $Y=1046820
X1141 2598 1 2 2522 DELC $T=598300 991760 0 0 $X=598300 $Y=991380
X1142 2627 1 2 2622 DELC $T=604500 1001840 0 0 $X=604500 $Y=1001460
X1143 2629 1 2 2602 DELC $T=605120 1042160 1 0 $X=605120 $Y=1036740
X1144 2635 1 2 2597 DELC $T=605740 1032080 1 0 $X=605740 $Y=1026660
X1145 2654 1 2 2618 DELC $T=609460 1001840 0 0 $X=609460 $Y=1001460
X1146 2834 1 2 2758 DELC $T=642940 981680 0 0 $X=642940 $Y=981300
X1147 2900 1 2 2824 DELC $T=654100 981680 0 0 $X=654100 $Y=981300
X1148 3023 1 2 2962 DELC $T=677660 1001840 0 0 $X=677660 $Y=1001460
X1149 3430 1 2 3453 DELC $T=765080 961520 0 0 $X=765080 $Y=961140
X1150 3508 1 2 3511 DELC $T=784300 1011920 1 0 $X=784300 $Y=1006500
X1151 3531 1 2 3520 DELC $T=790500 1042160 1 0 $X=790500 $Y=1036740
X1152 3545 1 2 3497 DELC $T=794840 961520 0 0 $X=794840 $Y=961140
X1153 3618 1 2 3631 DELC $T=812200 961520 0 0 $X=812200 $Y=961140
X1154 3617 1 2 3633 DELC $T=812820 941360 1 0 $X=812820 $Y=935940
X1155 3622 1 2 3636 DELC $T=814060 911120 0 0 $X=814060 $Y=910740
X1156 3652 1 2 3592 DELC $T=823360 1022000 0 0 $X=823360 $Y=1021620
X1157 3686 1 2 3553 DELC $T=827700 1042160 0 0 $X=827700 $Y=1041780
X1158 3712 1 2 3714 DELC $T=835140 971600 0 0 $X=835140 $Y=971220
X1159 3715 1 2 3717 DELC $T=835760 961520 1 0 $X=835760 $Y=956100
X1160 3719 1 2 3660 DELC $T=836380 911120 0 0 $X=836380 $Y=910740
X1161 3770 1 2 3785 DELC $T=854980 931280 0 0 $X=854980 $Y=930900
X1162 3779 1 2 3772 DELC $T=858080 991760 0 0 $X=858080 $Y=991380
X1163 3827 1 2 3792 DELC $T=872340 951440 0 0 $X=872340 $Y=951060
X1164 3839 1 2 3821 DELC $T=876060 911120 0 0 $X=876060 $Y=910740
X1165 3855 1 2 3874 DELC $T=880400 941360 1 0 $X=880400 $Y=935940
X1166 3870 1 2 474 DELC $T=895900 890960 1 0 $X=895900 $Y=885540
X1167 3967 1 2 3928 DELC $T=916360 981680 1 0 $X=916360 $Y=976260
X1168 3968 1 2 3929 DELC $T=917600 991760 0 0 $X=917600 $Y=991380
X1169 3972 1 2 3963 DELC $T=918220 921200 1 0 $X=918220 $Y=915780
X1170 3984 1 2 4001 DELC $T=920700 991760 1 0 $X=920700 $Y=986340
X1171 3991 1 2 3976 DELC $T=921940 941360 1 0 $X=921940 $Y=935940
X1172 4033 1 2 3983 DELC $T=934340 971600 0 0 $X=934340 $Y=971220
X1173 4048 1 2 3995 DELC $T=936820 1022000 1 0 $X=936820 $Y=1016580
X1174 4013 1 2 4039 DELC $T=937440 931280 1 0 $X=937440 $Y=925860
X1175 4022 1 2 4090 DELC $T=944260 911120 0 0 $X=944260 $Y=910740
X1176 4093 1 2 4017 DELC $T=945500 1042160 0 0 $X=945500 $Y=1041780
X1177 4074 1 2 4030 DELC $T=948600 1011920 1 0 $X=948600 $Y=1006500
X1178 4076 1 2 4099 DELC $T=949840 1052240 0 0 $X=949840 $Y=1051860
X1179 4141 1 2 4125 DELC $T=963480 1062320 1 0 $X=963480 $Y=1056900
X1180 4155 1 2 4044 DELC $T=967820 1032080 0 0 $X=967820 $Y=1031700
X1181 4185 1 2 4143 DELC $T=978360 931280 1 0 $X=978360 $Y=925860
X1182 4186 1 2 4204 DELC $T=982080 1032080 0 0 $X=982080 $Y=1031700
X1183 264 274 1 2 2598 QDBHN $T=591480 981680 0 0 $X=591480 $Y=981300
X1184 264 2808 1 2 2834 QDBHN $T=633640 991760 0 0 $X=633640 $Y=991380
X1185 264 2808 1 2 2900 QDBHN $T=647280 971600 0 0 $X=647280 $Y=971220
X1186 277 3000 1 2 3023 QDBHN $T=670840 1011920 0 0 $X=670840 $Y=1011540
X1187 264 3404 1 2 375 QDBHN $T=757640 1062320 0 0 $X=757640 $Y=1061940
X1188 264 3467 1 2 3430 QDBHN $T=770040 961520 0 0 $X=770040 $Y=961140
X1189 264 3528 1 2 3508 QDBHN $T=791740 1001840 0 180 $X=784300 $Y=996420
X1190 264 3527 1 2 3531 QDBHN $T=785540 1052240 0 0 $X=785540 $Y=1051860
X1191 264 3530 1 2 3545 QDBHN $T=788020 971600 0 0 $X=788020 $Y=971220
X1192 264 3604 1 2 411 QDBHN $T=812200 1062320 0 180 $X=804760 $Y=1056900
X1193 414 327 1 2 3617 QDBHN $T=806620 931280 0 0 $X=806620 $Y=930900
X1194 264 3625 1 2 3652 QDBHN $T=813440 1022000 0 0 $X=813440 $Y=1021620
X1195 414 3646 1 2 3618 QDBHN $T=817160 961520 0 0 $X=817160 $Y=961140
X1196 264 3668 1 2 3686 QDBHN $T=821500 1032080 0 0 $X=821500 $Y=1031700
X1197 414 440 1 2 3719 QDBHN $T=828940 911120 0 0 $X=828940 $Y=910740
X1198 414 440 1 2 3622 QDBHN $T=828940 921200 0 0 $X=828940 $Y=920820
X1199 3708 3740 1 2 3715 QDBHN $T=847540 951440 0 180 $X=840100 $Y=946020
X1200 3708 3747 1 2 3712 QDBHN $T=850640 971600 0 180 $X=843200 $Y=966180
X1201 414 3745 1 2 3770 QDBHN $T=843820 921200 0 0 $X=843820 $Y=920820
X1202 3708 3807 1 2 3779 QDBHN $T=861180 981680 0 0 $X=861180 $Y=981300
X1203 414 3842 1 2 3839 QDBHN $T=873580 911120 1 0 $X=873580 $Y=905700
X1204 3708 3850 1 2 3827 QDBHN $T=881020 961520 0 180 $X=873580 $Y=956100
X1205 414 327 1 2 3855 QDBHN $T=887840 931280 0 180 $X=880400 $Y=925860
X1206 468 466 1 2 3870 QDBHN $T=892180 890960 0 180 $X=884740 $Y=885540
X1207 3708 3467 1 2 3967 QDBHN $T=908300 971600 0 0 $X=908300 $Y=971220
X1208 3708 3807 1 2 3968 QDBHN $T=908300 991760 0 0 $X=908300 $Y=991380
X1209 414 3745 1 2 3972 QDBHN $T=913260 911120 0 0 $X=913260 $Y=910740
X1210 3708 3747 1 2 3984 QDBHN $T=913260 981680 0 0 $X=913260 $Y=981300
X1211 414 3740 1 2 3991 QDBHN $T=915120 941360 0 0 $X=915120 $Y=940980
X1212 3708 3530 1 2 4033 QDBHN $T=929380 971600 1 0 $X=929380 $Y=966180
X1213 414 3646 1 2 4013 QDBHN $T=937440 931280 0 180 $X=930000 $Y=925860
X1214 3708 3668 1 2 4048 QDBHN $T=930620 1011920 0 0 $X=930620 $Y=1011540
X1215 414 3850 1 2 4022 QDBHN $T=938680 911120 0 180 $X=931240 $Y=905700
X1216 3708 478 1 2 4076 QDBHN $T=934340 1052240 0 0 $X=934340 $Y=1051860
X1217 3708 3604 1 2 4093 QDBHN $T=938060 1042160 0 0 $X=938060 $Y=1041780
X1218 3708 3528 1 2 4074 QDBHN $T=948600 1011920 0 180 $X=941160 $Y=1006500
X1219 3708 3527 1 2 4141 QDBHN $T=955420 1052240 0 0 $X=955420 $Y=1051860
X1220 3708 3404 1 2 4155 QDBHN $T=960380 1032080 0 0 $X=960380 $Y=1031700
X1221 414 3842 1 2 4185 QDBHN $T=972780 921200 0 0 $X=972780 $Y=920820
X1222 3708 3625 1 2 4186 QDBHN $T=986420 1032080 0 180 $X=978980 $Y=1026660
X1223 657 9 662 1 2 AN2T $T=233120 991760 1 0 $X=233120 $Y=986340
X1224 1625 1605 1571 1 2 AN2T $T=407960 911120 1 180 $X=403620 $Y=910740
X1225 1635 143 1544 1 2 AN2T $T=410440 981680 1 0 $X=410440 $Y=976260
X1226 1736 148 1550 1 2 AN2T $T=427800 921200 0 0 $X=427800 $Y=920820
X1227 2522 264 2535 1 2 AN2T $T=583420 981680 0 0 $X=583420 $Y=981300
X1228 2758 264 2759 1 2 AN2T $T=625580 991760 0 0 $X=625580 $Y=991380
X1229 2818 2826 2853 1 2 AN2T $T=638600 1022000 0 0 $X=638600 $Y=1021620
X1230 2824 264 2825 1 2 AN2T $T=639220 971600 0 0 $X=639220 $Y=971220
X1231 383 264 3468 1 2 AN2T $T=768800 1062320 0 0 $X=768800 $Y=1061940
X1232 3453 264 3398 1 2 AN2T $T=770040 971600 0 0 $X=770040 $Y=971220
X1233 3511 264 3492 1 2 AN2T $T=781820 1011920 0 180 $X=777480 $Y=1006500
X1234 3497 264 3501 1 2 AN2T $T=779960 971600 0 0 $X=779960 $Y=971220
X1235 3520 264 3432 1 2 AN2T $T=785540 1042160 0 0 $X=785540 $Y=1041780
X1236 3553 264 3566 1 2 AN2T $T=797320 1032080 0 0 $X=797320 $Y=1031700
X1237 3592 264 3603 1 2 AN2T $T=805380 1022000 0 0 $X=805380 $Y=1021620
X1238 428 264 425 1 2 AN2T $T=820260 1062320 0 180 $X=815920 $Y=1056900
X1239 3633 414 3638 1 2 AN2T $T=822120 941360 0 180 $X=817780 $Y=935940
X1240 3636 414 3671 1 2 AN2T $T=820880 921200 0 0 $X=820880 $Y=920820
X1241 3660 414 3679 1 2 AN2T $T=822120 901040 0 0 $X=822120 $Y=900660
X1242 3631 414 3586 1 2 AN2T $T=828320 961520 0 0 $X=828320 $Y=961140
X1243 3717 3708 3703 1 2 AN2T $T=836380 951440 0 180 $X=832040 $Y=946020
X1244 3714 3708 3727 1 2 AN2T $T=835140 971600 1 0 $X=835140 $Y=966180
X1245 3785 414 3774 1 2 AN2T $T=859320 921200 1 180 $X=854980 $Y=920820
X1246 3792 3708 3775 1 2 AN2T $T=859320 951440 0 180 $X=854980 $Y=946020
X1247 3772 3708 3782 1 2 AN2T $T=854980 971600 1 0 $X=854980 $Y=966180
X1248 3821 3708 3809 1 2 AN2T $T=867380 911120 1 180 $X=863040 $Y=910740
X1249 3874 414 3863 1 2 AN2T $T=885980 921200 0 180 $X=881640 $Y=915780
X1250 3928 3708 3935 1 2 AN2T $T=901480 961520 0 0 $X=901480 $Y=961140
X1251 3929 3708 3939 1 2 AN2T $T=901480 1001840 0 0 $X=901480 $Y=1001460
X1252 3963 3708 3973 1 2 AN2T $T=914500 921200 0 0 $X=914500 $Y=920820
X1253 3976 3708 3898 1 2 AN2T $T=919460 931280 1 180 $X=915120 $Y=930900
X1254 3983 3708 3978 1 2 AN2T $T=920080 971600 0 0 $X=920080 $Y=971220
X1255 3995 3708 3953 1 2 AN2T $T=923800 1022000 0 0 $X=923800 $Y=1021620
X1256 4039 3708 3999 1 2 AN2T $T=928760 921200 0 180 $X=924420 $Y=915780
X1257 4001 3708 4008 1 2 AN2T $T=930620 991760 0 180 $X=926280 $Y=986340
X1258 4017 3708 4028 1 2 AN2T $T=930000 1042160 0 0 $X=930000 $Y=1041780
X1259 4030 3708 4047 1 2 AN2T $T=933100 1001840 0 0 $X=933100 $Y=1001460
X1260 4044 3708 4065 1 2 AN2T $T=936200 1032080 0 0 $X=936200 $Y=1031700
X1261 4090 3708 4079 1 2 AN2T $T=945500 921200 0 180 $X=941160 $Y=915780
X1262 4099 3708 4106 1 2 AN2T $T=945500 1052240 0 0 $X=945500 $Y=1051860
X1263 4125 3708 510 1 2 AN2T $T=955420 1062320 0 0 $X=955420 $Y=1061940
X1264 4143 414 4151 1 2 AN2T $T=964720 931280 1 0 $X=964720 $Y=925860
X1265 4204 3708 4176 1 2 AN2T $T=983320 1022000 0 180 $X=978980 $Y=1016580
X1266 2407 1 2 2408 DELA $T=574740 901040 1 0 $X=574740 $Y=895620
X1267 2475 1 2 2494 DELA $T=575360 981680 0 0 $X=575360 $Y=981300
X1268 2541 1 2 2634 DELA $T=602640 1011920 1 0 $X=602640 $Y=1006500
X1269 2683 1 2 2716 DELA $T=613800 1032080 1 0 $X=613800 $Y=1026660
X1270 2616 1 2 2664 DELA $T=614420 1001840 0 0 $X=614420 $Y=1001460
X1271 2785 1 2 2811 DELA $T=634260 1032080 0 0 $X=634260 $Y=1031700
X1272 2779 1 2 297 DELA $T=634260 1062320 0 0 $X=634260 $Y=1061940
X1273 3104 1 2 3071 DELA $T=695640 1032080 1 0 $X=695640 $Y=1026660
X1274 330 1 2 3111 DELA $T=698740 1062320 0 0 $X=698740 $Y=1061940
X1275 3134 1 2 3166 DELA $T=713620 1032080 0 0 $X=713620 $Y=1031700
X1276 3199 1 2 3217 DELA $T=719820 1052240 1 0 $X=719820 $Y=1046820
X1277 706 5 641 2 617 619 1 AO22 $T=229400 961520 0 180 $X=224440 $Y=956100
X1278 655 619 616 2 630 5 1 AO22 $T=230640 921200 0 180 $X=225680 $Y=915780
X1279 663 8 621 2 631 5 1 AO22 $T=231260 890960 1 180 $X=226300 $Y=890580
X1280 664 619 623 2 633 5 1 AO22 $T=231260 931280 1 180 $X=226300 $Y=930900
X1281 673 619 624 2 634 5 1 AO22 $T=231260 941360 1 180 $X=226300 $Y=940980
X1282 671 619 622 2 632 5 1 AO22 $T=231880 901040 1 180 $X=226920 $Y=900660
X1283 11 8 620 2 6 5 1 AO22 $T=232500 880880 1 180 $X=227540 $Y=880500
X1284 677 619 625 2 637 5 1 AO22 $T=232500 981680 0 180 $X=227540 $Y=976260
X1285 679 619 626 2 638 5 1 AO22 $T=232500 991760 1 180 $X=227540 $Y=991380
X1286 683 619 627 2 651 5 1 AO22 $T=233120 1001840 1 180 $X=228160 $Y=1001460
X1287 690 670 629 2 648 5 1 AO22 $T=233120 1042160 1 180 $X=228160 $Y=1041780
X1288 696 670 647 2 654 5 1 AO22 $T=233740 1032080 1 180 $X=228780 $Y=1031700
X1289 730 5 689 2 653 670 1 AO22 $T=239320 1022000 1 180 $X=234360 $Y=1021620
X1290 767 670 693 2 733 5 1 AO22 $T=244280 1032080 0 180 $X=239320 $Y=1026660
X1291 776 670 731 2 698 5 1 AO22 $T=248000 1052240 0 180 $X=243040 $Y=1046820
X1292 703 768 774 2 790 27 1 AO22 $T=246760 1022000 1 0 $X=246760 $Y=1016580
X1293 782 768 785 2 781 27 1 AO22 $T=249860 1001840 0 0 $X=249860 $Y=1001460
X1294 25 815 768 2 824 27 1 AO22 $T=251720 1011920 0 0 $X=251720 $Y=1011540
X1295 825 768 766 2 820 27 1 AO22 $T=254820 991760 1 0 $X=254820 $Y=986340
X1296 832 768 838 2 840 27 1 AO22 $T=255440 1001840 0 0 $X=255440 $Y=1001460
X1297 31 807 32 2 828 38 1 AO22 $T=256060 880880 0 0 $X=256060 $Y=880500
X1298 864 877 768 2 893 27 1 AO22 $T=265360 1001840 0 0 $X=265360 $Y=1001460
X1299 890 27 905 2 913 768 1 AO22 $T=267840 1011920 1 0 $X=267840 $Y=1006500
X1300 853 768 909 2 914 27 1 AO22 $T=267840 1011920 0 0 $X=267840 $Y=1011540
X1301 987 768 975 2 919 27 1 AO22 $T=286440 991760 0 180 $X=281480 $Y=986340
X1302 995 768 985 2 948 27 1 AO22 $T=288300 1011920 1 180 $X=283340 $Y=1011540
X1303 1041 768 971 2 1005 27 1 AO22 $T=295740 1001840 0 180 $X=290780 $Y=996420
X1304 1050 32 1035 2 865 38 1 AO22 $T=296980 921200 0 180 $X=292020 $Y=915780
X1305 1061 768 1038 2 1004 27 1 AO22 $T=299460 981680 1 180 $X=294500 $Y=981300
X1306 1086 32 1024 2 1027 38 1 AO22 $T=300700 890960 1 180 $X=295740 $Y=890580
X1307 1058 768 1054 2 1022 27 1 AO22 $T=300700 961520 1 180 $X=295740 $Y=961140
X1308 1059 32 1060 2 961 38 1 AO22 $T=302560 901040 1 180 $X=297600 $Y=900660
X1309 1065 32 1048 2 993 38 1 AO22 $T=303800 911120 1 180 $X=298840 $Y=910740
X1310 1052 80 1101 2 1099 1114 1 AO22 $T=306280 1042160 1 0 $X=306280 $Y=1036740
X1311 1053 80 1133 2 1148 1114 1 AO22 $T=311860 1022000 0 0 $X=311860 $Y=1021620
X1312 86 1181 1191 2 1194 1200 1 AO22 $T=319300 890960 0 0 $X=319300 $Y=890580
X1313 1175 1181 1145 2 1167 1200 1 AO22 $T=319300 901040 1 0 $X=319300 $Y=895620
X1314 1122 80 1153 2 1208 1114 1 AO22 $T=321160 1052240 0 0 $X=321160 $Y=1051860
X1315 1254 80 1240 2 1232 1114 1 AO22 $T=332320 1052240 1 180 $X=327360 $Y=1051860
X1316 1269 80 1250 2 1239 1114 1 AO22 $T=333560 1042160 0 180 $X=328600 $Y=1036740
X1317 1273 80 1212 2 1235 1114 1 AO22 $T=338520 1022000 0 180 $X=333560 $Y=1016580
X1318 1281 80 1249 2 1268 1114 1 AO22 $T=339140 1032080 0 180 $X=334180 $Y=1026660
X1319 100 1181 1270 2 1251 1294 1 AO22 $T=334800 890960 1 0 $X=334800 $Y=885540
X1320 1325 80 1267 2 1298 1114 1 AO22 $T=344720 1011920 0 180 $X=339760 $Y=1006500
X1321 1344 80 1310 2 1304 1114 1 AO22 $T=345960 1001840 0 180 $X=341000 $Y=996420
X1322 106 1181 1275 2 1300 1294 1 AO22 $T=346580 901040 1 180 $X=341620 $Y=900660
X1323 1380 1181 1301 2 1302 1348 1 AO22 $T=354020 941360 1 180 $X=349060 $Y=940980
X1324 1367 80 1324 2 1311 1348 1 AO22 $T=354020 981680 0 180 $X=349060 $Y=976260
X1325 1377 1181 1363 2 1280 1294 1 AO22 $T=355260 921200 1 180 $X=350300 $Y=920820
X1326 1375 1181 1368 2 1309 1294 1 AO22 $T=355880 901040 0 180 $X=350920 $Y=895620
X1327 1373 1181 1346 2 1318 1348 1 AO22 $T=356500 941360 0 180 $X=351540 $Y=935940
X1328 109 1181 1351 2 1319 1294 1 AO22 $T=357740 890960 0 180 $X=352780 $Y=885540
X1329 1402 1181 1317 2 1332 1294 1 AO22 $T=357740 911120 1 180 $X=352780 $Y=910740
X1330 1358 80 1335 2 1345 1348 1 AO22 $T=357740 951440 1 180 $X=352780 $Y=951060
X1331 1371 80 1354 2 1321 1348 1 AO22 $T=357740 971600 0 180 $X=352780 $Y=966180
X1332 1388 1181 1313 2 1361 1294 1 AO22 $T=358980 911120 0 180 $X=354020 $Y=905700
X1333 1374 75 1445 2 117 113 1 AO22 $T=371380 971600 1 0 $X=371380 $Y=966180
X1334 1474 125 1501 2 1507 126 1 AO22 $T=385020 1052240 1 0 $X=385020 $Y=1046820
X1335 1470 125 1527 2 1535 126 1 AO22 $T=390600 1052240 0 0 $X=390600 $Y=1051860
X1336 1479 1523 1534 2 1544 129 1 AO22 $T=391840 991760 0 0 $X=391840 $Y=991380
X1337 1508 1523 1538 2 1549 129 1 AO22 $T=392460 971600 1 0 $X=392460 $Y=966180
X1338 1515 1543 1542 2 1560 1568 1 AO22 $T=393700 941360 0 0 $X=393700 $Y=940980
X1339 1509 1543 1581 2 1552 1568 1 AO22 $T=399280 931280 1 0 $X=399280 $Y=925860
X1340 1593 1543 1588 2 1582 1568 1 AO22 $T=404860 941360 1 180 $X=399900 $Y=940980
X1341 1528 1543 1608 2 1617 1568 1 AO22 $T=405480 931280 1 0 $X=405480 $Y=925860
X1342 1562 122 1609 2 1630 126 1 AO22 $T=406720 1042160 1 0 $X=406720 $Y=1036740
X1343 140 125 1619 2 142 126 1 AO22 $T=406720 1062320 0 0 $X=406720 $Y=1061940
X1344 1599 1523 1604 2 1632 129 1 AO22 $T=408580 981680 0 0 $X=408580 $Y=981300
X1345 1580 1543 1652 2 1643 1568 1 AO22 $T=411680 921200 0 0 $X=411680 $Y=920820
X1346 1623 1523 1639 2 1657 129 1 AO22 $T=411680 991760 0 0 $X=411680 $Y=991380
X1347 1620 1543 1655 2 1640 1568 1 AO22 $T=414160 941360 0 0 $X=414160 $Y=940980
X1348 1670 1523 1679 2 1696 129 1 AO22 $T=418500 1001840 1 0 $X=418500 $Y=996420
X1349 1684 1543 1713 2 1717 1568 1 AO22 $T=421600 941360 0 0 $X=421600 $Y=940980
X1350 1707 1523 1734 2 1758 129 1 AO22 $T=428420 1001840 1 0 $X=428420 $Y=996420
X1351 1716 1747 1543 2 1759 1568 1 AO22 $T=429040 941360 0 0 $X=429040 $Y=940980
X1352 1774 1523 1785 2 1775 129 1 AO22 $T=438340 1001840 1 180 $X=433380 $Y=1001460
X1353 172 1731 125 2 1768 126 1 AO22 $T=435240 1062320 0 0 $X=435240 $Y=1061940
X1354 1787 1802 1543 2 1812 1568 1 AO22 $T=438340 941360 1 0 $X=438340 $Y=935940
X1355 174 125 1813 2 1839 126 1 AO22 $T=442680 1062320 0 0 $X=442680 $Y=1061940
X1356 1829 1543 1846 2 1849 1568 1 AO22 $T=444540 941360 0 0 $X=444540 $Y=940980
X1357 1844 1523 1821 2 1855 129 1 AO22 $T=448880 1001840 1 0 $X=448880 $Y=996420
X1358 1866 1543 1887 2 1893 1568 1 AO22 $T=451980 941360 1 0 $X=451980 $Y=935940
X1359 1865 1523 1888 2 1900 1926 1 AO22 $T=455700 1001840 1 0 $X=455700 $Y=996420
X1360 1947 1543 1924 2 1919 1568 1 AO22 $T=463140 941360 0 180 $X=458180 $Y=935940
X1361 182 1934 1903 2 1925 126 1 AO22 $T=464380 1062320 0 180 $X=459420 $Y=1056900
X1362 183 1934 1889 2 1912 126 1 AO22 $T=464380 1062320 1 180 $X=459420 $Y=1061940
X1363 1945 1951 1910 2 1943 1926 1 AO22 $T=466860 991760 1 180 $X=461900 $Y=991380
X1364 1982 1543 1955 2 1956 1568 1 AO22 $T=470580 941360 0 180 $X=465620 $Y=935940
X1365 1974 1951 1980 2 1986 1926 1 AO22 $T=468100 991760 0 0 $X=468100 $Y=991380
X1366 2048 1543 2004 2 2031 1568 1 AO22 $T=486080 941360 0 180 $X=481120 $Y=935940
X1367 2065 1543 2055 2 2045 1568 1 AO22 $T=486700 951440 0 180 $X=481740 $Y=946020
X1368 2061 1951 2026 2 2040 1926 1 AO22 $T=486700 991760 1 180 $X=481740 $Y=991380
X1369 192 1934 1995 2 2052 194 1 AO22 $T=484220 1062320 0 0 $X=484220 $Y=1061940
X1370 2079 1951 2051 2 2078 1926 1 AO22 $T=492900 991760 1 180 $X=487940 $Y=991380
X1371 2132 188 2090 2 2060 1568 1 AO22 $T=500340 931280 0 180 $X=495380 $Y=925860
X1372 2137 188 2123 2 2106 1568 1 AO22 $T=500340 941360 1 180 $X=495380 $Y=940980
X1373 2092 2125 2135 2 2110 1568 1 AO22 $T=496620 921200 0 0 $X=496620 $Y=920820
X1374 2094 2128 1951 2 2118 1926 1 AO22 $T=497860 961520 0 0 $X=497860 $Y=961140
X1375 2127 1951 2138 2 2091 1926 1 AO22 $T=502820 991760 1 180 $X=497860 $Y=991380
X1376 2152 1934 2116 2 2071 194 1 AO22 $T=505300 1052240 1 180 $X=500340 $Y=1051860
X1377 199 1934 2129 2 2003 194 1 AO22 $T=505920 1062320 1 180 $X=500960 $Y=1061940
X1378 2171 1951 2159 2 2067 1926 1 AO22 $T=507780 961520 1 180 $X=502820 $Y=961140
X1379 2196 1934 2186 2 1975 194 1 AO22 $T=512740 1062320 0 180 $X=507780 $Y=1056900
X1380 2206 1951 2193 2 2012 1926 1 AO22 $T=514600 981680 1 180 $X=509640 $Y=981300
X1381 2208 2135 2177 2 2053 1568 1 AO22 $T=517080 941360 0 180 $X=512120 $Y=935940
X1382 2197 1951 2182 2 2095 1926 1 AO22 $T=517080 1001840 0 180 $X=512120 $Y=996420
X1383 2227 1951 2215 2 2149 1926 1 AO22 $T=518940 961520 0 180 $X=513980 $Y=956100
X1384 2250 219 2253 2 2083 194 1 AO22 $T=527620 1052240 0 180 $X=522660 $Y=1046820
X1385 2276 229 2225 2 2258 222 1 AO22 $T=531960 901040 0 180 $X=527000 $Y=895620
X1386 2269 219 2277 2 2027 194 1 AO22 $T=534440 1052240 0 180 $X=529480 $Y=1046820
X1387 2286 219 2247 2 2028 194 1 AO22 $T=535060 1062320 0 180 $X=530100 $Y=1056900
X1388 228 203 1665 2 2285 207 1 AO22 $T=531340 901040 0 0 $X=531340 $Y=900660
X1389 233 203 2062 2 2284 207 1 AO22 $T=533820 890960 1 0 $X=533820 $Y=885540
X1390 234 203 231 2 2296 207 1 AO22 $T=535680 880880 0 0 $X=535680 $Y=880500
X1391 237 203 2188 2 2309 207 1 AO22 $T=537540 901040 0 0 $X=537540 $Y=900660
X1392 238 203 1761 2 2314 207 1 AO22 $T=538780 911120 0 0 $X=538780 $Y=910740
X1393 2324 229 2315 2 2297 222 1 AO22 $T=544360 931280 0 180 $X=539400 $Y=925860
X1394 2333 219 2302 2 2104 194 1 AO22 $T=544360 1062320 1 180 $X=539400 $Y=1061940
X1395 2317 219 2321 2 2039 194 1 AO22 $T=546840 1052240 0 180 $X=541880 $Y=1046820
X1396 2335 229 2322 2 2290 222 1 AO22 $T=547460 941360 0 180 $X=542500 $Y=935940
X1397 2340 229 2331 2 2323 222 1 AO22 $T=548700 901040 1 180 $X=543740 $Y=900660
X1398 2352 219 2347 2 1994 194 1 AO22 $T=553660 1042160 1 180 $X=548700 $Y=1041780
X1399 2368 229 2339 2 2353 222 1 AO22 $T=554900 951440 0 180 $X=549940 $Y=946020
X1400 2369 229 2341 2 2356 222 1 AO22 $T=556140 951440 1 180 $X=551180 $Y=951060
X1401 2381 229 2359 2 2363 222 1 AO22 $T=558000 961520 0 180 $X=553040 $Y=956100
X1402 2391 229 2373 2 2342 222 1 AO22 $T=560480 981680 0 180 $X=555520 $Y=976260
X1403 2344 229 2327 2 2390 222 1 AO22 $T=562960 961520 1 180 $X=558000 $Y=961140
X1404 2541 229 2524 2 2411 222 1 AO22 $T=587140 981680 0 180 $X=582180 $Y=976260
X1405 2582 229 2569 2 2473 222 1 AO22 $T=595820 981680 0 180 $X=590860 $Y=976260
X1406 2704 260 2675 2 2702 290 1 AO22 $T=617520 1062320 0 0 $X=617520 $Y=1061940
X1407 2683 260 2730 2 2733 290 1 AO22 $T=618760 1032080 1 0 $X=618760 $Y=1026660
X1408 2779 260 2784 2 2761 290 1 AO22 $T=629300 1062320 0 0 $X=629300 $Y=1061940
X1409 2785 260 2795 2 2797 290 1 AO22 $T=631160 1032080 1 0 $X=631160 $Y=1026660
X1410 2557 2 2516 2546 2536 1 2590 FA1S $T=585280 941360 0 0 $X=585280 $Y=940980
X1411 2579 2 2547 2601 2557 1 2609 FA1S $T=589620 951440 1 0 $X=589620 $Y=946020
X1412 2599 2 2571 2628 2611 1 2558 FA1S $T=603880 911120 0 180 $X=592100 $Y=905700
X1413 2608 2 2574 2643 2599 1 2581 FA1S $T=605740 901040 0 180 $X=593960 $Y=895620
X1414 2689 2 2667 2648 2674 1 2746 FA1S $T=610700 1032080 0 0 $X=610700 $Y=1031700
X1415 2693 2 2667 2657 2685 1 2730 FA1S $T=611320 1042160 1 0 $X=611320 $Y=1036740
X1416 2775 2 2766 2753 2693 1 2795 FA1S $T=624340 1042160 0 0 $X=624340 $Y=1041780
X1417 2789 2 292 2744 2782 1 2761 FA1S $T=637360 1052240 0 180 $X=625580 $Y=1046820
X1418 2782 2 2766 2760 2689 1 2797 FA1S $T=626200 1042160 1 0 $X=626200 $Y=1036740
X1419 2790 2 292 2749 2775 1 2784 FA1S $T=628060 1062320 1 0 $X=628060 $Y=1056900
X1420 2802 2 2665 2791 2830 1 2690 FA1S $T=642940 981680 0 180 $X=631160 $Y=976260
X1421 2854 2 298 2832 2790 1 302 FA1S $T=640460 1062320 0 0 $X=640460 $Y=1061940
X1422 2870 2 298 2844 2789 1 305 FA1S $T=643560 1062320 1 0 $X=643560 $Y=1056900
X1423 2926 2 2917 2906 2972 1 2985 FA1S $T=654720 981680 1 0 $X=654720 $Y=976260
X1424 2951 2 315 2963 2854 1 306 FA1S $T=667120 1062320 1 180 $X=655340 $Y=1061940
X1425 2940 2 2917 2904 2969 1 2979 FA1S $T=656580 971600 0 0 $X=656580 $Y=971220
X1426 2957 2 315 2960 2870 1 308 FA1S $T=668360 1052240 1 180 $X=656580 $Y=1051860
X1427 3017 2 320 2986 2957 1 322 FA1S $T=672080 1052240 0 0 $X=672080 $Y=1051860
X1428 317 2 320 2991 2951 1 323 FA1S $T=672080 1062320 0 0 $X=672080 $Y=1061940
X1429 3045 2 2994 3018 3025 1 3076 FA1S $T=678280 971600 1 0 $X=678280 $Y=966180
X1430 3059 2 2994 3024 3054 1 3084 FA1S $T=680760 971600 0 0 $X=680760 $Y=971220
X1431 3064 2 3061 3050 3049 1 2999 FA1S $T=682620 890960 1 0 $X=682620 $Y=885540
X1432 3066 2 3046 2614 3073 1 3095 FA1S $T=682620 1001840 1 0 $X=682620 $Y=996420
X1433 3069 2 3046 2687 3074 1 3097 FA1S $T=683240 1001840 0 0 $X=683240 $Y=1001460
X1434 3074 2 3071 2623 3079 1 3109 FA1S $T=684480 1022000 0 0 $X=684480 $Y=1021620
X1435 3073 2 3071 3001 3086 1 3128 FA1S $T=687580 1032080 0 0 $X=687580 $Y=1031700
X1436 3086 2 3110 3052 3129 1 3127 FA1S $T=687580 1042160 1 0 $X=687580 $Y=1036740
X1437 3079 2 3110 3047 3153 1 3137 FA1S $T=687580 1042160 0 0 $X=687580 $Y=1041780
X1438 3081 2 2980 3077 3038 1 3123 FA1S $T=688200 890960 0 0 $X=688200 $Y=890580
X1439 3089 2 326 3028 3017 1 331 FA1S $T=688200 1052240 0 0 $X=688200 $Y=1051860
X1440 3102 2 3068 3062 3045 1 3117 FA1S $T=691300 961520 0 0 $X=691300 $Y=961140
X1441 3103 2 3068 3094 3059 1 3136 FA1S $T=691300 971600 1 0 $X=691300 $Y=966180
X1442 3113 2 2996 3083 3132 1 3135 FA1S $T=693160 921200 1 0 $X=693160 $Y=915780
X1443 3119 2 3005 3093 3113 1 3145 FA1S $T=694400 931280 1 0 $X=694400 $Y=925860
X1444 3088 2 3118 3100 3066 1 3152 FA1S $T=694400 991760 1 0 $X=694400 $Y=986340
X1445 3132 2 2977 3105 3081 1 3096 FA1S $T=706800 901040 1 180 $X=695020 $Y=900660
X1446 3078 2 3118 2701 3069 1 3161 FA1S $T=697500 991760 0 0 $X=697500 $Y=991380
X1447 3141 2 2988 3087 3102 1 3148 FA1S $T=699360 961520 1 0 $X=699360 $Y=956100
X1448 3144 2 2977 3162 3168 1 3099 FA1S $T=712380 901040 0 180 $X=700600 $Y=895620
X1449 3150 2 332 329 3089 1 337 FA1S $T=702460 1062320 1 0 $X=702460 $Y=1056900
X1450 3153 2 3181 3120 334 1 3204 FA1S $T=703080 1052240 1 0 $X=703080 $Y=1046820
X1451 3129 2 3181 3015 3150 1 3197 FA1S $T=703700 1052240 0 0 $X=703700 $Y=1051860
X1452 3192 2 3005 3133 3198 1 3142 FA1S $T=720440 931280 0 180 $X=708660 $Y=925860
X1453 3155 2 2988 3183 3103 1 3160 FA1S $T=710520 971600 1 0 $X=710520 $Y=966180
X1454 3252 2 3246 3216 3193 1 3292 FA1S $T=723540 971600 1 0 $X=723540 $Y=966180
X1455 3272 2 3253 3252 3281 1 3247 FA1S $T=736560 971600 1 180 $X=724780 $Y=971220
X1456 3266 2 3251 3231 3268 1 3281 FA1S $T=725400 951440 1 0 $X=725400 $Y=946020
X1457 3276 2 3275 3245 3258 1 3306 FA1S $T=727880 941360 0 0 $X=727880 $Y=940980
X1458 3298 2 3303 3266 3306 1 3261 FA1S $T=740900 961520 0 180 $X=729120 $Y=956100
X1459 3312 2 3301 3294 3315 1 3364 FA1S $T=736560 931280 1 0 $X=736560 $Y=925860
X1460 3328 2 3310 3276 3364 1 3321 FA1S $T=740280 951440 1 0 $X=740280 $Y=946020
X1461 940 66 70 2 1 996 QDFFRBN $T=276520 1052240 1 0 $X=276520 $Y=1046820
X1462 958 66 70 2 1 1016 QDFFRBN $T=280240 1042160 1 0 $X=280240 $Y=1036740
X1463 967 66 70 2 1 1031 QDFFRBN $T=282100 1062320 0 0 $X=282100 $Y=1061940
X1464 107 66 108 2 1 1360 QDFFRBN $T=347200 1062320 1 0 $X=347200 $Y=1056900
X1465 1369 66 108 2 1 1411 QDFFRBN $T=353400 1062320 0 0 $X=353400 $Y=1061940
X1466 1396 66 108 2 1 1376 QDFFRBN $T=367040 1042160 0 180 $X=355260 $Y=1036740
X1467 1393 66 108 2 1 1438 QDFFRBN $T=358980 1032080 1 0 $X=358980 $Y=1026660
X1468 1394 66 108 2 1 1457 QDFFRBN $T=361460 1052240 1 0 $X=361460 $Y=1046820
X1469 1414 66 108 2 1 1444 QDFFRBN $T=368280 1011920 1 0 $X=368280 $Y=1006500
X1470 1434 66 108 2 1 1445 QDFFRBN $T=368900 971600 0 0 $X=368900 $Y=971220
X1471 1412 66 108 2 1 1427 QDFFRBN $T=369520 1001840 1 0 $X=369520 $Y=996420
X1472 1443 66 108 2 1 1478 QDFFRBN $T=371380 991760 0 0 $X=371380 $Y=991380
X1473 1454 66 108 2 1 1417 QDFFRBN $T=375100 961520 1 0 $X=375100 $Y=956100
X1474 1460 66 108 2 1 1498 QDFFRBN $T=376340 1032080 1 0 $X=376340 $Y=1026660
X1475 1462 66 124 2 1 1516 QDFFRBN $T=377580 901040 0 0 $X=377580 $Y=900660
X1476 1467 66 108 2 1 1522 QDFFRBN $T=379440 1022000 0 0 $X=379440 $Y=1021620
X1477 1471 66 124 2 1 1493 QDFFRBN $T=380060 911120 0 0 $X=380060 $Y=910740
X1478 1476 66 108 2 1 1500 QDFFRBN $T=380680 941360 1 0 $X=380680 $Y=935940
X1479 1475 66 108 2 1 1419 QDFFRBN $T=380680 941360 0 0 $X=380680 $Y=940980
X1480 1482 66 124 2 1 127 QDFFRBN $T=385640 880880 0 0 $X=385640 $Y=880500
X1481 1483 66 124 2 1 1459 QDFFRBN $T=386260 890960 1 0 $X=386260 $Y=885540
X1482 1533 128 108 2 1 1592 QDFFRBN $T=393080 911120 1 0 $X=393080 $Y=905700
X1483 1545 66 108 2 1 1615 QDFFRBN $T=394320 1022000 0 0 $X=394320 $Y=1021620
X1484 1583 128 124 2 1 1650 QDFFRBN $T=403000 901040 0 0 $X=403000 $Y=900660
X1485 1554 128 124 2 1 1665 QDFFRBN $T=404240 901040 1 0 $X=404240 $Y=895620
X1486 1589 128 108 2 1 1677 QDFFRBN $T=407340 911120 1 0 $X=407340 $Y=905700
X1487 1685 66 108 2 1 1628 QDFFRBN $T=420980 1022000 1 180 $X=409200 $Y=1021620
X1488 1700 128 108 2 1 1761 QDFFRBN $T=420980 911120 0 0 $X=420980 $Y=910740
X1489 187 128 189 2 1 2062 QDFFRBN $T=473680 890960 1 0 $X=473680 $Y=885540
X1490 1906 128 189 2 1 197 QDFFRBN $T=484840 901040 1 0 $X=484840 $Y=895620
X1491 1735 128 189 2 1 2144 QDFFRBN $T=487940 890960 1 0 $X=487940 $Y=885540
X1492 91 128 70 2 1 2151 QDFFRBN $T=491660 890960 0 0 $X=491660 $Y=890580
X1493 1828 128 70 2 1 2179 QDFFRBN $T=496000 901040 0 0 $X=496000 $Y=900660
X1494 2139 128 189 2 1 2188 QDFFRBN $T=499720 901040 1 0 $X=499720 $Y=895620
X1495 2154 128 189 2 1 2202 QDFFRBN $T=502820 890960 1 0 $X=502820 $Y=885540
X1496 2161 66 108 2 1 2214 QDFFRBN $T=504680 1022000 0 0 $X=504680 $Y=1021620
X1497 2150 128 189 2 1 2234 QDFFRBN $T=506540 890960 0 0 $X=506540 $Y=890580
X1498 2173 66 108 2 1 2239 QDFFRBN $T=510880 1042160 0 0 $X=510880 $Y=1041780
X1499 2183 66 108 2 1 2254 QDFFRBN $T=517080 1022000 1 0 $X=517080 $Y=1016580
X1500 2263 226 108 2 1 2298 QDFFRBN $T=527000 1032080 1 0 $X=527000 $Y=1026660
X1501 2184 2278 70 2 1 2265 QDFFRBN $T=540020 991760 0 180 $X=528240 $Y=986340
X1502 2292 2278 70 2 1 2241 QDFFRBN $T=540640 1001840 0 180 $X=528860 $Y=996420
X1503 2249 2278 70 2 1 2318 QDFFRBN $T=530100 1001840 0 0 $X=530100 $Y=1001460
X1504 2280 2278 70 2 1 2320 QDFFRBN $T=531960 981680 0 0 $X=531960 $Y=981300
X1505 2312 226 108 2 1 2348 QDFFRBN $T=540640 1022000 0 0 $X=540640 $Y=1021620
X1506 2357 2278 70 2 1 2311 QDFFRBN $T=553660 981680 0 180 $X=541880 $Y=976260
X1507 2330 2278 70 2 1 2295 QDFFRBN $T=554280 1001840 0 180 $X=542500 $Y=996420
X1508 2283 2278 70 2 1 2362 QDFFRBN $T=543120 991760 1 0 $X=543120 $Y=986340
X1509 2328 2278 70 2 1 2383 QDFFRBN $T=544980 1001840 0 0 $X=544980 $Y=1001460
X1510 2372 2278 70 2 1 2338 QDFFRBN $T=559860 981680 1 180 $X=548080 $Y=981300
X1511 2440 2278 70 2 1 2380 QDFFRBN $T=569160 1001840 0 180 $X=557380 $Y=996420
X1512 2396 2278 70 2 1 2453 QDFFRBN $T=560480 1001840 0 0 $X=560480 $Y=1001460
X1513 2483 226 70 2 1 2382 QDFFRBN $T=578460 1032080 1 180 $X=566680 $Y=1031700
X1514 2436 251 254 2 1 2508 QDFFRBN $T=568540 961520 1 0 $X=568540 $Y=956100
X1515 2428 226 70 2 1 2345 QDFFRBN $T=580940 1011920 1 180 $X=569160 $Y=1011540
X1516 2454 251 254 2 1 2516 QDFFRBN $T=571020 941360 0 0 $X=571020 $Y=940980
X1517 2456 251 254 2 1 2519 QDFFRBN $T=571640 931280 0 0 $X=571640 $Y=930900
X1518 2468 226 108 2 1 2392 QDFFRBN $T=573500 1042160 1 0 $X=573500 $Y=1036740
X1519 2469 251 254 2 1 2531 QDFFRBN $T=574120 931280 1 0 $X=574120 $Y=925860
X1520 2528 2278 70 2 1 2443 QDFFRBN $T=585900 1022000 1 180 $X=574120 $Y=1021620
X1521 2482 251 254 2 1 2547 QDFFRBN $T=576600 951440 1 0 $X=576600 $Y=946020
X1522 2490 257 254 2 1 2518 QDFFRBN $T=578460 921200 1 0 $X=578460 $Y=915780
X1523 2550 226 108 2 1 256 QDFFRBN $T=590860 1062320 1 180 $X=579080 $Y=1061940
X1524 2503 257 254 2 1 2571 QDFFRBN $T=580320 901040 1 0 $X=580320 $Y=895620
X1525 2510 257 254 2 1 2574 QDFFRBN $T=581560 890960 0 0 $X=581560 $Y=890580
X1526 2498 251 254 2 1 2580 QDFFRBN $T=582800 971600 1 0 $X=582800 $Y=966180
X1527 2530 2278 70 2 1 2561 QDFFRBN $T=584040 1022000 1 0 $X=584040 $Y=1016580
X1528 2567 2278 70 2 1 2629 QDFFRBN $T=593340 1042160 1 0 $X=593340 $Y=1036740
X1529 2553 2278 70 2 1 2635 QDFFRBN $T=593960 1032080 1 0 $X=593960 $Y=1026660
X1530 2529 2278 70 2 1 2627 QDFFRBN $T=596440 1022000 0 0 $X=596440 $Y=1021620
X1531 2585 2278 70 2 1 2654 QDFFRBN $T=599540 1022000 1 0 $X=599540 $Y=1016580
X1532 2607 251 254 2 1 2665 QDFFRBN $T=600160 981680 0 0 $X=600160 $Y=981300
X1533 2649 251 254 2 1 2678 QDFFRBN $T=607600 1011920 1 0 $X=607600 $Y=1006500
X1534 2716 257 254 2 1 2667 QDFFRBN $T=623100 1022000 1 180 $X=611320 $Y=1021620
X1535 2684 251 254 2 1 2752 QDFFRBN $T=613800 1011920 0 0 $X=613800 $Y=1011540
X1536 2708 251 254 2 1 2768 QDFFRBN $T=618140 971600 1 0 $X=618140 $Y=966180
X1537 2811 257 254 2 1 2766 QDFFRBN $T=638600 1022000 1 180 $X=626820 $Y=1021620
X1538 2819 251 254 2 1 2886 QDFFRBN $T=637980 1001840 1 0 $X=637980 $Y=996420
X1539 2846 251 254 2 1 2903 QDFFRBN $T=642940 981680 1 0 $X=642940 $Y=976260
X1540 2866 251 254 2 1 2929 QDFFRBN $T=648520 991760 1 0 $X=648520 $Y=986340
X1541 2919 257 310 2 1 2959 QDFFRBN $T=656580 890960 1 0 $X=656580 $Y=885540
X1542 2978 2945 310 2 1 2818 QDFFRBN $T=668980 1032080 0 180 $X=657200 $Y=1026660
X1543 2932 2945 310 2 1 2871 QDFFRBN $T=659680 1032080 0 0 $X=659680 $Y=1031700
X1544 2930 2945 310 2 1 2864 QDFFRBN $T=659680 1042160 0 0 $X=659680 $Y=1041780
X1545 2954 2945 310 2 1 2883 QDFFRBN $T=662160 1011920 1 0 $X=662160 $Y=1006500
X1546 2971 257 310 2 1 2977 QDFFRBN $T=666500 901040 0 0 $X=666500 $Y=900660
X1547 2937 251 254 2 1 2976 QDFFRBN $T=667740 991760 0 0 $X=667740 $Y=991380
X1548 3000 257 310 2 1 3006 QDFFRBN $T=686340 1032080 1 180 $X=674560 $Y=1031700
X1549 3041 257 310 2 1 2996 QDFFRBN $T=680760 901040 1 0 $X=680760 $Y=895620
X1550 3039 257 310 2 1 3005 QDFFRBN $T=680760 911120 1 0 $X=680760 $Y=905700
X1551 3042 251 254 2 1 2994 QDFFRBN $T=681380 991760 1 0 $X=681380 $Y=986340
X1552 3092 251 310 2 1 3035 QDFFRBN $T=694400 991760 1 180 $X=682620 $Y=991380
X1553 3037 257 310 2 1 3106 QDFFRBN $T=683860 880880 0 0 $X=683860 $Y=880500
X1554 3111 251 310 2 1 326 QDFFRBN $T=698740 1062320 1 180 $X=686960 $Y=1061940
X1555 3131 251 254 2 1 3068 QDFFRBN $T=703080 981680 1 180 $X=691300 $Y=981300
X1556 3108 257 310 2 1 3154 QDFFRBN $T=696260 941360 0 0 $X=696260 $Y=940980
X1557 3175 251 310 2 1 3104 QDFFRBN $T=712380 1032080 0 180 $X=700600 $Y=1026660
X1558 3169 251 310 2 1 3110 QDFFRBN $T=713000 1042160 0 180 $X=701220 $Y=1036740
X1559 3186 251 310 2 1 3031 QDFFRBN $T=714860 1022000 0 180 $X=703080 $Y=1016580
X1560 3178 251 310 2 1 3107 QDFFRBN $T=716720 1011920 1 180 $X=704940 $Y=1011540
X1561 3202 251 310 2 1 3156 QDFFRBN $T=719200 991760 0 180 $X=707420 $Y=986340
X1562 3174 251 310 2 1 2988 QDFFRBN $T=710520 971600 0 0 $X=710520 $Y=971220
X1563 3149 251 310 2 1 3056 QDFFRBN $T=711760 981680 0 0 $X=711760 $Y=981300
X1564 3212 251 310 2 1 3181 QDFFRBN $T=718580 1042160 0 0 $X=718580 $Y=1041780
X1565 3274 3334 358 2 1 3381 QDFFRBN $T=742140 901040 1 0 $X=742140 $Y=895620
X1566 3339 3334 358 2 1 3375 QDFFRBN $T=744000 890960 0 0 $X=744000 $Y=890580
X1567 3343 3334 358 2 1 3386 QDFFRBN $T=744620 890960 1 0 $X=744620 $Y=885540
X1568 3357 3334 358 2 1 3417 QDFFRBN $T=750820 901040 0 0 $X=750820 $Y=900660
X1569 3393 3334 358 2 1 3446 QDFFRBN $T=757020 901040 1 0 $X=757020 $Y=895620
X1570 3311 3334 358 2 1 3471 QDFFRBN $T=765080 901040 0 0 $X=765080 $Y=900660
X1571 3397 3334 358 2 1 3521 QDFFRBN $T=775620 901040 1 0 $X=775620 $Y=895620
X1572 3378 3334 358 2 1 3541 QDFFRBN $T=782440 901040 0 0 $X=782440 $Y=900660
X1573 3371 3334 358 2 1 3555 QDFFRBN $T=786780 890960 0 0 $X=786780 $Y=890580
X1574 3402 3334 358 2 1 3568 QDFFRBN $T=790500 901040 1 0 $X=790500 $Y=895620
X1575 404 405 358 2 1 413 QDFFRBN $T=794220 880880 0 0 $X=794220 $Y=880500
X1576 3458 3334 358 2 1 3605 QDFFRBN $T=797320 901040 0 0 $X=797320 $Y=900660
X1577 415 405 358 2 1 3642 QDFFRBN $T=807240 890960 1 0 $X=807240 $Y=885540
X1578 3589 3334 358 2 1 3655 QDFFRBN $T=810340 901040 0 0 $X=810340 $Y=900660
X1579 434 405 438 2 1 3707 QDFFRBN $T=822740 890960 1 0 $X=822740 $Y=885540
X1580 3392 3711 438 2 1 3742 QDFFRBN $T=833280 901040 1 0 $X=833280 $Y=895620
X1581 3259 3711 438 2 1 3743 QDFFRBN $T=834520 890960 1 0 $X=834520 $Y=885540
X1582 445 3711 438 2 1 3778 QDFFRBN $T=846300 890960 1 0 $X=846300 $Y=885540
X1583 3308 3711 438 2 1 3794 QDFFRBN $T=848160 890960 0 0 $X=848160 $Y=890580
X1584 3309 3711 438 2 1 3804 QDFFRBN $T=852500 901040 1 0 $X=852500 $Y=895620
X1585 451 3711 438 2 1 454 QDFFRBN $T=856220 880880 0 0 $X=856220 $Y=880500
X1586 3388 3711 438 2 1 3822 QDFFRBN $T=858080 890960 1 0 $X=858080 $Y=885540
X1587 3380 3334 438 2 1 3830 QDFFRBN $T=861800 911120 1 0 $X=861800 $Y=905700
X1588 3233 3711 438 2 1 3840 QDFFRBN $T=863040 890960 0 0 $X=863040 $Y=890580
X1589 3380 3334 438 2 1 3848 QDFFRBN $T=866140 901040 1 0 $X=866140 $Y=895620
X1590 457 441 438 2 1 3861 QDFFRBN $T=871100 880880 0 0 $X=871100 $Y=880500
X1591 3380 3334 438 2 1 3873 QDFFRBN $T=874200 901040 0 0 $X=874200 $Y=900660
X1592 457 441 438 2 1 3916 QDFFRBN $T=884740 880880 0 0 $X=884740 $Y=880500
X1593 3380 3334 438 2 1 3913 QDFFRBN $T=890940 901040 0 0 $X=890940 $Y=900660
X1594 3380 3334 438 2 1 3948 QDFFRBN $T=899620 911120 1 0 $X=899620 $Y=905700
X1595 457 441 438 2 1 3951 QDFFRBN $T=906440 880880 0 0 $X=906440 $Y=880500
X1596 3338 3711 438 2 1 4003 QDFFRBN $T=915120 901040 0 0 $X=915120 $Y=900660
X1597 3215 3711 438 2 1 4110 QDFFRBN $T=939920 901040 0 0 $X=939920 $Y=900660
X1598 3457 3711 438 2 1 4129 QDFFRBN $T=943640 901040 1 0 $X=943640 $Y=895620
X1599 3360 3711 438 2 1 4167 QDFFRBN $T=958520 901040 1 0 $X=958520 $Y=895620
X1600 3176 3711 438 2 1 4210 QDFFRBN $T=972780 901040 1 0 $X=972780 $Y=895620
X1601 3176 3711 438 2 1 4247 QDFFRBN $T=988900 901040 0 0 $X=988900 $Y=900660
X1602 3176 3711 438 2 1 4251 QDFFRBN $T=990140 890960 0 0 $X=990140 $Y=890580
X1603 532 405 438 2 1 4260 QDFFRBN $T=993240 890960 1 0 $X=993240 $Y=885540
X1604 532 405 438 2 1 4281 QDFFRBN $T=1000060 880880 0 0 $X=1000060 $Y=880500
X1605 3176 3711 438 2 1 4286 QDFFRBN $T=1003780 901040 0 0 $X=1003780 $Y=900660
X1606 3176 3711 438 2 1 4291 QDFFRBN $T=1005020 901040 1 0 $X=1005020 $Y=895620
X1607 532 405 438 2 1 4295 QDFFRBN $T=1008740 890960 1 0 $X=1008740 $Y=885540
X1608 532 405 438 2 1 4321 QDFFRBN $T=1014940 880880 0 0 $X=1014940 $Y=880500
X1609 631 2 600 1 INV1S $T=225060 890960 1 180 $X=223820 $Y=890580
X1610 630 2 593 1 INV1S $T=225060 921200 0 180 $X=223820 $Y=915780
X1611 632 2 601 1 INV1S $T=226300 901040 1 180 $X=225060 $Y=900660
X1612 633 2 602 1 INV1S $T=226300 931280 1 180 $X=225060 $Y=930900
X1613 634 2 603 1 INV1S $T=226300 941360 1 180 $X=225060 $Y=940980
X1614 637 2 605 1 INV1S $T=226300 971600 1 180 $X=225060 $Y=971220
X1615 638 2 606 1 INV1S $T=226300 981680 1 180 $X=225060 $Y=981300
X1616 651 2 607 1 INV1S $T=226300 1001840 0 180 $X=225060 $Y=996420
X1617 648 2 608 1 INV1S $T=226920 1042160 0 180 $X=225680 $Y=1036740
X1618 5 2 619 1 INV1S $T=226920 911120 0 0 $X=226920 $Y=910740
X1619 641 2 604 1 INV1S $T=228160 961520 1 180 $X=226920 $Y=961140
X1620 669 2 645 1 INV1S $T=229400 951440 0 180 $X=228160 $Y=946020
X1621 604 2 635 1 INV1S $T=228160 961520 0 0 $X=228160 $Y=961140
X1622 615 2 644 1 INV1S $T=230640 1052240 1 180 $X=229400 $Y=1051860
X1623 654 2 612 1 INV1S $T=231880 1032080 0 180 $X=230640 $Y=1026660
X1624 717 2 668 1 INV1S $T=233120 971600 1 180 $X=231880 $Y=971220
X1625 680 2 636 1 INV1S $T=233120 1011920 1 180 $X=231880 $Y=1011540
X1626 689 2 628 1 INV1S $T=233740 1022000 1 180 $X=232500 $Y=1021620
X1627 698 2 684 1 INV1S $T=234980 1042160 1 180 $X=233740 $Y=1041780
X1628 9 2 686 1 INV1S $T=235600 890960 1 0 $X=235600 $Y=885540
X1629 9 2 666 1 INV1S $T=235600 941360 1 0 $X=235600 $Y=935940
X1630 15 2 669 1 INV1S $T=236840 961520 1 0 $X=236840 $Y=956100
X1631 5 2 670 1 INV1S $T=239940 1022000 0 180 $X=238700 $Y=1016580
X1632 736 2 723 1 INV1S $T=240560 971600 0 180 $X=239320 $Y=966180
X1633 725 2 643 1 INV1S $T=241180 1001840 1 180 $X=239940 $Y=1001460
X1634 740 2 721 1 INV1S $T=243040 1001840 1 180 $X=241800 $Y=1001460
X1635 17 2 754 1 INV1S $T=244280 941360 0 0 $X=244280 $Y=940980
X1636 760 2 764 1 INV1S $T=245520 981680 0 0 $X=245520 $Y=981300
X1637 29 2 770 1 INV1S $T=249240 971600 1 180 $X=248000 $Y=971220
X1638 771 2 760 1 INV1S $T=253580 981680 0 180 $X=252340 $Y=976260
X1639 33 2 819 1 INV1S $T=257920 961520 1 0 $X=257920 $Y=956100
X1640 790 2 839 1 INV1S $T=261020 1022000 1 0 $X=261020 $Y=1016580
X1641 51 2 28 1 INV1S $T=262880 880880 1 180 $X=261640 $Y=880500
X1642 37 2 872 1 INV1S $T=262260 921200 1 0 $X=262260 $Y=915780
X1643 834 2 868 1 INV1S $T=262880 971600 0 0 $X=262880 $Y=971220
X1644 872 2 863 1 INV1S $T=264740 951440 0 180 $X=263500 $Y=946020
X1645 53 2 879 1 INV1S $T=267220 961520 1 180 $X=265980 $Y=961140
X1646 50 2 908 1 INV1S $T=269700 941360 0 0 $X=269700 $Y=940980
X1647 905 2 929 1 INV1S $T=272800 1001840 0 0 $X=272800 $Y=1001460
X1648 50 2 923 1 INV1S $T=275900 961520 1 180 $X=274660 $Y=961140
X1649 44 2 871 1 INV1S $T=277140 890960 0 180 $X=275900 $Y=885540
X1650 65 2 60 1 INV1S $T=277760 880880 1 180 $X=276520 $Y=880500
X1651 44 2 874 1 INV1S $T=276520 971600 1 0 $X=276520 $Y=966180
X1652 928 2 910 1 INV1S $T=277760 1022000 0 180 $X=276520 $Y=1016580
X1653 896 2 887 1 INV1S $T=277760 941360 0 0 $X=277760 $Y=940980
X1654 837 2 954 1 INV1S $T=280860 971600 1 180 $X=279620 $Y=971220
X1655 957 2 942 1 INV1S $T=280860 991760 0 180 $X=279620 $Y=986340
X1656 919 2 960 1 INV1S $T=280240 981680 0 0 $X=280240 $Y=981300
X1657 948 2 964 1 INV1S $T=280240 1011920 1 0 $X=280240 $Y=1006500
X1658 1005 2 989 1 INV1S $T=288920 1001840 0 180 $X=287680 $Y=996420
X1659 1004 2 1011 1 INV1S $T=289540 981680 1 0 $X=289540 $Y=976260
X1660 993 2 1018 1 INV1S $T=290160 911120 0 0 $X=290160 $Y=910740
X1661 73 2 1012 1 INV1S $T=290160 941360 0 0 $X=290160 $Y=940980
X1662 865 2 1014 1 INV1S $T=291400 921200 0 0 $X=291400 $Y=920820
X1663 1027 2 1006 1 INV1S $T=293260 901040 0 180 $X=292020 $Y=895620
X1664 1022 2 1032 1 INV1S $T=292020 961520 1 0 $X=292020 $Y=956100
X1665 961 2 1045 1 INV1S $T=295120 901040 0 0 $X=295120 $Y=900660
X1666 946 2 1040 1 INV1S $T=295740 971600 0 0 $X=295740 $Y=971220
X1667 706 2 1066 1 INV1S $T=300080 951440 0 0 $X=300080 $Y=951060
X1668 1033 2 1070 1 INV1S $T=300080 961520 1 0 $X=300080 $Y=956100
X1669 1093 2 1098 1 INV1S $T=308760 981680 0 180 $X=307520 $Y=976260
X1670 1111 2 1106 1 INV1S $T=310620 971600 1 180 $X=309380 $Y=971220
X1671 1099 2 1113 1 INV1S $T=310000 1032080 0 0 $X=310000 $Y=1031700
X1672 1106 2 1116 1 INV1S $T=310620 971600 1 0 $X=310620 $Y=966180
X1673 83 2 1121 1 INV1S $T=313100 981680 1 180 $X=311860 $Y=981300
X1674 1141 2 1130 1 INV1S $T=314340 971600 0 180 $X=313100 $Y=966180
X1675 1134 2 85 1 INV1S $T=313720 890960 1 0 $X=313720 $Y=885540
X1676 87 2 1162 1 INV1S $T=320540 961520 1 180 $X=319300 $Y=961140
X1677 1173 2 1146 1 INV1S $T=319920 971600 0 0 $X=319920 $Y=971220
X1678 1142 2 1185 1 INV1S $T=321780 1042160 1 0 $X=321780 $Y=1036740
X1679 1189 2 1199 1 INV1S $T=322400 991760 0 0 $X=322400 $Y=991380
X1680 88 2 1210 1 INV1S $T=323640 991760 0 0 $X=323640 $Y=991380
X1681 90 2 1224 1 INV1S $T=323640 1001840 0 0 $X=323640 $Y=1001460
X1682 83 2 1217 1 INV1S $T=324260 941360 0 0 $X=324260 $Y=940980
X1683 92 2 1141 1 INV1S $T=325500 961520 1 180 $X=324260 $Y=961140
X1684 80 2 1200 1 INV1S $T=326120 901040 0 180 $X=324880 $Y=895620
X1685 1208 2 1174 1 INV1S $T=326120 1042160 1 180 $X=324880 $Y=1041780
X1686 1194 2 1215 1 INV1S $T=325500 890960 0 0 $X=325500 $Y=890580
X1687 1235 2 1231 1 INV1S $T=329220 1011920 0 180 $X=327980 $Y=1006500
X1688 1241 2 1245 1 INV1S $T=329840 991760 1 0 $X=329840 $Y=986340
X1689 1232 2 1242 1 INV1S $T=331080 1052240 0 180 $X=329840 $Y=1046820
X1690 1251 2 1238 1 INV1S $T=331700 890960 1 180 $X=330460 $Y=890580
X1691 1126 2 1262 1 INV1S $T=332320 991760 1 0 $X=332320 $Y=986340
X1692 1268 2 1236 1 INV1S $T=334180 1022000 1 180 $X=332940 $Y=1021620
X1693 1239 2 1225 1 INV1S $T=333560 1032080 0 0 $X=333560 $Y=1031700
X1694 1108 2 1292 1 INV1S $T=337900 981680 0 0 $X=337900 $Y=981300
X1695 1298 2 1283 1 INV1S $T=339140 1011920 1 180 $X=337900 $Y=1011540
X1696 1300 2 1255 1 INV1S $T=340380 901040 1 180 $X=339140 $Y=900660
X1697 1296 2 1297 1 INV1S $T=341000 901040 1 0 $X=341000 $Y=895620
X1698 1302 2 1316 1 INV1S $T=343480 941360 0 0 $X=343480 $Y=940980
X1699 1280 2 1320 1 INV1S $T=344100 931280 1 0 $X=344100 $Y=925860
X1700 1319 2 1323 1 INV1S $T=344720 890960 1 0 $X=344720 $Y=885540
X1701 1318 2 1326 1 INV1S $T=345340 931280 0 0 $X=345340 $Y=930900
X1702 1321 2 1327 1 INV1S $T=346580 971600 1 0 $X=346580 $Y=966180
X1703 1311 2 1306 1 INV1S $T=349060 981680 0 180 $X=347820 $Y=976260
X1704 1309 2 1353 1 INV1S $T=348440 901040 0 0 $X=348440 $Y=900660
X1705 1304 2 1340 1 INV1S $T=350300 991760 0 180 $X=349060 $Y=986340
X1706 1345 2 1355 1 INV1S $T=349680 961520 0 0 $X=349680 $Y=961140
X1707 1332 2 1341 1 INV1S $T=351540 911120 1 180 $X=350300 $Y=910740
X1708 80 2 1294 1 INV1S $T=351540 890960 0 0 $X=351540 $Y=890580
X1709 1361 2 1338 1 INV1S $T=354020 911120 0 180 $X=352780 $Y=905700
X1710 80 2 1348 1 INV1S $T=356500 951440 1 0 $X=356500 $Y=946020
X1711 1506 2 1517 1 INV1S $T=390600 1022000 1 0 $X=390600 $Y=1016580
X1712 1552 2 1539 1 INV1S $T=395560 911120 1 180 $X=394320 $Y=910740
X1713 1549 2 1546 1 INV1S $T=396180 961520 1 180 $X=394940 $Y=961140
X1714 1537 2 1563 1 INV1S $T=395560 971600 0 0 $X=395560 $Y=971220
X1715 1565 2 1541 1 INV1S $T=397420 981680 1 180 $X=396180 $Y=981300
X1716 1507 2 1540 1 INV1S $T=396180 1052240 1 0 $X=396180 $Y=1046820
X1717 1535 2 1567 1 INV1S $T=396180 1052240 0 0 $X=396180 $Y=1051860
X1718 134 2 136 1 INV1S $T=401760 1062320 0 0 $X=401760 $Y=1061940
X1719 121 2 1590 1 INV1S $T=402380 890960 0 0 $X=402380 $Y=890580
X1720 135 2 844 1 INV1S $T=403620 901040 0 180 $X=402380 $Y=895620
X1721 1577 2 1591 1 INV1S $T=403000 941360 1 0 $X=403000 $Y=935940
X1722 1544 2 1573 1 INV1S $T=404240 1001840 0 180 $X=403000 $Y=996420
X1723 1531 2 1574 1 INV1S $T=404240 1062320 0 180 $X=403000 $Y=1056900
X1724 122 2 126 1 INV1S $T=406100 1052240 1 180 $X=404860 $Y=1051860
X1725 1610 2 1600 1 INV1S $T=407340 961520 1 180 $X=406100 $Y=961140
X1726 1622 2 1606 1 INV1S $T=409200 1032080 1 180 $X=407960 $Y=1031700
X1727 1627 2 1598 1 INV1S $T=409820 961520 0 180 $X=408580 $Y=956100
X1728 1636 2 1597 1 INV1S $T=410440 961520 1 180 $X=409200 $Y=961140
X1729 1632 2 1584 1 INV1S $T=410440 971600 1 180 $X=409200 $Y=971220
X1730 1560 2 1612 1 INV1S $T=411060 931280 1 180 $X=409820 $Y=930900
X1731 1582 2 1631 1 INV1S $T=412920 941360 1 180 $X=411680 $Y=940980
X1732 1630 2 1629 1 INV1S $T=412920 1042160 1 180 $X=411680 $Y=1041780
X1733 1634 2 1646 1 INV1S $T=416020 1052240 1 180 $X=414780 $Y=1051860
X1734 1663 2 1671 1 INV1S $T=416020 1052240 0 0 $X=416020 $Y=1051860
X1735 1648 2 1674 1 INV1S $T=416640 931280 1 0 $X=416640 $Y=925860
X1736 1657 2 1676 1 INV1S $T=417260 991760 1 0 $X=417260 $Y=986340
X1737 152 2 777 1 INV1S $T=419740 890960 1 180 $X=418500 $Y=890580
X1738 150 2 1673 1 INV1S $T=419740 971600 1 180 $X=418500 $Y=971220
X1739 149 2 1712 1 INV1S $T=419120 901040 0 0 $X=419120 $Y=900660
X1740 1640 2 1689 1 INV1S $T=419740 931280 0 0 $X=419740 $Y=930900
X1741 151 2 1702 1 INV1S $T=420360 1022000 1 0 $X=420360 $Y=1016580
X1742 147 2 1675 1 INV1S $T=422840 951440 1 180 $X=421600 $Y=951060
X1743 1717 2 1706 1 INV1S $T=424080 931280 0 180 $X=422840 $Y=925860
X1744 143 2 1698 1 INV1S $T=422840 981680 1 0 $X=422840 $Y=976260
X1745 142 2 1690 1 INV1S $T=424080 1062320 0 180 $X=422840 $Y=1056900
X1746 1733 2 1719 1 INV1S $T=425940 971600 0 180 $X=424700 $Y=966180
X1747 161 2 1663 1 INV1S $T=425940 1062320 0 180 $X=424700 $Y=1056900
X1748 1696 2 1704 1 INV1S $T=426560 1001840 1 180 $X=425320 $Y=1001460
X1749 159 2 1723 1 INV1S $T=427800 890960 1 180 $X=426560 $Y=890580
X1750 1672 2 1753 1 INV1S $T=429040 971600 0 0 $X=429040 $Y=971220
X1751 154 2 1739 1 INV1S $T=432140 1032080 1 0 $X=432140 $Y=1026660
X1752 167 2 1768 1 INV1S $T=432760 1052240 0 0 $X=432760 $Y=1051860
X1753 1664 2 1783 1 INV1S $T=433380 911120 0 0 $X=433380 $Y=910740
X1754 1759 2 1764 1 INV1S $T=433380 931280 1 0 $X=433380 $Y=925860
X1755 1758 2 1757 1 INV1S $T=435240 991760 0 180 $X=434000 $Y=986340
X1756 1773 2 1776 1 INV1S $T=434000 1042160 1 0 $X=434000 $Y=1036740
X1757 171 2 1781 1 INV1S $T=434620 890960 0 0 $X=434620 $Y=890580
X1758 1775 2 1801 1 INV1S $T=437100 991760 0 0 $X=437100 $Y=991380
X1759 1796 2 1769 1 INV1S $T=437720 921200 1 0 $X=437720 $Y=915780
X1760 1721 2 1789 1 INV1S $T=437720 1032080 0 0 $X=437720 $Y=1031700
X1761 1768 2 1751 1 INV1S $T=438960 1062320 0 180 $X=437720 $Y=1056900
X1762 148 2 1805 1 INV1S $T=439580 921200 1 0 $X=439580 $Y=915780
X1763 1812 2 1810 1 INV1S $T=442060 931280 0 180 $X=440820 $Y=925860
X1764 1854 2 1660 1 INV1S $T=448260 911120 1 180 $X=447020 $Y=910740
X1765 1849 2 1840 1 INV1S $T=448260 921200 1 180 $X=447020 $Y=920820
X1766 1855 2 1842 1 INV1S $T=448260 991760 0 180 $X=447020 $Y=986340
X1767 1839 2 1831 1 INV1S $T=447020 1062320 1 0 $X=447020 $Y=1056900
X1768 1824 2 1856 1 INV1S $T=447640 901040 0 0 $X=447640 $Y=900660
X1769 1858 2 1862 1 INV1S $T=448880 890960 0 0 $X=448880 $Y=890580
X1770 1817 2 1854 1 INV1S $T=449500 911120 0 0 $X=449500 $Y=910740
X1771 1893 2 1880 1 INV1S $T=455080 921200 0 180 $X=453840 $Y=915780
X1772 164 2 1897 1 INV1S $T=453840 1042160 0 0 $X=453840 $Y=1041780
X1773 1900 2 1872 1 INV1S $T=455700 981680 1 180 $X=454460 $Y=981300
X1774 1912 2 1873 1 INV1S $T=458180 1062320 1 180 $X=456940 $Y=1061940
X1775 1919 2 1915 1 INV1S $T=461900 921200 1 180 $X=460660 $Y=920820
X1776 1943 2 1929 1 INV1S $T=463140 991760 1 0 $X=463140 $Y=986340
X1777 1925 2 1879 1 INV1S $T=464380 1062320 1 0 $X=464380 $Y=1056900
X1778 146 2 1752 1 INV1S $T=471820 901040 0 0 $X=471820 $Y=900660
X1779 1956 2 1981 1 INV1S $T=471820 931280 0 0 $X=471820 $Y=930900
X1780 1986 2 1993 1 INV1S $T=471820 981680 0 0 $X=471820 $Y=981300
X1781 2031 2 2019 1 INV1S $T=479260 931280 1 180 $X=478020 $Y=930900
X1782 2040 2 2008 1 INV1S $T=482360 991760 0 180 $X=481120 $Y=986340
X1783 2052 2 2014 1 INV1S $T=482980 1062320 1 180 $X=481740 $Y=1061940
X1784 2045 2 2069 1 INV1S $T=484840 941360 0 0 $X=484840 $Y=940980
X1785 135 2 2022 1 INV1S $T=486700 890960 1 180 $X=485460 $Y=890580
X1786 2060 2 2066 1 INV1S $T=486700 931280 0 0 $X=486700 $Y=930900
X1787 152 2 2041 1 INV1S $T=489180 890960 1 180 $X=487940 $Y=890580
X1788 2078 2 2068 1 INV1S $T=490420 991760 0 180 $X=489180 $Y=986340
X1789 2071 2 2088 1 INV1S $T=489800 1052240 0 0 $X=489800 $Y=1051860
X1790 2003 2 2081 1 INV1S $T=491660 1062320 1 0 $X=491660 $Y=1056900
X1791 2106 2 2111 1 INV1S $T=494760 931280 0 0 $X=494760 $Y=930900
X1792 2074 2 2112 1 INV1S $T=494760 971600 0 0 $X=494760 $Y=971220
X1793 2043 2 2113 1 INV1S $T=494760 981680 1 0 $X=494760 $Y=976260
X1794 2091 2 2131 1 INV1S $T=494760 991760 1 0 $X=494760 $Y=986340
X1795 2117 2 2120 1 INV1S $T=496620 911120 0 0 $X=496620 $Y=910740
X1796 2122 2 2115 1 INV1S $T=497860 1022000 0 180 $X=496620 $Y=1016580
X1797 2001 2 2148 1 INV1S $T=500340 941360 0 0 $X=500340 $Y=940980
X1798 1568 2 2135 1 INV1S $T=501580 931280 1 0 $X=501580 $Y=925860
X1799 129 2 1951 1 INV1S $T=502200 971600 1 0 $X=502200 $Y=966180
X1800 2067 2 2153 1 INV1S $T=503440 961520 1 0 $X=503440 $Y=956100
X1801 2095 2 2160 1 INV1S $T=503440 991760 0 0 $X=503440 $Y=991380
X1802 2053 2 2162 1 INV1S $T=505300 931280 0 0 $X=505300 $Y=930900
X1803 2012 2 2178 1 INV1S $T=507160 981680 1 0 $X=507160 $Y=976260
X1804 2124 2 2169 1 INV1S $T=507780 921200 1 0 $X=507780 $Y=915780
X1805 2097 2 2181 1 INV1S $T=508400 961520 0 0 $X=508400 $Y=961140
X1806 1934 2 194 1 INV1S $T=510880 1052240 1 0 $X=510880 $Y=1046820
X1807 2149 2 2205 1 INV1S $T=513360 961520 0 0 $X=513360 $Y=961140
X1808 2030 2 2209 1 INV1S $T=513980 921200 0 0 $X=513980 $Y=920820
X1809 1975 2 2217 1 INV1S $T=513980 1052240 0 0 $X=513980 $Y=1051860
X1810 2105 2 2223 1 INV1S $T=518320 921200 1 0 $X=518320 $Y=915780
X1811 2083 2 2233 1 INV1S $T=520180 1052240 0 0 $X=520180 $Y=1051860
X1812 2072 2 2242 1 INV1S $T=520800 971600 1 0 $X=520800 $Y=966180
X1813 2084 2 2235 1 INV1S $T=522040 931280 0 0 $X=522040 $Y=930900
X1814 193 2 221 1 INV1S $T=528860 1062320 1 180 $X=527620 $Y=1061940
X1815 2027 2 2268 1 INV1S $T=528240 1052240 1 0 $X=528240 $Y=1046820
X1816 194 2 219 1 INV1S $T=530720 1062320 0 0 $X=530720 $Y=1061940
X1817 2104 2 235 1 INV1S $T=538780 1062320 1 180 $X=537540 $Y=1061940
X1818 2039 2 2307 1 INV1S $T=539400 1042160 0 0 $X=539400 $Y=1041780
X1819 1994 2 2337 1 INV1S $T=549940 1062320 1 0 $X=549940 $Y=1056900
X1820 2377 2 2379 1 INV1S $T=556760 951440 0 0 $X=556760 $Y=951060
X1821 2386 2 2398 1 INV1S $T=559240 961520 1 0 $X=559240 $Y=956100
X1822 2335 2 2393 1 INV1S $T=559860 941360 0 0 $X=559860 $Y=940980
X1823 2324 2 2403 1 INV1S $T=561720 931280 0 0 $X=561720 $Y=930900
X1824 2354 2 2419 1 INV1S $T=564820 911120 1 0 $X=564820 $Y=905700
X1825 2276 2 2424 1 INV1S $T=566680 921200 0 0 $X=566680 $Y=920820
X1826 2364 2 2426 1 INV1S $T=566680 971600 1 0 $X=566680 $Y=966180
X1827 2434 2 2437 1 INV1S $T=568540 911120 0 0 $X=568540 $Y=910740
X1828 2374 2 2445 1 INV1S $T=569780 880880 0 0 $X=569780 $Y=880500
X1829 250 2 2450 1 INV1S $T=571020 901040 1 0 $X=571020 $Y=895620
X1830 2416 2 2430 1 INV1S $T=572880 971600 1 180 $X=571640 $Y=971220
X1831 2387 2 2478 1 INV1S $T=575980 991760 0 0 $X=575980 $Y=991380
X1832 2460 2 2465 1 INV1S $T=580320 981680 0 0 $X=580320 $Y=981300
X1833 2471 2 2515 1 INV1S $T=581560 991760 1 0 $X=581560 $Y=986340
X1834 2475 2 2514 1 INV1S $T=583420 981680 1 180 $X=582180 $Y=981300
X1835 2520 2 2539 1 INV1S $T=585280 911120 1 0 $X=585280 $Y=905700
X1836 2512 2 2527 1 INV1S $T=587140 981680 1 0 $X=587140 $Y=976260
X1837 2554 2 2546 1 INV1S $T=589620 951440 0 180 $X=588380 $Y=946020
X1838 2566 2 2560 1 INV1S $T=593340 991760 1 180 $X=592100 $Y=991380
X1839 2556 2 2576 1 INV1S $T=592720 921200 0 0 $X=592720 $Y=920820
X1840 2586 2 2594 1 INV1S $T=597060 921200 1 0 $X=597060 $Y=915780
X1841 2541 2 2589 1 INV1S $T=598920 981680 0 0 $X=598920 $Y=981300
X1842 2518 2 2605 1 INV1S $T=599540 921200 1 0 $X=599540 $Y=915780
X1843 2574 2 2617 1 INV1S $T=600780 921200 1 0 $X=600780 $Y=915780
X1844 2613 2 2620 1 INV1S $T=602640 890960 1 0 $X=602640 $Y=885540
X1845 2600 2 2563 1 INV1S $T=603880 931280 1 180 $X=602640 $Y=930900
X1846 2619 2 2637 1 INV1S $T=603880 961520 0 0 $X=603880 $Y=961140
X1847 2624 2 2628 1 INV1S $T=605740 911120 0 180 $X=604500 $Y=905700
X1848 2651 2 2643 1 INV1S $T=607600 901040 0 180 $X=606360 $Y=895620
X1849 2677 2 2601 1 INV1S $T=608840 951440 1 180 $X=607600 $Y=951060
X1850 2648 2 2657 1 INV1S $T=607600 1032080 0 0 $X=607600 $Y=1031700
X1851 2616 2 2642 1 INV1S $T=608840 991760 1 0 $X=608840 $Y=986340
X1852 2659 2 2655 1 INV1S $T=611940 1062320 0 180 $X=610700 $Y=1056900
X1853 2516 2 2632 1 INV1S $T=612560 931280 1 180 $X=611320 $Y=930900
X1854 279 2 2694 1 INV1S $T=615660 931280 1 0 $X=615660 $Y=925860
X1855 282 2 2707 1 INV1S $T=616280 1052240 0 0 $X=616280 $Y=1051860
X1856 2669 2 2573 1 INV1S $T=618760 961520 0 180 $X=617520 $Y=956100
X1857 2681 2 2709 1 INV1S $T=617520 991760 0 0 $X=617520 $Y=991380
X1858 2547 2 2721 1 INV1S $T=618140 911120 0 0 $X=618140 $Y=910740
X1859 2744 2 2749 1 INV1S $T=623720 1062320 1 0 $X=623720 $Y=1056900
X1860 2760 2 2753 1 INV1S $T=626200 1042160 0 180 $X=624960 $Y=1036740
X1861 2738 2 293 1 INV1S $T=630540 880880 1 180 $X=629300 $Y=880500
X1862 2580 2 2767 1 INV1S $T=631160 931280 1 0 $X=631160 $Y=925860
X1863 287 2 2735 1 INV1S $T=633020 931280 0 0 $X=633020 $Y=930900
X1864 2794 2 2748 1 INV1S $T=634260 1001840 0 180 $X=633020 $Y=996420
X1865 2791 2 2741 1 INV1S $T=636740 981680 1 180 $X=635500 $Y=981300
X1866 285 2 2800 1 INV1S $T=638600 931280 0 180 $X=637360 $Y=925860
X1867 2817 2 2756 1 INV1S $T=639220 971600 1 180 $X=637980 $Y=971220
X1868 2508 2 2793 1 INV1S $T=639220 931280 1 0 $X=639220 $Y=925860
X1869 296 2 2724 1 INV1S $T=642320 931280 1 180 $X=641080 $Y=930900
X1870 2844 2 2832 1 INV1S $T=642320 1062320 0 180 $X=641080 $Y=1056900
X1871 2752 2 2734 1 INV1S $T=641700 931280 1 0 $X=641700 $Y=925860
X1872 2838 2 2792 1 INV1S $T=642940 1001840 1 180 $X=641700 $Y=1001460
X1873 2768 2 2705 1 INV1S $T=643560 931280 1 0 $X=643560 $Y=925860
X1874 301 2 2736 1 INV1S $T=646040 931280 0 180 $X=644800 $Y=925860
X1875 2856 2 2660 1 INV1S $T=646040 1022000 0 180 $X=644800 $Y=1016580
X1876 286 2 2737 1 INV1S $T=647280 931280 1 180 $X=646040 $Y=930900
X1877 288 2 2728 1 INV1S $T=647280 941360 1 0 $X=647280 $Y=935940
X1878 2646 2 2701 1 INV1S $T=649760 971600 1 0 $X=649760 $Y=966180
X1879 2871 2 2841 1 INV1S $T=650380 1042160 0 0 $X=650380 $Y=1041780
X1880 2665 2 2720 1 INV1S $T=652860 911120 0 0 $X=652860 $Y=910740
X1881 304 2 2751 1 INV1S $T=654720 941360 1 0 $X=654720 $Y=935940
X1882 2904 2 2906 1 INV1S $T=654720 971600 0 0 $X=654720 $Y=971220
X1883 2623 2 2711 1 INV1S $T=655340 951440 1 0 $X=655340 $Y=946020
X1884 2755 2 2925 1 INV1S $T=660300 971600 0 180 $X=659060 $Y=966180
X1885 2912 2 2930 1 INV1S $T=659060 1042160 1 0 $X=659060 $Y=1036740
X1886 2953 2 2927 1 INV1S $T=663400 1001840 0 180 $X=662160 $Y=996420
X1887 2993 2 2909 1 INV1S $T=663400 1001840 1 180 $X=662160 $Y=1001460
X1888 2678 2 2764 1 INV1S $T=662780 911120 0 0 $X=662780 $Y=910740
X1889 2960 2 2963 1 INV1S $T=664020 1062320 1 0 $X=664020 $Y=1056900
X1890 2959 2 2774 1 INV1S $T=665880 951440 0 180 $X=664640 $Y=946020
X1891 2818 2 2910 1 INV1S $T=664640 1022000 1 0 $X=664640 $Y=1016580
X1892 311 2 2769 1 INV1S $T=665260 931280 1 0 $X=665260 $Y=925860
X1893 2740 2 2970 1 INV1S $T=665260 931280 0 0 $X=665260 $Y=930900
X1894 2977 2 2822 1 INV1S $T=667120 951440 0 180 $X=665880 $Y=946020
X1895 2886 2 2750 1 INV1S $T=667740 921200 1 0 $X=667740 $Y=915780
X1896 2980 2 2780 1 INV1S $T=668360 951440 1 0 $X=668360 $Y=946020
X1897 2986 2 2991 1 INV1S $T=668980 1062320 1 0 $X=668980 $Y=1056900
X1898 2929 2 2783 1 INV1S $T=669600 911120 1 0 $X=669600 $Y=905700
X1899 2917 2 2796 1 INV1S $T=670840 921200 1 0 $X=670840 $Y=915780
X1900 2994 2 2835 1 INV1S $T=672080 921200 1 180 $X=670840 $Y=920820
X1901 2990 2 3014 1 INV1S $T=674560 971600 0 0 $X=674560 $Y=971220
X1902 3018 2 3024 1 INV1S $T=677040 971600 0 0 $X=677040 $Y=971220
X1903 2765 2 2984 1 INV1S $T=677660 941360 0 0 $X=677660 $Y=940980
X1904 2892 2 2989 1 INV1S $T=679520 1011920 1 180 $X=678280 $Y=1011540
X1905 2723 2 3058 1 INV1S $T=682000 941360 0 0 $X=682000 $Y=940980
X1906 2723 2 3040 1 INV1S $T=683240 951440 0 180 $X=682000 $Y=946020
X1907 3007 2 3050 1 INV1S $T=682620 890960 0 0 $X=682620 $Y=890580
X1908 2976 2 2831 1 INV1S $T=683860 921200 0 180 $X=682620 $Y=915780
X1909 2723 2 3048 1 INV1S $T=682620 941360 1 0 $X=682620 $Y=935940
X1910 2922 2 3052 1 INV1S $T=682620 1032080 1 0 $X=682620 $Y=1026660
X1911 3057 2 2915 1 INV1S $T=685720 951440 1 180 $X=684480 $Y=951060
X1912 2623 2 3001 1 INV1S $T=684480 1032080 1 0 $X=684480 $Y=1026660
X1913 3052 2 3047 1 INV1S $T=685720 1042160 1 180 $X=684480 $Y=1041780
X1914 2988 2 2890 1 INV1S $T=685100 931280 1 0 $X=685100 $Y=925860
X1915 2996 2 2849 1 INV1S $T=687580 951440 0 180 $X=686340 $Y=946020
X1916 3028 2 328 1 INV1S $T=686340 1062320 1 0 $X=686340 $Y=1056900
X1917 3056 2 2911 1 INV1S $T=686960 931280 1 0 $X=686960 $Y=925860
X1918 3005 2 2898 1 INV1S $T=687580 941360 0 0 $X=687580 $Y=940980
X1919 3068 2 2874 1 INV1S $T=688820 921200 1 0 $X=688820 $Y=915780
X1920 3062 2 3094 1 INV1S $T=693160 961520 1 0 $X=693160 $Y=956100
X1921 2701 2 3100 1 INV1S $T=696260 961520 1 0 $X=696260 $Y=956100
X1922 3083 2 3130 1 INV1S $T=698120 921200 0 0 $X=698120 $Y=920820
X1923 3015 2 3120 1 INV1S $T=698120 1052240 1 0 $X=698120 $Y=1046820
X1924 3093 2 3133 1 INV1S $T=701220 941360 1 0 $X=701220 $Y=935940
X1925 3105 2 3162 1 INV1S $T=706800 901040 0 0 $X=706800 $Y=900660
X1926 3077 2 3182 1 INV1S $T=708660 890960 1 0 $X=708660 $Y=885540
X1927 3087 2 3183 1 INV1S $T=714860 961520 0 180 $X=713620 $Y=956100
X1928 3190 2 3177 1 INV1S $T=714860 1001840 0 180 $X=713620 $Y=996420
X1929 335 2 3208 1 INV1S $T=717340 931280 0 0 $X=717340 $Y=930900
X1930 336 2 3219 1 INV1S $T=719820 931280 0 0 $X=719820 $Y=930900
X1931 338 2 3230 1 INV1S $T=720440 931280 1 0 $X=720440 $Y=925860
X1932 3224 2 3227 1 INV1S $T=724780 991760 1 180 $X=723540 $Y=991380
X1933 3223 2 3214 1 INV1S $T=724160 1022000 0 0 $X=724160 $Y=1021620
X1934 3225 2 3243 1 INV1S $T=725400 1032080 0 180 $X=724160 $Y=1026660
X1935 3236 2 3185 1 INV1S $T=725400 1001840 0 0 $X=725400 $Y=1001460
X1936 3256 2 3249 1 INV1S $T=728500 1032080 0 180 $X=727260 $Y=1026660
X1937 3191 2 3184 1 INV1S $T=727260 1032080 0 0 $X=727260 $Y=1031700
X1938 347 2 3238 1 INV1S $T=729120 880880 0 0 $X=729120 $Y=880500
X1939 3247 2 3267 1 INV1S $T=729120 981680 0 0 $X=729120 $Y=981300
X1940 3264 2 3211 1 INV1S $T=729120 1001840 0 0 $X=729120 $Y=1001460
X1941 349 2 3279 1 INV1S $T=732840 901040 1 0 $X=732840 $Y=895620
X1942 3288 2 3277 1 INV1S $T=735320 991760 0 180 $X=734080 $Y=986340
X1943 3292 2 3248 1 INV1S $T=737800 971600 1 0 $X=737800 $Y=966180
X1944 3307 2 3295 1 INV1S $T=740900 1001840 1 0 $X=740900 $Y=996420
X1945 3375 2 364 1 INV1S $T=752680 880880 0 0 $X=752680 $Y=880500
X1946 3386 2 370 1 INV1S $T=758260 890960 1 0 $X=758260 $Y=885540
X1947 3381 2 371 1 INV1S $T=758260 890960 0 0 $X=758260 $Y=890580
X1948 3400 2 350 1 INV1S $T=759500 951440 1 180 $X=758260 $Y=951060
X1949 373 2 3239 1 INV1S $T=761360 961520 1 0 $X=761360 $Y=956100
X1950 3419 2 342 1 INV1S $T=764460 961520 0 180 $X=763220 $Y=956100
X1951 3417 2 376 1 INV1S $T=763840 890960 1 0 $X=763840 $Y=885540
X1952 3428 2 360 1 INV1S $T=765700 911120 0 180 $X=764460 $Y=905700
X1953 3441 2 379 1 INV1S $T=766940 911120 0 0 $X=766940 $Y=910740
X1954 3452 2 385 1 INV1S $T=769420 911120 0 0 $X=769420 $Y=910740
X1955 3446 2 384 1 INV1S $T=770040 901040 1 0 $X=770040 $Y=895620
X1956 3460 2 386 1 INV1S $T=771280 911120 0 0 $X=771280 $Y=910740
X1957 3471 2 3476 1 INV1S $T=773140 901040 1 0 $X=773140 $Y=895620
X1958 3472 2 390 1 INV1S $T=773140 911120 0 0 $X=773140 $Y=910740
X1959 349 2 3496 1 INV1S $T=778720 890960 0 0 $X=778720 $Y=890580
X1960 3465 2 378 1 INV1S $T=778720 901040 0 0 $X=778720 $Y=900660
X1961 3505 2 362 1 INV1S $T=783060 941360 1 180 $X=781820 $Y=940980
X1962 3521 2 395 1 INV1S $T=784300 890960 1 180 $X=783060 $Y=890580
X1963 397 2 3518 1 INV1S $T=784920 880880 0 0 $X=784920 $Y=880500
X1964 3488 2 400 1 INV1S $T=790500 911120 0 0 $X=790500 $Y=910740
X1965 3541 2 3526 1 INV1S $T=794220 890960 1 0 $X=794220 $Y=885540
X1966 406 2 3543 1 INV1S $T=797320 1001840 1 180 $X=796080 $Y=1001460
X1967 3555 2 3564 1 INV1S $T=799180 890960 0 0 $X=799180 $Y=890580
X1968 3585 2 408 1 INV1S $T=805380 911120 1 180 $X=804140 $Y=910740
X1969 3568 2 3595 1 INV1S $T=805380 901040 1 0 $X=805380 $Y=895620
X1970 3533 2 410 1 INV1S $T=806000 911120 1 0 $X=806000 $Y=905700
X1971 3572 2 416 1 INV1S $T=807240 890960 0 0 $X=807240 $Y=890580
X1972 418 2 3601 1 INV1S $T=809100 890960 0 0 $X=809100 $Y=890580
X1973 417 2 3606 1 INV1S $T=809100 951440 1 0 $X=809100 $Y=946020
X1974 419 2 3602 1 INV1S $T=810340 961520 1 180 $X=809100 $Y=961140
X1975 3611 2 3610 1 INV1S $T=810960 951440 1 0 $X=810960 $Y=946020
X1976 3605 2 3615 1 INV1S $T=812200 901040 1 0 $X=812200 $Y=895620
X1977 3623 2 422 1 INV1S $T=815300 901040 0 180 $X=814060 $Y=895620
X1978 424 2 3629 1 INV1S $T=815920 890960 0 0 $X=815920 $Y=890580
X1979 427 2 3649 1 INV1S $T=820260 890960 1 0 $X=820260 $Y=885540
X1980 3650 2 429 1 INV1S $T=821500 901040 0 180 $X=820260 $Y=895620
X1981 3642 2 432 1 INV1S $T=821500 890960 1 0 $X=821500 $Y=885540
X1982 3655 2 3667 1 INV1S $T=825840 901040 1 0 $X=825840 $Y=895620
X1983 3644 2 433 1 INV1S $T=829560 951440 1 0 $X=829560 $Y=946020
X1984 3674 2 442 1 INV1S $T=830180 931280 0 0 $X=830180 $Y=930900
X1985 3669 2 436 1 INV1S $T=832660 901040 0 180 $X=831420 $Y=895620
X1986 3746 2 450 1 INV1S $T=853120 911120 1 0 $X=853120 $Y=905700
X1987 448 2 3773 1 INV1S $T=853740 880880 0 0 $X=853740 $Y=880500
X1988 3793 2 3734 1 INV1S $T=861800 931280 1 180 $X=860560 $Y=930900
X1989 3781 2 452 1 INV1S $T=864280 901040 0 0 $X=864280 $Y=900660
X1990 3707 2 3846 1 INV1S $T=869860 890960 1 0 $X=869860 $Y=885540
X1991 3830 2 3851 1 INV1S $T=878540 901040 1 0 $X=878540 $Y=895620
X1992 3852 2 453 1 INV1S $T=879780 931280 1 180 $X=878540 $Y=930900
X1993 3862 2 461 1 INV1S $T=882260 911120 1 180 $X=881020 $Y=910740
X1994 3861 2 3847 1 INV1S $T=882260 890960 0 0 $X=882260 $Y=890580
X1995 463 2 3867 1 INV1S $T=883500 880880 0 0 $X=883500 $Y=880500
X1996 3871 2 446 1 INV1S $T=885360 911120 1 180 $X=884120 $Y=910740
X1997 3848 2 3878 1 INV1S $T=885980 901040 0 0 $X=885980 $Y=900660
X1998 3869 2 467 1 INV1S $T=888460 911120 1 0 $X=888460 $Y=905700
X1999 3913 2 3893 1 INV1S $T=895900 890960 0 180 $X=894660 $Y=885540
X2000 3916 2 3902 1 INV1S $T=897140 890960 1 180 $X=895900 $Y=890580
X2001 476 2 3934 1 INV1S $T=902100 890960 0 0 $X=902100 $Y=890580
X2002 3873 2 3933 1 INV1S $T=904580 901040 0 0 $X=904580 $Y=900660
X2003 3923 2 462 1 INV1S $T=907680 941360 1 0 $X=907680 $Y=935940
X2004 3943 2 459 1 INV1S $T=909540 911120 1 180 $X=908300 $Y=910740
X2005 3941 2 477 1 INV1S $T=910780 890960 1 0 $X=910780 $Y=885540
X2006 3951 2 3942 1 INV1S $T=912020 890960 1 180 $X=910780 $Y=890580
X2007 3948 2 3946 1 INV1S $T=911400 911120 1 0 $X=911400 $Y=905700
X2008 3778 2 3990 1 INV1S $T=912020 890960 1 0 $X=912020 $Y=885540
X2009 3742 2 482 1 INV1S $T=916980 901040 1 0 $X=916980 $Y=895620
X2010 3950 2 3971 1 INV1S $T=917600 951440 0 0 $X=917600 $Y=951060
X2011 3986 2 3969 1 INV1S $T=920080 951440 0 180 $X=918840 $Y=946020
X2012 3977 2 486 1 INV1S $T=918840 951440 0 0 $X=918840 $Y=951060
X2013 3964 2 3974 1 INV1S $T=921320 931280 0 0 $X=921320 $Y=930900
X2014 3804 2 3994 1 INV1S $T=923180 901040 1 0 $X=923180 $Y=895620
X2015 4003 2 488 1 INV1S $T=926900 901040 0 0 $X=926900 $Y=900660
X2016 3743 2 4012 1 INV1S $T=927520 890960 0 0 $X=927520 $Y=890580
X2017 4004 2 3981 1 INV1S $T=928140 901040 0 0 $X=928140 $Y=900660
X2018 3794 2 4021 1 INV1S $T=930620 890960 0 0 $X=930620 $Y=890580
X2019 4042 2 493 1 INV1S $T=936820 931280 1 180 $X=935580 $Y=930900
X2020 3822 2 500 1 INV1S $T=937440 890960 1 0 $X=937440 $Y=885540
X2021 499 2 4068 1 INV1S $T=938680 880880 0 0 $X=938680 $Y=880500
X2022 3840 2 4060 1 INV1S $T=938680 890960 0 0 $X=938680 $Y=890580
X2023 4061 2 502 1 INV1S $T=940540 901040 1 0 $X=940540 $Y=895620
X2024 4067 2 501 1 INV1S $T=940540 911120 0 0 $X=940540 $Y=910740
X2025 4046 2 503 1 INV1S $T=943640 911120 1 0 $X=943640 $Y=905700
X2026 4038 2 512 1 INV1S $T=946120 890960 1 0 $X=946120 $Y=885540
X2027 4111 2 4075 1 INV1S $T=952320 901040 0 0 $X=952320 $Y=900660
X2028 4025 2 4127 1 INV1S $T=954800 901040 0 0 $X=954800 $Y=900660
X2029 4122 2 509 1 INV1S $T=959140 951440 1 0 $X=959140 $Y=946020
X2030 4126 2 513 1 INV1S $T=961620 880880 0 0 $X=961620 $Y=880500
X2031 4118 2 515 1 INV1S $T=964100 880880 0 0 $X=964100 $Y=880500
X2032 4110 2 4149 1 INV1S $T=964100 890960 1 0 $X=964100 $Y=885540
X2033 4129 2 4159 1 INV1S $T=964720 890960 0 0 $X=964720 $Y=890580
X2034 516 2 4150 1 INV1S $T=965960 880880 0 0 $X=965960 $Y=880500
X2035 4138 2 514 1 INV1S $T=970920 951440 1 0 $X=970920 $Y=946020
X2036 4167 2 4173 1 INV1S $T=972780 890960 0 0 $X=972780 $Y=890580
X2037 520 2 522 1 INV1S $T=974020 890960 1 0 $X=974020 $Y=885540
X2038 4212 2 530 1 INV1S $T=986420 911120 0 0 $X=986420 $Y=910740
X2039 4210 2 4220 1 INV1S $T=987040 890960 0 0 $X=987040 $Y=890580
X2040 4213 2 4206 1 INV1S $T=987660 901040 0 0 $X=987660 $Y=900660
X2041 4094 2 531 1 INV1S $T=988280 890960 1 0 $X=988280 $Y=885540
X2042 4191 2 534 1 INV1S $T=995100 951440 1 0 $X=995100 $Y=946020
X2043 4247 2 536 1 INV1S $T=1001920 901040 1 0 $X=1001920 $Y=895620
X2044 4054 2 537 1 INV1S $T=1003780 911120 1 0 $X=1003780 $Y=905700
X2045 4260 2 4289 1 INV1S $T=1014320 890960 0 0 $X=1014320 $Y=890580
X2046 4295 2 4305 1 INV1S $T=1017420 890960 0 0 $X=1017420 $Y=890580
X2047 4291 2 4302 1 INV1S $T=1018040 901040 1 0 $X=1018040 $Y=895620
X2048 4172 2 542 1 INV1S $T=1018040 901040 0 0 $X=1018040 $Y=900660
X2049 4306 2 543 1 INV1S $T=1023000 911120 0 0 $X=1023000 $Y=910740
X2050 4251 2 4322 1 INV1S $T=1025480 901040 1 0 $X=1025480 $Y=895620
X2051 4321 2 545 1 INV1S $T=1027960 890960 1 0 $X=1027960 $Y=885540
X2052 4281 2 4341 1 INV1S $T=1032300 880880 0 0 $X=1032300 $Y=880500
X2053 4286 2 4352 1 INV1S $T=1034160 901040 1 0 $X=1034160 $Y=895620
X2054 4316 2 4292 1 INV1S $T=1034780 961520 1 0 $X=1034780 $Y=956100
X2055 4366 2 553 1 INV1S $T=1039740 880880 0 0 $X=1039740 $Y=880500
X2056 4372 2 4362 1 INV1S $T=1041600 951440 1 0 $X=1041600 $Y=946020
X2057 4382 2 550 1 INV1S $T=1044700 901040 0 180 $X=1043460 $Y=895620
X2058 4373 2 554 1 INV1S $T=1045320 951440 1 0 $X=1045320 $Y=946020
X2059 4386 2 4392 1 INV1S $T=1047800 890960 0 0 $X=1047800 $Y=890580
X2060 4399 2 556 1 INV1S $T=1050900 890960 1 180 $X=1049660 $Y=890580
X2061 4342 2 555 1 INV1S $T=1052140 890960 0 0 $X=1052140 $Y=890580
X2062 4409 2 557 1 INV1S $T=1055860 890960 1 180 $X=1054620 $Y=890580
X2063 4381 2 560 1 INV1S $T=1058340 890960 0 0 $X=1058340 $Y=890580
X2064 4437 2 559 1 INV1S $T=1062680 901040 0 180 $X=1061440 $Y=895620
X2065 4334 2 565 1 INV1S $T=1063920 901040 1 0 $X=1063920 $Y=895620
X2066 767 775 825 2 1 842 XOR3 $T=247380 1032080 1 0 $X=247380 $Y=1026660
X2067 782 791 804 2 1 852 XOR3 $T=248620 1042160 0 0 $X=248620 $Y=1041780
X2068 696 853 769 2 1 62 XOR3 $T=260400 1052240 0 0 $X=260400 $Y=1051860
X2069 58 30 938 2 1 967 XOR3 $T=268460 1062320 1 0 $X=268460 $Y=1056900
X2070 922 842 970 2 1 958 XOR3 $T=273420 1032080 0 0 $X=273420 $Y=1031700
X2071 937 761 900 2 1 998 XOR3 $T=275900 1022000 0 0 $X=275900 $Y=1021620
X2072 1052 1029 983 2 1 58 XOR3 $T=295120 1062320 0 180 $X=283960 $Y=1056900
X2073 1068 1057 1042 2 1 904 XOR3 $T=305040 1042160 1 180 $X=293880 $Y=1041780
X2074 1082 1056 1053 2 1 922 XOR3 $T=307520 1032080 1 180 $X=296360 $Y=1031700
X2075 1059 671 1084 2 1 1110 XOR3 $T=299460 911120 1 0 $X=299460 $Y=905700
X2076 995 773 1010 2 1 1147 XOR3 $T=299460 1011920 0 0 $X=299460 $Y=1011540
X2077 1061 677 1074 2 1 1139 XOR3 $T=300080 991760 1 0 $X=300080 $Y=986340
X2078 1065 655 1090 2 1 1160 XOR3 $T=300700 921200 1 0 $X=300700 $Y=915780
X2079 1050 664 1087 2 1 1132 XOR3 $T=300700 931280 0 0 $X=300700 $Y=930900
X2080 987 679 1055 2 1 1157 XOR3 $T=304420 991760 0 0 $X=304420 $Y=991380
X2081 1086 663 1096 2 1 1165 XOR3 $T=305660 890960 0 0 $X=305660 $Y=890580
X2082 1041 683 1047 2 1 1163 XOR3 $T=305660 1001840 0 0 $X=305660 $Y=1001460
X2083 1122 84 1115 2 1 93 XOR3 $T=314340 1062320 0 0 $X=314340 $Y=1061940
X2084 1254 95 1186 2 1 89 XOR3 $T=332320 1062320 0 180 $X=321160 $Y=1056900
X2085 1269 1276 1299 2 1 103 XOR3 $T=335420 1052240 0 0 $X=335420 $Y=1051860
X2086 1273 1282 1307 2 1 1334 XOR3 $T=336040 1022000 0 0 $X=336040 $Y=1021620
X2087 1281 1286 1274 2 1 1342 XOR3 $T=336660 1042160 0 0 $X=336660 $Y=1041780
X2088 1325 1336 1330 2 1 1372 XOR3 $T=345960 1011920 0 0 $X=345960 $Y=1011540
X2089 859 1342 1329 2 1 1396 XOR3 $T=347200 1052240 1 0 $X=347200 $Y=1046820
X2090 1344 1352 1356 2 1 1362 XOR3 $T=348440 1001840 1 0 $X=348440 $Y=996420
X2091 1334 998 1350 2 1 1393 XOR3 $T=350920 1022000 0 0 $X=350920 $Y=1021620
X2092 1358 1364 1390 2 1 1415 XOR3 $T=351540 961520 0 0 $X=351540 $Y=961140
X2093 1362 1163 1404 2 1 1412 XOR3 $T=352160 1001840 0 0 $X=352160 $Y=1001460
X2094 1367 1370 1379 2 1 1385 XOR3 $T=352780 991760 1 0 $X=352780 $Y=986340
X2095 1371 1374 1400 2 1 1405 XOR3 $T=354020 971600 0 0 $X=354020 $Y=971220
X2096 1372 1147 1365 2 1 1414 XOR3 $T=354020 1022000 1 0 $X=354020 $Y=1016580
X2097 1373 1378 1406 2 1 1423 XOR3 $T=354640 931280 0 0 $X=354640 $Y=930900
X2098 1391 1399 1381 2 1 1369 XOR3 $T=365800 1052240 1 180 $X=354640 $Y=1051860
X2099 1380 1383 1397 2 1 1426 XOR3 $T=355880 941360 0 0 $X=355880 $Y=940980
X2100 1375 1386 1384 2 1 1435 XOR3 $T=356500 890960 0 0 $X=356500 $Y=890580
X2101 1385 1157 1420 2 1 1443 XOR3 $T=357120 991760 0 0 $X=357120 $Y=991380
X2102 1388 1395 1392 2 1 1416 XOR3 $T=358980 901040 0 0 $X=358980 $Y=900660
X2103 1402 1403 1382 2 1 1442 XOR3 $T=360840 921200 1 0 $X=360840 $Y=915780
X2104 1405 1139 1418 2 1 1434 XOR3 $T=362080 981680 1 0 $X=362080 $Y=976260
X2105 1377 1409 1389 2 1 1449 XOR3 $T=365180 921200 0 0 $X=365180 $Y=920820
X2106 1415 1089 1421 2 1 1454 XOR3 $T=365800 961520 0 0 $X=365800 $Y=961140
X2107 1430 1448 1425 2 1 1394 XOR3 $T=377580 1032080 1 180 $X=366420 $Y=1031700
X2108 1423 1132 1436 2 1 1476 XOR3 $T=367660 941360 1 0 $X=367660 $Y=935940
X2109 1428 1432 1451 2 1 1460 XOR3 $T=368280 1022000 1 0 $X=368280 $Y=1016580
X2110 1470 1463 1439 2 1 1430 XOR3 $T=380060 1052240 1 180 $X=368900 $Y=1051860
X2111 1426 1117 1424 2 1 1475 XOR3 $T=370140 951440 1 0 $X=370140 $Y=946020
X2112 1416 1165 1410 2 1 1483 XOR3 $T=371380 890960 0 0 $X=371380 $Y=890580
X2113 1435 110 1437 2 1 1482 XOR3 $T=372620 890960 1 0 $X=372620 $Y=885540
X2114 1449 1160 1452 2 1 1471 XOR3 $T=373860 931280 1 0 $X=373860 $Y=925860
X2115 1442 1110 1441 2 1 1462 XOR3 $T=375100 911120 1 0 $X=375100 $Y=905700
X2116 1495 1489 1461 2 1 1448 XOR3 $T=387500 981680 1 180 $X=376340 $Y=981300
X2117 1558 1578 1561 2 1 1545 XOR3 $T=406720 1022000 0 180 $X=395560 $Y=1016580
X2118 1606 1594 1562 2 1 1558 XOR3 $T=406720 1032080 0 180 $X=395560 $Y=1026660
X2119 1774 1787 1763 2 1 177 XOR3 $T=435240 1011920 1 0 $X=435240 $Y=1006500
X2120 1844 1829 1830 2 1 181 XOR3 $T=446400 1011920 0 0 $X=446400 $Y=1011540
X2121 2152 2147 2099 2 1 2093 XOR3 $T=503440 1052240 0 180 $X=492280 $Y=1046820
X2122 2080 2093 195 2 1 2173 XOR3 $T=496620 1032080 0 0 $X=496620 $Y=1031700
X2123 2127 2132 2157 2 1 2190 XOR3 $T=497860 1001840 0 0 $X=497860 $Y=1001460
X2124 2114 2122 2133 2 1 2161 XOR3 $T=502820 1022000 1 0 $X=502820 $Y=1016580
X2125 2196 2195 2158 2 1 2122 XOR3 $T=514600 1032080 0 180 $X=503440 $Y=1026660
X2126 2197 2137 2187 2 1 2248 XOR3 $T=512740 1001840 0 0 $X=512740 $Y=1001460
X2127 2206 2208 2244 2 1 2272 XOR3 $T=513980 991760 0 0 $X=513980 $Y=991380
X2128 2174 2210 2220 2 1 2259 XOR3 $T=514600 971600 0 0 $X=514600 $Y=971220
X2129 2250 2243 2212 2 1 2218 XOR3 $T=528240 1032080 1 180 $X=517080 $Y=1031700
X2130 2200 2219 2230 2 1 2299 XOR3 $T=528240 971600 0 0 $X=528240 $Y=971220
X2131 2165 2221 2246 2 1 2300 XOR3 $T=528240 981680 1 0 $X=528240 $Y=976260
X2132 2269 2273 2264 2 1 2294 XOR3 $T=529480 1042160 1 0 $X=529480 $Y=1036740
X2133 2294 2248 2282 2 1 2263 XOR3 $T=543120 1011920 1 180 $X=531960 $Y=1011540
X2134 2227 2199 2275 2 1 2336 XOR3 $T=536920 951440 0 0 $X=536920 $Y=951060
X2135 2317 2319 2289 2 1 2360 XOR3 $T=541880 1032080 0 0 $X=541880 $Y=1031700
X2136 2360 2272 2310 2 1 2312 XOR3 $T=553660 1011920 0 180 $X=542500 $Y=1006500
X2137 240 242 243 2 1 2402 XOR3 $T=548700 1062320 0 0 $X=548700 $Y=1061940
X2138 2352 2355 2343 2 1 2365 XOR3 $T=550560 1042160 1 0 $X=550560 $Y=1036740
X2139 2365 2300 2399 2 1 2428 XOR3 $T=554280 1011920 0 0 $X=554280 $Y=1011540
X2140 2333 2376 2370 2 1 2405 XOR3 $T=555520 1052240 0 0 $X=555520 $Y=1051860
X2141 2405 2259 2417 2 1 2483 XOR3 $T=562960 1032080 1 0 $X=562960 $Y=1026660
X2142 247 2316 2418 2 1 255 XOR3 $T=564200 1062320 0 0 $X=564200 $Y=1061940
X2143 2402 2299 2448 2 1 2468 XOR3 $T=564820 1042160 0 0 $X=564820 $Y=1041780
X2144 252 2336 2449 2 1 2550 XOR3 $T=574120 1062320 1 0 $X=574120 $Y=1056900
X2145 2257 275 2588 2 1 280 XOR3 $T=594580 1062320 0 0 $X=594580 $Y=1061940
X2146 3312 3302 357 2 1 3326 XOR3 $T=739040 931280 0 0 $X=739040 $Y=930900
X2147 3365 3340 3313 2 1 3300 XOR3 $T=750820 971600 1 180 $X=739660 $Y=971220
X2148 922 842 970 1 2 947 MAO222 $T=287680 1032080 0 0 $X=287680 $Y=1031700
X2149 77 76 11 1 2 74 MAO222 $T=298840 880880 1 180 $X=293880 $Y=880500
X2150 1056 1053 1082 1 2 1042 MAO222 $T=303800 1042160 0 180 $X=298840 $Y=1036740
X2151 1057 1068 1042 1 2 983 MAO222 $T=303800 1052240 0 180 $X=298840 $Y=1046820
X2152 1029 1052 983 1 2 79 MAO222 $T=298840 1062320 1 0 $X=298840 $Y=1056900
X2153 1050 1087 664 1 2 1090 MAO222 $T=305040 931280 1 0 $X=305040 $Y=925860
X2154 89 98 62 1 2 104 MAO222 $T=329220 1062320 0 0 $X=329220 $Y=1061940
X2155 100 99 101 1 2 97 MAO222 $T=337280 880880 1 180 $X=332320 $Y=880500
X2156 1254 1186 95 1 2 1299 MAO222 $T=334800 1062320 1 0 $X=334800 $Y=1056900
X2157 1269 1299 1276 1 2 1274 MAO222 $T=339140 1052240 1 0 $X=339140 $Y=1046820
X2158 1273 1307 1282 1 2 1330 MAO222 $T=340380 1022000 1 0 $X=340380 $Y=1016580
X2159 1325 1330 1336 1 2 1356 MAO222 $T=344720 1001840 0 0 $X=344720 $Y=1001460
X2160 1334 1350 998 1 2 1365 MAO222 $T=346580 1022000 1 0 $X=346580 $Y=1016580
X2161 1344 1356 1352 1 2 1379 MAO222 $T=349680 991760 0 0 $X=349680 $Y=991380
X2162 1367 1379 1370 1 2 1400 MAO222 $T=354640 981680 1 0 $X=354640 $Y=976260
X2163 1377 1389 1409 1 2 1382 MAO222 $T=361460 921200 1 180 $X=356500 $Y=920820
X2164 1388 1392 1395 1 2 1384 MAO222 $T=362080 901040 0 180 $X=357120 $Y=895620
X2165 1380 1397 1383 1 2 1406 MAO222 $T=357740 941360 1 0 $X=357740 $Y=935940
X2166 1375 1384 1386 1 2 111 MAO222 $T=358980 890960 1 0 $X=358980 $Y=885540
X2167 1358 1390 1364 1 2 1397 MAO222 $T=358980 961520 1 0 $X=358980 $Y=956100
X2168 1371 1400 1374 1 2 1390 MAO222 $T=363940 971600 0 180 $X=358980 $Y=966180
X2169 1402 1382 1403 1 2 1392 MAO222 $T=365180 911120 0 180 $X=360220 $Y=905700
X2170 1373 1406 1378 1 2 1389 MAO222 $T=365180 931280 0 180 $X=360220 $Y=925860
X2171 1362 1404 1163 1 2 1420 MAO222 $T=361460 1001840 1 0 $X=361460 $Y=996420
X2172 109 111 115 1 2 112 MAO222 $T=370140 890960 0 180 $X=365180 $Y=885540
X2173 1435 1437 110 1 2 119 MAO222 $T=372000 880880 0 0 $X=372000 $Y=880500
X2174 1453 1466 1455 1 2 118 MAO222 $T=381920 1062320 1 180 $X=376960 $Y=1061940
X2175 1477 1474 1484 1 2 1439 MAO222 $T=384400 1052240 0 180 $X=379440 $Y=1046820
X2176 1488 1468 1509 1 2 1461 MAO222 $T=388740 971600 1 180 $X=383780 $Y=971220
X2177 1502 1497 1517 1 2 1451 MAO222 $T=388740 1022000 0 180 $X=383780 $Y=1016580
X2178 1510 1553 1547 1 2 1484 MAO222 $T=398660 1042160 0 180 $X=393700 $Y=1036740
X2179 1558 1578 1561 1 2 1502 MAO222 $T=403000 1011920 0 180 $X=398040 $Y=1006500
X2180 1587 1580 1585 1 2 1536 MAO222 $T=403620 961520 0 180 $X=398660 $Y=956100
X2181 1594 1562 1606 1 2 1553 MAO222 $T=406100 1032080 1 180 $X=401140 $Y=1031700
X2182 1684 1621 1670 1 2 1724 MAO222 $T=420360 1011920 1 0 $X=420360 $Y=1006500
X2183 1707 1724 1716 1 2 1763 MAO222 $T=427180 1011920 1 0 $X=427180 $Y=1006500
X2184 1774 1763 1787 1 2 1830 MAO222 $T=440200 1001840 0 0 $X=440200 $Y=1001460
X2185 1844 1830 1829 1 2 1883 MAO222 $T=446400 1001840 0 0 $X=446400 $Y=1001460
X2186 2152 2099 2147 1 2 2158 MAO222 $T=503440 1052240 1 0 $X=503440 $Y=1046820
X2187 2127 2157 2132 1 2 2187 MAO222 $T=504680 1001840 1 0 $X=504680 $Y=996420
X2188 2196 2158 2195 1 2 2212 MAO222 $T=510260 1042160 1 0 $X=510260 $Y=1036740
X2189 2250 2212 2243 1 2 2264 MAO222 $T=522040 1042160 1 0 $X=522040 $Y=1036740
X2190 2171 2256 2176 1 2 2229 MAO222 $T=528240 951440 1 180 $X=523280 $Y=951060
X2191 2227 2275 2199 1 2 2256 MAO222 $T=533820 951440 1 180 $X=528860 $Y=951060
X2192 2269 2264 2273 1 2 2289 MAO222 $T=530720 1032080 0 0 $X=530720 $Y=1031700
X2193 2294 2282 2248 1 2 2310 MAO222 $T=535060 1011920 1 0 $X=535060 $Y=1006500
X2194 2317 2289 2319 1 2 2343 MAO222 $T=543120 1042160 1 0 $X=543120 $Y=1036740
X2195 2333 2370 2376 1 2 243 MAO222 $T=558000 1062320 0 180 $X=553040 $Y=1056900
X2196 2352 2343 2355 1 2 2370 MAO222 $T=554900 1042160 0 0 $X=554900 $Y=1041780
X2197 252 2449 2336 1 2 2588 MAO222 $T=589000 1062320 1 0 $X=589000 $Y=1056900
X2198 593 594 616 2 1 XOR2HS $T=220720 921200 0 0 $X=220720 $Y=920820
X2199 4 3 620 2 1 XOR2HS $T=221340 890960 1 0 $X=221340 $Y=885540
X2200 600 590 621 2 1 XOR2HS $T=221340 901040 1 0 $X=221340 $Y=895620
X2201 601 609 622 2 1 XOR2HS $T=221340 911120 0 0 $X=221340 $Y=910740
X2202 602 595 623 2 1 XOR2HS $T=221340 941360 1 0 $X=221340 $Y=935940
X2203 603 596 624 2 1 XOR2HS $T=221340 951440 0 0 $X=221340 $Y=951060
X2204 605 610 625 2 1 XOR2HS $T=221340 981680 1 0 $X=221340 $Y=976260
X2205 606 591 626 2 1 XOR2HS $T=221340 991760 1 0 $X=221340 $Y=986340
X2206 607 611 627 2 1 XOR2HS $T=221340 1001840 0 0 $X=221340 $Y=1001460
X2207 608 592 629 2 1 XOR2HS $T=221340 1042160 0 0 $X=221340 $Y=1041780
X2208 598 636 613 2 1 XOR2HS $T=227540 1011920 1 180 $X=221960 $Y=1011540
X2209 612 614 647 2 1 XOR2HS $T=224440 1032080 1 0 $X=224440 $Y=1026660
X2210 628 599 653 2 1 XOR2HS $T=226300 1022000 0 0 $X=226300 $Y=1021620
X2211 690 703 10 2 1 XOR2HS $T=236840 1062320 0 180 $X=231260 $Y=1056900
X2212 715 708 693 2 1 XOR2HS $T=238080 1032080 0 180 $X=232500 $Y=1026660
X2213 643 674 712 2 1 XOR2HS $T=233120 1011920 1 0 $X=233120 $Y=1006500
X2214 684 701 731 2 1 XOR2HS $T=236220 1052240 1 0 $X=236220 $Y=1046820
X2215 722 738 747 2 1 XOR2HS $T=239940 1042160 1 0 $X=239940 $Y=1036740
X2216 28 26 21 2 1 XOR2HS $T=252960 880880 1 180 $X=247380 $Y=880500
X2217 795 789 785 2 1 XOR2HS $T=253580 1001840 0 180 $X=248000 $Y=996420
X2218 828 822 807 2 1 XOR2HS $T=256680 890960 0 180 $X=251100 $Y=885540
X2219 839 836 774 2 1 XOR2HS $T=259160 1022000 0 180 $X=253580 $Y=1016580
X2220 801 831 838 2 1 XOR2HS $T=254200 1001840 1 0 $X=254200 $Y=996420
X2221 765 806 841 2 1 XOR2HS $T=255440 1022000 0 0 $X=255440 $Y=1021620
X2222 855 845 815 2 1 XOR2HS $T=261640 1011920 1 0 $X=261640 $Y=1006500
X2223 899 894 877 2 1 XOR2HS $T=269700 1001840 0 180 $X=264120 $Y=996420
X2224 60 61 63 2 1 XOR2HS $T=270320 880880 0 0 $X=270320 $Y=880500
X2225 942 921 927 2 1 XOR2HS $T=278380 991760 1 180 $X=272800 $Y=991380
X2226 929 931 913 2 1 XOR2HS $T=274040 1011920 1 0 $X=274040 $Y=1006500
X2227 989 986 971 2 1 XOR2HS $T=287680 1001840 0 180 $X=282100 $Y=996420
X2228 964 955 985 2 1 XOR2HS $T=282100 1011920 1 0 $X=282100 $Y=1006500
X2229 1006 1003 1024 2 1 XOR2HS $T=288920 890960 1 0 $X=288920 $Y=885540
X2230 960 994 975 2 1 XOR2HS $T=289540 991760 0 0 $X=289540 $Y=991380
X2231 1040 1036 1019 2 1 XOR2HS $T=296360 981680 0 180 $X=290780 $Y=976260
X2232 1011 1009 1038 2 1 XOR2HS $T=291400 991760 1 0 $X=291400 $Y=986340
X2233 1018 999 1048 2 1 XOR2HS $T=292640 911120 0 0 $X=292640 $Y=910740
X2234 1014 1007 1035 2 1 XOR2HS $T=293260 921200 0 0 $X=293260 $Y=920820
X2235 1026 841 1051 2 1 XOR2HS $T=293880 1022000 0 0 $X=293880 $Y=1021620
X2236 1032 1046 1054 2 1 XOR2HS $T=294500 961520 1 0 $X=294500 $Y=956100
X2237 1045 1044 1060 2 1 XOR2HS $T=298220 901040 1 0 $X=298220 $Y=895620
X2238 1058 673 1073 2 1 XOR2HS $T=298220 951440 1 0 $X=298220 $Y=946020
X2239 706 1033 1078 2 1 XOR2HS $T=300080 971600 1 0 $X=300080 $Y=966180
X2240 1109 1079 1026 2 1 XOR2HS $T=311240 1022000 0 180 $X=305660 $Y=1016580
X2241 1067 1073 1117 2 1 XOR2HS $T=307520 951440 1 0 $X=307520 $Y=946020
X2242 1167 1164 1145 2 1 XOR2HS $T=319300 901040 0 180 $X=313720 $Y=895620
X2243 1174 1168 1153 2 1 XOR2HS $T=319920 1052240 0 180 $X=314340 $Y=1046820
X2244 1125 1113 1101 2 1 XOR2HS $T=315580 1032080 0 0 $X=315580 $Y=1031700
X2245 1172 1180 1133 2 1 XOR2HS $T=318680 1022000 0 0 $X=318680 $Y=1021620
X2246 1231 1230 1212 2 1 XOR2HS $T=329220 1022000 0 180 $X=323640 $Y=1016580
X2247 1202 1236 1249 2 1 XOR2HS $T=327360 1032080 1 0 $X=327360 $Y=1026660
X2248 1225 1213 1250 2 1 XOR2HS $T=327360 1032080 0 0 $X=327360 $Y=1031700
X2249 1215 1228 1191 2 1 XOR2HS $T=327980 890960 1 0 $X=327980 $Y=885540
X2250 1238 1233 1270 2 1 XOR2HS $T=331700 890960 0 0 $X=331700 $Y=890580
X2251 1242 1203 1240 2 1 XOR2HS $T=332320 1052240 1 0 $X=332320 $Y=1046820
X2252 1255 1243 1275 2 1 XOR2HS $T=332940 901040 1 0 $X=332940 $Y=895620
X2253 1283 1261 1267 2 1 XOR2HS $T=339140 1011920 0 180 $X=333560 $Y=1006500
X2254 1316 1315 1301 2 1 XOR2HS $T=345960 951440 0 180 $X=340380 $Y=946020
X2255 1297 1290 1303 2 1 XOR2HS $T=341000 890960 0 0 $X=341000 $Y=890580
X2256 1306 1312 1324 2 1 XOR2HS $T=342240 981680 0 0 $X=342240 $Y=981300
X2257 1338 1331 1313 2 1 XOR2HS $T=348440 911120 0 180 $X=342860 $Y=905700
X2258 1340 1305 1310 2 1 XOR2HS $T=348440 991760 1 180 $X=342860 $Y=991380
X2259 1341 1339 1317 2 1 XOR2HS $T=349060 921200 0 180 $X=343480 $Y=915780
X2260 1326 1333 1346 2 1 XOR2HS $T=345340 941360 1 0 $X=345340 $Y=935940
X2261 1323 1337 1351 2 1 XOR2HS $T=345960 890960 1 0 $X=345960 $Y=885540
X2262 1355 1349 1335 2 1 XOR2HS $T=351540 961520 0 180 $X=345960 $Y=956100
X2263 1327 1328 1354 2 1 XOR2HS $T=346580 971600 0 0 $X=346580 $Y=971220
X2264 1353 1347 1368 2 1 XOR2HS $T=350920 901040 0 0 $X=350920 $Y=900660
X2265 1320 1343 1363 2 1 XOR2HS $T=352780 931280 1 0 $X=352780 $Y=925860
X2266 1473 1469 1399 2 1 XOR2HS $T=381920 1001840 1 180 $X=376340 $Y=1001460
X2267 1515 1479 1469 2 1 XOR2HS $T=390600 1001840 0 180 $X=385020 $Y=996420
X2268 1548 1540 1501 2 1 XOR2HS $T=396180 1052240 0 180 $X=390600 $Y=1046820
X2269 1556 1550 1530 2 1 XOR2HS $T=397420 921200 1 180 $X=391840 $Y=920820
X2270 1560 1564 1542 2 1 XOR2HS $T=399280 941360 0 180 $X=393700 $Y=935940
X2271 1579 1576 131 2 1 XOR2HS $T=401760 1001840 0 180 $X=396180 $Y=996420
X2272 1546 1570 1538 2 1 XOR2HS $T=397420 961520 0 0 $X=397420 $Y=961140
X2273 1573 1569 1534 2 1 XOR2HS $T=404240 991760 1 180 $X=398660 $Y=991380
X2274 1566 1567 1527 2 1 XOR2HS $T=398660 1052240 0 0 $X=398660 $Y=1051860
X2275 1563 1572 1526 2 1 XOR2HS $T=400520 971600 0 0 $X=400520 $Y=971220
X2276 1584 1586 1604 2 1 XOR2HS $T=402380 981680 1 0 $X=402380 $Y=976260
X2277 1623 1620 1576 2 1 XOR2HS $T=410440 991760 1 180 $X=404860 $Y=991380
X2278 1605 1625 1608 2 1 XOR2HS $T=411060 921200 1 180 $X=405480 $Y=920820
X2279 1631 1626 1588 2 1 XOR2HS $T=411060 941360 1 180 $X=405480 $Y=940980
X2280 1633 1629 1609 2 1 XOR2HS $T=411060 1042160 1 180 $X=405480 $Y=1041780
X2281 1597 1600 1627 2 1 XOR2HS $T=406100 971600 1 0 $X=406100 $Y=966180
X2282 1646 1603 1616 2 1 XOR2HS $T=412920 1062320 1 0 $X=412920 $Y=1056900
X2283 1641 1656 1642 2 1 XOR2HS $T=414160 951440 0 0 $X=414160 $Y=951060
X2284 1649 1642 1662 2 1 XOR2HS $T=414160 1022000 1 0 $X=414160 $Y=1016580
X2285 1654 1667 1649 2 1 XOR2HS $T=416020 1032080 1 0 $X=416020 $Y=1026660
X2286 1690 144 1619 2 1 XOR2HS $T=421600 1062320 1 180 $X=416020 $Y=1061940
X2287 1674 1683 1652 2 1 XOR2HS $T=417880 921200 0 0 $X=417880 $Y=920820
X2288 1704 1699 1679 2 1 XOR2HS $T=423460 991760 1 180 $X=417880 $Y=991380
X2289 1751 165 1731 2 1 XOR2HS $T=431520 1062320 0 180 $X=425940 $Y=1056900
X2290 1757 1728 1734 2 1 XOR2HS $T=432140 991760 1 180 $X=426560 $Y=991380
X2291 1764 1737 1747 2 1 XOR2HS $T=434000 931280 1 180 $X=428420 $Y=930900
X2292 1801 1784 1785 2 1 XOR2HS $T=440200 1001840 0 180 $X=434620 $Y=996420
X2293 1810 1795 1802 2 1 XOR2HS $T=443920 931280 1 180 $X=438340 $Y=930900
X2294 1831 1766 1813 2 1 XOR2HS $T=445780 1062320 0 180 $X=440200 $Y=1056900
X2295 1842 1818 1821 2 1 XOR2HS $T=447020 1001840 0 180 $X=441440 $Y=996420
X2296 1840 1835 1846 2 1 XOR2HS $T=445160 931280 0 0 $X=445160 $Y=930900
X2297 1872 1860 1888 2 1 XOR2HS $T=450120 991760 0 0 $X=450120 $Y=991380
X2298 1873 1864 1889 2 1 XOR2HS $T=450120 1062320 0 0 $X=450120 $Y=1061940
X2299 1880 1882 1887 2 1 XOR2HS $T=451980 931280 0 0 $X=451980 $Y=930900
X2300 1879 1877 1903 2 1 XOR2HS $T=453220 1062320 1 0 $X=453220 $Y=1056900
X2301 1929 1890 1910 2 1 XOR2HS $T=462520 991760 0 180 $X=456940 $Y=986340
X2302 1915 1918 1924 2 1 XOR2HS $T=458800 931280 0 0 $X=458800 $Y=930900
X2303 1981 1933 1955 2 1 XOR2HS $T=471200 931280 1 180 $X=465620 $Y=930900
X2304 1993 1971 1980 2 1 XOR2HS $T=474300 991760 0 180 $X=468720 $Y=986340
X2305 2014 1988 1995 2 1 XOR2HS $T=477400 1062320 1 180 $X=471820 $Y=1061940
X2306 2019 2021 2004 2 1 XOR2HS $T=479880 941360 0 180 $X=474300 $Y=935940
X2307 2008 2013 2026 2 1 XOR2HS $T=474920 991760 0 0 $X=474920 $Y=991380
X2308 2068 2033 2051 2 1 XOR2HS $T=487940 991760 0 180 $X=482360 $Y=986340
X2309 2061 2048 2070 2 1 XOR2HS $T=486080 1011920 0 0 $X=486080 $Y=1011540
X2310 2042 2070 2080 2 1 XOR2HS $T=486080 1022000 1 0 $X=486080 $Y=1016580
X2311 2065 2079 2087 2 1 XOR2HS $T=487940 1001840 1 0 $X=487940 $Y=996420
X2312 2066 2073 2090 2 1 XOR2HS $T=488560 931280 0 0 $X=488560 $Y=930900
X2313 2069 2050 2055 2 1 XOR2HS $T=489800 941360 0 0 $X=489800 $Y=940980
X2314 2092 2094 2108 2 1 XOR2HS $T=491660 951440 1 0 $X=491660 $Y=946020
X2315 2089 2087 2114 2 1 XOR2HS $T=492280 1011920 1 0 $X=492280 $Y=1006500
X2316 2088 2100 2116 2 1 XOR2HS $T=492280 1052240 0 0 $X=492280 $Y=1051860
X2317 2113 2119 2101 2 1 XOR2HS $T=498480 981680 1 180 $X=492900 $Y=981300
X2318 2081 2037 2129 2 1 XOR2HS $T=494760 1062320 0 0 $X=494760 $Y=1061940
X2319 2118 2143 2128 2 1 XOR2HS $T=502820 951440 1 180 $X=497240 $Y=951060
X2320 2112 2130 2142 2 1 XOR2HS $T=497240 971600 0 0 $X=497240 $Y=971220
X2321 2111 2140 2123 2 1 XOR2HS $T=503440 931280 1 180 $X=497860 $Y=930900
X2322 2110 2136 2125 2 1 XOR2HS $T=498480 921200 1 0 $X=498480 $Y=915780
X2323 2131 2096 2138 2 1 XOR2HS $T=505300 991760 0 180 $X=499720 $Y=986340
X2324 2120 2134 2155 2 1 XOR2HS $T=500960 911120 0 0 $X=500960 $Y=910740
X2325 2148 2170 2156 2 1 XOR2HS $T=509020 941360 1 180 $X=503440 $Y=940980
X2326 2162 2167 2177 2 1 XOR2HS $T=504680 931280 1 0 $X=504680 $Y=925860
X2327 2160 2172 2182 2 1 XOR2HS $T=505920 991760 0 0 $X=505920 $Y=991380
X2328 2153 2164 2159 2 1 XOR2HS $T=506540 951440 0 0 $X=506540 $Y=951060
X2329 2181 2141 2189 2 1 XOR2HS $T=508400 971600 1 0 $X=508400 $Y=966180
X2330 2169 2166 2194 2 1 XOR2HS $T=509020 921200 1 0 $X=509020 $Y=915780
X2331 2217 2168 2186 2 1 XOR2HS $T=518940 1052240 0 180 $X=513360 $Y=1046820
X2332 2178 2175 2193 2 1 XOR2HS $T=515220 981680 0 0 $X=515220 $Y=981300
X2333 2205 2207 2215 2 1 XOR2HS $T=516460 951440 0 0 $X=516460 $Y=951060
X2334 2209 2224 2201 2 1 XOR2HS $T=518320 931280 1 0 $X=518320 $Y=925860
X2335 2223 2216 2240 2 1 XOR2HS $T=520180 921200 1 0 $X=520180 $Y=915780
X2336 2028 2236 2247 2 1 XOR2HS $T=520180 1062320 1 0 $X=520180 $Y=1056900
X2337 2233 2228 2253 2 1 XOR2HS $T=521420 1052240 0 0 $X=521420 $Y=1051860
X2338 2242 2192 2222 2 1 XOR2HS $T=523280 961520 0 0 $X=523280 $Y=961140
X2339 2235 2191 2231 2 1 XOR2HS $T=523900 941360 0 0 $X=523900 $Y=940980
X2340 2268 2271 2277 2 1 XOR2HS $T=536920 1052240 1 180 $X=531340 $Y=1051860
X2341 235 236 2302 2 1 XOR2HS $T=535680 1062320 1 0 $X=535680 $Y=1056900
X2342 2307 2313 2321 2 1 XOR2HS $T=540020 1052240 0 0 $X=540020 $Y=1051860
X2343 2337 2334 2347 2 1 XOR2HS $T=546840 1052240 0 0 $X=546840 $Y=1051860
X2344 2379 2388 2400 2 1 XOR2HS $T=558620 951440 0 0 $X=558620 $Y=951060
X2345 2403 2394 2413 2 1 XOR2HS $T=562340 931280 1 0 $X=562340 $Y=925860
X2346 2393 2397 2414 2 1 XOR2HS $T=562340 941360 0 0 $X=562340 $Y=940980
X2347 2398 2375 2415 2 1 XOR2HS $T=562340 961520 1 0 $X=562340 $Y=956100
X2348 2430 2425 2409 2 1 XOR2HS $T=569160 981680 0 180 $X=563580 $Y=976260
X2349 2419 2429 2439 2 1 XOR2HS $T=566680 911120 1 0 $X=566680 $Y=905700
X2350 2424 2437 2435 2 1 XOR2HS $T=567920 921200 0 0 $X=567920 $Y=920820
X2351 2426 2422 2447 2 1 XOR2HS $T=567920 961520 0 0 $X=567920 $Y=961140
X2352 2465 2451 2444 2 1 XOR2HS $T=575360 991760 0 180 $X=569780 $Y=986340
X2353 2478 2476 2458 2 1 XOR2HS $T=577220 1001840 0 180 $X=571640 $Y=996420
X2354 2445 253 2486 2 1 XOR2HS $T=574120 880880 0 0 $X=574120 $Y=880500
X2355 2450 2452 2487 2 1 XOR2HS $T=574740 890960 0 0 $X=574740 $Y=890580
X2356 2484 2286 2499 2 1 XOR2HS $T=576600 1052240 1 0 $X=576600 $Y=1046820
X2357 2520 2518 2497 2 1 XOR2HS $T=584660 911120 1 180 $X=579080 $Y=910740
X2358 2527 2521 2501 2 1 XOR2HS $T=585280 971600 1 180 $X=579700 $Y=971220
X2359 2514 2523 2537 2 1 XOR2HS $T=582180 991760 0 0 $X=582180 $Y=991380
X2360 2515 2495 2549 2 1 XOR2HS $T=584660 1001840 1 0 $X=584660 $Y=996420
X2361 2499 267 2555 2 1 XOR2HS $T=585900 1052240 1 0 $X=585900 $Y=1046820
X2362 2560 2564 2575 2 1 XOR2HS $T=589620 991760 1 0 $X=589620 $Y=986340
X2363 2586 2556 2562 2 1 XOR2HS $T=597060 911120 1 180 $X=591480 $Y=910740
X2364 2589 2583 2641 2 1 XOR2HS $T=605740 991760 0 0 $X=605740 $Y=991380
X2365 2642 2595 2652 2 1 XOR2HS $T=605740 1001840 1 0 $X=605740 $Y=996420
X2366 2659 282 2702 2 1 XOR2HS $T=613800 1062320 1 0 $X=613800 $Y=1056900
X2367 2709 2671 2732 2 1 XOR2HS $T=618760 991760 0 0 $X=618760 $Y=991380
X2368 287 285 2923 2 1 XOR2HS $T=654720 890960 0 0 $X=654720 $Y=890580
X2369 3080 3088 3126 2 1 XOR2HS $T=696260 1001840 0 0 $X=696260 $Y=1001460
X2370 286 3125 3157 2 1 XOR2HS $T=704320 880880 0 0 $X=704320 $Y=880500
X2371 3057 3158 3170 2 1 XOR2HS $T=706800 921200 1 0 $X=706800 $Y=915780
X2372 2580 2508 3195 2 1 XOR2HS $T=713000 921200 1 0 $X=713000 $Y=915780
X2373 3005 3187 3206 2 1 XOR2HS $T=714860 901040 0 0 $X=714860 $Y=900660
X2374 3213 3209 3193 2 1 XOR2HS $T=720440 961520 0 180 $X=714860 $Y=956100
X2375 301 3205 3218 2 1 XOR2HS $T=716720 890960 1 0 $X=716720 $Y=885540
X2376 2996 3200 3228 2 1 XOR2HS $T=718580 901040 1 0 $X=718580 $Y=895620
X2377 2768 3188 3229 2 1 XOR2HS $T=718580 921200 0 0 $X=718580 $Y=920820
X2378 2678 3226 3240 2 1 XOR2HS $T=720440 911120 1 0 $X=720440 $Y=905700
X2379 3248 3241 3223 2 1 XOR2HS $T=726020 991760 0 180 $X=720440 $Y=986340
X2380 304 3244 3207 2 1 XOR2HS $T=723540 890960 0 0 $X=723540 $Y=890580
X2381 3222 3232 3256 2 1 XOR2HS $T=723540 961520 0 0 $X=723540 $Y=961140
X2382 2977 3237 3189 2 1 XOR2HS $T=724780 901040 0 0 $X=724780 $Y=900660
X2383 3249 3243 3191 2 1 XOR2HS $T=724780 1042160 1 0 $X=724780 $Y=1036740
X2384 2665 3201 3262 2 1 XOR2HS $T=725400 921200 0 0 $X=725400 $Y=920820
X2385 3267 3263 3190 2 1 XOR2HS $T=730980 991760 1 180 $X=725400 $Y=991380
X2386 3250 3269 3258 2 1 XOR2HS $T=732220 931280 0 180 $X=726640 $Y=925860
X2387 3234 3235 3268 2 1 XOR2HS $T=726640 941360 1 0 $X=726640 $Y=935940
X2388 2752 3255 3270 2 1 XOR2HS $T=727260 911120 1 0 $X=727260 $Y=905700
X2389 311 3254 3284 2 1 XOR2HS $T=730360 890960 0 0 $X=730360 $Y=890580
X2390 3272 3261 3288 2 1 XOR2HS $T=730980 981680 0 0 $X=730980 $Y=981300
X2391 3295 3289 3236 2 1 XOR2HS $T=736560 1001840 1 180 $X=730980 $Y=1001460
X2392 3300 3299 3264 2 1 XOR2HS $T=737800 1001840 0 180 $X=732220 $Y=996420
X2393 2886 3280 3290 2 1 XOR2HS $T=732840 911120 0 0 $X=732840 $Y=910740
X2394 2980 3287 3309 2 1 XOR2HS $T=735320 901040 0 0 $X=735320 $Y=900660
X2395 3277 3273 3224 2 1 XOR2HS $T=735320 991760 0 0 $X=735320 $Y=991380
X2396 3061 3271 3314 2 1 XOR2HS $T=736560 890960 0 0 $X=736560 $Y=890580
X2397 2929 3297 3316 2 1 XOR2HS $T=736560 911120 1 0 $X=736560 $Y=905700
X2398 3322 3317 3307 2 1 XOR2HS $T=742760 981680 1 180 $X=737180 $Y=981300
X2399 3286 3283 3315 2 1 XOR2HS $T=738420 880880 0 0 $X=738420 $Y=880500
X2400 3328 3326 3313 2 1 XOR2HS $T=744000 951440 1 180 $X=738420 $Y=951060
X2401 2917 3320 3330 2 1 XOR2HS $T=739660 921200 1 0 $X=739660 $Y=915780
X2402 2976 3332 3349 2 1 XOR2HS $T=742140 911120 1 0 $X=742140 $Y=905700
X2403 3298 3321 3322 2 1 XOR2HS $T=743380 961520 1 0 $X=743380 $Y=956100
X2404 2988 3333 3367 2 1 XOR2HS $T=745860 921200 1 0 $X=745860 $Y=915780
X2405 3056 3352 3361 2 1 XOR2HS $T=747100 941360 0 0 $X=747100 $Y=940980
X2406 3068 3379 3384 2 1 XOR2HS $T=752060 921200 1 0 $X=752060 $Y=915780
X2407 2994 3366 3396 2 1 XOR2HS $T=754540 911120 0 0 $X=754540 $Y=910740
X2408 811 802 29 2 1 ND2S $T=252340 941360 0 0 $X=252340 $Y=940980
X2409 811 780 819 2 1 ND2S $T=252340 951440 0 0 $X=252340 $Y=951060
X2410 812 803 819 2 1 ND2S $T=252340 961520 0 0 $X=252340 $Y=961140
X2411 788 805 29 2 1 ND2S $T=252340 971600 0 0 $X=252340 $Y=971220
X2412 835 799 819 2 1 ND2S $T=257300 971600 1 0 $X=257300 $Y=966180
X2413 849 778 819 2 1 ND2S $T=261020 941360 1 0 $X=261020 $Y=935940
X2414 1008 1000 1012 2 1 ND2S $T=289540 951440 1 0 $X=289540 $Y=946020
X2415 1080 1088 1081 2 1 ND2S $T=305040 961520 0 0 $X=305040 $Y=961140
X2416 1078 1102 1098 2 1 ND2S $T=306900 971600 0 0 $X=306900 $Y=971220
X2417 1137 1154 1141 2 1 ND2S $T=316200 961520 0 180 $X=314340 $Y=956100
X2418 1173 1184 1141 2 1 ND2S $T=323020 971600 1 180 $X=321160 $Y=971220
X2419 1198 1192 83 2 1 ND2S $T=323020 971600 0 0 $X=323020 $Y=971220
X2420 1117 1440 1426 2 1 ND2S $T=370140 941360 1 180 $X=368280 $Y=940980
X2421 1160 1458 1449 2 1 ND2S $T=376960 921200 1 0 $X=376960 $Y=915780
X2422 91 1607 113 2 1 ND2S $T=409200 890960 0 0 $X=409200 $Y=890580
X2423 1790 1796 1782 2 1 ND2S $T=438340 901040 1 180 $X=436480 $Y=900660
X2424 1682 1826 149 2 1 ND2S $T=445160 901040 0 0 $X=445160 $Y=900660
X2425 2892 2893 2843 2 1 ND2S $T=652860 1042160 0 180 $X=651000 $Y=1036740
X2426 2848 3015 2687 2 1 ND2S $T=675800 1052240 0 180 $X=673940 $Y=1046820
X2427 3052 3051 2836 2 1 ND2S $T=684480 1022000 1 180 $X=682620 $Y=1021620
X2428 652 656 645 1 2 ND2 $T=230020 951440 1 180 $X=228160 $Y=951060
X2429 656 657 672 1 2 ND2 $T=230020 961520 0 0 $X=230020 $Y=961140
X2430 680 685 5 1 2 ND2 $T=232500 1022000 0 180 $X=230640 $Y=1016580
X2431 662 691 5 1 2 ND2 $T=233120 1052240 1 180 $X=231260 $Y=1051860
X2432 668 672 669 1 2 ND2 $T=231880 971600 1 0 $X=231880 $Y=966180
X2433 695 688 685 1 2 ND2 $T=234360 1022000 0 180 $X=232500 $Y=1016580
X2434 699 13 691 1 2 ND2 $T=234980 1052240 1 180 $X=233120 $Y=1051860
X2435 613 695 670 1 2 ND2 $T=236220 1022000 0 180 $X=234360 $Y=1016580
X2436 639 699 670 1 2 ND2 $T=236840 1052240 1 180 $X=234980 $Y=1051860
X2437 15 724 9 1 2 ND2 $T=238700 991760 1 180 $X=236840 $Y=991380
X2438 16 735 690 1 2 ND2 $T=239940 1062320 0 180 $X=238080 $Y=1056900
X2439 690 739 703 1 2 ND2 $T=238700 1052240 0 0 $X=238700 $Y=1051860
X2440 742 736 754 1 2 ND2 $T=241800 971600 1 0 $X=241800 $Y=966180
X2441 16 748 703 1 2 ND2 $T=243660 1062320 0 180 $X=241800 $Y=1056900
X2442 778 720 796 1 2 ND2 $T=248620 931280 0 0 $X=248620 $Y=930900
X2443 779 716 821 1 2 ND2 $T=248620 951440 1 0 $X=248620 $Y=946020
X2444 780 732 793 1 2 ND2 $T=248620 961520 1 0 $X=248620 $Y=956100
X2445 23 763 25 1 2 ND2 $T=248620 1062320 1 0 $X=248620 $Y=1056900
X2446 797 796 29 1 2 ND2 $T=250480 931280 0 0 $X=250480 $Y=930900
X2447 798 755 802 1 2 ND2 $T=250480 951440 0 0 $X=250480 $Y=951060
X2448 799 742 805 1 2 ND2 $T=250480 971600 1 0 $X=250480 $Y=966180
X2449 810 779 819 1 2 ND2 $T=252340 941360 1 0 $X=252340 $Y=935940
X2450 803 783 833 1 2 ND2 $T=252340 961520 1 0 $X=252340 $Y=956100
X2451 812 793 29 1 2 ND2 $T=252340 971600 1 0 $X=252340 $Y=966180
X2452 28 822 26 1 2 ND2 $T=254200 880880 0 0 $X=254200 $Y=880500
X2453 830 821 29 1 2 ND2 $T=255440 951440 1 0 $X=255440 $Y=946020
X2454 830 798 819 1 2 ND2 $T=255440 951440 0 0 $X=255440 $Y=951060
X2455 835 833 29 1 2 ND2 $T=257920 961520 1 180 $X=256060 $Y=961140
X2456 37 794 44 1 2 ND2 $T=259160 981680 1 0 $X=259160 $Y=976260
X2457 856 862 730 1 2 ND2 $T=262260 1042160 0 180 $X=260400 $Y=1036740
X2458 876 866 863 1 2 ND2 $T=264740 951440 1 180 $X=262880 $Y=951060
X2459 866 858 885 1 2 ND2 $T=265360 981680 1 0 $X=265360 $Y=976260
X2460 889 876 897 1 2 ND2 $T=267220 951440 1 0 $X=267220 $Y=946020
X2461 868 885 872 1 2 ND2 $T=267220 981680 1 0 $X=267220 $Y=976260
X2462 730 884 890 1 2 ND2 $T=267220 1032080 0 0 $X=267220 $Y=1031700
X2463 903 889 908 1 2 ND2 $T=269080 951440 1 0 $X=269080 $Y=946020
X2464 856 878 890 1 2 ND2 $T=271560 1032080 1 180 $X=269700 $Y=1031700
X2465 915 897 891 1 2 ND2 $T=270940 961520 1 0 $X=270940 $Y=956100
X2466 938 64 30 1 2 ND2 $T=276520 1062320 1 180 $X=274660 $Y=1061940
X2467 945 903 939 1 2 ND2 $T=278380 951440 0 180 $X=276520 $Y=946020
X2468 58 67 938 1 2 ND2 $T=279620 1062320 1 180 $X=277760 $Y=1061940
X2469 953 945 68 1 2 ND2 $T=280240 951440 0 180 $X=278380 $Y=946020
X2470 963 939 53 1 2 ND2 $T=282100 951440 0 180 $X=280240 $Y=946020
X2471 904 962 947 1 2 ND2 $T=282720 1042160 1 180 $X=280860 $Y=1041780
X2472 904 978 852 1 2 ND2 $T=284580 1042160 1 180 $X=282720 $Y=1041780
X2473 953 980 53 1 2 ND2 $T=284580 951440 0 0 $X=284580 $Y=951060
X2474 852 981 947 1 2 ND2 $T=286440 1042160 1 180 $X=284580 $Y=1041780
X2475 1000 977 980 1 2 ND2 $T=288300 951440 0 180 $X=286440 $Y=946020
X2476 1010 1013 773 1 2 ND2 $T=290160 1011920 0 180 $X=288300 $Y=1006500
X2477 900 1002 937 1 2 ND2 $T=290160 1022000 0 180 $X=288300 $Y=1016580
X2478 946 1015 27 1 2 ND2 $T=291400 971600 0 180 $X=289540 $Y=966180
X2479 1010 1028 995 1 2 ND2 $T=291400 1001840 1 180 $X=289540 $Y=1001460
X2480 1037 1021 1043 1 2 ND2 $T=294500 931280 0 0 $X=294500 $Y=930900
X2481 1023 1043 53 1 2 ND2 $T=295120 941360 0 0 $X=295120 $Y=940980
X2482 683 1049 1041 1 2 ND2 $T=295740 1001840 1 0 $X=295740 $Y=996420
X2483 1034 1037 1012 1 2 ND2 $T=296980 941360 1 0 $X=296980 $Y=935940
X2484 995 1039 773 1 2 ND2 $T=296980 1011920 1 0 $X=296980 $Y=1006500
X2485 1047 1064 1041 1 2 ND2 $T=297600 1001840 1 0 $X=297600 $Y=996420
X2486 1047 1063 683 1 2 ND2 $T=298220 1001840 0 0 $X=298220 $Y=1001460
X2487 1061 1076 677 1 2 ND2 $T=303180 981680 0 180 $X=301320 $Y=976260
X2488 663 1069 1086 1 2 ND2 $T=301940 890960 0 0 $X=301940 $Y=890580
X2489 1033 1080 706 1 2 ND2 $T=301940 961520 0 0 $X=301940 $Y=961140
X2490 79 1097 78 1 2 ND2 $T=305040 1062320 1 180 $X=303180 $Y=1061940
X2491 1058 1091 673 1 2 ND2 $T=305040 951440 1 0 $X=305040 $Y=946020
X2492 79 1085 81 1 2 ND2 $T=305040 1052240 0 0 $X=305040 $Y=1051860
X2493 1088 1100 1093 1 2 ND2 $T=307520 961520 1 0 $X=307520 $Y=956100
X2494 1118 1095 80 1 2 ND2 $T=310000 1042160 1 180 $X=308140 $Y=1041780
X2495 1112 1103 1114 1 2 ND2 $T=310000 1052240 1 0 $X=310000 $Y=1046820
X2496 1115 1119 1122 1 2 ND2 $T=310620 1062320 1 0 $X=310620 $Y=1056900
X2497 1116 1135 1130 1 2 ND2 $T=311860 961520 0 0 $X=311860 $Y=961140
X2498 81 1107 78 1 2 ND2 $T=311860 1052240 0 0 $X=311860 $Y=1051860
X2499 1115 1128 84 1 2 ND2 $T=312480 1062320 1 0 $X=312480 $Y=1056900
X2500 1154 1138 1135 1 2 ND2 $T=315580 961520 1 180 $X=313720 $Y=961140
X2501 1122 1149 84 1 2 ND2 $T=314340 1062320 1 0 $X=314340 $Y=1056900
X2502 1159 1140 80 1 2 ND2 $T=316200 1042160 1 0 $X=316200 $Y=1036740
X2503 1137 1171 83 1 2 ND2 $T=316820 961520 0 0 $X=316820 $Y=961140
X2504 1158 1127 1114 1 2 ND2 $T=319920 1042160 1 0 $X=319920 $Y=1036740
X2505 1184 1195 1192 1 2 ND2 $T=320540 981680 1 0 $X=320540 $Y=976260
X2506 1196 1207 1171 1 2 ND2 $T=323640 961520 0 180 $X=321780 $Y=956100
X2507 1188 1196 1141 1 2 ND2 $T=322400 961520 0 0 $X=322400 $Y=961140
X2508 1166 1220 1217 1 2 ND2 $T=324260 951440 1 0 $X=324260 $Y=946020
X2509 1188 1211 83 1 2 ND2 $T=326120 961520 0 180 $X=324260 $Y=956100
X2510 1215 1164 1228 1 2 ND2 $T=325500 890960 1 0 $X=325500 $Y=885540
X2511 1220 1237 1211 1 2 ND2 $T=327360 951440 1 180 $X=325500 $Y=951060
X2512 1218 1205 1224 1 2 ND2 $T=325500 1011920 1 0 $X=325500 $Y=1006500
X2513 1274 1285 1281 1 2 ND2 $T=337280 1032080 0 0 $X=337280 $Y=1031700
X2514 1274 1295 1286 1 2 ND2 $T=342860 1032080 1 180 $X=341000 $Y=1031700
X2515 1281 1308 1286 1 2 ND2 $T=345960 1032080 1 0 $X=345960 $Y=1026660
X2516 1342 1357 859 1 2 ND2 $T=349680 1032080 1 180 $X=347820 $Y=1031700
X2517 1329 1359 859 1 2 ND2 $T=353400 1032080 1 180 $X=351540 $Y=1031700
X2518 1329 1366 1342 1 2 ND2 $T=353400 1042160 0 180 $X=351540 $Y=1036740
X2519 1365 1387 1372 1 2 ND2 $T=357120 1011920 0 0 $X=357120 $Y=1011540
X2520 1365 1398 1147 1 2 ND2 $T=358980 1011920 0 0 $X=358980 $Y=1011540
X2521 1399 1401 1391 1 2 ND2 $T=360840 1062320 0 180 $X=358980 $Y=1056900
X2522 1147 1407 1372 1 2 ND2 $T=360840 1011920 0 0 $X=360840 $Y=1011540
X2523 1410 1413 1165 1 2 ND2 $T=365180 901040 0 180 $X=363320 $Y=895620
X2524 1165 1431 1416 1 2 ND2 $T=372000 901040 1 0 $X=372000 $Y=895620
X2525 1452 1450 1449 1 2 ND2 $T=380680 921200 1 180 $X=378820 $Y=920820
X2526 1470 1472 1439 1 2 ND2 $T=380060 1052240 0 0 $X=380060 $Y=1051860
X2527 1470 1480 1463 1 2 ND2 $T=381920 1052240 0 0 $X=381920 $Y=1051860
X2528 1495 1496 1461 1 2 ND2 $T=385640 991760 0 180 $X=383780 $Y=986340
X2529 1439 1492 1463 1 2 ND2 $T=383780 1052240 0 0 $X=383780 $Y=1051860
X2530 1461 1512 1489 1 2 ND2 $T=386880 991760 1 0 $X=386880 $Y=986340
X2531 1489 1513 1495 1 2 ND2 $T=388740 981680 0 0 $X=388740 $Y=981300
X2532 1473 1490 1515 1 2 ND2 $T=389980 1001840 0 0 $X=389980 $Y=1001460
X2533 1508 1511 1528 1 2 ND2 $T=390600 961520 1 0 $X=390600 $Y=956100
X2534 1515 1486 1479 1 2 ND2 $T=390600 1001840 1 0 $X=390600 $Y=996420
X2535 1536 1525 1528 1 2 ND2 $T=394320 961520 0 180 $X=392460 $Y=956100
X2536 1508 1521 1536 1 2 ND2 $T=392460 961520 0 0 $X=392460 $Y=961140
X2537 1623 1658 1620 1 2 ND2 $T=413540 1001840 1 0 $X=413540 $Y=996420
X2538 1654 1622 1667 1 2 ND2 $T=414160 1032080 0 0 $X=414160 $Y=1031700
X2539 146 1651 148 1 2 ND2 $T=416020 901040 0 0 $X=416020 $Y=900660
X2540 1673 1653 143 1 2 ND2 $T=417880 971600 1 180 $X=416020 $Y=971220
X2541 1691 1669 156 1 2 ND2 $T=420980 961520 0 0 $X=420980 $Y=961140
X2542 1686 1672 156 1 2 ND2 $T=421600 961520 1 0 $X=421600 $Y=956100
X2543 1709 1535 1749 1 2 ND2 $T=422840 1052240 0 0 $X=422840 $Y=1051860
X2544 1726 1722 149 1 2 ND2 $T=426560 901040 0 0 $X=426560 $Y=900660
X2545 169 170 166 1 2 ND2 $T=433380 1062320 1 180 $X=431520 $Y=1061940
X2546 172 173 166 1 2 ND2 $T=437100 1062320 0 180 $X=435240 $Y=1056900
X2547 1792 1790 1781 1 2 ND2 $T=438340 890960 1 180 $X=436480 $Y=890580
X2548 1756 1782 171 1 2 ND2 $T=436480 901040 1 0 $X=436480 $Y=895620
X2549 2061 2063 2048 1 2 ND2 $T=484840 1001840 1 180 $X=482980 $Y=1001460
X2550 2065 2109 2079 1 2 ND2 $T=496620 991760 1 180 $X=494760 $Y=991380
X2551 2089 2126 2079 1 2 ND2 $T=496620 1001840 0 180 $X=494760 $Y=996420
X2552 2120 2136 2134 1 2 ND2 $T=497860 911120 1 0 $X=497860 $Y=905700
X2553 2122 2145 2114 1 2 ND2 $T=499720 1011920 1 180 $X=497860 $Y=1011540
X2554 2093 2082 2080 1 2 ND2 $T=499720 1022000 0 0 $X=499720 $Y=1021620
X2555 2153 2143 2164 1 2 ND2 $T=503440 951440 0 0 $X=503440 $Y=951060
X2556 2218 2262 2190 1 2 ND2 $T=527000 1011920 0 180 $X=525140 $Y=1006500
X2557 221 2236 225 1 2 ND2 $T=527000 1062320 1 0 $X=527000 $Y=1056900
X2558 2420 2457 2459 1 2 ND2 $T=571640 941360 1 0 $X=571640 $Y=935940
X2559 2433 2477 2470 1 2 ND2 $T=573500 951440 1 0 $X=573500 $Y=946020
X2560 2446 2469 2481 1 2 ND2 $T=574740 921200 1 0 $X=574740 $Y=915780
X2561 2412 2436 2496 1 2 ND2 $T=578460 951440 0 0 $X=578460 $Y=951060
X2562 2441 2498 2504 1 2 ND2 $T=578460 961520 0 0 $X=578460 $Y=961140
X2563 2493 2490 2511 1 2 ND2 $T=579700 911120 1 0 $X=579700 $Y=905700
X2564 2432 2525 2534 1 2 ND2 $T=583420 941360 1 0 $X=583420 $Y=935940
X2565 2538 2542 2551 1 2 ND2 $T=586520 901040 0 0 $X=586520 $Y=900660
X2566 271 2545 2591 1 2 ND2 $T=592100 890960 1 0 $X=592100 $Y=885540
X2567 2586 2596 2576 1 2 ND2 $T=599540 921200 1 180 $X=597680 $Y=920820
X2568 2520 2611 2605 1 2 ND2 $T=602640 911120 1 180 $X=600780 $Y=910740
X2569 2464 2607 2626 1 2 ND2 $T=603260 991760 1 0 $X=603260 $Y=986340
X2570 2491 2649 2666 1 2 ND2 $T=610080 991760 1 0 $X=610080 $Y=986340
X2571 2485 2684 2770 1 2 ND2 $T=614420 1022000 1 0 $X=614420 $Y=1016580
X2572 2659 2685 2707 1 2 ND2 $T=615660 1052240 1 0 $X=615660 $Y=1046820
X2573 2467 2708 2714 1 2 ND2 $T=616900 971600 0 0 $X=616900 $Y=971220
X2574 2548 2819 2809 1 2 ND2 $T=634880 1001840 1 0 $X=634880 $Y=996420
X2575 2532 2866 2858 1 2 ND2 $T=644800 991760 0 0 $X=644800 $Y=991380
X2576 2513 2846 2861 1 2 ND2 $T=645420 971600 0 0 $X=645420 $Y=971220
X2577 2921 2928 2719 1 2 ND2 $T=660920 931280 0 180 $X=659060 $Y=925860
X2578 309 2919 2955 1 2 ND2 $T=660300 880880 0 0 $X=660300 $Y=880500
X2579 2584 2937 2946 1 2 ND2 $T=660300 991760 1 0 $X=660300 $Y=986340
X2580 2973 2971 2983 1 2 ND2 $T=667120 901040 1 0 $X=667120 $Y=895620
X2581 2982 2904 2998 1 2 ND2 $T=670840 961520 0 0 $X=670840 $Y=961140
X2582 3004 3007 3012 1 2 ND2 $T=673940 911120 1 0 $X=673940 $Y=905700
X2583 2989 2808 3010 1 2 ND2 $T=673940 1022000 1 0 $X=673940 $Y=1016580
X2584 3009 2990 3027 1 2 ND2 $T=675800 961520 0 0 $X=675800 $Y=961140
X2585 2480 3041 3026 1 2 ND2 $T=677040 901040 1 0 $X=677040 $Y=895620
X2586 2502 3037 3032 1 2 ND2 $T=678280 890960 1 0 $X=678280 $Y=885540
X2587 3010 3043 3020 1 2 ND2 $T=680760 1032080 0 180 $X=678900 $Y=1026660
X2588 3016 3053 2765 1 2 ND2 $T=682620 951440 1 180 $X=680760 $Y=951060
X2589 325 3010 2989 1 2 ND2 $T=685720 1011920 0 180 $X=683860 $Y=1006500
X2590 2639 3042 3063 1 2 ND2 $T=684480 981680 1 0 $X=684480 $Y=976260
X2591 2472 3039 3065 1 2 ND2 $T=685720 911120 0 0 $X=685720 $Y=910740
X2592 3070 3072 2687 1 2 ND2 $T=689440 931280 0 0 $X=689440 $Y=930900
X2593 3085 3077 3060 1 2 ND2 $T=692540 921200 0 180 $X=690680 $Y=915780
X2594 3082 3018 3091 1 2 ND2 $T=692540 951440 0 0 $X=692540 $Y=951060
X2595 3080 3098 3088 1 2 ND2 $T=694400 1011920 1 180 $X=692540 $Y=1011540
X2596 2670 3131 3121 1 2 ND2 $T=693160 981680 1 0 $X=693160 $Y=976260
X2597 3090 3105 3114 1 2 ND2 $T=696260 941360 1 0 $X=696260 $Y=935940
X2598 2474 3108 3124 1 2 ND2 $T=698120 941360 1 0 $X=698120 $Y=935940
X2599 2729 3174 3163 1 2 ND2 $T=704320 981680 1 0 $X=704320 $Y=976260
X2600 2718 3143 3151 1 2 ND2 $T=706800 981680 0 0 $X=706800 $Y=981300
X2601 3264 3260 3185 1 2 ND2 $T=728500 1001840 1 180 $X=726640 $Y=1001460
X2602 3289 3299 3295 1 2 ND2 $T=738420 1001840 1 0 $X=738420 $Y=996420
X2603 372 3503 396 1 2 ND2 $T=783680 880880 1 180 $X=781820 $Y=880500
X2604 3958 3944 3964 1 2 ND2 $T=913260 931280 0 0 $X=913260 $Y=930900
X2605 3969 3965 3950 1 2 ND2 $T=916360 951440 1 0 $X=916360 $Y=946020
X2606 3969 3949 3971 1 2 ND2 $T=916360 961520 1 0 $X=916360 $Y=956100
X2607 3979 3954 3964 1 2 ND2 $T=920080 931280 0 180 $X=918220 $Y=925860
X2608 3974 3961 3979 1 2 ND2 $T=918220 941360 1 0 $X=918220 $Y=935940
X2609 3950 3966 3986 1 2 ND2 $T=918220 961520 1 0 $X=918220 $Y=956100
X2610 3974 3959 3958 1 2 ND2 $T=919460 931280 0 0 $X=919460 $Y=930900
X2611 3971 3955 3986 1 2 ND2 $T=921320 961520 1 0 $X=921320 $Y=956100
X2612 748 769 735 739 1 2 ND3P $T=241800 1052240 0 0 $X=241800 $Y=1051860
X2613 763 16 786 19 1 2 ND3P $T=248620 1062320 1 180 $X=243660 $Y=1061940
X2614 1028 1047 1013 1039 1 2 ND3P $T=291400 1011920 1 0 $X=291400 $Y=1006500
X2615 1075 76 1123 1069 1 2 ND3P $T=305660 880880 1 180 $X=300700 $Y=880500
X2616 1064 1055 1063 1049 1 2 ND3P $T=301320 1001840 1 0 $X=301320 $Y=996420
X2617 1077 1087 1094 1091 1 2 ND3P $T=303800 941360 1 0 $X=303800 $Y=935940
X2618 1097 1115 1085 1107 1 2 ND3P $T=305660 1062320 1 0 $X=305660 $Y=1056900
X2619 1119 1186 1128 1149 1 2 ND3P $T=316200 1062320 1 0 $X=316200 $Y=1056900
X2620 1366 1350 1359 1357 1 2 ND3P $T=350920 1032080 1 0 $X=350920 $Y=1026660
X2621 1413 1437 1429 1431 1 2 ND3P $T=365800 901040 1 0 $X=365800 $Y=895620
X2622 1408 114 1422 1401 1 2 ND3P $T=373240 1062320 0 180 $X=368280 $Y=1056900
X2623 1447 1436 1433 1440 1 2 ND3P $T=376340 941360 1 180 $X=371380 $Y=940980
X2624 1450 1441 1456 1458 1 2 ND3P $T=372620 911120 0 0 $X=372620 $Y=910740
X2625 1490 1514 1486 1485 1 2 ND3P $T=383780 1001840 0 0 $X=383780 $Y=1001460
X2626 1496 1473 1512 1513 1 2 ND3P $T=385640 991760 0 0 $X=385640 $Y=991380
X2627 1647 1621 1637 1658 1 2 ND3P $T=419120 1001840 1 180 $X=414160 $Y=1001460
X2628 2102 2133 2098 2082 1 2 ND3P $T=495380 1032080 1 0 $X=495380 $Y=1026660
X2629 2126 2157 2121 2109 1 2 ND3P $T=498480 1001840 1 0 $X=498480 $Y=996420
X2630 2270 2282 2266 2262 1 2 ND3P $T=528240 1011920 1 0 $X=528240 $Y=1006500
X2631 2910 2687 2836 2826 1 2 ND3P $T=659680 1022000 1 180 $X=654720 $Y=1021620
X2632 2871 2922 2910 2864 1 2 ND3P $T=662780 1022000 0 0 $X=662780 $Y=1021620
X2633 782 804 791 826 1 2 MAO222P $T=250480 1052240 1 0 $X=250480 $Y=1046820
X2634 826 832 776 23 1 2 MAO222P $T=257920 1052240 1 180 $X=252340 $Y=1051860
X2635 767 825 775 804 1 2 MAO222P $T=253580 1042160 1 0 $X=253580 $Y=1036740
X2636 769 853 696 856 1 2 MAO222P $T=262260 1042160 0 0 $X=262260 $Y=1041780
X2637 869 688 864 900 1 2 MAO222P $T=263500 1022000 1 0 $X=263500 $Y=1016580
X2638 1055 987 679 1074 1 2 MAO222P $T=296360 991760 0 0 $X=296360 $Y=991380
X2639 1084 1059 671 1096 1 2 MAO222P $T=303800 901040 0 0 $X=303800 $Y=900660
X2640 1090 1065 655 1084 1 2 MAO222P $T=305040 911120 0 0 $X=305040 $Y=910740
X2641 104 103 54 1329 1 2 MAO222P $T=341000 1062320 1 0 $X=341000 $Y=1056900
X2642 1418 1405 1139 1421 1 2 MAO222P $T=364560 971600 1 0 $X=364560 $Y=966180
X2643 1421 1415 1089 1424 1 2 MAO222P $T=365180 961520 1 0 $X=365180 $Y=956100
X2644 1420 1385 1157 1418 1 2 MAO222P $T=366420 991760 1 0 $X=366420 $Y=986340
X2645 1441 1442 1110 1410 1 2 MAO222P $T=373860 911120 0 180 $X=368280 $Y=905700
X2646 1436 1423 1132 1452 1 2 MAO222P $T=368280 931280 0 0 $X=368280 $Y=930900
X2647 1425 1448 1430 1381 1 2 MAO222P $T=375720 1042160 1 180 $X=370140 $Y=1041780
X2648 1451 1432 1428 1425 1 2 MAO222P $T=376960 1022000 1 180 $X=371380 $Y=1021620
X2649 1514 1599 1593 1579 1 2 MAO222P $T=404240 1001840 1 0 $X=404240 $Y=996420
X2650 1883 1865 1866 1914 1 2 MAO222P $T=453220 1001840 0 0 $X=453220 $Y=1001460
X2651 1914 1945 1947 1923 1 2 MAO222P $T=465620 1001840 1 180 $X=460040 $Y=1001460
X2652 1923 1974 1982 2042 1 2 MAO222P $T=477400 1011920 1 0 $X=477400 $Y=1006500
X2653 204 199 209 2099 1 2 MAO222P $T=513360 1062320 1 180 $X=507780 $Y=1061940
X2654 2220 2174 2210 2230 1 2 MAO222P $T=515220 981680 1 0 $X=515220 $Y=976260
X2655 2187 2197 2137 2244 1 2 MAO222P $T=518320 1001840 1 0 $X=518320 $Y=996420
X2656 2246 2165 2221 2220 1 2 MAO222P $T=526380 981680 0 180 $X=520800 $Y=976260
X2657 2244 2206 2208 2246 1 2 MAO222P $T=522040 981680 0 0 $X=522040 $Y=981300
X2658 2230 2200 2219 2288 1 2 MAO222P $T=530100 961520 0 0 $X=530100 $Y=961140
X2659 2288 2232 2251 2275 1 2 MAO222P $T=536920 961520 0 0 $X=536920 $Y=961140
X2660 2310 2360 2272 2399 1 2 MAO222P $T=557380 1011920 1 0 $X=557380 $Y=1006500
X2661 2399 2365 2300 2417 1 2 MAO222P $T=559860 1022000 0 0 $X=559860 $Y=1021620
X2662 2418 247 2316 2449 1 2 MAO222P $T=564200 1062320 1 0 $X=564200 $Y=1056900
X2663 2417 2405 2259 2448 1 2 MAO222P $T=564820 1042160 1 0 $X=564820 $Y=1036740
X2664 2448 2402 2299 2418 1 2 MAO222P $T=569780 1052240 0 0 $X=569780 $Y=1051860
X2665 2588 275 2257 2631 1 2 MAO222P $T=597060 1062320 1 0 $X=597060 $Y=1056900
X2666 754 1 759 717 2 ND2P $T=243660 971600 1 0 $X=243660 $Y=966180
X2667 13 1 23 786 2 ND2P $T=248620 1052240 0 0 $X=248620 $Y=1051860
X2668 847 1 881 837 2 ND2P $T=264120 971600 0 0 $X=264120 $Y=971220
X2669 1002 1 972 1010 2 ND2P $T=289540 1011920 0 0 $X=289540 $Y=1011540
X2670 1015 1 1025 1033 2 ND2P $T=295120 971600 0 180 $X=291400 $Y=966180
X2671 768 1 1019 1025 2 ND2P $T=298840 971600 0 180 $X=295120 $Y=966180
X2672 1058 1 1067 1077 2 ND2P $T=303800 941360 0 180 $X=300080 $Y=935940
X2673 1061 1 1074 1071 2 ND2P $T=304420 981680 1 180 $X=300700 $Y=981300
X2674 677 1 1074 1092 2 ND2P $T=303800 981680 1 0 $X=303800 $Y=976260
X2675 1103 1 1095 81 2 ND2P $T=308760 1052240 0 180 $X=305040 $Y=1046820
X2676 1086 1 1096 1075 2 ND2P $T=310000 890960 0 180 $X=306280 $Y=885540
X2677 1102 1 1100 1089 2 ND2P $T=310620 971600 0 180 $X=306900 $Y=966180
X2678 663 1 1096 1123 2 ND2P $T=310000 890960 1 0 $X=310000 $Y=885540
X2679 1127 1 1140 1068 2 ND2P $T=312480 1042160 1 0 $X=312480 $Y=1036740
X2680 1162 1 1151 1126 2 ND2P $T=318680 991760 0 180 $X=314960 $Y=986340
X2681 1162 1 1177 1189 2 ND2P $T=318680 991760 0 0 $X=318680 $Y=991380
X2682 1391 1 1381 1408 2 ND2P $T=364560 1062320 0 180 $X=360840 $Y=1056900
X2683 1399 1 1381 1422 2 ND2P $T=368280 1062320 0 180 $X=364560 $Y=1056900
X2684 1416 1 1410 1429 2 ND2P $T=365800 911120 0 0 $X=365800 $Y=910740
X2685 1426 1 1424 1433 2 ND2P $T=370140 951440 0 180 $X=366420 $Y=946020
X2686 1117 1 1424 1447 2 ND2P $T=380060 951440 1 180 $X=376340 $Y=951060
X2687 1160 1 1452 1456 2 ND2P $T=385640 921200 1 180 $X=381920 $Y=920820
X2688 1479 1 1473 1485 2 ND2P $T=381920 1011920 1 0 $X=381920 $Y=1006500
X2689 1620 1 1579 1647 2 ND2P $T=409820 1001840 1 0 $X=409820 $Y=996420
X2690 1623 1 1579 1637 2 ND2P $T=410440 1001840 0 0 $X=410440 $Y=1001460
X2691 1739 1 1714 1688 2 ND2P $T=426560 1032080 1 180 $X=422840 $Y=1031700
X2692 1739 1 1711 1721 2 ND2P $T=430900 1032080 0 180 $X=427180 $Y=1026660
X2693 2061 1 2042 2059 2 ND2P $T=484840 1022000 0 180 $X=481120 $Y=1016580
X2694 2048 1 2042 2046 2 ND2P $T=486080 1011920 1 180 $X=482360 $Y=1011540
X2695 2065 1 2089 2121 2 ND2P $T=497860 1001840 1 180 $X=494140 $Y=1001460
X2696 2218 1 2180 2270 2 ND2P $T=528860 1001840 1 180 $X=525140 $Y=1001460
X2697 1083 1 1104 1067 2 ND2T $T=306900 951440 0 0 $X=306900 $Y=951060
X2698 673 1 1067 1094 2 ND2T $T=308760 941360 1 0 $X=308760 $Y=935940
X2699 1081 1 1093 1104 2 ND2T $T=314340 961520 0 180 $X=309380 $Y=956100
X2700 2080 1 195 2098 2 ND2T $T=494140 1032080 1 180 $X=489180 $Y=1031700
X2701 2093 1 195 2102 2 ND2T $T=494760 1042160 0 0 $X=494760 $Y=1041780
X2702 2114 1 2133 2146 2 ND2T $T=502820 1022000 0 180 $X=497860 $Y=1016580
X2703 2190 1 2180 2266 2 ND2T $T=528860 1001840 0 180 $X=523900 $Y=996420
X2704 832 826 776 2 1 817 XNR3 $T=255440 1062320 0 0 $X=255440 $Y=1061940
X2705 864 688 869 2 1 850 XNR3 $T=262880 1032080 1 0 $X=262880 $Y=1026660
X2706 730 890 856 2 1 870 XNR3 $T=265980 1042160 1 0 $X=265980 $Y=1036740
X2707 1453 1455 1466 2 1 1446 XNR3 $T=375100 1062320 1 0 $X=375100 $Y=1056900
X2708 1488 1509 1468 2 1 1464 XNR3 $T=389980 971600 0 180 $X=378820 $Y=966180
X2709 1474 1477 1484 2 1 1465 XNR3 $T=380680 1042160 1 0 $X=380680 $Y=1036740
X2710 1536 1528 1508 2 1 1505 XNR3 $T=398040 951440 1 180 $X=386880 $Y=951060
X2711 1553 1547 1510 2 1 1506 XNR3 $T=398040 1032080 1 180 $X=386880 $Y=1031700
X2712 1599 1593 1514 2 1 130 XNR3 $T=406720 1001840 1 180 $X=395560 $Y=1001460
X2713 1585 1587 1580 2 1 1602 XNR3 $T=401760 951440 1 0 $X=401760 $Y=946020
X2714 1684 1670 1621 2 1 138 XNR3 $T=418500 1011920 0 180 $X=407340 $Y=1006500
X2715 1707 1716 1724 2 1 1693 XNR3 $T=422840 1011920 0 0 $X=422840 $Y=1011540
X2716 1865 1866 1883 2 1 1861 XNR3 $T=450740 1011920 1 0 $X=450740 $Y=1006500
X2717 1945 1947 1914 2 1 2010 XNR3 $T=463760 1011920 1 0 $X=463760 $Y=1006500
X2718 1974 1982 1923 2 1 1959 XNR3 $T=469960 1001840 0 0 $X=469960 $Y=1001460
X2719 2171 2176 2256 2 1 2252 XNR3 $T=527620 961520 1 0 $X=527620 $Y=956100
X2720 2232 2251 2288 2 1 2308 XNR3 $T=543120 971600 0 0 $X=543120 $Y=971220
X2721 662 618 1 2 INV2 $T=228780 1052240 0 180 $X=226920 $Y=1046820
X2722 667 718 1 2 INV2 $T=236840 961520 0 0 $X=236840 $Y=961140
X2723 733 708 1 2 INV2 $T=240560 1022000 0 0 $X=240560 $Y=1021620
X2724 752 715 1 2 INV2 $T=243660 1022000 0 0 $X=243660 $Y=1021620
X2725 762 738 1 2 INV2 $T=245520 1032080 1 180 $X=243660 $Y=1031700
X2726 753 757 1 2 INV2 $T=245520 971600 0 0 $X=245520 $Y=971220
X2727 820 784 1 2 INV2 $T=254200 981680 1 180 $X=252340 $Y=981300
X2728 817 30 1 2 INV2 $T=253580 1062320 0 0 $X=253580 $Y=1061940
X2729 781 789 1 2 INV2 $T=254200 991760 0 0 $X=254200 $Y=991380
X2730 824 845 1 2 INV2 $T=257300 1011920 0 0 $X=257300 $Y=1011540
X2731 840 831 1 2 INV2 $T=259160 991760 0 0 $X=259160 $Y=991380
X2732 850 859 1 2 INV2 $T=261020 1032080 1 0 $X=261020 $Y=1026660
X2733 50 847 1 2 INV2 $T=263500 951440 0 180 $X=261640 $Y=946020
X2734 870 54 1 2 INV2 $T=264120 1042160 1 0 $X=264120 $Y=1036740
X2735 893 894 1 2 INV2 $T=267840 991760 0 0 $X=267840 $Y=991380
X2736 911 898 1 2 INV2 $T=270940 971600 0 0 $X=270940 $Y=971220
X2737 898 800 1 2 INV2 $T=270940 981680 1 0 $X=270940 $Y=976260
X2738 914 928 1 2 INV2 $T=279000 1011920 1 180 $X=277140 $Y=1011540
X2739 27 768 1 2 INV2 $T=280240 1011920 0 0 $X=280240 $Y=1011540
X2740 1124 1172 1 2 INV2 $T=317440 1011920 1 180 $X=315580 $Y=1011540
X2741 1148 1180 1 2 INV2 $T=318680 1011920 0 0 $X=318680 $Y=1011540
X2742 1205 1112 1 2 INV2 $T=324880 1042160 0 180 $X=323020 $Y=1036740
X2743 1246 1247 1 2 INV2 $T=332320 991760 0 0 $X=332320 $Y=991380
X2744 80 1114 1 2 INV2 $T=344720 1001840 1 180 $X=342860 $Y=1001460
X2745 1446 1391 1 2 INV2 $T=373240 1062320 1 0 $X=373240 $Y=1056900
X2746 117 75 1 2 INV2 $T=378820 961520 0 0 $X=378820 $Y=961140
X2747 1465 1428 1 2 INV2 $T=378820 1042160 1 0 $X=378820 $Y=1036740
X2748 1464 1432 1 2 INV2 $T=380060 1011920 0 0 $X=380060 $Y=1011540
X2749 1487 1453 1 2 INV2 $T=385020 1062320 0 0 $X=385020 $Y=1061940
X2750 1519 1489 1 2 INV2 $T=390600 981680 0 0 $X=390600 $Y=981300
X2751 1505 1497 1 2 INV2 $T=390600 991760 1 0 $X=390600 $Y=986340
X2752 1503 1510 1 2 INV2 $T=400520 1042160 0 0 $X=400520 $Y=1041780
X2753 1602 1578 1 2 INV2 $T=406100 1011920 0 180 $X=404240 $Y=1006500
X2754 1617 1625 1 2 INV2 $T=409200 921200 1 0 $X=409200 $Y=915780
X2755 1659 1633 1 2 INV2 $T=415400 1052240 0 180 $X=413540 $Y=1046820
X2756 1664 1666 1 2 INV2 $T=416640 921200 1 0 $X=416640 $Y=915780
X2757 1643 1683 1 2 INV2 $T=420360 931280 1 0 $X=420360 $Y=925860
X2758 1693 153 1 2 INV2 $T=420980 1011920 0 0 $X=420980 $Y=1011540
X2759 1745 1645 1 2 INV2 $T=430280 971600 0 180 $X=428420 $Y=966180
X2760 1772 1638 1 2 INV2 $T=435240 981680 0 180 $X=433380 $Y=976260
X2761 1794 1697 1 2 INV2 $T=437100 1052240 1 0 $X=437100 $Y=1046820
X2762 1760 1794 1 2 INV2 $T=441440 1052240 0 0 $X=441440 $Y=1051860
X2763 129 1523 1 2 INV2 $T=450740 991760 0 180 $X=448880 $Y=986340
X2764 1861 178 1 2 INV2 $T=448880 1011920 1 0 $X=448880 $Y=1006500
X2765 1959 184 1 2 INV2 $T=468100 1001840 0 0 $X=468100 $Y=1001460
X2766 188 1568 1 2 INV2 $T=484220 931280 0 0 $X=484220 $Y=930900
X2767 2010 196 1 2 INV2 $T=492900 1032080 1 0 $X=492900 $Y=1026660
X2768 2308 2316 1 2 INV2 $T=541260 971600 0 0 $X=541260 $Y=971220
X2769 2851 249 1 2 INV2 $T=644800 991760 1 180 $X=642940 $Y=991380
X2770 2853 2829 1 2 INV2 $T=646040 1032080 1 0 $X=646040 $Y=1026660
X2771 2869 2623 1 2 INV2 $T=647900 1032080 1 0 $X=647900 $Y=1026660
X2772 2864 2843 1 2 INV2 $T=650380 1042160 0 180 $X=648520 $Y=1036740
X2773 2660 2719 1 2 INV2 $T=655340 941360 0 0 $X=655340 $Y=940980
X2774 2916 2745 1 2 INV2 $T=660300 961520 1 180 $X=658440 $Y=961140
X2775 2941 2717 1 2 INV2 $T=662160 961520 1 180 $X=660300 $Y=961140
X2776 2883 2836 1 2 INV2 $T=660300 1022000 0 0 $X=660300 $Y=1021620
X2777 2656 2712 1 2 INV2 $T=670220 951440 1 0 $X=670220 $Y=946020
X2778 2981 2723 1 2 INV2 $T=673940 961520 0 0 $X=673940 $Y=961140
X2779 2687 2614 1 2 INV2 $T=683860 961520 1 0 $X=683860 $Y=956100
X2780 1108 2 1105 1099 1 AN2B1S $T=311240 1011920 0 180 $X=308140 $Y=1006500
X2781 1180 1172 1 1190 2 AN2S $T=321160 1022000 1 0 $X=321160 $Y=1016580
X2782 1522 116 1 1547 2 AN2S $T=393080 1032080 1 0 $X=393080 $Y=1026660
X2783 1615 116 1 1594 2 AN2S $T=410440 1032080 1 0 $X=410440 $Y=1026660
X2784 1629 1633 1 1595 2 AN2S $T=412920 1052240 1 180 $X=410440 $Y=1051860
X2785 2526 269 1 2 INV8CK $T=584040 951440 0 0 $X=584040 $Y=951060
X2786 2828 257 1 2 INV8CK $T=642940 1032080 0 180 $X=636120 $Y=1026660
X2787 3825 414 1 2 INV8CK $T=869860 951440 1 180 $X=863040 $Y=951060
X2788 3978 3988 1 2 INV8CK $T=918840 961520 0 0 $X=918840 $Y=961140
X2789 4158 4103 1 2 INV8CK $T=974640 951440 0 0 $X=974640 $Y=951060
X2790 272 276 1 2 INV12CK $T=593340 971600 0 0 $X=593340 $Y=971220
X2791 276 277 1 2 INV12CK $T=597680 951440 0 0 $X=597680 $Y=951060
X2792 272 281 1 2 INV12CK $T=616900 941360 0 180 $X=606980 $Y=935940
X2793 276 264 1 2 INV12CK $T=606980 971600 0 0 $X=606980 $Y=971220
X2794 407 403 1 2 INV12CK $T=798560 941360 0 180 $X=788640 $Y=935940
X2795 3825 3708 1 2 INV12CK $T=872960 971600 1 180 $X=863040 $Y=971220
X2796 403 3825 1 2 INV12CK $T=886600 951440 0 180 $X=876680 $Y=946020
X2797 2204 207 206 205 1677 203 1 2 198 AO222 $T=514600 911120 0 180 $X=508400 $Y=905700
X2798 2213 207 206 208 1650 203 1 2 202 AO222 $T=516460 901040 1 180 $X=510260 $Y=900660
X2799 2245 207 206 215 1592 203 1 2 212 AO222 $T=523280 911120 0 180 $X=517080 $Y=905700
X2800 3525 3534 3537 3539 3544 3546 1 2 3455 AO222 $T=791120 931280 0 0 $X=791120 $Y=930900
X2801 3536 3534 3537 3532 3547 3546 1 2 3462 AO222 $T=792360 921200 0 0 $X=792360 $Y=920820
X2802 3540 3534 3537 3548 3552 3546 1 2 3461 AO222 $T=794220 971600 1 0 $X=794220 $Y=966180
X2803 3507 3534 3537 3538 3542 3546 1 2 3485 AO222 $T=795460 971600 0 0 $X=795460 $Y=971220
X2804 3597 3534 3537 3575 3551 3546 1 2 3522 AO222 $T=806620 951440 0 180 $X=800420 $Y=946020
X2805 3567 3534 3537 3579 3590 3546 1 2 3574 AO222 $T=801660 931280 1 0 $X=801660 $Y=925860
X2806 3598 3534 3537 3580 3576 3546 1 2 3444 AO222 $T=807860 971600 1 180 $X=801660 $Y=971220
X2807 3637 3534 3537 3648 3659 3546 1 2 3673 AO222 $T=818400 971600 1 0 $X=818400 $Y=966180
X2808 3630 3534 3537 3698 3664 3546 1 2 3677 AO222 $T=828940 931280 1 0 $X=828940 $Y=925860
X2809 3730 3534 3537 3722 3710 3546 1 2 3699 AO222 $T=840100 961520 1 180 $X=833900 $Y=961140
X2810 3762 3534 3537 3767 3756 3546 1 2 3741 AO222 $T=856840 961520 1 180 $X=850640 $Y=961140
X2811 3787 3534 3537 3777 3761 3546 1 2 3684 AO222 $T=860560 911120 0 180 $X=854360 $Y=905700
X2812 3776 3534 3537 3766 3790 3546 1 2 3786 AO222 $T=856840 961520 0 0 $X=856840 $Y=961140
X2813 3769 3534 3537 3732 3795 3546 1 2 3805 AO222 $T=858080 901040 0 0 $X=858080 $Y=900660
X2814 3823 3534 3537 3828 3833 3546 1 2 3844 AO222 $T=870480 971600 1 0 $X=870480 $Y=966180
X2815 3930 3534 3537 3927 3919 3546 1 2 3882 AO222 $T=903340 971600 0 180 $X=897140 $Y=966180
X2816 3957 3534 3537 3962 3940 3546 1 2 3909 AO222 $T=916980 921200 0 180 $X=910780 $Y=915780
X2817 3998 3534 3537 3996 4014 3546 1 2 4072 AO222 $T=927520 951440 1 0 $X=927520 $Y=946020
X2818 4011 3534 3537 3980 4029 3546 1 2 4040 AO222 $T=929380 921200 0 0 $X=929380 $Y=920820
X2819 3970 3534 3537 4059 4007 3546 1 2 4096 AO222 $T=936820 971600 1 0 $X=936820 $Y=966180
X2820 4136 3534 3537 4124 4140 3546 1 2 4131 AO222 $T=962860 921200 0 0 $X=962860 $Y=920820
X2821 4166 3534 3537 4154 4174 3546 1 2 4182 AO222 $T=970920 931280 1 0 $X=970920 $Y=925860
X2822 4192 3534 3537 4169 4153 3546 1 2 4162 AO222 $T=980220 971600 0 180 $X=974020 $Y=966180
X2823 4219 3534 3537 4195 4203 3546 1 2 4201 AO222 $T=988280 971600 0 180 $X=982080 $Y=966180
X2824 4235 3534 3537 4238 4248 3546 1 2 4257 AO222 $T=998200 921200 0 0 $X=998200 $Y=920820
X2825 4244 3534 3537 4265 4266 3546 1 2 4275 AO222 $T=1003780 971600 1 0 $X=1003780 $Y=966180
X2826 4313 3534 3537 4325 4300 3546 1 2 4310 AO222 $T=1031060 921200 0 180 $X=1024860 $Y=915780
X2827 4317 3534 3537 4324 4328 3546 1 2 4336 AO222 $T=1024860 961520 0 0 $X=1024860 $Y=961140
X2828 4340 3534 3537 4349 4355 3546 1 2 4367 AO222 $T=1032920 921200 1 0 $X=1032920 $Y=915780
X2829 4371 3534 3537 4378 4383 3546 1 2 4387 AO222 $T=1041600 921200 1 0 $X=1041600 $Y=915780
X2830 4455 3534 3537 4452 4444 3546 1 2 4397 AO222 $T=1071360 971600 0 180 $X=1065160 $Y=966180
X2831 4484 3534 3537 4476 4465 3546 1 2 4458 AO222 $T=1080040 921200 1 180 $X=1073840 $Y=920820
X2832 4492 3534 3537 4477 4471 3546 1 2 4456 AO222 $T=1080040 941360 1 180 $X=1073840 $Y=940980
X2833 4485 3534 3537 4478 4472 3546 1 2 4427 AO222 $T=1080040 971600 0 180 $X=1073840 $Y=966180
X2834 879 1 867 834 2 847 ND3 $T=264740 961520 1 180 $X=262260 $Y=961140
X2835 884 1 862 869 2 878 ND3 $T=262260 1032080 0 0 $X=262260 $Y=1031700
X2836 981 1 978 938 2 962 ND3 $T=288920 1042160 1 180 $X=286440 $Y=1041780
X2837 1308 1 1285 1307 2 1295 ND3 $T=343480 1032080 0 180 $X=341000 $Y=1026660
X2838 1407 1 1398 1404 2 1387 ND3 $T=362700 1011920 0 0 $X=362700 $Y=1011540
X2839 1511 1 1525 1468 2 1521 ND3 $T=387500 961520 1 180 $X=385020 $Y=961140
X2840 1492 1 1480 1466 2 1472 ND3 $T=385640 1052240 0 0 $X=385640 $Y=1051860
X2841 2625 1 2633 2586 2 2647 ND3 $T=604500 941360 1 0 $X=604500 $Y=935940
X2842 2650 1 2653 2624 2 2672 ND3 $T=608840 911120 1 0 $X=608840 $Y=905700
X2843 2663 1 2680 2520 2 2700 ND3 $T=613180 911120 0 0 $X=613180 $Y=910740
X2844 2686 1 2691 2651 2 2696 ND3 $T=615040 901040 0 0 $X=615040 $Y=900660
X2845 2726 1 2722 2600 2 2713 ND3 $T=621240 941360 0 180 $X=618760 $Y=935940
X2846 2743 1 2715 2554 2 2754 ND3 $T=625580 951440 0 0 $X=625580 $Y=951060
X2847 2786 1 2747 2677 2 2778 ND3 $T=632400 961520 0 180 $X=629920 $Y=956100
X2848 2773 1 2776 2613 2 2814 ND3 $T=631160 901040 0 0 $X=631160 $Y=900660
X2849 2804 1 2803 2738 2 2813 ND3 $T=636120 901040 0 0 $X=636120 $Y=900660
X2850 2807 1 2810 2619 2 2816 ND3 $T=636120 961520 0 0 $X=636120 $Y=961140
X2851 2820 1 2823 2669 2 2806 ND3 $T=640460 961520 0 180 $X=637980 $Y=956100
X2852 2842 1 2837 295 2 2845 ND3 $T=643560 890960 1 180 $X=641080 $Y=890580
X2853 2818 1 2841 2848 2 2843 ND3 $T=645420 1022000 1 180 $X=642940 $Y=1021620
X2854 2868 1 2864 2856 2 2818 ND3 $T=648520 1022000 1 180 $X=646040 $Y=1021620
X2855 2818 1 2843 2850 2 2871 ND3 $T=646660 1032080 0 0 $X=646660 $Y=1031700
X2856 2863 1 2855 2817 2 2881 ND3 $T=647900 961520 1 0 $X=647900 $Y=956100
X2857 2887 1 2884 2794 2 2877 ND3 $T=652240 951440 1 180 $X=649760 $Y=951060
X2858 2888 1 2891 303 2 2897 ND3 $T=651620 921200 0 0 $X=651620 $Y=920820
X2859 2875 1 2899 2791 2 2908 ND3 $T=652860 961520 0 0 $X=652860 $Y=961140
X2860 2947 1 2895 299 2 2913 ND3 $T=661540 901040 0 180 $X=659060 $Y=895620
X2861 2942 1 2933 2659 2 2905 ND3 $T=661540 1052240 0 180 $X=659060 $Y=1046820
X2862 2936 1 2950 2838 2 2967 ND3 $T=661540 941360 0 0 $X=661540 $Y=940980
X2863 2944 1 2956 314 2 2948 ND3 $T=663400 901040 1 0 $X=663400 $Y=895620
X2864 2952 1 2961 313 2 2966 ND3 $T=663400 921200 0 0 $X=663400 $Y=920820
X2865 2987 1 2992 2953 2 2997 ND3 $T=670220 961520 1 0 $X=670220 $Y=956100
X2866 3002 1 3011 2993 2 3022 ND3 $T=675180 941360 1 0 $X=675180 $Y=935940
X2867 3013 1 3021 318 2 3029 ND3 $T=677040 921200 0 0 $X=677040 $Y=920820
X2868 3036 1 3044 324 2 3055 ND3 $T=682000 911120 0 0 $X=682000 $Y=910740
X2869 2829 1 3047 329 2 2623 ND3 $T=682000 1052240 1 0 $X=682000 $Y=1046820
X2870 3242 1 3214 3265 2 3184 ND3 $T=726640 1022000 0 0 $X=726640 $Y=1021620
X2871 3236 1 3211 3257 2 3265 ND3 $T=732220 1022000 0 180 $X=729740 $Y=1016580
X2872 3327 1 3337 3341 2 3342 ND3 $T=743380 1032080 1 0 $X=743380 $Y=1026660
X2873 3329 1 3323 3382 2 3355 ND3 $T=745240 1022000 0 0 $X=745240 $Y=1021620
X2874 359 1 3363 3413 2 3372 ND3 $T=750200 1022000 0 0 $X=750200 $Y=1021620
X2875 3454 1 3448 3459 2 3426 ND3 $T=769420 1032080 1 0 $X=769420 $Y=1026660
X2876 393 1 3494 3491 2 3487 ND3 $T=779960 1022000 1 180 $X=777480 $Y=1021620
X2877 372 1 3407 369 2 396 ND3 $T=779340 880880 0 0 $X=779340 $Y=880500
X2878 3517 1 3515 3504 2 3509 ND3 $T=785540 1022000 0 180 $X=783060 $Y=1016580
X2879 3554 1 3558 3556 2 3561 ND3 $T=797940 1022000 0 0 $X=797940 $Y=1021620
X2880 420 1 3612 3613 2 3607 ND3 $T=812200 1022000 1 180 $X=809720 $Y=1021620
X2881 3624 1 3643 3662 2 3635 ND3 $T=820880 1022000 0 0 $X=820880 $Y=1021620
X2882 3683 1 3678 3696 2 3697 ND3 $T=827700 1032080 1 0 $X=827700 $Y=1026660
X2883 444 1 3728 3716 2 3736 ND3 $T=840100 1022000 0 0 $X=840100 $Y=1021620
X2884 3751 1 3763 3765 2 3760 ND3 $T=853120 1022000 0 0 $X=853120 $Y=1021620
X2885 3813 1 3816 3811 2 3812 ND3 $T=867380 1022000 1 180 $X=864900 $Y=1021620
X2886 455 1 3824 3834 2 3829 ND3 $T=869860 1032080 1 0 $X=869860 $Y=1026660
X2887 3854 1 3872 3866 2 3857 ND3 $T=885980 1022000 0 180 $X=883500 $Y=1016580
X2888 3890 1 3894 3889 2 3914 ND3 $T=890320 1022000 0 0 $X=890320 $Y=1021620
X2889 471 1 3922 3925 2 3931 ND3 $T=897140 1022000 1 0 $X=897140 $Y=1016580
X2890 491 1 4002 4026 2 4027 ND3 $T=929380 1022000 1 0 $X=929380 $Y=1016580
X2891 4053 1 4056 4057 2 4064 ND3 $T=938060 1022000 0 0 $X=938060 $Y=1021620
X2892 4066 1 4083 4086 2 4089 ND3 $T=941780 1022000 1 0 $X=941780 $Y=1016580
X2893 4112 1 4113 4114 2 4116 ND3 $T=951700 1022000 0 0 $X=951700 $Y=1021620
X2894 517 1 4146 4164 2 4163 ND3 $T=966580 1011920 0 0 $X=966580 $Y=1011540
X2895 4214 1 4183 4216 2 4189 ND3 $T=986420 1032080 1 0 $X=986420 $Y=1026660
X2896 4205 1 4225 4226 2 4224 ND3 $T=990140 1022000 0 0 $X=990140 $Y=1021620
X2897 4229 1 4250 4249 2 4258 ND3 $T=1001920 1032080 1 0 $X=1001920 $Y=1026660
X2898 538 1 4276 4269 2 4267 ND3 $T=1006880 1022000 1 0 $X=1006880 $Y=1016580
X2899 4287 1 4290 4288 2 4297 ND3 $T=1015560 1011920 0 0 $X=1015560 $Y=1011540
X2900 4319 1 4311 4330 2 4326 ND3 $T=1025480 1022000 1 0 $X=1025480 $Y=1016580
X2901 4357 1 4354 4363 2 4369 ND3 $T=1037260 1032080 1 0 $X=1037260 $Y=1026660
X2902 549 1 4376 4380 2 4402 ND3 $T=1042220 1022000 1 0 $X=1042220 $Y=1016580
X2903 4415 1 4421 4441 2 4429 ND3 $T=1057720 1022000 1 0 $X=1057720 $Y=1016580
X2904 4461 1 4459 4446 2 4464 ND3 $T=1070740 1022000 1 180 $X=1068260 $Y=1021620
X2905 567 1 4474 4460 2 4468 ND3 $T=1075700 1022000 1 180 $X=1073220 $Y=1021620
X2906 564 1 4467 4469 2 4475 ND3 $T=1073220 1032080 1 0 $X=1073220 $Y=1026660
X2907 3434 3431 3406 2 3444 1 3441 AN4B1S $T=765700 971600 0 0 $X=765700 $Y=971220
X2908 3425 3411 3450 2 3455 1 3452 AN4B1S $T=767560 931280 1 0 $X=767560 $Y=925860
X2909 3433 3456 3440 2 3461 1 3460 AN4B1S $T=768800 971600 1 0 $X=768800 $Y=966180
X2910 3479 3470 3466 2 3462 1 387 AN4B1S $T=775000 921200 1 180 $X=770660 $Y=920820
X2911 3474 3449 3387 2 3485 1 3472 AN4B1S $T=774380 971600 0 0 $X=774380 $Y=971220
X2912 3493 3423 3510 2 3522 1 401 AN4B1S $T=783680 951440 1 0 $X=783680 $Y=946020
X2913 3594 3584 3570 2 3574 1 3572 AN4B1S $T=806620 931280 1 180 $X=802280 $Y=930900
X2914 3670 3657 3680 2 3684 1 3623 AN4B1S $T=824600 911120 0 0 $X=824600 $Y=910740
X2915 3690 3685 3639 2 3677 1 3669 AN4B1S $T=828940 921200 0 180 $X=824600 $Y=915780
X2916 3653 3672 3688 2 3673 1 3650 AN4B1S $T=826460 971600 1 0 $X=826460 $Y=966180
X2917 3709 3704 3701 2 3699 1 439 AN4B1S $T=835140 971600 0 180 $X=830800 $Y=966180
X2918 3726 3738 3739 2 3741 1 3746 AN4B1S $T=842580 971600 0 0 $X=842580 $Y=971220
X2919 3799 3796 3789 2 3786 1 3781 AN4B1S $T=863040 961520 0 180 $X=858700 $Y=956100
X2920 3837 3832 3841 2 3805 1 3820 AN4B1S $T=881020 921200 1 180 $X=876680 $Y=920820
X2921 3897 3880 3868 2 3844 1 3862 AN4B1S $T=888460 961520 1 180 $X=884120 $Y=961140
X2922 3892 3888 3886 2 3882 1 3869 AN4B1S $T=890940 961520 0 180 $X=886600 $Y=956100
X2923 3895 3904 3905 2 3909 1 469 AN4B1S $T=891560 921200 0 0 $X=891560 $Y=920820
X2924 4069 4058 4055 2 4040 1 4046 AN4B1S $T=941160 921200 0 180 $X=936820 $Y=915780
X2925 4088 4080 4077 2 4072 1 4061 AN4B1S $T=944260 941360 1 180 $X=939920 $Y=940980
X2926 4034 4078 4020 2 4096 1 4067 AN4B1S $T=943020 971600 0 0 $X=943020 $Y=971220
X2927 4133 4134 4132 2 4131 1 4126 AN4B1S $T=961000 921200 1 180 $X=956660 $Y=920820
X2928 4170 4165 4157 2 4162 1 519 AN4B1S $T=972780 971600 1 180 $X=968440 $Y=971220
X2929 4200 4199 4197 2 4182 1 524 AN4B1S $T=984560 921200 1 180 $X=980220 $Y=920820
X2930 4233 4222 4228 2 4201 1 4212 AN4B1S $T=996340 961520 0 180 $X=992000 $Y=956100
X2931 4241 4263 4252 2 4257 1 539 AN4B1S $T=1005640 921200 0 0 $X=1005640 $Y=920820
X2932 4277 4278 4273 2 4275 1 540 AN4B1S $T=1011840 971600 1 0 $X=1011840 $Y=966180
X2933 4303 4301 4307 2 4310 1 4306 AN4B1S $T=1020520 931280 1 0 $X=1020520 $Y=925860
X2934 4333 4337 4332 2 4336 1 548 AN4B1S $T=1031060 971600 1 0 $X=1031060 $Y=966180
X2935 4368 4351 4364 2 4367 1 551 AN4B1S $T=1039120 931280 1 0 $X=1039120 $Y=925860
X2936 4396 4390 4384 2 4387 1 4385 AN4B1S $T=1049660 931280 0 180 $X=1045320 $Y=925860
X2937 4403 4395 4400 2 4397 1 4399 AN4B1S $T=1052760 961520 1 180 $X=1048420 $Y=961140
X2938 4417 4424 4426 2 4427 1 4409 AN4B1S $T=1058340 971600 1 0 $X=1058340 $Y=966180
X2939 4440 4432 4453 2 4456 1 4437 AN4B1S $T=1067020 941360 0 0 $X=1067020 $Y=940980
X2940 4447 4451 4448 2 4458 1 563 AN4B1S $T=1067640 921200 0 0 $X=1067640 $Y=920820
X2941 2746 1 2 2733 BUF1CK $T=623720 1032080 1 0 $X=623720 $Y=1026660
X2942 2489 1 2 2973 BUF1CK $T=668980 901040 1 0 $X=668980 $Y=895620
X2943 3035 1 2 3033 BUF1CK $T=680140 1001840 1 0 $X=680140 $Y=996420
X2944 3156 1 2 3165 BUF1CK $T=709280 991760 0 0 $X=709280 $Y=991380
X2945 2923 1 2 3319 BUF1CK $T=738420 901040 1 0 $X=738420 $Y=895620
X2946 456 1 2 457 BUF1CK $T=868620 880880 0 0 $X=868620 $Y=880500
X2947 3856 1 2 3845 BUF1CK $T=879780 991760 0 0 $X=879780 $Y=991380
X2948 4344 1 2 4340 BUF1CK $T=1032920 921200 0 0 $X=1032920 $Y=920820
X2949 4385 1 2 4382 BUF1CK $T=1047180 921200 0 0 $X=1047180 $Y=920820
X2950 4430 1 2 4434 BUF1CK $T=1060200 951440 1 0 $X=1060200 $Y=946020
X2951 366 368 369 370 2 1 3400 OA22 $T=756400 880880 0 0 $X=756400 $Y=880500
X2952 3407 374 369 371 2 1 3428 OA22 $T=761360 890960 0 0 $X=761360 $Y=890580
X2953 366 380 369 384 2 1 3419 OA22 $T=766940 880880 0 0 $X=766940 $Y=880500
X2954 366 381 369 376 2 1 3465 OA22 $T=766940 890960 0 0 $X=766940 $Y=890580
X2955 388 389 3476 391 2 1 392 OA22 $T=773140 890960 1 0 $X=773140 $Y=885540
X2956 3407 388 369 3476 2 1 3488 OA22 $T=773140 890960 0 0 $X=773140 $Y=890580
X2957 3407 394 369 395 2 1 3505 OA22 $T=778720 890960 1 0 $X=778720 $Y=885540
X2958 3407 399 369 3526 2 1 3533 OA22 $T=785540 890960 1 0 $X=785540 $Y=885540
X2959 399 389 3526 391 2 1 402 OA22 $T=786780 880880 0 0 $X=786780 $Y=880500
X2960 3518 389 3564 391 2 1 412 OA22 $T=801040 890960 1 0 $X=801040 $Y=885540
X2961 3407 3518 3562 3564 2 1 3585 OA22 $T=801660 890960 0 0 $X=801660 $Y=890580
X2962 3407 3601 3562 3595 2 1 3611 OA22 $T=807240 901040 1 0 $X=807240 $Y=895620
X2963 3601 389 3595 391 2 1 423 OA22 $T=810960 890960 0 0 $X=810960 $Y=890580
X2964 3407 3629 3562 3615 2 1 3644 OA22 $T=815920 901040 1 0 $X=815920 $Y=895620
X2965 3629 389 3615 391 2 1 435 OA22 $T=819020 890960 0 0 $X=819020 $Y=890580
X2966 3407 3649 3562 3667 2 1 3674 OA22 $T=821500 901040 1 0 $X=821500 $Y=895620
X2967 3649 389 3667 391 2 1 437 OA22 $T=824600 890960 0 0 $X=824600 $Y=890580
X2968 3847 389 3851 391 2 1 460 OA22 $T=877300 890960 0 0 $X=877300 $Y=890580
X2969 3407 3847 3562 3851 2 1 3793 OA22 $T=884120 901040 0 180 $X=879780 $Y=895620
X2970 3867 389 3878 391 2 1 465 OA22 $T=884740 890960 0 0 $X=884740 $Y=890580
X2971 3407 3867 3562 3878 2 1 3871 OA22 $T=890940 901040 0 180 $X=886600 $Y=895620
X2972 3407 3902 3562 3893 2 1 3852 OA22 $T=894040 890960 1 180 $X=889700 $Y=890580
X2973 3902 389 3893 391 2 1 475 OA22 $T=897140 890960 0 0 $X=897140 $Y=890580
X2974 3407 3934 3562 3933 2 1 3923 OA22 $T=905820 901040 0 180 $X=901480 $Y=895620
X2975 3407 3942 3562 3946 2 1 3943 OA22 $T=907680 901040 0 0 $X=907680 $Y=900660
X2976 3942 389 3946 391 2 1 3941 OA22 $T=911400 901040 1 0 $X=911400 $Y=895620
X2977 3934 389 3933 391 2 1 479 OA22 $T=912020 890960 0 0 $X=912020 $Y=890580
X2978 3407 481 3562 483 2 1 3977 OA22 $T=918220 890960 0 0 $X=918220 $Y=890580
X2979 3407 485 3562 3990 2 1 4004 OA22 $T=922560 890960 0 0 $X=922560 $Y=890580
X2980 485 389 3990 391 2 1 4038 OA22 $T=923180 890960 1 0 $X=923180 $Y=885540
X2981 3407 490 3562 482 2 1 4025 OA22 $T=928140 901040 1 0 $X=928140 $Y=895620
X2982 3407 495 3562 4012 2 1 4042 OA22 $T=932480 890960 0 0 $X=932480 $Y=890580
X2983 3407 496 3562 488 2 1 4054 OA22 $T=933100 901040 1 0 $X=933100 $Y=895620
X2984 495 389 4012 391 2 1 497 OA22 $T=933720 880880 0 0 $X=933720 $Y=880500
X2985 4068 389 3994 391 2 1 505 OA22 $T=940540 890960 1 0 $X=940540 $Y=885540
X2986 3407 4068 3562 3994 2 1 4094 OA22 $T=940540 890960 0 0 $X=940540 $Y=890580
X2987 3407 3773 3562 4060 2 1 4111 OA22 $T=946740 890960 0 0 $X=946740 $Y=890580
X2988 3773 389 4060 391 2 1 4118 OA22 $T=949220 880880 0 0 $X=949220 $Y=880500
X2989 3407 3846 3562 4021 2 1 4122 OA22 $T=952940 890960 0 0 $X=952940 $Y=890580
X2990 3846 389 4021 391 2 1 511 OA22 $T=956040 880880 0 0 $X=956040 $Y=880500
X2991 3407 432 3562 500 2 1 4138 OA22 $T=959140 890960 0 0 $X=959140 $Y=890580
X2992 3407 518 3562 4149 2 1 4172 OA22 $T=967200 890960 1 0 $X=967200 $Y=885540
X2993 518 389 4149 391 2 1 527 OA22 $T=968440 880880 0 0 $X=968440 $Y=880500
X2994 3407 523 3562 4173 2 1 4191 OA22 $T=975260 890960 0 0 $X=975260 $Y=890580
X2995 523 389 4173 391 2 1 525 OA22 $T=977120 890960 1 0 $X=977120 $Y=885540
X2996 3407 4150 3562 4159 2 1 4213 OA22 $T=980840 890960 0 0 $X=980840 $Y=890580
X2997 4150 389 4159 391 2 1 529 OA22 $T=983320 890960 1 0 $X=983320 $Y=885540
X2998 3407 4305 3562 4302 2 1 4316 OA22 $T=1020520 901040 1 0 $X=1020520 $Y=895620
X2999 4305 389 4302 391 2 1 544 OA22 $T=1021760 890960 1 0 $X=1021760 $Y=885540
X3000 4289 389 4322 391 2 1 4334 OA22 $T=1027960 880880 0 0 $X=1027960 $Y=880500
X3001 3407 545 3562 536 2 1 4342 OA22 $T=1027960 901040 1 0 $X=1027960 $Y=895620
X3002 3407 4289 3562 4322 2 1 4372 OA22 $T=1029820 890960 0 0 $X=1029820 $Y=890580
X3003 4341 389 4352 391 2 1 4366 OA22 $T=1034780 880880 0 0 $X=1034780 $Y=880500
X3004 547 389 4220 391 2 1 4381 OA22 $T=1036020 890960 1 0 $X=1036020 $Y=885540
X3005 3407 4341 3562 4352 2 1 4373 OA22 $T=1037260 901040 1 0 $X=1037260 $Y=895620
X3006 3407 547 3562 4220 2 1 4386 OA22 $T=1042220 890960 0 0 $X=1042220 $Y=890580
X3007 360 365 3416 1 2 362 343 3475 589 ICV_6 $T=753920 1062320 1 0 $X=753920 $Y=1056900
X3008 378 3362 3489 1 2 378 3478 3536 589 ICV_6 $T=771900 921200 1 0 $X=771900 $Y=915780
X3009 3239 3478 3507 1 2 350 3478 3540 589 ICV_6 $T=773140 971600 1 0 $X=773140 $Y=966180
X3010 3239 3523 3542 1 2 400 3347 3582 589 ICV_6 $T=784300 991760 0 0 $X=784300 $Y=991380
X3011 400 3362 3569 1 2 410 3362 3616 589 ICV_6 $T=792980 921200 1 0 $X=792980 $Y=915780
X3012 408 3282 3599 1 2 408 3278 3620 589 ICV_6 $T=798560 1042160 1 0 $X=798560 $Y=1036740
X3013 408 3478 3630 1 2 410 3383 3665 589 ICV_6 $T=807860 931280 1 0 $X=807860 $Y=925860
X3014 408 3347 3632 1 2 3610 3347 3687 589 ICV_6 $T=808480 1001840 1 0 $X=808480 $Y=996420
X3015 400 3376 3634 1 2 410 3376 3661 589 ICV_6 $T=809100 941360 0 0 $X=809100 $Y=940980
X3016 3610 3278 3713 1 2 433 3278 3748 589 ICV_6 $T=828940 1032080 0 0 $X=828940 $Y=1031700
X3017 3610 3282 3705 1 2 442 3282 3768 589 ICV_6 $T=830180 1042160 1 0 $X=830180 $Y=1036740
X3018 408 3376 3735 1 2 3734 3362 3771 589 ICV_6 $T=832660 941360 1 0 $X=832660 $Y=935940
X3019 410 3478 3787 1 2 446 3523 3795 589 ICV_6 $T=850020 921200 1 0 $X=850020 $Y=915780
X3020 410 3506 3777 1 2 446 3383 3836 589 ICV_6 $T=856220 931280 1 0 $X=856220 $Y=925860
X3021 3734 3376 3810 1 2 446 3347 3856 589 ICV_6 $T=859940 991760 1 0 $X=859940 $Y=986340
X3022 453 3390 3896 1 2 462 3390 3920 589 ICV_6 $T=886600 941360 1 0 $X=886600 $Y=935940
X3023 3981 4073 4104 1 2 3981 4107 4135 589 ICV_6 $T=939920 931280 0 0 $X=939920 $Y=930900
X3024 4075 3975 4117 1 2 4127 3975 4179 589 ICV_6 $T=951080 1042160 1 0 $X=951080 $Y=1036740
X3025 4206 507 4254 1 2 537 492 4283 589 ICV_6 $T=995720 1052240 1 0 $X=995720 $Y=1046820
X3026 4206 4107 4262 1 2 537 4107 4298 589 ICV_6 $T=998820 941360 0 0 $X=998820 $Y=940980
X3027 185 1 2 128 INV3CK $T=472440 880880 0 0 $X=472440 $Y=880500
X3028 2252 1 2 2257 INV3CK $T=524520 961520 1 0 $X=524520 $Y=956100
X3029 2540 1 2 2278 INV3CK $T=587140 1011920 0 180 $X=584040 $Y=1006500
X3030 2759 1 2 2757 INV3CK $T=625580 1001840 0 0 $X=625580 $Y=1001460
X3031 3638 1 2 3645 INV3CK $T=819020 911120 0 0 $X=819020 $Y=910740
X3032 3671 1 2 3681 INV3CK $T=825840 931280 0 0 $X=825840 $Y=930900
X3033 3703 1 2 3750 INV3CK $T=849400 961520 0 180 $X=846300 $Y=956100
X3034 3645 1 2 3334 INV3CK $T=853740 901040 0 0 $X=853740 $Y=900660
X3035 3775 1 2 3814 INV3CK $T=866140 921200 1 180 $X=863040 $Y=920820
X3036 3731 1 2 3347 INV3CK $T=863040 1001840 0 0 $X=863040 $Y=1001460
X3037 3774 1 2 3753 INV3CK $T=879780 941360 0 180 $X=876680 $Y=935940
X3038 3898 1 2 3900 INV3CK $T=891560 931280 0 0 $X=891560 $Y=930900
X3039 3973 1 2 3997 INV3CK $T=926280 931280 0 180 $X=923180 $Y=925860
X3040 4151 1 2 4158 INV3CK $T=966580 911120 0 0 $X=966580 $Y=910740
X3041 277 2526 1 2 INV6CK $T=597680 961520 0 0 $X=597680 $Y=961140
X3042 2757 251 1 2 INV6CK $T=625580 981680 0 0 $X=625580 $Y=981300
X3043 3389 3376 1 2 INV6CK $T=756400 961520 0 0 $X=756400 $Y=961140
X3044 3401 3383 1 2 INV6CK $T=759500 951440 0 0 $X=759500 $Y=951060
X3045 3486 346 1 2 INV6CK $T=777480 1052240 1 180 $X=771900 $Y=1051860
X3046 3437 343 1 2 INV6CK $T=776860 1062320 0 0 $X=776860 $Y=1061940
X3047 3753 3390 1 2 INV6CK $T=849400 931280 0 0 $X=849400 $Y=930900
X3048 3591 3478 1 2 INV6CK $T=849400 981680 1 0 $X=849400 $Y=976260
X3049 3819 3362 1 2 INV6CK $T=868620 931280 1 180 $X=863040 $Y=930900
X3050 3814 3506 1 2 INV6CK $T=882260 971600 0 180 $X=876680 $Y=966180
X3051 4081 4006 1 2 INV6CK $T=943020 941360 0 180 $X=937440 $Y=935940
X3052 3900 4043 1 2 INV6CK $T=956660 941360 0 180 $X=951080 $Y=935940
X3053 4084 484 1 2 INV6CK $T=963480 1022000 1 180 $X=957900 $Y=1021620
X3054 3988 4073 1 2 INV6CK $T=966580 951440 0 180 $X=961000 $Y=946020
X3055 2989 1 2922 2910 2975 2902 2 OAI22S $T=671460 1022000 1 180 $X=667740 $Y=1021620
X3056 3562 1 339 3407 3950 339 2 OAI22S $T=909540 911120 0 0 $X=909540 $Y=910740
X3057 3562 1 340 3407 3964 340 2 OAI22S $T=920700 911120 0 0 $X=920700 $Y=910740
X3058 3562 1 3496 3407 3979 3496 2 OAI22S $T=925660 911120 0 180 $X=921940 $Y=905700
X3059 3562 1 341 3407 3986 341 2 OAI22S $T=928140 911120 1 180 $X=924420 $Y=910740
X3060 391 1 3496 389 489 3496 2 OAI22S $T=932480 880880 1 180 $X=928760 $Y=880500
X3061 669 2 727 717 1 NR2 $T=236840 981680 0 0 $X=236840 $Y=981300
X3062 669 2 710 718 1 NR2 $T=237460 991760 1 0 $X=237460 $Y=986340
X3063 669 2 729 736 1 NR2 $T=240560 981680 1 0 $X=240560 $Y=976260
X3064 669 2 756 757 1 NR2 $T=245520 981680 1 0 $X=245520 $Y=976260
X3065 777 2 682 24 1 NR2 $T=248620 890960 0 0 $X=248620 $Y=890580
X3066 777 2 660 24 1 NR2 $T=248620 901040 1 0 $X=248620 $Y=895620
X3067 820 2 795 771 1 NR2 $T=254200 991760 0 180 $X=252340 $Y=986340
X3068 24 2 809 35 1 NR2 $T=257300 890960 0 0 $X=257300 $Y=890580
X3069 24 2 808 844 1 NR2 $T=257300 901040 1 0 $X=257300 $Y=895620
X3070 24 2 813 34 1 NR2 $T=257300 901040 0 0 $X=257300 $Y=900660
X3071 24 2 811 36 1 NR2 $T=257300 951440 0 0 $X=257300 $Y=951060
X3072 24 2 816 39 1 NR2 $T=259160 911120 1 0 $X=259160 $Y=905700
X3073 24 2 818 45 1 NR2 $T=259160 911120 0 0 $X=259160 $Y=910740
X3074 24 2 827 40 1 NR2 $T=259160 921200 1 0 $X=259160 $Y=915780
X3075 24 2 810 41 1 NR2 $T=259160 951440 1 0 $X=259160 $Y=946020
X3076 24 2 812 42 1 NR2 $T=259160 961520 0 0 $X=259160 $Y=961140
X3077 24 2 788 43 1 NR2 $T=259160 971600 0 0 $X=259160 $Y=971220
X3078 794 2 840 843 1 NR2 $T=261020 981680 1 180 $X=259160 $Y=981300
X3079 24 2 829 49 1 NR2 $T=260400 921200 0 0 $X=260400 $Y=920820
X3080 24 2 830 47 1 NR2 $T=260400 951440 0 0 $X=260400 $Y=951060
X3081 24 2 835 48 1 NR2 $T=261020 971600 1 0 $X=261020 $Y=966180
X3082 24 2 823 52 1 NR2 $T=262260 931280 1 0 $X=262260 $Y=925860
X3083 24 2 797 56 1 NR2 $T=262260 941360 0 0 $X=262260 $Y=940980
X3084 872 2 861 834 1 NR2 $T=264120 981680 0 180 $X=262260 $Y=976260
X3085 24 2 849 55 1 NR2 $T=264120 931280 0 0 $X=264120 $Y=930900
X3086 46 2 895 48 1 NR2 $T=267840 951440 1 180 $X=265980 $Y=951060
X3087 46 2 907 39 1 NR2 $T=270940 921200 1 180 $X=269080 $Y=920820
X3088 872 2 920 800 1 NR2 $T=272800 981680 1 180 $X=270940 $Y=981300
X3089 777 2 846 46 1 NR2 $T=271560 890960 0 0 $X=271560 $Y=890580
X3090 46 2 917 844 1 NR2 $T=272800 901040 0 0 $X=272800 $Y=900660
X3091 46 2 924 42 1 NR2 $T=274660 951440 0 0 $X=274660 $Y=951060
X3092 46 2 925 34 1 NR2 $T=277760 911120 1 180 $X=275900 $Y=910740
X3093 46 2 935 45 1 NR2 $T=276520 921200 0 0 $X=276520 $Y=920820
X3094 46 2 901 35 1 NR2 $T=277140 911120 1 0 $X=277140 $Y=905700
X3095 46 2 952 40 1 NR2 $T=277760 931280 1 0 $X=277760 $Y=925860
X3096 46 2 963 36 1 NR2 $T=282720 951440 0 0 $X=282720 $Y=951060
X3097 46 2 953 47 1 NR2 $T=283340 951440 1 0 $X=283340 $Y=946020
X3098 872 2 974 843 1 NR2 $T=285200 971600 1 180 $X=283340 $Y=971220
X3099 777 2 944 46 1 NR2 $T=285200 890960 1 0 $X=285200 $Y=885540
X3100 46 2 988 49 1 NR2 $T=288300 931280 0 180 $X=286440 $Y=925860
X3101 872 2 991 837 1 NR2 $T=288300 981680 0 180 $X=286440 $Y=976260
X3102 46 2 1023 56 1 NR2 $T=293260 941360 0 0 $X=293260 $Y=940980
X3103 46 2 1008 41 1 NR2 $T=293260 951440 0 0 $X=293260 $Y=951060
X3104 46 2 1030 1062 1 NR2 $T=301940 921200 1 180 $X=300080 $Y=920820
X3105 46 2 1034 55 1 NR2 $T=301940 931280 1 0 $X=301940 $Y=925860
X3106 1120 2 1129 844 1 NR2 $T=311860 901040 0 0 $X=311860 $Y=900660
X3107 1120 2 1150 35 1 NR2 $T=311860 911120 0 0 $X=311860 $Y=910740
X3108 1120 2 1143 34 1 NR2 $T=311860 921200 0 0 $X=311860 $Y=920820
X3109 1120 2 1144 39 1 NR2 $T=311860 931280 1 0 $X=311860 $Y=925860
X3110 1120 2 1152 45 1 NR2 $T=313720 941360 1 0 $X=313720 $Y=935940
X3111 1120 2 1136 40 1 NR2 $T=313720 941360 0 0 $X=313720 $Y=940980
X3112 1120 2 1137 41 1 NR2 $T=313720 951440 1 0 $X=313720 $Y=946020
X3113 82 2 1131 43 1 NR2 $T=316820 981680 0 180 $X=314960 $Y=976260
X3114 1120 2 1156 49 1 NR2 $T=315580 941360 0 0 $X=315580 $Y=940980
X3115 1120 2 1166 55 1 NR2 $T=318060 961520 0 180 $X=316200 $Y=956100
X3116 1120 2 1169 52 1 NR2 $T=316820 951440 1 0 $X=316820 $Y=946020
X3117 777 2 1155 1120 1 NR2 $T=317440 901040 0 0 $X=317440 $Y=900660
X3118 82 2 1173 36 1 NR2 $T=318060 971600 0 0 $X=318060 $Y=971220
X3119 1120 2 1188 56 1 NR2 $T=318680 961520 1 0 $X=318680 $Y=956100
X3120 82 2 1193 48 1 NR2 $T=324260 981680 1 180 $X=322400 $Y=981300
X3121 88 2 1214 1189 1 NR2 $T=324260 1001840 0 180 $X=322400 $Y=996420
X3122 82 2 1198 42 1 NR2 $T=323640 981680 1 0 $X=323640 $Y=976260
X3123 777 2 1206 1120 1 NR2 $T=326740 901040 1 180 $X=324880 $Y=900660
X3124 88 2 1266 1245 1 NR2 $T=334180 1001840 0 180 $X=332320 $Y=996420
X3125 88 2 1272 1126 1 NR2 $T=336040 991760 1 180 $X=334180 $Y=991380
X3126 88 2 1293 1292 1 NR2 $T=341000 981680 1 180 $X=339140 $Y=981300
X3127 1550 2 1614 1591 1 NR2 $T=406100 931280 1 180 $X=404240 $Y=930900
X3128 1653 2 1537 1638 1 NR2 $T=412920 971600 1 180 $X=411060 $Y=971220
X3129 1643 2 1605 1648 1 NR2 $T=412300 921200 1 0 $X=412300 $Y=915780
X3130 1651 2 1552 1660 1 NR2 $T=414160 921200 1 0 $X=414160 $Y=915780
X3131 1653 2 1610 1672 1 NR2 $T=416020 961520 1 0 $X=416020 $Y=956100
X3132 1653 2 1636 1669 1 NR2 $T=418500 961520 1 180 $X=416640 $Y=961140
X3133 150 2 1701 1669 1 NR2 $T=419740 981680 1 0 $X=419740 $Y=976260
X3134 155 2 1710 43 1 NR2 $T=423460 890960 0 180 $X=421600 $Y=885540
X3135 157 2 1661 43 1 NR2 $T=423460 951440 0 180 $X=421600 $Y=946020
X3136 155 2 1681 48 1 NR2 $T=422840 890960 0 0 $X=422840 $Y=890580
X3137 155 2 1720 36 1 NR2 $T=424700 890960 1 0 $X=424700 $Y=885540
X3138 157 2 1695 48 1 NR2 $T=424700 951440 1 0 $X=424700 $Y=946020
X3139 150 2 1740 1645 1 NR2 $T=426560 971600 0 0 $X=426560 $Y=971220
X3140 157 2 1750 36 1 NR2 $T=427800 951440 1 0 $X=427800 $Y=946020
X3141 164 2 1748 1688 1 NR2 $T=429660 1042160 1 180 $X=427800 $Y=1041780
X3142 155 2 1730 42 1 NR2 $T=430280 880880 1 180 $X=428420 $Y=880500
X3143 157 2 1743 42 1 NR2 $T=429040 951440 0 0 $X=429040 $Y=951060
X3144 150 2 1742 1672 1 NR2 $T=431520 981680 0 180 $X=429660 $Y=976260
X3145 158 2 1754 42 1 NR2 $T=432140 991760 0 180 $X=430280 $Y=986340
X3146 164 2 168 1721 1 NR2 $T=433380 1042160 0 180 $X=431520 $Y=1036740
X3147 155 2 1786 47 1 NR2 $T=433380 880880 0 0 $X=433380 $Y=880500
X3148 1752 2 1791 1722 1 NR2 $T=435240 921200 1 180 $X=433380 $Y=920820
X3149 158 2 1744 36 1 NR2 $T=438340 991760 0 180 $X=436480 $Y=986340
X3150 1752 2 1811 1783 1 NR2 $T=440200 921200 1 180 $X=438340 $Y=920820
X3151 158 2 1798 47 1 NR2 $T=440200 991760 0 180 $X=438340 $Y=986340
X3152 157 2 1793 41 1 NR2 $T=440200 951440 1 0 $X=440200 $Y=946020
X3153 164 2 1819 1697 1 NR2 $T=442060 1052240 0 180 $X=440200 $Y=1046820
X3154 155 2 1797 41 1 NR2 $T=441440 880880 0 0 $X=441440 $Y=880500
X3155 1752 2 1814 1826 1 NR2 $T=442060 911120 1 0 $X=442060 $Y=905700
X3156 157 2 1815 56 1 NR2 $T=442060 951440 0 0 $X=442060 $Y=951060
X3157 158 2 1808 41 1 NR2 $T=443920 991760 0 180 $X=442060 $Y=986340
X3158 157 2 1841 55 1 NR2 $T=443300 951440 1 0 $X=443300 $Y=946020
X3159 150 2 1825 1638 1 NR2 $T=445160 981680 0 180 $X=443300 $Y=976260
X3160 158 2 1822 56 1 NR2 $T=443300 991760 0 0 $X=443300 $Y=991380
X3161 1752 2 1859 1660 1 NR2 $T=448880 921200 0 180 $X=447020 $Y=915780
X3162 158 2 1848 55 1 NR2 $T=448880 981680 1 180 $X=447020 $Y=981300
X3163 157 2 1863 52 1 NR2 $T=450120 941360 0 0 $X=450120 $Y=940980
X3164 158 2 1869 52 1 NR2 $T=450120 981680 0 0 $X=450120 $Y=981300
X3165 155 2 1827 56 1 NR2 $T=450740 890960 1 0 $X=450740 $Y=885540
X3166 157 2 1894 49 1 NR2 $T=453840 941360 0 0 $X=453840 $Y=940980
X3167 157 2 1881 40 1 NR2 $T=456940 941360 0 0 $X=456940 $Y=940980
X3168 158 2 1905 49 1 NR2 $T=458800 981680 1 180 $X=456940 $Y=981300
X3169 155 2 1892 40 1 NR2 $T=458800 880880 0 0 $X=458800 $Y=880500
X3170 157 2 1898 45 1 NR2 $T=458800 961520 1 0 $X=458800 $Y=956100
X3171 157 2 1935 39 1 NR2 $T=460660 941360 0 0 $X=460660 $Y=940980
X3172 157 2 1954 34 1 NR2 $T=463760 941360 0 0 $X=463760 $Y=940980
X3173 1939 2 1948 45 1 NR2 $T=463760 981680 1 0 $X=463760 $Y=976260
X3174 1939 2 1928 40 1 NR2 $T=466240 981680 1 180 $X=464380 $Y=981300
X3175 1939 2 1964 39 1 NR2 $T=469340 981680 1 180 $X=467480 $Y=981300
X3176 155 2 1941 39 1 NR2 $T=468720 880880 0 0 $X=468720 $Y=880500
X3177 1939 2 1984 34 1 NR2 $T=471820 981680 1 180 $X=469960 $Y=981300
X3178 155 2 1944 45 1 NR2 $T=470580 880880 0 0 $X=470580 $Y=880500
X3179 155 2 1976 34 1 NR2 $T=472440 890960 0 0 $X=472440 $Y=890580
X3180 1939 2 1999 35 1 NR2 $T=473060 981680 0 0 $X=473060 $Y=981300
X3181 157 2 1991 35 1 NR2 $T=474300 941360 0 0 $X=474300 $Y=940980
X3182 1939 2 2018 2022 1 NR2 $T=475540 981680 0 0 $X=475540 $Y=981300
X3183 155 2 1965 35 1 NR2 $T=476780 890960 0 0 $X=476780 $Y=890580
X3184 155 2 2000 2022 1 NR2 $T=477400 901040 1 0 $X=477400 $Y=895620
X3185 157 2 1967 2022 1 NR2 $T=477400 941360 0 0 $X=477400 $Y=940980
X3186 2041 2 1989 155 1 NR2 $T=481120 901040 1 180 $X=479260 $Y=900660
X3187 2041 2 2058 155 1 NR2 $T=482980 901040 0 180 $X=481120 $Y=895620
X3188 2041 2 1996 157 1 NR2 $T=484840 961520 0 180 $X=482980 $Y=956100
X3189 2041 2 1963 1939 1 NR2 $T=485460 981680 1 180 $X=483600 $Y=981300
X3190 2041 2 2025 157 1 NR2 $T=486080 951440 1 180 $X=484220 $Y=951060
X3191 2281 2 2394 2276 1 NR2 $T=561100 931280 0 180 $X=559240 $Y=925860
X3192 2354 2 2462 2429 1 NR2 $T=572880 911120 1 0 $X=572880 $Y=905700
X3193 2636 2 2625 2644 1 NR2 $T=605740 931280 0 0 $X=605740 $Y=930900
X3194 2645 2 2650 2658 1 NR2 $T=608840 911120 0 0 $X=608840 $Y=910740
X3195 2640 2 2663 2638 1 NR2 $T=610700 911120 0 0 $X=610700 $Y=910740
X3196 2662 2 2686 2679 1 NR2 $T=611940 901040 0 0 $X=611940 $Y=900660
X3197 2681 2 2673 2671 1 NR2 $T=613800 991760 0 180 $X=611940 $Y=986340
X3198 2676 2 2726 2706 1 NR2 $T=616900 941360 1 0 $X=616900 $Y=935940
X3199 2731 2 2743 2762 1 NR2 $T=624340 931280 1 0 $X=624340 $Y=925860
X3200 2739 2 2773 2777 1 NR2 $T=628060 921200 1 0 $X=628060 $Y=915780
X3201 2771 2 2786 2788 1 NR2 $T=631160 931280 0 0 $X=631160 $Y=930900
X3202 2805 2 2804 2812 1 NR2 $T=636120 921200 1 0 $X=636120 $Y=915780
X3203 2799 2 2807 2821 1 NR2 $T=637980 941360 0 0 $X=637980 $Y=940980
X3204 2827 2 2820 2798 1 NR2 $T=640460 931280 1 180 $X=638600 $Y=930900
X3205 2833 2 2842 2857 1 NR2 $T=644800 911120 1 0 $X=644800 $Y=905700
X3206 2840 2 2863 2860 1 NR2 $T=645420 941360 0 0 $X=645420 $Y=940980
X3207 2847 2 2875 2876 1 NR2 $T=648520 951440 1 0 $X=648520 $Y=946020
X3208 2883 2 2868 2841 1 NR2 $T=650380 1022000 1 180 $X=648520 $Y=1021620
X3209 2878 2 2888 2872 1 NR2 $T=651620 921200 1 180 $X=649760 $Y=920820
X3210 2818 2 2873 2864 1 NR2 $T=652240 1032080 1 180 $X=650380 $Y=1031700
X3211 2885 2 2887 2880 1 NR2 $T=651620 951440 1 0 $X=651620 $Y=946020
X3212 2916 2 2907 2925 1 NR2 $T=656580 961520 0 0 $X=656580 $Y=961140
X3213 2931 2 2936 2939 1 NR2 $T=660300 941360 1 0 $X=660300 $Y=935940
X3214 2920 2 2944 2949 1 NR2 $T=660920 911120 0 0 $X=660920 $Y=910740
X3215 2943 2 2952 2958 1 NR2 $T=662160 921200 1 0 $X=662160 $Y=915780
X3216 2867 2 2947 2896 1 NR2 $T=662780 911120 1 0 $X=662780 $Y=905700
X3217 2829 2 2981 2883 1 NR2 $T=667740 1011920 0 0 $X=667740 $Y=1011540
X3218 2974 2 3002 2968 1 NR2 $T=670840 941360 1 0 $X=670840 $Y=935940
X3219 2848 2 3008 2883 1 NR2 $T=675800 1001840 1 180 $X=673940 $Y=1001460
X3220 2995 2 3013 3019 1 NR2 $T=675800 921200 1 0 $X=675800 $Y=915780
X3221 3034 2 3003 3040 1 NR2 $T=680140 941360 0 0 $X=680140 $Y=940980
X3222 3053 2 3070 2914 1 NR2 $T=689440 951440 1 0 $X=689440 $Y=946020
X3223 3208 2 3209 340 1 NR2 $T=719820 951440 1 0 $X=719820 $Y=946020
X3224 3219 2 3213 339 1 NR2 $T=720440 941360 1 0 $X=720440 $Y=935940
X3225 3208 2 3234 339 1 NR2 $T=721680 931280 0 0 $X=721680 $Y=930900
X3226 3230 2 3222 339 1 NR2 $T=723540 941360 1 180 $X=721680 $Y=940980
X3227 3230 2 3225 340 1 NR2 $T=723540 961520 0 180 $X=721680 $Y=956100
X3228 3238 2 3250 339 1 NR2 $T=723540 931280 1 0 $X=723540 $Y=925860
X3229 3238 2 3235 340 1 NR2 $T=723540 931280 0 0 $X=723540 $Y=930900
X3230 3230 2 3246 341 1 NR2 $T=723540 951440 0 0 $X=723540 $Y=951060
X3231 3219 2 3232 340 1 NR2 $T=725400 961520 0 180 $X=723540 $Y=956100
X3232 3219 2 3251 341 1 NR2 $T=725400 951440 0 0 $X=725400 $Y=951060
X3233 344 2 345 339 1 NR2 $T=726640 880880 0 0 $X=726640 $Y=880500
X3234 3225 2 3241 3256 1 NR2 $T=726640 981680 1 0 $X=726640 $Y=976260
X3235 344 2 3283 340 1 NR2 $T=728500 890960 1 0 $X=728500 $Y=885540
X3236 3279 2 3253 3230 1 NR2 $T=730360 951440 1 180 $X=728500 $Y=951060
X3237 348 2 3269 340 1 NR2 $T=733460 921200 1 180 $X=731600 $Y=920820
X3238 348 2 3286 339 1 NR2 $T=732220 880880 0 0 $X=732220 $Y=880500
X3239 3279 2 3302 3238 1 NR2 $T=733460 931280 0 0 $X=733460 $Y=930900
X3240 3208 2 3275 341 1 NR2 $T=733460 941360 1 0 $X=733460 $Y=935940
X3241 3279 2 3310 3208 1 NR2 $T=735320 941360 1 0 $X=735320 $Y=935940
X3242 3279 2 3303 3219 1 NR2 $T=735320 951440 0 0 $X=735320 $Y=951060
X3243 3238 2 3301 341 1 NR2 $T=735940 921200 0 0 $X=735940 $Y=920820
X3244 406 2 3559 367 1 NR2 $T=798560 951440 1 0 $X=798560 $Y=946020
X3245 3543 2 3593 367 1 NR2 $T=805380 991760 0 0 $X=805380 $Y=991380
X3246 3602 2 3573 3606 1 NR2 $T=808480 961520 1 0 $X=808480 $Y=956100
X3247 3606 2 3550 419 1 NR2 $T=810960 951440 1 180 $X=809100 $Y=951060
X3248 3602 2 3587 417 1 NR2 $T=812200 971600 1 180 $X=810340 $Y=971220
X3249 417 2 3596 419 1 NR2 $T=810960 971600 1 0 $X=810960 $Y=966180
X3250 3944 2 3467 3955 1 NR2 $T=911400 981680 0 0 $X=911400 $Y=981300
X3251 3949 2 3404 3961 1 NR2 $T=911400 1042160 0 0 $X=911400 $Y=1041780
X3252 3949 2 3527 3954 1 NR2 $T=911400 1052240 1 0 $X=911400 $Y=1046820
X3253 3959 2 3530 3966 1 NR2 $T=913260 961520 1 0 $X=913260 $Y=956100
X3254 3966 2 3625 3954 1 NR2 $T=915120 1022000 1 180 $X=913260 $Y=1021620
X3255 3965 2 3604 3961 1 NR2 $T=915120 1052240 0 180 $X=913260 $Y=1046820
X3256 3965 2 478 3954 1 NR2 $T=915120 1052240 1 180 $X=913260 $Y=1051860
X3257 3949 2 3850 3959 1 NR2 $T=913880 951440 0 0 $X=913880 $Y=951060
X3258 3944 2 3747 3966 1 NR2 $T=914500 981680 1 0 $X=914500 $Y=976260
X3259 3944 2 3740 3949 1 NR2 $T=917600 971600 1 180 $X=915740 $Y=971220
X3260 3955 2 3528 3961 1 NR2 $T=915740 991760 0 0 $X=915740 $Y=991380
X3261 3944 2 3745 3965 1 NR2 $T=916360 941360 1 0 $X=916360 $Y=935940
X3262 3966 2 3668 3961 1 NR2 $T=918220 1032080 0 0 $X=918220 $Y=1031700
X3263 3955 2 3807 3954 1 NR2 $T=920700 981680 0 0 $X=920700 $Y=981300
X3264 3959 2 3646 3965 1 NR2 $T=922560 941360 0 0 $X=922560 $Y=940980
X3265 3959 2 3842 3955 1 NR2 $T=924420 941360 0 0 $X=924420 $Y=940980
X3266 3257 3260 2 3010 1 2901 AOI12HS $T=730980 1011920 0 180 $X=726640 $Y=1006500
X3267 3503 3407 2 3979 1 3958 AOI12HS $T=916360 911120 1 0 $X=916360 $Y=905700
X3268 1051 1 2 1020 DELB $T=297600 1032080 1 0 $X=297600 $Y=1026660
X3269 1494 1 2 132 DELB $T=386260 951440 1 0 $X=386260 $Y=946020
X3270 1500 1 2 1520 DELB $T=388120 931280 0 0 $X=388120 $Y=930900
X3271 1524 1 2 1554 DELB $T=391840 890960 0 0 $X=391840 $Y=890580
X3272 1504 1 2 1533 DELB $T=391840 931280 1 0 $X=391840 $Y=925860
X3273 1529 1 2 1589 DELB $T=393080 921200 1 0 $X=393080 $Y=915780
X3274 1559 1 2 1583 DELB $T=396800 890960 0 0 $X=396800 $Y=890580
X3275 1662 1 2 1685 DELB $T=416020 1011920 0 0 $X=416020 $Y=1011540
X3276 1692 1 2 1735 DELB $T=423460 880880 0 0 $X=423460 $Y=880500
X3277 1551 1 2 1700 DELB $T=424700 911120 1 0 $X=424700 $Y=905700
X3278 1499 1 2 1906 DELB $T=450740 911120 0 0 $X=450740 $Y=910740
X3279 1668 1 2 2150 DELB $T=476780 880880 0 0 $X=476780 $Y=880500
X3280 1555 1 2 2139 DELB $T=500340 911120 1 0 $X=500340 $Y=905700
X3281 1596 1 2 2154 DELB $T=503440 880880 0 0 $X=503440 $Y=880500
X3282 2163 1 2 2184 DELB $T=505300 1042160 1 0 $X=505300 $Y=1036740
X3283 200 1 2 2211 DELB $T=508400 1032080 0 0 $X=508400 $Y=1031700
X3284 2214 1 2 2226 DELB $T=515840 1011920 0 0 $X=515840 $Y=1011540
X3285 213 1 2 217 DELB $T=518940 880880 0 0 $X=518940 $Y=880500
X3286 2239 1 2 2185 DELB $T=522660 1042160 0 0 $X=522660 $Y=1041780
X3287 218 1 2 227 DELB $T=523900 880880 0 0 $X=523900 $Y=880500
X3288 2260 1 2 2292 DELB $T=531960 1062320 0 0 $X=531960 $Y=1061940
X3289 2279 1 2 2280 DELB $T=533200 991760 0 0 $X=533200 $Y=991380
X3290 2301 1 2 2330 DELB $T=540640 1022000 1 0 $X=540640 $Y=1016580
X3291 2298 1 2 2325 DELB $T=541880 1042160 0 0 $X=541880 $Y=1041780
X3292 2332 1 2 2328 DELB $T=548080 991760 0 0 $X=548080 $Y=991380
X3293 2344 1 2 2364 DELB $T=549940 971600 1 0 $X=549940 $Y=966180
X3294 2348 1 2 2304 DELB $T=550560 1022000 1 0 $X=550560 $Y=1016580
X3295 2340 1 2 2387 DELB $T=553040 941360 0 0 $X=553040 $Y=940980
X3296 2361 1 2 2357 DELB $T=553040 1052240 1 0 $X=553040 $Y=1046820
X3297 2369 1 2 2377 DELB $T=554900 971600 1 0 $X=554900 $Y=966180
X3298 2391 1 2 2416 DELB $T=559860 971600 1 0 $X=559860 $Y=966180
X3299 2366 1 2 2396 DELB $T=561100 1022000 1 0 $X=561100 $Y=1016580
X3300 2368 1 2 2386 DELB $T=561720 951440 1 0 $X=561720 $Y=946020
X3301 2389 1 2 2363 DELB $T=562340 921200 1 0 $X=562340 $Y=915780
X3302 2367 1 2 2353 DELB $T=562960 931280 0 0 $X=562960 $Y=930900
X3303 246 1 2 2401 DELB $T=562960 1052240 1 0 $X=562960 $Y=1046820
X3304 2423 1 2 2466 DELB $T=567920 921200 1 0 $X=567920 $Y=915780
X3305 2421 1 2 2440 DELB $T=567920 991760 0 0 $X=567920 $Y=991380
X3306 2381 1 2 2460 DELB $T=568540 971600 1 0 $X=568540 $Y=966180
X3307 2431 1 2 2471 DELB $T=570400 981680 0 0 $X=570400 $Y=981300
X3308 2406 1 2 2390 DELB $T=573500 921200 0 0 $X=573500 $Y=920820
X3309 2281 1 2 2434 DELB $T=573500 941360 1 0 $X=573500 $Y=935940
X3310 2457 1 2 2454 DELB $T=573500 951440 0 0 $X=573500 $Y=951060
X3311 2488 1 2 2530 DELB $T=578460 1022000 1 0 $X=578460 $Y=1016580
X3312 2505 1 2 2511 DELB $T=580940 921200 0 0 $X=580940 $Y=920820
X3313 2509 1 2 2512 DELB $T=581560 961520 0 0 $X=581560 $Y=961140
X3314 2531 1 2 2556 DELB $T=585280 931280 0 0 $X=585280 $Y=930900
X3315 2346 1 2 2356 DELB $T=586520 911120 1 0 $X=586520 $Y=905700
X3316 2545 1 2 2510 DELB $T=587140 890960 1 0 $X=587140 $Y=885540
X3317 256 1 2 2463 DELB $T=589000 1032080 1 0 $X=589000 $Y=1026660
X3318 2525 1 2 2456 DELB $T=590240 931280 0 0 $X=590240 $Y=930900
X3319 2477 1 2 2482 DELB $T=590860 951440 0 0 $X=590860 $Y=951060
X3320 2506 1 2 2528 DELB $T=592100 1032080 0 0 $X=592100 $Y=1031700
X3321 2542 1 2 2503 DELB $T=593340 890960 0 0 $X=593340 $Y=890580
X3322 2704 1 2 291 DELB $T=622480 1062320 0 0 $X=622480 $Y=1061940
X3323 2918 1 2 2954 DELB $T=657200 1011920 1 0 $X=657200 $Y=1006500
X3324 2903 1 2 2917 DELB $T=659060 981680 0 0 $X=659060 $Y=981300
X3325 2893 1 2 2912 DELB $T=660300 1042160 1 0 $X=660300 $Y=1036740
X3326 2975 1 2 2978 DELB $T=667740 1042160 1 0 $X=667740 $Y=1036740
X3327 2924 1 2 2932 DELB $T=671460 1042160 0 0 $X=671460 $Y=1041780
X3328 3006 1 2 2892 DELB $T=674560 1042160 1 0 $X=674560 $Y=1036740
X3329 3043 1 2 3000 DELB $T=685720 1032080 1 0 $X=685720 $Y=1026660
X3330 3115 1 2 3139 DELB $T=698120 1022000 1 0 $X=698120 $Y=1016580
X3331 3106 1 2 2980 DELB $T=699980 890960 1 0 $X=699980 $Y=885540
X3332 3138 1 2 3171 DELB $T=705560 1011920 1 0 $X=705560 $Y=1006500
X3333 3154 1 2 3057 DELB $T=707420 951440 1 0 $X=707420 $Y=946020
X3334 3189 1 2 3215 DELB $T=715480 911120 1 0 $X=715480 $Y=905700
X3335 3207 1 2 3233 DELB $T=718580 890960 0 0 $X=718580 $Y=890580
X3336 3157 1 2 3259 DELB $T=723540 890960 1 0 $X=723540 $Y=885540
X3337 3195 1 2 3274 DELB $T=727880 911120 0 0 $X=727880 $Y=910740
X3338 3284 1 2 3308 DELB $T=734080 890960 1 0 $X=734080 $Y=885540
X3339 3290 1 2 3311 DELB $T=734700 921200 1 0 $X=734700 $Y=915780
X3340 3314 1 2 3338 DELB $T=739660 890960 1 0 $X=739660 $Y=885540
X3341 3229 1 2 3339 DELB $T=740280 911120 0 0 $X=740280 $Y=910740
X3342 3262 1 2 3357 DELB $T=740280 941360 1 0 $X=740280 $Y=935940
X3343 3240 1 2 3343 DELB $T=740900 901040 0 0 $X=740900 $Y=900660
X3344 3228 1 2 3360 DELB $T=744000 880880 0 0 $X=744000 $Y=880500
X3345 3349 1 2 3371 DELB $T=745860 901040 0 0 $X=745860 $Y=900660
X3346 3330 1 2 3378 DELB $T=747720 911120 1 0 $X=747720 $Y=905700
X3347 3361 1 2 3380 DELB $T=748340 941360 1 0 $X=748340 $Y=935940
X3348 3316 1 2 3397 DELB $T=753920 911120 1 0 $X=753920 $Y=905700
X3349 3384 1 2 3402 DELB $T=755780 931280 0 0 $X=755780 $Y=930900
X3350 3270 1 2 3393 DELB $T=758880 911120 1 0 $X=758880 $Y=905700
X3351 372 1 2 377 DELB $T=760740 880880 0 0 $X=760740 $Y=880500
X3352 3206 1 2 3457 DELB $T=765080 890960 1 0 $X=765080 $Y=885540
X3353 3396 1 2 3458 DELB $T=765700 911120 1 0 $X=765700 $Y=905700
X3354 3367 1 2 3589 DELB $T=770660 911120 1 0 $X=770660 $Y=905700
X3355 421 1 2 426 DELB $T=812200 880880 0 0 $X=812200 $Y=880500
X3356 3820 1 2 458 DELB $T=868000 921200 0 0 $X=868000 $Y=920820
X3357 3559 3573 3443 1 2 AN2P $T=805380 961520 0 180 $X=801660 $Y=956100
X3358 3596 3543 354 1 2 AN2P $T=807860 1032080 0 180 $X=804140 $Y=1026660
X3359 3593 3550 3429 1 2 AN2P $T=807240 981680 0 0 $X=807240 $Y=981300
X3360 3593 3596 3439 1 2 AN2P $T=812820 971600 1 0 $X=812820 $Y=966180
X3361 50 2 1 891 BUF1 $T=274660 961520 1 0 $X=274660 $Y=956100
X3362 82 2 1 1120 BUF1 $T=310000 901040 1 0 $X=310000 $Y=895620
X3363 80 2 1 1181 BUF1 $T=326740 901040 1 0 $X=326740 $Y=895620
X3364 122 2 1 125 BUF1 $T=409820 1052240 1 180 $X=407340 $Y=1051860
X3365 151 2 1 1778 BUF1 $T=436480 1022000 1 0 $X=436480 $Y=1016580
X3366 122 2 1 1934 BUF1 $T=460040 1052240 0 0 $X=460040 $Y=1051860
X3367 158 2 1 1939 BUF1 $T=460660 981680 0 0 $X=460660 $Y=981300
X3368 188 2 1 1543 BUF1 $T=480500 931280 0 0 $X=480500 $Y=930900
X3369 129 2 1 1926 BUF1 $T=494140 961520 0 0 $X=494140 $Y=961140
X3370 2889 2 1 2740 BUF1 $T=652240 971600 1 0 $X=652240 $Y=966180
X3371 2901 2 1 248 BUF1 $T=655340 1011920 1 180 $X=652860 $Y=1011540
X3372 2711 2 1 2914 BUF1 $T=661540 931280 1 0 $X=661540 $Y=925860
X3373 261 2 1 290 BUF1 $T=680760 1011920 1 0 $X=680760 $Y=1006500
X3374 2701 2 1 2815 BUF1 $T=695020 941360 0 180 $X=692540 $Y=935940
X3375 366 2 1 3407 BUF1 $T=760740 890960 1 0 $X=760740 $Y=885540
X3376 369 2 1 3562 BUF1 $T=796700 890960 1 0 $X=796700 $Y=885540
X3377 52 1 2 1062 BUF1S $T=299460 931280 1 0 $X=299460 $Y=925860
X3378 241 1 2 2354 BUF1S $T=549940 911120 1 0 $X=549940 $Y=905700
X3379 244 1 2 2374 BUF1S $T=553660 880880 0 0 $X=553660 $Y=880500
X3380 2438 1 2 2473 BUF1S $T=573500 901040 0 0 $X=573500 $Y=900660
X3381 2582 1 2 2681 BUF1S $T=614420 981680 0 0 $X=614420 $Y=981300
X3382 3033 1 2 3046 BUF1S $T=680140 991760 0 0 $X=680140 $Y=991380
X3383 2959 1 2 3061 BUF1S $T=683860 890960 0 0 $X=683860 $Y=890580
X3384 3107 1 2 3080 BUF1S $T=695640 1011920 0 0 $X=695640 $Y=1011540
X3385 3143 1 2 3149 BUF1S $T=704320 981680 0 0 $X=704320 $Y=981300
X3386 3165 1 2 3118 BUF1S $T=708660 981680 0 0 $X=708660 $Y=981300
X3387 3170 1 2 3176 BUF1S $T=709900 921200 0 0 $X=709900 $Y=920820
X3388 3374 1 2 3388 BUF1S $T=753920 880880 0 0 $X=753920 $Y=880500
X3389 3319 1 2 3392 BUF1S $T=753920 901040 1 0 $X=753920 $Y=895620
X3390 3218 2 1 3374 BUF3 $T=748960 880880 0 0 $X=748960 $Y=880500
X3391 1688 1663 2 1709 164 1 OR3B2 $T=434620 1052240 0 0 $X=434620 $Y=1051860
X3392 164 1663 2 1749 1773 1 OR3B2 $T=443300 1052240 0 0 $X=443300 $Y=1051860
X3393 3015 2623 2 3028 2850 1 OR3B2 $T=680760 1052240 0 180 $X=677040 $Y=1046820
X3394 3010 3257 2 2851 3260 1 OR3B2 $T=725400 1022000 1 0 $X=725400 $Y=1016580
X3395 1659 2 1630 1491 1548 1 NR3 $T=415400 1052240 1 0 $X=415400 $Y=1046820
X3396 2989 2 2836 2922 327 1 NR3 $T=685100 1022000 1 0 $X=685100 $Y=1016580
X3397 3190 2 3225 3224 3242 1 NR3 $T=727260 1001840 0 180 $X=724160 $Y=996420
X3398 2843 2836 1 2687 2760 2829 2 OAI112HS $T=644180 1052240 0 180 $X=639840 $Y=1046820
X3399 2836 2841 1 2839 2648 2829 2 OAI112HS $T=644800 1032080 1 180 $X=640460 $Y=1031700
X3400 2836 2826 1 2623 2744 2848 2 OAI112HS $T=651000 1052240 0 180 $X=646660 $Y=1046820
X3401 2843 2836 1 2905 2844 2922 2 OAI112HS $T=652860 1052240 1 0 $X=652860 $Y=1046820
X3402 3177 2851 1 3164 3092 3140 2 OAI112HS $T=712380 1001840 1 180 $X=708040 $Y=1001460
X3403 3184 2851 1 3172 3169 3166 2 OAI112HS $T=713620 1032080 1 180 $X=709280 $Y=1031700
X3404 2851 3185 1 3180 3178 3171 2 OAI112HS $T=715480 1011920 0 180 $X=711140 $Y=1006500
X3405 3214 2851 1 3194 3175 3167 2 OAI112HS $T=719200 1022000 1 180 $X=714860 $Y=1021620
X3406 2851 3211 1 3203 3186 3139 2 OAI112HS $T=721060 1022000 0 180 $X=716720 $Y=1016580
X3407 3227 2851 1 3210 3202 3179 2 OAI112HS $T=722300 991760 1 180 $X=717960 $Y=991380
X3408 3243 2851 1 3221 3212 3217 2 OAI112HS $T=724160 1032080 1 180 $X=719820 $Y=1031700
X3409 904 852 947 2 1 940 XOR3S $T=269080 1042160 0 0 $X=269080 $Y=1041780
X3410 1517 1497 1502 2 1 1467 XOR3S $T=396800 1011920 0 180 $X=385640 $Y=1006500
X3411 2190 2218 2180 2 1 2183 XOR3S $T=520800 1011920 0 180 $X=509640 $Y=1006500
X3412 3093 3057 3119 2 1 3173 XOR3S $T=699360 931280 0 0 $X=699360 $Y=930900
X3413 3087 3056 3141 2 1 3146 XOR3S $T=716720 951440 1 180 $X=705560 $Y=951060
X3414 3183 3056 3155 2 1 3147 XOR3S $T=717340 961520 1 180 $X=706180 $Y=961140
X3415 3133 3057 3192 2 1 3159 XOR3S $T=708660 941360 0 0 $X=708660 $Y=940980
X3416 2500 2573 2 2508 2579 1 2592 FA1 $T=582800 961520 1 0 $X=582800 $Y=956100
X3417 2552 2563 2 2519 2596 1 2536 FA1 $T=601400 931280 0 180 $X=585900 $Y=925860
X3418 2543 2600 2 2519 2565 1 2621 FA1 $T=589000 941360 1 0 $X=589000 $Y=935940
X3419 273 2620 2 279 2608 1 284 FA1 $T=593960 880880 0 0 $X=593960 $Y=880500
X3420 2568 2624 2 2571 2593 1 2668 FA1 $T=594580 901040 0 0 $X=594580 $Y=900660
X3421 2587 2637 2 2580 2592 1 2661 FA1 $T=595820 981680 1 0 $X=595820 $Y=976260
X3422 2507 2669 2 2508 2630 1 2697 FA1 $T=602020 961520 1 0 $X=602020 $Y=956100
X3423 2603 2554 2 2516 2621 1 2710 FA1 $T=602640 941360 0 0 $X=602640 $Y=940980
X3424 2604 2619 2 2580 2697 1 2703 FA1 $T=602640 971600 1 0 $X=602640 $Y=966180
X3425 278 2613 2 279 2699 1 2727 FA1 $T=604500 890960 1 0 $X=604500 $Y=885540
X3426 2612 2677 2 2547 2710 1 2630 FA1 $T=623100 951440 0 180 $X=607600 $Y=946020
X3427 2610 2651 2 2574 2668 1 2699 FA1 $T=610700 901040 1 0 $X=610700 $Y=895620
X3428 283 2738 2 285 2727 1 2763 FA1 $T=612560 880880 0 0 $X=612560 $Y=880500
X3429 2682 2748 2 2678 2695 1 2787 FA1 $T=614420 1001840 1 0 $X=614420 $Y=996420
X3430 2692 2756 2 2768 2661 1 2781 FA1 $T=615660 981680 1 0 $X=615660 $Y=976260
X3431 2698 2741 2 2665 2781 1 2695 FA1 $T=633020 991760 0 180 $X=617520 $Y=986340
X3432 289 295 2 287 2763 1 2801 FA1 $T=623100 890960 0 0 $X=623100 $Y=890580
X3433 2742 2792 2 2752 2787 1 2859 FA1 $T=623100 1011920 1 0 $X=623100 $Y=1006500
X3434 2725 2817 2 2768 2703 1 2830 FA1 $T=629920 971600 1 0 $X=629920 $Y=966180
X3435 2772 2838 2 2752 2865 1 2882 FA1 $T=632400 1011920 0 0 $X=632400 $Y=1011540
X3436 294 299 2 296 2801 1 300 FA1 $T=633020 880880 0 0 $X=633020 $Y=880500
X3437 2688 2794 2 2678 2802 1 2865 FA1 $T=633020 991760 1 0 $X=633020 $Y=986340
X3438 2852 2909 2 2886 2859 1 2935 FA1 $T=645420 1001840 0 0 $X=645420 $Y=1001460
X3439 2862 2927 2 2929 2935 1 2972 FA1 $T=649140 991760 0 0 $X=649140 $Y=991380
X3440 2934 2990 2 2976 2940 1 3025 FA1 $T=660300 971600 1 0 $X=660300 $Y=966180
X3441 2894 2993 2 2886 2882 1 3030 FA1 $T=664020 1001840 1 0 $X=664020 $Y=996420
X3442 312 316 2 311 319 1 3049 FA1 $T=664640 880880 0 0 $X=664640 $Y=880500
X3443 2964 3007 2 2959 321 1 3038 FA1 $T=665260 890960 0 0 $X=665260 $Y=890580
X3444 2879 2953 2 2929 3030 1 2969 FA1 $T=681380 991760 0 180 $X=665880 $Y=986340
X3445 2965 3014 2 2976 2926 1 3054 FA1 $T=667740 981680 0 0 $X=667740 $Y=981300
X3446 3116 3182 2 2980 3064 1 3168 FA1 $T=703080 890960 0 0 $X=703080 $Y=890580
X3447 3112 3130 2 2996 3144 1 3198 FA1 $T=703080 911120 0 0 $X=703080 $Y=910740
X3448 740 658 745 2 1 XNR2HS $T=240560 1011920 0 0 $X=240560 $Y=1011540
X3449 1142 1112 1118 2 1 XNR2HS $T=317440 1042160 1 180 $X=311860 $Y=1041780
X3450 1178 1175 1134 2 1 XNR2HS $T=321160 890960 0 180 $X=315580 $Y=885540
X3451 1190 1158 1159 2 1 XNR2HS $T=320540 1032080 1 0 $X=320540 $Y=1026660
X3452 1531 1532 1518 2 1 XNR2HS $T=394940 1062320 0 180 $X=389360 $Y=1056900
X3453 1557 1565 1575 2 1 XNR2HS $T=396180 981680 1 0 $X=396180 $Y=976260
X3454 1595 1491 1481 2 1 XNR2HS $T=405480 1052240 0 180 $X=399900 $Y=1046820
X3455 1571 1552 1581 2 1 XNR2HS $T=403620 921200 1 0 $X=403620 $Y=915780
X3456 1657 1624 1639 2 1 XNR2HS $T=416020 991760 0 180 $X=410440 $Y=986340
X3457 1640 1644 1655 2 1 XNR2HS $T=411060 931280 0 0 $X=411060 $Y=930900
X3458 1703 1717 1713 2 1 XNR2HS $T=428420 941360 0 180 $X=422840 $Y=935940
X3459 2539 2518 2517 2 1 XNR2HS $T=585280 911120 0 0 $X=585280 $Y=910740
X3460 2594 2556 2570 2 1 XNR2HS $T=603260 911120 0 0 $X=603260 $Y=910740
X3461 2655 282 2675 2 1 XNR2HS $T=608840 1062320 0 0 $X=608840 $Y=1061940
X3462 3080 3078 3067 2 1 XNR2HS $T=691920 1011920 1 180 $X=686340 $Y=1011540
X3463 3031 3075 3101 2 1 XNR2HS $T=691920 1022000 1 0 $X=691920 $Y=1016580
X3464 3031 3098 3122 2 1 XNR2HS $T=695640 1011920 1 0 $X=695640 $Y=1006500
X3465 1066 1070 2 1 1083 OR2 $T=303180 951440 0 0 $X=303180 $Y=951060
X3466 90 88 2 1 1105 OR2 $T=321160 1001840 0 180 $X=318680 $Y=996420
X3467 161 164 2 1 1613 OR2 $T=429660 1042160 0 180 $X=427180 $Y=1036740
X3468 2941 2928 2 1 3034 OR2 $T=675180 931280 0 0 $X=675180 $Y=930900
X3469 3080 3078 2 1 3075 OR2 $T=691300 1022000 0 180 $X=688820 $Y=1016580
X3470 1438 75 1 113 75 1282 2 MOAI1S $T=370140 1022000 1 180 $X=366420 $Y=1021620
X3471 162 116 1 163 116 166 2 MOAI1S $T=426560 1062320 0 0 $X=426560 $Y=1061940
X3472 2614 2519 1 2623 2632 2638 2 MOAI1S $T=602640 931280 1 0 $X=602640 $Y=925860
X3473 2614 2571 1 2623 2617 2644 2 MOAI1S $T=611320 931280 1 180 $X=607600 $Y=930900
X3474 2711 2547 1 2687 2632 2658 2 MOAI1S $T=617520 911120 0 180 $X=613800 $Y=905700
X3475 2711 279 1 2687 2617 2706 2 MOAI1S $T=621240 921200 1 180 $X=617520 $Y=920820
X3476 2711 2508 1 2687 2721 2679 2 MOAI1S $T=623100 911120 0 180 $X=619380 $Y=905700
X3477 2711 285 1 2687 2694 2762 2 MOAI1S $T=631160 931280 0 180 $X=627440 $Y=925860
X3478 2711 2580 1 2687 2793 2777 2 MOAI1S $T=631160 921200 1 0 $X=631160 $Y=915780
X3479 2711 287 1 2687 2800 2788 2 MOAI1S $T=633020 931280 1 0 $X=633020 $Y=925860
X3480 2711 296 1 2687 2735 2798 2 MOAI1S $T=638600 931280 1 180 $X=634880 $Y=930900
X3481 2711 2768 1 2687 2767 2812 2 MOAI1S $T=642320 921200 0 180 $X=638600 $Y=915780
X3482 2711 286 1 2687 2724 2821 2 MOAI1S $T=646040 931280 1 180 $X=642320 $Y=930900
X3483 2711 2665 1 2687 2705 2857 2 MOAI1S $T=642940 921200 1 0 $X=642940 $Y=915780
X3484 2711 288 1 2687 2737 2860 2 MOAI1S $T=643560 941360 1 0 $X=643560 $Y=935940
X3485 2711 301 1 2687 2728 2876 2 MOAI1S $T=647280 931280 0 0 $X=647280 $Y=930900
X3486 2711 2886 1 2734 2687 2872 2 MOAI1S $T=652860 931280 0 180 $X=649140 $Y=925860
X3487 2711 304 1 2687 2736 2880 2 MOAI1S $T=654100 941360 0 180 $X=650380 $Y=935940
X3488 2914 2678 1 2687 2720 2896 2 MOAI1S $T=657200 921200 0 180 $X=653480 $Y=915780
X3489 2826 2892 1 2841 2912 2924 2 MOAI1S $T=653480 1042160 1 0 $X=653480 $Y=1036740
X3490 2646 301 1 2719 2898 2931 2 MOAI1S $T=656580 941360 1 0 $X=656580 $Y=935940
X3491 2646 2752 1 2719 2890 2943 2 MOAI1S $T=657820 921200 1 0 $X=657820 $Y=915780
X3492 2892 2660 1 2938 2836 2918 2 MOAI1S $T=659060 1022000 1 0 $X=659060 $Y=1016580
X3493 2914 311 1 2687 2751 2939 2 MOAI1S $T=664640 931280 1 180 $X=660920 $Y=930900
X3494 2914 2959 1 2687 2769 2968 2 MOAI1S $T=663400 941360 1 0 $X=663400 $Y=935940
X3495 2914 2929 1 2687 2750 2958 2 MOAI1S $T=667740 921200 0 180 $X=664020 $Y=915780
X3496 2752 2711 1 2687 2764 2949 2 MOAI1S $T=668980 911120 0 180 $X=665260 $Y=905700
X3497 2656 2977 1 2815 2751 2974 2 MOAI1S $T=670840 941360 0 180 $X=667120 $Y=935940
X3498 2994 2656 1 2815 2750 2995 2 MOAI1S $T=675800 921200 1 180 $X=672080 $Y=920820
X3499 2917 2914 1 2783 2687 3019 2 MOAI1S $T=682620 921200 0 180 $X=678900 $Y=915780
X3500 3057 3072 1 2815 2898 3087 2 MOAI1S $T=688200 941360 1 0 $X=688200 $Y=935940
X3501 3056 3072 1 2815 2890 3093 2 MOAI1S $T=688820 921200 0 0 $X=688820 $Y=920820
X3502 2734 2719 1 2712 2705 2 2701 2662 2632 OAI222S $T=621860 921200 0 180 $X=616280 $Y=915780
X3503 2719 2736 1 2712 2724 2 2701 2731 2617 OAI222S $T=624340 931280 0 180 $X=618760 $Y=925860
X3504 2719 2750 1 2712 2720 2 2701 2739 2721 OAI222S $T=627440 921200 1 180 $X=621860 $Y=920820
X3505 2719 2751 1 2712 2737 2 2701 2771 2694 OAI222S $T=630540 931280 1 180 $X=624960 $Y=930900
X3506 2719 2774 1 2712 2736 2 2701 2799 2735 OAI222S $T=637360 941360 1 180 $X=631780 $Y=940980
X3507 2719 2783 1 2712 2764 2 2815 2805 2793 OAI222S $T=634880 911120 0 0 $X=634880 $Y=910740
X3508 2719 2769 1 2712 2728 2 2701 2827 2800 OAI222S $T=643560 941360 0 180 $X=637980 $Y=935940
X3509 2719 2780 1 2712 2751 2 2701 2840 2724 OAI222S $T=645420 941360 1 180 $X=639840 $Y=940980
X3510 2796 2719 1 2712 2734 2 2815 2833 2767 OAI222S $T=646040 911120 1 180 $X=640460 $Y=910740
X3511 2719 2822 1 2712 2769 2 2701 2847 2737 OAI222S $T=648520 951440 1 180 $X=642940 $Y=951060
X3512 2831 2719 1 2712 2750 2 2815 2867 2705 OAI222S $T=652860 911120 1 180 $X=647280 $Y=910740
X3513 2874 2719 1 2796 2712 2 2815 2878 2764 OAI222S $T=652860 921200 0 180 $X=647280 $Y=915780
X3514 2719 2849 1 2712 2774 2 2701 2885 2728 OAI222S $T=654100 941360 1 180 $X=648520 $Y=940980
X3515 2835 2719 1 2712 2783 2 2815 2920 2720 OAI222S $T=660300 911120 1 180 $X=654720 $Y=910740
X3516 2687 2898 1 3070 2915 2 2701 3062 2849 OAI222S $T=691300 961520 0 180 $X=685720 $Y=956100
X3517 2890 2687 1 3070 2911 2 2874 3083 2815 OAI222S $T=694400 911120 1 180 $X=688820 $Y=910740
X3518 724 2 718 1 698 NR2P $T=238080 1001840 1 0 $X=238080 $Y=996420
X3519 724 2 736 1 733 NR2P $T=239940 991760 0 0 $X=239940 $Y=991380
X3520 724 2 717 1 752 NR2P $T=242420 1001840 1 0 $X=242420 $Y=996420
X3521 724 2 757 1 762 NR2P $T=245520 991760 0 0 $X=245520 $Y=991380
X3522 794 2 800 1 781 NR2P $T=252340 981680 0 180 $X=248620 $Y=976260
X3523 794 2 834 1 771 NR2P $T=254200 971600 0 0 $X=254200 $Y=971220
X3524 46 2 43 1 867 NR2P $T=264120 961520 0 180 $X=260400 $Y=956100
X3525 1105 2 1126 1 1124 NR2P $T=316200 1011920 0 180 $X=312480 $Y=1006500
X3526 1185 2 1112 1 1168 NR2P $T=321780 1042160 1 180 $X=318060 $Y=1041780
X3527 1105 2 1189 1 1148 NR2P $T=318680 1001840 0 0 $X=318680 $Y=1001460
X3528 1105 2 1245 1 1158 NR2P $T=324880 1011920 1 180 $X=321160 $Y=1011540
X3529 1653 2 1645 1 1549 NR2P $T=412300 971600 1 0 $X=412300 $Y=966180
X3530 1651 2 1666 1 1617 NR2P $T=414160 911120 0 0 $X=414160 $Y=910740
X3531 1613 2 1688 1 1659 NR2P $T=417880 1032080 0 0 $X=417880 $Y=1031700
X3532 1613 2 1697 1 1491 NR2P $T=419120 1042160 0 0 $X=419120 $Y=1041780
X3533 1651 2 1722 1 1648 NR2P $T=425940 921200 0 180 $X=422220 $Y=915780
X3534 158 2 43 1 1708 NR2P $T=422840 991760 1 0 $X=422840 $Y=986340
X3535 1613 2 1721 1 1630 NR2P $T=422840 1042160 1 0 $X=422840 $Y=1036740
X3536 158 2 48 1 1727 NR2P $T=430280 991760 0 180 $X=426560 $Y=986340
X3537 157 2 47 1 1770 NR2P $T=438340 941360 0 180 $X=434620 $Y=935940
X3538 2843 2 2871 1 2826 NR2P $T=648520 1042160 1 180 $X=644800 $Y=1041780
X3539 2850 2 2883 1 2941 NR2P $T=660920 1011920 0 0 $X=660920 $Y=1011540
X3540 2989 2 3031 1 262 NR2P $T=677040 1022000 1 0 $X=677040 $Y=1016580
X3541 2989 2 3031 1 260 NR2P $T=682000 1011920 0 0 $X=682000 $Y=1011540
X3542 3008 2656 1 2 BUF2 $T=677040 1011920 1 0 $X=677040 $Y=1006500
X3543 3051 2765 1 2 BUF2 $T=683860 961520 0 180 $X=680760 $Y=956100
X3544 2740 2734 2705 2723 2720 2717 2 1 2653 OA222S $T=623720 901040 1 180 $X=618140 $Y=900660
X3545 2751 2740 2737 2723 2728 2717 2 1 2715 OA222S $T=624960 941360 1 180 $X=619380 $Y=940980
X3546 2736 2740 2724 2723 2737 2717 2 1 2722 OA222S $T=626820 941360 0 180 $X=621240 $Y=935940
X3547 2740 2750 2720 2723 2764 2717 2 1 2691 OA222S $T=629920 901040 1 180 $X=624340 $Y=900660
X3548 2769 2740 2728 2723 2736 2717 2 1 2747 OA222S $T=629920 961520 0 180 $X=624340 $Y=956100
X3549 2735 2765 2774 2755 2769 2745 2 1 2754 OA222S $T=631160 941360 1 180 $X=625580 $Y=940980
X3550 2793 2765 2755 2783 2745 2750 2 1 2672 OA222S $T=634260 911120 1 180 $X=628680 $Y=910740
X3551 2724 2765 2780 2755 2774 2745 2 1 2778 OA222S $T=634880 951440 1 180 $X=629300 $Y=951060
X3552 2740 2783 2764 2723 2734 2717 2 1 2776 OA222S $T=635500 901040 0 180 $X=629920 $Y=895620
X3553 2780 2740 2751 2723 2769 2717 2 1 2810 OA222S $T=630540 961520 0 0 $X=630540 $Y=961140
X3554 2767 2765 2755 2796 2745 2783 2 1 2696 OA222S $T=637360 911120 0 180 $X=631780 $Y=905700
X3555 2800 2765 2769 2755 2751 2745 2 1 2713 OA222S $T=637980 941360 0 180 $X=632400 $Y=935940
X3556 2774 2740 2736 2723 2751 2717 2 1 2823 OA222S $T=632400 961520 1 0 $X=632400 $Y=956100
X3557 2740 2796 2734 2723 2750 2717 2 1 2803 OA222S $T=641700 901040 0 180 $X=636120 $Y=895620
X3558 2737 2765 2822 2755 2780 2745 2 1 2806 OA222S $T=641700 951440 1 180 $X=636120 $Y=951060
X3559 2705 2765 2755 2831 2745 2796 2 1 2814 OA222S $T=644180 911120 0 180 $X=638600 $Y=905700
X3560 2720 2765 2755 2835 2745 2831 2 1 2813 OA222S $T=645420 901040 1 180 $X=639840 $Y=900660
X3561 2822 2740 2769 2723 2774 2717 2 1 2855 OA222S $T=639840 961520 0 0 $X=639840 $Y=961140
X3562 2728 2765 2849 2755 2822 2745 2 1 2816 OA222S $T=646660 961520 0 180 $X=641080 $Y=956100
X3563 2740 2831 2750 2723 2783 2717 2 1 2837 OA222S $T=649140 901040 0 180 $X=643560 $Y=895620
X3564 2849 2740 2774 2723 2780 2717 2 1 2899 OA222S $T=646040 961520 0 0 $X=646040 $Y=961140
X3565 2764 2765 2755 2874 2745 2835 2 1 2845 OA222S $T=652240 901040 1 180 $X=646660 $Y=900660
X3566 2740 2835 2783 2723 2796 2717 2 1 2895 OA222S $T=647900 890960 0 0 $X=647900 $Y=890580
X3567 2734 2765 2755 2890 2745 2874 2 1 2913 OA222S $T=649760 911120 1 0 $X=649760 $Y=905700
X3568 2740 2874 2796 2723 2831 2717 2 1 2956 OA222S $T=651620 901040 1 0 $X=651620 $Y=895620
X3569 2736 2765 2898 2755 2849 2745 2 1 2881 OA222S $T=651620 961520 1 0 $X=651620 $Y=956100
X3570 2717 2835 2911 2907 2831 2723 2 1 2891 OA222S $T=658440 931280 0 180 $X=652860 $Y=925860
X3571 2822 2717 2915 2907 2780 2723 2 1 2884 OA222S $T=659060 951440 1 180 $X=653480 $Y=951060
X3572 2874 2717 2911 2921 2835 2723 2 1 2961 OA222S $T=655340 921200 0 0 $X=655340 $Y=920820
X3573 2750 2765 2755 2911 2745 2890 2 1 2948 OA222S $T=655960 911120 1 0 $X=655960 $Y=905700
X3574 2751 2765 2915 2755 2898 2745 2 1 2908 OA222S $T=663400 961520 0 180 $X=657820 $Y=956100
X3575 2849 2717 2915 2921 2822 2723 2 1 2950 OA222S $T=659680 951440 0 0 $X=659680 $Y=951060
X3576 2774 2687 2769 2701 2780 2623 2 1 2987 OA222S $T=664020 961520 1 0 $X=664020 $Y=956100
X3577 2890 2712 2911 3003 2765 2874 2 1 3012 OA222S $T=671460 931280 1 0 $X=671460 $Y=925860
X3578 2780 2701 2915 3016 2898 2765 2 1 3027 OA222S $T=673940 961520 1 0 $X=673940 $Y=956100
X3579 2898 2712 2915 3003 2849 2765 2 1 2998 OA222S $T=680140 951440 1 180 $X=674560 $Y=951060
X3580 2687 2796 2783 2815 2623 2831 2 1 3036 OA222S $T=675800 911120 0 0 $X=675800 $Y=910740
X3581 2815 2831 2911 3016 2890 2765 2 1 3060 OA222S $T=679520 921200 0 0 $X=679520 $Y=920820
X3582 1590 113 1 1607 2 1611 OAI12HS $T=404240 890960 0 0 $X=404240 $Y=890580
X3583 2843 2841 1 2892 2 2902 OAI12HS $T=652860 1032080 1 0 $X=652860 $Y=1026660
X3584 2922 2836 1 2892 2 3020 OAI12HS $T=679520 1022000 1 180 $X=675800 $Y=1021620
X3585 2818 2905 2871 2864 2 3001 1 AOI13HS $T=670840 1032080 1 0 $X=670840 $Y=1026660
X3586 2883 1 2841 2889 2873 2 ND3S $T=654100 1022000 0 180 $X=651620 $Y=1016580
X3587 2871 1 2873 2755 2883 2 ND3S $T=651620 1022000 0 0 $X=651620 $Y=1021620
X3588 2933 1 2687 2960 2623 2 ND3S $T=661540 1052240 1 0 $X=661540 $Y=1046820
X3589 2905 1 2687 2986 2829 2 ND3S $T=670220 1052240 1 0 $X=670220 $Y=1046820
X3590 2728 2740 2735 2723 2724 2717 1 2 2633 OA222 $T=624340 961520 0 180 $X=618760 $Y=956100
X3591 2721 2765 2755 2750 2745 2734 1 2 2700 OA222 $T=628060 911120 1 180 $X=622480 $Y=910740
X3592 2764 2740 2767 2723 2705 2717 1 2 2680 OA222 $T=629920 911120 0 180 $X=624340 $Y=905700
X3593 2694 2765 2751 2755 2736 2745 1 2 2647 OA222 $T=632400 941360 0 180 $X=626820 $Y=935940
X3594 2780 2687 2774 2701 2822 2623 1 2 2982 OA222 $T=663400 961520 0 0 $X=663400 $Y=961140
X3595 2687 2831 2815 2796 2623 2835 1 2 3004 OA222 $T=669600 911120 0 0 $X=669600 $Y=910740
X3596 2989 2818 2902 2 1 2938 OA12S $T=670840 1022000 0 180 $X=667120 $Y=1016580
X3597 2848 2623 2850 2 1 2839 AN3 $T=646660 1042160 0 180 $X=642940 $Y=1036740
X3598 2841 2836 2873 2 1 2646 AN3 $T=646660 1022000 1 0 $X=646660 $Y=1016580
X3599 2873 2836 2871 2 1 2869 AN3 $T=652240 1032080 0 0 $X=652240 $Y=1031700
X3600 2883 2910 2826 2 1 2916 AN3 $T=654720 1022000 1 0 $X=654720 $Y=1016580
X3601 2836 2871 2864 2850 1 2 2933 OA13S $T=652240 1042160 0 0 $X=652240 $Y=1041780
X3602 2665 2660 2656 2508 2556 2646 1 2 2640 AO222S $T=612560 921200 0 180 $X=606360 $Y=915780
X3603 286 2660 2656 285 2518 2646 1 2 2636 AO222S $T=614420 931280 0 180 $X=608220 $Y=925860
X3604 2660 2678 2580 2656 2646 2519 1 2 2645 AO222S $T=615040 921200 1 180 $X=608840 $Y=920820
X3605 2660 288 287 2656 2646 2571 1 2 2676 AO222S $T=618760 931280 1 180 $X=612560 $Y=930900
X3606 657 666 2 1 638 640 MUX2 $T=230640 981680 1 180 $X=226300 $Y=981300
X3607 665 666 2 1 637 642 MUX2 $T=231260 971600 1 180 $X=226920 $Y=971220
X3608 667 669 2 1 709 702 MUX2 $T=231260 951440 0 0 $X=231260 $Y=951060
X3609 652 669 2 1 694 681 MUX2 $T=231880 951440 1 0 $X=231880 $Y=946020
X3610 707 666 2 1 641 676 MUX2 $T=236220 961520 1 180 $X=231880 $Y=961140
X3611 710 666 2 1 651 678 MUX2 $T=236220 981680 1 180 $X=231880 $Y=981300
X3612 700 669 2 1 659 682 MUX2 $T=236840 890960 1 180 $X=232500 $Y=890580
X3613 676 686 2 1 14 713 MUX2 $T=233120 901040 0 0 $X=233120 $Y=900660
X3614 687 686 2 1 12 682 MUX2 $T=238700 880880 1 180 $X=234360 $Y=880500
X3615 723 669 2 1 665 697 MUX2 $T=238700 971600 0 180 $X=234360 $Y=966180
X3616 727 666 2 1 680 694 MUX2 $T=238700 981680 0 180 $X=234360 $Y=976260
X3617 734 669 2 1 713 660 MUX2 $T=241180 901040 0 180 $X=236840 $Y=895620
X3618 743 669 2 1 649 682 MUX2 $T=242420 890960 1 180 $X=238080 $Y=890580
X3619 728 669 2 1 719 714 MUX2 $T=242420 931280 1 180 $X=238080 $Y=930900
X3620 716 17 2 1 702 720 MUX2 $T=242420 941360 0 180 $X=238080 $Y=935940
X3621 697 669 2 1 737 744 MUX2 $T=238080 951440 1 0 $X=238080 $Y=946020
X3622 732 17 2 1 697 716 MUX2 $T=242420 951440 1 180 $X=238080 $Y=951060
X3623 661 686 2 1 18 660 MUX2 $T=238700 890960 1 0 $X=238700 $Y=885540
X3624 753 669 2 1 707 728 MUX2 $T=243660 961520 1 180 $X=239320 $Y=961140
X3625 729 666 2 1 740 737 MUX2 $T=239320 991760 1 0 $X=239320 $Y=986340
X3626 742 17 2 1 667 732 MUX2 $T=244280 961520 0 180 $X=239940 $Y=956100
X3627 756 666 2 1 725 719 MUX2 $T=244280 971600 1 180 $X=239940 $Y=971220
X3628 711 686 2 1 20 682 MUX2 $T=241800 880880 0 0 $X=241800 $Y=880500
X3629 758 17 2 1 726 749 MUX2 $T=248000 921200 1 180 $X=243660 $Y=920820
X3630 720 17 2 1 744 750 MUX2 $T=248000 931280 1 180 $X=243660 $Y=930900
X3631 755 17 2 1 728 751 MUX2 $T=248000 951440 0 180 $X=243660 $Y=946020
X3632 725 5 2 1 773 712 MUX2 $T=243660 1001840 0 0 $X=243660 $Y=1001460
X3633 783 17 2 1 652 755 MUX2 $T=248620 951440 1 180 $X=244280 $Y=951060
X3634 704 686 2 1 22 660 MUX2 $T=244900 890960 1 0 $X=244900 $Y=885540
X3635 759 17 2 1 753 783 MUX2 $T=245520 961520 0 0 $X=245520 $Y=961140
X3636 751 17 2 1 681 792 MUX2 $T=246140 941360 0 0 $X=246140 $Y=940980
X3637 772 17 2 1 705 741 MUX2 $T=251720 911120 1 180 $X=247380 $Y=910740
X3638 814 17 2 1 646 787 MUX2 $T=253580 921200 1 180 $X=249240 $Y=920820
X3639 818 29 2 1 787 816 MUX2 $T=257300 911120 1 180 $X=252960 $Y=910740
X3640 827 29 2 1 758 818 MUX2 $T=257920 921200 0 180 $X=253580 $Y=915780
X3641 829 29 2 1 814 827 MUX2 $T=259160 921200 1 180 $X=254820 $Y=920820
X3642 823 29 2 1 750 829 MUX2 $T=259780 931280 1 180 $X=255440 $Y=930900
X3643 849 29 2 1 792 823 MUX2 $T=259780 941360 0 180 $X=255440 $Y=935940
X3644 810 29 2 1 751 797 MUX2 $T=260400 941360 1 180 $X=256060 $Y=940980
X3645 848 871 2 1 828 846 MUX2 $T=264740 890960 1 180 $X=260400 $Y=890580
X3646 861 874 2 1 893 886 MUX2 $T=264120 981680 0 0 $X=264120 $Y=981300
X3647 860 871 2 1 57 846 MUX2 $T=264740 890960 1 0 $X=264740 $Y=885540
X3648 851 872 2 1 906 846 MUX2 $T=265980 890960 0 0 $X=265980 $Y=890580
X3649 867 53 2 1 881 895 MUX2 $T=265980 961520 1 0 $X=265980 $Y=956100
X3650 895 53 2 1 915 924 MUX2 $T=268460 951440 0 0 $X=268460 $Y=951060
X3651 898 872 2 1 926 918 MUX2 $T=268460 971600 1 0 $X=268460 $Y=966180
X3652 875 871 2 1 59 906 MUX2 $T=274040 890960 0 180 $X=269700 $Y=885540
X3653 935 53 2 1 902 907 MUX2 $T=276520 921200 1 180 $X=272180 $Y=920820
X3654 903 50 2 1 918 936 MUX2 $T=272180 951440 1 0 $X=272180 $Y=946020
X3655 918 872 2 1 932 912 MUX2 $T=272800 941360 0 0 $X=272800 $Y=940980
X3656 926 874 2 1 946 875 MUX2 $T=274040 971600 0 0 $X=274040 $Y=971220
X3657 920 874 2 1 948 932 MUX2 $T=274040 981680 0 0 $X=274040 $Y=981300
X3658 881 891 2 1 959 950 MUX2 $T=276520 961520 0 0 $X=276520 $Y=961140
X3659 924 53 2 1 950 963 MUX2 $T=277140 951440 0 0 $X=277140 $Y=951060
X3660 973 871 2 1 65 944 MUX2 $T=282100 890960 0 180 $X=277760 $Y=885540
X3661 936 50 2 1 896 949 MUX2 $T=283340 941360 1 180 $X=279000 $Y=940980
X3662 950 50 2 1 976 977 MUX2 $T=279000 961520 1 0 $X=279000 $Y=956100
X3663 968 871 2 1 51 944 MUX2 $T=283960 880880 1 180 $X=279620 $Y=880500
X3664 954 872 2 1 882 976 MUX2 $T=279620 971600 1 0 $X=279620 $Y=966180
X3665 956 872 2 1 990 944 MUX2 $T=280240 890960 0 0 $X=280240 $Y=890580
X3666 959 872 2 1 951 982 MUX2 $T=282720 961520 0 0 $X=282720 $Y=961140
X3667 991 874 2 1 957 969 MUX2 $T=287680 981680 1 180 $X=283340 $Y=981300
X3668 882 874 2 1 1004 966 MUX2 $T=285200 971600 1 0 $X=285200 $Y=966180
X3669 974 874 2 1 1005 997 MUX2 $T=285200 971600 0 0 $X=285200 $Y=971220
X3670 976 872 2 1 969 992 MUX2 $T=285820 961520 1 0 $X=285820 $Y=956100
X3671 979 872 2 1 1017 944 MUX2 $T=287060 911120 1 0 $X=287060 $Y=905700
X3672 977 50 2 1 982 1021 MUX2 $T=288300 951440 0 0 $X=288300 $Y=951060
X3673 1030 53 2 1 1001 988 MUX2 $T=293880 931280 0 180 $X=289540 $Y=925860
X3674 951 874 2 1 1022 973 MUX2 $T=289540 961520 0 0 $X=289540 $Y=961140
X3675 1008 53 2 1 936 1023 MUX2 $T=296980 951440 0 180 $X=292640 $Y=946020
X3676 1034 53 2 1 949 1030 MUX2 $T=295120 931280 1 0 $X=295120 $Y=925860
X3677 1152 83 2 1 1179 1144 MUX2 $T=316200 931280 0 0 $X=316200 $Y=930900
X3678 1131 83 2 1 1177 1193 MUX2 $T=316820 981680 0 0 $X=316820 $Y=981300
X3679 1169 83 2 1 1201 1156 MUX2 $T=318680 941360 0 0 $X=318680 $Y=940980
X3680 1166 83 2 1 1197 1169 MUX2 $T=319300 951440 0 0 $X=319300 $Y=951060
X3681 1177 87 2 1 1108 1195 MUX2 $T=319300 991760 1 0 $X=319300 $Y=986340
X3682 1204 90 2 1 1167 1155 MUX2 $T=324880 901040 1 180 $X=320540 $Y=900660
X3683 1176 87 2 1 1209 1170 MUX2 $T=320540 921200 1 0 $X=320540 $Y=915780
X3684 1195 87 2 1 1222 1138 MUX2 $T=322400 971600 1 0 $X=322400 $Y=966180
X3685 1151 87 2 1 1241 1234 MUX2 $T=324880 991760 1 0 $X=324880 $Y=986340
X3686 1193 83 2 1 1234 1198 MUX2 $T=326120 981680 0 0 $X=326120 $Y=981300
X3687 1214 90 2 1 1235 1248 MUX2 $T=326120 1001840 1 0 $X=326120 $Y=996420
X3688 1223 88 2 1 1252 1206 MUX2 $T=326740 921200 0 0 $X=326740 $Y=920820
X3689 1161 87 2 1 1244 1207 MUX2 $T=326740 971600 0 0 $X=326740 $Y=971220
X3690 1221 90 2 1 1194 1206 MUX2 $T=332320 911120 0 180 $X=327980 $Y=905700
X3691 1207 87 2 1 1258 1197 MUX2 $T=327980 961520 1 0 $X=327980 $Y=956100
X3692 1138 87 2 1 1253 1237 MUX2 $T=327980 961520 0 0 $X=327980 $Y=961140
X3693 1222 88 2 1 1248 1260 MUX2 $T=327980 971600 1 0 $X=327980 $Y=966180
X3694 1216 88 2 1 1264 1155 MUX2 $T=330460 911120 0 0 $X=330460 $Y=910740
X3695 1277 90 2 1 1251 1155 MUX2 $T=337280 911120 0 180 $X=332940 $Y=905700
X3696 1234 87 2 1 1284 1161 MUX2 $T=332940 971600 0 0 $X=332940 $Y=971220
X3697 1244 88 2 1 1289 1259 MUX2 $T=334180 961520 0 0 $X=334180 $Y=961140
X3698 1284 88 2 1 1265 1258 MUX2 $T=338520 971600 0 180 $X=334180 $Y=966180
X3699 1262 88 2 1 1218 1284 MUX2 $T=334800 991760 1 0 $X=334800 $Y=986340
X3700 1266 90 2 1 1298 1289 MUX2 $T=335420 1001840 1 0 $X=335420 $Y=996420
X3701 1278 90 2 1 1296 1264 MUX2 $T=336660 911120 0 0 $X=336660 $Y=910740
X3702 1272 90 2 1 1268 1265 MUX2 $T=341000 991760 1 180 $X=336660 $Y=991380
X3703 1287 90 2 1 1300 1206 MUX2 $T=337900 911120 1 0 $X=337900 $Y=905700
X3704 1271 90 2 1 1302 1287 MUX2 $T=337900 941360 0 0 $X=337900 $Y=940980
X3705 1108 88 2 1 1271 1253 MUX2 $T=342860 981680 0 180 $X=338520 $Y=976260
X3706 1226 88 2 1 1314 1206 MUX2 $T=339140 931280 0 0 $X=339140 $Y=930900
X3707 1218 90 2 1 1311 1288 MUX2 $T=339760 971600 0 0 $X=339760 $Y=971220
X3708 1257 90 2 1 1345 1278 MUX2 $T=340380 951440 0 0 $X=340380 $Y=951060
X3709 1253 88 2 1 1322 1256 MUX2 $T=340380 961520 1 0 $X=340380 $Y=956100
X3710 1247 90 2 1 1321 1291 MUX2 $T=340380 961520 0 0 $X=340380 $Y=961140
X3711 1293 90 2 1 1304 1322 MUX2 $T=341000 991760 1 0 $X=341000 $Y=986340
X3712 1419 113 2 1 1499 1427 MUX2 $T=390600 921200 1 180 $X=386260 $Y=920820
X3713 1520 113 2 1 1504 1478 MUX2 $T=391840 931280 0 180 $X=387500 $Y=925860
X3714 1493 113 2 1 1529 1445 MUX2 $T=388740 921200 1 0 $X=388740 $Y=915780
X3715 127 113 2 1 1524 1520 MUX2 $T=389980 901040 1 0 $X=389980 $Y=895620
X3716 1459 113 2 1 1551 1419 MUX2 $T=391220 901040 0 0 $X=391220 $Y=900660
X3717 123 113 2 1 1555 1493 MUX2 $T=400520 901040 0 180 $X=396180 $Y=895620
X3718 1516 113 2 1 1559 1417 MUX2 $T=401140 901040 1 180 $X=396800 $Y=900660
X3719 121 113 2 1 139 1516 MUX2 $T=399280 890960 1 0 $X=399280 $Y=885540
X3720 91 113 2 1 1596 102 MUX2 $T=409200 880880 1 180 $X=404860 $Y=880500
X3721 91 113 2 1 1668 96 MUX2 $T=412920 890960 0 0 $X=412920 $Y=890580
X3722 1661 147 2 1 1686 1695 MUX2 $T=416020 951440 1 0 $X=416020 $Y=946020
X3723 96 113 2 1 1692 123 MUX2 $T=416640 890960 1 0 $X=416640 $Y=885540
X3724 1710 159 2 1 1682 1681 MUX2 $T=423460 901040 0 180 $X=419120 $Y=895620
X3725 1695 147 2 1 1732 1743 MUX2 $T=423460 951440 0 0 $X=423460 $Y=951060
X3726 1711 154 2 1 1618 1738 MUX2 $T=423460 1022000 0 0 $X=423460 $Y=1021620
X3727 1691 160 2 1 1745 1732 MUX2 $T=424700 961520 0 0 $X=424700 $Y=961140
X3728 1701 1698 2 1 1696 1741 MUX2 $T=424700 981680 1 0 $X=424700 $Y=976260
X3729 1708 151 2 1 1711 1727 MUX2 $T=425940 1022000 1 0 $X=425940 $Y=1016580
X3730 1748 161 2 1 142 1729 MUX2 $T=430900 1052240 0 180 $X=426560 $Y=1046820
X3731 1730 159 2 1 1755 1720 MUX2 $T=427180 890960 1 0 $X=427180 $Y=885540
X3732 1742 1698 2 1 1758 1762 MUX2 $T=428420 981680 0 0 $X=428420 $Y=981300
X3733 1681 159 2 1 1756 1730 MUX2 $T=429040 890960 0 0 $X=429040 $Y=890580
X3734 1754 1778 2 1 1738 1744 MUX2 $T=433380 1022000 1 180 $X=429040 $Y=1021620
X3735 1750 147 2 1 1771 1770 MUX2 $T=430280 951440 1 0 $X=430280 $Y=946020
X3736 1732 160 2 1 1733 1771 MUX2 $T=430280 961520 1 0 $X=430280 $Y=956100
X3737 1686 160 2 1 1772 1777 MUX2 $T=430280 961520 0 0 $X=430280 $Y=961140
X3738 1726 171 2 1 1664 1756 MUX2 $T=435240 901040 0 180 $X=430900 $Y=895620
X3739 1664 1752 2 1 1746 1779 MUX2 $T=431520 911120 1 0 $X=431520 $Y=905700
X3740 1727 151 2 1 1765 1754 MUX2 $T=431520 1022000 1 0 $X=431520 $Y=1016580
X3741 1743 147 2 1 1777 1750 MUX2 $T=432140 951440 0 0 $X=432140 $Y=951060
X3742 1745 150 2 1 1678 1804 MUX2 $T=432140 971600 0 0 $X=432140 $Y=971220
X3743 1720 159 2 1 1792 1786 MUX2 $T=433380 890960 1 0 $X=433380 $Y=885540
X3744 1753 150 2 1 1635 1807 MUX2 $T=434620 981680 0 0 $X=434620 $Y=981300
X3745 1765 154 2 1 1773 1803 MUX2 $T=434620 1032080 1 0 $X=434620 $Y=1026660
X3746 1791 1805 2 1 1717 1780 MUX2 $T=439580 931280 0 180 $X=435240 $Y=925860
X3747 1770 147 2 1 1799 1793 MUX2 $T=435240 951440 1 0 $X=435240 $Y=946020
X3748 1740 1698 2 1 1775 1800 MUX2 $T=435240 971600 1 0 $X=435240 $Y=966180
X3749 1744 1778 2 1 1803 1798 MUX2 $T=435240 1022000 0 0 $X=435240 $Y=1021620
X3750 1786 159 2 1 1806 1797 MUX2 $T=435860 880880 0 0 $X=435860 $Y=880500
X3751 1771 160 2 1 1804 1809 MUX2 $T=435860 961520 1 0 $X=435860 $Y=956100
X3752 1814 1805 2 1 1759 1788 MUX2 $T=440820 911120 0 180 $X=436480 $Y=905700
X3753 1777 160 2 1 1807 1799 MUX2 $T=436480 961520 0 0 $X=436480 $Y=961140
X3754 1789 164 2 1 1680 1816 MUX2 $T=436480 1042160 1 0 $X=436480 $Y=1036740
X3755 1793 147 2 1 1809 1815 MUX2 $T=437100 951440 0 0 $X=437100 $Y=951060
X3756 1772 150 2 1 1687 1820 MUX2 $T=437720 981680 1 0 $X=437720 $Y=976260
X3757 1755 171 2 1 1824 1806 MUX2 $T=438960 890960 0 0 $X=438960 $Y=890580
X3758 1797 159 2 1 1823 1827 MUX2 $T=439580 890960 1 0 $X=439580 $Y=885540
X3759 1794 164 2 1 1694 1832 MUX2 $T=439580 1042160 0 0 $X=439580 $Y=1041780
X3760 1792 171 2 1 1779 1823 MUX2 $T=440200 901040 1 0 $X=440200 $Y=895620
X3761 1803 154 2 1 1832 1843 MUX2 $T=440200 1032080 0 0 $X=440200 $Y=1031700
X3762 1733 150 2 1 1741 1837 MUX2 $T=440820 971600 1 0 $X=440820 $Y=966180
X3763 1798 1778 2 1 1838 1808 MUX2 $T=440820 1022000 0 0 $X=440820 $Y=1021620
X3764 1738 154 2 1 1816 1838 MUX2 $T=440820 1032080 1 0 $X=440820 $Y=1026660
X3765 1796 1752 2 1 1780 1845 MUX2 $T=441440 921200 1 0 $X=441440 $Y=915780
X3766 1811 1805 2 1 1812 1834 MUX2 $T=441440 921200 0 0 $X=441440 $Y=920820
X3767 1807 150 2 1 1762 1836 MUX2 $T=441440 981680 0 0 $X=441440 $Y=981300
X3768 1809 160 2 1 1837 1847 MUX2 $T=442060 961520 1 0 $X=442060 $Y=956100
X3769 1799 160 2 1 1820 1851 MUX2 $T=442060 961520 0 0 $X=442060 $Y=961140
X3770 1816 164 2 1 176 1850 MUX2 $T=442680 1042160 1 0 $X=442680 $Y=1036740
X3771 1819 161 2 1 1839 1852 MUX2 $T=443300 1052240 1 0 $X=443300 $Y=1046820
X3772 1806 171 2 1 1853 1833 MUX2 $T=444540 890960 0 0 $X=444540 $Y=890580
X3773 175 159 2 1 1857 179 MUX2 $T=445160 880880 0 0 $X=445160 $Y=880500
X3774 1827 159 2 1 1833 175 MUX2 $T=449500 890960 0 180 $X=445160 $Y=885540
X3775 1815 147 2 1 1851 1841 MUX2 $T=445160 951440 0 0 $X=445160 $Y=951060
X3776 1841 147 2 1 1847 1863 MUX2 $T=445780 951440 1 0 $X=445780 $Y=946020
X3777 1832 164 2 1 1852 1870 MUX2 $T=445780 1042160 0 0 $X=445780 $Y=1041780
X3778 1823 171 2 1 1845 1857 MUX2 $T=446400 901040 1 0 $X=446400 $Y=895620
X3779 1825 1698 2 1 1855 1874 MUX2 $T=446400 971600 0 0 $X=446400 $Y=971220
X3780 1843 154 2 1 1875 1884 MUX2 $T=446400 1032080 0 0 $X=446400 $Y=1031700
X3781 1804 150 2 1 1800 1871 MUX2 $T=447020 971600 1 0 $X=447020 $Y=966180
X3782 1822 1778 2 1 1876 1848 MUX2 $T=447020 1022000 0 0 $X=447020 $Y=1021620
X3783 1838 154 2 1 1878 1876 MUX2 $T=447020 1032080 1 0 $X=447020 $Y=1026660
X3784 1859 1805 2 1 1849 1886 MUX2 $T=448880 921200 0 0 $X=448880 $Y=920820
X3785 1618 164 2 1 1715 1878 MUX2 $T=448880 1042160 1 0 $X=448880 $Y=1036740
X3786 1854 1752 2 1 1718 1853 MUX2 $T=449500 921200 1 0 $X=449500 $Y=915780
X3787 1773 164 2 1 1729 1875 MUX2 $T=449500 1052240 1 0 $X=449500 $Y=1046820
X3788 1824 1752 2 1 1788 1895 MUX2 $T=450120 901040 0 0 $X=450120 $Y=900660
X3789 1863 147 2 1 1868 1894 MUX2 $T=450740 951440 1 0 $X=450740 $Y=946020
X3790 1779 1752 2 1 1834 1891 MUX2 $T=451360 911120 1 0 $X=451360 $Y=905700
X3791 1705 1698 2 1 1900 1904 MUX2 $T=452600 981680 1 0 $X=452600 $Y=976260
X3792 1848 1778 2 1 1884 1869 MUX2 $T=452600 1022000 0 0 $X=452600 $Y=1021620
X3793 1876 154 2 1 1850 1908 MUX2 $T=453220 1032080 1 0 $X=453220 $Y=1026660
X3794 1767 161 2 1 1912 1920 MUX2 $T=454460 1052240 0 0 $X=454460 $Y=1051860
X3795 1736 1805 2 1 1893 1921 MUX2 $T=455700 921200 0 0 $X=455700 $Y=920820
X3796 1635 1698 2 1 1943 1938 MUX2 $T=458180 981680 1 0 $X=458180 $Y=976260
X3797 1907 161 2 1 1925 1940 MUX2 $T=458800 1042160 0 0 $X=458800 $Y=1041780
X3798 1869 1778 2 1 1908 1905 MUX2 $T=464380 1011920 1 180 $X=460040 $Y=1011540
X3799 1901 154 2 1 1911 1946 MUX2 $T=460660 1032080 1 0 $X=460660 $Y=1026660
X3800 1898 147 2 1 1942 1935 MUX2 $T=461900 951440 0 0 $X=461900 $Y=951060
X3801 1937 171 2 1 1953 1972 MUX2 $T=462520 901040 0 0 $X=462520 $Y=900660
X3802 1944 159 2 1 1909 1941 MUX2 $T=467480 880880 1 180 $X=463140 $Y=880500
X3803 1725 1805 2 1 1919 1927 MUX2 $T=463140 921200 0 0 $X=463140 $Y=920820
X3804 1746 1805 2 1 1956 1960 MUX2 $T=463760 931280 1 0 $X=463760 $Y=925860
X3805 1948 1778 2 1 1946 1964 MUX2 $T=465620 1011920 0 0 $X=465620 $Y=1011540
X3806 1678 1698 2 1 1986 1977 MUX2 $T=466860 981680 1 0 $X=466860 $Y=976260
X3807 1957 161 2 1 186 1963 MUX2 $T=468100 1062320 1 0 $X=468100 $Y=1056900
X3808 1961 150 2 1 2005 1996 MUX2 $T=470580 971600 0 0 $X=470580 $Y=971220
X3809 1987 164 2 1 2006 1963 MUX2 $T=470580 1042160 0 0 $X=470580 $Y=1041780
X3810 1694 161 2 1 2003 2015 MUX2 $T=471200 1052240 0 0 $X=471200 $Y=1051860
X3811 1968 154 2 1 1949 1985 MUX2 $T=478020 1032080 0 180 $X=473680 $Y=1026660
X3812 1970 1752 2 1 2023 1989 MUX2 $T=474300 911120 0 0 $X=474300 $Y=910740
X3813 1960 1805 2 1 2030 2023 MUX2 $T=474300 921200 0 0 $X=474300 $Y=920820
X3814 1998 161 2 1 2028 1963 MUX2 $T=474300 1062320 1 0 $X=474300 $Y=1056900
X3815 2007 150 2 1 2038 1996 MUX2 $T=476780 971600 0 0 $X=476780 $Y=971220
X3816 2015 161 2 1 190 2006 MUX2 $T=477400 1052240 0 0 $X=477400 $Y=1051860
X3817 1687 1698 2 1 2040 1979 MUX2 $T=478020 981680 0 0 $X=478020 $Y=981300
X3818 1680 161 2 1 2052 2057 MUX2 $T=479260 1052240 1 0 $X=479260 $Y=1046820
X3819 2020 1752 2 1 2044 2058 MUX2 $T=479880 911120 0 0 $X=479880 $Y=910740
X3820 2029 161 2 1 191 1963 MUX2 $T=480500 1062320 1 0 $X=480500 $Y=1056900
X3821 2047 1698 2 1 2067 1996 MUX2 $T=482980 961520 0 0 $X=482980 $Y=961140
X3822 1979 1698 2 1 2072 1996 MUX2 $T=482980 971600 0 0 $X=482980 $Y=971220
X3823 2035 164 2 1 2032 1963 MUX2 $T=482980 1042160 0 0 $X=482980 $Y=1041780
X3824 2054 164 2 1 2075 1963 MUX2 $T=483600 1032080 0 0 $X=483600 $Y=1031700
X3825 1966 1805 2 1 2124 1989 MUX2 $T=485460 921200 1 0 $X=485460 $Y=915780
X3826 2064 1752 2 1 2077 2058 MUX2 $T=486080 911120 1 0 $X=486080 $Y=905700
X3827 2056 150 2 1 2086 2025 MUX2 $T=486080 961520 1 0 $X=486080 $Y=956100
X3828 2076 161 2 1 193 1963 MUX2 $T=491040 1062320 0 180 $X=486700 $Y=1056900
X3829 1977 1698 2 1 2097 2086 MUX2 $T=488560 961520 0 0 $X=488560 $Y=961140
X3830 2024 1805 2 1 2105 2058 MUX2 $T=491040 911120 0 0 $X=491040 $Y=910740
X3831 1992 1805 2 1 2110 1989 MUX2 $T=491660 921200 0 0 $X=491660 $Y=920820
X3832 2049 1805 2 1 2117 2058 MUX2 $T=492280 911120 1 0 $X=492280 $Y=905700
X3833 2085 1698 2 1 2118 2025 MUX2 $T=492280 951440 0 0 $X=492280 $Y=951060
X3834 2017 1698 2 1 2149 2025 MUX2 $T=492280 961520 1 0 $X=492280 $Y=956100
X3835 2185 163 2 1 2163 211 MUX2 $T=520800 1042160 0 180 $X=516460 $Y=1036740
X3836 2226 163 2 1 2249 2211 MUX2 $T=519560 1022000 0 0 $X=519560 $Y=1021620
X3837 2254 163 2 1 2279 230 MUX2 $T=525760 1022000 0 0 $X=525760 $Y=1021620
X3838 2304 163 2 1 2283 2185 MUX2 $T=537540 1022000 1 180 $X=533200 $Y=1021620
X3839 2325 163 2 1 2301 214 MUX2 $T=544980 1032080 0 180 $X=540640 $Y=1026660
X3840 2345 163 2 1 2332 2226 MUX2 $T=550560 1022000 0 180 $X=546220 $Y=1016580
X3841 2382 163 2 1 2366 2254 MUX2 $T=558620 1022000 1 180 $X=554280 $Y=1021620
X3842 2392 163 2 1 2361 2325 MUX2 $T=559860 1032080 1 180 $X=555520 $Y=1031700
X3843 2408 222 2 1 2431 2427 MUX2 $T=564200 981680 0 0 $X=564200 $Y=981300
X3844 2463 163 2 1 2421 2345 MUX2 $T=571020 1022000 1 180 $X=566680 $Y=1021620
X3845 2461 222 2 1 2475 2479 MUX2 $T=572880 981680 1 0 $X=572880 $Y=976260
X3846 2529 163 2 1 2488 2392 MUX2 $T=582800 1032080 0 180 $X=578460 $Y=1026660
X3847 2544 163 2 1 2506 2382 MUX2 $T=585900 1032080 1 180 $X=581560 $Y=1031700
X3848 2529 163 2 1 2553 2463 MUX2 $T=584660 1032080 1 0 $X=584660 $Y=1026660
X3849 2529 163 2 1 2567 2544 MUX2 $T=587760 1032080 0 0 $X=587760 $Y=1031700
X3850 2529 163 2 1 2585 2401 MUX2 $T=589000 1022000 0 0 $X=589000 $Y=1021620
X3851 2455 222 2 1 2616 2615 MUX2 $T=598920 991760 1 0 $X=598920 $Y=986340
X3852 2255 2572 2555 1 2 XNR2H $T=586520 1042160 0 0 $X=586520 $Y=1041780
X3853 2631 2606 2572 1 2 XNR2H $T=606980 1052240 0 180 $X=598300 $Y=1046820
X3854 1020 66 70 2 1 1072 QDFFRBS $T=291400 1022000 1 0 $X=291400 $Y=1016580
X3855 2606 226 70 2 1 2533 QDFFRBS $T=609460 1042160 1 180 $X=597680 $Y=1041780
X3856 2566 1 2 2577 BUF8CK $T=589000 961520 0 0 $X=589000 $Y=961140
X3857 105 1181 1303 2 1296 1294 1 AO22S $T=344720 890960 0 180 $X=339760 $Y=885540
X3858 2165 1951 2101 2 2043 1926 1 AO22S $T=504680 981680 0 180 $X=499720 $Y=976260
X3859 2176 2135 2155 2 2117 1568 1 AO22S $T=507780 921200 1 180 $X=502820 $Y=920820
X3860 2174 1951 2142 2 2074 1926 1 AO22S $T=508400 971600 1 180 $X=503440 $Y=971220
X3861 2199 2135 2194 2 2124 1568 1 AO22S $T=513980 921200 1 180 $X=509020 $Y=920820
X3862 2200 1951 2189 2 2097 1926 1 AO22S $T=513980 971600 1 180 $X=509020 $Y=971220
X3863 2219 2135 2201 2 2030 1568 1 AO22S $T=516460 931280 0 180 $X=511500 $Y=925860
X3864 2221 2135 2156 2 2001 1568 1 AO22S $T=517700 941360 1 180 $X=512740 $Y=940980
X3865 2232 1951 2222 2 2072 1926 1 AO22S $T=520180 961520 1 180 $X=515220 $Y=961140
X3866 2210 2135 2231 2 2084 1568 1 AO22S $T=523280 941360 1 180 $X=518320 $Y=940980
X3867 2251 2135 2240 2 2105 1568 1 AO22S $T=525140 921200 1 180 $X=520180 $Y=920820
X3868 2281 229 2237 2 2267 222 1 AO22S $T=533820 890960 0 180 $X=528860 $Y=885540
X3869 2509 229 2492 2 2466 222 1 AO22S $T=582180 981680 0 180 $X=577220 $Y=976260
X3870 2566 229 2559 2 268 222 1 AO22S $T=592720 971600 1 180 $X=587760 $Y=971220
X3871 681 669 2 646 1 640 MUX2S $T=231880 931280 0 180 $X=227540 $Y=925860
X3872 642 686 2 649 1 7 MUX2S $T=232500 901040 0 180 $X=228160 $Y=895620
X3873 640 686 2 650 1 6 MUX2S $T=232500 911120 0 180 $X=228160 $Y=905700
X3874 678 686 2 659 1 631 MUX2S $T=234360 890960 0 180 $X=230020 $Y=885540
X3875 705 669 2 660 1 650 MUX2S $T=234360 911120 1 180 $X=230020 $Y=910740
X3876 694 666 2 661 1 633 MUX2S $T=234360 941360 0 180 $X=230020 $Y=935940
X3877 675 669 2 700 1 687 MUX2S $T=231880 921200 1 0 $X=231880 $Y=915780
X3878 702 669 2 675 1 678 MUX2S $T=236840 931280 1 180 $X=232500 $Y=930900
X3879 709 666 2 687 1 634 MUX2S $T=236840 941360 1 180 $X=232500 $Y=940980
X3880 714 669 2 692 1 676 MUX2S $T=237460 931280 0 180 $X=233120 $Y=925860
X3881 719 686 2 704 1 632 MUX2S $T=239320 911120 0 180 $X=234980 $Y=905700
X3882 737 686 2 711 1 630 MUX2S $T=240560 911120 1 180 $X=236220 $Y=910740
X3883 646 669 2 705 1 661 MUX2S $T=241800 921200 1 180 $X=237460 $Y=920820
X3884 744 669 2 726 1 642 MUX2S $T=243040 931280 0 180 $X=238700 $Y=925860
X3885 692 669 2 734 1 704 MUX2S $T=244280 901040 1 180 $X=239940 $Y=900660
X3886 660 754 2 741 1 734 MUX2S $T=245520 911120 0 180 $X=241180 $Y=905700
X3887 726 669 2 743 1 711 MUX2S $T=246140 921200 0 180 $X=241800 $Y=915780
X3888 749 17 2 746 1 700 MUX2S $T=247380 901040 0 180 $X=243040 $Y=895620
X3889 746 17 2 682 1 743 MUX2S $T=248000 890960 1 180 $X=243660 $Y=890580
X3890 750 17 2 758 1 675 MUX2S $T=248620 931280 0 180 $X=244280 $Y=925860
X3891 808 29 2 660 1 741 MUX2S $T=250480 901040 1 180 $X=246140 $Y=900660
X3892 787 17 2 772 1 692 MUX2S $T=252340 921200 0 180 $X=248000 $Y=915780
X3893 792 17 2 814 1 714 MUX2S $T=249860 931280 1 0 $X=249860 $Y=925860
X3894 809 29 2 808 1 746 MUX2S $T=256060 890960 1 180 $X=251720 $Y=890580
X3895 813 29 2 809 1 772 MUX2S $T=256060 901040 0 180 $X=251720 $Y=895620
X3896 816 29 2 813 1 749 MUX2S $T=256680 911120 0 180 $X=252340 $Y=905700
X3897 846 847 2 857 1 851 MUX2S $T=260400 901040 0 0 $X=260400 $Y=900660
X3898 873 872 2 851 1 848 MUX2S $T=265360 901040 0 180 $X=261020 $Y=895620
X3899 880 50 2 857 1 854 MUX2S $T=265980 911120 0 180 $X=261640 $Y=905700
X3900 888 872 2 854 1 860 MUX2S $T=267220 911120 1 180 $X=262880 $Y=910740
X3901 886 874 2 860 1 865 MUX2S $T=267840 921200 1 180 $X=263500 $Y=920820
X3902 902 50 2 880 1 873 MUX2S $T=269700 921200 0 180 $X=265360 $Y=915780
X3903 912 872 2 873 1 875 MUX2S $T=270320 931280 0 180 $X=265980 $Y=925860
X3904 854 872 2 846 1 943 MUX2S $T=266600 901040 1 0 $X=266600 $Y=895620
X3905 917 53 2 846 1 857 MUX2S $T=270940 901040 1 180 $X=266600 $Y=900660
X3906 925 53 2 901 1 880 MUX2S $T=272800 911120 1 180 $X=268460 $Y=910740
X3907 896 872 2 888 1 916 MUX2S $T=269080 931280 0 0 $X=269080 $Y=930900
X3908 858 874 2 916 1 919 MUX2S $T=269080 991760 1 0 $X=269080 $Y=986340
X3909 901 53 2 917 1 933 MUX2S $T=270940 911120 1 0 $X=270940 $Y=905700
X3910 907 53 2 925 1 934 MUX2S $T=270940 921200 1 0 $X=270940 $Y=915780
X3911 930 50 2 902 1 888 MUX2S $T=275900 931280 0 180 $X=271560 $Y=925860
X3912 916 871 2 943 1 69 MUX2S $T=274660 890960 0 0 $X=274660 $Y=890580
X3913 949 50 2 930 1 912 MUX2S $T=279620 931280 1 180 $X=275280 $Y=930900
X3914 932 871 2 848 1 961 MUX2S $T=276520 901040 0 0 $X=276520 $Y=900660
X3915 965 50 2 934 1 941 MUX2S $T=281480 921200 0 180 $X=277140 $Y=915780
X3916 941 872 2 956 1 968 MUX2S $T=279000 911120 0 0 $X=279000 $Y=910740
X3917 952 53 2 935 1 965 MUX2S $T=279620 921200 0 0 $X=279620 $Y=920820
X3918 934 50 2 933 1 979 MUX2S $T=280860 911120 1 0 $X=280860 $Y=905700
X3919 988 53 2 952 1 930 MUX2S $T=285200 931280 0 180 $X=280860 $Y=925860
X3920 992 872 2 941 1 966 MUX2S $T=286440 931280 1 180 $X=282100 $Y=930900
X3921 933 50 2 944 1 956 MUX2S $T=287060 901040 1 180 $X=282720 $Y=900660
X3922 969 874 2 968 1 993 MUX2S $T=282720 921200 1 0 $X=282720 $Y=915780
X3923 984 872 2 979 1 973 MUX2S $T=288920 911120 1 180 $X=284580 $Y=910740
X3924 982 872 2 984 1 997 MUX2S $T=285200 941360 0 0 $X=285200 $Y=940980
X3925 1001 50 2 965 1 984 MUX2S $T=290160 921200 1 180 $X=285820 $Y=920820
X3926 966 871 2 990 1 72 MUX2S $T=290780 901040 0 180 $X=286440 $Y=895620
X3927 1021 50 2 1001 1 992 MUX2S $T=292640 931280 1 180 $X=288300 $Y=930900
X3928 997 871 2 1017 1 1027 MUX2S $T=288920 901040 0 0 $X=288920 $Y=900660
X3929 1129 83 2 1155 1 1170 MUX2S $T=313100 911120 1 0 $X=313100 $Y=905700
X3930 1150 83 2 1129 1 1187 MUX2S $T=314960 911120 0 0 $X=314960 $Y=910740
X3931 1143 83 2 1150 1 1176 MUX2S $T=314960 921200 0 0 $X=314960 $Y=920820
X3932 1144 83 2 1143 1 1182 MUX2S $T=315580 931280 1 0 $X=315580 $Y=925860
X3933 1136 83 2 1152 1 1183 MUX2S $T=316820 941360 1 0 $X=316820 $Y=935940
X3934 1155 1162 2 1170 1 1216 MUX2S $T=319300 911120 1 0 $X=319300 $Y=905700
X3935 1187 87 2 1206 1 1223 MUX2S $T=321160 921200 0 0 $X=321160 $Y=920820
X3936 1179 87 2 1176 1 1219 MUX2S $T=321160 931280 1 0 $X=321160 $Y=925860
X3937 1182 87 2 1187 1 1226 MUX2S $T=322400 931280 0 0 $X=322400 $Y=930900
X3938 1156 83 2 1136 1 1227 MUX2S $T=323020 941360 1 0 $X=323020 $Y=935940
X3939 1219 88 2 1216 1 1204 MUX2S $T=329220 911120 1 180 $X=324880 $Y=910740
X3940 1229 88 2 1223 1 1221 MUX2S $T=330460 921200 0 180 $X=326120 $Y=915780
X3941 1197 87 2 1227 1 1259 MUX2S $T=326740 951440 1 0 $X=326740 $Y=946020
X3942 1183 87 2 1182 1 1229 MUX2S $T=331700 931280 0 180 $X=327360 $Y=925860
X3943 1227 87 2 1179 1 1263 MUX2S $T=327980 931280 0 0 $X=327980 $Y=930900
X3944 1201 87 2 1183 1 1256 MUX2S $T=328600 941360 0 0 $X=328600 $Y=940980
X3945 1237 87 2 1201 1 1260 MUX2S $T=329220 951440 0 0 $X=329220 $Y=951060
X3946 1241 88 2 1244 1 1257 MUX2S $T=331700 981680 0 0 $X=331700 $Y=981300
X3947 1209 88 2 1155 1 1279 MUX2S $T=332320 921200 1 0 $X=332320 $Y=915780
X3948 1248 90 2 1221 1 1280 MUX2S $T=332940 921200 0 0 $X=332940 $Y=920820
X3949 1259 88 2 1219 1 1278 MUX2S $T=332940 941360 0 0 $X=332940 $Y=940980
X3950 1263 88 2 1209 1 1277 MUX2S $T=333560 931280 0 0 $X=333560 $Y=930900
X3951 1256 88 2 1226 1 1287 MUX2S $T=334180 941360 1 0 $X=334180 $Y=935940
X3952 1258 88 2 1263 1 1288 MUX2S $T=334180 961520 1 0 $X=334180 $Y=956100
X3953 1260 88 2 1229 1 1291 MUX2S $T=334800 951440 0 0 $X=334800 $Y=951060
X3954 1288 90 2 1279 1 1309 MUX2S $T=337900 921200 1 0 $X=337900 $Y=915780
X3955 1291 90 2 1252 1 1319 MUX2S $T=338520 921200 0 0 $X=338520 $Y=920820
X3956 1265 90 2 1277 1 1318 MUX2S $T=339760 941360 1 0 $X=339760 $Y=935940
X3957 1289 90 2 1204 1 1332 MUX2S $T=342240 911120 0 0 $X=342240 $Y=910740
X3958 1322 90 2 1314 1 1361 MUX2S $T=348440 931280 0 0 $X=348440 $Y=930900
X3959 1417 113 2 1444 1 1494 MUX2S $T=381920 951440 1 0 $X=381920 $Y=946020
X3960 141 113 2 1459 1 145 MUX2S $T=410440 890960 1 0 $X=410440 $Y=885540
X3961 1808 1778 2 1822 1 1843 MUX2S $T=440200 1022000 1 0 $X=440200 $Y=1016580
X3962 1847 160 2 1867 1 1871 MUX2S $T=447640 961520 1 0 $X=447640 $Y=956100
X3963 1851 160 2 1868 1 1836 MUX2S $T=447640 961520 0 0 $X=447640 $Y=961140
X3964 1833 171 2 1862 1 1895 MUX2S $T=450740 890960 0 0 $X=450740 $Y=890580
X3965 1857 171 2 1885 1 1891 MUX2S $T=450740 901040 1 0 $X=450740 $Y=895620
X3966 1820 150 2 1896 1 1874 MUX2S $T=452600 971600 0 0 $X=452600 $Y=971220
X3967 1881 147 2 1898 1 1902 MUX2S $T=453220 961520 1 0 $X=453220 $Y=956100
X3968 1837 150 2 1899 1 1904 MUX2S $T=453220 971600 1 0 $X=453220 $Y=966180
X3969 1884 154 2 1901 1 1870 MUX2S $T=453220 1032080 0 0 $X=453220 $Y=1031700
X3970 1868 160 2 1902 1 1896 MUX2S $T=453840 961520 0 0 $X=453840 $Y=961140
X3971 180 159 2 1892 1 1885 MUX2S $T=458800 890960 0 180 $X=454460 $Y=885540
X3972 1885 171 2 1909 1 1913 MUX2S $T=455080 901040 1 0 $X=455080 $Y=895620
X3973 1875 164 2 1911 1 1920 MUX2S $T=455080 1052240 1 0 $X=455080 $Y=1046820
X3974 1862 171 2 1916 1 1922 MUX2S $T=456320 890960 0 0 $X=456320 $Y=890580
X3975 1895 1752 2 1917 1 1927 MUX2S $T=456320 901040 0 0 $X=456320 $Y=900660
X3976 1845 1752 2 1913 1 1921 MUX2S $T=456320 921200 1 0 $X=456320 $Y=915780
X3977 1853 1752 2 1922 1 1886 MUX2S $T=456940 911120 1 0 $X=456940 $Y=905700
X3978 1894 147 2 1881 1 1867 MUX2S $T=456940 951440 1 0 $X=456940 $Y=946020
X3979 1905 1778 2 1928 1 1901 MUX2S $T=458180 1022000 1 0 $X=458180 $Y=1016580
X3980 1836 150 2 1930 1 1938 MUX2S $T=458800 971600 0 0 $X=458800 $Y=971220
X3981 1908 154 2 1931 1 1932 MUX2S $T=458800 1022000 0 0 $X=458800 $Y=1021620
X3982 1878 164 2 1932 1 1940 MUX2S $T=458800 1042160 1 0 $X=458800 $Y=1036740
X3983 1902 160 2 1936 1 1930 MUX2S $T=459420 971600 1 0 $X=459420 $Y=966180
X3984 1867 160 2 1942 1 1899 MUX2S $T=460040 961520 0 0 $X=460040 $Y=961140
X3985 1892 159 2 1944 1 1916 MUX2S $T=460660 890960 1 0 $X=460660 $Y=885540
X3986 1909 171 2 1937 1 1952 MUX2S $T=461280 901040 1 0 $X=461280 $Y=895620
X3987 1911 164 2 1949 1 1957 MUX2S $T=461280 1052240 1 0 $X=461280 $Y=1046820
X3988 1916 171 2 1950 1 1917 MUX2S $T=461900 890960 0 0 $X=461900 $Y=890580
X3989 1891 1752 2 1952 1 1960 MUX2S $T=462520 911120 1 0 $X=462520 $Y=905700
X3990 1913 1752 2 1953 1 1966 MUX2S $T=462520 921200 1 0 $X=462520 $Y=915780
X3991 1935 147 2 1954 1 1936 MUX2S $T=463140 951440 1 0 $X=463140 $Y=946020
X3992 1896 150 2 1961 1 1979 MUX2S $T=464380 971600 0 0 $X=464380 $Y=971220
X3993 1928 1778 2 1948 1 1931 MUX2S $T=464380 1022000 1 0 $X=464380 $Y=1016580
X3994 1936 160 2 1962 1 1961 MUX2S $T=465000 971600 1 0 $X=465000 $Y=966180
X3995 1946 154 2 1968 1 1969 MUX2S $T=465000 1022000 0 0 $X=465000 $Y=1021620
X3996 1870 164 2 1969 1 2015 MUX2S $T=465000 1042160 1 0 $X=465000 $Y=1036740
X3997 1949 164 2 1963 1 1978 MUX2S $T=465000 1042160 0 0 $X=465000 $Y=1041780
X3998 1729 161 2 1957 1 1975 MUX2S $T=465000 1052240 0 0 $X=465000 $Y=1051860
X3999 1871 150 2 1973 1 1977 MUX2S $T=465620 961520 1 0 $X=465620 $Y=956100
X4000 1941 159 2 1976 1 1950 MUX2S $T=466240 890960 1 0 $X=466240 $Y=885540
X4001 1976 159 2 1965 1 1937 MUX2S $T=471820 890960 1 180 $X=467480 $Y=890580
X4002 1991 147 2 1967 1 1962 MUX2S $T=471820 941360 1 180 $X=467480 $Y=940980
X4003 1942 160 2 1983 1 1973 MUX2S $T=467480 951440 0 0 $X=467480 $Y=951060
X4004 1963 1739 2 1985 1 1987 MUX2S $T=467480 1032080 1 0 $X=467480 $Y=1026660
X4005 1920 161 2 1978 1 1994 MUX2S $T=467480 1052240 1 0 $X=467480 $Y=1046820
X4006 1989 149 2 1972 1 1970 MUX2S $T=472440 911120 0 180 $X=468100 $Y=905700
X4007 1952 1752 2 1970 1 1992 MUX2S $T=468100 911120 0 0 $X=468100 $Y=910740
X4008 1953 1752 2 1989 1 1990 MUX2S $T=468720 921200 1 0 $X=468720 $Y=915780
X4009 1921 1805 2 1990 1 2001 MUX2S $T=469340 931280 1 0 $X=469340 $Y=925860
X4010 1954 147 2 1991 1 1983 MUX2S $T=469340 951440 1 0 $X=469340 $Y=946020
X4011 1964 1778 2 1984 1 1997 MUX2S $T=469960 1022000 1 0 $X=469960 $Y=1016580
X4012 1962 160 2 1996 1 2007 MUX2S $T=471200 961520 0 0 $X=471200 $Y=961140
X4013 1931 154 2 1997 1 2011 MUX2S $T=471200 1022000 0 0 $X=471200 $Y=1021620
X4014 1969 164 2 1987 1 1998 MUX2S $T=471200 1032080 0 0 $X=471200 $Y=1031700
X4015 1965 159 2 2000 1 2016 MUX2S $T=471820 901040 1 0 $X=471820 $Y=895620
X4016 1899 150 2 2002 1 2017 MUX2S $T=471820 961520 1 0 $X=471820 $Y=956100
X4017 1984 1778 2 1999 1 1968 MUX2S $T=471820 1011920 0 0 $X=471820 $Y=1011540
X4018 1874 1698 2 2005 1 2012 MUX2S $T=472440 981680 1 0 $X=472440 $Y=976260
X4019 1983 160 2 2009 1 2002 MUX2S $T=473060 951440 0 0 $X=473060 $Y=951060
X4020 1852 161 2 1998 1 2027 MUX2S $T=473680 1052240 1 0 $X=473680 $Y=1046820
X4021 1922 1752 2 2020 1 2024 MUX2S $T=474300 911120 1 0 $X=474300 $Y=905700
X4022 2000 159 2 1989 1 1972 MUX2S $T=474920 901040 0 0 $X=474920 $Y=900660
X4023 1718 1805 2 2024 1 2031 MUX2S $T=475540 931280 1 0 $X=475540 $Y=925860
X4024 1967 147 2 2025 1 2009 MUX2S $T=475540 951440 1 0 $X=475540 $Y=946020
X4025 2018 1778 2 1963 1 1985 MUX2S $T=479880 1022000 0 180 $X=475540 $Y=1016580
X4026 1930 150 2 2007 1 2047 MUX2S $T=476780 961520 0 0 $X=476780 $Y=961140
X4027 1940 161 2 2032 1 2039 MUX2S $T=476780 1042160 0 0 $X=476780 $Y=1041780
X4028 2002 150 2 2025 1 2036 MUX2S $T=477400 961520 1 0 $X=477400 $Y=956100
X4029 1999 1778 2 2018 1 2034 MUX2S $T=477400 1011920 0 0 $X=477400 $Y=1011540
X4030 1997 154 2 2034 1 2035 MUX2S $T=477400 1022000 0 0 $X=477400 $Y=1021620
X4031 1932 164 2 2035 1 2029 MUX2S $T=477400 1032080 0 0 $X=477400 $Y=1031700
X4032 1904 1698 2 2036 1 2043 MUX2S $T=478020 981680 1 0 $X=478020 $Y=976260
X4033 1950 171 2 2016 1 2020 MUX2S $T=478640 890960 0 0 $X=478640 $Y=890580
X4034 2025 156 2 2009 1 2056 MUX2S $T=478640 951440 0 0 $X=478640 $Y=951060
X4035 1886 1805 2 2044 1 2053 MUX2S $T=479880 921200 1 0 $X=479880 $Y=915780
X4036 1850 164 2 2011 1 2057 MUX2S $T=479880 1032080 1 0 $X=479880 $Y=1026660
X4037 1788 1805 2 2049 1 2060 MUX2S $T=480500 911120 1 0 $X=480500 $Y=905700
X4038 1780 1805 2 1966 1 2045 MUX2S $T=481120 921200 0 0 $X=481120 $Y=920820
X4039 2016 171 2 2058 1 2064 MUX2S $T=482980 901040 0 0 $X=482980 $Y=900660
X4040 1938 1698 2 2038 1 2074 MUX2S $T=483600 981680 1 0 $X=483600 $Y=976260
X4041 2034 154 2 1963 1 2054 MUX2S $T=483600 1022000 0 0 $X=483600 $Y=1021620
X4042 1715 161 2 2029 1 2071 MUX2S $T=483600 1052240 0 0 $X=483600 $Y=1051860
X4043 176 161 2 2076 1 2083 MUX2S $T=485460 1052240 1 0 $X=485460 $Y=1046820
X4044 1927 1805 2 2077 1 2084 MUX2S $T=486080 921200 0 0 $X=486080 $Y=920820
X4045 1973 150 2 2056 1 2085 MUX2S $T=486700 951440 0 0 $X=486700 $Y=951060
X4046 2011 164 2 2054 1 2076 MUX2S $T=486700 1032080 1 0 $X=486700 $Y=1026660
X4047 1762 1698 2 2047 1 2091 MUX2S $T=487320 981680 0 0 $X=487320 $Y=981300
X4048 1917 1752 2 2064 1 2049 MUX2S $T=488560 901040 0 0 $X=488560 $Y=900660
X4049 1800 1698 2 2085 1 2095 MUX2S $T=489180 971600 0 0 $X=489180 $Y=971220
X4050 1741 1698 2 2017 1 2078 MUX2S $T=489180 981680 1 0 $X=489180 $Y=976260
X4051 2057 161 2 2075 1 2104 MUX2S $T=489180 1042160 0 0 $X=489180 $Y=1041780
X4052 1834 1805 2 1992 1 2106 MUX2S $T=490420 931280 1 0 $X=490420 $Y=925860
X4053 214 163 2 216 1 2260 MUX2S $T=519560 1062320 0 0 $X=519560 $Y=1061940
X4054 2401 163 2 2304 1 2372 MUX2S $T=559860 1032080 0 180 $X=555520 $Y=1026660
X4055 2108 2229 2255 1 2 XOR2H $T=518940 951440 1 0 $X=518940 $Y=946020
X4056 1076 1 1071 1092 2 1093 ND3HT $T=304420 981680 0 0 $X=304420 $Y=981300
X4057 2063 1 2059 2046 2 2089 ND3HT $T=484840 1011920 1 0 $X=484840 $Y=1006500
X4058 2145 1 2103 2146 2 2180 ND3HT $T=500340 1011920 1 0 $X=500340 $Y=1006500
X4059 2082 2098 2102 2 2107 1 2115 AOI13H $T=489800 1022000 0 0 $X=489800 $Y=1021620
X4060 604 597 617 635 2 1 MXL2HS $T=221340 961520 0 0 $X=221340 $Y=961140
X4061 615 618 639 644 2 1 MXL2HS $T=223200 1052240 0 0 $X=223200 $Y=1051860
X4062 760 784 766 764 2 1 MXL2HS $T=251100 991760 0 180 $X=245520 $Y=986340
X4063 928 883 909 910 2 1 MXL2HS $T=275280 1022000 0 180 $X=269700 $Y=1016580
X4064 1669 150 1705 1719 2 1 MXL2HS $T=420360 971600 0 0 $X=420360 $Y=971220
X4065 1714 154 1760 1765 2 1 MXL2HS $T=429040 1032080 0 0 $X=429040 $Y=1031700
X4066 1722 1752 1736 1769 2 1 MXL2HS $T=429660 921200 1 0 $X=429660 $Y=915780
X4067 1688 164 1767 1776 2 1 MXL2HS $T=430900 1042160 0 0 $X=430900 $Y=1041780
X4068 1682 171 1817 1755 2 1 MXL2HS $T=438340 911120 0 0 $X=438340 $Y=910740
X4069 1826 1752 1725 1856 2 1 MXL2HS $T=444540 911120 1 0 $X=444540 $Y=905700
X4070 179 159 1858 180 2 1 MXL2HS $T=453220 880880 0 0 $X=453220 $Y=880500
X4071 1549 1570 1572 1 2 AN2B1T $T=398040 971600 1 0 $X=398040 $Y=966180
X4072 1613 1618 1507 1 2 AN2B1T $T=406720 1052240 1 0 $X=406720 $Y=1046820
X4073 1671 1680 1531 1 2 AN2B1T $T=417260 1052240 0 0 $X=417260 $Y=1051860
X4074 1698 1705 1565 1 2 AN2B1T $T=420980 981680 0 0 $X=420980 $Y=981300
X4075 1682 148 146 1643 1712 1 2 AN4B1 $T=419120 911120 1 0 $X=419120 $Y=905700
X4076 27 768 771 1 2 765 OA12 $T=250480 1011920 0 180 $X=246760 $Y=1006500
X4077 5 670 752 1 2 806 OA12 $T=246760 1022000 0 0 $X=246760 $Y=1021620
X4078 1114 80 1124 1 2 1109 OA12 $T=315580 1022000 0 180 $X=311860 $Y=1016580
X4079 129 1523 1636 1 2 1641 OA12 $T=411680 961520 0 0 $X=411680 $Y=961140
X4080 1568 1543 1648 1 2 1656 OA12 $T=412300 931280 1 0 $X=412300 $Y=925860
X4081 126 122 1659 1 2 1654 OA12 $T=412920 1042160 1 0 $X=412920 $Y=1036740
X4082 761 670 745 2 740 5 1 AO22P $T=246140 1022000 0 180 $X=240560 $Y=1016580
X4083 791 670 747 2 762 5 1 AO22P $T=252340 1042160 0 180 $X=246760 $Y=1036740
X4084 937 768 927 2 957 27 1 AO22P $T=280240 991760 0 0 $X=280240 $Y=991380
X4085 1488 1523 1526 2 1537 129 1 AO22P $T=389980 971600 0 0 $X=389980 $Y=971220
X4086 1495 1543 1530 2 1550 1568 1 AO22P $T=393080 931280 0 0 $X=393080 $Y=930900
X4087 137 1616 125 2 1634 126 1 AO22P $T=406100 1062320 1 0 $X=406100 $Y=1056900
X4088 876 872 1 887 886 872 2 MOAI1 $T=264740 941360 1 0 $X=264740 $Y=935940
X4089 1610 129 1 1598 1585 129 2 MOAI1 $T=408580 961520 0 180 $X=404240 $Y=956100
X4090 1552 1571 1 1556 2 OR2B1S $T=401140 921200 1 180 $X=398040 $Y=920820
X4091 1550 1577 1 1564 2 OR2B1S $T=402380 931280 1 180 $X=399280 $Y=930900
X4092 891 892 2 915 911 923 1 AOI22H $T=267220 961520 0 0 $X=267220 $Y=961140
X4093 761 937 2 900 972 761 1 AOI22H $T=278380 1022000 1 0 $X=278380 $Y=1016580
X4094 88 1199 2 1222 1246 1210 1 AOI22H $T=324880 991760 0 0 $X=324880 $Y=991380
X4095 122 1481 2 1491 1503 126 1 AOI22H $T=381300 1042160 0 0 $X=381300 $Y=1041780
X4096 125 1518 2 1531 1487 126 1 AOI22H $T=388740 1062320 0 0 $X=388740 $Y=1061940
X4097 1523 1575 2 1565 1519 129 1 AOI22H $T=398040 991760 1 0 $X=398040 $Y=986340
X4098 1125 1158 1148 1124 2 1 NR3H $T=315580 1022000 1 0 $X=315580 $Y=1016580
X4099 1111 1121 1 1146 1161 1121 2 MOAI1H $T=310620 971600 0 0 $X=310620 $Y=971220
X4100 820 837 1 794 2 NR2T $T=259160 981680 1 180 $X=254200 $Y=981300
X4101 1111 47 1 82 2 NR2T $T=314960 981680 0 180 $X=310000 $Y=976260
X4102 1070 706 1081 1 2 OR2B1P $T=301320 961520 1 0 $X=301320 $Y=956100
.ENDS
***************************************
.SUBCKT AO12 B2 B1 A1 GND VCC O
** N=7 EP=6 IP=0 FDC=0
.ENDS
***************************************
.SUBCKT INV3 I O GND VCC
** N=5 EP=4 IP=0 FDC=0
.ENDS
***************************************
.SUBCKT INV4 I O GND VCC
** N=5 EP=4 IP=0 FDC=0
.ENDS
***************************************
.SUBCKT QDLHN CK D GND VCC Q
** N=6 EP=5 IP=0 FDC=0
.ENDS
***************************************
.SUBCKT DFFRBN D CK RB Q GND VCC QB
** N=8 EP=7 IP=0 FDC=0
.ENDS
***************************************
.SUBCKT MAOI1 B1 B2 A1 A2 VCC GND O
** N=8 EP=7 IP=0 FDC=0
.ENDS
***************************************
.SUBCKT AN3B2S I1 B2 VCC B1 GND O
** N=7 EP=6 IP=0 FDC=0
.ENDS
***************************************
.SUBCKT AN4S I1 I2 I4 I3 VCC GND O
** N=8 EP=7 IP=0 FDC=0
.ENDS
***************************************
.SUBCKT AO112 O C2 C1 VCC B1 GND A1
** N=8 EP=7 IP=0 FDC=0
.ENDS
***************************************
.SUBCKT QDFFRBT D CK RB GND VCC Q
** N=7 EP=6 IP=0 FDC=0
.ENDS
***************************************
.SUBCKT QDFFRBP D CK RB Q GND VCC
** N=7 EP=6 IP=0 FDC=0
.ENDS
***************************************
.SUBCKT AO13 B3 B2 B1 A1 GND VCC O
** N=8 EP=7 IP=0 FDC=0
.ENDS
***************************************
.SUBCKT OR3 I3 I2 I1 VCC GND O
** N=7 EP=6 IP=0 FDC=0
.ENDS
***************************************
.SUBCKT MUXB2 S A B VCC EB O GND
** N=8 EP=7 IP=0 FDC=0
.ENDS
***************************************
.SUBCKT AN2B1 I1 O B1 GND VCC
** N=6 EP=5 IP=0 FDC=0
.ENDS
***************************************
.SUBCKT AOI12HP B2 B1 VCC O A1 GND
** N=7 EP=6 IP=0 FDC=0
.ENDS
***************************************
.SUBCKT AO13P B3 B2 B1 A1 O GND VCC
** N=8 EP=7 IP=0 FDC=0
.ENDS
***************************************
.SUBCKT OR3B1 B1 I1 I2 GND VCC O
** N=7 EP=6 IP=0 FDC=0
.ENDS
***************************************
.SUBCKT AOI12H B2 B1 VCC O A1 GND
** N=7 EP=6 IP=0 FDC=0
.ENDS
***************************************
.SUBCKT OAI112H C2 C1 GND B1 O A1 VCC
** N=8 EP=7 IP=0 FDC=0
.ENDS
***************************************
.SUBCKT ICV_8 1 2 3 4 5 6 7 8 9 10 11 12 13 14 15 16 17 18 19 20
+ 21 22 23 24 25 26 27 28 29 30 31 32 33 34 35 36 37 38 39 40
+ 41 42 43 44 45 46 47 48 49 50 51 52 53 54 55 56 57 58 59 60
+ 61 62 63 64 65 66 67 68 69 70 71 72 73 74 75 76 77 78 79 80
+ 81 82 83 84 85 86 87 88 89 90 91 92 93 94 95 96 97 98 99 100
+ 101 102 103 104 105 106 107 108 109 110 111 112 113 114 115 116 117 118 119 120
+ 121 122 123 124 125 126 127 128 129 130 131 132 133 134 135 136 137 138 139 140
+ 141 142 143 144 145 146 147 148 149 150 151 152 153 154 155 156 157 158 159 160
+ 161 162 163 164 165 166 167 168 169 170 171 172 173 174 175 176 177 178 179 180
+ 181 182 183 184 185 186 187 188 189 190 191 192 193 194 195 196 197 198 199 200
+ 201 202 203 204 205 206 207 208 209 210 211 212 213 214 215 216 217 218 219 220
+ 221 222 223 224 225 226 227 228 229 230 231 232 233 234 235 236 237 238 239 240
+ 241 242 243 244 245 246 247 248 249 250 251 252 253 254 255 256 257 258 259 260
+ 261 262 263 264 265 266 267 268 269 270 271 272 273 274 275 276 277 278 279 280
+ 281 282 283 284 285 286 287 288 289 290 291 292 293 294 295 296 297 298 299 300
+ 301 302 303 304 305 306 307 308 309 310 311 312 313 314 315 316 317 318 319 320
+ 321 322 323 324 325 326 327 328 329 330 331 332 333 334 335 336 337 338 339 340
+ 341 342 343 344 345 346 347 348 349 350 351 352 353 354 355 356 357 358 359 360
+ 361 362 363 364 365 366 367 368 369 370 371 372 373 374 375 376 377 378 379 380
+ 381 382 383 384 385 386 387 388 389 390 391 392 393 394 395 396 397 398 399 400
+ 401 402 403 404 405 406 407 408 409 410 411 412 413 414 415 416 417 418 419 420
+ 421 422 423 424 425 426 427 428 429 430 431 432 433 434 435 436 437 438 439 440
+ 441 442 443 444 445 446 447 448 449 450 451 452 453 454 455 456 457 458 459 460
+ 461 462 463 464 465 466 467 468 469 470 471 472 473 474 475 476 477 478 479 480
+ 481 482 483 484 485 486 487 488 489 490 491 492 493 494 495 496 497 498 499 500
+ 501 502 503 504 505 506 507 508 509 510 511 512 513 514 515 516 517 518 519 520
+ 521 522 523 524 525 526 527 528 529 530 531 532 533 534 535 536 537 538 539 540
+ 541 542 543 544 545 546 547 548 549 550 551 552 553 554 555 556 557 558 559 560
+ 561 562 563 564 565 566 567 568 569 570 571 572 573 574 575 576 577 578 579 580
+ 581 582 583 584 585 586 587 588 589 590 591 592 593 594 595 596 597 598 599 600
+ 601 602 603 604 605 606 607 608 609 610 611 612 613 614 615 616 617 618 619 620
+ 621 622 623 624 625 626 627 628 629 630 631 632 633 634 635 636 637 638 639 640
+ 641 642 643 644 645 646 647 648 649 650 651 652 653 654 655 656 657 658 659 660
+ 661 662 663 664 665 666 667 668 669 670 671 672 673 674 675 676 677 678 679 680
+ 681 682 683 684 685 686 687 688 689 690 691 692 693 694 695 696 697 698 699 700
+ 701 702 703 704 705 706 707 708 709 710 711 712 713 714 715 716 717 718 719 720
+ 721 722 723 724 725 726 727 728 729 730 731 732 733 734 735 736 737 738 739 740
+ 741 742 743 744 745 746 747 748 749 750 751 752 753 754 755 756 757 758 759 760
+ 761 762 763 764 765 766 767 768 769 770 771 772 773 774 775 776 777 778 779 780
+ 781 782 783 784 785 786 787 788 789 790 791 792 793 794 795 796 797 798 799 800
+ 801 802 803 804 805 806 807 808 809 810 811 812 813 814 815 816 817 818 819 820
+ 821 822 823 824 825 826 827 828 829 830 831 832 833 834 835 836 837 838 839 840
+ 841 842 843 844 845 846 847 848 849 850 851 852 853 854 855 856 857 858 859 860
+ 861 862 863 864 865 866 867 868 869 870 871 872 873 874 875 876 877 878 879 880
+ 881 882 883 884 885 886 887 888 889 890 891 892 893 894 895 896 897 898 899 900
+ 901 902 903 904 905 906 907 908 909 910 911 912 913 914 915 916 917 918 919 920
+ 921 922 923 924 925 926 927 928 929 930 931 932 933 934 935 936 937 938 939 940
+ 941 942 943 944 945 946 947 948 949 950 951 952 953 954 955 956 957 958 959 960
+ 961 962 963 964 965 966 967 968 969 970 971 972 973 974 975 976 977 978 979 980
+ 981 982 1013
** N=4781 EP=983 IP=26664 FDC=0
X0 2137 262 2307 1 2 QDFFN $T=474920 870800 1 0 $X=474920 $Y=865380
X1 2200 262 2321 1 2 QDFFN $T=478020 860720 0 0 $X=478020 $Y=860340
X2 2309 262 2361 1 2 QDFFN $T=487940 870800 1 0 $X=487940 $Y=865380
X3 2101 262 2367 1 2 QDFFN $T=489800 860720 1 0 $X=489800 $Y=855300
X4 2138 262 2379 1 2 QDFFN $T=491660 860720 0 0 $X=491660 $Y=860340
X5 2011 262 2418 1 2 QDFFN $T=500340 870800 1 0 $X=500340 $Y=865380
X6 2417 294 2469 1 2 QDFFN $T=511500 860720 0 0 $X=511500 $Y=860340
X7 2403 294 2477 1 2 QDFFN $T=513360 870800 1 0 $X=513360 $Y=865380
X8 2438 294 2481 1 2 QDFFN $T=518320 850640 1 0 $X=518320 $Y=845220
X9 333 323 2425 1 2 QDFFN $T=528860 870800 1 180 $X=518320 $Y=870420
X10 341 323 2435 1 2 QDFFN $T=530720 880880 0 180 $X=520180 $Y=875460
X11 2503 294 2518 1 2 QDFFN $T=530720 860720 1 0 $X=530720 $Y=855300
X12 2505 294 2563 1 2 QDFFN $T=531340 870800 0 0 $X=531340 $Y=870420
X13 2572 323 357 1 2 QDFFN $T=547460 790160 0 180 $X=536920 $Y=784740
X14 2502 294 2603 1 2 QDFFN $T=538160 860720 0 0 $X=538160 $Y=860340
X15 390 323 2526 1 2 QDFFN $T=551180 880880 0 180 $X=540640 $Y=875460
X16 2637 323 2589 1 2 QDFFN $T=558620 840560 0 180 $X=548080 $Y=835140
X17 2633 323 382 1 2 QDFFN $T=559860 780080 1 180 $X=549320 $Y=779700
X18 2648 323 2568 1 2 QDFFN $T=561720 790160 1 180 $X=551180 $Y=789780
X19 2602 262 2657 1 2 QDFFN $T=551180 860720 0 0 $X=551180 $Y=860340
X20 2614 396 420 1 2 QDFFN $T=554280 880880 1 0 $X=554280 $Y=875460
X21 2629 323 2673 1 2 QDFFN $T=558000 860720 1 0 $X=558000 $Y=855300
X22 2634 262 2685 1 2 QDFFN $T=559240 810320 1 0 $X=559240 $Y=804900
X23 2638 323 2679 1 2 QDFFN $T=559860 840560 0 0 $X=559860 $Y=840180
X24 2626 323 2682 1 2 QDFFN $T=561720 800240 0 0 $X=561720 $Y=799860
X25 2656 323 2436 1 2 QDFFN $T=562960 770000 1 0 $X=562960 $Y=764580
X26 2612 323 2710 1 2 QDFFN $T=562960 830480 0 0 $X=562960 $Y=830100
X27 2677 323 2714 1 2 QDFFN $T=567300 820400 1 0 $X=567300 $Y=814980
X28 2638 430 2731 1 2 QDFFN $T=567920 850640 0 0 $X=567920 $Y=850260
X29 2601 262 2694 1 2 QDFFN $T=568540 790160 0 0 $X=568540 $Y=789780
X30 2637 430 2743 1 2 QDFFN $T=569160 840560 1 0 $X=569160 $Y=835140
X31 2629 430 2666 1 2 QDFFN $T=571020 860720 1 0 $X=571020 $Y=855300
X32 2724 467 2675 1 2 QDFFN $T=582800 780080 0 180 $X=572260 $Y=774660
X33 2704 294 2749 1 2 QDFFN $T=572880 840560 0 0 $X=572880 $Y=840180
X34 2572 430 2720 1 2 QDFFN $T=574740 800240 0 0 $X=574740 $Y=799860
X35 2715 294 2751 1 2 QDFFN $T=575980 830480 0 0 $X=575980 $Y=830100
X36 2677 430 2786 1 2 QDFFN $T=576600 830480 1 0 $X=576600 $Y=825060
X37 2724 430 2750 1 2 QDFFN $T=577220 810320 0 0 $X=577220 $Y=809940
X38 2678 262 2772 1 2 QDFFN $T=581560 790160 1 0 $X=581560 $Y=784740
X39 2648 430 2782 1 2 QDFFN $T=584040 800240 1 0 $X=584040 $Y=794820
X40 2775 262 2800 1 2 QDFFN $T=587140 820400 1 0 $X=587140 $Y=814980
X41 2612 430 2837 1 2 QDFFN $T=588380 830480 0 0 $X=588380 $Y=830100
X42 2788 262 2805 1 2 QDFFN $T=589000 780080 1 0 $X=589000 $Y=774660
X43 2633 430 2813 1 2 QDFFN $T=590240 810320 1 0 $X=590240 $Y=804900
X44 2626 430 2856 1 2 QDFFN $T=590240 810320 0 0 $X=590240 $Y=809940
X45 2773 262 2850 1 2 QDFFN $T=592720 820400 0 0 $X=592720 $Y=820020
X46 2818 262 2849 1 2 QDFFN $T=594580 790160 1 0 $X=594580 $Y=784740
X47 741 3832 3847 1 2 QDFFN $T=803520 719600 1 0 $X=803520 $Y=714180
X48 740 3833 3854 1 2 QDFFN $T=803520 790160 0 0 $X=803520 $Y=789780
X49 749 3832 3877 1 2 QDFFN $T=804760 709520 0 0 $X=804760 $Y=709140
X50 741 3833 3856 1 2 QDFFN $T=806620 800240 0 0 $X=806620 $Y=799860
X51 771 3833 3857 1 2 QDFFN $T=806620 830480 0 0 $X=806620 $Y=830100
X52 756 3833 3859 1 2 QDFFN $T=807240 810320 0 0 $X=807240 $Y=809940
X53 748 3833 3866 1 2 QDFFN $T=807240 840560 0 0 $X=807240 $Y=840180
X54 749 3833 3860 1 2 QDFFN $T=807240 850640 0 0 $X=807240 $Y=850260
X55 740 3853 3840 1 2 QDFFN $T=819640 790160 0 180 $X=809100 $Y=784740
X56 756 779 3883 1 2 QDFFN $T=811580 729680 0 0 $X=811580 $Y=729300
X57 748 3850 3884 1 2 QDFFN $T=811580 780080 1 0 $X=811580 $Y=774660
X58 748 3853 3876 1 2 QDFFN $T=812200 850640 1 0 $X=812200 $Y=845220
X59 771 3853 3880 1 2 QDFFN $T=812820 820400 0 0 $X=812820 $Y=820020
X60 756 3832 3894 1 2 QDFFN $T=813440 729680 1 0 $X=813440 $Y=724260
X61 756 3850 3922 1 2 QDFFN $T=813440 770000 0 0 $X=813440 $Y=769620
X62 756 3853 3878 1 2 QDFFN $T=813440 820400 1 0 $X=813440 $Y=814980
X63 749 779 3893 1 2 QDFFN $T=814060 699440 0 0 $X=814060 $Y=699060
X64 748 3832 3929 1 2 QDFFN $T=815300 719600 0 0 $X=815300 $Y=719220
X65 741 3853 3858 1 2 QDFFN $T=826460 790160 1 180 $X=815920 $Y=789780
X66 741 779 3910 1 2 QDFFN $T=816540 719600 1 0 $X=816540 $Y=714180
X67 749 3853 3862 1 2 QDFFN $T=827080 860720 1 180 $X=816540 $Y=860340
X68 740 3832 3864 1 2 QDFFN $T=828320 739760 1 180 $X=817780 $Y=739380
X69 740 779 3863 1 2 QDFFN $T=828940 749840 1 180 $X=818400 $Y=749460
X70 749 3850 3874 1 2 QDFFN $T=829560 759920 0 180 $X=819020 $Y=754500
X71 741 3931 3886 1 2 QDFFN $T=831420 790160 0 180 $X=820880 $Y=784740
X72 749 3923 3943 1 2 QDFFN $T=825220 850640 0 0 $X=825220 $Y=850260
X73 748 779 3952 1 2 QDFFN $T=825840 729680 1 0 $X=825840 $Y=724260
X74 756 3931 3914 1 2 QDFFN $T=836380 820400 0 180 $X=825840 $Y=814980
X75 740 3923 3956 1 2 QDFFN $T=826460 780080 0 0 $X=826460 $Y=779700
X76 771 3931 3924 1 2 QDFFN $T=837620 820400 1 180 $X=827080 $Y=820020
X77 748 3923 3926 1 2 QDFFN $T=838240 840560 1 180 $X=827700 $Y=840180
X78 756 3923 3927 1 2 QDFFN $T=839480 810320 0 180 $X=828940 $Y=804900
X79 749 790 3962 1 2 QDFFN $T=828940 860720 0 0 $X=828940 $Y=860340
X80 740 3944 3959 1 2 QDFFN $T=829560 749840 0 0 $X=829560 $Y=749460
X81 740 3948 3939 1 2 QDFFN $T=840720 739760 1 180 $X=830180 $Y=739380
X82 741 3944 3965 1 2 QDFFN $T=830800 719600 1 0 $X=830800 $Y=714180
X83 756 3944 3961 1 2 QDFFN $T=830800 739760 1 0 $X=830800 $Y=734340
X84 740 3850 3942 1 2 QDFFN $T=841960 770000 0 180 $X=831420 $Y=764580
X85 741 3850 3938 1 2 QDFFN $T=842580 759920 1 180 $X=832040 $Y=759540
X86 741 790 3968 1 2 QDFFN $T=832040 800240 1 0 $X=832040 $Y=794820
X87 771 790 3977 1 2 QDFFN $T=832040 870800 0 0 $X=832040 $Y=870420
X88 749 3948 3964 1 2 QDFFN $T=832660 709520 1 0 $X=832660 $Y=704100
X89 740 3931 3967 1 2 QDFFN $T=833280 770000 0 0 $X=833280 $Y=769620
X90 740 790 3976 1 2 QDFFN $T=833280 790160 1 0 $X=833280 $Y=784740
X91 756 790 3979 1 2 QDFFN $T=833900 810320 0 0 $X=833900 $Y=809940
X92 741 3923 3928 1 2 QDFFN $T=845060 790160 1 180 $X=834520 $Y=789780
X93 748 3931 3932 1 2 QDFFN $T=845060 840560 0 180 $X=834520 $Y=835140
X94 771 3923 3941 1 2 QDFFN $T=845680 830480 1 180 $X=835140 $Y=830100
X95 749 3931 3945 1 2 QDFFN $T=846920 850640 0 180 $X=836380 $Y=845220
X96 748 3944 3998 1 2 QDFFN $T=837000 719600 0 0 $X=837000 $Y=719220
X97 756 3958 3996 1 2 QDFFN $T=838240 820400 1 0 $X=838240 $Y=814980
X98 749 3986 3957 1 2 QDFFN $T=848780 860720 0 180 $X=838240 $Y=855300
X99 748 3958 4003 1 2 QDFFN $T=839480 820400 0 0 $X=839480 $Y=820020
X100 749 3958 3995 1 2 QDFFN $T=839480 870800 1 0 $X=839480 $Y=865380
X101 748 3986 3963 1 2 QDFFN $T=851260 840560 1 180 $X=840720 $Y=840180
X102 741 3958 4005 1 2 QDFFN $T=841960 810320 1 0 $X=841960 $Y=804900
X103 748 3948 4007 1 2 QDFFN $T=843200 719600 1 0 $X=843200 $Y=714180
X104 749 3944 3975 1 2 QDFFN $T=858080 709520 0 180 $X=847540 $Y=704100
X105 741 3986 3988 1 2 QDFFN $T=859320 790160 1 180 $X=848780 $Y=789780
X106 771 3832 4001 1 2 QDFFN $T=860560 759920 0 180 $X=850020 $Y=754500
X107 802 3958 4014 1 2 QDFFN $T=850020 860720 0 0 $X=850020 $Y=860340
X108 756 3986 3991 1 2 QDFFN $T=850640 820400 1 0 $X=850640 $Y=814980
X109 748 790 3997 1 2 QDFFN $T=850640 850640 1 0 $X=850640 $Y=845220
X110 741 3948 3994 1 2 QDFFN $T=861800 709520 1 180 $X=851260 $Y=709140
X111 802 3931 4030 1 2 QDFFN $T=851880 860720 1 0 $X=851880 $Y=855300
X112 771 3986 3989 1 2 QDFFN $T=862420 870800 0 180 $X=851880 $Y=865380
X113 802 779 4021 1 2 QDFFN $T=852500 719600 0 0 $X=852500 $Y=719220
X114 771 3948 4006 1 2 QDFFN $T=863040 739760 1 180 $X=852500 $Y=739380
X115 807 790 4042 1 2 QDFFN $T=852500 820400 0 0 $X=852500 $Y=820020
X116 771 3850 4008 1 2 QDFFN $T=863660 770000 1 180 $X=853120 $Y=769620
X117 740 3986 3987 1 2 QDFFN $T=853740 790160 1 0 $X=853740 $Y=784740
X118 740 3958 4004 1 2 QDFFN $T=853740 800240 0 0 $X=853740 $Y=799860
X119 771 3958 4002 1 2 QDFFN $T=864280 870800 1 180 $X=853740 $Y=870420
X120 802 3853 4048 1 2 QDFFN $T=854360 840560 0 0 $X=854360 $Y=840180
X121 771 3944 4009 1 2 QDFFN $T=865520 739760 0 180 $X=854980 $Y=734340
X122 802 3850 4036 1 2 QDFFN $T=854980 780080 1 0 $X=854980 $Y=774660
X123 809 3958 4056 1 2 QDFFN $T=854980 810320 1 0 $X=854980 $Y=804900
X124 807 3931 4040 1 2 QDFFN $T=856220 830480 0 0 $X=856220 $Y=830100
X125 802 3944 4027 1 2 QDFFN $T=856840 719600 1 0 $X=856840 $Y=714180
X126 802 3833 4044 1 2 QDFFN $T=856840 840560 1 0 $X=856840 $Y=835140
X127 809 3931 4062 1 2 QDFFN $T=858080 780080 0 0 $X=858080 $Y=779700
X128 802 3948 4041 1 2 QDFFN $T=859940 709520 1 0 $X=859940 $Y=704100
X129 771 779 4016 1 2 QDFFN $T=871100 759920 0 180 $X=860560 $Y=754500
X130 802 3923 4038 1 2 QDFFN $T=875440 860720 0 180 $X=864900 $Y=855300
X131 807 3948 4079 1 2 QDFFN $T=866140 709520 0 0 $X=866140 $Y=709140
X132 802 790 4033 1 2 QDFFN $T=876680 870800 1 180 $X=866140 $Y=870420
X133 807 3958 4057 1 2 QDFFN $T=877300 810320 1 180 $X=866760 $Y=809940
X134 802 3986 4043 1 2 QDFFN $T=877300 870800 0 180 $X=866760 $Y=865380
X135 807 822 4084 1 2 QDFFN $T=867380 699440 0 0 $X=867380 $Y=699060
X136 809 3850 4082 1 2 QDFFN $T=867380 780080 1 0 $X=867380 $Y=774660
X137 809 790 4053 1 2 QDFFN $T=877920 810320 0 180 $X=867380 $Y=804900
X138 807 3986 4032 1 2 QDFFN $T=879780 820400 0 180 $X=869240 $Y=814980
X139 809 3948 4094 1 2 QDFFN $T=869860 719600 1 0 $X=869860 $Y=714180
X140 809 3833 4090 1 2 QDFFN $T=869860 790160 1 0 $X=869860 $Y=784740
X141 809 3853 4093 1 2 QDFFN $T=869860 790160 0 0 $X=869860 $Y=789780
X142 807 3923 4060 1 2 QDFFN $T=880400 840560 0 180 $X=869860 $Y=835140
X143 809 3923 4054 1 2 QDFFN $T=881020 780080 1 180 $X=870480 $Y=779700
X144 807 3833 4068 1 2 QDFFN $T=881020 830480 1 180 $X=870480 $Y=830100
X145 812 3986 4111 1 2 QDFFN $T=871100 820400 0 0 $X=871100 $Y=820020
X146 821 3958 4105 1 2 QDFFN $T=871100 860720 0 0 $X=871100 $Y=860340
X147 807 3944 4108 1 2 QDFFN $T=872340 709520 1 0 $X=872340 $Y=704100
X148 821 3944 4119 1 2 QDFFN $T=872340 729680 0 0 $X=872340 $Y=729300
X149 807 3853 4063 1 2 QDFFN $T=883500 830480 0 180 $X=872960 $Y=825060
X150 821 779 4078 1 2 QDFFN $T=884740 749840 0 180 $X=874200 $Y=744420
X151 821 3850 4099 1 2 QDFFN $T=874200 759920 0 0 $X=874200 $Y=759540
X152 821 3832 4080 1 2 QDFFN $T=885980 759920 0 180 $X=875440 $Y=754500
X153 812 3850 4085 1 2 QDFFN $T=887220 770000 0 180 $X=876680 $Y=764580
X154 821 3833 4123 1 2 QDFFN $T=876680 840560 0 0 $X=876680 $Y=840180
X155 821 3923 4126 1 2 QDFFN $T=877300 850640 0 0 $X=877300 $Y=850260
X156 809 3986 4072 1 2 QDFFN $T=877920 800240 0 0 $X=877920 $Y=799860
X157 821 790 4122 1 2 QDFFN $T=878540 870800 0 0 $X=878540 $Y=870420
X158 812 3958 4128 1 2 QDFFN $T=879780 820400 1 0 $X=879780 $Y=814980
X159 812 790 4117 1 2 QDFFN $T=880400 810320 1 0 $X=880400 $Y=804900
X160 821 3853 4135 1 2 QDFFN $T=880400 840560 1 0 $X=880400 $Y=835140
X161 812 3923 4138 1 2 QDFFN $T=881020 780080 0 0 $X=881020 $Y=779700
X162 812 3948 4140 1 2 QDFFN $T=881640 739760 0 0 $X=881640 $Y=739380
X163 805 3986 4172 1 2 QDFFN $T=883500 830480 1 0 $X=883500 $Y=825060
X164 821 3986 4114 1 2 QDFFN $T=894660 860720 1 180 $X=884120 $Y=860340
X165 812 3853 4142 1 2 QDFFN $T=884740 790160 1 0 $X=884740 $Y=784740
X166 805 3832 4149 1 2 QDFFN $T=885360 709520 0 0 $X=885360 $Y=709140
X167 821 3948 4118 1 2 QDFFN $T=895900 719600 1 180 $X=885360 $Y=719220
X168 812 3832 4153 1 2 QDFFN $T=886600 759920 0 0 $X=886600 $Y=759540
X169 805 3958 4169 1 2 QDFFN $T=888460 820400 0 0 $X=888460 $Y=820020
X170 805 3948 4134 1 2 QDFFN $T=899620 729680 1 180 $X=889080 $Y=729300
X171 812 779 4162 1 2 QDFFN $T=889080 749840 0 0 $X=889080 $Y=749460
X172 843 3923 4173 1 2 QDFFN $T=889080 850640 1 0 $X=889080 $Y=845220
X173 805 3850 4158 1 2 QDFFN $T=889700 770000 0 0 $X=889700 $Y=769620
X174 843 790 4163 1 2 QDFFN $T=889700 870800 1 0 $X=889700 $Y=865380
X175 812 3833 4139 1 2 QDFFN $T=900860 800240 1 180 $X=890320 $Y=799860
X176 843 3833 4192 1 2 QDFFN $T=890320 830480 0 0 $X=890320 $Y=830100
X177 821 3931 4133 1 2 QDFFN $T=900860 850640 1 180 $X=890320 $Y=850260
X178 844 3986 4200 1 2 QDFFN $T=891560 820400 1 0 $X=891560 $Y=814980
X179 805 790 4178 1 2 QDFFN $T=892800 810320 1 0 $X=892800 $Y=804900
X180 843 3853 4195 1 2 QDFFN $T=894040 840560 0 0 $X=894040 $Y=840180
X181 805 3833 4154 1 2 QDFFN $T=905820 790160 0 180 $X=895280 $Y=784740
X182 843 3986 4185 1 2 QDFFN $T=897140 860720 1 0 $X=897140 $Y=855300
X183 805 3944 4151 1 2 QDFFN $T=908920 739760 0 180 $X=898380 $Y=734340
X184 812 3944 4148 1 2 QDFFN $T=898380 749840 1 0 $X=898380 $Y=744420
X185 844 3850 4204 1 2 QDFFN $T=899620 780080 1 0 $X=899620 $Y=774660
X186 805 3853 4174 1 2 QDFFN $T=911400 800240 1 180 $X=900860 $Y=799860
X187 844 822 863 1 2 QDFFN $T=901480 709520 1 0 $X=901480 $Y=704100
X188 844 3958 4217 1 2 QDFFN $T=902100 820400 0 0 $X=902100 $Y=820020
X189 843 3850 4186 1 2 QDFFN $T=913880 770000 0 180 $X=903340 $Y=764580
X190 843 3931 4177 1 2 QDFFN $T=913880 850640 1 180 $X=903340 $Y=850260
X191 843 779 4215 1 2 QDFFN $T=904580 759920 1 0 $X=904580 $Y=754500
X192 844 3923 4233 1 2 QDFFN $T=904580 790160 0 0 $X=904580 $Y=789780
X193 858 3986 4187 1 2 QDFFN $T=915120 860720 1 180 $X=904580 $Y=860340
X194 858 3833 4191 1 2 QDFFN $T=915740 830480 0 180 $X=905200 $Y=825060
X195 805 3923 4197 1 2 QDFFN $T=916360 790160 0 180 $X=905820 $Y=784740
X196 858 3853 4218 1 2 QDFFN $T=921320 840560 1 180 $X=910780 $Y=840180
X197 844 3853 4221 1 2 QDFFN $T=921940 800240 1 180 $X=911400 $Y=799860
X198 862 3832 4249 1 2 QDFFN $T=912020 729680 0 0 $X=912020 $Y=729300
X199 843 3948 4222 1 2 QDFFN $T=912640 739760 0 0 $X=912640 $Y=739380
X200 844 790 4205 1 2 QDFFN $T=923800 810320 1 180 $X=913260 $Y=809940
X201 858 3850 4231 1 2 QDFFN $T=924420 770000 0 180 $X=913880 $Y=764580
X202 867 3986 4262 1 2 QDFFN $T=913880 820400 1 0 $X=913880 $Y=814980
X203 844 871 864 1 2 QDFFN $T=925660 709520 0 180 $X=915120 $Y=704100
X204 843 3832 4209 1 2 QDFFN $T=925660 759920 0 180 $X=915120 $Y=754500
X205 844 3833 4223 1 2 QDFFN $T=925660 790160 1 180 $X=915120 $Y=789780
X206 862 3833 4253 1 2 QDFFN $T=915740 820400 0 0 $X=915740 $Y=820020
X207 858 3931 4238 1 2 QDFFN $T=927520 850640 1 180 $X=916980 $Y=850260
X208 862 3850 4266 1 2 QDFFN $T=917600 780080 1 0 $X=917600 $Y=774660
X209 862 779 4265 1 2 QDFFN $T=918220 729680 1 0 $X=918220 $Y=724260
X210 844 779 4196 1 2 QDFFN $T=929380 719600 0 180 $X=918840 $Y=714180
X211 858 3923 4241 1 2 QDFFN $T=931860 850640 0 180 $X=921320 $Y=845220
X212 862 3986 4275 1 2 QDFFN $T=921320 860720 0 0 $X=921320 $Y=860340
X213 858 3832 4269 1 2 QDFFN $T=921940 719600 0 0 $X=921940 $Y=719220
X214 867 3833 4283 1 2 QDFFN $T=921940 800240 1 0 $X=921940 $Y=794820
X215 867 790 4270 1 2 QDFFN $T=921940 800240 0 0 $X=921940 $Y=799860
X216 843 3944 4213 1 2 QDFFN $T=933720 739760 1 180 $X=923180 $Y=739380
X217 862 3923 4248 1 2 QDFFN $T=933720 840560 1 180 $X=923180 $Y=840180
X218 867 3832 4279 1 2 QDFFN $T=925660 759920 1 0 $X=925660 $Y=754500
X219 867 822 880 1 2 QDFFN $T=926900 699440 0 0 $X=926900 $Y=699060
X220 867 779 4274 1 2 QDFFN $T=927520 749840 0 0 $X=927520 $Y=749460
X221 862 3853 4243 1 2 QDFFN $T=938060 830480 0 180 $X=927520 $Y=825060
X222 862 3958 4293 1 2 QDFFN $T=927520 870800 0 0 $X=927520 $Y=870420
X223 862 790 4282 1 2 QDFFN $T=930000 850640 0 0 $X=930000 $Y=850260
X224 862 3944 4281 1 2 QDFFN $T=941160 709520 1 180 $X=930620 $Y=709140
X225 862 3931 4271 1 2 QDFFN $T=930620 830480 0 0 $X=930620 $Y=830100
X226 867 3958 4297 1 2 QDFFN $T=931240 820400 1 0 $X=931240 $Y=814980
X227 867 3850 4307 1 2 QDFFN $T=933100 759920 0 0 $X=933100 $Y=759540
X228 867 3948 4304 1 2 QDFFN $T=934960 729680 0 0 $X=934960 $Y=729300
X229 862 3948 4296 1 2 QDFFN $T=946740 719600 1 180 $X=936200 $Y=719220
X230 867 3944 4299 1 2 QDFFN $T=938680 739760 0 0 $X=938680 $Y=739380
X231 858 3944 4306 1 2 QDFFN $T=941160 699440 0 0 $X=941160 $Y=699060
X232 858 3948 4309 1 2 QDFFN $T=951700 709520 1 180 $X=941160 $Y=709140
X233 897 4364 4380 1 2 QDFFN $T=952320 800240 1 0 $X=952320 $Y=794820
X234 897 899 4398 1 2 QDFFN $T=954180 820400 1 0 $X=954180 $Y=814980
X235 909 4393 4367 1 2 QDFFN $T=965340 709520 1 180 $X=954800 $Y=709140
X236 900 4395 4368 1 2 QDFFN $T=965340 840560 0 180 $X=954800 $Y=835140
X237 900 4364 4419 1 2 QDFFN $T=956040 830480 1 0 $X=956040 $Y=825060
X238 900 905 4379 1 2 QDFFN $T=967200 870800 0 180 $X=956660 $Y=865380
X239 900 4406 4383 1 2 QDFFN $T=967820 860720 0 180 $X=957280 $Y=855300
X240 897 905 4409 1 2 QDFFN $T=958520 810320 1 0 $X=958520 $Y=804900
X241 4373 907 4425 1 2 QDFFN $T=959140 729680 0 0 $X=959140 $Y=729300
X242 4373 4395 4435 1 2 QDFFN $T=961000 790160 1 0 $X=961000 $Y=784740
X243 900 899 4423 1 2 QDFFN $T=961000 880880 1 0 $X=961000 $Y=875460
X244 4373 916 4396 1 2 QDFFN $T=973400 739760 1 180 $X=962860 $Y=739380
X245 4373 919 4401 1 2 QDFFN $T=974640 719600 1 180 $X=964100 $Y=719220
X246 897 4434 4405 1 2 QDFFN $T=975260 800240 0 180 $X=964720 $Y=794820
X247 909 4412 4442 1 2 QDFFN $T=965340 840560 1 0 $X=965340 $Y=835140
X248 897 4395 4385 1 2 QDFFN $T=977120 790160 1 180 $X=966580 $Y=789780
X249 909 4443 4404 1 2 QDFFN $T=977740 709520 1 180 $X=967200 $Y=709140
X250 4373 4393 4453 1 2 QDFFN $T=968440 749840 0 0 $X=968440 $Y=749460
X251 897 4437 4415 1 2 QDFFN $T=979600 759920 0 180 $X=969060 $Y=754500
X252 897 4406 4417 1 2 QDFFN $T=980220 810320 1 180 $X=969680 $Y=809940
X253 909 4406 4454 1 2 QDFFN $T=970300 860720 1 0 $X=970300 $Y=855300
X254 909 4437 4461 1 2 QDFFN $T=971540 759920 0 0 $X=971540 $Y=759540
X255 897 4412 4431 1 2 QDFFN $T=982080 800240 1 180 $X=971540 $Y=799860
X256 909 4364 4467 1 2 QDFFN $T=972160 850640 1 0 $X=972160 $Y=845220
X257 909 899 4460 1 2 QDFFN $T=972780 880880 1 0 $X=972780 $Y=875460
X258 4373 923 4439 1 2 QDFFN $T=983940 729680 1 180 $X=973400 $Y=729300
X259 897 4393 4428 1 2 QDFFN $T=984560 709520 0 180 $X=974020 $Y=704100
X260 909 905 4449 1 2 QDFFN $T=974020 870800 0 0 $X=974020 $Y=870420
X261 4373 921 4471 1 2 QDFFN $T=974640 719600 0 0 $X=974640 $Y=719220
X262 909 4395 4472 1 2 QDFFN $T=974640 850640 0 0 $X=974640 $Y=850260
X263 909 4434 4459 1 2 QDFFN $T=976500 830480 0 0 $X=976500 $Y=830100
X264 4373 4443 4455 1 2 QDFFN $T=990140 749840 1 180 $X=979600 $Y=749460
X265 925 4364 4487 1 2 QDFFN $T=982080 860720 1 0 $X=982080 $Y=855300
X266 4373 4412 4481 1 2 QDFFN $T=982700 810320 0 0 $X=982700 $Y=809940
X267 4373 4437 4462 1 2 QDFFN $T=993860 759920 0 180 $X=983320 $Y=754500
X268 925 4406 4484 1 2 QDFFN $T=983320 860720 0 0 $X=983320 $Y=860340
X269 926 4443 4500 1 2 QDFFN $T=985180 699440 0 0 $X=985180 $Y=699060
X270 4373 930 4468 1 2 QDFFN $T=995720 719600 1 180 $X=985180 $Y=719220
X271 4373 4364 4474 1 2 QDFFN $T=995720 790160 1 180 $X=985180 $Y=789780
X272 4373 4434 4475 1 2 QDFFN $T=995720 810320 0 180 $X=985180 $Y=804900
X273 925 905 4488 1 2 QDFFN $T=985180 880880 1 0 $X=985180 $Y=875460
X274 897 4443 4433 1 2 QDFFN $T=985800 719600 1 0 $X=985800 $Y=714180
X275 4373 899 4441 1 2 QDFFN $T=996340 830480 0 180 $X=985800 $Y=825060
X276 4373 4406 4445 1 2 QDFFN $T=997580 820400 0 180 $X=987040 $Y=814980
X277 4361 923 4480 1 2 QDFFN $T=999440 739760 1 180 $X=988900 $Y=739380
X278 4361 4434 4502 1 2 QDFFN $T=990140 800240 0 0 $X=990140 $Y=799860
X279 900 4434 4483 1 2 QDFFN $T=1000680 830480 1 180 $X=990140 $Y=830100
X280 4361 4393 4489 1 2 QDFFN $T=1001920 759920 1 180 $X=991380 $Y=759540
X281 4361 4443 4485 1 2 QDFFN $T=1002540 749840 1 180 $X=992000 $Y=749460
X282 900 4437 4482 1 2 QDFFN $T=1002540 770000 1 180 $X=992000 $Y=769620
X283 925 4395 4493 1 2 QDFFN $T=1005640 860720 0 180 $X=995100 $Y=855300
X284 4361 919 4499 1 2 QDFFN $T=1006880 719600 1 180 $X=996340 $Y=719220
X285 4361 4364 4526 1 2 QDFFN $T=996340 790160 1 0 $X=996340 $Y=784740
X286 4373 905 4451 1 2 QDFFN $T=996340 830480 1 0 $X=996340 $Y=825060
X287 926 4406 4535 1 2 QDFFN $T=996340 860720 0 0 $X=996340 $Y=860340
X288 926 4393 4503 1 2 QDFFN $T=1007500 709520 1 180 $X=996960 $Y=709140
X289 4361 921 4530 1 2 QDFFN $T=997580 719600 1 0 $X=997580 $Y=714180
X290 4361 907 4505 1 2 QDFFN $T=1008120 739760 0 180 $X=997580 $Y=734340
X291 4361 4406 4527 1 2 QDFFN $T=997580 820400 1 0 $X=997580 $Y=814980
X292 926 905 4537 1 2 QDFFN $T=997580 870800 0 0 $X=997580 $Y=870420
X293 926 899 4554 1 2 QDFFN $T=1000060 880880 1 0 $X=1000060 $Y=875460
X294 900 916 4542 1 2 QDFFN $T=1000680 749840 1 0 $X=1000680 $Y=744420
X295 4361 4412 4511 1 2 QDFFN $T=1011220 810320 0 180 $X=1000680 $Y=804900
X296 925 4434 4546 1 2 QDFFN $T=1000680 850640 1 0 $X=1000680 $Y=845220
X297 4361 4395 4545 1 2 QDFFN $T=1001300 790160 0 0 $X=1001300 $Y=789780
X298 936 4434 4548 1 2 QDFFN $T=1001920 800240 0 0 $X=1001920 $Y=799860
X299 925 4412 4549 1 2 QDFFN $T=1001920 840560 1 0 $X=1001920 $Y=835140
X300 925 4443 4550 1 2 QDFFN $T=1002540 699440 0 0 $X=1002540 $Y=699060
X301 900 921 4560 1 2 QDFFN $T=1003780 729680 1 0 $X=1003780 $Y=724260
X302 900 4393 4558 1 2 QDFFN $T=1004400 759920 0 0 $X=1004400 $Y=759540
X303 900 4443 4561 1 2 QDFFN $T=1005020 749840 0 0 $X=1005020 $Y=749460
X304 925 4437 4543 1 2 QDFFN $T=1005020 780080 1 0 $X=1005020 $Y=774660
X305 4361 4437 4517 1 2 QDFFN $T=1016180 770000 0 180 $X=1005640 $Y=764580
X306 936 4406 4552 1 2 QDFFN $T=1006260 830480 0 0 $X=1006260 $Y=830100
X307 4361 905 4525 1 2 QDFFN $T=1017420 830480 0 180 $X=1006880 $Y=825060
X308 4361 930 4534 1 2 QDFFN $T=1018660 719600 0 180 $X=1008120 $Y=714180
X309 926 4364 4556 1 2 QDFFN $T=1008120 860720 1 0 $X=1008120 $Y=855300
X310 936 899 4538 1 2 QDFFN $T=1019280 820400 0 180 $X=1008740 $Y=814980
X311 926 4395 4541 1 2 QDFFN $T=1019900 860720 1 180 $X=1009360 $Y=860340
X312 900 919 4570 1 2 QDFFN $T=1009980 739760 1 0 $X=1009980 $Y=734340
X313 925 4393 4575 1 2 QDFFN $T=1011220 709520 0 0 $X=1011220 $Y=709140
X314 4361 916 4491 1 2 QDFFN $T=1021760 729680 1 180 $X=1011220 $Y=729300
X315 926 4437 4531 1 2 QDFFN $T=1022380 770000 1 180 $X=1011840 $Y=769620
X316 936 4412 4551 1 2 QDFFN $T=1023620 810320 0 180 $X=1013080 $Y=804900
X317 926 4412 4576 1 2 QDFFN $T=1014940 840560 1 0 $X=1014940 $Y=835140
X318 900 4412 4494 1 2 QDFFN $T=1014940 840560 0 0 $X=1014940 $Y=840180
X319 936 4443 4580 1 2 QDFFN $T=1015560 709520 1 0 $X=1015560 $Y=704100
X320 936 4395 4562 1 2 QDFFN $T=1026720 790160 0 180 $X=1016180 $Y=784740
X321 926 4434 4573 1 2 QDFFN $T=1016180 850640 0 0 $X=1016180 $Y=850260
X322 936 4437 4566 1 2 QDFFN $T=1027960 759920 1 180 $X=1017420 $Y=759540
X323 4361 899 4536 1 2 QDFFN $T=1017420 820400 0 0 $X=1017420 $Y=820020
X324 936 905 4555 1 2 QDFFN $T=1027960 830480 0 180 $X=1017420 $Y=825060
X325 936 4393 4583 1 2 QDFFN $T=1018660 719600 1 0 $X=1018660 $Y=714180
X326 936 4364 4567 1 2 QDFFN $T=1029200 780080 0 180 $X=1018660 $Y=774660
X327 935 4406 4603 1 2 QDFFN $T=1018660 830480 0 0 $X=1018660 $Y=830100
X328 4569 905 4596 1 2 QDFFN $T=1019900 870800 0 0 $X=1019900 $Y=870420
X329 4569 923 4592 1 2 QDFFN $T=1020520 749840 1 0 $X=1020520 $Y=744420
X330 935 899 4593 1 2 QDFFN $T=1021140 820400 1 0 $X=1021140 $Y=814980
X331 4569 4364 4604 1 2 QDFFN $T=1021140 860720 1 0 $X=1021140 $Y=855300
X332 4569 919 4589 1 2 QDFFN $T=1021760 729680 0 0 $X=1021760 $Y=729300
X333 935 4434 4608 1 2 QDFFN $T=1021760 800240 0 0 $X=1021760 $Y=799860
X334 4569 4434 4620 1 2 QDFFN $T=1021760 850640 1 0 $X=1021760 $Y=845220
X335 935 4437 4595 1 2 QDFFN $T=1022380 770000 0 0 $X=1022380 $Y=769620
X336 4569 4395 4598 1 2 QDFFN $T=1022380 860720 0 0 $X=1022380 $Y=860340
X337 4569 907 4594 1 2 QDFFN $T=1023000 739760 0 0 $X=1023000 $Y=739380
X338 4569 4393 4630 1 2 QDFFN $T=1023620 759920 1 0 $X=1023620 $Y=754500
X339 935 4395 4599 1 2 QDFFN $T=1024240 790160 0 0 $X=1024240 $Y=789780
X340 935 4393 4585 1 2 QDFFN $T=1036640 709520 1 180 $X=1026100 $Y=709140
X341 935 4412 4613 1 2 QDFFN $T=1026100 810320 1 0 $X=1026100 $Y=804900
X342 4569 4412 4631 1 2 QDFFN $T=1028580 840560 1 0 $X=1028580 $Y=835140
X343 4569 4443 4633 1 2 QDFFN $T=1030440 759920 0 0 $X=1030440 $Y=759540
X344 4569 930 4627 1 2 QDFFN $T=1031060 719600 1 0 $X=1031060 $Y=714180
X345 4569 4437 4601 1 2 QDFFN $T=1041600 770000 0 180 $X=1031060 $Y=764580
X346 935 4364 4605 1 2 QDFFN $T=1042840 780080 1 180 $X=1032300 $Y=779700
X347 935 4443 4588 1 2 QDFFN $T=1044080 709520 0 180 $X=1033540 $Y=704100
X348 935 905 4611 1 2 QDFFN $T=1044700 830480 0 180 $X=1034160 $Y=825060
X349 953 919 4661 1 2 QDFFN $T=1034780 729680 0 0 $X=1034780 $Y=729300
X350 952 4395 4641 1 2 QDFFN $T=1034780 790160 1 0 $X=1034780 $Y=784740
X351 952 899 4642 1 2 QDFFN $T=1034780 810320 0 0 $X=1034780 $Y=809940
X352 4569 4406 4618 1 2 QDFFN $T=1045320 870800 0 180 $X=1034780 $Y=865380
X353 4569 916 4619 1 2 QDFFN $T=1045940 739760 1 180 $X=1035400 $Y=739380
X354 953 916 4652 1 2 QDFFN $T=1036020 739760 1 0 $X=1036020 $Y=734340
X355 952 4434 4670 1 2 QDFFN $T=1037880 800240 1 0 $X=1037880 $Y=794820
X356 4569 899 4637 1 2 QDFFN $T=1037880 880880 1 0 $X=1037880 $Y=875460
X357 957 4393 4657 1 2 QDFFN $T=1038500 709520 0 0 $X=1038500 $Y=709140
X358 952 4412 4664 1 2 QDFFN $T=1039120 810320 1 0 $X=1039120 $Y=804900
X359 952 4437 4649 1 2 QDFFN $T=1040980 780080 1 0 $X=1040980 $Y=774660
X360 953 4412 4669 1 2 QDFFN $T=1040980 840560 1 0 $X=1040980 $Y=835140
X361 953 4393 4691 1 2 QDFFN $T=1041600 759920 1 0 $X=1041600 $Y=754500
X362 952 4406 4668 1 2 QDFFN $T=1041600 820400 0 0 $X=1041600 $Y=820020
X363 953 4434 4671 1 2 QDFFN $T=1041600 830480 0 0 $X=1041600 $Y=830100
X364 953 930 4640 1 2 QDFFN $T=1054000 719600 0 180 $X=1043460 $Y=714180
X365 953 4437 4638 1 2 QDFFN $T=1054000 759920 1 180 $X=1043460 $Y=759540
X366 953 4406 4688 1 2 QDFFN $T=1044700 870800 0 0 $X=1044700 $Y=870420
X367 953 923 4645 1 2 QDFFN $T=1055860 749840 1 180 $X=1045320 $Y=749460
X368 952 4364 4643 1 2 QDFFN $T=1055860 780080 1 180 $X=1045320 $Y=779700
X369 957 4443 4676 1 2 QDFFN $T=1045940 709520 1 0 $X=1045940 $Y=704100
X370 952 905 4655 1 2 QDFFN $T=1058340 830480 0 180 $X=1047800 $Y=825060
X371 953 4395 4681 1 2 QDFFN $T=1047800 870800 1 0 $X=1047800 $Y=865380
X372 953 4364 4690 1 2 QDFFN $T=1049040 860720 1 0 $X=1049040 $Y=855300
X373 953 907 4666 1 2 QDFFN $T=1060200 739760 0 180 $X=1049660 $Y=734340
X374 957 4434 4675 1 2 QDFFN $T=1062060 790160 1 180 $X=1051520 $Y=789780
X375 953 921 4651 1 2 QDFFN $T=1062680 729680 0 180 $X=1052140 $Y=724260
X376 953 905 4697 1 2 QDFFN $T=1052760 880880 1 0 $X=1052760 $Y=875460
X377 957 4437 4677 1 2 QDFFN $T=1064540 780080 0 180 $X=1054000 $Y=774660
X378 957 4412 4678 1 2 QDFFN $T=1064540 810320 0 180 $X=1054000 $Y=804900
X379 969 4412 4680 1 2 QDFFN $T=1064540 840560 0 180 $X=1054000 $Y=835140
X380 969 916 4703 1 2 QDFFN $T=1054620 739760 0 0 $X=1054620 $Y=739380
X381 970 4434 4698 1 2 QDFFN $T=1054620 820400 0 0 $X=1054620 $Y=820020
X382 957 899 4699 1 2 QDFFN $T=1055860 810320 0 0 $X=1055860 $Y=809940
X383 970 4412 4701 1 2 QDFFN $T=1055860 830480 0 0 $X=1055860 $Y=830100
X384 969 930 4700 1 2 QDFFN $T=1056480 719600 1 0 $X=1056480 $Y=714180
X385 953 4443 4694 1 2 QDFFN $T=1056480 759920 0 0 $X=1056480 $Y=759540
X386 969 4434 4689 1 2 QDFFN $T=1067020 850640 0 180 $X=1056480 $Y=845220
X387 952 4393 4686 1 2 QDFFN $T=1067640 709520 1 180 $X=1057100 $Y=709140
X388 969 919 4716 1 2 QDFFN $T=1057720 729680 0 0 $X=1057720 $Y=729300
X389 952 4443 4692 1 2 QDFFN $T=1068880 699440 1 180 $X=1058340 $Y=699060
X390 969 923 4711 1 2 QDFFN $T=1058340 749840 0 0 $X=1058340 $Y=749460
X391 969 4437 4706 1 2 QDFFN $T=1058340 770000 1 0 $X=1058340 $Y=764580
X392 957 4364 4693 1 2 QDFFN $T=1068880 780080 1 180 $X=1058340 $Y=779700
X393 969 4364 4718 1 2 QDFFN $T=1062060 860720 1 0 $X=1062060 $Y=855300
X394 969 907 4733 1 2 QDFFN $T=1062680 739760 1 0 $X=1062680 $Y=734340
X395 969 4443 4734 1 2 QDFFN $T=1062680 759920 1 0 $X=1062680 $Y=754500
X396 967 4434 4729 1 2 QDFFN $T=1063300 790160 0 0 $X=1063300 $Y=789780
X397 957 905 4725 1 2 QDFFN $T=1063300 800240 0 0 $X=1063300 $Y=799860
X398 967 4443 4728 1 2 QDFFN $T=1064540 709520 1 0 $X=1064540 $Y=704100
X399 969 921 4714 1 2 QDFFN $T=1065160 729680 1 0 $X=1065160 $Y=724260
X400 969 4395 4722 1 2 QDFFN $T=1065160 860720 0 0 $X=1065160 $Y=860340
X401 957 4395 4696 1 2 QDFFN $T=1065780 790160 1 0 $X=1065780 $Y=784740
X402 973 4412 4730 1 2 QDFFN $T=1066400 840560 0 0 $X=1066400 $Y=840180
X403 967 4412 4755 1 2 QDFFN $T=1067020 810320 1 0 $X=1067020 $Y=804900
X404 969 4406 4717 1 2 QDFFN $T=1068260 870800 1 0 $X=1068260 $Y=865380
X405 957 4406 4719 1 2 QDFFN $T=1068880 820400 1 0 $X=1068880 $Y=814980
X406 969 4393 4754 1 2 QDFFN $T=1069500 759920 0 0 $X=1069500 $Y=759540
X407 973 4434 4710 1 2 QDFFN $T=1069500 830480 0 0 $X=1069500 $Y=830100
X408 967 4393 4715 1 2 QDFFN $T=1080660 709520 1 180 $X=1070120 $Y=709140
X409 970 4437 4724 1 2 QDFFN $T=1081900 780080 1 180 $X=1071360 $Y=779700
X410 973 923 4764 1 2 QDFFN $T=1074460 739760 0 0 $X=1074460 $Y=739380
X411 973 930 4742 1 2 QDFFN $T=1086240 719600 1 180 $X=1075700 $Y=719220
X412 970 4395 4736 1 2 QDFFN $T=1080660 840560 1 0 $X=1080660 $Y=835140
X413 973 4395 4746 1 2 QDFFN $T=1080660 860720 0 0 $X=1080660 $Y=860340
X414 973 4406 4758 1 2 QDFFN $T=1081900 870800 1 0 $X=1081900 $Y=865380
X415 973 4437 4772 1 2 QDFFN $T=1082520 770000 1 0 $X=1082520 $Y=764580
X416 967 4437 4766 1 2 QDFFN $T=1082520 780080 1 0 $X=1082520 $Y=774660
X417 967 899 4770 1 2 QDFFN $T=1082520 810320 1 0 $X=1082520 $Y=804900
X418 970 4406 4748 1 2 QDFFN $T=1082520 820400 1 0 $X=1082520 $Y=814980
X419 970 4364 4757 1 2 QDFFN $T=1082520 850640 1 0 $X=1082520 $Y=845220
X420 970 916 982 1 2 QDFFN $T=1083140 699440 0 0 $X=1083140 $Y=699060
X421 970 4393 4767 1 2 QDFFN $T=1083140 709520 0 0 $X=1083140 $Y=709140
X422 973 921 4761 1 2 QDFFN $T=1083140 729680 1 0 $X=1083140 $Y=724260
X423 973 919 4762 1 2 QDFFN $T=1083140 729680 0 0 $X=1083140 $Y=729300
X424 973 907 4769 1 2 QDFFN $T=1083140 739760 1 0 $X=1083140 $Y=734340
X425 973 4443 4760 1 2 QDFFN $T=1083140 759920 0 0 $X=1083140 $Y=759540
X426 967 4364 4773 1 2 QDFFN $T=1083140 780080 0 0 $X=1083140 $Y=779700
X427 967 4395 4765 1 2 QDFFN $T=1083140 790160 0 0 $X=1083140 $Y=789780
X428 967 905 4753 1 2 QDFFN $T=1083140 800240 1 0 $X=1083140 $Y=794820
X429 970 905 4741 1 2 QDFFN $T=1083140 830480 1 0 $X=1083140 $Y=825060
X430 970 899 4768 1 2 QDFFN $T=1083140 830480 0 0 $X=1083140 $Y=830100
X431 973 4364 4774 1 2 QDFFN $T=1083140 850640 0 0 $X=1083140 $Y=850260
X432 970 4443 4759 1 2 QDFFN $T=1083760 709520 1 0 $X=1083760 $Y=704100
X433 973 916 4775 1 2 QDFFN $T=1083760 749840 1 0 $X=1083760 $Y=744420
X434 973 4393 4771 1 2 QDFFN $T=1083760 759920 1 0 $X=1083760 $Y=754500
X435 967 4406 4756 1 2 QDFFN $T=1083760 810320 0 0 $X=1083760 $Y=809940
X436 1161 1146 1165 1125 1 1118 2 AOI22S $T=246140 820400 1 0 $X=246140 $Y=814980
X437 369 2557 366 2558 1 2554 2 AOI22S $T=544360 699440 1 180 $X=540640 $Y=699060
X438 2557 375 2584 2564 1 2567 2 AOI22S $T=548080 749840 0 180 $X=544360 $Y=744420
X439 410 2557 2630 2617 1 2611 2 AOI22S $T=557380 719600 0 180 $X=553660 $Y=714180
X440 296 413 414 2649 1 2595 2 AOI22S $T=564200 699440 1 180 $X=560480 $Y=699060
X441 2557 375 2646 2631 1 2653 2 AOI22S $T=560480 749840 1 0 $X=560480 $Y=744420
X442 407 413 409 2639 1 2658 2 AOI22S $T=561100 709520 0 0 $X=561100 $Y=709140
X443 375 443 2718 2693 1 2641 2 AOI22S $T=575360 739760 0 180 $X=571640 $Y=734340
X444 2652 2705 444 2716 1 375 2 AOI22S $T=572880 739760 0 0 $X=572880 $Y=739380
X445 2728 2668 460 466 1 473 2 AOI22S $T=578460 870800 1 0 $X=578460 $Y=865380
X446 434 2719 2736 466 1 473 2 AOI22S $T=579700 860720 0 0 $X=579700 $Y=860340
X447 487 2705 2737 2781 1 2778 2 AOI22S $T=590240 749840 1 180 $X=586520 $Y=749460
X448 2770 2787 486 466 1 473 2 AOI22S $T=589000 880880 1 0 $X=589000 $Y=875460
X449 2756 2793 2808 466 1 473 2 AOI22S $T=592100 850640 0 0 $X=592100 $Y=850260
X450 2689 2816 2809 466 1 473 2 AOI22S $T=592100 870800 0 0 $X=592100 $Y=870420
X451 2779 2814 2823 466 1 473 2 AOI22S $T=595820 850640 1 0 $X=595820 $Y=845220
X452 410 407 2831 2791 1 2842 2 AOI22S $T=598920 719600 1 0 $X=598920 $Y=714180
X453 2834 2848 2843 466 1 473 2 AOI22S $T=600160 840560 0 0 $X=600160 $Y=840180
X454 507 508 2845 510 1 514 2 AOI22S $T=602020 870800 0 0 $X=602020 $Y=870420
X455 2705 511 2621 2854 1 2852 2 AOI22S $T=602640 739760 0 0 $X=602640 $Y=739380
X456 2825 2844 2855 466 1 473 2 AOI22S $T=603260 850640 0 0 $X=603260 $Y=850260
X457 2705 511 516 2884 1 2881 2 AOI22S $T=605740 729680 0 0 $X=605740 $Y=729300
X458 2867 2880 2882 466 1 473 2 AOI22S $T=607600 850640 0 0 $X=607600 $Y=850260
X459 2872 2893 2890 466 1 473 2 AOI22S $T=609460 850640 1 0 $X=609460 $Y=845220
X460 528 2894 2896 510 1 514 2 AOI22S $T=610700 870800 0 0 $X=610700 $Y=870420
X461 545 2906 2905 510 1 514 2 AOI22S $T=619380 870800 1 180 $X=615660 $Y=870420
X462 2870 2913 2917 466 1 473 2 AOI22S $T=617520 840560 0 0 $X=617520 $Y=840180
X463 564 2928 2973 510 1 578 2 AOI22S $T=633020 870800 1 0 $X=633020 $Y=865380
X464 487 511 3020 2897 1 2988 2 AOI22S $T=638600 719600 1 180 $X=634880 $Y=719220
X465 3005 2983 2911 510 1 578 2 AOI22S $T=637980 870800 1 0 $X=637980 $Y=865380
X466 591 487 3011 2919 1 595 2 AOI22S $T=644800 709520 1 0 $X=644800 $Y=704100
X467 3058 2944 3048 510 1 578 2 AOI22S $T=648520 870800 0 180 $X=644800 $Y=865380
X468 3067 3078 3090 577 1 580 2 AOI22S $T=655340 729680 0 0 $X=655340 $Y=729300
X469 3087 3038 3065 606 1 578 2 AOI22S $T=655340 870800 1 0 $X=655340 $Y=865380
X470 3069 3097 3061 577 1 580 2 AOI22S $T=656580 749840 1 0 $X=656580 $Y=744420
X471 3119 3112 3104 577 1 580 2 AOI22S $T=662780 739760 0 180 $X=659060 $Y=734340
X472 3102 3114 3095 577 1 580 2 AOI22S $T=660300 729680 1 0 $X=660300 $Y=724260
X473 3180 3132 3116 606 1 578 2 AOI22S $T=673940 870800 0 180 $X=670220 $Y=865380
X474 3190 614 3088 606 1 578 2 AOI22S $T=673940 880880 0 180 $X=670220 $Y=875460
X475 3192 3161 3187 573 1 580 2 AOI22S $T=676420 719600 0 180 $X=672700 $Y=714180
X476 3221 3228 622 573 1 580 2 AOI22S $T=682000 699440 0 0 $X=682000 $Y=699060
X477 3265 3251 3284 573 1 3111 2 AOI22S $T=691920 810320 1 0 $X=691920 $Y=804900
X478 3325 3314 3320 573 1 3111 2 AOI22S $T=699980 810320 0 180 $X=696260 $Y=804900
X479 3378 3378 3353 3390 1 3399 2 AOI22S $T=708040 820400 1 0 $X=708040 $Y=814980
X480 3379 3379 3352 3390 1 3399 2 AOI22S $T=708040 820400 0 0 $X=708040 $Y=820020
X481 3404 3404 3408 3390 1 3399 2 AOI22S $T=711140 800240 0 0 $X=711140 $Y=799860
X482 3370 3394 3358 573 1 3111 2 AOI22S $T=711760 790160 1 0 $X=711760 $Y=784740
X483 3449 3442 3458 573 1 3111 2 AOI22S $T=720440 790160 0 180 $X=716720 $Y=784740
X484 3444 3444 3439 3390 1 3399 2 AOI22S $T=718580 800240 0 0 $X=718580 $Y=799860
X485 3425 3425 3467 3390 1 3399 2 AOI22S $T=722920 800240 0 0 $X=722920 $Y=799860
X486 3292 3292 3469 3390 1 3399 2 AOI22S $T=722920 810320 1 0 $X=722920 $Y=804900
X487 3460 3462 3470 573 1 3111 2 AOI22S $T=723540 790160 1 0 $X=723540 $Y=784740
X488 3359 3359 3483 3390 1 3399 2 AOI22S $T=725400 820400 1 0 $X=725400 $Y=814980
X489 3416 3416 3508 3390 1 3399 2 AOI22S $T=730980 800240 1 180 $X=727260 $Y=799860
X490 3562 3575 3572 573 1 3111 2 AOI22S $T=743380 810320 1 0 $X=743380 $Y=804900
X491 3615 3605 3537 573 1 3111 2 AOI22S $T=751440 810320 0 180 $X=747720 $Y=804900
X492 3600 3604 3542 573 1 3111 2 AOI22S $T=748960 790160 1 0 $X=748960 $Y=784740
X493 3606 670 3602 3611 1 679 2 AOI22S $T=749580 719600 0 0 $X=749580 $Y=719220
X494 3619 3608 3576 3611 1 3606 2 AOI22S $T=753920 749840 1 180 $X=750200 $Y=749460
X495 678 686 3645 3643 1 3611 2 AOI22S $T=760120 719600 0 180 $X=756400 $Y=714180
X496 3616 3646 3610 3643 1 3611 2 AOI22S $T=756400 739760 1 0 $X=756400 $Y=734340
X497 3619 3646 3630 3611 1 3625 2 AOI22S $T=758260 749840 0 0 $X=758260 $Y=749460
X498 3617 3668 3659 3643 1 3611 2 AOI22S $T=761360 759920 0 0 $X=761360 $Y=759540
X499 3633 3619 3653 3671 1 3674 2 AOI22S $T=761980 759920 1 0 $X=761980 $Y=754500
X500 3668 3617 3679 3235 1 3365 2 AOI22S $T=766320 770000 1 180 $X=762600 $Y=769620
X501 3633 3668 3640 3671 1 3624 2 AOI22S $T=765080 749840 0 0 $X=765080 $Y=749460
X502 3619 3668 3682 3235 1 3365 2 AOI22S $T=765700 759920 0 0 $X=765700 $Y=759540
X503 713 679 3691 3671 1 3674 2 AOI22S $T=770660 729680 0 180 $X=766940 $Y=724260
X504 3633 3617 3687 3222 1 3689 2 AOI22S $T=768180 759920 1 0 $X=768180 $Y=754500
X505 679 686 3707 3611 1 3625 2 AOI22S $T=773140 719600 0 180 $X=769420 $Y=714180
X506 3611 3643 3711 721 1 690 2 AOI22S $T=771280 729680 1 0 $X=771280 $Y=724260
X507 713 721 3705 3671 1 3624 2 AOI22S $T=775000 729680 1 180 $X=771280 $Y=729300
X508 3729 3726 3721 577 1 3111 2 AOI22S $T=776860 780080 1 180 $X=773140 $Y=779700
X509 3365 3235 3724 690 1 721 2 AOI22S $T=774380 749840 0 0 $X=774380 $Y=749460
X510 3365 3235 3725 721 1 679 2 AOI22S $T=774380 759920 1 0 $X=774380 $Y=754500
X511 3737 3727 3717 577 1 3111 2 AOI22S $T=778100 780080 0 180 $X=774380 $Y=774660
X512 713 3222 3760 690 1 3689 2 AOI22S $T=782440 759920 0 180 $X=778720 $Y=754500
X513 3754 745 744 577 1 3111 2 AOI22S $T=788640 699440 0 0 $X=788640 $Y=699060
X514 3713 3769 3782 577 1 3111 2 AOI22S $T=791740 759920 0 0 $X=791740 $Y=759540
X515 3734 3797 3794 577 1 3111 2 AOI22S $T=793600 719600 0 0 $X=793600 $Y=719220
X516 3803 3804 3808 577 1 3111 2 AOI22S $T=797320 739760 0 180 $X=793600 $Y=734340
X517 3790 3805 3801 577 1 3111 2 AOI22S $T=794840 699440 0 0 $X=794840 $Y=699060
X518 3809 3781 3820 577 1 3111 2 AOI22S $T=801040 749840 1 180 $X=797320 $Y=749460
X519 3854 3840 3855 3861 1 3870 2 AOI22S $T=815300 780080 0 0 $X=815300 $Y=779700
X520 3866 3876 3868 3861 1 3870 2 AOI22S $T=818400 840560 1 0 $X=818400 $Y=835140
X521 3856 3858 3871 3861 1 3870 2 AOI22S $T=819020 800240 0 0 $X=819020 $Y=799860
X522 3859 3878 3875 3861 1 3870 2 AOI22S $T=819020 810320 0 0 $X=819020 $Y=809940
X523 3857 3880 3872 3861 1 3870 2 AOI22S $T=819020 830480 0 0 $X=819020 $Y=830100
X524 3860 3862 3873 3861 1 3870 2 AOI22S $T=819020 850640 0 0 $X=819020 $Y=850260
X525 3863 3864 3881 3888 1 3889 2 AOI22S $T=820260 749840 1 0 $X=820260 $Y=744420
X526 3910 3847 3925 3888 1 3889 2 AOI22S $T=826460 709520 1 180 $X=822740 $Y=709140
X527 3874 3897 3892 3898 1 3919 2 AOI22S $T=822740 759920 0 0 $X=822740 $Y=759540
X528 3884 3901 3899 3898 1 3919 2 AOI22S $T=823980 780080 1 0 $X=823980 $Y=774660
X529 3883 3894 3905 3888 1 3889 2 AOI22S $T=824600 729680 0 0 $X=824600 $Y=729300
X530 3893 3877 3917 3888 1 3889 2 AOI22S $T=825840 699440 0 0 $X=825840 $Y=699060
X531 3942 3918 3887 3898 1 3919 2 AOI22S $T=829560 770000 1 180 $X=825840 $Y=769620
X532 3938 3930 3912 3898 1 3919 2 AOI22S $T=830800 759920 1 180 $X=827080 $Y=759540
X533 3952 3929 3949 3888 1 3889 2 AOI22S $T=831420 719600 1 180 $X=827700 $Y=719220
X534 3886 3928 3911 3934 1 3937 2 AOI22S $T=827700 790160 0 0 $X=827700 $Y=789780
X535 3922 3936 3906 3898 1 3919 2 AOI22S $T=828940 780080 1 0 $X=828940 $Y=774660
X536 3914 3927 3902 3934 1 3937 2 AOI22S $T=828940 810320 0 0 $X=828940 $Y=809940
X537 3932 3926 3900 3934 1 3937 2 AOI22S $T=828940 840560 1 0 $X=828940 $Y=835140
X538 3924 3941 3903 3934 1 3937 2 AOI22S $T=829560 830480 0 0 $X=829560 $Y=830100
X539 3945 3943 3904 3934 1 3937 2 AOI22S $T=833280 850640 0 180 $X=829560 $Y=845220
X540 3967 3956 3885 3934 1 3937 2 AOI22S $T=841960 780080 1 180 $X=838240 $Y=779700
X541 792 793 3955 794 1 796 2 AOI22S $T=838860 699440 0 0 $X=838860 $Y=699060
X542 3939 3959 3940 798 1 800 2 AOI22S $T=841340 749840 1 0 $X=841340 $Y=744420
X543 3964 3975 3947 798 1 800 2 AOI22S $T=842580 699440 0 0 $X=842580 $Y=699060
X544 3960 3961 3950 798 1 800 2 AOI22S $T=842580 739760 1 0 $X=842580 $Y=734340
X545 3994 3965 3935 798 1 800 2 AOI22S $T=848160 709520 1 180 $X=844440 $Y=709140
X546 4007 3998 3951 798 1 800 2 AOI22S $T=851880 729680 0 180 $X=848160 $Y=724260
X547 4008 3985 3907 3898 1 3919 2 AOI22S $T=853740 770000 0 180 $X=850020 $Y=764580
X548 4006 4009 3990 798 1 800 2 AOI22S $T=856840 749840 1 180 $X=853120 $Y=749460
X549 4016 4001 3982 3888 1 3889 2 AOI22S $T=860560 749840 1 180 $X=856840 $Y=749460
X550 817 815 4024 794 1 796 2 AOI22S $T=864900 699440 1 180 $X=861180 $Y=699060
X551 4041 4027 4034 798 1 800 2 AOI22S $T=866140 709520 1 180 $X=862420 $Y=709140
X552 4021 4010 4035 3888 1 3889 2 AOI22S $T=864900 729680 0 0 $X=864900 $Y=729300
X553 4036 4045 4026 3898 1 3919 2 AOI22S $T=865520 770000 0 0 $X=865520 $Y=769620
X554 4062 4054 4059 3934 1 3937 2 AOI22S $T=869240 790160 0 180 $X=865520 $Y=784740
X555 4040 4060 4058 3934 1 3937 2 AOI22S $T=866760 830480 0 0 $X=866760 $Y=830100
X556 4044 4048 4051 3861 1 3870 2 AOI22S $T=866760 840560 0 0 $X=866760 $Y=840180
X557 4068 4063 4065 3861 1 3870 2 AOI22S $T=871100 820400 1 180 $X=867380 $Y=820020
X558 4030 4038 4037 3934 1 3937 2 AOI22S $T=868620 850640 1 0 $X=868620 $Y=845220
X559 4018 4067 4047 3898 1 3919 2 AOI22S $T=869240 770000 0 0 $X=869240 $Y=769620
X560 4066 4070 4069 3888 1 3889 2 AOI22S $T=870480 739760 1 0 $X=870480 $Y=734340
X561 4075 4023 4076 3888 1 3889 2 AOI22S $T=875440 759920 0 180 $X=871720 $Y=754500
X562 4082 4077 4055 3898 1 3919 2 AOI22S $T=876680 770000 1 180 $X=872960 $Y=769620
X563 4099 4087 4088 3898 1 3919 2 AOI22S $T=880400 770000 1 180 $X=876680 $Y=769620
X564 4084 828 4086 794 1 796 2 AOI22S $T=877920 699440 0 0 $X=877920 $Y=699060
X565 4094 4091 4100 798 1 800 2 AOI22S $T=881020 729680 1 0 $X=881020 $Y=724260
X566 4085 4109 4116 3898 1 3919 2 AOI22S $T=884740 770000 1 180 $X=881020 $Y=769620
X567 4090 4093 4064 3861 1 3870 2 AOI22S $T=881020 790160 1 0 $X=881020 $Y=784740
X568 4079 4108 4102 798 1 800 2 AOI22S $T=881640 709520 0 0 $X=881640 $Y=709140
X569 4078 4080 4103 3888 1 3889 2 AOI22S $T=887220 749840 1 180 $X=883500 $Y=749460
X570 4133 4126 4104 3934 1 3937 2 AOI22S $T=888460 850640 0 180 $X=884740 $Y=845220
X571 4118 4119 4110 798 1 800 2 AOI22S $T=885360 729680 0 0 $X=885360 $Y=729300
X572 834 837 4124 794 1 796 2 AOI22S $T=885980 709520 1 0 $X=885980 $Y=704100
X573 4123 4135 4121 3861 1 3870 2 AOI22S $T=888460 840560 0 0 $X=888460 $Y=840180
X574 4139 4142 4137 3861 1 3870 2 AOI22S $T=890940 800240 1 0 $X=890940 $Y=794820
X575 4131 4138 4129 3934 1 3937 2 AOI22S $T=891560 780080 0 0 $X=891560 $Y=779700
X576 4140 4148 4145 798 1 800 2 AOI22S $T=893420 739760 0 0 $X=893420 $Y=739380
X577 4134 4151 4150 798 1 800 2 AOI22S $T=894660 739760 1 0 $X=894660 $Y=734340
X578 847 4149 4155 3888 1 3889 2 AOI22S $T=895900 709520 0 0 $X=895900 $Y=709140
X579 4158 4156 4157 3898 1 3919 2 AOI22S $T=897140 759920 0 0 $X=897140 $Y=759540
X580 4177 4173 4179 3934 1 3937 2 AOI22S $T=903340 850640 0 180 $X=899620 $Y=845220
X581 4154 4174 4175 3861 1 3870 2 AOI22S $T=902720 800240 1 0 $X=902720 $Y=794820
X582 4162 4153 4152 3888 1 3889 2 AOI22S $T=904580 749840 0 0 $X=904580 $Y=749460
X583 4165 4197 4168 3934 1 3937 2 AOI22S $T=905820 780080 0 0 $X=905820 $Y=779700
X584 4192 4195 4183 3861 1 3870 2 AOI22S $T=905820 840560 0 0 $X=905820 $Y=840180
X585 4196 4198 4202 3888 1 3889 2 AOI22S $T=908300 719600 0 0 $X=908300 $Y=719220
X586 4214 4189 4212 798 1 800 2 AOI22S $T=912020 729680 1 180 $X=908300 $Y=729300
X587 4215 4209 4211 3888 1 3889 2 AOI22S $T=912020 749840 1 180 $X=908300 $Y=749460
X588 4222 4213 4220 798 1 800 2 AOI22S $T=912640 739760 1 180 $X=908920 $Y=739380
X589 4186 3898 4190 4203 1 3919 2 AOI22S $T=910160 780080 1 0 $X=910160 $Y=774660
X590 4223 4221 4216 3861 1 3870 2 AOI22S $T=912020 810320 1 0 $X=912020 $Y=804900
X591 4204 4235 4207 3898 1 3919 2 AOI22S $T=917600 780080 0 180 $X=913880 $Y=774660
X592 4191 4218 4236 3861 1 3870 2 AOI22S $T=915120 840560 1 0 $X=915120 $Y=835140
X593 4238 4241 4229 3934 1 3937 2 AOI22S $T=916360 850640 1 0 $X=916360 $Y=845220
X594 4253 4243 4247 3861 1 3870 2 AOI22S $T=921320 830480 0 180 $X=917600 $Y=825060
X595 4231 4245 4227 3898 1 3919 2 AOI22S $T=918840 770000 0 0 $X=918840 $Y=769620
X596 4265 4249 4272 3888 1 3889 2 AOI22S $T=928140 729680 1 180 $X=924420 $Y=729300
X597 4266 4260 4254 3898 1 3919 2 AOI22S $T=928140 770000 0 180 $X=924420 $Y=764580
X598 4271 4248 4250 3934 1 3937 2 AOI22S $T=928760 830480 1 180 $X=925040 $Y=830100
X599 4240 4269 4264 3888 1 3889 2 AOI22S $T=926900 709520 0 0 $X=926900 $Y=709140
X600 4280 4273 4278 3934 1 3937 2 AOI22S $T=931240 780080 1 180 $X=927520 $Y=779700
X601 4258 4233 4210 3934 1 3937 2 AOI22S $T=931860 780080 0 180 $X=928140 $Y=774660
X602 4274 4279 4276 3888 1 3889 2 AOI22S $T=929380 749840 1 0 $X=929380 $Y=744420
X603 4307 4288 4291 3898 1 3919 2 AOI22S $T=934960 770000 1 180 $X=931240 $Y=769620
X604 4296 4281 4289 798 1 800 2 AOI22S $T=936200 719600 1 180 $X=932480 $Y=719220
X605 4304 4299 4294 798 1 800 2 AOI22S $T=938680 739760 1 180 $X=934960 $Y=739380
X606 4283 4302 4298 3861 1 3870 2 AOI22S $T=936820 800240 1 0 $X=936820 $Y=794820
X607 4309 4306 4284 798 1 800 2 AOI22S $T=941160 699440 1 180 $X=937440 $Y=699060
X608 4380 4385 4372 3934 1 3937 2 AOI22S $T=957900 800240 0 0 $X=957900 $Y=799860
X609 4367 4404 4402 3888 1 3889 2 AOI22S $T=964100 709520 1 0 $X=964100 $Y=704100
X610 4419 4368 4411 3934 1 3937 2 AOI22S $T=967820 830480 1 180 $X=964100 $Y=830100
X611 4415 4420 4371 3898 1 3919 2 AOI22S $T=967820 759920 0 0 $X=967820 $Y=759540
X612 4431 4405 4381 3861 1 3870 2 AOI22S $T=972780 810320 0 180 $X=969060 $Y=804900
X613 4425 4401 4430 806 1 804 2 AOI22S $T=973400 729680 1 180 $X=969680 $Y=729300
X614 914 917 4422 798 1 800 2 AOI22S $T=970300 709520 1 0 $X=970300 $Y=704100
X615 4428 4433 4421 3888 1 3889 2 AOI22S $T=971540 699440 0 0 $X=971540 $Y=699060
X616 4396 4439 4440 798 1 800 2 AOI22S $T=974640 739760 0 0 $X=974640 $Y=739380
X617 4461 4418 4448 3898 1 3919 2 AOI22S $T=983320 759920 0 180 $X=979600 $Y=754500
X618 4442 4459 4457 3861 1 3870 2 AOI22S $T=980220 840560 0 0 $X=980220 $Y=840180
X619 4453 4455 4456 3888 1 3889 2 AOI22S $T=981460 749840 1 0 $X=981460 $Y=744420
X620 4462 4466 4464 3898 1 3919 2 AOI22S $T=982080 759920 0 0 $X=982080 $Y=759540
X621 4468 4471 4429 794 1 796 2 AOI22S $T=983940 729680 1 0 $X=983940 $Y=724260
X622 4467 4472 4452 3934 1 3937 2 AOI22S $T=983940 840560 0 0 $X=983940 $Y=840180
X623 4474 4435 4470 3934 1 3937 2 AOI22S $T=988900 800240 0 180 $X=985180 $Y=794820
X624 4482 4479 4426 3898 1 3919 2 AOI22S $T=990140 759920 1 180 $X=986420 $Y=759540
X625 4481 4475 4476 3861 1 3870 2 AOI22S $T=990140 800240 1 180 $X=986420 $Y=799860
X626 4491 4480 4490 798 1 800 2 AOI22S $T=994480 749840 0 180 $X=990760 $Y=744420
X627 4494 4483 4438 3861 1 3870 2 AOI22S $T=995100 840560 0 180 $X=991380 $Y=835140
X628 4487 4493 4492 3934 1 3937 2 AOI22S $T=993240 850640 0 0 $X=993240 $Y=850260
X629 4489 4485 4495 3888 1 3889 2 AOI22S $T=994480 749840 1 0 $X=994480 $Y=744420
X630 4503 4500 933 3888 1 3889 2 AOI22S $T=999440 699440 1 180 $X=995720 $Y=699060
X631 4511 4502 4501 3861 1 3870 2 AOI22S $T=999440 810320 0 180 $X=995720 $Y=804900
X632 4517 4506 4508 3898 1 3919 2 AOI22S $T=1000060 770000 0 180 $X=996340 $Y=764580
X633 4505 4499 4510 806 1 804 2 AOI22S $T=1003780 729680 0 180 $X=1000060 $Y=724260
X634 4531 938 4529 3898 1 3919 2 AOI22S $T=1007500 770000 1 180 $X=1003780 $Y=769620
X635 4543 939 4514 3898 1 3919 2 AOI22S $T=1011840 770000 1 180 $X=1008120 $Y=769620
X636 4534 4530 4515 794 1 796 2 AOI22S $T=1009980 719600 0 0 $X=1009980 $Y=719220
X637 4526 4545 4507 3934 1 3937 2 AOI22S $T=1010600 790160 1 0 $X=1010600 $Y=784740
X638 4556 4541 4533 3934 1 3937 2 AOI22S $T=1014320 850640 1 180 $X=1010600 $Y=850260
X639 4542 4547 4544 798 1 800 2 AOI22S $T=1011220 749840 1 0 $X=1011220 $Y=744420
X640 4549 4546 4520 3861 1 3870 2 AOI22S $T=1012460 850640 1 0 $X=1012460 $Y=845220
X641 4551 4548 4553 3861 1 3870 2 AOI22S $T=1013700 800240 0 0 $X=1013700 $Y=799860
X642 4581 4560 4578 794 1 796 2 AOI22S $T=1019280 729680 0 180 $X=1015560 $Y=724260
X643 4558 4561 4565 3888 1 3889 2 AOI22S $T=1018040 749840 0 0 $X=1018040 $Y=749460
X644 4576 4573 4539 3861 1 3870 2 AOI22S $T=1021760 850640 0 180 $X=1018040 $Y=845220
X645 4566 944 4571 3898 1 3919 2 AOI22S $T=1018660 770000 1 0 $X=1018660 $Y=764580
X646 4567 4562 4568 3934 1 3937 2 AOI22S $T=1018660 790160 0 0 $X=1018660 $Y=789780
X647 4575 4550 940 3888 1 3889 2 AOI22S $T=1021140 699440 0 0 $X=1021140 $Y=699060
X648 4583 4580 945 3888 1 3889 2 AOI22S $T=1025480 709520 1 180 $X=1021760 $Y=709140
X649 4579 4570 4577 806 1 804 2 AOI22S $T=1023000 739760 1 0 $X=1023000 $Y=734340
X650 4595 946 4584 3898 1 3919 2 AOI22S $T=1029200 770000 0 180 $X=1025480 $Y=764580
X651 4594 4589 4590 806 1 804 2 AOI22S $T=1030440 739760 0 180 $X=1026720 $Y=734340
X652 4585 4588 947 3888 1 3889 2 AOI22S $T=1027340 699440 0 0 $X=1027340 $Y=699060
X653 4605 4599 4587 3934 1 3937 2 AOI22S $T=1032920 790160 0 180 $X=1029200 $Y=784740
X654 4604 4598 4600 3934 1 3937 2 AOI22S $T=1032920 850640 1 180 $X=1029200 $Y=850260
X655 4619 4592 4616 798 1 800 2 AOI22S $T=1036640 749840 0 180 $X=1032920 $Y=744420
X656 4601 4617 4615 3898 1 3919 2 AOI22S $T=1034160 770000 0 0 $X=1034160 $Y=769620
X657 4613 4608 4591 3861 1 3870 2 AOI22S $T=1034160 800240 0 0 $X=1034160 $Y=799860
X658 4631 4620 4624 3861 1 3870 2 AOI22S $T=1037880 840560 1 180 $X=1034160 $Y=840180
X659 4627 4623 4597 794 1 796 2 AOI22S $T=1037880 719600 0 0 $X=1037880 $Y=719220
X660 4630 4633 4626 3888 1 3889 2 AOI22S $T=1039120 749840 0 0 $X=1039120 $Y=749460
X661 4649 962 4653 3898 1 3919 2 AOI22S $T=1046560 770000 0 180 $X=1042840 $Y=764580
X662 4640 4651 4647 794 1 796 2 AOI22S $T=1045940 729680 1 0 $X=1045940 $Y=724260
X663 4666 4661 4674 806 1 804 2 AOI22S $T=1051520 729680 1 180 $X=1047800 $Y=729300
X664 4652 4645 4658 798 1 800 2 AOI22S $T=1047800 739760 0 0 $X=1047800 $Y=739380
X665 4638 4662 4659 3898 1 3919 2 AOI22S $T=1047800 770000 1 0 $X=1047800 $Y=764580
X666 4643 4641 4656 3934 1 3937 2 AOI22S $T=1047800 790160 1 0 $X=1047800 $Y=784740
X667 4664 4670 4667 3861 1 3870 2 AOI22S $T=1049660 800240 0 0 $X=1049660 $Y=799860
X668 4669 4671 4672 3861 1 3870 2 AOI22S $T=1050280 850640 1 0 $X=1050280 $Y=845220
X669 4657 4676 966 3888 1 3889 2 AOI22S $T=1051520 709520 0 0 $X=1051520 $Y=709140
X670 4677 968 4685 3898 1 3919 2 AOI22S $T=1056480 770000 0 180 $X=1052760 $Y=764580
X671 4690 4681 4673 3934 1 3937 2 AOI22S $T=1057100 850640 1 180 $X=1053380 $Y=850260
X672 4678 4675 4679 3861 1 3870 2 AOI22S $T=1054620 800240 0 0 $X=1054620 $Y=799860
X673 4691 4694 4684 3888 1 3889 2 AOI22S $T=1057720 759920 1 0 $X=1057720 $Y=754500
X674 4686 4692 972 3888 1 3889 2 AOI22S $T=1058340 709520 1 0 $X=1058340 $Y=704100
X675 4680 4689 4695 3861 1 3870 2 AOI22S $T=1058340 850640 0 0 $X=1058340 $Y=850260
X676 4693 4696 4683 3934 1 3937 2 AOI22S $T=1059580 790160 1 0 $X=1059580 $Y=784740
X677 4701 4698 4707 3861 1 3870 2 AOI22S $T=1066400 830480 0 180 $X=1062680 $Y=825060
X678 4724 974 4712 3898 1 3919 2 AOI22S $T=1070740 780080 0 180 $X=1067020 $Y=774660
X679 4730 4710 4721 3861 1 3870 2 AOI22S $T=1070740 840560 0 180 $X=1067020 $Y=835140
X680 4700 4714 4708 794 1 796 2 AOI22S $T=1068260 719600 1 0 $X=1068260 $Y=714180
X681 4703 4711 4709 798 1 800 2 AOI22S $T=1068260 749840 1 0 $X=1068260 $Y=744420
X682 4706 4723 4704 3898 1 3919 2 AOI22S $T=1070120 770000 0 0 $X=1070120 $Y=769620
X683 4718 4722 4702 3934 1 3937 2 AOI22S $T=1070120 850640 0 0 $X=1070120 $Y=850260
X684 4715 4728 4726 3888 1 3889 2 AOI22S $T=1071360 699440 0 0 $X=1071360 $Y=699060
X685 4766 4735 4738 3898 1 3919 2 AOI22S $T=1076940 780080 0 180 $X=1073220 $Y=774660
X686 4757 4736 4713 3934 1 3937 2 AOI22S $T=1076940 840560 0 180 $X=1073220 $Y=835140
X687 4754 4734 4731 3888 1 3889 2 AOI22S $T=1077560 759920 0 180 $X=1073840 $Y=754500
X688 4733 4716 4727 806 1 804 2 AOI22S $T=1075080 729680 0 0 $X=1075080 $Y=729300
X689 4772 4745 4750 3898 1 3919 2 AOI22S $T=1078800 770000 1 180 $X=1075080 $Y=769620
X690 4774 4746 4749 3934 1 3937 2 AOI22S $T=1078800 860720 0 180 $X=1075080 $Y=855300
X691 4755 4729 4763 3861 1 3870 2 AOI22S $T=1080040 800240 1 180 $X=1076320 $Y=799860
X692 4767 4759 980 3888 1 3889 2 AOI22S $T=1081900 709520 0 180 $X=1078180 $Y=704100
X693 4771 4760 4740 3888 1 3889 2 AOI22S $T=1081900 759920 0 180 $X=1078180 $Y=754500
X694 4742 4761 4751 794 1 796 2 AOI22S $T=1082520 729680 0 180 $X=1078800 $Y=724260
X695 4769 4762 4743 806 1 804 2 AOI22S $T=1082520 739760 0 180 $X=1078800 $Y=734340
X696 4775 4764 4752 798 1 800 2 AOI22S $T=1082520 749840 1 180 $X=1078800 $Y=749460
X697 4773 4765 4744 3934 1 3937 2 AOI22S $T=1082520 790160 0 180 $X=1078800 $Y=784740
X698 1026 1030 1 2 1014 AN2 $T=223820 739760 0 180 $X=221340 $Y=734340
X699 1027 1014 1 2 1015 AN2 $T=223820 749840 1 180 $X=221340 $Y=749460
X700 1016 1015 1 2 1031 AN2 $T=221340 759920 0 0 $X=221340 $Y=759540
X701 1046 1033 1 2 1018 AN2 $T=223820 810320 0 180 $X=221340 $Y=804900
X702 1038 1018 1 2 1019 AN2 $T=223820 810320 1 180 $X=221340 $Y=809940
X703 1036 1019 1 2 1020 AN2 $T=223820 820400 0 180 $X=221340 $Y=814980
X704 1021 1020 1 2 1037 AN2 $T=221340 830480 0 0 $X=221340 $Y=830100
X705 3 4 1 2 1039 AN2 $T=221340 880880 1 0 $X=221340 $Y=875460
X706 5 6 1 2 1040 AN2 $T=222580 699440 0 0 $X=222580 $Y=699060
X707 1025 1029 1 2 1030 AN2 $T=225060 729680 0 180 $X=222580 $Y=724260
X708 1022 1031 1 2 1034 AN2 $T=222580 780080 1 0 $X=222580 $Y=774660
X709 1023 1034 1 2 1035 AN2 $T=222580 790160 1 0 $X=222580 $Y=784740
X710 1054 1035 1 2 1032 AN2 $T=225060 790160 1 180 $X=222580 $Y=789780
X711 1057 1032 1 2 1033 AN2 $T=225060 800240 1 180 $X=222580 $Y=799860
X712 1048 1040 1 2 1029 AN2 $T=225680 709520 1 180 $X=223200 $Y=709140
X713 1052 1039 1 2 1077 AN2 $T=228160 870800 1 0 $X=228160 $Y=865380
X714 1062 1077 1 2 1079 AN2 $T=231260 870800 1 0 $X=231260 $Y=865380
X715 1082 1079 1 2 1128 AN2 $T=236840 850640 0 0 $X=236840 $Y=850260
X716 1141 1128 1 2 1101 AN2 $T=240560 860720 0 180 $X=238080 $Y=855300
X717 1251 1243 1 2 53 AN2 $T=264740 880880 0 180 $X=262260 $Y=875460
X718 1217 1213 1 2 1263 AN2 $T=264120 770000 0 0 $X=264120 $Y=769620
X719 1247 1250 1 2 1265 AN2 $T=264120 820400 1 0 $X=264120 $Y=814980
X720 1261 1262 1 2 1213 AN2 $T=267840 770000 0 180 $X=265360 $Y=764580
X721 1260 1272 1 2 1262 AN2 $T=267220 749840 0 0 $X=267220 $Y=749460
X722 1267 1265 1 2 1278 AN2 $T=267220 830480 1 0 $X=267220 $Y=825060
X723 1281 1278 1 2 1242 AN2 $T=269700 830480 1 180 $X=267220 $Y=830100
X724 57 56 1 2 1243 AN2 $T=269700 880880 0 180 $X=267220 $Y=875460
X725 1273 1263 1 2 1249 AN2 $T=267840 780080 1 0 $X=267840 $Y=774660
X726 1283 58 1 2 1270 AN2 $T=271560 709520 0 180 $X=269080 $Y=704100
X727 1256 1249 1 2 1280 AN2 $T=269080 780080 0 0 $X=269080 $Y=779700
X728 1293 1285 1 2 1250 AN2 $T=271560 810320 0 180 $X=269080 $Y=804900
X729 1276 1270 1 2 1271 AN2 $T=270940 719600 1 0 $X=270940 $Y=714180
X730 1277 1271 1 2 1272 AN2 $T=273420 729680 1 180 $X=270940 $Y=729300
X731 1266 1264 1 2 1285 AN2 $T=270940 790160 0 0 $X=270940 $Y=789780
X732 1295 1296 1 2 56 AN2 $T=273420 880880 0 180 $X=270940 $Y=875460
X733 1284 1280 1 2 1264 AN2 $T=272180 790160 1 0 $X=272180 $Y=784740
X734 1332 1329 1 2 1296 AN2 $T=280240 870800 1 180 $X=277760 $Y=870420
X735 1346 76 1 2 1329 AN2 $T=283340 870800 1 180 $X=280860 $Y=870420
X736 1438 102 1 2 1448 AN2 $T=308140 800240 1 0 $X=308140 $Y=794820
X737 1406 102 1 2 1384 AN2 $T=313720 840560 1 180 $X=311240 $Y=840180
X738 1393 102 1 2 1381 AN2 $T=314340 830480 0 180 $X=311860 $Y=825060
X739 1445 102 1 2 1469 AN2 $T=313100 770000 1 0 $X=313100 $Y=764580
X740 1443 102 1 2 1429 AN2 $T=314960 780080 0 0 $X=314960 $Y=779700
X741 1467 102 1 2 1478 AN2 $T=314960 830480 1 0 $X=314960 $Y=825060
X742 1470 102 1 2 1485 AN2 $T=316820 749840 0 0 $X=316820 $Y=749460
X743 1474 102 1 2 1453 AN2 $T=319300 790160 1 180 $X=316820 $Y=789780
X744 1488 102 1 2 1497 AN2 $T=319920 719600 1 0 $X=319920 $Y=714180
X745 1466 102 1 2 1477 AN2 $T=324260 810320 1 180 $X=321780 $Y=809940
X746 1447 102 1 2 1450 AN2 $T=324260 820400 0 180 $X=321780 $Y=814980
X747 1491 102 1 2 1517 AN2 $T=324260 709520 1 0 $X=324260 $Y=704100
X748 1449 102 1 2 1521 AN2 $T=324260 850640 1 0 $X=324260 $Y=845220
X749 1518 102 1 2 1543 AN2 $T=328600 749840 1 0 $X=328600 $Y=744420
X750 1505 102 1 2 1536 AN2 $T=329840 780080 0 0 $X=329840 $Y=779700
X751 1548 1554 1 2 1562 AN2 $T=331700 820400 0 0 $X=331700 $Y=820020
X752 1562 1571 1 2 1560 AN2 $T=335420 820400 1 0 $X=335420 $Y=814980
X753 1582 1599 1 2 1569 AN2 $T=341620 739760 0 180 $X=339140 $Y=734340
X754 1575 1569 1 2 1583 AN2 $T=339140 749840 0 0 $X=339140 $Y=749460
X755 1565 1586 1 2 1603 AN2 $T=339760 780080 1 0 $X=339760 $Y=774660
X756 1585 1583 1 2 1602 AN2 $T=340380 759920 0 0 $X=340380 $Y=759540
X757 1554 1571 1 2 1566 AN2 $T=342860 820400 0 180 $X=340380 $Y=814980
X758 1595 1587 1 2 1599 AN2 $T=343480 719600 1 180 $X=341000 $Y=719220
X759 1590 1602 1 2 1586 AN2 $T=341000 770000 0 0 $X=341000 $Y=769620
X760 1612 1603 1 2 1570 AN2 $T=343480 780080 1 180 $X=341000 $Y=779700
X761 1576 1570 1 2 1596 AN2 $T=341620 790160 0 0 $X=341620 $Y=789780
X762 128 131 1 2 1594 AN2 $T=342240 709520 1 0 $X=342240 $Y=704100
X763 1598 1594 1 2 1587 AN2 $T=344720 709520 1 180 $X=342240 $Y=709140
X764 1600 1596 1 2 1613 AN2 $T=342240 800240 1 0 $X=342240 $Y=794820
X765 1604 1613 1 2 1571 AN2 $T=345960 810320 0 180 $X=343480 $Y=804900
X766 143 141 1 2 1627 AN2 $T=351540 880880 0 180 $X=349060 $Y=875460
X767 1691 165 1 2 1701 AN2 $T=365800 709520 0 0 $X=365800 $Y=709140
X768 1675 1707 1 2 1716 AN2 $T=369520 770000 0 0 $X=369520 $Y=769620
X769 1710 1707 1 2 1747 AN2 $T=375100 850640 1 0 $X=375100 $Y=845220
X770 1751 1746 1 2 1709 AN2 $T=378820 759920 1 180 $X=376340 $Y=759540
X771 1719 1707 1 2 1777 AN2 $T=380060 820400 0 0 $X=380060 $Y=820020
X772 1748 1707 1 2 1771 AN2 $T=380060 840560 0 0 $X=380060 $Y=840180
X773 1733 1707 1 2 1767 AN2 $T=381300 810320 0 0 $X=381300 $Y=809940
X774 1732 1707 1 2 1784 AN2 $T=381920 790160 0 0 $X=381920 $Y=789780
X775 1782 182 1 2 181 AN2 $T=385640 699440 1 180 $X=383160 $Y=699060
X776 1769 165 1 2 1789 AN2 $T=384400 709520 0 0 $X=384400 $Y=709140
X777 1778 165 1 2 1787 AN2 $T=384400 729680 0 0 $X=384400 $Y=729300
X778 1717 1707 1 2 1793 AN2 $T=385020 800240 0 0 $X=385020 $Y=799860
X779 1818 1814 1 2 1806 AN2 $T=393080 719600 0 180 $X=390600 $Y=714180
X780 1819 1824 1 2 1778 AN2 $T=392460 729680 0 0 $X=392460 $Y=729300
X781 1832 1834 1 2 1673 AN2 $T=394940 790160 0 0 $X=394940 $Y=789780
X782 1810 1808 1 2 1833 AN2 $T=395560 739760 0 0 $X=395560 $Y=739380
X783 1806 1826 1 2 1828 AN2 $T=396800 719600 0 0 $X=396800 $Y=719220
X784 1828 1831 1 2 1807 AN2 $T=399280 729680 0 180 $X=396800 $Y=724260
X785 1807 1841 1 2 1808 AN2 $T=396800 739760 1 0 $X=396800 $Y=734340
X786 1861 1824 1 2 1770 AN2 $T=401140 739760 1 180 $X=398660 $Y=739380
X787 1836 1833 1 2 1859 AN2 $T=398660 749840 1 0 $X=398660 $Y=744420
X788 1882 1824 1 2 1769 AN2 $T=404860 729680 1 180 $X=402380 $Y=729300
X789 1876 1878 1 2 1879 AN2 $T=407960 820400 0 180 $X=405480 $Y=814980
X790 1892 1859 1 2 1912 AN2 $T=407340 749840 1 0 $X=407340 $Y=744420
X791 1887 1890 1 2 1878 AN2 $T=409820 810320 1 180 $X=407340 $Y=809940
X792 1864 1834 1 2 1682 AN2 $T=407960 780080 0 0 $X=407960 $Y=779700
X793 1951 1935 1 2 1896 AN2 $T=414780 709520 0 180 $X=412300 $Y=704100
X794 1922 1912 1 2 1941 AN2 $T=412300 739760 0 0 $X=412300 $Y=739380
X795 1943 1937 1 2 1848 AN2 $T=414780 810320 1 180 $X=412300 $Y=809940
X796 1944 1937 1 2 1851 AN2 $T=414780 820400 0 180 $X=412300 $Y=814980
X797 1908 1707 1 2 1910 AN2 $T=416640 850640 1 180 $X=414160 $Y=850260
X798 1964 1937 1 2 1835 AN2 $T=418500 820400 0 180 $X=416020 $Y=814980
X799 1966 1941 1 2 1979 AN2 $T=418500 739760 1 0 $X=418500 $Y=734340
X800 1970 1949 1 2 1942 AN2 $T=420980 780080 1 0 $X=420980 $Y=774660
X801 1967 1924 1 2 1991 AN2 $T=420980 820400 0 0 $X=420980 $Y=820020
X802 2001 1707 1 2 1977 AN2 $T=423460 850640 1 180 $X=420980 $Y=850260
X803 2010 1991 1 2 1997 AN2 $T=426560 820400 1 180 $X=424080 $Y=820020
X804 2006 1997 1 2 2019 AN2 $T=425940 830480 1 0 $X=425940 $Y=825060
X805 2008 1979 1 2 2025 AN2 $T=427800 739760 0 0 $X=427800 $Y=739380
X806 1947 1931 1 2 2040 AN2 $T=429660 810320 1 0 $X=429660 $Y=804900
X807 2044 2025 1 2 2069 AN2 $T=436480 739760 0 0 $X=436480 $Y=739380
X808 2053 2019 1 2 2058 AN2 $T=436480 830480 0 0 $X=436480 $Y=830100
X809 2074 1707 1 2 2047 AN2 $T=440820 860720 0 180 $X=438340 $Y=855300
X810 2061 2058 1 2 2098 AN2 $T=441440 820400 1 0 $X=441440 $Y=814980
X811 2100 2069 1 2 2130 AN2 $T=448260 739760 0 0 $X=448260 $Y=739380
X812 2133 2130 1 2 2145 AN2 $T=451360 739760 0 0 $X=451360 $Y=739380
X813 2126 2098 1 2 2152 AN2 $T=451980 820400 0 0 $X=451980 $Y=820020
X814 2175 2145 1 2 2195 AN2 $T=460040 739760 0 0 $X=460040 $Y=739380
X815 2155 2152 1 2 2205 AN2 $T=463760 820400 1 0 $X=463760 $Y=814980
X816 2193 2205 1 2 2222 AN2 $T=465620 820400 0 0 $X=465620 $Y=820020
X817 2212 2195 1 2 2225 AN2 $T=466860 739760 0 0 $X=466860 $Y=739380
X818 2226 2222 1 2 2237 AN2 $T=468720 820400 0 0 $X=468720 $Y=820020
X819 2255 1707 1 2 2187 AN2 $T=472440 830480 1 180 $X=469960 $Y=830100
X820 2245 1707 1 2 2151 AN2 $T=473060 840560 0 180 $X=470580 $Y=835140
X821 2243 2225 1 2 2250 AN2 $T=472440 739760 1 0 $X=472440 $Y=734340
X822 2258 2237 1 2 2261 AN2 $T=475540 810320 0 0 $X=475540 $Y=809940
X823 2272 1707 1 2 2117 AN2 $T=478640 840560 0 180 $X=476160 $Y=835140
X824 2278 2282 1 2 2287 AN2 $T=479260 790160 0 0 $X=479260 $Y=789780
X825 2252 2261 1 2 2282 AN2 $T=479260 800240 0 0 $X=479260 $Y=799860
X826 2281 2250 1 2 2286 AN2 $T=480500 739760 1 0 $X=480500 $Y=734340
X827 2285 2287 1 2 2326 AN2 $T=484220 790160 0 0 $X=484220 $Y=789780
X828 2297 2286 1 2 2314 AN2 $T=486080 749840 1 0 $X=486080 $Y=744420
X829 2342 1707 1 2 2279 AN2 $T=491660 830480 1 180 $X=489180 $Y=830100
X830 2338 2335 1 2 2298 AN2 $T=493520 770000 1 180 $X=491040 $Y=769620
X831 2329 2326 1 2 2335 AN2 $T=492900 790160 0 0 $X=492900 $Y=789780
X832 2332 2328 1 2 2345 AN2 $T=493520 739760 0 0 $X=493520 $Y=739380
X833 2346 2345 1 2 2339 AN2 $T=496620 729680 0 180 $X=494140 $Y=724260
X834 2340 2314 1 2 2348 AN2 $T=494140 749840 0 0 $X=494140 $Y=749460
X835 2355 2348 1 2 2328 AN2 $T=498480 739760 1 180 $X=496000 $Y=739380
X836 2399 1707 1 2 2262 AN2 $T=507160 780080 0 180 $X=504680 $Y=774660
X837 2397 1707 1 2 2311 AN2 $T=507160 820400 0 180 $X=504680 $Y=814980
X838 282 280 1 2 1654 AN2 $T=507160 820400 1 180 $X=504680 $Y=820020
X839 282 280 1 2 2247 AN2 $T=507160 830480 0 180 $X=504680 $Y=825060
X840 2408 1707 1 2 2293 AN2 $T=507160 830480 1 180 $X=504680 $Y=830100
X841 2420 1707 1 2 2362 AN2 $T=513360 810320 0 180 $X=510880 $Y=804900
X842 2453 1707 1 2 2320 AN2 $T=515840 810320 0 180 $X=513360 $Y=804900
X843 2451 1707 1 2 2369 AN2 $T=520800 790160 0 180 $X=518320 $Y=784740
X844 307 2450 1 2 2431 AN2 $T=521420 719600 1 180 $X=518940 $Y=719220
X845 2462 1707 1 2 2413 AN2 $T=522660 780080 1 180 $X=520180 $Y=779700
X846 2478 1707 1 2 2423 AN2 $T=523900 810320 0 180 $X=521420 $Y=804900
X847 2546 1707 1 2 2457 AN2 $T=525760 800240 1 180 $X=523280 $Y=799860
X848 337 342 1 2 2508 AN2 $T=530100 709520 1 0 $X=530100 $Y=704100
X849 351 295 1 2 353 AN2 $T=533200 719600 0 0 $X=533200 $Y=719220
X850 303 350 1 2 2561 AN2 $T=540640 719600 1 0 $X=540640 $Y=714180
X851 282 280 1 2 2581 AN2 $T=549940 820400 1 180 $X=547460 $Y=820020
X852 282 280 1 2 384 AN2 $T=548700 830480 1 0 $X=548700 $Y=825060
X853 2687 2690 1 2 2697 AN2 $T=569780 870800 1 0 $X=569780 $Y=865380
X854 2697 2698 1 2 445 AN2 $T=571020 880880 1 0 $X=571020 $Y=875460
X855 2708 2700 1 2 2687 AN2 $T=575360 870800 0 180 $X=572880 $Y=865380
X856 2766 2763 1 2 2708 AN2 $T=585900 860720 0 180 $X=583420 $Y=855300
X857 2789 2784 1 2 2766 AN2 $T=589000 840560 1 180 $X=586520 $Y=840180
X858 2774 2771 1 2 2802 AN2 $T=586520 860720 1 0 $X=586520 $Y=855300
X859 494 2596 1 2 2797 AN2 $T=592720 719600 0 180 $X=590240 $Y=714180
X860 329 495 1 2 2824 AN2 $T=592720 709520 0 0 $X=592720 $Y=709140
X861 2821 2819 1 2 2789 AN2 $T=595820 840560 0 180 $X=593340 $Y=835140
X862 2802 2790 1 2 2829 AN2 $T=593340 860720 1 0 $X=593340 $Y=855300
X863 358 2847 1 2 2832 AN2 $T=602640 759920 1 180 $X=600160 $Y=759540
X864 2829 2833 1 2 2853 AN2 $T=600160 850640 0 0 $X=600160 $Y=850260
X865 2878 2875 1 2 2821 AN2 $T=607600 840560 0 180 $X=605120 $Y=835140
X866 512 2727 1 2 2761 AN2 $T=606980 729680 1 0 $X=606980 $Y=724260
X867 2853 2866 1 2 2888 AN2 $T=606980 840560 0 0 $X=606980 $Y=840180
X868 2888 2892 1 2 2878 AN2 $T=611320 830480 1 180 $X=608840 $Y=830100
X869 2839 2761 1 2 530 AN2 $T=609460 729680 1 0 $X=609460 $Y=724260
X870 321 527 1 2 529 AN2 $T=610080 699440 0 0 $X=610080 $Y=699060
X871 588 587 1 2 583 AN2 $T=642320 699440 1 180 $X=639840 $Y=699060
X872 598 546 1 2 2969 AN2 $T=652240 709520 0 180 $X=649760 $Y=704100
X873 3047 3039 1 2 3077 AN2 $T=651620 759920 0 0 $X=651620 $Y=759540
X874 3135 3131 1 2 3120 AN2 $T=665880 780080 0 180 $X=663400 $Y=774660
X875 3179 91 1 2 3096 AN2 $T=673320 780080 0 0 $X=673320 $Y=779700
X876 3054 3021 1 2 3182 AN2 $T=676420 729680 1 180 $X=673940 $Y=729300
X877 3225 3189 1 2 3111 AN2 $T=682000 790160 0 0 $X=682000 $Y=789780
X878 3249 3255 1 2 3204 AN2 $T=686340 830480 1 0 $X=686340 $Y=825060
X879 3195 3175 1 2 3267 AN2 $T=686960 719600 0 0 $X=686960 $Y=719220
X880 3318 3315 1 2 3249 AN2 $T=699360 830480 0 180 $X=696880 $Y=825060
X881 3375 3364 1 2 3318 AN2 $T=707420 830480 1 180 $X=704940 $Y=830100
X882 646 3239 1 2 3390 AN2 $T=708040 810320 1 0 $X=708040 $Y=804900
X883 3419 3413 1 2 3406 AN2 $T=713620 860720 1 180 $X=711140 $Y=860340
X884 646 3416 1 2 3399 AN2 $T=712380 810320 1 0 $X=712380 $Y=804900
X885 3443 3422 1 2 3375 AN2 $T=717960 830480 0 180 $X=715480 $Y=825060
X886 3434 3436 1 2 3423 AN2 $T=718580 850640 1 180 $X=716100 $Y=850260
X887 3478 3491 1 2 3499 AN2 $T=726640 830480 1 0 $X=726640 $Y=825060
X888 3482 3484 1 2 3473 AN2 $T=729120 850640 0 180 $X=726640 $Y=845220
X889 3477 3501 1 2 3463 AN2 $T=728500 870800 0 0 $X=728500 $Y=870420
X890 3509 3510 1 2 3443 AN2 $T=732220 830480 0 180 $X=729740 $Y=825060
X891 3474 555 1 2 3513 AN2 $T=734080 870800 1 180 $X=731600 $Y=870420
X892 3117 613 1 2 3532 AN2 $T=739040 780080 0 180 $X=736560 $Y=774660
X893 3532 648 1 2 3554 AN2 $T=737180 820400 0 0 $X=737180 $Y=820020
X894 3554 627 1 2 3574 AN2 $T=740280 820400 1 0 $X=740280 $Y=814980
X895 3446 3297 1 2 3584 AN2 $T=744000 729680 0 0 $X=744000 $Y=729300
X896 634 636 1 2 3589 AN2 $T=745240 770000 1 0 $X=745240 $Y=764580
X897 3589 653 1 2 3614 AN2 $T=748340 780080 1 0 $X=748340 $Y=774660
X898 3574 629 1 2 3613 AN2 $T=749580 820400 1 0 $X=749580 $Y=814980
X899 3601 3556 1 2 665 AN2 $T=750200 860720 1 0 $X=750200 $Y=855300
X900 3613 655 1 2 3623 AN2 $T=752060 820400 1 0 $X=752060 $Y=814980
X901 3614 639 1 2 3641 AN2 $T=753920 790160 1 0 $X=753920 $Y=784740
X902 3650 670 1 2 3663 AN2 $T=758880 810320 1 0 $X=758880 $Y=804900
X903 3623 666 1 2 3650 AN2 $T=758880 810320 0 0 $X=758880 $Y=809940
X904 3618 3289 1 2 3661 AN2 $T=760740 739760 1 0 $X=760740 $Y=734340
X905 3641 637 1 2 3684 AN2 $T=762600 790160 1 0 $X=762600 $Y=784740
X906 3680 686 1 2 3669 AN2 $T=765080 810320 0 180 $X=762600 $Y=804900
X907 3663 678 1 2 3680 AN2 $T=765080 800240 0 0 $X=765080 $Y=799860
X908 3723 721 1 2 3714 AN2 $T=775000 800240 0 180 $X=772520 $Y=794820
X909 3669 690 1 2 3723 AN2 $T=772520 810320 1 0 $X=772520 $Y=804900
X910 3684 3553 1 2 3770 AN2 $T=783060 790160 1 0 $X=783060 $Y=784740
X911 3714 679 1 2 3773 AN2 $T=784920 790160 0 0 $X=784920 $Y=789780
X912 3784 3701 1 2 3774 AN2 $T=790500 780080 1 180 $X=788020 $Y=779700
X913 3770 668 1 2 3800 AN2 $T=792980 790160 0 0 $X=792980 $Y=789780
X914 3800 3608 1 2 3807 AN2 $T=794840 790160 1 0 $X=794840 $Y=784740
X915 3815 3668 1 2 3784 AN2 $T=800420 780080 0 180 $X=797940 $Y=774660
X916 3829 3617 1 2 3815 AN2 $T=802900 770000 1 180 $X=800420 $Y=769620
X917 3807 3616 1 2 3836 AN2 $T=804760 790160 1 0 $X=804760 $Y=784740
X918 3836 3646 1 2 3829 AN2 $T=807860 780080 1 180 $X=805380 $Y=779700
X919 3955 791 1 2 3946 AN2 $T=838240 699440 1 180 $X=835760 $Y=699060
X920 3980 3970 1 2 3861 AN2 $T=845060 780080 0 180 $X=842580 $Y=774660
X921 3980 3983 1 2 3919 AN2 $T=846920 770000 1 180 $X=844440 $Y=769620
X922 3974 3970 1 2 3981 AN2 $T=844440 780080 0 0 $X=844440 $Y=779700
X923 3969 3869 1 2 800 AN2 $T=848160 749840 0 180 $X=845680 $Y=744420
X924 3983 3978 1 2 794 AN2 $T=848780 739760 0 180 $X=846300 $Y=734340
X925 3974 3969 1 2 3984 AN2 $T=846300 780080 1 0 $X=846300 $Y=774660
X926 3992 3869 1 2 3888 AN2 $T=847540 749840 0 0 $X=847540 $Y=749460
X927 3869 3983 1 2 798 AN2 $T=848160 749840 1 0 $X=848160 $Y=744420
X928 3992 3978 1 2 806 AN2 $T=849400 739760 0 0 $X=849400 $Y=739380
X929 3974 3992 1 2 3971 AN2 $T=849400 780080 0 0 $X=849400 $Y=779700
X930 4024 820 1 2 4049 AN2 $T=864900 699440 0 0 $X=864900 $Y=699060
X931 4086 836 1 2 4113 AN2 $T=885980 699440 0 0 $X=885980 $Y=699060
X932 4124 846 1 2 4144 AN2 $T=890320 709520 1 0 $X=890320 $Y=704100
X933 865 866 1 2 4234 AN2 $T=913260 699440 0 0 $X=913260 $Y=699060
X934 4429 4430 1 2 4436 AN2 $T=971540 729680 1 0 $X=971540 $Y=724260
X935 4515 4510 1 2 4504 AN2 $T=1000060 729680 0 180 $X=997580 $Y=724260
X936 4578 4577 1 2 4574 AN2 $T=1023000 739760 0 180 $X=1020520 $Y=734340
X937 4597 4590 1 2 4614 AN2 $T=1030440 739760 1 0 $X=1030440 $Y=734340
X938 4647 4674 1 2 4682 AN2 $T=1052140 729680 0 0 $X=1052140 $Y=729300
X939 4708 4727 1 2 4732 AN2 $T=1071360 729680 0 0 $X=1071360 $Y=729300
X940 4751 4743 1 2 4737 AN2 $T=1077560 739760 0 180 $X=1075080 $Y=734340
X941 2428 274 1 2 INV4CK $T=515220 709520 0 0 $X=515220 $Y=709140
X942 2577 2550 1 2 INV4CK $T=556760 749840 0 180 $X=553040 $Y=744420
X943 2686 2683 1 2 INV4CK $T=569160 800240 0 180 $X=565440 $Y=794820
X944 2862 2857 1 2 INV4CK $T=604500 810320 0 180 $X=600780 $Y=804900
X945 3064 3018 1 2 INV4CK $T=654720 780080 0 0 $X=654720 $Y=779700
X946 3966 3948 1 2 INV4CK $T=842580 729680 0 180 $X=838860 $Y=724260
X947 4011 4013 1 2 INV4CK $T=857460 699440 0 0 $X=857460 $Y=699060
X948 4061 779 1 2 INV4CK $T=868620 729680 0 0 $X=868620 $Y=729300
X949 832 3986 1 2 INV4CK $T=883500 870800 0 180 $X=879780 $Y=865380
X950 4000 3850 1 2 INV4CK $T=890940 770000 0 180 $X=887220 $Y=764580
X951 4013 3944 1 2 INV4CK $T=892180 759920 0 180 $X=888460 $Y=754500
X952 4164 3832 1 2 INV4CK $T=899620 709520 0 0 $X=899620 $Y=709140
X953 855 856 1 2 INV4CK $T=903340 699440 0 0 $X=903340 $Y=699060
X954 4226 3958 1 2 INV4CK $T=913880 880880 0 180 $X=910160 $Y=875460
X955 4208 3833 1 2 INV4CK $T=922560 840560 0 180 $X=918840 $Y=835140
X956 870 871 1 2 INV4CK $T=920700 709520 0 0 $X=920700 $Y=709140
X957 878 822 1 2 INV4CK $T=932480 729680 0 180 $X=928760 $Y=724260
X958 911 907 1 2 INV4CK $T=968440 719600 0 180 $X=964720 $Y=714180
X959 4376 916 1 2 INV4CK $T=975260 749840 0 180 $X=971540 $Y=744420
X960 4384 4412 1 2 INV4CK $T=976500 820400 0 180 $X=972780 $Y=814980
X961 4370 919 1 2 INV4CK $T=977740 729680 0 180 $X=974020 $Y=724260
X962 4335 4437 1 2 INV4CK $T=977740 770000 0 180 $X=974020 $Y=764580
X963 920 921 1 2 INV4CK $T=975260 699440 0 0 $X=975260 $Y=699060
X964 4339 4434 1 2 INV4CK $T=975260 810320 1 0 $X=975260 $Y=804900
X965 4312 4393 1 2 INV4CK $T=984560 739760 0 180 $X=980840 $Y=734340
X966 4375 4443 1 2 INV4CK $T=987040 749840 1 0 $X=987040 $Y=744420
X967 4331 923 1 2 INV4CK $T=991380 729680 0 180 $X=987660 $Y=724260
X968 4447 4406 1 2 INV4CK $T=989520 820400 0 0 $X=989520 $Y=820020
X969 1197 1203 1 2 INV2CK $T=255440 749840 1 0 $X=255440 $Y=744420
X970 112 113 1 2 INV2CK $T=318060 709520 1 0 $X=318060 $Y=704100
X971 2223 268 1 2 INV2CK $T=482360 850640 0 0 $X=482360 $Y=850260
X972 2587 2600 1 2 INV2CK $T=554280 780080 0 180 $X=551800 $Y=774660
X973 2540 2428 1 2 INV2CK $T=558000 709520 0 180 $X=555520 $Y=704100
X974 4052 3966 1 2 INV2CK $T=871100 739760 0 0 $X=871100 $Y=739380
X975 4050 4164 1 2 INV2CK $T=898380 719600 0 0 $X=898380 $Y=719220
X976 4329 4335 1 2 INV2CK $T=946740 770000 0 180 $X=944260 $Y=764580
X977 4378 4375 1 2 INV2CK $T=957900 759920 0 180 $X=955420 $Y=754500
X978 4382 4384 1 2 INV2CK $T=957900 820400 0 0 $X=957900 $Y=820020
X979 4446 4447 1 2 INV2CK $T=978360 830480 0 180 $X=975880 $Y=825060
X980 1431 1 2 1447 DELC $T=305660 820400 1 0 $X=305660 $Y=814980
X981 1410 1 2 1449 DELC $T=306280 840560 0 0 $X=306280 $Y=840180
X982 1496 1 2 120 DELC $T=326120 880880 1 0 $X=326120 $Y=875460
X983 1629 1 2 1641 DELC $T=349680 860720 1 0 $X=349680 $Y=855300
X984 1589 1 2 2011 DELC $T=421600 870800 1 0 $X=421600 $Y=865380
X985 1621 1 2 2101 DELC $T=439580 850640 1 0 $X=439580 $Y=845220
X986 1650 1 2 2137 DELC $T=445780 870800 1 0 $X=445780 $Y=865380
X987 1630 1 2 2138 DELC $T=447020 850640 1 0 $X=447020 $Y=845220
X988 1703 1 2 2200 DELC $T=458800 850640 0 0 $X=458800 $Y=850260
X989 2232 1 2 2206 DELC $T=470580 850640 0 0 $X=470580 $Y=850260
X990 1679 1 2 2309 DELC $T=486080 850640 0 0 $X=486080 $Y=850260
X991 2385 1 2 2403 DELC $T=504060 870800 0 0 $X=504060 $Y=870420
X992 2407 1 2 2417 DELC $T=511500 850640 0 0 $X=511500 $Y=850260
X993 2399 1 2 2448 DELC $T=513360 820400 1 0 $X=513360 $Y=814980
X994 2440 1 2 2438 DELC $T=518320 850640 0 0 $X=518320 $Y=850260
X995 2479 1 2 2502 DELC $T=526380 850640 0 0 $X=526380 $Y=850260
X996 2500 1 2 2503 DELC $T=530720 860720 0 0 $X=530720 $Y=860340
X997 2507 1 2 2505 DELC $T=536300 870800 1 0 $X=536300 $Y=865380
X998 2546 1 2 2543 DELC $T=540020 830480 1 0 $X=540020 $Y=825060
X999 2555 1 2 2572 DELC $T=541880 810320 1 0 $X=541880 $Y=804900
X1000 373 1 2 2552 DELC $T=544980 709520 1 0 $X=544980 $Y=704100
X1001 1667 1 2 2601 DELC $T=545600 800240 0 0 $X=545600 $Y=799860
X1002 1652 1 2 2602 DELC $T=549320 870800 1 0 $X=549320 $Y=865380
X1003 2591 1 2 2612 DELC $T=549940 830480 0 0 $X=549940 $Y=830100
X1004 2606 1 2 2626 DELC $T=552420 820400 1 0 $X=552420 $Y=814980
X1005 2613 1 2 2629 DELC $T=554280 870800 1 0 $X=554280 $Y=865380
X1006 2620 1 2 2615 DELC $T=555520 780080 1 0 $X=555520 $Y=774660
X1007 2365 1 2 2614 DELC $T=555520 870800 0 0 $X=555520 $Y=870420
X1008 2625 1 2 2648 DELC $T=556760 800240 0 0 $X=556760 $Y=799860
X1009 2628 1 2 2638 DELC $T=557380 850640 1 0 $X=557380 $Y=845220
X1010 158 1 2 2634 DELC $T=559240 820400 1 0 $X=559240 $Y=814980
X1011 2635 1 2 2656 DELC $T=559860 800240 1 0 $X=559860 $Y=794820
X1012 2623 1 2 2637 DELC $T=562340 850640 1 0 $X=562340 $Y=845220
X1013 1657 1 2 2678 DELC $T=562960 790160 1 0 $X=562960 $Y=784740
X1014 2661 1 2 2677 DELC $T=564820 820400 0 0 $X=564820 $Y=820020
X1015 2688 1 2 2633 DELC $T=569160 800240 1 0 $X=569160 $Y=794820
X1016 1804 1 2 2715 DELC $T=572260 820400 0 0 $X=572260 $Y=820020
X1017 1720 1 2 2704 DELC $T=572880 850640 1 0 $X=572880 $Y=845220
X1018 1649 1 2 2725 DELC $T=576600 790160 1 0 $X=576600 $Y=784740
X1019 2660 1 2 2724 DELC $T=577220 820400 0 0 $X=577220 $Y=820020
X1020 2681 1 2 2729 DELC $T=579080 800240 1 0 $X=579080 $Y=794820
X1021 1646 1 2 2773 DELC $T=582180 820400 0 0 $X=582180 $Y=820020
X1022 1655 1 2 2775 DELC $T=587140 820400 0 0 $X=587140 $Y=820020
X1023 171 1 2 2788 DELC $T=588380 780080 0 0 $X=588380 $Y=779700
X1024 2807 1 2 2795 DELC $T=593340 739760 1 0 $X=593340 $Y=734340
X1025 1659 1 2 2818 DELC $T=594580 780080 0 0 $X=594580 $Y=779700
X1026 2841 1 2 2765 DELC $T=600780 790160 0 0 $X=600780 $Y=789780
X1027 2863 1 2 2865 DELC $T=603880 759920 0 0 $X=603880 $Y=759540
X1028 2887 1 2 2874 DELC $T=609460 810320 1 0 $X=609460 $Y=804900
X1029 2898 1 2 2877 DELC $T=611320 820400 1 0 $X=611320 $Y=814980
X1030 2908 1 2 2900 DELC $T=614420 790160 0 0 $X=614420 $Y=789780
X1031 2858 1 2 2923 DELC $T=614420 830480 1 0 $X=614420 $Y=825060
X1032 2951 1 2 2948 DELC $T=627440 840560 0 0 $X=627440 $Y=840180
X1033 567 1 2 2949 DELC $T=632400 840560 0 0 $X=632400 $Y=840180
X1034 584 1 2 3040 DELC $T=639840 840560 0 0 $X=639840 $Y=840180
X1035 3051 1 2 3072 DELC $T=646660 830480 0 0 $X=646660 $Y=830100
X1036 3075 1 2 3010 DELC $T=652860 810320 0 0 $X=652860 $Y=809940
X1037 3109 1 2 3042 DELC $T=659680 770000 1 0 $X=659680 $Y=764580
X1038 609 1 2 3126 DELC $T=664020 860720 1 0 $X=664020 $Y=855300
X1039 3248 1 2 3179 DELC $T=688200 780080 0 0 $X=688200 $Y=779700
X1040 3557 1 2 3559 DELC $T=739660 860720 1 0 $X=739660 $Y=855300
X1041 3601 1 2 3596 DELC $T=748960 850640 0 0 $X=748960 $Y=850260
X1042 4031 1 2 4022 DELC $T=865520 739760 1 0 $X=865520 $Y=734340
X1043 4083 1 2 4019 DELC $T=876680 739760 0 0 $X=876680 $Y=739380
X1044 4115 1 2 4096 DELC $T=892180 719600 1 0 $X=892180 $Y=714180
X1045 4136 1 2 4101 DELC $T=897140 699440 0 0 $X=897140 $Y=699060
X1046 4159 1 2 4097 DELC $T=897760 780080 0 0 $X=897760 $Y=779700
X1047 4127 1 2 4146 DELC $T=899620 729680 0 0 $X=899620 $Y=729300
X1048 4125 1 2 4095 DELC $T=901480 739760 0 0 $X=901480 $Y=739380
X1049 4167 1 2 4188 DELC $T=906440 870800 1 0 $X=906440 $Y=865380
X1050 4201 1 2 4219 DELC $T=911400 860720 1 0 $X=911400 $Y=855300
X1051 4244 1 2 4263 DELC $T=924420 749840 1 0 $X=924420 $Y=744420
X1052 4242 1 2 4176 DELC $T=926280 770000 0 0 $X=926280 $Y=769620
X1053 4277 1 2 4232 DELC $T=930000 770000 1 0 $X=930000 $Y=764580
X1054 4268 1 2 4300 DELC $T=937440 749840 1 0 $X=937440 $Y=744420
X1055 4314 1 2 4319 DELC $T=940540 860720 0 0 $X=940540 $Y=860340
X1056 4321 1 2 4346 DELC $T=943020 739760 1 0 $X=943020 $Y=734340
X1057 4345 1 2 4377 DELC $T=947360 790160 0 0 $X=947360 $Y=789780
X1058 4287 1 2 4330 DELC $T=948600 709520 1 0 $X=948600 $Y=704100
X1059 4350 1 2 4354 DELC $T=949220 810320 1 0 $X=949220 $Y=804900
X1060 4325 1 2 4327 DELC $T=949840 800240 0 0 $X=949840 $Y=799860
X1061 4311 1 2 4356 DELC $T=951700 850640 0 0 $X=951700 $Y=850260
X1062 4357 1 2 4374 DELC $T=952320 729680 0 0 $X=952320 $Y=729300
X1063 4389 1 2 4301 DELC $T=960380 749840 0 0 $X=960380 $Y=749460
X1064 4407 1 2 4341 DELC $T=965960 780080 0 0 $X=965960 $Y=779700
X1065 4394 1 2 4410 DELC $T=967200 739760 1 0 $X=967200 $Y=734340
X1066 4469 1 2 4458 DELC $T=987660 840560 0 0 $X=987660 $Y=840180
X1067 151 1654 1 2 1629 QDBHN $T=354640 860720 0 0 $X=354640 $Y=860340
X1068 248 2247 1 2 2232 QDBHN $T=471200 840560 0 0 $X=471200 $Y=840180
X1069 248 2581 1 2 2620 QDBHN $T=562960 790160 0 180 $X=555520 $Y=784740
X1070 448 2701 1 2 2681 QDBHN $T=575360 790160 0 180 $X=567920 $Y=784740
X1071 448 2701 1 2 2807 QDBHN $T=600160 749840 0 180 $X=592720 $Y=744420
X1072 448 2701 1 2 2841 QDBHN $T=593340 790160 0 0 $X=593340 $Y=789780
X1073 448 2701 1 2 2863 QDBHN $T=616280 770000 0 180 $X=608840 $Y=764580
X1074 448 2701 1 2 2898 QDBHN $T=622480 820400 1 180 $X=615040 $Y=820020
X1075 151 563 1 2 2951 QDBHN $T=633640 840560 0 180 $X=626200 $Y=835140
X1076 448 3057 1 2 3075 QDBHN $T=645420 810320 0 0 $X=645420 $Y=809940
X1077 448 3057 1 2 3109 QDBHN $T=653480 770000 0 0 $X=653480 $Y=769620
X1078 151 3152 1 2 3248 QDBHN $T=679520 780080 0 0 $X=679520 $Y=779700
X1079 3686 702 1 2 694 QDBHN $T=770040 820400 0 180 $X=762600 $Y=814980
X1080 3686 762 1 2 770 QDBHN $T=798560 850640 0 0 $X=798560 $Y=850260
X1081 3686 765 1 2 755 QDBHN $T=806000 860720 0 180 $X=798560 $Y=855300
X1082 3686 777 1 2 773 QDBHN $T=814680 860720 1 180 $X=807240 $Y=860340
X1083 813 4015 1 2 4031 QDBHN $T=857460 729680 0 0 $X=857460 $Y=729300
X1084 818 4073 1 2 4083 QDBHN $T=871100 719600 0 0 $X=871100 $Y=719220
X1085 818 4092 1 2 4125 QDBHN $T=877300 739760 1 0 $X=877300 $Y=734340
X1086 813 841 1 2 4115 QDBHN $T=892180 719600 0 180 $X=884740 $Y=714180
X1087 818 4141 1 2 4127 QDBHN $T=894660 739760 0 180 $X=887220 $Y=734340
X1088 818 4147 1 2 4136 QDBHN $T=897140 699440 1 180 $X=889700 $Y=699060
X1089 818 4160 1 2 4159 QDBHN $T=895280 790160 0 0 $X=895280 $Y=789780
X1090 818 4184 1 2 4167 QDBHN $T=906440 870800 1 180 $X=899000 $Y=870420
X1091 818 4224 1 2 4201 QDBHN $T=915120 840560 0 180 $X=907680 $Y=835140
X1092 818 4228 1 2 4242 QDBHN $T=911400 770000 0 0 $X=911400 $Y=769620
X1093 818 4230 1 2 4244 QDBHN $T=912020 749840 0 0 $X=912020 $Y=749460
X1094 813 869 1 2 872 QDBHN $T=917600 699440 0 0 $X=917600 $Y=699060
X1095 818 4259 1 2 4277 QDBHN $T=923180 759920 0 0 $X=923180 $Y=759540
X1096 813 4147 1 2 4268 QDBHN $T=935580 739760 0 180 $X=928140 $Y=734340
X1097 818 4259 1 2 4325 QDBHN $T=932480 800240 0 0 $X=932480 $Y=799860
X1098 813 881 1 2 4287 QDBHN $T=940540 709520 0 180 $X=933100 $Y=704100
X1099 818 4230 1 2 4350 QDBHN $T=938680 810320 0 0 $X=938680 $Y=809940
X1100 818 4224 1 2 4345 QDBHN $T=940540 780080 0 0 $X=940540 $Y=779700
X1101 839 4184 1 2 4311 QDBHN $T=947980 860720 0 180 $X=940540 $Y=855300
X1102 839 892 1 2 4314 QDBHN $T=954180 870800 0 180 $X=946740 $Y=865380
X1103 818 4092 1 2 4321 QDBHN $T=957280 739760 0 180 $X=949840 $Y=734340
X1104 813 4073 1 2 4357 QDBHN $T=960380 729680 0 180 $X=952940 $Y=724260
X1105 818 4228 1 2 4407 QDBHN $T=958520 780080 0 0 $X=958520 $Y=779700
X1106 813 4015 1 2 4389 QDBHN $T=969060 759920 0 180 $X=961620 $Y=754500
X1107 818 4141 1 2 4394 QDBHN $T=970300 729680 0 180 $X=962860 $Y=724260
X1108 839 4160 1 2 4469 QDBHN $T=991380 840560 0 180 $X=983940 $Y=835140
X1109 1641 91 1533 1 2 AN2T $T=358980 860720 0 180 $X=354640 $Y=855300
X1110 1886 1834 1920 1 2 AN2T $T=404860 770000 0 0 $X=404860 $Y=769620
X1111 1937 1954 1884 1 2 AN2T $T=417880 800240 1 180 $X=413540 $Y=799860
X1112 2206 248 2223 1 2 AN2T $T=464380 850640 0 0 $X=464380 $Y=850260
X1113 2552 248 2540 1 2 AN2T $T=541880 709520 0 180 $X=537540 $Y=704100
X1114 2615 248 2587 1 2 AN2T $T=551800 790160 0 180 $X=547460 $Y=784740
X1115 2729 448 2686 1 2 AN2T $T=579080 790160 0 0 $X=579080 $Y=789780
X1116 2765 448 2762 1 2 AN2T $T=585280 790160 0 0 $X=585280 $Y=789780
X1117 2795 248 2776 1 2 AN2T $T=590240 739760 0 180 $X=585900 $Y=734340
X1118 2865 448 2815 1 2 AN2T $T=605120 770000 0 180 $X=600780 $Y=764580
X1119 2877 448 2862 1 2 AN2T $T=606980 820400 1 0 $X=606980 $Y=814980
X1120 3010 448 3026 1 2 AN2T $T=638600 800240 0 0 $X=638600 $Y=799860
X1121 3042 448 3064 1 2 AN2T $T=645420 770000 0 0 $X=645420 $Y=769620
X1122 4019 818 4050 1 2 AN2T $T=863040 719600 0 0 $X=863040 $Y=719220
X1123 4022 813 4052 1 2 AN2T $T=863040 739760 0 0 $X=863040 $Y=739380
X1124 4095 818 3999 1 2 AN2T $T=874820 749840 1 180 $X=870480 $Y=749460
X1125 4096 813 827 1 2 AN2T $T=881020 709520 1 180 $X=876680 $Y=709140
X1126 4097 818 4112 1 2 AN2T $T=880400 790160 0 0 $X=880400 $Y=789780
X1127 4101 818 4011 1 2 AN2T $T=881640 699440 0 0 $X=881640 $Y=699060
X1128 840 839 835 1 2 AN2T $T=889080 880880 0 180 $X=884740 $Y=875460
X1129 4146 818 4130 1 2 AN2T $T=891560 749840 0 180 $X=887220 $Y=744420
X1130 4188 839 4170 1 2 AN2T $T=902720 860720 1 180 $X=898380 $Y=860340
X1131 4176 818 4180 1 2 AN2T $T=903340 770000 0 0 $X=903340 $Y=769620
X1132 4219 839 4206 1 2 AN2T $T=912020 850640 0 180 $X=907680 $Y=845220
X1133 4232 818 4237 1 2 AN2T $T=915120 759920 0 0 $X=915120 $Y=759540
X1134 4263 818 4252 1 2 AN2T $T=927520 749840 1 180 $X=923180 $Y=749460
X1135 4300 813 4290 1 2 AN2T $T=937440 749840 0 180 $X=933100 $Y=744420
X1136 4301 813 4310 1 2 AN2T $T=936820 759920 1 0 $X=936820 $Y=754500
X1137 4319 839 4308 1 2 AN2T $T=943020 870800 0 180 $X=938680 $Y=865380
X1138 4341 818 4324 1 2 AN2T $T=946120 790160 1 180 $X=941780 $Y=789780
X1139 4346 818 4329 1 2 AN2T $T=947360 749840 0 180 $X=943020 $Y=744420
X1140 4327 818 4332 1 2 AN2T $T=943640 800240 0 0 $X=943640 $Y=799860
X1141 4330 813 895 1 2 AN2T $T=944260 709520 1 0 $X=944260 $Y=704100
X1142 4354 818 4362 1 2 AN2T $T=949840 810320 0 0 $X=949840 $Y=809940
X1143 4356 839 4369 1 2 AN2T $T=951700 860720 1 0 $X=951700 $Y=855300
X1144 4377 818 4382 1 2 AN2T $T=958520 790160 0 0 $X=958520 $Y=789780
X1145 4374 813 4378 1 2 AN2T $T=959760 749840 1 0 $X=959760 $Y=744420
X1146 4410 818 4315 1 2 AN2T $T=967200 739760 0 180 $X=962860 $Y=734340
X1147 4458 818 4446 1 2 AN2T $T=980220 840560 0 180 $X=975880 $Y=835140
X1148 1736 1 2 1726 DELA $T=378820 759920 1 0 $X=378820 $Y=754500
X1149 2504 1 2 380 DELA $T=544360 870800 1 0 $X=544360 $Y=865380
X1150 2527 1 2 431 DELA $T=565440 880880 1 0 $X=565440 $Y=875460
X1151 2618 1 2 2728 DELA $T=576600 870800 0 0 $X=576600 $Y=870420
X1152 2999 1 2 2986 DELA $T=636740 780080 1 0 $X=636740 $Y=774660
X1153 3014 1 2 3028 DELA $T=641700 790160 0 0 $X=641700 $Y=789780
X1154 3030 1 2 3003 DELA $T=642940 800240 0 0 $X=642940 $Y=799860
X1155 3041 1 2 3036 DELA $T=645420 749840 0 0 $X=645420 $Y=749460
X1156 3086 1 2 3080 DELA $T=654720 820400 1 0 $X=654720 $Y=814980
X1157 3101 1 2 3043 DELA $T=665260 739760 1 0 $X=665260 $Y=734340
X1158 3162 1 2 3177 DELA $T=670220 830480 1 0 $X=670220 $Y=825060
X1159 3284 1 2 3349 DELA $T=701840 820400 0 0 $X=701840 $Y=820020
X1160 3358 1 2 3386 DELA $T=704940 790160 0 0 $X=704940 $Y=789780
X1161 3851 1 2 3772 DELA $T=813440 840560 1 0 $X=813440 $Y=835140
X1162 4498 1 2 4473 DELA $T=996340 790160 0 0 $X=996340 $Y=789780
X1163 4516 1 2 4387 DELA $T=999440 810320 0 0 $X=999440 $Y=809940
X1164 18 13 12 2 10 9 1 AO22 $T=231260 699440 1 180 $X=226300 $Y=699060
X1165 1075 1069 1042 2 1050 9 1 AO22 $T=231260 739760 0 180 $X=226300 $Y=734340
X1166 1104 1069 1043 2 1051 9 1 AO22 $T=231880 749840 1 180 $X=226920 $Y=749460
X1167 1083 1069 1045 2 1053 9 1 AO22 $T=231880 780080 0 180 $X=226920 $Y=774660
X1168 1080 13 1024 2 1063 9 1 AO22 $T=232500 709520 0 180 $X=227540 $Y=704100
X1169 1081 13 1041 2 1060 9 1 AO22 $T=232500 719600 1 180 $X=227540 $Y=719220
X1170 1085 1069 1044 2 1056 9 1 AO22 $T=232500 759920 1 180 $X=227540 $Y=759540
X1171 1092 1069 1055 2 1017 9 1 AO22 $T=233740 780080 1 180 $X=228780 $Y=779700
X1172 1127 26 1028 2 19 16 1 AO22 $T=235600 870800 1 180 $X=230640 $Y=870420
X1173 1108 26 1067 2 22 16 1 AO22 $T=236220 860720 0 180 $X=231260 $Y=855300
X1174 1136 1069 1072 2 1086 9 1 AO22 $T=237460 790160 0 180 $X=232500 $Y=784740
X1175 1137 1102 1070 2 1087 9 1 AO22 $T=237460 800240 1 180 $X=232500 $Y=799860
X1176 1110 1102 1066 2 1078 9 1 AO22 $T=237460 810320 1 180 $X=232500 $Y=809940
X1177 1167 1115 1102 2 1099 9 1 AO22 $T=243660 830480 1 180 $X=238700 $Y=830100
X1178 1190 1138 26 2 30 16 1 AO22 $T=251100 870800 1 180 $X=246140 $Y=870420
X1179 1135 1193 1198 2 1200 48 1 AO22 $T=252960 780080 1 0 $X=252960 $Y=774660
X1180 1154 1193 1205 2 1206 48 1 AO22 $T=254200 830480 1 0 $X=254200 $Y=825060
X1181 1204 45 47 2 50 51 1 AO22 $T=256060 880880 1 0 $X=256060 $Y=875460
X1182 1126 1193 1215 2 1218 48 1 AO22 $T=256680 800240 1 0 $X=256680 $Y=794820
X1183 1132 1193 1196 2 1228 48 1 AO22 $T=259160 759920 0 0 $X=259160 $Y=759540
X1184 1159 1193 1222 2 1229 48 1 AO22 $T=259160 780080 1 0 $X=259160 $Y=774660
X1185 1144 1193 1223 2 1230 48 1 AO22 $T=259160 790160 1 0 $X=259160 $Y=784740
X1186 1145 1193 1224 2 1231 48 1 AO22 $T=259160 810320 0 0 $X=259160 $Y=809940
X1187 1161 1193 1227 2 1239 48 1 AO22 $T=259780 820400 0 0 $X=259780 $Y=820020
X1188 1123 1193 1240 2 1241 48 1 AO22 $T=260400 830480 1 0 $X=260400 $Y=825060
X1189 1212 52 1236 2 1244 48 1 AO22 $T=261020 749840 0 0 $X=261020 $Y=749460
X1190 1177 1193 1237 2 1245 48 1 AO22 $T=261020 800240 0 0 $X=261020 $Y=799860
X1191 1162 1232 45 2 1246 55 1 AO22 $T=261020 850640 1 0 $X=261020 $Y=845220
X1192 46 52 1248 2 1257 48 1 AO22 $T=262880 699440 0 0 $X=262880 $Y=699060
X1193 1194 45 1268 2 54 51 1 AO22 $T=264740 870800 1 0 $X=264740 $Y=865380
X1194 1195 52 1252 2 1274 48 1 AO22 $T=265360 709520 0 0 $X=265360 $Y=709140
X1195 1178 52 1253 2 1275 48 1 AO22 $T=265360 719600 0 0 $X=265360 $Y=719220
X1196 1202 52 1287 2 1255 48 1 AO22 $T=274040 739760 0 180 $X=269080 $Y=734340
X1197 1322 45 1310 2 61 51 1 AO22 $T=280240 860720 1 180 $X=275280 $Y=860340
X1198 1315 45 70 2 64 51 1 AO22 $T=280860 880880 0 180 $X=275900 $Y=875460
X1199 1372 45 1358 2 77 51 1 AO22 $T=288920 870800 1 180 $X=283960 $Y=870420
X1200 90 45 1362 2 74 51 1 AO22 $T=295120 880880 0 180 $X=290160 $Y=875460
X1201 1499 102 1476 2 110 108 1 AO22 $T=320540 739760 0 180 $X=315580 $Y=734340
X1202 1383 118 1525 2 1532 119 1 AO22 $T=326120 820400 1 0 $X=326120 $Y=814980
X1203 1500 118 1527 2 1535 119 1 AO22 $T=326740 749840 0 0 $X=326740 $Y=749460
X1204 1463 118 1528 2 1537 119 1 AO22 $T=326740 790160 0 0 $X=326740 $Y=789780
X1205 1520 118 1513 2 1530 119 1 AO22 $T=326740 830480 0 0 $X=326740 $Y=830100
X1206 1460 118 1531 2 1538 119 1 AO22 $T=327360 759920 1 0 $X=327360 $Y=754500
X1207 1516 118 1541 2 1549 119 1 AO22 $T=329220 770000 1 0 $X=329220 $Y=764580
X1208 1423 118 1542 2 1550 119 1 AO22 $T=329220 780080 1 0 $X=329220 $Y=774660
X1209 1495 121 1544 2 1555 119 1 AO22 $T=329840 709520 0 0 $X=329840 $Y=709140
X1210 1482 118 1552 2 1557 119 1 AO22 $T=329840 800240 0 0 $X=329840 $Y=799860
X1211 1547 118 1558 2 1561 119 1 AO22 $T=331700 729680 0 0 $X=331700 $Y=729300
X1212 1387 118 1546 2 1564 119 1 AO22 $T=332320 830480 0 0 $X=332320 $Y=830100
X1213 1451 118 1568 2 1578 119 1 AO22 $T=334180 780080 0 0 $X=334180 $Y=779700
X1214 1540 121 125 2 1579 119 1 AO22 $T=334800 699440 0 0 $X=334800 $Y=699060
X1215 1522 118 1573 2 1580 119 1 AO22 $T=334800 719600 0 0 $X=334800 $Y=719220
X1216 1455 118 1574 2 1581 119 1 AO22 $T=334800 810320 1 0 $X=334800 $Y=804900
X1217 1498 118 1591 2 1601 119 1 AO22 $T=337900 830480 1 0 $X=337900 $Y=825060
X1218 1699 169 1763 2 1770 165 1 AO22 $T=380680 739760 0 0 $X=380680 $Y=739380
X1219 1820 154 1829 2 1835 1834 1 AO22 $T=393080 820400 1 0 $X=393080 $Y=814980
X1220 1801 169 1822 2 1843 165 1 AO22 $T=394940 749840 0 0 $X=394940 $Y=749460
X1221 1812 154 1838 2 1840 1834 1 AO22 $T=394940 830480 0 0 $X=394940 $Y=830100
X1222 1773 154 1847 2 1848 1834 1 AO22 $T=395560 810320 0 0 $X=395560 $Y=809940
X1223 1765 154 1844 2 1851 1834 1 AO22 $T=396180 830480 1 0 $X=396180 $Y=825060
X1224 1870 169 1874 2 1889 165 1 AO22 $T=402380 739760 0 0 $X=402380 $Y=739380
X1225 1862 169 1939 2 1940 165 1 AO22 $T=414160 759920 1 0 $X=414160 $Y=754500
X1226 1850 1955 1930 2 1938 1834 1 AO22 $T=415400 830480 0 0 $X=415400 $Y=830100
X1227 1961 169 1952 2 1973 165 1 AO22 $T=417260 749840 1 0 $X=417260 $Y=744420
X1228 1898 1948 1955 2 1987 1834 1 AO22 $T=420360 830480 1 0 $X=420360 $Y=825060
X1229 2016 169 1986 2 1993 165 1 AO22 $T=427800 749840 0 180 $X=422840 $Y=744420
X1230 2043 1955 1988 2 2023 1834 1 AO22 $T=434000 830480 1 180 $X=429040 $Y=830100
X1231 1976 1955 2034 2 2030 1834 1 AO22 $T=430280 830480 1 0 $X=430280 $Y=825060
X1232 2031 169 2037 2 2049 165 1 AO22 $T=431520 749840 1 0 $X=431520 $Y=744420
X1233 2054 169 2070 2 2076 2092 1 AO22 $T=437720 749840 1 0 $X=437720 $Y=744420
X1234 2091 1955 2050 2 2072 1834 1 AO22 $T=443920 830480 0 180 $X=438960 $Y=825060
X1235 2089 1955 2068 2 2067 1834 1 AO22 $T=444540 830480 1 180 $X=439580 $Y=830100
X1236 2086 1707 2095 2 207 198 1 AO22 $T=443920 860720 1 0 $X=443920 $Y=855300
X1237 2122 2119 2114 2 2105 2092 1 AO22 $T=449500 749840 0 180 $X=444540 $Y=744420
X1238 2107 1955 2106 2 2132 2150 1 AO22 $T=448260 830480 1 0 $X=448260 $Y=825060
X1239 2176 1955 2168 2 2146 2150 1 AO22 $T=459420 830480 0 180 $X=454460 $Y=825060
X1240 2154 2119 2157 2 2163 2092 1 AO22 $T=458800 749840 0 0 $X=458800 $Y=749460
X1241 2224 2119 2216 2 2203 2092 1 AO22 $T=468720 749840 1 180 $X=463760 $Y=749460
X1242 2266 2249 2217 2 2186 2150 1 AO22 $T=476160 830480 0 180 $X=471200 $Y=825060
X1243 2256 2119 2263 2 2275 2092 1 AO22 $T=476160 749840 0 0 $X=476160 $Y=749460
X1244 2288 2249 2257 2 2231 2150 1 AO22 $T=482980 820400 1 180 $X=478020 $Y=820020
X1245 2294 2249 2284 2 2185 2150 1 AO22 $T=483600 810320 1 180 $X=478640 $Y=809940
X1246 2271 2119 2289 2 2170 2092 1 AO22 $T=482360 749840 0 0 $X=482360 $Y=749460
X1247 2295 2305 2119 2 2301 2092 1 AO22 $T=486080 719600 0 0 $X=486080 $Y=719220
X1248 2325 2119 2312 2 2238 2092 1 AO22 $T=492900 729680 1 180 $X=487940 $Y=729300
X1249 2334 2119 2324 2 2215 2092 1 AO22 $T=493520 749840 1 180 $X=488560 $Y=749460
X1250 2380 2119 2358 2 2280 2092 1 AO22 $T=502820 729680 0 180 $X=497860 $Y=724260
X1251 2375 2119 2316 2 2235 2092 1 AO22 $T=503440 739760 1 180 $X=498480 $Y=739380
X1252 2386 2119 2357 2 2267 2092 1 AO22 $T=505300 719600 1 180 $X=500340 $Y=719220
X1253 2392 2119 2373 2 2303 2092 1 AO22 $T=505300 749840 1 180 $X=500340 $Y=749460
X1254 332 326 2481 2 2367 309 1 AO22 $T=528860 860720 0 180 $X=523900 $Y=855300
X1255 334 326 2469 2 2379 309 1 AO22 $T=528860 860720 1 180 $X=523900 $Y=860340
X1256 2504 326 2477 2 2418 309 1 AO22 $T=530720 870800 0 180 $X=525760 $Y=865380
X1257 2527 326 2518 2 2321 309 1 AO22 $T=536300 870800 0 180 $X=531340 $Y=865380
X1258 2509 285 263 2 2526 293 1 AO22 $T=532580 880880 1 0 $X=532580 $Y=875460
X1259 381 326 2563 2 2361 309 1 AO22 $T=549320 870800 1 180 $X=544360 $Y=870420
X1260 2618 326 2603 2 2307 309 1 AO22 $T=555520 870800 1 180 $X=550560 $Y=870420
X1261 2689 326 2666 2 2657 309 1 AO22 $T=568540 860720 1 180 $X=563580 $Y=860340
X1262 2707 326 2699 2 2694 309 1 AO22 $T=574740 810320 0 180 $X=569780 $Y=804900
X1263 2734 326 2720 2 2685 309 1 AO22 $T=579700 810320 0 180 $X=574740 $Y=804900
X1264 2769 326 2750 2 2742 309 1 AO22 $T=585280 820400 0 180 $X=580320 $Y=814980
X1265 476 326 2731 2 2749 309 1 AO22 $T=585280 850640 1 180 $X=580320 $Y=850260
X1266 2770 326 2743 2 2751 309 1 AO22 $T=586520 840560 0 180 $X=581560 $Y=835140
X1267 2796 326 2782 2 2772 309 1 AO22 $T=590240 810320 0 180 $X=585280 $Y=804900
X1268 2825 326 2786 2 2800 309 1 AO22 $T=595200 830480 0 180 $X=590240 $Y=825060
X1269 2822 326 2813 2 2805 309 1 AO22 $T=595820 800240 1 180 $X=590860 $Y=799860
X1270 2870 326 2856 2 2849 309 1 AO22 $T=605740 820400 0 180 $X=600780 $Y=814980
X1271 2876 326 2837 2 2850 309 1 AO22 $T=605740 830480 1 180 $X=600780 $Y=830100
X1272 2864 522 364 2 2874 513 1 AO22 $T=609460 810320 0 180 $X=604500 $Y=804900
X1273 2873 522 422 2 2900 513 1 AO22 $T=608840 790160 0 0 $X=608840 $Y=789780
X1274 2903 522 435 2 2923 513 1 AO22 $T=619380 830480 1 0 $X=619380 $Y=825060
X1275 2931 522 418 2 2949 513 1 AO22 $T=622480 840560 0 0 $X=622480 $Y=840180
X1276 2968 573 2995 2 2965 580 1 AO22 $T=633640 800240 0 0 $X=633640 $Y=799860
X1277 2964 577 3001 2 3008 580 1 AO22 $T=634880 759920 1 0 $X=634880 $Y=754500
X1278 2981 577 3002 2 2994 580 1 AO22 $T=634880 780080 0 0 $X=634880 $Y=779700
X1279 2999 577 2997 2 3012 580 1 AO22 $T=636740 770000 0 0 $X=636740 $Y=769620
X1280 3014 586 3022 2 3029 580 1 AO22 $T=639840 790160 1 0 $X=639840 $Y=784740
X1281 3030 586 3027 2 3019 580 1 AO22 $T=642320 810320 1 0 $X=642320 $Y=804900
X1282 2987 522 415 2 3040 513 1 AO22 $T=644800 840560 0 0 $X=644800 $Y=840180
X1283 3051 522 441 2 3082 513 1 AO22 $T=651000 830480 1 0 $X=651000 $Y=825060
X1284 3070 522 416 2 601 513 1 AO22 $T=651620 840560 0 0 $X=651620 $Y=840180
X1285 3086 573 3113 2 3121 3111 1 AO22 $T=659680 800240 0 0 $X=659680 $Y=799860
X1286 3103 522 399 2 3126 513 1 AO22 $T=660920 850640 1 0 $X=660920 $Y=845220
X1287 3162 577 3160 2 3153 3111 1 AO22 $T=672080 810320 0 180 $X=667120 $Y=804900
X1288 698 3686 3690 2 711 3702 1 AO22 $T=766320 790160 0 0 $X=766320 $Y=789780
X1289 707 3686 3697 2 716 3702 1 AO22 $T=768180 800240 0 0 $X=768180 $Y=799860
X1290 708 3686 3708 2 3710 3702 1 AO22 $T=770040 810320 0 0 $X=770040 $Y=809940
X1291 710 3686 3709 2 720 3702 1 AO22 $T=770040 840560 1 0 $X=770040 $Y=835140
X1292 704 3686 3719 2 3722 3702 1 AO22 $T=771280 820400 0 0 $X=771280 $Y=820020
X1293 730 3686 3757 2 735 3702 1 AO22 $T=779960 850640 1 0 $X=779960 $Y=845220
X1294 768 3686 3837 2 775 3702 1 AO22 $T=805380 850640 1 0 $X=805380 $Y=845220
X1295 3834 3686 3839 2 776 3702 1 AO22 $T=806000 820400 0 0 $X=806000 $Y=820020
X1296 3848 3686 3867 2 780 3702 1 AO22 $T=815920 810320 1 0 $X=815920 $Y=804900
X1297 3852 3686 3895 2 784 3702 1 AO22 $T=822120 810320 1 0 $X=822120 $Y=804900
X1298 3933 3686 4012 2 814 3702 1 AO22 $T=854980 810320 0 0 $X=854980 $Y=809940
X1299 3842 3686 4089 2 829 3702 1 AO22 $T=877300 810320 0 0 $X=877300 $Y=809940
X1300 4107 3686 4120 2 838 3702 1 AO22 $T=884120 830480 0 0 $X=884120 $Y=830100
X1301 885 3686 4317 2 890 3702 1 AO22 $T=940540 800240 1 0 $X=940540 $Y=794820
X1302 886 3686 4318 2 891 3702 1 AO22 $T=940540 810320 1 0 $X=940540 $Y=804900
X1303 913 3686 4427 2 4432 3702 1 AO22 $T=969680 850640 0 0 $X=969680 $Y=850260
X1304 927 3686 4478 2 929 3702 1 AO22 $T=985180 850640 1 0 $X=985180 $Y=845220
X1305 941 3686 4559 2 943 3702 1 AO22 $T=1013080 790160 0 0 $X=1013080 $Y=789780
X1306 4518 3686 4607 2 4610 3702 1 AO22 $T=1030440 800240 1 0 $X=1030440 $Y=794820
X1307 4424 3686 4625 2 956 3702 1 AO22 $T=1034160 860720 0 0 $X=1034160 $Y=860340
X1308 4486 3686 4629 2 958 3702 1 AO22 $T=1036020 790160 0 0 $X=1036020 $Y=789780
X1309 4521 3686 4634 2 4636 3702 1 AO22 $T=1039740 850640 1 0 $X=1039740 $Y=845220
X1310 4403 3686 4632 2 960 3702 1 AO22 $T=1039740 850640 0 0 $X=1039740 $Y=850260
X1311 4348 3686 4635 2 961 3702 1 AO22 $T=1040360 860720 1 0 $X=1040360 $Y=855300
X1312 2929 2 2914 2915 2943 1 2965 FA1S $T=618140 800240 1 0 $X=618140 $Y=794820
X1313 2943 2 2926 2934 2971 1 2994 FA1S $T=620620 780080 1 0 $X=620620 $Y=774660
X1314 2955 2 569 2975 2963 1 2928 FA1S $T=633640 870800 1 180 $X=621860 $Y=870420
X1315 2967 2 2926 2941 3004 1 3002 FA1S $T=626200 790160 1 0 $X=626200 $Y=784740
X1316 2982 2 2914 2921 2967 1 2995 FA1S $T=628680 810320 1 0 $X=628680 $Y=804900
X1317 2989 2 2950 2977 2929 1 3019 FA1S $T=629920 800240 1 0 $X=629920 $Y=794820
X1318 2998 2 2950 2972 2982 1 3027 FA1S $T=631160 820400 1 0 $X=631160 $Y=814980
X1319 3025 2 2939 3056 3034 1 2997 FA1S $T=647280 770000 0 180 $X=635500 $Y=764580
X1320 3004 2 3071 3044 3025 1 3022 FA1S $T=643560 780080 1 0 $X=643560 $Y=774660
X1321 3074 2 2939 3062 3077 1 3012 FA1S $T=659060 770000 0 180 $X=647280 $Y=764580
X1322 2971 2 3071 3060 3074 1 3029 FA1S $T=649140 790160 1 0 $X=649140 $Y=784740
X1323 3079 2 2996 3107 3081 1 3119 FA1S $T=651000 739760 0 0 $X=651000 $Y=739380
X1324 3092 2 3031 3059 2998 1 3113 FA1S $T=651620 810320 1 0 $X=651620 $Y=804900
X1325 3099 2 3031 3055 2989 1 3121 FA1S $T=653480 800240 1 0 $X=653480 $Y=794820
X1326 3122 2 3106 3137 3092 1 3160 FA1S $T=658440 810320 0 0 $X=658440 $Y=809940
X1327 3142 2 3084 3148 3129 1 3102 FA1S $T=671460 719600 0 180 $X=659680 $Y=714180
X1328 3141 2 3084 3156 3165 1 3114 FA1S $T=673320 729680 1 180 $X=661540 $Y=729300
X1329 3167 2 2996 3128 3182 1 3112 FA1S $T=676420 739760 1 180 $X=664640 $Y=739380
X1330 3158 2 3106 3140 3099 1 3153 FA1S $T=664640 800240 0 0 $X=664640 $Y=799860
X1331 3201 2 3233 3234 3206 1 3159 FA1S $T=682000 850640 1 180 $X=670220 $Y=850260
X1332 3203 2 3176 3185 3122 1 3251 FA1S $T=673320 810320 0 0 $X=673320 $Y=809940
X1333 3138 2 3171 3227 3186 1 3240 FA1S $T=673320 830480 0 0 $X=673320 $Y=830100
X1334 3220 2 3231 3232 3159 1 3186 FA1S $T=685720 840560 0 180 $X=673940 $Y=835140
X1335 3218 2 3176 3191 3158 1 3265 FA1S $T=675800 810320 1 0 $X=675800 $Y=804900
X1336 624 2 612 618 3246 1 3190 FA1S $T=688820 880880 0 180 $X=677040 $Y=875460
X1337 3229 2 626 3202 3224 1 3228 FA1S $T=678900 709520 1 0 $X=678900 $Y=704100
X1338 3256 2 626 3194 3267 1 3221 FA1S $T=692540 719600 0 180 $X=680760 $Y=714180
X1339 3234 2 3333 3326 3278 1 3242 FA1S $T=696880 850640 1 180 $X=685100 $Y=850260
X1340 633 2 628 3264 3229 1 640 FA1S $T=687580 699440 0 0 $X=687580 $Y=699060
X1341 3283 2 3266 3263 3203 1 3314 FA1S $T=687580 810320 0 0 $X=687580 $Y=809940
X1342 3232 2 3287 3348 3242 1 3274 FA1S $T=701220 840560 1 180 $X=689440 $Y=840180
X1343 3299 2 3266 3198 3218 1 3325 FA1S $T=690680 800240 0 0 $X=690680 $Y=799860
X1344 3227 2 3275 3330 3274 1 3340 FA1S $T=690680 830480 0 0 $X=690680 $Y=830100
X1345 3304 2 3371 3406 3331 1 3278 FA1S $T=703700 860720 0 180 $X=691920 $Y=855300
X1346 3308 2 628 3288 3256 1 644 FA1S $T=692540 709520 1 0 $X=692540 $Y=704100
X1347 3334 2 3350 3304 3343 1 3206 FA1S $T=705560 870800 0 180 $X=693780 $Y=865380
X1348 3324 2 3300 3291 3299 1 3370 FA1S $T=695020 780080 0 0 $X=695020 $Y=779700
X1349 3335 2 3300 3135 3283 1 3394 FA1S $T=696260 790160 1 0 $X=696260 $Y=784740
X1350 3348 2 3369 3392 3354 1 3307 FA1S $T=708040 850640 0 180 $X=696260 $Y=845220
X1351 3330 2 3316 3393 3307 1 3400 FA1S $T=700600 840560 1 0 $X=700600 $Y=835140
X1352 3362 2 643 641 3308 1 647 FA1S $T=701840 699440 0 0 $X=701840 $Y=699060
X1353 3326 2 3409 3423 3418 1 3354 FA1S $T=716100 850640 1 180 $X=704320 $Y=850260
X1354 3398 2 3377 3365 3324 1 3449 FA1S $T=706180 780080 1 0 $X=706180 $Y=774660
X1355 3410 2 634 650 3362 1 652 FA1S $T=707420 709520 1 0 $X=707420 $Y=704100
X1356 3412 2 3377 3136 3335 1 3442 FA1S $T=708040 780080 0 0 $X=708040 $Y=779700
X1357 3407 2 3447 3463 3440 1 3343 FA1S $T=721680 870800 1 180 $X=709900 $Y=870420
X1358 3393 2 3391 3472 3448 1 3405 FA1S $T=722920 830480 1 180 $X=711140 $Y=830100
X1359 3392 2 3426 3473 3420 1 3448 FA1S $T=714860 840560 1 0 $X=714860 $Y=835140
X1360 3498 2 3511 3235 3398 1 3460 FA1S $T=733460 780080 0 180 $X=721680 $Y=774660
X1361 3502 2 3511 3105 3412 1 3462 FA1S $T=734080 780080 1 180 $X=722300 $Y=779700
X1362 3472 2 3489 3499 3517 1 3528 FA1S $T=730360 830480 0 0 $X=730360 $Y=830100
X1363 3558 2 3529 3296 3502 1 3604 FA1S $T=735320 790160 1 0 $X=735320 $Y=784740
X1364 3583 2 3529 3222 3498 1 3600 FA1S $T=740280 780080 0 0 $X=740280 $Y=779700
X1365 3716 2 3701 3688 3741 1 3737 FA1S $T=768800 770000 0 0 $X=768800 $Y=769620
X1366 3741 2 3668 3718 3748 1 3713 FA1S $T=783680 759920 1 180 $X=771900 $Y=759540
X1367 3739 2 3701 3747 3792 1 3727 FA1S $T=782440 780080 1 0 $X=782440 $Y=774660
X1368 3792 2 3668 3765 3795 1 3769 FA1S $T=797940 770000 0 180 $X=786160 $Y=764580
X1369 1360 84 1385 2 1 1393 QDFFRBN $T=285820 830480 0 0 $X=285820 $Y=830100
X1370 1349 84 1385 2 1 1407 QDFFRBN $T=287680 820400 0 0 $X=287680 $Y=820020
X1371 1367 84 1385 2 1 1411 QDFFRBN $T=288300 800240 0 0 $X=288300 $Y=799860
X1372 1368 84 1385 2 1 1406 QDFFRBN $T=288920 840560 0 0 $X=288920 $Y=840180
X1373 1378 84 1385 2 1 1438 QDFFRBN $T=292020 800240 1 0 $X=292020 $Y=794820
X1374 1379 84 1385 2 1 1431 QDFFRBN $T=294500 810320 0 0 $X=294500 $Y=809940
X1375 1395 84 1385 2 1 1439 QDFFRBN $T=296980 810320 1 0 $X=296980 $Y=804900
X1376 1396 84 1385 2 1 1443 QDFFRBN $T=297600 780080 0 0 $X=297600 $Y=779700
X1377 1399 84 1385 2 1 1445 QDFFRBN $T=299460 770000 1 0 $X=299460 $Y=764580
X1378 1416 84 105 2 1 1470 QDFFRBN $T=302560 749840 0 0 $X=302560 $Y=749460
X1379 1435 84 105 2 1 1488 QDFFRBN $T=306900 719600 1 0 $X=306900 $Y=714180
X1380 1437 84 1385 2 1 1480 QDFFRBN $T=306900 770000 0 0 $X=306900 $Y=769620
X1381 104 84 105 2 1 1491 QDFFRBN $T=309380 699440 0 0 $X=309380 $Y=699060
X1382 1444 84 105 2 1 1476 QDFFRBN $T=310620 729680 1 0 $X=310620 $Y=724260
X1383 1468 84 105 2 1 1518 QDFFRBN $T=316200 739760 0 0 $X=316200 $Y=739380
X1384 1452 84 111 2 1 122 QDFFRBN $T=319920 860720 1 0 $X=319920 $Y=855300
X1385 1509 106 111 2 1 126 QDFFRBN $T=323640 870800 1 0 $X=323640 $Y=865380
X1386 1508 1533 111 2 1 1589 QDFFRBN $T=327360 850640 1 0 $X=327360 $Y=845220
X1387 1490 1533 1385 2 1 1621 QDFFRBN $T=332940 840560 0 0 $X=332940 $Y=840180
X1388 1572 1533 1385 2 1 1630 QDFFRBN $T=337900 840560 1 0 $X=337900 $Y=835140
X1389 1593 106 111 2 1 143 QDFFRBN $T=339140 870800 1 0 $X=339140 $Y=865380
X1390 1559 1533 1385 2 1 1646 QDFFRBN $T=344100 820400 0 0 $X=344100 $Y=820020
X1391 1618 1533 1385 2 1 1652 QDFFRBN $T=344720 830480 0 0 $X=344720 $Y=830100
X1392 1556 1533 1385 2 1 1649 QDFFRBN $T=345340 790160 1 0 $X=345340 $Y=784740
X1393 1534 1533 1385 2 1 1655 QDFFRBN $T=345340 820400 1 0 $X=345340 $Y=814980
X1394 1620 1533 111 2 1 1650 QDFFRBN $T=345340 850640 0 0 $X=345340 $Y=850260
X1395 1502 1533 1385 2 1 1659 QDFFRBN $T=345960 790160 0 0 $X=345960 $Y=789780
X1396 1514 1533 1385 2 1 1657 QDFFRBN $T=346580 800240 1 0 $X=346580 $Y=794820
X1397 1545 1533 1385 2 1 158 QDFFRBN $T=346580 810320 0 0 $X=346580 $Y=809940
X1398 1523 1533 1385 2 1 1667 QDFFRBN $T=348440 810320 1 0 $X=348440 $Y=804900
X1399 1635 1533 1385 2 1 1720 QDFFRBN $T=352160 840560 1 0 $X=352160 $Y=835140
X1400 1449 1533 111 2 1 1679 QDFFRBN $T=352160 840560 0 0 $X=352160 $Y=840180
X1401 1644 84 1385 2 1 1696 QDFFRBN $T=354020 770000 1 0 $X=354020 $Y=764580
X1402 1539 1533 111 2 1 1703 QDFFRBN $T=357740 850640 1 0 $X=357740 $Y=845220
X1403 1647 84 1385 2 1 1713 QDFFRBN $T=358980 780080 0 0 $X=358980 $Y=779700
X1404 1662 84 1385 2 1 1719 QDFFRBN $T=358980 820400 0 0 $X=358980 $Y=820020
X1405 1588 1533 1385 2 1 171 QDFFRBN $T=359600 790160 1 0 $X=359600 $Y=784740
X1406 1651 1533 1385 2 1 1804 QDFFRBN $T=359600 830480 0 0 $X=359600 $Y=830100
X1407 1664 84 111 2 1 1710 QDFFRBN $T=359600 850640 0 0 $X=359600 $Y=850260
X1408 1666 84 1385 2 1 1717 QDFFRBN $T=360220 800240 0 0 $X=360220 $Y=799860
X1409 1669 84 1385 2 1 1732 QDFFRBN $T=360840 790160 0 0 $X=360840 $Y=789780
X1410 1670 84 1385 2 1 1733 QDFFRBN $T=360840 810320 0 0 $X=360840 $Y=809940
X1411 1726 84 1385 2 1 1675 QDFFRBN $T=374480 759920 1 180 $X=362700 $Y=759540
X1412 1685 84 111 2 1 1748 QDFFRBN $T=365800 840560 0 0 $X=365800 $Y=840180
X1413 1760 84 111 2 1 1805 QDFFRBN $T=381300 860720 0 0 $X=381300 $Y=860340
X1414 1689 106 111 2 1 188 QDFFRBN $T=383160 870800 0 0 $X=383160 $Y=870420
X1415 1761 106 111 2 1 189 QDFFRBN $T=385640 880880 1 0 $X=385640 $Y=875460
X1416 1837 106 111 2 1 1908 QDFFRBN $T=398040 870800 0 0 $X=398040 $Y=870420
X1417 1918 106 111 2 1 2001 QDFFRBN $T=412920 870800 0 0 $X=412920 $Y=870420
X1418 208 212 111 2 1 219 QDFFRBN $T=416640 880880 1 0 $X=416640 $Y=875460
X1419 2024 106 111 2 1 2074 QDFFRBN $T=429040 880880 1 0 $X=429040 $Y=875460
X1420 2041 84 111 2 1 2095 QDFFRBN $T=431520 860720 0 0 $X=431520 $Y=860340
X1421 2189 84 252 2 1 2245 QDFFRBN $T=460660 870800 1 0 $X=460660 $Y=865380
X1422 2128 212 252 2 1 263 QDFFRBN $T=461900 880880 1 0 $X=461900 $Y=875460
X1423 2202 84 252 2 1 2255 QDFFRBN $T=463140 860720 0 0 $X=463140 $Y=860340
X1424 2220 84 252 2 1 2272 QDFFRBN $T=466860 860720 1 0 $X=466860 $Y=855300
X1425 244 212 252 2 1 273 QDFFRBN $T=478640 880880 1 0 $X=478640 $Y=875460
X1426 276 274 202 2 1 1895 QDFFRBN $T=495380 699440 1 180 $X=483600 $Y=699060
X1427 2062 212 252 2 1 2365 QDFFRBN $T=484840 870800 0 0 $X=484840 $Y=870420
X1428 2350 274 202 2 1 2169 QDFFRBN $T=497860 709520 0 180 $X=486080 $Y=704100
X1429 2337 84 252 2 1 2342 QDFFRBN $T=491660 850640 1 0 $X=491660 $Y=845220
X1430 2401 274 202 2 1 2300 QDFFRBN $T=509640 699440 1 180 $X=497860 $Y=699060
X1431 2299 84 252 2 1 2408 QDFFRBN $T=500960 840560 0 0 $X=500960 $Y=840180
X1432 2378 84 252 2 1 2397 QDFFRBN $T=502820 840560 1 0 $X=502820 $Y=835140
X1433 2429 274 202 2 1 2253 QDFFRBN $T=517080 709520 0 180 $X=505300 $Y=704100
X1434 2416 2447 252 2 1 2407 QDFFRBN $T=521420 860720 0 180 $X=509640 $Y=855300
X1435 2410 84 252 2 1 2453 QDFFRBN $T=510880 820400 0 0 $X=510880 $Y=820020
X1436 2452 308 202 2 1 2399 QDFFRBN $T=524520 770000 1 180 $X=512740 $Y=769620
X1437 2446 308 252 2 1 2420 QDFFRBN $T=525760 810320 1 180 $X=513980 $Y=809940
X1438 2486 2447 252 2 1 2385 QDFFRBN $T=528240 840560 1 180 $X=516460 $Y=840180
X1439 2495 2447 252 2 1 2440 QDFFRBN $T=530100 840560 0 180 $X=518320 $Y=835140
X1440 2530 308 252 2 1 2478 QDFFRBN $T=540020 810320 1 180 $X=528240 $Y=809940
X1441 2547 274 202 2 1 206 QDFFRBN $T=541880 759920 0 180 $X=530100 $Y=754500
X1442 2475 2447 252 2 1 2555 QDFFRBN $T=530100 810320 1 0 $X=530100 $Y=804900
X1443 2573 2447 252 2 1 2500 QDFFRBN $T=542500 850640 0 180 $X=530720 $Y=845220
X1444 2448 2447 252 2 1 2507 QDFFRBN $T=543120 850640 1 180 $X=531340 $Y=850260
X1445 2517 2447 252 2 1 2479 QDFFRBN $T=533200 840560 1 0 $X=533200 $Y=835140
X1446 2585 308 202 2 1 2451 QDFFRBN $T=549320 770000 1 180 $X=537540 $Y=769620
X1447 2537 2447 252 2 1 2591 QDFFRBN $T=537540 830480 0 0 $X=537540 $Y=830100
X1448 2536 308 202 2 1 2462 QDFFRBN $T=550560 780080 0 180 $X=538780 $Y=774660
X1449 2556 2447 252 2 1 2606 QDFFRBN $T=540640 820400 1 0 $X=540640 $Y=814980
X1450 2566 308 252 2 1 2546 QDFFRBN $T=554900 810320 1 180 $X=543120 $Y=809940
X1451 368 2447 252 2 1 2613 QDFFRBN $T=543120 860720 1 0 $X=543120 $Y=855300
X1452 2560 2447 252 2 1 2623 QDFFRBN $T=545600 850640 1 0 $X=545600 $Y=845220
X1453 2391 2447 252 2 1 2628 QDFFRBN $T=545600 850640 0 0 $X=545600 $Y=850260
X1454 2421 2447 202 2 1 2625 QDFFRBN $T=547460 810320 1 0 $X=547460 $Y=804900
X1455 2588 2447 202 2 1 2635 QDFFRBN $T=548080 800240 1 0 $X=548080 $Y=794820
X1456 2636 274 202 2 1 2594 QDFFRBN $T=561100 759920 1 180 $X=549320 $Y=759540
X1457 2610 2447 252 2 1 2660 QDFFRBN $T=552420 820400 0 0 $X=552420 $Y=820020
X1458 2608 2447 252 2 1 2661 QDFFRBN $T=553660 830480 1 0 $X=553660 $Y=825060
X1459 2539 2447 252 2 1 2688 QDFFRBN $T=554900 810320 0 0 $X=554900 $Y=809940
X1460 2748 274 202 2 1 1958 QDFFRBN $T=583420 770000 1 180 $X=571640 $Y=769620
X1461 2826 500 509 2 1 520 QDFFRBN $T=595200 880880 1 0 $X=595200 $Y=875460
X1462 2836 500 509 2 1 2889 QDFFRBN $T=598300 870800 1 0 $X=598300 $Y=865380
X1463 2903 2871 202 2 1 2858 QDFFRBN $T=615040 820400 1 180 $X=603260 $Y=820020
X1464 2864 2871 252 2 1 2887 QDFFRBN $T=603880 810320 0 0 $X=603880 $Y=809940
X1465 2873 2871 252 2 1 2908 QDFFRBN $T=605740 800240 0 0 $X=605740 $Y=799860
X1466 2885 500 509 2 1 2935 QDFFRBN $T=608840 860720 0 0 $X=608840 $Y=860340
X1467 2952 500 509 2 1 537 QDFFRBN $T=628060 850640 1 180 $X=616280 $Y=850260
X1468 2958 556 548 2 1 2909 QDFFRBN $T=628680 810320 0 180 $X=616900 $Y=804900
X1469 2916 500 509 2 1 558 QDFFRBN $T=616900 850640 1 0 $X=616900 $Y=845220
X1470 2991 556 548 2 1 2922 QDFFRBN $T=633640 770000 1 180 $X=621860 $Y=769620
X1471 2931 2871 509 2 1 567 QDFFRBN $T=622480 830480 0 0 $X=622480 $Y=830100
X1472 2986 556 548 2 1 2939 QDFFRBN $T=635500 770000 0 180 $X=623720 $Y=764580
X1473 2946 308 509 2 1 555 QDFFRBN $T=624340 830480 1 0 $X=624340 $Y=825060
X1474 3003 556 548 2 1 2950 QDFFRBN $T=637980 820400 1 180 $X=626200 $Y=820020
X1475 2976 556 548 2 1 3039 QDFFRBN $T=631780 759920 0 0 $X=631780 $Y=759540
X1476 2979 500 509 2 1 569 QDFFRBN $T=632400 850640 1 0 $X=632400 $Y=845220
X1477 3036 590 548 2 1 2984 QDFFRBN $T=645420 749840 1 180 $X=633640 $Y=749460
X1478 2987 2871 582 2 1 584 QDFFRBN $T=633640 840560 1 0 $X=633640 $Y=835140
X1479 3043 590 548 2 1 2996 QDFFRBN $T=647280 739760 1 180 $X=635500 $Y=739380
X1480 3007 308 509 2 1 3017 QDFFRBN $T=636740 830480 1 0 $X=636740 $Y=825060
X1481 3028 556 548 2 1 3071 QDFFRBN $T=641700 800240 1 0 $X=641700 $Y=794820
X1482 3076 590 548 2 1 3021 QDFFRBN $T=654100 729680 0 180 $X=642320 $Y=724260
X1483 3033 590 548 2 1 3084 QDFFRBN $T=642940 719600 0 0 $X=642940 $Y=719220
X1484 3080 556 548 2 1 3031 QDFFRBN $T=654720 820400 0 180 $X=642940 $Y=814980
X1485 3045 308 509 2 1 3037 QDFFRBN $T=645420 820400 0 0 $X=645420 $Y=820020
X1486 3046 2871 582 2 1 601 QDFFRBN $T=645420 840560 1 0 $X=645420 $Y=835140
X1487 3052 500 582 2 1 602 QDFFRBN $T=646660 850640 1 0 $X=646660 $Y=845220
X1488 596 590 548 2 1 3117 QDFFRBN $T=647900 699440 0 0 $X=647900 $Y=699060
X1489 3072 2871 582 2 1 3082 QDFFRBN $T=651620 830480 0 0 $X=651620 $Y=830100
X1490 3091 500 582 2 1 611 QDFFRBN $T=655340 850640 0 0 $X=655340 $Y=850260
X1491 3100 500 582 2 1 3139 QDFFRBN $T=657200 880880 1 0 $X=657200 $Y=875460
X1492 3103 2871 582 2 1 609 QDFFRBN $T=658440 840560 0 0 $X=658440 $Y=840180
X1493 3177 590 509 2 1 3106 QDFFRBN $T=671460 820400 0 180 $X=659680 $Y=814980
X1494 3183 3096 548 2 1 3125 QDFFRBN $T=675180 759920 0 180 $X=663400 $Y=754500
X1495 3152 556 548 2 1 3189 QDFFRBN $T=667740 790160 0 0 $X=667740 $Y=789780
X1496 3169 3096 548 2 1 3223 QDFFRBN $T=671460 749840 0 0 $X=671460 $Y=749460
X1497 3170 3096 548 2 1 3209 QDFFRBN $T=671460 780080 1 0 $X=671460 $Y=774660
X1498 3238 590 509 2 1 3176 QDFFRBN $T=685720 820400 0 180 $X=673940 $Y=814980
X1499 3197 556 625 2 1 3175 QDFFRBN $T=676420 729680 1 0 $X=676420 $Y=724260
X1500 3321 590 509 2 1 3266 QDFFRBN $T=700600 820400 0 180 $X=688820 $Y=814980
X1501 3366 590 548 2 1 3300 QDFFRBN $T=708040 800240 0 180 $X=696260 $Y=794820
X1502 3451 590 548 2 1 3377 QDFFRBN $T=721680 790160 1 180 $X=709900 $Y=789780
X1503 3541 590 548 2 1 3225 QDFFRBN $T=739040 800240 0 180 $X=727260 $Y=794820
X1504 3486 590 548 2 1 3536 QDFFRBN $T=728500 790160 0 0 $X=728500 $Y=789780
X1505 3570 308 548 2 1 3503 QDFFRBN $T=743380 840560 0 180 $X=731600 $Y=835140
X1506 3533 590 548 2 1 3609 QDFFRBN $T=739040 810320 0 0 $X=739040 $Y=809940
X1507 3559 308 674 2 1 3599 QDFFRBN $T=739040 860720 0 0 $X=739040 $Y=860340
X1508 3551 590 548 2 1 3507 QDFFRBN $T=755160 790160 1 180 $X=743380 $Y=789780
X1509 3577 671 674 2 1 3626 QDFFRBN $T=743380 840560 0 0 $X=743380 $Y=840180
X1510 3582 671 548 2 1 3631 QDFFRBN $T=744000 830480 0 0 $X=744000 $Y=830100
X1511 673 308 674 2 1 689 QDFFRBN $T=745860 880880 1 0 $X=745860 $Y=875460
X1512 3543 308 674 2 1 3601 QDFFRBN $T=748960 850640 1 0 $X=748960 $Y=845220
X1513 3579 671 548 2 1 3658 QDFFRBN $T=750200 830480 1 0 $X=750200 $Y=825060
X1514 638 308 674 2 1 3651 QDFFRBN $T=753920 860720 0 0 $X=753920 $Y=860340
X1515 3636 671 548 2 1 3677 QDFFRBN $T=755160 840560 1 0 $X=755160 $Y=835140
X1516 3683 556 548 2 1 3633 QDFFRBN $T=767560 780080 1 180 $X=755780 $Y=779700
X1517 3644 671 674 2 1 3694 QDFFRBN $T=756400 860720 1 0 $X=756400 $Y=855300
X1518 3703 556 548 2 1 3619 QDFFRBN $T=770660 780080 0 180 $X=758880 $Y=774660
X1519 3662 671 674 2 1 3700 QDFFRBN $T=760740 840560 0 0 $X=760740 $Y=840180
X1520 3664 671 548 2 1 3695 QDFFRBN $T=761360 830480 0 0 $X=761360 $Y=830100
X1521 3685 671 674 2 1 3738 QDFFRBN $T=766320 850640 1 0 $X=766320 $Y=845220
X1522 3704 671 674 2 1 737 QDFFRBN $T=770660 850640 0 0 $X=770660 $Y=850260
X1523 3772 308 625 2 1 3730 QDFFRBN $T=788020 840560 1 180 $X=776240 $Y=840180
X1524 3742 308 625 2 1 3780 QDFFRBN $T=778100 820400 0 0 $X=778100 $Y=820020
X1525 3750 308 625 2 1 3787 QDFFRBN $T=779960 830480 1 0 $X=779960 $Y=825060
X1526 3758 738 674 2 1 3835 QDFFRBN $T=781820 880880 1 0 $X=781820 $Y=875460
X1527 3578 738 674 2 1 3799 QDFFRBN $T=782440 870800 0 0 $X=782440 $Y=870420
X1528 3735 671 674 2 1 764 QDFFRBN $T=783680 860720 0 0 $X=783680 $Y=860340
X1529 3763 671 674 2 1 754 QDFFRBN $T=784920 850640 0 0 $X=784920 $Y=850260
X1530 3816 308 625 2 1 3759 QDFFRBN $T=799180 810320 0 180 $X=787400 $Y=804900
X1531 3810 308 625 2 1 3768 QDFFRBN $T=799800 810320 1 180 $X=788020 $Y=809940
X1532 3824 308 625 2 1 3771 QDFFRBN $T=803520 840560 1 180 $X=791740 $Y=840180
X1533 3830 308 674 2 1 3786 QDFFRBN $T=805380 850640 0 180 $X=793600 $Y=845220
X1534 3779 671 674 2 1 774 QDFFRBN $T=796080 870800 1 0 $X=796080 $Y=865380
X1535 3666 738 674 2 1 3841 QDFFRBN $T=796080 870800 0 0 $X=796080 $Y=870420
X1536 3783 556 625 2 1 3812 QDFFRBN $T=810340 759920 1 180 $X=798560 $Y=759540
X1537 3825 556 625 2 1 3811 QDFFRBN $T=812200 699440 1 180 $X=800420 $Y=699060
X1538 3842 308 625 2 1 3814 QDFFRBN $T=812200 820400 0 180 $X=800420 $Y=814980
X1539 3845 308 625 2 1 3817 QDFFRBN $T=812200 840560 0 180 $X=800420 $Y=835140
X1540 3813 556 625 2 1 3846 QDFFRBN $T=801040 719600 0 0 $X=801040 $Y=719220
X1541 3818 556 625 2 1 3646 QDFFRBN $T=801660 739760 1 0 $X=801660 $Y=734340
X1542 3844 308 625 2 1 3819 QDFFRBN $T=813440 810320 0 180 $X=801660 $Y=804900
X1543 3828 556 625 2 1 3617 QDFFRBN $T=816540 749840 1 180 $X=804760 $Y=749460
X1544 3802 738 674 2 1 781 QDFFRBN $T=808480 880880 1 0 $X=808480 $Y=875460
X1545 3843 738 674 2 1 3891 QDFFRBN $T=810340 870800 1 0 $X=810340 $Y=865380
X1546 778 738 674 2 1 3896 QDFFRBN $T=811580 870800 0 0 $X=811580 $Y=870420
X1547 3909 738 788 2 1 3954 QDFFRBN $T=825220 870800 1 0 $X=825220 $Y=865380
X1548 3806 738 788 2 1 799 QDFFRBN $T=829560 880880 1 0 $X=829560 $Y=875460
X1549 3849 738 788 2 1 823 QDFFRBN $T=859940 880880 1 0 $X=859940 $Y=875460
X1550 825 671 788 2 1 833 QDFFRBN $T=872960 880880 1 0 $X=872960 $Y=875460
X1551 825 671 788 2 1 850 QDFFRBN $T=889080 880880 1 0 $X=889080 $Y=875460
X1552 4348 893 884 2 1 4303 QDFFRBN $T=949220 790160 0 180 $X=937440 $Y=784740
X1553 4387 893 884 2 1 4353 QDFFRBN $T=961000 790160 0 180 $X=949220 $Y=784740
X1554 4403 893 884 2 1 4359 QDFFRBN $T=966580 759920 1 180 $X=954800 $Y=759540
X1555 4424 893 884 2 1 4323 QDFFRBN $T=972160 780080 0 180 $X=960380 $Y=774660
X1556 4473 893 884 2 1 4386 QDFFRBN $T=987040 780080 1 180 $X=975260 $Y=779700
X1557 4477 893 884 2 1 4400 QDFFRBN $T=987660 780080 0 180 $X=975880 $Y=774660
X1558 4486 893 884 2 1 4365 QDFFRBN $T=992620 790160 0 180 $X=980840 $Y=784740
X1559 4518 893 884 2 1 4416 QDFFRBN $T=1001920 780080 1 180 $X=990140 $Y=779700
X1560 4519 893 884 2 1 4349 QDFFRBN $T=1002540 780080 0 180 $X=990760 $Y=774660
X1561 934 738 788 2 1 4586 QDFFRBN $T=1013700 880880 1 0 $X=1013700 $Y=875460
X1562 1017 2 1023 1 INV1S $T=221340 780080 0 0 $X=221340 $Y=779700
X1563 1060 2 1025 1 INV1S $T=226300 729680 0 180 $X=225060 $Y=724260
X1564 1050 2 1026 1 INV1S $T=226300 739760 0 180 $X=225060 $Y=734340
X1565 1051 2 1027 1 INV1S $T=226300 749840 1 180 $X=225060 $Y=749460
X1566 1056 2 1016 1 INV1S $T=226300 759920 1 180 $X=225060 $Y=759540
X1567 1053 2 1022 1 INV1S $T=226300 770000 0 180 $X=225060 $Y=764580
X1568 7 2 3 1 INV1S $T=226300 880880 0 180 $X=225060 $Y=875460
X1569 8 2 1062 1 INV1S $T=226300 860720 0 0 $X=226300 $Y=860340
X1570 1063 2 1048 1 INV1S $T=229400 709520 1 180 $X=228160 $Y=709140
X1571 19 2 1052 1 INV1S $T=229400 880880 0 180 $X=228160 $Y=875460
X1572 1071 2 1021 1 INV1S $T=230020 830480 0 180 $X=228780 $Y=825060
X1573 1076 2 1068 1 INV1S $T=231260 830480 0 180 $X=230020 $Y=825060
X1574 1078 2 1038 1 INV1S $T=231880 810320 1 180 $X=230640 $Y=809940
X1575 1089 2 1036 1 INV1S $T=231880 820400 0 180 $X=230640 $Y=814980
X1576 1086 2 1054 1 INV1S $T=232500 800240 0 180 $X=231260 $Y=794820
X1577 1093 2 1046 1 INV1S $T=233120 810320 0 180 $X=231880 $Y=804900
X1578 1087 2 1057 1 INV1S $T=234980 800240 0 180 $X=233740 $Y=794820
X1579 22 2 1082 1 INV1S $T=234980 850640 1 180 $X=233740 $Y=850260
X1580 9 2 1069 1 INV1S $T=234360 780080 0 0 $X=234360 $Y=779700
X1581 9 2 1102 1 INV1S $T=239320 810320 1 0 $X=239320 $Y=804900
X1582 37 2 1141 1 INV1S $T=243660 860720 0 180 $X=242420 $Y=855300
X1583 38 2 1111 1 INV1S $T=243660 870800 1 180 $X=242420 $Y=870420
X1584 16 2 26 1 INV1S $T=243660 860720 0 0 $X=243660 $Y=860340
X1585 1161 2 1179 1 INV1S $T=258540 820400 0 0 $X=258540 $Y=820020
X1586 48 2 1193 1 INV1S $T=259780 770000 0 0 $X=259780 $Y=769620
X1587 1206 2 1234 1 INV1S $T=260400 840560 1 0 $X=260400 $Y=835140
X1588 1228 2 1217 1 INV1S $T=262260 770000 1 0 $X=262260 $Y=764580
X1589 1231 2 1247 1 INV1S $T=264740 810320 0 0 $X=264740 $Y=809940
X1590 1255 2 1260 1 INV1S $T=265360 739760 0 0 $X=265360 $Y=739380
X1591 1244 2 1261 1 INV1S $T=265360 759920 1 0 $X=265360 $Y=754500
X1592 1229 2 1273 1 INV1S $T=265360 780080 1 0 $X=265360 $Y=774660
X1593 54 2 1251 1 INV1S $T=266600 880880 0 180 $X=265360 $Y=875460
X1594 1239 2 1267 1 INV1S $T=265980 820400 0 0 $X=265980 $Y=820020
X1595 55 2 45 1 INV1S $T=269080 850640 1 180 $X=267840 $Y=850260
X1596 1257 2 1283 1 INV1S $T=269080 699440 0 0 $X=269080 $Y=699060
X1597 1218 2 1266 1 INV1S $T=269080 790160 0 0 $X=269080 $Y=789780
X1598 1241 2 1281 1 INV1S $T=272180 830480 0 180 $X=270940 $Y=825060
X1599 1274 2 1276 1 INV1S $T=272800 709520 1 180 $X=271560 $Y=709140
X1600 1275 2 1277 1 INV1S $T=272800 719600 1 180 $X=271560 $Y=719220
X1601 1200 2 1256 1 INV1S $T=272800 780080 0 180 $X=271560 $Y=774660
X1602 1230 2 1284 1 INV1S $T=274040 780080 1 180 $X=272800 $Y=779700
X1603 1245 2 1293 1 INV1S $T=274660 790160 1 180 $X=273420 $Y=789780
X1604 61 2 1295 1 INV1S $T=275900 880880 0 180 $X=274660 $Y=875460
X1605 77 2 1332 1 INV1S $T=282720 870800 0 180 $X=281480 $Y=865380
X1606 74 2 1346 1 INV1S $T=281480 880880 1 0 $X=281480 $Y=875460
X1607 1392 2 1430 1 INV1S $T=304420 850640 1 0 $X=304420 $Y=845220
X1608 110 2 102 1 INV1S $T=316200 790160 0 180 $X=314960 $Y=784740
X1609 1487 2 1493 1 INV1S $T=325500 840560 1 0 $X=325500 $Y=835140
X1610 1532 2 1548 1 INV1S $T=332940 810320 0 0 $X=332940 $Y=809940
X1611 1550 2 1565 1 INV1S $T=334800 770000 1 0 $X=334800 $Y=764580
X1612 1564 2 1553 1 INV1S $T=337280 820400 1 180 $X=336040 $Y=820020
X1613 1447 2 1584 1 INV1S $T=336660 840560 1 0 $X=336660 $Y=835140
X1614 1561 2 1582 1 INV1S $T=337280 739760 1 0 $X=337280 $Y=734340
X1615 1549 2 1590 1 INV1S $T=337280 770000 1 0 $X=337280 $Y=764580
X1616 1537 2 1576 1 INV1S $T=339140 790160 0 0 $X=339140 $Y=789780
X1617 1579 2 128 1 INV1S $T=341000 699440 0 0 $X=341000 $Y=699060
X1618 1581 2 1604 1 INV1S $T=341000 810320 1 0 $X=341000 $Y=804900
X1619 1580 2 1595 1 INV1S $T=342860 719600 0 180 $X=341620 $Y=714180
X1620 1535 2 1575 1 INV1S $T=342860 749840 1 180 $X=341620 $Y=749460
X1621 1538 2 1585 1 INV1S $T=341620 759920 1 0 $X=341620 $Y=754500
X1622 1557 2 1600 1 INV1S $T=344100 790160 0 180 $X=342860 $Y=784740
X1623 1578 2 1612 1 INV1S $T=343480 780080 1 0 $X=343480 $Y=774660
X1624 1601 2 1554 1 INV1S $T=345960 810320 1 180 $X=344720 $Y=809940
X1625 1555 2 1598 1 INV1S $T=347200 709520 0 180 $X=345960 $Y=704100
X1626 1758 2 1739 1 INV1S $T=381300 840560 1 0 $X=381300 $Y=835140
X1627 1716 2 1799 1 INV1S $T=386260 770000 0 0 $X=386260 $Y=769620
X1628 187 2 1800 1 INV1S $T=392460 699440 0 0 $X=392460 $Y=699060
X1629 1770 2 1810 1 INV1S $T=393080 739760 0 0 $X=393080 $Y=739380
X1630 1802 2 187 1 INV1S $T=393700 709520 0 0 $X=393700 $Y=709140
X1631 1691 2 1814 1 INV1S $T=397420 709520 1 180 $X=396180 $Y=709140
X1632 1778 2 1841 1 INV1S $T=396800 729680 0 0 $X=396800 $Y=729300
X1633 1843 2 1836 1 INV1S $T=398660 749840 0 180 $X=397420 $Y=744420
X1634 1769 2 1831 1 INV1S $T=399280 729680 1 180 $X=398040 $Y=729300
X1635 154 2 1834 1 INV1S $T=398660 780080 1 0 $X=398660 $Y=774660
X1636 1832 2 1865 1 INV1S $T=399280 800240 1 0 $X=399280 $Y=794820
X1637 1851 2 1866 1 INV1S $T=399900 820400 0 0 $X=399900 $Y=820020
X1638 1863 2 1826 1 INV1S $T=401760 719600 1 180 $X=400520 $Y=719220
X1639 1864 2 1872 1 INV1S $T=404240 780080 1 0 $X=404240 $Y=774660
X1640 1895 2 1824 1 INV1S $T=406720 729680 1 180 $X=405480 $Y=729300
X1641 1840 2 1891 1 INV1S $T=408580 830480 1 180 $X=407340 $Y=830100
X1642 1898 2 1880 1 INV1S $T=407340 840560 0 0 $X=407340 $Y=840180
X1643 1906 2 1902 1 INV1S $T=409200 729680 1 180 $X=407960 $Y=729300
X1644 1889 2 1892 1 INV1S $T=409200 739760 1 180 $X=407960 $Y=739380
X1645 1848 2 1887 1 INV1S $T=409200 810320 0 180 $X=407960 $Y=804900
X1646 1835 2 1876 1 INV1S $T=409820 820400 0 180 $X=408580 $Y=814980
X1647 1940 2 1922 1 INV1S $T=414160 739760 0 180 $X=412920 $Y=734340
X1648 1938 2 1915 1 INV1S $T=414160 820400 1 180 $X=412920 $Y=820020
X1649 1895 2 204 1 INV1S $T=415400 739760 1 0 $X=415400 $Y=734340
X1650 1958 2 1937 1 INV1S $T=416640 810320 1 180 $X=415400 $Y=809940
X1651 203 2 1951 1 INV1S $T=417260 709520 0 180 $X=416020 $Y=704100
X1652 1897 2 1956 1 INV1S $T=416020 729680 0 0 $X=416020 $Y=729300
X1653 1929 2 1968 1 INV1S $T=417880 800240 0 0 $X=417880 $Y=799860
X1654 1973 2 1966 1 INV1S $T=421600 739760 1 180 $X=420360 $Y=739380
X1655 1987 2 1967 1 INV1S $T=422840 820400 0 180 $X=421600 $Y=814980
X1656 1947 2 1923 1 INV1S $T=422840 810320 1 0 $X=422840 $Y=804900
X1657 1860 2 1998 1 INV1S $T=423460 719600 0 0 $X=423460 $Y=719220
X1658 2013 2 1983 1 INV1S $T=425940 800240 0 180 $X=424700 $Y=794820
X1659 2017 2 2007 1 INV1S $T=428420 810320 0 180 $X=427180 $Y=804900
X1660 2023 2 2006 1 INV1S $T=428420 840560 0 180 $X=427180 $Y=835140
X1661 1993 2 2008 1 INV1S $T=429660 749840 1 180 $X=428420 $Y=749460
X1662 206 2 1949 1 INV1S $T=430900 780080 0 180 $X=429660 $Y=774660
X1663 2030 2 2010 1 INV1S $T=430900 810320 1 180 $X=429660 $Y=809940
X1664 2049 2 2044 1 INV1S $T=434620 729680 1 180 $X=433380 $Y=729300
X1665 2067 2 2053 1 INV1S $T=437720 830480 0 180 $X=436480 $Y=825060
X1666 2072 2 2061 1 INV1S $T=440200 820400 1 180 $X=438960 $Y=820020
X1667 233 2 1947 1 INV1S $T=445160 810320 0 180 $X=443920 $Y=804900
X1668 2076 2 2100 1 INV1S $T=446400 739760 0 0 $X=446400 $Y=739380
X1669 2132 2 2126 1 INV1S $T=451360 820400 0 180 $X=450120 $Y=814980
X1670 2105 2 2133 1 INV1S $T=450740 749840 1 0 $X=450740 $Y=744420
X1671 2146 2 2155 1 INV1S $T=454460 810320 0 0 $X=454460 $Y=809940
X1672 2163 2 2175 1 INV1S $T=458800 739760 1 0 $X=458800 $Y=734340
X1673 2186 2 2193 1 INV1S $T=460660 830480 1 0 $X=460660 $Y=825060
X1674 2203 2 2212 1 INV1S $T=463760 739760 0 0 $X=463760 $Y=739380
X1675 254 2 2197 1 INV1S $T=470580 759920 0 180 $X=469340 $Y=754500
X1676 2231 2 2226 1 INV1S $T=470580 830480 0 180 $X=469340 $Y=825060
X1677 254 2 1380 1 INV1S $T=471200 739760 1 180 $X=469960 $Y=739380
X1678 256 2 253 1 INV1S $T=471820 749840 0 180 $X=470580 $Y=744420
X1679 256 2 1208 1 INV1S $T=473060 749840 0 180 $X=471820 $Y=744420
X1680 2183 2 2252 1 INV1S $T=473060 810320 1 0 $X=473060 $Y=804900
X1681 2185 2 2258 1 INV1S $T=473060 810320 0 0 $X=473060 $Y=809940
X1682 259 2 1189 1 INV1S $T=475540 749840 0 180 $X=474300 $Y=744420
X1683 259 2 257 1 INV1S $T=475540 749840 1 180 $X=474300 $Y=749460
X1684 2275 2 2243 1 INV1S $T=477400 739760 0 180 $X=476160 $Y=734340
X1685 154 2 2150 1 INV1S $T=479880 790160 0 180 $X=478640 $Y=784740
X1686 2270 2 2278 1 INV1S $T=479880 800240 1 0 $X=479880 $Y=794820
X1687 2170 2 2281 1 INV1S $T=482360 729680 1 180 $X=481120 $Y=729300
X1688 2260 2 2292 1 INV1S $T=482360 780080 0 0 $X=482360 $Y=779700
X1689 2150 2 2249 1 INV1S $T=483600 780080 0 0 $X=483600 $Y=779700
X1690 2242 2 2285 1 INV1S $T=486080 800240 0 180 $X=484840 $Y=794820
X1691 2238 2 2297 1 INV1S $T=487940 729680 0 180 $X=486700 $Y=724260
X1692 2215 2 2340 1 INV1S $T=489800 739760 1 0 $X=489800 $Y=734340
X1693 2267 2 2327 1 INV1S $T=491660 719600 0 0 $X=491660 $Y=719220
X1694 2235 2 2332 1 INV1S $T=492900 729680 0 0 $X=492900 $Y=729300
X1695 2269 2 2338 1 INV1S $T=494140 780080 1 180 $X=492900 $Y=779700
X1696 2240 2 2329 1 INV1S $T=494760 800240 0 180 $X=493520 $Y=794820
X1697 2280 2 2346 1 INV1S $T=494760 719600 0 0 $X=494760 $Y=719220
X1698 2303 2 2355 1 INV1S $T=497240 749840 0 0 $X=497240 $Y=749460
X1699 2119 2 2092 1 INV1S $T=499100 719600 1 180 $X=497860 $Y=719220
X1700 165 2 2119 1 INV1S $T=502820 729680 1 180 $X=501580 $Y=729300
X1701 2380 2 2390 1 INV1S $T=504060 729680 0 0 $X=504060 $Y=729300
X1702 305 2 288 1 INV1S $T=519560 729680 1 180 $X=518320 $Y=729300
X1703 2439 2 2474 1 INV1S $T=524520 749840 1 0 $X=524520 $Y=744420
X1704 2470 2 328 1 INV1S $T=528240 709520 0 0 $X=528240 $Y=709140
X1705 329 2 2496 1 INV1S $T=528240 719600 0 0 $X=528240 $Y=719220
X1706 331 2 324 1 INV1S $T=529480 749840 1 180 $X=528240 $Y=749460
X1707 336 2 327 1 INV1S $T=530100 759920 0 180 $X=528860 $Y=754500
X1708 340 2 335 1 INV1S $T=530720 749840 1 180 $X=529480 $Y=749460
X1709 344 2 339 1 INV1S $T=531340 749840 0 180 $X=530100 $Y=744420
X1710 2509 2 348 1 INV1S $T=533200 749840 1 180 $X=531960 $Y=749460
X1711 2513 2 345 1 INV1S $T=533200 780080 1 180 $X=531960 $Y=779700
X1712 2519 2 2480 1 INV1S $T=534440 749840 1 180 $X=533200 $Y=749460
X1713 2501 2 351 1 INV1S $T=535680 729680 0 180 $X=534440 $Y=724260
X1714 354 2 355 1 INV1S $T=535060 749840 0 0 $X=535060 $Y=749460
X1715 358 2 2515 1 INV1S $T=537540 749840 0 0 $X=537540 $Y=749460
X1716 2543 2 2532 1 INV1S $T=538780 820400 0 180 $X=537540 $Y=814980
X1717 304 2 2557 1 INV1S $T=541260 749840 1 0 $X=541260 $Y=744420
X1718 321 2 2534 1 INV1S $T=543740 709520 1 0 $X=543740 $Y=704100
X1719 2565 2 2523 1 INV1S $T=545600 729680 1 180 $X=544360 $Y=729300
X1720 317 2 2551 1 INV1S $T=546220 759920 0 180 $X=544980 $Y=754500
X1721 2569 2 370 1 INV1S $T=546220 759920 1 180 $X=544980 $Y=759540
X1722 2578 2 376 1 INV1S $T=547460 780080 1 180 $X=546220 $Y=779700
X1723 2590 2 379 1 INV1S $T=549320 780080 1 180 $X=548080 $Y=779700
X1724 337 2 2542 1 INV1S $T=548700 749840 1 0 $X=548700 $Y=744420
X1725 2604 2 383 1 INV1S $T=551800 780080 0 180 $X=550560 $Y=774660
X1726 2508 2 385 1 INV1S $T=551800 729680 1 0 $X=551800 $Y=724260
X1727 2607 2 2571 1 INV1S $T=556140 759920 0 180 $X=554900 $Y=754500
X1728 2580 2 2562 1 INV1S $T=559240 729680 1 0 $X=559240 $Y=724260
X1729 2598 2 405 1 INV1S $T=559240 749840 0 0 $X=559240 $Y=749460
X1730 2642 2 406 1 INV1S $T=561100 780080 1 180 $X=559860 $Y=779700
X1731 2471 2 389 1 INV1S $T=561720 729680 1 0 $X=561720 $Y=724260
X1732 2647 2 412 1 INV1S $T=564200 780080 0 180 $X=562960 $Y=774660
X1733 2643 2 419 1 INV1S $T=565440 780080 0 180 $X=564200 $Y=774660
X1734 2654 2 2596 1 INV1S $T=567300 719600 1 0 $X=567300 $Y=714180
X1735 434 2 2700 1 INV1S $T=570400 860720 0 0 $X=570400 $Y=860340
X1736 2641 2 350 1 INV1S $T=572880 739760 1 180 $X=571640 $Y=739380
X1737 380 2 2698 1 INV1S $T=571640 870800 0 0 $X=571640 $Y=870420
X1738 360 2 391 1 INV1S $T=572260 729680 1 0 $X=572260 $Y=724260
X1739 397 2 451 1 INV1S $T=575980 729680 1 0 $X=575980 $Y=724260
X1740 313 2 2722 1 INV1S $T=576600 719600 0 0 $X=576600 $Y=719220
X1741 2728 2 2690 1 INV1S $T=577840 870800 0 180 $X=576600 $Y=865380
X1742 429 2 454 1 INV1S $T=577220 749840 0 0 $X=577220 $Y=749460
X1743 457 2 459 1 INV1S $T=578460 749840 0 0 $X=578460 $Y=749460
X1744 474 2 2745 1 INV1S $T=582800 870800 1 180 $X=581560 $Y=870420
X1745 475 2 2632 1 INV1S $T=584660 759920 1 180 $X=583420 $Y=759540
X1746 476 2 2754 1 INV1S $T=584660 870800 0 180 $X=583420 $Y=865380
X1747 2756 2 2763 1 INV1S $T=584040 850640 1 0 $X=584040 $Y=845220
X1748 2779 2 2784 1 INV1S $T=587140 840560 1 0 $X=587140 $Y=835140
X1749 2770 2 2771 1 INV1S $T=588380 850640 1 180 $X=587140 $Y=850260
X1750 2689 2 2790 1 INV1S $T=588380 860720 0 0 $X=588380 $Y=860340
X1751 2735 2 2696 1 INV1S $T=590860 729680 0 0 $X=590860 $Y=729300
X1752 2834 2 2819 1 INV1S $T=598300 840560 0 180 $X=597060 $Y=835140
X1753 2825 2 2833 1 INV1S $T=597680 850640 0 0 $X=597680 $Y=850260
X1754 352 2 410 1 INV1S $T=600160 699440 1 180 $X=598920 $Y=699060
X1755 482 2 2820 1 INV1S $T=600160 770000 0 180 $X=598920 $Y=764580
X1756 2811 2 2671 1 INV1S $T=600160 770000 1 180 $X=598920 $Y=769620
X1757 433 2 2705 1 INV1S $T=602020 749840 0 180 $X=600780 $Y=744420
X1758 2817 2 2852 1 INV1S $T=601400 739760 0 0 $X=601400 $Y=739380
X1759 2867 2 2866 1 INV1S $T=605120 840560 0 0 $X=605120 $Y=840180
X1760 178 2 519 1 INV1S $T=605740 770000 1 0 $X=605740 $Y=764580
X1761 2839 2 2695 1 INV1S $T=607600 739760 1 180 $X=606360 $Y=739380
X1762 2872 2 2875 1 INV1S $T=607600 830480 0 180 $X=606360 $Y=825060
X1763 437 2 2801 1 INV1S $T=607600 759920 1 0 $X=607600 $Y=754500
X1764 202 2 525 1 INV1S $T=607600 770000 1 0 $X=607600 $Y=764580
X1765 2609 2 322 1 INV1S $T=609460 739760 1 0 $X=609460 $Y=734340
X1766 2870 2 2892 1 INV1S $T=612560 830480 0 0 $X=612560 $Y=830100
X1767 2904 2 506 1 INV1S $T=614420 719600 1 180 $X=613180 $Y=719220
X1768 2747 2 458 1 INV1S $T=614420 759920 0 180 $X=613180 $Y=754500
X1769 464 2 487 1 INV1S $T=615660 759920 0 0 $X=615660 $Y=759540
X1770 362 2 393 1 INV1S $T=618140 739760 1 180 $X=616900 $Y=739380
X1771 2741 2 488 1 INV1S $T=618140 749840 0 180 $X=616900 $Y=744420
X1772 2915 2 2921 1 INV1S $T=616900 800240 1 0 $X=616900 $Y=794820
X1773 417 2 436 1 INV1S $T=620000 739760 0 180 $X=618760 $Y=734340
X1774 2925 2 2854 1 INV1S $T=620620 729680 1 180 $X=619380 $Y=729300
X1775 301 2 2709 1 INV1S $T=620000 739760 1 0 $X=620000 $Y=734340
X1776 2887 2 2936 1 INV1S $T=620000 810320 0 0 $X=620000 $Y=809940
X1777 483 2 496 1 INV1S $T=622480 739760 0 0 $X=622480 $Y=739380
X1778 2945 2 2593 1 INV1S $T=624340 749840 1 180 $X=623100 $Y=749460
X1779 2934 2 2941 1 INV1S $T=623100 790160 1 0 $X=623100 $Y=784740
X1780 315 2 479 1 INV1S $T=625580 739760 1 180 $X=624340 $Y=739380
X1781 2953 2 2674 1 INV1S $T=627440 739760 1 180 $X=626200 $Y=739380
X1782 2627 2 2957 1 INV1S $T=626820 719600 0 0 $X=626820 $Y=719220
X1783 566 2 2940 1 INV1S $T=629300 880880 0 180 $X=628060 $Y=875460
X1784 560 2 2937 1 INV1S $T=629920 759920 0 180 $X=628680 $Y=754500
X1785 2977 2 2972 1 INV1S $T=633640 800240 1 180 $X=632400 $Y=799860
X1786 571 2 2975 1 INV1S $T=634260 880880 0 180 $X=633020 $Y=875460
X1787 365 2 511 1 INV1S $T=639220 729680 1 180 $X=637980 $Y=729300
X1788 468 2 591 1 INV1S $T=641700 709520 1 0 $X=641700 $Y=704100
X1789 585 2 2990 1 INV1S $T=643560 870800 0 180 $X=642320 $Y=865380
X1790 427 2 296 1 INV1S $T=643560 699440 0 0 $X=643560 $Y=699060
X1791 3054 2 3049 1 INV1S $T=647900 739760 0 180 $X=646660 $Y=734340
X1792 3060 2 3044 1 INV1S $T=647900 790160 0 180 $X=646660 $Y=784740
X1793 3055 2 3059 1 INV1S $T=647280 810320 1 0 $X=647280 $Y=804900
X1794 3021 2 3063 1 INV1S $T=647900 739760 1 0 $X=647900 $Y=734340
X1795 3039 2 3068 1 INV1S $T=648520 759920 1 0 $X=648520 $Y=754500
X1796 593 2 3032 1 INV1S $T=650380 870800 0 180 $X=649140 $Y=865380
X1797 3047 2 3073 1 INV1S $T=651000 759920 1 0 $X=651000 $Y=754500
X1798 3062 2 3056 1 INV1S $T=652240 770000 1 180 $X=651000 $Y=769620
X1799 610 2 3085 1 INV1S $T=664020 870800 0 180 $X=662780 $Y=865380
X1800 3128 2 3107 1 INV1S $T=665260 739760 0 180 $X=664020 $Y=734340
X1801 2908 2 3154 1 INV1S $T=664020 830480 0 0 $X=664020 $Y=830100
X1802 3145 2 3094 1 INV1S $T=666500 770000 0 180 $X=665260 $Y=764580
X1803 3140 2 3137 1 INV1S $T=666500 810320 0 180 $X=665260 $Y=804900
X1804 3156 2 3148 1 INV1S $T=668360 729680 0 180 $X=667120 $Y=724260
X1805 3149 2 3157 1 INV1S $T=667740 840560 1 0 $X=667740 $Y=835140
X1806 3166 2 3108 1 INV1S $T=670220 749840 1 180 $X=668980 $Y=749460
X1807 3150 2 3127 1 INV1S $T=672080 709520 1 180 $X=670840 $Y=709140
X1808 3125 2 3124 1 INV1S $T=670840 759920 0 0 $X=670840 $Y=759540
X1809 3191 2 3185 1 INV1S $T=675180 810320 0 180 $X=673940 $Y=804900
X1810 617 2 3174 1 INV1S $T=676420 709520 0 180 $X=675180 $Y=704100
X1811 3195 2 3178 1 INV1S $T=677040 719600 1 180 $X=675800 $Y=719220
X1812 618 2 616 1 INV1S $T=677040 880880 0 180 $X=675800 $Y=875460
X1813 3194 2 3202 1 INV1S $T=676420 709520 1 0 $X=676420 $Y=704100
X1814 2984 2 3212 1 INV1S $T=677660 739760 0 0 $X=677660 $Y=739380
X1815 3204 2 3216 1 INV1S $T=677660 820400 0 0 $X=677660 $Y=820020
X1816 623 2 3188 1 INV1S $T=682620 860720 1 180 $X=681380 $Y=860340
X1817 3175 2 3237 1 INV1S $T=686340 719600 1 180 $X=685100 $Y=719220
X1818 3082 2 3259 1 INV1S $T=685720 860720 1 0 $X=685720 $Y=855300
X1819 2858 2 3258 1 INV1S $T=686340 840560 1 0 $X=686340 $Y=835140
X1820 3230 2 3257 1 INV1S $T=686960 759920 1 0 $X=686960 $Y=754500
X1821 3189 2 3215 1 INV1S $T=686960 780080 0 0 $X=686960 $Y=779700
X1822 3260 2 3226 1 INV1S $T=688200 759920 0 0 $X=688200 $Y=759540
X1823 3209 2 3244 1 INV1S $T=688200 780080 1 0 $X=688200 $Y=774660
X1824 3240 2 3255 1 INV1S $T=688200 830480 0 0 $X=688200 $Y=830100
X1825 3084 2 3298 1 INV1S $T=689440 729680 1 0 $X=689440 $Y=724260
X1826 3198 2 3263 1 INV1S $T=690680 810320 0 180 $X=689440 $Y=804900
X1827 2858 2 631 1 INV1S $T=689440 870800 0 0 $X=689440 $Y=870420
X1828 3082 2 632 1 INV1S $T=689440 880880 1 0 $X=689440 $Y=875460
X1829 3205 2 3289 1 INV1S $T=692540 739760 1 0 $X=692540 $Y=734340
X1830 3288 2 3264 1 INV1S $T=694400 709520 1 180 $X=693160 $Y=709140
X1831 628 2 3247 1 INV1S $T=693160 719600 1 0 $X=693160 $Y=714180
X1832 3285 2 3291 1 INV1S $T=693780 770000 0 0 $X=693780 $Y=769620
X1833 3291 2 3135 1 INV1S $T=695020 780080 0 180 $X=693780 $Y=774660
X1834 3319 2 3328 1 INV1S $T=699360 759920 1 0 $X=699360 $Y=754500
X1835 3226 2 3310 1 INV1S $T=699980 770000 1 0 $X=699980 $Y=764580
X1836 3340 2 3315 1 INV1S $T=701840 830480 0 180 $X=700600 $Y=825060
X1837 643 2 3355 1 INV1S $T=704320 739760 1 0 $X=704320 $Y=734340
X1838 629 2 3337 1 INV1S $T=704940 709520 0 0 $X=704940 $Y=709140
X1839 634 2 3373 1 INV1S $T=704940 770000 0 0 $X=704940 $Y=769620
X1840 584 2 3351 1 INV1S $T=705560 870800 1 0 $X=705560 $Y=865380
X1841 3379 2 3368 1 INV1S $T=708040 820400 1 180 $X=706800 $Y=820020
X1842 3400 2 3364 1 INV1S $T=710520 830480 1 180 $X=709280 $Y=830100
X1843 3404 2 3387 1 INV1S $T=711140 800240 1 180 $X=709900 $Y=799860
X1844 609 2 3388 1 INV1S $T=710520 870800 1 0 $X=710520 $Y=865380
X1845 3378 2 3395 1 INV1S $T=711140 810320 0 0 $X=711140 $Y=809940
X1846 648 2 3302 1 INV1S $T=713620 719600 1 180 $X=712380 $Y=719220
X1847 613 2 3363 1 INV1S $T=713620 729680 0 180 $X=712380 $Y=724260
X1848 3239 2 3416 1 INV1S $T=712380 810320 0 0 $X=712380 $Y=809940
X1849 3405 2 3422 1 INV1S $T=713000 830480 1 0 $X=713000 $Y=825060
X1850 3117 2 3402 1 INV1S $T=715480 739760 1 180 $X=714240 $Y=739380
X1851 3292 2 3342 1 INV1S $T=716100 810320 1 0 $X=716100 $Y=804900
X1852 3282 2 3438 1 INV1S $T=716720 739760 0 0 $X=716720 $Y=739380
X1853 636 2 3411 1 INV1S $T=717340 770000 1 0 $X=717340 $Y=764580
X1854 3444 2 3427 1 INV1S $T=720440 810320 0 180 $X=719200 $Y=804900
X1855 627 2 3317 1 INV1S $T=719820 739760 0 0 $X=719820 $Y=739380
X1856 601 2 3457 1 INV1S $T=720440 850640 0 0 $X=720440 $Y=850260
X1857 3425 2 3430 1 INV1S $T=722920 810320 0 180 $X=721680 $Y=804900
X1858 3465 2 3270 1 INV1S $T=722920 860720 0 180 $X=721680 $Y=855300
X1859 567 2 3437 1 INV1S $T=722300 850640 1 0 $X=722300 $Y=845220
X1860 655 2 3313 1 INV1S $T=723540 709520 0 0 $X=723540 $Y=709140
X1861 3476 2 3464 1 INV1S $T=726020 810320 1 180 $X=724780 $Y=809940
X1862 3359 2 3471 1 INV1S $T=727260 810320 1 180 $X=726020 $Y=809940
X1863 653 2 3309 1 INV1S $T=727880 770000 0 180 $X=726640 $Y=764580
X1864 3500 2 3272 1 INV1S $T=728500 850640 1 180 $X=727260 $Y=850260
X1865 3474 2 3146 1 INV1S $T=728500 860720 1 180 $X=727260 $Y=860340
X1866 3017 2 660 1 INV1S $T=731600 850640 1 180 $X=730360 $Y=850260
X1867 3513 2 3389 1 INV1S $T=732220 860720 1 180 $X=730980 $Y=860340
X1868 3037 2 656 1 INV1S $T=731600 860720 1 0 $X=731600 $Y=855300
X1869 3528 2 3510 1 INV1S $T=734080 830480 0 180 $X=732840 $Y=825060
X1870 637 2 3403 1 INV1S $T=735320 770000 0 0 $X=735320 $Y=769620
X1871 3520 2 664 1 INV1S $T=735940 699440 0 0 $X=735940 $Y=699060
X1872 666 2 3341 1 INV1S $T=739660 709520 0 0 $X=739660 $Y=709140
X1873 3553 2 3323 1 INV1S $T=739660 759920 0 0 $X=739660 $Y=759540
X1874 639 2 3303 1 INV1S $T=740900 770000 1 180 $X=739660 $Y=769620
X1875 3568 2 3573 1 INV1S $T=742140 709520 0 0 $X=742140 $Y=709140
X1876 670 2 3372 1 INV1S $T=744620 719600 1 180 $X=743380 $Y=719220
X1877 3596 2 3544 1 INV1S $T=745860 850640 0 180 $X=744620 $Y=845220
X1878 3599 2 3556 1 INV1S $T=748960 850640 1 180 $X=747720 $Y=850260
X1879 3297 2 3606 1 INV1S $T=749580 729680 0 0 $X=749580 $Y=729300
X1880 3608 2 3356 1 INV1S $T=750820 759920 1 180 $X=749580 $Y=759540
X1881 3617 2 3485 1 INV1S $T=752060 759920 0 180 $X=750820 $Y=754500
X1882 668 2 3347 1 INV1S $T=752060 770000 1 180 $X=750820 $Y=769620
X1883 3616 2 3441 1 INV1S $T=752680 759920 1 180 $X=751440 $Y=759540
X1884 3257 2 3625 1 INV1S $T=753920 749840 0 0 $X=753920 $Y=749460
X1885 678 2 3381 1 INV1S $T=755780 729680 0 180 $X=754540 $Y=724260
X1886 3626 2 682 1 INV1S $T=754540 860720 1 0 $X=754540 $Y=855300
X1887 3289 2 3643 1 INV1S $T=756400 729680 1 0 $X=756400 $Y=724260
X1888 3222 2 3296 1 INV1S $T=757640 770000 1 180 $X=756400 $Y=769620
X1889 3658 2 3621 1 INV1S $T=757640 830480 1 180 $X=756400 $Y=830100
X1890 3631 2 687 1 INV1S $T=756400 840560 0 0 $X=756400 $Y=840180
X1891 3566 2 3611 1 INV1S $T=757020 749840 1 0 $X=757020 $Y=744420
X1892 3597 2 3660 1 INV1S $T=759500 709520 1 0 $X=759500 $Y=704100
X1893 3646 2 3454 1 INV1S $T=760740 759920 1 180 $X=759500 $Y=759540
X1894 690 2 3461 1 INV1S $T=761980 719600 0 180 $X=760740 $Y=714180
X1895 3252 2 3671 1 INV1S $T=763220 749840 0 0 $X=763220 $Y=749460
X1896 3677 2 696 1 INV1S $T=764460 850640 1 0 $X=764460 $Y=845220
X1897 686 2 3452 1 INV1S $T=766320 719600 1 180 $X=765080 $Y=719220
X1898 3695 2 703 1 INV1S $T=769420 860720 1 180 $X=768180 $Y=860340
X1899 3633 2 3560 1 INV1S $T=768800 749840 0 0 $X=768800 $Y=749460
X1900 3619 2 3546 1 INV1S $T=770040 749840 0 0 $X=770040 $Y=749460
X1901 3700 2 715 1 INV1S $T=770040 860720 1 0 $X=770040 $Y=855300
X1902 3694 2 722 1 INV1S $T=770040 860720 0 0 $X=770040 $Y=860340
X1903 714 2 3710 1 INV1S $T=770660 870800 0 0 $X=770660 $Y=870420
X1904 3668 2 3494 1 INV1S $T=773760 759920 0 180 $X=772520 $Y=754500
X1905 3642 2 725 1 INV1S $T=773140 699440 0 0 $X=773140 $Y=699060
X1906 3732 2 3690 1 INV1S $T=774380 790160 1 180 $X=773140 $Y=789780
X1907 721 2 3493 1 INV1S $T=776240 719600 1 180 $X=775000 $Y=719220
X1908 679 2 3518 1 INV1S $T=775000 729680 0 0 $X=775000 $Y=729300
X1909 3733 2 3709 1 INV1S $T=776240 830480 1 180 $X=775000 $Y=830100
X1910 3756 2 3708 1 INV1S $T=778100 820400 0 180 $X=776860 $Y=814980
X1911 3738 2 726 1 INV1S $T=778100 870800 0 180 $X=776860 $Y=865380
X1912 727 2 3722 1 INV1S $T=778100 880880 0 180 $X=776860 $Y=875460
X1913 3744 2 3719 1 INV1S $T=779340 830480 0 180 $X=778100 $Y=825060
X1914 3688 2 3747 1 INV1S $T=778720 780080 1 0 $X=778720 $Y=774660
X1915 713 2 3521 1 INV1S $T=780580 729680 1 180 $X=779340 $Y=729300
X1916 3592 2 732 1 INV1S $T=779960 880880 1 0 $X=779960 $Y=875460
X1917 3755 2 3697 1 INV1S $T=781820 800240 1 180 $X=780580 $Y=799860
X1918 3692 2 3762 1 INV1S $T=781820 719600 1 0 $X=781820 $Y=714180
X1919 3731 2 740 1 INV1S $T=783060 800240 0 0 $X=783060 $Y=799860
X1920 3718 2 3765 1 INV1S $T=783680 770000 1 0 $X=783680 $Y=764580
X1921 3678 2 741 1 INV1S $T=784300 810320 0 0 $X=784300 $Y=809940
X1922 3776 2 3757 1 INV1S $T=786780 850640 0 180 $X=785540 $Y=845220
X1923 3766 2 3775 1 INV1S $T=786780 759920 1 0 $X=786780 $Y=754500
X1924 3767 2 3798 1 INV1S $T=788640 739760 0 0 $X=788640 $Y=739380
X1925 3699 2 748 1 INV1S $T=789880 850640 1 0 $X=789880 $Y=845220
X1926 3652 2 749 1 INV1S $T=792980 870800 1 0 $X=792980 $Y=865380
X1927 3720 2 750 1 INV1S $T=793600 699440 0 0 $X=793600 $Y=699060
X1928 3676 2 3831 1 INV1S $T=793600 729680 1 0 $X=793600 $Y=724260
X1929 3706 2 756 1 INV1S $T=796700 820400 1 0 $X=796700 $Y=814980
X1930 3753 2 771 1 INV1S $T=807860 870800 1 0 $X=807860 $Y=865380
X1931 3835 2 786 1 INV1S $T=820880 880880 1 0 $X=820880 $Y=875460
X1932 3921 2 3839 1 INV1S $T=826460 820400 1 180 $X=825220 $Y=820020
X1933 3869 2 3978 1 INV1S $T=843820 749840 0 0 $X=843820 $Y=749460
X1934 797 2 802 1 INV1S $T=844440 880880 1 0 $X=844440 $Y=875460
X1935 3879 2 3972 1 INV1S $T=845060 759920 0 0 $X=845060 $Y=759540
X1936 3865 2 3993 1 INV1S $T=846920 759920 0 0 $X=846920 $Y=759540
X1937 803 2 805 1 INV1S $T=848160 830480 0 0 $X=848160 $Y=830100
X1938 4017 2 3837 1 INV1S $T=851260 850640 1 180 $X=850020 $Y=850260
X1939 808 2 812 1 INV1S $T=852500 830480 0 0 $X=852500 $Y=830100
X1940 810 2 809 1 INV1S $T=853120 810320 0 0 $X=853120 $Y=809940
X1941 811 2 807 1 INV1S $T=853740 840560 1 0 $X=853740 $Y=835140
X1942 4028 2 3973 1 INV1S $T=863660 790160 1 180 $X=862420 $Y=789780
X1943 819 2 821 1 INV1S $T=864900 870800 1 0 $X=864900 $Y=865380
X1944 4039 2 3895 1 INV1S $T=868620 800240 1 180 $X=867380 $Y=799860
X1945 842 2 844 1 INV1S $T=889080 830480 0 0 $X=889080 $Y=830100
X1946 845 2 843 1 INV1S $T=890320 870800 0 0 $X=890320 $Y=870420
X1947 4182 2 4120 1 INV1S $T=892180 840560 0 180 $X=890940 $Y=835140
X1948 4143 2 4012 1 INV1S $T=892800 810320 0 180 $X=891560 $Y=804900
X1949 3954 2 849 1 INV1S $T=891560 870800 0 0 $X=891560 $Y=870420
X1950 4166 2 4025 1 INV1S $T=899620 810320 1 180 $X=898380 $Y=809940
X1951 851 2 852 1 INV1S $T=900860 880880 1 0 $X=900860 $Y=875460
X1952 853 2 854 1 INV1S $T=902100 880880 1 0 $X=902100 $Y=875460
X1953 3841 2 857 1 INV1S $T=907060 880880 1 0 $X=907060 $Y=875460
X1954 859 2 862 1 INV1S $T=908300 880880 1 0 $X=908300 $Y=875460
X1955 860 2 867 1 INV1S $T=912020 820400 1 0 $X=912020 $Y=814980
X1956 3891 2 873 1 INV1S $T=924420 880880 1 0 $X=924420 $Y=875460
X1957 3799 2 875 1 INV1S $T=925660 880880 1 0 $X=925660 $Y=875460
X1958 4267 2 4089 1 INV1S $T=928140 810320 0 180 $X=926900 $Y=804900
X1959 4286 2 4333 1 INV1S $T=943640 870800 1 0 $X=943640 $Y=865380
X1960 4326 2 4351 1 INV1S $T=945500 850640 1 0 $X=945500 $Y=845220
X1961 4342 2 4318 1 INV1S $T=947360 800240 0 180 $X=946120 $Y=794820
X1962 4355 2 4317 1 INV1S $T=949220 800240 0 180 $X=947980 $Y=794820
X1963 4295 2 4338 1 INV1S $T=949220 840560 1 180 $X=947980 $Y=840180
X1964 3896 2 896 1 INV1S $T=947980 880880 1 0 $X=947980 $Y=875460
X1965 4251 2 897 1 INV1S $T=950460 820400 0 0 $X=950460 $Y=820020
X1966 4285 2 4361 1 INV1S $T=951700 840560 1 0 $X=951700 $Y=835140
X1967 4392 2 4316 1 INV1S $T=953560 830480 1 180 $X=952320 $Y=830100
X1968 898 2 4373 1 INV1S $T=954180 820400 0 0 $X=954180 $Y=820020
X1969 4414 2 4399 1 INV1S $T=967820 840560 1 180 $X=966580 $Y=840180
X1970 918 2 4432 1 INV1S $T=971540 880880 1 0 $X=971540 $Y=875460
X1971 931 2 935 1 INV1S $T=995100 840560 1 0 $X=995100 $Y=835140
X1972 932 2 926 1 INV1S $T=996340 880880 1 0 $X=996340 $Y=875460
X1973 4513 2 4497 1 INV1S $T=998820 850640 0 180 $X=997580 $Y=845220
X1974 4523 2 4427 1 INV1S $T=1003780 850640 1 180 $X=1002540 $Y=850260
X1975 4305 2 936 1 INV1S $T=1003780 830480 0 0 $X=1003780 $Y=830100
X1976 4563 2 4557 1 INV1S $T=1016800 800240 0 180 $X=1015560 $Y=794820
X1977 4602 2 4569 1 INV1S $T=1032300 870800 1 180 $X=1031060 $Y=870420
X1978 4586 2 954 1 INV1S $T=1034160 880880 1 0 $X=1034160 $Y=875460
X1979 951 2 952 1 INV1S $T=1036640 830480 0 0 $X=1036640 $Y=830100
X1980 4609 2 4622 1 INV1S $T=1037260 850640 0 0 $X=1037260 $Y=850260
X1981 955 2 957 1 INV1S $T=1037880 820400 0 0 $X=1037880 $Y=820020
X1982 959 2 4610 1 INV1S $T=1039120 860720 0 180 $X=1037880 $Y=855300
X1983 4639 2 4621 1 INV1S $T=1043460 790160 1 180 $X=1042220 $Y=789780
X1984 4663 2 4634 1 INV1S $T=1047180 850640 0 180 $X=1045940 $Y=845220
X1985 4650 2 4628 1 INV1S $T=1047180 850640 1 180 $X=1045940 $Y=850260
X1986 4660 2 4646 1 INV1S $T=1047800 860720 1 180 $X=1046560 $Y=860340
X1987 965 2 4636 1 INV1S $T=1052140 880880 0 180 $X=1050900 $Y=875460
X1988 4654 2 4629 1 INV1S $T=1052760 790160 0 180 $X=1051520 $Y=784740
X1989 964 2 967 1 INV1S $T=1051520 810320 1 0 $X=1051520 $Y=804900
X1990 963 2 970 1 INV1S $T=1058340 860720 0 0 $X=1058340 $Y=860340
X1991 1123 1114 1151 2 1 1170 XOR3 $T=238080 830480 1 0 $X=238080 $Y=825060
X1992 1154 1106 1187 2 1 1207 XOR3 $T=244900 840560 1 0 $X=244900 $Y=835140
X1993 1135 1092 1131 2 1 1210 XOR3 $T=246140 790160 1 0 $X=246140 $Y=784740
X1994 1144 1136 1117 2 1 1226 XOR3 $T=246140 790160 0 0 $X=246140 $Y=789780
X1995 1145 1110 1142 2 1 1211 XOR3 $T=246140 810320 0 0 $X=246140 $Y=809940
X1996 1162 1167 1199 2 1 1216 XOR3 $T=246140 850640 1 0 $X=246140 $Y=845220
X1997 1159 1083 1166 2 1 1214 XOR3 $T=246760 770000 0 0 $X=246760 $Y=769620
X1998 1161 1118 1125 2 1 1238 XOR3 $T=249860 820400 1 0 $X=249860 $Y=814980
X1999 1178 1081 1220 2 1 1233 XOR3 $T=251720 719600 0 0 $X=251720 $Y=719220
X2000 43 1190 1225 2 1 1235 XOR3 $T=251720 870800 1 0 $X=251720 $Y=865380
X2001 1195 1080 1219 2 1 1269 XOR3 $T=254820 709520 1 0 $X=254820 $Y=704100
X2002 1177 1122 1174 2 1 1258 XOR3 $T=254820 810320 1 0 $X=254820 $Y=804900
X2003 1202 1075 1221 2 1 1259 XOR3 $T=256060 739760 1 0 $X=256060 $Y=734340
X2004 1194 1188 1192 2 1 1292 XOR3 $T=259160 860720 1 0 $X=259160 $Y=855300
X2005 1289 1238 1291 2 1 1349 XOR3 $T=273420 820400 0 0 $X=273420 $Y=820020
X2006 1304 1201 1316 2 1 1367 XOR3 $T=274040 800240 0 0 $X=274040 $Y=799860
X2007 1294 1207 1286 2 1 1368 XOR3 $T=274040 840560 1 0 $X=274040 $Y=835140
X2008 1318 1211 1313 2 1 1379 XOR3 $T=280860 820400 1 0 $X=280860 $Y=814980
X2009 1312 1258 1317 2 1 1395 XOR3 $T=282100 810320 1 0 $X=282100 $Y=804900
X2010 1321 1170 1314 2 1 1360 XOR3 $T=282720 830480 1 0 $X=282720 $Y=825060
X2011 1327 1226 1343 2 1 1378 XOR3 $T=286440 790160 0 0 $X=286440 $Y=789780
X2012 1315 1108 1309 2 1 1405 XOR3 $T=286440 850640 0 0 $X=286440 $Y=850260
X2013 1365 1210 1371 2 1 1396 XOR3 $T=288300 780080 1 0 $X=288300 $Y=774660
X2014 1322 1143 1328 2 1 1432 XOR3 $T=290160 860720 1 0 $X=290160 $Y=855300
X2015 1372 1127 85 2 1 1412 XOR3 $T=290160 870800 0 0 $X=290160 $Y=870420
X2016 1357 1214 1363 2 1 1437 XOR3 $T=292640 770000 0 0 $X=292640 $Y=769620
X2017 90 95 101 2 1 103 XOR3 $T=297600 880880 1 0 $X=297600 $Y=875460
X2018 1398 1269 1409 2 1 1435 XOR3 $T=298840 709520 1 0 $X=298840 $Y=704100
X2019 1386 1182 1382 2 1 1399 XOR3 $T=310000 759920 0 180 $X=298840 $Y=754500
X2020 1451 1448 1417 2 1 1327 XOR3 $T=312480 790160 1 180 $X=301320 $Y=789780
X2021 1408 1168 1422 2 1 1452 XOR3 $T=301320 850640 0 0 $X=301320 $Y=850260
X2022 1455 1450 1421 2 1 1318 XOR3 $T=313100 820400 1 180 $X=301940 $Y=820020
X2023 1415 1259 1424 2 1 1468 XOR3 $T=302560 739760 1 0 $X=302560 $Y=734340
X2024 1388 1203 1404 2 1 1416 XOR3 $T=313720 749840 0 180 $X=302560 $Y=744420
X2025 1463 1453 1427 2 1 1304 XOR3 $T=314340 800240 1 180 $X=303180 $Y=799860
X2026 1482 1477 1446 2 1 1312 XOR3 $T=319920 810320 1 180 $X=308760 $Y=809940
X2027 1436 1233 1419 2 1 1444 XOR3 $T=321160 719600 1 180 $X=310000 $Y=719220
X2028 1497 1495 1456 2 1 1398 XOR3 $T=323020 709520 1 180 $X=311860 $Y=709140
X2029 1500 1485 1471 2 1 1388 XOR3 $T=326740 749840 0 180 $X=315580 $Y=744420
X2030 1498 1478 1472 2 1 1289 XOR3 $T=326740 830480 1 180 $X=315580 $Y=830100
X2031 117 116 114 2 1 1408 XOR3 $T=331700 870800 1 180 $X=320540 $Y=870420
X2032 1516 1536 1501 2 1 1357 XOR3 $T=332940 770000 1 180 $X=321780 $Y=769620
X2033 1540 1517 115 2 1 112 XOR3 $T=333560 699440 1 180 $X=322400 $Y=699060
X2034 1522 1499 1506 2 1 1436 XOR3 $T=333560 719600 1 180 $X=322400 $Y=719220
X2035 1484 1292 1479 2 1 1509 XOR3 $T=322400 860720 0 0 $X=322400 $Y=860340
X2036 1547 1543 1510 2 1 1415 XOR3 $T=334180 739760 0 180 $X=323020 $Y=734340
X2037 130 127 123 2 1 1484 XOR3 $T=342860 870800 1 180 $X=331700 $Y=870420
X2038 134 1627 1617 2 1 1567 XOR3 $T=354640 870800 1 180 $X=343480 $Y=870420
X2039 1642 1432 1677 2 1 1689 XOR3 $T=354020 870800 1 0 $X=354020 $Y=865380
X2040 1694 1687 1653 2 1 1647 XOR3 $T=367040 780080 0 180 $X=355880 $Y=774660
X2041 148 157 149 2 1 1642 XOR3 $T=357120 870800 0 0 $X=357120 $Y=870420
X2042 155 160 167 2 1 1711 XOR3 $T=358980 880880 1 0 $X=358980 $Y=875460
X2043 1741 1688 1684 2 1 1670 XOR3 $T=374480 810320 0 180 $X=363320 $Y=804900
X2044 1739 1700 1692 2 1 1685 XOR3 $T=375720 830480 0 180 $X=364560 $Y=825060
X2045 1744 1740 1709 2 1 1644 XOR3 $T=380680 770000 0 180 $X=369520 $Y=764580
X2046 170 1724 1743 2 1 1752 XOR3 $T=371380 739760 1 0 $X=371380 $Y=734340
X2047 1412 1711 173 2 1 1761 XOR3 $T=371380 870800 0 0 $X=371380 $Y=870420
X2048 1745 1759 1728 2 1 1664 XOR3 $T=383160 850640 1 180 $X=372000 $Y=850260
X2049 1742 1752 1735 2 1 1662 XOR3 $T=383780 820400 0 180 $X=372620 $Y=814980
X2050 1749 1722 1738 2 1 1669 XOR3 $T=385020 790160 0 180 $X=373860 $Y=784740
X2051 1812 1747 1756 2 1 1745 XOR3 $T=389360 850640 0 180 $X=378200 $Y=845220
X2052 1815 1809 1729 2 1 1760 XOR3 $T=393080 860720 0 180 $X=381920 $Y=855300
X2053 1816 1757 1788 2 1 1744 XOR3 $T=396180 770000 0 180 $X=385020 $Y=764580
X2054 1820 1777 1791 2 1 1742 XOR3 $T=396800 820400 1 180 $X=385640 $Y=820020
X2055 1811 1793 1796 2 1 1754 XOR3 $T=398040 800240 0 180 $X=386880 $Y=794820
X2056 1790 1784 1795 2 1 1749 XOR3 $T=400520 790160 0 180 $X=389360 $Y=784740
X2057 1785 1850 1825 2 1 1815 XOR3 $T=403000 850640 1 180 $X=391840 $Y=850260
X2058 191 1870 1813 2 1 1809 XOR3 $T=406100 759920 1 180 $X=394940 $Y=759540
X2059 1853 1867 1842 2 1 1837 XOR3 $T=407340 870800 0 180 $X=396180 $Y=865380
X2060 1945 1962 1926 2 1 1918 XOR3 $T=421600 870800 0 180 $X=410440 $Y=865380
X2061 1977 1976 1950 2 1 1945 XOR3 $T=425320 850640 0 180 $X=414160 $Y=845220
X2062 1985 2014 1980 2 1 2024 XOR3 $T=425940 850640 0 0 $X=425940 $Y=850260
X2063 2043 2047 2021 2 1 2014 XOR3 $T=439580 850640 0 180 $X=428420 $Y=845220
X2064 2031 223 2045 2 1 2096 XOR3 $T=434620 759920 1 0 $X=434620 $Y=754500
X2065 2102 2096 2048 2 1 2041 XOR3 $T=445780 870800 0 180 $X=434620 $Y=865380
X2066 2107 2117 2156 2 1 2139 XOR3 $T=445780 830480 0 0 $X=445780 $Y=830100
X2067 2118 2124 2136 2 1 2189 XOR3 $T=447020 870800 0 0 $X=447020 $Y=870420
X2068 2122 235 2125 2 1 2143 XOR3 $T=448260 759920 0 0 $X=448260 $Y=759540
X2069 2091 2151 2108 2 1 2124 XOR3 $T=459420 840560 1 180 $X=448260 $Y=840180
X2070 2139 2143 2161 2 1 2220 XOR3 $T=451980 860720 1 0 $X=451980 $Y=855300
X2071 2192 2199 2177 2 1 2202 XOR3 $T=474920 850640 0 180 $X=463760 $Y=845220
X2072 2266 2279 2229 2 1 2259 XOR3 $T=486700 830480 1 180 $X=475540 $Y=830100
X2073 2259 2246 2241 2 1 2337 XOR3 $T=477400 850640 1 0 $X=477400 $Y=845220
X2074 2271 265 2283 2 1 2322 XOR3 $T=478020 770000 1 0 $X=478020 $Y=764580
X2075 2288 2293 2290 2 1 2343 XOR3 $T=482360 840560 1 0 $X=482360 $Y=835140
X2076 2317 2343 2296 2 1 2299 XOR3 $T=495380 840560 1 180 $X=484220 $Y=840180
X2077 2294 2311 2323 2 1 2330 XOR3 $T=485460 820400 0 0 $X=485460 $Y=820020
X2078 2315 2320 2351 2 1 2364 XOR3 $T=487940 810320 1 0 $X=487940 $Y=804900
X2079 2330 2322 2363 2 1 2378 XOR3 $T=491040 830480 1 0 $X=491040 $Y=825060
X2080 2334 275 2341 2 1 2381 XOR3 $T=492280 759920 0 0 $X=492280 $Y=759540
X2081 2325 271 2304 2 1 2360 XOR3 $T=492280 770000 1 0 $X=492280 $Y=764580
X2082 2360 2364 2383 2 1 2410 XOR3 $T=499720 810320 0 0 $X=499720 $Y=809940
X2083 2333 2369 2366 2 1 2409 XOR3 $T=500340 790160 1 0 $X=500340 $Y=784740
X2084 2354 2381 2400 2 1 2446 XOR3 $T=504680 790160 0 0 $X=504680 $Y=789780
X2085 2386 277 2382 2 1 2434 XOR3 $T=506540 719600 0 0 $X=506540 $Y=719220
X2086 2392 283 2374 2 1 2443 XOR3 $T=508400 749840 0 0 $X=508400 $Y=749460
X2087 2376 2413 2427 2 1 2483 XOR3 $T=510260 780080 1 0 $X=510260 $Y=774660
X2088 2368 2423 2441 2 1 2468 XOR3 $T=512120 800240 1 0 $X=512120 $Y=794820
X2089 2468 2461 2476 2 1 2530 XOR3 $T=525140 790160 1 0 $X=525140 $Y=784740
X2090 2483 2426 2494 2 1 2536 XOR3 $T=526380 780080 1 0 $X=526380 $Y=774660
X2091 2336 2457 2414 2 1 2498 XOR3 $T=527000 800240 1 0 $X=527000 $Y=794820
X2092 2434 2409 2459 2 1 2585 XOR3 $T=533820 770000 1 0 $X=533820 $Y=764580
X2093 2498 2443 2437 2 1 2566 XOR3 $T=535060 790160 0 0 $X=535060 $Y=789780
X2094 3138 3144 3181 2 1 3193 XOR3 $T=665260 820400 0 0 $X=665260 $Y=820020
X2095 3201 3211 3168 2 1 3163 XOR3 $T=681380 850640 0 180 $X=670220 $Y=845220
X2096 3220 3172 3163 2 1 3181 XOR3 $T=685720 840560 1 180 $X=674560 $Y=840180
X2097 3334 3279 3245 2 1 3168 XOR3 $T=695640 860720 1 180 $X=684480 $Y=860340
X2098 3407 3380 3344 2 1 3245 XOR3 $T=711760 880880 0 180 $X=700600 $Y=875460
X2099 662 3516 3475 2 1 672 XOR3 $T=731600 880880 1 0 $X=731600 $Y=875460
X2100 3568 639 3586 2 1 706 XOR3 $T=755780 709520 0 0 $X=755780 $Y=709140
X2101 3642 3553 3736 2 1 743 XOR3 $T=776240 699440 0 0 $X=776240 $Y=699060
X2102 1177 1174 1122 1 2 1142 MAO222 $T=247380 810320 1 0 $X=247380 $Y=804900
X2103 1154 1187 1106 1 2 1199 MAO222 $T=251100 830480 0 0 $X=251100 $Y=830100
X2104 1194 1192 1188 1 2 1183 MAO222 $T=256060 850640 1 180 $X=251100 $Y=850260
X2105 1315 1309 1108 1 2 1192 MAO222 $T=277140 860720 0 180 $X=272180 $Y=855300
X2106 1318 1313 1211 1 2 1291 MAO222 $T=277760 820400 0 180 $X=272800 $Y=814980
X2107 1312 1317 1258 1 2 1313 MAO222 $T=273420 810320 0 0 $X=273420 $Y=809940
X2108 1304 1316 1201 1 2 1317 MAO222 $T=274040 800240 1 0 $X=274040 $Y=794820
X2109 1357 1363 1214 1 2 1371 MAO222 $T=284580 770000 0 0 $X=284580 $Y=769620
X2110 1386 1382 1182 1 2 1363 MAO222 $T=296360 770000 0 180 $X=291400 $Y=764580
X2111 1383 1400 1381 1 2 1441 MAO222 $T=313720 830480 1 180 $X=308760 $Y=830100
X2112 1455 1421 1450 1 2 1472 MAO222 $T=315580 820400 1 0 $X=315580 $Y=814980
X2113 1460 1481 1469 1 2 1501 MAO222 $T=316820 770000 1 0 $X=316820 $Y=764580
X2114 1498 1472 1478 1 2 1400 MAO222 $T=323640 820400 1 180 $X=318680 $Y=820020
X2115 1500 1471 1485 1 2 1481 MAO222 $T=325500 749840 1 180 $X=320540 $Y=749460
X2116 117 114 116 1 2 1464 MAO222 $T=326120 880880 0 180 $X=321160 $Y=875460
X2117 1522 1506 1499 1 2 1510 MAO222 $T=324880 729680 0 0 $X=324880 $Y=729300
X2118 1547 1510 1543 1 2 1471 MAO222 $T=336040 739760 1 180 $X=331080 $Y=739380
X2119 134 1617 1627 1 2 123 MAO222 $T=347820 880880 0 180 $X=342860 $Y=875460
X2120 148 149 157 1 2 1617 MAO222 $T=357120 880880 0 180 $X=352160 $Y=875460
X2121 1705 1730 172 1 2 1715 MAO222 $T=376340 719600 0 180 $X=371380 $Y=714180
X2122 1742 1735 1752 1 2 1692 MAO222 $T=378200 820400 1 180 $X=373240 $Y=820020
X2123 1739 1692 1700 1 2 1728 MAO222 $T=373240 840560 1 0 $X=373240 $Y=835140
X2124 1744 1740 1709 1 2 1653 MAO222 $T=374480 770000 0 0 $X=374480 $Y=769620
X2125 1687 1653 1694 1 2 1738 MAO222 $T=380060 780080 1 180 $X=375100 $Y=779700
X2126 1749 1738 1722 1 2 1737 MAO222 $T=375100 790160 0 0 $X=375100 $Y=789780
X2127 1741 1684 1688 1 2 1735 MAO222 $T=375100 810320 0 0 $X=375100 $Y=809940
X2128 1754 1737 1721 1 2 1684 MAO222 $T=382540 810320 0 180 $X=377580 $Y=804900
X2129 180 1714 1755 1 2 1730 MAO222 $T=383160 719600 0 180 $X=378200 $Y=714180
X2130 1765 1792 1771 1 2 1756 MAO222 $T=389980 840560 1 180 $X=385020 $Y=840180
X2131 1780 1794 1768 1 2 1795 MAO222 $T=385640 780080 0 0 $X=385640 $Y=779700
X2132 1790 1795 1784 1 2 1796 MAO222 $T=385640 790160 0 0 $X=385640 $Y=789780
X2133 1773 1797 1767 1 2 1791 MAO222 $T=391840 820400 0 180 $X=386880 $Y=814980
X2134 1811 1796 1793 1 2 1797 MAO222 $T=393080 800240 1 180 $X=388120 $Y=799860
X2135 1820 1791 1777 1 2 1792 MAO222 $T=394320 830480 0 180 $X=389360 $Y=825060
X2136 1757 1788 1816 1 2 1780 MAO222 $T=393700 770000 0 0 $X=393700 $Y=769620
X2137 1870 1813 191 1 2 1893 MAO222 $T=401140 749840 0 0 $X=401140 $Y=749460
X2138 1862 1893 193 1 2 1913 MAO222 $T=407960 759920 1 0 $X=407960 $Y=754500
X2139 1961 1913 211 1 2 1990 MAO222 $T=420360 759920 1 0 $X=420360 $Y=754500
X2140 2016 1990 218 1 2 2045 MAO222 $T=426560 759920 1 0 $X=426560 $Y=754500
X2141 2031 2045 223 1 2 2065 MAO222 $T=432760 749840 0 0 $X=432760 $Y=749460
X2142 2091 2108 2151 1 2 2156 MAO222 $T=451360 840560 1 0 $X=451360 $Y=835140
X2143 2107 2156 2117 1 2 2198 MAO222 $T=457560 830480 0 0 $X=457560 $Y=830100
X2144 2176 2198 2187 1 2 2229 MAO222 $T=463760 830480 0 0 $X=463760 $Y=830100
X2145 2256 2254 261 1 2 2283 MAO222 $T=476160 759920 0 0 $X=476160 $Y=759540
X2146 2271 2283 265 1 2 2304 MAO222 $T=481120 759920 0 0 $X=481120 $Y=759540
X2147 2325 2304 271 1 2 2341 MAO222 $T=487940 759920 1 0 $X=487940 $Y=754500
X2148 2294 2323 2311 1 2 2351 MAO222 $T=491660 810320 0 0 $X=491660 $Y=809940
X2149 2315 2351 2320 1 2 2370 MAO222 $T=494760 800240 0 0 $X=494760 $Y=799860
X2150 2333 2366 2369 1 2 2384 MAO222 $T=499100 780080 1 0 $X=499100 $Y=774660
X2151 2386 2382 277 1 2 2331 MAO222 $T=506540 719600 0 180 $X=501580 $Y=714180
X2152 2381 2400 2354 1 2 2437 MAO222 $T=512120 800240 0 0 $X=512120 $Y=799860
X2153 2376 2427 2413 1 2 2366 MAO222 $T=517700 780080 1 180 $X=512740 $Y=779700
X2154 3568 639 3586 1 2 3638 MAO222 $T=745860 709520 1 0 $X=745860 $Y=704100
X2155 3642 3553 3736 1 2 3749 MAO222 $T=775000 719600 1 0 $X=775000 $Y=714180
X2156 1048 1040 1024 2 1 XOR2HS $T=226300 709520 0 180 $X=220720 $Y=704100
X2157 1025 1029 1041 2 1 XOR2HS $T=221340 719600 0 0 $X=221340 $Y=719220
X2158 1026 1030 1042 2 1 XOR2HS $T=221340 729680 0 0 $X=221340 $Y=729300
X2159 1027 1014 1043 2 1 XOR2HS $T=221340 749840 1 0 $X=221340 $Y=744420
X2160 1016 1015 1044 2 1 XOR2HS $T=221340 759920 1 0 $X=221340 $Y=754500
X2161 1022 1031 1045 2 1 XOR2HS $T=221340 770000 0 0 $X=221340 $Y=769620
X2162 1021 1020 1047 2 1 XOR2HS $T=221340 830480 1 0 $X=221340 $Y=825060
X2163 1052 1039 1028 2 1 XOR2HS $T=226920 870800 1 180 $X=221340 $Y=870420
X2164 1023 1034 1055 2 1 XOR2HS $T=222580 780080 0 0 $X=222580 $Y=779700
X2165 1036 1019 1061 2 1 XOR2HS $T=224440 820400 1 0 $X=224440 $Y=814980
X2166 1068 1037 1049 2 1 XOR2HS $T=230020 830480 1 180 $X=224440 $Y=830100
X2167 1038 1018 1066 2 1 XOR2HS $T=225060 810320 0 0 $X=225060 $Y=809940
X2168 1057 1032 1070 2 1 XOR2HS $T=225680 800240 1 0 $X=225680 $Y=794820
X2169 1054 1035 1072 2 1 XOR2HS $T=226300 790160 0 0 $X=226300 $Y=789780
X2170 1046 1033 1073 2 1 XOR2HS $T=226300 810320 1 0 $X=226300 $Y=804900
X2171 1082 1079 1067 2 1 XOR2HS $T=233120 850640 1 180 $X=227540 $Y=850260
X2172 1062 1077 1090 2 1 XOR2HS $T=229400 860720 0 0 $X=229400 $Y=860340
X2173 1099 1100 1115 2 1 XOR2HS $T=233740 840560 0 0 $X=233740 $Y=840180
X2174 30 1112 1138 2 1 XOR2HS $T=236840 880880 1 0 $X=236840 $Y=875460
X2175 1111 1101 1140 2 1 XOR2HS $T=237460 870800 1 0 $X=237460 $Y=865380
X2176 1141 1128 1150 2 1 XOR2HS $T=240560 850640 0 0 $X=240560 $Y=850260
X2177 1137 1126 1176 2 1 XOR2HS $T=246140 800240 1 0 $X=246140 $Y=794820
X2178 1119 1176 1201 2 1 XOR2HS $T=252340 800240 0 0 $X=252340 $Y=799860
X2179 1217 1213 1196 2 1 XOR2HS $T=259780 770000 0 180 $X=254200 $Y=764580
X2180 1234 1242 1205 2 1 XOR2HS $T=265980 840560 1 180 $X=260400 $Y=840180
X2181 1256 1249 1198 2 1 XOR2HS $T=266600 780080 1 180 $X=261020 $Y=779700
X2182 1266 1264 1215 2 1 XOR2HS $T=268460 790160 1 180 $X=262880 $Y=789780
X2183 1276 1270 1252 2 1 XOR2HS $T=269700 719600 0 180 $X=264120 $Y=714180
X2184 1277 1271 1253 2 1 XOR2HS $T=269700 729680 1 180 $X=264120 $Y=729300
X2185 1251 1243 1268 2 1 XOR2HS $T=264120 870800 0 0 $X=264120 $Y=870420
X2186 1281 1278 1240 2 1 XOR2HS $T=270940 840560 0 180 $X=265360 $Y=835140
X2187 1284 1280 1223 2 1 XOR2HS $T=271560 790160 0 180 $X=265980 $Y=784740
X2188 1247 1250 1224 2 1 XOR2HS $T=266600 810320 0 0 $X=266600 $Y=809940
X2189 1246 1254 1232 2 1 XOR2HS $T=266600 840560 0 0 $X=266600 $Y=840180
X2190 1260 1272 1287 2 1 XOR2HS $T=267220 739760 0 0 $X=267220 $Y=739380
X2191 1261 1262 1236 2 1 XOR2HS $T=267220 759920 1 0 $X=267220 $Y=754500
X2192 1273 1263 1222 2 1 XOR2HS $T=267220 770000 0 0 $X=267220 $Y=769620
X2193 1293 1285 1237 2 1 XOR2HS $T=272800 800240 1 180 $X=267220 $Y=799860
X2194 1267 1265 1227 2 1 XOR2HS $T=267220 820400 1 0 $X=267220 $Y=814980
X2195 1283 58 1248 2 1 XOR2HS $T=270940 699440 0 0 $X=270940 $Y=699060
X2196 1295 1296 1310 2 1 XOR2HS $T=270940 870800 1 0 $X=270940 $Y=865380
X2197 1346 76 1362 2 1 XOR2HS $T=283340 880880 1 0 $X=283340 $Y=875460
X2198 1332 1329 1358 2 1 XOR2HS $T=283960 870800 1 0 $X=283960 $Y=865380
X2199 1381 1383 1389 2 1 XOR2HS $T=292640 790160 1 0 $X=292640 $Y=784740
X2200 1403 1401 1390 2 1 XOR2HS $T=300700 870800 0 180 $X=295120 $Y=865380
X2201 1440 1235 1403 2 1 XOR2HS $T=309380 870800 0 180 $X=303800 $Y=865380
X2202 109 1464 1440 2 1 XOR2HS $T=316200 880880 0 180 $X=310620 $Y=875460
X2203 1530 1526 1513 2 1 XOR2HS $T=329840 820400 1 180 $X=324260 $Y=820020
X2204 1521 1520 1487 2 1 XOR2HS $T=326740 840560 1 0 $X=326740 $Y=835140
X2205 1553 1560 1546 2 1 XOR2HS $T=336040 830480 0 180 $X=330460 $Y=825060
X2206 1575 1569 1527 2 1 XOR2HS $T=337900 749840 1 180 $X=332320 $Y=749460
X2207 1576 1570 1528 2 1 XOR2HS $T=337900 790160 1 180 $X=332320 $Y=789780
X2208 1585 1583 1531 2 1 XOR2HS $T=339760 759920 1 180 $X=334180 $Y=759540
X2209 1548 1566 1525 2 1 XOR2HS $T=334180 810320 0 0 $X=334180 $Y=809940
X2210 1565 1586 1542 2 1 XOR2HS $T=340380 770000 1 180 $X=334800 $Y=769620
X2211 1595 1587 1573 2 1 XOR2HS $T=341000 719600 0 180 $X=335420 $Y=714180
X2212 1598 1594 1544 2 1 XOR2HS $T=341620 709520 1 180 $X=336040 $Y=709140
X2213 1600 1596 1552 2 1 XOR2HS $T=341620 800240 0 180 $X=336040 $Y=794820
X2214 1405 1567 1592 2 1 XOR2HS $T=336040 860720 0 0 $X=336040 $Y=860340
X2215 1582 1599 1558 2 1 XOR2HS $T=342860 729680 0 180 $X=337280 $Y=724260
X2216 1554 1571 1591 2 1 XOR2HS $T=344100 820400 1 180 $X=338520 $Y=820020
X2217 1590 1602 1541 2 1 XOR2HS $T=340380 770000 1 0 $X=340380 $Y=764580
X2218 1604 1613 1574 2 1 XOR2HS $T=346580 800240 1 180 $X=341000 $Y=799860
X2219 1612 1603 1568 2 1 XOR2HS $T=344720 780080 0 0 $X=344720 $Y=779700
X2220 1592 1607 1593 2 1 XOR2HS $T=345340 860720 0 0 $X=345340 $Y=860340
X2221 174 1723 1687 2 1 XOR2HS $T=375720 709520 0 180 $X=370140 $Y=704100
X2222 176 175 1723 2 1 XOR2HS $T=376960 699440 1 180 $X=371380 $Y=699060
X2223 1751 1746 1736 2 1 XOR2HS $T=378820 759920 0 180 $X=373240 $Y=754500
X2224 1772 1766 1759 2 1 XOR2HS $T=385020 759920 1 180 $X=379440 $Y=759540
X2225 1779 1716 1751 2 1 XOR2HS $T=385640 770000 1 180 $X=380060 $Y=769620
X2226 1782 182 1746 2 1 XOR2HS $T=388120 709520 0 180 $X=382540 $Y=704100
X2227 185 1801 1766 2 1 XOR2HS $T=391220 759920 0 180 $X=385640 $Y=754500
X2228 1810 1808 1763 2 1 XOR2HS $T=392460 739760 1 180 $X=386880 $Y=739380
X2229 1806 1826 1712 2 1 XOR2HS $T=395560 719600 1 180 $X=389980 $Y=719220
X2230 1831 1828 1786 2 1 XOR2HS $T=396180 729680 0 180 $X=390600 $Y=724260
X2231 1836 1833 1822 2 1 XOR2HS $T=397420 749840 0 180 $X=391840 $Y=744420
X2232 1845 1821 192 2 1 XOR2HS $T=397420 699440 0 0 $X=397420 $Y=699060
X2233 1875 1872 1668 2 1 XOR2HS $T=404240 780080 1 180 $X=398660 $Y=779700
X2234 1878 1876 1829 2 1 XOR2HS $T=404860 820400 0 180 $X=399280 $Y=814980
X2235 1865 1883 1663 2 1 XOR2HS $T=406100 790160 1 180 $X=400520 $Y=789780
X2236 1888 1869 1867 2 1 XOR2HS $T=406100 850640 0 180 $X=400520 $Y=845220
X2237 1890 1887 1847 2 1 XOR2HS $T=406720 810320 1 180 $X=401140 $Y=809940
X2238 1891 1817 1838 2 1 XOR2HS $T=406720 830480 1 180 $X=401140 $Y=830100
X2239 1892 1859 1874 2 1 XOR2HS $T=407340 749840 0 180 $X=401760 $Y=744420
X2240 1866 1879 1844 2 1 XOR2HS $T=402380 820400 0 0 $X=402380 $Y=820020
X2241 1910 1898 1888 2 1 XOR2HS $T=412920 850640 1 180 $X=407340 $Y=850260
X2242 1871 1886 1917 2 1 XOR2HS $T=408580 780080 1 0 $X=408580 $Y=774660
X2243 1915 1854 1930 2 1 XOR2HS $T=409200 830480 0 0 $X=409200 $Y=830100
X2244 1922 1912 1939 2 1 XOR2HS $T=410440 749840 1 0 $X=410440 $Y=744420
X2245 1967 1924 1948 2 1 XOR2HS $T=419740 820400 1 180 $X=414160 $Y=820020
X2246 1966 1941 1952 2 1 XOR2HS $T=420360 739760 1 180 $X=414780 $Y=739380
X2247 2008 1979 1986 2 1 XOR2HS $T=427800 739760 1 180 $X=422220 $Y=739380
X2248 2006 1997 1988 2 1 XOR2HS $T=427800 830480 1 180 $X=422220 $Y=830100
X2249 2010 1991 2034 2 1 XOR2HS $T=427180 820400 0 0 $X=427180 $Y=820020
X2250 2044 2025 2037 2 1 XOR2HS $T=435860 739760 1 180 $X=430280 $Y=739380
X2251 2061 2058 2050 2 1 XOR2HS $T=438960 820400 0 180 $X=433380 $Y=814980
X2252 2053 2019 2068 2 1 XOR2HS $T=435240 840560 1 0 $X=435240 $Y=835140
X2253 2100 2069 2070 2 1 XOR2HS $T=445780 739760 1 180 $X=440200 $Y=739380
X2254 2086 2089 2104 2 1 XOR2HS $T=441440 850640 0 0 $X=441440 $Y=850260
X2255 2126 2098 2106 2 1 XOR2HS $T=450120 820400 0 180 $X=444540 $Y=814980
X2256 2104 2073 2102 2 1 XOR2HS $T=447640 850640 0 0 $X=447640 $Y=850260
X2257 2133 2130 2114 2 1 XOR2HS $T=451980 749840 0 0 $X=451980 $Y=749460
X2258 2175 2145 2157 2 1 XOR2HS $T=460040 739760 1 180 $X=454460 $Y=739380
X2259 2155 2152 2168 2 1 XOR2HS $T=461900 820400 1 180 $X=456320 $Y=820020
X2260 2193 2205 2217 2 1 XOR2HS $T=463140 830480 1 0 $X=463140 $Y=825060
X2261 2212 2195 2216 2 1 XOR2HS $T=465000 749840 1 0 $X=465000 $Y=744420
X2262 250 2224 2236 2 1 XOR2HS $T=467480 770000 1 0 $X=467480 $Y=764580
X2263 2236 2221 2246 2 1 XOR2HS $T=469960 770000 0 0 $X=469960 $Y=769620
X2264 2226 2222 2257 2 1 XOR2HS $T=471820 820400 0 0 $X=471820 $Y=820020
X2265 2243 2225 2263 2 1 XOR2HS $T=473060 739760 0 0 $X=473060 $Y=739380
X2266 2252 2261 2274 2 1 XOR2HS $T=474920 810320 1 0 $X=474920 $Y=804900
X2267 2262 2265 2277 2 1 XOR2HS $T=475540 820400 1 0 $X=475540 $Y=814980
X2268 2264 2268 2276 2 1 XOR2HS $T=476160 780080 1 0 $X=476160 $Y=774660
X2269 2281 2250 2289 2 1 XOR2HS $T=479260 739760 0 0 $X=479260 $Y=739380
X2270 2285 2287 2302 2 1 XOR2HS $T=481120 790160 1 0 $X=481120 $Y=784740
X2271 2278 2282 2306 2 1 XOR2HS $T=482360 800240 0 0 $X=482360 $Y=799860
X2272 2295 270 2310 2 1 XOR2HS $T=482980 709520 0 0 $X=482980 $Y=709140
X2273 2297 2286 2312 2 1 XOR2HS $T=483600 739760 1 0 $X=483600 $Y=734340
X2274 2301 2318 2305 2 1 XOR2HS $T=490420 719600 0 180 $X=484840 $Y=714180
X2275 2258 2237 2284 2 1 XOR2HS $T=484840 810320 0 0 $X=484840 $Y=809940
X2276 2292 2298 2319 2 1 XOR2HS $T=485460 780080 1 0 $X=485460 $Y=774660
X2277 2329 2326 2313 2 1 XOR2HS $T=492280 790160 0 180 $X=486700 $Y=784740
X2278 2332 2328 2316 2 1 XOR2HS $T=492900 739760 1 180 $X=487320 $Y=739380
X2279 2340 2314 2324 2 1 XOR2HS $T=494760 749840 0 180 $X=489180 $Y=744420
X2280 2338 2335 2347 2 1 XOR2HS $T=492280 780080 1 0 $X=492280 $Y=774660
X2281 2327 2339 2357 2 1 XOR2HS $T=494760 719600 1 0 $X=494760 $Y=714180
X2282 2346 2345 2358 2 1 XOR2HS $T=494760 729680 0 0 $X=494760 $Y=729300
X2283 2355 2348 2373 2 1 XOR2HS $T=499100 749840 1 0 $X=499100 $Y=744420
X2284 2277 2384 2394 2 1 XOR2HS $T=504060 770000 0 0 $X=504060 $Y=769620
X2285 2394 2353 2406 2 1 XOR2HS $T=505920 770000 1 0 $X=505920 $Y=764580
X2286 279 2380 2419 2 1 XOR2HS $T=511500 729680 0 0 $X=511500 $Y=729300
X2287 2412 2419 2426 2 1 XOR2HS $T=511500 739760 0 0 $X=511500 $Y=739380
X2288 278 2375 2430 2 1 XOR2HS $T=512120 749840 1 0 $X=512120 $Y=744420
X2289 2406 2442 2452 2 1 XOR2HS $T=517080 770000 1 0 $X=517080 $Y=764580
X2290 2388 2430 2461 2 1 XOR2HS $T=519560 749840 0 0 $X=519560 $Y=749460
X2291 2690 2687 2668 2 1 XOR2HS $T=570400 870800 1 180 $X=564820 $Y=870420
X2292 2700 2708 2719 2 1 XOR2HS $T=572880 860720 0 0 $X=572880 $Y=860340
X2293 2698 2697 456 2 1 XOR2HS $T=574740 880880 1 0 $X=574740 $Y=875460
X2294 2754 2745 481 2 1 XOR2HS $T=582800 870800 0 0 $X=582800 $Y=870420
X2295 2771 2774 2787 2 1 XOR2HS $T=585280 870800 1 0 $X=585280 $Y=865380
X2296 2763 2766 2793 2 1 XOR2HS $T=585900 850640 1 0 $X=585900 $Y=845220
X2297 2784 2789 2814 2 1 XOR2HS $T=589620 840560 0 0 $X=589620 $Y=840180
X2298 2790 2802 2816 2 1 XOR2HS $T=590240 860720 0 0 $X=590240 $Y=860340
X2299 2833 2829 2844 2 1 XOR2HS $T=597060 860720 1 0 $X=597060 $Y=855300
X2300 2819 2821 2848 2 1 XOR2HS $T=598920 840560 1 0 $X=598920 $Y=835140
X2301 2866 2853 2880 2 1 XOR2HS $T=603880 850640 1 0 $X=603880 $Y=845220
X2302 2875 2878 2893 2 1 XOR2HS $T=610700 840560 0 0 $X=610700 $Y=840180
X2303 2892 2888 2913 2 1 XOR2HS $T=612560 840560 1 0 $X=612560 $Y=835140
X2304 3047 3039 3008 2 1 XOR2HS $T=647280 759920 0 180 $X=641700 $Y=754500
X2305 3054 3021 3078 2 1 XOR2HS $T=649760 739760 1 0 $X=649760 $Y=734340
X2306 3195 3175 3192 2 1 XOR2HS $T=682620 719600 1 180 $X=677040 $Y=719220
X2307 3216 3193 3239 2 1 XOR2HS $T=680760 820400 0 0 $X=680760 $Y=820020
X2308 3255 3249 3292 2 1 XOR2HS $T=690680 830480 1 0 $X=690680 $Y=825060
X2309 569 635 3305 2 1 XOR2HS $T=692540 880880 1 0 $X=692540 $Y=875460
X2310 3315 3318 3359 2 1 XOR2HS $T=701840 830480 1 0 $X=701840 $Y=825060
X2311 3364 3375 3425 2 1 XOR2HS $T=711760 820400 0 0 $X=711760 $Y=820020
X2312 3436 3434 3420 2 1 XOR2HS $T=718580 850640 0 180 $X=713000 $Y=845220
X2313 558 649 3432 2 1 XOR2HS $T=713000 880880 1 0 $X=713000 $Y=875460
X2314 3413 3419 3418 2 1 XOR2HS $T=719820 860720 1 180 $X=714240 $Y=860340
X2315 3422 3443 3444 2 1 XOR2HS $T=717340 820400 0 0 $X=717340 $Y=820020
X2316 3464 3368 3378 2 1 XOR2HS $T=724160 820400 0 180 $X=718580 $Y=814980
X2317 654 3123 3475 2 1 XOR2HS $T=720440 880880 1 0 $X=720440 $Y=875460
X2318 3491 3478 3476 2 1 XOR2HS $T=729120 820400 1 180 $X=723540 $Y=820020
X2319 3501 3477 3331 2 1 XOR2HS $T=730360 870800 0 180 $X=724780 $Y=865380
X2320 3484 3482 3517 2 1 XOR2HS $T=729740 850640 1 0 $X=729740 $Y=845220
X2321 3510 3509 3404 2 1 XOR2HS $T=730360 820400 0 0 $X=730360 $Y=820020
X2322 555 3037 3539 2 1 XOR2HS $T=733460 870800 1 0 $X=733460 $Y=865380
X2323 648 3532 3552 2 1 XOR2HS $T=735320 830480 1 0 $X=735320 $Y=825060
X2324 613 3117 3580 2 1 XOR2HS $T=741520 780080 1 0 $X=741520 $Y=774660
X2325 627 3554 3585 2 1 XOR2HS $T=742140 830480 1 0 $X=742140 $Y=825060
X2326 629 3574 3581 2 1 XOR2HS $T=748960 820400 0 180 $X=743380 $Y=814980
X2327 636 634 3548 2 1 XOR2HS $T=744000 770000 0 0 $X=744000 $Y=769620
X2328 3595 3583 3615 2 1 XOR2HS $T=748960 800240 0 0 $X=748960 $Y=799860
X2329 653 3589 3639 2 1 XOR2HS $T=752680 780080 1 0 $X=752680 $Y=774660
X2330 666 3623 3637 2 1 XOR2HS $T=752680 810320 0 0 $X=752680 $Y=809940
X2331 655 3613 3632 2 1 XOR2HS $T=755780 820400 1 0 $X=755780 $Y=814980
X2332 639 3614 3657 2 1 XOR2HS $T=757020 790160 1 0 $X=757020 $Y=784740
X2333 637 3641 3667 2 1 XOR2HS $T=758880 800240 1 0 $X=758880 $Y=794820
X2334 678 3663 3655 2 1 XOR2HS $T=764460 800240 1 180 $X=758880 $Y=799860
X2335 670 3650 3673 2 1 XOR2HS $T=762600 810320 0 0 $X=762600 $Y=809940
X2336 686 3680 3698 2 1 XOR2HS $T=766320 810320 1 0 $X=766320 $Y=804900
X2337 721 3723 3735 2 1 XOR2HS $T=773760 800240 0 0 $X=773760 $Y=799860
X2338 690 3669 3746 2 1 XOR2HS $T=775620 810320 0 0 $X=775620 $Y=809940
X2339 3553 3684 3752 2 1 XOR2HS $T=777480 790160 0 0 $X=777480 $Y=789780
X2340 679 3714 3779 2 1 XOR2HS $T=786160 800240 0 0 $X=786160 $Y=799860
X2341 3696 3774 3785 2 1 XOR2HS $T=787400 790160 1 0 $X=787400 $Y=784740
X2342 713 3773 747 2 1 XOR2HS $T=787400 790160 0 0 $X=787400 $Y=789780
X2343 3701 3784 3802 2 1 XOR2HS $T=791740 780080 0 0 $X=791740 $Y=779700
X2344 668 3770 3806 2 1 XOR2HS $T=793600 800240 1 0 $X=793600 $Y=794820
X2345 3608 3800 757 2 1 XOR2HS $T=796700 790160 0 0 $X=796700 $Y=789780
X2346 3668 3815 3822 2 1 XOR2HS $T=798560 780080 0 0 $X=798560 $Y=779700
X2347 3616 3807 3823 2 1 XOR2HS $T=798560 790160 1 0 $X=798560 $Y=784740
X2348 3617 3829 772 2 1 XOR2HS $T=803520 780080 1 0 $X=803520 $Y=774660
X2349 3646 3836 3838 2 1 XOR2HS $T=808480 780080 0 0 $X=808480 $Y=779700
X2350 1068 1100 1037 2 1 ND2S $T=231880 840560 0 180 $X=230020 $Y=835140
X2351 1137 1153 1126 2 1 ND2S $T=245520 800240 0 180 $X=243660 $Y=794820
X2352 1161 1158 1118 2 1 ND2S $T=247380 820400 0 0 $X=247380 $Y=820020
X2353 1384 1483 1387 2 1 ND2S $T=320540 840560 0 0 $X=320540 $Y=840180
X2354 1487 1458 1483 2 1 ND2S $T=331080 840560 0 0 $X=331080 $Y=840180
X2355 1449 1619 108 2 1 ND2S $T=347820 850640 1 0 $X=347820 $Y=845220
X2356 279 2389 2380 2 1 ND2S $T=505300 729680 0 180 $X=503440 $Y=724260
X2357 2448 2514 198 2 1 ND2S $T=533820 830480 1 180 $X=531960 $Y=830100
X2358 3189 3155 3151 2 1 ND2S $T=675180 759920 0 0 $X=675180 $Y=759540
X2359 3131 3198 3105 2 1 ND2S $T=676420 780080 0 0 $X=676420 $Y=779700
X2360 3291 3332 3130 2 1 ND2S $T=698120 770000 1 180 $X=696260 $Y=769620
X2361 3651 684 3656 2 1 ND2S $T=759500 870800 0 180 $X=757640 $Y=865380
X2362 4351 4328 4338 2 1 ND2S $T=947360 830480 0 0 $X=947360 $Y=830100
X2363 4295 4343 4326 2 1 ND2S $T=949220 850640 0 180 $X=947360 $Y=845220
X2364 4351 4347 4295 2 1 ND2S $T=949220 850640 1 180 $X=947360 $Y=850260
X2365 1111 1112 1101 1 2 ND2 $T=236840 870800 0 180 $X=234980 $Y=865380
X2366 1119 1148 1137 1 2 ND2 $T=242420 800240 0 180 $X=240560 $Y=794820
X2367 1146 1149 1125 1 2 ND2 $T=242420 820400 1 0 $X=242420 $Y=814980
X2368 1149 1151 1158 1 2 ND2 $T=244280 820400 1 0 $X=244280 $Y=814980
X2369 1234 1254 1242 1 2 ND2 $T=262260 840560 1 0 $X=262260 $Y=835140
X2370 1286 1290 1294 1 2 ND2 $T=270320 850640 1 0 $X=270320 $Y=845220
X2371 1286 1297 1207 1 2 ND2 $T=272180 850640 1 0 $X=272180 $Y=845220
X2372 1294 1308 1207 1 2 ND2 $T=274040 850640 1 0 $X=274040 $Y=845220
X2373 1328 1323 1322 1 2 ND2 $T=279620 860720 0 180 $X=277760 $Y=855300
X2374 1343 1341 1327 1 2 ND2 $T=280860 790160 1 180 $X=279000 $Y=789780
X2375 1321 1337 1170 1 2 ND2 $T=280860 830480 1 180 $X=279000 $Y=830100
X2376 1143 1342 1322 1 2 ND2 $T=281480 860720 0 180 $X=279620 $Y=855300
X2377 1226 1347 1327 1 2 ND2 $T=286440 800240 1 0 $X=286440 $Y=794820
X2378 1404 1394 1388 1 2 ND2 $T=296980 749840 0 180 $X=295120 $Y=744420
X2379 1203 1402 1388 1 2 ND2 $T=300080 749840 1 0 $X=300080 $Y=744420
X2380 1422 1414 1408 1 2 ND2 $T=303800 860720 1 180 $X=301940 $Y=860340
X2381 1422 1425 1168 1 2 ND2 $T=305660 860720 1 180 $X=303800 $Y=860340
X2382 1408 1434 1168 1 2 ND2 $T=307520 860720 1 180 $X=305660 $Y=860340
X2383 1233 1428 1436 1 2 ND2 $T=306900 729680 1 0 $X=306900 $Y=724260
X2384 1495 1511 1497 1 2 ND2 $T=324260 719600 0 180 $X=322400 $Y=714180
X2385 1456 1524 1495 1 2 ND2 $T=329220 709520 1 180 $X=327360 $Y=709140
X2386 1553 1526 1560 1 2 ND2 $T=332320 820400 1 0 $X=332320 $Y=814980
X2387 1405 1563 1567 1 2 ND2 $T=334180 860720 1 0 $X=334180 $Y=855300
X2388 1607 1597 1405 1 2 ND2 $T=337900 860720 0 180 $X=336040 $Y=855300
X2389 1607 1605 1567 1 2 ND2 $T=342860 860720 0 0 $X=342860 $Y=860340
X2390 1432 1640 1642 1 2 ND2 $T=352160 860720 0 0 $X=352160 $Y=860340
X2391 1677 1674 1432 1 2 ND2 $T=362700 860720 0 180 $X=360840 $Y=855300
X2392 1677 1683 1642 1 2 ND2 $T=362700 860720 1 0 $X=362700 $Y=855300
X2393 1711 1695 1412 1 2 ND2 $T=370140 870800 0 180 $X=368280 $Y=865380
X2394 173 1704 1711 1 2 ND2 $T=372620 870800 0 180 $X=370760 $Y=865380
X2395 173 1727 1412 1 2 ND2 $T=372620 870800 1 0 $X=372620 $Y=865380
X2396 175 1753 174 1 2 ND2 $T=378820 699440 0 0 $X=378820 $Y=699060
X2397 1734 1764 168 1 2 ND2 $T=381920 749840 0 180 $X=380060 $Y=744420
X2398 174 1750 176 1 2 ND2 $T=380680 699440 0 0 $X=380680 $Y=699060
X2399 168 1783 1699 1 2 ND2 $T=383780 749840 1 0 $X=383780 $Y=744420
X2400 1734 1776 1699 1 2 ND2 $T=387500 749840 0 180 $X=385640 $Y=744420
X2401 1772 1798 1801 1 2 ND2 $T=388120 749840 0 0 $X=388120 $Y=749460
X2402 1772 1803 185 1 2 ND2 $T=388740 749840 1 0 $X=388740 $Y=744420
X2403 185 1823 1801 1 2 ND2 $T=392460 759920 1 0 $X=392460 $Y=754500
X2404 1785 1855 1850 1 2 ND2 $T=397420 850640 1 0 $X=397420 $Y=845220
X2405 1853 1894 1867 1 2 ND2 $T=406100 850640 1 180 $X=404240 $Y=850260
X2406 1869 1901 1910 1 2 ND2 $T=407340 850640 1 0 $X=407340 $Y=845220
X2407 1842 1911 1867 1 2 ND2 $T=409200 860720 1 180 $X=407340 $Y=860340
X2408 1910 1933 1898 1 2 ND2 $T=412920 850640 0 180 $X=411060 $Y=845220
X2409 1950 1969 1976 1 2 ND2 $T=419740 840560 1 0 $X=419740 $Y=835140
X2410 1950 1992 1977 1 2 ND2 $T=419740 840560 0 0 $X=419740 $Y=840180
X2411 1976 2003 1977 1 2 ND2 $T=423460 840560 0 180 $X=421600 $Y=835140
X2412 1980 2015 1985 1 2 ND2 $T=424700 860720 1 180 $X=422840 $Y=860340
X2413 2014 2028 1985 1 2 ND2 $T=427800 860720 1 0 $X=427800 $Y=855300
X2414 1980 2020 2014 1 2 ND2 $T=427800 860720 0 0 $X=427800 $Y=860340
X2415 2021 2027 2043 1 2 ND2 $T=429660 840560 1 0 $X=429660 $Y=835140
X2416 2021 2042 2047 1 2 ND2 $T=431520 840560 0 0 $X=431520 $Y=840180
X2417 2047 2051 2043 1 2 ND2 $T=435240 840560 0 180 $X=433380 $Y=835140
X2418 2073 2088 2089 1 2 ND2 $T=440200 840560 0 0 $X=440200 $Y=840180
X2419 2086 2103 2089 1 2 ND2 $T=445160 840560 1 180 $X=443300 $Y=840180
X2420 2073 2090 2086 1 2 ND2 $T=447020 850640 0 180 $X=445160 $Y=845220
X2421 2118 2153 2124 1 2 ND2 $T=453840 860720 1 180 $X=451980 $Y=860340
X2422 2136 2162 2118 1 2 ND2 $T=453840 870800 0 180 $X=451980 $Y=865380
X2423 2136 2179 2124 1 2 ND2 $T=458800 870800 0 180 $X=456940 $Y=865380
X2424 2177 2184 2192 1 2 ND2 $T=460040 850640 1 0 $X=460040 $Y=845220
X2425 243 2218 2154 1 2 ND2 $T=462520 759920 0 180 $X=460660 $Y=754500
X2426 2158 2196 2154 1 2 ND2 $T=462520 759920 1 180 $X=460660 $Y=759540
X2427 2199 2194 2192 1 2 ND2 $T=463760 850640 0 180 $X=461900 $Y=845220
X2428 2177 2209 2199 1 2 ND2 $T=464380 840560 0 0 $X=464380 $Y=840180
X2429 2221 2244 250 1 2 ND2 $T=472440 749840 1 180 $X=470580 $Y=749460
X2430 250 2248 2224 1 2 ND2 $T=470580 759920 0 0 $X=470580 $Y=759540
X2431 2221 2251 2224 1 2 ND2 $T=475540 770000 0 180 $X=473680 $Y=764580
X2432 2292 2268 2298 1 2 ND2 $T=482980 780080 1 0 $X=482980 $Y=774660
X2433 2327 2318 2339 1 2 ND2 $T=491040 719600 1 0 $X=491040 $Y=714180
X2434 2296 2352 2317 1 2 ND2 $T=496620 840560 1 0 $X=496620 $Y=835140
X2435 2360 2372 2364 1 2 ND2 $T=501580 810320 0 180 $X=499720 $Y=804900
X2436 2343 2359 2317 1 2 ND2 $T=500960 830480 0 0 $X=500960 $Y=830100
X2437 278 2387 2375 1 2 ND2 $T=504680 739760 0 180 $X=502820 $Y=734340
X2438 2383 2377 2360 1 2 ND2 $T=504680 800240 1 180 $X=502820 $Y=799860
X2439 2383 2398 2364 1 2 ND2 $T=505300 810320 0 180 $X=503440 $Y=804900
X2440 2412 2402 279 1 2 ND2 $T=511500 729680 1 0 $X=511500 $Y=724260
X2441 307 2439 303 1 2 ND2 $T=520180 739760 0 180 $X=518320 $Y=734340
X2442 2434 2455 2409 1 2 ND2 $T=520800 759920 0 180 $X=518940 $Y=754500
X2443 307 2424 313 1 2 ND2 $T=520800 729680 0 0 $X=520800 $Y=729300
X2444 2464 2458 307 1 2 ND2 $T=523900 739760 0 180 $X=522040 $Y=734340
X2445 313 2471 303 1 2 ND2 $T=523900 739760 1 0 $X=523900 $Y=734340
X2446 315 2470 295 1 2 ND2 $T=525140 719600 1 0 $X=525140 $Y=714180
X2447 2459 2472 2409 1 2 ND2 $T=527000 759920 0 0 $X=527000 $Y=759540
X2448 317 2501 314 1 2 ND2 $T=530720 729680 0 180 $X=528860 $Y=724260
X2449 320 2445 313 1 2 ND2 $T=529480 709520 0 0 $X=529480 $Y=709140
X2450 2522 2558 351 1 2 ND2 $T=535680 699440 1 180 $X=533820 $Y=699060
X2451 319 2528 303 1 2 ND2 $T=537540 709520 0 180 $X=535680 $Y=704100
X2452 315 2564 317 1 2 ND2 $T=544360 749840 0 180 $X=542500 $Y=744420
X2453 2499 2567 314 1 2 ND2 $T=546840 739760 1 180 $X=544980 $Y=739380
X2454 2592 2580 295 1 2 ND2 $T=551180 739760 0 180 $X=549320 $Y=734340
X2455 2508 2597 295 1 2 ND2 $T=551180 739760 1 180 $X=549320 $Y=739380
X2456 317 2598 303 1 2 ND2 $T=549320 749840 0 0 $X=549320 $Y=749460
X2457 2607 2611 397 1 2 ND2 $T=556140 719600 0 0 $X=556140 $Y=719220
X2458 388 2554 397 1 2 ND2 $T=558000 709520 1 0 $X=558000 $Y=704100
X2459 337 2652 389 1 2 ND2 $T=563580 739760 1 180 $X=561720 $Y=739380
X2460 2508 2650 301 1 2 ND2 $T=572880 729680 0 0 $X=572880 $Y=729300
X2461 2645 2716 436 1 2 ND2 $T=576600 749840 1 0 $X=576600 $Y=744420
X2462 429 2747 397 1 2 ND2 $T=581560 749840 0 0 $X=581560 $Y=749460
X2463 2759 2739 457 1 2 ND2 $T=585280 749840 1 180 $X=583420 $Y=749460
X2464 2809 2838 2845 1 2 ND2 $T=597060 870800 0 0 $X=597060 $Y=870420
X2465 2855 2810 2896 1 2 ND2 $T=603880 860720 1 0 $X=603880 $Y=855300
X2466 2901 2881 358 1 2 ND2 $T=611940 739760 0 0 $X=611940 $Y=739380
X2467 2882 2885 2905 1 2 ND2 $T=612560 850640 0 0 $X=612560 $Y=850260
X2468 2904 2907 530 1 2 ND2 $T=615660 729680 0 180 $X=613800 $Y=724260
X2469 2843 2916 2911 1 2 ND2 $T=614420 850640 1 0 $X=614420 $Y=845220
X2470 315 2609 301 1 2 ND2 $T=628060 739760 0 0 $X=628060 $Y=739380
X2471 2917 2959 2973 1 2 ND2 $T=630540 850640 1 0 $X=630540 $Y=845220
X2472 2890 2952 3048 1 2 ND2 $T=631160 860720 1 0 $X=631160 $Y=855300
X2473 592 3041 3061 1 2 ND2 $T=646660 749840 1 0 $X=646660 $Y=744420
X2474 3047 3034 3068 1 2 ND2 $T=648520 759920 0 0 $X=648520 $Y=759540
X2475 2823 3052 3065 1 2 ND2 $T=648520 850640 0 0 $X=648520 $Y=850260
X2476 3054 3081 3063 1 2 ND2 $T=652240 749840 0 180 $X=650380 $Y=744420
X2477 2736 3100 3088 1 2 ND2 $T=653480 880880 1 0 $X=653480 $Y=875460
X2478 603 3066 3095 1 2 ND2 $T=655340 719600 1 0 $X=655340 $Y=714180
X2479 604 3089 3093 1 2 ND2 $T=655340 719600 0 0 $X=655340 $Y=719220
X2480 605 3101 3104 1 2 ND2 $T=656580 739760 1 0 $X=656580 $Y=734340
X2481 2808 3091 3116 1 2 ND2 $T=660300 870800 1 0 $X=660300 $Y=865380
X2482 620 3197 3199 1 2 ND2 $T=678900 719600 0 180 $X=677040 $Y=714180
X2483 3213 3214 3219 1 2 ND2 $T=679520 790160 0 0 $X=679520 $Y=789780
X2484 3195 3224 3237 1 2 ND2 $T=682620 719600 0 0 $X=682620 $Y=719220
X2485 3209 3098 3164 1 2 ND2 $T=685100 759920 1 180 $X=683240 $Y=759540
X2486 630 3213 3215 1 2 ND2 $T=689440 800240 1 180 $X=687580 $Y=799860
X2487 3215 3057 3213 1 2 ND2 $T=688820 800240 1 0 $X=688820 $Y=794820
X2488 3239 3336 3342 1 2 ND2 $T=700600 810320 1 0 $X=700600 $Y=804900
X2489 2937 3570 3563 1 2 ND2 $T=742140 850640 0 0 $X=742140 $Y=850260
X2490 3595 3547 3583 1 2 ND2 $T=747720 800240 1 180 $X=745860 $Y=799860
X2491 3603 675 3607 1 2 ND2 $T=748960 739760 0 0 $X=748960 $Y=739380
X2492 3584 3624 3310 1 2 ND2 $T=754540 729680 1 180 $X=752680 $Y=729300
X2493 3670 3676 3681 1 2 ND2 $T=764460 729680 1 0 $X=764460 $Y=724260
X2494 3679 697 3672 1 2 ND2 $T=766940 749840 0 180 $X=765080 $Y=744420
X2495 3682 699 3687 1 2 ND2 $T=765700 759920 1 0 $X=765700 $Y=754500
X2496 3661 3689 3566 1 2 ND2 $T=769420 749840 0 180 $X=767560 $Y=744420
X2497 718 3703 3717 1 2 ND2 $T=771280 780080 1 0 $X=771280 $Y=774660
X2498 719 3683 3721 1 2 ND2 $T=771280 780080 0 0 $X=771280 $Y=779700
X2499 3715 3743 3105 1 2 ND2 $T=778720 749840 0 180 $X=776860 $Y=744420
X2500 3592 3788 689 1 2 ND2 $T=779960 870800 1 0 $X=779960 $Y=865380
X2501 3725 3766 3760 1 2 ND2 $T=784920 759920 0 180 $X=783060 $Y=754500
X2502 3724 3767 3712 1 2 ND2 $T=786780 739760 1 180 $X=784920 $Y=739380
X2503 739 3783 3782 1 2 ND2 $T=788640 759920 0 0 $X=788640 $Y=759540
X2504 758 3825 3801 1 2 ND2 $T=800420 709520 1 180 $X=798560 $Y=709140
X2505 759 3813 3794 1 2 ND2 $T=800420 719600 1 180 $X=798560 $Y=719220
X2506 761 3818 3808 1 2 ND2 $T=800420 739760 0 180 $X=798560 $Y=734340
X2507 766 3828 3820 1 2 ND2 $T=803520 749840 1 180 $X=801660 $Y=749460
X2508 4333 4336 887 1 2 ND2 $T=946740 870800 0 180 $X=944880 $Y=865380
X2509 4338 4334 4326 1 2 ND2 $T=945500 840560 1 0 $X=945500 $Y=835140
X2510 4313 4322 4333 1 2 ND2 $T=945500 860720 0 0 $X=945500 $Y=860340
X2511 887 4337 4286 1 2 ND2 $T=947980 870800 1 180 $X=946120 $Y=870420
X2512 4313 4340 4286 1 2 ND2 $T=949840 860720 0 180 $X=947980 $Y=855300
X2513 1148 1174 1113 1153 1 2 ND3P $T=241180 800240 0 0 $X=241180 $Y=799860
X2514 1290 1361 1297 1308 1 2 ND3P $T=275900 850640 1 0 $X=275900 $Y=845220
X2515 1341 1316 1338 1347 1 2 ND3P $T=279620 800240 1 0 $X=279620 $Y=794820
X2516 1344 1286 1326 1337 1 2 ND3P $T=285820 830480 1 180 $X=280860 $Y=830100
X2517 1323 1309 1348 1342 1 2 ND3P $T=290160 860720 0 180 $X=285200 $Y=855300
X2518 1394 1382 1397 1402 1 2 ND3P $T=295740 749840 0 0 $X=295740 $Y=749460
X2519 98 1409 99 100 1 2 ND3P $T=300700 699440 0 0 $X=300700 $Y=699060
X2520 1420 1424 1426 1428 1 2 ND3P $T=301320 729680 1 0 $X=301320 $Y=724260
X2521 1414 1401 1425 1434 1 2 ND3P $T=312480 860720 1 180 $X=307520 $Y=860340
X2522 1524 1506 1515 1511 1 2 ND3P $T=330460 719600 0 180 $X=325500 $Y=714180
X2523 1597 1479 1605 1563 1 2 ND3P $T=342860 850640 1 180 $X=337900 $Y=850260
X2524 1683 1607 1674 1640 1 2 ND3P $T=367040 860720 1 180 $X=362080 $Y=860340
X2525 1704 1677 1727 1695 1 2 ND3P $T=372000 860720 1 180 $X=367040 $Y=860340
X2526 1776 1772 1764 1783 1 2 ND3P $T=382540 749840 0 0 $X=382540 $Y=749460
X2527 184 183 1782 182 1 2 ND3P $T=391840 699440 1 180 $X=386880 $Y=699060
X2528 1839 1869 1856 1855 1 2 ND3P $T=396800 840560 0 0 $X=396800 $Y=840180
X2529 1901 1950 1904 1933 1 2 ND3P $T=410440 840560 0 0 $X=410440 $Y=840180
X2530 1911 1926 1934 1894 1 2 ND3P $T=410440 860720 0 0 $X=410440 $Y=860340
X2531 1935 1897 1951 205 1 2 ND3P $T=415400 709520 0 0 $X=415400 $Y=709140
X2532 1969 2021 1992 2003 1 2 ND3P $T=424080 840560 0 0 $X=424080 $Y=840180
X2533 2020 2048 2015 2028 1 2 ND3P $T=426560 870800 1 0 $X=426560 $Y=865380
X2534 2027 2073 2042 2051 1 2 ND3P $T=434620 840560 0 0 $X=434620 $Y=840180
X2535 2090 2108 2088 2103 1 2 ND3P $T=441440 840560 1 0 $X=441440 $Y=835140
X2536 2162 2161 2179 2153 1 2 ND3P $T=460660 860720 1 180 $X=455700 $Y=860340
X2537 2196 2221 2165 2218 1 2 ND3P $T=463760 759920 0 0 $X=463760 $Y=759540
X2538 2184 2241 2209 2194 1 2 ND3P $T=466240 840560 0 0 $X=466240 $Y=840180
X2539 2352 2363 2356 2359 1 2 ND3P $T=494760 830480 0 0 $X=494760 $Y=830100
X2540 2393 2412 2396 2387 1 2 ND3P $T=505300 739760 1 0 $X=505300 $Y=734340
X2541 2402 2382 2405 2389 1 2 ND3P $T=510880 729680 0 180 $X=505920 $Y=724260
X2542 2472 2442 2465 2455 1 2 ND3P $T=527000 759920 0 180 $X=522040 $Y=754500
X2543 3244 3105 3130 3164 1 2 ND3P $T=695020 780080 1 0 $X=695020 $Y=774660
X2544 1131 1135 1092 1117 1 2 MAO222P $T=242420 780080 1 180 $X=236840 $Y=779700
X2545 1117 1144 1136 1119 1 2 MAO222P $T=244280 790160 1 180 $X=238700 $Y=789780
X2546 1142 1145 1110 1125 1 2 MAO222P $T=244280 810320 1 180 $X=238700 $Y=809940
X2547 1166 1159 1083 1131 1 2 MAO222P $T=245520 780080 1 0 $X=245520 $Y=774660
X2548 1173 1132 1085 1166 1 2 MAO222P $T=247380 770000 1 0 $X=247380 $Y=764580
X2549 1209 1212 1104 1173 1 2 MAO222P $T=260400 749840 1 180 $X=254820 $Y=749460
X2550 49 46 18 1219 1 2 MAO222P $T=256680 699440 0 0 $X=256680 $Y=699060
X2551 1219 1195 1080 1220 1 2 MAO222P $T=258540 719600 1 0 $X=258540 $Y=714180
X2552 1220 1178 1081 1221 1 2 MAO222P $T=258540 729680 1 0 $X=258540 $Y=724260
X2553 1221 1202 1075 1209 1 2 MAO222P $T=258540 739760 0 0 $X=258540 $Y=739380
X2554 1291 1289 1238 1314 1 2 MAO222P $T=269700 830480 0 0 $X=269700 $Y=830100
X2555 1371 1365 1210 1343 1 2 MAO222P $T=288300 780080 0 0 $X=288300 $Y=779700
X2556 85 1372 1127 1328 1 2 MAO222P $T=289540 870800 1 0 $X=289540 $Y=865380
X2557 1409 1398 1269 1419 1 2 MAO222P $T=299460 709520 0 0 $X=299460 $Y=709140
X2558 1424 1415 1259 1404 1 2 MAO222P $T=306900 729680 1 180 $X=301320 $Y=729300
X2559 1417 1451 1448 1427 1 2 MAO222P $T=311240 800240 1 0 $X=311240 $Y=794820
X2560 1446 1482 1477 1421 1 2 MAO222P $T=320540 810320 0 180 $X=314960 $Y=804900
X2561 1479 1484 1292 1422 1 2 MAO222P $T=320540 860720 1 180 $X=314960 $Y=860340
X2562 1457 1423 1429 1417 1 2 MAO222P $T=316200 780080 1 0 $X=316200 $Y=774660
X2563 1427 1463 1453 1446 1 2 MAO222P $T=317440 800240 0 0 $X=317440 $Y=799860
X2564 1501 1516 1536 1457 1 2 MAO222P $T=327980 780080 0 180 $X=322400 $Y=774660
X2565 115 1540 1517 1456 1 2 MAO222P $T=332940 709520 0 180 $X=327360 $Y=704100
X2566 1728 1745 1759 1729 1 2 MAO222P $T=378820 860720 0 180 $X=373240 $Y=855300
X2567 1743 1724 170 1734 1 2 MAO222P $T=379440 739760 1 180 $X=373860 $Y=739380
X2568 1715 1693 166 1743 1 2 MAO222P $T=378820 729680 0 0 $X=378820 $Y=729300
X2569 1756 1812 1747 1825 1 2 MAO222P $T=391220 850640 1 0 $X=391220 $Y=845220
X2570 1729 1815 1809 1842 1 2 MAO222P $T=396180 860720 1 0 $X=396180 $Y=855300
X2571 1926 1945 1962 1980 1 2 MAO222P $T=416640 860720 0 0 $X=416640 $Y=860340
X2572 2065 2054 225 2125 1 2 MAO222P $T=439580 749840 0 0 $X=439580 $Y=749460
X2573 2048 2102 2096 2136 1 2 MAO222P $T=445780 860720 0 0 $X=445780 $Y=860340
X2574 2125 2122 235 2158 1 2 MAO222P $T=447020 759920 1 0 $X=447020 $Y=754500
X2575 2161 2139 2143 2177 1 2 MAO222P $T=453840 850640 1 0 $X=453840 $Y=845220
X2576 2229 2266 2279 2290 1 2 MAO222P $T=476780 830480 1 0 $X=476780 $Y=825060
X2577 2241 2259 2246 2296 1 2 MAO222P $T=478640 840560 0 0 $X=478640 $Y=840180
X2578 2290 2288 2293 2323 1 2 MAO222P $T=482980 830480 1 0 $X=482980 $Y=825060
X2579 2341 2334 275 2374 1 2 MAO222P $T=494140 759920 1 0 $X=494140 $Y=754500
X2580 2363 2330 2322 2383 1 2 MAO222P $T=497860 820400 1 0 $X=497860 $Y=814980
X2581 2374 2392 283 2388 1 2 MAO222P $T=505300 749840 1 0 $X=505300 $Y=744420
X2582 2370 2344 2362 2414 1 2 MAO222P $T=505300 800240 0 0 $X=505300 $Y=799860
X2583 2414 2336 2457 2441 1 2 MAO222P $T=523280 800240 1 180 $X=517700 $Y=799860
X2584 2441 2368 2423 2427 1 2 MAO222P $T=519560 790160 0 0 $X=519560 $Y=789780
X2585 2476 2468 2461 2494 1 2 MAO222P $T=523900 780080 0 0 $X=523900 $Y=779700
X2586 2437 2498 2443 2476 1 2 MAO222P $T=531340 790160 1 180 $X=525760 $Y=789780
X2587 2494 2483 2426 2459 1 2 MAO222P $T=527000 770000 1 0 $X=527000 $Y=764580
X2588 1126 1 1119 1113 2 ND2P $T=240560 800240 0 180 $X=236840 $Y=794820
X2589 1321 1 1314 1326 2 ND2P $T=279000 830480 1 180 $X=275280 $Y=830100
X2590 1170 1 1314 1344 2 ND2P $T=282720 830480 0 180 $X=279000 $Y=825060
X2591 1143 1 1328 1348 2 ND2P $T=285200 860720 0 180 $X=281480 $Y=855300
X2592 1226 1 1343 1338 2 ND2P $T=282720 790160 0 0 $X=282720 $Y=789780
X2593 1203 1 1404 1397 2 ND2P $T=300080 739760 0 0 $X=300080 $Y=739380
X2594 1233 1 1419 1426 2 ND2P $T=301320 719600 0 0 $X=301320 $Y=719220
X2595 1436 1 1419 1420 2 ND2P $T=306280 719600 0 0 $X=306280 $Y=719220
X2596 1497 1 1456 1515 2 ND2P $T=323640 709520 0 0 $X=323640 $Y=709140
X2597 1785 1 1825 1839 2 ND2P $T=396180 840560 1 180 $X=392460 $Y=840180
X2598 1853 1 1842 1934 2 ND2P $T=406100 860720 0 180 $X=402380 $Y=855300
X2599 1850 1 1825 1856 2 ND2P $T=403000 840560 0 0 $X=403000 $Y=840180
X2600 1947 1 1937 1914 2 ND2P $T=414160 810320 1 0 $X=414160 $Y=804900
X2601 205 1 1928 1860 2 ND2P $T=416020 719600 1 0 $X=416020 $Y=714180
X2602 1972 1 1959 1929 2 ND2P $T=419740 790160 1 180 $X=416020 $Y=789780
X2603 243 1 2158 2165 2 ND2P $T=459420 759920 0 180 $X=455700 $Y=754500
X2604 2343 1 2296 2356 2 ND2P $T=496620 840560 0 0 $X=496620 $Y=840180
X2605 2375 1 2388 2393 2 ND2P $T=507780 739760 1 180 $X=504060 $Y=739380
X2606 278 1 2388 2396 2 ND2P $T=507780 739760 0 0 $X=507780 $Y=739380
X2607 2434 1 2459 2465 2 ND2P $T=520800 749840 1 0 $X=520800 $Y=744420
X2608 1132 1085 1173 2 1 1160 XNR3 $T=239940 749840 0 0 $X=239940 $Y=749460
X2609 1212 1104 1209 2 1 1197 XNR3 $T=257920 749840 1 0 $X=257920 $Y=744420
X2610 1423 1429 1457 2 1 1413 XNR3 $T=303800 780080 1 0 $X=303800 $Y=774660
X2611 1460 1469 1481 2 1 1454 XNR3 $T=314340 759920 1 0 $X=314340 $Y=754500
X2612 1693 166 1715 2 1 1680 XNR3 $T=366420 729680 0 0 $X=366420 $Y=729300
X2613 1699 168 1734 2 1 1698 XNR3 $T=367660 749840 0 0 $X=367660 $Y=749460
X2614 180 1755 1714 2 1 1706 XNR3 $T=381300 709520 1 180 $X=370140 $Y=709140
X2615 172 1705 1730 2 1 1708 XNR3 $T=372620 729680 1 0 $X=372620 $Y=724260
X2616 1765 1771 1792 2 1 1758 XNR3 $T=382540 840560 1 0 $X=382540 $Y=835140
X2617 1773 1767 1797 2 1 1774 XNR3 $T=383780 810320 1 0 $X=383780 $Y=804900
X2618 1780 1768 1794 2 1 1762 XNR3 $T=385020 780080 1 0 $X=385020 $Y=774660
X2619 1862 193 1893 2 1 1852 XNR3 $T=401140 770000 1 0 $X=401140 $Y=764580
X2620 1961 211 1913 2 1 1900 XNR3 $T=419740 759920 1 180 $X=408580 $Y=759540
X2621 2016 218 1990 2 1 1978 XNR3 $T=433380 759920 1 180 $X=422220 $Y=759540
X2622 2054 225 2065 2 1 2111 XNR3 $T=435860 770000 1 0 $X=435860 $Y=764580
X2623 2154 243 2158 2 1 2210 XNR3 $T=455080 770000 1 0 $X=455080 $Y=764580
X2624 2176 2187 2198 2 1 2227 XNR3 $T=459420 840560 1 0 $X=459420 $Y=835140
X2625 2256 261 2254 2 1 2308 XNR3 $T=474920 759920 1 0 $X=474920 $Y=754500
X2626 2344 2362 2370 2 1 2349 XNR3 $T=497860 800240 1 0 $X=497860 $Y=794820
X2627 3539 665 660 2 1 3656 XNR3 $T=743380 870800 1 0 $X=743380 $Y=865380
X2628 1160 1182 1 2 INV2 $T=246140 759920 0 0 $X=246140 $Y=759540
X2629 1352 1321 1 2 INV2 $T=284580 820400 0 0 $X=284580 $Y=820020
X2630 1413 1365 1 2 INV2 $T=301940 780080 1 0 $X=301940 $Y=774660
X2631 1418 1294 1 2 INV2 $T=302560 850640 1 0 $X=302560 $Y=845220
X2632 1454 1386 1 2 INV2 $T=312480 759920 1 0 $X=312480 $Y=754500
X2633 1680 1688 1 2 INV2 $T=364560 729680 0 0 $X=364560 $Y=729300
X2634 1698 1700 1 2 INV2 $T=367660 749840 1 0 $X=367660 $Y=744420
X2635 1702 1705 1 2 INV2 $T=368900 729680 1 0 $X=368900 $Y=724260
X2636 1708 1721 1 2 INV2 $T=370760 729680 1 0 $X=370760 $Y=724260
X2637 1706 1722 1 2 INV2 $T=370760 759920 1 0 $X=370760 $Y=754500
X2638 179 1740 1 2 INV2 $T=380060 749840 0 0 $X=380060 $Y=749460
X2639 1762 1694 1 2 INV2 $T=383160 780080 1 0 $X=383160 $Y=774660
X2640 1774 1741 1 2 INV2 $T=383780 810320 0 0 $X=383780 $Y=809940
X2641 1775 1755 1 2 INV2 $T=384400 719600 1 0 $X=384400 $Y=714180
X2642 1678 1794 1 2 INV2 $T=391220 780080 0 0 $X=391220 $Y=779700
X2643 1718 1790 1 2 INV2 $T=393080 790160 0 0 $X=393080 $Y=789780
X2644 1817 1830 1 2 INV2 $T=393080 830480 0 0 $X=393080 $Y=830100
X2645 1846 1811 1 2 INV2 $T=398040 800240 0 0 $X=398040 $Y=799860
X2646 1849 1788 1 2 INV2 $T=398660 770000 0 0 $X=398660 $Y=769620
X2647 1852 1853 1 2 INV2 $T=399280 770000 1 0 $X=399280 $Y=764580
X2648 1827 1845 1 2 INV2 $T=406100 699440 1 180 $X=404240 $Y=699060
X2649 197 1909 1 2 INV2 $T=410440 699440 0 0 $X=410440 $Y=699060
X2650 1931 1953 1 2 INV2 $T=412920 790160 0 0 $X=412920 $Y=789780
X2651 1960 1873 1 2 INV2 $T=417880 719600 1 180 $X=416020 $Y=719220
X2652 1900 1962 1 2 INV2 $T=416020 840560 1 0 $X=416020 $Y=835140
X2653 207 1707 1 2 INV2 $T=417880 850640 0 0 $X=417880 $Y=850260
X2654 1978 1985 1 2 INV2 $T=422840 860720 1 0 $X=422840 $Y=855300
X2655 209 1972 1 2 INV2 $T=443920 790160 0 180 $X=442060 $Y=784740
X2656 2111 2118 1 2 INV2 $T=446400 840560 1 0 $X=446400 $Y=835140
X2657 2210 2192 1 2 INV2 $T=465620 770000 1 180 $X=463760 $Y=769620
X2658 2227 2199 1 2 INV2 $T=468720 850640 0 0 $X=468720 $Y=850260
X2659 2253 205 1 2 INV2 $T=476160 780080 0 180 $X=474300 $Y=774660
X2660 2308 2317 1 2 INV2 $T=486080 759920 0 0 $X=486080 $Y=759540
X2661 2349 2354 1 2 INV2 $T=496000 800240 1 0 $X=496000 $Y=794820
X2662 547 309 1 2 INV2 $T=619380 830480 1 180 $X=617520 $Y=830100
X2663 3243 3252 1 2 INV2 $T=685720 749840 0 0 $X=685720 $Y=749460
X2664 3223 3130 1 2 INV2 $T=696260 759920 0 0 $X=696260 $Y=759540
X2665 3136 3254 1 2 INV2 $T=703700 770000 1 180 $X=701840 $Y=769620
X2666 3105 3235 1 2 INV2 $T=703080 780080 1 0 $X=703080 $Y=774660
X2667 665 547 1 2 INV2 $T=737180 860720 0 180 $X=735320 $Y=855300
X2668 3745 247 1 2 INV2 $T=779960 830480 1 180 $X=778100 $Y=830100
X2669 3761 736 1 2 INV2 $T=783680 820400 0 180 $X=781820 $Y=814980
X2670 3789 751 1 2 INV2 $T=793600 820400 1 0 $X=793600 $Y=814980
X2671 3793 752 1 2 INV2 $T=794220 840560 1 0 $X=794220 $Y=835140
X2672 3827 769 1 2 INV2 $T=803520 810320 0 0 $X=803520 $Y=809940
X2673 3821 767 1 2 INV2 $T=803520 820400 0 0 $X=803520 $Y=820020
X2674 4344 94 1 2 INV2 $T=947360 770000 1 180 $X=945500 $Y=769620
X2675 4352 92 1 2 INV2 $T=951080 770000 0 180 $X=949220 $Y=764580
X2676 4360 4363 1 2 INV2 $T=952940 770000 0 180 $X=951080 $Y=764580
X2677 3686 3702 1 2 INV2 $T=959760 850640 1 180 $X=957900 $Y=850260
X2678 4391 89 1 2 INV2 $T=962240 770000 0 180 $X=960380 $Y=764580
X2679 4390 97 1 2 INV2 $T=962860 770000 1 0 $X=962860 $Y=764580
X2680 1779 2 1799 1816 1 AN2B1S $T=389360 770000 0 0 $X=389360 $Y=769620
X2681 1883 2 1832 1877 1 AN2B1S $T=406100 800240 0 180 $X=403000 $Y=794820
X2682 2908 2 309 3123 1 AN2B1S $T=660920 840560 1 0 $X=660920 $Y=835140
X2683 1696 1707 1 1757 2 AN2S $T=371380 780080 1 0 $X=371380 $Y=774660
X2684 1713 1707 1 1768 2 AN2S $T=381300 780080 0 0 $X=381300 $Y=779700
X2685 1881 1824 1 1863 2 AN2S $T=404860 719600 1 180 $X=402380 $Y=719220
X2686 1827 165 1 196 2 AN2S $T=406100 699440 0 0 $X=406100 $Y=699060
X2687 2868 262 1 2 INV8CK $T=606980 729680 0 180 $X=600160 $Y=724260
X2688 2857 294 1 2 INV8CK $T=613800 790160 0 180 $X=606980 $Y=784740
X2689 2683 430 1 2 INV8CK $T=606980 800240 1 0 $X=606980 $Y=794820
X2690 2755 396 1 2 INV8CK $T=620620 780080 0 0 $X=620620 $Y=779700
X2691 3050 590 1 2 INV8CK $T=646660 790160 0 0 $X=646660 $Y=789780
X2692 178 252 1 2 BUF2CK $T=506540 880880 1 0 $X=506540 $Y=875460
X2693 509 582 1 2 BUF2CK $T=641700 830480 1 180 $X=638600 $Y=830100
X2694 548 509 1 2 BUF2CK $T=657200 820400 0 0 $X=657200 $Y=820020
X2695 548 674 1 2 BUF2CK $T=748960 840560 1 0 $X=748960 $Y=835140
X2696 674 788 1 2 BUF2CK $T=825840 870800 0 0 $X=825840 $Y=870420
X2697 4572 4540 1 2 BUF2CK $T=1018660 800240 0 0 $X=1018660 $Y=799860
X2698 1391 84 1 2 INV12CK $T=306280 830480 0 180 $X=296360 $Y=825060
X2699 1391 106 1 2 INV12CK $T=310620 870800 0 0 $X=310620 $Y=870420
X2700 2550 308 1 2 INV12CK $T=541260 749840 0 180 $X=531340 $Y=744420
X2701 2783 480 1 2 INV12CK $T=588380 770000 0 180 $X=578460 $Y=764580
X2702 554 448 1 2 INV12CK $T=624960 810320 0 0 $X=624960 $Y=809940
X2703 795 3953 1 2 INV12CK $T=841340 749840 0 180 $X=831420 $Y=744420
X2704 3953 818 1 2 INV12CK $T=876680 770000 0 180 $X=866760 $Y=764580
X2705 3953 813 1 2 INV12CK $T=884740 729680 1 0 $X=884740 $Y=724260
X2706 2425 293 292 291 287 285 1 2 284 AO222 $T=515220 870800 1 180 $X=509020 $Y=870420
X2707 2435 293 292 297 219 285 1 2 289 AO222 $T=517700 880880 0 180 $X=511500 $Y=875460
X2708 2436 293 292 306 1667 285 1 2 312 AO222 $T=517700 739760 0 0 $X=517700 $Y=739380
X2709 2568 293 292 364 1657 285 1 2 2513 AO222 $T=544980 780080 1 180 $X=538780 $Y=779700
X2710 2589 293 292 399 1804 285 1 2 2590 AO222 $T=561100 830480 1 180 $X=554900 $Y=830100
X2711 2673 293 292 415 1652 285 1 2 2604 AO222 $T=566060 850640 1 180 $X=559860 $Y=850260
X2712 2679 293 292 416 1720 285 1 2 2643 AO222 $T=566680 840560 0 180 $X=560480 $Y=835140
X2713 2675 293 292 418 1649 285 1 2 2647 AO222 $T=567300 780080 1 180 $X=561100 $Y=779700
X2714 2682 293 292 422 1659 285 1 2 2642 AO222 $T=568540 790160 1 180 $X=562340 $Y=789780
X2715 2710 293 292 435 1646 285 1 2 2569 AO222 $T=574120 830480 0 180 $X=567920 $Y=825060
X2716 2714 293 292 441 1655 285 1 2 2578 AO222 $T=575360 810320 1 180 $X=569160 $Y=809940
X2717 3995 3984 3981 3962 3957 3971 1 2 3916 AO222 $T=848160 860720 1 180 $X=841960 $Y=860340
X2718 4004 3984 3981 3976 3987 3971 1 2 3890 AO222 $T=851260 790160 0 180 $X=845060 $Y=784740
X2719 4005 3984 3981 3968 3988 3971 1 2 3920 AO222 $T=851260 800240 1 180 $X=845060 $Y=799860
X2720 4002 3984 3981 3977 3989 3971 1 2 3915 AO222 $T=851260 870800 1 180 $X=845060 $Y=870420
X2721 3996 3984 3981 3979 3991 3971 1 2 3913 AO222 $T=851880 810320 1 180 $X=845680 $Y=809940
X2722 4003 3984 3981 3997 3963 3971 1 2 3908 AO222 $T=852500 840560 0 180 $X=846300 $Y=835140
X2723 4014 3984 3981 4033 4043 3971 1 2 4029 AO222 $T=862420 860720 0 0 $X=862420 $Y=860340
X2724 4057 3984 3981 4042 4032 3971 1 2 4020 AO222 $T=869240 820400 0 180 $X=863040 $Y=814980
X2725 4056 3984 3981 4053 4072 3971 1 2 4046 AO222 $T=869240 800240 0 0 $X=869240 $Y=799860
X2726 4128 3984 3981 4117 4111 3971 1 2 4106 AO222 $T=888460 810320 1 180 $X=882260 $Y=809940
X2727 4105 3984 3981 4122 4114 3971 1 2 4098 AO222 $T=883500 870800 1 0 $X=883500 $Y=865380
X2728 4169 3984 3981 4178 4172 3971 1 2 4161 AO222 $T=905820 810320 1 180 $X=899620 $Y=809940
X2729 4171 3984 3981 4163 4185 3971 1 2 4193 AO222 $T=900240 870800 1 0 $X=900240 $Y=865380
X2730 4217 3984 3981 4205 4200 3971 1 2 4194 AO222 $T=912020 810320 0 180 $X=905820 $Y=804900
X2731 4246 3984 3981 868 4187 3971 1 2 4225 AO222 $T=921320 860720 1 180 $X=915120 $Y=860340
X2732 4297 3984 3981 4270 4262 3971 1 2 4255 AO222 $T=931240 810320 1 180 $X=925040 $Y=809940
X2733 4293 3984 3981 4282 4275 3971 1 2 4257 AO222 $T=934340 860720 0 180 $X=928140 $Y=855300
X2734 4398 3984 3981 4417 4409 3971 1 2 4366 AO222 $T=970920 820400 0 180 $X=964720 $Y=814980
X2735 4423 3984 3981 4383 4379 3971 1 2 4413 AO222 $T=973400 870800 0 180 $X=967200 $Y=865380
X2736 4441 3984 3981 4445 4451 3971 1 2 4465 AO222 $T=974640 820400 0 0 $X=974640 $Y=820020
X2737 4460 3984 3981 4454 4449 3971 1 2 4444 AO222 $T=982080 870800 0 180 $X=975880 $Y=865380
X2738 928 3984 3981 4484 4488 3971 1 2 4509 AO222 $T=988280 870800 1 0 $X=988280 $Y=865380
X2739 4536 3984 3981 4527 4525 3971 1 2 4512 AO222 $T=1009360 820400 1 180 $X=1003160 $Y=820020
X2740 4554 3984 3981 4535 4537 3971 1 2 4528 AO222 $T=1016800 870800 1 180 $X=1010600 $Y=870420
X2741 4538 3984 3981 4552 4555 3971 1 2 4564 AO222 $T=1011220 820400 0 0 $X=1011220 $Y=820020
X2742 4593 3984 3981 4603 4611 3971 1 2 4582 AO222 $T=1029820 820400 0 0 $X=1029820 $Y=820020
X2743 4637 3984 3981 4618 4596 3971 1 2 4612 AO222 $T=1041600 870800 1 180 $X=1035400 $Y=870420
X2744 4642 3984 3981 4668 4655 3971 1 2 4648 AO222 $T=1053380 810320 1 180 $X=1047180 $Y=809940
X2745 971 3984 3981 4688 4697 3971 1 2 4665 AO222 $T=1058340 870800 0 0 $X=1058340 $Y=870420
X2746 976 3984 3981 4717 975 3971 1 2 4705 AO222 $T=1073220 880880 0 180 $X=1067020 $Y=875460
X2747 4699 3984 3981 4719 4725 3971 1 2 4687 AO222 $T=1068260 810320 0 0 $X=1068260 $Y=809940
X2748 4768 3984 3981 4748 4741 3971 1 2 4720 AO222 $T=1080660 830480 0 180 $X=1074460 $Y=825060
X2749 4770 3984 3981 4756 4753 3971 1 2 4739 AO222 $T=1082520 810320 1 180 $X=1076320 $Y=809940
X2750 981 3984 3981 4758 978 3971 1 2 4747 AO222 $T=1082520 880880 0 180 $X=1076320 $Y=875460
X2751 177 1 1750 1714 2 1753 ND3 $T=376960 709520 1 0 $X=376960 $Y=704100
X2752 1823 1 1798 1813 2 1803 ND3 $T=392460 749840 1 180 $X=389980 $Y=749460
X2753 2248 1 2251 2254 2 2244 ND3 $T=473680 759920 0 0 $X=473680 $Y=759540
X2754 2372 1 2398 2400 2 2377 ND3 $T=506540 810320 1 0 $X=506540 $Y=804900
X2755 302 1 301 2444 2 295 ND3 $T=518320 699440 1 180 $X=515840 $Y=699060
X2756 322 1 319 2473 2 314 ND3 $T=527000 719600 1 180 $X=524520 $Y=719220
X2757 2484 1 321 2487 2 314 ND3 $T=527620 709520 0 180 $X=525140 $Y=704100
X2758 330 1 2484 2493 2 2474 ND3 $T=529480 739760 1 180 $X=527000 $Y=739380
X2759 328 1 303 2491 2 2484 ND3 $T=527620 709520 1 0 $X=527620 $Y=704100
X2760 330 1 2508 2463 2 350 ND3 $T=530720 719600 0 0 $X=530720 $Y=719220
X2761 2522 1 319 2511 2 314 ND3 $T=534440 709520 1 180 $X=531960 $Y=709140
X2762 2519 1 329 349 2 347 ND3 $T=534440 729680 0 180 $X=531960 $Y=724260
X2763 347 1 360 2535 2 315 ND3 $T=538160 729680 1 180 $X=535680 $Y=729300
X2764 2510 1 347 2533 2 361 ND3 $T=536300 699440 0 0 $X=536300 $Y=699060
X2765 2531 1 358 286 2 2541 ND3 $T=536920 719600 1 0 $X=536920 $Y=714180
X2766 313 1 360 2544 2 362 ND3 $T=538780 729680 0 0 $X=538780 $Y=729300
X2767 2484 1 307 2576 2 317 ND3 $T=546840 739760 0 0 $X=546840 $Y=739380
X2768 2579 1 328 2595 2 310 ND3 $T=548700 699440 0 0 $X=548700 $Y=699060
X2769 302 1 303 2605 2 2607 ND3 $T=550560 749840 1 0 $X=550560 $Y=744420
X2770 2466 1 2607 2624 2 2562 ND3 $T=555520 729680 0 0 $X=555520 $Y=729300
X2771 2549 1 313 2627 2 400 ND3 $T=556140 709520 0 0 $X=556140 $Y=709140
X2772 2630 1 402 404 2 2640 ND3 $T=558620 709520 0 0 $X=558620 $Y=709140
X2773 2488 1 2499 2639 2 2645 ND3 $T=559240 739760 1 0 $X=559240 $Y=734340
X2774 2672 1 2488 2653 2 2592 ND3 $T=564200 749840 1 180 $X=561720 $Y=749460
X2775 2651 1 389 2649 2 2565 ND3 $T=562340 739760 1 0 $X=562340 $Y=734340
X2776 2674 1 429 2693 2 437 ND3 $T=569160 739760 1 0 $X=569160 $Y=734340
X2777 436 1 301 439 2 426 ND3 $T=571020 699440 0 0 $X=571020 $Y=699060
X2778 446 1 2711 2547 2 450 ND3 $T=574120 699440 0 0 $X=574120 $Y=699060
X2779 313 1 360 2712 2 315 ND3 $T=574120 719600 0 0 $X=574120 $Y=719220
X2780 436 1 471 2659 2 313 ND3 $T=579080 729680 1 180 $X=576600 $Y=729300
X2781 2721 1 2717 2350 2 461 ND3 $T=577220 709520 0 0 $X=577220 $Y=709140
X2782 484 1 2741 465 2 2726 ND3 $T=582180 759920 0 180 $X=579700 $Y=754500
X2783 2508 1 315 2757 2 397 ND3 $T=583420 739760 1 0 $X=583420 $Y=734340
X2784 2744 1 482 477 2 458 ND3 $T=585900 699440 0 0 $X=585900 $Y=699060
X2785 475 1 397 2752 2 2735 ND3 $T=586520 729680 0 0 $X=586520 $Y=729300
X2786 2768 1 2726 2778 2 484 ND3 $T=586520 759920 1 0 $X=586520 $Y=754500
X2787 2764 1 483 2781 2 2674 ND3 $T=590240 739760 1 180 $X=587760 $Y=739380
X2788 2797 1 320 2791 2 360 ND3 $T=593340 719600 1 180 $X=590860 $Y=719220
X2789 2817 1 424 2794 2 2761 ND3 $T=595200 729680 0 180 $X=592720 $Y=724260
X2790 504 1 502 2636 2 2828 ND3 $T=599540 729680 1 180 $X=597060 $Y=729300
X2791 2835 1 2839 2842 2 2565 ND3 $T=601400 739760 1 180 $X=598920 $Y=739380
X2792 2883 1 2879 2429 2 518 ND3 $T=608840 709520 0 180 $X=606360 $Y=704100
X2793 469 1 322 2897 2 2839 ND3 $T=610080 719600 0 0 $X=610080 $Y=719220
X2794 2901 1 458 539 2 2869 ND3 $T=613180 749840 1 0 $X=613180 $Y=744420
X2795 475 1 362 2912 2 436 ND3 $T=616280 739760 1 180 $X=613800 $Y=739380
X2796 437 1 342 2924 2 436 ND3 $T=615660 719600 0 0 $X=615660 $Y=719220
X2797 2925 1 512 2932 2 472 ND3 $T=620620 729680 0 0 $X=620620 $Y=729300
X2798 2927 1 2960 2401 2 2974 ND3 $T=628680 709520 1 0 $X=628680 $Y=704100
X2799 2980 1 301 2988 2 342 ND3 $T=631780 719600 1 180 $X=629300 $Y=719220
X2800 2985 1 2978 2748 2 565 ND3 $T=633640 739760 0 180 $X=631160 $Y=734340
X2801 475 1 315 2953 2 350 ND3 $T=631160 749840 1 0 $X=631160 $Y=744420
X2802 2669 1 3013 3016 2 3020 ND3 $T=639220 719600 0 0 $X=639220 $Y=719220
X2803 3120 1 3115 3047 2 3110 ND3 $T=662780 780080 0 180 $X=660300 $Y=774660
X2804 3098 1 3135 3191 2 3136 ND3 $T=683860 790160 0 180 $X=681380 $Y=784740
X2805 3262 1 3269 3054 2 3277 ND3 $T=688200 749840 0 0 $X=688200 $Y=749460
X2806 3125 1 3130 3136 2 3273 ND3 $T=688820 770000 1 0 $X=688820 $Y=764580
X2807 3210 1 3276 3195 2 3281 ND3 $T=689440 719600 0 0 $X=689440 $Y=719220
X2808 3223 1 3124 3297 2 3273 ND3 $T=691300 759920 0 0 $X=691300 $Y=759540
X2809 3261 1 3286 3194 2 3293 ND3 $T=692540 719600 0 0 $X=692540 $Y=719220
X2810 3301 1 3306 3288 2 3311 ND3 $T=695640 719600 1 0 $X=695640 $Y=714180
X2811 3312 1 3290 3128 2 3322 ND3 $T=697500 749840 1 0 $X=697500 $Y=744420
X2812 3360 1 3367 3166 2 3382 ND3 $T=706180 749840 0 0 $X=706180 $Y=749460
X2813 3376 1 3383 3156 2 3397 ND3 $T=708040 759920 1 0 $X=708040 $Y=754500
X2814 3401 1 3396 641 2 3384 ND3 $T=711760 719600 1 180 $X=709280 $Y=719220
X2815 3424 1 3428 650 2 3435 ND3 $T=715480 719600 0 0 $X=715480 $Y=719220
X2816 3387 1 3430 3445 2 3427 ND3 $T=715480 800240 0 0 $X=715480 $Y=799860
X2817 3471 1 3395 3453 2 3368 ND3 $T=722920 810320 1 180 $X=720440 $Y=809940
X2818 3468 1 3456 617 2 3459 ND3 $T=724160 739760 0 180 $X=721680 $Y=734340
X2819 3431 1 3479 3150 2 3487 ND3 $T=724780 759920 1 0 $X=724780 $Y=754500
X2820 3481 1 3490 657 2 3496 ND3 $T=726640 719600 0 0 $X=726640 $Y=719220
X2821 3492 1 3495 659 2 3506 ND3 $T=728500 749840 1 0 $X=728500 $Y=744420
X2822 3519 1 3522 663 2 3512 ND3 $T=734080 749840 0 180 $X=731600 $Y=744420
X2823 3515 1 3524 3520 2 3534 ND3 $T=733460 729680 1 0 $X=733460 $Y=724260
X2824 3527 1 3565 3568 2 3538 ND3 $T=740280 719600 1 0 $X=740280 $Y=714180
X2825 3569 1 3571 667 2 3576 ND3 $T=741520 749840 0 0 $X=741520 $Y=749460
X2826 669 1 2937 3563 2 665 ND3 $T=745240 850640 0 0 $X=745240 $Y=850260
X2827 3588 1 3593 3597 2 3602 ND3 $T=747100 719600 0 0 $X=747100 $Y=719220
X2828 3591 1 3598 676 2 3610 ND3 $T=748960 739760 1 0 $X=748960 $Y=734340
X2829 3648 1 3640 685 2 3630 ND3 $T=757640 749840 1 180 $X=755160 $Y=749460
X2830 3635 1 3622 3642 2 3645 ND3 $T=755780 719600 0 0 $X=755780 $Y=719220
X2831 3647 1 3653 688 2 3659 ND3 $T=758880 759920 1 0 $X=758880 $Y=754500
X2832 3675 1 3691 3692 2 3711 ND3 $T=767560 719600 0 0 $X=767560 $Y=719220
X2833 3693 1 3705 3720 2 3707 ND3 $T=770660 719600 0 0 $X=770660 $Y=719220
X2834 3592 1 712 3634 2 689 ND3 $T=772520 880880 1 0 $X=772520 $Y=875460
X2835 782 1 3881 3918 2 3940 ND3 $T=825220 749840 1 0 $X=825220 $Y=744420
X2836 785 1 3925 3930 2 3935 ND3 $T=827080 709520 0 0 $X=827080 $Y=709140
X2837 787 1 3905 3936 2 3950 ND3 $T=828940 729680 0 0 $X=828940 $Y=729300
X2838 789 1 3917 3897 2 3947 ND3 $T=830800 699440 0 0 $X=830800 $Y=699060
X2839 3946 1 3949 3901 2 3951 ND3 $T=833900 719600 0 0 $X=833900 $Y=719220
X2840 801 1 3982 3985 2 3990 ND3 $T=845060 749840 0 0 $X=845060 $Y=749460
X2841 4049 1 4035 4045 2 4034 ND3 $T=867380 719600 0 0 $X=867380 $Y=719220
X2842 830 1 4103 4087 2 4110 ND3 $T=881020 749840 0 0 $X=881020 $Y=749460
X2843 4113 1 4069 4067 2 4102 ND3 $T=884120 719600 1 180 $X=881640 $Y=719220
X2844 831 1 4076 4077 2 4100 ND3 $T=882880 729680 0 0 $X=882880 $Y=729300
X2845 848 1 4152 4109 2 4145 ND3 $T=897140 749840 0 180 $X=894660 $Y=744420
X2846 4144 1 4155 4156 2 4150 ND3 $T=895900 719600 0 0 $X=895900 $Y=719220
X2847 861 1 4211 4203 2 4220 ND3 $T=909540 749840 1 0 $X=909540 $Y=744420
X2848 4234 1 4202 4235 2 4212 ND3 $T=915740 729680 1 0 $X=915740 $Y=724260
X2849 874 1 4264 4245 2 4284 ND3 $T=928140 709520 1 0 $X=928140 $Y=704100
X2850 877 1 4272 4260 2 4289 ND3 $T=928140 729680 0 0 $X=928140 $Y=729300
X2851 882 1 4276 4288 2 4294 ND3 $T=938060 739760 0 180 $X=935580 $Y=734340
X2852 910 1 4402 4418 2 4422 ND3 $T=967820 709520 1 0 $X=967820 $Y=704100
X2853 912 1 4421 4420 2 915 ND3 $T=969060 699440 0 0 $X=969060 $Y=699060
X2854 4436 1 4456 4466 2 4440 ND3 $T=978980 739760 0 0 $X=978980 $Y=739380
X2855 4504 1 4495 4506 2 4490 ND3 $T=1000680 749840 0 180 $X=998200 $Y=744420
X2856 4574 1 4565 4479 2 4544 ND3 $T=1018660 749840 0 180 $X=1016180 $Y=744420
X2857 4614 1 4626 4617 2 4616 ND3 $T=1037880 749840 1 180 $X=1035400 $Y=749460
X2858 4682 1 4684 4662 2 4658 ND3 $T=1057100 759920 0 180 $X=1054620 $Y=754500
X2859 4732 1 4731 4723 2 4709 ND3 $T=1073840 749840 1 180 $X=1071360 $Y=749460
X2860 4737 1 4740 4745 2 4752 ND3 $T=1075080 749840 0 0 $X=1075080 $Y=749460
X2861 979 1 4726 4735 2 977 ND3 $T=1078800 699440 1 180 $X=1076320 $Y=699060
X2862 2464 320 317 2 2439 1 316 AN4B1S $T=528240 699440 1 180 $X=523900 $Y=699060
X2863 2474 322 2488 2 325 1 2489 AN4B1S $T=530100 749840 0 180 $X=525760 $Y=744420
X2864 295 320 314 2 2458 1 2482 AN4B1S $T=530720 729680 1 180 $X=526380 $Y=729300
X2865 2549 2508 2474 2 2535 1 2525 AN4B1S $T=541260 739760 1 180 $X=536920 $Y=739380
X2866 2549 314 329 2 2424 1 2538 AN4B1S $T=542500 729680 0 180 $X=538160 $Y=724260
X2867 2565 347 2562 2 2544 1 2553 AN4B1S $T=545600 739760 0 180 $X=541260 $Y=734340
X2868 398 2549 351 2 391 1 2586 AN4B1S $T=558000 729680 0 180 $X=553660 $Y=724260
X2869 2584 2616 2621 2 2622 1 394 AN4B1S $T=554280 739760 0 0 $X=554280 $Y=739380
X2870 361 351 2562 2 2650 1 2662 AN4B1S $T=559240 719600 0 0 $X=559240 $Y=719220
X2871 405 362 2592 2 2650 1 2676 AN4B1S $T=563580 729680 1 0 $X=563580 $Y=724260
X2872 389 2592 322 2 2671 1 2667 AN4B1S $T=564200 739760 0 0 $X=564200 $Y=739380
X2873 350 360 329 2 2649 1 2680 AN4B1S $T=572260 729680 0 180 $X=567920 $Y=724260
X2874 2737 2646 2723 2 2702 1 455 AN4B1S $T=580940 739760 1 180 $X=576600 $Y=739380
X2875 350 2735 353 2 2722 1 2732 AN4B1S $T=582180 719600 1 180 $X=577840 $Y=719220
X2876 322 472 350 2 2739 1 2559 AN4B1S $T=584040 749840 0 180 $X=579700 $Y=744420
X2877 2740 2674 437 2 385 1 2792 AN4B1S $T=582180 739760 0 0 $X=582180 $Y=739380
X2878 2780 2767 2760 2 2753 1 463 AN4B1S $T=587760 709520 0 180 $X=583420 $Y=704100
X2879 2764 2798 2811 2 496 1 2516 AN4B1S $T=591480 749840 0 0 $X=591480 $Y=749460
X2880 2713 2764 437 2 2542 1 2827 AN4B1S $T=591480 759920 0 0 $X=591480 $Y=759540
X2881 494 2741 505 2 2854 1 2730 AN4B1S $T=600160 719600 0 0 $X=600160 $Y=719220
X2882 512 2741 2811 2 2609 1 2846 AN4B1S $T=605740 749840 1 180 $X=601400 $Y=749460
X2883 485 350 512 2 2852 1 2777 AN4B1S $T=602640 749840 1 0 $X=602640 $Y=744420
X2884 482 2847 2869 2 2801 1 2861 AN4B1S $T=603260 759920 1 0 $X=603260 $Y=754500
X2885 2859 2840 2831 2 517 1 2721 AN4B1S $T=603880 709520 0 0 $X=603880 $Y=709140
X2886 535 2902 2851 2 2895 1 2883 AN4B1S $T=614420 709520 0 180 $X=610080 $Y=704100
X2887 2741 458 485 2 2480 1 2891 AN4B1S $T=614420 749840 1 180 $X=610080 $Y=749460
X2888 2674 2817 423 2 417 1 543 AN4B1S $T=614420 729680 0 0 $X=614420 $Y=729300
X2889 2886 538 2718 2 541 1 2927 AN4B1S $T=615040 709520 0 0 $X=615040 $Y=709140
X2890 512 315 483 2 2593 1 2933 AN4B1S $T=621240 739760 1 0 $X=621240 $Y=734340
X2891 482 485 2945 2 2696 1 2938 AN4B1S $T=623100 759920 1 0 $X=623100 $Y=754500
X2892 482 475 2869 2 454 1 2970 AN4B1S $T=624960 749840 1 0 $X=624960 $Y=744420
X2893 475 2817 2954 2 2609 1 2947 AN4B1S $T=625580 739760 1 0 $X=625580 $Y=734340
X2894 2954 342 475 2 2920 1 2942 AN4B1S $T=631780 729680 0 180 $X=627440 $Y=724260
X2895 2529 576 3000 2 2703 1 2985 AN4B1S $T=634880 739760 1 0 $X=634880 $Y=734340
X2896 3015 3011 3009 2 2512 1 2960 AN4B1S $T=641080 709520 0 180 $X=636740 $Y=704100
X2897 3855 3885 3887 2 3890 1 3732 AN4B1S $T=820260 780080 0 0 $X=820260 $Y=779700
X2898 3868 3900 3899 2 3908 1 3733 AN4B1S $T=823360 840560 1 0 $X=823360 $Y=835140
X2899 3875 3902 3906 2 3913 1 3756 AN4B1S $T=823980 810320 0 0 $X=823980 $Y=809940
X2900 3872 3903 3907 2 3915 1 3744 AN4B1S $T=823980 830480 0 0 $X=823980 $Y=830100
X2901 3873 3904 3892 2 3916 1 3776 AN4B1S $T=823980 850640 1 0 $X=823980 $Y=845220
X2902 3871 3911 3912 2 3920 1 3755 AN4B1S $T=824600 800240 0 0 $X=824600 $Y=799860
X2903 4051 4037 4026 2 4029 1 4017 AN4B1S $T=867380 850640 0 180 $X=863040 $Y=845220
X2904 4065 4058 4047 2 4020 1 3921 AN4B1S $T=869240 830480 0 180 $X=864900 $Y=825060
X2905 4064 4059 4055 2 4046 1 4039 AN4B1S $T=869860 790160 1 180 $X=865520 $Y=789780
X2906 4121 4104 4088 2 4098 1 3882 AN4B1S $T=884120 850640 0 180 $X=879780 $Y=845220
X2907 4137 4129 4116 2 4106 1 4028 AN4B1S $T=889700 800240 0 180 $X=885360 $Y=794820
X2908 4175 4168 4157 2 4161 1 4143 AN4B1S $T=901480 800240 0 180 $X=897140 $Y=794820
X2909 4183 4179 4190 2 4193 1 4199 AN4B1S $T=903340 850640 1 0 $X=903340 $Y=845220
X2910 4216 4210 4207 2 4194 1 4166 AN4B1S $T=912020 800240 0 180 $X=907680 $Y=794820
X2911 4236 4229 4227 2 4225 1 4081 AN4B1S $T=916360 850640 0 180 $X=912020 $Y=845220
X2912 4247 4250 4254 2 4257 1 4261 AN4B1S $T=922560 840560 1 0 $X=922560 $Y=835140
X2913 4298 4278 4291 2 4255 1 4292 AN4B1S $T=936820 800240 0 180 $X=932480 $Y=794820
X2914 4381 4372 4371 2 4366 1 4342 AN4B1S $T=958520 810320 0 180 $X=954180 $Y=804900
X2915 4438 4411 4426 2 4413 1 4392 AN4B1S $T=974020 830480 1 180 $X=969680 $Y=830100
X2916 4457 4452 4448 2 4444 1 4414 AN4B1S $T=980220 840560 1 180 $X=975880 $Y=840180
X2917 4476 4470 4464 2 4465 1 4463 AN4B1S $T=986420 800240 1 180 $X=982080 $Y=799860
X2918 4501 4507 4508 2 4512 1 4496 AN4B1S $T=996960 800240 1 0 $X=996960 $Y=794820
X2919 4520 4492 4514 2 4509 1 4513 AN4B1S $T=1001920 850640 1 180 $X=997580 $Y=850260
X2920 4539 4533 4529 2 4528 1 4524 AN4B1S $T=1009360 850640 1 180 $X=1005020 $Y=850260
X2921 4553 4568 4571 2 4564 1 4563 AN4B1S $T=1018040 800240 1 0 $X=1018040 $Y=794820
X2922 4591 4587 4584 2 4582 1 4572 AN4B1S $T=1028580 800240 0 180 $X=1024240 $Y=794820
X2923 4624 4600 4615 2 4612 1 4609 AN4B1S $T=1037260 850640 1 180 $X=1032920 $Y=850260
X2924 4667 4656 4653 2 4648 1 4532 AN4B1S $T=1049660 790160 1 180 $X=1045320 $Y=789780
X2925 4672 4673 4659 2 4665 1 4660 AN4B1S $T=1052760 850640 1 180 $X=1048420 $Y=850260
X2926 4679 4683 4685 2 4687 1 4644 AN4B1S $T=1054620 790160 1 0 $X=1054620 $Y=784740
X2927 4695 4702 4704 2 4705 1 4663 AN4B1S $T=1065160 850640 0 0 $X=1065160 $Y=850260
X2928 4707 4713 4712 2 4720 1 4606 AN4B1S $T=1068260 830480 1 0 $X=1068260 $Y=825060
X2929 4763 4744 4738 2 4739 1 4639 AN4B1S $T=1078800 790160 1 180 $X=1074460 $Y=789780
X2930 4721 4749 4750 2 4747 1 4650 AN4B1S $T=1076320 850640 1 0 $X=1076320 $Y=845220
X2931 2968 1 2 2958 BUF1CK $T=629920 800240 0 0 $X=629920 $Y=799860
X2932 2981 1 2 2991 BUF1CK $T=632400 780080 0 0 $X=632400 $Y=779700
X2933 3320 1 2 3329 BUF1CK $T=700600 820400 1 0 $X=700600 $Y=814980
X2934 3536 1 2 3540 BUF1CK $T=735320 780080 0 0 $X=735320 $Y=779700
X2935 3834 1 2 3750 BUF1CK $T=806000 830480 1 0 $X=806000 $Y=825060
X2936 3848 1 2 3844 BUF1CK $T=812200 800240 1 0 $X=812200 $Y=794820
X2937 3852 1 2 3816 BUF1CK $T=813440 810320 1 0 $X=813440 $Y=804900
X2938 3933 1 2 3810 BUF1CK $T=828940 800240 0 0 $X=828940 $Y=799860
X2939 3973 1 2 3867 BUF1CK $T=842580 800240 1 0 $X=842580 $Y=794820
X2940 4107 1 2 3845 BUF1CK $T=881640 830480 0 0 $X=881640 $Y=830100
X2941 4261 1 2 4182 BUF1CK $T=926900 840560 1 0 $X=926900 $Y=835140
X2942 4292 1 2 4267 BUF1CK $T=934340 810320 1 0 $X=934340 $Y=804900
X2943 4463 1 2 4355 BUF1CK $T=982700 800240 1 0 $X=982700 $Y=794820
X2944 4496 1 2 4450 BUF1CK $T=994480 800240 1 0 $X=994480 $Y=794820
X2945 4497 1 2 4478 BUF1CK $T=995100 850640 1 0 $X=995100 $Y=845220
X2946 4521 1 2 4519 BUF1CK $T=1001920 780080 0 0 $X=1001920 $Y=779700
X2947 4524 1 2 4523 BUF1CK $T=1005640 860720 1 0 $X=1005640 $Y=855300
X2948 4557 1 2 4559 BUF1CK $T=1014940 780080 0 0 $X=1014940 $Y=779700
X2949 4621 1 2 4607 BUF1CK $T=1035400 800240 1 0 $X=1035400 $Y=794820
X2950 4622 1 2 4625 BUF1CK $T=1035400 860720 1 0 $X=1035400 $Y=855300
X2951 4628 1 2 4632 BUF1CK $T=1037260 850640 1 0 $X=1037260 $Y=845220
X2952 4644 1 2 4654 BUF1CK $T=1045320 790160 1 0 $X=1045320 $Y=784740
X2953 4646 1 2 4635 BUF1CK $T=1045320 860720 1 0 $X=1045320 $Y=855300
X2954 2738 371 2730 352 2 1 2723 OA22 $T=581560 729680 0 180 $X=577220 $Y=724260
X2955 570 365 574 403 2 1 3009 OA22 $T=633640 699440 0 0 $X=633640 $Y=699060
X2956 562 579 433 2954 2 1 3015 OA22 $T=636120 709520 0 0 $X=636120 $Y=709140
X2957 3621 3627 681 3634 2 1 3652 OA22 $T=753300 870800 0 0 $X=753300 $Y=870420
X2958 682 3627 692 3634 2 1 3678 OA22 $T=760740 870800 0 0 $X=760740 $Y=870420
X2959 684 3621 695 681 2 1 691 OA22 $T=765700 880880 0 180 $X=761360 $Y=875460
X2960 687 3627 701 705 2 1 3699 OA22 $T=765080 870800 1 0 $X=765080 $Y=865380
X2961 703 3627 709 3634 2 1 3706 OA22 $T=766940 880880 1 0 $X=766940 $Y=875460
X2962 696 712 724 705 2 1 3731 OA22 $T=771900 870800 1 0 $X=771900 $Y=865380
X2963 726 712 728 3634 2 1 3753 OA22 $T=776240 870800 0 0 $X=776240 $Y=870420
X2964 857 712 852 705 2 1 4251 OA22 $T=920080 880880 1 0 $X=920080 $Y=875460
X2965 875 712 876 705 2 1 4285 OA22 $T=928140 880880 1 0 $X=928140 $Y=875460
X2966 849 712 879 705 2 1 4305 OA22 $T=934340 880880 1 0 $X=934340 $Y=875460
X2967 902 712 904 705 2 1 906 OA22 $T=956660 880880 1 0 $X=956660 $Y=875460
X2968 948 712 950 705 2 1 4602 OA22 $T=1027960 880880 1 0 $X=1027960 $Y=875460
X2969 2656 294 2699 1 2 2725 294 2742 1013 ICV_6 $T=567300 780080 0 0 $X=567300 $Y=779700
X2970 756 3948 3960 1 2 802 3832 4010 1013 ICV_6 $T=836380 729680 0 0 $X=836380 $Y=729300
X2971 809 3832 4023 1 2 807 3832 4070 1013 ICV_6 $T=853120 749840 1 0 $X=853120 $Y=744420
X2972 807 3850 4018 1 2 809 779 4075 1013 ICV_6 $T=853120 759920 0 0 $X=853120 $Y=759540
X2973 807 779 4066 1 2 809 3944 4091 1013 ICV_6 $T=859940 729680 1 0 $X=859940 $Y=724260
X2974 812 3931 4131 1 2 805 3931 4165 1013 ICV_6 $T=878540 780080 1 0 $X=878540 $Y=774660
X2975 844 3944 4189 1 2 844 3948 4214 1013 ICV_6 $T=894660 729680 1 0 $X=894660 $Y=724260
X2976 844 3832 4198 1 2 858 779 4240 1013 ICV_6 $T=897760 719600 1 0 $X=897760 $Y=714180
X2977 843 3958 4171 1 2 858 3958 4246 1013 ICV_6 $T=906440 870800 0 0 $X=906440 $Y=870420
X2978 844 3931 4258 1 2 867 3853 4302 1013 ICV_6 $T=916360 790160 1 0 $X=916360 $Y=784740
X2979 867 3931 4280 1 2 867 3923 4273 1013 ICV_6 $T=931860 780080 1 0 $X=931860 $Y=774660
X2980 900 923 4547 1 2 900 907 4579 1013 ICV_6 $T=1001920 739760 0 0 $X=1001920 $Y=739380
X2981 900 930 4581 1 2 4569 921 4623 1013 ICV_6 $T=1014320 719600 0 0 $X=1014320 $Y=719220
X2982 356 1 2 2577 INV3CK $T=546220 749840 0 0 $X=546220 $Y=749460
X2983 2600 1 2 2447 INV3CK $T=550560 800240 0 0 $X=550560 $Y=799860
X2984 3026 1 2 3050 INV3CK $T=656580 800240 0 0 $X=656580 $Y=799860
X2985 3999 1 2 4000 INV3CK $T=850020 749840 0 0 $X=850020 $Y=749460
X2986 4112 1 2 4132 INV3CK $T=888460 790160 0 0 $X=888460 $Y=789780
X2987 4130 1 2 4061 INV3CK $T=898380 739760 0 0 $X=898380 $Y=739380
X2988 4180 1 2 4181 INV3CK $T=902720 780080 0 0 $X=902720 $Y=779700
X2989 4206 1 2 4208 INV3CK $T=910780 860720 0 180 $X=907680 $Y=855300
X2990 4237 1 2 4239 INV3CK $T=916360 780080 0 0 $X=916360 $Y=779700
X2991 4252 1 2 4256 INV3CK $T=926280 770000 1 180 $X=923180 $Y=769620
X2992 4315 1 2 4312 INV3CK $T=942400 739760 0 180 $X=939300 $Y=734340
X2993 4308 1 2 4320 INV3CK $T=943640 880880 0 180 $X=940540 $Y=875460
X2994 4290 1 2 4331 INV3CK $T=945500 729680 0 180 $X=942400 $Y=724260
X2995 4332 1 2 4339 INV3CK $T=944260 820400 0 0 $X=944260 $Y=820020
X2996 4324 1 2 4358 INV3CK $T=951700 780080 0 0 $X=951700 $Y=779700
X2997 901 1 2 4370 INV3CK $T=957280 709520 0 180 $X=954180 $Y=704100
X2998 4310 1 2 4376 INV3CK $T=957900 770000 0 180 $X=954800 $Y=764580
X2999 4369 1 2 4388 INV3CK $T=959760 860720 0 0 $X=959760 $Y=860340
X3000 4362 1 2 4397 INV3CK $T=961620 800240 0 0 $X=961620 $Y=799860
X3001 91 1391 1 2 INV6CK $T=297600 840560 0 180 $X=292020 $Y=835140
X3002 248 356 1 2 INV6CK $T=532580 759920 0 0 $X=532580 $Y=759540
X3003 2762 2755 1 2 INV6CK $T=585280 810320 0 180 $X=579700 $Y=804900
X3004 2815 2783 1 2 INV6CK $T=593340 770000 0 0 $X=593340 $Y=769620
X3005 2776 2868 1 2 INV6CK $T=609460 739760 0 180 $X=603880 $Y=734340
X3006 3018 556 1 2 INV6CK $T=641080 780080 0 0 $X=641080 $Y=779700
X3007 4132 790 1 2 INV6CK $T=888460 810320 0 0 $X=888460 $Y=809940
X3008 4239 3853 1 2 INV6CK $T=917600 800240 0 180 $X=912020 $Y=794820
X3009 4170 4226 1 2 INV6CK $T=921940 870800 0 180 $X=916360 $Y=865380
X3010 4256 3923 1 2 INV6CK $T=931240 790160 1 180 $X=925660 $Y=789780
X3011 4181 3931 1 2 INV6CK $T=931240 780080 0 0 $X=931240 $Y=779700
X3012 4358 4364 1 2 INV6CK $T=957900 810320 0 0 $X=957900 $Y=809940
X3013 4388 899 1 2 INV6CK $T=959760 850640 0 0 $X=959760 $Y=850260
X3014 4320 905 1 2 INV6CK $T=960380 870800 0 0 $X=960380 $Y=870420
X3015 4397 4395 1 2 INV6CK $T=980840 800240 0 180 $X=975260 $Y=794820
X3016 304 1 2431 299 298 2422 2 OAI22S $T=518320 729680 0 180 $X=514600 $Y=724260
X3017 365 1 2758 299 2753 2732 2 OAI22S $T=586520 719600 1 180 $X=582800 $Y=719220
X3018 433 1 2804 365 2799 2792 2 OAI22S $T=593960 739760 1 180 $X=590240 $Y=739380
X3019 521 1 2947 352 2706 2938 2 OAI22S $T=627440 729680 1 180 $X=623720 $Y=729300
X3020 3215 1 3135 3244 3236 3196 2 OAI22S $T=688200 780080 0 180 $X=684480 $Y=774660
X3021 3702 1 4074 824 3824 3686 2 OAI22S $T=875440 840560 1 180 $X=871720 $Y=840180
X3022 3702 1 4081 826 4071 3686 2 OAI22S $T=877920 850640 0 180 $X=874200 $Y=845220
X3023 705 1 665 712 4286 665 2 OAI22S $T=934960 870800 0 180 $X=931240 $Y=865380
X3024 705 1 660 712 4295 660 2 OAI22S $T=938680 870800 0 180 $X=934960 $Y=865380
X3025 705 1 656 712 4326 656 2 OAI22S $T=946120 870800 1 180 $X=942400 $Y=870420
X3026 1114 2 1175 1123 1 NR2 $T=248620 830480 0 0 $X=248620 $Y=830100
X3027 1189 2 1133 44 1 NR2 $T=252340 749840 0 0 $X=252340 $Y=749460
X3028 1189 2 1088 44 1 NR2 $T=252340 759920 1 0 $X=252340 $Y=754500
X3029 44 2 1181 1208 1 NR2 $T=256060 739760 0 0 $X=256060 $Y=739380
X3030 1189 2 1311 62 1 NR2 $T=274660 759920 0 0 $X=274660 $Y=759540
X3031 65 2 1324 63 1 NR2 $T=278380 699440 1 180 $X=276520 $Y=699060
X3032 1189 2 1303 62 1 NR2 $T=290160 759920 1 180 $X=288300 $Y=759540
X3033 44 2 1180 1380 1 NR2 $T=291400 749840 1 0 $X=291400 $Y=744420
X3034 62 2 1376 1380 1 NR2 $T=293260 749840 1 0 $X=293260 $Y=744420
X3035 62 2 1377 1208 1 NR2 $T=293260 749840 0 0 $X=293260 $Y=749460
X3036 44 2 1184 87 1 NR2 $T=294500 709520 1 0 $X=294500 $Y=704100
X3037 62 2 1366 87 1 NR2 $T=294500 709520 0 0 $X=294500 $Y=709140
X3038 44 2 1186 89 1 NR2 $T=295120 719600 0 0 $X=295120 $Y=719220
X3039 62 2 1369 93 1 NR2 $T=296360 709520 0 0 $X=296360 $Y=709140
X3040 44 2 1185 92 1 NR2 $T=296360 729680 1 0 $X=296360 $Y=724260
X3041 62 2 1374 92 1 NR2 $T=296360 729680 0 0 $X=296360 $Y=729300
X3042 44 2 1191 94 1 NR2 $T=296360 739760 1 0 $X=296360 $Y=734340
X3043 62 2 1375 94 1 NR2 $T=296360 739760 0 0 $X=296360 $Y=739380
X3044 62 2 88 96 1 NR2 $T=296980 699440 0 0 $X=296980 $Y=699060
X3045 44 2 1172 93 1 NR2 $T=296980 719600 1 0 $X=296980 $Y=714180
X3046 62 2 1370 89 1 NR2 $T=298220 719600 0 0 $X=298220 $Y=719220
X3047 44 2 1156 97 1 NR2 $T=298220 729680 1 0 $X=298220 $Y=724260
X3048 62 2 1373 97 1 NR2 $T=298220 729680 0 0 $X=298220 $Y=729300
X3049 1458 2 1459 1441 1 NR2 $T=313720 830480 0 0 $X=313720 $Y=830100
X3050 1189 2 1626 142 1 NR2 $T=349680 749840 0 0 $X=349680 $Y=749460
X3051 1189 2 1551 142 1 NR2 $T=354640 749840 1 0 $X=354640 $Y=744420
X3052 142 2 162 87 1 NR2 $T=361460 699440 1 180 $X=359600 $Y=699060
X3053 142 2 1676 1208 1 NR2 $T=365180 749840 1 180 $X=363320 $Y=749460
X3054 142 2 1672 92 1 NR2 $T=365180 729680 1 0 $X=365180 $Y=724260
X3055 142 2 1690 1380 1 NR2 $T=365180 749840 1 0 $X=365180 $Y=744420
X3056 142 2 1686 89 1 NR2 $T=368280 699440 0 0 $X=368280 $Y=699060
X3057 142 2 1681 97 1 NR2 $T=368280 719600 0 0 $X=368280 $Y=719220
X3058 142 2 1697 94 1 NR2 $T=370760 739760 0 0 $X=370760 $Y=739380
X3059 1800 2 1821 186 1 NR2 $T=388740 709520 1 0 $X=388740 $Y=704100
X3060 1858 2 1802 1897 1 NR2 $T=405480 709520 0 0 $X=405480 $Y=709140
X3061 1871 2 1875 1886 1 NR2 $T=406100 780080 0 0 $X=406100 $Y=779700
X3062 1905 2 1899 1897 1 NR2 $T=409200 719600 1 180 $X=407340 $Y=719220
X3063 1905 2 1903 1902 1 NR2 $T=409820 739760 0 180 $X=407960 $Y=734340
X3064 1923 2 1921 1907 1 NR2 $T=411060 800240 0 180 $X=409200 $Y=794820
X3065 1905 2 1932 1860 1 NR2 $T=412920 719600 1 0 $X=412920 $Y=714180
X3066 201 2 1946 200 1 NR2 $T=416020 770000 0 180 $X=414160 $Y=764580
X3067 210 2 1935 214 1 NR2 $T=417880 709520 1 0 $X=417880 $Y=704100
X3068 1905 2 1965 1873 1 NR2 $T=419740 729680 1 180 $X=417880 $Y=729300
X3069 201 2 1970 214 1 NR2 $T=417880 770000 0 0 $X=417880 $Y=769620
X3070 1923 2 1963 1929 1 NR2 $T=419740 810320 0 180 $X=417880 $Y=804900
X3071 210 2 1974 216 1 NR2 $T=424700 699440 0 0 $X=424700 $Y=699060
X3072 210 2 1994 217 1 NR2 $T=424700 709520 1 0 $X=424700 $Y=704100
X3073 1923 2 1996 2007 1 NR2 $T=424700 810320 1 0 $X=424700 $Y=804900
X3074 201 2 1982 216 1 NR2 $T=428420 739760 0 180 $X=426560 $Y=734340
X3075 210 2 220 221 1 NR2 $T=427800 709520 1 0 $X=427800 $Y=704100
X3076 201 2 2012 217 1 NR2 $T=430280 739760 0 180 $X=428420 $Y=734340
X3077 210 2 2026 222 1 NR2 $T=429660 709520 1 0 $X=429660 $Y=704100
X3078 201 2 2009 222 1 NR2 $T=429660 729680 1 0 $X=429660 $Y=724260
X3079 201 2 2036 221 1 NR2 $T=429660 729680 0 0 $X=429660 $Y=729300
X3080 201 2 2046 96 1 NR2 $T=433380 770000 1 0 $X=433380 $Y=764580
X3081 210 2 224 96 1 NR2 $T=436480 699440 1 180 $X=434620 $Y=699060
X3082 210 2 2075 87 1 NR2 $T=438340 709520 1 0 $X=438340 $Y=704100
X3083 201 2 2066 87 1 NR2 $T=438340 770000 0 0 $X=438340 $Y=769620
X3084 210 2 230 93 1 NR2 $T=443300 699440 0 0 $X=443300 $Y=699060
X3085 229 2 231 232 1 NR2 $T=443300 870800 0 0 $X=443300 $Y=870420
X3086 201 2 2099 93 1 NR2 $T=447020 770000 0 0 $X=447020 $Y=769620
X3087 201 2 2097 89 1 NR2 $T=450740 770000 0 180 $X=448880 $Y=764580
X3088 201 2 2115 97 1 NR2 $T=450120 770000 0 0 $X=450120 $Y=769620
X3089 229 2 238 239 1 NR2 $T=450120 880880 1 0 $X=450120 $Y=875460
X3090 201 2 2140 92 1 NR2 $T=451980 770000 1 0 $X=451980 $Y=764580
X3091 229 2 245 247 1 NR2 $T=456940 880880 1 0 $X=456940 $Y=875460
X3092 201 2 2159 94 1 NR2 $T=457560 770000 0 0 $X=457560 $Y=769620
X3093 201 2 2160 2197 1 NR2 $T=460660 770000 0 0 $X=460660 $Y=769620
X3094 210 2 2191 2197 1 NR2 $T=463760 699440 0 0 $X=463760 $Y=699060
X3095 201 2 2201 253 1 NR2 $T=467480 770000 0 0 $X=467480 $Y=769620
X3096 210 2 2214 253 1 NR2 $T=468720 709520 1 0 $X=468720 $Y=704100
X3097 229 2 251 2197 1 NR2 $T=471200 699440 1 180 $X=469340 $Y=699060
X3098 257 2 2181 201 1 NR2 $T=472440 790160 1 180 $X=470580 $Y=789780
X3099 257 2 2190 201 1 NR2 $T=473060 780080 1 180 $X=471200 $Y=779700
X3100 257 2 2180 258 1 NR2 $T=472440 729680 0 0 $X=472440 $Y=729300
X3101 257 2 2233 258 1 NR2 $T=476160 709520 0 0 $X=476160 $Y=709140
X3102 2424 2 2422 286 1 NR2 $T=513360 709520 1 180 $X=511500 $Y=709140
X3103 288 2 290 296 1 NR2 $T=512120 699440 0 0 $X=512120 $Y=699060
X3104 286 2 2450 2445 1 NR2 $T=516460 719600 1 0 $X=516460 $Y=714180
X3105 2424 2 2466 2473 1 NR2 $T=522040 729680 1 0 $X=522040 $Y=724260
X3106 2439 2 2499 343 1 NR2 $T=529480 739760 0 0 $X=529480 $Y=739380
X3107 2523 2 2510 2439 1 NR2 $T=535680 709520 0 180 $X=533820 $Y=704100
X3108 338 2 2522 343 1 NR2 $T=535060 709520 0 0 $X=535060 $Y=709140
X3109 2501 2 347 359 1 NR2 $T=536300 729680 1 0 $X=536300 $Y=724260
X3110 2551 2 302 343 1 NR2 $T=541260 749840 1 180 $X=539400 $Y=749460
X3111 367 2 2548 2528 1 NR2 $T=543740 709520 0 180 $X=541880 $Y=704100
X3112 2571 2 2519 2542 1 NR2 $T=543740 749840 1 180 $X=541880 $Y=749460
X3113 359 2 2488 2496 1 NR2 $T=542500 729680 0 0 $X=542500 $Y=729300
X3114 338 2 2592 2534 1 NR2 $T=544360 719600 0 0 $X=544360 $Y=719220
X3115 2593 2 2575 2523 1 NR2 $T=548080 729680 0 180 $X=546220 $Y=724260
X3116 386 2 2583 2542 1 NR2 $T=551180 719600 1 180 $X=549320 $Y=719220
X3117 2534 2 392 2597 1 NR2 $T=551180 719600 1 0 $X=551180 $Y=714180
X3118 2571 2 2484 385 1 NR2 $T=551180 739760 0 0 $X=551180 $Y=739380
X3119 2609 2 2565 385 1 NR2 $T=554280 739760 0 180 $X=552420 $Y=734340
X3120 2496 2 361 393 1 NR2 $T=553040 719600 0 0 $X=553040 $Y=719220
X3121 385 2 2619 2528 1 NR2 $T=553660 709520 1 0 $X=553660 $Y=704100
X3122 395 2 2607 391 1 NR2 $T=556140 749840 0 0 $X=556140 $Y=749460
X3123 2580 2 2549 2641 1 NR2 $T=559240 729680 0 0 $X=559240 $Y=729300
X3124 2551 2 2651 2580 1 NR2 $T=562960 729680 1 180 $X=561100 $Y=729300
X3125 411 2 2655 417 1 NR2 $T=562340 759920 1 0 $X=562340 $Y=754500
X3126 391 2 2664 2593 1 NR2 $T=564820 749840 1 0 $X=564820 $Y=744420
X3127 393 2 2665 2597 1 NR2 $T=567300 759920 0 180 $X=565440 $Y=754500
X3128 393 2 2670 2632 1 NR2 $T=566680 759920 0 0 $X=566680 $Y=759540
X3129 2460 2 2717 2692 1 NR2 $T=569160 699440 0 0 $X=569160 $Y=699060
X3130 2458 2 2691 2695 1 NR2 $T=569780 739760 0 0 $X=569780 $Y=739380
X3131 2641 2 449 343 1 NR2 $T=573500 759920 0 0 $X=573500 $Y=759540
X3132 2705 2 447 413 1 NR2 $T=575980 709520 0 180 $X=574120 $Y=704100
X3133 2709 2 2746 2551 1 NR2 $T=577840 709520 0 180 $X=575980 $Y=704100
X3134 386 2 452 459 1 NR2 $T=576600 759920 1 0 $X=576600 $Y=754500
X3135 386 2 2740 451 1 NR2 $T=580320 719600 1 0 $X=580320 $Y=714180
X3136 2632 2 2726 2747 1 NR2 $T=581560 759920 0 0 $X=581560 $Y=759540
X3137 2542 2 2735 391 1 NR2 $T=585280 729680 1 180 $X=583420 $Y=729300
X3138 2571 2 2645 479 1 NR2 $T=584660 749840 1 0 $X=584660 $Y=744420
X3139 474 2 2774 476 1 NR2 $T=585280 860720 0 0 $X=585280 $Y=860340
X3140 393 2 2713 490 1 NR2 $T=588380 759920 0 0 $X=588380 $Y=759540
X3141 479 2 484 492 1 NR2 $T=589620 699440 0 0 $X=589620 $Y=699060
X3142 488 2 2764 411 1 NR2 $T=590240 759920 1 0 $X=590240 $Y=754500
X3143 492 2 493 2709 1 NR2 $T=592720 699440 0 0 $X=592720 $Y=699060
X3144 2709 2 495 2722 1 NR2 $T=596440 719600 0 180 $X=594580 $Y=714180
X3145 2471 2 398 2709 1 NR2 $T=594580 719600 0 0 $X=594580 $Y=719220
X3146 451 2 499 2820 1 NR2 $T=597060 729680 0 180 $X=595200 $Y=724260
X3147 411 2 482 459 1 NR2 $T=595200 759920 1 0 $X=595200 $Y=754500
X3148 367 2 472 454 1 NR2 $T=595820 699440 0 0 $X=595820 $Y=699060
X3149 417 2 2759 496 1 NR2 $T=597060 739760 0 0 $X=597060 $Y=739380
X3150 395 2 2811 2542 1 NR2 $T=598920 759920 1 180 $X=597060 $Y=759540
X3151 2820 2 2830 2671 1 NR2 $T=598920 770000 0 180 $X=597060 $Y=764580
X3152 343 2 2847 490 1 NR2 $T=598920 759920 1 0 $X=598920 $Y=754500
X3153 496 2 437 492 1 NR2 $T=602640 699440 1 180 $X=600780 $Y=699060
X3154 490 2 2727 496 1 NR2 $T=600780 729680 0 0 $X=600780 $Y=729300
X3155 343 2 2817 454 1 NR2 $T=602020 739760 1 0 $X=602020 $Y=734340
X3156 2696 2 2860 2471 1 NR2 $T=605740 719600 0 180 $X=603880 $Y=714180
X3157 2497 2 2879 524 1 NR2 $T=606980 719600 0 0 $X=606980 $Y=719220
X3158 2571 2 2869 2709 1 NR2 $T=607600 749840 1 0 $X=607600 $Y=744420
X3159 488 2 2839 454 1 NR2 $T=610080 739760 0 0 $X=610080 $Y=739380
X3160 2801 2 2901 459 1 NR2 $T=610700 749840 1 0 $X=610700 $Y=744420
X3161 479 2 532 2480 1 NR2 $T=611940 729680 1 0 $X=611940 $Y=724260
X3162 479 2 2904 393 1 NR2 $T=615660 729680 1 0 $X=615660 $Y=724260
X3163 386 2 2741 417 1 NR2 $T=615660 749840 0 0 $X=615660 $Y=749460
X3164 2593 2 542 544 1 NR2 $T=617520 699440 0 0 $X=617520 $Y=699060
X3165 2709 2 2925 496 1 NR2 $T=619380 739760 0 0 $X=619380 $Y=739380
X3166 395 2 358 2709 1 NR2 $T=621240 759920 0 180 $X=619380 $Y=754500
X3167 479 2 485 490 1 NR2 $T=623100 749840 1 180 $X=621240 $Y=749460
X3168 2609 2 527 393 1 NR2 $T=624960 709520 0 0 $X=624960 $Y=709140
X3169 2937 2 2701 525 1 NR2 $T=626200 759920 0 0 $X=626200 $Y=759540
X3170 386 2 2954 496 1 NR2 $T=628060 729680 0 0 $X=628060 $Y=729300
X3171 386 2 2945 393 1 NR2 $T=628060 749840 0 0 $X=628060 $Y=749460
X3172 393 2 494 451 1 NR2 $T=633020 729680 1 180 $X=631160 $Y=729300
X3173 2953 2 572 2695 1 NR2 $T=633020 739760 1 180 $X=631160 $Y=739380
X3174 2961 2 2978 2993 1 NR2 $T=633020 709520 0 0 $X=633020 $Y=709140
X3175 393 2 568 2897 1 NR2 $T=633020 719600 1 0 $X=633020 $Y=714180
X3176 2696 2 575 2988 1 NR2 $T=633020 729680 1 0 $X=633020 $Y=724260
X3177 2907 2 2980 395 1 NR2 $T=634880 729680 1 180 $X=633020 $Y=729300
X3178 3146 2 3144 2936 1 NR2 $T=664020 830480 0 180 $X=662160 $Y=825060
X3179 3146 2 3149 309 1 NR2 $T=667120 840560 0 180 $X=665260 $Y=835140
X3180 3146 2 3171 3154 1 NR2 $T=668980 830480 0 0 $X=668980 $Y=830100
X3181 3157 2 3172 3154 1 NR2 $T=668980 840560 1 0 $X=668980 $Y=835140
X3182 3151 2 3164 3125 1 NR2 $T=672080 770000 1 180 $X=670220 $Y=769620
X3183 3200 2 3210 3208 1 NR2 $T=677040 729680 0 0 $X=677040 $Y=729300
X3184 3131 2 3205 3223 1 NR2 $T=677660 759920 1 0 $X=677660 $Y=754500
X3185 3143 2 3230 3223 1 NR2 $T=682000 759920 1 0 $X=682000 $Y=754500
X3186 3098 2 3243 3223 1 NR2 $T=684480 759920 1 0 $X=684480 $Y=754500
X3187 3215 2 586 3225 1 NR2 $T=686340 800240 1 180 $X=684480 $Y=799860
X3188 3157 2 3231 3258 1 NR2 $T=684480 850640 1 0 $X=684480 $Y=845220
X3189 3241 2 3261 3268 1 NR2 $T=687580 729680 0 0 $X=687580 $Y=729300
X3190 3271 2 3262 3250 1 NR2 $T=689440 749840 0 180 $X=687580 $Y=744420
X3191 3272 2 3211 3258 1 NR2 $T=689440 850640 0 180 $X=687580 $Y=845220
X3192 3270 2 3279 3259 1 NR2 $T=689440 860720 0 180 $X=687580 $Y=855300
X3193 3223 2 3253 3124 1 NR2 $T=688820 759920 1 0 $X=688820 $Y=754500
X3194 3209 2 3273 3147 1 NR2 $T=688820 770000 0 0 $X=688820 $Y=769620
X3195 3146 2 3275 3258 1 NR2 $T=691300 840560 0 180 $X=689440 $Y=835140
X3196 3272 2 3233 3259 1 NR2 $T=689440 850640 1 0 $X=689440 $Y=845220
X3197 3157 2 3287 3259 1 NR2 $T=694400 840560 1 0 $X=694400 $Y=835140
X3198 3294 2 3301 3295 1 NR2 $T=696880 719600 1 180 $X=695020 $Y=719220
X3199 3146 2 3316 3259 1 NR2 $T=699360 840560 0 180 $X=697500 $Y=835140
X3200 3280 2 3312 3327 1 NR2 $T=698120 739760 0 0 $X=698120 $Y=739380
X3201 3272 2 3333 3351 1 NR2 $T=701220 850640 0 0 $X=701220 $Y=850260
X3202 3157 2 3369 3351 1 NR2 $T=704940 840560 0 0 $X=704940 $Y=840180
X3203 3270 2 3350 3351 1 NR2 $T=704940 860720 0 0 $X=704940 $Y=860340
X3204 3338 2 3360 3361 1 NR2 $T=706180 749840 1 0 $X=706180 $Y=744420
X3205 3374 2 3376 3385 1 NR2 $T=708040 759920 0 0 $X=708040 $Y=759540
X3206 3146 2 3391 3351 1 NR2 $T=709900 840560 1 180 $X=708040 $Y=840180
X3207 3270 2 3371 3388 1 NR2 $T=708040 860720 0 0 $X=708040 $Y=860340
X3208 3389 2 3380 3351 1 NR2 $T=709900 870800 0 180 $X=708040 $Y=865380
X3209 3157 2 3426 3388 1 NR2 $T=709900 840560 0 0 $X=709900 $Y=840180
X3210 3272 2 3409 3388 1 NR2 $T=713000 850640 0 180 $X=711140 $Y=845220
X3211 3346 2 3401 3415 1 NR2 $T=711760 729680 0 0 $X=711760 $Y=729300
X3212 3433 2 3424 3414 1 NR2 $T=716720 729680 0 180 $X=714860 $Y=724260
X3213 3417 2 3431 3429 1 NR2 $T=714860 770000 1 0 $X=714860 $Y=764580
X3214 3319 2 3446 3438 1 NR2 $T=716720 749840 1 0 $X=716720 $Y=744420
X3215 3389 2 3419 3437 1 NR2 $T=716720 870800 1 0 $X=716720 $Y=865380
X3216 3270 2 3434 3437 1 NR2 $T=720440 860720 0 180 $X=718580 $Y=855300
X3217 3389 2 3447 3388 1 NR2 $T=718580 870800 1 0 $X=718580 $Y=865380
X3218 3272 2 3436 3457 1 NR2 $T=719820 850640 1 0 $X=719820 $Y=845220
X3219 3270 2 3413 3457 1 NR2 $T=720440 860720 0 0 $X=720440 $Y=860340
X3220 3146 2 3379 3437 1 NR2 $T=721680 830480 1 0 $X=721680 $Y=825060
X3221 3474 2 3440 3457 1 NR2 $T=723540 870800 0 180 $X=721680 $Y=865380
X3222 3421 2 3481 3466 1 NR2 $T=723540 719600 0 0 $X=723540 $Y=719220
X3223 3450 2 3468 3480 1 NR2 $T=723540 770000 1 0 $X=723540 $Y=764580
X3224 3272 2 3482 3437 1 NR2 $T=725400 850640 1 180 $X=723540 $Y=850260
X3225 3146 2 3465 656 1 NR2 $T=723540 860720 1 0 $X=723540 $Y=855300
X3226 3474 2 3344 3388 1 NR2 $T=726020 870800 1 180 $X=724160 $Y=870420
X3227 3157 2 3478 3437 1 NR2 $T=724780 830480 0 0 $X=724780 $Y=830100
X3228 3157 2 3484 3457 1 NR2 $T=724780 850640 1 0 $X=724780 $Y=845220
X3229 3474 2 3477 3437 1 NR2 $T=726640 860720 1 180 $X=724780 $Y=860340
X3230 3146 2 3489 3388 1 NR2 $T=728500 840560 0 180 $X=726640 $Y=835140
X3231 3146 2 3500 660 1 NR2 $T=726640 860720 1 0 $X=726640 $Y=855300
X3232 3146 2 3491 3457 1 NR2 $T=727260 840560 0 0 $X=727260 $Y=840180
X3233 3497 2 3492 3505 1 NR2 $T=728500 770000 0 0 $X=728500 $Y=769620
X3234 3389 2 3501 3457 1 NR2 $T=730360 860720 1 180 $X=728500 $Y=860340
X3235 3488 2 3515 3514 1 NR2 $T=730360 729680 1 0 $X=730360 $Y=724260
X3236 3379 2 3509 3476 1 NR2 $T=730360 820400 1 0 $X=730360 $Y=814980
X3237 656 2 3523 660 1 NR2 $T=735320 860720 0 180 $X=733460 $Y=855300
X3238 3525 2 3527 3530 1 NR2 $T=734080 719600 0 0 $X=734080 $Y=719220
X3239 3526 2 3519 3531 1 NR2 $T=734080 770000 1 0 $X=734080 $Y=764580
X3240 632 2 3516 656 1 NR2 $T=734080 870800 0 0 $X=734080 $Y=870420
X3241 3535 2 3569 3561 1 NR2 $T=742140 759920 0 0 $X=742140 $Y=759540
X3242 3555 2 3588 3587 1 NR2 $T=745240 719600 0 0 $X=745240 $Y=719220
X3243 3590 2 3591 3594 1 NR2 $T=747720 749840 0 0 $X=747720 $Y=749460
X3244 3629 2 3635 3612 1 NR2 $T=755160 719600 1 180 $X=753300 $Y=719220
X3245 3620 2 3648 3649 1 NR2 $T=757640 759920 0 0 $X=757640 $Y=759540
X3246 3674 2 3618 3671 1 NR2 $T=764460 739760 1 0 $X=764460 $Y=734340
X3247 3665 2 3693 3628 1 NR2 $T=766320 719600 1 0 $X=766320 $Y=714180
X3248 3689 2 3715 3365 1 NR2 $T=771280 749840 0 0 $X=771280 $Y=749460
X3249 3972 2 3969 3865 1 NR2 $T=843820 749840 1 180 $X=841960 $Y=749460
X3250 3869 2 3974 3898 1 NR2 $T=843200 759920 1 0 $X=843200 $Y=754500
X3251 3865 2 3970 3879 1 NR2 $T=843200 770000 1 0 $X=843200 $Y=764580
X3252 3972 2 3983 3993 1 NR2 $T=846300 759920 1 0 $X=846300 $Y=754500
X3253 3993 2 3992 3879 1 NR2 $T=848160 770000 0 180 $X=846300 $Y=764580
X3254 3978 2 3980 3898 1 NR2 $T=848160 759920 1 0 $X=848160 $Y=754500
X3255 4322 2 4259 4334 1 NR2 $T=943640 830480 0 0 $X=943640 $Y=830100
X3256 4328 2 892 4340 1 NR2 $T=943640 850640 0 0 $X=943640 $Y=850260
X3257 4347 2 881 4337 1 NR2 $T=947360 729680 0 180 $X=945500 $Y=724260
X3258 4328 2 841 4336 1 NR2 $T=945500 729680 0 0 $X=945500 $Y=729300
X3259 4340 2 4228 4334 1 NR2 $T=947360 810320 0 180 $X=945500 $Y=804900
X3260 4322 2 4230 4343 1 NR2 $T=945500 830480 0 0 $X=945500 $Y=830100
X3261 4322 2 4160 4328 1 NR2 $T=946120 840560 0 0 $X=946120 $Y=840180
X3262 4328 2 894 4337 1 NR2 $T=946740 719600 0 0 $X=946740 $Y=719220
X3263 4334 2 4141 4336 1 NR2 $T=947360 759920 1 0 $X=947360 $Y=754500
X3264 4334 2 4073 4337 1 NR2 $T=947360 759920 0 0 $X=947360 $Y=759540
X3265 4340 2 4224 4347 1 NR2 $T=947360 820400 0 0 $X=947360 $Y=820020
X3266 4322 2 4184 4347 1 NR2 $T=947360 860720 0 0 $X=947360 $Y=860340
X3267 4343 2 4015 4336 1 NR2 $T=947980 739760 1 0 $X=947980 $Y=734340
X3268 4343 2 4147 4337 1 NR2 $T=947980 749840 1 0 $X=947980 $Y=744420
X3269 4340 2 4092 4343 1 NR2 $T=947980 800240 0 0 $X=947980 $Y=799860
X3270 4347 2 869 4336 1 NR2 $T=948600 729680 0 0 $X=948600 $Y=729300
X3271 3357 3336 2 3213 1 646 AOI12HS $T=708660 800240 1 180 $X=704320 $Y=799860
X3272 3788 712 2 887 1 4313 AOI12HS $T=938060 870800 0 0 $X=938060 $Y=870420
X3273 4365 734 2 889 1 4360 AOI12HS $T=955420 770000 1 180 $X=951080 $Y=769620
X3274 1438 1 2 1465 DELB $T=308760 810320 1 0 $X=308760 $Y=804900
X3275 1445 1 2 1461 DELB $T=310000 780080 0 0 $X=310000 $Y=779700
X3276 1443 1 2 1462 DELB $T=310000 790160 1 0 $X=310000 $Y=784740
X3277 1439 1 2 1466 DELB $T=310620 820400 1 0 $X=310620 $Y=814980
X3278 107 1 2 1473 DELB $T=313100 709520 1 0 $X=313100 $Y=704100
X3279 1407 1 2 1467 DELB $T=313100 820400 0 0 $X=313100 $Y=820020
X3280 1406 1 2 1486 DELB $T=314960 850640 1 0 $X=314960 $Y=845220
X3281 1470 1 2 1492 DELB $T=316200 759920 0 0 $X=316200 $Y=759540
X3282 1411 1 2 1474 DELB $T=316820 800240 1 0 $X=316820 $Y=794820
X3283 1480 1 2 1505 DELB $T=321160 759920 0 0 $X=321160 $Y=759540
X3284 1393 1 2 1494 DELB $T=323020 830480 1 0 $X=323020 $Y=825060
X3285 1512 1 2 1534 DELB $T=324880 780080 0 0 $X=324880 $Y=779700
X3286 1504 1 2 1556 DELB $T=326120 759920 0 0 $X=326120 $Y=759540
X3287 1519 1 2 1618 DELB $T=345340 830480 1 0 $X=345340 $Y=825060
X3288 1507 1 2 1651 DELB $T=350300 800240 0 0 $X=350300 $Y=799860
X3289 1529 1 2 1635 DELB $T=352780 830480 1 0 $X=352780 $Y=825060
X3290 1925 1 2 2062 DELB $T=433380 870800 0 0 $X=433380 $Y=870420
X3291 227 1 2 228 DELB $T=438340 870800 0 0 $X=438340 $Y=870420
X3292 1857 1 2 2128 DELB $T=440820 880880 1 0 $X=440820 $Y=875460
X3293 240 1 2 244 DELB $T=451980 880880 1 0 $X=451980 $Y=875460
X3294 2371 1 2 2391 DELB $T=501580 850640 0 0 $X=501580 $Y=850260
X3295 2395 1 2 2416 DELB $T=507160 850640 1 0 $X=507160 $Y=845220
X3296 2404 1 2 2421 DELB $T=508400 820400 1 0 $X=508400 $Y=814980
X3297 2454 1 2 2475 DELB $T=520800 820400 1 0 $X=520800 $Y=814980
X3298 2490 1 2 2486 DELB $T=528240 840560 0 0 $X=528240 $Y=840180
X3299 2485 1 2 2495 DELB $T=533200 840560 0 0 $X=533200 $Y=840180
X3300 2520 1 2 2539 DELB $T=533820 820400 0 0 $X=533820 $Y=820020
X3301 2415 1 2 2537 DELB $T=535060 830480 1 0 $X=535060 $Y=825060
X3302 2411 1 2 2560 DELB $T=538160 840560 0 0 $X=538160 $Y=840180
X3303 2506 1 2 2556 DELB $T=540640 800240 0 0 $X=540640 $Y=799860
X3304 2521 1 2 2573 DELB $T=543120 840560 0 0 $X=543120 $Y=840180
X3305 2570 1 2 2588 DELB $T=546220 790160 0 0 $X=546220 $Y=789780
X3306 2432 1 2 2608 DELB $T=548080 840560 0 0 $X=548080 $Y=840180
X3307 2433 1 2 2610 DELB $T=553040 840560 0 0 $X=553040 $Y=840180
X3308 2707 1 2 2756 DELB $T=578460 850640 1 0 $X=578460 $Y=845220
X3309 2734 1 2 2779 DELB $T=588380 840560 1 0 $X=588380 $Y=835140
X3310 2810 1 2 2836 DELB $T=593340 870800 1 0 $X=593340 $Y=865380
X3311 2822 1 2 2834 DELB $T=595200 840560 0 0 $X=595200 $Y=840180
X3312 2769 1 2 474 DELB $T=595820 860720 0 0 $X=595820 $Y=860340
X3313 2796 1 2 2872 DELB $T=597060 830480 1 0 $X=597060 $Y=825060
X3314 2838 1 2 2826 DELB $T=605740 870800 0 0 $X=605740 $Y=870420
X3315 2876 1 2 2867 DELB $T=607600 840560 1 0 $X=607600 $Y=835140
X3316 2935 1 2 553 DELB $T=623100 860720 1 0 $X=623100 $Y=855300
X3317 2930 1 2 2946 DELB $T=624960 820400 1 0 $X=624960 $Y=814980
X3318 2959 1 2 2979 DELB $T=628060 850640 0 0 $X=628060 $Y=850260
X3319 2964 1 2 2976 DELB $T=629920 759920 1 0 $X=629920 $Y=754500
X3320 3006 1 2 3007 DELB $T=637360 810320 0 0 $X=637360 $Y=809940
X3321 3024 1 2 3045 DELB $T=641700 830480 0 0 $X=641700 $Y=830100
X3322 3066 1 2 3033 DELB $T=650380 719600 1 0 $X=650380 $Y=714180
X3323 3070 1 2 3046 DELB $T=650380 850640 0 0 $X=650380 $Y=850260
X3324 3089 1 2 3076 DELB $T=655340 729680 1 0 $X=655340 $Y=724260
X3325 3090 1 2 3093 DELB $T=657200 719600 0 0 $X=657200 $Y=719220
X3326 3139 1 2 612 DELB $T=665260 870800 1 0 $X=665260 $Y=865380
X3327 3155 1 2 3145 DELB $T=668360 770000 1 0 $X=668360 $Y=764580
X3328 3187 1 2 3199 DELB $T=677040 709520 0 0 $X=677040 $Y=709140
X3329 3207 1 2 3169 DELB $T=678280 759920 0 0 $X=678280 $Y=759540
X3330 3184 1 2 3183 DELB $T=680140 749840 1 0 $X=680140 $Y=744420
X3331 3236 1 2 3170 DELB $T=683860 770000 0 0 $X=683860 $Y=769620
X3332 3214 1 2 3152 DELB $T=684480 790160 0 0 $X=684480 $Y=789780
X3333 3305 1 2 642 DELB $T=696260 870800 0 0 $X=696260 $Y=870420
X3334 3458 1 2 3455 DELB $T=721680 790160 0 0 $X=721680 $Y=789780
X3335 3432 1 2 661 DELB $T=726640 880880 1 0 $X=726640 $Y=875460
X3336 3503 1 2 630 DELB $T=729740 840560 0 0 $X=729740 $Y=840180
X3337 3507 1 2 3529 DELB $T=730360 790160 1 0 $X=730360 $Y=784740
X3338 3548 1 2 3578 DELB $T=738420 840560 0 0 $X=738420 $Y=840180
X3339 3552 1 2 3579 DELB $T=739660 820400 0 0 $X=739660 $Y=820020
X3340 3572 1 2 3550 DELB $T=742140 800240 1 0 $X=742140 $Y=794820
X3341 3580 1 2 3577 DELB $T=744000 840560 1 0 $X=744000 $Y=835140
X3342 3581 1 2 3582 DELB $T=744620 820400 0 0 $X=744620 $Y=820020
X3343 3609 1 2 3595 DELB $T=750820 800240 1 0 $X=750820 $Y=794820
X3344 3632 1 2 3636 DELB $T=755780 820400 0 0 $X=755780 $Y=820020
X3345 3639 1 2 3666 DELB $T=756400 770000 1 0 $X=756400 $Y=764580
X3346 3637 1 2 3644 DELB $T=757020 850640 0 0 $X=757020 $Y=850260
X3347 3657 1 2 700 DELB $T=760740 790160 0 0 $X=760740 $Y=789780
X3348 3585 1 2 3664 DELB $T=760740 820400 0 0 $X=760740 $Y=820020
X3349 3655 1 2 3662 DELB $T=761980 830480 1 0 $X=761980 $Y=825060
X3350 3673 1 2 3685 DELB $T=765700 850640 0 0 $X=765700 $Y=850260
X3351 3619 1 2 3701 DELB $T=766320 770000 1 0 $X=766320 $Y=764580
X3352 3698 1 2 3704 DELB $T=771280 860720 1 0 $X=771280 $Y=855300
X3353 3667 1 2 3758 DELB $T=776240 860720 1 0 $X=776240 $Y=855300
X3354 3752 1 2 746 DELB $T=785540 800240 1 0 $X=785540 $Y=794820
X3355 3811 1 2 3608 DELB $T=798560 709520 1 0 $X=798560 $Y=704100
X3356 3812 1 2 3668 DELB $T=798560 770000 1 0 $X=798560 $Y=764580
X3357 3838 1 2 3849 DELB $T=808480 770000 0 0 $X=808480 $Y=769620
X3358 3822 1 2 3843 DELB $T=810960 860720 1 0 $X=810960 $Y=855300
X3359 4071 1 2 3830 DELB $T=872340 850640 0 0 $X=872340 $Y=850260
X3360 4199 1 2 4074 DELB $T=908300 830480 0 0 $X=908300 $Y=830100
X3361 2948 151 2871 1 2 AN2P $T=622480 840560 0 180 $X=618760 $Y=835140
X3362 3970 3869 3889 1 2 AN2P $T=843200 759920 0 180 $X=839480 $Y=754500
X3363 3970 3978 804 1 2 AN2P $T=844440 739760 0 0 $X=844440 $Y=739380
X3364 3974 3983 3870 1 2 AN2P $T=848160 770000 0 0 $X=848160 $Y=769620
X3365 3980 3969 3934 1 2 AN2P $T=849400 780080 1 0 $X=849400 $Y=774660
X3366 3969 3978 796 1 2 AN2P $T=850020 739760 1 0 $X=850020 $Y=734340
X3367 3980 3992 3937 1 2 AN2P $T=853120 780080 0 0 $X=853120 $Y=779700
X3368 11 2 1 1059 BUF1 $T=226920 729680 1 0 $X=226920 $Y=724260
X3369 59 2 1 1288 BUF1 $T=270940 749840 0 0 $X=270940 $Y=749460
X3370 55 2 1 51 BUF1 $T=270940 860720 0 0 $X=270940 $Y=860340
X3371 111 2 1 1385 BUF1 $T=350300 840560 1 180 $X=347820 $Y=840180
X3372 139 2 1 1632 BUF1 $T=349060 729680 0 0 $X=349060 $Y=729300
X3373 178 2 1 111 BUF1 $T=378820 870800 0 180 $X=376340 $Y=865380
X3374 198 2 1 108 BUF1 $T=412920 840560 0 180 $X=410440 $Y=835140
X3375 198 2 1 195 BUF1 $T=414780 880880 0 180 $X=412300 $Y=875460
X3376 178 2 1 202 BUF1 $T=412920 770000 0 0 $X=412920 $Y=769620
X3377 110 2 1 207 BUF1 $T=416020 840560 0 0 $X=416020 $Y=840180
X3378 154 2 1 1955 BUF1 $T=444540 830480 1 0 $X=444540 $Y=825060
X3379 2169 2 1 1905 BUF1 $T=459420 729680 0 180 $X=456940 $Y=724260
X3380 260 2 1 255 BUF1 $T=473060 709520 0 180 $X=470580 $Y=704100
X3381 266 2 1 210 BUF1 $T=476160 699440 1 180 $X=473680 $Y=699060
X3382 2253 2 1 1916 BUF1 $T=476160 709520 0 180 $X=473680 $Y=704100
X3383 2253 2 1 267 BUF1 $T=476780 870800 0 0 $X=476780 $Y=870420
X3384 269 2 1 264 BUF1 $T=484220 860720 0 180 $X=481740 $Y=855300
X3385 346 2 1 198 BUF1 $T=533200 820400 1 180 $X=530720 $Y=820020
X3386 547 2 1 326 BUF1 $T=621860 820400 0 180 $X=619380 $Y=814980
X3387 3111 2 1 580 BUF1 $T=662160 759920 0 180 $X=659680 $Y=754500
X3388 3332 2 1 3339 BUF1 $T=699360 770000 0 0 $X=699360 $Y=769620
X3389 3254 2 1 3365 BUF1 $T=711140 770000 1 0 $X=711140 $Y=764580
X3390 3339 2 1 3566 BUF1 $T=741520 749840 1 0 $X=741520 $Y=744420
X3391 3296 2 1 3654 BUF1 $T=755780 729680 0 0 $X=755780 $Y=729300
X3392 3627 2 1 712 BUF1 $T=767560 870800 0 0 $X=767560 $Y=870420
X3393 3634 2 1 705 BUF1 $T=772520 870800 0 0 $X=772520 $Y=870420
X3394 763 2 1 3686 BUF1 $T=804140 800240 0 180 $X=801660 $Y=794820
X3395 2889 1 2 534 BUF1S $T=611320 870800 1 0 $X=611320 $Y=865380
X3396 2909 1 2 2914 BUF1S $T=614420 810320 1 0 $X=614420 $Y=804900
X3397 2922 1 2 2926 BUF1S $T=618140 780080 1 0 $X=618140 $Y=774660
X3398 3329 1 2 3345 BUF1S $T=699980 810320 0 0 $X=699980 $Y=809940
X3399 3540 1 2 3511 BUF1S $T=737800 780080 0 0 $X=737800 $Y=779700
X3400 3633 1 2 3696 BUF1S $T=767560 780080 0 0 $X=767560 $Y=779700
X3401 729 1 2 3553 BUF1S $T=778100 709520 1 0 $X=778100 $Y=704100
X3402 3746 1 2 3763 BUF1S $T=781200 810320 0 0 $X=781200 $Y=809940
X3403 3846 1 2 3616 BUF1S $T=812820 719600 0 0 $X=812820 $Y=719220
X3404 3823 1 2 3909 BUF1S $T=829560 830480 1 0 $X=829560 $Y=825060
X3405 3785 1 2 934 BUF1S $T=997580 880880 1 0 $X=997580 $Y=875460
X3406 4522 1 2 4477 BUF1S $T=1002540 780080 1 0 $X=1002540 $Y=774660
X3407 2594 2 1 209 BUF3 $T=553040 770000 0 0 $X=553040 $Y=769620
X3408 2458 389 2 2631 2592 1 OR3B2 $T=560480 749840 0 180 $X=556760 $Y=744420
X3409 2597 2655 2 2654 2644 1 OR3B2 $T=565440 759920 1 180 $X=561720 $Y=759540
X3410 2659 302 2 2658 2674 1 OR3B2 $T=563580 729680 0 0 $X=563580 $Y=729300
X3411 2920 2741 2 2919 423 1 OR3B2 $T=621240 729680 0 180 $X=617520 $Y=724260
X3412 3198 3136 2 3140 3143 1 OR3B2 $T=677660 790160 0 180 $X=673940 $Y=784740
X3413 3213 3357 2 645 3336 1 OR3B2 $T=703080 810320 1 0 $X=703080 $Y=804900
X3414 2463 2 2470 2424 2456 1 NR3 $T=523900 719600 0 180 $X=520800 $Y=714180
X3415 2473 2 2471 2480 2492 1 NR3 $T=524520 729680 1 0 $X=524520 $Y=724260
X3416 2487 2 2471 318 2467 1 NR3 $T=528240 709520 1 180 $X=525140 $Y=709140
X3417 2496 2 338 2501 330 1 NR3 $T=528860 719600 1 0 $X=528860 $Y=714180
X3418 2511 2 2515 2424 2524 1 NR3 $T=532580 719600 1 0 $X=532580 $Y=714180
X3419 2501 2 2534 2542 2531 1 NR3 $T=536920 719600 0 0 $X=536920 $Y=719220
X3420 367 2 2534 2551 2579 1 NR3 $T=547460 709520 1 180 $X=544360 $Y=709140
X3421 2598 2 2632 2515 2644 1 NR3 $T=561100 759920 0 180 $X=558000 $Y=754500
X3422 2696 2 2551 2641 2672 1 NR3 $T=571640 759920 0 180 $X=568540 $Y=754500
X3423 2582 2 442 2706 2711 1 NR3 $T=572260 719600 1 0 $X=572260 $Y=714180
X3424 2542 2 2709 2641 2464 1 NR3 $T=576600 749840 0 180 $X=573500 $Y=744420
X3425 2712 2 451 2654 462 1 NR3 $T=576600 719600 1 0 $X=576600 $Y=714180
X3426 2752 2 2659 2609 2738 1 NR3 $T=583420 739760 0 180 $X=580320 $Y=734340
X3427 2593 2 411 2696 2768 1 NR3 $T=585280 759920 0 0 $X=585280 $Y=759540
X3428 2791 2 479 2722 2684 1 NR3 $T=589620 719600 0 180 $X=586520 $Y=714180
X3429 2757 2 2801 488 2758 1 NR3 $T=590240 739760 1 0 $X=590240 $Y=734340
X3430 2599 2 2806 2799 2828 1 NR3 $T=593340 729680 0 0 $X=593340 $Y=729300
X3431 2801 2 411 2542 498 1 NR3 $T=597060 739760 1 180 $X=593960 $Y=739380
X3432 2820 2 393 2801 2835 1 NR3 $T=600160 749840 1 180 $X=597060 $Y=749460
X3433 387 2 536 2910 2902 1 NR3 $T=613800 699440 0 0 $X=613800 $Y=699060
X3434 2924 2 2609 2920 2918 1 NR3 $T=619380 719600 0 0 $X=619380 $Y=719220
X3435 2627 2 552 2609 2962 1 NR3 $T=626200 719600 0 180 $X=623100 $Y=714180
X3436 559 2 2966 561 2974 1 NR3 $T=628680 699440 0 0 $X=628680 $Y=699060
X3437 3016 2 3035 597 599 1 NR3 $T=647900 709520 0 0 $X=647900 $Y=709140
X3438 3215 2 3130 3135 638 1 NR3 $T=691300 800240 1 0 $X=691300 $Y=794820
X3439 352 2830 1 497 2622 2803 2 OAI112HS $T=597060 770000 0 180 $X=592720 $Y=764580
X3440 3130 3124 1 3118 3062 3098 2 OAI112HS $T=665260 770000 1 180 $X=660920 $Y=769620
X3441 3151 3130 1 3105 3060 3098 2 OAI112HS $T=667120 790160 0 180 $X=662780 $Y=784740
X3442 3151 3130 1 3110 2915 3135 2 OAI112HS $T=672700 790160 0 180 $X=668360 $Y=784740
X3443 3130 3164 1 3136 2934 3131 2 OAI112HS $T=673320 780080 1 180 $X=668980 $Y=779700
X3444 3395 645 1 3353 3321 3345 2 OAI112HS $T=706800 810320 1 180 $X=702460 $Y=809940
X3445 3368 645 1 3352 3238 3349 2 OAI112HS $T=707420 820400 0 180 $X=703080 $Y=814980
X3446 3387 645 1 3408 3366 3386 2 OAI112HS $T=709280 800240 1 0 $X=709280 $Y=794820
X3447 3445 3453 1 3292 3357 3416 2 OAI112HS $T=719200 810320 1 180 $X=714860 $Y=809940
X3448 3427 645 1 3439 3451 3455 2 OAI112HS $T=715480 800240 1 0 $X=715480 $Y=794820
X3449 3430 645 1 3467 3486 3470 2 OAI112HS $T=721680 800240 1 0 $X=721680 $Y=794820
X3450 645 3342 1 3469 3533 3537 2 OAI112HS $T=730980 810320 1 0 $X=730980 $Y=804900
X3451 645 3416 1 3508 3541 3550 2 OAI112HS $T=732220 800240 0 0 $X=732220 $Y=799860
X3452 3471 645 1 3483 3551 3542 2 OAI112HS $T=732840 820400 1 0 $X=732840 $Y=814980
X3453 1754 1721 1737 2 1 1666 XOR3S $T=384400 800240 0 180 $X=373240 $Y=794820
X3454 3688 3696 3716 2 1 3729 XOR3S $T=768180 790160 1 0 $X=768180 $Y=784740
X3455 3747 3696 3739 2 1 3726 XOR3S $T=788020 780080 1 180 $X=776860 $Y=779700
X3456 1168 1204 2 1171 1183 1 1225 FA1 $T=248620 860720 0 0 $X=248620 $Y=860340
X3457 2894 549 2 534 531 1 2956 FA1 $T=610700 880880 1 0 $X=610700 $Y=875460
X3458 2906 2940 2 553 2956 1 2963 FA1 $T=613800 870800 1 0 $X=613800 $Y=865380
X3459 2944 2990 2 537 2955 1 3023 FA1 $T=624340 860720 0 0 $X=624340 $Y=860340
X3460 2983 3032 2 558 3023 1 3053 FA1 $T=633020 850640 0 0 $X=633020 $Y=850260
X3461 3058 585 2 537 594 1 2992 FA1 $T=650380 880880 0 180 $X=634880 $Y=875460
X3462 3005 593 2 558 2992 1 3083 FA1 $T=636740 870800 0 0 $X=636740 $Y=870420
X3463 3038 3085 2 602 3053 1 3133 FA1 $T=644180 860720 0 0 $X=644180 $Y=860340
X3464 3069 3108 2 2984 3079 1 3129 FA1 $T=650380 749840 0 0 $X=650380 $Y=749460
X3465 600 3127 2 3117 3142 1 3134 FA1 $T=654100 709520 0 0 $X=654100 $Y=709140
X3466 3087 610 2 602 3083 1 3173 FA1 $T=654720 870800 0 0 $X=654720 $Y=870420
X3467 607 3150 2 3117 3141 1 615 FA1 $T=657820 709520 1 0 $X=657820 $Y=704100
X3468 608 3174 2 613 3134 1 619 FA1 $T=662780 699440 0 0 $X=662780 $Y=699060
X3469 3097 3166 2 2984 3167 1 3165 FA1 $T=664640 749840 1 0 $X=664640 $Y=744420
X3470 3132 3188 2 611 3133 1 621 FA1 $T=664640 860720 0 0 $X=664640 $Y=860340
X3471 3180 623 2 611 3173 1 3246 FA1 $T=673940 870800 0 0 $X=673940 $Y=870420
X3472 651 657 2 636 3410 1 3504 FA1 $T=716720 699440 0 0 $X=716720 $Y=699060
X3473 658 3520 2 653 3504 1 3586 FA1 $T=726640 709520 1 0 $X=726640 $Y=704100
X3474 680 3573 2 639 677 1 3545 FA1 $T=753300 699440 1 180 $X=737800 $Y=699060
X3475 683 3660 2 637 3545 1 717 FA1 $T=756400 699440 0 0 $X=756400 $Y=699060
X3476 693 3597 2 637 3638 1 3736 FA1 $T=762600 709520 1 0 $X=762600 $Y=704100
X3477 3790 3692 2 3608 3777 1 3728 FA1 $T=791740 719600 1 180 $X=776240 $Y=719220
X3478 3734 3676 2 3616 3728 1 3791 FA1 $T=776860 729680 1 0 $X=776860 $Y=724260
X3479 3809 3766 2 3617 3751 1 3748 FA1 $T=795460 749840 1 180 $X=779960 $Y=749460
X3480 3803 3767 2 3646 3791 1 3751 FA1 $T=796080 729680 1 180 $X=780580 $Y=729300
X3481 3754 3720 2 668 3749 1 3777 FA1 $T=781200 709520 1 0 $X=781200 $Y=704100
X3482 3805 3762 2 3608 753 1 3764 FA1 $T=799800 719600 0 180 $X=784300 $Y=714180
X3483 3804 3798 2 3646 3826 1 3778 FA1 $T=805380 749840 0 180 $X=789880 $Y=744420
X3484 3781 3775 2 3617 3778 1 3795 FA1 $T=789880 759920 1 0 $X=789880 $Y=754500
X3485 3797 3831 2 3616 3764 1 3826 FA1 $T=796080 729680 0 0 $X=796080 $Y=729300
X3486 1384 1387 1392 2 1 XNR2HS $T=293260 820400 1 0 $X=293260 $Y=814980
X3487 1389 1400 1352 2 1 XNR2HS $T=297600 830480 0 0 $X=297600 $Y=830100
X3488 1216 1433 1442 2 1 XNR2HS $T=305660 850640 1 0 $X=305660 $Y=845220
X3489 1430 1441 1418 2 1 XNR2HS $T=312480 850640 0 0 $X=312480 $Y=850260
X3490 1778 1807 1781 2 1 XNR2HS $T=389360 739760 1 0 $X=389360 $Y=734340
X3491 1691 1818 1731 2 1 XNR2HS $T=393080 719600 1 0 $X=393080 $Y=714180
X3492 1884 1877 1868 2 1 XNR2HS $T=406720 800240 1 180 $X=401140 $Y=799860
X3493 3049 3021 3067 2 1 XNR2HS $T=646660 729680 0 0 $X=646660 $Y=729300
X3494 3073 3039 3001 2 1 XNR2HS $T=652860 759920 1 0 $X=652860 $Y=754500
X3495 3178 3175 3161 2 1 XNR2HS $T=674560 729680 0 180 $X=668980 $Y=724260
X3496 3225 3547 3562 2 1 XNR2HS $T=737180 810320 1 0 $X=737180 $Y=804900
X3497 3539 3017 3564 2 1 XNR2HS $T=737180 870800 0 0 $X=737180 $Y=870420
X3498 3225 3567 3575 2 1 XNR2HS $T=739660 800240 0 0 $X=739660 $Y=799860
X3499 665 3564 3592 2 1 XNR2HS $T=744000 870800 0 0 $X=744000 $Y=870420
X3500 3595 3558 3605 2 1 XNR2HS $T=758260 810320 0 180 $X=752680 $Y=804900
X3501 1384 1387 2 1 1475 OR2 $T=315580 840560 1 0 $X=315580 $Y=835140
X3502 1895 1905 2 1 1858 OR2 $T=409820 719600 0 180 $X=407340 $Y=714180
X3503 391 2528 2 1 2617 OR2 $T=553040 709520 0 0 $X=553040 $Y=709140
X3504 393 395 2 1 2641 OR2 $T=571020 759920 0 0 $X=571020 $Y=759540
X3505 488 2650 2 1 2884 OR2 $T=607600 739760 0 0 $X=607600 $Y=739380
X3506 395 2747 2 1 2920 OR2 $T=615660 759920 1 0 $X=615660 $Y=754500
X3507 3595 3558 2 1 3567 OR2 $T=758260 800240 0 180 $X=755780 $Y=794820
X3508 3625 3624 2 1 3674 OR2 $T=770040 729680 1 180 $X=767560 $Y=729300
X3509 1805 1707 1 108 1707 1785 2 MOAI1S $T=389360 850640 1 180 $X=385640 $Y=850260
X3510 288 2491 1 299 2510 2512 2 MOAI1S $T=529480 699440 0 0 $X=529480 $Y=699060
X3511 2557 2493 1 2559 365 363 2 MOAI1S $T=544980 739760 1 180 $X=541260 $Y=739380
X3512 2557 2533 1 2574 365 378 2 MOAI1S $T=544980 699440 0 0 $X=544980 $Y=699060
X3513 2649 288 1 2667 311 2703 2 MOAI1S $T=564820 739760 1 0 $X=564820 $Y=734340
X3514 288 2624 1 428 432 2702 2 MOAI1S $T=567920 729680 0 0 $X=567920 $Y=729300
X3515 443 2794 1 322 352 2806 2 MOAI1S $T=589000 729680 1 0 $X=589000 $Y=724260
X3516 506 407 1 2860 304 515 2 MOAI1S $T=602020 709520 1 0 $X=602020 $Y=704100
X3517 2854 369 1 401 551 2966 2 MOAI1S $T=621860 699440 0 0 $X=621860 $Y=699060
X3518 369 2932 1 2942 521 557 2 MOAI1S $T=622480 719600 0 0 $X=622480 $Y=719220
X3519 2937 555 1 2937 550 2930 2 MOAI1S $T=626200 820400 1 180 $X=622480 $Y=820020
X3520 443 454 1 546 401 2993 2 MOAI1S $T=633020 709520 1 0 $X=633020 $Y=704100
X3521 2937 3017 1 2937 581 3006 2 MOAI1S $T=641700 820400 1 180 $X=637980 $Y=820020
X3522 2937 3037 1 2937 589 3024 2 MOAI1S $T=645420 820400 1 180 $X=641700 $Y=820020
X3523 3164 3189 1 3124 3145 3184 2 MOAI1S $T=677040 770000 0 180 $X=673320 $Y=764580
X3524 3235 2996 1 3136 3212 3208 2 MOAI1S $T=683860 739760 1 180 $X=680140 $Y=739380
X3525 3189 3226 1 3217 3130 3207 2 MOAI1S $T=683860 770000 0 180 $X=680140 $Y=764580
X3526 3235 626 1 3136 3247 3250 2 MOAI1S $T=683860 739760 0 0 $X=683860 $Y=739380
X3527 3254 3084 1 3105 3212 3268 2 MOAI1S $T=689440 729680 0 0 $X=689440 $Y=729300
X3528 3254 3117 1 3105 3298 3295 2 MOAI1S $T=698120 739760 0 180 $X=694400 $Y=734340
X3529 3254 643 1 3105 3247 3327 2 MOAI1S $T=703700 739760 0 180 $X=699980 $Y=734340
X3530 3254 634 1 3105 3355 3361 2 MOAI1S $T=709280 739760 0 180 $X=705560 $Y=734340
X3531 3365 636 1 3105 3373 3385 2 MOAI1S $T=706800 770000 1 0 $X=706800 $Y=764580
X3532 3254 613 1 3105 3402 3415 2 MOAI1S $T=709900 739760 1 0 $X=709900 $Y=734340
X3533 3254 648 1 3105 3363 3414 2 MOAI1S $T=716720 709520 1 180 $X=713000 $Y=709140
X3534 3254 627 1 3105 3302 3466 2 MOAI1S $T=718580 719600 0 0 $X=718580 $Y=719220
X3535 3365 653 1 3105 3411 3429 2 MOAI1S $T=722300 770000 1 180 $X=718580 $Y=769620
X3536 3365 639 1 3105 3309 3480 2 MOAI1S $T=722920 770000 0 0 $X=722920 $Y=769620
X3537 3254 629 1 3105 3317 3514 2 MOAI1S $T=729740 719600 0 0 $X=729740 $Y=719220
X3538 3365 637 1 3105 3303 3505 2 MOAI1S $T=734080 770000 1 180 $X=730360 $Y=769620
X3539 655 3254 1 3105 3337 3530 2 MOAI1S $T=739040 709520 1 180 $X=735320 $Y=709140
X3540 3365 3553 1 3105 3403 3531 2 MOAI1S $T=740280 770000 0 180 $X=736560 $Y=764580
X3541 3365 668 1 3105 3323 3561 2 MOAI1S $T=744620 770000 0 180 $X=740900 $Y=764580
X3542 3254 666 1 3313 3105 3587 2 MOAI1S $T=743380 719600 1 0 $X=743380 $Y=714180
X3543 3222 3553 1 3310 3546 3590 2 MOAI1S $T=744000 749840 0 0 $X=744000 $Y=749460
X3544 3254 670 1 3105 3341 3612 2 MOAI1S $T=747720 709520 0 0 $X=747720 $Y=709140
X3545 3365 3608 1 3105 3347 3594 2 MOAI1S $T=751440 770000 0 180 $X=747720 $Y=764580
X3546 678 3254 1 3372 3105 3628 2 MOAI1S $T=752060 709520 0 0 $X=752060 $Y=709140
X3547 3222 655 1 3310 3518 3629 2 MOAI1S $T=752060 739760 1 0 $X=752060 $Y=734340
X3548 3643 3617 1 3296 3347 3620 2 MOAI1S $T=757020 759920 1 180 $X=753300 $Y=759540
X3549 3365 3616 1 3105 3356 3649 2 MOAI1S $T=761980 770000 1 180 $X=758260 $Y=769620
X3550 690 3643 1 3654 3341 3665 2 MOAI1S $T=765700 719600 0 180 $X=761980 $Y=714180
X3551 713 3743 1 3654 3518 3688 2 MOAI1S $T=783060 749840 0 180 $X=779340 $Y=744420
X3552 3633 3743 1 3654 3546 731 2 MOAI1S $T=783680 739760 1 180 $X=779960 $Y=739380
X3553 2467 311 1 2456 304 2 2449 2460 299 OAI222S $T=525140 709520 0 180 $X=519560 $Y=704100
X3554 2545 305 1 2482 304 2 2492 2497 299 OAI222S $T=533820 739760 0 180 $X=528240 $Y=734340
X3555 2561 371 1 2575 377 2 2583 374 365 OAI222S $T=544360 719600 1 0 $X=544360 $Y=714180
X3556 2538 305 1 2586 299 2 2553 2599 311 OAI222S $T=546220 729680 0 0 $X=546220 $Y=729300
X3557 2541 305 1 2596 371 2 2524 2582 304 OAI222S $T=553040 709520 1 180 $X=547460 $Y=709140
X3558 2665 299 1 2691 433 2 2664 438 352 OAI222S $T=567300 749840 0 0 $X=567300 $Y=749460
X3559 427 313 1 2676 305 2 425 2692 436 OAI222S $T=569160 709520 0 0 $X=569160 $Y=709140
X3560 2827 352 1 2733 464 2 2891 2895 365 OAI222S $T=608840 759920 0 0 $X=608840 $Y=759540
X3561 2969 562 1 2957 427 2 543 2961 464 OAI222S $T=632400 709520 1 180 $X=626820 $Y=709140
X3562 533 501 1 2962 427 2 2969 3035 562 OAI222S $T=646660 709520 1 180 $X=641080 $Y=709140
X3563 3313 3310 1 3289 3302 2 3296 3294 3212 OAI222S $T=699360 729680 1 180 $X=693780 $Y=729300
X3564 3310 3341 1 3289 3317 2 3296 3346 3298 OAI222S $T=704940 729680 1 180 $X=699360 $Y=729300
X3565 3310 3323 1 3289 3309 2 3296 3338 3247 OAI222S $T=706180 749840 0 180 $X=700600 $Y=744420
X3566 3310 3347 1 3289 3303 2 3296 3374 3355 OAI222S $T=701840 759920 0 0 $X=701840 $Y=759540
X3567 3310 3356 1 3289 3403 2 3296 3417 3373 OAI222S $T=716100 759920 1 180 $X=710520 $Y=759540
X3568 3381 3310 1 3289 3313 2 3296 3421 3363 OAI222S $T=719200 729680 1 180 $X=713620 $Y=729300
X3569 3310 3372 1 3289 3337 2 3296 3433 3402 OAI222S $T=719820 739760 0 180 $X=714240 $Y=734340
X3570 3310 3441 1 3289 3323 2 3296 3450 3411 OAI222S $T=722920 759920 1 180 $X=717340 $Y=759540
X3571 3452 3310 1 3289 3341 2 3296 3488 3302 OAI222S $T=729740 729680 0 180 $X=724160 $Y=724260
X3572 3310 3454 1 3289 3347 2 3296 3497 3309 OAI222S $T=732220 759920 1 180 $X=726640 $Y=759540
X3573 3310 3485 1 3289 3356 2 3296 3526 3303 OAI222S $T=733460 759920 0 0 $X=733460 $Y=759540
X3574 3310 3494 1 3289 3441 2 3296 3535 3403 OAI222S $T=740900 759920 0 180 $X=735320 $Y=754500
X3575 3493 3310 1 3381 3289 2 3296 3555 3337 OAI222S $T=742140 729680 0 180 $X=736560 $Y=724260
X3576 3461 3310 1 3289 3372 2 3296 3525 3317 OAI222S $T=743380 729680 1 180 $X=737800 $Y=729300
X3577 3105 3546 1 3715 3560 2 3654 723 3494 OAI222S $T=776240 749840 0 180 $X=770660 $Y=744420
X3578 3518 3105 1 3715 3521 2 3493 3718 3654 OAI222S $T=778720 739760 0 180 $X=773140 $Y=734340
X3579 1858 2 1860 1 186 NR2P $T=403000 709520 0 180 $X=399280 $Y=704100
X3580 1858 2 1873 1 1691 NR2P $T=400520 719600 1 0 $X=400520 $Y=714180
X3581 1914 2 1929 1 1886 NR2P $T=411060 790160 1 180 $X=407340 $Y=789780
X3582 1914 2 1907 1 1871 NR2P $T=409200 790160 1 0 $X=409200 $Y=784740
X3583 3215 2 3225 1 577 NR2P $T=682620 800240 1 180 $X=678900 $Y=799860
X3584 3215 2 3225 1 573 NR2P $T=684480 800240 1 0 $X=684480 $Y=794820
X3585 34 32 1 2 BUF2 $T=241800 709520 0 180 $X=238700 $Y=704100
X3586 121 118 1 2 BUF2 $T=331080 719600 1 0 $X=331080 $Y=714180
X3587 1958 249 1 2 BUF2 $T=461900 810320 0 0 $X=461900 $Y=809940
X3588 2300 203 1 2 BUF2 $T=479880 709520 0 180 $X=476780 $Y=704100
X3589 266 258 1 2 BUF2 $T=482360 709520 1 180 $X=479260 $Y=709140
X3590 2169 272 1 2 BUF2 $T=485460 860720 1 0 $X=485460 $Y=855300
X3591 3323 3297 3309 3252 3303 3257 2 1 3290 OA222S $T=699360 749840 1 180 $X=693780 $Y=749460
X3592 3297 3313 3302 3252 3317 3257 2 1 3286 OA222S $T=702460 719600 1 180 $X=696880 $Y=719220
X3593 3297 3341 3317 3252 3337 3257 2 1 3306 OA222S $T=704940 719600 0 180 $X=699360 $Y=714180
X3594 3373 3339 3356 3282 3347 3328 2 1 3322 OA222S $T=707420 759920 0 180 $X=701840 $Y=754500
X3595 3363 3339 3282 3381 3328 3372 2 1 3311 OA222S $T=711760 729680 0 180 $X=706180 $Y=724260
X3596 3402 3339 3282 3372 3328 3341 2 1 3293 OA222S $T=711760 729680 1 180 $X=706180 $Y=729300
X3597 3297 3372 3337 3252 3313 3257 2 1 3396 OA222S $T=706800 709520 0 0 $X=706800 $Y=709140
X3598 3347 3297 3303 3252 3403 3257 2 1 3367 OA222S $T=714860 749840 1 180 $X=709280 $Y=749460
X3599 3356 3297 3403 3252 3323 3257 2 1 3383 OA222S $T=717340 759920 0 180 $X=711760 $Y=754500
X3600 3411 3339 3441 3282 3356 3328 2 1 3382 OA222S $T=721060 749840 1 180 $X=715480 $Y=749460
X3601 3297 3381 3313 3252 3341 3257 2 1 3428 OA222S $T=722920 709520 1 180 $X=717340 $Y=709140
X3602 3302 3339 3282 3452 3328 3381 2 1 3384 OA222S $T=723540 729680 0 180 $X=717960 $Y=724260
X3603 3309 3339 3454 3282 3441 3328 2 1 3397 OA222S $T=723540 759920 0 180 $X=717960 $Y=754500
X3604 3317 3339 3282 3461 3328 3452 2 1 3435 OA222S $T=725400 729680 1 180 $X=719820 $Y=729300
X3605 3454 3297 3347 3252 3356 3257 2 1 3456 OA222S $T=726640 749840 0 180 $X=721060 $Y=744420
X3606 3441 3297 3323 3252 3347 3257 2 1 3479 OA222S $T=721680 749840 0 0 $X=721680 $Y=749460
X3607 3297 3452 3341 3252 3372 3257 2 1 3490 OA222S $T=723540 719600 1 0 $X=723540 $Y=714180
X3608 3403 3339 3494 3282 3485 3328 2 1 3459 OA222S $T=730360 739760 1 180 $X=724780 $Y=739380
X3609 3337 3339 3282 3493 3328 3461 2 1 3496 OA222S $T=725400 729680 0 0 $X=725400 $Y=729300
X3610 3485 3297 3356 3252 3441 3257 2 1 3495 OA222S $T=733460 749840 1 180 $X=727880 $Y=749460
X3611 3303 3339 3485 3282 3454 3328 2 1 3487 OA222S $T=734080 759920 0 180 $X=728500 $Y=754500
X3612 3297 3461 3372 3252 3381 3257 2 1 3524 OA222S $T=729120 709520 0 0 $X=729120 $Y=709140
X3613 3313 3339 3282 3518 3328 3493 2 1 3534 OA222S $T=730980 739760 1 0 $X=730980 $Y=734340
X3614 3341 3339 3282 3521 3328 3518 2 1 3538 OA222S $T=731600 729680 0 0 $X=731600 $Y=729300
X3615 3494 3297 3441 3252 3454 3257 2 1 3522 OA222S $T=739660 749840 1 180 $X=734080 $Y=749460
X3616 3323 3339 3546 3282 3494 3328 2 1 3506 OA222S $T=740900 749840 0 180 $X=735320 $Y=744420
X3617 3297 3493 3381 3252 3452 3257 2 1 3565 OA222S $T=737180 719600 0 0 $X=737180 $Y=719220
X3618 3347 3566 3560 3282 3546 3328 2 1 3512 OA222S $T=742760 739760 1 180 $X=737180 $Y=739380
X3619 3257 3461 3521 3446 3452 3252 2 1 3593 OA222S $T=742760 729680 1 0 $X=742760 $Y=724260
X3620 3494 3257 3560 3584 3485 3252 2 1 3598 OA222S $T=743380 739760 0 0 $X=743380 $Y=739380
X3621 3485 3257 3560 3446 3454 3252 2 1 3571 OA222S $T=750200 749840 0 180 $X=744620 $Y=744420
X3622 3493 3257 3521 3584 3461 3252 2 1 3622 OA222S $T=748960 729680 1 0 $X=748960 $Y=724260
X3623 3546 3289 3560 3618 3494 3566 2 1 3607 OA222S $T=756400 749840 0 180 $X=750820 $Y=744420
X3624 3441 3105 3356 3296 3454 3136 2 1 3647 OA222S $T=752680 759920 1 0 $X=752680 $Y=754500
X3625 3105 3381 3372 3654 3136 3452 2 1 3675 OA222S $T=758880 719600 0 0 $X=758880 $Y=719220
X3626 3454 3654 3560 3661 3546 3566 2 1 3672 OA222S $T=758880 749840 1 0 $X=758880 $Y=744420
X3627 3518 3289 3521 3618 3566 3493 2 1 3681 OA222S $T=760740 729680 0 0 $X=760740 $Y=729300
X3628 3654 3452 3521 3661 3518 3566 2 1 3712 OA222S $T=766940 739760 1 0 $X=766940 $Y=734340
X3629 1584 108 1 1619 2 1620 OAI12HS $T=342860 850640 1 0 $X=342860 $Y=845220
X3630 2532 198 1 2514 2 2517 OAI12HS $T=537540 830480 1 180 $X=533820 $Y=830100
X3631 425 2670 1 402 2 2663 OAI12HS $T=568540 709520 1 180 $X=564820 $Y=709140
X3632 2739 2571 1 487 2 2803 OAI12HS $T=588380 770000 1 0 $X=588380 $Y=764580
X3633 3151 3124 1 3189 2 3196 OAI12HS $T=672700 770000 0 0 $X=672700 $Y=769620
X3634 3135 3130 1 3189 2 3219 OAI12HS $T=677660 790160 1 0 $X=677660 $Y=784740
X3635 3549 3544 1 2937 2 3543 OAI12HS $T=739660 850640 0 180 $X=735940 $Y=845220
X3636 3549 3556 1 3563 2 3557 OAI12HS $T=738420 850640 0 0 $X=738420 $Y=850260
X3637 1475 1489 1493 1441 2 1459 1 AOI13HS $T=319300 830480 1 0 $X=319300 $Y=825060
X3638 328 387 388 389 2 371 1 AOI13HS $T=551180 699440 0 0 $X=551180 $Y=699060
X3639 2464 453 2727 458 2 464 1 AOI13HS $T=577220 699440 0 0 $X=577220 $Y=699060
X3640 3209 3110 3125 3147 2 3254 1 AOI13HS $T=684480 770000 1 0 $X=684480 $Y=764580
X3641 3110 1 3105 3055 3098 2 ND3S $T=660300 780080 0 180 $X=657820 $Y=774660
X3642 3115 1 3105 2977 3136 2 ND3S $T=667740 780080 1 180 $X=665260 $Y=779700
X3643 3209 1 3124 3131 3151 2 ND3S $T=679520 770000 0 180 $X=677040 $Y=764580
X3644 3209 1 3151 3143 3125 2 ND3S $T=679520 770000 1 180 $X=677040 $Y=769620
X3645 3253 1 3147 3260 3209 2 ND3S $T=687580 759920 1 180 $X=685100 $Y=759540
X3646 3125 1 3273 3282 3223 2 ND3S $T=690680 749840 0 0 $X=690680 $Y=749460
X3647 3147 1 3244 3285 3125 2 ND3S $T=690680 770000 0 0 $X=690680 $Y=769620
X3648 3523 1 547 3474 555 2 ND3S $T=735940 850640 1 180 $X=733460 $Y=850260
X3649 299 2489 352 2516 304 2525 1 2 2529 OA222 $T=531340 739760 0 0 $X=531340 $Y=739380
X3650 403 401 305 2619 299 310 1 2 2616 OA222 $T=560480 699440 1 180 $X=554900 $Y=699060
X3651 305 2680 371 2684 311 2450 1 2 2669 OA222 $T=571640 719600 1 180 $X=566060 $Y=719220
X3652 464 2740 468 470 427 2746 1 2 2760 OA222 $T=579700 709520 0 0 $X=579700 $Y=709140
X3653 377 2785 464 2508 425 2777 1 2 478 OA222 $T=591480 709520 1 180 $X=585900 $Y=709140
X3654 352 322 491 489 433 2735 1 2 2780 OA222 $T=593960 709520 0 180 $X=588380 $Y=704100
X3655 304 2824 377 2832 501 503 1 2 2767 OA222 $T=595200 709520 1 0 $X=595200 $Y=704100
X3656 377 485 427 495 425 2759 1 2 2851 OA222 $T=597060 709520 0 0 $X=597060 $Y=709140
X3657 365 2861 464 2812 433 2846 1 2 2840 OA222 $T=605740 770000 1 180 $X=600160 $Y=769620
X3658 526 523 521 2727 491 489 1 2 2859 OA222 $T=609460 699440 1 180 $X=603880 $Y=699060
X3659 526 533 352 2899 304 2662 1 2 2886 OA222 $T=615040 719600 0 180 $X=609460 $Y=714180
X3660 433 2798 526 546 377 2918 1 2 540 OA222 $T=622480 719600 0 180 $X=616900 $Y=714180
X3661 365 2970 468 588 377 2933 1 2 3000 OA222 $T=639840 729680 0 0 $X=639840 $Y=729300
X3662 3298 3339 3282 3341 3328 3313 1 2 3281 OA222 $T=704940 729680 0 180 $X=699360 $Y=724260
X3663 3355 3339 3347 3282 3323 3328 1 2 3277 OA222 $T=705560 749840 1 180 $X=699980 $Y=749460
X3664 3337 3297 3363 3252 3302 3257 1 2 3276 OA222 $T=708660 719600 1 180 $X=703080 $Y=719220
X3665 3403 3297 3411 3252 3309 3257 1 2 3269 OA222 $T=714860 749840 0 180 $X=709280 $Y=744420
X3666 3454 3105 3441 3296 3485 3136 1 2 3603 OA222 $T=744620 759920 1 0 $X=744620 $Y=754500
X3667 3105 3452 3654 3381 3136 3461 1 2 3670 OA222 $T=758260 729680 1 0 $X=758260 $Y=724260
X3668 3215 3209 3196 2 1 3217 OA12S $T=683860 770000 1 180 $X=680140 $Y=769620
X3669 1881 1824 165 2 1 1725 AN3 $T=404240 729680 0 180 $X=400520 $Y=724260
X3670 2548 361 328 2 1 2541 AN3 $T=540640 709520 0 0 $X=540640 $Y=709140
X3671 452 449 2726 2 1 2733 AN3 $T=576600 759920 0 0 $X=576600 $Y=759540
X3672 2759 2735 426 2 1 2744 AN3 $T=585280 699440 1 180 $X=581560 $Y=699060
X3673 2761 471 2484 2 1 469 AN3 $T=585280 729680 0 180 $X=581560 $Y=724260
X3674 2764 449 2727 2 1 2785 AN3 $T=585280 729680 1 0 $X=585280 $Y=724260
X3675 512 362 472 2 1 2798 AN3 $T=623100 749840 0 180 $X=619380 $Y=744420
X3676 3131 3136 3143 2 1 3118 AN3 $T=668980 770000 1 180 $X=665260 $Y=769620
X3677 3124 3130 3273 2 1 3222 AN3 $T=692540 770000 1 0 $X=692540 $Y=764580
X3678 3223 3244 3164 2 1 3319 AN3 $T=696260 770000 1 0 $X=696260 $Y=764580
X3679 3130 3125 3147 3143 1 2 3115 OA13S $T=671460 780080 0 180 $X=667120 $Y=774660
X3680 627 3226 3205 3117 3021 3222 1 2 3200 AO222S $T=686340 729680 1 180 $X=680140 $Y=729300
X3681 3226 629 613 3205 3222 2996 1 2 3241 AO222S $T=691300 739760 0 180 $X=685100 $Y=734340
X3682 3226 637 636 3205 3222 626 1 2 3280 AO222S $T=696880 739760 1 180 $X=690680 $Y=739380
X3683 639 3226 3205 634 3175 3222 1 2 3271 AO222S $T=696880 749840 0 180 $X=690680 $Y=744420
X3684 17 1059 2 1 1050 1058 MUX2 $T=231880 729680 1 180 $X=227540 $Y=729300
X3685 14 11 2 1 1063 1094 MUX2 $T=230020 709520 0 0 $X=230020 $Y=709140
X3686 15 11 2 1 1060 1095 MUX2 $T=230020 729680 1 0 $X=230020 $Y=724260
X3687 28 21 2 1 24 1091 MUX2 $T=237460 699440 1 180 $X=233120 $Y=699060
X3688 25 21 2 1 29 1109 MUX2 $T=233120 709520 1 0 $X=233120 $Y=704100
X3689 1121 21 2 1 1074 1088 MUX2 $T=237460 739760 1 180 $X=233120 $Y=739380
X3690 1064 1059 2 1 1071 1088 MUX2 $T=237460 770000 1 180 $X=233120 $Y=769620
X3691 23 1059 2 1 1051 1116 MUX2 $T=233740 749840 1 0 $X=233740 $Y=744420
X3692 1065 1059 2 1 1076 1133 MUX2 $T=234980 770000 1 0 $X=234980 $Y=764580
X3693 33 21 2 1 27 1105 MUX2 $T=240560 709520 1 180 $X=236220 $Y=709140
X3694 35 34 2 1 31 1124 MUX2 $T=243040 699440 1 180 $X=238700 $Y=699060
X3695 1116 1059 2 1 1089 1133 MUX2 $T=239320 770000 0 0 $X=239320 $Y=769620
X3696 1147 21 2 1 1097 1133 MUX2 $T=244280 759920 0 180 $X=239940 $Y=754500
X3697 1098 1059 2 1 1099 1088 MUX2 $T=239940 780080 1 0 $X=239940 $Y=774660
X3698 1130 21 2 1 1107 1133 MUX2 $T=245520 770000 0 180 $X=241180 $Y=764580
X3699 1139 32 2 1 1103 1157 MUX2 $T=241800 729680 1 0 $X=241800 $Y=724260
X3700 36 34 2 1 1091 1163 MUX2 $T=243040 709520 1 0 $X=243040 $Y=704100
X3701 41 40 2 1 36 39 MUX2 $T=249240 699440 1 180 $X=244900 $Y=699060
X3702 1186 40 2 1 1139 1156 MUX2 $T=249860 719600 0 180 $X=245520 $Y=714180
X3703 1156 40 2 1 1134 1185 MUX2 $T=247380 729680 1 0 $X=247380 $Y=724260
X3704 39 40 2 1 1124 1184 MUX2 $T=255440 699440 1 180 $X=251100 $Y=699060
X3705 1185 40 2 1 1157 1191 MUX2 $T=257300 729680 0 180 $X=252960 $Y=724260
X3706 1324 59 2 1 1257 1298 MUX2 $T=277140 709520 0 180 $X=272800 $Y=704100
X3707 66 59 2 1 1274 1299 MUX2 $T=277760 709520 1 180 $X=273420 $Y=709140
X3708 71 59 2 1 1275 1301 MUX2 $T=278380 729680 0 180 $X=274040 $Y=724260
X3709 68 1288 2 1 1244 1302 MUX2 $T=278380 749840 1 180 $X=274040 $Y=749460
X3710 1302 1288 2 1 1239 1303 MUX2 $T=278380 780080 0 180 $X=274040 $Y=774660
X3711 1331 65 2 1 1282 1311 MUX2 $T=279000 749840 0 180 $X=274660 $Y=744420
X3712 1279 1288 2 1 1241 1311 MUX2 $T=280240 790160 0 180 $X=275900 $Y=784740
X3713 1336 65 2 1 1306 1303 MUX2 $T=281480 759920 1 180 $X=277140 $Y=759540
X3714 1333 1288 2 1 1206 1303 MUX2 $T=280860 780080 1 0 $X=280860 $Y=774660
X3715 1340 65 2 1 1307 1303 MUX2 $T=286440 759920 1 180 $X=282100 $Y=759540
X3716 1319 1288 2 1 1246 1311 MUX2 $T=282100 790160 1 0 $X=282100 $Y=784740
X3717 1339 82 2 1 1330 1351 MUX2 $T=288920 719600 0 180 $X=284580 $Y=714180
X3718 1449 108 2 1 1490 1494 MUX2 $T=316200 840560 0 0 $X=316200 $Y=840180
X3719 1474 108 2 1 1502 1461 MUX2 $T=317440 790160 1 0 $X=317440 $Y=784740
X3720 1461 108 2 1 1507 1488 MUX2 $T=319920 780080 0 0 $X=319920 $Y=779700
X3721 1449 108 2 1 1508 1467 MUX2 $T=319920 850640 1 0 $X=319920 $Y=845220
X3722 1466 108 2 1 1514 1505 MUX2 $T=321160 790160 0 0 $X=321160 $Y=789780
X3723 1494 108 2 1 1523 1474 MUX2 $T=322400 810320 1 0 $X=322400 $Y=804900
X3724 1505 108 2 1 1519 1476 MUX2 $T=323020 790160 1 0 $X=323020 $Y=784740
X3725 1492 108 2 1 1529 1491 MUX2 $T=324260 800240 0 0 $X=324260 $Y=799860
X3726 1449 108 2 1 1539 1486 MUX2 $T=326740 840560 0 0 $X=326740 $Y=840180
X3727 1465 108 2 1 1559 1492 MUX2 $T=328600 810320 1 0 $X=328600 $Y=804900
X3728 1462 108 2 1 1512 1518 MUX2 $T=333560 790160 0 180 $X=329220 $Y=784740
X3729 1577 124 2 1 1532 1551 MUX2 $T=336660 749840 0 180 $X=332320 $Y=744420
X3730 1486 108 2 1 1572 1466 MUX2 $T=332320 840560 1 0 $X=332320 $Y=835140
X3731 1447 108 2 1 1588 1462 MUX2 $T=335420 790160 1 0 $X=335420 $Y=784740
X3732 1606 124 2 1 1530 1551 MUX2 $T=341620 739760 1 180 $X=337280 $Y=739380
X3733 135 133 2 1 1579 1608 MUX2 $T=347200 699440 1 180 $X=342860 $Y=699060
X3734 137 133 2 1 1580 1610 MUX2 $T=349060 719600 0 180 $X=344720 $Y=714180
X3735 1624 124 2 1 1601 1626 MUX2 $T=351540 770000 1 180 $X=347200 $Y=769620
X3736 145 133 2 1 1555 1622 MUX2 $T=352160 709520 0 180 $X=347820 $Y=704100
X3737 1638 1632 2 1 1615 1551 MUX2 $T=352160 739760 0 180 $X=347820 $Y=734340
X3738 147 144 2 1 138 1628 MUX2 $T=353400 699440 1 180 $X=349060 $Y=699060
X3739 1634 1632 2 1 1611 1626 MUX2 $T=353400 759920 0 180 $X=349060 $Y=754500
X3740 1645 1632 2 1 1616 1626 MUX2 $T=354640 759920 1 180 $X=350300 $Y=759540
X3741 1625 124 2 1 1564 1626 MUX2 $T=351540 780080 1 0 $X=351540 $Y=774660
X3742 1643 153 2 1 1623 1671 MUX2 $T=357740 719600 1 0 $X=357740 $Y=714180
X3743 126 195 2 1 1857 190 MUX2 $T=404240 880880 0 180 $X=399900 $Y=875460
X3744 1899 1895 2 1 1843 1885 MUX2 $T=409200 729680 0 180 $X=404860 $Y=724260
X3745 120 195 2 1 1925 143 MUX2 $T=406100 880880 1 0 $X=406100 $Y=875460
X3746 1903 1895 2 1 1940 1936 MUX2 $T=409820 729680 0 0 $X=409820 $Y=729300
X3747 1896 1916 2 1 1906 1909 MUX2 $T=414780 709520 1 180 $X=410440 $Y=709140
X3748 1932 1895 2 1 1889 1919 MUX2 $T=414780 719600 1 180 $X=410440 $Y=719220
X3749 1906 1905 2 1 1819 1971 MUX2 $T=411060 729680 1 0 $X=411060 $Y=724260
X3750 1921 1958 2 1 1840 1927 MUX2 $T=416640 800240 0 180 $X=412300 $Y=794820
X3751 1935 203 2 1 1928 199 MUX2 $T=417260 699440 1 180 $X=412920 $Y=699060
X3752 1946 1949 2 1 1959 1970 MUX2 $T=415400 780080 1 0 $X=415400 $Y=774660
X3753 1946 206 2 1 1957 215 MUX2 $T=416640 770000 1 0 $X=416640 $Y=764580
X3754 1963 1958 2 1 1938 1984 MUX2 $T=417880 810320 0 0 $X=417880 $Y=809940
X3755 1928 1916 2 1 1960 1981 MUX2 $T=418500 719600 0 0 $X=418500 $Y=719220
X3756 213 203 2 1 1981 1974 MUX2 $T=419120 699440 0 0 $X=419120 $Y=699060
X3757 1960 1905 2 1 1861 1989 MUX2 $T=419740 729680 0 0 $X=419740 $Y=729300
X3758 1968 1923 2 1 1943 1999 MUX2 $T=419740 800240 0 0 $X=419740 $Y=799860
X3759 1974 203 2 1 1995 1994 MUX2 $T=420360 709520 1 0 $X=420360 $Y=704100
X3760 1909 1916 2 1 2002 1995 MUX2 $T=420360 709520 0 0 $X=420360 $Y=709140
X3761 1956 1905 2 1 1881 2002 MUX2 $T=420980 729680 1 0 $X=420980 $Y=724260
X3762 215 206 2 1 2000 1982 MUX2 $T=420980 770000 0 0 $X=420980 $Y=769620
X3763 1959 209 2 1 1931 2000 MUX2 $T=420980 790160 0 0 $X=420980 $Y=789780
X3764 1965 1895 2 1 1973 2004 MUX2 $T=422220 739760 1 0 $X=422220 $Y=734340
X3765 1982 206 2 1 2005 2012 MUX2 $T=422220 770000 1 0 $X=422220 $Y=764580
X3766 1942 209 2 1 2017 1957 MUX2 $T=424080 780080 1 0 $X=424080 $Y=774660
X3767 1996 1958 2 1 1987 2018 MUX2 $T=424080 810320 0 0 $X=424080 $Y=809940
X3768 1881 1895 2 1 1993 2022 MUX2 $T=425320 729680 0 0 $X=425320 $Y=729300
X3769 2000 209 2 1 1999 2032 MUX2 $T=425940 790160 0 0 $X=425940 $Y=789780
X3770 1954 1958 2 1 2023 2033 MUX2 $T=425940 800240 0 0 $X=425940 $Y=799860
X3771 1994 203 2 1 2029 2026 MUX2 $T=426560 709520 0 0 $X=426560 $Y=709140
X3772 1981 1916 2 1 2035 2029 MUX2 $T=426560 719600 1 0 $X=426560 $Y=714180
X3773 1998 1905 2 1 1882 2035 MUX2 $T=426560 719600 0 0 $X=426560 $Y=719220
X3774 2009 206 2 1 2038 2036 MUX2 $T=426560 770000 0 0 $X=426560 $Y=769620
X3775 2012 206 2 1 2032 2009 MUX2 $T=427800 770000 1 0 $X=427800 $Y=764580
X3776 2017 1923 2 1 1964 2039 MUX2 $T=427800 800240 1 0 $X=427800 $Y=794820
X3777 1957 209 2 1 2013 2005 MUX2 $T=428420 790160 1 0 $X=428420 $Y=784740
X3778 2032 209 2 1 2056 2057 MUX2 $T=431520 790160 0 0 $X=431520 $Y=789780
X3779 1999 1923 2 1 1984 2052 MUX2 $T=431520 800240 0 0 $X=431520 $Y=799860
X3780 2040 1958 2 1 2030 2055 MUX2 $T=431520 810320 0 0 $X=431520 $Y=809940
X3781 2029 1916 2 1 1989 226 MUX2 $T=432140 719600 1 0 $X=432140 $Y=714180
X3782 2005 209 2 1 2039 2038 MUX2 $T=432140 780080 0 0 $X=432140 $Y=779700
X3783 2026 203 2 1 2059 220 MUX2 $T=432760 709520 1 0 $X=432760 $Y=704100
X3784 1995 1916 2 1 1971 2059 MUX2 $T=432760 709520 0 0 $X=432760 $Y=709140
X3785 2035 1905 2 1 1919 2063 MUX2 $T=432760 719600 0 0 $X=432760 $Y=719220
X3786 2002 1905 2 1 1885 2087 MUX2 $T=433380 729680 1 0 $X=433380 $Y=724260
X3787 2013 1923 2 1 1927 2064 MUX2 $T=434620 800240 1 0 $X=434620 $Y=794820
X3788 1882 1895 2 1 2049 2071 MUX2 $T=435240 739760 1 0 $X=435240 $Y=734340
X3789 1943 1958 2 1 2067 2082 MUX2 $T=437720 810320 0 0 $X=437720 $Y=809940
X3790 1861 1895 2 1 2105 2131 MUX2 $T=447020 739760 1 0 $X=447020 $Y=734340
X3791 2123 209 2 1 2134 2149 MUX2 $T=450740 790160 1 0 $X=450740 $Y=784740
X3792 2144 2169 2 1 2164 2180 MUX2 $T=456320 729680 0 0 $X=456320 $Y=729300
X3793 2127 233 2 1 2178 2181 MUX2 $T=456320 810320 1 0 $X=456320 $Y=804900
X3794 2172 2169 2 1 2204 2180 MUX2 $T=461900 729680 0 0 $X=461900 $Y=729300
X3795 2213 233 2 1 2228 2190 MUX2 $T=465620 790160 0 0 $X=465620 $Y=789780
X3796 2131 1895 2 1 2235 2180 MUX2 $T=466860 739760 1 0 $X=466860 $Y=734340
X3797 2207 233 2 1 2239 2181 MUX2 $T=467480 800240 0 0 $X=467480 $Y=799860
X3798 2135 1958 2 1 2240 2181 MUX2 $T=467480 810320 1 0 $X=467480 $Y=804900
X3799 2208 1958 2 1 2260 2181 MUX2 $T=472440 800240 1 0 $X=472440 $Y=794820
X3800 2230 1958 2 1 2264 2190 MUX2 $T=473060 790160 1 0 $X=473060 $Y=784740
X3801 2188 1895 2 1 2267 2180 MUX2 $T=473680 719600 0 0 $X=473680 $Y=719220
X3802 2142 1958 2 1 2269 2190 MUX2 $T=473680 790160 0 0 $X=473680 $Y=789780
X3803 2148 1895 2 1 2280 2233 MUX2 $T=475540 729680 1 0 $X=475540 $Y=724260
X3804 2219 2169 2 1 2291 2233 MUX2 $T=479260 719600 1 0 $X=479260 $Y=714180
X3805 2273 1895 2 1 2301 2233 MUX2 $T=479880 719600 0 0 $X=479880 $Y=719220
X3806 2342 198 2 1 281 2095 MUX2 $T=502200 860720 1 0 $X=502200 $Y=855300
X3807 2272 198 2 1 2371 2001 MUX2 $T=504680 860720 0 0 $X=504680 $Y=860340
X3808 2255 198 2 1 2411 2074 MUX2 $T=506540 850640 0 0 $X=506540 $Y=850260
X3809 2420 198 2 1 2404 2342 MUX2 $T=513980 830480 0 180 $X=509640 $Y=825060
X3810 2397 198 2 1 2415 2272 MUX2 $T=515840 830480 1 180 $X=511500 $Y=830100
X3811 2451 198 2 1 2395 2420 MUX2 $T=520800 830480 0 180 $X=516460 $Y=825060
X3812 2408 198 2 1 2432 2245 MUX2 $T=522040 830480 1 180 $X=517700 $Y=830100
X3813 2448 198 2 1 2485 2462 MUX2 $T=523280 830480 1 0 $X=523280 $Y=825060
X3814 2448 198 2 1 2490 2478 MUX2 $T=523900 830480 0 0 $X=523900 $Y=830100
X3815 2448 198 2 1 2521 2451 MUX2 $T=530100 830480 1 0 $X=530100 $Y=825060
X3816 2453 198 2 1 2506 2255 MUX2 $T=536300 820400 0 180 $X=531960 $Y=814980
X3817 2543 346 2 1 2520 2408 MUX2 $T=543120 820400 1 180 $X=538780 $Y=820020
X3818 2462 346 2 1 2570 2453 MUX2 $T=541260 800240 1 0 $X=541260 $Y=794820
X3819 1361 1364 1442 1 2 XNR2H $T=297600 840560 1 0 $X=297600 $Y=835140
X3820 1364 84 1385 2 1 1410 QDFFRBS $T=287680 850640 1 0 $X=287680 $Y=845220
X3821 1390 106 111 2 1 1496 QDFFRBS $T=309380 870800 1 0 $X=309380 $Y=865380
X3822 1114 1102 1047 2 1071 9 1 AO22S $T=236840 830480 0 180 $X=231880 $Y=825060
X3823 1106 1102 1049 2 1076 9 1 AO22S $T=236840 830480 1 180 $X=231880 $Y=830100
X3824 1118 1102 1061 2 1089 9 1 AO22S $T=238080 820400 0 180 $X=233120 $Y=814980
X3825 1122 1102 1073 2 1093 9 1 AO22S $T=238700 810320 0 180 $X=233740 $Y=804900
X3826 1143 26 1090 2 8 16 1 AO22S $T=241180 860720 1 180 $X=236220 $Y=860340
X3827 1171 26 1140 2 38 16 1 AO22S $T=249240 870800 0 180 $X=244280 $Y=865380
X3828 1188 26 1150 2 37 16 1 AO22S $T=249860 860720 0 180 $X=244900 $Y=855300
X3829 2265 2249 2276 2 2264 2150 1 AO22S $T=481740 780080 1 180 $X=476780 $Y=779700
X3830 2315 2249 2274 2 2183 2150 1 AO22S $T=486700 810320 0 180 $X=481740 $Y=804900
X3831 2333 2249 2319 2 2260 2150 1 AO22S $T=491660 780080 1 180 $X=486700 $Y=779700
X3832 2336 2249 2302 2 2242 2150 1 AO22S $T=492280 800240 0 180 $X=487320 $Y=794820
X3833 2344 2249 2306 2 2270 2150 1 AO22S $T=493520 800240 1 180 $X=488560 $Y=799860
X3834 2376 2249 2347 2 2269 2150 1 AO22S $T=499100 780080 1 180 $X=494140 $Y=779700
X3835 2368 2249 2313 2 2240 2150 1 AO22S $T=501580 790160 1 180 $X=496620 $Y=789780
X3836 3742 3686 4025 2 816 3702 1 AO22S $T=861180 810320 0 0 $X=861180 $Y=809940
X3837 883 3686 4316 2 888 3702 1 AO22S $T=939300 830480 1 0 $X=939300 $Y=825060
X3838 903 3686 4399 2 908 3702 1 AO22S $T=961000 850640 1 0 $X=961000 $Y=845220
X3839 1058 1059 2 1074 1 1078 MUX2S $T=227540 739760 0 0 $X=227540 $Y=739380
X3840 20 1059 2 1064 1 1056 MUX2S $T=232500 759920 0 180 $X=228160 $Y=754500
X3841 24 1059 2 1065 1 1053 MUX2S $T=232500 770000 0 180 $X=228160 $Y=764580
X3842 1120 21 2 1088 1 1084 MUX2S $T=236840 739760 0 180 $X=232500 $Y=734340
X3843 1094 1059 2 1084 1 1087 MUX2S $T=237460 729680 1 180 $X=233120 $Y=729300
X3844 31 21 2 1096 1 1094 MUX2S $T=238080 719600 1 180 $X=233740 $Y=719220
X3845 27 1059 2 1097 1 1086 MUX2S $T=238080 759920 0 180 $X=233740 $Y=754500
X3846 1095 1059 2 1107 1 1093 MUX2S $T=233740 759920 0 0 $X=233740 $Y=759540
X3847 29 1059 2 1098 1 1017 MUX2S $T=238080 780080 0 180 $X=233740 $Y=774660
X3848 1091 21 2 1103 1 1095 MUX2S $T=239940 729680 0 180 $X=235600 $Y=724260
X3849 1096 21 2 1120 1 1064 MUX2S $T=243040 739760 0 180 $X=238700 $Y=734340
X3850 1129 21 2 1121 1 1098 MUX2S $T=243040 739760 1 180 $X=238700 $Y=739380
X3851 1109 21 2 1129 1 1058 MUX2S $T=243660 729680 1 180 $X=239320 $Y=729300
X3852 1103 21 2 1130 1 1065 MUX2S $T=243660 759920 1 180 $X=239320 $Y=759540
X3853 1169 32 2 1134 1 1096 MUX2S $T=244280 719600 1 180 $X=239940 $Y=719220
X3854 1105 21 2 1147 1 1116 MUX2S $T=239940 749840 1 0 $X=239940 $Y=744420
X3855 1163 32 2 1139 1 1105 MUX2S $T=246140 709520 1 180 $X=241800 $Y=709140
X3856 1155 32 2 1152 1 1120 MUX2S $T=248620 739760 0 180 $X=244280 $Y=734340
X3857 1134 32 2 1155 1 1129 MUX2S $T=249240 729680 1 180 $X=244900 $Y=729300
X3858 1088 42 2 1152 1 1121 MUX2S $T=249240 739760 1 180 $X=244900 $Y=739380
X3859 1157 32 2 1164 1 1147 MUX2S $T=250480 749840 0 180 $X=246140 $Y=744420
X3860 1164 32 2 1133 1 1130 MUX2S $T=250480 759920 0 180 $X=246140 $Y=754500
X3861 1124 32 2 1169 1 1109 MUX2S $T=251720 709520 1 180 $X=247380 $Y=709140
X3862 1184 40 2 1172 1 1163 MUX2S $T=252960 709520 0 180 $X=248620 $Y=704100
X3863 1191 40 2 1180 1 1155 MUX2S $T=254820 729680 1 180 $X=250480 $Y=729300
X3864 1181 40 2 1088 1 1152 MUX2S $T=254820 739760 0 180 $X=250480 $Y=734340
X3865 1180 40 2 1181 1 1164 MUX2S $T=254820 739760 1 180 $X=250480 $Y=739380
X3866 1172 40 2 1186 1 1169 MUX2S $T=257300 719600 0 180 $X=252960 $Y=714180
X3867 60 1288 2 1279 1 1228 MUX2S $T=273420 770000 0 180 $X=269080 $Y=764580
X3868 1300 59 2 1282 1 1231 MUX2S $T=274040 749840 0 180 $X=269700 $Y=744420
X3869 67 65 2 1305 1 1299 MUX2S $T=278380 719600 1 180 $X=274040 $Y=719220
X3870 1298 1288 2 1306 1 1230 MUX2S $T=278380 759920 0 180 $X=274040 $Y=754500
X3871 1301 1288 2 1307 1 1245 MUX2S $T=278380 770000 1 180 $X=274040 $Y=769620
X3872 72 59 2 1300 1 1255 MUX2S $T=279000 729680 1 180 $X=274660 $Y=729300
X3873 1299 59 2 1320 1 1218 MUX2S $T=274660 739760 0 0 $X=274660 $Y=739380
X3874 69 1288 2 1319 1 1200 MUX2S $T=280240 780080 1 180 $X=275900 $Y=779700
X3875 75 65 2 1325 1 69 MUX2S $T=282720 709520 1 180 $X=278380 $Y=709140
X3876 78 65 2 1330 1 1298 MUX2S $T=283340 719600 0 180 $X=279000 $Y=714180
X3877 73 65 2 1345 1 1301 MUX2S $T=279620 719600 0 0 $X=279620 $Y=719220
X3878 1325 65 2 1334 1 1300 MUX2S $T=283960 729680 0 180 $X=279620 $Y=724260
X3879 1305 65 2 1335 1 1279 MUX2S $T=283960 739760 0 180 $X=279620 $Y=734340
X3880 1330 65 2 1336 1 1302 MUX2S $T=283960 749840 1 180 $X=279620 $Y=749460
X3881 79 1288 2 1333 1 1229 MUX2S $T=283960 770000 1 180 $X=279620 $Y=769620
X3882 81 82 2 1339 1 73 MUX2S $T=284580 699440 1 180 $X=280240 $Y=699060
X3883 1335 65 2 1311 1 1320 MUX2S $T=284580 739760 1 180 $X=280240 $Y=739380
X3884 1334 65 2 1331 1 1319 MUX2S $T=284580 749840 0 180 $X=280240 $Y=744420
X3885 1345 65 2 1340 1 1333 MUX2S $T=284580 770000 0 180 $X=280240 $Y=764580
X3886 80 82 2 1350 1 1325 MUX2S $T=288300 709520 0 180 $X=283960 $Y=704100
X3887 1350 82 2 1353 1 1305 MUX2S $T=288920 719600 1 180 $X=284580 $Y=719220
X3888 1351 82 2 1355 1 1345 MUX2S $T=289540 729680 0 180 $X=285200 $Y=724260
X3889 1353 82 2 1356 1 1334 MUX2S $T=289540 729680 1 180 $X=285200 $Y=729300
X3890 1356 82 2 1354 1 1335 MUX2S $T=289540 739760 0 180 $X=285200 $Y=734340
X3891 1311 83 2 1354 1 1331 MUX2S $T=285820 739760 0 0 $X=285820 $Y=739380
X3892 1377 86 2 1311 1 1354 MUX2S $T=290160 749840 1 180 $X=285820 $Y=749460
X3893 1355 82 2 1359 1 1336 MUX2S $T=290160 759920 0 180 $X=285820 $Y=754500
X3894 1359 82 2 1303 1 1340 MUX2S $T=290160 770000 0 180 $X=285820 $Y=764580
X3895 88 86 2 1366 1 80 MUX2S $T=292640 699440 1 180 $X=288300 $Y=699060
X3896 1366 86 2 1369 1 1339 MUX2S $T=293880 709520 1 180 $X=289540 $Y=709140
X3897 1369 86 2 1370 1 1350 MUX2S $T=293880 719600 0 180 $X=289540 $Y=714180
X3898 1370 86 2 1373 1 1351 MUX2S $T=294500 719600 1 180 $X=290160 $Y=719220
X3899 1373 86 2 1374 1 1353 MUX2S $T=295120 729680 0 180 $X=290780 $Y=724260
X3900 1374 86 2 1375 1 1355 MUX2S $T=295120 729680 1 180 $X=290780 $Y=729300
X3901 1375 86 2 1376 1 1356 MUX2S $T=295120 739760 1 180 $X=290780 $Y=739380
X3902 1376 86 2 1377 1 1359 MUX2S $T=295740 759920 0 180 $X=291400 $Y=754500
X3903 1518 108 2 1473 1 1504 MUX2S $T=327360 770000 0 180 $X=323020 $Y=764580
X3904 1467 108 2 1465 1 1545 MUX2S $T=326740 810320 0 0 $X=326740 $Y=809940
X3905 129 124 2 1577 1 1538 MUX2S $T=342240 749840 0 180 $X=337900 $Y=744420
X3906 136 124 2 1606 1 1550 MUX2S $T=346580 739760 0 180 $X=342240 $Y=734340
X3907 1622 133 2 1609 1 1537 MUX2S $T=347200 739760 1 180 $X=342860 $Y=739380
X3908 1608 124 2 1611 1 1578 MUX2S $T=347820 759920 0 180 $X=343480 $Y=754500
X3909 140 133 2 1614 1 1561 MUX2S $T=348440 729680 0 180 $X=344100 $Y=724260
X3910 1614 133 2 1615 1 1581 MUX2S $T=348440 729680 1 180 $X=344100 $Y=729300
X3911 132 124 2 1624 1 1535 MUX2S $T=344100 749840 1 0 $X=344100 $Y=744420
X3912 1610 124 2 1616 1 1557 MUX2S $T=348440 759920 1 180 $X=344100 $Y=759540
X3913 146 144 2 1623 1 1608 MUX2S $T=350920 709520 1 180 $X=346580 $Y=709140
X3914 138 124 2 1625 1 1549 MUX2S $T=350920 770000 0 180 $X=346580 $Y=764580
X3915 1636 1632 2 1551 1 1609 MUX2S $T=353400 739760 1 180 $X=349060 $Y=739380
X3916 1628 1632 2 1631 1 1610 MUX2S $T=354640 719600 1 180 $X=350300 $Y=719220
X3917 150 144 2 1633 1 1622 MUX2S $T=355260 719600 0 180 $X=350920 $Y=714180
X3918 1623 1632 2 1634 1 1624 MUX2S $T=356500 749840 1 180 $X=352160 $Y=749460
X3919 152 144 2 1637 1 136 MUX2S $T=357120 709520 1 180 $X=352780 $Y=709140
X3920 1639 1632 2 1638 1 1606 MUX2S $T=357120 729680 1 180 $X=352780 $Y=729300
X3921 1637 1632 2 1639 1 1614 MUX2S $T=357740 729680 0 180 $X=353400 $Y=724260
X3922 1633 1632 2 1636 1 1577 MUX2S $T=357740 739760 1 180 $X=353400 $Y=739380
X3923 156 153 2 1643 1 1628 MUX2S $T=358360 709520 0 180 $X=354020 $Y=704100
X3924 1631 1632 2 1645 1 1625 MUX2S $T=358980 759920 0 180 $X=354640 $Y=754500
X3925 1660 153 2 1648 1 1633 MUX2S $T=360220 719600 1 180 $X=355880 $Y=719220
X3926 1665 153 2 1626 1 1645 MUX2S $T=360220 759920 1 180 $X=355880 $Y=759540
X3927 1676 161 2 1551 1 1656 MUX2S $T=362080 749840 1 180 $X=357740 $Y=749460
X3928 1648 153 2 1658 1 1639 MUX2S $T=362700 729680 1 180 $X=358360 $Y=729300
X3929 1658 153 2 1656 1 1636 MUX2S $T=362700 749840 0 180 $X=358360 $Y=744420
X3930 163 153 2 1660 1 1637 MUX2S $T=363320 709520 1 180 $X=358980 $Y=709140
X3931 1671 153 2 1661 1 1631 MUX2S $T=363320 729680 0 180 $X=358980 $Y=724260
X3932 1551 159 2 1656 1 1638 MUX2S $T=358980 739760 1 0 $X=358980 $Y=734340
X3933 1661 153 2 1665 1 1634 MUX2S $T=364560 759920 0 180 $X=360220 $Y=754500
X3934 1681 161 2 1672 1 1648 MUX2S $T=366420 719600 1 180 $X=362080 $Y=719220
X3935 162 161 2 164 1 1643 MUX2S $T=362700 699440 0 0 $X=362700 $Y=699060
X3936 1686 161 2 1681 1 1671 MUX2S $T=367660 719600 0 180 $X=363320 $Y=714180
X3937 164 161 2 1686 1 1660 MUX2S $T=368900 709520 0 180 $X=364560 $Y=704100
X3938 1672 161 2 1697 1 1661 MUX2S $T=364560 739760 1 0 $X=364560 $Y=734340
X3939 1697 161 2 1690 1 1658 MUX2S $T=369520 739760 1 180 $X=365180 $Y=739380
X3940 1690 161 2 1676 1 1665 MUX2S $T=370140 759920 0 180 $X=365800 $Y=754500
X3941 2036 206 2 2046 1 2057 MUX2S $T=432140 770000 0 0 $X=432140 $Y=769620
X3942 2056 1947 2 1931 1 1944 MUX2S $T=437720 810320 0 180 $X=433380 $Y=804900
X3943 2038 209 2 2060 1 2064 MUX2S $T=434620 790160 1 0 $X=434620 $Y=784740
X3944 224 203 2 2075 1 2083 MUX2S $T=437720 699440 0 0 $X=437720 $Y=699060
X3945 2057 209 2 2077 1 2052 MUX2S $T=437720 790160 0 0 $X=437720 $Y=789780
X3946 2039 1923 2 2078 1 2018 MUX2S $T=437720 800240 0 0 $X=437720 $Y=799860
X3947 226 1916 2 2079 1 2063 MUX2S $T=438340 719600 1 0 $X=438340 $Y=714180
X3948 2063 1905 2 2080 1 2071 MUX2S $T=438340 719600 0 0 $X=438340 $Y=719220
X3949 2046 206 2 2066 1 2060 MUX2S $T=442680 780080 0 180 $X=438340 $Y=774660
X3950 2060 209 2 2081 1 2078 MUX2S $T=438340 780080 0 0 $X=438340 $Y=779700
X3951 2059 1916 2 2083 1 2087 MUX2S $T=438960 709520 0 0 $X=438960 $Y=709140
X3952 1971 1905 2 2084 1 1936 MUX2S $T=438960 729680 0 0 $X=438960 $Y=729300
X3953 2056 1923 2 2085 1 2055 MUX2S $T=438960 810320 1 0 $X=438960 $Y=804900
X3954 2075 203 2 230 1 2079 MUX2S $T=440820 709520 1 0 $X=440820 $Y=704100
X3955 1819 1895 2 2093 1 2076 MUX2S $T=440820 739760 1 0 $X=440820 $Y=734340
X3956 2064 1923 2 2094 1 2033 MUX2S $T=440820 800240 1 0 $X=440820 $Y=794820
X3957 2066 206 2 2099 1 2077 MUX2S $T=441440 770000 0 0 $X=441440 $Y=769620
X3958 2077 209 2 2109 1 2085 MUX2S $T=443300 790160 0 0 $X=443300 $Y=789780
X3959 1964 1958 2 2110 1 2072 MUX2S $T=443300 810320 0 0 $X=443300 $Y=809940
X3960 2079 1916 2 2112 1 2120 MUX2S $T=443920 719600 1 0 $X=443920 $Y=714180
X3961 2087 1905 2 2113 1 2022 MUX2S $T=443920 719600 0 0 $X=443920 $Y=719220
X3962 2097 206 2 2115 1 2109 MUX2S $T=443920 780080 0 0 $X=443920 $Y=779700
X3963 2052 1923 2 2116 1 2082 MUX2S $T=443920 800240 0 0 $X=443920 $Y=799860
X3964 2099 206 2 2097 1 2081 MUX2S $T=448880 780080 0 180 $X=444540 $Y=774660
X3965 2083 1916 2 236 1 2084 MUX2S $T=445160 709520 0 0 $X=445160 $Y=709140
X3966 2084 1905 2 2121 1 2093 MUX2S $T=445160 729680 1 0 $X=445160 $Y=724260
X3967 1989 1905 2 2120 1 2004 MUX2S $T=445160 729680 0 0 $X=445160 $Y=729300
X3968 2081 209 2 2123 1 2094 MUX2S $T=445160 790160 1 0 $X=445160 $Y=784740
X3969 2085 1923 2 2127 1 2135 MUX2S $T=446400 810320 1 0 $X=446400 $Y=804900
X3970 234 203 2 237 1 2112 MUX2S $T=447020 699440 0 0 $X=447020 $Y=699060
X3971 2109 209 2 2129 1 2116 MUX2S $T=447020 800240 1 0 $X=447020 $Y=794820
X3972 2078 233 2 2134 1 2110 MUX2S $T=448880 790160 0 0 $X=448880 $Y=789780
X3973 1944 1958 2 2135 1 2132 MUX2S $T=448880 810320 0 0 $X=448880 $Y=809940
X3974 2115 206 2 2140 1 2123 MUX2S $T=449500 780080 1 0 $X=449500 $Y=774660
X3975 2112 1916 2 241 1 2080 MUX2S $T=450120 719600 1 0 $X=450120 $Y=714180
X3976 2113 1905 2 2141 1 2148 MUX2S $T=450120 719600 0 0 $X=450120 $Y=719220
X3977 1927 1958 2 2142 1 2146 MUX2S $T=450120 800240 0 0 $X=450120 $Y=799860
X3978 2120 1905 2 2144 1 2131 MUX2S $T=450740 729680 0 0 $X=450740 $Y=729300
X3979 236 1916 2 2147 1 2113 MUX2S $T=451360 709520 1 0 $X=451360 $Y=704100
X3980 1885 1895 2 2148 1 2163 MUX2S $T=451360 729680 1 0 $X=451360 $Y=724260
X3981 237 203 2 242 1 2147 MUX2S $T=452600 699440 0 0 $X=452600 $Y=699060
X3982 2140 206 2 2159 1 2129 MUX2S $T=452600 770000 0 0 $X=452600 $Y=769620
X3983 2004 1895 2 2164 1 2170 MUX2S $T=453220 739760 1 0 $X=453220 $Y=734340
X3984 2129 209 2 2167 1 2127 MUX2S $T=453840 800240 1 0 $X=453840 $Y=794820
X3985 2094 233 2 2171 1 2142 MUX2S $T=454460 790160 0 0 $X=454460 $Y=789780
X3986 2159 206 2 2160 1 2149 MUX2S $T=459420 780080 0 180 $X=455080 $Y=774660
X3987 2080 1905 2 2172 1 2188 MUX2S $T=455700 719600 0 0 $X=455700 $Y=719220
X3988 2149 209 2 2173 1 2171 MUX2S $T=455700 790160 1 0 $X=455700 $Y=784740
X3989 2033 1958 2 2174 1 2183 MUX2S $T=455700 800240 0 0 $X=455700 $Y=799860
X3990 241 1916 2 2166 1 2144 MUX2S $T=460660 719600 0 180 $X=456320 $Y=714180
X3991 2055 1958 2 2178 1 2185 MUX2S $T=456320 810320 0 0 $X=456320 $Y=809940
X3992 2147 1916 2 2182 1 2121 MUX2S $T=457560 709520 1 0 $X=457560 $Y=704100
X3993 246 203 2 2191 1 2182 MUX2S $T=458800 699440 0 0 $X=458800 $Y=699060
X3994 2171 233 2 2190 1 2174 MUX2S $T=460040 790160 0 0 $X=460040 $Y=789780
X3995 2167 209 2 2181 1 2207 MUX2S $T=460040 800240 1 0 $X=460040 $Y=794820
X3996 2160 206 2 2201 1 2167 MUX2S $T=460660 780080 1 0 $X=460660 $Y=774660
X3997 1919 1895 2 2188 1 2203 MUX2S $T=461280 729680 1 0 $X=461280 $Y=724260
X3998 2071 1895 2 2204 1 2215 MUX2S $T=461280 739760 1 0 $X=461280 $Y=734340
X3999 2190 1972 2 2173 1 2213 MUX2S $T=461280 780080 0 0 $X=461280 $Y=779700
X4000 2166 1916 2 2180 1 2172 MUX2S $T=466240 719600 1 180 $X=461900 $Y=719220
X4001 2116 233 2 2207 1 2208 MUX2S $T=461900 800240 0 0 $X=461900 $Y=799860
X4002 1984 1958 2 2208 1 2186 MUX2S $T=461900 810320 1 0 $X=461900 $Y=804900
X4003 2182 1916 2 2211 1 2141 MUX2S $T=462520 709520 0 0 $X=462520 $Y=709140
X4004 2191 203 2 2214 1 2166 MUX2S $T=463140 709520 1 0 $X=463140 $Y=704100
X4005 2201 206 2 2190 1 2173 MUX2S $T=469960 780080 0 180 $X=465620 $Y=774660
X4006 2110 1958 2 2228 1 2242 MUX2S $T=466240 800240 1 0 $X=466240 $Y=794820
X4007 2134 233 2 2213 1 2230 MUX2S $T=466860 790160 1 0 $X=466860 $Y=784740
X4008 2018 249 2 2230 1 2231 MUX2S $T=466860 810320 0 0 $X=466860 $Y=809940
X4009 2233 205 2 2211 1 2219 MUX2S $T=471820 719600 0 180 $X=467480 $Y=714180
X4010 2141 2169 2 2233 1 2234 MUX2S $T=467480 719600 0 0 $X=467480 $Y=719220
X4011 2022 1895 2 2234 1 2238 MUX2S $T=467480 729680 0 0 $X=467480 $Y=729300
X4012 2214 203 2 2233 1 2211 MUX2S $T=468720 709520 0 0 $X=468720 $Y=709140
X4013 2121 2169 2 2219 1 2273 MUX2S $T=473060 719600 1 0 $X=473060 $Y=714180
X4014 2082 1958 2 2239 1 2270 MUX2S $T=473680 800240 0 0 $X=473680 $Y=799860
X4015 1936 1895 2 2273 1 2275 MUX2S $T=475540 729680 0 0 $X=475540 $Y=729300
X4016 2093 1895 2 2291 1 2303 MUX2S $T=481120 729680 1 0 $X=481120 $Y=724260
X4017 2245 198 2 1908 1 2433 MUX2S $T=512120 850640 1 0 $X=512120 $Y=845220
X4018 2478 198 2 2397 1 2454 MUX2S $T=525760 820400 1 0 $X=525760 $Y=814980
X4019 2310 2331 2353 1 2 XOR2H $T=490420 709520 0 0 $X=490420 $Y=709140
X4020 1907 1923 1954 1983 2 1 MXL2HS $T=417880 800240 1 0 $X=417880 $Y=794820
X4021 783 3702 3851 3882 2 1 MXL2HS $T=825840 840560 1 180 $X=820260 $Y=840180
X4022 924 3702 922 4450 2 1 MXL2HS $T=982700 790160 1 180 $X=977120 $Y=789780
X4023 4532 3686 4498 937 2 1 MXL2HS $T=1008120 800240 0 180 $X=1002540 $Y=794820
X4024 942 3702 4522 4540 2 1 MXL2HS $T=1014940 800240 0 180 $X=1009360 $Y=794820
X4025 4606 3686 4516 949 2 1 MXL2HS $T=1033540 830480 0 180 $X=1027960 $Y=825060
X4026 1827 1821 1818 1 2 AN2B1T $T=393700 709520 1 0 $X=393700 $Y=704100
X4027 1864 1875 1883 1 2 AN2B1T $T=403620 790160 1 0 $X=403620 $Y=784740
X4028 1851 1879 1817 1 2 AN2B1T $T=403620 830480 1 0 $X=403620 $Y=825060
X4029 165 169 1802 1 2 1782 OA12 $T=392460 709520 1 180 $X=388740 $Y=709140
X4030 1834 154 1871 1 2 1779 OA12 $T=404860 770000 1 180 $X=401140 $Y=769620
X4031 2920 479 443 1 2 2910 OA12 $T=621240 709520 0 180 $X=617520 $Y=704100
X4032 1123 1114 1 1165 1187 1175 2 MOAI1 $T=249240 830480 1 0 $X=249240 $Y=825060
X4033 1118 1179 1 1146 2 OR2B1S $T=249240 820400 0 0 $X=249240 $Y=820020
X4034 1475 1487 1 1503 2 OR2B1S $T=322400 840560 0 0 $X=322400 $Y=840180
X4035 201 1972 1 1975 2 OR2B1S $T=427180 790160 0 180 $X=424080 $Y=784740
X4036 3656 3651 1 3627 2 OR2B1S $T=760740 870800 1 0 $X=760740 $Y=865380
X4037 154 1868 2 1884 1846 1834 1 AOI22H $T=400520 810320 1 0 $X=400520 $Y=804900
X4038 1854 1840 1 1830 2 NR2T $T=394320 840560 1 0 $X=394320 $Y=835140
X4039 1832 1953 1 1914 2 NR2T $T=412920 790160 1 0 $X=412920 $Y=784740
X4040 169 1781 1787 1 2 1724 AO12 $T=384400 739760 1 0 $X=384400 $Y=734340
X4041 169 1786 1789 1 2 1693 AO12 $T=385020 729680 1 0 $X=385020 $Y=724260
X4042 2713 429 433 1 2 2640 AO12 $T=575980 759920 0 180 $X=572260 $Y=754500
X4043 669 3544 3570 1 2 3549 AO12 $T=744000 850640 0 180 $X=740280 $Y=845220
X4044 734 3759 733 1 2 3740 AO12 $T=784920 810320 0 180 $X=781200 $Y=804900
X4045 3730 734 733 1 2 3745 AO12 $T=784920 840560 0 180 $X=781200 $Y=835140
X4046 734 3768 733 1 2 3761 AO12 $T=788020 820400 0 180 $X=784300 $Y=814980
X4047 734 3771 733 1 2 742 AO12 $T=788640 840560 0 180 $X=784920 $Y=835140
X4048 734 3780 733 1 2 3789 AO12 $T=788640 820400 1 0 $X=788640 $Y=814980
X4049 734 3786 733 1 2 3793 AO12 $T=789880 840560 1 0 $X=789880 $Y=835140
X4050 3787 734 733 1 2 3796 AO12 $T=791740 820400 0 0 $X=791740 $Y=820020
X4051 734 3814 733 1 2 3821 AO12 $T=798560 820400 0 0 $X=798560 $Y=820020
X4052 734 3819 733 1 2 3827 AO12 $T=799800 810320 0 0 $X=799800 $Y=809940
X4053 734 3817 733 1 2 760 AO12 $T=804140 830480 1 180 $X=800420 $Y=830100
X4054 734 4323 889 1 2 256 AO12 $T=944880 770000 1 180 $X=941160 $Y=769620
X4055 734 4303 889 1 2 254 AO12 $T=947360 759920 1 180 $X=943640 $Y=759540
X4056 734 4349 889 1 2 4344 AO12 $T=951080 770000 1 180 $X=947360 $Y=769620
X4057 734 4353 889 1 2 4352 AO12 $T=952940 759920 1 180 $X=949220 $Y=759540
X4058 734 4359 889 1 2 259 AO12 $T=955420 759920 0 180 $X=951700 $Y=754500
X4059 734 4386 889 1 2 4390 AO12 $T=958520 770000 0 0 $X=958520 $Y=769620
X4060 734 4400 889 1 2 4391 AO12 $T=965960 770000 1 180 $X=962240 $Y=769620
X4061 734 4416 889 1 2 4408 AO12 $T=969680 770000 1 180 $X=965960 $Y=769620
X4062 3740 239 1 2 INV3 $T=778720 810320 0 180 $X=776240 $Y=804900
X4063 4408 93 1 2 INV3 $T=965960 770000 1 0 $X=965960 $Y=764580
X4064 3796 232 1 2 INV4 $T=794220 830480 1 0 $X=794220 $Y=825060
X4065 4363 87 1 2 INV4 $T=955420 770000 0 0 $X=955420 $Y=769620
X4066 763 702 1 2 3898 QDLHN $T=804760 770000 1 0 $X=804760 $Y=764580
X4067 763 777 1 2 3865 QDLHN $T=809100 759920 1 0 $X=809100 $Y=754500
X4068 763 765 1 2 3869 QDLHN $T=810340 749840 1 0 $X=810340 $Y=744420
X4069 763 762 1 2 3879 QDLHN $T=813440 759920 0 0 $X=813440 $Y=759540
X4070 3094 3096 548 3147 1 2 3151 DFFRBN $T=655960 759920 0 0 $X=655960 $Y=759540
X4071 377 2980 443 2907 2 1 3013 MAOI1 $T=635500 729680 1 0 $X=635500 $Y=724260
X4072 1883 1832 2 1884 1 1890 AN3B2S $T=407340 800240 0 0 $X=407340 $Y=799860
X4073 310 2439 2 2444 1 2449 AN3B2S $T=523900 699440 1 180 $X=520180 $Y=699060
X4074 2488 2580 2 2576 1 372 AN3B2S $T=549320 739760 0 180 $X=545600 $Y=734340
X4075 2592 2609 2 2605 1 2545 AN3B2S $T=554900 749840 1 180 $X=551180 $Y=749460
X4076 449 2632 2 2739 1 2812 AN3B2S $T=583420 770000 0 0 $X=583420 $Y=769620
X4077 2901 2650 2 2912 1 2899 AN3B2S $T=615040 739760 1 0 $X=615040 $Y=734340
X4078 426 424 423 2464 2 1 2574 AN4S $T=569160 699440 1 180 $X=564200 $Y=699060
X4079 2759 337 485 2798 2 1 2804 AN4S $T=587760 749840 1 0 $X=587760 $Y=744420
X4080 421 407 2445 2 440 1 2663 AO112 $T=569160 709520 1 0 $X=569160 $Y=704100
X4081 408 274 202 1 2 233 QDFFRBT $T=561720 770000 0 180 $X=548080 $Y=764580
X4082 300 274 202 154 1 2 QDFFRBP $T=517700 759920 1 180 $X=505300 $Y=759540
X4083 2387 2393 2396 2390 1 2 2405 AO13 $T=505300 729680 0 0 $X=505300 $Y=729300
X4084 206 214 1975 2 1 1907 OR3 $T=423460 790160 0 180 $X=419740 $Y=784740
X4085 1916 1909 1896 2 1858 1827 1 MUXB2 $T=411680 709520 0 180 $X=405480 $Y=704100
X4086 209 1957 1942 2 1914 1864 1 MUXB2 $T=418500 780080 1 180 $X=412300 $Y=779700
X4087 1854 1924 1938 1 2 AN2B1 $T=409200 830480 1 0 $X=409200 $Y=825060
X4088 154 1668 2 1678 1682 1 AOI12HP $T=354640 770000 0 0 $X=354640 $Y=769620
X4089 154 1917 2 1849 1920 1 AOI12HP $T=406100 749840 0 0 $X=406100 $Y=749460
X4090 1855 1856 1839 1880 1904 1 2 AO13P $T=401140 840560 1 0 $X=401140 $Y=835140
X4091 165 1858 1860 1 2 194 OR3B1 $T=399280 709520 0 0 $X=399280 $Y=709140
X4092 154 1663 2 1718 1673 1 AOI12H $T=358360 800240 1 0 $X=358360 $Y=794820
X4093 169 1712 2 1702 1725 1 AOI12H $T=369520 749840 1 0 $X=369520 $Y=744420
X4094 169 1731 2 1775 1701 1 AOI12H $T=372000 719600 0 0 $X=372000 $Y=719220
X4095 1483 1487 1 1503 1433 1489 2 OAI112H $T=318060 840560 1 0 $X=318060 $Y=835140
.ENDS
***************************************
.SUBCKT ICV_9 1 2 3 4 5 6 7 8 9
** N=9 EP=9 IP=12 FDC=0
X0 1 2 3 4 5 ND2 $T=-1860 0 0 0 $X=-1860 $Y=-380
X1 6 7 8 4 5 ND2 $T=0 0 0 0 $X=0 $Y=-380
.ENDS
***************************************
.SUBCKT ICV_10 1 2 3 4 5 6 7 8
** N=8 EP=8 IP=12 FDC=0
X0 3 4 5 2 1 6 XNR3 $T=1860 0 0 0 $X=1860 $Y=-380
X1 6 7 1 2 INV2 $T=0 0 0 0 $X=0 $Y=-380
.ENDS
***************************************
.SUBCKT INV6 I O GND VCC
** N=5 EP=4 IP=0 FDC=0
.ENDS
***************************************
.SUBCKT AO12T B2 B1 A1 GND VCC O
** N=7 EP=6 IP=0 FDC=0
.ENDS
***************************************
.SUBCKT XOR4 I1 I2 O I3 VCC GND I4
** N=8 EP=7 IP=0 FDC=0
.ENDS
***************************************
.SUBCKT MXL2HP B S OB A GND VCC
** N=7 EP=6 IP=0 FDC=0
.ENDS
***************************************
.SUBCKT BUF4 I O GND VCC
** N=5 EP=4 IP=0 FDC=0
.ENDS
***************************************
.SUBCKT INV8 O I GND VCC
** N=5 EP=4 IP=0 FDC=0
.ENDS
***************************************
.SUBCKT OA112 A1 B1 C1 C2 VCC GND O
** N=8 EP=7 IP=0 FDC=0
.ENDS
***************************************
.SUBCKT MXL2HT B S OB A GND VCC
** N=7 EP=6 IP=0 FDC=0
.ENDS
***************************************
.SUBCKT MOAI1HP B2 B1 GND A1 O A2 VCC
** N=8 EP=7 IP=0 FDC=0
.ENDS
***************************************
.SUBCKT INV12 O I GND VCC
** N=5 EP=4 IP=0 FDC=0
.ENDS
***************************************
.SUBCKT MOAI1HT B1 B2 GND A1 O A2 VCC
** N=8 EP=7 IP=0 FDC=0
.ENDS
***************************************
.SUBCKT DFFRBT D CK RB Q GND VCC QB
** N=8 EP=7 IP=0 FDC=0
.ENDS
***************************************
.SUBCKT AN3B1 B1 I2 I1 GND VCC O
** N=7 EP=6 IP=0 FDC=0
.ENDS
***************************************
.SUBCKT OR3P I3 I2 I1 O GND VCC
** N=7 EP=6 IP=0 FDC=0
.ENDS
***************************************
.SUBCKT INV1CK O I GND VCC
** N=5 EP=4 IP=0 FDC=0
.ENDS
***************************************
.SUBCKT OA112S A1 B1 C1 C2 VCC GND O
** N=8 EP=7 IP=0 FDC=0
.ENDS
***************************************
.SUBCKT HA1 A B C GND VCC S
** N=7 EP=6 IP=0 FDC=0
.ENDS
***************************************
.SUBCKT BUF4CK I GND O VCC
** N=5 EP=4 IP=0 FDC=0
.ENDS
***************************************
.SUBCKT OAI13HS B1 B2 B3 GND A1 VCC O
** N=8 EP=7 IP=0 FDC=0
.ENDS
***************************************
.SUBCKT OR2B1 B1 I1 GND VCC O
** N=6 EP=5 IP=0 FDC=0
.ENDS
***************************************
.SUBCKT DFFSBN D CK SB Q GND VCC QB
** N=8 EP=7 IP=0 FDC=0
.ENDS
***************************************
.SUBCKT AOI22HP A2 A1 VCC B1 O B2 GND
** N=8 EP=7 IP=0 FDC=0
.ENDS
***************************************
.SUBCKT BUF8 I O GND VCC
** N=5 EP=4 IP=0 FDC=0
.ENDS
***************************************
.SUBCKT ICV_11 1 2 3 4 5 6 7 8 9 10 11 12 13 14 15 16 17 18 19 20
+ 21 22 23 24 25 26 27 28 29 30 31 32 33 34 35 36 37 38 39 40
+ 41 42 43 44 45 46 47 48 49 50 51 52 53 54 55 56 57 58 59 60
+ 61 62 63 64 65 66 67 68 69 70 71 72 73 74 75 76 77 78 79 80
+ 81 82 83 84 85 86 87 88 89 90 91 92 93 94 95 96 97 98 99 100
+ 101 102 103 104 105 106 107 108 109 110 111 112 113 114 115 116 117 118 119 120
+ 121 122 123 124 125 126 127 128 129 130 131 132 133 134 135 136 137 138 139 140
+ 141 142 143 144 145 146 147 148 149 150 151 152 153 154 155 156 157 158 159 160
+ 161 162 163 164 165 166 167 168 169 170 171 172 173 174 175 176 177 178 179 180
+ 181 182 183 184 185 186 187 188 189 190 191 192 193 194 195 196 197 198 199 200
+ 201 202 203 204 205 206 207 208 209 210 211 212 213 214 215 216 217 218 219 220
+ 221 222 223 224 225 226 227 228 229 230 231 232 233 234 235 236 237 238 239 240
+ 241 242 243 244 245 246 247 248 249 250 251 252 253 254 255 256 257 258 259 260
+ 261 262 263 264 265 266 267 268 269 270 271 272 273 274 275 276 277 278 279 280
+ 281 282 283 284 285 286 287 288 289 290 291 292 293 294 295 296 297 298 299 300
+ 301 302 303 304 305 306 307 308 309 310 311 312 313 314 315 316 317 318 319 320
+ 321 322 323 324 325 326 327 328 329 330 331 332 333 334 335 336 337 338 339 340
+ 341 342 343 344 345 346 347 348 349 350 351 352 353 354 355 356 357 358 359 360
+ 361 362 363 364 365 366 367 368 369 370 371 372 373 374 375 376 377 378 379 380
+ 381 382 383 384 385 386 387 388 389 390 391 392 393 394 395 396 397 398 399 400
+ 401 402 403 404 405 406 407 408 409 410 411 412 413 414 415 416 417 418 419 420
+ 421 422 423 424 425 426 427 428 429 430 431 432 433 434 435 436 437 438 439 440
+ 441 442 443 444 445 446 447 448 449 450 451 452 453 454 455 456 457 458 459 460
+ 461 462 463 464 465 466 467 468 469 470 471 472 473 474 475 476 477 478 479 480
+ 481 482 483 484 485 486 487 488 489 490 491 492 493 494 495 496 497 498 499 500
+ 501 502 503 504 505 506 507 508 509 510 511 512 513 514 515 516 517 518 519 520
+ 521 522 523 524 525 526 527 528 529 530 531 532 533 534 535 536 537 538 539 540
+ 541 542 543 544 545 546 547 548 549 550 551 552 553 554 555 556 557 558 559 560
+ 561 562 563 564 565 566 567 568 569 570 571 572 573 574 575 576 577 578 579 580
+ 581 582 583 584 585 586 587 588 589 590 591 592 593 594 595 596 597 598 599 600
+ 601 602 603 604 605 606 607 608 609 610 611 612 613 614 615 616 617 618 619 620
+ 621 622 623 624 625 626 627 628 629 630 631 632 633 634 635 636 637 638 639 640
+ 641 642 643 644 645 646 647 648 649 650 651 652 653 654 655 656 657 658 659 660
+ 661 662 663 664 665 666 667 668 669 670 671 672 673 674 675 676 677 678 679 680
+ 681 682 683 684 685 686 687 688 689 690 691 692 693 694 695 696 697 698 699 700
+ 701 702 703 704 705 706 707 708 709 710 711 712 713 714 715 716 717 718 719 720
+ 721 722 723 724 725 726 727 728 729 730 731 732 733 734 735 736 737 738 739 740
+ 741 742 743 744 745 746 747 748 749 750 751 752 753 754 755 756 757 758 759 760
+ 761 762 763 764 765 766 767 768 769 770 771 772 773 774 775 776 777 778 779 780
+ 781 782 783 784 785 786 787 788 789 790 791 792 793 794 795 796 797 798 799 800
+ 801 802 803 804 805 806 807 808 809 810 811 812 813 814 815 816 817 818 819 820
+ 821 822 823 824 825 826 827 828 829 830 831 832 833 834 835 836 837 838 839 840
+ 841 842 843 844 845 846 847 848 849 850 851 852 853 854 855 856 857 858 859 860
+ 861 862 863 864 865 866 867 868 869 870 871 872 873 874 875 876 877 878 879 880
+ 881 882 883 884 885 886 887 888 889 890 891 892 893 894 895 896 897 898 899 900
+ 901 902 903 904 905 906 907 908 909 910 911 912 913 914 915 916 917 918 919 920
+ 921 922 923 924 925 926 927 928 929 930 931 932 933 934 935 936 937 938 939 940
+ 941 942 943 944 945 946 947 948 949 950 951 952 953 954 955 956 957 958 959 960
+ 961 962 963 964 965 966 967 968 969 970 971 972 973 974 975 976 977 978 979 980
+ 981 982 983 984 985 986 987 988 989 990 991 992 993 994 995 996 997 998 999 1000
+ 1001 1002 1003 1004 1005 1006 1007 1008 1009 1010 1011 1012 1013 1014 1015 1016 1017 1018 1019 1020
+ 1021 1022 1023 1024 1025 1026 1027 1028 1029 1030 1031 1032 1033 1034 1035 1036 1037 1038 1039 1040
+ 1041 1042 1043 1044 1045 1046 1047 1048 1049 1050 1051 1052 1053 1054 1055 1056 1057 1058 1059 1060
+ 1061 1062 1063 1064 1065 1066 1067 1068 1069 1070 1071 1072 1073 1074 1075 1076 1077 1078 1079 1080
+ 1081 1082 1083 1084 1085 1086 1087 1088 1089 1090 1091 1092 1093 1094 1095 1096 1097 1098 1099 1100
+ 1101 1102 1103 1104 1105 1106 1107 1108 1109 1110 1111 1112 1113 1114 1115 1116 1117 1118 1119 1120
+ 1121 1122 1123 1124 1125 1126 1127 1128 1129 1130 1131 1132 1133 1134 1135 1136 1137 1138 1139 1140
+ 1141 1142 1143 1144 1145 1146 1147 1148 1149 1150 1151 1152 1153 1154 1155 1156 1157 1158 1159 1160
+ 1161 1162 1163 1164 1165 1166 1167 1168 1169 1170 1171 1172 1173 1174 1175 1176 1177 1178 1179 1180
+ 1181 1182 1183 1184 1185 1186 1187 1188 1189 1190 1191 1192 1193 1194 1195 1196 1197 1198 1199 1200
+ 1201 1202 1203 1204 1205 1206 1207 1208 1209 1210 1211 1212 1213 1214 1215 1216 1217 1218 1219 1220
+ 1221 1222 1223 1224 1225 1226 1227 1228 1229 1230 1231 1232 1233 1234 1235 1236 1237 1238 1239 1240
+ 1241 1242 1243 1244 1245 1246 1247 1248 1249 1250 1251 1252 1253 1254 1255 1256 1257 1258 1259 1260
+ 1261 1262 1263 1264 1265 1266 1267 1268 1269 1270 1271 1272 1273 1274 1275 1276 1277 1283 1293
** N=5508 EP=1279 IP=30826 FDC=0
X0 1276 1277 1277 1277 3304 1277 1283 YA2GSD $T=1315640 625070 0 90 $X=1176140 $Y=627920
X1 303 1894 1870 1 2 QDFFN $T=341620 578480 1 180 $X=331080 $Y=578100
X2 295 1894 1875 1 2 QDFFN $T=342240 548240 0 180 $X=331700 $Y=542820
X3 305 1894 1884 1 2 QDFFN $T=343480 588560 0 180 $X=332940 $Y=583140
X4 286 1891 1917 1 2 QDFFN $T=333560 558320 1 0 $X=333560 $Y=552900
X5 287 1891 1927 1 2 QDFFN $T=333560 568400 0 0 $X=333560 $Y=568020
X6 287 1894 1922 1 2 QDFFN $T=334180 568400 1 0 $X=334180 $Y=562980
X7 286 1894 1926 1 2 QDFFN $T=336040 548240 0 0 $X=336040 $Y=547860
X8 295 1891 1939 1 2 QDFFN $T=337280 538160 0 0 $X=337280 $Y=537780
X9 305 1891 1898 1 2 QDFFN $T=347820 598640 0 180 $X=337280 $Y=593220
X10 300 1894 1944 1 2 QDFFN $T=339140 528080 0 0 $X=339140 $Y=527700
X11 322 1894 1915 1 2 QDFFN $T=352160 598640 1 180 $X=341620 $Y=598260
X12 300 1891 1967 1 2 QDFFN $T=342240 528080 1 0 $X=342240 $Y=522660
X13 303 1924 1973 1 2 QDFFN $T=343480 578480 1 0 $X=343480 $Y=573060
X14 303 1891 1975 1 2 QDFFN $T=344100 578480 0 0 $X=344100 $Y=578100
X15 295 1924 1983 1 2 QDFFN $T=347200 548240 1 0 $X=347200 $Y=542820
X16 286 1924 1986 1 2 QDFFN $T=347820 558320 1 0 $X=347820 $Y=552900
X17 287 1924 2007 1 2 QDFFN $T=347820 568400 0 0 $X=347820 $Y=568020
X18 322 1891 1942 1 2 QDFFN $T=358360 608720 1 180 $X=347820 $Y=608340
X19 305 1993 1958 1 2 QDFFN $T=361460 588560 1 180 $X=350920 $Y=588180
X20 300 1924 2015 1 2 QDFFN $T=351540 538160 1 0 $X=351540 $Y=532740
X21 322 1924 1998 1 2 QDFFN $T=352160 608720 1 0 $X=352160 $Y=603300
X22 329 1894 2025 1 2 QDFFN $T=354640 518000 0 0 $X=354640 $Y=517620
X23 342 339 1990 1 2 QDFFN $T=368280 507920 0 180 $X=357740 $Y=502500
X24 342 340 1997 1 2 QDFFN $T=369520 507920 1 180 $X=358980 $Y=507540
X25 329 1891 2009 1 2 QDFFN $T=371380 518000 0 180 $X=360840 $Y=512580
X26 337 1891 2045 1 2 QDFFN $T=360840 608720 0 0 $X=360840 $Y=608340
X27 286 1993 2018 1 2 QDFFN $T=372620 558320 1 180 $X=362080 $Y=557940
X28 305 1924 2016 1 2 QDFFN $T=373240 588560 0 180 $X=362700 $Y=583140
X29 337 1924 2047 1 2 QDFFN $T=362700 618800 1 0 $X=362700 $Y=613380
X30 287 1993 2019 1 2 QDFFN $T=374480 568400 1 180 $X=363940 $Y=568020
X31 303 1993 2005 1 2 QDFFN $T=374480 578480 1 180 $X=363940 $Y=578100
X32 337 1894 2048 1 2 QDFFN $T=364560 608720 1 0 $X=364560 $Y=603300
X33 337 1993 2057 1 2 QDFFN $T=365180 628880 1 0 $X=365180 $Y=623460
X34 300 1993 2026 1 2 QDFFN $T=376340 548240 1 180 $X=365800 $Y=547860
X35 322 1993 2006 1 2 QDFFN $T=376340 598640 1 180 $X=365800 $Y=598260
X36 295 1993 2017 1 2 QDFFN $T=376960 558320 0 180 $X=366420 $Y=552900
X37 343 1993 2074 1 2 QDFFN $T=367660 538160 0 0 $X=367660 $Y=537780
X38 329 1993 2078 1 2 QDFFN $T=368280 518000 0 0 $X=368280 $Y=517620
X39 329 1924 2069 1 2 QDFFN $T=368280 528080 0 0 $X=368280 $Y=527700
X40 343 1924 2073 1 2 QDFFN $T=369520 538160 1 0 $X=369520 $Y=532740
X41 346 339 2071 1 2 QDFFN $T=371380 507920 0 0 $X=371380 $Y=507540
X42 346 1993 2088 1 2 QDFFN $T=371380 568400 1 0 $X=371380 $Y=562980
X43 349 1993 2100 1 2 QDFFN $T=372620 588560 0 0 $X=372620 $Y=588180
X44 346 353 2079 1 2 QDFFN $T=374480 518000 1 0 $X=374480 $Y=512580
X45 346 1924 2087 1 2 QDFFN $T=374480 558320 0 0 $X=374480 $Y=557940
X46 349 1891 2126 1 2 QDFFN $T=375720 578480 0 0 $X=375720 $Y=578100
X47 349 1894 2096 1 2 QDFFN $T=375720 588560 1 0 $X=375720 $Y=583140
X48 351 1891 2106 1 2 QDFFN $T=375720 618800 1 0 $X=375720 $Y=613380
X49 351 1993 2101 1 2 QDFFN $T=375720 638960 1 0 $X=375720 $Y=633540
X50 346 1894 2105 1 2 QDFFN $T=376340 568400 0 0 $X=376340 $Y=568020
X51 351 1924 2110 1 2 QDFFN $T=376960 628880 0 0 $X=376960 $Y=628500
X52 351 1894 2102 1 2 QDFFN $T=377580 608720 1 0 $X=377580 $Y=603300
X53 355 1993 2118 1 2 QDFFN $T=378200 548240 1 0 $X=378200 $Y=542820
X54 355 1924 2119 1 2 QDFFN $T=378820 558320 1 0 $X=378820 $Y=552900
X55 349 1924 2116 1 2 QDFFN $T=378820 598640 0 0 $X=378820 $Y=598260
X56 346 340 2077 1 2 QDFFN $T=389980 497840 1 180 $X=379440 $Y=497460
X57 359 1924 2130 1 2 QDFFN $T=380680 538160 0 0 $X=380680 $Y=537780
X58 343 1891 2132 1 2 QDFFN $T=381300 518000 0 0 $X=381300 $Y=517620
X59 346 373 2094 1 2 QDFFN $T=394320 507920 1 180 $X=383780 $Y=507540
X60 355 1891 2154 1 2 QDFFN $T=386880 558320 0 0 $X=386880 $Y=557940
X61 346 379 2112 1 2 QDFFN $T=398040 518000 0 180 $X=387500 $Y=512580
X62 381 1891 2109 1 2 QDFFN $T=398040 578480 0 180 $X=387500 $Y=573060
X63 343 1894 2113 1 2 QDFFN $T=398660 528080 1 180 $X=388120 $Y=527700
X64 382 1891 2123 1 2 QDFFN $T=399280 568400 0 180 $X=388740 $Y=562980
X65 346 1891 2170 1 2 QDFFN $T=388740 568400 0 0 $X=388740 $Y=568020
X66 370 1891 2161 1 2 QDFFN $T=388740 618800 1 0 $X=388740 $Y=613380
X67 370 1894 2164 1 2 QDFFN $T=389980 608720 1 0 $X=389980 $Y=603300
X68 370 1993 2172 1 2 QDFFN $T=389980 638960 1 0 $X=389980 $Y=633540
X69 355 1894 2162 1 2 QDFFN $T=390600 548240 1 0 $X=390600 $Y=542820
X70 370 1924 2166 1 2 QDFFN $T=390600 628880 0 0 $X=390600 $Y=628500
X71 342 1894 2173 1 2 QDFFN $T=391840 538160 0 0 $X=391840 $Y=537780
X72 342 373 2158 1 2 QDFFN $T=392460 497840 0 0 $X=392460 $Y=497460
X73 375 1894 2178 1 2 QDFFN $T=392460 598640 1 0 $X=392460 $Y=593220
X74 375 1891 2174 1 2 QDFFN $T=393080 588560 0 0 $X=393080 $Y=588180
X75 342 1891 2176 1 2 QDFFN $T=393700 538160 1 0 $X=393700 $Y=532740
X76 381 1894 2142 1 2 QDFFN $T=404240 588560 0 180 $X=393700 $Y=583140
X77 342 379 2145 1 2 QDFFN $T=404860 507920 1 180 $X=394320 $Y=507540
X78 359 1894 2183 1 2 QDFFN $T=394940 518000 0 0 $X=394940 $Y=517620
X79 342 1993 2198 1 2 QDFFN $T=398040 558320 0 0 $X=398040 $Y=557940
X80 359 1891 2163 1 2 QDFFN $T=409820 518000 0 180 $X=399280 $Y=512580
X81 387 1891 2218 1 2 QDFFN $T=401760 618800 1 0 $X=401760 $Y=613380
X82 381 353 2232 1 2 QDFFN $T=402380 507920 1 0 $X=402380 $Y=502500
X83 342 1924 2220 1 2 QDFFN $T=402380 538160 0 0 $X=402380 $Y=537780
X84 382 1894 2210 1 2 QDFFN $T=402380 568400 0 0 $X=402380 $Y=568020
X85 387 1894 2231 1 2 QDFFN $T=402380 608720 1 0 $X=402380 $Y=603300
X86 387 1993 2222 1 2 QDFFN $T=403000 638960 1 0 $X=403000 $Y=633540
X87 381 1924 2228 1 2 QDFFN $T=403620 578480 0 0 $X=403620 $Y=578100
X88 390 1891 2214 1 2 QDFFN $T=404860 598640 0 0 $X=404860 $Y=598260
X89 387 1924 2233 1 2 QDFFN $T=404860 628880 1 0 $X=404860 $Y=623460
X90 381 340 2249 1 2 QDFFN $T=405480 497840 0 0 $X=405480 $Y=497460
X91 390 1894 2225 1 2 QDFFN $T=406100 588560 1 0 $X=406100 $Y=583140
X92 382 1993 2202 1 2 QDFFN $T=419120 558320 1 180 $X=408580 $Y=557940
X93 381 339 2229 1 2 QDFFN $T=409820 518000 1 0 $X=409820 $Y=512580
X94 359 1993 2201 1 2 QDFFN $T=422220 538160 0 180 $X=411680 $Y=532740
X95 390 1993 2252 1 2 QDFFN $T=413540 588560 0 0 $X=413540 $Y=588180
X96 382 1924 2239 1 2 QDFFN $T=425320 568400 1 180 $X=414780 $Y=568020
X97 390 1924 2266 1 2 QDFFN $T=414780 608720 1 0 $X=414780 $Y=603300
X98 375 1924 2246 1 2 QDFFN $T=427800 618800 1 180 $X=417260 $Y=618420
X99 286 2257 2294 1 2 QDFFN $T=419120 558320 0 0 $X=419120 $Y=557940
X100 381 1993 2241 1 2 QDFFN $T=429660 588560 0 180 $X=419120 $Y=583140
X101 375 1993 2244 1 2 QDFFN $T=429660 628880 1 180 $X=419120 $Y=628500
X102 370 2267 2315 1 2 QDFFN $T=420360 608720 0 0 $X=420360 $Y=608340
X103 286 2267 2299 1 2 QDFFN $T=421600 558320 1 0 $X=421600 $Y=552900
X104 287 2267 2304 1 2 QDFFN $T=422220 568400 1 0 $X=422220 $Y=562980
X105 300 2257 2313 1 2 QDFFN $T=424080 538160 1 0 $X=424080 $Y=532740
X106 343 2267 2324 1 2 QDFFN $T=424080 548240 0 0 $X=424080 $Y=547860
X107 322 2267 2314 1 2 QDFFN $T=424080 578480 0 0 $X=424080 $Y=578100
X108 370 2257 2320 1 2 QDFFN $T=424080 618800 1 0 $X=424080 $Y=613380
X109 381 373 2336 1 2 QDFFN $T=425320 497840 0 0 $X=425320 $Y=497460
X110 343 2257 2319 1 2 QDFFN $T=425320 548240 1 0 $X=425320 $Y=542820
X111 322 2257 2321 1 2 QDFFN $T=425320 588560 0 0 $X=425320 $Y=588180
X112 349 2257 2331 1 2 QDFFN $T=425940 598640 1 0 $X=425940 $Y=593220
X113 303 2257 2342 1 2 QDFFN $T=427800 568400 0 0 $X=427800 $Y=568020
X114 349 2267 2352 1 2 QDFFN $T=427800 608720 1 0 $X=427800 $Y=603300
X115 286 2303 2355 1 2 QDFFN $T=429660 558320 0 0 $X=429660 $Y=557940
X116 370 2303 2305 1 2 QDFFN $T=441440 618800 1 180 $X=430900 $Y=618420
X117 300 2267 2362 1 2 QDFFN $T=431520 518000 0 0 $X=431520 $Y=517620
X118 287 2257 2381 1 2 QDFFN $T=432760 568400 1 0 $X=432760 $Y=562980
X119 370 2346 2316 1 2 QDFFN $T=443300 628880 1 180 $X=432760 $Y=628500
X120 381 379 2349 1 2 QDFFN $T=435240 507920 0 0 $X=435240 $Y=507540
X121 286 2346 2363 1 2 QDFFN $T=435860 548240 0 0 $X=435860 $Y=547860
X122 303 2267 2348 1 2 QDFFN $T=447640 578480 1 180 $X=437100 $Y=578100
X123 322 2303 2360 1 2 QDFFN $T=450740 588560 0 180 $X=440200 $Y=583140
X124 375 2267 2361 1 2 QDFFN $T=451360 608720 0 180 $X=440820 $Y=603300
X125 287 2346 2427 1 2 QDFFN $T=443920 558320 0 0 $X=443920 $Y=557940
X126 322 2346 2384 1 2 QDFFN $T=455080 588560 1 180 $X=444540 $Y=588180
X127 375 2303 2391 1 2 QDFFN $T=455080 618800 1 180 $X=444540 $Y=618420
X128 287 2303 2423 1 2 QDFFN $T=445160 578480 1 0 $X=445160 $Y=573060
X129 375 2257 2385 1 2 QDFFN $T=456320 608720 1 180 $X=445780 $Y=608340
X130 375 2346 2397 1 2 QDFFN $T=456320 628880 0 180 $X=445780 $Y=623460
X131 349 2303 2386 1 2 QDFFN $T=456940 598640 1 180 $X=446400 $Y=598260
X132 343 2303 2405 1 2 QDFFN $T=457560 548240 1 180 $X=447020 $Y=547860
X133 300 2303 2450 1 2 QDFFN $T=448880 518000 0 0 $X=448880 $Y=517620
X134 300 2346 2451 1 2 QDFFN $T=450120 528080 0 0 $X=450120 $Y=527700
X135 343 2346 2414 1 2 QDFFN $T=460660 538160 1 180 $X=450120 $Y=537780
X136 303 2303 2421 1 2 QDFFN $T=463760 588560 0 180 $X=453220 $Y=583140
X137 382 2303 2470 1 2 QDFFN $T=453840 568400 0 0 $X=453840 $Y=568020
X138 387 2257 2465 1 2 QDFFN $T=453840 608720 1 0 $X=453840 $Y=603300
X139 346 2346 2475 1 2 QDFFN $T=454460 558320 0 0 $X=454460 $Y=557940
X140 387 2267 2471 1 2 QDFFN $T=455080 618800 1 0 $X=455080 $Y=613380
X141 382 2346 2485 1 2 QDFFN $T=455700 578480 1 0 $X=455700 $Y=573060
X142 303 2346 2417 1 2 QDFFN $T=466860 578480 1 180 $X=456320 $Y=578100
X143 387 2303 2481 1 2 QDFFN $T=457560 628880 1 0 $X=457560 $Y=623460
X144 305 2346 2490 1 2 QDFFN $T=458180 588560 0 0 $X=458180 $Y=588180
X145 349 2346 2433 1 2 QDFFN $T=469340 598640 1 180 $X=458800 $Y=598260
X146 387 2346 2489 1 2 QDFFN $T=458800 628880 0 0 $X=458800 $Y=628500
X147 295 2303 2499 1 2 QDFFN $T=460040 548240 0 0 $X=460040 $Y=547860
X148 295 2257 2509 1 2 QDFFN $T=460660 528080 0 0 $X=460660 $Y=527700
X149 295 2346 2498 1 2 QDFFN $T=460660 538160 0 0 $X=460660 $Y=537780
X150 295 2267 2529 1 2 QDFFN $T=462520 518000 0 0 $X=462520 $Y=517620
X151 382 2257 2516 1 2 QDFFN $T=464380 568400 0 0 $X=464380 $Y=568020
X152 346 2303 2491 1 2 QDFFN $T=465000 558320 0 0 $X=465000 $Y=557940
X153 381 2346 2531 1 2 QDFFN $T=466240 588560 1 0 $X=466240 $Y=583140
X154 381 458 464 1 2 QDFFN $T=466860 497840 0 0 $X=466860 $Y=497460
X155 337 2267 2486 1 2 QDFFN $T=477400 608720 0 180 $X=466860 $Y=603300
X156 381 2303 2530 1 2 QDFFN $T=467480 578480 0 0 $X=467480 $Y=578100
X157 305 2303 2540 1 2 QDFFN $T=469340 588560 0 0 $X=469340 $Y=588180
X158 329 2303 2506 1 2 QDFFN $T=481120 548240 1 180 $X=470580 $Y=547860
X159 337 2346 2541 1 2 QDFFN $T=470580 628880 1 0 $X=470580 $Y=623460
X160 381 467 2503 1 2 QDFFN $T=481740 507920 1 180 $X=471200 $Y=507540
X161 390 2303 2545 1 2 QDFFN $T=471200 598640 1 0 $X=471200 $Y=593220
X162 337 2303 2522 1 2 QDFFN $T=485460 618800 1 180 $X=474920 $Y=618420
X163 355 2346 2568 1 2 QDFFN $T=475540 558320 0 0 $X=475540 $Y=557940
X164 337 2257 2519 1 2 QDFFN $T=486080 608720 1 180 $X=475540 $Y=608340
X165 382 467 2544 1 2 QDFFN $T=477400 497840 0 0 $X=477400 $Y=497460
X166 329 2267 2536 1 2 QDFFN $T=489180 518000 1 180 $X=478640 $Y=517620
X167 346 2257 2577 1 2 QDFFN $T=478640 568400 0 0 $X=478640 $Y=568020
X168 305 2267 2584 1 2 QDFFN $T=479880 588560 0 0 $X=479880 $Y=588180
X169 390 2346 2565 1 2 QDFFN $T=479880 598640 0 0 $X=479880 $Y=598260
X170 329 2257 2548 1 2 QDFFN $T=492900 528080 1 180 $X=482360 $Y=527700
X171 342 2303 2587 1 2 QDFFN $T=483600 548240 0 0 $X=483600 $Y=547860
X172 351 2346 2564 1 2 QDFFN $T=494760 628880 0 180 $X=484220 $Y=623460
X173 329 2346 2555 1 2 QDFFN $T=495380 538160 0 180 $X=484840 $Y=532740
X174 381 2257 2616 1 2 QDFFN $T=485460 578480 0 0 $X=485460 $Y=578100
X175 382 2267 2571 1 2 QDFFN $T=496620 558320 1 180 $X=486080 $Y=557940
X176 359 2303 2623 1 2 QDFFN $T=488560 528080 1 0 $X=488560 $Y=522660
X177 351 2303 2569 1 2 QDFFN $T=499100 618800 1 180 $X=488560 $Y=618420
X178 381 2267 2593 1 2 QDFFN $T=500960 568400 1 180 $X=490420 $Y=568020
X179 305 2257 2596 1 2 QDFFN $T=500960 588560 1 180 $X=490420 $Y=588180
X180 346 467 2595 1 2 QDFFN $T=502200 507920 0 180 $X=491660 $Y=502500
X181 342 2346 2598 1 2 QDFFN $T=502200 548240 0 180 $X=491660 $Y=542820
X182 390 2257 2612 1 2 QDFFN $T=505300 598640 1 180 $X=494760 $Y=598260
X183 390 2267 2604 1 2 QDFFN $T=505920 598640 0 180 $X=495380 $Y=593220
X184 355 2303 2633 1 2 QDFFN $T=496620 558320 0 0 $X=496620 $Y=557940
X185 351 2257 2613 1 2 QDFFN $T=507160 618800 0 180 $X=496620 $Y=613380
X186 351 2267 2605 1 2 QDFFN $T=507780 608720 0 180 $X=497240 $Y=603300
X187 355 2267 2629 1 2 QDFFN $T=508400 558320 0 180 $X=497860 $Y=552900
X188 346 2267 2641 1 2 QDFFN $T=511500 568400 1 180 $X=500960 $Y=568020
X189 342 467 2617 1 2 QDFFN $T=512740 507920 0 180 $X=502200 $Y=502500
X190 359 2267 2643 1 2 QDFFN $T=512740 528080 0 180 $X=502200 $Y=522660
X191 359 2346 2632 1 2 QDFFN $T=502820 538160 1 0 $X=502820 $Y=532740
X192 355 2257 2667 1 2 QDFFN $T=518940 558320 0 180 $X=508400 $Y=552900
X193 342 2267 2679 1 2 QDFFN $T=520180 548240 0 180 $X=509640 $Y=542820
X194 342 458 2749 1 2 QDFFN $T=512740 507920 1 0 $X=512740 $Y=502500
X195 359 2257 2648 1 2 QDFFN $T=512740 528080 1 0 $X=512740 $Y=522660
X196 342 2257 2695 1 2 QDFFN $T=523900 538160 0 180 $X=513360 $Y=532740
X197 346 576 2793 1 2 QDFFN $T=527000 497840 0 0 $X=527000 $Y=497460
X198 3264 726 3269 1 2 QDFFN $T=593340 578480 0 0 $X=593340 $Y=578100
X199 3282 726 3305 1 2 QDFFN $T=597680 578480 1 0 $X=597680 $Y=573060
X200 3294 726 3260 1 2 QDFFN $T=597680 588560 0 0 $X=597680 $Y=588180
X201 3459 782 3394 1 2 QDFFN $T=628060 598640 0 180 $X=617520 $Y=593220
X202 3512 782 3430 1 2 QDFFN $T=634880 578480 1 180 $X=624340 $Y=578100
X203 777 788 3497 1 2 QDFFN $T=626200 598640 0 0 $X=626200 $Y=598260
X204 3496 782 3428 1 2 QDFFN $T=638600 568400 1 180 $X=628060 $Y=568020
X205 3492 782 3425 1 2 QDFFN $T=638600 578480 0 180 $X=628060 $Y=573060
X206 775 788 3554 1 2 QDFFN $T=630540 598640 1 0 $X=630540 $Y=593220
X207 778 788 3522 1 2 QDFFN $T=631780 588560 0 0 $X=631780 $Y=588180
X208 3475 788 3517 1 2 QDFFN $T=633640 568400 1 0 $X=633640 $Y=562980
X209 3484 788 3528 1 2 QDFFN $T=636120 588560 1 0 $X=636120 $Y=583140
X210 3502 788 3546 1 2 QDFFN $T=639840 548240 1 0 $X=639840 $Y=542820
X211 3530 782 3511 1 2 QDFFN $T=654720 578480 1 180 $X=644180 $Y=578100
X212 3548 782 3510 1 2 QDFFN $T=655340 558320 1 180 $X=644800 $Y=557940
X213 3512 821 3544 1 2 QDFFN $T=644800 598640 0 0 $X=644800 $Y=598260
X214 3567 782 3527 1 2 QDFFN $T=657820 578480 0 180 $X=647280 $Y=573060
X215 3530 821 3557 1 2 QDFFN $T=649140 588560 1 0 $X=649140 $Y=583140
X216 3582 821 3535 1 2 QDFFN $T=660920 558320 0 180 $X=650380 $Y=552900
X217 3582 782 3526 1 2 QDFFN $T=662160 548240 1 180 $X=651620 $Y=547860
X218 814 836 3618 1 2 QDFFN $T=655340 568400 1 0 $X=655340 $Y=562980
X219 3459 821 3566 1 2 QDFFN $T=667740 598640 1 180 $X=657200 $Y=598260
X220 3529 836 3620 1 2 QDFFN $T=659680 578480 1 0 $X=659680 $Y=573060
X221 3548 821 3622 1 2 QDFFN $T=662780 558320 0 0 $X=662780 $Y=557940
X222 3628 782 3552 1 2 QDFFN $T=673940 558320 0 180 $X=663400 $Y=552900
X223 3640 782 3581 1 2 QDFFN $T=675180 548240 1 180 $X=664640 $Y=547860
X224 3492 821 3602 1 2 QDFFN $T=678280 588560 0 180 $X=667740 $Y=583140
X225 858 862 3643 1 2 QDFFN $T=668980 608720 1 0 $X=668980 $Y=603300
X226 3657 782 3607 1 2 QDFFN $T=680140 598640 1 180 $X=669600 $Y=598260
X227 3661 836 3599 1 2 QDFFN $T=680760 518000 0 180 $X=670220 $Y=512580
X228 3658 782 3619 1 2 QDFFN $T=680760 598640 0 180 $X=670220 $Y=593220
X229 3496 821 3575 1 2 QDFFN $T=682620 578480 1 180 $X=672080 $Y=578100
X230 3625 836 3663 1 2 QDFFN $T=672700 528080 0 0 $X=672700 $Y=527700
X231 3657 880 3629 1 2 QDFFN $T=684480 628880 0 180 $X=673940 $Y=623460
X232 3638 836 3679 1 2 QDFFN $T=676420 538160 1 0 $X=676420 $Y=532740
X233 3691 782 3606 1 2 QDFFN $T=686960 548240 0 180 $X=676420 $Y=542820
X234 3640 821 3656 1 2 QDFFN $T=676420 548240 0 0 $X=676420 $Y=547860
X235 3578 836 3655 1 2 QDFFN $T=676420 568400 1 0 $X=676420 $Y=562980
X236 3648 836 3687 1 2 QDFFN $T=678280 528080 1 0 $X=678280 $Y=522660
X237 3567 821 3630 1 2 QDFFN $T=689440 578480 0 180 $X=678900 $Y=573060
X238 3658 880 3678 1 2 QDFFN $T=680760 618800 1 0 $X=680760 $Y=613380
X239 879 862 3698 1 2 QDFFN $T=682000 608720 1 0 $X=682000 $Y=603300
X240 882 836 3704 1 2 QDFFN $T=682620 518000 1 0 $X=682620 $Y=512580
X241 881 862 3673 1 2 QDFFN $T=682620 598640 0 0 $X=682620 $Y=598260
X242 3714 782 3671 1 2 QDFFN $T=693780 598640 0 180 $X=683240 $Y=593220
X243 3628 821 3650 1 2 QDFFN $T=696260 568400 1 180 $X=685720 $Y=568020
X244 3691 821 3680 1 2 QDFFN $T=699360 548240 0 180 $X=688820 $Y=542820
X245 3741 821 3695 1 2 QDFFN $T=699980 568400 0 180 $X=689440 $Y=562980
X246 3714 880 3696 1 2 QDFFN $T=700600 628880 0 180 $X=690060 $Y=623460
X247 3747 821 3633 1 2 QDFFN $T=701840 558320 0 180 $X=691300 $Y=552900
X248 3743 782 3701 1 2 QDFFN $T=701840 588560 1 180 $X=691300 $Y=588180
X249 3743 880 3716 1 2 QDFFN $T=704940 618800 0 180 $X=694400 $Y=613380
X250 899 836 3761 1 2 QDFFN $T=695640 507920 0 0 $X=695640 $Y=507540
X251 3767 782 3720 1 2 QDFFN $T=706180 598640 0 180 $X=695640 $Y=593220
X252 898 862 3755 1 2 QDFFN $T=695640 598640 0 0 $X=695640 $Y=598260
X253 910 862 3722 1 2 QDFFN $T=706180 608720 0 180 $X=695640 $Y=603300
X254 3721 836 3752 1 2 QDFFN $T=696260 518000 0 0 $X=696260 $Y=517620
X255 3717 836 3769 1 2 QDFFN $T=696260 528080 1 0 $X=696260 $Y=522660
X256 3777 788 3723 1 2 QDFFN $T=706800 548240 1 180 $X=696260 $Y=547860
X257 3790 788 3729 1 2 QDFFN $T=708040 528080 1 180 $X=697500 $Y=527700
X258 3793 788 3745 1 2 QDFFN $T=711760 568400 0 180 $X=701220 $Y=562980
X259 3759 788 3781 1 2 QDFFN $T=704320 538160 1 0 $X=704320 $Y=532740
X260 3819 782 3763 1 2 QDFFN $T=714860 588560 0 180 $X=704320 $Y=583140
X261 3816 782 3774 1 2 QDFFN $T=717340 598640 1 180 $X=706800 $Y=598260
X262 906 862 3812 1 2 QDFFN $T=706800 608720 1 0 $X=706800 $Y=603300
X263 3819 880 3783 1 2 QDFFN $T=719200 618800 1 180 $X=708660 $Y=618420
X264 3870 782 3809 1 2 QDFFN $T=724780 618800 0 180 $X=714240 $Y=613380
X265 913 862 3879 1 2 QDFFN $T=717340 608720 1 0 $X=717340 $Y=603300
X266 3767 880 3857 1 2 QDFFN $T=717340 628880 1 0 $X=717340 $Y=623460
X267 3878 782 3810 1 2 QDFFN $T=728500 588560 0 180 $X=717960 $Y=583140
X268 3907 782 3847 1 2 QDFFN $T=735320 598640 1 180 $X=724780 $Y=598260
X269 3816 880 3877 1 2 QDFFN $T=739040 618800 0 180 $X=728500 $Y=613380
X270 3929 782 3842 1 2 QDFFN $T=740280 608720 0 180 $X=729740 $Y=603300
X271 3870 880 3922 1 2 QDFFN $T=730360 628880 1 0 $X=730360 $Y=623460
X272 921 862 3919 1 2 QDFFN $T=735320 598640 0 0 $X=735320 $Y=598260
X273 3837 862 3954 1 2 QDFFN $T=742140 608720 0 0 $X=742140 $Y=608340
X274 3929 880 3943 1 2 QDFFN $T=752680 628880 0 180 $X=742140 $Y=623460
X275 3806 862 4005 1 2 QDFFN $T=745860 608720 1 0 $X=745860 $Y=603300
X276 3907 880 4006 1 2 QDFFN $T=750200 618800 1 0 $X=750200 $Y=613380
X277 929 862 3995 1 2 QDFFN $T=755160 608720 0 0 $X=755160 $Y=608340
X278 3940 862 4069 1 2 QDFFN $T=759500 608720 1 0 $X=759500 $Y=603300
X279 4026 862 4090 1 2 QDFFN $T=761980 618800 0 0 $X=761980 $Y=618420
X280 4042 862 4098 1 2 QDFFN $T=764460 618800 1 0 $X=764460 $Y=613380
X281 4065 862 4118 1 2 QDFFN $T=768800 608720 0 0 $X=768800 $Y=608340
X282 4086 862 4142 1 2 QDFFN $T=773140 608720 1 0 $X=773140 $Y=603300
X283 3878 880 4102 1 2 QDFFN $T=788640 618800 0 180 $X=778100 $Y=613380
X284 4127 862 4192 1 2 QDFFN $T=781820 608720 0 0 $X=781820 $Y=608340
X285 4269 880 4145 1 2 QDFFN $T=804760 618800 1 180 $X=794220 $Y=618420
X286 4283 880 4202 1 2 QDFFN $T=809720 618800 0 180 $X=799180 $Y=613380
X287 4282 880 4240 1 2 QDFFN $T=812820 628880 1 180 $X=802280 $Y=628500
X288 1021 1017 4252 1 2 QDFFN $T=814060 699440 0 180 $X=803520 $Y=694020
X289 4321 880 4103 1 2 QDFFN $T=814680 638960 0 180 $X=804140 $Y=633540
X290 4312 880 4165 1 2 QDFFN $T=818400 618800 1 180 $X=807860 $Y=618420
X291 1015 1017 4339 1 2 QDFFN $T=811580 659120 0 0 $X=811580 $Y=658740
X292 1016 1017 4333 1 2 QDFFN $T=811580 679280 1 0 $X=811580 $Y=673860
X293 1019 1017 4358 1 2 QDFFN $T=812820 669200 0 0 $X=812820 $Y=668820
X294 1020 1017 4340 1 2 QDFFN $T=814060 689360 0 0 $X=814060 $Y=688980
X295 4350 880 4176 1 2 QDFFN $T=826460 638960 1 180 $X=815920 $Y=638580
X296 1019 4309 4343 1 2 QDFFN $T=815920 669200 1 0 $X=815920 $Y=663780
X297 1020 4309 4351 1 2 QDFFN $T=816540 689360 1 0 $X=816540 $Y=683940
X298 1021 4309 4345 1 2 QDFFN $T=816540 699440 1 0 $X=816540 $Y=694020
X299 1015 4309 4366 1 2 QDFFN $T=819020 659120 1 0 $X=819020 $Y=653700
X300 1016 4309 4383 1 2 QDFFN $T=824600 679280 1 0 $X=824600 $Y=673860
X301 1015 1050 4375 1 2 QDFFN $T=841340 649040 0 180 $X=830800 $Y=643620
X302 1019 1050 4388 1 2 QDFFN $T=845680 659120 1 180 $X=835140 $Y=658740
X303 1016 1050 4395 1 2 QDFFN $T=845680 669200 1 180 $X=835140 $Y=668820
X304 1021 1050 1044 1 2 QDFFN $T=845680 699440 0 180 $X=835140 $Y=694020
X305 1048 1050 4446 1 2 QDFFN $T=837620 659120 1 0 $X=837620 $Y=653700
X306 1019 1055 4393 1 2 QDFFN $T=850020 669200 0 180 $X=839480 $Y=663780
X307 1020 1050 4410 1 2 QDFFN $T=850020 689360 1 180 $X=839480 $Y=688980
X308 1020 1055 4404 1 2 QDFFN $T=853740 689360 0 180 $X=843200 $Y=683940
X309 1016 1055 4413 1 2 QDFFN $T=854360 679280 1 180 $X=843820 $Y=678900
X310 1015 1055 4386 1 2 QDFFN $T=854980 649040 0 180 $X=844440 $Y=643620
X311 1021 1055 1063 1 2 QDFFN $T=847540 699440 1 0 $X=847540 $Y=694020
X312 1048 1017 4479 1 2 QDFFN $T=848160 659120 0 0 $X=848160 $Y=658740
X313 1048 4309 4494 1 2 QDFFN $T=850640 669200 0 0 $X=850640 $Y=668820
X314 1060 1055 1069 1 2 QDFFN $T=851260 689360 0 0 $X=851260 $Y=688980
X315 1060 1017 4524 1 2 QDFFN $T=856220 689360 1 0 $X=856220 $Y=683940
X316 1048 1055 4456 1 2 QDFFN $T=867380 659120 0 180 $X=856840 $Y=653700
X317 1060 4309 4521 1 2 QDFFN $T=856840 679280 0 0 $X=856840 $Y=678900
X318 1066 1017 4549 1 2 QDFFN $T=861180 659120 0 0 $X=861180 $Y=658740
X319 1066 4309 4547 1 2 QDFFN $T=861800 669200 0 0 $X=861800 $Y=668820
X320 1060 1050 1070 1 2 QDFFN $T=874200 689360 1 180 $X=863660 $Y=688980
X321 1074 4309 4571 1 2 QDFFN $T=867380 679280 0 0 $X=867380 $Y=678900
X322 1066 1055 4565 1 2 QDFFN $T=869240 649040 0 0 $X=869240 $Y=648660
X323 1066 1050 4583 1 2 QDFFN $T=870480 659120 1 0 $X=870480 $Y=653700
X324 1077 4309 4604 1 2 QDFFN $T=872340 669200 0 0 $X=872340 $Y=668820
X325 1074 1017 4597 1 2 QDFFN $T=872340 689360 1 0 $X=872340 $Y=683940
X326 1074 1055 1091 1 2 QDFFN $T=876060 689360 0 0 $X=876060 $Y=688980
X327 1080 1017 4624 1 2 QDFFN $T=877920 679280 1 0 $X=877920 $Y=673860
X328 1080 1050 1084 1 2 QDFFN $T=889700 699440 0 180 $X=879160 $Y=694020
X329 1077 1055 4596 1 2 QDFFN $T=894040 649040 1 180 $X=883500 $Y=648660
X330 1077 1050 4603 1 2 QDFFN $T=895900 659120 0 180 $X=885360 $Y=653700
X331 1077 1017 4611 1 2 QDFFN $T=897140 669200 0 180 $X=886600 $Y=663780
X332 1094 1017 4673 1 2 QDFFN $T=886600 669200 0 0 $X=886600 $Y=668820
X333 1080 1055 1095 1 2 QDFFN $T=898380 689360 1 180 $X=887840 $Y=688980
X334 1096 1017 4667 1 2 QDFFN $T=888460 679280 1 0 $X=888460 $Y=673860
X335 1080 1105 1098 1 2 QDFFN $T=900240 699440 0 180 $X=889700 $Y=694020
X336 1080 4309 4632 1 2 QDFFN $T=900860 689360 0 180 $X=890320 $Y=683940
X337 1094 1055 4713 1 2 QDFFN $T=897140 649040 0 0 $X=897140 $Y=648660
X338 1094 1050 4734 1 2 QDFFN $T=899000 659120 1 0 $X=899000 $Y=653700
X339 1096 4309 4674 1 2 QDFFN $T=909540 679280 0 180 $X=899000 $Y=673860
X340 1094 4309 4681 1 2 QDFFN $T=899620 669200 1 0 $X=899620 $Y=663780
X341 1108 1017 4719 1 2 QDFFN $T=900240 699440 1 0 $X=900240 $Y=694020
X342 1108 4309 4718 1 2 QDFFN $T=919460 689360 0 180 $X=908920 $Y=683940
X343 1120 1055 4784 1 2 QDFFN $T=911400 649040 0 0 $X=911400 $Y=648660
X344 1120 1050 4770 1 2 QDFFN $T=912020 659120 0 0 $X=912020 $Y=658740
X345 1096 1055 4729 1 2 QDFFN $T=922560 679280 0 180 $X=912020 $Y=673860
X346 1126 1050 4772 1 2 QDFFN $T=913880 669200 0 0 $X=913880 $Y=668820
X347 1096 1050 4743 1 2 QDFFN $T=928760 699440 0 180 $X=918220 $Y=694020
X348 1135 1055 4816 1 2 QDFFN $T=920700 689360 1 0 $X=920700 $Y=683940
X349 1126 1055 4794 1 2 QDFFN $T=921320 669200 1 0 $X=921320 $Y=663780
X350 1126 4309 4812 1 2 QDFFN $T=922560 679280 0 0 $X=922560 $Y=678900
X351 1120 4309 4802 1 2 QDFFN $T=940540 649040 1 180 $X=930000 $Y=648660
X352 1126 1017 4832 1 2 QDFFN $T=933100 669200 1 0 $X=933100 $Y=663780
X353 1120 1017 4821 1 2 QDFFN $T=936820 659120 0 0 $X=936820 $Y=658740
X354 1135 1017 4889 1 2 QDFFN $T=940540 679280 0 0 $X=940540 $Y=678900
X355 1135 4309 4883 1 2 QDFFN $T=941160 689360 0 0 $X=941160 $Y=688980
X356 1177 1174 4896 1 2 QDFFN $T=960380 659120 1 180 $X=949840 $Y=658740
X357 1177 1182 4922 1 2 QDFFN $T=965960 679280 1 180 $X=955420 $Y=678900
X358 1177 1185 4936 1 2 QDFFN $T=967820 669200 1 180 $X=957280 $Y=668820
X359 1177 1189 4949 1 2 QDFFN $T=970920 659120 0 180 $X=960380 $Y=653700
X360 1177 1191 1179 1 2 QDFFN $T=972160 689360 1 180 $X=961620 $Y=688980
X361 1190 1174 5026 1 2 QDFFN $T=968440 669200 1 0 $X=968440 $Y=663780
X362 1177 1197 1192 1 2 QDFFN $T=980220 689360 0 180 $X=969680 $Y=683940
X363 1190 1182 5024 1 2 QDFFN $T=970300 679280 0 0 $X=970300 $Y=678900
X364 1190 1189 5034 1 2 QDFFN $T=972780 659120 1 0 $X=972780 $Y=653700
X365 1190 1185 5000 1 2 QDFFN $T=983320 669200 1 180 $X=972780 $Y=668820
X366 1190 1191 5045 1 2 QDFFN $T=972780 699440 1 0 $X=972780 $Y=694020
X367 1200 1182 5072 1 2 QDFFN $T=980840 679280 1 0 $X=980840 $Y=673860
X368 1200 1185 5057 1 2 QDFFN $T=982080 669200 1 0 $X=982080 $Y=663780
X369 1190 1197 5069 1 2 QDFFN $T=982700 689360 0 0 $X=982700 $Y=688980
X370 1200 1189 5082 1 2 QDFFN $T=983940 659120 0 0 $X=983940 $Y=658740
X371 1200 1197 5090 1 2 QDFFN $T=984560 689360 1 0 $X=984560 $Y=683940
X372 1200 1174 5100 1 2 QDFFN $T=986420 649040 0 0 $X=986420 $Y=648660
X373 1210 1182 5143 1 2 QDFFN $T=993240 679280 1 0 $X=993240 $Y=673860
X374 1210 1185 5137 1 2 QDFFN $T=995100 669200 1 0 $X=995100 $Y=663780
X375 1200 1191 5080 1 2 QDFFN $T=1005640 689360 1 180 $X=995100 $Y=688980
X376 1210 1197 5160 1 2 QDFFN $T=998200 689360 1 0 $X=998200 $Y=683940
X377 1210 1189 5159 1 2 QDFFN $T=1000060 659120 1 0 $X=1000060 $Y=653700
X378 1210 1174 5149 1 2 QDFFN $T=1001920 649040 1 0 $X=1001920 $Y=643620
X379 1210 1191 5190 1 2 QDFFN $T=1006880 689360 0 0 $X=1006880 $Y=688980
X380 1222 1182 5198 1 2 QDFFN $T=1007500 679280 1 0 $X=1007500 $Y=673860
X381 1222 1185 5189 1 2 QDFFN $T=1008740 669200 1 0 $X=1008740 $Y=663780
X382 1222 1189 5215 1 2 QDFFN $T=1010600 659120 0 0 $X=1010600 $Y=658740
X383 1222 1197 5222 1 2 QDFFN $T=1012460 689360 1 0 $X=1012460 $Y=683940
X384 1222 1174 5232 1 2 QDFFN $T=1013700 649040 0 0 $X=1013700 $Y=648660
X385 1222 1191 5204 1 2 QDFFN $T=1027960 689360 1 180 $X=1017420 $Y=688980
X386 1230 1185 5266 1 2 QDFFN $T=1021760 669200 1 0 $X=1021760 $Y=663780
X387 1230 1182 5262 1 2 QDFFN $T=1021760 679280 1 0 $X=1021760 $Y=673860
X388 1230 1174 5274 1 2 QDFFN $T=1026100 649040 1 0 $X=1026100 $Y=643620
X389 1230 1197 5255 1 2 QDFFN $T=1036640 689360 0 180 $X=1026100 $Y=683940
X390 1230 1189 5297 1 2 QDFFN $T=1029200 659120 1 0 $X=1029200 $Y=653700
X391 1230 1191 5271 1 2 QDFFN $T=1041600 689360 1 180 $X=1031060 $Y=688980
X392 1239 1185 5292 1 2 QDFFN $T=1046560 669200 0 180 $X=1036020 $Y=663780
X393 1239 1182 5286 1 2 QDFFN $T=1046560 679280 1 180 $X=1036020 $Y=678900
X394 1239 1191 5348 1 2 QDFFN $T=1036020 699440 1 0 $X=1036020 $Y=694020
X395 1239 1174 5313 1 2 QDFFN $T=1050280 649040 0 180 $X=1039740 $Y=643620
X396 1239 1197 5361 1 2 QDFFN $T=1040360 689360 1 0 $X=1040360 $Y=683940
X397 1239 1189 5323 1 2 QDFFN $T=1054000 659120 0 180 $X=1043460 $Y=653700
X398 1243 1191 5412 1 2 QDFFN $T=1045320 689360 0 0 $X=1045320 $Y=688980
X399 1243 1185 5358 1 2 QDFFN $T=1060200 669200 0 180 $X=1049660 $Y=663780
X400 1243 1182 5364 1 2 QDFFN $T=1061440 679280 1 180 $X=1050900 $Y=678900
X401 1243 1174 5375 1 2 QDFFN $T=1064540 649040 0 180 $X=1054000 $Y=643620
X402 1243 1197 5416 1 2 QDFFN $T=1055860 689360 1 0 $X=1055860 $Y=683940
X403 1243 1189 5390 1 2 QDFFN $T=1067640 659120 0 180 $X=1057100 $Y=653700
X404 1252 1182 5437 1 2 QDFFN $T=1058960 679280 1 0 $X=1058960 $Y=673860
X405 1252 1189 5443 1 2 QDFFN $T=1060820 659120 0 0 $X=1060820 $Y=658740
X406 1252 1185 5451 1 2 QDFFN $T=1063920 669200 1 0 $X=1063920 $Y=663780
X407 1252 1197 5425 1 2 QDFFN $T=1076320 679280 1 180 $X=1065780 $Y=678900
X408 1252 1191 5442 1 2 QDFFN $T=1080040 689360 0 180 $X=1069500 $Y=683940
X409 1252 1174 5457 1 2 QDFFN $T=1070740 659120 1 0 $X=1070740 $Y=653700
X410 1270 1174 5467 1 2 QDFFN $T=1083140 659120 0 0 $X=1083140 $Y=658740
X411 1270 1189 5480 1 2 QDFFN $T=1083140 669200 1 0 $X=1083140 $Y=663780
X412 1270 1182 5500 1 2 QDFFN $T=1083140 679280 1 0 $X=1083140 $Y=673860
X413 1270 1185 5478 1 2 QDFFN $T=1083140 689360 1 0 $X=1083140 $Y=683940
X414 1270 1191 5460 1 2 QDFFN $T=1083140 689360 0 0 $X=1083140 $Y=688980
X415 42 35 1313 1340 1 1339 2 AOI22S $T=230640 528080 0 180 $X=226920 $Y=522660
X416 31 1357 1428 29 1 1394 2 AOI22S $T=242420 649040 0 0 $X=242420 $Y=648660
X417 30 100 1456 1452 1 97 2 AOI22S $T=248620 507920 0 180 $X=244900 $Y=502500
X418 42 1531 1528 1534 1 1547 2 AOI22S $T=257920 528080 1 0 $X=257920 $Y=522660
X419 1531 136 1446 1518 1 1559 2 AOI22S $T=260400 548240 0 0 $X=260400 $Y=547860
X420 95 153 150 1350 1 1593 2 AOI22S $T=267220 538160 1 0 $X=267220 $Y=532740
X421 1607 100 171 1618 1 136 2 AOI22S $T=274040 507920 1 0 $X=274040 $Y=502500
X422 35 153 1610 1624 1 1627 2 AOI22S $T=274660 528080 1 0 $X=274660 $Y=522660
X423 203 1531 1563 1685 1 1695 2 AOI22S $T=285820 518000 0 0 $X=285820 $Y=517620
X424 100 238 1750 90 1 235 2 AOI22S $T=303800 507920 0 180 $X=300080 $Y=502500
X425 100 238 1770 1765 1 1708 2 AOI22S $T=307520 507920 0 180 $X=303800 $Y=502500
X426 1531 136 1767 1766 1 1763 2 AOI22S $T=307520 548240 0 180 $X=303800 $Y=542820
X427 203 153 1829 1861 1 1808 2 AOI22S $T=326120 518000 0 0 $X=326120 $Y=517620
X428 1884 1898 1928 1957 1 1940 2 AOI22S $T=345960 588560 1 0 $X=345960 $Y=583140
X429 1922 1927 1941 1957 1 1940 2 AOI22S $T=347820 568400 1 0 $X=347820 $Y=562980
X430 1875 1939 1952 1957 1 1940 2 AOI22S $T=349680 538160 0 0 $X=349680 $Y=537780
X431 1926 1917 1953 1957 1 1940 2 AOI22S $T=349680 548240 0 0 $X=349680 $Y=547860
X432 1915 1942 1962 1957 1 1940 2 AOI22S $T=351540 598640 1 0 $X=351540 $Y=593220
X433 1944 1967 1966 1957 1 1940 2 AOI22S $T=354640 528080 0 0 $X=354640 $Y=527700
X434 1870 1975 1987 1957 1 1940 2 AOI22S $T=357120 578480 0 0 $X=357120 $Y=578100
X435 2025 2009 2030 1957 1 1940 2 AOI22S $T=363320 528080 1 180 $X=359600 $Y=527700
X436 1973 2005 1994 2008 1 2027 2 AOI22S $T=359600 578480 1 0 $X=359600 $Y=573060
X437 1998 2006 1979 2008 1 2027 2 AOI22S $T=359600 598640 1 0 $X=359600 $Y=593220
X438 1983 2017 1995 2008 1 2027 2 AOI22S $T=361460 548240 1 0 $X=361460 $Y=542820
X439 1986 2018 1996 2008 1 2027 2 AOI22S $T=361460 558320 1 0 $X=361460 $Y=552900
X440 2007 2019 1988 2008 1 2027 2 AOI22S $T=361460 568400 1 0 $X=361460 $Y=562980
X441 2015 2026 2020 2008 1 2027 2 AOI22S $T=362700 538160 0 0 $X=362700 $Y=537780
X442 2016 1958 2022 2008 1 2027 2 AOI22S $T=362700 588560 0 0 $X=362700 $Y=588180
X443 2048 2045 2051 1957 1 1940 2 AOI22S $T=373240 608720 0 0 $X=373240 $Y=608340
X444 2047 2057 2065 2008 1 2027 2 AOI22S $T=376960 618800 0 0 $X=376960 $Y=618420
X445 2069 2078 2029 2008 1 2027 2 AOI22S $T=381300 528080 0 0 $X=381300 $Y=527700
X446 2073 2074 2084 2008 1 2027 2 AOI22S $T=381920 538160 1 0 $X=381920 $Y=532740
X447 2087 2088 2097 2008 1 2027 2 AOI22S $T=385020 568400 1 0 $X=385020 $Y=562980
X448 2110 2101 2139 2008 1 2027 2 AOI22S $T=388740 618800 1 180 $X=385020 $Y=618420
X449 2116 2100 2125 2008 1 2027 2 AOI22S $T=389360 588560 1 180 $X=385640 $Y=588180
X450 2096 2126 2120 1957 1 1940 2 AOI22S $T=388740 588560 1 0 $X=388740 $Y=583140
X451 2102 2106 2121 1957 1 1940 2 AOI22S $T=388740 608720 0 0 $X=388740 $Y=608340
X452 2113 2132 2108 1957 1 1940 2 AOI22S $T=389980 538160 1 0 $X=389980 $Y=532740
X453 2119 2118 2133 2008 1 2027 2 AOI22S $T=390600 548240 0 0 $X=390600 $Y=547860
X454 2164 2161 2171 1957 1 1940 2 AOI22S $T=401140 608720 1 180 $X=397420 $Y=608340
X455 2142 2109 2160 1957 1 1940 2 AOI22S $T=398660 578480 1 0 $X=398660 $Y=573060
X456 2162 2154 2149 1957 1 1940 2 AOI22S $T=399280 548240 0 0 $X=399280 $Y=547860
X457 2105 2170 2167 1957 1 1940 2 AOI22S $T=400520 568400 1 0 $X=400520 $Y=562980
X458 2166 2172 2168 2008 1 2027 2 AOI22S $T=400520 618800 0 0 $X=400520 $Y=618420
X459 2183 2163 2181 1957 1 1940 2 AOI22S $T=404860 528080 1 180 $X=401140 $Y=527700
X460 2173 2176 2185 1957 1 1940 2 AOI22S $T=404240 538160 1 0 $X=404240 $Y=532740
X461 2178 2174 2186 1957 1 1940 2 AOI22S $T=404240 588560 0 0 $X=404240 $Y=588180
X462 2210 2123 2203 1957 1 1940 2 AOI22S $T=409200 568400 0 180 $X=405480 $Y=562980
X463 2220 2198 2226 2008 1 2027 2 AOI22S $T=411060 548240 1 180 $X=407340 $Y=547860
X464 2130 2201 2195 2008 1 2027 2 AOI22S $T=407960 538160 1 0 $X=407960 $Y=532740
X465 2225 2214 2219 1957 1 1940 2 AOI22S $T=412300 588560 1 180 $X=408580 $Y=588180
X466 2231 2218 2242 1957 1 1940 2 AOI22S $T=412920 608720 1 180 $X=409200 $Y=608340
X467 2233 2222 2236 2008 1 2027 2 AOI22S $T=414780 618800 1 180 $X=411060 $Y=618420
X468 2239 2202 2248 2008 1 2027 2 AOI22S $T=417880 568400 0 180 $X=414160 $Y=562980
X469 2228 2241 2235 2008 1 2027 2 AOI22S $T=414780 578480 0 0 $X=414780 $Y=578100
X470 2246 2244 2253 2008 1 2027 2 AOI22S $T=419740 618800 0 180 $X=416020 $Y=613380
X471 2266 2252 2263 2008 1 2027 2 AOI22S $T=421600 598640 0 180 $X=417880 $Y=593220
X472 2321 2314 2340 2309 1 2307 2 AOI22S $T=435240 588560 0 180 $X=431520 $Y=583140
X473 2294 2299 2311 2309 1 2307 2 AOI22S $T=432140 558320 1 0 $X=432140 $Y=552900
X474 2320 2315 2341 2309 1 2307 2 AOI22S $T=435860 608720 1 180 $X=432140 $Y=608340
X475 2316 2305 2328 2337 1 2366 2 AOI22S $T=435240 618800 1 0 $X=435240 $Y=613380
X476 2319 2324 2326 2351 1 2307 2 AOI22S $T=436480 538160 0 0 $X=436480 $Y=537780
X477 2331 2352 2339 2309 1 2307 2 AOI22S $T=437100 598640 0 0 $X=437100 $Y=598260
X478 2313 2362 2357 2351 1 2370 2 AOI22S $T=438960 528080 0 0 $X=438960 $Y=527700
X479 2384 2360 2353 2337 1 2366 2 AOI22S $T=443300 588560 1 180 $X=439580 $Y=588180
X480 2385 2361 2364 2309 1 2307 2 AOI22S $T=443300 608720 1 180 $X=439580 $Y=608340
X481 2363 2355 2347 2337 1 2366 2 AOI22S $T=440200 558320 0 0 $X=440200 $Y=557940
X482 2342 2348 2356 2309 1 2370 2 AOI22S $T=440200 568400 0 0 $X=440200 $Y=568020
X483 2433 2386 2354 2337 1 2366 2 AOI22S $T=445160 598640 0 180 $X=441440 $Y=593220
X484 2381 2304 2392 2309 1 2370 2 AOI22S $T=443300 568400 1 0 $X=443300 $Y=562980
X485 2397 2391 2376 2337 1 2366 2 AOI22S $T=447020 618800 0 180 $X=443300 $Y=613380
X486 2414 2405 2333 2406 1 2366 2 AOI22S $T=450120 538160 1 180 $X=446400 $Y=537780
X487 2427 2423 2425 2337 1 2413 2 AOI22S $T=453840 568400 1 180 $X=450120 $Y=568020
X488 2417 2421 2409 2337 1 2413 2 AOI22S $T=450120 578480 0 0 $X=450120 $Y=578100
X489 2451 2450 2394 2406 1 2413 2 AOI22S $T=462520 538160 0 180 $X=458800 $Y=532740
X490 2465 2471 2453 2452 1 2307 2 AOI22S $T=461900 608720 0 0 $X=461900 $Y=608340
X491 2519 2486 2508 2452 1 2307 2 AOI22S $T=469960 608720 1 180 $X=466240 $Y=608340
X492 2503 2493 2479 428 1 457 2 AOI22S $T=471200 507920 1 180 $X=467480 $Y=507540
X493 2475 2491 2488 2436 1 2413 2 AOI22S $T=467480 558320 1 0 $X=467480 $Y=552900
X494 2489 2481 2460 2436 1 2366 2 AOI22S $T=468100 618800 1 0 $X=468100 $Y=613380
X495 2498 2499 2515 2406 1 2413 2 AOI22S $T=474920 528080 1 180 $X=471200 $Y=527700
X496 2555 2506 2520 2406 1 2413 2 AOI22S $T=477400 538160 1 180 $X=473680 $Y=537780
X497 2541 2522 2525 2436 1 2366 2 AOI22S $T=478020 618800 0 180 $X=474300 $Y=613380
X498 2509 2529 2510 2351 1 2370 2 AOI22S $T=474920 528080 0 0 $X=474920 $Y=527700
X499 2485 2470 2523 2436 1 2413 2 AOI22S $T=474920 568400 0 0 $X=474920 $Y=568020
X500 2490 2540 2538 2436 1 2366 2 AOI22S $T=478020 578480 0 0 $X=478020 $Y=578100
X501 2548 2536 2517 2351 1 2370 2 AOI22S $T=482360 528080 1 180 $X=478640 $Y=527700
X502 2544 2524 470 428 1 457 2 AOI22S $T=480500 507920 1 0 $X=480500 $Y=502500
X503 2531 2530 2501 2436 1 2413 2 AOI22S $T=481740 578480 0 0 $X=481740 $Y=578100
X504 2565 2545 2561 2436 1 2366 2 AOI22S $T=485460 598640 0 180 $X=481740 $Y=593220
X505 2564 2569 2583 2436 1 2366 2 AOI22S $T=487940 618800 0 180 $X=484220 $Y=613380
X506 2516 2571 2513 2452 1 2370 2 AOI22S $T=489180 568400 0 180 $X=485460 $Y=562980
X507 2595 2560 478 428 1 457 2 AOI22S $T=491660 497840 1 180 $X=487940 $Y=497460
X508 2598 2587 2599 2406 1 2366 2 AOI22S $T=491660 548240 0 180 $X=487940 $Y=542820
X509 2612 2604 2600 2452 1 2307 2 AOI22S $T=494760 608720 0 180 $X=491040 $Y=603300
X510 2613 2605 2580 2452 1 2307 2 AOI22S $T=494760 608720 1 180 $X=491040 $Y=608340
X511 2617 2607 2611 428 1 457 2 AOI22S $T=495380 497840 1 180 $X=491660 $Y=497460
X512 2616 2593 2494 2452 1 2370 2 AOI22S $T=496620 578480 0 180 $X=492900 $Y=573060
X513 2632 2623 2628 2406 1 2366 2 AOI22S $T=499100 538160 0 180 $X=495380 $Y=532740
X514 2596 2584 2567 2452 1 2307 2 AOI22S $T=496000 578480 0 0 $X=496000 $Y=578100
X515 2568 2633 2624 2406 1 2366 2 AOI22S $T=497860 548240 0 0 $X=497860 $Y=547860
X516 2648 2643 2609 2351 1 2307 2 AOI22S $T=502820 538160 0 180 $X=499100 $Y=532740
X517 2577 2641 2558 2452 1 2370 2 AOI22S $T=499100 568400 1 0 $X=499100 $Y=562980
X518 2667 2629 2622 2351 1 2307 2 AOI22S $T=505920 548240 0 180 $X=502200 $Y=542820
X519 2695 2679 2650 2351 1 2307 2 AOI22S $T=509640 548240 0 180 $X=505920 $Y=542820
X520 540 2749 2640 449 1 450 2 AOI22S $T=520800 497840 1 180 $X=517080 $Y=497460
X521 2799 2743 2746 2760 1 2715 2 AOI22S $T=523280 618800 0 180 $X=519560 $Y=613380
X522 2793 552 2647 449 1 450 2 AOI22S $T=525140 497840 1 180 $X=521420 $Y=497460
X523 562 574 2812 570 1 2748 2 AOI22S $T=530100 689360 1 180 $X=526380 $Y=688980
X524 2777 2813 2834 2807 1 2690 2 AOI22S $T=530720 638960 1 180 $X=527000 $Y=638580
X525 598 574 2838 586 1 2808 2 AOI22S $T=536920 679280 0 180 $X=533200 $Y=673860
X526 573 2886 2881 2876 1 2829 2 AOI22S $T=542500 649040 1 180 $X=538780 $Y=648660
X527 3012 655 3023 598 1 2981 2 AOI22S $T=558620 628880 1 0 $X=558620 $Y=623460
X528 684 622 3057 515 1 2777 2 AOI22S $T=572880 689360 0 180 $X=569160 $Y=683940
X529 591 3147 3198 3183 1 583 2 AOI22S $T=582800 669200 1 180 $X=579080 $Y=668820
X530 704 693 3033 598 1 700 2 AOI22S $T=584660 689360 1 180 $X=580940 $Y=688980
X531 3216 591 3224 586 1 3182 2 AOI22S $T=585280 659120 0 180 $X=581560 $Y=653700
X532 704 3203 2970 3200 1 644 2 AOI22S $T=585280 669200 0 180 $X=581560 $Y=663780
X533 2981 712 3241 2777 1 3030 2 AOI22S $T=589620 628880 0 180 $X=585900 $Y=623460
X534 3200 706 3142 714 1 3203 2 AOI22S $T=586520 659120 1 0 $X=586520 $Y=653700
X535 714 3240 3252 3234 1 3223 2 AOI22S $T=591480 638960 1 180 $X=587760 $Y=638580
X536 718 573 3217 3253 1 3235 2 AOI22S $T=590240 669200 1 0 $X=590240 $Y=663780
X537 714 2791 2951 725 1 684 2 AOI22S $T=590240 699440 1 0 $X=590240 $Y=694020
X538 3012 598 3247 724 1 3261 2 AOI22S $T=592720 628880 1 0 $X=592720 $Y=623460
X539 3197 3200 728 3291 1 2886 2 AOI22S $T=595820 618800 1 0 $X=595820 $Y=613380
X540 3291 611 3333 714 1 2813 2 AOI22S $T=601400 679280 0 180 $X=597680 $Y=673860
X541 2886 3200 3302 3320 1 3324 2 AOI22S $T=601400 608720 0 0 $X=601400 $Y=608340
X542 3339 3030 3334 2806 1 3215 2 AOI22S $T=606980 618800 0 180 $X=603260 $Y=613380
X543 718 3014 3311 3325 1 3338 2 AOI22S $T=605120 659120 0 0 $X=605120 $Y=658740
X544 3030 3147 3309 3349 1 3352 2 AOI22S $T=606980 628880 1 0 $X=606980 $Y=623460
X545 3322 2791 3348 761 1 3351 2 AOI22S $T=615040 628880 1 180 $X=611320 $Y=628500
X546 3216 3012 3398 3391 1 3390 2 AOI22S $T=619380 628880 0 180 $X=615660 $Y=623460
X547 3200 2791 3416 724 1 3390 2 AOI22S $T=621240 628880 0 0 $X=621240 $Y=628500
X548 3355 706 3437 2791 1 3424 2 AOI22S $T=624960 659120 1 180 $X=621240 $Y=658740
X549 2791 3355 3366 3203 1 693 2 AOI22S $T=623100 649040 0 0 $X=623100 $Y=648660
X550 3012 3376 3443 3203 1 3411 2 AOI22S $T=627440 608720 1 180 $X=623720 $Y=608340
X551 2777 3438 3435 3122 1 3436 2 AOI22S $T=624340 618800 0 0 $X=624340 $Y=618420
X552 712 3313 3461 3449 1 704 2 AOI22S $T=631160 669200 1 180 $X=627440 $Y=668820
X553 3448 3457 2893 3449 1 3465 2 AOI22S $T=627440 679280 1 0 $X=627440 $Y=673860
X554 3473 3306 3453 3355 1 3390 2 AOI22S $T=633020 618800 1 180 $X=629300 $Y=618420
X555 3466 3472 3471 3480 1 3371 2 AOI22S $T=631160 608720 1 0 $X=631160 $Y=603300
X556 3365 3438 3420 3465 1 3203 2 AOI22S $T=635500 628880 1 0 $X=635500 $Y=623460
X557 3365 3322 3323 3424 1 3494 2 AOI22S $T=636120 649040 0 0 $X=636120 $Y=648660
X558 3122 3306 3518 3313 1 3355 2 AOI22S $T=644800 669200 0 180 $X=641080 $Y=663780
X559 3203 718 3462 3406 1 3532 2 AOI22S $T=647280 689360 1 0 $X=647280 $Y=683940
X560 3313 3438 3446 3533 1 3494 2 AOI22S $T=648520 669200 1 0 $X=648520 $Y=663780
X561 3200 817 3525 3533 1 3539 2 AOI22S $T=649760 669200 0 0 $X=649760 $Y=668820
X562 3545 3558 3551 3568 1 3565 2 AOI22S $T=655340 628880 0 0 $X=655340 $Y=628500
X563 3561 3540 833 3568 1 3565 2 AOI22S $T=656580 628880 1 0 $X=656580 $Y=623460
X564 3569 3571 838 3568 1 3565 2 AOI22S $T=658440 649040 0 0 $X=658440 $Y=648660
X565 842 845 3574 846 1 848 2 AOI22S $T=659680 699440 1 0 $X=659680 $Y=694020
X566 3605 3598 855 3568 1 3565 2 AOI22S $T=667120 628880 0 180 $X=663400 $Y=623460
X567 3583 3595 3592 3568 1 3565 2 AOI22S $T=663400 638960 1 0 $X=663400 $Y=633540
X568 850 3597 3591 846 1 848 2 AOI22S $T=663400 689360 0 0 $X=663400 $Y=688980
X569 3584 3584 852 3568 1 3565 2 AOI22S $T=664020 659120 1 0 $X=664020 $Y=653700
X570 3580 3600 3613 864 1 848 2 AOI22S $T=670220 669200 1 0 $X=670220 $Y=663780
X571 3615 3603 3626 3568 1 3565 2 AOI22S $T=672080 659120 1 0 $X=672080 $Y=653700
X572 3632 3634 3609 3568 1 3565 2 AOI22S $T=675800 638960 1 0 $X=675800 $Y=633540
X573 3635 3653 3651 3568 1 3565 2 AOI22S $T=678900 649040 1 0 $X=678900 $Y=643620
X574 3641 3659 3649 864 1 848 2 AOI22S $T=682000 669200 0 0 $X=682000 $Y=668820
X575 3668 3652 3670 3568 1 3565 2 AOI22S $T=682620 638960 0 0 $X=682620 $Y=638580
X576 3684 3684 3682 3568 1 3565 2 AOI22S $T=687580 638960 0 0 $X=687580 $Y=638580
X577 3675 3686 3705 3568 1 3565 2 AOI22S $T=692540 638960 0 0 $X=692540 $Y=638580
X578 3713 3692 3715 3568 1 3565 2 AOI22S $T=694400 638960 1 0 $X=694400 $Y=633540
X579 3703 3693 3676 864 1 848 2 AOI22S $T=694400 669200 1 0 $X=694400 $Y=663780
X580 907 904 3738 901 1 848 2 AOI22S $T=701220 699440 0 180 $X=697500 $Y=694020
X581 3749 3740 3739 901 1 848 2 AOI22S $T=702460 669200 0 180 $X=698740 $Y=663780
X582 3712 3751 3746 3568 1 3565 2 AOI22S $T=701220 638960 0 0 $X=701220 $Y=638580
X583 3732 3737 3765 3568 1 3565 2 AOI22S $T=704940 638960 1 0 $X=704940 $Y=633540
X584 916 3689 3782 901 1 848 2 AOI22S $T=711760 689360 0 180 $X=708040 $Y=683940
X585 911 3750 3775 901 1 848 2 AOI22S $T=708660 689360 0 0 $X=708660 $Y=688980
X586 3780 3771 3801 3568 1 3565 2 AOI22S $T=711140 649040 1 0 $X=711140 $Y=643620
X587 3797 3770 3803 3568 1 3565 2 AOI22S $T=711760 638960 1 0 $X=711760 $Y=633540
X588 3742 3825 3829 3568 1 3565 2 AOI22S $T=718580 649040 1 0 $X=718580 $Y=643620
X589 3824 3827 3832 864 1 848 2 AOI22S $T=719200 669200 1 0 $X=719200 $Y=663780
X590 3858 3822 3852 3568 1 3565 2 AOI22S $T=725400 638960 1 180 $X=721680 $Y=638580
X591 3754 3880 3873 3568 1 3565 2 AOI22S $T=728500 649040 1 0 $X=728500 $Y=643620
X592 935 3881 3869 901 1 848 2 AOI22S $T=728500 689360 0 0 $X=728500 $Y=688980
X593 3886 3897 3895 3568 1 3565 2 AOI22S $T=732220 638960 0 0 $X=732220 $Y=638580
X594 940 3915 3901 901 1 848 2 AOI22S $T=734080 699440 1 0 $X=734080 $Y=694020
X595 3872 3920 3909 846 1 848 2 AOI22S $T=735320 669200 0 0 $X=735320 $Y=668820
X596 3776 3934 3941 3568 1 3565 2 AOI22S $T=742140 638960 1 0 $X=742140 $Y=633540
X597 3918 3947 3949 864 1 848 2 AOI22S $T=745860 669200 1 0 $X=745860 $Y=663780
X598 3904 3964 3963 3568 1 3565 2 AOI22S $T=747100 638960 0 0 $X=747100 $Y=638580
X599 3992 3993 3999 864 1 848 2 AOI22S $T=756400 669200 0 180 $X=752680 $Y=663780
X600 3973 3965 3991 3568 1 3565 2 AOI22S $T=753920 649040 1 0 $X=753920 $Y=643620
X601 955 956 3985 901 1 848 2 AOI22S $T=754540 699440 1 0 $X=754540 $Y=694020
X602 3953 4007 4003 3568 1 3565 2 AOI22S $T=755780 638960 0 0 $X=755780 $Y=638580
X603 961 960 4028 846 1 848 2 AOI22S $T=762600 699440 0 180 $X=758880 $Y=694020
X604 4014 4040 4033 3568 1 3565 2 AOI22S $T=765700 638960 0 0 $X=765700 $Y=638580
X605 3970 4057 4053 3568 1 3565 2 AOI22S $T=766320 638960 1 0 $X=766320 $Y=633540
X606 4014 4047 4064 3568 1 3565 2 AOI22S $T=767560 649040 1 0 $X=767560 $Y=643620
X607 4023 4072 4063 901 1 848 2 AOI22S $T=768180 669200 1 0 $X=768180 $Y=663780
X608 4101 4080 976 3568 1 3565 2 AOI22S $T=776240 649040 0 180 $X=772520 $Y=643620
X609 4101 4104 979 3568 1 3565 2 AOI22S $T=776240 649040 1 0 $X=776240 $Y=643620
X610 4111 4123 4096 846 1 848 2 AOI22S $T=779960 669200 0 0 $X=779960 $Y=668820
X611 4124 4099 4149 3568 1 3565 2 AOI22S $T=784920 638960 1 0 $X=784920 $Y=633540
X612 4146 4152 988 3568 1 3565 2 AOI22S $T=784920 649040 1 0 $X=784920 $Y=643620
X613 4174 4162 4177 901 1 848 2 AOI22S $T=790500 669200 1 180 $X=786780 $Y=668820
X614 993 4051 4126 846 1 848 2 AOI22S $T=786780 689360 0 0 $X=786780 $Y=688980
X615 4159 4194 997 3568 1 3565 2 AOI22S $T=791740 638960 0 0 $X=791740 $Y=638580
X616 4206 4201 4185 901 1 848 2 AOI22S $T=795460 669200 0 180 $X=791740 $Y=663780
X617 4172 4204 1001 3568 1 3565 2 AOI22S $T=793600 659120 1 0 $X=793600 $Y=653700
X618 4241 4226 1005 3568 1 3565 2 AOI22S $T=800420 638960 1 180 $X=796700 $Y=638580
X619 4239 4233 1008 3568 1 3565 2 AOI22S $T=801660 649040 1 180 $X=797940 $Y=648660
X620 4351 4340 4360 1036 1 1034 2 AOI22S $T=827080 689360 0 0 $X=827080 $Y=688980
X621 4383 4333 4381 1036 1 1034 2 AOI22S $T=832660 689360 0 180 $X=828940 $Y=683940
X622 4345 4252 1035 1036 1 1034 2 AOI22S $T=828940 699440 1 0 $X=828940 $Y=694020
X623 4366 4339 4354 1036 1 1034 2 AOI22S $T=829560 659120 0 0 $X=829560 $Y=658740
X624 4343 4358 4368 1036 1 1034 2 AOI22S $T=829560 669200 1 0 $X=829560 $Y=663780
X625 4375 4386 4364 1042 1 1043 2 AOI22S $T=832660 649040 0 0 $X=832660 $Y=648660
X626 4388 4393 4391 1042 1 1043 2 AOI22S $T=833900 669200 1 0 $X=833900 $Y=663780
X627 4410 4404 4389 1042 1 1043 2 AOI22S $T=838240 689360 1 180 $X=834520 $Y=688980
X628 4395 4413 4406 1042 1 1043 2 AOI22S $T=837620 679280 0 0 $X=837620 $Y=678900
X629 4446 4456 4452 1042 1 1043 2 AOI22S $T=850020 649040 0 0 $X=850020 $Y=648660
X630 4494 4479 4467 1036 1 1034 2 AOI22S $T=858700 669200 0 180 $X=854980 $Y=663780
X631 4521 4524 1073 1036 1 1034 2 AOI22S $T=868000 689360 1 0 $X=868000 $Y=683940
X632 4547 4549 4562 1036 1 1034 2 AOI22S $T=874200 669200 0 180 $X=870480 $Y=663780
X633 4583 4565 4572 1042 1 1043 2 AOI22S $T=877920 659120 1 180 $X=874200 $Y=658740
X634 4603 4596 4599 1042 1 1043 2 AOI22S $T=884120 659120 1 180 $X=880400 $Y=658740
X635 4604 4611 4592 1036 1 1034 2 AOI22S $T=886600 669200 1 180 $X=882880 $Y=668820
X636 4571 4597 1088 1036 1 1034 2 AOI22S $T=882880 689360 1 0 $X=882880 $Y=683940
X637 4632 4624 1097 1036 1 1034 2 AOI22S $T=890320 689360 0 180 $X=886600 $Y=683940
X638 4681 4673 4684 1036 1 1034 2 AOI22S $T=900860 669200 1 180 $X=897140 $Y=668820
X639 4674 4667 4680 1036 1 1034 2 AOI22S $T=899620 679280 0 0 $X=899620 $Y=678900
X640 1127 1124 1125 1042 1 1043 2 AOI22S $T=914500 699440 0 180 $X=910780 $Y=694020
X641 4743 4729 4696 1042 1 1043 2 AOI22S $T=915120 679280 1 180 $X=911400 $Y=678900
X642 4734 4713 4695 1042 1 1043 2 AOI22S $T=912640 669200 1 0 $X=912640 $Y=663780
X643 4718 4719 1128 1036 1 1034 2 AOI22S $T=914500 699440 1 0 $X=914500 $Y=694020
X644 4770 4784 4780 1042 1 1043 2 AOI22S $T=925040 659120 1 0 $X=925040 $Y=653700
X645 4772 4794 4781 1042 1 1043 2 AOI22S $T=926900 669200 0 0 $X=926900 $Y=668820
X646 1145 4816 4824 1042 1 1043 2 AOI22S $T=935580 689360 1 180 $X=931860 $Y=688980
X647 4802 4821 4806 1036 1 1034 2 AOI22S $T=933100 659120 0 0 $X=933100 $Y=658740
X648 4812 4832 4814 1036 1 1034 2 AOI22S $T=938680 679280 0 180 $X=934960 $Y=673860
X649 4883 4889 4836 1036 1 1034 2 AOI22S $T=948600 689360 1 0 $X=948600 $Y=683940
X650 4949 4896 4950 1042 1 1043 2 AOI22S $T=962240 659120 0 0 $X=962240 $Y=658740
X651 4922 4936 4946 1036 1 1034 2 AOI22S $T=965960 679280 0 0 $X=965960 $Y=678900
X652 5024 5000 4982 1036 1 1034 2 AOI22S $T=980840 679280 0 180 $X=977120 $Y=673860
X653 5034 5026 4985 1042 1 1043 2 AOI22S $T=982700 659120 1 180 $X=978980 $Y=658740
X654 5069 5045 1206 1205 1 1204 2 AOI22S $T=989520 699440 0 180 $X=985800 $Y=694020
X655 5072 5057 5079 1036 1 1034 2 AOI22S $T=990140 669200 1 180 $X=986420 $Y=668820
X656 5090 5080 5113 1205 1 1204 2 AOI22S $T=995100 699440 0 180 $X=991380 $Y=694020
X657 5082 5100 5089 1042 1 1043 2 AOI22S $T=996960 659120 0 0 $X=996960 $Y=658740
X658 5143 5137 5148 1036 1 1034 2 AOI22S $T=1005640 669200 1 180 $X=1001920 $Y=668820
X659 5159 5149 5146 1042 1 1043 2 AOI22S $T=1008740 659120 1 180 $X=1005020 $Y=658740
X660 5198 5189 5221 1036 1 1034 2 AOI22S $T=1017420 669200 1 180 $X=1013700 $Y=668820
X661 5160 5190 5180 1205 1 1204 2 AOI22S $T=1014320 699440 1 0 $X=1014320 $Y=694020
X662 5222 5204 5214 1205 1 1204 2 AOI22S $T=1020520 699440 1 0 $X=1020520 $Y=694020
X663 5215 5232 5231 1042 1 1043 2 AOI22S $T=1022380 659120 0 0 $X=1022380 $Y=658740
X664 5262 5266 5254 1036 1 1034 2 AOI22S $T=1029200 669200 0 0 $X=1029200 $Y=668820
X665 5255 5271 5263 1205 1 1204 2 AOI22S $T=1030440 699440 1 0 $X=1030440 $Y=694020
X666 5297 5274 5260 1042 1 1043 2 AOI22S $T=1034780 659120 1 180 $X=1031060 $Y=658740
X667 5286 5292 5296 1036 1 1034 2 AOI22S $T=1037260 669200 0 0 $X=1037260 $Y=668820
X668 5323 5313 5318 1042 1 1043 2 AOI22S $T=1042840 659120 0 0 $X=1042840 $Y=658740
X669 5361 5348 5377 1205 1 1204 2 AOI22S $T=1051520 699440 0 180 $X=1047800 $Y=694020
X670 5364 5358 5372 1036 1 1034 2 AOI22S $T=1053380 679280 0 180 $X=1049660 $Y=673860
X671 5390 5375 5376 1042 1 1043 2 AOI22S $T=1058340 659120 1 180 $X=1054620 $Y=658740
X672 5416 5412 5409 1205 1 1204 2 AOI22S $T=1063300 689360 0 0 $X=1063300 $Y=688980
X673 5425 5442 1260 1205 1 1204 2 AOI22S $T=1070120 699440 1 0 $X=1070120 $Y=694020
X674 5437 5451 5448 1036 1 1034 2 AOI22S $T=1071980 679280 1 0 $X=1071980 $Y=673860
X675 5443 5457 5455 1042 1 1043 2 AOI22S $T=1073840 659120 0 0 $X=1073840 $Y=658740
X676 1275 5460 5464 1205 1 1204 2 AOI22S $T=1078800 699440 0 180 $X=1075080 $Y=694020
X677 5480 5467 5470 1042 1 1043 2 AOI22S $T=1081900 659120 1 180 $X=1078180 $Y=658740
X678 5500 5478 5473 1036 1 1034 2 AOI22S $T=1083760 679280 1 180 $X=1080040 $Y=678900
X679 1304 1297 1 2 1298 AN2 $T=223820 628880 0 180 $X=221340 $Y=623460
X680 1316 1298 1 2 1299 AN2 $T=223820 638960 0 180 $X=221340 $Y=633540
X681 1319 1299 1 2 1300 AN2 $T=223820 638960 1 180 $X=221340 $Y=638580
X682 1300 1311 1 2 1294 AN2 $T=223820 649040 1 180 $X=221340 $Y=648660
X683 1301 1294 1 2 1312 AN2 $T=221340 669200 1 0 $X=221340 $Y=663780
X684 1302 1306 1 2 12 AN2 $T=221340 689360 0 0 $X=221340 $Y=688980
X685 21 1331 1 2 1317 AN2 $T=226920 538160 1 180 $X=224440 $Y=537780
X686 55 26 1 2 1357 AN2 $T=233740 649040 0 180 $X=231260 $Y=643620
X687 1449 1444 1 2 1418 AN2 $T=246140 659120 0 180 $X=243660 $Y=653700
X688 120 1386 1 2 1464 AN2 $T=251100 558320 0 180 $X=248620 $Y=552900
X689 1552 1558 1 2 1567 AN2 $T=265360 628880 1 0 $X=265360 $Y=623460
X690 1384 155 1 2 149 AN2 $T=269700 507920 0 180 $X=267220 $Y=502500
X691 1567 1574 1 2 1565 AN2 $T=267220 638960 1 0 $X=267220 $Y=633540
X692 1583 1586 1 2 160 AN2 $T=267220 689360 0 0 $X=267220 $Y=688980
X693 162 151 1 2 1523 AN2 $T=271560 628880 1 180 $X=269080 $Y=628500
X694 1590 1585 1 2 1596 AN2 $T=269080 649040 0 0 $X=269080 $Y=648660
X695 1602 1596 1 2 1578 AN2 $T=271560 669200 1 180 $X=269080 $Y=668820
X696 1582 1578 1 2 1586 AN2 $T=271560 679280 0 180 $X=269080 $Y=673860
X697 1608 1603 1 2 1539 AN2 $T=273420 628880 0 180 $X=270940 $Y=623460
X698 186 151 1 2 1524 AN2 $T=278380 638960 1 180 $X=275900 $Y=638580
X699 183 151 1 2 1571 AN2 $T=278380 649040 0 180 $X=275900 $Y=643620
X700 177 28 1 2 1641 AN2 $T=276520 497840 0 0 $X=276520 $Y=497460
X701 1704 1666 1 2 1686 AN2 $T=290160 618800 0 180 $X=287680 $Y=613380
X702 211 1537 1 2 1548 AN2 $T=298840 518000 1 180 $X=296360 $Y=517620
X703 1720 236 1 2 1762 AN2 $T=300080 588560 0 0 $X=300080 $Y=588180
X704 1755 236 1 2 1738 AN2 $T=303180 598640 1 0 $X=303180 $Y=593220
X705 1821 236 1 2 1838 AN2 $T=319920 669200 1 0 $X=319920 $Y=663780
X706 1824 236 1 2 1820 AN2 $T=323020 638960 1 180 $X=320540 $Y=638580
X707 165 274 1 2 1793 AN2 $T=332940 518000 0 180 $X=330460 $Y=512580
X708 273 236 1 2 1869 AN2 $T=333560 699440 1 0 $X=333560 $Y=694020
X709 1892 1895 1 2 1909 AN2 $T=335420 659120 0 0 $X=335420 $Y=658740
X710 289 292 1 2 1877 AN2 $T=336040 507920 0 0 $X=336040 $Y=507540
X711 1902 1907 1 2 1895 AN2 $T=339140 649040 0 0 $X=339140 $Y=648660
X712 1900 1909 1 2 1901 AN2 $T=341000 659120 0 0 $X=341000 $Y=658740
X713 1905 1901 1 2 1916 AN2 $T=341000 679280 0 0 $X=341000 $Y=678900
X714 1919 1916 1 2 301 AN2 $T=343480 689360 1 180 $X=341000 $Y=688980
X715 313 1908 1 2 1911 AN2 $T=344720 649040 1 180 $X=342240 $Y=648660
X716 307 1908 1 2 1881 AN2 $T=344720 659120 0 180 $X=342240 $Y=653700
X717 1912 1913 1 2 1907 AN2 $T=346580 649040 0 180 $X=344100 $Y=643620
X718 314 1908 1 2 1886 AN2 $T=346580 669200 0 180 $X=344100 $Y=663780
X719 1935 1932 1 2 1912 AN2 $T=347820 638960 1 180 $X=345340 $Y=638580
X720 1930 1933 1 2 317 AN2 $T=351540 669200 0 180 $X=349060 $Y=663780
X721 328 326 1 2 1956 AN2 $T=355260 507920 1 180 $X=352780 $Y=507540
X722 1963 1923 1 2 332 AN2 $T=354640 497840 0 0 $X=354640 $Y=497460
X723 1979 1962 1 2 1989 AN2 $T=355880 598640 1 0 $X=355880 $Y=593220
X724 1994 1987 1 2 1982 AN2 $T=358980 578480 0 180 $X=356500 $Y=573060
X725 1988 1941 1 2 2003 AN2 $T=357740 568400 1 0 $X=357740 $Y=562980
X726 1995 1952 1 2 2010 AN2 $T=359600 538160 0 0 $X=359600 $Y=537780
X727 1996 1953 1 2 2021 AN2 $T=359600 548240 0 0 $X=359600 $Y=547860
X728 2004 1991 1 2 1932 AN2 $T=362080 638960 0 180 $X=359600 $Y=633540
X729 2029 2030 1 2 2036 AN2 $T=364560 528080 1 0 $X=364560 $Y=522660
X730 2020 1966 1 2 2038 AN2 $T=364560 538160 1 0 $X=364560 $Y=532740
X731 2022 1928 1 2 2044 AN2 $T=367660 588560 0 0 $X=367660 $Y=588180
X732 1977 1976 1 2 2039 AN2 $T=373860 649040 1 180 $X=371380 $Y=648660
X733 2055 2058 1 2 2064 AN2 $T=375100 649040 0 0 $X=375100 $Y=648660
X734 2052 2059 1 2 2056 AN2 $T=375100 679280 0 0 $X=375100 $Y=678900
X735 2056 2049 1 2 2072 AN2 $T=375720 689360 1 0 $X=375720 $Y=683940
X736 2065 2051 1 2 2091 AN2 $T=378200 608720 0 0 $X=378200 $Y=608340
X737 2082 2050 1 2 2095 AN2 $T=382540 669200 0 0 $X=382540 $Y=668820
X738 2084 2108 1 2 2115 AN2 $T=386880 538160 1 0 $X=386880 $Y=532740
X739 2093 2124 1 2 372 AN2 $T=388740 679280 1 0 $X=388740 $Y=673860
X740 2125 2120 1 2 2135 AN2 $T=389980 588560 0 0 $X=389980 $Y=588180
X741 2086 2072 1 2 2140 AN2 $T=389980 679280 0 0 $X=389980 $Y=678900
X742 2139 2121 1 2 2151 AN2 $T=393700 608720 0 0 $X=393700 $Y=608340
X743 2133 2149 1 2 2157 AN2 $T=395560 548240 0 0 $X=395560 $Y=547860
X744 384 2050 1 2 2055 AN2 $T=400520 659120 0 0 $X=400520 $Y=658740
X745 2168 2171 1 2 2197 AN2 $T=402380 608720 0 0 $X=402380 $Y=608340
X746 2193 384 1 2 2107 AN2 $T=407340 679280 0 180 $X=404860 $Y=673860
X747 2195 2181 1 2 2207 AN2 $T=407340 528080 0 0 $X=407340 $Y=527700
X748 2196 2150 1 2 2211 AN2 $T=407340 689360 1 0 $X=407340 $Y=683940
X749 2223 2215 1 2 2205 AN2 $T=411680 649040 1 180 $X=409200 $Y=648660
X750 2097 2167 1 2 2227 AN2 $T=411060 568400 1 0 $X=411060 $Y=562980
X751 2140 2184 1 2 2196 AN2 $T=411680 689360 1 0 $X=411680 $Y=683940
X752 2221 2211 1 2 2238 AN2 $T=412300 679280 1 0 $X=412300 $Y=673860
X753 2226 2185 1 2 2265 AN2 $T=412920 538160 0 0 $X=412920 $Y=537780
X754 389 2117 1 2 2247 AN2 $T=416020 679280 1 0 $X=416020 $Y=673860
X755 2236 2242 1 2 2251 AN2 $T=417260 608720 0 0 $X=417260 $Y=608340
X756 2248 2203 1 2 2258 AN2 $T=419120 568400 1 0 $X=419120 $Y=562980
X757 2235 2160 1 2 2272 AN2 $T=419120 578480 0 0 $X=419120 $Y=578100
X758 2253 2186 1 2 2268 AN2 $T=420360 618800 1 0 $X=420360 $Y=613380
X759 406 2262 1 2 345 AN2 $T=423460 507920 1 180 $X=420980 $Y=507540
X760 406 2230 1 2 410 AN2 $T=422840 497840 0 0 $X=422840 $Y=497460
X761 2263 2219 1 2 2283 AN2 $T=422840 598640 1 0 $X=422840 $Y=593220
X762 2261 2238 1 2 2289 AN2 $T=425940 679280 0 0 $X=425940 $Y=678900
X763 2292 2289 1 2 2318 AN2 $T=431520 679280 0 0 $X=431520 $Y=678900
X764 2322 2318 1 2 2358 AN2 $T=436480 679280 0 0 $X=436480 $Y=678900
X765 2388 2230 1 2 371 AN2 $T=443920 497840 1 180 $X=441440 $Y=497460
X766 2365 2358 1 2 2398 AN2 $T=443300 679280 0 0 $X=443300 $Y=678900
X767 425 408 1 2 2406 AN2 $T=443920 538160 0 0 $X=443920 $Y=537780
X768 2230 425 1 2 2370 AN2 $T=445160 528080 0 0 $X=445160 $Y=527700
X769 404 425 1 2 2309 AN2 $T=448260 558320 0 180 $X=445780 $Y=552900
X770 2262 425 1 2 2413 AN2 $T=447640 528080 0 0 $X=447640 $Y=527700
X771 404 425 1 2 2351 AN2 $T=450120 538160 0 180 $X=447640 $Y=532740
X772 2396 2398 1 2 2426 AN2 $T=450120 679280 0 0 $X=450120 $Y=678900
X773 425 408 1 2 2337 AN2 $T=453840 558320 1 0 $X=453840 $Y=552900
X774 425 408 1 2 2436 AN2 $T=453840 568400 1 0 $X=453840 $Y=562980
X775 2438 2426 1 2 2455 AN2 $T=456940 679280 0 0 $X=456940 $Y=678900
X776 404 425 1 2 2452 AN2 $T=457560 548240 0 0 $X=457560 $Y=547860
X777 2467 2455 1 2 2482 AN2 $T=463760 679280 0 0 $X=463760 $Y=678900
X778 2496 2482 1 2 2514 AN2 $T=469960 679280 0 0 $X=469960 $Y=678900
X779 2534 2514 1 2 2553 AN2 $T=480500 679280 0 0 $X=480500 $Y=678900
X780 2559 2553 1 2 2563 AN2 $T=484220 689360 1 0 $X=484220 $Y=683940
X781 2554 2563 1 2 2590 AN2 $T=487320 689360 1 0 $X=487320 $Y=683940
X782 2606 2603 1 2 2589 AN2 $T=493520 669200 0 180 $X=491040 $Y=663780
X783 2597 2590 1 2 2608 AN2 $T=492900 689360 1 0 $X=492900 $Y=683940
X784 2614 2608 1 2 2603 AN2 $T=494140 669200 0 0 $X=494140 $Y=668820
X785 2697 2691 1 2 2713 AN2 $T=509640 649040 0 0 $X=509640 $Y=648660
X786 2737 523 1 2 2797 AN2 $T=523280 598640 0 0 $X=523280 $Y=598260
X787 2737 548 1 2 2779 AN2 $T=523280 608720 0 0 $X=523280 $Y=608340
X788 2779 2761 1 2 562 AN2 $T=523280 659120 1 0 $X=523280 $Y=653700
X789 2712 2819 1 2 2792 AN2 $T=530720 618800 0 180 $X=528240 $Y=613380
X790 2797 2787 1 2 591 AN2 $T=532580 659120 1 0 $X=532580 $Y=653700
X791 328 548 1 2 2862 AN2 $T=539400 598640 0 180 $X=536920 $Y=593220
X792 2864 2738 1 2 2886 AN2 $T=541880 608720 0 0 $X=541880 $Y=608340
X793 319 2875 1 2 2919 AN2 $T=542500 628880 1 0 $X=542500 $Y=623460
X794 2885 2891 1 2 2930 AN2 $T=543740 578480 1 0 $X=543740 $Y=573060
X795 2875 2696 1 2 2937 AN2 $T=545600 628880 1 0 $X=545600 $Y=623460
X796 2930 2915 1 2 2942 AN2 $T=546220 578480 1 0 $X=546220 $Y=573060
X797 2857 2733 1 2 2974 AN2 $T=547460 608720 0 0 $X=547460 $Y=608340
X798 2849 2953 1 2 2962 AN2 $T=549320 618800 0 0 $X=549320 $Y=618420
X799 2985 277 1 2 3007 AN2 $T=554280 558320 1 0 $X=554280 $Y=552900
X800 3023 3000 1 2 2965 AN2 $T=557380 628880 1 180 $X=554900 $Y=628500
X801 2819 2802 1 2 3014 AN2 $T=556140 618800 0 0 $X=556140 $Y=618420
X802 2986 2718 1 2 655 AN2 $T=557380 638960 0 0 $X=557380 $Y=638580
X803 3057 3049 1 2 3043 AN2 $T=563580 649040 0 180 $X=561100 $Y=643620
X804 3142 3076 1 2 3101 AN2 $T=572880 649040 1 180 $X=570400 $Y=648660
X805 536 705 1 2 3162 AN2 $T=585900 679280 1 180 $X=583420 $Y=678900
X806 3241 3247 1 2 3249 AN2 $T=590240 628880 1 0 $X=590240 $Y=623460
X807 3331 3305 1 2 3275 AN2 $T=604500 568400 0 180 $X=602020 $Y=562980
X808 3117 3095 1 2 3289 AN2 $T=609460 598640 0 180 $X=606980 $Y=593220
X809 3020 3117 1 2 3375 AN2 $T=611940 598640 1 0 $X=611940 $Y=593220
X810 3353 629 1 2 2945 AN2 $T=613180 558320 0 0 $X=613180 $Y=557940
X811 3168 3091 1 2 3093 AN2 $T=613800 608720 1 0 $X=613800 $Y=603300
X812 3404 277 1 2 3441 AN2 $T=628680 568400 0 180 $X=626200 $Y=562980
X813 3447 3330 1 2 791 AN2 $T=627440 558320 0 0 $X=627440 $Y=557940
X814 3525 3518 1 2 3423 AN2 $T=647900 669200 0 180 $X=645420 $Y=663780
X815 686 3073 1 2 766 AN2 $T=655340 649040 1 180 $X=652860 $Y=648660
X816 277 631 1 2 3433 AN2 $T=659060 507920 1 180 $X=656580 $Y=507540
X817 3553 3556 1 2 3608 AN2 $T=663400 618800 0 0 $X=663400 $Y=618420
X818 3593 3573 1 2 3610 AN2 $T=666500 628880 0 0 $X=666500 $Y=628500
X819 3608 3616 1 2 3593 AN2 $T=670840 628880 0 180 $X=668360 $Y=623460
X820 3610 3590 1 2 3624 AN2 $T=668360 638960 1 0 $X=668360 $Y=633540
X821 3611 3612 1 2 3636 AN2 $T=673320 649040 0 0 $X=673320 $Y=648660
X822 3624 3623 1 2 3611 AN2 $T=673940 638960 0 0 $X=673940 $Y=638580
X823 3636 3644 1 2 3666 AN2 $T=680140 638960 0 0 $X=680140 $Y=638580
X824 3685 3702 1 2 3731 AN2 $T=695640 628880 0 0 $X=695640 $Y=628500
X825 3666 3700 1 2 3727 AN2 $T=695640 649040 1 0 $X=695640 $Y=643620
X826 3727 3733 1 2 3735 AN2 $T=698120 638960 0 0 $X=698120 $Y=638580
X827 3731 3758 1 2 3778 AN2 $T=704320 628880 1 0 $X=704320 $Y=623460
X828 277 631 1 2 3828 AN2 $T=706180 578480 1 0 $X=706180 $Y=573060
X829 277 631 1 2 912 AN2 $T=711760 518000 0 180 $X=709280 $Y=512580
X830 3735 3785 1 2 3800 AN2 $T=709280 638960 0 0 $X=709280 $Y=638580
X831 277 631 1 2 3799 AN2 $T=709900 608720 0 0 $X=709900 $Y=608340
X832 3804 753 1 2 3807 AN2 $T=712380 608720 0 0 $X=712380 $Y=608340
X833 3778 3784 1 2 3814 AN2 $T=713000 628880 1 0 $X=713000 $Y=623460
X834 3800 3808 1 2 3820 AN2 $T=715480 649040 1 0 $X=715480 $Y=643620
X835 3817 708 1 2 523 AN2 $T=722300 518000 1 0 $X=722300 $Y=512580
X836 3814 3838 1 2 3863 AN2 $T=724780 638960 1 0 $X=724780 $Y=633540
X837 3820 3860 1 2 3868 AN2 $T=725400 649040 1 0 $X=725400 $Y=643620
X838 3849 3890 1 2 3894 AN2 $T=730360 528080 0 0 $X=730360 $Y=527700
X839 3823 3890 1 2 3911 AN2 $T=731600 538160 1 0 $X=731600 $Y=532740
X840 3899 3890 1 2 3892 AN2 $T=733460 528080 0 0 $X=733460 $Y=527700
X841 3863 3891 1 2 3935 AN2 $T=738420 628880 0 0 $X=738420 $Y=628500
X842 3868 3923 1 2 3944 AN2 $T=739040 649040 1 0 $X=739040 $Y=643620
X843 3935 3950 1 2 3967 AN2 $T=746480 638960 1 0 $X=746480 $Y=633540
X844 3885 3890 1 2 3990 AN2 $T=752060 528080 0 0 $X=752060 $Y=527700
X845 3843 3890 1 2 3986 AN2 $T=752060 558320 1 0 $X=752060 $Y=552900
X846 3944 3977 1 2 3984 AN2 $T=752060 638960 1 0 $X=752060 $Y=633540
X847 3966 3890 1 2 3997 AN2 $T=753920 538160 1 0 $X=753920 $Y=532740
X848 3958 3890 1 2 4024 AN2 $T=757640 568400 0 0 $X=757640 $Y=568020
X849 3967 3982 1 2 4021 AN2 $T=758880 638960 1 0 $X=758880 $Y=633540
X850 3925 3890 1 2 4030 AN2 $T=760740 548240 1 0 $X=760740 $Y=542820
X851 3928 3890 1 2 4112 AN2 $T=760740 558320 0 0 $X=760740 $Y=557940
X852 3945 3890 1 2 4046 AN2 $T=760740 578480 0 0 $X=760740 $Y=578100
X853 4021 4029 1 2 4043 AN2 $T=762600 638960 1 0 $X=762600 $Y=633540
X854 4009 3890 1 2 4082 AN2 $T=769420 588560 1 0 $X=769420 $Y=583140
X855 4139 4133 1 2 4089 AN2 $T=783680 638960 0 180 $X=781200 $Y=633540
X856 4043 4110 1 2 4166 AN2 $T=783060 628880 0 0 $X=783060 $Y=628500
X857 4150 4143 1 2 4179 AN2 $T=788020 538160 1 0 $X=788020 $Y=532740
X858 3969 3890 1 2 4170 AN2 $T=788020 588560 1 0 $X=788020 $Y=583140
X859 4186 4182 1 2 4143 AN2 $T=792360 538160 1 180 $X=789880 $Y=537780
X860 4166 4171 1 2 4195 AN2 $T=791120 638960 1 0 $X=791120 $Y=633540
X861 4163 4179 1 2 4203 AN2 $T=791740 518000 0 0 $X=791740 $Y=517620
X862 4178 4169 1 2 4187 AN2 $T=794220 507920 1 0 $X=794220 $Y=502500
X863 998 4187 1 2 1002 AN2 $T=797320 497840 1 180 $X=794840 $Y=497460
X864 4223 4217 1 2 4169 AN2 $T=799180 507920 0 180 $X=796700 $Y=502500
X865 4216 4213 1 2 4242 AN2 $T=798560 558320 0 0 $X=798560 $Y=557940
X866 4195 4183 1 2 4244 AN2 $T=798560 649040 1 0 $X=798560 $Y=643620
X867 4224 4219 1 2 4182 AN2 $T=802280 538160 1 180 $X=799800 $Y=537780
X868 4245 4242 1 2 4219 AN2 $T=802280 548240 1 180 $X=799800 $Y=547860
X869 4220 4214 1 2 4213 AN2 $T=804140 568400 0 180 $X=801660 $Y=562980
X870 4237 4243 1 2 4214 AN2 $T=801660 578480 1 0 $X=801660 $Y=573060
X871 4251 4249 1 2 4139 AN2 $T=804140 638960 1 180 $X=801660 $Y=638580
X872 4244 4248 1 2 4251 AN2 $T=801660 649040 1 0 $X=801660 $Y=643620
X873 4261 4254 1 2 4243 AN2 $T=806000 568400 1 180 $X=803520 $Y=568020
X874 4270 4274 1 2 4217 AN2 $T=810960 507920 0 180 $X=808480 $Y=502500
X875 4314 4292 1 2 4254 AN2 $T=815920 568400 1 180 $X=813440 $Y=568020
X876 4303 4296 1 2 4274 AN2 $T=817780 507920 1 180 $X=815300 $Y=507540
X877 4120 3890 1 2 4318 AN2 $T=817160 598640 1 0 $X=817160 $Y=593220
X878 4341 4334 1 2 4296 AN2 $T=824600 497840 1 180 $X=822120 $Y=497460
X879 4348 4353 1 2 4292 AN2 $T=828320 568400 1 180 $X=825840 $Y=568020
X880 4364 4354 1 2 1030 AN2 $T=828320 659120 1 180 $X=825840 $Y=658740
X881 4391 4368 1 2 1032 AN2 $T=831420 669200 1 180 $X=828940 $Y=668820
X882 4373 4376 1 2 4334 AN2 $T=833280 497840 1 180 $X=830800 $Y=497460
X883 4382 4380 1 2 4353 AN2 $T=833280 578480 0 180 $X=830800 $Y=573060
X884 4389 4360 1 2 1039 AN2 $T=834520 689360 1 180 $X=832040 $Y=688980
X885 4049 3890 1 2 4400 AN2 $T=833900 598640 0 0 $X=833900 $Y=598260
X886 4406 4381 1 2 1041 AN2 $T=836380 689360 0 180 $X=833900 $Y=683940
X887 4407 4405 1 2 4380 AN2 $T=837620 568400 1 180 $X=835140 $Y=568020
X888 4409 1047 1 2 4376 AN2 $T=838240 497840 1 180 $X=835760 $Y=497460
X889 4423 3890 1 2 4439 AN2 $T=844440 598640 0 0 $X=844440 $Y=598260
X890 4444 4443 1 2 4407 AN2 $T=848780 578480 0 180 $X=846300 $Y=573060
X891 4452 4467 1 2 1058 AN2 $T=853740 669200 0 180 $X=851260 $Y=663780
X892 4480 4475 1 2 1057 AN2 $T=856840 497840 1 180 $X=854360 $Y=497460
X893 4483 4477 1 2 4444 AN2 $T=856840 578480 0 180 $X=854360 $Y=573060
X894 4317 3890 1 2 4487 AN2 $T=854980 588560 0 0 $X=854980 $Y=588180
X895 4519 4512 1 2 4475 AN2 $T=865520 497840 1 180 $X=863040 $Y=497460
X896 4517 4513 1 2 4483 AN2 $T=865520 568400 1 180 $X=863040 $Y=568020
X897 1075 4535 1 2 4512 AN2 $T=870480 497840 1 180 $X=868000 $Y=497460
X898 4552 4555 1 2 4517 AN2 $T=876060 568400 0 180 $X=873580 $Y=562980
X899 4581 4575 1 2 4555 AN2 $T=879160 568400 0 180 $X=876680 $Y=562980
X900 4572 4562 1 2 1083 AN2 $T=876680 669200 1 0 $X=876680 $Y=663780
X901 4594 1086 1 2 1075 AN2 $T=882880 497840 1 180 $X=880400 $Y=497460
X902 4599 4592 1 2 1085 AN2 $T=882880 669200 0 180 $X=880400 $Y=663780
X903 4379 4573 1 2 4618 AN2 $T=882260 568400 0 0 $X=882260 $Y=568020
X904 4610 4614 1 2 4617 AN2 $T=884740 548240 0 0 $X=884740 $Y=547860
X905 4605 4474 1 2 4591 AN2 $T=885360 598640 0 0 $X=885360 $Y=598260
X906 4623 4626 1 2 4575 AN2 $T=889700 568400 0 180 $X=887220 $Y=562980
X907 1100 4625 1 2 4594 AN2 $T=891560 497840 1 180 $X=889080 $Y=497460
X908 4629 4630 1 2 4636 AN2 $T=889080 558320 1 0 $X=889080 $Y=552900
X909 4622 4636 1 2 4623 AN2 $T=891560 558320 1 180 $X=889080 $Y=557940
X910 4635 4474 1 2 4649 AN2 $T=890320 538160 1 0 $X=890320 $Y=532740
X911 4654 1103 1 2 1100 AN2 $T=894660 497840 1 180 $X=892180 $Y=497460
X912 4645 4649 1 2 4670 AN2 $T=895280 538160 1 0 $X=895280 $Y=532740
X913 4679 4474 1 2 4652 AN2 $T=900860 598640 0 0 $X=900860 $Y=598260
X914 4695 4684 1 2 1111 AN2 $T=903960 669200 1 180 $X=901480 $Y=668820
X915 4690 4701 1 2 4654 AN2 $T=906440 497840 1 180 $X=903960 $Y=497460
X916 4703 4474 1 2 4676 AN2 $T=906440 528080 1 180 $X=903960 $Y=527700
X917 4696 4680 1 2 1114 AN2 $T=904580 679280 0 0 $X=904580 $Y=678900
X918 4730 4474 1 2 4686 AN2 $T=908300 568400 1 180 $X=905820 $Y=568020
X919 4659 1106 1 2 4692 AN2 $T=910160 518000 1 0 $X=910160 $Y=512580
X920 4750 4474 1 2 4705 AN2 $T=918840 548240 0 180 $X=916360 $Y=542820
X921 4760 4474 1 2 4717 AN2 $T=920080 548240 1 180 $X=917600 $Y=547860
X922 4739 4474 1 2 4723 AN2 $T=919460 538160 1 0 $X=919460 $Y=532740
X923 4732 4798 1 2 4753 AN2 $T=928140 578480 0 0 $X=928140 $Y=578100
X924 4627 4798 1 2 4809 AN2 $T=930000 588560 0 0 $X=930000 $Y=588180
X925 4631 4798 1 2 4810 AN2 $T=930000 608720 1 0 $X=930000 $Y=603300
X926 4648 4798 1 2 4811 AN2 $T=930000 618800 1 0 $X=930000 $Y=613380
X927 4671 4798 1 2 4826 AN2 $T=930000 628880 0 0 $X=930000 $Y=628500
X928 4780 4806 1 2 1140 AN2 $T=932480 659120 0 180 $X=930000 $Y=653700
X929 4781 4814 1 2 1141 AN2 $T=933720 679280 0 180 $X=931240 $Y=673860
X930 4824 4836 1 2 1146 AN2 $T=938060 689360 1 180 $X=935580 $Y=688980
X931 4822 4817 1 2 4833 AN2 $T=938060 518000 1 0 $X=938060 $Y=512580
X932 4691 4798 1 2 4844 AN2 $T=938060 618800 1 0 $X=938060 $Y=613380
X933 4837 4833 1 2 4846 AN2 $T=939920 507920 0 0 $X=939920 $Y=507540
X934 4830 4798 1 2 4861 AN2 $T=941160 618800 1 0 $X=941160 $Y=613380
X935 4874 4872 1 2 4817 AN2 $T=947360 518000 1 180 $X=944880 $Y=517620
X936 4875 4892 1 2 4882 AN2 $T=951080 598640 0 180 $X=948600 $Y=593220
X937 4886 4882 1 2 4880 AN2 $T=950460 588560 1 0 $X=950460 $Y=583140
X938 4905 4912 1 2 4872 AN2 $T=953560 507920 1 0 $X=953560 $Y=502500
X939 4920 4921 1 2 4892 AN2 $T=957900 598640 0 180 $X=955420 $Y=593220
X940 4876 4798 1 2 4939 AN2 $T=955420 628880 1 0 $X=955420 $Y=623460
X941 4950 4946 1 2 1176 AN2 $T=961620 679280 0 180 $X=959140 $Y=673860
X942 4943 4951 1 2 4912 AN2 $T=962860 507920 1 180 $X=960380 $Y=507540
X943 4964 4962 1 2 4921 AN2 $T=964720 598640 1 180 $X=962240 $Y=598260
X944 4976 4967 1 2 4951 AN2 $T=967820 518000 0 180 $X=965340 $Y=512580
X945 4961 4958 1 2 4962 AN2 $T=967200 588560 0 0 $X=967200 $Y=588180
X946 4985 4982 1 2 1188 AN2 $T=969680 679280 0 180 $X=967200 $Y=673860
X947 4994 4991 1 2 4958 AN2 $T=971540 588560 0 180 $X=969060 $Y=583140
X948 5004 5001 1 2 4967 AN2 $T=974640 507920 1 180 $X=972160 $Y=507540
X949 4952 4798 1 2 4978 AN2 $T=972160 628880 1 0 $X=972160 $Y=623460
X950 5017 5012 1 2 5001 AN2 $T=978360 507920 1 180 $X=975880 $Y=507540
X951 4791 4798 1 2 5023 AN2 $T=977740 608720 0 0 $X=977740 $Y=608340
X952 5022 5032 1 2 4991 AN2 $T=983320 598640 0 180 $X=980840 $Y=593220
X953 5031 5038 1 2 5032 AN2 $T=985180 588560 1 180 $X=982700 $Y=588180
X954 5066 5062 1 2 5038 AN2 $T=990140 598640 0 180 $X=987660 $Y=593220
X955 5075 5070 1 2 5012 AN2 $T=992000 507920 1 180 $X=989520 $Y=507540
X956 4721 4798 1 2 5055 AN2 $T=992000 628880 0 180 $X=989520 $Y=623460
X957 5102 5096 1 2 5070 AN2 $T=996960 507920 1 180 $X=994480 $Y=507540
X958 5089 5079 1 2 5101 AN2 $T=994480 669200 0 0 $X=994480 $Y=668820
X959 5126 5125 1 2 5062 AN2 $T=1002540 598640 0 180 $X=1000060 $Y=593220
X960 5077 4798 1 2 5119 AN2 $T=1005020 628880 0 180 $X=1002540 $Y=623460
X961 5133 5142 1 2 5125 AN2 $T=1005640 598640 0 180 $X=1003160 $Y=593220
X962 5152 5153 1 2 5096 AN2 $T=1009360 518000 0 180 $X=1006880 $Y=512580
X963 5146 5148 1 2 5156 AN2 $T=1006880 669200 0 0 $X=1006880 $Y=668820
X964 5169 5161 1 2 5152 AN2 $T=1010600 507920 1 180 $X=1008120 $Y=507540
X965 5173 5172 1 2 5142 AN2 $T=1012460 588560 0 180 $X=1009980 $Y=583140
X966 5153 5169 1 2 5182 AN2 $T=1011840 507920 0 0 $X=1011840 $Y=507540
X967 5183 4798 1 2 5196 AN2 $T=1014940 628880 1 0 $X=1014940 $Y=623460
X968 5134 5192 1 2 5235 AN2 $T=1020520 588560 1 0 $X=1020520 $Y=583140
X969 5138 5192 1 2 5234 AN2 $T=1021760 578480 1 0 $X=1021760 $Y=573060
X970 5231 5221 1 2 5202 AN2 $T=1024240 669200 1 180 $X=1021760 $Y=668820
X971 5249 5242 1 2 5169 AN2 $T=1026100 507920 0 180 $X=1023620 $Y=502500
X972 5071 5192 1 2 5247 AN2 $T=1023620 578480 0 0 $X=1023620 $Y=578100
X973 5258 5253 1 2 5172 AN2 $T=1027960 588560 0 180 $X=1025480 $Y=583140
X974 5260 5254 1 2 5239 AN2 $T=1027960 669200 1 180 $X=1025480 $Y=668820
X975 5246 5252 1 2 5253 AN2 $T=1027340 578480 1 0 $X=1027340 $Y=573060
X976 5264 4798 1 2 5281 AN2 $T=1030440 548240 0 0 $X=1030440 $Y=547860
X977 5244 4798 1 2 5270 AN2 $T=1030440 628880 1 0 $X=1030440 $Y=623460
X978 4752 4798 1 2 5295 AN2 $T=1032300 618800 0 0 $X=1032300 $Y=618420
X979 1219 1235 1 2 1238 AN2 $T=1034160 507920 0 0 $X=1034160 $Y=507540
X980 5282 5277 1 2 5307 AN2 $T=1034160 568400 1 0 $X=1034160 $Y=562980
X981 5290 5285 1 2 5252 AN2 $T=1036640 578480 0 180 $X=1034160 $Y=573060
X982 5298 5299 1 2 5242 AN2 $T=1039740 507920 0 180 $X=1037260 $Y=502500
X983 5276 1237 1 2 5319 AN2 $T=1037260 538160 1 0 $X=1037260 $Y=532740
X984 5291 5301 1 2 5285 AN2 $T=1039740 588560 0 180 $X=1037260 $Y=583140
X985 1242 5310 1 2 5299 AN2 $T=1041600 497840 1 180 $X=1039120 $Y=497460
X986 5316 5322 1 2 5301 AN2 $T=1043460 598640 0 180 $X=1040980 $Y=593220
X987 5318 5296 1 2 5370 AN2 $T=1042220 669200 0 0 $X=1042220 $Y=668820
X988 5344 5338 1 2 5351 AN2 $T=1047800 568400 0 0 $X=1047800 $Y=568020
X989 5345 5351 1 2 5352 AN2 $T=1047800 578480 1 0 $X=1047800 $Y=573060
X990 5367 5359 1 2 5322 AN2 $T=1052140 588560 1 180 $X=1049660 $Y=588180
X991 5366 5365 1 2 5310 AN2 $T=1053380 507920 0 180 $X=1050900 $Y=502500
X992 4749 4798 1 2 5373 AN2 $T=1050900 628880 1 0 $X=1050900 $Y=623460
X993 1250 1248 1 2 5365 AN2 $T=1055240 497840 1 180 $X=1052760 $Y=497460
X994 5376 5372 1 2 5386 AN2 $T=1054620 679280 1 0 $X=1054620 $Y=673860
X995 5405 5413 1 2 1255 AN2 $T=1063920 497840 1 180 $X=1061440 $Y=497460
X996 5445 4798 1 2 5406 AN2 $T=1070740 548240 0 180 $X=1068260 $Y=542820
X997 1262 1261 1 2 5413 AN2 $T=1073840 497840 1 180 $X=1071360 $Y=497460
X998 5449 4798 1 2 5385 AN2 $T=1076940 588560 1 180 $X=1074460 $Y=588180
X999 5461 4798 1 2 5444 AN2 $T=1077560 558320 1 180 $X=1075080 $Y=557940
X1000 5465 4798 1 2 5452 AN2 $T=1078800 548240 0 180 $X=1076320 $Y=542820
X1001 5455 5448 1 2 1265 AN2 $T=1076320 679280 1 0 $X=1076320 $Y=673860
X1002 5469 4798 1 2 5428 AN2 $T=1080660 608720 0 180 $X=1078180 $Y=603300
X1003 5474 4798 1 2 5436 AN2 $T=1082520 588560 0 180 $X=1080040 $Y=583140
X1004 5470 5473 1 2 5486 AN2 $T=1080040 669200 0 0 $X=1080040 $Y=668820
X1005 1805 1370 1 2 INV4CK $T=334800 578480 0 180 $X=331080 $Y=573060
X1006 2343 2213 1 2 INV4CK $T=443920 507920 0 180 $X=440200 $Y=502500
X1007 2416 2190 1 2 INV4CK $T=450740 568400 0 180 $X=447020 $Y=562980
X1008 2424 2234 1 2 INV4CK $T=458180 528080 0 180 $X=454460 $Y=522660
X1009 2401 2277 1 2 INV4CK $T=458800 538160 0 180 $X=455080 $Y=532740
X1010 2350 2473 1 2 INV4CK $T=465000 548240 0 180 $X=461280 $Y=542820
X1011 2472 2187 1 2 INV4CK $T=469340 518000 1 0 $X=469340 $Y=512580
X1012 465 2526 1 2 INV4CK $T=476780 558320 0 180 $X=473060 $Y=552900
X1013 2535 2383 1 2 INV4CK $T=478640 538160 0 180 $X=474920 $Y=532740
X1014 2542 472 1 2 INV4CK $T=483600 518000 0 180 $X=479880 $Y=512580
X1015 2556 2579 1 2 INV4CK $T=489180 598640 0 180 $X=485460 $Y=593220
X1016 2620 2619 1 2 INV4CK $T=495380 497840 0 0 $X=495380 $Y=497460
X1017 2585 2656 1 2 INV4CK $T=506540 568400 0 180 $X=502820 $Y=562980
X1018 2693 2649 1 2 INV4CK $T=509020 598640 0 0 $X=509020 $Y=598260
X1019 2759 2767 1 2 INV4CK $T=538160 538160 0 180 $X=534440 $Y=532740
X1020 3392 3414 1 2 INV4CK $T=621240 649040 0 180 $X=617520 $Y=643620
X1021 3588 3744 1 2 INV4CK $T=698120 558320 0 0 $X=698120 $Y=557940
X1022 3871 3813 1 2 INV4CK $T=734700 608720 0 0 $X=734700 $Y=608340
X1023 4576 4309 1 2 INV4CK $T=884740 659120 0 0 $X=884740 $Y=658740
X1024 4677 1109 1 2 INV4CK $T=899620 659120 0 0 $X=899620 $Y=658740
X1025 4838 1189 1 2 INV4CK $T=969060 659120 0 0 $X=969060 $Y=658740
X1026 85 1453 1 2 INV2CK $T=262260 578480 0 0 $X=262260 $Y=578100
X1027 1688 1679 1 2 INV2CK $T=288300 669200 0 0 $X=288300 $Y=668820
X1028 1764 248 1 2 INV2CK $T=304420 699440 1 0 $X=304420 $Y=694020
X1029 1799 1805 1 2 INV2CK $T=317440 568400 0 180 $X=314960 $Y=562980
X1030 3807 3871 1 2 INV2CK $T=727260 608720 0 0 $X=727260 $Y=608340
X1031 1081 4576 1 2 INV2CK $T=877920 679280 0 0 $X=877920 $Y=678900
X1032 4697 1113 1 2 INV2CK $T=903960 669200 0 0 $X=903960 $Y=668820
X1033 1164 1162 1 2 INV2CK $T=948600 699440 0 180 $X=946120 $Y=694020
X1034 5485 1271 1 2 INV2CK $T=1085620 497840 0 0 $X=1085620 $Y=497460
X1035 1802 1 2 1822 DELC $T=314960 588560 1 0 $X=314960 $Y=583140
X1036 2286 1 2 2344 DELC $T=425940 528080 0 0 $X=425940 $Y=527700
X1037 2335 1 2 2375 DELC $T=437100 548240 1 0 $X=437100 $Y=542820
X1038 2374 1 2 2368 DELC $T=441440 538160 1 0 $X=441440 $Y=532740
X1039 2404 1 2 2390 DELC $T=447640 548240 1 0 $X=447640 $Y=542820
X1040 2449 1 2 2435 DELC $T=458800 518000 1 0 $X=458800 $Y=512580
X1041 2469 1 2 2483 DELC $T=462520 558320 1 0 $X=462520 $Y=552900
X1042 2505 1 2 2528 DELC $T=471200 507920 1 0 $X=471200 $Y=502500
X1043 2551 1 2 2572 DELC $T=482980 548240 1 0 $X=482980 $Y=542820
X1044 2507 1 2 2570 DELC $T=486700 578480 1 0 $X=486700 $Y=573060
X1045 2532 1 2 2602 DELC $T=492900 588560 1 0 $X=492900 $Y=583140
X1046 2698 1 2 2665 DELC $T=510260 518000 1 0 $X=510260 $Y=512580
X1047 2727 1 2 2621 DELC $T=515220 518000 1 0 $X=515220 $Y=512580
X1048 2773 1 2 2682 DELC $T=528860 588560 0 0 $X=528860 $Y=588180
X1049 2817 1 2 2821 DELC $T=529480 538160 1 0 $X=529480 $Y=532740
X1050 2830 1 2 2736 DELC $T=541260 528080 1 0 $X=541260 $Y=522660
X1051 620 1 2 2884 DELC $T=543120 497840 0 0 $X=543120 $Y=497460
X1052 2987 1 2 2985 DELC $T=554900 558320 0 0 $X=554900 $Y=557940
X1053 2992 1 2 3039 DELC $T=558620 568400 0 0 $X=558620 $Y=568020
X1054 3017 1 2 3056 DELC $T=558620 588560 1 0 $X=558620 $Y=583140
X1055 3025 1 2 3047 DELC $T=561100 558320 0 0 $X=561100 $Y=557940
X1056 3064 1 2 3099 DELC $T=563580 588560 1 0 $X=563580 $Y=583140
X1057 3103 1 2 3123 DELC $T=567920 558320 0 0 $X=567920 $Y=557940
X1058 3133 1 2 3108 DELC $T=572260 568400 0 0 $X=572260 $Y=568020
X1059 3138 1 2 3106 DELC $T=576600 497840 0 0 $X=576600 $Y=497460
X1060 3156 1 2 3166 DELC $T=577220 568400 0 0 $X=577220 $Y=568020
X1061 3199 1 2 3213 DELC $T=584040 568400 1 0 $X=584040 $Y=562980
X1062 3132 1 2 3149 DELC $T=585280 548240 1 0 $X=585280 $Y=542820
X1063 3229 1 2 3208 DELC $T=588380 578480 0 0 $X=588380 $Y=578100
X1064 3277 1 2 3193 DELC $T=595820 568400 0 0 $X=595820 $Y=568020
X1065 3279 1 2 3282 DELC $T=600780 568400 0 0 $X=600780 $Y=568020
X1066 3288 1 2 3294 DELC $T=602640 588560 1 0 $X=602640 $Y=583140
X1067 3300 1 2 3301 DELC $T=603880 538160 0 0 $X=603880 $Y=537780
X1068 3336 1 2 3259 DELC $T=606360 568400 1 0 $X=606360 $Y=562980
X1069 3270 1 2 3264 DELC $T=609460 588560 1 0 $X=609460 $Y=583140
X1070 3388 1 2 3408 DELC $T=616280 618800 0 0 $X=616280 $Y=618420
X1071 3422 1 2 3342 DELC $T=621860 588560 0 0 $X=621860 $Y=588180
X1072 3454 1 2 3440 DELC $T=628060 518000 1 0 $X=628060 $Y=512580
X1073 779 1 2 3475 DELC $T=637980 558320 0 0 $X=637980 $Y=557940
X1074 3519 1 2 3484 DELC $T=648520 507920 1 0 $X=648520 $Y=502500
X1075 3559 1 2 3529 DELC $T=656580 507920 1 0 $X=656580 $Y=502500
X1076 3547 1 2 3578 DELC $T=656580 548240 1 0 $X=656580 $Y=542820
X1077 835 1 2 3502 DELC $T=657200 497840 0 0 $X=657200 $Y=497460
X1078 843 1 2 3625 DELC $T=673940 518000 0 0 $X=673940 $Y=517620
X1079 3637 1 2 3648 DELC $T=677040 507920 1 0 $X=677040 $Y=502500
X1080 857 1 2 3638 DELC $T=683860 538160 0 0 $X=683860 $Y=537780
X1081 3677 1 2 3661 DELC $T=686340 507920 1 0 $X=686340 $Y=502500
X1082 3753 1 2 3582 DELC $T=702460 558320 1 0 $X=702460 $Y=552900
X1083 3764 1 2 3721 DELC $T=706180 507920 0 0 $X=706180 $Y=507540
X1084 3762 1 2 3717 DELC $T=706800 497840 0 0 $X=706800 $Y=497460
X1085 3779 1 2 3691 DELC $T=708660 538160 0 0 $X=708660 $Y=537780
X1086 3789 1 2 3741 DELC $T=709900 568400 0 0 $X=709900 $Y=568020
X1087 3787 1 2 3777 DELC $T=711760 548240 1 0 $X=711760 $Y=542820
X1088 3792 1 2 3793 DELC $T=711760 568400 1 0 $X=711760 $Y=562980
X1089 917 1 2 3806 DELC $T=713000 497840 0 0 $X=713000 $Y=497460
X1090 3791 1 2 3823 DELC $T=713620 507920 0 0 $X=713620 $Y=507540
X1091 3786 1 2 3790 DELC $T=714860 538160 1 0 $X=714860 $Y=532740
X1092 3818 1 2 3459 DELC $T=717960 598640 1 0 $X=717960 $Y=593220
X1093 3796 1 2 3759 DELC $T=719820 538160 1 0 $X=719820 $Y=532740
X1094 3831 1 2 3640 DELC $T=719820 548240 1 0 $X=719820 $Y=542820
X1095 3830 1 2 3496 DELC $T=719820 578480 1 0 $X=719820 $Y=573060
X1096 927 1 2 3837 DELC $T=720440 497840 0 0 $X=720440 $Y=497460
X1097 3845 1 2 3804 DELC $T=722300 608720 0 0 $X=722300 $Y=608340
X1098 3846 1 2 3628 DELC $T=722920 568400 1 0 $X=722920 $Y=562980
X1099 3859 1 2 3530 DELC $T=726020 578480 0 0 $X=726020 $Y=578100
X1100 3851 1 2 3747 DELC $T=726640 558320 1 0 $X=726640 $Y=552900
X1101 3884 1 2 3492 DELC $T=730360 588560 0 0 $X=730360 $Y=588180
X1102 3903 1 2 3548 DELC $T=734080 558320 1 0 $X=734080 $Y=552900
X1103 944 1 2 3940 DELC $T=737800 518000 1 0 $X=737800 $Y=512580
X1104 3931 1 2 3567 DELC $T=740280 558320 0 0 $X=740280 $Y=557940
X1105 3908 1 2 3512 DELC $T=740280 608720 1 0 $X=740280 $Y=603300
X1106 957 1 2 4026 DELC $T=757020 618800 0 0 $X=757020 $Y=618420
X1107 963 1 2 4042 DELC $T=765700 628880 1 0 $X=765700 $Y=623460
X1108 965 1 2 4065 DELC $T=768800 598640 0 0 $X=768800 $Y=598260
X1109 4087 1 2 3819 DELC $T=773140 628880 0 0 $X=773140 $Y=628500
X1110 974 1 2 4086 DELC $T=773760 598640 0 0 $X=773760 $Y=598260
X1111 982 1 2 4127 DELC $T=778720 598640 0 0 $X=778720 $Y=598260
X1112 4266 1 2 4269 DELC $T=807240 628880 1 0 $X=807240 $Y=623460
X1113 4285 1 2 3657 DELC $T=813440 628880 1 0 $X=813440 $Y=623460
X1114 4308 1 2 4312 DELC $T=817780 618800 1 0 $X=817780 $Y=613380
X1115 4313 1 2 3767 DELC $T=818400 628880 1 0 $X=818400 $Y=623460
X1116 4319 1 2 3907 DELC $T=820880 618800 0 0 $X=820880 $Y=618420
X1117 4325 1 2 4321 DELC $T=821500 638960 1 0 $X=821500 $Y=633540
X1118 4331 1 2 4282 DELC $T=822740 618800 1 0 $X=822740 $Y=613380
X1119 4349 1 2 4350 DELC $T=826460 638960 1 0 $X=826460 $Y=633540
X1120 4394 1 2 3929 DELC $T=835140 618800 1 0 $X=835140 $Y=613380
X1121 4424 1 2 4283 DELC $T=841340 618800 1 0 $X=841340 $Y=613380
X1122 4425 1 2 3870 DELC $T=841340 628880 0 0 $X=841340 $Y=628500
X1123 4420 1 2 4344 DELC $T=841960 638960 0 0 $X=841960 $Y=638580
X1124 4458 1 2 3878 DELC $T=851260 618800 1 0 $X=851260 $Y=613380
X1125 4469 1 2 3658 DELC $T=853120 618800 0 0 $X=853120 $Y=618420
X1126 4489 1 2 3816 DELC $T=858080 618800 0 0 $X=858080 $Y=618420
X1127 4505 1 2 3743 DELC $T=863040 618800 0 0 $X=863040 $Y=618420
X1128 4570 1 2 3714 DELC $T=876060 618800 0 0 $X=876060 $Y=618420
X1129 4689 1 2 4402 DELC $T=901480 618800 0 0 $X=901480 $Y=618420
X1130 4698 1 2 4714 DELC $T=903960 689360 0 0 $X=903960 $Y=688980
X1131 4710 1 2 4671 DELC $T=907060 638960 0 0 $X=907060 $Y=638580
X1132 4732 1 2 4473 DELC $T=912020 598640 1 0 $X=912020 $Y=593220
X1133 4767 1 2 4726 DELC $T=922560 679280 1 0 $X=922560 $Y=673860
X1134 1137 1 2 4790 DELC $T=922560 689360 0 0 $X=922560 $Y=688980
X1135 4815 1 2 4862 DELC $T=939300 689360 1 0 $X=939300 $Y=683940
X1136 4926 1 2 4948 DELC $T=956660 689360 0 0 $X=956660 $Y=688980
X1137 4974 1 2 4953 DELC $T=967820 669200 0 0 $X=967820 $Y=668820
X1138 264 277 1 2 1802 QDBHN $T=327360 588560 0 180 $X=319920 $Y=583140
X1139 264 2297 1 2 2286 QDBHN $T=432760 528080 0 180 $X=425320 $Y=522660
X1140 264 2279 1 2 2335 QDBHN $T=445780 558320 0 180 $X=438340 $Y=552900
X1141 264 2382 1 2 2404 QDBHN $T=463760 568400 0 180 $X=456320 $Y=562980
X1142 264 2290 1 2 2449 QDBHN $T=469340 528080 0 180 $X=461900 $Y=522660
X1143 264 2300 1 2 2374 QDBHN $T=471200 538160 0 180 $X=463760 $Y=532740
X1144 264 2527 1 2 2507 QDBHN $T=478640 578480 0 180 $X=471200 $Y=573060
X1145 264 2323 1 2 2469 QDBHN $T=482980 568400 0 180 $X=475540 $Y=562980
X1146 264 2480 1 2 2532 QDBHN $T=484840 588560 0 180 $X=477400 $Y=583140
X1147 264 2439 1 2 2505 QDBHN $T=491660 507920 0 180 $X=484220 $Y=502500
X1148 264 2407 1 2 2551 QDBHN $T=496620 558320 0 180 $X=489180 $Y=552900
X1149 264 2592 1 2 2698 QDBHN $T=508400 497840 0 0 $X=508400 $Y=497460
X1150 264 2461 1 2 2727 QDBHN $T=509640 507920 0 0 $X=509640 $Y=507540
X1151 264 2610 1 2 2773 QDBHN $T=515840 588560 0 0 $X=515840 $Y=588180
X1152 264 2684 1 2 2830 QDBHN $T=524520 528080 1 0 $X=524520 $Y=522660
X1153 264 2646 1 2 2817 QDBHN $T=545600 548240 0 180 $X=538160 $Y=542820
X1154 455 277 1 2 625 QDBHN $T=551800 699440 0 180 $X=544360 $Y=694020
X1155 665 3169 1 2 3138 QDBHN $T=580320 507920 0 180 $X=572880 $Y=502500
X1156 665 277 1 2 3017 QDBHN $T=575360 588560 0 0 $X=575360 $Y=588180
X1157 665 3287 1 2 3336 QDBHN $T=600780 558320 0 0 $X=600780 $Y=557940
X1158 753 3344 1 2 3422 QDBHN $T=615040 608720 0 0 $X=615040 $Y=608340
X1159 665 3433 1 2 3454 QDBHN $T=621860 507920 0 0 $X=621860 $Y=507540
X1160 753 3344 1 2 3388 QDBHN $T=629920 628880 0 180 $X=622480 $Y=623460
X1161 753 3828 1 2 3845 QDBHN $T=717340 598640 0 0 $X=717340 $Y=598260
X1162 665 3799 1 2 4420 QDBHN $T=833900 628880 0 0 $X=833900 $Y=628500
X1163 1112 1122 1 2 4698 QDBHN $T=908920 689360 0 0 $X=908920 $Y=688980
X1164 1112 1133 1 2 4767 QDBHN $T=915120 679280 0 0 $X=915120 $Y=678900
X1165 1112 1148 1 2 4815 QDBHN $T=940540 679280 1 180 $X=933100 $Y=678900
X1166 1112 1133 1 2 4926 QDBHN $T=969680 689360 0 180 $X=962240 $Y=683940
X1167 1112 1194 1 2 4974 QDBHN $T=977120 679280 0 180 $X=969680 $Y=673860
X1168 1309 1303 1304 1 2 AN2T $T=226300 618800 0 180 $X=221960 $Y=613380
X1169 1334 1329 1309 1 2 AN2T $T=226920 598640 1 180 $X=222580 $Y=598260
X1170 17 26 1336 1 2 AN2T $T=225680 649040 1 0 $X=225680 $Y=643620
X1171 1399 1391 1329 1 2 AN2T $T=238700 598640 0 180 $X=234360 $Y=593220
X1172 1539 1532 1552 1 2 AN2T $T=265360 618800 0 0 $X=265360 $Y=618420
X1173 1621 1454 1636 1 2 AN2T $T=275900 618800 1 0 $X=275900 $Y=613380
X1174 1753 1746 1735 1 2 AN2T $T=305660 618800 1 0 $X=305660 $Y=613380
X1175 1822 264 1799 1 2 AN2T $T=317440 578480 0 180 $X=313100 $Y=573060
X1176 293 1908 1920 1 2 AN2T $T=338520 669200 1 0 $X=338520 $Y=663780
X1177 2188 384 2053 1 2 AN2T $T=404860 669200 0 0 $X=404860 $Y=668820
X1178 2058 384 2054 1 2 AN2T $T=405480 679280 0 0 $X=405480 $Y=678900
X1179 2344 264 2343 1 2 AN2T $T=440820 528080 0 180 $X=436480 $Y=522660
X1180 2368 264 2350 1 2 AN2T $T=441440 538160 0 180 $X=437100 $Y=532740
X1181 2390 264 2401 1 2 AN2T $T=443300 548240 1 0 $X=443300 $Y=542820
X1182 2375 264 2418 1 2 AN2T $T=453840 558320 0 180 $X=449500 $Y=552900
X1183 2435 264 2424 1 2 AN2T $T=455700 518000 0 180 $X=451360 $Y=512580
X1184 445 264 2472 1 2 AN2T $T=459420 507920 1 0 $X=459420 $Y=502500
X1185 2483 264 2416 1 2 AN2T $T=471820 568400 0 180 $X=467480 $Y=562980
X1186 2528 264 2542 1 2 AN2T $T=476160 507920 1 0 $X=476160 $Y=502500
X1187 2572 264 2535 1 2 AN2T $T=485460 558320 0 180 $X=481120 $Y=552900
X1188 2570 264 2556 1 2 AN2T $T=486700 578480 0 180 $X=482360 $Y=573060
X1189 2602 264 2585 1 2 AN2T $T=492900 588560 0 180 $X=488560 $Y=583140
X1190 2621 264 2562 1 2 AN2T $T=495380 518000 0 0 $X=495380 $Y=517620
X1191 2665 264 2620 1 2 AN2T $T=505920 507920 1 180 $X=501580 $Y=507540
X1192 2682 264 2693 1 2 AN2T $T=507780 588560 0 0 $X=507780 $Y=588180
X1193 2736 264 2759 1 2 AN2T $T=516460 528080 0 0 $X=516460 $Y=527700
X1194 2821 264 2794 1 2 AN2T $T=530100 548240 1 0 $X=530100 $Y=542820
X1195 3106 665 614 1 2 AN2T $T=569160 507920 0 180 $X=564820 $Y=502500
X1196 3056 665 3088 1 2 AN2T $T=567300 588560 0 0 $X=567300 $Y=588180
X1197 3259 665 3018 1 2 AN2T $T=592720 558320 0 0 $X=592720 $Y=557940
X1198 3342 753 3359 1 2 AN2T $T=606980 608720 0 0 $X=606980 $Y=608340
X1199 3408 753 3392 1 2 AN2T $T=620000 638960 0 180 $X=615660 $Y=633540
X1200 3440 665 774 1 2 AN2T $T=626200 507920 0 180 $X=621860 $Y=502500
X1201 4344 665 4332 1 2 AN2T $T=825840 628880 0 0 $X=825840 $Y=628500
X1202 4714 1112 4677 1 2 AN2T $T=905200 689360 0 180 $X=900860 $Y=683940
X1203 4726 1112 4697 1 2 AN2T $T=911400 679280 1 180 $X=907060 $Y=678900
X1204 4790 1112 4807 1 2 AN2T $T=927520 689360 0 0 $X=927520 $Y=688980
X1205 4862 1112 4869 1 2 AN2T $T=948600 689360 0 180 $X=944260 $Y=683940
X1206 4948 1112 1171 1 2 AN2T $T=958520 689360 0 180 $X=954180 $Y=683940
X1207 4953 1112 4954 1 2 AN2T $T=961620 679280 1 0 $X=961620 $Y=673860
X1208 5098 5192 5238 1 2 AN2T $T=1020520 568400 1 0 $X=1020520 $Y=562980
X1209 5200 1235 1240 1 2 AN2T $T=1033540 497840 0 0 $X=1033540 $Y=497460
X1210 1714 1 2 1691 DELA $T=293880 608720 0 0 $X=293880 $Y=608340
X1211 3191 1 2 3231 DELA $T=588380 507920 0 0 $X=588380 $Y=507540
X1212 3251 1 2 3250 DELA $T=591480 558320 1 0 $X=591480 $Y=552900
X1213 3560 1 2 3561 DELA $T=656580 608720 0 0 $X=656580 $Y=608340
X1214 3864 1 2 3858 DELA $T=727260 638960 1 0 $X=727260 $Y=633540
X1215 3788 1 2 3973 DELA $T=750200 618800 0 0 $X=750200 $Y=618420
X1216 4128 1 2 4146 DELA $T=789880 649040 0 0 $X=789880 $Y=648660
X1217 4225 1 2 4241 DELA $T=804140 649040 1 0 $X=804140 $Y=643620
X1218 1362 31 1326 2 1333 29 1 AO22 $T=232500 669200 1 180 $X=227540 $Y=668820
X1219 1368 1323 31 2 1330 29 1 AO22 $T=233120 659120 0 180 $X=228160 $Y=653700
X1220 1375 31 1335 2 1320 29 1 AO22 $T=233740 689360 0 180 $X=228780 $Y=683940
X1221 1403 31 1337 2 1360 1359 1 AO22 $T=238080 638960 0 180 $X=233120 $Y=633540
X1222 1408 31 1341 2 1364 1359 1 AO22 $T=238700 638960 1 180 $X=233740 $Y=638580
X1223 1463 121 1503 2 1509 128 1 AO22 $T=252960 628880 1 0 $X=252960 $Y=623460
X1224 1400 121 1515 2 1523 128 1 AO22 $T=254820 628880 0 0 $X=254820 $Y=628500
X1225 1429 121 1516 2 1524 128 1 AO22 $T=254820 638960 1 0 $X=254820 $Y=633540
X1226 1478 121 1569 2 1571 128 1 AO22 $T=262260 649040 0 0 $X=262260 $Y=648660
X1227 1512 121 1560 2 1572 128 1 AO22 $T=262260 659120 0 0 $X=262260 $Y=658740
X1228 1484 121 1562 2 1573 152 1 AO22 $T=262260 689360 1 0 $X=262260 $Y=683940
X1229 1504 121 1561 2 1580 152 1 AO22 $T=264120 679280 0 0 $X=264120 $Y=678900
X1230 1860 250 1871 2 1879 283 1 AO22 $T=329840 669200 1 0 $X=329840 $Y=663780
X1231 1810 250 1876 2 1881 283 1 AO22 $T=330460 659120 1 0 $X=330460 $Y=653700
X1232 1854 250 1878 2 1886 283 1 AO22 $T=331080 649040 1 0 $X=331080 $Y=643620
X1233 1840 250 1883 2 1888 283 1 AO22 $T=331700 669200 0 0 $X=331700 $Y=668820
X1234 1889 250 1897 2 1899 283 1 AO22 $T=334800 689360 0 0 $X=334800 $Y=688980
X1235 1847 250 1904 2 1911 283 1 AO22 $T=337900 628880 0 0 $X=337900 $Y=628500
X1236 1868 250 1929 2 1920 283 1 AO22 $T=344720 628880 0 0 $X=344720 $Y=628500
X1237 361 2060 2070 2 2043 2050 1 AO22 $T=380680 679280 1 0 $X=380680 $Y=673860
X1238 365 2060 2076 2 2107 2050 1 AO22 $T=384400 679280 0 0 $X=384400 $Y=678900
X1239 2104 371 2094 2 2112 374 1 AO22 $T=388120 507920 1 0 $X=388120 $Y=502500
X1240 377 2060 2144 2 2156 2050 1 AO22 $T=394320 689360 0 0 $X=394320 $Y=688980
X1241 2146 371 2158 2 2145 374 1 AO22 $T=396180 507920 1 0 $X=396180 $Y=502500
X1242 385 2060 2169 2 2180 2050 1 AO22 $T=400520 689360 1 0 $X=400520 $Y=683940
X1243 392 2060 2212 2 2216 2050 1 AO22 $T=408580 689360 0 0 $X=408580 $Y=688980
X1244 402 2060 2250 2 2256 2050 1 AO22 $T=417880 689360 0 0 $X=417880 $Y=688980
X1245 411 2060 2285 2 2298 2050 1 AO22 $T=427180 689360 0 0 $X=427180 $Y=688980
X1246 414 2060 2310 2 2327 2050 1 AO22 $T=433380 689360 0 0 $X=433380 $Y=688980
X1247 2325 371 2336 2 2349 374 1 AO22 $T=435240 507920 1 0 $X=435240 $Y=502500
X1248 421 2060 2359 2 2378 2050 1 AO22 $T=438960 689360 0 0 $X=438960 $Y=688980
X1249 432 2060 2410 2 2411 2050 1 AO22 $T=447640 689360 0 0 $X=447640 $Y=688980
X1250 444 435 2442 2 2399 2050 1 AO22 $T=458800 689360 1 180 $X=453840 $Y=688980
X1251 451 435 2464 2 2459 2050 1 AO22 $T=464380 699440 0 180 $X=459420 $Y=694020
X1252 466 435 2512 2 2484 2050 1 AO22 $T=478020 699440 0 180 $X=473060 $Y=694020
X1253 469 435 2521 2 2444 2050 1 AO22 $T=480500 689360 1 180 $X=475540 $Y=688980
X1254 481 435 2543 2 2474 2050 1 AO22 $T=482980 699440 0 180 $X=478020 $Y=694020
X1255 474 2557 435 2 2546 2050 1 AO22 $T=485460 669200 1 180 $X=480500 $Y=668820
X1256 480 435 2574 2 2518 2050 1 AO22 $T=492280 679280 0 180 $X=487320 $Y=673860
X1257 488 435 2576 2 2550 2050 1 AO22 $T=500340 699440 0 180 $X=495380 $Y=694020
X1258 490 435 2630 2 2539 2050 1 AO22 $T=501580 679280 0 180 $X=496620 $Y=673860
X1259 489 435 2594 2 2492 2050 1 AO22 $T=501580 679280 1 180 $X=496620 $Y=678900
X1260 2824 532 573 2 2791 2754 1 AO22 $T=530720 689360 0 180 $X=525760 $Y=683940
X1261 3186 3345 775 2 3425 2945 1 AO22 $T=619380 578480 1 0 $X=619380 $Y=573060
X1262 3145 3345 777 2 3394 2945 1 AO22 $T=619380 588560 1 0 $X=619380 $Y=583140
X1263 2800 3345 779 2 3428 2945 1 AO22 $T=620000 568400 1 0 $X=620000 $Y=562980
X1264 2968 3345 778 2 3430 2945 1 AO22 $T=620620 568400 0 0 $X=620620 $Y=568020
X1265 3362 803 3491 2 3218 3505 1 AO22 $T=636120 528080 1 0 $X=636120 $Y=522660
X1266 2933 3345 814 2 3510 2945 1 AO22 $T=640460 558320 1 0 $X=640460 $Y=552900
X1267 3374 3345 3484 2 3511 2945 1 AO22 $T=640460 568400 0 0 $X=640460 $Y=568020
X1268 3506 815 3447 2 3516 3218 1 AO22 $T=641700 528080 1 0 $X=641700 $Y=522660
X1269 2929 3345 3502 2 3526 2945 1 AO22 $T=644800 548240 0 0 $X=644800 $Y=547860
X1270 3238 3345 3529 2 3527 2945 1 AO22 $T=646660 568400 1 0 $X=646660 $Y=562980
X1271 2918 3345 3547 2 3552 2945 1 AO22 $T=652240 538160 0 0 $X=652240 $Y=537780
X1272 3545 834 3557 2 3528 3563 1 AO22 $T=654720 588560 0 0 $X=654720 $Y=588180
X1273 3583 834 3535 2 3546 3563 1 AO22 $T=662160 558320 1 180 $X=657200 $Y=557940
X1274 3584 834 3575 2 3517 3563 1 AO22 $T=662160 578480 1 180 $X=657200 $Y=578100
X1275 3560 834 3544 2 3522 3563 1 AO22 $T=662160 598640 0 180 $X=657200 $Y=593220
X1276 3569 834 3566 2 3497 3563 1 AO22 $T=662160 608720 0 180 $X=657200 $Y=603300
X1277 2865 3345 843 2 3581 2945 1 AO22 $T=658440 538160 0 0 $X=658440 $Y=537780
X1278 3605 834 3602 2 3554 3563 1 AO22 $T=668360 598640 0 180 $X=663400 $Y=593220
X1279 2887 3345 857 2 3606 2945 1 AO22 $T=664640 538160 0 0 $X=664640 $Y=537780
X1280 3468 3345 858 2 3607 2945 1 AO22 $T=664640 578480 0 0 $X=664640 $Y=578100
X1281 3594 834 3622 2 3618 3563 1 AO22 $T=674560 568400 1 180 $X=669600 $Y=568020
X1282 3646 834 3630 2 3620 3563 1 AO22 $T=677040 578480 0 180 $X=672080 $Y=573060
X1283 3645 834 3633 2 3617 3563 1 AO22 $T=678280 558320 1 180 $X=673320 $Y=557940
X1284 3621 834 3650 2 3655 3563 1 AO22 $T=677660 568400 0 0 $X=677660 $Y=568020
X1285 3660 834 3656 2 3654 3563 1 AO22 $T=683240 558320 1 180 $X=678280 $Y=557940
X1286 3601 3345 881 2 3619 2945 1 AO22 $T=680760 588560 0 0 $X=680760 $Y=588180
X1287 3688 834 3678 2 3673 3563 1 AO22 $T=688820 618800 1 180 $X=683860 $Y=618420
X1288 3410 3345 879 2 3671 2945 1 AO22 $T=685720 588560 1 0 $X=685720 $Y=583140
X1289 3712 834 3699 2 3697 3563 1 AO22 $T=694400 548240 1 180 $X=689440 $Y=547860
X1290 3713 834 3696 2 3698 3563 1 AO22 $T=695020 618800 1 180 $X=690060 $Y=618420
X1291 3719 834 3695 2 3706 3563 1 AO22 $T=696260 578480 0 180 $X=691300 $Y=573060
X1292 3452 3345 898 2 3701 2945 1 AO22 $T=692540 578480 0 0 $X=692540 $Y=578100
X1293 3521 3345 906 2 3720 2945 1 AO22 $T=698740 578480 0 0 $X=698740 $Y=578100
X1294 3757 834 3745 2 3736 3563 1 AO22 $T=704320 578480 0 180 $X=699360 $Y=573060
X1295 3756 834 3729 2 3752 3563 1 AO22 $T=705560 548240 0 180 $X=700600 $Y=542820
X1296 3788 834 3723 2 3766 3563 1 AO22 $T=708660 558320 1 180 $X=703700 $Y=557940
X1297 3726 3345 910 2 3763 2945 1 AO22 $T=705560 578480 0 0 $X=705560 $Y=578100
X1298 3734 834 3781 2 3687 3563 1 AO22 $T=711760 548240 0 180 $X=706800 $Y=542820
X1299 3370 3345 913 2 3774 2945 1 AO22 $T=708040 588560 0 0 $X=708040 $Y=588180
X1300 3397 3345 3806 2 3810 2945 1 AO22 $T=712380 578480 0 0 $X=712380 $Y=578100
X1301 3541 3345 921 2 3809 2945 1 AO22 $T=714240 588560 0 0 $X=714240 $Y=588180
X1302 3429 3345 3837 2 3842 2945 1 AO22 $T=719200 578480 0 0 $X=719200 $Y=578100
X1303 3048 3345 929 2 3847 2945 1 AO22 $T=720440 588560 0 0 $X=720440 $Y=588180
X1304 3867 834 3857 2 3812 3563 1 AO22 $T=727880 618800 1 180 $X=722920 $Y=618420
X1305 3900 834 3877 2 3879 3563 1 AO22 $T=734080 618800 1 180 $X=729120 $Y=618420
X1306 3930 834 3922 2 3919 3563 1 AO22 $T=740280 618800 1 180 $X=735320 $Y=618420
X1307 3883 834 3943 2 3954 3563 1 AO22 $T=742140 618800 1 0 $X=742140 $Y=613380
X1308 3955 834 4006 2 3995 3563 1 AO22 $T=759500 628880 0 180 $X=754540 $Y=623460
X1309 4114 834 4102 2 4005 3563 1 AO22 $T=779960 618800 1 180 $X=775000 $Y=618420
X1310 4088 984 4125 2 986 991 1 AO22 $T=779960 507920 1 0 $X=779960 $Y=502500
X1311 3921 4134 4137 2 4140 4153 1 AO22 $T=781820 528080 1 0 $X=781820 $Y=522660
X1312 4008 4134 4129 2 4148 4153 1 AO22 $T=782440 538160 1 0 $X=782440 $Y=532740
X1313 4136 834 4165 2 4142 3563 1 AO22 $T=791740 618800 1 180 $X=786780 $Y=618420
X1314 4130 4134 4164 2 4175 4153 1 AO22 $T=787400 568400 1 0 $X=787400 $Y=562980
X1315 4078 4134 4167 2 4180 4153 1 AO22 $T=788020 548240 1 0 $X=788020 $Y=542820
X1316 4122 4134 4168 2 4181 4153 1 AO22 $T=788020 548240 0 0 $X=788020 $Y=547860
X1317 4173 834 4176 2 4098 3563 1 AO22 $T=792980 628880 0 180 $X=788020 $Y=623460
X1318 4155 4134 4184 2 4190 4153 1 AO22 $T=789880 578480 1 0 $X=789880 $Y=573060
X1319 4135 4134 4193 2 4198 4153 1 AO22 $T=790500 558320 0 0 $X=790500 $Y=557940
X1320 4160 984 4188 2 1000 991 1 AO22 $T=791120 507920 0 0 $X=791120 $Y=507540
X1321 4044 4134 4189 2 4199 4153 1 AO22 $T=791120 538160 1 0 $X=791120 $Y=532740
X1322 4208 834 4202 2 4192 3563 1 AO22 $T=796700 618800 0 180 $X=791740 $Y=613380
X1323 3889 4134 4209 2 4229 4153 1 AO22 $T=796080 528080 0 0 $X=796080 $Y=527700
X1324 3996 4134 4221 2 4232 4153 1 AO22 $T=796700 538160 1 0 $X=796700 $Y=532740
X1325 4218 984 4263 2 1011 991 1 AO22 $T=804140 507920 0 0 $X=804140 $Y=507540
X1326 4200 4134 4262 2 4268 4153 1 AO22 $T=804760 578480 1 0 $X=804760 $Y=573060
X1327 4284 984 4280 2 1014 991 1 AO22 $T=814680 507920 1 180 $X=809720 $Y=507540
X1328 4235 4134 4289 2 4293 4153 1 AO22 $T=812820 578480 1 0 $X=812820 $Y=573060
X1329 4316 3890 3979 2 869 3854 1 AO22 $T=820260 588560 0 180 $X=815300 $Y=583140
X1330 4336 4134 4326 2 4320 4153 1 AO22 $T=824600 578480 1 180 $X=819640 $Y=578100
X1331 4315 984 4356 2 1033 991 1 AO22 $T=827080 507920 0 0 $X=827080 $Y=507540
X1332 4372 4134 4401 2 4385 4153 1 AO22 $T=838860 578480 1 180 $X=833900 $Y=578100
X1333 4411 984 4396 2 1037 991 1 AO22 $T=838860 507920 1 0 $X=838860 $Y=502500
X1334 4399 4134 4426 2 4418 4434 1 AO22 $T=840100 578480 1 0 $X=840100 $Y=573060
X1335 4408 984 4432 2 1051 991 1 AO22 $T=845060 507920 1 0 $X=845060 $Y=502500
X1336 4435 4134 4457 2 4441 4434 1 AO22 $T=848780 578480 0 0 $X=848780 $Y=578100
X1337 4442 984 4459 2 1061 991 1 AO22 $T=851880 507920 1 0 $X=851880 $Y=502500
X1338 4485 1052 4484 2 4468 4434 1 AO22 $T=859940 578480 1 180 $X=854980 $Y=578100
X1339 4462 984 4497 2 1064 991 1 AO22 $T=860560 507920 1 0 $X=860560 $Y=502500
X1340 4506 984 4528 2 1071 991 1 AO22 $T=866140 507920 0 0 $X=866140 $Y=507540
X1341 4533 1052 4531 2 4493 4434 1 AO22 $T=871100 578480 0 180 $X=866140 $Y=573060
X1342 4569 1052 4557 2 4540 4434 1 AO22 $T=876680 578480 1 180 $X=871720 $Y=578100
X1343 4544 984 4564 2 1076 991 1 AO22 $T=874200 507920 1 0 $X=874200 $Y=502500
X1344 4593 984 4577 2 1082 991 1 AO22 $T=881640 507920 1 180 $X=876680 $Y=507540
X1345 4600 1052 4584 2 4579 4434 1 AO22 $T=882880 578480 1 180 $X=877920 $Y=578100
X1346 4628 1093 984 2 1090 991 1 AO22 $T=888460 507920 1 180 $X=883500 $Y=507540
X1347 4646 1052 4612 2 4618 4434 1 AO22 $T=895900 578480 0 180 $X=890940 $Y=573060
X1348 4662 1052 4647 2 4615 4434 1 AO22 $T=896520 568400 1 180 $X=891560 $Y=568020
X1349 4665 1052 4637 2 4588 4434 1 AO22 $T=897760 548240 0 180 $X=892800 $Y=542820
X1350 4644 4661 984 2 1104 991 1 AO22 $T=899000 507920 0 180 $X=894040 $Y=502500
X1351 4707 1052 4660 2 4621 4434 1 AO22 $T=904580 558320 0 180 $X=899620 $Y=552900
X1352 4808 1144 4803 2 4828 1147 1 AO22 $T=933100 518000 0 0 $X=933100 $Y=517620
X1353 4820 4840 4843 2 4845 4860 1 AO22 $T=938060 578480 0 0 $X=938060 $Y=578100
X1354 4825 4840 4849 2 4852 4860 1 AO22 $T=939300 588560 0 0 $X=939300 $Y=588180
X1355 4839 1144 4853 2 4856 1147 1 AO22 $T=939920 518000 0 0 $X=939920 $Y=517620
X1356 4834 4840 4847 2 4855 4860 1 AO22 $T=939920 608720 1 0 $X=939920 $Y=603300
X1357 4755 4840 4851 2 4859 4860 1 AO22 $T=940540 568400 0 0 $X=940540 $Y=568020
X1358 4866 1144 4908 2 4903 1147 1 AO22 $T=956040 518000 1 180 $X=951080 $Y=517620
X1359 4854 4840 4906 2 4913 4860 1 AO22 $T=951080 588560 0 0 $X=951080 $Y=588180
X1360 4915 1144 4934 2 4930 1147 1 AO22 $T=956040 518000 0 0 $X=956040 $Y=517620
X1361 4823 4840 4911 2 4925 4860 1 AO22 $T=957900 608720 0 0 $X=957900 $Y=608340
X1362 4887 4840 4947 2 4956 4860 1 AO22 $T=959140 608720 1 0 $X=959140 $Y=603300
X1363 4968 1144 4986 2 4983 1147 1 AO22 $T=967820 528080 1 0 $X=967820 $Y=522660
X1364 4972 4840 4995 2 5002 4860 1 AO22 $T=970920 598640 1 0 $X=970920 $Y=593220
X1365 5005 1144 5010 2 1196 1147 1 AO22 $T=978980 528080 0 180 $X=974020 $Y=522660
X1366 4971 4840 5007 2 5011 4860 1 AO22 $T=974020 598640 0 0 $X=974020 $Y=598260
X1367 5020 1144 5036 2 5016 1147 1 AO22 $T=985800 518000 1 180 $X=980840 $Y=517620
X1368 5073 1144 5058 2 5054 1147 1 AO22 $T=991380 518000 1 180 $X=986420 $Y=517620
X1369 5041 4840 5025 2 5035 4860 1 AO22 $T=992000 588560 0 180 $X=987040 $Y=583140
X1370 5050 4840 5063 2 5061 4860 1 AO22 $T=987660 598640 0 0 $X=987660 $Y=598260
X1371 5109 4840 5094 2 5086 4860 1 AO22 $T=998200 588560 1 180 $X=993240 $Y=588180
X1372 5112 4840 5103 2 5095 4860 1 AO22 $T=999440 598640 1 180 $X=994480 $Y=598260
X1373 5122 4798 4748 2 869 3854 1 AO22 $T=1000060 608720 0 180 $X=995100 $Y=603300
X1374 5140 1144 5135 2 5114 1147 1 AO22 $T=1005640 518000 0 180 $X=1000680 $Y=512580
X1375 5154 1144 5184 2 5174 1147 1 AO22 $T=1016800 528080 0 180 $X=1011840 $Y=522660
X1376 5187 5224 5195 2 5158 5251 1 AO22 $T=1019900 588560 0 0 $X=1019900 $Y=588180
X1377 5280 1144 5267 2 5216 1147 1 AO22 $T=1033540 518000 0 180 $X=1028580 $Y=512580
X1378 5236 5224 5265 2 5208 5251 1 AO22 $T=1028580 598640 1 0 $X=1028580 $Y=593220
X1379 5278 5224 5261 2 5186 5251 1 AO22 $T=1034160 578480 1 180 $X=1029200 $Y=578100
X1380 5309 5224 5288 2 5179 5251 1 AO22 $T=1039740 598640 0 180 $X=1034780 $Y=593220
X1381 5300 1144 5306 2 5273 1147 1 AO22 $T=1042840 507920 1 180 $X=1037880 $Y=507540
X1382 5333 5224 5308 2 5165 5251 1 AO22 $T=1046560 588560 0 180 $X=1041600 $Y=583140
X1383 5347 5224 5329 2 5151 5251 1 AO22 $T=1047180 598640 1 180 $X=1042220 $Y=598260
X1384 5368 5224 5360 2 5235 5251 1 AO22 $T=1053380 598640 0 180 $X=1048420 $Y=593220
X1385 5414 5224 5374 2 5247 5251 1 AO22 $T=1063300 578480 1 180 $X=1058340 $Y=578100
X1386 5420 5224 5378 2 5234 5251 1 AO22 $T=1063920 578480 0 180 $X=1058960 $Y=573060
X1387 3631 2 867 877 871 1 3597 FA1S $T=680140 689360 1 180 $X=668360 $Y=688980
X1388 3855 2 934 3840 3835 1 3881 FA1S $T=720440 699440 1 0 $X=720440 $Y=694020
X1389 4025 2 967 4041 3998 1 3992 FA1S $T=766320 659120 1 180 $X=754540 $Y=658740
X1390 4070 2 973 962 4092 1 4072 FA1S $T=764460 679280 0 0 $X=764460 $Y=678900
X1391 4227 2 992 4257 4197 1 4174 FA1S $T=803520 669200 1 180 $X=791740 $Y=668820
X1392 4228 2 992 1010 4222 1 4162 FA1S $T=801660 689360 1 0 $X=801660 $Y=683940
X1393 51 1370 1382 2 1 1432 QDFFRBN $T=231260 568400 1 0 $X=231260 $Y=562980
X1394 1325 1370 1382 2 1 1405 QDFFRBN $T=231260 578480 0 0 $X=231260 $Y=578100
X1395 1461 1370 1382 2 1 1535 QDFFRBN $T=247380 578480 0 0 $X=247380 $Y=578100
X1396 1522 1370 1382 2 1 1422 QDFFRBN $T=259160 588560 0 180 $X=247380 $Y=583140
X1397 110 1370 1382 2 1 1541 QDFFRBN $T=248620 568400 1 0 $X=248620 $Y=562980
X1398 1566 1370 1382 2 1 1612 QDFFRBN $T=264120 578480 1 0 $X=264120 $Y=573060
X1399 175 1370 1382 2 1 85 QDFFRBN $T=276520 578480 1 180 $X=264740 $Y=578100
X1400 1650 1370 1382 2 1 84 QDFFRBN $T=277140 568400 0 180 $X=265360 $Y=562980
X1401 1643 191 1382 2 1 1720 QDFFRBN $T=279620 578480 0 0 $X=279620 $Y=578100
X1402 217 1370 1382 2 1 193 QDFFRBN $T=294500 568400 0 180 $X=282720 $Y=562980
X1403 1721 191 1382 2 1 1755 QDFFRBN $T=293880 598640 0 0 $X=293880 $Y=598260
X1404 1713 1370 1382 2 1 250 QDFFRBN $T=295120 578480 0 0 $X=295120 $Y=578100
X1405 229 1370 1382 2 1 1787 QDFFRBN $T=298220 568400 1 0 $X=298220 $Y=562980
X1406 1771 191 262 2 1 1824 QDFFRBN $T=306280 638960 0 0 $X=306280 $Y=638580
X1407 1772 191 262 2 1 1812 QDFFRBN $T=306280 679280 1 0 $X=306280 $Y=673860
X1408 1778 191 262 2 1 1821 QDFFRBN $T=307520 669200 1 0 $X=307520 $Y=663780
X1409 1783 191 262 2 1 1827 QDFFRBN $T=308140 628880 0 0 $X=308140 $Y=628500
X1410 254 1370 1382 2 1 278 QDFFRBN $T=308760 578480 0 0 $X=308760 $Y=578100
X1411 1791 191 262 2 1 273 QDFFRBN $T=311240 689360 0 0 $X=311240 $Y=688980
X1412 1801 191 262 2 1 1848 QDFFRBN $T=313720 628880 1 0 $X=313720 $Y=623460
X1413 1816 191 1382 2 1 1873 QDFFRBN $T=318060 588560 0 0 $X=318060 $Y=588180
X1414 1817 191 1382 2 1 1865 QDFFRBN $T=318060 618800 0 0 $X=318060 $Y=618420
X1415 2575 476 262 2 1 2533 QDFFRBN $T=489180 638960 1 180 $X=477400 $Y=638580
X1416 2591 476 262 2 1 468 QDFFRBN $T=491660 649040 1 180 $X=479880 $Y=648660
X1417 2658 476 383 2 1 2566 QDFFRBN $T=505300 659120 0 180 $X=493520 $Y=653700
X1418 2661 476 383 2 1 456 QDFFRBN $T=505920 659120 1 180 $X=494140 $Y=658740
X1419 2653 476 383 2 1 2615 QDFFRBN $T=507780 689360 1 180 $X=496000 $Y=688980
X1420 2681 476 383 2 1 2636 QDFFRBN $T=510880 669200 1 180 $X=499100 $Y=668820
X1421 2884 614 634 2 1 641 QDFFRBN $T=540020 507920 1 0 $X=540020 $Y=502500
X1422 2904 2755 634 2 1 2987 QDFFRBN $T=542500 548240 0 0 $X=542500 $Y=547860
X1423 3007 2978 634 2 1 2914 QDFFRBN $T=559240 568400 0 180 $X=547460 $Y=562980
X1424 3028 3018 634 2 1 2949 QDFFRBN $T=561100 518000 0 180 $X=549320 $Y=512580
X1425 3029 3018 634 2 1 2941 QDFFRBN $T=561100 518000 1 180 $X=549320 $Y=517620
X1426 3045 465 634 2 1 639 QDFFRBN $T=562960 507920 1 180 $X=551180 $Y=507540
X1427 661 614 634 2 1 642 QDFFRBN $T=564820 497840 1 180 $X=553040 $Y=497460
X1428 3078 3018 634 2 1 2992 QDFFRBN $T=566680 578480 0 180 $X=554900 $Y=573060
X1429 3116 3018 634 2 1 2936 QDFFRBN $T=567920 528080 1 180 $X=556140 $Y=527700
X1430 3115 3018 634 2 1 3025 QDFFRBN $T=571020 568400 0 180 $X=559240 $Y=562980
X1431 3047 3088 634 2 1 3156 QDFFRBN $T=564820 578480 0 0 $X=564820 $Y=578100
X1432 3039 3088 634 2 1 3133 QDFFRBN $T=566680 578480 1 0 $X=566680 $Y=573060
X1433 3108 3088 634 2 1 3064 QDFFRBN $T=568540 588560 1 0 $X=568540 $Y=583140
X1434 3123 3088 634 2 1 3199 QDFFRBN $T=571020 568400 1 0 $X=571020 $Y=562980
X1435 3202 3018 634 2 1 3103 QDFFRBN $T=584660 558320 1 180 $X=572880 $Y=557940
X1436 3149 3018 634 2 1 3177 QDFFRBN $T=573500 548240 1 0 $X=573500 $Y=542820
X1437 3204 3018 634 2 1 3129 QDFFRBN $T=585900 528080 0 180 $X=574120 $Y=522660
X1438 3166 3088 634 2 1 3229 QDFFRBN $T=576600 578480 0 0 $X=576600 $Y=578100
X1439 3244 3018 634 2 1 3153 QDFFRBN $T=592100 518000 0 180 $X=580320 $Y=512580
X1440 3193 3088 634 2 1 3279 QDFFRBN $T=581560 578480 1 0 $X=581560 $Y=573060
X1441 3208 3088 634 2 1 3270 QDFFRBN $T=583420 588560 1 0 $X=583420 $Y=583140
X1442 3213 3088 634 2 1 3277 QDFFRBN $T=584040 568400 0 0 $X=584040 $Y=568020
X1443 3099 3088 703 2 1 3288 QDFFRBN $T=585900 588560 0 0 $X=585900 $Y=588180
X1444 3345 3385 634 2 1 3331 QDFFRBN $T=618140 568400 1 180 $X=606360 $Y=568020
X1445 3441 3385 634 2 1 3330 QDFFRBN $T=627440 558320 1 180 $X=615660 $Y=557940
X1446 771 774 785 2 1 795 QDFFRBN $T=619380 497840 0 0 $X=619380 $Y=497460
X1447 808 3385 634 2 1 3380 QDFFRBN $T=639840 558320 0 180 $X=628060 $Y=552900
X1448 797 774 785 2 1 3519 QDFFRBN $T=633020 497840 0 0 $X=633020 $Y=497460
X1449 828 3385 816 2 1 3427 QDFFRBN $T=654100 608720 0 180 $X=642320 $Y=603300
X1450 3509 3385 634 2 1 3543 QDFFRBN $T=642940 538160 1 0 $X=642940 $Y=532740
X1451 819 774 785 2 1 3559 QDFFRBN $T=645420 497840 0 0 $X=645420 $Y=497460
X1452 840 3385 634 2 1 3485 QDFFRBN $T=660920 528080 0 180 $X=649140 $Y=522660
X1453 844 3385 634 2 1 3513 QDFFRBN $T=662160 528080 1 180 $X=650380 $Y=527700
X1454 849 3385 816 2 1 3419 QDFFRBN $T=662160 618800 0 180 $X=650380 $Y=613380
X1455 859 3385 634 2 1 3538 QDFFRBN $T=668980 518000 1 180 $X=657200 $Y=517620
X1456 3587 774 703 2 1 3547 QDFFRBN $T=662160 497840 0 0 $X=662160 $Y=497460
X1457 3589 851 816 2 1 874 QDFFRBN $T=662160 659120 0 0 $X=662160 $Y=658740
X1458 872 3385 634 2 1 3516 QDFFRBN $T=675800 528080 0 180 $X=664020 $Y=522660
X1459 873 3385 634 2 1 3498 QDFFRBN $T=675800 538160 0 180 $X=664020 $Y=532740
X1460 3604 851 868 2 1 867 QDFFRBN $T=665260 689360 1 0 $X=665260 $Y=683940
X1461 875 3385 816 2 1 3505 QDFFRBN $T=677660 618800 0 180 $X=665880 $Y=613380
X1462 886 774 703 2 1 3637 QDFFRBN $T=688200 497840 1 180 $X=676420 $Y=497460
X1463 3642 851 816 2 1 889 QDFFRBN $T=676420 659120 1 0 $X=676420 $Y=653700
X1464 3639 774 3674 2 1 3677 QDFFRBN $T=677040 507920 0 0 $X=677040 $Y=507540
X1465 3665 883 884 2 1 895 QDFFRBN $T=681380 699440 1 0 $X=681380 $Y=694020
X1466 3683 851 816 2 1 900 QDFFRBN $T=686340 649040 0 0 $X=686340 $Y=648660
X1467 3725 883 884 2 1 887 QDFFRBN $T=698740 679280 1 180 $X=686960 $Y=678900
X1468 893 774 3674 2 1 3762 QDFFRBN $T=690680 497840 0 0 $X=690680 $Y=497460
X1469 3614 774 3674 2 1 3764 QDFFRBN $T=691300 507920 1 0 $X=691300 $Y=502500
X1470 3811 883 884 2 1 902 QDFFRBN $T=713000 679280 1 180 $X=701220 $Y=678900
X1471 3768 851 816 2 1 922 QDFFRBN $T=704940 649040 0 0 $X=704940 $Y=648660
X1472 3821 3813 3674 2 1 3753 QDFFRBN $T=719200 558320 0 180 $X=707420 $Y=552900
X1473 3833 3813 3674 2 1 3786 QDFFRBN $T=721680 528080 0 180 $X=709900 $Y=522660
X1474 3834 3813 3674 2 1 3787 QDFFRBN $T=721680 548240 1 180 $X=709900 $Y=547860
X1475 3823 3813 3674 2 1 3792 QDFFRBN $T=722920 558320 1 180 $X=711140 $Y=557940
X1476 3841 3813 3674 2 1 3796 QDFFRBN $T=723540 528080 1 180 $X=711760 $Y=527700
X1477 3850 3813 3674 2 1 3779 QDFFRBN $T=725400 538160 1 180 $X=713620 $Y=537780
X1478 3856 3813 3674 2 1 3789 QDFFRBN $T=726640 568400 1 180 $X=714860 $Y=568020
X1479 3815 883 884 2 1 915 QDFFRBN $T=716100 679280 0 0 $X=716100 $Y=678900
X1480 3836 851 816 2 1 938 QDFFRBN $T=721060 649040 0 0 $X=721060 $Y=648660
X1481 3896 3813 703 2 1 3818 QDFFRBN $T=734700 598640 0 180 $X=722920 $Y=593220
X1482 3906 3813 3674 2 1 3851 QDFFRBN $T=735940 558320 1 180 $X=724160 $Y=557940
X1483 3910 3385 3674 2 1 3853 QDFFRBN $T=736560 518000 0 180 $X=724780 $Y=512580
X1484 3912 3813 3674 2 1 3831 QDFFRBN $T=736560 548240 0 180 $X=724780 $Y=542820
X1485 3913 3813 3674 2 1 3830 QDFFRBN $T=736560 578480 0 180 $X=724780 $Y=573060
X1486 3861 3385 3674 2 1 3899 QDFFRBN $T=726020 507920 0 0 $X=726020 $Y=507540
X1487 3862 883 884 2 1 3938 QDFFRBN $T=730360 679280 0 0 $X=730360 $Y=678900
X1488 3936 3813 3674 2 1 3846 QDFFRBN $T=742760 568400 1 180 $X=730980 $Y=568020
X1489 3937 3813 3876 2 1 3859 QDFFRBN $T=742760 578480 1 180 $X=730980 $Y=578100
X1490 3942 3813 3876 2 1 3884 QDFFRBN $T=744000 588560 0 180 $X=732220 $Y=583140
X1491 3956 3813 3674 2 1 3903 QDFFRBN $T=747100 568400 0 180 $X=735320 $Y=562980
X1492 3957 3813 3876 2 1 3908 QDFFRBN $T=747100 598640 0 180 $X=735320 $Y=593220
X1493 3917 851 816 2 1 946 QDFFRBN $T=735940 649040 0 0 $X=735940 $Y=648660
X1494 3926 883 884 2 1 3968 QDFFRBN $T=737800 689360 0 0 $X=737800 $Y=688980
X1495 3987 3385 3674 2 1 3843 QDFFRBN $T=752060 548240 1 180 $X=740280 $Y=547860
X1496 3988 3813 3876 2 1 3931 QDFFRBN $T=752060 578480 0 180 $X=740280 $Y=573060
X1497 3981 3385 3674 2 1 3885 QDFFRBN $T=757020 528080 0 180 $X=745240 $Y=522660
X1498 4001 883 884 2 1 949 QDFFRBN $T=757640 689360 0 180 $X=745860 $Y=683940
X1499 4004 3385 3674 2 1 3946 QDFFRBN $T=758260 548240 0 180 $X=746480 $Y=542820
X1500 4031 3385 3674 2 1 3966 QDFFRBN $T=760740 518000 0 180 $X=748960 $Y=512580
X1501 3960 851 816 2 1 950 QDFFRBN $T=750200 649040 0 0 $X=750200 $Y=648660
X1502 4052 3385 3674 2 1 3974 QDFFRBN $T=762600 568400 0 180 $X=750820 $Y=562980
X1503 4067 3385 3876 2 1 3945 QDFFRBN $T=765700 588560 0 180 $X=753920 $Y=583140
X1504 4056 3385 3876 2 1 3958 QDFFRBN $T=767560 578480 0 180 $X=755780 $Y=573060
X1505 4010 883 884 2 1 966 QDFFRBN $T=757020 689360 0 0 $X=757020 $Y=688980
X1506 3980 851 816 2 1 4095 QDFFRBN $T=763840 649040 0 0 $X=763840 $Y=648660
X1507 4113 3385 3876 2 1 4009 QDFFRBN $T=780580 598640 0 180 $X=768800 $Y=593220
X1508 4084 883 884 2 1 985 QDFFRBN $T=771280 689360 0 0 $X=771280 $Y=688980
X1509 4091 851 816 2 1 4147 QDFFRBN $T=773760 659120 0 0 $X=773760 $Y=658740
X1510 4105 851 816 2 1 4196 QDFFRBN $T=776860 669200 1 0 $X=776860 $Y=663780
X1511 4161 851 816 2 1 4108 QDFFRBN $T=789880 649040 1 180 $X=778100 $Y=648660
X1512 4211 3385 3876 2 1 4156 QDFFRBN $T=798560 608720 0 180 $X=786780 $Y=603300
X1513 4247 3385 3876 2 1 4120 QDFFRBN $T=807240 608720 1 180 $X=795460 $Y=608340
X1514 4210 851 816 2 1 4267 QDFFRBN $T=796080 659120 0 0 $X=796080 $Y=658740
X1515 4207 883 884 2 1 4215 QDFFRBN $T=810960 689360 1 180 $X=799180 $Y=688980
X1516 4304 3385 3876 2 1 3979 QDFFRBN $T=823360 608720 1 180 $X=811580 $Y=608340
X1517 4342 4332 4085 2 1 4285 QDFFRBN $T=825840 628880 1 180 $X=814060 $Y=628500
X1518 4371 3385 3876 2 1 4049 QDFFRBN $T=837620 608720 1 180 $X=825840 $Y=608340
X1519 4402 4332 3876 2 1 4319 QDFFRBN $T=837620 618800 1 180 $X=825840 $Y=618420
X1520 4403 4332 3876 2 1 4266 QDFFRBN $T=837620 628880 0 180 $X=825840 $Y=623460
X1521 4419 4332 3876 2 1 4349 QDFFRBN $T=841960 638960 1 180 $X=830180 $Y=638580
X1522 4427 4332 4085 2 1 4313 QDFFRBN $T=843200 638960 0 180 $X=831420 $Y=633540
X1523 4448 4332 3876 2 1 4331 QDFFRBN $T=850640 628880 0 180 $X=838860 $Y=623460
X1524 4472 3385 3876 2 1 4423 QDFFRBN $T=853120 608720 1 180 $X=841340 $Y=608340
X1525 4461 4332 3876 2 1 4424 QDFFRBN $T=853120 618800 1 180 $X=841340 $Y=618420
X1526 4473 4332 3876 2 1 4325 QDFFRBN $T=856220 638960 0 180 $X=844440 $Y=633540
X1527 4478 4332 3876 2 1 4425 QDFFRBN $T=858080 628880 1 180 $X=846300 $Y=628500
X1528 4500 4332 3876 2 1 4308 QDFFRBN $T=862420 628880 0 180 $X=850640 $Y=623460
X1529 4495 3385 3876 2 1 4317 QDFFRBN $T=868000 608720 1 180 $X=856220 $Y=608340
X1530 4523 4332 3876 2 1 4458 QDFFRBN $T=868000 618800 0 180 $X=856220 $Y=613380
X1531 1078 3385 816 2 1 3507 QDFFRBN $T=869860 638960 1 180 $X=858080 $Y=638580
X1532 4538 4332 3876 2 1 4489 QDFFRBN $T=871720 638960 0 180 $X=859940 $Y=633540
X1533 4548 4332 3876 2 1 4469 QDFFRBN $T=873580 628880 1 180 $X=861800 $Y=628500
X1534 4561 4332 3876 2 1 4505 QDFFRBN $T=876680 628880 0 180 $X=864900 $Y=623460
X1535 4546 3385 3876 2 1 4580 QDFFRBN $T=872340 618800 1 0 $X=872340 $Y=613380
X1536 4613 4332 3876 2 1 4087 QDFFRBN $T=886600 638960 0 180 $X=874820 $Y=633540
X1537 4619 4332 4085 2 1 4570 QDFFRBN $T=888460 628880 1 180 $X=876680 $Y=628500
X1538 4582 3385 3876 2 1 4635 QDFFRBN $T=879160 528080 0 0 $X=879160 $Y=527700
X1539 4678 4332 3876 2 1 4394 QDFFRBN $T=891560 628880 0 180 $X=879780 $Y=623460
X1540 1101 3385 816 2 1 3445 QDFFRBN $T=893420 649040 0 180 $X=881640 $Y=643620
X1541 4656 3385 3876 2 1 4605 QDFFRBN $T=897760 608720 1 180 $X=885980 $Y=608340
X1542 1117 3385 816 2 1 4367 QDFFRBN $T=910160 649040 0 180 $X=898380 $Y=643620
X1543 4682 3385 3876 2 1 4703 QDFFRBN $T=900240 528080 1 0 $X=900240 $Y=522660
X1544 4716 3385 3876 2 1 4679 QDFFRBN $T=913260 608720 1 180 $X=901480 $Y=608340
X1545 4731 3385 4085 2 1 4648 QDFFRBN $T=913260 618800 0 180 $X=901480 $Y=613380
X1546 4728 3385 3876 2 1 4694 QDFFRBN $T=916980 598640 1 180 $X=905200 $Y=598260
X1547 4756 1134 3876 2 1 4631 QDFFRBN $T=921320 608720 0 180 $X=909540 $Y=603300
X1548 4759 1134 4085 2 1 4710 QDFFRBN $T=923800 638960 1 180 $X=912020 $Y=638580
X1549 4737 3385 4085 2 1 4627 QDFFRBN $T=913880 588560 0 0 $X=913880 $Y=588180
X1550 4782 3385 3876 2 1 4739 QDFFRBN $T=926280 528080 0 180 $X=914500 $Y=522660
X1551 1143 1134 816 2 1 4363 QDFFRBN $T=932480 649040 0 180 $X=920700 $Y=643620
X1552 4829 1134 4085 2 1 4760 QDFFRBN $T=935580 558320 0 180 $X=923800 $Y=552900
X1553 4842 1134 4085 2 1 4750 QDFFRBN $T=941160 548240 1 180 $X=929380 $Y=547860
X1554 4827 1134 4085 2 1 4776 QDFFRBN $T=941160 638960 1 180 $X=929380 $Y=638580
X1555 4793 1134 4085 2 1 4730 QDFFRBN $T=944260 558320 1 180 $X=932480 $Y=557940
X1556 4902 1134 1150 2 1 4830 QDFFRBN $T=948600 649040 0 180 $X=936820 $Y=643620
X1557 1169 1134 816 2 1 4337 QDFFRBN $T=955420 649040 1 180 $X=943640 $Y=648660
X1558 1170 1134 816 2 1 4865 QDFFRBN $T=956040 669200 1 180 $X=944260 $Y=668820
X1559 4990 1134 1150 2 1 4876 QDFFRBN $T=971540 628880 0 180 $X=959760 $Y=623460
X1560 5030 1134 1150 2 1 4952 QDFFRBN $T=978980 649040 0 180 $X=967200 $Y=643620
X1561 5049 1134 1150 2 1 4791 QDFFRBN $T=984560 618800 1 180 $X=972780 $Y=618420
X1562 5046 1134 1150 2 1 5107 QDFFRBN $T=985800 649040 1 0 $X=985800 $Y=643620
X1563 5124 1134 1150 2 1 5077 QDFFRBN $T=1000680 638960 0 0 $X=1000680 $Y=638580
X1564 5163 1134 1150 2 1 4748 QDFFRBN $T=1014320 608720 1 180 $X=1002540 $Y=608340
X1565 5248 1134 1150 2 1 5183 QDFFRBN $T=1027960 638960 1 180 $X=1016180 $Y=638580
X1566 5210 1134 1150 2 1 5264 QDFFRBN $T=1018040 538160 0 0 $X=1018040 $Y=537780
X1567 5272 1134 1150 2 1 5244 QDFFRBN $T=1042220 628880 1 180 $X=1030440 $Y=628500
X1568 5346 1134 1150 2 1 5259 QDFFRBN $T=1044700 638960 1 180 $X=1032920 $Y=638580
X1569 5317 1134 1150 2 1 5302 QDFFRBN $T=1054000 538160 1 180 $X=1042220 $Y=537780
X1570 5387 1134 1150 2 1 5371 QDFFRBN $T=1066400 548240 0 180 $X=1054620 $Y=542820
X1571 5466 1134 1150 2 1 5369 QDFFRBN $T=1080660 628880 1 180 $X=1068880 $Y=628500
X1572 5471 1134 1150 2 1 5445 QDFFRBN $T=1083760 538160 1 180 $X=1071980 $Y=537780
X1573 5468 1134 1150 2 1 5449 QDFFRBN $T=1084380 598640 0 180 $X=1072600 $Y=593220
X1574 5484 1134 1150 2 1 5379 QDFFRBN $T=1084380 618800 1 180 $X=1072600 $Y=618420
X1575 5501 1134 1150 2 1 5461 QDFFRBN $T=1091200 558320 1 180 $X=1079420 $Y=557940
X1576 5497 1134 1150 2 1 5469 QDFFRBN $T=1093060 608720 1 180 $X=1081280 $Y=608340
X1577 5499 1134 1150 2 1 5465 QDFFRBN $T=1093680 538160 0 180 $X=1081900 $Y=532740
X1578 5498 1134 1150 2 1 5474 QDFFRBN $T=1093680 578480 1 180 $X=1081900 $Y=578100
X1579 1307 2 16 1 INV1S $T=225060 507920 1 0 $X=225060 $Y=502500
X1580 1357 2 1311 1 INV1S $T=226300 649040 1 180 $X=225060 $Y=648660
X1581 1333 2 1305 1 INV1S $T=226300 679280 0 180 $X=225060 $Y=673860
X1582 1320 2 1302 1 INV1S $T=226300 689360 1 180 $X=225060 $Y=688980
X1583 1315 2 19 1 INV1S $T=225680 518000 0 0 $X=225680 $Y=517620
X1584 1330 2 1301 1 INV1S $T=227540 659120 1 180 $X=226300 $Y=658740
X1585 23 2 30 1 INV1S $T=226920 507920 1 0 $X=226920 $Y=502500
X1586 1303 2 1332 1 INV1S $T=228160 608720 1 180 $X=226920 $Y=608340
X1587 1360 2 1316 1 INV1S $T=230020 628880 1 180 $X=228780 $Y=628500
X1588 53 2 37 1 INV1S $T=230640 538160 0 180 $X=229400 $Y=532740
X1589 31 2 1349 1 INV1S $T=229400 598640 0 0 $X=229400 $Y=598260
X1590 26 2 38 1 INV1S $T=230640 669200 0 180 $X=229400 $Y=663780
X1591 48 2 8 1 INV1S $T=231260 699440 0 180 $X=230020 $Y=694020
X1592 1364 2 1319 1 INV1S $T=231880 638960 1 180 $X=230640 $Y=638580
X1593 13 2 1366 1 INV1S $T=231260 518000 0 0 $X=231260 $Y=517620
X1594 31 2 29 1 INV1S $T=232500 649040 0 0 $X=232500 $Y=648660
X1595 1385 2 1383 1 INV1S $T=236220 538160 0 180 $X=234980 $Y=532740
X1596 1384 2 1324 1 INV1S $T=235600 528080 1 0 $X=235600 $Y=522660
X1597 1374 2 1389 1 INV1S $T=235600 689360 1 0 $X=235600 $Y=683940
X1598 1390 2 1387 1 INV1S $T=237460 518000 1 180 $X=236220 $Y=517620
X1599 59 2 67 1 INV1S $T=236840 538160 1 0 $X=236840 $Y=532740
X1600 1353 2 63 1 INV1S $T=237460 588560 0 0 $X=237460 $Y=588180
X1601 1405 2 107 1 INV1S $T=238700 598640 1 0 $X=238700 $Y=593220
X1602 1417 2 1391 1 INV1S $T=241180 608720 0 180 $X=239940 $Y=603300
X1603 1422 2 1359 1 INV1S $T=241800 618800 1 180 $X=240560 $Y=618420
X1604 85 2 82 1 INV1S $T=242420 659120 0 0 $X=242420 $Y=658740
X1605 85 2 1430 1 INV1S $T=242420 679280 0 0 $X=242420 $Y=678900
X1606 79 2 1367 1 INV1S $T=243040 538160 0 0 $X=243040 $Y=537780
X1607 1410 2 1331 1 INV1S $T=245520 538160 1 180 $X=244280 $Y=537780
X1608 98 2 41 1 INV1S $T=246140 518000 0 180 $X=244900 $Y=512580
X1609 85 2 1458 1 INV1S $T=246140 679280 0 0 $X=246140 $Y=678900
X1610 76 2 1444 1 INV1S $T=248000 659120 0 180 $X=246760 $Y=653700
X1611 104 2 42 1 INV1S $T=248000 528080 1 0 $X=248000 $Y=522660
X1612 111 2 1448 1 INV1S $T=249860 538160 0 180 $X=248620 $Y=532740
X1613 84 2 1496 1 INV1S $T=252340 649040 0 0 $X=252340 $Y=648660
X1614 130 2 49 1 INV1S $T=259160 507920 1 180 $X=257920 $Y=507540
X1615 125 2 1376 1 INV1S $T=261640 507920 1 0 $X=261640 $Y=502500
X1616 1573 2 1583 1 INV1S $T=265980 699440 1 0 $X=265980 $Y=694020
X1617 1523 2 1574 1 INV1S $T=266600 628880 0 0 $X=266600 $Y=628500
X1618 1589 2 145 1 INV1S $T=269080 528080 1 180 $X=267840 $Y=527700
X1619 102 2 1531 1 INV1S $T=270320 548240 0 180 $X=269080 $Y=542820
X1620 1509 2 1558 1 INV1S $T=270320 628880 0 180 $X=269080 $Y=623460
X1621 158 2 33 1 INV1S $T=270940 528080 1 180 $X=269700 $Y=527700
X1622 1571 2 1590 1 INV1S $T=270940 649040 0 180 $X=269700 $Y=643620
X1623 151 2 1597 1 INV1S $T=269700 659120 1 0 $X=269700 $Y=653700
X1624 1572 2 1602 1 INV1S $T=269700 669200 1 0 $X=269700 $Y=663780
X1625 121 2 152 1 INV1S $T=270940 679280 1 180 $X=269700 $Y=678900
X1626 1579 2 80 1 INV1S $T=270320 538160 0 0 $X=270320 $Y=537780
X1627 165 2 1476 1 INV1S $T=272180 507920 0 180 $X=270940 $Y=502500
X1628 1524 2 1568 1 INV1S $T=271560 649040 1 0 $X=271560 $Y=643620
X1629 1580 2 1582 1 INV1S $T=272800 679280 1 180 $X=271560 $Y=678900
X1630 1549 2 1605 1 INV1S $T=272180 528080 0 0 $X=272180 $Y=527700
X1631 45 2 136 1 INV1S $T=272180 558320 1 0 $X=272180 $Y=552900
X1632 156 2 4 1 INV1S $T=272800 528080 1 0 $X=272800 $Y=522660
X1633 151 2 169 1 INV1S $T=273420 679280 0 0 $X=273420 $Y=678900
X1634 1616 2 1613 1 INV1S $T=275900 659120 1 180 $X=274660 $Y=658740
X1635 1634 2 179 1 INV1S $T=277760 699440 0 180 $X=276520 $Y=694020
X1636 167 2 1639 1 INV1S $T=278380 659120 1 0 $X=278380 $Y=653700
X1637 151 2 1638 1 INV1S $T=280240 649040 0 180 $X=279000 $Y=643620
X1638 107 2 167 1 INV1S $T=279620 659120 1 0 $X=279620 $Y=653700
X1639 190 2 1653 1 INV1S $T=280860 649040 1 0 $X=280860 $Y=643620
X1640 166 2 194 1 INV1S $T=283960 548240 0 180 $X=282720 $Y=542820
X1641 1665 2 1674 1 INV1S $T=283340 679280 0 0 $X=283340 $Y=678900
X1642 141 2 200 1 INV1S $T=284580 699440 1 0 $X=284580 $Y=694020
X1643 161 2 1435 1 INV1S $T=285200 548240 1 0 $X=285200 $Y=542820
X1644 188 2 28 1 INV1S $T=285200 558320 1 0 $X=285200 $Y=552900
X1645 1670 2 1576 1 INV1S $T=287060 558320 1 0 $X=287060 $Y=552900
X1646 141 2 1687 1 INV1S $T=287060 669200 1 0 $X=287060 $Y=663780
X1647 210 2 1675 1 INV1S $T=291400 538160 0 180 $X=290160 $Y=532740
X1648 190 2 1690 1 INV1S $T=291400 649040 0 180 $X=290160 $Y=643620
X1649 190 2 1702 1 INV1S $T=290160 649040 0 0 $X=290160 $Y=648660
X1650 1684 2 211 1 INV1S $T=292640 548240 1 180 $X=291400 $Y=547860
X1651 193 2 1710 1 INV1S $T=291400 679280 0 0 $X=291400 $Y=678900
X1652 40 2 1668 1 INV1S $T=292020 558320 1 0 $X=292020 $Y=552900
X1653 190 2 214 1 INV1S $T=293260 638960 1 180 $X=292020 $Y=638580
X1654 1358 2 1667 1 INV1S $T=292640 528080 1 0 $X=292640 $Y=522660
X1655 34 2 140 1 INV1S $T=293260 538160 1 0 $X=293260 $Y=532740
X1656 189 2 220 1 INV1S $T=298220 528080 0 180 $X=296980 $Y=522660
X1657 62 2 199 1 INV1S $T=308140 538160 0 180 $X=306900 $Y=532740
X1658 1774 2 1640 1 INV1S $T=308140 558320 1 180 $X=306900 $Y=557940
X1659 1728 2 1790 1 INV1S $T=308760 538160 1 0 $X=308760 $Y=532740
X1660 1477 2 1807 1 INV1S $T=319300 528080 0 180 $X=318060 $Y=522660
X1661 25 2 205 1 INV1S $T=321780 548240 0 0 $X=321780 $Y=547860
X1662 1836 2 182 1 INV1S $T=324260 548240 0 180 $X=323020 $Y=542820
X1663 274 2 71 1 INV1S $T=324880 518000 1 180 $X=323640 $Y=517620
X1664 203 2 39 1 INV1S $T=327360 507920 0 180 $X=326120 $Y=502500
X1665 114 2 153 1 INV1S $T=327980 518000 1 0 $X=327980 $Y=512580
X1666 105 2 120 1 INV1S $T=330460 507920 0 180 $X=329220 $Y=502500
X1667 1793 2 174 1 INV1S $T=330460 528080 1 0 $X=330460 $Y=522660
X1668 1887 2 281 1 INV1S $T=332940 528080 0 180 $X=331700 $Y=522660
X1669 1881 2 1892 1 INV1S $T=332940 659120 0 0 $X=332940 $Y=658740
X1670 1879 2 1900 1 INV1S $T=336660 669200 0 0 $X=336660 $Y=668820
X1671 1886 2 1902 1 INV1S $T=337280 649040 0 0 $X=337280 $Y=648660
X1672 1888 2 1905 1 INV1S $T=342240 679280 0 180 $X=341000 $Y=673860
X1673 1911 2 1913 1 INV1S $T=343480 638960 0 0 $X=343480 $Y=638580
X1674 1899 2 1919 1 INV1S $T=344720 699440 1 0 $X=344720 $Y=694020
X1675 278 2 1930 1 INV1S $T=345340 659120 1 0 $X=345340 $Y=653700
X1676 131 2 1908 1 INV1S $T=345340 659120 0 0 $X=345340 $Y=658740
X1677 1936 2 1918 1 INV1S $T=347820 518000 0 180 $X=346580 $Y=512580
X1678 325 2 1921 1 INV1S $T=347820 518000 1 180 $X=346580 $Y=517620
X1679 1908 2 315 1 INV1S $T=347200 669200 1 0 $X=347200 $Y=663780
X1680 299 2 296 1 INV1S $T=350920 497840 1 180 $X=349680 $Y=497460
X1681 1970 2 1974 1 INV1S $T=354640 679280 1 0 $X=354640 $Y=673860
X1682 1954 2 1985 1 INV1S $T=355260 669200 1 0 $X=355260 $Y=663780
X1683 1931 2 1991 1 INV1S $T=357120 638960 1 0 $X=357120 $Y=633540
X1684 1980 2 1968 1 INV1S $T=358980 679280 1 180 $X=357740 $Y=678900
X1685 335 2 1923 1 INV1S $T=359600 497840 1 180 $X=358360 $Y=497460
X1686 269 2 333 1 INV1S $T=360840 669200 0 180 $X=359600 $Y=663780
X1687 269 2 2023 1 INV1S $T=361460 659120 0 0 $X=361460 $Y=658740
X1688 1951 2 262 1 INV1S $T=367040 628880 0 0 $X=367040 $Y=628500
X1689 258 2 2041 1 INV1S $T=368900 669200 1 0 $X=368900 $Y=663780
X1690 2043 2 2052 1 INV1S $T=371380 679280 1 0 $X=371380 $Y=673860
X1691 338 2 1977 1 INV1S $T=372000 649040 1 0 $X=372000 $Y=643620
X1692 2054 2 2049 1 INV1S $T=374480 689360 0 180 $X=373240 $Y=683940
X1693 2107 2 2086 1 INV1S $T=388120 679280 0 180 $X=386880 $Y=673860
X1694 2127 2 2111 1 INV1S $T=390600 649040 0 180 $X=389360 $Y=643620
X1695 2156 2 2150 1 INV1S $T=397420 679280 0 180 $X=396180 $Y=673860
X1696 383 2 1951 1 INV1S $T=399900 618800 1 180 $X=398660 $Y=618420
X1697 2177 2 2153 1 INV1S $T=403620 649040 0 180 $X=402380 $Y=643620
X1698 2177 2 2182 1 INV1S $T=404860 649040 0 180 $X=403620 $Y=643620
X1699 2189 2 1957 1 INV1S $T=406100 528080 1 180 $X=404860 $Y=527700
X1700 2192 2 1940 1 INV1S $T=407340 528080 1 180 $X=406100 $Y=527700
X1701 2191 2 2147 1 INV1S $T=407340 649040 0 180 $X=406100 $Y=643620
X1702 2180 2 2184 1 INV1S $T=406100 689360 1 0 $X=406100 $Y=683940
X1703 384 2 2204 1 INV1S $T=407340 679280 1 0 $X=407340 $Y=673860
X1704 2216 2 2221 1 INV1S $T=410440 679280 1 0 $X=410440 $Y=673860
X1705 2224 2 2215 1 INV1S $T=412920 659120 0 180 $X=411680 $Y=653700
X1706 2259 2 347 1 INV1S $T=421600 507920 1 0 $X=421600 $Y=502500
X1707 2264 2 2027 1 INV1S $T=422840 528080 1 180 $X=421600 $Y=527700
X1708 2159 2 2270 1 INV1S $T=421600 669200 1 0 $X=421600 $Y=663780
X1709 2256 2 2261 1 INV1S $T=423460 679280 0 0 $X=423460 $Y=678900
X1710 2271 2 2008 1 INV1S $T=425940 528080 1 180 $X=424700 $Y=527700
X1711 2287 2 2273 1 INV1S $T=425940 659120 0 180 $X=424700 $Y=653700
X1712 2298 2 2292 1 INV1S $T=430280 679280 1 180 $X=429040 $Y=678900
X1713 384 2 2209 1 INV1S $T=430280 679280 1 0 $X=430280 $Y=673860
X1714 2327 2 2322 1 INV1S $T=435860 679280 1 180 $X=434620 $Y=678900
X1715 2378 2 2365 1 INV1S $T=441440 679280 1 180 $X=440200 $Y=678900
X1716 2379 2 2307 1 INV1S $T=442060 528080 1 0 $X=442060 $Y=522660
X1717 2380 2 2366 1 INV1S $T=442060 548240 1 0 $X=442060 $Y=542820
X1718 425 2 2254 1 INV1S $T=445160 507920 0 180 $X=443920 $Y=502500
X1719 2411 2 2396 1 INV1S $T=449500 679280 1 180 $X=448260 $Y=678900
X1720 440 2 2429 1 INV1S $T=452600 497840 0 0 $X=452600 $Y=497460
X1721 2399 2 2438 1 INV1S $T=453840 679280 0 0 $X=453840 $Y=678900
X1722 2454 2 322 1 INV1S $T=456940 598640 0 180 $X=455700 $Y=593220
X1723 436 2 2443 1 INV1S $T=456320 507920 1 0 $X=456320 $Y=502500
X1724 2446 2 286 1 INV1S $T=457560 558320 0 180 $X=456320 $Y=552900
X1725 2432 2 2420 1 INV1S $T=457560 518000 1 0 $X=457560 $Y=512580
X1726 2456 2 2408 1 INV1S $T=460660 518000 1 180 $X=459420 $Y=517620
X1727 2459 2 2467 1 INV1S $T=461280 679280 0 0 $X=461280 $Y=678900
X1728 2448 2 449 1 INV1S $T=461900 497840 0 0 $X=461900 $Y=497460
X1729 2462 2 450 1 INV1S $T=463140 497840 0 0 $X=463140 $Y=497460
X1730 2497 2 370 1 INV1S $T=469340 598640 0 180 $X=468100 $Y=593220
X1731 2484 2 2496 1 INV1S $T=468720 679280 0 0 $X=468720 $Y=678900
X1732 384 2 2431 1 INV1S $T=476160 679280 1 0 $X=476160 $Y=673860
X1733 2444 2 2534 1 INV1S $T=478640 679280 0 0 $X=478640 $Y=678900
X1734 2547 2 387 1 INV1S $T=482360 548240 1 180 $X=481120 $Y=547860
X1735 2552 2 343 1 INV1S $T=483600 548240 1 180 $X=482360 $Y=547860
X1736 2474 2 2554 1 INV1S $T=482360 689360 1 0 $X=482360 $Y=683940
X1737 2518 2 2559 1 INV1S $T=482980 679280 1 0 $X=482980 $Y=673860
X1738 2566 2 389 1 INV1S $T=484840 659120 0 180 $X=483600 $Y=653700
X1739 2578 2 303 1 INV1S $T=488560 588560 0 180 $X=487320 $Y=583140
X1740 2487 2 2581 1 INV1S $T=487940 669200 1 0 $X=487940 $Y=663780
X1741 2588 2 287 1 INV1S $T=490420 568400 1 180 $X=489180 $Y=568020
X1742 2539 2 2606 1 INV1S $T=492900 669200 0 0 $X=492900 $Y=668820
X1743 2492 2 2614 1 INV1S $T=493520 679280 1 0 $X=493520 $Y=673860
X1744 2550 2 2597 1 INV1S $T=494760 699440 0 180 $X=493520 $Y=694020
X1745 2618 2 300 1 INV1S $T=495380 548240 1 180 $X=494140 $Y=547860
X1746 2627 2 295 1 INV1S $T=497860 558320 0 180 $X=496620 $Y=552900
X1747 2638 2 2634 1 INV1S $T=502200 528080 0 180 $X=500960 $Y=522660
X1748 2645 2 305 1 INV1S $T=502200 588560 1 180 $X=500960 $Y=588180
X1749 2651 2 349 1 INV1S $T=503440 588560 1 180 $X=502200 $Y=588180
X1750 491 2 2663 1 INV1S $T=505920 628880 0 180 $X=504680 $Y=623460
X1751 2672 2 2660 1 INV1S $T=506540 638960 0 180 $X=505300 $Y=633540
X1752 2654 2 382 1 INV1S $T=507780 568400 0 180 $X=506540 $Y=562980
X1753 494 2 2676 1 INV1S $T=506540 628880 1 0 $X=506540 $Y=623460
X1754 2677 2 2642 1 INV1S $T=507780 649040 0 180 $X=506540 $Y=643620
X1755 2687 2 381 1 INV1S $T=509020 578480 1 180 $X=507780 $Y=578100
X1756 498 2 2699 1 INV1S $T=508400 618800 1 0 $X=508400 $Y=613380
X1757 2728 2 351 1 INV1S $T=510260 578480 1 180 $X=509020 $Y=578100
X1758 319 2 2696 1 INV1S $T=509020 638960 1 0 $X=509020 $Y=633540
X1759 486 2 2694 1 INV1S $T=511500 608720 0 0 $X=511500 $Y=608340
X1760 2712 2 2701 1 INV1S $T=512740 638960 0 180 $X=511500 $Y=633540
X1761 2725 2 337 1 INV1S $T=514600 588560 1 180 $X=513360 $Y=588180
X1762 2700 2 2652 1 INV1S $T=513360 608720 0 0 $X=513360 $Y=608340
X1763 2688 2 2664 1 INV1S $T=513980 598640 1 0 $X=513980 $Y=593220
X1764 323 2 2729 1 INV1S $T=514600 608720 0 0 $X=514600 $Y=608340
X1765 2774 2 390 1 INV1S $T=516460 548240 1 180 $X=515220 $Y=547860
X1766 2785 2 359 1 INV1S $T=518940 538160 1 180 $X=517700 $Y=537780
X1767 2741 2 2747 1 INV1S $T=517700 649040 0 0 $X=517700 $Y=648660
X1768 530 2 2742 1 INV1S $T=518940 638960 0 0 $X=518940 $Y=638580
X1769 506 2 2768 1 INV1S $T=520800 659120 1 0 $X=520800 $Y=653700
X1770 544 2 515 1 INV1S $T=522040 689360 0 180 $X=520800 $Y=683940
X1771 550 2 547 1 INV1S $T=523280 659120 0 180 $X=522040 $Y=653700
X1772 316 2 2778 1 INV1S $T=522660 628880 0 0 $X=522660 $Y=628500
X1773 2781 2 2762 1 INV1S $T=524520 528080 0 180 $X=523280 $Y=522660
X1774 2776 2 2763 1 INV1S $T=523280 588560 0 0 $X=523280 $Y=588180
X1775 536 2 556 1 INV1S $T=523280 679280 0 0 $X=523280 $Y=678900
X1776 555 2 2786 1 INV1S $T=523900 598640 1 0 $X=523900 $Y=593220
X1777 2789 2 329 1 INV1S $T=525760 548240 0 180 $X=524520 $Y=542820
X1778 2790 2 375 1 INV1S $T=525760 568400 1 180 $X=524520 $Y=568020
X1779 2787 2 2689 1 INV1S $T=524520 638960 0 0 $X=524520 $Y=638580
X1780 2782 2 355 1 INV1S $T=526380 568400 0 180 $X=525140 $Y=562980
X1781 2761 2 2715 1 INV1S $T=525760 618800 0 0 $X=525760 $Y=618420
X1782 2800 2 2707 1 INV1S $T=527620 568400 0 180 $X=526380 $Y=562980
X1783 2717 2 2738 1 INV1S $T=528240 608720 0 180 $X=527000 $Y=603300
X1784 2905 2 342 1 INV1S $T=531960 558320 1 180 $X=530720 $Y=557940
X1785 519 2 586 1 INV1S $T=530720 689360 1 0 $X=530720 $Y=683940
X1786 520 2 574 1 INV1S $T=531960 689360 1 0 $X=531960 $Y=683940
X1787 2851 2 346 1 INV1S $T=535060 578480 0 180 $X=533820 $Y=573060
X1788 502 2 592 1 INV1S $T=536920 659120 0 180 $X=535680 $Y=653700
X1789 2865 2 2861 1 INV1S $T=538160 548240 0 180 $X=536920 $Y=542820
X1790 526 2 611 1 INV1S $T=536920 689360 1 0 $X=536920 $Y=683940
X1791 2859 2 2853 1 INV1S $T=538780 507920 1 180 $X=537540 $Y=507540
X1792 2856 2 2840 1 INV1S $T=538780 528080 0 180 $X=537540 $Y=522660
X1793 591 2 609 1 INV1S $T=538160 659120 1 0 $X=538160 $Y=653700
X1794 2878 2 2764 1 INV1S $T=540020 518000 1 180 $X=538780 $Y=517620
X1795 2887 2 2822 1 INV1S $T=540640 548240 1 180 $X=539400 $Y=547860
X1796 2888 2 2827 1 INV1S $T=541880 518000 1 180 $X=540640 $Y=517620
X1797 2889 2 2756 1 INV1S $T=541880 528080 1 180 $X=540640 $Y=527700
X1798 328 2 2896 1 INV1S $T=541260 608720 1 0 $X=541260 $Y=603300
X1799 613 2 598 1 INV1S $T=542500 669200 1 180 $X=541260 $Y=668820
X1800 565 2 622 1 INV1S $T=541260 679280 0 0 $X=541260 $Y=678900
X1801 2901 2 2788 1 INV1S $T=543120 528080 1 180 $X=541880 $Y=527700
X1802 2926 2 2780 1 INV1S $T=544360 538160 0 180 $X=543120 $Y=532740
X1803 335 2 2891 1 INV1S $T=544360 568400 1 180 $X=543120 $Y=568020
X1804 531 2 624 1 INV1S $T=543120 699440 1 0 $X=543120 $Y=694020
X1805 2918 2 2798 1 INV1S $T=544980 538160 1 180 $X=543740 $Y=537780
X1806 626 2 2791 1 INV1S $T=545600 638960 1 180 $X=544360 $Y=638580
X1807 562 2 628 1 INV1S $T=544360 679280 0 0 $X=544360 $Y=678900
X1808 2929 2 2803 1 INV1S $T=546840 548240 0 180 $X=545600 $Y=542820
X1809 2945 2 2815 1 INV1S $T=547460 538160 0 180 $X=546220 $Y=532740
X1810 2933 2 2772 1 INV1S $T=547460 568400 0 180 $X=546220 $Y=562980
X1811 334 2 2915 1 INV1S $T=546220 568400 0 0 $X=546220 $Y=568020
X1812 2968 2 2751 1 INV1S $T=548700 558320 1 180 $X=547460 $Y=557940
X1813 507 2 2946 1 INV1S $T=548080 528080 0 0 $X=548080 $Y=527700
X1814 2869 2 2807 1 INV1S $T=548080 618800 1 0 $X=548080 $Y=613380
X1815 1936 2 2931 1 INV1S $T=549320 588560 0 0 $X=549320 $Y=588180
X1816 571 2 638 1 INV1S $T=549320 689360 1 0 $X=549320 $Y=683940
X1817 2863 2 2963 1 INV1S $T=550560 608720 1 0 $X=550560 $Y=603300
X1818 637 2 2916 1 INV1S $T=553040 588560 1 180 $X=551800 $Y=588180
X1819 2906 2 2966 1 INV1S $T=552420 638960 1 0 $X=552420 $Y=633540
X1820 648 2 2813 1 INV1S $T=554900 638960 0 180 $X=553660 $Y=633540
X1821 327 2 2955 1 INV1S $T=561100 578480 1 180 $X=559860 $Y=578100
X1822 3014 2 2852 1 INV1S $T=559860 638960 1 0 $X=559860 $Y=633540
X1823 2984 2 660 1 INV1S $T=561720 518000 1 0 $X=561720 $Y=512580
X1824 3048 2 2675 1 INV1S $T=562960 588560 1 180 $X=561720 $Y=588180
X1825 2994 2 2947 1 INV1S $T=561720 608720 1 0 $X=561720 $Y=603300
X1826 2771 2 3035 1 INV1S $T=561720 618800 1 0 $X=561720 $Y=613380
X1827 2733 2 3042 1 INV1S $T=562960 598640 0 0 $X=562960 $Y=598260
X1828 3039 2 2995 1 INV1S $T=563580 548240 1 0 $X=563580 $Y=542820
X1829 2938 2 2777 1 INV1S $T=563580 638960 0 0 $X=563580 $Y=638580
X1830 2691 2 3086 1 INV1S $T=565440 598640 1 0 $X=565440 $Y=593220
X1831 3047 2 3077 1 INV1S $T=566680 558320 1 0 $X=566680 $Y=552900
X1832 2732 2 3087 1 INV1S $T=567920 618800 0 180 $X=566680 $Y=613380
X1833 667 2 3090 1 INV1S $T=567300 699440 1 0 $X=567300 $Y=694020
X1834 2956 2 3100 1 INV1S $T=567920 618800 1 0 $X=567920 $Y=613380
X1835 612 2 3034 1 INV1S $T=568540 699440 1 0 $X=568540 $Y=694020
X1836 3072 2 3105 1 INV1S $T=571020 507920 0 180 $X=569780 $Y=502500
X1837 3105 2 678 1 INV1S $T=571640 497840 1 180 $X=570400 $Y=497460
X1838 2941 2 663 1 INV1S $T=571640 528080 1 0 $X=571640 $Y=522660
X1839 2979 2 672 1 INV1S $T=571640 528080 0 0 $X=571640 $Y=527700
X1840 3145 2 2692 1 INV1S $T=572880 588560 1 180 $X=571640 $Y=588180
X1841 2920 2 3136 1 INV1S $T=571640 618800 1 0 $X=571640 $Y=613380
X1842 3123 2 2952 1 INV1S $T=573500 558320 0 180 $X=572260 $Y=552900
X1843 3129 2 617 1 INV1S $T=575360 528080 0 0 $X=575360 $Y=527700
X1844 3079 2 3165 1 INV1S $T=575980 628880 1 0 $X=575980 $Y=623460
X1845 3177 2 3140 1 INV1S $T=578460 538160 1 180 $X=577220 $Y=537780
X1846 3167 2 3174 1 INV1S $T=577220 608720 1 0 $X=577220 $Y=603300
X1847 2828 2 3161 1 INV1S $T=577220 618800 1 0 $X=577220 $Y=613380
X1848 3186 2 2709 1 INV1S $T=579700 578480 0 180 $X=578460 $Y=573060
X1849 3201 2 3170 1 INV1S $T=583420 618800 1 180 $X=582180 $Y=618420
X1850 3205 2 3210 1 INV1S $T=583420 598640 1 0 $X=583420 $Y=593220
X1851 653 2 706 1 INV1S $T=584040 689360 1 0 $X=584040 $Y=683940
X1852 3046 2 3200 1 INV1S $T=584660 628880 0 0 $X=584660 $Y=628500
X1853 2971 2 708 1 INV1S $T=587140 528080 1 0 $X=587140 $Y=522660
X1854 3221 2 3233 1 INV1S $T=587760 538160 0 0 $X=587760 $Y=537780
X1855 2886 2 3097 1 INV1S $T=589620 608720 0 180 $X=588380 $Y=603300
X1856 3238 2 2775 1 INV1S $T=590240 568400 0 180 $X=589000 $Y=562980
X1857 3245 2 3063 1 INV1S $T=590860 528080 0 180 $X=589620 $Y=522660
X1858 3232 2 3080 1 INV1S $T=590860 528080 1 180 $X=589620 $Y=527700
X1859 583 2 3263 1 INV1S $T=589620 669200 0 0 $X=589620 $Y=668820
X1860 3250 2 3246 1 INV1S $T=592100 548240 0 180 $X=590860 $Y=542820
X1861 3197 2 3176 1 INV1S $T=590860 608720 0 0 $X=590860 $Y=608340
X1862 3031 2 721 1 INV1S $T=591480 689360 1 0 $X=591480 $Y=683940
X1863 3187 2 709 1 INV1S $T=592100 598640 1 0 $X=592100 $Y=593220
X1864 3195 2 3248 1 INV1S $T=594580 618800 1 0 $X=594580 $Y=613380
X1865 3225 2 3284 1 INV1S $T=595820 669200 1 0 $X=595820 $Y=663780
X1866 3282 2 729 1 INV1S $T=596440 578480 1 0 $X=596440 $Y=573060
X1867 3264 2 733 1 INV1S $T=597060 588560 1 0 $X=597060 $Y=583140
X1868 2981 2 3266 1 INV1S $T=597680 608720 0 0 $X=597680 $Y=608340
X1869 3294 2 736 1 INV1S $T=598920 598640 1 0 $X=598920 $Y=593220
X1870 3298 2 3345 1 INV1S $T=607600 578480 0 0 $X=607600 $Y=578100
X1871 3030 2 3120 1 INV1S $T=608840 618800 1 180 $X=607600 $Y=618420
X1872 713 2 734 1 INV1S $T=608840 578480 1 0 $X=608840 $Y=573060
X1873 3370 2 2804 1 INV1S $T=611940 588560 1 180 $X=610700 $Y=588180
X1874 3328 2 3008 1 INV1S $T=611320 659120 1 0 $X=611320 $Y=653700
X1875 3374 2 2752 1 INV1S $T=614420 578480 0 180 $X=613180 $Y=573060
X1876 3397 2 2801 1 INV1S $T=618760 578480 0 180 $X=617520 $Y=573060
X1877 3410 2 2879 1 INV1S $T=620620 578480 1 180 $X=619380 $Y=578100
X1878 3429 2 2783 1 INV1S $T=622480 578480 1 180 $X=621240 $Y=578100
X1879 3412 2 3390 1 INV1S $T=622480 628880 0 180 $X=621240 $Y=623460
X1880 3012 2 671 1 INV1S $T=622480 608720 0 0 $X=622480 $Y=608340
X1881 3447 2 3434 1 INV1S $T=626200 558320 0 180 $X=624960 $Y=552900
X1882 3452 2 2845 1 INV1S $T=626200 578480 0 180 $X=624960 $Y=573060
X1883 3468 2 2890 1 INV1S $T=631160 568400 0 180 $X=629920 $Y=562980
X1884 3480 2 3356 1 INV1S $T=631160 689360 1 180 $X=629920 $Y=688980
X1885 658 2 3376 1 INV1S $T=632400 608720 1 180 $X=631160 $Y=608340
X1886 2977 2 3322 1 INV1S $T=631160 628880 0 0 $X=631160 $Y=628500
X1887 2866 2 3365 1 INV1S $T=633020 608720 0 0 $X=633020 $Y=608340
X1888 633 2 3313 1 INV1S $T=633640 659120 0 0 $X=633640 $Y=658740
X1889 659 2 3240 1 INV1S $T=634880 669200 1 180 $X=633640 $Y=668820
X1890 3157 2 640 1 INV1S $T=634880 689360 1 0 $X=634880 $Y=683940
X1891 3402 2 3339 1 INV1S $T=637360 618800 1 180 $X=636120 $Y=618420
X1892 3389 2 3491 1 INV1S $T=636740 518000 0 0 $X=636740 $Y=517620
X1893 3119 2 3203 1 INV1S $T=639220 628880 1 0 $X=639220 $Y=623460
X1894 668 2 3355 1 INV1S $T=639220 638960 1 0 $X=639220 $Y=633540
X1895 3182 2 685 1 INV1S $T=640460 628880 1 0 $X=640460 $Y=623460
X1896 3521 2 2874 1 INV1S $T=642320 578480 0 180 $X=641080 $Y=573060
X1897 670 2 3473 1 INV1S $T=642320 628880 1 0 $X=642320 $Y=623460
X1898 635 2 3465 1 INV1S $T=643560 669200 1 180 $X=642320 $Y=668820
X1899 3073 2 3291 1 INV1S $T=642940 608720 0 0 $X=642940 $Y=608340
X1900 3065 2 3216 1 INV1S $T=644180 638960 1 180 $X=642940 $Y=638580
X1901 3122 2 3159 1 INV1S $T=644180 638960 0 0 $X=644180 $Y=638580
X1902 3061 2 3438 1 INV1S $T=646040 628880 0 180 $X=644800 $Y=623460
X1903 3147 2 3160 1 INV1S $T=646040 638960 0 180 $X=644800 $Y=633540
X1904 3476 2 3424 1 INV1S $T=646040 659120 0 0 $X=646040 $Y=658740
X1905 3059 2 3306 1 INV1S $T=646660 628880 1 0 $X=646660 $Y=623460
X1906 825 2 829 1 INV1S $T=649140 518000 0 0 $X=649140 $Y=517620
X1907 3234 2 2877 1 INV1S $T=650380 618800 1 180 $X=649140 $Y=618420
X1908 3539 2 818 1 INV1S $T=651620 689360 1 180 $X=650380 $Y=688980
X1909 3541 2 2769 1 INV1S $T=652240 588560 1 180 $X=651000 $Y=588180
X1910 3538 2 3536 1 INV1S $T=652860 518000 0 180 $X=651620 $Y=512580
X1911 766 2 3494 1 INV1S $T=653480 659120 1 180 $X=652240 $Y=658740
X1912 830 2 832 1 INV1S $T=654100 518000 1 0 $X=654100 $Y=512580
X1913 3545 2 3573 1 INV1S $T=658440 638960 1 0 $X=658440 $Y=633540
X1914 3569 2 3579 1 INV1S $T=660300 638960 1 0 $X=660300 $Y=633540
X1915 3555 2 3570 1 INV1S $T=660300 679280 1 0 $X=660300 $Y=673860
X1916 3560 2 3556 1 INV1S $T=660920 628880 1 0 $X=660920 $Y=623460
X1917 3583 2 3590 1 INV1S $T=662160 638960 1 0 $X=662160 $Y=633540
X1918 834 2 3563 1 INV1S $T=664020 608720 0 0 $X=664020 $Y=608340
X1919 3584 2 3585 1 INV1S $T=665260 638960 1 180 $X=664020 $Y=638580
X1920 3601 2 2846 1 INV1S $T=665880 588560 1 180 $X=664640 $Y=588180
X1921 3605 2 3616 1 INV1S $T=668980 618800 0 0 $X=668980 $Y=618420
X1922 863 2 3627 1 INV1S $T=670840 679280 1 0 $X=670840 $Y=673860
X1923 3615 2 3612 1 INV1S $T=672700 649040 0 180 $X=671460 $Y=643620
X1924 3632 2 3623 1 INV1S $T=675180 638960 0 180 $X=673940 $Y=633540
X1925 3635 2 3644 1 INV1S $T=677040 649040 1 0 $X=677040 $Y=643620
X1926 816 2 3662 1 INV1S $T=678900 689360 1 0 $X=678900 $Y=683940
X1927 3668 2 3669 1 INV1S $T=686340 628880 1 180 $X=685100 $Y=628500
X1928 3684 2 3667 1 INV1S $T=687580 638960 0 180 $X=686340 $Y=633540
X1929 891 2 3681 1 INV1S $T=687580 669200 1 180 $X=686340 $Y=668820
X1930 3588 2 3694 1 INV1S $T=689440 538160 0 0 $X=689440 $Y=537780
X1931 3675 2 3700 1 INV1S $T=691920 638960 1 0 $X=691920 $Y=633540
X1932 523 2 548 1 INV1S $T=692540 507920 0 0 $X=692540 $Y=507540
X1933 3713 2 3702 1 INV1S $T=694400 628880 1 180 $X=693160 $Y=628500
X1934 897 2 3730 1 INV1S $T=694400 699440 1 0 $X=694400 $Y=694020
X1935 3726 2 2921 1 INV1S $T=698120 578480 0 180 $X=696880 $Y=573060
X1936 3712 2 3733 1 INV1S $T=701220 638960 0 180 $X=699980 $Y=633540
X1937 905 2 3748 1 INV1S $T=703700 669200 0 180 $X=702460 $Y=663780
X1938 3732 2 3758 1 INV1S $T=704940 618800 0 0 $X=704940 $Y=618420
X1939 703 2 909 1 INV1S $T=705560 497840 0 0 $X=705560 $Y=497460
X1940 3718 2 3785 1 INV1S $T=711140 638960 0 180 $X=709900 $Y=633540
X1941 3794 2 3784 1 INV1S $T=711140 628880 1 0 $X=711140 $Y=623460
X1942 3742 2 3808 1 INV1S $T=713000 638960 0 0 $X=713000 $Y=638580
X1943 925 2 3802 1 INV1S $T=716720 689360 1 180 $X=715480 $Y=688980
X1944 2903 2 3817 1 INV1S $T=716100 518000 1 0 $X=716100 $Y=512580
X1945 930 2 3840 1 INV1S $T=722920 689360 1 180 $X=721680 $Y=688980
X1946 3864 2 3838 1 INV1S $T=724780 628880 1 180 $X=723540 $Y=628500
X1947 926 2 3805 1 INV1S $T=725400 669200 0 180 $X=724160 $Y=663780
X1948 931 2 3865 1 INV1S $T=725400 669200 0 0 $X=725400 $Y=668820
X1949 3754 2 3860 1 INV1S $T=728500 628880 0 0 $X=728500 $Y=628500
X1950 3886 2 3891 1 INV1S $T=730360 628880 0 0 $X=730360 $Y=628500
X1951 3776 2 3923 1 INV1S $T=739040 638960 1 0 $X=739040 $Y=633540
X1952 947 2 3924 1 INV1S $T=742140 669200 1 180 $X=740900 $Y=668820
X1953 3904 2 3950 1 INV1S $T=742140 628880 0 0 $X=742140 $Y=628500
X1954 3973 2 3977 1 INV1S $T=750200 638960 1 0 $X=750200 $Y=633540
X1955 954 2 3959 1 INV1S $T=751440 669200 0 180 $X=750200 $Y=663780
X1956 3953 2 3982 1 INV1S $T=752060 628880 0 0 $X=752060 $Y=628500
X1957 4014 2 4020 1 INV1S $T=759500 649040 1 0 $X=759500 $Y=643620
X1958 3970 2 4029 1 INV1S $T=761360 628880 1 0 $X=761360 $Y=623460
X1959 962 2 4036 1 INV1S $T=763220 679280 0 0 $X=763220 $Y=678900
X1960 964 2 4041 1 INV1S $T=766320 669200 0 180 $X=765080 $Y=663780
X1961 970 2 4085 1 INV1S $T=771900 628880 0 0 $X=771900 $Y=628500
X1962 978 2 981 1 INV1S $T=776860 518000 0 0 $X=776860 $Y=517620
X1963 4101 2 4094 1 INV1S $T=778100 638960 1 180 $X=776860 $Y=638580
X1964 983 2 4158 1 INV1S $T=779960 679280 0 0 $X=779960 $Y=678900
X1965 4124 2 4110 1 INV1S $T=781200 628880 0 0 $X=781200 $Y=628500
X1966 4128 2 4133 1 INV1S $T=781820 638960 0 0 $X=781820 $Y=638580
X1967 4140 2 4163 1 INV1S $T=787400 528080 1 0 $X=787400 $Y=522660
X1968 4148 2 4150 1 INV1S $T=789260 538160 1 180 $X=788020 $Y=537780
X1969 4159 2 4171 1 INV1S $T=789260 638960 1 0 $X=789260 $Y=633540
X1970 4172 2 4183 1 INV1S $T=789880 649040 1 0 $X=789880 $Y=643620
X1971 986 2 4178 1 INV1S $T=792360 507920 1 0 $X=792360 $Y=502500
X1972 825 2 999 1 INV1S $T=792360 518000 1 0 $X=792360 $Y=512580
X1973 4199 2 4186 1 INV1S $T=794220 538160 1 180 $X=792980 $Y=537780
X1974 4190 2 4237 1 INV1S $T=795460 578480 1 0 $X=795460 $Y=573060
X1975 4198 2 4216 1 INV1S $T=796700 558320 0 0 $X=796700 $Y=557940
X1976 1000 2 4223 1 INV1S $T=799800 507920 1 0 $X=799800 $Y=502500
X1977 4180 2 4224 1 INV1S $T=800420 548240 1 0 $X=800420 $Y=542820
X1978 4229 2 4234 1 INV1S $T=802280 528080 0 0 $X=802280 $Y=527700
X1979 4175 2 4220 1 INV1S $T=803520 558320 1 180 $X=802280 $Y=557940
X1980 4225 2 4249 1 INV1S $T=802280 638960 1 0 $X=802280 $Y=633540
X1981 4239 2 4248 1 INV1S $T=802280 659120 1 0 $X=802280 $Y=653700
X1982 4181 2 4245 1 INV1S $T=804760 548240 1 180 $X=803520 $Y=547860
X1983 830 2 1013 1 INV1S $T=804140 528080 1 0 $X=804140 $Y=522660
X1984 1010 2 4257 1 INV1S $T=806620 669200 0 0 $X=806620 $Y=668820
X1985 1011 2 4270 1 INV1S $T=807240 507920 1 0 $X=807240 $Y=502500
X1986 4268 2 4261 1 INV1S $T=809720 578480 1 0 $X=809720 $Y=573060
X1987 1014 2 4303 1 INV1S $T=815920 507920 1 0 $X=815920 $Y=502500
X1988 4293 2 4314 1 INV1S $T=819020 578480 1 0 $X=819020 $Y=573060
X1989 4320 2 4348 1 INV1S $T=825840 578480 0 0 $X=825840 $Y=578100
X1990 1033 2 4341 1 INV1S $T=827700 497840 1 180 $X=826460 $Y=497460
X1991 1037 2 4373 1 INV1S $T=830180 507920 1 0 $X=830180 $Y=502500
X1992 4385 2 4382 1 INV1S $T=833900 568400 1 180 $X=832660 $Y=568020
X1993 1051 2 4409 1 INV1S $T=840720 497840 1 180 $X=839480 $Y=497460
X1994 4418 2 4405 1 INV1S $T=840720 568400 1 180 $X=839480 $Y=568020
X1995 1052 2 4153 1 INV1S $T=843200 538160 0 180 $X=841960 $Y=532740
X1996 1029 2 4327 1 INV1S $T=844440 538160 0 0 $X=844440 $Y=537780
X1997 4434 2 4134 1 INV1S $T=845680 578480 0 0 $X=845680 $Y=578100
X1998 4441 2 4443 1 INV1S $T=847540 578480 0 0 $X=847540 $Y=578100
X1999 4449 2 4466 1 INV1S $T=851880 558320 0 0 $X=851880 $Y=557940
X2000 4468 2 4477 1 INV1S $T=856840 568400 0 0 $X=856840 $Y=568020
X2001 1064 2 4480 1 INV1S $T=859940 507920 0 180 $X=858700 $Y=502500
X2002 4507 2 4496 1 INV1S $T=863660 538160 1 180 $X=862420 $Y=537780
X2003 4493 2 4513 1 INV1S $T=863660 578480 0 0 $X=863660 $Y=578100
X2004 4511 2 4492 1 INV1S $T=865520 558320 1 180 $X=864280 $Y=557940
X2005 1071 2 4519 1 INV1S $T=866760 497840 0 0 $X=866760 $Y=497460
X2006 4501 2 4529 1 INV1S $T=867380 548240 0 0 $X=867380 $Y=547860
X2007 1076 2 4535 1 INV1S $T=871720 497840 0 0 $X=871720 $Y=497460
X2008 4543 2 4545 1 INV1S $T=872960 558320 1 180 $X=871720 $Y=557940
X2009 4540 2 4552 1 INV1S $T=872340 568400 1 0 $X=872340 $Y=562980
X2010 4559 2 4299 1 INV1S $T=874820 558320 1 180 $X=873580 $Y=557940
X2011 4567 2 4563 1 INV1S $T=876680 538160 0 180 $X=875440 $Y=532740
X2012 1065 2 4556 1 INV1S $T=875440 538160 0 0 $X=875440 $Y=537780
X2013 4579 2 4581 1 INV1S $T=881020 568400 0 180 $X=879780 $Y=562980
X2014 4327 2 4560 1 INV1S $T=880400 538160 0 0 $X=880400 $Y=537780
X2015 4587 2 4590 1 INV1S $T=880400 588560 0 0 $X=880400 $Y=588180
X2016 4585 2 4595 1 INV1S $T=883500 538160 0 180 $X=882260 $Y=532740
X2017 4588 2 4610 1 INV1S $T=883500 548240 1 0 $X=883500 $Y=542820
X2018 4573 2 4259 1 INV1S $T=883500 548240 0 0 $X=883500 $Y=547860
X2019 1092 2 1028 1 INV1S $T=885980 497840 1 180 $X=884740 $Y=497460
X2020 4615 2 4622 1 INV1S $T=885980 558320 0 0 $X=885980 $Y=557940
X2021 1090 2 4625 1 INV1S $T=886600 497840 0 0 $X=886600 $Y=497460
X2022 4618 2 4626 1 INV1S $T=887840 568400 0 0 $X=887840 $Y=568020
X2023 4621 2 4629 1 INV1S $T=888460 548240 0 0 $X=888460 $Y=547860
X2024 4578 2 4638 1 INV1S $T=890320 548240 0 0 $X=890320 $Y=547860
X2025 4664 2 4668 1 INV1S $T=897140 538160 0 0 $X=897140 $Y=537780
X2026 4655 2 4666 1 INV1S $T=898380 548240 1 180 $X=897140 $Y=547860
X2027 4671 2 4657 1 INV1S $T=899000 638960 1 180 $X=897760 $Y=638580
X2028 1052 2 4434 1 INV1S $T=900860 548240 0 180 $X=899620 $Y=542820
X2029 1110 2 4690 1 INV1S $T=901480 497840 0 0 $X=901480 $Y=497460
X2030 869 2 4474 1 INV1S $T=905200 588560 1 0 $X=905200 $Y=583140
X2031 1121 2 1119 1 INV1S $T=912020 497840 1 180 $X=910780 $Y=497460
X2032 4766 2 4788 1 INV1S $T=926280 578480 1 0 $X=926280 $Y=573060
X2033 869 2 4798 1 INV1S $T=930000 598640 1 0 $X=930000 $Y=593220
X2034 4828 2 4822 1 INV1S $T=939920 518000 1 180 $X=938680 $Y=517620
X2035 978 2 1149 1 INV1S $T=939300 548240 1 0 $X=939300 $Y=542820
X2036 1157 2 4559 1 INV1S $T=943020 568400 0 180 $X=941780 $Y=562980
X2037 4831 2 4837 1 INV1S $T=944260 507920 1 180 $X=943020 $Y=507540
X2038 4852 2 4886 1 INV1S $T=944260 588560 1 0 $X=944260 $Y=583140
X2039 4855 2 4875 1 INV1S $T=946740 598640 1 0 $X=946740 $Y=593220
X2040 4856 2 4874 1 INV1S $T=951080 518000 0 180 $X=949840 $Y=512580
X2041 4845 2 4881 1 INV1S $T=952320 578480 1 180 $X=951080 $Y=578100
X2042 4903 2 4905 1 INV1S $T=951700 507920 1 0 $X=951700 $Y=502500
X2043 4925 2 4920 1 INV1S $T=957280 588560 1 180 $X=956040 $Y=588180
X2044 4930 2 4943 1 INV1S $T=959140 507920 0 0 $X=959140 $Y=507540
X2045 4913 2 4961 1 INV1S $T=962860 588560 0 0 $X=962860 $Y=588180
X2046 4956 2 4964 1 INV1S $T=967820 598640 1 0 $X=967820 $Y=593220
X2047 4983 2 4976 1 INV1S $T=970920 507920 1 180 $X=969680 $Y=507540
X2048 1196 2 5004 1 INV1S $T=975880 507920 0 180 $X=974640 $Y=502500
X2049 5002 2 4994 1 INV1S $T=976500 588560 0 0 $X=976500 $Y=588180
X2050 5011 2 5022 1 INV1S $T=978360 598640 1 0 $X=978360 $Y=593220
X2051 5016 2 5017 1 INV1S $T=979600 507920 0 0 $X=979600 $Y=507540
X2052 5035 2 5031 1 INV1S $T=983320 578480 1 180 $X=982080 $Y=578100
X2053 5061 2 5066 1 INV1S $T=990760 598640 1 0 $X=990760 $Y=593220
X2054 5054 2 5075 1 INV1S $T=992620 507920 0 0 $X=992620 $Y=507540
X2055 1065 2 5053 1 INV1S $T=993860 548240 0 0 $X=993860 $Y=547860
X2056 4840 2 4860 1 INV1S $T=995100 588560 0 180 $X=993860 $Y=583140
X2057 5114 2 5102 1 INV1S $T=999440 507920 1 180 $X=998200 $Y=507540
X2058 5086 2 5133 1 INV1S $T=998820 588560 0 0 $X=998820 $Y=588180
X2059 1212 2 5117 1 INV1S $T=999440 518000 1 0 $X=999440 $Y=512580
X2060 5095 2 5126 1 INV1S $T=1000680 598640 0 0 $X=1000680 $Y=598260
X2061 5116 2 5120 1 INV1S $T=1003160 568400 1 180 $X=1001920 $Y=568020
X2062 5174 2 5161 1 INV1S $T=1011840 518000 0 180 $X=1010600 $Y=512580
X2063 5158 2 5173 1 INV1S $T=1010600 588560 0 0 $X=1010600 $Y=588180
X2064 1225 2 5177 1 INV1S $T=1011840 497840 0 0 $X=1011840 $Y=497460
X2065 5168 2 5176 1 INV1S $T=1013700 568400 1 180 $X=1012460 $Y=568020
X2066 1157 2 5178 1 INV1S $T=1016800 568400 1 180 $X=1015560 $Y=568020
X2067 1163 2 5192 1 INV1S $T=1017420 588560 1 0 $X=1017420 $Y=583140
X2068 5155 2 5225 1 INV1S $T=1020520 578480 1 0 $X=1020520 $Y=573060
X2069 5228 2 5153 1 INV1S $T=1024240 507920 1 180 $X=1023000 $Y=507540
X2070 5216 2 5249 1 INV1S $T=1024240 507920 0 0 $X=1024240 $Y=507540
X2071 5229 2 5245 1 INV1S $T=1025480 558320 1 0 $X=1025480 $Y=552900
X2072 5186 2 5246 1 INV1S $T=1025480 578480 1 0 $X=1025480 $Y=573060
X2073 5208 2 5258 1 INV1S $T=1027340 578480 0 0 $X=1027340 $Y=578100
X2074 1235 2 5269 1 INV1S $T=1030440 507920 1 0 $X=1030440 $Y=502500
X2075 1052 2 5251 1 INV1S $T=1034780 568400 1 180 $X=1033540 $Y=568020
X2076 5165 2 5290 1 INV1S $T=1034780 568400 0 0 $X=1034780 $Y=568020
X2077 5179 2 5291 1 INV1S $T=1035400 588560 1 0 $X=1035400 $Y=583140
X2078 5273 2 5298 1 INV1S $T=1037880 497840 0 0 $X=1037880 $Y=497460
X2079 5293 2 5314 1 INV1S $T=1039740 558320 1 0 $X=1039740 $Y=552900
X2080 5151 2 5316 1 INV1S $T=1040360 588560 1 0 $X=1040360 $Y=583140
X2081 5233 2 5321 1 INV1S $T=1042840 578480 1 0 $X=1042840 $Y=573060
X2082 5234 2 5345 1 INV1S $T=1045940 578480 1 0 $X=1045940 $Y=573060
X2083 5305 2 5341 1 INV1S $T=1045940 628880 0 0 $X=1045940 $Y=628500
X2084 5247 2 5357 1 INV1S $T=1048420 578480 0 0 $X=1048420 $Y=578100
X2085 5145 2 5366 1 INV1S $T=1051520 507920 0 0 $X=1051520 $Y=507540
X2086 5235 2 5367 1 INV1S $T=1053380 588560 0 0 $X=1053380 $Y=588180
X2087 1238 2 5400 1 INV1S $T=1058960 507920 0 0 $X=1058960 $Y=507540
X2088 5279 2 5405 1 INV1S $T=1061440 507920 1 0 $X=1061440 $Y=502500
X2089 1400 1403 1459 2 1 1487 XOR3 $T=238080 628880 1 0 $X=238080 $Y=623460
X2090 1463 1347 1500 2 1 1536 XOR3 $T=248000 608720 0 0 $X=248000 $Y=608340
X2091 1478 1488 1519 2 1 1555 XOR3 $T=250480 649040 1 0 $X=250480 $Y=643620
X2092 1484 1375 1525 2 1 1551 XOR3 $T=251100 679280 0 0 $X=251100 $Y=678900
X2093 118 122 134 2 1 1570 XOR3 $T=253580 699440 1 0 $X=253580 $Y=694020
X2094 1504 1362 1527 2 1 1584 XOR3 $T=254820 669200 0 0 $X=254820 $Y=668820
X2095 1512 1368 1520 2 1 1588 XOR3 $T=256060 659120 1 0 $X=256060 $Y=653700
X2096 1651 1636 1465 2 1 1594 XOR3 $T=280860 608720 1 180 $X=269700 $Y=608340
X2097 1601 1693 1652 2 1 1643 XOR3 $T=291400 588560 0 180 $X=280240 $Y=583140
X2098 1669 1594 1686 2 1 1721 XOR3 $T=283960 608720 1 0 $X=283960 $Y=603300
X2099 1712 1402 1742 2 1 1783 XOR3 $T=293260 628880 0 0 $X=293260 $Y=628500
X2100 1739 1584 1743 2 1 1772 XOR3 $T=300080 669200 0 0 $X=300080 $Y=668820
X2101 1747 1588 1761 2 1 1778 XOR3 $T=301940 659120 1 0 $X=301940 $Y=653700
X2102 1760 1487 1777 2 1 1801 XOR3 $T=303800 618800 0 0 $X=303800 $Y=618420
X2103 1758 1555 1754 2 1 1771 XOR3 $T=305040 649040 1 0 $X=305040 $Y=643620
X2104 1551 1769 1751 2 1 1791 XOR3 $T=305040 679280 0 0 $X=305040 $Y=678900
X2105 1820 1810 1788 2 1 1758 XOR3 $T=319300 649040 1 180 $X=308140 $Y=648660
X2106 253 1570 1752 2 1 256 XOR3 $T=320540 699440 0 180 $X=309380 $Y=694020
X2107 1852 1536 1828 2 1 1817 XOR3 $T=330460 608720 0 180 $X=319300 $Y=603300
X2108 1846 1505 1744 2 1 1816 XOR3 $T=331700 598640 0 180 $X=320540 $Y=593220
X2109 1860 1838 1837 2 1 1747 XOR3 $T=332320 659120 1 180 $X=321160 $Y=658740
X2110 1893 1890 1796 2 1 1846 XOR3 $T=339140 598640 1 180 $X=327980 $Y=598260
X2111 3933 945 3888 2 1 3861 XOR3 $T=740900 507920 0 180 $X=729740 $Y=502500
X2112 3889 3892 3932 2 1 3933 XOR3 $T=730980 528080 1 0 $X=730980 $Y=522660
X2113 939 941 3855 2 1 3915 XOR3 $T=733460 689360 1 0 $X=733460 $Y=683940
X2114 3921 3894 3961 2 1 3962 XOR3 $T=738420 538160 1 0 $X=738420 $Y=532740
X2115 3962 952 3939 2 1 3910 XOR3 $T=752060 507920 1 180 $X=740900 $Y=507540
X2116 4013 958 3989 2 1 3981 XOR3 $T=764460 507920 0 180 $X=753300 $Y=502500
X2117 4022 4038 4002 2 1 3987 XOR3 $T=766320 548240 1 180 $X=755160 $Y=547860
X2118 971 4079 4032 2 1 4022 XOR3 $T=773140 497840 1 180 $X=761980 $Y=497460
X2119 969 4073 4048 2 1 4031 XOR3 $T=775000 518000 0 180 $X=763840 $Y=512580
X2120 4062 4071 4061 2 1 4052 XOR3 $T=778100 568400 0 180 $X=766940 $Y=562980
X2121 4077 4074 4068 2 1 4056 XOR3 $T=778720 578480 1 180 $X=767560 $Y=578100
X2122 4106 980 4066 2 1 4004 XOR3 $T=779340 528080 1 180 $X=768180 $Y=527700
X2123 4122 3986 4075 2 1 4038 XOR3 $T=779960 548240 1 180 $X=768800 $Y=547860
X2124 4044 3997 4037 2 1 4073 XOR3 $T=780580 538160 0 180 $X=769420 $Y=532740
X2125 4130 4024 4093 2 1 4077 XOR3 $T=784300 568400 1 180 $X=773140 $Y=568020
X2126 4116 4131 4100 2 1 4067 XOR3 $T=785540 588560 0 180 $X=774380 $Y=583140
X2127 4078 4030 4083 2 1 4106 XOR3 $T=775620 548240 1 0 $X=775620 $Y=542820
X2128 994 4160 4119 2 1 4074 XOR3 $T=790500 518000 0 180 $X=779340 $Y=512580
X2129 4157 4154 4144 2 1 4113 XOR3 $T=794840 598640 1 180 $X=783680 $Y=598260
X2130 4200 4082 4191 2 1 4157 XOR3 $T=804760 588560 1 180 $X=793600 $Y=588180
X2131 4271 4264 4236 2 1 4211 XOR3 $T=809720 598640 1 180 $X=798560 $Y=598260
X2132 4287 4278 4250 2 1 4247 XOR3 $T=813440 608720 0 180 $X=802280 $Y=603300
X2133 4235 4170 4230 2 1 4271 XOR3 $T=802900 578480 0 0 $X=802900 $Y=578100
X2134 1018 4284 4258 2 1 4154 XOR3 $T=815920 518000 1 180 $X=804760 $Y=517620
X2135 4336 4318 4295 2 1 4287 XOR3 $T=825840 588560 1 180 $X=814680 $Y=588180
X2136 4338 4347 4311 2 1 4304 XOR3 $T=828320 608720 0 180 $X=817160 $Y=603300
X2137 4372 4316 4370 2 1 4338 XOR3 $T=840100 598640 0 180 $X=828940 $Y=593220
X2138 4422 4416 4374 2 1 4371 XOR3 $T=841340 608720 0 180 $X=830180 $Y=603300
X2139 1046 4411 4377 2 1 4278 XOR3 $T=841960 518000 0 180 $X=830800 $Y=512580
X2140 4399 4400 4421 2 1 4422 XOR3 $T=835760 588560 0 0 $X=835760 $Y=588180
X2141 4435 4439 4465 2 1 4436 XOR3 $T=844440 598640 1 0 $X=844440 $Y=593220
X2142 4436 4440 4454 2 1 4472 XOR3 $T=845060 608720 1 0 $X=845060 $Y=603300
X2143 4485 4487 4499 2 1 4541 XOR3 $T=859940 598640 1 0 $X=859940 $Y=593220
X2144 4541 4526 4503 2 1 4495 XOR3 $T=871100 608720 0 180 $X=859940 $Y=603300
X2145 4530 4554 4553 2 1 4546 XOR3 $T=882880 608720 1 180 $X=871720 $Y=608340
X2146 1087 4593 4606 2 1 4598 XOR3 $T=881640 518000 0 0 $X=881640 $Y=517620
X2147 4590 4598 4589 2 1 4656 XOR3 $T=881640 608720 1 0 $X=881640 $Y=603300
X2148 4646 4651 4672 2 1 4669 XOR3 $T=893420 578480 0 0 $X=893420 $Y=578100
X2149 1099 4628 4633 2 1 4663 XOR3 $T=894040 518000 1 0 $X=894040 $Y=512580
X2150 4600 4652 4641 2 1 4653 XOR3 $T=905820 598640 0 180 $X=894660 $Y=593220
X2151 4653 4663 4658 2 1 4716 XOR3 $T=895900 608720 1 0 $X=895900 $Y=603300
X2152 4669 4639 4706 2 1 4728 XOR3 $T=897760 578480 1 0 $X=897760 $Y=573060
X2153 4662 4686 4683 2 1 4740 XOR3 $T=900240 558320 0 0 $X=900240 $Y=557940
X2154 4668 4727 4692 2 1 4682 XOR3 $T=913260 518000 1 180 $X=902100 $Y=517620
X2155 4707 4717 4712 2 1 4765 XOR3 $T=908300 558320 1 0 $X=908300 $Y=552900
X2156 4771 1136 4724 2 1 4737 XOR3 $T=925040 588560 0 180 $X=913880 $Y=583140
X2157 4774 4769 4745 2 1 4731 XOR3 $T=925040 618800 1 180 $X=913880 $Y=618420
X2158 4711 1131 4757 2 1 4782 XOR3 $T=915740 518000 1 0 $X=915740 $Y=512580
X2159 4736 4740 4785 2 1 4793 XOR3 $T=916980 568400 1 0 $X=916980 $Y=562980
X2160 1129 4754 4792 2 1 4795 XOR3 $T=918220 507920 0 0 $X=918220 $Y=507540
X2161 4789 4795 4761 2 1 4756 XOR3 $T=930620 598640 1 180 $X=919460 $Y=598260
X2162 4787 4796 4764 2 1 4759 XOR3 $T=931240 638960 0 180 $X=920080 $Y=633540
X2163 4747 1132 4762 2 1 4842 XOR3 $T=923800 538160 0 0 $X=923800 $Y=537780
X2164 4765 4775 4779 2 1 4829 XOR3 $T=925660 548240 1 0 $X=925660 $Y=542820
X2165 1142 4808 4799 2 1 4774 XOR3 $T=939300 528080 0 180 $X=928140 $Y=522660
X2166 1151 4839 4800 2 1 4796 XOR3 $T=939920 528080 1 180 $X=928760 $Y=527700
X2167 4823 4826 4801 2 1 4787 XOR3 $T=939920 628880 0 180 $X=928760 $Y=623460
X2168 4834 4811 4805 2 1 4769 XOR3 $T=941160 608720 1 180 $X=930000 $Y=608340
X2169 1154 4804 4786 2 1 4777 XOR3 $T=941780 568400 0 180 $X=930620 $Y=562980
X2170 4820 4809 4813 2 1 4771 XOR3 $T=943640 588560 0 180 $X=932480 $Y=583140
X2171 4825 4810 4818 2 1 4789 XOR3 $T=944880 598640 1 180 $X=933720 $Y=598260
X2172 4864 4858 4835 2 1 4827 XOR3 $T=946740 638960 0 180 $X=935580 $Y=633540
X2173 4854 4861 4868 2 1 4895 XOR3 $T=942400 618800 0 0 $X=942400 $Y=618420
X2174 4887 4844 4870 2 1 4864 XOR3 $T=955420 608720 1 180 $X=944260 $Y=608340
X2175 4917 4895 4904 2 1 4902 XOR3 $T=963480 649040 0 180 $X=952320 $Y=643620
X2176 1184 4968 4941 2 1 4937 XOR3 $T=969060 528080 1 180 $X=957900 $Y=527700
X2177 4972 4939 4945 2 1 4933 XOR3 $T=969680 618800 1 180 $X=958520 $Y=618420
X2178 4933 4937 4957 2 1 4990 XOR3 $T=960380 628880 0 0 $X=960380 $Y=628500
X2179 4971 4978 5003 2 1 4996 XOR3 $T=967200 608720 1 0 $X=967200 $Y=603300
X2180 1195 5005 4988 2 1 4975 XOR3 $T=979600 538160 0 180 $X=968440 $Y=532740
X2181 4975 4996 4999 2 1 5030 XOR3 $T=971540 638960 0 0 $X=971540 $Y=638580
X2182 5041 5023 5033 2 1 5006 XOR3 $T=992620 608720 0 180 $X=981460 $Y=603300
X2183 5110 5085 5051 2 1 5046 XOR3 $T=996960 638960 1 180 $X=985800 $Y=638580
X2184 5050 5055 5059 2 1 5110 XOR3 $T=987660 618800 0 0 $X=987660 $Y=618420
X2185 5213 5201 5170 2 1 5163 XOR3 $T=1020520 598640 0 180 $X=1009360 $Y=593220
X2186 5193 5194 5237 2 1 5248 XOR3 $T=1015560 628880 0 0 $X=1015560 $Y=628500
X2187 5187 5122 5209 2 1 5213 XOR3 $T=1016180 608720 1 0 $X=1016180 $Y=603300
X2188 5109 5196 5175 2 1 5193 XOR3 $T=1016800 618800 1 0 $X=1016800 $Y=613380
X2189 5236 5270 5241 2 1 5304 XOR3 $T=1030440 618800 1 0 $X=1030440 $Y=613380
X2190 5304 5312 5275 2 1 5272 XOR3 $T=1042840 608720 0 180 $X=1031680 $Y=603300
X2191 1236 5280 5283 2 1 5312 XOR3 $T=1032920 528080 0 0 $X=1032920 $Y=527700
X2192 5315 1244 5319 2 1 5317 XOR3 $T=1054000 538160 0 180 $X=1042840 $Y=532740
X2193 5309 5339 5382 2 1 5389 XOR3 $T=1045940 608720 1 0 $X=1045940 $Y=603300
X2194 5305 5287 5320 2 1 5346 XOR3 $T=1060200 638960 1 180 $X=1049040 $Y=638580
X2195 1246 5354 5362 2 1 5398 XOR3 $T=1049660 528080 0 0 $X=1049660 $Y=527700
X2196 5368 5385 5415 2 1 5427 XOR3 $T=1055240 588560 1 0 $X=1055240 $Y=583140
X2197 1251 5388 5399 2 1 5396 XOR3 $T=1056480 528080 1 0 $X=1056480 $Y=522660
X2198 5356 1256 5349 2 1 5387 XOR3 $T=1068260 538160 1 180 $X=1057100 $Y=537780
X2199 5333 5373 5380 2 1 5391 XOR3 $T=1057100 618800 0 0 $X=1057100 $Y=618420
X2200 5397 1259 5446 2 1 5471 XOR3 $T=1068260 538160 1 0 $X=1068260 $Y=532740
X2201 5391 5398 5404 2 1 5466 XOR3 $T=1068880 638960 1 0 $X=1068880 $Y=633540
X2202 5420 5444 5438 2 1 5472 XOR3 $T=1069500 568400 1 0 $X=1069500 $Y=562980
X2203 1258 5439 5432 2 1 5476 XOR3 $T=1071980 518000 0 0 $X=1071980 $Y=517620
X2204 5433 5452 5434 2 1 5479 XOR3 $T=1073220 558320 1 0 $X=1073220 $Y=552900
X2205 5389 5396 5411 2 1 5484 XOR3 $T=1073840 618800 1 0 $X=1073840 $Y=613380
X2206 1263 5459 5490 2 1 5481 XOR3 $T=1077560 507920 1 0 $X=1077560 $Y=502500
X2207 5427 5489 5477 2 1 5468 XOR3 $T=1091200 588560 1 180 $X=1080040 $Y=588180
X2208 5430 5481 5492 2 1 5498 XOR3 $T=1081280 568400 0 0 $X=1081280 $Y=568020
X2209 5479 1269 5487 2 1 5499 XOR3 $T=1081900 528080 1 0 $X=1081900 $Y=522660
X2210 5423 5476 5450 2 1 5497 XOR3 $T=1081900 598640 0 0 $X=1081900 $Y=598260
X2211 1429 1442 1408 1 2 1519 MAO222 $T=243040 638960 0 0 $X=243040 $Y=638580
X2212 1400 1459 1403 1 2 1442 MAO222 $T=245520 628880 0 0 $X=245520 $Y=628500
X2213 1379 1486 1471 1 2 1500 MAO222 $T=249860 608720 1 0 $X=249860 $Y=603300
X2214 1712 1742 1402 1 2 1754 MAO222 $T=298220 638960 1 0 $X=298220 $Y=633540
X2215 1758 1754 1555 1 2 1761 MAO222 $T=301320 649040 0 0 $X=301320 $Y=648660
X2216 1747 1761 1588 1 2 1743 MAO222 $T=301320 669200 1 0 $X=301320 $Y=663780
X2217 1760 1777 1487 1 2 1742 MAO222 $T=310620 628880 0 180 $X=305660 $Y=623460
X2218 1852 1828 1536 1 2 1777 MAO222 $T=327980 618800 0 180 $X=323020 $Y=613380
X2219 1847 1885 1853 1 2 1859 MAO222 $T=331080 638960 1 0 $X=331080 $Y=633540
X2220 3889 3932 3892 1 2 3898 MAO222 $T=738420 528080 0 0 $X=738420 $Y=527700
X2221 3933 3888 945 1 2 3874 MAO222 $T=744000 497840 1 180 $X=739040 $Y=497460
X2222 939 941 3855 1 2 953 MAO222 $T=740280 699440 1 0 $X=740280 $Y=694020
X2223 3921 3961 3894 1 2 3932 MAO222 $T=750200 528080 1 180 $X=745240 $Y=527700
X2224 971 4032 4079 1 2 975 MAO222 $T=781200 497840 1 180 $X=776240 $Y=497460
X2225 4106 4066 980 1 2 4048 MAO222 $T=781200 528080 0 180 $X=776240 $Y=522660
X2226 4200 4191 4082 1 2 4151 MAO222 $T=795460 588560 0 180 $X=790500 $Y=583140
X2227 4235 4230 4170 1 2 4191 MAO222 $T=801660 588560 0 180 $X=796700 $Y=583140
X2228 1045 4428 4408 1 2 4377 MAO222 $T=845680 507920 1 180 $X=840720 $Y=507540
X2229 1054 4450 4442 1 2 4428 MAO222 $T=852500 507920 1 180 $X=847540 $Y=507540
X2230 4436 4454 4440 1 2 4374 MAO222 $T=853120 598640 1 180 $X=848160 $Y=598260
X2231 4435 4465 4439 1 2 4421 MAO222 $T=849400 588560 1 0 $X=849400 $Y=583140
X2232 1059 4481 4462 1 2 4450 MAO222 $T=859940 507920 1 180 $X=854980 $Y=507540
X2233 4485 4499 4487 1 2 4465 MAO222 $T=863660 588560 1 180 $X=858700 $Y=588180
X2234 4530 4553 4554 1 2 4503 MAO222 $T=878540 608720 0 180 $X=873580 $Y=603300
X2235 4590 4589 4598 1 2 4553 MAO222 $T=883500 598640 1 180 $X=878540 $Y=598260
X2236 1099 4633 4628 1 2 4606 MAO222 $T=892800 518000 0 180 $X=887840 $Y=512580
X2237 4600 4641 4652 1 2 4620 MAO222 $T=895280 588560 0 180 $X=890320 $Y=583140
X2238 4653 4658 4663 1 2 4589 MAO222 $T=898380 598640 1 180 $X=893420 $Y=598260
X2239 4646 4672 4651 1 2 4641 MAO222 $T=901480 588560 0 180 $X=896520 $Y=583140
X2240 4676 4607 4670 1 2 4693 MAO222 $T=898380 528080 0 0 $X=898380 $Y=527700
X2241 4662 4683 4686 1 2 4672 MAO222 $T=903340 568400 1 180 $X=898380 $Y=568020
X2242 1102 4688 4644 1 2 4633 MAO222 $T=900240 507920 1 0 $X=900240 $Y=502500
X2243 4707 4712 4717 1 2 4683 MAO222 $T=910160 548240 1 180 $X=905200 $Y=547860
X2244 1118 1116 1123 1 2 4688 MAO222 $T=910780 507920 0 180 $X=905820 $Y=502500
X2245 4665 4693 4723 1 2 4702 MAO222 $T=910780 538160 0 0 $X=910780 $Y=537780
X2246 4675 4702 4705 1 2 4712 MAO222 $T=916360 548240 1 180 $X=911400 $Y=547860
X2247 4668 4727 4692 1 2 4757 MAO222 $T=915120 518000 0 0 $X=915120 $Y=517620
X2248 4711 1131 4757 1 2 4762 MAO222 $T=920700 518000 0 0 $X=920700 $Y=517620
X2249 4775 4768 4765 1 2 4744 MAO222 $T=921940 548240 0 0 $X=921940 $Y=547860
X2250 4771 4733 1136 1 2 4786 MAO222 $T=921940 578480 0 0 $X=921940 $Y=578100
X2251 4789 4761 4795 1 2 4733 MAO222 $T=928760 598640 0 180 $X=923800 $Y=593220
X2252 1129 4792 4754 1 2 1139 MAO222 $T=933100 497840 1 180 $X=928140 $Y=497460
X2253 4820 4813 4809 1 2 4797 MAO222 $T=931860 578480 0 0 $X=931860 $Y=578100
X2254 4825 4818 4810 1 2 4813 MAO222 $T=937440 588560 1 180 $X=932480 $Y=588180
X2255 4823 4801 4826 1 2 4805 MAO222 $T=932480 618800 1 0 $X=932480 $Y=613380
X2256 4834 4805 4811 1 2 4818 MAO222 $T=938680 608720 0 180 $X=933720 $Y=603300
X2257 4864 4835 4858 1 2 4764 MAO222 $T=946740 628880 1 180 $X=941780 $Y=628500
X2258 5041 5033 5023 1 2 5003 MAO222 $T=985800 608720 1 180 $X=980840 $Y=608340
X2259 5050 5059 5055 1 2 5033 MAO222 $T=991380 618800 0 180 $X=986420 $Y=613380
X2260 5187 5209 5122 1 2 5175 MAO222 $T=1016180 608720 0 0 $X=1016180 $Y=608340
X2261 5236 5241 5270 1 2 5209 MAO222 $T=1027340 608720 1 180 $X=1022380 $Y=608340
X2262 5326 5268 5314 1 2 5337 MAO222 $T=1041600 558320 1 0 $X=1041600 $Y=552900
X2263 5315 1244 5319 1 2 5349 MAO222 $T=1044080 528080 0 0 $X=1044080 $Y=527700
X2264 5278 5340 5295 1 2 5241 MAO222 $T=1049660 618800 0 180 $X=1044700 $Y=613380
X2265 5333 5380 5373 1 2 5340 MAO222 $T=1057720 618800 0 180 $X=1052760 $Y=613380
X2266 5309 5382 5339 1 2 5380 MAO222 $T=1056480 608720 0 0 $X=1056480 $Y=608340
X2267 5355 5337 5363 1 2 5407 MAO222 $T=1057100 558320 0 0 $X=1057100 $Y=557940
X2268 5406 5407 5402 1 2 5434 MAO222 $T=1062680 558320 0 0 $X=1062680 $Y=557940
X2269 5433 5434 5452 1 2 5438 MAO222 $T=1073840 558320 1 180 $X=1068880 $Y=557940
X2270 1297 1304 1322 2 1 XOR2HS $T=220720 618800 0 0 $X=220720 $Y=618420
X2271 1301 1294 1323 2 1 XOR2HS $T=220720 659120 0 0 $X=220720 $Y=658740
X2272 1305 1312 1326 2 1 XOR2HS $T=221340 669200 0 0 $X=221340 $Y=668820
X2273 8 12 18 2 1 XOR2HS $T=222580 699440 1 0 $X=222580 $Y=694020
X2274 1316 1298 1337 2 1 XOR2HS $T=223820 638960 1 0 $X=223820 $Y=633540
X2275 1319 1299 1341 2 1 XOR2HS $T=224440 638960 0 0 $X=224440 $Y=638580
X2276 1329 1334 1342 2 1 XOR2HS $T=225060 598640 1 0 $X=225060 $Y=593220
X2277 1391 1399 1433 2 1 XOR2HS $T=239940 598640 0 0 $X=239940 $Y=598260
X2278 1539 1532 1514 2 1 XOR2HS $T=261020 618800 1 180 $X=255440 $Y=618420
X2279 1558 1552 1503 2 1 XOR2HS $T=264740 628880 0 180 $X=259160 $Y=623460
X2280 1568 1565 1516 2 1 XOR2HS $T=265980 638960 0 180 $X=260400 $Y=633540
X2281 1574 1567 1515 2 1 XOR2HS $T=266600 628880 1 180 $X=261020 $Y=628500
X2282 1582 1578 1561 2 1 XOR2HS $T=268460 679280 0 180 $X=262880 $Y=673860
X2283 1590 1585 1569 2 1 XOR2HS $T=269700 649040 0 180 $X=264120 $Y=643620
X2284 1361 1581 1592 2 1 XOR2HS $T=265980 598640 0 0 $X=265980 $Y=598260
X2285 1602 1596 1560 2 1 XOR2HS $T=273420 659120 1 180 $X=267840 $Y=658740
X2286 1553 1592 1601 2 1 XOR2HS $T=268460 598640 1 0 $X=268460 $Y=593220
X2287 1583 1586 1562 2 1 XOR2HS $T=268460 689360 1 0 $X=268460 $Y=683940
X2288 1603 1608 1591 2 1 XOR2HS $T=275280 618800 1 180 $X=269700 $Y=618420
X2289 1621 1454 1666 2 1 XOR2HS $T=280240 618800 1 0 $X=280240 $Y=613380
X2290 1704 1666 1714 2 1 XOR2HS $T=291400 618800 1 0 $X=291400 $Y=613380
X2291 1753 1746 1704 2 1 XOR2HS $T=303800 618800 0 180 $X=298220 $Y=613380
X2292 1785 1782 1693 2 1 XOR2HS $T=310620 588560 1 180 $X=305040 $Y=588180
X2293 1762 1795 1782 2 1 XOR2HS $T=311860 588560 0 0 $X=311860 $Y=588180
X2294 1814 1811 1739 2 1 XOR2HS $T=319300 669200 1 180 $X=313720 $Y=668820
X2295 1840 1834 1811 2 1 XOR2HS $T=324880 679280 0 180 $X=319300 $Y=673860
X2296 1856 1857 1769 2 1 XOR2HS $T=328600 689360 0 180 $X=323020 $Y=683940
X2297 1889 1869 1857 2 1 XOR2HS $T=337280 689360 0 180 $X=331700 $Y=683940
X2298 1905 1901 1883 2 1 XOR2HS $T=339760 679280 1 180 $X=334180 $Y=678900
X2299 1892 1895 1876 2 1 XOR2HS $T=336040 659120 1 0 $X=336040 $Y=653700
X2300 1913 1912 1904 2 1 XOR2HS $T=342860 638960 0 180 $X=337280 $Y=633540
X2301 302 301 297 2 1 XOR2HS $T=342860 699440 0 180 $X=337280 $Y=694020
X2302 1902 1907 1878 2 1 XOR2HS $T=337900 649040 1 0 $X=337900 $Y=643620
X2303 1900 1909 1871 2 1 XOR2HS $T=338520 669200 0 0 $X=338520 $Y=668820
X2304 1919 1916 1897 2 1 XOR2HS $T=344100 689360 0 180 $X=338520 $Y=683940
X2305 1921 1918 1910 2 1 XOR2HS $T=344720 518000 1 180 $X=339140 $Y=517620
X2306 1923 1963 1934 2 1 XOR2HS $T=354640 507920 0 180 $X=349060 $Y=502500
X2307 1935 1932 1929 2 1 XOR2HS $T=349680 638960 0 0 $X=349680 $Y=638580
X2308 2000 2001 1964 2 1 XOR2HS $T=360840 628880 0 0 $X=360840 $Y=628500
X2309 2004 1991 1961 2 1 XOR2HS $T=363940 638960 1 0 $X=363940 $Y=633540
X2310 2049 2056 2046 2 1 XOR2HS $T=376960 689360 1 180 $X=371380 $Y=688980
X2311 2052 2059 2070 2 1 XOR2HS $T=374480 679280 1 0 $X=374480 $Y=673860
X2312 2086 2072 2076 2 1 XOR2HS $T=383780 679280 1 180 $X=378200 $Y=678900
X2313 2127 2136 2081 2 1 XOR2HS $T=394320 659120 1 180 $X=388740 $Y=658740
X2314 2150 2140 2144 2 1 XOR2HS $T=399280 679280 1 180 $X=393700 $Y=678900
X2315 2124 2148 2138 2 1 XOR2HS $T=398040 669200 0 0 $X=398040 $Y=668820
X2316 2184 2179 2169 2 1 XOR2HS $T=405480 679280 1 180 $X=399900 $Y=678900
X2317 2221 2211 2212 2 1 XOR2HS $T=411060 679280 0 0 $X=411060 $Y=678900
X2318 2261 2238 2250 2 1 XOR2HS $T=422840 679280 1 180 $X=417260 $Y=678900
X2319 2292 2289 2285 2 1 XOR2HS $T=429660 689360 0 180 $X=424080 $Y=683940
X2320 2322 2318 2310 2 1 XOR2HS $T=437100 689360 0 180 $X=431520 $Y=683940
X2321 2365 2358 2359 2 1 XOR2HS $T=443920 689360 0 180 $X=438340 $Y=683940
X2322 2396 2398 2410 2 1 XOR2HS $T=445160 689360 1 0 $X=445160 $Y=683940
X2323 2438 2426 2442 2 1 XOR2HS $T=455080 689360 1 0 $X=455080 $Y=683940
X2324 2467 2455 2464 2 1 XOR2HS $T=461900 689360 1 0 $X=461900 $Y=683940
X2325 2496 2482 2512 2 1 XOR2HS $T=468720 689360 1 0 $X=468720 $Y=683940
X2326 2534 2514 2521 2 1 XOR2HS $T=478640 679280 1 180 $X=473060 $Y=678900
X2327 2554 2563 2543 2 1 XOR2HS $T=486080 689360 1 180 $X=480500 $Y=688980
X2328 2546 2549 2557 2 1 XOR2HS $T=481120 659120 0 0 $X=481120 $Y=658740
X2329 2559 2553 2574 2 1 XOR2HS $T=483600 679280 0 0 $X=483600 $Y=678900
X2330 2581 2589 2573 2 1 XOR2HS $T=491660 659120 0 180 $X=486080 $Y=653700
X2331 2597 2590 2576 2 1 XOR2HS $T=492280 689360 1 180 $X=486700 $Y=688980
X2332 2614 2608 2594 2 1 XOR2HS $T=495380 679280 1 180 $X=489800 $Y=678900
X2333 2606 2603 2630 2 1 XOR2HS $T=494760 669200 1 0 $X=494760 $Y=663780
X2334 2856 2781 2816 2 1 XOR2HS $T=537540 528080 0 180 $X=531960 $Y=522660
X2335 2891 2885 2868 2 1 XOR2HS $T=542500 568400 1 180 $X=536920 $Y=568020
X2336 2888 2889 2925 2 1 XOR2HS $T=541880 518000 0 0 $X=541880 $Y=517620
X2337 2916 2931 2898 2 1 XOR2HS $T=548080 588560 1 180 $X=542500 $Y=588180
X2338 2915 2930 2948 2 1 XOR2HS $T=545600 578480 0 0 $X=545600 $Y=578100
X2339 2955 2942 2998 2 1 XOR2HS $T=552420 578480 0 0 $X=552420 $Y=578100
X2340 3181 3177 3155 2 1 XOR2HS $T=582180 548240 1 180 $X=576600 $Y=547860
X2341 3556 3553 3540 2 1 XOR2HS $T=657200 618800 1 180 $X=651620 $Y=618420
X2342 3579 3585 3571 2 1 XOR2HS $T=663400 638960 1 180 $X=657820 $Y=638580
X2343 3573 3593 3558 2 1 XOR2HS $T=665880 628880 1 180 $X=660300 $Y=628500
X2344 3612 3611 3603 2 1 XOR2HS $T=670220 649040 1 180 $X=664640 $Y=648660
X2345 3590 3610 3595 2 1 XOR2HS $T=667120 638960 0 0 $X=667120 $Y=638580
X2346 3616 3608 3598 2 1 XOR2HS $T=670220 618800 0 0 $X=670220 $Y=618420
X2347 3623 3624 3634 2 1 XOR2HS $T=672080 628880 0 0 $X=672080 $Y=628500
X2348 3669 3667 3652 2 1 XOR2HS $T=684480 628880 1 180 $X=678900 $Y=628500
X2349 3644 3636 3653 2 1 XOR2HS $T=678900 649040 0 0 $X=678900 $Y=648660
X2350 3700 3666 3686 2 1 XOR2HS $T=692540 649040 0 180 $X=686960 $Y=643620
X2351 3702 3685 3692 2 1 XOR2HS $T=693160 628880 1 180 $X=687580 $Y=628500
X2352 3758 3731 3737 2 1 XOR2HS $T=704940 628880 1 180 $X=699360 $Y=628500
X2353 3733 3727 3751 2 1 XOR2HS $T=699360 649040 1 0 $X=699360 $Y=643620
X2354 3784 3778 3770 2 1 XOR2HS $T=710520 628880 1 180 $X=704940 $Y=628500
X2355 3785 3735 3771 2 1 XOR2HS $T=710520 649040 0 180 $X=704940 $Y=643620
X2356 3808 3800 3825 2 1 XOR2HS $T=714860 638960 0 0 $X=714860 $Y=638580
X2357 3838 3814 3822 2 1 XOR2HS $T=722300 638960 0 180 $X=716720 $Y=633540
X2358 3860 3820 3880 2 1 XOR2HS $T=726020 638960 0 0 $X=726020 $Y=638580
X2359 3893 3898 3916 2 1 XOR2HS $T=732220 518000 0 0 $X=732220 $Y=517620
X2360 3891 3863 3897 2 1 XOR2HS $T=737800 638960 0 180 $X=732220 $Y=633540
X2361 3923 3868 3934 2 1 XOR2HS $T=737180 638960 0 0 $X=737180 $Y=638580
X2362 3950 3935 3964 2 1 XOR2HS $T=745240 628880 0 0 $X=745240 $Y=628500
X2363 3977 3944 3965 2 1 XOR2HS $T=752680 649040 0 180 $X=747100 $Y=643620
X2364 3982 3967 4007 2 1 XOR2HS $T=753920 628880 0 0 $X=753920 $Y=628500
X2365 3911 3996 3893 2 1 XOR2HS $T=754540 518000 0 0 $X=754540 $Y=517620
X2366 4020 3984 4047 2 1 XOR2HS $T=761360 649040 1 0 $X=761360 $Y=643620
X2367 4008 3990 4054 2 1 XOR2HS $T=762600 528080 1 0 $X=762600 $Y=522660
X2368 4029 4021 4057 2 1 XOR2HS $T=762600 628880 0 0 $X=762600 $Y=628500
X2369 4012 4054 4013 2 1 XOR2HS $T=768800 528080 1 0 $X=768800 $Y=522660
X2370 4094 4089 4080 2 1 XOR2HS $T=775620 638960 1 180 $X=770040 $Y=638580
X2371 4110 4043 4099 2 1 XOR2HS $T=779960 638960 0 180 $X=774380 $Y=633540
X2372 4150 4143 4129 2 1 XOR2HS $T=786780 528080 1 180 $X=781200 $Y=527700
X2373 4133 4139 4152 2 1 XOR2HS $T=784920 638960 0 0 $X=784920 $Y=638580
X2374 4178 4169 4125 2 1 XOR2HS $T=791740 507920 0 180 $X=786160 $Y=502500
X2375 998 4187 4138 2 1 XOR2HS $T=794220 497840 1 180 $X=788640 $Y=497460
X2376 4163 4179 4137 2 1 XOR2HS $T=789260 528080 1 0 $X=789260 $Y=522660
X2377 4183 4195 4204 2 1 XOR2HS $T=791740 649040 1 0 $X=791740 $Y=643620
X2378 4216 4213 4193 2 1 XOR2HS $T=799180 558320 0 180 $X=793600 $Y=552900
X2379 4220 4214 4164 2 1 XOR2HS $T=799180 568400 0 180 $X=793600 $Y=562980
X2380 4186 4182 4189 2 1 XOR2HS $T=794220 538160 0 0 $X=794220 $Y=537780
X2381 4224 4219 4167 2 1 XOR2HS $T=799800 548240 0 180 $X=794220 $Y=542820
X2382 4234 4203 4209 2 1 XOR2HS $T=801040 518000 1 180 $X=795460 $Y=517620
X2383 4171 4166 4194 2 1 XOR2HS $T=795460 638960 1 0 $X=795460 $Y=633540
X2384 4237 4243 4184 2 1 XOR2HS $T=802900 568400 1 180 $X=797320 $Y=568020
X2385 4245 4242 4168 2 1 XOR2HS $T=805380 558320 0 180 $X=799800 $Y=552900
X2386 4223 4217 4188 2 1 XOR2HS $T=801040 507920 1 0 $X=801040 $Y=502500
X2387 4232 4253 4221 2 1 XOR2HS $T=802900 538160 1 0 $X=802900 $Y=532740
X2388 4248 4244 4233 2 1 XOR2HS $T=804140 649040 0 0 $X=804140 $Y=648660
X2389 4249 4251 4226 2 1 XOR2HS $T=805380 638960 0 0 $X=805380 $Y=638580
X2390 4261 4254 4262 2 1 XOR2HS $T=812820 568400 1 180 $X=807240 $Y=568020
X2391 4270 4274 4263 2 1 XOR2HS $T=811580 497840 0 0 $X=811580 $Y=497460
X2392 4303 4296 4280 2 1 XOR2HS $T=817780 507920 1 0 $X=817780 $Y=502500
X2393 4314 4292 4289 2 1 XOR2HS $T=820260 568400 0 0 $X=820260 $Y=568020
X2394 4341 4334 4356 2 1 XOR2HS $T=823980 507920 1 0 $X=823980 $Y=502500
X2395 4348 4353 4326 2 1 XOR2HS $T=827080 578480 0 0 $X=827080 $Y=578100
X2396 4373 4376 4396 2 1 XOR2HS $T=832040 507920 1 0 $X=832040 $Y=502500
X2397 4382 4380 4401 2 1 XOR2HS $T=833900 578480 1 0 $X=833900 $Y=573060
X2398 4409 1047 4432 2 1 XOR2HS $T=840720 497840 0 0 $X=840720 $Y=497460
X2399 4405 4407 4426 2 1 XOR2HS $T=840720 568400 0 0 $X=840720 $Y=568020
X2400 1056 1057 4459 2 1 XOR2HS $T=848160 497840 0 0 $X=848160 $Y=497460
X2401 4443 4444 4457 2 1 XOR2HS $T=848780 578480 1 0 $X=848780 $Y=573060
X2402 4480 4475 4497 2 1 XOR2HS $T=857460 497840 0 0 $X=857460 $Y=497460
X2403 4477 4483 4484 2 1 XOR2HS $T=858080 578480 1 0 $X=858080 $Y=573060
X2404 4508 4515 4526 2 1 XOR2HS $T=863660 528080 0 0 $X=863660 $Y=527700
X2405 1067 4506 4515 2 1 XOR2HS $T=865520 518000 0 0 $X=865520 $Y=517620
X2406 4513 4517 4531 2 1 XOR2HS $T=866140 568400 0 0 $X=866140 $Y=568020
X2407 4519 4512 4528 2 1 XOR2HS $T=867380 507920 1 0 $X=867380 $Y=502500
X2408 4558 4566 4554 2 1 XOR2HS $T=877920 528080 1 180 $X=872340 $Y=527700
X2409 4535 1075 4564 2 1 XOR2HS $T=873580 497840 0 0 $X=873580 $Y=497460
X2410 4544 1079 4566 2 1 XOR2HS $T=874200 528080 1 0 $X=874200 $Y=522660
X2411 4563 4574 4585 2 1 XOR2HS $T=876680 538160 1 0 $X=876680 $Y=532740
X2412 4575 4581 4584 2 1 XOR2HS $T=877920 578480 1 0 $X=877920 $Y=573060
X2413 4626 4623 4612 2 1 XOR2HS $T=889700 578480 0 180 $X=884120 $Y=573060
X2414 4617 4638 4655 2 1 XOR2HS $T=891560 548240 0 0 $X=891560 $Y=547860
X2415 4622 4636 4647 2 1 XOR2HS $T=892180 558320 0 0 $X=892180 $Y=557940
X2416 4645 4649 4659 2 1 XOR2HS $T=892800 528080 1 0 $X=892800 $Y=522660
X2417 4630 4629 4660 2 1 XOR2HS $T=892800 558320 1 0 $X=892800 $Y=552900
X2418 4659 1106 4601 2 1 XOR2HS $T=900240 518000 1 180 $X=894660 $Y=517620
X2419 1103 4654 4661 2 1 XOR2HS $T=895900 497840 0 0 $X=895900 $Y=497460
X2420 4788 4797 4804 2 1 XOR2HS $T=927520 578480 1 0 $X=927520 $Y=573060
X2421 4822 4817 4803 2 1 XOR2HS $T=935580 518000 0 180 $X=930000 $Y=512580
X2422 4837 4833 4819 2 1 XOR2HS $T=938680 507920 0 180 $X=933100 $Y=502500
X2423 1152 4846 1156 2 1 XOR2HS $T=939920 507920 1 0 $X=939920 $Y=502500
X2424 4874 4872 4853 2 1 XOR2HS $T=949220 518000 0 180 $X=943640 $Y=512580
X2425 4881 4880 4843 2 1 XOR2HS $T=949840 578480 1 180 $X=944260 $Y=578100
X2426 4886 4882 4849 2 1 XOR2HS $T=950460 588560 1 180 $X=944880 $Y=588180
X2427 4875 4892 4847 2 1 XOR2HS $T=951700 598640 1 180 $X=946120 $Y=598260
X2428 4859 4898 4851 2 1 XOR2HS $T=952320 568400 1 180 $X=946740 $Y=568020
X2429 4905 4912 4908 2 1 XOR2HS $T=952320 518000 1 0 $X=952320 $Y=512580
X2430 4920 4921 4911 2 1 XOR2HS $T=957900 608720 0 180 $X=952320 $Y=603300
X2431 4961 4958 4906 2 1 XOR2HS $T=964720 598640 0 180 $X=959140 $Y=593220
X2432 4943 4951 4934 2 1 XOR2HS $T=961620 518000 0 0 $X=961620 $Y=517620
X2433 4964 4962 4947 2 1 XOR2HS $T=965960 598640 0 0 $X=965960 $Y=598260
X2434 4976 4967 4986 2 1 XOR2HS $T=967820 518000 0 0 $X=967820 $Y=517620
X2435 4994 4991 4995 2 1 XOR2HS $T=978360 588560 0 180 $X=972780 $Y=583140
X2436 5004 5001 5010 2 1 XOR2HS $T=974020 518000 0 0 $X=974020 $Y=517620
X2437 5031 5038 5025 2 1 XOR2HS $T=985180 588560 0 180 $X=979600 $Y=583140
X2438 5022 5032 5007 2 1 XOR2HS $T=980840 598640 0 0 $X=980840 $Y=598260
X2439 5017 5012 5036 2 1 XOR2HS $T=981460 507920 0 0 $X=981460 $Y=507540
X2440 5020 1202 5047 2 1 XOR2HS $T=982700 528080 1 0 $X=982700 $Y=522660
X2441 5044 5047 5013 2 1 XOR2HS $T=988900 538160 1 180 $X=983320 $Y=537780
X2442 5075 5070 5058 2 1 XOR2HS $T=993240 518000 0 180 $X=987660 $Y=512580
X2443 5108 5106 5085 2 1 XOR2HS $T=998820 538160 0 180 $X=993240 $Y=532740
X2444 5066 5062 5063 2 1 XOR2HS $T=993240 598640 1 0 $X=993240 $Y=593220
X2445 5073 1212 5108 2 1 XOR2HS $T=993860 518000 1 0 $X=993860 $Y=512580
X2446 5102 5096 5135 2 1 XOR2HS $T=1000060 507920 0 0 $X=1000060 $Y=507540
X2447 5126 5125 5103 2 1 XOR2HS $T=1002540 598640 0 0 $X=1002540 $Y=598260
X2448 5133 5142 5094 2 1 XOR2HS $T=1003160 588560 0 0 $X=1003160 $Y=588180
X2449 5161 5182 5184 2 1 XOR2HS $T=1012460 518000 1 0 $X=1012460 $Y=512580
X2450 5173 5172 5195 2 1 XOR2HS $T=1012460 588560 0 0 $X=1012460 $Y=588180
X2451 5153 5169 5217 2 1 XOR2HS $T=1016800 507920 0 0 $X=1016800 $Y=507540
X2452 5246 5252 5261 2 1 XOR2HS $T=1025480 568400 0 0 $X=1025480 $Y=568020
X2453 5249 5242 5267 2 1 XOR2HS $T=1027340 507920 0 0 $X=1027340 $Y=507540
X2454 5258 5253 5265 2 1 XOR2HS $T=1028580 588560 1 0 $X=1028580 $Y=583140
X2455 5276 1237 5207 2 1 XOR2HS $T=1036020 538160 0 180 $X=1030440 $Y=532740
X2456 5289 5281 5276 2 1 XOR2HS $T=1037880 538160 1 180 $X=1032300 $Y=537780
X2457 5277 5282 5294 2 1 XOR2HS $T=1034160 558320 0 0 $X=1034160 $Y=557940
X2458 5291 5301 5288 2 1 XOR2HS $T=1040360 588560 1 180 $X=1034780 $Y=588180
X2459 5290 5285 5308 2 1 XOR2HS $T=1036640 578480 1 0 $X=1036640 $Y=573060
X2460 5298 5299 5306 2 1 XOR2HS $T=1041600 507920 1 0 $X=1041600 $Y=502500
X2461 5321 5307 5332 2 1 XOR2HS $T=1041600 568400 1 0 $X=1041600 $Y=562980
X2462 5316 5322 5329 2 1 XOR2HS $T=1043460 588560 0 0 $X=1043460 $Y=588180
X2463 1242 5310 5328 2 1 XOR2HS $T=1045940 497840 0 0 $X=1045940 $Y=497460
X2464 5357 5352 5374 2 1 XOR2HS $T=1050900 578480 0 0 $X=1050900 $Y=578100
X2465 5345 5351 5378 2 1 XOR2HS $T=1051520 578480 1 0 $X=1051520 $Y=573060
X2466 5338 5344 5384 2 1 XOR2HS $T=1052760 568400 0 0 $X=1052760 $Y=568020
X2467 5366 5365 5383 2 1 XOR2HS $T=1053380 507920 1 0 $X=1053380 $Y=502500
X2468 5367 5359 5360 2 1 XOR2HS $T=1054620 598640 1 0 $X=1054620 $Y=593220
X2469 1250 1248 5392 2 1 XOR2HS $T=1055240 497840 0 0 $X=1055240 $Y=497460
X2470 5400 1255 5419 2 1 XOR2HS $T=1061440 507920 0 0 $X=1061440 $Y=507540
X2471 5405 5413 5424 2 1 XOR2HS $T=1062680 507920 1 0 $X=1062680 $Y=502500
X2472 1421 1413 1430 2 1 ND2S $T=241800 669200 0 0 $X=241800 $Y=668820
X2473 1475 1473 76 2 1 ND2S $T=250480 659120 1 180 $X=248620 $Y=658740
X2474 1502 1468 1496 2 1 ND2S $T=250480 689360 0 180 $X=248620 $Y=683940
X2475 1475 1485 1496 2 1 ND2S $T=252340 659120 1 0 $X=252340 $Y=653700
X2476 1661 1662 141 2 1 ND2S $T=282720 659120 1 0 $X=282720 $Y=653700
X2477 1698 1696 1702 2 1 ND2S $T=290160 659120 1 0 $X=290160 $Y=653700
X2478 1703 1711 190 2 1 ND2S $T=293260 679280 0 0 $X=293260 $Y=678900
X2479 1840 1850 1834 2 1 ND2S $T=325500 679280 1 180 $X=323640 $Y=678900
X2480 1889 1855 1869 2 1 ND2S $T=331080 689360 0 0 $X=331080 $Y=688980
X2481 1955 1937 283 2 1 ND2S $T=350300 628880 0 180 $X=348440 $Y=623460
X2482 2039 2024 269 2 1 ND2S $T=363320 638960 1 180 $X=361460 $Y=638580
X2483 2031 2040 2041 2 1 ND2S $T=366420 649040 1 0 $X=366420 $Y=643620
X2484 2013 2037 338 2 1 ND2S $T=368280 669200 0 180 $X=366420 $Y=663780
X2485 2042 2034 2041 2 1 ND2S $T=368280 679280 1 0 $X=368280 $Y=673860
X2486 1976 2033 338 2 1 ND2S $T=372000 659120 1 0 $X=372000 $Y=653700
X2487 2581 2549 2589 2 1 ND2S $T=487940 659120 0 0 $X=487940 $Y=658740
X2488 2903 637 708 2 1 ND2S $T=673940 518000 1 180 $X=672080 $Y=517620
X2489 4008 4016 3990 2 1 ND2S $T=759500 528080 1 0 $X=759500 $Y=522660
X2490 4470 4482 1062 2 1 ND2S $T=858700 548240 0 180 $X=856840 $Y=542820
X2491 4473 4642 3854 2 1 ND2S $T=890940 638960 1 180 $X=889080 $Y=638580
X2492 1152 1153 4846 2 1 ND2S $T=940540 497840 0 0 $X=940540 $Y=497460
X2493 5147 5118 1029 2 1 ND2S $T=1005020 558320 0 180 $X=1003160 $Y=552900
X2494 5414 5440 5436 2 1 ND2S $T=1068260 588560 0 0 $X=1068260 $Y=588180
X2495 5424 5453 1144 2 1 ND2S $T=1071980 507920 0 180 $X=1070120 $Y=502500
X2496 1321 1372 31 1 2 ND2 $T=230640 608720 1 0 $X=230640 $Y=603300
X2497 1372 1379 1377 1 2 ND2 $T=235600 608720 0 180 $X=233740 $Y=603300
X2498 37 59 62 1 2 ND2 $T=234980 538160 0 0 $X=234980 $Y=537780
X2499 1373 1377 1359 1 2 ND2 $T=234980 608720 0 0 $X=234980 $Y=608340
X2500 63 1351 26 1 2 ND2 $T=236840 628880 1 180 $X=234980 $Y=628500
X2501 1393 1398 1359 1 2 ND2 $T=237460 608720 1 0 $X=237460 $Y=603300
X2502 1401 1396 1415 1 2 ND2 $T=238700 659120 1 0 $X=238700 $Y=653700
X2503 1412 1401 82 1 2 ND2 $T=239940 659120 0 0 $X=239940 $Y=658740
X2504 1413 1406 1420 1 2 ND2 $T=239940 669200 0 0 $X=239940 $Y=668820
X2505 1418 1415 85 1 2 ND2 $T=240560 659120 1 0 $X=240560 $Y=653700
X2506 1433 1434 31 1 2 ND2 $T=243040 608720 0 180 $X=241180 $Y=603300
X2507 1412 1420 85 1 2 ND2 $T=241800 669200 1 0 $X=241800 $Y=663780
X2508 1445 1438 85 1 2 ND2 $T=245520 679280 1 180 $X=243660 $Y=678900
X2509 1437 52 1438 1 2 ND2 $T=243660 689360 1 0 $X=243660 $Y=683940
X2510 1451 1437 1458 1 2 ND2 $T=245520 689360 1 0 $X=245520 $Y=683940
X2511 1445 1450 1453 1 2 ND2 $T=248000 679280 0 180 $X=246140 $Y=673860
X2512 25 108 1385 1 2 ND2 $T=248620 538160 1 180 $X=246760 $Y=537780
X2513 1449 1492 76 1 2 ND2 $T=250480 659120 0 180 $X=248620 $Y=653700
X2514 1467 1412 1473 1 2 ND2 $T=248620 669200 1 0 $X=248620 $Y=663780
X2515 1489 1469 76 1 2 ND2 $T=250480 669200 1 180 $X=248620 $Y=668820
X2516 1468 1421 1469 1 2 ND2 $T=248620 679280 1 0 $X=248620 $Y=673860
X2517 1479 1467 1496 1 2 ND2 $T=250480 669200 1 0 $X=250480 $Y=663780
X2518 1347 1466 1463 1 2 ND2 $T=252340 618800 1 0 $X=252340 $Y=613380
X2519 1500 1462 1347 1 2 ND2 $T=254200 618800 1 180 $X=252340 $Y=618420
X2520 1500 1455 1463 1 2 ND2 $T=254200 628880 1 180 $X=252340 $Y=628500
X2521 1485 1436 1492 1 2 ND2 $T=252340 659120 0 0 $X=252340 $Y=658740
X2522 1517 1471 1526 1 2 ND2 $T=256680 608720 1 0 $X=256680 $Y=603300
X2523 135 1491 120 1 2 ND2 $T=261020 538160 1 0 $X=261020 $Y=532740
X2524 1514 1517 121 1 2 ND2 $T=261020 618800 1 0 $X=261020 $Y=613380
X2525 1549 1547 146 1 2 ND2 $T=262260 528080 1 0 $X=262260 $Y=522660
X2526 67 1546 25 1 2 ND2 $T=264120 538160 0 0 $X=264120 $Y=537780
X2527 1557 1526 128 1 2 ND2 $T=264120 618800 1 0 $X=264120 $Y=613380
X2528 1361 1545 1581 1 2 ND2 $T=265980 608720 1 0 $X=265980 $Y=603300
X2529 165 1607 80 1 2 ND2 $T=274660 507920 1 180 $X=272800 $Y=507540
X2530 1614 1509 1604 1 2 ND2 $T=274660 649040 1 180 $X=272800 $Y=648660
X2531 1622 1614 1629 1 2 ND2 $T=275900 649040 0 0 $X=275900 $Y=648660
X2532 1613 1625 167 1 2 ND2 $T=275900 659120 1 0 $X=275900 $Y=653700
X2533 1633 180 1625 1 2 ND2 $T=278380 659120 1 180 $X=276520 $Y=658740
X2534 1465 1626 1636 1 2 ND2 $T=277760 598640 0 0 $X=277760 $Y=598260
X2535 107 1615 151 1 2 ND2 $T=281480 638960 0 180 $X=279620 $Y=633540
X2536 1639 1633 1629 1 2 ND2 $T=279620 659120 0 0 $X=279620 $Y=658740
X2537 1637 1618 184 1 2 ND2 $T=280240 507920 0 0 $X=280240 $Y=507540
X2538 1659 1657 128 1 2 ND2 $T=282720 628880 1 180 $X=280860 $Y=628500
X2539 1465 1631 1651 1 2 ND2 $T=281480 598640 1 0 $X=281480 $Y=593220
X2540 1655 1646 1662 1 2 ND2 $T=281480 669200 0 0 $X=281480 $Y=668820
X2541 1671 1644 121 1 2 ND2 $T=285200 628880 0 180 $X=283340 $Y=623460
X2542 1679 1655 1687 1 2 ND2 $T=286440 669200 0 0 $X=286440 $Y=668820
X2543 1696 1678 1676 1 2 ND2 $T=289540 659120 0 180 $X=287680 $Y=653700
X2544 1700 1708 111 1 2 ND2 $T=291400 507920 1 180 $X=289540 $Y=507540
X2545 1630 1685 211 1 2 ND2 $T=289540 548240 1 0 $X=289540 $Y=542820
X2546 1601 1709 1693 1 2 ND2 $T=291400 598640 0 180 $X=289540 $Y=593220
X2547 1659 1677 1705 1 2 ND2 $T=289540 628880 1 0 $X=289540 $Y=623460
X2548 209 1695 146 1 2 ND2 $T=290160 518000 0 0 $X=290160 $Y=517620
X2549 1707 1681 1711 1 2 ND2 $T=291400 689360 1 0 $X=291400 $Y=683940
X2550 1716 1707 1710 1 2 ND2 $T=296360 689360 0 180 $X=294500 $Y=683940
X2551 1752 241 1570 1 2 ND2 $T=301940 699440 0 180 $X=300080 $Y=694020
X2552 1645 1763 148 1 2 ND2 $T=301940 538160 0 0 $X=301940 $Y=537780
X2553 166 1556 177 1 2 ND2 $T=303800 538160 1 0 $X=303800 $Y=532740
X2554 1551 1759 1769 1 2 ND2 $T=306900 689360 0 180 $X=305040 $Y=683940
X2555 1774 1684 148 1 2 ND2 $T=306900 558320 1 0 $X=306900 $Y=552900
X2556 1785 1786 1762 1 2 ND2 $T=308760 598640 0 180 $X=306900 $Y=593220
X2557 1570 251 253 1 2 ND2 $T=306900 699440 1 0 $X=306900 $Y=694020
X2558 37 1766 1774 1 2 ND2 $T=308760 538160 0 0 $X=308760 $Y=537780
X2559 1795 1794 1762 1 2 ND2 $T=311860 598640 0 180 $X=310000 $Y=593220
X2560 1813 1650 257 1 2 ND2 $T=312480 507920 0 180 $X=310620 $Y=502500
X2561 1414 1670 1537 1 2 ND2 $T=311860 548240 0 0 $X=311860 $Y=547860
X2562 1781 1800 1735 1 2 ND2 $T=313720 608720 0 180 $X=311860 $Y=603300
X2563 1793 1460 1537 1 2 ND2 $T=313720 528080 1 0 $X=313720 $Y=522660
X2564 1785 1792 1795 1 2 ND2 $T=313720 598640 1 0 $X=313720 $Y=593220
X2565 1773 266 1385 1 2 ND2 $T=315580 518000 1 0 $X=315580 $Y=512580
X2566 1793 1729 62 1 2 ND2 $T=315580 528080 1 0 $X=315580 $Y=522660
X2567 1774 1477 177 1 2 ND2 $T=318680 528080 0 0 $X=318680 $Y=527700
X2568 37 1836 1537 1 2 ND2 $T=322400 548240 0 180 $X=320540 $Y=542820
X2569 1810 1833 1820 1 2 ND2 $T=322400 659120 0 180 $X=320540 $Y=653700
X2570 1744 1823 1846 1 2 ND2 $T=323020 598640 0 0 $X=323020 $Y=598260
X2571 274 259 210 1 2 ND2 $T=323640 528080 1 0 $X=323640 $Y=522660
X2572 1846 1831 1505 1 2 ND2 $T=324880 598640 0 0 $X=324880 $Y=598260
X2573 120 1728 177 1 2 ND2 $T=325500 538160 1 0 $X=325500 $Y=532740
X2574 120 1443 1385 1 2 ND2 $T=327360 548240 0 0 $X=327360 $Y=547860
X2575 1788 1844 1810 1 2 ND2 $T=327360 659120 1 0 $X=327360 $Y=653700
X2576 1385 1579 177 1 2 ND2 $T=329220 538160 1 0 $X=329220 $Y=532740
X2577 1814 1864 1840 1 2 ND2 $T=329220 669200 0 0 $X=329220 $Y=668820
X2578 1856 1845 1869 1 2 ND2 $T=329220 689360 1 0 $X=329220 $Y=683940
X2579 1856 1851 1889 1 2 ND2 $T=329220 689360 0 0 $X=329220 $Y=688980
X2580 209 1808 274 1 2 ND2 $T=330460 518000 0 0 $X=330460 $Y=517620
X2581 1874 165 284 1 2 ND2 $T=332320 507920 1 0 $X=332320 $Y=502500
X2582 1877 1774 288 1 2 ND2 $T=332320 518000 0 0 $X=332320 $Y=517620
X2583 1874 25 289 1 2 ND2 $T=332940 507920 0 0 $X=332940 $Y=507540
X2584 1537 1887 40 1 2 ND2 $T=336040 528080 0 180 $X=334180 $Y=522660
X2585 290 210 292 1 2 ND2 $T=336040 497840 0 0 $X=336040 $Y=497460
X2586 1906 1903 1872 1 2 ND2 $T=339140 618800 0 0 $X=339140 $Y=618420
X2587 1906 1896 1868 1 2 ND2 $T=344100 608720 0 0 $X=344100 $Y=608340
X2588 1868 1914 1872 1 2 ND2 $T=344720 618800 1 0 $X=344720 $Y=613380
X2589 1959 1945 250 1 2 ND2 $T=351540 618800 0 0 $X=351540 $Y=618420
X2590 2011 1980 2024 1 2 ND2 $T=361460 649040 0 0 $X=361460 $Y=648660
X2591 2012 2011 2023 1 2 ND2 $T=361460 659120 1 0 $X=361460 $Y=653700
X2592 2033 1981 2040 1 2 ND2 $T=366420 649040 0 0 $X=366420 $Y=648660
X2593 2034 1999 2037 1 2 ND2 $T=366420 669200 0 0 $X=366420 $Y=668820
X2594 352 354 357 1 2 ND2 $T=378200 699440 1 0 $X=378200 $Y=694020
X2595 2129 2103 364 1 2 ND2 $T=387500 689360 1 180 $X=385640 $Y=688980
X2596 362 2122 2129 1 2 ND2 $T=391840 689360 0 0 $X=391840 $Y=688980
X2597 2138 2134 2060 1 2 ND2 $T=392460 689360 1 0 $X=392460 $Y=683940
X2598 2175 2143 2182 1 2 ND2 $T=402380 638960 0 0 $X=402380 $Y=638580
X2599 2230 2192 2254 1 2 ND2 $T=416020 528080 1 0 $X=416020 $Y=522660
X2600 404 2189 2254 1 2 ND2 $T=419740 528080 0 0 $X=419740 $Y=527700
X2601 406 2259 2230 1 2 ND2 $T=420980 497840 0 0 $X=420980 $Y=497460
X2602 2262 2264 2254 1 2 ND2 $T=421600 528080 1 0 $X=421600 $Y=522660
X2603 408 2271 2254 1 2 ND2 $T=424080 538160 0 180 $X=422220 $Y=532740
X2604 2262 2380 425 1 2 ND2 $T=442060 538160 0 0 $X=442060 $Y=537780
X2605 2230 2379 425 1 2 ND2 $T=445160 518000 0 0 $X=445160 $Y=517620
X2606 2388 431 408 1 2 ND2 $T=447020 497840 0 0 $X=447020 $Y=497460
X2607 2408 2282 2420 1 2 ND2 $T=449500 518000 1 0 $X=449500 $Y=512580
X2608 2408 2296 2432 1 2 ND2 $T=451980 528080 1 0 $X=451980 $Y=522660
X2609 2388 2448 2262 1 2 ND2 $T=459420 507920 0 180 $X=457560 $Y=502500
X2610 2420 2445 2456 1 2 ND2 $T=458800 507920 0 0 $X=458800 $Y=507540
X2611 2388 2462 404 1 2 ND2 $T=461900 497840 1 180 $X=460040 $Y=497460
X2612 2432 2601 2456 1 2 ND2 $T=494760 507920 0 0 $X=494760 $Y=507540
X2613 2631 2293 2638 1 2 ND2 $T=498480 518000 1 0 $X=498480 $Y=512580
X2614 2634 2276 2631 1 2 ND2 $T=499100 528080 1 0 $X=499100 $Y=522660
X2615 2670 2295 2634 1 2 ND2 $T=506540 518000 0 180 $X=504680 $Y=512580
X2616 2670 2389 2638 1 2 ND2 $T=506540 518000 0 0 $X=506540 $Y=517620
X2617 2660 2690 2691 1 2 ND2 $T=506540 638960 0 0 $X=506540 $Y=638580
X2618 2642 2720 2701 1 2 ND2 $T=512120 638960 1 180 $X=510260 $Y=638580
X2619 2718 516 2666 1 2 ND2 $T=513360 659120 0 180 $X=511500 $Y=653700
X2620 2666 522 2691 1 2 ND2 $T=515220 649040 1 180 $X=513360 $Y=648660
X2621 2706 519 2697 1 2 ND2 $T=515220 669200 1 180 $X=513360 $Y=668820
X2622 2706 517 2672 1 2 ND2 $T=515220 679280 0 180 $X=513360 $Y=673860
X2623 2726 2732 2652 1 2 ND2 $T=517080 638960 0 180 $X=515220 $Y=633540
X2624 2726 2733 2700 1 2 ND2 $T=517080 638960 1 180 $X=515220 $Y=638580
X2625 512 506 524 1 2 ND2 $T=515220 689360 1 0 $X=515220 $Y=683940
X2626 531 2748 526 1 2 ND2 $T=518940 689360 0 180 $X=517080 $Y=683940
X2627 529 2724 519 1 2 ND2 $T=518940 699440 0 180 $X=517080 $Y=694020
X2628 2761 2680 328 1 2 ND2 $T=520180 628880 0 180 $X=518320 $Y=623460
X2629 2739 2771 2712 1 2 ND2 $T=520180 649040 0 180 $X=518320 $Y=643620
X2630 2729 2760 2680 1 2 ND2 $T=520800 618800 1 180 $X=518940 $Y=618420
X2631 2713 543 2739 1 2 ND2 $T=520800 669200 0 180 $X=518940 $Y=663780
X2632 531 2754 536 1 2 ND2 $T=518940 689360 1 0 $X=518940 $Y=683940
X2633 526 532 542 1 2 ND2 $T=519560 699440 1 0 $X=519560 $Y=694020
X2634 2765 551 2691 1 2 ND2 $T=523900 669200 1 180 $X=522040 $Y=668820
X2635 2765 536 2718 1 2 ND2 $T=523900 679280 0 180 $X=522040 $Y=673860
X2636 2743 542 2691 1 2 ND2 $T=526380 679280 1 180 $X=524520 $Y=678900
X2637 2787 575 2779 1 2 ND2 $T=528860 659120 1 180 $X=527000 $Y=658740
X2638 2797 579 2761 1 2 ND2 $T=529480 659120 0 180 $X=527620 $Y=653700
X2639 517 583 495 1 2 ND2 $T=530720 679280 0 180 $X=528860 $Y=673860
X2640 2825 2805 2853 1 2 ND2 $T=530720 507920 1 0 $X=530720 $Y=502500
X2641 578 2829 528 1 2 ND2 $T=530720 669200 1 0 $X=530720 $Y=663780
X2642 2859 2716 2825 1 2 ND2 $T=535680 518000 1 180 $X=533820 $Y=517620
X2643 2712 2857 2677 1 2 ND2 $T=538780 598640 0 0 $X=538780 $Y=598260
X2644 2867 2661 2880 1 2 ND2 $T=538780 659120 0 0 $X=538780 $Y=658740
X2645 2860 2703 2854 1 2 ND2 $T=543740 538160 1 180 $X=541880 $Y=537780
X2646 2710 2920 2700 1 2 ND2 $T=544360 618800 0 180 $X=542500 $Y=613380
X2647 2802 2906 2870 1 2 ND2 $T=544360 638960 0 180 $X=542500 $Y=633540
X2648 2717 2744 2947 1 2 ND2 $T=547460 618800 0 0 $X=547460 $Y=618420
X2649 2908 2938 2802 1 2 ND2 $T=549320 638960 0 180 $X=547460 $Y=633540
X2650 2810 2866 2870 1 2 ND2 $T=551180 628880 0 180 $X=549320 $Y=623460
X2651 2919 2977 2819 1 2 ND2 $T=554280 628880 0 180 $X=552420 $Y=623460
X2652 2784 633 2937 1 2 ND2 $T=552420 638960 0 0 $X=552420 $Y=638580
X2653 622 2976 573 1 2 ND2 $T=554280 679280 0 180 $X=552420 $Y=673860
X2654 2986 650 2691 1 2 ND2 $T=556140 649040 0 180 $X=554280 $Y=643620
X2655 2819 2997 2937 1 2 ND2 $T=556140 618800 1 0 $X=556140 $Y=613380
X2656 2802 648 3010 1 2 ND2 $T=556140 638960 1 0 $X=556140 $Y=633540
X2657 2989 653 2718 1 2 ND2 $T=559240 669200 1 180 $X=557380 $Y=668820
X2658 3035 3022 2691 1 2 ND2 $T=559860 588560 1 180 $X=558000 $Y=588180
X2659 2810 658 2819 1 2 ND2 $T=561100 618800 1 180 $X=559240 $Y=618420
X2660 2989 656 2691 1 2 ND2 $T=559240 669200 0 0 $X=559240 $Y=668820
X2661 3010 659 2937 1 2 ND2 $T=562960 638960 1 180 $X=561100 $Y=638580
X2662 2937 3065 2870 1 2 ND2 $T=563580 618800 1 180 $X=561720 $Y=618420
X2663 2956 3073 2863 1 2 ND2 $T=564820 608720 0 180 $X=562960 $Y=603300
X2664 3035 3020 3086 1 2 ND2 $T=564820 598640 0 0 $X=564820 $Y=598260
X2665 3087 3091 2691 1 2 ND2 $T=568540 598640 0 180 $X=566680 $Y=593220
X2666 2810 668 2784 1 2 ND2 $T=569160 628880 1 180 $X=567300 $Y=628500
X2667 3087 3117 3086 1 2 ND2 $T=569780 598640 1 180 $X=567920 $Y=598260
X2668 3042 3095 2691 1 2 ND2 $T=569780 598640 1 0 $X=569780 $Y=593220
X2669 3111 2975 3163 1 2 ND2 $T=571020 679280 0 0 $X=571020 $Y=678900
X2670 682 681 3105 1 2 ND2 $T=571640 497840 0 0 $X=571640 $Y=497460
X2671 3042 3131 3086 1 2 ND2 $T=573500 598640 0 180 $X=571640 $Y=593220
X2672 3136 3125 3086 1 2 ND2 $T=573500 598640 1 180 $X=571640 $Y=598260
X2673 3136 3107 2691 1 2 ND2 $T=573500 598640 0 0 $X=573500 $Y=598260
X2674 2807 3168 2691 1 2 ND2 $T=576600 608720 0 0 $X=576600 $Y=608340
X2675 2828 3178 2691 1 2 ND2 $T=578460 608720 0 0 $X=578460 $Y=608340
X2676 3117 3219 3168 1 2 ND2 $T=585280 608720 1 180 $X=583420 $Y=608340
X2677 3092 3201 2997 1 2 ND2 $T=583420 618800 1 0 $X=583420 $Y=613380
X2678 3093 3205 2947 1 2 ND2 $T=587140 598640 0 180 $X=585280 $Y=593220
X2679 650 3223 652 1 2 ND2 $T=587140 649040 0 180 $X=585280 $Y=643620
X2680 527 3235 652 1 2 ND2 $T=588380 669200 0 180 $X=586520 $Y=663780
X2681 3245 3255 682 1 2 ND2 $T=593960 528080 0 180 $X=592100 $Y=522660
X2682 3125 3187 3248 1 2 ND2 $T=592100 598640 0 0 $X=592100 $Y=598260
X2683 3263 3253 524 1 2 ND2 $T=595200 669200 1 180 $X=593340 $Y=668820
X2684 3196 3267 3255 1 2 ND2 $T=595820 518000 1 180 $X=593960 $Y=517620
X2685 3246 3196 629 1 2 ND2 $T=593960 528080 1 0 $X=593960 $Y=522660
X2686 3263 3280 519 1 2 ND2 $T=598300 669200 1 180 $X=596440 $Y=668820
X2687 3289 2806 3266 1 2 ND2 $T=603260 598640 0 0 $X=603260 $Y=598260
X2688 3266 3324 3091 1 2 ND2 $T=605120 608720 0 0 $X=605120 $Y=608340
X2689 3293 3254 3347 1 2 ND2 $T=607600 528080 1 0 $X=607600 $Y=522660
X2690 3330 3298 629 1 2 ND2 $T=608220 558320 0 0 $X=608220 $Y=557940
X2691 3109 3351 3119 1 2 ND2 $T=610080 638960 1 0 $X=610080 $Y=633540
X2692 3117 3352 3131 1 2 ND2 $T=610700 598640 0 0 $X=610700 $Y=598260
X2693 3160 3320 3159 1 2 ND2 $T=611940 638960 1 0 $X=611940 $Y=633540
X2694 766 3325 3159 1 2 ND2 $T=615040 659120 0 180 $X=613180 $Y=653700
X2695 550 3382 704 1 2 ND2 $T=618760 679280 1 0 $X=618760 $Y=673860
X2696 721 3379 2791 1 2 ND2 $T=620000 649040 0 0 $X=620000 $Y=648660
X2697 3420 3037 3431 1 2 ND2 $T=621240 618800 0 0 $X=621240 $Y=618420
X2698 3315 3448 2866 1 2 ND2 $T=625580 669200 1 180 $X=623720 $Y=668820
X2699 3418 3436 547 1 2 ND2 $T=625580 689360 0 180 $X=623720 $Y=683940
X2700 550 3432 2777 1 2 ND2 $T=624340 638960 0 0 $X=624340 $Y=638580
X2701 3426 3449 3119 1 2 ND2 $T=626820 679280 0 180 $X=624960 $Y=673860
X2702 671 3466 3120 1 2 ND2 $T=628060 608720 0 180 $X=626200 $Y=603300
X2703 2977 3361 3061 1 2 ND2 $T=631160 689360 1 0 $X=631160 $Y=683940
X2704 633 3457 670 1 2 ND2 $T=631780 679280 1 0 $X=631780 $Y=673860
X2705 3474 3349 658 1 2 ND2 $T=633020 618800 0 0 $X=633020 $Y=618420
X2706 3473 737 3465 1 2 ND2 $T=634880 669200 1 0 $X=634880 $Y=663780
X2707 3439 3472 2866 1 2 ND2 $T=636740 608720 1 0 $X=636740 $Y=603300
X2708 3322 3386 3306 1 2 ND2 $T=639840 649040 0 0 $X=639840 $Y=648660
X2709 3447 3523 820 1 2 ND2 $T=648520 507920 0 180 $X=646660 $Y=502500
X2710 2858 822 3059 1 2 ND2 $T=646660 699440 1 0 $X=646660 $Y=694020
X2711 3061 3532 2852 1 2 ND2 $T=652860 679280 0 0 $X=652860 $Y=678900
X2712 3073 3555 3159 1 2 ND2 $T=657200 679280 0 180 $X=655340 $Y=673860
X2713 3564 837 3574 1 2 ND2 $T=657200 699440 1 0 $X=657200 $Y=694020
X2714 3592 3596 3591 1 2 ND2 $T=665260 679280 0 180 $X=663400 $Y=673860
X2715 3609 3589 3613 1 2 ND2 $T=668980 659120 1 0 $X=668980 $Y=653700
X2716 3626 3642 3649 1 2 ND2 $T=676420 649040 0 0 $X=676420 $Y=648660
X2717 3670 3672 878 1 2 ND2 $T=684480 689360 1 180 $X=682620 $Y=688980
X2718 3651 3683 3676 1 2 ND2 $T=684480 649040 1 0 $X=684480 $Y=643620
X2719 3715 3728 3738 1 2 ND2 $T=698120 679280 1 0 $X=698120 $Y=673860
X2720 3705 3768 3739 1 2 ND2 $T=699360 649040 0 0 $X=699360 $Y=648660
X2721 3765 3798 3782 1 2 ND2 $T=706180 679280 1 0 $X=706180 $Y=673860
X2722 3803 3815 3775 1 2 ND2 $T=713620 679280 0 180 $X=711760 $Y=673860
X2723 3746 3836 3832 1 2 ND2 $T=719200 649040 0 0 $X=719200 $Y=648660
X2724 3852 3862 3869 1 2 ND2 $T=724160 689360 0 0 $X=724160 $Y=688980
X2725 3895 3926 3901 1 2 ND2 $T=733460 689360 0 0 $X=733460 $Y=688980
X2726 3801 3917 3909 1 2 ND2 $T=735320 649040 1 0 $X=735320 $Y=643620
X2727 3829 3960 3949 1 2 ND2 $T=744000 649040 1 0 $X=744000 $Y=643620
X2728 3873 3980 3999 1 2 ND2 $T=752680 659120 1 0 $X=752680 $Y=653700
X2729 3963 4001 3985 1 2 ND2 $T=752680 689360 0 0 $X=752680 $Y=688980
X2730 4012 4015 4008 1 2 ND2 $T=758880 538160 0 180 $X=757020 $Y=532740
X2731 3866 959 617 1 2 ND2 $T=759500 497840 1 180 $X=757640 $Y=497460
X2732 4003 4010 4028 1 2 ND2 $T=759500 679280 0 0 $X=759500 $Y=678900
X2733 4002 4058 4022 1 2 ND2 $T=764460 538160 1 180 $X=762600 $Y=537780
X2734 4022 4045 4038 1 2 ND2 $T=763220 548240 1 0 $X=763220 $Y=542820
X2735 4012 4011 3990 1 2 ND2 $T=766320 528080 1 180 $X=764460 $Y=527700
X2736 4048 4034 4073 1 2 ND2 $T=766320 507920 1 0 $X=766320 $Y=502500
X2737 4002 4060 4038 1 2 ND2 $T=766320 548240 1 0 $X=766320 $Y=542820
X2738 3941 4091 4063 1 2 ND2 $T=766320 659120 1 0 $X=766320 $Y=653700
X2739 4048 4059 969 1 2 ND2 $T=767560 507920 0 0 $X=767560 $Y=507540
X2740 4073 4027 969 1 2 ND2 $T=769420 507920 1 0 $X=769420 $Y=502500
X2741 4074 4055 4077 1 2 ND2 $T=769420 568400 0 0 $X=769420 $Y=568020
X2742 4068 4039 4074 1 2 ND2 $T=769420 578480 1 0 $X=769420 $Y=573060
X2743 3991 4105 4096 1 2 ND2 $T=773140 669200 1 0 $X=773140 $Y=663780
X2744 4053 4084 4126 1 2 ND2 $T=776240 689360 1 0 $X=776240 $Y=683940
X2745 4154 4117 4157 1 2 ND2 $T=786160 588560 1 0 $X=786160 $Y=583140
X2746 4144 4132 4157 1 2 ND2 $T=786160 588560 0 0 $X=786160 $Y=588180
X2747 4144 4141 4154 1 2 ND2 $T=788640 588560 0 0 $X=788640 $Y=588180
X2748 4064 4161 4177 1 2 ND2 $T=789880 659120 1 0 $X=789880 $Y=653700
X2749 4033 4210 4185 1 2 ND2 $T=789880 659120 0 0 $X=789880 $Y=658740
X2750 4149 4207 995 1 2 ND2 $T=793600 689360 1 180 $X=791740 $Y=688980
X2751 4234 4253 4203 1 2 ND2 $T=804140 528080 0 0 $X=804140 $Y=527700
X2752 1067 4491 4506 1 2 ND2 $T=861800 507920 0 0 $X=861800 $Y=507540
X2753 4508 4498 4506 1 2 ND2 $T=863660 528080 1 0 $X=863660 $Y=522660
X2754 4508 4514 1067 1 2 ND2 $T=864900 518000 1 0 $X=864900 $Y=512580
X2755 4525 4502 4533 1 2 ND2 $T=866760 578480 0 0 $X=866760 $Y=578100
X2756 4525 4516 4536 1 2 ND2 $T=866760 588560 0 0 $X=866760 $Y=588180
X2757 4533 4534 4536 1 2 ND2 $T=868620 578480 0 0 $X=868620 $Y=578100
X2758 4544 4551 1079 1 2 ND2 $T=871720 518000 0 0 $X=871720 $Y=517620
X2759 4620 4609 4569 1 2 ND2 $T=885980 588560 0 180 $X=884120 $Y=583140
X2760 4620 4616 4591 1 2 ND2 $T=887220 588560 1 0 $X=887220 $Y=583140
X2761 4569 4608 4591 1 2 ND2 $T=889700 578480 0 0 $X=889700 $Y=578100
X2762 4706 4722 4639 1 2 ND2 $T=911400 578480 1 180 $X=909540 $Y=578100
X2763 4744 4738 4736 1 2 ND2 $T=915120 568400 0 180 $X=913260 $Y=562980
X2764 4744 4725 4740 1 2 ND2 $T=916360 558320 1 180 $X=914500 $Y=557940
X2765 4736 4715 4740 1 2 ND2 $T=915120 568400 1 0 $X=915120 $Y=562980
X2766 1132 4751 4747 1 2 ND2 $T=918220 538160 1 180 $X=916360 $Y=537780
X2767 4762 4758 4747 1 2 ND2 $T=921940 538160 1 180 $X=920080 $Y=537780
X2768 4762 4763 1132 1 2 ND2 $T=926900 528080 1 180 $X=925040 $Y=527700
X2769 4774 4773 4769 1 2 ND2 $T=925040 608720 0 0 $X=925040 $Y=608340
X2770 1158 4867 4866 1 2 ND2 $T=946740 528080 0 180 $X=944880 $Y=522660
X2771 4881 4898 4880 1 2 ND2 $T=950460 578480 1 0 $X=950460 $Y=573060
X2772 4887 4927 4844 1 2 ND2 $T=954800 618800 0 180 $X=952940 $Y=613380
X2773 4917 4885 4895 1 2 ND2 $T=955420 628880 0 0 $X=955420 $Y=628500
X2774 4975 4987 4996 1 2 ND2 $T=974640 628880 0 0 $X=974640 $Y=628500
X2775 5020 5015 1202 1 2 ND2 $T=979600 528080 1 0 $X=979600 $Y=522660
X2776 5073 5067 1212 1 2 ND2 $T=991380 518000 0 0 $X=991380 $Y=517620
X2777 5051 5074 5110 1 2 ND2 $T=995720 628880 0 0 $X=995720 $Y=628500
X2778 5112 5104 5119 1 2 ND2 $T=998200 618800 1 0 $X=998200 $Y=613380
X2779 5085 5064 5110 1 2 ND2 $T=1000060 628880 1 0 $X=1000060 $Y=623460
X2780 5154 5150 1221 1 2 ND2 $T=1008740 528080 1 180 $X=1006880 $Y=527700
X2781 5140 5105 1220 1 2 ND2 $T=1008740 518000 0 0 $X=1008740 $Y=517620
X2782 5201 5227 5213 1 2 ND2 $T=1018660 598640 0 0 $X=1018660 $Y=598260
X2783 5205 5219 1228 1 2 ND2 $T=1019900 528080 0 0 $X=1019900 $Y=527700
X2784 5194 5197 5193 1 2 ND2 $T=1026720 638960 1 0 $X=1026720 $Y=633540
X2785 5289 5293 5281 1 2 ND2 $T=1037880 548240 0 180 $X=1036020 $Y=542820
X2786 5287 5353 5305 1 2 ND2 $T=1050900 618800 1 0 $X=1050900 $Y=613380
X2787 5362 5342 1246 1 2 ND2 $T=1051520 528080 1 0 $X=1051520 $Y=522660
X2788 5396 5403 5389 1 2 ND2 $T=1059580 618800 0 180 $X=1057720 $Y=613380
X2789 5395 5433 5408 1 2 ND2 $T=1063920 568400 0 180 $X=1062060 $Y=562980
X2790 5417 5401 5428 1 2 ND2 $T=1063920 598640 0 0 $X=1063920 $Y=598260
X2791 5458 5447 5414 1 2 ND2 $T=1068260 578480 1 180 $X=1066400 $Y=578100
X2792 5347 5393 5428 1 2 ND2 $T=1067640 598640 0 0 $X=1067640 $Y=598260
X2793 5279 5441 1147 1 2 ND2 $T=1070120 507920 0 180 $X=1068260 $Y=502500
X2794 1238 5429 1147 1 2 ND2 $T=1072600 507920 1 180 $X=1070740 $Y=507540
X2795 5446 5454 1259 1 2 ND2 $T=1073840 528080 0 180 $X=1071980 $Y=522660
X2796 5446 5463 5397 1 2 ND2 $T=1073840 528080 1 180 $X=1071980 $Y=527700
X2797 5453 5459 5441 1 2 ND2 $T=1075700 507920 0 180 $X=1073840 $Y=502500
X2798 1259 5475 5397 1 2 ND2 $T=1076940 528080 0 180 $X=1075080 $Y=522660
X2799 5458 5456 5436 1 2 ND2 $T=1075700 588560 1 0 $X=1075700 $Y=583140
X2800 5489 5488 5427 1 2 ND2 $T=1086240 598640 0 180 $X=1084380 $Y=593220
X2801 1274 5495 5472 1 2 ND2 $T=1092440 548240 0 0 $X=1092440 $Y=547860
X2802 5483 5493 5472 1 2 ND2 $T=1092440 558320 1 0 $X=1092440 $Y=552900
X2803 1455 1459 1462 1466 1 2 ND3P $T=244900 618800 1 0 $X=244900 $Y=613380
X2804 1545 1486 1554 1538 1 2 ND3P $T=264120 608720 0 180 $X=259160 $Y=603300
X2805 1631 1553 1626 1619 1 2 ND3P $T=280240 598640 0 180 $X=275280 $Y=593220
X2806 1694 1744 1730 1709 1 2 ND3P $T=293880 598640 1 0 $X=293880 $Y=593220
X2807 1745 1752 1756 1759 1 2 ND3P $T=300080 689360 0 0 $X=300080 $Y=688980
X2808 1786 1796 1792 1794 1 2 ND3P $T=309380 598640 0 0 $X=309380 $Y=598260
X2809 1823 1828 1831 1825 1 2 ND3P $T=318060 598640 0 0 $X=318060 $Y=598260
X2810 1844 1837 1849 1833 1 2 ND3P $T=327360 659120 0 180 $X=322400 $Y=653700
X2811 1845 275 1851 1855 1 2 ND3P $T=323020 689360 0 0 $X=323020 $Y=688980
X2812 1864 1856 1866 1850 1 2 ND3P $T=331700 679280 1 180 $X=326740 $Y=678900
X2813 2122 366 2103 369 1 2 ND3P $T=391840 699440 0 180 $X=386880 $Y=694020
X2814 3373 3393 3278 3347 1 2 ND3P $T=613180 538160 0 0 $X=613180 $Y=537780
X2815 3278 3372 3347 3373 1 2 ND3P $T=620000 538160 0 0 $X=620000 $Y=537780
X2816 3347 3369 3278 3373 1 2 ND3P $T=621240 528080 0 0 $X=621240 $Y=527700
X2817 4034 3989 4059 4027 1 2 ND3P $T=766320 507920 1 180 $X=761360 $Y=507540
X2818 4039 4061 4050 4055 1 2 ND3P $T=762600 568400 0 0 $X=762600 $Y=568020
X2819 4132 4100 4141 4117 1 2 ND3P $T=784920 588560 1 180 $X=779960 $Y=588180
X2820 4498 4481 4514 4491 1 2 ND3P $T=863660 518000 0 180 $X=858700 $Y=512580
X2821 4542 4508 4550 4551 1 2 ND3P $T=869240 518000 1 0 $X=869240 $Y=512580
X2822 4616 4525 4609 4608 1 2 ND3P $T=889080 578480 1 180 $X=884120 $Y=578100
X2823 4725 4706 4738 4715 1 2 ND3P $T=913260 568400 0 180 $X=908300 $Y=562980
X2824 4722 4658 4720 4704 1 2 ND3P $T=913260 588560 0 180 $X=908300 $Y=583140
X2825 4783 4761 4778 4773 1 2 ND3P $T=928760 608720 0 180 $X=923800 $Y=603300
X2826 4899 4835 4914 4885 1 2 ND3P $T=953560 628880 1 180 $X=948600 $Y=628500
X2827 4897 4800 4884 4867 1 2 ND3P $T=955420 528080 0 180 $X=950460 $Y=522660
X2828 4973 4957 4984 4987 1 2 ND3P $T=965960 638960 1 0 $X=965960 $Y=633540
X2829 5021 4988 5040 5015 1 2 ND3P $T=982700 528080 1 180 $X=977740 $Y=527700
X2830 5074 5029 5087 5064 1 2 ND3P $T=994480 628880 1 180 $X=989520 $Y=628500
X2831 5092 5059 5099 5104 1 2 ND3P $T=993240 618800 1 0 $X=993240 $Y=613380
X2832 5206 5136 5226 5197 1 2 ND3P $T=1021140 638960 0 180 $X=1016180 $Y=633540
X2833 5335 5275 5327 5353 1 2 ND3P $T=1044700 628880 1 0 $X=1044700 $Y=623460
X2834 5336 5320 5334 5330 1 2 ND3P $T=1050900 638960 1 0 $X=1050900 $Y=633540
X2835 5401 5382 5410 5393 1 2 ND3P $T=1063300 598640 1 180 $X=1058340 $Y=598260
X2836 5447 5415 5456 5440 1 2 ND3P $T=1074460 588560 0 180 $X=1069500 $Y=583140
X2837 5454 5487 5463 5475 1 2 ND3P $T=1078180 528080 0 0 $X=1078180 $Y=527700
X2838 5493 5492 5491 5495 1 2 ND3P $T=1086860 558320 1 0 $X=1086860 $Y=552900
X2839 5496 5450 5494 5488 1 2 ND3P $T=1094920 598640 0 180 $X=1089960 $Y=593220
X2840 1519 1478 1488 1520 1 2 MAO222P $T=255440 649040 0 0 $X=255440 $Y=648660
X2841 1520 1512 1368 1527 1 2 MAO222P $T=255440 659120 0 0 $X=255440 $Y=658740
X2842 1525 1484 1375 134 1 2 MAO222P $T=256060 689360 0 0 $X=256060 $Y=688980
X2843 1527 1504 1362 1525 1 2 MAO222P $T=256680 679280 1 0 $X=256680 $Y=673860
X2844 1594 1669 1686 1652 1 2 MAO222P $T=290160 598640 1 180 $X=284580 $Y=598260
X2845 1743 1739 1584 1751 1 2 MAO222P $T=299460 679280 1 0 $X=299460 $Y=673860
X2846 1837 1860 1838 1814 1 2 MAO222P $T=329220 669200 0 180 $X=323640 $Y=663780
X2847 1859 1854 1858 1788 1 2 MAO222P $T=329840 649040 0 180 $X=324260 $Y=643620
X2848 1796 1893 1890 1906 1 2 MAO222P $T=334800 608720 1 0 $X=334800 $Y=603300
X2849 3939 3962 952 3888 1 2 MAO222P $T=749580 507920 0 180 $X=744000 $Y=502500
X2850 3989 4013 958 3939 1 2 MAO222P $T=760740 507920 1 180 $X=755160 $Y=507540
X2851 4037 4044 3997 4012 1 2 MAO222P $T=766940 538160 0 180 $X=761360 $Y=532740
X2852 4061 4062 4071 4002 1 2 MAO222P $T=769420 558320 0 180 $X=763840 $Y=552900
X2853 4083 4078 4030 4037 1 2 MAO222P $T=774380 538160 1 180 $X=768800 $Y=537780
X2854 4097 972 4088 4032 1 2 MAO222P $T=778100 507920 0 180 $X=772520 $Y=502500
X2855 4100 4116 4131 4068 1 2 MAO222P $T=782440 578480 0 180 $X=776860 $Y=573060
X2856 4093 4130 4024 4081 1 2 MAO222P $T=781200 568400 1 0 $X=781200 $Y=562980
X2857 4075 4122 3986 4083 1 2 MAO222P $T=781820 548240 0 0 $X=781820 $Y=547860
X2858 4151 4155 4046 4093 1 2 MAO222P $T=788640 578480 0 180 $X=783060 $Y=573060
X2859 4081 4135 4112 4075 1 2 MAO222P $T=783680 558320 1 0 $X=783680 $Y=552900
X2860 4119 994 4160 4097 1 2 MAO222P $T=790500 507920 1 180 $X=784920 $Y=507540
X2861 4238 1004 4218 4119 1 2 MAO222P $T=802900 507920 1 180 $X=797320 $Y=507540
X2862 4236 4271 4264 4144 1 2 MAO222P $T=810960 588560 1 180 $X=805380 $Y=588180
X2863 4258 1018 4284 4238 1 2 MAO222P $T=814680 518000 0 180 $X=809100 $Y=512580
X2864 4250 4287 4278 4236 1 2 MAO222P $T=815920 598640 0 180 $X=810340 $Y=593220
X2865 4328 1023 4315 4258 1 2 MAO222P $T=825220 507920 1 180 $X=819640 $Y=507540
X2866 4311 4338 4347 4250 1 2 MAO222P $T=826460 598640 0 180 $X=820880 $Y=593220
X2867 4295 4336 4318 4230 1 2 MAO222P $T=827080 588560 0 180 $X=821500 $Y=583140
X2868 4370 4372 4316 4295 1 2 MAO222P $T=833280 588560 0 180 $X=827700 $Y=583140
X2869 4377 1046 4411 4328 1 2 MAO222P $T=838860 507920 1 180 $X=833280 $Y=507540
X2870 4374 4422 4416 4311 1 2 MAO222P $T=843200 598640 1 180 $X=837620 $Y=598260
X2871 4421 4399 4400 4370 1 2 MAO222P $T=839480 578480 0 0 $X=839480 $Y=578100
X2872 4503 4541 4526 4454 1 2 MAO222P $T=870480 598640 0 0 $X=870480 $Y=598260
X2873 4606 1087 4593 4558 1 2 MAO222P $T=887220 518000 0 180 $X=881640 $Y=512580
X2874 4764 4787 4796 4745 1 2 MAO222P $T=928760 628880 1 180 $X=923180 $Y=628500
X2875 4799 1142 4808 4792 1 2 MAO222P $T=932480 518000 1 180 $X=926900 $Y=517620
X2876 4800 1151 4839 4799 1 2 MAO222P $T=939300 528080 1 0 $X=939300 $Y=522660
X2877 4868 4854 4861 4870 1 2 MAO222P $T=943640 618800 1 0 $X=943640 $Y=613380
X2878 4928 1168 4915 4878 1 2 MAO222P $T=955420 528080 1 0 $X=955420 $Y=522660
X2879 4957 4933 4937 4904 1 2 MAO222P $T=965340 638960 0 180 $X=959760 $Y=633540
X2880 4941 1184 4968 4928 1 2 MAO222P $T=966580 528080 0 180 $X=961000 $Y=522660
X2881 4945 4972 4939 4868 1 2 MAO222P $T=969680 608720 1 180 $X=964100 $Y=608340
X2882 4988 1195 5005 4941 1 2 MAO222P $T=976500 528080 1 180 $X=970920 $Y=527700
X2883 5003 4971 4978 4945 1 2 MAO222P $T=976500 608720 1 180 $X=970920 $Y=608340
X2884 5029 5006 5013 4999 1 2 MAO222P $T=984560 628880 1 180 $X=978980 $Y=628500
X2885 5136 5166 5121 5051 1 2 MAO222P $T=1011840 628880 0 180 $X=1006260 $Y=623460
X2886 5175 5109 5196 5123 1 2 MAO222P $T=1014320 618800 0 180 $X=1008740 $Y=613380
X2887 5283 1236 5280 5218 1 2 MAO222P $T=1033540 528080 1 0 $X=1033540 $Y=522660
X2888 5275 5304 5312 5170 1 2 MAO222P $T=1041600 598640 1 180 $X=1036020 $Y=598260
X2889 5324 1241 5300 5283 1 2 MAO222P $T=1045320 528080 0 180 $X=1039740 $Y=522660
X2890 5399 1251 5388 5362 1 2 MAO222P $T=1058340 518000 0 0 $X=1058340 $Y=517620
X2891 5415 5368 5385 5417 1 2 MAO222P $T=1061440 598640 1 0 $X=1061440 $Y=593220
X2892 1256 5356 5349 5446 1 2 MAO222P $T=1062060 528080 0 0 $X=1062060 $Y=527700
X2893 5432 1258 5439 5399 1 2 MAO222P $T=1070120 518000 1 180 $X=1064540 $Y=517620
X2894 5438 5420 5444 5458 1 2 MAO222P $T=1068260 568400 0 0 $X=1068260 $Y=568020
X2895 5450 5423 5476 5411 1 2 MAO222P $T=1075700 598640 1 180 $X=1070120 $Y=598260
X2896 5462 1264 5431 5432 1 2 MAO222P $T=1080040 507920 1 180 $X=1074460 $Y=507540
X2897 5487 5479 1269 5483 1 2 MAO222P $T=1085000 528080 0 0 $X=1085000 $Y=527700
X2898 5492 5430 5481 5477 1 2 MAO222P $T=1086240 568400 1 0 $X=1086240 $Y=562980
X2899 1273 1272 1271 5490 1 2 MAO222P $T=1088720 497840 0 0 $X=1088720 $Y=497460
X2900 5490 1263 5459 5462 1 2 MAO222P $T=1088720 507920 1 0 $X=1088720 $Y=502500
X2901 82 1 1436 1374 2 ND2P $T=244280 669200 0 0 $X=244280 $Y=668820
X2902 1398 1 1434 1465 2 ND2P $T=248620 608720 0 180 $X=244900 $Y=603300
X2903 1361 1 1553 1538 2 ND2P $T=265980 598640 1 180 $X=262260 $Y=598260
X2904 1581 1 1553 1554 2 ND2P $T=272800 598640 0 0 $X=272800 $Y=598260
X2905 1657 1 1644 1651 2 ND2P $T=283340 628880 0 180 $X=279620 $Y=623460
X2906 1651 1 1636 1619 2 ND2P $T=280860 598640 0 0 $X=280860 $Y=598260
X2907 200 1 1678 1665 2 ND2P $T=284580 659120 0 0 $X=284580 $Y=658740
X2908 1601 1 1652 1694 2 ND2P $T=289540 598640 0 180 $X=285820 $Y=593220
X2909 1693 1 1652 1730 2 ND2P $T=289540 588560 0 0 $X=289540 $Y=588180
X2910 1551 1 1751 1745 2 ND2P $T=305040 689360 0 180 $X=301320 $Y=683940
X2911 1769 1 1751 1756 2 ND2P $T=307520 689360 0 0 $X=307520 $Y=688980
X2912 1800 1 1804 1785 2 ND2P $T=314340 598640 0 0 $X=314340 $Y=598260
X2913 1505 1 1744 1825 2 ND2P $T=320540 598640 0 180 $X=316820 $Y=593220
X2914 1820 1 1788 1849 2 ND2P $T=324260 649040 1 180 $X=320540 $Y=648660
X2915 1834 1 1814 1866 2 ND2P $T=325500 679280 1 0 $X=325500 $Y=673860
X2916 1937 1 1945 1795 2 ND2P $T=347200 618800 1 0 $X=347200 $Y=613380
X2917 1908 1 1930 1943 2 ND2P $T=353400 649040 1 180 $X=349680 $Y=648660
X2918 333 1 1981 1970 2 ND2P $T=356500 659120 0 0 $X=356500 $Y=658740
X2919 2060 1 2081 2092 2 ND2P $T=379440 649040 0 0 $X=379440 $Y=648660
X2920 2114 1 2092 357 2 ND2P $T=388120 669200 1 0 $X=388120 $Y=663780
X2921 2134 1 2141 2129 2 ND2P $T=391840 669200 0 0 $X=391840 $Y=668820
X2922 384 1 389 2131 2 ND2P $T=402380 659120 1 0 $X=402380 $Y=653700
X2923 394 1 2191 2159 2 ND2P $T=409200 659120 1 180 $X=405480 $Y=658740
X2924 2903 1 3588 277 2 ND2P $T=703080 538160 0 180 $X=699360 $Y=532740
X2925 4077 1 4068 4050 2 ND2P $T=772520 578480 1 0 $X=772520 $Y=573060
X2926 4544 1 4558 4550 2 ND2P $T=872340 507920 0 0 $X=872340 $Y=507540
X2927 1079 1 4558 4542 2 ND2P $T=877300 518000 1 0 $X=877300 $Y=512580
X2928 4573 1 4559 4568 2 ND2P $T=882880 558320 0 180 $X=879160 $Y=552900
X2929 4774 1 4745 4778 2 ND2P $T=923180 608720 1 180 $X=919460 $Y=608340
X2930 4769 1 4745 4783 2 ND2P $T=928760 618800 0 180 $X=925040 $Y=613380
X2931 4866 1 4878 4884 2 ND2P $T=950460 528080 0 180 $X=946740 $Y=522660
X2932 1158 1 4878 4897 2 ND2P $T=951080 518000 1 180 $X=947360 $Y=517620
X2933 4895 1 4904 4899 2 ND2P $T=950460 638960 1 0 $X=950460 $Y=633540
X2934 4917 1 4904 4914 2 ND2P $T=955420 638960 1 0 $X=955420 $Y=633540
X2935 4975 1 4999 4984 2 ND2P $T=971540 638960 1 0 $X=971540 $Y=633540
X2936 4996 1 4999 4973 2 ND2P $T=976500 638960 1 0 $X=976500 $Y=633540
X2937 1202 1 5044 5040 2 ND2P $T=983320 538160 1 0 $X=983320 $Y=532740
X2938 5020 1 5044 5021 2 ND2P $T=987660 538160 1 0 $X=987660 $Y=532740
X2939 5085 1 5051 5087 2 ND2P $T=995100 628880 1 0 $X=995100 $Y=623460
X2940 5119 1 5123 5092 2 ND2P $T=1003780 618800 0 180 $X=1000060 $Y=613380
X2941 5112 1 5123 5099 2 ND2P $T=1003780 618800 1 0 $X=1003780 $Y=613380
X2942 1221 1 5164 5171 2 ND2P $T=1012460 528080 1 180 $X=1008740 $Y=527700
X2943 4918 1 5162 5168 2 ND2P $T=1009980 558320 1 0 $X=1009980 $Y=552900
X2944 5154 1 5164 5181 2 ND2P $T=1015560 538160 0 180 $X=1011840 $Y=532740
X2945 1228 1 5218 5223 2 ND2P $T=1018660 528080 1 0 $X=1018660 $Y=522660
X2946 5205 1 5218 5243 2 ND2P $T=1021760 528080 0 0 $X=1021760 $Y=527700
X2947 5201 1 5170 5250 2 ND2P $T=1022380 598640 0 0 $X=1022380 $Y=598260
X2948 5194 1 5237 5226 2 ND2P $T=1022380 638960 1 0 $X=1022380 $Y=633540
X2949 5213 1 5170 5256 2 ND2P $T=1023620 598640 1 0 $X=1023620 $Y=593220
X2950 5193 1 5237 5206 2 ND2P $T=1029200 638960 1 0 $X=1029200 $Y=633540
X2951 5287 1 5320 5327 2 ND2P $T=1044700 638960 0 180 $X=1040980 $Y=633540
X2952 5342 1 5343 5324 2 ND2P $T=1045940 528080 1 0 $X=1045940 $Y=522660
X2953 5331 1 5325 5354 2 ND2P $T=1050280 507920 1 180 $X=1046560 $Y=507540
X2954 5391 1 5398 5330 2 ND2P $T=1057720 628880 0 0 $X=1057720 $Y=628500
X2955 5391 1 5404 5334 2 ND2P $T=1060200 638960 1 0 $X=1060200 $Y=633540
X2956 5396 1 5411 5418 2 ND2P $T=1065160 608720 1 180 $X=1061440 $Y=608340
X2957 5389 1 5411 5421 2 ND2P $T=1065160 618800 0 180 $X=1061440 $Y=613380
X2958 5398 1 5404 5336 2 ND2P $T=1061440 628880 0 0 $X=1061440 $Y=628500
X2959 5347 1 5417 5410 2 ND2P $T=1067020 608720 0 180 $X=1063300 $Y=603300
X2960 5489 1 5477 5494 2 ND2P $T=1089960 598640 0 180 $X=1086240 $Y=593220
X2961 1274 1 5483 5491 2 ND2P $T=1091200 538160 1 180 $X=1087480 $Y=537780
X2962 5427 1 5477 5496 2 ND2P $T=1094920 588560 1 180 $X=1091200 $Y=588180
X2963 386 1 2152 2165 2 ND2T $T=399280 689360 0 0 $X=399280 $Y=688980
X2964 2165 1 388 362 2 ND2T $T=399280 699440 1 0 $X=399280 $Y=694020
X2965 5073 1 5106 5078 2 ND2T $T=996960 528080 0 0 $X=996960 $Y=527700
X2966 5140 1 5144 5115 2 ND2T $T=1001920 528080 0 0 $X=1001920 $Y=527700
X2967 1220 1 5144 5111 2 ND2T $T=1006880 538160 1 0 $X=1006880 $Y=532740
X2968 5192 1 5178 5188 2 ND2T $T=1015560 568400 1 0 $X=1015560 $Y=562980
X2969 1471 1379 1486 2 1 1470 XNR3 $T=249240 598640 0 0 $X=249240 $Y=598260
X2970 1735 1738 1781 2 1 1734 XNR3 $T=298840 608720 0 0 $X=298840 $Y=608340
X2971 2129 364 362 2 1 358 XNR3 $T=391220 689360 0 180 $X=380060 $Y=683940
X2972 4591 4569 4620 2 1 4587 XNR3 $T=881640 588560 0 0 $X=881640 $Y=588180
X2973 4670 4676 4607 2 1 4664 XNR3 $T=898380 538160 0 0 $X=898380 $Y=537780
X2974 4702 4705 4675 2 1 4746 XNR3 $T=905200 548240 1 0 $X=905200 $Y=542820
X2975 1123 1118 1116 2 1 4735 XNR3 $T=912640 507920 1 0 $X=912640 $Y=502500
X2976 1168 4915 4928 2 1 4935 XNR3 $T=953560 538160 1 0 $X=953560 $Y=532740
X2977 1220 5140 5144 2 1 5185 XNR3 $T=1003780 538160 0 0 $X=1003780 $Y=537780
X2978 1228 5205 5218 2 1 5199 XNR3 $T=1022380 528080 1 0 $X=1022380 $Y=522660
X2979 1264 5431 5462 2 1 5482 XNR3 $T=1082520 507920 0 0 $X=1082520 $Y=507540
X2980 1336 1297 1 2 INV2 $T=227540 628880 0 180 $X=225680 $Y=623460
X2981 1346 1334 1 2 INV2 $T=230020 608720 0 180 $X=228160 $Y=603300
X2982 1373 1303 1 2 INV2 $T=231880 608720 1 180 $X=230020 $Y=608340
X2983 1342 1371 1 2 INV2 $T=231880 598640 1 0 $X=231880 $Y=593220
X2984 1359 31 1 2 INV2 $T=234980 608720 1 180 $X=233120 $Y=608340
X2985 1392 1381 1 2 INV2 $T=236840 679280 1 180 $X=234980 $Y=678900
X2986 1432 26 1 2 INV2 $T=237460 588560 0 180 $X=235600 $Y=583140
X2987 1396 1343 1 2 INV2 $T=237460 659120 0 180 $X=235600 $Y=653700
X2988 63 50 1 2 INV2 $T=236840 669200 1 0 $X=236840 $Y=663780
X2989 1393 1399 1 2 INV2 $T=238080 598640 0 0 $X=238080 $Y=598260
X2990 1406 1419 1 2 INV2 $T=239320 669200 1 0 $X=239320 $Y=663780
X2991 1422 81 1 2 INV2 $T=242420 638960 1 180 $X=240560 $Y=638580
X2992 1470 1505 1 2 INV2 $T=249240 598640 1 0 $X=249240 $Y=593220
X2993 1428 1488 1 2 INV2 $T=249860 649040 0 0 $X=249860 $Y=648660
X2994 1535 151 1 2 INV2 $T=261020 588560 0 0 $X=261020 $Y=588180
X2995 1557 1532 1 2 INV2 $T=263500 618800 0 0 $X=263500 $Y=618420
X2996 1612 128 1 2 INV2 $T=275280 618800 0 180 $X=273420 $Y=613380
X2997 1599 1608 1 2 INV2 $T=276520 618800 0 0 $X=276520 $Y=618420
X2998 128 121 1 2 INV2 $T=276520 628880 1 0 $X=276520 $Y=623460
X2999 1646 1628 1 2 INV2 $T=281480 669200 0 180 $X=279620 $Y=663780
X3000 1660 1705 1 2 INV2 $T=290780 638960 1 0 $X=290780 $Y=633540
X3001 1734 1669 1 2 INV2 $T=298840 608720 1 0 $X=298840 $Y=603300
X3002 250 283 1 2 INV2 $T=332320 679280 0 0 $X=332320 $Y=678900
X3003 1951 1382 1 2 INV2 $T=345960 618800 1 180 $X=344100 $Y=618420
X3004 1933 1938 1 2 INV2 $T=346580 659120 1 0 $X=346580 $Y=653700
X3005 1920 1935 1 2 INV2 $T=347820 638960 0 0 $X=347820 $Y=638580
X3006 1980 1984 1 2 INV2 $T=355880 649040 1 0 $X=355880 $Y=643620
X3007 1925 2000 1 2 INV2 $T=358360 628880 1 0 $X=358360 $Y=623460
X3008 1971 2001 1 2 INV2 $T=358360 628880 0 0 $X=358360 $Y=628500
X3009 356 1726 1 2 INV2 $T=376960 649040 0 180 $X=375100 $Y=643620
X3010 2082 2075 1 2 INV2 $T=380680 659120 0 180 $X=378820 $Y=653700
X3011 2117 2128 1 2 INV2 $T=388740 649040 0 0 $X=388740 $Y=648660
X3012 2098 2136 1 2 INV2 $T=392460 659120 0 180 $X=390600 $Y=653700
X3013 2137 2155 1 2 INV2 $T=399280 649040 1 180 $X=397420 $Y=648660
X3014 2063 2137 1 2 INV2 $T=402380 649040 0 0 $X=402380 $Y=648660
X3015 368 391 1 2 INV2 $T=407340 638960 1 180 $X=405480 $Y=638580
X3016 396 386 1 2 INV2 $T=411680 699440 1 0 $X=411680 $Y=694020
X3017 356 405 1 2 INV2 $T=419740 659120 1 0 $X=419740 $Y=653700
X3018 2274 2269 1 2 INV2 $T=425940 638960 1 0 $X=425940 $Y=633540
X3019 389 2066 1 2 INV2 $T=430280 669200 0 180 $X=428420 $Y=663780
X3020 2312 2080 1 2 INV2 $T=436480 669200 1 0 $X=436480 $Y=663780
X3021 435 2050 1 2 INV2 $T=451980 689360 1 0 $X=451980 $Y=683940
X3022 468 394 1 2 INV2 $T=479880 659120 0 180 $X=478020 $Y=653700
X3023 2533 384 1 2 INV2 $T=479260 649040 1 0 $X=479260 $Y=643620
X3024 483 1723 1 2 INV2 $T=494760 608720 0 0 $X=494760 $Y=608340
X3025 2958 2847 1 2 INV2 $T=550560 578480 1 0 $X=550560 $Y=573060
X3026 2718 2691 1 2 INV2 $T=558000 598640 1 0 $X=558000 $Y=593220
X3027 3362 757 1 2 INV2 $T=611320 507920 1 180 $X=609460 $Y=507540
X3028 2903 629 1 2 INV2 $T=612560 507920 0 0 $X=612560 $Y=507540
X3029 3467 225 1 2 INV2 $T=630540 548240 1 0 $X=630540 $Y=542820
X3030 755 816 1 2 INV2 $T=644800 608720 0 0 $X=644800 $Y=608340
X3031 3403 860 1 2 INV2 $T=666500 528080 0 0 $X=666500 $Y=527700
X3032 3662 868 1 2 INV2 $T=682000 689360 1 0 $X=682000 $Y=683940
X3033 3662 884 1 2 INV2 $T=682620 679280 0 0 $X=682620 $Y=678900
X3034 3588 3690 1 2 INV2 $T=688820 538160 0 180 $X=686960 $Y=532740
X3035 909 3674 1 2 INV2 $T=706180 507920 1 0 $X=706180 $Y=502500
X3036 3362 918 1 2 INV2 $T=709900 518000 0 0 $X=709900 $Y=517620
X3037 3523 919 1 2 INV2 $T=713000 518000 1 0 $X=713000 $Y=512580
X3038 924 3565 1 2 INV2 $T=715480 659120 0 180 $X=713620 $Y=653700
X3039 4337 3978 1 2 INV2 $T=823980 608720 0 0 $X=823980 $Y=608340
X3040 4363 3711 1 2 INV2 $T=828320 638960 1 180 $X=826460 $Y=638580
X3041 4367 3724 1 2 INV2 $T=828320 649040 0 180 $X=826460 $Y=643620
X3042 483 1072 1 2 INV2 $T=865520 507920 1 0 $X=865520 $Y=502500
X3043 4532 4511 1 2 INV2 $T=868620 538160 0 0 $X=868620 $Y=537780
X3044 4520 4501 1 2 INV2 $T=876680 548240 0 0 $X=876680 $Y=547860
X3045 4586 4574 1 2 INV2 $T=880400 548240 1 0 $X=880400 $Y=542820
X3046 1130 4727 1 2 INV2 $T=913260 507920 1 180 $X=911400 $Y=507540
X3047 4735 4736 1 2 INV2 $T=912640 497840 0 0 $X=912640 $Y=497460
X3048 4746 4747 1 2 INV2 $T=921940 538160 0 0 $X=921940 $Y=537780
X3049 1138 4775 1 2 INV2 $T=925040 497840 0 0 $X=925040 $Y=497460
X3050 1163 4573 1 2 INV2 $T=947360 568400 0 180 $X=945500 $Y=562980
X3051 4935 4917 1 2 INV2 $T=957280 548240 0 180 $X=955420 $Y=542820
X3052 356 1216 1 2 INV2 $T=996960 507920 1 0 $X=996960 $Y=502500
X3053 5088 5141 1 2 INV2 $T=1001920 568400 1 0 $X=1001920 $Y=562980
X3054 1029 4918 1 2 INV2 $T=1008740 558320 0 180 $X=1006880 $Y=552900
X3055 5185 5166 1 2 INV2 $T=1012460 548240 0 180 $X=1010600 $Y=542820
X3056 5199 5201 1 2 INV2 $T=1016800 528080 1 0 $X=1016800 $Y=522660
X3057 5220 5230 1 2 INV2 $T=1020520 558320 1 0 $X=1020520 $Y=552900
X3058 1144 1147 1 2 INV2 $T=1025480 518000 1 0 $X=1025480 $Y=512580
X3059 5212 5229 1 2 INV2 $T=1027340 568400 0 180 $X=1025480 $Y=562980
X3060 5203 5282 1 2 INV2 $T=1029200 568400 1 0 $X=1029200 $Y=562980
X3061 5238 5344 1 2 INV2 $T=1047800 568400 1 0 $X=1047800 $Y=562980
X3062 5381 5402 1 2 INV2 $T=1062060 558320 1 0 $X=1062060 $Y=552900
X3063 5482 5489 1 2 INV2 $T=1082520 518000 1 0 $X=1082520 $Y=512580
X3064 1388 50 17 1419 1 2 MXL2H $T=237460 649040 1 0 $X=237460 $Y=643620
X3065 2205 2177 2063 2269 1 2 MXL2H $T=415400 628880 1 0 $X=415400 $Y=623460
X3066 885 3690 3709 3724 1 2 MXL2H $T=686960 528080 0 0 $X=686960 $Y=527700
X3067 2068 2 2053 2059 1 AN2B1S $T=376960 669200 0 0 $X=376960 $Y=668820
X3068 2083 2 2082 2085 1 AN2B1S $T=385020 659120 0 180 $X=381920 $Y=653700
X3069 2140 2 2156 2179 1 AN2B1S $T=398660 679280 1 0 $X=398660 $Y=673860
X3070 682 2 3237 3287 1 AN2B1S $T=594580 548240 0 0 $X=594580 $Y=547860
X3071 3331 2 3330 3353 1 AN2B1S $T=610080 558320 0 0 $X=610080 $Y=557940
X3072 5307 2 5233 5338 1 AN2B1S $T=1041600 568400 0 0 $X=1041600 $Y=568020
X3073 43 26 1 1360 2 AN2S $T=230020 638960 1 0 $X=230020 $Y=633540
X3074 54 26 1 1364 2 AN2S $T=234980 649040 1 0 $X=234980 $Y=643620
X3075 1568 1565 1 1585 2 AN2S $T=273420 638960 0 180 $X=270940 $Y=633540
X3076 1653 1673 1 1661 2 AN2S $T=285200 649040 0 180 $X=282720 $Y=643620
X3077 1740 236 1 1746 2 AN2S $T=301320 628880 1 0 $X=301320 $Y=623460
X3078 1827 236 1 1858 2 AN2S $T=321780 638960 1 0 $X=321780 $Y=633540
X3079 1848 236 1 1853 2 AN2S $T=330460 628880 1 0 $X=330460 $Y=623460
X3080 1873 236 1 1890 2 AN2S $T=332320 598640 1 0 $X=332320 $Y=593220
X3081 1865 236 1 1872 2 AN2S $T=332320 618800 0 0 $X=332320 $Y=618420
X3082 1931 283 1 1948 2 AN2S $T=346580 638960 1 0 $X=346580 $Y=633540
X3083 2001 2000 1 1969 2 AN2S $T=363320 628880 0 180 $X=360840 $Y=623460
X3084 2053 2050 1 2062 2 AN2S $T=373860 659120 0 0 $X=373860 $Y=658740
X3085 2075 2083 1 2068 2 AN2S $T=380680 659120 1 180 $X=378200 $Y=658740
X3086 4539 4556 1 4510 2 AN2S $T=871100 548240 0 180 $X=868620 $Y=542820
X3087 4357 4573 1 4579 2 AN2S $T=876680 558320 0 0 $X=876680 $Y=557940
X3088 4415 4573 1 4615 2 AN2S $T=882260 558320 0 0 $X=882260 $Y=557940
X3089 4694 4474 1 4651 2 AN2S $T=903960 588560 0 180 $X=901480 $Y=583140
X3090 1119 1115 1 4701 2 AN2S $T=909540 497840 1 180 $X=907060 $Y=497460
X3091 5128 5053 1 5147 2 AN2S $T=1003160 548240 0 0 $X=1003160 $Y=547860
X3092 5302 4798 1 5326 2 AN2S $T=1039120 548240 1 0 $X=1039120 $Y=542820
X3093 5371 4798 1 5363 2 AN2S $T=1054620 548240 0 0 $X=1054620 $Y=547860
X3094 2502 455 1 2 INV8CK $T=471200 699440 0 180 $X=464380 $Y=694020
X3095 465 2757 1 2 INV8CK $T=516460 679280 0 0 $X=516460 $Y=678900
X3096 3295 726 1 2 INV8CK $T=597680 618800 0 0 $X=597680 $Y=618420
X3097 3321 3278 1 2 INV8CK $T=603880 538160 1 0 $X=603880 $Y=532740
X3098 3024 328 1 2 BUF2CK $T=559240 548240 1 0 $X=559240 $Y=542820
X3099 383 703 1 2 BUF2CK $T=582800 588560 0 0 $X=582800 $Y=588180
X3100 631 3404 1 2 BUF2CK $T=616900 568400 1 0 $X=616900 $Y=562980
X3101 816 634 1 2 BUF2CK $T=642940 598640 1 180 $X=639840 $Y=598260
X3102 703 3876 1 2 BUF2CK $T=727260 588560 0 0 $X=727260 $Y=588180
X3103 4085 1150 1 2 BUF2CK $T=945500 638960 0 0 $X=945500 $Y=638580
X3104 2502 264 1 2 INV12CK $T=523900 578480 0 180 $X=513980 $Y=573060
X3105 580 2502 1 2 INV12CK $T=530100 689360 0 0 $X=530100 $Y=688980
X3106 615 465 1 2 INV12CK $T=542500 558320 0 180 $X=532580 $Y=552900
X3107 2844 665 1 2 INV12CK $T=557380 659120 0 0 $X=557380 $Y=658740
X3108 870 3385 1 2 INV12CK $T=673940 538160 0 0 $X=673940 $Y=537780
X3109 665 870 1 2 INV12CK $T=683240 558320 0 0 $X=683240 $Y=557940
X3110 3971 231 1 2 INV12CK $T=753920 588560 0 0 $X=753920 $Y=588180
X3111 870 1134 1 2 INV12CK $T=921940 558320 0 0 $X=921940 $Y=557940
X3112 1990 345 347 348 1997 350 1 2 2061 AO222 $T=370140 507920 1 0 $X=370140 $Y=502500
X3113 2071 345 347 2079 2077 350 1 2 2090 AO222 $T=378200 507920 1 0 $X=378200 $Y=502500
X3114 2229 345 347 2232 2249 350 1 2 2255 AO222 $T=414780 507920 1 0 $X=414780 $Y=502500
X3115 514 508 507 504 500 499 1 2 2688 AO222 $T=513980 608720 0 180 $X=507780 $Y=603300
X3116 2672 2655 502 2702 2708 2715 1 2 2635 AO222 $T=508400 618800 0 0 $X=508400 $Y=618420
X3117 525 508 507 533 539 499 1 2 2776 AO222 $T=517080 598640 1 0 $X=517080 $Y=593220
X3118 573 586 3216 3465 3449 3473 1 2 3495 AO222 $T=633020 659120 1 0 $X=633020 $Y=653700
X3119 1296 1 5 1310 2 9 ND3 $T=221340 528080 1 0 $X=221340 $Y=522660
X3120 1295 1 1327 1325 2 20 ND3 $T=224440 528080 1 0 $X=224440 $Y=522660
X3121 1317 1 25 1340 2 34 ND3 $T=226300 538160 1 0 $X=226300 $Y=532740
X3122 41 1 37 1315 2 28 ND3 $T=230640 518000 1 180 $X=228160 $Y=517620
X3123 1378 1 1384 1339 2 1358 ND3 $T=233740 528080 0 180 $X=231260 $Y=522660
X3124 1385 1 34 1395 2 37 ND3 $T=237460 528080 1 180 $X=234980 $Y=527700
X3125 1427 1 67 77 2 1384 ND3 $T=242420 507920 1 180 $X=239940 $Y=507540
X3126 96 1 1423 1424 2 83 ND3 $T=244280 528080 1 180 $X=241800 $Y=527700
X3127 1449 1 82 1388 2 1444 ND3 $T=247380 659120 1 180 $X=244900 $Y=658740
X3128 1472 1 101 1452 2 19 ND3 $T=248000 497840 1 180 $X=245520 $Y=497460
X3129 1499 1 1409 1461 2 113 ND3 $T=254200 518000 1 180 $X=251720 $Y=517620
X3130 1528 1 133 1501 2 1544 ND3 $T=259780 518000 0 0 $X=259780 $Y=517620
X3131 1543 1 137 1575 2 1563 ND3 $T=262260 518000 1 0 $X=262260 $Y=512580
X3132 1564 1 1549 1404 2 1576 ND3 $T=264120 538160 1 0 $X=264120 $Y=532740
X3133 41 1 146 1577 2 156 ND3 $T=266600 518000 0 0 $X=266600 $Y=517620
X3134 1600 1 1598 1595 2 157 ND3 $T=272180 518000 0 180 $X=269700 $Y=512580
X3135 1606 1 80 1350 2 1358 ND3 $T=273420 548240 1 180 $X=270940 $Y=547860
X3136 181 1 177 1508 2 1549 ND3 $T=274660 538160 1 180 $X=272180 $Y=537780
X3137 67 1 166 1587 2 148 ND3 $T=274660 548240 0 180 $X=272180 $Y=542820
X3138 1630 1 166 1457 2 148 ND3 $T=276520 548240 1 180 $X=274040 $Y=547860
X3139 1632 1 1620 1559 2 1414 ND3 $T=277140 558320 0 180 $X=274660 $Y=552900
X3140 182 1 177 1483 2 1609 ND3 $T=278380 538160 0 180 $X=275900 $Y=532740
X3141 1642 1 1385 178 2 161 ND3 $T=278380 548240 0 180 $X=275900 $Y=542820
X3142 184 1 172 1623 2 1385 ND3 $T=279000 507920 1 180 $X=276520 $Y=507540
X3143 1648 1 111 1482 2 1426 ND3 $T=281480 548240 1 180 $X=279000 $Y=547860
X3144 1620 1 1645 1624 2 1637 ND3 $T=282100 538160 0 180 $X=279620 $Y=532740
X3145 1653 1 200 1616 2 1673 ND3 $T=284580 649040 0 0 $X=284580 $Y=648660
X3146 1700 1 143 208 2 1355 ND3 $T=291400 497840 1 180 $X=288920 $Y=497460
X3147 212 1 1701 1697 2 206 ND3 $T=292020 528080 0 180 $X=289540 $Y=522660
X3148 1689 1 182 1593 2 1706 ND3 $T=289540 538160 0 0 $X=289540 $Y=537780
X3149 41 1 158 1724 2 184 ND3 $T=292640 507920 0 0 $X=292640 $Y=507540
X3150 1385 1 34 1725 2 158 ND3 $T=292640 538160 0 0 $X=292640 $Y=537780
X3151 1497 1 1715 1731 2 189 ND3 $T=296360 538160 1 0 $X=296360 $Y=532740
X3152 242 1 239 245 2 155 ND3 $T=303180 497840 1 180 $X=300700 $Y=497460
X3153 1773 1 1609 1776 2 1790 ND3 $T=312480 528080 0 180 $X=310000 $Y=522660
X3154 1793 1 37 1748 2 146 ND3 $T=314340 518000 0 180 $X=311860 $Y=512580
X3155 1773 1 1793 1798 2 28 ND3 $T=314340 548240 0 180 $X=311860 $Y=542820
X3156 181 1 62 1826 2 1537 ND3 $T=316820 538160 1 0 $X=316820 $Y=532740
X3157 1715 1 34 1797 2 37 ND3 $T=321160 538160 1 180 $X=318680 $Y=537780
X3158 1815 1 1770 272 2 1829 ND3 $T=319300 507920 0 0 $X=319300 $Y=507540
X3159 130 1 172 1863 2 34 ND3 $T=323640 497840 0 0 $X=323640 $Y=497460
X3160 1609 1 120 1809 2 1774 ND3 $T=326740 548240 1 180 $X=324260 $Y=547860
X3161 1589 1 40 1861 2 1715 ND3 $T=329840 528080 0 180 $X=327360 $Y=522660
X3162 285 1 288 209 2 284 ND3 $T=335420 497840 1 180 $X=332940 $Y=497460
X3163 289 1 288 40 2 285 ND3 $T=336040 518000 0 180 $X=333560 $Y=512580
X3164 1609 1 210 1880 2 148 ND3 $T=333560 528080 0 0 $X=333560 $Y=527700
X3165 294 1 291 177 2 289 ND3 $T=337900 507920 0 180 $X=335420 $Y=502500
X3166 1877 1 291 1537 2 296 ND3 $T=335420 518000 0 0 $X=335420 $Y=517620
X3167 1877 1 291 1385 2 299 ND3 $T=337280 528080 1 0 $X=337280 $Y=522660
X3168 1914 1 1903 1885 2 1896 ND3 $T=339760 628880 0 180 $X=337280 $Y=623460
X3169 1877 1 298 166 2 299 ND3 $T=338520 507920 1 0 $X=338520 $Y=502500
X3170 294 1 298 148 2 289 ND3 $T=343480 497840 1 180 $X=341000 $Y=497460
X3171 1956 1 319 1950 2 316 ND3 $T=351540 518000 0 180 $X=349060 $Y=512580
X3172 323 1 1950 1550 2 304 ND3 $T=351540 518000 1 180 $X=349060 $Y=517620
X3173 2215 1 394 2194 2 2223 ND3 $T=412300 649040 0 0 $X=412300 $Y=648660
X3174 2115 1 2326 417 2 2333 ND3 $T=434620 538160 1 0 $X=434620 $Y=532740
X3175 2021 1 2311 418 2 2347 ND3 $T=435860 558320 1 0 $X=435860 $Y=552900
X3176 1989 1 2340 422 2 2353 ND3 $T=436480 588560 1 0 $X=436480 $Y=583140
X3177 2135 1 2339 419 2 2354 ND3 $T=436480 588560 0 0 $X=436480 $Y=588180
X3178 2197 1 2341 420 2 2328 ND3 $T=436480 608720 0 0 $X=436480 $Y=608340
X3179 2268 1 2364 424 2 2376 ND3 $T=439580 618800 1 0 $X=439580 $Y=613380
X3180 2038 1 2357 426 2 2394 ND3 $T=442680 528080 0 0 $X=442680 $Y=527700
X3181 1982 1 2356 433 2 2409 ND3 $T=444540 568400 0 0 $X=444540 $Y=568020
X3182 2003 1 2392 439 2 2425 ND3 $T=450740 568400 1 0 $X=450740 $Y=562980
X3183 2251 1 2453 447 2 2460 ND3 $T=458800 608720 0 0 $X=458800 $Y=608340
X3184 2367 1 452 453 2 2479 ND3 $T=464380 497840 0 0 $X=464380 $Y=497460
X3185 2272 1 2494 2493 2 2501 ND3 $T=468720 578480 1 0 $X=468720 $Y=573060
X3186 2091 1 2508 462 2 2525 ND3 $T=470580 608720 0 0 $X=470580 $Y=608340
X3187 2010 1 2510 461 2 2515 ND3 $T=471200 538160 0 0 $X=471200 $Y=537780
X3188 2258 1 2513 2524 2 2523 ND3 $T=471820 568400 1 0 $X=471820 $Y=562980
X3189 2036 1 2517 463 2 2520 ND3 $T=474920 538160 0 180 $X=472440 $Y=532740
X3190 2227 1 2558 2560 2 2488 ND3 $T=482980 568400 1 0 $X=482980 $Y=562980
X3191 2044 1 2567 475 2 2538 ND3 $T=484840 588560 1 0 $X=484840 $Y=583140
X3192 2151 1 2580 477 2 2583 ND3 $T=487320 608720 0 0 $X=487320 $Y=608340
X3193 2283 1 2600 482 2 2561 ND3 $T=491040 598640 1 0 $X=491040 $Y=593220
X3194 2207 1 2609 484 2 2628 ND3 $T=492900 528080 0 0 $X=492900 $Y=527700
X3195 2157 1 2622 485 2 2624 ND3 $T=495380 548240 0 0 $X=495380 $Y=547860
X3196 380 1 2640 487 2 2611 ND3 $T=501580 497840 1 180 $X=499100 $Y=497460
X3197 323 1 2642 2644 2 2652 ND3 $T=499720 618800 0 0 $X=499720 $Y=618420
X3198 2099 1 2647 493 2 478 ND3 $T=501580 497840 0 0 $X=501580 $Y=497460
X3199 2265 1 2650 2607 2 2599 ND3 $T=504060 538160 1 180 $X=501580 $Y=537780
X3200 2674 1 2677 497 2 2697 ND3 $T=507780 659120 1 0 $X=507780 $Y=653700
X3201 2674 1 2642 495 2 2697 ND3 $T=507780 669200 1 0 $X=507780 $Y=663780
X3202 2686 1 2705 505 2 2714 ND3 $T=510260 689360 0 0 $X=510260 $Y=688980
X3203 2674 1 2642 510 2 2672 ND3 $T=511500 669200 1 0 $X=511500 $Y=663780
X3204 2713 1 2642 512 2 2652 ND3 $T=514600 659120 0 0 $X=514600 $Y=658740
X3205 2735 1 2738 2740 2 2745 ND3 $T=516460 608720 0 0 $X=516460 $Y=608340
X3206 2746 1 2740 2659 2 2731 ND3 $T=518940 618800 1 180 $X=516460 $Y=618420
X3207 2697 1 2739 524 2 2718 ND3 $T=516460 669200 0 0 $X=516460 $Y=668820
X3208 2672 1 2691 526 2 2739 ND3 $T=516460 679280 1 0 $X=516460 $Y=673860
X3209 2718 1 2739 531 2 2672 ND3 $T=522040 669200 1 180 $X=519560 $Y=668820
X3210 2713 1 2677 565 2 2700 ND3 $T=522040 659120 0 0 $X=522040 $Y=658740
X3211 2792 1 2715 2731 2 2671 ND3 $T=525760 618800 0 180 $X=523280 $Y=613380
X3212 2779 1 2778 2795 2 2696 ND3 $T=524520 638960 1 0 $X=524520 $Y=633540
X3213 2779 1 2778 544 2 319 ND3 $T=524520 649040 0 0 $X=524520 $Y=648660
X3214 2797 1 2778 553 2 319 ND3 $T=527000 649040 1 0 $X=527000 $Y=643620
X3215 2823 1 2820 2637 2 2809 ND3 $T=530720 638960 0 180 $X=528240 $Y=633540
X3216 323 1 2855 2669 2 2847 ND3 $T=531960 598640 0 0 $X=531960 $Y=598260
X3217 2825 1 2703 2685 2 2853 ND3 $T=537540 507920 1 180 $X=535060 $Y=507540
X3218 2862 1 319 2855 2 316 ND3 $T=537540 598640 1 180 $X=535060 $Y=598260
X3219 2863 1 523 2835 2 2729 ND3 $T=537540 608720 1 180 $X=535060 $Y=608340
X3220 2859 1 2668 2662 2 2825 ND3 $T=538160 518000 1 180 $X=535680 $Y=517620
X3221 2787 1 2729 608 2 2784 ND3 $T=536300 638960 1 0 $X=536300 $Y=633540
X3222 2787 1 2729 593 2 2870 ND3 $T=536300 638960 0 0 $X=536300 $Y=638580
X3223 2873 1 2696 589 2 2908 ND3 $T=539400 628880 0 0 $X=539400 $Y=628500
X3224 2848 1 2881 2902 2 2871 ND3 $T=539400 669200 1 0 $X=539400 $Y=663780
X3225 2873 1 2696 2892 2 2870 ND3 $T=540020 628880 1 0 $X=540020 $Y=623460
X3226 2761 1 2729 613 2 2870 ND3 $T=540020 638960 1 0 $X=540020 $Y=633540
X3227 2873 1 2870 520 2 319 ND3 $T=540640 638960 0 0 $X=540640 $Y=638580
X3228 551 1 592 2913 2 527 ND3 $T=540640 689360 1 0 $X=540640 $Y=683940
X3229 2883 1 2893 2895 2 619 ND3 $T=540640 699440 1 0 $X=540640 $Y=694020
X3230 2928 1 2912 2591 2 2922 ND3 $T=543120 649040 0 0 $X=543120 $Y=648660
X3231 2924 1 2900 2719 2 2897 ND3 $T=545600 679280 0 180 $X=543120 $Y=673860
X3232 2908 1 2729 626 2 2761 ND3 $T=546840 638960 0 180 $X=544360 $Y=633540
X3233 2873 1 319 596 2 2908 ND3 $T=544360 649040 1 0 $X=544360 $Y=643620
X3234 646 1 2932 649 2 3001 ND3 $T=554280 679280 0 0 $X=554280 $Y=678900
X3235 3002 1 651 3016 2 2812 ND3 $T=556760 689360 0 0 $X=556760 $Y=688980
X3236 3062 1 3011 2673 2 3015 ND3 $T=560480 679280 1 180 $X=558000 $Y=678900
X3237 3050 1 3053 2983 2 3040 ND3 $T=562960 659120 0 180 $X=560480 $Y=653700
X3238 3036 1 2920 3124 2 3071 ND3 $T=561100 608720 0 0 $X=561100 $Y=608340
X3239 3066 1 3051 2704 2 3041 ND3 $T=563580 679280 1 180 $X=561100 $Y=678900
X3240 2951 1 2990 3052 2 3090 ND3 $T=562960 679280 1 0 $X=562960 $Y=673860
X3241 3129 1 2941 3003 2 2971 ND3 $T=571640 538160 1 180 $X=569160 $Y=537780
X3242 2995 1 2952 3130 2 3077 ND3 $T=571020 548240 1 0 $X=571020 $Y=542820
X3243 3095 1 2947 3172 2 3020 ND3 $T=576600 598640 1 0 $X=576600 $Y=593220
X3244 3176 1 3022 3167 2 3107 ND3 $T=579080 598640 1 180 $X=576600 $Y=598260
X3245 3090 1 3135 3175 2 2996 ND3 $T=576600 659120 0 0 $X=576600 $Y=658740
X3246 699 1 571 3184 2 692 ND3 $T=582180 679280 1 180 $X=579700 $Y=678900
X3247 3072 1 674 697 2 3196 ND3 $T=580320 507920 1 0 $X=580320 $Y=502500
X3248 3188 1 698 2658 2 3209 ND3 $T=580940 649040 0 0 $X=580940 $Y=648660
X3249 3164 1 3177 3212 2 3206 ND3 $T=581560 538160 0 0 $X=581560 $Y=537780
X3250 3072 1 674 3179 2 3214 ND3 $T=582800 507920 1 0 $X=582800 $Y=502500
X3251 3248 1 3178 3242 2 3107 ND3 $T=590860 598640 0 180 $X=588380 $Y=593220
X3252 2923 1 3236 3257 2 2970 ND3 $T=593340 659120 0 180 $X=590860 $Y=653700
X3253 3272 1 3265 2964 2 3224 ND3 $T=595200 649040 1 180 $X=592720 $Y=648660
X3254 3275 1 3269 3251 2 3260 ND3 $T=595820 568400 0 180 $X=593340 $Y=562980
X3255 3176 1 3266 3261 2 3178 ND3 $T=593340 608720 0 0 $X=593340 $Y=608340
X3256 3289 1 3022 2999 2 3131 ND3 $T=597680 598640 0 180 $X=595200 $Y=593220
X3257 3273 1 3178 3290 2 3107 ND3 $T=598300 608720 1 0 $X=598300 $Y=603300
X3258 3309 1 737 2917 2 3284 ND3 $T=600780 669200 0 180 $X=598300 $Y=663780
X3259 3302 1 719 3307 2 3310 ND3 $T=598920 608720 0 0 $X=598920 $Y=608340
X3260 3299 1 3311 3303 2 3323 ND3 $T=600160 659120 0 0 $X=600160 $Y=658740
X3261 709 1 3107 3317 2 3289 ND3 $T=600780 598640 0 0 $X=600780 $Y=598260
X3262 744 1 529 3338 2 749 ND3 $T=603880 699440 1 0 $X=603880 $Y=694020
X3263 3098 1 3125 3371 2 3210 ND3 $T=608840 608720 1 0 $X=608840 $Y=603300
X3264 3365 1 3124 3310 2 2956 ND3 $T=613800 618800 0 180 $X=611320 $Y=613380
X3265 3375 1 3337 3391 2 3093 ND3 $T=613800 598640 0 0 $X=613800 $Y=598260
X3266 2956 1 3124 3383 2 3014 ND3 $T=613800 618800 1 0 $X=613800 $Y=613380
X3267 768 1 3341 3400 2 3398 ND3 $T=616900 689360 0 0 $X=616900 $Y=688980
X3268 3337 1 2947 3411 2 3131 ND3 $T=617520 608720 1 0 $X=617520 $Y=603300
X3269 3421 1 3118 3395 2 3378 ND3 $T=620000 659120 1 180 $X=617520 $Y=658740
X3270 3399 1 3396 3276 2 3423 ND3 $T=618140 669200 1 0 $X=618140 $Y=663780
X3271 773 1 517 3406 2 679 ND3 $T=621240 699440 0 180 $X=618760 $Y=694020
X3272 3451 1 3446 783 2 3437 ND3 $T=628060 659120 1 180 $X=625580 $Y=658740
X3273 790 1 3455 2575 2 3346 ND3 $T=629300 628880 1 180 $X=626820 $Y=628500
X3274 3460 1 3456 3354 2 3450 ND3 $T=629920 649040 1 180 $X=627440 $Y=648660
X3275 3462 1 737 3405 2 3407 ND3 $T=629920 679280 1 180 $X=627440 $Y=678900
X3276 3463 1 737 3154 2 3487 ND3 $T=632400 679280 0 0 $X=632400 $Y=678900
X3277 3479 1 668 3183 2 3493 ND3 $T=639220 638960 1 180 $X=636740 $Y=638580
X3278 818 1 685 3480 2 3059 ND3 $T=643560 699440 0 180 $X=641080 $Y=694020
X3279 663 1 672 3520 2 660 ND3 $T=648520 518000 1 180 $X=646040 $Y=517620
X3280 3128 1 3059 3533 2 3387 ND3 $T=649140 679280 1 0 $X=649140 $Y=673860
X3281 3387 1 3073 3539 2 640 ND3 $T=654720 679280 0 180 $X=652240 $Y=673860
X3282 3576 1 3586 3508 2 3524 ND3 $T=661540 669200 1 0 $X=661540 $Y=663780
X3283 4016 1 4015 3961 2 4011 ND3 $T=760740 528080 1 180 $X=758260 $Y=527700
X3284 4045 1 4058 4066 2 4060 ND3 $T=765700 538160 0 0 $X=765700 $Y=537780
X3285 4534 1 4502 4499 2 4516 ND3 $T=860560 588560 1 0 $X=860560 $Y=583140
X3286 4556 1 4539 4543 2 4327 ND3 $T=874200 548240 0 180 $X=871720 $Y=542820
X3287 4751 1 4758 4768 2 4763 ND3 $T=919460 548240 1 0 $X=919460 $Y=542820
X3288 4927 1 4907 4801 2 4888 ND3 $T=957280 618800 0 180 $X=954800 $Y=613380
X3289 5101 1 1215 1213 2 5113 ND3 $T=996340 699440 1 0 $X=996340 $Y=694020
X3290 4918 1 5053 5116 2 5128 ND3 $T=998200 548240 0 0 $X=998200 $Y=547860
X3291 5156 1 1224 1223 2 5180 ND3 $T=1010600 699440 1 0 $X=1010600 $Y=694020
X3292 5202 1 1227 1229 2 5214 ND3 $T=1018040 699440 1 0 $X=1018040 $Y=694020
X3293 5239 1 1234 1232 2 5263 ND3 $T=1027340 699440 1 0 $X=1027340 $Y=694020
X3294 5370 1 1247 1249 2 5377 ND3 $T=1052760 699440 1 0 $X=1052760 $Y=694020
X3295 5386 1 1253 1254 2 5409 ND3 $T=1059580 689360 0 0 $X=1059580 $Y=688980
X3296 5486 1 1268 1267 2 5464 ND3 $T=1081900 699440 0 180 $X=1079420 $Y=694020
X3297 13 7 1307 2 4 1 3 AN4B1S $T=225060 507920 0 180 $X=220720 $Y=502500
X3298 14 1318 1313 2 6 1 1295 AN4B1S $T=225680 507920 1 180 $X=221340 $Y=507540
X3299 1328 11 1314 2 1308 1 1296 AN4B1S $T=225680 528080 1 180 $X=221340 $Y=527700
X3300 28 34 40 2 1350 1 1369 AN4B1S $T=228160 548240 1 0 $X=228160 $Y=542820
X3301 13 41 1355 2 49 1 1354 AN4B1S $T=229400 507920 0 0 $X=229400 $Y=507540
X3302 13 58 1355 2 1376 1 1348 AN4B1S $T=236840 518000 0 180 $X=232500 $Y=512580
X3303 73 66 1390 2 59 1 1338 AN4B1S $T=239320 507920 1 180 $X=234980 $Y=507540
X3304 80 1414 67 2 1387 1 1356 AN4B1S $T=241800 538160 1 180 $X=237460 $Y=537780
X3305 21 66 87 2 90 1 1439 AN4B1S $T=240560 507920 1 0 $X=240560 $Y=502500
X3306 1456 1446 1441 2 1425 1 1423 AN4B1S $T=247380 538160 0 180 $X=243040 $Y=532740
X3307 1472 119 1390 2 115 1 1490 AN4B1S $T=256060 497840 1 180 $X=251720 $Y=497460
X3308 1494 1472 125 2 1476 1 1530 AN4B1S $T=255440 507920 1 0 $X=255440 $Y=502500
X3309 66 143 7 2 145 1 1540 AN4B1S $T=263500 497840 0 0 $X=263500 $Y=497460
X3310 1537 25 148 2 1491 1 1533 AN4B1S $T=269700 548240 1 180 $X=265360 $Y=547860
X3311 125 28 161 2 164 1 1510 AN4B1S $T=270940 497840 0 0 $X=270940 $Y=497460
X3312 192 187 1610 2 1635 1 1598 AN4B1S $T=282100 518000 1 180 $X=277760 $Y=517620
X3313 1358 1715 1576 2 1725 1 1732 AN4B1S $T=292640 548240 1 0 $X=292640 $Y=542820
X3314 28 156 1548 2 1383 1 1727 AN4B1S $T=300080 518000 0 180 $X=295740 $Y=512580
X3315 219 1642 211 2 140 1 1741 AN4B1S $T=296360 538160 0 0 $X=296360 $Y=537780
X3316 189 211 1576 2 1729 1 240 AN4B1S $T=298220 528080 0 0 $X=298220 $Y=527700
X3317 1642 148 40 2 1443 1 1733 AN4B1S $T=298220 558320 1 0 $X=298220 $Y=552900
X3318 1767 1757 1750 2 1717 1 246 AN4B1S $T=305660 518000 0 180 $X=301320 $Y=512580
X3319 7 28 73 2 235 1 1789 AN4B1S $T=306280 497840 0 0 $X=306280 $Y=497460
X3320 67 196 28 2 106 1 1779 AN4B1S $T=312480 507920 1 180 $X=308140 $Y=507540
X3321 1790 67 1620 2 259 1 1529 AN4B1S $T=311240 538160 1 0 $X=311240 $Y=532740
X3322 1642 1793 1790 2 1797 1 1511 AN4B1S $T=311860 538160 0 0 $X=311860 $Y=537780
X3323 177 189 1537 2 71 1 1803 AN4B1S $T=313720 518000 0 0 $X=313720 $Y=517620
X3324 1715 1385 67 2 1808 1 1784 AN4B1S $T=314960 548240 1 0 $X=314960 $Y=542820
X3325 1832 270 1806 2 268 1 1813 AN4B1S $T=322400 497840 1 180 $X=318060 $Y=497460
X3326 1807 158 1414 2 1729 1 1830 AN4B1S $T=318060 518000 0 0 $X=318060 $Y=517620
X3327 135 25 1774 2 1728 1 1841 AN4B1S $T=323020 528080 0 0 $X=323020 $Y=527700
X3328 1715 37 209 2 105 1 280 AN4B1S $T=327980 507920 0 0 $X=327980 $Y=507540
X3329 563 528 529 2 2748 1 2723 AN4B1S $T=525760 699440 0 180 $X=521420 $Y=694020
X3330 563 522 531 2 550 1 2814 AN4B1S $T=525140 669200 1 0 $X=525140 $Y=663780
X3331 2907 2838 2834 2 2832 1 2823 AN4B1S $T=535060 649040 0 180 $X=530720 $Y=643620
X3332 495 612 512 2 611 1 2940 AN4B1S $T=540020 689360 0 0 $X=540020 $Y=688980
X3333 2872 2899 621 2 2910 1 2867 AN4B1S $T=541260 659120 0 0 $X=541260 $Y=658740
X3334 2909 2950 2934 2 2964 1 2922 AN4B1S $T=548700 649040 1 0 $X=548700 $Y=643620
X3335 2960 2954 2970 2 2975 1 2972 AN4B1S $T=550560 659120 1 0 $X=550560 $Y=653700
X3336 3004 2996 2990 2 2983 1 2897 AN4B1S $T=557380 659120 1 180 $X=553040 $Y=658740
X3337 2984 277 2979 2 3003 1 2988 AN4B1S $T=554280 548240 1 0 $X=554280 $Y=542820
X3338 2960 2976 3008 2 3013 1 3004 AN4B1S $T=555520 659120 1 0 $X=555520 $Y=653700
X3339 2911 3020 3022 2 2863 1 2943 AN4B1S $T=557380 598640 0 0 $X=557380 $Y=598260
X3340 3044 3033 654 2 2939 1 3011 AN4B1S $T=561720 689360 0 180 $X=557380 $Y=683940
X3341 2965 3027 3032 2 3037 1 3015 AN4B1S $T=558000 669200 1 0 $X=558000 $Y=663780
X3342 3091 3098 3095 2 2994 1 3082 AN4B1S $T=569780 608720 0 180 $X=565440 $Y=603300
X3343 676 594 571 2 680 1 3121 AN4B1S $T=574740 699440 0 180 $X=570400 $Y=694020
X3344 3140 2984 2941 2 672 1 3139 AN4B1S $T=577220 538160 0 180 $X=572880 $Y=532740
X3345 3144 3150 3058 2 3154 1 2880 AN4B1S $T=573500 669200 0 0 $X=573500 $Y=668820
X3346 3139 3129 2971 2 3130 1 3207 AN4B1S $T=578460 528080 0 0 $X=578460 $Y=527700
X3347 3210 3178 3125 2 2806 1 3185 AN4B1S $T=584660 598640 1 180 $X=580320 $Y=598260
X3348 3211 3217 3220 2 3225 1 3050 AN4B1S $T=584040 669200 0 0 $X=584040 $Y=668820
X3349 3067 702 653 2 684 1 715 AN4B1S $T=584040 699440 1 0 $X=584040 $Y=694020
X3350 3031 592 536 2 3184 1 3227 AN4B1S $T=590860 679280 1 180 $X=586520 $Y=678900
X3351 2950 3249 3239 2 3013 1 3268 AN4B1S $T=590240 628880 0 0 $X=590240 $Y=628500
X3352 740 705 669 2 722 1 3230 AN4B1S $T=596440 679280 1 180 $X=592100 $Y=678900
X3353 3236 3286 3292 2 3297 1 3209 AN4B1S $T=595820 649040 0 0 $X=595820 $Y=648660
X3354 3308 3284 3326 2 745 1 747 AN4B1S $T=602640 669200 1 0 $X=602640 $Y=663780
X3355 3357 3350 3335 2 751 1 3066 AN4B1S $T=610700 669200 1 180 $X=606360 $Y=668820
X3356 3360 3334 3348 2 3307 1 3188 AN4B1S $T=611320 618800 0 180 $X=606980 $Y=613380
X3357 3283 3292 3332 2 3354 1 762 AN4B1S $T=607600 649040 0 0 $X=607600 $Y=648660
X3358 3396 3382 3378 2 3364 1 2714 AN4B1S $T=616900 669200 1 180 $X=612560 $Y=668820
X3359 3091 2947 3131 2 3317 1 3417 AN4B1S $T=617520 598640 0 0 $X=617520 $Y=598260
X3360 3443 3435 3453 2 789 1 3360 AN4B1S $T=626200 618800 1 0 $X=626200 $Y=613380
X3361 3471 3432 3383 2 3481 1 3455 AN4B1S $T=632400 618800 1 0 $X=632400 $Y=613380
X3362 277 708 617 2 3520 1 3509 AN4B1S $T=649140 528080 1 180 $X=644800 $Y=527700
X3363 3531 3534 2894 2 772 1 3409 AN4B1S $T=649760 628880 0 0 $X=649760 $Y=628500
X3364 4556 4327 4539 2 4568 1 4567 AN4B1S $T=879780 528080 1 0 $X=879780 $Y=522660
X3365 3329 1 2 3318 BUF1CK $T=604500 528080 1 0 $X=604500 $Y=522660
X3366 3682 1 2 888 BUF1CK $T=685720 689360 0 0 $X=685720 $Y=688980
X3367 3718 1 2 3780 BUF1CK $T=706800 638960 0 0 $X=706800 $Y=638580
X3368 985 1 2 4107 BUF1CK $T=781200 699440 1 0 $X=781200 $Y=694020
X3369 4240 1 2 4231 BUF1CK $T=799800 628880 0 0 $X=799800 $Y=628500
X3370 1474 68 1439 104 2 1 1441 OA22 $T=250480 518000 1 180 $X=246140 $Y=517620
X3371 2675 2668 2664 2662 2 1 2654 OA22 $T=507780 588560 1 180 $X=503440 $Y=588180
X3372 2703 2692 2685 2676 2 1 492 OA22 $T=510880 588560 0 180 $X=506540 $Y=583140
X3373 2707 2668 2694 2662 2 1 2588 OA22 $T=512120 568400 0 180 $X=507780 $Y=562980
X3374 2692 2668 2676 2662 2 1 2497 OA22 $T=512120 598640 0 180 $X=507780 $Y=593220
X3375 2703 2709 2685 2663 2 1 496 OA22 $T=513980 578480 0 180 $X=509640 $Y=573060
X3376 2703 2675 2685 2664 2 1 518 OA22 $T=510880 588560 1 0 $X=510880 $Y=583140
X3377 2703 2707 2685 2694 2 1 509 OA22 $T=516460 568400 0 180 $X=512120 $Y=562980
X3378 2752 2668 2699 2662 2 1 2687 OA22 $T=519560 568400 1 180 $X=515220 $Y=568020
X3379 2709 2668 2663 2662 2 1 2728 OA22 $T=519560 588560 0 180 $X=515220 $Y=583140
X3380 2703 2751 2685 2742 2 1 521 OA22 $T=520800 568400 0 180 $X=516460 $Y=562980
X3381 2772 2668 538 2662 2 1 2446 OA22 $T=523280 558320 0 180 $X=518940 $Y=552900
X3382 2703 2769 2685 2763 2 1 534 OA22 $T=523900 588560 0 180 $X=519560 $Y=583140
X3383 2751 2668 2742 2662 2 1 2618 OA22 $T=524520 548240 0 180 $X=520180 $Y=542820
X3384 2703 2752 2685 2699 2 1 535 OA22 $T=524520 568400 1 180 $X=520180 $Y=568020
X3385 2783 2668 545 2662 2 1 2627 OA22 $T=524520 578480 1 180 $X=520180 $Y=578100
X3386 2703 2775 2685 546 2 1 541 OA22 $T=525140 568400 0 180 $X=520800 $Y=562980
X3387 2738 2784 2747 2761 2 1 2722 OA22 $T=525760 628880 0 180 $X=521420 $Y=623460
X3388 2703 2798 2685 560 2 1 554 OA22 $T=528240 538160 0 180 $X=523900 $Y=532740
X3389 2801 2668 2786 2662 2 1 2782 OA22 $T=528240 578480 0 180 $X=523900 $Y=573060
X3390 2769 2668 2763 2662 2 1 2725 OA22 $T=528860 588560 1 180 $X=524520 $Y=588180
X3391 2703 2803 2685 566 2 1 557 OA22 $T=529480 538160 1 180 $X=525140 $Y=537780
X3392 2703 2783 2685 545 2 1 559 OA22 $T=529480 578480 1 180 $X=525140 $Y=578100
X3393 2703 2804 2685 568 2 1 561 OA22 $T=529480 588560 0 180 $X=525140 $Y=583140
X3394 2798 2668 560 2662 2 1 2552 OA22 $T=530100 548240 0 180 $X=525760 $Y=542820
X3395 2703 2801 2685 2786 2 1 577 OA22 $T=525760 568400 0 0 $X=525760 $Y=568020
X3396 2804 2668 568 2662 2 1 2651 OA22 $T=530100 598640 0 180 $X=525760 $Y=593220
X3397 2822 2668 572 2662 2 1 2547 OA22 $T=530720 548240 1 180 $X=526380 $Y=547860
X3398 2703 2772 2685 538 2 1 567 OA22 $T=530720 558320 0 180 $X=526380 $Y=552900
X3399 2775 2668 546 2662 2 1 2790 OA22 $T=531960 568400 0 180 $X=527620 $Y=562980
X3400 2803 2668 566 2662 2 1 2785 OA22 $T=533820 538160 1 180 $X=529480 $Y=537780
X3401 2703 2822 2685 572 2 1 582 OA22 $T=535060 548240 1 180 $X=530720 $Y=547860
X3402 2703 2845 2685 587 2 1 584 OA22 $T=535680 568400 1 180 $X=531340 $Y=568020
X3403 2703 2846 2685 588 2 1 585 OA22 $T=535680 588560 0 180 $X=531340 $Y=583140
X3404 2846 2668 588 2662 2 1 2454 OA22 $T=535680 598640 0 180 $X=531340 $Y=593220
X3405 2842 594 2852 2858 2 1 2871 OA22 $T=533820 669200 1 0 $X=533820 $Y=663780
X3406 2874 2668 597 2662 2 1 2578 OA22 $T=538780 578480 1 180 $X=534440 $Y=578100
X3407 2861 2668 600 2662 2 1 2774 OA22 $T=539400 548240 1 180 $X=535060 $Y=547860
X3408 2845 2668 587 2662 2 1 2851 OA22 $T=539400 578480 0 180 $X=535060 $Y=573060
X3409 2879 2668 604 2662 2 1 2645 OA22 $T=541260 588560 1 180 $X=536920 $Y=588180
X3410 2703 2861 2685 600 2 1 603 OA22 $T=541880 538160 1 180 $X=537540 $Y=537780
X3411 2890 2668 607 2662 2 1 2789 OA22 $T=541880 568400 0 180 $X=537540 $Y=562980
X3412 2703 2879 2685 604 2 1 601 OA22 $T=541880 588560 0 180 $X=537540 $Y=583140
X3413 2703 2874 2685 597 2 1 610 OA22 $T=544360 578480 1 180 $X=540020 $Y=578100
X3414 2703 2890 2685 607 2 1 616 OA22 $T=546220 568400 0 180 $X=541880 $Y=562980
X3415 2703 2921 2685 623 2 1 618 OA22 $T=546840 558320 0 180 $X=542500 $Y=552900
X3416 2921 2668 623 2662 2 1 2905 OA22 $T=551180 558320 0 180 $X=546840 $Y=552900
X3417 613 510 636 609 2 1 2960 OA22 $T=546840 679280 1 0 $X=546840 $Y=673860
X3418 671 3095 2852 3159 2 1 3044 OA22 $T=579080 628880 1 180 $X=574740 $Y=628500
X3419 3134 3100 709 3097 2 1 3236 OA22 $T=585280 618800 0 0 $X=585280 $Y=618420
X3420 3107 3120 3160 668 2 1 3239 OA22 $T=585900 628880 0 0 $X=585900 $Y=628500
X3421 671 3131 3120 3125 2 1 3265 OA22 $T=590860 608720 1 0 $X=590860 $Y=603300
X3422 3065 2877 3273 3120 2 1 3286 OA22 $T=593340 618800 0 0 $X=593340 $Y=618420
X3423 553 739 3046 3128 2 1 3341 OA22 $T=599540 689360 0 0 $X=599540 $Y=688980
X3424 671 3178 658 3073 2 1 3431 OA22 $T=621860 618800 1 0 $X=621860 $Y=613380
X3425 685 3474 2877 668 2 1 3524 OA22 $T=643560 628880 0 0 $X=643560 $Y=628500
X3426 3159 3065 3061 3387 2 1 3531 OA22 $T=646040 638960 1 0 $X=646040 $Y=633540
X3427 659 826 2997 3476 2 1 3572 OA22 $T=651620 659120 1 0 $X=651620 $Y=653700
X3428 2418 1 2 2208 INV3CK $T=460660 558320 0 180 $X=457560 $Y=552900
X3429 2562 1 2 471 INV3CK $T=484840 528080 0 180 $X=481740 $Y=522660
X3430 2794 1 2 2721 INV3CK $T=526380 558320 0 180 $X=523280 $Y=552900
X3431 3359 1 2 3295 INV3CK $T=611320 618800 0 0 $X=611320 $Y=618420
X3432 4807 1 2 4838 INV3CK $T=938680 699440 0 180 $X=935580 $Y=694020
X3433 4869 1 2 1161 INV3CK $T=947980 679280 0 180 $X=944880 $Y=673860
X3434 4954 1 2 1180 INV3CK $T=961620 699440 1 0 $X=961620 $Y=694020
X3435 2187 353 1 2 INV6CK $T=404860 507920 0 0 $X=404860 $Y=507540
X3436 2208 1894 1 2 INV6CK $T=410440 558320 0 180 $X=404860 $Y=552900
X3437 2213 339 1 2 INV6CK $T=411060 518000 1 180 $X=405480 $Y=517620
X3438 2190 1924 1 2 INV6CK $T=405480 548240 1 0 $X=405480 $Y=542820
X3439 2234 1891 1 2 INV6CK $T=415400 528080 1 180 $X=409820 $Y=527700
X3440 2277 340 1 2 INV6CK $T=423460 538160 0 0 $X=423460 $Y=537780
X3441 2383 379 1 2 INV6CK $T=443300 518000 0 180 $X=437720 $Y=512580
X3442 2473 1993 1 2 INV6CK $T=477400 548240 0 180 $X=471820 $Y=542820
X3443 2619 2303 1 2 INV6CK $T=494760 568400 0 180 $X=489180 $Y=562980
X3444 2579 2257 1 2 INV6CK $T=500340 578480 0 0 $X=500340 $Y=578100
X3445 2649 2346 1 2 INV6CK $T=502820 528080 0 0 $X=502820 $Y=527700
X3446 2656 2267 1 2 INV6CK $T=505300 538160 0 0 $X=505300 $Y=537780
X3447 2721 467 1 2 INV6CK $T=513360 518000 0 0 $X=513360 $Y=517620
X3448 2502 2758 1 2 INV6CK $T=516460 689360 0 0 $X=516460 $Y=688980
X3449 2767 458 1 2 INV6CK $T=521420 507920 0 0 $X=521420 $Y=507540
X3450 2758 2844 1 2 INV6CK $T=530100 679280 0 0 $X=530100 $Y=678900
X3451 3318 3347 1 2 INV6CK $T=605740 518000 0 0 $X=605740 $Y=517620
X3452 3414 782 1 2 INV6CK $T=639220 638960 0 180 $X=633640 $Y=633540
X3453 102 1 1464 114 116 1493 2 OAI22S $T=256060 548240 0 180 $X=252340 $Y=542820
X3454 32 1 222 47 1719 215 2 OAI22S $T=296980 497840 1 180 $X=293260 $Y=497460
X3455 47 1 1749 114 247 1727 2 OAI22S $T=306900 507920 1 180 $X=303180 $Y=507540
X3456 45 1 1819 172 1635 276 2 OAI22S $T=327980 518000 0 180 $X=324260 $Y=512580
X3457 2685 1 2756 2703 537 2762 2 OAI22S $T=518940 518000 0 0 $X=518940 $Y=517620
X3458 2685 1 2764 2703 549 2780 2 OAI22S $T=520180 518000 1 0 $X=520180 $Y=512580
X3459 2662 1 2756 2668 2456 2762 2 OAI22S $T=524520 528080 1 180 $X=520800 $Y=527700
X3460 2662 1 2764 2668 2432 2780 2 OAI22S $T=522660 518000 0 0 $X=522660 $Y=517620
X3461 2685 1 2788 2703 564 2815 2 OAI22S $T=523900 518000 1 0 $X=523900 $Y=512580
X3462 2662 1 2788 2668 2638 2815 2 OAI22S $T=526380 518000 0 0 $X=526380 $Y=517620
X3463 2662 1 2827 2668 2631 2840 2 OAI22S $T=530100 518000 0 0 $X=530100 $Y=517620
X3464 2685 1 2827 2703 558 2840 2 OAI22S $T=531340 507920 0 0 $X=531340 $Y=507540
X3465 2852 1 2837 589 2833 2814 2 OAI22S $T=535060 638960 0 180 $X=531340 $Y=633540
X3466 2811 1 542 579 2678 599 2 OAI22S $T=533200 689360 1 0 $X=533200 $Y=683940
X3467 544 1 632 592 2939 2892 2 OAI22S $T=546220 679280 0 0 $X=546220 $Y=678900
X3468 2866 1 640 2993 2991 2877 2 OAI22S $T=553040 669200 0 0 $X=553040 $Y=668820
X3469 3046 1 3173 609 3171 691 2 OAI22S $T=580320 659120 0 180 $X=576600 $Y=653700
X3470 613 1 3230 628 3189 3227 2 OAI22S $T=590240 689360 1 180 $X=586520 $Y=688980
X3471 1315 2 10 1324 1 NR2 $T=223200 518000 0 0 $X=223200 $Y=517620
X3472 24 2 1307 33 1 NR2 $T=226920 507920 0 0 $X=226920 $Y=507540
X3473 50 2 1352 1343 1 NR2 $T=232500 669200 0 180 $X=230640 $Y=663780
X3474 50 2 1365 1374 1 NR2 $T=231880 679280 1 0 $X=231880 $Y=673860
X3475 1351 2 1373 1381 1 NR2 $T=233120 628880 1 0 $X=233120 $Y=623460
X3476 50 2 1363 1381 1 NR2 $T=233740 669200 0 0 $X=233740 $Y=668820
X3477 53 2 7 61 1 NR2 $T=234980 507920 1 0 $X=234980 $Y=502500
X3478 50 2 1345 1388 1 NR2 $T=234980 669200 1 0 $X=234980 $Y=663780
X3479 1366 2 1397 1387 1 NR2 $T=237460 518000 0 0 $X=237460 $Y=517620
X3480 71 2 58 61 1 NR2 $T=238080 507920 1 0 $X=238080 $Y=502500
X3481 74 2 70 1366 1 NR2 $T=240560 518000 0 180 $X=238700 $Y=512580
X3482 1407 2 1409 1416 1 NR2 $T=239320 518000 0 0 $X=239320 $Y=517620
X3483 1435 2 87 105 1 NR2 $T=243660 507920 0 0 $X=243660 $Y=507540
X3484 1482 2 1386 108 1 NR2 $T=250480 548240 0 180 $X=248620 $Y=542820
X3485 126 2 1390 1476 1 NR2 $T=252340 518000 0 180 $X=250480 $Y=512580
X3486 1491 2 1481 1324 1 NR2 $T=252340 528080 0 180 $X=250480 $Y=522660
X3487 1367 2 1498 95 1 NR2 $T=250480 538160 0 0 $X=250480 $Y=537780
X3488 33 2 1495 1460 1 NR2 $T=252340 528080 0 0 $X=252340 $Y=527700
X3489 1443 2 1493 1482 1 NR2 $T=252340 548240 0 0 $X=252340 $Y=547860
X3490 33 2 1494 61 1 NR2 $T=252960 507920 1 0 $X=252960 $Y=502500
X3491 140 2 1507 16 1 NR2 $T=259160 518000 1 180 $X=257300 $Y=517620
X3492 24 2 139 144 1 NR2 $T=264120 507920 1 0 $X=264120 $Y=502500
X3493 1443 2 1564 1587 1 NR2 $T=264120 548240 1 0 $X=264120 $Y=542820
X3494 126 2 1549 140 1 NR2 $T=267840 528080 0 180 $X=265980 $Y=522660
X3495 154 2 1472 86 1 NR2 $T=268460 497840 0 0 $X=268460 $Y=497460
X3496 154 2 1384 49 1 NR2 $T=269080 507920 0 0 $X=269080 $Y=507540
X3497 1476 2 156 140 1 NR2 $T=271560 528080 0 180 $X=269700 $Y=522660
X3498 59 2 1358 174 1 NR2 $T=270940 538160 1 0 $X=270940 $Y=532740
X3499 4 2 173 1579 1 NR2 $T=274040 528080 0 0 $X=274040 $Y=527700
X3500 167 2 1611 1616 1 NR2 $T=274040 669200 1 0 $X=274040 $Y=663780
X3501 1605 2 1609 174 1 NR2 $T=275900 528080 0 0 $X=275900 $Y=527700
X3502 167 2 1617 1628 1 NR2 $T=276520 669200 0 0 $X=276520 $Y=668820
X3503 1605 2 1637 53 1 NR2 $T=279620 528080 1 180 $X=277760 $Y=527700
X3504 167 2 1622 1638 1 NR2 $T=277760 649040 0 0 $X=277760 $Y=648660
X3505 1640 2 1606 1670 1 NR2 $T=281480 558320 0 0 $X=281480 $Y=557940
X3506 167 2 1649 1665 1 NR2 $T=281480 679280 0 0 $X=281480 $Y=678900
X3507 1435 2 196 49 1 NR2 $T=282720 507920 0 0 $X=282720 $Y=507540
X3508 1605 2 1355 199 1 NR2 $T=282720 518000 1 0 $X=282720 $Y=512580
X3509 16 2 1656 1667 1 NR2 $T=282720 518000 0 0 $X=282720 $Y=517620
X3510 126 2 111 199 1 NR2 $T=282720 528080 0 0 $X=282720 $Y=527700
X3511 1435 2 1658 1556 1 NR2 $T=282720 538160 1 0 $X=282720 $Y=532740
X3512 1668 2 189 33 1 NR2 $T=284580 538160 1 180 $X=282720 $Y=537780
X3513 194 2 1620 1668 1 NR2 $T=282720 558320 1 0 $X=282720 $Y=552900
X3514 1670 2 1642 188 1 NR2 $T=284580 558320 0 0 $X=284580 $Y=557940
X3515 199 2 202 1383 1 NR2 $T=285200 518000 1 0 $X=285200 $Y=512580
X3516 24 2 1663 1476 1 NR2 $T=285820 507920 1 0 $X=285820 $Y=502500
X3517 1605 2 1589 1476 1 NR2 $T=288300 528080 0 180 $X=286440 $Y=522660
X3518 1660 2 1603 1659 1 NR2 $T=286440 628880 1 0 $X=286440 $Y=623460
X3519 188 2 109 71 1 NR2 $T=287680 518000 1 0 $X=287680 $Y=512580
X3520 205 2 1630 71 1 NR2 $T=287680 548240 1 0 $X=287680 $Y=542820
X3521 205 2 1414 1675 1 NR2 $T=290160 548240 1 180 $X=288300 $Y=547860
X3522 1675 2 207 1460 1 NR2 $T=289540 528080 0 0 $X=289540 $Y=527700
X3523 220 2 1706 194 1 NR2 $T=295120 518000 1 180 $X=293260 $Y=517620
X3524 1579 2 219 199 1 NR2 $T=293260 528080 0 0 $X=293260 $Y=527700
X3525 218 2 1673 1726 1 NR2 $T=293260 649040 0 0 $X=293260 $Y=648660
X3526 218 2 1698 1722 1 NR2 $T=293260 659120 1 0 $X=293260 $Y=653700
X3527 218 2 1718 1723 1 NR2 $T=293260 659120 0 0 $X=293260 $Y=658740
X3528 1667 2 1497 1728 1 NR2 $T=293880 528080 1 0 $X=293880 $Y=522660
X3529 221 2 103 223 1 NR2 $T=294500 689360 0 0 $X=294500 $Y=688980
X3530 1684 2 1715 194 1 NR2 $T=296980 548240 1 180 $X=295120 $Y=547860
X3531 221 2 1475 1722 1 NR2 $T=296360 659120 0 0 $X=296360 $Y=658740
X3532 218 2 1699 225 1 NR2 $T=296360 669200 1 0 $X=296360 $Y=663780
X3533 221 2 1489 225 1 NR2 $T=296360 669200 0 0 $X=296360 $Y=668820
X3534 218 2 1703 231 1 NR2 $T=296360 679280 1 0 $X=296360 $Y=673860
X3535 221 2 1502 231 1 NR2 $T=296360 679280 0 0 $X=296360 $Y=678900
X3536 1376 2 1700 144 1 NR2 $T=296980 507920 1 0 $X=296980 $Y=502500
X3537 221 2 1480 227 1 NR2 $T=296980 689360 1 0 $X=296980 $Y=683940
X3538 218 2 1692 223 1 NR2 $T=296980 689360 0 0 $X=296980 $Y=688980
X3539 221 2 224 233 1 NR2 $T=296980 699440 1 0 $X=296980 $Y=694020
X3540 221 2 1479 1723 1 NR2 $T=298220 669200 1 0 $X=298220 $Y=663780
X3541 140 2 161 71 1 NR2 $T=298840 538160 1 0 $X=298840 $Y=532740
X3542 218 2 1716 227 1 NR2 $T=298840 689360 1 0 $X=298840 $Y=683940
X3543 1728 2 1645 71 1 NR2 $T=301320 538160 1 0 $X=301320 $Y=532740
X3544 174 2 1768 1556 1 NR2 $T=305660 528080 0 180 $X=303800 $Y=522660
X3545 199 2 244 1640 1 NR2 $T=303800 528080 0 0 $X=303800 $Y=527700
X3546 1640 2 181 71 1 NR2 $T=306900 538160 0 0 $X=306900 $Y=537780
X3547 1835 2 1327 1818 1 NR2 $T=322400 528080 0 180 $X=320540 $Y=522660
X3548 291 2 288 299 1 NR2 $T=337900 518000 1 0 $X=337900 $Y=512580
X3549 298 2 306 285 1 NR2 $T=341000 507920 1 0 $X=341000 $Y=502500
X3550 318 2 1946 1954 1 NR2 $T=349680 669200 0 0 $X=349680 $Y=668820
X3551 318 2 1947 1970 1 NR2 $T=349680 679280 1 0 $X=349680 $Y=673860
X3552 318 2 1949 1968 1 NR2 $T=351540 689360 1 0 $X=351540 $Y=683940
X3553 1936 2 1963 325 1 NR2 $T=356500 507920 0 180 $X=354640 $Y=502500
X3554 267 2 2031 1722 1 NR2 $T=363320 649040 0 0 $X=363320 $Y=648660
X3555 267 2 2014 233 1 NR2 $T=367040 699440 0 180 $X=365180 $Y=694020
X3556 267 2 2032 223 1 NR2 $T=368900 689360 1 180 $X=367040 $Y=688980
X3557 267 2 2013 225 1 NR2 $T=370140 659120 1 180 $X=368280 $Y=658740
X3558 267 2 341 344 1 NR2 $T=368280 699440 1 0 $X=368280 $Y=694020
X3559 267 2 2042 231 1 NR2 $T=372000 669200 0 0 $X=372000 $Y=668820
X3560 267 2 2035 227 1 NR2 $T=372000 679280 0 0 $X=372000 $Y=678900
X3561 267 2 2028 1723 1 NR2 $T=373240 669200 1 0 $X=373240 $Y=663780
X3562 267 2 1976 1726 1 NR2 $T=373860 659120 1 0 $X=373860 $Y=653700
X3563 2090 2 2099 2104 1 NR2 $T=385640 507920 1 0 $X=385640 $Y=502500
X3564 2098 2 2083 2111 1 NR2 $T=385640 649040 0 0 $X=385640 $Y=648660
X3565 2061 2 380 2146 1 NR2 $T=393700 507920 1 0 $X=393700 $Y=502500
X3566 2124 2 2127 2148 1 NR2 $T=394320 669200 1 0 $X=394320 $Y=663780
X3567 2066 2 2206 2155 1 NR2 $T=409200 669200 0 180 $X=407340 $Y=663780
X3568 2066 2 2217 2194 1 NR2 $T=410440 659120 0 0 $X=410440 $Y=658740
X3569 400 2 397 391 1 NR2 $T=416640 689360 1 180 $X=414780 $Y=688980
X3570 398 2 2200 225 1 NR2 $T=417880 638960 0 180 $X=416020 $Y=633540
X3571 398 2 2240 1723 1 NR2 $T=416020 638960 0 0 $X=416020 $Y=638580
X3572 398 2 2223 405 1 NR2 $T=416020 649040 0 0 $X=416020 $Y=648660
X3573 2066 2 2245 2159 1 NR2 $T=416020 669200 1 0 $X=416020 $Y=663780
X3574 400 2 403 1723 1 NR2 $T=419740 699440 1 0 $X=419740 $Y=694020
X3575 407 2 409 1723 1 NR2 $T=422840 689360 0 0 $X=422840 $Y=688980
X3576 2282 2 2279 2276 1 NR2 $T=425320 528080 0 180 $X=423460 $Y=522660
X3577 398 2 2281 231 1 NR2 $T=424080 638960 1 0 $X=424080 $Y=633540
X3578 2282 2 2290 2293 1 NR2 $T=427800 518000 0 0 $X=427800 $Y=517620
X3579 2295 2 412 2282 1 NR2 $T=430280 518000 0 180 $X=428420 $Y=512580
X3580 2296 2 2300 2293 1 NR2 $T=429660 518000 0 0 $X=429660 $Y=517620
X3581 398 2 2302 227 1 NR2 $T=431520 638960 0 180 $X=429660 $Y=633540
X3582 2295 2 2297 2296 1 NR2 $T=432140 518000 0 180 $X=430280 $Y=512580
X3583 2296 2 2323 2276 1 NR2 $T=434620 528080 0 180 $X=432760 $Y=522660
X3584 398 2 2329 223 1 NR2 $T=435240 638960 1 0 $X=435240 $Y=633540
X3585 2255 2 2367 2325 1 NR2 $T=438340 497840 0 0 $X=438340 $Y=497460
X3586 398 2 2369 423 1 NR2 $T=438340 638960 1 0 $X=438340 $Y=633540
X3587 398 2 2308 233 1 NR2 $T=438340 638960 0 0 $X=438340 $Y=638580
X3588 2282 2 2382 2389 1 NR2 $T=442060 518000 0 0 $X=442060 $Y=517620
X3589 425 2 406 428 1 NR2 $T=443920 497840 0 0 $X=443920 $Y=497460
X3590 2254 2 2388 428 1 NR2 $T=445160 507920 1 0 $X=445160 $Y=502500
X3591 400 2 430 429 1 NR2 $T=445160 689360 0 0 $X=445160 $Y=688980
X3592 2389 2 2407 2296 1 NR2 $T=447020 518000 0 0 $X=447020 $Y=517620
X3593 398 2 2393 344 1 NR2 $T=448880 638960 0 180 $X=447020 $Y=633540
X3594 398 2 2415 429 1 NR2 $T=450740 638960 0 180 $X=448880 $Y=633540
X3595 436 2 2230 440 1 NR2 $T=450120 497840 0 0 $X=450120 $Y=497460
X3596 400 2 437 438 1 NR2 $T=450120 699440 1 0 $X=450120 $Y=694020
X3597 2429 2 2262 436 1 NR2 $T=453840 507920 0 180 $X=451980 $Y=502500
X3598 400 2 442 441 1 NR2 $T=451980 699440 1 0 $X=451980 $Y=694020
X3599 2429 2 408 2443 1 NR2 $T=455080 497840 0 0 $X=455080 $Y=497460
X3600 398 2 2440 438 1 NR2 $T=456940 638960 0 180 $X=455080 $Y=633540
X3601 2295 2 2439 2445 1 NR2 $T=455700 518000 1 0 $X=455700 $Y=512580
X3602 2443 2 404 440 1 NR2 $T=458800 497840 1 180 $X=456940 $Y=497460
X3603 398 2 2457 441 1 NR2 $T=460660 638960 0 180 $X=458800 $Y=633540
X3604 400 2 443 448 1 NR2 $T=458800 689360 0 0 $X=458800 $Y=688980
X3605 2389 2 2461 2445 1 NR2 $T=460660 518000 0 0 $X=460660 $Y=517620
X3606 2445 2 2480 2293 1 NR2 $T=463140 507920 0 0 $X=463140 $Y=507540
X3607 398 2 2476 448 1 NR2 $T=469340 638960 1 180 $X=467480 $Y=638580
X3608 460 2 2437 398 1 NR2 $T=472440 679280 0 180 $X=470580 $Y=673860
X3609 398 2 2468 459 1 NR2 $T=473060 699440 0 180 $X=471200 $Y=694020
X3610 460 2 2500 398 1 NR2 $T=474300 679280 0 180 $X=472440 $Y=673860
X3611 2445 2 2527 2276 1 NR2 $T=473060 518000 1 0 $X=473060 $Y=512580
X3612 2601 2 2592 2293 1 NR2 $T=492280 507920 1 180 $X=490420 $Y=507540
X3613 2601 2 2610 2276 1 NR2 $T=492280 507920 0 0 $X=492280 $Y=507540
X3614 2389 2 2646 2601 1 NR2 $T=501580 518000 1 0 $X=501580 $Y=512580
X3615 2295 2 2684 2601 1 NR2 $T=505920 507920 0 0 $X=505920 $Y=507540
X3616 2691 2 2674 2652 1 NR2 $T=508400 649040 1 180 $X=506540 $Y=648660
X3617 2642 2 2710 2712 1 NR2 $T=510880 618800 1 0 $X=510880 $Y=613380
X3618 2701 2 2697 2717 1 NR2 $T=511500 649040 1 0 $X=511500 $Y=643620
X3619 2717 2 2672 2712 1 NR2 $T=512740 638960 1 0 $X=512740 $Y=633540
X3620 2720 2 2735 2715 1 NR2 $T=513360 618800 1 0 $X=513360 $Y=613380
X3621 2701 2 2726 2677 1 NR2 $T=513360 638960 0 0 $X=513360 $Y=638580
X3622 523 2 2702 2715 1 NR2 $T=517080 628880 0 180 $X=515220 $Y=623460
X3623 2720 2 2741 2700 1 NR2 $T=515220 649040 1 0 $X=515220 $Y=643620
X3624 2642 2 2739 2700 1 NR2 $T=515220 659120 1 0 $X=515220 $Y=653700
X3625 2747 2 2743 2717 1 NR2 $T=518320 638960 1 0 $X=518320 $Y=633540
X3626 2677 2 2753 2718 1 NR2 $T=520800 659120 0 180 $X=518940 $Y=653700
X3627 328 2 2737 323 1 NR2 $T=520800 598640 0 0 $X=520800 $Y=598260
X3628 2778 2 2761 2696 1 NR2 $T=523900 638960 0 180 $X=522040 $Y=633540
X3629 2733 2 2765 2717 1 NR2 $T=523900 638960 1 180 $X=522040 $Y=638580
X3630 2778 2 2787 319 1 NR2 $T=523900 649040 1 0 $X=523900 $Y=643620
X3631 2796 2 2705 2770 1 NR2 $T=526380 689360 1 180 $X=524520 $Y=688980
X3632 2689 2 2810 2729 1 NR2 $T=525760 628880 0 0 $X=525760 $Y=628500
X3633 2715 2 2802 2729 1 NR2 $T=527000 628880 1 0 $X=527000 $Y=623460
X3634 573 2 2811 574 1 NR2 $T=528240 679280 0 0 $X=528240 $Y=678900
X3635 2652 2 2828 2720 1 NR2 $T=530720 608720 0 0 $X=530720 $Y=608340
X3636 2828 2 2837 2807 1 NR2 $T=532580 628880 0 180 $X=530720 $Y=623460
X3637 2826 2 2820 2833 1 NR2 $T=530720 628880 0 0 $X=530720 $Y=628500
X3638 2836 2 2809 2841 1 NR2 $T=532580 618800 0 0 $X=532580 $Y=618420
X3639 598 2 2842 2791 1 NR2 $T=536300 679280 0 0 $X=536300 $Y=678900
X3640 2652 2 2863 2857 1 NR2 $T=536920 608720 1 0 $X=536920 $Y=603300
X3641 2729 2 2875 316 1 NR2 $T=537540 628880 1 0 $X=537540 $Y=623460
X3642 316 2 2873 323 1 NR2 $T=539400 608720 0 0 $X=539400 $Y=608340
X3643 523 2 2908 2896 1 NR2 $T=540640 618800 0 0 $X=540640 $Y=618420
X3644 523 2 2784 2896 1 NR2 $T=544360 618800 0 0 $X=544360 $Y=618420
X3645 328 2 2819 548 1 NR2 $T=547460 608720 1 180 $X=545600 $Y=608340
X3646 2896 2 2870 548 1 NR2 $T=545600 618800 1 0 $X=545600 $Y=613380
X3647 2946 2 2850 617 1 NR2 $T=549320 528080 0 180 $X=547460 $Y=522660
X3648 1936 2 2885 637 1 NR2 $T=548700 578480 1 0 $X=548700 $Y=573060
X3649 2813 2 2849 2966 1 NR2 $T=549320 638960 1 0 $X=549320 $Y=633540
X3650 644 2 571 611 1 NR2 $T=553040 679280 1 180 $X=551180 $Y=678900
X3651 2999 2 2969 2927 1 NR2 $T=554900 598640 1 180 $X=553040 $Y=598260
X3652 2691 2 2981 2747 1 NR2 $T=554900 608720 1 180 $X=553040 $Y=608340
X3653 2947 2 502 2717 1 NR2 $T=553040 618800 0 0 $X=553040 $Y=618420
X3654 2963 2 2986 2717 1 NR2 $T=553040 628880 0 0 $X=553040 $Y=628500
X3655 2771 2 2989 2717 1 NR2 $T=554280 638960 0 0 $X=554280 $Y=638580
X3656 2747 2 2994 2718 1 NR2 $T=554900 608720 1 0 $X=554900 $Y=603300
X3657 3034 2 643 622 1 NR2 $T=557380 699440 0 180 $X=555520 $Y=694020
X3658 2718 2 2956 2717 1 NR2 $T=558000 608720 1 180 $X=556140 $Y=608340
X3659 2892 2 3012 2717 1 NR2 $T=557380 608720 1 0 $X=557380 $Y=603300
X3660 523 2 3010 328 1 NR2 $T=558000 608720 0 0 $X=558000 $Y=608340
X3661 2732 2 3021 2717 1 NR2 $T=559860 638960 0 180 $X=558000 $Y=633540
X3662 2795 2 3030 2717 1 NR2 $T=561100 618800 0 180 $X=559240 $Y=613380
X3663 2863 2 3036 3042 1 NR2 $T=559860 608720 1 0 $X=559860 $Y=603300
X3664 622 2 3038 624 1 NR2 $T=559860 689360 0 0 $X=559860 $Y=688980
X3665 624 2 3067 655 1 NR2 $T=561720 689360 0 0 $X=561720 $Y=688980
X3666 3035 2 3071 3087 1 NR2 $T=564200 618800 1 0 $X=564200 $Y=613380
X3667 674 2 675 3105 1 NR2 $T=569160 507920 0 0 $X=569160 $Y=507540
X3668 2920 2 3122 3100 1 NR2 $T=571020 618800 0 180 $X=569160 $Y=613380
X3669 3141 2 3134 3074 1 NR2 $T=573500 618800 1 180 $X=571640 $Y=618420
X3670 3127 2 2980 3143 1 NR2 $T=571640 638960 1 0 $X=571640 $Y=633540
X3671 3100 2 3147 2771 1 NR2 $T=575360 628880 0 180 $X=573500 $Y=623460
X3672 690 2 3152 3105 1 NR2 $T=576600 497840 1 180 $X=574740 $Y=497460
X3673 3147 2 3173 3165 1 NR2 $T=579080 628880 0 180 $X=577220 $Y=623460
X3674 3129 2 3206 3130 1 NR2 $T=579700 538160 0 0 $X=579700 $Y=537780
X3675 3161 2 3195 2691 1 NR2 $T=579700 618800 1 0 $X=579700 $Y=613380
X3676 3100 2 3182 3161 1 NR2 $T=581560 618800 1 180 $X=579700 $Y=618420
X3677 3182 2 3079 3122 1 NR2 $T=581560 628880 0 180 $X=579700 $Y=623460
X3678 2869 2 3197 2691 1 NR2 $T=583420 608720 1 180 $X=581560 $Y=608340
X3679 3122 2 707 3203 1 NR2 $T=584660 659120 0 0 $X=584660 $Y=658740
X3680 3212 2 3221 708 1 NR2 $T=585280 538160 1 0 $X=585280 $Y=532740
X3681 3212 2 3228 2971 1 NR2 $T=585280 538160 0 0 $X=585280 $Y=537780
X3682 2966 2 3222 3200 1 NR2 $T=585280 638960 1 0 $X=585280 $Y=633540
X3683 3100 2 3234 2869 1 NR2 $T=587760 608720 1 180 $X=585900 $Y=608340
X3684 3195 2 3243 3219 1 NR2 $T=588380 618800 0 180 $X=586520 $Y=613380
X3685 3240 2 2959 3216 1 NR2 $T=590240 638960 0 180 $X=588380 $Y=633540
X3686 713 2 3258 507 1 NR2 $T=593340 538160 0 0 $X=593340 $Y=537780
X3687 638 2 730 550 1 NR2 $T=595200 699440 1 0 $X=595200 $Y=694020
X3688 3290 2 3098 2981 1 NR2 $T=597680 608720 1 180 $X=595820 $Y=608340
X3689 3195 2 3273 3197 1 NR2 $T=596440 608720 1 0 $X=596440 $Y=603300
X3690 3240 2 2973 3313 1 NR2 $T=598300 649040 1 0 $X=598300 $Y=643620
X3691 3119 2 3225 3315 1 NR2 $T=599540 669200 0 0 $X=599540 $Y=668820
X3692 3306 2 3271 3291 1 NR2 $T=602640 689360 0 180 $X=600780 $Y=683940
X3693 3313 2 2993 3322 1 NR2 $T=601400 649040 1 0 $X=601400 $Y=643620
X3694 3254 2 713 3321 1 NR2 $T=602020 538160 0 0 $X=602020 $Y=537780
X3695 3240 2 3315 2813 1 NR2 $T=602640 669200 0 0 $X=602640 $Y=668820
X3696 3157 2 743 3306 1 NR2 $T=606360 689360 0 180 $X=604500 $Y=683940
X3697 3014 2 3096 3355 1 NR2 $T=605120 649040 1 0 $X=605120 $Y=643620
X3698 755 2 3344 3343 1 NR2 $T=609460 588560 0 180 $X=607600 $Y=583140
X3699 3376 2 3092 3014 1 NR2 $T=613800 608720 1 180 $X=611940 $Y=608340
X3700 3328 2 3377 3364 1 NR2 $T=613800 638960 1 0 $X=613800 $Y=633540
X3701 712 2 3418 721 1 NR2 $T=613800 689360 1 0 $X=613800 $Y=683940
X3702 693 2 669 721 1 NR2 $T=616900 699440 0 180 $X=615040 $Y=694020
X3703 3097 2 772 3178 1 NR2 $T=621240 628880 0 180 $X=619380 $Y=623460
X3704 3424 2 3109 3306 1 NR2 $T=621860 659120 0 180 $X=620000 $Y=653700
X3705 3291 2 3426 3182 1 NR2 $T=621860 679280 1 0 $X=621860 $Y=673860
X3706 3390 2 2858 3182 1 NR2 $T=622480 638960 0 0 $X=622480 $Y=638580
X3707 3436 2 683 693 1 NR2 $T=624340 689360 1 180 $X=622480 $Y=688980
X3708 550 2 740 706 1 NR2 $T=622480 699440 1 0 $X=622480 $Y=694020
X3709 3291 2 3412 3234 1 NR2 $T=627440 608720 0 0 $X=627440 $Y=608340
X3710 3458 2 3450 3384 1 NR2 $T=629300 638960 1 180 $X=627440 $Y=638580
X3711 3376 2 3439 3200 1 NR2 $T=631160 608720 1 180 $X=629300 $Y=608340
X3712 3355 2 3158 3438 1 NR2 $T=632400 618800 0 180 $X=630540 $Y=613380
X3713 3322 2 3479 3365 1 NR2 $T=631780 638960 1 0 $X=631780 $Y=633540
X3714 3465 2 3442 3449 1 NR2 $T=633640 669200 0 180 $X=631780 $Y=663780
X3715 3216 2 3474 3322 1 NR2 $T=633640 628880 1 0 $X=633640 $Y=623460
X3716 3438 2 3489 3240 1 NR2 $T=636740 679280 0 180 $X=634880 $Y=673860
X3717 3157 2 3499 3203 1 NR2 $T=637980 618800 1 0 $X=637980 $Y=613380
X3718 3216 2 3368 3313 1 NR2 $T=637980 669200 1 0 $X=637980 $Y=663780
X3719 3147 2 3402 3182 1 NR2 $T=639220 618800 0 0 $X=639220 $Y=618420
X3720 3216 2 3493 3438 1 NR2 $T=639840 638960 0 0 $X=639840 $Y=638580
X3721 3182 2 3476 3157 1 NR2 $T=642320 669200 1 180 $X=640460 $Y=668820
X3722 3234 2 3503 3465 1 NR2 $T=643560 679280 0 180 $X=641700 $Y=673860
X3723 3147 2 811 3234 1 NR2 $T=645420 669200 1 180 $X=643560 $Y=668820
X3724 3306 2 635 3122 1 NR2 $T=646040 659120 1 180 $X=644180 $Y=658740
X3725 817 2 3488 3361 1 NR2 $T=646040 689360 0 180 $X=644180 $Y=683940
X3726 3339 2 823 3291 1 NR2 $T=644800 618800 1 0 $X=644800 $Y=613380
X3727 3147 2 686 3306 1 NR2 $T=646660 638960 0 0 $X=646660 $Y=638580
X3728 3182 2 3128 3234 1 NR2 $T=646660 669200 0 0 $X=646660 $Y=668820
X3729 3203 2 3387 3147 1 NR2 $T=650380 638960 1 180 $X=648520 $Y=638580
X3730 3424 2 826 3203 1 NR2 $T=648520 659120 0 0 $X=648520 $Y=658740
X3731 3494 2 3514 3203 1 NR2 $T=651620 649040 1 180 $X=649760 $Y=648660
X3732 3555 2 695 3203 1 NR2 $T=655960 689360 1 180 $X=654100 $Y=688980
X3733 725 2 3549 827 1 NR2 $T=656580 699440 0 180 $X=654720 $Y=694020
X3734 3533 2 3363 3555 1 NR2 $T=657820 689360 0 0 $X=657820 $Y=688980
X3735 3584 2 3553 3569 1 NR2 $T=662160 618800 1 180 $X=660300 $Y=618420
X3736 3438 2 3577 3313 1 NR2 $T=667740 669200 0 180 $X=665880 $Y=663780
X3737 3684 2 3685 3668 1 NR2 $T=687580 628880 0 180 $X=685720 $Y=623460
X3738 2903 2 920 660 1 NR2 $T=716720 518000 1 180 $X=714860 $Y=517620
X3739 3866 2 932 708 1 NR2 $T=727260 528080 1 180 $X=725400 $Y=527700
X3740 3866 2 937 663 1 NR2 $T=728500 528080 0 180 $X=726640 $Y=522660
X3741 3866 2 936 672 1 NR2 $T=730360 528080 1 180 $X=728500 $Y=527700
X3742 3866 2 4017 617 1 NR2 $T=755780 528080 0 0 $X=755780 $Y=527700
X3743 4014 2 4040 3984 1 NR2 $T=760740 638960 0 0 $X=760740 $Y=638580
X3744 4101 2 4104 4089 1 NR2 $T=778100 638960 0 0 $X=778100 $Y=638580
X3745 4276 2 4272 1013 1 NR2 $T=810340 528080 0 180 $X=808480 $Y=522660
X3746 4276 2 4279 1012 1 NR2 $T=810960 528080 1 180 $X=809100 $Y=527700
X3747 999 2 4246 4276 1 NR2 $T=809100 538160 1 0 $X=809100 $Y=532740
X3748 999 2 4255 4276 1 NR2 $T=809100 538160 0 0 $X=809100 $Y=537780
X3749 4276 2 4306 1024 1 NR2 $T=817160 528080 1 0 $X=817160 $Y=522660
X3750 4276 2 4322 1026 1 NR2 $T=819020 528080 1 0 $X=819020 $Y=522660
X3751 4276 2 4355 1031 1 NR2 $T=829560 528080 0 180 $X=827700 $Y=522660
X3752 4276 2 4369 1038 1 NR2 $T=829560 528080 0 0 $X=829560 $Y=527700
X3753 4276 2 4378 1040 1 NR2 $T=830800 518000 0 0 $X=830800 $Y=517620
X3754 4276 2 4417 1049 1 NR2 $T=837620 528080 0 0 $X=837620 $Y=527700
X3755 4276 2 4429 1053 1 NR2 $T=846920 528080 1 180 $X=845060 $Y=527700
X3756 4276 2 4453 806 1 NR2 $T=850020 538160 1 0 $X=850020 $Y=532740
X3757 4276 2 4445 810 1 NR2 $T=850020 538160 0 0 $X=850020 $Y=537780
X3758 4276 2 4471 918 1 NR2 $T=850640 528080 0 0 $X=850640 $Y=527700
X3759 4299 2 4455 4466 1 NR2 $T=851260 568400 1 0 $X=851260 $Y=562980
X3760 4276 2 4488 765 1 NR2 $T=857460 538160 1 0 $X=857460 $Y=532740
X3761 4299 2 4504 4511 1 NR2 $T=861800 558320 0 0 $X=861800 $Y=557940
X3762 4276 2 4509 807 1 NR2 $T=864900 538160 1 0 $X=864900 $Y=532740
X3763 4299 2 4486 4529 1 NR2 $T=866760 558320 1 0 $X=866760 $Y=552900
X3764 4299 2 4518 4543 1 NR2 $T=869860 558320 1 0 $X=869860 $Y=552900
X3765 4276 2 4539 860 1 NR2 $T=870480 528080 1 0 $X=870480 $Y=522660
X3766 4276 2 4527 769 1 NR2 $T=870480 538160 1 0 $X=870480 $Y=532740
X3767 4568 2 4578 4466 1 NR2 $T=879160 558320 0 180 $X=877300 $Y=552900
X3768 4586 2 4614 4567 1 NR2 $T=882260 538160 0 0 $X=882260 $Y=537780
X3769 4276 2 4841 1155 1 NR2 $T=943640 538160 0 180 $X=941780 $Y=532740
X3770 4276 2 4850 1149 1 NR2 $T=943640 538160 1 180 $X=941780 $Y=537780
X3771 4276 2 4871 441 1 NR2 $T=945500 538160 1 0 $X=945500 $Y=532740
X3772 4276 2 4873 448 1 NR2 $T=949840 548240 0 180 $X=947980 $Y=542820
X3773 1167 2 4877 1173 1 NR2 $T=952320 538160 0 0 $X=952320 $Y=537780
X3774 4276 2 4942 429 1 NR2 $T=959140 548240 1 0 $X=959140 $Y=542820
X3775 4276 2 4931 344 1 NR2 $T=962240 548240 1 0 $X=962240 $Y=542820
X3776 4276 2 4916 438 1 NR2 $T=965960 538160 1 180 $X=964100 $Y=537780
X3777 4276 2 4980 423 1 NR2 $T=969060 548240 0 180 $X=967200 $Y=542820
X3778 1173 2 4998 233 1 NR2 $T=972780 548240 1 0 $X=972780 $Y=542820
X3779 1173 2 5039 223 1 NR2 $T=986420 548240 0 180 $X=984560 $Y=542820
X3780 1173 2 5028 227 1 NR2 $T=989520 548240 0 180 $X=987660 $Y=542820
X3781 933 2 5076 1173 1 NR2 $T=990140 538160 0 0 $X=990140 $Y=537780
X3782 1173 2 5068 231 1 NR2 $T=990140 548240 1 0 $X=990140 $Y=542820
X3783 1173 2 5097 1072 1 NR2 $T=993240 538160 0 0 $X=993240 $Y=537780
X3784 1157 2 5129 5116 1 NR2 $T=1001920 578480 1 0 $X=1001920 $Y=573060
X3785 1157 2 5139 5141 1 NR2 $T=1005020 558320 0 0 $X=1005020 $Y=557940
X3786 1187 2 5167 1225 1 NR2 $T=1008740 497840 0 0 $X=1008740 $Y=497460
X3787 1157 2 5157 5168 1 NR2 $T=1009360 568400 0 0 $X=1009360 $Y=568020
X3788 1157 2 5211 5225 1 NR2 $T=1020520 578480 0 0 $X=1020520 $Y=578100
X3789 1175 2 5257 1233 1 NR2 $T=1026100 497840 0 0 $X=1026100 $Y=497460
X3790 5212 2 5277 5220 1 NR2 $T=1032920 558320 1 180 $X=1031060 $Y=557940
X3791 2716 2668 2 2631 1 2670 AOI12HS $T=513360 518000 1 180 $X=509020 $Y=517620
X3792 2805 2703 2 558 1 569 AOI12HS $T=528240 507920 0 180 $X=523900 $Y=502500
X3793 3365 3291 2 3413 1 3089 AOI12HS $T=644800 659120 1 0 $X=644800 $Y=653700
X3794 2936 1 2 2979 DELB $T=551180 528080 0 0 $X=551180 $Y=527700
X3795 2988 1 2 2904 DELB $T=555520 528080 1 0 $X=555520 $Y=522660
X3796 639 1 2 3072 DELB $T=559860 507920 1 0 $X=559860 $Y=502500
X3797 2949 1 2 2984 DELB $T=560480 528080 1 0 $X=560480 $Y=522660
X3798 3153 1 2 2971 DELB $T=575360 518000 1 0 $X=575360 $Y=512580
X3799 3179 1 2 3169 DELB $T=579080 507920 0 0 $X=579080 $Y=507540
X3800 3083 1 2 3045 DELB $T=581560 497840 0 0 $X=581560 $Y=497460
X3801 3296 1 2 3314 DELB $T=597060 528080 0 0 $X=597060 $Y=527700
X3802 3298 1 2 3343 DELB $T=608840 578480 0 0 $X=608840 $Y=578100
X3803 841 1 2 853 DELB $T=659680 507920 0 0 $X=659680 $Y=507540
X3804 847 1 2 3587 DELB $T=661540 507920 1 0 $X=661540 $Y=502500
X3805 3551 1 2 3564 DELB $T=663400 699440 1 0 $X=663400 $Y=694020
X3806 3594 1 2 3615 DELB $T=664640 568400 0 0 $X=664640 $Y=568020
X3807 854 1 2 3614 DELB $T=665260 507920 0 0 $X=665260 $Y=507540
X3808 3599 1 2 3617 DELB $T=665260 518000 1 0 $X=665260 $Y=512580
X3809 3596 1 2 3604 DELB $T=665880 679280 1 0 $X=665880 $Y=673860
X3810 856 1 2 861 DELB $T=666500 507920 1 0 $X=666500 $Y=502500
X3811 3621 1 2 3635 DELB $T=671460 568400 1 0 $X=671460 $Y=562980
X3812 865 1 2 3639 DELB $T=672080 507920 1 0 $X=672080 $Y=502500
X3813 3660 1 2 3675 DELB $T=681380 558320 1 0 $X=681380 $Y=552900
X3814 3663 1 2 3654 DELB $T=682000 518000 0 0 $X=682000 $Y=517620
X3815 3646 1 2 3632 DELB $T=682620 578480 0 0 $X=682620 $Y=578100
X3816 3672 1 2 3665 DELB $T=683860 689360 1 0 $X=683860 $Y=683940
X3817 3680 1 2 3699 DELB $T=686340 558320 1 0 $X=686340 $Y=552900
X3818 890 1 2 896 DELB $T=688820 528080 1 0 $X=688820 $Y=522660
X3819 3679 1 2 3697 DELB $T=690680 538160 0 0 $X=690680 $Y=537780
X3820 3704 1 2 3706 DELB $T=693160 518000 1 0 $X=693160 $Y=512580
X3821 3719 1 2 3742 DELB $T=696260 568400 0 0 $X=696260 $Y=568020
X3822 3728 1 2 3725 DELB $T=697500 689360 1 0 $X=697500 $Y=683940
X3823 3734 1 2 3754 DELB $T=698740 538160 0 0 $X=698740 $Y=537780
X3824 903 1 2 908 DELB $T=699360 518000 1 0 $X=699360 $Y=512580
X3825 3756 1 2 3776 DELB $T=703700 538160 0 0 $X=703700 $Y=537780
X3826 3761 1 2 3766 DELB $T=704320 518000 1 0 $X=704320 $Y=512580
X3827 3798 1 2 3811 DELB $T=711760 689360 1 0 $X=711760 $Y=683940
X3828 923 1 2 928 DELB $T=717340 518000 1 0 $X=717340 $Y=512580
X3829 3844 1 2 3850 DELB $T=722920 548240 0 0 $X=722920 $Y=547860
X3830 3853 1 2 3849 DELB $T=724780 518000 0 0 $X=724780 $Y=517620
X3831 3875 1 2 3841 DELB $T=729120 538160 0 0 $X=729120 $Y=537780
X3832 3883 1 2 3904 DELB $T=729740 608720 0 0 $X=729740 $Y=608340
X3833 3900 1 2 3886 DELB $T=733460 628880 0 0 $X=733460 $Y=628500
X3834 3899 1 2 3905 DELB $T=734080 538160 0 0 $X=734080 $Y=537780
X3835 3930 1 2 3953 DELB $T=740280 618800 0 0 $X=740280 $Y=618420
X3836 3938 1 2 934 DELB $T=742140 679280 0 0 $X=742140 $Y=678900
X3837 3946 1 2 3925 DELB $T=743380 538160 0 0 $X=743380 $Y=537780
X3838 3952 1 2 3936 DELB $T=744620 558320 1 0 $X=744620 $Y=552900
X3839 948 1 2 951 DELB $T=745240 497840 0 0 $X=745240 $Y=497460
X3840 3955 1 2 3970 DELB $T=745240 618800 0 0 $X=745240 $Y=618420
X3841 3966 1 2 3902 DELB $T=748340 538160 0 0 $X=748340 $Y=537780
X3842 3972 1 2 3942 DELB $T=750200 598640 0 0 $X=750200 $Y=598260
X3843 3974 1 2 3928 DELB $T=750820 558320 0 0 $X=750820 $Y=557940
X3844 3976 1 2 3937 DELB $T=750820 598640 1 0 $X=750820 $Y=593220
X3845 3927 1 2 3912 DELB $T=753300 538160 0 0 $X=753300 $Y=537780
X3846 3948 1 2 3956 DELB $T=754540 558320 1 0 $X=754540 $Y=552900
X3847 3994 1 2 3988 DELB $T=755780 558320 0 0 $X=755780 $Y=557940
X3848 4035 1 2 3957 DELB $T=763840 598640 1 0 $X=763840 $Y=593220
X3849 4095 1 2 967 DELB $T=775000 659120 1 0 $X=775000 $Y=653700
X3850 4108 1 2 992 DELB $T=779960 659120 1 0 $X=779960 $Y=653700
X3851 4120 1 2 3975 DELB $T=780580 598640 1 0 $X=780580 $Y=593220
X3852 4136 1 2 4159 DELB $T=783060 628880 1 0 $X=783060 $Y=623460
X3853 4156 1 2 3969 DELB $T=786780 598640 1 0 $X=786780 $Y=593220
X3854 4173 1 2 4172 DELB $T=789880 628880 0 0 $X=789880 $Y=628500
X3855 4196 1 2 996 DELB $T=795460 669200 1 0 $X=795460 $Y=663780
X3856 4208 1 2 4239 DELB $T=796080 628880 1 0 $X=796080 $Y=623460
X3857 4114 1 2 4124 DELB $T=801040 628880 1 0 $X=801040 $Y=623460
X3858 4317 1 2 3983 DELB $T=819640 598640 0 0 $X=819640 $Y=598260
X3859 4423 1 2 4019 DELB $T=846300 618800 1 0 $X=846300 $Y=613380
X3860 4601 1 2 4582 DELB $T=884120 528080 1 0 $X=884120 $Y=522660
X3861 4602 1 2 4461 DELB $T=884120 618800 1 0 $X=884120 $Y=613380
X3862 4627 1 2 4643 DELB $T=888460 598640 0 0 $X=888460 $Y=598260
X3863 4631 1 2 4650 DELB $T=889700 618800 0 0 $X=889700 $Y=618420
X3864 4741 1 2 4561 DELB $T=914500 608720 0 0 $X=914500 $Y=608340
X3865 4776 1 2 4691 DELB $T=924420 638960 0 0 $X=924420 $Y=638580
X3866 4791 1 2 4685 DELB $T=927520 618800 0 0 $X=927520 $Y=618420
X3867 4830 1 2 4687 DELB $T=939920 628880 1 0 $X=939920 $Y=623460
X3868 4876 1 2 4708 DELB $T=947360 628880 1 0 $X=947360 $Y=623460
X3869 4952 1 2 4640 DELB $T=961620 638960 0 0 $X=961620 $Y=638580
X3870 5077 1 2 4699 DELB $T=992620 638960 1 0 $X=992620 $Y=633540
X3871 5107 1 2 4721 DELB $T=996960 649040 0 0 $X=996960 $Y=648660
X3872 5183 1 2 4700 DELB $T=1013700 649040 1 0 $X=1013700 $Y=643620
X3873 5207 1 2 5210 DELB $T=1018660 548240 1 0 $X=1018660 $Y=542820
X3874 5244 1 2 4742 DELB $T=1025480 628880 1 0 $X=1025480 $Y=623460
X3875 5259 1 2 4752 DELB $T=1027960 638960 0 0 $X=1027960 $Y=638580
X3876 5369 1 2 4749 DELB $T=1052760 628880 0 0 $X=1052760 $Y=628500
X3877 278 2 1 318 BUF1 $T=347200 699440 1 0 $X=347200 $Y=694020
X3878 435 2 1 2060 BUF1 $T=450740 669200 1 180 $X=448260 $Y=668820
X3879 456 2 1 2224 BUF1 $T=475540 649040 0 180 $X=473060 $Y=643620
X3880 468 2 1 2177 BUF1 $T=482980 659120 0 180 $X=480500 $Y=653700
X3881 2636 2 1 435 BUF1 $T=505300 679280 0 180 $X=502820 $Y=673860
X3882 2944 2 1 316 BUF1 $T=549320 548240 0 180 $X=546840 $Y=542820
X3883 2982 2 1 327 BUF1 $T=553040 538160 0 0 $X=553040 $Y=537780
X3884 2945 2 1 508 BUF1 $T=565440 598640 0 180 $X=562960 $Y=593220
X3885 3110 2 1 319 BUF1 $T=568540 548240 1 0 $X=568540 $Y=542820
X3886 3345 2 1 499 BUF1 $T=610700 588560 1 180 $X=608220 $Y=588180
X3887 914 2 1 3568 BUF1 $T=709900 659120 1 0 $X=709900 $Y=653700
X3888 2903 2 1 3866 BUF1 $T=722920 507920 1 0 $X=722920 $Y=502500
X3889 3817 2 1 3854 BUF1 $T=722920 528080 1 0 $X=722920 $Y=522660
X3890 1029 2 1 4361 BUF1 $T=843200 538160 1 180 $X=840720 $Y=537780
X3891 4474 2 1 3890 BUF1 $T=856840 598640 1 180 $X=854360 $Y=598260
X3892 1065 2 1 4286 BUF1 $T=862420 528080 1 180 $X=859940 $Y=527700
X3893 1052 2 1 4840 BUF1 $T=996960 578480 0 180 $X=994480 $Y=573060
X3894 1175 2 1 1187 BUF1 $T=999440 497840 0 0 $X=999440 $Y=497460
X3895 1052 2 1 5224 BUF1 $T=1039120 568400 0 0 $X=1039120 $Y=568020
X3896 2914 1 2 631 BUF1S $T=544980 558320 0 0 $X=544980 $Y=557940
X3897 3688 1 2 3684 BUF1S $T=687580 628880 1 0 $X=687580 $Y=623460
X3898 3645 1 2 3718 BUF1S $T=692540 608720 1 0 $X=692540 $Y=603300
X3899 3769 1 2 3736 BUF1S $T=706800 528080 1 0 $X=706800 $Y=522660
X3900 3795 1 2 3794 BUF1S $T=711760 618800 1 0 $X=711760 $Y=613380
X3901 3794 1 2 3797 BUF1S $T=711760 628880 0 0 $X=711760 $Y=628500
X3902 3867 1 2 3864 BUF1S $T=727880 628880 1 0 $X=727880 $Y=623460
X3903 3968 1 2 941 BUF1S $T=749580 689360 0 0 $X=749580 $Y=688980
X3904 3757 1 2 4014 BUF1S $T=770040 608720 1 0 $X=770040 $Y=603300
X3905 4109 1 2 4101 BUF1S $T=778720 628880 1 0 $X=778720 $Y=623460
X3906 4147 1 2 973 BUF1S $T=785540 659120 0 0 $X=785540 $Y=658740
X3907 4215 1 2 4212 BUF1S $T=796700 689360 0 0 $X=796700 $Y=688980
X3908 4212 1 2 1007 BUF1S $T=800420 699440 1 0 $X=800420 $Y=694020
X3909 4267 1 2 1009 BUF1S $T=807860 659120 0 0 $X=807860 $Y=658740
X3910 4733 1 2 4724 BUF1S $T=912020 588560 1 180 $X=909540 $Y=588180
X3911 4768 1 2 4779 BUF1S $T=923180 548240 1 0 $X=923180 $Y=542820
X3912 4744 1 2 4785 BUF1S $T=928140 568400 1 0 $X=928140 $Y=562980
X3913 193 2 1 190 BUF3 $T=288300 638960 0 0 $X=288300 $Y=638580
X3914 1736 2 1 221 BUF3 $T=299460 649040 1 180 $X=295740 $Y=648660
X3915 258 2 1 338 BUF3 $T=369520 638960 0 0 $X=369520 $Y=638580
X3916 2586 2 1 398 BUF3 $T=471200 638960 0 180 $X=467480 $Y=633540
X3917 3218 2 1 3588 BUF3 $T=656580 538160 1 0 $X=656580 $Y=532740
X3918 1173 2 1 4276 BUF3 $T=972780 548240 0 180 $X=969060 $Y=542820
X3919 1460 99 2 1410 1431 1 OR3B2 $T=248000 528080 0 180 $X=244280 $Y=522660
X3920 1491 80 2 1518 1414 1 OR3B2 $T=259160 548240 1 180 $X=255440 $Y=547860
X3921 1597 167 2 1604 1613 1 OR3B2 $T=271560 659120 1 0 $X=271560 $Y=653700
X3922 1623 181 2 1627 19 1 OR3B2 $T=278380 528080 1 0 $X=278380 $Y=522660
X3923 2131 2137 2 2114 2050 1 OR3B2 $T=390600 649040 1 0 $X=390600 $Y=643620
X3924 2743 510 2 2808 571 1 OR3B2 $T=524520 679280 1 0 $X=524520 $Y=673860
X3925 2983 3044 2 3026 3043 1 OR3B2 $T=559860 649040 0 0 $X=559860 $Y=648660
X3926 3219 3176 2 2876 3125 1 OR3B2 $T=590860 618800 1 0 $X=590860 $Y=613380
X3927 1340 2 53 1383 1380 1 NR3 $T=231260 538160 1 0 $X=231260 $Y=532740
X3928 1366 2 33 1376 1378 1 NR3 $T=232500 518000 0 0 $X=232500 $Y=517620
X3929 1395 2 74 1410 72 1 NR3 $T=238080 528080 0 0 $X=238080 $Y=527700
X3930 16 2 86 4 94 1 NR3 $T=244280 497840 1 180 $X=241180 $Y=497460
X3931 1457 2 1448 1443 1447 1 NR3 $T=247380 558320 0 180 $X=244280 $Y=552900
X3932 1477 2 98 1448 1431 1 NR3 $T=251100 528080 1 180 $X=248000 $Y=527700
X3933 1376 2 86 1476 112 1 NR3 $T=248620 507920 1 0 $X=248620 $Y=502500
X3934 1501 2 1506 123 1499 1 NR3 $T=254200 518000 0 0 $X=254200 $Y=517620
X3935 1577 2 1623 59 1474 1 NR3 $T=265980 518000 1 180 $X=262880 $Y=517620
X3936 1575 2 147 1513 1600 1 NR3 $T=265360 518000 1 0 $X=265360 $Y=512580
X3937 1587 2 1579 145 1542 1 NR3 $T=265980 548240 1 0 $X=265980 $Y=542820
X3938 4 2 1640 188 1632 1 NR3 $T=278380 558320 1 0 $X=278380 $Y=552900
X3939 1684 2 1675 1476 1648 1 NR3 $T=287680 548240 1 180 $X=284580 $Y=547860
X3940 1476 2 199 188 135 1 NR3 $T=285820 528080 0 0 $X=285820 $Y=527700
X3941 1435 2 1675 1640 1689 1 NR3 $T=285820 538160 0 0 $X=285820 $Y=537780
X3942 1737 2 226 1719 228 1 NR3 $T=300080 497840 1 180 $X=296980 $Y=497460
X3943 1748 2 1376 154 1749 1 NR3 $T=302560 507920 1 180 $X=299460 $Y=507540
X3944 1668 2 205 1684 1773 1 NR3 $T=303800 548240 0 0 $X=303800 $Y=547860
X3945 249 2 1775 1780 1701 1 NR3 $T=306280 528080 0 0 $X=306280 $Y=527700
X3946 1798 2 1836 1443 1867 1 NR3 $T=325500 548240 1 0 $X=325500 $Y=542820
X3947 1863 2 24 174 279 1 NR3 $T=328600 497840 0 0 $X=328600 $Y=497460
X3948 1880 2 1579 1887 1882 1 NR3 $T=332940 538160 1 0 $X=332940 $Y=532740
X3949 299 2 298 292 1874 1 NR3 $T=339760 507920 0 0 $X=339760 $Y=507540
X3950 1925 2 1971 1955 2004 1 NR3 $T=359600 638960 1 180 $X=356500 $Y=638580
X3951 2652 2 2642 2660 2666 1 NR3 $T=502820 649040 1 0 $X=502820 $Y=643620
X3952 503 2 2683 2678 2686 1 NR3 $T=509640 699440 0 180 $X=506540 $Y=694020
X3953 2700 2 2677 2691 2706 1 NR3 $T=513980 659120 1 180 $X=510880 $Y=658740
X3954 2882 2 605 2734 2900 1 NR3 $T=540640 679280 0 180 $X=537540 $Y=673860
X3955 2902 2 2917 627 2928 1 NR3 $T=543120 669200 1 0 $X=543120 $Y=663780
X3956 2913 2 556 630 2935 1 NR3 $T=544360 689360 1 0 $X=544360 $Y=683940
X3957 2991 2 2824 3005 2990 1 NR3 $T=554900 679280 1 0 $X=554900 $Y=673860
X3958 3026 2 2964 2975 3001 1 NR3 $T=559860 649040 1 180 $X=556760 $Y=648660
X3959 3052 2 3037 657 3041 1 NR3 $T=562340 679280 0 180 $X=559240 $Y=673860
X3960 2895 2 3085 3094 3062 1 NR3 $T=564820 689360 0 0 $X=564820 $Y=688980
X3961 3016 2 3148 3151 687 1 NR3 $T=572880 659120 1 0 $X=572880 $Y=653700
X3962 2941 2 2979 2984 3164 1 NR3 $T=573500 538160 0 0 $X=573500 $Y=537780
X3963 3180 2 696 3189 3051 1 NR3 $T=579080 689360 1 0 $X=579080 $Y=683940
X3964 3172 2 3187 3167 3146 1 NR3 $T=579700 598640 1 0 $X=579700 $Y=593220
X3965 3215 2 3200 3201 3190 1 NR3 $T=585280 628880 0 180 $X=582180 $Y=623460
X3966 3242 2 2999 3205 3194 1 NR3 $T=589000 598640 1 180 $X=585900 $Y=598260
X3967 713 2 277 507 3245 1 NR3 $T=593960 548240 1 0 $X=593960 $Y=542820
X3968 3303 2 3175 3276 731 1 NR3 $T=597680 659120 1 180 $X=594580 $Y=658740
X3969 3312 2 3316 3327 2912 1 NR3 $T=600780 659120 1 0 $X=600780 $Y=653700
X3970 3319 2 748 3340 3346 1 NR3 $T=605740 638960 1 0 $X=605740 $Y=633540
X3971 3400 2 3405 3415 2924 1 NR3 $T=618140 689360 1 0 $X=618140 $Y=683940
X3972 3171 2 3413 3354 3451 1 NR3 $T=628060 659120 1 0 $X=628060 $Y=653700
X3973 3470 2 3464 3486 3460 1 NR3 $T=633640 649040 1 0 $X=633640 $Y=643620
X3974 3257 2 3508 3515 813 1 NR3 $T=640460 689360 0 0 $X=640460 $Y=688980
X3975 3504 2 3562 3508 839 1 NR3 $T=656580 669200 0 0 $X=656580 $Y=668820
X3976 104 1397 1 216 1717 1682 2 OAI112HS $T=290780 518000 1 0 $X=290780 $Y=512580
X3977 2671 2680 1 2657 2655 2644 2 OAI112HS $T=507160 618800 1 180 $X=502820 $Y=618420
X3978 2720 2717 1 581 2839 522 2 OAI112HS $T=528240 649040 0 0 $X=528240 $Y=648660
X3979 2857 328 1 2818 2708 2835 2 OAI112HS $T=536920 608720 0 180 $X=532580 $Y=603300
X3980 2906 2712 1 2744 2826 2843 2 OAI112HS $T=537540 628880 1 180 $X=533200 $Y=628500
X3981 565 544 1 2909 2910 2923 2 OAI112HS $T=541260 659120 1 0 $X=541260 $Y=653700
X3982 2691 2857 1 2738 2927 2963 2 OAI112HS $T=547460 598640 0 0 $X=547460 $Y=598260
X3983 575 702 1 3198 3005 3032 2 OAI112HS $T=584660 679280 0 180 $X=580320 $Y=673860
X3984 593 738 1 735 3297 3118 2 OAI112HS $T=602640 699440 0 180 $X=598300 $Y=694020
X3985 592 2795 1 3358 3364 3366 2 OAI112HS $T=608220 638960 0 0 $X=608220 $Y=638580
X3986 633 3476 1 3043 3470 3399 2 OAI112HS $T=635500 649040 1 180 $X=631160 $Y=648660
X3987 522 628 1 3423 3504 3421 2 OAI112HS $T=635500 669200 0 0 $X=635500 $Y=668820
X3988 670 811 1 3386 809 3490 2 OAI112HS $T=642320 689360 0 180 $X=637980 $Y=683940
X3989 648 3514 1 3572 3562 3537 2 OAI112HS $T=662780 659120 0 180 $X=658440 $Y=653700
X3990 4135 4112 4081 2 1 4062 XOR3S $T=781200 558320 0 180 $X=770040 $Y=552900
X3991 4155 4046 4151 2 1 4116 XOR3S $T=786780 578480 0 0 $X=786780 $Y=578100
X3992 1010 1009 4228 2 1 4201 XOR3S $T=808480 679280 0 180 $X=797320 $Y=673860
X3993 4257 1009 4227 2 1 4206 XOR3S $T=811580 669200 0 180 $X=800420 $Y=663780
X3994 5006 5013 5029 2 1 5049 XOR3S $T=976500 628880 1 0 $X=976500 $Y=623460
X3995 5121 5166 5136 2 1 5124 XOR3S $T=1013080 638960 0 180 $X=1001920 $Y=633540
X3996 5472 5483 1274 2 1 5501 XOR3S $T=1081900 548240 1 0 $X=1081900 $Y=542820
X3997 3580 3627 2 874 876 1 3647 FA1 $T=663400 669200 0 0 $X=663400 $Y=668820
X3998 3600 863 2 874 3631 1 3664 FA1 $T=665260 679280 0 0 $X=665260 $Y=678900
X3999 3641 3681 2 889 3647 1 3710 FA1 $T=676420 669200 1 0 $X=676420 $Y=663780
X4000 3659 891 2 889 3664 1 3708 FA1 $T=680760 679280 1 0 $X=680760 $Y=673860
X4001 3689 3730 2 902 894 1 3760 FA1 $T=688200 689360 0 0 $X=688200 $Y=688980
X4002 3693 905 2 900 3708 1 3773 FA1 $T=690060 669200 0 0 $X=690060 $Y=668820
X4003 3703 3748 2 900 3710 1 3772 FA1 $T=691920 659120 0 0 $X=691920 $Y=658740
X4004 3750 3802 2 915 3760 1 3835 FA1 $T=701840 699440 1 0 $X=701840 $Y=694020
X4005 3749 3805 2 922 3772 1 3826 FA1 $T=703700 669200 1 0 $X=703700 $Y=663780
X4006 3740 926 2 922 3773 1 3839 FA1 $T=708660 669200 0 0 $X=708660 $Y=668820
X4007 3824 3865 2 938 3826 1 3887 FA1 $T=717960 659120 0 0 $X=717960 $Y=658740
X4008 3827 931 2 938 3839 1 3914 FA1 $T=718580 679280 1 0 $X=718580 $Y=673860
X4009 3872 3924 2 946 3887 1 3951 FA1 $T=727880 669200 1 0 $X=727880 $Y=663780
X4010 3918 3959 2 950 3951 1 3998 FA1 $T=735940 659120 0 0 $X=735940 $Y=658740
X4011 3920 947 2 946 3914 1 4000 FA1 $T=738420 679280 1 0 $X=738420 $Y=673860
X4012 3947 954 2 950 4000 1 4018 FA1 $T=743380 669200 0 0 $X=743380 $Y=668820
X4013 3993 964 2 967 4018 1 4092 FA1 $T=757640 679280 1 0 $X=757640 $Y=673860
X4014 4023 4036 2 973 4025 1 4115 FA1 $T=761980 669200 0 0 $X=761980 $Y=668820
X4015 4051 977 2 4107 968 1 4121 FA1 $T=765700 699440 1 0 $X=765700 $Y=694020
X4016 4111 4158 2 996 4115 1 4197 FA1 $T=778720 679280 1 0 $X=778720 $Y=673860
X4017 4123 983 2 996 4070 1 4222 FA1 $T=782440 689360 1 0 $X=782440 $Y=683940
X4018 989 1003 2 4212 4121 1 1006 FA1 $T=784920 699440 1 0 $X=784920 $Y=694020
X4019 1320 1306 1335 2 1 XNR2HS $T=223200 689360 1 0 $X=223200 $Y=683940
X4020 1357 1300 1394 2 1 XNR2HS $T=233740 649040 0 0 $X=233740 $Y=648660
X4021 138 1550 1522 2 1 XNR2HS $T=264120 558320 1 180 $X=258540 $Y=557940
X4022 1595 1550 1566 2 1 XNR2HS $T=271560 558320 1 180 $X=265980 $Y=557940
X4023 1697 1550 1713 2 1 XNR2HS $T=289540 558320 0 0 $X=289540 $Y=557940
X4024 1969 1955 1959 2 1 XNR2HS $T=353400 618800 0 0 $X=353400 $Y=618420
X4025 2053 2085 2067 2 1 XNR2HS $T=381920 659120 0 0 $X=381920 $Y=658740
X4026 2082 2083 2089 2 1 XNR2HS $T=385020 659120 1 0 $X=385020 $Y=653700
X4027 376 378 2152 2 1 XNR2HS $T=393080 699440 1 0 $X=393080 $Y=694020
X4028 2673 2669 2653 2 1 XNR2HS $T=507780 679280 1 180 $X=502200 $Y=678900
X4029 2704 2669 2681 2 1 XNR2HS $T=512120 679280 0 180 $X=506540 $Y=673860
X4030 2719 2669 501 2 1 XNR2HS $T=513980 679280 1 180 $X=508400 $Y=678900
X4031 673 3105 3083 2 1 XNR2HS $T=570400 497840 1 180 $X=564820 $Y=497460
X4032 3882 3874 3848 2 1 XNR2HS $T=730980 497840 1 180 $X=725400 $Y=497460
X4033 3916 942 3882 2 1 XNR2HS $T=737800 497840 1 180 $X=732220 $Y=497460
X4034 936 920 4290 2 1 XNR2HS $T=810960 649040 0 0 $X=810960 $Y=648660
X4035 4540 4555 4557 2 1 XNR2HS $T=872340 578480 1 0 $X=872340 $Y=573060
X4036 1082 4594 4577 2 1 XNR2HS $T=881020 507920 1 0 $X=881020 $Y=502500
X4037 4614 4588 4637 2 1 XNR2HS $T=887220 548240 1 0 $X=887220 $Y=542820
X4038 4753 4755 4766 2 1 XNR2HS $T=918220 568400 0 0 $X=918220 $Y=568020
X4039 61 105 2 1 98 OR2 $T=251720 507920 1 180 $X=249240 $Y=507540
X4040 140 1556 2 1 1534 OR2 $T=264740 528080 1 180 $X=262260 $Y=527700
X4041 33 126 2 1 188 OR2 $T=279620 528080 0 0 $X=279620 $Y=527700
X4042 154 1729 2 1 1765 OR2 $T=310000 507920 0 180 $X=307520 $Y=502500
X4043 1537 68 2 1 255 OR2 $T=312480 518000 1 180 $X=310000 $Y=517620
X4044 335 334 2 1 1978 OR2 $T=358360 507920 1 180 $X=355880 $Y=507540
X4045 2050 2060 2 1 2093 OR2 $T=380680 699440 1 0 $X=380680 $Y=694020
X4046 2674 2677 2 1 2671 OR2 $T=507780 649040 1 0 $X=507780 $Y=643620
X4047 507 2860 2 1 2825 OR2 $T=541260 528080 0 180 $X=538780 $Y=522660
X4048 512 609 2 1 2954 OR2 $T=547460 659120 1 0 $X=547460 $Y=653700
X4049 335 334 2 1 2957 OR2 $T=548700 568400 0 0 $X=548700 $Y=568020
X4050 2732 3100 2 1 3119 OR2 $T=567300 628880 1 0 $X=567300 $Y=623460
X4051 2733 3100 2 1 3059 OR2 $T=569780 628880 1 0 $X=569780 $Y=623460
X4052 3246 3228 2 1 3226 OR2 $T=591480 538160 1 180 $X=589000 $Y=537780
X4053 2903 708 2 1 866 OR2 $T=670220 507920 0 0 $X=670220 $Y=507540
X4054 1350 1367 1 1356 45 1308 2 MOAI1S $T=233740 538160 1 180 $X=230020 $Y=537780
X4055 1367 1404 1 75 78 1425 2 MOAI1S $T=238080 538160 1 0 $X=238080 $Y=532740
X4056 93 24 1 79 1385 1416 2 MOAI1S $T=244280 518000 0 180 $X=240560 $Y=512580
X4057 1435 95 1 91 88 1407 2 MOAI1S $T=245520 518000 1 180 $X=241800 $Y=517620
X4058 1367 1483 1 114 1497 117 2 MOAI1S $T=250480 538160 1 0 $X=250480 $Y=532740
X4059 136 1546 1 1498 1537 1506 2 MOAI1S $T=262880 538160 1 180 $X=259160 $Y=537780
X4060 1531 1731 1 237 47 243 2 MOAI1S $T=299460 518000 0 0 $X=299460 $Y=517620
X4061 1531 1776 1 1779 47 1775 2 MOAI1S $T=306900 518000 1 0 $X=306900 $Y=512580
X4062 1482 136 1 1784 114 1780 2 MOAI1S $T=307520 548240 0 0 $X=307520 $Y=547860
X4063 1812 236 1 271 236 1834 2 MOAI1S $T=318680 679280 0 0 $X=318680 $Y=678900
X4064 515 2724 1 513 512 2683 2 MOAI1S $T=515840 699440 0 180 $X=512120 $Y=694020
X4065 511 515 1 2723 520 2734 2 MOAI1S $T=512740 689360 0 0 $X=512740 $Y=688980
X4066 323 328 1 2737 523 2745 2 MOAI1S $T=515220 608720 1 0 $X=515220 $Y=603300
X4067 2750 2652 1 2677 2737 2766 2 MOAI1S $T=518940 608720 0 0 $X=518940 $Y=608340
X4068 2791 556 1 553 528 2770 2 MOAI1S $T=525760 689360 0 180 $X=522040 $Y=683940
X4069 2864 2831 1 2849 2720 2841 2 MOAI1S $T=536920 628880 0 180 $X=533200 $Y=623460
X4070 2791 2839 1 516 593 2832 2 MOAI1S $T=538160 649040 1 180 $X=534440 $Y=648660
X4071 2896 2927 1 548 2911 2799 2 MOAI1S $T=546840 608720 0 180 $X=543120 $Y=603300
X4072 2903 2936 1 2903 2952 2982 2 MOAI1S $T=548700 538160 0 0 $X=548700 $Y=537780
X4073 2979 629 1 629 2952 2944 2 MOAI1S $T=553040 548240 0 180 $X=549320 $Y=542820
X4074 638 573 1 2977 640 2796 2 MOAI1S $T=555520 689360 1 180 $X=551800 $Y=688980
X4075 2903 2941 1 2995 2903 3006 2 MOAI1S $T=553660 538160 1 0 $X=553660 $Y=532740
X4076 2941 629 1 629 2995 3024 2 MOAI1S $T=556140 538160 0 0 $X=556140 $Y=537780
X4077 3075 3080 1 663 3063 3054 2 MOAI1S $T=566680 518000 1 180 $X=562960 $Y=517620
X4078 3104 3080 1 660 3063 3028 2 MOAI1S $T=567920 507920 1 180 $X=564200 $Y=507540
X4079 2903 2984 1 3077 2903 3060 2 MOAI1S $T=567920 538160 1 180 $X=564200 $Y=537780
X4080 2984 629 1 629 3077 3110 2 MOAI1S $T=564820 548240 1 0 $X=564820 $Y=542820
X4081 3055 3080 1 672 3063 3116 2 MOAI1S $T=567300 528080 1 0 $X=567300 $Y=522660
X4082 3009 3080 1 3114 2995 3078 2 MOAI1S $T=567920 548240 0 0 $X=567920 $Y=547860
X4083 3081 3080 1 3114 3077 3115 2 MOAI1S $T=567920 558320 1 0 $X=567920 $Y=552900
X4084 3155 3080 1 3114 3140 3132 2 MOAI1S $T=575980 548240 1 180 $X=572260 $Y=547860
X4085 2777 693 1 671 3020 3143 2 MOAI1S $T=578460 638960 0 180 $X=574740 $Y=633540
X4086 2791 694 1 2852 3119 689 2 MOAI1S $T=579080 689360 1 180 $X=575360 $Y=688980
X4087 617 3080 1 617 3063 3204 2 MOAI1S $T=587140 518000 1 180 $X=583420 $Y=517620
X4088 3192 3080 1 3114 2952 3202 2 MOAI1S $T=587140 558320 0 180 $X=583420 $Y=552900
X4089 3231 3080 1 708 3063 3244 2 MOAI1S $T=588380 518000 0 0 $X=588380 $Y=517620
X4090 507 3207 1 3274 3293 3296 2 MOAI1S $T=597060 528080 1 0 $X=597060 $Y=522660
X4091 2945 3269 1 3298 733 2781 2 MOAI1S $T=600780 558320 1 180 $X=597060 $Y=557940
X4092 2945 3305 1 3298 729 2856 2 MOAI1S $T=600780 568400 0 180 $X=597060 $Y=562980
X4093 3014 3306 1 3273 3097 3013 2 MOAI1S $T=600780 628880 0 180 $X=597060 $Y=623460
X4094 2945 3260 1 3298 736 2926 2 MOAI1S $T=602640 588560 0 180 $X=598920 $Y=583140
X4095 3291 2966 1 685 2997 3328 2 MOAI1S $T=600780 628880 0 0 $X=600780 $Y=628500
X4096 3355 3325 1 695 662 3327 2 MOAI1S $T=609460 659120 0 180 $X=605740 $Y=653700
X4097 3216 3351 1 3098 3097 3340 2 MOAI1S $T=610080 628880 1 180 $X=606360 $Y=628500
X4098 3291 3361 1 592 2795 750 2 MOAI1S $T=611940 689360 0 180 $X=608220 $Y=683940
X4099 3165 3365 1 3092 3059 3384 2 MOAI1S $T=611320 628880 1 0 $X=611320 $Y=623460
X4100 2777 693 1 3097 3168 3413 2 MOAI1S $T=623720 638960 0 180 $X=620000 $Y=633540
X4101 3034 573 1 3402 2977 793 2 MOAI1S $T=627440 699440 1 0 $X=627440 $Y=694020
X4102 3203 3473 1 3097 3248 3464 2 MOAI1S $T=633640 628880 0 180 $X=629920 $Y=623460
X4103 573 3280 1 3493 3159 3458 2 MOAI1S $T=636740 649040 1 0 $X=636740 $Y=643620
X4104 3494 3355 1 594 628 3486 2 MOAI1S $T=643560 659120 0 180 $X=639840 $Y=653700
X4105 3203 3473 1 3073 3065 3316 2 MOAI1S $T=642320 649040 0 0 $X=642320 $Y=648660
X4106 718 824 1 635 3061 3515 2 MOAI1S $T=649760 689360 1 180 $X=646040 $Y=688980
X4107 3203 3313 1 648 3160 3550 2 MOAI1S $T=652240 638960 1 0 $X=652240 $Y=633540
X4108 4580 4474 1 3854 4474 4536 2 MOAI1S $T=877300 588560 1 180 $X=873580 $Y=588180
X4109 5379 4798 1 3854 4798 5339 2 MOAI1S $T=1053380 608720 1 180 $X=1049660 $Y=608340
X4110 1426 79 1 1331 68 2 1447 92 102 OAI222S $T=241800 548240 1 0 $X=241800 $Y=542820
X4111 1427 32 1 78 91 2 1510 1513 23 OAI222S $T=252340 507920 0 0 $X=252340 $Y=507540
X4112 1495 114 1 1481 32 2 1507 124 104 OAI222S $T=252340 528080 1 0 $X=252340 $Y=522660
X4113 1530 104 1 129 23 2 1540 127 47 OAI222S $T=256680 497840 0 0 $X=256680 $Y=497460
X4114 1521 79 1 1533 102 2 1542 132 114 OAI222S $T=257300 548240 1 0 $X=257300 $Y=542820
X4115 1641 68 1 1656 39 2 1663 197 47 OAI222S $T=279620 507920 1 0 $X=279620 $Y=502500
X4116 1733 79 1 1741 114 2 1732 1737 45 OAI222S $T=298220 548240 1 0 $X=298220 $Y=542820
X4117 265 1385 1 1830 79 2 263 1818 184 OAI222S $T=323640 518000 0 180 $X=318060 $Y=512580
X4118 1882 45 1 1867 102 2 1842 1835 114 OAI222S $T=333560 538160 1 180 $X=327980 $Y=537780
X4119 2956 2962 1 2969 2795 2 2974 2836 2997 OAI222S $T=549940 618800 1 0 $X=549940 $Y=613380
X4120 671 3091 1 666 589 2 3046 3085 3059 OAI222S $T=568540 689360 0 180 $X=562960 $Y=683940
X4121 2906 2771 1 3092 2733 2 2963 3074 658 OAI222S $T=569780 618800 1 180 $X=564200 $Y=618420
X4122 653 609 1 3109 662 2 626 2882 679 OAI222S $T=566680 669200 0 0 $X=566680 $Y=668820
X4123 3097 3107 1 3082 3120 2 3146 3151 671 OAI222S $T=570400 608720 1 0 $X=570400 $Y=603300
X4124 3079 658 1 686 659 2 2906 3127 3159 OAI222S $T=571020 638960 0 0 $X=571020 $Y=638580
X4125 529 609 1 2852 3160 2 3119 3180 2977 OAI222S $T=572880 689360 1 0 $X=572880 $Y=683940
X4126 3071 3065 1 3158 3161 2 3170 3141 2869 OAI222S $T=573500 618800 0 0 $X=573500 $Y=618420
X4127 648 3059 1 3159 658 2 692 3148 2938 OAI222S $T=573500 649040 0 0 $X=573500 $Y=648660
X4128 701 608 1 695 2977 2 3121 3094 579 OAI222S $T=582180 699440 0 180 $X=576600 $Y=694020
X4129 575 3031 1 635 2997 2 3109 3312 633 OAI222S $T=594580 659120 1 0 $X=594580 $Y=653700
X4130 3237 734 1 3218 3233 2 3281 3300 3278 OAI222S $T=601400 538160 1 180 $X=595820 $Y=537780
X4131 746 626 1 3289 671 2 692 3319 2938 OAI222S $T=607600 638960 1 180 $X=602020 $Y=638580
X4132 544 542 1 3356 3046 2 3363 758 662 OAI222S $T=607600 689360 0 0 $X=607600 $Y=688980
X4133 3426 670 1 3418 2938 2 749 3415 613 OAI222S $T=623720 679280 1 180 $X=618140 $Y=678900
X4134 3417 671 1 3412 2866 2 3120 781 3248 OAI222S $T=620620 608720 1 0 $X=620620 $Y=603300
X4135 796 575 1 3363 3488 2 804 3481 608 OAI222S $T=633640 699440 1 0 $X=633640 $Y=694020
X4136 1351 2 1343 1 1346 NR2P $T=231880 628880 0 180 $X=228160 $Y=623460
X4137 1351 2 1388 1 1417 NR2P $T=238700 628880 0 0 $X=238700 $Y=628500
X4138 1615 2 1628 1 1599 NR2P $T=277760 628880 1 180 $X=274040 $Y=628500
X4139 1615 2 1665 1 1659 NR2P $T=285200 638960 0 180 $X=281480 $Y=633540
X4140 1615 2 1616 1 1660 NR2P $T=286440 638960 1 0 $X=286440 $Y=633540
X4141 221 2 1726 1 1449 NR2P $T=300080 659120 0 180 $X=296360 $Y=653700
X4142 1943 2 1954 1 1925 NR2P $T=350920 649040 0 180 $X=347200 $Y=643620
X4143 1938 2 1943 1 1931 NR2P $T=348440 659120 1 0 $X=348440 $Y=653700
X4144 1943 2 1970 1 1971 NR2P $T=355260 649040 0 180 $X=351540 $Y=643620
X4145 1943 2 1984 1 1955 NR2P $T=357740 649040 1 0 $X=357740 $Y=643620
X4146 2131 2 2155 1 2098 NR2P $T=394940 659120 1 0 $X=394940 $Y=653700
X4147 2131 2 2159 1 2148 NR2P $T=400520 659120 1 180 $X=396800 $Y=658740
X4148 2131 2 2194 1 2124 NR2P $T=406720 669200 0 180 $X=403000 $Y=663780
X4149 617 2 2903 1 323 NR2P $T=540640 507920 0 0 $X=540640 $Y=507540
X4150 617 2 629 1 1936 NR2P $T=545600 507920 0 0 $X=545600 $Y=507540
X4151 3152 2 3254 1 723 NR2P $T=590240 497840 0 0 $X=590240 $Y=497460
X4152 3254 2 3278 1 507 NR2P $T=598300 538160 1 0 $X=598300 $Y=532740
X4153 708 2 3817 1 325 NR2P $T=718580 507920 0 0 $X=718580 $Y=507540
X4154 4568 2 4511 1 4586 NR2P $T=878540 548240 0 180 $X=874820 $Y=542820
X4155 1173 2 1216 1 5128 NR2P $T=1003160 538160 0 180 $X=999440 $Y=532740
X4156 1173 2 1218 1 5131 NR2P $T=1003160 538160 1 0 $X=1003160 $Y=532740
X4157 5188 2 5141 1 5203 NR2P $T=1013700 558320 0 0 $X=1013700 $Y=557940
X4158 5188 2 5116 1 5212 NR2P $T=1019280 558320 0 180 $X=1015560 $Y=552900
X4159 84 76 1 2 BUF2 $T=242420 649040 1 180 $X=239320 $Y=648660
X4160 1787 269 1 2 BUF2 $T=315580 659120 1 0 $X=315580 $Y=653700
X4161 3006 335 1 2 BUF2 $T=558000 538160 1 0 $X=558000 $Y=532740
X4162 3060 334 1 2 BUF2 $T=563580 538160 1 180 $X=560480 $Y=537780
X4163 3588 987 1 2 BUF2 $T=781200 649040 1 0 $X=781200 $Y=643620
X4164 2946 3207 3218 3221 3226 2903 2 1 3232 OA222S $T=583420 528080 0 0 $X=583420 $Y=527700
X4165 106 1605 1 30 2 1682 OAI12HS $T=285820 507920 0 0 $X=285820 $Y=507540
X4166 1705 1659 1 1677 2 1671 OAI12HS $T=289540 628880 1 180 $X=285820 $Y=628500
X4167 2153 2147 1 2143 2 2117 OAI12HS $T=397420 638960 1 180 $X=393700 $Y=638580
X4168 2730 2729 1 2744 2 2625 OAI12HS $T=515840 628880 0 0 $X=515840 $Y=628500
X4169 3436 722 1 2777 2 3463 OAI12HS $T=626200 689360 0 0 $X=626200 $Y=688980
X4170 3449 3157 1 3438 2 3490 OAI12HS $T=637360 679280 1 0 $X=637360 $Y=673860
X4171 3234 3306 1 817 2 3534 OAI12HS $T=648520 628880 1 0 $X=648520 $Y=623460
X4172 1068 4496 1 4482 2 4490 OAI12HS $T=862420 548240 0 180 $X=858700 $Y=542820
X4173 4657 3854 1 4642 2 4419 OAI12HS $T=895900 638960 1 180 $X=892180 $Y=638580
X4174 2761 2657 2766 548 2 2777 1 AOI13HS $T=520800 618800 0 0 $X=520800 $Y=618420
X4175 2797 2818 2712 2700 2 2717 1 AOI13HS $T=530720 598640 1 180 $X=527000 $Y=598260
X4176 3228 3114 3250 629 2 3245 1 AOI13HS $T=590240 548240 0 0 $X=590240 $Y=547860
X4177 2713 1 2642 528 2700 2 ND3S $T=515220 669200 1 0 $X=515220 $Y=663780
X4178 2753 1 2700 527 2672 2 ND3S $T=520800 659120 1 180 $X=518320 $Y=658740
X4179 3258 1 682 3214 3218 2 ND3S $T=592720 538160 0 180 $X=590240 $Y=532740
X4180 3318 1 3293 682 3278 2 ND3S $T=598920 518000 1 180 $X=596440 $Y=517620
X4181 47 1348 23 1344 32 1338 1 2 1318 OA222 $T=231880 518000 0 180 $X=226300 $Y=512580
X4182 47 1354 46 44 39 36 1 2 1314 OA222 $T=233740 497840 1 180 $X=228160 $Y=497460
X4183 79 1369 68 1380 45 1386 1 2 56 OA222 $T=239940 548240 0 180 $X=234360 $Y=542820
X4184 114 1529 104 1490 102 1511 1 2 1328 OA222 $T=260400 538160 0 180 $X=254820 $Y=532740
X4185 130 142 104 139 79 1548 1 2 1543 OA222 $T=266600 507920 1 180 $X=261020 $Y=507540
X4186 88 252 79 1768 114 1706 1 2 1757 OA222 $T=309380 518000 1 180 $X=303800 $Y=517620
X4187 39 1683 23 1793 263 1789 1 2 1806 OA222 $T=311860 497840 0 0 $X=311860 $Y=497460
X4188 88 261 45 1803 265 1807 1 2 1815 OA222 $T=313100 507920 0 0 $X=313100 $Y=507540
X4189 120 114 265 1841 172 47 1 2 1832 OA222 $T=327360 507920 1 180 $X=321780 $Y=507540
X4190 547 520 589 590 592 593 1 2 2872 OA222 $T=531340 659120 0 0 $X=531340 $Y=658740
X4191 2877 2866 531 2811 596 595 1 2 2848 OA222 $T=539400 669200 1 180 $X=533820 $Y=668820
X4192 551 2842 575 602 553 606 1 2 2883 OA222 $T=535060 699440 1 0 $X=535060 $Y=694020
X4193 527 553 633 635 497 544 1 2 2961 OA222 $T=546220 669200 1 0 $X=546220 $Y=663780
X4194 2747 2953 628 2935 2892 2943 1 2 2907 OA222 $T=552420 638960 1 180 $X=546840 $Y=638580
X4195 640 2973 544 2940 589 647 1 2 3002 OA222 $T=551180 689360 1 0 $X=551180 $Y=683940
X4196 3059 2997 668 3079 553 664 1 2 3058 OA222 $T=568540 669200 0 180 $X=562960 $Y=663780
X4197 3059 2906 3097 3093 596 612 1 2 3068 OA222 $T=569780 649040 1 180 $X=564200 $Y=648660
X4198 553 516 613 669 671 3093 1 2 3111 OA222 $T=564200 679280 0 0 $X=564200 $Y=678900
X4199 3125 3097 3073 3096 553 3038 1 2 3076 OA222 $T=570400 649040 0 180 $X=564820 $Y=643620
X4200 679 628 3107 3097 2977 3073 1 2 3049 OA222 $T=571020 638960 0 180 $X=565440 $Y=633540
X4201 3091 3120 626 676 658 3079 1 2 3053 OA222 $T=572880 659120 1 180 $X=567300 $Y=658740
X4202 668 3128 589 677 575 3067 1 2 3102 OA222 $T=573500 689360 1 180 $X=567920 $Y=688980
X4203 3046 685 2877 3061 3107 3120 1 2 3000 OA222 $T=574740 628880 1 180 $X=569160 $Y=628500
X4204 671 3174 613 3162 527 688 1 2 3144 OA222 $T=579700 679280 0 180 $X=574120 $Y=673860
X4205 2866 685 3159 2997 3160 633 1 2 2967 OA222 $T=580940 669200 0 180 $X=575360 $Y=663780
X4206 3159 648 685 2993 3059 2959 1 2 3211 OA222 $T=578460 638960 0 0 $X=578460 $Y=638580
X4207 3120 3178 626 692 3117 671 1 2 2950 OA222 $T=579080 628880 0 0 $X=579080 $Y=628500
X4208 679 628 658 685 652 626 1 2 3137 OA222 $T=584660 659120 1 180 $X=579080 $Y=658740
X4209 3073 2892 3120 3194 3097 3185 1 2 2899 OA222 $T=585280 608720 0 180 $X=579700 $Y=603300
X4210 544 2768 3059 3222 608 716 1 2 3272 OA222 $T=585280 649040 0 0 $X=585280 $Y=648660
X4211 527 589 3065 3109 652 628 1 2 3299 OA222 $T=586520 659120 0 0 $X=586520 $Y=658740
X4212 575 699 2877 2973 596 720 1 2 3150 OA222 $T=595820 679280 0 180 $X=590240 $Y=673860
X4213 544 730 608 727 3061 3271 1 2 3163 OA222 $T=598920 689360 0 180 $X=593340 $Y=683940
X4214 633 3073 3125 3120 3266 3097 1 2 3308 OA222 $T=594580 628880 0 0 $X=594580 $Y=628500
X4215 671 3107 2877 2997 3160 2906 1 2 3332 OA222 $T=595820 638960 1 0 $X=595820 $Y=633540
X4216 3248 671 3266 3120 2866 685 1 2 3335 OA222 $T=600780 628880 1 0 $X=600780 $Y=623460
X4217 553 756 662 759 544 760 1 2 3357 OA222 $T=608220 699440 1 0 $X=608220 $Y=694020
X4218 592 2892 3119 3368 2866 686 1 2 3367 OA222 $T=609460 669200 1 0 $X=609460 $Y=663780
X4219 628 683 542 596 547 575 1 2 3396 OA222 $T=610080 679280 1 0 $X=610080 $Y=673860
X4220 3120 3168 2852 3387 626 740 1 2 3358 OA222 $T=618760 638960 1 180 $X=613180 $Y=638580
X4221 3095 671 3061 3402 658 3412 1 2 776 OA222 $T=616280 618800 1 0 $X=616280 $Y=613380
X4222 589 786 3065 3442 3439 3387 1 2 3350 OA222 $T=629300 669200 0 180 $X=623720 $Y=663780
X4223 2977 3387 613 794 2877 633 1 2 3477 OA222 $T=629300 638960 0 0 $X=629300 $Y=638580
X4224 2977 3503 3489 3476 608 805 1 2 799 OA222 $T=641700 679280 1 180 $X=636120 $Y=678900
X4225 668 3514 3160 648 662 3119 1 2 3469 OA222 $T=646040 649040 0 180 $X=640460 $Y=643620
X4226 2852 3570 3160 3577 628 3549 1 2 3586 OA222 $T=657200 689360 1 0 $X=657200 $Y=683940
X4227 3152 710 713 2 1 3237 OA12S $T=586520 548240 0 0 $X=586520 $Y=547860
X4228 155 172 1609 2 1 1427 AN3 $T=276520 518000 0 180 $X=272800 $Y=512580
X4229 1658 189 182 2 1 1426 AN3 $T=282720 538160 1 180 $X=279000 $Y=537780
X4230 1472 109 201 2 1 1683 AN3 $T=283960 497840 0 0 $X=283960 $Y=497460
X4231 73 158 196 2 1 119 AN3 $T=296360 507920 0 180 $X=292640 $Y=502500
X4232 2711 2691 2722 2 1 2730 AN3 $T=512120 628880 0 0 $X=512120 $Y=628500
X4233 2741 2691 2717 2 1 550 AN3 $T=520180 649040 0 0 $X=520180 $Y=648660
X4234 2972 2980 645 2 1 2909 AN3 $T=552420 649040 0 0 $X=552420 $Y=648660
X4235 3135 3101 3118 2 1 3027 AN3 $T=572880 659120 0 180 $X=569160 $Y=653700
X4236 3068 3102 3112 2 1 3135 AN3 $T=572880 659120 0 0 $X=572880 $Y=658740
X4237 3252 3256 3262 2 1 2996 AN3 $T=591480 638960 1 0 $X=591480 $Y=633540
X4238 3377 3416 3409 2 1 3118 AN3 $T=622480 638960 1 180 $X=618760 $Y=638580
X4239 780 3432 3386 2 1 3456 AN3 $T=623100 659120 1 0 $X=623100 $Y=653700
X4240 3461 3008 3469 2 1 2923 AN3 $T=629300 659120 0 0 $X=629300 $Y=658740
X4241 3477 3482 3268 2 1 3421 AN3 $T=633640 628880 0 0 $X=633640 $Y=628500
X4242 1978 1936 325 327 1 2 304 OA13S $T=357120 518000 0 180 $X=352780 $Y=512580
X4243 1345 38 2 1 1330 15 MUX2 $T=229400 669200 0 180 $X=225060 $Y=663780
X4244 1365 38 2 1 1333 22 MUX2 $T=230640 679280 1 180 $X=226300 $Y=678900
X4245 1352 38 2 1 1320 27 MUX2 $T=231260 689360 1 180 $X=226920 $Y=688980
X4246 1363 38 2 1 48 60 MUX2 $T=231880 699440 1 0 $X=231880 $Y=694020
X4247 1389 50 2 1 43 52 MUX2 $T=236840 689360 1 180 $X=232500 $Y=688980
X4248 1396 50 2 1 54 57 MUX2 $T=238700 659120 1 180 $X=234360 $Y=658740
X4249 1406 50 2 1 15 64 MUX2 $T=241180 699440 0 180 $X=236840 $Y=694020
X4250 1421 85 2 1 57 69 MUX2 $T=241800 679280 1 180 $X=237460 $Y=678900
X4251 1392 50 2 1 55 65 MUX2 $T=242420 689360 0 180 $X=238080 $Y=683940
X4252 1451 85 2 1 65 89 MUX2 $T=246760 699440 0 180 $X=242420 $Y=694020
X4253 1480 76 2 1 69 103 MUX2 $T=251720 699440 0 180 $X=247380 $Y=694020
X4254 1502 76 2 1 1451 1480 MUX2 $T=254820 689360 1 180 $X=250480 $Y=688980
X4255 1479 76 2 1 1445 1489 MUX2 $T=256060 679280 0 180 $X=251720 $Y=673860
X4256 1617 169 2 1 1573 159 MUX2 $T=275280 699440 0 180 $X=270940 $Y=694020
X4257 1611 169 2 1 1572 163 MUX2 $T=277140 679280 0 180 $X=272800 $Y=673860
X4258 1629 167 2 1 163 170 MUX2 $T=279000 689360 0 180 $X=274660 $Y=683940
X4259 1649 169 2 1 1580 168 MUX2 $T=280240 679280 1 180 $X=275900 $Y=678900
X4260 1647 167 2 1 168 176 MUX2 $T=281480 689360 1 180 $X=277140 $Y=688980
X4261 1646 167 2 1 186 185 MUX2 $T=282720 679280 0 180 $X=278380 $Y=673860
X4262 1634 167 2 1 183 195 MUX2 $T=279000 699440 1 0 $X=279000 $Y=694020
X4263 1674 167 2 1 162 1647 MUX2 $T=285200 689360 0 180 $X=280860 $Y=683940
X4264 1678 141 2 1 1634 1654 MUX2 $T=285820 669200 0 180 $X=281480 $Y=663780
X4265 1679 141 2 1 1629 1672 MUX2 $T=288920 679280 0 180 $X=284580 $Y=673860
X4266 1672 141 2 1 185 1680 MUX2 $T=290780 679280 1 180 $X=286440 $Y=678900
X4267 1654 141 2 1 1647 1681 MUX2 $T=290780 689360 0 180 $X=286440 $Y=683940
X4268 1681 141 2 1 195 204 MUX2 $T=290780 699440 0 180 $X=286440 $Y=694020
X4269 1716 190 2 1 1680 1692 MUX2 $T=293260 689360 1 180 $X=288920 $Y=688980
X4270 1718 190 2 1 1654 1699 MUX2 $T=294500 669200 0 180 $X=290160 $Y=663780
X4271 1699 190 2 1 1672 1703 MUX2 $T=295120 669200 1 180 $X=290780 $Y=668820
X4272 1692 190 2 1 204 213 MUX2 $T=295740 699440 0 180 $X=291400 $Y=694020
X4273 1946 315 2 1 1879 308 MUX2 $T=348440 669200 1 180 $X=344100 $Y=668820
X4274 1947 315 2 1 1888 309 MUX2 $T=348440 679280 0 180 $X=344100 $Y=673860
X4275 1949 315 2 1 1899 310 MUX2 $T=349060 689360 1 180 $X=344720 $Y=688980
X4276 1933 318 2 1 307 311 MUX2 $T=350300 689360 0 180 $X=345960 $Y=683940
X4277 1965 318 2 1 308 321 MUX2 $T=355260 689360 1 180 $X=350920 $Y=688980
X4278 1981 269 2 1 1933 1960 MUX2 $T=355880 659120 1 180 $X=351540 $Y=658740
X4279 1974 318 2 1 313 320 MUX2 $T=355880 679280 1 180 $X=351540 $Y=678900
X4280 1985 318 2 1 293 1965 MUX2 $T=357740 669200 1 180 $X=353400 $Y=668820
X4281 1980 318 2 1 314 324 MUX2 $T=358980 689360 0 180 $X=354640 $Y=683940
X4282 1992 269 2 1 321 330 MUX2 $T=358980 699440 0 180 $X=354640 $Y=694020
X4283 2002 269 2 1 311 331 MUX2 $T=360220 689360 1 180 $X=355880 $Y=688980
X4284 2012 269 2 1 1965 1999 MUX2 $T=363940 669200 1 180 $X=359600 $Y=668820
X4285 1960 269 2 1 320 2002 MUX2 $T=364560 679280 0 180 $X=360220 $Y=673860
X4286 2014 338 2 1 330 336 MUX2 $T=364560 699440 0 180 $X=360220 $Y=694020
X4287 1999 269 2 1 324 1992 MUX2 $T=365180 689360 0 180 $X=360840 $Y=683940
X4288 2028 338 2 1 1960 2013 MUX2 $T=365800 669200 0 180 $X=361460 $Y=663780
X4289 2032 338 2 1 331 2014 MUX2 $T=365800 689360 1 180 $X=361460 $Y=688980
X4290 2031 338 2 1 2012 2028 MUX2 $T=368280 659120 1 180 $X=363940 $Y=658740
X4291 2042 338 2 1 2002 2035 MUX2 $T=370760 679280 1 180 $X=366420 $Y=678900
X4292 2035 338 2 1 1992 2032 MUX2 $T=371380 689360 0 180 $X=367040 $Y=683940
X4293 2223 2224 2 1 2191 2199 MUX2 $T=412920 649040 0 180 $X=408580 $Y=643620
X4294 2240 2224 2 1 2175 2200 MUX2 $T=414780 638960 1 180 $X=410440 $Y=638580
X4295 2206 2209 2 1 2216 2237 MUX2 $T=410440 669200 1 0 $X=410440 $Y=663780
X4296 2217 2209 2 1 2156 2243 MUX2 $T=411060 669200 0 0 $X=411060 $Y=668820
X4297 2245 2209 2 1 2180 2275 MUX2 $T=417260 669200 0 0 $X=417260 $Y=668820
X4298 2200 2224 2 1 2260 2281 MUX2 $T=417880 638960 1 0 $X=417880 $Y=633540
X4299 2247 2209 2 1 2256 2278 MUX2 $T=419740 679280 1 0 $X=419740 $Y=673860
X4300 2175 2177 2 1 2280 2284 MUX2 $T=420360 638960 0 0 $X=420360 $Y=638580
X4301 2269 2177 2 1 2287 2260 MUX2 $T=422220 649040 0 0 $X=422220 $Y=648660
X4302 2270 2066 2 1 2288 2280 MUX2 $T=423460 669200 1 0 $X=423460 $Y=663780
X4303 2117 2066 2 1 2193 2291 MUX2 $T=424700 669200 0 0 $X=424700 $Y=668820
X4304 2284 2177 2 1 2291 2301 MUX2 $T=425940 649040 1 0 $X=425940 $Y=643620
X4305 2281 2224 2 1 2284 2302 MUX2 $T=426560 638960 0 0 $X=426560 $Y=638580
X4306 2287 2066 2 1 2243 2338 MUX2 $T=426560 659120 0 0 $X=426560 $Y=658740
X4307 2260 2177 2 1 2312 2306 MUX2 $T=427180 659120 1 0 $X=427180 $Y=653700
X4308 413 399 2 1 415 416 MUX2 $T=429040 699440 1 0 $X=429040 $Y=694020
X4309 2188 2209 2 1 2298 2317 MUX2 $T=430280 669200 0 0 $X=430280 $Y=668820
X4310 2329 2224 2 1 2301 2308 MUX2 $T=436480 649040 0 180 $X=432140 $Y=643620
X4311 2280 2066 2 1 2275 2332 MUX2 $T=432140 669200 1 0 $X=432140 $Y=663780
X4312 2302 2224 2 1 2306 2329 MUX2 $T=432760 638960 0 0 $X=432760 $Y=638580
X4313 2301 2177 2 1 2332 2334 MUX2 $T=432760 649040 0 0 $X=432760 $Y=648660
X4314 2288 2209 2 1 2327 2345 MUX2 $T=432760 679280 1 0 $X=432760 $Y=673860
X4315 2291 2066 2 1 2278 2373 MUX2 $T=436480 669200 0 0 $X=436480 $Y=668820
X4316 2306 2177 2 1 2338 2387 MUX2 $T=438340 649040 0 0 $X=438340 $Y=648660
X4317 2308 2224 2 1 2387 2369 MUX2 $T=441440 649040 1 0 $X=441440 $Y=643620
X4318 2193 2209 2 1 2411 2412 MUX2 $T=445160 679280 1 0 $X=445160 $Y=673860
X4319 2403 2066 2 1 2434 2437 MUX2 $T=451980 669200 0 0 $X=451980 $Y=668820
X4320 2430 2066 2 1 2463 2437 MUX2 $T=456940 669200 1 0 $X=456940 $Y=663780
X4321 2458 2431 2 1 2487 2437 MUX2 $T=463760 669200 0 0 $X=463760 $Y=668820
X4322 2412 2431 2 1 2492 2437 MUX2 $T=465000 679280 1 0 $X=465000 $Y=673860
X4323 2504 2066 2 1 2537 2500 MUX2 $T=473680 659120 0 0 $X=473680 $Y=658740
X4324 2395 2431 2 1 2539 2500 MUX2 $T=474920 669200 0 0 $X=474920 $Y=668820
X4325 2478 2431 2 1 2546 2500 MUX2 $T=475540 669200 1 0 $X=475540 $Y=663780
X4326 812 3447 2 1 3501 3513 MUX2 $T=640460 507920 1 0 $X=640460 $Y=502500
X4327 3643 3563 2 1 3668 3629 MUX2 $T=677660 618800 0 0 $X=677660 $Y=618420
X4328 3755 3563 2 1 3732 3716 MUX2 $T=703080 618800 1 180 $X=698740 $Y=618420
X4329 3722 3563 2 1 3795 3783 MUX2 $T=707420 618800 1 0 $X=707420 $Y=613380
X4330 3823 3817 2 1 3833 3849 MUX2 $T=717960 518000 0 0 $X=717960 $Y=517620
X4331 3849 3854 2 1 3844 3843 MUX2 $T=726640 558320 0 180 $X=722300 $Y=552900
X4332 3823 3854 2 1 3875 3885 MUX2 $T=725400 538160 1 0 $X=725400 $Y=532740
X4333 3823 3854 2 1 3834 3905 MUX2 $T=727880 548240 0 0 $X=727880 $Y=547860
X4334 3823 3854 2 1 3856 3902 MUX2 $T=727880 568400 1 0 $X=727880 $Y=562980
X4335 3905 3854 2 1 3906 3925 MUX2 $T=734080 548240 0 0 $X=734080 $Y=547860
X4336 3925 3854 2 1 3948 3945 MUX2 $T=739040 558320 1 0 $X=739040 $Y=552900
X4337 3928 3854 2 1 3821 3969 MUX2 $T=745860 558320 0 0 $X=745860 $Y=557940
X4338 3902 3854 2 1 3952 3958 MUX2 $T=750200 568400 1 180 $X=745860 $Y=568020
X4339 3945 3854 2 1 3972 3979 MUX2 $T=746480 588560 1 0 $X=746480 $Y=583140
X4340 3958 3854 2 1 3976 3975 MUX2 $T=747100 578480 0 0 $X=747100 $Y=578100
X4341 3843 3854 2 1 3994 4009 MUX2 $T=751440 568400 0 0 $X=751440 $Y=568020
X4342 3969 3854 2 1 3896 4019 MUX2 $T=765700 598640 1 180 $X=761360 $Y=598260
X4343 4009 3854 2 1 4035 4049 MUX2 $T=769420 588560 1 180 $X=765080 $Y=588180
X4344 4069 3563 2 1 4109 4103 MUX2 $T=774380 628880 1 0 $X=774380 $Y=623460
X4345 4118 3563 2 1 4128 4145 MUX2 $T=781200 618800 0 0 $X=781200 $Y=618420
X4346 4090 3563 2 1 4225 4231 MUX2 $T=794840 628880 0 0 $X=794840 $Y=628500
X4347 4260 4259 2 1 4140 4246 MUX2 $T=806620 548240 0 180 $X=802280 $Y=542820
X4348 4256 4259 2 1 4232 4246 MUX2 $T=807860 538160 1 180 $X=803520 $Y=537780
X4349 4275 4259 2 1 4229 4255 MUX2 $T=810340 558320 0 180 $X=806000 $Y=552900
X4350 4288 4259 2 1 4148 4255 MUX2 $T=810960 558320 1 180 $X=806620 $Y=557940
X4351 4277 4259 2 1 4199 4265 MUX2 $T=811580 548240 0 180 $X=807240 $Y=542820
X4352 4305 4299 2 1 4265 4246 MUX2 $T=816540 538160 1 180 $X=812200 $Y=537780
X4353 4310 4299 2 1 4300 4255 MUX2 $T=821500 558320 1 180 $X=817160 $Y=557940
X4354 4355 4286 2 1 4330 4322 MUX2 $T=827080 528080 0 180 $X=822740 $Y=522660
X4355 4365 4299 2 1 4335 4255 MUX2 $T=827700 558320 0 180 $X=823360 $Y=552900
X4356 4379 4259 2 1 4320 4277 MUX2 $T=832660 568400 0 180 $X=828320 $Y=562980
X4357 4415 4259 2 1 4385 4323 MUX2 $T=838860 568400 0 180 $X=834520 $Y=562980
X4358 4417 4286 2 1 4398 4369 MUX2 $T=840100 538160 0 180 $X=835760 $Y=532740
X4359 4429 4286 2 1 4414 4417 MUX2 $T=844440 528080 1 180 $X=840100 $Y=527700
X4360 4438 4259 2 1 4418 4302 MUX2 $T=844440 568400 0 180 $X=840100 $Y=562980
X4361 4445 4286 2 1 4430 4429 MUX2 $T=848160 538160 0 180 $X=843820 $Y=532740
X4362 4449 4299 2 1 4357 4431 MUX2 $T=850020 558320 1 180 $X=845680 $Y=557940
X4363 4463 1029 2 1 4437 4414 MUX2 $T=850640 548240 0 180 $X=846300 $Y=542820
X4364 4451 1029 2 1 4431 4430 MUX2 $T=850640 548240 1 180 $X=846300 $Y=547860
X4365 4460 4299 2 1 4291 4412 MUX2 $T=850640 558320 0 180 $X=846300 $Y=552900
X4366 4455 4259 2 1 4441 4352 MUX2 $T=851260 568400 0 180 $X=846920 $Y=562980
X4367 4470 1029 2 1 4464 4463 MUX2 $T=856220 548240 0 180 $X=851880 $Y=542820
X4368 4476 1029 2 1 4460 4451 MUX2 $T=856220 548240 1 180 $X=851880 $Y=547860
X4369 4453 1065 2 1 4463 4445 MUX2 $T=856840 538160 1 180 $X=852500 $Y=537780
X4370 4464 4299 2 1 4273 4387 MUX2 $T=856840 558320 0 180 $X=852500 $Y=552900
X4371 4471 4286 2 1 4451 4453 MUX2 $T=857460 538160 0 180 $X=853120 $Y=532740
X4372 4486 4259 2 1 4468 4273 MUX2 $T=857460 568400 0 180 $X=853120 $Y=562980
X4373 4488 4286 2 1 4470 4471 MUX2 $T=858700 528080 1 180 $X=854360 $Y=527700
X4374 4492 4299 2 1 4415 4460 MUX2 $T=859940 558320 1 180 $X=855600 $Y=557940
X4375 4501 4299 2 1 4379 4464 MUX2 $T=861800 548240 1 180 $X=857460 $Y=547860
X4376 4490 4299 2 1 4294 4437 MUX2 $T=862420 558320 0 180 $X=858080 $Y=552900
X4377 4509 1065 2 1 4476 4488 MUX2 $T=863660 538160 0 180 $X=859320 $Y=532740
X4378 4504 4259 2 1 4493 4291 MUX2 $T=863660 568400 0 180 $X=859320 $Y=562980
X4379 4522 1029 2 1 4449 4476 MUX2 $T=866760 548240 1 180 $X=862420 $Y=547860
X4380 4527 1065 2 1 4507 4509 MUX2 $T=868000 538160 1 180 $X=863660 $Y=537780
X4381 4518 4259 2 1 4540 4294 MUX2 $T=866760 568400 1 0 $X=866760 $Y=562980
X4382 4539 1065 2 1 4522 4527 MUX2 $T=875440 538160 1 180 $X=871100 $Y=537780
X4383 4545 4299 2 1 4438 4490 MUX2 $T=871720 558320 1 0 $X=871720 $Y=552900
X4384 4473 3854 2 1 4602 4648 MUX2 $T=889080 618800 1 0 $X=889080 $Y=613380
X4385 4473 3854 2 1 4403 4643 MUX2 $T=891560 628880 0 0 $X=891560 $Y=628500
X4386 4671 3854 2 1 4478 4640 MUX2 $T=897760 638960 0 180 $X=893420 $Y=633540
X4387 4473 3854 2 1 4448 4650 MUX2 $T=899000 618800 1 180 $X=894660 $Y=618420
X4388 4650 3854 2 1 4523 4687 MUX2 $T=895280 618800 1 0 $X=895280 $Y=613380
X4389 4643 3854 2 1 4500 4691 MUX2 $T=897760 628880 0 0 $X=897760 $Y=628500
X4390 4640 3854 2 1 4613 4700 MUX2 $T=899620 638960 1 0 $X=899620 $Y=633540
X4391 4691 3854 2 1 4678 4685 MUX2 $T=905200 628880 0 180 $X=900860 $Y=623460
X4392 4708 3854 2 1 4427 4699 MUX2 $T=908920 628880 1 180 $X=904580 $Y=628500
X4393 4687 3854 2 1 4538 4721 MUX2 $T=905820 638960 1 0 $X=905820 $Y=633540
X4394 4721 3854 2 1 4619 4742 MUX2 $T=910780 628880 0 0 $X=910780 $Y=628500
X4395 4699 3854 2 1 4342 4752 MUX2 $T=912020 638960 1 0 $X=912020 $Y=633540
X4396 4685 3854 2 1 4741 4748 MUX2 $T=921320 618800 0 180 $X=916980 $Y=613380
X4397 4890 1165 2 1 4831 1159 MUX2 $T=950460 497840 1 180 $X=946120 $Y=497460
X4398 4891 1165 2 1 4828 1160 MUX2 $T=950460 507920 0 180 $X=946120 $Y=502500
X4399 4910 1163 2 1 4859 4877 MUX2 $T=952940 568400 0 180 $X=948600 $Y=562980
X4400 4940 1163 2 1 4845 4877 MUX2 $T=957900 578480 1 180 $X=953560 $Y=578100
X4401 4894 1157 2 1 4929 4877 MUX2 $T=954180 568400 1 0 $X=954180 $Y=562980
X4402 4938 1163 2 1 4852 4877 MUX2 $T=958520 588560 0 180 $X=954180 $Y=583140
X4403 4966 1163 2 1 4855 4877 MUX2 $T=964100 588560 0 180 $X=959760 $Y=583140
X4404 4965 1157 2 1 4963 4877 MUX2 $T=969680 578480 0 180 $X=965340 $Y=573060
X4405 1193 1187 2 1 4979 1160 MUX2 $T=972780 497840 1 180 $X=968440 $Y=497460
X4406 4993 1157 2 1 4992 4877 MUX2 $T=975260 578480 1 180 $X=970920 $Y=578100
X4407 5039 1065 2 1 5014 4998 MUX2 $T=982080 548240 0 180 $X=977740 $Y=542820
X4408 5028 1065 2 1 5048 5039 MUX2 $T=981460 548240 0 0 $X=981460 $Y=547860
X4409 1207 1187 2 1 4997 1199 MUX2 $T=988900 507920 0 180 $X=984560 $Y=502500
X4410 5060 1029 2 1 5043 5014 MUX2 $T=989520 558320 1 180 $X=985180 $Y=557940
X4411 1208 1187 2 1 5037 1203 MUX2 $T=992000 497840 1 180 $X=987660 $Y=497460
X4412 5028 5053 2 1 5060 5068 MUX2 $T=987660 548240 0 0 $X=987660 $Y=547860
X4413 5081 1029 2 1 5052 5048 MUX2 $T=992620 558320 0 180 $X=988280 $Y=552900
X4414 5084 1157 2 1 5056 5018 MUX2 $T=993240 578480 0 180 $X=988900 $Y=573060
X4415 5083 1157 2 1 5065 5009 MUX2 $T=994480 568400 1 180 $X=990140 $Y=568020
X4416 5088 1157 2 1 5071 5052 MUX2 $T=995100 558320 1 180 $X=990760 $Y=557940
X4417 1214 1187 2 1 1211 1209 MUX2 $T=997580 497840 1 180 $X=993240 $Y=497460
X4418 5076 1065 2 1 5081 5068 MUX2 $T=997580 548240 0 180 $X=993240 $Y=542820
X4419 5093 1029 2 1 5083 5081 MUX2 $T=998820 558320 0 180 $X=994480 $Y=552900
X4420 5131 1065 2 1 5093 5097 MUX2 $T=1000680 538160 1 180 $X=996340 $Y=537780
X4421 5132 1029 2 1 5084 5060 MUX2 $T=1000680 558320 1 180 $X=996340 $Y=557940
X4422 5120 1157 2 1 5098 5083 MUX2 $T=1000680 568400 1 180 $X=996340 $Y=568020
X4423 1219 1165 2 1 5114 4891 MUX2 $T=1004400 507920 0 180 $X=1000060 $Y=502500
X4424 5129 1163 2 1 5151 5065 MUX2 $T=1001920 578480 0 0 $X=1001920 $Y=578100
X4425 5176 1157 2 1 5138 5084 MUX2 $T=1008740 578480 0 180 $X=1004400 $Y=573060
X4426 5138 1163 2 1 5158 4981 MUX2 $T=1004400 588560 1 0 $X=1004400 $Y=583140
X4427 5139 1163 2 1 5165 5042 MUX2 $T=1005020 568400 1 0 $X=1005020 $Y=562980
X4428 5167 1165 2 1 5145 5037 MUX2 $T=1009980 507920 0 180 $X=1005640 $Y=502500
X4429 5131 5053 2 1 5162 5128 MUX2 $T=1005640 548240 1 0 $X=1005640 $Y=542820
X4430 5162 1029 2 1 5155 5132 MUX2 $T=1012460 558320 1 180 $X=1008120 $Y=557940
X4431 5157 1163 2 1 5179 5056 MUX2 $T=1008740 578480 0 0 $X=1008740 $Y=578100
X4432 1226 1165 2 1 5174 1172 MUX2 $T=1016180 507920 0 180 $X=1011840 $Y=502500
X4433 5177 1187 2 1 5200 1208 MUX2 $T=1014320 497840 0 0 $X=1014320 $Y=497460
X4434 5211 1163 2 1 5186 5027 MUX2 $T=1018660 578480 1 180 $X=1014320 $Y=578100
X4435 5098 1163 2 1 5208 4960 MUX2 $T=1014940 578480 1 0 $X=1014940 $Y=573060
X4436 5200 1165 2 1 5228 4969 MUX2 $T=1018040 507920 1 0 $X=1018040 $Y=502500
X4437 1231 1165 2 1 5216 1181 MUX2 $T=1024860 497840 1 180 $X=1020520 $Y=497460
X4438 5257 1165 2 1 5273 4997 MUX2 $T=1028580 497840 0 0 $X=1028580 $Y=497460
X4439 1424 1370 1382 2 1 1353 QDFFRBS $T=243660 578480 0 180 $X=231880 $Y=573060
X4440 1691 191 1382 2 1 1740 QDFFRBS $T=288300 618800 0 0 $X=288300 $Y=618420
X4441 4777 1134 3876 2 1 4732 QDFFRBS $T=923800 578480 0 180 $X=912020 $Y=573060
X4442 479 435 2573 2 2487 2050 1 AO22S $T=491660 669200 1 180 $X=486700 $Y=668820
X4443 4079 984 4138 2 990 991 1 AO22S $T=782440 497840 0 0 $X=782440 $Y=497460
X4444 4754 1144 4819 2 4831 1147 1 AO22S $T=933720 497840 0 0 $X=933720 $Y=497460
X4445 1680 141 2 198 1 170 MUX2S $T=287680 689360 1 180 $X=283340 $Y=688980
X4446 2312 2066 2 2330 1 2237 MUX2S $T=432760 659120 1 0 $X=432760 $Y=653700
X4447 2338 2066 2 2371 1 2317 MUX2S $T=438340 659120 1 0 $X=438340 $Y=653700
X4448 2332 2066 2 2372 1 2345 MUX2S $T=438340 659120 0 0 $X=438340 $Y=658740
X4449 2058 2209 2 2377 1 2378 MUX2S $T=438960 679280 1 0 $X=438960 $Y=673860
X4450 2369 2224 2 2393 1 2334 MUX2S $T=440820 638960 1 0 $X=440820 $Y=633540
X4451 2243 2209 2 2395 1 2399 MUX2S $T=442680 669200 0 0 $X=442680 $Y=668820
X4452 2334 2177 2 2400 1 2373 MUX2S $T=443920 649040 0 0 $X=443920 $Y=648660
X4453 2330 2066 2 2402 1 2377 MUX2S $T=444540 659120 1 0 $X=444540 $Y=653700
X4454 2373 2066 2 2403 1 2412 MUX2S $T=444540 659120 0 0 $X=444540 $Y=658740
X4455 427 399 2 430 1 434 MUX2S $T=445160 699440 1 0 $X=445160 $Y=694020
X4456 2393 2224 2 2415 1 2422 MUX2S $T=447020 638960 0 0 $X=447020 $Y=638580
X4457 2387 2177 2 2422 1 2330 MUX2S $T=448260 649040 1 0 $X=448260 $Y=643620
X4458 2400 2177 2 2419 1 2372 MUX2S $T=454460 649040 1 180 $X=450120 $Y=648660
X4459 2371 2066 2 2428 1 2395 MUX2S $T=450120 659120 1 0 $X=450120 $Y=653700
X4460 2372 2066 2 2430 1 2458 MUX2S $T=450740 659120 0 0 $X=450740 $Y=658740
X4461 2278 2431 2 2434 1 2444 MUX2S $T=451980 679280 1 0 $X=451980 $Y=673860
X4462 2415 2224 2 2440 1 2400 MUX2S $T=453220 638960 0 0 $X=453220 $Y=638580
X4463 2422 2177 2 2447 1 2371 MUX2S $T=454460 649040 1 0 $X=454460 $Y=643620
X4464 442 399 2 443 1 446 MUX2S $T=455080 699440 1 0 $X=455080 $Y=694020
X4465 2419 2177 2 2441 1 2403 MUX2S $T=460040 649040 1 180 $X=455700 $Y=648660
X4466 2441 2177 2 2437 1 2430 MUX2S $T=460660 659120 0 180 $X=456320 $Y=653700
X4467 2275 2431 2 2458 1 2459 MUX2S $T=457560 669200 0 0 $X=457560 $Y=668820
X4468 2345 2431 2 2463 1 2474 MUX2S $T=458800 679280 1 0 $X=458800 $Y=673860
X4469 2440 2224 2 2457 1 2447 MUX2S $T=464380 638960 1 180 $X=460040 $Y=638580
X4470 2447 2177 2 2466 1 2402 MUX2S $T=460660 649040 1 0 $X=460660 $Y=643620
X4471 2457 2224 2 2476 1 2419 MUX2S $T=461900 638960 1 0 $X=461900 $Y=633540
X4472 2466 2177 2 2477 1 2428 MUX2S $T=461900 649040 0 0 $X=461900 $Y=648660
X4473 454 2224 2 2468 1 2441 MUX2S $T=466240 659120 1 180 $X=461900 $Y=658740
X4474 2237 2431 2 2478 1 2484 MUX2S $T=463140 669200 1 0 $X=463140 $Y=663780
X4475 2476 2224 2 454 1 2466 MUX2S $T=471200 649040 0 180 $X=466860 $Y=643620
X4476 2468 456 2 2500 1 2477 MUX2S $T=467480 649040 0 0 $X=467480 $Y=648660
X4477 2402 2066 2 2504 1 2478 MUX2S $T=468100 659120 0 0 $X=468100 $Y=658740
X4478 2428 2066 2 2500 1 2511 MUX2S $T=469340 669200 1 0 $X=469340 $Y=663780
X4479 2317 2431 2 2511 1 2518 MUX2S $T=469340 669200 0 0 $X=469340 $Y=668820
X4480 2500 394 2 2477 1 2504 MUX2S $T=477400 659120 0 180 $X=473060 $Y=653700
X4481 2377 2431 2 2537 1 2550 MUX2S $T=478020 679280 1 0 $X=478020 $Y=673860
X4482 3885 3854 2 3928 1 3927 MUX2S $T=743380 548240 0 180 $X=739040 $Y=542820
X4483 3975 3854 2 3983 1 3913 MUX2S $T=757640 578480 1 180 $X=753300 $Y=578100
X4484 4273 4259 2 4256 1 4175 MUX2S $T=809720 568400 0 180 $X=805380 $Y=562980
X4485 4291 4259 2 4275 1 4190 MUX2S $T=815300 568400 0 180 $X=810960 $Y=562980
X4486 4279 4286 2 4272 1 4298 MUX2S $T=812200 528080 1 0 $X=812200 $Y=522660
X4487 4272 4286 2 4246 1 4301 MUX2S $T=812200 538160 1 0 $X=812200 $Y=532740
X4488 4302 4259 2 4281 1 4181 MUX2S $T=816540 548240 1 180 $X=812200 $Y=547860
X4489 4294 4259 2 4260 1 4268 MUX2S $T=816540 558320 0 180 $X=812200 $Y=552900
X4490 4307 4299 2 4246 1 4281 MUX2S $T=817160 548240 0 180 $X=812820 $Y=542820
X4491 4323 4259 2 4300 1 4180 MUX2S $T=820880 568400 0 180 $X=816540 $Y=562980
X4492 1027 1028 2 1022 1 990 MUX2S $T=821500 497840 1 180 $X=817160 $Y=497460
X4493 4306 4286 2 4279 1 4329 MUX2S $T=817780 528080 0 0 $X=817780 $Y=527700
X4494 4329 1029 2 4301 1 4307 MUX2S $T=822120 538160 0 180 $X=817780 $Y=532740
X4495 4346 4299 2 4307 1 4260 MUX2S $T=822120 548240 1 180 $X=817780 $Y=547860
X4496 4324 4299 2 4310 1 4275 MUX2S $T=822120 558320 0 180 $X=817780 $Y=552900
X4497 4246 4327 2 4301 1 4305 MUX2S $T=822740 538160 1 180 $X=818400 $Y=537780
X4498 4357 4259 2 4288 1 4293 MUX2S $T=827080 568400 0 180 $X=822740 $Y=562980
X4499 4298 4361 2 4255 1 4310 MUX2S $T=827700 548240 0 180 $X=823360 $Y=542820
X4500 4352 4259 2 4335 1 4198 MUX2S $T=827700 558320 1 180 $X=823360 $Y=557940
X4501 4322 4286 2 4306 1 4362 MUX2S $T=823980 528080 0 0 $X=823980 $Y=527700
X4502 4330 1029 2 4329 1 4359 MUX2S $T=823980 538160 1 0 $X=823980 $Y=532740
X4503 4359 4299 2 4305 1 4256 MUX2S $T=828320 538160 1 180 $X=823980 $Y=537780
X4504 4362 4361 2 4298 1 4365 MUX2S $T=833280 548240 1 180 $X=828940 $Y=547860
X4505 4390 4299 2 4365 1 4288 MUX2S $T=833280 558320 1 180 $X=828940 $Y=557940
X4506 4384 1029 2 4330 1 4346 MUX2S $T=833900 538160 1 180 $X=829560 $Y=537780
X4507 4387 4299 2 4359 1 4277 MUX2S $T=833900 548240 0 180 $X=829560 $Y=542820
X4508 4369 4286 2 4378 1 4384 MUX2S $T=830180 538160 1 0 $X=830180 $Y=532740
X4509 4378 4286 2 4355 1 4397 MUX2S $T=832040 528080 0 0 $X=832040 $Y=527700
X4510 4412 4299 2 4324 1 4323 MUX2S $T=838860 558320 0 180 $X=834520 $Y=552900
X4511 4414 4361 2 4384 1 4387 MUX2S $T=839480 538160 1 180 $X=835140 $Y=537780
X4512 4398 4361 2 4397 1 4390 MUX2S $T=839480 548240 0 180 $X=835140 $Y=542820
X4513 4397 4361 2 4362 1 4324 MUX2S $T=839480 548240 1 180 $X=835140 $Y=547860
X4514 4431 4299 2 4390 1 4352 MUX2S $T=844440 558320 0 180 $X=840100 $Y=552900
X4515 4430 4361 2 4398 1 4412 MUX2S $T=845060 548240 0 180 $X=840720 $Y=542820
X4516 4437 4299 2 4346 1 4302 MUX2S $T=845060 548240 1 180 $X=840720 $Y=547860
X4517 4648 3854 2 4708 1 4689 MUX2S $T=910780 618800 1 180 $X=906440 $Y=618420
X4518 4700 3854 2 4749 1 4548 MUX2S $T=921320 628880 1 180 $X=916980 $Y=628500
X4519 4841 1065 2 4850 1 4863 MUX2S $T=939300 558320 1 0 $X=939300 $Y=552900
X4520 4873 1065 2 4841 1 4848 MUX2S $T=946120 548240 0 180 $X=941780 $Y=542820
X4521 4850 1065 2 4877 1 4879 MUX2S $T=944880 558320 1 0 $X=944880 $Y=552900
X4522 4848 1029 2 4879 1 4893 MUX2S $T=944880 558320 0 0 $X=944880 $Y=557940
X4523 4871 1065 2 4873 1 4900 MUX2S $T=946740 538160 0 0 $X=946740 $Y=537780
X4524 4916 1065 2 4871 1 4901 MUX2S $T=955420 548240 0 180 $X=951080 $Y=542820
X4525 4877 4918 2 4879 1 4894 MUX2S $T=955420 558320 0 180 $X=951080 $Y=552900
X4526 4901 1029 2 4848 1 4919 MUX2S $T=951080 558320 0 0 $X=951080 $Y=557940
X4527 1172 1165 2 1166 1 4856 MUX2S $T=956040 497840 1 180 $X=951700 $Y=497460
X4528 4909 1163 2 4929 1 4925 MUX2S $T=954180 578480 1 0 $X=954180 $Y=573060
X4529 1178 1175 2 1159 1 4924 MUX2S $T=961000 497840 1 180 $X=956660 $Y=497460
X4530 4919 1157 2 4894 1 4910 MUX2S $T=961000 558320 1 180 $X=956660 $Y=557940
X4531 1181 1165 2 4924 1 4930 MUX2S $T=961620 507920 0 180 $X=957280 $Y=502500
X4532 4931 1065 2 4942 1 4955 MUX2S $T=957280 548240 0 0 $X=957280 $Y=547860
X4533 4955 1029 2 4901 1 4932 MUX2S $T=961620 558320 0 180 $X=957280 $Y=552900
X4534 4893 1157 2 4877 1 4944 MUX2S $T=964100 568400 1 180 $X=959760 $Y=568020
X4535 4960 1163 2 4944 1 4913 MUX2S $T=964100 578480 1 180 $X=959760 $Y=578100
X4536 4932 1157 2 4893 1 4938 MUX2S $T=960380 568400 1 0 $X=960380 $Y=562980
X4537 1186 1187 2 1178 1 4890 MUX2S $T=966580 497840 1 180 $X=962240 $Y=497460
X4538 4863 1029 2 4877 1 4965 MUX2S $T=962240 558320 0 0 $X=962240 $Y=557940
X4539 4969 1165 2 1183 1 4903 MUX2S $T=967820 507920 0 180 $X=963480 $Y=502500
X4540 4942 1065 2 4916 1 4977 MUX2S $T=963480 548240 0 0 $X=963480 $Y=547860
X4541 4970 1029 2 4955 1 4959 MUX2S $T=967820 558320 0 180 $X=963480 $Y=552900
X4542 4981 1163 2 4963 1 4956 MUX2S $T=969060 578480 1 180 $X=964720 $Y=578100
X4543 4989 1157 2 4965 1 4940 MUX2S $T=970300 568400 1 180 $X=965960 $Y=568020
X4544 4900 1029 2 4863 1 4993 MUX2S $T=967820 558320 0 0 $X=967820 $Y=557940
X4545 4997 1165 2 4979 1 4983 MUX2S $T=973400 507920 0 180 $X=969060 $Y=502500
X4546 4998 1065 2 4980 1 4970 MUX2S $T=974020 548240 1 180 $X=969680 $Y=547860
X4547 4977 1029 2 4900 1 4989 MUX2S $T=974020 558320 0 180 $X=969680 $Y=552900
X4548 5008 1157 2 4993 1 4966 MUX2S $T=975880 578480 0 180 $X=971540 $Y=573060
X4549 5009 1157 2 4932 1 4960 MUX2S $T=976500 568400 0 180 $X=972160 $Y=562980
X4550 4959 1157 2 4919 1 4909 MUX2S $T=977740 558320 1 180 $X=973400 $Y=557940
X4551 1199 1187 2 1193 1 4891 MUX2S $T=978980 497840 1 180 $X=974640 $Y=497460
X4552 4980 1065 2 4931 1 5019 MUX2S $T=975260 548240 0 0 $X=975260 $Y=547860
X4553 5019 1029 2 4977 1 5008 MUX2S $T=980220 558320 0 180 $X=975880 $Y=552900
X4554 5027 1163 2 4992 1 5002 MUX2S $T=980840 578480 1 180 $X=976500 $Y=578100
X4555 5018 1157 2 4989 1 4981 MUX2S $T=981460 578480 0 180 $X=977120 $Y=573060
X4556 5037 1165 2 1198 1 5016 MUX2S $T=982700 507920 0 180 $X=978360 $Y=502500
X4557 5042 1163 2 4910 1 5011 MUX2S $T=982700 568400 0 180 $X=978360 $Y=562980
X4558 5014 1029 2 5019 1 5018 MUX2S $T=983320 558320 1 180 $X=978980 $Y=557940
X4559 1203 1187 2 1201 1 4969 MUX2S $T=985180 497840 1 180 $X=980840 $Y=497460
X4560 5048 1029 2 4970 1 5009 MUX2S $T=986420 558320 0 180 $X=982080 $Y=552900
X4561 5043 1157 2 5008 1 5027 MUX2S $T=987660 578480 0 180 $X=983320 $Y=573060
X4562 5056 1163 2 4940 1 5035 MUX2S $T=987660 578480 1 180 $X=983320 $Y=578100
X4563 5052 1157 2 4959 1 5042 MUX2S $T=988900 568400 0 180 $X=984560 $Y=562980
X4564 5065 1163 2 4938 1 5061 MUX2S $T=993240 578480 1 180 $X=988900 $Y=578100
X4565 1211 1165 2 4890 1 5054 MUX2S $T=995100 507920 0 180 $X=990760 $Y=502500
X4566 5071 1163 2 4909 1 5086 MUX2S $T=1000060 578480 1 180 $X=995720 $Y=578100
X4567 5134 1163 2 4966 1 5095 MUX2S $T=1003160 588560 0 180 $X=998820 $Y=583140
X4568 5097 1065 2 5076 1 5132 MUX2S $T=999440 548240 1 0 $X=999440 $Y=542820
X4569 5043 5178 2 5155 1 5134 MUX2S $T=1011220 568400 1 0 $X=1011220 $Y=562980
X4570 3373 1 3347 3278 2 3389 ND3HT $T=619380 528080 0 180 $X=611940 $Y=522660
X4571 3373 1 3347 3278 2 3218 ND3HT $T=617520 538160 1 0 $X=617520 $Y=532740
X4572 5067 1 5078 5091 2 5044 ND3HT $T=989520 528080 1 0 $X=989520 $Y=522660
X4573 5105 1 5111 5115 2 5106 ND3HT $T=1002540 528080 1 0 $X=1002540 $Y=522660
X4574 5150 1 5171 5181 2 5144 ND3HT $T=1019900 528080 1 180 $X=1012460 $Y=527700
X4575 5219 1 5243 5223 2 5164 ND3HT $T=1025480 528080 0 0 $X=1025480 $Y=527700
X4576 5227 1 5250 5256 2 5237 ND3HT $T=1026720 598640 0 0 $X=1026720 $Y=598260
X4577 5403 1 5421 5418 2 5404 ND3HT $T=1073840 618800 0 180 $X=1066400 $Y=613380
X4578 1759 1756 1745 2 1764 1 260 AOI13H $T=307520 689360 1 0 $X=307520 $Y=683940
X4579 1303 1309 1321 1332 2 1 MXL2HS $T=221340 608720 0 0 $X=221340 $Y=608340
X4580 1698 190 1688 1718 2 1 MXL2HS $T=289540 679280 1 0 $X=289540 $Y=673860
X4581 2063 2066 2058 2080 2 1 MXL2HS $T=376340 628880 1 0 $X=376340 $Y=623460
X4582 397 399 401 403 2 1 MXL2HS $T=414160 699440 1 0 $X=414160 $Y=694020
X4583 2194 2066 2188 2273 2 1 MXL2HS $T=418500 659120 0 0 $X=418500 $Y=658740
X4584 2199 2224 2274 2240 2 1 MXL2HS $T=420360 649040 1 0 $X=420360 $Y=643620
X4585 892 3694 3707 3711 2 1 MXL2HS $T=689440 538160 1 0 $X=689440 $Y=532740
X4586 4510 1029 4520 4507 2 1 MXL2HS $T=863040 548240 1 0 $X=863040 $Y=542820
X4587 5229 5230 5240 5245 2 1 MXL2HS $T=1021760 548240 0 0 $X=1021760 $Y=547860
X4588 1333 1312 1306 1 2 AN2B1T $T=226300 679280 1 0 $X=226300 $Y=673860
X4589 398 368 2199 1 2 AN2B1T $T=414160 659120 1 0 $X=414160 $Y=653700
X4590 2204 2288 2043 1 2 AN2B1T $T=424080 679280 1 0 $X=424080 $Y=673860
X4591 3434 798 802 1 2 AN2B1T $T=632400 558320 0 0 $X=632400 $Y=557940
X4592 4259 4438 4621 1 2 AN2B1T $T=883500 558320 1 0 $X=883500 $Y=552900
X4593 4578 4617 4630 1 2 AN2B1T $T=889700 568400 1 0 $X=889700 $Y=562980
X4594 5188 5155 5233 1 2 AN2B1T $T=1018660 558320 0 0 $X=1018660 $Y=557940
X4595 1359 31 1417 1 2 1454 OA12 $T=239320 608720 0 0 $X=239320 $Y=608340
X4596 128 121 1660 1 2 1621 OA12 $T=285200 618800 1 180 $X=281480 $Y=618420
X4597 283 250 1925 1 2 1753 OA12 $T=347820 628880 0 180 $X=344100 $Y=623460
X4598 2696 316 2689 1 2 2626 OA12 $T=510880 628880 1 180 $X=507160 $Y=628500
X4599 2691 2963 2738 1 2 2911 OA12 $T=556760 598640 0 180 $X=553040 $Y=593220
X4600 2807 3136 2956 1 2 3157 OA12 $T=572880 618800 1 0 $X=572880 $Y=613380
X4601 3120 3243 719 1 2 3256 OA12 $T=589620 618800 0 0 $X=589620 $Y=618420
X4602 2946 3207 3274 1 2 3281 OA12 $T=593340 538160 1 0 $X=593340 $Y=532740
X4603 3353 3330 629 1 2 2860 OA12 $T=607600 558320 0 180 $X=603880 $Y=552900
X4604 2906 766 2894 1 2 3537 OA12 $T=646040 649040 1 0 $X=646040 $Y=643620
X4605 4434 1052 4567 1 2 4645 OA12 $T=889080 538160 0 0 $X=889080 $Y=537780
X4606 5251 1052 5212 1 2 5289 OA12 $T=1032920 558320 1 0 $X=1032920 $Y=552900
X4607 1347 1359 1336 2 1322 31 1 AO22P $T=229400 618800 0 0 $X=229400 $Y=618420
X4608 1581 1591 121 2 1599 128 1 AO22P $T=267220 618800 1 0 $X=267220 $Y=613380
X4609 1781 250 1964 2 1971 283 1 AO22P $T=350920 628880 1 0 $X=350920 $Y=623460
X4610 5205 1144 5217 2 5228 1147 1 AO22P $T=1019280 518000 0 0 $X=1019280 $Y=517620
X4611 5268 1052 5240 2 5220 5251 1 AO22P $T=1032300 558320 0 180 $X=1026720 $Y=552900
X4612 5355 1052 5294 2 5203 5251 1 AO22P $T=1046560 558320 1 180 $X=1040980 $Y=557940
X4613 5388 1144 5383 2 5145 1147 1 AO22P $T=1058960 507920 1 180 $X=1053380 $Y=507540
X4614 5439 1144 5392 2 1257 1147 1 AO22P $T=1070740 497840 1 180 $X=1065160 $Y=497460
X4615 1910 304 1 1921 299 304 2 MOAI1 $T=341620 518000 1 0 $X=341620 $Y=512580
X4616 1934 304 1 1923 298 304 2 MOAI1 $T=348440 507920 0 180 $X=344100 $Y=502500
X4617 1936 304 1 1918 285 304 2 MOAI1 $T=349060 507920 1 180 $X=344720 $Y=507540
X4618 2868 2847 1 2891 2677 2847 2 MOAI1 $T=539400 578480 1 0 $X=539400 $Y=573060
X4619 2898 2847 1 2916 2700 2847 2 MOAI1 $T=541880 598640 0 0 $X=541880 $Y=598260
X4620 2948 2847 1 2915 2712 2847 2 MOAI1 $T=547460 588560 0 180 $X=543120 $Y=583140
X4621 1936 2847 1 2931 2718 2847 2 MOAI1 $T=547460 598640 1 0 $X=547460 $Y=593220
X4622 2998 2847 1 2955 2717 2847 2 MOAI1 $T=553660 588560 0 180 $X=549320 $Y=583140
X4623 4586 4434 1 4595 4607 1089 2 MOAI1 $T=888460 538160 0 180 $X=884120 $Y=532740
X4624 4578 4434 1 4666 4675 1107 2 MOAI1 $T=903340 548240 1 180 $X=899000 $Y=547860
X4625 1690 1673 1 1676 2 OR2B1S $T=288920 649040 0 180 $X=285820 $Y=643620
X4626 1972 1976 1 1954 2 OR2B1S $T=354640 649040 0 0 $X=354640 $Y=648660
X4627 269 1977 1 1972 2 OR2B1S $T=354640 659120 1 0 $X=354640 $Y=653700
X4628 817 670 1 3215 2 OR2B1S $T=643560 618800 0 180 $X=640460 $Y=613380
X4629 1246 5354 2 5362 5343 5354 1 AOI22H $T=1057100 518000 1 180 $X=1049660 $Y=517620
X4630 1052 5332 2 5233 5381 5251 1 AOI22H $T=1049660 558320 0 0 $X=1049660 $Y=557940
X4631 1144 1266 2 1240 5485 1147 1 AOI22H $T=1078180 497840 0 0 $X=1078180 $Y=497460
X4632 1346 1359 1 1371 1361 1349 2 MOAI1H $T=238080 598640 1 180 $X=230640 $Y=598260
X4633 3372 3419 1 3393 3381 767 2 MOAI1H $T=623100 548240 1 180 $X=615660 $Y=547860
X4634 3393 3445 1 792 3467 3218 2 MOAI1H $T=625580 538160 0 0 $X=625580 $Y=537780
X4635 3372 3498 1 3389 3483 732 2 MOAI1H $T=641080 538160 1 180 $X=633640 $Y=537780
X4636 1393 1374 1 1351 2 NR2T $T=234980 618800 0 0 $X=234980 $Y=618420
X4637 2082 2131 1 2128 2 NR2T $T=390600 649040 0 0 $X=390600 $Y=648660
X4638 5220 5168 1 5188 2 NR2T $T=1019280 548240 1 180 $X=1014320 $Y=547860
X4639 1494 130 32 1 2 1544 AO12 $T=257920 518000 1 0 $X=257920 $Y=512580
X4640 250 1961 1948 1 2 1893 AO12 $T=350920 638960 1 0 $X=350920 $Y=633540
X4641 2060 2046 2064 1 2 363 AO12 $T=378820 689360 0 0 $X=378820 $Y=688980
X4642 2635 2626 2625 1 2 2582 AO12 $T=499720 628880 1 180 $X=496000 $Y=628500
X4643 2659 2626 2625 1 2 2639 AO12 $T=504680 628880 1 180 $X=500960 $Y=628500
X4644 328 2691 323 1 2 2750 AO12 $T=515220 598640 0 0 $X=515220 $Y=598260
X4645 2936 507 2856 1 2 2888 AO12 $T=546840 528080 1 180 $X=543120 $Y=527700
X4646 2941 507 2926 1 2 2878 AO12 $T=548700 538160 1 180 $X=544980 $Y=537780
X4647 2971 507 2945 1 2 2901 AO12 $T=553040 538160 0 180 $X=549320 $Y=532740
X4648 2771 2963 2959 1 2 2843 AO12 $T=553040 628880 1 180 $X=549320 $Y=628500
X4649 2949 507 2781 1 2 2889 AO12 $T=554280 528080 0 180 $X=550560 $Y=522660
X4650 699 652 613 1 2 3220 AO12 $T=589000 679280 0 180 $X=585280 $Y=673860
X4651 2906 2997 3119 1 2 719 AO12 $T=599540 618800 1 0 $X=599540 $Y=613380
X4652 3210 3337 671 1 2 3326 AO12 $T=609460 598640 1 180 $X=605740 $Y=598260
X4653 3091 3117 3097 1 2 3407 AO12 $T=616280 628880 0 0 $X=616280 $Y=628500
X4654 3514 2877 658 1 2 3500 AO12 $T=647280 618800 1 180 $X=643560 $Y=618420
X4655 3368 2852 635 1 2 3487 AO12 $T=647900 679280 1 180 $X=644180 $Y=678900
X4656 573 827 772 1 2 3542 AO12 $T=649760 699440 1 0 $X=649760 $Y=694020
X4657 368 1722 1 2 INV3 $T=384400 638960 1 180 $X=381920 $Y=638580
X4658 2615 396 1 2 INV3 $T=500960 699440 1 0 $X=500960 $Y=694020
X4659 3362 752 1 2 INV3 $T=610700 558320 0 180 $X=608220 $Y=552900
X4660 3381 765 1 2 INV3 $T=613180 548240 0 0 $X=613180 $Y=547860
X4661 3444 3478 1 2 INV3 $T=633020 518000 1 0 $X=633020 $Y=512580
X4662 3506 810 1 2 INV3 $T=641700 518000 1 180 $X=639220 $Y=517620
X4663 3707 223 1 2 INV3 $T=695640 538160 0 0 $X=695640 $Y=537780
X4664 3467 933 1 2 INV3 $T=726640 538160 0 0 $X=726640 $Y=537780
X4665 3218 3447 1 2 INV4 $T=628060 528080 0 0 $X=628060 $Y=527700
X4666 3501 806 1 2 INV4 $T=640460 507920 0 180 $X=637360 $Y=502500
X4667 3109 659 2813 3325 2 1 3292 MAOI1 $T=601400 649040 0 0 $X=601400 $Y=648660
X4668 109 98 2 106 1 1344 AN3B2S $T=250480 518000 0 180 $X=246760 $Y=512580
X4669 1414 59 2 1508 1 1521 AN3B2S $T=254200 538160 0 0 $X=254200 $Y=537780
X4670 1700 1729 2 1724 1 232 AN3B2S $T=295740 507920 0 0 $X=295740 $Y=507540
X4671 1620 1670 2 1809 1 1819 AN3B2S $T=315580 548240 0 0 $X=315580 $Y=547860
X4672 1706 1728 2 1826 1 1842 AN3B2S $T=321160 538160 1 0 $X=321160 $Y=532740
X4673 2797 316 2 319 1 2864 AN3B2S $T=535680 618800 0 0 $X=535680 $Y=618420
X4674 3287 507 2 277 1 742 AN3B2S $T=598920 558320 1 0 $X=598920 $Y=552900
X4675 3332 3171 2 3395 1 770 AN3B2S $T=616280 659120 1 0 $X=616280 $Y=653700
X4676 3366 3542 2 3550 1 3262 AN3B2S $T=657200 649040 0 180 $X=653480 $Y=643620
X4677 3089 3542 2 3495 1 3576 AN3B2S $T=654720 659120 0 0 $X=654720 $Y=658740
X4678 2831 2712 2671 2 2806 1 2717 AO112 $T=531960 618800 1 180 $X=527000 $Y=618420
X4679 831 3313 3533 2 3562 1 3413 AO112 $T=654100 669200 1 0 $X=654100 $Y=663780
X4680 1310 1370 1382 131 1 2 QDFFRBP $T=248000 578480 1 0 $X=248000 $Y=573060
X4681 234 1370 1382 258 1 2 QDFFRBP $T=300080 568400 0 0 $X=300080 $Y=568020
X4682 3267 3285 703 3329 1 2 QDFFRBP $T=595820 518000 1 0 $X=595820 $Y=512580
X4683 3301 3285 634 3321 1 2 QDFFRBP $T=598920 548240 1 0 $X=598920 $Y=542820
X4684 3848 3385 3674 3791 1 2 QDFFRBP $T=722920 507920 0 180 $X=710520 $Y=502500
X4685 2700 2660 2680 2 1 2711 OR3 $T=509640 628880 1 0 $X=509640 $Y=623460
X4686 1065 4527 4539 2 4560 4532 1 MUXB2 $T=870480 548240 0 0 $X=870480 $Y=547860
X4687 1634 1557 1615 1 2 AN2B1 $T=282100 638960 0 0 $X=282100 $Y=638580
X4688 4501 4588 4568 1 2 AN2B1 $T=879160 548240 0 0 $X=879160 $Y=547860
X4689 1226 5279 5269 1 2 AN2B1 $T=1031680 507920 1 0 $X=1031680 $Y=502500
X4690 5352 5359 5247 1 2 AN2B1 $T=1047800 588560 1 0 $X=1047800 $Y=583140
X4691 5105 5111 5115 5117 5091 1 2 AO13P $T=996960 528080 1 0 $X=996960 $Y=522660
X4692 5330 5334 5336 5341 5335 1 2 AO13P $T=1044700 638960 1 0 $X=1044700 $Y=633540
X4693 2050 2131 2159 1 2 2141 OR3B1 $T=396800 669200 1 0 $X=396800 $Y=663780
X4694 1450 1392 1440 1 2 1436 1440 85 1293 ICV_9 $T=244280 679280 0 180 $X=242420 $Y=673860
X4695 502 2894 2864 1 2 2710 2869 2652 1293 ICV_9 $T=539400 618800 0 180 $X=537540 $Y=613380
X4696 3021 3031 2691 1 2 3021 652 2718 1293 ICV_9 $T=559240 649040 0 180 $X=557380 $Y=643620
X4697 2919 662 3010 1 2 2810 3046 3010 1293 ICV_9 $T=562960 638960 0 180 $X=561100 $Y=633540
X4698 2919 670 2784 1 2 2919 3061 2870 1293 ICV_9 $T=564820 628880 0 180 $X=562960 $Y=623460
X4699 4706 4720 4669 1 2 4639 4704 4669 1293 ICV_9 $T=907680 578480 1 180 $X=905820 $Y=578100
X4700 4870 4907 4844 1 2 4870 4888 4887 1293 ICV_9 $T=951080 618800 0 180 $X=949220 $Y=613380
X4701 5093 5130 1217 1 2 5130 5088 5118 1293 ICV_9 $T=1001300 558320 0 180 $X=999440 $Y=552900
X4702 1245 5331 1147 1 2 5328 5325 1144 1293 ICV_9 $T=1044700 507920 1 180 $X=1042840 $Y=507540
X4703 5238 5408 5251 1 2 5384 5395 1052 1293 ICV_9 $T=1060200 568400 0 180 $X=1058340 $Y=562980
X4704 5419 5435 1144 1 2 5435 5431 5429 1293 ICV_9 $T=1068880 507920 1 180 $X=1067020 $Y=507540
X4705 1 2 1408 1429 1442 1411 1402 1293 ICV_10 $T=239940 638960 1 0 $X=239940 $Y=633540
X4706 1 2 1847 1853 1885 1839 1760 1293 ICV_10 $T=323020 628880 0 0 $X=323020 $Y=628500
X4707 1 2 1854 1858 1859 1843 1712 1293 ICV_10 $T=324260 638960 0 0 $X=324260 $Y=638580
X4708 1 2 1868 1872 1906 1862 1852 1293 ICV_10 $T=328600 618800 1 0 $X=328600 $Y=613380
X4709 1 2 972 4088 4097 4076 4071 1293 ICV_10 $T=770660 507920 0 0 $X=770660 $Y=507540
X4710 1 2 1004 4218 4238 4205 4131 1293 ICV_10 $T=794840 518000 1 0 $X=794840 $Y=512580
X4711 1 2 1023 4315 4328 4297 4264 1293 ICV_10 $T=816540 518000 1 0 $X=816540 $Y=512580
X4712 1 2 1045 4408 4428 4392 4347 1293 ICV_10 $T=834520 518000 0 0 $X=834520 $Y=517620
X4713 1 2 1054 4442 4450 4433 4416 1293 ICV_10 $T=844440 518000 1 0 $X=844440 $Y=512580
X4714 1 2 1059 4462 4481 4447 4440 1293 ICV_10 $T=848780 528080 1 0 $X=848780 $Y=522660
X4715 1 2 4536 4533 4525 4537 4530 1293 ICV_10 $T=869860 588560 1 0 $X=869860 $Y=583140
X4716 1 2 1102 4644 4688 4634 4639 1293 ICV_10 $T=890320 507920 0 0 $X=890320 $Y=507540
X4717 1 2 4693 4723 4665 4709 4711 1293 ICV_10 $T=907060 528080 0 0 $X=907060 $Y=527700
X4718 1 2 1158 4866 4878 4857 4858 1293 ICV_10 $T=943020 528080 0 0 $X=943020 $Y=527700
X4719 1 2 5119 5112 5123 5127 5121 1293 ICV_10 $T=1001300 618800 0 0 $X=1001300 $Y=618420
X4720 1 2 1221 5154 5164 5191 5194 1293 ICV_10 $T=1015560 538160 1 0 $X=1015560 $Y=532740
X4721 1 2 1241 5300 5324 5284 5287 1293 ICV_10 $T=1035400 518000 1 0 $X=1035400 $Y=512580
X4722 1 2 5278 5295 5340 5303 5305 1293 ICV_10 $T=1039120 618800 0 0 $X=1039120 $Y=618420
X4723 1 2 5314 5326 5268 5311 5315 1293 ICV_10 $T=1040360 548240 0 0 $X=1040360 $Y=547860
X4724 1 2 5355 5363 5337 5350 5356 1293 ICV_10 $T=1048420 558320 1 0 $X=1048420 $Y=552900
X4725 1 2 5402 5406 5407 5394 5397 1293 ICV_10 $T=1058960 548240 0 0 $X=1058960 $Y=547860
X4726 1 2 5428 5347 5417 5422 5423 1293 ICV_10 $T=1065160 608720 0 0 $X=1065160 $Y=608340
X4727 1 2 5436 5414 5458 5426 5430 1293 ICV_10 $T=1066400 578480 1 0 $X=1066400 $Y=573060
X4728 3709 227 1 2 INV6 $T=696260 518000 1 180 $X=691300 $Y=517620
X4729 4923 233 1 2 INV6 $T=958520 649040 0 0 $X=958520 $Y=648660
X4730 2060 2067 2062 1 2 360 AO12T $T=376340 669200 1 0 $X=376340 $Y=663780
X4731 2060 2089 2095 1 2 367 AO12T $T=382540 669200 1 0 $X=382540 $Y=663780
X4732 386 393 395 1 2 352 AO12T $T=406100 699440 1 0 $X=406100 $Y=694020
X4733 4865 987 919 1 2 4923 AO12T $T=948600 669200 1 0 $X=948600 $Y=663780
X4734 2780 2816 2854 2815 2 1 2860 XOR4 $T=525760 528080 0 0 $X=525760 $Y=527700
X4735 2878 2925 2859 2788 2 1 2850 XOR4 $T=546840 518000 0 180 $X=531960 $Y=512580
X4736 932 4017 1025 4290 2 1 937 XOR4 $T=809100 649040 1 0 $X=809100 $Y=643620
X4737 943 3744 3971 3978 1 2 MXL2HP $T=738420 588560 0 0 $X=738420 $Y=588180
X4738 1664 218 1 2 BUF4 $T=293260 638960 1 0 $X=293260 $Y=633540
X4739 2495 407 1 2 BUF4 $T=469340 638960 0 0 $X=469340 $Y=638580
X4740 3543 869 1 2 BUF4 $T=669600 538160 0 0 $X=669600 $Y=537780
X4741 764 3403 1 2 INV8 $T=617520 558320 0 180 $X=611320 $Y=552900
X4742 356 3478 1 2 INV8 $T=632400 507920 0 180 $X=626200 $Y=502500
X4743 807 3483 1 2 INV8 $T=637360 548240 0 0 $X=637360 $Y=547860
X4744 2965 2951 520 497 2 1 2934 OA112 $T=551800 649040 1 180 $X=546840 $Y=648660
X4745 2967 2961 613 531 2 1 2932 OA112 $T=552420 669200 1 180 $X=547460 $Y=668820
X4746 3101 3089 516 609 2 1 3040 OA112 $T=568540 659120 0 180 $X=563580 $Y=653700
X4747 2967 3137 683 2938 2 1 3112 OA112 $T=574740 669200 0 180 $X=569780 $Y=663780
X4748 3249 3265 608 547 2 1 3283 OA112 $T=592100 649040 1 0 $X=592100 $Y=643620
X4749 3386 3333 685 659 2 1 3032 OA112 $T=607600 679280 1 180 $X=602640 $Y=678900
X4750 3286 3367 613 547 2 1 3378 OA112 $T=610700 659120 0 0 $X=610700 $Y=658740
X4751 2894 3379 3120 3091 2 1 3399 OA112 $T=613180 649040 0 0 $X=613180 $Y=648660
X4752 3432 3500 3499 2866 2 1 3482 OA112 $T=641700 608720 1 180 $X=636740 $Y=608340
X4753 801 3447 368 3536 1 2 MXL2HT $T=634880 507920 0 0 $X=634880 $Y=507540
X4754 3427 3389 1 741 3401 3369 2 MOAI1HP $T=624340 518000 0 180 $X=611320 $Y=512580
X4755 3485 3369 1 784 3444 3218 2 MOAI1HP $T=634880 518000 1 180 $X=621860 $Y=517620
X4756 3507 3218 1 800 483 3389 2 MOAI1HP $T=641080 538160 0 180 $X=628060 $Y=532740
X4757 769 3401 1 2 INV12 $T=621860 507920 1 180 $X=614420 $Y=507540
X4758 711 717 1 717 3304 741 2 MOAI1HT $T=586520 507920 1 0 $X=586520 $Y=502500
X4759 763 717 1 717 754 732 2 MOAI1HT $T=615040 497840 1 180 $X=596440 $Y=497460
X4760 3372 3380 1 3393 3403 787 2 MOAI1HT $T=611940 548240 1 0 $X=611940 $Y=542820
X4761 3314 465 703 3373 1 2 3293 DFFRBT $T=602020 528080 0 0 $X=602020 $Y=527700
X4762 3183 2973 3190 1 2 2953 AN3B1 $T=584040 638960 0 180 $X=579080 $Y=633540
X4763 3290 3125 3022 1 2 3337 AN3B1 $T=600780 598640 1 0 $X=600780 $Y=593220
X4764 3278 3293 3318 2903 1 2 OR3P $T=600160 518000 0 0 $X=600160 $Y=517620
X4765 2755 2757 1 2 INV1CK $T=519560 628880 0 0 $X=519560 $Y=628500
X4766 2978 2526 1 2 INV1CK $T=553040 558320 0 0 $X=553040 $Y=557940
X4767 3285 615 1 2 INV1CK $T=597680 548240 0 0 $X=597680 $Y=547860
X4768 3218 3255 3246 2903 2 1 3274 OA112S $T=592100 528080 0 0 $X=592100 $Y=527700
X4769 3039 3069 3019 1 2 3009 HA1 $T=565440 548240 1 180 $X=557380 $Y=547860
X4770 3047 3019 3070 1 2 3081 HA1 $T=558000 558320 1 0 $X=558000 $Y=552900
X4771 2979 3113 3069 1 2 3055 HA1 $T=571020 538160 0 180 $X=562960 $Y=532740
X4772 2941 3126 3084 1 2 3075 HA1 $T=572880 518000 0 180 $X=564820 $Y=512580
X4773 2984 3084 3113 1 2 3104 HA1 $T=579080 507920 1 180 $X=571020 $Y=507540
X4774 3123 3070 3181 1 2 3192 HA1 $T=573500 558320 1 0 $X=573500 $Y=552900
X4775 2971 3129 3126 1 2 3191 HA1 $T=574120 518000 0 0 $X=574120 $Y=517620
X4776 3054 1 3029 2 BUF4CK $T=566680 518000 0 0 $X=566680 $Y=517620
X4777 637 1936 2957 1 327 2 2958 OAI13HS $T=551180 568400 0 0 $X=551180 $Y=568020
X4778 2860 2854 1 2 2668 OR2B1 $T=537540 538160 1 180 $X=533820 $Y=537780
X4779 230 1370 1382 1664 1 2 5503 DFFSBN $T=295120 568400 1 180 $X=282100 $Y=568020
X4780 312 1370 1382 1736 1 2 5504 DFFSBN $T=328600 558320 1 180 $X=315580 $Y=557940
X4781 282 1370 1382 267 1 2 5505 DFFSBN $T=329220 568400 1 180 $X=316200 $Y=568020
X4782 2582 476 262 2495 1 2 5506 DFFSBN $T=488560 628880 1 180 $X=475540 $Y=628500
X4783 2637 476 262 473 1 2 5507 DFFSBN $T=496000 649040 0 180 $X=482980 $Y=643620
X4784 2639 476 262 2586 1 2 5508 DFFSBN $T=503440 638960 0 180 $X=490420 $Y=633540
X4785 1738 1735 2 1781 1804 1738 1 AOI22HP $T=310000 618800 1 0 $X=310000 $Y=613380
X4786 1541 141 1 2 BUF8 $T=260400 598640 1 0 $X=260400 $Y=593220
.ENDS
***************************************
.SUBCKT OR2S I2 I1 VCC GND O
** N=6 EP=5 IP=0 FDC=0
.ENDS
***************************************
.SUBCKT OR3S I3 I2 I1 VCC GND O
** N=7 EP=6 IP=0 FDC=0
.ENDS
***************************************
.SUBCKT OR2P I2 I1 O GND VCC
** N=6 EP=5 IP=0 FDC=0
.ENDS
***************************************
.SUBCKT ICV_12 1 2 3 4 5 6 7 8 9
** N=9 EP=9 IP=12 FDC=0
X0 1 2 3 4 5 NR2 $T=0 0 1 0 $X=0 $Y=-5420
X1 6 2 7 8 5 NR2 $T=0 0 0 0 $X=0 $Y=-380
.ENDS
***************************************
.SUBCKT AN3S I1 I2 I3 GND VCC O
** N=7 EP=6 IP=0 FDC=0
.ENDS
***************************************
.SUBCKT OA22S A1 A2 B1 B2 VCC GND O
** N=8 EP=7 IP=0 FDC=0
.ENDS
***************************************
.SUBCKT AO13S B3 B2 B1 A1 GND VCC O
** N=8 EP=7 IP=0 FDC=0
.ENDS
***************************************
.SUBCKT OA13 B3 B2 B1 A1 VCC GND O
** N=8 EP=7 IP=0 FDC=0
.ENDS
***************************************
.SUBCKT XNR3S I2 I1 I3 GND VCC O
** N=7 EP=6 IP=0 FDC=0
.ENDS
***************************************
.SUBCKT XNR2HP I2 O I1 GND VCC
** N=6 EP=5 IP=0 FDC=0
.ENDS
***************************************
.SUBCKT OR2B1T B1 I1 GND O VCC
** N=6 EP=5 IP=0 FDC=0
.ENDS
***************************************
.SUBCKT OR3B2T B2 I1 B1 GND VCC O
** N=7 EP=6 IP=0 FDC=0
.ENDS
***************************************
.SUBCKT ICV_13 1 2 3 4 5 6 7 8 9 10 11 12 13 14 15 16 17 18 19 20
+ 21 22 23 24 25 26 27 28 29 30 31 32 33 34 35 36 37 38 39 40
+ 41 42 43 44 45 46 47 48 49 50 51 52 53 54 55 56 57 58 59 60
+ 61 62 63 64 65 66 67 68 69 70 71 72 73 74 75 76 77 78 79 80
+ 81 82 83 84 85 86 87 88 89 90 91 92 93 94 95 96 97 98 99 100
+ 101 102 103 104 105 106 107 108 109 110 111 112 113 114 115 116 117 118 119 120
+ 121 122 123 124 125 126 127 128 129 130 131 132 133 134 135 136 137 138 139 140
+ 141 142 143 144 145 146 147 148 149 150 151 152 153 154 155 156 157 158 159 160
+ 161 162 163 164 165 166 167 168 169 170 171 172 173 174 175 176 177 178 179 180
+ 181 182 183 184 185 186 187 188 189 190 191 192 193 194 195 196 197 198 199 200
+ 201 202 203 204 205 206 207 208 209 210 211 212 213 214 215 216 217 218 219 220
+ 221 222 223 224 225 226 227 228 229 230 231 232 233 234 235 236 237 238 239 240
+ 241 242 243 244 245 246 247 248 249 250 251 252 253 254 255 256 257 258 259 260
+ 261 262 263 264 265 266 267 268 269 270 271 272 273 274 275 276 277 278 279 280
+ 281 282 283 284 285 286 287 288 289 290 291 292 293 294 295 296 297 298 299 300
+ 301 302 303 304 305 306 307 308 309 310 311 312 313 314 315 316 317 318 319 320
+ 321 322 323 324 325 326 327 328 329 330 331 332 333 334 335 336 337 338 339 340
+ 341 342 343 344 345 346 347 348 349 350 351 352 353 354 355 356 357 358 359 360
+ 361 362 363 364 365 366 367 368 369 370 371 372 373 374 375 376 377 378 379 380
+ 381 382 383 384 385 386 387 388 389 390 391 392 393 394 395 396 397 398 399 400
+ 401 402 403 404 405 406 407 408 409 410 411 412 413 414 415 416 417 418 419 420
+ 421 422 423 424 425 426 427 428 429 430 431 432 433 434 435 436 437 438 439 440
+ 441 442 443 444 445 446 447 448 449 450 451 452 453 454 455 456 457 458 459 460
+ 461 462 463 464 465 466 467 468 469 470 471 472 473 474 475 476 477 478 479 480
+ 481 482 483 484 485 486 487 488 489 490 491 492 493 494 495 496 497 498 499 500
+ 501 502 503 504 505 506 507 508 509 510 511 512 513 514 515 516 517 518 519 520
+ 521 522 523 524 525 526 527 528 529 530 531 532 533 534 535 536 537 538 539 540
+ 541 542 543 544 545 546 547 548 549 550 551 552 553 554 555 556 557 558 559 560
+ 561 562 563 564 565 566 567 568 569 570 571 572 573 574 575 576 577 578 579 580
+ 581 582 583 584 585 586 587 588 589 590 591 592 593 594 595 596 597 598 599 600
+ 601 602 603 604 605 606 607 608 609 610 611 612 613 614 615 616 617 618 619 620
+ 621 622 623 624 625 626 627 628 629 630 631 632 633 634 635 636 637 638 639 640
+ 641 642 643 644 645 646 647 648 649 650 651 652 653 654 655 656 657 658 659 660
+ 661 662 663 664 665 666 667 668 669 670 671 672 673 674 675 676 677 678 679 680
+ 681 682 683 684 685 686 687 688 689 690 691 692 693 694 695 696 697 698 699 700
+ 701 702 703 704 705 706 707 708 709 710 711 712 713 714 715 716 717 718 719 720
+ 721 722 723 724 725 726 727 728 729 730 731 732 733 734 735 736 737 738 739 740
+ 741 742 743 744 745 746 747 748 749 750 751 752 753 754 755 756 757 758 759 760
+ 761 762 763 764 765 766 767 768 769 770 771 772 773 774 775 776 777 778 779 780
+ 781 782 783 784 785 786 787 788 789 790 791 792 793 794 795 796 797 798 799 800
+ 801 802 803 804 805 806 807 808 809 810 811 812 813 814 815 816 817 818 819 820
+ 821 822 823 824 825 826 827 828 829 830 831 832 833 834 835 836 837 838 839 840
+ 841 842 843 844 845 846 847 848 849 850 851 852 853 854 855 856 857 858 859 860
+ 861 862 863 864 865 866 867 868 869 870 871 872 873 874 875 876 877 878 879 880
+ 881 882 883 884 885 886 887 888 889 890 891 892 893 894 895 896 897 898 899 900
+ 901 902 903 904 905 906 907 908 909 910 911 912 913 914 915 916 917 918 919 920
+ 921 922 923 924 925 926 927 928 929 930 931 932 933 934 935 936 937 938 939 940
+ 941 942 943 944 945 946 947 948 949 950 951 952 953 954 955 956 957 958 959 960
+ 961 962 963 964 965 966 967 968 969 970 971 972 973 974 975 976 977 978 979 980
+ 981 982 983 984 985 986 987 988 989 990 991 992 993 994 995 996 997 998 999 1000
+ 1001 1002 1003 1004 1005 1006 1007 1008 1009 1010 1011 1012 1013 1014 1015 1016 1017 1018 1019 1020
+ 1021 1022 1023 1024 1025 1026 1027 1028 1029 1030 1031 1032 1033 1034 1035 1036 1037 1038 1039 1040
+ 1041 1042 1043 1044 1045 1046 1047 1048 1049 1050 1051 1052 1053 1054 1055 1056 1057 1058 1059 1060
+ 1061 1062 1063 1064 1065 1066 1067 1068 1069 1070 1071 1072 1073 1074 1075 1076 1077 1078 1079 1080
+ 1081 1082 1083 1084 1085 1086 1087 1088 1089 1090 1091 1092 1093 1094 1095 1096 1097 1098 1099 1100
+ 1101 1102 1103 1104 1105 1106 1107 1108 1109 1110 1111 1112 1113 1114 1115 1116 1117 1118 1119 1120
+ 1121 1122 1123 1124 1125 1126 1127 1128 1129 1130 1131 1132 1133 1134 1135 1136 1137 1138 1139 1140
+ 1141 1142 1143 1144 1145 1146 1147 1148 1149 1150 1151 1152 1153 1154 1155 1156 1157 1158 1159 1160
+ 1161 1162 1163 1164 1165 1166 1167 1168 1169 1170 1171 1172 1173 1174 1175 1176 1177 1178 1179 1180
+ 1181 1182 1183 1184 1185 1186 1187 1188 1189 1190 1191 1192 1193 1194 1195 1196 1197 1198 1199 1200
+ 1201 1202 1203 1204 1205 1206 1207 1208 1209 1210 1211 1212 1213 1214 1215 1216 1217 1218 1219 1220
+ 1221 1222 1223 1224 1225 1226 1227 1228 1229 1230 1231 1232 1233 1234 1235 1236 1237 1238 1239 1240
+ 1241 1242 1243 1244 1245 1246 1247 1248 1249 1250 1251 1252 1253 1254 1255 1256 1257 1258 1259 1260
+ 1261 1262 1263 1264 1265 1266 1267 1268 1269 1270 1271 1272 1273 1274 1275 1276 1277 1278 1279 1280
+ 1281 1282 1283 1284 1285 1286 1287 1288 1289 1290 1291 1300 1320
** N=5105 EP=1293 IP=29258 FDC=0
X0 1291 1290 1290 1290 2481 1290 1300 YA2GSD $T=1315640 351290 0 90 $X=1176140 $Y=354140
X1 1571 91 1498 1 2 QDFFN $T=259160 346640 0 180 $X=248620 $Y=341220
X2 86 101 1518 1 2 QDFFN $T=262880 356720 0 180 $X=252340 $Y=351300
X3 86 91 1591 1 2 QDFFN $T=252960 336560 1 0 $X=252960 $Y=331140
X4 86 94 1585 1 2 QDFFN $T=253580 326480 0 0 $X=253580 $Y=326100
X5 86 108 1594 1 2 QDFFN $T=261020 366800 0 0 $X=261020 $Y=366420
X6 1571 101 1629 1 2 QDFFN $T=262260 346640 0 0 $X=262260 $Y=346260
X7 1571 94 1628 1 2 QDFFN $T=262880 346640 1 0 $X=262880 $Y=341220
X8 1571 108 1639 1 2 QDFFN $T=263500 366800 1 0 $X=263500 $Y=361380
X9 118 94 1648 1 2 QDFFN $T=267840 326480 0 0 $X=267840 $Y=326100
X10 160 94 1638 1 2 QDFFN $T=284580 336560 0 180 $X=274040 $Y=331140
X11 160 108 1640 1 2 QDFFN $T=285820 376880 0 180 $X=275280 $Y=371460
X12 160 91 1677 1 2 QDFFN $T=291400 346640 1 180 $X=280860 $Y=346260
X13 160 101 1660 1 2 QDFFN $T=291400 356720 0 180 $X=280860 $Y=351300
X14 1700 101 1740 1 2 QDFFN $T=285820 366800 1 0 $X=285820 $Y=361380
X15 155 108 172 1 2 QDFFN $T=287060 336560 0 0 $X=287060 $Y=336180
X16 1700 94 1761 1 2 QDFFN $T=289540 346640 1 0 $X=289540 $Y=341220
X17 1700 108 1746 1 2 QDFFN $T=289540 376880 1 0 $X=289540 $Y=371460
X18 155 91 185 1 2 QDFFN $T=291400 326480 0 0 $X=291400 $Y=326100
X19 1700 91 1784 1 2 QDFFN $T=293260 356720 0 0 $X=293260 $Y=356340
X20 1769 91 1735 1 2 QDFFN $T=305040 346640 1 180 $X=294500 $Y=346260
X21 1769 94 1764 1 2 QDFFN $T=311240 336560 0 180 $X=300700 $Y=331140
X22 1769 101 1819 1 2 QDFFN $T=303180 366800 0 0 $X=303180 $Y=366420
X23 183 91 201 1 2 QDFFN $T=304420 326480 0 0 $X=304420 $Y=326100
X24 1769 108 1832 1 2 QDFFN $T=306900 356720 0 0 $X=306900 $Y=356340
X25 1801 94 1841 1 2 QDFFN $T=309380 346640 1 0 $X=309380 $Y=341220
X26 1801 108 1856 1 2 QDFFN $T=311860 346640 0 0 $X=311860 $Y=346260
X27 1820 94 1869 1 2 QDFFN $T=313720 336560 0 0 $X=313720 $Y=336180
X28 1801 101 1826 1 2 QDFFN $T=324880 376880 1 180 $X=314340 $Y=376500
X29 1820 91 1887 1 2 QDFFN $T=317440 326480 0 0 $X=317440 $Y=326100
X30 1820 108 1889 1 2 QDFFN $T=317440 366800 0 0 $X=317440 $Y=366420
X31 1820 101 1882 1 2 QDFFN $T=319920 356720 1 0 $X=319920 $Y=351300
X32 1801 91 1863 1 2 QDFFN $T=334800 346640 1 180 $X=324260 $Y=346260
X33 1801 212 1934 1 2 QDFFN $T=329220 376880 0 0 $X=329220 $Y=376500
X34 1801 213 1939 1 2 QDFFN $T=330460 366800 0 0 $X=330460 $Y=366420
X35 1820 214 1927 1 2 QDFFN $T=331080 346640 1 0 $X=331080 $Y=341220
X36 211 212 230 1 2 QDFFN $T=331700 326480 0 0 $X=331700 $Y=326100
X37 1801 214 1932 1 2 QDFFN $T=331700 376880 1 0 $X=331700 $Y=371460
X38 1820 212 1941 1 2 QDFFN $T=332940 336560 1 0 $X=332940 $Y=331140
X39 1769 213 1948 1 2 QDFFN $T=332940 356720 1 0 $X=332940 $Y=351300
X40 1769 224 1951 1 2 QDFFN $T=336660 346640 0 0 $X=336660 $Y=346260
X41 1801 224 1935 1 2 QDFFN $T=352160 366800 0 180 $X=341620 $Y=361380
X42 1769 214 1973 1 2 QDFFN $T=343480 376880 0 0 $X=343480 $Y=376500
X43 155 224 248 1 2 QDFFN $T=344720 326480 0 0 $X=344720 $Y=326100
X44 1769 212 1979 1 2 QDFFN $T=344720 386960 0 0 $X=344720 $Y=386580
X45 1820 224 1968 1 2 QDFFN $T=345960 336560 1 0 $X=345960 $Y=331140
X46 237 242 1987 1 2 QDFFN $T=347820 397040 1 0 $X=347820 $Y=391620
X47 1820 213 1959 1 2 QDFFN $T=359600 346640 1 180 $X=349060 $Y=346260
X48 240 242 2012 1 2 QDFFN $T=349060 407120 0 0 $X=349060 $Y=406740
X49 1571 224 1991 1 2 QDFFN $T=350300 366800 0 0 $X=350300 $Y=366420
X50 244 242 1998 1 2 QDFFN $T=350920 397040 0 0 $X=350920 $Y=396660
X51 1571 213 1988 1 2 QDFFN $T=352780 356720 1 0 $X=352780 $Y=351300
X52 246 242 2001 1 2 QDFFN $T=353400 417200 0 0 $X=353400 $Y=416820
X53 1571 212 2003 1 2 QDFFN $T=356500 386960 1 0 $X=356500 $Y=381540
X54 118 224 2005 1 2 QDFFN $T=357120 336560 0 0 $X=357120 $Y=336180
X55 249 242 2004 1 2 QDFFN $T=357120 427280 1 0 $X=357120 $Y=421860
X56 237 252 2022 1 2 QDFFN $T=357740 386960 0 0 $X=357740 $Y=386580
X57 155 213 260 1 2 QDFFN $T=358360 326480 0 0 $X=358360 $Y=326100
X58 118 213 2011 1 2 QDFFN $T=358980 336560 1 0 $X=358980 $Y=331140
X59 240 252 2009 1 2 QDFFN $T=358980 417200 1 0 $X=358980 $Y=411780
X60 253 242 2061 1 2 QDFFN $T=359600 437360 1 0 $X=359600 $Y=431940
X61 160 224 2010 1 2 QDFFN $T=360840 356720 0 0 $X=360840 $Y=356340
X62 86 224 2013 1 2 QDFFN $T=361460 346640 0 0 $X=361460 $Y=346260
X63 254 242 2014 1 2 QDFFN $T=362080 447440 1 0 $X=362080 $Y=442020
X64 255 256 2015 1 2 QDFFN $T=362080 477680 0 0 $X=362080 $Y=477300
X65 244 252 2032 1 2 QDFFN $T=362700 407120 1 0 $X=362700 $Y=401700
X66 255 242 2019 1 2 QDFFN $T=362700 467600 0 0 $X=362700 $Y=467220
X67 1700 224 2031 1 2 QDFFN $T=363320 366800 0 0 $X=363320 $Y=366420
X68 244 256 2023 1 2 QDFFN $T=363320 397040 0 0 $X=363320 $Y=396660
X69 254 256 2035 1 2 QDFFN $T=363940 457520 1 0 $X=363940 $Y=452100
X70 257 242 2020 1 2 QDFFN $T=363940 487760 0 0 $X=363940 $Y=487380
X71 249 252 2034 1 2 QDFFN $T=364560 427280 0 0 $X=364560 $Y=426900
X72 258 242 2025 1 2 QDFFN $T=364560 467600 1 0 $X=364560 $Y=462180
X73 160 213 2028 1 2 QDFFN $T=365800 356720 1 0 $X=365800 $Y=351300
X74 246 252 2036 1 2 QDFFN $T=365800 417200 0 0 $X=365800 $Y=416820
X75 257 256 2042 1 2 QDFFN $T=365800 487760 1 0 $X=365800 $Y=482340
X76 254 252 2041 1 2 QDFFN $T=366420 447440 0 0 $X=366420 $Y=447060
X77 259 256 271 1 2 QDFFN $T=367040 497840 1 0 $X=367040 $Y=492420
X78 1571 214 2008 1 2 QDFFN $T=379440 376880 1 180 $X=368900 $Y=376500
X79 237 256 2007 1 2 QDFFN $T=380060 386960 0 180 $X=369520 $Y=381540
X80 86 213 2030 1 2 QDFFN $T=370140 346640 1 0 $X=370140 $Y=341220
X81 1700 213 2044 1 2 QDFFN $T=370760 376880 1 0 $X=370760 $Y=371460
X82 253 256 2068 1 2 QDFFN $T=372620 437360 0 0 $X=372620 $Y=436980
X83 258 252 2069 1 2 QDFFN $T=375100 467600 1 0 $X=375100 $Y=462180
X84 255 252 2027 1 2 QDFFN $T=385640 477680 1 180 $X=375100 $Y=477300
X85 244 272 2073 1 2 QDFFN $T=376340 397040 0 0 $X=376340 $Y=396660
X86 258 256 2067 1 2 QDFFN $T=376340 457520 1 0 $X=376340 $Y=452100
X87 253 252 2072 1 2 QDFFN $T=378200 427280 0 0 $X=378200 $Y=426900
X88 237 272 2076 1 2 QDFFN $T=378820 397040 1 0 $X=378820 $Y=391620
X89 257 252 2048 1 2 QDFFN $T=389360 487760 0 180 $X=378820 $Y=482340
X90 240 256 2024 1 2 QDFFN $T=390600 417200 0 180 $X=380060 $Y=411780
X91 254 272 2081 1 2 QDFFN $T=380680 447440 0 0 $X=380680 $Y=447060
X92 118 214 2054 1 2 QDFFN $T=392460 336560 1 180 $X=381920 $Y=336180
X93 249 256 2033 1 2 QDFFN $T=392460 427280 0 180 $X=381920 $Y=421860
X94 1700 214 2053 1 2 QDFFN $T=393080 376880 1 180 $X=382540 $Y=376500
X95 1700 212 2051 1 2 QDFFN $T=393080 386960 0 180 $X=382540 $Y=381540
X96 160 214 2060 1 2 QDFFN $T=394320 366800 1 180 $X=383780 $Y=366420
X97 255 272 2099 1 2 QDFFN $T=383780 477680 1 0 $X=383780 $Y=472260
X98 155 214 2059 1 2 QDFFN $T=396180 336560 0 180 $X=385640 $Y=331140
X99 246 272 2080 1 2 QDFFN $T=385640 437360 1 0 $X=385640 $Y=431940
X100 257 272 2101 1 2 QDFFN $T=385640 487760 0 0 $X=385640 $Y=487380
X101 86 214 2070 1 2 QDFFN $T=396800 356720 1 180 $X=386260 $Y=356340
X102 246 256 2049 1 2 QDFFN $T=396800 417200 1 180 $X=386260 $Y=416820
X103 258 272 2104 1 2 QDFFN $T=386880 467600 0 0 $X=386880 $Y=467220
X104 257 278 2100 1 2 QDFFN $T=388120 477680 0 0 $X=388120 $Y=477300
X105 86 212 2064 1 2 QDFFN $T=399280 346640 1 180 $X=388740 $Y=346260
X106 160 212 2065 1 2 QDFFN $T=399900 366800 0 180 $X=389360 $Y=361380
X107 258 278 2102 1 2 QDFFN $T=389360 457520 1 0 $X=389360 $Y=452100
X108 118 212 2063 1 2 QDFFN $T=400520 346640 0 180 $X=389980 $Y=341220
X109 237 278 2083 1 2 QDFFN $T=404240 386960 1 180 $X=393700 $Y=386580
X110 155 285 2088 1 2 QDFFN $T=405480 336560 1 180 $X=394940 $Y=336180
X111 1571 285 2094 1 2 QDFFN $T=405480 376880 0 180 $X=394940 $Y=371460
X112 240 278 2091 1 2 QDFFN $T=405480 407120 0 180 $X=394940 $Y=401700
X113 254 278 2095 1 2 QDFFN $T=405480 447440 0 180 $X=394940 $Y=442020
X114 244 278 2077 1 2 QDFFN $T=406100 397040 1 180 $X=395560 $Y=396660
X115 1700 285 2122 1 2 QDFFN $T=398660 386960 1 0 $X=398660 $Y=381540
X116 282 256 2124 1 2 QDFFN $T=398660 427280 1 0 $X=398660 $Y=421860
X117 283 256 2125 1 2 QDFFN $T=398660 437360 1 0 $X=398660 $Y=431940
X118 284 256 2126 1 2 QDFFN $T=398660 487760 0 0 $X=398660 $Y=487380
X119 1820 285 2123 1 2 QDFFN $T=399280 356720 0 0 $X=399280 $Y=356340
X120 240 272 2085 1 2 QDFFN $T=409820 417200 1 180 $X=399280 $Y=416820
X121 246 278 2087 1 2 QDFFN $T=409820 427280 1 180 $X=399280 $Y=426900
X122 255 278 2106 1 2 QDFFN $T=410440 467600 1 180 $X=399900 $Y=467220
X123 286 256 2136 1 2 QDFFN $T=400520 407120 0 0 $X=400520 $Y=406740
X124 287 256 2131 1 2 QDFFN $T=400520 477680 0 0 $X=400520 $Y=477300
X125 288 256 2128 1 2 QDFFN $T=401140 457520 0 0 $X=401140 $Y=457140
X126 118 285 2110 1 2 QDFFN $T=412300 336560 0 180 $X=401760 $Y=331140
X127 289 242 2133 1 2 QDFFN $T=401760 447440 0 0 $X=401760 $Y=447060
X128 1801 285 2109 1 2 QDFFN $T=412920 366800 0 180 $X=402380 $Y=361380
X129 290 242 2130 1 2 QDFFN $T=402380 397040 1 0 $X=402380 $Y=391620
X130 289 256 2134 1 2 QDFFN $T=402380 457520 1 0 $X=402380 $Y=452100
X131 86 285 2111 1 2 QDFFN $T=413540 346640 0 180 $X=403000 $Y=341220
X132 284 242 2129 1 2 QDFFN $T=403000 487760 1 0 $X=403000 $Y=482340
X133 287 242 2127 1 2 QDFFN $T=406720 477680 1 0 $X=406720 $Y=472260
X134 290 256 2144 1 2 QDFFN $T=407340 386960 0 0 $X=407340 $Y=386580
X135 283 242 2140 1 2 QDFFN $T=407340 447440 1 0 $X=407340 $Y=442020
X136 292 242 2143 1 2 QDFFN $T=407960 407120 1 0 $X=407960 $Y=401700
X137 292 256 2147 1 2 QDFFN $T=408580 397040 0 0 $X=408580 $Y=396660
X138 1769 285 2163 1 2 QDFFN $T=411060 376880 1 0 $X=411060 $Y=371460
X139 86 295 2151 1 2 QDFFN $T=411680 356720 1 0 $X=411680 $Y=351300
X140 286 242 2132 1 2 QDFFN $T=422220 417200 1 180 $X=411680 $Y=416820
X141 282 242 2152 1 2 QDFFN $T=411680 427280 1 0 $X=411680 $Y=421860
X142 283 252 2158 1 2 QDFFN $T=411680 437360 1 0 $X=411680 $Y=431940
X143 155 295 2153 1 2 QDFFN $T=412300 336560 1 0 $X=412300 $Y=331140
X144 282 252 2161 1 2 QDFFN $T=412300 427280 0 0 $X=412300 $Y=426900
X145 288 242 2135 1 2 QDFFN $T=422840 467600 1 180 $X=412300 $Y=467220
X146 118 296 2159 1 2 QDFFN $T=412920 336560 0 0 $X=412920 $Y=336180
X147 160 285 2154 1 2 QDFFN $T=412920 356720 0 0 $X=412920 $Y=356340
X148 160 295 2160 1 2 QDFFN $T=413540 376880 0 0 $X=413540 $Y=376500
X149 118 295 2166 1 2 QDFFN $T=415400 366800 1 0 $X=415400 $Y=361380
X150 289 252 2139 1 2 QDFFN $T=425940 447440 1 180 $X=415400 $Y=447060
X151 118 297 2167 1 2 QDFFN $T=416020 346640 1 0 $X=416020 $Y=341220
X152 284 252 2137 1 2 QDFFN $T=426560 487760 0 180 $X=416020 $Y=482340
X153 288 278 2185 1 2 QDFFN $T=418500 477680 1 0 $X=418500 $Y=472260
X154 286 252 2138 1 2 QDFFN $T=429660 407120 1 180 $X=419120 $Y=406740
X155 253 272 2191 1 2 QDFFN $T=419740 447440 1 0 $X=419740 $Y=442020
X156 290 252 2146 1 2 QDFFN $T=431520 386960 1 180 $X=420980 $Y=386580
X157 288 252 2141 1 2 QDFFN $T=431520 457520 1 180 $X=420980 $Y=457140
X158 284 278 2198 1 2 QDFFN $T=420980 487760 0 0 $X=420980 $Y=487380
X159 292 252 2155 1 2 QDFFN $T=432140 397040 1 180 $X=421600 $Y=396660
X160 287 252 2142 1 2 QDFFN $T=432140 477680 1 180 $X=421600 $Y=477300
X161 289 278 2207 1 2 QDFFN $T=423460 457520 1 0 $X=423460 $Y=452100
X162 292 278 2209 1 2 QDFFN $T=424700 417200 0 0 $X=424700 $Y=416820
X163 86 309 2172 1 2 QDFFN $T=435860 356720 1 180 $X=425320 $Y=356340
X164 282 278 2211 1 2 QDFFN $T=425320 427280 0 0 $X=425320 $Y=426900
X165 292 272 2210 1 2 QDFFN $T=427800 407120 1 0 $X=427800 $Y=401700
X166 1769 309 2240 1 2 QDFFN $T=429040 376880 0 0 $X=429040 $Y=376500
X167 287 272 2223 1 2 QDFFN $T=429040 487760 1 0 $X=429040 $Y=482340
X168 160 309 2171 1 2 QDFFN $T=440200 376880 0 180 $X=429660 $Y=371460
X169 253 278 2219 1 2 QDFFN $T=429660 447440 0 0 $X=429660 $Y=447060
X170 287 278 2221 1 2 QDFFN $T=430900 477680 1 0 $X=430900 $Y=472260
X171 183 297 2200 1 2 QDFFN $T=443300 346640 0 180 $X=432760 $Y=341220
X172 183 296 2245 1 2 QDFFN $T=433380 356720 1 0 $X=433380 $Y=351300
X173 118 309 2184 1 2 QDFFN $T=443920 366800 0 180 $X=433380 $Y=361380
X174 282 272 2204 1 2 QDFFN $T=443920 437360 0 180 $X=433380 $Y=431940
X175 289 272 2205 1 2 QDFFN $T=443920 457520 1 180 $X=433380 $Y=457140
X176 118 315 2239 1 2 QDFFN $T=434000 336560 1 0 $X=434000 $Y=331140
X177 290 278 2203 1 2 QDFFN $T=444540 386960 1 180 $X=434000 $Y=386580
X178 290 272 2201 1 2 QDFFN $T=444540 397040 1 180 $X=434000 $Y=396660
X179 288 272 2192 1 2 QDFFN $T=445160 467600 1 180 $X=434620 $Y=467220
X180 249 272 2249 1 2 QDFFN $T=437100 417200 0 0 $X=437100 $Y=416820
X181 1769 296 2252 1 2 QDFFN $T=437720 356720 0 0 $X=437720 $Y=356340
X182 1769 297 2259 1 2 QDFFN $T=439580 366800 0 0 $X=439580 $Y=366420
X183 286 272 2228 1 2 QDFFN $T=450740 407120 0 180 $X=440200 $Y=401700
X184 283 272 2253 1 2 QDFFN $T=440200 447440 1 0 $X=440200 $Y=442020
X185 244 327 2233 1 2 QDFFN $T=451980 457520 0 180 $X=441440 $Y=452100
X186 283 278 2258 1 2 QDFFN $T=442060 427280 0 0 $X=442060 $Y=426900
X187 1769 295 2236 1 2 QDFFN $T=453220 386960 0 180 $X=442680 $Y=381540
X188 237 327 2230 1 2 QDFFN $T=453220 477680 0 180 $X=442680 $Y=472260
X189 254 327 2238 1 2 QDFFN $T=453220 487760 0 180 $X=442680 $Y=482340
X190 284 272 2224 1 2 QDFFN $T=453220 487760 1 180 $X=442680 $Y=487380
X191 118 323 2281 1 2 QDFFN $T=444540 336560 1 0 $X=444540 $Y=331140
X192 1769 315 2290 1 2 QDFFN $T=446400 356720 1 0 $X=446400 $Y=351300
X193 290 327 2282 1 2 QDFFN $T=447020 447440 0 0 $X=447020 $Y=447060
X194 1769 323 2295 1 2 QDFFN $T=448260 346640 1 0 $X=448260 $Y=341220
X195 286 278 2237 1 2 QDFFN $T=458800 407120 1 180 $X=448260 $Y=406740
X196 249 278 2246 1 2 QDFFN $T=460040 427280 0 180 $X=449500 $Y=421860
X197 1801 297 2302 1 2 QDFFN $T=450120 366800 0 0 $X=450120 $Y=366420
X198 1801 295 2306 1 2 QDFFN $T=451360 376880 0 0 $X=451360 $Y=376500
X199 1769 339 2314 1 2 QDFFN $T=452600 356720 0 0 $X=452600 $Y=356340
X200 258 327 2260 1 2 QDFFN $T=463760 467600 1 180 $X=453220 $Y=467220
X201 244 354 2286 1 2 QDFFN $T=465620 397040 1 180 $X=455080 $Y=396660
X202 292 327 2280 1 2 QDFFN $T=465620 477680 1 180 $X=455080 $Y=477300
X203 258 354 2291 1 2 QDFFN $T=467480 457520 1 180 $X=456940 $Y=457140
X204 254 354 2300 1 2 QDFFN $T=469340 457520 0 180 $X=458800 $Y=452100
X205 1801 323 2321 1 2 QDFFN $T=459420 346640 1 0 $X=459420 $Y=341220
X206 292 354 2301 1 2 QDFFN $T=469960 417200 1 180 $X=459420 $Y=416820
X207 254 355 2304 1 2 QDFFN $T=470580 447440 1 180 $X=460040 $Y=447060
X208 282 327 2293 1 2 QDFFN $T=471200 477680 0 180 $X=460660 $Y=472260
X209 1801 309 2310 1 2 QDFFN $T=471820 386960 0 180 $X=461280 $Y=381540
X210 237 355 2322 1 2 QDFFN $T=461900 407120 0 0 $X=461900 $Y=406740
X211 282 354 2312 1 2 QDFFN $T=472440 427280 1 180 $X=461900 $Y=426900
X212 183 339 360 1 2 QDFFN $T=462520 336560 1 0 $X=462520 $Y=331140
X213 282 355 2315 1 2 QDFFN $T=474920 437360 1 180 $X=464380 $Y=436980
X214 1801 339 2342 1 2 QDFFN $T=465000 356720 1 0 $X=465000 $Y=351300
X215 237 354 2328 1 2 QDFFN $T=467480 397040 1 0 $X=467480 $Y=391620
X216 292 355 2317 1 2 QDFFN $T=467480 427280 1 0 $X=467480 $Y=421860
X217 244 355 2303 1 2 QDFFN $T=479880 407120 0 180 $X=469340 $Y=401700
X218 240 327 2346 1 2 QDFFN $T=469340 457520 0 0 $X=469340 $Y=457140
X219 287 327 2329 1 2 QDFFN $T=479880 487760 0 180 $X=469340 $Y=482340
X220 1700 323 2358 1 2 QDFFN $T=469960 346640 1 0 $X=469960 $Y=341220
X221 1700 309 2359 1 2 QDFFN $T=469960 376880 1 0 $X=469960 $Y=371460
X222 258 355 2326 1 2 QDFFN $T=480500 467600 0 180 $X=469960 $Y=462180
X223 1700 295 2353 1 2 QDFFN $T=470580 376880 0 0 $X=470580 $Y=376500
X224 287 355 2363 1 2 QDFFN $T=470580 477680 0 0 $X=470580 $Y=477300
X225 359 354 2386 1 2 QDFFN $T=470580 487760 0 0 $X=470580 $Y=487380
X226 1801 296 2309 1 2 QDFFN $T=481740 366800 0 180 $X=471200 $Y=361380
X227 183 323 362 1 2 QDFFN $T=483600 336560 0 180 $X=473060 $Y=331140
X228 1571 295 2364 1 2 QDFFN $T=473060 386960 1 0 $X=473060 $Y=381540
X229 246 327 2340 1 2 QDFFN $T=483600 447440 0 180 $X=473060 $Y=442020
X230 240 354 2369 1 2 QDFFN $T=473680 417200 0 0 $X=473680 $Y=416820
X231 287 354 2367 1 2 QDFFN $T=473680 477680 1 0 $X=473680 $Y=472260
X232 240 355 2372 1 2 QDFFN $T=474920 417200 1 0 $X=474920 $Y=411780
X233 246 355 2366 1 2 QDFFN $T=476780 437360 0 0 $X=476780 $Y=436980
X234 290 354 2349 1 2 QDFFN $T=488560 397040 0 180 $X=478020 $Y=391620
X235 1820 295 2395 1 2 QDFFN $T=479880 356720 0 0 $X=479880 $Y=356340
X236 1801 315 2325 1 2 QDFFN $T=491040 346640 0 180 $X=480500 $Y=341220
X237 246 354 2362 1 2 QDFFN $T=491040 427280 0 180 $X=480500 $Y=421860
X238 249 327 2357 1 2 QDFFN $T=491660 457520 0 180 $X=481120 $Y=452100
X239 253 327 2388 1 2 QDFFN $T=482360 467600 0 0 $X=482360 $Y=467220
X240 284 354 2383 1 2 QDFFN $T=482360 487760 1 0 $X=482360 $Y=482340
X241 290 355 2343 1 2 QDFFN $T=493520 407120 0 180 $X=482980 $Y=401700
X242 373 309 2399 1 2 QDFFN $T=483600 336560 1 0 $X=483600 $Y=331140
X243 1571 309 2370 1 2 QDFFN $T=494140 376880 0 180 $X=483600 $Y=371460
X244 1700 315 2374 1 2 QDFFN $T=497240 346640 1 180 $X=486700 $Y=346260
X245 1820 309 2417 1 2 QDFFN $T=488560 366800 1 0 $X=488560 $Y=361380
X246 286 327 2391 1 2 QDFFN $T=499720 447440 0 180 $X=489180 $Y=442020
X247 286 354 2435 1 2 QDFFN $T=491040 417200 1 0 $X=491040 $Y=411780
X248 284 355 2376 1 2 QDFFN $T=502200 487760 1 180 $X=491660 $Y=487380
X249 249 354 2441 1 2 QDFFN $T=492900 417200 0 0 $X=492900 $Y=416820
X250 283 354 2445 1 2 QDFFN $T=492900 427280 1 0 $X=492900 $Y=421860
X251 1700 339 2413 1 2 QDFFN $T=505300 336560 1 180 $X=494760 $Y=336180
X252 373 297 403 1 2 QDFFN $T=495380 326480 0 0 $X=495380 $Y=326100
X253 1700 297 2455 1 2 QDFFN $T=495380 366800 0 0 $X=495380 $Y=366420
X254 1700 296 2462 1 2 QDFFN $T=496620 376880 0 0 $X=496620 $Y=376500
X255 1571 315 2454 1 2 QDFFN $T=498480 356720 1 0 $X=498480 $Y=351300
X256 253 354 2457 1 2 QDFFN $T=498480 437360 0 0 $X=498480 $Y=436980
X257 1571 323 2463 1 2 QDFFN $T=499720 346640 1 0 $X=499720 $Y=341220
X258 1820 296 2464 1 2 QDFFN $T=500340 356720 0 0 $X=500340 $Y=356340
X259 283 327 2408 1 2 QDFFN $T=512740 447440 1 180 $X=502200 $Y=447060
X260 1571 296 2473 1 2 QDFFN $T=502820 386960 1 0 $X=502820 $Y=381540
X261 255 327 2433 1 2 QDFFN $T=513360 477680 0 180 $X=502820 $Y=472260
X262 257 355 2465 1 2 QDFFN $T=502820 487760 0 0 $X=502820 $Y=487380
X263 289 327 2403 1 2 QDFFN $T=513980 467600 0 180 $X=503440 $Y=462180
X264 283 355 2439 1 2 QDFFN $T=515220 427280 1 180 $X=504680 $Y=426900
X265 257 327 2427 1 2 QDFFN $T=515220 497840 0 180 $X=504680 $Y=492420
X266 257 354 2469 1 2 QDFFN $T=505300 477680 0 0 $X=505300 $Y=477300
X267 249 355 2453 1 2 QDFFN $T=505920 427280 1 0 $X=505920 $Y=421860
X268 288 327 2444 1 2 QDFFN $T=516460 467600 1 180 $X=505920 $Y=467220
X269 373 339 2475 1 2 QDFFN $T=506540 336560 0 0 $X=506540 $Y=336180
X270 289 354 2483 1 2 QDFFN $T=506540 457520 1 0 $X=506540 $Y=452100
X271 253 355 2466 1 2 QDFFN $T=509020 447440 1 0 $X=509020 $Y=442020
X272 1571 297 2478 1 2 QDFFN $T=512120 376880 0 0 $X=512120 $Y=376500
X273 286 355 2450 1 2 QDFFN $T=522660 417200 1 180 $X=512120 $Y=416820
X274 1571 339 2470 1 2 QDFFN $T=524520 356720 1 180 $X=513980 $Y=356340
X275 289 355 2489 1 2 QDFFN $T=514600 447440 0 0 $X=514600 $Y=447060
X276 1820 297 2461 1 2 QDFFN $T=515220 366800 1 0 $X=515220 $Y=361380
X277 1820 339 2474 1 2 QDFFN $T=526380 346640 1 180 $X=515840 $Y=346260
X278 255 355 2476 1 2 QDFFN $T=517700 477680 0 0 $X=517700 $Y=477300
X279 408 355 418 1 2 QDFFN $T=517700 497840 1 0 $X=517700 $Y=492420
X280 1820 315 2472 1 2 QDFFN $T=528860 336560 1 180 $X=518320 $Y=336180
X281 288 355 2477 1 2 QDFFN $T=518320 467600 0 0 $X=518320 $Y=467220
X282 373 315 2467 1 2 QDFFN $T=530100 326480 1 180 $X=519560 $Y=326100
X283 1820 323 2468 1 2 QDFFN $T=531960 346640 0 180 $X=521420 $Y=341220
X284 288 354 2484 1 2 QDFFN $T=522660 467600 1 0 $X=522660 $Y=462180
X285 255 354 2485 1 2 QDFFN $T=522660 477680 1 0 $X=522660 $Y=472260
X286 259 354 431 1 2 QDFFN $T=530100 497840 1 0 $X=530100 $Y=492420
X287 25 18 1351 15 1 1359 2 AOI22S $T=228780 497840 0 180 $X=225060 $Y=492420
X288 1394 1329 31 1347 1 1353 2 AOI22S $T=231880 437360 1 180 $X=228160 $Y=436980
X289 25 37 1405 1395 1 1393 2 AOI22S $T=234360 457520 1 180 $X=230640 $Y=457140
X290 1326 1330 1435 1337 1 1375 2 AOI22S $T=238700 407120 0 180 $X=234980 $Y=401700
X291 1440 1425 1431 1362 1 1375 2 AOI22S $T=238700 407120 1 180 $X=234980 $Y=406740
X292 1401 25 1414 1446 1 1433 2 AOI22S $T=235600 457520 0 0 $X=235600 $Y=457140
X293 40 1383 1438 1432 1 1372 2 AOI22S $T=240560 447440 0 180 $X=236840 $Y=442020
X294 1423 52 1430 55 1 1362 2 AOI22S $T=238080 417200 1 0 $X=238080 $Y=411780
X295 1483 57 1470 75 1 1465 2 AOI22S $T=246140 447440 1 0 $X=246140 $Y=442020
X296 1511 1476 1509 1326 1 1423 2 AOI22S $T=251720 407120 0 180 $X=248000 $Y=401700
X297 1521 1507 1415 1487 1 1502 2 AOI22S $T=252340 386960 0 180 $X=248620 $Y=381540
X298 25 1523 1517 1499 1 1510 2 AOI22S $T=255440 437360 1 180 $X=251720 $Y=436980
X299 1537 1401 1529 1337 1 1504 2 AOI22S $T=256060 407120 1 180 $X=252340 $Y=406740
X300 1440 1330 1562 1353 1 1349 2 AOI22S $T=259780 386960 1 180 $X=256060 $Y=386580
X301 55 1423 1541 1349 1 103 2 AOI22S $T=256680 417200 1 0 $X=256680 $Y=411780
X302 1537 52 1554 75 1 1349 2 AOI22S $T=260400 427280 0 180 $X=256680 $Y=421860
X303 75 55 1545 32 1 14 2 AOI22S $T=259160 477680 1 0 $X=259160 $Y=472260
X304 75 1336 1566 1364 1 1584 2 AOI22S $T=260400 427280 1 0 $X=260400 $Y=421860
X305 1594 1518 1597 128 1 126 2 AOI22S $T=265980 356720 0 0 $X=265980 $Y=356340
X306 1425 55 1598 1555 1 1610 2 AOI22S $T=265980 407120 1 0 $X=265980 $Y=401700
X307 1585 1591 1606 122 1 124 2 AOI22S $T=267220 336560 1 0 $X=267220 $Y=331140
X308 1639 1629 1631 128 1 126 2 AOI22S $T=274660 356720 1 180 $X=270940 $Y=356340
X309 1604 1476 1655 1423 1 1614 2 AOI22S $T=278380 397040 1 180 $X=274660 $Y=396660
X310 1628 1498 1641 122 1 124 2 AOI22S $T=275900 346640 1 0 $X=275900 $Y=341220
X311 1640 1660 1653 128 1 126 2 AOI22S $T=277760 366800 1 0 $X=277760 $Y=361380
X312 1522 1330 1658 1511 1 1670 2 AOI22S $T=278380 407120 1 0 $X=278380 $Y=401700
X313 1663 1527 1652 1349 1 1762 2 AOI22S $T=279000 386960 0 0 $X=279000 $Y=386580
X314 18 103 142 1368 1 1683 2 AOI22S $T=279620 497840 1 0 $X=279620 $Y=492420
X315 1648 144 1679 122 1 124 2 AOI22S $T=281480 326480 0 0 $X=281480 $Y=326100
X316 14 147 1699 146 1 1522 2 AOI22S $T=285200 467600 1 180 $X=281480 $Y=467220
X317 1638 1677 1687 122 1 124 2 AOI22S $T=282720 346640 1 0 $X=282720 $Y=341220
X318 1349 25 1705 1674 1 1681 2 AOI22S $T=286440 447440 0 180 $X=282720 $Y=442020
X319 1636 1694 1690 1698 1 1623 2 AOI22S $T=283960 417200 1 0 $X=283960 $Y=411780
X320 1457 1663 1704 1696 1 1614 2 AOI22S $T=288300 397040 1 180 $X=284580 $Y=396660
X321 1694 1383 1657 1477 1 1706 2 AOI22S $T=285200 386960 1 0 $X=285200 $Y=381540
X322 62 1326 1709 1347 1 18 2 AOI22S $T=288920 437360 1 180 $X=285200 $Y=436980
X323 146 1368 1720 1711 1 159 2 AOI22S $T=292020 487760 0 180 $X=288300 $Y=482340
X324 1746 1740 1748 128 1 126 2 AOI22S $T=298220 366800 1 0 $X=298220 $Y=361380
X325 1756 1537 1759 1745 1 1749 2 AOI22S $T=301940 397040 1 180 $X=298220 $Y=396660
X326 18 1349 1774 1537 1 177 2 AOI22S $T=302560 437360 1 180 $X=298840 $Y=436980
X327 1771 1537 1736 1483 1 1756 2 AOI22S $T=303180 407120 0 180 $X=299460 $Y=401700
X328 1764 1735 1775 122 1 124 2 AOI22S $T=303180 346640 1 0 $X=303180 $Y=341220
X329 1761 1784 1776 122 1 124 2 AOI22S $T=306280 346640 0 0 $X=306280 $Y=346260
X330 37 1756 1646 1810 1 198 2 AOI22S $T=310000 437360 1 0 $X=310000 $Y=431940
X331 1832 1819 1799 128 1 126 2 AOI22S $T=315580 366800 0 180 $X=311860 $Y=361380
X332 1793 62 1824 1522 1 1694 2 AOI22S $T=315580 427280 0 180 $X=311860 $Y=421860
X333 1457 40 1821 125 1 1538 2 AOI22S $T=315580 437360 1 0 $X=315580 $Y=431940
X334 1663 1368 1823 121 1 1811 2 AOI22S $T=319920 427280 1 180 $X=316200 $Y=426900
X335 1856 1826 1852 128 1 126 2 AOI22S $T=320540 366800 0 180 $X=316820 $Y=361380
X336 1663 1456 1783 1368 1 1793 2 AOI22S $T=319920 427280 0 0 $X=319920 $Y=426900
X337 1841 1863 1849 122 1 124 2 AOI22S $T=322400 346640 1 0 $X=322400 $Y=341220
X338 1889 1882 1878 128 1 126 2 AOI22S $T=329220 366800 0 180 $X=325500 $Y=361380
X339 1869 1887 1883 122 1 124 2 AOI22S $T=327360 336560 1 0 $X=327360 $Y=331140
X340 1368 133 1885 125 1 1894 2 AOI22S $T=327360 487760 0 0 $X=327360 $Y=487380
X341 1522 1465 1892 1898 1 1900 2 AOI22S $T=329220 447440 1 0 $X=329220 $Y=442020
X342 1927 1941 1938 233 1 234 2 AOI22S $T=342860 346640 1 0 $X=342860 $Y=341220
X343 1935 1939 1949 239 1 236 2 AOI22S $T=344100 366800 0 0 $X=344100 $Y=366420
X344 1951 1948 1954 239 1 236 2 AOI22S $T=345960 356720 1 0 $X=345960 $Y=351300
X345 1932 1934 1955 233 1 234 2 AOI22S $T=345960 376880 1 0 $X=345960 $Y=371460
X346 1968 1959 1981 239 1 236 2 AOI22S $T=351540 346640 0 180 $X=347820 $Y=341220
X347 1973 1979 1975 233 1 234 2 AOI22S $T=352780 376880 1 0 $X=352780 $Y=371460
X348 1969 218 1978 1985 1 1953 2 AOI22S $T=353400 457520 1 0 $X=353400 $Y=452100
X349 1991 1988 1989 239 1 236 2 AOI22S $T=359600 356720 1 180 $X=355880 $Y=356340
X350 2008 2003 1999 233 1 234 2 AOI22S $T=368280 376880 0 180 $X=364560 $Y=371460
X351 2005 2011 2017 267 1 236 2 AOI22S $T=372000 336560 1 0 $X=372000 $Y=331140
X352 2010 2028 2021 267 1 236 2 AOI22S $T=373240 356720 0 0 $X=373240 $Y=356340
X353 2013 2030 2029 267 1 236 2 AOI22S $T=373860 346640 0 0 $X=373860 $Y=346260
X354 2031 2044 2047 267 1 236 2 AOI22S $T=380680 356720 1 180 $X=376960 $Y=356340
X355 2053 2051 2038 274 1 234 2 AOI22S $T=383160 366800 0 180 $X=379440 $Y=361380
X356 2059 275 2026 274 1 234 2 AOI22S $T=383780 336560 0 180 $X=380060 $Y=331140
X357 2070 2064 2045 274 1 234 2 AOI22S $T=386880 356720 0 180 $X=383160 $Y=351300
X358 2054 2063 2037 274 1 234 2 AOI22S $T=383780 346640 1 0 $X=383780 $Y=341220
X359 2060 2065 2057 274 1 234 2 AOI22S $T=383780 366800 1 0 $X=383780 $Y=361380
X360 2088 270 2093 280 1 281 2 AOI22S $T=394320 326480 0 0 $X=394320 $Y=326100
X361 2094 2000 2103 280 1 281 2 AOI22S $T=397420 366800 0 0 $X=397420 $Y=366420
X362 2111 2071 2108 280 1 281 2 AOI22S $T=403000 346640 1 180 $X=399280 $Y=346260
X363 2109 1970 2112 280 1 281 2 AOI22S $T=402380 366800 0 0 $X=402380 $Y=366420
X364 2122 2040 2120 280 1 281 2 AOI22S $T=409820 366800 1 180 $X=406100 $Y=366420
X365 2123 1995 2121 280 1 281 2 AOI22S $T=410440 346640 1 180 $X=406720 $Y=346260
X366 2110 2043 2119 280 1 281 2 AOI22S $T=407340 336560 0 0 $X=407340 $Y=336180
X367 2154 2058 2164 280 1 281 2 AOI22S $T=414160 366800 1 180 $X=410440 $Y=366420
X368 2163 1992 2175 280 1 281 2 AOI22S $T=425940 376880 0 180 $X=422220 $Y=371460
X369 2151 2172 2170 304 1 305 2 AOI22S $T=424700 356720 1 0 $X=424700 $Y=351300
X370 2160 2171 2168 304 1 305 2 AOI22S $T=424700 376880 0 0 $X=424700 $Y=376500
X371 2153 307 2181 304 1 305 2 AOI22S $T=427800 336560 1 0 $X=427800 $Y=331140
X372 2166 2184 2178 304 1 305 2 AOI22S $T=427800 366800 1 0 $X=427800 $Y=361380
X373 2236 2240 2256 304 1 305 2 AOI22S $T=445780 376880 0 180 $X=442060 $Y=371460
X374 2230 319 2235 320 1 321 2 AOI22S $T=442060 477680 0 0 $X=442060 $Y=477300
X375 2233 322 2247 320 1 321 2 AOI22S $T=445160 457520 0 0 $X=445160 $Y=457140
X376 2238 326 2254 320 1 321 2 AOI22S $T=446400 477680 0 0 $X=446400 $Y=477300
X377 2280 333 2279 320 1 321 2 AOI22S $T=453840 477680 1 180 $X=450120 $Y=477300
X378 2260 335 2275 320 1 321 2 AOI22S $T=451980 457520 0 0 $X=451980 $Y=457140
X379 2282 342 2278 320 1 321 2 AOI22S $T=453840 457520 1 0 $X=453840 $Y=452100
X380 2293 344 2294 320 1 321 2 AOI22S $T=458180 477680 0 180 $X=454460 $Y=472260
X381 2286 2303 2255 350 1 352 2 AOI22S $T=458800 407120 1 0 $X=458800 $Y=401700
X382 2300 2304 2288 350 1 352 2 AOI22S $T=458800 447440 1 0 $X=458800 $Y=442020
X383 2312 2315 2305 350 1 352 2 AOI22S $T=461900 437360 1 0 $X=461900 $Y=431940
X384 2301 2317 2272 350 1 352 2 AOI22S $T=462520 427280 1 0 $X=462520 $Y=421860
X385 2328 2322 2241 350 1 352 2 AOI22S $T=467480 407120 0 180 $X=463760 $Y=401700
X386 2329 320 2333 356 1 321 2 AOI22S $T=467480 487760 0 180 $X=463760 $Y=482340
X387 2291 2326 2264 350 1 352 2 AOI22S $T=465620 467600 0 0 $X=465620 $Y=467220
X388 2306 2310 2327 304 1 305 2 AOI22S $T=466240 376880 1 0 $X=466240 $Y=371460
X389 2346 363 2338 320 1 321 2 AOI22S $T=474920 457520 0 180 $X=471200 $Y=452100
X390 2349 2343 2271 350 1 352 2 AOI22S $T=476160 397040 1 180 $X=472440 $Y=396660
X391 2340 365 2348 320 1 321 2 AOI22S $T=475540 457520 1 0 $X=475540 $Y=452100
X392 2353 2359 2355 304 1 305 2 AOI22S $T=479260 366800 0 0 $X=479260 $Y=366420
X393 2362 2366 2347 350 1 352 2 AOI22S $T=481120 437360 1 0 $X=481120 $Y=431940
X394 2357 371 2361 320 1 321 2 AOI22S $T=481120 457520 0 0 $X=481120 $Y=457140
X395 2367 2363 2330 350 1 352 2 AOI22S $T=482360 477680 0 0 $X=482360 $Y=477300
X396 2369 2372 2336 350 1 352 2 AOI22S $T=484840 417200 0 0 $X=484840 $Y=416820
X397 2383 2376 2368 350 1 352 2 AOI22S $T=488560 497840 0 180 $X=484840 $Y=492420
X398 2388 378 2381 320 1 321 2 AOI22S $T=489180 457520 1 180 $X=485460 $Y=457140
X399 2391 380 2385 320 1 321 2 AOI22S $T=489800 447440 1 180 $X=486080 $Y=447060
X400 2364 2370 2377 304 1 305 2 AOI22S $T=486700 366800 0 0 $X=486700 $Y=366420
X401 2386 384 383 350 1 352 2 AOI22S $T=488560 497840 1 0 $X=488560 $Y=492420
X402 2403 386 2406 320 1 321 2 AOI22S $T=492900 457520 1 180 $X=489180 $Y=457140
X403 390 2399 368 304 1 305 2 AOI22S $T=494140 326480 1 180 $X=490420 $Y=326100
X404 2408 388 2405 320 1 321 2 AOI22S $T=494140 447440 1 180 $X=490420 $Y=447060
X405 2395 2417 2416 304 1 305 2 AOI22S $T=494760 356720 1 0 $X=494760 $Y=351300
X406 2427 394 2440 320 1 321 2 AOI22S $T=498480 487760 0 180 $X=494760 $Y=482340
X407 2433 397 2415 320 1 321 2 AOI22S $T=500340 477680 0 180 $X=496620 $Y=472260
X408 2445 2439 2430 350 1 352 2 AOI22S $T=503440 427280 1 180 $X=499720 $Y=426900
X409 2444 399 2443 320 1 321 2 AOI22S $T=503440 467600 1 180 $X=499720 $Y=467220
X410 2435 2450 2382 350 1 352 2 AOI22S $T=504060 417200 1 0 $X=504060 $Y=411780
X411 2441 2453 2389 350 1 352 2 AOI22S $T=505920 417200 0 0 $X=505920 $Y=416820
X412 2457 2466 2390 350 1 352 2 AOI22S $T=512740 437360 0 0 $X=512740 $Y=436980
X413 2484 2477 2436 350 1 352 2 AOI22S $T=518940 467600 0 180 $X=515220 $Y=462180
X414 2485 2476 2410 350 1 352 2 AOI22S $T=518940 477680 0 180 $X=515220 $Y=472260
X415 2469 2465 2434 350 1 352 2 AOI22S $T=515840 487760 0 0 $X=515840 $Y=487380
X416 2483 2489 2423 350 1 352 2 AOI22S $T=525760 457520 0 180 $X=522040 $Y=452100
X417 775 777 770 3912 1 786 2 AOI22S $T=846920 336560 0 0 $X=846920 $Y=336180
X418 777 784 3867 775 1 786 2 AOI22S $T=847540 336560 1 0 $X=847540 $Y=331140
X419 788 792 3929 784 1 786 2 AOI22S $T=854980 356720 0 180 $X=851260 $Y=351300
X420 779 784 778 803 1 805 2 AOI22S $T=855600 356720 1 0 $X=855600 $Y=351300
X421 786 808 772 816 1 805 2 AOI22S $T=857460 346640 1 0 $X=857460 $Y=341220
X422 3949 805 804 3912 1 826 2 AOI22S $T=859320 336560 0 0 $X=859320 $Y=336180
X423 808 823 3953 829 1 779 2 AOI22S $T=864280 336560 1 0 $X=864280 $Y=331140
X424 775 821 4036 802 1 784 2 AOI22S $T=874200 346640 1 0 $X=874200 $Y=341220
X425 859 3949 4073 4013 1 4082 2 AOI22S $T=882260 326480 0 0 $X=882260 $Y=326100
X426 889 865 888 802 1 801 2 AOI22S $T=891560 326480 1 180 $X=887840 $Y=326100
X427 895 792 4104 4119 1 899 2 AOI22S $T=892180 376880 1 0 $X=892180 $Y=371460
X428 4114 4122 4083 4099 1 4128 2 AOI22S $T=892800 397040 0 0 $X=892800 $Y=396660
X429 4151 4152 4101 910 1 4099 2 AOI22S $T=901480 397040 1 180 $X=897760 $Y=396660
X430 800 809 4140 4172 1 4127 2 AOI22S $T=898380 346640 0 0 $X=898380 $Y=346260
X431 779 792 918 815 1 852 2 AOI22S $T=903960 326480 1 180 $X=900240 $Y=326100
X432 919 816 4147 4082 1 910 2 AOI22S $T=903960 336560 0 0 $X=903960 $Y=336180
X433 933 816 948 931 1 930 2 AOI22S $T=912640 326480 1 180 $X=908920 $Y=326100
X434 865 809 4221 4222 1 4238 2 AOI22S $T=911400 336560 0 0 $X=911400 $Y=336180
X435 4240 809 4234 4227 1 4078 2 AOI22S $T=916360 386960 0 180 $X=912640 $Y=381540
X436 924 941 4042 943 1 4256 2 AOI22S $T=915740 336560 1 0 $X=915740 $Y=331140
X437 245 4240 4251 241 1 4264 2 AOI22S $T=925660 386960 1 180 $X=921940 $Y=386580
X438 779 924 961 808 1 4082 2 AOI22S $T=926900 336560 0 180 $X=923180 $Y=331140
X439 779 786 4294 808 1 4256 2 AOI22S $T=926900 336560 0 0 $X=926900 $Y=336180
X440 4314 854 4308 4242 1 4267 2 AOI22S $T=931240 386960 0 180 $X=927520 $Y=381540
X441 933 786 4407 4260 1 1003 2 AOI22S $T=952320 326480 1 180 $X=948600 $Y=326100
X442 865 933 4422 1011 1 4402 2 AOI22S $T=956660 326480 1 180 $X=952940 $Y=326100
X443 245 1014 4432 1012 1 4413 2 AOI22S $T=957280 376880 1 180 $X=953560 $Y=376500
X444 4395 4450 4446 4441 1 4436 2 AOI22S $T=959760 386960 0 0 $X=959760 $Y=386580
X445 1014 4462 4445 1027 1 4469 2 AOI22S $T=961620 376880 1 0 $X=961620 $Y=371460
X446 4492 4486 4474 1033 1 4441 2 AOI22S $T=969680 376880 1 180 $X=965960 $Y=376500
X447 4475 1004 4489 1016 1 1031 2 AOI22S $T=967820 336560 0 0 $X=967820 $Y=336180
X448 1064 4553 4561 1060 1 1030 2 AOI22S $T=983940 346640 1 180 $X=980220 $Y=346260
X449 1104 4646 4643 4650 1 1033 2 AOI22S $T=998200 356720 1 0 $X=998200 $Y=351300
X450 4674 4462 4668 4704 1 4694 2 AOI22S $T=1003780 376880 1 0 $X=1003780 $Y=371460
X451 4685 1088 4712 1119 1 4619 2 AOI22S $T=1010600 386960 1 180 $X=1006880 $Y=386580
X452 4619 1101 4701 4620 1 4596 2 AOI22S $T=1010600 407120 1 0 $X=1010600 $Y=401700
X453 1124 4690 4723 4717 1 4650 2 AOI22S $T=1013080 366800 0 0 $X=1013080 $Y=366420
X454 1147 4596 4771 4761 1 1152 2 AOI22S $T=1021140 336560 1 0 $X=1021140 $Y=331140
X455 4706 4553 4856 4623 1 4629 2 AOI22S $T=1027960 397040 0 180 $X=1024240 $Y=391620
X456 4721 4777 4725 4623 1 4629 2 AOI22S $T=1026100 366800 0 0 $X=1026100 $Y=366420
X457 4777 4462 4817 4614 1 4805 2 AOI22S $T=1030440 376880 0 180 $X=1026720 $Y=371460
X458 4721 4623 4835 4579 1 1124 2 AOI22S $T=1032300 346640 0 180 $X=1028580 $Y=341220
X459 4842 1168 4814 1088 1 4721 2 AOI22S $T=1032920 356720 0 180 $X=1029200 $Y=351300
X460 1138 4623 4819 4674 1 1171 2 AOI22S $T=1029820 386960 0 0 $X=1029820 $Y=386580
X461 4623 1101 4825 4579 1 1178 2 AOI22S $T=1032920 397040 0 0 $X=1032920 $Y=396660
X462 1184 4553 4862 4858 1 1174 2 AOI22S $T=1037880 356720 1 180 $X=1034160 $Y=356340
X463 4842 4685 4864 4646 1 4596 2 AOI22S $T=1038500 386960 0 180 $X=1034780 $Y=381540
X464 4690 4596 4876 4871 1 4858 2 AOI22S $T=1040980 407120 0 180 $X=1037260 $Y=401700
X465 4706 1191 4831 1192 1 1195 2 AOI22S $T=1038500 326480 0 0 $X=1038500 $Y=326100
X466 4658 1124 4882 1190 1 4646 2 AOI22S $T=1039740 356720 1 0 $X=1039740 $Y=351300
X467 1068 1101 4722 1178 1 4842 2 AOI22S $T=1039740 407120 0 0 $X=1039740 $Y=406740
X468 1178 1068 4909 4871 1 4842 2 AOI22S $T=1045320 407120 0 180 $X=1041600 $Y=401700
X469 1152 4646 4919 4865 1 1203 2 AOI22S $T=1047800 346640 0 180 $X=1044080 $Y=341220
X470 1178 1171 4911 1088 1 4922 2 AOI22S $T=1044700 397040 0 0 $X=1044700 $Y=396660
X471 4842 4623 4959 4685 1 1190 2 AOI22S $T=1056480 376880 0 0 $X=1056480 $Y=376500
X472 4629 1239 4968 1152 1 4996 2 AOI22S $T=1060820 366800 0 0 $X=1060820 $Y=366420
X473 1190 4462 4982 4922 1 4629 2 AOI22S $T=1061440 376880 0 0 $X=1061440 $Y=376500
X474 1242 4579 4992 1124 1 4922 2 AOI22S $T=1065160 397040 0 180 $X=1061440 $Y=391620
X475 4620 4811 4997 4462 1 4623 2 AOI22S $T=1065160 407120 0 180 $X=1061440 $Y=401700
X476 4553 4706 4880 4811 1 4619 2 AOI22S $T=1065160 397040 0 0 $X=1065160 $Y=396660
X477 1245 4924 4928 5011 1 1184 2 AOI22S $T=1066400 366800 0 0 $X=1066400 $Y=366420
X478 1245 1101 5003 4685 1 1184 2 AOI22S $T=1066400 376880 0 0 $X=1066400 $Y=376500
X479 4579 4620 4925 4922 1 5011 2 AOI22S $T=1066400 397040 1 0 $X=1066400 $Y=391620
X480 4811 1192 5015 1248 1 5009 2 AOI22S $T=1070740 366800 0 180 $X=1067020 $Y=361380
X481 1152 4842 5037 4791 1 1249 2 AOI22S $T=1071360 356720 0 180 $X=1067640 $Y=351300
X482 4706 4553 4750 1101 1 4842 2 AOI22S $T=1070120 397040 0 0 $X=1070120 $Y=396660
X483 4619 4811 5034 4685 1 4650 2 AOI22S $T=1074460 386960 1 180 $X=1070740 $Y=386580
X484 4619 4553 4908 4922 1 1190 2 AOI22S $T=1075080 376880 0 180 $X=1071360 $Y=371460
X485 4619 4842 5047 4685 1 5009 2 AOI22S $T=1075700 366800 1 180 $X=1071980 $Y=366420
X486 1190 4658 5033 4842 1 1101 2 AOI22S $T=1075700 386960 0 180 $X=1071980 $Y=381540
X487 1178 4579 5017 4623 1 1101 2 AOI22S $T=1075080 407120 1 0 $X=1075080 $Y=401700
X488 4777 1152 5073 1278 1 5079 2 AOI22S $T=1084380 376880 1 0 $X=1084380 $Y=371460
X489 1356 1340 1 2 1324 AN2 $T=227540 427280 0 180 $X=225060 $Y=421860
X490 80 82 1 2 1520 AN2 $T=250480 477680 1 0 $X=250480 $Y=472260
X491 1529 1509 1 2 1398 AN2 $T=254200 407120 0 180 $X=251720 $Y=401700
X492 1554 1595 1 2 1579 AN2 $T=267220 427280 0 180 $X=264740 $Y=421860
X493 42 105 1 2 120 AN2 $T=270940 497840 0 180 $X=268460 $Y=492420
X494 123 1620 1 2 1603 AN2 $T=271560 467600 1 180 $X=269080 $Y=467220
X495 67 1575 1 2 1612 AN2 $T=274660 487760 0 180 $X=272180 $Y=482340
X496 1642 1464 1 2 1340 AN2 $T=277140 417200 0 180 $X=274660 $Y=411780
X497 1597 1606 1 2 1668 AN2 $T=275280 346640 0 0 $X=275280 $Y=346260
X498 1631 1641 1 2 1669 AN2 $T=275900 356720 1 0 $X=275900 $Y=351300
X499 1653 1687 1 2 1693 AN2 $T=282720 366800 1 0 $X=282720 $Y=361380
X500 1699 1691 1 2 1550 AN2 $T=285200 427280 1 180 $X=282720 $Y=426900
X501 153 1679 1 2 1716 AN2 $T=285820 326480 0 0 $X=285820 $Y=326100
X502 33 165 1 2 1702 AN2 $T=293880 477680 0 180 $X=291400 $Y=472260
X503 1748 1776 1 2 1792 AN2 $T=303180 366800 1 0 $X=303180 $Y=361380
X504 1783 1763 1 2 1671 AN2 $T=305660 427280 0 180 $X=303180 $Y=421860
X505 1786 1737 1 2 1804 AN2 $T=308140 386960 0 0 $X=308140 $Y=386580
X506 1799 1775 1 2 1808 AN2 $T=308760 366800 1 0 $X=308760 $Y=361380
X507 1824 1823 1 2 1773 AN2 $T=315580 427280 1 180 $X=313100 $Y=426900
X508 190 148 1 2 1851 AN2 $T=320540 477680 0 0 $X=320540 $Y=477300
X509 1852 1849 1 2 1867 AN2 $T=322400 366800 1 0 $X=322400 $Y=361380
X510 1854 1868 1 2 1523 AN2 $T=325500 437360 1 180 $X=323020 $Y=436980
X511 1877 1872 1 2 40 AN2 $T=326120 467600 0 180 $X=323640 $Y=462180
X512 1878 1883 1 2 1891 AN2 $T=326740 346640 1 0 $X=326740 $Y=341220
X513 1884 209 1 2 1456 AN2 $T=329220 427280 0 180 $X=326740 $Y=421860
X514 1563 1635 1 2 1794 AN2 $T=331080 397040 1 180 $X=328600 $Y=396660
X515 1899 1880 1 2 150 AN2 $T=331080 477680 0 180 $X=328600 $Y=472260
X516 1919 1905 1 2 1838 AN2 $T=337280 447440 1 180 $X=334800 $Y=447060
X517 1922 206 1 2 96 AN2 $T=337900 487760 0 180 $X=335420 $Y=482340
X518 1903 1789 1 2 1925 AN2 $T=337280 427280 1 0 $X=337280 $Y=421860
X519 215 1919 1 2 1835 AN2 $T=339760 447440 1 180 $X=337280 $Y=447060
X520 1737 1672 1 2 1622 AN2 $T=339140 386960 0 0 $X=339140 $Y=386580
X521 1943 1862 1 2 1921 AN2 $T=344720 417200 1 180 $X=342240 $Y=416820
X522 1952 1944 1 2 1756 AN2 $T=345340 437360 1 180 $X=342860 $Y=436980
X523 1976 238 1 2 1877 AN2 $T=354020 477680 0 180 $X=351540 $Y=472260
X524 1907 1854 1 2 1993 AN2 $T=357120 457520 1 0 $X=357120 $Y=452100
X525 1976 241 1 2 1899 AN2 $T=360220 477680 1 180 $X=357740 $Y=477300
X526 251 1972 1 2 1994 AN2 $T=357740 487760 0 0 $X=357740 $Y=487380
X527 301 316 1 2 277 AN2 $T=437720 497840 1 0 $X=437720 $Y=492420
X528 2486 417 1 2 2505 AN2 $T=527000 376880 0 0 $X=527000 $Y=376500
X529 2492 417 1 2 2500 AN2 $T=528240 366800 1 0 $X=528240 $Y=361380
X530 422 417 1 2 2507 AN2 $T=530100 336560 0 0 $X=530100 $Y=336180
X531 2588 2609 1 2 2618 AN2 $T=557380 386960 0 0 $X=557380 $Y=386580
X532 2563 417 1 2 2585 AN2 $T=557380 427280 1 0 $X=557380 $Y=421860
X533 2659 2656 1 2 2623 AN2 $T=568540 407120 0 180 $X=566060 $Y=401700
X534 2623 2657 1 2 2658 AN2 $T=566680 407120 0 0 $X=566680 $Y=406740
X535 2658 2645 1 2 2672 AN2 $T=567920 417200 0 0 $X=567920 $Y=416820
X536 2624 417 1 2 2670 AN2 $T=567920 437360 1 0 $X=567920 $Y=431940
X537 461 2664 1 2 2674 AN2 $T=569160 336560 0 0 $X=569160 $Y=336180
X538 2644 2618 1 2 2656 AN2 $T=569780 397040 1 0 $X=569780 $Y=391620
X539 2674 2653 1 2 2688 AN2 $T=571020 336560 1 0 $X=571020 $Y=331140
X540 2661 2666 1 2 2600 AN2 $T=573500 376880 1 180 $X=571020 $Y=376500
X541 2698 2684 1 2 2566 AN2 $T=573500 397040 1 180 $X=571020 $Y=396660
X542 2697 2713 1 2 2718 AN2 $T=576600 336560 1 0 $X=576600 $Y=331140
X543 2704 2688 1 2 2713 AN2 $T=576600 346640 1 0 $X=576600 $Y=341220
X544 2706 417 1 2 2681 AN2 $T=576600 457520 1 0 $X=576600 $Y=452100
X545 2720 2718 1 2 480 AN2 $T=579700 336560 1 0 $X=579700 $Y=331140
X546 2672 2715 1 2 2752 AN2 $T=581560 417200 1 0 $X=581560 $Y=411780
X547 2748 2752 1 2 2763 AN2 $T=584660 427280 1 0 $X=584660 $Y=421860
X548 2766 2765 1 2 2482 AN2 $T=587760 376880 0 0 $X=587760 $Y=376500
X549 2778 2775 1 2 2781 AN2 $T=590240 356720 0 0 $X=590240 $Y=356340
X550 2771 2763 1 2 2788 AN2 $T=591480 427280 1 0 $X=591480 $Y=421860
X551 2794 417 1 2 2798 AN2 $T=595200 467600 0 0 $X=595200 $Y=467220
X552 2796 2788 1 2 2821 AN2 $T=597060 427280 1 0 $X=597060 $Y=421860
X553 2825 2821 1 2 2851 AN2 $T=603880 427280 0 0 $X=603880 $Y=426900
X554 507 480 1 2 2854 AN2 $T=606980 326480 0 0 $X=606980 $Y=326100
X555 2858 2851 1 2 2876 AN2 $T=610700 417200 0 0 $X=610700 $Y=416820
X556 2879 2854 1 2 2891 AN2 $T=613800 336560 0 0 $X=613800 $Y=336180
X557 2864 417 1 2 2841 AN2 $T=616280 457520 1 180 $X=613800 $Y=457140
X558 2889 417 1 2 2874 AN2 $T=616280 467600 0 180 $X=613800 $Y=462180
X559 2892 2876 1 2 2906 AN2 $T=617520 427280 1 0 $X=617520 $Y=421860
X560 2907 2891 1 2 2925 AN2 $T=622480 336560 1 0 $X=622480 $Y=331140
X561 2922 2906 1 2 2934 AN2 $T=624340 417200 0 0 $X=624340 $Y=416820
X562 2938 417 1 2 2909 AN2 $T=628060 467600 1 180 $X=625580 $Y=467220
X563 2939 2934 1 2 2951 AN2 $T=629300 427280 1 0 $X=629300 $Y=421860
X564 2955 417 1 2 2941 AN2 $T=631780 467600 1 180 $X=629300 $Y=467220
X565 2944 2925 1 2 2974 AN2 $T=634260 336560 1 0 $X=634260 $Y=331140
X566 2961 2951 1 2 2975 AN2 $T=634260 427280 0 0 $X=634260 $Y=426900
X567 2990 2974 1 2 555 AN2 $T=640460 326480 0 0 $X=640460 $Y=326100
X568 3007 417 1 2 2976 AN2 $T=645420 467600 1 180 $X=642940 $Y=467220
X569 2996 2975 1 2 3022 AN2 $T=646040 427280 0 0 $X=646040 $Y=426900
X570 3012 3014 1 2 3030 AN2 $T=647900 417200 0 0 $X=647900 $Y=416820
X571 3031 3022 1 2 3014 AN2 $T=651000 427280 1 180 $X=648520 $Y=426900
X572 3027 3030 1 2 3038 AN2 $T=649760 417200 1 0 $X=649760 $Y=411780
X573 3039 417 1 2 3001 AN2 $T=654100 467600 1 180 $X=651620 $Y=467220
X574 3055 417 1 2 3037 AN2 $T=657200 457520 0 180 $X=654720 $Y=452100
X575 3050 3060 1 2 3066 AN2 $T=657820 366800 1 0 $X=657820 $Y=361380
X576 571 555 1 2 573 AN2 $T=658440 336560 1 0 $X=658440 $Y=331140
X577 3062 3064 1 2 3060 AN2 $T=659680 346640 0 0 $X=659680 $Y=346260
X578 3080 3076 1 2 3064 AN2 $T=662780 336560 1 180 $X=660300 $Y=336180
X579 575 573 1 2 3076 AN2 $T=661540 336560 1 0 $X=661540 $Y=331140
X580 3093 417 1 2 3077 AN2 $T=665880 397040 0 180 $X=663400 $Y=391620
X581 3092 417 1 2 3069 AN2 $T=667740 437360 0 180 $X=665260 $Y=431940
X582 3094 417 1 2 3082 AN2 $T=668980 417200 0 180 $X=666500 $Y=411780
X583 3105 417 1 2 3059 AN2 $T=670840 417200 1 180 $X=668360 $Y=416820
X584 3087 417 1 2 3075 AN2 $T=672700 457520 1 180 $X=670220 $Y=457140
X585 3164 603 1 2 3170 AN2 $T=687580 356720 1 0 $X=687580 $Y=351300
X586 3159 603 1 2 3175 AN2 $T=690680 366800 0 0 $X=690680 $Y=366420
X587 3166 603 1 2 3184 AN2 $T=690680 376880 0 0 $X=690680 $Y=376500
X588 3198 603 1 2 3236 AN2 $T=701220 397040 0 0 $X=701220 $Y=396660
X589 3185 603 1 2 3214 AN2 $T=702460 407120 0 0 $X=702460 $Y=406740
X590 3221 603 1 2 3226 AN2 $T=704320 447440 0 0 $X=704320 $Y=447060
X591 3219 603 1 2 3247 AN2 $T=706180 437360 1 0 $X=706180 $Y=431940
X592 3243 3241 1 2 3253 AN2 $T=708040 346640 0 0 $X=708040 $Y=346260
X593 3244 3250 1 2 3254 AN2 $T=708040 366800 1 0 $X=708040 $Y=361380
X594 3251 3254 1 2 3252 AN2 $T=709280 376880 0 0 $X=709280 $Y=376500
X595 3269 618 1 2 3241 AN2 $T=713620 346640 0 180 $X=711140 $Y=341220
X596 3257 3253 1 2 3250 AN2 $T=711140 366800 1 0 $X=711140 $Y=361380
X597 3255 3252 1 2 3261 AN2 $T=711140 386960 0 0 $X=711140 $Y=386580
X598 3259 3261 1 2 3273 AN2 $T=711140 397040 0 0 $X=711140 $Y=396660
X599 3267 3273 1 2 3285 AN2 $T=713000 417200 1 0 $X=713000 $Y=411780
X600 3287 3285 1 2 3299 AN2 $T=716100 417200 1 0 $X=716100 $Y=411780
X601 3263 603 1 2 3296 AN2 $T=716100 447440 1 0 $X=716100 $Y=442020
X602 3275 603 1 2 3314 AN2 $T=724160 447440 1 180 $X=721680 $Y=447060
X603 3315 3299 1 2 3325 AN2 $T=722300 417200 1 0 $X=722300 $Y=411780
X604 3349 3352 1 2 644 AN2 $T=729740 346640 1 0 $X=729740 $Y=341220
X605 3320 603 1 2 3346 AN2 $T=729740 447440 0 0 $X=729740 $Y=447060
X606 3335 3325 1 2 3360 AN2 $T=731600 417200 0 0 $X=731600 $Y=416820
X607 3362 3360 1 2 3373 AN2 $T=732220 417200 1 0 $X=732220 $Y=411780
X608 3409 603 1 2 3397 AN2 $T=743380 427280 0 180 $X=740900 $Y=421860
X609 3361 603 1 2 3392 AN2 $T=743380 447440 0 0 $X=743380 $Y=447060
X610 3414 603 1 2 3419 AN2 $T=748960 447440 1 0 $X=748960 $Y=442020
X611 3472 3471 1 2 3489 AN2 $T=758880 366800 1 0 $X=758880 $Y=361380
X612 681 682 1 2 3499 AN2 $T=760740 326480 0 0 $X=760740 $Y=326100
X613 3493 3488 1 2 3483 AN2 $T=763220 346640 1 180 $X=760740 $Y=346260
X614 3474 3483 1 2 3471 AN2 $T=760740 356720 0 0 $X=760740 $Y=356340
X615 3484 3489 1 2 3502 AN2 $T=760740 376880 0 0 $X=760740 $Y=376500
X616 3495 3496 1 2 3482 AN2 $T=763220 397040 0 180 $X=760740 $Y=391620
X617 3481 3499 1 2 3488 AN2 $T=763840 336560 0 180 $X=761360 $Y=331140
X618 3494 3502 1 2 3496 AN2 $T=762600 386960 0 0 $X=762600 $Y=386580
X619 3485 3482 1 2 3535 AN2 $T=763840 407120 1 0 $X=763840 $Y=401700
X620 3551 3544 1 2 3536 AN2 $T=773140 437360 1 180 $X=770660 $Y=436980
X621 3523 3536 1 2 3515 AN2 $T=770660 447440 0 0 $X=770660 $Y=447060
X622 3517 3515 1 2 3554 AN2 $T=771280 457520 1 0 $X=771280 $Y=452100
X623 3558 3535 1 2 3559 AN2 $T=778100 397040 0 0 $X=778100 $Y=396660
X624 3540 3559 1 2 3599 AN2 $T=781200 397040 0 0 $X=781200 $Y=396660
X625 3608 3602 1 2 3544 AN2 $T=785540 437360 1 180 $X=783060 $Y=436980
X626 3590 3589 1 2 3588 AN2 $T=783060 477680 0 0 $X=783060 $Y=477300
X627 3593 3588 1 2 3623 AN2 $T=785540 467600 0 0 $X=785540 $Y=467220
X628 3627 3617 1 2 3589 AN2 $T=788640 477680 1 180 $X=786160 $Y=477300
X629 3626 3630 1 2 3621 AN2 $T=790500 457520 0 180 $X=788020 $Y=452100
X630 3629 3621 1 2 3602 AN2 $T=792360 447440 0 180 $X=789880 $Y=442020
X631 3655 3640 1 2 3630 AN2 $T=794220 457520 0 180 $X=791740 $Y=452100
X632 3641 708 1 2 3617 AN2 $T=794220 487760 0 180 $X=791740 $Y=482340
X633 3605 3599 1 2 3639 AN2 $T=792360 407120 0 0 $X=792360 $Y=406740
X634 717 718 1 2 3701 AN2 $T=801660 326480 0 0 $X=801660 $Y=326100
X635 3672 3666 1 2 3704 AN2 $T=801660 417200 0 0 $X=801660 $Y=416820
X636 3686 3695 1 2 3707 AN2 $T=802900 407120 1 0 $X=802900 $Y=401700
X637 3689 3701 1 2 3705 AN2 $T=803520 336560 0 0 $X=803520 $Y=336180
X638 3715 3707 1 2 3666 AN2 $T=806000 417200 0 180 $X=803520 $Y=411780
X639 3683 3676 1 2 3695 AN2 $T=804760 397040 1 0 $X=804760 $Y=391620
X640 3693 3690 1 2 3697 AN2 $T=805380 356720 0 0 $X=805380 $Y=356340
X641 3702 3697 1 2 3694 AN2 $T=805380 366800 0 0 $X=805380 $Y=366420
X642 3698 3694 1 2 3676 AN2 $T=805380 386960 1 0 $X=805380 $Y=381540
X643 3712 3718 1 2 3640 AN2 $T=807860 447440 1 180 $X=805380 $Y=447060
X644 3710 3705 1 2 3690 AN2 $T=809100 336560 1 180 $X=806620 $Y=336180
X645 3716 3704 1 2 3739 AN2 $T=808480 427280 1 0 $X=808480 $Y=421860
X646 3770 3756 1 2 3718 AN2 $T=814680 457520 0 180 $X=812200 $Y=452100
X647 3771 3739 1 2 3794 AN2 $T=820260 417200 1 0 $X=820260 $Y=411780
X648 3816 3809 1 2 3756 AN2 $T=826460 457520 0 180 $X=823980 $Y=452100
X649 3856 3853 1 2 3809 AN2 $T=837000 447440 0 180 $X=834520 $Y=442020
X650 3880 763 1 2 3871 AN2 $T=842580 366800 0 180 $X=840100 $Y=361380
X651 3884 3882 1 2 3853 AN2 $T=843200 447440 1 180 $X=840720 $Y=447060
X652 787 785 1 2 780 AN2 $T=850020 497840 0 180 $X=847540 $Y=492420
X653 3936 3934 1 2 3882 AN2 $T=855600 447440 0 180 $X=853120 $Y=442020
X654 3966 3960 1 2 3934 AN2 $T=862420 447440 0 180 $X=859940 $Y=442020
X655 4011 3992 1 2 3960 AN2 $T=869240 447440 1 180 $X=866760 $Y=447060
X656 4005 4017 1 2 851 AN2 $T=871720 376880 1 0 $X=871720 $Y=371460
X657 4024 215 1 2 4029 AN2 $T=873580 376880 0 0 $X=873580 $Y=376500
X658 4024 4028 1 2 4007 AN2 $T=873580 397040 1 0 $X=873580 $Y=391620
X659 245 241 1 2 4043 AN2 $T=877920 407120 1 180 $X=875440 $Y=406740
X660 4061 4045 1 2 4011 AN2 $T=879780 447440 1 180 $X=877300 $Y=447060
X661 4087 4052 1 2 4019 AN2 $T=881020 477680 0 180 $X=878540 $Y=472260
X662 4066 215 1 2 4009 AN2 $T=882880 386960 1 180 $X=880400 $Y=386580
X663 4066 4028 1 2 4079 AN2 $T=880400 397040 0 0 $X=880400 $Y=396660
X664 4080 4077 1 2 4045 AN2 $T=884120 447440 1 180 $X=881640 $Y=447060
X665 4069 4075 1 2 4094 AN2 $T=883500 417200 0 0 $X=883500 $Y=416820
X666 3874 883 1 2 892 AN2 $T=889080 487760 1 0 $X=889080 $Y=482340
X667 901 858 1 2 850 AN2 $T=895900 326480 1 180 $X=893420 $Y=326100
X668 4168 4175 1 2 921 AN2 $T=902100 487760 1 0 $X=902100 $Y=482340
X669 4176 4169 1 2 4197 AN2 $T=903340 427280 1 0 $X=903340 $Y=421860
X670 4224 4214 1 2 4120 AN2 $T=912020 447440 1 180 $X=909540 $Y=447060
X671 4269 4232 1 2 4214 AN2 $T=920080 427280 0 180 $X=917600 $Y=421860
X672 4275 4282 1 2 4277 AN2 $T=926900 417200 1 180 $X=924420 $Y=416820
X673 4263 4242 1 2 4281 AN2 $T=928760 376880 1 180 $X=926280 $Y=376500
X674 4287 4293 1 2 4299 AN2 $T=926280 457520 0 0 $X=926280 $Y=457140
X675 4310 4312 1 2 4293 AN2 $T=932480 457520 1 180 $X=930000 $Y=457140
X676 4331 4336 1 2 4344 AN2 $T=934960 407120 1 0 $X=934960 $Y=401700
X677 4354 4348 1 2 4312 AN2 $T=940540 457520 1 180 $X=938060 $Y=457140
X678 4378 4374 1 2 4348 AN2 $T=946120 457520 1 180 $X=943640 $Y=457140
X679 4146 1010 1 2 4205 AN2 $T=954180 366800 1 180 $X=951700 $Y=366420
X680 4427 4418 1 2 4374 AN2 $T=956040 457520 1 180 $X=953560 $Y=457140
X681 4422 3953 1 2 4285 AN2 $T=955420 336560 1 0 $X=955420 $Y=331140
X682 4485 4481 1 2 4418 AN2 $T=967820 457520 1 180 $X=965340 $Y=457140
X683 245 1012 1 2 4502 AN2 $T=969060 417200 1 0 $X=969060 $Y=411780
X684 4507 4494 1 2 4532 AN2 $T=972780 407120 1 0 $X=972780 $Y=401700
X685 4538 4535 1 2 4481 AN2 $T=978360 457520 0 180 $X=975880 $Y=452100
X686 4507 215 1 2 4550 AN2 $T=977740 407120 1 0 $X=977740 $Y=401700
X687 4514 1016 1 2 4547 AN2 $T=978980 336560 0 0 $X=978980 $Y=336180
X688 4503 215 1 2 4551 AN2 $T=978980 397040 1 0 $X=978980 $Y=391620
X689 4503 4494 1 2 4583 AN2 $T=979600 397040 0 0 $X=979600 $Y=396660
X690 4600 4594 1 2 4535 AN2 $T=989520 457520 1 0 $X=989520 $Y=452100
X691 4622 4617 1 2 4594 AN2 $T=994480 467600 0 180 $X=992000 $Y=462180
X692 4493 4504 1 2 4658 AN2 $T=998200 376880 0 0 $X=998200 $Y=376500
X693 4670 4660 1 2 4617 AN2 $T=1002540 467600 0 180 $X=1000060 $Y=462180
X694 4648 4672 1 2 4692 AN2 $T=1003780 447440 1 0 $X=1003780 $Y=442020
X695 4731 4726 1 2 4660 AN2 $T=1013700 467600 0 180 $X=1011220 $Y=462180
X696 4681 4716 1 2 4719 AN2 $T=1013700 487760 0 180 $X=1011220 $Y=482340
X697 4768 4779 1 2 4726 AN2 $T=1023000 467600 0 180 $X=1020520 $Y=462180
X698 4795 4790 1 2 4779 AN2 $T=1025480 467600 0 180 $X=1023000 $Y=462180
X699 4823 4764 1 2 4742 AN2 $T=1031680 386960 0 180 $X=1029200 $Y=381540
X700 4832 4651 1 2 4839 AN2 $T=1034780 447440 1 180 $X=1032300 $Y=447060
X701 4857 4849 1 2 4790 AN2 $T=1034780 467600 0 180 $X=1032300 $Y=462180
X702 4697 4863 1 2 4915 AN2 $T=1044080 457520 1 0 $X=1044080 $Y=452100
X703 4904 4913 1 2 4849 AN2 $T=1046560 457520 1 180 $X=1044080 $Y=457140
X704 4947 4963 1 2 4978 AN2 $T=1054620 487760 0 0 $X=1054620 $Y=487380
X705 4988 4980 1 2 4913 AN2 $T=1060200 457520 1 180 $X=1057720 $Y=457140
X706 4855 979 1 2 4989 AN2 $T=1059580 487760 1 0 $X=1059580 $Y=482340
X707 4978 4986 1 2 5021 AN2 $T=1068260 487760 0 0 $X=1068260 $Y=487380
X708 5008 5016 1 2 4980 AN2 $T=1071360 457520 0 0 $X=1071360 $Y=457140
X709 5001 5023 1 2 5038 AN2 $T=1072600 437360 0 0 $X=1072600 $Y=436980
X710 5042 5046 1 2 5016 AN2 $T=1080660 457520 1 180 $X=1078180 $Y=457140
X711 5038 5051 1 2 5063 AN2 $T=1081280 447440 0 0 $X=1081280 $Y=447060
X712 5073 4712 1 2 5085 AN2 $T=1086240 397040 1 0 $X=1086240 $Y=391620
X713 2006 261 1 2 INV4CK $T=368900 336560 0 0 $X=368900 $Y=336180
X714 2113 2115 1 2 INV4CK $T=403000 346640 0 0 $X=403000 $Y=346260
X715 2182 2186 1 2 INV4CK $T=428420 366800 0 0 $X=428420 $Y=366420
X716 3889 760 1 2 INV4CK $T=843820 386960 0 180 $X=840100 $Y=381540
X717 4664 4458 1 2 INV4CK $T=1002540 427280 0 180 $X=998820 $Y=421860
X718 2567 2694 1 2 INV2CK $T=573500 356720 0 0 $X=573500 $Y=356340
X719 3859 3889 1 2 INV2CK $T=846920 386960 0 180 $X=844440 $Y=381540
X720 3916 4110 1 2 INV2CK $T=891560 437360 1 0 $X=891560 $Y=431940
X721 4376 4611 1 2 INV2CK $T=986420 437360 0 0 $X=986420 $Y=436980
X722 4628 4664 1 2 INV2CK $T=1008740 467600 0 0 $X=1008740 $Y=467220
X723 4718 4753 1 2 INV2CK $T=1013700 447440 1 0 $X=1013700 $Y=442020
X724 2018 1 2 2016 DELC $T=372620 336560 0 0 $X=372620 $Y=336180
X725 2118 1 2 293 DELC $T=405480 326480 0 0 $X=405480 $Y=326100
X726 2157 1 2 2177 DELC $T=428420 356720 1 0 $X=428420 $Y=351300
X727 2244 1 2 2162 DELC $T=445160 326480 0 0 $X=445160 $Y=326100
X728 2268 1 2 2311 DELC $T=461900 376880 0 0 $X=461900 $Y=376500
X729 2297 1 2 2276 DELC $T=462520 346640 0 0 $X=462520 $Y=346260
X730 2316 1 2 357 DELC $T=462520 487760 0 0 $X=462520 $Y=487380
X731 2576 1 2 2575 DELC $T=556760 487760 0 0 $X=556760 $Y=487380
X732 2630 1 2 478 DELC $T=574740 497840 1 0 $X=574740 $Y=492420
X733 2927 1 2 538 DELC $T=624960 477680 1 0 $X=624960 $Y=472260
X734 2949 1 2 545 DELC $T=630540 487760 0 0 $X=630540 $Y=487380
X735 552 1 2 557 DELC $T=640460 487760 0 0 $X=640460 $Y=487380
X736 3024 1 2 566 DELC $T=648520 487760 0 0 $X=648520 $Y=487380
X737 3083 1 2 583 DELC $T=662780 477680 0 0 $X=662780 $Y=477300
X738 3093 1 2 582 DELC $T=667740 477680 0 0 $X=667740 $Y=477300
X739 3122 1 2 593 DELC $T=672700 477680 0 0 $X=672700 $Y=477300
X740 3138 1 2 598 DELC $T=677660 477680 0 0 $X=677660 $Y=477300
X741 3171 1 2 611 DELC $T=690060 487760 1 0 $X=690060 $Y=482340
X742 3154 1 2 3153 DELC $T=693780 477680 0 0 $X=693780 $Y=477300
X743 3187 1 2 614 DELC $T=694400 487760 0 0 $X=694400 $Y=487380
X744 3228 1 2 617 DELC $T=703080 487760 0 0 $X=703080 $Y=487380
X745 3249 1 2 619 DELC $T=708040 487760 0 0 $X=708040 $Y=487380
X746 3270 1 2 629 DELC $T=713000 477680 0 0 $X=713000 $Y=477300
X747 3276 1 2 633 DELC $T=717960 477680 0 0 $X=717960 $Y=477300
X748 3322 1 2 3350 DELC $T=724160 477680 0 0 $X=724160 $Y=477300
X749 3332 1 2 642 DELC $T=726020 487760 1 0 $X=726020 $Y=482340
X750 3340 1 2 647 DELC $T=730980 487760 1 0 $X=730980 $Y=482340
X751 3409 1 2 3339 DELC $T=752060 437360 0 0 $X=752060 $Y=436980
X752 3881 1 2 3880 DELC $T=841960 376880 1 0 $X=841960 $Y=371460
X753 4688 1 2 4606 DELC $T=1004400 457520 1 0 $X=1004400 $Y=452100
X754 263 273 1 2 2018 QDBHN $T=376960 326480 0 0 $X=376960 $Y=326100
X755 263 294 1 2 2118 QDBHN $T=410440 326480 0 0 $X=410440 $Y=326100
X756 263 298 1 2 2157 QDBHN $T=415400 346640 0 0 $X=415400 $Y=346260
X757 263 318 1 2 2244 QDBHN $T=437720 326480 0 0 $X=437720 $Y=326100
X758 263 331 1 2 2297 QDBHN $T=448260 346640 0 0 $X=448260 $Y=346260
X759 263 341 1 2 2268 QDBHN $T=458180 376880 0 180 $X=450740 $Y=371460
X760 2265 340 1 2 332 QDBHN $T=460040 397040 0 180 $X=452600 $Y=391620
X761 2265 2296 1 2 336 QDBHN $T=461280 386960 0 180 $X=453840 $Y=381540
X762 2265 2313 1 2 343 QDBHN $T=467480 397040 0 180 $X=460040 $Y=391620
X763 361 358 1 2 2316 QDBHN $T=472440 497840 0 180 $X=465000 $Y=492420
X764 2265 2345 1 2 280 QDBHN $T=478020 386960 1 180 $X=470580 $Y=386580
X765 600 602 1 2 3154 QDBHN $T=690060 487760 0 180 $X=682620 $Y=482340
X766 763 789 1 2 3881 QDBHN $T=853740 366800 0 180 $X=846300 $Y=361380
X767 1086 789 1 2 4688 QDBHN $T=997580 457520 0 0 $X=997580 $Y=457140
X768 2016 263 2006 1 2 AN2T $T=373240 326480 1 180 $X=368900 $Y=326100
X769 293 263 300 1 2 AN2T $T=425940 326480 1 180 $X=421600 $Y=326100
X770 2162 263 2113 1 2 AN2T $T=423460 336560 0 0 $X=423460 $Y=336180
X771 2177 263 2182 1 2 AN2T $T=426560 346640 0 0 $X=426560 $Y=346260
X772 314 263 2188 1 2 AN2T $T=434000 326480 1 180 $X=429660 $Y=326100
X773 2276 263 2261 1 2 AN2T $T=452600 356720 1 180 $X=448260 $Y=356340
X774 2311 263 2323 1 2 AN2T $T=461900 376880 1 0 $X=461900 $Y=371460
X775 2709 2684 2581 1 2 AN2T $T=576600 386960 1 180 $X=572260 $Y=386580
X776 2699 2684 2637 1 2 AN2T $T=574740 397040 1 0 $X=574740 $Y=391620
X777 3153 600 3148 1 2 AN2T $T=682620 477680 0 0 $X=682620 $Y=477300
X778 3850 883 884 1 2 AN2T $T=886600 487760 0 0 $X=886600 $Y=487380
X779 4109 4115 4080 1 2 AN2T $T=894660 447440 1 180 $X=890320 $Y=447060
X780 3845 4126 4102 1 2 AN2T $T=894040 437360 1 0 $X=894040 $Y=431940
X781 4040 4143 4155 1 2 AN2T $T=895900 427280 1 0 $X=895900 $Y=421860
X782 3909 883 916 1 2 AN2T $T=896520 497840 1 0 $X=896520 $Y=492420
X783 4129 4123 4187 1 2 AN2T $T=905200 477680 1 0 $X=905200 $Y=472260
X784 4606 1086 4628 1 2 AN2T $T=990760 467600 0 0 $X=990760 $Y=467220
X785 1162 1161 4829 1 2 AN2T $T=1027960 487760 0 0 $X=1027960 $Y=487380
X786 4878 4872 4843 1 2 AN2T $T=1044080 477680 1 0 $X=1044080 $Y=472260
X787 4780 4863 4927 1 2 AN2T $T=1045320 447440 0 0 $X=1045320 $Y=447060
X788 4809 4863 4936 1 2 AN2T $T=1047800 457520 1 0 $X=1047800 $Y=452100
X789 4940 4941 4965 1 2 AN2T $T=1052760 437360 0 0 $X=1052760 $Y=436980
X790 4981 4965 5001 1 2 AN2T $T=1061440 437360 0 0 $X=1061440 $Y=436980
X791 5027 5021 1260 1 2 AN2T $T=1073220 487760 0 0 $X=1073220 $Y=487380
X792 2422 1 2 2799 DELA $T=609460 487760 0 0 $X=609460 $Y=487380
X793 1439 202 37 2 55 1848 1 AO22 $T=315580 487760 0 0 $X=315580 $Y=487380
X794 2084 279 2077 2 2073 277 1 AO22 $T=393700 397040 1 180 $X=388740 $Y=396660
X795 2097 279 2083 2 2076 277 1 AO22 $T=396180 397040 0 180 $X=391220 $Y=391620
X796 2098 279 2087 2 2080 277 1 AO22 $T=396800 427280 1 180 $X=391840 $Y=426900
X797 2105 279 2091 2 2085 277 1 AO22 $T=397420 417200 0 180 $X=392460 $Y=411780
X798 2089 279 2095 2 2081 277 1 AO22 $T=394320 447440 0 0 $X=394320 $Y=447060
X799 2082 279 2102 2 2104 277 1 AO22 $T=394940 457520 0 0 $X=394940 $Y=457140
X800 2086 279 2100 2 2101 277 1 AO22 $T=395560 487760 1 0 $X=395560 $Y=482340
X801 2114 279 2106 2 2099 277 1 AO22 $T=402380 477680 0 180 $X=397420 $Y=472260
X802 2179 303 2167 2 2159 302 1 AO22 $T=427800 336560 0 180 $X=422840 $Y=331140
X803 2173 279 2185 2 2192 277 1 AO22 $T=427800 467600 0 0 $X=427800 $Y=467220
X804 2218 279 2203 2 2201 277 1 AO22 $T=436480 397040 0 180 $X=431520 $Y=391620
X805 2194 279 2209 2 2210 277 1 AO22 $T=432140 417200 1 0 $X=432140 $Y=411780
X806 2220 279 2211 2 2204 277 1 AO22 $T=438340 427280 0 180 $X=433380 $Y=421860
X807 2202 279 2219 2 2191 277 1 AO22 $T=435240 447440 1 0 $X=435240 $Y=442020
X808 2231 279 2207 2 2205 277 1 AO22 $T=440820 457520 0 180 $X=435860 $Y=452100
X809 2212 279 2221 2 2223 277 1 AO22 $T=437100 477680 0 0 $X=437100 $Y=477300
X810 2213 279 2198 2 2224 277 1 AO22 $T=437100 487760 0 0 $X=437100 $Y=487380
X811 2222 279 2237 2 2228 277 1 AO22 $T=441440 417200 1 0 $X=441440 $Y=411780
X812 2214 303 2200 2 2245 302 1 AO22 $T=443300 346640 1 0 $X=443300 $Y=341220
X813 2229 279 2246 2 2249 277 1 AO22 $T=443300 427280 1 0 $X=443300 $Y=421860
X814 2267 279 2258 2 2253 277 1 AO22 $T=450740 437360 0 180 $X=445780 $Y=431940
X815 2274 2265 2263 2 2193 2248 1 AO22 $T=451980 386960 1 180 $X=447020 $Y=386580
X816 2257 303 2259 2 2252 302 1 AO22 $T=448880 366800 1 0 $X=448880 $Y=361380
X817 2287 2265 2283 2 2174 2248 1 AO22 $T=456940 437360 0 180 $X=451980 $Y=431940
X818 2292 2265 2284 2 338 2248 1 AO22 $T=458180 407120 0 180 $X=453220 $Y=401700
X819 2298 2265 2273 2 2195 2248 1 AO22 $T=458180 417200 1 180 $X=453220 $Y=416820
X820 2308 2265 2289 2 2197 2248 1 AO22 $T=459420 427280 1 180 $X=454460 $Y=426900
X821 2324 303 2302 2 2309 302 1 AO22 $T=465620 366800 1 180 $X=460660 $Y=366420
X822 2354 2265 2350 2 364 2248 1 AO22 $T=479880 427280 1 180 $X=474920 $Y=426900
X823 2365 2265 2360 2 367 2248 1 AO22 $T=482980 397040 1 180 $X=478020 $Y=396660
X824 2384 2265 2371 2 2352 2248 1 AO22 $T=486700 386960 1 180 $X=481740 $Y=386580
X825 2398 2265 2379 2 381 2248 1 AO22 $T=492280 477680 1 180 $X=487320 $Y=477300
X826 2401 2265 2392 2 2351 2248 1 AO22 $T=492900 397040 1 180 $X=487940 $Y=396660
X827 2387 2265 2393 2 2262 2248 1 AO22 $T=492900 427280 1 180 $X=487940 $Y=426900
X828 2424 2265 2394 2 2414 2248 1 AO22 $T=497860 437360 1 180 $X=492900 $Y=436980
X829 2422 2265 393 2 389 2248 1 AO22 $T=497860 477680 1 180 $X=492900 $Y=477300
X830 2431 2265 2419 2 392 2248 1 AO22 $T=499100 467600 1 180 $X=494140 $Y=467220
X831 2432 2265 2409 2 2418 2248 1 AO22 $T=500340 447440 1 180 $X=495380 $Y=447060
X832 2438 2265 2421 2 396 2248 1 AO22 $T=501580 407120 0 180 $X=496620 $Y=401700
X833 2446 2265 2437 2 398 2248 1 AO22 $T=504060 477680 1 180 $X=499100 $Y=477300
X834 2459 2265 401 2 2397 2248 1 AO22 $T=506540 447440 0 180 $X=501580 $Y=442020
X835 2380 303 2455 2 2462 302 1 AO22 $T=507160 366800 0 0 $X=507160 $Y=366420
X836 2451 303 2461 2 2464 302 1 AO22 $T=508400 366800 1 0 $X=508400 $Y=361380
X837 2480 303 2478 2 2473 302 1 AO22 $T=520180 366800 1 180 $X=515220 $Y=366420
X838 2533 2593 2599 2 2602 2551 1 AO22 $T=553660 407120 1 0 $X=553660 $Y=401700
X839 2506 2593 2605 2 2612 2551 1 AO22 $T=555520 397040 0 0 $X=555520 $Y=396660
X840 2569 455 2620 2 2622 462 1 AO22 $T=558620 346640 1 0 $X=558620 $Y=341220
X841 2577 2593 2619 2 2627 2551 1 AO22 $T=559240 407120 0 0 $X=559240 $Y=406740
X842 2540 455 2626 2 464 462 1 AO22 $T=560480 336560 1 0 $X=560480 $Y=331140
X843 2497 2593 2634 2 2637 2551 1 AO22 $T=562960 386960 1 0 $X=562960 $Y=381540
X844 465 2554 2636 2 2648 2551 1 AO22 $T=563580 366800 1 0 $X=563580 $Y=361380
X845 2686 2593 2692 2 2703 2551 1 AO22 $T=572260 417200 0 0 $X=572260 $Y=416820
X846 476 2554 2707 2 2690 2551 1 AO22 $T=574120 366800 1 0 $X=574120 $Y=361380
X847 2689 455 2682 2 2721 462 1 AO22 $T=578460 356720 1 0 $X=578460 $Y=351300
X848 2671 2593 2729 2 2734 2551 1 AO22 $T=578460 417200 0 0 $X=578460 $Y=416820
X849 2719 455 2726 2 2678 462 1 AO22 $T=587140 336560 1 180 $X=582180 $Y=336180
X850 483 455 2702 2 2749 462 1 AO22 $T=584660 336560 1 0 $X=584660 $Y=331140
X851 2737 2593 2755 2 2762 2551 1 AO22 $T=591480 417200 1 180 $X=586520 $Y=416820
X852 2743 417 2774 2 495 424 1 AO22 $T=589620 467600 1 0 $X=589620 $Y=462180
X853 2785 2593 2783 2 2795 2551 1 AO22 $T=592720 417200 0 0 $X=592720 $Y=416820
X854 2852 2865 2810 2 2835 2840 1 AO22 $T=613180 427280 1 180 $X=608220 $Y=426900
X855 2868 2865 2843 2 2867 2840 1 AO22 $T=613180 417200 0 0 $X=613180 $Y=416820
X856 2904 2865 2873 2 2890 2840 1 AO22 $T=619380 427280 1 180 $X=614420 $Y=426900
X857 536 527 2895 2 2875 521 1 AO22 $T=620620 326480 1 180 $X=615660 $Y=326100
X858 2931 2865 2916 2 2908 2840 1 AO22 $T=626200 437360 0 180 $X=621240 $Y=431940
X859 2958 2865 2940 2 2919 2840 1 AO22 $T=631780 437360 0 180 $X=626820 $Y=431940
X860 541 527 2930 2 2959 462 1 AO22 $T=629920 326480 0 0 $X=629920 $Y=326100
X861 2969 2865 2954 2 2968 2840 1 AO22 $T=636740 417200 0 0 $X=636740 $Y=416820
X862 3006 2865 2981 2 2992 2840 1 AO22 $T=644800 437360 0 180 $X=639840 $Y=431940
X863 559 527 3015 2 2998 462 1 AO22 $T=650380 326480 0 0 $X=650380 $Y=326100
X864 3048 2865 3018 2 2957 2840 1 AO22 $T=657200 437360 0 180 $X=652240 $Y=431940
X865 3054 2865 3043 2 2979 2840 1 AO22 $T=657820 407120 1 180 $X=652860 $Y=406740
X866 3073 506 3058 2 3028 2840 1 AO22 $T=660920 407120 0 180 $X=655960 $Y=401700
X867 3070 506 3040 2 3026 2840 1 AO22 $T=661540 397040 1 180 $X=656580 $Y=396660
X868 3085 527 3072 2 3044 462 1 AO22 $T=667740 346640 1 180 $X=662780 $Y=346260
X869 3081 3079 527 2 3042 462 1 AO22 $T=663400 366800 0 0 $X=663400 $Y=366420
X870 3097 527 3078 2 3052 462 1 AO22 $T=669600 346640 0 180 $X=664640 $Y=341220
X871 586 527 3089 2 3025 462 1 AO22 $T=671460 336560 0 180 $X=666500 $Y=331140
X872 3095 527 3090 2 3053 462 1 AO22 $T=674560 366800 0 180 $X=669600 $Y=361380
X873 3193 603 3179 2 495 604 1 AO22 $T=696260 437360 1 180 $X=691300 $Y=436980
X874 3207 3211 3216 2 3223 3224 1 AO22 $T=699360 386960 1 0 $X=699360 $Y=381540
X875 3199 3211 3222 2 3230 3224 1 AO22 $T=700600 366800 0 0 $X=700600 $Y=366420
X876 3169 3211 3229 2 3233 3224 1 AO22 $T=701840 346640 0 0 $X=701840 $Y=346260
X877 3173 3211 3235 2 3237 3224 1 AO22 $T=702460 356720 0 0 $X=702460 $Y=356340
X878 3242 3211 3234 2 3231 3224 1 AO22 $T=707420 376880 1 180 $X=702460 $Y=376500
X879 3208 3211 3238 2 3239 3224 1 AO22 $T=703080 336560 0 0 $X=703080 $Y=336180
X880 3265 506 3274 2 3277 3304 1 AO22 $T=714860 407120 1 0 $X=714860 $Y=401700
X881 3280 506 3291 2 3295 3304 1 AO22 $T=715480 427280 0 0 $X=715480 $Y=426900
X882 3218 506 3282 2 3298 3304 1 AO22 $T=720440 407120 0 0 $X=720440 $Y=406740
X883 3313 506 3326 2 3305 3304 1 AO22 $T=722300 427280 0 0 $X=722300 $Y=426900
X884 3341 506 3343 2 3333 3304 1 AO22 $T=728500 407120 0 0 $X=728500 $Y=406740
X885 3383 506 3344 2 3371 3304 1 AO22 $T=739660 427280 0 180 $X=734700 $Y=421860
X886 3407 506 3372 2 3357 3304 1 AO22 $T=740280 407120 0 180 $X=735320 $Y=401700
X887 3396 506 3390 2 3370 3304 1 AO22 $T=741520 417200 0 180 $X=736560 $Y=411780
X888 3413 527 3442 2 3447 679 1 AO22 $T=752060 356720 1 0 $X=752060 $Y=351300
X889 3428 527 3443 2 3448 679 1 AO22 $T=752060 366800 1 0 $X=752060 $Y=361380
X890 3431 527 3444 2 3449 679 1 AO22 $T=752060 376880 0 0 $X=752060 $Y=376500
X891 3435 527 3462 2 3466 679 1 AO22 $T=754540 326480 0 0 $X=754540 $Y=326100
X892 3433 527 3463 2 3467 679 1 AO22 $T=754540 346640 0 0 $X=754540 $Y=346260
X893 3423 527 3453 2 3468 679 1 AO22 $T=754540 386960 1 0 $X=754540 $Y=381540
X894 3425 527 3454 2 3469 679 1 AO22 $T=754540 397040 1 0 $X=754540 $Y=391620
X895 3479 527 3470 2 3497 679 1 AO22 $T=759500 407120 0 0 $X=759500 $Y=406740
X896 3460 3509 3513 2 3519 3524 1 AO22 $T=764460 457520 1 0 $X=764460 $Y=452100
X897 3538 527 3525 2 3518 679 1 AO22 $T=771280 407120 1 180 $X=766320 $Y=406740
X898 3552 527 3547 2 3549 679 1 AO22 $T=776860 407120 0 180 $X=771900 $Y=401700
X899 3213 3569 3509 2 3579 3524 1 AO22 $T=776860 467600 1 0 $X=776860 $Y=462180
X900 3597 527 3583 2 3578 679 1 AO22 $T=783680 407120 1 180 $X=778720 $Y=406740
X901 700 3509 3586 2 3594 3524 1 AO22 $T=779960 447440 0 0 $X=779960 $Y=447060
X902 3451 703 3575 2 3595 706 1 AO22 $T=779960 497840 1 0 $X=779960 $Y=492420
X903 3456 703 3574 2 3604 706 1 AO22 $T=782440 477680 1 0 $X=782440 $Y=472260
X904 701 3509 3607 2 3609 3524 1 AO22 $T=783060 457520 0 0 $X=783060 $Y=457140
X905 3625 3614 527 2 3598 679 1 AO22 $T=789260 397040 0 180 $X=784300 $Y=391620
X906 3572 527 3615 2 3566 679 1 AO22 $T=789880 407120 0 180 $X=784920 $Y=401700
X907 3514 703 3616 2 3624 706 1 AO22 $T=785540 487760 0 0 $X=785540 $Y=487380
X908 3510 703 3633 2 3638 706 1 AO22 $T=789260 477680 1 0 $X=789260 $Y=472260
X909 3440 3645 3647 2 3652 713 1 AO22 $T=792980 386960 1 0 $X=792980 $Y=381540
X910 3408 3645 3650 2 3657 713 1 AO22 $T=793600 397040 0 0 $X=793600 $Y=396660
X911 3426 711 3656 2 3660 713 1 AO22 $T=794840 346640 1 0 $X=794840 $Y=341220
X912 710 3509 3658 2 3662 3524 1 AO22 $T=795460 457520 0 0 $X=795460 $Y=457140
X913 3561 703 3643 2 3663 706 1 AO22 $T=795460 487760 1 0 $X=795460 $Y=482340
X914 3473 3645 3661 2 3670 713 1 AO22 $T=796080 407120 0 0 $X=796080 $Y=406740
X915 3437 711 3675 2 3665 713 1 AO22 $T=797320 336560 0 0 $X=797320 $Y=336180
X916 3406 711 3673 2 3679 713 1 AO22 $T=797320 356720 0 0 $X=797320 $Y=356340
X917 3430 3645 3669 2 3677 713 1 AO22 $T=797320 407120 1 0 $X=797320 $Y=401700
X918 3548 3645 3653 2 3678 713 1 AO22 $T=797320 417200 1 0 $X=797320 $Y=411780
X919 3212 3664 703 2 3682 706 1 AO22 $T=797320 477680 1 0 $X=797320 $Y=472260
X920 3434 3645 3680 2 3688 713 1 AO22 $T=798560 366800 0 0 $X=798560 $Y=366420
X921 720 3509 3713 2 3708 3524 1 AO22 $T=804140 467600 1 0 $X=804140 $Y=462180
X922 3560 3645 3692 2 3737 713 1 AO22 $T=807240 417200 1 0 $X=807240 $Y=411780
X923 3567 3645 3736 2 3741 713 1 AO22 $T=808480 407120 0 0 $X=808480 $Y=406740
X924 736 3509 3749 2 3743 3524 1 AO22 $T=815300 467600 0 180 $X=810340 $Y=462180
X925 3635 3645 3755 2 3773 713 1 AO22 $T=814060 407120 0 0 $X=814060 $Y=406740
X926 3646 3818 3645 2 3803 713 1 AO22 $T=828320 407120 1 180 $X=823360 $Y=406740
X927 750 3509 3823 2 3827 3524 1 AO22 $T=826460 457520 0 0 $X=826460 $Y=457140
X928 761 3509 3864 2 3852 3524 1 AO22 $T=841340 457520 1 180 $X=836380 $Y=457140
X929 776 3509 3895 2 3878 3524 1 AO22 $T=846920 457520 0 180 $X=841960 $Y=452100
X930 791 3509 3917 2 3914 3524 1 AO22 $T=853120 457520 0 180 $X=848160 $Y=452100
X931 811 3509 3956 2 3961 3524 1 AO22 $T=859320 457520 0 0 $X=859320 $Y=457140
X932 846 3509 4033 2 4008 3524 1 AO22 $T=872340 457520 1 0 $X=872340 $Y=452100
X933 860 3509 4055 2 4044 3524 1 AO22 $T=876680 467600 1 0 $X=876680 $Y=462180
X934 874 3509 4086 2 4093 3524 1 AO22 $T=883500 457520 0 0 $X=883500 $Y=457140
X935 900 3509 4111 2 4102 3524 1 AO22 $T=894660 457520 1 180 $X=889700 $Y=457140
X936 4170 913 4145 2 4097 4121 1 AO22 $T=901480 467600 0 180 $X=896520 $Y=462180
X937 906 3509 4153 2 4116 3524 1 AO22 $T=897760 457520 1 0 $X=897760 $Y=452100
X938 4209 913 4199 2 4112 4121 1 AO22 $T=910160 487760 0 180 $X=905200 $Y=482340
X939 4198 4174 4181 2 4155 3524 1 AO22 $T=910780 447440 0 180 $X=905820 $Y=442020
X940 4225 4196 4174 2 4117 3524 1 AO22 $T=912020 437360 0 180 $X=907060 $Y=431940
X941 4229 4217 913 2 880 4121 1 AO22 $T=915740 487760 0 180 $X=910780 $Y=482340
X942 4239 4235 4174 2 4139 3524 1 AO22 $T=917600 447440 0 180 $X=912640 $Y=442020
X943 4246 913 4206 2 4100 4121 1 AO22 $T=917600 467600 1 180 $X=912640 $Y=467220
X944 935 4174 4236 2 4173 3524 1 AO22 $T=913260 447440 0 0 $X=913260 $Y=447060
X945 4286 4292 4291 2 4297 4305 1 AO22 $T=925040 447440 0 0 $X=925040 $Y=447060
X946 964 4292 4301 2 4283 4305 1 AO22 $T=927520 477680 1 0 $X=927520 $Y=472260
X947 4280 4322 4292 2 4333 4305 1 AO22 $T=932480 457520 1 0 $X=932480 $Y=452100
X948 968 4292 4323 2 4329 4305 1 AO22 $T=932480 467600 0 0 $X=932480 $Y=467220
X949 4289 4326 913 2 4338 979 1 AO22 $T=933100 487760 0 0 $X=933100 $Y=487380
X950 984 4292 4343 2 4365 4305 1 AO22 $T=939300 467600 0 0 $X=939300 $Y=467220
X951 1005 4292 4388 2 4383 4305 1 AO22 $T=951080 467600 0 180 $X=946120 $Y=462180
X952 1013 4292 4429 2 4401 4305 1 AO22 $T=954800 467600 1 0 $X=954800 $Y=462180
X953 1036 4292 4498 2 4499 4305 1 AO22 $T=968440 467600 1 0 $X=968440 $Y=462180
X954 1051 4292 4542 2 4533 4305 1 AO22 $T=977740 467600 1 0 $X=977740 $Y=462180
X955 1065 4292 4575 2 4568 4305 1 AO22 $T=983940 467600 0 0 $X=983940 $Y=467220
X956 1106 4292 4639 2 4609 4305 1 AO22 $T=1000060 477680 0 180 $X=995100 $Y=472260
X957 1148 4174 4781 2 4751 4305 1 AO22 $T=1021140 477680 1 0 $X=1021140 $Y=472260
X958 1170 4174 4816 2 4785 4305 1 AO22 $T=1032300 467600 1 180 $X=1027340 $Y=467220
X959 1187 4174 4861 2 4850 4305 1 AO22 $T=1038500 467600 1 180 $X=1033540 $Y=467220
X960 1237 4174 4993 2 4774 4305 1 AO22 $T=1060200 467600 1 0 $X=1060200 $Y=462180
X961 1251 4174 5024 2 4830 4305 1 AO22 $T=1071980 467600 0 0 $X=1071980 $Y=467220
X962 1274 4174 5052 2 4915 4305 1 AO22 $T=1083760 477680 0 180 $X=1078800 $Y=472260
X963 2299 385 395 2 1 2442 QDFFRBN $T=489180 386960 0 0 $X=489180 $Y=386580
X964 2335 385 395 2 1 2458 QDFFRBN $T=491660 397040 1 0 $X=491660 $Y=391620
X965 2365 385 395 2 1 405 QDFFRBN $T=496000 397040 0 0 $X=496000 $Y=396660
X966 2412 385 395 2 1 2479 QDFFRBN $T=504060 386960 0 0 $X=504060 $Y=386580
X967 2448 385 395 2 1 2471 QDFFRBN $T=504680 407120 0 0 $X=504680 $Y=406740
X968 2420 385 395 2 1 2488 QDFFRBN $T=512120 397040 0 0 $X=512120 $Y=396660
X969 2319 410 415 2 1 411 QDFFRBN $T=517700 427280 0 0 $X=517700 $Y=426900
X970 2378 410 415 2 1 2503 QDFFRBN $T=519560 437360 0 0 $X=519560 $Y=436980
X971 2517 385 395 2 1 2486 QDFFRBN $T=533820 376880 0 180 $X=522040 $Y=371460
X972 2487 410 415 2 1 2518 QDFFRBN $T=522040 447440 1 0 $X=522040 $Y=442020
X973 2521 385 395 2 1 2492 QDFFRBN $T=538780 356720 0 180 $X=527000 $Y=351300
X974 2511 385 395 2 1 2498 QDFFRBN $T=541260 397040 1 180 $X=529480 $Y=396660
X975 2334 410 415 2 1 2501 QDFFRBN $T=530720 457520 0 0 $X=530720 $Y=457140
X976 2447 410 415 2 1 436 QDFFRBN $T=531960 427280 0 0 $X=531960 $Y=426900
X977 2431 410 415 2 1 2544 QDFFRBN $T=531960 467600 0 0 $X=531960 $Y=467220
X978 2512 410 415 2 1 2563 QDFFRBN $T=535680 437360 1 0 $X=535680 $Y=431940
X979 2307 410 439 2 1 2553 QDFFRBN $T=536920 447440 1 0 $X=536920 $Y=442020
X980 2523 430 440 2 1 2542 QDFFRBN $T=536920 487760 1 0 $X=536920 $Y=482340
X981 2456 410 439 2 1 2604 QDFFRBN $T=545600 457520 0 0 $X=545600 $Y=457140
X982 2496 410 439 2 1 457 QDFFRBN $T=547460 467600 1 0 $X=547460 $Y=462180
X983 2404 410 415 2 1 463 QDFFRBN $T=549320 457520 1 0 $X=549320 $Y=452100
X984 2572 410 415 2 1 2624 QDFFRBN $T=550560 447440 0 0 $X=550560 $Y=447060
X985 2575 430 440 2 1 2586 QDFFRBN $T=551180 487760 1 0 $X=551180 $Y=482340
X986 2639 410 415 2 1 2706 QDFFRBN $T=566060 457520 0 0 $X=566060 $Y=457140
X987 2270 410 415 2 1 2735 QDFFRBN $T=567300 467600 0 0 $X=567300 $Y=467220
X988 2764 430 440 2 1 2651 QDFFRBN $T=584660 487760 0 180 $X=572880 $Y=482340
X989 2693 410 415 2 1 2774 QDFFRBN $T=573500 467600 1 0 $X=573500 $Y=462180
X990 2717 410 439 2 1 2769 QDFFRBN $T=577220 477680 0 0 $X=577220 $Y=477300
X991 2731 430 440 2 1 2780 QDFFRBN $T=579700 487760 0 0 $X=579700 $Y=487380
X992 2741 410 415 2 1 2794 QDFFRBN $T=582180 467600 0 0 $X=582180 $Y=467220
X993 2638 410 439 2 1 2819 QDFFRBN $T=587760 487760 1 0 $X=587760 $Y=482340
X994 2789 410 415 2 1 508 QDFFRBN $T=593960 487760 0 0 $X=593960 $Y=487380
X995 2799 410 415 2 1 510 QDFFRBN $T=595820 477680 0 0 $X=595820 $Y=477300
X996 2816 410 415 2 1 2864 QDFFRBN $T=599540 467600 1 0 $X=599540 $Y=462180
X997 2817 410 439 2 1 2882 QDFFRBN $T=602640 487760 1 0 $X=602640 $Y=482340
X998 2871 410 415 2 1 2889 QDFFRBN $T=613800 467600 0 0 $X=613800 $Y=467220
X999 2888 522 439 2 1 2927 QDFFRBN $T=614420 487760 0 0 $X=614420 $Y=487380
X1000 2896 410 439 2 1 2938 QDFFRBN $T=617520 477680 0 0 $X=617520 $Y=477300
X1001 2862 522 439 2 1 539 QDFFRBN $T=618140 497840 1 0 $X=618140 $Y=492420
X1002 2948 410 439 2 1 2955 QDFFRBN $T=629920 477680 1 0 $X=629920 $Y=472260
X1003 2993 522 439 2 1 2949 QDFFRBN $T=642320 497840 0 180 $X=630540 $Y=492420
X1004 3056 410 439 2 1 3007 QDFFRBN $T=657200 477680 0 180 $X=645420 $Y=472260
X1005 3011 522 439 2 1 572 QDFFRBN $T=645420 497840 1 0 $X=645420 $Y=492420
X1006 580 522 439 2 1 3024 QDFFRBN $T=665260 487760 1 180 $X=653480 $Y=487380
X1007 3046 410 439 2 1 3039 QDFFRBN $T=657200 467600 0 0 $X=657200 $Y=467220
X1008 577 522 415 2 1 590 QDFFRBN $T=660920 497840 1 0 $X=660920 $Y=492420
X1009 3132 410 439 2 1 3055 QDFFRBN $T=675180 467600 0 180 $X=663400 $Y=462180
X1010 3071 522 415 2 1 595 QDFFRBN $T=668360 487760 0 0 $X=668360 $Y=487380
X1011 3155 3148 3127 2 1 3122 QDFFRBN $T=684480 467600 1 180 $X=672700 $Y=467220
X1012 3150 3148 3127 2 1 3083 QDFFRBN $T=685100 477680 0 180 $X=673320 $Y=472260
X1013 3129 385 395 2 1 3164 QDFFRBN $T=675800 356720 1 0 $X=675800 $Y=351300
X1014 3130 385 395 2 1 3159 QDFFRBN $T=675800 356720 0 0 $X=675800 $Y=356340
X1015 3134 385 395 2 1 3166 QDFFRBN $T=676420 376880 0 0 $X=676420 $Y=376500
X1016 3135 522 415 2 1 3171 QDFFRBN $T=676420 497840 1 0 $X=676420 $Y=492420
X1017 3144 410 439 2 1 3087 QDFFRBN $T=690060 467600 0 180 $X=678280 $Y=462180
X1018 596 385 395 2 1 3179 QDFFRBN $T=680140 336560 1 0 $X=680140 $Y=331140
X1019 3113 410 439 2 1 3094 QDFFRBN $T=680140 417200 0 0 $X=680140 $Y=416820
X1020 3146 385 395 2 1 3185 QDFFRBN $T=680760 407120 0 0 $X=680760 $Y=406740
X1021 3177 410 439 2 1 3092 QDFFRBN $T=694400 447440 0 180 $X=682620 $Y=442020
X1022 3143 410 439 2 1 3105 QDFFRBN $T=683860 427280 1 0 $X=683860 $Y=421860
X1023 3156 385 395 2 1 3198 QDFFRBN $T=685720 397040 0 0 $X=685720 $Y=396660
X1024 3163 3148 3127 2 1 3187 QDFFRBN $T=685720 467600 0 0 $X=685720 $Y=467220
X1025 3197 3148 3127 2 1 3138 QDFFRBN $T=698120 477680 0 180 $X=686340 $Y=472260
X1026 3176 410 439 2 1 3221 QDFFRBN $T=690680 447440 0 0 $X=690680 $Y=447060
X1027 3181 410 439 2 1 3219 QDFFRBN $T=691920 427280 0 0 $X=691920 $Y=426900
X1028 606 522 3127 2 1 3228 QDFFRBN $T=691920 497840 1 0 $X=691920 $Y=492420
X1029 3205 3148 3127 2 1 3249 QDFFRBN $T=698740 487760 1 0 $X=698740 $Y=482340
X1030 3210 410 3127 2 1 3263 QDFFRBN $T=699360 467600 1 0 $X=699360 $Y=462180
X1031 3215 3148 3127 2 1 3270 QDFFRBN $T=701220 477680 0 0 $X=701220 $Y=477300
X1032 3225 3148 3127 2 1 3276 QDFFRBN $T=702460 477680 1 0 $X=702460 $Y=472260
X1033 621 3148 3127 2 1 635 QDFFRBN $T=712380 497840 1 0 $X=712380 $Y=492420
X1034 636 3148 3127 2 1 622 QDFFRBN $T=724780 487760 1 180 $X=713000 $Y=487380
X1035 3316 410 3127 2 1 3275 QDFFRBN $T=725400 467600 0 180 $X=713620 $Y=462180
X1036 3279 3148 3127 2 1 3332 QDFFRBN $T=714240 487760 1 0 $X=714240 $Y=482340
X1037 3292 3148 3127 2 1 3340 QDFFRBN $T=716720 477680 1 0 $X=716720 $Y=472260
X1038 3339 3148 3127 2 1 649 QDFFRBN $T=727260 497840 1 0 $X=727260 $Y=492420
X1039 3345 3148 3127 2 1 651 QDFFRBN $T=728500 487760 0 0 $X=728500 $Y=487380
X1040 3350 3148 3127 2 1 654 QDFFRBN $T=729120 477680 0 0 $X=729120 $Y=477300
X1041 3364 3148 3127 2 1 659 QDFFRBN $T=732220 477680 1 0 $X=732220 $Y=472260
X1042 3394 410 3127 2 1 3320 QDFFRBN $T=746480 457520 1 180 $X=734700 $Y=457140
X1043 3410 3148 3127 2 1 677 QDFFRBN $T=743380 487760 1 0 $X=743380 $Y=482340
X1044 664 3148 3127 2 1 680 QDFFRBN $T=744620 487760 0 0 $X=744620 $Y=487380
X1045 3461 410 3127 2 1 3361 QDFFRBN $T=758260 467600 0 180 $X=746480 $Y=462180
X1046 3452 410 3127 2 1 3414 QDFFRBN $T=760740 457520 1 180 $X=748960 $Y=457140
X1047 3883 760 684 2 1 3841 QDFFRBN $T=843820 336560 1 180 $X=832040 $Y=336180
X1048 3886 760 684 2 1 527 QDFFRBN $T=844440 397040 1 180 $X=832660 $Y=396660
X1049 3906 760 684 2 1 506 QDFFRBN $T=848160 397040 0 180 $X=836380 $Y=391620
X1050 3973 760 684 2 1 3645 QDFFRBN $T=861800 386960 1 180 $X=850020 $Y=386580
X1051 4634 4458 684 2 1 976 QDFFRBN $T=995720 417200 0 0 $X=995720 $Y=416820
X1052 4743 4458 1134 2 1 1121 QDFFRBN $T=1022380 427280 1 180 $X=1010600 $Y=426900
X1053 4841 4458 684 2 1 4298 QDFFRBN $T=1023000 417200 1 180 $X=1011220 $Y=416820
X1054 4820 4458 1134 2 1 1154 QDFFRBN $T=1037260 427280 1 180 $X=1025480 $Y=426900
X1055 4926 4458 1134 2 1 1177 QDFFRBN $T=1049660 427280 0 180 $X=1037880 $Y=421860
X1056 5041 4458 1134 2 1 876 QDFFRBN $T=1068260 437360 0 180 $X=1056480 $Y=431940
X1057 4998 4458 1134 2 1 1227 QDFFRBN $T=1070120 427280 1 180 $X=1058340 $Y=426900
X1058 5026 4458 1134 2 1 5014 QDFFRBN $T=1071980 427280 0 0 $X=1071980 $Y=426900
X1059 5030 4458 1134 2 1 5087 QDFFRBN $T=1076940 437360 1 0 $X=1076940 $Y=431940
X1060 8 2 1326 1 INV1S $T=223200 397040 1 180 $X=221960 $Y=396660
X1061 13 2 1346 1 INV1S $T=223820 487760 1 0 $X=223820 $Y=482340
X1062 1352 2 1336 1 INV1S $T=225060 437360 1 0 $X=225060 $Y=431940
X1063 1331 2 1370 1 INV1S $T=226920 407120 1 0 $X=226920 $Y=401700
X1064 19 2 32 1 INV1S $T=230020 477680 1 0 $X=230020 $Y=472260
X1065 1343 2 1362 1 INV1S $T=230640 407120 0 0 $X=230640 $Y=406740
X1066 1364 2 1382 1 INV1S $T=230640 417200 0 0 $X=230640 $Y=416820
X1067 39 2 18 1 INV1S $T=233740 487760 1 180 $X=232500 $Y=487380
X1068 1340 2 1375 1 INV1S $T=233120 407120 0 0 $X=233120 $Y=406740
X1069 1383 2 1389 1 INV1S $T=233740 397040 0 0 $X=233740 $Y=396660
X1070 40 2 47 1 INV1S $T=233740 447440 0 0 $X=233740 $Y=447060
X1071 1344 2 1423 1 INV1S $T=235600 397040 0 0 $X=235600 $Y=396660
X1072 1338 2 43 1 INV1S $T=235600 417200 1 0 $X=235600 $Y=411780
X1073 16 2 1425 1 INV1S $T=235600 427280 1 0 $X=235600 $Y=421860
X1074 1422 2 1443 1 INV1S $T=236220 397040 1 0 $X=236220 $Y=391620
X1075 36 2 1401 1 INV1S $T=237460 427280 1 0 $X=237460 $Y=421860
X1076 1372 2 1406 1 INV1S $T=240560 477680 1 180 $X=239320 $Y=477300
X1077 1453 2 1476 1 INV1S $T=243660 397040 1 0 $X=243660 $Y=391620
X1078 1487 2 1467 1 INV1S $T=246140 417200 1 180 $X=244900 $Y=416820
X1079 1379 2 1440 1 INV1S $T=248620 386960 0 0 $X=248620 $Y=386580
X1080 1503 2 1505 1 INV1S $T=249240 457520 0 0 $X=249240 $Y=457140
X1081 1504 2 1387 1 INV1S $T=251100 417200 1 180 $X=249860 $Y=416820
X1082 1385 2 1527 1 INV1S $T=254200 386960 0 0 $X=254200 $Y=386580
X1083 1473 2 52 1 INV1S $T=256680 487760 0 0 $X=256680 $Y=487380
X1084 1524 2 1555 1 INV1S $T=257300 467600 0 0 $X=257300 $Y=467220
X1085 11 2 37 1 INV1S $T=259160 457520 0 0 $X=259160 $Y=457140
X1086 1512 2 107 1 INV1S $T=264120 487760 1 180 $X=262880 $Y=487380
X1087 1494 2 1457 1 INV1S $T=264120 386960 0 0 $X=264120 $Y=386580
X1088 58 2 121 1 INV1S $T=267840 447440 1 0 $X=267840 $Y=442020
X1089 1620 2 1353 1 INV1S $T=271560 427280 0 180 $X=270320 $Y=421860
X1090 1328 2 1604 1 INV1S $T=270940 397040 1 0 $X=270940 $Y=391620
X1091 1627 2 1472 1 INV1S $T=272800 417200 1 180 $X=271560 $Y=416820
X1092 1523 2 1380 1 INV1S $T=273420 407120 0 180 $X=272180 $Y=401700
X1093 1464 2 1483 1 INV1S $T=274660 407120 0 180 $X=273420 $Y=401700
X1094 1630 2 1614 1 INV1S $T=276520 397040 0 180 $X=275280 $Y=391620
X1095 1408 2 1349 1 INV1S $T=277140 417200 1 0 $X=277140 $Y=411780
X1096 1491 2 1330 1 INV1S $T=278380 417200 0 0 $X=278380 $Y=416820
X1097 130 2 46 1 INV1S $T=280240 487760 1 0 $X=280240 $Y=482340
X1098 1599 2 1688 1 INV1S $T=281480 437360 1 0 $X=281480 $Y=431940
X1099 1680 2 1636 1 INV1S $T=286440 417200 1 180 $X=285200 $Y=416820
X1100 1684 2 156 1 INV1S $T=285820 477680 0 0 $X=285820 $Y=477300
X1101 1511 2 1441 1 INV1S $T=291400 407120 0 0 $X=291400 $Y=406740
X1102 1538 2 1426 1 INV1S $T=292020 417200 0 0 $X=292020 $Y=416820
X1103 1694 2 1546 1 INV1S $T=295120 386960 1 0 $X=295120 $Y=381540
X1104 1756 2 1572 1 INV1S $T=303180 397040 0 0 $X=303180 $Y=396660
X1105 51 2 186 1 INV1S $T=303800 497840 1 0 $X=303800 $Y=492420
X1106 1663 2 1534 1 INV1S $T=304420 397040 0 0 $X=304420 $Y=396660
X1107 115 2 62 1 INV1S $T=306280 427280 1 180 $X=305040 $Y=426900
X1108 1791 2 1618 1 INV1S $T=306900 397040 0 180 $X=305660 $Y=391620
X1109 4 2 189 1 INV1S $T=305660 497840 1 0 $X=305660 $Y=492420
X1110 1793 2 1626 1 INV1S $T=308140 386960 0 180 $X=306900 $Y=381540
X1111 1803 2 1816 1 INV1S $T=310620 407120 0 0 $X=310620 $Y=406740
X1112 1806 2 103 1 INV1S $T=312480 497840 0 180 $X=311240 $Y=492420
X1113 1463 2 1537 1 INV1S $T=314960 437360 0 180 $X=313720 $Y=431940
X1114 1827 2 1616 1 INV1S $T=315580 397040 1 180 $X=314340 $Y=396660
X1115 1771 2 1805 1 INV1S $T=314340 407120 1 0 $X=314340 $Y=401700
X1116 1800 2 1560 1 INV1S $T=316820 477680 1 180 $X=315580 $Y=477300
X1117 1456 2 140 1 INV1S $T=318680 477680 0 180 $X=317440 $Y=472260
X1118 1844 2 1847 1 INV1S $T=319300 407120 0 0 $X=319300 $Y=406740
X1119 104 2 55 1 INV1S $T=319300 437360 1 0 $X=319300 $Y=431940
X1120 1734 2 1818 1 INV1S $T=323020 417200 1 180 $X=321780 $Y=416820
X1121 63 2 92 1 INV1S $T=323020 477680 0 0 $X=323020 $Y=477300
X1122 190 2 29 1 INV1S $T=323640 497840 1 0 $X=323640 $Y=492420
X1123 1896 2 1730 1 INV1S $T=326120 386960 0 180 $X=324880 $Y=381540
X1124 1409 2 1368 1 INV1S $T=324880 467600 0 0 $X=324880 $Y=467220
X1125 1871 2 1874 1 INV1S $T=326740 407120 0 180 $X=325500 $Y=401700
X1126 1621 2 1522 1 INV1S $T=326120 447440 0 0 $X=326120 $Y=447060
X1127 1643 2 1772 1 INV1S $T=329840 437360 0 180 $X=328600 $Y=431940
X1128 10 2 1465 1 INV1S $T=328600 437360 0 0 $X=328600 $Y=436980
X1129 1890 2 1822 1 INV1S $T=330460 417200 0 180 $X=329220 $Y=411780
X1130 1813 2 1898 1 INV1S $T=335420 417200 0 180 $X=334180 $Y=411780
X1131 1872 2 1920 1 INV1S $T=335420 457520 1 0 $X=335420 $Y=452100
X1132 1873 2 1918 1 INV1S $T=336040 417200 1 0 $X=336040 $Y=411780
X1133 215 2 1905 1 INV1S $T=337280 457520 1 180 $X=336040 $Y=457140
X1134 1915 2 1766 1 INV1S $T=337280 386960 0 0 $X=337280 $Y=386580
X1135 1875 2 1909 1 INV1S $T=337900 417200 1 0 $X=337900 $Y=411780
X1136 223 2 1906 1 INV1S $T=338520 477680 1 0 $X=338520 $Y=472260
X1137 1907 2 1933 1 INV1S $T=341000 487760 1 0 $X=341000 $Y=482340
X1138 1862 2 1930 1 INV1S $T=344100 407120 1 180 $X=342860 $Y=406740
X1139 1940 2 1902 1 INV1S $T=344100 447440 0 180 $X=342860 $Y=442020
X1140 222 2 1946 1 INV1S $T=345340 477680 1 180 $X=344100 $Y=477300
X1141 232 2 221 1 INV1S $T=345340 487760 1 180 $X=344100 $Y=487380
X1142 235 2 1876 1 INV1S $T=345960 457520 1 180 $X=344720 $Y=457140
X1143 1936 2 1861 1 INV1S $T=347200 417200 1 180 $X=345960 $Y=416820
X1144 1845 2 1944 1 INV1S $T=352780 427280 0 180 $X=351540 $Y=421860
X1145 1880 2 1953 1 INV1S $T=352780 457520 0 0 $X=352780 $Y=457140
X1146 247 2 1971 1 INV1S $T=355260 487760 0 0 $X=355260 $Y=487380
X1147 250 2 1972 1 INV1S $T=357740 497840 0 180 $X=356500 $Y=492420
X1148 245 2 1958 1 INV1S $T=360220 427280 1 180 $X=358980 $Y=426900
X1149 276 2 234 1 INV1S $T=384400 326480 0 0 $X=384400 $Y=326100
X1150 2145 2 268 1 INV1S $T=417880 497840 0 180 $X=416640 $Y=492420
X1151 325 2 321 1 INV1S $T=447020 497840 1 0 $X=447020 $Y=492420
X1152 332 2 334 1 INV1S $T=453220 326480 1 180 $X=451980 $Y=326100
X1153 343 2 329 1 INV1S $T=456320 336560 0 180 $X=455080 $Y=331140
X1154 2265 2 2248 1 INV1S $T=472440 437360 1 0 $X=472440 $Y=431940
X1155 369 2 1769 1 INV1S $T=480500 386960 1 180 $X=479260 $Y=386580
X1156 372 2 86 1 INV1S $T=483600 366800 0 180 $X=482360 $Y=361380
X1157 374 2 183 1 INV1S $T=485460 366800 0 180 $X=484220 $Y=361380
X1158 376 2 160 1 INV1S $T=486700 386960 0 180 $X=485460 $Y=381540
X1159 382 2 1801 1 INV1S $T=489180 386960 0 180 $X=487940 $Y=381540
X1160 400 2 118 1 INV1S $T=502820 366800 0 180 $X=501580 $Y=361380
X1161 402 2 155 1 INV1S $T=506540 336560 1 180 $X=505300 $Y=336180
X1162 409 2 1700 1 INV1S $T=518320 386960 0 180 $X=517080 $Y=381540
X1163 414 2 1820 1 INV1S $T=525140 376880 1 180 $X=523900 $Y=376500
X1164 405 2 2491 1 INV1S $T=527000 397040 1 180 $X=525760 $Y=396660
X1165 420 2 373 1 INV1S $T=528860 346640 1 180 $X=527620 $Y=346260
X1166 428 2 1571 1 INV1S $T=530100 386960 1 180 $X=528860 $Y=386580
X1167 2536 2 2531 1 INV1S $T=541880 487760 1 180 $X=540640 $Y=487380
X1168 434 2 2541 1 INV1S $T=548080 497840 0 180 $X=546840 $Y=492420
X1169 2584 2 2591 1 INV1S $T=553660 376880 0 0 $X=553660 $Y=376500
X1170 2597 2 2583 1 INV1S $T=556140 427280 0 180 $X=554900 $Y=421860
X1171 2586 2 2578 1 INV1S $T=556760 487760 1 180 $X=555520 $Y=487380
X1172 2566 2 2609 1 INV1S $T=559240 397040 0 180 $X=558000 $Y=391620
X1173 2551 2 2554 1 INV1S $T=561720 386960 0 180 $X=560480 $Y=381540
X1174 458 2 2625 1 INV1S $T=561720 487760 0 0 $X=561720 $Y=487380
X1175 2518 2 472 1 INV1S $T=562960 457520 1 0 $X=562960 $Y=452100
X1176 2622 2 2653 1 INV1S $T=564820 346640 1 0 $X=564820 $Y=341220
X1177 2627 2 2645 1 INV1S $T=565440 407120 0 0 $X=565440 $Y=406740
X1178 2660 2 2633 1 INV1S $T=567920 437360 1 180 $X=566680 $Y=436980
X1179 2651 2 2641 1 INV1S $T=569160 487760 0 180 $X=567920 $Y=482340
X1180 464 2 2669 1 INV1S $T=569160 336560 1 0 $X=569160 $Y=331140
X1181 2614 2 2664 1 INV1S $T=571020 346640 0 180 $X=569780 $Y=341220
X1182 2637 2 2644 1 INV1S $T=571020 386960 1 180 $X=569780 $Y=386580
X1183 2675 2 2680 1 INV1S $T=571020 386960 0 0 $X=571020 $Y=386580
X1184 2612 2 2659 1 INV1S $T=572260 407120 0 180 $X=571020 $Y=401700
X1185 2678 2 2697 1 INV1S $T=571640 336560 0 0 $X=571640 $Y=336180
X1186 2602 2 2657 1 INV1S $T=573500 407120 0 180 $X=572260 $Y=401700
X1187 406 2 2691 1 INV1S $T=573500 497840 1 0 $X=573500 $Y=492420
X1188 2716 2 2701 1 INV1S $T=576600 376880 0 180 $X=575360 $Y=371460
X1189 2684 2 2683 1 INV1S $T=575360 407120 0 0 $X=575360 $Y=406740
X1190 2662 2 2711 1 INV1S $T=577220 386960 1 0 $X=577220 $Y=381540
X1191 2703 2 2715 1 INV1S $T=580320 417200 0 180 $X=579080 $Y=411780
X1192 2721 2 2704 1 INV1S $T=581560 346640 0 180 $X=580320 $Y=341220
X1193 2695 2 2723 1 INV1S $T=581560 386960 1 180 $X=580320 $Y=386580
X1194 2749 2 2720 1 INV1S $T=584660 336560 0 180 $X=583420 $Y=331140
X1195 2734 2 2748 1 INV1S $T=586520 417200 1 180 $X=585280 $Y=416820
X1196 484 2 2765 1 INV1S $T=587140 376880 1 0 $X=587140 $Y=371460
X1197 2762 2 2771 1 INV1S $T=590240 427280 0 180 $X=589000 $Y=421860
X1198 2667 2 2746 1 INV1S $T=591480 407120 1 180 $X=590240 $Y=406740
X1199 493 2 2772 1 INV1S $T=592100 346640 0 180 $X=590860 $Y=341220
X1200 492 2 2778 1 INV1S $T=592100 356720 0 180 $X=590860 $Y=351300
X1201 2551 2 2593 1 INV1S $T=590860 417200 1 0 $X=590860 $Y=411780
X1202 2784 2 491 1 INV1S $T=593340 346640 0 180 $X=592100 $Y=341220
X1203 2808 2 499 1 INV1S $T=597060 346640 1 180 $X=595820 $Y=346260
X1204 2795 2 2796 1 INV1S $T=598920 417200 1 180 $X=597680 $Y=416820
X1205 2814 2 2761 1 INV1S $T=600780 397040 0 0 $X=600780 $Y=396660
X1206 2829 2 2813 1 INV1S $T=603260 336560 0 180 $X=602020 $Y=331140
X1207 2835 2 2825 1 INV1S $T=605120 437360 1 180 $X=603880 $Y=436980
X1208 504 2 507 1 INV1S $T=604500 326480 0 0 $X=604500 $Y=326100
X1209 2867 2 2858 1 INV1S $T=611940 417200 0 180 $X=610700 $Y=411780
X1210 516 2 2879 1 INV1S $T=611320 336560 1 0 $X=611320 $Y=331140
X1211 2890 2 2892 1 INV1S $T=619380 417200 1 180 $X=618140 $Y=416820
X1212 412 2 2757 1 INV1S $T=620620 397040 0 180 $X=619380 $Y=391620
X1213 2875 2 2907 1 INV1S $T=620000 336560 1 0 $X=620000 $Y=331140
X1214 2908 2 2922 1 INV1S $T=624960 417200 1 0 $X=624960 $Y=411780
X1215 2959 2 2944 1 INV1S $T=633020 336560 0 180 $X=631780 $Y=331140
X1216 2919 2 2961 1 INV1S $T=632400 427280 1 0 $X=632400 $Y=421860
X1217 2968 2 2939 1 INV1S $T=636120 417200 1 180 $X=634880 $Y=416820
X1218 2998 2 2990 1 INV1S $T=642320 336560 1 0 $X=642320 $Y=331140
X1219 2992 2 2996 1 INV1S $T=643560 427280 0 0 $X=643560 $Y=426900
X1220 3013 2 3012 1 INV1S $T=647280 417200 1 180 $X=646040 $Y=416820
X1221 2979 2 3027 1 INV1S $T=650380 407120 0 0 $X=650380 $Y=406740
X1222 2957 2 3031 1 INV1S $T=653480 427280 1 180 $X=652240 $Y=426900
X1223 3028 2 3036 1 INV1S $T=655340 407120 0 180 $X=654100 $Y=401700
X1224 3044 2 3050 1 INV1S $T=655340 356720 0 0 $X=655340 $Y=356340
X1225 564 2 571 1 INV1S $T=655960 336560 1 0 $X=655960 $Y=331140
X1226 3052 2 3062 1 INV1S $T=658440 336560 0 0 $X=658440 $Y=336180
X1227 3053 2 3067 1 INV1S $T=660920 366800 1 0 $X=660920 $Y=361380
X1228 3025 2 3080 1 INV1S $T=665880 336560 0 180 $X=664640 $Y=331140
X1229 3088 2 3099 1 INV1S $T=667740 407120 1 0 $X=667740 $Y=401700
X1230 3106 2 3110 1 INV1S $T=670220 437360 1 0 $X=670220 $Y=431940
X1231 3118 2 3131 1 INV1S $T=674560 397040 0 0 $X=674560 $Y=396660
X1232 238 2 241 1 INV1S $T=689440 457520 1 0 $X=689440 $Y=452100
X1233 3189 2 3174 1 INV1S $T=696260 386960 0 0 $X=696260 $Y=386580
X1234 506 2 3224 1 INV1S $T=701220 376880 0 0 $X=701220 $Y=376500
X1235 3224 2 3211 1 INV1S $T=704320 356720 0 180 $X=703080 $Y=351300
X1236 3230 2 3244 1 INV1S $T=706180 366800 0 0 $X=706180 $Y=366420
X1237 3231 2 3251 1 INV1S $T=708040 376880 0 0 $X=708040 $Y=376500
X1238 3233 2 3243 1 INV1S $T=709900 346640 0 180 $X=708660 $Y=341220
X1239 3237 2 3257 1 INV1S $T=708660 356720 0 0 $X=708660 $Y=356340
X1240 3256 2 3168 1 INV1S $T=710520 336560 1 180 $X=709280 $Y=336180
X1241 3239 2 3269 1 INV1S $T=711760 336560 0 0 $X=711760 $Y=336180
X1242 3223 2 3255 1 INV1S $T=713620 376880 1 180 $X=712380 $Y=376500
X1243 3277 2 3259 1 INV1S $T=714860 397040 1 180 $X=713620 $Y=396660
X1244 3317 2 3201 1 INV1S $T=717960 346640 1 180 $X=716720 $Y=346260
X1245 3295 2 3287 1 INV1S $T=717960 417200 1 180 $X=716720 $Y=416820
X1246 3298 2 3267 1 INV1S $T=718580 407120 1 180 $X=717340 $Y=406740
X1247 3305 2 3315 1 INV1S $T=719820 417200 1 0 $X=719820 $Y=411780
X1248 3275 2 3336 1 INV1S $T=725400 467600 1 0 $X=725400 $Y=462180
X1249 3333 2 3335 1 INV1S $T=726640 407120 0 0 $X=726640 $Y=406740
X1250 3068 2 3349 1 INV1S $T=730980 346640 1 180 $X=729740 $Y=346260
X1251 484 2 3352 1 INV1S $T=732220 346640 1 180 $X=730980 $Y=346260
X1252 506 2 3304 1 INV1S $T=732220 407120 1 0 $X=732220 $Y=401700
X1253 3371 2 3362 1 INV1S $T=737180 417200 1 180 $X=735940 $Y=416820
X1254 3404 2 3180 1 INV1S $T=742140 386960 1 180 $X=740900 $Y=386580
X1255 3357 2 3388 1 INV1S $T=745240 417200 1 0 $X=745240 $Y=411780
X1256 3421 2 3190 1 INV1S $T=747100 407120 0 0 $X=747100 $Y=406740
X1257 3457 2 3476 1 INV1S $T=756400 427280 1 0 $X=756400 $Y=421860
X1258 3448 2 3472 1 INV1S $T=757640 366800 1 0 $X=757640 $Y=361380
X1259 3447 2 3474 1 INV1S $T=758260 356720 1 0 $X=758260 $Y=351300
X1260 3449 2 3484 1 INV1S $T=758260 376880 0 0 $X=758260 $Y=376500
X1261 3466 2 3481 1 INV1S $T=758880 336560 1 0 $X=758880 $Y=331140
X1262 3469 2 3495 1 INV1S $T=760740 386960 0 0 $X=760740 $Y=386580
X1263 3468 2 3494 1 INV1S $T=761360 386960 1 0 $X=761360 $Y=381540
X1264 3497 2 3485 1 INV1S $T=763220 397040 1 180 $X=761980 $Y=396660
X1265 3467 2 3493 1 INV1S $T=764460 346640 0 0 $X=764460 $Y=346260
X1266 3519 2 3523 1 INV1S $T=767560 447440 1 0 $X=767560 $Y=442020
X1267 3516 2 3517 1 INV1S $T=768800 457520 0 0 $X=768800 $Y=457140
X1268 3518 2 3540 1 INV1S $T=769420 397040 0 0 $X=769420 $Y=396660
X1269 3550 2 3553 1 INV1S $T=775000 457520 0 0 $X=775000 $Y=457140
X1270 3549 2 3558 1 INV1S $T=776860 397040 1 0 $X=776860 $Y=391620
X1271 3581 2 3551 1 INV1S $T=781820 437360 1 180 $X=780580 $Y=436980
X1272 3578 2 3605 1 INV1S $T=783680 407120 0 0 $X=783680 $Y=406740
X1273 3604 2 3593 1 INV1S $T=785540 467600 1 180 $X=784300 $Y=467220
X1274 3595 2 3590 1 INV1S $T=786160 487760 0 180 $X=784920 $Y=482340
X1275 3612 2 3608 1 INV1S $T=786780 437360 0 0 $X=786780 $Y=436980
X1276 3609 2 3626 1 INV1S $T=788020 467600 1 0 $X=788020 $Y=462180
X1277 3594 2 3629 1 INV1S $T=790500 447440 0 0 $X=790500 $Y=447060
X1278 3566 2 3637 1 INV1S $T=791120 397040 0 0 $X=791120 $Y=396660
X1279 3624 2 3641 1 INV1S $T=792360 487760 0 0 $X=792360 $Y=487380
X1280 3638 2 3644 1 INV1S $T=795460 477680 1 0 $X=795460 $Y=472260
X1281 3663 2 3627 1 INV1S $T=797940 477680 1 180 $X=796700 $Y=477300
X1282 3662 2 3655 1 INV1S $T=798560 457520 0 180 $X=797320 $Y=452100
X1283 3665 2 3689 1 INV1S $T=798560 336560 1 0 $X=798560 $Y=331140
X1284 715 2 712 1 INV1S $T=799800 497840 0 180 $X=798560 $Y=492420
X1285 3678 2 3672 1 INV1S $T=800420 417200 1 180 $X=799180 $Y=416820
X1286 3677 2 3686 1 INV1S $T=799800 397040 0 0 $X=799800 $Y=396660
X1287 722 2 3418 1 INV1S $T=802280 457520 1 180 $X=801040 $Y=457140
X1288 3657 2 3683 1 INV1S $T=802280 397040 1 0 $X=802280 $Y=391620
X1289 3679 2 3693 1 INV1S $T=806620 346640 1 180 $X=805380 $Y=346260
X1290 3652 2 3698 1 INV1S $T=806620 376880 1 180 $X=805380 $Y=376500
X1291 3688 2 3702 1 INV1S $T=807240 366800 0 180 $X=806000 $Y=361380
X1292 3708 2 3712 1 INV1S $T=807240 447440 0 180 $X=806000 $Y=442020
X1293 3670 2 3715 1 INV1S $T=807860 407120 0 180 $X=806620 $Y=401700
X1294 3660 2 3710 1 INV1S $T=807240 346640 1 0 $X=807240 $Y=341220
X1295 3737 2 3716 1 INV1S $T=810340 417200 1 180 $X=809100 $Y=416820
X1296 3741 2 3769 1 INV1S $T=814680 407120 1 0 $X=814680 $Y=401700
X1297 3743 2 3770 1 INV1S $T=815920 457520 0 0 $X=815920 $Y=457140
X1298 3773 2 3771 1 INV1S $T=817780 417200 0 0 $X=817780 $Y=416820
X1299 745 2 3374 1 INV1S $T=819640 467600 1 180 $X=818400 $Y=467220
X1300 3827 2 3816 1 INV1S $T=828940 457520 0 180 $X=827700 $Y=452100
X1301 3852 2 3856 1 INV1S $T=839480 447440 1 0 $X=839480 $Y=442020
X1302 3878 2 3884 1 INV1S $T=841340 437360 0 0 $X=841340 $Y=436980
X1303 795 2 3912 1 INV1S $T=849400 326480 1 180 $X=848160 $Y=326100
X1304 798 2 787 1 INV1S $T=853120 497840 0 180 $X=851880 $Y=492420
X1305 783 2 792 1 INV1S $T=852500 376880 1 0 $X=852500 $Y=371460
X1306 796 2 788 1 INV1S $T=854980 356720 1 180 $X=853740 $Y=356340
X1307 3914 2 3936 1 INV1S $T=853740 437360 0 0 $X=853740 $Y=436980
X1308 797 2 3949 1 INV1S $T=858080 346640 0 0 $X=858080 $Y=346260
X1309 807 2 821 1 INV1S $T=861800 366800 0 0 $X=861800 $Y=366420
X1310 3774 2 3747 1 INV1S $T=861800 427280 0 0 $X=861800 $Y=426900
X1311 822 2 815 1 INV1S $T=864280 356720 1 180 $X=863040 $Y=356340
X1312 823 2 825 1 INV1S $T=863660 376880 0 0 $X=863660 $Y=376500
X1313 3961 2 3966 1 INV1S $T=863660 447440 1 0 $X=863660 $Y=442020
X1314 824 2 827 1 INV1S $T=864280 346640 0 0 $X=864280 $Y=346260
X1315 830 2 803 1 INV1S $T=866140 356720 1 180 $X=864900 $Y=356340
X1316 3964 2 3988 1 INV1S $T=865520 447440 1 0 $X=865520 $Y=442020
X1317 3978 2 3995 1 INV1S $T=867380 487760 1 0 $X=867380 $Y=482340
X1318 4008 2 3992 1 INV1S $T=870480 457520 0 180 $X=869240 $Y=452100
X1319 835 2 4013 1 INV1S $T=869860 336560 1 0 $X=869860 $Y=331140
X1320 3982 2 4015 1 INV1S $T=870480 487760 1 0 $X=870480 $Y=482340
X1321 3976 2 4021 1 INV1S $T=871720 437360 1 0 $X=871720 $Y=431940
X1322 215 2 4028 1 INV1S $T=872340 397040 1 0 $X=872340 $Y=391620
X1323 4041 2 3984 1 INV1S $T=875440 467600 1 180 $X=874200 $Y=467220
X1324 4057 2 4049 1 INV1S $T=879160 487760 0 180 $X=877920 $Y=482340
X1325 3891 2 864 1 INV1S $T=879160 336560 0 0 $X=879160 $Y=336180
X1326 802 2 831 1 INV1S $T=879160 346640 1 0 $X=879160 $Y=341220
X1327 4044 2 4061 1 INV1S $T=879780 447440 0 0 $X=879780 $Y=447060
X1328 863 2 867 1 INV1S $T=880400 487760 0 0 $X=880400 $Y=487380
X1329 4072 2 4058 1 INV1S $T=882260 477680 1 180 $X=881020 $Y=477300
X1330 3781 2 4075 1 INV1S $T=882260 417200 0 0 $X=882260 $Y=416820
X1331 245 2 4039 1 INV1S $T=885360 397040 0 180 $X=884120 $Y=391620
X1332 868 2 775 1 INV1S $T=884740 346640 0 0 $X=884740 $Y=346260
X1333 4093 2 4077 1 INV1S $T=885980 447440 1 180 $X=884740 $Y=447060
X1334 3501 2 4088 1 INV1S $T=885360 397040 1 0 $X=885360 $Y=391620
X1335 3951 2 4087 1 INV1S $T=886600 477680 0 180 $X=885360 $Y=472260
X1336 882 2 777 1 INV1S $T=887220 356720 0 0 $X=887220 $Y=356340
X1337 4025 2 4113 1 INV1S $T=890940 386960 1 0 $X=890940 $Y=381540
X1338 4091 2 4105 1 INV1S $T=890940 427280 0 0 $X=890940 $Y=426900
X1339 4102 2 4109 1 INV1S $T=892800 447440 0 180 $X=891560 $Y=442020
X1340 892 2 897 1 INV1S $T=892180 487760 0 0 $X=892180 $Y=487380
X1341 4095 2 4123 1 INV1S $T=892800 477680 1 0 $X=892800 $Y=472260
X1342 4053 2 4125 1 INV1S $T=894040 386960 0 0 $X=894040 $Y=386580
X1343 842 2 808 1 INV1S $T=895900 346640 0 180 $X=894660 $Y=341220
X1344 4118 2 4096 1 INV1S $T=895900 427280 0 180 $X=894660 $Y=421860
X1345 876 2 4137 1 INV1S $T=895900 477680 0 0 $X=895900 $Y=477300
X1346 4099 2 4128 1 INV1S $T=896520 407120 1 0 $X=896520 $Y=401700
X1347 856 2 904 1 INV1S $T=897140 346640 0 0 $X=897140 $Y=346260
X1348 877 2 809 1 INV1S $T=897760 366800 0 0 $X=897760 $Y=366420
X1349 4018 2 4138 1 INV1S $T=899620 427280 1 180 $X=898380 $Y=426900
X1350 3524 2 3509 1 INV1S $T=898380 447440 0 0 $X=898380 $Y=447060
X1351 4116 2 4160 1 INV1S $T=899620 447440 1 0 $X=899620 $Y=442020
X1352 4112 2 4168 1 INV1S $T=899620 477680 0 0 $X=899620 $Y=477300
X1353 4159 2 4169 1 INV1S $T=900240 427280 1 0 $X=900240 $Y=421860
X1354 4158 2 4149 1 INV1S $T=901480 386960 1 0 $X=901480 $Y=381540
X1355 837 2 865 1 INV1S $T=902100 336560 0 0 $X=902100 $Y=336180
X1356 4187 2 4183 1 INV1S $T=905200 477680 0 180 $X=903960 $Y=472260
X1357 4139 2 4211 1 INV1S $T=904580 427280 0 0 $X=904580 $Y=426900
X1358 4182 2 4194 1 INV1S $T=905200 457520 0 0 $X=905200 $Y=457140
X1359 917 2 826 1 INV1S $T=906440 346640 0 0 $X=906440 $Y=346260
X1360 3981 2 4162 1 INV1S $T=906440 366800 1 0 $X=906440 $Y=361380
X1361 784 2 873 1 INV1S $T=908300 336560 0 0 $X=908300 $Y=336180
X1362 4135 2 4213 1 INV1S $T=910160 366800 1 0 $X=910160 $Y=361380
X1363 4173 2 4224 1 INV1S $T=910160 457520 1 0 $X=910160 $Y=452100
X1364 911 2 4223 1 INV1S $T=911400 407120 0 0 $X=911400 $Y=406740
X1365 913 2 4121 1 INV1S $T=912640 487760 1 180 $X=911400 $Y=487380
X1366 4190 2 4203 1 INV1S $T=913260 376880 0 0 $X=913260 $Y=376500
X1367 4186 2 4233 1 INV1S $T=913880 397040 1 0 $X=913880 $Y=391620
X1368 4106 2 805 1 INV1S $T=919460 366800 1 180 $X=918220 $Y=366420
X1369 914 2 4220 1 INV1S $T=918220 417200 0 0 $X=918220 $Y=416820
X1370 4249 2 4269 1 INV1S $T=918220 437360 1 0 $X=918220 $Y=431940
X1371 250 2 4288 1 INV1S $T=923800 417200 1 0 $X=923800 $Y=411780
X1372 896 2 4282 1 INV1S $T=923800 427280 1 0 $X=923800 $Y=421860
X1373 4283 2 4287 1 INV1S $T=924420 457520 0 0 $X=924420 $Y=457140
X1374 845 2 786 1 INV1S $T=925040 336560 0 0 $X=925040 $Y=336180
X1375 875 2 889 1 INV1S $T=925040 346640 0 0 $X=925040 $Y=346260
X1376 854 2 910 1 INV1S $T=925040 397040 1 0 $X=925040 $Y=391620
X1377 779 2 834 1 INV1S $T=926280 366800 1 0 $X=926280 $Y=361380
X1378 965 2 4256 1 INV1S $T=928140 326480 1 180 $X=926900 $Y=326100
X1379 4200 2 4242 1 INV1S $T=926900 386960 0 0 $X=926900 $Y=386580
X1380 4243 2 4267 1 INV1S $T=928140 397040 0 180 $X=926900 $Y=391620
X1381 4046 2 4300 1 INV1S $T=926900 407120 0 0 $X=926900 $Y=406740
X1382 4298 2 4126 1 INV1S $T=928760 437360 1 180 $X=927520 $Y=436980
X1383 4126 2 3659 1 INV1S $T=928760 437360 0 0 $X=928760 $Y=436980
X1384 4297 2 4304 1 INV1S $T=930000 447440 0 0 $X=930000 $Y=447060
X1385 4154 2 4146 1 INV1S $T=931240 376880 0 0 $X=931240 $Y=376500
X1386 4319 2 4307 1 INV1S $T=933100 386960 1 180 $X=931860 $Y=386580
X1387 4051 2 800 1 INV1S $T=932480 346640 1 0 $X=932480 $Y=341220
X1388 722 2 970 1 INV1S $T=932480 477680 1 0 $X=932480 $Y=472260
X1389 4119 2 4327 1 INV1S $T=933100 356720 0 0 $X=933100 $Y=356340
X1390 4329 2 4310 1 INV1S $T=934960 457520 1 180 $X=933720 $Y=457140
X1391 250 2 4340 1 INV1S $T=934960 397040 0 0 $X=934960 $Y=396660
X1392 896 2 4336 1 INV1S $T=934960 407120 0 0 $X=934960 $Y=406740
X1393 976 2 883 1 INV1S $T=936820 477680 1 180 $X=935580 $Y=477300
X1394 851 2 843 1 INV1S $T=936820 336560 0 0 $X=936820 $Y=336180
X1395 4148 2 4202 1 INV1S $T=938060 397040 0 180 $X=936820 $Y=391620
X1396 833 2 801 1 INV1S $T=941160 346640 0 180 $X=939920 $Y=341220
X1397 4207 2 4349 1 INV1S $T=941160 376880 1 180 $X=939920 $Y=376500
X1398 4342 2 986 1 INV1S $T=941780 497840 0 180 $X=940540 $Y=492420
X1399 4103 2 4082 1 INV1S $T=941160 346640 1 0 $X=941160 $Y=341220
X1400 4365 2 4354 1 INV1S $T=942400 457520 1 180 $X=941160 $Y=457140
X1401 745 2 993 1 INV1S $T=943640 467600 1 0 $X=943640 $Y=462180
X1402 838 2 852 1 INV1S $T=945500 346640 0 180 $X=944260 $Y=341220
X1403 4252 2 4227 1 INV1S $T=945500 386960 1 180 $X=944260 $Y=386580
X1404 4372 2 4380 1 INV1S $T=945500 407120 1 0 $X=945500 $Y=401700
X1405 4204 2 922 1 INV1S $T=946740 356720 0 0 $X=946740 $Y=356340
X1406 817 2 936 1 INV1S $T=949220 336560 1 180 $X=947980 $Y=336180
X1407 4383 2 4378 1 INV1S $T=949840 457520 0 180 $X=948600 $Y=452100
X1408 4403 2 4255 1 INV1S $T=950460 346640 0 180 $X=949220 $Y=341220
X1409 4391 2 954 1 INV1S $T=950460 366800 1 180 $X=949220 $Y=366420
X1410 989 2 4394 1 INV1S $T=949220 397040 0 0 $X=949220 $Y=396660
X1411 924 2 793 1 INV1S $T=957280 356720 0 180 $X=956040 $Y=351300
X1412 3501 2 4426 1 INV1S $T=956040 386960 1 0 $X=956040 $Y=381540
X1413 4401 2 4427 1 INV1S $T=956660 457520 0 0 $X=956660 $Y=457140
X1414 4441 2 4436 1 INV1S $T=959140 386960 0 180 $X=957900 $Y=381540
X1415 911 2 4400 1 INV1S $T=957900 407120 1 0 $X=957900 $Y=401700
X1416 4444 2 1020 1 INV1S $T=960380 366800 0 180 $X=959140 $Y=361380
X1417 4384 2 1031 1 INV1S $T=962860 346640 1 0 $X=962860 $Y=341220
X1418 4468 2 4461 1 INV1S $T=964100 376880 1 180 $X=962860 $Y=376500
X1419 4420 2 4456 1 INV1S $T=964720 336560 0 180 $X=963480 $Y=331140
X1420 4411 2 1027 1 INV1S $T=965340 346640 0 0 $X=965340 $Y=346260
X1421 4483 2 4440 1 INV1S $T=967200 356720 0 180 $X=965960 $Y=351300
X1422 1024 2 1016 1 INV1S $T=967820 346640 1 180 $X=966580 $Y=346260
X1423 4499 2 4485 1 INV1S $T=970300 457520 1 180 $X=969060 $Y=457140
X1424 4490 2 4480 1 INV1S $T=969680 356720 0 0 $X=969680 $Y=356340
X1425 245 2 4501 1 INV1S $T=970300 386960 0 0 $X=970300 $Y=386580
X1426 1038 2 4470 1 INV1S $T=972160 346640 0 0 $X=972160 $Y=346260
X1427 4500 2 4424 1 INV1S $T=974020 376880 0 0 $X=974020 $Y=376500
X1428 1047 2 4527 1 INV1S $T=977120 346640 0 180 $X=975880 $Y=341220
X1429 215 2 4494 1 INV1S $T=977740 397040 1 180 $X=976500 $Y=396660
X1430 4515 2 1049 1 INV1S $T=977740 346640 1 0 $X=977740 $Y=341220
X1431 4533 2 4538 1 INV1S $T=980840 457520 0 180 $X=979600 $Y=452100
X1432 1057 2 1068 1 INV1S $T=982700 356720 0 0 $X=982700 $Y=356340
X1433 1063 2 4462 1 INV1S $T=983320 376880 0 0 $X=983320 $Y=376500
X1434 4557 2 4553 1 INV1S $T=983320 397040 1 0 $X=983320 $Y=391620
X1435 4546 2 4596 1 INV1S $T=986420 386960 1 0 $X=986420 $Y=381540
X1436 4568 2 4600 1 INV1S $T=987040 457520 1 0 $X=987040 $Y=452100
X1437 4571 2 4604 1 INV1S $T=989520 366800 0 0 $X=989520 $Y=366420
X1438 4574 2 4613 1 INV1S $T=990140 356720 1 0 $X=990140 $Y=351300
X1439 1078 2 4579 1 INV1S $T=991380 386960 0 0 $X=991380 $Y=386580
X1440 3904 2 3994 1 INV1S $T=993240 417200 0 180 $X=992000 $Y=411780
X1441 1060 2 1093 1 INV1S $T=992620 336560 1 0 $X=992620 $Y=331140
X1442 4619 2 4569 1 INV1S $T=994480 397040 0 180 $X=993240 $Y=391620
X1443 4609 2 4622 1 INV1S $T=995100 467600 0 0 $X=995100 $Y=467220
X1444 3904 2 4035 1 INV1S $T=998200 417200 0 180 $X=996960 $Y=411780
X1445 4541 2 1095 1 INV1S $T=998820 336560 0 180 $X=997580 $Y=331140
X1446 4018 2 4513 1 INV1S $T=997580 427280 1 0 $X=997580 $Y=421860
X1447 3904 2 4447 1 INV1S $T=1000060 487760 0 0 $X=1000060 $Y=487380
X1448 3781 2 4672 1 INV1S $T=1001300 447440 1 0 $X=1001300 $Y=442020
X1449 4676 2 4670 1 INV1S $T=1003780 467600 0 180 $X=1002540 $Y=462180
X1450 4636 2 4674 1 INV1S $T=1003780 386960 0 0 $X=1003780 $Y=386580
X1451 4592 2 4685 1 INV1S $T=1005640 386960 1 0 $X=1005640 $Y=381540
X1452 4018 2 4346 1 INV1S $T=1007500 417200 0 0 $X=1007500 $Y=416820
X1453 4552 2 1123 1 INV1S $T=1008740 346640 1 0 $X=1008740 $Y=341220
X1454 3774 2 4387 1 INV1S $T=1008740 437360 1 0 $X=1008740 $Y=431940
X1455 1088 2 4563 1 INV1S $T=1009360 397040 1 0 $X=1009360 $Y=391620
X1456 3951 2 4716 1 INV1S $T=1009360 487760 1 0 $X=1009360 $Y=482340
X1457 4698 2 4717 1 INV1S $T=1010600 366800 0 0 $X=1010600 $Y=366420
X1458 1124 2 1136 1 INV1S $T=1010600 376880 0 0 $X=1010600 $Y=376500
X1459 3951 2 4023 1 INV1S $T=1011840 417200 0 180 $X=1010600 $Y=411780
X1460 4582 2 4706 1 INV1S $T=1013080 397040 0 180 $X=1011840 $Y=391620
X1461 3951 2 3999 1 INV1S $T=1013080 417200 0 180 $X=1011840 $Y=411780
X1462 4733 2 4731 1 INV1S $T=1013700 467600 1 0 $X=1013700 $Y=462180
X1463 1138 2 4707 1 INV1S $T=1016800 376880 1 180 $X=1015560 $Y=376500
X1464 1140 2 1141 1 INV1S $T=1017420 326480 0 0 $X=1017420 $Y=326100
X1465 4675 2 4761 1 INV1S $T=1017420 356720 0 0 $X=1017420 $Y=356340
X1466 4746 2 4757 1 INV1S $T=1017420 437360 1 0 $X=1017420 $Y=431940
X1467 4739 2 4758 1 INV1S $T=1017420 477680 0 0 $X=1017420 $Y=477300
X1468 4751 2 4768 1 INV1S $T=1018660 457520 1 0 $X=1018660 $Y=452100
X1469 4736 2 4775 1 INV1S $T=1020520 447440 1 0 $X=1020520 $Y=442020
X1470 4744 2 4650 1 INV1S $T=1026100 376880 0 180 $X=1024860 $Y=371460
X1471 4785 2 4795 1 INV1S $T=1027340 457520 1 180 $X=1026100 $Y=457140
X1472 976 2 1161 1 INV1S $T=1026100 487760 0 0 $X=1026100 $Y=487380
X1473 876 2 4827 1 INV1S $T=1029200 477680 1 0 $X=1029200 $Y=472260
X1474 4018 2 4832 1 INV1S $T=1029820 447440 0 0 $X=1029820 $Y=447060
X1475 4540 2 4690 1 INV1S $T=1031680 407120 1 0 $X=1031680 $Y=401700
X1476 4850 2 4857 1 INV1S $T=1036020 467600 1 0 $X=1036020 $Y=462180
X1477 4298 2 4863 1 INV1S $T=1036640 457520 1 0 $X=1036640 $Y=452100
X1478 4710 2 1178 1 INV1S $T=1037880 356720 0 0 $X=1037880 $Y=356340
X1479 4728 2 4871 1 INV1S $T=1037880 407120 0 0 $X=1037880 $Y=406740
X1480 1197 2 1188 1 INV1S $T=1039740 427280 1 180 $X=1038500 $Y=426900
X1481 4654 2 1190 1 INV1S $T=1039120 376880 0 0 $X=1039120 $Y=376500
X1482 1151 2 1194 1 INV1S $T=1039740 497840 1 0 $X=1039740 $Y=492420
X1483 4821 2 4897 1 INV1S $T=1040980 487760 0 0 $X=1040980 $Y=487380
X1484 4637 2 4865 1 INV1S $T=1042220 346640 0 0 $X=1042220 $Y=346260
X1485 4667 2 4620 1 INV1S $T=1044080 386960 0 180 $X=1042840 $Y=381540
X1486 4730 2 4904 1 INV1S $T=1042840 467600 1 0 $X=1042840 $Y=462180
X1487 4823 2 4646 1 INV1S $T=1043460 386960 0 0 $X=1043460 $Y=386580
X1488 4863 2 4874 1 INV1S $T=1046560 457520 1 0 $X=1046560 $Y=452100
X1489 4623 2 4727 1 INV1S $T=1047180 376880 0 0 $X=1047180 $Y=376500
X1490 4851 2 4930 1 INV1S $T=1048420 487760 0 0 $X=1048420 $Y=487380
X1491 1227 2 1222 1 INV1S $T=1054620 427280 1 180 $X=1053380 $Y=426900
X1492 1165 2 1226 1 INV1S $T=1053380 497840 1 0 $X=1053380 $Y=492420
X1493 1227 2 1230 1 INV1S $T=1057100 427280 1 180 $X=1055860 $Y=426900
X1494 4855 2 4963 1 INV1S $T=1057100 487760 0 180 $X=1055860 $Y=482340
X1495 4906 2 4972 1 INV1S $T=1057100 386960 1 0 $X=1057100 $Y=381540
X1496 4881 2 4986 1 INV1S $T=1059580 487760 0 0 $X=1059580 $Y=487380
X1497 4631 2 4629 1 INV1S $T=1060200 386960 1 0 $X=1060200 $Y=381540
X1498 4774 2 4988 1 INV1S $T=1062060 457520 0 0 $X=1062060 $Y=457140
X1499 4590 2 1242 1 INV1S $T=1065160 356720 1 0 $X=1065160 $Y=351300
X1500 4890 2 5023 1 INV1S $T=1066400 447440 1 0 $X=1066400 $Y=442020
X1501 4830 2 5008 1 INV1S $T=1066400 467600 1 0 $X=1066400 $Y=462180
X1502 1254 2 1257 1 INV1S $T=1071980 497840 1 0 $X=1071980 $Y=492420
X1503 4658 2 1111 1 INV1S $T=1076940 376880 1 180 $X=1075700 $Y=376500
X1504 4625 2 5011 1 INV1S $T=1075700 386960 0 0 $X=1075700 $Y=386580
X1505 1127 2 4858 1 INV1S $T=1077560 376880 0 0 $X=1077560 $Y=376500
X1506 4642 2 4842 1 INV1S $T=1078800 386960 1 180 $X=1077560 $Y=386580
X1507 4633 2 4924 1 INV1S $T=1077560 397040 0 0 $X=1077560 $Y=396660
X1508 5036 2 5053 1 INV1S $T=1078800 487760 1 0 $X=1078800 $Y=482340
X1509 4915 2 5042 1 INV1S $T=1080660 457520 0 180 $X=1079420 $Y=452100
X1510 4655 2 4721 1 INV1S $T=1080040 356720 1 0 $X=1080040 $Y=351300
X1511 4927 2 5078 1 INV1S $T=1085000 447440 0 0 $X=1085000 $Y=447060
X1512 5061 2 5009 1 INV1S $T=1086860 366800 0 180 $X=1085620 $Y=361380
X1513 4666 2 4777 1 INV1S $T=1087480 366800 1 0 $X=1087480 $Y=361380
X1514 4537 2 4922 1 INV1S $T=1088720 376880 1 180 $X=1087480 $Y=376500
X1515 1120 2 4811 1 INV1S $T=1089340 407120 1 0 $X=1089340 $Y=401700
X1516 1101 2 1209 1 INV1S $T=1090580 356720 0 0 $X=1090580 $Y=356340
X1517 5096 2 5077 1 INV1S $T=1093060 386960 1 0 $X=1093060 $Y=381540
X1518 2550 2535 2515 2 1 2511 XOR3 $T=544360 397040 0 180 $X=533200 $Y=391620
X1519 2558 2538 2516 2 1 2512 XOR3 $T=544980 417200 1 180 $X=533820 $Y=416820
X1520 2520 2527 2524 2 1 2517 XOR3 $T=547460 376880 0 180 $X=536300 $Y=371460
X1521 2495 2547 432 2 1 2521 XOR3 $T=550560 346640 1 180 $X=539400 $Y=346260
X1522 454 2587 2560 2 1 2559 XOR3 $T=559240 356720 1 180 $X=548080 $Y=356340
X1523 2689 473 2617 2 1 2629 XOR3 $T=573500 356720 1 180 $X=562340 $Y=356340
X1524 2660 2629 2635 2 1 2639 XOR3 $T=575980 447440 1 180 $X=564820 $Y=447060
X1525 498 2782 2751 2 1 2741 XOR3 $T=593960 457520 1 180 $X=582800 $Y=457140
X1526 2785 2798 2812 2 1 2782 XOR3 $T=595200 447440 1 0 $X=595200 $Y=442020
X1527 2852 2841 2815 2 1 2809 XOR3 $T=609460 447440 1 180 $X=598300 $Y=447060
X1528 2809 2848 2822 2 1 2816 XOR3 $T=611320 457520 1 180 $X=600160 $Y=457140
X1529 2860 529 2885 2 1 2871 XOR3 $T=624340 447440 1 180 $X=613180 $Y=447060
X1530 2913 530 2886 2 1 2896 XOR3 $T=630540 467600 0 180 $X=619380 $Y=462180
X1531 2904 2909 2900 2 1 2913 XOR3 $T=620000 437360 0 0 $X=620000 $Y=436980
X1532 2935 553 2929 2 1 2948 XOR3 $T=644800 467600 0 180 $X=633640 $Y=462180
X1533 2965 558 3010 2 1 3056 XOR3 $T=648520 467600 1 0 $X=648520 $Y=462180
X1534 3006 3037 3029 2 1 3091 XOR3 $T=651620 447440 1 0 $X=651620 $Y=442020
X1535 3021 576 3041 2 1 3046 XOR3 $T=666500 457520 1 180 $X=655340 $Y=457140
X1536 3054 3059 3045 2 1 3100 XOR3 $T=657200 427280 1 0 $X=657200 $Y=421860
X1537 3048 3075 3061 2 1 3111 XOR3 $T=660300 437360 0 0 $X=660300 $Y=436980
X1538 3085 581 3103 2 1 3109 XOR3 $T=664640 356720 0 0 $X=664640 $Y=356340
X1539 3091 584 3084 2 1 3132 XOR3 $T=666500 457520 1 0 $X=666500 $Y=452100
X1540 3096 3104 3139 2 1 3147 XOR3 $T=668980 386960 1 0 $X=668980 $Y=381540
X1541 3095 585 3116 2 1 3145 XOR3 $T=669600 376880 1 0 $X=669600 $Y=371460
X1542 3131 3145 3124 2 1 3113 XOR3 $T=683240 407120 0 180 $X=672080 $Y=401700
X1543 3165 3162 3141 2 1 3134 XOR3 $T=688200 366800 1 180 $X=677040 $Y=366420
X1544 3178 3168 597 2 1 3129 XOR3 $T=690680 336560 1 180 $X=679520 $Y=336180
X1545 3106 3133 3152 2 1 3177 XOR3 $T=679520 437360 1 0 $X=679520 $Y=431940
X1546 3174 3180 3158 2 1 3156 XOR3 $T=694400 386960 0 180 $X=683240 $Y=381540
X1547 3196 3190 3161 2 1 3146 XOR3 $T=696880 407120 0 180 $X=685720 $Y=401700
X1548 3169 3170 3182 2 1 3178 XOR3 $T=688820 346640 1 0 $X=688820 $Y=341220
X1549 3206 3201 3172 2 1 3130 XOR3 $T=699980 346640 1 180 $X=688820 $Y=346260
X1550 3173 3175 3192 2 1 3206 XOR3 $T=690060 366800 1 0 $X=690060 $Y=361380
X1551 3199 3184 3186 2 1 3165 XOR3 $T=704320 376880 0 180 $X=693160 $Y=371460
X1552 3208 3193 612 2 1 608 XOR3 $T=705560 326480 1 180 $X=694400 $Y=326100
X1553 3217 3194 3195 2 1 3181 XOR3 $T=706180 417200 0 180 $X=695020 $Y=411780
X1554 3258 3240 3203 2 1 3176 XOR3 $T=708040 447440 0 180 $X=696880 $Y=442020
X1555 3207 3214 3246 2 1 3196 XOR3 $T=700600 407120 1 0 $X=700600 $Y=401700
X1556 3265 3247 3227 2 1 3217 XOR3 $T=713000 417200 1 180 $X=701840 $Y=416820
X1557 3218 3226 3260 2 1 3258 XOR3 $T=701840 437360 0 0 $X=701840 $Y=436980
X1558 3280 3296 3283 2 1 3266 XOR3 $T=717340 437360 0 0 $X=717340 $Y=436980
X1559 3313 3314 3306 2 1 3365 XOR3 $T=721060 447440 1 0 $X=721060 $Y=442020
X1560 3365 3359 3297 2 1 3316 XOR3 $T=733460 457520 1 180 $X=722300 $Y=457140
X1561 3341 3346 3330 2 1 3411 XOR3 $T=729740 427280 0 0 $X=729740 $Y=426900
X1562 3423 3408 3375 2 1 3194 XOR3 $T=745860 397040 0 180 $X=734700 $Y=391620
X1563 3430 3425 3395 2 1 3240 XOR3 $T=750820 397040 1 180 $X=739660 $Y=396660
X1564 3439 3411 3400 2 1 3394 XOR3 $T=751440 457520 0 180 $X=740280 $Y=452100
X1565 3413 3406 3405 2 1 3162 XOR3 $T=752680 356720 1 180 $X=741520 $Y=356340
X1566 3460 3451 3422 2 1 668 XOR3 $T=757020 497840 0 180 $X=745860 $Y=492420
X1567 3478 3456 3424 2 1 672 XOR3 $T=758260 477680 0 180 $X=747100 $Y=472260
X1568 3479 3473 3432 2 1 3262 XOR3 $T=760740 417200 0 180 $X=749580 $Y=411780
X1569 3476 3498 3458 2 1 3452 XOR3 $T=766320 437360 0 180 $X=755160 $Y=431940
X1570 3526 3510 3464 2 1 676 XOR3 $T=766940 467600 1 180 $X=755780 $Y=467220
X1571 3511 3514 694 2 1 698 XOR3 $T=765080 497840 1 0 $X=765080 $Y=492420
X1572 3538 3560 3527 2 1 3439 XOR3 $T=778720 437360 0 180 $X=767560 $Y=431940
X1573 3522 3561 3520 2 1 689 XOR3 $T=778720 477680 1 180 $X=767560 $Y=477300
X1574 3552 3548 3531 2 1 3359 XOR3 $T=783680 417200 1 180 $X=772520 $Y=416820
X1575 3572 3567 3580 2 1 3498 XOR3 $T=790500 427280 0 180 $X=779340 $Y=421860
X1576 3597 3635 3563 2 1 3486 XOR3 $T=792980 437360 0 180 $X=781820 $Y=431940
X1577 3625 3646 3587 2 1 3600 XOR3 $T=796080 417200 1 180 $X=784920 $Y=416820
X1578 4209 4239 4259 2 1 959 XOR3 $T=914500 477680 1 0 $X=914500 $Y=472260
X1579 4246 4225 4228 2 1 963 XOR3 $T=916360 467600 1 0 $X=916360 $Y=462180
X1580 4286 4309 955 2 1 952 XOR3 $T=932480 497840 0 180 $X=921320 $Y=492420
X1581 5019 5018 5002 2 1 1246 XOR3 $T=1077560 477680 1 180 $X=1066400 $Y=477300
X1582 1272 1275 1284 2 1 1286 XOR3 $T=1082520 497840 1 0 $X=1082520 $Y=492420
X1583 2686 2654 2670 1 2 2705 MAO222 $T=571020 437360 1 0 $X=571020 $Y=431940
X1584 2689 2617 473 1 2 2714 MAO222 $T=572880 356720 1 0 $X=572880 $Y=351300
X1585 2671 2705 2681 1 2 2739 MAO222 $T=577840 437360 1 0 $X=577840 $Y=431940
X1586 2719 2714 477 1 2 489 MAO222 $T=584660 356720 1 0 $X=584660 $Y=351300
X1587 2737 2739 2743 1 2 2812 MAO222 $T=590240 437360 0 0 $X=590240 $Y=436980
X1588 2785 2812 2798 1 2 2815 MAO222 $T=597060 437360 1 0 $X=597060 $Y=431940
X1589 2852 2815 2841 1 2 2866 MAO222 $T=605740 437360 0 0 $X=605740 $Y=436980
X1590 2868 2866 2874 1 2 2900 MAO222 $T=611940 437360 0 0 $X=611940 $Y=436980
X1591 2904 2900 2909 1 2 2943 MAO222 $T=624340 447440 1 0 $X=624340 $Y=442020
X1592 2931 2943 2941 1 2 2970 MAO222 $T=630540 447440 1 0 $X=630540 $Y=442020
X1593 2969 2970 2976 1 2 3000 MAO222 $T=637360 447440 1 0 $X=637360 $Y=442020
X1594 2958 3000 3001 1 2 3029 MAO222 $T=643560 447440 1 0 $X=643560 $Y=442020
X1595 3006 3029 3037 1 2 3061 MAO222 $T=651620 437360 0 0 $X=651620 $Y=436980
X1596 3048 3061 3075 1 2 3074 MAO222 $T=658440 437360 1 0 $X=658440 $Y=431940
X1597 3054 3045 3059 1 2 3086 MAO222 $T=662160 417200 0 0 $X=662160 $Y=416820
X1598 3073 3086 3082 1 2 3065 MAO222 $T=667740 397040 1 180 $X=662780 $Y=396660
X1599 3085 3103 581 1 2 3116 MAO222 $T=668360 346640 0 0 $X=668360 $Y=346260
X1600 3095 3116 585 1 2 3101 MAO222 $T=674560 366800 1 180 $X=669600 $Y=366420
X1601 586 591 588 1 2 3117 MAO222 $T=672700 336560 1 0 $X=672700 $Y=331140
X1602 3131 3124 3145 1 2 3139 MAO222 $T=682620 397040 1 180 $X=677660 $Y=396660
X1603 3169 3182 3170 1 2 3192 MAO222 $T=691300 356720 1 0 $X=691300 $Y=351300
X1604 3173 3192 3175 1 2 3186 MAO222 $T=693780 366800 0 0 $X=693780 $Y=366420
X1605 3199 3186 3184 1 2 3188 MAO222 $T=699360 376880 1 180 $X=694400 $Y=376500
X1606 3208 612 3193 1 2 3182 MAO222 $T=703080 336560 1 180 $X=698120 $Y=336180
X1607 3242 3188 3236 1 2 3246 MAO222 $T=704940 397040 0 0 $X=704940 $Y=396660
X1608 3207 3246 3214 1 2 3227 MAO222 $T=705560 407120 0 0 $X=705560 $Y=406740
X1609 3265 3227 3247 1 2 3260 MAO222 $T=709280 427280 1 0 $X=709280 $Y=421860
X1610 3218 3260 3226 1 2 3283 MAO222 $T=709280 437360 1 0 $X=709280 $Y=431940
X1611 3280 3283 3296 1 2 3306 MAO222 $T=715480 437360 1 0 $X=715480 $Y=431940
X1612 3407 3417 3419 1 2 3416 MAO222 $T=744620 427280 1 0 $X=744620 $Y=421860
X1613 3478 3424 3456 1 2 3464 MAO222 $T=761360 477680 0 0 $X=761360 $Y=477300
X1614 3526 3464 3510 1 2 3491 MAO222 $T=775000 467600 1 180 $X=770040 $Y=467220
X1615 3511 694 3514 1 2 3520 MAO222 $T=776240 487760 1 180 $X=771280 $Y=487380
X1616 3572 3580 3567 1 2 3587 MAO222 $T=777480 417200 1 0 $X=777480 $Y=411780
X1617 4170 4198 4194 1 2 4228 MAO222 $T=908300 467600 1 0 $X=908300 $Y=462180
X1618 4229 4245 4237 1 2 947 MAO222 $T=914500 497840 1 0 $X=914500 $Y=492420
X1619 4239 4259 4209 1 2 4245 MAO222 $T=921940 487760 0 180 $X=916980 $Y=482340
X1620 4225 4228 4246 1 2 4259 MAO222 $T=918840 467600 0 0 $X=918840 $Y=467220
X1621 4286 955 4309 1 2 4295 MAO222 $T=931860 487760 1 180 $X=926900 $Y=487380
X1622 1971 1994 1974 2 1 XOR2HS $T=357740 487760 1 0 $X=357740 $Y=482340
X1623 1972 251 1983 2 1 XOR2HS $T=359600 497840 1 0 $X=359600 $Y=492420
X1624 2580 2589 2572 2 1 XOR2HS $T=556140 447440 0 180 $X=550560 $Y=442020
X1625 2559 2597 2580 2 1 XOR2HS $T=556760 437360 0 180 $X=551180 $Y=431940
X1626 2581 2603 2570 2 1 XOR2HS $T=555520 366800 0 0 $X=555520 $Y=366420
X1627 2618 2644 2634 2 1 XOR2HS $T=567920 386960 1 180 $X=562340 $Y=386580
X1628 2653 461 2620 2 1 XOR2HS $T=568540 336560 1 180 $X=562960 $Y=336180
X1629 2655 2648 2636 2 1 XOR2HS $T=568540 366800 1 180 $X=562960 $Y=366420
X1630 2666 2661 2564 2 1 XOR2HS $T=570400 376880 1 180 $X=564820 $Y=376500
X1631 2669 471 2626 2 1 XOR2HS $T=571020 326480 1 180 $X=565440 $Y=326100
X1632 2645 2658 2619 2 1 XOR2HS $T=571640 417200 0 180 $X=566060 $Y=411780
X1633 2614 2642 2650 2 1 XOR2HS $T=567300 346640 0 0 $X=567300 $Y=346260
X1634 2628 2651 2646 2 1 XOR2HS $T=569780 477680 0 0 $X=569780 $Y=477300
X1635 2704 2688 2682 2 1 XOR2HS $T=576600 346640 0 180 $X=571020 $Y=341220
X1636 2715 2672 2692 2 1 XOR2HS $T=578460 417200 0 180 $X=572880 $Y=411780
X1637 2720 2718 2702 2 1 XOR2HS $T=579700 326480 1 180 $X=574120 $Y=326100
X1638 2697 2713 2726 2 1 XOR2HS $T=575980 336560 0 0 $X=575980 $Y=336180
X1639 2679 2690 2707 2 1 XOR2HS $T=579700 366800 0 0 $X=579700 $Y=366420
X1640 2750 2673 2693 2 1 XOR2HS $T=585280 457520 0 180 $X=579700 $Y=452100
X1641 2748 2752 2729 2 1 XOR2HS $T=583420 437360 1 0 $X=583420 $Y=431940
X1642 2771 2763 2755 2 1 XOR2HS $T=590240 427280 1 180 $X=584660 $Y=426900
X1643 2710 2730 2750 2 1 XOR2HS $T=587140 457520 1 0 $X=587140 $Y=452100
X1644 2796 2788 2783 2 1 XOR2HS $T=597060 427280 1 180 $X=591480 $Y=426900
X1645 2825 2821 2810 2 1 XOR2HS $T=603260 427280 1 180 $X=597680 $Y=426900
X1646 2858 2851 2843 2 1 XOR2HS $T=611320 427280 0 180 $X=605740 $Y=421860
X1647 2879 2854 515 2 1 XOR2HS $T=615040 326480 1 180 $X=609460 $Y=326100
X1648 2892 2876 2873 2 1 XOR2HS $T=616900 427280 0 180 $X=611320 $Y=421860
X1649 2907 2891 2895 2 1 XOR2HS $T=620000 336560 0 0 $X=620000 $Y=336180
X1650 2922 2906 2916 2 1 XOR2HS $T=626820 427280 0 180 $X=621240 $Y=421860
X1651 2944 2925 2930 2 1 XOR2HS $T=631160 336560 0 180 $X=625580 $Y=331140
X1652 2939 2934 2954 2 1 XOR2HS $T=628060 417200 0 0 $X=628060 $Y=416820
X1653 2961 2951 2940 2 1 XOR2HS $T=633020 437360 1 0 $X=633020 $Y=431940
X1654 2996 2975 2981 2 1 XOR2HS $T=642940 427280 1 180 $X=637360 $Y=426900
X1655 3012 3014 3004 2 1 XOR2HS $T=648520 427280 0 180 $X=642940 $Y=421860
X1656 2990 2974 3015 2 1 XOR2HS $T=643560 326480 0 0 $X=643560 $Y=326100
X1657 3031 3022 3018 2 1 XOR2HS $T=651620 437360 0 180 $X=646040 $Y=431940
X1658 3026 3035 3040 2 1 XOR2HS $T=650380 397040 0 0 $X=650380 $Y=396660
X1659 3027 3030 3043 2 1 XOR2HS $T=654720 417200 0 0 $X=654720 $Y=416820
X1660 3077 3070 3057 2 1 XOR2HS $T=662780 397040 0 180 $X=657200 $Y=391620
X1661 3050 3060 3072 2 1 XOR2HS $T=657820 356720 0 0 $X=657820 $Y=356340
X1662 3062 3064 3078 2 1 XOR2HS $T=658440 346640 1 0 $X=658440 $Y=341220
X1663 3042 3063 3079 2 1 XOR2HS $T=658440 376880 1 0 $X=658440 $Y=371460
X1664 3036 3038 3058 2 1 XOR2HS $T=659060 407120 0 0 $X=659060 $Y=406740
X1665 3082 3073 3088 2 1 XOR2HS $T=662160 407120 1 0 $X=662160 $Y=401700
X1666 3080 3076 3089 2 1 XOR2HS $T=662780 336560 0 0 $X=662780 $Y=336180
X1667 3067 3066 3090 2 1 XOR2HS $T=662780 366800 1 0 $X=662780 $Y=361380
X1668 3099 3086 3118 2 1 XOR2HS $T=668980 397040 0 0 $X=668980 $Y=396660
X1669 3109 3100 3126 2 1 XOR2HS $T=670220 427280 1 0 $X=670220 $Y=421860
X1670 587 3097 3128 2 1 XOR2HS $T=672700 336560 0 0 $X=672700 $Y=336180
X1671 3125 3126 3143 2 1 XOR2HS $T=676420 427280 1 0 $X=676420 $Y=421860
X1672 592 3111 3142 2 1 XOR2HS $T=677040 447440 0 0 $X=677040 $Y=447060
X1673 3123 3142 3144 2 1 XOR2HS $T=677040 457520 0 0 $X=677040 $Y=457140
X1674 3117 3128 3133 2 1 XOR2HS $T=680760 346640 1 0 $X=680760 $Y=341220
X1675 3243 3241 3229 2 1 XOR2HS $T=708040 346640 0 180 $X=702460 $Y=341220
X1676 3248 3245 3210 2 1 XOR2HS $T=709280 457520 0 180 $X=703700 $Y=452100
X1677 3255 3252 3216 2 1 XOR2HS $T=710520 386960 1 180 $X=704940 $Y=386580
X1678 3257 3253 3235 2 1 XOR2HS $T=711140 356720 0 180 $X=705560 $Y=351300
X1679 3269 618 3238 2 1 XOR2HS $T=713620 326480 1 180 $X=708040 $Y=326100
X1680 3251 3254 3234 2 1 XOR2HS $T=708040 376880 1 0 $X=708040 $Y=371460
X1681 3262 3266 3245 2 1 XOR2HS $T=713620 447440 1 180 $X=708040 $Y=447060
X1682 3244 3250 3222 2 1 XOR2HS $T=709280 366800 0 0 $X=709280 $Y=366420
X1683 3259 3261 3274 2 1 XOR2HS $T=709900 397040 1 0 $X=709900 $Y=391620
X1684 3267 3273 3282 2 1 XOR2HS $T=711760 407120 0 0 $X=711760 $Y=406740
X1685 3287 3285 3291 2 1 XOR2HS $T=715480 427280 1 0 $X=715480 $Y=421860
X1686 3315 3299 3326 2 1 XOR2HS $T=721680 417200 0 0 $X=721680 $Y=416820
X1687 3335 3325 3343 2 1 XOR2HS $T=725400 417200 1 0 $X=725400 $Y=411780
X1688 3362 3360 3344 2 1 XOR2HS $T=733460 427280 0 180 $X=727880 $Y=421860
X1689 3388 3373 3372 2 1 XOR2HS $T=739660 407120 1 180 $X=734080 $Y=406740
X1690 3392 3383 3401 2 1 XOR2HS $T=738420 437360 0 0 $X=738420 $Y=436980
X1691 3370 3402 3390 2 1 XOR2HS $T=740900 407120 0 0 $X=740900 $Y=406740
X1692 3401 3382 3429 2 1 XOR2HS $T=746480 437360 0 0 $X=746480 $Y=436980
X1693 3472 3471 3443 2 1 XOR2HS $T=759500 356720 1 180 $X=753920 $Y=356340
X1694 3485 3482 3470 2 1 XOR2HS $T=761980 397040 1 180 $X=756400 $Y=396660
X1695 3493 3488 3463 2 1 XOR2HS $T=763220 336560 1 180 $X=757640 $Y=336180
X1696 3484 3489 3444 2 1 XOR2HS $T=763220 376880 0 180 $X=757640 $Y=371460
X1697 3459 3490 3461 2 1 XOR2HS $T=763220 457520 0 180 $X=757640 $Y=452100
X1698 3474 3483 3442 2 1 XOR2HS $T=759500 356720 1 0 $X=759500 $Y=351300
X1699 3486 3429 3490 2 1 XOR2HS $T=767560 447440 1 180 $X=761980 $Y=447060
X1700 3494 3502 3453 2 1 XOR2HS $T=762600 386960 1 0 $X=762600 $Y=381540
X1701 3517 3515 3503 2 1 XOR2HS $T=768180 457520 1 180 $X=762600 $Y=457140
X1702 3481 3499 3462 2 1 XOR2HS $T=764460 326480 0 0 $X=764460 $Y=326100
X1703 3495 3496 3454 2 1 XOR2HS $T=764460 397040 1 0 $X=764460 $Y=391620
X1704 3523 3536 3513 2 1 XOR2HS $T=769420 447440 1 0 $X=769420 $Y=442020
X1705 3558 3535 3547 2 1 XOR2HS $T=776860 397040 0 180 $X=771280 $Y=391620
X1706 3540 3559 3525 2 1 XOR2HS $T=777480 407120 1 180 $X=771900 $Y=406740
X1707 3553 3554 3542 2 1 XOR2HS $T=773760 447440 0 0 $X=773760 $Y=447060
X1708 3551 3544 3568 2 1 XOR2HS $T=774380 437360 0 0 $X=774380 $Y=436980
X1709 3579 3564 3569 2 1 XOR2HS $T=783680 457520 0 180 $X=778100 $Y=452100
X1710 3593 3588 3574 2 1 XOR2HS $T=783680 467600 1 180 $X=778100 $Y=467220
X1711 3590 3589 3575 2 1 XOR2HS $T=783680 487760 0 180 $X=778100 $Y=482340
X1712 3598 3610 3614 2 1 XOR2HS $T=784920 397040 0 0 $X=784920 $Y=396660
X1713 3629 3621 3586 2 1 XOR2HS $T=790500 447440 1 180 $X=784920 $Y=447060
X1714 3605 3599 3583 2 1 XOR2HS $T=791740 407120 1 180 $X=786160 $Y=406740
X1715 3608 3602 3606 2 1 XOR2HS $T=788020 437360 0 0 $X=788020 $Y=436980
X1716 3626 3630 3607 2 1 XOR2HS $T=789260 467600 1 0 $X=789260 $Y=462180
X1717 3644 3623 3633 2 1 XOR2HS $T=794840 467600 1 180 $X=789260 $Y=467220
X1718 3627 3617 3643 2 1 XOR2HS $T=789880 477680 0 0 $X=789880 $Y=477300
X1719 3637 3639 3615 2 1 XOR2HS $T=796080 407120 0 180 $X=790500 $Y=401700
X1720 3672 3666 3653 2 1 XOR2HS $T=800420 427280 1 180 $X=794840 $Y=426900
X1721 3641 708 3616 2 1 XOR2HS $T=794840 487760 0 0 $X=794840 $Y=487380
X1722 3683 3676 3650 2 1 XOR2HS $T=801660 397040 0 180 $X=796080 $Y=391620
X1723 3682 3654 3664 2 1 XOR2HS $T=803520 467600 1 180 $X=797940 $Y=467220
X1724 3693 3690 3673 2 1 XOR2HS $T=804140 346640 1 180 $X=798560 $Y=346260
X1725 3698 3694 3647 2 1 XOR2HS $T=804760 386960 0 180 $X=799180 $Y=381540
X1726 3655 3640 3658 2 1 XOR2HS $T=799180 457520 1 0 $X=799180 $Y=452100
X1727 3702 3697 3680 2 1 XOR2HS $T=805380 366800 0 180 $X=799800 $Y=361380
X1728 3710 3705 3656 2 1 XOR2HS $T=806620 346640 0 180 $X=801040 $Y=341220
X1729 3686 3695 3669 2 1 XOR2HS $T=801660 397040 0 0 $X=801660 $Y=396660
X1730 3715 3707 3661 2 1 XOR2HS $T=807240 407120 1 180 $X=801660 $Y=406740
X1731 3716 3704 3692 2 1 XOR2HS $T=807240 427280 0 180 $X=801660 $Y=421860
X1732 3689 3701 3675 2 1 XOR2HS $T=802900 336560 1 0 $X=802900 $Y=331140
X1733 3712 3718 3713 2 1 XOR2HS $T=805380 457520 1 0 $X=805380 $Y=452100
X1734 3771 3739 3755 2 1 XOR2HS $T=817780 417200 1 180 $X=812200 $Y=416820
X1735 3769 3794 3736 2 1 XOR2HS $T=822740 407120 0 180 $X=817160 $Y=401700
X1736 3770 3756 3749 2 1 XOR2HS $T=817780 457520 1 0 $X=817780 $Y=452100
X1737 3803 3813 3818 2 1 XOR2HS $T=826460 407120 1 0 $X=826460 $Y=401700
X1738 3816 3809 3823 2 1 XOR2HS $T=828940 447440 0 0 $X=828940 $Y=447060
X1739 3856 3853 3864 2 1 XOR2HS $T=835760 457520 1 0 $X=835760 $Y=452100
X1740 3884 3882 3895 2 1 XOR2HS $T=843200 447440 0 0 $X=843200 $Y=447060
X1741 3936 3934 3917 2 1 XOR2HS $T=854360 447440 0 0 $X=854360 $Y=447060
X1742 3966 3960 3956 2 1 XOR2HS $T=866140 457520 0 180 $X=860560 $Y=452100
X1743 3992 4011 4033 2 1 XOR2HS $T=871100 447440 0 0 $X=871100 $Y=447060
X1744 4123 4129 4145 2 1 XOR2HS $T=894660 477680 1 0 $X=894660 $Y=472260
X1745 4161 4156 903 2 1 XOR2HS $T=901480 457520 1 180 $X=895900 $Y=457140
X1746 916 4171 4130 2 1 XOR2HS $T=903960 487760 1 180 $X=898380 $Y=487380
X1747 4108 4155 4181 2 1 XOR2HS $T=900240 437360 0 0 $X=900240 $Y=436980
X1748 4169 4176 4196 2 1 XOR2HS $T=903340 417200 0 0 $X=903340 $Y=416820
X1749 4160 4120 4153 2 1 XOR2HS $T=903340 447440 0 0 $X=903340 $Y=447060
X1750 4175 4168 4199 2 1 XOR2HS $T=904580 477680 0 0 $X=904580 $Y=477300
X1751 4195 4187 4206 2 1 XOR2HS $T=905820 467600 0 0 $X=905820 $Y=467220
X1752 921 929 4217 2 1 XOR2HS $T=907680 497840 1 0 $X=907680 $Y=492420
X1753 4220 4223 4231 2 1 XOR2HS $T=910780 417200 1 0 $X=910780 $Y=411780
X1754 4197 4211 4235 2 1 XOR2HS $T=911400 427280 0 0 $X=911400 $Y=426900
X1755 247 4253 4262 2 1 XOR2HS $T=916360 407120 0 0 $X=916360 $Y=406740
X1756 4269 4232 4276 2 1 XOR2HS $T=921320 427280 0 0 $X=921320 $Y=426900
X1757 4304 4299 4291 2 1 XOR2HS $T=930620 447440 0 180 $X=925040 $Y=442020
X1758 4287 4293 4301 2 1 XOR2HS $T=925040 467600 0 0 $X=925040 $Y=467220
X1759 4288 4277 4303 2 1 XOR2HS $T=926280 407120 1 0 $X=926280 $Y=401700
X1760 4310 4312 4323 2 1 XOR2HS $T=930000 467600 1 0 $X=930000 $Y=462180
X1761 4333 4318 4322 2 1 XOR2HS $T=939300 447440 0 180 $X=933720 $Y=442020
X1762 4340 4344 4355 2 1 XOR2HS $T=936820 397040 0 0 $X=936820 $Y=396660
X1763 4354 4348 4343 2 1 XOR2HS $T=942400 467600 0 180 $X=936820 $Y=462180
X1764 4338 988 4326 2 1 XOR2HS $T=944260 487760 1 180 $X=938680 $Y=487380
X1765 247 4358 4368 2 1 XOR2HS $T=939300 397040 1 0 $X=939300 $Y=391620
X1766 4378 4374 4388 2 1 XOR2HS $T=946740 457520 0 0 $X=946740 $Y=457140
X1767 4394 4400 4415 2 1 XOR2HS $T=951080 397040 0 0 $X=951080 $Y=396660
X1768 4427 4418 4429 2 1 XOR2HS $T=959140 457520 0 0 $X=959140 $Y=457140
X1769 4485 4481 4498 2 1 XOR2HS $T=970920 457520 0 0 $X=970920 $Y=457140
X1770 4538 4535 4542 2 1 XOR2HS $T=977740 457520 0 0 $X=977740 $Y=457140
X1771 4600 4594 4575 2 1 XOR2HS $T=990140 457520 1 180 $X=984560 $Y=457140
X1772 4622 4617 4639 2 1 XOR2HS $T=994480 467600 1 0 $X=994480 $Y=462180
X1773 4670 4660 4656 2 1 XOR2HS $T=1005640 477680 0 180 $X=1000060 $Y=472260
X1774 4731 4726 4754 2 1 XOR2HS $T=1014940 467600 1 0 $X=1014940 $Y=462180
X1775 4768 4779 4781 2 1 XOR2HS $T=1020520 467600 0 0 $X=1020520 $Y=467220
X1776 4795 4790 4816 2 1 XOR2HS $T=1025480 467600 1 0 $X=1025480 $Y=462180
X1777 4878 4872 1181 2 1 XOR2HS $T=1040980 477680 1 180 $X=1035400 $Y=477300
X1778 4857 4849 4861 2 1 XOR2HS $T=1037260 467600 1 0 $X=1037260 $Y=462180
X1779 4904 4913 4923 2 1 XOR2HS $T=1048420 457520 0 0 $X=1048420 $Y=457140
X1780 4891 4855 4952 2 1 XOR2HS $T=1050280 487760 1 0 $X=1050280 $Y=482340
X1781 4941 4940 4956 2 1 XOR2HS $T=1050900 447440 0 0 $X=1050900 $Y=447060
X1782 4965 4981 4984 2 1 XOR2HS $T=1058340 447440 0 0 $X=1058340 $Y=447060
X1783 4986 4978 5000 2 1 XOR2HS $T=1061440 487760 0 0 $X=1061440 $Y=487380
X1784 4988 4980 4993 2 1 XOR2HS $T=1064540 457520 0 0 $X=1064540 $Y=457140
X1785 5008 5016 5024 2 1 XOR2HS $T=1068260 467600 1 0 $X=1068260 $Y=462180
X1786 5021 5027 5036 2 1 XOR2HS $T=1071360 487760 1 0 $X=1071360 $Y=482340
X1787 1257 1260 1264 2 1 XOR2HS $T=1075080 497840 1 0 $X=1075080 $Y=492420
X1788 5038 5051 5025 2 1 XOR2HS $T=1082520 437360 1 180 $X=1076940 $Y=436980
X1789 5042 5046 5052 2 1 XOR2HS $T=1076940 467600 1 0 $X=1076940 $Y=462180
X1790 5058 5044 5088 2 1 XOR2HS $T=1085620 477680 1 0 $X=1085620 $Y=472260
X1791 5078 5063 5074 2 1 XOR2HS $T=1092440 447440 1 180 $X=1086860 $Y=447060
X1792 5076 5088 1285 2 1 XOR2HS $T=1088720 477680 0 0 $X=1088720 $Y=477300
X1793 2514 2504 2507 2 1 ND2S $T=539400 336560 1 180 $X=537540 $Y=336180
X1794 2540 2573 438 2 1 ND2S $T=553040 326480 1 180 $X=551180 $Y=326100
X1795 2759 2745 2757 2 1 ND2S $T=586520 386960 0 0 $X=586520 $Y=386580
X1796 3339 3355 604 2 1 ND2S $T=733460 467600 1 0 $X=733460 $Y=462180
X1797 3388 3402 3373 2 1 ND2S $T=744620 417200 0 180 $X=742760 $Y=411780
X1798 3637 3610 3639 2 1 ND2S $T=791740 397040 1 0 $X=791740 $Y=391620
X1799 3769 3813 3794 2 1 ND2S $T=825840 407120 0 180 $X=823980 $Y=401700
X1800 3965 3979 3967 2 1 ND2S $T=864900 467600 1 180 $X=863040 $Y=467220
X1801 4012 4014 3951 2 1 ND2S $T=870480 467600 1 180 $X=868620 $Y=467220
X1802 4244 4249 4265 2 1 ND2S $T=919460 427280 0 0 $X=919460 $Y=426900
X1803 4277 4253 4288 2 1 ND2S $T=923180 407120 0 0 $X=923180 $Y=406740
X1804 4240 969 4325 2 1 ND2S $T=931860 366800 1 0 $X=931860 $Y=361380
X1805 859 939 808 2 1 ND2S $T=935580 336560 1 180 $X=933720 $Y=336180
X1806 4320 898 4154 2 1 ND2S $T=934960 366800 1 0 $X=934960 $Y=361380
X1807 4335 4216 4158 2 1 ND2S $T=939300 376880 1 180 $X=937440 $Y=376500
X1808 4325 4207 4227 2 1 ND2S $T=940540 376880 1 0 $X=940540 $Y=371460
X1809 4352 987 4200 2 1 ND2S $T=943640 366800 0 180 $X=941780 $Y=361380
X1810 4313 4263 4227 2 1 ND2S $T=943640 386960 0 180 $X=941780 $Y=381540
X1811 4344 4358 4340 2 1 ND2S $T=941780 407120 1 0 $X=941780 $Y=401700
X1812 4352 995 4325 2 1 ND2S $T=943640 366800 1 0 $X=943640 $Y=361380
X1813 4411 1044 1037 2 1 ND2S $T=972780 336560 1 0 $X=972780 $Y=331140
X1814 1023 4517 4411 2 1 ND2S $T=974640 336560 1 180 $X=972780 $Y=336180
X1815 4479 4543 1038 2 1 ND2S $T=979600 356720 1 180 $X=977740 $Y=356340
X1816 4999 4995 4174 2 1 ND2S $T=1065160 457520 0 180 $X=1063300 $Y=452100
X1817 8 1329 1328 1 2 ND2 $T=223200 437360 1 180 $X=221340 $Y=436980
X1818 23 1393 19 1 2 ND2 $T=228780 457520 1 180 $X=226920 $Y=457140
X1819 1406 1395 33 1 2 ND2 $T=232500 477680 1 180 $X=230640 $Y=477300
X1820 1400 1394 1379 1 2 ND2 $T=232500 437360 0 0 $X=232500 $Y=436980
X1821 1406 1403 35 1 2 ND2 $T=234980 487760 0 180 $X=233120 $Y=482340
X1822 1464 1331 1441 1 2 ND2 $T=243660 397040 1 180 $X=241800 $Y=396660
X1823 1466 1433 1453 1 2 ND2 $T=243040 457520 1 0 $X=243040 $Y=452100
X1824 1425 1339 1476 1 2 ND2 $T=243660 397040 0 0 $X=243660 $Y=396660
X1825 1419 1477 1385 1 2 ND2 $T=245520 386960 1 0 $X=245520 $Y=381540
X1826 1340 1499 1441 1 2 ND2 $T=250480 427280 0 180 $X=248620 $Y=421860
X1827 78 1500 18 1 2 ND2 $T=250480 437360 0 180 $X=248620 $Y=431940
X1828 16 1390 1491 1 2 ND2 $T=248620 447440 0 0 $X=248620 $Y=447060
X1829 78 1396 1522 1 2 ND2 $T=249860 417200 1 0 $X=249860 $Y=411780
X1830 1526 1507 1379 1 2 ND2 $T=254200 386960 1 0 $X=254200 $Y=381540
X1831 1524 1366 95 1 2 ND2 $T=254200 477680 1 0 $X=254200 $Y=472260
X1832 1534 1521 1546 1 2 ND2 $T=255440 376880 0 0 $X=255440 $Y=376500
X1833 1562 1583 1561 1 2 ND2 $T=262880 386960 1 180 $X=261020 $Y=386580
X1834 109 1512 115 1 2 ND2 $T=264120 487760 1 0 $X=264120 $Y=482340
X1835 1604 99 1353 1 2 ND2 $T=267840 376880 1 180 $X=265980 $Y=376500
X1836 115 1584 19 1 2 ND2 $T=267840 437360 1 0 $X=267840 $Y=431940
X1837 1482 1610 1408 1 2 ND2 $T=269700 407120 1 0 $X=269700 $Y=401700
X1838 134 1372 138 1 2 ND2 $T=274040 487760 0 0 $X=274040 $Y=487380
X1839 1637 1347 1408 1 2 ND2 $T=275900 437360 1 0 $X=275900 $Y=431940
X1840 1560 1662 55 1 2 ND2 $T=278380 437360 1 180 $X=276520 $Y=436980
X1841 1624 1670 90 1 2 ND2 $T=281480 437360 1 180 $X=279620 $Y=436980
X1842 1491 1681 1380 1 2 ND2 $T=282720 447440 0 180 $X=280860 $Y=442020
X1843 1737 1706 1753 1 2 ND2 $T=296360 376880 0 0 $X=296360 $Y=376500
X1844 1389 1745 1441 1 2 ND2 $T=298220 397040 1 180 $X=296360 $Y=396660
X1845 147 1742 37 1 2 ND2 $T=296360 447440 0 0 $X=296360 $Y=447060
X1846 1622 1698 1626 1 2 ND2 $T=297600 386960 1 0 $X=297600 $Y=381540
X1847 1626 1749 1635 1 2 ND2 $T=298840 397040 1 0 $X=298840 $Y=391620
X1848 1737 1795 1563 1 2 ND2 $T=308760 407120 1 180 $X=306900 $Y=406740
X1849 1715 193 1806 1 2 ND2 $T=308760 497840 1 0 $X=308760 $Y=492420
X1850 1508 1803 1365 1 2 ND2 $T=310000 417200 1 0 $X=310000 $Y=411780
X1851 1701 1827 1618 1 2 ND2 $T=315580 397040 0 180 $X=313720 $Y=391620
X1852 1831 1463 1834 1 2 ND2 $T=315580 447440 1 0 $X=315580 $Y=442020
X1853 1839 1798 1506 1 2 ND2 $T=318060 467600 0 180 $X=316200 $Y=462180
X1854 1834 1352 1838 1 2 ND2 $T=316820 447440 0 0 $X=316820 $Y=447060
X1855 1835 36 1834 1 2 ND2 $T=317440 437360 0 0 $X=317440 $Y=436980
X1856 1835 1491 1846 1 2 ND2 $T=318680 447440 0 0 $X=318680 $Y=447060
X1857 1838 1494 1846 1 2 ND2 $T=319300 457520 1 0 $X=319300 $Y=452100
X1858 1835 16 1854 1 2 ND2 $T=320540 437360 0 0 $X=320540 $Y=436980
X1859 130 1848 190 1 2 ND2 $T=320540 487760 1 0 $X=320540 $Y=482340
X1860 1831 1385 1854 1 2 ND2 $T=321780 447440 1 0 $X=321780 $Y=442020
X1861 1855 8 1838 1 2 ND2 $T=321780 447440 0 0 $X=321780 $Y=447060
X1862 1835 1328 1855 1 2 ND2 $T=322400 457520 1 0 $X=322400 $Y=452100
X1863 1831 1379 1846 1 2 ND2 $T=322400 457520 0 0 $X=322400 $Y=457140
X1864 1864 1800 206 1 2 ND2 $T=323640 447440 0 0 $X=323640 $Y=447060
X1865 1865 109 206 1 2 ND2 $T=323640 487760 1 0 $X=323640 $Y=482340
X1866 1866 1473 209 1 2 ND2 $T=323640 487760 0 0 $X=323640 $Y=487380
X1867 1874 1701 209 1 2 ND2 $T=325500 397040 1 0 $X=325500 $Y=391620
X1868 1874 1738 206 1 2 ND2 $T=325500 407120 0 0 $X=325500 $Y=406740
X1869 1864 19 209 1 2 ND2 $T=325500 437360 0 0 $X=325500 $Y=436980
X1870 1868 10 1834 1 2 ND2 $T=325500 447440 1 0 $X=325500 $Y=442020
X1871 1831 1344 1879 1 2 ND2 $T=325500 457520 1 0 $X=325500 $Y=452100
X1872 1865 190 209 1 2 ND2 $T=325500 477680 0 0 $X=325500 $Y=477300
X1873 1866 1806 206 1 2 ND2 $T=325500 497840 1 0 $X=325500 $Y=492420
X1874 1884 115 206 1 2 ND2 $T=327360 427280 0 0 $X=327360 $Y=426900
X1875 1879 1621 1868 1 2 ND2 $T=327360 447440 0 0 $X=327360 $Y=447060
X1876 1877 20 1880 1 2 ND2 $T=327360 467600 0 0 $X=327360 $Y=467220
X1877 1890 1578 206 1 2 ND2 $T=329220 407120 0 0 $X=329220 $Y=406740
X1878 1794 1896 1766 1 2 ND2 $T=330460 386960 1 0 $X=330460 $Y=381540
X1879 1872 22 1899 1 2 ND2 $T=331700 477680 0 0 $X=331700 $Y=477300
X1880 1898 1563 206 1 2 ND2 $T=332320 407120 1 0 $X=332320 $Y=401700
X1881 1868 1643 1846 1 2 ND2 $T=332320 447440 0 0 $X=332320 $Y=447060
X1882 209 111 1922 1 2 ND2 $T=333560 477680 0 0 $X=333560 $Y=477300
X1883 1909 1635 206 1 2 ND2 $T=334180 407120 0 0 $X=334180 $Y=406740
X1884 1917 1813 220 1 2 ND2 $T=336040 437360 0 0 $X=336040 $Y=436980
X1885 1854 1365 1838 1 2 ND2 $T=337280 447440 1 0 $X=337280 $Y=442020
X1886 1917 1871 225 1 2 ND2 $T=337900 437360 0 0 $X=337900 $Y=436980
X1887 217 1873 1907 1 2 ND2 $T=337900 487760 0 0 $X=337900 $Y=487380
X1888 1909 1737 209 1 2 ND2 $T=339140 417200 1 0 $X=339140 $Y=411780
X1889 221 1911 1933 1 2 ND2 $T=340380 477680 0 0 $X=340380 $Y=477300
X1890 1734 1464 1936 1 2 ND2 $T=341000 407120 0 0 $X=341000 $Y=406740
X1891 1845 1912 1766 1 2 ND2 $T=342860 427280 1 180 $X=341000 $Y=426900
X1892 1931 1875 220 1 2 ND2 $T=341000 437360 0 0 $X=341000 $Y=436980
X1893 1931 1862 225 1 2 ND2 $T=341000 447440 1 0 $X=341000 $Y=442020
X1894 1930 1672 206 1 2 ND2 $T=342860 397040 0 0 $X=342860 $Y=396660
X1895 1946 1900 206 1 2 ND2 $T=344720 457520 1 180 $X=342860 $Y=457140
X1896 63 1607 1952 1 2 ND2 $T=344100 427280 1 0 $X=344100 $Y=421860
X1897 1930 1753 209 1 2 ND2 $T=344720 397040 0 0 $X=344720 $Y=396660
X1898 1918 1786 209 1 2 ND2 $T=344720 407120 1 0 $X=344720 $Y=401700
X1899 1907 1943 232 1 2 ND2 $T=346580 487760 1 0 $X=346580 $Y=482340
X1900 1918 1828 206 1 2 ND2 $T=347820 407120 1 0 $X=347820 $Y=401700
X1901 1876 1985 1982 1 2 ND2 $T=354640 457520 0 0 $X=354640 $Y=457140
X1902 1880 1982 245 1 2 ND2 $T=354640 467600 1 0 $X=354640 $Y=462180
X1903 301 2145 299 1 2 ND2 $T=420980 497840 0 180 $X=419120 $Y=492420
X1904 426 2513 2507 1 2 ND2 $T=535680 336560 1 180 $X=533820 $Y=336180
X1905 426 2508 2514 1 2 ND2 $T=537540 346640 1 0 $X=537540 $Y=341220
X1906 2533 2545 2525 1 2 ND2 $T=539400 407120 1 180 $X=537540 $Y=406740
X1907 2526 2534 2506 1 2 ND2 $T=540640 386960 1 180 $X=538780 $Y=386580
X1908 2526 2543 2505 1 2 ND2 $T=541260 386960 0 180 $X=539400 $Y=381540
X1909 2506 2556 2505 1 2 ND2 $T=546220 386960 0 180 $X=544360 $Y=381540
X1910 2558 2562 2538 1 2 ND2 $T=549320 427280 0 180 $X=547460 $Y=421860
X1911 2564 2598 2554 1 2 ND2 $T=549940 366800 1 0 $X=549940 $Y=361380
X1912 2560 2592 454 1 2 ND2 $T=552420 346640 0 0 $X=552420 $Y=346260
X1913 2560 2601 2587 1 2 ND2 $T=556140 356720 0 180 $X=554280 $Y=351300
X1914 452 2595 2540 1 2 ND2 $T=556140 336560 0 0 $X=556140 $Y=336180
X1915 452 2611 438 1 2 ND2 $T=558000 326480 0 0 $X=558000 $Y=326100
X1916 2559 2616 2597 1 2 ND2 $T=559860 437360 0 180 $X=558000 $Y=431940
X1917 2587 2613 454 1 2 ND2 $T=559240 356720 1 0 $X=559240 $Y=351300
X1918 2629 2696 2660 1 2 ND2 $T=575360 447440 1 0 $X=575360 $Y=442020
X1919 2736 2725 2759 1 2 ND2 $T=581560 397040 1 0 $X=581560 $Y=391620
X1920 2730 2773 2710 1 2 ND2 $T=589000 447440 1 180 $X=587140 $Y=447060
X1921 2781 493 2777 1 2 ND2 $T=592100 346640 1 180 $X=590240 $Y=346260
X1922 2751 2804 498 1 2 ND2 $T=597060 457520 0 0 $X=597060 $Y=457140
X1923 2751 2811 2782 1 2 ND2 $T=597060 467600 1 0 $X=597060 $Y=462180
X1924 498 2818 2782 1 2 ND2 $T=603880 457520 1 0 $X=603880 $Y=452100
X1925 3036 3035 3038 1 2 ND2 $T=651620 407120 1 0 $X=651620 $Y=401700
X1926 3067 3063 3066 1 2 ND2 $T=660300 366800 0 0 $X=660300 $Y=366420
X1927 587 3098 3097 1 2 ND2 $T=670840 336560 1 180 $X=668980 $Y=336180
X1928 3100 3102 3109 1 2 ND2 $T=670220 417200 1 0 $X=670220 $Y=411780
X1929 3117 3114 587 1 2 ND2 $T=672700 336560 1 180 $X=670840 $Y=336180
X1930 3125 3107 3100 1 2 ND2 $T=673940 417200 1 180 $X=672080 $Y=416820
X1931 3123 3119 3111 1 2 ND2 $T=673940 447440 0 180 $X=672080 $Y=442020
X1932 3111 3115 592 1 2 ND2 $T=673940 447440 1 0 $X=673940 $Y=442020
X1933 3123 3121 592 1 2 ND2 $T=673940 447440 0 0 $X=673940 $Y=447060
X1934 3133 3136 3106 1 2 ND2 $T=676420 427280 1 180 $X=674560 $Y=426900
X1935 3117 3108 3097 1 2 ND2 $T=679520 346640 0 180 $X=677660 $Y=341220
X1936 3195 3202 3217 1 2 ND2 $T=702460 427280 1 0 $X=702460 $Y=421860
X1937 3194 3209 3217 1 2 ND2 $T=707420 427280 0 180 $X=705560 $Y=421860
X1938 3248 3278 3262 1 2 ND2 $T=713000 457520 0 180 $X=711140 $Y=452100
X1939 3262 3300 3266 1 2 ND2 $T=718580 447440 0 0 $X=718580 $Y=447060
X1940 3330 3348 3341 1 2 ND2 $T=726640 437360 1 0 $X=726640 $Y=431940
X1941 3346 3354 3341 1 2 ND2 $T=732220 437360 0 180 $X=730360 $Y=431940
X1942 3330 3369 3346 1 2 ND2 $T=734080 437360 1 180 $X=732220 $Y=436980
X1943 3297 3379 3365 1 2 ND2 $T=735320 447440 1 180 $X=733460 $Y=447060
X1944 3297 3391 3359 1 2 ND2 $T=735320 457520 0 180 $X=733460 $Y=452100
X1945 3359 3377 3365 1 2 ND2 $T=735940 447440 0 180 $X=734080 $Y=442020
X1946 3382 3403 3383 1 2 ND2 $T=739040 437360 0 180 $X=737180 $Y=431940
X1947 3392 3393 3383 1 2 ND2 $T=739040 447440 0 180 $X=737180 $Y=442020
X1948 3382 3398 3392 1 2 ND2 $T=744000 437360 0 0 $X=744000 $Y=436980
X1949 3400 3427 3411 1 2 ND2 $T=748960 447440 1 180 $X=747100 $Y=447060
X1950 3425 3436 3430 1 2 ND2 $T=752060 407120 1 180 $X=750200 $Y=406740
X1951 3411 3438 3439 1 2 ND2 $T=750820 447440 0 0 $X=750820 $Y=447060
X1952 3400 3446 3439 1 2 ND2 $T=752680 447440 1 0 $X=752680 $Y=442020
X1953 3395 3450 3425 1 2 ND2 $T=756400 397040 1 180 $X=754540 $Y=396660
X1954 3459 3465 3429 1 2 ND2 $T=756400 447440 0 180 $X=754540 $Y=442020
X1955 3459 3477 3486 1 2 ND2 $T=759500 447440 0 0 $X=759500 $Y=447060
X1956 3422 3480 3460 1 2 ND2 $T=759500 487760 0 0 $X=759500 $Y=487380
X1957 604 3501 445 1 2 ND2 $T=762600 467600 0 180 $X=760740 $Y=462180
X1958 3451 3492 3460 1 2 ND2 $T=761360 487760 0 0 $X=761360 $Y=487380
X1959 3486 3487 3429 1 2 ND2 $T=764460 437360 0 0 $X=764460 $Y=436980
X1960 3553 3564 3554 1 2 ND2 $T=776240 457520 0 180 $X=774380 $Y=452100
X1961 3644 3654 3623 1 2 ND2 $T=797320 467600 1 180 $X=795460 $Y=467220
X1962 3891 3885 765 1 2 ND2 $T=844440 366800 0 180 $X=842580 $Y=361380
X1963 803 3945 801 1 2 ND2 $T=858080 336560 0 180 $X=856220 $Y=331140
X1964 3972 3987 3951 1 2 ND2 $T=866760 457520 1 180 $X=864900 $Y=457140
X1965 3986 3991 3781 1 2 ND2 $T=867380 407120 1 180 $X=865520 $Y=406740
X1966 844 3980 832 1 2 ND2 $T=868620 366800 0 180 $X=866760 $Y=361380
X1967 3993 3968 3987 1 2 ND2 $T=868620 457520 1 180 $X=866760 $Y=457140
X1968 3998 3990 3991 1 2 ND2 $T=869240 407120 1 180 $X=867380 $Y=406740
X1969 835 3905 793 1 2 ND2 $T=870480 346640 1 180 $X=868620 $Y=346260
X1970 3947 3993 3999 1 2 ND2 $T=870480 457520 1 180 $X=868620 $Y=457140
X1971 3971 3998 4003 1 2 ND2 $T=871100 407120 1 180 $X=869240 $Y=406740
X1972 4007 839 4025 1 2 ND2 $T=869860 376880 0 0 $X=869860 $Y=376500
X1973 4009 838 4017 1 2 ND2 $T=870480 356720 0 0 $X=870480 $Y=356340
X1974 4009 832 4025 1 2 ND2 $T=870480 366800 1 0 $X=870480 $Y=361380
X1975 4007 810 4017 1 2 ND2 $T=870480 366800 0 0 $X=870480 $Y=366420
X1976 4005 820 4025 1 2 ND2 $T=870480 386960 1 0 $X=870480 $Y=381540
X1977 4020 4001 4014 1 2 ND2 $T=872340 467600 1 180 $X=870480 $Y=467220
X1978 4010 4020 4023 1 2 ND2 $T=874200 467600 1 180 $X=872340 $Y=467220
X1979 4025 849 4029 1 2 ND2 $T=873580 366800 1 0 $X=873580 $Y=361380
X1980 4038 841 4029 1 2 ND2 $T=875440 366800 1 180 $X=873580 $Y=366420
X1981 4040 4022 3747 1 2 ND2 $T=875440 427280 0 180 $X=873580 $Y=421860
X1982 4005 855 4038 1 2 ND2 $T=874200 376880 1 0 $X=874200 $Y=371460
X1983 4029 837 4017 1 2 ND2 $T=875440 366800 0 0 $X=875440 $Y=366420
X1984 4029 830 4053 1 2 ND2 $T=876680 366800 1 0 $X=876680 $Y=361380
X1985 4007 796 4053 1 2 ND2 $T=876680 376880 1 0 $X=876680 $Y=371460
X1986 4007 862 4038 1 2 ND2 $T=877300 376880 0 0 $X=877300 $Y=376500
X1987 4005 4051 4053 1 2 ND2 $T=877300 386960 1 0 $X=877300 $Y=381540
X1988 223 4056 4028 1 2 ND2 $T=879160 397040 1 180 $X=877300 $Y=396660
X1989 4009 868 4053 1 2 ND2 $T=878540 366800 0 0 $X=878540 $Y=366420
X1990 4009 828 4038 1 2 ND2 $T=879160 376880 1 0 $X=879160 $Y=371460
X1991 4067 866 4038 1 2 ND2 $T=882260 386960 0 180 $X=880400 $Y=381540
X1992 4041 4057 3787 1 2 ND2 $T=880400 467600 0 0 $X=880400 $Y=467220
X1993 4067 856 4053 1 2 ND2 $T=881020 366800 1 0 $X=881020 $Y=361380
X1994 4078 783 4053 1 2 ND2 $T=884120 366800 1 180 $X=882260 $Y=366420
X1995 4038 871 4078 1 2 ND2 $T=882260 376880 1 0 $X=882260 $Y=371460
X1996 4038 872 4079 1 2 ND2 $T=882260 386960 1 0 $X=882260 $Y=381540
X1997 4053 842 4089 1 2 ND2 $T=883500 366800 1 0 $X=883500 $Y=361380
X1998 4067 875 4017 1 2 ND2 $T=884120 366800 0 0 $X=884120 $Y=366420
X1999 4067 879 4025 1 2 ND2 $T=884120 376880 0 0 $X=884120 $Y=376500
X2000 4038 881 4089 1 2 ND2 $T=885980 376880 1 0 $X=885980 $Y=371460
X2001 4017 807 4089 1 2 ND2 $T=889080 366800 1 180 $X=887220 $Y=366420
X2002 4025 885 4089 1 2 ND2 $T=889080 376880 1 180 $X=887220 $Y=376500
X2003 4053 882 4079 1 2 ND2 $T=887220 386960 1 0 $X=887220 $Y=381540
X2004 4078 797 4017 1 2 ND2 $T=889080 376880 1 0 $X=889080 $Y=371460
X2005 4025 877 4078 1 2 ND2 $T=890940 366800 0 0 $X=890940 $Y=366420
X2006 4079 4106 4017 1 2 ND2 $T=892800 376880 1 180 $X=890940 $Y=376500
X2007 4113 4107 4039 1 2 ND2 $T=892800 386960 1 180 $X=890940 $Y=386580
X2008 223 4099 215 1 2 ND2 $T=890940 397040 1 0 $X=890940 $Y=391620
X2009 835 4127 845 1 2 ND2 $T=894660 346640 0 0 $X=894660 $Y=346260
X2010 4136 902 912 1 2 ND2 $T=897140 326480 0 0 $X=897140 $Y=326100
X2011 4138 4118 4126 1 2 ND2 $T=897760 437360 0 0 $X=897760 $Y=436980
X2012 4137 4084 883 1 2 ND2 $T=897760 477680 0 0 $X=897760 $Y=477300
X2013 4165 3962 4179 1 2 ND2 $T=900860 376880 1 0 $X=900860 $Y=371460
X2014 4161 4182 4156 1 2 ND2 $T=904580 457520 1 180 $X=902720 $Y=457140
X2015 4186 4124 854 1 2 ND2 $T=909540 386960 0 180 $X=907680 $Y=381540
X2016 4185 4222 4226 1 2 ND2 $T=911400 366800 1 0 $X=911400 $Y=361380
X2017 4204 845 4190 1 2 ND2 $T=915120 356720 1 180 $X=913260 $Y=356340
X2018 901 4238 845 1 2 ND2 $T=915740 336560 0 0 $X=915740 $Y=336180
X2019 4241 4244 4004 1 2 ND2 $T=915740 427280 1 0 $X=915740 $Y=421860
X2020 4240 894 4154 1 2 ND2 $T=928140 366800 1 0 $X=928140 $Y=361380
X2021 808 4302 4311 1 2 ND2 $T=930000 356720 1 0 $X=930000 $Y=351300
X2022 4317 966 4119 1 2 ND2 $T=931860 356720 1 180 $X=930000 $Y=356340
X2023 4204 3946 4311 1 2 ND2 $T=930000 366800 1 0 $X=930000 $Y=361380
X2024 4304 4318 4299 1 2 ND2 $T=933100 447440 0 180 $X=931240 $Y=442020
X2025 4200 908 4320 1 2 ND2 $T=931860 366800 0 0 $X=931860 $Y=366420
X2026 800 4324 4339 1 2 ND2 $T=934960 346640 0 0 $X=934960 $Y=346260
X2027 4335 4226 4349 1 2 ND2 $T=935580 376880 0 0 $X=935580 $Y=376500
X2028 4204 926 4339 1 2 ND2 $T=938680 346640 0 180 $X=936820 $Y=341220
X2029 4352 980 4154 1 2 ND2 $T=940540 356720 1 180 $X=938680 $Y=356340
X2030 4320 983 4325 1 2 ND2 $T=938680 366800 1 0 $X=938680 $Y=361380
X2031 4346 4357 4004 1 2 ND2 $T=938680 427280 1 0 $X=938680 $Y=421860
X2032 4320 960 4313 1 2 ND2 $T=940540 386960 0 0 $X=940540 $Y=386580
X2033 4103 4260 4106 1 2 ND2 $T=943640 336560 0 0 $X=943640 $Y=336180
X2034 4352 996 4313 1 2 ND2 $T=943640 376880 1 0 $X=943640 $Y=371460
X2035 4313 4188 4252 1 2 ND2 $T=945500 376880 0 0 $X=945500 $Y=376500
X2036 4252 4279 4325 1 2 ND2 $T=947360 386960 0 180 $X=945500 $Y=381540
X2037 4357 3924 4386 1 2 ND2 $T=946120 427280 1 0 $X=946120 $Y=421860
X2038 4204 822 4391 1 2 ND2 $T=949220 366800 1 0 $X=949220 $Y=361380
X2039 4335 4390 4391 1 2 ND2 $T=949220 376880 1 0 $X=949220 $Y=371460
X2040 822 4402 873 1 2 ND2 $T=951080 336560 1 0 $X=951080 $Y=331140
X2041 847 4409 833 1 2 ND2 $T=955420 356720 0 180 $X=953560 $Y=351300
X2042 924 4433 904 1 2 ND2 $T=957280 346640 1 180 $X=955420 $Y=346260
X2043 223 4441 215 1 2 ND2 $T=959140 386960 1 180 $X=957280 $Y=386580
X2044 223 4466 4494 1 2 ND2 $T=967820 407120 1 0 $X=967820 $Y=401700
X2045 1023 4514 1027 1 2 ND2 $T=974640 326480 1 180 $X=972780 $Y=326100
X2046 4468 4531 1004 1 2 ND2 $T=972780 366800 0 0 $X=972780 $Y=366420
X2047 4424 4509 4501 1 2 ND2 $T=974640 376880 0 180 $X=972780 $Y=371460
X2048 1037 1047 1027 1 2 ND2 $T=977740 326480 1 180 $X=975880 $Y=326100
X2049 4479 4530 4527 1 2 ND2 $T=977740 356720 0 180 $X=975880 $Y=351300
X2050 4500 1048 4528 1 2 ND2 $T=977740 386960 0 180 $X=975880 $Y=381540
X2051 4541 4537 4515 1 2 ND2 $T=979600 346640 1 180 $X=977740 $Y=346260
X2052 4479 4548 4515 1 2 ND2 $T=979600 356720 0 180 $X=977740 $Y=351300
X2053 4520 1053 4469 1 2 ND2 $T=979600 366800 1 180 $X=977740 $Y=366420
X2054 4490 1057 4532 1 2 ND2 $T=979600 376880 1 180 $X=977740 $Y=376500
X2055 4520 1059 4532 1 2 ND2 $T=981460 366800 1 180 $X=979600 $Y=366420
X2056 4532 4546 4504 1 2 ND2 $T=979600 376880 1 0 $X=979600 $Y=371460
X2057 4500 1063 4469 1 2 ND2 $T=981460 376880 1 180 $X=979600 $Y=376500
X2058 4469 4540 4504 1 2 ND2 $T=979600 386960 1 0 $X=979600 $Y=381540
X2059 4469 4557 4490 1 2 ND2 $T=981460 386960 1 180 $X=979600 $Y=386580
X2060 4520 1062 4528 1 2 ND2 $T=982700 386960 1 0 $X=982700 $Y=381540
X2061 4570 4564 4584 1 2 ND2 $T=984560 346640 0 0 $X=984560 $Y=346260
X2062 4490 4592 4528 1 2 ND2 $T=986420 386960 1 180 $X=984560 $Y=386580
X2063 4518 1076 4500 1 2 ND2 $T=988280 366800 0 180 $X=986420 $Y=361380
X2064 4550 1069 4500 1 2 ND2 $T=988280 366800 1 180 $X=986420 $Y=366420
X2065 1050 4591 1069 1 2 ND2 $T=986420 376880 1 0 $X=986420 $Y=371460
X2066 4500 1067 4551 1 2 ND2 $T=988280 376880 1 180 $X=986420 $Y=376500
X2067 4583 4582 4490 1 2 ND2 $T=988280 397040 1 180 $X=986420 $Y=396660
X2068 4444 1073 1060 1 2 ND2 $T=990140 336560 1 180 $X=988280 $Y=336180
X2069 4583 4590 4504 1 2 ND2 $T=990760 386960 0 180 $X=988900 $Y=381540
X2070 4504 1078 4528 1 2 ND2 $T=991380 386960 1 180 $X=989520 $Y=386580
X2071 4577 4614 4530 1 2 ND2 $T=992000 376880 0 180 $X=990140 $Y=371460
X2072 4583 1083 4520 1 2 ND2 $T=993240 366800 1 180 $X=991380 $Y=366420
X2073 4583 1084 4500 1 2 ND2 $T=993240 386960 0 180 $X=991380 $Y=381540
X2074 4518 1087 4520 1 2 ND2 $T=993860 366800 0 180 $X=992000 $Y=361380
X2075 4493 1096 4500 1 2 ND2 $T=995720 386960 1 180 $X=993860 $Y=386580
X2076 4493 1092 4520 1 2 ND2 $T=996960 366800 1 180 $X=995100 $Y=366420
X2077 4520 1091 4551 1 2 ND2 $T=996960 376880 1 180 $X=995100 $Y=376500
X2078 4493 4636 4490 1 2 ND2 $T=998200 386960 1 180 $X=996340 $Y=386580
X2079 4550 1085 4520 1 2 ND2 $T=998820 376880 0 180 $X=996960 $Y=371460
X2080 4541 4642 4483 1 2 ND2 $T=1000060 346640 0 180 $X=998200 $Y=341220
X2081 4518 4655 4504 1 2 ND2 $T=1000060 366800 1 180 $X=998200 $Y=366420
X2082 4541 1110 4644 1 2 ND2 $T=1000680 326480 1 180 $X=998820 $Y=326100
X2083 4518 4633 4490 1 2 ND2 $T=998820 386960 0 0 $X=998820 $Y=386580
X2084 4541 4649 4523 1 2 ND2 $T=1000060 346640 1 0 $X=1000060 $Y=341220
X2085 4550 4654 4504 1 2 ND2 $T=1001920 376880 0 180 $X=1000060 $Y=371460
X2086 4551 4666 4504 1 2 ND2 $T=1001920 386960 0 180 $X=1000060 $Y=381540
X2087 4674 4673 4644 1 2 ND2 $T=1003780 326480 1 180 $X=1001920 $Y=326100
X2088 4550 4710 4490 1 2 ND2 $T=1003780 366800 1 180 $X=1001920 $Y=366420
X2089 4551 4667 4490 1 2 ND2 $T=1003780 386960 1 180 $X=1001920 $Y=386580
X2090 4675 4662 4625 1 2 ND2 $T=1003780 397040 1 180 $X=1001920 $Y=396660
X2091 4685 4678 4523 1 2 ND2 $T=1005020 346640 0 180 $X=1003160 $Y=341220
X2092 4656 4684 4292 1 2 ND2 $T=1003780 467600 1 0 $X=1003780 $Y=462180
X2093 4676 4699 4305 1 2 ND2 $T=1005640 467600 1 0 $X=1005640 $Y=462180
X2094 4698 4694 4642 1 2 ND2 $T=1006880 366800 1 0 $X=1006880 $Y=361380
X2095 4698 4687 1120 1 2 ND2 $T=1006880 376880 0 0 $X=1006880 $Y=376500
X2096 4596 4738 1124 1 2 ND2 $T=1019900 336560 0 180 $X=1018040 $Y=331140
X2097 4782 4724 4784 1 2 ND2 $T=1023000 366800 1 0 $X=1023000 $Y=361380
X2098 4744 4791 4546 1 2 ND2 $T=1026100 366800 1 180 $X=1024240 $Y=366420
X2099 4823 4805 4642 1 2 ND2 $T=1030440 376880 1 0 $X=1030440 $Y=371460
X2100 1158 4808 1183 1 2 ND2 $T=1036020 326480 0 0 $X=1036020 $Y=326100
X2101 4569 1195 1136 1 2 ND2 $T=1040980 336560 1 180 $X=1039120 $Y=336180
X2102 4833 4875 4631 1 2 ND2 $T=1039120 376880 1 0 $X=1039120 $Y=371460
X2103 4851 4905 979 1 2 ND2 $T=1045320 477680 1 180 $X=1043460 $Y=477300
X2104 4730 4916 4305 1 2 ND2 $T=1045940 467600 0 180 $X=1044080 $Y=462180
X2105 4923 4929 4174 1 2 ND2 $T=1047800 467600 0 180 $X=1045940 $Y=462180
X2106 4929 1219 4916 1 2 ND2 $T=1051520 467600 0 180 $X=1049660 $Y=462180
X2107 4959 4883 1229 1 2 ND2 $T=1054620 386960 1 0 $X=1054620 $Y=381540
X2108 4657 4906 4969 1 2 ND2 $T=1055240 356720 1 0 $X=1055240 $Y=351300
X2109 4909 4942 4968 1 2 ND2 $T=1055240 397040 0 0 $X=1055240 $Y=396660
X2110 4951 4974 4970 1 2 ND2 $T=1055240 477680 0 0 $X=1055240 $Y=477300
X2111 4970 4987 4943 1 2 ND2 $T=1058960 477680 0 0 $X=1058960 $Y=477300
X2112 4620 4973 4629 1 2 ND2 $T=1059580 407120 1 0 $X=1059580 $Y=401700
X2113 1111 4996 1063 1 2 ND2 $T=1064540 376880 1 0 $X=1064540 $Y=371460
X2114 4890 5005 4305 1 2 ND2 $T=1067020 457520 0 180 $X=1065160 $Y=452100
X2115 4995 5018 5005 1 2 ND2 $T=1068880 457520 0 180 $X=1067020 $Y=452100
X2116 5025 5022 4174 1 2 ND2 $T=1072600 457520 0 180 $X=1070740 $Y=452100
X2117 1124 4732 4685 1 2 ND2 $T=1074460 346640 0 180 $X=1072600 $Y=341220
X2118 4936 5035 4305 1 2 ND2 $T=1074460 457520 0 180 $X=1072600 $Y=452100
X2119 5044 5069 5058 1 2 ND2 $T=1083760 487760 0 180 $X=1081900 $Y=482340
X2120 4537 5079 1209 1 2 ND2 $T=1087480 366800 0 0 $X=1087480 $Y=366420
X2121 4537 1289 4642 1 2 ND2 $T=1090580 336560 0 0 $X=1090580 $Y=336180
X2122 4811 5091 4924 1 2 ND2 $T=1092440 407120 1 0 $X=1092440 $Y=401700
X2123 2557 2568 2561 2545 1 2 ND3P $T=546220 407120 0 0 $X=546220 $Y=406740
X2124 2571 2589 2552 2562 1 2 ND3P $T=549940 427280 1 0 $X=549940 $Y=421860
X2125 2592 2617 2601 2613 1 2 ND3P $T=555520 346640 0 0 $X=555520 $Y=346260
X2126 2596 2635 2608 2616 1 2 ND3P $T=556760 437360 0 0 $X=556760 $Y=436980
X2127 2758 2751 2740 2773 1 2 ND3P $T=595200 447440 1 180 $X=590240 $Y=447060
X2128 2811 2822 2804 2818 1 2 ND3P $T=597060 457520 1 0 $X=597060 $Y=452100
X2129 3107 3124 3102 3120 1 2 ND3P $T=668980 407120 0 0 $X=668980 $Y=406740
X2130 3121 3152 3119 3115 1 2 ND3P $T=677040 437360 0 0 $X=677040 $Y=436980
X2131 3202 3203 3204 3209 1 2 ND3P $T=696260 427280 1 0 $X=696260 $Y=421860
X2132 3278 3297 3284 3300 1 2 ND3P $T=715480 457520 1 0 $X=715480 $Y=452100
X2133 3369 3382 3348 3354 1 2 ND3P $T=732220 437360 1 0 $X=732220 $Y=431940
X2134 3391 3400 3379 3377 1 2 ND3P $T=737180 447440 0 0 $X=737180 $Y=447060
X2135 3450 3432 3441 3436 1 2 ND3P $T=757640 407120 1 180 $X=752680 $Y=406740
X2136 3446 3459 3427 3438 1 2 ND3P $T=753300 447440 0 0 $X=753300 $Y=447060
X2137 3477 3458 3465 3487 1 2 ND3P $T=757640 447440 1 0 $X=757640 $Y=442020
X2138 4974 5002 4987 4957 1 2 ND3P $T=1060820 477680 0 0 $X=1060820 $Y=477300
X2139 5084 1284 5082 5069 1 2 ND3P $T=1088720 487760 1 0 $X=1088720 $Y=482340
X2140 2509 2497 2500 2526 1 2 MAO222P $T=531960 366800 1 0 $X=531960 $Y=361380
X2141 432 2495 2547 2524 1 2 MAO222P $T=546840 356720 1 180 $X=541260 $Y=356340
X2142 2524 2527 2520 2515 1 2 MAO222P $T=541880 366800 1 0 $X=541880 $Y=361380
X2143 2515 2550 2535 2516 1 2 MAO222P $T=545600 397040 0 0 $X=545600 $Y=396660
X2144 2530 2569 446 2560 1 2 MAO222P $T=558000 346640 0 180 $X=552420 $Y=341220
X2145 2568 2577 2585 2654 1 2 MAO222P $T=561100 427280 1 0 $X=561100 $Y=421860
X2146 2822 2809 2848 2885 1 2 MAO222P $T=606980 457520 1 0 $X=606980 $Y=452100
X2147 2885 2860 529 2886 1 2 MAO222P $T=620000 457520 0 180 $X=614420 $Y=452100
X2148 2886 2913 530 2929 1 2 MAO222P $T=620620 457520 1 0 $X=620620 $Y=452100
X2149 2929 2935 553 3010 1 2 MAO222P $T=638600 457520 0 0 $X=638600 $Y=457140
X2150 3010 2965 558 3041 1 2 MAO222P $T=646040 457520 0 0 $X=646040 $Y=457140
X2151 3041 3021 576 3084 1 2 MAO222P $T=658440 457520 1 0 $X=658440 $Y=452100
X2152 3084 3091 584 3123 1 2 MAO222P $T=665260 447440 0 0 $X=665260 $Y=447060
X2153 3141 3165 3162 3158 1 2 MAO222P $T=689440 376880 0 180 $X=683860 $Y=371460
X2154 3158 3174 3180 3161 1 2 MAO222P $T=692540 397040 0 180 $X=686960 $Y=391620
X2155 597 3178 3168 3172 1 2 MAO222P $T=691920 336560 0 0 $X=691920 $Y=336180
X2156 3161 3196 3190 3195 1 2 MAO222P $T=695640 407120 0 0 $X=695640 $Y=406740
X2157 3172 3206 3201 3141 1 2 MAO222P $T=702460 356720 0 180 $X=696880 $Y=351300
X2158 3203 3258 3240 3248 1 2 MAO222P $T=709900 447440 1 0 $X=709900 $Y=442020
X2159 3306 3313 3314 3330 1 2 MAO222P $T=721060 437360 1 0 $X=721060 $Y=431940
X2160 3405 3413 3406 3399 1 2 MAO222P $T=747100 346640 1 180 $X=741520 $Y=346260
X2161 3399 3428 3434 3420 1 2 MAO222P $T=752060 366800 0 180 $X=746480 $Y=361380
X2162 3420 3431 3440 3375 1 2 MAO222P $T=752680 386960 0 180 $X=747100 $Y=381540
X2163 3415 3433 3426 3405 1 2 MAO222P $T=753300 346640 1 180 $X=747720 $Y=346260
X2164 671 3435 3437 3415 1 2 MAO222P $T=753920 326480 1 180 $X=748340 $Y=326100
X2165 3375 3423 3408 3395 1 2 MAO222P $T=748340 397040 1 0 $X=748340 $Y=391620
X2166 3458 3476 3498 3541 1 2 MAO222P $T=759500 427280 0 0 $X=759500 $Y=426900
X2167 3432 3479 3473 3531 1 2 MAO222P $T=764460 417200 1 0 $X=764460 $Y=411780
X2168 3520 3522 3561 3422 1 2 MAO222P $T=770040 487760 0 180 $X=764460 $Y=482340
X2169 3531 3552 3548 3527 1 2 MAO222P $T=776240 417200 0 180 $X=770660 $Y=411780
X2170 3527 3538 3560 3563 1 2 MAO222P $T=773140 427280 1 0 $X=773140 $Y=421860
X2171 3563 3597 3635 3580 1 2 MAO222P $T=797940 427280 0 180 $X=792360 $Y=421860
X2172 4888 4834 4843 4951 1 2 MAO222P $T=1048420 467600 0 0 $X=1048420 $Y=467220
X2173 5002 5018 5019 5076 1 2 MAO222P $T=1079420 477680 0 0 $X=1079420 $Y=477300
X2174 2538 1 2516 2552 2 ND2P $T=546220 427280 0 180 $X=542500 $Y=421860
X2175 2533 1 2537 2557 2 ND2P $T=548080 417200 0 180 $X=544360 $Y=411780
X2176 2558 1 2516 2571 2 ND2P $T=549320 427280 1 180 $X=545600 $Y=426900
X2177 2559 1 2589 2608 2 ND2P $T=559860 427280 1 180 $X=556140 $Y=426900
X2178 2598 1 2579 459 2 ND2P $T=558620 376880 0 0 $X=558620 $Y=376500
X2179 2629 1 2635 2643 2 ND2P $T=566060 447440 0 180 $X=562340 $Y=442020
X2180 2710 1 2673 2758 2 ND2P $T=586520 447440 1 180 $X=582800 $Y=447060
X2181 2777 1 2753 496 2 ND2P $T=596440 356720 0 180 $X=592720 $Y=351300
X2182 3109 1 3125 3120 2 ND2P $T=673940 417200 0 0 $X=673940 $Y=416820
X2183 3133 1 3152 3149 2 ND2P $T=685720 427280 0 0 $X=685720 $Y=426900
X2184 3194 1 3195 3204 2 ND2P $T=696260 417200 0 0 $X=696260 $Y=416820
X2185 3266 1 3248 3284 2 ND2P $T=714860 447440 0 0 $X=714860 $Y=447060
X2186 3430 1 3395 3441 2 ND2P $T=750820 397040 0 0 $X=750820 $Y=396660
X2187 3451 1 3422 3475 2 ND2P $T=759500 497840 1 0 $X=759500 $Y=492420
X2188 4313 1 4240 967 2 ND2P $T=931860 376880 1 0 $X=931860 $Y=371460
X2189 4699 1 4684 1122 2 ND2P $T=1007500 467600 1 0 $X=1007500 $Y=462180
X2190 4447 1 4703 1125 2 ND2P $T=1012460 487760 1 180 $X=1008740 $Y=487380
X2191 4387 1 4682 4746 2 ND2P $T=1015560 437360 0 180 $X=1011840 $Y=431940
X2192 4387 1 4692 4736 2 ND2P $T=1015560 437360 1 180 $X=1011840 $Y=436980
X2193 1161 1 4827 4804 2 ND2P $T=1030440 477680 0 0 $X=1030440 $Y=477300
X2194 4863 1 4832 4868 2 ND2P $T=1036020 437360 0 0 $X=1036020 $Y=436980
X2195 913 1 4910 4902 2 ND2P $T=1046560 487760 0 180 $X=1042840 $Y=482340
X2196 4905 1 4902 4834 2 ND2P $T=1050280 487760 0 180 $X=1046560 $Y=482340
X2197 4943 1 4951 4957 2 ND2P $T=1051520 477680 0 0 $X=1051520 $Y=477300
X2198 5035 1 5022 5044 2 ND2P $T=1078180 457520 0 180 $X=1074460 $Y=452100
X2199 5044 1 5076 5082 2 ND2P $T=1088720 477680 1 180 $X=1085000 $Y=477300
X2200 5058 1 5076 5084 2 ND2P $T=1088720 487760 0 180 $X=1085000 $Y=482340
X2201 2525 1 2537 2561 2 ND2T $T=552420 407120 0 0 $X=552420 $Y=406740
X2202 2684 1 2711 2555 2 ND2T $T=581560 376880 1 180 $X=576600 $Y=376500
X2203 2730 1 2673 2740 2 ND2T $T=577840 447440 0 0 $X=577840 $Y=447060
X2204 2497 2500 2509 2 1 2494 XNR3 $T=528860 356720 0 0 $X=528860 $Y=356340
X2205 2506 2505 2526 2 1 2502 XNR3 $T=531340 366800 0 0 $X=531340 $Y=366420
X2206 2507 2514 426 2 1 2510 XNR3 $T=533200 336560 1 0 $X=533200 $Y=331140
X2207 2569 446 2530 2 1 2529 XNR3 $T=550560 346640 0 180 $X=539400 $Y=341220
X2208 2525 2533 2537 2 1 2582 XNR3 $T=540020 407120 1 0 $X=540020 $Y=401700
X2209 2540 438 452 2 1 2532 XNR3 $T=543120 336560 0 0 $X=543120 $Y=336180
X2210 2577 2585 2568 2 1 2565 XNR3 $T=551800 417200 0 0 $X=551800 $Y=416820
X2211 2686 2670 2654 2 1 2621 XNR3 $T=579080 427280 0 180 $X=567920 $Y=421860
X2212 2671 2681 2705 2 1 2663 XNR3 $T=570400 437360 0 0 $X=570400 $Y=436980
X2213 2719 477 2714 2 1 2708 XNR3 $T=577840 356720 0 0 $X=577840 $Y=356340
X2214 2737 2743 2739 2 1 2727 XNR3 $T=581560 447440 1 0 $X=581560 $Y=442020
X2215 2868 2874 2866 2 1 2857 XNR3 $T=611320 447440 1 0 $X=611320 $Y=442020
X2216 2931 2941 2943 2 1 2932 XNR3 $T=628680 457520 1 0 $X=628680 $Y=452100
X2217 2969 2976 2970 2 1 2964 XNR3 $T=635500 437360 0 0 $X=635500 $Y=436980
X2218 2958 3001 3000 2 1 2997 XNR3 $T=641700 447440 0 0 $X=641700 $Y=447060
X2219 3242 3236 3188 2 1 3189 XNR3 $T=706800 397040 0 180 $X=695640 $Y=391620
X2220 3433 3426 3415 2 1 3317 XNR3 $T=755160 346640 0 180 $X=744000 $Y=341220
X2221 3428 3434 3399 2 1 3404 XNR3 $T=755160 376880 0 180 $X=744000 $Y=371460
X2222 3435 3437 671 2 1 3256 XNR3 $T=757020 336560 0 180 $X=745860 $Y=331140
X2223 3431 3440 3420 2 1 3421 XNR3 $T=758260 386960 1 180 $X=747100 $Y=386580
X2224 4198 4194 4170 2 1 945 XNR3 $T=907060 457520 0 0 $X=907060 $Y=457140
X2225 4229 4237 4245 2 1 958 XNR3 $T=913880 487760 0 0 $X=913880 $Y=487380
X2226 4280 4289 4295 2 1 4273 XNR3 $T=924420 487760 1 0 $X=924420 $Y=482340
X2227 4834 4843 4888 2 1 4894 XNR3 $T=1031680 477680 1 0 $X=1031680 $Y=472260
X2228 4970 4943 4951 2 1 4966 XNR3 $T=1057720 477680 1 0 $X=1057720 $Y=472260
X2229 209 206 1 2 INV2 $T=344100 497840 1 0 $X=344100 $Y=492420
X2230 2442 413 1 2 INV2 $T=518320 386960 0 0 $X=518320 $Y=386580
X2231 2494 2495 1 2 INV2 $T=527000 356720 0 0 $X=527000 $Y=356340
X2232 2488 421 1 2 INV2 $T=527000 407120 1 0 $X=527000 $Y=401700
X2233 2502 2520 1 2 INV2 $T=531340 376880 0 0 $X=531340 $Y=376500
X2234 2510 427 1 2 INV2 $T=533200 326480 0 0 $X=533200 $Y=326100
X2235 2519 2514 1 2 INV2 $T=535680 346640 1 0 $X=535680 $Y=341220
X2236 2503 429 1 2 INV2 $T=537540 437360 0 0 $X=537540 $Y=436980
X2237 433 2527 1 2 INV2 $T=540640 366800 0 180 $X=538780 $Y=361380
X2238 2501 443 1 2 INV2 $T=540640 467600 1 0 $X=540640 $Y=462180
X2239 2532 2535 1 2 INV2 $T=541260 336560 0 0 $X=541260 $Y=336180
X2240 2529 2538 1 2 INV2 $T=544360 376880 0 0 $X=544360 $Y=376500
X2241 449 2547 1 2 INV2 $T=548080 326480 1 180 $X=546220 $Y=326100
X2242 2553 442 1 2 INV2 $T=547460 437360 0 0 $X=547460 $Y=436980
X2243 2565 2558 1 2 INV2 $T=549940 417200 0 0 $X=549940 $Y=416820
X2244 2582 2550 1 2 INV2 $T=552420 397040 0 0 $X=552420 $Y=396660
X2245 2615 2587 1 2 INV2 $T=559860 356720 0 0 $X=559860 $Y=356340
X2246 2621 2597 1 2 INV2 $T=561720 427280 1 180 $X=559860 $Y=426900
X2247 2604 460 1 2 INV2 $T=561100 457520 0 0 $X=561100 $Y=457140
X2248 2650 2607 1 2 INV2 $T=566680 356720 1 0 $X=566680 $Y=351300
X2249 2544 468 1 2 INV2 $T=567300 467600 1 0 $X=567300 $Y=462180
X2250 2663 2660 1 2 INV2 $T=568540 437360 0 0 $X=568540 $Y=436980
X2251 2665 2661 1 2 INV2 $T=569160 366800 0 0 $X=569160 $Y=366420
X2252 2676 2612 1 2 INV2 $T=571020 407120 0 0 $X=571020 $Y=406740
X2253 2695 2668 1 2 INV2 $T=574120 366800 0 0 $X=574120 $Y=366420
X2254 2708 2710 1 2 INV2 $T=575980 356720 0 0 $X=575980 $Y=356340
X2255 2687 2684 1 2 INV2 $T=578460 386960 1 180 $X=576600 $Y=386580
X2256 2725 2690 1 2 INV2 $T=579700 386960 1 0 $X=579700 $Y=381540
X2257 2727 2730 1 2 INV2 $T=579700 447440 1 0 $X=579700 $Y=442020
X2258 2493 2695 1 2 INV2 $T=589620 386960 0 0 $X=589620 $Y=386580
X2259 2769 500 1 2 INV2 $T=590240 477680 0 0 $X=590240 $Y=477300
X2260 495 417 1 2 INV2 $T=598920 467600 0 0 $X=598920 $Y=467220
X2261 506 2551 1 2 INV2 $T=605740 427280 0 180 $X=603880 $Y=421860
X2262 512 2848 1 2 INV2 $T=609460 376880 0 180 $X=607600 $Y=371460
X2263 2819 511 1 2 INV2 $T=607600 487760 0 0 $X=607600 $Y=487380
X2264 2857 2860 1 2 INV2 $T=609460 447440 1 0 $X=609460 $Y=442020
X2265 2882 520 1 2 INV2 $T=614420 497840 0 180 $X=612560 $Y=492420
X2266 2932 2935 1 2 INV2 $T=626820 457520 1 0 $X=626820 $Y=452100
X2267 2964 2965 1 2 INV2 $T=633640 437360 0 0 $X=633640 $Y=436980
X2268 2997 3021 1 2 INV2 $T=641700 457520 1 0 $X=641700 $Y=452100
X2269 497 2777 1 2 INV2 $T=642940 366800 1 0 $X=642940 $Y=361380
X2270 3051 3096 1 2 INV2 $T=665260 386960 0 0 $X=665260 $Y=386580
X2271 594 395 1 2 INV2 $T=678280 407120 1 180 $X=676420 $Y=406740
X2272 615 3127 1 2 INV2 $T=706180 497840 1 0 $X=706180 $Y=492420
X2273 655 660 1 2 INV2 $T=742140 497840 1 0 $X=742140 $Y=492420
X2274 594 684 1 2 INV2 $T=769420 417200 0 0 $X=769420 $Y=416820
X2275 497 705 1 2 INV2 $T=783060 326480 0 0 $X=783060 $Y=326100
X2276 3904 3787 1 2 INV2 $T=873580 477680 1 180 $X=871720 $Y=477300
X2277 4097 4129 1 2 INV2 $T=893420 467600 1 0 $X=893420 $Y=462180
X2278 4100 4195 1 2 INV2 $T=911400 477680 1 0 $X=911400 $Y=472260
X2279 4174 3524 1 2 INV2 $T=919460 447440 0 0 $X=919460 $Y=447060
X2280 4273 953 1 2 INV2 $T=922560 487760 1 0 $X=922560 $Y=482340
X2281 3781 4003 1 2 INV2 $T=980840 417200 1 180 $X=978980 $Y=416820
X2282 4567 4562 1 2 INV2 $T=983940 487760 1 0 $X=983940 $Y=482340
X2283 3904 3967 1 2 INV2 $T=996340 417200 0 180 $X=994480 $Y=411780
X2284 4174 4305 1 2 INV2 $T=1013700 477680 1 0 $X=1013700 $Y=472260
X2285 4737 4756 1 2 INV2 $T=1017420 487760 0 0 $X=1017420 $Y=487380
X2286 4683 1182 1 2 INV2 $T=1029820 497840 1 0 $X=1029820 $Y=492420
X2287 1197 1199 1 2 INV2 $T=1041600 437360 1 0 $X=1041600 $Y=431940
X2288 1197 1202 1 2 INV2 $T=1044080 437360 1 0 $X=1044080 $Y=431940
X2289 4894 1208 1 2 INV2 $T=1045320 477680 0 0 $X=1045320 $Y=477300
X2290 4892 4941 1 2 INV2 $T=1045940 437360 0 0 $X=1045940 $Y=436980
X2291 4886 4940 1 2 INV2 $T=1049660 447440 1 0 $X=1049660 $Y=442020
X2292 4966 1217 1 2 INV2 $T=1055860 477680 1 0 $X=1055860 $Y=472260
X2293 4975 4943 1 2 INV2 $T=1057720 487760 1 0 $X=1057720 $Y=482340
X2294 4912 4981 1 2 INV2 $T=1058340 437360 0 0 $X=1058340 $Y=436980
X2295 4829 5027 1 2 INV2 $T=1071360 487760 0 0 $X=1071360 $Y=487380
X2296 4936 5051 1 2 INV2 $T=1078800 447440 0 0 $X=1078800 $Y=447060
X2297 2482 412 2493 2499 1 2 MXL2H $T=520180 366800 0 0 $X=520180 $Y=366420
X2298 2677 2687 2676 2724 1 2 MXL2H $T=571020 477680 1 0 $X=571020 $Y=472260
X2299 4719 3904 4734 4663 1 2 MXL2H $T=1016800 487760 1 0 $X=1016800 $Y=482340
X2300 2606 2 2581 2588 1 AN2B1S $T=556760 386960 1 0 $X=556760 $Y=381540
X2301 461 2 2622 2642 1 AN2B1S $T=561720 346640 0 0 $X=561720 $Y=346260
X2302 2757 2 2555 2736 1 AN2B1S $T=588380 397040 0 0 $X=588380 $Y=396660
X2303 3747 2 4118 4143 1 AN2B1S $T=897760 417200 1 0 $X=897760 $Y=411780
X2304 4197 2 4139 4232 1 AN2B1S $T=907680 427280 1 0 $X=907680 $Y=421860
X2305 4051 2 851 965 1 AN2B1S $T=931860 336560 0 180 $X=928760 $Y=331140
X2306 4636 2 4658 5061 1 AN2B1S $T=1081280 356720 1 0 $X=1081280 $Y=351300
X2307 2591 2600 1 2606 2 AN2S $T=555520 376880 0 0 $X=555520 $Y=376500
X2308 4126 3869 1 4116 2 AN2S $T=895900 447440 1 0 $X=895900 $Y=442020
X2309 4930 4897 1 4947 2 AN2S $T=1050900 487760 0 0 $X=1050900 $Y=487380
X2310 2780 406 1 2 BUF2CK $T=590240 497840 0 180 $X=587140 $Y=492420
X2311 347 263 1 2 INV12CK $T=459420 386960 0 0 $X=459420 $Y=386580
X2312 607 385 1 2 INV12CK $T=693160 417200 0 180 $X=683240 $Y=411780
X2313 37 125 1457 1353 1347 1604 1 2 1549 AO222 $T=273420 397040 1 180 $X=267220 $Y=396660
X2314 222 1956 63 1961 1963 1953 1 2 1947 AO222 $T=345340 477680 1 0 $X=345340 $Y=472260
X2315 1987 262 264 2007 2022 268 1 2 2039 AO222 $T=370140 397040 1 0 $X=370140 $Y=391620
X2316 2012 262 265 2024 2009 268 1 2 2046 AO222 $T=371380 417200 1 0 $X=371380 $Y=411780
X2317 2004 262 265 2033 2034 268 1 2 2050 AO222 $T=373240 427280 1 0 $X=373240 $Y=421860
X2318 2014 262 265 2035 2041 268 1 2 2055 AO222 $T=375100 447440 1 0 $X=375100 $Y=442020
X2319 2019 262 264 2015 2027 268 1 2 2056 AO222 $T=375100 477680 1 0 $X=375100 $Y=472260
X2320 1998 262 265 2023 2032 268 1 2 2052 AO222 $T=376340 407120 1 0 $X=376340 $Y=401700
X2321 2020 262 264 2042 2048 268 1 2 2062 AO222 $T=376960 487760 0 0 $X=376960 $Y=487380
X2322 2001 262 265 2049 2036 268 1 2 2066 AO222 $T=378200 417200 0 0 $X=378200 $Y=416820
X2323 2025 262 265 2067 2069 268 1 2 2074 AO222 $T=383160 457520 0 0 $X=383160 $Y=457140
X2324 2061 262 265 2068 2072 268 1 2 2075 AO222 $T=383780 447440 1 0 $X=383780 $Y=442020
X2325 2129 262 265 2126 2137 268 1 2 2148 AO222 $T=411680 487760 0 0 $X=411680 $Y=487380
X2326 2132 262 265 2136 2138 268 1 2 2165 AO222 $T=412300 417200 1 0 $X=412300 $Y=411780
X2327 2135 262 264 2128 2141 268 1 2 2149 AO222 $T=412920 457520 0 0 $X=412920 $Y=457140
X2328 2127 262 265 2131 2142 268 1 2 2150 AO222 $T=412920 477680 0 0 $X=412920 $Y=477300
X2329 2133 262 264 2134 2139 268 1 2 2156 AO222 $T=414780 457520 1 0 $X=414780 $Y=452100
X2330 2130 262 264 2144 2146 268 1 2 2187 AO222 $T=415400 397040 1 0 $X=415400 $Y=391620
X2331 2143 262 264 2147 2155 268 1 2 2176 AO222 $T=419740 407120 1 0 $X=419740 $Y=401700
X2332 2140 262 264 2125 2158 268 1 2 2190 AO222 $T=424080 437360 1 0 $X=424080 $Y=431940
X2333 2152 262 265 2124 2161 268 1 2 2196 AO222 $T=424700 427280 1 0 $X=424700 $Y=421860
X2334 353 349 348 2239 2281 345 1 2 2180 AO222 $T=462520 336560 0 180 $X=456320 $Y=331140
X2335 2314 349 348 2290 2295 345 1 2 2250 AO222 $T=465000 356720 0 180 $X=458800 $Y=351300
X2336 2342 349 348 2325 2321 345 1 2 2318 AO222 $T=469960 356720 1 180 $X=463760 $Y=356340
X2337 2413 349 387 2374 2358 345 1 2 2373 AO222 $T=494760 336560 1 180 $X=488560 $Y=336180
X2338 2470 349 348 2454 2463 345 1 2 2452 AO222 $T=515220 356720 0 180 $X=509020 $Y=351300
X2339 2475 349 387 2467 407 345 1 2 2460 AO222 $T=517700 336560 0 180 $X=511500 $Y=331140
X2340 2474 349 387 2472 2468 345 1 2 2449 AO222 $T=518940 346640 0 180 $X=512740 $Y=341220
X2341 7 1 1355 1341 2 1351 ND3 $T=221960 487760 0 0 $X=221960 $Y=487380
X2342 1323 1 1371 21 2 1384 ND3 $T=226920 447440 0 0 $X=226920 $Y=447060
X2343 1424 1 1411 1373 2 1407 ND3 $T=235600 386960 1 180 $X=233120 $Y=386580
X2344 1378 1 48 1359 2 49 ND3 $T=236220 497840 1 0 $X=236220 $Y=492420
X2345 1434 1 1344 1432 2 1437 ND3 $T=238080 386960 0 0 $X=238080 $Y=386580
X2346 1458 1 1435 1459 2 1430 ND3 $T=241800 407120 1 180 $X=239320 $Y=406740
X2347 1410 1 1461 1444 2 1474 ND3 $T=243040 427280 0 0 $X=243040 $Y=426900
X2348 65 1 1475 69 2 1489 ND3 $T=244900 497840 1 0 $X=244900 $Y=492420
X2349 1492 1 1469 1478 2 1481 ND3 $T=248620 397040 0 180 $X=246140 $Y=391620
X2350 1489 1 58 1471 2 1475 ND3 $T=248620 487760 0 180 $X=246140 $Y=482340
X2351 1412 1 1464 1504 2 43 ND3 $T=246760 417200 1 0 $X=246760 $Y=411780
X2352 1387 1 1426 1487 2 1453 ND3 $T=246760 417200 0 0 $X=246760 $Y=416820
X2353 76 1 79 1510 2 1501 ND3 $T=249240 477680 0 0 $X=249240 $Y=477300
X2354 1528 1 1453 1337 2 1412 ND3 $T=254200 417200 1 180 $X=251720 $Y=416820
X2355 1515 1 1517 1532 2 1431 ND3 $T=251720 447440 0 0 $X=251720 $Y=447060
X2356 1531 1 1496 87 2 1513 ND3 $T=255440 487760 0 180 $X=252960 $Y=482340
X2357 1552 1 1530 1544 2 1398 ND3 $T=259160 437360 0 180 $X=256680 $Y=431940
X2358 1505 1 1564 1565 2 1588 ND3 $T=259780 447440 0 0 $X=259780 $Y=447060
X2359 1567 1 1580 106 2 1590 ND3 $T=261640 467600 0 0 $X=261640 $Y=467220
X2360 1545 1 1452 1582 2 1505 ND3 $T=264740 457520 1 180 $X=262260 $Y=457140
X2361 1420 1 1611 1613 2 1609 ND3 $T=267840 437360 0 0 $X=267840 $Y=436980
X2362 140 1 48 139 2 1473 ND3 $T=277760 497840 0 180 $X=275280 $Y=492420
X2363 1657 1 99 1654 2 1443 ND3 $T=278380 386960 0 180 $X=275900 $Y=381540
X2364 1651 1 1646 1649 2 1615 ND3 $T=278380 457520 0 180 $X=275900 $Y=452100
X2365 131 1 49 1633 2 140 ND3 $T=276520 487760 1 0 $X=276520 $Y=482340
X2366 1664 1 1661 143 2 1673 ND3 $T=279000 467600 1 0 $X=279000 $Y=462180
X2367 1575 1 134 1674 2 140 ND3 $T=279620 477680 0 0 $X=279620 $Y=477300
X2368 1685 1 50 1683 2 107 ND3 $T=283340 487760 1 180 $X=280860 $Y=487380
X2369 1684 1 42 1682 2 148 ND3 $T=285820 477680 1 180 $X=283340 $Y=477300
X2370 1650 1 1695 1703 2 1704 ND3 $T=285200 447440 0 0 $X=285200 $Y=447060
X2371 1665 1 99 1713 2 1707 ND3 $T=286440 467600 1 0 $X=286440 $Y=462180
X2372 1705 1 99 1710 2 1714 ND3 $T=287680 447440 1 0 $X=287680 $Y=442020
X2373 54 1 109 1711 2 131 ND3 $T=288300 487760 0 0 $X=288300 $Y=487380
X2374 1726 1 1429 167 2 1728 ND3 $T=290160 467600 1 0 $X=290160 $Y=462180
X2375 1601 1 1701 1502 2 1730 ND3 $T=290780 386960 1 0 $X=290780 $Y=381540
X2376 1734 1 1729 1404 2 1523 ND3 $T=295120 397040 1 180 $X=292640 $Y=396660
X2377 1440 1 1729 1731 2 1734 ND3 $T=292640 407120 1 0 $X=292640 $Y=401700
X2378 1759 1 162 1697 2 1731 ND3 $T=298220 407120 0 180 $X=295740 $Y=401700
X2379 1616 1 1738 1744 2 1622 ND3 $T=296360 397040 1 0 $X=296360 $Y=391620
X2380 1548 1 1676 173 2 176 ND3 $T=296980 487760 0 0 $X=296980 $Y=487380
X2381 1751 1 1497 178 2 1757 ND3 $T=298840 487760 1 0 $X=298840 $Y=482340
X2382 1727 1 1766 1762 2 1753 ND3 $T=303180 386960 0 180 $X=300700 $Y=381540
X2383 1723 1 1490 1778 2 1774 ND3 $T=306280 447440 0 180 $X=303800 $Y=442020
X2384 44 1 191 1787 2 107 ND3 $T=306280 487760 0 0 $X=306280 $Y=487380
X2385 1804 1 1727 1696 2 1794 ND3 $T=310620 386960 0 180 $X=308140 $Y=381540
X2386 1777 1 1802 195 2 1809 ND3 $T=308760 487760 1 0 $X=308760 $Y=482340
X2387 1805 1 1626 1811 2 1578 ND3 $T=310000 397040 1 0 $X=310000 $Y=391620
X2388 1634 1 1578 1815 2 1738 ND3 $T=311240 386960 0 0 $X=311240 $Y=386580
X2389 1830 1 1781 1817 2 1821 ND3 $T=316200 437360 1 180 $X=313720 $Y=436980
X2390 1618 1 1578 1853 2 1738 ND3 $T=318680 386960 0 0 $X=318680 $Y=386580
X2391 1805 1 1828 1844 2 1738 ND3 $T=323020 407120 1 0 $X=323020 $Y=401700
X2392 1855 1 1876 104 2 1880 ND3 $T=324880 457520 0 0 $X=324880 $Y=457140
X2393 1880 1 1876 1409 2 1846 ND3 $T=329220 467600 0 180 $X=326740 $Y=462180
X2394 1872 1 1876 4 2 1855 ND3 $T=329840 457520 1 180 $X=327360 $Y=457140
X2395 1908 1 1905 170 2 1846 ND3 $T=332320 457520 1 180 $X=329840 $Y=457140
X2396 1872 1 1876 39 2 1846 ND3 $T=332320 467600 1 180 $X=329840 $Y=467220
X2397 1908 1 1905 11 2 1879 ND3 $T=334800 457520 0 180 $X=332320 $Y=452100
X2398 1908 1 215 88 2 1879 ND3 $T=334800 467600 0 180 $X=332320 $Y=462180
X2399 1877 1 1906 114 2 215 ND3 $T=334800 477680 0 180 $X=332320 $Y=472260
X2400 1908 1 1846 187 2 215 ND3 $T=335420 467600 1 180 $X=332940 $Y=467220
X2401 1672 1 1766 1858 2 1786 ND3 $T=336040 386960 1 180 $X=333560 $Y=386580
X2402 1901 1 1910 219 2 1914 ND3 $T=333560 447440 1 0 $X=333560 $Y=442020
X2403 1899 1 1906 68 2 215 ND3 $T=337900 477680 1 180 $X=335420 $Y=477300
X2404 222 1 206 49 2 217 ND3 $T=338520 497840 0 180 $X=336040 $Y=492420
X2405 1928 1 1871 1729 2 1836 ND3 $T=339760 407120 0 180 $X=337280 $Y=401700
X2406 1899 1 1906 1539 2 1905 ND3 $T=340380 467600 1 180 $X=337900 $Y=467220
X2407 227 1 221 48 2 222 ND3 $T=341000 497840 0 180 $X=338520 $Y=492420
X2408 231 1 225 23 2 222 ND3 $T=343480 497840 0 180 $X=341000 $Y=492420
X2409 1622 1 1828 1893 2 1753 ND3 $T=342240 397040 1 0 $X=342240 $Y=391620
X2410 235 1 221 1962 2 220 ND3 $T=345960 477680 0 0 $X=345960 $Y=477300
X2411 1867 1 1955 1970 2 1949 ND3 $T=350300 376880 1 0 $X=350300 $Y=371460
X2412 1936 1 238 1977 2 1876 ND3 $T=350300 447440 1 0 $X=350300 $Y=442020
X2413 1891 1 1938 1995 2 1981 ND3 $T=352160 346640 1 0 $X=352160 $Y=341220
X2414 1808 1 1975 1992 2 1954 ND3 $T=357740 376880 1 0 $X=357740 $Y=371460
X2415 1978 1 1990 1942 2 1996 ND3 $T=357740 457520 0 0 $X=357740 $Y=457140
X2416 1993 1 1953 1996 2 1966 ND3 $T=362080 457520 0 180 $X=359600 $Y=452100
X2417 1669 1 1999 2000 2 1989 ND3 $T=361460 376880 1 0 $X=361460 $Y=371460
X2418 2002 1 1944 1990 2 1997 ND3 $T=363940 457520 1 180 $X=361460 $Y=457140
X2419 266 1 2026 270 2 269 ND3 $T=373240 326480 0 0 $X=373240 $Y=326100
X2420 1716 1 2037 2043 2 2017 ND3 $T=376340 336560 1 0 $X=376340 $Y=331140
X2421 1792 1 2038 2040 2 2047 ND3 $T=376340 366800 1 0 $X=376340 $Y=361380
X2422 1668 1 2045 2071 2 2029 ND3 $T=378200 346640 0 0 $X=378200 $Y=346260
X2423 1693 1 2057 2058 2 2021 ND3 $T=381920 356720 0 0 $X=381920 $Y=356340
X2424 306 1 2168 2174 2 2164 ND3 $T=428420 366800 1 180 $X=425940 $Y=366420
X2425 308 1 2170 2193 2 2108 ND3 $T=430280 346640 1 0 $X=430280 $Y=341220
X2426 2183 1 2178 2195 2 2119 ND3 $T=430900 346640 0 0 $X=430900 $Y=346260
X2427 2199 1 311 2197 2 310 ND3 $T=434000 336560 0 180 $X=431520 $Y=331140
X2428 313 1 2181 2215 2 2093 ND3 $T=435240 326480 0 0 $X=435240 $Y=326100
X2429 2107 1 2241 2242 2 2235 ND3 $T=443300 397040 1 0 $X=443300 $Y=391620
X2430 2251 1 2256 2262 2 2175 ND3 $T=446400 376880 1 0 $X=446400 $Y=371460
X2431 2079 1 2255 2284 2 2247 ND3 $T=446400 397040 0 0 $X=446400 $Y=396660
X2432 2078 1 2264 2266 2 2275 ND3 $T=448880 457520 0 0 $X=448880 $Y=457140
X2433 2225 1 2271 2263 2 2278 ND3 $T=450120 397040 0 0 $X=450120 $Y=396660
X2434 2189 1 2272 2273 2 2279 ND3 $T=450120 417200 0 0 $X=450120 $Y=416820
X2435 2092 1 2288 2283 2 2254 ND3 $T=457560 447440 0 180 $X=455080 $Y=442020
X2436 2227 1 2305 2289 2 2294 ND3 $T=461280 437360 0 180 $X=458800 $Y=431940
X2437 2216 1 2330 2331 2 2333 ND3 $T=466860 477680 0 0 $X=466860 $Y=477300
X2438 2332 1 2327 2337 2 2112 ND3 $T=468100 366800 1 0 $X=468100 $Y=361380
X2439 2117 1 2336 2341 2 2338 ND3 $T=470580 417200 0 0 $X=470580 $Y=416820
X2440 2096 1 2347 2350 2 2348 ND3 $T=474920 437360 1 0 $X=474920 $Y=431940
X2441 2356 1 368 2339 2 366 ND3 $T=480500 326480 1 180 $X=478020 $Y=326100
X2442 2217 1 2368 2379 2 375 ND3 $T=482360 487760 0 0 $X=482360 $Y=487380
X2443 2375 1 2355 2344 2 2120 ND3 $T=486700 366800 1 180 $X=484220 $Y=366420
X2444 2226 1 2382 2371 2 2385 ND3 $T=487320 417200 1 0 $X=487320 $Y=411780
X2445 2234 1 2389 2392 2 2361 ND3 $T=489180 417200 0 0 $X=489180 $Y=416820
X2446 2206 1 2390 2394 2 2381 ND3 $T=489180 437360 0 0 $X=489180 $Y=436980
X2447 2411 1 2377 2396 2 2103 ND3 $T=493520 366800 1 180 $X=491040 $Y=366420
X2448 2116 1 2410 2421 2 2415 ND3 $T=492900 477680 1 0 $X=492900 $Y=472260
X2449 2429 1 2416 2407 2 2121 ND3 $T=496620 356720 1 180 $X=494140 $Y=356340
X2450 2243 1 2423 2402 2 2406 ND3 $T=496620 457520 0 180 $X=494140 $Y=452100
X2451 2285 1 2430 2393 2 2405 ND3 $T=498480 427280 1 180 $X=496000 $Y=426900
X2452 2169 1 2436 2428 2 2443 ND3 $T=499720 467600 1 0 $X=499720 $Y=462180
X2453 2090 1 2434 2437 2 2440 ND3 $T=499720 487760 1 0 $X=499720 $Y=482340
X2454 2504 1 2508 2509 2 2513 ND3 $T=531960 346640 0 0 $X=531960 $Y=346260
X2455 2573 1 2595 2530 2 2611 ND3 $T=554280 336560 1 0 $X=554280 $Y=331140
X2456 2536 1 2586 2640 2 434 ND3 $T=564200 487760 1 0 $X=564200 $Y=482340
X2457 2647 1 467 2652 2 406 ND3 $T=566060 487760 0 0 $X=566060 $Y=487380
X2458 3098 1 3114 3103 2 3108 ND3 $T=673320 346640 0 180 $X=670840 $Y=341220
X2459 3393 1 3398 3417 2 3403 ND3 $T=740280 437360 1 0 $X=740280 $Y=431940
X2460 3492 1 3475 3424 2 3480 ND3 $T=758260 487760 1 0 $X=758260 $Y=482340
X2461 753 1 755 756 2 758 ND3 $T=837000 326480 0 0 $X=837000 $Y=326100
X2462 3900 1 3897 3890 2 3888 ND3 $T=845680 356720 1 180 $X=843200 $Y=356340
X2463 774 1 3899 3883 2 3868 ND3 $T=846300 336560 0 180 $X=843820 $Y=331140
X2464 3927 1 3922 3919 2 3879 ND3 $T=853740 356720 1 180 $X=851260 $Y=356340
X2465 841 1 839 3977 2 828 ND3 $T=869240 376880 1 180 $X=866760 $Y=376500
X2466 4043 1 215 4032 2 223 ND3 $T=876060 407120 0 180 $X=873580 $Y=401700
X2467 4027 1 4059 4016 2 4065 ND3 $T=878540 366800 1 0 $X=878540 $Y=361380
X2468 4075 1 4069 4076 2 3747 ND3 $T=884740 427280 0 180 $X=882260 $Y=421860
X2469 4087 1 3787 4072 2 4052 ND3 $T=884740 477680 0 180 $X=882260 $Y=472260
X2470 4128 1 4208 4230 2 241 ND3 $T=909540 397040 0 0 $X=909540 $Y=396660
X2471 940 1 4248 4074 2 4257 ND3 $T=916360 356720 1 0 $X=916360 $Y=351300
X2472 956 1 4272 4002 2 4266 ND3 $T=923800 336560 1 180 $X=921320 $Y=336180
X2473 960 1 910 4274 2 4242 ND3 $T=926900 386960 0 180 $X=924420 $Y=381540
X2474 4263 1 4327 4339 2 4207 ND3 $T=934960 356720 0 0 $X=934960 $Y=356340
X2475 4341 1 4279 4311 2 4330 ND3 $T=937440 366800 1 180 $X=934960 $Y=366420
X2476 851 1 4311 974 2 4204 ND3 $T=935580 356720 1 0 $X=935580 $Y=351300
X2477 4396 1 838 4268 2 843 ND3 $T=951700 336560 1 180 $X=949220 $Y=336180
X2478 4316 1 1008 4403 2 4408 ND3 $T=951700 336560 0 0 $X=951700 $Y=336180
X2479 4438 1 1017 3989 2 4423 ND3 $T=957900 336560 1 180 $X=955420 $Y=336180
X2480 4502 1 215 4512 2 223 ND3 $T=970920 417200 0 0 $X=970920 $Y=416820
X2481 3501 1 4512 4516 2 4372 ND3 $T=972160 417200 1 0 $X=972160 $Y=411780
X2482 4511 1 1044 4523 2 4521 ND3 $T=972780 346640 1 0 $X=972780 $Y=341220
X2483 1091 1 1084 4605 2 1085 ND3 $T=994480 376880 1 180 $X=992000 $Y=376500
X2484 4514 1 1093 4644 2 1047 ND3 $T=996340 326480 0 0 $X=996340 $Y=326100
X2485 4680 1 4653 4634 2 4645 ND3 $T=1001920 407120 0 180 $X=999440 $Y=401700
X2486 4658 1 4523 1109 2 4541 ND3 $T=1002540 336560 1 180 $X=1000060 $Y=336180
X2487 1113 1 4669 4641 2 4659 ND3 $T=1003780 407120 1 180 $X=1001300 $Y=406740
X2488 4716 1 4447 4739 2 4681 ND3 $T=1013700 487760 1 0 $X=1013700 $Y=482340
X2489 4714 1 4729 4743 2 4748 ND3 $T=1014940 407120 1 0 $X=1014940 $Y=401700
X2490 4814 1 4786 4801 2 1157 ND3 $T=1028580 346640 1 180 $X=1026100 $Y=346260
X2491 4818 1 4810 4820 2 4778 ND3 $T=1029820 417200 0 180 $X=1027340 $Y=411780
X2492 4825 1 4701 4815 2 4797 ND3 $T=1031060 407120 0 180 $X=1028580 $Y=401700
X2493 4854 1 4840 4848 2 4747 ND3 $T=1035400 346640 0 180 $X=1032920 $Y=341220
X2494 4825 1 4856 4859 2 4819 ND3 $T=1034160 397040 1 0 $X=1034160 $Y=391620
X2495 1189 1 4786 4879 2 4882 ND3 $T=1039120 346640 0 0 $X=1039120 $Y=346260
X2496 1196 1 4884 4867 2 4873 ND3 $T=1041600 417200 1 180 $X=1039120 $Y=416820
X2497 4932 1 4901 4926 2 4893 ND3 $T=1044700 417200 1 180 $X=1042220 $Y=416820
X2498 4914 1 1207 4841 2 1211 ND3 $T=1045940 407120 1 0 $X=1045940 $Y=401700
X2499 1215 1 4933 4824 2 4928 ND3 $T=1050900 336560 1 180 $X=1048420 $Y=336180
X2500 4946 1 4769 4939 2 4935 ND3 $T=1053380 417200 1 180 $X=1050900 $Y=416820
X2501 4945 1 4944 4889 2 4954 ND3 $T=1052140 336560 0 0 $X=1052140 $Y=336180
X2502 4917 1 4654 4693 2 1111 ND3 $T=1052760 376880 1 0 $X=1052760 $Y=371460
X2503 4976 1 1221 4971 2 1082 ND3 $T=1057720 346640 0 180 $X=1055240 $Y=341220
X2504 1235 1 4964 4624 2 4899 ND3 $T=1060200 397040 0 180 $X=1057720 $Y=391620
X2505 4953 1 5013 4960 2 5003 ND3 $T=1070120 386960 1 180 $X=1067640 $Y=386580
X2506 5004 1 1250 4752 2 1252 ND3 $T=1068260 407120 0 0 $X=1068260 $Y=406740
X2507 5006 1 4679 5020 2 5050 ND3 $T=1071360 407120 0 0 $X=1071360 $Y=406740
X2508 4625 1 1136 5043 2 4631 ND3 $T=1073840 346640 0 0 $X=1073840 $Y=346260
X2509 1287 1 5054 5041 2 5012 ND3 $T=1080040 417200 1 0 $X=1080040 $Y=411780
X2510 5075 1 5072 5007 2 5062 ND3 $T=1085620 376880 1 180 $X=1083140 $Y=376500
X2511 5071 1 1283 5096 2 4903 ND3 $T=1090580 366800 0 0 $X=1090580 $Y=366420
X2512 1282 1 5093 5056 2 5098 ND3 $T=1090580 376880 0 0 $X=1090580 $Y=376500
X2513 5089 1 5094 5040 2 5097 ND3 $T=1090580 397040 1 0 $X=1090580 $Y=391620
X2514 42 28 19 2 34 1 27 AN4B1S $T=234980 497840 0 180 $X=230640 $Y=492420
X2515 1415 1396 1404 2 1350 1 1371 AN4B1S $T=235600 397040 0 180 $X=231260 $Y=391620
X2516 1397 1414 1417 2 45 1 1429 AN4B1S $T=233740 467600 0 0 $X=233740 $Y=467220
X2517 1442 1405 1428 2 1422 1 1420 AN4B1S $T=239940 437360 1 180 $X=235600 $Y=436980
X2518 56 51 1391 2 24 1 1418 AN4B1S $T=240560 487760 0 180 $X=236220 $Y=482340
X2519 54 51 1449 2 1456 1 1358 AN4B1S $T=239320 497840 1 0 $X=239320 $Y=492420
X2520 1391 49 56 2 1436 1 1480 AN4B1S $T=241180 477680 0 0 $X=241180 $Y=477300
X2521 1486 50 1473 2 14 1 1402 AN4B1S $T=247380 467600 1 180 $X=243040 $Y=467220
X2522 1490 1485 1479 2 1468 1 64 AN4B1S $T=248620 437360 0 180 $X=244280 $Y=431940
X2523 1530 1500 1474 2 1516 1 81 AN4B1S $T=255440 437360 0 180 $X=251100 $Y=431940
X2524 1535 1479 1454 2 1478 1 1513 AN4B1S $T=256060 427280 1 180 $X=251720 $Y=426900
X2525 1558 1547 1542 2 97 1 1531 AN4B1S $T=259780 477680 1 180 $X=255440 $Y=477300
X2526 1671 1589 1451 2 1583 1 113 AN4B1S $T=267220 457520 0 180 $X=262880 $Y=452100
X2527 1600 1569 1586 2 112 1 1567 AN4B1S $T=267220 467600 0 180 $X=262880 $Y=462180
X2528 1587 1592 1607 2 1581 1 1602 AN4B1S $T=265980 417200 0 0 $X=265980 $Y=416820
X2529 1667 1588 1452 2 1613 1 137 AN4B1S $T=280240 447440 0 180 $X=275900 $Y=442020
X2530 1652 1658 1655 2 1659 1 1689 AN4B1S $T=279000 397040 0 0 $X=279000 $Y=396660
X2531 1686 1443 1675 2 1647 1 1676 AN4B1S $T=283960 386960 0 180 $X=279620 $Y=381540
X2532 1689 1690 1598 2 1697 1 151 AN4B1S $T=283340 407120 1 0 $X=283340 $Y=401700
X2533 1755 54 131 2 161 1 163 AN4B1S $T=292640 497840 0 180 $X=288300 $Y=492420
X2534 1743 1736 1720 2 1459 1 1726 AN4B1S $T=297600 457520 1 180 $X=293260 $Y=457140
X2535 56 148 1449 2 96 1 1739 AN4B1S $T=293260 487760 1 0 $X=293260 $Y=482340
X2536 1750 1742 1688 2 1721 1 1667 AN4B1S $T=299460 447440 0 180 $X=295120 $Y=442020
X2537 1768 1752 1754 2 1713 1 174 AN4B1S $T=302560 467600 1 180 $X=298220 $Y=467220
X2538 1758 1718 1765 2 181 1 1777 AN4B1S $T=300080 477680 0 0 $X=300080 $Y=477300
X2539 1782 1773 1767 2 1721 1 1386 AN4B1S $T=305040 417200 1 180 $X=300700 $Y=416820
X2540 1635 1766 1753 2 1744 1 1733 AN4B1S $T=306900 386960 1 180 $X=302560 $Y=386580
X2541 1800 92 190 2 1787 1 1747 AN4B1S $T=309380 477680 1 180 $X=305040 $Y=477300
X2542 8 1352 1790 2 1432 1 1789 AN4B1S $T=310620 417200 1 180 $X=306280 $Y=416820
X2543 1750 192 1774 2 1798 1 1796 AN4B1S $T=306280 457520 0 0 $X=306280 $Y=457140
X2544 1812 1782 1807 2 1817 1 1673 AN4B1S $T=311860 457520 0 0 $X=311860 $Y=457140
X2545 1730 1578 1701 2 1698 1 1859 AN4B1S $T=319300 386960 1 0 $X=319300 $Y=381540
X2546 1881 1885 1892 2 1897 1 1901 AN4B1S $T=327980 457520 1 0 $X=327980 $Y=452100
X2547 1635 1601 1672 2 1915 1 1860 AN4B1S $T=333560 397040 0 0 $X=333560 $Y=396660
X2548 1967 1786 1828 2 1936 1 1888 AN4B1S $T=350300 417200 0 180 $X=345960 $Y=411780
X2549 3875 759 3867 2 757 1 3868 AN4B1S $T=841960 336560 0 180 $X=837620 $Y=331140
X2550 773 768 767 2 766 1 3879 AN4B1S $T=846300 326480 1 180 $X=841960 $Y=326100
X2551 3907 772 771 2 3893 1 764 AN4B1S $T=847540 346640 0 180 $X=843200 $Y=341220
X2552 782 778 3875 2 3893 1 3888 AN4B1S $T=848780 356720 0 180 $X=844440 $Y=351300
X2553 3867 3945 3953 2 813 1 3935 AN4B1S $T=858700 336560 1 0 $X=858700 $Y=331140
X2554 4048 4042 4036 2 4026 1 4027 AN4B1S $T=877300 356720 1 180 $X=872960 $Y=356340
X2555 4085 870 4073 2 4054 1 3927 AN4B1S $T=884740 336560 1 180 $X=880400 $Y=336180
X2556 878 4081 3929 2 4074 1 4065 AN4B1S $T=885980 356720 1 180 $X=881640 $Y=356340
X2557 4069 3747 4096 2 3781 1 4108 AN4B1S $T=885980 427280 1 0 $X=885980 $Y=421860
X2558 4140 907 4147 2 4150 1 3900 AN4B1S $T=897140 346640 1 0 $X=897140 $Y=341220
X2559 4104 4157 4163 2 4167 1 4165 AN4B1S $T=899000 366800 0 0 $X=899000 $Y=366420
X2560 4193 4184 4178 2 4164 1 4179 AN4B1S $T=906440 376880 1 180 $X=902100 $Y=376500
X2561 937 934 4221 2 4210 1 3925 AN4B1S $T=915120 336560 0 180 $X=910780 $Y=331140
X2562 938 910 4242 2 942 1 4144 AN4B1S $T=914500 376880 0 0 $X=914500 $Y=376500
X2563 3907 944 4255 2 4074 1 4266 AN4B1S $T=916360 346640 1 0 $X=916360 $Y=341220
X2564 4254 810 951 2 4268 1 4201 AN4B1S $T=919460 346640 0 0 $X=919460 $Y=346260
X2565 4308 825 834 2 4119 1 4278 AN4B1S $T=931240 366800 1 180 $X=926900 $Y=366420
X2566 4324 875 4302 2 4268 1 962 AN4B1S $T=931860 346640 1 180 $X=927520 $Y=346260
X2567 878 4433 4285 2 4403 1 4423 AN4B1S $T=957900 346640 1 0 $X=957900 $Y=341220
X2568 4360 1021 4407 2 4452 1 4438 AN4B1S $T=959140 336560 1 0 $X=959140 $Y=331140
X2569 4489 4563 4569 2 1060 1 4573 AN4B1S $T=982700 336560 0 0 $X=982700 $Y=336180
X2570 4576 4566 1071 2 1072 1 4584 AN4B1S $T=985800 336560 1 0 $X=985800 $Y=331140
X2571 4561 4597 4601 2 4587 1 4570 AN4B1S $T=987660 346640 0 0 $X=987660 $Y=346260
X2572 4668 1114 4643 2 4689 1 4680 AN4B1S $T=1002540 356720 1 0 $X=1002540 $Y=351300
X2573 4673 4655 4678 2 4693 1 1135 AN4B1S $T=1003780 326480 0 0 $X=1003780 $Y=326100
X2574 4677 4590 1118 2 4693 1 4559 AN4B1S $T=1003780 336560 0 0 $X=1003780 $Y=336180
X2575 4708 4701 4671 2 4696 1 4645 AN4B1S $T=1009360 407120 0 180 $X=1005020 $Y=401700
X2576 4671 4711 4722 2 4724 1 4659 AN4B1S $T=1009980 407120 0 0 $X=1009980 $Y=406740
X2577 4740 1128 4723 2 4686 1 4714 AN4B1S $T=1014940 356720 1 180 $X=1010600 $Y=356340
X2578 4799 1153 4711 2 4752 1 4778 AN4B1S $T=1026100 417200 0 180 $X=1021760 $Y=411780
X2579 4806 4800 4763 2 1155 1 4784 AN4B1S $T=1027960 356720 1 180 $X=1023620 $Y=356340
X2580 1173 4835 4831 2 4796 1 4818 AN4B1S $T=1034160 336560 0 180 $X=1029820 $Y=331140
X2581 4862 1175 4817 2 4845 1 4836 AN4B1S $T=1036640 376880 0 180 $X=1032300 $Y=371460
X2582 1167 4877 4885 2 4889 1 4854 AN4B1S $T=1039120 346640 1 0 $X=1039120 $Y=341220
X2583 4907 4864 4895 2 4696 1 4887 AN4B1S $T=1045320 397040 0 180 $X=1040980 $Y=391620
X2584 4876 1206 4918 2 4879 1 4914 AN4B1S $T=1044700 407120 0 0 $X=1044700 $Y=406740
X2585 4799 4921 4911 2 4879 1 4935 AN4B1S $T=1045940 417200 1 0 $X=1045940 $Y=411780
X2586 4880 4918 4938 2 4942 1 4748 AN4B1S $T=1049660 397040 0 0 $X=1049660 $Y=396660
X2587 4937 4948 1223 2 4955 1 4946 AN4B1S $T=1052140 336560 1 0 $X=1052140 $Y=331140
X2588 4887 4938 4807 2 4960 1 4767 AN4B1S $T=1052760 397040 1 0 $X=1052760 $Y=391620
X2589 4962 4977 4972 2 4960 1 4964 AN4B1S $T=1060200 386960 1 180 $X=1055860 $Y=386580
X2590 4722 4973 4712 2 4958 1 4983 AN4B1S $T=1056480 407120 0 0 $X=1056480 $Y=406740
X2591 1231 4866 4979 2 4971 1 4932 AN4B1S $T=1057100 346640 0 0 $X=1057100 $Y=346260
X2592 4992 4895 4997 2 4838 1 5004 AN4B1S $T=1062680 407120 0 0 $X=1062680 $Y=406740
X2593 4852 4992 4921 2 4991 1 5012 AN4B1S $T=1062680 417200 1 0 $X=1062680 $Y=411780
X2594 5028 5015 5017 2 4837 1 5006 AN4B1S $T=1072600 407120 0 180 $X=1068260 $Y=401700
X2595 5065 5060 4750 2 5056 1 5050 AN4B1S $T=1084380 397040 0 180 $X=1080040 $Y=391620
X2596 4907 4990 5077 2 5056 1 5062 AN4B1S $T=1083760 386960 0 0 $X=1083760 $Y=386580
X2597 5067 4976 1265 2 5080 1 5083 AN4B1S $T=1085000 346640 1 0 $X=1085000 $Y=341220
X2598 5068 5070 5037 2 5045 1 5089 AN4B1S $T=1085620 356720 0 0 $X=1085620 $Y=356340
X2599 5065 5091 5085 2 5096 1 5097 AN4B1S $T=1089960 397040 0 0 $X=1089960 $Y=396660
X2600 5049 5095 4919 2 5081 1 5075 AN4B1S $T=1090580 346640 1 0 $X=1090580 $Y=341220
X2601 2402 1 2 2409 BUF1CK $T=491660 457520 1 0 $X=491660 $Y=452100
X2602 3910 1 2 3721 BUF1CK $T=848780 457520 1 180 $X=846300 $Y=457140
X2603 4174 1 2 4292 BUF1CK $T=1055860 467600 1 0 $X=1055860 $Y=462180
X2604 1352 1356 1365 1343 2 1 1374 OA22 $T=225060 407120 0 0 $X=225060 $Y=406740
X2605 1328 1333 4 1391 2 1 1397 OA22 $T=228160 467600 0 0 $X=228160 $Y=467220
X2606 1402 39 1352 43 2 1 1417 OA22 $T=232500 467600 1 0 $X=232500 $Y=462180
X2607 1426 1419 1382 1344 2 1 1407 OA22 $T=237460 386960 0 180 $X=233120 $Y=381540
X2608 1534 1578 1385 1464 2 1 1561 OA22 $T=264120 386960 0 180 $X=259780 $Y=381540
X2609 1441 1494 1491 1412 2 1 1587 OA22 $T=261020 417200 0 0 $X=261020 $Y=416820
X2610 110 59 1380 1466 2 1 1615 OA22 $T=265360 457520 0 0 $X=265360 $Y=457140
X2611 1463 1630 104 58 2 1 1608 OA22 $T=275280 427280 1 180 $X=270940 $Y=426900
X2612 1494 1382 1634 1546 2 1 1485 OA22 $T=276520 386960 1 180 $X=272180 $Y=386580
X2613 1534 1672 1380 1441 2 1 145 OA22 $T=279000 417200 1 0 $X=279000 $Y=411780
X2614 114 157 1463 1528 2 1 1695 OA22 $T=290160 457520 0 180 $X=285820 $Y=452100
X2615 1738 1546 1389 1344 2 1 1767 OA22 $T=298220 407120 0 0 $X=298220 $Y=406740
X2616 1534 1753 1546 1701 2 1 1781 OA22 $T=301320 376880 0 0 $X=301320 $Y=376500
X2617 1409 48 197 47 2 1 1750 OA22 $T=314340 487760 1 180 $X=310000 $Y=487380
X2618 1837 1818 1616 1572 2 1 1490 OA22 $T=318680 417200 0 180 $X=314340 $Y=411780
X2619 1944 1855 1902 1880 2 1 1960 OA22 $T=352780 457520 0 180 $X=348440 $Y=452100
X2620 3938 810 807 3946 2 1 3875 OA22 $T=861180 356720 1 180 $X=856840 $Y=356340
X2621 4047 830 858 4060 2 1 4048 OA22 $T=876680 356720 1 0 $X=876680 $Y=351300
X2622 834 981 833 965 2 1 4360 OA22 $T=937440 336560 1 0 $X=937440 $Y=331140
X2623 4638 4590 1078 4649 2 1 4671 OA22 $T=996960 397040 1 0 $X=996960 $Y=391620
X2624 4727 4715 1136 4741 2 1 4763 OA22 $T=1013080 366800 1 0 $X=1013080 $Y=361380
X2625 1004 1169 4764 4592 2 1 4806 OA22 $T=1032920 356720 1 180 $X=1028580 $Y=356340
X2626 1183 1198 1210 1212 2 1 4937 OA22 $T=1045940 326480 0 0 $X=1045940 $Y=326100
X2627 1120 1070 1126 1213 2 1 4933 OA22 $T=1047180 336560 1 0 $X=1047180 $Y=331140
X2628 4655 4847 1198 1232 2 1 4954 OA22 $T=1060200 336560 1 180 $X=1055860 $Y=336180
X2629 1094 1256 1136 1253 2 1 5013 OA22 $T=1073840 336560 0 180 $X=1069500 $Y=331140
X2630 4569 1253 4631 5061 2 1 5068 OA22 $T=1080040 356720 0 0 $X=1080040 $Y=356340
X2631 5057 4667 4764 5066 2 1 5028 OA22 $T=1081280 407120 0 0 $X=1081280 $Y=406740
X2632 2188 1 2 2232 INV3CK $T=441440 336560 0 0 $X=441440 $Y=336180
X2633 2261 1 2 2208 INV3CK $T=459420 346640 0 0 $X=459420 $Y=346260
X2634 2323 1 2 2320 INV3CK $T=469960 366800 0 0 $X=469960 $Y=366420
X2635 291 285 1 2 INV6CK $T=403620 326480 1 180 $X=398040 $Y=326100
X2636 312 278 1 2 INV6CK $T=433380 497840 0 180 $X=427800 $Y=492420
X2637 2208 297 1 2 INV6CK $T=434620 346640 0 0 $X=434620 $Y=346260
X2638 2232 309 1 2 INV6CK $T=453220 326480 0 0 $X=453220 $Y=326100
X2639 351 296 1 2 INV6CK $T=461900 366800 0 180 $X=456320 $Y=361380
X2640 2320 315 1 2 INV6CK $T=465000 336560 0 0 $X=465000 $Y=336180
X2641 370 354 1 2 INV6CK $T=481740 497840 0 180 $X=476160 $Y=492420
X2642 2115 339 1 2 INV6CK $T=478640 336560 0 0 $X=478640 $Y=336180
X2643 2186 323 1 2 INV6CK $T=480500 326480 0 0 $X=480500 $Y=326100
X2644 1409 1 1418 22 1413 41 2 OAI22S $T=237460 477680 1 180 $X=233740 $Y=477300
X2645 1379 1 43 1427 1416 1382 2 OAI22S $T=234980 437360 1 0 $X=234980 $Y=431940
X2646 1463 1 1462 47 1448 61 2 OAI22S $T=244900 437360 1 180 $X=241180 $Y=436980
X2647 1559 1 67 20 98 1489 2 OAI22S $T=259780 497840 0 180 $X=256060 $Y=492420
X2648 1409 1 1739 30 1574 1747 2 OAI22S $T=295120 477680 0 0 $X=295120 $Y=477300
X2649 1380 1 1895 11 1904 216 2 OAI22S $T=330460 437360 0 0 $X=330460 $Y=436980
X2650 474 1 467 2640 469 2652 2 OAI22S $T=570400 497840 0 180 $X=566680 $Y=492420
X2651 909 1 854 4124 4064 877 2 OAI22S $T=898380 356720 1 0 $X=898380 $Y=351300
X2652 4128 1 4191 4148 4189 3501 2 OAI22S $T=905820 407120 1 0 $X=905820 $Y=401700
X2653 4436 1 4487 4444 4465 3501 2 OAI22S $T=966580 386960 0 0 $X=966580 $Y=386580
X2654 1097 1 1004 4531 4640 1063 2 OAI22S $T=995100 366800 1 0 $X=995100 $Y=361380
X2655 1129 1 1180 4569 4846 4853 2 OAI22S $T=1038500 336560 1 180 $X=1034780 $Y=336180
X2656 1330 2 1342 1326 1 NR2 $T=221340 407120 1 0 $X=221340 $Y=401700
X2657 1337 2 1325 1331 1 NR2 $T=223200 417200 0 180 $X=221340 $Y=411780
X2658 1330 2 1327 1336 1 NR2 $T=221340 437360 1 0 $X=221340 $Y=431940
X2659 1332 2 3 1335 1 NR2 $T=221340 487760 1 0 $X=221340 $Y=482340
X2660 6 2 1357 1359 1 NR2 $T=221960 497840 1 0 $X=221960 $Y=492420
X2661 1338 2 1367 1349 1 NR2 $T=225060 397040 0 0 $X=225060 $Y=396660
X2662 1362 2 1356 1349 1 NR2 $T=226920 407120 0 180 $X=225060 $Y=401700
X2663 1364 2 1354 1353 1 NR2 $T=226920 437360 1 180 $X=225060 $Y=436980
X2664 1375 2 1360 1349 1 NR2 $T=227540 397040 0 180 $X=225680 $Y=391620
X2665 26 2 1377 15 1 NR2 $T=229400 477680 1 180 $X=227540 $Y=477300
X2666 1383 2 1333 1364 1 NR2 $T=230020 447440 0 180 $X=228160 $Y=442020
X2667 29 2 1391 32 1 NR2 $T=230020 487760 1 0 $X=230020 $Y=482340
X2668 1401 2 1361 1390 1 NR2 $T=232500 447440 1 180 $X=230640 $Y=447060
X2669 1349 2 1412 1383 1 NR2 $T=232500 417200 1 0 $X=232500 $Y=411780
X2670 32 2 1399 26 1 NR2 $T=233120 477680 1 0 $X=233120 $Y=472260
X2671 1366 2 1378 46 1 NR2 $T=234980 487760 0 0 $X=234980 $Y=487380
X2672 1326 2 1427 1425 1 NR2 $T=238700 427280 1 180 $X=236840 $Y=426900
X2673 57 2 51 14 1 NR2 $T=238700 487760 1 180 $X=236840 $Y=487380
X2674 1425 2 1434 1440 1 NR2 $T=238700 386960 1 0 $X=238700 $Y=381540
X2675 1408 2 1422 1400 1 NR2 $T=240560 437360 0 180 $X=238700 $Y=431940
X2676 1457 2 1437 1330 1 NR2 $T=242420 397040 0 180 $X=240560 $Y=391620
X2677 26 2 38 62 1 NR2 $T=240560 477680 1 0 $X=240560 $Y=472260
X2678 29 2 58 1456 1 NR2 $T=240560 487760 1 0 $X=240560 $Y=482340
X2679 1457 2 1419 1425 1 NR2 $T=241800 386960 1 0 $X=241800 $Y=381540
X2680 1383 2 1462 1472 1 NR2 $T=241800 417200 0 0 $X=241800 $Y=416820
X2681 1336 2 1400 1465 1 NR2 $T=241800 437360 1 0 $X=241800 $Y=431940
X2682 1362 2 1482 1476 1 NR2 $T=243660 407120 1 0 $X=243660 $Y=401700
X2683 63 2 66 1456 1 NR2 $T=243660 487760 0 0 $X=243660 $Y=487380
X2684 1331 2 84 1349 1 NR2 $T=245520 407120 0 0 $X=245520 $Y=406740
X2685 1476 2 1484 1483 1 NR2 $T=246140 427280 1 0 $X=246140 $Y=421860
X2686 74 2 1496 1455 1 NR2 $T=248000 487760 1 180 $X=246140 $Y=487380
X2687 1447 2 1481 1493 1 NR2 $T=246760 397040 0 0 $X=246760 $Y=396660
X2688 34 2 1501 78 1 NR2 $T=248620 497840 1 0 $X=248620 $Y=492420
X2689 77 2 1475 1512 1 NR2 $T=249240 487760 0 0 $X=249240 $Y=487380
X2690 26 2 1525 77 1 NR2 $T=254200 477680 1 180 $X=252340 $Y=477300
X2691 1527 2 1526 1537 1 NR2 $T=254200 397040 1 0 $X=254200 $Y=391620
X2692 1538 2 1343 1338 1 NR2 $T=256680 417200 0 180 $X=254820 $Y=411780
X2693 96 2 1524 26 1 NR2 $T=256680 467600 1 180 $X=254820 $Y=467220
X2694 1353 2 1551 1347 1 NR2 $T=255440 437360 0 0 $X=255440 $Y=436980
X2695 96 2 1489 1560 1 NR2 $T=257300 487760 1 0 $X=257300 $Y=482340
X2696 52 2 105 32 1 NR2 $T=259160 487760 0 0 $X=259160 $Y=487380
X2697 24 2 1575 26 1 NR2 $T=262880 487760 0 180 $X=261020 $Y=482340
X2698 1572 2 1581 1578 1 NR2 $T=262260 397040 1 0 $X=262260 $Y=391620
X2699 1368 2 110 55 1 NR2 $T=264120 477680 0 0 $X=264120 $Y=477300
X2700 1599 2 1593 1516 1 NR2 $T=267220 437360 0 180 $X=265360 $Y=431940
X2701 96 2 1596 116 1 NR2 $T=267840 487760 1 180 $X=265980 $Y=487380
X2702 1614 2 1466 1538 1 NR2 $T=269700 417200 0 180 $X=267840 $Y=411780
X2703 1538 2 1528 1364 1 NR2 $T=267840 427280 1 0 $X=267840 $Y=421860
X2704 37 2 1559 133 1 NR2 $T=272180 497840 1 0 $X=272180 $Y=492420
X2705 1527 2 1508 1523 1 NR2 $T=274660 397040 0 180 $X=272800 $Y=391620
X2706 1483 2 1630 1364 1 NR2 $T=272800 417200 1 0 $X=272800 $Y=411780
X2707 1636 2 123 1483 1 NR2 $T=274660 427280 0 180 $X=272800 $Y=421860
X2708 1523 2 1644 1423 1 NR2 $T=274660 427280 1 0 $X=274660 $Y=421860
X2709 1423 2 1645 1330 1 NR2 $T=275900 407120 1 0 $X=275900 $Y=401700
X2710 32 2 131 1560 1 NR2 $T=275900 477680 0 0 $X=275900 $Y=477300
X2711 1483 2 1637 1538 1 NR2 $T=279620 437360 0 180 $X=277760 $Y=431940
X2712 63 2 50 103 1 NR2 $T=277760 487760 0 0 $X=277760 $Y=487380
X2713 62 2 1624 1560 1 NR2 $T=281480 447440 1 180 $X=279620 $Y=447060
X2714 147 2 1678 46 1 NR2 $T=283960 457520 0 180 $X=282100 $Y=452100
X2715 46 2 1486 1456 1 NR2 $T=282720 467600 1 0 $X=282720 $Y=462180
X2716 149 2 1684 32 1 NR2 $T=284580 487760 0 180 $X=282720 $Y=482340
X2717 1456 2 1715 32 1 NR2 $T=286440 487760 0 180 $X=284580 $Y=482340
X2718 1336 2 154 1326 1 NR2 $T=285820 437360 1 0 $X=285820 $Y=431940
X2719 1336 2 1450 1457 1 NR2 $T=287060 427280 1 0 $X=287060 $Y=421860
X2720 1338 2 1708 1476 1 NR2 $T=287680 417200 0 0 $X=287680 $Y=416820
X2721 1383 2 1642 1476 1 NR2 $T=290160 407120 1 180 $X=288300 $Y=406740
X2722 1457 2 1712 1326 1 NR2 $T=290780 427280 1 180 $X=288920 $Y=426900
X2723 1538 2 1627 1511 1 NR2 $T=289540 417200 1 0 $X=289540 $Y=411780
X2724 1383 2 1680 1538 1 NR2 $T=289540 427280 1 0 $X=289540 $Y=421860
X2725 1476 2 1620 1511 1 NR2 $T=292020 427280 0 0 $X=292020 $Y=426900
X2726 1511 2 1760 1349 1 NR2 $T=303800 427280 1 180 $X=301940 $Y=426900
X2727 1741 2 1785 1788 1 NR2 $T=303180 407120 0 0 $X=303180 $Y=406740
X2728 29 2 1755 62 1 NR2 $T=303800 487760 0 0 $X=303800 $Y=487380
X2729 1791 2 1717 1795 1 NR2 $T=306900 397040 0 0 $X=306900 $Y=396660
X2730 1791 2 1634 1771 1 NR2 $T=308140 397040 1 0 $X=308140 $Y=391620
X2731 1818 2 1364 1813 1 NR2 $T=313720 417200 0 180 $X=311860 $Y=411780
X2732 103 2 1449 1560 1 NR2 $T=311860 487760 1 0 $X=311860 $Y=482340
X2733 1815 2 1601 1793 1 NR2 $T=313720 386960 0 0 $X=313720 $Y=386580
X2734 1560 2 1833 149 1 NR2 $T=316200 487760 0 180 $X=314340 $Y=482340
X2735 1818 2 1538 1822 1 NR2 $T=317440 417200 1 180 $X=315580 $Y=416820
X2736 1822 2 1791 206 1 NR2 $T=316820 407120 1 0 $X=316820 $Y=401700
X2737 1539 2 1694 1845 1 NR2 $T=318680 427280 1 0 $X=318680 $Y=421860
X2738 1772 2 1843 1537 1 NR2 $T=321160 447440 0 180 $X=319300 $Y=442020
X2739 1813 2 1771 206 1 NR2 $T=319920 407120 1 0 $X=319920 $Y=401700
X2740 189 2 1850 133 1 NR2 $T=320540 487760 0 0 $X=320540 $Y=487380
X2741 1871 2 1511 1818 1 NR2 $T=325500 437360 0 180 $X=323640 $Y=431940
X2742 1818 2 1383 1873 1 NR2 $T=324260 427280 0 0 $X=324260 $Y=426900
X2743 1862 2 1865 1845 1 NR2 $T=325500 477680 1 0 $X=325500 $Y=472260
X2744 1875 2 1864 1845 1 NR2 $T=327980 437360 0 180 $X=326120 $Y=431940
X2745 1873 2 1866 1845 1 NR2 $T=329220 487760 0 180 $X=327360 $Y=482340
X2746 1861 2 1884 1845 1 NR2 $T=331080 427280 1 180 $X=329220 $Y=426900
X2747 1890 2 1895 1898 1 NR2 $T=330460 427280 1 0 $X=330460 $Y=421860
X2748 1465 2 1903 1772 1 NR2 $T=330460 437360 1 0 $X=330460 $Y=431940
X2749 206 2 1793 1902 1 NR2 $T=331080 417200 1 0 $X=331080 $Y=411780
X2750 209 2 1734 1845 1 NR2 $T=334180 417200 0 0 $X=334180 $Y=416820
X2751 1913 2 1910 1904 1 NR2 $T=336040 437360 0 180 $X=334180 $Y=431940
X2752 1906 2 1880 1905 1 NR2 $T=336040 467600 1 0 $X=336040 $Y=462180
X2753 1906 2 1872 215 1 NR2 $T=337900 477680 0 180 $X=336040 $Y=472260
X2754 1920 2 1831 1876 1 NR2 $T=337280 457520 1 0 $X=337280 $Y=452100
X2755 1918 2 1836 1909 1 NR2 $T=339760 407120 1 180 $X=337900 $Y=406740
X2756 220 2 1890 1911 1 NR2 $T=337900 437360 1 0 $X=337900 $Y=431940
X2757 221 2 1917 1907 1 NR2 $T=337900 477680 0 0 $X=337900 $Y=477300
X2758 1902 2 1915 209 1 NR2 $T=339140 397040 0 0 $X=339140 $Y=396660
X2759 1876 2 1919 223 1 NR2 $T=339140 457520 1 0 $X=339140 $Y=452100
X2760 1936 2 1928 1930 1 NR2 $T=342860 407120 0 180 $X=341000 $Y=401700
X2761 1766 2 63 1845 1 NR2 $T=341000 427280 1 0 $X=341000 $Y=421860
X2762 1923 2 1914 1937 1 NR2 $T=341000 437360 1 0 $X=341000 $Y=431940
X2763 1933 2 228 1845 1 NR2 $T=342860 487760 1 180 $X=341000 $Y=487380
X2764 1933 2 1931 232 1 NR2 $T=342240 477680 0 0 $X=342240 $Y=477300
X2765 1893 2 1924 1950 1 NR2 $T=342860 417200 1 0 $X=342860 $Y=411780
X2766 1911 2 1940 225 1 NR2 $T=344720 447440 1 0 $X=344720 $Y=442020
X2767 1953 2 1868 1876 1 NR2 $T=346580 447440 1 180 $X=344720 $Y=447060
X2768 223 2 1908 235 1 NR2 $T=344720 467600 1 0 $X=344720 $Y=462180
X2769 1902 2 218 1845 1 NR2 $T=347820 457520 0 180 $X=345960 $Y=452100
X2770 1845 2 222 1907 1 NR2 $T=345960 487760 0 0 $X=345960 $Y=487380
X2771 206 2 227 220 1 NR2 $T=346580 497840 1 0 $X=346580 $Y=492420
X2772 238 2 1961 1953 1 NR2 $T=347820 467600 1 0 $X=347820 $Y=462180
X2773 220 2 1936 1943 1 NR2 $T=348440 437360 0 0 $X=348440 $Y=436980
X2774 238 2 1855 1958 1 NR2 $T=352780 447440 1 180 $X=350920 $Y=447060
X2775 238 2 1834 245 1 NR2 $T=357740 437360 0 0 $X=357740 $Y=436980
X2776 245 2 1854 241 1 NR2 $T=358360 447440 0 0 $X=358360 $Y=447060
X2777 245 2 1976 235 1 NR2 $T=358360 477680 1 0 $X=358360 $Y=472260
X2778 1911 2 2002 1953 1 NR2 $T=363320 447440 1 180 $X=361460 $Y=447060
X2779 2074 2 2078 2082 1 NR2 $T=391840 457520 0 0 $X=391840 $Y=457140
X2780 2052 2 2079 2084 1 NR2 $T=392460 407120 1 0 $X=392460 $Y=401700
X2781 2055 2 2092 2089 1 NR2 $T=392460 447440 1 0 $X=392460 $Y=442020
X2782 2062 2 2090 2086 1 NR2 $T=392460 487760 1 0 $X=392460 $Y=482340
X2783 2066 2 2096 2098 1 NR2 $T=395560 427280 1 0 $X=395560 $Y=421860
X2784 2039 2 2107 2097 1 NR2 $T=397420 397040 1 0 $X=397420 $Y=391620
X2785 2046 2 2117 2105 1 NR2 $T=399280 417200 1 0 $X=399280 $Y=411780
X2786 2056 2 2116 2114 1 NR2 $T=404240 477680 1 0 $X=404240 $Y=472260
X2787 2149 2 2169 2173 1 NR2 $T=424700 467600 0 0 $X=424700 $Y=467220
X2788 2180 2 2183 2179 1 NR2 $T=428420 346640 1 0 $X=428420 $Y=341220
X2789 2176 2 2189 2194 1 NR2 $T=430280 417200 1 0 $X=430280 $Y=411780
X2790 2075 2 2206 2202 1 NR2 $T=432140 447440 1 0 $X=432140 $Y=442020
X2791 2150 2 2216 2212 1 NR2 $T=434000 477680 0 0 $X=434000 $Y=477300
X2792 2148 2 2217 2213 1 NR2 $T=434000 487760 0 0 $X=434000 $Y=487380
X2793 317 2 2199 2214 1 NR2 $T=437720 336560 1 180 $X=435860 $Y=336180
X2794 2187 2 2225 2218 1 NR2 $T=438340 397040 1 0 $X=438340 $Y=391620
X2795 2165 2 2226 2222 1 NR2 $T=438340 417200 1 0 $X=438340 $Y=411780
X2796 2196 2 2227 2220 1 NR2 $T=438340 427280 0 0 $X=438340 $Y=426900
X2797 2050 2 2234 2229 1 NR2 $T=440200 427280 1 0 $X=440200 $Y=421860
X2798 2156 2 2243 2231 1 NR2 $T=442060 447440 0 0 $X=442060 $Y=447060
X2799 2250 2 2251 2257 1 NR2 $T=446400 366800 1 0 $X=446400 $Y=361380
X2800 329 2 330 332 1 NR2 $T=450120 326480 0 0 $X=450120 $Y=326100
X2801 2190 2 2285 2267 1 NR2 $T=451980 447440 1 0 $X=451980 $Y=442020
X2802 2318 2 2332 2324 1 NR2 $T=468100 366800 0 180 $X=466240 $Y=361380
X2803 2373 2 2375 2380 1 NR2 $T=486080 366800 1 0 $X=486080 $Y=361380
X2804 2449 2 2429 2451 1 NR2 $T=505300 366800 1 0 $X=505300 $Y=361380
X2805 2460 2 2356 404 1 NR2 $T=510260 336560 0 180 $X=508400 $Y=331140
X2806 2452 2 2411 2480 1 NR2 $T=508400 376880 1 0 $X=508400 $Y=371460
X2807 2641 2 2647 2625 1 NR2 $T=566060 487760 1 180 $X=564200 $Y=487380
X2808 2701 2 2666 2648 1 NR2 $T=575360 376880 0 180 $X=573500 $Y=371460
X2809 2662 2 2712 2723 1 NR2 $T=576600 397040 0 0 $X=576600 $Y=396660
X2810 2662 2 2677 2675 1 NR2 $T=576600 407120 0 0 $X=576600 $Y=406740
X2811 2679 2 2716 2690 1 NR2 $T=578460 376880 1 0 $X=578460 $Y=371460
X2812 2662 2 2728 2694 1 NR2 $T=581560 397040 1 180 $X=579700 $Y=396660
X2813 2732 2 2679 2744 1 NR2 $T=581560 376880 1 0 $X=581560 $Y=371460
X2814 2662 2 2770 2745 1 NR2 $T=589000 407120 0 180 $X=587140 $Y=401700
X2815 488 2 2767 491 1 NR2 $T=588380 346640 1 0 $X=588380 $Y=341220
X2816 2768 2 2766 482 1 NR2 $T=589000 386960 1 0 $X=589000 $Y=381540
X2817 494 2 2775 482 1 NR2 $T=591480 376880 0 180 $X=589620 $Y=371460
X2818 494 2 2756 490 1 NR2 $T=592100 366800 1 180 $X=590240 $Y=366420
X2819 2768 2 2779 490 1 NR2 $T=592720 376880 1 0 $X=592720 $Y=371460
X2820 488 2 2787 499 1 NR2 $T=593340 346640 0 0 $X=593340 $Y=346260
X2821 494 2 2792 501 1 NR2 $T=595200 366800 0 0 $X=595200 $Y=366420
X2822 2768 2 2797 501 1 NR2 $T=595200 376880 1 0 $X=595200 $Y=371460
X2823 488 2 2806 496 1 NR2 $T=597680 326480 1 180 $X=595820 $Y=326100
X2824 494 2 2805 503 1 NR2 $T=600780 376880 1 0 $X=600780 $Y=371460
X2825 2768 2 2801 503 1 NR2 $T=604500 376880 1 180 $X=602640 $Y=376500
X2826 494 2 2837 509 1 NR2 $T=605120 376880 1 0 $X=605120 $Y=371460
X2827 2768 2 2844 509 1 NR2 $T=605740 376880 0 0 $X=605740 $Y=376500
X2828 494 2 2830 514 1 NR2 $T=607600 366800 0 0 $X=607600 $Y=366420
X2829 2768 2 2823 514 1 NR2 $T=608840 376880 0 0 $X=608840 $Y=376500
X2830 517 2 518 514 1 NR2 $T=612560 356720 0 0 $X=612560 $Y=356340
X2831 494 2 2856 525 1 NR2 $T=614420 366800 0 0 $X=614420 $Y=366420
X2832 2768 2 2855 525 1 NR2 $T=615660 376880 0 0 $X=615660 $Y=376500
X2833 517 2 524 490 1 NR2 $T=616280 376880 1 0 $X=616280 $Y=371460
X2834 517 2 523 501 1 NR2 $T=617520 356720 0 0 $X=617520 $Y=356340
X2835 2768 2 2878 528 1 NR2 $T=617520 376880 0 0 $X=617520 $Y=376500
X2836 494 2 2883 528 1 NR2 $T=621240 366800 1 180 $X=619380 $Y=366420
X2837 517 2 532 503 1 NR2 $T=623100 376880 1 0 $X=623100 $Y=371460
X2838 2768 2 2914 535 1 NR2 $T=624340 386960 1 0 $X=624340 $Y=381540
X2839 494 2 2926 535 1 NR2 $T=625580 366800 0 0 $X=625580 $Y=366420
X2840 517 2 533 525 1 NR2 $T=626200 356720 0 0 $X=626200 $Y=356340
X2841 517 2 540 528 1 NR2 $T=631160 356720 1 180 $X=629300 $Y=356340
X2842 494 2 2945 537 1 NR2 $T=629300 376880 1 0 $X=629300 $Y=371460
X2843 517 2 546 531 1 NR2 $T=636740 336560 1 180 $X=634880 $Y=336180
X2844 517 2 544 535 1 NR2 $T=636740 346640 0 180 $X=634880 $Y=341220
X2845 517 2 547 537 1 NR2 $T=637980 326480 1 180 $X=636120 $Y=326100
X2846 517 2 551 550 1 NR2 $T=637980 326480 0 0 $X=637980 $Y=326100
X2847 2768 2 2953 550 1 NR2 $T=637980 376880 0 0 $X=637980 $Y=376500
X2848 494 2 2960 550 1 NR2 $T=641700 376880 0 180 $X=639840 $Y=371460
X2849 2768 2 2978 554 1 NR2 $T=639840 386960 1 0 $X=639840 $Y=381540
X2850 494 2 2982 554 1 NR2 $T=641700 376880 1 0 $X=641700 $Y=371460
X2851 517 2 556 554 1 NR2 $T=646660 376880 0 180 $X=644800 $Y=371460
X2852 517 2 561 560 1 NR2 $T=652240 376880 1 180 $X=650380 $Y=376500
X2853 2768 2 3002 565 1 NR2 $T=650380 386960 1 0 $X=650380 $Y=381540
X2854 562 2 2989 2768 1 NR2 $T=651000 397040 1 0 $X=651000 $Y=391620
X2855 562 2 2999 494 1 NR2 $T=651620 336560 0 0 $X=651620 $Y=336180
X2856 517 2 563 565 1 NR2 $T=651620 376880 1 0 $X=651620 $Y=371460
X2857 2768 2 3020 569 1 NR2 $T=653480 386960 0 0 $X=653480 $Y=386580
X2858 562 2 2918 2768 1 NR2 $T=655960 397040 0 180 $X=654100 $Y=391620
X2859 562 2 3005 494 1 NR2 $T=655340 366800 1 0 $X=655340 $Y=361380
X2860 494 2 3034 569 1 NR2 $T=657200 366800 1 180 $X=655340 $Y=366420
X2861 494 2 3008 565 1 NR2 $T=657200 376880 0 180 $X=655340 $Y=371460
X2862 648 2 3351 646 1 NR2 $T=737180 356720 0 180 $X=735320 $Y=351300
X2863 648 2 3368 666 1 NR2 $T=739040 356720 1 0 $X=739040 $Y=351300
X2864 648 2 652 656 1 NR2 $T=741520 326480 0 0 $X=741520 $Y=326100
X2865 648 2 3380 678 1 NR2 $T=742140 336560 0 0 $X=742140 $Y=336180
X2866 648 2 3381 658 1 NR2 $T=742140 346640 1 0 $X=742140 $Y=341220
X2867 648 2 3386 662 1 NR2 $T=742760 376880 0 0 $X=742760 $Y=376500
X2868 648 2 3387 675 1 NR2 $T=746480 376880 0 0 $X=746480 $Y=376500
X2869 3374 2 3529 494 1 NR2 $T=770660 386960 0 0 $X=770660 $Y=386580
X2870 494 2 3619 3418 1 NR2 $T=788020 376880 0 180 $X=786160 $Y=371460
X2871 494 2 3611 669 1 NR2 $T=786780 366800 0 0 $X=786780 $Y=366420
X2872 494 2 3631 663 1 NR2 $T=789880 386960 0 0 $X=789880 $Y=386580
X2873 3374 2 3557 494 1 NR2 $T=791740 397040 0 180 $X=789880 $Y=391620
X2874 494 2 3628 650 1 NR2 $T=793600 346640 0 180 $X=791740 $Y=341220
X2875 494 2 3622 667 1 NR2 $T=791740 366800 1 0 $X=791740 $Y=361380
X2876 494 2 3634 658 1 NR2 $T=794840 336560 0 0 $X=794840 $Y=336180
X2877 494 2 709 678 1 NR2 $T=795460 336560 1 0 $X=795460 $Y=331140
X2878 494 2 3613 653 1 NR2 $T=795460 346640 0 0 $X=795460 $Y=346260
X2879 517 2 714 670 1 NR2 $T=797320 326480 0 0 $X=797320 $Y=326100
X2880 494 2 3649 675 1 NR2 $T=800420 376880 1 180 $X=798560 $Y=376500
X2881 494 2 3651 662 1 NR2 $T=800420 376880 1 0 $X=800420 $Y=371460
X2882 721 2 3668 3721 1 NR2 $T=804140 467600 0 0 $X=804140 $Y=467220
X2883 517 2 730 660 1 NR2 $T=807240 326480 1 180 $X=805380 $Y=326100
X2884 517 2 3754 3418 1 NR2 $T=809100 376880 1 180 $X=807240 $Y=376500
X2885 3721 2 3734 565 1 NR2 $T=807860 467600 0 0 $X=807860 $Y=467220
X2886 517 2 3730 663 1 NR2 $T=810960 386960 0 180 $X=809100 $Y=381540
X2887 721 2 3642 3748 1 NR2 $T=810340 447440 0 0 $X=810340 $Y=447060
X2888 3721 2 3744 729 1 NR2 $T=810960 467600 0 0 $X=810960 $Y=467220
X2889 3748 2 3758 565 1 NR2 $T=814060 427280 0 180 $X=812200 $Y=421860
X2890 3374 2 3768 517 1 NR2 $T=814060 397040 1 0 $X=814060 $Y=391620
X2891 3374 2 3735 517 1 NR2 $T=817780 397040 1 180 $X=815920 $Y=396660
X2892 3748 2 3766 729 1 NR2 $T=817780 447440 0 180 $X=815920 $Y=442020
X2893 3748 2 3798 560 1 NR2 $T=820880 417200 0 0 $X=820880 $Y=416820
X2894 3748 2 3815 554 1 NR2 $T=822740 417200 0 0 $X=822740 $Y=416820
X2895 3721 2 3810 554 1 NR2 $T=822740 467600 0 0 $X=822740 $Y=467220
X2896 3721 2 3776 560 1 NR2 $T=825220 457520 1 180 $X=823360 $Y=457140
X2897 517 2 3804 650 1 NR2 $T=827700 346640 0 180 $X=825840 $Y=341220
X2898 3721 2 3824 550 1 NR2 $T=827700 467600 1 0 $X=827700 $Y=462180
X2899 517 2 3820 658 1 NR2 $T=831420 346640 0 180 $X=829560 $Y=341220
X2900 3748 2 3833 550 1 NR2 $T=831420 417200 0 180 $X=829560 $Y=411780
X2901 517 2 3831 678 1 NR2 $T=830800 326480 0 0 $X=830800 $Y=326100
X2902 517 2 3832 653 1 NR2 $T=830800 356720 1 0 $X=830800 $Y=351300
X2903 3721 2 3842 535 1 NR2 $T=832660 467600 1 180 $X=830800 $Y=467220
X2904 3748 2 3840 535 1 NR2 $T=833280 427280 0 180 $X=831420 $Y=421860
X2905 3748 2 3844 537 1 NR2 $T=832660 407120 1 0 $X=832660 $Y=401700
X2906 3721 2 3849 537 1 NR2 $T=832660 457520 0 0 $X=832660 $Y=457140
X2907 517 2 3861 669 1 NR2 $T=839480 376880 1 180 $X=837620 $Y=376500
X2908 3721 2 3862 531 1 NR2 $T=837620 467600 1 0 $X=837620 $Y=462180
X2909 3748 2 3865 531 1 NR2 $T=841340 407120 1 180 $X=839480 $Y=406740
X2910 517 2 3876 662 1 NR2 $T=843820 376880 0 0 $X=843820 $Y=376500
X2911 517 2 3843 667 1 NR2 $T=844440 366800 1 0 $X=844440 $Y=361380
X2912 517 2 3851 675 1 NR2 $T=844440 386960 0 0 $X=844440 $Y=386580
X2913 3721 2 3903 528 1 NR2 $T=844440 457520 0 0 $X=844440 $Y=457140
X2914 779 2 3908 3905 1 NR2 $T=847540 356720 1 180 $X=845680 $Y=356340
X2915 3748 2 3892 528 1 NR2 $T=848160 407120 1 180 $X=846300 $Y=406740
X2916 3912 2 3891 786 1 NR2 $T=849400 346640 1 0 $X=849400 $Y=341220
X2917 3748 2 3913 525 1 NR2 $T=850020 417200 1 0 $X=850020 $Y=411780
X2918 3721 2 3915 525 1 NR2 $T=850020 457520 0 0 $X=850020 $Y=457140
X2919 3931 2 3920 3926 1 NR2 $T=854980 346640 0 180 $X=853120 $Y=341220
X2920 3910 2 3937 509 1 NR2 $T=853120 457520 0 0 $X=853120 $Y=457140
X2921 801 2 3938 3885 1 NR2 $T=856840 356720 1 180 $X=854980 $Y=356340
X2922 3910 2 3947 806 1 NR2 $T=856840 457520 0 0 $X=856840 $Y=457140
X2923 3748 2 3943 509 1 NR2 $T=859940 417200 0 180 $X=858080 $Y=411780
X2924 812 2 3897 3959 1 NR2 $T=859940 356720 1 0 $X=859940 $Y=351300
X2925 3955 2 3963 806 1 NR2 $T=861800 427280 0 180 $X=859940 $Y=421860
X2926 3910 2 3972 503 1 NR2 $T=861800 467600 1 0 $X=861800 $Y=462180
X2927 3969 2 3899 3974 1 NR2 $T=863660 346640 1 0 $X=863660 $Y=341220
X2928 3955 2 3971 503 1 NR2 $T=865520 407120 1 180 $X=863660 $Y=406740
X2929 826 2 835 784 1 NR2 $T=866760 346640 0 0 $X=866760 $Y=346260
X2930 3980 2 836 3977 1 NR2 $T=868620 356720 1 180 $X=866760 $Y=356340
X2931 3750 2 3958 3995 1 NR2 $T=866760 487760 0 0 $X=866760 $Y=487380
X2932 3750 2 4006 4015 1 NR2 $T=868620 487760 0 0 $X=868620 $Y=487380
X2933 3955 2 4037 490 1 NR2 $T=869860 417200 1 0 $X=869860 $Y=411780
X2934 3955 2 3986 501 1 NR2 $T=870480 407120 1 0 $X=870480 $Y=401700
X2935 3910 2 4010 501 1 NR2 $T=870480 467600 1 0 $X=870480 $Y=462180
X2936 238 2 4017 3501 1 NR2 $T=871720 386960 0 0 $X=871720 $Y=386580
X2937 802 2 858 784 1 NR2 $T=875440 356720 0 180 $X=873580 $Y=351300
X2938 4039 2 4024 223 1 NR2 $T=875440 386960 0 180 $X=873580 $Y=381540
X2939 4018 2 4000 4021 1 NR2 $T=873580 437360 1 0 $X=873580 $Y=431940
X2940 3910 2 4012 490 1 NR2 $T=875440 467600 0 180 $X=873580 $Y=462180
X2941 4018 2 4031 4022 1 NR2 $T=874200 437360 0 0 $X=874200 $Y=436980
X2942 802 2 4047 826 1 NR2 $T=875440 346640 0 0 $X=875440 $Y=346260
X2943 3910 2 4052 861 1 NR2 $T=875440 477680 1 0 $X=875440 $Y=472260
X2944 4056 2 4005 4039 1 NR2 $T=879160 386960 1 180 $X=877300 $Y=386580
X2945 3750 2 4050 4057 1 NR2 $T=877300 487760 0 0 $X=877300 $Y=487380
X2946 3955 2 4069 861 1 NR2 $T=877920 427280 1 0 $X=877920 $Y=421860
X2947 864 2 853 4013 1 NR2 $T=880400 336560 0 180 $X=878540 $Y=331140
X2948 4064 2 4059 4034 1 NR2 $T=880400 356720 1 180 $X=878540 $Y=356340
X2949 223 2 4066 245 1 NR2 $T=878540 397040 1 0 $X=878540 $Y=391620
X2950 4056 2 4067 245 1 NR2 $T=880400 376880 0 0 $X=880400 $Y=376500
X2951 3750 2 4063 4072 1 NR2 $T=880400 487760 1 0 $X=880400 $Y=482340
X2952 4018 2 4071 4076 1 NR2 $T=882260 437360 0 0 $X=882260 $Y=436980
X2953 4092 2 869 4062 1 NR2 $T=884740 346640 0 180 $X=882880 $Y=341220
X2954 241 2 4053 3501 1 NR2 $T=884120 386960 1 0 $X=884120 $Y=381540
X2955 4088 2 4038 241 1 NR2 $T=885980 386960 1 180 $X=884120 $Y=386580
X2956 4084 2 4095 4072 1 NR2 $T=884740 467600 0 0 $X=884740 $Y=467220
X2957 852 2 4098 805 1 NR2 $T=887840 336560 1 180 $X=885980 $Y=336180
X2958 4088 2 4025 238 1 NR2 $T=887220 386960 0 0 $X=887220 $Y=386580
X2959 4039 2 4078 4099 1 NR2 $T=887220 397040 1 0 $X=887220 $Y=391620
X2960 4099 2 4089 245 1 NR2 $T=889080 397040 1 180 $X=887220 $Y=396660
X2961 4018 2 4070 4105 1 NR2 $T=887220 437360 0 0 $X=887220 $Y=436980
X2962 821 2 3981 792 1 NR2 $T=890940 366800 1 0 $X=890940 $Y=361380
X2963 777 2 4135 805 1 NR2 $T=894040 366800 0 0 $X=894040 $Y=366420
X2964 4118 2 4117 4105 1 NR2 $T=895900 437360 1 180 $X=894040 $Y=436980
X2965 889 2 4060 904 1 NR2 $T=895900 356720 1 0 $X=895900 $Y=351300
X2966 4162 2 890 865 1 NR2 $T=898380 336560 1 180 $X=896520 $Y=336180
X2967 779 2 901 815 1 NR2 $T=903340 336560 0 180 $X=901480 $Y=331140
X2968 801 2 917 815 1 NR2 $T=904580 346640 0 180 $X=902720 $Y=341220
X2969 4189 2 4090 4166 1 NR2 $T=904580 407120 0 180 $X=902720 $Y=401700
X2970 4108 2 4176 4155 1 NR2 $T=902720 427280 0 0 $X=902720 $Y=426900
X2971 4100 2 4175 4183 1 NR2 $T=902720 477680 0 0 $X=902720 $Y=477300
X2972 922 2 784 4149 1 NR2 $T=905820 366800 0 180 $X=903960 $Y=361380
X2973 924 2 923 784 1 NR2 $T=905820 326480 0 0 $X=905820 $Y=326100
X2974 854 2 4191 4186 1 NR2 $T=908300 397040 0 180 $X=906440 $Y=391620
X2975 4149 2 899 4202 1 NR2 $T=907680 386960 0 0 $X=907680 $Y=386580
X2976 4202 2 928 4207 1 NR2 $T=908300 366800 1 0 $X=908300 $Y=361380
X2977 4142 2 4219 4190 1 NR2 $T=909540 376880 0 0 $X=909540 $Y=376500
X2978 4203 2 4186 4148 1 NR2 $T=911400 386960 1 180 $X=909540 $Y=386580
X2979 4213 2 4218 4082 1 NR2 $T=911400 346640 0 0 $X=911400 $Y=346260
X2980 4215 2 4248 4192 1 NR2 $T=913260 356720 1 0 $X=913260 $Y=351300
X2981 4242 2 4190 4252 1 NR2 $T=916360 386960 1 0 $X=916360 $Y=381540
X2982 854 2 4114 4258 1 NR2 $T=916360 407120 1 0 $X=916360 $Y=401700
X2983 4162 2 946 4260 1 NR2 $T=918220 336560 0 0 $X=918220 $Y=336180
X2984 821 2 4261 805 1 NR2 $T=920080 376880 0 180 $X=918220 $Y=371460
X2985 4263 2 949 4202 1 NR2 $T=921940 356720 0 180 $X=920080 $Y=351300
X2986 4227 2 4142 4267 1 NR2 $T=920080 386960 1 0 $X=920080 $Y=381540
X2987 911 2 4275 914 1 NR2 $T=923180 417200 1 180 $X=921320 $Y=416820
X2988 775 2 4103 803 1 NR2 $T=921940 346640 1 0 $X=921940 $Y=341220
X2989 788 2 4284 889 1 NR2 $T=925040 346640 1 0 $X=925040 $Y=341220
X2990 922 2 779 4188 1 NR2 $T=926900 356720 0 0 $X=926900 $Y=356340
X2991 4242 2 4119 4227 1 NR2 $T=928760 376880 0 0 $X=928760 $Y=376500
X2992 4307 2 4154 4267 1 NR2 $T=930620 386960 1 180 $X=928760 $Y=386580
X2993 802 2 795 859 1 NR2 $T=931860 336560 0 0 $X=931860 $Y=336180
X2994 4307 2 4313 4243 1 NR2 $T=933720 397040 0 180 $X=931860 $Y=391620
X2995 4243 2 4200 4319 1 NR2 $T=931860 397040 0 0 $X=931860 $Y=396660
X2996 3955 2 4296 675 1 NR2 $T=931860 427280 1 0 $X=931860 $Y=421860
X2997 3955 2 4306 970 1 NR2 $T=931860 437360 0 0 $X=931860 $Y=436980
X2998 4327 2 971 4317 1 NR2 $T=934960 356720 0 180 $X=933100 $Y=351300
X2999 4267 2 4325 4319 1 NR2 $T=933720 386960 0 0 $X=933720 $Y=386580
X3000 889 2 982 3949 1 NR2 $T=934960 326480 0 0 $X=934960 $Y=326100
X3001 800 2 920 3949 1 NR2 $T=934960 336560 1 0 $X=934960 $Y=331140
X3002 922 2 859 4327 1 NR2 $T=936820 346640 0 180 $X=934960 $Y=341220
X3003 3910 2 4334 970 1 NR2 $T=934960 477680 1 0 $X=934960 $Y=472260
X3004 4158 2 4212 975 1 NR2 $T=935580 376880 1 0 $X=935580 $Y=371460
X3005 4252 2 4240 4148 1 NR2 $T=936200 386960 0 0 $X=936200 $Y=386580
X3006 4146 2 4158 4227 1 NR2 $T=936820 386960 1 0 $X=936820 $Y=381540
X3007 3955 2 4321 978 1 NR2 $T=936820 437360 0 0 $X=936820 $Y=436980
X3008 3910 2 4351 675 1 NR2 $T=938680 477680 0 180 $X=936820 $Y=472260
X3009 4158 2 4330 4349 1 NR2 $T=937440 376880 1 0 $X=937440 $Y=371460
X3010 924 2 4361 801 1 NR2 $T=938680 346640 0 0 $X=938680 $Y=346260
X3011 3955 2 4345 662 1 NR2 $T=938680 417200 0 0 $X=938680 $Y=416820
X3012 3910 2 4362 978 1 NR2 $T=938680 487760 1 0 $X=938680 $Y=482340
X3013 922 2 924 4207 1 NR2 $T=942400 356720 1 180 $X=940540 $Y=356340
X3014 4227 2 4352 4317 1 NR2 $T=941780 376880 0 0 $X=941780 $Y=376500
X3015 803 2 4364 852 1 NR2 $T=942400 336560 1 0 $X=942400 $Y=331140
X3016 803 2 4367 788 1 NR2 $T=942400 346640 1 0 $X=942400 $Y=341220
X3017 911 2 4331 989 1 NR2 $T=943640 407120 0 0 $X=943640 $Y=406740
X3018 993 2 4347 3955 1 NR2 $T=945500 457520 0 180 $X=943640 $Y=452100
X3019 3949 2 4373 4082 1 NR2 $T=945500 346640 1 0 $X=945500 $Y=341220
X3020 4202 2 4320 4252 1 NR2 $T=945500 386960 0 0 $X=945500 $Y=386580
X3021 3910 2 4379 662 1 NR2 $T=945500 467600 0 0 $X=945500 $Y=467220
X3022 993 2 994 3910 1 NR2 $T=945500 487760 0 0 $X=945500 $Y=487380
X3023 801 2 887 786 1 NR2 $T=946120 336560 0 0 $X=946120 $Y=336180
X3024 4279 2 999 4317 1 NR2 $T=949220 346640 1 180 $X=947360 $Y=346260
X3025 4390 2 817 877 1 NR2 $T=949220 376880 0 180 $X=947360 $Y=371460
X3026 993 2 998 3910 1 NR2 $T=949840 487760 1 180 $X=947980 $Y=487380
X3027 788 2 1007 4268 1 NR2 $T=949220 336560 1 0 $X=949220 $Y=331140
X3028 3955 2 4377 669 1 NR2 $T=949840 417200 0 0 $X=949840 $Y=416820
X3029 1004 2 4395 4404 1 NR2 $T=950460 376880 0 0 $X=950460 $Y=376500
X3030 993 2 4397 3955 1 NR2 $T=950460 457520 1 0 $X=950460 $Y=452100
X3031 3910 2 4405 669 1 NR2 $T=952320 467600 1 0 $X=952320 $Y=462180
X3032 865 2 4396 904 1 NR2 $T=953560 336560 1 0 $X=953560 $Y=331140
X3033 924 2 847 802 1 NR2 $T=957900 356720 1 180 $X=956040 $Y=356340
X3034 3955 2 4425 667 1 NR2 $T=956040 427280 1 0 $X=956040 $Y=421860
X3035 1019 2 4272 1018 1 NR2 $T=959140 326480 1 180 $X=957280 $Y=326100
X3036 999 2 1010 1001 1 NR2 $T=957900 346640 0 0 $X=957900 $Y=346260
X3037 821 2 1022 931 1 NR2 $T=961000 326480 1 180 $X=959140 $Y=326100
X3038 4456 2 1023 4384 1 NR2 $T=961000 336560 1 180 $X=959140 $Y=336180
X3039 4411 2 1014 4444 1 NR2 $T=959140 356720 0 0 $X=959140 $Y=356340
X3040 4384 2 1024 4420 1 NR2 $T=961000 346640 0 0 $X=961000 $Y=346260
X3041 3910 2 4451 667 1 NR2 $T=962860 467600 0 180 $X=961000 $Y=462180
X3042 4456 2 1025 1031 1 NR2 $T=962240 336560 0 0 $X=962240 $Y=336180
X3043 4421 2 4460 646 1 NR2 $T=964720 467600 1 180 $X=962860 $Y=467220
X3044 4470 2 1030 1020 1 NR2 $T=965340 346640 1 180 $X=963480 $Y=346260
X3045 4465 2 4442 4473 1 NR2 $T=964100 386960 0 0 $X=964100 $Y=386580
X3046 1031 2 1037 4420 1 NR2 $T=967820 326480 1 180 $X=965960 $Y=326100
X3047 1004 2 4479 4444 1 NR2 $T=965960 336560 0 0 $X=965960 $Y=336180
X3048 1027 2 4471 1031 1 NR2 $T=967820 346640 0 180 $X=965960 $Y=341220
X3049 3955 2 4495 666 1 NR2 $T=967820 417200 1 180 $X=965960 $Y=416820
X3050 3955 2 4472 646 1 NR2 $T=967820 427280 0 180 $X=965960 $Y=421860
X3051 4421 2 4488 666 1 NR2 $T=965960 467600 0 0 $X=965960 $Y=467220
X3052 4018 2 4241 3659 1 NR2 $T=966580 437360 1 0 $X=966580 $Y=431940
X3053 4440 2 4468 4444 1 NR2 $T=967820 366800 0 0 $X=967820 $Y=366420
X3054 4466 2 4493 4501 1 NR2 $T=967820 397040 1 0 $X=967820 $Y=391620
X3055 1020 2 1032 4411 1 NR2 $T=969060 336560 1 0 $X=969060 $Y=331140
X3056 1029 2 4504 3501 1 NR2 $T=969680 386960 1 0 $X=969680 $Y=381540
X3057 1016 2 4483 4411 1 NR2 $T=970300 346640 0 0 $X=970300 $Y=346260
X3058 1004 2 4487 4468 1 NR2 $T=970300 366800 0 0 $X=970300 $Y=366420
X3059 4426 2 4500 1029 1 NR2 $T=972160 376880 1 180 $X=970300 $Y=376500
X3060 1039 2 1038 1027 1 NR2 $T=970920 326480 0 0 $X=970920 $Y=326100
X3061 1027 2 1046 4444 1 NR2 $T=970920 336560 1 0 $X=970920 $Y=331140
X3062 4471 2 1040 4483 1 NR2 $T=970920 346640 1 0 $X=970920 $Y=341220
X3063 4501 2 4503 223 1 NR2 $T=970920 397040 1 0 $X=970920 $Y=391620
X3064 223 2 4507 245 1 NR2 $T=972780 407120 0 180 $X=970920 $Y=401700
X3065 4426 2 4520 1012 1 NR2 $T=972160 376880 0 0 $X=972160 $Y=376500
X3066 1039 2 4515 4411 1 NR2 $T=974640 356720 0 180 $X=972780 $Y=351300
X3067 1012 2 4490 3501 1 NR2 $T=974640 397040 0 180 $X=972780 $Y=391620
X3068 4513 2 4290 3659 1 NR2 $T=972780 437360 1 0 $X=972780 $Y=431940
X3069 1038 2 4521 4527 1 NR2 $T=974640 346640 0 0 $X=974640 $Y=346260
X3070 4441 2 4528 245 1 NR2 $T=976500 386960 1 180 $X=974640 $Y=386580
X3071 4421 2 4525 653 1 NR2 $T=974640 467600 1 0 $X=974640 $Y=462180
X3072 1020 2 4541 1004 1 NR2 $T=975880 336560 1 0 $X=975880 $Y=331140
X3073 3955 2 4529 653 1 NR2 $T=977740 417200 1 180 $X=975880 $Y=416820
X3074 4548 2 4552 1063 1 NR2 $T=981460 356720 1 0 $X=981460 $Y=351300
X3075 3910 2 4556 650 1 NR2 $T=982700 477680 1 0 $X=982700 $Y=472260
X3076 3955 2 4555 650 1 NR2 $T=983320 427280 1 0 $X=983320 $Y=421860
X3077 4579 2 4571 4553 1 NR2 $T=986420 397040 0 180 $X=984560 $Y=391620
X3078 1044 2 1077 4444 1 NR2 $T=986420 326480 0 0 $X=986420 $Y=326100
X3079 3955 2 4580 658 1 NR2 $T=988280 427280 0 180 $X=986420 $Y=421860
X3080 3910 2 4586 678 1 NR2 $T=988900 467600 0 0 $X=988900 $Y=467220
X3081 1068 2 4574 4596 1 NR2 $T=989520 366800 1 0 $X=989520 $Y=361380
X3082 4591 2 1074 4605 1 NR2 $T=989520 376880 0 0 $X=989520 $Y=376500
X3083 4514 2 1079 1020 1 NR2 $T=990760 336560 1 0 $X=990760 $Y=331140
X3084 3955 2 4608 656 1 NR2 $T=993240 437360 0 180 $X=991380 $Y=431940
X3085 3910 2 4612 656 1 NR2 $T=993240 487760 0 180 $X=991380 $Y=482340
X3086 4620 2 4560 4613 1 NR2 $T=994480 346640 1 180 $X=992620 $Y=346260
X3087 1093 2 1089 4444 1 NR2 $T=995100 326480 1 180 $X=993240 $Y=326100
X3088 1095 2 4619 4517 1 NR2 $T=995100 356720 0 180 $X=993240 $Y=351300
X3089 3955 2 4627 1090 1 NR2 $T=993240 457520 1 0 $X=993240 $Y=452100
X3090 4579 2 4549 4596 1 NR2 $T=995100 346640 1 0 $X=995100 $Y=341220
X3091 1095 2 1101 4470 1 NR2 $T=995100 356720 1 0 $X=995100 $Y=351300
X3092 4629 2 4638 4662 1 NR2 $T=998200 397040 0 0 $X=998200 $Y=396660
X3093 1107 2 4653 4661 1 NR2 $T=1000060 366800 1 0 $X=1000060 $Y=361380
X3094 4640 2 4679 4665 1 NR2 $T=1003160 386960 1 0 $X=1003160 $Y=381540
X3095 4695 2 4669 4647 1 NR2 $T=1005640 397040 0 180 $X=1003780 $Y=391620
X3096 4613 2 4691 4650 1 NR2 $T=1006880 346640 1 180 $X=1005020 $Y=346260
X3097 4619 2 4705 4687 1 NR2 $T=1008740 397040 0 180 $X=1006880 $Y=391620
X3098 4674 2 1070 4690 1 NR2 $T=1008120 356720 0 0 $X=1008120 $Y=356340
X3099 4706 2 4700 4721 1 NR2 $T=1008740 346640 0 0 $X=1008740 $Y=346260
X3100 4620 2 4713 4706 1 NR2 $T=1008740 386960 1 0 $X=1008740 $Y=381540
X3101 4721 2 4715 4690 1 NR2 $T=1011840 366800 0 180 $X=1009980 $Y=361380
X3102 4623 2 4766 4629 1 NR2 $T=1015560 407120 0 0 $X=1015560 $Y=406740
X3103 4018 2 4749 4753 1 NR2 $T=1015560 437360 0 0 $X=1015560 $Y=436980
X3104 4761 2 4735 4717 1 NR2 $T=1019900 366800 1 180 $X=1018040 $Y=366420
X3105 4623 2 4728 1124 1 NR2 $T=1020520 386960 0 0 $X=1020520 $Y=386580
X3106 1041 2 4759 4756 1 NR2 $T=1020520 487760 0 0 $X=1020520 $Y=487380
X3107 1149 2 4769 4770 1 NR2 $T=1023000 376880 0 180 $X=1021140 $Y=371460
X3108 1041 2 4787 4739 1 NR2 $T=1022380 487760 0 0 $X=1022380 $Y=487380
X3109 4018 2 4793 4746 1 NR2 $T=1024240 437360 1 0 $X=1024240 $Y=431940
X3110 4811 2 4783 4629 1 NR2 $T=1029200 376880 1 180 $X=1027340 $Y=376500
X3111 4018 2 4802 4826 1 NR2 $T=1029200 447440 1 0 $X=1029200 $Y=442020
X3112 4690 2 4798 4650 1 NR2 $T=1032300 386960 1 0 $X=1032300 $Y=381540
X3113 4811 2 4833 4623 1 NR2 $T=1034780 376880 1 180 $X=1032920 $Y=376500
X3114 4674 2 4741 4553 1 NR2 $T=1034160 356720 1 0 $X=1034160 $Y=351300
X3115 4579 2 4853 4865 1 NR2 $T=1036020 346640 1 0 $X=1036020 $Y=341220
X3116 4858 2 4698 1101 1 NR2 $T=1038500 376880 0 180 $X=1036640 $Y=371460
X3117 4871 2 4675 4842 1 NR2 $T=1039120 397040 1 180 $X=1037260 $Y=396660
X3118 1190 2 4794 4596 1 NR2 $T=1039740 356720 0 180 $X=1037880 $Y=351300
X3119 1178 2 4744 4620 1 NR2 $T=1040980 376880 1 0 $X=1040980 $Y=371460
X3120 1204 2 4901 4900 1 NR2 $T=1044700 366800 1 180 $X=1042840 $Y=366420
X3121 4629 2 4762 4842 1 NR2 $T=1044700 386960 1 0 $X=1044700 $Y=381540
X3122 4777 2 4917 4924 1 NR2 $T=1051520 376880 0 180 $X=1049660 $Y=371460
X3123 4920 2 4961 4950 1 NR2 $T=1052760 407120 0 0 $X=1052760 $Y=406740
X3124 4931 2 4885 4967 1 NR2 $T=1053380 366800 0 0 $X=1053380 $Y=366420
X3125 4619 2 4847 4842 1 NR2 $T=1058960 366800 1 180 $X=1057100 $Y=366420
X3126 4706 2 4637 1242 1 NR2 $T=1058340 397040 0 0 $X=1058340 $Y=396660
X3127 4706 2 4994 4693 1 NR2 $T=1063920 346640 1 180 $X=1062060 $Y=346260
X3128 4811 2 4985 1101 1 NR2 $T=1063300 366800 1 0 $X=1063300 $Y=361380
X3129 4629 2 1127 4922 1 NR2 $T=1068880 376880 1 0 $X=1068880 $Y=371460
X3130 4674 2 1255 4685 1 NR2 $T=1071360 336560 0 0 $X=1071360 $Y=336180
X3131 4674 2 5031 1242 1 NR2 $T=1071980 356720 0 0 $X=1071980 $Y=356340
X3132 4619 2 4625 4811 1 NR2 $T=1076940 397040 1 180 $X=1075080 $Y=396660
X3133 4619 2 4823 4922 1 NR2 $T=1076940 397040 1 0 $X=1076940 $Y=391620
X3134 4623 2 5057 4858 1 NR2 $T=1081900 407120 0 180 $X=1080040 $Y=401700
X3135 4623 2 4764 1101 1 NR2 $T=1083760 407120 1 0 $X=1083760 $Y=401700
X3136 1277 2 5072 5064 1 NR2 $T=1084380 336560 0 0 $X=1084380 $Y=336180
X3137 4620 2 1253 4721 1 NR2 $T=1087480 346640 1 180 $X=1085620 $Y=346260
X3138 4721 2 5066 4924 1 NR2 $T=1086240 407120 1 0 $X=1086240 $Y=401700
X3139 4620 2 5092 1190 1 NR2 $T=1090580 356720 1 0 $X=1090580 $Y=351300
X3140 4949 2 5093 5090 1 NR2 $T=1090580 386960 1 0 $X=1090580 $Y=381540
X3141 5029 2 5094 1288 1 NR2 $T=1092440 366800 1 0 $X=1092440 $Y=361380
X3142 1440 1483 2 1376 1 1556 AOI12HS $T=255440 407120 1 0 $X=255440 $Y=401700
X3143 4142 4053 2 4158 1 4132 AOI12HS $T=897140 376880 0 0 $X=897140 $Y=376500
X3144 4471 4490 2 1038 1 4497 AOI12HS $T=967820 356720 1 0 $X=967820 $Y=351300
X3145 1176 1172 2 1126 1 4828 AOI12HS $T=1035400 326480 1 180 $X=1031060 $Y=326100
X3146 4721 4623 2 4958 1 4918 AOI12HS $T=1058340 407120 0 180 $X=1054000 $Y=401700
X3147 2266 1 2 2269 DELB $T=451360 467600 1 0 $X=451360 $Y=462180
X3148 2274 1 2 2299 DELB $T=454460 386960 0 0 $X=454460 $Y=386580
X3149 2287 1 2 2307 DELB $T=456320 437360 0 0 $X=456320 $Y=436980
X3150 2298 1 2 2319 DELB $T=458800 417200 1 0 $X=458800 $Y=411780
X3151 2277 1 2 2335 DELB $T=465620 397040 0 0 $X=465620 $Y=396660
X3152 2308 1 2 2334 DELB $T=465620 437360 1 0 $X=465620 $Y=431940
X3153 2339 1 2 2351 DELB $T=473060 326480 0 0 $X=473060 $Y=326100
X3154 2344 1 2 2352 DELB $T=474300 366800 0 0 $X=474300 $Y=366420
X3155 2354 1 2 2378 DELB $T=479880 427280 0 0 $X=479880 $Y=426900
X3156 2341 1 2 2360 DELB $T=482980 397040 0 0 $X=482980 $Y=396660
X3157 379 1 2 2397 DELB $T=487320 407120 0 0 $X=487320 $Y=406740
X3158 2387 1 2 2404 DELB $T=488560 437360 1 0 $X=488560 $Y=431940
X3159 2384 1 2 2412 DELB $T=489180 386960 1 0 $X=489180 $Y=381540
X3160 2401 1 2 2420 DELB $T=492280 407120 0 0 $X=492280 $Y=406740
X3161 2407 1 2 2414 DELB $T=493520 437360 1 0 $X=493520 $Y=431940
X3162 391 1 2 2419 DELB $T=494760 467600 1 0 $X=494760 $Y=462180
X3163 2337 1 2 2418 DELB $T=498480 437360 1 0 $X=498480 $Y=431940
X3164 2428 1 2 2426 DELB $T=498480 457520 0 0 $X=498480 $Y=457140
X3165 2292 1 2 2447 DELB $T=499720 407120 0 0 $X=499720 $Y=406740
X3166 2438 1 2 2448 DELB $T=501580 407120 1 0 $X=501580 $Y=401700
X3167 2424 1 2 2456 DELB $T=503440 437360 1 0 $X=503440 $Y=431940
X3168 2425 1 2 2496 DELB $T=503440 457520 0 0 $X=503440 $Y=457140
X3169 2459 1 2 2487 DELB $T=508400 437360 1 0 $X=508400 $Y=431940
X3170 2542 1 2 2536 DELB $T=543740 477680 0 0 $X=543740 $Y=477300
X3171 2685 1 2 2764 DELB $T=583420 477680 1 0 $X=583420 $Y=472260
X3172 2446 1 2 2717 DELB $T=588380 477680 1 0 $X=588380 $Y=472260
X3173 2398 1 2 2817 DELB $T=593340 477680 1 0 $X=593340 $Y=472260
X3174 2400 1 2 2789 DELB $T=600780 467600 0 0 $X=600780 $Y=467220
X3175 2838 1 2 2862 DELB $T=605740 467600 0 0 $X=605740 $Y=467220
X3176 2869 1 2 526 DELB $T=612560 477680 1 0 $X=612560 $Y=472260
X3177 2847 1 2 2888 DELB $T=617520 477680 1 0 $X=617520 $Y=472260
X3178 2962 1 2 549 DELB $T=633020 467600 0 0 $X=633020 $Y=467220
X3179 2938 1 2 2986 DELB $T=635500 487760 0 0 $X=635500 $Y=487380
X3180 2980 1 2 2993 DELB $T=637980 467600 0 0 $X=637980 $Y=467220
X3181 3007 1 2 3019 DELB $T=646040 467600 0 0 $X=646040 $Y=467220
X3182 3003 1 2 3011 DELB $T=648520 487760 1 0 $X=648520 $Y=482340
X3183 3023 1 2 567 DELB $T=649760 457520 1 0 $X=649760 $Y=452100
X3184 3049 1 2 3071 DELB $T=656580 487760 1 0 $X=656580 $Y=482340
X3185 3137 1 2 3150 DELB $T=677660 447440 1 0 $X=677660 $Y=442020
X3186 3112 1 2 3135 DELB $T=677660 457520 1 0 $X=677660 $Y=452100
X3187 3157 1 2 3155 DELB $T=683240 437360 0 0 $X=683240 $Y=436980
X3188 3160 1 2 3163 DELB $T=684480 457520 1 0 $X=684480 $Y=452100
X3189 3159 1 2 3167 DELB $T=685100 366800 1 0 $X=685100 $Y=361380
X3190 3151 1 2 609 DELB $T=688820 457520 0 0 $X=688820 $Y=457140
X3191 3183 1 2 3197 DELB $T=693160 437360 1 0 $X=693160 $Y=431940
X3192 3191 1 2 3205 DELB $T=695020 457520 0 0 $X=695020 $Y=457140
X3193 3200 1 2 3225 DELB $T=698120 437360 1 0 $X=698120 $Y=431940
X3194 3220 1 2 3215 DELB $T=705560 457520 0 0 $X=705560 $Y=457140
X3195 3271 1 2 3279 DELB $T=714860 457520 0 0 $X=714860 $Y=457140
X3196 3307 1 2 3292 DELB $T=720440 457520 1 0 $X=720440 $Y=452100
X3197 3358 1 2 3345 DELB $T=735940 487760 1 0 $X=735940 $Y=482340
X3198 3384 1 2 3364 DELB $T=737180 467600 0 0 $X=737180 $Y=467220
X3199 3412 1 2 3410 DELB $T=744620 477680 0 0 $X=744620 $Y=477300
X3200 2551 2 1 2840 BUF1 $T=603880 417200 0 0 $X=603880 $Y=416820
X3201 527 2 1 455 BUF1 $T=619380 336560 1 180 $X=616900 $Y=336180
X3202 488 2 1 2898 BUF1 $T=625580 336560 0 0 $X=625580 $Y=336180
X3203 506 2 1 2865 BUF1 $T=642940 417200 0 0 $X=642940 $Y=416820
X3204 415 2 1 439 BUF1 $T=646040 487760 1 0 $X=646040 $Y=482340
X3205 424 2 1 604 BUF1 $T=690060 467600 1 0 $X=690060 $Y=462180
X3206 2687 2 1 620 BUF1 $T=716100 386960 0 0 $X=716100 $Y=386580
X3207 481 2 1 3512 BUF1 $T=765700 356720 1 0 $X=765700 $Y=351300
X3208 693 2 1 3539 BUF1 $T=774380 346640 0 0 $X=774380 $Y=346260
X3209 492 2 1 3636 BUF1 $T=789260 366800 0 0 $X=789260 $Y=366420
X3210 726 2 1 3746 BUF1 $T=814680 346640 1 180 $X=812200 $Y=346260
X3211 733 2 1 3725 BUF1 $T=815300 346640 0 0 $X=815300 $Y=346260
X3212 3904 2 1 3780 BUF1 $T=846920 477680 0 180 $X=844440 $Y=472260
X3213 3951 2 1 3778 BUF1 $T=856840 457520 0 180 $X=854360 $Y=452100
X3214 3955 2 1 3748 BUF1 $T=862420 407120 1 180 $X=859940 $Y=406740
X3215 4018 2 1 3681 BUF1 $T=872340 437360 1 180 $X=869860 $Y=436980
X3216 876 2 1 3750 BUF1 $T=885980 477680 1 180 $X=883500 $Y=477300
X3217 4121 2 1 706 BUF1 $T=895900 477680 1 180 $X=893420 $Y=477300
X3218 913 2 1 703 BUF1 $T=901480 487760 0 180 $X=899000 $Y=482340
X3219 4148 2 1 4317 BUF1 $T=938060 386960 0 0 $X=938060 $Y=386580
X3220 4398 2 1 4411 BUF1 $T=951700 386960 1 0 $X=951700 $Y=381540
X3221 4298 2 1 4416 BUF1 $T=1014940 457520 0 0 $X=1014940 $Y=457140
X3222 5014 2 1 913 BUF1 $T=1070740 437360 1 180 $X=1068260 $Y=436980
X3223 2432 1 2 2638 BUF1S $T=562340 447440 0 0 $X=562340 $Y=447060
X3224 4736 1 2 4826 BUF1S $T=1031060 447440 1 0 $X=1031060 $Y=442020
X3225 3645 2 1 711 BUF3 $T=798560 366800 0 180 $X=794840 $Y=361380
X3226 4421 2 1 3910 BUF3 $T=964100 467600 1 0 $X=964100 $Y=462180
X3227 4506 2 1 3955 BUF3 $T=975260 417200 1 0 $X=975260 $Y=411780
X3228 1436 58 2 1446 1449 1 OR3B2 $T=238700 467600 0 0 $X=238700 $Y=467220
X3229 1613 145 2 1692 1550 1 OR3B2 $T=281480 437360 0 0 $X=281480 $Y=436980
X3230 1795 1805 2 1810 1701 1 OR3B2 $T=309380 407120 1 0 $X=309380 $Y=401700
X3231 218 48 2 1894 191 1 OR3B2 $T=334800 487760 1 180 $X=331080 $Y=487380
X3232 4222 765 2 3997 4250 1 OR3B2 $T=913260 366800 1 0 $X=913260 $Y=361380
X3233 4614 4625 2 4621 4572 1 OR3B2 $T=996960 376880 0 180 $X=993240 $Y=371460
X3234 4838 4797 2 4822 4788 1 OR3B2 $T=1032920 407120 1 180 $X=1029200 $Y=406740
X3235 4848 1153 2 4860 4852 1 OR3B2 $T=1033540 407120 0 0 $X=1033540 $Y=406740
X3236 1341 2 1334 1321 1323 1 NR3 $T=224440 457520 1 180 $X=221340 $Y=457140
X3237 1363 2 1345 1373 17 1 NR3 $T=226300 437360 1 0 $X=226300 $Y=431940
X3238 13 2 1372 24 1348 1 NR3 $T=226300 487760 1 0 $X=226300 $Y=482340
X3239 1416 2 1439 1445 1452 1 NR3 $T=238700 457520 1 0 $X=238700 $Y=452100
X3240 1448 2 1376 1478 1458 1 NR3 $T=243040 417200 1 0 $X=243040 $Y=411780
X3241 71 2 1488 1413 1497 1 NR3 $T=246140 477680 0 0 $X=246140 $Y=477300
X3242 1519 2 1514 1460 1492 1 NR3 $T=253580 397040 0 180 $X=250480 $Y=391620
X3243 1532 2 1565 1544 1548 1 NR3 $T=255440 447440 0 0 $X=255440 $Y=447060
X3244 1557 2 100 1570 1384 1 NR3 $T=259160 457520 1 0 $X=259160 $Y=452100
X3245 1495 2 1568 1574 1580 1 NR3 $T=259780 477680 0 0 $X=259780 $Y=477300
X3246 1582 2 1583 117 1590 1 NR3 $T=265360 467600 0 0 $X=265360 $Y=467220
X3247 1617 2 1581 1605 1547 1 NR3 $T=269700 477680 1 180 $X=266600 $Y=477300
X3248 1633 2 24 1436 1625 1 NR3 $T=272180 487760 1 180 $X=269080 $Y=487380
X3249 1666 2 1656 1536 1661 1 NR3 $T=280240 427280 0 180 $X=277140 $Y=421860
X3250 1649 2 1654 141 1664 1 NR3 $T=277760 457520 0 0 $X=277760 $Y=457140
X3251 1703 2 1710 1619 164 1 NR3 $T=287680 447440 0 0 $X=287680 $Y=447060
X3252 1719 2 1724 1725 1728 1 NR3 $T=291400 457520 1 0 $X=291400 $Y=452100
X3253 1778 2 1373 1732 1757 1 NR3 $T=303180 447440 0 180 $X=300080 $Y=442020
X3254 1623 2 1537 1803 1790 1 NR3 $T=306280 417200 1 0 $X=306280 $Y=411780
X3255 1692 2 1817 1798 1809 1 NR3 $T=311860 467600 1 0 $X=311860 $Y=462180
X3256 1858 2 1827 1844 1842 1 NR3 $T=319300 397040 0 180 $X=316200 $Y=391620
X3257 203 2 1825 1840 1751 1 NR3 $T=316820 487760 1 0 $X=316820 $Y=482340
X3258 1853 2 1893 1896 1870 1 NR3 $T=328600 386960 0 0 $X=328600 $Y=386580
X3259 220 2 221 1946 1922 1 NR3 $T=343480 487760 1 0 $X=343480 $Y=482340
X3260 3970 2 817 3954 3932 1 NR3 $T=864280 376880 0 180 $X=861180 $Y=371460
X3261 852 2 788 4082 1000 1 NR3 $T=944880 326480 0 0 $X=944880 $Y=326100
X3262 4588 2 4552 4618 4589 1 NR3 $T=989520 397040 0 0 $X=989520 $Y=396660
X3263 4616 2 4610 1080 4595 1 NR3 $T=993860 407120 0 180 $X=990760 $Y=401700
X3264 4801 2 4765 4789 4782 1 NR3 $T=1022380 346640 0 0 $X=1022380 $Y=346260
X3265 4803 2 4815 4824 4799 1 NR3 $T=1028580 397040 0 0 $X=1028580 $Y=396660
X3266 4822 2 4773 1159 4873 1 NR3 $T=1033540 417200 0 180 $X=1030440 $Y=411780
X3267 4846 2 4552 4828 4840 1 NR3 $T=1034160 336560 1 180 $X=1031060 $Y=336180
X3268 4870 2 4883 4812 4884 1 NR3 $T=1039120 386960 1 0 $X=1039120 $Y=381540
X3269 4934 2 4942 4883 4953 1 NR3 $T=1051520 386960 0 0 $X=1051520 $Y=386580
X3270 1190 2 4706 4650 5010 1 NR3 $T=1071980 346640 1 180 $X=1068880 $Y=346260
X3271 5059 2 1266 5055 5054 1 NR3 $T=1079420 376880 0 0 $X=1079420 $Y=376500
X3272 1328 1333 1 1339 12 1322 2 OAI112HS $T=220720 447440 0 0 $X=220720 $Y=447060
X3273 10 1360 1 1374 1345 1392 2 OAI112HS $T=226300 417200 1 0 $X=226300 $Y=411780
X3274 28 30 1 1398 1363 1410 2 OAI112HS $T=230020 437360 1 0 $X=230020 $Y=431940
X3275 22 50 1 1438 1445 1451 2 OAI112HS $T=237460 447440 0 0 $X=237460 $Y=447060
X3276 39 1358 1 60 1468 1461 2 OAI112HS $T=238700 467600 1 0 $X=238700 $Y=462180
X3277 8 1343 1 1550 1519 1552 2 OAI112HS $T=256060 417200 0 0 $X=256060 $Y=416820
X3278 92 1539 1 1577 1516 1541 2 OAI112HS $T=265360 427280 1 180 $X=261020 $Y=426900
X3279 204 68 1 1812 200 1723 2 OAI112HS $T=317440 497840 0 180 $X=313100 $Y=492420
X3280 1911 1845 1 85 1886 28 2 OAI112HS $T=334800 487760 0 180 $X=330460 $Y=482340
X3281 1643 1907 1 1912 1913 1916 2 OAI112HS $T=332940 427280 0 0 $X=332940 $Y=426900
X3282 206 1943 1 1944 1950 1861 2 OAI112HS $T=351540 427280 0 180 $X=347200 $Y=421860
X3283 1966 1982 1 1984 1956 1962 2 OAI112HS $T=357120 467600 1 180 $X=352780 $Y=467220
X3284 1943 245 1 1980 1963 1977 2 OAI112HS $T=357740 447440 0 180 $X=353400 $Y=442020
X3285 4218 3891 1 936 4150 939 2 OAI112HS $T=911400 346640 1 0 $X=911400 $Y=341220
X3286 4234 4243 1 4233 4152 4230 2 OAI112HS $T=918220 397040 1 180 $X=913880 $Y=396660
X3287 4445 4384 1 4461 4486 4453 2 OAI112HS $T=960380 386960 1 0 $X=960380 $Y=381540
X3288 4691 4675 1 1123 4689 4732 2 OAI112HS $T=1008120 356720 1 0 $X=1008120 $Y=351300
X3289 1117 1105 1 4708 4720 4725 2 OAI112HS $T=1008740 336560 1 0 $X=1008740 $Y=331140
X3290 4537 4715 1 4738 1131 1132 2 OAI112HS $T=1018040 336560 0 180 $X=1013700 $Y=331140
X3291 4633 4766 1 4772 4773 1150 2 OAI112HS $T=1018660 407120 1 0 $X=1018660 $Y=401700
X3292 1091 4563 1 1156 4803 4807 2 OAI112HS $T=1022380 386960 1 0 $X=1022380 $Y=381540
X3293 1218 1220 1 4732 4955 4738 2 OAI112HS $T=1051520 326480 0 0 $X=1051520 $Y=326100
X3294 1120 4654 1 1224 4958 4898 2 OAI112HS $T=1051520 366800 1 0 $X=1051520 $Y=361380
X3295 1056 1105 1 1234 4838 4869 2 OAI112HS $T=1062060 366800 0 180 $X=1057720 $Y=361380
X3296 4631 4540 1 4869 4991 4982 2 OAI112HS $T=1066400 386960 0 180 $X=1062060 $Y=381540
X3297 3081 579 3101 2 1 3104 XOR3S $T=662160 376880 0 0 $X=662160 $Y=376500
X3298 3106 3047 2 3069 3074 1 3045 FA1 $T=670840 427280 1 180 $X=655340 $Y=426900
X3299 2345 2296 2490 2 1 XNR2HS $T=535680 477680 1 180 $X=530100 $Y=477300
X3300 2566 2588 2549 2 1 XNR2HS $T=556140 397040 0 180 $X=550560 $Y=391620
X3301 2602 2623 2599 2 1 XNR2HS $T=560480 407120 1 0 $X=560480 $Y=401700
X3302 2584 2600 2574 2 1 XNR2HS $T=561100 376880 1 0 $X=561100 $Y=371460
X3303 3057 3065 3051 2 1 XNR2HS $T=661540 386960 0 180 $X=655960 $Y=381540
X3304 3212 3213 3232 2 1 XNR2HS $T=699980 457520 0 0 $X=699980 $Y=457140
X3305 3232 3491 683 2 1 XNR2HS $T=760120 477680 1 0 $X=760120 $Y=472260
X3306 3989 3985 3973 2 1 XNR2HS $T=868620 386960 0 180 $X=863040 $Y=381540
X3307 4002 3985 3906 2 1 XNR2HS $T=870480 386960 1 180 $X=864900 $Y=386580
X3308 4016 3985 3886 2 1 XNR2HS $T=872340 397040 1 180 $X=866760 $Y=396660
X3309 4044 4045 4055 2 1 XNR2HS $T=874820 457520 0 0 $X=874820 $Y=457140
X3310 4080 4093 4086 2 1 XNR2HS $T=885980 457520 1 0 $X=885980 $Y=452100
X3311 884 886 891 2 1 XNR2HS $T=887840 497840 1 0 $X=887840 $Y=492420
X3312 4115 4102 4111 2 1 XNR2HS $T=892800 467600 0 0 $X=892800 $Y=467220
X3313 4214 4173 4236 2 1 XNR2HS $T=918220 447440 1 0 $X=918220 $Y=442020
X3314 4282 4275 4315 2 1 XNR2HS $T=928140 417200 1 0 $X=928140 $Y=411780
X3315 4336 4331 4356 2 1 XNR2HS $T=936820 407120 0 0 $X=936820 $Y=406740
X3316 4897 4851 4910 2 1 XNR2HS $T=1042840 497840 1 0 $X=1042840 $Y=492420
X3317 5007 4516 4998 2 1 XNR2HS $T=1068880 417200 1 180 $X=1063300 $Y=416820
X3318 4890 5001 4999 2 1 XNR2HS $T=1063920 447440 0 0 $X=1063920 $Y=447060
X3319 5020 4516 5030 2 1 XNR2HS $T=1070120 417200 1 0 $X=1070120 $Y=411780
X3320 5040 4516 5026 2 1 XNR2HS $T=1077560 427280 0 180 $X=1071980 $Y=421860
X3321 4896 5032 5039 2 1 XNR2HS $T=1072600 447440 1 0 $X=1072600 $Y=442020
X3322 46 1512 2 1 1436 OR2 $T=250480 487760 1 0 $X=250480 $Y=482340
X3323 1875 1818 2 1 1408 OR2 $T=326120 417200 1 180 $X=323640 $Y=416820
X3324 1862 1818 2 1 1453 OR2 $T=326120 427280 0 180 $X=323640 $Y=421860
X3325 227 232 2 1 1966 OR2 $T=347820 487760 0 0 $X=347820 $Y=487380
X3326 2690 2679 2 1 2655 OR2 $T=573500 366800 1 180 $X=571020 $Y=366420
X3327 854 885 2 1 818 OR2 $T=888460 356720 0 0 $X=888460 $Y=356340
X3328 896 250 2 1 4134 OR2 $T=894040 407120 0 0 $X=894040 $Y=406740
X3329 887 4051 2 1 972 OR2 $T=931860 336560 1 0 $X=931860 $Y=331140
X3330 4335 4320 2 1 4314 OR2 $T=934960 376880 1 180 $X=932480 $Y=376500
X3331 896 250 2 1 4359 OR2 $T=936820 417200 1 0 $X=936820 $Y=411780
X3332 877 4216 2 1 985 OR2 $T=938060 366800 0 0 $X=938060 $Y=366420
X3333 4202 4188 2 1 992 OR2 $T=946120 356720 1 180 $X=943640 $Y=356340
X3334 4279 922 2 1 833 OR2 $T=949220 356720 0 0 $X=949220 $Y=356340
X3335 4479 1032 2 1 4475 OR2 $T=967820 336560 0 180 $X=965340 $Y=331140
X3336 1063 4543 2 1 1082 OR2 $T=988900 356720 0 0 $X=988900 $Y=356340
X3337 1020 4517 2 1 1094 OR2 $T=991380 336560 0 0 $X=991380 $Y=336180
X3338 1044 1095 2 1 4631 OR2 $T=994480 336560 0 0 $X=994480 $Y=336180
X3339 4762 4636 2 1 1221 OR2 $T=1044080 356720 1 0 $X=1044080 $Y=351300
X3340 4592 1110 2 1 4976 OR2 $T=1064540 346640 0 0 $X=1064540 $Y=346260
X3341 1368 14 1 1340 10 1335 2 MOAI1S $T=225680 477680 1 180 $X=221960 $Y=477300
X3342 37 1403 1 1437 1441 1447 2 MOAI1S $T=237460 397040 0 0 $X=237460 $Y=396660
X3343 1375 1423 1 59 30 1460 2 MOAI1S $T=239320 407120 1 0 $X=239320 $Y=401700
X3344 55 1471 1 1380 1408 1488 2 MOAI1S $T=243040 477680 1 0 $X=243040 $Y=472260
X3345 1472 1440 1 1508 1453 1493 2 MOAI1S $T=252960 397040 1 180 $X=249240 $Y=396660
X3346 1423 1499 1 84 36 1536 2 MOAI1S $T=251720 427280 1 0 $X=251720 $Y=421860
X3347 1349 1326 1 10 1389 1543 2 MOAI1S $T=253580 397040 0 0 $X=253580 $Y=396660
X3348 1483 1390 1 92 1539 1533 2 MOAI1S $T=253580 457520 1 0 $X=253580 $Y=452100
X3349 1522 103 1 1572 1563 1376 2 MOAI1S $T=264120 407120 1 180 $X=260400 $Y=406740
X3350 1457 1610 1 1601 1572 1570 2 MOAI1S $T=269700 397040 0 180 $X=265980 $Y=391620
X3351 1349 1604 1 1572 1618 1514 2 MOAI1S $T=267220 386960 0 0 $X=267220 $Y=386580
X3352 1555 40 1 135 88 1647 2 MOAI1S $T=274040 467600 1 0 $X=274040 $Y=462180
X3353 1349 1604 1 1464 1494 1656 2 MOAI1S $T=277140 397040 1 0 $X=277140 $Y=391620
X3354 150 1682 1 1480 1409 1659 2 MOAI1S $T=283340 477680 0 180 $X=279620 $Y=472260
X3355 1523 1476 1 1634 1572 1721 2 MOAI1S $T=288300 397040 0 0 $X=288300 $Y=396660
X3356 25 166 1 1620 1491 1732 2 MOAI1S $T=290780 447440 1 0 $X=290780 $Y=442020
X3357 168 37 1 1680 16 1725 2 MOAI1S $T=295740 447440 1 180 $X=292020 $Y=447060
X3358 156 150 1 10 1642 1724 2 MOAI1S $T=297600 467600 1 180 $X=293880 $Y=467220
X3359 1483 1772 1 1426 1365 1599 2 MOAI1S $T=303800 437360 0 180 $X=300080 $Y=431940
X3360 1368 182 1 79 22 171 2 MOAI1S $T=303800 487760 1 180 $X=300080 $Y=487380
X3361 1522 103 1 1534 1786 1788 2 MOAI1S $T=303180 407120 1 0 $X=303180 $Y=401700
X3362 55 1886 1 111 39 1897 2 MOAI1S $T=327360 477680 0 0 $X=327360 $Y=477300
X3363 1952 1957 1 1903 1911 1937 2 MOAI1S $T=347820 437360 0 180 $X=344100 $Y=431940
X3364 1958 1950 1 241 1967 1969 2 MOAI1S $T=347820 427280 0 0 $X=347820 $Y=426900
X3365 1964 220 1 232 1976 1986 2 MOAI1S $T=353400 487760 1 0 $X=353400 $Y=482340
X3366 235 245 1 1976 238 1997 2 MOAI1S $T=358360 467600 1 0 $X=358360 $Y=462180
X3367 2498 417 1 424 417 2525 2 MOAI1S $T=531960 407120 0 0 $X=531960 $Y=406740
X3368 2546 441 1 437 2531 2523 2 MOAI1S $T=546220 487760 1 180 $X=542500 $Y=487380
X3369 2548 441 1 437 2541 435 2 MOAI1S $T=546220 497840 0 180 $X=542500 $Y=492420
X3370 451 2546 1 445 444 2528 2 MOAI1S $T=550560 487760 1 180 $X=546840 $Y=487380
X3371 451 2548 1 448 444 2313 2 MOAI1S $T=551800 497840 0 180 $X=548080 $Y=492420
X3372 2590 441 1 437 2578 2576 2 MOAI1S $T=554900 487760 1 180 $X=551180 $Y=487380
X3373 451 2590 1 453 444 340 2 MOAI1S $T=555520 497840 0 180 $X=551800 $Y=492420
X3374 451 2610 1 456 444 2296 2 MOAI1S $T=559240 497840 0 180 $X=555520 $Y=492420
X3375 2610 441 1 437 2625 2630 2 MOAI1S $T=559240 497840 1 0 $X=559240 $Y=492420
X3376 2646 451 1 466 444 2345 2 MOAI1S $T=566680 497840 0 180 $X=562960 $Y=492420
X3377 2646 441 1 437 2641 2685 2 MOAI1S $T=569160 487760 0 0 $X=569160 $Y=487380
X3378 2691 441 1 2691 437 2731 2 MOAI1S $T=573500 487760 0 0 $X=573500 $Y=487380
X3379 3885 788 1 3908 783 3893 2 MOAI1S $T=851260 356720 1 180 $X=847540 $Y=356340
X3380 802 800 1 796 795 3926 2 MOAI1S $T=856840 336560 1 180 $X=853120 $Y=336180
X3381 3949 3905 1 814 818 3959 2 MOAI1S $T=859940 346640 0 0 $X=859940 $Y=346260
X3382 823 3977 1 3981 834 3970 2 MOAI1S $T=864280 376880 1 0 $X=864280 $Y=371460
X3383 809 3997 1 783 833 3974 2 MOAI1S $T=869860 366800 1 180 $X=866140 $Y=366420
X3384 824 3980 1 838 847 4026 2 MOAI1S $T=869240 356720 1 0 $X=869240 $Y=351300
X3385 3949 3905 1 822 843 4034 2 MOAI1S $T=871100 346640 0 0 $X=871100 $Y=346260
X3386 816 851 1 854 857 4054 2 MOAI1S $T=872960 336560 0 0 $X=872960 $Y=336180
X3387 238 899 1 245 4131 4122 2 MOAI1S $T=892800 397040 1 0 $X=892800 $Y=391620
X3388 829 4141 1 4144 885 4164 2 MOAI1S $T=896520 376880 1 0 $X=896520 $Y=371460
X3389 815 889 1 837 793 4192 2 MOAI1S $T=902720 356720 0 0 $X=902720 $Y=356340
X3390 816 904 1 887 810 4215 2 MOAI1S $T=907680 356720 1 0 $X=907680 $Y=351300
X3391 4202 4200 1 4088 4203 4208 2 MOAI1S $T=913260 397040 0 180 $X=909540 $Y=391620
X3392 4202 241 1 4252 4088 4264 2 MOAI1S $T=923800 397040 0 180 $X=920080 $Y=391620
X3393 896 4300 1 4315 4300 4319 2 MOAI1S $T=930000 407120 0 0 $X=930000 $Y=406740
X3394 4415 4372 1 4394 4372 4398 2 MOAI1S $T=956040 397040 0 180 $X=952320 $Y=391620
X3395 1020 1012 1 4411 4426 4413 2 MOAI1S $T=959140 366800 1 180 $X=955420 $Y=366420
X3396 1020 1024 1 4426 4440 4439 2 MOAI1S $T=962860 366800 1 180 $X=959140 $Y=366420
X3397 826 821 1 854 1028 4452 2 MOAI1S $T=961000 326480 0 0 $X=961000 $Y=326100
X3398 1029 1030 1 245 4455 4450 2 MOAI1S $T=964720 366800 0 180 $X=961000 $Y=361380
X3399 1088 4605 1 4571 4569 4588 2 MOAI1S $T=991380 397040 0 180 $X=987660 $Y=391620
X3400 4462 4621 1 4557 4631 4647 2 MOAI1S $T=993240 386960 1 0 $X=993240 $Y=381540
X3401 1068 4623 1 4633 4625 4610 2 MOAI1S $T=998820 407120 1 180 $X=995100 $Y=406740
X3402 4646 4658 1 1004 1116 4686 2 MOAI1S $T=1001300 346640 0 0 $X=1001300 $Y=346260
X3403 4690 4687 1 4537 1111 4665 2 MOAI1S $T=1005640 376880 1 180 $X=1001920 $Y=376500
X3404 4690 4687 1 1115 1105 4661 2 MOAI1S $T=1006260 366800 0 180 $X=1002540 $Y=361380
X3405 4662 4706 1 4705 4557 4696 2 MOAI1S $T=1010600 397040 1 180 $X=1006880 $Y=396660
X3406 1064 1138 1 4667 4728 4770 2 MOAI1S $T=1017420 376880 0 0 $X=1017420 $Y=376500
X3407 4777 1101 1 1158 1094 4789 2 MOAI1S $T=1027960 346640 0 180 $X=1024240 $Y=341220
X3408 1068 4619 1 4557 1120 4792 2 MOAI1S $T=1027960 397040 1 180 $X=1024240 $Y=396660
X3409 1163 4808 1 4537 4776 4796 2 MOAI1S $T=1029200 336560 0 180 $X=1025480 $Y=331140
X3410 1088 1160 1 4742 1078 4812 2 MOAI1S $T=1025480 386960 0 0 $X=1025480 $Y=386580
X3411 1138 4591 1 4654 4833 4837 2 MOAI1S $T=1029200 376880 0 0 $X=1029200 $Y=376500
X3412 4619 1178 1 4582 4728 4844 2 MOAI1S $T=1037260 407120 0 180 $X=1033540 $Y=401700
X3413 4646 4924 1 4762 4590 4949 2 MOAI1S $T=1047180 386960 1 0 $X=1047180 $Y=381540
X3414 4623 4674 1 4582 4728 4950 2 MOAI1S $T=1049040 407120 1 0 $X=1049040 $Y=401700
X3415 4777 4922 1 4654 4727 4934 2 MOAI1S $T=1053380 376880 1 180 $X=1049660 $Y=376500
X3416 4858 4579 1 1004 1262 5045 2 MOAI1S $T=1075080 356720 0 0 $X=1075080 $Y=356340
X3417 4777 4623 1 1269 1129 5064 2 MOAI1S $T=1080660 336560 0 0 $X=1080660 $Y=336180
X3418 5011 4721 1 1271 1158 5055 2 MOAI1S $T=1080660 366800 0 0 $X=1080660 $Y=366420
X3419 1268 1276 1 4631 1273 5081 2 MOAI1S $T=1083760 326480 0 0 $X=1083760 $Y=326100
X3420 4922 4721 1 4666 1120 5090 2 MOAI1S $T=1085620 386960 1 0 $X=1085620 $Y=381540
X3421 1387 1344 1 1348 11 2 1324 1334 1328 OAI222S $T=226920 467600 0 180 $X=221340 $Y=462180
X3422 1324 1328 1 1346 11 2 1358 1332 20 OAI222S $T=221960 477680 1 0 $X=221960 $Y=472260
X3423 1377 22 1 1325 1361 2 1357 1350 4 OAI222S $T=230020 457520 0 180 $X=224440 $Y=452100
X3424 68 67 1 1467 1463 2 1325 1455 36 OAI222S $T=246760 457520 1 180 $X=241180 $Y=457140
X3425 79 47 1 1380 1389 2 1408 1495 16 OAI222S $T=253580 467600 1 180 $X=248000 $Y=467220
X3426 95 104 1 1622 1534 2 107 1557 1621 OAI222S $T=268460 447440 0 0 $X=268460 $Y=447060
X3427 1637 1328 1 1624 1621 2 1501 1619 1409 OAI222S $T=274660 447440 0 180 $X=269080 $Y=442020
X3428 1534 1635 1 127 11 2 1463 132 1453 OAI222S $T=275900 457520 1 180 $X=270320 $Y=457140
X3429 1733 1534 1 1630 1379 2 1546 1719 1618 OAI222S $T=295740 397040 0 180 $X=290160 $Y=391620
X3430 1627 1385 1 1642 1352 2 1643 1741 1441 OAI222S $T=299460 417200 0 180 $X=293880 $Y=411780
X3431 1473 47 1 1482 36 2 104 196 140 OAI222S $T=306280 477680 1 0 $X=306280 $Y=472260
X3432 22 1800 1 1620 1365 2 1482 1666 8 OAI222S $T=313720 447440 0 180 $X=308140 $Y=442020
X3433 10 1453 1 1441 1385 2 107 1825 1621 OAI222S $T=316820 447440 1 180 $X=311240 $Y=447060
X3434 1836 1494 1 1645 1822 2 1816 1829 1813 OAI222S $T=318060 407120 1 180 $X=312480 $Y=406740
X3435 1572 1738 1 1860 1546 2 1842 1840 1534 OAI222S $T=325500 397040 1 180 $X=319920 $Y=396660
X3436 1643 1873 1 1508 1862 2 1861 1857 1385 OAI222S $T=327360 417200 0 180 $X=321780 $Y=411780
X3437 1734 1925 1 1924 1539 2 1921 1923 1365 OAI222S $T=341620 417200 1 180 $X=336040 $Y=416820
X3438 796 831 1 837 840 2 842 3969 845 OAI222S $T=865520 336560 0 0 $X=865520 $Y=336180
X3439 873 4051 1 837 840 2 845 4062 830 OAI222S $T=884740 346640 1 180 $X=879160 $Y=346260
X3440 822 875 1 877 827 2 810 4092 833 OAI222S $T=882880 356720 1 0 $X=882880 $Y=351300
X3441 873 875 1 887 842 2 818 3931 894 OAI222S $T=887220 346640 1 0 $X=887220 $Y=341220
X3442 4125 4149 1 4146 4107 2 245 4151 4132 OAI222S $T=901480 386960 1 180 $X=895900 $Y=386580
X3443 893 834 1 925 838 2 920 4210 901 OAI222S $T=904580 336560 1 0 $X=904580 $Y=331140
X3444 4263 810 1 954 796 2 4278 4167 877 OAI222S $T=920080 366800 0 0 $X=920080 $Y=366420
X3445 4480 4470 1 1039 4509 2 245 4492 4497 OAI222S $T=977120 366800 0 180 $X=971540 $Y=361380
X3446 4514 4590 1 1049 4582 2 4573 4587 1063 OAI222S $T=990140 346640 0 180 $X=984560 $Y=341220
X3447 4582 4727 1 4666 1136 2 4592 4695 4642 OAI222S $T=1011840 386960 1 0 $X=1011840 $Y=381540
X3448 4625 1057 1 1142 1143 2 4762 4765 4710 OAI222S $T=1015560 356720 1 0 $X=1015560 $Y=351300
X3449 4637 4569 1 4847 4654 2 1070 4845 4823 OAI222S $T=1036020 366800 1 180 $X=1030440 $Y=366420
X3450 4698 4540 1 4764 4667 2 1193 4900 1158 OAI222S $T=1036640 366800 0 0 $X=1036640 $Y=366420
X3451 1209 4655 1 4762 4592 2 1105 4920 1205 OAI222S $T=1052140 356720 1 180 $X=1046560 $Y=356340
X3452 4537 4655 1 1063 4707 2 4590 4931 4631 OAI222S $T=1052140 366800 1 180 $X=1046560 $Y=366420
X3453 1209 4636 1 4666 1136 2 4642 4967 4667 OAI222S $T=1057100 376880 1 0 $X=1057100 $Y=371460
X3454 1270 1158 1 4625 1063 2 4823 5029 4540 OAI222S $T=1078180 366800 0 180 $X=1072600 $Y=361380
X3455 4592 4537 1 4642 4667 2 4666 5059 1120 OAI222S $T=1078180 386960 1 0 $X=1078180 $Y=381540
X3456 1232 1281 1 1255 4537 2 5061 5080 4642 OAI222S $T=1088720 326480 0 0 $X=1088720 $Y=326100
X3457 1670 2 103 1 42 NR2P $T=281480 447440 0 0 $X=281480 $Y=447060
X3458 2555 2 2694 1 2665 NR2P $T=579080 366800 1 0 $X=579080 $Y=361380
X3459 517 2 482 1 519 NR2P $T=614420 376880 1 180 $X=610700 $Y=376500
X3460 4084 2 4057 1 4097 NR2P $T=889080 467600 0 0 $X=889080 $Y=467220
X3461 4110 2 3659 1 4173 NR2P $T=898380 437360 1 0 $X=898380 $Y=431940
X3462 4263 2 922 1 802 NR2P $T=949220 356720 1 0 $X=949220 $Y=351300
X3463 3955 2 678 1 4599 NR2P $T=983320 427280 1 180 $X=979600 $Y=426900
X3464 4514 2 1095 1 4623 NR2P $T=993860 346640 0 180 $X=990140 $Y=341220
X3465 3910 2 1090 1 4615 NR2P $T=995100 477680 0 180 $X=991380 $Y=472260
X3466 3955 2 1108 1 4648 NR2P $T=998200 457520 1 0 $X=998200 $Y=452100
X3467 3910 2 1108 1 4681 NR2P $T=1005640 487760 0 180 $X=1001920 $Y=482340
X3468 3910 2 1098 1 4709 NR2P $T=1009360 477680 0 180 $X=1005640 $Y=472260
X3469 4804 2 4739 1 4821 NR2P $T=1029200 487760 0 180 $X=1025480 $Y=482340
X3470 4804 2 1125 1 4851 NR2P $T=1036020 487760 1 180 $X=1032300 $Y=487380
X3471 4804 2 1182 1 4881 NR2P $T=1039740 487760 1 180 $X=1036020 $Y=487380
X3472 3068 2768 1 2 BUF2 $T=660300 376880 1 180 $X=657200 $Y=376500
X3473 3068 648 1 2 BUF2 $T=737180 386960 0 0 $X=737180 $Y=386580
X3474 3841 741 1 2 BUF2 $T=832660 336560 1 0 $X=832660 $Y=331140
X3475 5087 4174 1 2 BUF2 $T=1089960 437360 1 180 $X=1086860 $Y=436980
X3476 879 908 4149 893 862 915 2 1 4163 OA222S $T=897140 356720 0 0 $X=897140 $Y=356340
X3477 4203 3981 4146 4135 4188 920 2 1 4157 OA222S $T=908920 366800 1 180 $X=903340 $Y=366420
X3478 4440 4571 1039 4574 4517 1070 2 1 4597 OA222S $T=983320 356720 1 0 $X=983320 $Y=351300
X3479 1076 1099 4470 4637 1083 1103 2 1 4601 OA222S $T=994480 346640 0 0 $X=994480 $Y=346260
X3480 4631 4557 1126 1144 1092 4563 2 1 4788 OA222S $T=1016800 336560 0 0 $X=1016800 $Y=336180
X3481 1143 1094 1087 4563 4631 4666 2 1 4786 OA222S $T=1018660 346640 1 0 $X=1018660 $Y=341220
X3482 1198 1105 1201 1133 4563 1048 2 1 4898 OA222S $T=1041600 336560 0 0 $X=1041600 $Y=336180
X3483 1347 1338 1 1330 2 1322 OAI12HS $T=225060 427280 0 180 $X=221340 $Y=421860
X3484 104 1525 1 99 2 1540 OAI12HS $T=261020 467600 0 180 $X=257300 $Y=462180
X3485 1364 1476 1 1401 2 1592 OAI12HS $T=267840 407120 1 180 $X=264120 $Y=406740
X3486 1670 96 1 1522 2 1665 OAI12HS $T=281480 467600 1 180 $X=277760 $Y=467220
X3487 1945 1876 1 1912 2 1926 OAI12HS $T=344720 457520 0 180 $X=341000 $Y=452100
X3488 3336 604 1 3355 2 3322 OAI12HS $T=728500 467600 1 0 $X=728500 $Y=462180
X3489 3994 3984 1 3979 2 3978 OAI12HS $T=868620 467600 1 180 $X=864900 $Y=467220
X3490 4028 223 1 4056 2 4068 OAI12HS $T=882880 407120 0 180 $X=879160 $Y=401700
X3491 4068 4083 1 4090 2 3983 OAI12HS $T=883500 407120 1 0 $X=883500 $Y=401700
X3492 4068 4101 1 4090 2 3996 OAI12HS $T=889080 407120 1 0 $X=889080 $Y=401700
X3493 851 775 1 802 2 950 OAI12HS $T=923180 336560 0 180 $X=919460 $Y=331140
X3494 4457 4446 1 4442 2 4437 OAI12HS $T=962860 397040 0 180 $X=959140 $Y=391620
X3495 4457 4474 1 4442 2 4464 OAI12HS $T=967200 397040 0 180 $X=963480 $Y=391620
X3496 4494 223 1 4466 2 4457 OAI12HS $T=967200 397040 1 180 $X=963480 $Y=396660
X3497 4658 1178 1 4623 2 5067 OAI12HS $T=1080660 346640 1 0 $X=1080660 $Y=341220
X3498 102 1568 105 107 2 20 1 AOI13HS $T=261020 497840 1 0 $X=261020 $Y=492420
X3499 136 1617 130 127 2 47 1 AOI13HS $T=274660 477680 1 180 $X=270940 $Y=477300
X3500 1877 1980 1907 225 2 1845 1 AOI13HS $T=353400 437360 0 0 $X=353400 $Y=436980
X3501 1880 1984 1986 241 2 1522 1 AOI13HS $T=354640 477680 1 0 $X=354640 $Y=472260
X3502 4142 4131 238 4148 2 4154 1 AOI13HS $T=897140 397040 1 0 $X=897140 $Y=391620
X3503 4186 4177 241 245 2 910 1 AOI13HS $T=905200 397040 1 180 $X=901480 $Y=396660
X3504 4471 4455 1029 4444 2 1025 1 AOI13HS $T=965340 356720 0 180 $X=961620 $Y=351300
X3505 4468 4463 1012 245 2 1033 1 AOI13HS $T=964100 366800 0 0 $X=964100 $Y=366420
X3506 794 1 3932 3940 3950 2 ND3S $T=853740 366800 1 0 $X=853740 $Y=361380
X3507 3501 1 4032 3985 4046 2 ND3S $T=873580 397040 0 0 $X=873580 $Y=396660
X3508 4185 1 827 4172 917 2 ND3S $T=905200 346640 1 180 $X=902720 $Y=346260
X3509 4436 1 4439 4453 1012 2 ND3S $T=958520 376880 0 0 $X=958520 $Y=376500
X3510 4595 1 4589 4544 4585 2 ND3S $T=988900 407120 0 180 $X=986420 $Y=401700
X3511 4577 1 4707 4704 1127 2 ND3S $T=1008120 376880 1 0 $X=1008120 $Y=371460
X3512 4767 1 1145 4760 4755 2 ND3S $T=1020520 386960 1 180 $X=1018040 $Y=386580
X3513 4819 1 1186 4870 4864 2 ND3S $T=1037260 397040 1 0 $X=1037260 $Y=391620
X3514 16 1354 1327 1343 4 9 1 2 5 OA222 $T=226920 447440 0 180 $X=221340 $Y=442020
X3515 1380 1370 1389 1342 30 1399 1 2 1411 OA222 $T=228780 407120 1 0 $X=228780 $Y=401700
X3516 1344 1360 1389 10 36 1408 1 2 1421 OA222 $T=229400 427280 0 0 $X=229400 $Y=426900
X3517 16 1412 1409 38 1382 8 1 2 1381 OA222 $T=236220 447440 0 180 $X=230640 $Y=442020
X3518 1441 10 1426 1427 1453 1450 1 2 1442 OA222 $T=245520 427280 0 180 $X=239940 $Y=421860
X3519 68 70 4 73 1491 1484 1 2 1506 OA222 $T=244900 467600 1 0 $X=244900 $Y=462180
X3520 23 11 1494 1482 19 30 1 2 1515 OA222 $T=246760 457520 1 0 $X=246760 $Y=452100
X3521 30 42 67 88 90 22 1 2 1530 OA222 $T=251720 457520 0 0 $X=251720 $Y=457140
X3522 11 80 1494 1551 1526 1412 1 2 1569 OA222 $T=256060 447440 1 0 $X=256060 $Y=442020
X3523 1546 1563 1380 1412 104 56 1 2 1577 OA222 $T=259160 437360 1 0 $X=259160 $Y=431940
X3524 114 1596 36 1603 68 1612 1 2 1600 OA222 $T=264740 477680 1 0 $X=264740 $Y=472260
X3525 1385 1426 1409 105 1534 1616 1 2 119 OA222 $T=273420 467600 0 180 $X=267840 $Y=462180
X3526 1618 1534 1626 1546 1379 1426 1 2 1586 OA222 $T=274660 386960 0 180 $X=269080 $Y=381540
X3527 1635 1546 104 131 1385 1627 1 2 1611 OA222 $T=276520 437360 1 180 $X=270940 $Y=436980
X3528 4 129 1385 1340 30 1625 1 2 1650 OA222 $T=271560 467600 0 0 $X=271560 $Y=467220
X3529 1382 1379 130 1559 88 136 1 2 1651 OA222 $T=272800 477680 1 0 $X=272800 $Y=472260
X3530 1672 1534 1491 1680 1385 1630 1 2 1558 OA222 $T=285200 417200 1 180 $X=279620 $Y=416820
X3531 1701 1572 1464 1644 114 1678 1 2 1595 OA222 $T=286440 427280 0 180 $X=280860 $Y=421860
X3532 8 1464 1701 1546 1626 1572 1 2 1686 OA222 $T=288920 397040 0 180 $X=283340 $Y=391620
X3533 88 1702 30 1520 1344 1708 1 2 1718 OA222 $T=284580 477680 1 0 $X=284580 $Y=472260
X3534 1344 1528 11 158 22 1486 1 2 1722 OA222 $T=286440 457520 0 0 $X=286440 $Y=457140
X3535 30 44 11 165 104 1715 1 2 1542 OA222 $T=293880 477680 1 180 $X=288300 $Y=477300
X3536 1534 1738 1382 1365 1389 1643 1 2 1454 OA222 $T=298220 427280 0 180 $X=292640 $Y=421860
X3537 92 170 1408 1712 1379 1642 1 2 1632 OA222 $T=298220 437360 0 180 $X=292640 $Y=431940
X3538 1463 1426 1382 1491 1738 1546 1 2 1763 OA222 $T=294500 427280 0 0 $X=294500 $Y=426900
X3539 22 44 1382 154 88 165 1 2 1752 OA222 $T=294500 477680 1 0 $X=294500 $Y=472260
X3540 1453 1365 1344 1627 114 175 1 2 1754 OA222 $T=295120 457520 1 0 $X=295120 $Y=452100
X3541 1379 1426 1441 1365 1389 8 1 2 1779 OA222 $T=299460 447440 0 0 $X=299460 $Y=447060
X3542 1385 1387 22 180 88 179 1 2 1743 OA222 $T=305040 457520 1 180 $X=299460 $Y=457140
X3543 22 79 1534 1616 4 152 1 2 1758 OA222 $T=305660 477680 0 180 $X=300080 $Y=472260
X3544 20 1755 36 1760 11 184 1 2 1765 OA222 $T=307520 487760 0 180 $X=301940 $Y=482340
X3545 140 30 1385 1426 19 104 1 2 1797 OA222 $T=305040 447440 0 0 $X=305040 $Y=447060
X3546 1546 1578 104 107 1737 1534 1 2 1782 OA222 $T=311860 427280 0 180 $X=306280 $Y=421860
X3547 140 30 1738 1572 16 1464 1 2 1691 OA222 $T=312480 427280 1 180 $X=306900 $Y=426900
X3548 1453 1643 1572 1794 88 199 1 2 1780 OA222 $T=316820 457520 0 180 $X=311240 $Y=452100
X3549 23 114 8 1620 188 68 1 2 1814 OA222 $T=317440 467600 1 180 $X=311860 $Y=467220
X3550 68 207 1453 1843 4 1833 1 2 1830 OA222 $T=322400 457520 1 180 $X=316820 $Y=457140
X3551 114 111 1409 1449 1534 1794 1 2 1839 OA222 $T=323640 467600 1 180 $X=318060 $Y=467220
X3552 1534 1847 1409 1851 23 1850 1 2 1768 OA222 $T=318680 477680 1 0 $X=318680 $Y=472260
X3553 1464 170 1546 1870 1572 1859 1 2 208 OA222 $T=327980 386960 1 180 $X=322400 $Y=386580
X3554 1902 1789 30 210 170 1888 1 2 1881 OA222 $T=332940 417200 1 180 $X=327360 $Y=416820
X3555 839 827 840 843 822 838 1 2 771 OA222 $T=872340 346640 0 180 $X=866760 $Y=341220
X3556 4051 795 856 853 842 850 1 2 3975 OA222 $T=877920 336560 0 180 $X=872340 $Y=331140
X3557 868 793 833 4103 825 871 1 2 782 OA222 $T=888460 346640 0 0 $X=888460 $Y=346260
X3558 831 893 4098 3891 833 890 1 2 4085 OA222 $T=895280 336560 1 180 $X=889700 $Y=336180
X3559 807 887 793 893 810 858 1 2 3950 OA222 $T=895280 356720 0 180 $X=889700 $Y=351300
X3560 4051 822 898 818 4124 877 1 2 4136 OA222 $T=891560 356720 0 0 $X=891560 $Y=356340
X3561 873 797 4051 926 827 862 1 2 3907 OA222 $T=910780 346640 0 180 $X=905200 $Y=341220
X3562 4191 927 4201 4204 881 932 1 2 4193 OA222 $T=906440 356720 0 0 $X=906440 $Y=356340
X3563 882 4219 844 4212 872 4205 1 2 4178 OA222 $T=913260 376880 0 180 $X=907680 $Y=371460
X3564 4203 4088 4251 4243 4242 4113 1 2 4258 OA222 $T=915740 386960 0 0 $X=915740 $Y=386580
X3565 797 4281 4279 4261 4207 4271 1 2 4184 OA222 $T=926280 376880 0 180 $X=920700 $Y=371460
X3566 795 4103 873 797 831 796 1 2 991 OA222 $T=938060 336560 0 0 $X=938060 $Y=336180
X3567 4106 4361 822 4367 834 4373 1 2 997 OA222 $T=941160 346640 0 0 $X=941160 $Y=346260
X3568 4440 4426 4432 4384 1016 4424 1 2 4404 OA222 $T=959760 376880 0 180 $X=954180 $Y=371460
X3569 4540 4547 1044 4549 1047 4560 1 2 4566 OA222 $T=978980 346640 1 0 $X=978980 $Y=341220
X3570 4487 1061 4559 4541 1062 1066 1 2 4576 OA222 $T=980840 326480 0 0 $X=980840 $Y=326100
X3571 4636 4537 1102 1105 4531 1063 1 2 4657 OA222 $T=996340 356720 0 0 $X=996340 $Y=356340
X3572 1073 1129 1102 1126 4707 1083 1 2 4711 OA222 $T=1014940 336560 1 180 $X=1009360 $Y=336180
X3573 1120 4557 1133 1099 4633 4735 1 2 4747 OA222 $T=1011840 346640 1 0 $X=1011840 $Y=341220
X3574 4636 4728 4633 4735 4592 4742 1 2 4745 OA222 $T=1011840 386960 0 0 $X=1011840 $Y=386580
X3575 4633 1095 1129 1137 1136 4710 1 2 4755 OA222 $T=1013080 346640 0 0 $X=1013080 $Y=346260
X3576 4710 1120 4631 4744 4563 1053 1 2 4708 OA222 $T=1019280 376880 0 180 $X=1013700 $Y=371460
X3577 1078 4762 1120 4637 4590 4764 1 2 4585 OA222 $T=1023620 397040 0 180 $X=1018040 $Y=391620
X3578 4727 4637 4794 4675 4631 4776 1 2 4740 OA222 $T=1027340 356720 0 180 $X=1021760 $Y=351300
X3579 4546 4783 4537 4713 4569 4798 1 2 4800 OA222 $T=1021760 376880 0 0 $X=1021760 $Y=376500
X3580 1078 4833 1136 4741 1129 1176 1 2 4866 OA222 $T=1031060 346640 0 0 $X=1031060 $Y=346260
X3581 1084 4707 1136 1111 4537 4654 1 2 4895 OA222 $T=1040360 376880 0 0 $X=1040360 $Y=376500
X3582 1209 4540 4636 1110 4707 1083 1 2 4907 OA222 $T=1049660 346640 1 180 $X=1044080 $Y=346260
X3583 4728 4744 1209 4540 4727 4582 1 2 1216 OA222 $T=1045320 366800 1 0 $X=1045320 $Y=361380
X3584 4537 4540 1136 4582 1111 1120 1 2 1225 OA222 $T=1049040 346640 1 0 $X=1049040 $Y=341220
X3585 1111 4764 4655 4985 4666 4847 1 2 4969 OA222 $T=1063920 356720 0 180 $X=1058340 $Y=351300
X3586 1111 4985 1110 4655 1143 1244 1 2 4948 OA222 $T=1062680 336560 1 0 $X=1062680 $Y=331140
X3587 1210 1158 1198 1243 4631 4592 1 2 4962 OA222 $T=1068260 336560 1 180 $X=1062680 $Y=336180
X3588 1210 1126 4537 5010 1143 1247 1 2 4979 OA222 $T=1071360 346640 0 180 $X=1065780 $Y=341220
X3589 4666 4569 1198 1105 4631 4655 1 2 5048 OA222 $T=1074460 336560 0 0 $X=1074460 $Y=336180
X3590 1273 4728 4633 1263 1261 1004 1 2 1259 OA222 $T=1081280 336560 0 180 $X=1075700 $Y=331140
X3591 5031 4728 1143 1267 1136 4994 1 2 5070 OA222 $T=1078800 346640 0 0 $X=1078800 $Y=346260
X3592 1381 1369 1386 2 1 1410 AN3 $T=228780 427280 1 0 $X=228780 $Y=421860
X3593 72 1396 1339 2 1 1469 AN3 $T=247380 386960 1 180 $X=243660 $Y=386580
X3594 93 85 1475 2 1 83 AN3 $T=254820 497840 0 180 $X=251100 $Y=492420
X3595 1566 1576 1573 2 1 1588 AN3 $T=261020 407120 1 0 $X=261020 $Y=401700
X3596 1564 1579 1461 2 1 1589 AN3 $T=262880 447440 1 0 $X=262880 $Y=442020
X3597 1593 1608 1602 2 1 1461 AN3 $T=269700 427280 1 180 $X=265980 $Y=426900
X3598 1715 152 1473 2 1 1685 AN3 $T=287680 487760 1 180 $X=283960 $Y=487380
X3599 1709 1688 1421 2 1 1723 AN3 $T=288920 437360 1 0 $X=288920 $Y=431940
X3600 1780 1722 1770 2 1 1564 AN3 $T=305040 457520 0 180 $X=301320 $Y=452100
X3601 1796 1785 194 2 1 1812 AN3 $T=308140 467600 1 0 $X=308140 $Y=462180
X3602 1940 206 1845 2 1 78 AN3 $T=344100 447440 1 180 $X=340380 $Y=447060
X3603 1965 206 1960 2 1 1945 AN3 $T=350300 457520 1 180 $X=346580 $Y=457140
X3604 458 2586 406 2 1 2631 AN3 $T=559240 477680 0 0 $X=559240 $Y=477300
X3605 3935 3920 3925 2 1 790 AN3 $T=855600 336560 0 180 $X=851880 $Y=331140
X3606 3909 883 4121 2 1 4133 AN3 $T=892180 487760 1 0 $X=892180 $Y=482340
X3607 3924 4126 3524 2 1 4270 AN3 $T=916360 437360 0 0 $X=916360 $Y=436980
X3608 954 4263 4188 2 1 4341 AN3 $T=945500 366800 1 180 $X=941780 $Y=366420
X3609 1049 4514 4517 2 1 4511 AN3 $T=978360 336560 1 180 $X=974640 $Y=336180
X3610 1185 1179 4813 2 1 4852 AN3 $T=1038500 336560 0 180 $X=1034780 $Y=331140
X3611 4983 4961 4836 2 1 4921 AN3 $T=1058340 417200 1 180 $X=1054620 $Y=416820
X3612 5034 5033 1258 2 1 4807 AN3 $T=1075700 397040 0 180 $X=1071980 $Y=391620
X3613 5048 1279 5083 2 1 5065 AN3 $T=1086860 336560 0 0 $X=1086860 $Y=336180
X3614 4359 911 989 247 1 2 4372 OA13S $T=941160 417200 0 0 $X=941160 $Y=416820
X3615 324 2248 2 1 2270 2269 MUX2 $T=447020 467600 1 0 $X=447020 $Y=462180
X3616 2215 2248 2 1 2277 2242 MUX2 $T=447640 397040 1 0 $X=447640 $Y=391620
X3617 377 2248 2 1 2400 2331 MUX2 $T=487320 477680 1 0 $X=487320 $Y=472260
X3618 2396 2248 2 1 2425 2426 MUX2 $T=494140 457520 0 0 $X=494140 $Y=457140
X3619 2712 2687 2 1 2627 2700 MUX2 $T=579080 407120 0 180 $X=574740 $Y=401700
X3620 2733 481 2 1 2721 2722 MUX2 $T=582800 346640 1 180 $X=578460 $Y=346260
X3621 2728 2687 2 1 2703 2760 MUX2 $T=580940 407120 1 0 $X=580940 $Y=401700
X3622 2767 481 2 1 2614 2742 MUX2 $T=587140 346640 0 180 $X=582800 $Y=341220
X3623 2772 488 2 1 2733 2747 MUX2 $T=589000 346640 1 180 $X=584660 $Y=346260
X3624 2770 2687 2 1 2602 2754 MUX2 $T=589620 407120 1 180 $X=585280 $Y=406740
X3625 2738 2687 2 1 2734 2776 MUX2 $T=585280 417200 1 0 $X=585280 $Y=411780
X3626 2775 492 2 1 2753 2756 MUX2 $T=590240 366800 0 180 $X=585900 $Y=361380
X3627 487 481 2 1 2678 2786 MUX2 $T=589000 336560 0 0 $X=589000 $Y=336180
X3628 2759 412 2 1 2567 2791 MUX2 $T=589620 397040 1 0 $X=589620 $Y=391620
X3629 2695 2662 2 1 2698 2793 MUX2 $T=590240 407120 1 0 $X=590240 $Y=401700
X3630 486 481 2 1 2749 2790 MUX2 $T=590860 326480 0 0 $X=590860 $Y=326100
X3631 2779 484 2 1 2499 2797 MUX2 $T=591480 376880 0 0 $X=591480 $Y=376500
X3632 2766 484 2 1 2759 2779 MUX2 $T=595820 386960 0 180 $X=591480 $Y=381540
X3633 2756 492 2 1 2800 2792 MUX2 $T=592100 366800 1 0 $X=592100 $Y=361380
X3634 2667 2662 2 1 2724 2802 MUX2 $T=593340 407120 0 0 $X=593340 $Y=406740
X3635 2709 2687 2 1 2762 2803 MUX2 $T=593340 417200 1 0 $X=593340 $Y=411780
X3636 2787 481 2 1 2622 2807 MUX2 $T=594580 346640 1 0 $X=594580 $Y=341220
X3637 2781 497 2 1 2808 2800 MUX2 $T=594580 356720 0 0 $X=594580 $Y=356340
X3638 2499 412 2 1 2667 2820 MUX2 $T=595820 386960 0 0 $X=595820 $Y=386580
X3639 2791 412 2 1 2814 2824 MUX2 $T=595820 397040 1 0 $X=595820 $Y=391620
X3640 2567 2662 2 1 2699 2828 MUX2 $T=595820 407120 1 0 $X=595820 $Y=401700
X3641 2797 484 2 1 2791 2801 MUX2 $T=597060 376880 0 0 $X=597060 $Y=376500
X3642 2801 484 2 1 2820 2823 MUX2 $T=597060 386960 1 0 $X=597060 $Y=381540
X3643 2753 497 2 1 2784 2826 MUX2 $T=597680 356720 1 0 $X=597680 $Y=351300
X3644 2805 492 2 1 2827 2830 MUX2 $T=597680 366800 1 0 $X=597680 $Y=361380
X3645 2806 481 2 1 464 2832 MUX2 $T=598920 326480 0 0 $X=598920 $Y=326100
X3646 2792 492 2 1 2826 2805 MUX2 $T=598920 366800 0 0 $X=598920 $Y=366420
X3647 2784 488 2 1 502 2833 MUX2 $T=599540 346640 1 0 $X=599540 $Y=341220
X3648 2808 488 2 1 486 2836 MUX2 $T=599540 346640 0 0 $X=599540 $Y=346260
X3649 2814 2662 2 1 2754 2831 MUX2 $T=599540 407120 0 0 $X=599540 $Y=406740
X3650 2698 2687 2 1 2795 2834 MUX2 $T=599540 417200 1 0 $X=599540 $Y=411780
X3651 2800 497 2 1 2747 2827 MUX2 $T=600780 356720 0 0 $X=600780 $Y=356340
X3652 2820 412 2 1 2793 2842 MUX2 $T=602020 386960 0 0 $X=602020 $Y=386580
X3653 2824 412 2 1 2828 2839 MUX2 $T=602020 397040 1 0 $X=602020 $Y=391620
X3654 2823 484 2 1 2824 2844 MUX2 $T=602640 386960 1 0 $X=602640 $Y=381540
X3655 2826 497 2 1 2829 2846 MUX2 $T=603260 356720 1 0 $X=603260 $Y=351300
X3656 2830 492 2 1 2846 2837 MUX2 $T=603260 366800 1 0 $X=603260 $Y=361380
X3657 502 481 2 1 504 2845 MUX2 $T=603880 336560 0 0 $X=603880 $Y=336180
X3658 2793 2662 2 1 2700 2853 MUX2 $T=603880 407120 1 0 $X=603880 $Y=401700
X3659 2829 488 2 1 2832 2859 MUX2 $T=605120 346640 1 0 $X=605120 $Y=341220
X3660 2747 488 2 1 513 2861 MUX2 $T=606360 346640 0 0 $X=606360 $Y=346260
X3661 2827 497 2 1 2836 2863 MUX2 $T=606980 356720 0 0 $X=606980 $Y=356340
X3662 2844 484 2 1 2842 2855 MUX2 $T=607600 386960 0 0 $X=607600 $Y=386580
X3663 2842 412 2 1 2802 2881 MUX2 $T=607600 397040 1 0 $X=607600 $Y=391620
X3664 2864 424 2 1 2847 2624 MUX2 $T=612560 477680 0 180 $X=608220 $Y=472260
X3665 2855 484 2 1 2839 2878 MUX2 $T=608840 386960 1 0 $X=608840 $Y=381540
X3666 2846 497 2 1 2833 2877 MUX2 $T=609460 356720 1 0 $X=609460 $Y=351300
X3667 2856 492 2 1 2877 2883 MUX2 $T=609460 366800 1 0 $X=609460 $Y=361380
X3668 2837 492 2 1 2863 2856 MUX2 $T=609460 376880 1 0 $X=609460 $Y=371460
X3669 2889 424 2 1 2869 2706 MUX2 $T=615660 477680 1 180 $X=611320 $Y=477300
X3670 2836 488 2 1 2807 2893 MUX2 $T=612560 346640 0 0 $X=612560 $Y=346260
X3671 2839 412 2 1 2831 2917 MUX2 $T=613800 386960 0 0 $X=613800 $Y=386580
X3672 2881 412 2 1 2853 2894 MUX2 $T=613800 397040 1 0 $X=613800 $Y=391620
X3673 2878 484 2 1 2881 2897 MUX2 $T=614420 386960 1 0 $X=614420 $Y=381540
X3674 2863 497 2 1 2861 2902 MUX2 $T=615040 356720 1 0 $X=615040 $Y=351300
X3675 2883 492 2 1 2902 2910 MUX2 $T=615660 366800 1 0 $X=615660 $Y=361380
X3676 2897 484 2 1 2917 2914 MUX2 $T=619380 386960 1 0 $X=619380 $Y=381540
X3677 2910 492 2 1 2921 2926 MUX2 $T=621240 366800 0 0 $X=621240 $Y=366420
X3678 2947 2662 2 1 2933 2918 MUX2 $T=632400 407120 1 180 $X=628060 $Y=406740
X3679 2960 492 2 1 2967 2982 MUX2 $T=633020 366800 0 0 $X=633020 $Y=366420
X3680 2887 2687 2 1 2979 2918 MUX2 $T=633020 417200 1 0 $X=633020 $Y=411780
X3681 2953 484 2 1 2912 2978 MUX2 $T=633640 376880 0 0 $X=633640 $Y=376500
X3682 2955 424 2 1 2962 2794 MUX2 $T=641700 477680 1 180 $X=637360 $Y=477300
X3683 2956 2898 2 1 2987 2999 MUX2 $T=637980 336560 0 0 $X=637980 $Y=336180
X3684 2986 424 2 1 2980 2774 MUX2 $T=642320 487760 0 180 $X=637980 $Y=482340
X3685 2971 2662 2 1 2972 2989 MUX2 $T=639220 407120 1 0 $X=639220 $Y=401700
X3686 2973 2662 2 1 2995 2989 MUX2 $T=639840 407120 0 0 $X=639840 $Y=406740
X3687 2985 2898 2 1 3016 3005 MUX2 $T=642320 346640 0 0 $X=642320 $Y=346260
X3688 3019 424 2 1 3003 2864 MUX2 $T=647900 477680 1 180 $X=643560 $Y=477300
X3689 2984 2898 2 1 3032 2999 MUX2 $T=644800 336560 0 0 $X=644800 $Y=336180
X3690 2901 2687 2 1 3026 2918 MUX2 $T=644800 397040 0 0 $X=644800 $Y=396660
X3691 2850 2687 2 1 3013 2989 MUX2 $T=644800 417200 1 0 $X=644800 $Y=411780
X3692 2905 2687 2 1 3028 2989 MUX2 $T=645420 407120 1 0 $X=645420 $Y=401700
X3693 3039 424 2 1 3023 2889 MUX2 $T=654100 477680 1 180 $X=649760 $Y=477300
X3694 2952 481 2 1 3042 3005 MUX2 $T=650380 356720 0 0 $X=650380 $Y=356340
X3695 2845 481 2 1 3052 2999 MUX2 $T=653480 336560 0 0 $X=653480 $Y=336180
X3696 2870 481 2 1 3053 2999 MUX2 $T=653480 346640 1 0 $X=653480 $Y=341220
X3697 2884 481 2 1 3044 3005 MUX2 $T=654100 346640 0 0 $X=654100 $Y=346260
X3698 3055 424 2 1 570 2986 MUX2 $T=659680 477680 1 180 $X=655340 $Y=477300
X3699 3087 424 2 1 574 2955 MUX2 $T=664640 477680 0 180 $X=660300 $Y=472260
X3700 582 424 2 1 3112 3087 MUX2 $T=666500 477680 1 0 $X=666500 $Y=472260
X3701 3105 424 2 1 3049 3039 MUX2 $T=672080 487760 0 180 $X=667740 $Y=482340
X3702 3094 424 2 1 589 3055 MUX2 $T=677660 487760 0 180 $X=673320 $Y=482340
X3703 582 424 2 1 3151 3092 MUX2 $T=678280 487760 1 0 $X=678280 $Y=482340
X3704 3167 604 2 1 3157 599 MUX2 $T=687580 447440 1 180 $X=683240 $Y=447060
X3705 582 424 2 1 605 3094 MUX2 $T=683860 487760 0 0 $X=683860 $Y=487380
X3706 582 424 2 1 610 3105 MUX2 $T=690060 487760 0 0 $X=690060 $Y=487380
X3707 3166 604 2 1 3183 613 MUX2 $T=691920 457520 1 0 $X=691920 $Y=452100
X3708 3198 604 2 1 3160 3179 MUX2 $T=696880 467600 0 180 $X=692540 $Y=462180
X3709 3185 604 2 1 3200 3164 MUX2 $T=701840 467600 1 180 $X=697500 $Y=467220
X3710 3219 604 2 1 3191 3167 MUX2 $T=702460 457520 0 180 $X=698120 $Y=452100
X3711 3221 604 2 1 3220 3166 MUX2 $T=706180 467600 1 180 $X=701840 $Y=467220
X3712 3263 604 2 1 616 3198 MUX2 $T=711760 467600 1 180 $X=707420 $Y=467220
X3713 623 620 2 1 3239 3288 MUX2 $T=714240 336560 1 0 $X=714240 $Y=331140
X3714 3275 604 2 1 3271 3185 MUX2 $T=718580 467600 1 180 $X=714240 $Y=467220
X3715 630 632 2 1 624 3272 MUX2 $T=719200 326480 1 180 $X=714860 $Y=326100
X3716 638 632 2 1 631 3311 MUX2 $T=724780 326480 1 180 $X=720440 $Y=326100
X3717 3334 412 2 1 637 3331 MUX2 $T=729740 336560 0 180 $X=725400 $Y=331140
X3718 641 412 2 1 630 3334 MUX2 $T=730360 326480 1 180 $X=726020 $Y=326100
X3719 3361 604 2 1 639 3221 MUX2 $T=730980 467600 1 180 $X=726640 $Y=467220
X3720 645 412 2 1 640 3356 MUX2 $T=735320 326480 1 180 $X=730980 $Y=326100
X3721 3356 412 2 1 3311 3342 MUX2 $T=735320 336560 1 180 $X=730980 $Y=336180
X3722 3339 604 2 1 3358 3320 MUX2 $T=737180 467600 1 180 $X=732840 $Y=467220
X3723 3378 484 2 1 3331 3367 MUX2 $T=737800 346640 0 180 $X=733460 $Y=341220
X3724 3381 484 2 1 3356 3378 MUX2 $T=740900 336560 1 180 $X=736560 $Y=336180
X3725 652 484 2 1 645 3380 MUX2 $T=741520 326480 1 180 $X=737180 $Y=326100
X3726 3380 484 2 1 3334 3381 MUX2 $T=741520 336560 0 180 $X=737180 $Y=331140
X3727 3414 604 2 1 3384 3263 MUX2 $T=742140 467600 0 180 $X=737800 $Y=462180
X3728 3339 604 2 1 3412 3414 MUX2 $T=742140 467600 0 0 $X=742140 $Y=467220
X3729 3339 604 2 1 674 3361 MUX2 $T=752680 467600 1 180 $X=748340 $Y=467220
X3730 687 481 2 1 3467 3504 MUX2 $T=768180 346640 0 180 $X=763840 $Y=341220
X3731 3534 693 2 1 691 3530 MUX2 $T=773760 346640 0 180 $X=769420 $Y=341220
X3732 696 693 2 1 687 3534 MUX2 $T=775000 326480 1 180 $X=770660 $Y=326100
X3733 699 693 2 1 686 3532 MUX2 $T=775620 336560 0 180 $X=771280 $Y=331140
X3734 702 497 2 1 3534 3562 MUX2 $T=781200 336560 1 180 $X=776860 $Y=336180
X3735 704 693 2 1 697 3565 MUX2 $T=781820 326480 1 180 $X=777480 $Y=326100
X3736 3562 497 2 1 3532 3582 MUX2 $T=784920 346640 0 180 $X=780580 $Y=341220
X3737 3603 497 2 1 3565 3596 MUX2 $T=787400 336560 1 180 $X=783060 $Y=336180
X3738 707 497 2 1 695 3603 MUX2 $T=789260 336560 0 180 $X=784920 $Y=331140
X3739 3628 492 2 1 3562 3613 MUX2 $T=791120 346640 0 180 $X=786780 $Y=341220
X3740 3634 492 2 1 3603 3628 MUX2 $T=793600 336560 1 180 $X=789260 $Y=336180
X3741 3613 492 2 1 3596 3632 MUX2 $T=794220 346640 1 180 $X=789880 $Y=346260
X3742 709 492 2 1 702 3634 MUX2 $T=794840 336560 0 180 $X=790500 $Y=331140
X3743 3674 3659 2 1 3579 3642 MUX2 $T=797940 447440 0 180 $X=793600 $Y=442020
X3744 3671 3659 2 1 3516 3642 MUX2 $T=797940 447440 1 180 $X=793600 $Y=447060
X3745 3667 3659 2 1 3581 3648 MUX2 $T=799180 437360 1 180 $X=794840 $Y=436980
X3746 3684 3681 2 1 3648 3642 MUX2 $T=799800 437360 0 180 $X=795460 $Y=431940
X3747 3696 719 2 1 3638 3668 MUX2 $T=802900 477680 1 180 $X=798560 $Y=477300
X3748 3699 3659 2 1 3550 3642 MUX2 $T=804140 447440 1 180 $X=799800 $Y=447060
X3749 3714 719 2 1 3595 3668 MUX2 $T=805380 487760 1 180 $X=801040 $Y=487380
X3750 3717 719 2 1 3663 3691 MUX2 $T=806620 487760 0 180 $X=802280 $Y=482340
X3751 3685 719 2 1 3682 3668 MUX2 $T=807860 477680 0 180 $X=803520 $Y=472260
X3752 3723 719 2 1 3604 3668 MUX2 $T=808480 477680 1 180 $X=804140 $Y=477300
X3753 3757 3746 2 1 723 3720 MUX2 $T=811580 356720 0 180 $X=807240 $Y=351300
X3754 3740 3681 2 1 3719 3642 MUX2 $T=811580 437360 0 180 $X=807240 $Y=431940
X3755 3745 3750 2 1 3722 3668 MUX2 $T=812200 487760 0 180 $X=807860 $Y=482340
X3756 738 733 2 1 3665 3728 MUX2 $T=813440 336560 0 180 $X=809100 $Y=331140
X3757 734 733 2 1 3660 3729 MUX2 $T=814060 346640 0 180 $X=809720 $Y=341220
X3758 3733 3750 2 1 3691 3668 MUX2 $T=814060 477680 1 180 $X=809720 $Y=477300
X3759 727 726 2 1 734 3757 MUX2 $T=810340 336560 0 0 $X=810340 $Y=336180
X3760 3760 3659 2 1 3519 3642 MUX2 $T=814680 447440 0 180 $X=810340 $Y=442020
X3761 735 725 2 1 737 3779 MUX2 $T=814060 326480 0 0 $X=814060 $Y=326100
X3762 737 726 2 1 740 3782 MUX2 $T=815300 346640 1 0 $X=815300 $Y=341220
X3763 743 726 2 1 738 3767 MUX2 $T=820260 336560 1 180 $X=815920 $Y=336180
X3764 3792 725 2 1 3757 3783 MUX2 $T=823360 346640 1 180 $X=819020 $Y=346260
X3765 3795 3774 2 1 3785 3726 MUX2 $T=823980 427280 1 180 $X=819640 $Y=426900
X3766 730 741 2 1 747 749 MUX2 $T=820260 326480 0 0 $X=820260 $Y=326100
X3767 744 3746 2 1 731 3784 MUX2 $T=824600 356720 0 180 $X=820260 $Y=351300
X3768 3767 3746 2 1 748 3817 MUX2 $T=820260 366800 1 0 $X=820260 $Y=361380
X3769 3779 725 2 1 3767 3793 MUX2 $T=825220 346640 0 180 $X=820880 $Y=341220
X3770 747 725 2 1 744 3792 MUX2 $T=825840 336560 0 180 $X=821500 $Y=331140
X3771 3783 725 2 1 3784 3791 MUX2 $T=825840 356720 1 180 $X=821500 $Y=356340
X3772 3820 741 2 1 3793 3804 MUX2 $T=828940 346640 1 180 $X=824600 $Y=346260
X3773 3805 3681 2 1 3806 3642 MUX2 $T=828940 437360 1 180 $X=824600 $Y=436980
X3774 3824 3778 2 1 3807 3810 MUX2 $T=829560 467600 1 180 $X=825220 $Y=467220
X3775 749 741 2 1 3779 3831 MUX2 $T=825840 326480 0 0 $X=825840 $Y=326100
X3776 3804 741 2 1 3783 3832 MUX2 $T=825840 356720 1 0 $X=825840 $Y=351300
X3777 3833 3781 2 1 3814 3815 MUX2 $T=830180 417200 1 180 $X=825840 $Y=416820
X3778 3811 3750 2 1 3808 3668 MUX2 $T=830180 487760 1 180 $X=825840 $Y=487380
X3779 3831 741 2 1 3792 3820 MUX2 $T=831420 336560 0 180 $X=827080 $Y=331140
X3780 3793 725 2 1 3782 3830 MUX2 $T=827700 356720 0 0 $X=827700 $Y=356340
X3781 3832 741 2 1 3830 3863 MUX2 $T=833900 356720 0 0 $X=833900 $Y=356340
X3782 3869 3659 2 1 3852 3667 MUX2 $T=840100 437360 1 180 $X=835760 $Y=436980
X3783 3874 719 2 1 754 3717 MUX2 $T=840720 497840 0 180 $X=836380 $Y=492420
X3784 3865 3781 2 1 3894 3840 MUX2 $T=838860 417200 0 0 $X=838860 $Y=416820
X3785 3862 3778 2 1 3896 3842 MUX2 $T=839480 467600 0 0 $X=839480 $Y=467220
X3786 3903 3778 2 1 3872 3862 MUX2 $T=845060 467600 0 180 $X=840720 $Y=462180
X3787 3892 3781 2 1 3877 3865 MUX2 $T=845680 407120 1 180 $X=841340 $Y=406740
X3788 3909 719 2 1 762 3751 MUX2 $T=846920 497840 0 180 $X=842580 $Y=492420
X3789 3916 3659 2 1 3878 3742 MUX2 $T=848160 437360 1 180 $X=843820 $Y=436980
X3790 3913 3781 2 1 3901 3892 MUX2 $T=849400 417200 1 180 $X=845060 $Y=416820
X3791 3915 3778 2 1 3902 3903 MUX2 $T=849400 467600 1 180 $X=845060 $Y=467220
X3792 3921 3774 2 1 3898 3877 MUX2 $T=850640 427280 0 180 $X=846300 $Y=421860
X3793 3918 3904 2 1 3911 3872 MUX2 $T=851880 477680 0 180 $X=847540 $Y=472260
X3794 3923 3681 2 1 3703 3870 MUX2 $T=852500 437360 0 180 $X=848160 $Y=431940
X3795 3924 3659 2 1 3914 3822 MUX2 $T=853120 447440 0 180 $X=848780 $Y=442020
X3796 3930 3750 2 1 3738 3887 MUX2 $T=854360 487760 1 180 $X=850020 $Y=487380
X3797 3937 3778 2 1 3918 3915 MUX2 $T=854980 467600 0 180 $X=850640 $Y=462180
X3798 3943 3781 2 1 3921 3913 MUX2 $T=856840 417200 0 180 $X=852500 $Y=411780
X3799 3941 3774 2 1 3923 3921 MUX2 $T=856840 417200 1 180 $X=852500 $Y=416820
X3800 3948 3750 2 1 3709 3866 MUX2 $T=856840 477680 1 180 $X=852500 $Y=477300
X3801 3942 3904 2 1 3928 3902 MUX2 $T=857460 467600 1 180 $X=853120 $Y=467220
X3802 3944 3774 2 1 3933 3901 MUX2 $T=858700 427280 1 180 $X=854360 $Y=426900
X3803 3952 719 2 1 798 769 MUX2 $T=859940 487760 1 180 $X=855600 $Y=487380
X3804 3947 3951 2 1 3942 3937 MUX2 $T=860560 467600 0 180 $X=856220 $Y=462180
X3805 3957 3750 2 1 3799 3911 MUX2 $T=860560 487760 0 180 $X=856220 $Y=482340
X3806 3958 719 2 1 799 3829 MUX2 $T=860560 497840 0 180 $X=856220 $Y=492420
X3807 3964 3681 2 1 3687 3873 MUX2 $T=861180 437360 1 180 $X=856840 $Y=436980
X3808 3963 3781 2 1 3944 3943 MUX2 $T=862420 417200 1 180 $X=858080 $Y=416820
X3809 3968 3904 2 1 3948 3918 MUX2 $T=862420 477680 0 180 $X=858080 $Y=472260
X3810 3965 3904 2 1 3930 3942 MUX2 $T=863040 467600 1 180 $X=858700 $Y=467220
X3811 3976 3681 2 1 3845 3933 MUX2 $T=864280 437360 0 180 $X=859940 $Y=431940
X3812 3978 3750 2 1 3850 3928 MUX2 $T=865520 487760 1 180 $X=861180 $Y=487380
X3813 4006 719 2 1 819 3709 MUX2 $T=866760 497840 0 180 $X=862420 $Y=492420
X3814 4000 3659 2 1 3961 3825 MUX2 $T=867380 437360 1 180 $X=863040 $Y=436980
X3815 3971 3781 2 1 3941 3963 MUX2 $T=868000 417200 0 180 $X=863660 $Y=411780
X3816 3990 3774 2 1 3964 3944 MUX2 $T=868000 427280 0 180 $X=863660 $Y=421860
X3817 4001 3904 2 1 3957 3968 MUX2 $T=868620 477680 0 180 $X=864280 $Y=472260
X3818 4010 3951 2 1 3965 3972 MUX2 $T=869240 467600 0 180 $X=864900 $Y=462180
X3819 4004 3681 2 1 3775 3898 MUX2 $T=869860 437360 0 180 $X=865520 $Y=431940
X3820 4040 3774 2 1 3976 3990 MUX2 $T=871720 427280 1 180 $X=867380 $Y=426900
X3821 4030 3774 2 1 4004 3941 MUX2 $T=874200 417200 1 180 $X=869860 $Y=416820
X3822 4050 719 2 1 848 3738 MUX2 $T=876060 487760 1 180 $X=871720 $Y=487380
X3823 4049 3750 2 1 3909 3930 MUX2 $T=877300 487760 0 180 $X=872960 $Y=482340
X3824 4031 3659 2 1 4044 3687 MUX2 $T=874820 447440 1 0 $X=874820 $Y=442020
X3825 4058 3750 2 1 3952 3957 MUX2 $T=879160 477680 1 180 $X=874820 $Y=477300
X3826 4052 3951 2 1 4041 4012 MUX2 $T=879780 467600 1 180 $X=875440 $Y=467220
X3827 4069 3781 2 1 4040 4037 MUX2 $T=880400 417200 1 180 $X=876060 $Y=416820
X3828 4037 3781 2 1 4030 3986 MUX2 $T=882260 417200 0 180 $X=877920 $Y=411780
X3829 4070 3659 2 1 4008 3703 MUX2 $T=882260 437360 1 180 $X=877920 $Y=436980
X3830 4071 3659 2 1 4093 3775 MUX2 $T=881640 447440 1 0 $X=881640 $Y=442020
X3831 4063 719 2 1 863 3799 MUX2 $T=885980 497840 0 180 $X=881640 $Y=492420
X3832 4091 4018 2 1 3869 3923 MUX2 $T=889700 437360 0 180 $X=885360 $Y=431940
X3833 4094 3774 2 1 4091 4030 MUX2 $T=892800 417200 1 180 $X=888460 $Y=416820
X3834 4262 4046 2 1 854 247 MUX2 $T=920700 397040 0 0 $X=920700 $Y=396660
X3835 4366 4298 2 1 4283 4347 MUX2 $T=943020 457520 0 180 $X=938680 $Y=452100
X3836 4371 4298 2 1 4333 4347 MUX2 $T=944880 447440 1 180 $X=940540 $Y=447060
X3837 1002 976 2 1 4342 994 MUX2 $T=948600 497840 0 180 $X=944260 $Y=492420
X3838 4368 4372 2 1 1004 247 MUX2 $T=946740 397040 1 0 $X=946740 $Y=391620
X3839 4370 4018 2 1 4399 4347 MUX2 $T=946740 447440 0 0 $X=946740 $Y=447060
X3840 4428 876 2 1 1006 998 MUX2 $T=954800 497840 0 180 $X=950460 $Y=492420
X3841 4419 976 2 1 4338 998 MUX2 $T=955420 487760 1 180 $X=951080 $Y=487380
X3842 4454 4018 2 1 4434 4397 MUX2 $T=962860 437360 1 180 $X=958520 $Y=436980
X3843 4459 4298 2 1 4297 4397 MUX2 $T=962860 457520 0 180 $X=958520 $Y=452100
X3844 4478 876 2 1 1026 994 MUX2 $T=966580 497840 0 180 $X=962240 $Y=492420
X3845 4496 4298 2 1 4329 4397 MUX2 $T=969060 457520 0 180 $X=964720 $Y=452100
X3846 4414 4018 2 1 4476 4397 MUX2 $T=969680 447440 1 180 $X=965340 $Y=447060
X3847 4525 3951 2 1 4505 4488 MUX2 $T=975880 467600 1 180 $X=971540 $Y=467220
X3848 4539 3774 2 1 4519 4477 MUX2 $T=977740 427280 1 180 $X=973400 $Y=426900
X3849 4555 3781 2 1 4534 4529 MUX2 $T=981460 427280 0 180 $X=977120 $Y=421860
X3850 4556 3951 2 1 4526 4525 MUX2 $T=982080 477680 0 180 $X=977740 $Y=472260
X3851 4562 3904 2 1 1052 4505 MUX2 $T=983320 477680 1 180 $X=978980 $Y=477300
X3852 4526 3904 2 1 1058 4510 MUX2 $T=983940 487760 0 180 $X=979600 $Y=482340
X3853 4382 3774 2 1 4545 4534 MUX2 $T=985180 437360 1 180 $X=980840 $Y=436980
X3854 4581 1041 2 1 4565 4536 MUX2 $T=988900 497840 0 180 $X=984560 $Y=492420
X3855 4599 3781 2 1 4382 4580 MUX2 $T=990140 437360 0 180 $X=985800 $Y=431940
X3856 4603 3904 2 1 4581 4562 MUX2 $T=990140 487760 0 180 $X=985800 $Y=482340
X3857 4586 3951 2 1 4607 4554 MUX2 $T=987040 477680 1 0 $X=987040 $Y=472260
X3858 4580 3781 2 1 4539 4555 MUX2 $T=993240 427280 0 180 $X=988900 $Y=421860
X3859 4608 3781 2 1 4598 4599 MUX2 $T=993240 427280 1 180 $X=988900 $Y=426900
X3860 4611 4018 2 1 4602 4522 MUX2 $T=993860 447440 0 180 $X=989520 $Y=442020
X3861 4607 3904 2 1 1075 4526 MUX2 $T=994480 487760 1 180 $X=990140 $Y=487380
X3862 4612 3951 2 1 4603 4586 MUX2 $T=995100 477680 1 180 $X=990760 $Y=477300
X3863 4635 3781 2 1 4626 4627 MUX2 $T=998820 437360 1 180 $X=994480 $Y=436980
X3864 4627 3781 2 1 4369 4608 MUX2 $T=995100 437360 1 0 $X=995100 $Y=431940
X3865 4615 3951 2 1 4630 4612 MUX2 $T=999440 487760 0 180 $X=995100 $Y=482340
X3866 4598 3774 2 1 4593 4539 MUX2 $T=1000060 427280 1 180 $X=995720 $Y=426900
X3867 4652 4018 2 1 4632 4519 MUX2 $T=1000060 447440 0 180 $X=995720 $Y=442020
X3868 4630 3904 2 1 1081 4607 MUX2 $T=1000060 497840 0 180 $X=995720 $Y=492420
X3869 4663 3904 2 1 1100 4603 MUX2 $T=1000680 477680 1 180 $X=996340 $Y=477300
X3870 4682 3774 2 1 4651 4369 MUX2 $T=1004400 437360 1 180 $X=1000060 $Y=436980
X3871 4626 3774 2 1 4652 4598 MUX2 $T=1005640 437360 0 180 $X=1001300 $Y=431940
X3872 4648 3781 2 1 4682 4635 MUX2 $T=1001300 447440 0 0 $X=1001300 $Y=447060
X3873 4683 1041 2 1 1112 1075 MUX2 $T=1006880 497840 0 180 $X=1002540 $Y=492420
X3874 4703 3904 2 1 4683 4630 MUX2 $T=1008120 487760 1 180 $X=1003780 $Y=487380
X3875 4681 3951 2 1 4703 4709 MUX2 $T=1005020 477680 0 0 $X=1005020 $Y=477300
X3876 4692 3774 2 1 4718 4626 MUX2 $T=1006260 437360 0 0 $X=1006260 $Y=436980
X3877 4718 4018 2 1 4702 4593 MUX2 $T=1011840 447440 0 180 $X=1007500 $Y=442020
X3878 4651 4018 2 1 4697 4545 MUX2 $T=1011840 447440 1 180 $X=1007500 $Y=447060
X3879 4709 3951 2 1 4663 4615 MUX2 $T=1013700 477680 0 180 $X=1009360 $Y=472260
X3880 4749 4416 2 1 4730 4558 MUX2 $T=1017420 447440 1 180 $X=1013080 $Y=447060
X3881 4737 1041 2 1 1130 4581 MUX2 $T=1017420 497840 0 180 $X=1013080 $Y=492420
X3882 4757 4018 2 1 4780 4611 MUX2 $T=1018660 437360 1 0 $X=1018660 $Y=431940
X3883 4780 4416 2 1 4751 4467 MUX2 $T=1023000 447440 1 180 $X=1018660 $Y=447060
X3884 4758 1041 2 1 1162 1100 MUX2 $T=1019280 477680 0 0 $X=1019280 $Y=477300
X3885 4759 976 2 1 1151 4565 MUX2 $T=1019280 497840 1 0 $X=1019280 $Y=492420
X3886 4793 4416 2 1 4774 4602 MUX2 $T=1025480 457520 0 180 $X=1021140 $Y=452100
X3887 4775 4018 2 1 4809 4652 MUX2 $T=1023000 447440 1 0 $X=1023000 $Y=442020
X3888 4809 4416 2 1 4785 4435 MUX2 $T=1028580 447440 1 180 $X=1024240 $Y=447060
X3889 4787 976 2 1 1165 1166 MUX2 $T=1024860 497840 1 0 $X=1024860 $Y=492420
X3890 4802 4416 2 1 4830 4632 MUX2 $T=1027340 457520 1 0 $X=1027340 $Y=452100
X3891 4839 4298 2 1 4850 4524 MUX2 $T=1032300 457520 0 0 $X=1032300 $Y=457140
X3892 3396 3455 3397 1 2 XNR2H $T=750820 366800 0 0 $X=750820 $Y=366420
X3893 3541 3543 3620 1 2 XNR2H $T=772520 427280 0 0 $X=772520 $Y=426900
X3894 3600 3620 3445 1 2 XNR2H $T=782440 417200 1 0 $X=782440 $Y=411780
X3895 3047 2865 3004 2 3013 2840 1 AO22S $T=654720 427280 0 180 $X=649760 $Y=421860
X3896 3478 3509 3503 2 3516 3524 1 AO22S $T=763840 467600 1 0 $X=763840 $Y=462180
X3897 3526 3509 3542 2 3550 3524 1 AO22S $T=770040 467600 1 0 $X=770040 $Y=462180
X3898 3522 3509 3568 2 3581 3524 1 AO22S $T=777480 447440 1 0 $X=777480 $Y=442020
X3899 3511 3509 3606 2 3612 3524 1 AO22S $T=783680 447440 1 0 $X=783680 $Y=442020
X3900 4309 913 973 2 4342 979 1 AO22S $T=934340 497840 1 0 $X=934340 $Y=492420
X3901 2794 424 2 2563 1 2838 MUX2S $T=602020 477680 1 0 $X=602020 $Y=472260
X3902 2802 2662 2 2849 1 2776 MUX2S $T=605120 407120 0 0 $X=605120 $Y=406740
X3903 2699 2687 2 2850 1 2835 MUX2S $T=605120 417200 1 0 $X=605120 $Y=411780
X3904 2832 481 2 2870 1 2875 MUX2S $T=608840 336560 0 0 $X=608840 $Y=336180
X3905 2828 2662 2 2872 1 2760 MUX2S $T=609460 397040 0 0 $X=609460 $Y=396660
X3906 2831 2662 2 2880 1 2803 MUX2S $T=610700 407120 1 0 $X=610700 $Y=401700
X3907 513 481 2 2884 1 516 MUX2S $T=611320 346640 1 0 $X=611320 $Y=341220
X3908 2724 2687 2 2887 1 2867 MUX2S $T=611940 417200 1 0 $X=611940 $Y=411780
X3909 2853 2662 2 2899 1 2834 MUX2S $T=615660 397040 0 0 $X=615660 $Y=396660
X3910 2700 2687 2 2901 1 2908 MUX2S $T=616280 407120 1 0 $X=616280 $Y=401700
X3911 2833 2898 2 2903 1 2742 MUX2S $T=616900 346640 1 0 $X=616900 $Y=341220
X3912 2754 2687 2 2905 1 2890 MUX2S $T=617520 417200 1 0 $X=617520 $Y=411780
X3913 2861 2898 2 2911 1 2722 MUX2S $T=618760 346640 0 0 $X=618760 $Y=346260
X3914 2776 2687 2 2915 1 2919 MUX2S $T=619380 417200 0 0 $X=619380 $Y=416820
X3915 2902 497 2 2920 1 2893 MUX2S $T=620620 356720 0 0 $X=620620 $Y=356340
X3916 2877 497 2 2921 1 2859 MUX2S $T=621240 356720 1 0 $X=621240 $Y=351300
X3917 2894 412 2 2912 1 2849 MUX2S $T=625580 397040 1 180 $X=621240 $Y=396660
X3918 2914 484 2 2923 1 2894 MUX2S $T=621860 397040 1 0 $X=621860 $Y=391620
X3919 2849 2662 2 2924 1 2887 MUX2S $T=621860 407120 1 0 $X=621860 $Y=401700
X3920 2924 2662 2 2918 1 2915 MUX2S $T=626820 407120 1 180 $X=622480 $Y=406740
X3921 2859 2898 2 2928 1 2786 MUX2S $T=623100 346640 1 0 $X=623100 $Y=341220
X3922 2893 2898 2 2936 1 2790 MUX2S $T=624960 346640 0 0 $X=624960 $Y=346260
X3923 2921 497 2 2942 1 2903 MUX2S $T=626820 356720 1 0 $X=626820 $Y=351300
X3924 2926 492 2 2945 1 2920 MUX2S $T=627440 366800 0 0 $X=627440 $Y=366420
X3925 2918 2757 2 2946 1 2947 MUX2S $T=627440 397040 1 0 $X=627440 $Y=391620
X3926 2899 2662 2 2947 1 2901 MUX2S $T=627440 407120 1 0 $X=627440 $Y=401700
X3927 2834 2687 2 2933 1 2957 MUX2S $T=627440 417200 1 0 $X=627440 $Y=411780
X3928 2917 412 2 2950 1 2872 MUX2S $T=628060 386960 1 0 $X=628060 $Y=381540
X3929 2912 412 2 2937 1 2899 MUX2S $T=632400 386960 1 180 $X=628060 $Y=386580
X3930 2807 481 2 2952 1 2959 MUX2S $T=628680 346640 1 0 $X=628680 $Y=341220
X3931 2923 484 2 2953 1 2950 MUX2S $T=628680 376880 0 0 $X=628680 $Y=376500
X3932 2903 2898 2 2956 1 2845 MUX2S $T=629300 336560 0 0 $X=629300 $Y=336180
X3933 2911 2898 2 2963 1 2884 MUX2S $T=630540 346640 0 0 $X=630540 $Y=346260
X3934 2942 497 2 2966 1 2928 MUX2S $T=632400 356720 1 0 $X=632400 $Y=351300
X3935 2920 497 2 2967 1 2911 MUX2S $T=632400 366800 1 0 $X=632400 $Y=361380
X3936 2945 492 2 2960 1 2942 MUX2S $T=633020 376880 1 0 $X=633020 $Y=371460
X3937 2872 2662 2 2971 1 2850 MUX2S $T=633640 397040 0 0 $X=633640 $Y=396660
X3938 2760 2687 2 2972 1 2968 MUX2S $T=633640 407120 1 0 $X=633640 $Y=401700
X3939 2880 2662 2 2973 1 2905 MUX2S $T=633640 407120 0 0 $X=633640 $Y=406740
X3940 2950 412 2 2977 1 2880 MUX2S $T=634260 386960 1 0 $X=634260 $Y=381540
X3941 2937 412 2 2946 1 2924 MUX2S $T=638600 397040 0 180 $X=634260 $Y=391620
X3942 2928 2898 2 2984 1 2870 MUX2S $T=636740 346640 1 0 $X=636740 $Y=341220
X3943 2936 2898 2 2985 1 2952 MUX2S $T=636740 346640 0 0 $X=636740 $Y=346260
X3944 2742 481 2 2987 1 2998 MUX2S $T=637360 336560 1 0 $X=637360 $Y=331140
X3945 2967 497 2 2988 1 2936 MUX2S $T=637360 366800 1 0 $X=637360 $Y=361380
X3946 2966 497 2 2983 1 2956 MUX2S $T=642940 356720 1 180 $X=638600 $Y=356340
X3947 2982 492 2 2994 1 2966 MUX2S $T=638600 366800 0 0 $X=638600 $Y=366420
X3948 2803 2687 2 2995 1 2992 MUX2S $T=638600 417200 1 0 $X=638600 $Y=411780
X3949 2991 412 2 2989 1 2973 MUX2S $T=644180 397040 0 180 $X=639840 $Y=391620
X3950 2977 412 2 2991 1 2971 MUX2S $T=644800 386960 1 180 $X=640460 $Y=386580
X3951 2983 497 2 2999 1 2984 MUX2S $T=646660 346640 0 180 $X=642320 $Y=341220
X3952 2978 484 2 3009 1 2977 MUX2S $T=642320 376880 0 0 $X=642320 $Y=376500
X3953 3009 484 2 3002 1 2937 MUX2S $T=647280 386960 0 180 $X=642940 $Y=381540
X3954 3005 2777 2 3017 1 2985 MUX2S $T=644180 356720 0 0 $X=644180 $Y=356340
X3955 2790 481 2 3016 1 3025 MUX2S $T=644800 336560 1 0 $X=644800 $Y=331140
X3956 2994 492 2 3008 1 2988 MUX2S $T=649140 366800 1 180 $X=644800 $Y=366420
X3957 2988 497 2 3017 1 2963 MUX2S $T=645420 366800 1 0 $X=645420 $Y=361380
X3958 3020 484 2 2918 1 2946 MUX2S $T=651000 397040 0 180 $X=646660 $Y=391620
X3959 3002 484 2 3020 1 2991 MUX2S $T=651620 386960 1 180 $X=647280 $Y=386580
X3960 2722 481 2 3033 1 564 MUX2S $T=647900 346640 1 0 $X=647900 $Y=341220
X3961 2963 2898 2 3005 1 3033 MUX2S $T=648520 356720 1 0 $X=648520 $Y=351300
X3962 3008 492 2 3034 1 2983 MUX2S $T=654720 366800 1 180 $X=650380 $Y=366420
X3963 2786 481 2 3032 1 568 MUX2S $T=651000 336560 1 0 $X=651000 $Y=331140
X3964 3034 492 2 3005 1 3017 MUX2S $T=655340 366800 0 180 $X=651000 $Y=361380
X3965 3092 424 2 3019 1 578 MUX2S $T=665880 487760 0 180 $X=661540 $Y=482340
X3966 3164 604 2 601 1 3137 MUX2S $T=688820 457520 1 180 $X=684480 $Y=457140
X3967 626 620 2 3264 1 3233 MUX2S $T=715480 346640 1 180 $X=711140 $Y=346260
X3968 628 620 2 3268 1 3237 MUX2S $T=716100 356720 1 180 $X=711760 $Y=356340
X3969 3272 2662 2 3286 1 3288 MUX2S $T=713000 356720 1 0 $X=713000 $Y=351300
X3970 624 620 2 3289 1 3231 MUX2S $T=714240 376880 0 0 $X=714240 $Y=376500
X3971 625 620 2 3290 1 3277 MUX2S $T=714240 386960 1 0 $X=714240 $Y=381540
X3972 631 620 2 3281 1 3230 MUX2S $T=719200 366800 0 180 $X=714860 $Y=361380
X3973 627 620 2 3294 1 3298 MUX2S $T=714860 366800 0 0 $X=714860 $Y=366420
X3974 3288 2687 2 3301 1 3295 MUX2S $T=716720 397040 0 0 $X=716720 $Y=396660
X3975 3293 2662 2 3309 1 3268 MUX2S $T=717340 356720 0 0 $X=717340 $Y=356340
X3976 3327 412 2 3302 1 3293 MUX2S $T=723540 356720 0 180 $X=719200 $Y=351300
X3977 3319 2662 2 3303 1 3301 MUX2S $T=723540 397040 0 180 $X=719200 $Y=391620
X3978 637 632 2 3293 1 625 MUX2S $T=724160 336560 0 180 $X=719820 $Y=331140
X3979 3311 2662 2 3308 1 627 MUX2S $T=724160 346640 0 180 $X=719820 $Y=341220
X3980 3309 2662 2 3303 1 3290 MUX2S $T=724160 376880 1 180 $X=719820 $Y=376500
X3981 634 620 2 3310 1 3223 MUX2S $T=724160 386960 0 180 $X=719820 $Y=381540
X3982 3320 604 2 3219 1 3307 MUX2S $T=724160 467600 1 180 $X=719820 $Y=467220
X3983 3312 412 2 3318 1 3309 MUX2S $T=720440 366800 0 0 $X=720440 $Y=366420
X3984 3286 2662 2 3319 1 3289 MUX2S $T=720440 376880 1 0 $X=720440 $Y=371460
X3985 3302 412 2 3312 1 3286 MUX2S $T=725400 366800 0 180 $X=721060 $Y=361380
X3986 3268 2687 2 3303 1 3333 MUX2S $T=721060 407120 1 0 $X=721060 $Y=401700
X3987 3264 2687 2 3324 1 3305 MUX2S $T=722300 397040 0 0 $X=722300 $Y=396660
X3988 3323 2662 2 3321 1 3264 MUX2S $T=727880 356720 1 180 $X=723540 $Y=356340
X3989 640 2662 2 3323 1 634 MUX2S $T=729120 336560 1 180 $X=724780 $Y=336180
X3990 3331 412 2 3327 1 3272 MUX2S $T=729120 346640 0 180 $X=724780 $Y=341220
X3991 3342 412 2 3328 1 3323 MUX2S $T=729120 346640 1 180 $X=724780 $Y=346260
X3992 3321 2662 2 3338 1 3310 MUX2S $T=724780 386960 1 0 $X=724780 $Y=381540
X3993 3338 2662 2 3329 1 3324 MUX2S $T=729120 386960 1 180 $X=724780 $Y=386580
X3994 3347 2662 2 3329 1 3294 MUX2S $T=730360 376880 0 180 $X=726020 $Y=371460
X3995 3318 412 2 3303 1 3319 MUX2S $T=730360 376880 1 180 $X=726020 $Y=376500
X3996 3328 412 2 3337 1 3308 MUX2S $T=730980 366800 0 180 $X=726640 $Y=361380
X3997 3308 2662 2 3347 1 3281 MUX2S $T=726640 366800 0 0 $X=726640 $Y=366420
X3998 3289 2687 2 3303 1 3357 MUX2S $T=726640 407120 1 0 $X=726640 $Y=401700
X3999 3281 2687 2 3329 1 3371 MUX2S $T=728500 397040 0 0 $X=728500 $Y=396660
X4000 3368 484 2 3351 1 3327 MUX2S $T=734080 356720 0 180 $X=729740 $Y=351300
X4001 3329 643 2 3353 1 3338 MUX2S $T=734700 386960 0 180 $X=730360 $Y=381540
X4002 3310 2687 2 3329 1 3370 MUX2S $T=730360 386960 0 0 $X=730360 $Y=386580
X4003 3363 412 2 3353 1 3347 MUX2S $T=735940 376880 0 180 $X=731600 $Y=371460
X4004 3376 484 2 3329 1 3353 MUX2S $T=735940 376880 1 180 $X=731600 $Y=376500
X4005 3337 412 2 3363 1 3321 MUX2S $T=736560 366800 1 180 $X=732220 $Y=366420
X4006 3351 484 2 3366 1 3328 MUX2S $T=737180 356720 1 180 $X=732840 $Y=356340
X4007 3367 484 2 3368 1 3342 MUX2S $T=737800 346640 1 180 $X=733460 $Y=346260
X4008 3387 484 2 3385 1 3363 MUX2S $T=741520 376880 1 180 $X=737180 $Y=376500
X4009 3389 484 2 3386 1 3337 MUX2S $T=742140 366800 1 180 $X=737800 $Y=366420
X4010 3386 484 2 3387 1 3312 MUX2S $T=742140 376880 0 180 $X=737800 $Y=371460
X4011 3366 484 2 3389 1 3302 MUX2S $T=742760 366800 0 180 $X=738420 $Y=361380
X4012 3385 484 2 3376 1 3318 MUX2S $T=743380 386960 0 180 $X=739040 $Y=381540
X4013 686 3512 2 3500 1 3448 MUX2S $T=766940 366800 0 180 $X=762600 $Y=361380
X4014 685 3512 2 3505 1 3497 MUX2S $T=768180 376880 0 180 $X=763840 $Y=371460
X4015 688 3512 2 3506 1 3469 MUX2S $T=768180 376880 1 180 $X=763840 $Y=376500
X4016 690 481 2 3507 1 3466 MUX2S $T=768800 336560 1 180 $X=764460 $Y=336180
X4017 691 3512 2 3508 1 3468 MUX2S $T=768800 356720 1 180 $X=764460 $Y=356340
X4018 3504 3512 2 3529 1 3518 MUX2S $T=766320 386960 0 0 $X=766320 $Y=386580
X4019 3532 3539 2 3521 1 685 MUX2S $T=771900 346640 1 180 $X=767560 $Y=346260
X4020 3521 3539 2 3528 1 3500 MUX2S $T=773140 366800 0 180 $X=768800 $Y=361380
X4021 3530 3539 2 3533 1 3504 MUX2S $T=773760 356720 0 180 $X=769420 $Y=351300
X4022 692 3512 2 3545 1 3449 MUX2S $T=769420 376880 0 0 $X=769420 $Y=376500
X4023 3507 3512 2 3546 1 3549 MUX2S $T=769420 386960 1 0 $X=769420 $Y=381540
X4024 3533 3539 2 3529 1 3508 MUX2S $T=774380 356720 1 180 $X=770040 $Y=356340
X4025 3528 3539 2 3529 1 3505 MUX2S $T=774380 376880 0 180 $X=770040 $Y=371460
X4026 695 693 2 3537 1 692 MUX2S $T=775000 336560 1 180 $X=770660 $Y=336180
X4027 3500 3512 2 3529 1 3566 MUX2S $T=773760 386960 0 0 $X=773760 $Y=386580
X4028 3576 497 2 3555 1 3533 MUX2S $T=778720 366800 0 180 $X=774380 $Y=361380
X4029 3565 693 2 3556 1 688 MUX2S $T=779340 346640 0 180 $X=775000 $Y=341220
X4030 3573 3539 2 3557 1 3506 MUX2S $T=779340 376880 1 180 $X=775000 $Y=376500
X4031 3577 3539 2 3557 1 3546 MUX2S $T=779340 386960 0 180 $X=775000 $Y=381540
X4032 697 3512 2 3571 1 3447 MUX2S $T=775620 356720 1 0 $X=775620 $Y=351300
X4033 3555 497 2 3529 1 3528 MUX2S $T=779960 376880 0 180 $X=775620 $Y=371460
X4034 3556 3539 2 3573 1 3571 MUX2S $T=776240 356720 0 0 $X=776240 $Y=356340
X4035 3537 3539 2 3570 1 3507 MUX2S $T=782440 346640 1 180 $X=778100 $Y=346260
X4036 3545 3512 2 3557 1 3598 MUX2S $T=778720 397040 1 0 $X=778720 $Y=391620
X4037 3571 3512 2 3557 1 3578 MUX2S $T=779340 386960 0 0 $X=779340 $Y=386580
X4038 3591 497 2 3576 1 3521 MUX2S $T=784920 366800 0 180 $X=780580 $Y=361380
X4039 3570 3539 2 3577 1 3545 MUX2S $T=780580 386960 1 0 $X=780580 $Y=381540
X4040 3592 497 2 3584 1 3570 MUX2S $T=785540 366800 1 180 $X=781200 $Y=366420
X4041 3584 497 2 3585 1 3573 MUX2S $T=785540 376880 1 180 $X=781200 $Y=376500
X4042 3582 497 2 3591 1 3530 MUX2S $T=786160 356720 0 180 $X=781820 $Y=351300
X4043 3601 497 2 3592 1 3556 MUX2S $T=786160 356720 1 180 $X=781820 $Y=356340
X4044 3596 497 2 3601 1 3537 MUX2S $T=788020 346640 1 180 $X=783680 $Y=346260
X4045 3557 705 2 3585 1 3577 MUX2S $T=789260 386960 1 180 $X=784920 $Y=386580
X4046 3622 492 2 3611 1 3591 MUX2S $T=790500 366800 0 180 $X=786160 $Y=361380
X4047 3631 3636 2 3557 1 3585 MUX2S $T=791120 376880 1 180 $X=786780 $Y=376500
X4048 3632 492 2 3618 1 3582 MUX2S $T=791740 356720 0 180 $X=787400 $Y=351300
X4049 3618 3636 2 3622 1 3601 MUX2S $T=792360 356720 1 180 $X=788020 $Y=356340
X4050 3619 3636 2 3631 1 3555 MUX2S $T=793600 376880 0 180 $X=789260 $Y=371460
X4051 3611 3636 2 3651 1 3592 MUX2S $T=792980 366800 0 0 $X=792980 $Y=366420
X4052 3649 3636 2 3619 1 3584 MUX2S $T=797320 376880 1 180 $X=792980 $Y=376500
X4053 3651 3636 2 3649 1 3576 MUX2S $T=799180 376880 0 180 $X=794840 $Y=371460
X4054 3703 3659 2 3674 1 3662 MUX2S $T=804760 447440 0 180 $X=800420 $Y=442020
X4055 3709 719 2 3685 1 716 MUX2S $T=804760 497840 0 180 $X=800420 $Y=492420
X4056 3687 3659 2 3699 1 3708 MUX2S $T=801040 437360 0 0 $X=801040 $Y=436980
X4057 3711 3681 2 3684 1 3674 MUX2S $T=806000 437360 0 180 $X=801660 $Y=431940
X4058 723 3725 2 3700 1 3657 MUX2S $T=807860 376880 0 180 $X=803520 $Y=371460
X4059 3738 719 2 3696 1 724 MUX2S $T=810340 497840 0 180 $X=806000 $Y=492420
X4060 3742 3659 2 3719 1 3612 MUX2S $T=810960 437360 1 180 $X=806620 $Y=436980
X4061 3751 719 2 3722 1 3624 MUX2S $T=811580 487760 1 180 $X=807240 $Y=487380
X4062 3642 3747 2 3726 1 3684 MUX2S $T=812200 427280 1 180 $X=807860 $Y=426900
X4063 731 3725 2 3724 1 3688 MUX2S $T=812820 366800 0 180 $X=808480 $Y=361380
X4064 732 3725 2 3727 1 3670 MUX2S $T=812820 386960 1 180 $X=808480 $Y=386580
X4065 3724 3725 2 3735 1 3741 MUX2S $T=808480 397040 1 0 $X=808480 $Y=391620
X4066 3720 3746 2 3731 1 3729 MUX2S $T=813440 356720 1 180 $X=809100 $Y=356340
X4067 3753 3746 2 3732 1 3724 MUX2S $T=813440 366800 1 180 $X=809100 $Y=366420
X4068 3788 3750 2 3733 1 3685 MUX2S $T=813440 477680 0 180 $X=809100 $Y=472260
X4069 3731 3746 2 3735 1 3700 MUX2S $T=814060 376880 0 180 $X=809720 $Y=371460
X4070 3729 3725 2 3735 1 3737 MUX2S $T=809720 407120 1 0 $X=809720 $Y=401700
X4071 3762 725 2 3735 1 3732 MUX2S $T=815920 386960 0 180 $X=811580 $Y=381540
X4072 3799 719 2 3723 1 728 MUX2S $T=816540 497840 0 180 $X=812200 $Y=492420
X4073 3801 3681 2 3740 1 3699 MUX2S $T=817160 437360 1 180 $X=812820 $Y=436980
X4074 3744 3778 2 3668 1 3752 MUX2S $T=817160 467600 1 180 $X=812820 $Y=467220
X4075 3761 3774 2 3642 1 3740 MUX2S $T=817780 437360 0 180 $X=813440 $Y=431940
X4076 3775 3659 2 3671 1 3743 MUX2S $T=817780 447440 1 180 $X=813440 $Y=447060
X4077 3777 3750 2 3745 1 3696 MUX2S $T=817780 487760 1 180 $X=813440 $Y=487380
X4078 3732 3746 2 3735 1 3727 MUX2S $T=818400 386960 1 180 $X=814060 $Y=386580
X4079 3766 3781 2 3642 1 3726 MUX2S $T=818400 427280 1 180 $X=814060 $Y=426900
X4080 3763 3780 2 3668 1 3745 MUX2S $T=818400 487760 0 180 $X=814060 $Y=482340
X4081 740 3725 2 3759 1 3679 MUX2S $T=819020 356720 0 180 $X=814680 $Y=351300
X4082 3784 3746 2 3753 1 732 MUX2S $T=819020 366800 0 180 $X=814680 $Y=361380
X4083 3668 3787 2 3752 1 3733 MUX2S $T=819020 477680 1 180 $X=814680 $Y=477300
X4084 3791 725 2 3764 1 3720 MUX2S $T=819640 356720 1 180 $X=815300 $Y=356340
X4085 3764 725 2 3765 1 3753 MUX2S $T=819640 366800 1 180 $X=815300 $Y=366420
X4086 3765 725 2 3762 1 3731 MUX2S $T=819640 376880 1 180 $X=815300 $Y=376500
X4087 3758 3781 2 3766 1 3761 MUX2S $T=819640 427280 0 180 $X=815300 $Y=421860
X4088 3728 3725 2 3772 1 3678 MUX2S $T=820880 397040 0 180 $X=816540 $Y=391620
X4089 3734 3778 2 3744 1 3763 MUX2S $T=820880 467600 0 180 $X=816540 $Y=462180
X4090 3776 3778 2 3734 1 3797 MUX2S $T=817160 457520 0 0 $X=817160 $Y=457140
X4091 3754 741 2 3730 1 3762 MUX2S $T=822120 386960 0 180 $X=817780 $Y=381540
X4092 3759 3725 2 3768 1 3773 MUX2S $T=823360 397040 1 180 $X=819020 $Y=396660
X4093 3800 3681 2 3785 1 3671 MUX2S $T=823360 437360 0 180 $X=819020 $Y=431940
X4094 3785 3681 2 3642 1 3786 MUX2S $T=819020 447440 1 0 $X=819020 $Y=442020
X4095 3822 3659 2 3786 1 3594 MUX2S $T=823360 447440 1 180 $X=819020 $Y=447060
X4096 3790 3750 2 3668 1 739 MUX2S $T=823360 487760 1 180 $X=819020 $Y=487380
X4097 748 3725 2 3789 1 3652 MUX2S $T=823980 386960 1 180 $X=819640 $Y=386580
X4098 3838 3750 2 3790 1 3723 MUX2S $T=823980 487760 0 180 $X=819640 $Y=482340
X4099 3797 3780 2 3752 1 3790 MUX2S $T=824600 477680 1 180 $X=820260 $Y=477300
X4100 3782 3746 2 3802 1 746 MUX2S $T=820880 366800 0 0 $X=820880 $Y=366420
X4101 3802 3746 2 3796 1 3759 MUX2S $T=825220 376880 1 180 $X=820880 $Y=376500
X4102 3798 3781 2 3758 1 3795 MUX2S $T=825220 427280 0 180 $X=820880 $Y=421860
X4103 3807 3780 2 3797 1 3788 MUX2S $T=825220 477680 0 180 $X=820880 $Y=472260
X4104 746 3725 2 3812 1 3677 MUX2S $T=822740 397040 1 0 $X=822740 $Y=391620
X4105 3730 741 2 3768 1 3821 MUX2S $T=823360 386960 1 0 $X=823360 $Y=381540
X4106 3789 3725 2 3768 1 3803 MUX2S $T=824600 397040 0 0 $X=824600 $Y=396660
X4107 3834 3774 2 3761 1 3805 MUX2S $T=828940 437360 0 180 $X=824600 $Y=431940
X4108 3825 3659 2 3806 1 3609 MUX2S $T=828940 447440 0 180 $X=824600 $Y=442020
X4109 3829 719 2 3808 1 742 MUX2S $T=828940 497840 0 180 $X=824600 $Y=492420
X4110 3828 3780 2 3763 1 3811 MUX2S $T=829560 477680 1 180 $X=825220 $Y=477300
X4111 3796 3746 2 3768 1 3812 MUX2S $T=830180 386960 1 180 $X=825840 $Y=386580
X4112 3814 3774 2 3795 1 3711 MUX2S $T=830180 427280 1 180 $X=825840 $Y=426900
X4113 3830 725 2 3819 1 3817 MUX2S $T=830800 366800 0 180 $X=826460 $Y=361380
X4114 3817 3746 2 3826 1 3728 MUX2S $T=826460 376880 1 0 $X=826460 $Y=371460
X4115 3815 3781 2 3798 1 3834 MUX2S $T=826460 427280 1 0 $X=826460 $Y=421860
X4116 3810 3778 2 3776 1 3828 MUX2S $T=826460 477680 1 0 $X=826460 $Y=472260
X4117 3835 725 2 3821 1 3796 MUX2S $T=831420 376880 1 180 $X=827080 $Y=376500
X4118 3768 751 2 3821 1 3839 MUX2S $T=827700 386960 1 0 $X=827700 $Y=381540
X4119 3839 3746 2 3768 1 3772 MUX2S $T=833280 397040 0 180 $X=828940 $Y=391620
X4120 3845 3659 2 3760 1 3827 MUX2S $T=833900 447440 0 180 $X=829560 $Y=442020
X4121 3846 3681 2 3805 1 3760 MUX2S $T=834520 437360 1 180 $X=830180 $Y=436980
X4122 3836 3780 2 3828 1 3777 MUX2S $T=835140 477680 1 180 $X=830800 $Y=477300
X4123 3850 719 2 3714 1 752 MUX2S $T=835140 497840 0 180 $X=830800 $Y=492420
X4124 3855 3774 2 3834 1 3801 MUX2S $T=835760 427280 1 180 $X=831420 $Y=426900
X4125 3849 3778 2 3824 1 3836 MUX2S $T=835760 467600 0 180 $X=831420 $Y=462180
X4126 3851 741 2 3754 1 3835 MUX2S $T=836380 386960 0 180 $X=832040 $Y=381540
X4127 3826 3746 2 3839 1 3789 MUX2S $T=832040 386960 0 0 $X=832040 $Y=386580
X4128 3840 3781 2 3844 1 3857 MUX2S $T=832040 417200 0 0 $X=832040 $Y=416820
X4129 3858 3750 2 3811 1 3714 MUX2S $T=836380 487760 0 180 $X=832040 $Y=482340
X4130 3847 741 2 3843 1 3819 MUX2S $T=837000 366800 0 180 $X=832660 $Y=361380
X4131 3854 725 2 3835 1 3826 MUX2S $T=837000 376880 1 180 $X=832660 $Y=376500
X4132 3860 3780 2 3807 1 3838 MUX2S $T=837000 477680 0 180 $X=832660 $Y=472260
X4133 3819 725 2 3854 1 3802 MUX2S $T=833280 366800 0 0 $X=833280 $Y=366420
X4134 3857 3774 2 3814 1 3800 MUX2S $T=838240 427280 0 180 $X=833900 $Y=421860
X4135 3842 3778 2 3849 1 3860 MUX2S $T=833900 467600 0 0 $X=833900 $Y=467220
X4136 3863 741 2 3847 1 3791 MUX2S $T=838860 356720 0 180 $X=834520 $Y=351300
X4137 3844 3781 2 3833 1 3855 MUX2S $T=834520 417200 1 0 $X=834520 $Y=411780
X4138 3873 3681 2 3801 1 3742 MUX2S $T=840720 437360 0 180 $X=836380 $Y=431940
X4139 3866 3750 2 3788 1 3717 MUX2S $T=840720 477680 1 180 $X=836380 $Y=477300
X4140 3870 3681 2 3711 1 3667 MUX2S $T=841340 427280 1 180 $X=837000 $Y=426900
X4141 3876 741 2 3851 1 3765 MUX2S $T=841960 386960 1 180 $X=837620 $Y=386580
X4142 3843 741 2 3861 1 3764 MUX2S $T=842580 366800 1 180 $X=838240 $Y=366420
X4143 3887 3750 2 3777 1 3751 MUX2S $T=842580 487760 0 180 $X=838240 $Y=482340
X4144 3872 3780 2 3860 1 3866 MUX2S $T=843200 477680 0 180 $X=838860 $Y=472260
X4145 3861 741 2 3876 1 3854 MUX2S $T=839480 376880 0 0 $X=839480 $Y=376500
X4146 3877 3774 2 3857 1 3870 MUX2S $T=844440 427280 0 180 $X=840100 $Y=421860
X4147 3896 3780 2 3836 1 3858 MUX2S $T=846300 477680 1 180 $X=841960 $Y=477300
X4148 3894 3774 2 3855 1 3846 MUX2S $T=846920 427280 1 180 $X=842580 $Y=426900
X4149 3898 3681 2 3800 1 3822 MUX2S $T=846920 437360 0 180 $X=842580 $Y=431940
X4150 3911 3750 2 3838 1 769 MUX2S $T=848780 487760 0 180 $X=844440 $Y=482340
X4151 3902 3904 2 3896 1 3887 MUX2S $T=851260 477680 1 180 $X=846920 $Y=477300
X4152 3901 3774 2 3894 1 3873 MUX2S $T=853120 427280 1 180 $X=848780 $Y=426900
X4153 3928 3750 2 3858 1 3829 MUX2S $T=854360 487760 0 180 $X=850020 $Y=482340
X4154 3933 3681 2 3846 1 3825 MUX2S $T=858700 437360 0 180 $X=854360 $Y=431940
X4155 3982 3750 2 3948 1 3874 MUX2S $T=866760 487760 0 180 $X=862420 $Y=482340
X4156 4296 3781 2 4306 1 4337 MUX2S $T=927520 427280 0 0 $X=927520 $Y=426900
X4157 4306 3781 2 4321 1 4332 MUX2S $T=930620 437360 1 0 $X=930620 $Y=431940
X4158 4345 3781 2 4296 1 4328 MUX2S $T=938680 427280 0 180 $X=934340 $Y=421860
X4159 4337 3774 2 4350 1 4353 MUX2S $T=936820 427280 0 0 $X=936820 $Y=426900
X4160 4321 3781 2 4347 1 4350 MUX2S $T=936820 437360 1 0 $X=936820 $Y=431940
X4161 4353 4018 2 4347 1 4375 MUX2S $T=939920 437360 0 0 $X=939920 $Y=436980
X4162 4351 3951 2 4334 1 4393 MUX2S $T=939920 477680 0 0 $X=939920 $Y=477300
X4163 4377 3781 2 4345 1 4363 MUX2S $T=946120 427280 0 180 $X=941780 $Y=421860
X4164 4363 3774 2 4337 1 4381 MUX2S $T=943020 427280 0 0 $X=943020 $Y=426900
X4165 4334 3951 2 4362 1 4385 MUX2S $T=943020 487760 1 0 $X=943020 $Y=482340
X4166 4347 4387 2 4350 1 4370 MUX2S $T=947980 437360 0 180 $X=943640 $Y=431940
X4167 4379 3951 2 4351 1 4406 MUX2S $T=945500 477680 1 0 $X=945500 $Y=472260
X4168 4381 4018 2 4370 1 4371 MUX2S $T=950460 437360 1 180 $X=946120 $Y=436980
X4169 4389 3774 2 4328 1 4410 MUX2S $T=948600 427280 0 0 $X=948600 $Y=426900
X4170 4362 3951 2 998 1 4412 MUX2S $T=949220 487760 1 0 $X=949220 $Y=482340
X4171 4425 3781 2 4377 1 4389 MUX2S $T=954180 427280 0 180 $X=949840 $Y=421860
X4172 4328 3774 2 4332 1 4414 MUX2S $T=949840 437360 1 0 $X=949840 $Y=431940
X4173 4405 3951 2 4379 1 4392 MUX2S $T=954800 467600 1 180 $X=950460 $Y=467220
X4174 4393 3904 2 4412 1 1015 MUX2S $T=951080 477680 0 0 $X=951080 $Y=477300
X4175 4417 4018 2 4353 1 4366 MUX2S $T=956660 437360 1 180 $X=952320 $Y=436980
X4176 4435 4416 2 4375 1 4401 MUX2S $T=957280 447440 1 180 $X=952940 $Y=447060
X4177 4430 4416 2 4399 1 4365 MUX2S $T=957280 457520 0 180 $X=952940 $Y=452100
X4178 4443 3774 2 4363 1 4417 MUX2S $T=959140 427280 1 180 $X=954800 $Y=426900
X4179 4332 3774 2 4397 1 4454 MUX2S $T=956040 437360 1 0 $X=956040 $Y=431940
X4180 998 4447 2 4412 1 4428 MUX2S $T=960380 487760 0 180 $X=956040 $Y=482340
X4181 4448 876 2 4428 1 4419 MUX2S $T=960380 487760 1 180 $X=956040 $Y=487380
X4182 4451 3951 2 4405 1 4431 MUX2S $T=961000 477680 0 180 $X=956660 $Y=472260
X4183 4392 3904 2 4393 1 4448 MUX2S $T=956660 477680 0 0 $X=956660 $Y=477300
X4184 4467 4416 2 4434 1 4383 MUX2S $T=963480 447440 1 180 $X=959140 $Y=447060
X4185 4472 3781 2 4425 1 4443 MUX2S $T=964100 427280 0 180 $X=959760 $Y=421860
X4186 4477 3774 2 4443 1 4449 MUX2S $T=965340 427280 1 180 $X=961000 $Y=426900
X4187 4406 3904 2 4385 1 1035 MUX2S $T=961620 487760 1 0 $X=961620 $Y=482340
X4188 4385 3904 2 994 1 4478 MUX2S $T=961620 487760 0 0 $X=961620 $Y=487380
X4189 4410 4018 2 4454 1 4459 MUX2S $T=966580 437360 0 180 $X=962240 $Y=431940
X4190 4460 3951 2 4451 1 4482 MUX2S $T=962240 477680 1 0 $X=962240 $Y=472260
X4191 4449 4018 2 4381 1 4430 MUX2S $T=969060 437360 1 180 $X=964720 $Y=436980
X4192 4495 3781 2 4472 1 4484 MUX2S $T=971540 427280 1 180 $X=967200 $Y=426900
X4193 4488 3951 2 4460 1 4510 MUX2S $T=967820 477680 1 0 $X=967820 $Y=472260
X4194 4482 3904 2 4392 1 1034 MUX2S $T=972160 487760 0 180 $X=967820 $Y=482340
X4195 4431 3904 2 4406 1 1042 MUX2S $T=967820 487760 0 0 $X=967820 $Y=487380
X4196 4484 3774 2 4389 1 4508 MUX2S $T=968440 437360 1 0 $X=968440 $Y=431940
X4197 1042 1041 2 4478 1 1002 MUX2S $T=972780 497840 0 180 $X=968440 $Y=492420
X4198 4524 4298 2 4476 1 4499 MUX2S $T=974640 457520 0 180 $X=970300 $Y=452100
X4199 4529 3781 2 4495 1 4477 MUX2S $T=975260 427280 0 180 $X=970920 $Y=421860
X4200 4522 4018 2 4410 1 4467 MUX2S $T=975260 447440 0 180 $X=970920 $Y=442020
X4201 4508 4018 2 4414 1 4496 MUX2S $T=975880 447440 1 180 $X=971540 $Y=447060
X4202 4505 3904 2 4482 1 4536 MUX2S $T=973400 477680 0 0 $X=973400 $Y=477300
X4203 4510 3904 2 4431 1 1055 MUX2S $T=973400 487760 1 0 $X=973400 $Y=482340
X4204 4536 1041 2 4448 1 1045 MUX2S $T=977740 487760 1 180 $X=973400 $Y=487380
X4205 1052 1041 2 1034 1 1043 MUX2S $T=978360 497840 0 180 $X=974020 $Y=492420
X4206 4534 3774 2 4484 1 4522 MUX2S $T=978980 437360 0 180 $X=974640 $Y=431940
X4207 4519 4018 2 4417 1 4435 MUX2S $T=981460 447440 0 180 $X=977120 $Y=442020
X4208 4558 4416 2 4371 1 4533 MUX2S $T=982080 447440 1 180 $X=977740 $Y=447060
X4209 4565 976 2 4419 1 1054 MUX2S $T=983320 497840 0 180 $X=978980 $Y=492420
X4210 4545 4018 2 4508 1 4524 MUX2S $T=985800 457520 0 180 $X=981460 $Y=452100
X4211 4593 4018 2 4449 1 4558 MUX2S $T=987660 447440 0 180 $X=983320 $Y=442020
X4212 4602 4298 2 4459 1 4568 MUX2S $T=990760 447440 1 180 $X=986420 $Y=447060
X4213 4632 4416 2 4366 1 4609 MUX2S $T=996960 447440 1 180 $X=992620 $Y=447060
X4214 4697 4298 2 4496 1 4676 MUX2S $T=1009360 457520 1 180 $X=1005020 $Y=457140
X4215 4702 4416 2 4430 1 4733 MUX2S $T=1009360 457520 0 0 $X=1009360 $Y=457140
X4216 2612 2632 2605 1 2 XOR2H $T=561720 427280 0 0 $X=561720 $Y=426900
X4217 2556 1 2534 2543 2 2537 ND3HT $T=549940 386960 1 180 $X=542500 $Y=386580
X4218 2696 1 2643 2649 2 2673 ND3HT $T=574120 447440 0 180 $X=566680 $Y=442020
X4219 3136 1 3149 3140 2 3125 ND3HT $T=677040 427280 0 0 $X=677040 $Y=426900
X4220 2675 2662 2738 2746 2 1 MXL2HS $T=579080 407120 0 0 $X=579080 $Y=406740
X4221 2745 2662 2709 2761 2 1 MXL2HS $T=582800 397040 0 0 $X=582800 $Y=396660
X4222 496 488 487 2813 2 1 MXL2HS $T=595200 336560 0 0 $X=595200 $Y=336180
X4223 4022 4018 3916 3988 2 1 MXL2HS $T=873580 447440 0 180 $X=868000 $Y=442020
X4224 4369 3774 4376 4382 2 1 MXL2HS $T=942400 447440 1 0 $X=942400 $Y=442020
X4225 4554 3951 4567 4556 2 1 MXL2HS $T=981460 487760 0 0 $X=981460 $Y=487380
X4226 479 2733 485 1 2 AN2B1T $T=579700 326480 0 0 $X=579700 $Y=326100
X4227 719 3952 880 1 2 AN2B1T $T=882260 487760 1 0 $X=882260 $Y=482340
X4228 4084 3978 4112 1 2 AN2B1T $T=887840 477680 0 0 $X=887840 $Y=477300
X4229 4116 4120 4115 1 2 AN2B1T $T=892180 457520 1 0 $X=892180 $Y=452100
X4230 4118 3976 4139 1 2 AN2B1T $T=892800 427280 0 0 $X=892800 $Y=426900
X4231 4874 4702 4896 1 2 AN2B1T $T=1038500 457520 1 0 $X=1038500 $Y=452100
X4232 1236 1238 1241 1 2 AN2B1T $T=1058960 497840 1 0 $X=1058960 $Y=492420
X4233 4896 5032 5046 1 2 AN2B1T $T=1085000 457520 0 0 $X=1085000 $Y=457140
X4234 4927 5063 5032 1 2 AN2B1T $T=1089340 457520 1 0 $X=1089340 $Y=452100
X4235 1436 96 1368 1 2 1605 OA12 $T=270940 487760 0 180 $X=267220 $Y=482340
X4236 1643 1340 1607 1 2 1392 OA12 $T=277760 417200 1 180 $X=274040 $Y=416820
X4237 1546 1717 162 1 2 1576 OA12 $T=292020 407120 0 180 $X=288300 $Y=401700
X4238 1898 1874 1734 1 2 1338 OA12 $T=332320 407120 0 180 $X=328600 $Y=401700
X4239 1905 223 1920 1 2 1929 OA12 $T=337280 457520 0 0 $X=337280 $Y=457140
X4240 206 1861 1944 1 2 1967 OA12 $T=347820 417200 0 0 $X=347820 $Y=416820
X4241 2551 2554 2679 1 2 475 OA12 $T=569780 366800 1 0 $X=569780 $Y=361380
X4242 779 801 809 1 2 3954 OA12 $T=856840 366800 0 0 $X=856840 $Y=366420
X4243 3524 4174 4108 1 2 4161 OA12 $T=904580 447440 0 180 $X=900860 $Y=442020
X4244 4121 913 4095 1 2 4156 OA12 $T=902100 467600 1 0 $X=902100 $Y=462180
X4245 996 854 4390 1 2 4250 OA12 $T=955420 366800 0 180 $X=951700 $Y=361380
X4246 1056 1004 4548 1 2 4572 OA12 $T=978360 366800 1 0 $X=978360 $Y=361380
X4247 4619 4629 4462 1 2 4618 OA12 $T=996960 397040 1 180 $X=993240 $Y=396660
X4248 1050 4707 4856 1 2 4869 OA12 $T=1034780 376880 0 0 $X=1034780 $Y=376500
X4249 979 913 4821 1 2 4872 OA12 $T=1035400 487760 1 0 $X=1035400 $Y=482340
X4250 4305 4174 4892 1 2 4878 OA12 $T=1039740 467600 0 0 $X=1039740 $Y=467220
X4251 447 2554 2570 2 2581 2551 1 AO22P $T=548700 366800 0 0 $X=548700 $Y=366420
X4252 450 2554 2574 2 2584 2551 1 AO22P $T=549320 376880 1 0 $X=549320 $Y=371460
X4253 3982 3904 4019 2 4001 4035 1 AO22P $T=869240 477680 1 0 $X=869240 $Y=472260
X4254 1139 4174 4754 2 4733 4305 1 AO22P $T=1015560 477680 1 0 $X=1015560 $Y=472260
X4255 4888 4292 4956 2 4886 4305 1 AO22P $T=1057720 457520 0 180 $X=1052140 $Y=452100
X4256 4970 4292 4984 2 4912 4305 1 AO22P $T=1057720 457520 1 0 $X=1057720 $Y=452100
X4257 5019 913 5000 2 4881 979 1 AO22P $T=1070120 487760 0 180 $X=1064540 $Y=482340
X4258 1272 4174 5074 2 4927 4305 1 AO22P $T=1088100 457520 0 180 $X=1082520 $Y=452100
X4259 1280 4174 5039 2 4896 4305 1 AO22P $T=1089340 467600 1 180 $X=1083760 $Y=467220
X4260 1974 243 1 1971 1845 243 2 MOAI1 $T=354640 487760 1 180 $X=350300 $Y=487380
X4261 1983 243 1 1972 1907 243 2 MOAI1 $T=354640 497840 0 180 $X=350300 $Y=492420
X4262 510 406 1 406 548 468 2 MOAI1 $T=631780 477680 0 0 $X=631780 $Y=477300
X4263 463 406 1 406 543 472 2 MOAI1 $T=636740 457520 1 180 $X=632400 $Y=457140
X4264 911 4046 1 4223 4148 4046 2 MOAI1 $T=915120 407120 0 180 $X=910780 $Y=401700
X4265 4231 4046 1 4220 4252 4046 2 MOAI1 $T=917600 417200 1 0 $X=917600 $Y=411780
X4266 4303 4046 1 4288 4243 4046 2 MOAI1 $T=930620 397040 1 180 $X=926280 $Y=396660
X4267 4355 4372 1 4340 4384 4372 2 MOAI1 $T=943640 397040 0 0 $X=943640 $Y=396660
X4268 896 4380 1 4356 4420 4380 2 MOAI1 $T=946740 407120 1 0 $X=946740 $Y=401700
X4269 911 4372 1 4400 4444 4372 2 MOAI1 $T=957900 397040 0 0 $X=957900 $Y=396660
X4270 1401 1328 1 1623 2 OR2B1S $T=269700 417200 1 0 $X=269700 $Y=411780
X4271 2584 2600 1 2603 2 OR2B1S $T=556140 376880 1 0 $X=556140 $Y=371460
X4272 2768 2757 1 2744 2 OR2B1S $T=588380 386960 0 180 $X=585280 $Y=381540
X4273 4113 4079 1 844 2 OR2B1S $T=892800 376880 0 0 $X=892800 $Y=376500
X4274 880 921 1 4171 2 OR2B1S $T=907680 487760 1 180 $X=904580 $Y=487380
X4275 4076 4290 1 4265 2 OR2B1S $T=925040 427280 1 0 $X=925040 $Y=421860
X4276 4076 4018 1 4386 2 OR2B1S $T=946120 417200 0 0 $X=946120 $Y=416820
X4277 4424 4532 1 1050 2 OR2B1S $T=975260 376880 1 0 $X=975260 $Y=371460
X4278 2549 2554 2 2566 2519 2551 1 AOI22H $T=546220 356720 1 0 $X=546220 $Y=351300
X4279 455 2607 2 2614 2615 462 1 AOI22H $T=556140 366800 1 0 $X=556140 $Y=361380
X4280 4829 979 1 5053 5058 979 2 MOAI1H $T=1077560 487760 0 0 $X=1077560 $Y=487380
X4281 2648 2668 1 2555 2 NR2T $T=566680 376880 1 0 $X=566680 $Y=371460
X4282 665 670 1 648 2 NR2T $T=743380 326480 0 0 $X=743380 $Y=326100
X4283 4554 658 1 3910 2 NR2T $T=988280 477680 1 180 $X=983320 $Y=477300
X4284 4635 1098 1 3955 2 NR2T $T=992620 457520 0 0 $X=992620 $Y=457140
X4285 4855 4756 1 4804 2 NR2T $T=1035400 487760 0 180 $X=1030440 $Y=482340
X4286 4886 4746 1 4868 2 NR2T $T=1040360 437360 0 180 $X=1035400 $Y=431940
X4287 4892 4736 1 4868 2 NR2T $T=1036020 447440 1 0 $X=1036020 $Y=442020
X4288 4912 4753 1 4868 2 NR2T $T=1045940 437360 1 180 $X=1040980 $Y=436980
X4289 1360 1382 1385 1 2 1388 AO12 $T=228160 386960 1 0 $X=228160 $Y=381540
X4290 44 19 1409 1 2 1428 AO12 $T=235600 477680 1 0 $X=235600 $Y=472260
X4291 37 26 1581 1 2 1553 AO12 $T=265980 397040 1 180 $X=262260 $Y=396660
X4292 1712 1380 1620 1 2 1707 AO12 $T=293260 437360 1 180 $X=289540 $Y=436980
X4293 1730 1727 1534 1 2 1675 AO12 $T=295120 376880 1 180 $X=291400 $Y=376500
X4294 1643 1365 1408 1 2 162 AO12 $T=296360 407120 1 180 $X=292640 $Y=406740
X4295 1635 1737 1572 1 2 1714 AO12 $T=302560 427280 0 180 $X=298840 $Y=421860
X4296 1873 1861 1450 1 2 1916 AO12 $T=332940 427280 1 0 $X=332940 $Y=421860
X4297 1942 1929 1926 1 2 226 AO12 $T=342860 467600 0 180 $X=339140 $Y=462180
X4298 1947 1929 1926 1 2 229 AO12 $T=344720 477680 0 180 $X=341000 $Y=472260
X4299 245 206 235 1 2 1964 AO12 $T=352780 487760 0 180 $X=349060 $Y=482340
X4300 703 4130 4133 1 2 905 AO12 $T=894040 487760 0 0 $X=894040 $Y=487380
X4301 4200 4125 4190 1 2 4180 AO12 $T=907680 386960 0 180 $X=903960 $Y=381540
X4302 4174 4276 4270 1 2 4237 AO12 $T=921940 437360 0 0 $X=921940 $Y=436980
X4303 1024 4480 4483 1 2 4491 AO12 $T=965340 366800 1 0 $X=965340 $Y=361380
X4304 5010 1057 4728 1 2 5086 AO12 $T=1085000 356720 1 0 $X=1085000 $Y=351300
X4305 657 661 1 2 INV3 $T=742760 336560 1 0 $X=742760 $Y=331140
X4306 4734 4737 1 2 INV3 $T=1013700 487760 0 0 $X=1013700 $Y=487380
X4307 673 670 1 2 INV4 $T=747720 366800 0 0 $X=747720 $Y=366420
X4308 673 1098 1 2 INV4 $T=996960 487760 0 0 $X=996960 $Y=487380
X4309 2265 340 1 2 328 QDLHN $T=457560 497840 0 180 $X=450120 $Y=492420
X4310 2265 2296 1 2 337 QDLHN $T=462520 487760 1 180 $X=455080 $Y=487380
X4311 2265 2313 1 2 346 QDLHN $T=465000 497840 0 180 $X=457560 $Y=492420
X4312 2265 2345 1 2 320 QDLHN $T=505920 457520 0 180 $X=498480 $Y=452100
X4313 30 1378 1368 1366 2 1 1355 MAOI1 $T=230640 487760 1 180 $X=225680 $Y=487380
X4314 1482 1352 1465 1499 2 1 1479 MAOI1 $T=246140 427280 0 0 $X=246140 $Y=426900
X4315 887 4396 3949 4409 2 1 4408 MAOI1 $T=950460 346640 0 0 $X=950460 $Y=346260
X4316 4762 4917 4690 4875 2 1 4903 MAOI1 $T=1048420 376880 0 180 $X=1043460 $Y=371460
X4317 4666 4985 1152 1240 2 1 4944 MAOI1 $T=1059580 346640 1 0 $X=1059580 $Y=341220
X4318 1212 1247 4553 5043 2 1 5049 MAOI1 $T=1075080 346640 1 0 $X=1075080 $Y=341220
X4319 1454 1448 2 1444 1 53 AN3B2S $T=243040 427280 1 180 $X=239320 $Y=426900
X4320 1556 1553 2 1549 1 1424 AN3B2S $T=261020 397040 0 180 $X=257300 $Y=391620
X4321 1541 1553 2 1543 1 1573 AN3B2S $T=257920 397040 0 0 $X=257920 $Y=396660
X4322 1877 223 2 215 1 1952 AN3B2S $T=355260 437360 0 180 $X=351540 $Y=431940
X4323 920 4162 2 4082 1 4254 AN3B2S $T=914500 346640 0 0 $X=914500 $Y=346260
X4324 4284 808 2 4213 1 951 AN3B2S $T=925040 356720 1 0 $X=925040 $Y=351300
X4325 1070 4604 2 4650 1 4677 AN3B2S $T=1007500 356720 1 180 $X=1003780 $Y=356340
X4326 4700 4685 2 4613 1 1118 AN3B2S $T=1008740 346640 0 180 $X=1005020 $Y=341220
X4327 1157 1159 2 4792 1 4810 AN3B2S $T=1024240 407120 0 0 $X=1024240 $Y=406740
X4328 4788 4844 2 4860 1 4893 AN3B2S $T=1034160 417200 0 0 $X=1034160 $Y=416820
X4329 4880 4848 2 4859 1 4899 AN3B2S $T=1039740 397040 0 0 $X=1039740 $Y=396660
X4330 1715 134 44 129 2 1 169 AN4S $T=291400 487760 0 0 $X=291400 $Y=487380
X4331 1473 190 1449 102 2 1 205 AN4S $T=322400 497840 0 180 $X=317440 $Y=492420
X4332 1321 1326 1337 2 1345 1 1376 AO112 $T=221340 417200 0 0 $X=221340 $Y=416820
X4333 1503 40 89 2 1533 1 1540 AO112 $T=252340 467600 1 0 $X=252340 $Y=462180
X4334 1957 1907 1966 2 1698 1 1845 AO112 $T=352160 427280 0 0 $X=352160 $Y=426900
X4335 4141 4267 4240 2 4274 1 957 AO112 $T=920080 376880 0 0 $X=920080 $Y=376500
X4336 3147 385 395 3093 1 2 QDFFRBP $T=683240 397040 0 180 $X=670840 $Y=391620
X4337 3543 410 684 3409 1 2 QDFFRBP $T=772520 427280 0 180 $X=760120 $Y=421860
X4338 3890 760 684 733 1 2 QDFFRBP $T=842580 346640 1 180 $X=830180 $Y=346260
X4339 3940 760 684 725 1 2 QDFFRBP $T=856840 366800 1 180 $X=844440 $Y=366420
X4340 3919 3848 684 2687 1 2 QDFFRBP $T=859940 386960 0 180 $X=847540 $Y=381540
X4341 4544 4458 684 3904 1 2 QDFFRBP $T=979600 417200 1 0 $X=979600 $Y=411780
X4342 4624 4458 684 3781 1 2 QDFFRBP $T=993860 417200 1 180 $X=981460 $Y=416820
X4343 4641 4458 684 3951 1 2 QDFFRBP $T=998200 417200 1 0 $X=998200 $Y=411780
X4344 4760 4458 684 4018 1 2 QDFFRBP $T=1021140 427280 0 180 $X=1008740 $Y=421860
X4345 4867 4458 1134 3774 1 2 QDFFRBP $T=1034160 427280 0 180 $X=1021760 $Y=421860
X4346 4939 4458 1134 1197 1 2 QDFFRBP $T=1053380 427280 1 180 $X=1040980 $Y=426900
X4347 225 1946 1982 2 1 1965 OR3 $T=354020 467600 0 180 $X=350300 $Y=462180
X4348 484 482 2744 2 1 2675 OR3 $T=585900 386960 1 180 $X=582180 $Y=386580
X4349 2555 484 482 2 1 2732 OR3 $T=587140 376880 1 180 $X=583420 $Y=376500
X4350 4724 4773 4752 2 1 4616 OR3 $T=1020520 417200 0 180 $X=1016800 $Y=411780
X4351 2662 2667 2680 2 2683 2584 1 MUXB2 $T=567920 386960 1 0 $X=567920 $Y=381540
X4352 3774 4030 4094 2 4118 4159 1 MUXB2 $T=894660 417200 0 0 $X=894660 $Y=416820
X4353 3982 4100 4084 1 2 AN2B1 $T=887220 477680 1 0 $X=887220 $Y=472260
X4354 4651 4890 4868 1 2 AN2B1 $T=1039120 447440 0 0 $X=1039120 $Y=447060
X4355 2562 2571 2552 2583 2596 1 2 AO13P $T=549940 427280 0 0 $X=549940 $Y=426900
X4356 2616 2608 2596 2633 2649 1 2 AO13P $T=560480 437360 1 0 $X=560480 $Y=431940
X4357 3115 3121 3119 3110 3140 1 2 AO13P $T=671460 437360 1 0 $X=671460 $Y=431940
X4358 913 4952 2 4975 4989 1 AOI12H $T=1057100 467600 0 0 $X=1057100 $Y=467220
X4359 2313 2528 2265 2490 2 1 340 XOR4 $T=537540 487760 1 180 $X=522660 $Y=487380
X4360 632 2662 1 2 BUF4 $T=719200 336560 1 180 $X=714860 $Y=336180
X4361 3706 494 1 2 BUF4 $T=805380 376880 1 180 $X=801040 $Y=376500
X4362 1396 1388 1367 1379 2 1 1369 OA112 $T=232500 397040 1 180 $X=227540 $Y=396660
X4363 1339 1470 1426 1352 2 1 1451 OA112 $T=242420 447440 0 0 $X=242420 $Y=447060
X4364 1579 1556 111 47 2 1 1609 OA112 $T=262260 437360 0 0 $X=262260 $Y=436980
X4365 1485 1632 1409 90 2 1 1474 OA112 $T=275280 437360 0 180 $X=270320 $Y=431940
X4366 1607 1662 1546 1635 2 1 1552 OA112 $T=281480 427280 1 180 $X=276520 $Y=426900
X4367 1671 1545 187 188 2 1 1807 OA112 $T=303180 467600 0 0 $X=303180 $Y=467220
X4368 1773 1781 4 90 2 1 1535 OA112 $T=309380 437360 1 180 $X=304420 $Y=436980
X4369 1779 1797 42 1621 2 1 1770 OA112 $T=310620 457520 0 180 $X=305660 $Y=452100
X4370 1779 1814 1409 130 2 1 1802 OA112 $T=314340 477680 1 180 $X=309380 $Y=477300
X4371 3929 778 797 793 2 1 781 OA112 $T=856840 346640 1 180 $X=851880 $Y=346260
X4372 3929 3975 825 820 2 1 3922 OA112 $T=866760 356720 0 180 $X=861800 $Y=351300
X4373 4285 4247 882 834 2 1 4257 OA112 $T=923180 366800 0 180 $X=918220 $Y=361380
X4374 918 4294 877 825 2 1 4316 OA112 $T=927520 346640 1 0 $X=927520 $Y=341220
X4375 939 990 4364 873 2 1 977 OA112 $T=944880 326480 1 180 $X=939920 $Y=326100
X4376 4750 4745 4563 1096 2 1 4729 OA112 $T=1018040 397040 0 180 $X=1013080 $Y=391620
X4377 4750 4701 4540 1120 2 1 4772 OA112 $T=1018660 397040 0 0 $X=1018660 $Y=396660
X4378 4725 4771 1063 1120 2 1 4813 OA112 $T=1019900 326480 0 0 $X=1019900 $Y=326100
X4379 1167 1164 4590 4642 2 1 4797 OA112 $T=1030440 336560 1 180 $X=1025480 $Y=336180
X4380 1186 4925 4590 4569 2 1 4938 OA112 $T=1046560 397040 1 0 $X=1046560 $Y=391620
X4381 4962 4885 4590 1136 2 1 1214 OA112 $T=1054620 346640 1 180 $X=1049660 $Y=346260
X4382 4982 1228 4590 1120 2 1 4945 OA112 $T=1057720 356720 1 180 $X=1052760 $Y=356340
X4383 4738 1233 1110 1078 2 1 4990 OA112 $T=1057100 336560 1 0 $X=1057100 $Y=331140
X4384 4990 1206 4631 4667 2 1 4977 OA112 $T=1066400 386960 1 180 $X=1061440 $Y=386580
X4385 4908 5047 1063 4563 2 1 5071 OA112 $T=1077560 376880 1 0 $X=1077560 $Y=371460
X4386 4732 5086 5092 1209 2 1 5095 OA112 $T=1089340 346640 0 0 $X=1089340 $Y=346260
X4387 5085 4578 1057 4569 2 1 5098 OA112 $T=1089340 376880 1 0 $X=1089340 $Y=371460
X4388 2458 406 1 406 2481 2491 2 MOAI1HT $T=509020 397040 1 0 $X=509020 $Y=391620
X4389 2471 406 1 406 416 421 2 MOAI1HT $T=513980 417200 1 0 $X=513980 $Y=411780
X4390 2479 406 1 406 423 413 2 MOAI1HT $T=518940 386960 1 0 $X=518940 $Y=381540
X4391 411 406 1 406 419 429 2 MOAI1HT $T=520180 427280 1 0 $X=520180 $Y=421860
X4392 2501 406 1 406 425 442 2 MOAI1HT $T=528860 447440 0 0 $X=528860 $Y=447060
X4393 2735 406 1 406 505 511 2 MOAI1HT $T=592100 497840 1 0 $X=592100 $Y=492420
X4394 436 406 1 406 542 460 2 MOAI1HT $T=636120 487760 0 180 $X=617520 $Y=482340
X4395 1815 1701 1828 1 2 1727 AN3B1 $T=318060 386960 0 180 $X=313100 $Y=381540
X4396 603 495 1 2 INV1CK $T=697500 437360 0 0 $X=697500 $Y=436980
X4397 3848 3837 1 2 INV1CK $T=832660 376880 0 180 $X=830800 $Y=371460
X4398 3859 3837 1 2 INV1CK $T=838240 386960 0 180 $X=836380 $Y=381540
X4399 3837 3871 1 2 INV1CK $T=841960 376880 0 180 $X=840100 $Y=371460
X4400 4908 4898 4631 4710 2 1 4877 OA112S $T=1044700 356720 1 180 $X=1039740 $Y=356340
X4401 434 2522 2539 1 2 2548 HA1 $T=536920 477680 1 0 $X=536920 $Y=472260
X4402 2536 406 2522 1 2 2546 HA1 $T=553660 467600 1 180 $X=545600 $Y=467220
X4403 2586 2539 2594 1 2 2590 HA1 $T=548700 477680 0 0 $X=548700 $Y=477300
X4404 458 2594 2628 1 2 2610 HA1 $T=556140 467600 0 0 $X=556140 $Y=467220
X4405 3939 1 517 2 BUF4CK $T=851880 397040 1 180 $X=846920 $Y=396660
X4406 3962 760 684 3706 1 2 5100 DFFSBN $T=859320 376880 1 180 $X=846300 $Y=376500
X4407 3983 760 684 3068 1 2 5101 DFFSBN $T=864280 397040 0 180 $X=851260 $Y=391620
X4408 3996 760 684 3939 1 2 5102 DFFSBN $T=868000 407120 0 180 $X=854980 $Y=401700
X4409 4437 4458 684 1009 1 2 5103 DFFSBN $T=964100 417200 0 180 $X=951080 $Y=411780
X4410 4464 4458 684 4421 1 2 5104 DFFSBN $T=967200 407120 1 180 $X=954180 $Y=406740
X4411 4564 4458 684 4506 1 2 5105 DFFSBN $T=983940 407120 1 180 $X=970920 $Y=406740
X4412 885 825 2 1 4081 OR2S $T=889080 366800 0 180 $X=886600 $Y=361380
X4413 1048 4563 2 1 5060 OR2S $T=1080040 386960 0 0 $X=1080040 $Y=386580
X4414 4889 4906 4720 2 1 1200 OR3S $T=1045940 326480 1 180 $X=1042220 $Y=326100
X4415 4851 4821 4891 1 2 OR2P $T=1039120 487760 1 0 $X=1039120 $Y=482340
X4416 170 2 1663 1845 1 1829 1837 1857 1320 ICV_12 $T=318680 417200 1 0 $X=318680 $Y=411780
X4417 238 2 1879 1958 1 1958 1846 241 1320 ICV_12 $T=347820 447440 1 0 $X=347820 $Y=442020
X4418 2768 2 2897 531 1 494 2910 531 1320 ICV_12 $T=621240 376880 1 0 $X=621240 $Y=371460
X4419 2768 2 2923 537 1 517 534 509 1320 ICV_12 $T=626200 376880 1 0 $X=626200 $Y=371460
X4420 2768 2 3009 560 1 494 2994 560 1320 ICV_12 $T=648520 376880 1 0 $X=648520 $Y=371460
X4421 3374 2 3329 648 1 3374 3303 648 1320 ICV_12 $T=735320 386960 1 0 $X=735320 $Y=381540
X4422 648 2 3378 650 1 648 3367 653 1320 ICV_12 $T=739040 346640 1 0 $X=739040 $Y=341220
X4423 648 2 3389 669 1 648 3366 667 1320 ICV_12 $T=744000 366800 1 0 $X=744000 $Y=361380
X4424 648 2 3376 663 1 648 3385 3418 1320 ICV_12 $T=744000 386960 1 0 $X=744000 $Y=381540
X4425 494 2 3618 646 1 494 3632 666 1320 ICV_12 $T=793600 356720 1 0 $X=793600 $Y=351300
X4426 517 2 3847 646 1 517 3863 666 1320 ICV_12 $T=839480 356720 1 0 $X=839480 $Y=351300
X4427 803 2 4271 4213 1 779 765 924 1320 ICV_12 $T=923180 356720 1 0 $X=923180 $Y=351300
X4428 4202 2 4204 854 1 4202 1001 4279 1320 ICV_12 $T=946740 366800 1 0 $X=946740 $Y=361380
X4429 854 2 4335 4148 1 4146 4391 4252 1320 ICV_12 $T=950460 386960 0 180 $X=948600 $Y=381540
X4430 4466 2 4518 245 1 4501 4469 4441 1320 ICV_12 $T=972780 386960 1 0 $X=972780 $Y=381540
X4431 4604 2 1146 4791 1 4604 4776 4777 1320 ICV_12 $T=1020520 366800 1 0 $X=1020520 $Y=361380
X4432 4124 825 4216 1 2 4185 AN3S $T=909540 366800 0 0 $X=909540 $Y=366420
X4433 4531 4563 4543 1 2 4577 AN3S $T=982700 366800 0 0 $X=982700 $Y=366420
X4434 4226 877 825 881 2 1 4247 OA22S $T=913260 376880 1 0 $X=913260 $Y=371460
X4435 1062 4563 4530 1063 2 1 4578 OA22S $T=982080 376880 1 0 $X=982080 $Y=371460
X4436 2631 2536 434 2651 1 2 470 AO13S $T=564200 477680 0 0 $X=564200 $Y=477300
X4437 4078 910 4180 4177 1 2 4166 AO13S $T=906440 386960 1 180 $X=902100 $Y=386580
X4438 4469 1033 4491 4463 1 2 4473 AO13S $T=971540 376880 0 180 $X=967200 $Y=371460
X4439 4134 911 914 247 2 1 4046 OA13 $T=898380 407120 0 0 $X=898380 $Y=406740
X4440 3407 3419 3417 1 2 3457 XNR3S $T=745240 427280 0 0 $X=745240 $Y=426900
X4441 3416 3445 3455 1 2 XNR2HP $T=742760 417200 0 0 $X=742760 $Y=416820
X4442 2618 2637 1 2632 2 OR2B1T $T=561100 397040 0 0 $X=561100 $Y=396660
X4443 2551 2555 2567 1 2 2579 OR3B2T $T=546840 376880 0 0 $X=546840 $Y=376500
.ENDS
***************************************
.SUBCKT TIE1 O VCC GND
** N=4 EP=3 IP=0 FDC=0
.ENDS
***************************************
.SUBCKT MAOI1S B1 B2 A1 A2 VCC GND O
** N=8 EP=7 IP=0 FDC=0
.ENDS
***************************************
.SUBCKT MUXB2P S A B EB VCC O GND
** N=8 EP=7 IP=0 FDC=0
.ENDS
***************************************
.SUBCKT BUF6 I O GND VCC
** N=5 EP=4 IP=0 FDC=0
.ENDS
***************************************
.SUBCKT OAI12H B2 B1 GND A1 O VCC
** N=7 EP=6 IP=0 FDC=0
.ENDS
***************************************
.SUBCKT OR2T I2 I1 GND O VCC
** N=6 EP=5 IP=0 FDC=0
.ENDS
***************************************
.SUBCKT TIE0 O VCC GND
** N=4 EP=3 IP=0 FDC=0
.ENDS
***************************************
.SUBCKT ICV_14 1 2 3 4 5 6 7 8 9 10 11 12 13 14 15 16 17 18 19 20
+ 21 22 23 24 25 26 27 28 29 30 31 32 33 34 35 36 37 38 39 40
+ 41 42 43 44 45 46 47 48 49 50 51 52 53 54 55 56 57 58 59 60
+ 61 62 63 64 65 66 67 68 69 70 71 72 73 74 75 76 77 78 79 80
+ 81 82 83 84 85 86 87 88 89 90 91 92 93 94 95 96 97 98 99 100
+ 101 102 103 104 105 106 107 108 109 110 111 112 113 114 115 116 117 118 119 120
+ 121 122 123 124 125 126 127 128 129 130 131 132 133 134 135 136 137 138 139 140
+ 141 142 143 144 146 147 148 149 150 151 152 153 154 155 156 157 158 159 160 162
+ 163 164 165 166 167 168 169 170 171 172 173 174 175 176 177 178 180 181 182 183
+ 184 185 186 187 188 189 190 191 192 193 194 195 196 197 198 199 200 201 202 203
+ 204 205 206 207 208 209 210 211 212 213 214 215 216 218 219 220 221 222 223 224
+ 225 227 228 229 230 231 232 233 234 235 236 237 238 239 241 242 243 244 245 246
+ 247 248 249 250 251 252 253 254 255 256 257 258 259 260 261 262 263 264 265 266
+ 267 268 269 270 271 272 273 274 275 276 277 278 279 280 281 282 283 284 285 286
+ 287 288 289 290 291 292 293 294 295 296 297 298 299 300 301 302 303 304 305 306
+ 307 308 309 310 311 312 313 314 315 316 317 318 319 320 321 322 323 324 325 326
+ 327 328 329 330 331 332 333 334 335 336 337 338 339 340 341 342 343 344 345 346
+ 347 348 349 350 351 352 353 354 355 356 357 358 359 360 361 362 363 364 365 366
+ 367 368 369 370 371 372 373 374 375 376 377 378 379 380 381 382 383 384 385 386
+ 387 388 389 390 391 392 393 394 395 396 397 398 399 400 401 402 403 404 405 406
+ 407 408 409 410 411 412 413 414 415 416 417 418 419 420 421 422 423 424 425 426
+ 427 428 429 430 431 432 433 434 435 436 437 438 439 440 441 442 443 444 445 446
+ 447 448 449 450 451 452 453 454 455 456 457 458 459 460 461 462 463 464 465 466
+ 467 468 469 470 471 472 473 474 475 476 477 478 479 480 481 482 483 484 485 486
+ 487 488 489 490 491 492 493 494 495 496 497 498 499 500 501 502 503 504 505 506
+ 507 508 509 510 511 512 513 514 515 516 517 518 519 520 521 522 523 524 525 526
+ 527 528 529 530 531 532 533 534 535 536 537 538 539 540 541 542 543 544 545 546
+ 547 548 549 550 551 552 553 554 555 556 557 558 559 560 561 562 563 564 565 566
+ 567 568 569 570 571 572 573 574 575 576 577 578 579 580 581 582 583 584 585 586
+ 587 588 589 590 591 592 593 594 595 596 597 598 599 600 601 602 603 604 605 606
+ 607 608 609 610 611 612 613 614 615 616 617 618 619 620 621 622 623 624 625 626
+ 627 628 629 630 631 632 633 634 635 636 637 638 639 640 641 642 643 644 645 646
+ 647 648 649 650 651 652 653 654 655 656 657 658 659 660 661 662 663 664 665 666
+ 667 668 669 670 671 672 673 674 675 676 677 678 679 680 681 682 683 684 685 686
+ 687 688 689 690 691 692 693 694 695 696 697 698 699 700 701 702 718 735
** N=2872 EP=698 IP=16244 FDC=0
X0 702 284 284 284 718 284 701 YA2GSD $T=1315640 214400 0 90 $X=1176140 $Y=217250
X1 736 5 741 1 2 QDFFN $T=250480 306320 1 0 $X=250480 $Y=300900
X2 736 8 737 1 2 QDFFN $T=261640 296240 0 180 $X=251100 $Y=290820
X3 736 6 743 1 2 QDFFN $T=251100 306320 0 0 $X=251100 $Y=305940
X4 7 6 742 1 2 QDFFN $T=253580 316400 1 0 $X=253580 $Y=310980
X5 7 5 745 1 2 QDFFN $T=253580 326480 1 0 $X=253580 $Y=321060
X6 738 8 752 1 2 QDFFN $T=260400 266000 0 0 $X=260400 $Y=265620
X7 739 8 748 1 2 QDFFN $T=261020 266000 1 0 $X=261020 $Y=260580
X8 738 5 749 1 2 QDFFN $T=261640 235760 0 0 $X=261640 $Y=235380
X9 739 9 750 1 2 QDFFN $T=262260 255920 1 0 $X=262260 $Y=250500
X10 740 9 759 1 2 QDFFN $T=262260 276080 0 0 $X=262260 $Y=275700
X11 739 5 756 1 2 QDFFN $T=263500 245840 0 0 $X=263500 $Y=245460
X12 740 8 763 1 2 QDFFN $T=263500 286160 1 0 $X=263500 $Y=280740
X13 736 9 753 1 2 QDFFN $T=263500 286160 0 0 $X=263500 $Y=285780
X14 7 9 761 1 2 QDFFN $T=265980 306320 0 0 $X=265980 $Y=305940
X15 12 5 15 1 2 QDFFN $T=267220 326480 1 0 $X=267220 $Y=321060
X16 738 6 755 1 2 QDFFN $T=285200 235760 0 180 $X=274660 $Y=230340
X17 738 9 757 1 2 QDFFN $T=285200 276080 0 180 $X=274660 $Y=270660
X18 740 6 773 1 2 QDFFN $T=274660 296240 0 0 $X=274660 $Y=295860
X19 739 6 770 1 2 QDFFN $T=275280 235760 0 0 $X=275280 $Y=235380
X20 7 8 762 1 2 QDFFN $T=286440 306320 0 180 $X=275900 $Y=300900
X21 780 8 767 1 2 QDFFN $T=290780 266000 0 180 $X=280240 $Y=260580
X22 12 9 781 1 2 QDFFN $T=280860 306320 0 0 $X=280860 $Y=305940
X23 777 9 769 1 2 QDFFN $T=292020 276080 1 180 $X=281480 $Y=275700
X24 12 8 778 1 2 QDFFN $T=281480 326480 1 0 $X=281480 $Y=321060
X25 740 5 766 1 2 QDFFN $T=294500 296240 0 180 $X=283960 $Y=290820
X26 780 9 775 1 2 QDFFN $T=295740 255920 0 180 $X=285200 $Y=250500
X27 777 5 792 1 2 QDFFN $T=287680 286160 1 0 $X=287680 $Y=280740
X28 777 6 787 1 2 QDFFN $T=287680 296240 0 0 $X=287680 $Y=295860
X29 777 8 788 1 2 QDFFN $T=288300 276080 1 0 $X=288300 $Y=270660
X30 780 5 794 1 2 QDFFN $T=289540 235760 0 0 $X=289540 $Y=235380
X31 780 6 799 1 2 QDFFN $T=292640 225680 0 0 $X=292640 $Y=225300
X32 17 8 783 1 2 QDFFN $T=303180 316400 1 180 $X=292640 $Y=316020
X33 796 8 784 1 2 QDFFN $T=303800 266000 0 180 $X=293260 $Y=260580
X34 17 6 798 1 2 QDFFN $T=295120 306320 0 0 $X=295120 $Y=305940
X35 789 8 805 1 2 QDFFN $T=296360 255920 0 0 $X=296360 $Y=255540
X36 18 8 801 1 2 QDFFN $T=297600 306320 1 0 $X=297600 $Y=300900
X37 789 9 803 1 2 QDFFN $T=299460 245840 0 0 $X=299460 $Y=245460
X38 18 9 807 1 2 QDFFN $T=300700 296240 0 0 $X=300700 $Y=295860
X39 796 9 804 1 2 QDFFN $T=301940 266000 0 0 $X=301940 $Y=265620
X40 797 8 814 1 2 QDFFN $T=301940 276080 0 0 $X=301940 $Y=275700
X41 789 5 817 1 2 QDFFN $T=303180 235760 0 0 $X=303180 $Y=235380
X42 18 5 809 1 2 QDFFN $T=303800 286160 0 0 $X=303800 $Y=285780
X43 797 9 812 1 2 QDFFN $T=305660 286160 1 0 $X=305660 $Y=280740
X44 22 8 819 1 2 QDFFN $T=305660 316400 1 0 $X=305660 $Y=310980
X45 789 6 813 1 2 QDFFN $T=306900 225680 0 0 $X=306900 $Y=225300
X46 22 9 818 1 2 QDFFN $T=308140 306320 1 0 $X=308140 $Y=300900
X47 22 6 820 1 2 QDFFN $T=309380 326480 1 0 $X=309380 $Y=321060
X48 796 6 823 1 2 QDFFN $T=310620 266000 1 0 $X=310620 $Y=260580
X49 808 9 835 1 2 QDFFN $T=312480 245840 0 0 $X=312480 $Y=245460
X50 808 8 832 1 2 QDFFN $T=313720 255920 0 0 $X=313720 $Y=255540
X51 18 6 833 1 2 QDFFN $T=314340 286160 0 0 $X=314340 $Y=285780
X52 797 6 831 1 2 QDFFN $T=315580 266000 0 0 $X=315580 $Y=265620
X53 808 5 837 1 2 QDFFN $T=316820 235760 1 0 $X=316820 $Y=230340
X54 797 5 829 1 2 QDFFN $T=319300 286160 1 0 $X=319300 $Y=280740
X55 808 6 842 1 2 QDFFN $T=321780 225680 0 0 $X=321780 $Y=225300
X56 796 5 828 1 2 QDFFN $T=338520 266000 0 180 $X=327980 $Y=260580
X57 777 25 852 1 2 QDFFN $T=328600 276080 1 0 $X=328600 $Y=270660
X58 7 26 850 1 2 QDFFN $T=329220 326480 1 0 $X=329220 $Y=321060
X59 7 27 871 1 2 QDFFN $T=329840 316400 1 0 $X=329840 $Y=310980
X60 738 26 873 1 2 QDFFN $T=331080 235760 0 0 $X=331080 $Y=235380
X61 738 27 861 1 2 QDFFN $T=331080 245840 1 0 $X=331080 $Y=240420
X62 808 28 853 1 2 QDFFN $T=332320 255920 1 0 $X=332320 $Y=250500
X63 738 28 857 1 2 QDFFN $T=332320 255920 0 0 $X=332320 $Y=255540
X64 740 25 862 1 2 QDFFN $T=332940 286160 1 0 $X=332940 $Y=280740
X65 738 25 874 1 2 QDFFN $T=337280 225680 0 0 $X=337280 $Y=225300
X66 740 26 867 1 2 QDFFN $T=337280 276080 0 0 $X=337280 $Y=275700
X67 7 28 870 1 2 QDFFN $T=337280 306320 0 0 $X=337280 $Y=305940
X68 736 25 876 1 2 QDFFN $T=339140 306320 1 0 $X=339140 $Y=300900
X69 796 28 887 1 2 QDFFN $T=341000 266000 1 0 $X=341000 $Y=260580
X70 736 26 882 1 2 QDFFN $T=341000 286160 0 0 $X=341000 $Y=285780
X71 777 26 884 1 2 QDFFN $T=342240 276080 1 0 $X=342240 $Y=270660
X72 808 27 878 1 2 QDFFN $T=343480 245840 0 0 $X=343480 $Y=245460
X73 736 27 885 1 2 QDFFN $T=347820 306320 0 0 $X=347820 $Y=305940
X74 808 26 879 1 2 QDFFN $T=359600 225680 0 180 $X=349060 $Y=220260
X75 796 27 877 1 2 QDFFN $T=359600 255920 1 180 $X=349060 $Y=255540
X76 808 25 890 1 2 QDFFN $T=361460 235760 0 180 $X=350920 $Y=230340
X77 740 28 894 1 2 QDFFN $T=362080 286160 1 180 $X=351540 $Y=285780
X78 22 27 914 1 2 QDFFN $T=351540 316400 1 0 $X=351540 $Y=310980
X79 736 28 881 1 2 QDFFN $T=363940 296240 1 180 $X=353400 $Y=295860
X80 789 27 918 1 2 QDFFN $T=356500 245840 0 0 $X=356500 $Y=245460
X81 789 28 917 1 2 QDFFN $T=357740 255920 1 0 $X=357740 $Y=250500
X82 22 28 921 1 2 QDFFN $T=358360 306320 0 0 $X=358360 $Y=305940
X83 797 27 924 1 2 QDFFN $T=360220 266000 0 0 $X=360220 $Y=265620
X84 777 27 912 1 2 QDFFN $T=372000 276080 0 180 $X=361460 $Y=270660
X85 739 27 935 1 2 QDFFN $T=362080 255920 0 0 $X=362080 $Y=255540
X86 18 28 925 1 2 QDFFN $T=362080 286160 0 0 $X=362080 $Y=285780
X87 796 26 929 1 2 QDFFN $T=363320 225680 1 0 $X=363320 $Y=220260
X88 780 27 927 1 2 QDFFN $T=363320 235760 0 0 $X=363320 $Y=235380
X89 18 27 930 1 2 QDFFN $T=363940 296240 0 0 $X=363940 $Y=295860
X90 796 25 934 1 2 QDFFN $T=365180 235760 1 0 $X=365180 $Y=230340
X91 777 28 916 1 2 QDFFN $T=376960 276080 1 180 $X=366420 $Y=275700
X92 780 28 937 1 2 QDFFN $T=370760 255920 1 0 $X=370760 $Y=250500
X93 740 27 902 1 2 QDFFN $T=383160 286160 1 180 $X=372620 $Y=285780
X94 797 28 928 1 2 QDFFN $T=385020 266000 1 180 $X=374480 $Y=265620
X95 18 26 936 1 2 QDFFN $T=387500 296240 1 180 $X=376960 $Y=295860
X96 789 25 941 1 2 QDFFN $T=388120 225680 0 180 $X=377580 $Y=220260
X97 22 26 958 1 2 QDFFN $T=378820 306320 0 0 $X=378820 $Y=305940
X98 739 28 942 1 2 QDFFN $T=380060 276080 0 0 $X=380060 $Y=275700
X99 739 26 956 1 2 QDFFN $T=394320 255920 0 180 $X=383780 $Y=250500
X100 17 25 43 1 2 QDFFN $T=395560 326480 0 180 $X=385020 $Y=321060
X101 780 26 959 1 2 QDFFN $T=396180 235760 1 180 $X=385640 $Y=235380
X102 22 25 954 1 2 QDFFN $T=396180 316400 0 180 $X=385640 $Y=310980
X103 789 26 952 1 2 QDFFN $T=396800 235760 0 180 $X=386260 $Y=230340
X104 780 25 953 1 2 QDFFN $T=398040 245840 1 180 $X=387500 $Y=245460
X105 18 25 945 1 2 QDFFN $T=398040 296240 1 180 $X=387500 $Y=295860
X106 797 26 962 1 2 QDFFN $T=399280 276080 0 180 $X=388740 $Y=270660
X107 739 25 957 1 2 QDFFN $T=399900 255920 1 180 $X=389360 $Y=255540
X108 797 25 961 1 2 QDFFN $T=401760 266000 1 180 $X=391220 $Y=265620
X109 739 45 978 1 2 QDFFN $T=396180 255920 1 0 $X=396180 $Y=250500
X110 740 45 979 1 2 QDFFN $T=396800 286160 1 0 $X=396800 $Y=280740
X111 736 45 986 1 2 QDFFN $T=397420 286160 0 0 $X=397420 $Y=285780
X112 22 45 981 1 2 QDFFN $T=397420 326480 1 0 $X=397420 $Y=321060
X113 808 45 992 1 2 QDFFN $T=398040 235760 0 0 $X=398040 $Y=235380
X114 777 45 983 1 2 QDFFN $T=398040 276080 0 0 $X=398040 $Y=275700
X115 789 45 993 1 2 QDFFN $T=399280 225680 0 0 $X=399280 $Y=225300
X116 18 45 988 1 2 QDFFN $T=399280 296240 0 0 $X=399280 $Y=295860
X117 780 45 990 1 2 QDFFN $T=400520 245840 1 0 $X=400520 $Y=240420
X118 796 45 995 1 2 QDFFN $T=402380 255920 0 0 $X=402380 $Y=255540
X119 797 45 991 1 2 QDFFN $T=402380 276080 1 0 $X=402380 $Y=270660
X120 7 45 974 1 2 QDFFN $T=413540 306320 1 180 $X=403000 $Y=305940
X121 50 51 1005 1 2 QDFFN $T=411060 286160 1 0 $X=411060 $Y=280740
X122 738 45 1006 1 2 QDFFN $T=412300 235760 1 0 $X=412300 $Y=230340
X123 17 51 1012 1 2 QDFFN $T=412300 326480 1 0 $X=412300 $Y=321060
X124 52 54 1009 1 2 QDFFN $T=412920 306320 1 0 $X=412920 $Y=300900
X125 17 54 1014 1 2 QDFFN $T=413540 316400 1 0 $X=413540 $Y=310980
X126 780 54 1020 1 2 QDFFN $T=414780 245840 0 0 $X=414780 $Y=245460
X127 780 55 1017 1 2 QDFFN $T=415400 255920 0 0 $X=415400 $Y=255540
X128 739 51 1028 1 2 QDFFN $T=415400 266000 0 0 $X=415400 $Y=265620
X129 739 54 1027 1 2 QDFFN $T=416020 266000 1 0 $X=416020 $Y=260580
X130 52 51 1029 1 2 QDFFN $T=417880 296240 1 0 $X=417880 $Y=290820
X131 50 54 1013 1 2 QDFFN $T=418500 276080 1 0 $X=418500 $Y=270660
X132 789 51 1025 1 2 QDFFN $T=419740 225680 1 0 $X=419740 $Y=220260
X133 780 51 1026 1 2 QDFFN $T=420980 245840 1 0 $X=420980 $Y=240420
X134 22 55 1035 1 2 QDFFN $T=423460 306320 1 0 $X=423460 $Y=300900
X135 789 54 1019 1 2 QDFFN $T=435860 225680 1 180 $X=425320 $Y=225300
X136 739 65 1022 1 2 QDFFN $T=437100 286160 0 180 $X=426560 $Y=280740
X137 780 65 1032 1 2 QDFFN $T=439580 266000 0 180 $X=429040 $Y=260580
X138 738 51 1063 1 2 QDFFN $T=434620 225680 1 0 $X=434620 $Y=220260
X139 789 55 1047 1 2 QDFFN $T=445160 245840 0 180 $X=434620 $Y=240420
X140 789 65 1053 1 2 QDFFN $T=447020 255920 1 180 $X=436480 $Y=255540
X141 739 55 1043 1 2 QDFFN $T=447020 266000 1 180 $X=436480 $Y=265620
X142 17 65 67 1 2 QDFFN $T=447020 326480 0 180 $X=436480 $Y=321060
X143 22 65 1038 1 2 QDFFN $T=448260 316400 0 180 $X=437720 $Y=310980
X144 738 54 1061 1 2 QDFFN $T=452600 225680 1 180 $X=442060 $Y=225300
X145 738 65 1071 1 2 QDFFN $T=442060 266000 1 0 $X=442060 $Y=260580
X146 50 71 1078 1 2 QDFFN $T=442680 276080 0 0 $X=442680 $Y=275700
X147 738 55 1065 1 2 QDFFN $T=455080 245840 1 180 $X=444540 $Y=245460
X148 739 71 1080 1 2 QDFFN $T=446400 276080 1 0 $X=446400 $Y=270660
X149 738 71 1081 1 2 QDFFN $T=448880 225680 1 0 $X=448880 $Y=220260
X150 739 80 1085 1 2 QDFFN $T=450120 266000 0 0 $X=450120 $Y=265620
X151 52 71 1089 1 2 QDFFN $T=452600 296240 1 0 $X=452600 $Y=290820
X152 780 71 1084 1 2 QDFFN $T=454460 255920 1 0 $X=454460 $Y=250500
X153 738 91 1077 1 2 QDFFN $T=465620 225680 1 180 $X=455080 $Y=225300
X154 738 80 1091 1 2 QDFFN $T=455080 245840 1 0 $X=455080 $Y=240420
X155 780 80 1092 1 2 QDFFN $T=455080 266000 1 0 $X=455080 $Y=260580
X156 50 80 1079 1 2 QDFFN $T=466240 276080 1 180 $X=455700 $Y=275700
X157 12 80 88 1 2 QDFFN $T=466860 326480 0 180 $X=456320 $Y=321060
X158 17 71 1101 1 2 QDFFN $T=462520 316400 1 0 $X=462520 $Y=310980
X159 52 91 1090 1 2 QDFFN $T=473680 296240 0 180 $X=463140 $Y=290820
X160 789 71 1099 1 2 QDFFN $T=463760 225680 1 0 $X=463760 $Y=220260
X161 739 91 1093 1 2 QDFFN $T=474300 266000 1 180 $X=463760 $Y=265620
X162 52 80 1094 1 2 QDFFN $T=475540 296240 1 180 $X=465000 $Y=295860
X163 780 91 1083 1 2 QDFFN $T=476780 255920 0 180 $X=466240 $Y=250500
X164 789 80 1098 1 2 QDFFN $T=478020 245840 0 180 $X=467480 $Y=240420
X165 789 91 1097 1 2 QDFFN $T=478640 235760 0 180 $X=468100 $Y=230340
X166 797 55 1104 1 2 QDFFN $T=468100 255920 0 0 $X=468100 $Y=255540
X167 50 91 1096 1 2 QDFFN $T=479260 286160 1 180 $X=468720 $Y=285780
X168 17 80 1108 1 2 QDFFN $T=468720 306320 1 0 $X=468720 $Y=300900
X169 797 65 1109 1 2 QDFFN $T=469340 276080 1 0 $X=469340 $Y=270660
X170 777 55 1106 1 2 QDFFN $T=469340 276080 0 0 $X=469340 $Y=275700
X171 777 65 1114 1 2 QDFFN $T=469340 286160 1 0 $X=469340 $Y=280740
X172 17 91 1115 1 2 QDFFN $T=473060 316400 1 0 $X=473060 $Y=310980
X173 22 71 1100 1 2 QDFFN $T=483600 326480 0 180 $X=473060 $Y=321060
X174 736 55 1119 1 2 QDFFN $T=475540 296240 0 0 $X=475540 $Y=295860
X175 797 71 1103 1 2 QDFFN $T=487940 225680 0 180 $X=477400 $Y=220260
X176 808 65 1121 1 2 QDFFN $T=477400 255920 1 0 $X=477400 $Y=250500
X177 736 65 1122 1 2 QDFFN $T=477400 296240 1 0 $X=477400 $Y=290820
X178 7 65 1125 1 2 QDFFN $T=479880 306320 1 0 $X=479880 $Y=300900
X179 797 80 1102 1 2 QDFFN $T=491040 245840 1 180 $X=480500 $Y=245460
X180 7 55 1123 1 2 QDFFN $T=480500 306320 0 0 $X=480500 $Y=305940
X181 797 91 1105 1 2 QDFFN $T=491660 235760 0 180 $X=481120 $Y=230340
X182 796 65 1126 1 2 QDFFN $T=483600 276080 1 0 $X=483600 $Y=270660
X183 18 55 104 1 2 QDFFN $T=483600 326480 1 0 $X=483600 $Y=321060
X184 796 55 1132 1 2 QDFFN $T=484840 255920 0 0 $X=484840 $Y=255540
X185 740 55 1134 1 2 QDFFN $T=489180 286160 1 0 $X=489180 $Y=280740
X186 740 65 1130 1 2 QDFFN $T=491040 296240 1 0 $X=491040 $Y=290820
X187 797 51 1127 1 2 QDFFN $T=502200 225680 0 180 $X=491660 $Y=220260
X188 736 54 1150 1 2 QDFFN $T=492280 306320 0 0 $X=492280 $Y=305940
X189 796 51 1155 1 2 QDFFN $T=494140 235760 1 0 $X=494140 $Y=230340
X190 808 55 1131 1 2 QDFFN $T=494140 245840 1 0 $X=494140 $Y=240420
X191 7 54 1151 1 2 QDFFN $T=494140 316400 1 0 $X=494140 $Y=310980
X192 18 51 1153 1 2 QDFFN $T=494140 326480 1 0 $X=494140 $Y=321060
X193 7 51 1157 1 2 QDFFN $T=494760 316400 0 0 $X=494760 $Y=316020
X194 736 51 1152 1 2 QDFFN $T=496000 296240 0 0 $X=496000 $Y=295860
X195 740 51 1148 1 2 QDFFN $T=497240 276080 1 0 $X=497240 $Y=270660
X196 777 54 1161 1 2 QDFFN $T=497860 266000 1 0 $X=497860 $Y=260580
X197 808 51 1162 1 2 QDFFN $T=499720 255920 0 0 $X=499720 $Y=255540
X198 777 51 1163 1 2 QDFFN $T=499720 266000 0 0 $X=499720 $Y=265620
X199 7 80 1175 1 2 QDFFN $T=505300 306320 0 0 $X=505300 $Y=305940
X200 796 54 1154 1 2 QDFFN $T=517080 225680 0 180 $X=506540 $Y=220260
X201 797 54 1128 1 2 QDFFN $T=507160 235760 1 0 $X=507160 $Y=230340
X202 808 54 1158 1 2 QDFFN $T=517700 245840 0 180 $X=507160 $Y=240420
X203 740 54 1147 1 2 QDFFN $T=518320 286160 1 180 $X=507780 $Y=285780
X204 736 80 1183 1 2 QDFFN $T=509020 296240 0 0 $X=509020 $Y=295860
X205 18 91 112 1 2 QDFFN $T=521420 326480 0 180 $X=510880 $Y=321060
X206 808 80 1184 1 2 QDFFN $T=513360 255920 0 0 $X=513360 $Y=255540
X207 740 80 1169 1 2 QDFFN $T=523900 276080 0 180 $X=513360 $Y=270660
X208 7 71 1167 1 2 QDFFN $T=523900 316400 1 180 $X=513360 $Y=316020
X209 777 80 1181 1 2 QDFFN $T=529480 266000 0 180 $X=518940 $Y=260580
X210 740 71 1171 1 2 QDFFN $T=530720 286160 0 180 $X=520180 $Y=280740
X211 7 91 1164 1 2 QDFFN $T=520180 316400 1 0 $X=520180 $Y=310980
X212 796 71 1177 1 2 QDFFN $T=531340 225680 0 180 $X=520800 $Y=220260
X213 796 80 1182 1 2 QDFFN $T=531340 245840 0 180 $X=520800 $Y=240420
X214 740 91 1168 1 2 QDFFN $T=531340 286160 1 180 $X=520800 $Y=285780
X215 736 91 1174 1 2 QDFFN $T=531340 296240 1 180 $X=520800 $Y=295860
X216 736 71 1178 1 2 QDFFN $T=531340 306320 0 180 $X=520800 $Y=300900
X217 796 91 1172 1 2 QDFFN $T=531960 235760 0 180 $X=521420 $Y=230340
X218 808 91 1173 1 2 QDFFN $T=533820 235760 1 180 $X=523280 $Y=235380
X219 808 71 1176 1 2 QDFFN $T=533820 255920 0 180 $X=523280 $Y=250500
X220 777 91 1179 1 2 QDFFN $T=533820 266000 1 180 $X=523280 $Y=265620
X221 777 71 1180 1 2 QDFFN $T=534440 276080 1 180 $X=523900 $Y=275700
X222 743 741 744 10 1 11 2 AOI22S $T=264120 306320 1 0 $X=264120 $Y=300900
X223 753 737 746 14 1 13 2 AOI22S $T=272800 296240 0 180 $X=269080 $Y=290820
X224 742 745 747 10 1 11 2 AOI22S $T=269080 316400 1 0 $X=269080 $Y=310980
X225 757 752 758 14 1 13 2 AOI22S $T=277760 266000 0 180 $X=274040 $Y=260580
X226 750 748 760 14 1 13 2 AOI22S $T=275900 255920 0 0 $X=275900 $Y=255540
X227 755 749 764 10 1 11 2 AOI22S $T=277760 245840 1 0 $X=277760 $Y=240420
X228 759 763 765 14 1 13 2 AOI22S $T=277760 286160 1 0 $X=277760 $Y=280740
X229 773 766 771 10 1 11 2 AOI22S $T=281480 286160 1 180 $X=277760 $Y=285780
X230 761 762 754 14 1 13 2 AOI22S $T=277760 316400 1 0 $X=277760 $Y=310980
X231 770 756 768 10 1 11 2 AOI22S $T=282720 245840 1 0 $X=282720 $Y=240420
X232 781 778 16 14 1 13 2 AOI22S $T=290160 316400 1 180 $X=286440 $Y=316020
X233 775 767 782 14 1 13 2 AOI22S $T=290780 255920 0 0 $X=290780 $Y=255540
X234 769 788 786 14 1 13 2 AOI22S $T=295120 276080 0 0 $X=295120 $Y=275700
X235 19 783 793 14 1 13 2 AOI22S $T=298840 326480 0 180 $X=295120 $Y=321060
X236 787 792 790 10 1 11 2 AOI22S $T=296360 296240 1 0 $X=296360 $Y=290820
X237 799 794 785 10 1 11 2 AOI22S $T=301940 245840 0 180 $X=298220 $Y=240420
X238 798 21 795 10 1 11 2 AOI22S $T=303180 326480 1 0 $X=303180 $Y=321060
X239 804 784 806 14 1 13 2 AOI22S $T=310000 266000 0 180 $X=306280 $Y=260580
X240 803 805 802 14 1 13 2 AOI22S $T=308760 255920 1 0 $X=308760 $Y=250500
X241 807 801 810 14 1 13 2 AOI22S $T=312480 296240 0 0 $X=312480 $Y=295860
X242 813 817 811 10 1 11 2 AOI22S $T=315580 245840 1 0 $X=315580 $Y=240420
X243 812 814 815 14 1 13 2 AOI22S $T=315580 276080 0 0 $X=315580 $Y=275700
X244 818 819 821 14 1 13 2 AOI22S $T=318680 316400 0 0 $X=318680 $Y=316020
X245 833 809 822 10 1 11 2 AOI22S $T=324880 306320 0 180 $X=321160 $Y=300900
X246 823 828 826 10 1 11 2 AOI22S $T=322400 266000 1 0 $X=322400 $Y=260580
X247 831 829 836 10 1 11 2 AOI22S $T=326120 276080 1 180 $X=322400 $Y=275700
X248 820 24 827 10 1 11 2 AOI22S $T=322400 326480 1 0 $X=322400 $Y=321060
X249 842 837 839 10 1 11 2 AOI22S $T=329220 245840 0 180 $X=325500 $Y=240420
X250 835 832 838 14 1 13 2 AOI22S $T=329220 255920 0 180 $X=325500 $Y=250500
X251 850 30 856 31 1 32 2 AOI22S $T=341620 326480 1 0 $X=341620 $Y=321060
X252 857 861 860 866 1 33 2 AOI22S $T=344100 255920 1 0 $X=344100 $Y=250500
X253 867 862 868 31 1 872 2 AOI22S $T=345960 286160 1 0 $X=345960 $Y=280740
X254 870 871 865 34 1 33 2 AOI22S $T=346580 316400 0 0 $X=346580 $Y=316020
X255 882 876 891 31 1 872 2 AOI22S $T=350920 296240 1 180 $X=347200 $Y=295860
X256 873 874 863 880 1 32 2 AOI22S $T=347820 235760 0 0 $X=347820 $Y=235380
X257 853 878 875 866 1 33 2 AOI22S $T=348440 255920 1 0 $X=348440 $Y=250500
X258 881 885 883 34 1 895 2 AOI22S $T=349680 296240 1 0 $X=349680 $Y=290820
X259 884 852 888 31 1 872 2 AOI22S $T=350920 276080 0 0 $X=350920 $Y=275700
X260 879 890 898 880 1 32 2 AOI22S $T=352780 235760 0 0 $X=352780 $Y=235380
X261 887 877 897 866 1 33 2 AOI22S $T=352780 266000 0 0 $X=352780 $Y=265620
X262 894 902 899 34 1 895 2 AOI22S $T=354640 276080 0 0 $X=354640 $Y=275700
X263 916 912 913 34 1 895 2 AOI22S $T=363320 276080 1 180 $X=359600 $Y=275700
X264 917 918 920 866 1 895 2 AOI22S $T=368280 245840 0 0 $X=368280 $Y=245460
X265 921 914 939 38 1 895 2 AOI22S $T=373860 316400 0 180 $X=370140 $Y=310980
X266 928 924 926 866 1 33 2 AOI22S $T=374480 266000 1 180 $X=370760 $Y=265620
X267 39 41 40 38 1 33 2 AOI22S $T=371380 326480 1 0 $X=371380 $Y=321060
X268 925 930 931 38 1 895 2 AOI22S $T=376340 306320 0 180 $X=372620 $Y=300900
X269 937 927 947 866 1 895 2 AOI22S $T=376960 245840 1 180 $X=373240 $Y=245460
X270 929 934 906 880 1 32 2 AOI22S $T=375100 235760 0 0 $X=375100 $Y=235380
X271 942 935 951 866 1 895 2 AOI22S $T=378820 255920 1 180 $X=375100 $Y=255540
X272 936 945 938 42 1 872 2 AOI22S $T=378820 306320 1 0 $X=378820 $Y=300900
X273 952 941 950 880 1 872 2 AOI22S $T=383780 235760 0 180 $X=380060 $Y=230340
X274 959 953 943 880 1 872 2 AOI22S $T=385640 245840 1 180 $X=381920 $Y=245460
X275 958 954 933 42 1 872 2 AOI22S $T=385640 316400 0 180 $X=381920 $Y=310980
X276 956 957 948 880 1 872 2 AOI22S $T=386880 255920 1 180 $X=383160 $Y=255540
X277 962 961 964 880 1 32 2 AOI22S $T=388740 266000 1 180 $X=385020 $Y=265620
X278 978 949 976 47 1 46 2 AOI22S $T=404860 266000 0 180 $X=401140 $Y=260580
X279 986 900 982 47 1 46 2 AOI22S $T=408580 296240 0 180 $X=404860 $Y=290820
X280 991 965 984 47 1 46 2 AOI22S $T=409200 266000 0 180 $X=405480 $Y=260580
X281 974 47 980 859 1 46 2 AOI22S $T=406100 316400 1 0 $X=406100 $Y=310980
X282 979 893 985 47 1 46 2 AOI22S $T=407340 286160 1 0 $X=407340 $Y=280740
X283 983 907 989 47 1 46 2 AOI22S $T=408580 276080 0 0 $X=408580 $Y=275700
X284 981 946 48 47 1 46 2 AOI22S $T=408580 326480 1 0 $X=408580 $Y=321060
X285 990 944 987 47 1 46 2 AOI22S $T=409200 255920 1 0 $X=409200 $Y=250500
X286 988 940 49 47 1 46 2 AOI22S $T=409200 306320 1 0 $X=409200 $Y=300900
X287 995 911 999 47 1 46 2 AOI22S $T=413540 266000 0 180 $X=409820 $Y=260580
X288 993 955 994 47 1 46 2 AOI22S $T=411060 235760 0 0 $X=411060 $Y=235380
X289 996 904 998 47 1 46 2 AOI22S $T=414160 245840 1 0 $X=414160 $Y=240420
X290 1006 864 1015 47 1 46 2 AOI22S $T=419740 235760 1 180 $X=416020 $Y=235380
X291 1017 1032 1031 58 1 59 2 AOI22S $T=428420 255920 0 0 $X=428420 $Y=255540
X292 1043 1022 1037 58 1 59 2 AOI22S $T=432760 276080 0 180 $X=429040 $Y=270660
X293 1035 1038 62 58 1 59 2 AOI22S $T=431520 326480 1 0 $X=431520 $Y=321060
X294 1047 1053 1057 58 1 59 2 AOI22S $T=438340 245840 0 0 $X=438340 $Y=245460
X295 1065 1071 1069 58 1 59 2 AOI22S $T=448880 255920 1 0 $X=448880 $Y=250500
X296 1104 1109 1107 58 1 59 2 AOI22S $T=479260 266000 0 0 $X=479260 $Y=265620
X297 1106 1114 1112 58 1 59 2 AOI22S $T=481120 276080 0 0 $X=481120 $Y=275700
X298 1131 1121 1129 58 1 59 2 AOI22S $T=493520 255920 0 180 $X=489800 $Y=250500
X299 1132 1126 1133 58 1 59 2 AOI22S $T=493520 266000 1 180 $X=489800 $Y=265620
X300 1119 1122 1117 58 1 59 2 AOI22S $T=489800 296240 0 0 $X=489800 $Y=295860
X301 1134 1130 1137 58 1 59 2 AOI22S $T=494760 286160 1 180 $X=491040 $Y=285780
X302 1123 1125 1120 58 1 59 2 AOI22S $T=491040 316400 0 0 $X=491040 $Y=316020
X303 1877 1880 1878 1833 1 1836 2 AOI22S $T=781200 235760 0 0 $X=781200 $Y=235380
X304 2095 2089 2063 2084 1 2078 2 AOI22S $T=848160 245840 0 180 $X=844440 $Y=240420
X305 330 2090 2069 2085 1 314 2 AOI22S $T=848160 276080 0 180 $X=844440 $Y=270660
X306 322 2085 2072 2107 1 2095 2 AOI22S $T=848780 276080 1 0 $X=848780 $Y=270660
X307 322 331 2053 344 1 2100 2 AOI22S $T=849400 316400 1 0 $X=849400 $Y=310980
X308 352 348 316 346 1 338 2 AOI22S $T=853740 326480 0 180 $X=850020 $Y=321060
X309 2125 2119 2137 2114 1 2111 2 AOI22S $T=854360 255920 0 180 $X=850640 $Y=250500
X310 348 352 2066 331 1 347 2 AOI22S $T=854980 316400 1 180 $X=851260 $Y=316020
X311 342 2100 2110 314 1 354 2 AOI22S $T=852500 306320 0 0 $X=852500 $Y=305940
X312 2145 2129 2132 339 1 2127 2 AOI22S $T=857460 276080 1 180 $X=853740 $Y=275700
X313 331 355 2071 356 1 342 2 AOI22S $T=853740 316400 1 0 $X=853740 $Y=310980
X314 369 346 2143 362 1 331 2 AOI22S $T=858700 326480 0 180 $X=854980 $Y=321060
X315 2155 351 2141 2151 1 314 2 AOI22S $T=861800 276080 1 180 $X=858080 $Y=275700
X316 367 331 2025 373 1 375 2 AOI22S $T=858080 316400 1 0 $X=858080 $Y=310980
X317 2145 2090 2170 2089 1 2125 2 AOI22S $T=863660 235760 0 180 $X=859940 $Y=230340
X318 2167 2155 2162 2154 1 2150 2 AOI22S $T=863660 255920 0 180 $X=859940 $Y=250500
X319 375 362 2135 354 1 347 2 AOI22S $T=860560 326480 1 0 $X=860560 $Y=321060
X320 386 2164 2134 378 1 2080 2 AOI22S $T=864900 225680 1 180 $X=861180 $Y=225300
X321 367 2168 2176 314 1 372 2 AOI22S $T=865520 276080 1 180 $X=861800 $Y=275700
X322 2125 2177 2172 2079 1 2181 2 AOI22S $T=864900 255920 1 0 $X=864900 $Y=250500
X323 2151 2138 2020 2178 1 2184 2 AOI22S $T=864900 266000 0 0 $X=864900 $Y=265620
X324 2085 2145 2159 397 1 2190 2 AOI22S $T=866760 276080 0 0 $X=866760 $Y=275700
X325 2196 2164 2198 378 1 2186 2 AOI22S $T=871100 225680 1 180 $X=867380 $Y=225300
X326 2119 2189 2187 2125 1 2196 2 AOI22S $T=868000 235760 0 0 $X=868000 $Y=235380
X327 330 2080 2171 2201 1 2193 2 AOI22S $T=868620 245840 0 0 $X=868620 $Y=245460
X328 2199 356 2117 401 1 354 2 AOI22S $T=872340 306320 1 180 $X=868620 $Y=305940
X329 2188 2129 2200 2177 1 2164 2 AOI22S $T=873580 266000 1 180 $X=869860 $Y=265620
X330 356 369 2185 354 1 2197 2 AOI22S $T=870480 316400 0 0 $X=870480 $Y=316020
X331 409 401 2209 375 1 406 2 AOI22S $T=876060 326480 0 180 $X=872340 $Y=321060
X332 2218 2212 2140 2196 1 2188 2 AOI22S $T=876680 276080 0 180 $X=872960 $Y=270660
X333 347 2196 2093 397 1 2234 2 AOI22S $T=876060 316400 0 0 $X=876060 $Y=316020
X334 2080 2186 2202 2230 1 2231 2 AOI22S $T=877300 245840 1 0 $X=877300 $Y=240420
X335 2218 415 2237 414 1 397 2 AOI22S $T=881640 326480 0 180 $X=877920 $Y=321060
X336 2107 2189 2228 2226 1 2240 2 AOI22S $T=878540 276080 1 0 $X=878540 $Y=270660
X337 2196 2168 2247 2090 1 2186 2 AOI22S $T=884120 235760 1 180 $X=880400 $Y=235380
X338 2226 2196 2216 2240 1 2145 2 AOI22S $T=880400 276080 0 0 $X=880400 $Y=275700
X339 2240 339 2246 2264 1 2230 2 AOI22S $T=884120 286160 0 0 $X=884120 $Y=285780
X340 372 331 2266 356 1 401 2 AOI22S $T=889700 316400 0 180 $X=885980 $Y=310980
X341 348 2189 2283 430 1 2272 2 AOI22S $T=894040 286160 1 180 $X=890320 $Y=285780
X342 2226 329 2241 2272 1 2286 2 AOI22S $T=890940 296240 1 0 $X=890940 $Y=290820
X343 433 355 432 373 1 2264 2 AOI22S $T=895900 316400 1 180 $X=892180 $Y=316020
X344 2090 2168 2279 2292 1 2095 2 AOI22S $T=895280 266000 0 0 $X=895280 $Y=265620
X345 2119 2095 2290 2306 1 2303 2 AOI22S $T=896520 266000 1 0 $X=896520 $Y=260580
X346 433 447 2326 2197 1 2264 2 AOI22S $T=904580 316400 1 180 $X=900860 $Y=316020
X347 450 2264 2300 2340 1 2226 2 AOI22S $T=906440 296240 1 0 $X=906440 $Y=290820
X348 2127 2138 2359 2292 1 2319 2 AOI22S $T=913260 266000 1 180 $X=909540 $Y=265620
X349 2129 2138 2361 2196 1 2340 2 AOI22S $T=916980 296240 0 180 $X=913260 $Y=290820
X350 2264 352 458 460 1 2345 2 AOI22S $T=913880 326480 1 0 $X=913880 $Y=321060
X351 2351 455 2291 2127 1 2212 2 AOI22S $T=914500 276080 1 0 $X=914500 $Y=270660
X352 2212 2151 2334 2388 1 2394 2 AOI22S $T=921320 266000 1 0 $X=921320 $Y=260580
X353 2240 2212 2370 2403 1 2406 2 AOI22S $T=923800 266000 0 0 $X=923800 $Y=265620
X354 2226 2151 2411 2090 1 2418 2 AOI22S $T=927520 266000 0 0 $X=927520 $Y=265620
X355 375 409 2399 367 1 355 2 AOI22S $T=927520 326480 1 0 $X=927520 $Y=321060
X356 2167 442 2413 2226 1 2240 2 AOI22S $T=928140 276080 1 0 $X=928140 $Y=270660
X357 355 375 2425 2392 1 2441 2 AOI22S $T=933100 306320 0 0 $X=933100 $Y=305940
X358 2129 397 2457 2452 1 2450 2 AOI22S $T=944260 276080 0 180 $X=940540 $Y=270660
X359 2240 2127 490 2491 1 2498 2 AOI22S $T=954180 286160 1 0 $X=954180 $Y=280740
X360 540 2577 2583 2576 1 2572 2 AOI22S $T=988280 255920 1 180 $X=984560 $Y=255540
X361 2581 2582 2585 2588 1 2573 2 AOI22S $T=987660 286160 0 0 $X=987660 $Y=285780
X362 556 2561 2590 2579 1 2594 2 AOI22S $T=993860 266000 1 180 $X=990140 $Y=265620
X363 2600 2618 2563 2623 1 2625 2 AOI22S $T=995100 276080 1 0 $X=995100 $Y=270660
X364 2607 570 2632 2612 1 2630 2 AOI22S $T=1001920 316400 0 180 $X=998200 $Y=310980
X365 556 2633 2629 2609 1 2676 2 AOI22S $T=999440 286160 1 0 $X=999440 $Y=280740
X366 578 2657 2639 536 1 2577 2 AOI22S $T=1005020 255920 1 0 $X=1005020 $Y=250500
X367 594 2657 2683 536 1 2667 2 AOI22S $T=1013700 255920 0 180 $X=1009980 $Y=250500
X368 2577 2667 2649 2685 1 2688 2 AOI22S $T=1009980 276080 1 0 $X=1009980 $Y=270660
X369 2633 592 2678 556 1 594 2 AOI22S $T=1011220 276080 0 0 $X=1011220 $Y=275700
X370 2693 553 2687 2642 1 2700 2 AOI22S $T=1014320 316400 1 0 $X=1014320 $Y=310980
X371 540 2587 607 2624 1 551 2 AOI22S $T=1020520 316400 1 0 $X=1020520 $Y=310980
X372 2728 2587 2733 2618 1 556 2 AOI22S $T=1027960 276080 0 180 $X=1024240 $Y=270660
X373 535 2624 612 2716 1 2600 2 AOI22S $T=1024860 316400 1 0 $X=1024860 $Y=310980
X374 2633 2600 2741 2734 1 2730 2 AOI22S $T=1029200 286160 0 180 $X=1025480 $Y=280740
X375 2739 2607 615 2561 1 2657 2 AOI22S $T=1029820 306320 1 180 $X=1026100 $Y=305940
X376 2624 2728 616 570 1 2714 2 AOI22S $T=1028580 316400 1 0 $X=1028580 $Y=310980
X377 602 2742 2747 594 1 2739 2 AOI22S $T=1033540 306320 0 180 $X=1029820 $Y=300900
X378 2587 619 2745 2642 1 2600 2 AOI22S $T=1034780 286160 0 180 $X=1031060 $Y=280740
X379 594 619 2746 2587 1 2667 2 AOI22S $T=1035400 276080 0 180 $X=1031680 $Y=270660
X380 2728 2607 2744 2599 1 2693 2 AOI22S $T=1032300 306320 0 0 $X=1032300 $Y=305940
X381 2764 2742 2698 2754 1 2731 2 AOI22S $T=1039120 296240 0 180 $X=1035400 $Y=290820
X382 2764 2599 629 623 1 2685 2 AOI22S $T=1039740 316400 0 180 $X=1036020 $Y=310980
X383 549 623 628 2761 1 546 2 AOI22S $T=1037260 316400 0 0 $X=1037260 $Y=316020
X384 546 634 632 636 1 2778 2 AOI22S $T=1040980 326480 1 0 $X=1040980 $Y=321060
X385 546 594 631 2764 1 2728 2 AOI22S $T=1042220 316400 1 0 $X=1042220 $Y=310980
X386 2582 561 637 2777 1 551 2 AOI22S $T=1042840 306320 1 0 $X=1042840 $Y=300900
X387 2802 2554 645 2693 1 2742 2 AOI22S $T=1054000 296240 1 180 $X=1050280 $Y=295860
X388 546 2777 2801 2587 1 2752 2 AOI22S $T=1054620 296240 0 180 $X=1050900 $Y=290820
X389 2742 2777 648 2769 1 2798 2 AOI22S $T=1055240 286160 1 180 $X=1051520 $Y=285780
X390 2777 553 650 2808 1 2810 2 AOI22S $T=1054620 306320 0 0 $X=1054620 $Y=305940
X391 2716 592 649 546 1 2764 2 AOI22S $T=1055240 316400 1 0 $X=1055240 $Y=310980
X392 2607 553 654 594 1 2761 2 AOI22S $T=1058960 316400 0 0 $X=1058960 $Y=316020
X393 2581 516 2821 546 1 2764 2 AOI22S $T=1060200 296240 0 0 $X=1060200 $Y=295860
X394 685 694 2866 661 1 2863 2 AOI22S $T=1089960 326480 1 0 $X=1089960 $Y=321060
X395 2764 2693 697 2862 1 2864 2 AOI22S $T=1090580 296240 0 0 $X=1090580 $Y=295860
X396 746 744 1 2 751 AN2 $T=269080 306320 1 0 $X=269080 $Y=300900
X397 754 747 1 2 774 AN2 $T=274040 316400 0 0 $X=274040 $Y=316020
X398 758 764 1 2 772 AN2 $T=279000 255920 1 0 $X=279000 $Y=250500
X399 760 768 1 2 779 AN2 $T=280860 255920 0 0 $X=280860 $Y=255540
X400 765 771 1 2 776 AN2 $T=282720 286160 1 0 $X=282720 $Y=280740
X401 782 785 1 2 791 AN2 $T=294500 245840 1 0 $X=294500 $Y=240420
X402 786 790 1 2 800 AN2 $T=299460 286160 1 0 $X=299460 $Y=280740
X403 793 795 1 2 20 AN2 $T=299460 326480 1 0 $X=299460 $Y=321060
X404 810 822 1 2 824 AN2 $T=318680 306320 1 0 $X=318680 $Y=300900
X405 802 811 1 2 830 AN2 $T=319920 245840 1 0 $X=319920 $Y=240420
X406 821 827 1 2 834 AN2 $T=323640 316400 0 0 $X=323640 $Y=316020
X407 806 826 1 2 843 AN2 $T=326740 255920 0 0 $X=326740 $Y=255540
X408 815 836 1 2 844 AN2 $T=326740 276080 0 0 $X=326740 $Y=275700
X409 838 839 1 2 855 AN2 $T=327360 245840 0 0 $X=327360 $Y=245460
X410 36 886 1 2 34 AN2 $T=358980 316400 1 180 $X=356500 $Y=316020
X411 37 36 1 2 31 AN2 $T=365800 316400 1 180 $X=363320 $Y=316020
X412 903 36 1 2 895 AN2 $T=363940 316400 1 0 $X=363940 $Y=310980
X413 901 36 1 2 872 AN2 $T=366420 316400 1 0 $X=366420 $Y=310980
X414 36 886 1 2 866 AN2 $T=366420 326480 1 0 $X=366420 $Y=321060
X415 36 886 1 2 38 AN2 $T=368900 326480 1 0 $X=368900 $Y=321060
X416 37 36 1 2 42 AN2 $T=376340 326480 1 0 $X=376340 $Y=321060
X417 37 36 1 2 880 AN2 $T=378820 326480 1 0 $X=378820 $Y=321060
X418 975 901 1 2 56 AN2 $T=425320 316400 1 180 $X=422840 $Y=316020
X419 1046 886 1 2 57 AN2 $T=451360 326480 0 180 $X=448880 $Y=321060
X420 1046 903 1 2 90 AN2 $T=455080 316400 1 0 $X=455080 $Y=310980
X421 1046 901 1 2 93 AN2 $T=465000 316400 0 0 $X=465000 $Y=316020
X422 1202 123 1 2 1206 AN2 $T=538160 306320 0 0 $X=538160 $Y=305940
X423 1222 123 1 2 1221 AN2 $T=546220 266000 1 0 $X=546220 $Y=260580
X424 1232 123 1 2 1233 AN2 $T=552420 235760 0 0 $X=552420 $Y=235380
X425 1236 123 1 2 1259 AN2 $T=553040 245840 1 0 $X=553040 $Y=240420
X426 1305 1302 1 2 1297 AN2 $T=568540 306320 1 180 $X=566060 $Y=305940
X427 1298 1297 1 2 137 AN2 $T=566060 316400 0 0 $X=566060 $Y=316020
X428 1287 1306 1 2 1318 AN2 $T=571640 276080 1 0 $X=571640 $Y=270660
X429 1320 1319 1 2 1302 AN2 $T=574740 306320 0 180 $X=572260 $Y=300900
X430 1322 123 1 2 1327 AN2 $T=574740 235760 0 0 $X=574740 $Y=235380
X431 1318 1325 1 2 1332 AN2 $T=576600 286160 0 0 $X=576600 $Y=285780
X432 1325 1333 1 2 1337 AN2 $T=577840 286160 1 0 $X=577840 $Y=280740
X433 1337 1318 1 2 1347 AN2 $T=579700 286160 0 0 $X=579700 $Y=285780
X434 1345 1340 1 2 1310 AN2 $T=582800 296240 1 180 $X=580320 $Y=295860
X435 1346 1342 1 2 1300 AN2 $T=584040 266000 0 180 $X=581560 $Y=260580
X436 1356 1352 1 2 1312 AN2 $T=585900 235760 0 180 $X=583420 $Y=230340
X437 1363 1364 1 2 1345 AN2 $T=589000 306320 0 180 $X=586520 $Y=300900
X438 1368 1371 1 2 1380 AN2 $T=590240 276080 1 0 $X=590240 $Y=270660
X439 1387 1347 1 2 1371 AN2 $T=597680 276080 1 180 $X=595200 $Y=275700
X440 1384 1380 1 2 1398 AN2 $T=597060 266000 0 0 $X=597060 $Y=265620
X441 1391 162 1 2 1365 AN2 $T=598920 306320 1 0 $X=598920 $Y=300900
X442 1411 1407 1 2 1401 AN2 $T=604500 235760 1 180 $X=602020 $Y=235380
X443 1421 1422 1 2 1381 AN2 $T=613180 245840 1 180 $X=610700 $Y=245460
X444 1427 1398 1 2 1440 AN2 $T=611320 255920 0 0 $X=611320 $Y=255540
X445 1435 174 1 2 1446 AN2 $T=613800 296240 1 0 $X=613800 $Y=290820
X446 1485 1440 1 2 1493 AN2 $T=636120 255920 1 0 $X=636120 $Y=250500
X447 1496 1493 1 2 1505 AN2 $T=638600 245840 1 0 $X=638600 $Y=240420
X448 1504 1505 1 2 1509 AN2 $T=641080 245840 1 0 $X=641080 $Y=240420
X449 1512 1509 1 2 1534 AN2 $T=651620 245840 1 0 $X=651620 $Y=240420
X450 1531 1534 1 2 1539 AN2 $T=656580 245840 0 0 $X=656580 $Y=245460
X451 1537 1539 1 2 1547 AN2 $T=658440 255920 1 0 $X=658440 $Y=250500
X452 1548 1547 1 2 1559 AN2 $T=661540 266000 1 0 $X=661540 $Y=260580
X453 1555 1559 1 2 1562 AN2 $T=664020 286160 1 0 $X=664020 $Y=280740
X454 1549 1562 1 2 1564 AN2 $T=668360 286160 0 0 $X=668360 $Y=285780
X455 1581 220 1 2 1599 AN2 $T=684480 245840 1 0 $X=684480 $Y=240420
X456 1587 220 1 2 1624 AN2 $T=688820 266000 1 0 $X=688820 $Y=260580
X457 221 220 1 2 1619 AN2 $T=690680 306320 0 0 $X=690680 $Y=305940
X458 223 220 1 2 1627 AN2 $T=692540 296240 1 0 $X=692540 $Y=290820
X459 219 220 1 2 1631 AN2 $T=695020 316400 0 0 $X=695020 $Y=316020
X460 1646 220 1 2 1654 AN2 $T=702460 245840 1 0 $X=702460 $Y=240420
X461 1660 1647 1 2 1651 AN2 $T=706180 266000 1 180 $X=703700 $Y=265620
X462 1655 1651 1 2 1662 AN2 $T=704320 276080 1 0 $X=704320 $Y=270660
X463 1663 1653 1 2 1660 AN2 $T=708040 255920 1 180 $X=705560 $Y=255540
X464 1667 1662 1 2 1657 AN2 $T=708660 286160 1 180 $X=706180 $Y=285780
X465 1658 1657 1 2 1665 AN2 $T=706180 296240 0 0 $X=706180 $Y=295860
X466 1674 1672 1 2 1663 AN2 $T=711760 255920 1 180 $X=709280 $Y=255540
X467 1668 1665 1 2 1666 AN2 $T=709280 316400 1 0 $X=709280 $Y=310980
X468 235 1676 1 2 1638 AN2 $T=713620 286160 1 180 $X=711140 $Y=285780
X469 1669 1666 1 2 234 AN2 $T=711140 326480 1 0 $X=711140 $Y=321060
X470 1670 220 1 2 1682 AN2 $T=713000 245840 1 0 $X=713000 $Y=240420
X471 1679 1681 1 2 1698 AN2 $T=716100 266000 1 0 $X=716100 $Y=260580
X472 1694 1691 1 2 1679 AN2 $T=718580 276080 0 180 $X=716100 $Y=270660
X473 239 1676 1 2 1637 AN2 $T=718580 286160 1 180 $X=716100 $Y=285780
X474 1676 1688 1 2 1708 AN2 $T=719820 286160 0 0 $X=719820 $Y=285780
X475 1698 1715 1 2 1674 AN2 $T=724160 255920 1 180 $X=721680 $Y=255540
X476 248 249 1 2 1739 AN2 $T=731600 326480 1 0 $X=731600 $Y=321060
X477 1764 220 1 2 1730 AN2 $T=740900 245840 1 180 $X=738420 $Y=245460
X478 1761 220 1 2 1759 AN2 $T=740900 286160 0 180 $X=738420 $Y=280740
X479 1766 220 1 2 1734 AN2 $T=742760 245840 0 180 $X=740280 $Y=240420
X480 1771 220 1 2 1756 AN2 $T=744620 255920 1 180 $X=742140 $Y=255540
X481 1765 1781 1 2 1791 AN2 $T=750820 266000 0 0 $X=750820 $Y=265620
X482 1824 1821 1 2 1814 AN2 $T=762600 286160 1 180 $X=760120 $Y=285780
X483 1812 1814 1 2 1827 AN2 $T=760740 306320 0 0 $X=760740 $Y=305940
X484 1807 1827 1 2 260 AN2 $T=764460 316400 1 180 $X=761980 $Y=316020
X485 1848 1839 1 2 1821 AN2 $T=770040 286160 0 180 $X=767560 $Y=280740
X486 269 1842 1 2 1846 AN2 $T=770660 296240 1 0 $X=770660 $Y=290820
X487 1857 1855 1 2 1839 AN2 $T=775000 276080 0 180 $X=772520 $Y=270660
X488 265 1842 1 2 1864 AN2 $T=772520 286160 0 0 $X=772520 $Y=285780
X489 1863 1858 1 2 1853 AN2 $T=775620 296240 0 180 $X=773140 $Y=290820
X490 1861 1867 1 2 1855 AN2 $T=776240 266000 0 0 $X=776240 $Y=265620
X491 1866 1869 1 2 1867 AN2 $T=781820 255920 1 180 $X=779340 $Y=255540
X492 1849 1879 1 2 1866 AN2 $T=783680 245840 1 180 $X=781200 $Y=245460
X493 1885 1876 1 2 1896 AN2 $T=784920 306320 0 0 $X=784920 $Y=305940
X494 1918 1882 1 2 1911 AN2 $T=797320 255920 0 180 $X=794840 $Y=250500
X495 1905 1919 1 2 1934 AN2 $T=798560 266000 0 0 $X=798560 $Y=265620
X496 1945 1939 1 2 1932 AN2 $T=804140 296240 0 180 $X=801660 $Y=290820
X497 1933 1932 1 2 1941 AN2 $T=801660 306320 1 0 $X=801660 $Y=300900
X498 1935 1941 1 2 287 AN2 $T=804140 316400 1 180 $X=801660 $Y=316020
X499 1942 1943 1 2 1939 AN2 $T=804760 276080 0 180 $X=802280 $Y=270660
X500 1938 1937 1 2 1955 AN2 $T=808480 255920 0 0 $X=808480 $Y=255540
X501 1962 1963 1 2 1937 AN2 $T=812820 245840 0 180 $X=810340 $Y=240420
X502 1957 1955 1 2 1943 AN2 $T=810340 266000 0 0 $X=810340 $Y=265620
X503 296 1968 1 2 1951 AN2 $T=814060 255920 1 180 $X=811580 $Y=255540
X504 1964 1959 1 2 1971 AN2 $T=811580 316400 1 0 $X=811580 $Y=310980
X505 1985 1974 1 2 1962 AN2 $T=815920 225680 1 180 $X=813440 $Y=225300
X506 298 1968 1 2 1960 AN2 $T=815920 255920 0 180 $X=813440 $Y=250500
X507 320 2061 1 2 2051 AN2 $T=843200 245840 0 180 $X=840720 $Y=240420
X508 2297 2321 1 2 2243 AN2 $T=905200 225680 1 180 $X=902720 $Y=225300
X509 2214 2323 1 2 2347 AN2 $T=910780 245840 1 0 $X=910780 $Y=240420
X510 2395 2397 1 2 2113 AN2 $T=925660 245840 0 180 $X=923180 $Y=240420
X511 411 333 1 2 2353 AN2 $T=942400 266000 0 0 $X=942400 $Y=265620
X512 444 2502 1 2 2518 AN2 $T=965340 235760 0 0 $X=965340 $Y=235380
X513 2540 2564 1 2 2560 AN2 $T=983320 276080 0 180 $X=980840 $Y=270660
X514 509 2574 1 2 2570 AN2 $T=986420 316400 1 180 $X=983940 $Y=316020
X515 2550 2626 1 2 2621 AN2 $T=998820 296240 1 180 $X=996340 $Y=295860
X516 2652 2608 1 2 2638 AN2 $T=1005020 245840 0 180 $X=1002540 $Y=240420
X517 2527 569 1 2 2655 AN2 $T=1003780 276080 1 0 $X=1003780 $Y=270660
X518 2584 2720 1 2 2724 AN2 $T=1021140 266000 0 0 $X=1021140 $Y=265620
X519 2826 2783 1 2 2640 AN2 $T=1059580 276080 0 180 $X=1057100 $Y=270660
X520 519 2813 1 2 2830 AN2 $T=1073840 245840 0 180 $X=1071360 $Y=240420
X521 1072 1021 1 2 INV4CK $T=460660 276080 0 180 $X=456940 $Y=270660
X522 1382 1379 1 2 INV4CK $T=593960 266000 0 180 $X=590240 $Y=260580
X523 1291 1305 1 2 INV2CK $T=566680 316400 1 0 $X=566680 $Y=310980
X524 1467 1459 1 2 INV2CK $T=623720 266000 0 180 $X=621240 $Y=260580
X525 1900 1905 1 2 INV2CK $T=788020 266000 0 0 $X=788020 $Y=265620
X526 299 1966 1 2 INV2CK $T=814680 306320 0 180 $X=812200 $Y=300900
X527 294 1980 1 2 INV2CK $T=816540 316400 0 0 $X=816540 $Y=316020
X528 910 1 2 909 DELC $T=359600 326480 1 0 $X=359600 $Y=321060
X529 908 1 2 905 DELC $T=366420 306320 1 0 $X=366420 $Y=300900
X530 923 1 2 922 DELC $T=371380 286160 1 0 $X=371380 $Y=280740
X531 1002 1 2 1004 DELC $T=418500 306320 0 0 $X=418500 $Y=305940
X532 1011 1 2 1000 DELC $T=422840 296240 0 0 $X=422840 $Y=295860
X533 1007 1 2 1023 DELC $T=427800 276080 0 0 $X=427800 $Y=275700
X534 1054 1 2 1059 DELC $T=441440 286160 1 0 $X=441440 $Y=280740
X535 1062 1 2 75 DELC $T=443920 316400 0 0 $X=443920 $Y=316020
X536 1076 1 2 1082 DELC $T=457560 306320 1 0 $X=457560 $Y=300900
X537 1087 1 2 1066 DELC $T=461900 286160 1 0 $X=461900 $Y=280740
X538 35 869 1 2 908 QDBHN $T=366420 306320 0 180 $X=358980 $Y=300900
X539 35 848 1 2 910 QDBHN $T=368900 306320 0 0 $X=368900 $Y=305940
X540 35 858 1 2 923 QDBHN $T=381300 276080 0 180 $X=373860 $Y=270660
X541 35 970 1 2 1002 QDBHN $T=407340 316400 0 0 $X=407340 $Y=316020
X542 35 963 1 2 1007 QDBHN $T=412300 276080 0 0 $X=412300 $Y=275700
X543 35 969 1 2 1011 QDBHN $T=415400 296240 0 0 $X=415400 $Y=295860
X544 35 1058 1 2 1062 QDBHN $T=436480 316400 0 0 $X=436480 $Y=316020
X545 35 997 1 2 1054 QDBHN $T=444540 276080 0 180 $X=437100 $Y=270660
X546 35 1003 1 2 1076 QDBHN $T=447640 296240 0 0 $X=447640 $Y=295860
X547 35 1039 1 2 1087 QDBHN $T=455080 286160 0 0 $X=455080 $Y=285780
X548 905 35 892 1 2 AN2T $T=355260 306320 0 180 $X=350920 $Y=300900
X549 909 35 915 1 2 AN2T $T=358980 316400 0 0 $X=358980 $Y=316020
X550 922 35 919 1 2 AN2T $T=371380 286160 0 180 $X=367040 $Y=280740
X551 1000 35 977 1 2 AN2T $T=415400 286160 0 0 $X=415400 $Y=285780
X552 1004 35 1010 1 2 AN2T $T=418500 316400 0 0 $X=418500 $Y=316020
X553 1023 35 1016 1 2 AN2T $T=427800 276080 1 180 $X=423460 $Y=275700
X554 1059 35 1049 1 2 AN2T $T=441440 286160 0 180 $X=437100 $Y=280740
X555 1066 35 1072 1 2 AN2T $T=447020 286160 0 0 $X=447020 $Y=285780
X556 1082 35 1088 1 2 AN2T $T=458800 296240 0 0 $X=458800 $Y=295860
X557 1278 1283 1276 1 2 AN2T $T=563580 266000 0 0 $X=563580 $Y=265620
X558 1310 1309 1320 1 2 AN2T $T=580320 296240 1 180 $X=575980 $Y=295860
X559 146 1334 1279 1 2 AN2T $T=580320 316400 0 180 $X=575980 $Y=310980
X560 147 1334 1291 1 2 AN2T $T=580320 316400 1 180 $X=575980 $Y=316020
X561 1327 149 1321 1 2 AN2T $T=582180 235760 1 180 $X=577840 $Y=235380
X562 1379 1381 1346 1 2 AN2T $T=595820 255920 0 180 $X=591480 $Y=250500
X563 1383 1385 1364 1 2 AN2T $T=597060 296240 1 180 $X=592720 $Y=295860
X564 1409 1408 1382 1 2 AN2T $T=604500 266000 1 180 $X=600160 $Y=265620
X565 1410 1408 1284 1 2 AN2T $T=603880 276080 1 0 $X=603880 $Y=270660
X566 1454 1441 1422 1 2 AN2T $T=619380 245840 0 180 $X=615040 $Y=240420
X567 1460 1408 1275 1 2 AN2T $T=621240 266000 0 180 $X=616900 $Y=260580
X568 1840 1842 1880 1 2 AN2T $T=777480 286160 1 0 $X=777480 $Y=280740
X569 1969 1968 1995 1 2 AN2T $T=817780 255920 1 0 $X=817780 $Y=250500
X570 2005 1999 2023 1 2 AN2T $T=832040 245840 0 0 $X=832040 $Y=245460
X571 2021 2016 2005 1 2 AN2T $T=833900 255920 1 0 $X=833900 $Y=250500
X572 2006 1983 2016 1 2 AN2T $T=833900 266000 1 0 $X=833900 $Y=260580
X573 1008 56 1013 2 1005 57 1 AO22 $T=421600 286160 1 0 $X=421600 $Y=280740
X574 1024 56 1014 2 1012 57 1 AO22 $T=427800 326480 0 180 $X=422840 $Y=321060
X575 1042 56 1019 2 1025 57 1 AO22 $T=432140 235760 1 180 $X=427180 $Y=235380
X576 1036 56 1020 2 1026 57 1 AO22 $T=432140 245840 1 180 $X=427180 $Y=245460
X577 1048 56 1027 2 1028 57 1 AO22 $T=433380 266000 1 180 $X=428420 $Y=265620
X578 1034 56 1009 2 1029 57 1 AO22 $T=433380 296240 0 180 $X=428420 $Y=290820
X579 1068 56 1061 2 1063 57 1 AO22 $T=447640 235760 1 180 $X=442680 $Y=235380
X580 1116 56 1128 2 1127 57 1 AO22 $T=489800 235760 0 0 $X=489800 $Y=235380
X581 1145 56 1147 2 1148 57 1 AO22 $T=499720 286160 0 0 $X=499720 $Y=285780
X582 1144 56 1154 2 1155 57 1 AO22 $T=502200 235760 0 0 $X=502200 $Y=235380
X583 1159 56 1150 2 1152 57 1 AO22 $T=508400 296240 0 180 $X=503440 $Y=290820
X584 111 56 109 2 1153 57 1 AO22 $T=509640 326480 0 180 $X=504680 $Y=321060
X585 1146 56 1158 2 1162 57 1 AO22 $T=506540 245840 0 0 $X=506540 $Y=245460
X586 1156 56 1151 2 1157 57 1 AO22 $T=506540 316400 0 0 $X=506540 $Y=316020
X587 1170 56 1161 2 1163 57 1 AO22 $T=515840 266000 0 180 $X=510880 $Y=260580
X588 1240 1266 1272 2 1281 1286 1 AO22 $T=558000 296240 1 0 $X=558000 $Y=290820
X589 1262 133 1289 2 1291 134 1 AO22 $T=559860 316400 0 0 $X=559860 $Y=316020
X590 1235 133 1290 2 1292 134 1 AO22 $T=559860 326480 1 0 $X=559860 $Y=321060
X591 151 1266 1351 2 1357 1286 1 AO22 $T=582800 276080 0 0 $X=582800 $Y=275700
X592 153 1266 1360 2 1366 1286 1 AO22 $T=585280 286160 0 0 $X=585280 $Y=285780
X593 1341 1266 1372 2 1393 1286 1 AO22 $T=594580 276080 1 0 $X=594580 $Y=270660
X594 1402 133 1405 2 165 162 1 AO22 $T=600780 316400 0 0 $X=600780 $Y=316020
X595 1400 1266 1416 2 1418 1286 1 AO22 $T=603260 266000 1 0 $X=603260 $Y=260580
X596 1424 133 171 2 172 162 1 AO22 $T=608220 326480 1 0 $X=608220 $Y=321060
X597 1426 164 1475 2 1478 1286 1 AO22 $T=627440 255920 0 0 $X=627440 $Y=255540
X598 1469 164 1483 2 1490 1286 1 AO22 $T=630540 245840 1 0 $X=630540 $Y=240420
X599 1481 164 1501 2 1502 1286 1 AO22 $T=637980 255920 0 0 $X=637980 $Y=255540
X600 1521 164 1519 2 1511 1286 1 AO22 $T=651620 245840 1 180 $X=646660 $Y=245460
X601 1532 164 1529 2 1526 1286 1 AO22 $T=657200 255920 0 180 $X=652240 $Y=250500
X602 1538 176 1535 2 201 134 1 AO22 $T=659680 316400 1 180 $X=654720 $Y=316020
X603 1558 164 1552 2 1536 1286 1 AO22 $T=665260 255920 1 180 $X=660300 $Y=255540
X604 208 1543 164 2 1556 1286 1 AO22 $T=665880 306320 1 0 $X=665880 $Y=300900
X605 1560 176 1557 2 209 134 1 AO22 $T=671460 316400 1 180 $X=666500 $Y=316020
X606 211 164 1567 2 1544 1286 1 AO22 $T=670840 266000 0 0 $X=670840 $Y=265620
X607 213 164 1569 2 1545 1286 1 AO22 $T=672080 306320 1 0 $X=672080 $Y=300900
X608 215 164 1570 2 1542 1286 1 AO22 $T=678900 286160 0 180 $X=673940 $Y=280740
X609 1616 1632 1633 2 1637 1641 1 AO22 $T=696260 245840 0 0 $X=696260 $Y=245460
X610 1601 1632 1634 2 1638 1641 1 AO22 $T=696260 266000 1 0 $X=696260 $Y=260580
X611 1629 1632 1639 2 1643 1641 1 AO22 $T=698740 276080 0 0 $X=698740 $Y=275700
X612 1626 1632 1640 2 1644 1641 1 AO22 $T=699360 286160 1 0 $X=699360 $Y=280740
X613 1630 1632 1645 2 1650 1641 1 AO22 $T=700600 306320 0 0 $X=700600 $Y=305940
X614 1635 1632 1649 2 1656 1641 1 AO22 $T=701840 296240 1 0 $X=701840 $Y=290820
X615 1636 1632 1659 2 1661 1641 1 AO22 $T=703700 316400 0 0 $X=703700 $Y=316020
X616 1648 1632 1680 2 1683 1641 1 AO22 $T=711760 255920 1 0 $X=711760 $Y=250500
X617 1741 1632 1737 2 1725 1641 1 AO22 $T=734080 276080 1 180 $X=729120 $Y=275700
X618 1768 176 1790 2 1793 259 1 AO22 $T=750820 306320 0 0 $X=750820 $Y=305940
X619 1785 176 1797 2 1801 259 1 AO22 $T=753300 326480 1 0 $X=753300 $Y=321060
X620 1787 176 1800 2 1805 259 1 AO22 $T=754540 306320 1 0 $X=754540 $Y=300900
X621 1795 176 1834 2 1822 1833 1 AO22 $T=764460 296240 1 0 $X=764460 $Y=290820
X622 1829 1836 1838 2 1835 1833 1 AO22 $T=766320 276080 1 0 $X=766320 $Y=270660
X623 1809 1836 1841 2 1846 1833 1 AO22 $T=767560 266000 1 0 $X=767560 $Y=260580
X624 1830 1836 1847 2 1851 1833 1 AO22 $T=768800 266000 0 0 $X=768800 $Y=265620
X625 1868 1836 1860 2 1852 1833 1 AO22 $T=777480 245840 0 180 $X=772520 $Y=240420
X626 1823 1836 1856 2 1864 1833 1 AO22 $T=773140 255920 1 0 $X=773140 $Y=250500
X627 1915 1836 1892 2 1884 1833 1 AO22 $T=793600 266000 0 180 $X=788640 $Y=260580
X628 1788 164 1921 2 1926 285 1 AO22 $T=794840 316400 0 0 $X=794840 $Y=316020
X629 1811 164 1923 2 1927 285 1 AO22 $T=795460 276080 0 0 $X=795460 $Y=275700
X630 1792 164 1920 2 1928 285 1 AO22 $T=795460 296240 1 0 $X=795460 $Y=290820
X631 1763 164 1924 2 1929 285 1 AO22 $T=795460 306320 0 0 $X=795460 $Y=305940
X632 1784 164 1925 2 1931 285 1 AO22 $T=796080 286160 0 0 $X=796080 $Y=285780
X633 1828 164 1947 2 1949 285 1 AO22 $T=803520 266000 0 0 $X=803520 $Y=265620
X634 1813 164 1930 2 1951 285 1 AO22 $T=804760 245840 0 0 $X=804760 $Y=245460
X635 1185 117 119 2 1 122 QDFFRBN $T=525760 326480 1 0 $X=525760 $Y=321060
X636 1187 117 119 2 1 1222 QDFFRBN $T=531960 266000 1 0 $X=531960 $Y=260580
X637 1189 117 119 2 1 1202 QDFFRBN $T=533200 296240 0 0 $X=533200 $Y=295860
X638 1197 117 119 2 1 1236 QDFFRBN $T=536300 225680 0 0 $X=536300 $Y=225300
X639 1200 117 119 2 1 1232 QDFFRBN $T=536920 235760 0 0 $X=536920 $Y=235380
X640 1308 117 119 2 1 1277 QDFFRBN $T=572260 235760 0 180 $X=560480 $Y=230340
X641 1390 117 119 2 1 1322 QDFFRBN $T=597680 225680 0 180 $X=585900 $Y=220260
X642 1551 117 119 2 1 1581 QDFFRBN $T=662160 245840 1 0 $X=662160 $Y=240420
X643 1554 117 119 2 1 1593 QDFFRBN $T=662780 225680 0 0 $X=662780 $Y=225300
X644 1563 117 119 2 1 1587 QDFFRBN $T=667740 266000 1 0 $X=667740 $Y=260580
X645 1571 117 119 2 1 219 QDFFRBN $T=671460 316400 0 0 $X=671460 $Y=316020
X646 1573 117 119 2 1 223 QDFFRBN $T=673320 286160 0 0 $X=673320 $Y=285780
X647 1577 117 119 2 1 1604 QDFFRBN $T=674560 276080 0 0 $X=674560 $Y=275700
X648 1572 117 119 2 1 221 QDFFRBN $T=677660 306320 0 0 $X=677660 $Y=305940
X649 1618 117 119 2 1 1646 QDFFRBN $T=694400 225680 0 0 $X=694400 $Y=225300
X650 1706 117 119 2 1 1670 QDFFRBN $T=721680 225680 1 180 $X=709900 $Y=225300
X651 1789 117 257 2 1 1761 QDFFRBN $T=753920 286160 0 180 $X=742140 $Y=280740
X652 1796 117 257 2 1 1771 QDFFRBN $T=756400 255920 0 180 $X=744620 $Y=250500
X653 1803 117 257 2 1 1766 QDFFRBN $T=758880 235760 0 180 $X=747100 $Y=230340
X654 1815 117 257 2 1 1764 QDFFRBN $T=761980 245840 1 180 $X=750200 $Y=245460
X655 2012 304 257 2 1 1910 QDFFRBN $T=828940 296240 0 180 $X=817160 $Y=290820
X656 2039 304 257 2 1 2003 QDFFRBN $T=839480 266000 1 180 $X=827700 $Y=265620
X657 2042 304 257 2 1 1913 QDFFRBN $T=840100 286160 0 180 $X=828320 $Y=280740
X658 2045 304 257 2 1 1994 QDFFRBN $T=840720 276080 1 180 $X=828940 $Y=275700
X659 840 2 13 1 INV1S $T=327360 326480 0 180 $X=326120 $Y=321060
X660 841 2 11 1 INV1S $T=328600 316400 1 180 $X=327360 $Y=316020
X661 854 2 14 1 INV1S $T=330460 316400 1 180 $X=329220 $Y=316020
X662 889 2 10 1 INV1S $T=349680 326480 0 180 $X=348440 $Y=321060
X663 932 2 33 1 INV1S $T=375100 326480 1 0 $X=375100 $Y=321060
X664 36 2 896 1 INV1S $T=393700 316400 0 0 $X=393700 $Y=316020
X665 973 2 46 1 INV1S $T=403000 316400 1 0 $X=403000 $Y=310980
X666 1018 2 58 1 INV1S $T=425320 316400 0 0 $X=425320 $Y=316020
X667 69 2 1040 1 INV1S $T=435240 306320 0 180 $X=434000 $Y=300900
X668 1030 2 59 1 INV1S $T=435240 326480 1 0 $X=435240 $Y=321060
X669 70 2 1056 1 INV1S $T=442060 306320 1 180 $X=440820 $Y=305940
X670 77 2 1067 1 INV1S $T=451360 316400 0 180 $X=450120 $Y=310980
X671 1074 2 81 1 INV1S $T=451360 326480 1 0 $X=451360 $Y=321060
X672 1086 2 89 1 INV1S $T=466240 306320 0 0 $X=466240 $Y=305940
X673 103 2 780 1 INV1S $T=484840 266000 0 180 $X=483600 $Y=260580
X674 101 2 789 1 INV1S $T=489180 266000 1 180 $X=487940 $Y=265620
X675 108 2 739 1 INV1S $T=506540 286160 0 180 $X=505300 $Y=280740
X676 110 2 797 1 INV1S $T=508400 286160 0 180 $X=507160 $Y=280740
X677 113 2 738 1 INV1S $T=510880 276080 0 180 $X=509640 $Y=270660
X678 114 2 777 1 INV1S $T=517080 306320 0 0 $X=517080 $Y=305940
X679 115 2 740 1 INV1S $T=517080 316400 1 0 $X=517080 $Y=310980
X680 116 2 7 1 INV1S $T=523900 326480 0 180 $X=522660 $Y=321060
X681 118 2 736 1 INV1S $T=531960 306320 1 180 $X=530720 $Y=305940
X682 121 2 796 1 INV1S $T=537540 276080 1 180 $X=536300 $Y=275700
X683 125 2 808 1 INV1S $T=538780 245840 1 180 $X=537540 $Y=245460
X684 1227 2 1213 1 INV1S $T=547460 296240 1 180 $X=546220 $Y=295860
X685 1281 2 1270 1 INV1S $T=560480 286160 1 180 $X=559240 $Y=285780
X686 1284 2 1307 1 INV1S $T=571020 266000 1 180 $X=569780 $Y=265620
X687 1304 2 1325 1 INV1S $T=573500 286160 1 0 $X=573500 $Y=280740
X688 1292 2 1298 1 INV1S $T=575360 326480 0 180 $X=574120 $Y=321060
X689 1288 2 1319 1 INV1S $T=575980 296240 1 180 $X=574740 $Y=295860
X690 1353 2 1328 1 INV1S $T=581560 225680 1 180 $X=580320 $Y=225300
X691 1334 2 148 1 INV1S $T=580320 316400 0 0 $X=580320 $Y=316020
X692 1315 2 1333 1 INV1S $T=582800 286160 0 180 $X=581560 $Y=280740
X693 1330 2 1342 1 INV1S $T=583420 266000 1 180 $X=582180 $Y=265620
X694 152 2 1334 1 INV1S $T=584660 316400 1 180 $X=583420 $Y=316020
X695 155 2 1359 1 INV1S $T=587140 316400 0 180 $X=585900 $Y=310980
X696 1357 2 1368 1 INV1S $T=588380 276080 1 0 $X=588380 $Y=270660
X697 1366 2 1387 1 INV1S $T=599540 276080 1 180 $X=598300 $Y=275700
X698 1393 2 1384 1 INV1S $T=600780 276080 0 180 $X=599540 $Y=270660
X699 1408 2 1430 1 INV1S $T=607600 266000 0 0 $X=607600 $Y=265620
X700 1418 2 1427 1 INV1S $T=609460 266000 1 0 $X=609460 $Y=260580
X701 173 2 1435 1 INV1S $T=613180 296240 1 180 $X=611940 $Y=295860
X702 1436 2 1428 1 INV1S $T=613800 276080 0 180 $X=612560 $Y=270660
X703 1434 2 1444 1 INV1S $T=613180 235760 1 0 $X=613180 $Y=230340
X704 176 2 162 1 INV1S $T=615660 326480 0 180 $X=614420 $Y=321060
X705 166 2 1408 1 INV1S $T=619380 255920 0 0 $X=619380 $Y=255540
X706 1478 2 1485 1 INV1S $T=634260 255920 1 0 $X=634260 $Y=250500
X707 1490 2 1496 1 INV1S $T=636740 245840 1 0 $X=636740 $Y=240420
X708 1502 2 1504 1 INV1S $T=639840 255920 1 0 $X=639840 $Y=250500
X709 192 2 1445 1 INV1S $T=641700 296240 0 0 $X=641700 $Y=295860
X710 1511 2 1512 1 INV1S $T=644180 245840 0 0 $X=644180 $Y=245460
X711 1526 2 1531 1 INV1S $T=654720 245840 0 0 $X=654720 $Y=245460
X712 1536 2 1537 1 INV1S $T=658440 255920 0 0 $X=658440 $Y=255540
X713 1540 2 1555 1 INV1S $T=661540 276080 0 0 $X=661540 $Y=275700
X714 1542 2 1549 1 INV1S $T=661540 286160 1 0 $X=661540 $Y=280740
X715 1544 2 1548 1 INV1S $T=662160 276080 1 0 $X=662160 $Y=270660
X716 209 2 205 1 INV1S $T=665260 326480 0 180 $X=664020 $Y=321060
X717 1545 2 1561 1 INV1S $T=673320 286160 1 180 $X=672080 $Y=285780
X718 1620 2 1598 1 INV1S $T=691920 225680 1 180 $X=690680 $Y=225300
X719 1638 2 1647 1 INV1S $T=701220 266000 0 0 $X=701220 $Y=265620
X720 1637 2 1653 1 INV1S $T=702460 255920 0 0 $X=702460 $Y=255540
X721 1650 2 1668 1 INV1S $T=704940 316400 1 0 $X=704940 $Y=310980
X722 1644 2 1667 1 INV1S $T=710520 286160 1 180 $X=709280 $Y=285780
X723 1643 2 1655 1 INV1S $T=712380 276080 1 180 $X=711140 $Y=275700
X724 1661 2 1669 1 INV1S $T=713000 316400 1 180 $X=711760 $Y=316020
X725 1683 2 1672 1 INV1S $T=714240 255920 1 180 $X=713000 $Y=255540
X726 1676 2 1677 1 INV1S $T=715480 286160 1 180 $X=714240 $Y=285780
X727 1656 2 1658 1 INV1S $T=715480 296240 0 180 $X=714240 $Y=290820
X728 1686 2 1681 1 INV1S $T=716100 276080 0 180 $X=714860 $Y=270660
X729 1695 2 1692 1 INV1S $T=718580 316400 1 180 $X=717340 $Y=316020
X730 238 2 1699 1 INV1S $T=718580 306320 0 0 $X=718580 $Y=305940
X731 237 2 1676 1 INV1S $T=719200 296240 1 0 $X=719200 $Y=290820
X732 1713 2 1684 1 INV1S $T=721680 296240 1 180 $X=720440 $Y=295860
X733 1725 2 1702 1 INV1S $T=722920 276080 0 180 $X=721680 $Y=270660
X734 1718 2 1694 1 INV1S $T=723540 276080 1 180 $X=722300 $Y=275700
X735 1717 2 1723 1 INV1S $T=723540 235760 1 0 $X=723540 $Y=230340
X736 238 2 1716 1 INV1S $T=724780 316400 1 0 $X=724780 $Y=310980
X737 1729 2 1721 1 INV1S $T=726640 296240 1 180 $X=725400 $Y=295860
X738 1733 2 1704 1 INV1S $T=728500 306320 1 180 $X=727260 $Y=305940
X739 1696 2 1733 1 INV1S $T=730360 306320 1 180 $X=729120 $Y=305940
X740 247 2 250 1 INV1S $T=732220 316400 0 0 $X=732220 $Y=316020
X741 1759 2 1757 1 INV1S $T=740900 266000 0 0 $X=740900 $Y=265620
X742 1793 2 1807 1 INV1S $T=756400 306320 0 0 $X=756400 $Y=305940
X743 1822 2 1824 1 INV1S $T=761360 296240 1 0 $X=761360 $Y=290820
X744 1805 2 1812 1 INV1S $T=762600 306320 0 180 $X=761360 $Y=300900
X745 1801 2 261 1 INV1S $T=762600 326480 0 180 $X=761360 $Y=321060
X746 1842 2 1844 1 INV1S $T=769420 286160 0 0 $X=769420 $Y=285780
X747 1835 2 1848 1 INV1S $T=770040 276080 0 0 $X=770040 $Y=275700
X748 1852 2 1849 1 INV1S $T=772520 245840 0 180 $X=771280 $Y=240420
X749 1846 2 1861 1 INV1S $T=773140 266000 1 0 $X=773140 $Y=260580
X750 1851 2 1857 1 INV1S $T=773760 266000 0 0 $X=773760 $Y=265620
X751 1859 2 1862 1 INV1S $T=776240 316400 0 180 $X=775000 $Y=310980
X752 152 2 1842 1 INV1S $T=778100 286160 1 180 $X=776860 $Y=285780
X753 155 2 1863 1 INV1S $T=778100 296240 0 180 $X=776860 $Y=290820
X754 273 2 1850 1 INV1S $T=776860 326480 1 0 $X=776860 $Y=321060
X755 1864 2 1869 1 INV1S $T=778720 255920 1 0 $X=778720 $Y=250500
X756 155 2 1873 1 INV1S $T=781200 296240 0 0 $X=781200 $Y=295860
X757 278 2 1876 1 INV1S $T=783060 316400 0 180 $X=781820 $Y=310980
X758 1881 2 1888 1 INV1S $T=783680 286160 0 0 $X=783680 $Y=285780
X759 1884 2 1918 1 INV1S $T=795460 255920 0 0 $X=795460 $Y=255540
X760 1929 2 1935 1 INV1S $T=800420 306320 0 0 $X=800420 $Y=305940
X761 1926 2 286 1 INV1S $T=800420 316400 1 0 $X=800420 $Y=310980
X762 1927 2 1942 1 INV1S $T=801660 276080 0 0 $X=801660 $Y=275700
X763 1931 2 1945 1 INV1S $T=802280 286160 1 0 $X=802280 $Y=280740
X764 1928 2 1933 1 INV1S $T=803520 296240 1 180 $X=802280 $Y=295860
X765 173 2 1950 1 INV1S $T=805380 306320 1 0 $X=805380 $Y=300900
X766 1951 2 1938 1 INV1S $T=809720 255920 0 180 $X=808480 $Y=250500
X767 173 2 1959 1 INV1S $T=809100 316400 1 0 $X=809100 $Y=310980
X768 1949 2 1957 1 INV1S $T=811580 266000 0 180 $X=810340 $Y=260580
X769 1960 2 1963 1 INV1S $T=810960 255920 1 0 $X=810960 $Y=250500
X770 166 2 1968 1 INV1S $T=814060 255920 0 0 $X=814060 $Y=255540
X771 1972 2 1984 1 INV1S $T=814060 316400 1 0 $X=814060 $Y=310980
X772 1977 2 1972 1 INV1S $T=815920 316400 1 180 $X=814680 $Y=316020
X773 1970 2 1983 1 INV1S $T=815920 266000 1 0 $X=815920 $Y=260580
X774 1968 2 1979 1 INV1S $T=817780 255920 0 180 $X=816540 $Y=250500
X775 1986 2 1974 1 INV1S $T=820260 235760 1 0 $X=820260 $Y=230340
X776 1466 2 294 1 INV1S $T=822120 276080 1 180 $X=820880 $Y=275700
X777 1999 2 2001 1 INV1S $T=823360 245840 0 0 $X=823360 $Y=245460
X778 2003 2 1466 1 INV1S $T=825840 276080 0 180 $X=824600 $Y=270660
X779 192 2 305 1 INV1S $T=824600 326480 1 0 $X=824600 $Y=321060
X780 2005 2 2010 1 INV1S $T=838240 255920 1 0 $X=838240 $Y=250500
X781 334 2 2080 1 INV1S $T=848780 245840 1 0 $X=848780 $Y=240420
X782 339 2 2104 1 INV1S $T=850640 255920 1 180 $X=849400 $Y=255540
X783 343 2 330 1 INV1S $T=851880 245840 0 0 $X=851880 $Y=245460
X784 332 2 2125 1 INV1S $T=853740 235760 0 0 $X=853740 $Y=235380
X785 357 2 2087 1 INV1S $T=856220 306320 0 180 $X=854980 $Y=300900
X786 359 2 2095 1 INV1S $T=856840 235760 1 180 $X=855600 $Y=235380
X787 370 2 2119 1 INV1S $T=859320 255920 0 180 $X=858080 $Y=250500
X788 360 2 378 1 INV1S $T=858700 235760 0 0 $X=858700 $Y=235380
X789 2106 2 2149 1 INV1S $T=861180 245840 0 180 $X=859940 $Y=240420
X790 380 2 2089 1 INV1S $T=862420 245840 0 180 $X=861180 $Y=240420
X791 2085 2 2163 1 INV1S $T=861800 276080 1 0 $X=861800 $Y=270660
X792 385 2 2155 1 INV1S $T=864280 266000 1 180 $X=863040 $Y=265620
X793 379 2 2168 1 INV1S $T=863660 235760 0 0 $X=863660 $Y=235380
X794 386 2 2180 1 INV1S $T=864900 235760 1 0 $X=864900 $Y=230340
X795 390 2 2100 1 INV1S $T=866760 225680 1 180 $X=865520 $Y=225300
X796 2151 2 2192 1 INV1S $T=869240 276080 1 0 $X=869240 $Y=270660
X797 324 2 2197 1 INV1S $T=869240 316400 1 0 $X=869240 $Y=310980
X798 387 2 2186 1 INV1S $T=871100 225680 1 0 $X=871100 $Y=220260
X799 2188 2 2194 1 INV1S $T=871100 276080 1 0 $X=871100 $Y=270660
X800 2206 2 2253 1 INV1S $T=884120 255920 0 0 $X=884120 $Y=255540
X801 350 2 2258 1 INV1S $T=884740 225680 0 0 $X=884740 $Y=225300
X802 2251 2 2227 1 INV1S $T=887220 245840 1 180 $X=885980 $Y=245460
X803 2129 2 2223 1 INV1S $T=888460 276080 0 0 $X=888460 $Y=275700
X804 2249 2 2274 1 INV1S $T=890320 255920 0 0 $X=890320 $Y=255540
X805 2277 2 2244 1 INV1S $T=894660 235760 0 180 $X=893420 $Y=230340
X806 433 2 2214 1 INV1S $T=895900 245840 0 180 $X=894660 $Y=240420
X807 435 2 406 1 INV1S $T=895900 326480 0 180 $X=894660 $Y=321060
X808 2314 2 2304 1 INV1S $T=902100 235760 1 180 $X=900860 $Y=235380
X809 394 2 2199 1 INV1S $T=905820 326480 1 0 $X=905820 $Y=321060
X810 440 2 452 1 INV1S $T=907680 316400 0 0 $X=907680 $Y=316020
X811 450 2 2248 1 INV1S $T=908300 245840 1 0 $X=908300 $Y=240420
X812 2321 2 2292 1 INV1S $T=908300 266000 1 0 $X=908300 $Y=260580
X813 384 2 397 1 INV1S $T=910160 316400 0 0 $X=910160 $Y=316020
X814 320 2 455 1 INV1S $T=911400 245840 0 0 $X=911400 $Y=245460
X815 2138 2 2179 1 INV1S $T=912020 276080 1 0 $X=912020 $Y=270660
X816 442 2 2147 1 INV1S $T=914500 286160 0 180 $X=913260 $Y=280740
X817 2356 2 2190 1 INV1S $T=916360 235760 0 0 $X=916360 $Y=235380
X818 430 2 2348 1 INV1S $T=916980 296240 1 0 $X=916980 $Y=290820
X819 2226 2 2357 1 INV1S $T=918220 276080 0 0 $X=918220 $Y=275700
X820 2264 2 2233 1 INV1S $T=923180 296240 0 180 $X=921940 $Y=290820
X821 2400 2 2380 1 INV1S $T=924420 235760 0 180 $X=923180 $Y=230340
X822 434 2 2189 1 INV1S $T=928760 276080 0 0 $X=928760 $Y=275700
X823 2240 2 2316 1 INV1S $T=928760 286160 0 0 $X=928760 $Y=285780
X824 2212 2 2429 1 INV1S $T=932480 276080 1 0 $X=932480 $Y=270660
X825 475 2 2128 1 INV1S $T=933720 286160 0 180 $X=932480 $Y=280740
X826 2191 2 351 1 INV1S $T=936200 276080 0 180 $X=934960 $Y=270660
X827 401 2 392 1 INV1S $T=934960 326480 1 0 $X=934960 $Y=321060
X828 321 2 2351 1 INV1S $T=936820 276080 0 0 $X=936820 $Y=275700
X829 2405 2 2418 1 INV1S $T=939920 235760 0 180 $X=938680 $Y=230340
X830 2265 2 2409 1 INV1S $T=939300 245840 1 0 $X=939300 $Y=240420
X831 2389 2 2374 1 INV1S $T=941780 255920 0 0 $X=941780 $Y=255540
X832 2419 2 2340 1 INV1S $T=943640 255920 1 0 $X=943640 $Y=250500
X833 2472 2 2230 1 INV1S $T=948600 276080 1 180 $X=947360 $Y=275700
X834 2455 2 2473 1 INV1S $T=947980 276080 1 0 $X=947980 $Y=270660
X835 333 2 2145 1 INV1S $T=949840 255920 1 0 $X=949840 $Y=250500
X836 2109 2 2368 1 INV1S $T=950460 245840 0 0 $X=950460 $Y=245460
X837 2480 2 2469 1 INV1S $T=954180 276080 0 0 $X=954180 $Y=275700
X838 423 2 2231 1 INV1S $T=954800 245840 1 0 $X=954800 $Y=240420
X839 376 2 2218 1 INV1S $T=954800 255920 1 0 $X=954800 $Y=250500
X840 416 2 2090 1 INV1S $T=957280 235760 1 180 $X=956040 $Y=235380
X841 2127 2 2366 1 INV1S $T=956040 276080 0 0 $X=956040 $Y=275700
X842 484 2 442 1 INV1S $T=956040 296240 1 0 $X=956040 $Y=290820
X843 412 2 2167 1 INV1S $T=959760 266000 1 0 $X=959760 $Y=260580
X844 339 2 2260 1 INV1S $T=961000 266000 1 180 $X=959760 $Y=265620
X845 431 2 2470 1 INV1S $T=960380 276080 1 0 $X=960380 $Y=270660
X846 2385 2 2345 1 INV1S $T=964100 245840 0 180 $X=962860 $Y=240420
X847 2494 2 493 1 INV1S $T=964100 266000 0 180 $X=962860 $Y=260580
X848 2420 2 2338 1 INV1S $T=965960 245840 0 180 $X=964720 $Y=240420
X849 498 2 502 1 INV1S $T=965960 326480 1 0 $X=965960 $Y=321060
X850 2493 2 2526 1 INV1S $T=969680 255920 0 0 $X=969680 $Y=255540
X851 2349 2 2529 1 INV1S $T=970300 286160 1 0 $X=970300 $Y=280740
X852 504 2 509 1 INV1S $T=970300 316400 0 0 $X=970300 $Y=316020
X853 411 2 2177 1 INV1S $T=972160 255920 0 0 $X=972160 $Y=255540
X854 2506 2 2525 1 INV1S $T=975880 296240 0 180 $X=974640 $Y=290820
X855 2538 2 2541 1 INV1S $T=976500 276080 0 0 $X=976500 $Y=275700
X856 2527 2 2561 1 INV1S $T=981460 286160 0 0 $X=981460 $Y=285780
X857 527 2 2566 1 INV1S $T=981460 316400 0 0 $X=981460 $Y=316020
X858 353 2 2495 1 INV1S $T=983320 255920 0 180 $X=982080 $Y=250500
X859 2540 2 2554 1 INV1S $T=983320 266000 0 0 $X=983320 $Y=265620
X860 534 2 2577 1 INV1S $T=987660 255920 0 180 $X=986420 $Y=250500
X861 2550 2 2581 1 INV1S $T=986420 286160 0 0 $X=986420 $Y=285780
X862 533 2 2582 1 INV1S $T=986420 306320 0 0 $X=986420 $Y=305940
X863 538 2 2580 1 INV1S $T=987660 316400 0 180 $X=986420 $Y=310980
X864 544 2 540 1 INV1S $T=989520 306320 0 180 $X=988280 $Y=300900
X865 532 2 536 1 INV1S $T=993860 245840 0 0 $X=993860 $Y=245460
X866 554 2 2584 1 INV1S $T=993860 266000 0 0 $X=993860 $Y=265620
X867 2615 2 2610 1 INV1S $T=995720 276080 1 180 $X=994480 $Y=275700
X868 560 2 539 1 INV1S $T=996960 316400 1 180 $X=995720 $Y=316020
X869 531 2 2618 1 INV1S $T=998200 266000 1 180 $X=996960 $Y=265620
X870 564 2 556 1 INV1S $T=998200 316400 0 0 $X=998200 $Y=316020
X871 2608 2 2642 1 INV1S $T=1000680 286160 0 0 $X=1000680 $Y=285780
X872 575 2 570 1 INV1S $T=1003160 316400 0 0 $X=1003160 $Y=316020
X873 579 2 2648 1 INV1S $T=1005640 266000 1 180 $X=1004400 $Y=265620
X874 2619 2 2665 1 INV1S $T=1008740 286160 0 0 $X=1008740 $Y=285780
X875 2624 2 577 1 INV1S $T=1008740 316400 0 0 $X=1008740 $Y=316020
X876 582 2 2635 1 INV1S $T=1011840 296240 0 180 $X=1010600 $Y=290820
X877 581 2 2667 1 INV1S $T=1013080 245840 0 180 $X=1011840 $Y=240420
X878 2682 2 2697 1 INV1S $T=1017420 296240 0 180 $X=1016180 $Y=290820
X879 574 2 2712 1 INV1S $T=1018660 245840 1 0 $X=1018660 $Y=240420
X880 2566 2 2710 1 INV1S $T=1018660 286160 1 0 $X=1018660 $Y=280740
X881 2656 2 2721 1 INV1S $T=1023620 286160 0 180 $X=1022380 $Y=280740
X882 2702 2 2628 1 INV1S $T=1023000 255920 1 0 $X=1023000 $Y=250500
X883 2662 2 608 1 INV1S $T=1024240 286160 0 0 $X=1024240 $Y=285780
X884 549 2 617 1 INV1S $T=1029200 276080 1 0 $X=1029200 $Y=270660
X885 2749 2 2735 1 INV1S $T=1032920 255920 0 180 $X=1031680 $Y=250500
X886 569 2 2728 1 INV1S $T=1032300 266000 0 0 $X=1032300 $Y=265620
X887 2739 2 621 1 INV1S $T=1032920 296240 1 0 $X=1032920 $Y=290820
X888 584 2 2752 1 INV1S $T=1034160 255920 1 0 $X=1034160 $Y=250500
X889 559 2 2633 1 INV1S $T=1036020 276080 0 0 $X=1036020 $Y=275700
X890 588 2 2600 1 INV1S $T=1037880 255920 1 180 $X=1036640 $Y=255540
X891 2755 2 2714 1 INV1S $T=1037880 266000 1 0 $X=1037880 $Y=260580
X892 2675 2 2779 1 INV1S $T=1043460 245840 0 0 $X=1043460 $Y=245460
X893 2713 2 2775 1 INV1S $T=1043460 286160 0 0 $X=1043460 $Y=285780
X894 2568 2 2688 1 INV1S $T=1045320 266000 0 0 $X=1045320 $Y=265620
X895 2777 2 604 1 INV1S $T=1049660 286160 1 180 $X=1048420 $Y=285780
X896 2793 2 2774 1 INV1S $T=1050280 245840 1 180 $X=1049040 $Y=245460
X897 507 2 2716 1 INV1S $T=1050280 286160 0 0 $X=1050280 $Y=285780
X898 578 2 585 1 INV1S $T=1052760 266000 1 0 $X=1052760 $Y=260580
X899 2738 2 2822 1 INV1S $T=1060820 266000 1 0 $X=1060820 $Y=260580
X900 519 2 594 1 INV1S $T=1063300 255920 0 180 $X=1062060 $Y=250500
X901 2809 2 2670 1 INV1S $T=1063300 296240 0 180 $X=1062060 $Y=290820
X902 2742 2 2825 1 INV1S $T=1062680 286160 0 0 $X=1062680 $Y=285780
X903 514 2 2802 1 INV1S $T=1063920 296240 1 0 $X=1063920 $Y=290820
X904 633 2 647 1 INV1S $T=1064540 296240 0 0 $X=1064540 $Y=295860
X905 545 2 619 1 INV1S $T=1066400 266000 1 180 $X=1065160 $Y=265620
X906 610 2 561 1 INV1S $T=1066400 306320 1 180 $X=1065160 $Y=305940
X907 623 2 597 1 INV1S $T=1068880 306320 1 180 $X=1067640 $Y=305940
X908 550 2 592 1 INV1S $T=1069500 286160 0 180 $X=1068260 $Y=280740
X909 511 2 602 1 INV1S $T=1070120 266000 0 0 $X=1070120 $Y=265620
X910 2774 2 2701 1 INV1S $T=1071360 276080 0 180 $X=1070120 $Y=270660
X911 2794 2 2761 1 INV1S $T=1071980 255920 0 180 $X=1070740 $Y=250500
X912 2835 2 2677 1 INV1S $T=1072600 276080 0 0 $X=1072600 $Y=275700
X913 676 2 2685 1 INV1S $T=1074460 306320 1 180 $X=1073220 $Y=305940
X914 2832 2 2843 1 INV1S $T=1073840 276080 1 0 $X=1073840 $Y=270660
X915 2845 2 2804 1 INV1S $T=1075080 255920 1 0 $X=1075080 $Y=250500
X916 2607 2 601 1 INV1S $T=1078800 306320 0 0 $X=1078800 $Y=305940
X917 2850 2 2856 1 INV1S $T=1080660 245840 0 0 $X=1080660 $Y=245460
X918 2797 2 572 1 INV1S $T=1083760 296240 0 180 $X=1082520 $Y=290820
X919 2599 2 599 1 INV1S $T=1085620 276080 1 0 $X=1085620 $Y=270660
X920 553 2 596 1 INV1S $T=1085620 306320 0 0 $X=1085620 $Y=305940
X921 2759 2 2829 1 INV1S $T=1088720 266000 1 180 $X=1087480 $Y=265620
X922 2764 2 605 1 INV1S $T=1089960 306320 1 180 $X=1088720 $Y=305940
X923 2693 2 2727 1 INV1S $T=1092440 286160 1 180 $X=1091200 $Y=285780
X924 120 1192 1186 2 1 1185 XOR3 $T=537540 316400 1 180 $X=526380 $Y=316020
X925 1208 1201 1188 2 1 1187 XOR3 $T=540020 255920 1 180 $X=528860 $Y=255540
X926 1212 1190 1194 2 1 1189 XOR3 $T=546220 286160 0 180 $X=535060 $Y=280740
X927 1223 1228 1210 2 1 1200 XOR3 $T=549940 245840 0 180 $X=538780 $Y=240420
X928 1264 1265 1243 2 1 1197 XOR3 $T=561720 225680 0 180 $X=550560 $Y=220260
X929 1328 1326 1312 2 1 1308 XOR3 $T=581560 225680 0 180 $X=570400 $Y=220260
X930 150 1341 154 2 1 158 XOR3 $T=580940 326480 1 0 $X=580940 $Y=321060
X931 1424 1426 1433 2 1 180 XOR3 $T=608220 316400 0 0 $X=608220 $Y=316020
X932 182 1469 1447 2 1 175 XOR3 $T=628060 326480 0 180 $X=616900 $Y=321060
X933 195 1521 1508 2 1 193 XOR3 $T=653480 326480 0 180 $X=642320 $Y=321060
X934 1588 1578 1566 2 1 1563 XOR3 $T=677660 255920 0 180 $X=666500 $Y=250500
X935 1583 1580 1568 2 1 1551 XOR3 $T=678900 235760 0 180 $X=667740 $Y=230340
X936 210 211 214 2 1 216 XOR3 $T=667740 326480 1 0 $X=667740 $Y=321060
X937 1602 1594 1575 2 1 1572 XOR3 $T=684480 296240 1 180 $X=673320 $Y=295860
X938 1595 1600 1584 2 1 1571 XOR3 $T=687580 316400 0 180 $X=676420 $Y=310980
X939 1598 1605 1586 2 1 1554 XOR3 $T=688200 225680 0 180 $X=677040 $Y=220260
X940 1574 1579 1582 2 1 1577 XOR3 $T=690680 266000 1 180 $X=679520 $Y=265620
X941 1610 1612 1590 2 1 1573 XOR3 $T=692540 286160 0 180 $X=681380 $Y=280740
X942 224 1614 1596 2 1 218 XOR3 $T=693160 326480 0 180 $X=682000 $Y=321060
X943 1617 1626 1607 2 1 1574 XOR3 $T=697500 276080 0 180 $X=686340 $Y=270660
X944 1629 1624 1606 2 1 1588 XOR3 $T=700600 255920 0 180 $X=689440 $Y=250500
X945 1652 1642 1621 2 1 1618 XOR3 $T=703700 225680 0 180 $X=692540 $Y=220260
X946 1635 1627 1622 2 1 1610 XOR3 $T=703700 286160 1 180 $X=692540 $Y=285780
X947 1636 1631 1623 2 1 1595 XOR3 $T=703700 316400 0 180 $X=692540 $Y=310980
X948 1630 1619 1625 2 1 1602 XOR3 $T=704320 296240 1 180 $X=693160 $Y=295860
X949 1754 1756 1741 2 1 1736 XOR3 $T=739660 266000 0 180 $X=728500 $Y=260580
X950 1734 1712 1744 2 1 1760 XOR3 $T=729120 235760 0 0 $X=729120 $Y=235380
X951 1768 1763 1749 2 1 1600 XOR3 $T=744620 306320 0 180 $X=733460 $Y=300900
X952 1785 1788 1772 2 1 1614 XOR3 $T=753920 316400 1 180 $X=742760 $Y=316020
X953 1736 1775 1791 2 1 1796 XOR3 $T=743380 266000 1 0 $X=743380 $Y=260580
X954 1762 1776 1769 2 1 1815 XOR3 $T=748340 235760 0 0 $X=748340 $Y=235380
X955 1946 1940 1915 2 1 1776 XOR3 $T=805380 245840 0 180 $X=794220 $Y=240420
X956 1936 1934 1917 2 1 1775 XOR3 $T=807860 266000 0 180 $X=796700 $Y=260580
X957 1223 1210 1228 1 2 1205 MAO222 $T=546220 245840 1 180 $X=541260 $Y=245460
X958 1235 1217 1240 1 2 132 MAO222 $T=554280 326480 1 0 $X=554280 $Y=321060
X959 1316 141 1321 1 2 1273 MAO222 $T=577840 245840 1 180 $X=572880 $Y=245460
X960 1328 1326 1312 1 2 1243 MAO222 $T=579080 225680 1 180 $X=574120 $Y=225300
X961 1344 1362 1348 1 2 1313 MAO222 $T=590240 255920 1 180 $X=585280 $Y=255540
X962 1395 1392 1401 1 2 1374 MAO222 $T=600160 235760 1 180 $X=595200 $Y=235380
X963 1377 1397 1374 1 2 1362 MAO222 $T=596440 245840 0 0 $X=596440 $Y=245460
X964 1424 1433 1426 1 2 1447 MAO222 $T=611940 316400 1 0 $X=611940 $Y=310980
X965 182 1447 1469 1 2 1470 MAO222 $T=621240 316400 0 0 $X=621240 $Y=316020
X966 186 1470 1481 1 2 1508 MAO222 $T=639220 316400 1 0 $X=639220 $Y=310980
X967 195 1508 1521 1 2 1530 MAO222 $T=645420 316400 1 0 $X=645420 $Y=310980
X968 1538 1530 1532 1 2 1546 MAO222 $T=656580 306320 0 0 $X=656580 $Y=305940
X969 1560 1546 1558 1 2 214 MAO222 $T=670840 316400 1 0 $X=670840 $Y=310980
X970 1583 1568 1580 1 2 1566 MAO222 $T=678900 245840 1 180 $X=673940 $Y=245460
X971 1629 1606 1624 1 2 1607 MAO222 $T=698120 266000 1 180 $X=693160 $Y=265620
X972 1626 1607 1617 1 2 1622 MAO222 $T=693780 276080 0 0 $X=693780 $Y=275700
X973 1630 1625 1619 1 2 1623 MAO222 $T=694400 306320 0 0 $X=694400 $Y=305940
X974 1635 1622 1627 1 2 1625 MAO222 $T=700600 296240 0 180 $X=695640 $Y=290820
X975 1636 1623 1631 1 2 227 MAO222 $T=697500 316400 0 0 $X=697500 $Y=316020
X976 1648 1664 1654 1 2 1628 MAO222 $T=711140 235760 1 180 $X=706180 $Y=235380
X977 1652 1621 1642 1 2 1586 MAO222 $T=713620 225680 0 180 $X=708660 $Y=220260
X978 1754 1741 1756 1 2 1750 MAO222 $T=740280 255920 1 180 $X=735320 $Y=255540
X979 1760 1758 1773 1 2 1731 MAO222 $T=740900 225680 0 180 $X=735940 $Y=220260
X980 1736 1775 1791 1 2 1769 MAO222 $T=750820 255920 1 180 $X=745860 $Y=255540
X981 1886 1875 1891 1 2 1837 MAO222 $T=785540 225680 1 180 $X=780580 $Y=225300
X982 1283 1278 1263 2 1 XOR2HS $T=562340 266000 0 180 $X=556760 $Y=260580
X983 1270 1276 1272 2 1 XOR2HS $T=562960 286160 0 0 $X=562960 $Y=285780
X984 1310 1309 1268 2 1 XOR2HS $T=572260 296240 1 180 $X=566680 $Y=295860
X985 1287 1306 1311 2 1 XOR2HS $T=567920 276080 0 0 $X=567920 $Y=275700
X986 1307 1300 1294 2 1 XOR2HS $T=569160 266000 1 0 $X=569160 $Y=260580
X987 1302 1305 1289 2 1 XOR2HS $T=569160 316400 1 0 $X=569160 $Y=310980
X988 1319 1320 1282 2 1 XOR2HS $T=575360 306320 1 180 $X=569780 $Y=305940
X989 1297 1298 1290 2 1 XOR2HS $T=569780 316400 0 0 $X=569780 $Y=316020
X990 1325 1318 1301 2 1 XOR2HS $T=577220 296240 0 180 $X=571640 $Y=290820
X991 1333 1332 1323 2 1 XOR2HS $T=580320 276080 1 180 $X=574740 $Y=275700
X992 1345 1340 1331 2 1 XOR2HS $T=584040 306320 1 180 $X=578460 $Y=305940
X993 149 1327 1356 2 1 XOR2HS $T=582180 235760 0 0 $X=582180 $Y=235380
X994 1330 1361 1324 2 1 XOR2HS $T=589000 266000 1 180 $X=583420 $Y=265620
X995 1364 1363 1355 2 1 XOR2HS $T=589620 296240 1 180 $X=584040 $Y=295860
X996 1356 1352 1375 2 1 XOR2HS $T=588380 235760 0 0 $X=588380 $Y=235380
X997 1368 1371 1351 2 1 XOR2HS $T=589000 276080 0 0 $X=589000 $Y=275700
X998 1384 1380 1372 2 1 XOR2HS $T=595820 266000 1 180 $X=590240 $Y=265620
X999 1385 1383 1358 2 1 XOR2HS $T=595820 306320 1 180 $X=590240 $Y=305940
X1000 1387 1347 1360 2 1 XOR2HS $T=597060 286160 1 180 $X=591480 $Y=285780
X1001 1388 1378 1376 2 1 XOR2HS $T=597060 296240 0 180 $X=591480 $Y=290820
X1002 1381 1379 1386 2 1 XOR2HS $T=600780 255920 1 180 $X=595200 $Y=255540
X1003 168 167 1405 2 1 XOR2HS $T=607600 326480 0 180 $X=602020 $Y=321060
X1004 1422 1421 1415 2 1 XOR2HS $T=609460 245840 1 180 $X=603880 $Y=245460
X1005 1411 1407 1352 2 1 XOR2HS $T=605120 245840 1 0 $X=605120 $Y=240420
X1006 1427 1398 1416 2 1 XOR2HS $T=611320 266000 1 0 $X=611320 $Y=260580
X1007 1485 1440 1475 2 1 XOR2HS $T=633640 255920 0 180 $X=628060 $Y=250500
X1008 1496 1493 1483 2 1 XOR2HS $T=637360 235760 1 180 $X=631780 $Y=235380
X1009 1504 1505 1501 2 1 XOR2HS $T=639840 235760 0 0 $X=639840 $Y=235380
X1010 1512 1509 1519 2 1 XOR2HS $T=644800 245840 1 0 $X=644800 $Y=240420
X1011 1531 1534 1529 2 1 XOR2HS $T=659060 235760 1 180 $X=653480 $Y=235380
X1012 203 204 1535 2 1 XOR2HS $T=656580 326480 1 0 $X=656580 $Y=321060
X1013 1556 1553 1543 2 1 XOR2HS $T=664640 296240 0 180 $X=659060 $Y=290820
X1014 205 206 1557 2 1 XOR2HS $T=660300 316400 0 0 $X=660300 $Y=316020
X1015 1537 1539 1552 2 1 XOR2HS $T=662160 245840 0 0 $X=662160 $Y=245460
X1016 1555 1559 1565 2 1 XOR2HS $T=664020 276080 0 0 $X=664020 $Y=275700
X1017 1548 1547 1567 2 1 XOR2HS $T=664640 266000 0 0 $X=664640 $Y=265620
X1018 1561 1564 1569 2 1 XOR2HS $T=665880 296240 1 0 $X=665880 $Y=290820
X1019 1549 1562 1570 2 1 XOR2HS $T=667120 286160 1 0 $X=667120 $Y=280740
X1020 1592 1591 1583 2 1 XOR2HS $T=683240 245840 0 180 $X=677660 $Y=240420
X1021 1601 1599 1591 2 1 XOR2HS $T=686340 255920 0 180 $X=680760 $Y=250500
X1022 1647 1660 1634 2 1 XOR2HS $T=707420 266000 0 180 $X=701840 $Y=260580
X1023 1653 1663 1633 2 1 XOR2HS $T=709900 255920 0 180 $X=704320 $Y=250500
X1024 1655 1651 1639 2 1 XOR2HS $T=704320 276080 0 0 $X=704320 $Y=275700
X1025 1667 1662 1640 2 1 XOR2HS $T=710520 286160 0 180 $X=704940 $Y=280740
X1026 1669 1666 1659 2 1 XOR2HS $T=710520 326480 0 180 $X=704940 $Y=321060
X1027 1668 1665 1645 2 1 XOR2HS $T=711760 306320 1 180 $X=706180 $Y=305940
X1028 1658 1657 1649 2 1 XOR2HS $T=706800 296240 1 0 $X=706800 $Y=290820
X1029 1681 1679 1671 2 1 XOR2HS $T=714860 266000 1 180 $X=709280 $Y=265620
X1030 1672 1674 1680 2 1 XOR2HS $T=714860 255920 0 0 $X=714860 $Y=255540
X1031 1718 1720 1728 2 1 XOR2HS $T=723540 266000 0 0 $X=723540 $Y=265620
X1032 1715 1698 1707 2 1 XOR2HS $T=725400 255920 0 0 $X=725400 $Y=255540
X1033 1755 1759 1765 2 1 XOR2HS $T=738420 276080 1 0 $X=738420 $Y=270660
X1034 1770 1767 1612 2 1 XOR2HS $T=744620 296240 0 180 $X=739040 $Y=290820
X1035 1765 1781 1777 2 1 XOR2HS $T=750200 276080 0 180 $X=744620 $Y=270660
X1036 1784 1795 1770 2 1 XOR2HS $T=761360 296240 0 180 $X=755780 $Y=290820
X1037 261 260 1797 2 1 XOR2HS $T=761360 316400 1 180 $X=755780 $Y=316020
X1038 1807 1827 1790 2 1 XOR2HS $T=764460 316400 0 180 $X=758880 $Y=310980
X1039 1812 1814 1800 2 1 XOR2HS $T=759500 296240 0 0 $X=759500 $Y=295860
X1040 1824 1821 1834 2 1 XOR2HS $T=763220 286160 0 0 $X=763220 $Y=285780
X1041 1848 1839 1838 2 1 XOR2HS $T=771900 286160 1 0 $X=771900 $Y=280740
X1042 1869 1866 1856 2 1 XOR2HS $T=778720 255920 1 180 $X=773140 $Y=255540
X1043 1861 1867 1841 2 1 XOR2HS $T=775620 266000 1 0 $X=775620 $Y=260580
X1044 1857 1855 1847 2 1 XOR2HS $T=777480 276080 0 0 $X=777480 $Y=275700
X1045 1849 1879 1860 2 1 XOR2HS $T=783680 245840 0 180 $X=778100 $Y=240420
X1046 1887 1890 1897 2 1 XOR2HS $T=783680 276080 1 0 $X=783680 $Y=270660
X1047 1905 1919 1781 2 1 XOR2HS $T=797940 266000 1 180 $X=792360 $Y=265620
X1048 1933 1932 1920 2 1 XOR2HS $T=801040 296240 1 180 $X=795460 $Y=295860
X1049 1938 1937 1930 2 1 XOR2HS $T=803520 245840 1 180 $X=797940 $Y=245460
X1050 1903 1944 1773 2 1 XOR2HS $T=806000 225680 0 180 $X=800420 $Y=220260
X1051 1909 1922 1944 2 1 XOR2HS $T=800420 225680 0 0 $X=800420 $Y=225300
X1052 286 287 1921 2 1 XOR2HS $T=800420 326480 1 0 $X=800420 $Y=321060
X1053 1935 1941 1924 2 1 XOR2HS $T=801660 306320 0 0 $X=801660 $Y=305940
X1054 1945 1939 1925 2 1 XOR2HS $T=803520 286160 0 0 $X=803520 $Y=285780
X1055 1942 1943 1923 2 1 XOR2HS $T=804760 276080 0 0 $X=804760 $Y=275700
X1056 1957 1955 1947 2 1 XOR2HS $T=810960 276080 0 180 $X=805380 $Y=270660
X1057 1974 1985 1981 2 1 XOR2HS $T=823360 225680 1 180 $X=817780 $Y=225300
X1058 1999 2005 1982 2 1 XOR2HS $T=827700 235760 1 180 $X=822120 $Y=235380
X1059 1983 2006 1997 2 1 XOR2HS $T=832660 266000 0 180 $X=827080 $Y=260580
X1060 2016 2021 2009 2 1 XOR2HS $T=832660 255920 0 0 $X=832660 $Y=255540
X1061 1601 1603 1599 2 1 ND2S $T=684480 245840 1 180 $X=682620 $Y=245460
X1062 302 1988 1980 2 1 ND2S $T=820880 316400 1 180 $X=819020 $Y=316020
X1063 2109 2154 2147 2 1 ND2S $T=854980 266000 1 0 $X=854980 $Y=260580
X1064 2353 2303 2147 2 1 ND2S $T=914500 255920 1 180 $X=912640 $Y=255540
X1065 415 2333 401 2 1 ND2S $T=912640 306320 0 0 $X=912640 $Y=305940
X1066 2382 2439 2109 2 1 ND2S $T=954180 255920 1 180 $X=952320 $Y=255540
X1067 506 507 504 2 1 ND2S $T=970920 326480 0 180 $X=969060 $Y=321060
X1068 515 514 504 2 1 ND2S $T=974640 316400 1 180 $X=972780 $Y=316020
X1069 505 512 504 2 1 ND2S $T=974640 326480 0 180 $X=972780 $Y=321060
X1070 2557 2572 2540 2 1 ND2S $T=984560 266000 0 180 $X=982700 $Y=260580
X1071 2540 2625 569 2 1 ND2S $T=998820 276080 1 0 $X=998820 $Y=270660
X1072 599 2594 2540 2 1 ND2S $T=1042840 276080 1 0 $X=1042840 $Y=270660
X1073 2568 643 514 2 1 ND2S $T=1047800 316400 0 0 $X=1047800 $Y=316020
X1074 2540 2778 585 2 1 ND2S $T=1052760 316400 1 0 $X=1052760 $Y=310980
X1075 655 2818 2615 2 1 ND2S $T=1080660 266000 1 180 $X=1078800 $Y=265620
X1076 886 854 896 1 2 ND2 $T=350920 316400 0 0 $X=350920 $Y=316020
X1077 903 840 896 1 2 ND2 $T=354640 326480 0 180 $X=352780 $Y=321060
X1078 901 841 896 1 2 ND2 $T=355260 316400 1 180 $X=353400 $Y=316020
X1079 37 889 896 1 2 ND2 $T=359600 326480 0 180 $X=357740 $Y=321060
X1080 903 932 36 1 2 ND2 $T=375100 316400 0 0 $X=375100 $Y=316020
X1081 901 44 36 1 2 ND2 $T=381920 326480 1 0 $X=381920 $Y=321060
X1082 975 973 886 1 2 ND2 $T=403620 316400 0 0 $X=403620 $Y=316020
X1083 975 1030 37 1 2 ND2 $T=429660 326480 0 180 $X=427800 $Y=321060
X1084 975 1018 903 1 2 ND2 $T=429660 316400 1 0 $X=429660 $Y=310980
X1085 1056 972 69 1 2 ND2 $T=438340 306320 0 0 $X=438340 $Y=305940
X1086 1040 851 1056 1 2 ND2 $T=439580 286160 0 0 $X=439580 $Y=285780
X1087 1040 845 70 1 2 ND2 $T=440200 296240 0 0 $X=440200 $Y=295860
X1088 70 967 69 1 2 ND2 $T=443300 306320 0 0 $X=443300 $Y=305940
X1089 1067 847 74 1 2 ND2 $T=447020 306320 0 0 $X=447020 $Y=305940
X1090 1067 1064 79 1 2 ND2 $T=450120 306320 1 0 $X=450120 $Y=300900
X1091 74 849 77 1 2 ND2 $T=450120 316400 0 0 $X=450120 $Y=316020
X1092 1046 1074 37 1 2 ND2 $T=453840 316400 0 180 $X=451980 $Y=310980
X1093 79 1001 77 1 2 ND2 $T=458180 306320 1 180 $X=456320 $Y=305940
X1094 1046 1086 901 1 2 ND2 $T=460660 316400 1 0 $X=460660 $Y=310980
X1095 1198 1191 1190 1 2 ND2 $T=534440 286160 1 180 $X=532580 $Y=285780
X1096 1199 1193 1192 1 2 ND2 $T=536920 306320 1 180 $X=535060 $Y=305940
X1097 1198 1195 1212 1 2 ND2 $T=536920 286160 0 0 $X=536920 $Y=285780
X1098 1199 1203 120 1 2 ND2 $T=536920 316400 1 0 $X=536920 $Y=310980
X1099 126 1207 1206 1 2 ND2 $T=540640 316400 0 180 $X=538780 $Y=310980
X1100 1192 1218 120 1 2 ND2 $T=541260 316400 1 180 $X=539400 $Y=316020
X1101 1201 1211 1208 1 2 ND2 $T=542500 255920 1 180 $X=540640 $Y=255540
X1102 1205 1219 1201 1 2 ND2 $T=544360 255920 1 180 $X=542500 $Y=255540
X1103 1205 1225 1208 1 2 ND2 $T=546220 255920 1 180 $X=544360 $Y=255540
X1104 1224 1209 1213 1 2 ND2 $T=544980 296240 1 0 $X=544980 $Y=290820
X1105 1245 1230 1247 1 2 ND2 $T=552420 296240 1 0 $X=552420 $Y=290820
X1106 1244 1234 1253 1 2 ND2 $T=554280 286160 1 0 $X=554280 $Y=280740
X1107 1253 1229 1261 1 2 ND2 $T=554280 286160 0 0 $X=554280 $Y=285780
X1108 1258 1256 1262 1 2 ND2 $T=555520 316400 0 0 $X=555520 $Y=316020
X1109 1237 1257 1245 1 2 ND2 $T=556760 296240 0 0 $X=556760 $Y=295860
X1110 1262 1251 1255 1 2 ND2 $T=557380 316400 0 0 $X=557380 $Y=316020
X1111 1243 1260 1264 1 2 ND2 $T=559860 225680 1 180 $X=558000 $Y=225300
X1112 1265 1254 1264 1 2 ND2 $T=558000 235760 0 0 $X=558000 $Y=235380
X1113 1268 1269 133 1 2 ND2 $T=558620 296240 0 0 $X=558620 $Y=295860
X1114 1273 1271 1259 1 2 ND2 $T=561100 255920 0 180 $X=559240 $Y=250500
X1115 1248 1249 129 1 2 ND2 $T=561720 255920 1 180 $X=559860 $Y=255540
X1116 1279 1285 134 1 2 ND2 $T=560480 296240 0 0 $X=560480 $Y=295860
X1117 1284 1280 1286 1 2 ND2 $T=561720 276080 1 0 $X=561720 $Y=270660
X1118 1294 1299 1266 1 2 ND2 $T=563580 276080 1 0 $X=563580 $Y=270660
X1119 1265 1250 1243 1 2 ND2 $T=566680 225680 0 0 $X=566680 $Y=225300
X1120 1299 1245 1280 1 2 ND2 $T=567300 276080 1 0 $X=567300 $Y=270660
X1121 1315 1317 1286 1 2 ND2 $T=572880 266000 0 0 $X=572880 $Y=265620
X1122 1323 1329 1266 1 2 ND2 $T=574740 266000 0 0 $X=574740 $Y=265620
X1123 1350 1343 134 1 2 ND2 $T=584040 296240 0 180 $X=582180 $Y=290820
X1124 1355 1354 133 1 2 ND2 $T=589620 296240 0 180 $X=587760 $Y=290820
X1125 1370 1396 1402 1 2 ND2 $T=598300 316400 0 0 $X=598300 $Y=316020
X1126 1370 1404 1400 1 2 ND2 $T=600780 316400 0 180 $X=598920 $Y=310980
X1127 1400 1417 1402 1 2 ND2 $T=605740 316400 0 180 $X=603880 $Y=310980
X1128 1561 1553 1564 1 2 ND2 $T=665260 286160 0 0 $X=665260 $Y=285780
X1129 1579 1576 1574 1 2 ND2 $T=676420 276080 0 180 $X=674560 $Y=270660
X1130 1600 1597 1595 1 2 ND2 $T=685100 316400 1 180 $X=683240 $Y=316020
X1131 1671 1685 1632 1 2 ND2 $T=713620 266000 0 180 $X=711760 $Y=260580
X1132 1685 1712 1701 1 2 ND2 $T=721060 266000 1 180 $X=719200 $Y=265620
X1133 1711 1700 1678 1 2 ND2 $T=721680 245840 0 180 $X=719820 $Y=240420
X1134 1678 1703 1682 1 2 ND2 $T=721680 245840 0 0 $X=721680 $Y=245460
X1135 1711 1709 1682 1 2 ND2 $T=725400 245840 0 180 $X=723540 $Y=240420
X1136 1723 1697 1735 1 2 ND2 $T=725400 225680 1 0 $X=725400 $Y=220260
X1137 1731 1705 1723 1 2 ND2 $T=727260 225680 1 180 $X=725400 $Y=225300
X1138 1731 1722 1735 1 2 ND2 $T=728500 225680 1 0 $X=728500 $Y=220260
X1139 1744 1738 1734 1 2 ND2 $T=730980 245840 1 180 $X=729120 $Y=245460
X1140 1725 1732 1710 1 2 ND2 $T=729120 286160 1 0 $X=729120 $Y=280740
X1141 1739 1696 250 1 2 ND2 $T=732220 306320 0 0 $X=732220 $Y=305940
X1142 1744 1745 1712 1 2 ND2 $T=733460 245840 1 0 $X=733460 $Y=240420
X1143 1712 1727 1734 1 2 ND2 $T=737180 245840 1 0 $X=737180 $Y=240420
X1144 1776 1779 1769 1 2 ND2 $T=745240 245840 1 180 $X=743380 $Y=245460
X1145 1769 1778 1762 1 2 ND2 $T=745860 235760 1 180 $X=744000 $Y=235380
X1146 1776 1774 1762 1 2 ND2 $T=745860 245840 0 180 $X=744000 $Y=240420
X1147 1767 1783 1795 1 2 ND2 $T=753300 296240 1 0 $X=753300 $Y=290820
X1148 1784 1786 1795 1 2 ND2 $T=754540 286160 0 0 $X=754540 $Y=285780
X1149 1808 1804 1799 1 2 ND2 $T=758880 245840 0 180 $X=757020 $Y=240420
X1150 1794 1806 1811 1 2 ND2 $T=757020 286160 0 0 $X=757020 $Y=285780
X1151 1798 1810 1830 1 2 ND2 $T=757640 266000 1 0 $X=757640 $Y=260580
X1152 1794 1818 1829 1 2 ND2 $T=761360 286160 1 0 $X=761360 $Y=280740
X1153 1799 1832 1823 1 2 ND2 $T=764460 245840 0 180 $X=762600 $Y=240420
X1154 1811 1802 1829 1 2 ND2 $T=764460 276080 0 0 $X=764460 $Y=275700
X1155 1828 1820 1830 1 2 ND2 $T=766320 266000 0 0 $X=766320 $Y=265620
X1156 1888 1898 155 1 2 ND2 $T=784920 296240 0 180 $X=783060 $Y=290820
X1157 1880 1889 1895 1 2 ND2 $T=788640 245840 1 0 $X=788640 $Y=240420
X1158 1897 1916 1836 1 2 ND2 $T=792360 276080 0 180 $X=790500 $Y=270660
X1159 2000 1998 285 1 2 ND2 $T=823980 255920 0 180 $X=822120 $Y=250500
X1160 1997 1992 164 1 2 ND2 $T=822120 266000 1 0 $X=822120 $Y=260580
X1161 2025 2015 2020 1 2 ND2 $T=835140 316400 0 180 $X=833280 $Y=310980
X1162 323 308 2093 1 2 ND2 $T=845680 326480 1 0 $X=845680 $Y=321060
X1163 320 2078 333 1 2 ND2 $T=846300 245840 0 0 $X=846300 $Y=245460
X1164 2106 2084 2109 1 2 ND2 $T=850020 245840 0 0 $X=850020 $Y=245460
X1165 318 2150 360 1 2 ND2 $T=854980 255920 0 0 $X=854980 $Y=255540
X1166 370 2079 332 1 2 ND2 $T=859940 245840 1 180 $X=858080 $Y=245460
X1167 2161 311 2169 1 2 ND2 $T=862420 316400 1 0 $X=862420 $Y=310980
X1168 2203 2193 320 1 2 ND2 $T=872340 255920 0 180 $X=870480 $Y=250500
X1169 2098 2201 2214 1 2 ND2 $T=873580 245840 0 0 $X=873580 $Y=245460
X1170 2203 2178 412 1 2 ND2 $T=877300 266000 0 0 $X=877300 $Y=265620
X1171 418 2234 421 1 2 ND2 $T=881020 316400 0 0 $X=881020 $Y=316020
X1172 2242 2184 2248 1 2 ND2 $T=882260 245840 1 0 $X=882260 $Y=240420
X1173 2260 2181 320 1 2 ND2 $T=887220 255920 1 0 $X=887220 $Y=250500
X1174 388 2272 392 1 2 ND2 $T=891560 316400 1 0 $X=891560 $Y=310980
X1175 2119 2294 437 1 2 ND2 $T=897760 276080 0 0 $X=897760 $Y=275700
X1176 408 2306 444 1 2 ND2 $T=899000 255920 0 0 $X=899000 $Y=255540
X1177 2095 2308 437 1 2 ND2 $T=901480 276080 0 180 $X=899620 $Y=270660
X1178 320 2286 2180 1 2 ND2 $T=900240 296240 1 0 $X=900240 $Y=290820
X1179 2179 2307 2294 1 2 ND2 $T=901480 276080 0 0 $X=901480 $Y=275700
X1180 412 2315 321 1 2 ND2 $T=903340 296240 0 0 $X=903340 $Y=295860
X1181 2223 2325 2308 1 2 ND2 $T=906440 276080 1 180 $X=904580 $Y=275700
X1182 423 449 321 1 2 ND2 $T=910160 296240 0 0 $X=910160 $Y=295860
X1183 434 2371 412 1 2 ND2 $T=920080 286160 0 0 $X=920080 $Y=285780
X1184 2405 2364 2407 1 2 ND2 $T=926900 225680 1 0 $X=926900 $Y=220260
X1185 417 2392 405 1 2 ND2 $T=928760 306320 0 180 $X=926900 $Y=300900
X1186 2203 477 321 1 2 ND2 $T=934960 286160 1 0 $X=934960 $Y=280740
X1187 2417 2441 393 1 2 ND2 $T=938060 306320 0 0 $X=938060 $Y=305940
X1188 2321 2452 408 1 2 ND2 $T=942400 266000 1 180 $X=940540 $Y=265620
X1189 2324 2450 2461 1 2 ND2 $T=943640 266000 1 0 $X=943640 $Y=260580
X1190 2420 485 353 1 2 ND2 $T=949220 296240 1 0 $X=949220 $Y=290820
X1191 2485 2293 333 1 2 ND2 $T=954180 255920 0 180 $X=952320 $Y=250500
X1192 2494 2466 2349 1 2 ND2 $T=957280 255920 1 0 $X=957280 $Y=250500
X1193 2260 2498 333 1 2 ND2 $T=959140 286160 1 0 $X=959140 $Y=280740
X1194 2494 2261 412 1 2 ND2 $T=964100 255920 1 180 $X=962240 $Y=255540
X1195 2508 2491 416 1 2 ND2 $T=962240 286160 1 0 $X=962240 $Y=280740
X1196 2251 2431 434 1 2 ND2 $T=964720 276080 0 0 $X=964720 $Y=275700
X1197 505 2527 503 1 2 ND2 $T=970920 316400 0 180 $X=969060 $Y=310980
X1198 503 513 506 1 2 ND2 $T=972780 316400 0 180 $X=970920 $Y=310980
X1199 506 511 510 1 2 ND2 $T=974640 306320 1 180 $X=972780 $Y=305940
X1200 505 518 510 1 2 ND2 $T=976500 316400 0 180 $X=974640 $Y=310980
X1201 506 519 517 1 2 ND2 $T=976500 316400 1 180 $X=974640 $Y=316020
X1202 515 2540 510 1 2 ND2 $T=978360 316400 0 180 $X=976500 $Y=310980
X1203 2557 2551 514 1 2 ND2 $T=980840 316400 1 180 $X=978980 $Y=316020
X1204 515 2568 517 1 2 ND2 $T=981460 306320 1 180 $X=979600 $Y=305940
X1205 505 2550 517 1 2 ND2 $T=981460 316400 0 180 $X=979600 $Y=310980
X1206 524 2573 532 1 2 ND2 $T=985180 286160 0 180 $X=983320 $Y=280740
X1207 2578 2576 2584 1 2 ND2 $T=986420 266000 0 0 $X=986420 $Y=265620
X1208 2608 2612 512 1 2 ND2 $T=996340 296240 1 180 $X=994480 $Y=295860
X1209 559 2579 564 1 2 ND2 $T=996340 276080 0 0 $X=996340 $Y=275700
X1210 2615 2588 518 1 2 ND2 $T=996960 286160 0 0 $X=996960 $Y=285780
X1211 2571 2630 2634 1 2 ND2 $T=1001300 296240 0 0 $X=1001300 $Y=295860
X1212 2656 2647 550 1 2 ND2 $T=1005640 306320 1 0 $X=1005640 $Y=300900
X1213 579 2623 2615 1 2 ND2 $T=1007500 276080 1 0 $X=1007500 $Y=270660
X1214 2655 2730 518 1 2 ND2 $T=1026100 286160 0 0 $X=1026100 $Y=285780
X1215 512 2734 519 1 2 ND2 $T=1027340 276080 0 0 $X=1027340 $Y=275700
X1216 584 2736 2751 1 2 ND2 $T=1032300 255920 0 0 $X=1032300 $Y=255540
X1217 2600 624 502 1 2 ND2 $T=1036020 306320 0 180 $X=1034160 $Y=300900
X1218 601 2765 624 1 2 ND2 $T=1039740 316400 1 0 $X=1039740 $Y=310980
X1219 2633 627 502 1 2 ND2 $T=1040980 296240 0 0 $X=1040980 $Y=295860
X1220 2557 2808 2550 1 2 ND2 $T=1056480 306320 0 180 $X=1054620 $Y=300900
X1221 2699 2810 617 1 2 ND2 $T=1057720 266000 1 0 $X=1057720 $Y=260580
X1222 2550 660 514 1 2 ND2 $T=1065780 316400 1 180 $X=1063920 $Y=316020
X1223 2701 668 2545 1 2 ND2 $T=1069500 316400 0 180 $X=1067640 $Y=310980
X1224 2797 2836 2619 1 2 ND2 $T=1075080 255920 0 0 $X=1075080 $Y=255540
X1225 2846 2768 569 1 2 ND2 $T=1077560 276080 1 0 $X=1077560 $Y=270660
X1226 550 687 2550 1 2 ND2 $T=1081900 286160 0 180 $X=1080040 $Y=280740
X1227 2797 2770 2550 1 2 ND2 $T=1083760 286160 0 0 $X=1083760 $Y=285780
X1228 599 2864 569 1 2 ND2 $T=1086860 296240 0 180 $X=1085000 $Y=290820
X1229 693 2863 696 1 2 ND2 $T=1088100 326480 0 180 $X=1086240 $Y=321060
X1230 2867 2862 513 1 2 ND2 $T=1090580 286160 1 180 $X=1088720 $Y=285780
X1231 1191 1199 1195 1196 1 2 ND3P $T=532580 296240 1 0 $X=532580 $Y=290820
X1232 1193 128 1203 1218 1 2 ND3P $T=548080 316400 1 180 $X=543120 $Y=316020
X1233 1225 1198 1219 1211 1 2 ND3P $T=551180 255920 1 180 $X=546220 $Y=255540
X1234 1234 1227 1242 1229 1 2 ND3P $T=552420 286160 1 180 $X=547460 $Y=285780
X1235 1220 130 1231 1207 1 2 ND3P $T=554280 316400 0 180 $X=549320 $Y=310980
X1236 1254 1210 1260 1250 1 2 ND3P $T=557380 235760 0 180 $X=552420 $Y=230340
X1237 1396 1433 1404 1417 1 2 ND3P $T=606360 316400 1 0 $X=606360 $Y=310980
X1238 1585 1590 1589 1576 1 2 ND3P $T=686340 276080 0 180 $X=681380 $Y=270660
X1239 1609 1606 1615 1603 1 2 ND3P $T=691300 245840 1 180 $X=686340 $Y=245460
X1240 1613 1596 1608 1597 1 2 ND3P $T=695020 316400 1 180 $X=690060 $Y=316020
X1241 1705 1621 1722 1697 1 2 ND3P $T=722920 225680 0 180 $X=717960 $Y=220260
X1242 1738 1711 1745 1727 1 2 ND3P $T=731600 245840 0 180 $X=726640 $Y=240420
X1243 1774 1758 1778 1779 1 2 ND3P $T=742760 225680 0 0 $X=742760 $Y=225300
X1244 1783 1780 1782 1786 1 2 ND3P $T=747100 296240 1 0 $X=747100 $Y=290820
X1245 1806 1767 1818 1802 1 2 ND3P $T=760740 286160 0 180 $X=755780 $Y=280740
X1246 1810 1794 1817 1820 1 2 ND3P $T=757640 266000 0 0 $X=757640 $Y=265620
X1247 1804 1816 1825 1832 1 2 ND3P $T=771280 245840 0 180 $X=766320 $Y=240420
X1248 1907 1875 1906 1914 1 2 ND3P $T=791120 225680 0 0 $X=791120 $Y=225300
X1249 1226 127 1221 1215 1 2 MAO222P $T=544360 276080 0 0 $X=544360 $Y=275700
X1250 1313 1335 1338 1244 1 2 MAO222P $T=580940 266000 0 180 $X=575360 $Y=260580
X1251 154 150 1341 1370 1 2 MAO222P $T=584660 316400 0 0 $X=584660 $Y=316020
X1252 1586 1598 1605 1568 1 2 MAO222P $T=686340 235760 0 180 $X=680760 $Y=230340
X1253 1566 1588 1578 1582 1 2 MAO222P $T=688200 255920 1 180 $X=682620 $Y=255540
X1254 1575 1602 1594 1584 1 2 MAO222P $T=685100 296240 0 0 $X=685100 $Y=295860
X1255 1590 1610 1612 1575 1 2 MAO222P $T=691920 296240 0 180 $X=686340 $Y=290820
X1256 1628 1616 1611 1592 1 2 MAO222P $T=694400 245840 1 0 $X=694400 $Y=240420
X1257 1596 224 1614 225 1 2 MAO222P $T=701840 326480 0 180 $X=696260 $Y=321060
X1258 1750 1724 1730 1744 1 2 MAO222P $T=737800 245840 1 180 $X=732220 $Y=245460
X1259 1749 1768 1763 1772 1 2 MAO222P $T=742140 306320 0 0 $X=742140 $Y=305940
X1260 1772 1785 1788 258 1 2 MAO222P $T=752680 326480 0 180 $X=747100 $Y=321060
X1261 1780 1787 1792 1749 1 2 MAO222P $T=753300 306320 0 180 $X=747720 $Y=300900
X1262 1816 1813 1809 1798 1 2 MAO222P $T=758880 255920 1 0 $X=758880 $Y=250500
X1263 1837 1868 1865 1808 1 2 MAO222P $T=780580 235760 0 180 $X=775000 $Y=230340
X1264 1936 1917 1934 1946 1 2 MAO222P $T=799800 255920 1 0 $X=799800 $Y=250500
X1265 1915 1946 1940 1903 1 2 MAO222P $T=806620 235760 1 180 $X=801040 $Y=235380
X1266 1209 1 1204 1192 2 ND2P $T=541260 296240 0 180 $X=537540 $Y=290820
X1267 1212 1 1190 1196 2 ND2P $T=540640 286160 0 0 $X=540640 $Y=285780
X1268 126 1 1215 1220 2 ND2P $T=544360 316400 0 180 $X=540640 $Y=310980
X1269 1249 1 1252 1226 2 ND2P $T=552420 266000 1 0 $X=552420 $Y=260580
X1270 1257 1 1238 1258 2 ND2P $T=556760 296240 1 180 $X=553040 $Y=295860
X1271 1255 1 1258 1246 2 ND2P $T=554280 306320 1 0 $X=554280 $Y=300900
X1272 1261 1 1244 1242 2 ND2P $T=556140 286160 1 0 $X=556140 $Y=280740
X1273 1273 1 135 1293 2 ND2P $T=564820 255920 0 180 $X=561100 $Y=250500
X1274 1285 1 1269 1261 2 ND2P $T=562340 296240 0 0 $X=562340 $Y=295860
X1275 1259 1 135 1303 2 ND2P $T=568540 255920 0 180 $X=564820 $Y=250500
X1276 1317 1 1329 143 2 ND2P $T=578460 266000 0 0 $X=578460 $Y=265620
X1277 1343 1 1354 1348 2 ND2P $T=587760 296240 0 180 $X=584040 $Y=290820
X1278 1334 1 1359 1367 2 ND2P $T=584040 306320 0 0 $X=584040 $Y=305940
X1279 1445 1 1425 1436 2 ND2P $T=616900 286160 1 180 $X=613180 $Y=285780
X1280 1408 1 1466 1442 2 ND2P $T=622480 255920 0 0 $X=622480 $Y=255540
X1281 1579 1 1582 1585 2 ND2P $T=679520 266000 1 180 $X=675800 $Y=265620
X1282 1595 1 1584 1613 2 ND2P $T=691300 316400 0 180 $X=687580 $Y=310980
X1283 1601 1 1592 1609 2 ND2P $T=692540 245840 0 0 $X=692540 $Y=245460
X1284 1716 1 243 1714 2 ND2P $T=722920 316400 0 0 $X=722920 $Y=316020
X1285 1784 1 1767 1782 2 ND2P $T=750820 286160 0 0 $X=750820 $Y=285780
X1286 1823 1 1808 1825 2 ND2P $T=762600 245840 0 180 $X=758880 $Y=240420
X1287 1828 1 1798 1817 2 ND2P $T=762600 266000 0 0 $X=762600 $Y=265620
X1288 276 1 1871 1859 2 ND2P $T=780580 316400 0 180 $X=776860 $Y=310980
X1289 1842 1 1873 1883 2 ND2P $T=778720 286160 0 0 $X=778720 $Y=285780
X1290 1909 1 1903 1906 2 ND2P $T=792360 235760 0 180 $X=788640 $Y=230340
X1291 1912 1 1916 1917 2 ND2P $T=798560 276080 0 180 $X=794840 $Y=270660
X1292 1922 1 1903 1907 2 ND2P $T=796700 235760 1 0 $X=796700 $Y=230340
X1293 1909 1 1922 1914 2 ND2P $T=800420 235760 1 180 $X=796700 $Y=235380
X1294 1950 1 1952 1958 2 ND2P $T=810960 306320 0 180 $X=807240 $Y=300900
X1295 1987 1 1992 1936 2 ND2P $T=817780 266000 1 0 $X=817780 $Y=260580
X1296 1968 1 1466 1973 2 ND2P $T=819020 255920 0 0 $X=819020 $Y=255540
X1297 305 1 1993 1977 2 ND2P $T=824600 316400 0 180 $X=820880 $Y=310980
X1298 1998 1 2004 1940 2 ND2P $T=828320 245840 1 180 $X=824600 $Y=245460
X1299 164 1 2009 2004 2 ND2P $T=828320 245840 0 0 $X=828320 $Y=245460
X1300 2023 1 1995 2008 2 ND2P $T=838240 235760 1 180 $X=834520 $Y=235380
X1301 1206 1 1215 1231 2 ND2T $T=549320 316400 0 180 $X=544360 $Y=310980
X1302 1574 1 1582 1589 2 ND2T $T=681380 276080 0 180 $X=676420 $Y=270660
X1303 1600 1 1584 1608 2 ND2T $T=690060 316400 1 180 $X=685100 $Y=316020
X1304 1599 1 1592 1615 2 ND2T $T=693160 245840 0 180 $X=688200 $Y=240420
X1305 1240 1235 1217 2 1 124 XNR3 $T=551800 326480 0 180 $X=540640 $Y=321060
X1306 127 1221 1226 2 1 1241 XNR3 $T=541880 266000 0 0 $X=541880 $Y=265620
X1307 126 1206 1215 2 1 1216 XNR3 $T=553040 306320 1 180 $X=541880 $Y=305940
X1308 129 1233 1248 2 1 1267 XNR3 $T=548080 255920 1 0 $X=548080 $Y=250500
X1309 1253 1261 1244 2 1 1239 XNR3 $T=561720 276080 1 180 $X=550560 $Y=275700
X1310 1255 1262 1258 2 1 131 XNR3 $T=566680 316400 0 180 $X=555520 $Y=310980
X1311 1273 1259 135 2 1 1274 XNR3 $T=559860 245840 1 0 $X=559860 $Y=240420
X1312 1338 1335 1313 2 1 1295 XNR3 $T=581560 255920 1 180 $X=570400 $Y=255540
X1313 1321 1316 141 2 1 1353 XNR3 $T=574740 245840 1 0 $X=574740 $Y=240420
X1314 1344 1348 1362 2 1 1339 XNR3 $T=582800 245840 0 0 $X=582800 $Y=245460
X1315 1374 1377 1397 2 1 1369 XNR3 $T=591480 245840 1 0 $X=591480 $Y=240420
X1316 1392 1395 1401 2 1 1394 XNR3 $T=599540 235760 1 0 $X=599540 $Y=230340
X1317 1402 1400 1370 2 1 170 XNR3 $T=600160 306320 0 0 $X=600160 $Y=305940
X1318 186 1481 1470 2 1 1474 XNR3 $T=629920 316400 0 0 $X=629920 $Y=316020
X1319 1538 1532 1530 2 1 1533 XNR3 $T=658440 316400 1 0 $X=658440 $Y=310980
X1320 1560 1558 1546 2 1 1550 XNR3 $T=664640 306320 0 0 $X=664640 $Y=305940
X1321 1616 1611 1628 2 1 1620 XNR3 $T=691920 235760 0 0 $X=691920 $Y=235380
X1322 1648 1654 1664 2 1 1675 XNR3 $T=703080 245840 0 0 $X=703080 $Y=245460
X1323 1678 1682 1711 2 1 1717 XNR3 $T=713000 235760 0 0 $X=713000 $Y=235380
X1324 1724 1730 1750 2 1 1753 XNR3 $T=726020 255920 1 0 $X=726020 $Y=250500
X1325 1787 1792 1780 2 1 1740 XNR3 $T=756400 296240 1 180 $X=745240 $Y=295860
X1326 1829 1811 1794 2 1 1751 XNR3 $T=763840 276080 0 180 $X=752680 $Y=270660
X1327 1830 1828 1798 2 1 1673 XNR3 $T=765080 255920 1 180 $X=753920 $Y=255540
X1328 1799 1823 1808 2 1 1819 XNR3 $T=772520 235760 0 180 $X=761360 $Y=230340
X1329 1809 1813 1816 2 1 1726 XNR3 $T=776240 245840 1 180 $X=765080 $Y=245460
X1330 1868 1865 1837 2 1 1826 XNR3 $T=777480 225680 1 180 $X=766320 $Y=225300
X1331 1891 1886 1875 2 1 1831 XNR3 $T=790500 225680 0 180 $X=779340 $Y=220260
X1332 1239 1190 1 2 INV2 $T=541260 276080 0 180 $X=539400 $Y=270660
X1333 1216 1212 1 2 INV2 $T=544360 286160 0 0 $X=544360 $Y=285780
X1334 1241 1208 1 2 INV2 $T=551180 266000 0 180 $X=549320 $Y=260580
X1335 1237 1247 1 2 INV2 $T=556760 296240 0 180 $X=554900 $Y=290820
X1336 1267 1223 1 2 INV2 $T=558000 245840 0 180 $X=556140 $Y=240420
X1337 1274 1264 1 2 INV2 $T=559860 245840 0 0 $X=559860 $Y=245460
X1338 1295 1201 1 2 INV2 $T=564820 255920 1 180 $X=562960 $Y=255540
X1339 1275 1278 1 2 INV2 $T=562960 266000 1 0 $X=562960 $Y=260580
X1340 1296 1253 1 2 INV2 $T=565440 286160 1 0 $X=565440 $Y=280740
X1341 1314 1306 1 2 INV2 $T=571640 286160 0 180 $X=569780 $Y=280740
X1342 1279 1309 1 2 INV2 $T=575980 306320 1 0 $X=575980 $Y=300900
X1343 144 1340 1 2 INV2 $T=580320 316400 1 0 $X=580320 $Y=310980
X1344 1339 1228 1 2 INV2 $T=580940 245840 0 0 $X=580940 $Y=245460
X1345 1349 1335 1 2 INV2 $T=584040 266000 1 0 $X=584040 $Y=260580
X1346 1346 1361 1 2 INV2 $T=587140 266000 1 0 $X=587140 $Y=260580
X1347 1350 1363 1 2 INV2 $T=587140 316400 1 0 $X=587140 $Y=310980
X1348 1369 1265 1 2 INV2 $T=589620 245840 1 0 $X=589620 $Y=240420
X1349 1406 1281 1 2 INV2 $T=598920 286160 1 180 $X=597060 $Y=285780
X1350 1391 1383 1 2 INV2 $T=598920 296240 1 180 $X=597060 $Y=295860
X1351 1394 1326 1 2 INV2 $T=597680 235760 1 0 $X=597680 $Y=230340
X1352 1373 1397 1 2 INV2 $T=598920 296240 0 0 $X=598920 $Y=295860
X1353 1419 1421 1 2 INV2 $T=608840 255920 0 0 $X=608840 $Y=255540
X1354 1432 1409 1 2 INV2 $T=611320 276080 0 0 $X=611320 $Y=275700
X1355 1449 1392 1 2 INV2 $T=616900 235760 0 0 $X=616900 $Y=235380
X1356 1457 1468 1 2 INV2 $T=622480 286160 1 0 $X=622480 $Y=280740
X1357 1468 1464 1 2 INV2 $T=624340 266000 0 0 $X=624340 $Y=265620
X1358 1461 1454 1 2 INV2 $T=626200 245840 1 0 $X=626200 $Y=240420
X1359 1474 185 1 2 INV2 $T=628060 316400 0 0 $X=628060 $Y=316020
X1360 1489 1482 1 2 INV2 $T=633020 296240 0 0 $X=633020 $Y=295860
X1361 164 1286 1 2 INV2 $T=641080 255920 1 0 $X=641080 $Y=250500
X1362 1466 1429 1 2 INV2 $T=646660 266000 0 0 $X=646660 $Y=265620
X1363 1533 202 1 2 INV2 $T=656580 316400 1 0 $X=656580 $Y=310980
X1364 1550 207 1 2 INV2 $T=662780 306320 0 0 $X=662780 $Y=305940
X1365 228 1641 1 2 INV2 $T=703080 326480 1 0 $X=703080 $Y=321060
X1366 1675 1652 1 2 INV2 $T=709900 235760 0 180 $X=708040 $Y=230340
X1367 1673 1578 1 2 INV2 $T=711140 266000 0 180 $X=709280 $Y=260580
X1368 1641 1632 1 2 INV2 $T=717340 276080 1 180 $X=715480 $Y=275700
X1369 1708 1715 1 2 INV2 $T=722300 266000 1 0 $X=722300 $Y=260580
X1370 1726 1580 1 2 INV2 $T=727260 245840 1 180 $X=725400 $Y=245460
X1371 1740 1594 1 2 INV2 $T=729740 296240 1 180 $X=727880 $Y=295860
X1372 1747 1710 1 2 INV2 $T=733460 286160 0 180 $X=731600 $Y=280740
X1373 1751 1579 1 2 INV2 $T=737180 276080 0 180 $X=735320 $Y=270660
X1374 1753 1762 1 2 INV2 $T=740280 255920 1 0 $X=740280 $Y=250500
X1375 1826 1642 1 2 INV2 $T=762600 225680 0 180 $X=760740 $Y=220260
X1376 1819 1605 1 2 INV2 $T=762600 225680 1 180 $X=760740 $Y=225300
X1377 1831 1735 1 2 INV2 $T=765080 225680 0 180 $X=763220 $Y=220260
X1378 176 1833 1 2 INV2 $T=766320 296240 0 0 $X=766320 $Y=295860
X1379 275 1874 1 2 INV2 $T=778720 306320 0 0 $X=778720 $Y=305940
X1380 1833 1836 1 2 INV2 $T=781820 266000 0 0 $X=781820 $Y=265620
X1381 1878 1886 1 2 INV2 $T=786780 225680 0 0 $X=786780 $Y=225300
X1382 164 285 1 2 INV2 $T=800420 276080 1 0 $X=800420 $Y=270660
X1383 295 1956 1 2 INV2 $T=813440 296240 0 180 $X=811580 $Y=290820
X1384 1975 1922 1 2 INV2 $T=814680 235760 0 0 $X=814680 $Y=235380
X1385 301 1991 1 2 INV2 $T=819020 276080 0 0 $X=819020 $Y=275700
X1386 1989 1993 1 2 INV2 $T=820880 316400 0 0 $X=820880 $Y=316020
X1387 1990 1999 1 2 INV2 $T=821500 245840 0 0 $X=821500 $Y=245460
X1388 2002 2006 1 2 INV2 $T=825840 266000 0 0 $X=825840 $Y=265620
X1389 2000 2021 1 2 INV2 $T=831420 255920 1 0 $X=831420 $Y=250500
X1390 408 2164 1 2 INV2 $T=884120 255920 0 180 $X=882260 $Y=250500
X1391 425 2107 1 2 INV2 $T=889080 276080 0 180 $X=887220 $Y=270660
X1392 422 2060 1 2 INV2 $T=890940 255920 1 0 $X=890940 $Y=250500
X1393 444 2196 1 2 INV2 $T=967820 225680 1 0 $X=967820 $Y=220260
X1394 518 516 1 2 INV2 $T=976500 306320 0 180 $X=974640 $Y=300900
X1395 512 2657 1 2 INV2 $T=1080040 296240 1 0 $X=1080040 $Y=290820
X1396 513 2587 1 2 INV2 $T=1089960 276080 0 180 $X=1088100 $Y=270660
X1397 1439 1429 1432 1451 1 2 MXL2H $T=613180 245840 0 0 $X=613180 $Y=245460
X1398 1748 252 1746 253 1 2 MXL2H $T=734080 276080 0 0 $X=734080 $Y=275700
X1399 1971 192 1996 307 1 2 MXL2H $T=822120 296240 0 0 $X=822120 $Y=295860
X1400 231 2 1677 1683 1 AN2B1S $T=711760 286160 1 0 $X=711760 $Y=280740
X1401 1755 2 1757 1754 1 AN2B1S $T=739660 266000 1 180 $X=736560 $Y=265620
X1402 1882 2 1884 1901 1 AN2B1S $T=782440 255920 0 0 $X=782440 $Y=255540
X1403 1895 2 1880 1879 1 AN2B1S $T=788020 245840 1 180 $X=784920 $Y=245460
X1404 1277 123 1 1316 2 AN2S $T=567920 235760 0 0 $X=567920 $Y=235380
X1405 144 134 1 1336 2 AN2S $T=578460 306320 1 0 $X=578460 $Y=300900
X1406 1446 1445 1 1439 2 AN2S $T=617520 286160 0 0 $X=617520 $Y=285780
X1407 1593 220 1 1611 2 AN2S $T=685720 235760 0 0 $X=685720 $Y=235380
X1408 1702 1710 1 1691 2 AN2S $T=720440 276080 1 180 $X=717960 $Y=275700
X1409 4 3 1 2 BUF2CK $T=224440 225680 0 180 $X=221340 $Y=220260
X1410 1091 90 89 1081 1077 81 1 2 1075 AO222 $T=461280 235760 1 180 $X=455080 $Y=235380
X1411 1092 90 89 1084 1083 81 1 2 1044 AO222 $T=463760 245840 1 180 $X=457560 $Y=245460
X1412 1085 90 89 1080 1093 81 1 2 1051 AO222 $T=460660 276080 1 0 $X=460660 $Y=270660
X1413 1079 90 89 1078 1096 81 1 2 1052 AO222 $T=462520 286160 0 0 $X=462520 $Y=285780
X1414 1094 90 93 1089 1090 81 1 2 1041 AO222 $T=468720 306320 0 180 $X=462520 $Y=300900
X1415 1098 90 89 1099 1097 81 1 2 1095 AO222 $T=472440 235760 1 180 $X=466240 $Y=235380
X1416 96 90 89 1100 95 81 1 2 94 AO222 $T=473060 326480 0 180 $X=466860 $Y=321060
X1417 1102 90 93 1103 1105 81 1 2 1110 AO222 $T=474920 235760 0 0 $X=474920 $Y=235380
X1418 1108 90 93 1101 1115 81 1 2 1033 AO222 $T=489800 316400 0 180 $X=483600 $Y=310980
X1419 1175 90 89 1167 1164 81 1 2 1160 AO222 $T=515840 316400 0 180 $X=509640 $Y=310980
X1420 1169 90 89 1171 1168 81 1 2 1149 AO222 $T=517700 286160 0 180 $X=511500 $Y=280740
X1421 1182 90 93 1177 1172 81 1 2 1140 AO222 $T=519560 235760 1 180 $X=513360 $Y=235380
X1422 1184 90 89 1176 1173 81 1 2 1141 AO222 $T=519560 245840 1 180 $X=513360 $Y=245460
X1423 1183 90 89 1178 1174 81 1 2 1166 AO222 $T=519560 296240 0 180 $X=513360 $Y=290820
X1424 1181 90 89 1180 1179 81 1 2 1165 AO222 $T=521420 266000 1 180 $X=515220 $Y=265620
X1425 2095 2118 351 2089 2119 2131 1 2 2136 AO222 $T=851260 245840 1 0 $X=851260 $Y=240420
X1426 2115 2129 2138 2133 2114 2085 1 2 349 AO222 $T=859320 276080 0 180 $X=853120 $Y=270660
X1427 2186 2262 2229 2100 2258 2270 1 2 2267 AO222 $T=885980 225680 1 0 $X=885980 $Y=220260
X1428 2095 2337 2317 2119 2168 2331 1 2 2355 AO222 $T=908920 235760 0 0 $X=908920 $Y=235380
X1429 430 2381 437 2355 2199 2392 1 2 2402 AO222 $T=919460 306320 1 0 $X=919460 $Y=300900
X1430 2426 2127 2212 2412 2410 2151 1 2 2217 AO222 $T=932480 266000 0 180 $X=926280 $Y=260580
X1431 2595 2607 553 2613 2609 2624 1 2 567 AO222 $T=992620 306320 0 0 $X=992620 $Y=305940
X1432 2600 2631 561 2618 2633 2641 1 2 2636 AO222 $T=998200 266000 0 0 $X=998200 $Y=265620
X1433 2667 2722 2718 539 2712 2709 1 2 2668 AO222 $T=1024240 235760 1 180 $X=1018040 $Y=235380
X1434 2600 2756 2732 2633 619 2725 1 2 2767 AO222 $T=1035400 266000 0 0 $X=1035400 $Y=265620
X1435 2792 2693 2742 2780 2771 2777 1 2 638 AO222 $T=1049660 296240 0 180 $X=1043460 $Y=290820
X1436 633 2831 502 2767 662 661 1 2 2815 AO222 $T=1069500 306320 0 180 $X=1063300 $Y=300900
X1437 774 1 856 859 2 865 ND3 $T=342860 316400 0 0 $X=342860 $Y=316020
X1438 772 1 863 864 2 860 ND3 $T=344100 235760 0 0 $X=344100 $Y=235380
X1439 776 1 868 893 2 899 ND3 $T=350920 286160 1 0 $X=350920 $Y=280740
X1440 751 1 891 900 2 883 ND3 $T=350920 296240 0 0 $X=350920 $Y=295860
X1441 855 1 898 904 2 875 ND3 $T=352780 255920 1 0 $X=352780 $Y=250500
X1442 800 1 888 907 2 913 ND3 $T=355880 276080 1 0 $X=355880 $Y=270660
X1443 843 1 906 911 2 897 ND3 $T=357740 266000 1 0 $X=357740 $Y=260580
X1444 834 1 933 946 2 939 ND3 $T=375100 316400 1 0 $X=375100 $Y=310980
X1445 824 1 938 940 2 931 ND3 $T=376340 306320 1 0 $X=376340 $Y=300900
X1446 791 1 943 944 2 947 ND3 $T=378200 245840 0 0 $X=378200 $Y=245460
X1447 779 1 948 949 2 951 ND3 $T=380060 255920 0 0 $X=380060 $Y=255540
X1448 830 1 950 955 2 920 ND3 $T=380680 235760 0 0 $X=380680 $Y=235380
X1449 844 1 964 965 2 926 ND3 $T=388740 266000 0 0 $X=388740 $Y=265620
X1450 1050 1 1031 73 2 987 ND3 $T=435240 255920 0 180 $X=432760 $Y=250500
X1451 1045 1 1037 64 2 976 ND3 $T=435240 276080 0 180 $X=432760 $Y=270660
X1452 1055 1 1057 1060 2 994 ND3 $T=438340 235760 0 0 $X=438340 $Y=235380
X1453 1070 1 1069 1073 2 1015 ND3 $T=452600 245840 0 180 $X=450120 $Y=240420
X1454 1111 1 1107 1113 2 984 ND3 $T=482360 266000 0 180 $X=479880 $Y=260580
X1455 1136 1 1112 98 2 989 ND3 $T=488560 276080 1 180 $X=486080 $Y=275700
X1456 1118 1 1117 99 2 982 ND3 $T=488560 296240 1 180 $X=486080 $Y=295860
X1457 1124 1 1120 102 2 980 ND3 $T=491040 316400 1 180 $X=488560 $Y=316020
X1458 1139 1 1135 1138 2 998 ND3 $T=496620 255920 0 180 $X=494140 $Y=250500
X1459 1142 1 1133 106 2 999 ND3 $T=496620 266000 1 180 $X=494140 $Y=265620
X1460 1143 1 1137 105 2 985 ND3 $T=498480 286160 1 180 $X=496000 $Y=285780
X1461 1251 1 1246 1217 2 1256 ND3 $T=553040 316400 1 180 $X=550560 $Y=316020
X1462 174 1 1435 1437 2 1445 ND3 $T=613180 296240 0 0 $X=613180 $Y=295860
X1463 1703 1 1700 1664 2 1709 ND3 $T=720440 245840 1 180 $X=717960 $Y=245460
X1464 1876 1 276 1881 2 1885 ND3 $T=781200 306320 0 0 $X=781200 $Y=305940
X1465 2014 1 2013 2012 2 2011 ND3 $T=833280 296240 1 180 $X=830800 $Y=295860
X1466 2041 1 2036 2030 2 2032 ND3 $T=838860 306320 1 180 $X=836380 $Y=305940
X1467 2073 1 2058 2026 2 2056 ND3 $T=843200 286160 1 180 $X=840720 $Y=285780
X1468 2070 1 2074 2022 2 2050 ND3 $T=843820 306320 0 180 $X=841340 $Y=300900
X1469 2071 1 2066 2054 2 2053 ND3 $T=843820 316400 1 180 $X=841340 $Y=316020
X1470 2071 1 327 2086 2 2029 ND3 $T=847540 306320 0 180 $X=845060 $Y=300900
X1471 2099 1 2103 2045 2 2083 ND3 $T=848780 276080 1 180 $X=846300 $Y=275700
X1472 2123 1 2120 2039 2 2112 ND3 $T=853740 276080 1 180 $X=851260 $Y=275700
X1473 2126 1 2104 2111 2 2109 ND3 $T=854360 255920 1 180 $X=851880 $Y=255540
X1474 364 1 320 2131 2 353 ND3 $T=857460 245840 1 180 $X=854980 $Y=245460
X1475 2146 1 2140 2028 2 2132 ND3 $T=858080 286160 0 180 $X=855600 $Y=280740
X1476 2142 1 2148 2040 2 2153 ND3 $T=858080 286160 1 0 $X=858080 $Y=280740
X1477 2139 1 2158 2042 2 2165 ND3 $T=861180 286160 1 0 $X=861180 $Y=280740
X1478 2176 1 2174 2166 2 2072 ND3 $T=866760 286160 0 180 $X=864280 $Y=280740
X1479 2222 1 2174 2116 2 2209 ND3 $T=877300 286160 1 180 $X=874820 $Y=285780
X1480 2219 1 2180 2229 2 2238 ND3 $T=876680 235760 1 0 $X=876680 $Y=230340
X1481 2257 1 2250 2057 2 2255 ND3 $T=885360 306320 1 180 $X=882880 $Y=305940
X1482 2232 1 2260 2262 2 2265 ND3 $T=885980 235760 1 0 $X=885980 $Y=230340
X1483 2269 1 425 2115 2 423 ND3 $T=888460 255920 1 180 $X=885980 $Y=255540
X1484 2268 1 2278 441 2 2137 ND3 $T=890940 245840 0 0 $X=890940 $Y=245460
X1485 2311 1 2309 2259 2 2296 ND3 $T=900860 306320 1 180 $X=898380 $Y=305940
X1486 2310 1 2106 2319 2 2320 ND3 $T=900240 266000 0 0 $X=900240 $Y=265620
X1487 2335 1 2328 2088 2 2326 ND3 $T=908920 296240 1 180 $X=906440 $Y=295860
X1488 2225 1 353 2322 2 2329 ND3 $T=910160 255920 0 180 $X=907680 $Y=250500
X1489 2352 1 444 2270 2 2375 ND3 $T=917600 225680 1 0 $X=917600 $Y=220260
X1490 324 1 392 2386 2 374 ND3 $T=919460 316400 1 0 $X=919460 $Y=310980
X1491 2395 1 408 2381 2 376 ND3 $T=923180 255920 1 180 $X=920700 $Y=255540
X1492 2401 1 2295 2388 2 2271 ND3 $T=925040 235760 1 180 $X=922560 $Y=235380
X1493 2365 1 425 2403 2 2225 ND3 $T=924420 255920 0 0 $X=924420 $Y=255540
X1494 2428 1 2109 2118 2 2242 ND3 $T=933720 245840 0 180 $X=931240 $Y=240420
X1495 2248 1 408 2437 2 425 ND3 $T=932480 255920 1 0 $X=932480 $Y=250500
X1496 2358 1 2420 2406 2 2427 ND3 $T=932480 266000 0 0 $X=932480 $Y=265620
X1497 2354 1 461 2447 2 480 ND3 $T=937440 316400 1 0 $X=937440 $Y=310980
X1498 2448 1 2414 2410 2 2265 ND3 $T=940540 255920 0 180 $X=938060 $Y=250500
X1499 2449 1 474 2435 2 480 ND3 $T=940540 306320 0 180 $X=938060 $Y=300900
X1500 2440 1 376 2455 2 2400 ND3 $T=940540 255920 1 0 $X=940540 $Y=250500
X1501 2457 1 483 2451 2 2464 ND3 $T=943020 276080 0 0 $X=943020 $Y=275700
X1502 2353 1 2376 2426 2 2463 ND3 $T=943640 255920 0 0 $X=943640 $Y=255540
X1503 2420 1 376 2459 2 2260 ND3 $T=954180 276080 1 0 $X=954180 $Y=270660
X1504 2496 1 2389 2493 2 2467 ND3 $T=956660 266000 0 0 $X=956660 $Y=265620
X1505 2506 1 2407 2394 2 2461 ND3 $T=966580 235760 0 180 $X=964100 $Y=230340
X1506 2385 1 2060 2517 2 333 ND3 $T=968440 276080 0 180 $X=965960 $Y=270660
X1507 511 1 502 2537 2 508 ND3 $T=974020 296240 1 180 $X=971540 $Y=295860
X1508 2547 1 2545 2548 2 2555 ND3 $T=978980 296240 1 180 $X=976500 $Y=295860
X1509 2552 1 2530 2538 2 2414 ND3 $T=980220 276080 0 180 $X=977740 $Y=270660
X1510 2621 1 507 2595 2 2568 ND3 $T=997580 306320 0 180 $X=995100 $Y=300900
X1511 2620 1 2617 562 2 2629 ND3 $T=996340 245840 0 0 $X=996340 $Y=245460
X1512 518 1 511 2613 2 576 ND3 $T=1000060 306320 0 0 $X=1000060 $Y=305940
X1513 2632 1 571 2637 2 2643 ND3 $T=1000060 316400 0 0 $X=1000060 $Y=316020
X1514 2706 1 579 2700 2 2703 ND3 $T=1014320 306320 0 0 $X=1014320 $Y=305940
X1515 2707 1 2615 2631 2 2699 ND3 $T=1017420 266000 1 180 $X=1014940 $Y=265620
X1516 598 1 599 2676 2 2615 ND3 $T=1017420 286160 0 180 $X=1014940 $Y=280740
X1517 2708 1 2651 2713 2 2692 ND3 $T=1018660 296240 1 0 $X=1018660 $Y=290820
X1518 2729 1 585 2718 2 2666 ND3 $T=1026100 245840 1 180 $X=1023620 $Y=245460
X1519 2673 1 599 2722 2 2738 ND3 $T=1027340 245840 1 0 $X=1027340 $Y=240420
X1520 2750 1 519 2709 2 2743 ND3 $T=1032920 245840 0 180 $X=1030440 $Y=240420
X1521 620 1 2747 618 2 2744 ND3 $T=1033540 316400 1 180 $X=1031060 $Y=316020
X1522 2757 1 507 2754 2 2547 ND3 $T=1037880 286160 1 180 $X=1035400 $Y=285780
X1523 2757 1 2615 2756 2 2755 ND3 $T=1038500 276080 0 180 $X=1036020 $Y=270660
X1524 2766 1 2604 2769 2 2593 ND3 $T=1040360 255920 1 0 $X=1040360 $Y=250500
X1525 2784 1 2692 2771 2 2738 ND3 $T=1046560 266000 0 180 $X=1044080 $Y=260580
X1526 617 1 512 2782 2 507 ND3 $T=1048420 276080 0 180 $X=1045940 $Y=270660
X1527 2655 1 2653 2792 2 2796 ND3 $T=1055240 276080 1 180 $X=1052760 $Y=275700
X1528 2809 1 2751 2798 2 2634 ND3 $T=1057720 266000 0 180 $X=1055240 $Y=260580
X1529 2826 1 512 2831 2 511 ND3 $T=1066400 276080 0 0 $X=1066400 $Y=275700
X1530 2833 1 511 2832 2 2675 ND3 $T=1070740 266000 0 180 $X=1068260 $Y=260580
X1531 2701 1 511 2840 2 599 ND3 $T=1069500 286160 1 0 $X=1069500 $Y=280740
X1532 2869 1 2759 2850 2 2868 ND3 $T=1092440 266000 1 180 $X=1089960 $Y=265620
X1533 2865 1 672 2870 2 699 ND3 $T=1091820 316400 0 0 $X=1091820 $Y=316020
X1534 317 313 2052 2 312 1 2037 AN4B1S $T=842580 326480 0 180 $X=838240 $Y=321060
X1535 2076 2067 2063 2 2059 1 2038 AN4B1S $T=845060 245840 1 180 $X=840720 $Y=245460
X1536 2097 2091 2087 2 312 1 2074 AN4B1S $T=848160 306320 1 180 $X=843820 $Y=305940
X1537 2102 2069 328 2 2040 1 2056 AN4B1S $T=849400 286160 0 180 $X=845060 $Y=280740
X1538 2102 340 2110 2 2116 1 2083 AN4B1S $T=849400 286160 0 0 $X=849400 $Y=285780
X1539 2082 2117 340 2 2121 1 2112 AN4B1S $T=850640 296240 1 0 $X=850640 $Y=290820
X1540 2124 2130 2134 2 2136 1 366 AN4B1S $T=854360 225680 0 0 $X=854360 $Y=225300
X1541 368 2141 358 2 2116 1 2139 AN4B1S $T=859320 286160 1 180 $X=854980 $Y=285780
X1542 2117 363 2143 2 2018 1 2142 AN4B1S $T=855600 296240 0 0 $X=855600 $Y=295860
X1543 382 379 361 2 2155 1 2152 AN4B1S $T=864280 255920 1 180 $X=859940 $Y=255540
X1544 2162 2171 2172 2 2173 1 2183 AN4B1S $T=863040 245840 0 0 $X=863040 $Y=245460
X1545 2152 391 2182 2 2079 1 400 AN4B1S $T=865520 255920 0 0 $X=865520 $Y=255540
X1546 2187 2202 2207 2 2211 1 2076 AN4B1S $T=871720 245840 1 0 $X=871720 $Y=240420
X1547 2205 2210 2198 2 2215 1 2092 AN4B1S $T=872960 225680 0 0 $X=872960 $Y=225300
X1548 2060 2195 2239 2 2231 1 2245 AN4B1S $T=879160 255920 0 0 $X=879160 $Y=255540
X1549 2216 2254 398 2 2259 1 2257 AN4B1S $T=884120 306320 1 0 $X=884120 $Y=300900
X1550 2291 2266 2283 2 2282 1 2073 AN4B1S $T=895900 286160 0 180 $X=891560 $Y=280740
X1551 2290 2279 2247 2 2285 1 2281 AN4B1S $T=897760 255920 1 180 $X=893420 $Y=255540
X1552 423 2295 2271 2 433 1 2287 AN4B1S $T=899620 235760 0 180 $X=895280 $Y=230340
X1553 2183 2298 2301 2 2305 1 445 AN4B1S $T=897140 245840 1 0 $X=897140 $Y=240420
X1554 2061 2314 448 2 2218 1 2312 AN4B1S $T=901480 235760 1 0 $X=901480 $Y=230340
X1555 412 2060 444 2 2322 1 2318 AN4B1S $T=902100 255920 0 0 $X=902100 $Y=255540
X1556 2330 2332 2334 2 2336 1 2099 AN4B1S $T=907680 276080 0 0 $X=907680 $Y=275700
X1557 2321 2060 2349 2 351 1 2302 AN4B1S $T=911400 255920 1 0 $X=911400 $Y=250500
X1558 2356 431 2295 2 2145 1 2346 AN4B1S $T=916980 235760 0 180 $X=912640 $Y=230340
X1559 2248 333 2214 2 2364 1 2369 AN4B1S $T=913880 245840 0 0 $X=913880 $Y=245460
X1560 2370 2362 2359 2 2360 1 457 AN4B1S $T=918220 286160 1 180 $X=913880 $Y=285780
X1561 2356 2265 2376 2 2380 1 2344 AN4B1S $T=918220 225680 0 0 $X=918220 $Y=225300
X1562 2389 333 2349 2 2371 1 2372 AN4B1S $T=923180 276080 0 180 $X=918840 $Y=270660
X1563 2387 467 465 2 2378 1 464 AN4B1S $T=923180 326480 0 180 $X=918840 $Y=321060
X1564 2128 468 434 2 2390 1 2377 AN4B1S $T=921320 286160 1 0 $X=921320 $Y=280740
X1565 466 2354 2384 2 2393 1 2367 AN4B1S $T=921320 306320 0 0 $X=921320 $Y=305940
X1566 2400 2277 2407 2 2189 1 2238 AN4B1S $T=925040 235760 1 0 $X=925040 $Y=230340
X1567 2353 2397 320 2 2189 1 2436 AN4B1S $T=930620 255920 0 0 $X=930620 $Y=255540
X1568 2425 2424 2411 2 2435 1 479 AN4B1S $T=932480 306320 1 0 $X=932480 $Y=300900
X1569 2385 2420 2427 2 386 1 2428 AN4B1S $T=933720 235760 0 0 $X=933720 $Y=235380
X1570 408 2382 2376 2 2167 1 2438 AN4B1S $T=936200 255920 0 0 $X=936200 $Y=255540
X1571 321 2382 2443 2 2107 1 2442 AN4B1S $T=936200 276080 1 0 $X=936200 $Y=270660
X1572 2444 2445 2446 2 2451 1 2123 AN4B1S $T=938060 286160 1 0 $X=938060 $Y=280740
X1573 2461 444 423 2 2418 1 2453 AN4B1S $T=945500 235760 0 180 $X=941160 $Y=230340
X1574 2313 481 2458 2 2454 1 2169 AN4B1S $T=941160 316400 1 0 $X=941160 $Y=310980
X1575 2225 484 2191 2 485 1 2465 AN4B1S $T=944260 286160 0 0 $X=944260 $Y=285780
X1576 2251 423 2480 2 2409 1 2477 AN4B1S $T=949840 276080 0 0 $X=949840 $Y=275700
X1577 2486 2487 2481 2 2402 1 2070 AN4B1S $T=956040 306320 0 180 $X=951700 $Y=300900
X1578 2492 2490 2488 2 2447 1 2041 AN4B1S $T=956660 306320 1 180 $X=952320 $Y=305940
X1579 2485 444 2109 2 2469 1 2476 AN4B1S $T=955420 266000 1 0 $X=955420 $Y=260580
X1580 2494 2242 2407 2 2107 1 2479 AN4B1S $T=956660 235760 1 0 $X=956660 $Y=230340
X1581 2485 2414 2180 2 2368 1 2507 AN4B1S $T=957900 245840 0 0 $X=957900 $Y=245460
X1582 416 431 2061 2 2495 1 2511 AN4B1S $T=958520 235760 0 0 $X=958520 $Y=235380
X1583 2407 431 2420 2 2345 1 2478 AN4B1S $T=959140 225680 0 0 $X=959140 $Y=225300
X1584 423 2506 2341 2 2409 1 2510 AN4B1S $T=960380 296240 0 0 $X=960380 $Y=295860
X1585 411 2494 2382 2 2338 1 2519 AN4B1S $T=962860 255920 1 0 $X=962860 $Y=250500
X1586 2500 2509 499 2 2515 1 2014 AN4B1S $T=962860 306320 1 0 $X=962860 $Y=300900
X1587 2251 500 2405 2 2469 1 2524 AN4B1S $T=964720 266000 0 0 $X=964720 $Y=265620
X1588 353 2419 416 2 2261 1 2523 AN4B1S $T=965340 255920 0 0 $X=965340 $Y=255540
X1589 2419 434 2349 2 2304 1 2503 AN4B1S $T=965340 286160 1 0 $X=965340 $Y=280740
X1590 2530 434 2420 2 2292 1 2514 AN4B1S $T=971540 276080 1 180 $X=967200 $Y=275700
X1591 2242 2461 2203 2 475 1 2533 AN4B1S $T=969060 235760 0 0 $X=969060 $Y=235380
X1592 2251 411 2203 2 2304 1 2534 AN4B1S $T=972160 286160 1 0 $X=972160 $Y=280740
X1593 2542 2484 2170 2 2543 1 526 AN4B1S $T=977740 235760 0 0 $X=977740 $Y=235380
X1594 2545 502 508 2 2554 1 2562 AN4B1S $T=977740 306320 1 0 $X=977740 $Y=300900
X1595 2569 2565 2563 2 2553 1 2556 AN4B1S $T=984560 276080 1 180 $X=980220 $Y=275700
X1596 2550 2566 519 2 2548 1 2559 AN4B1S $T=985180 296240 0 180 $X=980840 $Y=290820
X1597 2589 542 2586 2 2579 1 537 AN4B1S $T=990760 296240 0 180 $X=986420 $Y=290820
X1598 548 545 543 2 2582 1 2589 AN4B1S $T=992000 296240 1 180 $X=987660 $Y=295860
X1599 2585 2583 2590 2 2592 1 2605 AN4B1S $T=988280 266000 1 0 $X=988280 $Y=260580
X1600 2580 547 550 2 2591 1 2614 AN4B1S $T=989520 316400 0 0 $X=989520 $Y=316020
X1601 2568 2604 2593 2 554 1 2597 AN4B1S $T=995720 245840 0 180 $X=991380 $Y=240420
X1602 2605 2611 2616 2 2601 1 563 AN4B1S $T=993860 255920 0 0 $X=993860 $Y=255540
X1603 2608 2566 2619 2 561 1 2606 AN4B1S $T=994480 286160 1 0 $X=994480 $Y=280740
X1604 2654 2644 2639 2 2636 1 568 AN4B1S $T=1004400 245840 1 180 $X=1000060 $Y=245460
X1605 2678 2649 2603 2 2646 1 2569 AN4B1S $T=1005640 276080 1 180 $X=1001300 $Y=275700
X1606 2656 2574 584 2 2677 1 2672 AN4B1S $T=1007500 296240 0 0 $X=1007500 $Y=295860
X1607 2691 2686 2683 2 2681 1 2671 AN4B1S $T=1014320 235760 1 180 $X=1009980 $Y=235380
X1608 2698 2689 2687 2 589 1 586 AN4B1S $T=1014940 316400 1 180 $X=1010600 $Y=316020
X1609 2566 2690 2696 2 2688 1 2695 AN4B1S $T=1012460 286160 0 0 $X=1012460 $Y=285780
X1610 2564 2702 600 2 602 1 2704 AN4B1S $T=1014940 245840 0 0 $X=1014940 $Y=245460
X1611 2651 550 2701 2 2642 1 2723 AN4B1S $T=1018660 306320 1 0 $X=1018660 $Y=300900
X1612 2662 2701 2726 2 578 1 2707 AN4B1S $T=1021760 276080 0 0 $X=1021760 $Y=275700
X1613 617 569 2584 2 2736 1 2705 AN4B1S $T=1031680 266000 1 180 $X=1027340 $Y=265620
X1614 2741 2745 2746 2 2748 1 622 AN4B1S $T=1030440 276080 0 0 $X=1030440 $Y=275700
X1615 2675 2749 2751 2 592 1 2666 AN4B1S $T=1032300 245840 0 0 $X=1032300 $Y=245460
X1616 2755 582 2604 2 2728 1 2758 AN4B1S $T=1037880 245840 0 0 $X=1037880 $Y=245460
X1617 2755 2738 2653 2 2779 1 2763 AN4B1S $T=1042840 245840 1 0 $X=1042840 $Y=240420
X1618 2634 519 2568 2 2752 1 2776 AN4B1S $T=1042840 255920 0 0 $X=1042840 $Y=255540
X1619 2797 2699 2751 2 2716 1 2788 AN4B1S $T=1052760 255920 1 180 $X=1048420 $Y=255540
X1620 2655 2783 2540 2 592 1 2803 AN4B1S $T=1050280 286160 1 0 $X=1050280 $Y=280740
X1621 2751 582 2793 2 608 1 2800 AN4B1S $T=1051520 245840 0 0 $X=1051520 $Y=245460
X1622 513 582 2564 2 2804 1 2820 AN4B1S $T=1052140 255920 1 0 $X=1052140 $Y=250500
X1623 2699 2634 2557 2 538 1 2811 AN4B1S $T=1054000 255920 0 0 $X=1054000 $Y=255540
X1624 512 655 2653 2 2581 1 2805 AN4B1S $T=1060200 276080 1 180 $X=1055860 $Y=275700
X1625 2656 2527 2557 2 2628 1 2807 AN4B1S $T=1055860 286160 1 0 $X=1055860 $Y=280740
X1626 514 655 2812 2 2716 1 2806 AN4B1S $T=1060820 286160 1 180 $X=1056480 $Y=285780
X1627 2823 2819 657 2 2815 1 652 AN4B1S $T=1062060 306320 0 180 $X=1057720 $Y=300900
X1628 2824 2814 2733 2 2817 1 659 AN4B1S $T=1063920 235760 1 180 $X=1059580 $Y=235380
X1629 2547 518 610 2 668 1 2837 AN4B1S $T=1066400 296240 0 0 $X=1066400 $Y=295860
X1630 2656 2568 2835 2 2822 1 2842 AN4B1S $T=1069500 286160 0 0 $X=1069500 $Y=285780
X1631 2568 2809 664 2 2822 1 2847 AN4B1S $T=1073220 296240 1 0 $X=1073220 $Y=290820
X1632 682 2834 2844 2 2637 1 675 AN4B1S $T=1077560 326480 0 180 $X=1073220 $Y=321060
X1633 2846 519 2615 2 2677 1 679 AN4B1S $T=1078800 286160 0 180 $X=1074460 $Y=280740
X1634 2852 2849 684 2 2848 1 680 AN4B1S $T=1081280 316400 0 180 $X=1076940 $Y=310980
X1635 2527 2797 655 2 2774 1 2853 AN4B1S $T=1081280 276080 1 0 $X=1081280 $Y=270660
X1636 2846 2692 585 2 2610 1 2857 AN4B1S $T=1082520 266000 0 0 $X=1082520 $Y=265620
X1637 2794 550 2619 2 2628 1 2859 AN4B1S $T=1083140 286160 1 0 $X=1083140 $Y=280740
X1638 2759 569 2619 2 687 1 2860 AN4B1S $T=1085620 276080 0 0 $X=1085620 $Y=275700
X1639 2845 2794 513 2 2770 1 2855 AN4B1S $T=1088100 255920 1 0 $X=1088100 $Y=250500
X1640 2866 2858 2801 2 2870 1 700 AN4B1S $T=1089960 316400 1 0 $X=1089960 $Y=310980
X1641 992 1 2 996 BUF1CK $T=411060 245840 1 0 $X=411060 $Y=240420
X1642 1129 1 2 1135 BUF1CK $T=492280 245840 0 0 $X=492280 $Y=245460
X1643 411 382 408 343 2 1 2207 OA22 $T=877920 255920 0 180 $X=873580 $Y=250500
X1644 319 2281 407 402 2 1 2313 OA22 $T=895280 316400 1 0 $X=895280 $Y=310980
X1645 438 443 2260 2316 2 1 2296 OA22 $T=905820 306320 1 180 $X=901480 $Y=305940
X1646 2294 2104 376 2308 2 1 2330 OA22 $T=902720 286160 1 0 $X=902720 $Y=280740
X1647 345 454 2194 2180 2 1 2328 OA22 $T=912020 306320 0 180 $X=907680 $Y=300900
X1648 384 2414 2316 408 2 1 2424 OA22 $T=927520 296240 1 0 $X=927520 $Y=290820
X1649 380 2242 387 2414 2 1 2301 OA22 $T=933100 245840 0 0 $X=933100 $Y=245460
X1650 333 2404 392 478 2 1 476 OA22 $T=939300 316400 1 180 $X=934960 $Y=316020
X1651 2429 2443 2366 408 2 1 2160 OA22 $T=941160 286160 1 180 $X=936820 $Y=285780
X1652 395 472 392 2432 2 1 2458 OA22 $T=939920 316400 0 0 $X=939920 $Y=316020
X1653 2527 548 512 544 2 1 2603 OA22 $T=989520 286160 1 0 $X=989520 $Y=280740
X1654 531 2699 581 2692 2 1 2616 OA22 $T=1016800 266000 0 180 $X=1012460 $Y=260580
X1655 2825 2812 2727 512 2 1 653 OA22 $T=1063920 306320 1 180 $X=1059580 $Y=305940
X1656 575 2692 605 512 2 1 2858 OA22 $T=1080660 306320 0 0 $X=1080660 $Y=305940
X1657 892 1 2 846 INV3CK $T=356500 296240 0 180 $X=353400 $Y=290820
X1658 919 1 2 825 INV3CK $T=370140 296240 0 180 $X=367040 $Y=290820
X1659 915 1 2 816 INV3CK $T=376960 316400 0 0 $X=376960 $Y=316020
X1660 977 1 2 960 INV3CK $T=404860 296240 0 180 $X=401760 $Y=290820
X1661 1016 1 2 966 INV3CK $T=426560 286160 1 180 $X=423460 $Y=285780
X1662 1010 1 2 968 INV3CK $T=429040 306320 0 0 $X=429040 $Y=305940
X1663 1049 1 2 971 INV3CK $T=435240 296240 0 0 $X=435240 $Y=295860
X1664 82 1 2 85 INV3CK $T=453840 316400 0 0 $X=453840 $Y=316020
X1665 1088 1 2 92 INV3CK $T=462520 306320 0 0 $X=462520 $Y=305940
X1666 1965 1 2 307 INV3CK $T=827700 316400 1 0 $X=827700 $Y=310980
X1667 23 8 1 2 INV6CK $T=308140 316400 0 0 $X=308140 $Y=316020
X1668 816 9 1 2 INV6CK $T=316820 306320 1 180 $X=311240 $Y=305940
X1669 825 6 1 2 INV6CK $T=322400 296240 0 180 $X=316820 $Y=290820
X1670 846 5 1 2 INV6CK $T=336040 296240 0 180 $X=330460 $Y=290820
X1671 960 28 1 2 INV6CK $T=386260 296240 0 180 $X=380680 $Y=290820
X1672 966 27 1 2 INV6CK $T=390600 286160 0 180 $X=385020 $Y=280740
X1673 968 25 1 2 INV6CK $T=394940 316400 0 0 $X=394940 $Y=316020
X1674 971 26 1 2 INV6CK $T=401760 306320 0 180 $X=396180 $Y=300900
X1675 1021 55 1 2 INV6CK $T=426560 316400 0 0 $X=426560 $Y=316020
X1676 321 1 2068 318 2059 2051 2 OAI22S $T=845060 255920 1 180 $X=841340 $Y=255540
X1677 2223 1 2239 2279 2252 319 2 OAI22S $T=889700 266000 0 0 $X=889700 $Y=265620
X1678 380 1 2287 379 2275 2243 2 OAI22S $T=896520 225680 1 180 $X=892800 $Y=225300
X1679 2297 1 379 370 2215 2312 2 OAI22S $T=897760 225680 0 0 $X=897760 $Y=225300
X1680 361 1 2302 382 2305 2318 2 OAI22S $T=897760 255920 1 0 $X=897760 $Y=250500
X1681 360 1 2324 385 2047 2329 2 OAI22S $T=903960 266000 1 0 $X=903960 $Y=260580
X1682 350 1 2376 361 2211 2385 2 OAI22S $T=918220 245840 1 0 $X=918220 $Y=240420
X1683 2192 1 2383 2366 2221 2372 2 OAI22S $T=923180 276080 1 180 $X=919460 $Y=275700
X1684 2223 1 2520 388 2499 501 2 OAI22S $T=969680 316400 1 180 $X=965960 $Y=316020
X1685 370 1 2511 359 2543 2533 2 OAI22S $T=980220 245840 0 180 $X=976500 $Y=240420
X1686 514 1 2546 524 2553 2560 2 OAI22S $T=977120 286160 1 0 $X=977120 $Y=280740
X1687 532 1 2571 533 2567 2555 2 OAI22S $T=986420 296240 1 180 $X=982700 $Y=295860
X1688 543 1 2606 548 2601 2559 2 OAI22S $T=995720 286160 1 180 $X=992000 $Y=285780
X1689 531 1 2597 545 2627 2638 2 OAI22S $T=996960 245840 1 0 $X=996960 $Y=240420
X1690 574 1 2653 543 2646 2662 2 OAI22S $T=1003780 286160 0 0 $X=1003780 $Y=285780
X1691 2652 1 545 559 2681 2704 2 OAI22S $T=1013700 245840 1 0 $X=1013700 $Y=240420
X1692 601 1 2696 2745 2753 498 2 OAI22S $T=1037880 296240 1 180 $X=1034160 $Y=295860
X1693 559 1 2820 588 2817 2811 2 OAI22S $T=1062680 245840 1 180 $X=1058960 $Y=245460
X1694 604 1 2791 2727 695 2860 2 OAI22S $T=1083140 296240 0 0 $X=1083140 $Y=295860
X1695 845 2 848 847 1 NR2 $T=335420 306320 0 0 $X=335420 $Y=305940
X1696 845 2 29 849 1 NR2 $T=336040 306320 1 0 $X=336040 $Y=300900
X1697 851 2 869 849 1 NR2 $T=339140 296240 0 0 $X=339140 $Y=295860
X1698 851 2 858 847 1 NR2 $T=340380 296240 1 0 $X=340380 $Y=290820
X1699 967 2 963 849 1 NR2 $T=392460 296240 0 180 $X=390600 $Y=290820
X1700 967 2 969 847 1 NR2 $T=393700 296240 1 0 $X=393700 $Y=290820
X1701 972 2 970 849 1 NR2 $T=402380 306320 1 180 $X=400520 $Y=305940
X1702 896 2 975 47 1 NR2 $T=405480 316400 0 0 $X=405480 $Y=316020
X1703 972 2 997 847 1 NR2 $T=408580 296240 1 0 $X=408580 $Y=290820
X1704 1001 2 1003 845 1 NR2 $T=416640 306320 1 180 $X=414780 $Y=305940
X1705 1001 2 53 967 1 NR2 $T=416020 296240 1 0 $X=416020 $Y=290820
X1706 1033 2 60 1024 1 NR2 $T=431520 326480 0 180 $X=429660 $Y=321060
X1707 1041 2 61 1034 1 NR2 $T=433380 296240 1 180 $X=431520 $Y=295860
X1708 1044 2 1050 1036 1 NR2 $T=435240 245840 1 180 $X=433380 $Y=245460
X1709 1052 2 63 1008 1 NR2 $T=435240 286160 1 180 $X=433380 $Y=285780
X1710 1001 2 1039 972 1 NR2 $T=435240 296240 0 180 $X=433380 $Y=290820
X1711 36 2 1046 47 1 NR2 $T=436480 316400 1 180 $X=434620 $Y=316020
X1712 1051 2 1045 1048 1 NR2 $T=437100 276080 0 180 $X=435240 $Y=270660
X1713 1064 2 66 972 1 NR2 $T=437100 296240 0 180 $X=435240 $Y=290820
X1714 1095 2 1055 1042 1 NR2 $T=440200 235760 0 180 $X=438340 $Y=230340
X1715 1064 2 1058 967 1 NR2 $T=444540 296240 1 0 $X=444540 $Y=290820
X1716 1064 2 68 845 1 NR2 $T=447020 306320 0 180 $X=445160 $Y=300900
X1717 76 2 886 72 1 NR2 $T=448880 326480 0 180 $X=447020 $Y=321060
X1718 1075 2 1070 1068 1 NR2 $T=451980 235760 1 180 $X=450120 $Y=235380
X1719 1001 2 78 851 1 NR2 $T=450740 296240 1 0 $X=450740 $Y=290820
X1720 851 2 87 1064 1 NR2 $T=453840 306320 0 180 $X=451980 $Y=300900
X1721 76 2 903 83 1 NR2 $T=452600 326480 1 0 $X=452600 $Y=321060
X1722 83 2 901 86 1 NR2 $T=456320 326480 0 180 $X=454460 $Y=321060
X1723 1110 2 1111 1116 1 NR2 $T=482980 235760 0 0 $X=482980 $Y=235380
X1724 1140 2 1142 1144 1 NR2 $T=497860 235760 0 0 $X=497860 $Y=235380
X1725 1141 2 1139 1146 1 NR2 $T=497860 255920 1 0 $X=497860 $Y=250500
X1726 1149 2 1143 1145 1 NR2 $T=502820 286160 0 180 $X=500960 $Y=280740
X1727 1160 2 1124 1156 1 NR2 $T=508400 316400 0 180 $X=506540 $Y=310980
X1728 1166 2 1118 1159 1 NR2 $T=512120 296240 0 180 $X=510260 $Y=290820
X1729 1165 2 1136 1170 1 NR2 $T=511500 266000 0 0 $X=511500 $Y=265620
X1730 1213 2 1214 1224 1 NR2 $T=541260 306320 1 0 $X=541260 $Y=300900
X1731 1367 2 1350 157 1 NR2 $T=590240 316400 1 0 $X=590240 $Y=310980
X1732 155 2 1389 159 1 NR2 $T=595820 326480 0 180 $X=593960 $Y=321060
X1733 1378 2 1385 1388 1 NR2 $T=597060 306320 1 0 $X=597060 $Y=300900
X1734 1429 2 1431 1436 1 NR2 $T=610700 286160 0 0 $X=610700 $Y=285780
X1735 1429 2 1423 1437 1 NR2 $T=610700 296240 1 0 $X=610700 $Y=290820
X1736 1434 2 1441 1438 1 NR2 $T=611940 245840 1 0 $X=611940 $Y=240420
X1737 1442 2 1434 1437 1 NR2 $T=614420 255920 0 0 $X=614420 $Y=255540
X1738 1429 2 1456 1464 1 NR2 $T=622480 266000 0 0 $X=622480 $Y=265620
X1739 1429 2 1477 1459 1 NR2 $T=629300 266000 1 180 $X=627440 $Y=265620
X1740 199 2 1523 1527 1 NR2 $T=655340 306320 0 180 $X=653480 $Y=300900
X1741 1527 2 1525 200 1 NR2 $T=653480 306320 0 0 $X=653480 $Y=305940
X1742 1689 2 1686 1684 1 NR2 $T=716720 286160 0 180 $X=714860 $Y=280740
X1743 238 2 1687 1695 1 NR2 $T=716720 296240 1 0 $X=716720 $Y=290820
X1744 238 2 1693 1684 1 NR2 $T=716720 296240 0 0 $X=716720 $Y=295860
X1745 238 2 1690 1696 1 NR2 $T=716720 306320 0 0 $X=716720 $Y=305940
X1746 238 2 1719 1721 1 NR2 $T=723540 306320 1 0 $X=723540 $Y=300900
X1747 254 2 1752 255 1 NR2 $T=741520 326480 1 0 $X=741520 $Y=321060
X1748 271 2 1843 1850 1 NR2 $T=773140 316400 0 180 $X=771280 $Y=310980
X1749 271 2 1854 1859 1 NR2 $T=773140 306320 1 0 $X=773140 $Y=300900
X1750 155 2 1872 1881 1 NR2 $T=779960 306320 1 0 $X=779960 $Y=300900
X1751 280 2 1885 256 1 NR2 $T=784920 316400 1 180 $X=783060 $Y=316020
X1752 1887 2 1882 1890 1 NR2 $T=786780 266000 1 180 $X=784920 $Y=265620
X1753 280 2 1893 281 1 NR2 $T=784920 316400 0 0 $X=784920 $Y=316020
X1754 280 2 1904 255 1 NR2 $T=791740 316400 0 0 $X=791740 $Y=316020
X1755 280 2 1894 283 1 NR2 $T=795460 326480 1 0 $X=795460 $Y=321060
X1756 198 2 1964 256 1 NR2 $T=809100 326480 0 180 $X=807240 $Y=321060
X1757 294 2 1954 1956 1 NR2 $T=810960 296240 1 180 $X=809100 $Y=295860
X1758 294 2 1976 1958 1 NR2 $T=814060 296240 1 0 $X=814060 $Y=290820
X1759 1973 2 1970 1958 1 NR2 $T=817780 276080 0 180 $X=815920 $Y=270660
X1760 294 2 1978 1977 1 NR2 $T=817780 286160 0 180 $X=815920 $Y=280740
X1761 294 2 1961 1991 1 NR2 $T=815920 286160 0 0 $X=815920 $Y=285780
X1762 198 2 306 283 1 NR2 $T=829560 326480 0 180 $X=827700 $Y=321060
X1763 2047 2 2067 2077 1 NR2 $T=839480 255920 1 0 $X=839480 $Y=250500
X1764 2048 2 2044 2055 1 NR2 $T=839480 266000 1 0 $X=839480 $Y=260580
X1765 2100 2 2068 2079 1 NR2 $T=846920 255920 1 180 $X=845060 $Y=255540
X1766 2108 2 2103 2105 1 NR2 $T=851260 276080 1 180 $X=849400 $Y=275700
X1767 331 2 2094 347 1 NR2 $T=849400 316400 0 0 $X=849400 $Y=316020
X1768 2128 2 322 319 1 NR2 $T=854980 286160 0 180 $X=853120 $Y=280740
X1769 361 2 2129 319 1 NR2 $T=856220 266000 1 180 $X=854360 $Y=265620
X1770 351 2 2122 2149 1 NR2 $T=856840 235760 1 0 $X=856840 $Y=230340
X1771 332 2 2127 319 1 NR2 $T=861180 276080 0 180 $X=859320 $Y=270660
X1772 382 2 2085 319 1 NR2 $T=863660 266000 0 180 $X=861800 $Y=260580
X1773 387 2 2151 319 1 NR2 $T=866140 276080 0 180 $X=864280 $Y=270660
X1774 385 2 2138 319 1 NR2 $T=868620 266000 0 180 $X=866760 $Y=260580
X1775 390 2 2188 319 1 NR2 $T=866760 276080 1 0 $X=866760 $Y=270660
X1776 2189 2 2175 339 1 NR2 $T=869860 245840 0 180 $X=868000 $Y=240420
X1777 2206 2 364 2164 1 NR2 $T=873580 255920 1 180 $X=871720 $Y=255540
X1778 2080 2 2182 2186 1 NR2 $T=873580 235760 0 0 $X=873580 $Y=235380
X1779 350 2 2212 319 1 NR2 $T=873580 266000 0 0 $X=873580 $Y=265620
X1780 2217 2 2036 2204 1 NR2 $T=875440 306320 1 180 $X=873580 $Y=305940
X1781 334 2 2226 319 1 NR2 $T=878540 276080 0 180 $X=876680 $Y=270660
X1782 2164 2 2219 2107 1 NR2 $T=877300 235760 0 0 $X=877300 $Y=235380
X1783 2227 2 2195 2107 1 NR2 $T=879160 245840 1 180 $X=877300 $Y=245460
X1784 2189 2 2106 2231 1 NR2 $T=880400 245840 0 0 $X=880400 $Y=245460
X1785 2164 2 2225 2231 1 NR2 $T=880400 255920 1 0 $X=880400 $Y=250500
X1786 360 2 2240 319 1 NR2 $T=882260 266000 1 180 $X=880400 $Y=265620
X1787 2252 2 2222 2263 1 NR2 $T=885980 276080 0 0 $X=885980 $Y=275700
X1788 2095 2 2273 330 1 NR2 $T=889080 245840 1 180 $X=887220 $Y=245460
X1789 2267 2 2268 2275 1 NR2 $T=889080 225680 0 0 $X=889080 $Y=225300
X1790 2167 2 2269 2274 1 NR2 $T=889700 266000 1 0 $X=889700 $Y=260580
X1791 343 2 430 319 1 NR2 $T=894040 276080 0 0 $X=894040 $Y=275700
X1792 2230 2 431 422 1 NR2 $T=895900 235760 0 0 $X=895900 $Y=235380
X1793 380 2 2264 319 1 NR2 $T=898380 296240 0 180 $X=896520 $Y=290820
X1794 339 2 2284 2304 1 NR2 $T=897760 235760 0 0 $X=897760 $Y=235380
X1795 348 2 440 2199 1 NR2 $T=897760 316400 0 0 $X=897760 $Y=316020
X1796 2230 2 2310 2292 1 NR2 $T=900860 266000 1 0 $X=900860 $Y=260580
X1797 2230 2 2314 2167 1 NR2 $T=902720 245840 0 0 $X=902720 $Y=245460
X1798 338 2 443 367 1 NR2 $T=902720 326480 1 0 $X=902720 $Y=321060
X1799 2196 2 2299 449 1 NR2 $T=903960 296240 1 0 $X=903960 $Y=290820
X1800 442 2 2098 450 1 NR2 $T=904580 245840 1 0 $X=904580 $Y=240420
X1801 442 2 2321 2167 1 NR2 $T=904580 245840 0 0 $X=904580 $Y=245460
X1802 2177 2 2320 2090 1 NR2 $T=904580 266000 0 0 $X=904580 $Y=265620
X1803 2090 2 2323 2231 1 NR2 $T=905820 235760 0 0 $X=905820 $Y=235380
X1804 351 2 2271 450 1 NR2 $T=906440 235760 1 0 $X=906440 $Y=230340
X1805 2231 2 2342 2218 1 NR2 $T=907060 266000 0 0 $X=907060 $Y=265620
X1806 2338 2 2288 2149 1 NR2 $T=909540 245840 1 180 $X=907680 $Y=245460
X1807 2231 2 2339 2145 1 NR2 $T=907680 276080 1 0 $X=907680 $Y=270660
X1808 2345 2 448 2177 1 NR2 $T=911400 235760 0 180 $X=909540 $Y=230340
X1809 2177 2 2329 455 1 NR2 $T=909540 255920 0 0 $X=909540 $Y=255540
X1810 2292 2 2324 2190 1 NR2 $T=911400 266000 1 0 $X=911400 $Y=260580
X1811 2351 2 2343 2286 1 NR2 $T=913260 296240 0 180 $X=911400 $Y=290820
X1812 2368 2 2239 2167 1 NR2 $T=916980 255920 1 180 $X=915120 $Y=255540
X1813 339 2 2356 2231 1 NR2 $T=919460 235760 0 0 $X=919460 $Y=235380
X1814 2364 2 2352 2380 1 NR2 $T=920080 225680 1 0 $X=920080 $Y=220260
X1815 397 2 2404 2264 1 NR2 $T=925040 316400 0 180 $X=923180 $Y=310980
X1816 342 2 2379 375 1 NR2 $T=925660 306320 0 0 $X=925660 $Y=305940
X1817 2340 2 2277 2196 1 NR2 $T=926280 235760 0 0 $X=926280 $Y=235380
X1818 475 2 2401 2107 1 NR2 $T=930000 235760 1 180 $X=928140 $Y=235380
X1819 2418 2 2295 2340 1 NR2 $T=931860 235760 0 180 $X=930000 $Y=230340
X1820 2338 2 2397 2230 1 NR2 $T=931240 245840 0 0 $X=931240 $Y=245460
X1821 344 2 2423 2199 1 NR2 $T=933100 316400 1 180 $X=931240 $Y=316020
X1822 344 2 2432 352 1 NR2 $T=933720 326480 0 180 $X=931860 $Y=321060
X1823 344 2 2417 373 1 NR2 $T=936200 316400 0 180 $X=934340 $Y=310980
X1824 2190 2 2427 2218 1 NR2 $T=935580 245840 1 0 $X=935580 $Y=240420
X1825 2409 2 2440 2181 1 NR2 $T=938060 255920 0 180 $X=936200 $Y=250500
X1826 369 2 478 372 1 NR2 $T=938680 326480 0 180 $X=936820 $Y=321060
X1827 2189 2 2405 386 1 NR2 $T=938680 225680 0 0 $X=938680 $Y=225300
X1828 475 2 2265 386 1 NR2 $T=938680 235760 0 0 $X=938680 $Y=235380
X1829 442 2 2443 386 1 NR2 $T=941780 276080 1 180 $X=939920 $Y=275700
X1830 2368 2 2448 2190 1 NR2 $T=940540 245840 0 0 $X=940540 $Y=245460
X1831 2340 2 2341 2230 1 NR2 $T=941780 286160 0 0 $X=941780 $Y=285780
X1832 455 2 2375 2218 1 NR2 $T=943020 245840 0 0 $X=943020 $Y=245460
X1833 2090 2 2191 2145 1 NR2 $T=945500 276080 1 0 $X=945500 $Y=270660
X1834 351 2 2400 2351 1 NR2 $T=947360 255920 0 0 $X=947360 $Y=255540
X1835 2470 2 2461 351 1 NR2 $T=949220 266000 0 180 $X=947360 $Y=260580
X1836 455 2 2376 2107 1 NR2 $T=952320 235760 1 180 $X=950460 $Y=235380
X1837 2145 2 2109 2351 1 NR2 $T=950460 266000 1 0 $X=950460 $Y=260580
X1838 2338 2 2389 422 1 NR2 $T=952320 266000 1 180 $X=950460 $Y=265620
X1839 422 2 2480 2090 1 NR2 $T=950460 276080 1 0 $X=950460 $Y=270660
X1840 2164 2 2472 2351 1 NR2 $T=952320 286160 1 180 $X=950460 $Y=285780
X1841 455 2 2385 2090 1 NR2 $T=951700 245840 1 0 $X=951700 $Y=240420
X1842 2090 2 2483 2439 1 NR2 $T=952320 266000 1 0 $X=952320 $Y=260580
X1843 2164 2 2468 2459 1 NR2 $T=952940 245840 0 0 $X=952940 $Y=245460
X1844 2164 2 2494 2145 1 NR2 $T=955420 235760 0 180 $X=953560 $Y=230340
X1845 442 2 2496 2409 1 NR2 $T=955420 266000 1 180 $X=953560 $Y=265620
X1846 2495 2 2485 339 1 NR2 $T=956660 245840 1 180 $X=954800 $Y=245460
X1847 2462 2 492 2497 1 NR2 $T=956040 316400 1 0 $X=956040 $Y=310980
X1848 493 2 2358 442 1 NR2 $T=959140 276080 0 180 $X=957280 $Y=270660
X1849 339 2 2467 2351 1 NR2 $T=960380 276080 1 180 $X=958520 $Y=275700
X1850 455 2 2419 442 1 NR2 $T=959140 255920 0 0 $X=959140 $Y=255540
X1851 2338 2 2061 2231 1 NR2 $T=962240 245840 0 180 $X=960380 $Y=240420
X1852 339 2 2489 2196 1 NR2 $T=962860 306320 1 180 $X=961000 $Y=305940
X1853 2338 2 2508 2351 1 NR2 $T=964100 266000 1 180 $X=962240 $Y=265620
X1854 2190 2 2382 2495 1 NR2 $T=962860 245840 0 0 $X=962860 $Y=245460
X1855 2218 2 2535 2345 1 NR2 $T=967820 225680 1 180 $X=965960 $Y=225300
X1856 442 2 2414 2196 1 NR2 $T=965960 245840 0 0 $X=965960 $Y=245460
X1857 2107 2 2420 2196 1 NR2 $T=969680 235760 0 180 $X=967820 $Y=230340
X1858 2189 2 2242 442 1 NR2 $T=969680 245840 0 180 $X=967820 $Y=240420
X1859 2470 2 2530 339 1 NR2 $T=969060 276080 1 0 $X=969060 $Y=270660
X1860 2190 2 2407 475 1 NR2 $T=969680 245840 0 0 $X=969680 $Y=245460
X1861 493 2 2520 2525 1 NR2 $T=971540 306320 1 180 $X=969680 $Y=305940
X1862 2190 2 2513 2525 1 NR2 $T=972780 296240 0 180 $X=970920 $Y=290820
X1863 2190 2 2349 2177 1 NR2 $T=972160 255920 1 0 $X=972160 $Y=250500
X1864 2292 2 2502 2218 1 NR2 $T=974020 266000 0 0 $X=974020 $Y=265620
X1865 339 2 2203 2107 1 NR2 $T=974640 276080 1 0 $X=974640 $Y=270660
X1866 508 2 521 520 1 NR2 $T=978360 316400 1 180 $X=976500 $Y=316020
X1867 523 2 2558 2551 1 NR2 $T=978980 326480 1 0 $X=978980 $Y=321060
X1868 2218 2 2552 2177 1 NR2 $T=981460 266000 1 180 $X=979600 $Y=265620
X1869 2561 2 2555 2554 1 NR2 $T=981460 296240 1 180 $X=979600 $Y=295860
X1870 2107 2 2544 2189 1 NR2 $T=981460 245840 0 0 $X=981460 $Y=245460
X1871 2567 2 2565 2575 1 NR2 $T=983320 276080 1 0 $X=983320 $Y=270660
X1872 2218 2 2506 2107 1 NR2 $T=986420 245840 1 0 $X=986420 $Y=240420
X1873 539 2 2546 2579 1 NR2 $T=988280 286160 0 180 $X=986420 $Y=280740
X1874 2580 2 535 498 1 NR2 $T=986420 316400 0 0 $X=986420 $Y=316020
X1875 516 2 2578 549 1 NR2 $T=988280 266000 0 0 $X=988280 $Y=265620
X1876 533 2 553 498 1 NR2 $T=988280 306320 0 0 $X=988280 $Y=305940
X1877 2600 2 2596 540 1 NR2 $T=991380 255920 1 180 $X=989520 $Y=255540
X1878 534 2 546 498 1 NR2 $T=989520 326480 1 0 $X=989520 $Y=321060
X1879 555 2 2599 552 1 NR2 $T=993240 326480 0 180 $X=991380 $Y=321060
X1880 543 2 2607 498 1 NR2 $T=995100 316400 0 180 $X=993240 $Y=310980
X1881 555 2 554 557 1 NR2 $T=993240 326480 1 0 $X=993240 $Y=321060
X1882 548 2 2624 498 1 NR2 $T=995100 316400 1 0 $X=995100 $Y=310980
X1883 566 2 565 558 1 NR2 $T=998200 326480 0 180 $X=996340 $Y=321060
X1884 2599 2 2602 2628 1 NR2 $T=996960 255920 1 0 $X=996960 $Y=250500
X1885 2668 2 2620 2627 1 NR2 $T=1000060 235760 1 180 $X=998200 $Y=235380
X1886 516 2 2608 2581 1 NR2 $T=998200 276080 0 0 $X=998200 $Y=275700
X1887 538 2 2574 2599 1 NR2 $T=998200 306320 1 0 $X=998200 $Y=300900
X1888 2635 2 2634 561 1 NR2 $T=1001300 296240 1 180 $X=999440 $Y=295860
X1889 561 2 2593 549 1 NR2 $T=1000060 255920 1 0 $X=1000060 $Y=250500
X1890 561 2 2645 2648 1 NR2 $T=1001920 255920 1 0 $X=1001920 $Y=250500
X1891 2635 2 2651 2599 1 NR2 $T=1005020 306320 0 0 $X=1005020 $Y=305940
X1892 2577 2 2586 2667 1 NR2 $T=1006880 255920 0 0 $X=1006880 $Y=255540
X1893 2682 2 576 2657 1 NR2 $T=1011840 286160 0 180 $X=1009980 $Y=280740
X1894 592 2 2684 2599 1 NR2 $T=1013700 266000 1 180 $X=1011840 $Y=265620
X1895 564 2 2693 498 1 NR2 $T=1011840 306320 0 0 $X=1011840 $Y=305940
X1896 2554 2 2662 2587 1 NR2 $T=1014320 276080 1 0 $X=1014320 $Y=270660
X1897 592 2 579 2688 1 NR2 $T=1017420 276080 1 180 $X=1015560 $Y=275700
X1898 2685 2 2702 2581 1 NR2 $T=1019280 276080 0 180 $X=1017420 $Y=270660
X1899 602 2 2708 2561 1 NR2 $T=1017420 286160 0 0 $X=1017420 $Y=285780
X1900 2685 2 2706 2642 1 NR2 $T=1019280 306320 1 180 $X=1017420 $Y=305940
X1901 2711 2 603 2694 1 NR2 $T=1019900 316400 0 180 $X=1018040 $Y=310980
X1902 2714 2 2619 2561 1 NR2 $T=1020520 266000 1 180 $X=1018660 $Y=265620
X1903 2685 2 582 2710 1 NR2 $T=1018660 276080 0 0 $X=1018660 $Y=275700
X1904 608 2 600 2561 1 NR2 $T=1022380 245840 1 180 $X=1020520 $Y=245460
X1905 2587 2 2720 2688 1 NR2 $T=1020520 276080 1 0 $X=1020520 $Y=270660
X1906 2721 2 2690 2716 1 NR2 $T=1022380 286160 0 180 $X=1020520 $Y=280740
X1907 2642 2 2571 2714 1 NR2 $T=1022380 296240 1 0 $X=1022380 $Y=290820
X1908 2688 2 2717 2728 1 NR2 $T=1022380 316400 0 0 $X=1022380 $Y=316020
X1909 2599 2 2557 2716 1 NR2 $T=1023620 255920 0 0 $X=1023620 $Y=255540
X1910 2657 2 2729 2716 1 NR2 $T=1024240 245840 1 0 $X=1024240 $Y=240420
X1911 2714 2 2726 602 1 NR2 $T=1026100 296240 1 180 $X=1024240 $Y=295860
X1912 2587 2 610 2728 1 NR2 $T=1024240 306320 1 0 $X=1024240 $Y=300900
X1913 2735 2 2656 602 1 NR2 $T=1027340 255920 0 180 $X=1025480 $Y=250500
X1914 538 2 2738 578 1 NR2 $T=1029200 255920 1 0 $X=1029200 $Y=250500
X1915 592 2 584 578 1 NR2 $T=1031060 255920 1 180 $X=1029200 $Y=255540
X1916 572 2 2737 516 1 NR2 $T=1031060 286160 1 180 $X=1029200 $Y=285780
X1917 2561 2 2703 2587 1 NR2 $T=1030440 306320 0 0 $X=1030440 $Y=305940
X1918 560 2 2739 498 1 NR2 $T=1031060 296240 0 0 $X=1031060 $Y=295860
X1919 2736 2 2750 2779 1 NR2 $T=1032300 235760 0 0 $X=1032300 $Y=235380
X1920 2610 2 2696 2581 1 NR2 $T=1032300 286160 0 0 $X=1032300 $Y=285780
X1921 2599 2 625 594 1 NR2 $T=1033540 316400 0 0 $X=1033540 $Y=316020
X1922 592 2 2699 516 1 NR2 $T=1034160 266000 1 0 $X=1034160 $Y=260580
X1923 531 2 623 498 1 NR2 $T=1036020 326480 0 180 $X=1034160 $Y=321060
X1924 2752 2 2604 2761 1 NR2 $T=1035400 255920 1 0 $X=1035400 $Y=250500
X1925 2753 2 626 2760 1 NR2 $T=1036640 306320 1 0 $X=1036640 $Y=300900
X1926 572 2 630 2670 1 NR2 $T=1037880 326480 1 0 $X=1037880 $Y=321060
X1927 2761 2 2749 594 1 NR2 $T=1038500 255920 1 0 $X=1038500 $Y=250500
X1928 538 2 2766 2716 1 NR2 $T=1040980 255920 1 180 $X=1039120 $Y=255540
X1929 2657 2 2547 2688 1 NR2 $T=1039120 286160 0 0 $X=1039120 $Y=285780
X1930 2599 2 2755 2688 1 NR2 $T=1039740 276080 1 0 $X=1039740 $Y=270660
X1931 2714 2 2751 538 1 NR2 $T=1042840 266000 0 180 $X=1040980 $Y=260580
X1932 532 2 2764 498 1 NR2 $T=1041600 296240 1 0 $X=1041600 $Y=290820
X1933 2774 2 2762 2648 1 NR2 $T=1044700 266000 1 180 $X=1042840 $Y=265620
X1934 544 2 633 498 1 NR2 $T=1042840 296240 0 0 $X=1042840 $Y=295860
X1935 574 2 2742 498 1 NR2 $T=1046560 296240 1 180 $X=1044700 $Y=295860
X1936 594 2 2787 643 1 NR2 $T=1045940 316400 0 0 $X=1045940 $Y=316020
X1937 2610 2 2784 2714 1 NR2 $T=1047800 266000 1 0 $X=1047800 $Y=260580
X1938 581 2 2777 498 1 NR2 $T=1047800 296240 0 0 $X=1047800 $Y=295860
X1939 2774 2 2564 2688 1 NR2 $T=1050900 266000 1 0 $X=1050900 $Y=260580
X1940 2688 2 2799 602 1 NR2 $T=1050900 316400 0 0 $X=1050900 $Y=316020
X1941 2802 2 644 2778 1 NR2 $T=1053380 306320 0 180 $X=1051520 $Y=300900
X1942 2774 2 2783 2685 1 NR2 $T=1054620 276080 1 0 $X=1054620 $Y=270660
X1943 2642 2 2813 602 1 NR2 $T=1055240 296240 1 0 $X=1055240 $Y=290820
X1944 516 2 2812 578 1 NR2 $T=1060820 296240 0 180 $X=1058960 $Y=290820
X1945 2554 2 2653 2716 1 NR2 $T=1059580 255920 0 0 $X=1059580 $Y=255540
X1946 2714 2 655 2804 1 NR2 $T=1059580 266000 0 0 $X=1059580 $Y=265620
X1947 2714 2 2816 2670 1 NR2 $T=1059580 316400 1 0 $X=1059580 $Y=310980
X1948 516 2 2692 594 1 NR2 $T=1063920 266000 1 180 $X=1062060 $Y=265620
X1949 2716 2 2793 594 1 NR2 $T=1065160 245840 1 180 $X=1063300 $Y=245460
X1950 602 2 2828 608 1 NR2 $T=1067020 255920 0 180 $X=1065160 $Y=250500
X1951 2761 2 664 2685 1 NR2 $T=1065160 286160 1 0 $X=1065160 $Y=280740
X1952 602 2 2809 2716 1 NR2 $T=1067020 255920 1 0 $X=1067020 $Y=250500
X1953 561 2 2675 2802 1 NR2 $T=1067640 276080 1 0 $X=1067640 $Y=270660
X1954 2716 2 2841 592 1 NR2 $T=1070120 255920 0 0 $X=1070120 $Y=255540
X1955 570 2 673 623 1 NR2 $T=1071980 306320 1 180 $X=1070120 $Y=305940
X1956 2822 2 2833 2594 1 NR2 $T=1073220 266000 1 180 $X=1071360 $Y=265620
X1957 592 2 2845 602 1 NR2 $T=1071980 255920 1 0 $X=1071980 $Y=250500
X1958 2710 2 2835 2587 1 NR2 $T=1071980 276080 1 0 $X=1071980 $Y=270660
X1959 2657 2 2797 2728 1 NR2 $T=1076940 245840 1 180 $X=1075080 $Y=245460
X1960 2657 2 2839 2840 1 NR2 $T=1076940 266000 0 180 $X=1075080 $Y=260580
X1961 2774 2 2759 2710 1 NR2 $T=1076940 266000 1 180 $X=1075080 $Y=265620
X1962 2728 2 2615 2802 1 NR2 $T=1075080 276080 0 0 $X=1075080 $Y=275700
X1963 2657 2 676 2802 1 NR2 $T=1076940 306320 1 180 $X=1075080 $Y=305940
X1964 2554 2 2743 602 1 NR2 $T=1080660 255920 1 180 $X=1078800 $Y=255540
X1965 2804 2 2846 2599 1 NR2 $T=1078800 266000 1 0 $X=1078800 $Y=260580
X1966 2587 2 686 2818 1 NR2 $T=1082520 266000 1 180 $X=1080660 $Y=265620
X1967 690 2 691 694 1 NR2 $T=1082520 326480 1 0 $X=1082520 $Y=321060
X1968 2554 2 2794 516 1 NR2 $T=1090580 255920 0 0 $X=1090580 $Y=255540
X1969 2599 2 2868 2802 1 NR2 $T=1090580 276080 1 0 $X=1090580 $Y=270660
X1970 2774 2 2867 2802 1 NR2 $T=1090580 276080 0 0 $X=1090580 $Y=275700
X1971 516 2 2869 2822 1 NR2 $T=1092440 266000 0 0 $X=1092440 $Y=265620
X1972 372 331 2 365 1 358 AOI12HS $T=859940 316400 1 180 $X=855600 $Y=316020
X1973 2489 2405 2 2194 1 2505 AOI12HS $T=963480 316400 1 0 $X=963480 $Y=310980
X1974 1060 1 2 97 DELB $T=465620 245840 0 0 $X=465620 $Y=245460
X1975 1113 1 2 100 DELB $T=482980 266000 0 0 $X=482980 $Y=265620
X1976 1375 1 2 1390 DELB $T=592100 235760 1 0 $X=592100 $Y=230340
X1977 1777 1 2 1789 DELB $T=745860 276080 0 0 $X=745860 $Y=275700
X1978 164 2 1 1266 BUF1 $T=604500 255920 1 180 $X=602020 $Y=255540
X1979 162 2 1 134 BUF1 $T=609460 296240 0 180 $X=606980 $Y=290820
X1980 166 2 1 1480 BUF1 $T=634260 255920 0 0 $X=634260 $Y=255540
X1981 192 2 1 1452 BUF1 $T=640460 296240 1 180 $X=637980 $Y=295860
X1982 198 2 1 1527 BUF1 $T=651620 316400 0 0 $X=651620 $Y=316020
X1983 192 2 1 1486 BUF1 $T=659060 296240 1 180 $X=656580 $Y=295860
X1984 1833 2 1 259 BUF1 $T=766320 306320 0 180 $X=763840 $Y=300900
X1985 155 2 1 271 BUF1 $T=775620 306320 1 0 $X=775620 $Y=300900
X1986 2845 2 1 2545 BUF1 $T=1077560 255920 1 0 $X=1077560 $Y=250500
X1987 1073 1 2 84 BUF1S $T=452600 245840 1 0 $X=452600 $Y=240420
X1988 1138 1 2 107 BUF1S $T=496000 255920 0 0 $X=496000 $Y=255540
X1989 1199 1 2 1186 BUF1S $T=536300 316400 0 180 $X=533820 $Y=310980
X1990 1198 1 2 1194 BUF1S $T=538160 266000 1 180 $X=535680 $Y=265620
X1991 1205 1 2 1188 BUF1S $T=539400 255920 0 180 $X=536920 $Y=250500
X1992 4 2 1 284 BUF3 $T=794840 225680 1 0 $X=794840 $Y=220260
X1993 2018 2029 2 2017 2031 1 OR3B2 $T=833280 296240 0 0 $X=833280 $Y=295860
X1994 2057 2069 2 2043 2082 1 OR3B2 $T=841340 296240 0 0 $X=841340 $Y=295860
X1995 192 2 198 256 1952 1 NR3 $T=808480 316400 1 180 $X=805380 $Y=316020
X1996 2033 2 308 2015 309 1 NR3 $T=835140 326480 0 180 $X=832040 $Y=321060
X1997 2017 2 2024 2028 2011 1 NR3 $T=833280 296240 1 0 $X=833280 $Y=290820
X1998 2019 2 2015 2027 2013 1 NR3 $T=833280 306320 1 0 $X=833280 $Y=300900
X1999 2049 2 2065 2062 315 1 NR3 $T=841340 296240 1 0 $X=841340 $Y=290820
X2000 2096 2 2086 2088 2102 1 NR3 $T=848160 286160 1 180 $X=845060 $Y=285780
X2001 2166 2 2157 2156 2161 1 NR3 $T=863660 316400 1 180 $X=860560 $Y=316020
X2002 2224 2 2221 2220 2120 1 NR3 $T=879160 276080 1 180 $X=876060 $Y=275700
X2003 2212 2 2127 2151 2256 1 NR3 $T=885980 276080 0 180 $X=882880 $Y=270660
X2004 2261 2 2231 2227 2213 1 NR3 $T=887220 255920 0 180 $X=884120 $Y=250500
X2005 2229 2 422 2218 2276 1 NR3 $T=887840 235760 1 180 $X=884740 $Y=235380
X2006 2177 2 2164 2331 2297 1 NR3 $T=906440 225680 0 0 $X=906440 $Y=225300
X2007 2373 2 2374 2371 2208 1 NR3 $T=918220 266000 1 0 $X=918220 $Y=260580
X2008 2416 2 2380 2149 2383 1 NR3 $T=922560 245840 1 180 $X=919460 $Y=245460
X2009 2364 2 450 2345 2415 1 NR3 $T=926280 225680 1 180 $X=923180 $Y=225300
X2010 2391 2 2398 2289 2075 1 NR3 $T=923800 296240 1 0 $X=923800 $Y=290820
X2011 2409 2 351 2181 2395 1 NR3 $T=928140 255920 0 180 $X=925040 $Y=250500
X2012 2340 2 422 2409 2365 1 NR3 $T=926900 245840 1 0 $X=926900 $Y=240420
X2013 2392 2 355 401 2421 1 NR3 $T=932480 306320 1 180 $X=929380 $Y=305940
X2014 2455 2 2189 2374 2422 1 NR3 $T=944880 225680 1 180 $X=941780 $Y=225300
X2015 2437 2 2469 2410 2471 1 NR3 $T=946120 255920 1 0 $X=946120 $Y=250500
X2016 2340 2 475 2439 2475 1 NR3 $T=947360 235760 0 0 $X=947360 $Y=235380
X2017 2493 2 2164 2218 2474 1 NR3 $T=957280 225680 1 180 $X=954180 $Y=225300
X2018 2495 2 2231 2304 2463 1 NR3 $T=956660 245840 1 0 $X=956660 $Y=240420
X2019 2499 2 495 2505 2250 1 NR3 $T=959140 316400 1 0 $X=959140 $Y=310980
X2020 2517 2 2529 2525 2504 1 NR3 $T=967820 306320 1 0 $X=967820 $Y=300900
X2021 2261 2 455 2459 2531 1 NR3 $T=968440 255920 1 0 $X=968440 $Y=250500
X2022 2431 2 2529 2469 2516 1 NR3 $T=970300 286160 0 0 $X=970300 $Y=285780
X2023 2528 2 493 2292 2532 1 NR3 $T=970920 266000 1 0 $X=970920 $Y=260580
X2024 2430 2 2456 2536 2512 1 NR3 $T=972780 245840 0 0 $X=972780 $Y=245460
X2025 2538 2 2107 2167 2539 1 NR3 $T=980840 255920 0 0 $X=980840 $Y=255540
X2026 2622 2 572 2642 2650 1 NR3 $T=1000060 296240 1 0 $X=1000060 $Y=290820
X2027 2674 2 2664 2663 2661 1 NR3 $T=1009980 276080 1 180 $X=1006880 $Y=275700
X2028 2659 2 2665 2670 2660 1 NR3 $T=1006880 316400 1 0 $X=1006880 $Y=310980
X2029 2647 2 2665 2677 2679 1 NR3 $T=1008120 306320 1 0 $X=1008120 $Y=300900
X2030 2561 2 2657 2725 2652 1 NR3 $T=1015560 255920 0 0 $X=1015560 $Y=255540
X2031 2718 2 2710 602 2598 1 NR3 $T=1022380 255920 0 180 $X=1019280 $Y=250500
X2032 2713 2 2716 2581 2658 1 NR3 $T=1019900 286160 0 0 $X=1019900 $Y=285780
X2033 2736 2 549 608 2719 1 NR3 $T=1029200 266000 0 180 $X=1026100 $Y=260580
X2034 2770 2 2688 2721 635 1 NR3 $T=1042840 286160 0 180 $X=1039740 $Y=280740
X2035 2740 2 2772 639 640 1 NR3 $T=1041600 316400 0 0 $X=1041600 $Y=316020
X2036 2782 2 2677 2771 2773 1 NR3 $T=1045320 276080 1 180 $X=1042220 $Y=275700
X2037 2790 2 2779 2648 2791 1 NR3 $T=1050280 266000 1 180 $X=1047180 $Y=265620
X2038 2742 2 2693 2777 2786 1 NR3 $T=1050280 306320 0 180 $X=1047180 $Y=300900
X2039 2804 2 2688 2628 2796 1 NR3 $T=1054000 266000 1 180 $X=1050900 $Y=265620
X2040 2761 2 538 2818 2785 1 NR3 $T=1058340 255920 1 0 $X=1058340 $Y=250500
X2041 2761 2 2822 2710 2757 1 NR3 $T=1060200 276080 1 0 $X=1060200 $Y=270660
X2042 2822 2 561 2594 2826 1 NR3 $T=1066400 276080 0 180 $X=1063300 $Y=270660
X2043 2832 2 592 2829 2715 1 NR3 $T=1070120 255920 1 180 $X=1067020 $Y=255540
X2044 2850 2 2657 602 2795 1 NR3 $T=1078180 245840 0 180 $X=1075080 $Y=240420
X2045 661 2 685 565 683 1 NR3 $T=1081280 326480 0 180 $X=1078180 $Y=321060
X2046 2789 2 2829 687 689 1 NR3 $T=1079420 286160 0 0 $X=1079420 $Y=285780
X2047 2770 2 2554 2840 2854 1 NR3 $T=1089960 255920 1 180 $X=1086860 $Y=255540
X2048 326 2094 1 325 2024 2081 2 OAI112HS $T=849400 296240 0 180 $X=845060 $Y=290820
X2049 374 371 1 2144 2121 2135 2 OAI112HS $T=860560 306320 0 180 $X=856220 $Y=300900
X2050 359 383 1 2159 2096 2052 2 OAI112HS $T=865520 286160 1 180 $X=861180 $Y=285780
X2051 2147 384 1 2160 2018 2144 2 OAI112HS $T=865520 296240 1 180 $X=861180 $Y=295860
X2052 345 396 1 2228 365 2235 2 OAI112HS $T=877300 306320 0 0 $X=877300 $Y=305940
X2053 408 384 1 428 2280 426 2 OAI112HS $T=888460 326480 1 0 $X=888460 $Y=321060
X2054 2348 2343 1 453 2336 2333 2 OAI112HS $T=913260 286160 1 180 $X=908920 $Y=285780
X2055 2189 2090 1 2168 2384 437 2 OAI112HS $T=927520 276080 1 180 $X=923180 $Y=275700
X2056 417 472 1 2333 2360 2408 2 OAI112HS $T=931240 286160 0 180 $X=926900 $Y=280740
X2057 423 360 1 2434 2430 2202 2 OAI112HS $T=937440 235760 0 180 $X=933100 $Y=230340
X2058 2366 2467 1 480 2398 2460 2 OAI112HS $T=948600 296240 0 180 $X=944260 $Y=290820
X2059 2568 532 1 2669 2674 2649 2 OAI112HS $T=1006260 266000 1 0 $X=1006260 $Y=260580
X2060 592 2587 1 619 663 502 2 OAI112HS $T=1062060 316400 1 0 $X=1062060 $Y=310980
X2061 2727 2868 1 699 2772 2871 2 OAI112HS $T=1090580 306320 1 0 $X=1090580 $Y=300900
X2062 1723 1731 1735 2 1 1706 XOR3S $T=728500 225680 0 0 $X=728500 $Y=225300
X2063 1760 1773 1758 2 1 1803 XOR3S $T=745860 225680 1 0 $X=745860 $Y=220260
X2064 1444 1438 1455 2 1 XNR2HS $T=615660 235760 1 0 $X=615660 $Y=230340
X2065 1441 1461 1465 2 1 XNR2HS $T=620620 245840 1 0 $X=620620 $Y=240420
X2066 1882 1884 1892 2 1 XNR2HS $T=781820 266000 1 0 $X=781820 $Y=260580
X2067 1899 1911 1908 2 1 XNR2HS $T=792360 245840 0 0 $X=792360 $Y=245460
X2068 1962 1960 1953 2 1 XNR2HS $T=812820 235760 0 180 $X=807240 $Y=230340
X2069 237 238 2 1 1689 OR2 $T=721680 296240 1 0 $X=721680 $Y=290820
X2070 402 451 2 1 2354 OR2 $T=912020 316400 0 0 $X=912020 $Y=316020
X2071 2375 2429 2 1 2460 OR2 $T=943640 286160 1 0 $X=943640 $Y=280740
X2072 566 557 2 1 573 OR2 $T=999440 326480 1 0 $X=999440 $Y=321060
X2073 498 524 2 1 575 OR2 $T=1005020 316400 0 180 $X=1002540 $Y=310980
X2074 2743 2825 2 1 2871 OR2 $T=1089960 296240 1 0 $X=1089960 $Y=290820
X2075 1604 220 1 222 220 1617 2 MOAI1S $T=688820 276080 0 0 $X=688820 $Y=275700
X2076 2080 322 1 319 2038 2062 2 MOAI1S $T=845680 266000 0 180 $X=841960 $Y=260580
X2077 329 331 1 326 324 2065 2 MOAI1S $T=848780 316400 1 180 $X=845060 $Y=316020
X2078 2079 2090 1 2098 334 2077 2 MOAI1S $T=846300 255920 1 0 $X=846300 $Y=250500
X2079 2085 2101 1 319 2092 2055 2 MOAI1S $T=850020 266000 0 180 $X=846300 $Y=260580
X2080 330 322 1 336 335 2105 2 MOAI1S $T=847540 306320 1 0 $X=847540 $Y=300900
X2081 338 342 1 337 335 2046 2 MOAI1S $T=851880 306320 1 180 $X=848160 $Y=305940
X2082 329 338 1 341 345 2064 2 MOAI1S $T=848780 296240 0 0 $X=848780 $Y=295860
X2083 314 2125 1 389 393 2027 2 MOAI1S $T=864280 306320 0 0 $X=864280 $Y=305940
X2084 399 355 1 2179 333 2156 2 MOAI1S $T=869240 316400 0 180 $X=865520 $Y=310980
X2085 399 354 1 396 395 2033 2 MOAI1S $T=869860 326480 0 180 $X=866140 $Y=321060
X2086 2197 372 1 2208 2179 2220 2 MOAI1S $T=871720 276080 0 0 $X=871720 $Y=275700
X2087 2196 430 1 2277 2194 2263 2 MOAI1S $T=894040 276080 1 180 $X=890320 $Y=275700
X2088 2293 2100 1 2288 343 2285 2 MOAI1S $T=897760 255920 0 180 $X=894040 $Y=250500
X2089 442 2307 1 417 436 2282 2 MOAI1S $T=900860 286160 0 180 $X=897140 $Y=280740
X2090 2368 2212 1 2358 2179 2048 2 MOAI1S $T=917600 266000 0 180 $X=913880 $Y=260580
X2091 2138 2371 1 374 2379 2378 2 MOAI1S $T=917600 296240 0 0 $X=917600 $Y=295860
X2092 2129 2459 1 345 2417 2454 2 MOAI1S $T=944880 306320 0 180 $X=941160 $Y=300900
X2093 2168 2466 1 2468 370 2173 2 MOAI1S $T=945500 245840 0 0 $X=945500 $Y=245460
X2094 399 331 1 2472 2223 494 2 MOAI1S $T=955420 326480 1 0 $X=955420 $Y=321060
X2095 2129 2501 1 487 418 2497 2 MOAI1S $T=961000 306320 1 180 $X=957280 $Y=305940
X2096 536 2549 1 2562 524 528 2 MOAI1S $T=985800 316400 0 180 $X=982080 $Y=310980
X2097 2577 535 1 498 2556 530 2 MOAI1S $T=986420 306320 0 180 $X=982700 $Y=300900
X2098 2579 2587 1 2578 534 2575 2 MOAI1S $T=989520 276080 1 180 $X=985800 $Y=275700
X2099 2624 2680 1 498 2671 2694 2 MOAI1S $T=1010600 316400 1 0 $X=1010600 $Y=310980
X2100 2610 2742 1 2737 596 2711 2 MOAI1S $T=1031060 296240 1 180 $X=1027340 $Y=295860
X2101 2768 539 1 2762 544 2748 2 MOAI1S $T=1041600 276080 1 180 $X=1037880 $Y=275700
X2102 594 633 1 2749 621 2760 2 MOAI1S $T=1042840 306320 0 180 $X=1039120 $Y=300900
X2103 619 2836 1 2839 559 2592 2 MOAI1S $T=1071360 266000 1 0 $X=1071360 $Y=260580
X2104 2607 2840 1 573 693 688 2 MOAI1S $T=1087480 316400 1 180 $X=1083760 $Y=316020
X2105 2607 2861 1 665 658 698 2 MOAI1S $T=1088100 316400 0 0 $X=1088100 $Y=316020
X2106 403 371 1 407 336 2 2213 2204 2179 OAI222S $T=871100 316400 1 0 $X=871100 $Y=310980
X2107 402 417 1 405 336 2 404 2224 345 OAI222S $T=882880 306320 0 180 $X=877300 $Y=300900
X2108 324 424 1 2106 2163 2 427 2157 410 OAI222S $T=884740 316400 0 0 $X=884740 $Y=316020
X2109 2385 2357 1 2316 321 2 2405 2391 2233 OAI222S $T=921940 286160 0 0 $X=921940 $Y=285780
X2110 2316 444 1 2417 417 2 471 2393 405 OAI222S $T=932480 316400 0 180 $X=926900 $Y=310980
X2111 2376 387 1 2182 333 2 2400 2456 359 OAI222S $T=947360 235760 1 180 $X=941780 $Y=235380
X2112 2476 2179 1 324 421 2 435 2462 371 OAI222S $T=949840 316400 1 180 $X=944260 $Y=316020
X2113 2504 2163 1 496 345 2 319 497 2512 OAI222S $T=959760 316400 0 0 $X=959760 $Y=316020
X2114 416 2223 1 2516 2366 2 2514 2108 2179 OAI222S $T=969680 286160 1 180 $X=964100 $Y=285780
X2115 2510 2348 1 319 2521 2 2414 2515 2223 OAI222S $T=965340 296240 0 0 $X=965340 $Y=295860
X2116 2524 343 1 2539 370 2 2532 2536 379 OAI222S $T=974640 266000 1 0 $X=974640 $Y=260580
X2117 2672 544 1 2658 559 2 2650 2663 545 OAI222S $T=1009980 296240 0 180 $X=1004400 $Y=290820
X2118 2653 581 1 2586 569 2 2675 2664 588 OAI222S $T=1006260 266000 0 0 $X=1006260 $Y=265620
X2119 2660 577 1 583 573 2 498 587 2661 OAI222S $T=1006260 326480 1 0 $X=1006260 $Y=321060
X2120 513 601 1 2679 2727 2 2723 611 596 OAI222S $T=1020520 306320 0 0 $X=1020520 $Y=305940
X2121 2662 593 1 605 514 2 584 2740 597 OAI222S $T=1024860 316400 0 0 $X=1024860 $Y=316020
X2122 2847 647 1 498 2851 2 2692 2848 601 OAI222S $T=1077560 296240 0 0 $X=1077560 $Y=295860
X2123 1367 2 156 1 1378 NR2P $T=593960 316400 1 180 $X=590240 $Y=316020
X2124 1367 2 159 1 1388 NR2P $T=593960 316400 1 0 $X=593960 $Y=310980
X2125 1367 2 160 1 1391 NR2P $T=597680 316400 1 180 $X=593960 $Y=316020
X2126 1442 2 1459 1 1419 NR2P $T=619380 255920 1 0 $X=619380 $Y=250500
X2127 254 2 256 1 1748 NR2P $T=743380 326480 1 0 $X=743380 $Y=321060
X2128 1883 2 1881 1 1887 NR2P $T=784920 286160 0 0 $X=784920 $Y=285780
X2129 1973 2 1956 1 1990 NR2P $T=819640 266000 0 0 $X=819640 $Y=265620
X2130 1973 2 1977 1 2002 NR2P $T=823980 276080 0 0 $X=823980 $Y=275700
X2131 2060 2 319 1 314 NR2P $T=844440 276080 0 180 $X=840720 $Y=270660
X2132 2244 2 2218 1 2251 NR2P $T=885360 235760 0 180 $X=881640 $Y=230340
X2133 2189 2 2218 1 353 NR2P $T=986420 245840 0 0 $X=986420 $Y=245460
X2134 2566 2 498 1 551 NR2P $T=992000 316400 0 180 $X=988280 $Y=310980
X2135 1913 152 1 2 BUF2 $T=794840 296240 0 180 $X=791740 $Y=290820
X2136 1994 247 1 2 BUF2 $T=821500 286160 0 180 $X=818400 $Y=280740
X2137 374 341 2194 2191 361 383 2 1 2031 OA222S $T=872960 286160 1 180 $X=867380 $Y=285780
X2138 374 404 2163 333 370 383 2 1 2174 OA222S $T=872960 296240 1 180 $X=867380 $Y=295860
X2139 379 2243 390 2238 387 2232 2 1 2130 OA222S $T=884120 225680 0 180 $X=878540 $Y=220260
X2140 2260 384 2248 2233 383 318 2 1 2235 OA222S $T=888460 296240 0 180 $X=882880 $Y=290820
X2141 376 2194 417 486 2163 2382 2 1 2488 OA222S $T=946120 316400 1 0 $X=946120 $Y=310980
X2142 605 2701 566 595 593 2604 2 1 591 OA222S $T=1017420 326480 0 180 $X=1011840 $Y=321060
X2143 1245 1247 1 1230 2 1224 OAI12HS $T=551180 296240 0 180 $X=547460 $Y=290820
X2144 1245 1237 1 1227 2 1238 OAI12HS $T=552420 296240 1 180 $X=548700 $Y=295860
X2145 1710 1725 1 1732 2 1737 OAI12HS $T=725400 286160 1 0 $X=725400 $Y=280740
X2146 1895 1880 1 1889 2 1877 OAI12HS $T=788020 245840 0 180 $X=784300 $Y=240420
X2147 1980 1984 1 1988 2 1967 OAI12HS $T=815920 316400 1 0 $X=815920 $Y=310980
X2148 1833 1836 1 1887 2 1900 OAI12HS $T=825840 276080 1 0 $X=825840 $Y=270660
X2149 2023 1995 1 2008 2 2007 OAI12HS $T=832660 235760 1 180 $X=828940 $Y=235380
X2150 477 2431 1 397 2 2408 OAI12HS $T=935580 286160 1 180 $X=931860 $Y=285780
X2151 2551 2647 1 570 2 580 OAI12HS $T=1001920 326480 1 0 $X=1001920 $Y=321060
X2152 2053 1 2075 2019 310 2 ND3S $T=839480 316400 0 180 $X=837000 $Y=310980
X2153 2037 1 2044 2034 2035 2 ND3S $T=840100 306320 0 180 $X=837620 $Y=300900
X2154 2147 1 376 2133 364 2 ND3S $T=859320 266000 1 180 $X=856840 $Y=265620
X2155 2106 1 431 2101 2251 2 ND3S $T=895280 266000 0 180 $X=892800 $Y=260580
X2156 2323 1 2251 2317 2314 2 ND3S $T=905200 235760 1 180 $X=902720 $Y=235380
X2157 2365 1 2109 2337 2356 2 ND3S $T=916980 245840 0 180 $X=914500 $Y=240420
X2158 2356 1 321 2373 320 2 ND3S $T=916980 255920 1 0 $X=916980 $Y=250500
X2159 2239 1 2356 2206 2389 2 ND3S $T=917600 255920 0 0 $X=917600 $Y=255540
X2160 2356 1 2397 2412 2295 2 ND3S $T=927520 255920 0 0 $X=927520 $Y=255540
X2161 2419 1 425 2416 2248 2 ND3S $T=931240 255920 0 180 $X=928760 $Y=250500
X2162 2508 1 2349 2501 2419 2 ND3S $T=964100 276080 1 180 $X=961620 $Y=275700
X2163 353 1 2060 2528 411 2 ND3S $T=969680 266000 0 0 $X=969680 $Y=265620
X2164 2545 1 2527 2622 2566 2 ND3S $T=992000 296240 1 0 $X=992000 $Y=290820
X2165 576 1 2540 2641 2545 2 ND3S $T=1003780 276080 0 180 $X=1001300 $Y=270660
X2166 2662 1 2566 2659 569 2 ND3S $T=1007500 316400 1 180 $X=1005020 $Y=316020
X2167 579 1 582 2680 2656 2 ND3S $T=1008120 306320 0 0 $X=1008120 $Y=305940
X2168 2720 1 2656 2732 2702 2 ND3S $T=1023620 266000 0 0 $X=1023620 $Y=265620
X2169 2737 1 2701 2731 2726 2 ND3S $T=1029200 306320 0 180 $X=1026720 $Y=300900
X2170 2696 1 2755 2682 2759 2 ND3S $T=1036020 286160 1 0 $X=1036020 $Y=280740
X2171 2755 1 2783 2780 2604 2 ND3S $T=1047800 286160 1 180 $X=1045320 $Y=285780
X2172 2755 1 514 2789 2540 2 ND3S $T=1046560 286160 1 0 $X=1046560 $Y=280740
X2173 2794 1 507 2790 617 2 ND3S $T=1052140 276080 1 180 $X=1049660 $Y=275700
X2174 2867 1 2619 2861 2794 2 ND3S $T=1093060 286160 0 180 $X=1090580 $Y=280740
X2175 332 2061 343 2113 350 2122 1 2 2124 OA222 $T=849400 235760 1 0 $X=849400 $Y=230340
X2176 2180 2182 350 2175 332 2195 1 2 2205 OA222 $T=866760 235760 1 0 $X=866760 $Y=230340
X2177 376 2179 2104 2192 374 402 1 2 2097 OA222 $T=874200 286160 0 180 $X=868620 $Y=280740
X2178 326 413 2223 2126 392 410 1 2 2035 OA222 $T=880400 296240 1 180 $X=874820 $Y=295860
X2179 2163 412 2180 2192 2179 408 1 2 2153 OA222 $T=881640 286160 0 180 $X=876060 $Y=280740
X2180 345 341 2233 416 326 419 1 2 2255 OA222 $T=877920 316400 1 0 $X=877920 $Y=310980
X2181 2223 2245 2179 2253 2163 2249 1 2 420 OA222 $T=888460 266000 0 180 $X=882880 $Y=260580
X2182 2233 416 423 2256 320 2192 1 2 2165 OA222 $T=889700 286160 0 180 $X=884120 $Y=280740
X2183 334 2271 2273 2276 360 2284 1 2 2278 OA222 $T=889080 245840 1 0 $X=889080 $Y=240420
X2184 434 2223 425 2194 381 387 1 2 328 OA222 $T=895900 306320 0 180 $X=890320 $Y=300900
X2185 425 2308 2179 2299 2294 434 1 2 2158 OA222 $T=901480 286160 1 180 $X=895900 $Y=285780
X2186 418 407 438 439 404 443 1 2 446 OA222 $T=897140 326480 1 0 $X=897140 $Y=321060
X2187 418 439 451 438 2163 2341 1 2 2332 OA222 $T=906440 306320 0 0 $X=906440 $Y=305940
X2188 404 388 2260 384 374 438 1 2 2350 OA222 $T=906440 316400 1 0 $X=906440 $Y=310980
X2189 390 2352 359 2346 343 2344 1 2 2210 OA222 $T=915740 225680 0 180 $X=910160 $Y=220260
X2190 345 462 2316 2339 2357 2347 1 2 456 OA222 $T=918220 306320 0 180 $X=912640 $Y=300900
X2191 421 459 2233 2180 2366 353 1 2 2363 OA222 $T=913260 316400 1 0 $X=913260 $Y=310980
X2192 2233 2377 2357 2369 2147 2192 1 2 2362 OA222 $T=921320 286160 0 180 $X=915740 $Y=280740
X2193 2316 2420 413 473 2357 2295 1 2 470 OA222 $T=932480 296240 1 180 $X=926900 $Y=295860
X2194 380 2415 390 2422 350 2428 1 2 2434 OA222 $T=929380 225680 0 0 $X=929380 $Y=225300
X2195 2379 335 326 2421 2433 319 1 2 2444 OA222 $T=933100 296240 0 0 $X=933100 $Y=295860
X2196 359 2442 370 2438 379 2436 1 2 2433 OA222 $T=939300 266000 0 180 $X=933720 $Y=260580
X2197 417 371 392 337 418 345 1 2 2481 OA222 $T=940540 306320 0 0 $X=940540 $Y=305940
X2198 487 454 2233 2443 392 478 1 2 2445 OA222 $T=951080 306320 0 180 $X=945500 $Y=300900
X2199 2429 2465 2348 2473 2194 2477 1 2 2446 OA222 $T=946120 286160 1 0 $X=946120 $Y=280740
X2200 387 2471 343 2474 390 2478 1 2 2484 OA222 $T=946740 225680 1 0 $X=946740 $Y=220260
X2201 350 2453 359 2475 390 2479 1 2 2298 OA222 $T=946740 235760 1 0 $X=946740 $Y=230340
X2202 434 2233 2194 2472 2429 2482 1 2 2486 OA222 $T=948600 296240 0 0 $X=948600 $Y=295860
X2203 2423 335 2163 2483 392 489 1 2 491 OA222 $T=949840 326480 1 0 $X=949840 $Y=321060
X2204 393 488 392 2432 2223 2489 1 2 2490 OA222 $T=950460 316400 0 0 $X=950460 $Y=316020
X2205 412 2366 2429 416 444 2192 1 2 2500 OA222 $T=954180 296240 0 0 $X=954180 $Y=295860
X2206 392 424 333 2179 2163 2503 1 2 2509 OA222 $T=956660 306320 1 0 $X=956660 $Y=300900
X2207 2429 2260 2366 2502 484 2348 1 2 2148 OA222 $T=957900 286160 0 0 $X=957900 $Y=285780
X2208 2522 319 2348 2513 418 451 1 2 2492 OA222 $T=969060 306320 1 180 $X=963480 $Y=305940
X2209 360 2506 379 2518 350 2535 1 2 2542 OA222 $T=970920 235760 1 0 $X=970920 $Y=230340
X2210 359 2526 370 2523 379 2519 1 2 2522 OA222 $T=979600 255920 1 180 $X=974020 $Y=255540
X2211 2223 411 2366 2534 2163 2541 1 2 2487 OA222 $T=974020 286160 0 0 $X=974020 $Y=285780
X2212 359 2507 379 2544 370 2531 1 2 2521 OA222 $T=980840 255920 0 180 $X=975260 $Y=250500
X2213 525 529 531 2558 534 2570 1 2 541 OA222 $T=980840 326480 1 0 $X=980840 $Y=321060
X2214 534 2593 2596 2598 532 2602 1 2 2617 OA222 $T=989520 255920 1 0 $X=989520 $Y=250500
X2215 564 2564 544 2640 574 2645 1 2 2654 OA222 $T=999440 255920 0 0 $X=999440 $Y=255540
X2216 545 2638 560 2666 581 2673 1 2 2644 OA222 $T=1005640 245840 1 0 $X=1005640 $Y=240420
X2217 585 2586 574 2684 564 2690 1 2 2691 OA222 $T=1009360 255920 0 0 $X=1009360 $Y=255540
X2218 601 2695 596 2697 577 2626 1 2 590 OA222 $T=1017420 306320 0 180 $X=1011840 $Y=300900
X2219 597 2614 593 2705 518 604 1 2 2689 OA222 $T=1014940 316400 0 0 $X=1014940 $Y=316020
X2220 531 2719 560 2715 574 2707 1 2 2669 OA222 $T=1023620 266000 0 180 $X=1018040 $Y=260580
X2221 573 606 605 2717 593 2724 1 2 609 OA222 $T=1018660 326480 1 0 $X=1018660 $Y=321060
X2222 560 2750 588 2758 544 2763 1 2 2686 OA222 $T=1035400 245840 1 0 $X=1035400 $Y=240420
X2223 574 2776 588 2785 560 2788 1 2 2611 OA222 $T=1044700 255920 1 0 $X=1044700 $Y=250500
X2224 507 624 596 2787 627 550 1 2 641 OA222 $T=1050900 326480 0 180 $X=1045320 $Y=321060
X2225 597 513 2568 2786 2540 604 1 2 642 OA222 $T=1052140 306320 1 180 $X=1046560 $Y=305940
X2226 581 2773 544 2795 560 2800 1 2 2814 OA222 $T=1049660 235760 0 0 $X=1049660 $Y=235380
X2227 601 2527 2727 2807 577 2775 1 2 2819 OA222 $T=1054000 296240 0 0 $X=1054000 $Y=295860
X2228 2827 498 647 2816 658 656 1 2 651 OA222 $T=1063300 326480 0 180 $X=1057720 $Y=321060
X2229 588 2806 559 2805 545 2803 1 2 669 OA222 $T=1060820 276080 0 0 $X=1060820 $Y=275700
X2230 532 2809 545 2830 574 2828 1 2 2824 OA222 $T=1070120 245840 0 180 $X=1064540 $Y=240420
X2231 665 667 597 2812 670 671 1 2 2834 OA222 $T=1065780 326480 1 0 $X=1065780 $Y=321060
X2232 2825 599 2727 2813 518 647 1 2 666 OA222 $T=1071980 296240 0 180 $X=1066400 $Y=290820
X2233 577 2550 585 604 596 512 1 2 674 OA222 $T=1067640 316400 0 0 $X=1067640 $Y=316020
X2234 550 597 621 676 2825 2838 1 2 2823 OA222 $T=1076940 306320 0 180 $X=1071360 $Y=300900
X2235 2825 2837 647 2843 621 2842 1 2 2844 OA222 $T=1071980 296240 0 0 $X=1071980 $Y=295860
X2236 678 681 597 585 2727 2545 1 2 692 OA222 $T=1075700 316400 0 0 $X=1075700 $Y=316020
X2237 588 2856 559 2855 545 2853 1 2 2827 OA222 $T=1086240 255920 0 180 $X=1080660 $Y=250500
X2238 588 2857 545 2841 559 2854 1 2 2851 OA222 $T=1086240 255920 1 180 $X=1080660 $Y=255540
X2239 670 525 569 596 577 2859 1 2 2849 OA222 $T=1082520 316400 1 0 $X=1082520 $Y=310980
X2240 2550 2727 2825 513 519 604 1 2 2852 OA222 $T=1089340 306320 0 180 $X=1083760 $Y=300900
X2241 2225 2060 2195 2 1 2126 AN3 $T=878540 255920 1 180 $X=874820 $Y=255540
X2242 2246 2241 2236 2 1 2082 AN3 $T=882880 286160 1 180 $X=879160 $Y=285780
X2243 2350 2363 2367 2 1 463 AN3 $T=915120 316400 0 0 $X=915120 $Y=316020
X2244 469 2399 2396 2 1 2052 AN3 $T=926900 326480 0 180 $X=923180 $Y=321060
X2245 2547 2566 2690 2 1 598 AN3 $T=1012460 296240 1 0 $X=1012460 $Y=290820
X2246 379 319 2427 461 1 2 2081 OA13S $T=935580 276080 1 180 $X=931240 $Y=275700
X2247 545 498 2726 614 1 2 613 OA13S $T=1029820 326480 0 180 $X=1025480 $Y=321060
X2248 1389 152 2 1 1292 163 MUX2 $T=597060 326480 1 0 $X=597060 $Y=321060
X2249 1409 166 2 1 1366 1399 MUX2 $T=603260 286160 0 180 $X=598920 $Y=280740
X2250 1414 166 2 1 1357 1403 MUX2 $T=605120 276080 1 180 $X=600780 $Y=275700
X2251 1431 166 2 1 1314 1412 MUX2 $T=609460 286160 0 180 $X=605120 $Y=280740
X2252 1428 1429 2 1 1414 1420 MUX2 $T=610700 276080 1 180 $X=606360 $Y=275700
X2253 174 173 2 1 1425 169 MUX2 $T=613180 306320 0 180 $X=608840 $Y=300900
X2254 169 173 2 1 1453 178 MUX2 $T=613800 306320 0 0 $X=613800 $Y=305940
X2255 1456 166 2 1 1304 1443 MUX2 $T=619380 276080 0 180 $X=615040 $Y=270660
X2256 1410 166 2 1 1393 1450 MUX2 $T=621240 266000 1 180 $X=616900 $Y=265620
X2257 1453 1452 2 1 1451 1448 MUX2 $T=621240 296240 1 180 $X=616900 $Y=295860
X2258 1451 1429 2 1 1413 1462 MUX2 $T=617520 286160 1 0 $X=617520 $Y=280740
X2259 181 173 2 1 1448 177 MUX2 $T=622480 316400 0 180 $X=618140 $Y=310980
X2260 178 173 2 1 1463 181 MUX2 $T=619380 306320 0 0 $X=619380 $Y=305940
X2261 1425 1452 2 1 1467 1463 MUX2 $T=620620 286160 0 0 $X=620620 $Y=285780
X2262 1468 1429 2 1 1410 1458 MUX2 $T=625580 276080 0 180 $X=621240 $Y=270660
X2263 1463 1452 2 1 1420 1471 MUX2 $T=622480 296240 1 0 $X=622480 $Y=290820
X2264 1448 1452 2 1 1458 1472 MUX2 $T=622480 296240 0 0 $X=622480 $Y=295860
X2265 177 173 2 1 1471 183 MUX2 $T=623720 316400 1 0 $X=623720 $Y=310980
X2266 1467 1429 2 1 1460 1473 MUX2 $T=624340 266000 1 0 $X=624340 $Y=260580
X2267 183 173 2 1 1472 187 MUX2 $T=624960 306320 1 0 $X=624960 $Y=300900
X2268 1420 1429 2 1 1412 1479 MUX2 $T=626200 286160 0 0 $X=626200 $Y=285780
X2269 1458 1429 2 1 1443 1484 MUX2 $T=627440 276080 0 0 $X=627440 $Y=275700
X2270 1471 1452 2 1 1473 1482 MUX2 $T=628060 296240 1 0 $X=628060 $Y=290820
X2271 1472 1452 2 1 1462 1487 MUX2 $T=628680 296240 0 0 $X=628680 $Y=295860
X2272 184 173 2 1 1487 189 MUX2 $T=628680 316400 1 0 $X=628680 $Y=310980
X2273 1477 1480 2 1 1315 1491 MUX2 $T=630540 266000 0 0 $X=630540 $Y=265620
X2274 1482 1486 2 1 1479 1497 MUX2 $T=631780 286160 0 0 $X=631780 $Y=285780
X2275 189 173 2 1 1497 188 MUX2 $T=634260 316400 1 0 $X=634260 $Y=310980
X2276 191 173 2 1 1507 194 MUX2 $T=642320 306320 0 0 $X=642320 $Y=305940
X2277 1513 1429 2 1 1518 1523 MUX2 $T=647900 266000 1 0 $X=647900 $Y=260580
X2278 1516 1429 2 1 1528 1523 MUX2 $T=650380 266000 0 0 $X=650380 $Y=265620
X2279 1520 1429 2 1 1541 1523 MUX2 $T=651000 276080 1 0 $X=651000 $Y=270660
X2280 1488 1480 2 1 1540 1523 MUX2 $T=655340 266000 1 0 $X=655340 $Y=260580
X2281 1476 166 2 1 1542 1523 MUX2 $T=655960 286160 1 0 $X=655960 $Y=280740
X2282 1494 166 2 1 1545 1523 MUX2 $T=657200 276080 0 0 $X=657200 $Y=275700
X2283 1499 166 2 1 1556 1523 MUX2 $T=659680 286160 0 0 $X=659680 $Y=285780
X2284 1687 237 2 1 1644 229 MUX2 $T=714860 296240 1 180 $X=710520 $Y=295860
X2285 1690 237 2 1 1643 230 MUX2 $T=716100 316400 0 180 $X=711760 $Y=310980
X2286 1693 237 2 1 1650 232 MUX2 $T=717340 306320 0 180 $X=713000 $Y=300900
X2287 1688 237 2 1 1661 233 MUX2 $T=717340 316400 1 180 $X=713000 $Y=316020
X2288 1692 238 2 1 231 236 MUX2 $T=719200 326480 0 180 $X=714860 $Y=321060
X2289 1713 238 2 1 235 241 MUX2 $T=724780 326480 0 180 $X=720440 $Y=321060
X2290 1719 237 2 1 1656 242 MUX2 $T=725400 306320 1 180 $X=721060 $Y=305940
X2291 1729 238 2 1 239 244 MUX2 $T=730360 306320 0 180 $X=726020 $Y=300900
X2292 1742 247 2 1 243 245 MUX2 $T=730980 316400 0 180 $X=726640 $Y=310980
X2293 1743 247 2 1 1713 246 MUX2 $T=730980 316400 1 180 $X=726640 $Y=316020
X2294 1739 247 2 1 1729 1742 MUX2 $T=735320 296240 1 180 $X=730980 $Y=295860
X2295 1752 252 2 1 246 251 MUX2 $T=739660 316400 1 180 $X=735320 $Y=316020
X2296 253 252 2 1 1742 1752 MUX2 $T=740900 306320 1 180 $X=736560 $Y=305940
X2297 1748 252 2 1 1743 253 MUX2 $T=741520 316400 0 180 $X=737180 $Y=310980
X2298 1840 152 2 1 1793 263 MUX2 $T=769420 316400 0 180 $X=765080 $Y=310980
X2299 1845 152 2 1 1801 262 MUX2 $T=769420 326480 0 180 $X=765080 $Y=321060
X2300 1843 152 2 1 1805 264 MUX2 $T=770040 316400 1 180 $X=765700 $Y=316020
X2301 1854 152 2 1 1835 266 MUX2 $T=771900 306320 0 180 $X=767560 $Y=300900
X2302 1853 152 2 1 1822 267 MUX2 $T=773140 296240 1 180 $X=768800 $Y=295860
X2303 1862 271 2 1 1845 270 MUX2 $T=775000 316400 1 180 $X=770660 $Y=316020
X2304 1858 271 2 1 265 268 MUX2 $T=775620 306320 1 180 $X=771280 $Y=305940
X2305 1872 152 2 1 1851 272 MUX2 $T=779340 296240 1 180 $X=775000 $Y=295860
X2306 1871 277 2 1 273 1870 MUX2 $T=781820 316400 1 180 $X=777480 $Y=316020
X2307 1870 277 2 1 270 274 MUX2 $T=782440 326480 0 180 $X=778100 $Y=321060
X2308 1885 278 2 1 1871 1893 MUX2 $T=783680 316400 1 0 $X=783680 $Y=310980
X2309 1902 277 2 1 275 279 MUX2 $T=788640 326480 0 180 $X=784300 $Y=321060
X2310 1904 278 2 1 1870 1894 MUX2 $T=791740 316400 1 180 $X=787400 $Y=316020
X2311 1896 277 2 1 1858 1902 MUX2 $T=789260 306320 0 0 $X=789260 $Y=305940
X2312 1893 278 2 1 1902 1904 MUX2 $T=789260 316400 1 0 $X=789260 $Y=310980
X2313 1894 278 2 1 279 282 MUX2 $T=794220 326480 0 180 $X=789880 $Y=321060
X2314 1954 166 2 1 1928 288 MUX2 $T=808480 296240 1 180 $X=804140 $Y=295860
X2315 1961 166 2 1 1931 289 MUX2 $T=811580 296240 0 180 $X=807240 $Y=290820
X2316 1967 166 2 1 1926 290 MUX2 $T=812820 306320 1 180 $X=808480 $Y=305940
X2317 1978 166 2 1 1927 292 MUX2 $T=814680 276080 1 180 $X=810340 $Y=275700
X2318 1976 166 2 1 1949 293 MUX2 $T=814680 286160 0 180 $X=810340 $Y=280740
X2319 1969 166 2 1 1929 300 MUX2 $T=814680 306320 0 0 $X=814680 $Y=305940
X2320 1993 192 2 1 295 303 MUX2 $T=820260 326480 1 0 $X=820260 $Y=321060
X2321 212 164 1565 2 1540 1286 1 AO22S $T=669600 276080 1 0 $X=669600 $Y=270660
X2322 1413 166 2 1476 1 1478 MUX2S $T=626200 286160 1 0 $X=626200 $Y=280740
X2323 1460 1480 2 1488 1 1418 MUX2S $T=629920 266000 1 0 $X=629920 $Y=260580
X2324 1462 1429 2 1492 1 1399 MUX2S $T=631780 286160 1 0 $X=631780 $Y=280740
X2325 1412 166 2 1494 1 1490 MUX2S $T=633020 276080 0 0 $X=633020 $Y=275700
X2326 1487 1452 2 1495 1 1484 MUX2S $T=633020 296240 1 0 $X=633020 $Y=290820
X2327 188 173 2 190 1 1495 MUX2S $T=634260 306320 1 0 $X=634260 $Y=300900
X2328 1443 1480 2 1499 1 1502 MUX2S $T=635500 266000 0 0 $X=635500 $Y=265620
X2329 1473 1429 2 1500 1 1491 MUX2S $T=636120 266000 1 0 $X=636120 $Y=260580
X2330 190 173 2 191 1 1498 MUX2S $T=636120 306320 0 0 $X=636120 $Y=305940
X2331 1498 1486 2 1503 1 1506 MUX2S $T=637360 286160 0 0 $X=637360 $Y=285780
X2332 1497 1486 2 1498 1 1500 MUX2S $T=637980 286160 1 0 $X=637980 $Y=280740
X2333 1479 1429 2 1506 1 1403 MUX2S $T=639220 276080 0 0 $X=639220 $Y=275700
X2334 1495 192 2 1507 1 1492 MUX2S $T=639840 306320 1 0 $X=639840 $Y=300900
X2335 1484 1429 2 1510 1 1450 MUX2S $T=641080 266000 0 0 $X=641080 $Y=265620
X2336 1500 1429 2 1513 1 1488 MUX2S $T=642320 266000 1 0 $X=642320 $Y=260580
X2337 1503 1486 2 1514 1 1513 MUX2S $T=642320 296240 1 0 $X=642320 $Y=290820
X2338 1492 1429 2 1515 1 1476 MUX2S $T=642940 286160 0 0 $X=642940 $Y=285780
X2339 1506 1429 2 1516 1 1494 MUX2S $T=644180 276080 0 0 $X=644180 $Y=275700
X2340 1491 1480 2 1518 1 1511 MUX2S $T=644800 255920 0 0 $X=644800 $Y=255540
X2341 1507 192 2 1517 1 1510 MUX2S $T=644800 296240 0 0 $X=644800 $Y=295860
X2342 1510 1429 2 1520 1 1499 MUX2S $T=645420 276080 1 0 $X=645420 $Y=270660
X2343 194 173 2 197 1 1503 MUX2S $T=646040 306320 1 0 $X=646040 $Y=300900
X2344 1517 1486 2 1522 1 1515 MUX2S $T=647900 296240 1 0 $X=647900 $Y=290820
X2345 197 173 2 196 1 1517 MUX2S $T=652240 306320 1 180 $X=647900 $Y=305940
X2346 1515 1429 2 1523 1 1524 MUX2S $T=649140 286160 1 0 $X=649140 $Y=280740
X2347 1399 166 2 1524 1 1526 MUX2S $T=650380 276080 0 0 $X=650380 $Y=275700
X2348 196 173 2 1525 1 1514 MUX2S $T=650380 296240 0 0 $X=650380 $Y=295860
X2349 1403 1480 2 1528 1 1536 MUX2S $T=651620 255920 0 0 $X=651620 $Y=255540
X2350 1514 1486 2 1523 1 1516 MUX2S $T=654100 286160 0 0 $X=654100 $Y=285780
X2351 1523 1445 2 1522 1 1520 MUX2S $T=654100 296240 1 0 $X=654100 $Y=290820
X2352 1450 1480 2 1541 1 1544 MUX2S $T=656580 266000 0 0 $X=656580 $Y=265620
X2353 1525 173 2 1523 1 1522 MUX2S $T=664640 306320 0 180 $X=660300 $Y=300900
X2354 1271 1 1293 1303 2 1248 ND3HT $T=575980 255920 0 180 $X=568540 $Y=250500
X2355 1423 166 1406 1413 2 1 MXL2HS $T=609460 286160 1 180 $X=603880 $Y=285780
X2356 1446 1452 1457 1453 2 1 MXL2HS $T=616280 296240 1 0 $X=616280 $Y=290820
X2357 187 173 1489 184 2 1 MXL2HS $T=630540 306320 0 0 $X=630540 $Y=305940
X2358 291 173 1965 297 2 1 MXL2HS $T=809100 316400 0 0 $X=809100 $Y=316020
X2359 1958 294 1969 1966 2 1 MXL2HS $T=817160 296240 1 180 $X=811580 $Y=295860
X2360 1964 173 1989 1948 2 1 MXL2HS $T=814680 326480 1 0 $X=814680 $Y=321060
X2361 1284 1300 1283 1 2 AN2B1T $T=564820 255920 0 0 $X=564820 $Y=255540
X2362 138 137 140 1 2 AN2B1T $T=568540 326480 1 0 $X=568540 $Y=321060
X2363 1844 1845 1852 1 2 AN2B1T $T=771280 276080 0 0 $X=771280 $Y=275700
X2364 1899 1901 1895 1 2 AN2B1T $T=786780 255920 1 0 $X=786780 $Y=250500
X2365 1883 273 1899 1 2 AN2B1T $T=786780 296240 0 0 $X=786780 $Y=295860
X2366 1979 1967 1986 1 2 AN2B1T $T=815300 245840 0 0 $X=815300 $Y=245460
X2367 162 133 1388 1 2 1411 OA12 $T=607600 296240 1 180 $X=603880 $Y=295860
X2368 1286 164 1434 1 2 1407 OA12 $T=614420 235760 1 180 $X=610700 $Y=235380
X2369 1641 1632 1747 1 2 1755 OA12 $T=734080 286160 1 0 $X=734080 $Y=280740
X2370 285 164 1970 1 2 1919 OA12 $T=815920 266000 0 180 $X=812200 $Y=260580
X2371 380 381 2066 1 2 2144 OA12 $T=864900 306320 0 180 $X=861180 $Y=300900
X2372 1255 1266 1263 2 1275 1286 1 AO22P $T=556140 266000 0 0 $X=556140 $Y=265620
X2373 1237 133 1282 2 1288 134 1 AO22P $T=558620 306320 1 0 $X=558620 $Y=300900
X2374 136 1266 1301 2 1304 1286 1 AO22P $T=564200 296240 1 0 $X=564200 $Y=290820
X2375 139 1311 1266 2 1314 1286 1 AO22P $T=569780 286160 0 0 $X=569780 $Y=285780
X2376 1395 133 1376 2 1378 162 1 AO22P $T=599540 296240 1 0 $X=599540 $Y=290820
X2377 1344 164 1415 2 1419 1286 1 AO22P $T=602640 255920 1 0 $X=602640 $Y=250500
X2378 1377 164 1465 2 1461 1286 1 AO22P $T=624340 235760 0 0 $X=624340 $Y=235380
X2379 1678 1632 1707 2 1708 1641 1 AO22P $T=717960 255920 1 0 $X=717960 $Y=250500
X2380 1724 1632 1728 2 1718 1641 1 AO22P $T=735940 266000 1 180 $X=730360 $Y=265620
X2381 1909 1836 1908 2 1899 1833 1 AO22P $T=796080 235760 1 180 $X=790500 $Y=235380
X2382 1799 164 1953 2 1960 285 1 AO22P $T=807240 235760 0 0 $X=807240 $Y=235380
X2383 1865 164 1981 2 1986 285 1 AO22P $T=814060 235760 1 0 $X=814060 $Y=230340
X2384 1891 285 1995 2 2007 164 1 AO22P $T=823980 235760 1 0 $X=823980 $Y=230340
X2385 1725 1710 1 1720 2 OR2B1S $T=727880 276080 1 180 $X=724780 $Y=275700
X2386 1266 1324 2 1330 1296 1286 1 AOI22H $T=574120 276080 1 0 $X=574120 $Y=270660
X2387 1266 1386 2 1382 1349 1286 1 AOI22H $T=593960 266000 1 0 $X=593960 $Y=260580
X2388 164 1455 2 1438 1449 1286 1 AOI22H $T=621240 235760 1 0 $X=621240 $Y=230340
X2389 164 1982 2 1990 1975 285 1 AOI22H $T=814680 245840 1 0 $X=814680 $Y=240420
X2390 1985 1995 2001 2010 2 1 NR3H $T=823980 255920 1 0 $X=823980 $Y=250500
X2391 1438 1436 1 1442 2 NR2T $T=612560 255920 1 0 $X=612560 $Y=250500
X2392 1461 1464 1 1442 2 NR2T $T=628060 255920 0 180 $X=623100 $Y=250500
X2393 1725 1695 1 1689 2 NR2T $T=723540 286160 0 0 $X=723540 $Y=285780
X2394 1890 1859 1 1883 2 NR2T $T=788020 276080 1 180 $X=783060 $Y=275700
X2395 1948 281 1 198 2 NR2T $T=802280 316400 1 0 $X=802280 $Y=310980
X2396 2000 1991 1 1973 2 NR2T $T=827700 255920 0 0 $X=827700 $Y=255540
X2397 2179 2366 2225 1 2 2449 AO12 $T=943640 296240 0 180 $X=939920 $Y=290820
X2398 486 424 335 1 2 482 AO12 $T=949220 326480 0 180 $X=945500 $Y=321060
X2399 2251 2530 2163 1 2 2464 AO12 $T=972160 276080 0 0 $X=972160 $Y=275700
X2400 2656 2651 577 1 2 2643 AO12 $T=1005640 306320 0 180 $X=1001920 $Y=300900
X2401 596 2727 2547 1 2 2865 AO12 $T=1086860 296240 0 0 $X=1086860 $Y=295860
X2402 1996 301 1 2 INV4 $T=821500 286160 1 0 $X=821500 $Y=280740
X2403 404 439 397 2315 2 1 2309 MAOI1 $T=906440 306320 0 180 $X=901480 $Y=300900
X2404 2294 2320 2164 2325 2 1 2327 MAOI1 $T=902100 276080 1 0 $X=902100 $Y=270660
X2405 627 2703 2657 2765 2 1 2781 MAOI1 $T=1037260 306320 0 0 $X=1037260 $Y=305940
X2406 1739 247 2 1689 1 1747 AN3B2S $T=733460 286160 0 0 $X=733460 $Y=285780
X2407 2031 2046 2 2043 1 2032 AN3B2S $T=841340 296240 1 180 $X=837620 $Y=295860
X2408 316 2057 2 2054 1 2050 AN3B2S $T=843200 306320 1 180 $X=839480 $Y=305940
X2409 2072 2028 2 2064 1 2058 AN3B2S $T=845060 276080 1 180 $X=841340 $Y=275700
X2410 2271 2244 2 2149 1 2232 AN3B2S $T=892800 235760 0 180 $X=889080 $Y=230340
X2411 2353 2470 2 2431 1 2249 AN3B2S $T=949220 266000 1 180 $X=945500 $Y=265620
X2412 2341 2409 2 2293 1 2482 AN3B2S $T=955420 296240 0 180 $X=951700 $Y=290820
X2413 2655 2635 2 2647 1 2626 AN3B2S $T=1006880 296240 1 180 $X=1003160 $Y=295860
X2414 2593 2735 2 2648 1 2673 AN3B2S $T=1031060 245840 1 180 $X=1027340 $Y=245460
X2415 664 2822 2 2768 1 2838 AN3B2S $T=1075080 286160 0 0 $X=1075080 $Y=285780
X2416 2549 522 515 2 2537 1 516 AO112 $T=979600 306320 1 180 $X=974640 $Y=305940
X2417 2022 304 257 1 2 278 QDFFRBT $T=834520 306320 1 180 $X=820880 $Y=305940
X2418 2026 304 257 238 1 2 QDFFRBP $T=831420 286160 1 180 $X=819020 $Y=285780
X2419 2034 304 257 155 1 2 QDFFRBP $T=832040 306320 0 180 $X=819640 $Y=300900
X2420 2030 304 257 252 1 2 QDFFRBP $T=835760 316400 1 180 $X=823360 $Y=316020
X2421 311 2024 2040 2 1 2049 OR3 $T=836380 286160 0 0 $X=836380 $Y=285780
X2422 2090 339 2115 2 1 2114 OR3 $T=850020 266000 0 0 $X=850020 $Y=265620
X2423 450 2368 2181 2 1 2390 OR3 $T=920700 255920 1 0 $X=920700 $Y=250500
X2424 2374 2345 2439 2 1 2331 OR3 $T=938680 225680 0 180 $X=934960 $Y=220260
X2425 549 2610 2594 2 1 2591 OR3 $T=993860 276080 1 180 $X=990140 $Y=275700
X2426 2587 2599 2595 2 1 2609 OR3 $T=991380 306320 1 0 $X=991380 $Y=300900
X2427 2829 608 2818 2 1 2725 OR3 $T=1066400 266000 0 180 $X=1062680 $Y=260580
X2428 1429 1420 1428 2 1430 1330 1 MUXB2 $T=615660 266000 1 180 $X=609460 $Y=265620
X2429 247 1742 1739 2 1689 1718 1 MUXB2 $T=733460 296240 0 180 $X=727260 $Y=290820
X2430 1276 1287 1281 1 2 AN2B1 $T=559860 286160 1 0 $X=559860 $Y=280740
X2431 142 1288 148 1 2 AN2B1 $T=575360 326480 1 0 $X=575360 $Y=321060
X2432 1641 1689 1684 1 2 1701 OR3B1 $T=718580 286160 1 0 $X=718580 $Y=280740
X2433 1833 1883 1859 1 2 1912 OR3B1 $T=788640 276080 0 0 $X=788640 $Y=275700
X2434 285 1973 1977 1 2 1987 OR3B1 $T=813440 266000 0 0 $X=813440 $Y=265620
X2435 133 1358 2 1373 1365 1 AOI12H $T=584040 286160 1 0 $X=584040 $Y=280740
X2436 133 1331 1336 1 2 1338 AO12T $T=577220 296240 1 0 $X=577220 $Y=290820
X2437 377 2141 374 336 2 1 2091 OA112 $T=862420 306320 1 180 $X=857460 $Y=305940
X2438 2075 2185 394 388 2 1 313 OA112 $T=869240 316400 1 180 $X=864280 $Y=316020
X2439 2097 398 394 392 2 1 2146 OA112 $T=870480 306320 0 180 $X=865520 $Y=300900
X2440 2216 2200 394 405 2 1 2029 OA112 $T=876060 306320 0 180 $X=871100 $Y=300900
X2441 426 2237 421 345 2 1 2236 OA112 $T=887840 326480 0 180 $X=882880 $Y=321060
X2442 2135 2300 394 345 2 1 2311 OA112 $T=897140 296240 0 0 $X=897140 $Y=295860
X2443 461 2327 2342 2348 2 1 2335 OA112 $T=916980 276080 1 180 $X=912020 $Y=275700
X2444 2333 2361 451 393 2 1 377 OA112 $T=915120 306320 0 0 $X=915120 $Y=305940
X2445 474 2413 2404 423 2 1 2396 OA112 $T=930620 316400 1 180 $X=925660 $Y=316020
X2446 614 2781 2799 647 2 1 646 OA112 $T=1057720 316400 1 180 $X=1052760 $Y=316020
X2447 672 2821 673 2568 2 1 677 OA112 $T=1070740 316400 1 0 $X=1070740 $Y=310980
X2448 1204 1214 1 2 INV1CK $T=541260 296240 1 0 $X=541260 $Y=290820
X2449 429 2235 374 410 2 1 2254 OA112S $T=891560 306320 1 180 $X=886600 $Y=305940
X2450 2259 357 2280 2 1 2289 OR3S $T=892800 306320 0 0 $X=892800 $Y=305940
X2451 701 2 1 TIE1 $T=1094300 225680 0 180 $X=1092440 $Y=220260
X2452 2308 2382 352 2386 2 1 2387 MAOI1S $T=919460 316400 0 0 $X=919460 $Y=316020
X2453 277 1902 1896 1883 2 1884 1 MUXB2P $T=789880 286160 1 0 $X=789880 $Y=280740
X2454 1910 277 1 2 BUF6 $T=794840 306320 0 180 $X=787400 $Y=300900
X2455 129 1248 1 1233 1252 2 OAI12H $T=551180 255920 0 0 $X=551180 $Y=255540
X2456 1699 1704 1 1714 1688 2 OAI12H $T=718580 316400 1 0 $X=718580 $Y=310980
X2457 155 1874 1 1898 1840 2 OAI12H $T=783060 286160 1 0 $X=783060 $Y=280740
X2458 247 1746 1 1695 2 OR2T $T=730980 316400 1 0 $X=730980 $Y=310980
X2459 4 2 1 TIE0 $T=230020 225680 1 0 $X=230020 $Y=220260
.ENDS
***************************************
.SUBCKT ICV_15 1 8 9 10 11 12 13 14 15 16 17 18 19 20 21 28 29 30 31 46
** N=66 EP=20 IP=64 FDC=0
X0 9 1 1 1 17 1 19 YA2GSD $T=177320 0 0 0 $X=180170 $Y=0
X1 10 1 1 1 18 1 19 YA2GSD $T=277140 0 0 0 $X=279990 $Y=0
X2 11 1 1 1 20 1 19 YA2GSD $T=376960 0 0 0 $X=379810 $Y=0
X3 12 1 1 1 21 1 19 YA2GSD $T=476780 0 0 0 $X=479630 $Y=0
X4 13 1 1 8 28 8 19 YA2GSD $T=776240 0 0 0 $X=779090 $Y=0
X5 14 8 8 8 29 8 19 YA2GSD $T=876060 0 0 0 $X=878910 $Y=0
X6 15 8 8 8 30 8 19 YA2GSD $T=975880 0 0 0 $X=978730 $Y=0
X7 16 8 8 8 31 8 19 YA2GSD $T=1075700 0 0 0 $X=1078550 $Y=0
.ENDS
***************************************
.SUBCKT ICV_16
** N=1 EP=0 IP=0 FDC=0
.ENDS
***************************************
.SUBCKT ICV_17 1 2 3 4 5
** N=6 EP=5 IP=6 FDC=0
X0 3 2 2 1 4 XMD $T=0 1151010 0 270 $X=0 $Y=1091240
.ENDS
***************************************
.SUBCKT ICV_18 1 2 3 4 5 8
** N=10 EP=6 IP=12 FDC=0
X0 1 2 2 2 4 XMD $T=0 982530 0 270 $X=0 $Y=922760
X1 3 2 2 2 5 XMD $T=0 1066770 0 270 $X=0 $Y=1007000
.ENDS
***************************************
.SUBCKT ICV_19 2 3 5 13
** N=14 EP=4 IP=6 FDC=0
X0 2 3 3 3 5 XMD $T=0 814050 0 270 $X=0 $Y=754280
.ENDS
***************************************
.SUBCKT ICV_20 2 3 5 10
** N=17 EP=4 IP=6 FDC=0
X0 2 3 3 3 5 XMD $T=0 561330 0 270 $X=0 $Y=501560
.ENDS
***************************************
.SUBCKT ICV_21 1 2 3 4 5 6
** N=8 EP=6 IP=12 FDC=0
X0 1 2 2 2 4 XMD $T=0 392850 0 270 $X=0 $Y=333080
X1 3 2 2 2 5 XMD $T=0 477090 0 270 $X=0 $Y=417320
.ENDS
***************************************
.SUBCKT ICV_22 1 2 3 4 5 6
** N=8 EP=6 IP=12 FDC=0
X0 2 1 1 1 4 XMD $T=0 224370 0 270 $X=0 $Y=164600
X1 3 1 1 1 5 XMD $T=0 308610 0 270 $X=0 $Y=248840
.ENDS
***************************************
.SUBCKT ICV_23
** N=1 EP=0 IP=0 FDC=0
.ENDS
***************************************
.SUBCKT CHIP o_data[10] o_data[8] i_data[12] clk rst_n i_valid o_ready i_data[0] i_data[1] i_data[2] i_data[3] i_data[4] i_data[5] VCC GND o_data[9] o_data[7] o_data[6] i_ready o_valid
+ o_data[0] o_data[1] o_data[2] o_data[3] o_data[4] o_data[5] i_data[15] i_data[13] i_data[14] i_data[11] i_data[10] i_data[8] i_data[9] i_data[6] i_data[7]
** N=2584 EP=35 IP=5360 FDC=0
X0 o_data[10] 4 1420 236 2584 ICV_1 $T=1315640 1035740 0 90 $X=1176140 $Y=1038590
X1 o_data[8] 33 937 236 2584 ICV_2 $T=1315640 488180 0 90 $X=1176140 $Y=491030
X2 i_data[12] 21 1421 2584 ICV_3 $T=0 898290 0 270 $X=0 $Y=838520
X3 4 clk rst_n i_valid o_ready i_data[0] i_data[1] i_data[2] i_data[3] i_data[4] i_data[5] 53 54 55 56 63 64 65 66 67
+ 1422 2584
+ ICV_4 $T=0 0 0 0 $X=139500 $Y=1173260
X4 GND VCC 4 21 68 69 70 1481 1422 71 72 73 74 75 76 77 1452 53 78 79
+ 80 83 86 81 82 1453 84 85 87 89 88 92 90 91 93 1455 95 1454 94 54
+ 1458 96 1457 1456 97 1430 98 99 100 101 102 1460 103 104 1459 105 107 109 108 110
+ 111 113 112 126 1464 114 1465 1462 1463 1466 1461 1468 115 117 119 123 120 1472 121 106
+ 1467 122 1470 124 125 128 1471 116 127 130 129 131 132 133 55 1473 1469 118 134 135
+ 136 137 138 139 140 141 142 143 144 145 146 165 1474 147 148 150 151 149 152 153
+ 154 155 156 157 158 159 161 162 163 164 160 166 167 168 169 1475 170 171 209 176
+ 1476 172 1477 173 174 175 1478 177 178 1479 179 180 182 181 1480 183 184 210 185 186
+ 187 188 1482 189 192 1483 191 190 198 194 193 195 196 197 199 200 201 202 203 208
+ 204 205 207 206 1484 1485 212 211 213 214 229 1433 215 217 1486 1487 1488 216 218 1489
+ 220 221 219 222 223 224 1490 225 226 227 228 233 234 230 231 232 235 2584
+ ICV_5 $T=0 0 0 0 $X=139500 $Y=1066980
X5 GND VCC 238 237 239 240 241 242 1491 69 265 243 71 1492 1493 68 1494 244 70 245
+ 247 246 73 494 72 252 1497 248 477 75 249 250 1495 1577 1581 1515 1496 251 302 1527
+ 1518 1520 1511 1498 1567 495 292 1513 301 492 253 1522 1499 88 1519 1523 254 77 258 255
+ 256 84 257 74 259 1452 76 1501 260 53 261 262 1500 263 78 266 264 79 80 1503
+ 81 526 523 82 267 268 521 1506 85 1505 271 1502 83 270 87 1504 269 86 272 273
+ 274 275 89 90 277 276 91 92 278 279 281 280 289 93 282 94 1456 95 283 284
+ 285 1507 286 287 97 98 288 1510 540 96 1455 1508 99 1430 1579 100 1457 101 293 102
+ 290 104 1509 103 291 1517 542 1514 1525 307 1516 1530 1459 1521 300 1528 1529 1512 294 304
+ 1466 105 106 1524 107 108 1461 1462 1460 110 303 109 111 113 296 1468 1464 1463 297 299
+ 1465 114 115 1467 305 116 295 309 306 118 1469 119 129 130 122 121 313 1531 125 120
+ 311 1532 312 123 1432 1534 314 1429 124 1540 117 1533 315 1471 1431 126 316 310 131 1539
+ 127 317 320 318 128 1470 319 1535 321 1472 308 1538 1537 323 132 133 324 1536 322 134
+ 325 135 136 326 1541 137 138 330 1544 327 1475 140 328 1549 139 141 1474 1542 329 154
+ 1548 352 331 1480 332 333 142 1543 1545 143 334 1453 335 1546 144 1550 1547 336 337 145
+ 1526 146 338 339 341 361 345 362 340 149 147 150 342 343 344 348 148 151 346 349
+ 1553 153 1551 1552 152 155 350 156 351 165 355 353 1554 347 157 354 160 1555 356 162
+ 357 159 158 358 1556 163 1564 164 161 166 167 168 363 169 1557 1559 170 1560 1561 365
+ 1563 171 209 359 364 1476 1558 360 1562 176 366 172 173 174 1477 175 367 368 1478 183
+ 177 187 178 369 1479 370 1565 371 375 372 1568 373 374 1566 179 378 376 182 1569 1570
+ 377 180 181 1573 1571 1572 379 380 381 1574 388 403 184 382 384 385 386 185 387 186
+ 383 389 1590 390 1580 1578 1481 1482 188 189 191 391 418 1597 1576 392 1583 1582 1584 190
+ 395 393 396 397 1483 394 398 194 1585 192 193 432 198 399 400 401 1589 402 1586 1588
+ 1575 197 195 196 405 201 199 404 200 406 407 1591 203 408 202 1592 409 1594 208 410
+ 1595 205 411 204 414 413 1596 1600 415 206 207 416 1598 412 1599 417 422 210 421 423
+ 420 427 424 1484 1601 1485 1602 1603 429 426 211 213 212 1488 419 428 431 214 1593 433
+ 1604 1606 1605 215 1608 1433 229 1486 217 1487 434 436 437 220 438 1587 216 430 439 435
+ 218 441 425 1607 440 219 442 443 1610 444 1490 445 221 1489 1609 1613 223 222 446 1611
+ 224 225 1612 447 448 226 449 1614 227 1615 450 228 451 233 234 452 454 455 456 457
+ 1616 458 453 230 460 459 231 235 232 461 462 2584
+ ICV_7 $T=0 0 0 0 $X=139500 $Y=880500
X6 GND VCC 237 238 464 465 240 1492 1435 468 1619 466 467 463 1620 239 1618 478 241 1617
+ 1624 243 1621 469 470 242 1623 471 1622 246 472 1494 1625 1626 473 474 244 245 475 477
+ 476 1627 249 494 250 479 247 1628 480 253 251 481 252 254 1497 256 255 482 484 1629
+ 258 495 485 259 486 1632 1630 488 1633 257 1635 1631 487 260 1634 261 262 489 483 490
+ 491 492 1636 1637 263 1499 1646 493 1664 264 1545 557 553 1668 265 496 1666 497 498 499
+ 266 507 279 500 503 1452 505 504 267 1656 287 502 501 269 506 270 268 1503 510 271
+ 508 1504 272 1505 509 275 274 511 1638 273 1639 1640 514 276 512 513 1642 515 1506 1641
+ 78 526 290 518 1643 1644 517 277 280 516 1547 520 521 1507 278 519 284 1682 1645 282
+ 523 522 524 525 540 1647 281 1650 1653 530 1676 1649 283 532 527 529 528 53 1648 1651
+ 531 1436 533 534 1652 536 535 285 286 288 1654 538 1655 537 289 539 544 106 541 1657
+ 1512 571 542 1509 1528 1516 1456 1508 1521 543 1660 1510 545 1659 546 1661 1662 547 311 548
+ 1658 1437 1663 550 551 549 293 295 300 552 296 1519 1524 554 1665 555 556 297 1522 291
+ 560 558 1667 298 299 559 301 1669 1466 561 562 306 563 1864 294 1860 1670 1529 1866 1677
+ 564 1760 322 303 565 1675 304 305 1671 566 567 307 308 1692 569 570 568 573 574 2462
+ 310 1678 572 1684 312 579 313 577 1673 578 1421 1534 314 1766 580 600 1434 1679 586 575
+ 1697 1698 1696 1717 588 1439 1690 1470 317 598 1700 1681 583 1691 1704 584 1694 1699 1701 581
+ 585 618 1538 1674 582 321 1672 1706 1695 1702 324 326 318 315 1687 1535 640 1709 2464 1537
+ 320 1708 1712 1536 1693 939 587 1688 1703 609 1705 1707 1716 323 2463 1714 1685 2486 589 2474
+ 590 1713 1715 1444 1722 591 622 319 593 2470 599 1718 592 1719 2476 2471 616 595 2473 1542
+ 325 1686 2469 1546 594 1710 596 597 1729 1541 1723 607 658 2467 1720 1540 2472 1758 64 1725
+ 1730 1775 601 576 1724 1683 2477 1727 602 625 2466 1689 603 604 65 63 1726 56 1680 1543
+ 605 1443 606 1733 1734 615 1732 2475 2465 1802 327 613 650 316 67 639 627 1763 608 1739
+ 66 1738 1750 1771 328 610 1736 1767 2468 611 2488 1711 612 624 1745 329 1744 1742 2485 351
+ 1759 1741 1743 1737 1740 330 1779 1746 1747 1751 1748 621 1544 331 641 332 614 1721 643 1539
+ 333 1749 2479 1728 1757 334 1784 2487 2480 2478 1753 619 620 1776 1752 628 2481 629 1754 1474
+ 1735 1756 626 1755 623 2483 336 335 1549 154 1773 636 1789 1548 1761 1731 1772 1765 1822 337
+ 1764 1786 631 632 1796 2484 634 338 635 1762 339 633 653 341 1768 656 361 2482 1783 637
+ 1769 630 644 638 340 1785 1816 663 342 2489 642 1770 345 1550 1562 1800 2491 362 645 2490
+ 646 1780 1794 343 1774 344 1560 647 348 617 346 1777 1810 648 649 1778 661 149 1781 669
+ 1795 165 651 1558 347 1799 654 1438 1798 1782 652 1790 1551 349 655 659 1788 1787 1797 657
+ 1559 1553 1793 1792 1791 352 660 662 1557 1554 1552 355 664 353 665 354 667 358 666 1801
+ 356 668 1555 357 670 671 1803 672 1811 1556 359 360 673 679 350 685 698 1588 690 675
+ 674 407 677 676 1813 1812 680 681 363 683 682 678 689 364 1814 1563 684 686 1815 1561
+ 405 366 1817 687 365 688 1819 706 376 1820 1575 367 1564 368 1821 1818 691 693 1829 694
+ 369 1566 695 370 1823 697 371 1824 373 700 374 1568 696 1565 375 1570 1826 1808 1825 390
+ 372 1839 377 1805 388 692 1807 1806 378 1804 1569 381 1836 379 387 1571 699 1827 1831 1572
+ 1833 380 1828 1573 701 382 383 384 702 1809 710 385 1830 757 1574 1567 386 1580 1832 716
+ 714 1530 704 705 703 1576 1592 712 711 707 302 1577 708 397 1578 1842 399 1835 1837 1579
+ 1838 713 715 1582 1841 709 1581 1834 1527 1584 1847 395 1583 398 392 393 1840 394 1852 1585
+ 1587 1843 1586 401 1844 1601 1845 402 718 1602 717 719 724 720 1590 721 403 770 404 769
+ 722 723 1589 1846 739 766 729 396 725 391 389 1851 1856 406 726 1591 727 1600 400 728
+ 737 1848 1593 1594 409 415 730 1849 1595 731 1850 416 411 732 1598 733 734 1596 1597 412
+ 755 410 751 738 414 736 735 1853 428 417 408 424 418 419 740 1854 420 422 421 1599
+ 741 747 742 743 744 745 749 423 746 1865 1857 748 425 750 426 427 752 1859 1603 754
+ 1863 753 1862 760 1861 1855 429 1605 758 1606 1604 413 1869 756 1867 430 768 431 1609 436
+ 759 432 1858 433 1616 435 1872 437 438 761 1871 763 1868 764 765 1876 762 439 1874 1873
+ 1875 1870 1878 1607 441 767 1877 443 444 1879 440 434 772 445 782 776 446 771 773 775
+ 774 1611 1612 778 777 779 780 448 1614 1613 1610 783 451 449 1608 456 781 1615 450 452
+ 454 787 447 442 453 784 1880 785 457 792 455 786 460 790 459 458 788 462 789 791
+ 461 793 2584
+ ICV_8 $T=0 0 0 0 $X=139500 $Y=699060
X7 GND VCC 797 798 795 1885 851 464 1881 1886 1883 465 1896 1889 1617 802 463 466 811 794
+ 796 469 823 858 1882 1491 1622 832 1435 799 467 850 1910 859 2498 800 803 1619 801 1975
+ 840 1914 1620 1891 854 1892 1893 468 805 1624 1890 471 1920 1618 1621 1884 470 1894 1919 1623
+ 818 806 1493 472 1625 1898 1903 1932 473 1895 1899 2492 804 1897 2511 477 1888 2499 2505 1923
+ 239 1627 2493 1495 1626 808 1905 2497 474 837 2502 1902 1921 809 1900 2504 810 1907 1901 813
+ 812 2507 476 822 1906 852 1496 2496 817 1909 1908 814 2501 1973 816 1911 2503 479 1922 2515
+ 481 478 821 1917 831 1929 820 1497 815 857 1505 1904 1913 480 824 1927 2494 1915 819 1950
+ 492 826 825 835 827 1918 1930 1980 1912 2500 1498 1628 1926 829 828 1936 1916 1974 1633 482
+ 1959 1635 1629 833 1924 855 486 483 484 1630 2495 1970 1928 1943 1931 487 834 1887 485 1632
+ 1962 1925 488 1933 1634 1631 836 1941 2510 1499 1637 1934 1500 2508 489 841 1935 490 1938 1636
+ 830 1937 1972 491 1976 2506 1940 838 1969 2512 1947 1939 493 1501 839 2514 1942 495 2509 1945
+ 494 842 1658 475 1661 843 1437 844 1948 2513 1662 1949 496 1951 849 507 1966 848 845 1953
+ 497 846 1946 1952 847 1956 1954 498 1958 508 499 1955 502 1960 1957 500 1961 1502 1964 501
+ 1944 503 1965 2011 1967 1963 526 853 521 856 504 1968 505 807 506 1971 1678 1506 1440 1979
+ 1977 1978 510 864 861 1995 2516 860 865 862 866 863 1643 867 2006 870 509 869 1981 2001
+ 1639 511 2023 871 879 868 1640 1638 515 513 1644 1982 1642 1641 514 1983 512 518 1984 517
+ 516 2003 1985 520 2108 1986 872 1987 2017 524 519 873 1645 874 2056 522 2025 523 1988 1990
+ 525 875 877 553 882 915 883 878 1993 880 2028 527 876 528 913 1216 529 1648 914 1649
+ 1647 534 530 531 1650 532 1651 2079 533 2008 881 1436 1992 888 2037 535 1652 536 1989 911
+ 899 902 571 1514 1654 1653 2005 537 1517 2031 1657 1655 538 1525 539 540 541 300 542 543
+ 544 1660 545 884 1659 885 1512 891 546 886 547 887 548 1663 549 550 1994 1991 1998 2004
+ 551 2002 1646 1997 892 1999 552 889 1664 554 890 1665 2012 555 309 895 556 1666 2000 893
+ 557 558 559 1667 896 560 2007 1668 904 905 561 897 898 562 1669 1677 908 2010 563 1670
+ 2013 2019 900 901 2052 564 2014 1671 565 906 903 2015 1675 566 2016 1692 2022 907 568 567
+ 569 2020 2064 2018 909 1673 910 572 573 574 1531 2027 912 1684 1696 2029 1691 1532 312 1682
+ 575 2466 576 1442 570 1699 1534 314 2030 1697 579 580 578 1685 2476 1713 640 2195 581 586
+ 2024 1704 2120 1695 1686 1708 2474 583 618 1533 597 582 1441 2026 1148 1733 1996 1674 1676 916
+ 2032 585 1694 1700 1693 1672 1690 2122 2034 638 2465 918 588 2036 1681 1710 2035 2043 2021 1687
+ 2033 593 587 2009 1701 2464 2038 1683 917 1703 1725 1688 600 603 1707 2039 2041 1702 1737 1454
+ 2468 1149 1770 2042 2040 1709 2469 1689 1732 584 2477 1748 1722 609 1706 1717 2470 1750 1728 2463
+ 2044 1711 2046 2473 1715 1716 1680 650 599 2048 1712 590 1764 2051 1714 2045 987 2047 591 919
+ 1721 589 2471 1720 592 1734 1719 616 939 594 2462 1718 2475 2050 654 1698 2112 622 921 601
+ 2049 923 598 1723 2467 1743 1724 1730 1727 2472 1731 2479 615 602 1726 1744 595 2484 648 924
+ 931 1746 922 1705 2072 1729 605 1735 606 1780 1753 2053 925 1473 2054 627 607 926 639 608
+ 927 928 636 624 631 642 610 1736 1738 930 1741 1742 2485 1740 613 612 929 1745 1757 614
+ 1747 1749 936 1773 621 2478 1751 920 2480 1458 932 2488 1786 625 617 620 934 1784 2481 1752
+ 619 643 933 2487 628 1538 1754 2482 2489 623 1755 935 1798 1789 604 1795 1775 644 1758 641
+ 941 1794 626 629 1761 1762 1756 1679 630 1739 1763 292 1767 1420 1796 633 2057 632 651 635
+ 2483 1765 940 1511 1515 1785 2055 637 1513 1774 942 656 634 2060 946 1768 2061 948 945 1771
+ 645 1779 1769 943 944 2486 938 1539 2491 1797 2490 2063 646 1776 947 647 2066 2062 1778 2065
+ 2058 1830 2059 649 1777 1518 1520 1807 1772 1523 1781 949 611 953 950 760 652 653 952 951
+ 1760 655 1438 1783 1530 1787 658 1809 2067 1579 1788 2068 1790 1816 955 1540 659 1791 1759 1870
+ 954 657 962 1834 660 661 956 669 1804 662 1782 1792 959 970 1793 958 963 2070 1855 2104
+ 957 1766 1815 1799 961 960 664 663 1656 2074 665 1805 1806 681 1808 666 667 668 967 1802
+ 2073 964 1800 670 2069 966 672 1801 1803 965 1817 2071 968 673 671 969 674 2075 971 1811
+ 1810 677 2076 675 1819 2077 676 972 973 975 678 974 2078 1812 679 680 976 2101 758 1841
+ 2080 1814 2081 1813 683 1818 977 978 2082 684 1823 1840 2084 685 682 1839 713 688 687 686
+ 689 979 2083 980 986 1820 1824 982 690 693 984 985 691 1821 692 694 2088 983 988 695
+ 696 1825 2085 1826 2086 698 697 699 989 1822 2090 2091 700 981 990 1827 701 1860 1831 991
+ 2089 2087 1828 992 702 1002 757 1832 703 997 993 1829 704 994 705 1833 1835 995 2094 998
+ 1837 996 707 2092 709 708 706 1838 1836 710 999 1581 2093 1000 716 1842 1854 2095 714 711
+ 712 1001 2096 1577 715 302 1007 1003 2133 1843 1567 1844 1004 1846 717 766 1005 301 718 1527
+ 1845 720 721 719 2098 2097 1008 1847 1522 1848 1006 2145 1519 2099 1857 1010 1009 722 2100 723
+ 1011 2142 724 1012 2130 725 2102 2138 726 727 1013 2126 728 729 1014 1015 737 1861 2103 739
+ 730 1016 1850 732 731 1017 1018 733 2139 1020 1849 1019 1022 1851 734 751 736 735 2105 1021
+ 1862 2106 1024 1023 1852 2107 2135 738 1859 1025 1853 1856 740 741 1026 1031 1858 1028 1027 422
+ 1029 746 2109 743 744 747 742 745 1036 1030 2110 1034 756 1869 749 1032 748 1033 1035 750
+ 752 1037 1868 1038 754 753 1040 755 2114 2150 2113 1041 1042 2111 2115 1039 2136 2116 1043 1044
+ 1871 1865 2129 1867 1046 1045 2117 2119 1877 774 759 1047 2118 1875 1048 761 438 1049 762 1873
+ 1052 1872 1050 2121 1874 1053 1058 763 1879 768 1878 764 1051 1863 2124 1054 1876 2123 1055 767
+ 1056 2125 1057 769 770 765 1059 1060 1061 441 1070 1063 771 1062 772 1064 2131 2127 1065 2128
+ 2132 776 773 775 1066 1067 777 2134 778 782 1068 779 1069 780 1071 2137 2140 1076 781 1072
+ 2141 1073 783 2143 1074 2144 784 1078 785 1075 2147 1880 786 787 1077 2146 1079 2149 2148 788
+ 1080 1081 2151 1083 789 1082 790 791 2152 792 1084 1085 1087 1086 793 o_data[9] 33 236 2584
+ ICV_11 $T=0 0 0 0 $X=139500 $Y=497460
X8 GND VCC 795 850 1883 798 1884 2511 1886 1955 1967 1885 1887 805 1888 2502 794 848 812 823
+ 1890 822 859 1919 799 1910 800 803 858 801 2494 816 1975 802 1882 1892 1900 796 1893 2498
+ 797 804 2497 851 2503 1929 1932 806 807 1896 846 818 1881 811 1921 840 1899 1898 832 2500
+ 2492 1897 808 2493 809 1901 2512 854 810 1905 1902 2495 1895 1904 1914 814 1907 1906 1903 1908
+ 2501 1894 815 2499 817 1120 1909 2507 2496 2515 2154 1970 819 2153 1912 1920 820 821 1913 1911
+ 2155 824 835 1965 830 1915 825 2157 857 826 1974 1917 1916 2505 1918 827 1946 1088 1889 828
+ 829 1089 1891 1090 1976 1095 1923 1093 1922 1969 831 1930 1926 1924 1928 1925 2506 834 833 1933
+ 1935 836 1931 1091 1934 1927 2508 841 1938 1972 2504 1936 1092 1944 1094 837 2509 1940 1941 2184
+ 1943 2514 839 1939 1937 838 1942 1945 842 1971 843 1096 1948 1961 1947 844 1950 1951 1953 1949
+ 1954 847 1098 1952 1099 849 1973 1980 813 845 1959 1957 852 1956 1960 1958 1962 1963 2510 853
+ 1100 1964 1968 855 1966 863 1977 856 861 1440 1101 2159 2162 2158 1984 1979 860 862 2513 870
+ 866 864 1983 2161 1981 1982 867 865 1978 1103 868 869 1104 1105 1985 1106 1995 960 2160 2006
+ 1986 1988 871 2001 1987 2017 872 1107 2023 874 873 1990 879 2003 914 876 913 877 875 1108
+ 2156 882 2164 886 883 1097 2163 880 1109 1110 878 1989 1102 1111 1112 1113 888 1992 881 1116
+ 1114 2516 2028 902 1115 2037 2005 2031 2025 1993 2178 2008 1118 1119 2165 2166 2167 2168 884 2169
+ 885 1121 1122 1141 1126 2172 1123 2170 2174 1117 1125 2015 1124 1127 2182 891 1137 1128 1991 889
+ 908 1999 2187 2176 890 2002 2014 893 1129 2175 2171 1131 2004 1130 1994 2173 892 2179 2183 894
+ 2181 1998 1132 2000 1134 895 1526 1136 1135 904 2180 905 1133 2039 2010 2007 896 887 899 2186
+ 2011 1138 2013 2177 900 2185 2188 1139 2029 903 2012 2033 1140 2030 906 2040 2191 2016 2190 1997
+ 2189 2026 897 901 2196 2019 1147 2022 2192 1142 910 2193 898 909 1150 1143 2018 2194 2020 2027
+ 912 2038 1144 1145 951 934 1146 915 2032 2052 2059 1218 2071 2044 936 1418 2197 918 1408 2048
+ 2069 1152 2198 939 1407 1154 1151 2046 2058 2051 916 1155 1153 2049 919 949 929 2205 944 2050
+ 2054 943 2055 927 987 2202 2200 920 1156 2199 921 1157 922 2203 1158 924 932 923 2201 2065
+ 1162 1159 950 1160 2204 2053 926 2083 925 930 1161 2063 2209 928 2207 2206 2208 931 1164 1177
+ 1167 1511 1165 2246 1166 1163 2210 1172 1168 1513 1169 1242 1170 1243 1656 1171 1238 2211 1173 935
+ 1520 2212 1515 1175 937 1204 1176 940 1518 2062 938 2213 1174 2057 1178 1179 1249 2218 2216 941
+ 1180 2060 2217 2214 1523 942 1181 1519 2219 2215 1522 1182 2222 2220 301 1183 1527 2061 945 2221
+ 1184 1415 1416 2223 946 1185 1186 1417 2066 1567 1187 947 2224 302 1188 1189 948 2225 1190 1577
+ 2227 2067 2226 1191 1581 953 952 1195 2068 954 1192 955 1194 956 1193 2228 957 958 2230 959
+ 2231 968 2073 2229 2233 1196 2232 1197 961 962 1198 1199 2070 1822 963 1200 1202 967 2235 2072
+ 2234 974 2236 2237 965 969 2074 1201 966 970 964 1203 2238 2075 973 2076 971 1205 2077 1206
+ 972 976 1207 2239 2240 2241 2242 2244 2078 1208 1210 1209 975 2243 977 978 1211 1212 2081 1214
+ 1213 2080 2245 1215 1219 553 2082 1220 980 1658 2087 1217 496 2085 2064 2084 1216 1437 981 1221
+ 1222 557 2089 984 1223 1646 1664 983 1666 2251 1224 985 2079 982 1668 986 2086 1662 1225 2088
+ 1226 1227 979 1260 2247 1230 1231 2248 989 1229 1228 2249 1234 990 2250 1233 1232 991 1235 2090
+ 2091 1236 992 1237 1239 993 1240 996 1241 994 1244 995 1246 1245 997 998 1247 1248 1003 2092
+ 2094 1864 2252 999 1250 2257 1251 1000 2093 1252 2254 2253 2256 2255 1253 2095 1255 1254 1001 2261
+ 2258 1002 2262 1256 1866 2260 1257 2259 1258 2096 2267 1004 1259 1005 2275 1262 2273 2281 2283 2270
+ 2097 1006 1590 1263 2279 1265 1266 1267 1007 1268 2269 1261 1264 2274 2285 2098 1269 2277 1271 1008
+ 2282 2307 2297 1302 1009 1315 1010 1274 1678 2264 2099 1273 2545 2278 1270 2284 2289 1011 1012 1272
+ 1281 1275 1277 2268 1292 2101 2526 1279 2287 2531 2100 2276 1278 2266 2290 1286 2345 2304 1013 2523
+ 2529 2347 1282 2288 2286 1308 2303 2272 2521 2296 1283 2528 2341 2311 1285 2518 1299 2292 2527 2295
+ 2519 2301 2294 2308 2293 2102 2349 1015 2271 2291 1287 1280 1290 1328 2522 2298 2263 2302 1288 2103
+ 2104 2533 1016 1291 1284 2520 1017 2305 2299 2300 2309 2265 2351 1018 1297 1048 2322 2327 2532 1029
+ 2530 2306 1019 1020 2524 1021 1293 1294 1318 2312 1022 1023 2314 2536 2280 2056 1024 2313 2319 2105
+ 1295 1296 2107 2316 1028 2106 2323 2310 2534 2318 988 1298 1038 2108 2535 1025 2326 2317 2537 2321
+ 1026 2335 1301 1276 1300 2324 2525 2315 1027 1303 1304 2320 1289 1305 2109 1306 1307 2546 2325 2338
+ 1309 2539 2540 2328 1030 2329 1031 1311 2330 1312 2353 1032 2111 2331 1035 1310 2541 1033 1034 2544
+ 1314 2333 2110 1036 1316 2334 2538 1037 2332 2115 2340 1317 1039 2337 2336 1046 1313 2114 1040 2542
+ 1319 1320 2543 2113 2339 1041 2343 1042 2112 1321 2358 2342 2117 1044 2348 2352 2344 1043 2346 1322
+ 2357 2123 1323 1330 2116 1045 1324 2350 2118 2547 2359 2122 2119 2356 1049 1338 2354 1325 1327 1347
+ 2355 1326 2365 2360 2362 1050 1335 1329 2120 2368 2361 1331 2363 1053 1051 2121 1333 1336 1332 2364
+ 1058 1056 1052 1346 1047 1334 1353 2550 2376 1341 2124 1061 2548 1054 1055 2367 1339 1057 2369 1348
+ 1340 2366 2563 2374 2125 1342 2410 2421 2373 2426 1343 1344 2381 2375 1059 2382 1345 2433 2372 2370
+ 1060 1402 2552 2549 2385 1856 2553 2377 1349 2126 2555 2379 1350 2391 1351 2383 2380 2127 2371 1062
+ 2445 2388 2386 2384 1355 1063 2389 1064 1354 1384 1385 1065 2393 1360 2392 2390 1337 1357 2387 1358
+ 2129 2128 2436 1352 1066 2414 2448 2397 2418 1067 1361 1356 2398 2150 1363 1390 2399 2551 2132 1364
+ 1362 2395 1389 2401 2400 2396 2404 2134 2558 1367 1074 1365 2402 2136 1396 2411 2405 2406 2409 2554
+ 1071 1068 2403 2408 1079 1070 2417 2561 2412 2137 2394 1368 2413 2556 1366 1369 2130 2451 1374 1371
+ 2140 1069 1377 2419 1370 2420 2141 2131 2415 1405 1372 2437 2557 1073 1373 2446 2133 2452 2142 1375
+ 2559 2138 2423 2422 2407 2564 1376 2143 2453 2439 2424 1378 1379 2416 2425 2447 2146 1380 2144 1381
+ 2432 2135 2560 2427 2430 1075 2145 2428 2429 2139 1382 1400 1383 2431 2567 1076 2147 1077 2434 1387
+ 1078 2438 2435 2444 2378 2148 2442 2443 2440 2566 2149 2562 1391 1072 1399 1392 1080 2459 1394 1081
+ 2441 2454 1395 1082 1388 2456 2449 1386 2450 2565 2458 1085 1397 1083 1084 2455 1359 2568 1398 2151
+ 1401 1406 2457 1087 2152 1086 1393 1403 1404 33 o_data[7] 236 2584
+ ICV_13 $T=0 0 0 0 $X=139500 $Y=326100
X9 GND VCC 21 26 2154 2153 1101 2155 2157 1089 1090 1088 1095 1093 1091 1092 1094 1140 1096 1097
+ 1099 1098 2156 1100 2159 2158 2162 2161 1102 1103 1104 1105 1106 2160 2164 2173 2175 2163 1107 1109
+ 1108 1111 1112 1113 1115 1114 1116 1117 2185 2184 2166 1120 1119 2167 2165 1122 1121 1141 1126 1124
+ 2170 1125 2172 2177 2174 2171 1123 1128 1996 2034 2182 1129 2179 2043 1127 1130 2009 2168 917 2183
+ 1134 2169 1132 2176 2178 1131 2181 1133 1147 1135 2187 2180 1136 1137 1138 2186 2188 2189 2190 1143
+ 2021 2191 2024 1142 2192 2194 2193 2045 1144 2035 1145 1146 2036 2195 1148 1149 2196 2042 1150 1151
+ 2041 1152 2197 1153 2047 2200 2199 1155 2201 1154 1156 1157 1158 1159 2204 2202 1161 1160 2205 1162
+ 2206 1163 2203 1166 2210 2212 1164 2207 1165 2208 1167 2209 1168 1172 1171 1169 2211 1170 1173 1180
+ 1174 1244 1175 2256 1177 1176 2214 2213 1178 1179 2258 2216 2215 1181 2218 2217 2219 1182 1183 2220
+ 2221 2224 1184 2222 2223 1185 1186 1187 1250 2225 1189 1190 2226 2227 1249 2067 2068 1191 2228 1192
+ 1188 1193 1194 2229 2230 1195 1196 1197 2232 2233 1198 2231 1199 1200 2238 2236 2235 2237 2234 1201
+ 1202 1203 1204 2239 1210 1207 2240 2242 1205 2244 1208 1206 1209 2241 1211 2243 1212 1214 1219 1213
+ 1218 1215 1216 2245 1217 2246 1223 1220 1221 1222 1260 1224 1225 1227 1226 2247 2248 1228 1229 1230
+ 2249 2250 1231 1235 1234 1232 1233 1236 1237 1239 1238 1242 1240 1243 2251 1241 2084 33 1246 1247
+ 1248 2252 2259 2253 1245 2254 2261 2257 1251 2255 1252 1254 1255 2260 2262 1256 1257 2270 2267 1258
+ 1253 1265 1259 1261 2273 1262 1266 1282 2278 1264 1263 2524 1328 2538 2536 2288 1268 2279 2282 2298
+ 2277 2283 1269 2280 1275 2523 2342 2265 1270 2296 2284 1271 2357 2264 2297 2285 2528 1272 2545 1276
+ 1281 1274 2276 2527 2540 1273 2546 2290 1302 2529 1296 1267 2519 2309 2522 2287 2269 2266 1278 2263
+ 1315 2268 1277 2520 2289 1318 1279 2341 1280 2544 2328 2521 2271 2308 2303 2532 2286 2304 2530 2340
+ 2533 2311 2291 2272 2518 2295 2526 2531 1283 2292 1289 2299 1284 2525 1288 2301 1285 1299 2293 1286
+ 2302 2542 1287 2305 2343 2348 2335 1291 1292 2310 2347 2294 1290 2300 2322 2319 2332 2306 2313 1294
+ 1293 2307 2317 1309 2535 2281 2315 2334 1295 2312 2318 1297 1301 2314 2537 2541 1300 2543 2534 1298
+ 2316 2320 1303 2330 2324 1304 2325 2321 2539 1305 2274 1307 2326 1308 1317 2329 2327 1310 1311 1312
+ 1313 2331 1314 2323 1316 1320 2333 1306 2346 2275 2336 1319 2338 2339 2344 1321 2337 2352 1323 1322
+ 2351 2349 1324 2350 2355 2354 2359 1325 2345 2353 1327 1330 2358 2547 1326 2363 2360 2362 1334 1331
+ 2388 1338 1332 2365 2439 1337 2371 2407 2356 2403 1333 2367 1401 1335 1348 2361 1336 2550 1339 1329
+ 2368 1344 2364 2370 1341 2548 2366 2369 2551 2387 1340 1345 2394 2374 1343 2375 2379 2373 2410 1364
+ 2376 2382 2372 2381 2377 1346 1386 2378 1347 2554 1353 1350 2553 2385 2443 2384 2380 2383 1352 1351
+ 2389 2390 2391 1365 1354 2568 1358 2549 1355 2392 1389 1349 2395 1356 2552 2386 1357 1368 1379 2393
+ 1359 2555 1361 2397 1360 1372 1362 2434 1363 2406 2398 2399 2452 1342 2418 2404 2400 2435 1400 2396
+ 2402 2556 1366 2401 2558 2405 1367 2432 2408 2411 2559 2409 2561 2416 2414 2412 2419 1378 1369 2415
+ 1377 2428 1370 1371 2417 1374 2437 2421 2557 1373 2564 2422 1375 2420 1376 2424 2423 1381 2413 2425
+ 1380 2560 2427 2429 1382 2567 2431 1383 2442 1384 2430 1385 2454 1387 1404 2438 1388 2444 2453 2566
+ 2426 2440 2441 1390 1391 2436 1392 2562 1393 2450 2459 2563 2565 2446 2448 1394 1395 2447 2445 2449
+ 2455 1396 2458 2451 1397 1398 1399 1405 2456 2433 2457 1403 1402 1406 236 o_data[6] 2198 2584
+ ICV_14 $T=0 0 0 0 $X=139500 $Y=139500
X10 26 33 i_ready o_valid o_data[0] o_data[1] o_data[2] o_data[3] o_data[4] o_data[5] 933 926 236 1407 1408 1415 1416 1417 1418 2584 ICV_15 $T=0 0 0 0 $X=139500 $Y=-56920
X12 21 4 i_data[15] 1429 2584 ICV_17 $T=0 0 0 0 $X=-56920 $Y=1067800
X13 i_data[13] 21 i_data[14] 1431 1432 2584 ICV_18 $T=0 0 0 0 $X=-56920 $Y=881300
X14 i_data[11] 21 1434 2584 ICV_19 $T=0 0 0 0 $X=-56920 $Y=699100
X15 i_data[10] 21 1439 2584 ICV_20 $T=0 0 0 0 $X=-56920 $Y=497500
X16 i_data[8] 21 i_data[9] 1441 1442 2584 ICV_21 $T=0 0 0 0 $X=-56920 $Y=326900
X17 21 i_data[6] i_data[7] 1443 1444 2584 ICV_22 $T=0 0 0 0 $X=-56920 $Y=139500
.ENDS
***************************************
